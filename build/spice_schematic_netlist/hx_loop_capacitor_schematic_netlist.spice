** sch_path: /home/hx2003/Desktop/ttihp-delay/schematics/hx_loop_capacitor.sch
.subckt hx_loop_capacitor SIGP VSS
*.PININFO VSS:I SIGP:B
MM1 VSS SIGP VSS VSS sg13_lv_nmos w=56u l=7u ng=8 m=2
.ends
