** sch_path: /home/hx2003/Desktop/ttihp-delay/schematics/hx_delay_line_with_mux.sch
.subckt hx_delay_line_with_mux VSS VDD DELAY_OUT_LAST DELAY_IN MUX_SEL0 MUX_SEL1 MUX_OUT MUX_SEL4 MUX_SEL2 MUX_SEL3 DELAY_VBIASN
+ DELAY_VBIASP
*.PININFO VDD:I VSS:I MUX_OUT:O DELAY_IN:I DELAY_VBIASP:I DELAY_VBIASN:I DELAY_OUT_LAST:O MUX_SEL0:I MUX_SEL1:I MUX_SEL2:I
*+ MUX_SEL3:I MUX_SEL4:I
x1 VSS VDD DELAY_OUT_LAST net1 net2 net3 net4 net5 net6 net7 net8 net9 net10 net11 net12 net13 net14 net15 net16 net17 net18 net19
+ net20 net21 net22 net23 net24 net25 net26 net27 net28 net29 net30 net31 DELAY_IN DELAY_VBIASN DELAY_VBIASP hx_delay_line
x2 VSS VDD DELAY_IN net1 net2 net3 net4 net5 net6 net7 net8 net9 net10 net11 net12 net13 net14 net15 net16 net17 net18 net19 net20
+ net21 net22 net23 net24 net25 net26 net27 net28 net29 net30 net31 MUX_SEL0 MUX_SEL1 MUX_OUT MUX_SEL4 MUX_SEL2 MUX_SEL3 hx_mux
.ends

* expanding   symbol:  hx_delay_line.sym # of pins=37
** sym_path: /home/hx2003/Desktop/ttihp-delay/schematics/hx_delay_line.sym
** sch_path: /home/hx2003/Desktop/ttihp-delay/schematics/hx_delay_line.sch
.subckt hx_delay_line VSS VDD DELAY_OUT_LAST DELAY_OUT_TAP1 DELAY_OUT_TAP2 DELAY_OUT_TAP3 DELAY_OUT_TAP4 DELAY_OUT_TAP5
+ DELAY_OUT_TAP6 DELAY_OUT_TAP7 DELAY_OUT_TAP8 DELAY_OUT_TAP9 DELAY_OUT_TAP10 DELAY_OUT_TAP11 DELAY_OUT_TAP12 DELAY_OUT_TAP13 DELAY_OUT_TAP14
+ DELAY_OUT_TAP15 DELAY_OUT_TAP16 DELAY_OUT_TAP17 DELAY_OUT_TAP18 DELAY_OUT_TAP19 DELAY_OUT_TAP20 DELAY_OUT_TAP21 DELAY_OUT_TAP22 DELAY_OUT_TAP23
+ DELAY_OUT_TAP24 DELAY_OUT_TAP25 DELAY_OUT_TAP26 DELAY_OUT_TAP27 DELAY_OUT_TAP28 DELAY_OUT_TAP29 DELAY_OUT_TAP30 DELAY_OUT_TAP31 DELAY_IN
+ DELAY_VBIASN DELAY_VBIASP
*.PININFO VDD:I VSS:I DELAY_VBIASN:I DELAY_VBIASP:I DELAY_IN:I DELAY_OUT_TAP1:O DELAY_OUT_TAP2:O DELAY_OUT_TAP3:O DELAY_OUT_TAP4:O
*+ DELAY_OUT_TAP5:O DELAY_OUT_TAP6:O DELAY_OUT_TAP7:O DELAY_OUT_TAP8:O DELAY_OUT_TAP9:O DELAY_OUT_TAP10:O DELAY_OUT_TAP11:O DELAY_OUT_TAP12:O
*+ DELAY_OUT_TAP13:O DELAY_OUT_TAP14:O DELAY_OUT_TAP15:O DELAY_OUT_TAP16:O DELAY_OUT_TAP17:O DELAY_OUT_TAP18:O DELAY_OUT_TAP19:O DELAY_OUT_TAP20:O
*+ DELAY_OUT_TAP21:O DELAY_OUT_TAP22:O DELAY_OUT_TAP23:O DELAY_OUT_TAP24:O DELAY_OUT_TAP25:O DELAY_OUT_TAP26:O DELAY_OUT_TAP27:O DELAY_OUT_TAP28:O
*+ DELAY_OUT_TAP29:O DELAY_OUT_TAP30:O DELAY_OUT_TAP31:O DELAY_OUT_LAST:O
x0 VDD VSS net1 DELAY_OUT_TAP1 DELAY_IN DELAY_VBIASP DELAY_VBIASN hx_delay_cell
x1 VDD VSS net3 DELAY_OUT_TAP2 net1 DELAY_VBIASP DELAY_VBIASN hx_delay_cell
x2 VDD VSS net2 DELAY_OUT_TAP3 net3 DELAY_VBIASP DELAY_VBIASN hx_delay_cell
x3 VDD VSS net25 DELAY_OUT_TAP4 net2 DELAY_VBIASP DELAY_VBIASN hx_delay_cell
x4 VDD VSS net4 DELAY_OUT_TAP5 net25 DELAY_VBIASP DELAY_VBIASN hx_delay_cell
x5 VDD VSS net26 DELAY_OUT_TAP6 net4 DELAY_VBIASP DELAY_VBIASN hx_delay_cell
x6 VDD VSS net5 DELAY_OUT_TAP7 net26 DELAY_VBIASP DELAY_VBIASN hx_delay_cell
x7 VDD VSS net27 DELAY_OUT_TAP8 net5 DELAY_VBIASP DELAY_VBIASN hx_delay_cell
x8 VDD VSS net6 DELAY_OUT_TAP9 net27 DELAY_VBIASP DELAY_VBIASN hx_delay_cell
x9 VDD VSS net28 DELAY_OUT_TAP10 net6 DELAY_VBIASP DELAY_VBIASN hx_delay_cell
x10 VDD VSS net7 DELAY_OUT_TAP11 net28 DELAY_VBIASP DELAY_VBIASN hx_delay_cell
x11 VDD VSS net31 DELAY_OUT_TAP12 net7 DELAY_VBIASP DELAY_VBIASN hx_delay_cell
x12 VDD VSS net8 DELAY_OUT_TAP13 net31 DELAY_VBIASP DELAY_VBIASN hx_delay_cell
x13 VDD VSS net29 DELAY_OUT_TAP14 net8 DELAY_VBIASP DELAY_VBIASN hx_delay_cell
x14 VDD VSS net9 DELAY_OUT_TAP15 net29 DELAY_VBIASP DELAY_VBIASN hx_delay_cell
x15 VDD VSS net30 DELAY_OUT_TAP16 net9 DELAY_VBIASP DELAY_VBIASN hx_delay_cell
x16 VDD VSS net10 DELAY_OUT_TAP17 net30 DELAY_VBIASP DELAY_VBIASN hx_delay_cell
x17 VDD VSS net12 DELAY_OUT_TAP18 net10 DELAY_VBIASP DELAY_VBIASN hx_delay_cell
x18 VDD VSS net11 DELAY_OUT_TAP19 net12 DELAY_VBIASP DELAY_VBIASN hx_delay_cell
x19 VDD VSS net16 DELAY_OUT_TAP20 net11 DELAY_VBIASP DELAY_VBIASN hx_delay_cell
x20 VDD VSS net13 DELAY_OUT_TAP21 net16 DELAY_VBIASP DELAY_VBIASN hx_delay_cell
x21 VDD VSS net15 DELAY_OUT_TAP22 net13 DELAY_VBIASP DELAY_VBIASN hx_delay_cell
x22 VDD VSS net14 DELAY_OUT_TAP23 net15 DELAY_VBIASP DELAY_VBIASN hx_delay_cell
x23 VDD VSS net24 DELAY_OUT_TAP24 net14 DELAY_VBIASP DELAY_VBIASN hx_delay_cell
x24 VDD VSS net17 DELAY_OUT_TAP25 net24 DELAY_VBIASP DELAY_VBIASN hx_delay_cell
x25 VDD VSS net19 DELAY_OUT_TAP26 net17 DELAY_VBIASP DELAY_VBIASN hx_delay_cell
x26 VDD VSS net18 DELAY_OUT_TAP27 net19 DELAY_VBIASP DELAY_VBIASN hx_delay_cell
x27 VDD VSS net23 DELAY_OUT_TAP28 net18 DELAY_VBIASP DELAY_VBIASN hx_delay_cell
x28 VDD VSS net20 DELAY_OUT_TAP29 net23 DELAY_VBIASP DELAY_VBIASN hx_delay_cell
x29 VDD VSS net22 DELAY_OUT_TAP30 net20 DELAY_VBIASP DELAY_VBIASN hx_delay_cell
x30 VDD VSS net21 DELAY_OUT_TAP31 net22 DELAY_VBIASP DELAY_VBIASN hx_delay_cell
x31 VDD VSS DELAY_OUT_LAST net32 net21 DELAY_VBIASP DELAY_VBIASN hx_delay_cell
.ends

* expanding   symbol:  hx_mux.sym # of pins=40
** sym_path: /home/hx2003/Desktop/ttihp-delay/schematics/hx_mux.sym
** sch_path: /home/hx2003/Desktop/ttihp-delay/schematics/hx_mux.sch
.subckt hx_mux VSS VDD DELAY_OUT_TAP0 DELAY_OUT_TAP1 DELAY_OUT_TAP2 DELAY_OUT_TAP3 DELAY_OUT_TAP4 DELAY_OUT_TAP5 DELAY_OUT_TAP6
+ DELAY_OUT_TAP7 DELAY_OUT_TAP8 DELAY_OUT_TAP9 DELAY_OUT_TAP10 DELAY_OUT_TAP11 DELAY_OUT_TAP12 DELAY_OUT_TAP13 DELAY_OUT_TAP14 DELAY_OUT_TAP15
+ DELAY_OUT_TAP16 DELAY_OUT_TAP17 DELAY_OUT_TAP18 DELAY_OUT_TAP19 DELAY_OUT_TAP20 DELAY_OUT_TAP21 DELAY_OUT_TAP22 DELAY_OUT_TAP23 DELAY_OUT_TAP24
+ DELAY_OUT_TAP25 DELAY_OUT_TAP26 DELAY_OUT_TAP27 DELAY_OUT_TAP28 DELAY_OUT_TAP29 DELAY_OUT_TAP30 DELAY_OUT_TAP31 MUX_SEL0 MUX_SEL1 MUX_OUT
+ MUX_SEL4 MUX_SEL2 MUX_SEL3
*.PININFO VDD:I VSS:I DELAY_OUT_TAP0:I MUX_OUT:O DELAY_OUT_TAP1:I DELAY_OUT_TAP2:I DELAY_OUT_TAP3:I MUX_SEL0:I MUX_SEL1:I
*+ MUX_SEL4:I DELAY_OUT_TAP4:I DELAY_OUT_TAP5:I DELAY_OUT_TAP6:I DELAY_OUT_TAP7:I DELAY_OUT_TAP8:I DELAY_OUT_TAP9:I DELAY_OUT_TAP11:I
*+ DELAY_OUT_TAP10:I DELAY_OUT_TAP12:I DELAY_OUT_TAP13:I DELAY_OUT_TAP15:I DELAY_OUT_TAP14:I DELAY_OUT_TAP16:I DELAY_OUT_TAP17:I DELAY_OUT_TAP19:I
*+ DELAY_OUT_TAP18:I DELAY_OUT_TAP20:I DELAY_OUT_TAP21:I DELAY_OUT_TAP23:I DELAY_OUT_TAP22:I DELAY_OUT_TAP24:I DELAY_OUT_TAP25:I DELAY_OUT_TAP27:I
*+ DELAY_OUT_TAP26:I DELAY_OUT_TAP28:I DELAY_OUT_TAP29:I DELAY_OUT_TAP31:I DELAY_OUT_TAP30:I MUX_SEL2:I MUX_SEL3:I
x1 VSS net3 net4 net1 net2 DELAY_OUT_TAP1 DELAY_OUT_TAP2 DELAY_OUT_TAP3 net23 VDD net5 hx_mux_4to1_leaf
x2 VSS net3 net4 net1 net2 DELAY_OUT_TAP5 DELAY_OUT_TAP6 DELAY_OUT_TAP7 DELAY_OUT_TAP4 VDD net6 hx_mux_4to1_leaf
x3 VSS net3 net4 net1 net2 DELAY_OUT_TAP9 DELAY_OUT_TAP10 DELAY_OUT_TAP11 DELAY_OUT_TAP8 VDD net7 hx_mux_4to1_leaf
x4 VSS net3 net4 net1 net2 DELAY_OUT_TAP13 DELAY_OUT_TAP14 DELAY_OUT_TAP15 DELAY_OUT_TAP12 VDD net8 hx_mux_4to1_leaf
x5 VSS net3 net4 net1 net2 DELAY_OUT_TAP17 DELAY_OUT_TAP18 DELAY_OUT_TAP19 DELAY_OUT_TAP16 VDD net15 hx_mux_4to1_leaf
x6 VSS net3 net4 net1 net2 DELAY_OUT_TAP21 DELAY_OUT_TAP22 DELAY_OUT_TAP23 DELAY_OUT_TAP20 VDD net16 hx_mux_4to1_leaf
x7 VSS net3 net4 net1 net2 DELAY_OUT_TAP25 DELAY_OUT_TAP26 DELAY_OUT_TAP27 DELAY_OUT_TAP24 VDD net17 hx_mux_4to1_leaf
x8 VSS net3 net4 net1 net2 DELAY_OUT_TAP29 DELAY_OUT_TAP30 DELAY_OUT_TAP31 DELAY_OUT_TAP28 VDD net18 hx_mux_4to1_leaf
x9 VSS VDD net11 net12 net13 net14 net5 net6 net7 net8 net21 hx_mux_4to1_intermediate
x10 net1 net10 net9 VDD VSS sg13g2_and2_2
x42 net10 MUX_SEL0 VDD VSS sg13g2_inv_1
x11 net2 MUX_SEL0 net9 VDD VSS sg13g2_and2_2
x12 net3 MUX_SEL1 net10 VDD VSS sg13g2_and2_2
x13 net4 MUX_SEL0 MUX_SEL1 VDD VSS sg13g2_and2_2
x14 net9 MUX_SEL1 VDD VSS sg13g2_inv_1
x15 VSS VDD net11 net12 net13 net14 net15 net16 net17 net18 net22 hx_mux_4to1_intermediate
x16 net11 net20 net19 VDD VSS sg13g2_and2_2
x17 net20 MUX_SEL2 VDD VSS sg13g2_inv_1
x18 net12 MUX_SEL2 net19 VDD VSS sg13g2_and2_2
x19 net13 MUX_SEL3 net20 VDD VSS sg13g2_and2_2
x20 net14 MUX_SEL2 MUX_SEL3 VDD VSS sg13g2_and2_2
x21 net19 MUX_SEL3 VDD VSS sg13g2_inv_1
x22 VSS VDD MUX_OUT MUX_SEL4 net22 net21 hx_mux_2to1_root
MM7 net23 DELAY_OUT_TAP0 VSS VSS sg13_lv_nmos w=0.74u l=0.13u ng=1
MM8 net23 DELAY_OUT_TAP0 VDD VDD sg13_lv_pmos w=1.12u l=0.13u ng=1
.ends

* expanding   symbol:  hx_delay_cell.sym # of pins=7
** sym_path: /home/hx2003/Desktop/ttihp-delay/schematics/hx_delay_cell.sym
** sch_path: /home/hx2003/Desktop/ttihp-delay/schematics/hx_delay_cell.sch
.subckt hx_delay_cell VDD VSS DELAY_CELL_OUT_INV DELAY_CELL_OUT DELAY_CELL_IN DELAY_VBIASP DELAY_VBIASN
*.PININFO VDD:I VSS:I DELAY_CELL_OUT_INV:O DELAY_VBIASN:I DELAY_VBIASP:I DELAY_CELL_IN:I DELAY_CELL_OUT:O
MM1 net1 DELAY_CELL_IN net3 VSS sg13_lv_nmos w=0.74u l=0.2u ng=1
MM2 net3 DELAY_VBIASN VSS VSS sg13_lv_nmos w=0.74u l=0.6u ng=1
MM3 net2 DELAY_VBIASP VDD VDD sg13_lv_pmos w=1.12u l=0.6u ng=1
MM4 DELAY_CELL_OUT net1 VSS VSS sg13_lv_nmos w=0.74u l=0.13u ng=1
MM5 net1 DELAY_CELL_IN net2 VDD sg13_lv_pmos w=1.12u l=0.2u ng=1
MM6 DELAY_CELL_OUT net1 VDD VDD sg13_lv_pmos w=1.12u l=0.13u ng=1
MM7 DELAY_CELL_OUT_INV DELAY_CELL_OUT VSS VSS sg13_lv_nmos w=0.74u l=0.13u ng=1
MM8 DELAY_CELL_OUT_INV DELAY_CELL_OUT VDD VDD sg13_lv_pmos w=1.12u l=0.13u ng=1
.ends

* expanding   symbol:  hx_mux_4to1_leaf.sym # of pins=11
** sym_path: /home/hx2003/Desktop/ttihp-delay/schematics/hx_mux_4to1_leaf.sym
** sch_path: /home/hx2003/Desktop/ttihp-delay/schematics/hx_mux_4to1_leaf.sch
.subckt hx_mux_4to1_leaf VSS MUX_ONEHOT_SEL2 MUX_ONEHOT_SEL3 MUX_ONEHOT_SEL0 MUX_ONEHOT_SEL1 MUX_IN1 MUX_IN2 MUX_IN3 MUX_IN0 VDD
+ MUX_OUT
*.PININFO VDD:I VSS:I MUX_IN0:I MUX_OUT:O MUX_ONEHOT_SEL0:I MUX_IN1:I MUX_IN2:I MUX_IN3:I MUX_ONEHOT_SEL1:I MUX_ONEHOT_SEL2:I
*+ MUX_ONEHOT_SEL3:I
MM2 net1 MUX_IN0 VSS VSS sg13_lv_nmos w=0.74u l=0.13u ng=1
MM1 net1 MUX_IN0 VDD VDD sg13_lv_pmos w=1.12u l=0.13u ng=1
MM3 net7 net2 VSS VSS sg13_lv_nmos w=0.74u l=0.13u ng=1
MM4 net7 net2 VDD VDD sg13_lv_pmos w=1.12u l=0.13u ng=1
MM5 net2 MUX_IN1 VSS VSS sg13_lv_nmos w=0.74u l=0.13u ng=1
MM6 net2 MUX_IN1 VDD VDD sg13_lv_pmos w=1.12u l=0.13u ng=1
MM7 net3 MUX_IN2 VSS VSS sg13_lv_nmos w=0.74u l=0.13u ng=1
MM8 net3 MUX_IN2 VDD VDD sg13_lv_pmos w=1.12u l=0.13u ng=1
MM9 net5 net4 VSS VSS sg13_lv_nmos w=0.74u l=0.13u ng=1
MM10 net5 net4 VDD VDD sg13_lv_pmos w=1.12u l=0.13u ng=1
MM11 net4 MUX_IN3 VSS VSS sg13_lv_nmos w=0.74u l=0.13u ng=1
MM12 net4 MUX_IN3 VDD VDD sg13_lv_pmos w=1.12u l=0.13u ng=1
MM13 net6 MUX_ONEHOT_SEL0 VSS VSS sg13_lv_nmos w=0.74u l=0.13u ng=1
MM14 net6 MUX_ONEHOT_SEL0 VDD VDD sg13_lv_pmos w=1.12u l=0.13u ng=1
MM15 net1 MUX_ONEHOT_SEL0 MUX_OUT VSS sg13_lv_nmos w=0.74u l=0.13u ng=1
MM16 net1 net6 MUX_OUT VDD sg13_lv_pmos w=1.12u l=0.13u ng=1
MM17 net8 MUX_ONEHOT_SEL1 VSS VSS sg13_lv_nmos w=0.74u l=0.13u ng=1
MM18 net8 MUX_ONEHOT_SEL1 VDD VDD sg13_lv_pmos w=1.12u l=0.13u ng=1
MM19 net7 MUX_ONEHOT_SEL1 MUX_OUT VSS sg13_lv_nmos w=0.74u l=0.13u ng=1
MM20 net7 net8 MUX_OUT VDD sg13_lv_pmos w=1.12u l=0.13u ng=1
MM21 net9 MUX_ONEHOT_SEL2 VSS VSS sg13_lv_nmos w=0.74u l=0.13u ng=1
MM22 net9 MUX_ONEHOT_SEL2 VDD VDD sg13_lv_pmos w=1.12u l=0.13u ng=1
MM23 net3 MUX_ONEHOT_SEL2 MUX_OUT VSS sg13_lv_nmos w=0.74u l=0.13u ng=1
MM24 net3 net9 MUX_OUT VDD sg13_lv_pmos w=1.12u l=0.13u ng=1
MM25 net10 MUX_ONEHOT_SEL3 VSS VSS sg13_lv_nmos w=0.74u l=0.13u ng=1
MM26 net10 MUX_ONEHOT_SEL3 VDD VDD sg13_lv_pmos w=1.12u l=0.13u ng=1
MM27 net5 MUX_ONEHOT_SEL3 MUX_OUT VSS sg13_lv_nmos w=0.74u l=0.13u ng=1
MM28 net5 net10 MUX_OUT VDD sg13_lv_pmos w=1.12u l=0.13u ng=1
.ends

* expanding   symbol:  hx_mux_4to1_intermediate.sym # of pins=11
** sym_path: /home/hx2003/Desktop/ttihp-delay/schematics/hx_mux_4to1_intermediate.sym
** sch_path: /home/hx2003/Desktop/ttihp-delay/schematics/hx_mux_4to1_intermediate.sch
.subckt hx_mux_4to1_intermediate VSS VDD MUX_ONEHOT_SEL0 MUX_ONEHOT_SEL1 MUX_ONEHOT_SEL2 MUX_ONEHOT_SEL3 MUX_IN0 MUX_IN1 MUX_IN2
+ MUX_IN3 MUX_OUT
*.PININFO VDD:I VSS:I MUX_IN0:I MUX_OUT:O MUX_ONEHOT_SEL0:I MUX_IN1:I MUX_IN2:I MUX_IN3:I MUX_ONEHOT_SEL1:I MUX_ONEHOT_SEL2:I
*+ MUX_ONEHOT_SEL3:I
MM17 net1 MUX_ONEHOT_SEL0 VSS VSS sg13_lv_nmos w=0.74u l=0.13u ng=1
MM18 net1 MUX_ONEHOT_SEL0 VDD VDD sg13_lv_pmos w=1.12u l=0.13u ng=1
MM19 MUX_IN0 MUX_ONEHOT_SEL0 MUX_OUT VSS sg13_lv_nmos w=0.74u l=0.13u ng=1
MM20 MUX_IN0 net1 MUX_OUT VDD sg13_lv_pmos w=1.12u l=0.13u ng=1
MM21 net2 MUX_ONEHOT_SEL1 VSS VSS sg13_lv_nmos w=0.74u l=0.13u ng=1
MM22 net2 MUX_ONEHOT_SEL1 VDD VDD sg13_lv_pmos w=1.12u l=0.13u ng=1
MM23 MUX_IN1 MUX_ONEHOT_SEL1 MUX_OUT VSS sg13_lv_nmos w=0.74u l=0.13u ng=1
MM24 MUX_IN1 net2 MUX_OUT VDD sg13_lv_pmos w=1.12u l=0.13u ng=1
MM25 net3 MUX_ONEHOT_SEL2 VSS VSS sg13_lv_nmos w=0.74u l=0.13u ng=1
MM26 net3 MUX_ONEHOT_SEL2 VDD VDD sg13_lv_pmos w=1.12u l=0.13u ng=1
MM27 MUX_IN2 MUX_ONEHOT_SEL2 MUX_OUT VSS sg13_lv_nmos w=0.74u l=0.13u ng=1
MM28 MUX_IN2 net3 MUX_OUT VDD sg13_lv_pmos w=1.12u l=0.13u ng=1
MM29 net4 MUX_ONEHOT_SEL3 VSS VSS sg13_lv_nmos w=0.74u l=0.13u ng=1
MM30 net4 MUX_ONEHOT_SEL3 VDD VDD sg13_lv_pmos w=1.12u l=0.13u ng=1
MM31 MUX_IN3 MUX_ONEHOT_SEL3 MUX_OUT VSS sg13_lv_nmos w=0.74u l=0.13u ng=1
MM32 MUX_IN3 net4 MUX_OUT VDD sg13_lv_pmos w=1.12u l=0.13u ng=1
x1 VDD VSS sg13g2_decap_8
x2 VDD VSS sg13g2_decap_8
x3 VDD VSS sg13g2_decap_8
x4 VDD VSS sg13g2_decap_8
x5 VDD VSS sg13g2_decap_8
x6 VDD VSS sg13g2_decap_8
x7 VDD VSS sg13g2_decap_8
x8 VDD VSS sg13g2_decap_8
x9 VDD VSS sg13g2_decap_8
.ends

* expanding   symbol:  sg13g2_and2_2.sym # of pins=3
** sym_path: /home/hx2003/Desktop/IHP-Open-PDK/ihp-sg13g2/libs.tech/xschem/sg13g2_stdcells/sg13g2_and2_2.sym
** sch_path: /home/hx2003/Desktop/IHP-Open-PDK/ihp-sg13g2/libs.tech/xschem/sg13g2_stdcells/sg13g2_and2_2.sch
.subckt sg13g2_and2_2 X A B VDD VSS

*.PININFO A:I B:I X:O
MM1 net1 A net2 VSS sg13_lv_nmos w=640.00n l=130.00n ng=1
MM2 net2 B VSS VSS sg13_lv_nmos w=640.00n l=130.00n ng=1
MM3 X net1 VSS VSS sg13_lv_nmos w=1.48u l=130.00n ng=2
MM4 net1 B VDD VDD sg13_lv_pmos w=840.00n l=130.00n ng=1
MM5 net1 A VDD VDD sg13_lv_pmos w=840.00n l=130.00n ng=1
MM6 X net1 VDD VDD sg13_lv_pmos w=2.24u l=130.00n ng=2
.ends

* expanding   symbol:  sg13g2_inv_1.sym # of pins=2
** sym_path: /home/hx2003/Desktop/IHP-Open-PDK/ihp-sg13g2/libs.tech/xschem/sg13g2_stdcells/sg13g2_inv_1.sym
** sch_path: /home/hx2003/Desktop/IHP-Open-PDK/ihp-sg13g2/libs.tech/xschem/sg13g2_stdcells/sg13g2_inv_1.sch
.subckt sg13g2_inv_1 Y A VDD VSS

*.PININFO Y:O A:I
MM1 Y A VSS VSS sg13_lv_nmos w=740.00n l=130.00n ng=1
MM2 Y A VDD VDD sg13_lv_pmos w=1.12u l=130.00n ng=1
.ends

* expanding   symbol:  hx_mux_2to1_root.sym # of pins=6
** sym_path: /home/hx2003/Desktop/ttihp-delay/schematics/hx_mux_2to1_root.sym
** sch_path: /home/hx2003/Desktop/ttihp-delay/schematics/hx_mux_2to1_root.sch
.subckt hx_mux_2to1_root VSS VDD MUX_OUT MUX_SEL MUX_IN1 MUX_IN0
*.PININFO VDD:I VSS:I MUX_IN0:I MUX_OUT:O MUX_IN1:I MUX_SEL:I
MM1 net1 MUX_SEL VSS VSS sg13_lv_nmos w=0.74u l=0.13u ng=1
MM2 net1 MUX_SEL VDD VDD sg13_lv_pmos w=1.12u l=0.13u ng=1
MM3 MUX_IN0 net1 net2 VSS sg13_lv_nmos w=0.74u l=0.13u ng=1
MM4 MUX_IN0 MUX_SEL net2 VDD sg13_lv_pmos w=1.12u l=0.13u ng=1
MM5 MUX_IN1 MUX_SEL net2 VSS sg13_lv_nmos w=0.74u l=0.13u ng=1
MM6 MUX_IN1 net1 net2 VDD sg13_lv_pmos w=1.12u l=0.13u ng=1
x14 MUX_OUT net2 VDD VSS sg13g2_buf_2
.ends

* expanding   symbol:  sg13g2_decap_8.sym # of pins=0
** sym_path: /home/hx2003/Desktop/IHP-Open-PDK/ihp-sg13g2/libs.tech/xschem/sg13g2_stdcells/sg13g2_decap_8.sym
** sch_path: /home/hx2003/Desktop/IHP-Open-PDK/ihp-sg13g2/libs.tech/xschem/sg13g2_stdcells/sg13g2_decap_8.sch
.subckt sg13g2_decap_8 VDD VSS

MM1 VSS VDD VSS VSS sg13_lv_nmos w=840.00n l=1.000u ng=2
MM2 VDD VSS VDD VDD sg13_lv_pmos w=2.000u l=1.000u ng=2
.ends

* expanding   symbol:  sg13g2_buf_2.sym # of pins=2
** sym_path: /home/hx2003/Desktop/IHP-Open-PDK/ihp-sg13g2/libs.tech/xschem/sg13g2_stdcells/sg13g2_buf_2.sym
** sch_path: /home/hx2003/Desktop/IHP-Open-PDK/ihp-sg13g2/libs.tech/xschem/sg13g2_stdcells/sg13g2_buf_2.sch
.subckt sg13g2_buf_2 X A VDD VSS

*.PININFO A:I X:O
MM1 net1 A VSS VSS sg13_lv_nmos w=640.00n l=130.00n ng=1
MM2 X net1 VSS VSS sg13_lv_nmos w=1.48u l=130.00n ng=2
MM3 net1 A VDD VDD sg13_lv_pmos w=1.000u l=130.00n ng=1
MM4 X net1 VDD VDD sg13_lv_pmos w=2.24u l=130.00n ng=2
.ends
