** sch_path: /home/hx2003/Desktop/ttihp-delay/schematics/hx_mux_2to1_root.sch
.subckt hx_mux_2to1_root VSS VDD MUX_OUT MUX_SEL MUX_IN1 MUX_IN0
*.PININFO VDD:I VSS:I MUX_IN0:I MUX_OUT:O MUX_IN1:I MUX_SEL:I
MM1 net1 MUX_SEL VSS VSS sg13_lv_nmos w=0.74u l=0.13u ng=1
MM2 net1 MUX_SEL VDD VDD sg13_lv_pmos w=1.12u l=0.13u ng=1
MM3 MUX_IN0 net1 net2 VSS sg13_lv_nmos w=0.74u l=0.13u ng=1
MM4 MUX_IN0 MUX_SEL net2 VDD sg13_lv_pmos w=1.12u l=0.13u ng=1
MM5 MUX_IN1 MUX_SEL net2 VSS sg13_lv_nmos w=0.74u l=0.13u ng=1
MM6 MUX_IN1 net1 net2 VDD sg13_lv_pmos w=1.12u l=0.13u ng=1
x14 MUX_OUT net2 VDD VSS sg13g2_buf_2
.ends

* expanding   symbol:  sg13g2_buf_2.sym # of pins=2
** sym_path: /home/hx2003/Desktop/IHP-Open-PDK/ihp-sg13g2/libs.tech/xschem/sg13g2_stdcells/sg13g2_buf_2.sym
** sch_path: /home/hx2003/Desktop/IHP-Open-PDK/ihp-sg13g2/libs.tech/xschem/sg13g2_stdcells/sg13g2_buf_2.sch
.subckt sg13g2_buf_2 X A VDD VSS

*.PININFO A:I X:O
MM1 net1 A VSS VSS sg13_lv_nmos w=640.00n l=130.00n ng=1
MM2 X net1 VSS VSS sg13_lv_nmos w=1.48u l=130.00n ng=2
MM3 net1 A VDD VDD sg13_lv_pmos w=1.000u l=130.00n ng=1
MM4 X net1 VDD VDD sg13_lv_pmos w=2.24u l=130.00n ng=2
.ends
