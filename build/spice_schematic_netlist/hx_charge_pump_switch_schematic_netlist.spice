** sch_path: /home/hx2003/Desktop/ttihp-delay/schematics/hx_charge_pump_switch.sch
.subckt hx_charge_pump_switch VSS VDD UP_INV DOWN DOWN_INV UP DELAY_VBIASP DELAY_VBIASN CURRENT_SOURCE CURRENT_SINK DLL_RESETN
*.PININFO CURRENT_SOURCE:I VSS:I DELAY_VBIASP:O DELAY_VBIASN:O UP_INV:I UP:I DOWN:I DOWN_INV:I DLL_RESETN:I VDD:I CURRENT_SINK:I
MM3004 DELAY_VBIASN DOWN CURRENT_SINK VSS sg13_lv_nmos w=0.4u l=0.2u ng=1
MM3003 DELAY_VBIASN UP_INV CURRENT_SOURCE VDD sg13_lv_pmos w=0.4u l=0.2u ng=1
MM3002 DELAY_VBIASN DLL_RESETN VDD VDD sg13_lv_pmos w=0.8u l=0.2u ng=1
MM3005 VSS UP CURRENT_SOURCE VDD sg13_lv_pmos w=0.4u l=0.2u ng=1
MM3006 VDD DOWN_INV CURRENT_SINK VSS sg13_lv_nmos w=0.4u l=0.2u ng=1
MM3000 DELAY_VBIASP DELAY_VBIASP VDD VDD sg13_lv_pmos w=1.12u l=0.6u ng=1
MM3001 DELAY_VBIASP DELAY_VBIASN VSS VSS sg13_lv_nmos w=0.74u l=0.6u ng=1
.ends
