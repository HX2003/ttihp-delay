** sch_path: /home/hx2003/Desktop/ttihp-delay/schematics/hx_delay_line.sch
.subckt hx_delay_line DELAY_IN DELAY_OUT_LAST DELAY_OUT_TAP1 DELAY_OUT_TAP2 DELAY_OUT_TAP3 DELAY_OUT_TAP4 DELAY_OUT_TAP5
+ DELAY_OUT_TAP6 DELAY_OUT_TAP7 DELAY_OUT_TAP8 DELAY_OUT_TAP9 DELAY_OUT_TAP10 DELAY_OUT_TAP11 DELAY_OUT_TAP12 DELAY_OUT_TAP13 DELAY_OUT_TAP14
+ DELAY_OUT_TAP15 DELAY_OUT_TAP16 DELAY_OUT_TAP17 DELAY_OUT_TAP18 DELAY_OUT_TAP19 DELAY_OUT_TAP20 DELAY_OUT_TAP21 DELAY_OUT_TAP22 DELAY_OUT_TAP23
+ DELAY_OUT_TAP24 DELAY_OUT_TAP25 DELAY_OUT_TAP26 DELAY_OUT_TAP27 DELAY_OUT_TAP28 DELAY_OUT_TAP29 DELAY_OUT_TAP30 DELAY_OUT_TAP31 VDD VSS
+ DELAY_VBIASN DELAY_VBIASP
*.PININFO VDD:I VSS:I DELAY_VBIASN:I DELAY_VBIASP:I DELAY_IN:I DELAY_OUT_TAP1:O DELAY_OUT_TAP2:O DELAY_OUT_TAP3:O DELAY_OUT_TAP4:O
*+ DELAY_OUT_TAP5:O DELAY_OUT_TAP6:O DELAY_OUT_TAP7:O DELAY_OUT_TAP8:O DELAY_OUT_TAP9:O DELAY_OUT_TAP10:O DELAY_OUT_TAP11:O DELAY_OUT_TAP12:O
*+ DELAY_OUT_TAP13:O DELAY_OUT_TAP14:O DELAY_OUT_TAP15:O DELAY_OUT_TAP16:O DELAY_OUT_TAP17:O DELAY_OUT_TAP18:O DELAY_OUT_TAP19:O DELAY_OUT_TAP20:O
*+ DELAY_OUT_TAP21:O DELAY_OUT_TAP22:O DELAY_OUT_TAP23:O DELAY_OUT_TAP24:O DELAY_OUT_TAP25:O DELAY_OUT_TAP26:O DELAY_OUT_TAP27:O DELAY_OUT_TAP28:O
*+ DELAY_OUT_TAP29:O DELAY_OUT_TAP30:O DELAY_OUT_TAP31:O DELAY_OUT_LAST:O
x0 DELAY_IN DELAY_OUT_TAP1 net1 DELAY_VBIASP DELAY_VBIASN VSS VDD hx_delay_cell
x1 net1 DELAY_OUT_TAP2 net3 DELAY_VBIASP DELAY_VBIASN VSS VDD hx_delay_cell
x2 net3 DELAY_OUT_TAP3 net2 DELAY_VBIASP DELAY_VBIASN VSS VDD hx_delay_cell
x3 net2 DELAY_OUT_TAP4 net25 DELAY_VBIASP DELAY_VBIASN VSS VDD hx_delay_cell
x4 net25 DELAY_OUT_TAP5 net4 DELAY_VBIASP DELAY_VBIASN VSS VDD hx_delay_cell
x5 net4 DELAY_OUT_TAP6 net26 DELAY_VBIASP DELAY_VBIASN VSS VDD hx_delay_cell
x6 net26 DELAY_OUT_TAP7 net5 DELAY_VBIASP DELAY_VBIASN VSS VDD hx_delay_cell
x7 net5 DELAY_OUT_TAP8 net27 DELAY_VBIASP DELAY_VBIASN VSS VDD hx_delay_cell
x8 net27 DELAY_OUT_TAP9 net6 DELAY_VBIASP DELAY_VBIASN VSS VDD hx_delay_cell
x9 net6 DELAY_OUT_TAP10 net28 DELAY_VBIASP DELAY_VBIASN VSS VDD hx_delay_cell
x10 net28 DELAY_OUT_TAP11 net7 DELAY_VBIASP DELAY_VBIASN VSS VDD hx_delay_cell
x11 net7 DELAY_OUT_TAP12 net31 DELAY_VBIASP DELAY_VBIASN VSS VDD hx_delay_cell
x12 net31 DELAY_OUT_TAP13 net8 DELAY_VBIASP DELAY_VBIASN VSS VDD hx_delay_cell
x13 net8 DELAY_OUT_TAP14 net29 DELAY_VBIASP DELAY_VBIASN VSS VDD hx_delay_cell
x14 net29 DELAY_OUT_TAP15 net9 DELAY_VBIASP DELAY_VBIASN VSS VDD hx_delay_cell
x15 net9 DELAY_OUT_TAP16 net30 DELAY_VBIASP DELAY_VBIASN VSS VDD hx_delay_cell
x16 net30 DELAY_OUT_TAP17 net10 DELAY_VBIASP DELAY_VBIASN VSS VDD hx_delay_cell
x17 net10 DELAY_OUT_TAP18 net12 DELAY_VBIASP DELAY_VBIASN VSS VDD hx_delay_cell
x18 net12 DELAY_OUT_TAP19 net11 DELAY_VBIASP DELAY_VBIASN VSS VDD hx_delay_cell
x19 net11 DELAY_OUT_TAP20 net16 DELAY_VBIASP DELAY_VBIASN VSS VDD hx_delay_cell
x20 net16 DELAY_OUT_TAP21 net13 DELAY_VBIASP DELAY_VBIASN VSS VDD hx_delay_cell
x21 net13 DELAY_OUT_TAP22 net15 DELAY_VBIASP DELAY_VBIASN VSS VDD hx_delay_cell
x22 net15 DELAY_OUT_TAP23 net14 DELAY_VBIASP DELAY_VBIASN VSS VDD hx_delay_cell
x23 net14 DELAY_OUT_TAP24 net24 DELAY_VBIASP DELAY_VBIASN VSS VDD hx_delay_cell
x24 net24 DELAY_OUT_TAP25 net17 DELAY_VBIASP DELAY_VBIASN VSS VDD hx_delay_cell
x25 net17 DELAY_OUT_TAP26 net19 DELAY_VBIASP DELAY_VBIASN VSS VDD hx_delay_cell
x26 net19 DELAY_OUT_TAP27 net18 DELAY_VBIASP DELAY_VBIASN VSS VDD hx_delay_cell
x27 net18 DELAY_OUT_TAP28 net23 DELAY_VBIASP DELAY_VBIASN VSS VDD hx_delay_cell
x28 net23 DELAY_OUT_TAP29 net20 DELAY_VBIASP DELAY_VBIASN VSS VDD hx_delay_cell
x29 net20 DELAY_OUT_TAP30 net22 DELAY_VBIASP DELAY_VBIASN VSS VDD hx_delay_cell
x30 net22 DELAY_OUT_TAP31 net21 DELAY_VBIASP DELAY_VBIASN VSS VDD hx_delay_cell
x31 net21 net32 DELAY_OUT_LAST DELAY_VBIASP DELAY_VBIASN VSS VDD hx_delay_cell
.ends

* expanding   symbol:  hx_delay_cell.sym # of pins=7
** sym_path: /home/hx2003/Desktop/ttihp-delay/schematics/hx_delay_cell.sym
** sch_path: /home/hx2003/Desktop/ttihp-delay/schematics/hx_delay_cell.sch
.subckt hx_delay_cell DELAY_CELL_IN DELAY_CELL_OUT DELAY_CELL_OUT_INV DELAY_VBIASP DELAY_VBIASN VSS VDD
*.PININFO VDD:I VSS:I DELAY_CELL_OUT_INV:O DELAY_VBIASN:I DELAY_VBIASP:I DELAY_CELL_IN:I DELAY_CELL_OUT:O
MM1 net1 DELAY_CELL_IN net3 VSS sg13_lv_nmos w=0.74u l=0.2u ng=1
MM2 net3 DELAY_VBIASN VSS VSS sg13_lv_nmos w=0.74u l=0.6u ng=1
MM3 net2 DELAY_VBIASP VDD VDD sg13_lv_pmos w=1.12u l=0.6u ng=1
MM4 DELAY_CELL_OUT net1 VSS VSS sg13_lv_nmos w=0.74u l=0.13u ng=1
MM5 net1 DELAY_CELL_IN net2 VDD sg13_lv_pmos w=1.12u l=0.2u ng=1
MM6 DELAY_CELL_OUT net1 VDD VDD sg13_lv_pmos w=1.12u l=0.13u ng=1
MM7 DELAY_CELL_OUT_INV DELAY_CELL_OUT VSS VSS sg13_lv_nmos w=0.74u l=0.13u ng=1
MM8 DELAY_CELL_OUT_INV DELAY_CELL_OUT VDD VDD sg13_lv_pmos w=1.12u l=0.13u ng=1
.ends
