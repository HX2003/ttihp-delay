** sch_path: /home/hx2003/Desktop/ttihp-delay/schematics/hx_delay_line.sch
.subckt hx_delay_line VSS VDD DELAY_OUT_LAST DELAY_OUT_TAP1 DELAY_OUT_TAP2 DELAY_OUT_TAP3 DELAY_OUT_TAP4 DELAY_OUT_TAP5
+ DELAY_OUT_TAP6 DELAY_OUT_TAP7 DELAY_OUT_TAP8 DELAY_OUT_TAP9 DELAY_OUT_TAP10 DELAY_OUT_TAP11 DELAY_OUT_TAP12 DELAY_OUT_TAP13 DELAY_OUT_TAP14
+ DELAY_OUT_TAP15 DELAY_OUT_TAP16 DELAY_OUT_TAP17 DELAY_OUT_TAP18 DELAY_OUT_TAP19 DELAY_OUT_TAP20 DELAY_OUT_TAP21 DELAY_OUT_TAP22 DELAY_OUT_TAP23
+ DELAY_OUT_TAP24 DELAY_OUT_TAP25 DELAY_OUT_TAP26 DELAY_OUT_TAP27 DELAY_OUT_TAP28 DELAY_OUT_TAP29 DELAY_OUT_TAP30 DELAY_OUT_TAP31 DELAY_IN
+ DELAY_VBIASN DELAY_VBIASP
*.PININFO VDD:I VSS:I DELAY_VBIASN:I DELAY_VBIASP:I DELAY_IN:I DELAY_OUT_TAP1:O DELAY_OUT_TAP2:O DELAY_OUT_TAP3:O DELAY_OUT_TAP4:O
*+ DELAY_OUT_TAP5:O DELAY_OUT_TAP6:O DELAY_OUT_TAP7:O DELAY_OUT_TAP8:O DELAY_OUT_TAP9:O DELAY_OUT_TAP10:O DELAY_OUT_TAP11:O DELAY_OUT_TAP12:O
*+ DELAY_OUT_TAP13:O DELAY_OUT_TAP14:O DELAY_OUT_TAP15:O DELAY_OUT_TAP16:O DELAY_OUT_TAP17:O DELAY_OUT_TAP18:O DELAY_OUT_TAP19:O DELAY_OUT_TAP20:O
*+ DELAY_OUT_TAP21:O DELAY_OUT_TAP22:O DELAY_OUT_TAP23:O DELAY_OUT_TAP24:O DELAY_OUT_TAP25:O DELAY_OUT_TAP26:O DELAY_OUT_TAP27:O DELAY_OUT_TAP28:O
*+ DELAY_OUT_TAP29:O DELAY_OUT_TAP30:O DELAY_OUT_TAP31:O DELAY_OUT_LAST:O
x0 VDD VSS net1 DELAY_OUT_TAP1 DELAY_IN DELAY_VBIASP DELAY_VBIASN hx_delay_cell
x1 VDD VSS net3 DELAY_OUT_TAP2 net1 DELAY_VBIASP DELAY_VBIASN hx_delay_cell
x2 VDD VSS net2 DELAY_OUT_TAP3 net3 DELAY_VBIASP DELAY_VBIASN hx_delay_cell
x3 VDD VSS net25 DELAY_OUT_TAP4 net2 DELAY_VBIASP DELAY_VBIASN hx_delay_cell
x4 VDD VSS net4 DELAY_OUT_TAP5 net25 DELAY_VBIASP DELAY_VBIASN hx_delay_cell
x5 VDD VSS net26 DELAY_OUT_TAP6 net4 DELAY_VBIASP DELAY_VBIASN hx_delay_cell
x6 VDD VSS net5 DELAY_OUT_TAP7 net26 DELAY_VBIASP DELAY_VBIASN hx_delay_cell
x7 VDD VSS net27 DELAY_OUT_TAP8 net5 DELAY_VBIASP DELAY_VBIASN hx_delay_cell
x8 VDD VSS net6 DELAY_OUT_TAP9 net27 DELAY_VBIASP DELAY_VBIASN hx_delay_cell
x9 VDD VSS net28 DELAY_OUT_TAP10 net6 DELAY_VBIASP DELAY_VBIASN hx_delay_cell
x10 VDD VSS net7 DELAY_OUT_TAP11 net28 DELAY_VBIASP DELAY_VBIASN hx_delay_cell
x11 VDD VSS net31 DELAY_OUT_TAP12 net7 DELAY_VBIASP DELAY_VBIASN hx_delay_cell
x12 VDD VSS net8 DELAY_OUT_TAP13 net31 DELAY_VBIASP DELAY_VBIASN hx_delay_cell
x13 VDD VSS net29 DELAY_OUT_TAP14 net8 DELAY_VBIASP DELAY_VBIASN hx_delay_cell
x14 VDD VSS net9 DELAY_OUT_TAP15 net29 DELAY_VBIASP DELAY_VBIASN hx_delay_cell
x15 VDD VSS net30 DELAY_OUT_TAP16 net9 DELAY_VBIASP DELAY_VBIASN hx_delay_cell
x16 VDD VSS net10 DELAY_OUT_TAP17 net30 DELAY_VBIASP DELAY_VBIASN hx_delay_cell
x17 VDD VSS net12 DELAY_OUT_TAP18 net10 DELAY_VBIASP DELAY_VBIASN hx_delay_cell
x18 VDD VSS net11 DELAY_OUT_TAP19 net12 DELAY_VBIASP DELAY_VBIASN hx_delay_cell
x19 VDD VSS net16 DELAY_OUT_TAP20 net11 DELAY_VBIASP DELAY_VBIASN hx_delay_cell
x20 VDD VSS net13 DELAY_OUT_TAP21 net16 DELAY_VBIASP DELAY_VBIASN hx_delay_cell
x21 VDD VSS net15 DELAY_OUT_TAP22 net13 DELAY_VBIASP DELAY_VBIASN hx_delay_cell
x22 VDD VSS net14 DELAY_OUT_TAP23 net15 DELAY_VBIASP DELAY_VBIASN hx_delay_cell
x23 VDD VSS net24 DELAY_OUT_TAP24 net14 DELAY_VBIASP DELAY_VBIASN hx_delay_cell
x24 VDD VSS net17 DELAY_OUT_TAP25 net24 DELAY_VBIASP DELAY_VBIASN hx_delay_cell
x25 VDD VSS net19 DELAY_OUT_TAP26 net17 DELAY_VBIASP DELAY_VBIASN hx_delay_cell
x26 VDD VSS net18 DELAY_OUT_TAP27 net19 DELAY_VBIASP DELAY_VBIASN hx_delay_cell
x27 VDD VSS net23 DELAY_OUT_TAP28 net18 DELAY_VBIASP DELAY_VBIASN hx_delay_cell
x28 VDD VSS net20 DELAY_OUT_TAP29 net23 DELAY_VBIASP DELAY_VBIASN hx_delay_cell
x29 VDD VSS net22 DELAY_OUT_TAP30 net20 DELAY_VBIASP DELAY_VBIASN hx_delay_cell
x30 VDD VSS net21 DELAY_OUT_TAP31 net22 DELAY_VBIASP DELAY_VBIASN hx_delay_cell
x31 VDD VSS DELAY_OUT_LAST net32 net21 DELAY_VBIASP DELAY_VBIASN hx_delay_cell
.ends

* expanding   symbol:  hx_delay_cell.sym # of pins=7
** sym_path: /home/hx2003/Desktop/ttihp-delay/schematics/hx_delay_cell.sym
** sch_path: /home/hx2003/Desktop/ttihp-delay/schematics/hx_delay_cell.sch
.subckt hx_delay_cell VDD VSS DELAY_CELL_OUT_INV DELAY_CELL_OUT DELAY_CELL_IN DELAY_VBIASP DELAY_VBIASN
*.PININFO VDD:I VSS:I DELAY_CELL_OUT_INV:O DELAY_VBIASN:I DELAY_VBIASP:I DELAY_CELL_IN:I DELAY_CELL_OUT:O
MM1 net1 DELAY_CELL_IN net3 VSS sg13_lv_nmos w=0.74u l=0.2u ng=1
MM2 net3 DELAY_VBIASN VSS VSS sg13_lv_nmos w=0.74u l=0.6u ng=1
MM3 net2 DELAY_VBIASP VDD VDD sg13_lv_pmos w=1.12u l=0.6u ng=1
MM4 DELAY_CELL_OUT net1 VSS VSS sg13_lv_nmos w=0.74u l=0.13u ng=1
MM5 net1 DELAY_CELL_IN net2 VDD sg13_lv_pmos w=1.12u l=0.2u ng=1
MM6 DELAY_CELL_OUT net1 VDD VDD sg13_lv_pmos w=1.12u l=0.13u ng=1
MM7 DELAY_CELL_OUT_INV DELAY_CELL_OUT VSS VSS sg13_lv_nmos w=0.74u l=0.13u ng=1
MM8 DELAY_CELL_OUT_INV DELAY_CELL_OUT VDD VDD sg13_lv_pmos w=1.12u l=0.13u ng=1
.ends
