** sch_path: /home/hx2003/Desktop/ttihp-delay/schematics/hx_mux_4to1_leaf.sch
.subckt hx_mux_4to1_leaf VSS MUX_ONEHOT_SEL2 MUX_ONEHOT_SEL3 MUX_ONEHOT_SEL0 MUX_ONEHOT_SEL1 MUX_IN1 MUX_IN2 MUX_IN3 MUX_IN0 VDD
+ MUX_OUT
*.PININFO VDD:I VSS:I MUX_IN0:I MUX_OUT:O MUX_ONEHOT_SEL0:I MUX_IN1:I MUX_IN2:I MUX_IN3:I MUX_ONEHOT_SEL1:I MUX_ONEHOT_SEL2:I
*+ MUX_ONEHOT_SEL3:I
MM2 net1 MUX_IN0 VSS VSS sg13_lv_nmos w=0.74u l=0.13u ng=1
MM1 net1 MUX_IN0 VDD VDD sg13_lv_pmos w=1.12u l=0.13u ng=1
MM3 net7 net2 VSS VSS sg13_lv_nmos w=0.74u l=0.13u ng=1
MM4 net7 net2 VDD VDD sg13_lv_pmos w=1.12u l=0.13u ng=1
MM5 net2 MUX_IN1 VSS VSS sg13_lv_nmos w=0.74u l=0.13u ng=1
MM6 net2 MUX_IN1 VDD VDD sg13_lv_pmos w=1.12u l=0.13u ng=1
MM7 net3 MUX_IN2 VSS VSS sg13_lv_nmos w=0.74u l=0.13u ng=1
MM8 net3 MUX_IN2 VDD VDD sg13_lv_pmos w=1.12u l=0.13u ng=1
MM9 net5 net4 VSS VSS sg13_lv_nmos w=0.74u l=0.13u ng=1
MM10 net5 net4 VDD VDD sg13_lv_pmos w=1.12u l=0.13u ng=1
MM11 net4 MUX_IN3 VSS VSS sg13_lv_nmos w=0.74u l=0.13u ng=1
MM12 net4 MUX_IN3 VDD VDD sg13_lv_pmos w=1.12u l=0.13u ng=1
MM13 net6 MUX_ONEHOT_SEL0 VSS VSS sg13_lv_nmos w=0.74u l=0.13u ng=1
MM14 net6 MUX_ONEHOT_SEL0 VDD VDD sg13_lv_pmos w=1.12u l=0.13u ng=1
MM15 net1 MUX_ONEHOT_SEL0 MUX_OUT VSS sg13_lv_nmos w=0.74u l=0.13u ng=1
MM16 net1 net6 MUX_OUT VDD sg13_lv_pmos w=1.12u l=0.13u ng=1
MM17 net8 MUX_ONEHOT_SEL1 VSS VSS sg13_lv_nmos w=0.74u l=0.13u ng=1
MM18 net8 MUX_ONEHOT_SEL1 VDD VDD sg13_lv_pmos w=1.12u l=0.13u ng=1
MM19 net7 MUX_ONEHOT_SEL1 MUX_OUT VSS sg13_lv_nmos w=0.74u l=0.13u ng=1
MM20 net7 net8 MUX_OUT VDD sg13_lv_pmos w=1.12u l=0.13u ng=1
MM21 net9 MUX_ONEHOT_SEL2 VSS VSS sg13_lv_nmos w=0.74u l=0.13u ng=1
MM22 net9 MUX_ONEHOT_SEL2 VDD VDD sg13_lv_pmos w=1.12u l=0.13u ng=1
MM23 net3 MUX_ONEHOT_SEL2 MUX_OUT VSS sg13_lv_nmos w=0.74u l=0.13u ng=1
MM24 net3 net9 MUX_OUT VDD sg13_lv_pmos w=1.12u l=0.13u ng=1
MM25 net10 MUX_ONEHOT_SEL3 VSS VSS sg13_lv_nmos w=0.74u l=0.13u ng=1
MM26 net10 MUX_ONEHOT_SEL3 VDD VDD sg13_lv_pmos w=1.12u l=0.13u ng=1
MM27 net5 MUX_ONEHOT_SEL3 MUX_OUT VSS sg13_lv_nmos w=0.74u l=0.13u ng=1
MM28 net5 net10 MUX_OUT VDD sg13_lv_pmos w=1.12u l=0.13u ng=1
.ends
