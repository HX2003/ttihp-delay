* NGSPICE file created from hx_delay_bank.ext - technology: ihp-sg13g2

.subckt hx_delay_bank VDD CHAN0_DELAY_OUT_LAST CHAN1_DELAY_OUT_LAST CHAN3_DELAY_OUT_LAST
+ CHAN2_DELAY_OUT_LAST REF_DELAY_OUT_LAST DLL_RESETN REF_CLK VSS CHAN0_DELAY_IN CHAN0_MUX_SEL0
+ CHAN0_MUX_SEL1 CHAN0_MUX_OUT CHAN0_MUX_SEL4 CHAN0_MUX_SEL2 CHAN0_MUX_SEL3 CHAN1_DELAY_IN
+ CHAN1_MUX_SEL0 CHAN1_MUX_SEL1 CHAN1_MUX_OUT CHAN1_MUX_SEL4 CHAN1_MUX_SEL2 CHAN1_MUX_SEL3
+ CHAN3_DELAY_IN CHAN2_DELAY_IN CHAN3_MUX_SEL0 CHAN2_MUX_SEL0 CHAN3_MUX_SEL1 CHAN2_MUX_SEL1
+ CHAN3_MUX_OUT CHAN2_MUX_OUT CHAN3_MUX_SEL4 CHAN2_MUX_SEL4 CHAN3_MUX_SEL2 CHAN2_MUX_SEL2
+ CHAN3_MUX_SEL3 CHAN2_MUX_SEL3 REF_MUX_SEL0 REF_MUX_SEL1 REF_MUX_OUT REF_MUX_SEL4
+ REF_MUX_SEL2 REF_MUX_SEL3
X0 VDD.t1296 a_4003_1842# a_4437_1842# VDD.t373 sg13_lv_pmos ad=0.2128p pd=1.5u as=0.3808p ps=2.92u w=1.12u l=0.13u
X1 VSS.t890 a_4187_1764.t102 a_26151_14024# VSS.t889 sg13_lv_nmos ad=0.2516p pd=2.16u as=0.1406p ps=1.12u w=0.74u l=0.6u
X2 a_22590_3889# a_22564_3853# a_22488_3889# VDD.t0 sg13_lv_pmos ad=0.3808p pd=2.92u as=0.2128p ps=1.5u w=1.12u l=0.13u
X3 a_15511_8160# a_15273_7532# a_15403_7532# VDD.t346 sg13_lv_pmos ad=0.2128p pd=1.5u as=0.3808p ps=2.92u w=1.12u l=0.2u
X4 a_5974_11413# a_6126_9506# VSS.t55 VSS.t49 sg13_lv_nmos ad=0.38p pd=2.38u as=0.68p ps=4.68u w=2u l=1u
X5 VDD.t551 a_3171_16074.t4 a_21044_16035# VDD.t90 sg13_lv_pmos ad=0.3808p pd=2.92u as=0.3808p ps=2.92u w=1.12u l=0.13u
X6 a_14751_14652# a_14513_14024# a_14643_14024# VDD.t374 sg13_lv_pmos ad=0.2128p pd=1.5u as=0.3808p ps=2.92u w=1.12u l=0.2u
X7 VSS.t543 VSS.t541 VSS.t540 VSS.t542 sg13_lv_nmos ad=0.1406p pd=1.12u as=0 ps=0 w=0.74u l=0.2u
X8 a_18551_5315# a_18313_4687# a_18443_4687# VDD.t348 sg13_lv_pmos ad=0.2128p pd=1.5u as=0.3808p ps=2.92u w=1.12u l=0.2u
X9 a_5731_15316# a_14825_15546# a_13470_16071# VDD.t90 sg13_lv_pmos ad=0.3808p pd=2.92u as=0.3808p ps=2.92u w=1.12u l=0.13u
X10 a_19073_14024# a_18877_14024# VDD.t1054 VDD.t374 sg13_lv_pmos ad=0.3808p pd=2.92u as=0.2128p ps=1.5u w=1.12u l=0.13u
X11 VDD.t331 VSS.t188 VDD.t330 VDD.t90 sg13_lv_pmos ad=0.34p pd=2.68u as=0 ps=0 w=1u l=1u
X12 VSS.t358 VDD.t1648 VSS.t358 VSS.t360 sg13_lv_nmos ad=0.1428p pd=1.52u as=0 ps=0 w=0.42u l=1u
X13 a_8808_3889# a_8237_4687# VDD.t1019 VDD.t0 sg13_lv_pmos ad=0.2128p pd=1.5u as=0.3808p ps=2.92u w=1.12u l=0.13u
X14 a_25153_4687# a_24957_4687# VSS.t42 VSS.t41 sg13_lv_nmos ad=0.2516p pd=2.16u as=0.1406p ps=1.12u w=0.74u l=0.13u
X15 VDD.t381 a_15108_11799# a_15053_11680# VDD.t355 sg13_lv_pmos ad=1.10612p pd=6.66u as=93.45f ps=0.865u w=0.42u l=0.13u
X16 VSS.t687 a_12037_4687# a_12505_3889# VSS.t686 sg13_lv_nmos ad=0.1665p pd=1.19u as=0.2516p ps=2.16u w=0.74u l=0.13u
X17 a_23871_16869# a_23633_16869# a_23763_16869# VSS.t946 sg13_lv_nmos ad=0.1406p pd=1.12u as=0.2516p ps=2.16u w=0.74u l=0.2u
X18 CHAN0_DELAY_OUT_LAST a_27997_16869# VSS.t75 VSS.t2325 sg13_lv_nmos ad=0.2516p pd=2.16u as=0.1406p ps=1.12u w=0.74u l=0.13u
X19 VSS.t1213 a_15077_1842# a_15545_1044# VSS.t1212 sg13_lv_nmos ad=0.1665p pd=1.19u as=0.2516p ps=2.16u w=0.74u l=0.13u
X20 a_15108_11015# a_12849_11557# VDD.t381 VDD.t355 sg13_lv_pmos ad=79.8f pd=0.8u as=1.03698p ps=6.245u w=0.42u l=0.13u
X21 a_3449_13577# CHAN1_MUX_SEL0 VDD.t903 VDD.t5 sg13_lv_pmos ad=0.1596p pd=1.22u as=0.2856p ps=2.36u w=0.84u l=0.13u
X22 VDD.t282 VSS.t333 VDD.t281 VDD.t67 sg13_lv_pmos ad=0.34p pd=2.68u as=0 ps=0 w=1u l=1u
X23 VDD.t276 VSS.t326 VDD.t274 VDD.t67 sg13_lv_pmos ad=0.19p pd=1.38u as=0 ps=0 w=1u l=1u
X24 VDD.t558 a_16851_5999# REF_MUX_OUT VDD.t67 sg13_lv_pmos ad=0.7336p pd=3.55u as=0.2128p ps=1.5u w=1.12u l=0.13u
X25 VSS.t1055 a_4187_1764.t136 a_24631_16869# VSS.t2110 sg13_lv_nmos ad=0.2516p pd=2.16u as=0.1406p ps=1.12u w=0.74u l=0.6u
X26 a_7390_6734# a_8231_6698# a_8155_6734# VDD.t67 sg13_lv_pmos ad=0.3808p pd=2.92u as=0.2128p ps=1.5u w=1.12u l=0.13u
X27 a_27915_1044# a_27705_1044# VDD.t961 VDD.t2 sg13_lv_pmos ad=0.2128p pd=1.5u as=0.252p ps=1.57u w=1.12u l=0.13u
X28 a_10430_6734# a_2019_6737.t7 a_10328_6734# VSS.t1710 sg13_lv_nmos ad=0.2516p pd=2.16u as=0.1406p ps=1.12u w=0.74u l=0.13u
X29 VDD.t502 a_3747_16074.t6 a_15831_16035# VDD.t90 sg13_lv_pmos ad=0.3808p pd=2.92u as=0.3808p ps=2.92u w=1.12u l=0.13u
X30 a_25630_13226# a_3171_13229.t2 a_27048_13226# VSS.t9 sg13_lv_nmos ad=0.2516p pd=2.16u as=0.1406p ps=1.12u w=0.74u l=0.13u
X31 VDD.t20 VSS.t251 VDD.t240 VDD.t5 sg13_lv_pmos ad=0.34p pd=2.68u as=0 ps=0 w=1u l=1u
X32 VSS.t27 a_1721_16422# a_2019_16074.t1 VSS.t1999 sg13_lv_nmos ad=0.2812p pd=2.24u as=0.1406p ps=1.12u w=0.74u l=0.13u
X33 a_2873_16422# CHAN0_MUX_SEL1 VDD.t352 VDD.t90 sg13_lv_pmos ad=0.1596p pd=1.22u as=0.2856p ps=2.36u w=0.84u l=0.13u
X34 a_22351_5315# a_22113_4687# a_22243_4687# VDD.t348 sg13_lv_pmos ad=0.2128p pd=1.5u as=0.3808p ps=2.92u w=1.12u l=0.2u
X35 a_1544_16071# CHAN0_MUX_SEL1 VDD.t353 VDD.t90 sg13_lv_pmos ad=0.3808p pd=2.92u as=0.3808p ps=2.92u w=1.12u l=0.13u
X36 VDD.t367 a_13883_7532# a_14317_7532# VDD.t346 sg13_lv_pmos ad=0.2128p pd=1.5u as=0.3808p ps=2.92u w=1.12u l=0.13u
X37 VSS.t32 a_11748_11799# a_11397_11918# VSS.t1083 sg13_lv_nmos ad=79.8f pd=0.8u as=0.1428p ps=1.52u w=0.42u l=0.13u
X38 VDD.t940 a_16923_4687# a_17357_4687# VDD.t348 sg13_lv_pmos ad=0.2128p pd=1.5u as=0.3808p ps=2.92u w=1.12u l=0.13u
X39 VSS.t312 VDD.t1665 VSS.t312 VSS.t317 sg13_lv_nmos ad=79.8f pd=0.8u as=0 ps=0 w=0.42u l=1u
X40 a_13818_11982# a_12849_11557# VSS.t161 VSS.t160 sg13_lv_nmos ad=37.8f pd=0.6u as=0.1701p ps=1.65u w=0.42u l=0.13u
X41 a_7390_6734# a_3171_6737.t8 a_8808_6734# VSS.t2120 sg13_lv_nmos ad=0.2516p pd=2.16u as=0.1406p ps=1.12u w=0.74u l=0.13u
X42 VSS.t403 VDD.t1633 VSS.t405 VSS.t404 sg13_lv_nmos ad=79.8f pd=0.8u as=0 ps=0 w=0.42u l=1u
X43 a_8433_16869# a_8237_16869# VSS.t669 VSS.t1239 sg13_lv_nmos ad=0.2516p pd=2.16u as=0.1406p ps=1.12u w=0.74u l=0.13u
X44 VSS.t482 a_2019_16074.t2 a_25604_16035# VSS.t2106 sg13_lv_nmos ad=0.2516p pd=2.16u as=0.2516p ps=2.16u w=0.74u l=0.13u
X45 a_22873_7532# a_22677_7532# VSS.t171 VSS.t170 sg13_lv_nmos ad=0.2516p pd=2.16u as=0.1406p ps=1.12u w=0.74u l=0.13u
X46 VSS.t379 VDD.t1640 VSS.t379 VSS.t380 sg13_lv_nmos ad=79.8f pd=0.8u as=0 ps=0 w=0.42u l=1u
X47 a_5115_13226# a_4905_13226# VSS.t1932 VSS.t2063 sg13_lv_nmos ad=0.1406p pd=1.12u as=0.1665p ps=1.19u w=0.74u l=0.13u
X48 a_6326_10280# a_6326_10280# VDD.t987 VDD.t355 sg13_lv_pmos ad=0.38p pd=2.38u as=0.38p ps=2.38u w=2u l=1u
X49 a_13566_11018# a_14009_10774# a_13306_10795# VSS.t471 sg13_lv_nmos ad=79.8f pd=0.8u as=0.1296p ps=1.52u w=0.42u l=0.13u
X50 VDD.t1289 a_27237_4687# a_27705_3889# VDD.t0 sg13_lv_pmos ad=0.252p pd=1.57u as=0.3808p ps=2.92u w=1.12u l=0.13u
X51 VSS.t319 VDD.t1664 VSS.t319 VSS.t320 sg13_lv_nmos ad=79.8f pd=0.8u as=0 ps=0 w=0.42u l=1u
X52 VSS.t725 a_3171_1047.t7 a_11924_1008# VSS.t1691 sg13_lv_nmos ad=0.2516p pd=2.16u as=0.2516p ps=2.16u w=0.74u l=0.13u
X53 a_10951_2470# a_10713_1842# a_10843_1842# VDD.t373 sg13_lv_pmos ad=0.2128p pd=1.5u as=0.3808p ps=2.92u w=1.12u l=0.2u
X54 VSS.t2093 a_1544_3134# a_2391_3176# VSS.t906 sg13_lv_nmos ad=0.1331p pd=1.12u as=0.1216p ps=1.02u w=0.64u l=0.13u
X55 VDD.t415 a_12037_7532# a_12505_6734# VDD.t67 sg13_lv_pmos ad=0.252p pd=1.57u as=0.3808p ps=2.92u w=1.12u l=0.13u
X56 VDD.t9 VSS.t451 VDD.t8 VDD.t2 sg13_lv_pmos ad=0.34p pd=2.68u as=0 ps=0 w=1u l=1u
X57 a_1721_15358# a_1256_15316# VDD.t1416 VDD.t90 sg13_lv_pmos ad=0.1596p pd=1.22u as=0.2856p ps=2.36u w=0.84u l=0.13u
X58 a_6326_10280# a_6126_9506# a_5778_9057# VSS.t46 sg13_lv_nmos ad=0.38p pd=2.38u as=0.68p ps=4.68u w=2u l=1u
X59 VSS.t574 a_4187_1764.t148 a_15511_16869# VSS.t2262 sg13_lv_nmos ad=0.2516p pd=2.16u as=0.1406p ps=1.12u w=0.74u l=0.6u
X60 a_25913_14024# a_25717_14024# VSS.t776 VSS.t938 sg13_lv_nmos ad=0.2516p pd=2.16u as=0.1406p ps=1.12u w=0.74u l=0.13u
X61 VDD.t547 a_4003_7532# a_4437_7532# VDD.t346 sg13_lv_pmos ad=0.2128p pd=1.5u as=0.3808p ps=2.92u w=1.12u l=0.13u
X62 a_10191_16869# a_9953_16869# a_10083_16869# VSS.t572 sg13_lv_nmos ad=0.1406p pd=1.12u as=0.2516p ps=2.16u w=0.74u l=0.2u
X63 VDD.t92 VSS.t221 VDD.t91 VDD.t90 sg13_lv_pmos ad=0.19p pd=1.38u as=0 ps=0 w=1u l=1u
X64 VSS.t407 VDD.t1632 VSS.t407 VSS.t406 sg13_lv_nmos ad=0.1428p pd=1.52u as=0 ps=0 w=0.42u l=1u
X65 VDD.t732 a_4187_2434# a_10951_5315# VDD.t348 sg13_lv_pmos ad=0.3808p pd=2.92u as=0.2128p ps=1.5u w=1.12u l=0.6u
X66 VDD.t770 a_15077_14024# a_15545_13226# VDD.t5 sg13_lv_pmos ad=0.252p pd=1.57u as=0.3808p ps=2.92u w=1.12u l=0.13u
X67 VSS.t147 a_1256_1044# a_2967_1395# VSS.t146 sg13_lv_nmos ad=0.1331p pd=1.12u as=0.1216p ps=1.02u w=0.64u l=0.13u
X68 VSS.t1186 a_4187_1764.t154 a_10951_16869# VSS.t1589 sg13_lv_nmos ad=0.2516p pd=2.16u as=0.1406p ps=1.12u w=0.74u l=0.6u
X69 a_21353_14024# a_21157_14024# VSS.t791 VSS.t1521 sg13_lv_nmos ad=0.2516p pd=2.16u as=0.1406p ps=1.12u w=0.74u l=0.13u
X70 a_9946_11995# a_9772_11533# VDD.t357 VDD.t355 sg13_lv_pmos ad=79.8f pd=0.8u as=0.1428p ps=1.52u w=0.42u l=0.13u
X71 a_5731_3134# a_3747_3156.t3 a_13470_3889# VSS.t1059 sg13_lv_nmos ad=0.2516p pd=2.16u as=0.2516p ps=2.16u w=0.74u l=0.13u
X72 a_16033_16869# a_15837_16869# VDD.t507 VDD.t368 sg13_lv_pmos ad=0.3808p pd=2.92u as=0.2128p ps=1.5u w=1.12u l=0.13u
X73 VDD.t29 VSS.t423 VDD.t28 VDD.t2 sg13_lv_pmos ad=0.34p pd=2.68u as=0 ps=0 w=1u l=1u
X74 VSS.t839 a_14643_14024# a_15077_14024# VSS.t888 sg13_lv_nmos ad=0.1406p pd=1.12u as=0.2516p ps=2.16u w=0.74u l=0.13u
X75 a_25153_1842# a_24957_1842# VSS.t793 VSS.t1483 sg13_lv_nmos ad=0.2516p pd=2.16u as=0.1406p ps=1.12u w=0.74u l=0.13u
X76 a_10328_3889# a_9757_4687# VSS.t61 VSS.t60 sg13_lv_nmos ad=0.1406p pd=1.12u as=0.2516p ps=2.16u w=0.74u l=0.13u
X77 VDD.t594 a_20723_4687# a_21157_4687# VDD.t348 sg13_lv_pmos ad=0.2128p pd=1.5u as=0.3808p ps=2.92u w=1.12u l=0.13u
X78 VDD.t1127 a_3171_13229.t3 a_24084_13190# VDD.t5 sg13_lv_pmos ad=0.3808p pd=2.92u as=0.3808p ps=2.92u w=1.12u l=0.13u
X79 a_17791_4687# a_17553_4687# a_17683_4687# VSS.t179 sg13_lv_nmos ad=0.1406p pd=1.12u as=0.2516p ps=2.16u w=0.74u l=0.2u
X80 VSS.t1021 a_15077_7532# a_15545_6734# VSS.t1020 sg13_lv_nmos ad=0.1665p pd=1.19u as=0.2516p ps=2.16u w=0.74u l=0.13u
X81 a_22590_3889# a_2019_3892.t3 a_22488_3889# VSS.t2023 sg13_lv_nmos ad=0.2516p pd=2.16u as=0.1406p ps=1.12u w=0.74u l=0.13u
X82 VDD.t142 VSS.t379 VDD.t141 VDD.t0 sg13_lv_pmos ad=0.34p pd=2.68u as=0 ps=0 w=1u l=1u
X83 a_25630_1044# a_2019_1047.t2 a_25528_1044# VSS.t973 sg13_lv_nmos ad=0.2516p pd=2.16u as=0.1406p ps=1.12u w=0.74u l=0.13u
X84 VDD.t88 VSS.t372 VDD.t86 VDD.t0 sg13_lv_pmos ad=0.19p pd=1.38u as=0 ps=0 w=1u l=1u
X85 VSS.t1275 a_9444_10280# a_9444_9602# VSS.t1274 sg13_lv_nmos ad=0.68p pd=4.68u as=0.38p ps=2.38u w=2u l=1u
X86 VDD.t747 a_4187_2434# a_19311_2470# VDD.t373 sg13_lv_pmos ad=0.3808p pd=2.92u as=0.2128p ps=1.5u w=1.12u l=0.6u
X87 a_8808_3889# a_8237_4687# VSS.t1348 VSS.t1347 sg13_lv_nmos ad=0.1406p pd=1.12u as=0.2516p ps=2.16u w=0.74u l=0.13u
X88 VSS.t1428 a_3747_6001.t2 a_26985_6209# VSS.t1427 sg13_lv_nmos ad=0.2516p pd=2.16u as=0.2516p ps=2.16u w=0.74u l=0.13u
X89 VSS.t2046 a_2019_13229.t6 a_13444_13190# VSS.t2045 sg13_lv_nmos ad=0.2516p pd=2.16u as=0.2516p ps=2.16u w=0.74u l=0.13u
X90 VDD.t264 VSS.t288 VDD.t263 VDD.t5 sg13_lv_pmos ad=0.19p pd=1.38u as=0 ps=0 w=1u l=1u
X91 VSS.t635 a_13123_16869# a_13557_16869# VSS.t1373 sg13_lv_nmos ad=0.1406p pd=1.12u as=0.2516p ps=2.16u w=0.74u l=0.13u
X92 VDD.t720 a_4187_2434# a_23871_5315# VDD.t348 sg13_lv_pmos ad=0.3808p pd=2.92u as=0.2128p ps=1.5u w=1.12u l=0.6u
X93 VSS.t664 a_3171_16074.t7 a_11924_16035# VSS.t663 sg13_lv_nmos ad=0.2516p pd=2.16u as=0.2516p ps=2.16u w=0.74u l=0.13u
X94 VDD.t506 a_3747_13229.t5 a_18871_13190# VDD.t5 sg13_lv_pmos ad=0.3808p pd=2.92u as=0.3808p ps=2.92u w=1.12u l=0.13u
X95 VSS.t473 a_14009_10774# a_14111_10917# VSS.t472 sg13_lv_nmos ad=1.45407p pd=9.445u as=0.2516p ps=2.16u w=0.74u l=0.13u
X96 a_6635_3889# a_6425_3889# VDD.t908 VDD.t0 sg13_lv_pmos ad=0.2128p pd=1.5u as=0.252p ps=1.57u w=1.12u l=0.13u
X97 VDD.t172 VSS.t312 VDD.t170 VDD.t67 sg13_lv_pmos ad=0.19p pd=1.38u as=0 ps=0 w=1u l=1u
X98 VDD.t848 a_4763_16869# a_5197_16869# VDD.t368 sg13_lv_pmos ad=0.2128p pd=1.5u as=0.3808p ps=2.92u w=1.12u l=0.13u
X99 a_16108_289# a_2019_311.t2 a_16510_1044# VSS.t2199 sg13_lv_nmos ad=0.2516p pd=2.16u as=0.2516p ps=2.16u w=0.74u l=0.13u
X100 VSS.t305 a_2019_6001.t3 a_5705_6209# VSS.t1890 sg13_lv_nmos ad=0.2516p pd=2.16u as=0.2516p ps=2.16u w=0.74u l=0.13u
X101 VDD.t341 a_3747_12493.t2 a_26985_12701# VDD.t5 sg13_lv_pmos ad=0.3808p pd=2.92u as=0.3808p ps=2.92u w=1.12u l=0.13u
X102 VDD.t1375 a_2595_3892.t9 a_5191_3853# VDD.t0 sg13_lv_pmos ad=0.3808p pd=2.92u as=0.3808p ps=2.92u w=1.12u l=0.13u
X103 VSS.t159 a_13121_11521# a_13045_11905# VSS.t1862 sg13_lv_nmos ad=0.2516p pd=2.16u as=0.1406p ps=1.12u w=0.74u l=0.13u
X104 VDD.t752 a_4187_2434# a_9431_2470# VDD.t373 sg13_lv_pmos ad=0.3808p pd=2.92u as=0.2128p ps=1.5u w=1.12u l=0.6u
X105 a_21591_4687# a_21353_4687# a_21483_4687# VSS.t622 sg13_lv_nmos ad=0.1406p pd=1.12u as=0.2516p ps=2.16u w=0.74u l=0.2u
X106 VDD.t1508 a_2595_16074.t2 a_26471_16035# VDD.t90 sg13_lv_pmos ad=0.3808p pd=2.92u as=0.3808p ps=2.92u w=1.12u l=0.13u
X107 a_20315_3889# a_20105_3889# VDD.t1003 VDD.t0 sg13_lv_pmos ad=0.2128p pd=1.5u as=0.252p ps=1.57u w=1.12u l=0.13u
X108 a_6153_4687# a_5957_4687# VSS.t919 VSS.t1170 sg13_lv_nmos ad=0.2516p pd=2.16u as=0.1406p ps=1.12u w=0.74u l=0.13u
X109 VDD.t217 VSS.t319 VDD.t215 VDD.t67 sg13_lv_pmos ad=0.19p pd=1.38u as=0 ps=0 w=1u l=1u
X110 VSS.t305 VDD.t1669 VSS.t305 VSS.t308 sg13_lv_nmos ad=79.8f pd=0.8u as=0 ps=0 w=0.42u l=1u
X111 VSS.t460 VDD.t1619 VSS.t459 VSS.t458 sg13_lv_nmos ad=0.1428p pd=1.52u as=0 ps=0 w=0.42u l=1u
X112 a_25528_3889# a_24957_4687# VDD.t360 VDD.t0 sg13_lv_pmos ad=0.2128p pd=1.5u as=0.3808p ps=2.92u w=1.12u l=0.13u
X113 a_26911_14024# a_26673_14024# a_26803_14024# VSS.t1581 sg13_lv_nmos ad=0.1406p pd=1.12u as=0.2516p ps=2.16u w=0.74u l=0.2u
X114 a_15108_11799# a_14851_11918# a_15270_11995# VSS.t156 sg13_lv_nmos ad=0.1428p pd=1.52u as=37.8f ps=0.6u w=0.42u l=0.13u
X115 VSS.t986 a_16163_4687# a_16597_4687# VSS.t1183 sg13_lv_nmos ad=0.1406p pd=1.12u as=0.2516p ps=2.16u w=0.74u l=0.13u
X116 a_13231_5315# a_12993_4687# a_13123_4687# VDD.t348 sg13_lv_pmos ad=0.2128p pd=1.5u as=0.3808p ps=2.92u w=1.12u l=0.2u
X117 VDD.t1126 a_3171_13229.t6 a_14964_13190# VDD.t5 sg13_lv_pmos ad=0.3808p pd=2.92u as=0.3808p ps=2.92u w=1.12u l=0.13u
X118 CHAN1_MUX_OUT a_16851_12491# VSS.t764 VSS.t2170 sg13_lv_nmos ad=0.1406p pd=1.12u as=0.1371p ps=1.12u w=0.74u l=0.13u
X119 a_10951_8160# a_10713_7532# a_10843_7532# VDD.t346 sg13_lv_pmos ad=0.2128p pd=1.5u as=0.3808p ps=2.92u w=1.12u l=0.2u
X120 VSS.t1386 a_3171_6737.t7 a_11924_6698# VSS.t1877 sg13_lv_nmos ad=0.2516p pd=2.16u as=0.2516p ps=2.16u w=0.74u l=0.13u
X121 a_10328_6734# a_9757_7532# VDD.t1472 VDD.t67 sg13_lv_pmos ad=0.2128p pd=1.5u as=0.3808p ps=2.92u w=1.12u l=0.13u
X122 a_3449_6021# REF_MUX_SEL2 VDD.t1544 VDD.t67 sg13_lv_pmos ad=0.1596p pd=1.22u as=0.2856p ps=2.36u w=0.84u l=0.13u
X123 VDD.t765 a_4187_2434# a_23111_2470# VDD.t373 sg13_lv_pmos ad=0.3808p pd=2.92u as=0.2128p ps=1.5u w=1.12u l=0.6u
X124 VSS.t1701 a_4187_1764.t100 a_27671_14024# VSS.t1700 sg13_lv_nmos ad=0.2516p pd=2.16u as=0.1406p ps=1.12u w=0.74u l=0.6u
X125 a_22351_14024# a_22113_14024# a_22243_14024# VSS.t2249 sg13_lv_nmos ad=0.1406p pd=1.12u as=0.2516p ps=2.16u w=0.74u l=0.2u
X126 VSS.t1550 a_3747_15338.t3 a_14825_15546# VSS.t1549 sg13_lv_nmos ad=0.2516p pd=2.16u as=0.2516p ps=2.16u w=0.74u l=0.13u
X127 a_1721_12513# a_1256_12471# VDD.t1141 VDD.t5 sg13_lv_pmos ad=0.1596p pd=1.22u as=0.2856p ps=2.36u w=0.84u l=0.13u
X128 VDD.t880 a_2019_16074.t3 a_22564_16035# VDD.t90 sg13_lv_pmos ad=0.3808p pd=2.92u as=0.3808p ps=2.92u w=1.12u l=0.13u
X129 a_22590_6734# a_22564_6698# a_22488_6734# VDD.t67 sg13_lv_pmos ad=0.3808p pd=2.92u as=0.2128p ps=1.5u w=1.12u l=0.13u
X130 a_7390_1044# a_8231_1008# a_8155_1044# VDD.t2 sg13_lv_pmos ad=0.3808p pd=2.92u as=0.2128p ps=1.5u w=1.12u l=0.13u
X131 VSS.t864 a_1256_6734# a_2967_7085# VSS.t1573 sg13_lv_nmos ad=0.1331p pd=1.12u as=0.1216p ps=1.02u w=0.64u l=0.13u
X132 VSS.t390 VDD.t1636 VSS.t390 VSS.t391 sg13_lv_nmos ad=0.1428p pd=1.52u as=0 ps=0 w=0.42u l=1u
X133 a_10713_16869# a_10517_16869# VSS.t120 VSS.t670 sg13_lv_nmos ad=0.2516p pd=2.16u as=0.1406p ps=1.12u w=0.74u l=0.13u
X134 VSS.t165 a_4187_1764.t57 a_10191_4687# VSS.t2051 sg13_lv_nmos ad=0.2516p pd=2.16u as=0.1406p ps=1.12u w=0.74u l=0.6u
X135 a_12233_4687# a_12037_4687# VDD.t561 VDD.t348 sg13_lv_pmos ad=0.3808p pd=2.92u as=0.2128p ps=1.5u w=1.12u l=0.13u
X136 a_7390_16071# a_7364_16035# a_7288_16071# VDD.t90 sg13_lv_pmos ad=0.3808p pd=2.92u as=0.2128p ps=1.5u w=1.12u l=0.13u
X137 a_16108_15316# CHAN0_MUX_SEL4 a_15964_15316# VSS.t2148 sg13_lv_nmos ad=0.2516p pd=2.16u as=0.2183p ps=1.33u w=0.74u l=0.13u
X138 a_16033_14024# a_15837_14024# VDD.t791 VDD.t374 sg13_lv_pmos ad=0.3808p pd=2.92u as=0.2128p ps=1.5u w=1.12u l=0.13u
X139 a_8808_6734# a_8237_7532# VDD.t895 VDD.t67 sg13_lv_pmos ad=0.2128p pd=1.5u as=0.3808p ps=2.92u w=1.12u l=0.13u
X140 VSS.t411 a_2595_311.t3 a_8745_519# VSS.t1135 sg13_lv_nmos ad=0.2516p pd=2.16u as=0.2516p ps=2.16u w=0.74u l=0.13u
X141 VSS.t1885 a_27237_4687# a_27705_3889# VSS.t2312 sg13_lv_nmos ad=0.1665p pd=1.19u as=0.2516p ps=2.16u w=0.74u l=0.13u
X142 a_25153_7532# a_24957_7532# VSS.t118 VSS.t2292 sg13_lv_nmos ad=0.2516p pd=2.16u as=0.1406p ps=1.12u w=0.74u l=0.13u
X143 a_2297_15358# CHAN0_MUX_SEL2 VDD.t590 VDD.t90 sg13_lv_pmos ad=0.1596p pd=1.22u as=0.2856p ps=2.36u w=0.84u l=0.13u
X144 a_17791_1842# a_17553_1842# a_17683_1842# VSS.t2339 sg13_lv_nmos ad=0.1406p pd=1.12u as=0.2516p ps=2.16u w=0.74u l=0.2u
X145 VDD.t344 a_2019_12493.t2 a_17865_12701# VDD.t5 sg13_lv_pmos ad=0.3808p pd=2.92u as=0.3808p ps=2.92u w=1.12u l=0.13u
X146 a_14851_11918# a_14009_11568# a_13592_11561# VDD.t355 sg13_lv_pmos ad=0.2048p pd=1.63u as=0.34p ps=2.68u w=1u l=0.13u
X147 a_25153_16869# a_24957_16869# VSS.t1055 VSS.t1054 sg13_lv_nmos ad=0.2516p pd=2.16u as=0.1406p ps=1.12u w=0.74u l=0.13u
X148 VSS.t94 a_19963_4687# a_20397_4687# VSS.t1081 sg13_lv_nmos ad=0.1406p pd=1.12u as=0.2516p ps=2.16u w=0.74u l=0.13u
X149 VDD.t992 a_6326_10280# a_6126_9506# VDD.t355 sg13_lv_pmos ad=0.38p pd=2.38u as=0.38p ps=2.38u w=2u l=1u
X150 VDD.t1232 a_1721_12513# a_2019_12493.t0 VDD.t5 sg13_lv_pmos ad=0.4256p pd=3u as=0.2128p ps=1.5u w=1.12u l=0.13u
X151 a_12656_11554# DLL_RESETN VDD.t1501 VDD.t355 sg13_lv_pmos ad=0.3808p pd=2.92u as=0.3808p ps=2.92u w=1.12u l=0.13u
X152 a_25630_6734# a_2019_6737.t2 a_25528_6734# VSS.t2252 sg13_lv_nmos ad=0.2516p pd=2.16u as=0.1406p ps=1.12u w=0.74u l=0.13u
X153 VDD.t386 a_2595_16074.t5 a_17351_16035# VDD.t90 sg13_lv_pmos ad=0.3808p pd=2.92u as=0.3808p ps=2.92u w=1.12u l=0.13u
X154 VDD.t693 a_4187_2434# a_19311_8160# VDD.t346 sg13_lv_pmos ad=0.3808p pd=2.92u as=0.2128p ps=1.5u w=1.12u l=0.6u
X155 a_25630_16071# a_3171_16074.t2 a_27048_16071# VSS.t1201 sg13_lv_nmos ad=0.2516p pd=2.16u as=0.1406p ps=1.12u w=0.74u l=0.13u
X156 VDD.t921 a_3747_16074.t7 a_12791_16035# VDD.t90 sg13_lv_pmos ad=0.3808p pd=2.92u as=0.3808p ps=2.92u w=1.12u l=0.13u
X157 a_2595_13229.t1 a_2297_13577# VSS.t1074 VSS.t2343 sg13_lv_nmos ad=0.1406p pd=1.12u as=0.1331p ps=1.12u w=0.74u l=0.13u
X158 VDD.t897 a_12037_1842# a_12505_1044# VDD.t2 sg13_lv_pmos ad=0.252p pd=1.57u as=0.3808p ps=2.92u w=1.12u l=0.13u
X159 a_13231_14024# a_12993_14024# a_13123_14024# VSS.t1246 sg13_lv_nmos ad=0.1406p pd=1.12u as=0.2516p ps=2.16u w=0.74u l=0.2u
X160 VDD.t122 VSS.t358 VDD.t120 VDD.t0 sg13_lv_pmos ad=0.19p pd=1.38u as=0 ps=0 w=1u l=1u
X161 a_16510_1044# a_2019_1047.t5 a_16408_1044# VSS.t2002 sg13_lv_nmos ad=0.2516p pd=2.16u as=0.1406p ps=1.12u w=0.74u l=0.13u
X162 VSS.t346 VDD.t1653 VSS.t346 VSS.t350 sg13_lv_nmos ad=79.8f pd=0.8u as=0 ps=0 w=0.42u l=1u
X163 VDD.t1315 a_4763_14024# a_5197_14024# VDD.t374 sg13_lv_pmos ad=0.2128p pd=1.5u as=0.3808p ps=2.92u w=1.12u l=0.13u
X164 VDD.t102 VSS.t305 VDD.t100 VDD.t67 sg13_lv_pmos ad=0.19p pd=1.38u as=0 ps=0 w=1u l=1u
X165 VSS.t78 a_4187_1764.t118 a_13991_14024# VSS.t1219 sg13_lv_nmos ad=0.2516p pd=2.16u as=0.1406p ps=1.12u w=0.74u l=0.6u
X166 a_9953_16869# a_9757_16869# VSS.t68 VSS.t1368 sg13_lv_nmos ad=0.2516p pd=2.16u as=0.1406p ps=1.12u w=0.74u l=0.13u
X167 VSS.t274 VDD.t1678 VSS.t274 VSS.t273 sg13_lv_nmos ad=0.1428p pd=1.52u as=0 ps=0 w=0.42u l=1u
X168 VDD.t692 a_4187_2434# a_9431_8160# VDD.t346 sg13_lv_pmos ad=0.3808p pd=2.92u as=0.2128p ps=1.5u w=1.12u l=0.6u
X169 a_21591_1842# a_21353_1842# a_21483_1842# VSS.t1328 sg13_lv_nmos ad=0.1406p pd=1.12u as=0.2516p ps=2.16u w=0.74u l=0.2u
X170 a_2873_3176# CHAN2_MUX_SEL3 VDD.t805 VDD.t0 sg13_lv_pmos ad=0.1596p pd=1.22u as=0.2856p ps=2.36u w=0.84u l=0.13u
X171 VSS.t1866 a_2019_6001.t2 a_17865_6209# VSS.t1865 sg13_lv_nmos ad=0.2516p pd=2.16u as=0.2516p ps=2.16u w=0.74u l=0.13u
X172 a_6153_1842# a_5957_1842# VSS.t1108 VSS.t1952 sg13_lv_nmos ad=0.2516p pd=2.16u as=0.1406p ps=1.12u w=0.74u l=0.13u
X173 VDD.t33 VSS.t365 VDD.t31 VDD.t0 sg13_lv_pmos ad=0.19p pd=1.38u as=0 ps=0 w=1u l=1u
X174 a_5115_16071# a_4905_16071# VSS.t881 VSS.t2060 sg13_lv_nmos ad=0.1406p pd=1.12u as=0.1665p ps=1.19u w=0.74u l=0.13u
X175 VSS.t730 a_3171_1047.t2 a_27124_1008# VSS.t729 sg13_lv_nmos ad=0.2516p pd=2.16u as=0.2516p ps=2.16u w=0.74u l=0.13u
X176 VSS.t937 a_16163_1842# a_16597_1842# VSS.t936 sg13_lv_nmos ad=0.1406p pd=1.12u as=0.2516p ps=2.16u w=0.74u l=0.13u
X177 VDD.t1092 a_2595_6001.t2 a_20905_6209# VDD.t67 sg13_lv_pmos ad=0.3808p pd=2.92u as=0.3808p ps=2.92u w=1.12u l=0.13u
X178 VDD.t1026 a_27237_7532# a_27705_6734# VDD.t67 sg13_lv_pmos ad=0.252p pd=1.57u as=0.3808p ps=2.92u w=1.12u l=0.13u
X179 VDD.t710 a_4187_2434# a_23111_8160# VDD.t346 sg13_lv_pmos ad=0.3808p pd=2.92u as=0.2128p ps=1.5u w=1.12u l=0.6u
X180 VDD.t954 a_11603_1842# a_12037_1842# VDD.t373 sg13_lv_pmos ad=0.2128p pd=1.5u as=0.3808p ps=2.92u w=1.12u l=0.13u
X181 a_6635_3889# a_6425_3889# VSS.t1169 VSS.t1793 sg13_lv_nmos ad=0.1406p pd=1.12u as=0.1665p ps=1.19u w=0.74u l=0.13u
X182 VSS.t1142 a_1544_5979# a_2391_6021# VSS.t741 sg13_lv_nmos ad=0.1331p pd=1.12u as=0.1216p ps=1.02u w=0.64u l=0.13u
X183 a_11711_16869# a_11473_16869# a_11603_16869# VSS.t1241 sg13_lv_nmos ad=0.1406p pd=1.12u as=0.2516p ps=2.16u w=0.74u l=0.2u
X184 VDD.t1487 a_3171_311.t3 a_11785_519# VDD.t2 sg13_lv_pmos ad=0.3808p pd=2.92u as=0.3808p ps=2.92u w=1.12u l=0.13u
X185 VDD.t742 a_4187_2434# a_26151_5315# VDD.t348 sg13_lv_pmos ad=0.3808p pd=2.92u as=0.2128p ps=1.5u w=1.12u l=0.6u
X186 a_5731_289# a_2595_311.t3 a_7390_1044# VSS.t1134 sg13_lv_nmos ad=0.2516p pd=2.16u as=0.2516p ps=2.16u w=0.74u l=0.13u
X187 a_10430_1044# a_2595_1047.t7 a_11195_1044# VSS.t723 sg13_lv_nmos ad=0.2516p pd=2.16u as=0.1406p ps=1.12u w=0.74u l=0.13u
X188 VSS.t872 a_2595_3892.t9 a_5191_3853# VSS.t2019 sg13_lv_nmos ad=0.2516p pd=2.16u as=0.2516p ps=2.16u w=0.74u l=0.13u
X189 a_6854_11676# a_6326_10280# VDD.t444 VDD.t355 sg13_lv_pmos ad=0.38p pd=2.38u as=0.38p ps=2.38u w=2u l=1u
X190 a_15464_9374# a_14851_10872# VSS.t163 VSS.t1175 sg13_lv_nmos ad=0.2849p pd=2.25u as=0.2516p ps=2.16u w=0.74u l=0.13u
X191 a_24393_1842# a_24197_1842# VDD.t979 VDD.t373 sg13_lv_pmos ad=0.3808p pd=2.92u as=0.2128p ps=1.5u w=1.12u l=0.13u
X192 VSS.t1599 a_4187_1764.t152 a_12471_16869# VSS.t1598 sg13_lv_nmos ad=0.2516p pd=2.16u as=0.1406p ps=1.12u w=0.74u l=0.6u
X193 a_22873_14024# a_22677_14024# VSS.t643 VSS.t2335 sg13_lv_nmos ad=0.2516p pd=2.16u as=0.1406p ps=1.12u w=0.74u l=0.13u
X194 a_16408_3889# a_15837_4687# VDD.t545 VDD.t0 sg13_lv_pmos ad=0.2128p pd=1.5u as=0.3808p ps=2.92u w=1.12u l=0.13u
X195 a_20315_3889# a_20105_3889# VSS.t1322 VSS.t1802 sg13_lv_nmos ad=0.1406p pd=1.12u as=0.1665p ps=1.19u w=0.74u l=0.13u
X196 a_17553_16869# a_17357_16869# VDD.t1458 VDD.t368 sg13_lv_pmos ad=0.3808p pd=2.92u as=0.2128p ps=1.5u w=1.12u l=0.13u
X197 VDD.t186 VSS.t209 VDD.t184 VDD.t90 sg13_lv_pmos ad=0.19p pd=1.38u as=0 ps=0 w=1u l=1u
X198 a_27048_16071# a_26477_16869# VDD.t1580 VDD.t90 sg13_lv_pmos ad=0.2128p pd=1.5u as=0.3808p ps=2.92u w=1.12u l=0.13u
X199 VSS.t843 a_16163_14024# a_16597_14024# VSS.t1481 sg13_lv_nmos ad=0.1406p pd=1.12u as=0.2516p ps=2.16u w=0.74u l=0.13u
X200 a_23355_1044# a_23145_1044# VSS.t1225 VSS.t1224 sg13_lv_nmos ad=0.1406p pd=1.12u as=0.1665p ps=1.19u w=0.74u l=0.13u
X201 a_25528_3889# a_24957_4687# VSS.t40 VSS.t39 sg13_lv_nmos ad=0.1406p pd=1.12u as=0.2516p ps=2.16u w=0.74u l=0.13u
X202 VSS.t589 a_1256_3889# a_2967_4240# VSS.t588 sg13_lv_nmos ad=0.1331p pd=1.12u as=0.1216p ps=1.02u w=0.64u l=0.13u
X203 VDD.t1197 a_2019_13229.t2 a_25604_13190# VDD.t5 sg13_lv_pmos ad=0.3808p pd=2.92u as=0.3808p ps=2.92u w=1.12u l=0.13u
X204 VDD.t616 a_4187_2434# a_4871_5315# VDD.t348 sg13_lv_pmos ad=0.3808p pd=2.92u as=0.2128p ps=1.5u w=1.12u l=0.6u
X205 VDD.t631 a_4187_2434# a_4111_17497# VDD.t368 sg13_lv_pmos ad=0.3808p pd=2.92u as=0.2128p ps=1.5u w=1.12u l=0.6u
X206 a_26151_16869# a_25913_16869# a_26043_16869# VSS.t73 sg13_lv_nmos ad=0.1406p pd=1.12u as=0.2516p ps=2.16u w=0.74u l=0.2u
X207 VSS.t887 a_4187_1764.t25 a_10191_1842# VSS.t901 sg13_lv_nmos ad=0.2516p pd=2.16u as=0.1406p ps=1.12u w=0.74u l=0.6u
X208 VSS.t319 VDD.t1662 VSS.t319 VSS.t323 sg13_lv_nmos ad=0.1428p pd=1.52u as=0 ps=0 w=0.42u l=1u
X209 VSS.t301 VDD.t1671 VSS.t301 VSS.t303 sg13_lv_nmos ad=79.8f pd=0.8u as=0 ps=0 w=0.42u l=1u
X210 VDD.t1073 REF_MUX_SEL1 a_3449_7085# VDD.t67 sg13_lv_pmos ad=0.1918p pd=1.5u as=0.1596p ps=1.22u w=0.84u l=0.13u
X211 VSS.t708 a_3747_1047.t4 a_21911_1008# VSS.t707 sg13_lv_nmos ad=0.2516p pd=2.16u as=0.2516p ps=2.16u w=0.74u l=0.13u
X212 VSS.t1128 a_11603_14024# a_12037_14024# VSS.t1245 sg13_lv_nmos ad=0.1406p pd=1.12u as=0.2516p ps=2.16u w=0.74u l=0.13u
X213 a_9772_11533# a_9746_11495# VDD.t381 VDD.t355 sg13_lv_pmos ad=0.3927p pd=2.99u as=1.10612p ps=6.66u w=1.155u l=0.13u
X214 a_17791_7532# a_17553_7532# a_17683_7532# VSS.t1091 sg13_lv_nmos ad=0.1406p pd=1.12u as=0.2516p ps=2.16u w=0.74u l=0.2u
X215 VDD.t756 a_4187_2434# a_14751_2470# VDD.t373 sg13_lv_pmos ad=0.3808p pd=2.92u as=0.2128p ps=1.5u w=1.12u l=0.6u
X216 a_2297_12513# CHAN1_MUX_SEL2 VDD.t1454 VDD.t5 sg13_lv_pmos ad=0.1596p pd=1.22u as=0.2856p ps=2.36u w=0.84u l=0.13u
X217 a_10232_11561# a_10206_11525# VDD.t537 VDD.t355 sg13_lv_pmos ad=0.34p pd=2.68u as=0.36237p ps=2.605u w=1u l=0.13u
X218 a_11473_4687# a_11277_4687# VSS.t484 VSS.t483 sg13_lv_nmos ad=0.2516p pd=2.16u as=0.1406p ps=1.12u w=0.74u l=0.13u
X219 VSS.t604 a_19963_1842# a_20397_1842# VSS.t748 sg13_lv_nmos ad=0.1406p pd=1.12u as=0.2516p ps=2.16u w=0.74u l=0.13u
X220 a_2967_15358# CHAN0_MUX_SEL3 a_2873_15358# VSS.t1154 sg13_lv_nmos ad=0.1216p pd=1.02u as=0.2176p ps=1.96u w=0.64u l=0.13u
X221 VSS.t365 VDD.t1644 VSS.t365 VSS.t370 sg13_lv_nmos ad=79.8f pd=0.8u as=0 ps=0 w=0.42u l=1u
X222 a_7390_3889# a_9751_3853# a_9675_3889# VDD.t0 sg13_lv_pmos ad=0.3808p pd=2.92u as=0.2128p ps=1.5u w=1.12u l=0.13u
X223 VDD.t729 a_4187_2434# a_4111_2470# VDD.t373 sg13_lv_pmos ad=0.3808p pd=2.92u as=0.2128p ps=1.5u w=1.12u l=0.6u
X224 VSS.t1618 a_2019_16074.t6 a_13444_16035# VSS.t1617 sg13_lv_nmos ad=0.2516p pd=2.16u as=0.2516p ps=2.16u w=0.74u l=0.13u
X225 a_20968_1044# a_20397_1842# VSS.t602 VSS.t601 sg13_lv_nmos ad=0.1406p pd=1.12u as=0.2516p ps=2.16u w=0.74u l=0.13u
X226 a_10328_1044# a_9757_1842# VDD.t1050 VDD.t2 sg13_lv_pmos ad=0.2128p pd=1.5u as=0.3808p ps=2.92u w=1.12u l=0.13u
X227 VDD.t297 VSS.t346 VDD.t295 VDD.t67 sg13_lv_pmos ad=0.19p pd=1.38u as=0 ps=0 w=1u l=1u
X228 VSS.t2039 a_2019_13229.t7 a_10404_13190# VSS.t2038 sg13_lv_nmos ad=0.2516p pd=2.16u as=0.2516p ps=2.16u w=0.74u l=0.13u
X229 VDD.t1100 a_6283_16869# a_6717_16869# VDD.t368 sg13_lv_pmos ad=0.2128p pd=1.5u as=0.3808p ps=2.92u w=1.12u l=0.13u
X230 a_6635_6734# a_6425_6734# VDD.t379 VDD.t67 sg13_lv_pmos ad=0.2128p pd=1.5u as=0.252p ps=1.57u w=1.12u l=0.13u
X231 a_16510_6734# a_2019_6737.t5 a_16408_6734# VSS.t1112 sg13_lv_nmos ad=0.2516p pd=2.16u as=0.1406p ps=1.12u w=0.74u l=0.13u
X232 a_22590_1044# a_22564_1008# a_22488_1044# VDD.t2 sg13_lv_pmos ad=0.3808p pd=2.92u as=0.2128p ps=1.5u w=1.12u l=0.13u
X233 VDD.t1205 a_3747_15338.t2 a_26985_15546# VDD.t90 sg13_lv_pmos ad=0.3808p pd=2.92u as=0.3808p ps=2.92u w=1.12u l=0.13u
X234 VDD.t194 VSS.t417 VDD.t160 VDD.t2 sg13_lv_pmos ad=0.19p pd=1.38u as=0 ps=0 w=1u l=1u
X235 a_22590_16071# a_24084_16035# a_24008_16071# VDD.t90 sg13_lv_pmos ad=0.3808p pd=2.92u as=0.2128p ps=1.5u w=1.12u l=0.13u
X236 VDD.t261 VSS.t195 VDD.t259 VDD.t90 sg13_lv_pmos ad=0.19p pd=1.38u as=0 ps=0 w=1u l=1u
X237 VDD.t884 a_2595_6737.t9 a_5191_6698# VDD.t67 sg13_lv_pmos ad=0.3808p pd=2.92u as=0.3808p ps=2.92u w=1.12u l=0.13u
X238 VDD.t54 VSS.t86 VDD.t52 VDD.t0 sg13_lv_pmos ad=0.19p pd=1.38u as=0 ps=0 w=1u l=1u
X239 VDD.t1274 a_3449_4240# a_3747_3892.t0 VDD.t0 sg13_lv_pmos ad=0.4256p pd=3u as=0.2128p ps=1.5u w=1.12u l=0.13u
X240 a_21591_7532# a_21353_7532# a_21483_7532# VSS.t1163 sg13_lv_nmos ad=0.1406p pd=1.12u as=0.2516p ps=2.16u w=0.74u l=0.2u
X241 a_6153_7532# a_5957_7532# VSS.t90 VSS.t89 sg13_lv_nmos ad=0.2516p pd=2.16u as=0.1406p ps=1.12u w=0.74u l=0.13u
X242 a_20315_6734# a_20105_6734# VDD.t835 VDD.t67 sg13_lv_pmos ad=0.2128p pd=1.5u as=0.252p ps=1.57u w=1.12u l=0.13u
X243 a_8808_1044# a_8237_1842# VDD.t928 VDD.t2 sg13_lv_pmos ad=0.2128p pd=1.5u as=0.3808p ps=2.92u w=1.12u l=0.13u
X244 VDD.t485 VDD.t483 VDD.t484 VDD.t348 sg13_lv_pmos ad=0.3808p pd=2.92u as=0 ps=0 w=1.12u l=0.6u
X245 a_1256_12471# CHAN1_MUX_SEL2 VSS.t149 VSS.t2139 sg13_lv_nmos ad=0.2516p pd=2.16u as=0.2516p ps=2.16u w=0.74u l=0.13u
X246 a_25528_6734# a_24957_7532# VDD.t1552 VDD.t67 sg13_lv_pmos ad=0.2128p pd=1.5u as=0.3808p ps=2.92u w=1.12u l=0.13u
X247 a_3171_13229.t1 a_2873_13577# VSS.t1074 VSS.t1073 sg13_lv_nmos ad=0.1406p pd=1.12u as=0.1331p ps=1.12u w=0.74u l=0.13u
X248 VSS.t1585 a_16163_7532# a_16597_7532# VSS.t1594 sg13_lv_nmos ad=0.1406p pd=1.12u as=0.2516p ps=2.16u w=0.74u l=0.13u
X249 VSS.t1124 a_3171_6737.t2 a_27124_6698# VSS.t1390 sg13_lv_nmos ad=0.2516p pd=2.16u as=0.2516p ps=2.16u w=0.74u l=0.13u
X250 VDD.t211 VSS.t202 VDD.t210 VDD.t90 sg13_lv_pmos ad=0.34p pd=2.68u as=0 ps=0 w=1u l=1u
X251 VDD.t602 a_2595_3156.t2 a_20905_3364# VDD.t0 sg13_lv_pmos ad=0.3808p pd=2.92u as=0.3808p ps=2.92u w=1.12u l=0.13u
X252 a_23871_14024# a_23633_14024# a_23763_14024# VSS.t2332 sg13_lv_nmos ad=0.1406p pd=1.12u as=0.2516p ps=2.16u w=0.74u l=0.2u
X253 VDD.t774 a_11603_7532# a_12037_7532# VDD.t346 sg13_lv_pmos ad=0.2128p pd=1.5u as=0.3808p ps=2.92u w=1.12u l=0.13u
X254 a_18551_17497# a_18313_16869# a_18443_16869# VDD.t368 sg13_lv_pmos ad=0.2128p pd=1.5u as=0.3808p ps=2.92u w=1.12u l=0.2u
X255 CHAN1_DELAY_OUT_LAST a_27997_14024# VSS.t1838 VSS.t1837 sg13_lv_nmos ad=0.2516p pd=2.16u as=0.1406p ps=1.12u w=0.74u l=0.13u
X256 VDD.t1180 a_3171_13229.t7 a_11924_13190# VDD.t5 sg13_lv_pmos ad=0.3808p pd=2.92u as=0.3808p ps=2.92u w=1.12u l=0.13u
X257 VSS.t188 VDD.t1705 VSS.t188 VSS.t190 sg13_lv_nmos ad=0.1428p pd=1.52u as=0 ps=0 w=0.42u l=1u
X258 a_4350_13226# a_2595_13229.t9 a_5115_13226# VSS.t2042 sg13_lv_nmos ad=0.2516p pd=2.16u as=0.1406p ps=1.12u w=0.74u l=0.13u
X259 a_3449_4240# CHAN2_MUX_SEL0 VDD.t1563 VDD.t0 sg13_lv_pmos ad=0.1596p pd=1.22u as=0.2856p ps=2.36u w=0.84u l=0.13u
X260 a_13880_10808# a_14111_10917# a_13566_11018# VSS.t1806 sg13_lv_nmos ad=0.2373p pd=1.97u as=79.8f ps=0.8u w=0.42u l=0.13u
X261 VSS.t1002 a_4187_1764.t104 a_24631_14024# VSS.t1001 sg13_lv_nmos ad=0.2516p pd=2.16u as=0.1406p ps=1.12u w=0.74u l=0.6u
X262 a_24393_7532# a_24197_7532# VDD.t803 VDD.t346 sg13_lv_pmos ad=0.3808p pd=2.92u as=0.2128p ps=1.5u w=1.12u l=0.13u
X263 a_10430_6734# a_2595_6737.t7 a_11195_6734# VSS.t1384 sg13_lv_nmos ad=0.2516p pd=2.16u as=0.1406p ps=1.12u w=0.74u l=0.13u
X264 VSS.t202 a_3171_15338.t3 a_11785_15546# VSS.t2268 sg13_lv_nmos ad=0.2516p pd=2.16u as=0.2516p ps=2.16u w=0.74u l=0.13u
X265 a_4157_1313# CHAN3_DELAY_IN VDD.t915 VDD.t2 sg13_lv_pmos ad=0.3808p pd=2.92u as=0.3808p ps=2.92u w=1.12u l=0.13u
X266 a_27433_4687# a_27237_4687# VDD.t607 VDD.t348 sg13_lv_pmos ad=0.3808p pd=2.92u as=0.2128p ps=1.5u w=1.12u l=0.13u
X267 a_7390_16071# a_8884_16035# a_8808_16071# VDD.t90 sg13_lv_pmos ad=0.3808p pd=2.92u as=0.2128p ps=1.5u w=1.12u l=0.13u
X268 a_17031_2470# a_16793_1842# a_16923_1842# VDD.t373 sg13_lv_pmos ad=0.2128p pd=1.5u as=0.3808p ps=2.92u w=1.12u l=0.2u
X269 VSS.t1450 a_4187_1764.t37 a_25391_4687# VSS.t1612 sg13_lv_nmos ad=0.2516p pd=2.16u as=0.1406p ps=1.12u w=0.74u l=0.6u
X270 VDD.t223 VSS.t319 VDD.t222 VDD.t67 sg13_lv_pmos ad=0.34p pd=2.68u as=0 ps=0 w=1u l=1u
X271 VDD.t1426 a_1544_15316# a_1721_15358# VDD.t90 sg13_lv_pmos ad=0.1918p pd=1.5u as=0.1596p ps=1.22u w=0.84u l=0.13u
X272 a_17553_14024# a_17357_14024# VDD.t1087 VDD.t374 sg13_lv_pmos ad=0.3808p pd=2.92u as=0.2128p ps=1.5u w=1.12u l=0.13u
X273 a_23355_6734# a_23145_6734# VSS.t169 VSS.t470 sg13_lv_nmos ad=0.1406p pd=1.12u as=0.1665p ps=1.19u w=0.74u l=0.13u
X274 VSS.t614 a_4187_1764.t89 a_10191_7532# VSS.t2257 sg13_lv_nmos ad=0.2516p pd=2.16u as=0.1406p ps=1.12u w=0.74u l=0.6u
X275 VDD.t667 a_4187_2434# a_4111_14652# VDD.t374 sg13_lv_pmos ad=0.3808p pd=2.92u as=0.2128p ps=1.5u w=1.12u l=0.6u
X276 VDD.t21 VSS.t253 VDD.t20 VDD.t5 sg13_lv_pmos ad=0.19p pd=1.38u as=0 ps=0 w=1u l=1u
X277 a_4350_16071# a_4324_16035# a_4248_16071# VDD.t90 sg13_lv_pmos ad=0.3808p pd=2.92u as=0.2128p ps=1.5u w=1.12u l=0.13u
X278 VSS.t1121 a_3747_6737.t4 a_21911_6698# VSS.t1770 sg13_lv_nmos ad=0.2516p pd=2.16u as=0.2516p ps=2.16u w=0.74u l=0.13u
X279 VDD.t1199 a_3171_3892.t5 a_18004_3853# VDD.t0 sg13_lv_pmos ad=0.3808p pd=2.92u as=0.3808p ps=2.92u w=1.12u l=0.13u
X280 VDD.t704 a_4187_2434# a_14751_8160# VDD.t346 sg13_lv_pmos ad=0.3808p pd=2.92u as=0.2128p ps=1.5u w=1.12u l=0.6u
X281 a_3171_3156.t0 a_2873_3176# VDD.t1410 VDD.t0 sg13_lv_pmos ad=0.2128p pd=1.5u as=0.1918p ps=1.5u w=1.12u l=0.13u
X282 a_26673_16869# a_26477_16869# VSS.t877 VSS.t2320 sg13_lv_nmos ad=0.2516p pd=2.16u as=0.1406p ps=1.12u w=0.74u l=0.13u
X283 a_11473_1842# a_11277_1842# VSS.t713 VSS.t1064 sg13_lv_nmos ad=0.2516p pd=2.16u as=0.1406p ps=1.12u w=0.74u l=0.13u
X284 VDD.t1412 a_2019_15338.t2 a_17865_15546# VDD.t90 sg13_lv_pmos ad=0.3808p pd=2.92u as=0.3808p ps=2.92u w=1.12u l=0.13u
X285 VSS.t692 a_19963_7532# a_20397_7532# VSS.t2202 sg13_lv_nmos ad=0.1406p pd=1.12u as=0.2516p ps=2.16u w=0.74u l=0.13u
X286 VDD.t1423 a_2297_3176# a_2595_3156.t0 VDD.t0 sg13_lv_pmos ad=0.4256p pd=3u as=0.2128p ps=1.5u w=1.12u l=0.13u
X287 a_2967_12513# CHAN1_MUX_SEL3 a_2873_12513# VSS.t695 sg13_lv_nmos ad=0.1216p pd=1.02u as=0.2176p ps=1.96u w=0.64u l=0.13u
X288 VSS.t451 VDD.t1621 VSS.t453 VSS.t452 sg13_lv_nmos ad=79.8f pd=0.8u as=0 ps=0 w=0.42u l=1u
X289 VDD.t830 a_3747_12493.t3 a_14825_12701# VDD.t5 sg13_lv_pmos ad=0.3808p pd=2.92u as=0.3808p ps=2.92u w=1.12u l=0.13u
X290 a_16408_3889# a_15837_4687# VSS.t655 VSS.t654 sg13_lv_nmos ad=0.1406p pd=1.12u as=0.2516p ps=2.16u w=0.74u l=0.13u
X291 VDD.t1427 a_1721_15358# a_2019_15338.t0 VDD.t90 sg13_lv_pmos ad=0.4256p pd=3u as=0.2128p ps=1.5u w=1.12u l=0.13u
X292 VSS.t2097 a_1721_15358# a_2019_15338.t1 VSS.t1997 sg13_lv_nmos ad=0.2812p pd=2.24u as=0.1406p ps=1.12u w=0.74u l=0.13u
X293 a_8433_14024# a_8237_14024# VSS.t1320 VSS.t1945 sg13_lv_nmos ad=0.2516p pd=2.16u as=0.1406p ps=1.12u w=0.74u l=0.13u
X294 a_19448_1044# a_18877_1842# VSS.t1289 VSS.t1529 sg13_lv_nmos ad=0.1406p pd=1.12u as=0.2516p ps=2.16u w=0.74u l=0.13u
X295 VDD.t1124 a_2595_16074.t6 a_14311_16035# VDD.t90 sg13_lv_pmos ad=0.3808p pd=2.92u as=0.3808p ps=2.92u w=1.12u l=0.13u
X296 VSS.t235 VDD.t1688 VSS.t234 VSS.t233 sg13_lv_nmos ad=0.1428p pd=1.52u as=0 ps=0 w=0.42u l=1u
X297 a_25630_13226# a_2019_13229.t2 a_25528_13226# VSS.t1721 sg13_lv_nmos ad=0.2516p pd=2.16u as=0.1406p ps=1.12u w=0.74u l=0.13u
X298 a_15053_11680# a_14111_11568# a_14851_11918# VDD.t355 sg13_lv_pmos ad=93.45f pd=0.865u as=0.2048p ps=1.63u w=0.42u l=0.13u
X299 VDD.t691 a_4187_2434# a_4111_8160# VDD.t346 sg13_lv_pmos ad=0.3808p pd=2.92u as=0.2128p ps=1.5u w=1.12u l=0.6u
X300 a_10430_1044# a_3171_1047.t7 a_11848_1044# VSS.t1690 sg13_lv_nmos ad=0.2516p pd=2.16u as=0.1406p ps=1.12u w=0.74u l=0.13u
X301 a_20968_6734# a_20397_7532# VSS.t690 VSS.t689 sg13_lv_nmos ad=0.1406p pd=1.12u as=0.2516p ps=2.16u w=0.74u l=0.13u
X302 VDD.t961 a_27237_1842# a_27705_1044# VDD.t2 sg13_lv_pmos ad=0.252p pd=1.57u as=0.3808p ps=2.92u w=1.12u l=0.13u
X303 a_14235_3889# a_14025_3889# VDD.t906 VDD.t0 sg13_lv_pmos ad=0.2128p pd=1.5u as=0.252p ps=1.57u w=1.12u l=0.13u
X304 a_5731_5979# a_14825_6209# a_13470_6734# VDD.t67 sg13_lv_pmos ad=0.3808p pd=2.92u as=0.3808p ps=2.92u w=1.12u l=0.13u
X305 a_19448_13226# a_18877_14024# VSS.t570 VSS.t2180 sg13_lv_nmos ad=0.1406p pd=1.12u as=0.2516p ps=2.16u w=0.74u l=0.13u
X306 VDD.t731 a_4187_2434# a_7151_5315# VDD.t348 sg13_lv_pmos ad=0.3808p pd=2.92u as=0.2128p ps=1.5u w=1.12u l=0.6u
X307 VSS.t2127 a_16851_15336# CHAN0_MUX_OUT VSS.t2128 sg13_lv_nmos ad=0.2516p pd=2.16u as=0.1406p ps=1.12u w=0.74u l=0.13u
X308 a_16108_12471# a_15765_12645# a_15964_12471# VDD.t5 sg13_lv_pmos ad=0.3808p pd=2.92u as=0.3304p ps=1.71u w=1.12u l=0.13u
X309 VDD.t990 a_6326_10280# a_6326_10280# VDD.t355 sg13_lv_pmos ad=0.38p pd=2.38u as=0.38p ps=2.38u w=2u l=1u
X310 VSS.t422 VDD.t1628 VSS.t425 VSS.t424 sg13_lv_nmos ad=79.8f pd=0.8u as=0 ps=0 w=0.42u l=1u
X311 VDD.t126 VSS.t395 VDD.t124 VDD.t0 sg13_lv_pmos ad=0.19p pd=1.38u as=0 ps=0 w=1u l=1u
X312 a_2595_16074.t1 a_2297_16422# VSS.t27 VSS.t1760 sg13_lv_nmos ad=0.1406p pd=1.12u as=0.1331p ps=1.12u w=0.74u l=0.13u
X313 a_20831_2470# a_20593_1842# a_20723_1842# VDD.t373 sg13_lv_pmos ad=0.2128p pd=1.5u as=0.3808p ps=2.92u w=1.12u l=0.2u
X314 VDD.t1043 a_6283_14024# a_6717_14024# VDD.t374 sg13_lv_pmos ad=0.2128p pd=1.5u as=0.3808p ps=2.92u w=1.12u l=0.13u
X315 a_5393_1842# a_5197_1842# VDD.t1085 VDD.t373 sg13_lv_pmos ad=0.3808p pd=2.92u as=0.2128p ps=1.5u w=1.12u l=0.13u
X316 VDD.t1185 a_3747_3892.t7 a_12791_3853# VDD.t0 sg13_lv_pmos ad=0.3808p pd=2.92u as=0.3808p ps=2.92u w=1.12u l=0.13u
X317 VSS.t885 a_4187_1764.t116 a_15511_14024# VSS.t969 sg13_lv_nmos ad=0.2516p pd=2.16u as=0.1406p ps=1.12u w=0.74u l=0.6u
X318 a_13949_11186# a_13592_11113# VDD.t404 VDD.t355 sg13_lv_pmos ad=63f pd=0.72u as=0.1563p ps=1.22u w=0.42u l=0.13u
X319 VDD.t748 a_4187_2434# a_17031_2470# VDD.t373 sg13_lv_pmos ad=0.3808p pd=2.92u as=0.2128p ps=1.5u w=1.12u l=0.6u
X320 a_10191_14024# a_9953_14024# a_10083_14024# VSS.t1899 sg13_lv_nmos ad=0.1406p pd=1.12u as=0.2516p ps=2.16u w=0.74u l=0.2u
X321 VSS.t1872 a_4187_1764.t122 a_10951_14024# VSS.t1871 sg13_lv_nmos ad=0.2516p pd=2.16u as=0.1406p ps=1.12u w=0.74u l=0.6u
X322 a_7390_3889# a_3747_3892.t8 a_9675_3889# VSS.t1914 sg13_lv_nmos ad=0.2516p pd=2.16u as=0.1406p ps=1.12u w=0.74u l=0.13u
X323 a_25630_13226# a_27124_13190# a_27048_13226# VDD.t5 sg13_lv_pmos ad=0.3808p pd=2.92u as=0.2128p ps=1.5u w=1.12u l=0.13u
X324 VDD.t1357 a_26803_1842# a_27237_1842# VDD.t373 sg13_lv_pmos ad=0.2128p pd=1.5u as=0.3808p ps=2.92u w=1.12u l=0.13u
X325 VDD.t1260 CHAN3_MUX_SEL1 a_3449_1395# VDD.t2 sg13_lv_pmos ad=0.1918p pd=1.5u as=0.1596p ps=1.22u w=0.84u l=0.13u
X326 a_17275_16071# a_17065_16071# VDD.t1079 VDD.t90 sg13_lv_pmos ad=0.2128p pd=1.5u as=0.252p ps=1.57u w=1.12u l=0.13u
X327 a_11848_3889# a_11277_4687# VDD.t505 VDD.t0 sg13_lv_pmos ad=0.2128p pd=1.5u as=0.3808p ps=2.92u w=1.12u l=0.13u
X328 a_18551_14652# a_18313_14024# a_18443_14024# VDD.t374 sg13_lv_pmos ad=0.2128p pd=1.5u as=0.3808p ps=2.92u w=1.12u l=0.2u
X329 VSS.t163 a_15108_11015# a_14757_10872# VSS.t1345 sg13_lv_nmos ad=79.8f pd=0.8u as=0.1428p ps=1.52u w=0.42u l=0.13u
X330 a_25630_1044# a_2595_1047.t2 a_26395_1044# VSS.t2009 sg13_lv_nmos ad=0.2516p pd=2.16u as=0.1406p ps=1.12u w=0.74u l=0.13u
X331 a_17031_8160# a_16793_7532# a_16923_7532# VDD.t346 sg13_lv_pmos ad=0.2128p pd=1.5u as=0.3808p ps=2.92u w=1.12u l=0.2u
X332 a_16408_6734# a_15837_7532# VDD.t843 VDD.t67 sg13_lv_pmos ad=0.2128p pd=1.5u as=0.3808p ps=2.92u w=1.12u l=0.13u
X333 VSS.t326 VDD.t1659 VSS.t326 VSS.t330 sg13_lv_nmos ad=0.1428p pd=1.52u as=0 ps=0 w=0.42u l=1u
X334 a_27671_16869# a_27433_16869# a_27563_16869# VSS.t1296 sg13_lv_nmos ad=0.1406p pd=1.12u as=0.2516p ps=2.16u w=0.74u l=0.2u
X335 a_16510_13226# a_2019_13229.t5 a_16408_13226# VSS.t2031 sg13_lv_nmos ad=0.2516p pd=2.16u as=0.1406p ps=1.12u w=0.74u l=0.13u
X336 VSS.t1442 a_4187_1764.t5 a_25391_1842# VSS.t1663 sg13_lv_nmos ad=0.2516p pd=2.16u as=0.1406p ps=1.12u w=0.74u l=0.6u
X337 VDD.t401 a_1544_12471# a_1721_12513# VDD.t5 sg13_lv_pmos ad=0.1918p pd=1.5u as=0.1596p ps=1.22u w=0.84u l=0.13u
X338 VDD.t39 VSS.t365 VDD.t38 VDD.t0 sg13_lv_pmos ad=0.34p pd=2.68u as=0 ps=0 w=1u l=1u
X339 VSS.t1869 a_13123_14024# a_13557_14024# VSS.t1964 sg13_lv_nmos ad=0.1406p pd=1.12u as=0.2516p ps=2.16u w=0.74u l=0.13u
X340 a_5115_13226# a_4905_13226# VDD.t1319 VDD.t5 sg13_lv_pmos ad=0.2128p pd=1.5u as=0.252p ps=1.57u w=1.12u l=0.13u
X341 a_26673_4687# a_26477_4687# VSS.t789 VSS.t1814 sg13_lv_nmos ad=0.2516p pd=2.16u as=0.1406p ps=1.12u w=0.74u l=0.13u
X342 a_6635_1044# a_6425_1044# VDD.t1333 VDD.t2 sg13_lv_pmos ad=0.2128p pd=1.5u as=0.252p ps=1.57u w=1.12u l=0.13u
X343 a_11473_7532# a_11277_7532# VSS.t773 VSS.t1820 sg13_lv_nmos ad=0.2516p pd=2.16u as=0.1406p ps=1.12u w=0.74u l=0.13u
X344 VSS.t290 VDD.t1674 VSS.t290 VSS.t292 sg13_lv_nmos ad=79.8f pd=0.8u as=0 ps=0 w=0.42u l=1u
X345 a_18313_4687# a_18117_4687# VDD.t778 VDD.t348 sg13_lv_pmos ad=0.3808p pd=2.92u as=0.2128p ps=1.5u w=1.12u l=0.13u
X346 VDD.t1372 a_2595_1047.t9 a_5191_1008# VDD.t2 sg13_lv_pmos ad=0.3808p pd=2.92u as=0.3808p ps=2.92u w=1.12u l=0.13u
X347 a_9431_5315# a_9193_4687# a_9323_4687# VDD.t348 sg13_lv_pmos ad=0.2128p pd=1.5u as=0.3808p ps=2.92u w=1.12u l=0.2u
X348 a_19448_6734# a_18877_7532# VSS.t651 VSS.t650 sg13_lv_nmos ad=0.1406p pd=1.12u as=0.2516p ps=2.16u w=0.74u l=0.13u
X349 a_20315_1044# a_20105_1044# VDD.t377 VDD.t2 sg13_lv_pmos ad=0.2128p pd=1.5u as=0.252p ps=1.57u w=1.12u l=0.13u
X350 a_13592_11113# a_14111_10917# a_14851_10872# VSS.t1807 sg13_lv_nmos ad=0.3473p pd=2.71u as=0.12665p ps=1.145u w=0.74u l=0.13u
X351 a_10430_6734# a_3171_6737.t7 a_11848_6734# VSS.t1876 sg13_lv_nmos ad=0.2516p pd=2.16u as=0.1406p ps=1.12u w=0.74u l=0.13u
X352 a_7390_6734# a_9751_6698# a_9675_6734# VDD.t67 sg13_lv_pmos ad=0.3808p pd=2.92u as=0.2128p ps=1.5u w=1.12u l=0.13u
X353 a_25528_1044# a_24957_1842# VDD.t1089 VDD.t2 sg13_lv_pmos ad=0.2128p pd=1.5u as=0.3808p ps=2.92u w=1.12u l=0.13u
X354 VSS.t905 a_1721_1395# a_2019_1047.t1 VSS.t1787 sg13_lv_nmos ad=0.2812p pd=2.24u as=0.1406p ps=1.12u w=0.74u l=0.13u
X355 a_19311_2470# a_19073_1842# a_19203_1842# VDD.t373 sg13_lv_pmos ad=0.2128p pd=1.5u as=0.3808p ps=2.92u w=1.12u l=0.2u
X356 a_5731_3134# a_14825_3364# a_13470_3889# VDD.t0 sg13_lv_pmos ad=0.3808p pd=2.92u as=0.3808p ps=2.92u w=1.12u l=0.13u
X357 VSS.t1954 a_5957_1842# a_6425_1044# VSS.t1953 sg13_lv_nmos ad=0.1665p pd=1.19u as=0.2516p ps=2.16u w=0.74u l=0.13u
X358 VSS.t957 a_3171_3892.t5 a_18004_3853# VSS.t1729 sg13_lv_nmos ad=0.2516p pd=2.16u as=0.2516p ps=2.16u w=0.74u l=0.13u
X359 VSS.t1370 a_2019_16074.t7 a_10404_16035# VSS.t1706 sg13_lv_nmos ad=0.2516p pd=2.16u as=0.2516p ps=2.16u w=0.74u l=0.13u
X360 a_20831_8160# a_20593_7532# a_20723_7532# VDD.t346 sg13_lv_pmos ad=0.2128p pd=1.5u as=0.3808p ps=2.92u w=1.12u l=0.2u
X361 a_5393_7532# a_5197_7532# VDD.t351 VDD.t346 sg13_lv_pmos ad=0.3808p pd=2.92u as=0.2128p ps=1.5u w=1.12u l=0.13u
X362 a_23871_5315# a_23633_4687# a_23763_4687# VDD.t348 sg13_lv_pmos ad=0.2128p pd=1.5u as=0.3808p ps=2.92u w=1.12u l=0.2u
X363 VDD.t706 a_4187_2434# a_17031_8160# VDD.t346 sg13_lv_pmos ad=0.3808p pd=2.92u as=0.2128p ps=1.5u w=1.12u l=0.6u
X364 VSS.t20 a_4187_1764.t62 a_6391_4687# VSS.t2382 sg13_lv_nmos ad=0.2516p pd=2.16u as=0.1406p ps=1.12u w=0.74u l=0.6u
X365 a_8433_4687# a_8237_4687# VDD.t1018 VDD.t348 sg13_lv_pmos ad=0.3808p pd=2.92u as=0.2128p ps=1.5u w=1.12u l=0.13u
X366 VSS.t1074 a_2297_13577# a_2595_13229.t1 VSS.t2344 sg13_lv_nmos ad=0.2812p pd=2.24u as=0.1406p ps=1.12u w=0.74u l=0.13u
X367 VSS.t96 a_10649_11568# a_10751_11568# VSS.t1314 sg13_lv_nmos ad=2.39977p pd=15.495u as=0.2516p ps=2.16u w=0.74u l=0.13u
X368 VDD.t242 VSS.t216 VDD.t241 VDD.t90 sg13_lv_pmos ad=0.34p pd=2.68u as=0 ps=0 w=1u l=1u
X369 VDD.t945 a_18443_4687# a_18877_4687# VDD.t348 sg13_lv_pmos ad=0.2128p pd=1.5u as=0.3808p ps=2.92u w=1.12u l=0.13u
X370 a_19550_16071# a_21044_16035# a_20968_16071# VDD.t90 sg13_lv_pmos ad=0.3808p pd=2.92u as=0.2128p ps=1.5u w=1.12u l=0.13u
X371 a_10713_14024# a_10517_14024# VSS.t593 VSS.t592 sg13_lv_nmos ad=0.2516p pd=2.16u as=0.1406p ps=1.12u w=0.74u l=0.13u
X372 VDD.t1025 a_26803_7532# a_27237_7532# VDD.t346 sg13_lv_pmos ad=0.2128p pd=1.5u as=0.3808p ps=2.92u w=1.12u l=0.13u
X373 a_14235_3889# a_14025_3889# VSS.t1165 VSS.t1379 sg13_lv_nmos ad=0.1406p pd=1.12u as=0.1665p ps=1.19u w=0.74u l=0.13u
X374 a_22113_4687# a_21917_4687# VDD.t1503 VDD.t348 sg13_lv_pmos ad=0.3808p pd=2.92u as=0.2128p ps=1.5u w=1.12u l=0.13u
X375 VSS.t1699 a_4187_1764.t143 a_19311_16869# VSS.t1698 sg13_lv_nmos ad=0.2516p pd=2.16u as=0.1406p ps=1.12u w=0.74u l=0.6u
X376 a_3171_16074.t1 a_2873_16422# VSS.t1754 VSS.t1804 sg13_lv_nmos ad=0.1406p pd=1.12u as=0.1331p ps=1.12u w=0.74u l=0.13u
X377 VDD.t1385 a_2019_13229.t6 a_13444_13190# VDD.t5 sg13_lv_pmos ad=0.3808p pd=2.92u as=0.3808p ps=2.92u w=1.12u l=0.13u
X378 VDD.t1003 a_19637_4687# a_20105_3889# VDD.t0 sg13_lv_pmos ad=0.252p pd=1.57u as=0.3808p ps=2.92u w=1.12u l=0.13u
X379 VDD.t259 VSS.t195 VDD.t258 VDD.t90 sg13_lv_pmos ad=0.34p pd=2.68u as=0 ps=0 w=1u l=1u
X380 VSS.t2015 a_2019_1047.t6 a_13444_1008# VSS.t2014 sg13_lv_nmos ad=0.2516p pd=2.16u as=0.2516p ps=2.16u w=0.74u l=0.13u
X381 VSS.t1678 a_3747_3892.t7 a_12791_3853# VSS.t1677 sg13_lv_nmos ad=0.2516p pd=2.16u as=0.2516p ps=2.16u w=0.74u l=0.13u
X382 VSS.t92 a_4187_1764.t43 a_20831_4687# VSS.t91 sg13_lv_nmos ad=0.2516p pd=2.16u as=0.1406p ps=1.12u w=0.74u l=0.6u
X383 VDD.t1474 a_16851_12491# CHAN1_MUX_OUT VDD.t5 sg13_lv_pmos ad=0.7336p pd=3.55u as=0.2128p ps=1.5u w=1.12u l=0.13u
X384 a_25630_6734# a_2595_6737.t2 a_26395_6734# VSS.t1122 sg13_lv_nmos ad=0.2516p pd=2.16u as=0.1406p ps=1.12u w=0.74u l=0.13u
X385 a_4350_16071# a_2595_16074.t9 a_5115_16071# VSS.t1874 sg13_lv_nmos ad=0.2516p pd=2.16u as=0.1406p ps=1.12u w=0.74u l=0.13u
X386 a_25153_14024# a_24957_14024# VSS.t1002 VSS.t1424 sg13_lv_nmos ad=0.2516p pd=2.16u as=0.1406p ps=1.12u w=0.74u l=0.13u
X387 VSS.t403 VDD.t1633 VSS.t403 VSS.t402 sg13_lv_nmos ad=0.1428p pd=1.52u as=0 ps=0 w=0.42u l=1u
X388 a_23111_2470# a_22873_1842# a_23003_1842# VDD.t373 sg13_lv_pmos ad=0.2128p pd=1.5u as=0.3808p ps=2.92u w=1.12u l=0.2u
X389 VSS.t854 a_15964_289# a_16851_309# VSS.t853 sg13_lv_nmos ad=0.1371p pd=1.12u as=0.2176p ps=1.96u w=0.64u l=0.13u
X390 VDD.t274 VSS.t326 VDD.t273 VDD.t67 sg13_lv_pmos ad=0.34p pd=2.68u as=0 ps=0 w=1u l=1u
X391 a_16108_289# a_17865_519# a_16510_1044# VDD.t2 sg13_lv_pmos ad=0.3808p pd=2.92u as=0.3808p ps=2.92u w=1.12u l=0.13u
X392 VDD.t722 a_4187_2434# a_12471_5315# VDD.t348 sg13_lv_pmos ad=0.3808p pd=2.92u as=0.2128p ps=1.5u w=1.12u l=0.6u
X393 VDD.t935 a_17683_1842# a_18117_1842# VDD.t373 sg13_lv_pmos ad=0.2128p pd=1.5u as=0.3808p ps=2.92u w=1.12u l=0.13u
X394 VSS.t176 a_4187_1764.t69 a_25391_7532# VSS.t1716 sg13_lv_nmos ad=0.2516p pd=2.16u as=0.1406p ps=1.12u w=0.74u l=0.6u
X395 a_10713_1842# a_10517_1842# VDD.t792 VDD.t373 sg13_lv_pmos ad=0.3808p pd=2.92u as=0.2128p ps=1.5u w=1.12u l=0.13u
X396 a_4350_16071# a_5844_16035# a_5768_16071# VDD.t90 sg13_lv_pmos ad=0.3808p pd=2.92u as=0.2128p ps=1.5u w=1.12u l=0.13u
X397 a_11848_3889# a_11277_4687# VSS.t486 VSS.t485 sg13_lv_nmos ad=0.1406p pd=1.12u as=0.2516p ps=2.16u w=0.74u l=0.13u
X398 a_10191_4687# a_9953_4687# a_10083_4687# VSS.t1569 sg13_lv_nmos ad=0.1406p pd=1.12u as=0.2516p ps=2.16u w=0.74u l=0.2u
X399 VSS.t830 a_4187_1764.t98 VSS.t828 VSS.t813 sg13_lv_nmos ad=1.33p pd=7.38u as=0 ps=0 w=7u l=7u
X400 VDD.t1442 a_3171_6737.t5 a_18004_6698# VDD.t67 sg13_lv_pmos ad=0.3808p pd=2.92u as=0.3808p ps=2.92u w=1.12u l=0.13u
X401 a_26673_1842# a_26477_1842# VSS.t1221 VSS.t2188 sg13_lv_nmos ad=0.2516p pd=2.16u as=0.1406p ps=1.12u w=0.74u l=0.13u
X402 VDD.t1129 a_22243_4687# a_22677_4687# VDD.t348 sg13_lv_pmos ad=0.2128p pd=1.5u as=0.3808p ps=2.92u w=1.12u l=0.13u
X403 VDD.t209 VSS.t202 VDD.t207 VDD.t90 sg13_lv_pmos ad=0.19p pd=1.38u as=0 ps=0 w=1u l=1u
X404 a_23633_16869# a_23437_16869# VSS.t580 VSS.t579 sg13_lv_nmos ad=0.2516p pd=2.16u as=0.1406p ps=1.12u w=0.74u l=0.13u
X405 a_13019_11521# a_15688_11093# VSS.t163 VSS.t2308 sg13_lv_nmos ad=0.2516p pd=2.16u as=0.1406p ps=1.12u w=0.74u l=0.13u
X406 a_9953_14024# a_9757_14024# VSS.t1518 VSS.t1517 sg13_lv_nmos ad=0.2516p pd=2.16u as=0.1406p ps=1.12u w=0.74u l=0.13u
X407 a_20315_13226# a_20105_13226# VSS.t1067 VSS.t2090 sg13_lv_nmos ad=0.1406p pd=1.12u as=0.1665p ps=1.19u w=0.74u l=0.13u
X408 a_16510_3889# a_17351_3853# a_17275_3889# VDD.t0 sg13_lv_pmos ad=0.3808p pd=2.92u as=0.2128p ps=1.5u w=1.12u l=0.13u
X409 VSS.t798 a_16923_16869# a_17357_16869# VSS.t2349 sg13_lv_nmos ad=0.1406p pd=1.12u as=0.2516p ps=2.16u w=0.74u l=0.13u
X410 VDD.t1123 a_3747_15338.t3 a_14825_15546# VDD.t90 sg13_lv_pmos ad=0.3808p pd=2.92u as=0.3808p ps=2.92u w=1.12u l=0.13u
X411 VDD.t927 a_7803_1842# a_8237_1842# VDD.t373 sg13_lv_pmos ad=0.2128p pd=1.5u as=0.3808p ps=2.92u w=1.12u l=0.13u
X412 VDD.t829 a_3171_12493.t3 a_11785_12701# VDD.t5 sg13_lv_pmos ad=0.3808p pd=2.92u as=0.3808p ps=2.92u w=1.12u l=0.13u
X413 VSS.t379 VDD.t1640 VSS.t379 VSS.t378 sg13_lv_nmos ad=0.1428p pd=1.52u as=0 ps=0 w=0.42u l=1u
X414 a_2595_12493.t0 a_2297_12513# VDD.t400 VDD.t5 sg13_lv_pmos ad=0.2128p pd=1.5u as=0.1918p ps=1.5u w=1.12u l=0.13u
X415 a_25630_16071# a_2019_16074.t2 a_25528_16071# VSS.t2105 sg13_lv_nmos ad=0.2516p pd=2.16u as=0.1406p ps=1.12u w=0.74u l=0.13u
X416 a_19311_8160# a_19073_7532# a_19203_7532# VDD.t346 sg13_lv_pmos ad=0.2128p pd=1.5u as=0.3808p ps=2.92u w=1.12u l=0.2u
X417 VSS.t864 a_1721_7085# a_2019_6737.t1 VSS.t1311 sg13_lv_nmos ad=0.2812p pd=2.24u as=0.1406p ps=1.12u w=0.74u l=0.13u
X418 a_4248_1044# a_4157_1313# VSS.t630 VSS.t629 sg13_lv_nmos ad=0.1406p pd=1.12u as=0.2516p ps=2.16u w=0.74u l=0.13u
X419 VDD.t1101 a_8563_16869# a_8997_16869# VDD.t368 sg13_lv_pmos ad=0.2128p pd=1.5u as=0.3808p ps=2.92u w=1.12u l=0.13u
X420 VSS.t319 VDD.t1664 VSS.t319 VSS.t318 sg13_lv_nmos ad=0.1428p pd=1.52u as=0 ps=0 w=0.42u l=1u
X421 a_19448_16071# a_18877_16869# VSS.t1105 VSS.t1751 sg13_lv_nmos ad=0.1406p pd=1.12u as=0.2516p ps=2.16u w=0.74u l=0.13u
X422 VDD.t1608 a_2595_16074.t7 a_11271_16035# VDD.t90 sg13_lv_pmos ad=0.3808p pd=2.92u as=0.3808p ps=2.92u w=1.12u l=0.13u
X423 VSS.t88 a_5957_7532# a_6425_6734# VSS.t87 sg13_lv_nmos ad=0.1665p pd=1.19u as=0.2516p ps=2.16u w=0.74u l=0.13u
X424 a_14235_6734# a_14025_6734# VDD.t1494 VDD.t67 sg13_lv_pmos ad=0.2128p pd=1.5u as=0.252p ps=1.57u w=1.12u l=0.13u
X425 VSS.t195 VDD.t1703 VSS.t195 VSS.t194 sg13_lv_nmos ad=0.1428p pd=1.52u as=0 ps=0 w=0.42u l=1u
X426 a_16108_15316# a_15765_15490# a_15964_15316# VDD.t90 sg13_lv_pmos ad=0.3808p pd=2.92u as=0.3304p ps=1.71u w=1.12u l=0.13u
X427 a_16108_289# a_3171_311.t2 a_22590_1044# VSS.t1138 sg13_lv_nmos ad=0.2516p pd=2.16u as=0.2516p ps=2.16u w=0.74u l=0.13u
X428 VDD.t1184 a_3747_3892.t2 a_27991_3853# VDD.t0 sg13_lv_pmos ad=0.3808p pd=2.92u as=0.3808p ps=2.92u w=1.12u l=0.13u
X429 a_11711_14024# a_11473_14024# a_11603_14024# VSS.t1900 sg13_lv_nmos ad=0.1406p pd=1.12u as=0.2516p ps=2.16u w=0.74u l=0.2u
X430 a_1721_6021# a_1256_5979# VDD.t1528 VDD.t67 sg13_lv_pmos ad=0.1596p pd=1.22u as=0.2856p ps=2.36u w=0.84u l=0.13u
X431 VDD.t1221 a_3747_6737.t7 a_12791_6698# VDD.t67 sg13_lv_pmos ad=0.3808p pd=2.92u as=0.3808p ps=2.92u w=1.12u l=0.13u
X432 VSS.t1110 a_4187_1764.t30 a_6391_1842# VSS.t1109 sg13_lv_nmos ad=0.2516p pd=2.16u as=0.1406p ps=1.12u w=0.74u l=0.6u
X433 VSS.t929 a_4187_1764.t120 a_12471_14024# VSS.t928 sg13_lv_nmos ad=0.2516p pd=2.16u as=0.1406p ps=1.12u w=0.74u l=0.6u
X434 a_16408_1044# a_15837_1842# VDD.t1523 VDD.t2 sg13_lv_pmos ad=0.2128p pd=1.5u as=0.3808p ps=2.92u w=1.12u l=0.13u
X435 VDD.t1183 a_3747_3892.t9 a_6711_3853# VDD.t0 sg13_lv_pmos ad=0.3808p pd=2.92u as=0.3808p ps=2.92u w=1.12u l=0.13u
X436 a_26151_14024# a_25913_14024# a_26043_14024# VSS.t1525 sg13_lv_nmos ad=0.1406p pd=1.12u as=0.2516p ps=2.16u w=0.74u l=0.2u
X437 VDD.t236 VSS.t260 VDD.t64 VDD.t5 sg13_lv_pmos ad=0.19p pd=1.38u as=0 ps=0 w=1u l=1u
X438 a_19550_1044# a_3747_1047.t4 a_21835_1044# VSS.t706 sg13_lv_nmos ad=0.2516p pd=2.16u as=0.1406p ps=1.12u w=0.74u l=0.13u
X439 a_7673_4687# a_7477_4687# VSS.t2212 VSS.t2211 sg13_lv_nmos ad=0.2516p pd=2.16u as=0.1406p ps=1.12u w=0.74u l=0.13u
X440 VDD.t178 VSS.t209 VDD.t176 VDD.t90 sg13_lv_pmos ad=0.19p pd=1.38u as=0 ps=0 w=1u l=1u
X441 a_18795_16071# a_18585_16071# VDD.t974 VDD.t90 sg13_lv_pmos ad=0.2128p pd=1.5u as=0.252p ps=1.57u w=1.12u l=0.13u
X442 VSS.t1118 a_2019_6737.t6 a_13444_6698# VSS.t1117 sg13_lv_nmos ad=0.2516p pd=2.16u as=0.2516p ps=2.16u w=0.74u l=0.13u
X443 a_11848_6734# a_11277_7532# VDD.t1256 VDD.t67 sg13_lv_pmos ad=0.2128p pd=1.5u as=0.3808p ps=2.92u w=1.12u l=0.13u
X444 a_3171_311.t0 a_2873_331# VDD.t1279 VDD.t2 sg13_lv_pmos ad=0.2128p pd=1.5u as=0.1918p ps=1.5u w=1.12u l=0.13u
X445 VSS.t778 a_4187_1764.t11 a_20831_1842# VSS.t1659 sg13_lv_nmos ad=0.2516p pd=2.16u as=0.1406p ps=1.12u w=0.74u l=0.6u
X446 a_14513_16869# a_14317_16869# VSS.t1291 VSS.t1371 sg13_lv_nmos ad=0.2516p pd=2.16u as=0.1406p ps=1.12u w=0.74u l=0.13u
X447 a_13880_10808# a_13592_11113# a_13818_10808# VSS.t2201 sg13_lv_nmos ad=0.1428p pd=1.52u as=37.8f ps=0.6u w=0.42u l=0.13u
X448 a_23111_8160# a_22873_7532# a_23003_7532# VDD.t346 sg13_lv_pmos ad=0.2128p pd=1.5u as=0.3808p ps=2.92u w=1.12u l=0.2u
X449 a_14235_16071# a_14025_16071# VDD.t1036 VDD.t90 sg13_lv_pmos ad=0.2128p pd=1.5u as=0.252p ps=1.57u w=1.12u l=0.13u
X450 VDD.t86 VSS.t372 VDD.t85 VDD.t0 sg13_lv_pmos ad=0.34p pd=2.68u as=0 ps=0 w=1u l=1u
X451 VDD.t1422 a_1544_3134# a_2297_3176# VDD.t0 sg13_lv_pmos ad=0.1918p pd=1.5u as=0.1596p ps=1.22u w=0.84u l=0.13u
X452 a_26151_5315# a_25913_4687# a_26043_4687# VDD.t348 sg13_lv_pmos ad=0.2128p pd=1.5u as=0.3808p ps=2.92u w=1.12u l=0.2u
X453 a_3747_311.t0 a_3449_331# VDD.t868 VDD.t2 sg13_lv_pmos ad=0.2128p pd=1.5u as=0.1918p ps=1.5u w=1.12u l=0.13u
X454 VDD.t800 a_17683_7532# a_18117_7532# VDD.t346 sg13_lv_pmos ad=0.2128p pd=1.5u as=0.3808p ps=2.92u w=1.12u l=0.13u
X455 a_7390_1044# a_9751_1008# a_9675_1044# VDD.t2 sg13_lv_pmos ad=0.3808p pd=2.92u as=0.2128p ps=1.5u w=1.12u l=0.13u
X456 a_16510_16071# a_2019_16074.t5 a_16408_16071# VSS.t2377 sg13_lv_nmos ad=0.2516p pd=2.16u as=0.1406p ps=1.12u w=0.74u l=0.13u
X457 a_25528_16071# a_24957_16869# VDD.t854 VDD.t90 sg13_lv_pmos ad=0.2128p pd=1.5u as=0.3808p ps=2.92u w=1.12u l=0.13u
X458 a_10713_7532# a_10517_7532# VDD.t525 VDD.t346 sg13_lv_pmos ad=0.3808p pd=2.92u as=0.2128p ps=1.5u w=1.12u l=0.13u
X459 VSS.t1322 a_19637_4687# a_20105_3889# VSS.t1321 sg13_lv_nmos ad=0.1665p pd=1.19u as=0.2516p ps=2.16u w=0.74u l=0.13u
X460 a_13470_13226# a_2019_13229.t6 a_13368_13226# VSS.t2044 sg13_lv_nmos ad=0.2516p pd=2.16u as=0.1406p ps=1.12u w=0.74u l=0.13u
X461 VSS.t1225 a_22677_1842# a_23145_1044# VSS.t1429 sg13_lv_nmos ad=0.1665p pd=1.19u as=0.2516p ps=2.16u w=0.74u l=0.13u
X462 VSS.t685 a_4187_1764.t55 a_11711_4687# VSS.t1162 sg13_lv_nmos ad=0.2516p pd=2.16u as=0.1406p ps=1.12u w=0.74u l=0.6u
X463 a_13753_4687# a_13557_4687# VDD.t907 VDD.t348 sg13_lv_pmos ad=0.3808p pd=2.92u as=0.2128p ps=1.5u w=1.12u l=0.13u
X464 VDD.t1212 a_19963_16869# a_20397_16869# VDD.t368 sg13_lv_pmos ad=0.2128p pd=1.5u as=0.3808p ps=2.92u w=1.12u l=0.13u
X465 a_4871_5315# a_4633_4687# a_4763_4687# VDD.t348 sg13_lv_pmos ad=0.2128p pd=1.5u as=0.3808p ps=2.92u w=1.12u l=0.2u
X466 a_26673_7532# a_26477_7532# VSS.t745 VSS.t2275 sg13_lv_nmos ad=0.2516p pd=2.16u as=0.1406p ps=1.12u w=0.74u l=0.13u
X467 a_10191_1842# a_9953_1842# a_10083_1842# VSS.t2243 sg13_lv_nmos ad=0.1406p pd=1.12u as=0.2516p ps=2.16u w=0.74u l=0.2u
X468 VDD.t1364 a_1721_13577# a_2019_13229.t0 VDD.t5 sg13_lv_pmos ad=0.4256p pd=3u as=0.2128p ps=1.5u w=1.12u l=0.13u
X469 a_16108_12471# a_2019_12493.t2 a_16510_13226# VSS.t12 sg13_lv_nmos ad=0.2516p pd=2.16u as=0.2516p ps=2.16u w=0.74u l=0.13u
X470 a_14751_2470# a_14513_1842# a_14643_1842# VDD.t373 sg13_lv_pmos ad=0.2128p pd=1.5u as=0.3808p ps=2.92u w=1.12u l=0.2u
X471 VSS.t278 VDD.t1677 VSS.t278 VSS.t279 sg13_lv_nmos ad=79.8f pd=0.8u as=0 ps=0 w=0.42u l=1u
X472 a_5731_289# a_8745_519# a_7390_1044# VDD.t2 sg13_lv_pmos ad=0.3808p pd=2.92u as=0.3808p ps=2.92u w=1.12u l=0.13u
X473 VSS.t2071 a_21483_4687# a_21917_4687# VSS.t2280 sg13_lv_nmos ad=0.1406p pd=1.12u as=0.2516p ps=2.16u w=0.74u l=0.13u
X474 VDD.t896 a_7803_7532# a_8237_7532# VDD.t346 sg13_lv_pmos ad=0.2128p pd=1.5u as=0.3808p ps=2.92u w=1.12u l=0.13u
X475 VDD.t215 VSS.t319 VDD.t214 VDD.t67 sg13_lv_pmos ad=0.34p pd=2.68u as=0 ps=0 w=1u l=1u
X476 VDD.t493 VDD.t491 VDD.t489 VDD.t373 sg13_lv_pmos ad=0.2128p pd=1.5u as=0 ps=0 w=1.12u l=0.13u
X477 VSS.t305 VDD.t1669 VSS.t305 VSS.t307 sg13_lv_nmos ad=0.1428p pd=1.52u as=0 ps=0 w=0.42u l=1u
X478 a_4248_6734# a_4157_7003# VSS.t140 VSS.t139 sg13_lv_nmos ad=0.1406p pd=1.12u as=0.2516p ps=2.16u w=0.74u l=0.13u
X479 VSS.t742 a_1721_4240# a_2019_3892.t1 VSS.t1462 sg13_lv_nmos ad=0.2812p pd=2.24u as=0.1406p ps=1.12u w=0.74u l=0.13u
X480 VDD.t1000 a_8563_14024# a_8997_14024# VDD.t374 sg13_lv_pmos ad=0.2128p pd=1.5u as=0.3808p ps=2.92u w=1.12u l=0.13u
X481 a_4111_2470# CHAN3_DELAY_IN a_4003_1842# VDD.t373 sg13_lv_pmos ad=0.2128p pd=1.5u as=0.3808p ps=2.92u w=1.12u l=0.2u
X482 VDD.t361 a_24523_4687# a_24957_4687# VDD.t348 sg13_lv_pmos ad=0.2128p pd=1.5u as=0.3808p ps=2.92u w=1.12u l=0.13u
X483 a_2019_12493.t1 a_1721_12513# VSS.t149 VSS.t1780 sg13_lv_nmos ad=0.1406p pd=1.12u as=0.1331p ps=1.12u w=0.74u l=0.13u
X484 VSS.t98 a_4187_1764.t94 a_6391_7532# VSS.t915 sg13_lv_nmos ad=0.2516p pd=2.16u as=0.1406p ps=1.12u w=0.74u l=0.6u
X485 a_16510_3889# a_2595_3892.t5 a_17275_3889# VSS.t955 sg13_lv_nmos ad=0.2516p pd=2.16u as=0.1406p ps=1.12u w=0.74u l=0.13u
X486 a_22590_16071# a_22564_16035# a_22488_16071# VDD.t90 sg13_lv_pmos ad=0.3808p pd=2.92u as=0.2128p ps=1.5u w=1.12u l=0.13u
X487 VSS.t27 a_2297_16422# a_2595_16074.t1 VSS.t1761 sg13_lv_nmos ad=0.2812p pd=2.24u as=0.1406p ps=1.12u w=0.74u l=0.13u
X488 a_3171_12493.t0 a_2873_12513# VDD.t877 VDD.t5 sg13_lv_pmos ad=0.2128p pd=1.5u as=0.1918p ps=1.5u w=1.12u l=0.13u
X489 VSS.t358 VDD.t1648 VSS.t358 VSS.t361 sg13_lv_nmos ad=79.8f pd=0.8u as=0 ps=0 w=0.42u l=1u
X490 a_16408_16071# a_15837_16869# VDD.t851 VDD.t90 sg13_lv_pmos ad=0.2128p pd=1.5u as=0.3808p ps=2.92u w=1.12u l=0.13u
X491 a_15511_16869# a_15273_16869# a_15403_16869# VSS.t1187 sg13_lv_nmos ad=0.1406p pd=1.12u as=0.2516p ps=2.16u w=0.74u l=0.2u
X492 a_19550_6734# a_3747_6737.t4 a_21835_6734# VSS.t1769 sg13_lv_nmos ad=0.2516p pd=2.16u as=0.1406p ps=1.12u w=0.74u l=0.13u
X493 a_7673_1842# a_7477_1842# VSS.t982 VSS.t1324 sg13_lv_nmos ad=0.2516p pd=2.16u as=0.1406p ps=1.12u w=0.74u l=0.13u
X494 VDD.t835 a_19637_7532# a_20105_6734# VDD.t67 sg13_lv_pmos ad=0.252p pd=1.57u as=0.3808p ps=2.92u w=1.12u l=0.13u
X495 VDD.t1189 a_3171_1047.t5 a_18004_1008# VDD.t2 sg13_lv_pmos ad=0.3808p pd=2.92u as=0.3808p ps=2.92u w=1.12u l=0.13u
X496 VSS.t1675 a_3747_3892.t2 a_27991_3853# VSS.t1674 sg13_lv_nmos ad=0.2516p pd=2.16u as=0.2516p ps=2.16u w=0.74u l=0.13u
X497 VSS.t1156 CHAN1_MUX_SEL1 a_3543_13577# VSS.t1155 sg13_lv_nmos ad=0.1331p pd=1.12u as=0.1216p ps=1.02u w=0.64u l=0.13u
X498 VSS.t1458 a_4187_1764.t147 a_16271_16869# VSS.t2360 sg13_lv_nmos ad=0.2516p pd=2.16u as=0.1406p ps=1.12u w=0.74u l=0.6u
X499 a_26673_14024# a_26477_14024# VSS.t890 VSS.t1976 sg13_lv_nmos ad=0.2516p pd=2.16u as=0.1406p ps=1.12u w=0.74u l=0.13u
X500 VDD.t1382 a_2019_13229.t7 a_10404_13190# VDD.t5 sg13_lv_pmos ad=0.3808p pd=2.92u as=0.3808p ps=2.92u w=1.12u l=0.13u
X501 VDD.t538 a_13123_1842# a_13557_1842# VDD.t373 sg13_lv_pmos ad=0.2128p pd=1.5u as=0.3808p ps=2.92u w=1.12u l=0.13u
X502 VSS.t18 a_4187_1764.t75 a_20831_7532# VSS.t896 sg13_lv_nmos ad=0.2516p pd=2.16u as=0.1406p ps=1.12u w=0.74u l=0.6u
X503 VDD.t1446 a_16851_15336# CHAN0_MUX_OUT VDD.t90 sg13_lv_pmos ad=0.7336p pd=3.55u as=0.2128p ps=1.5u w=1.12u l=0.13u
X504 VDD.t888 a_3747_311.t2 a_26985_519# VDD.t2 sg13_lv_pmos ad=0.3808p pd=2.92u as=0.3808p ps=2.92u w=1.12u l=0.13u
X505 VDD.t744 a_4187_2434# a_27671_5315# VDD.t348 sg13_lv_pmos ad=0.3808p pd=2.92u as=0.2128p ps=1.5u w=1.12u l=0.6u
X506 VSS.t253 VDD.t1683 VSS.t253 VSS.t255 sg13_lv_nmos ad=79.8f pd=0.8u as=0 ps=0 w=0.42u l=1u
X507 a_7390_3889# a_7364_3853# a_7288_3889# VDD.t0 sg13_lv_pmos ad=0.3808p pd=2.92u as=0.2128p ps=1.5u w=1.12u l=0.13u
X508 a_16510_16071# a_17351_16035# a_17275_16071# VDD.t90 sg13_lv_pmos ad=0.3808p pd=2.92u as=0.2128p ps=1.5u w=1.12u l=0.13u
X509 a_10430_1044# a_3747_1047.t7 a_12715_1044# VSS.t703 sg13_lv_nmos ad=0.2516p pd=2.16u as=0.1406p ps=1.12u w=0.74u l=0.13u
X510 VSS.t22 a_3747_3892.t9 a_6711_3853# VSS.t1672 sg13_lv_nmos ad=0.2516p pd=2.16u as=0.2516p ps=2.16u w=0.74u l=0.13u
X511 a_25913_1842# a_25717_1842# VDD.t1071 VDD.t373 sg13_lv_pmos ad=0.3808p pd=2.92u as=0.2128p ps=1.5u w=1.12u l=0.13u
X512 VSS.t265 VDD.t1680 VSS.t265 VSS.t266 sg13_lv_nmos ad=0.1428p pd=1.52u as=0 ps=0 w=0.42u l=1u
X513 VSS.t495 VSS.t496 VSS.t495 VSS.t497 sg13_lv_nmos ad=0.1406p pd=1.12u as=0 ps=0 w=0.74u l=0.2u
X514 a_24875_1044# a_24665_1044# VSS.t1173 VSS.t1172 sg13_lv_nmos ad=0.1406p pd=1.12u as=0.1665p ps=1.19u w=0.74u l=0.13u
X515 a_14235_1044# a_14025_1044# VDD.t539 VDD.t2 sg13_lv_pmos ad=0.2128p pd=1.5u as=0.252p ps=1.57u w=1.12u l=0.13u
X516 a_25391_4687# a_25153_4687# a_25283_4687# VSS.t2165 sg13_lv_nmos ad=0.1406p pd=1.12u as=0.2516p ps=2.16u w=0.74u l=0.2u
X517 VSS.t169 a_22677_7532# a_23145_6734# VSS.t168 sg13_lv_nmos ad=0.1665p pd=1.19u as=0.2516p ps=2.16u w=0.74u l=0.13u
X518 VDD.t862 a_19963_14024# a_20397_14024# VDD.t374 sg13_lv_pmos ad=0.2128p pd=1.5u as=0.3808p ps=2.92u w=1.12u l=0.13u
X519 VSS.t826 a_4187_1764.t98 VSS.t824 VSS.t809 sg13_lv_nmos ad=1.33p pd=7.38u as=0 ps=0 w=7u l=7u
X520 VSS.t1249 a_4187_1764.t23 a_11711_1842# VSS.t1477 sg13_lv_nmos ad=0.2516p pd=2.16u as=0.1406p ps=1.12u w=0.74u l=0.6u
X521 a_10191_7532# a_9953_7532# a_10083_7532# VSS.t611 sg13_lv_nmos ad=0.1406p pd=1.12u as=0.2516p ps=2.16u w=0.74u l=0.2u
X522 VDD.t1022 a_1256_6734# a_2873_7085# VDD.t67 sg13_lv_pmos ad=0.1918p pd=1.5u as=0.1596p ps=1.22u w=0.84u l=0.13u
X523 VSS.t739 a_2595_1047.t3 a_23431_1008# VSS.t738 sg13_lv_nmos ad=0.2516p pd=2.16u as=0.2516p ps=2.16u w=0.74u l=0.13u
X524 VDD.t570 a_3747_1047.t7 a_12791_1008# VDD.t2 sg13_lv_pmos ad=0.3808p pd=2.92u as=0.3808p ps=2.92u w=1.12u l=0.13u
X525 VDD.t404 a_12849_11557# a_13566_11018# VDD.t355 sg13_lv_pmos ad=0.1563p pd=1.22u as=0.147p ps=1.54u w=0.42u l=0.13u
X526 a_4350_13226# a_5191_13190# a_5115_13226# VDD.t5 sg13_lv_pmos ad=0.3808p pd=2.92u as=0.2128p ps=1.5u w=1.12u l=0.13u
X527 a_14751_8160# a_14513_7532# a_14643_7532# VDD.t346 sg13_lv_pmos ad=0.2128p pd=1.5u as=0.3808p ps=2.92u w=1.12u l=0.2u
X528 a_12993_4687# a_12797_4687# VSS.t35 VSS.t2223 sg13_lv_nmos ad=0.2516p pd=2.16u as=0.1406p ps=1.12u w=0.74u l=0.13u
X529 VSS.t1099 a_18443_16869# a_18877_16869# VSS.t1098 sg13_lv_nmos ad=0.1406p pd=1.12u as=0.2516p ps=2.16u w=0.74u l=0.13u
X530 a_2595_3892.t0 a_2297_4240# VDD.t581 VDD.t0 sg13_lv_pmos ad=0.2128p pd=1.5u as=0.1918p ps=1.5u w=1.12u l=0.13u
X531 VDD.t100 VSS.t305 VDD.t99 VDD.t67 sg13_lv_pmos ad=0.34p pd=2.68u as=0 ps=0 w=1u l=1u
X532 a_16510_6734# a_17351_6698# a_17275_6734# VDD.t67 sg13_lv_pmos ad=0.3808p pd=2.92u as=0.2128p ps=1.5u w=1.12u l=0.13u
X533 VSS.t717 a_21483_1842# a_21917_1842# VSS.t1331 sg13_lv_nmos ad=0.1406p pd=1.12u as=0.2516p ps=2.16u w=0.74u l=0.13u
X534 a_20315_16071# a_20105_16071# VSS.t2059 VSS.t2058 sg13_lv_nmos ad=0.1406p pd=1.12u as=0.1665p ps=1.19u w=0.74u l=0.13u
X535 VDD.t1530 a_3171_15338.t3 a_11785_15546# VDD.t90 sg13_lv_pmos ad=0.3808p pd=2.92u as=0.3808p ps=2.92u w=1.12u l=0.13u
X536 VDD.t471 VDD.t469 VDD.t467 VDD.t346 sg13_lv_pmos ad=0.2128p pd=1.5u as=0 ps=0 w=1.12u l=0.13u
X537 VSS.t639 a_13557_1842# a_14025_1044# VSS.t638 sg13_lv_nmos ad=0.1665p pd=1.19u as=0.2516p ps=2.16u w=0.74u l=0.13u
X538 VDD.t31 VSS.t365 VDD.t30 VDD.t0 sg13_lv_pmos ad=0.34p pd=2.68u as=0 ps=0 w=1u l=1u
X539 a_2595_15338.t0 a_2297_15358# VDD.t1433 VDD.t90 sg13_lv_pmos ad=0.2128p pd=1.5u as=0.1918p ps=1.5u w=1.12u l=0.13u
X540 a_2595_15338.t1 a_2297_15358# VSS.t2097 VSS.t2343 sg13_lv_nmos ad=0.1406p pd=1.12u as=0.1331p ps=1.12u w=0.74u l=0.13u
X541 a_17928_13226# a_17357_14024# VSS.t1007 VSS.t1970 sg13_lv_nmos ad=0.1406p pd=1.12u as=0.2516p ps=2.16u w=0.74u l=0.13u
X542 a_4111_8160# REF_CLK a_4003_7532# VDD.t346 sg13_lv_pmos ad=0.2128p pd=1.5u as=0.3808p ps=2.92u w=1.12u l=0.2u
X543 a_11848_1044# a_11277_1842# VDD.t859 VDD.t2 sg13_lv_pmos ad=0.2128p pd=1.5u as=0.3808p ps=2.92u w=1.12u l=0.13u
X544 VDD.t1241 a_5523_16869# a_5957_16869# VDD.t368 sg13_lv_pmos ad=0.2128p pd=1.5u as=0.3808p ps=2.92u w=1.12u l=0.13u
X545 VSS.t1086 a_4187_1764.t52 a_13991_4687# VSS.t2265 sg13_lv_nmos ad=0.2516p pd=2.16u as=0.1406p ps=1.12u w=0.74u l=0.6u
X546 a_16033_4687# a_15837_4687# VDD.t544 VDD.t348 sg13_lv_pmos ad=0.3808p pd=2.92u as=0.2128p ps=1.5u w=1.12u l=0.13u
X547 VDD.t1220 a_3747_6737.t2 a_27991_6698# VDD.t67 sg13_lv_pmos ad=0.3808p pd=2.92u as=0.3808p ps=2.92u w=1.12u l=0.13u
X548 a_7151_5315# a_6913_4687# a_7043_4687# VDD.t348 sg13_lv_pmos ad=0.2128p pd=1.5u as=0.3808p ps=2.92u w=1.12u l=0.2u
X549 a_1721_4240# a_1256_3889# VDD.t513 VDD.t0 sg13_lv_pmos ad=0.1596p pd=1.22u as=0.2856p ps=2.36u w=0.84u l=0.13u
X550 VDD.t325 VSS.t466 VDD.t313 VDD.t2 sg13_lv_pmos ad=0.19p pd=1.38u as=0 ps=0 w=1u l=1u
X551 a_27671_14024# a_27433_14024# a_27563_14024# VSS.t646 sg13_lv_nmos ad=0.1406p pd=1.12u as=0.2516p ps=2.16u w=0.74u l=0.2u
X552 VDD.t1219 a_3747_6737.t9 a_6711_6698# VDD.t67 sg13_lv_pmos ad=0.3808p pd=2.92u as=0.3808p ps=2.92u w=1.12u l=0.13u
X553 VSS.t1362 a_23763_4687# a_24197_4687# VSS.t2073 sg13_lv_nmos ad=0.1406p pd=1.12u as=0.2516p ps=2.16u w=0.74u l=0.13u
X554 a_7673_7532# a_7477_7532# VSS.t868 VSS.t867 sg13_lv_nmos ad=0.2516p pd=2.16u as=0.1406p ps=1.12u w=0.74u l=0.13u
X555 a_25630_13226# a_25604_13190# a_25528_13226# VDD.t5 sg13_lv_pmos ad=0.3808p pd=2.92u as=0.2128p ps=1.5u w=1.12u l=0.13u
X556 VSS.t86 VDD.t1652 VSS.t86 VSS.t352 sg13_lv_nmos ad=79.8f pd=0.8u as=0 ps=0 w=0.42u l=1u
X557 a_19448_13226# a_18877_14024# VDD.t1481 VDD.t5 sg13_lv_pmos ad=0.2128p pd=1.5u as=0.3808p ps=2.92u w=1.12u l=0.13u
X558 VDD.t150 VSS.t301 VDD.t149 VDD.t5 sg13_lv_pmos ad=0.34p pd=2.68u as=0 ps=0 w=1u l=1u
X559 a_15755_16071# a_15545_16071# VDD.t509 VDD.t90 sg13_lv_pmos ad=0.2128p pd=1.5u as=0.252p ps=1.57u w=1.12u l=0.13u
X560 VDD.t1548 a_13123_7532# a_13557_7532# VDD.t346 sg13_lv_pmos ad=0.2128p pd=1.5u as=0.3808p ps=2.92u w=1.12u l=0.13u
X561 a_11473_16869# a_11277_16869# VSS.t1186 VSS.t1453 sg13_lv_nmos ad=0.2516p pd=2.16u as=0.1406p ps=1.12u w=0.74u l=0.13u
X562 a_25913_7532# a_25717_7532# VDD.t414 VDD.t346 sg13_lv_pmos ad=0.3808p pd=2.92u as=0.2128p ps=1.5u w=1.12u l=0.13u
X563 a_10430_6734# a_3747_6737.t7 a_12715_6734# VSS.t1767 sg13_lv_nmos ad=0.2516p pd=2.16u as=0.1406p ps=1.12u w=0.74u l=0.13u
X564 a_13470_13226# a_3171_13229.t6 a_14888_13226# VSS.t1555 sg13_lv_nmos ad=0.2516p pd=2.16u as=0.1406p ps=1.12u w=0.74u l=0.13u
X565 VSS.t837 a_4187_1764.t35 a_26911_4687# VSS.t1853 sg13_lv_nmos ad=0.2516p pd=2.16u as=0.1406p ps=1.12u w=0.74u l=0.6u
X566 VDD.t923 a_21483_16869# a_21917_16869# VDD.t368 sg13_lv_pmos ad=0.2128p pd=1.5u as=0.3808p ps=2.92u w=1.12u l=0.13u
X567 VDD.t13 VSS.t243 VDD.t11 VDD.t5 sg13_lv_pmos ad=0.19p pd=1.38u as=0 ps=0 w=1u l=1u
X568 a_24875_6734# a_24665_6734# VSS.t620 VSS.t619 sg13_lv_nmos ad=0.1406p pd=1.12u as=0.1665p ps=1.19u w=0.74u l=0.13u
X569 a_25391_1842# a_25153_1842# a_25283_1842# VSS.t1635 sg13_lv_nmos ad=0.1406p pd=1.12u as=0.2516p ps=2.16u w=0.74u l=0.2u
X570 a_13470_16071# a_2019_16074.t6 a_13368_16071# VSS.t1616 sg13_lv_nmos ad=0.2516p pd=2.16u as=0.1406p ps=1.12u w=0.74u l=0.13u
X571 VSS.t816 a_4187_1764.t98 VSS.t818 VSS.t817 sg13_lv_nmos ad=1.33p pd=7.38u as=0 ps=0 w=7u l=7u
X572 a_6326_10280# a_5974_11413# a_6126_9506# VSS.t49 sg13_lv_nmos ad=0.38p pd=2.38u as=0.68p ps=4.68u w=2u l=1u
X573 VSS.t849 a_4187_1764.t87 a_11711_7532# VSS.t2261 sg13_lv_nmos ad=0.2516p pd=2.16u as=0.1406p ps=1.12u w=0.74u l=0.6u
X574 VDD.t802 a_5523_4687# a_5957_4687# VDD.t348 sg13_lv_pmos ad=0.2128p pd=1.5u as=0.3808p ps=2.92u w=1.12u l=0.13u
X575 a_10430_13226# a_2019_13229.t7 a_10328_13226# VSS.t2037 sg13_lv_nmos ad=0.2516p pd=2.16u as=0.1406p ps=1.12u w=0.74u l=0.13u
X576 VSS.t159 a_12849_11557# a_13400_11995# VSS.t158 sg13_lv_nmos ad=0.1626p pd=1.415u as=60.89999f ps=0.71u w=0.42u l=0.13u
X577 VSS.t1280 a_2595_6737.t3 a_23431_6698# VSS.t1436 sg13_lv_nmos ad=0.2516p pd=2.16u as=0.2516p ps=2.16u w=0.74u l=0.13u
X578 VDD.t1105 a_2019_3892.t4 a_19524_3853# VDD.t0 sg13_lv_pmos ad=0.3808p pd=2.92u as=0.3808p ps=2.92u w=1.12u l=0.13u
X579 a_12993_1842# a_12797_1842# VSS.t124 VSS.t894 sg13_lv_nmos ad=0.2516p pd=2.16u as=0.1406p ps=1.12u w=0.74u l=0.13u
X580 VDD.t52 VSS.t86 VDD.t51 VDD.t0 sg13_lv_pmos ad=0.34p pd=2.68u as=0 ps=0 w=1u l=1u
X581 a_7390_3889# a_2019_3892.t8 a_7288_3889# VSS.t1916 sg13_lv_nmos ad=0.2516p pd=2.16u as=0.1406p ps=1.12u w=0.74u l=0.13u
X582 VSS.t1259 a_21483_7532# a_21917_7532# VSS.t1258 sg13_lv_nmos ad=0.1406p pd=1.12u as=0.2516p ps=2.16u w=0.74u l=0.13u
X583 a_5731_12471# a_3747_12493.t3 a_13470_13226# VSS.t66 sg13_lv_nmos ad=0.2516p pd=2.16u as=0.2516p ps=2.16u w=0.74u l=0.13u
X584 VSS.t2209 a_13557_7532# a_14025_6734# VSS.t2351 sg13_lv_nmos ad=0.1665p pd=1.19u as=0.2516p ps=2.16u w=0.74u l=0.13u
X585 VDD.t327 VSS.t466 VDD.t326 VDD.t2 sg13_lv_pmos ad=0.34p pd=2.68u as=0 ps=0 w=1u l=1u
X586 a_3543_3176# CHAN2_MUX_SEL2 a_3449_3176# VSS.t618 sg13_lv_nmos ad=0.1216p pd=1.02u as=0.2176p ps=1.96u w=0.64u l=0.13u
X587 a_16108_5979# a_3171_6001.t2 a_22590_6734# VSS.t770 sg13_lv_nmos ad=0.2516p pd=2.16u as=0.2516p ps=2.16u w=0.74u l=0.13u
X588 a_2873_15358# CHAN0_MUX_SEL3 VDD.t1466 VDD.t90 sg13_lv_pmos ad=0.1596p pd=1.22u as=0.2856p ps=2.36u w=0.84u l=0.13u
X589 a_16510_13226# a_16484_13190# a_16408_13226# VDD.t5 sg13_lv_pmos ad=0.3808p pd=2.92u as=0.2128p ps=1.5u w=1.12u l=0.13u
X590 CHAN3_DELAY_OUT_LAST a_27997_1842# VDD.t1118 VDD.t373 sg13_lv_pmos ad=0.3808p pd=2.92u as=0.2128p ps=1.5u w=1.12u l=0.13u
X591 VSS.t1069 a_4187_1764.t111 a_19311_14024# VSS.t1715 sg13_lv_nmos ad=0.2516p pd=2.16u as=0.1406p ps=1.12u w=0.74u l=0.6u
X592 VDD.t377 a_19637_1842# a_20105_1044# VDD.t2 sg13_lv_pmos ad=0.252p pd=1.57u as=0.3808p ps=2.92u w=1.12u l=0.13u
X593 VSS.t216 VDD.t1693 VSS.t216 VSS.t218 sg13_lv_nmos ad=0.1428p pd=1.52u as=0 ps=0 w=0.42u l=1u
X594 a_19550_13226# a_2595_13229.t4 a_20315_13226# VSS.t1014 sg13_lv_nmos ad=0.2516p pd=2.16u as=0.1406p ps=1.12u w=0.74u l=0.13u
X595 VSS.t2062 a_5957_14024# a_6425_13226# VSS.t2131 sg13_lv_nmos ad=0.1665p pd=1.19u as=0.2516p ps=2.16u w=0.74u l=0.13u
X596 a_22590_1044# a_3171_1047.t3 a_24008_1044# VSS.t1285 sg13_lv_nmos ad=0.2516p pd=2.16u as=0.1406p ps=1.12u w=0.74u l=0.13u
X597 a_15755_3889# a_15545_3889# VDD.t1013 VDD.t0 sg13_lv_pmos ad=0.2128p pd=1.5u as=0.252p ps=1.57u w=1.12u l=0.13u
X598 VSS.t451 VDD.t1621 VSS.t451 VSS.t450 sg13_lv_nmos ad=0.1428p pd=1.52u as=0 ps=0 w=0.42u l=1u
X599 VDD.t623 a_4187_2434# a_8671_5315# VDD.t348 sg13_lv_pmos ad=0.3808p pd=2.92u as=0.2128p ps=1.5u w=1.12u l=0.6u
X600 VDD.t1322 a_5523_14024# a_5957_14024# VDD.t374 sg13_lv_pmos ad=0.2128p pd=1.5u as=0.3808p ps=2.92u w=1.12u l=0.13u
X601 VDD.t535 a_2297_12513# a_2595_12493.t0 VDD.t5 sg13_lv_pmos ad=0.4256p pd=3u as=0.2128p ps=1.5u w=1.12u l=0.13u
X602 a_12943_11557# a_12656_11554# a_12849_11557# VDD.t355 sg13_lv_pmos ad=0.2128p pd=1.5u as=0.3808p ps=2.92u w=1.12u l=0.13u
X603 VSS.t971 a_4187_1764.t20 a_13991_1842# VSS.t970 sg13_lv_nmos ad=0.2516p pd=2.16u as=0.1406p ps=1.12u w=0.74u l=0.6u
X604 VSS.t1861 a_13121_11521# a_6854_11676# VDD.t456 sg13_lv_pmos ad=0.232p pd=2.08u as=0.136p ps=1.14u w=0.4u l=0.2u
X605 VDD.t1217 a_1544_16071# a_2297_16422# VDD.t90 sg13_lv_pmos ad=0.1918p pd=1.5u as=0.1596p ps=1.22u w=0.84u l=0.13u
X606 a_6913_1842# a_6717_1842# VDD.t1046 VDD.t373 sg13_lv_pmos ad=0.3808p pd=2.92u as=0.2128p ps=1.5u w=1.12u l=0.13u
X607 VDD.t823 a_2595_3892.t6 a_14311_3853# VDD.t0 sg13_lv_pmos ad=0.3808p pd=2.92u as=0.3808p ps=2.92u w=1.12u l=0.13u
X608 VDD.t757 a_4187_2434# a_18551_2470# VDD.t373 sg13_lv_pmos ad=0.3808p pd=2.92u as=0.2128p ps=1.5u w=1.12u l=0.6u
X609 VSS.t393 VDD.t1636 VSS.t390 VSS.t392 sg13_lv_nmos ad=79.8f pd=0.8u as=0 ps=0 w=0.42u l=1u
X610 a_15273_4687# a_15077_4687# VSS.t1342 VSS.t1341 sg13_lv_nmos ad=0.2516p pd=2.16u as=0.1406p ps=1.12u w=0.74u l=0.13u
X611 a_17031_16869# a_16793_16869# a_16923_16869# VSS.t1749 sg13_lv_nmos ad=0.1406p pd=1.12u as=0.2516p ps=2.16u w=0.74u l=0.2u
X612 a_6391_4687# a_6153_4687# a_6283_4687# VSS.t2206 sg13_lv_nmos ad=0.1406p pd=1.12u as=0.2516p ps=2.16u w=0.74u l=0.2u
X613 a_3171_15338.t0 a_2873_15358# VDD.t1417 VDD.t90 sg13_lv_pmos ad=0.2128p pd=1.5u as=0.1918p ps=1.5u w=1.12u l=0.13u
X614 a_3171_15338.t1 a_2873_15358# VSS.t2088 VSS.t1073 sg13_lv_nmos ad=0.1406p pd=1.12u as=0.1331p ps=1.12u w=0.74u l=0.13u
X615 VSS.t1304 a_23763_1842# a_24197_1842# VSS.t1303 sg13_lv_nmos ad=0.1406p pd=1.12u as=0.2516p ps=2.16u w=0.74u l=0.13u
X616 a_5115_3889# a_4905_3889# VDD.t587 VDD.t0 sg13_lv_pmos ad=0.2128p pd=1.5u as=0.252p ps=1.57u w=1.12u l=0.13u
X617 VDD.t448 VDD.t446 VDD.t447 VDD.t355 sg13_lv_pmos ad=0.38p pd=2.38u as=0 ps=0 w=2u l=1u
X618 VSS.t423 VDD.t1628 VSS.t422 VSS.t421 sg13_lv_nmos ad=0.1428p pd=1.52u as=0 ps=0 w=0.42u l=1u
X619 a_13368_16071# a_12797_16869# VDD.t1515 VDD.t90 sg13_lv_pmos ad=0.2128p pd=1.5u as=0.3808p ps=2.92u w=1.12u l=0.13u
X620 a_12471_16869# a_12233_16869# a_12363_16869# VSS.t1863 sg13_lv_nmos ad=0.1406p pd=1.12u as=0.2516p ps=2.16u w=0.74u l=0.2u
X621 VSS.t1293 a_4187_1764.t145 a_17791_16869# VSS.t1546 sg13_lv_nmos ad=0.2516p pd=2.16u as=0.1406p ps=1.12u w=0.74u l=0.6u
X622 VDD.t399 a_1256_1044# a_2873_1395# VDD.t2 sg13_lv_pmos ad=0.1918p pd=1.5u as=0.1596p ps=1.22u w=0.84u l=0.13u
X623 VDD.t867 DLL_RESETN a_10206_11525# VDD.t355 sg13_lv_pmos ad=0.1563p pd=1.22u as=0.147p ps=1.54u w=0.42u l=0.13u
X624 VSS.t30 CHAN0_MUX_SEL1 a_3543_16422# VSS.t29 sg13_lv_nmos ad=0.1331p pd=1.12u as=0.1216p ps=1.02u w=0.64u l=0.13u
X625 VDD.t1280 a_2873_331# a_3171_311.t0 VDD.t2 sg13_lv_pmos ad=0.4256p pd=3u as=0.2128p ps=1.5u w=1.12u l=0.13u
X626 VSS.t678 a_15964_5979# a_16851_5999# VSS.t1266 sg13_lv_nmos ad=0.1371p pd=1.12u as=0.2176p ps=1.96u w=0.64u l=0.13u
X627 a_4111_17497# CHAN0_DELAY_IN a_4003_16869# VDD.t368 sg13_lv_pmos ad=0.2128p pd=1.5u as=0.3808p ps=2.92u w=1.12u l=0.2u
X628 VSS.t635 a_4187_1764.t151 a_13231_16869# VSS.t634 sg13_lv_nmos ad=0.2516p pd=2.16u as=0.1406p ps=1.12u w=0.74u l=0.6u
X629 a_23633_14024# a_23437_14024# VSS.t1419 VSS.t2334 sg13_lv_nmos ad=0.2516p pd=2.16u as=0.1406p ps=1.12u w=0.74u l=0.13u
X630 VSS.t282 VDD.t1676 VSS.t281 VSS.t280 sg13_lv_nmos ad=0.1428p pd=1.52u as=0 ps=0 w=0.42u l=1u
X631 a_9712_9602# a_6854_11144# a_9444_9602# VSS.t137 sg13_lv_nmos ad=0.38p pd=2.38u as=0.68p ps=4.68u w=2u l=1u
X632 a_3171_311.t1 a_2873_331# VSS.t1859 VSS.t1858 sg13_lv_nmos ad=0.1406p pd=1.12u as=0.1331p ps=1.12u w=0.74u l=0.13u
X633 a_16510_16071# a_18871_16035# a_18795_16071# VDD.t90 sg13_lv_pmos ad=0.3808p pd=2.92u as=0.2128p ps=1.5u w=1.12u l=0.13u
X634 a_25630_1044# a_3747_1047.t2 a_27915_1044# VSS.t700 sg13_lv_nmos ad=0.2516p pd=2.16u as=0.1406p ps=1.12u w=0.74u l=0.13u
X635 a_16510_1044# a_17351_1008# a_17275_1044# VDD.t2 sg13_lv_pmos ad=0.3808p pd=2.92u as=0.2128p ps=1.5u w=1.12u l=0.13u
X636 VSS.t1480 a_16923_14024# a_17357_14024# VSS.t1479 sg13_lv_nmos ad=0.1406p pd=1.12u as=0.2516p ps=2.16u w=0.74u l=0.13u
X637 a_7390_6734# a_7364_6698# a_7288_6734# VDD.t67 sg13_lv_pmos ad=0.3808p pd=2.92u as=0.2128p ps=1.5u w=1.12u l=0.13u
X638 VDD.t869 a_3449_331# a_3747_311.t0 VDD.t2 sg13_lv_pmos ad=0.4256p pd=3u as=0.2128p ps=1.5u w=1.12u l=0.13u
X639 a_1256_16071# CHAN0_MUX_SEL0 VDD.t416 VDD.t90 sg13_lv_pmos ad=0.3808p pd=2.92u as=0.3808p ps=2.92u w=1.12u l=0.13u
X640 VSS.t202 VDD.t1698 VSS.t202 VSS.t207 sg13_lv_nmos ad=79.8f pd=0.8u as=0 ps=0 w=0.42u l=1u
X641 VSS.t653 a_15403_4687# a_15837_4687# VSS.t1568 sg13_lv_nmos ad=0.1406p pd=1.12u as=0.2516p ps=2.16u w=0.74u l=0.13u
X642 a_12471_5315# a_12233_4687# a_12363_4687# VDD.t348 sg13_lv_pmos ad=0.2128p pd=1.5u as=0.3808p ps=2.92u w=1.12u l=0.2u
X643 a_13470_16071# a_14311_16035# a_14235_16071# VDD.t90 sg13_lv_pmos ad=0.3808p pd=2.92u as=0.2128p ps=1.5u w=1.12u l=0.13u
X644 VDD.t1056 a_21483_14024# a_21917_14024# VDD.t374 sg13_lv_pmos ad=0.2128p pd=1.5u as=0.3808p ps=2.92u w=1.12u l=0.13u
X645 a_3747_311.t1 a_3449_331# VSS.t1079 VSS.t1078 sg13_lv_nmos ad=0.1406p pd=1.12u as=0.1331p ps=1.12u w=0.74u l=0.13u
X646 VSS.t795 a_4187_1764.t3 a_26911_1842# VSS.t794 sg13_lv_nmos ad=0.2516p pd=2.16u as=0.1406p ps=1.12u w=0.74u l=0.6u
X647 VSS.t489 VSS.t489 VSS.t491 VSS.t490 sg13_lv_nmos ad=0.1406p pd=1.12u as=0 ps=0 w=0.74u l=0.13u
X648 a_25391_7532# a_25153_7532# a_25283_7532# VSS.t1590 sg13_lv_nmos ad=0.1406p pd=1.12u as=0.2516p ps=2.16u w=0.74u l=0.2u
X649 VDD.t569 a_3747_1047.t2 a_27991_1008# VDD.t2 sg13_lv_pmos ad=0.3808p pd=2.92u as=0.3808p ps=2.92u w=1.12u l=0.13u
X650 VDD.t761 a_4187_2434# a_22351_2470# VDD.t373 sg13_lv_pmos ad=0.3808p pd=2.92u as=0.2128p ps=1.5u w=1.12u l=0.6u
X651 VSS.t253 VDD.t1683 VSS.t253 VSS.t254 sg13_lv_nmos ad=0.1428p pd=1.52u as=0 ps=0 w=0.42u l=1u
X652 VDD.t43 VSS.t401 VDD.t95 VDD.t2 sg13_lv_pmos ad=0.19p pd=1.38u as=0 ps=0 w=1u l=1u
X653 VSS.t195 VDD.t1703 VSS.t195 VSS.t196 sg13_lv_nmos ad=79.8f pd=0.8u as=0 ps=0 w=0.42u l=1u
X654 VDD.t549 a_3171_16074.t8 a_8884_16035# VDD.t90 sg13_lv_pmos ad=0.3808p pd=2.92u as=0.3808p ps=2.92u w=1.12u l=0.13u
X655 a_12993_7532# a_12797_7532# VSS.t751 VSS.t750 sg13_lv_nmos ad=0.2516p pd=2.16u as=0.1406p ps=1.12u w=0.74u l=0.13u
X656 VSS.t870 a_4763_4687# a_5197_4687# VSS.t2224 sg13_lv_nmos ad=0.1406p pd=1.12u as=0.2516p ps=2.16u w=0.74u l=0.13u
X657 VDD.t1533 a_1721_6021# a_2019_6001.t0 VDD.t67 sg13_lv_pmos ad=0.4256p pd=3u as=0.2128p ps=1.5u w=1.12u l=0.13u
X658 VSS.t574 a_15403_16869# a_15837_16869# VSS.t573 sg13_lv_nmos ad=0.1406p pd=1.12u as=0.2516p ps=2.16u w=0.74u l=0.13u
X659 VDD.t381 a_11491_11918# a_11748_11799# VDD.t355 sg13_lv_pmos ad=1.10612p pd=6.66u as=79.8f ps=0.8u w=0.42u l=0.13u
X660 VDD.t568 a_3747_1047.t9 a_6711_1008# VDD.t2 sg13_lv_pmos ad=0.3808p pd=2.92u as=0.3808p ps=2.92u w=1.12u l=0.13u
X661 VDD.t381 a_10649_11568# a_10751_11568# VDD.t355 sg13_lv_pmos ad=1.10612p pd=6.66u as=0.3864p ps=2.93u w=1.12u l=0.13u
X662 a_2873_12513# CHAN1_MUX_SEL3 VDD.t566 VDD.t5 sg13_lv_pmos ad=0.1596p pd=1.22u as=0.2856p ps=2.36u w=0.84u l=0.13u
X663 REF_DELAY_OUT_LAST a_27997_7532# VDD.t419 VDD.t346 sg13_lv_pmos ad=0.3808p pd=2.92u as=0.2128p ps=1.5u w=1.12u l=0.13u
X664 VDD.t1099 a_7043_16869# a_7477_16869# VDD.t368 sg13_lv_pmos ad=0.2128p pd=1.5u as=0.3808p ps=2.92u w=1.12u l=0.13u
X665 a_17928_16071# a_17357_16869# VSS.t107 VSS.t2142 sg13_lv_nmos ad=0.1406p pd=1.12u as=0.2516p ps=2.16u w=0.74u l=0.13u
X666 a_22590_6734# a_3171_6737.t3 a_24008_6734# VSS.t1882 sg13_lv_nmos ad=0.2516p pd=2.16u as=0.1406p ps=1.12u w=0.74u l=0.13u
X667 VSS.t1513 a_2019_3892.t4 a_19524_3853# VSS.t1512 sg13_lv_nmos ad=0.2516p pd=2.16u as=0.2516p ps=2.16u w=0.74u l=0.13u
X668 VSS.t262 VDD.t1681 VSS.t265 VSS.t264 sg13_lv_nmos ad=79.8f pd=0.8u as=0 ps=0 w=0.42u l=1u
X669 a_12355_11557# a_12158_11557# VSS.t32 VSS.t31 sg13_lv_nmos ad=0.2516p pd=2.16u as=0.1406p ps=1.12u w=0.74u l=0.13u
X670 VSS.t65 a_4187_1764.t84 a_13991_7532# VSS.t1704 sg13_lv_nmos ad=0.2516p pd=2.16u as=0.1406p ps=1.12u w=0.74u l=0.6u
X671 a_14513_14024# a_14317_14024# VSS.t78 VSS.t1209 sg13_lv_nmos ad=0.2516p pd=2.16u as=0.1406p ps=1.12u w=0.74u l=0.13u
X672 VSS.t209 VDD.t1696 VSS.t209 VSS.t212 sg13_lv_nmos ad=79.8f pd=0.8u as=0 ps=0 w=0.42u l=1u
X673 a_6913_7532# a_6717_7532# VDD.t382 VDD.t346 sg13_lv_pmos ad=0.3808p pd=2.92u as=0.2128p ps=1.5u w=1.12u l=0.13u
X674 VDD.t703 a_4187_2434# a_18551_8160# VDD.t346 sg13_lv_pmos ad=0.3808p pd=2.92u as=0.2128p ps=1.5u w=1.12u l=0.6u
X675 VSS.t116 a_4187_1764.t60 a_7911_4687# VSS.t115 sg13_lv_nmos ad=0.2516p pd=2.16u as=0.1406p ps=1.12u w=0.74u l=0.6u
X676 VDD.t504 a_10843_4687# a_11277_4687# VDD.t348 sg13_lv_pmos ad=0.2128p pd=1.5u as=0.3808p ps=2.92u w=1.12u l=0.13u
X677 a_9953_4687# a_9757_4687# VDD.t364 VDD.t348 sg13_lv_pmos ad=0.3808p pd=2.92u as=0.2128p ps=1.5u w=1.12u l=0.13u
X678 a_20315_13226# a_20105_13226# VDD.t860 VDD.t5 sg13_lv_pmos ad=0.2128p pd=1.5u as=0.252p ps=1.57u w=1.12u l=0.13u
X679 a_15273_1842# a_15077_1842# VSS.t122 VSS.t1211 sg13_lv_nmos ad=0.2516p pd=2.16u as=0.1406p ps=1.12u w=0.74u l=0.13u
X680 VSS.t921 a_23763_7532# a_24197_7532# VSS.t920 sg13_lv_nmos ad=0.1406p pd=1.12u as=0.2516p ps=2.16u w=0.74u l=0.13u
X681 a_6391_1842# a_6153_1842# a_6283_1842# VSS.t1948 sg13_lv_nmos ad=0.1406p pd=1.12u as=0.2516p ps=2.16u w=0.74u l=0.2u
X682 a_19833_1842# a_19637_1842# VDD.t376 VDD.t373 sg13_lv_pmos ad=0.3808p pd=2.92u as=0.2128p ps=1.5u w=1.12u l=0.13u
X683 a_15755_3889# a_15545_3889# VSS.t1340 VSS.t1772 sg13_lv_nmos ad=0.1406p pd=1.12u as=0.1665p ps=1.19u w=0.74u l=0.13u
X684 VDD.t595 a_21157_4687# a_21625_3889# VDD.t0 sg13_lv_pmos ad=0.252p pd=1.57u as=0.3808p ps=2.92u w=1.12u l=0.13u
X685 VDD.t1210 a_1256_16071# a_2873_16422# VDD.t90 sg13_lv_pmos ad=0.1918p pd=1.5u as=0.1596p ps=1.22u w=0.84u l=0.13u
X686 a_12993_16869# a_12797_16869# VSS.t1599 VSS.t2235 sg13_lv_nmos ad=0.2516p pd=2.16u as=0.1406p ps=1.12u w=0.74u l=0.13u
X687 a_16108_289# a_23945_519# a_22590_1044# VDD.t2 sg13_lv_pmos ad=0.3808p pd=2.92u as=0.3808p ps=2.92u w=1.12u l=0.13u
X688 VSS.t965 a_2595_3892.t6 a_14311_3853# VSS.t964 sg13_lv_nmos ad=0.2516p pd=2.16u as=0.2516p ps=2.16u w=0.74u l=0.13u
X689 a_4111_14652# CHAN1_DELAY_IN a_4003_14024# VDD.t374 sg13_lv_pmos ad=0.2128p pd=1.5u as=0.3808p ps=2.92u w=1.12u l=0.2u
X690 a_25630_6734# a_3747_6737.t2 a_27915_6734# VSS.t1764 sg13_lv_nmos ad=0.2516p pd=2.16u as=0.1406p ps=1.12u w=0.74u l=0.13u
X691 a_24631_2470# a_24393_1842# a_24523_1842# VDD.t373 sg13_lv_pmos ad=0.2128p pd=1.5u as=0.3808p ps=2.92u w=1.12u l=0.2u
X692 a_3747_13229.t1 a_3449_13577# VSS.t1156 VSS.t2066 sg13_lv_nmos ad=0.1406p pd=1.12u as=0.1331p ps=1.12u w=0.74u l=0.13u
X693 a_9193_1842# a_8997_1842# VDD.t1299 VDD.t373 sg13_lv_pmos ad=0.3808p pd=2.92u as=0.2128p ps=1.5u w=1.12u l=0.13u
X694 a_5115_3889# a_4905_3889# VSS.t757 VSS.t1756 sg13_lv_nmos ad=0.1406p pd=1.12u as=0.1665p ps=1.19u w=0.74u l=0.13u
X695 a_13470_16071# a_3171_16074.t6 a_14888_16071# VSS.t605 sg13_lv_nmos ad=0.2516p pd=2.16u as=0.1406p ps=1.12u w=0.74u l=0.13u
X696 VSS.t270 VDD.t1679 VSS.t272 VSS.t271 sg13_lv_nmos ad=79.8f pd=0.8u as=0 ps=0 w=0.42u l=1u
X697 VSS.t645 a_15403_1842# a_15837_1842# VSS.t644 sg13_lv_nmos ad=0.1406p pd=1.12u as=0.2516p ps=2.16u w=0.74u l=0.13u
X698 VSS.t1357 a_4187_1764.t67 a_26911_7532# VSS.t1870 sg13_lv_nmos ad=0.2516p pd=2.16u as=0.1406p ps=1.12u w=0.74u l=0.6u
X699 a_8155_1044# a_7945_1044# VSS.t1326 VSS.t2305 sg13_lv_nmos ad=0.1406p pd=1.12u as=0.1665p ps=1.19u w=0.74u l=0.13u
X700 VSS.t86 VDD.t1650 VSS.t86 VSS.t355 sg13_lv_nmos ad=0.1428p pd=1.52u as=0 ps=0 w=0.42u l=1u
X701 a_10430_13226# a_3171_13229.t7 a_11848_13226# VSS.t1656 sg13_lv_nmos ad=0.2516p pd=2.16u as=0.1406p ps=1.12u w=0.74u l=0.13u
X702 VDD.t709 a_4187_2434# a_22351_8160# VDD.t346 sg13_lv_pmos ad=0.3808p pd=2.92u as=0.2128p ps=1.5u w=1.12u l=0.6u
X703 a_27433_16869# a_27237_16869# VSS.t586 VSS.t2326 sg13_lv_nmos ad=0.2516p pd=2.16u as=0.1406p ps=1.12u w=0.74u l=0.13u
X704 a_10430_16071# a_2019_16074.t7 a_10328_16071# VSS.t1705 sg13_lv_nmos ad=0.2516p pd=2.16u as=0.1406p ps=1.12u w=0.74u l=0.13u
X705 a_11711_4687# a_11473_4687# a_11603_4687# VSS.t680 sg13_lv_nmos ad=0.1406p pd=1.12u as=0.2516p ps=2.16u w=0.74u l=0.2u
X706 VDD.t1196 a_2019_6737.t4 a_19524_6698# VDD.t67 sg13_lv_pmos ad=0.3808p pd=2.92u as=0.3808p ps=2.92u w=1.12u l=0.13u
X707 a_23633_1842# a_23437_1842# VDD.t1354 VDD.t373 sg13_lv_pmos ad=0.3808p pd=2.92u as=0.2128p ps=1.5u w=1.12u l=0.13u
X708 VDD.t1103 a_2019_3892.t9 a_4324_3853# VDD.t0 sg13_lv_pmos ad=0.3808p pd=2.92u as=0.3808p ps=2.92u w=1.12u l=0.13u
X709 VSS.t2127 a_15964_15316# a_16851_15336# VSS.t2129 sg13_lv_nmos ad=0.1371p pd=1.12u as=0.2176p ps=1.96u w=0.64u l=0.13u
X710 a_2595_13229.t0 a_2297_13577# VDD.t959 VDD.t5 sg13_lv_pmos ad=0.2128p pd=1.5u as=0.1918p ps=1.5u w=1.12u l=0.13u
X711 a_27048_1044# a_26477_1842# VSS.t730 VSS.t2189 sg13_lv_nmos ad=0.1406p pd=1.12u as=0.2516p ps=2.16u w=0.74u l=0.13u
X712 VSS.t1338 a_4763_1842# a_5197_1842# VSS.t1469 sg13_lv_nmos ad=0.1406p pd=1.12u as=0.2516p ps=2.16u w=0.74u l=0.13u
X713 a_16510_3889# a_18871_3853# a_18795_3889# VDD.t0 sg13_lv_pmos ad=0.3808p pd=2.92u as=0.2128p ps=1.5u w=1.12u l=0.13u
X714 VSS.t2093 a_1721_3176# a_2019_3156.t1 VSS.t1787 sg13_lv_nmos ad=0.2812p pd=2.24u as=0.1406p ps=1.12u w=0.74u l=0.13u
X715 a_15511_14024# a_15273_14024# a_15403_14024# VSS.t1471 sg13_lv_nmos ad=0.1406p pd=1.12u as=0.2516p ps=2.16u w=0.74u l=0.2u
X716 VDD.t975 a_9323_1842# a_9757_1842# VDD.t373 sg13_lv_pmos ad=0.2128p pd=1.5u as=0.3808p ps=2.92u w=1.12u l=0.13u
X717 a_3543_6021# REF_MUX_SEL2 a_3449_6021# VSS.t2285 sg13_lv_nmos ad=0.1216p pd=1.02u as=0.2176p ps=1.96u w=0.64u l=0.13u
X718 a_2019_16074.t0 a_1721_16422# VDD.t1254 VDD.t90 sg13_lv_pmos ad=0.2128p pd=1.5u as=0.1918p ps=1.5u w=1.12u l=0.13u
X719 VSS.t333 a_2595_6001.t2 a_20905_6209# VSS.t1489 sg13_lv_nmos ad=0.2516p pd=2.16u as=0.2516p ps=2.16u w=0.74u l=0.13u
X720 a_19550_16071# a_2595_16074.t4 a_20315_16071# VSS.t2368 sg13_lv_nmos ad=0.2516p pd=2.16u as=0.1406p ps=1.12u w=0.74u l=0.13u
X721 VDD.t1323 a_7043_14024# a_7477_14024# VDD.t374 sg13_lv_pmos ad=0.2128p pd=1.5u as=0.3808p ps=2.92u w=1.12u l=0.13u
X722 a_13470_13226# a_13444_13190# a_13368_13226# VDD.t5 sg13_lv_pmos ad=0.3808p pd=2.92u as=0.2128p ps=1.5u w=1.12u l=0.13u
X723 a_5768_1044# a_5197_1842# VSS.t733 VSS.t1894 sg13_lv_nmos ad=0.1406p pd=1.12u as=0.2516p ps=2.16u w=0.74u l=0.13u
X724 VSS.t1801 a_5957_16869# a_6425_16071# VSS.t1800 sg13_lv_nmos ad=0.1665p pd=1.19u as=0.2516p ps=2.16u w=0.74u l=0.13u
X725 VSS.t843 a_4187_1764.t115 a_16271_14024# VSS.t1042 sg13_lv_nmos ad=0.2516p pd=2.16u as=0.1406p ps=1.12u w=0.74u l=0.6u
X726 a_15755_6734# a_15545_6734# VDD.t837 VDD.t67 sg13_lv_pmos ad=0.2128p pd=1.5u as=0.252p ps=1.57u w=1.12u l=0.13u
X727 VDD.t1598 a_2297_15358# a_2595_15338.t0 VDD.t90 sg13_lv_pmos ad=0.4256p pd=3u as=0.2128p ps=1.5u w=1.12u l=0.13u
X728 VSS.t2097 a_2297_15358# a_2595_15338.t1 VSS.t2344 sg13_lv_nmos ad=0.2812p pd=2.24u as=0.1406p ps=1.12u w=0.74u l=0.13u
X729 VDD.t1066 a_2595_6737.t6 a_14311_6698# VDD.t67 sg13_lv_pmos ad=0.3808p pd=2.92u as=0.3808p ps=2.92u w=1.12u l=0.13u
X730 a_7390_1044# a_7364_1008# a_7288_1044# VDD.t2 sg13_lv_pmos ad=0.3808p pd=2.92u as=0.2128p ps=1.5u w=1.12u l=0.13u
X731 VDD.t1079 a_16597_16869# a_17065_16071# VDD.t90 sg13_lv_pmos ad=0.252p pd=1.57u as=0.3808p ps=2.92u w=1.12u l=0.13u
X732 a_15273_7532# a_15077_7532# VSS.t1023 VSS.t1022 sg13_lv_nmos ad=0.2516p pd=2.16u as=0.1406p ps=1.12u w=0.74u l=0.13u
X733 VSS.t994 a_4187_1764.t28 a_7911_1842# VSS.t993 sg13_lv_nmos ad=0.2516p pd=2.16u as=0.1406p ps=1.12u w=0.74u l=0.6u
X734 a_14888_16071# a_14317_16869# VDD.t1033 VDD.t90 sg13_lv_pmos ad=0.2128p pd=1.5u as=0.3808p ps=2.92u w=1.12u l=0.13u
X735 a_13306_11995# a_12355_11557# VDD.t384 VDD.t355 sg13_lv_pmos ad=79.8f pd=0.8u as=0.1428p ps=1.52u w=0.42u l=0.13u
X736 a_6391_7532# a_6153_7532# a_6283_7532# VSS.t2310 sg13_lv_nmos ad=0.1406p pd=1.12u as=0.2516p ps=2.16u w=0.74u l=0.2u
X737 a_5115_6734# a_4905_6734# VDD.t359 VDD.t67 sg13_lv_pmos ad=0.2128p pd=1.5u as=0.252p ps=1.57u w=1.12u l=0.13u
X738 a_13991_16869# a_13753_16869# a_13883_16869# VSS.t1456 sg13_lv_nmos ad=0.1406p pd=1.12u as=0.2516p ps=2.16u w=0.74u l=0.2u
X739 VSS.t507 VSS.t507 VSS.t506 VSS.t508 sg13_lv_nmos ad=0.1406p pd=1.12u as=0 ps=0 w=0.74u l=0.2u
X740 a_19833_7532# a_19637_7532# VDD.t1130 VDD.t346 sg13_lv_pmos ad=0.3808p pd=2.92u as=0.2128p ps=1.5u w=1.12u l=0.13u
X741 a_18313_16869# a_18117_16869# VSS.t1293 VSS.t1292 sg13_lv_nmos ad=0.2516p pd=2.16u as=0.1406p ps=1.12u w=0.74u l=0.13u
X742 VSS.t165 a_10083_4687# a_10517_4687# VSS.t2231 sg13_lv_nmos ad=0.1406p pd=1.12u as=0.2516p ps=2.16u w=0.74u l=0.13u
X743 a_10328_16071# a_9757_16869# VDD.t1031 VDD.t90 sg13_lv_pmos ad=0.2128p pd=1.5u as=0.3808p ps=2.92u w=1.12u l=0.13u
X744 a_5631_17497# a_5393_16869# a_5523_16869# VDD.t368 sg13_lv_pmos ad=0.2128p pd=1.5u as=0.3808p ps=2.92u w=1.12u l=0.2u
X745 VSS.t576 a_4187_1764.t149 a_14751_16869# VSS.t2264 sg13_lv_nmos ad=0.2516p pd=2.16u as=0.1406p ps=1.12u w=0.74u l=0.6u
X746 a_19833_16869# a_19637_16869# VDD.t1459 VDD.t368 sg13_lv_pmos ad=0.3808p pd=2.92u as=0.2128p ps=1.5u w=1.12u l=0.13u
X747 VSS.t1412 a_18443_14024# a_18877_14024# VSS.t1411 sg13_lv_nmos ad=0.1406p pd=1.12u as=0.2516p ps=2.16u w=0.74u l=0.13u
X748 a_24631_8160# a_24393_7532# a_24523_7532# VDD.t346 sg13_lv_pmos ad=0.2128p pd=1.5u as=0.3808p ps=2.92u w=1.12u l=0.2u
X749 VDD.t635 a_4187_2434# a_6391_17497# VDD.t368 sg13_lv_pmos ad=0.3808p pd=2.92u as=0.2128p ps=1.5u w=1.12u l=0.6u
X750 VDD.t371 a_23763_16869# a_24197_16869# VDD.t368 sg13_lv_pmos ad=0.2128p pd=1.5u as=0.3808p ps=2.92u w=1.12u l=0.13u
X751 a_9193_7532# a_8997_7532# VDD.t948 VDD.t346 sg13_lv_pmos ad=0.3808p pd=2.92u as=0.2128p ps=1.5u w=1.12u l=0.13u
X752 a_27671_5315# a_27433_4687# a_27563_4687# VDD.t348 sg13_lv_pmos ad=0.2128p pd=1.5u as=0.3808p ps=2.92u w=1.12u l=0.2u
X753 a_13470_16071# a_15831_16035# a_15755_16071# VDD.t90 sg13_lv_pmos ad=0.3808p pd=2.92u as=0.2128p ps=1.5u w=1.12u l=0.13u
X754 VSS.t225 VDD.t1691 VSS.t224 VSS.t223 sg13_lv_nmos ad=0.1428p pd=1.52u as=0 ps=0 w=0.42u l=1u
X755 VDD.t27 VSS.t274 VDD.t26 VDD.t5 sg13_lv_pmos ad=0.34p pd=2.68u as=0 ps=0 w=1u l=1u
X756 VSS.t1034 a_15403_7532# a_15837_7532# VSS.t1230 sg13_lv_nmos ad=0.1406p pd=1.12u as=0.2516p ps=2.16u w=0.74u l=0.13u
X757 a_8155_6734# a_7945_6734# VSS.t802 VSS.t801 sg13_lv_nmos ad=0.1406p pd=1.12u as=0.1665p ps=1.19u w=0.74u l=0.13u
X758 VDD.t231 VSS.t430 VDD.t229 VDD.t2 sg13_lv_pmos ad=0.19p pd=1.38u as=0 ps=0 w=1u l=1u
X759 VSS.t769 a_21157_4687# a_21625_3889# VSS.t768 sg13_lv_nmos ad=0.1665p pd=1.19u as=0.2516p ps=2.16u w=0.74u l=0.13u
X760 VSS.t312 VDD.t1666 VSS.t312 VSS.t314 sg13_lv_nmos ad=0.1428p pd=1.52u as=0 ps=0 w=0.42u l=1u
X761 VSS.t1173 a_24197_1842# a_24665_1044# VSS.t1437 sg13_lv_nmos ad=0.1665p pd=1.19u as=0.2516p ps=2.16u w=0.74u l=0.13u
X762 VSS.t157 a_4187_1764.t98 VSS.t804 VSS.t803 sg13_lv_nmos ad=2.38p pd=14.68u as=0 ps=0 w=7u l=7u
X763 a_11711_1842# a_11473_1842# a_11603_1842# VSS.t1519 sg13_lv_nmos ad=0.1406p pd=1.12u as=0.2516p ps=2.16u w=0.74u l=0.2u
X764 a_23633_7532# a_23437_7532# VDD.t842 VDD.t346 sg13_lv_pmos ad=0.3808p pd=2.92u as=0.2128p ps=1.5u w=1.12u l=0.13u
X765 a_16510_1044# a_3171_1047.t5 a_17928_1044# VSS.t1686 sg13_lv_nmos ad=0.2516p pd=2.16u as=0.1406p ps=1.12u w=0.74u l=0.13u
X766 VSS.t25 a_4763_7532# a_5197_7532# VSS.t24 sg13_lv_nmos ad=0.1406p pd=1.12u as=0.2516p ps=2.16u w=0.74u l=0.13u
X767 a_27048_6734# a_26477_7532# VSS.t1124 VSS.t2276 sg13_lv_nmos ad=0.1406p pd=1.12u as=0.2516p ps=2.16u w=0.74u l=0.13u
X768 VSS.t415 VDD.t1630 VSS.t417 VSS.t416 sg13_lv_nmos ad=79.8f pd=0.8u as=0 ps=0 w=0.42u l=1u
X769 VSS.t42 a_4187_1764.t38 a_24631_4687# VSS.t2225 sg13_lv_nmos ad=0.2516p pd=2.16u as=0.1406p ps=1.12u w=0.74u l=0.6u
X770 VSS.t188 VDD.t1706 VSS.t188 VSS.t189 sg13_lv_nmos ad=79.8f pd=0.8u as=0 ps=0 w=0.42u l=1u
X771 VSS.t372 VDD.t1642 VSS.t372 VSS.t375 sg13_lv_nmos ad=79.8f pd=0.8u as=0 ps=0 w=0.42u l=1u
X772 VDD.t402 a_9323_7532# a_9757_7532# VDD.t346 sg13_lv_pmos ad=0.2128p pd=1.5u as=0.3808p ps=2.92u w=1.12u l=0.13u
X773 VSS.t2097 a_1544_15316# a_2391_15358# VSS.t1255 sg13_lv_nmos ad=0.1331p pd=1.12u as=0.1216p ps=1.02u w=0.64u l=0.13u
X774 VDD.t735 a_4187_2434# a_16271_5315# VDD.t348 sg13_lv_pmos ad=0.3808p pd=2.92u as=0.2128p ps=1.5u w=1.12u l=0.6u
X775 a_5768_6734# a_5197_7532# VSS.t45 VSS.t44 sg13_lv_nmos ad=0.1406p pd=1.12u as=0.2516p ps=2.16u w=0.74u l=0.13u
X776 a_14513_1842# a_14317_1842# VDD.t1058 VDD.t373 sg13_lv_pmos ad=0.3808p pd=2.92u as=0.2128p ps=1.5u w=1.12u l=0.13u
X777 VDD.t788 a_4003_16869# a_4437_16869# VDD.t368 sg13_lv_pmos ad=0.2128p pd=1.5u as=0.3808p ps=2.92u w=1.12u l=0.13u
X778 a_6854_11676# a_6326_10280# VDD.t997 VDD.t355 sg13_lv_pmos ad=0.38p pd=2.38u as=0.38p ps=2.38u w=2u l=1u
X779 a_5631_2470# a_5393_1842# a_5523_1842# VDD.t373 sg13_lv_pmos ad=0.2128p pd=1.5u as=0.3808p ps=2.92u w=1.12u l=0.2u
X780 a_3171_13229.t0 a_2873_13577# VDD.t864 VDD.t5 sg13_lv_pmos ad=0.2128p pd=1.5u as=0.1918p ps=1.5u w=1.12u l=0.13u
X781 VDD.t152 VSS.t301 VDD.t150 VDD.t5 sg13_lv_pmos ad=0.19p pd=1.38u as=0 ps=0 w=1u l=1u
X782 VDD.t982 a_1721_7085# a_2019_6737.t0 VDD.t67 sg13_lv_pmos ad=0.4256p pd=3u as=0.2128p ps=1.5u w=1.12u l=0.13u
X783 VSS.t1508 a_2019_3892.t9 a_4324_3853# VSS.t1507 sg13_lv_nmos ad=0.2516p pd=2.16u as=0.2516p ps=2.16u w=0.74u l=0.13u
X784 a_19311_16869# a_19073_16869# a_19203_16869# VSS.t1196 sg13_lv_nmos ad=0.1406p pd=1.12u as=0.2516p ps=2.16u w=0.74u l=0.2u
X785 VDD.t1248 a_26043_4687# a_26477_4687# VDD.t348 sg13_lv_pmos ad=0.2128p pd=1.5u as=0.3808p ps=2.92u w=1.12u l=0.13u
X786 a_11473_14024# a_11277_14024# VSS.t1872 VSS.t1962 sg13_lv_nmos ad=0.2516p pd=2.16u as=0.1406p ps=1.12u w=0.74u l=0.13u
X787 VSS.t820 a_4187_1764.t98 VSS.t819 VSS.t803 sg13_lv_nmos ad=2.38p pd=14.68u as=0 ps=0 w=7u l=7u
X788 VSS.t1147 a_4187_1764.t92 a_7911_7532# VSS.t2137 sg13_lv_nmos ad=0.2516p pd=2.16u as=0.1406p ps=1.12u w=0.74u l=0.6u
X789 a_16510_3889# a_3747_3892.t5 a_18795_3889# VSS.t1627 sg13_lv_nmos ad=0.2516p pd=2.16u as=0.1406p ps=1.12u w=0.74u l=0.13u
X790 a_10430_3889# a_10404_3853# a_10328_3889# VDD.t0 sg13_lv_pmos ad=0.3808p pd=2.92u as=0.2128p ps=1.5u w=1.12u l=0.13u
X791 VSS.t333 VDD.t1658 VSS.t333 VSS.t334 sg13_lv_nmos ad=79.8f pd=0.8u as=0 ps=0 w=0.42u l=1u
X792 VSS.t602 a_3171_1047.t4 a_21044_1008# VSS.t1693 sg13_lv_nmos ad=0.2516p pd=2.16u as=0.2516p ps=2.16u w=0.74u l=0.13u
X793 VSS.t887 a_10083_1842# a_10517_1842# VSS.t886 sg13_lv_nmos ad=0.1406p pd=1.12u as=0.2516p ps=2.16u w=0.74u l=0.13u
X794 a_3747_3156.t0 a_3449_3176# VDD.t804 VDD.t0 sg13_lv_pmos ad=0.2128p pd=1.5u as=0.1918p ps=1.5u w=1.12u l=0.13u
X795 a_17928_13226# a_17357_14024# VDD.t1345 VDD.t5 sg13_lv_pmos ad=0.2128p pd=1.5u as=0.3808p ps=2.92u w=1.12u l=0.13u
X796 VDD.t345 a_21157_7532# a_21625_6734# VDD.t67 sg13_lv_pmos ad=0.252p pd=1.57u as=0.3808p ps=2.92u w=1.12u l=0.13u
X797 a_4633_1842# a_4437_1842# VDD.t1296 VDD.t373 sg13_lv_pmos ad=0.3808p pd=2.92u as=0.2128p ps=1.5u w=1.12u l=0.13u
X798 VDD.t1369 a_2019_1047.t4 a_19524_1008# VDD.t2 sg13_lv_pmos ad=0.3808p pd=2.92u as=0.3808p ps=2.92u w=1.12u l=0.13u
X799 a_5631_14652# a_5393_14024# a_5523_14024# VDD.t374 sg13_lv_pmos ad=0.2128p pd=1.5u as=0.3808p ps=2.92u w=1.12u l=0.2u
X800 VSS.t5 a_3747_12493.t2 a_26985_12701# VSS.t4 sg13_lv_nmos ad=0.2516p pd=2.16u as=0.2516p ps=2.16u w=0.74u l=0.13u
X801 a_6854_11676# a_15304_10295# a_4187_1764.t0 VDD.t456 sg13_lv_pmos ad=0.136p pd=1.14u as=0.158p ps=1.245u w=0.4u l=0.2u
X802 a_19833_14024# a_19637_14024# VDD.t861 VDD.t374 sg13_lv_pmos ad=0.3808p pd=2.92u as=0.2128p ps=1.5u w=1.12u l=0.13u
X803 VDD.t617 a_4187_2434# a_20071_5315# VDD.t348 sg13_lv_pmos ad=0.3808p pd=2.92u as=0.2128p ps=1.5u w=1.12u l=0.6u
X804 VSS.t1859 a_2873_331# a_3171_311.t1 VSS.t1860 sg13_lv_nmos ad=0.2812p pd=2.24u as=0.1406p ps=1.12u w=0.74u l=0.13u
X805 VDD.t668 a_4187_2434# a_6391_14652# VDD.t374 sg13_lv_pmos ad=0.3808p pd=2.92u as=0.2128p ps=1.5u w=1.12u l=0.6u
X806 a_3747_16074.t1 a_3449_16422# VSS.t30 VSS.t2052 sg13_lv_nmos ad=0.1406p pd=1.12u as=0.1331p ps=1.12u w=0.74u l=0.13u
X807 VDD.t976 a_23763_14024# a_24197_14024# VDD.t374 sg13_lv_pmos ad=0.2128p pd=1.5u as=0.3808p ps=2.92u w=1.12u l=0.13u
X808 a_7390_3889# a_8884_3853# a_8808_3889# VDD.t0 sg13_lv_pmos ad=0.3808p pd=2.92u as=0.2128p ps=1.5u w=1.12u l=0.13u
X809 a_13306_10795# a_13132_11110# VDD.t846 VDD.t355 sg13_lv_pmos ad=79.8f pd=0.8u as=0.1428p ps=1.52u w=0.42u l=0.13u
X810 a_16108_3134# a_3171_3156.t2 a_22590_3889# VSS.t786 sg13_lv_nmos ad=0.2516p pd=2.16u as=0.2516p ps=2.16u w=0.74u l=0.13u
X811 VDD.t166 VSS.t312 VDD.t165 VDD.t67 sg13_lv_pmos ad=0.34p pd=2.68u as=0 ps=0 w=1u l=1u
X812 VSS.t1067 a_19637_14024# a_20105_13226# VSS.t1066 sg13_lv_nmos ad=0.1665p pd=1.19u as=0.2516p ps=2.16u w=0.74u l=0.13u
X813 VSS.t1079 a_3449_331# a_3747_311.t1 VSS.t1080 sg13_lv_nmos ad=0.2812p pd=2.24u as=0.1406p ps=1.12u w=0.74u l=0.13u
X814 VSS.t544 VSS.t544 VSS.t546 VSS.t545 sg13_lv_nmos ad=0.2516p pd=2.16u as=0 ps=0 w=0.74u l=0.13u
X815 a_10430_16071# a_3171_16074.t7 a_11848_16071# VSS.t662 sg13_lv_nmos ad=0.2516p pd=2.16u as=0.1406p ps=1.12u w=0.74u l=0.13u
X816 a_15755_1044# a_15545_1044# VDD.t933 VDD.t2 sg13_lv_pmos ad=0.2128p pd=1.5u as=0.252p ps=1.57u w=1.12u l=0.13u
X817 a_26911_4687# a_26673_4687# a_26803_4687# VSS.t1498 sg13_lv_nmos ad=0.1406p pd=1.12u as=0.2516p ps=2.16u w=0.74u l=0.2u
X818 VSS.t620 a_24197_7532# a_24665_6734# VSS.t1024 sg13_lv_nmos ad=0.1665p pd=1.19u as=0.2516p ps=2.16u w=0.74u l=0.13u
X819 VSS.t1652 a_3171_13229.t5 a_18004_13190# VSS.t1651 sg13_lv_nmos ad=0.2516p pd=2.16u as=0.2516p ps=2.16u w=0.74u l=0.13u
X820 VDD.t984 a_6326_10280# a_6854_11144# VDD.t355 sg13_lv_pmos ad=0.38p pd=2.38u as=0.38p ps=2.38u w=2u l=1u
X821 a_11711_7532# a_11473_7532# a_11603_7532# VSS.t2346 sg13_lv_nmos ad=0.1406p pd=1.12u as=0.2516p ps=2.16u w=0.74u l=0.2u
X822 a_16510_6734# a_3171_6737.t5 a_17928_6734# VSS.t2118 sg13_lv_nmos ad=0.2516p pd=2.16u as=0.1406p ps=1.12u w=0.74u l=0.13u
X823 VDD.t578 a_2595_1047.t6 a_14311_1008# VDD.t2 sg13_lv_pmos ad=0.3808p pd=2.92u as=0.3808p ps=2.92u w=1.12u l=0.13u
X824 VDD.t334 VSS.t188 VDD.t333 VDD.t90 sg13_lv_pmos ad=0.34p pd=2.68u as=0 ps=0 w=1u l=1u
X825 VDD.t1194 a_2019_6737.t9 a_4324_6698# VDD.t67 sg13_lv_pmos ad=0.3808p pd=2.92u as=0.3808p ps=2.92u w=1.12u l=0.13u
X826 a_17031_14024# a_16793_14024# a_16923_14024# VSS.t1973 sg13_lv_nmos ad=0.1406p pd=1.12u as=0.2516p ps=2.16u w=0.74u l=0.2u
X827 a_5974_11413# a_6126_9506# VSS.t51 VSS.t49 sg13_lv_nmos ad=0.38p pd=2.38u as=0.68p ps=4.68u w=2u l=1u
X828 VSS.t793 a_4187_1764.t6 a_24631_1842# VSS.t792 sg13_lv_nmos ad=0.2516p pd=2.16u as=0.1406p ps=1.12u w=0.74u l=0.6u
X829 a_16510_6734# a_18871_6698# a_18795_6734# VDD.t67 sg13_lv_pmos ad=0.3808p pd=2.92u as=0.2128p ps=1.5u w=1.12u l=0.13u
X830 a_5115_1044# a_4905_1044# VDD.t1144 VDD.t2 sg13_lv_pmos ad=0.2128p pd=1.5u as=0.252p ps=1.57u w=1.12u l=0.13u
X831 VSS.t1142 a_1721_6021# a_2019_6001.t1 VSS.t1462 sg13_lv_nmos ad=0.2812p pd=2.24u as=0.1406p ps=1.12u w=0.74u l=0.13u
X832 a_13470_13226# a_14964_13190# a_14888_13226# VDD.t5 sg13_lv_pmos ad=0.3808p pd=2.92u as=0.2128p ps=1.5u w=1.12u l=0.13u
X833 a_12471_14024# a_12233_14024# a_12363_14024# VSS.t1247 sg13_lv_nmos ad=0.1406p pd=1.12u as=0.2516p ps=2.16u w=0.74u l=0.2u
X834 VSS.t847 a_4187_1764.t113 a_17791_14024# VSS.t995 sg13_lv_nmos ad=0.2516p pd=2.16u as=0.1406p ps=1.12u w=0.74u l=0.6u
X835 VSS.t149 a_1544_12471# a_2391_12513# VSS.t148 sg13_lv_nmos ad=0.1331p pd=1.12u as=0.1216p ps=1.02u w=0.64u l=0.13u
X836 VSS.t1932 a_4437_14024# a_4905_13226# VSS.t1931 sg13_lv_nmos ad=0.1665p pd=1.19u as=0.2516p ps=2.16u w=0.74u l=0.13u
X837 a_14513_7532# a_14317_7532# VDD.t367 VDD.t346 sg13_lv_pmos ad=0.3808p pd=2.92u as=0.2128p ps=1.5u w=1.12u l=0.13u
X838 VDD.t655 a_4187_2434# a_23111_17497# VDD.t368 sg13_lv_pmos ad=0.3808p pd=2.92u as=0.2128p ps=1.5u w=1.12u l=0.6u
X839 VDD.t980 a_4003_14024# a_4437_14024# VDD.t374 sg13_lv_pmos ad=0.2128p pd=1.5u as=0.3808p ps=2.92u w=1.12u l=0.13u
X840 a_10430_13226# a_10404_13190# a_10328_13226# VDD.t5 sg13_lv_pmos ad=0.3808p pd=2.92u as=0.2128p ps=1.5u w=1.12u l=0.13u
X841 VSS.t14 a_2019_12493.t2 a_17865_12701# VSS.t13 sg13_lv_nmos ad=0.2516p pd=2.16u as=0.2516p ps=2.16u w=0.74u l=0.13u
X842 a_5631_8160# a_5393_7532# a_5523_7532# VDD.t346 sg13_lv_pmos ad=0.2128p pd=1.5u as=0.3808p ps=2.92u w=1.12u l=0.2u
X843 VSS.t2114 a_15964_3134# a_16851_3154# VSS.t2122 sg13_lv_nmos ad=0.1371p pd=1.12u as=0.2176p ps=1.96u w=0.64u l=0.13u
X844 VDD.t1013 a_15077_4687# a_15545_3889# VDD.t0 sg13_lv_pmos ad=0.252p pd=1.57u as=0.3808p ps=2.92u w=1.12u l=0.13u
X845 VSS.t653 a_4187_1764.t50 a_15511_4687# VSS.t1407 sg13_lv_nmos ad=0.2516p pd=2.16u as=0.1406p ps=1.12u w=0.74u l=0.6u
X846 a_17553_4687# a_17357_4687# VDD.t940 VDD.t348 sg13_lv_pmos ad=0.3808p pd=2.92u as=0.2128p ps=1.5u w=1.12u l=0.13u
X847 VSS.t1869 a_4187_1764.t119 a_13231_14024# VSS.t1868 sg13_lv_nmos ad=0.2516p pd=2.16u as=0.1406p ps=1.12u w=0.74u l=0.6u
X848 a_8671_5315# a_8433_4687# a_8563_4687# VDD.t348 sg13_lv_pmos ad=0.2128p pd=1.5u as=0.3808p ps=2.92u w=1.12u l=0.2u
X849 VDD.t974 a_18117_16869# a_18585_16071# VDD.t90 sg13_lv_pmos ad=0.252p pd=1.57u as=0.3808p ps=2.92u w=1.12u l=0.13u
X850 a_13566_11525# a_14009_11568# a_13306_11995# VSS.t185 sg13_lv_nmos ad=79.8f pd=0.8u as=0.1296p ps=1.52u w=0.42u l=0.13u
X851 VDD.t280 VSS.t333 VDD.t278 VDD.t67 sg13_lv_pmos ad=0.19p pd=1.38u as=0 ps=0 w=1u l=1u
X852 VSS.t2088 a_1256_15316# a_2967_15358# VSS.t1911 sg13_lv_nmos ad=0.1331p pd=1.12u as=0.1216p ps=1.02u w=0.64u l=0.13u
X853 a_18551_2470# a_18313_1842# a_18443_1842# VDD.t373 sg13_lv_pmos ad=0.2128p pd=1.5u as=0.3808p ps=2.92u w=1.12u l=0.2u
X854 VSS.t500 VSS.t500 VSS.t502 VSS.t501 sg13_lv_nmos ad=0.1406p pd=1.12u as=0 ps=0 w=0.74u l=0.13u
X855 VSS.t1450 a_25283_4687# a_25717_4687# VSS.t1449 sg13_lv_nmos ad=0.1406p pd=1.12u as=0.2516p ps=2.16u w=0.74u l=0.13u
X856 VDD.t926 a_3171_16074.t2 a_27124_16035# VDD.t90 sg13_lv_pmos ad=0.3808p pd=2.92u as=0.3808p ps=2.92u w=1.12u l=0.13u
X857 a_11848_16071# a_11277_16869# VDD.t1077 VDD.t90 sg13_lv_pmos ad=0.2128p pd=1.5u as=0.3808p ps=2.92u w=1.12u l=0.13u
X858 VDD.t7 VSS.t235 VDD.t6 VDD.t5 sg13_lv_pmos ad=0.34p pd=2.68u as=0 ps=0 w=1u l=1u
X859 VSS.t690 a_3171_6737.t4 a_21044_6698# VSS.t1879 sg13_lv_nmos ad=0.2516p pd=2.16u as=0.2516p ps=2.16u w=0.74u l=0.13u
X860 a_10951_16869# a_10713_16869# a_10843_16869# VSS.t1455 sg13_lv_nmos ad=0.1406p pd=1.12u as=0.2516p ps=2.16u w=0.74u l=0.2u
X861 a_19550_13226# a_20391_13190# a_20315_13226# VDD.t5 sg13_lv_pmos ad=0.3808p pd=2.92u as=0.2128p ps=1.5u w=1.12u l=0.13u
X862 VSS.t614 a_10083_7532# a_10517_7532# VSS.t1327 sg13_lv_nmos ad=0.1406p pd=1.12u as=0.2516p ps=2.16u w=0.74u l=0.13u
X863 VDD.t19 VSS.t449 VDD.t18 VDD.t2 sg13_lv_pmos ad=0.19p pd=1.38u as=0 ps=0 w=1u l=1u
X864 a_15273_16869# a_15077_16869# VSS.t576 VSS.t575 sg13_lv_nmos ad=0.2516p pd=2.16u as=0.1406p ps=1.12u w=0.74u l=0.13u
X865 a_13592_11561# a_13566_11525# VDD.t403 VDD.t355 sg13_lv_pmos ad=0.34p pd=2.68u as=0.36237p ps=2.605u w=1u l=0.13u
X866 a_4633_7532# a_4437_7532# VDD.t547 VDD.t346 sg13_lv_pmos ad=0.3808p pd=2.92u as=0.2128p ps=1.5u w=1.12u l=0.13u
X867 VDD.t1395 a_5957_14024# a_6425_13226# VDD.t5 sg13_lv_pmos ad=0.252p pd=1.57u as=0.3808p ps=2.92u w=1.12u l=0.13u
X868 VSS.t919 a_4187_1764.t63 a_5631_4687# VSS.t1218 sg13_lv_nmos ad=0.2516p pd=2.16u as=0.1406p ps=1.12u w=0.74u l=0.6u
X869 VDD.t638 a_4187_2434# a_7911_17497# VDD.t368 sg13_lv_pmos ad=0.3808p pd=2.92u as=0.2128p ps=1.5u w=1.12u l=0.6u
X870 VDD.t1581 a_25283_16869# a_25717_16869# VDD.t368 sg13_lv_pmos ad=0.2128p pd=1.5u as=0.3808p ps=2.92u w=1.12u l=0.13u
X871 a_3171_1047.t1 a_2873_1395# VSS.t147 VSS.t1839 sg13_lv_nmos ad=0.1406p pd=1.12u as=0.1331p ps=1.12u w=0.74u l=0.13u
X872 VSS.t885 a_15403_14024# a_15837_14024# VSS.t1397 sg13_lv_nmos ad=0.1406p pd=1.12u as=0.2516p ps=2.16u w=0.74u l=0.13u
X873 VSS.t1010 a_2595_13229.t8 a_8231_13190# VSS.t1009 sg13_lv_nmos ad=0.2516p pd=2.16u as=0.2516p ps=2.16u w=0.74u l=0.13u
X874 VSS.t907 a_2297_1395# a_2595_1047.t1 VSS.t1775 sg13_lv_nmos ad=0.2812p pd=2.24u as=0.1406p ps=1.12u w=0.74u l=0.13u
X875 VDD.t116 VSS.t358 VDD.t115 VDD.t0 sg13_lv_pmos ad=0.34p pd=2.68u as=0 ps=0 w=1u l=1u
X876 a_10430_3889# a_2019_3892.t7 a_10328_3889# VSS.t1514 sg13_lv_nmos ad=0.2516p pd=2.16u as=0.1406p ps=1.12u w=0.74u l=0.13u
X877 a_21353_4687# a_21157_4687# VDD.t594 VDD.t348 sg13_lv_pmos ad=0.3808p pd=2.92u as=0.2128p ps=1.5u w=1.12u l=0.13u
X878 VDD.t924 a_20723_16869# a_21157_16869# VDD.t368 sg13_lv_pmos ad=0.2128p pd=1.5u as=0.3808p ps=2.92u w=1.12u l=0.13u
X879 VSS.t347 VDD.t1654 VSS.t346 VSS.t345 sg13_lv_nmos ad=0.1428p pd=1.52u as=0 ps=0 w=0.42u l=1u
X880 VSS.t559 VSS.t557 VSS.t557 VSS.t558 sg13_lv_nmos ad=0.2516p pd=2.16u as=0 ps=0 w=0.74u l=0.13u
X881 a_1815_3176# a_1256_3134# a_1721_3176# VSS.t145 sg13_lv_nmos ad=0.1216p pd=1.02u as=0.2176p ps=1.96u w=0.64u l=0.13u
X882 a_26911_1842# a_26673_1842# a_26803_1842# VSS.t1253 sg13_lv_nmos ad=0.1406p pd=1.12u as=0.2516p ps=2.16u w=0.74u l=0.2u
X883 VSS.t423 a_3171_311.t3 a_11785_519# VSS.t2195 sg13_lv_nmos ad=0.2516p pd=2.16u as=0.2516p ps=2.16u w=0.74u l=0.13u
X884 VDD.t1496 a_7043_4687# a_7477_4687# VDD.t348 sg13_lv_pmos ad=0.2128p pd=1.5u as=0.3808p ps=2.92u w=1.12u l=0.13u
X885 VDD.t1235 a_1721_1395# a_2019_1047.t0 VDD.t2 sg13_lv_pmos ad=0.4256p pd=3u as=0.2128p ps=1.5u w=1.12u l=0.13u
X886 a_22351_2470# a_22113_1842# a_22243_1842# VDD.t373 sg13_lv_pmos ad=0.2128p pd=1.5u as=0.3808p ps=2.92u w=1.12u l=0.2u
X887 VDD.t1201 a_3171_3892.t7 a_11924_3853# VDD.t0 sg13_lv_pmos ad=0.3808p pd=2.92u as=0.3808p ps=2.92u w=1.12u l=0.13u
X888 a_2391_1395# CHAN3_MUX_SEL0 a_2297_1395# VSS.t617 sg13_lv_nmos ad=0.1216p pd=1.02u as=0.2176p ps=1.96u w=0.64u l=0.13u
X889 VDD.t518 a_16923_1842# a_17357_1842# VDD.t373 sg13_lv_pmos ad=0.2128p pd=1.5u as=0.3808p ps=2.92u w=1.12u l=0.13u
X890 VSS.t118 a_4187_1764.t70 a_24631_7532# VSS.t117 sg13_lv_nmos ad=0.2516p pd=2.16u as=0.1406p ps=1.12u w=0.74u l=0.6u
X891 a_7390_3889# a_3171_3892.t8 a_8808_3889# VSS.t1730 sg13_lv_nmos ad=0.2516p pd=2.16u as=0.1406p ps=1.12u w=0.74u l=0.13u
X892 a_13368_1044# a_12797_1842# VSS.t705 VSS.t893 sg13_lv_nmos ad=0.1406p pd=1.12u as=0.2516p ps=2.16u w=0.74u l=0.13u
X893 VSS.t905 a_1544_1044# a_1815_1395# VSS.t904 sg13_lv_nmos ad=0.1331p pd=1.12u as=0.1216p ps=1.02u w=0.64u l=0.13u
X894 VSS.t86 VDD.t1652 VSS.t86 VSS.t351 sg13_lv_nmos ad=0.1428p pd=1.52u as=0 ps=0 w=0.42u l=1u
X895 VDD.t1607 a_2297_13577# a_2595_13229.t0 VDD.t5 sg13_lv_pmos ad=0.4256p pd=3u as=0.2128p ps=1.5u w=1.12u l=0.13u
X896 a_14009_10774# REF_DELAY_OUT_LAST VDD.t381 VDD.t355 sg13_lv_pmos ad=0.4088p pd=2.97u as=1.10612p ps=6.66u w=1.12u l=0.13u
X897 VDD.t600 a_21157_1842# a_21625_1044# VDD.t2 sg13_lv_pmos ad=0.252p pd=1.57u as=0.3808p ps=2.92u w=1.12u l=0.13u
X898 a_5974_11413# a_6126_9506# VSS.t53 VSS.t49 sg13_lv_nmos ad=0.38p pd=2.38u as=0.68p ps=4.68u w=2u l=1u
X899 a_5731_289# a_3171_311.t3 a_10430_1044# VSS.t2194 sg13_lv_nmos ad=0.2516p pd=2.16u as=0.2516p ps=2.16u w=0.74u l=0.13u
X900 VDD.t674 a_4187_2434# a_23111_14652# VDD.t374 sg13_lv_pmos ad=0.3808p pd=2.92u as=0.2128p ps=1.5u w=1.12u l=0.6u
X901 a_12993_14024# a_12797_14024# VSS.t929 VSS.t1903 sg13_lv_nmos ad=0.2516p pd=2.16u as=0.1406p ps=1.12u w=0.74u l=0.13u
X902 VSS.t645 a_4187_1764.t18 a_15511_1842# VSS.t1111 sg13_lv_nmos ad=0.2516p pd=2.16u as=0.1406p ps=1.12u w=0.74u l=0.6u
X903 VDD.t721 a_4187_2434# a_10951_2470# VDD.t373 sg13_lv_pmos ad=0.3808p pd=2.92u as=0.2128p ps=1.5u w=1.12u l=0.6u
X904 VDD.t199 VSS.t290 VDD.t198 VDD.t5 sg13_lv_pmos ad=0.19p pd=1.38u as=0 ps=0 w=1u l=1u
X905 a_16271_16869# a_16033_16869# a_16163_16869# VSS.t709 sg13_lv_nmos ad=0.1406p pd=1.12u as=0.2516p ps=2.16u w=0.74u l=0.2u
X906 a_25630_3889# a_25604_3853# a_25528_3889# VDD.t0 sg13_lv_pmos ad=0.3808p pd=2.92u as=0.2128p ps=1.5u w=1.12u l=0.13u
X907 VDD.t140 VSS.t379 VDD.t138 VDD.t0 sg13_lv_pmos ad=0.19p pd=1.38u as=0 ps=0 w=1u l=1u
X908 a_16793_4687# a_16597_4687# VSS.t986 VSS.t2279 sg13_lv_nmos ad=0.2516p pd=2.16u as=0.1406p ps=1.12u w=0.74u l=0.13u
X909 VSS.t1093 a_1256_12471# a_2967_12513# VSS.t1583 sg13_lv_nmos ad=0.1331p pd=1.12u as=0.1216p ps=1.02u w=0.64u l=0.13u
X910 a_18551_8160# a_18313_7532# a_18443_7532# VDD.t346 sg13_lv_pmos ad=0.2128p pd=1.5u as=0.3808p ps=2.92u w=1.12u l=0.2u
X911 a_7911_4687# a_7673_4687# a_7803_4687# VSS.t693 sg13_lv_nmos ad=0.1406p pd=1.12u as=0.2516p ps=2.16u w=0.74u l=0.2u
X912 a_10430_6734# a_10404_6698# a_10328_6734# VDD.t67 sg13_lv_pmos ad=0.3808p pd=2.92u as=0.2128p ps=1.5u w=1.12u l=0.13u
X913 VSS.t202 VDD.t1700 VSS.t202 VSS.t201 sg13_lv_nmos ad=0.1428p pd=1.52u as=0 ps=0 w=0.42u l=1u
X914 a_4350_1044# a_3747_1047.t9 a_6635_1044# VSS.t698 sg13_lv_nmos ad=0.2516p pd=2.16u as=0.1406p ps=1.12u w=0.74u l=0.13u
X915 VSS.t1442 a_25283_1842# a_25717_1842# VSS.t1532 sg13_lv_nmos ad=0.1406p pd=1.12u as=0.2516p ps=2.16u w=0.74u l=0.13u
X916 VDD.t388 REF_MUX_SEL3 a_3449_6021# VDD.t67 sg13_lv_pmos ad=0.1918p pd=1.5u as=0.1596p ps=1.22u w=0.84u l=0.13u
X917 VSS.t798 a_4187_1764.t146 a_17031_16869# VSS.t797 sg13_lv_nmos ad=0.2516p pd=2.16u as=0.1406p ps=1.12u w=0.74u l=0.6u
X918 a_27433_14024# a_27237_14024# VSS.t600 VSS.t1906 sg13_lv_nmos ad=0.2516p pd=2.16u as=0.1406p ps=1.12u w=0.74u l=0.13u
X919 VDD.t599 a_20723_1842# a_21157_1842# VDD.t373 sg13_lv_pmos ad=0.2128p pd=1.5u as=0.3808p ps=2.92u w=1.12u l=0.13u
X920 VDD.t914 a_14851_10872# a_15688_11093# VDD.t355 sg13_lv_pmos ad=0.2128p pd=1.5u as=0.3864p ps=2.93u w=1.12u l=0.13u
X921 VSS.t1340 a_15077_4687# a_15545_3889# VSS.t1339 sg13_lv_nmos ad=0.1665p pd=1.19u as=0.2516p ps=2.16u w=0.74u l=0.13u
X922 a_3747_12493.t0 a_3449_12513# VDD.t567 VDD.t5 sg13_lv_pmos ad=0.2128p pd=1.5u as=0.1918p ps=1.5u w=1.12u l=0.13u
X923 VDD.t1367 a_2019_1047.t9 a_4324_1008# VDD.t2 sg13_lv_pmos ad=0.3808p pd=2.92u as=0.3808p ps=2.92u w=1.12u l=0.13u
X924 VSS.t1108 a_4187_1764.t31 a_5631_1842# VSS.t1107 sg13_lv_nmos ad=0.2516p pd=2.16u as=0.1406p ps=1.12u w=0.74u l=0.6u
X925 a_3449_16422# CHAN0_MUX_SEL0 VDD.t418 VDD.t90 sg13_lv_pmos ad=0.1596p pd=1.22u as=0.2856p ps=2.36u w=0.84u l=0.13u
X926 VDD.t1445 a_15964_15316# a_16851_15336# VDD.t90 sg13_lv_pmos ad=0.2086p pd=1.5u as=0.34p ps=2.68u w=1u l=0.13u
X927 VDD.t619 a_4187_2434# a_7911_14652# VDD.t374 sg13_lv_pmos ad=0.3808p pd=2.92u as=0.2128p ps=1.5u w=1.12u l=0.6u
X928 VDD.t598 a_25283_14024# a_25717_14024# VDD.t374 sg13_lv_pmos ad=0.2128p pd=1.5u as=0.3808p ps=2.92u w=1.12u l=0.13u
X929 a_19550_1044# a_2595_1047.t4 a_20315_1044# VSS.t726 sg13_lv_nmos ad=0.2516p pd=2.16u as=0.1406p ps=1.12u w=0.74u l=0.13u
X930 a_3171_6737.t1 a_2873_7085# VSS.t864 VSS.t1351 sg13_lv_nmos ad=0.1406p pd=1.12u as=0.1331p ps=1.12u w=0.74u l=0.13u
X931 VDD.t292 VSS.t347 VDD.t304 VDD.t67 sg13_lv_pmos ad=0.34p pd=2.68u as=0 ps=0 w=1u l=1u
X932 a_16510_1044# a_18871_1008# a_18795_1044# VDD.t2 sg13_lv_pmos ad=0.3808p pd=2.92u as=0.2128p ps=1.5u w=1.12u l=0.13u
X933 a_7390_6734# a_8884_6698# a_8808_6734# VDD.t67 sg13_lv_pmos ad=0.3808p pd=2.92u as=0.2128p ps=1.5u w=1.12u l=0.13u
X934 VSS.t1523 a_21157_14024# a_21625_13226# VSS.t1522 sg13_lv_nmos ad=0.1665p pd=1.19u as=0.2516p ps=2.16u w=0.74u l=0.13u
X935 VSS.t864 a_2297_7085# a_2595_6737.t1 VSS.t865 sg13_lv_nmos ad=0.2812p pd=2.24u as=0.1406p ps=1.12u w=0.74u l=0.13u
X936 VDD.t1110 a_20723_14024# a_21157_14024# VDD.t374 sg13_lv_pmos ad=0.2128p pd=1.5u as=0.3808p ps=2.92u w=1.12u l=0.13u
X937 a_13991_5315# a_13753_4687# a_13883_4687# VDD.t348 sg13_lv_pmos ad=0.2128p pd=1.5u as=0.3808p ps=2.92u w=1.12u l=0.2u
X938 VSS.t2059 a_19637_16869# a_20105_16071# VSS.t2145 sg13_lv_nmos ad=0.1665p pd=1.19u as=0.2516p ps=2.16u w=0.74u l=0.13u
X939 VSS.t534 VSS.t532 VSS.t532 VSS.t533 sg13_lv_nmos ad=0.2516p pd=2.16u as=0 ps=0 w=0.74u l=0.13u
X940 VSS.t1367 a_27563_4687# a_27997_4687# VSS.t1366 sg13_lv_nmos ad=0.1406p pd=1.12u as=0.2516p ps=2.16u w=0.74u l=0.13u
X941 a_26911_7532# a_26673_7532# a_26803_7532# VSS.t762 sg13_lv_nmos ad=0.1406p pd=1.12u as=0.2516p ps=2.16u w=0.74u l=0.2u
X942 VSS.t1326 a_7477_1842# a_7945_1044# VSS.t1325 sg13_lv_nmos ad=0.1665p pd=1.19u as=0.2516p ps=2.16u w=0.74u l=0.13u
X943 VDD.t764 a_4187_2434# a_23871_2470# VDD.t373 sg13_lv_pmos ad=0.3808p pd=2.92u as=0.2128p ps=1.5u w=1.12u l=0.6u
X944 VSS.t2036 a_2019_13229.t4 a_19524_13190# VSS.t2035 sg13_lv_nmos ad=0.2516p pd=2.16u as=0.2516p ps=2.16u w=0.74u l=0.13u
X945 a_20593_4687# a_20397_4687# VSS.t94 VSS.t681 sg13_lv_nmos ad=0.2516p pd=2.16u as=0.1406p ps=1.12u w=0.74u l=0.13u
X946 VSS.t1699 a_19203_16869# a_19637_16869# VSS.t2193 sg13_lv_nmos ad=0.1406p pd=1.12u as=0.2516p ps=2.16u w=0.74u l=0.13u
X947 a_22351_8160# a_22113_7532# a_22243_7532# VDD.t346 sg13_lv_pmos ad=0.2128p pd=1.5u as=0.3808p ps=2.92u w=1.12u l=0.2u
X948 VSS.t107 a_3171_16074.t5 a_18004_16035# VSS.t659 sg13_lv_nmos ad=0.2516p pd=2.16u as=0.2516p ps=2.16u w=0.74u l=0.13u
X949 VSS.t384 VDD.t1638 VSS.t384 VSS.t385 sg13_lv_nmos ad=79.8f pd=0.8u as=0 ps=0 w=0.42u l=1u
X950 VDD.t397 a_16923_7532# a_17357_7532# VDD.t346 sg13_lv_pmos ad=0.2128p pd=1.5u as=0.3808p ps=2.92u w=1.12u l=0.13u
X951 a_2391_7085# REF_MUX_SEL0 a_2297_7085# VSS.t2163 sg13_lv_nmos ad=0.1216p pd=1.02u as=0.2176p ps=1.96u w=0.64u l=0.13u
X952 VSS.t20 a_6283_4687# a_6717_4687# VSS.t1574 sg13_lv_nmos ad=0.1406p pd=1.12u as=0.2516p ps=2.16u w=0.74u l=0.13u
X953 VSS.t319 VDD.t1662 VSS.t319 VSS.t324 sg13_lv_nmos ad=79.8f pd=0.8u as=0 ps=0 w=0.42u l=1u
X954 a_13368_6734# a_12797_7532# VSS.t753 VSS.t752 sg13_lv_nmos ad=0.1406p pd=1.12u as=0.2516p ps=2.16u w=0.74u l=0.13u
X955 VSS.t1061 a_3747_3156.t3 a_14825_3364# VSS.t1060 sg13_lv_nmos ad=0.2516p pd=2.16u as=0.2516p ps=2.16u w=0.74u l=0.13u
X956 a_13991_14024# a_13753_14024# a_13883_14024# VSS.t1062 sg13_lv_nmos ad=0.1406p pd=1.12u as=0.2516p ps=2.16u w=0.74u l=0.2u
X957 a_18313_14024# a_18117_14024# VSS.t847 VSS.t1404 sg13_lv_nmos ad=0.2516p pd=2.16u as=0.1406p ps=1.12u w=0.74u l=0.13u
X958 VSS.t864 a_1544_6734# a_1815_7085# VSS.t1089 sg13_lv_nmos ad=0.1331p pd=1.12u as=0.1216p ps=1.02u w=0.64u l=0.13u
X959 VDD.t43 VSS.t399 VDD.t42 VDD.t2 sg13_lv_pmos ad=0.34p pd=2.68u as=0 ps=0 w=1u l=1u
X960 a_13231_2470# a_12993_1842# a_13123_1842# VDD.t373 sg13_lv_pmos ad=0.2128p pd=1.5u as=0.3808p ps=2.92u w=1.12u l=0.2u
X961 a_10430_13226# a_11924_13190# a_11848_13226# VDD.t5 sg13_lv_pmos ad=0.3808p pd=2.92u as=0.2128p ps=1.5u w=1.12u l=0.13u
X962 VSS.t839 a_4187_1764.t117 a_14751_14024# VSS.t1547 sg13_lv_nmos ad=0.2516p pd=2.16u as=0.1406p ps=1.12u w=0.74u l=0.6u
X963 a_3449_3176# CHAN2_MUX_SEL2 VDD.t527 VDD.t0 sg13_lv_pmos ad=0.1596p pd=1.22u as=0.2856p ps=2.36u w=0.84u l=0.13u
X964 VSS.t486 a_3171_3892.t7 a_11924_3853# VSS.t1733 sg13_lv_nmos ad=0.2516p pd=2.16u as=0.2516p ps=2.16u w=0.74u l=0.13u
X965 VSS.t881 a_4437_16869# a_4905_16071# VSS.t880 sg13_lv_nmos ad=0.1665p pd=1.19u as=0.2516p ps=2.16u w=0.74u l=0.13u
X966 VSS.t1423 a_3747_13229.t3 a_24951_13190# VSS.t1644 sg13_lv_nmos ad=0.2516p pd=2.16u as=0.2516p ps=2.16u w=0.74u l=0.13u
X967 a_13880_11982# a_13592_11561# a_13818_11982# VSS.t1233 sg13_lv_nmos ad=0.1428p pd=1.52u as=37.8f ps=0.6u w=0.42u l=0.13u
X968 VDD.t660 a_4187_2434# a_20071_17497# VDD.t368 sg13_lv_pmos ad=0.3808p pd=2.92u as=0.2128p ps=1.5u w=1.12u l=0.6u
X969 VSS.t1034 a_4187_1764.t82 a_15511_7532# VSS.t2191 sg13_lv_nmos ad=0.2516p pd=2.16u as=0.1406p ps=1.12u w=0.74u l=0.6u
X970 VDD.t837 a_15077_7532# a_15545_6734# VDD.t67 sg13_lv_pmos ad=0.252p pd=1.57u as=0.3808p ps=2.92u w=1.12u l=0.13u
X971 VSS.t1000 a_3747_12493.t3 a_14825_12701# VSS.t66 sg13_lv_nmos ad=0.2516p pd=2.16u as=0.2516p ps=2.16u w=0.74u l=0.13u
X972 VDD.t688 a_4187_2434# a_10951_8160# VDD.t346 sg13_lv_pmos ad=0.3808p pd=2.92u as=0.2128p ps=1.5u w=1.12u l=0.6u
X973 VSS.t822 a_4187_1764.t98 VSS.t820 VSS.t805 sg13_lv_nmos ad=1.33p pd=7.38u as=0 ps=0 w=7u l=7u
X974 VDD.t509 a_15077_16869# a_15545_16071# VDD.t90 sg13_lv_pmos ad=0.252p pd=1.57u as=0.3808p ps=2.92u w=1.12u l=0.13u
X975 VDD.t358 a_12363_4687# a_12797_4687# VDD.t348 sg13_lv_pmos ad=0.2128p pd=1.5u as=0.3808p ps=2.92u w=1.12u l=0.13u
X976 a_16793_1842# a_16597_1842# VSS.t937 VSS.t2338 sg13_lv_nmos ad=0.2516p pd=2.16u as=0.1406p ps=1.12u w=0.74u l=0.13u
X977 VSS.t176 a_25283_7532# a_25717_7532# VSS.t1776 sg13_lv_nmos ad=0.1406p pd=1.12u as=0.2516p ps=2.16u w=0.74u l=0.13u
X978 a_7911_1842# a_7673_1842# a_7803_1842# VSS.t1966 sg13_lv_nmos ad=0.1406p pd=1.12u as=0.2516p ps=2.16u w=0.74u l=0.2u
X979 a_12233_1842# a_12037_1842# VDD.t954 VDD.t373 sg13_lv_pmos ad=0.3808p pd=2.92u as=0.2128p ps=1.5u w=1.12u l=0.13u
X980 a_16793_16869# a_16597_16869# VSS.t1458 VSS.t1457 sg13_lv_nmos ad=0.2516p pd=2.16u as=0.1406p ps=1.12u w=0.74u l=0.13u
X981 a_4350_6734# a_3747_6737.t9 a_6635_6734# VSS.t1762 sg13_lv_nmos ad=0.2516p pd=2.16u as=0.1406p ps=1.12u w=0.74u l=0.13u
X982 VSS.t224 VDD.t1691 VSS.t227 VSS.t226 sg13_lv_nmos ad=79.8f pd=0.8u as=0 ps=0 w=0.42u l=1u
X983 a_16108_12471# CHAN1_MUX_SEL4 a_15964_12471# VSS.t66 sg13_lv_nmos ad=0.2516p pd=2.16u as=0.2183p ps=1.33u w=0.74u l=0.13u
X984 VDD.t347 a_20723_7532# a_21157_7532# VDD.t346 sg13_lv_pmos ad=0.2128p pd=1.5u as=0.3808p ps=2.92u w=1.12u l=0.13u
X985 VDD.t523 a_3171_16074.t3 a_24084_16035# VDD.t90 sg13_lv_pmos ad=0.3808p pd=2.92u as=0.3808p ps=2.92u w=1.12u l=0.13u
X986 VSS.t358 VDD.t1647 VSS.t358 VSS.t362 sg13_lv_nmos ad=0.1428p pd=1.52u as=0 ps=0 w=0.42u l=1u
X987 a_12233_16869# a_12037_16869# VSS.t674 VSS.t673 sg13_lv_nmos ad=0.2516p pd=2.16u as=0.1406p ps=1.12u w=0.74u l=0.13u
X988 VDD.t251 VSS.t195 VDD.t250 VDD.t90 sg13_lv_pmos ad=0.34p pd=2.68u as=0 ps=0 w=1u l=1u
X989 VSS.t90 a_4187_1764.t95 a_5631_7532# VSS.t875 sg13_lv_nmos ad=0.2516p pd=2.16u as=0.1406p ps=1.12u w=0.74u l=0.6u
X990 a_19550_6734# a_2595_6737.t4 a_20315_6734# VSS.t1387 sg13_lv_nmos ad=0.2516p pd=2.16u as=0.1406p ps=1.12u w=0.74u l=0.13u
X991 VDD.t1488 a_3747_311.t3 a_14825_519# VDD.t2 sg13_lv_pmos ad=0.3808p pd=2.92u as=0.3808p ps=2.92u w=1.12u l=0.13u
X992 a_16510_3889# a_16484_3853# a_16408_3889# VDD.t0 sg13_lv_pmos ad=0.3808p pd=2.92u as=0.2128p ps=1.5u w=1.12u l=0.13u
X993 VSS.t954 a_3747_13229.t8 a_9751_13190# VSS.t953 sg13_lv_nmos ad=0.2516p pd=2.16u as=0.2516p ps=2.16u w=0.74u l=0.13u
X994 VDD.t629 a_4187_2434# a_4871_17497# VDD.t368 sg13_lv_pmos ad=0.3808p pd=2.92u as=0.2128p ps=1.5u w=1.12u l=0.6u
X995 a_25630_3889# a_2019_3892.t2 a_25528_3889# VSS.t1918 sg13_lv_nmos ad=0.2516p pd=2.16u as=0.1406p ps=1.12u w=0.74u l=0.13u
X996 a_3171_3892.t1 a_2873_4240# VSS.t589 VSS.t1613 sg13_lv_nmos ad=0.1406p pd=1.12u as=0.1331p ps=1.12u w=0.74u l=0.13u
X997 VDD.t1575 a_22243_16869# a_22677_16869# VDD.t368 sg13_lv_pmos ad=0.2128p pd=1.5u as=0.3808p ps=2.92u w=1.12u l=0.13u
X998 VDD.t47 VSS.t390 VDD.t46 VDD.t0 sg13_lv_pmos ad=0.34p pd=2.68u as=0 ps=0 w=1u l=1u
X999 VSS.t110 a_2595_16074.t8 a_8231_16035# VSS.t109 sg13_lv_nmos ad=0.2516p pd=2.16u as=0.2516p ps=2.16u w=0.74u l=0.13u
X1000 VSS.t1926 a_2595_13229.t9 a_5191_13190# VSS.t2043 sg13_lv_nmos ad=0.2516p pd=2.16u as=0.2516p ps=2.16u w=0.74u l=0.13u
X1001 VSS.t742 a_2297_4240# a_2595_3892.t1 VSS.t1796 sg13_lv_nmos ad=0.2812p pd=2.24u as=0.1406p ps=1.12u w=0.74u l=0.13u
X1002 a_19073_4687# a_18877_4687# VSS.t860 VSS.t1576 sg13_lv_nmos ad=0.2516p pd=2.16u as=0.1406p ps=1.12u w=0.74u l=0.13u
X1003 a_9675_1044# a_9465_1044# VSS.t1046 VSS.t1045 sg13_lv_nmos ad=0.1406p pd=1.12u as=0.1665p ps=1.19u w=0.74u l=0.13u
X1004 VDD.t821 a_3171_3892.t2 a_27124_3853# VDD.t0 sg13_lv_pmos ad=0.3808p pd=2.92u as=0.3808p ps=2.92u w=1.12u l=0.13u
X1005 a_1815_6021# a_1256_5979# a_1721_6021# VSS.t587 sg13_lv_nmos ad=0.1216p pd=1.02u as=0.2176p ps=1.96u w=0.64u l=0.13u
X1006 VDD.t711 a_4187_2434# a_23871_8160# VDD.t346 sg13_lv_pmos ad=0.3808p pd=2.92u as=0.2128p ps=1.5u w=1.12u l=0.6u
X1007 VSS.t802 a_7477_7532# a_7945_6734# VSS.t866 sg13_lv_nmos ad=0.1665p pd=1.19u as=0.2516p ps=2.16u w=0.74u l=0.13u
X1008 VSS.t1534 a_27563_1842# a_27997_1842# VSS.t1533 sg13_lv_nmos ad=0.1406p pd=1.12u as=0.2516p ps=2.16u w=0.74u l=0.13u
X1009 VDD.t881 a_3747_16074.t5 a_18871_16035# VDD.t90 sg13_lv_pmos ad=0.3808p pd=2.92u as=0.3808p ps=2.92u w=1.12u l=0.13u
X1010 VDD.t1285 a_3171_6737.t7 a_11924_6698# VDD.t67 sg13_lv_pmos ad=0.3808p pd=2.92u as=0.3808p ps=2.92u w=1.12u l=0.13u
X1011 a_20593_1842# a_20397_1842# VSS.t604 VSS.t603 sg13_lv_nmos ad=0.2516p pd=2.16u as=0.1406p ps=1.12u w=0.74u l=0.13u
X1012 VDD.t557 a_15964_5979# a_16851_5999# VDD.t67 sg13_lv_pmos ad=0.2086p pd=1.5u as=0.34p ps=2.68u w=1u l=0.13u
X1013 VSS.t722 a_2595_1047.t8 a_8231_1008# VSS.t721 sg13_lv_nmos ad=0.2516p pd=2.16u as=0.2516p ps=2.16u w=0.74u l=0.13u
X1014 a_19311_14024# a_19073_14024# a_19203_14024# VSS.t1210 sg13_lv_nmos ad=0.1406p pd=1.12u as=0.2516p ps=2.16u w=0.74u l=0.2u
X1015 VDD.t225 VSS.t319 VDD.t223 VDD.t67 sg13_lv_pmos ad=0.19p pd=1.38u as=0 ps=0 w=1u l=1u
X1016 VSS.t1110 a_6283_1842# a_6717_1842# VSS.t1897 sg13_lv_nmos ad=0.1406p pd=1.12u as=0.2516p ps=2.16u w=0.74u l=0.13u
X1017 a_10430_3889# a_11271_3853# a_11195_3889# VDD.t0 sg13_lv_pmos ad=0.3808p pd=2.92u as=0.2128p ps=1.5u w=1.12u l=0.13u
X1018 a_2391_4240# CHAN2_MUX_SEL0 a_2297_4240# VSS.t2284 sg13_lv_nmos ad=0.1216p pd=1.02u as=0.2176p ps=1.96u w=0.64u l=0.13u
X1019 a_10430_1044# a_10404_1008# a_10328_1044# VDD.t2 sg13_lv_pmos ad=0.3808p pd=2.92u as=0.2128p ps=1.5u w=1.12u l=0.13u
X1020 a_23355_3889# a_23145_3889# VDD.t1128 VDD.t0 sg13_lv_pmos ad=0.2128p pd=1.5u as=0.252p ps=1.57u w=1.12u l=0.13u
X1021 VSS.t742 a_1544_3889# a_1815_4240# VSS.t743 sg13_lv_nmos ad=0.1331p pd=1.12u as=0.1216p ps=1.02u w=0.64u l=0.13u
X1022 a_16108_5979# a_23945_6209# a_22590_6734# VDD.t67 sg13_lv_pmos ad=0.3808p pd=2.92u as=0.3808p ps=2.92u w=1.12u l=0.13u
X1023 a_13231_8160# a_12993_7532# a_13123_7532# VDD.t346 sg13_lv_pmos ad=0.2128p pd=1.5u as=0.3808p ps=2.92u w=1.12u l=0.2u
X1024 VDD.t522 a_3171_16074.t6 a_14964_16035# VDD.t90 sg13_lv_pmos ad=0.3808p pd=2.92u as=0.3808p ps=2.92u w=1.12u l=0.13u
X1025 VSS.t476 a_19203_4687# a_19637_4687# VSS.t475 sg13_lv_nmos ad=0.1406p pd=1.12u as=0.2516p ps=2.16u w=0.74u l=0.13u
X1026 a_16271_5315# a_16033_4687# a_16163_4687# VDD.t348 sg13_lv_pmos ad=0.2128p pd=1.5u as=0.3808p ps=2.92u w=1.12u l=0.2u
X1027 a_15108_11799# a_12849_11557# VDD.t381 VDD.t355 sg13_lv_pmos ad=79.8f pd=0.8u as=1.03698p ps=6.245u w=0.42u l=0.13u
X1028 VDD.t1186 a_3747_3892.t4 a_21911_3853# VDD.t0 sg13_lv_pmos ad=0.3808p pd=2.92u as=0.3808p ps=2.92u w=1.12u l=0.13u
X1029 a_8155_13226# a_7945_13226# VSS.t1941 VSS.t2056 sg13_lv_nmos ad=0.1406p pd=1.12u as=0.1665p ps=1.19u w=0.74u l=0.13u
X1030 a_5778_9057# a_6126_9506# a_6326_10280# VSS.t46 sg13_lv_nmos ad=0.68p pd=4.68u as=0.38p ps=2.38u w=2u l=1u
X1031 VDD.t768 a_4187_2434# a_26151_2470# VDD.t373 sg13_lv_pmos ad=0.3808p pd=2.92u as=0.2128p ps=1.5u w=1.12u l=0.6u
X1032 VDD.t912 a_14851_10872# a_15108_11015# VDD.t355 sg13_lv_pmos ad=0.2639p pd=1.81u as=79.8f ps=0.8u w=0.42u l=0.13u
X1033 a_17791_16869# a_17553_16869# a_17683_16869# VSS.t2348 sg13_lv_nmos ad=0.1406p pd=1.12u as=0.2516p ps=2.16u w=0.74u l=0.2u
X1034 VDD.t675 a_4187_2434# a_20071_14652# VDD.t374 sg13_lv_pmos ad=0.3808p pd=2.92u as=0.2128p ps=1.5u w=1.12u l=0.6u
X1035 VDD.t901 CHAN1_MUX_SEL1 a_3449_13577# VDD.t5 sg13_lv_pmos ad=0.1918p pd=1.5u as=0.1596p ps=1.22u w=0.84u l=0.13u
X1036 a_7390_1044# a_8884_1008# a_8808_1044# VDD.t2 sg13_lv_pmos ad=0.3808p pd=2.92u as=0.2128p ps=1.5u w=1.12u l=0.13u
X1037 VDD.t190 VSS.t278 VDD.t188 VDD.t5 sg13_lv_pmos ad=0.19p pd=1.38u as=0 ps=0 w=1u l=1u
X1038 a_25630_6734# a_25604_6698# a_25528_6734# VDD.t67 sg13_lv_pmos ad=0.3808p pd=2.92u as=0.2128p ps=1.5u w=1.12u l=0.13u
X1039 a_9431_17497# a_9193_16869# a_9323_16869# VDD.t368 sg13_lv_pmos ad=0.2128p pd=1.5u as=0.3808p ps=2.92u w=1.12u l=0.2u
X1040 VSS.t1099 a_4187_1764.t144 a_18551_16869# VSS.t2152 sg13_lv_nmos ad=0.2516p pd=2.16u as=0.1406p ps=1.12u w=0.74u l=0.6u
X1041 a_16793_7532# a_16597_7532# VSS.t1585 VSS.t1584 sg13_lv_nmos ad=0.2516p pd=2.16u as=0.1406p ps=1.12u w=0.74u l=0.13u
X1042 VSS.t114 a_8563_4687# a_8997_4687# VSS.t625 sg13_lv_nmos ad=0.1406p pd=1.12u as=0.2516p ps=2.16u w=0.74u l=0.13u
X1043 a_12233_7532# a_12037_7532# VDD.t774 VDD.t346 sg13_lv_pmos ad=0.3808p pd=2.92u as=0.2128p ps=1.5u w=1.12u l=0.13u
X1044 a_7911_7532# a_7673_7532# a_7803_7532# VSS.t1494 sg13_lv_nmos ad=0.1406p pd=1.12u as=0.2516p ps=2.16u w=0.74u l=0.2u
X1045 VDD.t612 a_4187_2434# a_4871_2470# VDD.t373 sg13_lv_pmos ad=0.3808p pd=2.92u as=0.2128p ps=1.5u w=1.12u l=0.6u
X1046 VSS.t1167 a_4187_1764.t53 a_13231_4687# VSS.t2266 sg13_lv_nmos ad=0.2516p pd=2.16u as=0.1406p ps=1.12u w=0.74u l=0.6u
X1047 a_20968_3889# a_20397_4687# VDD.t560 VDD.t0 sg13_lv_pmos ad=0.2128p pd=1.5u as=0.3808p ps=2.92u w=1.12u l=0.13u
X1048 VDD.t1154 CHAN2_MUX_SEL1 a_3449_4240# VDD.t0 sg13_lv_pmos ad=0.1918p pd=1.5u as=0.1596p ps=1.22u w=0.84u l=0.13u
X1049 VDD.t372 a_27563_16869# a_27997_16869# VDD.t368 sg13_lv_pmos ad=0.2128p pd=1.5u as=0.3808p ps=2.92u w=1.12u l=0.13u
X1050 a_13880_11982# a_14111_11568# a_13566_11525# VSS.t185 sg13_lv_nmos ad=0.2373p pd=1.97u as=79.8f ps=0.8u w=0.42u l=0.13u
X1051 a_13949_11604# a_13592_11561# VDD.t408 VDD.t355 sg13_lv_pmos ad=63f pd=0.72u as=0.1563p ps=1.22u w=0.42u l=0.13u
X1052 a_3747_15338.t0 a_3449_15358# VDD.t1440 VDD.t90 sg13_lv_pmos ad=0.2128p pd=1.5u as=0.1918p ps=1.5u w=1.12u l=0.13u
X1053 a_3449_331# CHAN3_MUX_SEL2 VDD.t1169 VDD.t2 sg13_lv_pmos ad=0.1596p pd=1.22u as=0.2856p ps=2.36u w=0.84u l=0.13u
X1054 a_3747_15338.t1 a_3449_15358# VSS.t1784 VSS.t2116 sg13_lv_nmos ad=0.1406p pd=1.12u as=0.1331p ps=1.12u w=0.74u l=0.13u
X1055 VSS.t112 a_23003_4687# a_23437_4687# VSS.t1171 sg13_lv_nmos ad=0.1406p pd=1.12u as=0.2516p ps=2.16u w=0.74u l=0.13u
X1056 a_20071_5315# a_19833_4687# a_19963_4687# VDD.t348 sg13_lv_pmos ad=0.2128p pd=1.5u as=0.3808p ps=2.92u w=1.12u l=0.2u
X1057 VDD.t647 a_4187_2434# a_4871_14652# VDD.t374 sg13_lv_pmos ad=0.3808p pd=2.92u as=0.2128p ps=1.5u w=1.12u l=0.6u
X1058 a_11910_11995# DLL_RESETN VSS.t32 VSS.t2218 sg13_lv_nmos ad=37.8f pd=0.6u as=79.8f ps=0.8u w=0.42u l=0.13u
X1059 VDD.t540 a_22243_14024# a_22677_14024# VDD.t374 sg13_lv_pmos ad=0.2128p pd=1.5u as=0.3808p ps=2.92u w=1.12u l=0.13u
X1060 VDD.t814 a_14851_11918# a_15688_11557# VDD.t355 sg13_lv_pmos ad=0.2128p pd=1.5u as=0.3864p ps=2.93u w=1.12u l=0.13u
X1061 VSS.t1978 a_21157_16869# a_21625_16071# VSS.t2239 sg13_lv_nmos ad=0.1665p pd=1.19u as=0.2516p ps=2.16u w=0.74u l=0.13u
X1062 VDD.t311 VSS.t443 VDD.t309 VDD.t2 sg13_lv_pmos ad=0.19p pd=1.38u as=0 ps=0 w=1u l=1u
X1063 a_19073_1842# a_18877_1842# VSS.t980 VSS.t1528 sg13_lv_nmos ad=0.2516p pd=2.16u as=0.1406p ps=1.12u w=0.74u l=0.13u
X1064 VDD.t1411 a_2873_3176# a_3171_3156.t0 VDD.t0 sg13_lv_pmos ad=0.4256p pd=3u as=0.2128p ps=1.5u w=1.12u l=0.13u
X1065 VDD.t1014 a_14643_4687# a_15077_4687# VDD.t348 sg13_lv_pmos ad=0.2128p pd=1.5u as=0.3808p ps=2.92u w=1.12u l=0.13u
X1066 a_9675_6734# a_9465_6734# VSS.t1602 VSS.t1818 sg13_lv_nmos ad=0.1406p pd=1.12u as=0.1665p ps=1.19u w=0.74u l=0.13u
X1067 VSS.t184 a_27563_7532# a_27997_7532# VSS.t183 sg13_lv_nmos ad=0.1406p pd=1.12u as=0.2516p ps=2.16u w=0.74u l=0.13u
X1068 VSS.t1105 a_2019_16074.t4 a_19524_16035# VSS.t2109 sg13_lv_nmos ad=0.2516p pd=2.16u as=0.2516p ps=2.16u w=0.74u l=0.13u
X1069 a_20593_7532# a_20397_7532# VSS.t692 VSS.t691 sg13_lv_nmos ad=0.2516p pd=2.16u as=0.1406p ps=1.12u w=0.74u l=0.13u
X1070 VDD.t933 a_15077_1842# a_15545_1044# VDD.t2 sg13_lv_pmos ad=0.252p pd=1.57u as=0.3808p ps=2.92u w=1.12u l=0.13u
X1071 VDD.t1438 a_15964_3134# a_16851_3154# VDD.t0 sg13_lv_pmos ad=0.2086p pd=1.5u as=0.34p ps=2.68u w=1u l=0.13u
X1072 VSS.t2033 a_2019_13229.t5 a_16484_13190# VSS.t2032 sg13_lv_nmos ad=0.2516p pd=2.16u as=0.2516p ps=2.16u w=0.74u l=0.13u
X1073 VSS.t1145 a_2595_6737.t8 a_8231_6698# VSS.t1383 sg13_lv_nmos ad=0.2516p pd=2.16u as=0.2516p ps=2.16u w=0.74u l=0.13u
X1074 a_16510_3889# a_2019_3892.t5 a_16408_3889# VSS.t1509 sg13_lv_nmos ad=0.2516p pd=2.16u as=0.1406p ps=1.12u w=0.74u l=0.13u
X1075 VDD.t41 VSS.t365 VDD.t39 VDD.t0 sg13_lv_pmos ad=0.19p pd=1.38u as=0 ps=0 w=1u l=1u
X1076 a_19550_1044# a_2019_1047.t4 a_19448_1044# VSS.t2005 sg13_lv_nmos ad=0.2516p pd=2.16u as=0.1406p ps=1.12u w=0.74u l=0.13u
X1077 VDD.t25 VSS.t253 VDD.t23 VDD.t5 sg13_lv_pmos ad=0.19p pd=1.38u as=0 ps=0 w=1u l=1u
X1078 VSS.t98 a_6283_7532# a_6717_7532# VSS.t2277 sg13_lv_nmos ad=0.1406p pd=1.12u as=0.2516p ps=2.16u w=0.74u l=0.13u
X1079 VSS.t466 VDD.t1618 VSS.t464 VSS.t465 sg13_lv_nmos ad=79.8f pd=0.8u as=0 ps=0 w=0.42u l=1u
X1080 VDD.t552 a_7803_16869# a_8237_16869# VDD.t368 sg13_lv_pmos ad=0.2128p pd=1.5u as=0.3808p ps=2.92u w=1.12u l=0.13u
X1081 VDD.t496 VDD.t494 VDD.t495 VDD.t373 sg13_lv_pmos ad=0.3808p pd=2.92u as=0 ps=0 w=1.12u l=0.6u
X1082 a_20831_17497# a_20593_16869# a_20723_16869# VDD.t368 sg13_lv_pmos ad=0.2128p pd=1.5u as=0.3808p ps=2.92u w=1.12u l=0.2u
X1083 VDD.t537 DLL_RESETN a_9946_11995# VDD.t355 sg13_lv_pmos ad=0.36237p pd=2.605u as=79.8f ps=0.8u w=0.42u l=0.13u
X1084 VDD.t17 VSS.t441 VDD.t4 VDD.t2 sg13_lv_pmos ad=0.19p pd=1.38u as=0 ps=0 w=1u l=1u
X1085 a_5731_5979# a_2595_6001.t3 a_7390_6734# VSS.t1485 sg13_lv_nmos ad=0.2516p pd=2.16u as=0.2516p ps=2.16u w=0.74u l=0.13u
X1086 a_16108_3134# a_23945_3364# a_22590_3889# VDD.t0 sg13_lv_pmos ad=0.3808p pd=2.92u as=0.3808p ps=2.92u w=1.12u l=0.13u
X1087 VSS.t960 a_3171_3892.t2 a_27124_3853# VSS.t959 sg13_lv_nmos ad=0.2516p pd=2.16u as=0.2516p ps=2.16u w=0.74u l=0.13u
X1088 a_10951_14024# a_10713_14024# a_10843_14024# VSS.t2353 sg13_lv_nmos ad=0.1406p pd=1.12u as=0.2516p ps=2.16u w=0.74u l=0.2u
X1089 VDD.t860 a_19637_14024# a_20105_13226# VDD.t5 sg13_lv_pmos ad=0.252p pd=1.57u as=0.3808p ps=2.92u w=1.12u l=0.13u
X1090 VDD.t286 VSS.t265 VDD.t316 VDD.t5 sg13_lv_pmos ad=0.34p pd=2.68u as=0 ps=0 w=1u l=1u
X1091 VDD.t727 a_4187_2434# a_17791_5315# VDD.t348 sg13_lv_pmos ad=0.3808p pd=2.92u as=0.2128p ps=1.5u w=1.12u l=0.6u
X1092 a_15273_14024# a_15077_14024# VSS.t839 VSS.t838 sg13_lv_nmos ad=0.2516p pd=2.16u as=0.1406p ps=1.12u w=0.74u l=0.13u
X1093 VSS.t81 a_19203_1842# a_19637_1842# VSS.t1982 sg13_lv_nmos ad=0.1406p pd=1.12u as=0.2516p ps=2.16u w=0.74u l=0.13u
X1094 VSS.t783 a_2595_3156.t3 a_8745_3364# VSS.t782 sg13_lv_nmos ad=0.2516p pd=2.16u as=0.2516p ps=2.16u w=0.74u l=0.13u
X1095 VDD.t658 a_4187_2434# a_21591_17497# VDD.t368 sg13_lv_pmos ad=0.3808p pd=2.92u as=0.2128p ps=1.5u w=1.12u l=0.6u
X1096 a_2019_3156.t0 a_1721_3176# VDD.t1425 VDD.t0 sg13_lv_pmos ad=0.2128p pd=1.5u as=0.1918p ps=1.5u w=1.12u l=0.13u
X1097 VDD.t712 a_4187_2434# a_26151_8160# VDD.t346 sg13_lv_pmos ad=0.3808p pd=2.92u as=0.2128p ps=1.5u w=1.12u l=0.6u
X1098 VDD.t130 VSS.t419 VDD.t129 VDD.t2 sg13_lv_pmos ad=0.34p pd=2.68u as=0 ps=0 w=1u l=1u
X1099 VSS.t482 a_3747_16074.t3 a_24951_16035# VSS.t481 sg13_lv_nmos ad=0.2516p pd=2.16u as=0.2516p ps=2.16u w=0.74u l=0.13u
X1100 VDD.t1178 a_3171_13229.t5 a_18004_13190# VDD.t5 sg13_lv_pmos ad=0.3808p pd=2.92u as=0.3808p ps=2.92u w=1.12u l=0.13u
X1101 VSS.t239 VDD.t1687 VSS.t239 VSS.t238 sg13_lv_nmos ad=0.1428p pd=1.52u as=0 ps=0 w=0.42u l=1u
X1102 VSS.t1414 a_3747_13229.t4 a_21911_13190# VSS.t1544 sg13_lv_nmos ad=0.2516p pd=2.16u as=0.2516p ps=2.16u w=0.74u l=0.13u
X1103 a_10430_3889# a_2595_3892.t7 a_11195_3889# VSS.t1465 sg13_lv_nmos ad=0.2516p pd=2.16u as=0.1406p ps=1.12u w=0.74u l=0.13u
X1104 a_15511_4687# a_15273_4687# a_15403_4687# VSS.t1841 sg13_lv_nmos ad=0.1406p pd=1.12u as=0.2516p ps=2.16u w=0.74u l=0.2u
X1105 VSS.t258 a_3171_12493.t3 a_11785_12701# VSS.t999 sg13_lv_nmos ad=0.2516p pd=2.16u as=0.2516p ps=2.16u w=0.74u l=0.13u
X1106 a_13470_1044# a_2595_1047.t6 a_14235_1044# VSS.t734 sg13_lv_nmos ad=0.2516p pd=2.16u as=0.1406p ps=1.12u w=0.74u l=0.13u
X1107 VDD.t1279 a_1256_289# a_2873_331# VDD.t2 sg13_lv_pmos ad=0.1918p pd=1.5u as=0.1596p ps=1.22u w=0.84u l=0.13u
X1108 a_27433_1842# a_27237_1842# VDD.t1357 VDD.t373 sg13_lv_pmos ad=0.3808p pd=2.92u as=0.2128p ps=1.5u w=1.12u l=0.13u
X1109 a_9431_14652# a_9193_14024# a_9323_14024# VDD.t374 sg13_lv_pmos ad=0.2128p pd=1.5u as=0.3808p ps=2.92u w=1.12u l=0.2u
X1110 VSS.t1476 a_8563_1842# a_8997_1842# VSS.t1961 sg13_lv_nmos ad=0.1406p pd=1.12u as=0.2516p ps=2.16u w=0.74u l=0.13u
X1111 a_19448_3889# a_18877_4687# VDD.t1136 VDD.t0 sg13_lv_pmos ad=0.2128p pd=1.5u as=0.3808p ps=2.92u w=1.12u l=0.13u
X1112 a_23355_3889# a_23145_3889# VSS.t1562 VSS.t1809 sg13_lv_nmos ad=0.1406p pd=1.12u as=0.1665p ps=1.19u w=0.74u l=0.13u
X1113 VDD.t699 a_4187_2434# a_4871_8160# VDD.t346 sg13_lv_pmos ad=0.3808p pd=2.92u as=0.2128p ps=1.5u w=1.12u l=0.6u
X1114 VDD.t1434 a_2019_16074.t2 a_25604_16035# VDD.t90 sg13_lv_pmos ad=0.3808p pd=2.92u as=0.3808p ps=2.92u w=1.12u l=0.13u
X1115 a_3543_15358# CHAN0_MUX_SEL2 a_3449_15358# VSS.t761 sg13_lv_nmos ad=0.1216p pd=1.02u as=0.2176p ps=1.96u w=0.64u l=0.13u
X1116 VDD.t381 a_14009_10774# a_14111_10917# VDD.t355 sg13_lv_pmos ad=1.10612p pd=6.66u as=0.3864p ps=2.93u w=1.12u l=0.13u
X1117 a_10430_3889# a_11924_3853# a_11848_3889# VDD.t0 sg13_lv_pmos ad=0.3808p pd=2.92u as=0.2128p ps=1.5u w=1.12u l=0.13u
X1118 VSS.t637 a_4187_1764.t21 a_13231_1842# VSS.t996 sg13_lv_nmos ad=0.2516p pd=2.16u as=0.1406p ps=1.12u w=0.74u l=0.6u
X1119 VSS.t1681 a_3747_3892.t4 a_21911_3853# VSS.t1680 sg13_lv_nmos ad=0.2516p pd=2.16u as=0.2516p ps=2.16u w=0.74u l=0.13u
X1120 a_13753_16869# a_13557_16869# VSS.t635 VSS.t1374 sg13_lv_nmos ad=0.2516p pd=2.16u as=0.1406p ps=1.12u w=0.74u l=0.13u
X1121 VSS.t216 VDD.t1694 VSS.t216 VSS.t217 sg13_lv_nmos ad=79.8f pd=0.8u as=0 ps=0 w=0.42u l=1u
X1122 VDD.t1319 a_4437_14024# a_4905_13226# VDD.t5 sg13_lv_pmos ad=0.252p pd=1.57u as=0.3808p ps=2.92u w=1.12u l=0.13u
X1123 VSS.t708 a_2019_1047.t3 a_22564_1008# VSS.t2017 sg13_lv_nmos ad=0.2516p pd=2.16u as=0.2516p ps=2.16u w=0.74u l=0.13u
X1124 VDD.t1191 a_3171_1047.t7 a_11924_1008# VDD.t2 sg13_lv_pmos ad=0.3808p pd=2.92u as=0.3808p ps=2.92u w=1.12u l=0.13u
X1125 VDD.t1265 a_27563_14024# a_27997_14024# VDD.t374 sg13_lv_pmos ad=0.2128p pd=1.5u as=0.3808p ps=2.92u w=1.12u l=0.13u
X1126 a_16510_6734# a_16484_6698# a_16408_6734# VDD.t67 sg13_lv_pmos ad=0.3808p pd=2.92u as=0.2128p ps=1.5u w=1.12u l=0.13u
X1127 a_5393_16869# a_5197_16869# VDD.t848 VDD.t368 sg13_lv_pmos ad=0.3808p pd=2.92u as=0.2128p ps=1.5u w=1.12u l=0.13u
X1128 VDD.t740 a_4187_2434# a_21591_5315# VDD.t348 sg13_lv_pmos ad=0.3808p pd=2.92u as=0.2128p ps=1.5u w=1.12u l=0.6u
X1129 VSS.t1370 a_3747_16074.t8 a_9751_16035# VSS.t1444 sg13_lv_nmos ad=0.2516p pd=2.16u as=0.2516p ps=2.16u w=0.74u l=0.13u
X1130 VSS.t1661 a_23003_1842# a_23437_1842# VSS.t1987 sg13_lv_nmos ad=0.1406p pd=1.12u as=0.2516p ps=2.16u w=0.74u l=0.13u
X1131 VSS.t372 VDD.t1642 VSS.t372 VSS.t374 sg13_lv_nmos ad=0.1428p pd=1.52u as=0 ps=0 w=0.42u l=1u
X1132 VSS.t1394 a_3747_13229.t9 a_6711_13190# VSS.t1536 sg13_lv_nmos ad=0.2516p pd=2.16u as=0.2516p ps=2.16u w=0.74u l=0.13u
X1133 VSS.t149 a_1721_12513# a_2019_12493.t1 VSS.t1781 sg13_lv_nmos ad=0.2812p pd=2.24u as=0.1406p ps=1.12u w=0.74u l=0.13u
X1134 VSS.t466 VDD.t1617 VSS.t466 VSS.t467 sg13_lv_nmos ad=0.1428p pd=1.52u as=0 ps=0 w=0.42u l=1u
X1135 VSS.t1050 a_2595_16074.t9 a_5191_16035# VSS.t1875 sg13_lv_nmos ad=0.2516p pd=2.16u as=0.2516p ps=2.16u w=0.74u l=0.13u
X1136 a_19073_7532# a_18877_7532# VSS.t649 VSS.t648 sg13_lv_nmos ad=0.2516p pd=2.16u as=0.1406p ps=1.12u w=0.74u l=0.13u
X1137 VDD.t728 a_4187_2434# a_7151_2470# VDD.t373 sg13_lv_pmos ad=0.3808p pd=2.92u as=0.2128p ps=1.5u w=1.12u l=0.6u
X1138 a_20968_3889# a_20397_4687# VSS.t683 VSS.t682 sg13_lv_nmos ad=0.1406p pd=1.12u as=0.2516p ps=2.16u w=0.74u l=0.13u
X1139 VDD.t1042 a_3171_6737.t2 a_27124_6698# VDD.t67 sg13_lv_pmos ad=0.3808p pd=2.92u as=0.3808p ps=2.92u w=1.12u l=0.13u
X1140 VSS.t764 a_16851_12491# CHAN1_MUX_OUT VSS.t2171 sg13_lv_nmos ad=0.2516p pd=2.16u as=0.1406p ps=1.12u w=0.74u l=0.13u
X1141 VSS.t1086 a_13883_4687# a_14317_4687# VSS.t2286 sg13_lv_nmos ad=0.1406p pd=1.12u as=0.2516p ps=2.16u w=0.74u l=0.13u
X1142 a_11491_11918# a_10649_11568# a_11397_11918# VSS.t1315 sg13_lv_nmos ad=0.12665p pd=1.145u as=0.1428p ps=1.52u w=0.42u l=0.13u
X1143 a_25630_3889# a_26471_3853# a_26395_3889# VDD.t0 sg13_lv_pmos ad=0.3808p pd=2.92u as=0.2128p ps=1.5u w=1.12u l=0.13u
X1144 a_19550_6734# a_2019_6737.t4 a_19448_6734# VSS.t1713 sg13_lv_nmos ad=0.2516p pd=2.16u as=0.1406p ps=1.12u w=0.74u l=0.13u
X1145 a_16271_14024# a_16033_14024# a_16163_14024# VSS.t2329 sg13_lv_nmos ad=0.1406p pd=1.12u as=0.2516p ps=2.16u w=0.74u l=0.2u
X1146 a_25630_1044# a_25604_1008# a_25528_1044# VDD.t2 sg13_lv_pmos ad=0.3808p pd=2.92u as=0.2128p ps=1.5u w=1.12u l=0.13u
X1147 a_10430_6734# a_11271_6698# a_11195_6734# VDD.t67 sg13_lv_pmos ad=0.3808p pd=2.92u as=0.2128p ps=1.5u w=1.12u l=0.13u
X1148 VDD.t832 a_2595_13229.t8 a_8231_13190# VDD.t5 sg13_lv_pmos ad=0.3808p pd=2.92u as=0.3808p ps=2.92u w=1.12u l=0.13u
X1149 VDD.t484 VDD.t486 VDD.t487 VDD.t348 sg13_lv_pmos ad=0.2128p pd=1.5u as=0 ps=0 w=1.12u l=0.2u
X1150 VDD.t1002 a_7803_14024# a_8237_14024# VDD.t374 sg13_lv_pmos ad=0.2128p pd=1.5u as=0.3808p ps=2.92u w=1.12u l=0.13u
X1151 VDD.t474 VDD.t472 VDD.t473 VDD.t346 sg13_lv_pmos ad=0.3808p pd=2.92u as=0 ps=0 w=1.12u l=0.6u
X1152 a_20831_14652# a_20593_14024# a_20723_14024# VDD.t374 sg13_lv_pmos ad=0.2128p pd=1.5u as=0.3808p ps=2.92u w=1.12u l=0.2u
X1153 VSS.t333 VDD.t1658 VSS.t333 VSS.t332 sg13_lv_nmos ad=0.1428p pd=1.52u as=0 ps=0 w=0.42u l=1u
X1154 VSS.t1480 a_4187_1764.t114 a_17031_14024# VSS.t1524 sg13_lv_nmos ad=0.2516p pd=2.16u as=0.1406p ps=1.12u w=0.74u l=0.6u
X1155 a_23355_6734# a_23145_6734# VDD.t411 VDD.t67 sg13_lv_pmos ad=0.2128p pd=1.5u as=0.252p ps=1.57u w=1.12u l=0.13u
X1156 a_9675_13226# a_9465_13226# VSS.t1318 VSS.t2072 sg13_lv_nmos ad=0.1406p pd=1.12u as=0.1665p ps=1.19u w=0.74u l=0.13u
X1157 VSS.t1566 a_19203_7532# a_19637_7532# VSS.t1565 sg13_lv_nmos ad=0.1406p pd=1.12u as=0.2516p ps=2.16u w=0.74u l=0.13u
X1158 VDD.t550 a_3171_16074.t7 a_11924_16035# VDD.t90 sg13_lv_pmos ad=0.3808p pd=2.92u as=0.3808p ps=2.92u w=1.12u l=0.13u
X1159 VDD.t1433 a_1544_15316# a_2297_15358# VDD.t90 sg13_lv_pmos ad=0.1918p pd=1.5u as=0.1596p ps=1.22u w=0.84u l=0.13u
X1160 VDD.t673 a_4187_2434# a_21591_14652# VDD.t374 sg13_lv_pmos ad=0.3808p pd=2.92u as=0.2128p ps=1.5u w=1.12u l=0.6u
X1161 VDD.t1222 a_3747_6737.t4 a_21911_6698# VDD.t67 sg13_lv_pmos ad=0.3808p pd=2.92u as=0.3808p ps=2.92u w=1.12u l=0.13u
X1162 a_8155_16071# a_7945_16071# VSS.t2048 VSS.t2047 sg13_lv_nmos ad=0.1406p pd=1.12u as=0.1665p ps=1.19u w=0.74u l=0.13u
X1163 VSS.t755 a_4003_4687# a_4437_4687# VSS.t799 sg13_lv_nmos ad=0.1406p pd=1.12u as=0.2516p ps=2.16u w=0.74u l=0.13u
X1164 a_14851_10872# a_14009_10774# a_14757_10872# VSS.t474 sg13_lv_nmos ad=0.12665p pd=1.145u as=0.1428p ps=1.52u w=0.42u l=0.13u
X1165 a_15511_1842# a_15273_1842# a_15403_1842# VSS.t79 sg13_lv_nmos ad=0.1406p pd=1.12u as=0.2516p ps=2.16u w=0.74u l=0.2u
X1166 a_14751_16869# a_14513_16869# a_14643_16869# VSS.t1378 sg13_lv_nmos ad=0.1406p pd=1.12u as=0.2516p ps=2.16u w=0.74u l=0.2u
X1167 a_27433_7532# a_27237_7532# VDD.t1025 VDD.t346 sg13_lv_pmos ad=0.3808p pd=2.92u as=0.2128p ps=1.5u w=1.12u l=0.13u
X1168 a_13470_6734# a_2595_6737.t6 a_14235_6734# VSS.t1433 sg13_lv_nmos ad=0.2516p pd=2.16u as=0.1406p ps=1.12u w=0.74u l=0.13u
X1169 VDD.t553 a_10083_16869# a_10517_16869# VDD.t368 sg13_lv_pmos ad=0.2128p pd=1.5u as=0.3808p ps=2.92u w=1.12u l=0.13u
X1170 a_19073_16869# a_18877_16869# VSS.t1099 VSS.t1750 sg13_lv_nmos ad=0.2516p pd=2.16u as=0.1406p ps=1.12u w=0.74u l=0.13u
X1171 VSS.t1235 a_8563_7532# a_8997_7532# VSS.t1234 sg13_lv_nmos ad=0.1406p pd=1.12u as=0.2516p ps=2.16u w=0.74u l=0.13u
X1172 VDD.t1293 a_3747_6001.t3 a_14825_6209# VDD.t67 sg13_lv_pmos ad=0.3808p pd=2.92u as=0.3808p ps=2.92u w=1.12u l=0.13u
X1173 a_6391_17497# a_6153_16869# a_6283_16869# VDD.t368 sg13_lv_pmos ad=0.2128p pd=1.5u as=0.3808p ps=2.92u w=1.12u l=0.2u
X1174 VSS.t1278 a_9444_10280# a_9444_10280# VSS.t1274 sg13_lv_nmos ad=0.68p pd=4.68u as=0.38p ps=2.38u w=2u l=1u
X1175 a_3543_12513# CHAN1_MUX_SEL2 a_3449_12513# VSS.t2141 sg13_lv_nmos ad=0.1216p pd=1.02u as=0.2176p ps=1.96u w=0.64u l=0.13u
X1176 VSS.t1588 a_4187_1764.t85 a_13231_7532# VSS.t1587 sg13_lv_nmos ad=0.2516p pd=2.16u as=0.1406p ps=1.12u w=0.74u l=0.6u
X1177 VSS.t1121 a_2019_6737.t3 a_22564_6698# VSS.t1120 sg13_lv_nmos ad=0.2516p pd=2.16u as=0.2516p ps=2.16u w=0.74u l=0.13u
X1178 a_20968_6734# a_20397_7532# VDD.t563 VDD.t67 sg13_lv_pmos ad=0.2128p pd=1.5u as=0.3808p ps=2.92u w=1.12u l=0.13u
X1179 VDD.t908 a_5957_4687# a_6425_3889# VDD.t0 sg13_lv_pmos ad=0.252p pd=1.57u as=0.3808p ps=2.92u w=1.12u l=0.13u
X1180 VDD.t246 VSS.t216 VDD.t245 VDD.t90 sg13_lv_pmos ad=0.34p pd=2.68u as=0 ps=0 w=1u l=1u
X1181 VSS.t1069 a_19203_14024# a_19637_14024# VSS.t1832 sg13_lv_nmos ad=0.1406p pd=1.12u as=0.2516p ps=2.16u w=0.74u l=0.13u
X1182 a_3171_6001.t0 a_2873_6021# VDD.t1156 VDD.t67 sg13_lv_pmos ad=0.2128p pd=1.5u as=0.1918p ps=1.5u w=1.12u l=0.13u
X1183 VSS.t526 VSS.t526 VSS.t528 VSS.t527 sg13_lv_nmos ad=0.2516p pd=2.16u as=0 ps=0 w=0.74u l=0.13u
X1184 VSS.t398 VDD.t1634 VSS.t401 VSS.t400 sg13_lv_nmos ad=79.8f pd=0.8u as=0 ps=0 w=0.42u l=1u
X1185 VDD.t642 a_4187_2434# a_7151_17497# VDD.t368 sg13_lv_pmos ad=0.3808p pd=2.92u as=0.2128p ps=1.5u w=1.12u l=0.6u
X1186 a_16510_13226# a_3171_13229.t5 a_17928_13226# VSS.t1650 sg13_lv_nmos ad=0.2516p pd=2.16u as=0.1406p ps=1.12u w=0.74u l=0.13u
X1187 a_5731_289# a_11785_519# a_10430_1044# VDD.t2 sg13_lv_pmos ad=0.3808p pd=2.92u as=0.3808p ps=2.92u w=1.12u l=0.13u
X1188 VDD.t853 a_24523_16869# a_24957_16869# VDD.t368 sg13_lv_pmos ad=0.2128p pd=1.5u as=0.3808p ps=2.92u w=1.12u l=0.13u
X1189 VSS.t525 VSS.t522 VSS.t522 VSS.t523 sg13_lv_nmos ad=0.1406p pd=1.12u as=0 ps=0 w=0.74u l=0.13u
X1190 a_18313_1842# a_18117_1842# VDD.t935 VDD.t373 sg13_lv_pmos ad=0.3808p pd=2.92u as=0.2128p ps=1.5u w=1.12u l=0.13u
X1191 a_5393_14024# a_5197_14024# VDD.t1315 VDD.t374 sg13_lv_pmos ad=0.3808p pd=2.92u as=0.2128p ps=1.5u w=1.12u l=0.13u
X1192 VDD.t1240 a_2297_6021# a_2595_6001.t0 VDD.t67 sg13_lv_pmos ad=0.4256p pd=3u as=0.2128p ps=1.5u w=1.12u l=0.13u
X1193 VDD.t381 a_12907_10876# a_12907_11110# VDD.t355 sg13_lv_pmos ad=1.10612p pd=6.66u as=0.2442p ps=2.06u w=0.66u l=0.13u
X1194 VSS.t1030 a_23003_7532# a_23437_7532# VSS.t1029 sg13_lv_nmos ad=0.1406p pd=1.12u as=0.2516p ps=2.16u w=0.74u l=0.13u
X1195 a_9431_2470# a_9193_1842# a_9323_1842# VDD.t373 sg13_lv_pmos ad=0.2128p pd=1.5u as=0.3808p ps=2.92u w=1.12u l=0.2u
X1196 a_17275_1044# a_17065_1044# VSS.t874 VSS.t873 sg13_lv_nmos ad=0.1406p pd=1.12u as=0.1665p ps=1.19u w=0.74u l=0.13u
X1197 a_19448_3889# a_18877_4687# VSS.t1513 VSS.t1575 sg13_lv_nmos ad=0.1406p pd=1.12u as=0.2516p ps=2.16u w=0.74u l=0.13u
X1198 VDD.t18 VSS.t447 VDD.t1615 VDD.t2 sg13_lv_pmos ad=0.34p pd=2.68u as=0 ps=0 w=1u l=1u
X1199 a_10430_3889# a_3171_3892.t7 a_11848_3889# VSS.t1732 sg13_lv_nmos ad=0.2516p pd=2.16u as=0.1406p ps=1.12u w=0.74u l=0.13u
X1200 a_22873_4687# a_22677_4687# VDD.t1129 VDD.t348 sg13_lv_pmos ad=0.3808p pd=2.92u as=0.2128p ps=1.5u w=1.12u l=0.13u
X1201 VDD.t614 a_4187_2434# a_7151_8160# VDD.t346 sg13_lv_pmos ad=0.3808p pd=2.92u as=0.2128p ps=1.5u w=1.12u l=0.6u
X1202 VSS.t2004 a_3747_1047.t6 a_15831_1008# VSS.t2371 sg13_lv_nmos ad=0.2516p pd=2.16u as=0.2516p ps=2.16u w=0.74u l=0.13u
X1203 VSS.t1133 a_3747_311.t2 a_26985_519# VSS.t1132 sg13_lv_nmos ad=0.2516p pd=2.16u as=0.2516p ps=2.16u w=0.74u l=0.13u
X1204 VSS.t479 a_2019_16074.t5 a_16484_16035# VSS.t2378 sg13_lv_nmos ad=0.2516p pd=2.16u as=0.2516p ps=2.16u w=0.74u l=0.13u
X1205 a_5778_9057# VSS.t1044 VSS.t1043 rppd l=32u w=1u
X1206 VSS.t971 a_13883_1842# a_14317_1842# VSS.t2181 sg13_lv_nmos ad=0.1406p pd=1.12u as=0.2516p ps=2.16u w=0.74u l=0.13u
X1207 a_23871_2470# a_23633_1842# a_23763_1842# VDD.t373 sg13_lv_pmos ad=0.2128p pd=1.5u as=0.3808p ps=2.92u w=1.12u l=0.2u
X1208 VDD.t1376 a_2019_3892.t6 a_13444_3853# VDD.t0 sg13_lv_pmos ad=0.3808p pd=2.92u as=0.3808p ps=2.92u w=1.12u l=0.13u
X1209 a_8433_1842# a_8237_1842# VDD.t927 VDD.t373 sg13_lv_pmos ad=0.3808p pd=2.92u as=0.2128p ps=1.5u w=1.12u l=0.13u
X1210 VDD.t369 a_9323_16869# a_9757_16869# VDD.t368 sg13_lv_pmos ad=0.2128p pd=1.5u as=0.3808p ps=2.92u w=1.12u l=0.13u
X1211 VDD.t136 VSS.t282 VDD.t135 VDD.t5 sg13_lv_pmos ad=0.34p pd=2.68u as=0 ps=0 w=1u l=1u
X1212 VDD.t278 VSS.t333 VDD.t277 VDD.t67 sg13_lv_pmos ad=0.34p pd=2.68u as=0 ps=0 w=1u l=1u
X1213 VDD.t1113 a_18443_1842# a_18877_1842# VDD.t373 sg13_lv_pmos ad=0.2128p pd=1.5u as=0.3808p ps=2.92u w=1.12u l=0.13u
X1214 a_4350_1044# a_2019_1047.t9 a_4248_1044# VSS.t2000 sg13_lv_nmos ad=0.2516p pd=2.16u as=0.1406p ps=1.12u w=0.74u l=0.13u
X1215 a_7288_13226# a_6717_14024# VSS.t1394 VSS.t1393 sg13_lv_nmos ad=0.1406p pd=1.12u as=0.2516p ps=2.16u w=0.74u l=0.13u
X1216 a_25630_16071# a_27124_16035# a_27048_16071# VDD.t90 sg13_lv_pmos ad=0.3808p pd=2.92u as=0.2128p ps=1.5u w=1.12u l=0.13u
X1217 a_16793_14024# a_16597_14024# VSS.t843 VSS.t842 sg13_lv_nmos ad=0.2516p pd=2.16u as=0.1406p ps=1.12u w=0.74u l=0.13u
X1218 VDD.t1111 a_21157_14024# a_21625_13226# VDD.t5 sg13_lv_pmos ad=0.252p pd=1.57u as=0.3808p ps=2.92u w=1.12u l=0.13u
X1219 a_14888_1044# a_14317_1842# VSS.t736 VSS.t1416 sg13_lv_nmos ad=0.1406p pd=1.12u as=0.2516p ps=2.16u w=0.74u l=0.13u
X1220 VDD.t213 VSS.t202 VDD.t211 VDD.t90 sg13_lv_pmos ad=0.19p pd=1.38u as=0 ps=0 w=1u l=1u
X1221 a_22113_1842# a_21917_1842# VDD.t1011 VDD.t373 sg13_lv_pmos ad=0.3808p pd=2.92u as=0.2128p ps=1.5u w=1.12u l=0.13u
X1222 a_10951_4687# a_10713_4687# a_10843_4687# VSS.t1035 sg13_lv_nmos ad=0.1406p pd=1.12u as=0.2516p ps=2.16u w=0.74u l=0.2u
X1223 a_22113_16869# a_21917_16869# VDD.t923 VDD.t368 sg13_lv_pmos ad=0.3808p pd=2.92u as=0.2128p ps=1.5u w=1.12u l=0.13u
X1224 VDD.t1381 a_2019_13229.t4 a_19524_13190# VDD.t5 sg13_lv_pmos ad=0.3808p pd=2.92u as=0.3808p ps=2.92u w=1.12u l=0.13u
X1225 a_12233_14024# a_12037_14024# VSS.t1128 VSS.t1956 sg13_lv_nmos ad=0.2516p pd=2.16u as=0.1406p ps=1.12u w=0.74u l=0.13u
X1226 VDD.t23 VSS.t253 VDD.t22 VDD.t5 sg13_lv_pmos ad=0.34p pd=2.68u as=0 ps=0 w=1u l=1u
X1227 a_16108_289# a_3747_311.t2 a_25630_1044# VSS.t1131 sg13_lv_nmos ad=0.2516p pd=2.16u as=0.2516p ps=2.16u w=0.74u l=0.13u
X1228 VSS.t1670 a_2595_13229.t3 a_23431_13190# VSS.t1669 sg13_lv_nmos ad=0.2516p pd=2.16u as=0.2516p ps=2.16u w=0.74u l=0.13u
X1229 VDD.t400 a_1544_12471# a_2297_12513# VDD.t5 sg13_lv_pmos ad=0.1918p pd=1.5u as=0.1596p ps=1.22u w=0.84u l=0.13u
X1230 a_16510_1044# a_16484_1008# a_16408_1044# VDD.t2 sg13_lv_pmos ad=0.3808p pd=2.92u as=0.2128p ps=1.5u w=1.12u l=0.13u
X1231 VSS.t1039 a_4003_1842# a_4437_1842# VSS.t1896 sg13_lv_nmos ad=0.1406p pd=1.12u as=0.2516p ps=2.16u w=0.74u l=0.13u
X1232 a_25630_3889# a_2595_3892.t2 a_26395_3889# VSS.t1912 sg13_lv_nmos ad=0.2516p pd=2.16u as=0.1406p ps=1.12u w=0.74u l=0.13u
X1233 VDD.t253 VSS.t195 VDD.t251 VDD.t90 sg13_lv_pmos ad=0.19p pd=1.38u as=0 ps=0 w=1u l=1u
X1234 VSS.t1102 a_3747_16074.t4 a_21911_16035# VSS.t1193 sg13_lv_nmos ad=0.2516p pd=2.16u as=0.2516p ps=2.16u w=0.74u l=0.13u
X1235 a_15511_7532# a_15273_7532# a_15403_7532# VSS.t1808 sg13_lv_nmos ad=0.1406p pd=1.12u as=0.2516p ps=2.16u w=0.74u l=0.2u
X1236 VDD.t753 a_4187_2434# a_12471_2470# VDD.t373 sg13_lv_pmos ad=0.3808p pd=2.92u as=0.2128p ps=1.5u w=1.12u l=0.6u
X1237 a_7390_13226# a_2595_13229.t8 a_8155_13226# VSS.t1008 sg13_lv_nmos ad=0.2516p pd=2.16u as=0.1406p ps=1.12u w=0.74u l=0.13u
X1238 VSS.t312 VDD.t1666 VSS.t312 VSS.t315 sg13_lv_nmos ad=79.8f pd=0.8u as=0 ps=0 w=0.42u l=1u
X1239 VDD.t516 a_10083_14024# a_10517_14024# VDD.t374 sg13_lv_pmos ad=0.2128p pd=1.5u as=0.3808p ps=2.92u w=1.12u l=0.13u
X1240 a_19448_6734# a_18877_7532# VDD.t543 VDD.t67 sg13_lv_pmos ad=0.2128p pd=1.5u as=0.3808p ps=2.92u w=1.12u l=0.13u
X1241 VDD.t856 a_3747_3156.t3 a_14825_3364# VDD.t0 sg13_lv_pmos ad=0.3808p pd=2.92u as=0.3808p ps=2.92u w=1.12u l=0.13u
X1242 a_5115_16071# a_4905_16071# VDD.t789 VDD.t90 sg13_lv_pmos ad=0.2128p pd=1.5u as=0.252p ps=1.57u w=1.12u l=0.13u
X1243 a_3747_13229.t0 a_3449_13577# VDD.t901 VDD.t5 sg13_lv_pmos ad=0.2128p pd=1.5u as=0.1918p ps=1.5u w=1.12u l=0.13u
X1244 a_10430_6734# a_11924_6698# a_11848_6734# VDD.t67 sg13_lv_pmos ad=0.3808p pd=2.92u as=0.2128p ps=1.5u w=1.12u l=0.13u
X1245 VDD.t576 a_3171_1047.t2 a_27124_1008# VDD.t2 sg13_lv_pmos ad=0.3808p pd=2.92u as=0.3808p ps=2.92u w=1.12u l=0.13u
X1246 VDD.t1156 a_1256_5979# a_2873_6021# VDD.t67 sg13_lv_pmos ad=0.1918p pd=1.5u as=0.1596p ps=1.22u w=0.84u l=0.13u
X1247 a_6391_14652# a_6153_14024# a_6283_14024# VDD.t374 sg13_lv_pmos ad=0.2128p pd=1.5u as=0.3808p ps=2.92u w=1.12u l=0.2u
X1248 a_4248_3889# a_4157_4158# VDD.t1216 VDD.t0 sg13_lv_pmos ad=0.2128p pd=1.5u as=0.3808p ps=2.92u w=1.12u l=0.13u
X1249 VDD.t1417 a_1256_15316# a_2873_15358# VDD.t90 sg13_lv_pmos ad=0.1918p pd=1.5u as=0.1596p ps=1.22u w=0.84u l=0.13u
X1250 VDD.t1064 a_22243_1842# a_22677_1842# VDD.t373 sg13_lv_pmos ad=0.2128p pd=1.5u as=0.3808p ps=2.92u w=1.12u l=0.13u
X1251 a_6913_16869# a_6717_16869# VDD.t1100 VDD.t368 sg13_lv_pmos ad=0.3808p pd=2.92u as=0.2128p ps=1.5u w=1.12u l=0.13u
X1252 VDD.t1176 a_3747_13229.t3 a_24951_13190# VDD.t5 sg13_lv_pmos ad=0.3808p pd=2.92u as=0.3808p ps=2.92u w=1.12u l=0.13u
X1253 a_3171_3156.t1 a_2873_3176# VSS.t2081 VSS.t1839 sg13_lv_nmos ad=0.1406p pd=1.12u as=0.1331p ps=1.12u w=0.74u l=0.13u
X1254 VDD.t624 a_4187_2434# a_7151_14652# VDD.t374 sg13_lv_pmos ad=0.3808p pd=2.92u as=0.2128p ps=1.5u w=1.12u l=0.6u
X1255 VDD.t978 a_24523_14024# a_24957_14024# VDD.t374 sg13_lv_pmos ad=0.2128p pd=1.5u as=0.3808p ps=2.92u w=1.12u l=0.13u
X1256 VDD.t315 VSS.t265 VDD.t291 VDD.t5 sg13_lv_pmos ad=0.19p pd=1.38u as=0 ps=0 w=1u l=1u
X1257 a_10206_11525# a_10649_11568# a_10589_11604# VDD.t355 sg13_lv_pmos ad=79.8f pd=0.8u as=63f ps=0.72u w=0.42u l=0.13u
X1258 a_18313_7532# a_18117_7532# VDD.t800 VDD.t346 sg13_lv_pmos ad=0.3808p pd=2.92u as=0.2128p ps=1.5u w=1.12u l=0.13u
X1259 a_2595_311.t0 a_2297_331# VDD.t941 VDD.t2 sg13_lv_pmos ad=0.2128p pd=1.5u as=0.1918p ps=1.5u w=1.12u l=0.13u
X1260 VDD.t868 CHAN3_MUX_SEL3 a_3449_331# VDD.t2 sg13_lv_pmos ad=0.1918p pd=1.5u as=0.1596p ps=1.22u w=0.84u l=0.13u
X1261 VDD.t841 a_13019_11521# a_12943_11557# VDD.t355 sg13_lv_pmos ad=0.2128p pd=1.5u as=0.2128p ps=1.5u w=1.12u l=0.13u
X1262 a_9431_8160# a_9193_7532# a_9323_7532# VDD.t346 sg13_lv_pmos ad=0.2128p pd=1.5u as=0.3808p ps=2.92u w=1.12u l=0.2u
X1263 a_10430_1044# a_11271_1008# a_11195_1044# VDD.t2 sg13_lv_pmos ad=0.3808p pd=2.92u as=0.2128p ps=1.5u w=1.12u l=0.13u
X1264 VDD.t182 VSS.t209 VDD.t180 VDD.t90 sg13_lv_pmos ad=0.19p pd=1.38u as=0 ps=0 w=1u l=1u
X1265 VSS.t2093 a_2297_3176# a_2595_3156.t1 VSS.t1775 sg13_lv_nmos ad=0.2812p pd=2.24u as=0.1406p ps=1.12u w=0.74u l=0.13u
X1266 VSS.t476 a_4187_1764.t45 a_19311_4687# VSS.t1727 sg13_lv_nmos ad=0.2516p pd=2.16u as=0.1406p ps=1.12u w=0.74u l=0.6u
X1267 VSS.t914 a_3747_16074.t9 a_6711_16035# VSS.t2245 sg13_lv_nmos ad=0.2516p pd=2.16u as=0.2516p ps=2.16u w=0.74u l=0.13u
X1268 a_26395_13226# a_26185_13226# VSS.t940 VSS.t2091 sg13_lv_nmos ad=0.1406p pd=1.12u as=0.1665p ps=1.19u w=0.74u l=0.13u
X1269 a_17275_6734# a_17065_6734# VSS.t1151 VSS.t1150 sg13_lv_nmos ad=0.1406p pd=1.12u as=0.1665p ps=1.19u w=0.74u l=0.13u
X1270 VSS.t1271 a_9444_10280# a_9444_10280# VSS.t1270 sg13_lv_nmos ad=0.68p pd=4.68u as=0.38p ps=2.38u w=2u l=1u
X1271 a_23355_1044# a_23145_1044# VDD.t939 VDD.t2 sg13_lv_pmos ad=0.2128p pd=1.5u as=0.252p ps=1.57u w=1.12u l=0.13u
X1272 a_19550_3889# a_21911_3853# a_21835_3889# VDD.t0 sg13_lv_pmos ad=0.3808p pd=2.92u as=0.2128p ps=1.5u w=1.12u l=0.13u
X1273 VSS.t1074 a_2873_13577# a_3171_13229.t1 VSS.t1075 sg13_lv_nmos ad=0.2812p pd=2.24u as=0.1406p ps=1.12u w=0.74u l=0.13u
X1274 VSS.t1032 a_3747_6737.t6 a_15831_6698# VSS.t1789 sg13_lv_nmos ad=0.2516p pd=2.16u as=0.2516p ps=2.16u w=0.74u l=0.13u
X1275 VSS.t1169 a_5957_4687# a_6425_3889# VSS.t1168 sg13_lv_nmos ad=0.1665p pd=1.19u as=0.2516p ps=2.16u w=0.74u l=0.13u
X1276 VSS.t247 VDD.t1685 VSS.t246 VSS.t245 sg13_lv_nmos ad=0.1428p pd=1.52u as=0 ps=0 w=0.42u l=1u
X1277 a_10649_11568# REF_CLK VSS.t96 VSS.t130 sg13_lv_nmos ad=0.2516p pd=2.16u as=1.9998p ps=12.915u w=0.74u l=0.13u
X1278 VDD.t571 a_3747_1047.t4 a_21911_1008# VDD.t2 sg13_lv_pmos ad=0.3808p pd=2.92u as=0.3808p ps=2.92u w=1.12u l=0.13u
X1279 VSS.t1046 a_8997_1842# a_9465_1044# VSS.t1902 sg13_lv_nmos ad=0.1665p pd=1.19u as=0.2516p ps=2.16u w=0.74u l=0.13u
X1280 a_17791_14024# a_17553_14024# a_17683_14024# VSS.t1409 sg13_lv_nmos ad=0.1406p pd=1.12u as=0.2516p ps=2.16u w=0.74u l=0.2u
X1281 a_23871_8160# a_23633_7532# a_23763_7532# VDD.t346 sg13_lv_pmos ad=0.2128p pd=1.5u as=0.3808p ps=2.92u w=1.12u l=0.2u
X1282 VSS.t65 a_13883_7532# a_14317_7532# VSS.t2294 sg13_lv_nmos ad=0.1406p pd=1.12u as=0.2516p ps=2.16u w=0.74u l=0.13u
X1283 a_1721_3176# a_1256_3134# VDD.t1431 VDD.t0 sg13_lv_pmos ad=0.1596p pd=1.22u as=0.2856p ps=2.36u w=0.84u l=0.13u
X1284 a_8433_7532# a_8237_7532# VDD.t896 VDD.t346 sg13_lv_pmos ad=0.3808p pd=2.92u as=0.2128p ps=1.5u w=1.12u l=0.13u
X1285 a_25630_6734# a_26471_6698# a_26395_6734# VDD.t67 sg13_lv_pmos ad=0.3808p pd=2.92u as=0.2128p ps=1.5u w=1.12u l=0.13u
X1286 a_23111_17497# a_22873_16869# a_23003_16869# VDD.t368 sg13_lv_pmos ad=0.2128p pd=1.5u as=0.3808p ps=2.92u w=1.12u l=0.2u
X1287 VDD.t1108 a_9323_14024# a_9757_14024# VDD.t374 sg13_lv_pmos ad=0.2128p pd=1.5u as=0.3808p ps=2.92u w=1.12u l=0.13u
X1288 VDD.t819 a_3747_13229.t8 a_9751_13190# VDD.t5 sg13_lv_pmos ad=0.3808p pd=2.92u as=0.3808p ps=2.92u w=1.12u l=0.13u
X1289 VSS.t59 a_4187_1764.t58 a_9431_4687# VSS.t1823 sg13_lv_nmos ad=0.2516p pd=2.16u as=0.1406p ps=1.12u w=0.74u l=0.6u
X1290 VDD.t542 a_18443_7532# a_18877_7532# VDD.t346 sg13_lv_pmos ad=0.2128p pd=1.5u as=0.3808p ps=2.92u w=1.12u l=0.13u
X1291 VDD.t138 VSS.t379 VDD.t137 VDD.t0 sg13_lv_pmos ad=0.34p pd=2.68u as=0 ps=0 w=1u l=1u
X1292 VSS.t1412 a_4187_1764.t112 a_18551_14024# VSS.t1662 sg13_lv_nmos ad=0.2516p pd=2.16u as=0.1406p ps=1.12u w=0.74u l=0.6u
X1293 a_4350_6734# a_2019_6737.t9 a_4248_6734# VSS.t1708 sg13_lv_nmos ad=0.2516p pd=2.16u as=0.1406p ps=1.12u w=0.74u l=0.13u
X1294 a_22113_7532# a_21917_7532# VDD.t960 VDD.t346 sg13_lv_pmos ad=0.3808p pd=2.92u as=0.2128p ps=1.5u w=1.12u l=0.13u
X1295 a_14888_6734# a_14317_7532# VSS.t63 VSS.t62 sg13_lv_nmos ad=0.1406p pd=1.12u as=0.2516p ps=2.16u w=0.74u l=0.13u
X1296 VDD.t1384 a_2595_13229.t9 a_5191_13190# VDD.t5 sg13_lv_pmos ad=0.3808p pd=2.92u as=0.3808p ps=2.92u w=1.12u l=0.13u
X1297 VDD.t201 VSS.t272 VDD.t200 VDD.t5 sg13_lv_pmos ad=0.19p pd=1.38u as=0 ps=0 w=1u l=1u
X1298 VDD.t1158 a_2019_16074.t6 a_13444_16035# VDD.t90 sg13_lv_pmos ad=0.3808p pd=2.92u as=0.3808p ps=2.92u w=1.12u l=0.13u
X1299 a_20968_1044# a_20397_1842# VDD.t520 VDD.t2 sg13_lv_pmos ad=0.2128p pd=1.5u as=0.3808p ps=2.92u w=1.12u l=0.13u
X1300 a_25153_4687# a_24957_4687# VDD.t361 VDD.t348 sg13_lv_pmos ad=0.3808p pd=2.92u as=0.2128p ps=1.5u w=1.12u l=0.13u
X1301 a_9675_16071# a_9465_16071# VSS.t1844 VSS.t1920 sg13_lv_nmos ad=0.1406p pd=1.12u as=0.1665p ps=1.19u w=0.74u l=0.13u
X1302 VDD.t408 a_12849_11557# a_13566_11525# VDD.t355 sg13_lv_pmos ad=0.1563p pd=1.22u as=0.147p ps=1.54u w=0.42u l=0.13u
X1303 a_10951_1842# a_10713_1842# a_10843_1842# VSS.t1470 sg13_lv_nmos ad=0.1406p pd=1.12u as=0.2516p ps=2.16u w=0.74u l=0.2u
X1304 VDD.t1128 a_22677_4687# a_23145_3889# VDD.t0 sg13_lv_pmos ad=0.252p pd=1.57u as=0.3808p ps=2.92u w=1.12u l=0.13u
X1305 VSS.t112 a_4187_1764.t40 a_23111_4687# VSS.t111 sg13_lv_nmos ad=0.2516p pd=2.16u as=0.1406p ps=1.12u w=0.74u l=0.6u
X1306 a_22113_14024# a_21917_14024# VDD.t1056 VDD.t374 sg13_lv_pmos ad=0.3808p pd=2.92u as=0.2128p ps=1.5u w=1.12u l=0.13u
X1307 a_6635_13226# a_6425_13226# VSS.t2062 VSS.t2061 sg13_lv_nmos ad=0.1406p pd=1.12u as=0.1665p ps=1.19u w=0.74u l=0.13u
X1308 VSS.t2022 a_2019_3892.t6 a_13444_3853# VSS.t2021 sg13_lv_nmos ad=0.2516p pd=2.16u as=0.2516p ps=2.16u w=0.74u l=0.13u
X1309 VSS.t657 a_4003_7532# a_4437_7532# VSS.t656 sg13_lv_nmos ad=0.1406p pd=1.12u as=0.2516p ps=2.16u w=0.74u l=0.13u
X1310 VSS.t2004 a_2019_1047.t5 a_16484_1008# VSS.t2003 sg13_lv_nmos ad=0.2516p pd=2.16u as=0.2516p ps=2.16u w=0.74u l=0.13u
X1311 VDD.t168 VSS.t312 VDD.t166 VDD.t67 sg13_lv_pmos ad=0.19p pd=1.38u as=0 ps=0 w=1u l=1u
X1312 a_26151_2470# a_25913_1842# a_26043_1842# VDD.t373 sg13_lv_pmos ad=0.2128p pd=1.5u as=0.3808p ps=2.92u w=1.12u l=0.2u
X1313 VDD.t696 a_4187_2434# a_12471_8160# VDD.t346 sg13_lv_pmos ad=0.3808p pd=2.92u as=0.2128p ps=1.5u w=1.12u l=0.6u
X1314 VDD.t1535 a_1721_331# a_2019_311.t0 VDD.t2 sg13_lv_pmos ad=0.4256p pd=3u as=0.2128p ps=1.5u w=1.12u l=0.13u
X1315 a_7911_17497# a_7673_16869# a_7803_16869# VDD.t368 sg13_lv_pmos ad=0.2128p pd=1.5u as=0.3808p ps=2.92u w=1.12u l=0.2u
X1316 a_16033_16869# a_15837_16869# VSS.t574 VSS.t1051 sg13_lv_nmos ad=0.2516p pd=2.16u as=0.1406p ps=1.12u w=0.74u l=0.13u
X1317 a_13753_1842# a_13557_1842# VDD.t538 VDD.t373 sg13_lv_pmos ad=0.3808p pd=2.92u as=0.2128p ps=1.5u w=1.12u l=0.13u
X1318 VSS.t305 VDD.t1670 VSS.t305 VSS.t306 sg13_lv_nmos ad=79.8f pd=0.8u as=0 ps=0 w=0.42u l=1u
X1319 VSS.t430 VDD.t1626 VSS.t430 VSS.t432 sg13_lv_nmos ad=79.8f pd=0.8u as=0 ps=0 w=0.42u l=1u
X1320 VSS.t733 a_3171_1047.t9 a_5844_1008# VSS.t732 sg13_lv_nmos ad=0.2516p pd=2.16u as=0.2516p ps=2.16u w=0.74u l=0.13u
X1321 a_4871_2470# a_4633_1842# a_4763_1842# VDD.t373 sg13_lv_pmos ad=0.2128p pd=1.5u as=0.3808p ps=2.92u w=1.12u l=0.2u
X1322 VDD.t636 a_4187_2434# a_8671_17497# VDD.t368 sg13_lv_pmos ad=0.3808p pd=2.92u as=0.2128p ps=1.5u w=1.12u l=0.6u
X1323 a_19550_13226# a_2019_13229.t4 a_19448_13226# VSS.t2034 sg13_lv_nmos ad=0.2516p pd=2.16u as=0.1406p ps=1.12u w=0.74u l=0.13u
X1324 VDD.t877 a_1256_12471# a_2873_12513# VDD.t5 sg13_lv_pmos ad=0.1918p pd=1.5u as=0.1596p ps=1.22u w=0.84u l=0.13u
X1325 VDD.t412 a_22243_7532# a_22677_7532# VDD.t346 sg13_lv_pmos ad=0.2128p pd=1.5u as=0.3808p ps=2.92u w=1.12u l=0.13u
X1326 VDD.t890 a_2595_311.t2 a_20905_519# VDD.t2 sg13_lv_pmos ad=0.3808p pd=2.92u as=0.3808p ps=2.92u w=1.12u l=0.13u
X1327 VDD.t925 a_26043_16869# a_26477_16869# VDD.t368 sg13_lv_pmos ad=0.2128p pd=1.5u as=0.3808p ps=2.92u w=1.12u l=0.13u
X1328 VDD.t379 a_5957_7532# a_6425_6734# VDD.t67 sg13_lv_pmos ad=0.252p pd=1.57u as=0.3808p ps=2.92u w=1.12u l=0.13u
X1329 VDD.t1097 a_2297_331# a_2595_311.t0 VDD.t2 sg13_lv_pmos ad=0.4256p pd=3u as=0.2128p ps=1.5u w=1.12u l=0.13u
X1330 VDD.t1091 a_2595_6001.t3 a_8745_6209# VDD.t67 sg13_lv_pmos ad=0.3808p pd=2.92u as=0.3808p ps=2.92u w=1.12u l=0.13u
X1331 a_16510_16071# a_3171_16074.t5 a_17928_16071# VSS.t658 sg13_lv_nmos ad=0.2516p pd=2.16u as=0.1406p ps=1.12u w=0.74u l=0.13u
X1332 a_6913_14024# a_6717_14024# VDD.t1043 VDD.t374 sg13_lv_pmos ad=0.3808p pd=2.92u as=0.2128p ps=1.5u w=1.12u l=0.13u
X1333 a_8155_13226# a_7945_13226# VDD.t1326 VDD.t5 sg13_lv_pmos ad=0.2128p pd=1.5u as=0.252p ps=1.57u w=1.12u l=0.13u
X1334 VSS.t379 VDD.t1638 VSS.t384 VSS.t383 sg13_lv_nmos ad=0.1428p pd=1.52u as=0 ps=0 w=0.42u l=1u
X1335 VSS.t514 VSS.t512 VSS.t512 VSS.t513 sg13_lv_nmos ad=0.68p pd=4.68u as=0 ps=0 w=2u l=1u
X1336 VSS.t725 a_2595_1047.t7 a_11271_1008# VSS.t724 sg13_lv_nmos ad=0.2516p pd=2.16u as=0.2516p ps=2.16u w=0.74u l=0.13u
X1337 VSS.t81 a_4187_1764.t13 a_19311_1842# VSS.t972 sg13_lv_nmos ad=0.2516p pd=2.16u as=0.1406p ps=1.12u w=0.74u l=0.6u
X1338 a_5731_3134# a_2595_3156.t3 a_7390_3889# VSS.t781 sg13_lv_nmos ad=0.2516p pd=2.16u as=0.2516p ps=2.16u w=0.74u l=0.13u
X1339 VSS.t388 VDD.t1637 VSS.t387 VSS.t386 sg13_lv_nmos ad=0.1428p pd=1.52u as=0 ps=0 w=0.42u l=1u
X1340 a_3171_6737.t0 a_2873_7085# VDD.t1022 VDD.t67 sg13_lv_pmos ad=0.2128p pd=1.5u as=0.1918p ps=1.5u w=1.12u l=0.13u
X1341 a_4248_3889# a_4157_4158# VSS.t1508 VSS.t1759 sg13_lv_nmos ad=0.1406p pd=1.12u as=0.2516p ps=2.16u w=0.74u l=0.13u
X1342 a_1815_13577# a_1256_13226# a_1721_13577# VSS.t1910 sg13_lv_nmos ad=0.1216p pd=1.02u as=0.2176p ps=1.96u w=0.64u l=0.13u
X1343 VSS.t1602 a_8997_7532# a_9465_6734# VSS.t1601 sg13_lv_nmos ad=0.1665p pd=1.19u as=0.2516p ps=2.16u w=0.74u l=0.13u
X1344 VDD.t782 a_2297_7085# a_2595_6737.t0 VDD.t67 sg13_lv_pmos ad=0.4256p pd=3u as=0.2128p ps=1.5u w=1.12u l=0.13u
X1345 VDD.t957 a_24523_1842# a_24957_1842# VDD.t373 sg13_lv_pmos ad=0.2128p pd=1.5u as=0.3808p ps=2.92u w=1.12u l=0.13u
X1346 VSS.t1048 a_4763_16869# a_5197_16869# VSS.t1237 sg13_lv_nmos ad=0.1406p pd=1.12u as=0.2516p ps=2.16u w=0.74u l=0.13u
X1347 VDD.t885 a_2019_6737.t6 a_13444_6698# VDD.t67 sg13_lv_pmos ad=0.3808p pd=2.92u as=0.3808p ps=2.92u w=1.12u l=0.13u
X1348 a_15270_10795# a_12849_11557# VSS.t163 VSS.t162 sg13_lv_nmos ad=37.8f pd=0.6u as=79.8f ps=0.8u w=0.42u l=0.13u
X1349 VSS.t1402 a_3747_1047.t8 a_9751_1008# VSS.t1855 sg13_lv_nmos ad=0.2516p pd=2.16u as=0.2516p ps=2.16u w=0.74u l=0.13u
X1350 VSS.t473 a_12907_10876# a_12907_10876# VSS.t1265 sg13_lv_nmos ad=1.45407p pd=9.445u as=0.111p ps=1.34u w=0.3u l=0.13u
X1351 a_8808_13226# a_8237_14024# VSS.t1010 VSS.t1946 sg13_lv_nmos ad=0.1406p pd=1.12u as=0.2516p ps=2.16u w=0.74u l=0.13u
X1352 a_23111_14652# a_22873_14024# a_23003_14024# VDD.t374 sg13_lv_pmos ad=0.2128p pd=1.5u as=0.3808p ps=2.92u w=1.12u l=0.2u
X1353 a_6126_9506# a_5974_11413# a_6326_10280# VSS.t49 sg13_lv_nmos ad=0.68p pd=4.68u as=0.38p ps=2.38u w=2u l=1u
X1354 VSS.t711 a_4187_1764.t26 a_9431_1842# VSS.t710 sg13_lv_nmos ad=0.2516p pd=2.16u as=0.1406p ps=1.12u w=0.74u l=0.6u
X1355 a_19448_1044# a_18877_1842# VDD.t1114 VDD.t2 sg13_lv_pmos ad=0.2128p pd=1.5u as=0.3808p ps=2.92u w=1.12u l=0.13u
X1356 a_10430_3889# a_12791_3853# a_12715_3889# VDD.t0 sg13_lv_pmos ad=0.3808p pd=2.92u as=0.2128p ps=1.5u w=1.12u l=0.13u
X1357 a_7288_16071# a_6717_16869# VSS.t914 VSS.t2173 sg13_lv_nmos ad=0.1406p pd=1.12u as=0.2516p ps=2.16u w=0.74u l=0.13u
X1358 a_10430_1044# a_11924_1008# a_11848_1044# VDD.t2 sg13_lv_pmos ad=0.3808p pd=2.92u as=0.2128p ps=1.5u w=1.12u l=0.13u
X1359 a_19550_3889# a_3747_3892.t4 a_21835_3889# VSS.t1679 sg13_lv_nmos ad=0.2516p pd=2.16u as=0.1406p ps=1.12u w=0.74u l=0.13u
X1360 VDD.t305 VSS.t225 VDD.t1614 VDD.t90 sg13_lv_pmos ad=0.34p pd=2.68u as=0 ps=0 w=1u l=1u
X1361 a_4248_13226# a_4157_13495# VSS.t2030 VSS.t2055 sg13_lv_nmos ad=0.1406p pd=1.12u as=0.2516p ps=2.16u w=0.74u l=0.13u
X1362 a_2297_7085# REF_MUX_SEL0 VDD.t1467 VDD.t67 sg13_lv_pmos ad=0.1596p pd=1.22u as=0.2856p ps=2.36u w=0.84u l=0.13u
X1363 a_24875_3889# a_24665_3889# VDD.t1028 VDD.t0 sg13_lv_pmos ad=0.2128p pd=1.5u as=0.252p ps=1.57u w=1.12u l=0.13u
X1364 a_13753_14024# a_13557_14024# VSS.t1869 VSS.t1967 sg13_lv_nmos ad=0.2516p pd=2.16u as=0.1406p ps=1.12u w=0.74u l=0.13u
X1365 VSS.t685 a_11603_4687# a_12037_4687# VSS.t2234 sg13_lv_nmos ad=0.1406p pd=1.12u as=0.2516p ps=2.16u w=0.74u l=0.13u
X1366 a_10951_7532# a_10713_7532# a_10843_7532# VSS.t1360 sg13_lv_nmos ad=0.1406p pd=1.12u as=0.2516p ps=2.16u w=0.74u l=0.2u
X1367 VSS.t1661 a_4187_1764.t8 a_23111_1842# VSS.t1660 sg13_lv_nmos ad=0.2516p pd=2.16u as=0.1406p ps=1.12u w=0.74u l=0.6u
X1368 a_17791_5315# a_17553_4687# a_17683_4687# VDD.t348 sg13_lv_pmos ad=0.2128p pd=1.5u as=0.3808p ps=2.92u w=1.12u l=0.2u
X1369 VDD.t876 a_1544_6734# a_1721_7085# VDD.t67 sg13_lv_pmos ad=0.1918p pd=1.5u as=0.1596p ps=1.22u w=0.84u l=0.13u
X1370 VDD.t824 a_2595_3892.t3 a_23431_3853# VDD.t0 sg13_lv_pmos ad=0.3808p pd=2.92u as=0.3808p ps=2.92u w=1.12u l=0.13u
X1371 VSS.t582 a_2595_16074.t3 a_23431_16035# VSS.t1554 sg13_lv_nmos ad=0.2516p pd=2.16u as=0.2516p ps=2.16u w=0.74u l=0.13u
X1372 VDD.t1380 a_2019_13229.t5 a_16484_13190# VDD.t5 sg13_lv_pmos ad=0.3808p pd=2.92u as=0.3808p ps=2.92u w=1.12u l=0.13u
X1373 VSS.t1032 a_2019_6737.t5 a_16484_6698# VSS.t1113 sg13_lv_nmos ad=0.2516p pd=2.16u as=0.2516p ps=2.16u w=0.74u l=0.13u
X1374 VDD.t766 a_4187_2434# a_27671_2470# VDD.t373 sg13_lv_pmos ad=0.3808p pd=2.92u as=0.2128p ps=1.5u w=1.12u l=0.6u
X1375 a_24393_4687# a_24197_4687# VSS.t1362 VSS.t1361 sg13_lv_nmos ad=0.2516p pd=2.16u as=0.1406p ps=1.12u w=0.74u l=0.13u
X1376 a_7390_13226# a_3747_13229.t8 a_9675_13226# VSS.t952 sg13_lv_nmos ad=0.2516p pd=2.16u as=0.1406p ps=1.12u w=0.74u l=0.13u
X1377 VSS.t1016 a_2595_13229.t4 a_20391_13190# VSS.t1015 sg13_lv_nmos ad=0.2516p pd=2.16u as=0.2516p ps=2.16u w=0.74u l=0.13u
X1378 a_26151_8160# a_25913_7532# a_26043_7532# VDD.t346 sg13_lv_pmos ad=0.2128p pd=1.5u as=0.3808p ps=2.92u w=1.12u l=0.2u
X1379 VDD.t118 VSS.t358 VDD.t116 VDD.t0 sg13_lv_pmos ad=0.19p pd=1.38u as=0 ps=0 w=1u l=1u
X1380 VSS.t346 VDD.t1654 VSS.t346 VSS.t348 sg13_lv_nmos ad=79.8f pd=0.8u as=0 ps=0 w=0.42u l=1u
X1381 a_7390_16071# a_2595_16074.t8 a_8155_16071# VSS.t108 sg13_lv_nmos ad=0.2516p pd=2.16u as=0.1406p ps=1.12u w=0.74u l=0.13u
X1382 VDD.t331 VSS.t188 VDD.t332 VDD.t90 sg13_lv_pmos ad=0.19p pd=1.38u as=0 ps=0 w=1u l=1u
X1383 a_9444_10280# a_6854_11144# a_6854_11144# VSS.t138 sg13_lv_nmos ad=0.68p pd=4.68u as=0.38p ps=2.38u w=2u l=1u
X1384 VDD.t97 VSS.t305 VDD.t98 VDD.t67 sg13_lv_pmos ad=0.19p pd=1.38u as=0 ps=0 w=1u l=1u
X1385 a_7911_14652# a_7673_14024# a_7803_14024# VDD.t374 sg13_lv_pmos ad=0.2128p pd=1.5u as=0.3808p ps=2.92u w=1.12u l=0.2u
X1386 VDD.t906 a_13557_4687# a_14025_3889# VDD.t0 sg13_lv_pmos ad=0.252p pd=1.57u as=0.3808p ps=2.92u w=1.12u l=0.13u
X1387 a_13753_7532# a_13557_7532# VDD.t1548 VDD.t346 sg13_lv_pmos ad=0.3808p pd=2.92u as=0.2128p ps=1.5u w=1.12u l=0.13u
X1388 VSS.t808 a_4187_1764.t98 VSS.t810 VSS.t809 sg13_lv_nmos ad=1.33p pd=7.38u as=0 ps=0 w=7u l=7u
X1389 a_4871_8160# a_4633_7532# a_4763_7532# VDD.t346 sg13_lv_pmos ad=0.2128p pd=1.5u as=0.3808p ps=2.92u w=1.12u l=0.2u
X1390 VSS.t45 a_3171_6737.t9 a_5844_6698# VSS.t1432 sg13_lv_nmos ad=0.2516p pd=2.16u as=0.2516p ps=2.16u w=0.74u l=0.13u
X1391 a_4248_6734# a_4157_7003# VDD.t395 VDD.t67 sg13_lv_pmos ad=0.2128p pd=1.5u as=0.3808p ps=2.92u w=1.12u l=0.13u
X1392 VSS.t1562 a_22677_4687# a_23145_3889# VSS.t1561 sg13_lv_nmos ad=0.1665p pd=1.19u as=0.2516p ps=2.16u w=0.74u l=0.13u
X1393 VSS.t1342 a_4187_1764.t51 a_14751_4687# VSS.t1408 sg13_lv_nmos ad=0.2516p pd=2.16u as=0.1406p ps=1.12u w=0.74u l=0.6u
X1394 VDD.t1366 a_1721_16422# a_2019_16074.t0 VDD.t90 sg13_lv_pmos ad=0.4256p pd=3u as=0.2128p ps=1.5u w=1.12u l=0.13u
X1395 VDD.t669 a_4187_2434# a_8671_14652# VDD.t374 sg13_lv_pmos ad=0.3808p pd=2.92u as=0.2128p ps=1.5u w=1.12u l=0.6u
X1396 VDD.t514 a_1256_3889# a_2873_4240# VDD.t0 sg13_lv_pmos ad=0.1918p pd=1.5u as=0.1596p ps=1.22u w=0.84u l=0.13u
X1397 VDD.t882 a_26043_14024# a_26477_14024# VDD.t374 sg13_lv_pmos ad=0.2128p pd=1.5u as=0.3808p ps=2.92u w=1.12u l=0.13u
X1398 VDD.t601 a_2595_3156.t3 a_8745_3364# VDD.t0 sg13_lv_pmos ad=0.3808p pd=2.92u as=0.3808p ps=2.92u w=1.12u l=0.13u
X1399 a_25630_1044# a_26471_1008# a_26395_1044# VDD.t2 sg13_lv_pmos ad=0.3808p pd=2.92u as=0.2128p ps=1.5u w=1.12u l=0.13u
X1400 a_3171_6001.t1 a_2873_6021# VSS.t1614 VSS.t1613 sg13_lv_nmos ad=0.1406p pd=1.12u as=0.1331p ps=1.12u w=0.74u l=0.13u
X1401 a_27915_13226# a_27705_13226# VSS.t1908 VSS.t2099 sg13_lv_nmos ad=0.1406p pd=1.12u as=0.1665p ps=1.19u w=0.74u l=0.13u
X1402 VDD.t1122 a_3747_13229.t4 a_21911_13190# VDD.t5 sg13_lv_pmos ad=0.3808p pd=2.92u as=0.3808p ps=2.92u w=1.12u l=0.13u
X1403 VSS.t1386 a_2595_6737.t7 a_11271_6698# VSS.t1385 sg13_lv_nmos ad=0.2516p pd=2.16u as=0.2516p ps=2.16u w=0.74u l=0.13u
X1404 VSS.t1566 a_4187_1764.t77 a_19311_7532# VSS.t2355 sg13_lv_nmos ad=0.2516p pd=2.16u as=0.1406p ps=1.12u w=0.74u l=0.6u
X1405 a_21591_5315# a_21353_4687# a_21483_4687# VDD.t348 sg13_lv_pmos ad=0.2128p pd=1.5u as=0.3808p ps=2.92u w=1.12u l=0.2u
X1406 VSS.t1142 a_2297_6021# a_2595_6001.t1 VSS.t1796 sg13_lv_nmos ad=0.2812p pd=2.24u as=0.1406p ps=1.12u w=0.74u l=0.13u
X1407 a_26395_16071# a_26185_16071# VSS.t1995 VSS.t1994 sg13_lv_nmos ad=0.1406p pd=1.12u as=0.1665p ps=1.19u w=0.74u l=0.13u
X1408 VSS.t509 VSS.t509 VSS.t511 VSS.t510 sg13_lv_nmos ad=0.68p pd=4.68u as=0 ps=0 w=2u l=1u
X1409 VSS.t810 a_4187_1764.t98 VSS.t812 VSS.t811 sg13_lv_nmos ad=1.33p pd=7.38u as=0 ps=0 w=7u l=7u
X1410 VSS.t755 a_4187_1764.t65 a_4111_4687# VSS.t927 sg13_lv_nmos ad=0.2516p pd=2.16u as=0.1406p ps=1.12u w=0.74u l=0.6u
X1411 a_6153_4687# a_5957_4687# VDD.t802 VDD.t348 sg13_lv_pmos ad=0.3808p pd=2.92u as=0.2128p ps=1.5u w=1.12u l=0.13u
X1412 a_23355_13226# a_23145_13226# VSS.t2101 VSS.t2100 sg13_lv_nmos ad=0.1406p pd=1.12u as=0.1665p ps=1.19u w=0.74u l=0.13u
X1413 a_2595_12493.t1 a_2297_12513# VSS.t149 VSS.t627 sg13_lv_nmos ad=0.1406p pd=1.12u as=0.1331p ps=1.12u w=0.74u l=0.13u
X1414 a_19550_6734# a_21911_6698# a_21835_6734# VDD.t67 sg13_lv_pmos ad=0.3808p pd=2.92u as=0.2128p ps=1.5u w=1.12u l=0.13u
X1415 VSS.t1754 a_2873_16422# a_3171_16074.t1 VSS.t1805 sg13_lv_nmos ad=0.2812p pd=2.24u as=0.1406p ps=1.12u w=0.74u l=0.13u
X1416 VDD.t919 a_16163_4687# a_16597_4687# VDD.t348 sg13_lv_pmos ad=0.2128p pd=1.5u as=0.3808p ps=2.92u w=1.12u l=0.13u
X1417 a_16033_1842# a_15837_1842# VDD.t541 VDD.t373 sg13_lv_pmos ad=0.3808p pd=2.92u as=0.2128p ps=1.5u w=1.12u l=0.13u
X1418 VDD.t394 a_24523_7532# a_24957_7532# VDD.t346 sg13_lv_pmos ad=0.2128p pd=1.5u as=0.3808p ps=2.92u w=1.12u l=0.13u
X1419 a_7151_2470# a_6913_1842# a_7043_1842# VDD.t373 sg13_lv_pmos ad=0.2128p pd=1.5u as=0.3808p ps=2.92u w=1.12u l=0.2u
X1420 VDD.t777 a_15964_289# a_16851_309# VDD.t2 sg13_lv_pmos ad=0.2086p pd=1.5u as=0.34p ps=2.68u w=1u l=0.13u
X1421 a_24631_17497# a_24393_16869# a_24523_16869# VDD.t368 sg13_lv_pmos ad=0.2128p pd=1.5u as=0.3808p ps=2.92u w=1.12u l=0.2u
X1422 VSS.t1712 a_3747_6737.t8 a_9751_6698# VSS.t1888 sg13_lv_nmos ad=0.2516p pd=2.16u as=0.2516p ps=2.16u w=0.74u l=0.13u
X1423 VDD.t309 VSS.t443 VDD.t308 VDD.t2 sg13_lv_pmos ad=0.34p pd=2.68u as=0 ps=0 w=1u l=1u
X1424 VSS.t925 CHAN2_MUX_SEL3 a_3543_3176# VSS.t924 sg13_lv_nmos ad=0.1331p pd=1.12u as=0.1216p ps=1.02u w=0.64u l=0.13u
X1425 a_14751_14024# a_14513_14024# a_14643_14024# VSS.t2328 sg13_lv_nmos ad=0.1406p pd=1.12u as=0.2516p ps=2.16u w=0.74u l=0.2u
X1426 a_19073_14024# a_18877_14024# VSS.t1412 VSS.t2179 sg13_lv_nmos ad=0.2516p pd=2.16u as=0.1406p ps=1.12u w=0.74u l=0.13u
X1427 VSS.t152 a_4187_1764.t90 a_9431_7532# VSS.t633 sg13_lv_nmos ad=0.2516p pd=2.16u as=0.1406p ps=1.12u w=0.74u l=0.6u
X1428 VDD.t653 a_4187_2434# a_25391_17497# VDD.t368 sg13_lv_pmos ad=0.3808p pd=2.92u as=0.2128p ps=1.5u w=1.12u l=0.6u
X1429 VDD.t1119 a_3747_13229.t9 a_6711_13190# VDD.t5 sg13_lv_pmos ad=0.3808p pd=2.92u as=0.3808p ps=2.92u w=1.12u l=0.13u
X1430 VSS.t365 VDD.t1645 VSS.t365 VSS.t368 sg13_lv_nmos ad=79.8f pd=0.8u as=0 ps=0 w=0.42u l=1u
X1431 a_20071_17497# a_19833_16869# a_19963_16869# VDD.t368 sg13_lv_pmos ad=0.2128p pd=1.5u as=0.3808p ps=2.92u w=1.12u l=0.2u
X1432 a_2391_13577# CHAN1_MUX_SEL0 a_2297_13577# VSS.t760 sg13_lv_nmos ad=0.1216p pd=1.02u as=0.2176p ps=1.96u w=0.64u l=0.13u
X1433 VDD.t733 a_4187_2434# a_10191_5315# VDD.t348 sg13_lv_pmos ad=0.3808p pd=2.92u as=0.2128p ps=1.5u w=1.12u l=0.6u
X1434 VDD.t1333 a_5957_1842# a_6425_1044# VDD.t2 sg13_lv_pmos ad=0.252p pd=1.57u as=0.3808p ps=2.92u w=1.12u l=0.13u
X1435 VSS.t446 VDD.t1622 VSS.t449 VSS.t448 sg13_lv_nmos ad=79.8f pd=0.8u as=0 ps=0 w=0.42u l=1u
X1436 VSS.t1249 a_11603_1842# a_12037_1842# VSS.t1905 sg13_lv_nmos ad=0.1406p pd=1.12u as=0.2516p ps=2.16u w=0.74u l=0.13u
X1437 VSS.t1030 a_4187_1764.t72 a_23111_7532# VSS.t1095 sg13_lv_nmos ad=0.2516p pd=2.16u as=0.1406p ps=1.12u w=0.74u l=0.6u
X1438 VDD.t411 a_22677_7532# a_23145_6734# VDD.t67 sg13_lv_pmos ad=0.252p pd=1.57u as=0.3808p ps=2.92u w=1.12u l=0.13u
X1439 VDD.t1193 a_2019_16074.t7 a_10404_16035# VDD.t90 sg13_lv_pmos ad=0.3808p pd=2.92u as=0.3808p ps=2.92u w=1.12u l=0.13u
X1440 VDD.t160 VSS.t415 VDD.t159 VDD.t2 sg13_lv_pmos ad=0.34p pd=2.68u as=0 ps=0 w=1u l=1u
X1441 VDD.t293 VSS.t346 VDD.t292 VDD.t67 sg13_lv_pmos ad=0.19p pd=1.38u as=0 ps=0 w=1u l=1u
X1442 a_6635_16071# a_6425_16071# VSS.t1801 VSS.t2057 sg13_lv_nmos ad=0.1406p pd=1.12u as=0.1665p ps=1.19u w=0.74u l=0.13u
X1443 VDD.t713 a_4187_2434# a_27671_8160# VDD.t346 sg13_lv_pmos ad=0.3808p pd=2.92u as=0.2128p ps=1.5u w=1.12u l=0.6u
X1444 a_3747_1047.t1 a_3449_1395# VSS.t1826 VSS.t1825 sg13_lv_nmos ad=0.1406p pd=1.12u as=0.1331p ps=1.12u w=0.74u l=0.13u
X1445 a_24393_1842# a_24197_1842# VSS.t1304 VSS.t1438 sg13_lv_nmos ad=0.2516p pd=2.16u as=0.1406p ps=1.12u w=0.74u l=0.13u
X1446 VDD.t559 a_19963_4687# a_20397_4687# VDD.t348 sg13_lv_pmos ad=0.2128p pd=1.5u as=0.3808p ps=2.92u w=1.12u l=0.13u
X1447 VSS.t216 VDD.t1692 VSS.t221 VSS.t220 sg13_lv_nmos ad=0.1428p pd=1.52u as=0 ps=0 w=0.42u l=1u
X1448 VDD.t4 VSS.t439 VDD.t3 VDD.t2 sg13_lv_pmos ad=0.34p pd=2.68u as=0 ps=0 w=1u l=1u
X1449 a_1544_1044# CHAN3_MUX_SEL1 VSS.t905 VSS.t922 sg13_lv_nmos ad=0.2516p pd=2.16u as=0.2516p ps=2.16u w=0.74u l=0.13u
X1450 a_10430_3889# a_3747_3892.t7 a_12715_3889# VSS.t1676 sg13_lv_nmos ad=0.2516p pd=2.16u as=0.1406p ps=1.12u w=0.74u l=0.13u
X1451 a_17031_4687# a_16793_4687# a_16923_4687# VSS.t2156 sg13_lv_nmos ad=0.1406p pd=1.12u as=0.2516p ps=2.16u w=0.74u l=0.2u
X1452 a_17553_16869# a_17357_16869# VSS.t798 VSS.t2143 sg13_lv_nmos ad=0.2516p pd=2.16u as=0.1406p ps=1.12u w=0.74u l=0.13u
X1453 VDD.t451 VDD.t443 VDD.t450 VDD.t355 sg13_lv_pmos ad=0.68p pd=4.68u as=0 ps=0 w=2u l=1u
X1454 a_13470_1044# a_3747_1047.t6 a_15755_1044# VSS.t2370 sg13_lv_nmos ad=0.2516p pd=2.16u as=0.1406p ps=1.12u w=0.74u l=0.13u
X1455 VDD.t49 VSS.t86 VDD.t50 VDD.t0 sg13_lv_pmos ad=0.19p pd=1.38u as=0 ps=0 w=1u l=1u
X1456 a_3171_1047.t0 a_2873_1395# VDD.t399 VDD.t2 sg13_lv_pmos ad=0.2128p pd=1.5u as=0.1918p ps=1.5u w=1.12u l=0.13u
X1457 a_24875_3889# a_24665_3889# VSS.t1364 VSS.t1779 sg13_lv_nmos ad=0.1406p pd=1.12u as=0.1665p ps=1.19u w=0.74u l=0.13u
X1458 a_4871_17497# a_4633_16869# a_4763_16869# VDD.t368 sg13_lv_pmos ad=0.2128p pd=1.5u as=0.3808p ps=2.92u w=1.12u l=0.2u
X1459 VSS.t879 a_4187_1764.t163 a_4111_16869# VSS.t2158 sg13_lv_nmos ad=0.2516p pd=2.16u as=0.1406p ps=1.12u w=0.74u l=0.6u
X1460 a_9193_16869# a_8997_16869# VDD.t1101 VDD.t368 sg13_lv_pmos ad=0.3808p pd=2.92u as=0.2128p ps=1.5u w=1.12u l=0.13u
X1461 VDD.t1298 a_5523_1842# a_5957_1842# VDD.t373 sg13_lv_pmos ad=0.2128p pd=1.5u as=0.3808p ps=2.92u w=1.12u l=0.13u
X1462 a_9675_13226# a_9465_13226# VDD.t1001 VDD.t5 sg13_lv_pmos ad=0.2128p pd=1.5u as=0.252p ps=1.57u w=1.12u l=0.13u
X1463 VSS.t1719 a_4187_1764.t99 a_4187_2434# VSS.t1718 sg13_lv_nmos ad=0.2516p pd=2.16u as=0.6808p ps=3.32u w=0.74u l=0.6u
X1464 VDD.t1227 a_2297_1395# a_2595_1047.t0 VDD.t2 sg13_lv_pmos ad=0.4256p pd=3u as=0.2128p ps=1.5u w=1.12u l=0.13u
X1465 a_22590_3889# a_24084_3853# a_24008_3889# VDD.t0 sg13_lv_pmos ad=0.3808p pd=2.92u as=0.2128p ps=1.5u w=1.12u l=0.13u
X1466 a_19550_16071# a_2019_16074.t4 a_19448_16071# VSS.t2108 sg13_lv_nmos ad=0.2516p pd=2.16u as=0.1406p ps=1.12u w=0.74u l=0.13u
X1467 VDD.t1373 a_2019_1047.t6 a_13444_1008# VDD.t2 sg13_lv_pmos ad=0.3808p pd=2.92u as=0.3808p ps=2.92u w=1.12u l=0.13u
X1468 VSS.t122 a_4187_1764.t19 a_14751_1842# VSS.t121 sg13_lv_nmos ad=0.2516p pd=2.16u as=0.1406p ps=1.12u w=0.74u l=0.6u
X1469 VSS.t968 a_2595_3892.t3 a_23431_3853# VSS.t967 sg13_lv_nmos ad=0.2516p pd=2.16u as=0.2516p ps=2.16u w=0.74u l=0.13u
X1470 VDD.t625 a_4187_2434# a_5631_17497# VDD.t368 sg13_lv_pmos ad=0.3808p pd=2.92u as=0.2128p ps=1.5u w=1.12u l=0.6u
X1471 VDD.t510 a_23003_16869# a_23437_16869# VDD.t368 sg13_lv_pmos ad=0.2128p pd=1.5u as=0.3808p ps=2.92u w=1.12u l=0.13u
X1472 a_4350_16071# a_5191_16035# a_5115_16071# VDD.t90 sg13_lv_pmos ad=0.3808p pd=2.92u as=0.2128p ps=1.5u w=1.12u l=0.13u
X1473 VSS.t730 a_2595_1047.t2 a_26471_1008# VSS.t2010 sg13_lv_nmos ad=0.2516p pd=2.16u as=0.2516p ps=2.16u w=0.74u l=0.13u
X1474 a_4350_1044# a_2595_1047.t9 a_5115_1044# VSS.t2011 sg13_lv_nmos ad=0.2516p pd=2.16u as=0.1406p ps=1.12u w=0.74u l=0.13u
X1475 a_2967_1395# CHAN3_MUX_SEL1 a_2873_1395# VSS.t923 sg13_lv_nmos ad=0.1216p pd=1.02u as=0.2176p ps=1.96u w=0.64u l=0.13u
X1476 VSS.t2230 CHAN2_MUX_SEL4 a_15765_3308# VSS.t2229 sg13_lv_nmos ad=0.2516p pd=2.16u as=0.2516p ps=2.16u w=0.74u l=0.13u
X1477 a_2595_311.t1 a_2297_331# VSS.t1228 VSS.t1495 sg13_lv_nmos ad=0.1406p pd=1.12u as=0.1331p ps=1.12u w=0.74u l=0.13u
X1478 VSS.t188 VDD.t1704 VSS.t188 VSS.t192 sg13_lv_nmos ad=0.1428p pd=1.52u as=0 ps=0 w=0.42u l=1u
X1479 VSS.t1165 a_13557_4687# a_14025_3889# VSS.t1164 sg13_lv_nmos ad=0.1665p pd=1.19u as=0.2516p ps=2.16u w=0.74u l=0.13u
X1480 a_9946_11995# a_10751_11568# a_10206_11525# VDD.t355 sg13_lv_pmos ad=0.1428p pd=1.52u as=79.8f ps=0.8u w=0.42u l=0.13u
X1481 VSS.t874 a_16597_1842# a_17065_1044# VSS.t2337 sg13_lv_nmos ad=0.1665p pd=1.19u as=0.2516p ps=2.16u w=0.74u l=0.13u
X1482 a_2297_1395# CHAN3_MUX_SEL0 VDD.t1414 VDD.t2 sg13_lv_pmos ad=0.1596p pd=1.22u as=0.2856p ps=2.36u w=0.84u l=0.13u
X1483 VSS.t1039 a_4187_1764.t33 a_4111_1842# VSS.t1038 sg13_lv_nmos ad=0.2516p pd=2.16u as=0.1406p ps=1.12u w=0.74u l=0.6u
X1484 VSS.t286 VDD.t1675 VSS.t286 VSS.t285 sg13_lv_nmos ad=0.1428p pd=1.52u as=0 ps=0 w=0.42u l=1u
X1485 a_12943_11557# a_13121_11521# VDD.t841 VDD.t355 sg13_lv_pmos ad=0.3808p pd=2.92u as=0.2128p ps=1.5u w=1.12u l=0.13u
X1486 VSS.t305 VDD.t1668 VSS.t305 VSS.t309 sg13_lv_nmos ad=0.1428p pd=1.52u as=0 ps=0 w=0.42u l=1u
X1487 VSS.t898 a_6283_16869# a_6717_16869# VSS.t1502 sg13_lv_nmos ad=0.1406p pd=1.12u as=0.2516p ps=2.16u w=0.74u l=0.13u
X1488 a_25630_13226# a_2595_13229.t2 a_26395_13226# VSS.t2040 sg13_lv_nmos ad=0.2516p pd=2.16u as=0.1406p ps=1.12u w=0.74u l=0.13u
X1489 a_16033_7532# a_15837_7532# VDD.t844 VDD.t346 sg13_lv_pmos ad=0.3808p pd=2.92u as=0.2128p ps=1.5u w=1.12u l=0.13u
X1490 VDD.t798 a_1544_1044# a_1721_1395# VDD.t2 sg13_lv_pmos ad=0.1918p pd=1.5u as=0.1596p ps=1.22u w=0.84u l=0.13u
X1491 VDD.t719 a_4187_2434# a_8671_2470# VDD.t373 sg13_lv_pmos ad=0.3808p pd=2.92u as=0.2128p ps=1.5u w=1.12u l=0.6u
X1492 a_20831_4687# a_20593_4687# a_20723_4687# VSS.t1830 sg13_lv_nmos ad=0.1406p pd=1.12u as=0.2516p ps=2.16u w=0.74u l=0.2u
X1493 a_1815_16422# a_1256_16071# a_1721_16422# VSS.t1752 sg13_lv_nmos ad=0.1216p pd=1.02u as=0.2176p ps=1.96u w=0.64u l=0.13u
X1494 VSS.t157 a_15108_11799# a_14757_11918# VSS.t156 sg13_lv_nmos ad=79.8f pd=0.8u as=0.1428p ps=1.52u w=0.42u l=0.13u
X1495 a_7151_8160# a_6913_7532# a_7043_7532# VDD.t346 sg13_lv_pmos ad=0.2128p pd=1.5u as=0.3808p ps=2.92u w=1.12u l=0.2u
X1496 a_5393_4687# a_5197_4687# VSS.t870 VSS.t869 sg13_lv_nmos ad=0.2516p pd=2.16u as=0.1406p ps=1.12u w=0.74u l=0.13u
X1497 VSS.t984 a_4187_1764.t48 a_17031_4687# VSS.t983 sg13_lv_nmos ad=0.2516p pd=2.16u as=0.1406p ps=1.12u w=0.74u l=0.6u
X1498 a_16510_13226# a_18004_13190# a_17928_13226# VDD.t5 sg13_lv_pmos ad=0.3808p pd=2.92u as=0.2128p ps=1.5u w=1.12u l=0.13u
X1499 VDD.t94 VSS.t413 VDD.t60 VDD.t2 sg13_lv_pmos ad=0.19p pd=1.38u as=0 ps=0 w=1u l=1u
X1500 a_24631_14652# a_24393_14024# a_24523_14024# VDD.t374 sg13_lv_pmos ad=0.2128p pd=1.5u as=0.3808p ps=2.92u w=1.12u l=0.2u
X1501 VSS.t86 VDD.t1650 VSS.t86 VSS.t356 sg13_lv_nmos ad=79.8f pd=0.8u as=0 ps=0 w=0.42u l=1u
X1502 a_25630_3889# a_27991_3853# a_27915_3889# VDD.t0 sg13_lv_pmos ad=0.3808p pd=2.92u as=0.2128p ps=1.5u w=1.12u l=0.13u
X1503 a_8808_16071# a_8237_16869# VSS.t110 VSS.t1238 sg13_lv_nmos ad=0.1406p pd=1.12u as=0.2516p ps=2.16u w=0.74u l=0.13u
X1504 VSS.t1941 a_7477_14024# a_7945_13226# VSS.t1940 sg13_lv_nmos ad=0.1665p pd=1.19u as=0.2516p ps=2.16u w=0.74u l=0.13u
X1505 a_3171_12493.t1 a_2873_12513# VSS.t1093 VSS.t1092 sg13_lv_nmos ad=0.1406p pd=1.12u as=0.1331p ps=1.12u w=0.74u l=0.13u
X1506 a_10430_6734# a_12791_6698# a_12715_6734# VDD.t67 sg13_lv_pmos ad=0.3808p pd=2.92u as=0.2128p ps=1.5u w=1.12u l=0.13u
X1507 a_20071_14652# a_19833_14024# a_19963_14024# VDD.t374 sg13_lv_pmos ad=0.2128p pd=1.5u as=0.3808p ps=2.92u w=1.12u l=0.2u
X1508 VDD.t684 a_4187_2434# a_25391_14652# VDD.t374 sg13_lv_pmos ad=0.3808p pd=2.92u as=0.2128p ps=1.5u w=1.12u l=0.6u
X1509 a_5768_13226# a_5197_14024# VSS.t1926 VSS.t1925 sg13_lv_nmos ad=0.1406p pd=1.12u as=0.2516p ps=2.16u w=0.74u l=0.13u
X1510 VSS.t837 a_26803_4687# a_27237_4687# VSS.t836 sg13_lv_nmos ad=0.1406p pd=1.12u as=0.2516p ps=2.16u w=0.74u l=0.13u
X1511 a_25630_16071# a_25604_16035# a_25528_16071# VDD.t90 sg13_lv_pmos ad=0.3808p pd=2.92u as=0.2128p ps=1.5u w=1.12u l=0.13u
X1512 a_4248_1044# a_4157_1313# VDD.t536 VDD.t2 sg13_lv_pmos ad=0.2128p pd=1.5u as=0.3808p ps=2.92u w=1.12u l=0.13u
X1513 a_4248_16071# a_4157_16340# VSS.t1648 VSS.t2065 sg13_lv_nmos ad=0.1406p pd=1.12u as=0.2516p ps=2.16u w=0.74u l=0.13u
X1514 a_19448_16071# a_18877_16869# VDD.t1209 VDD.t90 sg13_lv_pmos ad=0.2128p pd=1.5u as=0.3808p ps=2.92u w=1.12u l=0.13u
X1515 VSS.t849 a_11603_7532# a_12037_7532# VSS.t848 sg13_lv_nmos ad=0.1406p pd=1.12u as=0.2516p ps=2.16u w=0.74u l=0.13u
X1516 a_24875_6734# a_24665_6734# VDD.t529 VDD.t67 sg13_lv_pmos ad=0.2128p pd=1.5u as=0.252p ps=1.57u w=1.12u l=0.13u
X1517 a_20593_16869# a_20397_16869# VDD.t1212 VDD.t368 sg13_lv_pmos ad=0.3808p pd=2.92u as=0.2128p ps=1.5u w=1.12u l=0.13u
X1518 a_18551_16869# a_18313_16869# a_18443_16869# VSS.t1188 sg13_lv_nmos ad=0.1406p pd=1.12u as=0.2516p ps=2.16u w=0.74u l=0.2u
X1519 VDD.t972 a_13883_16869# a_14317_16869# VDD.t368 sg13_lv_pmos ad=0.2128p pd=1.5u as=0.3808p ps=2.92u w=1.12u l=0.13u
X1520 VDD.t76 VSS.t393 VDD.t47 VDD.t0 sg13_lv_pmos ad=0.19p pd=1.38u as=0 ps=0 w=1u l=1u
X1521 a_3747_6737.t1 a_3449_7085# VSS.t1446 VSS.t1445 sg13_lv_nmos ad=0.1406p pd=1.12u as=0.1331p ps=1.12u w=0.74u l=0.13u
X1522 a_11473_4687# a_11277_4687# VDD.t504 VDD.t348 sg13_lv_pmos ad=0.3808p pd=2.92u as=0.2128p ps=1.5u w=1.12u l=0.13u
X1523 VDD.t1067 a_2595_6737.t3 a_23431_6698# VDD.t67 sg13_lv_pmos ad=0.3808p pd=2.92u as=0.3808p ps=2.92u w=1.12u l=0.13u
X1524 a_7390_16071# a_3747_16074.t8 a_9675_16071# VSS.t1443 sg13_lv_nmos ad=0.2516p pd=2.16u as=0.1406p ps=1.12u w=0.74u l=0.13u
X1525 a_24393_7532# a_24197_7532# VSS.t921 VSS.t1025 sg13_lv_nmos ad=0.2516p pd=2.16u as=0.1406p ps=1.12u w=0.74u l=0.13u
X1526 VSS.t667 a_2595_16074.t4 a_20391_16035# VSS.t2369 sg13_lv_nmos ad=0.2516p pd=2.16u as=0.2516p ps=2.16u w=0.74u l=0.13u
X1527 a_1544_6734# REF_MUX_SEL1 VSS.t2162 VSS.t2295 sg13_lv_nmos ad=0.2516p pd=2.16u as=0.2516p ps=2.16u w=0.74u l=0.13u
X1528 a_4350_13226# a_3747_13229.t9 a_6635_13226# VSS.t1535 sg13_lv_nmos ad=0.2516p pd=2.16u as=0.1406p ps=1.12u w=0.74u l=0.13u
X1529 a_17031_1842# a_16793_1842# a_16923_1842# VSS.t1420 sg13_lv_nmos ad=0.1406p pd=1.12u as=0.2516p ps=2.16u w=0.74u l=0.2u
X1530 a_13470_6734# a_3747_6737.t6 a_15755_6734# VSS.t1788 sg13_lv_nmos ad=0.2516p pd=2.16u as=0.1406p ps=1.12u w=0.74u l=0.13u
X1531 a_7288_13226# a_6717_14024# VDD.t1044 VDD.t5 sg13_lv_pmos ad=0.2128p pd=1.5u as=0.3808p ps=2.92u w=1.12u l=0.13u
X1532 VSS.t265 VDD.t1680 VSS.t268 VSS.t267 sg13_lv_nmos ad=79.8f pd=0.8u as=0 ps=0 w=0.42u l=1u
X1533 a_12471_2470# a_12233_1842# a_12363_1842# VDD.t373 sg13_lv_pmos ad=0.2128p pd=1.5u as=0.3808p ps=2.92u w=1.12u l=0.2u
X1534 a_13592_11561# a_14111_11568# a_14851_11918# VSS.t156 sg13_lv_nmos ad=0.3473p pd=2.71u as=0.12665p ps=1.145u w=0.74u l=0.13u
X1535 VDD.t1494 a_13557_7532# a_14025_6734# VDD.t67 sg13_lv_pmos ad=0.252p pd=1.57u as=0.3808p ps=2.92u w=1.12u l=0.13u
X1536 a_19550_1044# a_21911_1008# a_21835_1044# VDD.t2 sg13_lv_pmos ad=0.3808p pd=2.92u as=0.2128p ps=1.5u w=1.12u l=0.13u
X1537 VSS.t1228 a_1721_331# a_2019_311.t1 VSS.t2274 sg13_lv_nmos ad=0.2812p pd=2.24u as=0.1406p ps=1.12u w=0.74u l=0.13u
X1538 a_4871_14652# a_4633_14024# a_4763_14024# VDD.t374 sg13_lv_pmos ad=0.2128p pd=1.5u as=0.3808p ps=2.92u w=1.12u l=0.2u
X1539 VDD.t1531 a_15464_9374# a_9712_9602# VSS.t2270 sg13_lv_nmos ad=0.232p pd=2.08u as=0.136p ps=1.14u w=0.4u l=0.2u
X1540 a_9193_14024# a_8997_14024# VDD.t1000 VDD.t374 sg13_lv_pmos ad=0.3808p pd=2.92u as=0.2128p ps=1.5u w=1.12u l=0.13u
X1541 VDD.t380 a_5523_7532# a_5957_7532# VDD.t346 sg13_lv_pmos ad=0.2128p pd=1.5u as=0.3808p ps=2.92u w=1.12u l=0.13u
X1542 a_14851_10872# a_14009_10774# a_13592_11113# VDD.t355 sg13_lv_pmos ad=0.2048p pd=1.63u as=0.34p ps=2.68u w=1u l=0.13u
X1543 VSS.t1023 a_4187_1764.t83 a_14751_7532# VSS.t2357 sg13_lv_nmos ad=0.2516p pd=2.16u as=0.1406p ps=1.12u w=0.74u l=0.6u
X1544 a_3449_15358# CHAN0_MUX_SEL2 VDD.t589 VDD.t90 sg13_lv_pmos ad=0.1596p pd=1.22u as=0.2856p ps=2.36u w=0.84u l=0.13u
X1545 a_6854_11144# a_6326_10280# VDD.t992 VDD.t355 sg13_lv_pmos ad=0.38p pd=2.38u as=0.38p ps=2.38u w=2u l=1u
X1546 VDD.t646 a_4187_2434# a_5631_14652# VDD.t374 sg13_lv_pmos ad=0.3808p pd=2.92u as=0.2128p ps=1.5u w=1.12u l=0.6u
X1547 VDD.t1182 a_2595_13229.t3 a_23431_13190# VDD.t5 sg13_lv_pmos ad=0.3808p pd=2.92u as=0.3808p ps=2.92u w=1.12u l=0.13u
X1548 VSS.t246 VDD.t1685 VSS.t249 VSS.t248 sg13_lv_nmos ad=79.8f pd=0.8u as=0 ps=0 w=0.42u l=1u
X1549 VSS.t1124 a_2595_6737.t2 a_26471_6698# VSS.t1123 sg13_lv_nmos ad=0.2516p pd=2.16u as=0.2516p ps=2.16u w=0.74u l=0.13u
X1550 VSS.t1228 a_2297_331# a_2595_311.t1 VSS.t1496 sg13_lv_nmos ad=0.2812p pd=2.24u as=0.1406p ps=1.12u w=0.74u l=0.13u
X1551 VDD.t1059 a_23003_14024# a_23437_14024# VDD.t374 sg13_lv_pmos ad=0.2128p pd=1.5u as=0.3808p ps=2.92u w=1.12u l=0.13u
X1552 a_2967_7085# REF_MUX_SEL1 a_2873_7085# VSS.t2296 sg13_lv_nmos ad=0.1216p pd=1.02u as=0.2176p ps=1.96u w=0.64u l=0.13u
X1553 a_4350_6734# a_2595_6737.t9 a_5115_6734# VSS.t1114 sg13_lv_nmos ad=0.2516p pd=2.16u as=0.1406p ps=1.12u w=0.74u l=0.13u
X1554 a_16108_289# a_26985_519# a_25630_1044# VDD.t2 sg13_lv_pmos ad=0.3808p pd=2.92u as=0.3808p ps=2.92u w=1.12u l=0.13u
X1555 a_27915_16071# a_27705_16071# VSS.t1992 VSS.t1991 sg13_lv_nmos ad=0.1406p pd=1.12u as=0.1665p ps=1.19u w=0.74u l=0.13u
X1556 VDD.t104 VSS.t305 VDD.t103 VDD.t67 sg13_lv_pmos ad=0.34p pd=2.68u as=0 ps=0 w=1u l=1u
X1557 a_24875_13226# a_24665_13226# VSS.t1301 VSS.t2092 sg13_lv_nmos ad=0.1406p pd=1.12u as=0.1665p ps=1.19u w=0.74u l=0.13u
X1558 a_7390_13226# a_8231_13190# a_8155_13226# VDD.t5 sg13_lv_pmos ad=0.3808p pd=2.92u as=0.2128p ps=1.5u w=1.12u l=0.13u
X1559 VDD.t878 a_2873_12513# a_3171_12493.t0 VDD.t5 sg13_lv_pmos ad=0.4256p pd=3u as=0.2128p ps=1.5u w=1.12u l=0.13u
X1560 a_16510_16071# a_16484_16035# a_16408_16071# VDD.t90 sg13_lv_pmos ad=0.3808p pd=2.92u as=0.2128p ps=1.5u w=1.12u l=0.13u
X1561 VSS.t657 a_4187_1764.t97 a_4111_7532# VSS.t2107 sg13_lv_nmos ad=0.2516p pd=2.16u as=0.1406p ps=1.12u w=0.74u l=0.6u
X1562 a_18795_1044# a_18585_1044# VSS.t1215 VSS.t1873 sg13_lv_nmos ad=0.1406p pd=1.12u as=0.1665p ps=1.19u w=0.74u l=0.13u
X1563 a_19311_4687# a_19073_4687# a_19203_4687# VSS.t2207 sg13_lv_nmos ad=0.1406p pd=1.12u as=0.2516p ps=2.16u w=0.74u l=0.2u
X1564 VSS.t1151 a_16597_7532# a_17065_6734# VSS.t1586 sg13_lv_nmos ad=0.1665p pd=1.19u as=0.2516p ps=2.16u w=0.74u l=0.13u
X1565 a_23355_16071# a_23145_16071# VSS.t2050 VSS.t2049 sg13_lv_nmos ad=0.1406p pd=1.12u as=0.1665p ps=1.19u w=0.74u l=0.13u
X1566 VSS.t399 VDD.t1634 VSS.t398 VSS.t397 sg13_lv_nmos ad=0.1428p pd=1.52u as=0 ps=0 w=0.42u l=1u
X1567 VDD.t203 VSS.t202 VDD.t202 VDD.t90 sg13_lv_pmos ad=0.34p pd=2.68u as=0 ps=0 w=1u l=1u
X1568 VDD.t939 a_22677_1842# a_23145_1044# VDD.t2 sg13_lv_pmos ad=0.252p pd=1.57u as=0.3808p ps=2.92u w=1.12u l=0.13u
X1569 a_22590_3889# a_3171_3892.t3 a_24008_3889# VSS.t1738 sg13_lv_nmos ad=0.2516p pd=2.16u as=0.1406p ps=1.12u w=0.74u l=0.13u
X1570 VDD.t701 a_4187_2434# a_8671_8160# VDD.t346 sg13_lv_pmos ad=0.3808p pd=2.92u as=0.2128p ps=1.5u w=1.12u l=0.6u
X1571 VSS.t596 a_2595_1047.t5 a_17351_1008# VSS.t719 sg13_lv_nmos ad=0.2516p pd=2.16u as=0.2516p ps=2.16u w=0.74u l=0.13u
X1572 a_20831_1842# a_20593_1842# a_20723_1842# VSS.t1981 sg13_lv_nmos ad=0.1406p pd=1.12u as=0.2516p ps=2.16u w=0.74u l=0.2u
X1573 a_25630_1044# a_3171_1047.t2 a_27048_1044# VSS.t728 sg13_lv_nmos ad=0.2516p pd=2.16u as=0.1406p ps=1.12u w=0.74u l=0.13u
X1574 a_5393_1842# a_5197_1842# VSS.t1338 VSS.t1895 sg13_lv_nmos ad=0.2516p pd=2.16u as=0.1406p ps=1.12u w=0.74u l=0.13u
X1575 VSS.t274 VDD.t1678 VSS.t276 VSS.t275 sg13_lv_nmos ad=79.8f pd=0.8u as=0 ps=0 w=0.42u l=1u
X1576 VSS.t598 a_4187_1764.t16 a_17031_1842# VSS.t1474 sg13_lv_nmos ad=0.2516p pd=2.16u as=0.1406p ps=1.12u w=0.74u l=0.6u
X1577 a_5731_15316# a_2595_15338.t3 a_7390_16071# VSS.t947 sg13_lv_nmos ad=0.2516p pd=2.16u as=0.2516p ps=2.16u w=0.74u l=0.13u
X1578 VSS.t1074 a_1544_13226# a_1815_13577# VSS.t1256 sg13_lv_nmos ad=0.1331p pd=1.12u as=0.1216p ps=1.02u w=0.64u l=0.13u
X1579 a_9953_1842# a_9757_1842# VDD.t975 VDD.t373 sg13_lv_pmos ad=0.3808p pd=2.92u as=0.2128p ps=1.5u w=1.12u l=0.13u
X1580 VSS.t126 REF_MUX_SEL3 a_3543_6021# VSS.t933 sg13_lv_nmos ad=0.1331p pd=1.12u as=0.1216p ps=1.02u w=0.64u l=0.13u
X1581 a_21591_17497# a_21353_16869# a_21483_16869# VDD.t368 sg13_lv_pmos ad=0.2128p pd=1.5u as=0.3808p ps=2.92u w=1.12u l=0.2u
X1582 VDD.t666 a_4187_2434# a_26911_17497# VDD.t368 sg13_lv_pmos ad=0.3808p pd=2.92u as=0.2128p ps=1.5u w=1.12u l=0.6u
X1583 VDD.t858 a_10843_1842# a_11277_1842# VDD.t373 sg13_lv_pmos ad=0.2128p pd=1.5u as=0.3808p ps=2.92u w=1.12u l=0.13u
X1584 a_26395_13226# a_26185_13226# VDD.t813 VDD.t5 sg13_lv_pmos ad=0.2128p pd=1.5u as=0.252p ps=1.57u w=1.12u l=0.13u
X1585 VDD.t743 a_4187_2434# a_25391_5315# VDD.t348 sg13_lv_pmos ad=0.3808p pd=2.92u as=0.2128p ps=1.5u w=1.12u l=0.6u
X1586 VSS.t326 VDD.t1660 VSS.t326 VSS.t329 sg13_lv_nmos ad=79.8f pd=0.8u as=0 ps=0 w=0.42u l=1u
X1587 a_16033_14024# a_15837_14024# VSS.t885 VSS.t884 sg13_lv_nmos ad=0.2516p pd=2.16u as=0.1406p ps=1.12u w=0.74u l=0.13u
X1588 a_4350_1044# a_3171_1047.t9 a_5768_1044# VSS.t731 sg13_lv_nmos ad=0.2516p pd=2.16u as=0.1406p ps=1.12u w=0.74u l=0.13u
X1589 a_9444_10280# a_9444_10280# VSS.t1277 VSS.t1272 sg13_lv_nmos ad=0.38p pd=2.38u as=0.68p ps=4.68u w=2u l=1u
X1590 VSS.t795 a_26803_1842# a_27237_1842# VSS.t1988 sg13_lv_nmos ad=0.1406p pd=1.12u as=0.2516p ps=2.16u w=0.74u l=0.13u
X1591 a_8155_3889# a_7945_3889# VDD.t1229 VDD.t0 sg13_lv_pmos ad=0.2128p pd=1.5u as=0.252p ps=1.57u w=1.12u l=0.13u
X1592 a_5731_5979# a_8745_6209# a_7390_6734# VDD.t67 sg13_lv_pmos ad=0.3808p pd=2.92u as=0.3808p ps=2.92u w=1.12u l=0.13u
X1593 VDD.t664 a_4187_2434# a_22351_17497# VDD.t368 sg13_lv_pmos ad=0.3808p pd=2.92u as=0.2128p ps=1.5u w=1.12u l=0.6u
X1594 a_2391_16422# CHAN0_MUX_SEL0 a_2297_16422# VSS.t181 sg13_lv_nmos ad=0.1216p pd=1.02u as=0.2176p ps=1.96u w=0.64u l=0.13u
X1595 a_20593_14024# a_20397_14024# VDD.t862 VDD.t374 sg13_lv_pmos ad=0.3808p pd=2.92u as=0.2128p ps=1.5u w=1.12u l=0.13u
X1596 a_23111_4687# a_22873_4687# a_23003_4687# VSS.t2203 sg13_lv_nmos ad=0.1406p pd=1.12u as=0.2516p ps=2.16u w=0.74u l=0.2u
X1597 VDD.t375 a_13883_14024# a_14317_14024# VDD.t374 sg13_lv_pmos ad=0.2128p pd=1.5u as=0.3808p ps=2.92u w=1.12u l=0.13u
X1598 VDD.t987 a_6326_10280# a_6854_11676# VDD.t355 sg13_lv_pmos ad=0.38p pd=2.38u as=0.38p ps=2.38u w=2u l=1u
X1599 a_25630_3889# a_3747_3892.t2 a_27915_3889# VSS.t1673 sg13_lv_nmos ad=0.2516p pd=2.16u as=0.1406p ps=1.12u w=0.74u l=0.13u
X1600 a_3747_3892.t1 a_3449_4240# VSS.t1611 VSS.t1848 sg13_lv_nmos ad=0.1406p pd=1.12u as=0.1331p ps=1.12u w=0.74u l=0.13u
X1601 a_27048_3889# a_26477_4687# VDD.t1252 VDD.t0 sg13_lv_pmos ad=0.2128p pd=1.5u as=0.3808p ps=2.92u w=1.12u l=0.13u
X1602 VSS.t856 a_17683_4687# a_18117_4687# VSS.t1182 sg13_lv_nmos ad=0.1406p pd=1.12u as=0.2516p ps=2.16u w=0.74u l=0.13u
X1603 a_17031_7532# a_16793_7532# a_16923_7532# VSS.t1028 sg13_lv_nmos ad=0.1406p pd=1.12u as=0.2516p ps=2.16u w=0.74u l=0.2u
X1604 VSS.t209 VDD.t1695 VSS.t209 VSS.t213 sg13_lv_nmos ad=0.1428p pd=1.52u as=0 ps=0 w=0.42u l=1u
X1605 a_12471_8160# a_12233_7532# a_12363_7532# VDD.t346 sg13_lv_pmos ad=0.2128p pd=1.5u as=0.3808p ps=2.92u w=1.12u l=0.2u
X1606 a_10713_4687# a_10517_4687# VSS.t165 VSS.t164 sg13_lv_nmos ad=0.2516p pd=2.16u as=0.1406p ps=1.12u w=0.74u l=0.13u
X1607 a_11195_13226# a_10985_13226# VSS.t591 VSS.t2089 sg13_lv_nmos ad=0.1406p pd=1.12u as=0.1665p ps=1.19u w=0.74u l=0.13u
X1608 a_5768_3889# a_5197_4687# VDD.t786 VDD.t0 sg13_lv_pmos ad=0.2128p pd=1.5u as=0.3808p ps=2.92u w=1.12u l=0.13u
X1609 a_6153_16869# a_5957_16869# VDD.t1241 VDD.t368 sg13_lv_pmos ad=0.3808p pd=2.92u as=0.2128p ps=1.5u w=1.12u l=0.13u
X1610 a_22590_6734# a_24084_6698# a_24008_6734# VDD.t67 sg13_lv_pmos ad=0.3808p pd=2.92u as=0.2128p ps=1.5u w=1.12u l=0.13u
X1611 VSS.t1924 a_4763_14024# a_5197_14024# VSS.t2134 sg13_lv_nmos ad=0.1406p pd=1.12u as=0.2516p ps=2.16u w=0.74u l=0.13u
X1612 a_6635_13226# a_6425_13226# VDD.t1395 VDD.t5 sg13_lv_pmos ad=0.2128p pd=1.5u as=0.252p ps=1.57u w=1.12u l=0.13u
X1613 a_3449_12513# CHAN1_MUX_SEL2 VDD.t1455 VDD.t5 sg13_lv_pmos ad=0.1596p pd=1.22u as=0.2856p ps=2.36u w=0.84u l=0.13u
X1614 a_10649_11568# REF_CLK VDD.t381 VDD.t355 sg13_lv_pmos ad=0.4088p pd=2.97u as=1.03698p ps=6.245u w=1.12u l=0.13u
X1615 a_22488_13226# a_21917_14024# VSS.t1414 VSS.t1413 sg13_lv_nmos ad=0.1406p pd=1.12u as=0.2516p ps=2.16u w=0.74u l=0.13u
X1616 VSS.t764 a_15964_12471# a_16851_12491# VSS.t926 sg13_lv_nmos ad=0.1371p pd=1.12u as=0.2176p ps=1.96u w=0.64u l=0.13u
X1617 a_2967_4240# CHAN2_MUX_SEL1 a_2873_4240# VSS.t932 sg13_lv_nmos ad=0.1216p pd=1.02u as=0.2176p ps=1.96u w=0.64u l=0.13u
X1618 a_10430_1044# a_12791_1008# a_12715_1044# VDD.t2 sg13_lv_pmos ad=0.3808p pd=2.92u as=0.2128p ps=1.5u w=1.12u l=0.13u
X1619 VSS.t116 a_7803_4687# a_8237_4687# VSS.t1773 sg13_lv_nmos ad=0.1406p pd=1.12u as=0.2516p ps=2.16u w=0.74u l=0.13u
X1620 VDD.t56 VSS.t86 VDD.t55 VDD.t0 sg13_lv_pmos ad=0.34p pd=2.68u as=0 ps=0 w=1u l=1u
X1621 a_18795_6734# a_18585_6734# VSS.t909 VSS.t1822 sg13_lv_nmos ad=0.1406p pd=1.12u as=0.1665p ps=1.19u w=0.74u l=0.13u
X1622 a_19311_1842# a_19073_1842# a_19203_1842# VSS.t1425 sg13_lv_nmos ad=0.1406p pd=1.12u as=0.2516p ps=2.16u w=0.74u l=0.2u
X1623 a_25630_13226# a_3747_13229.t2 a_27915_13226# VSS.t1537 sg13_lv_nmos ad=0.2516p pd=2.16u as=0.1406p ps=1.12u w=0.74u l=0.13u
X1624 a_24875_1044# a_24665_1044# VDD.t911 VDD.t2 sg13_lv_pmos ad=0.2128p pd=1.5u as=0.252p ps=1.57u w=1.12u l=0.13u
X1625 a_25630_16071# a_2595_16074.t2 a_26395_16071# VSS.t2226 sg13_lv_nmos ad=0.2516p pd=2.16u as=0.1406p ps=1.12u w=0.74u l=0.13u
X1626 VDD.t306 VSS.t227 VDD.t305 VDD.t90 sg13_lv_pmos ad=0.19p pd=1.38u as=0 ps=0 w=1u l=1u
X1627 a_19550_13226# a_19524_13190# a_19448_13226# VDD.t5 sg13_lv_pmos ad=0.3808p pd=2.92u as=0.2128p ps=1.5u w=1.12u l=0.13u
X1628 a_20831_7532# a_20593_7532# a_20723_7532# VSS.t1794 sg13_lv_nmos ad=0.1406p pd=1.12u as=0.2516p ps=2.16u w=0.74u l=0.2u
X1629 VSS.t142 a_2595_6737.t5 a_17351_6698# VSS.t1381 sg13_lv_nmos ad=0.2516p pd=2.16u as=0.2516p ps=2.16u w=0.74u l=0.13u
X1630 a_5393_7532# a_5197_7532# VSS.t25 VSS.t43 sg13_lv_nmos ad=0.2516p pd=2.16u as=0.1406p ps=1.12u w=0.74u l=0.13u
X1631 a_25630_6734# a_3171_6737.t2 a_27048_6734# VSS.t1389 sg13_lv_nmos ad=0.2516p pd=2.16u as=0.1406p ps=1.12u w=0.74u l=0.13u
X1632 VDD.t579 a_2595_1047.t3 a_23431_1008# VDD.t2 sg13_lv_pmos ad=0.3808p pd=2.92u as=0.3808p ps=2.92u w=1.12u l=0.13u
X1633 a_22590_13226# a_2595_13229.t3 a_23355_13226# VSS.t1668 sg13_lv_nmos ad=0.2516p pd=2.16u as=0.1406p ps=1.12u w=0.74u l=0.13u
X1634 VSS.t227 VDD.t1690 VSS.t229 VSS.t228 sg13_lv_nmos ad=0.1428p pd=1.52u as=0 ps=0 w=0.42u l=1u
X1635 VSS.t149 a_2297_12513# a_2595_12493.t1 VSS.t628 sg13_lv_nmos ad=0.2812p pd=2.24u as=0.1406p ps=1.12u w=0.74u l=0.13u
X1636 VSS.t144 a_4187_1764.t80 a_17031_7532# VSS.t1694 sg13_lv_nmos ad=0.2516p pd=2.16u as=0.1406p ps=1.12u w=0.74u l=0.6u
X1637 VSS.t1318 a_8997_14024# a_9465_13226# VSS.t1317 sg13_lv_nmos ad=0.1665p pd=1.19u as=0.2516p ps=2.16u w=0.74u l=0.13u
X1638 VDD.t272 VSS.t326 VDD.t270 VDD.t67 sg13_lv_pmos ad=0.19p pd=1.38u as=0 ps=0 w=1u l=1u
X1639 a_9953_7532# a_9757_7532# VDD.t402 VDD.t346 sg13_lv_pmos ad=0.3808p pd=2.92u as=0.2128p ps=1.5u w=1.12u l=0.13u
X1640 a_25630_6734# a_27991_6698# a_27915_6734# VDD.t67 sg13_lv_pmos ad=0.3808p pd=2.92u as=0.2128p ps=1.5u w=1.12u l=0.13u
X1641 a_20315_16071# a_20105_16071# VDD.t1393 VDD.t90 sg13_lv_pmos ad=0.2128p pd=1.5u as=0.252p ps=1.57u w=1.12u l=0.13u
X1642 VDD.t648 a_4187_2434# a_26911_14652# VDD.t374 sg13_lv_pmos ad=0.3808p pd=2.92u as=0.2128p ps=1.5u w=1.12u l=0.6u
X1643 VDD.t597 a_10843_7532# a_11277_7532# VDD.t346 sg13_lv_pmos ad=0.2128p pd=1.5u as=0.3808p ps=2.92u w=1.12u l=0.13u
X1644 VSS.t2048 a_7477_16869# a_7945_16071# VSS.t2175 sg13_lv_nmos ad=0.1665p pd=1.19u as=0.2516p ps=2.16u w=0.74u l=0.13u
X1645 a_21591_14652# a_21353_14024# a_21483_14024# VDD.t374 sg13_lv_pmos ad=0.2128p pd=1.5u as=0.3808p ps=2.92u w=1.12u l=0.2u
X1646 a_16108_5979# a_2019_6001.t2 a_16510_6734# VSS.t1864 sg13_lv_nmos ad=0.2516p pd=2.16u as=0.2516p ps=2.16u w=0.74u l=0.13u
X1647 a_4350_6734# a_3171_6737.t9 a_5768_6734# VSS.t1431 sg13_lv_nmos ad=0.2516p pd=2.16u as=0.1406p ps=1.12u w=0.74u l=0.13u
X1648 VDD.t539 a_13557_1842# a_14025_1044# VDD.t2 sg13_lv_pmos ad=0.252p pd=1.57u as=0.3808p ps=2.92u w=1.12u l=0.13u
X1649 CHAN2_MUX_OUT a_16851_3154# VDD.t1438 VDD.t0 sg13_lv_pmos ad=0.2128p pd=1.5u as=0.2086p ps=1.5u w=1.12u l=0.13u
X1650 a_5768_16071# a_5197_16869# VSS.t1050 VSS.t1049 sg13_lv_nmos ad=0.1406p pd=1.12u as=0.2516p ps=2.16u w=0.74u l=0.13u
X1651 VSS.t1357 a_26803_7532# a_27237_7532# VSS.t1497 sg13_lv_nmos ad=0.1406p pd=1.12u as=0.2516p ps=2.16u w=0.74u l=0.13u
X1652 a_5731_3134# a_8745_3364# a_7390_3889# VDD.t0 sg13_lv_pmos ad=0.3808p pd=2.92u as=0.3808p ps=2.92u w=1.12u l=0.13u
X1653 VDD.t676 a_4187_2434# a_22351_14652# VDD.t374 sg13_lv_pmos ad=0.3808p pd=2.92u as=0.2128p ps=1.5u w=1.12u l=0.6u
X1654 VSS.t188 VDD.t1705 VSS.t188 VSS.t191 sg13_lv_nmos ad=79.8f pd=0.8u as=0 ps=0 w=0.42u l=1u
X1655 a_26673_4687# a_26477_4687# VDD.t1248 VDD.t348 sg13_lv_pmos ad=0.3808p pd=2.92u as=0.2128p ps=1.5u w=1.12u l=0.13u
X1656 VDD.t1028 a_24197_4687# a_24665_3889# VDD.t0 sg13_lv_pmos ad=0.252p pd=1.57u as=0.3808p ps=2.92u w=1.12u l=0.13u
X1657 VDD.t381 a_9547_11862# a_9547_11632# VDD.t355 sg13_lv_pmos ad=1.10612p pd=6.66u as=0.2442p ps=2.06u w=0.66u l=0.13u
X1658 a_23111_1842# a_22873_1842# a_23003_1842# VSS.t1985 sg13_lv_nmos ad=0.1406p pd=1.12u as=0.2516p ps=2.16u w=0.74u l=0.2u
X1659 a_16510_3889# a_18004_3853# a_17928_3889# VDD.t0 sg13_lv_pmos ad=0.3808p pd=2.92u as=0.2128p ps=1.5u w=1.12u l=0.13u
X1660 VDD.t920 a_10843_16869# a_11277_16869# VDD.t368 sg13_lv_pmos ad=0.2128p pd=1.5u as=0.3808p ps=2.92u w=1.12u l=0.13u
X1661 a_8808_13226# a_8237_14024# VDD.t1329 VDD.t5 sg13_lv_pmos ad=0.2128p pd=1.5u as=0.3808p ps=2.92u w=1.12u l=0.13u
X1662 VSS.t1217 a_17683_1842# a_18117_1842# VSS.t1630 sg13_lv_nmos ad=0.1406p pd=1.12u as=0.2516p ps=2.16u w=0.74u l=0.13u
X1663 a_27671_2470# a_27433_1842# a_27563_1842# VDD.t373 sg13_lv_pmos ad=0.2128p pd=1.5u as=0.3808p ps=2.92u w=1.12u l=0.2u
X1664 a_7151_17497# a_6913_16869# a_7043_16869# VDD.t368 sg13_lv_pmos ad=0.2128p pd=1.5u as=0.3808p ps=2.92u w=1.12u l=0.2u
X1665 a_4350_16071# a_3747_16074.t9 a_6635_16071# VSS.t2244 sg13_lv_nmos ad=0.2516p pd=2.16u as=0.1406p ps=1.12u w=0.74u l=0.13u
X1666 VSS.t295 VDD.t1673 VSS.t294 VSS.t293 sg13_lv_nmos ad=0.1428p pd=1.52u as=0 ps=0 w=0.42u l=1u
X1667 VSS.t443 VDD.t1623 VSS.t443 VSS.t444 sg13_lv_nmos ad=79.8f pd=0.8u as=0 ps=0 w=0.42u l=1u
X1668 a_10713_1842# a_10517_1842# VSS.t887 VSS.t1398 sg13_lv_nmos ad=0.2516p pd=2.16u as=0.1406p ps=1.12u w=0.74u l=0.13u
X1669 VDD.t1406 a_3449_3176# a_3747_3156.t0 VDD.t0 sg13_lv_pmos ad=0.4256p pd=3u as=0.2128p ps=1.5u w=1.12u l=0.13u
X1670 a_8155_3889# a_7945_3889# VSS.t1778 VSS.t1777 sg13_lv_nmos ad=0.1406p pd=1.12u as=0.1665p ps=1.19u w=0.74u l=0.13u
X1671 a_4248_13226# a_4157_13495# VDD.t1390 VDD.t5 sg13_lv_pmos ad=0.2128p pd=1.5u as=0.3808p ps=2.92u w=1.12u l=0.13u
X1672 VSS.t104 a_2019_1047.t8 a_7364_1008# VSS.t103 sg13_lv_nmos ad=0.2516p pd=2.16u as=0.2516p ps=2.16u w=0.74u l=0.13u
X1673 a_6153_14024# a_5957_14024# VDD.t1322 VDD.t374 sg13_lv_pmos ad=0.3808p pd=2.92u as=0.2128p ps=1.5u w=1.12u l=0.13u
X1674 a_14751_4687# a_14513_4687# a_14643_4687# VSS.t647 sg13_lv_nmos ad=0.1406p pd=1.12u as=0.2516p ps=2.16u w=0.74u l=0.2u
X1675 a_2595_16074.t0 a_2297_16422# VDD.t1217 VDD.t90 sg13_lv_pmos ad=0.2128p pd=1.5u as=0.1918p ps=1.5u w=1.12u l=0.13u
X1676 a_27048_3889# a_26477_4687# VSS.t960 VSS.t1815 sg13_lv_nmos ad=0.1406p pd=1.12u as=0.2516p ps=2.16u w=0.74u l=0.13u
X1677 a_7390_13226# a_9751_13190# a_9675_13226# VDD.t5 sg13_lv_pmos ad=0.3808p pd=2.92u as=0.2128p ps=1.5u w=1.12u l=0.13u
X1678 VDD.t834 a_2595_13229.t4 a_20391_13190# VDD.t5 sg13_lv_pmos ad=0.3808p pd=2.92u as=0.3808p ps=2.92u w=1.12u l=0.13u
X1679 VSS.t234 VDD.t1688 VSS.t237 VSS.t236 sg13_lv_nmos ad=79.8f pd=0.8u as=0 ps=0 w=0.42u l=1u
X1680 VDD.t717 a_4187_2434# a_6391_5315# VDD.t348 sg13_lv_pmos ad=0.3808p pd=2.92u as=0.2128p ps=1.5u w=1.12u l=0.6u
X1681 VSS.t994 a_7803_1842# a_8237_1842# VSS.t2354 sg13_lv_nmos ad=0.1406p pd=1.12u as=0.2516p ps=2.16u w=0.74u l=0.13u
X1682 VSS.t549 VSS.t546 VSS.t546 VSS.t547 sg13_lv_nmos ad=0.1406p pd=1.12u as=0 ps=0 w=0.74u l=0.13u
X1683 a_24875_16071# a_24665_16071# VSS.t70 VSS.t2064 sg13_lv_nmos ad=0.1406p pd=1.12u as=0.1665p ps=1.19u w=0.74u l=0.13u
X1684 VDD.t1596 a_2873_15358# a_3171_15338.t0 VDD.t90 sg13_lv_pmos ad=0.4256p pd=3u as=0.2128p ps=1.5u w=1.12u l=0.13u
X1685 VSS.t439 VDD.t1624 VSS.t441 VSS.t440 sg13_lv_nmos ad=79.8f pd=0.8u as=0 ps=0 w=0.42u l=1u
X1686 VSS.t2088 a_2873_15358# a_3171_15338.t1 VSS.t1075 sg13_lv_nmos ad=0.2812p pd=2.24u as=0.1406p ps=1.12u w=0.74u l=0.13u
X1687 a_19311_7532# a_19073_7532# a_19203_7532# VSS.t2302 sg13_lv_nmos ad=0.1406p pd=1.12u as=0.2516p ps=2.16u w=0.74u l=0.2u
X1688 VDD.t749 a_4187_2434# a_16271_2470# VDD.t373 sg13_lv_pmos ad=0.3808p pd=2.92u as=0.2128p ps=1.5u w=1.12u l=0.6u
X1689 VSS.t1097 a_8563_16869# a_8997_16869# VSS.t1504 sg13_lv_nmos ad=0.1406p pd=1.12u as=0.2516p ps=2.16u w=0.74u l=0.13u
X1690 a_21835_13226# a_21625_13226# VSS.t1523 VSS.t2345 sg13_lv_nmos ad=0.1406p pd=1.12u as=0.1665p ps=1.19u w=0.74u l=0.13u
X1691 a_13470_16071# a_13444_16035# a_13368_16071# VDD.t90 sg13_lv_pmos ad=0.3808p pd=2.92u as=0.2128p ps=1.5u w=1.12u l=0.13u
X1692 a_5768_3889# a_5197_4687# VSS.t872 VSS.t871 sg13_lv_nmos ad=0.1406p pd=1.12u as=0.2516p ps=2.16u w=0.74u l=0.13u
X1693 a_4111_4687# CHAN2_DELAY_IN a_4003_4687# VSS.t1492 sg13_lv_nmos ad=0.1406p pd=1.12u as=0.2516p ps=2.16u w=0.74u l=0.2u
X1694 VDD.t1202 a_3171_3892.t4 a_21044_3853# VDD.t0 sg13_lv_pmos ad=0.3808p pd=2.92u as=0.3808p ps=2.92u w=1.12u l=0.13u
X1695 VSS.t419 VDD.t1629 VSS.t419 VSS.t418 sg13_lv_nmos ad=0.1428p pd=1.52u as=0 ps=0 w=0.42u l=1u
X1696 VDD.t1081 a_1721_4240# a_2019_3892.t0 VDD.t0 sg13_lv_pmos ad=0.4256p pd=3u as=0.2128p ps=1.5u w=1.12u l=0.13u
X1697 VDD.t739 a_4187_2434# a_20831_5315# VDD.t348 sg13_lv_pmos ad=0.3808p pd=2.92u as=0.2128p ps=1.5u w=1.12u l=0.6u
X1698 VDD.t936 a_26043_1842# a_26477_1842# VDD.t373 sg13_lv_pmos ad=0.2128p pd=1.5u as=0.3808p ps=2.92u w=1.12u l=0.13u
X1699 a_27915_13226# a_27705_13226# VDD.t1305 VDD.t5 sg13_lv_pmos ad=0.2128p pd=1.5u as=0.252p ps=1.57u w=1.12u l=0.13u
X1700 VDD.t84 VSS.t372 VDD.t82 VDD.t0 sg13_lv_pmos ad=0.19p pd=1.38u as=0 ps=0 w=1u l=1u
X1701 VSS.t27 a_1544_16071# a_1815_16422# VSS.t1816 sg13_lv_nmos ad=0.1331p pd=1.12u as=0.1216p ps=1.02u w=0.64u l=0.13u
X1702 a_17553_14024# a_17357_14024# VSS.t1480 VSS.t1971 sg13_lv_nmos ad=0.2516p pd=2.16u as=0.1406p ps=1.12u w=0.74u l=0.13u
X1703 a_5731_15316# a_2019_15338.t3 a_4350_16071# VSS.t2259 sg13_lv_nmos ad=0.2516p pd=2.16u as=0.2516p ps=2.16u w=0.74u l=0.13u
X1704 a_22488_1044# a_21917_1842# VSS.t708 VSS.t1530 sg13_lv_nmos ad=0.1406p pd=1.12u as=0.2516p ps=2.16u w=0.74u l=0.13u
X1705 VDD.t1024 REF_MUX_SEL4 a_15765_6153# VDD.t67 sg13_lv_pmos ad=0.3808p pd=2.92u as=0.3808p ps=2.92u w=1.12u l=0.13u
X1706 VDD.t665 a_4187_2434# a_23871_17497# VDD.t368 sg13_lv_pmos ad=0.3808p pd=2.92u as=0.2128p ps=1.5u w=1.12u l=0.6u
X1707 VSS.t1307 a_4187_1764.t131 a_4111_14024# VSS.t1707 sg13_lv_nmos ad=0.2516p pd=2.16u as=0.1406p ps=1.12u w=0.74u l=0.6u
X1708 a_3543_331# CHAN3_MUX_SEL2 a_3449_331# VSS.t1633 sg13_lv_nmos ad=0.1216p pd=1.02u as=0.2176p ps=1.96u w=0.64u l=0.13u
X1709 VSS.t305 VDD.t1670 VSS.t305 VSS.t304 sg13_lv_nmos ad=0.1428p pd=1.52u as=0 ps=0 w=0.42u l=1u
X1710 a_23355_13226# a_23145_13226# VDD.t1429 VDD.t5 sg13_lv_pmos ad=0.2128p pd=1.5u as=0.252p ps=1.57u w=1.12u l=0.13u
X1711 a_8155_6734# a_7945_6734# VDD.t606 VDD.t67 sg13_lv_pmos ad=0.2128p pd=1.5u as=0.252p ps=1.57u w=1.12u l=0.13u
X1712 a_22590_1044# a_24084_1008# a_24008_1044# VDD.t2 sg13_lv_pmos ad=0.3808p pd=2.92u as=0.2128p ps=1.5u w=1.12u l=0.13u
X1713 VDD.t156 VSS.t407 VDD.t154 VDD.t2 sg13_lv_pmos ad=0.19p pd=1.38u as=0 ps=0 w=1u l=1u
X1714 VSS.t1167 a_13123_4687# a_13557_4687# VSS.t2304 sg13_lv_nmos ad=0.1406p pd=1.12u as=0.2516p ps=2.16u w=0.74u l=0.13u
X1715 a_10191_5315# a_9953_4687# a_10083_4687# VDD.t348 sg13_lv_pmos ad=0.2128p pd=1.5u as=0.3808p ps=2.92u w=1.12u l=0.2u
X1716 a_23111_7532# a_22873_7532# a_23003_7532# VSS.t610 sg13_lv_nmos ad=0.1406p pd=1.12u as=0.2516p ps=2.16u w=0.74u l=0.2u
X1717 a_13106_11047# a_12907_11110# VSS.t473 VSS.t2347 sg13_lv_nmos ad=0.27427p pd=2.28u as=1.45407p ps=9.445u w=0.795u l=0.13u
X1718 VDD.t758 a_4187_2434# a_20071_2470# VDD.t373 sg13_lv_pmos ad=0.3808p pd=2.92u as=0.2128p ps=1.5u w=1.12u l=0.6u
X1719 VDD.t1336 a_10843_14024# a_11277_14024# VDD.t374 sg13_lv_pmos ad=0.2128p pd=1.5u as=0.3808p ps=2.92u w=1.12u l=0.13u
X1720 a_25913_4687# a_25717_4687# VSS.t1450 VSS.t1619 sg13_lv_nmos ad=0.2516p pd=2.16u as=0.1406p ps=1.12u w=0.74u l=0.13u
X1721 a_27048_6734# a_26477_7532# VDD.t1537 VDD.t67 sg13_lv_pmos ad=0.2128p pd=1.5u as=0.3808p ps=2.92u w=1.12u l=0.13u
X1722 a_5731_12471# a_8745_12701# a_7390_13226# VDD.t5 sg13_lv_pmos ad=0.3808p pd=2.92u as=0.3808p ps=2.92u w=1.12u l=0.13u
X1723 a_27671_8160# a_27433_7532# a_27563_7532# VDD.t346 sg13_lv_pmos ad=0.2128p pd=1.5u as=0.3808p ps=2.92u w=1.12u l=0.2u
X1724 VSS.t911 a_17683_7532# a_18117_7532# VSS.t2303 sg13_lv_nmos ad=0.1406p pd=1.12u as=0.2516p ps=2.16u w=0.74u l=0.13u
X1725 a_7151_14652# a_6913_14024# a_7043_14024# VDD.t374 sg13_lv_pmos ad=0.2128p pd=1.5u as=0.3808p ps=2.92u w=1.12u l=0.2u
X1726 a_10713_7532# a_10517_7532# VSS.t614 VSS.t613 sg13_lv_nmos ad=0.2516p pd=2.16u as=0.1406p ps=1.12u w=0.74u l=0.13u
X1727 VDD.t423 VDD.t421 VDD.t422 VDD.t368 sg13_lv_pmos ad=0.3808p pd=2.92u as=0 ps=0 w=1.12u l=0.13u
X1728 a_12715_13226# a_12505_13226# VSS.t1958 VSS.t2075 sg13_lv_nmos ad=0.1406p pd=1.12u as=0.1665p ps=1.19u w=0.74u l=0.13u
X1729 VSS.t1004 a_19963_16869# a_20397_16869# VSS.t1755 sg13_lv_nmos ad=0.1406p pd=1.12u as=0.2516p ps=2.16u w=0.74u l=0.13u
X1730 a_7673_16869# a_7477_16869# VDD.t1099 VDD.t368 sg13_lv_pmos ad=0.3808p pd=2.92u as=0.2128p ps=1.5u w=1.12u l=0.13u
X1731 a_11195_16071# a_10985_16071# VSS.t672 VSS.t1965 sg13_lv_nmos ad=0.1406p pd=1.12u as=0.1665p ps=1.19u w=0.74u l=0.13u
X1732 VSS.t1392 a_6283_14024# a_6717_14024# VSS.t1579 sg13_lv_nmos ad=0.1406p pd=1.12u as=0.2516p ps=2.16u w=0.74u l=0.13u
X1733 VSS.t940 a_25717_14024# a_26185_13226# VSS.t939 sg13_lv_nmos ad=0.1665p pd=1.19u as=0.2516p ps=2.16u w=0.74u l=0.13u
X1734 VSS.t100 a_2019_6737.t8 a_7364_6698# VSS.t2255 sg13_lv_nmos ad=0.2516p pd=2.16u as=0.2516p ps=2.16u w=0.74u l=0.13u
X1735 a_5768_6734# a_5197_7532# VDD.t363 VDD.t67 sg13_lv_pmos ad=0.2128p pd=1.5u as=0.3808p ps=2.92u w=1.12u l=0.13u
X1736 VSS.t1364 a_24197_4687# a_24665_3889# VSS.t1363 sg13_lv_nmos ad=0.1665p pd=1.19u as=0.2516p ps=2.16u w=0.74u l=0.13u
X1737 a_24008_13226# a_23437_14024# VSS.t1670 VSS.t2333 sg13_lv_nmos ad=0.1406p pd=1.12u as=0.2516p ps=2.16u w=0.74u l=0.13u
X1738 VDD.t192 VSS.t462 VDD.t191 VDD.t2 sg13_lv_pmos ad=0.19p pd=1.38u as=0 ps=0 w=1u l=1u
X1739 VSS.t147 a_2873_1395# a_3171_1047.t1 VSS.t1840 sg13_lv_nmos ad=0.2812p pd=2.24u as=0.1406p ps=1.12u w=0.74u l=0.13u
X1740 a_16510_3889# a_3171_3892.t5 a_17928_3889# VSS.t1728 sg13_lv_nmos ad=0.2516p pd=2.16u as=0.1406p ps=1.12u w=0.74u l=0.13u
X1741 a_14751_1842# a_14513_1842# a_14643_1842# VSS.t640 sg13_lv_nmos ad=0.1406p pd=1.12u as=0.2516p ps=2.16u w=0.74u l=0.2u
X1742 a_22488_16071# a_21917_16869# VSS.t1102 VSS.t2237 sg13_lv_nmos ad=0.1406p pd=1.12u as=0.2516p ps=2.16u w=0.74u l=0.13u
X1743 a_25630_1044# a_27991_1008# a_27915_1044# VDD.t2 sg13_lv_pmos ad=0.3808p pd=2.92u as=0.2128p ps=1.5u w=1.12u l=0.13u
X1744 VDD.t74 VSS.t239 VDD.t73 VDD.t5 sg13_lv_pmos ad=0.34p pd=2.68u as=0 ps=0 w=1u l=1u
X1745 VSS.t832 a_4187_1764.t98 VSS.t830 VSS.t815 sg13_lv_nmos ad=1.33p pd=7.38u as=0 ps=0 w=7u l=7u
X1746 VSS.t1147 a_7803_7532# a_8237_7532# VSS.t2232 sg13_lv_nmos ad=0.1406p pd=1.12u as=0.2516p ps=2.16u w=0.74u l=0.13u
X1747 a_13132_11110# a_13106_11047# VDD.t381 VDD.t355 sg13_lv_pmos ad=0.3927p pd=2.99u as=1.10612p ps=6.66u w=1.155u l=0.13u
X1748 VSS.t559 VSS.t559 VSS.t561 VSS.t560 sg13_lv_nmos ad=0.1406p pd=1.12u as=0 ps=0 w=0.74u l=0.13u
X1749 VDD.t707 a_4187_2434# a_16271_8160# VDD.t346 sg13_lv_pmos ad=0.3808p pd=2.92u as=0.2128p ps=1.5u w=1.12u l=0.6u
X1750 a_7673_4687# a_7477_4687# VDD.t1496 VDD.t348 sg13_lv_pmos ad=0.3808p pd=2.92u as=0.2128p ps=1.5u w=1.12u l=0.13u
X1751 VDD.t428 VDD.t426 VDD.t427 VDD.t368 sg13_lv_pmos ad=0.3808p pd=2.92u as=0 ps=0 w=1.12u l=0.6u
X1752 a_25630_16071# a_3747_16074.t2 a_27915_16071# VSS.t2246 sg13_lv_nmos ad=0.2516p pd=2.16u as=0.1406p ps=1.12u w=0.74u l=0.13u
X1753 VDD.t610 a_4187_2434# a_10191_17497# VDD.t368 sg13_lv_pmos ad=0.3808p pd=2.92u as=0.2128p ps=1.5u w=1.12u l=0.6u
X1754 a_4111_1842# CHAN3_DELAY_IN a_4003_1842# VSS.t1177 sg13_lv_nmos ad=0.1406p pd=1.12u as=0.2516p ps=2.16u w=0.74u l=0.2u
X1755 a_18551_14024# a_18313_14024# a_18443_14024# VSS.t1833 sg13_lv_nmos ad=0.1406p pd=1.12u as=0.2516p ps=2.16u w=0.74u l=0.2u
X1756 a_22590_13226# a_3747_13229.t3 a_24875_13226# VSS.t1643 sg13_lv_nmos ad=0.2516p pd=2.16u as=0.1406p ps=1.12u w=0.74u l=0.13u
X1757 a_3171_16074.t0 a_2873_16422# VDD.t1210 VDD.t90 sg13_lv_pmos ad=0.2128p pd=1.5u as=0.1918p ps=1.5u w=1.12u l=0.13u
X1758 VSS.t2198 a_3747_311.t3 a_14825_519# VSS.t2197 sg13_lv_nmos ad=0.2516p pd=2.16u as=0.2516p ps=2.16u w=0.74u l=0.13u
X1759 a_17553_1842# a_17357_1842# VDD.t518 VDD.t373 sg13_lv_pmos ad=0.3808p pd=2.92u as=0.2128p ps=1.5u w=1.12u l=0.13u
X1760 VDD.t244 VSS.t216 VDD.t242 VDD.t90 sg13_lv_pmos ad=0.19p pd=1.38u as=0 ps=0 w=1u l=1u
X1761 VSS.t1859 a_1256_289# a_2967_331# VSS.t2205 sg13_lv_nmos ad=0.1331p pd=1.12u as=0.1216p ps=1.02u w=0.64u l=0.13u
X1762 VSS.t907 a_1544_1044# a_2391_1395# VSS.t906 sg13_lv_nmos ad=0.1331p pd=1.12u as=0.1216p ps=1.02u w=0.64u l=0.13u
X1763 a_22590_16071# a_2595_16074.t3 a_23355_16071# VSS.t1553 sg13_lv_nmos ad=0.2516p pd=2.16u as=0.1406p ps=1.12u w=0.74u l=0.13u
X1764 VDD.t845 a_26043_7532# a_26477_7532# VDD.t346 sg13_lv_pmos ad=0.2128p pd=1.5u as=0.3808p ps=2.92u w=1.12u l=0.13u
X1765 a_8671_2470# a_8433_1842# a_8563_1842# VDD.t373 sg13_lv_pmos ad=0.2128p pd=1.5u as=0.3808p ps=2.92u w=1.12u l=0.2u
X1766 VSS.t1844 a_8997_16869# a_9465_16071# VSS.t1843 sg13_lv_nmos ad=0.1665p pd=1.19u as=0.2516p ps=2.16u w=0.74u l=0.13u
X1767 a_13470_1044# a_2019_1047.t6 a_13368_1044# VSS.t2013 sg13_lv_nmos ad=0.2516p pd=2.16u as=0.1406p ps=1.12u w=0.74u l=0.13u
X1768 a_2019_1047.t1 a_1721_1395# VSS.t905 VSS.t1786 sg13_lv_nmos ad=0.1406p pd=1.12u as=0.1331p ps=1.12u w=0.74u l=0.13u
X1769 VSS.t338 VDD.t1656 VSS.t338 VSS.t339 sg13_lv_nmos ad=79.8f pd=0.8u as=0 ps=0 w=0.42u l=1u
X1770 a_6854_11144# a_6854_11144# a_9444_10280# VSS.t137 sg13_lv_nmos ad=0.38p pd=2.38u as=0.68p ps=4.68u w=2u l=1u
X1771 a_22488_6734# a_21917_7532# VSS.t1121 VSS.t1490 sg13_lv_nmos ad=0.1406p pd=1.12u as=0.2516p ps=2.16u w=0.74u l=0.13u
X1772 VSS.t387 a_3171_3156.t2 a_23945_3364# VSS.t787 sg13_lv_nmos ad=0.2516p pd=2.16u as=0.2516p ps=2.16u w=0.74u l=0.13u
X1773 VSS.t2081 a_1256_3134# a_2967_3176# VSS.t146 sg13_lv_nmos ad=0.1331p pd=1.12u as=0.1216p ps=1.02u w=0.64u l=0.13u
X1774 VDD.t97 VSS.t305 VDD.t96 VDD.t67 sg13_lv_pmos ad=0.34p pd=2.68u as=0 ps=0 w=1u l=1u
X1775 VSS.t2068 a_3449_13577# a_3747_13229.t1 VSS.t2067 sg13_lv_nmos ad=0.2812p pd=2.24u as=0.1406p ps=1.12u w=0.74u l=0.13u
X1776 a_15964_289# a_15765_463# a_5731_289# VSS.t1577 sg13_lv_nmos ad=0.2183p pd=1.33u as=0.2516p ps=2.16u w=0.74u l=0.13u
X1777 VDD.t1509 CHAN2_MUX_SEL4 a_15765_3308# VDD.t0 sg13_lv_pmos ad=0.3808p pd=2.92u as=0.3808p ps=2.92u w=1.12u l=0.13u
X1778 VSS.t1893 a_3747_6001.t3 a_14825_6209# VSS.t1892 sg13_lv_nmos ad=0.2516p pd=2.16u as=0.2516p ps=2.16u w=0.74u l=0.13u
X1779 VDD.t632 a_4187_2434# a_23871_14652# VDD.t374 sg13_lv_pmos ad=0.3808p pd=2.92u as=0.2128p ps=1.5u w=1.12u l=0.6u
X1780 VSS.t683 a_3171_3892.t4 a_21044_3853# VSS.t1735 sg13_lv_nmos ad=0.2516p pd=2.16u as=0.2516p ps=2.16u w=0.74u l=0.13u
X1781 a_17928_16071# a_17357_16869# VDD.t1457 VDD.t90 sg13_lv_pmos ad=0.2128p pd=1.5u as=0.3808p ps=2.92u w=1.12u l=0.13u
X1782 VDD.t725 a_4187_2434# a_11711_5315# VDD.t348 sg13_lv_pmos ad=0.3808p pd=2.92u as=0.2128p ps=1.5u w=1.12u l=0.6u
X1783 a_3747_6001.t0 a_3449_6021# VDD.t388 VDD.t67 sg13_lv_pmos ad=0.2128p pd=1.5u as=0.1918p ps=1.5u w=1.12u l=0.13u
X1784 a_25630_13226# a_26471_13190# a_26395_13226# VDD.t5 sg13_lv_pmos ad=0.3808p pd=2.92u as=0.2128p ps=1.5u w=1.12u l=0.13u
X1785 VSS.t739 a_3171_1047.t3 a_24084_1008# VSS.t1286 sg13_lv_nmos ad=0.2516p pd=2.16u as=0.2516p ps=2.16u w=0.74u l=0.13u
X1786 VSS.t637 a_13123_1842# a_13557_1842# VSS.t2331 sg13_lv_nmos ad=0.1406p pd=1.12u as=0.2516p ps=2.16u w=0.74u l=0.13u
X1787 VDD.t529 a_24197_7532# a_24665_6734# VDD.t67 sg13_lv_pmos ad=0.252p pd=1.57u as=0.3808p ps=2.92u w=1.12u l=0.13u
X1788 VDD.t1270 a_12363_16869# a_12797_16869# VDD.t368 sg13_lv_pmos ad=0.2128p pd=1.5u as=0.3808p ps=2.92u w=1.12u l=0.13u
X1789 VDD.t613 a_4187_2434# a_20071_8160# VDD.t346 sg13_lv_pmos ad=0.3808p pd=2.92u as=0.2128p ps=1.5u w=1.12u l=0.6u
X1790 VDD.t313 VSS.t464 VDD.t312 VDD.t2 sg13_lv_pmos ad=0.34p pd=2.68u as=0 ps=0 w=1u l=1u
X1791 a_16510_6734# a_18004_6698# a_17928_6734# VDD.t67 sg13_lv_pmos ad=0.3808p pd=2.92u as=0.2128p ps=1.5u w=1.12u l=0.13u
X1792 a_8671_17497# a_8433_16869# a_8563_16869# VDD.t368 sg13_lv_pmos ad=0.2128p pd=1.5u as=0.3808p ps=2.92u w=1.12u l=0.2u
X1793 a_25913_1842# a_25717_1842# VSS.t1442 VSS.t1441 sg13_lv_nmos ad=0.2516p pd=2.16u as=0.1406p ps=1.12u w=0.74u l=0.13u
X1794 VDD.t1503 a_21483_4687# a_21917_4687# VDD.t348 sg13_lv_pmos ad=0.2128p pd=1.5u as=0.3808p ps=2.92u w=1.12u l=0.13u
X1795 VDD.t1326 a_7477_14024# a_7945_13226# VDD.t5 sg13_lv_pmos ad=0.252p pd=1.57u as=0.3808p ps=2.92u w=1.12u l=0.13u
X1796 a_2297_331# CHAN3_MUX_SEL2 VDD.t1170 VDD.t2 sg13_lv_pmos ad=0.1596p pd=1.22u as=0.2856p ps=2.36u w=0.84u l=0.13u
X1797 a_4187_1764.t0 DLL_RESETN VDD.t1502 VDD.t456 sg13_lv_pmos ad=0.158p pd=1.245u as=0.272p ps=2.28u w=0.8u l=0.2u
X1798 VSS.t447 VDD.t1622 VSS.t446 VSS.t445 sg13_lv_nmos ad=0.1428p pd=1.52u as=0 ps=0 w=0.42u l=1u
X1799 a_21353_1842# a_21157_1842# VDD.t599 VDD.t373 sg13_lv_pmos ad=0.3808p pd=2.92u as=0.2128p ps=1.5u w=1.12u l=0.13u
X1800 VDD.t434 VDD.t432 VDD.t433 VDD.t374 sg13_lv_pmos ad=0.3808p pd=2.92u as=0 ps=0 w=1.12u l=0.13u
X1801 a_5768_13226# a_5197_14024# VDD.t1316 VDD.t5 sg13_lv_pmos ad=0.2128p pd=1.5u as=0.3808p ps=2.92u w=1.12u l=0.13u
X1802 a_13368_3889# a_12797_4687# VDD.t1505 VDD.t0 sg13_lv_pmos ad=0.2128p pd=1.5u as=0.3808p ps=2.92u w=1.12u l=0.13u
X1803 VDD.t618 a_4187_2434# a_9431_17497# VDD.t368 sg13_lv_pmos ad=0.3808p pd=2.92u as=0.2128p ps=1.5u w=1.12u l=0.6u
X1804 VDD.t512 a_26803_16869# a_27237_16869# VDD.t368 sg13_lv_pmos ad=0.2128p pd=1.5u as=0.3808p ps=2.92u w=1.12u l=0.13u
X1805 a_16108_15316# a_3747_15338.t2 a_25630_16071# VSS.t1742 sg13_lv_nmos ad=0.2516p pd=2.16u as=0.2516p ps=2.16u w=0.74u l=0.13u
X1806 a_7673_14024# a_7477_14024# VDD.t1323 VDD.t374 sg13_lv_pmos ad=0.3808p pd=2.92u as=0.2128p ps=1.5u w=1.12u l=0.13u
X1807 a_2873_331# CHAN3_MUX_SEL3 VDD.t1163 VDD.t2 sg13_lv_pmos ad=0.1596p pd=1.22u as=0.2856p ps=2.36u w=0.84u l=0.13u
X1808 VDD.t857 a_7043_1842# a_7477_1842# VDD.t373 sg13_lv_pmos ad=0.2128p pd=1.5u as=0.3808p ps=2.92u w=1.12u l=0.13u
X1809 a_15464_9374# a_14851_10872# VDD.t912 VDD.t355 sg13_lv_pmos ad=0.4312p pd=3.01u as=0.2639p ps=1.81u w=1.12u l=0.13u
X1810 VSS.t864 a_2873_7085# a_3171_6737.t1 VSS.t1352 sg13_lv_nmos ad=0.2812p pd=2.24u as=0.1406p ps=1.12u w=0.74u l=0.13u
X1811 VSS.t312 VDD.t1665 VSS.t312 VSS.t316 sg13_lv_nmos ad=0.1428p pd=1.52u as=0 ps=0 w=0.42u l=1u
X1812 a_10430_13226# a_2595_13229.t7 a_11195_13226# VSS.t1011 sg13_lv_nmos ad=0.2516p pd=2.16u as=0.1406p ps=1.12u w=0.74u l=0.13u
X1813 a_14751_7532# a_14513_7532# a_14643_7532# VSS.t2125 sg13_lv_nmos ad=0.1406p pd=1.12u as=0.2516p ps=2.16u w=0.74u l=0.2u
X1814 VSS.t202 VDD.t1699 VSS.t202 VSS.t204 sg13_lv_nmos ad=0.1428p pd=1.52u as=0 ps=0 w=0.42u l=1u
X1815 a_6326_10280# a_6326_10280# VDD.t985 VDD.t355 sg13_lv_pmos ad=0.38p pd=2.38u as=0.38p ps=2.38u w=2u l=1u
X1816 a_5778_9057# a_6126_9506# a_6326_10280# VSS.t46 sg13_lv_nmos ad=0.68p pd=4.68u as=0.42p ps=2.42u w=2u l=1u
X1817 VSS.t534 VSS.t534 VSS.t536 VSS.t535 sg13_lv_nmos ad=0.1406p pd=1.12u as=0 ps=0 w=0.74u l=0.13u
X1818 VSS.t365 VDD.t1645 VSS.t365 VSS.t367 sg13_lv_nmos ad=0.1428p pd=1.52u as=0 ps=0 w=0.42u l=1u
X1819 a_4350_13226# a_6711_13190# a_6635_13226# VDD.t5 sg13_lv_pmos ad=0.3808p pd=2.92u as=0.2128p ps=1.5u w=1.12u l=0.13u
X1820 VDD.t403 a_12849_11557# a_13306_11995# VDD.t355 sg13_lv_pmos ad=0.36237p pd=2.605u as=79.8f ps=0.8u w=0.42u l=0.13u
X1821 CHAN2_DELAY_OUT_LAST a_27997_4687# VSS.t1367 VSS.t2313 sg13_lv_nmos ad=0.2516p pd=2.16u as=0.1406p ps=1.12u w=0.74u l=0.13u
X1822 a_13470_16071# a_14964_16035# a_14888_16071# VDD.t90 sg13_lv_pmos ad=0.3808p pd=2.92u as=0.2128p ps=1.5u w=1.12u l=0.13u
X1823 a_8155_1044# a_7945_1044# VDD.t1006 VDD.t2 sg13_lv_pmos ad=0.2128p pd=1.5u as=0.252p ps=1.57u w=1.12u l=0.13u
X1824 a_21835_16071# a_21625_16071# VSS.t1978 VSS.t1977 sg13_lv_nmos ad=0.1406p pd=1.12u as=0.1665p ps=1.19u w=0.74u l=0.13u
X1825 a_4350_3889# a_6711_3853# a_6635_3889# VDD.t0 sg13_lv_pmos ad=0.3808p pd=2.92u as=0.2128p ps=1.5u w=1.12u l=0.13u
X1826 VDD.t440 VDD.t438 VDD.t439 VDD.t374 sg13_lv_pmos ad=0.3808p pd=2.92u as=0 ps=0 w=1.12u l=0.6u
X1827 VSS.t8 a_3171_13229.t9 a_5844_13190# VSS.t7 sg13_lv_nmos ad=0.2516p pd=2.16u as=0.2516p ps=2.16u w=0.74u l=0.13u
X1828 VSS.t1215 a_18117_1842# a_18585_1044# VSS.t1214 sg13_lv_nmos ad=0.1665p pd=1.19u as=0.2516p ps=2.16u w=0.74u l=0.13u
X1829 VSS.t1798 a_5523_16869# a_5957_16869# VSS.t1797 sg13_lv_nmos ad=0.1406p pd=1.12u as=0.2516p ps=2.16u w=0.74u l=0.13u
X1830 VDD.t626 a_4187_2434# a_10191_14652# VDD.t374 sg13_lv_pmos ad=0.3808p pd=2.92u as=0.2128p ps=1.5u w=1.12u l=0.6u
X1831 a_4111_7532# REF_CLK a_4003_7532# VSS.t131 sg13_lv_nmos ad=0.1406p pd=1.12u as=0.2516p ps=2.16u w=0.74u l=0.2u
X1832 VDD.t1286 a_3171_6737.t4 a_21044_6698# VDD.t67 sg13_lv_pmos ad=0.3808p pd=2.92u as=0.3808p ps=2.92u w=1.12u l=0.13u
X1833 a_10430_16071# a_10404_16035# a_10328_16071# VDD.t90 sg13_lv_pmos ad=0.3808p pd=2.92u as=0.2128p ps=1.5u w=1.12u l=0.13u
X1834 a_17553_7532# a_17357_7532# VDD.t397 VDD.t346 sg13_lv_pmos ad=0.3808p pd=2.92u as=0.2128p ps=1.5u w=1.12u l=0.13u
X1835 VSS.t864 a_1544_6734# a_2391_7085# VSS.t1090 sg13_lv_nmos ad=0.1331p pd=1.12u as=0.1216p ps=1.02u w=0.64u l=0.13u
X1836 VDD.t69 VSS.t338 VDD.t68 VDD.t67 sg13_lv_pmos ad=0.19p pd=1.38u as=0 ps=0 w=1u l=1u
X1837 a_8671_8160# a_8433_7532# a_8563_7532# VDD.t346 sg13_lv_pmos ad=0.2128p pd=1.5u as=0.3808p ps=2.92u w=1.12u l=0.2u
X1838 a_6913_4687# a_6717_4687# VSS.t20 VSS.t19 sg13_lv_nmos ad=0.2516p pd=2.16u as=0.1406p ps=1.12u w=0.74u l=0.13u
X1839 VSS.t860 a_4187_1764.t46 a_18551_4687# VSS.t859 sg13_lv_nmos ad=0.2516p pd=2.16u as=0.1406p ps=1.12u w=0.74u l=0.6u
X1840 a_27048_1044# a_26477_1842# VDD.t1485 VDD.t2 sg13_lv_pmos ad=0.2128p pd=1.5u as=0.3808p ps=2.92u w=1.12u l=0.13u
X1841 a_19550_3889# a_20391_3853# a_20315_3889# VDD.t0 sg13_lv_pmos ad=0.3808p pd=2.92u as=0.2128p ps=1.5u w=1.12u l=0.13u
X1842 a_2019_6737.t1 a_1721_7085# VSS.t864 VSS.t1310 sg13_lv_nmos ad=0.1406p pd=1.12u as=0.1331p ps=1.12u w=0.74u l=0.13u
X1843 a_13470_6734# a_2019_6737.t6 a_13368_6734# VSS.t1116 sg13_lv_nmos ad=0.2516p pd=2.16u as=0.1406p ps=1.12u w=0.74u l=0.13u
X1844 a_24393_16869# a_24197_16869# VDD.t371 VDD.t368 sg13_lv_pmos ad=0.3808p pd=2.92u as=0.2128p ps=1.5u w=1.12u l=0.13u
X1845 VDD.t49 VSS.t86 VDD.t48 VDD.t0 sg13_lv_pmos ad=0.34p pd=2.68u as=0 ps=0 w=1u l=1u
X1846 a_24875_13226# a_24665_13226# VDD.t977 VDD.t5 sg13_lv_pmos ad=0.2128p pd=1.5u as=0.252p ps=1.57u w=1.12u l=0.13u
X1847 VDD.t973 a_17683_16869# a_18117_16869# VDD.t368 sg13_lv_pmos ad=0.2128p pd=1.5u as=0.3808p ps=2.92u w=1.12u l=0.13u
X1848 VSS.t258 VDD.t1682 VSS.t257 VSS.t256 sg13_lv_nmos ad=0.1428p pd=1.52u as=0 ps=0 w=0.42u l=1u
X1849 VDD.t804 CHAN2_MUX_SEL3 a_3449_3176# VDD.t0 sg13_lv_pmos ad=0.1918p pd=1.5u as=0.1596p ps=1.22u w=0.84u l=0.13u
X1850 VDD.t659 a_4187_2434# a_20831_17497# VDD.t368 sg13_lv_pmos ad=0.3808p pd=2.92u as=0.2128p ps=1.5u w=1.12u l=0.6u
X1851 a_6326_10280# a_6126_9506# a_5778_9057# VSS.t46 sg13_lv_nmos ad=0.38p pd=2.38u as=0.68p ps=4.68u w=2u l=1u
X1852 a_25391_5315# a_25153_4687# a_25283_4687# VDD.t348 sg13_lv_pmos ad=0.2128p pd=1.5u as=0.3808p ps=2.92u w=1.12u l=0.2u
X1853 a_19550_16071# a_20391_16035# a_20315_16071# VDD.t90 sg13_lv_pmos ad=0.3808p pd=2.92u as=0.2128p ps=1.5u w=1.12u l=0.13u
X1854 VSS.t209 VDD.t1697 VSS.t209 VSS.t208 sg13_lv_nmos ad=0.1428p pd=1.52u as=0 ps=0 w=0.42u l=1u
X1855 a_5768_1044# a_5197_1842# VDD.t1294 VDD.t2 sg13_lv_pmos ad=0.2128p pd=1.5u as=0.3808p ps=2.92u w=1.12u l=0.13u
X1856 VSS.t1280 a_3171_6737.t3 a_24084_6698# VSS.t1883 sg13_lv_nmos ad=0.2516p pd=2.16u as=0.2516p ps=2.16u w=0.74u l=0.13u
X1857 VDD.t1229 a_7477_4687# a_7945_3889# VDD.t0 sg13_lv_pmos ad=0.252p pd=1.57u as=0.3808p ps=2.92u w=1.12u l=0.13u
X1858 VDD.t1243 a_5957_16869# a_6425_16071# VDD.t90 sg13_lv_pmos ad=0.252p pd=1.57u as=0.3808p ps=2.92u w=1.12u l=0.13u
X1859 VSS.t1588 a_13123_7532# a_13557_7532# VSS.t2287 sg13_lv_nmos ad=0.1406p pd=1.12u as=0.2516p ps=2.16u w=0.74u l=0.13u
X1860 a_3747_3156.t1 a_3449_3176# VSS.t925 VSS.t2076 sg13_lv_nmos ad=0.1406p pd=1.12u as=0.1331p ps=1.12u w=0.74u l=0.13u
X1861 VDD.t929 a_12363_14024# a_12797_14024# VDD.t374 sg13_lv_pmos ad=0.2128p pd=1.5u as=0.3808p ps=2.92u w=1.12u l=0.13u
X1862 VDD.t807 a_15964_12471# a_16851_12491# VDD.t5 sg13_lv_pmos ad=0.2086p pd=1.5u as=0.34p ps=2.68u w=1u l=0.13u
X1863 a_12993_4687# a_12797_4687# VDD.t358 VDD.t348 sg13_lv_pmos ad=0.3808p pd=2.92u as=0.2128p ps=1.5u w=1.12u l=0.13u
X1864 a_8671_14652# a_8433_14024# a_8563_14024# VDD.t374 sg13_lv_pmos ad=0.2128p pd=1.5u as=0.3808p ps=2.92u w=1.12u l=0.2u
X1865 a_25913_7532# a_25717_7532# VSS.t176 VSS.t175 sg13_lv_nmos ad=0.2516p pd=2.16u as=0.1406p ps=1.12u w=0.74u l=0.13u
X1866 VSS.t390 VDD.t1637 VSS.t388 VSS.t389 sg13_lv_nmos ad=79.8f pd=0.8u as=0 ps=0 w=0.42u l=1u
X1867 a_5731_15316# a_8745_15546# a_7390_16071# VDD.t90 sg13_lv_pmos ad=0.3808p pd=2.92u as=0.3808p ps=2.92u w=1.12u l=0.13u
X1868 a_21353_7532# a_21157_7532# VDD.t347 VDD.t346 sg13_lv_pmos ad=0.3808p pd=2.92u as=0.2128p ps=1.5u w=1.12u l=0.13u
X1869 VSS.t892 a_21483_16869# a_21917_16869# VSS.t1197 sg13_lv_nmos ad=0.1406p pd=1.12u as=0.2516p ps=2.16u w=0.74u l=0.13u
X1870 a_12715_16071# a_12505_16071# VSS.t676 VSS.t1960 sg13_lv_nmos ad=0.1406p pd=1.12u as=0.1665p ps=1.19u w=0.74u l=0.13u
X1871 a_5731_12471# a_5705_12701# a_4350_13226# VDD.t5 sg13_lv_pmos ad=0.3808p pd=2.92u as=0.3808p ps=2.92u w=1.12u l=0.13u
X1872 VSS.t736 a_3171_1047.t6 a_14964_1008# VSS.t1284 sg13_lv_nmos ad=0.2516p pd=2.16u as=0.2516p ps=2.16u w=0.74u l=0.13u
X1873 VSS.t1564 a_4187_1764.t41 a_22351_4687# VSS.t2069 sg13_lv_nmos ad=0.2516p pd=2.16u as=0.1406p ps=1.12u w=0.74u l=0.6u
X1874 VDD.t634 a_4187_2434# a_9431_14652# VDD.t374 sg13_lv_pmos ad=0.3808p pd=2.92u as=0.2128p ps=1.5u w=1.12u l=0.6u
X1875 VSS.t1908 a_27237_14024# a_27705_13226# VSS.t1907 sg13_lv_nmos ad=0.1665p pd=1.19u as=0.2516p ps=2.16u w=0.74u l=0.13u
X1876 a_13991_2470# a_13753_1842# a_13883_1842# VDD.t373 sg13_lv_pmos ad=0.2128p pd=1.5u as=0.3808p ps=2.92u w=1.12u l=0.2u
X1877 VDD.t170 VSS.t312 VDD.t169 VDD.t67 sg13_lv_pmos ad=0.34p pd=2.68u as=0 ps=0 w=1u l=1u
X1878 VDD.t519 a_26803_14024# a_27237_14024# VDD.t374 sg13_lv_pmos ad=0.2128p pd=1.5u as=0.3808p ps=2.92u w=1.12u l=0.13u
X1879 a_10232_11561# a_10206_11525# VSS.t632 VSS.t631 sg13_lv_nmos ad=0.2516p pd=2.16u as=0.1626p ps=1.415u w=0.74u l=0.13u
X1880 VSS.t1995 a_25717_16869# a_26185_16071# VSS.t2324 sg13_lv_nmos ad=0.1665p pd=1.19u as=0.2516p ps=2.16u w=0.74u l=0.13u
X1881 VDD.t784 a_7043_7532# a_7477_7532# VDD.t346 sg13_lv_pmos ad=0.2128p pd=1.5u as=0.3808p ps=2.92u w=1.12u l=0.13u
X1882 a_4633_16869# a_4437_16869# VDD.t788 VDD.t368 sg13_lv_pmos ad=0.3808p pd=2.92u as=0.2128p ps=1.5u w=1.12u l=0.13u
X1883 a_24008_16071# a_23437_16869# VSS.t582 VSS.t581 sg13_lv_nmos ad=0.1406p pd=1.12u as=0.2516p ps=2.16u w=0.74u l=0.13u
X1884 VSS.t589 a_2873_4240# a_3171_3892.t1 VSS.t1615 sg13_lv_nmos ad=0.2812p pd=2.24u as=0.1406p ps=1.12u w=0.74u l=0.13u
X1885 VDD.t724 a_4187_2434# a_13991_5315# VDD.t348 sg13_lv_pmos ad=0.3808p pd=2.92u as=0.2128p ps=1.5u w=1.12u l=0.6u
X1886 VSS.t2101 a_22677_14024# a_23145_13226# VSS.t2336 sg13_lv_nmos ad=0.1665p pd=1.19u as=0.2516p ps=2.16u w=0.74u l=0.13u
X1887 VDD.t865 a_2873_13577# a_3171_13229.t0 VDD.t5 sg13_lv_pmos ad=0.4256p pd=3u as=0.2128p ps=1.5u w=1.12u l=0.13u
X1888 a_6854_11144# a_6854_11144# a_9444_10280# VSS.t135 sg13_lv_nmos ad=0.38p pd=2.38u as=0.68p ps=4.68u w=2u l=1u
X1889 a_20968_13226# a_20397_14024# VSS.t1016 VSS.t1072 sg13_lv_nmos ad=0.1406p pd=1.12u as=0.2516p ps=2.16u w=0.74u l=0.13u
X1890 VDD.t1489 a_2019_311.t2 a_17865_519# VDD.t2 sg13_lv_pmos ad=0.3808p pd=2.92u as=0.3808p ps=2.92u w=1.12u l=0.13u
X1891 VSS.t229 VDD.t1690 VSS.t229 VSS.t230 sg13_lv_nmos ad=79.8f pd=0.8u as=0 ps=0 w=0.42u l=1u
X1892 a_15964_5979# a_15765_6153# a_5731_5979# VSS.t1305 sg13_lv_nmos ad=0.2183p pd=1.33u as=0.2516p ps=2.16u w=0.74u l=0.13u
X1893 a_16108_3134# a_2019_3156.t2 a_16510_3889# VSS.t0 sg13_lv_nmos ad=0.2516p pd=2.16u as=0.2516p ps=2.16u w=0.74u l=0.13u
X1894 a_11195_1044# a_10985_1044# VSS.t1400 VSS.t1596 sg13_lv_nmos ad=0.1406p pd=1.12u as=0.1665p ps=1.19u w=0.74u l=0.13u
X1895 CHAN3_DELAY_OUT_LAST a_27997_1842# VSS.t1534 VSS.t1993 sg13_lv_nmos ad=0.2516p pd=2.16u as=0.1406p ps=1.12u w=0.74u l=0.13u
X1896 a_13368_3889# a_12797_4687# VSS.t1678 VSS.t2222 sg13_lv_nmos ad=0.1406p pd=1.12u as=0.2516p ps=2.16u w=0.74u l=0.13u
X1897 VDD.t1027 a_23763_4687# a_24197_4687# VDD.t348 sg13_lv_pmos ad=0.2128p pd=1.5u as=0.3808p ps=2.92u w=1.12u l=0.13u
X1898 VDD.t644 a_4187_2434# a_11711_17497# VDD.t368 sg13_lv_pmos ad=0.3808p pd=2.92u as=0.2128p ps=1.5u w=1.12u l=0.6u
X1899 VDD.t1218 a_2297_16422# a_2595_16074.t0 VDD.t90 sg13_lv_pmos ad=0.4256p pd=3u as=0.2128p ps=1.5u w=1.12u l=0.13u
X1900 VSS.t358 VDD.t1649 VSS.t358 VSS.t357 sg13_lv_nmos ad=0.1428p pd=1.52u as=0 ps=0 w=0.42u l=1u
X1901 VSS.t909 a_18117_7532# a_18585_6734# VSS.t908 sg13_lv_nmos ad=0.1665p pd=1.19u as=0.2516p ps=2.16u w=0.74u l=0.13u
X1902 a_11195_13226# a_10985_13226# VDD.t515 VDD.t5 sg13_lv_pmos ad=0.2128p pd=1.5u as=0.252p ps=1.57u w=1.12u l=0.13u
X1903 a_25391_17497# a_25153_16869# a_25283_16869# VDD.t368 sg13_lv_pmos ad=0.2128p pd=1.5u as=0.3808p ps=2.92u w=1.12u l=0.2u
X1904 a_22590_16071# a_3747_16074.t3 a_24875_16071# VSS.t480 sg13_lv_nmos ad=0.2516p pd=2.16u as=0.1406p ps=1.12u w=0.74u l=0.13u
X1905 VDD.t911 a_24197_1842# a_24665_1044# VDD.t2 sg13_lv_pmos ad=0.252p pd=1.57u as=0.3808p ps=2.92u w=1.12u l=0.13u
X1906 a_19550_13226# a_3747_13229.t4 a_21835_13226# VSS.t1543 sg13_lv_nmos ad=0.2516p pd=2.16u as=0.1406p ps=1.12u w=0.74u l=0.13u
X1907 a_16510_1044# a_18004_1008# a_17928_1044# VDD.t2 sg13_lv_pmos ad=0.3808p pd=2.92u as=0.2128p ps=1.5u w=1.12u l=0.13u
X1908 VDD.t234 VSS.t384 VDD.t146 VDD.t0 sg13_lv_pmos ad=0.19p pd=1.38u as=0 ps=0 w=1u l=1u
X1909 VSS.t742 a_1544_3889# a_2391_4240# VSS.t741 sg13_lv_nmos ad=0.1331p pd=1.12u as=0.1216p ps=1.02u w=0.64u l=0.13u
X1910 a_6913_1842# a_6717_1842# VSS.t1110 VSS.t1396 sg13_lv_nmos ad=0.2516p pd=2.16u as=0.1406p ps=1.12u w=0.74u l=0.13u
X1911 a_22488_13226# a_21917_14024# VDD.t1055 VDD.t5 sg13_lv_pmos ad=0.2128p pd=1.5u as=0.3808p ps=2.92u w=1.12u l=0.13u
X1912 VSS.t980 a_4187_1764.t14 a_18551_1842# VSS.t979 sg13_lv_nmos ad=0.2516p pd=2.16u as=0.1406p ps=1.12u w=0.74u l=0.6u
X1913 VDD.t656 a_4187_2434# a_26151_17497# VDD.t368 sg13_lv_pmos ad=0.3808p pd=2.92u as=0.2128p ps=1.5u w=1.12u l=0.6u
X1914 a_2019_3892.t1 a_1721_4240# VSS.t742 VSS.t1461 sg13_lv_nmos ad=0.1406p pd=1.12u as=0.1331p ps=1.12u w=0.74u l=0.13u
X1915 VSS.t1614 a_1256_5979# a_2967_6021# VSS.t588 sg13_lv_nmos ad=0.1331p pd=1.12u as=0.1216p ps=1.02u w=0.64u l=0.13u
X1916 VSS.t2054 a_3449_16422# a_3747_16074.t1 VSS.t2053 sg13_lv_nmos ad=0.2812p pd=2.24u as=0.1406p ps=1.12u w=0.74u l=0.13u
X1917 a_24393_14024# a_24197_14024# VDD.t976 VDD.t374 sg13_lv_pmos ad=0.3808p pd=2.92u as=0.2128p ps=1.5u w=1.12u l=0.13u
X1918 VDD.t795 a_12363_1842# a_12797_1842# VDD.t373 sg13_lv_pmos ad=0.2128p pd=1.5u as=0.3808p ps=2.92u w=1.12u l=0.13u
X1919 VDD.t406 a_12849_11557# a_13306_10795# VDD.t355 sg13_lv_pmos ad=0.36237p pd=2.605u as=79.8f ps=0.8u w=0.42u l=0.13u
X1920 a_19833_4687# a_19637_4687# VSS.t476 VSS.t1323 sg13_lv_nmos ad=0.2516p pd=2.16u as=0.1406p ps=1.12u w=0.74u l=0.13u
X1921 a_4350_3889# a_3747_3892.t9 a_6635_3889# VSS.t1671 sg13_lv_nmos ad=0.2516p pd=2.16u as=0.1406p ps=1.12u w=0.74u l=0.13u
X1922 VDD.t716 a_4187_2434# a_26911_5315# VDD.t348 sg13_lv_pmos ad=0.3808p pd=2.92u as=0.2128p ps=1.5u w=1.12u l=0.6u
X1923 VDD.t773 a_17683_14024# a_18117_14024# VDD.t374 sg13_lv_pmos ad=0.2128p pd=1.5u as=0.3808p ps=2.92u w=1.12u l=0.13u
X1924 VDD.t677 a_4187_2434# a_20831_14652# VDD.t374 sg13_lv_pmos ad=0.3808p pd=2.92u as=0.2128p ps=1.5u w=1.12u l=0.6u
X1925 a_25630_13226# a_27991_13190# a_27915_13226# VDD.t5 sg13_lv_pmos ad=0.3808p pd=2.92u as=0.2128p ps=1.5u w=1.12u l=0.13u
X1926 VSS.t297 VDD.t1673 VSS.t295 VSS.t296 sg13_lv_nmos ad=79.8f pd=0.8u as=0 ps=0 w=0.42u l=1u
X1927 VDD.t454 a_6326_10280# a_6854_11676# VDD.t355 sg13_lv_pmos ad=0.38p pd=2.38u as=0.38p ps=2.38u w=2u l=1u
X1928 VSS.t1079 CHAN3_MUX_SEL3 a_3543_331# VSS.t1624 sg13_lv_nmos ad=0.1331p pd=1.12u as=0.1216p ps=1.02u w=0.64u l=0.13u
X1929 a_9675_3889# a_9465_3889# VDD.t1152 VDD.t0 sg13_lv_pmos ad=0.2128p pd=1.5u as=0.252p ps=1.57u w=1.12u l=0.13u
X1930 VSS.t1969 a_13557_14024# a_14025_13226# VSS.t1968 sg13_lv_nmos ad=0.1665p pd=1.19u as=0.2516p ps=2.16u w=0.74u l=0.13u
X1931 VSS.t1487 a_2595_6001.t3 a_8745_6209# VSS.t1486 sg13_lv_nmos ad=0.2516p pd=2.16u as=0.2516p ps=2.16u w=0.74u l=0.13u
X1932 VDD.t62 VSS.t247 VDD.t61 VDD.t5 sg13_lv_pmos ad=0.34p pd=2.68u as=0 ps=0 w=1u l=1u
X1933 a_4111_16869# CHAN0_DELAY_IN a_4003_16869# VSS.t1782 sg13_lv_nmos ad=0.1406p pd=1.12u as=0.2516p ps=2.16u w=0.74u l=0.2u
X1934 VDD.t1082 a_2595_3892.t8 a_8231_3853# VDD.t0 sg13_lv_pmos ad=0.3808p pd=2.92u as=0.3808p ps=2.92u w=1.12u l=0.13u
X1935 a_22590_13226# a_23431_13190# a_23355_13226# VDD.t5 sg13_lv_pmos ad=0.3808p pd=2.92u as=0.2128p ps=1.5u w=1.12u l=0.13u
X1936 a_19550_3889# a_2595_3892.t4 a_20315_3889# VSS.t1467 sg13_lv_nmos ad=0.2516p pd=2.16u as=0.1406p ps=1.12u w=0.74u l=0.13u
X1937 a_24631_4687# a_24393_4687# a_24523_4687# VSS.t1158 sg13_lv_nmos ad=0.1406p pd=1.12u as=0.2516p ps=2.16u w=0.74u l=0.2u
X1938 a_9193_4687# a_8997_4687# VSS.t114 VSS.t1606 sg13_lv_nmos ad=0.2516p pd=2.16u as=0.1406p ps=1.12u w=0.74u l=0.13u
X1939 VDD.t1001 a_8997_14024# a_9465_13226# VDD.t5 sg13_lv_pmos ad=0.252p pd=1.57u as=0.3808p ps=2.92u w=1.12u l=0.13u
X1940 a_22590_1044# a_2595_1047.t3 a_23355_1044# VSS.t737 sg13_lv_nmos ad=0.2516p pd=2.16u as=0.1406p ps=1.12u w=0.74u l=0.13u
X1941 a_2967_13577# CHAN1_MUX_SEL1 a_2873_13577# VSS.t1154 sg13_lv_nmos ad=0.1216p pd=1.02u as=0.2176p ps=1.96u w=0.64u l=0.13u
X1942 a_3747_6737.t0 a_3449_7085# VDD.t1073 VDD.t67 sg13_lv_pmos ad=0.2128p pd=1.5u as=0.1918p ps=1.5u w=1.12u l=0.13u
X1943 VSS.t978 a_8563_14024# a_8997_14024# VSS.t1949 sg13_lv_nmos ad=0.1406p pd=1.12u as=0.2516p ps=2.16u w=0.74u l=0.13u
X1944 a_13991_8160# a_13753_7532# a_13883_7532# VDD.t346 sg13_lv_pmos ad=0.2128p pd=1.5u as=0.3808p ps=2.92u w=1.12u l=0.2u
X1945 VSS.t63 a_3171_6737.t6 a_14964_6698# VSS.t1881 sg13_lv_nmos ad=0.2516p pd=2.16u as=0.2516p ps=2.16u w=0.74u l=0.13u
X1946 a_13368_6734# a_12797_7532# VDD.t585 VDD.t67 sg13_lv_pmos ad=0.2128p pd=1.5u as=0.3808p ps=2.92u w=1.12u l=0.13u
X1947 VSS.t715 a_4187_1764.t9 a_22351_1842# VSS.t714 sg13_lv_nmos ad=0.2516p pd=2.16u as=0.1406p ps=1.12u w=0.74u l=0.6u
X1948 VDD.t1192 a_3171_1047.t4 a_21044_1008# VDD.t2 sg13_lv_pmos ad=0.3808p pd=2.92u as=0.3808p ps=2.92u w=1.12u l=0.13u
X1949 VDD.t120 VSS.t358 VDD.t119 VDD.t0 sg13_lv_pmos ad=0.34p pd=2.68u as=0 ps=0 w=1u l=1u
X1950 VSS.t1778 a_7477_4687# a_7945_3889# VSS.t2213 sg13_lv_nmos ad=0.1665p pd=1.19u as=0.2516p ps=2.16u w=0.74u l=0.13u
X1951 a_16108_15316# a_3171_15338.t2 a_22590_16071# VSS.t1570 sg13_lv_nmos ad=0.2516p pd=2.16u as=0.2516p ps=2.16u w=0.74u l=0.13u
X1952 a_4633_14024# a_4437_14024# VDD.t980 VDD.t374 sg13_lv_pmos ad=0.3808p pd=2.92u as=0.2128p ps=1.5u w=1.12u l=0.13u
X1953 a_10430_13226# a_3747_13229.t7 a_12715_13226# VSS.t1540 sg13_lv_nmos ad=0.2516p pd=2.16u as=0.1406p ps=1.12u w=0.74u l=0.13u
X1954 a_23633_4687# a_23437_4687# VSS.t112 VSS.t1349 sg13_lv_nmos ad=0.2516p pd=2.16u as=0.1406p ps=1.12u w=0.74u l=0.13u
X1955 a_10430_16071# a_2595_16074.t7 a_11195_16071# VSS.t2366 sg13_lv_nmos ad=0.2516p pd=2.16u as=0.1406p ps=1.12u w=0.74u l=0.13u
X1956 a_1721_13577# a_1256_13226# VDD.t1307 VDD.t5 sg13_lv_pmos ad=0.1596p pd=1.22u as=0.2856p ps=2.36u w=0.84u l=0.13u
X1957 VSS.t96 a_9547_11862# a_9547_11862# VSS.t95 sg13_lv_nmos ad=2.39977p pd=15.495u as=0.111p ps=1.34u w=0.3u l=0.13u
X1958 VSS.t195 VDD.t1702 VSS.t195 VSS.t197 sg13_lv_nmos ad=0.1428p pd=1.52u as=0 ps=0 w=0.42u l=1u
X1959 a_15273_4687# a_15077_4687# VDD.t1014 VDD.t348 sg13_lv_pmos ad=0.3808p pd=2.92u as=0.2128p ps=1.5u w=1.12u l=0.13u
X1960 VSS.t59 a_9323_4687# a_9757_4687# VSS.t623 sg13_lv_nmos ad=0.1406p pd=1.12u as=0.2516p ps=2.16u w=0.74u l=0.13u
X1961 a_6391_5315# a_6153_4687# a_6283_4687# VDD.t348 sg13_lv_pmos ad=0.2128p pd=1.5u as=0.3808p ps=2.92u w=1.12u l=0.2u
X1962 VSS.t326 VDD.t1660 VSS.t326 VSS.t328 sg13_lv_nmos ad=0.1428p pd=1.52u as=0 ps=0 w=0.42u l=1u
X1963 VSS.t1726 a_2019_13229.t8 a_7364_13190# VSS.t1725 sg13_lv_nmos ad=0.2516p pd=2.16u as=0.2516p ps=2.16u w=0.74u l=0.13u
X1964 REF_DELAY_OUT_LAST a_27997_7532# VSS.t184 VSS.t1180 sg13_lv_nmos ad=0.2516p pd=2.16u as=0.1406p ps=1.12u w=0.74u l=0.13u
X1965 a_11195_6734# a_10985_6734# VSS.t133 VSS.t132 sg13_lv_nmos ad=0.1406p pd=1.12u as=0.1665p ps=1.19u w=0.74u l=0.13u
X1966 a_2873_7085# REF_MUX_SEL1 VDD.t1557 VDD.t67 sg13_lv_pmos ad=0.1596p pd=1.22u as=0.2856p ps=2.36u w=0.84u l=0.13u
X1967 VSS.t1501 a_7043_16869# a_7477_16869# VSS.t1500 sg13_lv_nmos ad=0.1406p pd=1.12u as=0.2516p ps=2.16u w=0.74u l=0.13u
X1968 VDD.t645 a_4187_2434# a_11711_14652# VDD.t374 sg13_lv_pmos ad=0.3808p pd=2.92u as=0.2128p ps=1.5u w=1.12u l=0.6u
X1969 VDD.t196 VSS.t455 VDD.t174 VDD.t2 sg13_lv_pmos ad=0.19p pd=1.38u as=0 ps=0 w=1u l=1u
X1970 VSS.t1050 a_3171_16074.t9 a_5844_16035# VSS.t1748 sg13_lv_nmos ad=0.2516p pd=2.16u as=0.2516p ps=2.16u w=0.74u l=0.13u
X1971 a_10430_16071# a_11924_16035# a_11848_16071# VDD.t90 sg13_lv_pmos ad=0.3808p pd=2.92u as=0.2128p ps=1.5u w=1.12u l=0.13u
X1972 a_15304_10295# a_14851_11918# VDD.t1008 VDD.t355 sg13_lv_pmos ad=0.4312p pd=3.01u as=0.2639p ps=1.81u w=1.12u l=0.13u
X1973 a_4350_6734# a_6711_6698# a_6635_6734# VDD.t67 sg13_lv_pmos ad=0.3808p pd=2.92u as=0.2128p ps=1.5u w=1.12u l=0.13u
X1974 a_16108_12471# a_26985_12701# a_25630_13226# VDD.t5 sg13_lv_pmos ad=0.3808p pd=2.92u as=0.3808p ps=2.92u w=1.12u l=0.13u
X1975 a_16271_2470# a_16033_1842# a_16163_1842# VDD.t373 sg13_lv_pmos ad=0.2128p pd=1.5u as=0.3808p ps=2.92u w=1.12u l=0.2u
X1976 a_25391_14652# a_25153_14024# a_25283_14024# VDD.t374 sg13_lv_pmos ad=0.2128p pd=1.5u as=0.3808p ps=2.92u w=1.12u l=0.2u
X1977 a_13566_11018# a_14009_10774# a_13949_11186# VDD.t355 sg13_lv_pmos ad=79.8f pd=0.8u as=63f ps=0.72u w=0.42u l=0.13u
X1978 a_6913_7532# a_6717_7532# VSS.t98 VSS.t97 sg13_lv_nmos ad=0.2516p pd=2.16u as=0.1406p ps=1.12u w=0.74u l=0.13u
X1979 VDD.t381 a_11748_11799# a_11693_11680# VDD.t355 sg13_lv_pmos ad=1.10612p pd=6.66u as=93.45f ps=0.865u w=0.42u l=0.13u
X1980 a_25913_16869# a_25717_16869# VDD.t1581 VDD.t368 sg13_lv_pmos ad=0.3808p pd=2.92u as=0.2128p ps=1.5u w=1.12u l=0.13u
X1981 VDD.t356 a_11491_11918# a_12158_11557# VDD.t355 sg13_lv_pmos ad=0.2128p pd=1.5u as=0.3864p ps=2.93u w=1.12u l=0.13u
X1982 VSS.t649 a_4187_1764.t78 a_18551_7532# VSS.t976 sg13_lv_nmos ad=0.2516p pd=2.16u as=0.1406p ps=1.12u w=0.74u l=0.6u
X1983 a_19550_6734# a_20391_6698# a_20315_6734# VDD.t67 sg13_lv_pmos ad=0.3808p pd=2.92u as=0.2128p ps=1.5u w=1.12u l=0.13u
X1984 VDD.t685 a_4187_2434# a_26151_14652# VDD.t374 sg13_lv_pmos ad=0.3808p pd=2.92u as=0.2128p ps=1.5u w=1.12u l=0.6u
X1985 VDD.t227 VSS.t430 VDD.t134 VDD.t2 sg13_lv_pmos ad=0.19p pd=1.38u as=0 ps=0 w=1u l=1u
X1986 VDD.t584 a_12363_7532# a_12797_7532# VDD.t346 sg13_lv_pmos ad=0.2128p pd=1.5u as=0.3808p ps=2.92u w=1.12u l=0.13u
X1987 a_2595_3156.t0 a_2297_3176# VDD.t1422 VDD.t0 sg13_lv_pmos ad=0.2128p pd=1.5u as=0.1918p ps=1.5u w=1.12u l=0.13u
X1988 VDD.t544 a_15403_4687# a_15837_4687# VDD.t348 sg13_lv_pmos ad=0.2128p pd=1.5u as=0.3808p ps=2.92u w=1.12u l=0.13u
X1989 a_21353_16869# a_21157_16869# VDD.t924 VDD.t368 sg13_lv_pmos ad=0.3808p pd=2.92u as=0.2128p ps=1.5u w=1.12u l=0.13u
X1990 a_19833_1842# a_19637_1842# VSS.t81 VSS.t80 sg13_lv_nmos ad=0.2516p pd=2.16u as=0.1406p ps=1.12u w=0.74u l=0.13u
X1991 VSS.t1071 a_19963_14024# a_20397_14024# VSS.t2182 sg13_lv_nmos ad=0.1406p pd=1.12u as=0.2516p ps=2.16u w=0.74u l=0.13u
X1992 a_21835_13226# a_21625_13226# VDD.t1111 VDD.t5 sg13_lv_pmos ad=0.2128p pd=1.5u as=0.252p ps=1.57u w=1.12u l=0.13u
X1993 VDD.t892 a_2019_311.t3 a_5705_519# VDD.t2 sg13_lv_pmos ad=0.3808p pd=2.92u as=0.3808p ps=2.92u w=1.12u l=0.13u
X1994 VDD.t508 a_14643_16869# a_15077_16869# VDD.t368 sg13_lv_pmos ad=0.2128p pd=1.5u as=0.3808p ps=2.92u w=1.12u l=0.13u
X1995 VDD.t606 a_7477_7532# a_7945_6734# VDD.t67 sg13_lv_pmos ad=0.252p pd=1.57u as=0.3808p ps=2.92u w=1.12u l=0.13u
X1996 a_3747_6001.t1 a_3449_6021# VSS.t126 VSS.t125 sg13_lv_nmos ad=0.1406p pd=1.12u as=0.1331p ps=1.12u w=0.74u l=0.13u
X1997 a_3747_12493.t1 a_3449_12513# VSS.t697 VSS.t1222 sg13_lv_nmos ad=0.1406p pd=1.12u as=0.1331p ps=1.12u w=0.74u l=0.13u
X1998 VSS.t1402 a_2019_1047.t7 a_10404_1008# VSS.t2008 sg13_lv_nmos ad=0.2516p pd=2.16u as=0.2516p ps=2.16u w=0.74u l=0.13u
X1999 VDD.t229 VSS.t430 VDD.t228 VDD.t2 sg13_lv_pmos ad=0.34p pd=2.68u as=0 ps=0 w=1u l=1u
X2000 a_24631_1842# a_24393_1842# a_24523_1842# VSS.t1484 sg13_lv_nmos ad=0.1406p pd=1.12u as=0.2516p ps=2.16u w=0.74u l=0.2u
X2001 a_22590_6734# a_2595_6737.t3 a_23355_6734# VSS.t1435 sg13_lv_nmos ad=0.2516p pd=2.16u as=0.1406p ps=1.12u w=0.74u l=0.13u
X2002 a_19550_3889# a_19524_3853# a_19448_3889# VDD.t0 sg13_lv_pmos ad=0.3808p pd=2.92u as=0.2128p ps=1.5u w=1.12u l=0.13u
X2003 VDD.t785 a_4763_4687# a_5197_4687# VDD.t348 sg13_lv_pmos ad=0.2128p pd=1.5u as=0.3808p ps=2.92u w=1.12u l=0.13u
X2004 a_9193_1842# a_8997_1842# VSS.t1476 VSS.t1901 sg13_lv_nmos ad=0.2516p pd=2.16u as=0.1406p ps=1.12u w=0.74u l=0.13u
X2005 a_20071_2470# a_19833_1842# a_19963_1842# VDD.t373 sg13_lv_pmos ad=0.2128p pd=1.5u as=0.3808p ps=2.92u w=1.12u l=0.2u
X2006 VDD.t596 a_3171_6001.t2 a_23945_6209# VDD.t67 sg13_lv_pmos ad=0.3808p pd=2.92u as=0.3808p ps=2.92u w=1.12u l=0.13u
X2007 a_1544_5979# REF_MUX_SEL3 VSS.t931 VSS.t930 sg13_lv_nmos ad=0.2516p pd=2.16u as=0.2516p ps=2.16u w=0.74u l=0.13u
X2008 VDD.t941 a_1544_289# a_2297_331# VDD.t2 sg13_lv_pmos ad=0.1918p pd=1.5u as=0.1596p ps=1.22u w=0.84u l=0.13u
X2009 a_5731_15316# a_5705_15546# a_4350_16071# VDD.t90 sg13_lv_pmos ad=0.3808p pd=2.92u as=0.3808p ps=2.92u w=1.12u l=0.13u
X2010 VDD.t932 a_14643_1842# a_15077_1842# VDD.t373 sg13_lv_pmos ad=0.2128p pd=1.5u as=0.3808p ps=2.92u w=1.12u l=0.13u
X2011 VSS.t1992 a_27237_16869# a_27705_16071# VSS.t2327 sg13_lv_nmos ad=0.1665p pd=1.19u as=0.2516p ps=2.16u w=0.74u l=0.13u
X2012 VSS.t171 a_4187_1764.t73 a_22351_7532# VSS.t2379 sg13_lv_nmos ad=0.2516p pd=2.16u as=0.1406p ps=1.12u w=0.74u l=0.6u
X2013 a_9675_3889# a_9465_3889# VSS.t1608 VSS.t1852 sg13_lv_nmos ad=0.1406p pd=1.12u as=0.1665p ps=1.19u w=0.74u l=0.13u
X2014 a_14009_11568# REF_CLK VSS.t96 VSS.t129 sg13_lv_nmos ad=0.2516p pd=2.16u as=1.9998p ps=12.915u w=0.74u l=0.13u
X2015 VSS.t1301 a_24197_14024# a_24665_13226# VSS.t1300 sg13_lv_nmos ad=0.1665p pd=1.19u as=0.2516p ps=2.16u w=0.74u l=0.13u
X2016 a_2019_311.t0 a_1721_331# VDD.t942 VDD.t2 sg13_lv_pmos ad=0.2128p pd=1.5u as=0.1918p ps=1.5u w=1.12u l=0.13u
X2017 VSS.t1348 a_2595_3892.t8 a_8231_3853# VSS.t1464 sg13_lv_nmos ad=0.2516p pd=2.16u as=0.2516p ps=2.16u w=0.74u l=0.13u
X2018 VSS.t2050 a_22677_16869# a_23145_16071# VSS.t2316 sg13_lv_nmos ad=0.1665p pd=1.19u as=0.2516p ps=2.16u w=0.74u l=0.13u
X2019 a_23633_1842# a_23437_1842# VSS.t1661 VSS.t1983 sg13_lv_nmos ad=0.2516p pd=2.16u as=0.1406p ps=1.12u w=0.74u l=0.13u
X2020 VDD.t270 VSS.t326 VDD.t269 VDD.t67 sg13_lv_pmos ad=0.34p pd=2.68u as=0 ps=0 w=1u l=1u
X2021 a_20968_16071# a_20397_16869# VSS.t667 VSS.t2146 sg13_lv_nmos ad=0.1406p pd=1.12u as=0.2516p ps=2.16u w=0.74u l=0.13u
X2022 VSS.t443 VDD.t1623 VSS.t443 VSS.t442 sg13_lv_nmos ad=0.1428p pd=1.52u as=0 ps=0 w=0.42u l=1u
X2023 a_26395_1044# a_26185_1044# VSS.t851 VSS.t850 sg13_lv_nmos ad=0.1406p pd=1.12u as=0.1665p ps=1.19u w=0.74u l=0.13u
X2024 VDD.t730 a_4187_2434# a_7911_5315# VDD.t348 sg13_lv_pmos ad=0.3808p pd=2.92u as=0.2128p ps=1.5u w=1.12u l=0.6u
X2025 VSS.t216 VDD.t1693 VSS.t216 VSS.t219 sg13_lv_nmos ad=79.8f pd=0.8u as=0 ps=0 w=0.42u l=1u
X2026 VSS.t711 a_9323_1842# a_9757_1842# VSS.t1297 sg13_lv_nmos ad=0.1406p pd=1.12u as=0.2516p ps=2.16u w=0.74u l=0.13u
X2027 a_13470_3889# a_14311_3853# a_14235_3889# VDD.t0 sg13_lv_pmos ad=0.3808p pd=2.92u as=0.2128p ps=1.5u w=1.12u l=0.13u
X2028 a_12715_13226# a_12505_13226# VDD.t1335 VDD.t5 sg13_lv_pmos ad=0.2128p pd=1.5u as=0.252p ps=1.57u w=1.12u l=0.13u
X2029 VSS.t975 a_3747_1047.t3 a_24951_1008# VSS.t2373 sg13_lv_nmos ad=0.2516p pd=2.16u as=0.2516p ps=2.16u w=0.74u l=0.13u
X2030 a_26911_17497# a_26673_16869# a_26803_16869# VDD.t368 sg13_lv_pmos ad=0.2128p pd=1.5u as=0.3808p ps=2.92u w=1.12u l=0.2u
X2031 VDD.t746 a_4187_2434# a_17791_2470# VDD.t373 sg13_lv_pmos ad=0.3808p pd=2.92u as=0.2128p ps=1.5u w=1.12u l=0.6u
X2032 a_14513_4687# a_14317_4687# VSS.t1086 VSS.t1085 sg13_lv_nmos ad=0.2516p pd=2.16u as=0.1406p ps=1.12u w=0.74u l=0.13u
X2033 a_13019_11521# a_15688_11093# VDD.t914 VDD.t355 sg13_lv_pmos ad=0.3808p pd=2.92u as=0.2128p ps=1.5u w=1.12u l=0.13u
X2034 a_16271_8160# a_16033_7532# a_16163_7532# VDD.t346 sg13_lv_pmos ad=0.2128p pd=1.5u as=0.3808p ps=2.92u w=1.12u l=0.2u
X2035 a_5631_4687# a_5393_4687# a_5523_4687# VSS.t1262 sg13_lv_nmos ad=0.1406p pd=1.12u as=0.2516p ps=2.16u w=0.74u l=0.2u
X2036 VDD.t813 a_25717_14024# a_26185_13226# VDD.t5 sg13_lv_pmos ad=0.252p pd=1.57u as=0.3808p ps=2.92u w=1.12u l=0.13u
X2037 VSS.t415 VDD.t1630 VSS.t415 VSS.t414 sg13_lv_nmos ad=0.1428p pd=1.52u as=0 ps=0 w=0.42u l=1u
X2038 VDD.t1377 a_2019_3892.t3 a_22564_3853# VDD.t0 sg13_lv_pmos ad=0.3808p pd=2.92u as=0.3808p ps=2.92u w=1.12u l=0.13u
X2039 a_2297_13577# CHAN1_MUX_SEL0 VDD.t904 VDD.t5 sg13_lv_pmos ad=0.1596p pd=1.22u as=0.2856p ps=2.36u w=0.84u l=0.13u
X2040 a_24008_13226# a_23437_14024# VDD.t1588 VDD.t5 sg13_lv_pmos ad=0.2128p pd=1.5u as=0.3808p ps=2.92u w=1.12u l=0.13u
X2041 a_22351_17497# a_22113_16869# a_22243_16869# VDD.t368 sg13_lv_pmos ad=0.2128p pd=1.5u as=0.3808p ps=2.92u w=1.12u l=0.2u
X2042 VDD.t641 a_4187_2434# a_27671_17497# VDD.t368 sg13_lv_pmos ad=0.3808p pd=2.92u as=0.2128p ps=1.5u w=1.12u l=0.6u
X2043 a_19550_16071# a_3747_16074.t4 a_21835_16071# VSS.t1192 sg13_lv_nmos ad=0.2516p pd=2.16u as=0.1406p ps=1.12u w=0.74u l=0.13u
X2044 VDD.t938 a_3449_12513# a_3747_12493.t0 VDD.t5 sg13_lv_pmos ad=0.4256p pd=3u as=0.2128p ps=1.5u w=1.12u l=0.13u
X2045 VDD.t354 CHAN0_MUX_SEL1 a_3449_16422# VDD.t90 sg13_lv_pmos ad=0.1918p pd=1.5u as=0.1596p ps=1.22u w=0.84u l=0.13u
X2046 VSS.t439 VDD.t1624 VSS.t439 VSS.t438 sg13_lv_nmos ad=0.1428p pd=1.52u as=0 ps=0 w=0.42u l=1u
X2047 a_25913_14024# a_25717_14024# VDD.t598 VDD.t374 sg13_lv_pmos ad=0.3808p pd=2.92u as=0.2128p ps=1.5u w=1.12u l=0.13u
X2048 VSS.t1539 a_3747_13229.t2 a_27991_13190# VSS.t1538 sg13_lv_nmos ad=0.2516p pd=2.16u as=0.2516p ps=2.16u w=0.74u l=0.13u
X2049 VDD.t627 a_4187_2434# a_4187_2434# VDD.t456 sg13_lv_pmos ad=0.3808p pd=2.92u as=1.0304p ps=4.08u w=1.12u l=0.6u
X2050 a_3747_1047.t0 a_3449_1395# VDD.t1260 VDD.t2 sg13_lv_pmos ad=0.2128p pd=1.5u as=0.1918p ps=1.5u w=1.12u l=0.13u
X2051 a_24008_1044# a_23437_1842# VSS.t739 VSS.t1984 sg13_lv_nmos ad=0.1406p pd=1.12u as=0.2516p ps=2.16u w=0.74u l=0.13u
X2052 a_13368_1044# a_12797_1842# VDD.t794 VDD.t2 sg13_lv_pmos ad=0.2128p pd=1.5u as=0.3808p ps=2.92u w=1.12u l=0.13u
X2053 a_19833_7532# a_19637_7532# VSS.t1566 VSS.t2289 sg13_lv_nmos ad=0.2516p pd=2.16u as=0.1406p ps=1.12u w=0.74u l=0.13u
X2054 VSS.t372 VDD.t1643 VSS.t372 VSS.t373 sg13_lv_nmos ad=79.8f pd=0.8u as=0 ps=0 w=0.42u l=1u
X2055 a_21353_14024# a_21157_14024# VDD.t1110 VDD.t374 sg13_lv_pmos ad=0.3808p pd=2.92u as=0.2128p ps=1.5u w=1.12u l=0.13u
X2056 a_9675_6734# a_9465_6734# VDD.t1148 VDD.t67 sg13_lv_pmos ad=0.2128p pd=1.5u as=0.252p ps=1.57u w=1.12u l=0.13u
X2057 a_4633_4687# a_4437_4687# VSS.t755 VSS.t754 sg13_lv_nmos ad=0.2516p pd=2.16u as=0.1406p ps=1.12u w=0.74u l=0.13u
X2058 a_5631_16869# a_5393_16869# a_5523_16869# VSS.t1803 sg13_lv_nmos ad=0.1406p pd=1.12u as=0.2516p ps=2.16u w=0.74u l=0.2u
X2059 VDD.t769 a_14643_14024# a_15077_14024# VDD.t374 sg13_lv_pmos ad=0.2128p pd=1.5u as=0.3808p ps=2.92u w=1.12u l=0.13u
X2060 a_9444_9602# a_6854_11144# a_9712_9602# VSS.t138 sg13_lv_nmos ad=0.68p pd=4.68u as=0.38p ps=2.38u w=2u l=1u
X2061 a_22590_13226# a_24951_13190# a_24875_13226# VDD.t5 sg13_lv_pmos ad=0.3808p pd=2.92u as=0.2128p ps=1.5u w=1.12u l=0.13u
X2062 VSS.t281 VDD.t1676 VSS.t284 VSS.t283 sg13_lv_nmos ad=79.8f pd=0.8u as=0 ps=0 w=0.42u l=1u
X2063 a_19833_16869# a_19637_16869# VSS.t1699 VSS.t2144 sg13_lv_nmos ad=0.2516p pd=2.16u as=0.1406p ps=1.12u w=0.74u l=0.13u
X2064 VSS.t1376 a_13557_16869# a_14025_16071# VSS.t1375 sg13_lv_nmos ad=0.1665p pd=1.19u as=0.2516p ps=2.16u w=0.74u l=0.13u
X2065 a_11711_5315# a_11473_4687# a_11603_4687# VDD.t348 sg13_lv_pmos ad=0.2128p pd=1.5u as=0.3808p ps=2.92u w=1.12u l=0.2u
X2066 VDD.t1039 a_2595_6737.t8 a_8231_6698# VDD.t67 sg13_lv_pmos ad=0.3808p pd=2.92u as=0.3808p ps=2.92u w=1.12u l=0.13u
X2067 VSS.t591 a_10517_14024# a_10985_13226# VSS.t590 sg13_lv_nmos ad=0.1665p pd=1.19u as=0.2516p ps=2.16u w=0.74u l=0.13u
X2068 a_24631_7532# a_24393_7532# a_24523_7532# VSS.t902 sg13_lv_nmos ad=0.1406p pd=1.12u as=0.2516p ps=2.16u w=0.74u l=0.2u
X2069 VSS.t1712 a_2019_6737.t7 a_10404_6698# VSS.t1711 sg13_lv_nmos ad=0.2516p pd=2.16u as=0.2516p ps=2.16u w=0.74u l=0.13u
X2070 VSS.t898 a_4187_1764.t160 a_6391_16869# VSS.t897 sg13_lv_nmos ad=0.2516p pd=2.16u as=0.1406p ps=1.12u w=0.74u l=0.6u
X2071 VDD.t759 a_4187_2434# a_21591_2470# VDD.t373 sg13_lv_pmos ad=0.3808p pd=2.92u as=0.2128p ps=1.5u w=1.12u l=0.6u
X2072 VSS.t72 a_23763_16869# a_24197_16869# VSS.t945 sg13_lv_nmos ad=0.1406p pd=1.12u as=0.2516p ps=2.16u w=0.74u l=0.13u
X2073 a_20071_8160# a_19833_7532# a_19963_7532# VDD.t346 sg13_lv_pmos ad=0.2128p pd=1.5u as=0.3808p ps=2.92u w=1.12u l=0.2u
X2074 a_9193_7532# a_8997_7532# VSS.t1235 VSS.t1600 sg13_lv_nmos ad=0.2516p pd=2.16u as=0.1406p ps=1.12u w=0.74u l=0.13u
X2075 a_2967_16422# CHAN0_MUX_SEL1 a_2873_16422# VSS.t28 sg13_lv_nmos ad=0.1216p pd=1.02u as=0.2176p ps=1.96u w=0.64u l=0.13u
X2076 VDD.t943 a_5974_11413# a_5974_11413# VDD.t355 sg13_lv_pmos ad=0.2448p pd=2.08u as=0.2826p ps=2.29u w=0.36u l=2u
X2077 a_2873_1395# CHAN3_MUX_SEL1 VDD.t1453 VDD.t2 sg13_lv_pmos ad=0.1596p pd=1.22u as=0.2856p ps=2.36u w=0.84u l=0.13u
X2078 VDD.t603 a_3171_3156.t2 a_23945_3364# VDD.t0 sg13_lv_pmos ad=0.3808p pd=2.92u as=0.3808p ps=2.92u w=1.12u l=0.13u
X2079 VDD.t838 a_14643_7532# a_15077_7532# VDD.t346 sg13_lv_pmos ad=0.2128p pd=1.5u as=0.3808p ps=2.92u w=1.12u l=0.13u
X2080 a_4350_1044# a_6711_1008# a_6635_1044# VDD.t2 sg13_lv_pmos ad=0.3808p pd=2.92u as=0.2128p ps=1.5u w=1.12u l=0.13u
X2081 a_15964_289# CHAN3_MUX_SEL4 a_5731_289# VDD.t2 sg13_lv_pmos ad=0.3304p pd=1.71u as=0.3808p ps=2.92u w=1.12u l=0.13u
X2082 VDD.t1157 a_2873_6021# a_3171_6001.t0 VDD.t67 sg13_lv_pmos ad=0.4256p pd=3u as=0.2128p ps=1.5u w=1.12u l=0.13u
X2083 VSS.t1936 a_5523_14024# a_5957_14024# VSS.t1935 sg13_lv_nmos ad=0.1406p pd=1.12u as=0.2516p ps=2.16u w=0.74u l=0.13u
X2084 a_13231_17497# a_12993_16869# a_13123_16869# VDD.t368 sg13_lv_pmos ad=0.2128p pd=1.5u as=0.3808p ps=2.92u w=1.12u l=0.2u
X2085 a_10430_16071# a_3747_16074.t7 a_12715_16071# VSS.t1189 sg13_lv_nmos ad=0.2516p pd=2.16u as=0.1406p ps=1.12u w=0.74u l=0.13u
X2086 a_11748_11799# a_11491_11918# a_11910_11995# VSS.t2306 sg13_lv_nmos ad=0.1428p pd=1.52u as=37.8f ps=0.6u w=0.42u l=0.13u
X2087 a_16108_15316# a_2595_15338.t2 a_19550_16071# VSS.t950 sg13_lv_nmos ad=0.2516p pd=2.16u as=0.2516p ps=2.16u w=0.74u l=0.13u
X2088 a_23633_7532# a_23437_7532# VSS.t1030 VSS.t1281 sg13_lv_nmos ad=0.2516p pd=2.16u as=0.1406p ps=1.12u w=0.74u l=0.13u
X2089 VSS.t410 VDD.t1631 VSS.t413 VSS.t412 sg13_lv_nmos ad=79.8f pd=0.8u as=0 ps=0 w=0.42u l=1u
X2090 a_19550_1044# a_20391_1008# a_20315_1044# VDD.t2 sg13_lv_pmos ad=0.3808p pd=2.92u as=0.2128p ps=1.5u w=1.12u l=0.13u
X2091 VDD.t82 VSS.t372 VDD.t81 VDD.t0 sg13_lv_pmos ad=0.34p pd=2.68u as=0 ps=0 w=1u l=1u
X2092 a_19550_3889# a_2019_3892.t4 a_19448_3889# VSS.t1511 sg13_lv_nmos ad=0.2516p pd=2.16u as=0.1406p ps=1.12u w=0.74u l=0.13u
X2093 a_26395_6734# a_26185_6734# VSS.t174 VSS.t800 sg13_lv_nmos ad=0.1406p pd=1.12u as=0.1665p ps=1.19u w=0.74u l=0.13u
X2094 a_1256_1044# CHAN3_MUX_SEL0 VSS.t905 VSS.t615 sg13_lv_nmos ad=0.2516p pd=2.16u as=0.2516p ps=2.16u w=0.74u l=0.13u
X2095 VDD.t652 a_4187_2434# a_13991_17497# VDD.t368 sg13_lv_pmos ad=0.3808p pd=2.92u as=0.2128p ps=1.5u w=1.12u l=0.6u
X2096 VDD.t91 VSS.t216 VDD.t249 VDD.t90 sg13_lv_pmos ad=0.34p pd=2.68u as=0 ps=0 w=1u l=1u
X2097 VSS.t152 a_9323_7532# a_9757_7532# VSS.t151 sg13_lv_nmos ad=0.1406p pd=1.12u as=0.2516p ps=2.16u w=0.74u l=0.13u
X2098 VDD.t495 VDD.t497 VDD.t498 VDD.t373 sg13_lv_pmos ad=0.2128p pd=1.5u as=0 ps=0 w=1.12u l=0.2u
X2099 VSS.t914 a_2019_16074.t8 a_7364_16035# VSS.t913 sg13_lv_nmos ad=0.2516p pd=2.16u as=0.2516p ps=2.16u w=0.74u l=0.13u
X2100 VSS.t1792 a_3747_6737.t3 a_24951_6698# VSS.t1791 sg13_lv_nmos ad=0.2516p pd=2.16u as=0.2516p ps=2.16u w=0.74u l=0.13u
X2101 VDD.t1393 a_19637_16869# a_20105_16071# VDD.t90 sg13_lv_pmos ad=0.252p pd=1.57u as=0.3808p ps=2.92u w=1.12u l=0.13u
X2102 VDD.t705 a_4187_2434# a_17791_8160# VDD.t346 sg13_lv_pmos ad=0.3808p pd=2.92u as=0.2128p ps=1.5u w=1.12u l=0.6u
X2103 VSS.t447 a_2595_311.t2 a_20905_519# VSS.t1137 sg13_lv_nmos ad=0.2516p pd=2.16u as=0.2516p ps=2.16u w=0.74u l=0.13u
X2104 a_26911_14652# a_26673_14024# a_26803_14024# VDD.t374 sg13_lv_pmos ad=0.2128p pd=1.5u as=0.3808p ps=2.92u w=1.12u l=0.2u
X2105 VSS.t2030 a_2019_13229.t9 a_4324_13190# VSS.t2029 sg13_lv_nmos ad=0.2516p pd=2.16u as=0.2516p ps=2.16u w=0.74u l=0.13u
X2106 VDD.t1006 a_7477_1842# a_7945_1044# VDD.t2 sg13_lv_pmos ad=0.252p pd=1.57u as=0.3808p ps=2.92u w=1.12u l=0.13u
X2107 VDD.t409 a_10083_4687# a_10517_4687# VDD.t348 sg13_lv_pmos ad=0.2128p pd=1.5u as=0.3808p ps=2.92u w=1.12u l=0.13u
X2108 VSS.t879 a_4003_16869# a_4437_16869# VSS.t1626 sg13_lv_nmos ad=0.1406p pd=1.12u as=0.2516p ps=2.16u w=0.74u l=0.13u
X2109 VSS.t2150 CHAN0_MUX_SEL4 a_15765_15490# VSS.t2149 sg13_lv_nmos ad=0.2516p pd=2.16u as=0.2516p ps=2.16u w=0.74u l=0.13u
X2110 a_16108_15316# a_26985_15546# a_25630_16071# VDD.t90 sg13_lv_pmos ad=0.3808p pd=2.92u as=0.3808p ps=2.92u w=1.12u l=0.13u
X2111 a_14513_1842# a_14317_1842# VSS.t971 VSS.t1417 sg13_lv_nmos ad=0.2516p pd=2.16u as=0.1406p ps=1.12u w=0.74u l=0.13u
X2112 a_5631_1842# a_5393_1842# a_5523_1842# VSS.t1955 sg13_lv_nmos ad=0.1406p pd=1.12u as=0.2516p ps=2.16u w=0.74u l=0.2u
X2113 a_16108_12471# a_23945_12701# a_22590_13226# VDD.t5 sg13_lv_pmos ad=0.3808p pd=2.92u as=0.3808p ps=2.92u w=1.12u l=0.13u
X2114 a_2019_6001.t0 a_1721_6021# VDD.t894 VDD.t67 sg13_lv_pmos ad=0.2128p pd=1.5u as=0.1918p ps=1.5u w=1.12u l=0.13u
X2115 VDD.t548 a_3171_16074.t5 a_18004_16035# VDD.t90 sg13_lv_pmos ad=0.3808p pd=2.92u as=0.3808p ps=2.92u w=1.12u l=0.13u
X2116 a_22351_14652# a_22113_14024# a_22243_14024# VDD.t374 sg13_lv_pmos ad=0.2128p pd=1.5u as=0.3808p ps=2.92u w=1.12u l=0.2u
X2117 VDD.t639 a_4187_2434# a_27671_14652# VDD.t374 sg13_lv_pmos ad=0.3808p pd=2.92u as=0.2128p ps=1.5u w=1.12u l=0.6u
X2118 a_10430_13226# a_11271_13190# a_11195_13226# VDD.t5 sg13_lv_pmos ad=0.3808p pd=2.92u as=0.2128p ps=1.5u w=1.12u l=0.13u
X2119 a_22873_16869# a_22677_16869# VDD.t1575 VDD.t368 sg13_lv_pmos ad=0.3808p pd=2.92u as=0.2128p ps=1.5u w=1.12u l=0.13u
X2120 a_13470_1044# a_3171_1047.t6 a_14888_1044# VSS.t1283 sg13_lv_nmos ad=0.2516p pd=2.16u as=0.1406p ps=1.12u w=0.74u l=0.13u
X2121 a_13470_3889# a_2595_3892.t6 a_14235_3889# VSS.t963 sg13_lv_nmos ad=0.2516p pd=2.16u as=0.1406p ps=1.12u w=0.74u l=0.13u
X2122 a_18551_4687# a_18313_4687# a_18443_4687# VSS.t36 sg13_lv_nmos ad=0.1406p pd=1.12u as=0.2516p ps=2.16u w=0.74u l=0.2u
X2123 VSS.t900 a_21483_14024# a_21917_14024# VSS.t1520 sg13_lv_nmos ad=0.1406p pd=1.12u as=0.2516p ps=2.16u w=0.74u l=0.13u
X2124 a_24008_6734# a_23437_7532# VSS.t1280 VSS.t1279 sg13_lv_nmos ad=0.1406p pd=1.12u as=0.2516p ps=2.16u w=0.74u l=0.13u
X2125 a_17275_3889# a_17065_3889# VDD.t1249 VDD.t0 sg13_lv_pmos ad=0.2128p pd=1.5u as=0.252p ps=1.57u w=1.12u l=0.13u
X2126 a_16108_5979# a_17865_6209# a_16510_6734# VDD.t67 sg13_lv_pmos ad=0.3808p pd=2.92u as=0.3808p ps=2.92u w=1.12u l=0.13u
X2127 a_9444_9602# a_9444_10280# VSS.t1273 VSS.t1272 sg13_lv_nmos ad=0.38p pd=2.38u as=0.68p ps=4.68u w=2u l=1u
X2128 VDD.t1078 a_16163_16869# a_16597_16869# VDD.t368 sg13_lv_pmos ad=0.2128p pd=1.5u as=0.3808p ps=2.92u w=1.12u l=0.13u
X2129 VDD.t338 VSS.t188 VDD.t337 VDD.t90 sg13_lv_pmos ad=0.34p pd=2.68u as=0 ps=0 w=1u l=1u
X2130 a_1256_289# CHAN3_MUX_SEL2 VSS.t1228 VSS.t1631 sg13_lv_nmos ad=0.2516p pd=2.16u as=0.2516p ps=2.16u w=0.74u l=0.13u
X2131 VDD.t342 a_3171_13229.t9 a_5844_13190# VDD.t5 sg13_lv_pmos ad=0.3808p pd=2.92u as=0.3808p ps=2.92u w=1.12u l=0.13u
X2132 VDD.t1187 a_3747_3892.t6 a_15831_3853# VDD.t0 sg13_lv_pmos ad=0.3808p pd=2.92u as=0.3808p ps=2.92u w=1.12u l=0.13u
X2133 VDD.t263 VSS.t286 VDD.t289 VDD.t5 sg13_lv_pmos ad=0.34p pd=2.68u as=0 ps=0 w=1u l=1u
X2134 a_4633_1842# a_4437_1842# VSS.t1039 VSS.t1934 sg13_lv_nmos ad=0.2516p pd=2.16u as=0.1406p ps=1.12u w=0.74u l=0.13u
X2135 VSS.t1681 a_2019_3892.t3 a_22564_3853# VSS.t2024 sg13_lv_nmos ad=0.2516p pd=2.16u as=0.2516p ps=2.16u w=0.74u l=0.13u
X2136 VDD.t789 a_4437_16869# a_4905_16071# VDD.t90 sg13_lv_pmos ad=0.252p pd=1.57u as=0.3808p ps=2.92u w=1.12u l=0.13u
X2137 a_5731_15316# a_3171_15338.t3 a_10430_16071# VSS.t2267 sg13_lv_nmos ad=0.2516p pd=2.16u as=0.2516p ps=2.16u w=0.74u l=0.13u
X2138 VDD.t555 a_11603_16869# a_12037_16869# VDD.t368 sg13_lv_pmos ad=0.2128p pd=1.5u as=0.3808p ps=2.92u w=1.12u l=0.13u
X2139 VSS.t975 a_2019_1047.t2 a_25604_1008# VSS.t974 sg13_lv_nmos ad=0.2516p pd=2.16u as=0.2516p ps=2.16u w=0.74u l=0.13u
X2140 VDD.t690 a_4187_2434# a_21591_8160# VDD.t346 sg13_lv_pmos ad=0.3808p pd=2.92u as=0.2128p ps=1.5u w=1.12u l=0.6u
X2141 a_16108_289# CHAN3_MUX_SEL4 a_15964_289# VSS.t2374 sg13_lv_nmos ad=0.2516p pd=2.16u as=0.2183p ps=1.33u w=0.74u l=0.13u
X2142 a_15964_3134# a_15765_3308# a_5731_3134# VSS.t2123 sg13_lv_nmos ad=0.2183p pd=1.33u as=0.2516p ps=2.16u w=0.74u l=0.13u
X2143 a_19550_6734# a_19524_6698# a_19448_6734# VDD.t67 sg13_lv_pmos ad=0.3808p pd=2.92u as=0.2128p ps=1.5u w=1.12u l=0.13u
X2144 VDD.t609 a_4187_2434# a_24631_5315# VDD.t348 sg13_lv_pmos ad=0.3808p pd=2.92u as=0.2128p ps=1.5u w=1.12u l=0.6u
X2145 a_4350_3889# a_4324_3853# a_4248_3889# VDD.t0 sg13_lv_pmos ad=0.3808p pd=2.92u as=0.2128p ps=1.5u w=1.12u l=0.13u
X2146 a_22873_1842# a_22677_1842# VDD.t1064 VDD.t373 sg13_lv_pmos ad=0.3808p pd=2.92u as=0.2128p ps=1.5u w=1.12u l=0.13u
X2147 a_14888_3889# a_14317_4687# VDD.t874 VDD.t0 sg13_lv_pmos ad=0.2128p pd=1.5u as=0.3808p ps=2.92u w=1.12u l=0.13u
X2148 VSS.t2081 a_2873_3176# a_3171_3156.t1 VSS.t1840 sg13_lv_nmos ad=0.2812p pd=2.24u as=0.1406p ps=1.12u w=0.74u l=0.13u
X2149 VSS.t70 a_24197_16869# a_24665_16071# VSS.t69 sg13_lv_nmos ad=0.1665p pd=1.19u as=0.2516p ps=2.16u w=0.74u l=0.13u
X2150 a_21835_1044# a_21625_1044# VSS.t780 VSS.t2282 sg13_lv_nmos ad=0.1406p pd=1.12u as=0.1665p ps=1.19u w=0.74u l=0.13u
X2151 a_22351_4687# a_22113_4687# a_22243_4687# VSS.t749 sg13_lv_nmos ad=0.1406p pd=1.12u as=0.2516p ps=2.16u w=0.74u l=0.2u
X2152 VDD.t1008 a_14851_11918# a_15108_11799# VDD.t355 sg13_lv_pmos ad=0.2639p pd=1.81u as=79.8f ps=0.8u w=0.42u l=0.13u
X2153 VSS.t812 a_4187_1764.t98 VSS.t814 VSS.t813 sg13_lv_nmos ad=1.33p pd=7.38u as=0 ps=0 w=7u l=7u
X2154 a_13231_14652# a_12993_14024# a_13123_14024# VDD.t374 sg13_lv_pmos ad=0.2128p pd=1.5u as=0.3808p ps=2.92u w=1.12u l=0.2u
X2155 VSS.t602 a_2595_1047.t4 a_20391_1008# VSS.t727 sg13_lv_nmos ad=0.2516p pd=2.16u as=0.2516p ps=2.16u w=0.74u l=0.13u
X2156 VSS.t984 a_16923_4687# a_17357_4687# VSS.t1226 sg13_lv_nmos ad=0.1406p pd=1.12u as=0.2516p ps=2.16u w=0.74u l=0.13u
X2157 VSS.t333 VDD.t1656 VSS.t338 VSS.t337 sg13_lv_nmos ad=0.1428p pd=1.52u as=0 ps=0 w=0.42u l=1u
X2158 a_1256_6734# REF_MUX_SEL0 VSS.t2162 VSS.t2161 sg13_lv_nmos ad=0.2516p pd=2.16u as=0.2516p ps=2.16u w=0.74u l=0.13u
X2159 VDD.t640 a_4187_2434# a_13991_14652# VDD.t374 sg13_lv_pmos ad=0.3808p pd=2.92u as=0.2128p ps=1.5u w=1.12u l=0.6u
X2160 VDD.t473 VDD.t475 VDD.t476 VDD.t346 sg13_lv_pmos ad=0.2128p pd=1.5u as=0 ps=0 w=1.12u l=0.2u
X2161 VDD.t387 a_2595_16074.t8 a_8231_16035# VDD.t90 sg13_lv_pmos ad=0.3808p pd=2.92u as=0.3808p ps=2.92u w=1.12u l=0.13u
X2162 a_13470_6734# a_14311_6698# a_14235_6734# VDD.t67 sg13_lv_pmos ad=0.3808p pd=2.92u as=0.2128p ps=1.5u w=1.12u l=0.13u
X2163 a_2297_6021# REF_MUX_SEL2 VDD.t1545 VDD.t67 sg13_lv_pmos ad=0.1596p pd=1.22u as=0.2856p ps=2.36u w=0.84u l=0.13u
X2164 VDD.t958 a_1544_13226# a_1721_13577# VDD.t5 sg13_lv_pmos ad=0.1918p pd=1.5u as=0.1596p ps=1.22u w=0.84u l=0.13u
X2165 a_13400_10795# a_13132_11110# a_13306_10795# VSS.t1041 sg13_lv_nmos ad=60.89999f pd=0.71u as=0.1428p ps=1.52u w=0.42u l=0.13u
X2166 VDD.t1305 a_27237_14024# a_27705_13226# VDD.t5 sg13_lv_pmos ad=0.252p pd=1.57u as=0.3808p ps=2.92u w=1.12u l=0.13u
X2167 VDD.t287 VSS.t268 VDD.t286 VDD.t5 sg13_lv_pmos ad=0.19p pd=1.38u as=0 ps=0 w=1u l=1u
X2168 VSS.t1400 a_10517_1842# a_10985_1044# VSS.t1399 sg13_lv_nmos ad=0.1665p pd=1.19u as=0.2516p ps=2.16u w=0.74u l=0.13u
X2169 a_9675_1044# a_9465_1044# VDD.t847 VDD.t2 sg13_lv_pmos ad=0.2128p pd=1.5u as=0.252p ps=1.57u w=1.12u l=0.13u
X2170 VSS.t342 VDD.t1655 VSS.t341 VSS.t340 sg13_lv_nmos ad=0.1428p pd=1.52u as=0 ps=0 w=0.42u l=1u
X2171 VDD.t894 a_1544_5979# a_1721_6021# VDD.t67 sg13_lv_pmos ad=0.1918p pd=1.5u as=0.1596p ps=1.22u w=0.84u l=0.13u
X2172 VSS.t580 a_4187_1764.t138 a_23111_16869# VSS.t1720 sg13_lv_nmos ad=0.2516p pd=2.16u as=0.1406p ps=1.12u w=0.74u l=0.6u
X2173 a_14513_7532# a_14317_7532# VSS.t65 VSS.t64 sg13_lv_nmos ad=0.2516p pd=2.16u as=0.1406p ps=1.12u w=0.74u l=0.13u
X2174 a_23871_17497# a_23633_16869# a_23763_16869# VDD.t368 sg13_lv_pmos ad=0.2128p pd=1.5u as=0.3808p ps=2.92u w=1.12u l=0.2u
X2175 a_5631_7532# a_5393_7532# a_5523_7532# VSS.t469 sg13_lv_nmos ad=0.1406p pd=1.12u as=0.2516p ps=2.16u w=0.74u l=0.2u
X2176 VDD.t886 a_2019_6737.t3 a_22564_6698# VDD.t67 sg13_lv_pmos ad=0.3808p pd=2.92u as=0.3808p ps=2.92u w=1.12u l=0.13u
X2177 CHAN0_DELAY_OUT_LAST a_27997_16869# VDD.t372 VDD.t368 sg13_lv_pmos ad=0.3808p pd=2.92u as=0.2128p ps=1.5u w=1.12u l=0.13u
X2178 a_4111_14024# CHAN1_DELAY_IN a_4003_14024# VSS.t943 sg13_lv_nmos ad=0.1406p pd=1.12u as=0.2516p ps=2.16u w=0.74u l=0.2u
X2179 VDD.t573 a_2595_1047.t8 a_8231_1008# VDD.t2 sg13_lv_pmos ad=0.3808p pd=2.92u as=0.3808p ps=2.92u w=1.12u l=0.13u
X2180 VDD.t1441 a_3449_15358# a_3747_15338.t0 VDD.t90 sg13_lv_pmos ad=0.4256p pd=3u as=0.2128p ps=1.5u w=1.12u l=0.13u
X2181 a_1544_15316# CHAN0_MUX_SEL3 VSS.t759 VSS.t1152 sg13_lv_nmos ad=0.2516p pd=2.16u as=0.2516p ps=2.16u w=0.74u l=0.13u
X2182 VDD.t1429 a_22677_14024# a_23145_13226# VDD.t5 sg13_lv_pmos ad=0.252p pd=1.57u as=0.3808p ps=2.92u w=1.12u l=0.13u
X2183 a_2019_3156.t1 a_1721_3176# VSS.t2093 VSS.t1786 sg13_lv_nmos ad=0.1406p pd=1.12u as=0.1331p ps=1.12u w=0.74u l=0.13u
X2184 VSS.t484 a_4187_1764.t56 a_10951_4687# VSS.t2124 sg13_lv_nmos ad=0.2516p pd=2.16u as=0.1406p ps=1.12u w=0.74u l=0.6u
X2185 VDD.t663 a_4187_2434# a_24631_17497# VDD.t368 sg13_lv_pmos ad=0.3808p pd=2.92u as=0.2128p ps=1.5u w=1.12u l=0.6u
X2186 VSS.t1784 a_3449_15358# a_3747_15338.t1 VSS.t2117 sg13_lv_nmos ad=0.2812p pd=2.24u as=0.1406p ps=1.12u w=0.74u l=0.13u
X2187 a_20968_13226# a_20397_14024# VDD.t863 VDD.t5 sg13_lv_pmos ad=0.2128p pd=1.5u as=0.3808p ps=2.92u w=1.12u l=0.13u
X2188 VDD.t318 VSS.t249 VDD.t62 VDD.t5 sg13_lv_pmos ad=0.19p pd=1.38u as=0 ps=0 w=1u l=1u
X2189 VSS.t2248 a_3747_16074.t2 a_27991_16035# VSS.t2247 sg13_lv_nmos ad=0.2516p pd=2.16u as=0.2516p ps=2.16u w=0.74u l=0.13u
X2190 VSS.t632 DLL_RESETN a_10040_11995# VSS.t2214 sg13_lv_nmos ad=0.1626p pd=1.415u as=60.89999f ps=0.71u w=0.42u l=0.13u
X2191 a_13306_10795# a_14111_10917# a_13566_11018# VDD.t355 sg13_lv_pmos ad=0.1428p pd=1.52u as=79.8f ps=0.8u w=0.42u l=0.13u
X2192 a_13470_6734# a_3171_6737.t6 a_14888_6734# VSS.t1880 sg13_lv_nmos ad=0.2516p pd=2.16u as=0.1406p ps=1.12u w=0.74u l=0.13u
X2193 a_18551_1842# a_18313_1842# a_18443_1842# VSS.t2187 sg13_lv_nmos ad=0.1406p pd=1.12u as=0.2516p ps=2.16u w=0.74u l=0.2u
X2194 a_22873_14024# a_22677_14024# VDD.t540 VDD.t374 sg13_lv_pmos ad=0.3808p pd=2.92u as=0.2128p ps=1.5u w=1.12u l=0.13u
X2195 a_16108_3134# a_17865_3364# a_16510_3889# VDD.t0 sg13_lv_pmos ad=0.3808p pd=2.92u as=0.3808p ps=2.92u w=1.12u l=0.13u
X2196 VDD.t771 a_16163_14024# a_16597_14024# VDD.t374 sg13_lv_pmos ad=0.2128p pd=1.5u as=0.3808p ps=2.92u w=1.12u l=0.13u
X2197 a_13121_11521# a_15688_11557# VDD.t814 VDD.t355 sg13_lv_pmos ad=0.3808p pd=2.92u as=0.2128p ps=1.5u w=1.12u l=0.13u
X2198 VDD.t1410 a_1256_3134# a_2873_3176# VDD.t0 sg13_lv_pmos ad=0.1918p pd=1.5u as=0.1596p ps=1.22u w=0.84u l=0.13u
X2199 VSS.t92 a_20723_4687# a_21157_4687# VSS.t1082 sg13_lv_nmos ad=0.1406p pd=1.12u as=0.2516p ps=2.16u w=0.74u l=0.13u
X2200 VDD.t479 VDD.t477 VDD.t478 VDD.t348 sg13_lv_pmos ad=0.3808p pd=2.92u as=0 ps=0 w=1.12u l=0.13u
X2201 a_4633_7532# a_4437_7532# VSS.t657 VSS.t766 sg13_lv_nmos ad=0.2516p pd=2.16u as=0.1406p ps=1.12u w=0.74u l=0.13u
X2202 a_26911_5315# a_26673_4687# a_26803_4687# VDD.t348 sg13_lv_pmos ad=0.2128p pd=1.5u as=0.3808p ps=2.92u w=1.12u l=0.2u
X2203 VSS.t1958 a_12037_14024# a_12505_13226# VSS.t1957 sg13_lv_nmos ad=0.1665p pd=1.19u as=0.2516p ps=2.16u w=0.74u l=0.13u
X2204 VSS.t1792 a_2019_6737.t2 a_25604_6698# VSS.t2253 sg13_lv_nmos ad=0.2516p pd=2.16u as=0.2516p ps=2.16u w=0.74u l=0.13u
X2205 VDD.t1152 a_8997_4687# a_9465_3889# VDD.t0 sg13_lv_pmos ad=0.252p pd=1.57u as=0.3808p ps=2.92u w=1.12u l=0.13u
X2206 VSS.t669 a_4187_1764.t158 a_7911_16869# VSS.t2380 sg13_lv_nmos ad=0.2516p pd=2.16u as=0.1406p ps=1.12u w=0.74u l=0.6u
X2207 VDD.t953 a_11603_14024# a_12037_14024# VDD.t374 sg13_lv_pmos ad=0.2128p pd=1.5u as=0.3808p ps=2.92u w=1.12u l=0.13u
X2208 VSS.t2186 a_25283_16869# a_25717_16869# VSS.t2322 sg13_lv_nmos ad=0.1406p pd=1.12u as=0.2516p ps=2.16u w=0.74u l=0.13u
X2209 a_19550_13226# a_21911_13190# a_21835_13226# VDD.t5 sg13_lv_pmos ad=0.3808p pd=2.92u as=0.2128p ps=1.5u w=1.12u l=0.13u
X2210 VSS.t672 a_10517_16869# a_10985_16071# VSS.t671 sg13_lv_nmos ad=0.1665p pd=1.19u as=0.2516p ps=2.16u w=0.74u l=0.13u
X2211 VDD.t108 VSS.t276 VDD.t27 VDD.t5 sg13_lv_pmos ad=0.19p pd=1.38u as=0 ps=0 w=1u l=1u
X2212 VSS.t157 a_14851_11918# a_15688_11557# VSS.t156 sg13_lv_nmos ad=0.1406p pd=1.12u as=0.2516p ps=2.16u w=0.74u l=0.13u
X2213 VSS.t1640 a_3171_13229.t4 a_21044_13190# VSS.t1639 sg13_lv_nmos ad=0.2516p pd=2.16u as=0.2516p ps=2.16u w=0.74u l=0.13u
X2214 a_17275_3889# a_17065_3889# VSS.t1812 VSS.t1811 sg13_lv_nmos ad=0.1406p pd=1.12u as=0.1665p ps=1.19u w=0.74u l=0.13u
X2215 VSS.t1199 a_20723_16869# a_21157_16869# VSS.t1198 sg13_lv_nmos ad=0.1406p pd=1.12u as=0.2516p ps=2.16u w=0.74u l=0.13u
X2216 a_8433_16869# a_8237_16869# VDD.t552 VDD.t368 sg13_lv_pmos ad=0.3808p pd=2.92u as=0.2128p ps=1.5u w=1.12u l=0.13u
X2217 VSS.t195 VDD.t1702 VSS.t195 VSS.t198 sg13_lv_nmos ad=79.8f pd=0.8u as=0 ps=0 w=0.42u l=1u
X2218 a_22873_7532# a_22677_7532# VDD.t412 VDD.t346 sg13_lv_pmos ad=0.3808p pd=2.92u as=0.2128p ps=1.5u w=1.12u l=0.13u
X2219 VSS.t1696 a_7043_14024# a_7477_14024# VSS.t1937 sg13_lv_nmos ad=0.1406p pd=1.12u as=0.2516p ps=2.16u w=0.74u l=0.13u
X2220 VSS.t655 a_3747_3892.t6 a_15831_3853# VSS.t1683 sg13_lv_nmos ad=0.2516p pd=2.16u as=0.2516p ps=2.16u w=0.74u l=0.13u
X2221 VSS.t1362 a_4187_1764.t39 a_23871_4687# VSS.t1665 sg13_lv_nmos ad=0.2516p pd=2.16u as=0.1406p ps=1.12u w=0.74u l=0.6u
X2222 a_21835_6734# a_21625_6734# VSS.t16 VSS.t626 sg13_lv_nmos ad=0.1406p pd=1.12u as=0.1665p ps=1.19u w=0.74u l=0.13u
X2223 VSS.t1289 a_3747_1047.t5 a_18871_1008# VSS.t1288 sg13_lv_nmos ad=0.2516p pd=2.16u as=0.2516p ps=2.16u w=0.74u l=0.13u
X2224 a_22351_1842# a_22113_1842# a_22243_1842# VSS.t1986 sg13_lv_nmos ad=0.1406p pd=1.12u as=0.2516p ps=2.16u w=0.74u l=0.2u
X2225 VDD.t891 a_3171_311.t2 a_23945_519# VDD.t2 sg13_lv_pmos ad=0.3808p pd=2.92u as=0.3808p ps=2.92u w=1.12u l=0.13u
X2226 VDD.t68 VSS.t333 VDD.t285 VDD.t67 sg13_lv_pmos ad=0.34p pd=2.68u as=0 ps=0 w=1u l=1u
X2227 VDD.t1344 a_13557_14024# a_14025_13226# VDD.t5 sg13_lv_pmos ad=0.252p pd=1.57u as=0.3808p ps=2.92u w=1.12u l=0.13u
X2228 VDD.t736 a_4187_2434# a_15511_5315# VDD.t348 sg13_lv_pmos ad=0.3808p pd=2.92u as=0.2128p ps=1.5u w=1.12u l=0.6u
X2229 a_10191_17497# a_9953_16869# a_10083_16869# VDD.t368 sg13_lv_pmos ad=0.2128p pd=1.5u as=0.3808p ps=2.92u w=1.12u l=0.2u
X2230 VDD.t633 a_4187_2434# a_15511_17497# VDD.t368 sg13_lv_pmos ad=0.3808p pd=2.92u as=0.2128p ps=1.5u w=1.12u l=0.6u
X2231 VSS.t48 a_6126_9506# a_6126_9506# VSS.t46 sg13_lv_nmos ad=0.68p pd=4.68u as=0.38p ps=2.38u w=2u l=1u
X2232 VSS.t690 a_2595_6737.t4 a_20391_6698# VSS.t1388 sg13_lv_nmos ad=0.2516p pd=2.16u as=0.2516p ps=2.16u w=0.74u l=0.13u
X2233 a_2019_311.t1 a_1721_331# VSS.t1228 VSS.t2273 sg13_lv_nmos ad=0.1406p pd=1.12u as=0.1331p ps=1.12u w=0.74u l=0.13u
X2234 VSS.t598 a_16923_1842# a_17357_1842# VSS.t1526 sg13_lv_nmos ad=0.1406p pd=1.12u as=0.2516p ps=2.16u w=0.74u l=0.13u
X2235 VDD.t1104 a_2019_3892.t5 a_16484_3853# VDD.t0 sg13_lv_pmos ad=0.3808p pd=2.92u as=0.3808p ps=2.92u w=1.12u l=0.13u
X2236 REF_MUX_OUT a_16851_5999# VSS.t678 VSS.t677 sg13_lv_nmos ad=0.1406p pd=1.12u as=0.1371p ps=1.12u w=0.74u l=0.13u
X2237 VDD.t1023 a_2873_7085# a_3171_6737.t0 VDD.t67 sg13_lv_pmos ad=0.4256p pd=3u as=0.2128p ps=1.5u w=1.12u l=0.13u
X2238 a_4350_3889# a_2019_3892.t9 a_4248_3889# VSS.t1506 sg13_lv_nmos ad=0.2516p pd=2.16u as=0.1406p ps=1.12u w=0.74u l=0.13u
X2239 VDD.t127 VSS.t342 VDD.t237 VDD.t67 sg13_lv_pmos ad=0.34p pd=2.68u as=0 ps=0 w=1u l=1u
X2240 VSS.t883 a_3747_13229.t6 a_15831_13190# VSS.t1642 sg13_lv_nmos ad=0.2516p pd=2.16u as=0.2516p ps=2.16u w=0.74u l=0.13u
X2241 VDD.t649 a_4187_2434# a_10951_17497# VDD.t368 sg13_lv_pmos ad=0.3808p pd=2.92u as=0.2128p ps=1.5u w=1.12u l=0.6u
X2242 VDD.t1350 a_21157_16869# a_21625_16071# VDD.t90 sg13_lv_pmos ad=0.252p pd=1.57u as=0.3808p ps=2.92u w=1.12u l=0.13u
X2243 VDD.t445 VDD.t443 VDD.t444 VDD.t355 sg13_lv_pmos ad=0.68p pd=4.68u as=0 ps=0 w=2u l=1u
X2244 VDD.t184 VSS.t209 VDD.t183 VDD.t90 sg13_lv_pmos ad=0.34p pd=2.68u as=0 ps=0 w=1u l=1u
X2245 VSS.t96 a_14009_11568# a_14111_11568# VSS.t1232 sg13_lv_nmos ad=2.39977p pd=15.495u as=0.2516p ps=2.16u w=0.74u l=0.13u
X2246 a_12715_1044# a_12505_1044# VSS.t1149 VSS.t1148 sg13_lv_nmos ad=0.1406p pd=1.12u as=0.1665p ps=1.19u w=0.74u l=0.13u
X2247 a_14888_3889# a_14317_4687# VSS.t965 VSS.t1087 sg13_lv_nmos ad=0.1406p pd=1.12u as=0.2516p ps=2.16u w=0.74u l=0.13u
X2248 a_13231_4687# a_12993_4687# a_13123_4687# VSS.t2383 sg13_lv_nmos ad=0.1406p pd=1.12u as=0.2516p ps=2.16u w=0.74u l=0.2u
X2249 VDD.t1075 a_25283_4687# a_25717_4687# VDD.t348 sg13_lv_pmos ad=0.2128p pd=1.5u as=0.3808p ps=2.92u w=1.12u l=0.13u
X2250 VSS.t133 a_10517_7532# a_10985_6734# VSS.t612 sg13_lv_nmos ad=0.1665p pd=1.19u as=0.2516p ps=2.16u w=0.74u l=0.13u
X2251 a_17928_1044# a_17357_1842# VSS.t596 VSS.t595 sg13_lv_nmos ad=0.1406p pd=1.12u as=0.2516p ps=2.16u w=0.74u l=0.13u
X2252 a_16108_5979# a_2595_6001.t2 a_19550_6734# VSS.t1488 sg13_lv_nmos ad=0.2516p pd=2.16u as=0.2516p ps=2.16u w=0.74u l=0.13u
X2253 VSS.t1648 a_2019_16074.t9 a_4324_16035# VSS.t1647 sg13_lv_nmos ad=0.2516p pd=2.16u as=0.2516p ps=2.16u w=0.74u l=0.13u
X2254 VSS.t1784 CHAN0_MUX_SEL3 a_3543_15358# VSS.t2155 sg13_lv_nmos ad=0.1331p pd=1.12u as=0.1216p ps=1.02u w=0.64u l=0.13u
X2255 a_25153_1842# a_24957_1842# VDD.t957 VDD.t373 sg13_lv_pmos ad=0.3808p pd=2.92u as=0.2128p ps=1.5u w=1.12u l=0.13u
X2256 VDD.t1435 a_2019_16074.t4 a_19524_16035# VDD.t90 sg13_lv_pmos ad=0.3808p pd=2.92u as=0.3808p ps=2.92u w=1.12u l=0.13u
X2257 VDD.t822 a_3171_3892.t9 a_5844_3853# VDD.t0 sg13_lv_pmos ad=0.3808p pd=2.92u as=0.3808p ps=2.92u w=1.12u l=0.13u
X2258 a_23871_14652# a_23633_14024# a_23763_14024# VDD.t374 sg13_lv_pmos ad=0.2128p pd=1.5u as=0.3808p ps=2.92u w=1.12u l=0.2u
X2259 a_1544_13226# CHAN1_MUX_SEL1 VSS.t1153 VSS.t1152 sg13_lv_nmos ad=0.2516p pd=2.16u as=0.2516p ps=2.16u w=0.74u l=0.13u
X2260 a_16108_15316# a_23945_15546# a_22590_16071# VDD.t90 sg13_lv_pmos ad=0.3808p pd=2.92u as=0.3808p ps=2.92u w=1.12u l=0.13u
X2261 CHAN1_DELAY_OUT_LAST a_27997_14024# VDD.t1265 VDD.t374 sg13_lv_pmos ad=0.3808p pd=2.92u as=0.2128p ps=1.5u w=1.12u l=0.13u
X2262 a_10430_13226# a_12791_13190# a_12715_13226# VDD.t5 sg13_lv_pmos ad=0.3808p pd=2.92u as=0.2128p ps=1.5u w=1.12u l=0.13u
X2263 a_19550_1044# a_3171_1047.t4 a_20968_1044# VSS.t1692 sg13_lv_nmos ad=0.2516p pd=2.16u as=0.1406p ps=1.12u w=0.74u l=0.13u
X2264 VDD.t1612 CHAN3_MUX_SEL4 a_15765_463# VDD.t2 sg13_lv_pmos ad=0.3808p pd=2.92u as=0.3808p ps=2.92u w=1.12u l=0.13u
X2265 VDD.t723 a_4187_2434# a_5631_5315# VDD.t348 sg13_lv_pmos ad=0.3808p pd=2.92u as=0.2128p ps=1.5u w=1.12u l=0.6u
X2266 a_16108_12471# a_20905_12701# a_19550_13226# VDD.t5 sg13_lv_pmos ad=0.3808p pd=2.92u as=0.3808p ps=2.92u w=1.12u l=0.13u
X2267 a_19550_1044# a_19524_1008# a_19448_1044# VDD.t2 sg13_lv_pmos ad=0.3808p pd=2.92u as=0.2128p ps=1.5u w=1.12u l=0.13u
X2268 VSS.t713 a_4187_1764.t24 a_10951_1842# VSS.t712 sg13_lv_nmos ad=0.2516p pd=2.16u as=0.1406p ps=1.12u w=0.74u l=0.6u
X2269 VDD.t630 a_4187_2434# a_24631_14652# VDD.t374 sg13_lv_pmos ad=0.3808p pd=2.92u as=0.2128p ps=1.5u w=1.12u l=0.6u
X2270 VSS.t379 VDD.t1639 VSS.t379 VSS.t382 sg13_lv_nmos ad=79.8f pd=0.8u as=0 ps=0 w=0.42u l=1u
X2271 VDD.t1083 a_2595_3892.t7 a_11271_3853# VDD.t0 sg13_lv_pmos ad=0.3808p pd=2.92u as=0.3808p ps=2.92u w=1.12u l=0.13u
X2272 a_18551_7532# a_18313_7532# a_18443_7532# VSS.t2269 sg13_lv_nmos ad=0.1406p pd=1.12u as=0.2516p ps=2.16u w=0.74u l=0.2u
X2273 VDD.t781 a_1544_6734# a_2297_7085# VDD.t67 sg13_lv_pmos ad=0.1918p pd=1.5u as=0.1596p ps=1.22u w=0.84u l=0.13u
X2274 a_7288_1044# a_6717_1842# VSS.t104 VSS.t1395 sg13_lv_nmos ad=0.1406p pd=1.12u as=0.2516p ps=2.16u w=0.74u l=0.13u
X2275 a_1544_3134# CHAN2_MUX_SEL3 VSS.t616 VSS.t922 sg13_lv_nmos ad=0.2516p pd=2.16u as=0.2516p ps=2.16u w=0.74u l=0.13u
X2276 a_12233_4687# a_12037_4687# VSS.t685 VSS.t684 sg13_lv_nmos ad=0.2516p pd=2.16u as=0.1406p ps=1.12u w=0.74u l=0.13u
X2277 a_17275_6734# a_17065_6734# VDD.t898 VDD.t67 sg13_lv_pmos ad=0.2128p pd=1.5u as=0.252p ps=1.57u w=1.12u l=0.13u
X2278 VSS.t319 VDD.t1663 VSS.t319 VSS.t322 sg13_lv_nmos ad=79.8f pd=0.8u as=0 ps=0 w=0.42u l=1u
X2279 a_3747_16074.t0 a_3449_16422# VDD.t354 VDD.t90 sg13_lv_pmos ad=0.2128p pd=1.5u as=0.1918p ps=1.5u w=1.12u l=0.13u
X2280 VDD.t1198 a_2019_13229.t8 a_7364_13190# VDD.t5 sg13_lv_pmos ad=0.3808p pd=2.92u as=0.3808p ps=2.92u w=1.12u l=0.13u
X2281 VSS.t778 a_20723_1842# a_21157_1842# VSS.t2340 sg13_lv_nmos ad=0.1406p pd=1.12u as=0.2516p ps=2.16u w=0.74u l=0.13u
X2282 a_2019_6737.t0 a_1721_7085# VDD.t876 VDD.t67 sg13_lv_pmos ad=0.2128p pd=1.5u as=0.1918p ps=1.5u w=1.12u l=0.13u
X2283 VDD.t1034 a_13123_16869# a_13557_16869# VDD.t368 sg13_lv_pmos ad=0.2128p pd=1.5u as=0.3808p ps=2.92u w=1.12u l=0.13u
X2284 VDD.t1236 a_3747_6737.t6 a_15831_6698# VDD.t67 sg13_lv_pmos ad=0.3808p pd=2.92u as=0.3808p ps=2.92u w=1.12u l=0.13u
X2285 a_11693_11680# a_10751_11568# a_11491_11918# VDD.t355 sg13_lv_pmos ad=93.45f pd=0.865u as=0.2048p ps=1.63u w=0.42u l=0.13u
X2286 VDD.t591 CHAN1_MUX_SEL4 a_15765_12645# VDD.t5 sg13_lv_pmos ad=0.3808p pd=2.92u as=0.3808p ps=2.92u w=1.12u l=0.13u
X2287 VDD.t503 a_3747_16074.t3 a_24951_16035# VDD.t90 sg13_lv_pmos ad=0.3808p pd=2.92u as=0.3808p ps=2.92u w=1.12u l=0.13u
X2288 a_1544_289# CHAN3_MUX_SEL3 VSS.t1228 VSS.t1622 sg13_lv_nmos ad=0.2516p pd=2.16u as=0.2516p ps=2.16u w=0.74u l=0.13u
X2289 VDD.t1309 a_3747_3892.t8 a_9751_3853# VDD.t0 sg13_lv_pmos ad=0.3808p pd=2.92u as=0.3808p ps=2.92u w=1.12u l=0.13u
X2290 VDD.t298 VSS.t227 VDD.t307 VDD.t90 sg13_lv_pmos ad=0.34p pd=2.68u as=0 ps=0 w=1u l=1u
X2291 a_22590_1044# a_3747_1047.t3 a_24875_1044# VSS.t2372 sg13_lv_nmos ad=0.2516p pd=2.16u as=0.1406p ps=1.12u w=0.74u l=0.13u
X2292 a_13470_1044# a_14311_1008# a_14235_1044# VDD.t2 sg13_lv_pmos ad=0.3808p pd=2.92u as=0.2128p ps=1.5u w=1.12u l=0.13u
X2293 a_4350_6734# a_4324_6698# a_4248_6734# VDD.t67 sg13_lv_pmos ad=0.3808p pd=2.92u as=0.2128p ps=1.5u w=1.12u l=0.13u
X2294 a_8433_14024# a_8237_14024# VDD.t1002 VDD.t374 sg13_lv_pmos ad=0.3808p pd=2.92u as=0.2128p ps=1.5u w=1.12u l=0.13u
X2295 a_3171_3892.t0 a_2873_4240# VDD.t514 VDD.t0 sg13_lv_pmos ad=0.2128p pd=1.5u as=0.1918p ps=1.5u w=1.12u l=0.13u
X2296 a_14888_6734# a_14317_7532# VDD.t366 VDD.t67 sg13_lv_pmos ad=0.2128p pd=1.5u as=0.3808p ps=2.92u w=1.12u l=0.13u
X2297 VSS.t1304 a_4187_1764.t7 a_23871_1842# VSS.t1336 sg13_lv_nmos ad=0.2516p pd=2.16u as=0.1406p ps=1.12u w=0.74u l=0.6u
X2298 a_22351_7532# a_22113_7532# a_22243_7532# VSS.t1236 sg13_lv_nmos ad=0.1406p pd=1.12u as=0.2516p ps=2.16u w=0.74u l=0.2u
X2299 VSS.t651 a_3747_6737.t5 a_18871_6698# VSS.t1746 sg13_lv_nmos ad=0.2516p pd=2.16u as=0.2516p ps=2.16u w=0.74u l=0.13u
X2300 VDD.t1374 a_2019_1047.t3 a_22564_1008# VDD.t2 sg13_lv_pmos ad=0.3808p pd=2.92u as=0.3808p ps=2.92u w=1.12u l=0.13u
X2301 VSS.t1608 a_8997_4687# a_9465_3889# VSS.t1607 sg13_lv_nmos ad=0.1665p pd=1.19u as=0.2516p ps=2.16u w=0.74u l=0.13u
X2302 VSS.t1614 a_2873_6021# a_3171_6001.t1 VSS.t1615 sg13_lv_nmos ad=0.2812p pd=2.24u as=0.1406p ps=1.12u w=0.74u l=0.13u
X2303 VDD.t146 VSS.t379 VDD.t145 VDD.t0 sg13_lv_pmos ad=0.34p pd=2.68u as=0 ps=0 w=1u l=1u
X2304 VDD.t1272 a_2297_4240# a_2595_3892.t0 VDD.t0 sg13_lv_pmos ad=0.4256p pd=3u as=0.2128p ps=1.5u w=1.12u l=0.13u
X2305 VDD.t336 VSS.t188 VDD.t334 VDD.t90 sg13_lv_pmos ad=0.19p pd=1.38u as=0 ps=0 w=1u l=1u
X2306 a_5731_12471# a_11785_12701# a_10430_13226# VDD.t5 sg13_lv_pmos ad=0.3808p pd=2.92u as=0.3808p ps=2.92u w=1.12u l=0.13u
X2307 a_15964_15316# a_15765_15490# a_5731_15316# VSS.t2132 sg13_lv_nmos ad=0.2183p pd=1.33u as=0.2516p ps=2.16u w=0.74u l=0.13u
X2308 VSS.t144 a_16923_7532# a_17357_7532# VSS.t862 sg13_lv_nmos ad=0.1406p pd=1.12u as=0.2516p ps=2.16u w=0.74u l=0.13u
X2309 VDD.t1072 a_3747_16074.t8 a_9751_16035# VDD.t90 sg13_lv_pmos ad=0.3808p pd=2.92u as=0.3808p ps=2.92u w=1.12u l=0.13u
X2310 a_10191_14652# a_9953_14024# a_10083_14024# VDD.t374 sg13_lv_pmos ad=0.2128p pd=1.5u as=0.3808p ps=2.92u w=1.12u l=0.2u
X2311 VDD.t682 a_4187_2434# a_15511_14652# VDD.t374 sg13_lv_pmos ad=0.3808p pd=2.92u as=0.2128p ps=1.5u w=1.12u l=0.6u
X2312 VSS.t1355 REF_MUX_SEL4 a_15765_6153# VSS.t1354 sg13_lv_nmos ad=0.2516p pd=2.16u as=0.2516p ps=2.16u w=0.74u l=0.13u
X2313 a_10713_16869# a_10517_16869# VDD.t553 VDD.t368 sg13_lv_pmos ad=0.3808p pd=2.92u as=0.2128p ps=1.5u w=1.12u l=0.13u
X2314 VDD.t44 VSS.t387 VDD.t72 VDD.t0 sg13_lv_pmos ad=0.34p pd=2.68u as=0 ps=0 w=1u l=1u
X2315 a_16793_4687# a_16597_4687# VDD.t919 VDD.t348 sg13_lv_pmos ad=0.3808p pd=2.92u as=0.2128p ps=1.5u w=1.12u l=0.13u
X2316 VSS.t851 a_25717_1842# a_26185_1044# VSS.t1440 sg13_lv_nmos ad=0.1665p pd=1.19u as=0.2516p ps=2.16u w=0.74u l=0.13u
X2317 a_7911_5315# a_7673_4687# a_7803_4687# VDD.t348 sg13_lv_pmos ad=0.2128p pd=1.5u as=0.3808p ps=2.92u w=1.12u l=0.2u
X2318 VDD.t1284 a_2595_16074.t9 a_5191_16035# VDD.t90 sg13_lv_pmos ad=0.3808p pd=2.92u as=0.3808p ps=2.92u w=1.12u l=0.13u
X2319 VDD.t670 a_4187_2434# a_10951_14652# VDD.t374 sg13_lv_pmos ad=0.3808p pd=2.92u as=0.2128p ps=1.5u w=1.12u l=0.6u
X2320 VDD.t158 VSS.t294 VDD.t157 VDD.t5 sg13_lv_pmos ad=0.34p pd=2.68u as=0 ps=0 w=1u l=1u
X2321 a_12715_6734# a_12505_6734# VSS.t178 VSS.t177 sg13_lv_nmos ad=0.1406p pd=1.12u as=0.1665p ps=1.19u w=0.74u l=0.13u
X2322 a_13231_1842# a_12993_1842# a_13123_1842# VSS.t1410 sg13_lv_nmos ad=0.1406p pd=1.12u as=0.2516p ps=2.16u w=0.74u l=0.2u
X2323 a_2297_4240# CHAN2_MUX_SEL0 VDD.t1562 VDD.t0 sg13_lv_pmos ad=0.1596p pd=1.22u as=0.2856p ps=2.36u w=0.84u l=0.13u
X2324 a_25153_7532# a_24957_7532# VDD.t394 VDD.t346 sg13_lv_pmos ad=0.3808p pd=2.92u as=0.2128p ps=1.5u w=1.12u l=0.13u
X2325 a_17928_6734# a_17357_7532# VSS.t142 VSS.t141 sg13_lv_nmos ad=0.1406p pd=1.12u as=0.2516p ps=2.16u w=0.74u l=0.13u
X2326 a_5631_14024# a_5393_14024# a_5523_14024# VSS.t2133 sg13_lv_nmos ad=0.1406p pd=1.12u as=0.2516p ps=2.16u w=0.74u l=0.2u
X2327 VSS.t697 CHAN1_MUX_SEL3 a_3543_12513# VSS.t696 sg13_lv_nmos ad=0.1331p pd=1.12u as=0.1216p ps=1.02u w=0.64u l=0.13u
X2328 VSS.t407 VDD.t1632 VSS.t407 VSS.t408 sg13_lv_nmos ad=79.8f pd=0.8u as=0 ps=0 w=0.42u l=1u
X2329 VDD.t977 a_24197_14024# a_24665_13226# VDD.t5 sg13_lv_pmos ad=0.252p pd=1.57u as=0.3808p ps=2.92u w=1.12u l=0.13u
X2330 a_19833_14024# a_19637_14024# VSS.t1069 VSS.t1068 sg13_lv_nmos ad=0.2516p pd=2.16u as=0.1406p ps=1.12u w=0.74u l=0.13u
X2331 a_17791_2470# a_17553_1842# a_17683_1842# VDD.t373 sg13_lv_pmos ad=0.2128p pd=1.5u as=0.3808p ps=2.92u w=1.12u l=0.2u
X2332 VDD.t580 a_1544_3889# a_1721_4240# VDD.t0 sg13_lv_pmos ad=0.1918p pd=1.5u as=0.1596p ps=1.22u w=0.84u l=0.13u
X2333 VSS.t789 a_4187_1764.t36 a_26151_4687# VSS.t788 sg13_lv_nmos ad=0.2516p pd=2.16u as=0.1406p ps=1.12u w=0.74u l=0.6u
X2334 a_19550_6734# a_3171_6737.t4 a_20968_6734# VSS.t1878 sg13_lv_nmos ad=0.2516p pd=2.16u as=0.1406p ps=1.12u w=0.74u l=0.13u
X2335 VSS.t1004 a_4187_1764.t142 a_20071_16869# VSS.t1003 sg13_lv_nmos ad=0.2516p pd=2.16u as=0.1406p ps=1.12u w=0.74u l=0.6u
X2336 VSS.t1593 a_4437_1842# a_4905_1044# VSS.t1933 sg13_lv_nmos ad=0.1665p pd=1.19u as=0.2516p ps=2.16u w=0.74u l=0.13u
X2337 VSS.t655 a_2019_3892.t5 a_16484_3853# VSS.t1510 sg13_lv_nmos ad=0.2516p pd=2.16u as=0.2516p ps=2.16u w=0.74u l=0.13u
X2338 a_25153_16869# a_24957_16869# VDD.t853 VDD.t368 sg13_lv_pmos ad=0.3808p pd=2.92u as=0.2128p ps=1.5u w=1.12u l=0.13u
X2339 VSS.t1392 a_4187_1764.t128 a_6391_14024# VSS.t2365 sg13_lv_nmos ad=0.2516p pd=2.16u as=0.1406p ps=1.12u w=0.74u l=0.6u
X2340 VSS.t773 a_4187_1764.t88 a_10951_7532# VSS.t2263 sg13_lv_nmos ad=0.2516p pd=2.16u as=0.1406p ps=1.12u w=0.74u l=0.6u
X2341 a_2019_6001.t1 a_1721_6021# VSS.t1142 VSS.t1461 sg13_lv_nmos ad=0.1406p pd=1.12u as=0.1331p ps=1.12u w=0.74u l=0.13u
X2342 VSS.t1299 a_23763_14024# a_24197_14024# VSS.t1836 sg13_lv_nmos ad=0.1406p pd=1.12u as=0.2516p ps=2.16u w=0.74u l=0.13u
X2343 VDD.t221 VSS.t319 VDD.t219 VDD.t67 sg13_lv_pmos ad=0.19p pd=1.38u as=0 ps=0 w=1u l=1u
X2344 VSS.t305 VDD.t1668 VSS.t305 VSS.t310 sg13_lv_nmos ad=79.8f pd=0.8u as=0 ps=0 w=0.42u l=1u
X2345 VSS.t1975 a_2595_13229.t2 a_26471_13190# VSS.t2041 sg13_lv_nmos ad=0.2516p pd=2.16u as=0.2516p ps=2.16u w=0.74u l=0.13u
X2346 VDD.t7 VSS.t237 VDD.t89 VDD.t5 sg13_lv_pmos ad=0.19p pd=1.38u as=0 ps=0 w=1u l=1u
X2347 a_7288_6734# a_6717_7532# VSS.t100 VSS.t99 sg13_lv_nmos ad=0.1406p pd=1.12u as=0.2516p ps=2.16u w=0.74u l=0.13u
X2348 VDD.t174 VSS.t456 VDD.t173 VDD.t2 sg13_lv_pmos ad=0.34p pd=2.68u as=0 ps=0 w=1u l=1u
X2349 VSS.t870 a_4187_1764.t64 a_4871_4687# VSS.t1867 sg13_lv_nmos ad=0.2516p pd=2.16u as=0.1406p ps=1.12u w=0.74u l=0.6u
X2350 a_5731_5979# a_3171_6001.t3 a_10430_6734# VSS.t1856 sg13_lv_nmos ad=0.2516p pd=2.16u as=0.2516p ps=2.16u w=0.74u l=0.13u
X2351 a_12233_1842# a_12037_1842# VSS.t1249 VSS.t1248 sg13_lv_nmos ad=0.2516p pd=2.16u as=0.1406p ps=1.12u w=0.74u l=0.13u
X2352 VSS.t18 a_20723_7532# a_21157_7532# VSS.t186 sg13_lv_nmos ad=0.1406p pd=1.12u as=0.2516p ps=2.16u w=0.74u l=0.13u
X2353 VSS.t872 a_3171_3892.t9 a_5844_3853# VSS.t962 sg13_lv_nmos ad=0.2516p pd=2.16u as=0.2516p ps=2.16u w=0.74u l=0.13u
X2354 VDD.t1029 a_27563_4687# a_27997_4687# VDD.t348 sg13_lv_pmos ad=0.2128p pd=1.5u as=0.3808p ps=2.92u w=1.12u l=0.13u
X2355 VDD.t1341 a_13123_14024# a_13557_14024# VDD.t374 sg13_lv_pmos ad=0.2128p pd=1.5u as=0.3808p ps=2.92u w=1.12u l=0.13u
X2356 VSS.t722 a_3171_1047.t8 a_8884_1008# VSS.t1689 sg13_lv_nmos ad=0.2516p pd=2.16u as=0.2516p ps=2.16u w=0.74u l=0.13u
X2357 VSS.t462 VDD.t1619 VSS.t460 VSS.t461 sg13_lv_nmos ad=79.8f pd=0.8u as=0 ps=0 w=0.42u l=1u
X2358 VSS.t1828 a_3449_1395# a_3747_1047.t1 VSS.t1827 sg13_lv_nmos ad=0.2812p pd=2.24u as=0.1406p ps=1.12u w=0.74u l=0.13u
X2359 VSS.t676 a_12037_16869# a_12505_16071# VSS.t675 sg13_lv_nmos ad=0.1665p pd=1.19u as=0.2516p ps=2.16u w=0.74u l=0.13u
X2360 a_20593_4687# a_20397_4687# VDD.t559 VDD.t348 sg13_lv_pmos ad=0.3808p pd=2.92u as=0.2128p ps=1.5u w=1.12u l=0.13u
X2361 a_8155_16071# a_7945_16071# VDD.t1386 VDD.t90 sg13_lv_pmos ad=0.2128p pd=1.5u as=0.252p ps=1.57u w=1.12u l=0.13u
X2362 a_14009_11568# REF_CLK VDD.t381 VDD.t355 sg13_lv_pmos ad=0.4088p pd=2.97u as=1.03698p ps=6.245u w=1.12u l=0.13u
X2363 VDD.t1148 a_8997_7532# a_9465_6734# VDD.t67 sg13_lv_pmos ad=0.252p pd=1.57u as=0.3808p ps=2.92u w=1.12u l=0.13u
X2364 VDD.t134 VSS.t428 VDD.t133 VDD.t2 sg13_lv_pmos ad=0.34p pd=2.68u as=0 ps=0 w=1u l=1u
X2365 VDD.t71 VSS.t437 VDD.t70 VDD.t2 sg13_lv_pmos ad=0.19p pd=1.38u as=0 ps=0 w=1u l=1u
X2366 VSS.t2027 a_2019_13229.t3 a_22564_13190# VSS.t2026 sg13_lv_nmos ad=0.2516p pd=2.16u as=0.2516p ps=2.16u w=0.74u l=0.13u
X2367 VSS.t1048 a_4187_1764.t162 a_4871_16869# VSS.t1717 sg13_lv_nmos ad=0.2516p pd=2.16u as=0.1406p ps=1.12u w=0.74u l=0.6u
X2368 a_1544_12471# CHAN1_MUX_SEL3 VDD.t565 VDD.t5 sg13_lv_pmos ad=0.3808p pd=2.92u as=0.3808p ps=2.92u w=1.12u l=0.13u
X2369 VDD.t1267 a_2873_1395# a_3171_1047.t0 VDD.t2 sg13_lv_pmos ad=0.4256p pd=3u as=0.2128p ps=1.5u w=1.12u l=0.13u
X2370 VSS.t395 VDD.t1635 VSS.t395 VSS.t394 sg13_lv_nmos ad=0.1428p pd=1.52u as=0 ps=0 w=0.42u l=1u
X2371 VSS.t486 a_2595_3892.t7 a_11271_3853# VSS.t1466 sg13_lv_nmos ad=0.2516p pd=2.16u as=0.2516p ps=2.16u w=0.74u l=0.13u
X2372 a_9953_16869# a_9757_16869# VDD.t369 VDD.t368 sg13_lv_pmos ad=0.3808p pd=2.92u as=0.2128p ps=1.5u w=1.12u l=0.13u
X2373 VSS.t1703 a_22243_16869# a_22677_16869# VSS.t2318 sg13_lv_nmos ad=0.1406p pd=1.12u as=0.2516p ps=2.16u w=0.74u l=0.13u
X2374 a_22590_6734# a_3747_6737.t3 a_24875_6734# VSS.t1790 sg13_lv_nmos ad=0.2516p pd=2.16u as=0.1406p ps=1.12u w=0.74u l=0.13u
X2375 VDD.t349 a_6283_4687# a_6717_4687# VDD.t348 sg13_lv_pmos ad=0.2128p pd=1.5u as=0.3808p ps=2.92u w=1.12u l=0.13u
X2376 VSS.t667 a_3171_16074.t4 a_21044_16035# VSS.t666 sg13_lv_nmos ad=0.2516p pd=2.16u as=0.2516p ps=2.16u w=0.74u l=0.13u
X2377 VDD.t1120 a_3747_13229.t2 a_27991_13190# VDD.t5 sg13_lv_pmos ad=0.3808p pd=2.92u as=0.3808p ps=2.92u w=1.12u l=0.13u
X2378 a_21591_2470# a_21353_1842# a_21483_1842# VDD.t373 sg13_lv_pmos ad=0.2128p pd=1.5u as=0.3808p ps=2.92u w=1.12u l=0.2u
X2379 a_6153_1842# a_5957_1842# VDD.t1298 VDD.t373 sg13_lv_pmos ad=0.3808p pd=2.92u as=0.2128p ps=1.5u w=1.12u l=0.13u
X2380 a_7390_13226# a_2019_13229.t8 a_7288_13226# VSS.t1724 sg13_lv_nmos ad=0.2516p pd=2.16u as=0.1406p ps=1.12u w=0.74u l=0.13u
X2381 a_3543_1395# CHAN3_MUX_SEL0 a_3449_1395# VSS.t2087 sg13_lv_nmos ad=0.1216p pd=1.02u as=0.2176p ps=1.96u w=0.64u l=0.13u
X2382 VDD.t811 a_16163_1842# a_16597_1842# VDD.t373 sg13_lv_pmos ad=0.2128p pd=1.5u as=0.3808p ps=2.92u w=1.12u l=0.13u
X2383 VSS.t1307 a_4003_14024# a_4437_14024# VSS.t1306 sg13_lv_nmos ad=0.1406p pd=1.12u as=0.2516p ps=2.16u w=0.74u l=0.13u
X2384 VSS.t921 a_4187_1764.t71 a_23871_7532# VSS.t1129 sg13_lv_nmos ad=0.2516p pd=2.16u as=0.1406p ps=1.12u w=0.74u l=0.6u
X2385 a_11711_17497# a_11473_16869# a_11603_16869# VDD.t368 sg13_lv_pmos ad=0.2128p pd=1.5u as=0.3808p ps=2.92u w=1.12u l=0.2u
X2386 VSS.t61 a_3747_3892.t8 a_9751_3853# VSS.t1915 sg13_lv_nmos ad=0.2516p pd=2.16u as=0.2516p ps=2.16u w=0.74u l=0.13u
X2387 VDD.t515 a_10517_14024# a_10985_13226# VDD.t5 sg13_lv_pmos ad=0.252p pd=1.57u as=0.3808p ps=2.92u w=1.12u l=0.13u
X2388 VDD.t883 a_2019_6737.t5 a_16484_6698# VDD.t67 sg13_lv_pmos ad=0.3808p pd=2.92u as=0.3808p ps=2.92u w=1.12u l=0.13u
X2389 VSS.t1007 a_2595_13229.t5 a_17351_13190# VSS.t1006 sg13_lv_nmos ad=0.2516p pd=2.16u as=0.2516p ps=2.16u w=0.74u l=0.13u
X2390 VDD.t643 a_4187_2434# a_12471_17497# VDD.t368 sg13_lv_pmos ad=0.3808p pd=2.92u as=0.2128p ps=1.5u w=1.12u l=0.6u
X2391 VDD.t797 a_1544_1044# a_2297_1395# VDD.t2 sg13_lv_pmos ad=0.1918p pd=1.5u as=0.1596p ps=1.22u w=0.84u l=0.13u
X2392 a_1544_3889# CHAN2_MUX_SEL1 VDD.t1153 VDD.t0 sg13_lv_pmos ad=0.3808p pd=2.92u as=0.3808p ps=2.92u w=1.12u l=0.13u
X2393 a_15964_5979# REF_MUX_SEL4 a_5731_5979# VDD.t67 sg13_lv_pmos ad=0.3304p pd=1.71u as=0.3808p ps=2.92u w=1.12u l=0.13u
X2394 a_27915_1044# a_27705_1044# VSS.t1261 VSS.t1260 sg13_lv_nmos ad=0.1406p pd=1.12u as=0.1665p ps=1.19u w=0.74u l=0.13u
X2395 a_17275_1044# a_17065_1044# VDD.t787 VDD.t2 sg13_lv_pmos ad=0.2128p pd=1.5u as=0.252p ps=1.57u w=1.12u l=0.13u
X2396 VSS.t553 VSS.t550 VSS.t552 VSS.t551 sg13_lv_nmos ad=0.2516p pd=2.16u as=0 ps=0 w=0.74u l=0.6u
X2397 VSS.t479 a_3747_16074.t6 a_15831_16035# VSS.t478 sg13_lv_nmos ad=0.2516p pd=2.16u as=0.2516p ps=2.16u w=0.74u l=0.13u
X2398 VSS.t174 a_25717_7532# a_26185_6734# VSS.t173 sg13_lv_nmos ad=0.1665p pd=1.19u as=0.2516p ps=2.16u w=0.74u l=0.13u
X2399 a_10713_14024# a_10517_14024# VDD.t516 VDD.t374 sg13_lv_pmos ad=0.3808p pd=2.92u as=0.2128p ps=1.5u w=1.12u l=0.13u
X2400 a_13470_3889# a_15831_3853# a_15755_3889# VDD.t0 sg13_lv_pmos ad=0.3808p pd=2.92u as=0.2128p ps=1.5u w=1.12u l=0.13u
X2401 a_26151_17497# a_25913_16869# a_26043_16869# VDD.t368 sg13_lv_pmos ad=0.2128p pd=1.5u as=0.3808p ps=2.92u w=1.12u l=0.2u
X2402 VSS.t225 a_3171_15338.t2 a_23945_15546# VSS.t1571 sg13_lv_nmos ad=0.2516p pd=2.16u as=0.2516p ps=2.16u w=0.74u l=0.13u
X2403 VSS.t1542 a_3747_13229.t7 a_12791_13190# VSS.t1541 sg13_lv_nmos ad=0.2516p pd=2.16u as=0.2516p ps=2.16u w=0.74u l=0.13u
X2404 VDD.t463 VDD.t461 VDD.t462 VDD.t456 sg13_lv_pmos ad=0.3808p pd=2.92u as=0 ps=0 w=1.12u l=0.13u
X2405 a_13231_7532# a_12993_7532# a_13123_7532# VSS.t1595 sg13_lv_nmos ad=0.1406p pd=1.12u as=0.2516p ps=2.16u w=0.74u l=0.2u
X2406 a_2019_1047.t0 a_1721_1395# VDD.t798 VDD.t2 sg13_lv_pmos ad=0.2128p pd=1.5u as=0.1918p ps=1.5u w=1.12u l=0.13u
X2407 VDD.t745 a_4187_2434# a_10191_2470# VDD.t373 sg13_lv_pmos ad=0.3808p pd=2.92u as=0.2128p ps=1.5u w=1.12u l=0.6u
X2408 a_16108_5979# REF_MUX_SEL4 a_15964_5979# VSS.t1353 sg13_lv_nmos ad=0.2516p pd=2.16u as=0.2183p ps=1.33u w=0.74u l=0.13u
X2409 VDD.t1400 a_3449_13577# a_3747_13229.t0 VDD.t5 sg13_lv_pmos ad=0.4256p pd=3u as=0.2128p ps=1.5u w=1.12u l=0.13u
X2410 VDD.t1610 a_3747_1047.t6 a_15831_1008# VDD.t2 sg13_lv_pmos ad=0.3808p pd=2.92u as=0.3808p ps=2.92u w=1.12u l=0.13u
X2411 a_15108_11015# a_14851_10872# a_15270_10795# VSS.t1174 sg13_lv_nmos ad=0.1428p pd=1.52u as=37.8f ps=0.6u w=0.42u l=0.13u
X2412 a_17791_8160# a_17553_7532# a_17683_7532# VDD.t346 sg13_lv_pmos ad=0.2128p pd=1.5u as=0.3808p ps=2.92u w=1.12u l=0.2u
X2413 VDD.t1065 a_3171_6737.t9 a_5844_6698# VDD.t67 sg13_lv_pmos ad=0.3808p pd=2.92u as=0.3808p ps=2.92u w=1.12u l=0.13u
X2414 VSS.t1221 a_4187_1764.t4 a_26151_1842# VSS.t1472 sg13_lv_nmos ad=0.2516p pd=2.16u as=0.1406p ps=1.12u w=0.74u l=0.6u
X2415 a_1544_16071# CHAN0_MUX_SEL1 VSS.t27 VSS.t26 sg13_lv_nmos ad=0.2516p pd=2.16u as=0.2516p ps=2.16u w=0.74u l=0.13u
X2416 VDD.t1613 a_2019_16074.t5 a_16484_16035# VDD.t90 sg13_lv_pmos ad=0.3808p pd=2.92u as=0.3808p ps=2.92u w=1.12u l=0.13u
X2417 VSS.t804 a_4187_1764.t98 VSS.t806 VSS.t805 sg13_lv_nmos ad=1.33p pd=7.38u as=0 ps=0 w=7u l=7u
X2418 VSS.t464 VDD.t1618 VSS.t464 VSS.t463 sg13_lv_nmos ad=0.1428p pd=1.52u as=0 ps=0 w=0.42u l=1u
X2419 VDD.t106 VSS.t305 VDD.t104 VDD.t67 sg13_lv_pmos ad=0.19p pd=1.38u as=0 ps=0 w=1u l=1u
X2420 VSS.t38 a_4437_7532# a_4905_6734# VSS.t765 sg13_lv_nmos ad=0.1665p pd=1.19u as=0.2516p ps=2.16u w=0.74u l=0.13u
X2421 VDD.t1308 a_2595_3892.t2 a_26471_3853# VDD.t0 sg13_lv_pmos ad=0.3808p pd=2.92u as=0.3808p ps=2.92u w=1.12u l=0.13u
X2422 a_25153_14024# a_24957_14024# VDD.t978 VDD.t374 sg13_lv_pmos ad=0.3808p pd=2.92u as=0.2128p ps=1.5u w=1.12u l=0.13u
X2423 VDD.t521 a_19963_1842# a_20397_1842# VDD.t373 sg13_lv_pmos ad=0.2128p pd=1.5u as=0.3808p ps=2.92u w=1.12u l=0.13u
X2424 a_16108_15316# a_20905_15546# a_19550_16071# VDD.t90 sg13_lv_pmos ad=0.3808p pd=2.92u as=0.3808p ps=2.92u w=1.12u l=0.13u
X2425 VSS.t291 VDD.t1674 VSS.t290 VSS.t289 sg13_lv_nmos ad=0.1428p pd=1.52u as=0 ps=0 w=0.42u l=1u
X2426 a_4350_3889# a_5191_3853# a_5115_3889# VDD.t0 sg13_lv_pmos ad=0.3808p pd=2.92u as=0.2128p ps=1.5u w=1.12u l=0.13u
X2427 a_27433_4687# a_27237_4687# VSS.t837 VSS.t2311 sg13_lv_nmos ad=0.2516p pd=2.16u as=0.1406p ps=1.12u w=0.74u l=0.13u
X2428 VSS.t202 VDD.t1700 VSS.t202 VSS.t203 sg13_lv_nmos ad=79.8f pd=0.8u as=0 ps=0 w=0.42u l=1u
X2429 VDD.t1040 a_2595_6737.t7 a_11271_6698# VDD.t67 sg13_lv_pmos ad=0.3808p pd=2.92u as=0.3808p ps=2.92u w=1.12u l=0.13u
X2430 VDD.t37 VSS.t365 VDD.t35 VDD.t0 sg13_lv_pmos ad=0.19p pd=1.38u as=0 ps=0 w=1u l=1u
X2431 a_9431_16869# a_9193_16869# a_9323_16869# VSS.t1503 sg13_lv_nmos ad=0.1406p pd=1.12u as=0.2516p ps=2.16u w=0.74u l=0.2u
X2432 a_4350_1044# a_4324_1008# a_4248_1044# VDD.t2 sg13_lv_pmos ad=0.3808p pd=2.92u as=0.2128p ps=1.5u w=1.12u l=0.13u
X2433 a_12233_7532# a_12037_7532# VSS.t849 VSS.t1264 sg13_lv_nmos ad=0.2516p pd=2.16u as=0.1406p ps=1.12u w=0.74u l=0.13u
X2434 a_14888_1044# a_14317_1842# VDD.t1057 VDD.t2 sg13_lv_pmos ad=0.2128p pd=1.5u as=0.3808p ps=2.92u w=1.12u l=0.13u
X2435 VSS.t1338 a_4187_1764.t32 a_4871_1842# VSS.t1337 sg13_lv_nmos ad=0.2516p pd=2.16u as=0.1406p ps=1.12u w=0.74u l=0.6u
X2436 a_19073_4687# a_18877_4687# VDD.t945 VDD.t348 sg13_lv_pmos ad=0.3808p pd=2.92u as=0.2128p ps=1.5u w=1.12u l=0.13u
X2437 VDD.t1249 a_16597_4687# a_17065_3889# VDD.t0 sg13_lv_pmos ad=0.252p pd=1.57u as=0.3808p ps=2.92u w=1.12u l=0.13u
X2438 VSS.t949 a_2595_15338.t3 a_8745_15546# VSS.t948 sg13_lv_nmos ad=0.2516p pd=2.16u as=0.2516p ps=2.16u w=0.74u l=0.13u
X2439 VDD.t1379 a_2019_13229.t9 a_4324_13190# VDD.t5 sg13_lv_pmos ad=0.3808p pd=2.92u as=0.3808p ps=2.92u w=1.12u l=0.13u
X2440 VSS.t1448 a_3449_7085# a_3747_6737.t1 VSS.t1447 sg13_lv_nmos ad=0.2812p pd=2.24u as=0.1406p ps=1.12u w=0.74u l=0.13u
X2441 VSS.t75 a_27563_16869# a_27997_16869# VSS.t74 sg13_lv_nmos ad=0.1406p pd=1.12u as=0.2516p ps=2.16u w=0.74u l=0.13u
X2442 VDD.t381 a_15108_11015# a_15053_11110# VDD.t355 sg13_lv_pmos ad=1.10612p pd=6.66u as=93.45f ps=0.865u w=0.42u l=0.13u
X2443 VSS.t1145 a_3171_6737.t8 a_8884_6698# VSS.t2121 sg13_lv_nmos ad=0.2516p pd=2.16u as=0.2516p ps=2.16u w=0.74u l=0.13u
X2444 VDD.t1463 CHAN0_MUX_SEL4 a_15765_15490# VDD.t90 sg13_lv_pmos ad=0.3808p pd=2.92u as=0.3808p ps=2.92u w=1.12u l=0.13u
X2445 VDD.t1291 a_3747_6737.t8 a_9751_6698# VDD.t67 sg13_lv_pmos ad=0.3808p pd=2.92u as=0.3808p ps=2.92u w=1.12u l=0.13u
X2446 VDD.t922 a_3747_16074.t4 a_21911_16035# VDD.t90 sg13_lv_pmos ad=0.3808p pd=2.92u as=0.3808p ps=2.92u w=1.12u l=0.13u
X2447 a_9953_14024# a_9757_14024# VDD.t1108 VDD.t374 sg13_lv_pmos ad=0.3808p pd=2.92u as=0.2128p ps=1.5u w=1.12u l=0.13u
X2448 a_21591_8160# a_21353_7532# a_21483_7532# VDD.t346 sg13_lv_pmos ad=0.2128p pd=1.5u as=0.3808p ps=2.92u w=1.12u l=0.2u
X2449 VSS.t358 VDD.t1649 VSS.t358 VSS.t359 sg13_lv_nmos ad=79.8f pd=0.8u as=0 ps=0 w=0.42u l=1u
X2450 a_27048_13226# a_26477_14024# VSS.t1975 VSS.t1974 sg13_lv_nmos ad=0.1406p pd=1.12u as=0.2516p ps=2.16u w=0.74u l=0.13u
X2451 VSS.t243 VDD.t1686 VSS.t243 VSS.t242 sg13_lv_nmos ad=0.1428p pd=1.52u as=0 ps=0 w=0.42u l=1u
X2452 a_6153_7532# a_5957_7532# VDD.t380 VDD.t346 sg13_lv_pmos ad=0.3808p pd=2.92u as=0.2128p ps=1.5u w=1.12u l=0.13u
X2453 a_3543_7085# REF_MUX_SEL0 a_3449_7085# VSS.t2164 sg13_lv_nmos ad=0.1216p pd=1.02u as=0.2176p ps=1.96u w=0.64u l=0.13u
X2454 VSS.t2212 a_4187_1764.t61 a_7151_4687# VSS.t2381 sg13_lv_nmos ad=0.2516p pd=2.16u as=0.1406p ps=1.12u w=0.74u l=0.6u
X2455 VDD.t1142 a_16163_7532# a_16597_7532# VDD.t346 sg13_lv_pmos ad=0.2128p pd=1.5u as=0.3808p ps=2.92u w=1.12u l=0.13u
X2456 VSS.t1419 a_4187_1764.t106 a_23111_14024# VSS.t2151 sg13_lv_nmos ad=0.2516p pd=2.16u as=0.1406p ps=1.12u w=0.74u l=0.6u
X2457 a_1256_289# CHAN3_MUX_SEL2 VDD.t1171 VDD.t2 sg13_lv_pmos ad=0.3808p pd=2.92u as=0.3808p ps=2.92u w=1.12u l=0.13u
X2458 VDD.t501 a_19203_4687# a_19637_4687# VDD.t348 sg13_lv_pmos ad=0.2128p pd=1.5u as=0.3808p ps=2.92u w=1.12u l=0.13u
X2459 a_11711_14652# a_11473_14024# a_11603_14024# VDD.t374 sg13_lv_pmos ad=0.2128p pd=1.5u as=0.3808p ps=2.92u w=1.12u l=0.2u
X2460 a_5731_15316# a_11785_15546# a_10430_16071# VDD.t90 sg13_lv_pmos ad=0.3808p pd=2.92u as=0.3808p ps=2.92u w=1.12u l=0.13u
X2461 VSS.t669 a_7803_16869# a_8237_16869# VSS.t668 sg13_lv_nmos ad=0.1406p pd=1.12u as=0.2516p ps=2.16u w=0.74u l=0.13u
X2462 VDD.t1521 a_3747_16074.t9 a_6711_16035# VDD.t90 sg13_lv_pmos ad=0.3808p pd=2.92u as=0.3808p ps=2.92u w=1.12u l=0.13u
X2463 VDD.t672 a_4187_2434# a_12471_14652# VDD.t374 sg13_lv_pmos ad=0.3808p pd=2.92u as=0.2128p ps=1.5u w=1.12u l=0.6u
X2464 a_27915_6734# a_27705_6734# VSS.t1359 VSS.t2299 sg13_lv_nmos ad=0.1406p pd=1.12u as=0.1665p ps=1.19u w=0.74u l=0.13u
X2465 a_16108_289# a_15765_463# a_15964_289# VDD.t2 sg13_lv_pmos ad=0.3808p pd=2.92u as=0.3304p ps=1.71u w=1.12u l=0.13u
X2466 VSS.t565 VSS.t562 VSS.t564 VSS.t563 sg13_lv_nmos ad=0.2516p pd=2.16u as=0 ps=0 w=0.74u l=0.6u
X2467 a_15964_3134# CHAN2_MUX_SEL4 a_5731_3134# VDD.t0 sg13_lv_pmos ad=0.3304p pd=1.71u as=0.3808p ps=2.92u w=1.12u l=0.13u
X2468 a_20831_16869# a_20593_16869# a_20723_16869# VSS.t2178 sg13_lv_nmos ad=0.1406p pd=1.12u as=0.2516p ps=2.16u w=0.74u l=0.2u
X2469 VSS.t372 VDD.t1643 VSS.t372 VSS.t371 sg13_lv_nmos ad=0.1428p pd=1.52u as=0 ps=0 w=0.42u l=1u
X2470 VDD.t532 a_8563_4687# a_8997_4687# VDD.t348 sg13_lv_pmos ad=0.2128p pd=1.5u as=0.3808p ps=2.92u w=1.12u l=0.13u
X2471 VDD.t687 a_4187_2434# a_10191_8160# VDD.t346 sg13_lv_pmos ad=0.3808p pd=2.92u as=0.2128p ps=1.5u w=1.12u l=0.6u
X2472 a_26151_14652# a_25913_14024# a_26043_14024# VDD.t374 sg13_lv_pmos ad=0.2128p pd=1.5u as=0.3808p ps=2.92u w=1.12u l=0.2u
X2473 VDD.t738 a_4187_2434# a_13231_5315# VDD.t348 sg13_lv_pmos ad=0.3808p pd=2.92u as=0.2128p ps=1.5u w=1.12u l=0.6u
X2474 VSS.t892 a_4187_1764.t140 a_21591_16869# VSS.t891 sg13_lv_nmos ad=0.2516p pd=2.16u as=0.1406p ps=1.12u w=0.74u l=0.6u
X2475 VDD.t847 a_8997_1842# a_9465_1044# VDD.t2 sg13_lv_pmos ad=0.252p pd=1.57u as=0.3808p ps=2.92u w=1.12u l=0.13u
X2476 a_26673_16869# a_26477_16869# VDD.t925 VDD.t368 sg13_lv_pmos ad=0.3808p pd=2.92u as=0.2128p ps=1.5u w=1.12u l=0.13u
X2477 VSS.t1320 a_4187_1764.t126 a_7911_14024# VSS.t1649 sg13_lv_nmos ad=0.2516p pd=2.16u as=0.1406p ps=1.12u w=0.74u l=0.6u
X2478 VSS.t745 a_4187_1764.t68 a_26151_7532# VSS.t744 sg13_lv_nmos ad=0.2516p pd=2.16u as=0.1406p ps=1.12u w=0.74u l=0.6u
X2479 VSS.t776 a_25283_14024# a_25717_14024# VSS.t775 sg13_lv_nmos ad=0.1406p pd=1.12u as=0.2516p ps=2.16u w=0.74u l=0.13u
X2480 a_11473_1842# a_11277_1842# VDD.t858 VDD.t373 sg13_lv_pmos ad=0.3808p pd=2.92u as=0.2128p ps=1.5u w=1.12u l=0.13u
X2481 VDD.t58 VSS.t86 VDD.t56 VDD.t0 sg13_lv_pmos ad=0.19p pd=1.38u as=0 ps=0 w=1u l=1u
X2482 a_2391_331# CHAN3_MUX_SEL2 a_2297_331# VSS.t1632 sg13_lv_nmos ad=0.1216p pd=1.02u as=0.2176p ps=1.96u w=0.64u l=0.13u
X2483 a_22590_13226# a_3171_13229.t3 a_24008_13226# VSS.t1558 sg13_lv_nmos ad=0.2516p pd=2.16u as=0.1406p ps=1.12u w=0.74u l=0.13u
X2484 VDD.t564 a_19963_7532# a_20397_7532# VDD.t346 sg13_lv_pmos ad=0.2128p pd=1.5u as=0.3808p ps=2.92u w=1.12u l=0.13u
X2485 a_1544_3889# CHAN2_MUX_SEL1 VSS.t1609 VSS.t930 sg13_lv_nmos ad=0.2516p pd=2.16u as=0.2516p ps=2.16u w=0.74u l=0.13u
X2486 a_16108_5979# a_3747_6001.t2 a_25630_6734# VSS.t1426 sg13_lv_nmos ad=0.2516p pd=2.16u as=0.2516p ps=2.16u w=0.74u l=0.13u
X2487 VDD.t207 VSS.t202 VDD.t206 VDD.t90 sg13_lv_pmos ad=0.34p pd=2.68u as=0 ps=0 w=1u l=1u
X2488 a_15964_12471# CHAN1_MUX_SEL4 a_5731_12471# VDD.t5 sg13_lv_pmos ad=0.3304p pd=1.71u as=0.3808p ps=2.92u w=1.12u l=0.13u
X2489 a_27433_1842# a_27237_1842# VSS.t795 VSS.t1989 sg13_lv_nmos ad=0.2516p pd=2.16u as=0.1406p ps=1.12u w=0.74u l=0.13u
X2490 VDD.t910 a_23003_4687# a_23437_4687# VDD.t348 sg13_lv_pmos ad=0.2128p pd=1.5u as=0.3808p ps=2.92u w=1.12u l=0.13u
X2491 VSS.t1203 a_2595_16074.t2 a_26471_16035# VSS.t2227 sg13_lv_nmos ad=0.2516p pd=2.16u as=0.2516p ps=2.16u w=0.74u l=0.13u
X2492 VSS.t791 a_20723_14024# a_21157_14024# VSS.t1834 sg13_lv_nmos ad=0.1406p pd=1.12u as=0.2516p ps=2.16u w=0.74u l=0.13u
X2493 VSS.t25 a_4187_1764.t96 a_4871_7532# VSS.t2184 sg13_lv_nmos ad=0.2516p pd=2.16u as=0.1406p ps=1.12u w=0.74u l=0.6u
X2494 a_4157_4158# CHAN2_DELAY_IN VDD.t1095 VDD.t0 sg13_lv_pmos ad=0.3808p pd=2.92u as=0.3808p ps=2.92u w=1.12u l=0.13u
X2495 a_13470_3889# a_3747_3892.t6 a_15755_3889# VSS.t1682 sg13_lv_nmos ad=0.2516p pd=2.16u as=0.1406p ps=1.12u w=0.74u l=0.13u
X2496 a_13592_11113# a_13566_11018# VDD.t406 VDD.t355 sg13_lv_pmos ad=0.34p pd=2.68u as=0.36237p ps=2.605u w=1u l=0.13u
X2497 a_2967_331# CHAN3_MUX_SEL3 a_2873_331# VSS.t1623 sg13_lv_nmos ad=0.1216p pd=1.02u as=0.2176p ps=1.96u w=0.64u l=0.13u
X2498 a_18795_3889# a_18585_3889# VDD.t779 VDD.t0 sg13_lv_pmos ad=0.2128p pd=1.5u as=0.252p ps=1.57u w=1.12u l=0.13u
X2499 a_9675_16071# a_9465_16071# VDD.t1269 VDD.t90 sg13_lv_pmos ad=0.2128p pd=1.5u as=0.252p ps=1.57u w=1.12u l=0.13u
X2500 VDD.t820 a_2595_3892.t5 a_17351_3853# VDD.t0 sg13_lv_pmos ad=0.3808p pd=2.92u as=0.3808p ps=2.92u w=1.12u l=0.13u
X2501 VSS.t1850 a_3449_4240# a_3747_3892.t1 VSS.t1849 sg13_lv_nmos ad=0.2812p pd=2.24u as=0.1406p ps=1.12u w=0.74u l=0.13u
X2502 a_25630_3889# a_27124_3853# a_27048_3889# VDD.t0 sg13_lv_pmos ad=0.3808p pd=2.92u as=0.2128p ps=1.5u w=1.12u l=0.13u
X2503 VSS.t960 a_2595_3892.t2 a_26471_3853# VSS.t1913 sg13_lv_nmos ad=0.2516p pd=2.16u as=0.2516p ps=2.16u w=0.74u l=0.13u
X2504 a_18313_4687# a_18117_4687# VSS.t856 VSS.t855 sg13_lv_nmos ad=0.2516p pd=2.16u as=0.1406p ps=1.12u w=0.74u l=0.13u
X2505 a_5393_16869# a_5197_16869# VSS.t1048 VSS.t1047 sg13_lv_nmos ad=0.2516p pd=2.16u as=0.1406p ps=1.12u w=0.74u l=0.13u
X2506 VDD.t1368 a_2019_1047.t5 a_16484_1008# VDD.t2 sg13_lv_pmos ad=0.3808p pd=2.92u as=0.3808p ps=2.92u w=1.12u l=0.13u
X2507 a_9431_4687# a_9193_4687# a_9323_4687# VSS.t621 sg13_lv_nmos ad=0.1406p pd=1.12u as=0.2516p ps=2.16u w=0.74u l=0.2u
X2508 a_4350_3889# a_2595_3892.t9 a_5115_3889# VSS.t2018 sg13_lv_nmos ad=0.2516p pd=2.16u as=0.1406p ps=1.12u w=0.74u l=0.13u
X2509 VSS.t1102 a_2019_16074.t3 a_22564_16035# VSS.t1101 sg13_lv_nmos ad=0.2516p pd=2.16u as=0.2516p ps=2.16u w=0.74u l=0.13u
X2510 a_1544_15316# CHAN0_MUX_SEL3 VDD.t1464 VDD.t90 sg13_lv_pmos ad=0.3808p pd=2.92u as=0.3808p ps=2.92u w=1.12u l=0.13u
X2511 a_7390_1044# a_2595_1047.t8 a_8155_1044# VSS.t720 sg13_lv_nmos ad=0.2516p pd=2.16u as=0.1406p ps=1.12u w=0.74u l=0.13u
X2512 CHAN2_MUX_OUT a_16851_3154# VSS.t2114 VSS.t2113 sg13_lv_nmos ad=0.1406p pd=1.12u as=0.1371p ps=1.12u w=0.74u l=0.13u
X2513 a_7390_13226# a_3171_13229.t8 a_8808_13226# VSS.t1653 sg13_lv_nmos ad=0.2516p pd=2.16u as=0.1406p ps=1.12u w=0.74u l=0.13u
X2514 a_1544_5979# REF_MUX_SEL3 VDD.t809 VDD.t67 sg13_lv_pmos ad=0.3808p pd=2.92u as=0.3808p ps=2.92u w=1.12u l=0.13u
X2515 a_7390_16071# a_2019_16074.t8 a_7288_16071# VSS.t912 sg13_lv_nmos ad=0.2516p pd=2.16u as=0.1406p ps=1.12u w=0.74u l=0.13u
X2516 a_4350_3889# a_5844_3853# a_5768_3889# VDD.t0 sg13_lv_pmos ad=0.3808p pd=2.92u as=0.2128p ps=1.5u w=1.12u l=0.13u
X2517 a_16108_3134# a_2595_3156.t2 a_19550_3889# VSS.t784 sg13_lv_nmos ad=0.2516p pd=2.16u as=0.2516p ps=2.16u w=0.74u l=0.13u
X2518 VSS.t1812 a_16597_4687# a_17065_3889# VSS.t2278 sg13_lv_nmos ad=0.1665p pd=1.19u as=0.2516p ps=2.16u w=0.74u l=0.13u
X2519 a_3543_4240# CHAN2_MUX_SEL0 a_3449_4240# VSS.t2301 sg13_lv_nmos ad=0.1216p pd=1.02u as=0.2176p ps=1.96u w=0.64u l=0.13u
X2520 a_4350_13226# a_2019_13229.t9 a_4248_13226# VSS.t2028 sg13_lv_nmos ad=0.2516p pd=2.16u as=0.1406p ps=1.12u w=0.74u l=0.13u
X2521 VDD.t64 VSS.t258 VDD.t63 VDD.t5 sg13_lv_pmos ad=0.34p pd=2.68u as=0 ps=0 w=1u l=1u
X2522 VDD.t577 a_3171_1047.t9 a_5844_1008# VDD.t2 sg13_lv_pmos ad=0.3808p pd=2.92u as=0.3808p ps=2.92u w=1.12u l=0.13u
X2523 VSS.t982 a_4187_1764.t29 a_7151_1842# VSS.t981 sg13_lv_nmos ad=0.2516p pd=2.16u as=0.1406p ps=1.12u w=0.74u l=0.6u
X2524 VDD.t176 VSS.t209 VDD.t175 VDD.t90 sg13_lv_pmos ad=0.34p pd=2.68u as=0 ps=0 w=1u l=1u
X2525 VDD.t1335 a_12037_14024# a_12505_13226# VDD.t5 sg13_lv_pmos ad=0.252p pd=1.57u as=0.3808p ps=2.92u w=1.12u l=0.13u
X2526 a_23871_4687# a_23633_4687# a_23763_4687# VSS.t1157 sg13_lv_nmos ad=0.1406p pd=1.12u as=0.2516p ps=2.16u w=0.74u l=0.2u
X2527 a_16510_16071# a_18004_16035# a_17928_16071# VDD.t90 sg13_lv_pmos ad=0.3808p pd=2.92u as=0.2128p ps=1.5u w=1.12u l=0.13u
X2528 a_8433_4687# a_8237_4687# VSS.t116 VSS.t1346 sg13_lv_nmos ad=0.2516p pd=2.16u as=0.1406p ps=1.12u w=0.74u l=0.13u
X2529 a_5731_12471# a_2595_12493.t3 a_7390_13226# VSS.t987 sg13_lv_nmos ad=0.2516p pd=2.16u as=0.2516p ps=2.16u w=0.74u l=0.13u
X2530 a_12656_11554# DLL_RESETN VSS.t2216 VSS.t2215 sg13_lv_nmos ad=0.2516p pd=2.16u as=0.2516p ps=2.16u w=0.74u l=0.13u
X2531 VDD.t574 a_2595_1047.t7 a_11271_1008# VDD.t2 sg13_lv_pmos ad=0.3808p pd=2.92u as=0.3808p ps=2.92u w=1.12u l=0.13u
X2532 VSS.t860 a_18443_4687# a_18877_4687# VSS.t1231 sg13_lv_nmos ad=0.1406p pd=1.12u as=0.2516p ps=2.16u w=0.74u l=0.13u
X2533 a_15511_5315# a_15273_4687# a_15403_4687# VDD.t348 sg13_lv_pmos ad=0.2128p pd=1.5u as=0.3808p ps=2.92u w=1.12u l=0.2u
X2534 VSS.t107 a_2595_16074.t5 a_17351_16035# VSS.t106 sg13_lv_nmos ad=0.2516p pd=2.16u as=0.2516p ps=2.16u w=0.74u l=0.13u
X2535 VDD.t1174 a_3171_13229.t4 a_21044_13190# VDD.t5 sg13_lv_pmos ad=0.3808p pd=2.92u as=0.3808p ps=2.92u w=1.12u l=0.13u
X2536 VSS.t540 VSS.t537 VSS.t539 VSS.t538 sg13_lv_nmos ad=0.2516p pd=2.16u as=0 ps=0 w=0.74u l=0.6u
X2537 a_1544_6734# REF_MUX_SEL1 VDD.t1556 VDD.t67 sg13_lv_pmos ad=0.3808p pd=2.92u as=0.3808p ps=2.92u w=1.12u l=0.13u
X2538 a_27671_17497# a_27433_16869# a_27563_16869# VDD.t368 sg13_lv_pmos ad=0.2128p pd=1.5u as=0.3808p ps=2.92u w=1.12u l=0.2u
X2539 VSS.t1208 a_2595_13229.t6 a_14311_13190# VSS.t1667 sg13_lv_nmos ad=0.2516p pd=2.16u as=0.2516p ps=2.16u w=0.74u l=0.13u
X2540 VDD.t760 a_4187_2434# a_25391_2470# VDD.t373 sg13_lv_pmos ad=0.3808p pd=2.92u as=0.2128p ps=1.5u w=1.12u l=0.6u
X2541 a_22113_4687# a_21917_4687# VSS.t2071 VSS.t2220 sg13_lv_nmos ad=0.2516p pd=2.16u as=0.1406p ps=1.12u w=0.74u l=0.13u
X2542 a_13470_6734# a_15831_6698# a_15755_6734# VDD.t67 sg13_lv_pmos ad=0.3808p pd=2.92u as=0.2128p ps=1.5u w=1.12u l=0.13u
X2543 VDD.t132 VSS.t419 VDD.t130 VDD.t2 sg13_lv_pmos ad=0.19p pd=1.38u as=0 ps=0 w=1u l=1u
X2544 VSS.t1191 a_3747_16074.t7 a_12791_16035# VSS.t1190 sg13_lv_nmos ad=0.2516p pd=2.16u as=0.2516p ps=2.16u w=0.74u l=0.13u
X2545 VSS.t1149 a_12037_1842# a_12505_1044# VSS.t1250 sg13_lv_nmos ad=0.1665p pd=1.19u as=0.2516p ps=2.16u w=0.74u l=0.13u
X2546 VSS.t216 a_2595_15338.t2 a_20905_15546# VSS.t951 sg13_lv_nmos ad=0.2516p pd=2.16u as=0.2516p ps=2.16u w=0.74u l=0.13u
X2547 a_26673_14024# a_26477_14024# VDD.t882 VDD.t374 sg13_lv_pmos ad=0.3808p pd=2.92u as=0.2128p ps=1.5u w=1.12u l=0.13u
X2548 a_11473_7532# a_11277_7532# VDD.t597 VDD.t346 sg13_lv_pmos ad=0.3808p pd=2.92u as=0.2128p ps=1.5u w=1.12u l=0.13u
X2549 VDD.t1277 a_3747_1047.t8 a_9751_1008# VDD.t2 sg13_lv_pmos ad=0.3808p pd=2.92u as=0.3808p ps=2.92u w=1.12u l=0.13u
X2550 VDD.t1439 a_16851_3154# CHAN2_MUX_OUT VDD.t0 sg13_lv_pmos ad=0.7336p pd=3.55u as=0.2128p ps=1.5u w=1.12u l=0.13u
X2551 VSS.t35 a_4187_1764.t54 a_12471_4687# VSS.t2157 sg13_lv_nmos ad=0.2516p pd=2.16u as=0.1406p ps=1.12u w=0.74u l=0.6u
X2552 VDD.t887 a_2595_6737.t2 a_26471_6698# VDD.t67 sg13_lv_pmos ad=0.3808p pd=2.92u as=0.3808p ps=2.92u w=1.12u l=0.13u
X2553 a_4350_6734# a_5191_6698# a_5115_6734# VDD.t67 sg13_lv_pmos ad=0.3808p pd=2.92u as=0.2128p ps=1.5u w=1.12u l=0.13u
X2554 a_27433_7532# a_27237_7532# VSS.t1357 VSS.t1356 sg13_lv_nmos ad=0.2516p pd=2.16u as=0.1406p ps=1.12u w=0.74u l=0.13u
X2555 VSS.t120 a_10083_16869# a_10517_16869# VSS.t1505 sg13_lv_nmos ad=0.1406p pd=1.12u as=0.2516p ps=2.16u w=0.74u l=0.13u
X2556 VDD.t299 VSS.t229 VDD.t298 VDD.t90 sg13_lv_pmos ad=0.19p pd=1.38u as=0 ps=0 w=1u l=1u
X2557 a_7288_16071# a_6717_16869# VDD.t1476 VDD.t90 sg13_lv_pmos ad=0.2128p pd=1.5u as=0.3808p ps=2.92u w=1.12u l=0.13u
X2558 VDD.t1175 a_3747_13229.t6 a_15831_13190# VDD.t5 sg13_lv_pmos ad=0.3808p pd=2.92u as=0.3808p ps=2.92u w=1.12u l=0.13u
X2559 VSS.t278 VDD.t1677 VSS.t278 VSS.t277 sg13_lv_nmos ad=0.1428p pd=1.52u as=0 ps=0 w=0.42u l=1u
X2560 a_6391_16869# a_6153_16869# a_6283_16869# VSS.t1365 sg13_lv_nmos ad=0.1406p pd=1.12u as=0.2516p ps=2.16u w=0.74u l=0.2u
X2561 VSS.t229 VDD.t1689 VSS.t229 VSS.t231 sg13_lv_nmos ad=0.1428p pd=1.52u as=0 ps=0 w=0.42u l=1u
X2562 a_2873_13577# CHAN1_MUX_SEL1 VDD.t900 VDD.t5 sg13_lv_pmos ad=0.1596p pd=1.22u as=0.2856p ps=2.36u w=0.84u l=0.13u
X2563 VDD.t898 a_16597_7532# a_17065_6734# VDD.t67 sg13_lv_pmos ad=0.252p pd=1.57u as=0.3808p ps=2.92u w=1.12u l=0.13u
X2564 VSS.t1564 a_22243_4687# a_22677_4687# VSS.t2290 sg13_lv_nmos ad=0.1406p pd=1.12u as=0.2516p ps=2.16u w=0.74u l=0.13u
X2565 VDD.t828 a_3171_12493.t2 a_23945_12701# VDD.t5 sg13_lv_pmos ad=0.3808p pd=2.92u as=0.3808p ps=2.92u w=1.12u l=0.13u
X2566 a_17275_13226# a_17065_13226# VSS.t845 VSS.t2078 sg13_lv_nmos ad=0.1406p pd=1.12u as=0.1665p ps=1.19u w=0.74u l=0.13u
X2567 VSS.t1501 a_4187_1764.t159 a_7151_16869# VSS.t1741 sg13_lv_nmos ad=0.2516p pd=2.16u as=0.1406p ps=1.12u w=0.74u l=0.6u
X2568 a_1544_13226# CHAN1_MUX_SEL1 VDD.t899 VDD.t5 sg13_lv_pmos ad=0.3808p pd=2.92u as=0.3808p ps=2.92u w=1.12u l=0.13u
X2569 VSS.t1055 a_24523_16869# a_24957_16869# VSS.t2242 sg13_lv_nmos ad=0.1406p pd=1.12u as=0.2516p ps=2.16u w=0.74u l=0.13u
X2570 VDD.t1125 a_2595_16074.t3 a_23431_16035# VDD.t90 sg13_lv_pmos ad=0.3808p pd=2.92u as=0.3808p ps=2.92u w=1.12u l=0.13u
X2571 VSS.t188 a_2019_15338.t3 a_5705_15546# VSS.t2260 sg13_lv_nmos ad=0.2516p pd=2.16u as=0.2516p ps=2.16u w=0.74u l=0.13u
X2572 a_18313_1842# a_18117_1842# VSS.t1217 VSS.t1216 sg13_lv_nmos ad=0.2516p pd=2.16u as=0.1406p ps=1.12u w=0.74u l=0.13u
X2573 VDD.t873 a_13883_4687# a_14317_4687# VDD.t348 sg13_lv_pmos ad=0.2128p pd=1.5u as=0.3808p ps=2.92u w=1.12u l=0.13u
X2574 CHAN3_MUX_OUT a_16851_309# VSS.t854 VSS.t1604 sg13_lv_nmos ad=0.1406p pd=1.12u as=0.1371p ps=1.12u w=0.74u l=0.13u
X2575 a_9431_1842# a_9193_1842# a_9323_1842# VSS.t594 sg13_lv_nmos ad=0.1406p pd=1.12u as=0.2516p ps=2.16u w=0.74u l=0.2u
X2576 a_7390_6734# a_2595_6737.t8 a_8155_6734# VSS.t1382 sg13_lv_nmos ad=0.2516p pd=2.16u as=0.1406p ps=1.12u w=0.74u l=0.13u
X2577 a_7390_16071# a_8231_16035# a_8155_16071# VDD.t90 sg13_lv_pmos ad=0.3808p pd=2.92u as=0.2128p ps=1.5u w=1.12u l=0.13u
X2578 VSS.t188 VDD.t1704 VSS.t188 VSS.t193 sg13_lv_nmos ad=79.8f pd=0.8u as=0 ps=0 w=0.42u l=1u
X2579 a_27048_16071# a_26477_16869# VSS.t1203 VSS.t2321 sg13_lv_nmos ad=0.1406p pd=1.12u as=0.2516p ps=2.16u w=0.74u l=0.13u
X2580 a_18795_3889# a_18585_3889# VSS.t858 VSS.t1758 sg13_lv_nmos ad=0.1406p pd=1.12u as=0.1665p ps=1.19u w=0.74u l=0.13u
X2581 VSS.t53 a_6126_9506# a_5974_11413# VSS.t49 sg13_lv_nmos ad=0.68p pd=4.68u as=0.38p ps=2.38u w=2u l=1u
X2582 VSS.t455 VDD.t1620 VSS.t455 VSS.t457 sg13_lv_nmos ad=79.8f pd=0.8u as=0 ps=0 w=0.42u l=1u
X2583 a_1544_3134# CHAN2_MUX_SEL3 VDD.t806 VDD.t0 sg13_lv_pmos ad=0.3808p pd=2.92u as=0.3808p ps=2.92u w=1.12u l=0.13u
X2584 VDD.t661 a_4187_2434# a_19311_17497# VDD.t368 sg13_lv_pmos ad=0.3808p pd=2.92u as=0.2128p ps=1.5u w=1.12u l=0.6u
X2585 VSS.t1074 a_1544_13226# a_2391_13577# VSS.t1255 sg13_lv_nmos ad=0.1331p pd=1.12u as=0.1216p ps=1.02u w=0.64u l=0.13u
X2586 VSS.t868 a_4187_1764.t93 a_7151_7532# VSS.t1333 sg13_lv_nmos ad=0.2516p pd=2.16u as=0.1406p ps=1.12u w=0.74u l=0.6u
X2587 VDD.t322 VSS.t297 VDD.t158 VDD.t5 sg13_lv_pmos ad=0.19p pd=1.38u as=0 ps=0 w=1u l=1u
X2588 VSS.t957 a_2595_3892.t5 a_17351_3853# VSS.t956 sg13_lv_nmos ad=0.2516p pd=2.16u as=0.2516p ps=2.16u w=0.74u l=0.13u
X2589 a_25630_3889# a_3171_3892.t2 a_27048_3889# VSS.t958 sg13_lv_nmos ad=0.2516p pd=2.16u as=0.1406p ps=1.12u w=0.74u l=0.13u
X2590 VSS.t1071 a_4187_1764.t110 a_20071_14024# VSS.t1240 sg13_lv_nmos ad=0.2516p pd=2.16u as=0.1406p ps=1.12u w=0.74u l=0.6u
X2591 VDD.t826 a_2595_12493.t3 a_8745_12701# VDD.t5 sg13_lv_pmos ad=0.3808p pd=2.92u as=0.3808p ps=2.92u w=1.12u l=0.13u
X2592 VDD.t381 a_14009_11568# a_14111_11568# VDD.t355 sg13_lv_pmos ad=1.10612p pd=6.66u as=0.3864p ps=2.93u w=1.12u l=0.13u
X2593 a_23871_1842# a_23633_1842# a_23763_1842# VSS.t1439 sg13_lv_nmos ad=0.1406p pd=1.12u as=0.2516p ps=2.16u w=0.74u l=0.2u
X2594 VSS.t299 VDD.t1672 VSS.t299 VSS.t298 sg13_lv_nmos ad=0.1428p pd=1.52u as=0 ps=0 w=0.42u l=1u
X2595 VDD.t586 a_4003_4687# a_4437_4687# VDD.t348 sg13_lv_pmos ad=0.2128p pd=1.5u as=0.3808p ps=2.92u w=1.12u l=0.13u
X2596 a_8433_1842# a_8237_1842# VSS.t994 VSS.t1204 sg13_lv_nmos ad=0.2516p pd=2.16u as=0.1406p ps=1.12u w=0.74u l=0.13u
X2597 VSS.t68 a_9323_16869# a_9757_16869# VSS.t67 sg13_lv_nmos ad=0.1406p pd=1.12u as=0.2516p ps=2.16u w=0.74u l=0.13u
X2598 VSS.t427 VDD.t1627 VSS.t430 VSS.t429 sg13_lv_nmos ad=79.8f pd=0.8u as=0 ps=0 w=0.42u l=1u
X2599 VSS.t980 a_18443_1842# a_18877_1842# VSS.t1979 sg13_lv_nmos ad=0.1406p pd=1.12u as=0.2516p ps=2.16u w=0.74u l=0.13u
X2600 a_1544_289# CHAN3_MUX_SEL3 VDD.t1162 VDD.t2 sg13_lv_pmos ad=0.3808p pd=2.92u as=0.3808p ps=2.92u w=1.12u l=0.13u
X2601 a_5731_3134# a_3171_3156.t3 a_10430_3889# VSS.t1057 sg13_lv_nmos ad=0.2516p pd=2.16u as=0.2516p ps=2.16u w=0.74u l=0.13u
X2602 a_26395_16071# a_26185_16071# VDD.t1362 VDD.t90 sg13_lv_pmos ad=0.2128p pd=1.5u as=0.252p ps=1.57u w=1.12u l=0.13u
X2603 VDD.t714 a_4187_2434# a_25391_8160# VDD.t346 sg13_lv_pmos ad=0.3808p pd=2.92u as=0.2128p ps=1.5u w=1.12u l=0.6u
X2604 a_27671_14652# a_27433_14024# a_27563_14024# VDD.t374 sg13_lv_pmos ad=0.2128p pd=1.5u as=0.3808p ps=2.92u w=1.12u l=0.2u
X2605 a_4350_3889# a_3171_3892.t9 a_5768_3889# VSS.t961 sg13_lv_nmos ad=0.2516p pd=2.16u as=0.1406p ps=1.12u w=0.74u l=0.13u
X2606 a_22113_1842# a_21917_1842# VSS.t717 VSS.t1531 sg13_lv_nmos ad=0.2516p pd=2.16u as=0.1406p ps=1.12u w=0.74u l=0.13u
X2607 a_10328_1044# a_9757_1842# VSS.t1402 VSS.t1401 sg13_lv_nmos ad=0.1406p pd=1.12u as=0.2516p ps=2.16u w=0.74u l=0.13u
X2608 a_22113_16869# a_21917_16869# VSS.t892 VSS.t2238 sg13_lv_nmos ad=0.2516p pd=2.16u as=0.1406p ps=1.12u w=0.74u l=0.13u
X2609 VSS.t239 VDD.t1687 VSS.t241 VSS.t240 sg13_lv_nmos ad=79.8f pd=0.8u as=0 ps=0 w=0.42u l=1u
X2610 VSS.t178 a_12037_7532# a_12505_6734# VSS.t1263 sg13_lv_nmos ad=0.1665p pd=1.19u as=0.2516p ps=2.16u w=0.74u l=0.13u
X2611 a_26673_1842# a_26477_1842# VDD.t936 VDD.t373 sg13_lv_pmos ad=0.3808p pd=2.92u as=0.2128p ps=1.5u w=1.12u l=0.13u
X2612 VDD.t1310 a_2019_3892.t8 a_7364_3853# VDD.t0 sg13_lv_pmos ad=0.3808p pd=2.92u as=0.3808p ps=2.92u w=1.12u l=0.13u
X2613 VDD.t463 VDD.t464 VDD.t465 VDD.t456 sg13_lv_pmos ad=0.2128p pd=1.5u as=0 ps=0 w=1.12u l=0.13u
X2614 VSS.t430 VDD.t1626 VSS.t430 VSS.t431 sg13_lv_nmos ad=0.1428p pd=1.52u as=0 ps=0 w=0.42u l=1u
X2615 a_22590_1044# a_2019_1047.t3 a_22488_1044# VSS.t2016 sg13_lv_nmos ad=0.2516p pd=2.16u as=0.1406p ps=1.12u w=0.74u l=0.13u
X2616 a_26151_4687# a_25913_4687# a_26043_4687# VSS.t1452 sg13_lv_nmos ad=0.1406p pd=1.12u as=0.2516p ps=2.16u w=0.74u l=0.2u
X2617 a_23633_16869# a_23437_16869# VDD.t510 VDD.t368 sg13_lv_pmos ad=0.3808p pd=2.92u as=0.2128p ps=1.5u w=1.12u l=0.13u
X2618 a_22590_16071# a_3171_16074.t3 a_24008_16071# VSS.t608 sg13_lv_nmos ad=0.2516p pd=2.16u as=0.1406p ps=1.12u w=0.74u l=0.13u
X2619 VSS.t1924 a_4187_1764.t130 a_4871_14024# VSS.t2358 sg13_lv_nmos ad=0.2516p pd=2.16u as=0.1406p ps=1.12u w=0.74u l=0.6u
X2620 VSS.t643 a_22243_14024# a_22677_14024# VSS.t642 sg13_lv_nmos ad=0.1406p pd=1.12u as=0.2516p ps=2.16u w=0.74u l=0.13u
X2621 a_6126_9506# a_6326_10280# VDD.t990 VDD.t355 sg13_lv_pmos ad=0.38p pd=2.38u as=0.38p ps=2.38u w=2u l=1u
X2622 VSS.t124 a_4187_1764.t22 a_12471_1842# VSS.t123 sg13_lv_nmos ad=0.2516p pd=2.16u as=0.1406p ps=1.12u w=0.74u l=0.6u
X2623 VDD.t1458 a_16923_16869# a_17357_16869# VDD.t368 sg13_lv_pmos ad=0.2128p pd=1.5u as=0.3808p ps=2.92u w=1.12u l=0.13u
X2624 a_15964_15316# CHAN0_MUX_SEL4 a_5731_15316# VDD.t90 sg13_lv_pmos ad=0.3304p pd=1.71u as=0.3808p ps=2.92u w=1.12u l=0.13u
X2625 a_19550_13226# a_3171_13229.t4 a_20968_13226# VSS.t1638 sg13_lv_nmos ad=0.2516p pd=2.16u as=0.1406p ps=1.12u w=0.74u l=0.13u
X2626 VSS.t342 a_3171_6001.t2 a_23945_6209# VSS.t771 sg13_lv_nmos ad=0.2516p pd=2.16u as=0.2516p ps=2.16u w=0.74u l=0.13u
X2627 VDD.t255 VSS.t195 VDD.t254 VDD.t90 sg13_lv_pmos ad=0.34p pd=2.68u as=0 ps=0 w=1u l=1u
X2628 a_8808_1044# a_8237_1842# VSS.t722 VSS.t1205 sg13_lv_nmos ad=0.1406p pd=1.12u as=0.2516p ps=2.16u w=0.74u l=0.13u
X2629 a_13753_4687# a_13557_4687# VSS.t1167 VSS.t1166 sg13_lv_nmos ad=0.2516p pd=2.16u as=0.1406p ps=1.12u w=0.74u l=0.13u
X2630 a_13592_11561# a_13566_11525# VSS.t159 VSS.t2352 sg13_lv_nmos ad=0.2516p pd=2.16u as=0.1626p ps=1.415u w=0.74u l=0.13u
X2631 a_5778_9057# a_6126_9506# a_6326_10280# VSS.t46 sg13_lv_nmos ad=0.68p pd=4.68u as=0.38p ps=2.38u w=2u l=1u
X2632 a_18795_6734# a_18585_6734# VDD.t799 VDD.t67 sg13_lv_pmos ad=0.2128p pd=1.5u as=0.252p ps=1.57u w=1.12u l=0.13u
X2633 a_4871_4687# a_4633_4687# a_4763_4687# VSS.t23 sg13_lv_nmos ad=0.1406p pd=1.12u as=0.2516p ps=2.16u w=0.74u l=0.2u
X2634 VSS.t715 a_22243_1842# a_22677_1842# VSS.t1634 sg13_lv_nmos ad=0.1406p pd=1.12u as=0.2516p ps=2.16u w=0.74u l=0.13u
X2635 a_6913_16869# a_6717_16869# VSS.t898 VSS.t2172 sg13_lv_nmos ad=0.2516p pd=2.16u as=0.1406p ps=1.12u w=0.74u l=0.13u
X2636 a_15270_11995# a_12849_11557# VSS.t157 VSS.t156 sg13_lv_nmos ad=37.8f pd=0.6u as=79.8f ps=0.8u w=0.42u l=0.13u
X2637 VDD.t1038 a_2595_6737.t5 a_17351_6698# VDD.t67 sg13_lv_pmos ad=0.3808p pd=2.92u as=0.3808p ps=2.92u w=1.12u l=0.13u
X2638 a_6635_16071# a_6425_16071# VDD.t1243 VDD.t90 sg13_lv_pmos ad=0.2128p pd=1.5u as=0.252p ps=1.57u w=1.12u l=0.13u
X2639 a_25630_6734# a_27124_6698# a_27048_6734# VDD.t67 sg13_lv_pmos ad=0.3808p pd=2.92u as=0.2128p ps=1.5u w=1.12u l=0.13u
X2640 a_18313_7532# a_18117_7532# VSS.t911 VSS.t910 sg13_lv_nmos ad=0.2516p pd=2.16u as=0.1406p ps=1.12u w=0.74u l=0.13u
X2641 a_9431_7532# a_9193_7532# a_9323_7532# VSS.t1785 sg13_lv_nmos ad=0.1406p pd=1.12u as=0.2516p ps=2.16u w=0.74u l=0.2u
X2642 VDD.t750 a_4187_2434# a_6391_2470# VDD.t373 sg13_lv_pmos ad=0.3808p pd=2.92u as=0.2128p ps=1.5u w=1.12u l=0.6u
X2643 a_1544_1044# CHAN3_MUX_SEL1 VDD.t1451 VDD.t2 sg13_lv_pmos ad=0.3808p pd=2.92u as=0.3808p ps=2.92u w=1.12u l=0.13u
X2644 a_7390_16071# a_3171_16074.t8 a_8808_16071# VSS.t660 sg13_lv_nmos ad=0.2516p pd=2.16u as=0.1406p ps=1.12u w=0.74u l=0.13u
X2645 VDD.t1383 a_2595_13229.t2 a_26471_13190# VDD.t5 sg13_lv_pmos ad=0.3808p pd=2.92u as=0.3808p ps=2.92u w=1.12u l=0.13u
X2646 a_13470_1044# a_15831_1008# a_15755_1044# VDD.t2 sg13_lv_pmos ad=0.3808p pd=2.92u as=0.2128p ps=1.5u w=1.12u l=0.13u
X2647 a_22488_3889# a_21917_4687# VDD.t1504 VDD.t0 sg13_lv_pmos ad=0.2128p pd=1.5u as=0.3808p ps=2.92u w=1.12u l=0.13u
X2648 a_10520_11982# a_10232_11561# a_10458_11982# VSS.t1077 sg13_lv_nmos ad=0.1428p pd=1.52u as=37.8f ps=0.6u w=0.42u l=0.13u
X2649 a_16108_3134# CHAN2_MUX_SEL4 a_15964_3134# VSS.t2228 sg13_lv_nmos ad=0.2516p pd=2.16u as=0.2183p ps=1.33u w=0.74u l=0.13u
X2650 a_4350_13226# a_3171_13229.t9 a_5768_13226# VSS.t6 sg13_lv_nmos ad=0.2516p pd=2.16u as=0.1406p ps=1.12u w=0.74u l=0.13u
X2651 VSS.t1093 a_2873_12513# a_3171_12493.t1 VSS.t1094 sg13_lv_nmos ad=0.2812p pd=2.24u as=0.1406p ps=1.12u w=0.74u l=0.13u
X2652 a_4350_6734# a_5844_6698# a_5768_6734# VDD.t67 sg13_lv_pmos ad=0.3808p pd=2.92u as=0.2128p ps=1.5u w=1.12u l=0.13u
X2653 a_4350_16071# a_2019_16074.t9 a_4248_16071# VSS.t1646 sg13_lv_nmos ad=0.2516p pd=2.16u as=0.1406p ps=1.12u w=0.74u l=0.13u
X2654 VDD.t683 a_4187_2434# a_19311_14652# VDD.t374 sg13_lv_pmos ad=0.3808p pd=2.92u as=0.2128p ps=1.5u w=1.12u l=0.6u
X2655 a_10951_5315# a_10713_4687# a_10843_4687# VDD.t348 sg13_lv_pmos ad=0.2128p pd=1.5u as=0.3808p ps=2.92u w=1.12u l=0.2u
X2656 a_19550_16071# a_19524_16035# a_19448_16071# VDD.t90 sg13_lv_pmos ad=0.3808p pd=2.92u as=0.2128p ps=1.5u w=1.12u l=0.13u
X2657 VSS.t42 a_24523_4687# a_24957_4687# VSS.t903 sg13_lv_nmos ad=0.1406p pd=1.12u as=0.2516p ps=2.16u w=0.74u l=0.13u
X2658 a_23871_7532# a_23633_7532# a_23763_7532# VSS.t1159 sg13_lv_nmos ad=0.1406p pd=1.12u as=0.2516p ps=2.16u w=0.74u l=0.2u
X2659 VDD.t762 a_4187_2434# a_20831_2470# VDD.t373 sg13_lv_pmos ad=0.3808p pd=2.92u as=0.2128p ps=1.5u w=1.12u l=0.6u
X2660 a_14513_16869# a_14317_16869# VDD.t972 VDD.t368 sg13_lv_pmos ad=0.3808p pd=2.92u as=0.2128p ps=1.5u w=1.12u l=0.13u
X2661 a_8433_7532# a_8237_7532# VSS.t1147 VSS.t1146 sg13_lv_nmos ad=0.2516p pd=2.16u as=0.1406p ps=1.12u w=0.74u l=0.13u
X2662 VDD.t1371 a_2595_1047.t2 a_26471_1008# VDD.t2 sg13_lv_pmos ad=0.3808p pd=2.92u as=0.3808p ps=2.92u w=1.12u l=0.13u
X2663 a_4350_1044# a_5191_1008# a_5115_1044# VDD.t2 sg13_lv_pmos ad=0.3808p pd=2.92u as=0.2128p ps=1.5u w=1.12u l=0.13u
X2664 VDD.t1378 a_2019_13229.t3 a_22564_13190# VDD.t5 sg13_lv_pmos ad=0.3808p pd=2.92u as=0.3808p ps=2.92u w=1.12u l=0.13u
X2665 a_23111_16869# a_22873_16869# a_23003_16869# VSS.t583 sg13_lv_nmos ad=0.1406p pd=1.12u as=0.2516p ps=2.16u w=0.74u l=0.2u
X2666 VSS.t649 a_18443_7532# a_18877_7532# VSS.t2309 sg13_lv_nmos ad=0.1406p pd=1.12u as=0.2516p ps=2.16u w=0.74u l=0.13u
X2667 VSS.t379 VDD.t1639 VSS.t379 VSS.t381 sg13_lv_nmos ad=0.1428p pd=1.52u as=0 ps=0 w=0.42u l=1u
X2668 a_9431_14024# a_9193_14024# a_9323_14024# VSS.t1947 sg13_lv_nmos ad=0.1406p pd=1.12u as=0.2516p ps=2.16u w=0.74u l=0.2u
X2669 a_5731_12471# a_2019_12493.t3 a_4350_13226# VSS.t1636 sg13_lv_nmos ad=0.2516p pd=2.16u as=0.2516p ps=2.16u w=0.74u l=0.13u
X2670 VSS.t51 a_6126_9506# a_5974_11413# VSS.t49 sg13_lv_nmos ad=0.68p pd=4.68u as=0.38p ps=2.38u w=2u l=1u
X2671 VSS.t372 VDD.t1641 VSS.t372 VSS.t377 sg13_lv_nmos ad=79.8f pd=0.8u as=0 ps=0 w=0.42u l=1u
X2672 REF_MUX_OUT a_16851_5999# VDD.t557 VDD.t67 sg13_lv_pmos ad=0.2128p pd=1.5u as=0.2086p ps=1.5u w=1.12u l=0.13u
X2673 a_1256_5979# REF_MUX_SEL2 VSS.t931 VSS.t2283 sg13_lv_nmos ad=0.2516p pd=2.16u as=0.2516p ps=2.16u w=0.74u l=0.13u
X2674 VSS.t607 a_2595_16074.t6 a_14311_16035# VSS.t1552 sg13_lv_nmos ad=0.2516p pd=2.16u as=0.2516p ps=2.16u w=0.74u l=0.13u
X2675 VSS.t319 VDD.t1663 VSS.t319 VSS.t321 sg13_lv_nmos ad=0.1428p pd=1.52u as=0 ps=0 w=0.42u l=1u
X2676 VSS.t1074 a_1256_13226# a_2967_13577# VSS.t1911 sg13_lv_nmos ad=0.1331p pd=1.12u as=0.1216p ps=1.02u w=0.64u l=0.13u
X2677 a_7390_13226# a_7364_13190# a_7288_13226# VDD.t5 sg13_lv_pmos ad=0.3808p pd=2.92u as=0.2128p ps=1.5u w=1.12u l=0.13u
X2678 a_22113_7532# a_21917_7532# VSS.t1259 VSS.t1491 sg13_lv_nmos ad=0.2516p pd=2.16u as=0.1406p ps=1.12u w=0.74u l=0.13u
X2679 VSS.t1261 a_27237_1842# a_27705_1044# VSS.t1990 sg13_lv_nmos ad=0.1665p pd=1.19u as=0.2516p ps=2.16u w=0.74u l=0.13u
X2680 VDD.t787 a_16597_1842# a_17065_1044# VDD.t2 sg13_lv_pmos ad=0.252p pd=1.57u as=0.3808p ps=2.92u w=1.12u l=0.13u
X2681 VSS.t1013 a_2595_13229.t7 a_11271_13190# VSS.t1012 sg13_lv_nmos ad=0.2516p pd=2.16u as=0.2516p ps=2.16u w=0.74u l=0.13u
X2682 a_10328_6734# a_9757_7532# VSS.t1712 VSS.t2169 sg13_lv_nmos ad=0.1406p pd=1.12u as=0.2516p ps=2.16u w=0.74u l=0.13u
X2683 VSS.t365 a_3171_3156.t3 a_11785_3364# VSS.t1058 sg13_lv_nmos ad=0.2516p pd=2.16u as=0.2516p ps=2.16u w=0.74u l=0.13u
X2684 a_2595_1047.t1 a_2297_1395# VSS.t907 VSS.t1774 sg13_lv_nmos ad=0.1406p pd=1.12u as=0.1331p ps=1.12u w=0.74u l=0.13u
X2685 VSS.t1838 a_27563_14024# a_27997_14024# VSS.t1980 sg13_lv_nmos ad=0.1406p pd=1.12u as=0.2516p ps=2.16u w=0.74u l=0.13u
X2686 a_26673_7532# a_26477_7532# VDD.t845 VDD.t346 sg13_lv_pmos ad=0.3808p pd=2.92u as=0.2128p ps=1.5u w=1.12u l=0.13u
X2687 a_10191_2470# a_9953_1842# a_10083_1842# VDD.t373 sg13_lv_pmos ad=0.2128p pd=1.5u as=0.3808p ps=2.92u w=1.12u l=0.2u
X2688 VSS.t1037 a_4187_1764.t34 a_27671_4687# VSS.t1036 sg13_lv_nmos ad=0.2516p pd=2.16u as=0.1406p ps=1.12u w=0.74u l=0.6u
X2689 VDD.t1440 CHAN0_MUX_SEL3 a_3449_15358# VDD.t90 sg13_lv_pmos ad=0.1918p pd=1.5u as=0.1596p ps=1.22u w=0.84u l=0.13u
X2690 VSS.t435 a_2019_311.t2 a_17865_519# VSS.t2200 sg13_lv_nmos ad=0.2516p pd=2.16u as=0.2516p ps=2.16u w=0.74u l=0.13u
X2691 a_22590_6734# a_2019_6737.t3 a_22488_6734# VSS.t1119 sg13_lv_nmos ad=0.2516p pd=2.16u as=0.1406p ps=1.12u w=0.74u l=0.13u
X2692 a_26151_1842# a_25913_1842# a_26043_1842# VSS.t1254 sg13_lv_nmos ad=0.1406p pd=1.12u as=0.2516p ps=2.16u w=0.74u l=0.2u
X2693 a_23633_14024# a_23437_14024# VDD.t1059 VDD.t374 sg13_lv_pmos ad=0.3808p pd=2.92u as=0.2128p ps=1.5u w=1.12u l=0.13u
X2694 VSS.t1228 a_1544_289# a_2391_331# VSS.t1227 sg13_lv_nmos ad=0.1331p pd=1.12u as=0.1216p ps=1.02u w=0.64u l=0.13u
X2695 VSS.t751 a_4187_1764.t86 a_12471_7532# VSS.t2359 sg13_lv_nmos ad=0.2516p pd=2.16u as=0.1406p ps=1.12u w=0.74u l=0.6u
X2696 a_8808_16071# a_8237_16869# VDD.t950 VDD.t90 sg13_lv_pmos ad=0.2128p pd=1.5u as=0.3808p ps=2.92u w=1.12u l=0.13u
X2697 VDD.t1087 a_16923_14024# a_17357_14024# VDD.t374 sg13_lv_pmos ad=0.2128p pd=1.5u as=0.3808p ps=2.92u w=1.12u l=0.13u
X2698 VDD.t831 a_2595_13229.t5 a_17351_13190# VDD.t5 sg13_lv_pmos ad=0.3808p pd=2.92u as=0.3808p ps=2.92u w=1.12u l=0.13u
X2699 a_6326_10280# a_6126_9506# a_5778_9057# VSS.t46 sg13_lv_nmos ad=0.42p pd=2.42u as=0.68p ps=4.68u w=2u l=1u
X2700 VDD.t715 a_4187_2434# a_19311_5315# VDD.t348 sg13_lv_pmos ad=0.3808p pd=2.92u as=0.2128p ps=1.5u w=1.12u l=0.6u
X2701 a_7911_16869# a_7673_16869# a_7803_16869# VSS.t1184 sg13_lv_nmos ad=0.1406p pd=1.12u as=0.2516p ps=2.16u w=0.74u l=0.2u
X2702 a_8808_6734# a_8237_7532# VSS.t1145 VSS.t1144 sg13_lv_nmos ad=0.1406p pd=1.12u as=0.2516p ps=2.16u w=0.74u l=0.13u
X2703 VDD.t389 a_3449_6021# a_3747_6001.t0 VDD.t67 sg13_lv_pmos ad=0.4256p pd=3u as=0.2128p ps=1.5u w=1.12u l=0.13u
X2704 VDD.t248 VSS.t216 VDD.t246 VDD.t90 sg13_lv_pmos ad=0.19p pd=1.38u as=0 ps=0 w=1u l=1u
X2705 a_18795_13226# a_18585_13226# VSS.t1406 VSS.t2074 sg13_lv_nmos ad=0.1406p pd=1.12u as=0.1665p ps=1.19u w=0.74u l=0.13u
X2706 a_13753_1842# a_13557_1842# VSS.t637 VSS.t636 sg13_lv_nmos ad=0.2516p pd=2.16u as=0.1406p ps=1.12u w=0.74u l=0.13u
X2707 a_4248_16071# a_4157_16340# VDD.t1398 VDD.t90 sg13_lv_pmos ad=0.2128p pd=1.5u as=0.3808p ps=2.92u w=1.12u l=0.13u
X2708 VDD.t1121 a_3747_13229.t7 a_12791_13190# VDD.t5 sg13_lv_pmos ad=0.3808p pd=2.92u as=0.3808p ps=2.92u w=1.12u l=0.13u
X2709 VSS.t171 a_22243_7532# a_22677_7532# VSS.t1076 sg13_lv_nmos ad=0.1406p pd=1.12u as=0.2516p ps=2.16u w=0.74u l=0.13u
X2710 a_1815_1395# a_1256_1044# a_1721_1395# VSS.t145 sg13_lv_nmos ad=0.1216p pd=1.02u as=0.2176p ps=1.96u w=0.64u l=0.13u
X2711 a_4871_1842# a_4633_1842# a_4763_1842# VSS.t1928 sg13_lv_nmos ad=0.1406p pd=1.12u as=0.2516p ps=2.16u w=0.74u l=0.2u
X2712 VSS.t1097 a_4187_1764.t157 a_8671_16869# VSS.t1096 sg13_lv_nmos ad=0.2516p pd=2.16u as=0.1406p ps=1.12u w=0.74u l=0.6u
X2713 VSS.t877 a_26043_16869# a_26477_16869# VSS.t1200 sg13_lv_nmos ad=0.1406p pd=1.12u as=0.2516p ps=2.16u w=0.74u l=0.13u
X2714 VDD.t1132 a_3171_15338.t2 a_23945_15546# VDD.t90 sg13_lv_pmos ad=0.3808p pd=2.92u as=0.3808p ps=2.92u w=1.12u l=0.13u
X2715 a_17275_16071# a_17065_16071# VSS.t1460 VSS.t1938 sg13_lv_nmos ad=0.1406p pd=1.12u as=0.1665p ps=1.19u w=0.74u l=0.13u
X2716 VSS.t22 a_2019_3892.t8 a_7364_3853# VSS.t1917 sg13_lv_nmos ad=0.2516p pd=2.16u as=0.2516p ps=2.16u w=0.74u l=0.13u
X2717 VDD.t827 a_2595_12493.t2 a_20905_12701# VDD.t5 sg13_lv_pmos ad=0.3808p pd=2.92u as=0.3808p ps=2.92u w=1.12u l=0.13u
X2718 a_14235_13226# a_14025_13226# VSS.t1969 VSS.t2080 sg13_lv_nmos ad=0.1406p pd=1.12u as=0.1665p ps=1.19u w=0.74u l=0.13u
X2719 a_2391_3176# CHAN2_MUX_SEL2 a_2297_3176# VSS.t617 sg13_lv_nmos ad=0.1216p pd=1.02u as=0.2176p ps=1.96u w=0.64u l=0.13u
X2720 a_7390_16071# a_9751_16035# a_9675_16071# VDD.t90 sg13_lv_pmos ad=0.3808p pd=2.92u as=0.2128p ps=1.5u w=1.12u l=0.13u
X2721 VDD.t697 a_4187_2434# a_6391_8160# VDD.t346 sg13_lv_pmos ad=0.3808p pd=2.92u as=0.2128p ps=1.5u w=1.12u l=0.6u
X2722 VDD.t1609 a_2595_16074.t4 a_20391_16035# VDD.t90 sg13_lv_pmos ad=0.3808p pd=2.92u as=0.3808p ps=2.92u w=1.12u l=0.13u
X2723 a_13470_3889# a_13444_3853# a_13368_3889# VDD.t0 sg13_lv_pmos ad=0.3808p pd=2.92u as=0.2128p ps=1.5u w=1.12u l=0.13u
X2724 VSS.t1320 a_7803_14024# a_8237_14024# VSS.t1319 sg13_lv_nmos ad=0.1406p pd=1.12u as=0.2516p ps=2.16u w=0.74u l=0.13u
X2725 a_2019_13229.t1 a_1721_13577# VSS.t1074 VSS.t1996 sg13_lv_nmos ad=0.1406p pd=1.12u as=0.1331p ps=1.12u w=0.74u l=0.13u
X2726 VSS.t2093 a_1544_3134# a_1815_3176# VSS.t904 sg13_lv_nmos ad=0.1331p pd=1.12u as=0.1216p ps=1.02u w=0.64u l=0.13u
X2727 VDD.t734 a_4187_2434# a_9431_5315# VDD.t348 sg13_lv_pmos ad=0.3808p pd=2.92u as=0.2128p ps=1.5u w=1.12u l=0.6u
X2728 a_20831_14024# a_20593_14024# a_20723_14024# VSS.t641 sg13_lv_nmos ad=0.1406p pd=1.12u as=0.2516p ps=2.16u w=0.74u l=0.2u
X2729 a_25528_13226# a_24957_14024# VSS.t1423 VSS.t1422 sg13_lv_nmos ad=0.1406p pd=1.12u as=0.2516p ps=2.16u w=0.74u l=0.13u
X2730 VSS.t341 VDD.t1655 VSS.t344 VSS.t343 sg13_lv_nmos ad=79.8f pd=0.8u as=0 ps=0 w=0.42u l=1u
X2731 a_15511_17497# a_15273_16869# a_15403_16869# VDD.t368 sg13_lv_pmos ad=0.2128p pd=1.5u as=0.3808p ps=2.92u w=1.12u l=0.2u
X2732 a_10040_11995# a_9772_11533# a_9946_11995# VSS.t33 sg13_lv_nmos ad=60.89999f pd=0.71u as=0.1428p ps=1.52u w=0.42u l=0.13u
X2733 a_1721_331# a_1256_289# VDD.t1493 VDD.t2 sg13_lv_pmos ad=0.1596p pd=1.22u as=0.2856p ps=2.36u w=0.84u l=0.13u
X2734 a_7673_1842# a_7477_1842# VDD.t857 VDD.t373 sg13_lv_pmos ad=0.3808p pd=2.92u as=0.2128p ps=1.5u w=1.12u l=0.13u
X2735 a_12849_11557# a_12656_11554# VSS.t159 VSS.t1181 sg13_lv_nmos ad=0.1406p pd=1.12u as=0.2516p ps=2.16u w=0.74u l=0.13u
X2736 a_15053_11110# a_14111_10917# a_14851_10872# VDD.t355 sg13_lv_pmos ad=93.45f pd=0.865u as=0.2048p ps=1.63u w=0.42u l=0.13u
X2737 VSS.t27 a_1544_16071# a_2391_16422# VSS.t1817 sg13_lv_nmos ad=0.1331p pd=1.12u as=0.1216p ps=1.02u w=0.64u l=0.13u
X2738 CHAN0_MUX_OUT a_16851_15336# VSS.t2127 VSS.t2126 sg13_lv_nmos ad=0.1406p pd=1.12u as=0.1371p ps=1.12u w=0.74u l=0.13u
X2739 a_16033_4687# a_15837_4687# VSS.t653 VSS.t652 sg13_lv_nmos ad=0.2516p pd=2.16u as=0.1406p ps=1.12u w=0.74u l=0.13u
X2740 VSS.t900 a_4187_1764.t108 a_21591_14024# VSS.t899 sg13_lv_nmos ad=0.2516p pd=2.16u as=0.1406p ps=1.12u w=0.74u l=0.6u
X2741 VDD.t447 a_6326_10280# a_6854_11144# VDD.t355 sg13_lv_pmos ad=0.38p pd=2.38u as=0.38p ps=2.38u w=2u l=1u
X2742 VDD.t70 VSS.t435 VDD.t1616 VDD.t2 sg13_lv_pmos ad=0.34p pd=2.68u as=0 ps=0 w=1u l=1u
X2743 a_7151_4687# a_6913_4687# a_7043_4687# VSS.t1088 sg13_lv_nmos ad=0.1406p pd=1.12u as=0.2516p ps=2.16u w=0.74u l=0.2u
X2744 VDD.t741 a_4187_2434# a_23111_5315# VDD.t348 sg13_lv_pmos ad=0.3808p pd=2.92u as=0.2128p ps=1.5u w=1.12u l=0.6u
X2745 VDD.t611 a_4187_2434# a_16271_17497# VDD.t368 sg13_lv_pmos ad=0.3808p pd=2.92u as=0.2128p ps=1.5u w=1.12u l=0.6u
X2746 a_6635_1044# a_6425_1044# VSS.t1954 VSS.t2293 sg13_lv_nmos ad=0.1406p pd=1.12u as=0.1665p ps=1.19u w=0.74u l=0.13u
X2747 VDD.t1204 a_3171_3892.t3 a_24084_3853# VDD.t0 sg13_lv_pmos ad=0.3808p pd=2.92u as=0.3808p ps=2.92u w=1.12u l=0.13u
X2748 VDD.t817 a_2595_15338.t3 a_8745_15546# VDD.t90 sg13_lv_pmos ad=0.3808p pd=2.92u as=0.3808p ps=2.92u w=1.12u l=0.13u
X2749 VDD.t708 a_4187_2434# a_20831_8160# VDD.t346 sg13_lv_pmos ad=0.3808p pd=2.92u as=0.2128p ps=1.5u w=1.12u l=0.6u
X2750 VSS.t793 a_24523_1842# a_24957_1842# VSS.t1252 sg13_lv_nmos ad=0.1406p pd=1.12u as=0.2516p ps=2.16u w=0.74u l=0.13u
X2751 VDD.t320 VSS.t284 VDD.t136 VDD.t5 sg13_lv_pmos ad=0.19p pd=1.38u as=0 ps=0 w=1u l=1u
X2752 a_14513_14024# a_14317_14024# VDD.t375 VDD.t374 sg13_lv_pmos ad=0.3808p pd=2.92u as=0.2128p ps=1.5u w=1.12u l=0.13u
X2753 VDD.t1173 a_2019_12493.t3 a_5705_12701# VDD.t5 sg13_lv_pmos ad=0.3808p pd=2.92u as=0.3808p ps=2.92u w=1.12u l=0.13u
X2754 VSS.t733 a_2595_1047.t9 a_5191_1008# VSS.t2012 sg13_lv_nmos ad=0.2516p pd=2.16u as=0.2516p ps=2.16u w=0.74u l=0.13u
X2755 a_16108_3134# a_3747_3156.t2 a_25630_3889# VSS.t1242 sg13_lv_nmos ad=0.2516p pd=2.16u as=0.2516p ps=2.16u w=0.74u l=0.13u
X2756 VDD.t219 VSS.t319 VDD.t218 VDD.t67 sg13_lv_pmos ad=0.34p pd=2.68u as=0 ps=0 w=1u l=1u
X2757 a_27915_16071# a_27705_16071# VDD.t1360 VDD.t90 sg13_lv_pmos ad=0.2128p pd=1.5u as=0.252p ps=1.57u w=1.12u l=0.13u
X2758 a_10589_11604# a_10232_11561# VDD.t867 VDD.t355 sg13_lv_pmos ad=63f pd=0.72u as=0.1563p ps=1.22u w=0.42u l=0.13u
X2759 a_20315_1044# a_20105_1044# VSS.t83 VSS.t2233 sg13_lv_nmos ad=0.1406p pd=1.12u as=0.1665p ps=1.19u w=0.74u l=0.13u
X2760 a_22488_3889# a_21917_4687# VSS.t1681 VSS.t2221 sg13_lv_nmos ad=0.1406p pd=1.12u as=0.2516p ps=2.16u w=0.74u l=0.13u
X2761 a_27048_13226# a_26477_14024# VDD.t1348 VDD.t5 sg13_lv_pmos ad=0.2128p pd=1.5u as=0.3808p ps=2.92u w=1.12u l=0.13u
X2762 a_25528_1044# a_24957_1842# VSS.t975 VSS.t1482 sg13_lv_nmos ad=0.1406p pd=1.12u as=0.2516p ps=2.16u w=0.74u l=0.13u
X2763 a_18795_1044# a_18585_1044# VDD.t934 VDD.t2 sg13_lv_pmos ad=0.2128p pd=1.5u as=0.252p ps=1.57u w=1.12u l=0.13u
X2764 VDD.t458 VDD.t455 VDD.t457 VDD.t456 sg13_lv_pmos ad=0.3808p pd=2.92u as=0 ps=0 w=1.12u l=0.13u
X2765 VSS.t1359 a_27237_7532# a_27705_6734# VSS.t1358 sg13_lv_nmos ad=0.1665p pd=1.19u as=0.2516p ps=2.16u w=0.74u l=0.13u
X2766 VDD.t431 VDD.t429 VDD.t428 VDD.t368 sg13_lv_pmos ad=0.2128p pd=1.5u as=0 ps=0 w=1.12u l=0.2u
X2767 a_23355_16071# a_23145_16071# VDD.t1387 VDD.t90 sg13_lv_pmos ad=0.2128p pd=1.5u as=0.252p ps=1.57u w=1.12u l=0.13u
X2768 VSS.t806 a_4187_1764.t98 VSS.t808 VSS.t807 sg13_lv_nmos ad=1.33p pd=7.38u as=0 ps=0 w=7u l=7u
X2769 a_2595_6737.t1 a_2297_7085# VSS.t864 VSS.t863 sg13_lv_nmos ad=0.1406p pd=1.12u as=0.1331p ps=1.12u w=0.74u l=0.13u
X2770 VDD.t622 a_4187_2434# a_11711_2470# VDD.t373 sg13_lv_pmos ad=0.3808p pd=2.92u as=0.2128p ps=1.5u w=1.12u l=0.6u
X2771 a_16108_5979# a_20905_6209# a_19550_6734# VDD.t67 sg13_lv_pmos ad=0.3808p pd=2.92u as=0.3808p ps=2.92u w=1.12u l=0.13u
X2772 VSS.t312 VDD.t1667 VSS.t312 VSS.t311 sg13_lv_nmos ad=0.1428p pd=1.52u as=0 ps=0 w=0.42u l=1u
X2773 a_10191_8160# a_9953_7532# a_10083_7532# VDD.t346 sg13_lv_pmos ad=0.2128p pd=1.5u as=0.3808p ps=2.92u w=1.12u l=0.2u
X2774 VDD.t572 a_2595_1047.t5 a_17351_1008# VDD.t2 sg13_lv_pmos ad=0.3808p pd=2.92u as=0.3808p ps=2.92u w=1.12u l=0.13u
X2775 a_25630_1044# a_27124_1008# a_27048_1044# VDD.t2 sg13_lv_pmos ad=0.3808p pd=2.92u as=0.2128p ps=1.5u w=1.12u l=0.13u
X2776 VDD.t1526 a_2019_6737.t8 a_7364_6698# VDD.t67 sg13_lv_pmos ad=0.3808p pd=2.92u as=0.3808p ps=2.92u w=1.12u l=0.13u
X2777 a_5731_289# a_3747_311.t3 a_13470_1044# VSS.t2196 sg13_lv_nmos ad=0.2516p pd=2.16u as=0.2516p ps=2.16u w=0.74u l=0.13u
X2778 a_5393_14024# a_5197_14024# VSS.t1924 VSS.t1923 sg13_lv_nmos ad=0.2516p pd=2.16u as=0.1406p ps=1.12u w=0.74u l=0.13u
X2779 VSS.t1195 a_4187_1764.t2 a_27671_1842# VSS.t1194 sg13_lv_nmos ad=0.2516p pd=2.16u as=0.1406p ps=1.12u w=0.74u l=0.6u
X2780 VDD.t879 a_18443_16869# a_18877_16869# VDD.t368 sg13_lv_pmos ad=0.2128p pd=1.5u as=0.3808p ps=2.92u w=1.12u l=0.13u
X2781 VDD.t567 CHAN1_MUX_SEL3 a_3449_12513# VDD.t5 sg13_lv_pmos ad=0.1918p pd=1.5u as=0.1596p ps=1.22u w=0.84u l=0.13u
X2782 a_26151_7532# a_25913_7532# a_26043_7532# VSS.t2166 sg13_lv_nmos ad=0.1406p pd=1.12u as=0.2516p ps=2.16u w=0.74u l=0.2u
X2783 VSS.t358 VDD.t1647 VSS.t358 VSS.t363 sg13_lv_nmos ad=79.8f pd=0.8u as=0 ps=0 w=0.42u l=1u
X2784 a_22590_13226# a_2019_13229.t3 a_22488_13226# VSS.t2025 sg13_lv_nmos ad=0.2516p pd=2.16u as=0.1406p ps=1.12u w=0.74u l=0.13u
X2785 VDD.t1011 a_21483_1842# a_21917_1842# VDD.t373 sg13_lv_pmos ad=0.2128p pd=1.5u as=0.3808p ps=2.92u w=1.12u l=0.13u
X2786 a_16408_13226# a_15837_14024# VSS.t883 VSS.t882 sg13_lv_nmos ad=0.1406p pd=1.12u as=0.2516p ps=2.16u w=0.74u l=0.13u
X2787 a_19550_16071# a_3171_16074.t4 a_20968_16071# VSS.t665 sg13_lv_nmos ad=0.2516p pd=2.16u as=0.1406p ps=1.12u w=0.74u l=0.13u
X2788 a_4350_1044# a_5844_1008# a_5768_1044# VDD.t2 sg13_lv_pmos ad=0.3808p pd=2.92u as=0.2128p ps=1.5u w=1.12u l=0.13u
X2789 a_16108_12471# a_3747_12493.t2 a_25630_13226# VSS.t3 sg13_lv_nmos ad=0.2516p pd=2.16u as=0.2516p ps=2.16u w=0.74u l=0.13u
X2790 a_13753_7532# a_13557_7532# VSS.t1588 VSS.t2350 sg13_lv_nmos ad=0.2516p pd=2.16u as=0.1406p ps=1.12u w=0.74u l=0.13u
X2791 VSS.t365 VDD.t1646 VSS.t365 VSS.t366 sg13_lv_nmos ad=79.8f pd=0.8u as=0 ps=0 w=0.42u l=1u
X2792 VSS.t925 a_3449_3176# a_3747_3156.t1 VSS.t2077 sg13_lv_nmos ad=0.2812p pd=2.24u as=0.1406p ps=1.12u w=0.74u l=0.13u
X2793 VSS.t919 a_5523_4687# a_5957_4687# VSS.t918 sg13_lv_nmos ad=0.1406p pd=1.12u as=0.2516p ps=2.16u w=0.74u l=0.13u
X2794 a_4871_7532# a_4633_7532# a_4763_7532# VSS.t1084 sg13_lv_nmos ad=0.1406p pd=1.12u as=0.2516p ps=2.16u w=0.74u l=0.2u
X2795 a_1815_7085# a_1256_6734# a_1721_7085# VSS.t1572 sg13_lv_nmos ad=0.1216p pd=1.02u as=0.2176p ps=1.96u w=0.64u l=0.13u
X2796 VDD.t779 a_18117_4687# a_18585_3889# VDD.t0 sg13_lv_pmos ad=0.252p pd=1.57u as=0.3808p ps=2.92u w=1.12u l=0.13u
X2797 VSS.t263 VDD.t1681 VSS.t262 VSS.t261 sg13_lv_nmos ad=0.1428p pd=1.52u as=0 ps=0 w=0.42u l=1u
X2798 VDD.t128 VSS.t344 VDD.t127 VDD.t67 sg13_lv_pmos ad=0.19p pd=1.38u as=0 ps=0 w=1u l=1u
X2799 a_22590_13226# a_24084_13190# a_24008_13226# VDD.t5 sg13_lv_pmos ad=0.3808p pd=2.92u as=0.2128p ps=1.5u w=1.12u l=0.13u
X2800 VSS.t209 VDD.t1696 VSS.t209 VSS.t211 sg13_lv_nmos ad=0.1428p pd=1.52u as=0 ps=0 w=0.42u l=1u
X2801 a_16510_13226# a_2595_13229.t5 a_17275_13226# VSS.t1005 sg13_lv_nmos ad=0.2516p pd=2.16u as=0.1406p ps=1.12u w=0.74u l=0.13u
X2802 a_6326_10280# a_6126_9506# a_5778_9057# VSS.t46 sg13_lv_nmos ad=0.38p pd=2.38u as=0.68p ps=4.68u w=2u l=1u
X2803 VSS.t854 a_16851_309# CHAN3_MUX_OUT VSS.t1605 sg13_lv_nmos ad=0.2516p pd=2.16u as=0.1406p ps=1.12u w=0.74u l=0.13u
X2804 a_2873_6021# REF_MUX_SEL3 VDD.t810 VDD.t67 sg13_lv_pmos ad=0.1596p pd=1.22u as=0.2856p ps=2.36u w=0.84u l=0.13u
X2805 a_22488_6734# a_21917_7532# VDD.t1093 VDD.t67 sg13_lv_pmos ad=0.2128p pd=1.5u as=0.3808p ps=2.92u w=1.12u l=0.13u
X2806 VDD.t942 a_1544_289# a_1721_331# VDD.t2 sg13_lv_pmos ad=0.1918p pd=1.5u as=0.1596p ps=1.22u w=0.84u l=0.13u
X2807 VSS.t399 a_2019_311.t3 a_5705_519# VSS.t1141 sg13_lv_nmos ad=0.2516p pd=2.16u as=0.2516p ps=2.16u w=0.74u l=0.13u
X2808 a_4350_16071# a_3171_16074.t9 a_5768_16071# VSS.t1747 sg13_lv_nmos ad=0.2516p pd=2.16u as=0.1406p ps=1.12u w=0.74u l=0.13u
X2809 a_15511_14652# a_15273_14024# a_15403_14024# VDD.t374 sg13_lv_pmos ad=0.2128p pd=1.5u as=0.3808p ps=2.92u w=1.12u l=0.2u
X2810 a_7673_7532# a_7477_7532# VDD.t784 VDD.t346 sg13_lv_pmos ad=0.3808p pd=2.92u as=0.2128p ps=1.5u w=1.12u l=0.13u
X2811 VSS.t114 a_4187_1764.t59 a_8671_4687# VSS.t113 sg13_lv_nmos ad=0.2516p pd=2.16u as=0.1406p ps=1.12u w=0.74u l=0.6u
X2812 a_16033_1842# a_15837_1842# VSS.t645 VSS.t2251 sg13_lv_nmos ad=0.2516p pd=2.16u as=0.1406p ps=1.12u w=0.74u l=0.13u
X2813 VDD.t561 a_11603_4687# a_12037_4687# VDD.t348 sg13_lv_pmos ad=0.2128p pd=1.5u as=0.3808p ps=2.92u w=1.12u l=0.13u
X2814 VSS.t118 a_24523_7532# a_24957_7532# VSS.t134 sg13_lv_nmos ad=0.1406p pd=1.12u as=0.2516p ps=2.16u w=0.74u l=0.13u
X2815 a_6635_6734# a_6425_6734# VSS.t88 VSS.t2298 sg13_lv_nmos ad=0.1406p pd=1.12u as=0.1665p ps=1.19u w=0.74u l=0.13u
X2816 a_7151_1842# a_6913_1842# a_7043_1842# VSS.t1944 sg13_lv_nmos ad=0.1406p pd=1.12u as=0.2516p ps=2.16u w=0.74u l=0.2u
X2817 VDD.t679 a_4187_2434# a_16271_14652# VDD.t374 sg13_lv_pmos ad=0.3808p pd=2.92u as=0.2128p ps=1.5u w=1.12u l=0.6u
X2818 a_9746_11495# a_9547_11632# VSS.t96 VSS.t1603 sg13_lv_nmos ad=0.27427p pd=2.28u as=2.39977p ps=15.495u w=0.795u l=0.13u
X2819 a_24631_16869# a_24393_16869# a_24523_16869# VSS.t2241 sg13_lv_nmos ad=0.1406p pd=1.12u as=0.2516p ps=2.16u w=0.74u l=0.2u
X2820 VSS.t45 a_2595_6737.t9 a_5191_6698# VSS.t1115 sg13_lv_nmos ad=0.2516p pd=2.16u as=0.2516p ps=2.16u w=0.74u l=0.13u
X2821 VDD.t35 VSS.t365 VDD.t34 VDD.t0 sg13_lv_pmos ad=0.34p pd=2.68u as=0 ps=0 w=1u l=1u
X2822 a_13470_3889# a_2019_3892.t6 a_13368_3889# VSS.t2020 sg13_lv_nmos ad=0.2516p pd=2.16u as=0.1406p ps=1.12u w=0.74u l=0.13u
X2823 a_24393_4687# a_24197_4687# VDD.t1027 VDD.t348 sg13_lv_pmos ad=0.3808p pd=2.92u as=0.2128p ps=1.5u w=1.12u l=0.13u
X2824 a_11473_16869# a_11277_16869# VDD.t920 VDD.t368 sg13_lv_pmos ad=0.3808p pd=2.92u as=0.2128p ps=1.5u w=1.12u l=0.13u
X2825 VSS.t593 a_10083_14024# a_10517_14024# VSS.t747 sg13_lv_nmos ad=0.1406p pd=1.12u as=0.2516p ps=2.16u w=0.74u l=0.13u
X2826 a_20315_6734# a_20105_6734# VSS.t1018 VSS.t1017 sg13_lv_nmos ad=0.1406p pd=1.12u as=0.1665p ps=1.19u w=0.74u l=0.13u
X2827 a_20071_16869# a_19833_16869# a_19963_16869# VSS.t740 sg13_lv_nmos ad=0.1406p pd=1.12u as=0.2516p ps=2.16u w=0.74u l=0.2u
X2828 VSS.t2186 a_4187_1764.t135 a_25391_16869# VSS.t2185 sg13_lv_nmos ad=0.2516p pd=2.16u as=0.1406p ps=1.12u w=0.74u l=0.6u
X2829 a_7390_13226# a_8884_13190# a_8808_13226# VDD.t5 sg13_lv_pmos ad=0.3808p pd=2.92u as=0.2128p ps=1.5u w=1.12u l=0.13u
X2830 a_25528_6734# a_24957_7532# VSS.t1792 VSS.t2291 sg13_lv_nmos ad=0.1406p pd=1.12u as=0.2516p ps=2.16u w=0.74u l=0.13u
X2831 CHAN3_MUX_OUT a_16851_309# VDD.t777 VDD.t2 sg13_lv_pmos ad=0.2128p pd=1.5u as=0.2086p ps=1.5u w=1.12u l=0.13u
X2832 VSS.t1244 a_3747_3156.t2 a_26985_3364# VSS.t1243 sg13_lv_nmos ad=0.2516p pd=2.16u as=0.2516p ps=2.16u w=0.74u l=0.13u
X2833 VDD.t162 VSS.t312 VDD.t161 VDD.t67 sg13_lv_pmos ad=0.34p pd=2.68u as=0 ps=0 w=1u l=1u
X2834 a_6126_9506# a_6326_10280# VDD.t984 VDD.t355 sg13_lv_pmos ad=0.38p pd=2.38u as=0.38p ps=2.38u w=2u l=1u
X2835 VSS.t1754 a_1256_16071# a_2967_16422# VSS.t1753 sg13_lv_nmos ad=0.1331p pd=1.12u as=0.1216p ps=1.02u w=0.64u l=0.13u
X2836 a_6391_14024# a_6153_14024# a_6283_14024# VSS.t1942 sg13_lv_nmos ad=0.1406p pd=1.12u as=0.2516p ps=2.16u w=0.74u l=0.2u
X2837 VSS.t664 a_2595_16074.t7 a_11271_16035# VSS.t2367 sg13_lv_nmos ad=0.2516p pd=2.16u as=0.2516p ps=2.16u w=0.74u l=0.13u
X2838 a_25391_2470# a_25153_1842# a_25283_1842# VDD.t373 sg13_lv_pmos ad=0.2128p pd=1.5u as=0.3808p ps=2.92u w=1.12u l=0.2u
X2839 VDD.t1203 a_3171_3892.t6 a_14964_3853# VDD.t0 sg13_lv_pmos ad=0.3808p pd=2.92u as=0.3808p ps=2.92u w=1.12u l=0.13u
X2840 a_5731_5979# a_2019_6001.t3 a_4350_6734# VSS.t1889 sg13_lv_nmos ad=0.2516p pd=2.16u as=0.2516p ps=2.16u w=0.74u l=0.13u
X2841 VDD.t439 VDD.t441 VDD.t442 VDD.t374 sg13_lv_pmos ad=0.2128p pd=1.5u as=0 ps=0 w=1.12u l=0.2u
X2842 VSS.t14 VDD.t1679 VSS.t270 VSS.t269 sg13_lv_nmos ad=0.1428p pd=1.52u as=0 ps=0 w=0.42u l=1u
X2843 VDD.t702 a_4187_2434# a_11711_8160# VDD.t346 sg13_lv_pmos ad=0.3808p pd=2.92u as=0.2128p ps=1.5u w=1.12u l=0.6u
X2844 VDD.t60 VSS.t411 VDD.t59 VDD.t2 sg13_lv_pmos ad=0.34p pd=2.68u as=0 ps=0 w=1u l=1u
X2845 a_16108_3134# a_20905_3364# a_19550_3889# VDD.t0 sg13_lv_pmos ad=0.3808p pd=2.92u as=0.3808p ps=2.92u w=1.12u l=0.13u
X2846 a_2595_3892.t1 a_2297_4240# VSS.t742 VSS.t1795 sg13_lv_nmos ad=0.1406p pd=1.12u as=0.1331p ps=1.12u w=0.74u l=0.13u
X2847 VSS.t229 VDD.t1689 VSS.t229 VSS.t232 sg13_lv_nmos ad=79.8f pd=0.8u as=0 ps=0 w=0.42u l=1u
X2848 a_4350_13226# a_4324_13190# a_4248_13226# VDD.t5 sg13_lv_pmos ad=0.3808p pd=2.92u as=0.2128p ps=1.5u w=1.12u l=0.13u
X2849 VSS.t968 a_3171_3892.t3 a_24084_3853# VSS.t1739 sg13_lv_nmos ad=0.2516p pd=2.16u as=0.2516p ps=2.16u w=0.74u l=0.13u
X2850 a_25630_16071# a_26471_16035# a_26395_16071# VDD.t90 sg13_lv_pmos ad=0.3808p pd=2.92u as=0.2128p ps=1.5u w=1.12u l=0.13u
X2851 VSS.t1696 a_4187_1764.t127 a_7151_14024# VSS.t1695 sg13_lv_nmos ad=0.2516p pd=2.16u as=0.1406p ps=1.12u w=0.74u l=0.6u
X2852 CHAN1_MUX_OUT a_16851_12491# VDD.t807 VDD.t5 sg13_lv_pmos ad=0.2128p pd=1.5u as=0.2086p ps=1.5u w=1.12u l=0.13u
X2853 VSS.t828 a_4187_1764.t98 VSS.t826 VSS.t811 sg13_lv_nmos ad=1.33p pd=7.38u as=0 ps=0 w=7u l=7u
X2854 VDD.t737 a_4187_2434# a_14751_5315# VDD.t348 sg13_lv_pmos ad=0.3808p pd=2.92u as=0.2128p ps=1.5u w=1.12u l=0.6u
X2855 VSS.t1002 a_24523_14024# a_24957_14024# VSS.t1302 sg13_lv_nmos ad=0.1406p pd=1.12u as=0.2516p ps=2.16u w=0.74u l=0.13u
X2856 VSS.t86 a_2019_3156.t3 a_5705_3364# VSS.t85 sg13_lv_nmos ad=0.2516p pd=2.16u as=0.2516p ps=2.16u w=0.74u l=0.13u
X2857 VSS.t1126 a_4187_1764.t66 a_27671_7532# VSS.t1125 sg13_lv_nmos ad=0.2516p pd=2.16u as=0.1406p ps=1.12u w=0.74u l=0.6u
X2858 a_12993_1842# a_12797_1842# VDD.t795 VDD.t373 sg13_lv_pmos ad=0.3808p pd=2.92u as=0.2128p ps=1.5u w=1.12u l=0.13u
X2859 VDD.t1054 a_18443_14024# a_18877_14024# VDD.t374 sg13_lv_pmos ad=0.2128p pd=1.5u as=0.3808p ps=2.92u w=1.12u l=0.13u
X2860 a_16408_1044# a_15837_1842# VSS.t2004 VSS.t2250 sg13_lv_nmos ad=0.1406p pd=1.12u as=0.2516p ps=2.16u w=0.74u l=0.13u
X2861 VDD.t960 a_21483_7532# a_21917_7532# VDD.t346 sg13_lv_pmos ad=0.2128p pd=1.5u as=0.3808p ps=2.92u w=1.12u l=0.13u
X2862 VDD.t1386 a_7477_16869# a_7945_16071# VDD.t90 sg13_lv_pmos ad=0.252p pd=1.57u as=0.3808p ps=2.92u w=1.12u l=0.13u
X2863 VSS.t86 VDD.t1651 VSS.t86 VSS.t354 sg13_lv_nmos ad=79.8f pd=0.8u as=0 ps=0 w=0.42u l=1u
X2864 a_12471_4687# a_12233_4687# a_12363_4687# VSS.t172 sg13_lv_nmos ad=0.1406p pd=1.12u as=0.2516p ps=2.16u w=0.74u l=0.2u
X2865 a_5768_16071# a_5197_16869# VDD.t849 VDD.t90 sg13_lv_pmos ad=0.2128p pd=1.5u as=0.3808p ps=2.92u w=1.12u l=0.13u
X2866 VDD.t1181 a_2595_13229.t6 a_14311_13190# VDD.t5 sg13_lv_pmos ad=0.3808p pd=2.92u as=0.3808p ps=2.92u w=1.12u l=0.13u
X2867 a_11195_3889# a_10985_3889# VDD.t410 VDD.t0 sg13_lv_pmos ad=0.2128p pd=1.5u as=0.252p ps=1.57u w=1.12u l=0.13u
X2868 a_5731_5979# a_11785_6209# a_10430_6734# VDD.t67 sg13_lv_pmos ad=0.3808p pd=2.92u as=0.3808p ps=2.92u w=1.12u l=0.13u
X2869 a_4871_16869# a_4633_16869# a_4763_16869# VSS.t1499 sg13_lv_nmos ad=0.1406p pd=1.12u as=0.2516p ps=2.16u w=0.74u l=0.2u
X2870 VDD.t628 a_4187_2434# a_4111_5315# VDD.t348 sg13_lv_pmos ad=0.3808p pd=2.92u as=0.2128p ps=1.5u w=1.12u l=0.6u
X2871 a_9193_16869# a_8997_16869# VSS.t1097 VSS.t1842 sg13_lv_nmos ad=0.2516p pd=2.16u as=0.1406p ps=1.12u w=0.74u l=0.13u
X2872 a_18795_16071# a_18585_16071# VSS.t1295 VSS.t1927 sg13_lv_nmos ad=0.1406p pd=1.12u as=0.1665p ps=1.19u w=0.74u l=0.13u
X2873 VSS.t1108 a_5523_1842# a_5957_1842# VSS.t1898 sg13_lv_nmos ad=0.1406p pd=1.12u as=0.2516p ps=2.16u w=0.74u l=0.13u
X2874 a_13566_11525# a_14009_11568# a_13949_11604# VDD.t355 sg13_lv_pmos ad=79.8f pd=0.8u as=63f ps=0.72u w=0.42u l=0.13u
X2875 a_15755_13226# a_15545_13226# VSS.t841 VSS.t2079 sg13_lv_nmos ad=0.1406p pd=1.12u as=0.1665p ps=1.19u w=0.74u l=0.13u
X2876 a_1815_4240# a_1256_3889# a_1721_4240# VSS.t587 sg13_lv_nmos ad=0.1216p pd=1.02u as=0.2176p ps=1.96u w=0.64u l=0.13u
X2877 a_5731_289# a_2019_311.t3 a_4350_1044# VSS.t1140 sg13_lv_nmos ad=0.2516p pd=2.16u as=0.2516p ps=2.16u w=0.74u l=0.13u
X2878 VDD.t754 a_4187_2434# a_13991_2470# VDD.t373 sg13_lv_pmos ad=0.3808p pd=2.92u as=0.2128p ps=1.5u w=1.12u l=0.6u
X2879 VSS.t1798 a_4187_1764.t161 a_5631_16869# VSS.t2160 sg13_lv_nmos ad=0.2516p pd=2.16u as=0.1406p ps=1.12u w=0.74u l=0.6u
X2880 VDD.t818 a_2595_15338.t2 a_20905_15546# VDD.t90 sg13_lv_pmos ad=0.3808p pd=2.92u as=0.3808p ps=2.92u w=1.12u l=0.13u
X2881 VSS.t163 a_14851_10872# a_15688_11093# VSS.t1176 sg13_lv_nmos ad=0.1406p pd=1.12u as=0.2516p ps=2.16u w=0.74u l=0.13u
X2882 VSS.t580 a_23003_16869# a_23437_16869# VSS.t2319 sg13_lv_nmos ad=0.1406p pd=1.12u as=0.2516p ps=2.16u w=0.74u l=0.13u
X2883 a_14235_16071# a_14025_16071# VSS.t1376 VSS.t1950 sg13_lv_nmos ad=0.1406p pd=1.12u as=0.1665p ps=1.19u w=0.74u l=0.13u
X2884 VSS.t1518 a_9323_14024# a_9757_14024# VSS.t1580 sg13_lv_nmos ad=0.1406p pd=1.12u as=0.2516p ps=2.16u w=0.74u l=0.13u
X2885 VDD.t45 VSS.t390 VDD.t44 VDD.t0 sg13_lv_pmos ad=0.19p pd=1.38u as=0 ps=0 w=1u l=1u
X2886 a_2391_6021# REF_MUX_SEL2 a_2297_6021# VSS.t2284 sg13_lv_nmos ad=0.1216p pd=1.02u as=0.2176p ps=1.96u w=0.64u l=0.13u
X2887 VSS.t301 VDD.t1672 VSS.t299 VSS.t300 sg13_lv_nmos ad=79.8f pd=0.8u as=0 ps=0 w=0.42u l=1u
X2888 VDD.t1074 a_3449_7085# a_3747_6737.t0 VDD.t67 sg13_lv_pmos ad=0.4256p pd=3u as=0.2128p ps=1.5u w=1.12u l=0.13u
X2889 a_13470_6734# a_13444_6698# a_13368_6734# VDD.t67 sg13_lv_pmos ad=0.3808p pd=2.92u as=0.2128p ps=1.5u w=1.12u l=0.13u
X2890 a_17031_17497# a_16793_16869# a_16923_16869# VDD.t368 sg13_lv_pmos ad=0.2128p pd=1.5u as=0.3808p ps=2.92u w=1.12u l=0.2u
X2891 a_2019_16074.t1 a_1721_16422# VSS.t27 VSS.t1998 sg13_lv_nmos ad=0.1406p pd=1.12u as=0.1331p ps=1.12u w=0.74u l=0.13u
X2892 a_10458_11982# DLL_RESETN VSS.t632 VSS.t2217 sg13_lv_nmos ad=37.8f pd=0.6u as=0.1701p ps=1.65u w=0.42u l=0.13u
X2893 a_7390_1044# a_3747_1047.t8 a_9675_1044# VSS.t1854 sg13_lv_nmos ad=0.2516p pd=2.16u as=0.1406p ps=1.12u w=0.74u l=0.13u
X2894 VSS.t1142 a_1544_5979# a_1815_6021# VSS.t743 sg13_lv_nmos ad=0.1331p pd=1.12u as=0.1216p ps=1.02u w=0.64u l=0.13u
X2895 a_4350_16071# a_6711_16035# a_6635_16071# VDD.t90 sg13_lv_pmos ad=0.3808p pd=2.92u as=0.2128p ps=1.5u w=1.12u l=0.13u
X2896 VDD.t979 a_23763_1842# a_24197_1842# VDD.t373 sg13_lv_pmos ad=0.2128p pd=1.5u as=0.3808p ps=2.92u w=1.12u l=0.13u
X2897 a_25528_16071# a_24957_16869# VSS.t482 VSS.t1056 sg13_lv_nmos ad=0.1406p pd=1.12u as=0.2516p ps=2.16u w=0.74u l=0.13u
X2898 a_1256_15316# CHAN0_MUX_SEL2 VSS.t759 VSS.t758 sg13_lv_nmos ad=0.2516p pd=2.16u as=0.2516p ps=2.16u w=0.74u l=0.13u
X2899 a_22113_14024# a_21917_14024# VSS.t900 VSS.t1415 sg13_lv_nmos ad=0.2516p pd=2.16u as=0.1406p ps=1.12u w=0.74u l=0.13u
X2900 VSS.t858 a_18117_4687# a_18585_3889# VSS.t857 sg13_lv_nmos ad=0.1665p pd=1.19u as=0.2516p ps=2.16u w=0.74u l=0.13u
X2901 a_12471_17497# a_12233_16869# a_12363_16869# VDD.t368 sg13_lv_pmos ad=0.2128p pd=1.5u as=0.3808p ps=2.92u w=1.12u l=0.2u
X2902 VDD.t654 a_4187_2434# a_17791_17497# VDD.t368 sg13_lv_pmos ad=0.3808p pd=2.92u as=0.2128p ps=1.5u w=1.12u l=0.6u
X2903 a_16033_7532# a_15837_7532# VSS.t1034 VSS.t1033 sg13_lv_nmos ad=0.2516p pd=2.16u as=0.1406p ps=1.12u w=0.74u l=0.13u
X2904 VDD.t385 a_2019_1047.t8 a_7364_1008# VDD.t2 sg13_lv_pmos ad=0.3808p pd=2.92u as=0.3808p ps=2.92u w=1.12u l=0.13u
X2905 VSS.t1476 a_4187_1764.t27 a_8671_1842# VSS.t1475 sg13_lv_nmos ad=0.2516p pd=2.16u as=0.1406p ps=1.12u w=0.74u l=0.6u
X2906 a_17275_13226# a_17065_13226# VDD.t772 VDD.t5 sg13_lv_pmos ad=0.2128p pd=1.5u as=0.252p ps=1.57u w=1.12u l=0.13u
X2907 a_7151_7532# a_6913_7532# a_7043_7532# VSS.t688 sg13_lv_nmos ad=0.1406p pd=1.12u as=0.2516p ps=2.16u w=0.74u l=0.2u
X2908 VDD.t1288 a_3171_6737.t3 a_24084_6698# VDD.t67 sg13_lv_pmos ad=0.3808p pd=2.92u as=0.3808p ps=2.92u w=1.12u l=0.13u
X2909 a_3449_7085# REF_MUX_SEL0 VDD.t1468 VDD.t67 sg13_lv_pmos ad=0.1596p pd=1.22u as=0.2856p ps=2.36u w=0.84u l=0.13u
X2910 VDD.t651 a_4187_2434# a_13231_17497# VDD.t368 sg13_lv_pmos ad=0.3808p pd=2.92u as=0.2128p ps=1.5u w=1.12u l=0.6u
X2911 a_9953_4687# a_9757_4687# VSS.t59 VSS.t58 sg13_lv_nmos ad=0.2516p pd=2.16u as=0.1406p ps=1.12u w=0.74u l=0.13u
X2912 VDD.t1529 a_2019_15338.t3 a_5705_15546# VDD.t90 sg13_lv_pmos ad=0.3808p pd=2.92u as=0.3808p ps=2.92u w=1.12u l=0.13u
X2913 VSS.t484 a_10843_4687# a_11277_4687# VSS.t1824 sg13_lv_nmos ad=0.1406p pd=1.12u as=0.2516p ps=2.16u w=0.74u l=0.13u
X2914 a_11473_14024# a_11277_14024# VDD.t1336 VDD.t374 sg13_lv_pmos ad=0.3808p pd=2.92u as=0.2128p ps=1.5u w=1.12u l=0.13u
X2915 a_22590_3889# a_23431_3853# a_23355_3889# VDD.t0 sg13_lv_pmos ad=0.3808p pd=2.92u as=0.2128p ps=1.5u w=1.12u l=0.13u
X2916 a_17031_5315# a_16793_4687# a_16923_4687# VDD.t348 sg13_lv_pmos ad=0.2128p pd=1.5u as=0.3808p ps=2.92u w=1.12u l=0.2u
X2917 a_24875_16071# a_24665_16071# VDD.t370 VDD.t90 sg13_lv_pmos ad=0.2128p pd=1.5u as=0.252p ps=1.57u w=1.12u l=0.13u
X2918 VDD.t112 VSS.t358 VDD.t111 VDD.t0 sg13_lv_pmos ad=0.34p pd=2.68u as=0 ps=0 w=1u l=1u
X2919 VDD.t423 VDD.t424 VDD.t425 VDD.t368 sg13_lv_pmos ad=0.2128p pd=1.5u as=0 ps=0 w=1.12u l=0.13u
X2920 a_4157_13495# CHAN1_DELAY_IN VSS.t697 VSS.t944 sg13_lv_nmos ad=0.2516p pd=2.16u as=0.2553p ps=2.17u w=0.74u l=0.13u
X2921 VDD.t767 a_4187_2434# a_26911_2470# VDD.t373 sg13_lv_pmos ad=0.3808p pd=2.92u as=0.2128p ps=1.5u w=1.12u l=0.6u
X2922 VDD.t257 VSS.t195 VDD.t255 VDD.t90 sg13_lv_pmos ad=0.19p pd=1.38u as=0 ps=0 w=1u l=1u
X2923 a_25391_8160# a_25153_7532# a_25283_7532# VDD.t346 sg13_lv_pmos ad=0.2128p pd=1.5u as=0.3808p ps=2.92u w=1.12u l=0.2u
X2924 a_16108_5979# a_15765_6153# a_15964_5979# VDD.t67 sg13_lv_pmos ad=0.3808p pd=2.92u as=0.3304p ps=1.71u w=1.12u l=0.13u
X2925 a_20593_16869# a_20397_16869# VSS.t1004 VSS.t2147 sg13_lv_nmos ad=0.2516p pd=2.16u as=0.1406p ps=1.12u w=0.74u l=0.13u
X2926 VDD.t329 VSS.t466 VDD.t327 VDD.t2 sg13_lv_pmos ad=0.19p pd=1.38u as=0 ps=0 w=1u l=1u
X2927 VSS.t1291 a_13883_16869# a_14317_16869# VSS.t1290 sg13_lv_nmos ad=0.1406p pd=1.12u as=0.2516p ps=2.16u w=0.74u l=0.13u
X2928 a_6913_14024# a_6717_14024# VSS.t1392 VSS.t1391 sg13_lv_nmos ad=0.2516p pd=2.16u as=0.1406p ps=1.12u w=0.74u l=0.13u
X2929 VSS.t395 VDD.t1635 VSS.t395 VSS.t396 sg13_lv_nmos ad=79.8f pd=0.8u as=0 ps=0 w=0.42u l=1u
X2930 a_12993_7532# a_12797_7532# VDD.t584 VDD.t346 sg13_lv_pmos ad=0.3808p pd=2.92u as=0.2128p ps=1.5u w=1.12u l=0.13u
X2931 a_22590_16071# a_2019_16074.t3 a_22488_16071# VSS.t1100 sg13_lv_nmos ad=0.2516p pd=2.16u as=0.1406p ps=1.12u w=0.74u l=0.13u
X2932 a_16408_6734# a_15837_7532# VSS.t1032 VSS.t1031 sg13_lv_nmos ad=0.1406p pd=1.12u as=0.2516p ps=2.16u w=0.74u l=0.13u
X2933 VSS.t2 a_2019_3156.t2 a_17865_3364# VSS.t1 sg13_lv_nmos ad=0.2516p pd=2.16u as=0.2516p ps=2.16u w=0.74u l=0.13u
X2934 VDD.t507 a_15403_16869# a_15837_16869# VDD.t368 sg13_lv_pmos ad=0.2128p pd=1.5u as=0.3808p ps=2.92u w=1.12u l=0.13u
X2935 a_22488_1044# a_21917_1842# VDD.t1115 VDD.t2 sg13_lv_pmos ad=0.2128p pd=1.5u as=0.3808p ps=2.92u w=1.12u l=0.13u
X2936 a_16408_16071# a_15837_16869# VSS.t479 VSS.t1052 sg13_lv_nmos ad=0.1406p pd=1.12u as=0.2516p ps=2.16u w=0.74u l=0.13u
X2937 VSS.t188 VDD.t1706 VSS.t188 VSS.t187 sg13_lv_nmos ad=0.1428p pd=1.52u as=0 ps=0 w=0.42u l=1u
X2938 a_12471_1842# a_12233_1842# a_12363_1842# VSS.t895 sg13_lv_nmos ad=0.1406p pd=1.12u as=0.2516p ps=2.16u w=0.74u l=0.2u
X2939 a_3747_3892.t0 a_3449_4240# VDD.t1154 VDD.t0 sg13_lv_pmos ad=0.2128p pd=1.5u as=0.1918p ps=1.5u w=1.12u l=0.13u
X2940 a_5731_3134# a_11785_3364# a_10430_3889# VDD.t0 sg13_lv_pmos ad=0.3808p pd=2.92u as=0.3808p ps=2.92u w=1.12u l=0.13u
X2941 a_13368_13226# a_12797_14024# VSS.t1542 VSS.t1904 sg13_lv_nmos ad=0.1406p pd=1.12u as=0.2516p ps=2.16u w=0.74u l=0.13u
X2942 VSS.t965 a_3171_3892.t6 a_14964_3853# VSS.t1737 sg13_lv_nmos ad=0.2516p pd=2.16u as=0.2516p ps=2.16u w=0.74u l=0.13u
X2943 VSS.t90 a_5523_7532# a_5957_7532# VSS.t1282 sg13_lv_nmos ad=0.1406p pd=1.12u as=0.2516p ps=2.16u w=0.74u l=0.13u
X2944 VSS.t326 VDD.t1661 VSS.t326 VSS.t327 sg13_lv_nmos ad=79.8f pd=0.8u as=0 ps=0 w=0.42u l=1u
X2945 VSS.t126 a_3449_6021# a_3747_6001.t1 VSS.t127 sg13_lv_nmos ad=0.2812p pd=2.24u as=0.1406p ps=1.12u w=0.74u l=0.13u
X2946 VSS.t596 a_3171_1047.t5 a_18004_1008# VSS.t1687 sg13_lv_nmos ad=0.2516p pd=2.16u as=0.2516p ps=2.16u w=0.74u l=0.13u
X2947 VDD.t889 a_2595_311.t3 a_8745_519# VDD.t2 sg13_lv_pmos ad=0.3808p pd=2.92u as=0.3808p ps=2.92u w=1.12u l=0.13u
X2948 VDD.t1278 a_3171_6001.t3 a_11785_6209# VDD.t67 sg13_lv_pmos ad=0.3808p pd=2.92u as=0.3808p ps=2.92u w=1.12u l=0.13u
X2949 a_16108_12471# a_3171_12493.t2 a_22590_13226# VSS.t991 sg13_lv_nmos ad=0.2516p pd=2.16u as=0.2516p ps=2.16u w=0.74u l=0.13u
X2950 VDD.t799 a_18117_7532# a_18585_6734# VDD.t67 sg13_lv_pmos ad=0.252p pd=1.57u as=0.3808p ps=2.92u w=1.12u l=0.13u
X2951 a_20831_5315# a_20593_4687# a_20723_4687# VDD.t348 sg13_lv_pmos ad=0.2128p pd=1.5u as=0.3808p ps=2.92u w=1.12u l=0.2u
X2952 VSS.t154 a_12849_11557# a_13400_10795# VSS.t155 sg13_lv_nmos ad=0.1626p pd=1.415u as=60.89999f ps=0.71u w=0.42u l=0.13u
X2953 VDD.t694 a_4187_2434# a_13991_8160# VDD.t346 sg13_lv_pmos ad=0.3808p pd=2.92u as=0.2128p ps=1.5u w=1.12u l=0.6u
X2954 a_5393_4687# a_5197_4687# VDD.t785 VDD.t348 sg13_lv_pmos ad=0.3808p pd=2.92u as=0.2128p ps=1.5u w=1.12u l=0.13u
X2955 VDD.t1246 a_2873_16422# a_3171_16074.t0 VDD.t90 sg13_lv_pmos ad=0.4256p pd=3u as=0.2128p ps=1.5u w=1.12u l=0.13u
X2956 a_16510_13226# a_3747_13229.t5 a_18795_13226# VSS.t568 sg13_lv_nmos ad=0.2516p pd=2.16u as=0.1406p ps=1.12u w=0.74u l=0.13u
X2957 VDD.t997 a_6326_10280# a_6326_10280# VDD.t355 sg13_lv_pmos ad=0.38p pd=2.38u as=0.38p ps=2.38u w=2u l=1u
X2958 VDD.t608 a_4187_2434# a_17031_5315# VDD.t348 sg13_lv_pmos ad=0.3808p pd=2.92u as=0.2128p ps=1.5u w=1.12u l=0.6u
X2959 a_23111_14024# a_22873_14024# a_23003_14024# VSS.t1835 sg13_lv_nmos ad=0.1406p pd=1.12u as=0.2516p ps=2.16u w=0.74u l=0.2u
X2960 VSS.t834 a_4187_1764.t98 VSS.t832 VSS.t817 sg13_lv_nmos ad=1.33p pd=7.38u as=0 ps=0 w=7u l=7u
X2961 a_16510_16071# a_2595_16074.t5 a_17275_16071# VSS.t105 sg13_lv_nmos ad=0.2516p pd=2.16u as=0.1406p ps=1.12u w=0.74u l=0.13u
X2962 a_15273_1842# a_15077_1842# VDD.t932 VDD.t373 sg13_lv_pmos ad=0.3808p pd=2.92u as=0.2128p ps=1.5u w=1.12u l=0.13u
X2963 a_17031_14652# a_16793_14024# a_16923_14024# VDD.t374 sg13_lv_pmos ad=0.2128p pd=1.5u as=0.3808p ps=2.92u w=1.12u l=0.2u
X2964 VSS.t251 VDD.t1684 VSS.t251 VSS.t250 sg13_lv_nmos ad=0.1428p pd=1.52u as=0 ps=0 w=0.42u l=1u
X2965 a_9444_9602# a_6854_11144# a_9712_9602# VSS.t136 sg13_lv_nmos ad=0.68p pd=4.68u as=0.38p ps=2.38u w=2u l=1u
X2966 a_7390_6734# a_3747_6737.t8 a_9675_6734# VSS.t1887 sg13_lv_nmos ad=0.2516p pd=2.16u as=0.1406p ps=1.12u w=0.74u l=0.13u
X2967 a_1256_3134# CHAN2_MUX_SEL2 VSS.t616 VSS.t615 sg13_lv_nmos ad=0.2516p pd=2.16u as=0.2516p ps=2.16u w=0.74u l=0.13u
X2968 a_1256_13226# CHAN1_MUX_SEL0 VSS.t1153 VSS.t758 sg13_lv_nmos ad=0.2516p pd=2.16u as=0.2516p ps=2.16u w=0.74u l=0.13u
X2969 a_13470_13226# a_2595_13229.t6 a_14235_13226# VSS.t1666 sg13_lv_nmos ad=0.2516p pd=2.16u as=0.1406p ps=1.12u w=0.74u l=0.13u
X2970 a_19550_13226# a_21044_13190# a_20968_13226# VDD.t5 sg13_lv_pmos ad=0.3808p pd=2.92u as=0.2128p ps=1.5u w=1.12u l=0.13u
X2971 VDD.t803 a_23763_7532# a_24197_7532# VDD.t346 sg13_lv_pmos ad=0.2128p pd=1.5u as=0.3808p ps=2.92u w=1.12u l=0.13u
X2972 a_6391_2470# a_6153_1842# a_6283_1842# VDD.t373 sg13_lv_pmos ad=0.2128p pd=1.5u as=0.3808p ps=2.92u w=1.12u l=0.2u
X2973 a_11195_3889# a_10985_3889# VSS.t167 VSS.t1757 sg13_lv_nmos ad=0.1406p pd=1.12u as=0.1665p ps=1.19u w=0.74u l=0.13u
X2974 a_2873_4240# CHAN2_MUX_SEL1 VDD.t1155 VDD.t0 sg13_lv_pmos ad=0.1596p pd=1.22u as=0.2856p ps=2.36u w=0.84u l=0.13u
X2975 a_14235_1044# a_14025_1044# VSS.t639 VSS.t2210 sg13_lv_nmos ad=0.1406p pd=1.12u as=0.1665p ps=1.19u w=0.74u l=0.13u
X2976 VSS.t365 VDD.t1644 VSS.t365 VSS.t369 sg13_lv_nmos ad=0.1428p pd=1.52u as=0 ps=0 w=0.42u l=1u
X2977 VDD.t607 a_26803_4687# a_27237_4687# VDD.t348 sg13_lv_pmos ad=0.2128p pd=1.5u as=0.3808p ps=2.92u w=1.12u l=0.13u
X2978 a_11195_16071# a_10985_16071# VDD.t554 VDD.t90 sg13_lv_pmos ad=0.2128p pd=1.5u as=0.252p ps=1.57u w=1.12u l=0.13u
X2979 a_12471_14652# a_12233_14024# a_12363_14024# VDD.t374 sg13_lv_pmos ad=0.2128p pd=1.5u as=0.3808p ps=2.92u w=1.12u l=0.2u
X2980 VDD.t681 a_4187_2434# a_17791_14652# VDD.t374 sg13_lv_pmos ad=0.3808p pd=2.92u as=0.2128p ps=1.5u w=1.12u l=0.6u
X2981 a_10206_11525# a_10649_11568# a_9946_11995# VSS.t1313 sg13_lv_nmos ad=79.8f pd=0.8u as=0.1296p ps=1.52u w=0.42u l=0.13u
X2982 VSS.t1235 a_4187_1764.t91 a_8671_7532# VSS.t1597 sg13_lv_nmos ad=0.2516p pd=2.16u as=0.1406p ps=1.12u w=0.74u l=0.6u
X2983 a_9444_10280# a_9444_10280# VSS.t1269 VSS.t1267 sg13_lv_nmos ad=0.38p pd=2.38u as=0.68p ps=4.68u w=2u l=1u
X2984 VSS.t705 a_3747_1047.t7 a_12791_1008# VSS.t704 sg13_lv_nmos ad=0.2516p pd=2.16u as=0.2516p ps=2.16u w=0.74u l=0.13u
X2985 a_12993_16869# a_12797_16869# VDD.t1270 VDD.t368 sg13_lv_pmos ad=0.3808p pd=2.92u as=0.2128p ps=1.5u w=1.12u l=0.13u
X2986 VSS.t1655 a_3171_13229.t8 a_8884_13190# VSS.t1654 sg13_lv_nmos ad=0.2516p pd=2.16u as=0.2516p ps=2.16u w=0.74u l=0.13u
X2987 a_22488_16071# a_21917_16869# VDD.t1516 VDD.t90 sg13_lv_pmos ad=0.2128p pd=1.5u as=0.3808p ps=2.92u w=1.12u l=0.13u
X2988 VDD.t671 a_4187_2434# a_13231_14652# VDD.t374 sg13_lv_pmos ad=0.3808p pd=2.92u as=0.2128p ps=1.5u w=1.12u l=0.6u
X2989 VDD.t1106 a_2019_3892.t7 a_10404_3853# VDD.t0 sg13_lv_pmos ad=0.3808p pd=2.92u as=0.3808p ps=2.92u w=1.12u l=0.13u
X2990 a_21591_16869# a_21353_16869# a_21483_16869# VSS.t2317 sg13_lv_nmos ad=0.1406p pd=1.12u as=0.2516p ps=2.16u w=0.74u l=0.2u
X2991 VSS.t586 a_4187_1764.t133 a_26911_16869# VSS.t916 sg13_lv_nmos ad=0.2516p pd=2.16u as=0.1406p ps=1.12u w=0.74u l=0.6u
X2992 VSS.t713 a_10843_1842# a_11277_1842# VSS.t1478 sg13_lv_nmos ad=0.1406p pd=1.12u as=0.2516p ps=2.16u w=0.74u l=0.13u
X2993 a_9953_1842# a_9757_1842# VSS.t711 VSS.t1403 sg13_lv_nmos ad=0.2516p pd=2.16u as=0.1406p ps=1.12u w=0.74u l=0.13u
X2994 VSS.t456 VDD.t1620 VSS.t455 VSS.t454 sg13_lv_nmos ad=0.1428p pd=1.52u as=0 ps=0 w=0.42u l=1u
X2995 a_7911_14024# a_7673_14024# a_7803_14024# VSS.t1312 sg13_lv_nmos ad=0.1406p pd=1.12u as=0.2516p ps=2.16u w=0.74u l=0.2u
X2996 VDD.t615 a_4187_2434# a_26911_8160# VDD.t346 sg13_lv_pmos ad=0.3808p pd=2.92u as=0.2128p ps=1.5u w=1.12u l=0.6u
X2997 VDD.t541 a_15403_1842# a_15837_1842# VDD.t373 sg13_lv_pmos ad=0.2128p pd=1.5u as=0.3808p ps=2.92u w=1.12u l=0.13u
X2998 VSS.t1703 a_4187_1764.t139 a_22351_16869# VSS.t1702 sg13_lv_nmos ad=0.2516p pd=2.16u as=0.1406p ps=1.12u w=0.74u l=0.6u
X2999 a_4350_13226# a_5844_13190# a_5768_13226# VDD.t5 sg13_lv_pmos ad=0.3808p pd=2.92u as=0.2128p ps=1.5u w=1.12u l=0.13u
X3000 a_27433_16869# a_27237_16869# VDD.t512 VDD.t368 sg13_lv_pmos ad=0.3808p pd=2.92u as=0.2128p ps=1.5u w=1.12u l=0.13u
X3001 a_25630_16071# a_27991_16035# a_27915_16071# VDD.t90 sg13_lv_pmos ad=0.3808p pd=2.92u as=0.2128p ps=1.5u w=1.12u l=0.13u
X3002 VDD.t437 VDD.t435 VDD.t433 VDD.t374 sg13_lv_pmos ad=0.2128p pd=1.5u as=0 ps=0 w=1.12u l=0.13u
X3003 VDD.t1287 a_3171_6737.t6 a_14964_6698# VDD.t67 sg13_lv_pmos ad=0.3808p pd=2.92u as=0.3808p ps=2.92u w=1.12u l=0.13u
X3004 a_16108_3134# a_15765_3308# a_15964_3134# VDD.t0 sg13_lv_pmos ad=0.3808p pd=2.92u as=0.3304p ps=1.71u w=1.12u l=0.13u
X3005 VSS.t978 a_4187_1764.t125 a_8671_14024# VSS.t977 sg13_lv_nmos ad=0.2516p pd=2.16u as=0.1406p ps=1.12u w=0.74u l=0.6u
X3006 VSS.t890 a_26043_14024# a_26477_14024# VSS.t1106 sg13_lv_nmos ad=0.1406p pd=1.12u as=0.2516p ps=2.16u w=0.74u l=0.13u
X3007 a_3543_13577# CHAN1_MUX_SEL0 a_3449_13577# VSS.t1161 sg13_lv_nmos ad=0.1216p pd=1.02u as=0.2176p ps=1.96u w=0.64u l=0.13u
X3008 a_11848_1044# a_11277_1842# VSS.t725 VSS.t1065 sg13_lv_nmos ad=0.1406p pd=1.12u as=0.2516p ps=2.16u w=0.74u l=0.13u
X3009 CHAN0_MUX_OUT a_16851_15336# VDD.t1445 VDD.t90 sg13_lv_pmos ad=0.2128p pd=1.5u as=0.2086p ps=1.5u w=1.12u l=0.13u
X3010 VSS.t221 VDD.t1692 VSS.t221 VSS.t222 sg13_lv_nmos ad=79.8f pd=0.8u as=0 ps=0 w=0.42u l=1u
X3011 VDD.t458 VDD.t459 VDD.t460 VDD.t456 sg13_lv_pmos ad=0.2128p pd=1.5u as=0 ps=0 w=1.12u l=0.13u
X3012 VSS.t428 VDD.t1627 VSS.t427 VSS.t426 sg13_lv_nmos ad=0.1428p pd=1.52u as=0 ps=0 w=0.42u l=1u
X3013 a_22590_16071# a_23431_16035# a_23355_16071# VDD.t90 sg13_lv_pmos ad=0.3808p pd=2.92u as=0.2128p ps=1.5u w=1.12u l=0.13u
X3014 a_11491_11918# a_10649_11568# a_10232_11561# VDD.t355 sg13_lv_pmos ad=0.2048p pd=1.63u as=0.34p ps=2.68u w=1u l=0.13u
X3015 VSS.t434 VDD.t1625 VSS.t437 VSS.t436 sg13_lv_nmos ad=79.8f pd=0.8u as=0 ps=0 w=0.42u l=1u
X3016 a_6854_11144# a_6326_10280# VDD.t450 VDD.t355 sg13_lv_pmos ad=0.38p pd=2.38u as=0.38p ps=2.38u w=2u l=1u
X3017 VDD.t1261 a_3449_1395# a_3747_1047.t0 VDD.t2 sg13_lv_pmos ad=0.4256p pd=3u as=0.2128p ps=1.5u w=1.12u l=0.13u
X3018 VDD.t1269 a_8997_16869# a_9465_16071# VDD.t90 sg13_lv_pmos ad=0.252p pd=1.57u as=0.3808p ps=2.92u w=1.12u l=0.13u
X3019 a_13470_1044# a_13444_1008# a_13368_1044# VDD.t2 sg13_lv_pmos ad=0.3808p pd=2.92u as=0.2128p ps=1.5u w=1.12u l=0.13u
X3020 VDD.t1085 a_4763_1842# a_5197_1842# VDD.t373 sg13_lv_pmos ad=0.2128p pd=1.5u as=0.3808p ps=2.92u w=1.12u l=0.13u
X3021 a_22590_3889# a_2595_3892.t3 a_23355_3889# VSS.t966 sg13_lv_nmos ad=0.2516p pd=2.16u as=0.1406p ps=1.12u w=0.74u l=0.13u
X3022 a_27671_4687# a_27433_4687# a_27563_4687# VSS.t1451 sg13_lv_nmos ad=0.1406p pd=1.12u as=0.2516p ps=2.16u w=0.74u l=0.2u
X3023 a_16108_5979# a_26985_6209# a_25630_6734# VDD.t67 sg13_lv_pmos ad=0.3808p pd=2.92u as=0.3808p ps=2.92u w=1.12u l=0.13u
X3024 VDD.t791 a_15403_14024# a_15837_14024# VDD.t374 sg13_lv_pmos ad=0.2128p pd=1.5u as=0.3808p ps=2.92u w=1.12u l=0.13u
X3025 a_26395_3889# a_26185_3889# VDD.t1160 VDD.t0 sg13_lv_pmos ad=0.2128p pd=1.5u as=0.252p ps=1.57u w=1.12u l=0.13u
X3026 VDD.t268 VSS.t326 VDD.t266 VDD.t67 sg13_lv_pmos ad=0.19p pd=1.38u as=0 ps=0 w=1u l=1u
X3027 a_12471_7532# a_12233_7532# a_12363_7532# VSS.t1831 sg13_lv_nmos ad=0.1406p pd=1.12u as=0.2516p ps=2.16u w=0.74u l=0.2u
X3028 a_19311_5315# a_19073_4687# a_19203_4687# VDD.t348 sg13_lv_pmos ad=0.2128p pd=1.5u as=0.3808p ps=2.92u w=1.12u l=0.2u
X3029 a_11195_6734# a_10985_6734# VDD.t393 VDD.t67 sg13_lv_pmos ad=0.2128p pd=1.5u as=0.252p ps=1.57u w=1.12u l=0.13u
X3030 VDD.t1188 a_3747_3892.t3 a_24951_3853# VDD.t0 sg13_lv_pmos ad=0.3808p pd=2.92u as=0.3808p ps=2.92u w=1.12u l=0.13u
X3031 VDD.t833 a_2595_13229.t7 a_11271_13190# VDD.t5 sg13_lv_pmos ad=0.3808p pd=2.92u as=0.3808p ps=2.92u w=1.12u l=0.13u
X3032 VSS.t142 a_3171_6737.t5 a_18004_6698# VSS.t2119 sg13_lv_nmos ad=0.2516p pd=2.16u as=0.2516p ps=2.16u w=0.74u l=0.13u
X3033 VDD.t855 a_3171_3156.t3 a_11785_3364# VDD.t0 sg13_lv_pmos ad=0.3808p pd=2.92u as=0.3808p ps=2.92u w=1.12u l=0.13u
X3034 VDD.t970 a_3171_1047.t3 a_24084_1008# VDD.t2 sg13_lv_pmos ad=0.3808p pd=2.92u as=0.3808p ps=2.92u w=1.12u l=0.13u
X3035 a_6153_16869# a_5957_16869# VSS.t1798 VSS.t1799 sg13_lv_nmos ad=0.2516p pd=2.16u as=0.1406p ps=1.12u w=0.74u l=0.13u
X3036 a_15755_16071# a_15545_16071# VSS.t578 VSS.t1943 sg13_lv_nmos ad=0.1406p pd=1.12u as=0.1665p ps=1.19u w=0.74u l=0.13u
X3037 a_3449_1395# CHAN3_MUX_SEL0 VDD.t1415 VDD.t2 sg13_lv_pmos ad=0.1596p pd=1.22u as=0.2856p ps=2.36u w=0.84u l=0.13u
X3038 a_2019_12493.t0 a_1721_12513# VDD.t401 VDD.t5 sg13_lv_pmos ad=0.2128p pd=1.5u as=0.1918p ps=1.5u w=1.12u l=0.13u
X3039 a_1721_16422# a_1256_16071# VDD.t1211 VDD.t90 sg13_lv_pmos ad=0.1596p pd=1.22u as=0.2856p ps=2.36u w=0.84u l=0.13u
X3040 a_15273_7532# a_15077_7532# VDD.t838 VDD.t346 sg13_lv_pmos ad=0.3808p pd=2.92u as=0.2128p ps=1.5u w=1.12u l=0.13u
X3041 VDD.t751 a_4187_2434# a_7911_2470# VDD.t373 sg13_lv_pmos ad=0.3808p pd=2.92u as=0.2128p ps=1.5u w=1.12u l=0.6u
X3042 a_13818_10808# a_12849_11557# VSS.t154 VSS.t153 sg13_lv_nmos ad=37.8f pd=0.6u as=0.1701p ps=1.65u w=0.42u l=0.13u
X3043 a_6391_8160# a_6153_7532# a_6283_7532# VDD.t346 sg13_lv_pmos ad=0.2128p pd=1.5u as=0.3808p ps=2.92u w=1.12u l=0.2u
X3044 VDD.t239 VSS.t405 VDD.t238 VDD.t2 sg13_lv_pmos ad=0.19p pd=1.38u as=0 ps=0 w=1u l=1u
X3045 VSS.t286 VDD.t1675 VSS.t288 VSS.t287 sg13_lv_nmos ad=79.8f pd=0.8u as=0 ps=0 w=0.42u l=1u
X3046 VSS.t986 a_4187_1764.t49 a_16271_4687# VSS.t985 sg13_lv_nmos ad=0.2516p pd=2.16u as=0.1406p ps=1.12u w=0.74u l=0.6u
X3047 a_13991_17497# a_13753_16869# a_13883_16869# VDD.t368 sg13_lv_pmos ad=0.2128p pd=1.5u as=0.3808p ps=2.92u w=1.12u l=0.2u
X3048 a_24008_3889# a_23437_4687# VDD.t1021 VDD.t0 sg13_lv_pmos ad=0.2128p pd=1.5u as=0.3808p ps=2.92u w=1.12u l=0.13u
X3049 a_18313_16869# a_18117_16869# VDD.t973 VDD.t368 sg13_lv_pmos ad=0.3808p pd=2.92u as=0.2128p ps=1.5u w=1.12u l=0.13u
X3050 a_14235_6734# a_14025_6734# VSS.t2209 VSS.t2208 sg13_lv_nmos ad=0.1406p pd=1.12u as=0.1665p ps=1.19u w=0.74u l=0.13u
X3051 a_18795_13226# a_18585_13226# VDD.t1053 VDD.t5 sg13_lv_pmos ad=0.2128p pd=1.5u as=0.252p ps=1.57u w=1.12u l=0.13u
X3052 VDD.t650 a_4187_2434# a_14751_17497# VDD.t368 sg13_lv_pmos ad=0.3808p pd=2.92u as=0.2128p ps=1.5u w=1.12u l=0.6u
X3053 VSS.t753 a_3747_6737.t7 a_12791_6698# VSS.t1768 sg13_lv_nmos ad=0.2516p pd=2.16u as=0.2516p ps=2.16u w=0.74u l=0.13u
X3054 VSS.t789 a_26043_4687# a_26477_4687# VSS.t1810 sg13_lv_nmos ad=0.1406p pd=1.12u as=0.2516p ps=2.16u w=0.74u l=0.13u
X3055 a_12993_14024# a_12797_14024# VDD.t929 VDD.t374 sg13_lv_pmos ad=0.3808p pd=2.92u as=0.2128p ps=1.5u w=1.12u l=0.13u
X3056 a_14235_13226# a_14025_13226# VDD.t1344 VDD.t5 sg13_lv_pmos ad=0.2128p pd=1.5u as=0.252p ps=1.57u w=1.12u l=0.13u
X3057 a_23111_5315# a_22873_4687# a_23003_4687# VDD.t348 sg13_lv_pmos ad=0.2128p pd=1.5u as=0.3808p ps=2.92u w=1.12u l=0.2u
X3058 a_9953_7532# a_9757_7532# VSS.t152 VSS.t2168 sg13_lv_nmos ad=0.2516p pd=2.16u as=0.1406p ps=1.12u w=0.74u l=0.13u
X3059 VDD.t154 VSS.t407 VDD.t153 VDD.t2 sg13_lv_pmos ad=0.34p pd=2.68u as=0 ps=0 w=1u l=1u
X3060 VSS.t773 a_10843_7532# a_11277_7532# VSS.t772 sg13_lv_nmos ad=0.1406p pd=1.12u as=0.2516p ps=2.16u w=0.74u l=0.13u
X3061 VSS.t520 VSS.t520 VSS.t522 VSS.t521 sg13_lv_nmos ad=0.2516p pd=2.16u as=0 ps=0 w=0.74u l=0.13u
X3062 a_22590_6734# a_23431_6698# a_23355_6734# VDD.t67 sg13_lv_pmos ad=0.3808p pd=2.92u as=0.2128p ps=1.5u w=1.12u l=0.13u
X3063 VDD.t778 a_17683_4687# a_18117_4687# VDD.t348 sg13_lv_pmos ad=0.2128p pd=1.5u as=0.3808p ps=2.92u w=1.12u l=0.13u
X3064 a_4157_7003# REF_CLK VSS.t126 VSS.t128 sg13_lv_nmos ad=0.2516p pd=2.16u as=0.2553p ps=2.17u w=0.74u l=0.13u
X3065 a_2595_6001.t0 a_2297_6021# VDD.t893 VDD.t67 sg13_lv_pmos ad=0.2128p pd=1.5u as=0.1918p ps=1.5u w=1.12u l=0.13u
X3066 a_25528_13226# a_24957_14024# VDD.t1060 VDD.t5 sg13_lv_pmos ad=0.2128p pd=1.5u as=0.3808p ps=2.92u w=1.12u l=0.13u
X3067 VDD.t844 a_15403_7532# a_15837_7532# VDD.t346 sg13_lv_pmos ad=0.2128p pd=1.5u as=0.3808p ps=2.92u w=1.12u l=0.13u
X3068 VSS.t83 a_19637_1842# a_20105_1044# VSS.t82 sg13_lv_nmos ad=0.1665p pd=1.19u as=0.2516p ps=2.16u w=0.74u l=0.13u
X3069 VDD.t1150 a_16851_309# CHAN3_MUX_OUT VDD.t2 sg13_lv_pmos ad=0.7336p pd=3.55u as=0.2128p ps=1.5u w=1.12u l=0.13u
X3070 a_10713_4687# a_10517_4687# VDD.t409 VDD.t348 sg13_lv_pmos ad=0.3808p pd=2.92u as=0.2128p ps=1.5u w=1.12u l=0.13u
X3071 a_21835_16071# a_21625_16071# VDD.t1350 VDD.t90 sg13_lv_pmos ad=0.2128p pd=1.5u as=0.252p ps=1.57u w=1.12u l=0.13u
X3072 a_4157_16340# CHAN0_DELAY_IN VSS.t1784 VSS.t1783 sg13_lv_nmos ad=0.2516p pd=2.16u as=0.2553p ps=2.17u w=0.74u l=0.13u
X3073 a_1256_12471# CHAN1_MUX_SEL2 VDD.t1456 VDD.t5 sg13_lv_pmos ad=0.3808p pd=2.92u as=0.3808p ps=2.92u w=1.12u l=0.13u
X3074 VDD.t934 a_18117_1842# a_18585_1044# VDD.t2 sg13_lv_pmos ad=0.252p pd=1.57u as=0.3808p ps=2.92u w=1.12u l=0.13u
X3075 a_27433_14024# a_27237_14024# VDD.t519 VDD.t374 sg13_lv_pmos ad=0.3808p pd=2.92u as=0.2128p ps=1.5u w=1.12u l=0.13u
X3076 a_11848_6734# a_11277_7532# VSS.t1386 VSS.t1819 sg13_lv_nmos ad=0.1406p pd=1.12u as=0.2516p ps=2.16u w=0.74u l=0.13u
X3077 VSS.t459 a_3171_311.t2 a_23945_519# VSS.t1139 sg13_lv_nmos ad=0.2516p pd=2.16u as=0.2516p ps=2.16u w=0.74u l=0.13u
X3078 VSS.t94 a_4187_1764.t44 a_20071_4687# VSS.t93 sg13_lv_nmos ad=0.2516p pd=2.16u as=0.1406p ps=1.12u w=0.74u l=0.6u
X3079 a_11711_2470# a_11473_1842# a_11603_1842# VDD.t373 sg13_lv_pmos ad=0.2128p pd=1.5u as=0.3808p ps=2.92u w=1.12u l=0.2u
X3080 VSS.t61 a_2019_3892.t7 a_10404_3853# VSS.t1515 sg13_lv_nmos ad=0.2516p pd=2.16u as=0.2516p ps=2.16u w=0.74u l=0.13u
X3081 VSS.t1186 a_10843_16869# a_11277_16869# VSS.t1185 sg13_lv_nmos ad=0.1406p pd=1.12u as=0.2516p ps=2.16u w=0.74u l=0.13u
X3082 VSS.t845 a_16597_14024# a_17065_13226# VSS.t844 sg13_lv_nmos ad=0.1665p pd=1.19u as=0.2516p ps=2.16u w=0.74u l=0.13u
X3083 VDD.t351 a_4763_7532# a_5197_7532# VDD.t346 sg13_lv_pmos ad=0.2128p pd=1.5u as=0.3808p ps=2.92u w=1.12u l=0.13u
X3084 a_27671_1842# a_27433_1842# a_27563_1842# VSS.t2190 sg13_lv_nmos ad=0.1406p pd=1.12u as=0.2516p ps=2.16u w=0.74u l=0.2u
X3085 VDD.t1018 a_7803_4687# a_8237_4687# VDD.t348 sg13_lv_pmos ad=0.2128p pd=1.5u as=0.3808p ps=2.92u w=1.12u l=0.13u
X3086 a_7151_16869# a_6913_16869# a_7043_16869# VSS.t571 sg13_lv_nmos ad=0.1406p pd=1.12u as=0.2516p ps=2.16u w=0.74u l=0.2u
X3087 a_14888_13226# a_14317_14024# VSS.t1208 VSS.t1207 sg13_lv_nmos ad=0.1406p pd=1.12u as=0.2516p ps=2.16u w=0.74u l=0.13u
X3088 a_16108_3134# a_26985_3364# a_25630_3889# VDD.t0 sg13_lv_pmos ad=0.3808p pd=2.92u as=0.3808p ps=2.92u w=1.12u l=0.13u
X3089 VDD.t80 VSS.t372 VDD.t78 VDD.t0 sg13_lv_pmos ad=0.19p pd=1.38u as=0 ps=0 w=1u l=1u
X3090 a_1256_3889# CHAN2_MUX_SEL0 VDD.t1561 VDD.t0 sg13_lv_pmos ad=0.3808p pd=2.92u as=0.3808p ps=2.92u w=1.12u l=0.13u
X3091 VDD.t1062 a_3747_6001.t2 a_26985_6209# VDD.t67 sg13_lv_pmos ad=0.3808p pd=2.92u as=0.3808p ps=2.92u w=1.12u l=0.13u
X3092 a_13368_16071# a_12797_16869# VSS.t1191 VSS.t2236 sg13_lv_nmos ad=0.1406p pd=1.12u as=0.2516p ps=2.16u w=0.74u l=0.13u
X3093 VSS.t531 VSS.t528 VSS.t528 VSS.t529 sg13_lv_nmos ad=0.1406p pd=1.12u as=0 ps=0 w=0.74u l=0.13u
X3094 a_10328_13226# a_9757_14024# VSS.t954 VSS.t1516 sg13_lv_nmos ad=0.1406p pd=1.12u as=0.2516p ps=2.16u w=0.74u l=0.13u
X3095 VSS.t2376 CHAN3_MUX_SEL4 a_15765_463# VSS.t2375 sg13_lv_nmos ad=0.2516p pd=2.16u as=0.2516p ps=2.16u w=0.74u l=0.13u
X3096 a_24631_14024# a_24393_14024# a_24523_14024# VSS.t1527 sg13_lv_nmos ad=0.1406p pd=1.12u as=0.2516p ps=2.16u w=0.74u l=0.2u
X3097 a_16108_12471# a_2595_12493.t2 a_19550_13226# VSS.t989 sg13_lv_nmos ad=0.2516p pd=2.16u as=0.2516p ps=2.16u w=0.74u l=0.13u
X3098 a_19311_17497# a_19073_16869# a_19203_16869# VDD.t368 sg13_lv_pmos ad=0.2128p pd=1.5u as=0.3808p ps=2.92u w=1.12u l=0.2u
X3099 a_16510_1044# a_2595_1047.t5 a_17275_1044# VSS.t718 sg13_lv_nmos ad=0.2516p pd=2.16u as=0.1406p ps=1.12u w=0.74u l=0.13u
X3100 a_5731_289# a_14825_519# a_13470_1044# VDD.t2 sg13_lv_pmos ad=0.3808p pd=2.92u as=0.3808p ps=2.92u w=1.12u l=0.13u
X3101 a_16510_16071# a_3747_16074.t5 a_18795_16071# VSS.t1103 sg13_lv_nmos ad=0.2516p pd=2.16u as=0.1406p ps=1.12u w=0.74u l=0.13u
X3102 a_13306_11995# a_14111_11568# a_13566_11525# VDD.t355 sg13_lv_pmos ad=0.1428p pd=1.52u as=79.8f ps=0.8u w=0.42u l=0.13u
X3103 VDD.t1292 a_2019_6001.t3 a_5705_6209# VDD.t67 sg13_lv_pmos ad=0.3808p pd=2.92u as=0.3808p ps=2.92u w=1.12u l=0.13u
X3104 a_22590_13226# a_22564_13190# a_22488_13226# VDD.t5 sg13_lv_pmos ad=0.3808p pd=2.92u as=0.2128p ps=1.5u w=1.12u l=0.13u
X3105 a_13470_13226# a_3747_13229.t6 a_15755_13226# VSS.t1641 sg13_lv_nmos ad=0.2516p pd=2.16u as=0.1406p ps=1.12u w=0.74u l=0.13u
X3106 a_5974_11413# a_6126_9506# VSS.t50 VSS.t49 sg13_lv_nmos ad=0.38p pd=2.38u as=0.68p ps=4.68u w=2u l=1u
X3107 VDD.t700 a_4187_2434# a_7911_8160# VDD.t346 sg13_lv_pmos ad=0.3808p pd=2.92u as=0.2128p ps=1.5u w=1.12u l=0.6u
X3108 VSS.t372 VDD.t1641 VSS.t372 VSS.t376 sg13_lv_nmos ad=0.1428p pd=1.52u as=0 ps=0 w=0.42u l=1u
X3109 a_26395_3889# a_26185_3889# VSS.t1621 VSS.t1886 sg13_lv_nmos ad=0.1406p pd=1.12u as=0.1665p ps=1.19u w=0.74u l=0.13u
X3110 a_20071_14024# a_19833_14024# a_19963_14024# VSS.t2330 sg13_lv_nmos ad=0.1406p pd=1.12u as=0.2516p ps=2.16u w=0.74u l=0.2u
X3111 VSS.t776 a_4187_1764.t103 a_25391_14024# VSS.t2384 sg13_lv_nmos ad=0.2516p pd=2.16u as=0.1406p ps=1.12u w=0.74u l=0.6u
X3112 a_16408_13226# a_15837_14024# VDD.t790 VDD.t5 sg13_lv_pmos ad=0.2128p pd=1.5u as=0.3808p ps=2.92u w=1.12u l=0.13u
X3113 VDD.t198 VSS.t291 VDD.t262 VDD.t5 sg13_lv_pmos ad=0.34p pd=2.68u as=0 ps=0 w=1u l=1u
X3114 a_13470_3889# a_14964_3853# a_14888_3889# VDD.t0 sg13_lv_pmos ad=0.3808p pd=2.92u as=0.2128p ps=1.5u w=1.12u l=0.13u
X3115 a_1256_16071# CHAN0_MUX_SEL0 VSS.t27 VSS.t180 sg13_lv_nmos ad=0.2516p pd=2.16u as=0.2516p ps=2.16u w=0.74u l=0.13u
X3116 VDD.t205 VSS.t202 VDD.t203 VDD.t90 sg13_lv_pmos ad=0.19p pd=1.38u as=0 ps=0 w=1u l=1u
X3117 a_13470_16071# a_2595_16074.t6 a_14235_16071# VSS.t1551 sg13_lv_nmos ad=0.2516p pd=2.16u as=0.1406p ps=1.12u w=0.74u l=0.13u
X3118 a_12715_16071# a_12505_16071# VDD.t556 VDD.t90 sg13_lv_pmos ad=0.2128p pd=1.5u as=0.252p ps=1.57u w=1.12u l=0.13u
X3119 VDD.t191 VSS.t459 VDD.t232 VDD.t2 sg13_lv_pmos ad=0.34p pd=2.68u as=0 ps=0 w=1u l=1u
X3120 VSS.t937 a_4187_1764.t17 a_16271_1842# VSS.t1473 sg13_lv_nmos ad=0.2516p pd=2.16u as=0.1406p ps=1.12u w=0.74u l=0.6u
X3121 VSS.t40 a_3747_3892.t3 a_24951_3853# VSS.t1685 sg13_lv_nmos ad=0.2516p pd=2.16u as=0.2516p ps=2.16u w=0.74u l=0.13u
X3122 a_13991_14652# a_13753_14024# a_13883_14024# VDD.t374 sg13_lv_pmos ad=0.2128p pd=1.5u as=0.3808p ps=2.92u w=1.12u l=0.2u
X3123 VDD.t969 a_3171_1047.t6 a_14964_1008# VDD.t2 sg13_lv_pmos ad=0.3808p pd=2.92u as=0.3808p ps=2.92u w=1.12u l=0.13u
X3124 a_5731_3134# a_2019_3156.t3 a_4350_3889# VSS.t84 sg13_lv_nmos ad=0.2516p pd=2.16u as=0.2516p ps=2.16u w=0.74u l=0.13u
X3125 a_18313_14024# a_18117_14024# VDD.t773 VDD.t374 sg13_lv_pmos ad=0.3808p pd=2.92u as=0.2128p ps=1.5u w=1.12u l=0.13u
X3126 VDD.t985 a_6326_10280# a_6126_9506# VDD.t355 sg13_lv_pmos ad=0.38p pd=2.38u as=0.38p ps=2.38u w=2u l=1u
X3127 VSS.t702 a_3747_1047.t2 a_27991_1008# VSS.t701 sg13_lv_nmos ad=0.2516p pd=2.16u as=0.2516p ps=2.16u w=0.74u l=0.13u
X3128 VDD.t792 a_10083_1842# a_10517_1842# VDD.t373 sg13_lv_pmos ad=0.2128p pd=1.5u as=0.3808p ps=2.92u w=1.12u l=0.13u
X3129 VDD.t1362 a_25717_16869# a_26185_16071# VDD.t90 sg13_lv_pmos ad=0.252p pd=1.57u as=0.3808p ps=2.92u w=1.12u l=0.13u
X3130 VSS.t764 CHAN1_MUX_SEL4 a_15765_12645# VSS.t763 sg13_lv_nmos ad=0.2516p pd=2.16u as=0.2516p ps=2.16u w=0.74u l=0.13u
X3131 a_9444_10280# a_6854_11144# a_6854_11144# VSS.t136 sg13_lv_nmos ad=0.68p pd=4.68u as=0.38p ps=2.38u w=2u l=1u
X3132 a_17553_4687# a_17357_4687# VSS.t984 VSS.t1343 sg13_lv_nmos ad=0.2516p pd=2.16u as=0.1406p ps=1.12u w=0.74u l=0.13u
X3133 a_2297_16422# CHAN0_MUX_SEL0 VDD.t417 VDD.t90 sg13_lv_pmos ad=0.1596p pd=1.22u as=0.2856p ps=2.36u w=0.84u l=0.13u
X3134 a_24008_16071# a_23437_16869# VDD.t511 VDD.t90 sg13_lv_pmos ad=0.2128p pd=1.5u as=0.3808p ps=2.92u w=1.12u l=0.13u
X3135 a_8671_4687# a_8433_4687# a_8563_4687# VSS.t1578 sg13_lv_nmos ad=0.1406p pd=1.12u as=0.2516p ps=2.16u w=0.74u l=0.2u
X3136 VDD.t637 a_4187_2434# a_14751_14652# VDD.t374 sg13_lv_pmos ad=0.3808p pd=2.92u as=0.2128p ps=1.5u w=1.12u l=0.6u
X3137 VDD.t1311 a_2019_3892.t2 a_25604_3853# VDD.t0 sg13_lv_pmos ad=0.3808p pd=2.92u as=0.3808p ps=2.92u w=1.12u l=0.13u
X3138 VSS.t110 a_3171_16074.t8 a_8884_16035# VSS.t661 sg13_lv_nmos ad=0.2516p pd=2.16u as=0.2516p ps=2.16u w=0.74u l=0.13u
X3139 VSS.t1221 a_26043_1842# a_26477_1842# VSS.t1220 sg13_lv_nmos ad=0.1406p pd=1.12u as=0.2516p ps=2.16u w=0.74u l=0.13u
X3140 VDD.t893 a_1544_5979# a_2297_6021# VDD.t67 sg13_lv_pmos ad=0.1918p pd=1.5u as=0.1596p ps=1.22u w=0.84u l=0.13u
X3141 VDD.t1195 a_2019_6737.t7 a_10404_6698# VDD.t67 sg13_lv_pmos ad=0.3808p pd=2.92u as=0.3808p ps=2.92u w=1.12u l=0.13u
X3142 a_16510_13226# a_17351_13190# a_17275_13226# VDD.t5 sg13_lv_pmos ad=0.3808p pd=2.92u as=0.2128p ps=1.5u w=1.12u l=0.13u
X3143 VSS.t104 a_3747_1047.t9 a_6711_1008# VSS.t699 sg13_lv_nmos ad=0.2516p pd=2.16u as=0.2516p ps=2.16u w=0.74u l=0.13u
X3144 VSS.t72 a_4187_1764.t137 a_23871_16869# VSS.t835 sg13_lv_nmos ad=0.2516p pd=2.16u as=0.1406p ps=1.12u w=0.74u l=0.6u
X3145 a_11195_1044# a_10985_1044# VDD.t1049 VDD.t2 sg13_lv_pmos ad=0.2128p pd=1.5u as=0.252p ps=1.57u w=1.12u l=0.13u
X3146 a_24008_3889# a_23437_4687# VSS.t968 VSS.t1350 sg13_lv_nmos ad=0.1406p pd=1.12u as=0.2516p ps=2.16u w=0.74u l=0.13u
X3147 a_4871_14024# a_4633_14024# a_4763_14024# VSS.t1929 sg13_lv_nmos ad=0.1406p pd=1.12u as=0.2516p ps=2.16u w=0.74u l=0.2u
X3148 VDD.t11 VSS.t243 VDD.t10 VDD.t5 sg13_lv_pmos ad=0.34p pd=2.68u as=0 ps=0 w=1u l=1u
X3149 VSS.t1018 a_19637_7532# a_20105_6734# VSS.t2288 sg13_lv_nmos ad=0.1665p pd=1.19u as=0.2516p ps=2.16u w=0.74u l=0.13u
X3150 a_2595_3156.t1 a_2297_3176# VSS.t2093 VSS.t1774 sg13_lv_nmos ad=0.1406p pd=1.12u as=0.1331p ps=1.12u w=0.74u l=0.13u
X3151 a_9193_14024# a_8997_14024# VSS.t978 VSS.t1316 sg13_lv_nmos ad=0.2516p pd=2.16u as=0.1406p ps=1.12u w=0.74u l=0.13u
X3152 a_16108_289# a_2595_311.t2 a_19550_1044# VSS.t1136 sg13_lv_nmos ad=0.2516p pd=2.16u as=0.2516p ps=2.16u w=0.74u l=0.13u
X3153 a_3543_16422# CHAN0_MUX_SEL0 a_3449_16422# VSS.t182 sg13_lv_nmos ad=0.1216p pd=1.02u as=0.2176p ps=1.96u w=0.64u l=0.13u
X3154 a_22590_16071# a_24951_16035# a_24875_16071# VDD.t90 sg13_lv_pmos ad=0.3808p pd=2.92u as=0.2128p ps=1.5u w=1.12u l=0.13u
X3155 a_21835_3889# a_21625_3889# VDD.t595 VDD.t0 sg13_lv_pmos ad=0.2128p pd=1.5u as=0.252p ps=1.57u w=1.12u l=0.13u
X3156 VSS.t1936 a_4187_1764.t129 a_5631_14024# VSS.t2192 sg13_lv_nmos ad=0.2516p pd=2.16u as=0.1406p ps=1.12u w=0.74u l=0.6u
X3157 a_5731_12471# a_3171_12493.t3 a_10430_13226# VSS.t998 sg13_lv_nmos ad=0.2516p pd=2.16u as=0.2516p ps=2.16u w=0.74u l=0.13u
X3158 a_11711_8160# a_11473_7532# a_11603_7532# VDD.t346 sg13_lv_pmos ad=0.2128p pd=1.5u as=0.3808p ps=2.92u w=1.12u l=0.2u
X3159 VSS.t1419 a_23003_14024# a_23437_14024# VSS.t1418 sg13_lv_nmos ad=0.1406p pd=1.12u as=0.2516p ps=2.16u w=0.74u l=0.13u
X3160 VSS.t604 a_4187_1764.t12 a_20071_1842# VSS.t997 sg13_lv_nmos ad=0.2516p pd=2.16u as=0.1406p ps=1.12u w=0.74u l=0.6u
X3161 a_16108_15316# a_2019_15338.t2 a_16510_16071# VSS.t2083 sg13_lv_nmos ad=0.2516p pd=2.16u as=0.2516p ps=2.16u w=0.74u l=0.13u
X3162 a_14751_5315# a_14513_4687# a_14643_4687# VDD.t348 sg13_lv_pmos ad=0.2128p pd=1.5u as=0.3808p ps=2.92u w=1.12u l=0.2u
X3163 VDD.t1084 a_2595_3892.t4 a_20391_3853# VDD.t0 sg13_lv_pmos ad=0.3808p pd=2.92u as=0.3808p ps=2.92u w=1.12u l=0.13u
X3164 VSS.t209 VDD.t1695 VSS.t209 VSS.t214 sg13_lv_nmos ad=79.8f pd=0.8u as=0 ps=0 w=0.42u l=1u
X3165 a_27671_7532# a_27433_7532# a_27563_7532# VSS.t1257 sg13_lv_nmos ad=0.1406p pd=1.12u as=0.2516p ps=2.16u w=0.74u l=0.2u
X3166 VDD.t763 a_4187_2434# a_24631_2470# VDD.t373 sg13_lv_pmos ad=0.3808p pd=2.92u as=0.2128p ps=1.5u w=1.12u l=0.6u
X3167 a_21353_4687# a_21157_4687# VSS.t92 VSS.t767 sg13_lv_nmos ad=0.2516p pd=2.16u as=0.1406p ps=1.12u w=0.74u l=0.13u
X3168 VSS.t333 VDD.t1657 VSS.t333 VSS.t336 sg13_lv_nmos ad=79.8f pd=0.8u as=0 ps=0 w=0.42u l=1u
X3169 a_26395_6734# a_26185_6734# VDD.t413 VDD.t67 sg13_lv_pmos ad=0.2128p pd=1.5u as=0.252p ps=1.57u w=1.12u l=0.13u
X3170 VSS.t489 VSS.t487 VSS.t30 VSS.t488 sg13_lv_nmos ad=0.2516p pd=2.16u as=0 ps=0 w=0.74u l=0.13u
X3171 VDD.t482 VDD.t480 VDD.t478 VDD.t348 sg13_lv_pmos ad=0.2128p pd=1.5u as=0 ps=0 w=1.12u l=0.13u
X3172 VDD.t952 a_3747_3156.t2 a_26985_3364# VDD.t0 sg13_lv_pmos ad=0.3808p pd=2.92u as=0.3808p ps=2.92u w=1.12u l=0.13u
X3173 a_7673_16869# a_7477_16869# VSS.t1501 VSS.t2174 sg13_lv_nmos ad=0.2516p pd=2.16u as=0.1406p ps=1.12u w=0.74u l=0.13u
X3174 VDD.t410 a_10517_4687# a_10985_3889# VDD.t0 sg13_lv_pmos ad=0.252p pd=1.57u as=0.3808p ps=2.92u w=1.12u l=0.13u
X3175 VDD.t1237 a_3747_6737.t3 a_24951_6698# VDD.t67 sg13_lv_pmos ad=0.3808p pd=2.92u as=0.3808p ps=2.92u w=1.12u l=0.13u
X3176 VSS.t2212 a_7043_4687# a_7477_4687# VSS.t2281 sg13_lv_nmos ad=0.1406p pd=1.12u as=0.2516p ps=2.16u w=0.74u l=0.13u
X3177 a_4111_5315# CHAN2_DELAY_IN a_4003_4687# VDD.t348 sg13_lv_pmos ad=0.2128p pd=1.5u as=0.3808p ps=2.92u w=1.12u l=0.2u
X3178 a_2019_15338.t0 a_1721_15358# VDD.t1426 VDD.t90 sg13_lv_pmos ad=0.2128p pd=1.5u as=0.1918p ps=1.5u w=1.12u l=0.13u
X3179 a_16510_6734# a_2595_6737.t5 a_17275_6734# VSS.t1380 sg13_lv_nmos ad=0.2516p pd=2.16u as=0.1406p ps=1.12u w=0.74u l=0.13u
X3180 a_2019_15338.t1 a_1721_15358# VSS.t2097 VSS.t1996 sg13_lv_nmos ad=0.1406p pd=1.12u as=0.1331p ps=1.12u w=0.74u l=0.13u
X3181 a_19311_14652# a_19073_14024# a_19203_14024# VDD.t374 sg13_lv_pmos ad=0.2128p pd=1.5u as=0.3808p ps=2.92u w=1.12u l=0.2u
X3182 a_11748_11799# DLL_RESETN VDD.t381 VDD.t355 sg13_lv_pmos ad=79.8f pd=0.8u as=1.10612p ps=6.66u w=0.42u l=0.13u
X3183 VDD.t378 a_2019_3156.t3 a_5705_3364# VDD.t0 sg13_lv_pmos ad=0.3808p pd=2.92u as=0.3808p ps=2.92u w=1.12u l=0.13u
X3184 a_12355_11557# a_12158_11557# VDD.t356 VDD.t355 sg13_lv_pmos ad=0.3808p pd=2.92u as=0.2128p ps=1.5u w=1.12u l=0.13u
X3185 a_22590_1044# a_23431_1008# a_23355_1044# VDD.t2 sg13_lv_pmos ad=0.3808p pd=2.92u as=0.2128p ps=1.5u w=1.12u l=0.13u
X3186 a_1256_3889# CHAN2_MUX_SEL0 VSS.t1609 VSS.t2283 sg13_lv_nmos ad=0.2516p pd=2.16u as=0.2516p ps=2.16u w=0.74u l=0.13u
X3187 VDD.t1282 a_2019_6001.t2 a_17865_6209# VDD.t67 sg13_lv_pmos ad=0.3808p pd=2.92u as=0.3808p ps=2.92u w=1.12u l=0.13u
X3188 a_15304_10295# a_14851_11918# VSS.t157 VSS.t156 sg13_lv_nmos ad=0.2849p pd=2.25u as=0.2516p ps=2.16u w=0.74u l=0.13u
X3189 a_2297_3176# CHAN2_MUX_SEL2 VDD.t528 VDD.t0 sg13_lv_pmos ad=0.1596p pd=1.22u as=0.2856p ps=2.36u w=0.84u l=0.13u
X3190 a_14851_11918# a_14009_11568# a_14757_11918# VSS.t156 sg13_lv_nmos ad=0.12665p pd=1.145u as=0.1428p ps=1.52u w=0.42u l=0.13u
X3191 VSS.t1585 a_4187_1764.t81 a_16271_7532# VSS.t2364 sg13_lv_nmos ad=0.2516p pd=2.16u as=0.1406p ps=1.12u w=0.74u l=0.6u
X3192 a_24008_6734# a_23437_7532# VDD.t966 VDD.t67 sg13_lv_pmos ad=0.2128p pd=1.5u as=0.3808p ps=2.92u w=1.12u l=0.13u
X3193 VSS.t495 VSS.t492 VSS.t494 VSS.t493 sg13_lv_nmos ad=0.2516p pd=2.16u as=0 ps=0 w=0.74u l=0.6u
X3194 VSS.t419 VDD.t1629 VSS.t419 VSS.t420 sg13_lv_nmos ad=79.8f pd=0.8u as=0 ps=0 w=0.42u l=1u
X3195 VSS.t120 a_4187_1764.t155 a_10191_16869# VSS.t119 sg13_lv_nmos ad=0.2516p pd=2.16u as=0.1406p ps=1.12u w=0.74u l=0.6u
X3196 a_20593_14024# a_20397_14024# VSS.t1071 VSS.t1070 sg13_lv_nmos ad=0.2516p pd=2.16u as=0.1406p ps=1.12u w=0.74u l=0.13u
X3197 VSS.t1766 a_3747_6737.t2 a_27991_6698# VSS.t1765 sg13_lv_nmos ad=0.2516p pd=2.16u as=0.2516p ps=2.16u w=0.74u l=0.13u
X3198 VDD.t1425 a_1544_3134# a_1721_3176# VDD.t0 sg13_lv_pmos ad=0.1918p pd=1.5u as=0.1596p ps=1.22u w=0.84u l=0.13u
X3199 a_10951_17497# a_10713_16869# a_10843_16869# VDD.t368 sg13_lv_pmos ad=0.2128p pd=1.5u as=0.3808p ps=2.92u w=1.12u l=0.2u
X3200 VDD.t525 a_10083_7532# a_10517_7532# VDD.t346 sg13_lv_pmos ad=0.2128p pd=1.5u as=0.3808p ps=2.92u w=1.12u l=0.13u
X3201 a_15273_16869# a_15077_16869# VDD.t508 VDD.t368 sg13_lv_pmos ad=0.3808p pd=2.92u as=0.2128p ps=1.5u w=1.12u l=0.13u
X3202 VSS.t78 a_13883_14024# a_14317_14024# VSS.t77 sg13_lv_nmos ad=0.1406p pd=1.12u as=0.2516p ps=2.16u w=0.74u l=0.13u
X3203 VSS.t32 a_11491_11918# a_12158_11557# VSS.t2307 sg13_lv_nmos ad=0.1406p pd=1.12u as=0.2516p ps=2.16u w=0.74u l=0.13u
X3204 VDD.t907 a_13123_4687# a_13557_4687# VDD.t348 sg13_lv_pmos ad=0.2128p pd=1.5u as=0.3808p ps=2.92u w=1.12u l=0.13u
X3205 a_15755_13226# a_15545_13226# VDD.t770 VDD.t5 sg13_lv_pmos ad=0.2128p pd=1.5u as=0.252p ps=1.57u w=1.12u l=0.13u
X3206 a_17553_1842# a_17357_1842# VSS.t598 VSS.t597 sg13_lv_nmos ad=0.2516p pd=2.16u as=0.1406p ps=1.12u w=0.74u l=0.13u
X3207 VSS.t745 a_26043_7532# a_26477_7532# VSS.t1040 sg13_lv_nmos ad=0.1406p pd=1.12u as=0.2516p ps=2.16u w=0.74u l=0.13u
X3208 a_8671_1842# a_8433_1842# a_8563_1842# VSS.t76 sg13_lv_nmos ad=0.1406p pd=1.12u as=0.2516p ps=2.16u w=0.74u l=0.2u
X3209 VSS.t678 a_16851_5999# REF_MUX_OUT VSS.t679 sg13_lv_nmos ad=0.2516p pd=2.16u as=0.1406p ps=1.12u w=0.74u l=0.13u
X3210 VSS.t195 VDD.t1701 VSS.t195 VSS.t200 sg13_lv_nmos ad=79.8f pd=0.8u as=0 ps=0 w=0.42u l=1u
X3211 a_1544_12471# CHAN1_MUX_SEL3 VSS.t149 VSS.t694 sg13_lv_nmos ad=0.2516p pd=2.16u as=0.2516p ps=2.16u w=0.74u l=0.13u
X3212 a_5731_289# a_5705_519# a_4350_1044# VDD.t2 sg13_lv_pmos ad=0.3808p pd=2.92u as=0.3808p ps=2.92u w=1.12u l=0.13u
X3213 a_10430_16071# a_11271_16035# a_11195_16071# VDD.t90 sg13_lv_pmos ad=0.3808p pd=2.92u as=0.2128p ps=1.5u w=1.12u l=0.13u
X3214 VSS.t697 a_3449_12513# a_3747_12493.t1 VSS.t1223 sg13_lv_nmos ad=0.2812p pd=2.24u as=0.1406p ps=1.12u w=0.74u l=0.13u
X3215 a_10520_11982# a_10751_11568# a_10206_11525# VSS.t1313 sg13_lv_nmos ad=0.2373p pd=1.97u as=79.8f ps=0.8u w=0.42u l=0.13u
X3216 a_9712_9602# a_13019_11521# a_4187_1764.t1 VSS.t1027 sg13_lv_nmos ad=0.136p pd=1.14u as=0.232p ps=2.08u w=0.4u l=0.2u
X3217 VSS.t100 a_3747_6737.t9 a_6711_6698# VSS.t1763 sg13_lv_nmos ad=0.2516p pd=2.16u as=0.2516p ps=2.16u w=0.74u l=0.13u
X3218 a_13470_3889# a_3171_3892.t6 a_14888_3889# VSS.t1736 sg13_lv_nmos ad=0.2516p pd=2.16u as=0.1406p ps=1.12u w=0.74u l=0.13u
X3219 a_25913_4687# a_25717_4687# VDD.t1075 VDD.t348 sg13_lv_pmos ad=0.3808p pd=2.92u as=0.2128p ps=1.5u w=1.12u l=0.13u
X3220 VSS.t57 a_6126_9506# a_5974_11413# VSS.t49 sg13_lv_nmos ad=0.68p pd=4.68u as=0.38p ps=2.38u w=2u l=1u
X3221 VSS.t202 VDD.t1698 VSS.t202 VSS.t206 sg13_lv_nmos ad=0.1428p pd=1.52u as=0 ps=0 w=0.42u l=1u
X3222 VSS.t365 VDD.t1646 VSS.t365 VSS.t364 sg13_lv_nmos ad=0.1428p pd=1.52u as=0 ps=0 w=0.42u l=1u
X3223 a_1256_5979# REF_MUX_SEL2 VDD.t1546 VDD.t67 sg13_lv_pmos ad=0.3808p pd=2.92u as=0.3808p ps=2.92u w=1.12u l=0.13u
X3224 VDD.t490 VDD.t488 VDD.t489 VDD.t373 sg13_lv_pmos ad=0.3808p pd=2.92u as=0 ps=0 w=1.12u l=0.13u
X3225 VDD.t1207 a_3171_16074.t9 a_5844_16035# VDD.t90 sg13_lv_pmos ad=0.3808p pd=2.92u as=0.3808p ps=2.92u w=1.12u l=0.13u
X3226 a_1256_15316# CHAN0_MUX_SEL2 VDD.t588 VDD.t90 sg13_lv_pmos ad=0.3808p pd=2.92u as=0.3808p ps=2.92u w=1.12u l=0.13u
X3227 a_26911_2470# a_26673_1842# a_26803_1842# VDD.t373 sg13_lv_pmos ad=0.2128p pd=1.5u as=0.3808p ps=2.92u w=1.12u l=0.2u
X3228 VDD.t1166 a_3747_3892.t5 a_18871_3853# VDD.t0 sg13_lv_pmos ad=0.3808p pd=2.92u as=0.3808p ps=2.92u w=1.12u l=0.13u
X3229 VSS.t1599 a_12363_16869# a_12797_16869# VSS.t1845 sg13_lv_nmos ad=0.1406p pd=1.12u as=0.2516p ps=2.16u w=0.74u l=0.13u
X3230 VSS.t40 a_2019_3892.t2 a_25604_3853# VSS.t1919 sg13_lv_nmos ad=0.2516p pd=2.16u as=0.2516p ps=2.16u w=0.74u l=0.13u
X3231 VSS.t692 a_4187_1764.t76 a_20071_7532# VSS.t2159 sg13_lv_nmos ad=0.2516p pd=2.16u as=0.1406p ps=1.12u w=0.74u l=0.6u
X3232 VSS.t1406 a_18117_14024# a_18585_13226# VSS.t1405 sg13_lv_nmos ad=0.1665p pd=1.19u as=0.2516p ps=2.16u w=0.74u l=0.13u
X3233 VDD.t284 VSS.t333 VDD.t282 VDD.t67 sg13_lv_pmos ad=0.19p pd=1.38u as=0 ps=0 w=1u l=1u
X3234 a_8671_16869# a_8433_16869# a_8563_16869# VSS.t2176 sg13_lv_nmos ad=0.1406p pd=1.12u as=0.2516p ps=2.16u w=0.74u l=0.2u
X3235 a_2595_6737.t0 a_2297_7085# VDD.t781 VDD.t67 sg13_lv_pmos ad=0.2128p pd=1.5u as=0.1918p ps=1.5u w=1.12u l=0.13u
X3236 a_7390_1044# a_2019_1047.t8 a_7288_1044# VSS.t102 sg13_lv_nmos ad=0.2516p pd=2.16u as=0.1406p ps=1.12u w=0.74u l=0.13u
X3237 VDD.t686 a_4187_2434# a_24631_8160# VDD.t346 sg13_lv_pmos ad=0.3808p pd=2.92u as=0.2128p ps=1.5u w=1.12u l=0.6u
X3238 VSS.t1460 a_16597_16869# a_17065_16071# VSS.t1459 sg13_lv_nmos ad=0.1665p pd=1.19u as=0.2516p ps=2.16u w=0.74u l=0.13u
X3239 a_14888_16071# a_14317_16869# VSS.t607 VSS.t1372 sg13_lv_nmos ad=0.1406p pd=1.12u as=0.2516p ps=2.16u w=0.74u l=0.13u
X3240 a_1256_6734# REF_MUX_SEL0 VDD.t1469 VDD.t67 sg13_lv_pmos ad=0.3808p pd=2.92u as=0.3808p ps=2.92u w=1.12u l=0.13u
X3241 a_21353_1842# a_21157_1842# VSS.t778 VSS.t777 sg13_lv_nmos ad=0.2516p pd=2.16u as=0.1406p ps=1.12u w=0.74u l=0.13u
X3242 VSS.t11 a_3171_13229.t2 a_27124_13190# VSS.t10 sg13_lv_nmos ad=0.2516p pd=2.16u as=0.2516p ps=2.16u w=0.74u l=0.13u
X3243 a_13991_4687# a_13753_4687# a_13883_4687# VSS.t1821 sg13_lv_nmos ad=0.1406p pd=1.12u as=0.2516p ps=2.16u w=0.74u l=0.2u
X3244 VSS.t68 a_4187_1764.t156 a_9431_16869# VSS.t1130 sg13_lv_nmos ad=0.2516p pd=2.16u as=0.1406p ps=1.12u w=0.74u l=0.6u
X3245 a_11848_13226# a_11277_14024# VSS.t1013 VSS.t1963 sg13_lv_nmos ad=0.1406p pd=1.12u as=0.2516p ps=2.16u w=0.74u l=0.13u
X3246 VSS.t251 VDD.t1684 VSS.t253 VSS.t252 sg13_lv_nmos ad=79.8f pd=0.8u as=0 ps=0 w=0.42u l=1u
X3247 VSS.t586 a_26803_16869# a_27237_16869# VSS.t585 sg13_lv_nmos ad=0.1406p pd=1.12u as=0.2516p ps=2.16u w=0.74u l=0.13u
X3248 a_12715_3889# a_12505_3889# VDD.t562 VDD.t0 sg13_lv_pmos ad=0.2128p pd=1.5u as=0.252p ps=1.57u w=1.12u l=0.13u
X3249 a_1815_15358# a_1256_15316# a_1721_15358# VSS.t1910 sg13_lv_nmos ad=0.1216p pd=1.02u as=0.2176p ps=1.96u w=0.64u l=0.13u
X3250 a_10328_16071# a_9757_16869# VSS.t1370 VSS.t1369 sg13_lv_nmos ad=0.1406p pd=1.12u as=0.2516p ps=2.16u w=0.74u l=0.13u
X3251 a_4157_13495# CHAN1_DELAY_IN VDD.t815 VDD.t5 sg13_lv_pmos ad=0.3808p pd=2.92u as=0.3808p ps=2.92u w=1.12u l=0.13u
X3252 VSS.t982 a_7043_1842# a_7477_1842# VSS.t1063 sg13_lv_nmos ad=0.1406p pd=1.12u as=0.2516p ps=2.16u w=0.74u l=0.13u
X3253 a_17928_3889# a_17357_4687# VDD.t1016 VDD.t0 sg13_lv_pmos ad=0.2128p pd=1.5u as=0.3808p ps=2.92u w=1.12u l=0.13u
X3254 a_21835_3889# a_21625_3889# VSS.t769 VSS.t1813 sg13_lv_nmos ad=0.1406p pd=1.12u as=0.1665p ps=1.19u w=0.74u l=0.13u
X3255 VDD.t959 a_1544_13226# a_2297_13577# VDD.t5 sg13_lv_pmos ad=0.1918p pd=1.5u as=0.1596p ps=1.22u w=0.84u l=0.13u
X3256 VDD.t755 a_4187_2434# a_15511_2470# VDD.t373 sg13_lv_pmos ad=0.3808p pd=2.92u as=0.2128p ps=1.5u w=1.12u l=0.6u
X3257 a_19550_3889# a_21044_3853# a_20968_3889# VDD.t0 sg13_lv_pmos ad=0.3808p pd=2.92u as=0.2128p ps=1.5u w=1.12u l=0.13u
X3258 VDD.t1370 a_2019_1047.t7 a_10404_1008# VDD.t2 sg13_lv_pmos ad=0.3808p pd=2.92u as=0.3808p ps=2.92u w=1.12u l=0.13u
X3259 VSS.t683 a_2595_3892.t4 a_20391_3853# VSS.t1468 sg13_lv_nmos ad=0.2516p pd=2.16u as=0.2516p ps=2.16u w=0.74u l=0.13u
X3260 a_21591_14024# a_21353_14024# a_21483_14024# VSS.t934 sg13_lv_nmos ad=0.1406p pd=1.12u as=0.2516p ps=2.16u w=0.74u l=0.2u
X3261 VSS.t600 a_4187_1764.t101 a_26911_14024# VSS.t796 sg13_lv_nmos ad=0.2516p pd=2.16u as=0.1406p ps=1.12u w=0.74u l=0.6u
X3262 a_1721_7085# a_1256_6734# VDD.t1133 VDD.t67 sg13_lv_pmos ad=0.1596p pd=1.22u as=0.2856p ps=2.36u w=0.84u l=0.13u
X3263 a_16271_17497# a_16033_16869# a_16163_16869# VDD.t368 sg13_lv_pmos ad=0.2128p pd=1.5u as=0.3808p ps=2.92u w=1.12u l=0.2u
X3264 a_13470_16071# a_3747_16074.t6 a_15755_16071# VSS.t477 sg13_lv_nmos ad=0.2516p pd=2.16u as=0.1406p ps=1.12u w=0.74u l=0.13u
X3265 VDD.t1314 a_2873_4240# a_3171_3892.t0 VDD.t0 sg13_lv_pmos ad=0.4256p pd=3u as=0.2128p ps=1.5u w=1.12u l=0.13u
X3266 VSS.t346 VDD.t1653 VSS.t346 VSS.t349 sg13_lv_nmos ad=0.1428p pd=1.52u as=0 ps=0 w=0.42u l=1u
X3267 a_13470_6734# a_14964_6698# a_14888_6734# VDD.t67 sg13_lv_pmos ad=0.3808p pd=2.92u as=0.2128p ps=1.5u w=1.12u l=0.13u
X3268 VDD.t1 a_2019_3156.t2 a_17865_3364# VDD.t0 sg13_lv_pmos ad=0.3808p pd=2.92u as=0.3808p ps=2.92u w=1.12u l=0.13u
X3269 a_7288_3889# a_6717_4687# VDD.t350 VDD.t0 sg13_lv_pmos ad=0.2128p pd=1.5u as=0.3808p ps=2.92u w=1.12u l=0.13u
X3270 VDD.t1254 a_1544_16071# a_1721_16422# VDD.t90 sg13_lv_pmos ad=0.1918p pd=1.5u as=0.1596p ps=1.22u w=0.84u l=0.13u
X3271 VSS.t643 a_4187_1764.t107 a_22351_14024# VSS.t1545 sg13_lv_nmos ad=0.2516p pd=2.16u as=0.1406p ps=1.12u w=0.74u l=0.6u
X3272 VDD.t1071 a_25283_1842# a_25717_1842# VDD.t373 sg13_lv_pmos ad=0.2128p pd=1.5u as=0.3808p ps=2.92u w=1.12u l=0.13u
X3273 VDD.t1360 a_27237_16869# a_27705_16071# VDD.t90 sg13_lv_pmos ad=0.252p pd=1.57u as=0.3808p ps=2.92u w=1.12u l=0.13u
X3274 a_13368_13226# a_12797_14024# VDD.t1302 VDD.t5 sg13_lv_pmos ad=0.2128p pd=1.5u as=0.3808p ps=2.92u w=1.12u l=0.13u
X3275 VDD.t188 VSS.t278 VDD.t187 VDD.t5 sg13_lv_pmos ad=0.34p pd=2.68u as=0 ps=0 w=1u l=1u
X3276 VSS.t167 a_10517_4687# a_10985_3889# VSS.t166 sg13_lv_nmos ad=0.1665p pd=1.19u as=0.2516p ps=2.16u w=0.74u l=0.13u
X3277 VDD.t657 a_4187_2434# a_17031_17497# VDD.t368 sg13_lv_pmos ad=0.3808p pd=2.92u as=0.2128p ps=1.5u w=1.12u l=0.6u
X3278 VDD.t301 VSS.t229 VDD.t300 VDD.t90 sg13_lv_pmos ad=0.34p pd=2.68u as=0 ps=0 w=1u l=1u
X3279 a_10951_14652# a_10713_14024# a_10843_14024# VDD.t374 sg13_lv_pmos ad=0.2128p pd=1.5u as=0.3808p ps=2.92u w=1.12u l=0.2u
X3280 a_15273_14024# a_15077_14024# VDD.t769 VDD.t374 sg13_lv_pmos ad=0.3808p pd=2.92u as=0.2128p ps=1.5u w=1.12u l=0.13u
X3281 VSS.t55 a_6126_9506# a_5974_11413# VSS.t49 sg13_lv_nmos ad=0.76p pd=4.76u as=0.38p ps=2.38u w=2u l=1u
X3282 a_17553_7532# a_17357_7532# VSS.t144 VSS.t143 sg13_lv_nmos ad=0.2516p pd=2.16u as=0.1406p ps=1.12u w=0.74u l=0.13u
X3283 VDD.t1387 a_22677_16869# a_23145_16071# VDD.t90 sg13_lv_pmos ad=0.252p pd=1.57u as=0.3808p ps=2.92u w=1.12u l=0.13u
X3284 a_8671_7532# a_8433_7532# a_8563_7532# VSS.t1567 sg13_lv_nmos ad=0.1406p pd=1.12u as=0.2516p ps=2.16u w=0.74u l=0.2u
X3285 VDD.t620 a_4187_2434# a_5631_2470# VDD.t373 sg13_lv_pmos ad=0.3808p pd=2.92u as=0.2128p ps=1.5u w=1.12u l=0.6u
X3286 VDD.t1525 a_2019_6737.t2 a_25604_6698# VDD.t67 sg13_lv_pmos ad=0.3808p pd=2.92u as=0.3808p ps=2.92u w=1.12u l=0.13u
X3287 a_20968_16071# a_20397_16869# VDD.t1461 VDD.t90 sg13_lv_pmos ad=0.2128p pd=1.5u as=0.3808p ps=2.92u w=1.12u l=0.13u
X3288 a_16510_13226# a_18871_13190# a_18795_13226# VDD.t5 sg13_lv_pmos ad=0.3808p pd=2.92u as=0.2128p ps=1.5u w=1.12u l=0.13u
X3289 a_10232_11561# a_10751_11568# a_11491_11918# VSS.t1829 sg13_lv_nmos ad=0.3473p pd=2.71u as=0.12665p ps=1.145u w=0.74u l=0.13u
X3290 a_26395_1044# a_26185_1044# VDD.t775 VDD.t2 sg13_lv_pmos ad=0.2128p pd=1.5u as=0.252p ps=1.57u w=1.12u l=0.13u
X3291 a_24393_16869# a_24197_16869# VSS.t72 VSS.t71 sg13_lv_nmos ad=0.2516p pd=2.16u as=0.1406p ps=1.12u w=0.74u l=0.13u
X3292 VSS.t86 VDD.t1651 VSS.t86 VSS.t353 sg13_lv_nmos ad=0.1428p pd=1.52u as=0 ps=0 w=0.42u l=1u
X3293 VSS.t35 a_12363_4687# a_12797_4687# VSS.t34 sg13_lv_nmos ad=0.1406p pd=1.12u as=0.2516p ps=2.16u w=0.74u l=0.13u
X3294 a_22590_3889# a_24951_3853# a_24875_3889# VDD.t0 sg13_lv_pmos ad=0.3808p pd=2.92u as=0.2128p ps=1.5u w=1.12u l=0.13u
X3295 VDD.t581 a_1544_3889# a_2297_4240# VDD.t0 sg13_lv_pmos ad=0.1918p pd=1.5u as=0.1596p ps=1.22u w=0.84u l=0.13u
X3296 VSS.t1293 a_17683_16869# a_18117_16869# VSS.t2314 sg13_lv_nmos ad=0.1406p pd=1.12u as=0.2516p ps=2.16u w=0.74u l=0.13u
X3297 a_1256_13226# CHAN1_MUX_SEL0 VDD.t902 VDD.t5 sg13_lv_pmos ad=0.3808p pd=2.92u as=0.3808p ps=2.92u w=1.12u l=0.13u
X3298 VDD.t340 VSS.t188 VDD.t338 VDD.t90 sg13_lv_pmos ad=0.19p pd=1.38u as=0 ps=0 w=1u l=1u
X3299 a_13470_13226# a_14311_13190# a_14235_13226# VDD.t5 sg13_lv_pmos ad=0.3808p pd=2.92u as=0.2128p ps=1.5u w=1.12u l=0.13u
X3300 VDD.t1611 a_3747_1047.t3 a_24951_1008# VDD.t2 sg13_lv_pmos ad=0.3808p pd=2.92u as=0.3808p ps=2.92u w=1.12u l=0.13u
X3301 a_1256_3134# CHAN2_MUX_SEL2 VDD.t526 VDD.t0 sg13_lv_pmos ad=0.3808p pd=2.92u as=0.3808p ps=2.92u w=1.12u l=0.13u
X3302 a_2595_6001.t1 a_2297_6021# VSS.t1142 VSS.t1795 sg13_lv_nmos ad=0.1406p pd=1.12u as=0.1331p ps=1.12u w=0.74u l=0.13u
X3303 VSS.t1199 a_4187_1764.t141 a_20831_16869# VSS.t2385 sg13_lv_nmos ad=0.2516p pd=2.16u as=0.1406p ps=1.12u w=0.74u l=0.6u
X3304 a_2019_3892.t0 a_1721_4240# VDD.t580 VDD.t0 sg13_lv_pmos ad=0.2128p pd=1.5u as=0.1918p ps=1.5u w=1.12u l=0.13u
X3305 VDD.t468 VDD.t466 VDD.t467 VDD.t346 sg13_lv_pmos ad=0.3808p pd=2.92u as=0 ps=0 w=1.12u l=0.13u
X3306 a_6153_14024# a_5957_14024# VSS.t1936 VSS.t2130 sg13_lv_nmos ad=0.2516p pd=2.16u as=0.1406p ps=1.12u w=0.74u l=0.13u
X3307 a_26911_8160# a_26673_7532# a_26803_7532# VDD.t346 sg13_lv_pmos ad=0.2128p pd=1.5u as=0.3808p ps=2.92u w=1.12u l=0.2u
X3308 VDD.t1459 a_19203_16869# a_19637_16869# VDD.t368 sg13_lv_pmos ad=0.2128p pd=1.5u as=0.3808p ps=2.92u w=1.12u l=0.13u
X3309 a_21835_6734# a_21625_6734# VDD.t345 VDD.t67 sg13_lv_pmos ad=0.2128p pd=1.5u as=0.252p ps=1.57u w=1.12u l=0.13u
X3310 a_19550_16071# a_21911_16035# a_21835_16071# VDD.t90 sg13_lv_pmos ad=0.3808p pd=2.92u as=0.2128p ps=1.5u w=1.12u l=0.13u
X3311 VDD.t1179 a_3171_13229.t8 a_8884_13190# VDD.t5 sg13_lv_pmos ad=0.3808p pd=2.92u as=0.3808p ps=2.92u w=1.12u l=0.13u
X3312 VDD.t147 VSS.t299 VDD.t197 VDD.t5 sg13_lv_pmos ad=0.34p pd=2.68u as=0 ps=0 w=1u l=1u
X3313 a_7390_6734# a_2019_6737.t8 a_7288_6734# VSS.t2254 sg13_lv_nmos ad=0.2516p pd=2.16u as=0.1406p ps=1.12u w=0.74u l=0.13u
X3314 VDD.t15 VSS.t453 VDD.t9 VDD.t2 sg13_lv_pmos ad=0.19p pd=1.38u as=0 ps=0 w=1u l=1u
X3315 VDD.t144 VSS.t379 VDD.t142 VDD.t0 sg13_lv_pmos ad=0.19p pd=1.38u as=0 ps=0 w=1u l=1u
X3316 a_5731_15316# a_3747_15338.t3 a_13470_16071# VSS.t1548 sg13_lv_nmos ad=0.2516p pd=2.16u as=0.2516p ps=2.16u w=0.74u l=0.13u
X3317 VDD.t1041 a_2595_6737.t4 a_20391_6698# VDD.t67 sg13_lv_pmos ad=0.3808p pd=2.92u as=0.3808p ps=2.92u w=1.12u l=0.13u
X3318 VDD.t1437 a_1721_3176# a_2019_3156.t0 VDD.t0 sg13_lv_pmos ad=0.4256p pd=3u as=0.2128p ps=1.5u w=1.12u l=0.13u
X3319 a_21353_7532# a_21157_7532# VSS.t18 VSS.t17 sg13_lv_nmos ad=0.2516p pd=2.16u as=0.1406p ps=1.12u w=0.74u l=0.13u
X3320 a_24008_1044# a_23437_1842# VDD.t1355 VDD.t2 sg13_lv_pmos ad=0.2128p pd=1.5u as=0.3808p ps=2.92u w=1.12u l=0.13u
X3321 CHAN2_DELAY_OUT_LAST a_27997_4687# VDD.t1029 VDD.t348 sg13_lv_pmos ad=0.3808p pd=2.92u as=0.2128p ps=1.5u w=1.12u l=0.13u
X3322 a_13991_1842# a_13753_1842# a_13883_1842# VSS.t935 sg13_lv_nmos ad=0.1406p pd=1.12u as=0.2516p ps=2.16u w=0.74u l=0.2u
X3323 VDD.t1160 a_25717_4687# a_26185_3889# VDD.t0 sg13_lv_pmos ad=0.252p pd=1.57u as=0.3808p ps=2.92u w=1.12u l=0.13u
X3324 a_1815_12513# a_1256_12471# a_1721_12513# VSS.t1582 sg13_lv_nmos ad=0.1216p pd=1.02u as=0.2176p ps=1.96u w=0.64u l=0.13u
X3325 VSS.t868 a_7043_7532# a_7477_7532# VSS.t1771 sg13_lv_nmos ad=0.1406p pd=1.12u as=0.2516p ps=2.16u w=0.74u l=0.13u
X3326 VDD.t393 a_10517_7532# a_10985_6734# VDD.t67 sg13_lv_pmos ad=0.252p pd=1.57u as=0.3808p ps=2.92u w=1.12u l=0.13u
X3327 VSS.t1289 a_2019_1047.t4 a_19524_1008# VSS.t2006 sg13_lv_nmos ad=0.2516p pd=2.16u as=0.2516p ps=2.16u w=0.74u l=0.13u
X3328 VSS.t1513 a_3747_3892.t5 a_18871_3853# VSS.t1628 sg13_lv_nmos ad=0.2516p pd=2.16u as=0.2516p ps=2.16u w=0.74u l=0.13u
X3329 a_4633_16869# a_4437_16869# VSS.t879 VSS.t878 sg13_lv_nmos ad=0.2516p pd=2.16u as=0.1406p ps=1.12u w=0.74u l=0.13u
X3330 VDD.t66 VSS.t425 VDD.t29 VDD.t2 sg13_lv_pmos ad=0.19p pd=1.38u as=0 ps=0 w=1u l=1u
X3331 VDD.t1036 a_13557_16869# a_14025_16071# VDD.t90 sg13_lv_pmos ad=0.252p pd=1.57u as=0.3808p ps=2.92u w=1.12u l=0.13u
X3332 VDD.t110 VSS.t241 VDD.t74 VDD.t5 sg13_lv_pmos ad=0.19p pd=1.38u as=0 ps=0 w=1u l=1u
X3333 VDD.t695 a_4187_2434# a_15511_8160# VDD.t346 sg13_lv_pmos ad=0.3808p pd=2.92u as=0.2128p ps=1.5u w=1.12u l=0.6u
X3334 VDD.t295 VSS.t346 VDD.t294 VDD.t67 sg13_lv_pmos ad=0.34p pd=2.68u as=0 ps=0 w=1u l=1u
X3335 VDD.t587 a_4437_4687# a_4905_3889# VDD.t0 sg13_lv_pmos ad=0.252p pd=1.57u as=0.3808p ps=2.92u w=1.12u l=0.13u
X3336 a_6913_4687# a_6717_4687# VDD.t349 VDD.t348 sg13_lv_pmos ad=0.3808p pd=2.92u as=0.2128p ps=1.5u w=1.12u l=0.13u
X3337 a_16108_12471# a_17865_12701# a_16510_13226# VDD.t5 sg13_lv_pmos ad=0.3808p pd=2.92u as=0.3808p ps=2.92u w=1.12u l=0.13u
X3338 a_15964_12471# a_15765_12645# a_5731_12471# VSS.t66 sg13_lv_nmos ad=0.2183p pd=1.33u as=0.2516p ps=2.16u w=0.74u l=0.13u
X3339 VDD.t726 a_4187_2434# a_18551_5315# VDD.t348 sg13_lv_pmos ad=0.3808p pd=2.92u as=0.2128p ps=1.5u w=1.12u l=0.6u
X3340 a_16271_14652# a_16033_14024# a_16163_14024# VDD.t374 sg13_lv_pmos ad=0.2128p pd=1.5u as=0.3808p ps=2.92u w=1.12u l=0.2u
X3341 VSS.t1276 a_9444_10280# a_9444_9602# VSS.t1270 sg13_lv_nmos ad=0.68p pd=4.68u as=0.38p ps=2.38u w=2u l=1u
X3342 VSS.t1826 CHAN3_MUX_SEL1 a_3543_1395# VSS.t2136 sg13_lv_nmos ad=0.1331p pd=1.12u as=0.1216p ps=1.02u w=0.64u l=0.13u
X3343 a_4157_4158# CHAN2_DELAY_IN VSS.t925 VSS.t1493 sg13_lv_nmos ad=0.2516p pd=2.16u as=0.2553p ps=2.17u w=0.74u l=0.13u
X3344 a_16793_1842# a_16597_1842# VDD.t811 VDD.t373 sg13_lv_pmos ad=0.3808p pd=2.92u as=0.2128p ps=1.5u w=1.12u l=0.13u
X3345 a_2391_15358# CHAN0_MUX_SEL2 a_2297_15358# VSS.t760 sg13_lv_nmos ad=0.1216p pd=1.02u as=0.2176p ps=1.96u w=0.64u l=0.13u
X3346 a_7911_2470# a_7673_1842# a_7803_1842# VDD.t373 sg13_lv_pmos ad=0.2128p pd=1.5u as=0.3808p ps=2.92u w=1.12u l=0.2u
X3347 VSS.t312 VDD.t1667 VSS.t312 VSS.t313 sg13_lv_nmos ad=79.8f pd=0.8u as=0 ps=0 w=0.42u l=1u
X3348 VSS.t674 a_4187_1764.t153 a_11711_16869# VSS.t2138 sg13_lv_nmos ad=0.2516p pd=2.16u as=0.1406p ps=1.12u w=0.74u l=0.6u
X3349 VDD.t414 a_25283_7532# a_25717_7532# VDD.t346 sg13_lv_pmos ad=0.2128p pd=1.5u as=0.3808p ps=2.92u w=1.12u l=0.13u
X3350 a_12715_3889# a_12505_3889# VSS.t687 VSS.t1851 sg13_lv_nmos ad=0.1406p pd=1.12u as=0.1665p ps=1.19u w=0.74u l=0.13u
X3351 a_16793_16869# a_16597_16869# VDD.t1078 VDD.t368 sg13_lv_pmos ad=0.3808p pd=2.92u as=0.2128p ps=1.5u w=1.12u l=0.13u
X3352 VDD.t678 a_4187_2434# a_17031_14652# VDD.t374 sg13_lv_pmos ad=0.3808p pd=2.92u as=0.2128p ps=1.5u w=1.12u l=0.6u
X3353 a_15755_1044# a_15545_1044# VSS.t1213 VSS.t1332 sg13_lv_nmos ad=0.1406p pd=1.12u as=0.1665p ps=1.19u w=0.74u l=0.13u
X3354 a_17928_3889# a_17357_4687# VSS.t957 VSS.t1344 sg13_lv_nmos ad=0.1406p pd=1.12u as=0.2516p ps=2.16u w=0.74u l=0.13u
X3355 a_16271_4687# a_16033_4687# a_16163_4687# VSS.t942 sg13_lv_nmos ad=0.1406p pd=1.12u as=0.2516p ps=2.16u w=0.74u l=0.2u
X3356 a_25391_16869# a_25153_16869# a_25283_16869# VSS.t774 sg13_lv_nmos ad=0.1406p pd=1.12u as=0.2516p ps=2.16u w=0.74u l=0.2u
X3357 VDD.t864 a_1256_13226# a_2873_13577# VDD.t5 sg13_lv_pmos ad=0.1918p pd=1.5u as=0.1596p ps=1.22u w=0.84u l=0.13u
X3358 a_10430_16071# a_12791_16035# a_12715_16071# VDD.t90 sg13_lv_pmos ad=0.3808p pd=2.92u as=0.2128p ps=1.5u w=1.12u l=0.13u
X3359 VDD.t1200 a_3171_3892.t8 a_8884_3853# VDD.t0 sg13_lv_pmos ad=0.3808p pd=2.92u as=0.3808p ps=2.92u w=1.12u l=0.13u
X3360 a_19550_3889# a_3171_3892.t4 a_20968_3889# VSS.t1734 sg13_lv_nmos ad=0.2516p pd=2.16u as=0.1406p ps=1.12u w=0.74u l=0.13u
X3361 a_12233_16869# a_12037_16869# VDD.t555 VDD.t368 sg13_lv_pmos ad=0.3808p pd=2.92u as=0.2128p ps=1.5u w=1.12u l=0.13u
X3362 VDD.t698 a_4187_2434# a_5631_8160# VDD.t346 sg13_lv_pmos ad=0.3808p pd=2.92u as=0.2128p ps=1.5u w=1.12u l=0.6u
X3363 VSS.t736 a_2595_1047.t6 a_14311_1008# VSS.t735 sg13_lv_nmos ad=0.2516p pd=2.16u as=0.2516p ps=2.16u w=0.74u l=0.13u
X3364 a_2595_1047.t0 a_2297_1395# VDD.t797 VDD.t2 sg13_lv_pmos ad=0.2128p pd=1.5u as=0.1918p ps=1.5u w=1.12u l=0.13u
X3365 VSS.t216 VDD.t1694 VSS.t216 VSS.t215 sg13_lv_nmos ad=0.1428p pd=1.52u as=0 ps=0 w=0.42u l=1u
X3366 VSS.t1872 a_10843_14024# a_11277_14024# VSS.t1959 sg13_lv_nmos ad=0.1406p pd=1.12u as=0.2516p ps=2.16u w=0.74u l=0.13u
X3367 VSS.t877 a_4187_1764.t134 a_26151_16869# VSS.t876 sg13_lv_nmos ad=0.2516p pd=2.16u as=0.1406p ps=1.12u w=0.74u l=0.6u
X3368 a_1256_1044# CHAN3_MUX_SEL0 VDD.t1413 VDD.t2 sg13_lv_pmos ad=0.3808p pd=2.92u as=0.3808p ps=2.92u w=1.12u l=0.13u
X3369 a_7151_14024# a_6913_14024# a_7043_14024# VSS.t1309 sg13_lv_nmos ad=0.1406p pd=1.12u as=0.2516p ps=2.16u w=0.74u l=0.2u
X3370 VSS.t124 a_12363_1842# a_12797_1842# VSS.t1972 sg13_lv_nmos ad=0.1406p pd=1.12u as=0.2516p ps=2.16u w=0.74u l=0.13u
X3371 a_5115_1044# a_4905_1044# VSS.t1593 VSS.t1592 sg13_lv_nmos ad=0.1406p pd=1.12u as=0.1665p ps=1.19u w=0.74u l=0.13u
X3372 a_7288_3889# a_6717_4687# VSS.t22 VSS.t21 sg13_lv_nmos ad=0.1406p pd=1.12u as=0.2516p ps=2.16u w=0.74u l=0.13u
X3373 VDD.t801 a_2019_16074.t8 a_7364_16035# VDD.t90 sg13_lv_pmos ad=0.3808p pd=2.92u as=0.3808p ps=2.92u w=1.12u l=0.13u
X3374 VSS.t326 VDD.t1661 VSS.t326 VSS.t325 sg13_lv_nmos ad=0.1428p pd=1.52u as=0 ps=0 w=0.42u l=1u
X3375 VDD.t718 a_4187_2434# a_22351_5315# VDD.t348 sg13_lv_pmos ad=0.3808p pd=2.92u as=0.2128p ps=1.5u w=1.12u l=0.6u
X3376 VSS.t195 VDD.t1701 VSS.t195 VSS.t199 sg13_lv_nmos ad=0.1428p pd=1.52u as=0 ps=0 w=0.42u l=1u
X3377 VDD.t1118 a_27563_1842# a_27997_1842# VDD.t373 sg13_lv_pmos ad=0.2128p pd=1.5u as=0.3808p ps=2.92u w=1.12u l=0.13u
X3378 a_5731_5979# a_5705_6209# a_4350_6734# VDD.t67 sg13_lv_pmos ad=0.3808p pd=2.92u as=0.3808p ps=2.92u w=1.12u l=0.13u
X3379 a_20593_1842# a_20397_1842# VDD.t521 VDD.t373 sg13_lv_pmos ad=0.3808p pd=2.92u as=0.2128p ps=1.5u w=1.12u l=0.13u
X3380 VDD.t861 a_19203_14024# a_19637_14024# VDD.t374 sg13_lv_pmos ad=0.2128p pd=1.5u as=0.3808p ps=2.92u w=1.12u l=0.13u
X3381 VDD.t1206 a_3747_6737.t5 a_18871_6698# VDD.t67 sg13_lv_pmos ad=0.3808p pd=2.92u as=0.3808p ps=2.92u w=1.12u l=0.13u
X3382 a_2967_3176# CHAN2_MUX_SEL3 a_2873_3176# VSS.t923 sg13_lv_nmos ad=0.1216p pd=1.02u as=0.2176p ps=1.96u w=0.64u l=0.13u
X3383 VSS.t1295 a_18117_16869# a_18585_16071# VSS.t1294 sg13_lv_nmos ad=0.1665p pd=1.19u as=0.2516p ps=2.16u w=0.74u l=0.13u
X3384 a_1721_1395# a_1256_1044# VDD.t398 VDD.t2 sg13_lv_pmos ad=0.1596p pd=1.22u as=0.2856p ps=2.36u w=0.84u l=0.13u
X3385 a_20071_4687# a_19833_4687# a_19963_4687# VSS.t2219 sg13_lv_nmos ad=0.1406p pd=1.12u as=0.2516p ps=2.16u w=0.74u l=0.2u
X3386 VSS.t841 a_15077_14024# a_15545_13226# VSS.t840 sg13_lv_nmos ad=0.1665p pd=1.19u as=0.2516p ps=2.16u w=0.74u l=0.13u
X3387 a_13470_1044# a_14964_1008# a_14888_1044# VDD.t2 sg13_lv_pmos ad=0.3808p pd=2.92u as=0.2128p ps=1.5u w=1.12u l=0.13u
X3388 VDD.t1046 a_6283_1842# a_6717_1842# VDD.t373 sg13_lv_pmos ad=0.2128p pd=1.5u as=0.3808p ps=2.92u w=1.12u l=0.13u
X3389 a_22590_3889# a_3747_3892.t3 a_24875_3889# VSS.t1684 sg13_lv_nmos ad=0.2516p pd=2.16u as=0.1406p ps=1.12u w=0.74u l=0.13u
X3390 a_27915_3889# a_27705_3889# VDD.t1289 VDD.t0 sg13_lv_pmos ad=0.2128p pd=1.5u as=0.252p ps=1.57u w=1.12u l=0.13u
X3391 VSS.t1342 a_14643_4687# a_15077_4687# VSS.t2361 sg13_lv_nmos ad=0.1406p pd=1.12u as=0.2516p ps=2.16u w=0.74u l=0.13u
X3392 VSS.t1203 a_3171_16074.t2 a_27124_16035# VSS.t1202 sg13_lv_nmos ad=0.2516p pd=2.16u as=0.2516p ps=2.16u w=0.74u l=0.13u
X3393 a_13991_7532# a_13753_7532# a_13883_7532# VSS.t917 sg13_lv_nmos ad=0.1406p pd=1.12u as=0.2516p ps=2.16u w=0.74u l=0.2u
X3394 a_11848_16071# a_11277_16869# VSS.t664 VSS.t1454 sg13_lv_nmos ad=0.1406p pd=1.12u as=0.2516p ps=2.16u w=0.74u l=0.13u
X3395 a_2019_13229.t0 a_1721_13577# VDD.t958 VDD.t5 sg13_lv_pmos ad=0.2128p pd=1.5u as=0.1918p ps=1.5u w=1.12u l=0.13u
X3396 a_12715_6734# a_12505_6734# VDD.t415 VDD.t67 sg13_lv_pmos ad=0.2128p pd=1.5u as=0.252p ps=1.57u w=1.12u l=0.13u
X3397 VSS.t1560 a_3171_13229.t3 a_24084_13190# VSS.t1559 sg13_lv_nmos ad=0.2516p pd=2.16u as=0.2516p ps=2.16u w=0.74u l=0.13u
X3398 VSS.t435 VDD.t1625 VSS.t434 VSS.t433 sg13_lv_nmos ad=0.1428p pd=1.52u as=0 ps=0 w=0.42u l=1u
X3399 a_4157_16340# CHAN0_DELAY_IN VDD.t1233 VDD.t90 sg13_lv_pmos ad=0.3808p pd=2.92u as=0.3808p ps=2.92u w=1.12u l=0.13u
X3400 VSS.t651 a_2019_6737.t4 a_19524_6698# VSS.t1714 sg13_lv_nmos ad=0.2516p pd=2.16u as=0.2516p ps=2.16u w=0.74u l=0.13u
X3401 a_17928_6734# a_17357_7532# VDD.t396 VDD.t67 sg13_lv_pmos ad=0.2128p pd=1.5u as=0.3808p ps=2.92u w=1.12u l=0.13u
X3402 VSS.t202 VDD.t1699 VSS.t202 VSS.t205 sg13_lv_nmos ad=79.8f pd=0.8u as=0 ps=0 w=0.42u l=1u
X3403 VDD.t825 a_2019_1047.t2 a_25604_1008# VDD.t2 sg13_lv_pmos ad=0.3808p pd=2.92u as=0.3808p ps=2.92u w=1.12u l=0.13u
X3404 VDD.t124 VSS.t395 VDD.t123 VDD.t0 sg13_lv_pmos ad=0.34p pd=2.68u as=0 ps=0 w=1u l=1u
X3405 a_17791_17497# a_17553_16869# a_17683_16869# VDD.t368 sg13_lv_pmos ad=0.2128p pd=1.5u as=0.3808p ps=2.92u w=1.12u l=0.2u
X3406 a_19550_6734# a_21044_6698# a_20968_6734# VDD.t67 sg13_lv_pmos ad=0.3808p pd=2.92u as=0.2128p ps=1.5u w=1.12u l=0.13u
X3407 VDD.t164 VSS.t312 VDD.t162 VDD.t67 sg13_lv_pmos ad=0.19p pd=1.38u as=0 ps=0 w=1u l=1u
X3408 VSS.t1299 a_4187_1764.t105 a_23871_14024# VSS.t1697 sg13_lv_nmos ad=0.2516p pd=2.16u as=0.1406p ps=1.12u w=0.74u l=0.6u
X3409 VDD.t772 a_16597_14024# a_17065_13226# VDD.t5 sg13_lv_pmos ad=0.252p pd=1.57u as=0.3808p ps=2.92u w=1.12u l=0.13u
X3410 VSS.t1446 REF_MUX_SEL1 a_3543_7085# VSS.t2297 sg13_lv_nmos ad=0.1331p pd=1.12u as=0.1216p ps=1.02u w=0.64u l=0.13u
X3411 a_14888_13226# a_14317_14024# VDD.t930 VDD.t5 sg13_lv_pmos ad=0.2128p pd=1.5u as=0.3808p ps=2.92u w=1.12u l=0.13u
X3412 a_16793_7532# a_16597_7532# VDD.t1142 VDD.t346 sg13_lv_pmos ad=0.3808p pd=2.92u as=0.2128p ps=1.5u w=1.12u l=0.13u
X3413 VDD.t662 a_4187_2434# a_18551_17497# VDD.t368 sg13_lv_pmos ad=0.3808p pd=2.92u as=0.2128p ps=1.5u w=1.12u l=0.6u
X3414 a_7911_8160# a_7673_7532# a_7803_7532# VDD.t346 sg13_lv_pmos ad=0.2128p pd=1.5u as=0.3808p ps=2.92u w=1.12u l=0.2u
X3415 a_7288_6734# a_6717_7532# VDD.t383 VDD.t67 sg13_lv_pmos ad=0.2128p pd=1.5u as=0.3808p ps=2.92u w=1.12u l=0.13u
X3416 VSS.t1621 a_25717_4687# a_26185_3889# VSS.t1620 sg13_lv_nmos ad=0.1665p pd=1.19u as=0.2516p ps=2.16u w=0.74u l=0.13u
X3417 a_2391_12513# CHAN1_MUX_SEL2 a_2297_12513# VSS.t2140 sg13_lv_nmos ad=0.1216p pd=1.02u as=0.2176p ps=1.96u w=0.64u l=0.13u
X3418 a_9712_9602# a_6854_11144# a_9444_9602# VSS.t135 sg13_lv_nmos ad=0.38p pd=2.38u as=0.68p ps=4.68u w=2u l=1u
X3419 VSS.t856 a_4187_1764.t47 a_17791_4687# VSS.t861 sg13_lv_nmos ad=0.2516p pd=2.16u as=0.1406p ps=1.12u w=0.74u l=0.6u
X3420 a_19833_4687# a_19637_4687# VDD.t501 VDD.t348 sg13_lv_pmos ad=0.3808p pd=2.92u as=0.2128p ps=1.5u w=1.12u l=0.13u
X3421 a_16793_14024# a_16597_14024# VDD.t771 VDD.t374 sg13_lv_pmos ad=0.3808p pd=2.92u as=0.2128p ps=1.5u w=1.12u l=0.13u
X3422 VSS.t294 a_3171_12493.t2 a_23945_12701# VSS.t992 sg13_lv_nmos ad=0.2516p pd=2.16u as=0.2516p ps=2.16u w=0.74u l=0.13u
X3423 a_15755_6734# a_15545_6734# VSS.t1021 VSS.t1625 sg13_lv_nmos ad=0.1406p pd=1.12u as=0.1665p ps=1.19u w=0.74u l=0.13u
X3424 a_16271_1842# a_16033_1842# a_16163_1842# VSS.t1421 sg13_lv_nmos ad=0.1406p pd=1.12u as=0.2516p ps=2.16u w=0.74u l=0.2u
X3425 VSS.t570 a_3747_13229.t5 a_18871_13190# VSS.t569 sg13_lv_nmos ad=0.2516p pd=2.16u as=0.2516p ps=2.16u w=0.74u l=0.13u
X3426 a_10328_13226# a_9757_14024# VDD.t1107 VDD.t5 sg13_lv_pmos ad=0.2128p pd=1.5u as=0.3808p ps=2.92u w=1.12u l=0.13u
X3427 a_21835_1044# a_21625_1044# VDD.t600 VDD.t2 sg13_lv_pmos ad=0.2128p pd=1.5u as=0.252p ps=1.57u w=1.12u l=0.13u
X3428 VDD.t370 a_24197_16869# a_24665_16071# VDD.t90 sg13_lv_pmos ad=0.252p pd=1.57u as=0.3808p ps=2.92u w=1.12u l=0.13u
X3429 a_12233_14024# a_12037_14024# VDD.t953 VDD.t374 sg13_lv_pmos ad=0.3808p pd=2.92u as=0.2128p ps=1.5u w=1.12u l=0.13u
X3430 VSS.t63 a_2595_6737.t6 a_14311_6698# VSS.t1434 sg13_lv_nmos ad=0.2516p pd=2.16u as=0.2516p ps=2.16u w=0.74u l=0.13u
X3431 VSS.t757 a_4437_4687# a_4905_3889# VSS.t756 sg13_lv_nmos ad=0.1665p pd=1.19u as=0.2516p ps=2.16u w=0.74u l=0.13u
X3432 a_25913_16869# a_25717_16869# VSS.t2186 VSS.t2323 sg13_lv_nmos ad=0.2516p pd=2.16u as=0.1406p ps=1.12u w=0.74u l=0.13u
X3433 VDD.t575 a_2595_1047.t4 a_20391_1008# VDD.t2 sg13_lv_pmos ad=0.3808p pd=2.92u as=0.3808p ps=2.92u w=1.12u l=0.13u
X3434 VDD.t238 VSS.t403 VDD.t323 VDD.t2 sg13_lv_pmos ad=0.34p pd=2.68u as=0 ps=0 w=1u l=1u
X3435 a_24631_5315# a_24393_4687# a_24523_4687# VDD.t348 sg13_lv_pmos ad=0.2128p pd=1.5u as=0.3808p ps=2.92u w=1.12u l=0.2u
X3436 a_13121_11521# a_15688_11557# VSS.t157 VSS.t156 sg13_lv_nmos ad=0.2516p pd=2.16u as=0.1406p ps=1.12u w=0.74u l=0.13u
X3437 a_9193_4687# a_8997_4687# VDD.t532 VDD.t348 sg13_lv_pmos ad=0.3808p pd=2.92u as=0.2128p ps=1.5u w=1.12u l=0.13u
X3438 VDD.t266 VSS.t326 VDD.t265 VDD.t67 sg13_lv_pmos ad=0.34p pd=2.68u as=0 ps=0 w=1u l=1u
X3439 a_13470_13226# a_15831_13190# a_15755_13226# VDD.t5 sg13_lv_pmos ad=0.3808p pd=2.92u as=0.2128p ps=1.5u w=1.12u l=0.13u
X3440 VSS.t257 VDD.t1682 VSS.t260 VSS.t259 sg13_lv_nmos ad=79.8f pd=0.8u as=0 ps=0 w=0.42u l=1u
X3441 a_5778_9057# a_6126_9506# a_6326_10280# VSS.t46 sg13_lv_nmos ad=0.68p pd=4.68u as=0.38p ps=2.38u w=2u l=1u
X3442 VSS.t751 a_12363_7532# a_12797_7532# VSS.t852 sg13_lv_nmos ad=0.1406p pd=1.12u as=0.2516p ps=2.16u w=0.74u l=0.13u
X3443 VSS.t500 VSS.t498 VSS.t498 VSS.t499 sg13_lv_nmos ad=0.2516p pd=2.16u as=0 ps=0 w=0.74u l=0.13u
X3444 a_5115_6734# a_4905_6734# VSS.t38 VSS.t37 sg13_lv_nmos ad=0.1406p pd=1.12u as=0.1665p ps=1.19u w=0.74u l=0.13u
X3445 a_22590_6734# a_24951_6698# a_24875_6734# VDD.t67 sg13_lv_pmos ad=0.3808p pd=2.92u as=0.2128p ps=1.5u w=1.12u l=0.13u
X3446 a_21353_16869# a_21157_16869# VSS.t1199 VSS.t2240 sg13_lv_nmos ad=0.2516p pd=2.16u as=0.1406p ps=1.12u w=0.74u l=0.13u
X3447 VSS.t209 VDD.t1697 VSS.t209 VSS.t210 sg13_lv_nmos ad=79.8f pd=0.8u as=0 ps=0 w=0.42u l=1u
X3448 VSS.t1557 a_3171_13229.t6 a_14964_13190# VSS.t1556 sg13_lv_nmos ad=0.2516p pd=2.16u as=0.2516p ps=2.16u w=0.74u l=0.13u
X3449 a_5731_5979# a_3747_6001.t3 a_13470_6734# VSS.t1891 sg13_lv_nmos ad=0.2516p pd=2.16u as=0.2516p ps=2.16u w=0.74u l=0.13u
X3450 a_7673_14024# a_7477_14024# VSS.t1696 VSS.t1939 sg13_lv_nmos ad=0.2516p pd=2.16u as=0.1406p ps=1.12u w=0.74u l=0.13u
X3451 a_9444_9602# a_9444_10280# VSS.t1268 VSS.t1267 sg13_lv_nmos ad=0.38p pd=2.38u as=0.68p ps=4.68u w=2u l=1u
X3452 VSS.t824 a_4187_1764.t98 VSS.t822 VSS.t807 sg13_lv_nmos ad=1.33p pd=7.38u as=0 ps=0 w=7u l=7u
X3453 VSS.t780 a_21157_1842# a_21625_1044# VSS.t779 sg13_lv_nmos ad=0.1665p pd=1.19u as=0.2516p ps=2.16u w=0.74u l=0.13u
X3454 VDD.t1049 a_10517_1842# a_10985_1044# VDD.t2 sg13_lv_pmos ad=0.252p pd=1.57u as=0.3808p ps=2.92u w=1.12u l=0.13u
X3455 a_19073_1842# a_18877_1842# VDD.t1113 VDD.t373 sg13_lv_pmos ad=0.3808p pd=2.92u as=0.2128p ps=1.5u w=1.12u l=0.13u
X3456 VSS.t576 a_14643_16869# a_15077_16869# VSS.t1053 sg13_lv_nmos ad=0.1406p pd=1.12u as=0.2516p ps=2.16u w=0.74u l=0.13u
X3457 VDD.t419 a_27563_7532# a_27997_7532# VDD.t346 sg13_lv_pmos ad=0.2128p pd=1.5u as=0.3808p ps=2.92u w=1.12u l=0.13u
X3458 VSS.t247 a_2595_12493.t3 a_8745_12701# VSS.t988 sg13_lv_nmos ad=0.2516p pd=2.16u as=0.2516p ps=2.16u w=0.74u l=0.13u
X3459 a_5731_3134# a_5705_3364# a_4350_3889# VDD.t0 sg13_lv_pmos ad=0.3808p pd=2.92u as=0.3808p ps=2.92u w=1.12u l=0.13u
X3460 a_20593_7532# a_20397_7532# VDD.t564 VDD.t346 sg13_lv_pmos ad=0.3808p pd=2.92u as=0.2128p ps=1.5u w=1.12u l=0.13u
X3461 VSS.t1348 a_3171_3892.t8 a_8884_3853# VSS.t1731 sg13_lv_nmos ad=0.2516p pd=2.16u as=0.2516p ps=2.16u w=0.74u l=0.13u
X3462 VSS.t2071 a_4187_1764.t42 a_21591_4687# VSS.t2070 sg13_lv_nmos ad=0.2516p pd=2.16u as=0.1406p ps=1.12u w=0.74u l=0.6u
X3463 a_23633_4687# a_23437_4687# VDD.t910 VDD.t348 sg13_lv_pmos ad=0.3808p pd=2.92u as=0.2128p ps=1.5u w=1.12u l=0.13u
X3464 a_20071_1842# a_19833_1842# a_19963_1842# VSS.t1909 sg13_lv_nmos ad=0.1406p pd=1.12u as=0.2516p ps=2.16u w=0.74u l=0.2u
X3465 a_1815_331# a_1256_289# a_1721_331# VSS.t2204 sg13_lv_nmos ad=0.1216p pd=1.02u as=0.2176p ps=1.96u w=0.64u l=0.13u
X3466 VDD.t1522 a_3747_16074.t2 a_27991_16035# VDD.t90 sg13_lv_pmos ad=0.3808p pd=2.92u as=0.3808p ps=2.92u w=1.12u l=0.13u
X3467 VDD.t382 a_6283_7532# a_6717_7532# VDD.t346 sg13_lv_pmos ad=0.2128p pd=1.5u as=0.3808p ps=2.92u w=1.12u l=0.13u
X3468 VDD.t364 a_9323_4687# a_9757_4687# VDD.t348 sg13_lv_pmos ad=0.2128p pd=1.5u as=0.3808p ps=2.92u w=1.12u l=0.13u
X3469 VSS.t122 a_14643_1842# a_15077_1842# VSS.t1251 sg13_lv_nmos ad=0.1406p pd=1.12u as=0.2516p ps=2.16u w=0.74u l=0.13u
X3470 VSS.t506 VSS.t503 VSS.t505 VSS.t504 sg13_lv_nmos ad=0.2516p pd=2.16u as=0 ps=0 w=0.74u l=0.6u
X3471 VDD.t413 a_25717_7532# a_26185_6734# VDD.t67 sg13_lv_pmos ad=0.252p pd=1.57u as=0.3808p ps=2.92u w=1.12u l=0.13u
X3472 VSS.t593 a_4187_1764.t123 a_10191_14024# VSS.t746 sg13_lv_nmos ad=0.2516p pd=2.16u as=0.1406p ps=1.12u w=0.74u l=0.6u
X3473 VDD.t376 a_19203_1842# a_19637_1842# VDD.t373 sg13_lv_pmos ad=0.2128p pd=1.5u as=0.3808p ps=2.92u w=1.12u l=0.13u
X3474 a_16108_289# a_20905_519# a_19550_1044# VDD.t2 sg13_lv_pmos ad=0.3808p pd=2.92u as=0.3808p ps=2.92u w=1.12u l=0.13u
X3475 VSS.t2114 a_16851_3154# CHAN2_MUX_OUT VSS.t2115 sg13_lv_nmos ad=0.2516p pd=2.16u as=0.1406p ps=1.12u w=0.74u l=0.13u
X3476 VSS.t630 a_2019_1047.t9 a_4324_1008# VSS.t2001 sg13_lv_nmos ad=0.2516p pd=2.16u as=0.2516p ps=2.16u w=0.74u l=0.13u
X3477 VDD.t554 a_10517_16869# a_10985_16071# VDD.t90 sg13_lv_pmos ad=0.252p pd=1.57u as=0.3808p ps=2.92u w=1.12u l=0.13u
X3478 VSS.t2097 a_1544_15316# a_1815_15358# VSS.t1256 sg13_lv_nmos ad=0.1331p pd=1.12u as=0.1216p ps=1.02u w=0.64u l=0.13u
X3479 a_17791_14652# a_17553_14024# a_17683_14024# VDD.t374 sg13_lv_pmos ad=0.2128p pd=1.5u as=0.3808p ps=2.92u w=1.12u l=0.2u
X3480 VDD.t359 a_4437_7532# a_4905_6734# VDD.t67 sg13_lv_pmos ad=0.252p pd=1.57u as=0.3808p ps=2.92u w=1.12u l=0.13u
X3481 a_16510_1044# a_3747_1047.t5 a_18795_1044# VSS.t1287 sg13_lv_nmos ad=0.2516p pd=2.16u as=0.1406p ps=1.12u w=0.74u l=0.13u
X3482 VDD.t114 VSS.t358 VDD.t112 VDD.t0 sg13_lv_pmos ad=0.19p pd=1.38u as=0 ps=0 w=1u l=1u
X3483 a_16108_15316# a_17865_15546# a_16510_16071# VDD.t90 sg13_lv_pmos ad=0.3808p pd=2.92u as=0.3808p ps=2.92u w=1.12u l=0.13u
X3484 VSS.t552 VSS.t554 VSS.t556 VSS.t555 sg13_lv_nmos ad=0.1406p pd=1.12u as=0 ps=0 w=0.74u l=0.2u
X3485 a_27915_3889# a_27705_3889# VSS.t1885 VSS.t1884 sg13_lv_nmos ad=0.1406p pd=1.12u as=0.1665p ps=1.19u w=0.74u l=0.13u
X3486 VSS.t1611 CHAN2_MUX_SEL1 a_3543_4240# VSS.t1610 sg13_lv_nmos ad=0.1331p pd=1.12u as=0.1216p ps=1.02u w=0.64u l=0.13u
X3487 a_5731_12471# a_14825_12701# a_13470_13226# VDD.t5 sg13_lv_pmos ad=0.3808p pd=2.92u as=0.3808p ps=2.92u w=1.12u l=0.13u
X3488 VDD.t680 a_4187_2434# a_18551_14652# VDD.t374 sg13_lv_pmos ad=0.3808p pd=2.92u as=0.2128p ps=1.5u w=1.12u l=0.6u
X3489 VDD.t1299 a_8563_1842# a_8997_1842# VDD.t373 sg13_lv_pmos ad=0.2128p pd=1.5u as=0.3808p ps=2.92u w=1.12u l=0.13u
X3490 a_26911_16869# a_26673_16869# a_26803_16869# VSS.t584 sg13_lv_nmos ad=0.1406p pd=1.12u as=0.2516p ps=2.16u w=0.74u l=0.2u
X3491 VDD.t1389 a_3449_16422# a_3747_16074.t0 VDD.t90 sg13_lv_pmos ad=0.4256p pd=3u as=0.2128p ps=1.5u w=1.12u l=0.13u
X3492 VSS.t1217 a_4187_1764.t15 a_17791_1842# VSS.t1664 sg13_lv_nmos ad=0.2516p pd=2.16u as=0.1406p ps=1.12u w=0.74u l=0.6u
X3493 a_16271_7532# a_16033_7532# a_16163_7532# VSS.t1591 sg13_lv_nmos ad=0.1406p pd=1.12u as=0.2516p ps=2.16u w=0.74u l=0.2u
X3494 VSS.t411 VDD.t1631 VSS.t410 VSS.t409 sg13_lv_nmos ad=0.1428p pd=1.52u as=0 ps=0 w=0.42u l=1u
X3495 VDD.t621 a_4187_2434# a_13231_2470# VDD.t373 sg13_lv_pmos ad=0.3808p pd=2.92u as=0.2128p ps=1.5u w=1.12u l=0.6u
X3496 a_13753_16869# a_13557_16869# VDD.t1034 VDD.t368 sg13_lv_pmos ad=0.3808p pd=2.92u as=0.2128p ps=1.5u w=1.12u l=0.13u
X3497 VDD.t971 a_3747_1047.t5 a_18871_1008# VDD.t2 sg13_lv_pmos ad=0.3808p pd=2.92u as=0.3808p ps=2.92u w=1.12u l=0.13u
X3498 VSS.t929 a_12363_14024# a_12797_14024# VSS.t1206 sg13_lv_nmos ad=0.1406p pd=1.12u as=0.2516p ps=2.16u w=0.74u l=0.13u
X3499 VSS.t1335 a_4187_1764.t132 a_27671_16869# VSS.t1334 sg13_lv_nmos ad=0.2516p pd=2.16u as=0.1406p ps=1.12u w=0.74u l=0.6u
X3500 a_14009_10774# REF_DELAY_OUT_LAST VSS.t473 VSS.t1019 sg13_lv_nmos ad=0.2516p pd=2.16u as=1.45407p ps=9.445u w=0.74u l=0.13u
X3501 VDD.t1443 a_3171_6737.t8 a_8884_6698# VDD.t67 sg13_lv_pmos ad=0.3808p pd=2.92u as=0.3808p ps=2.92u w=1.12u l=0.13u
X3502 a_22351_16869# a_22113_16869# a_22243_16869# VSS.t2153 sg13_lv_nmos ad=0.1406p pd=1.12u as=0.2516p ps=2.16u w=0.74u l=0.2u
X3503 a_8671_14024# a_8433_14024# a_8563_14024# VSS.t1951 sg13_lv_nmos ad=0.1406p pd=1.12u as=0.2516p ps=2.16u w=0.74u l=0.2u
X3504 VSS.t814 a_4187_1764.t98 VSS.t816 VSS.t815 sg13_lv_nmos ad=1.33p pd=7.38u as=0 ps=0 w=7u l=7u
X3505 VDD.t291 VSS.t263 VDD.t290 VDD.t5 sg13_lv_pmos ad=0.34p pd=2.68u as=0 ps=0 w=1u l=1u
X3506 VDD.t1354 a_23003_1842# a_23437_1842# VDD.t373 sg13_lv_pmos ad=0.2128p pd=1.5u as=0.3808p ps=2.92u w=1.12u l=0.13u
X3507 VDD.t78 VSS.t372 VDD.t77 VDD.t0 sg13_lv_pmos ad=0.34p pd=2.68u as=0 ps=0 w=1u l=1u
X3508 a_7390_3889# a_8231_3853# a_8155_3889# VDD.t0 sg13_lv_pmos ad=0.3808p pd=2.92u as=0.2128p ps=1.5u w=1.12u l=0.13u
X3509 VDD.t180 VSS.t209 VDD.t179 VDD.t90 sg13_lv_pmos ad=0.34p pd=2.68u as=0 ps=0 w=1u l=1u
X3510 VSS.t1518 a_4187_1764.t124 a_9431_14024# VSS.t2356 sg13_lv_nmos ad=0.2516p pd=2.16u as=0.1406p ps=1.12u w=0.74u l=0.6u
X3511 VDD.t454 VDD.t446 VDD.t453 VDD.t355 sg13_lv_pmos ad=0.38p pd=2.38u as=0 ps=0 w=2u l=1u
X3512 VSS.t600 a_26803_14024# a_27237_14024# VSS.t599 sg13_lv_nmos ad=0.1406p pd=1.12u as=0.2516p ps=2.16u w=0.74u l=0.13u
X3513 VSS.t1074 a_1721_13577# a_2019_13229.t1 VSS.t1997 sg13_lv_nmos ad=0.2812p pd=2.24u as=0.1406p ps=1.12u w=0.74u l=0.13u
X3514 a_19073_7532# a_18877_7532# VDD.t542 VDD.t346 sg13_lv_pmos ad=0.3808p pd=2.92u as=0.2128p ps=1.5u w=1.12u l=0.13u
X3515 a_12715_1044# a_12505_1044# VDD.t897 VDD.t2 sg13_lv_pmos ad=0.2128p pd=1.5u as=0.252p ps=1.57u w=1.12u l=0.13u
X3516 VSS.t16 a_21157_7532# a_21625_6734# VSS.t15 sg13_lv_nmos ad=0.1665p pd=1.19u as=0.2516p ps=2.16u w=0.74u l=0.13u
X3517 VDD.t1177 a_2019_16074.t9 a_4324_16035# VDD.t90 sg13_lv_pmos ad=0.3808p pd=2.92u as=0.3808p ps=2.92u w=1.12u l=0.13u
X3518 a_17928_1044# a_17357_1842# VDD.t517 VDD.t2 sg13_lv_pmos ad=0.2128p pd=1.5u as=0.3808p ps=2.92u w=1.12u l=0.13u
X3519 a_13045_11905# a_13019_11521# a_12849_11557# VSS.t1026 sg13_lv_nmos ad=0.1406p pd=1.12u as=0.1406p ps=1.12u w=0.74u l=0.13u
X3520 a_19550_1044# a_21044_1008# a_20968_1044# VDD.t2 sg13_lv_pmos ad=0.3808p pd=2.92u as=0.2128p ps=1.5u w=1.12u l=0.13u
X3521 a_2967_6021# REF_MUX_SEL3 a_2873_6021# VSS.t932 sg13_lv_nmos ad=0.1216p pd=1.02u as=0.2176p ps=1.96u w=0.64u l=0.13u
X3522 VSS.t1228 a_1544_289# a_1815_331# VSS.t1229 sg13_lv_nmos ad=0.1331p pd=1.12u as=0.1216p ps=1.02u w=0.64u l=0.13u
X3523 VSS.t717 a_4187_1764.t10 a_21591_1842# VSS.t716 sg13_lv_nmos ad=0.2516p pd=2.16u as=0.1406p ps=1.12u w=0.74u l=0.6u
X3524 a_20071_7532# a_19833_7532# a_19963_7532# VSS.t1308 sg13_lv_nmos ad=0.1406p pd=1.12u as=0.2516p ps=2.16u w=0.74u l=0.2u
X3525 VSS.t578 a_15077_16869# a_15545_16071# VSS.t577 sg13_lv_nmos ad=0.1665p pd=1.19u as=0.2516p ps=2.16u w=0.74u l=0.13u
X3526 a_13592_11113# a_13566_11018# VSS.t154 VSS.t624 sg13_lv_nmos ad=0.2516p pd=2.16u as=0.1626p ps=1.415u w=0.74u l=0.13u
X3527 a_7288_1044# a_6717_1842# VDD.t1045 VDD.t2 sg13_lv_pmos ad=0.2128p pd=1.5u as=0.3808p ps=2.92u w=1.12u l=0.13u
X3528 a_22873_4687# a_22677_4687# VSS.t1564 VSS.t1563 sg13_lv_nmos ad=0.2516p pd=2.16u as=0.1406p ps=1.12u w=0.74u l=0.13u
X3529 VSS.t1723 a_2019_13229.t2 a_25604_13190# VSS.t1722 sg13_lv_nmos ad=0.2516p pd=2.16u as=0.2516p ps=2.16u w=0.74u l=0.13u
X3530 a_13400_11995# a_12355_11557# a_13306_11995# VSS.t101 sg13_lv_nmos ad=60.89999f pd=0.71u as=0.1428p ps=1.52u w=0.42u l=0.13u
X3531 VSS.t514 VSS.t512 VSS.t512 VSS.t513 sg13_lv_nmos ad=0.68p pd=4.68u as=0 ps=0 w=2u l=1u
X3532 VSS.t1023 a_14643_7532# a_15077_7532# VSS.t1179 sg13_lv_nmos ad=0.1406p pd=1.12u as=0.2516p ps=2.16u w=0.74u l=0.13u
X3533 a_27915_6734# a_27705_6734# VDD.t1026 VDD.t67 sg13_lv_pmos ad=0.2128p pd=1.5u as=0.252p ps=1.57u w=1.12u l=0.13u
X3534 VSS.t582 a_3171_16074.t3 a_24084_16035# VSS.t609 sg13_lv_nmos ad=0.2516p pd=2.16u as=0.2516p ps=2.16u w=0.74u l=0.13u
X3535 VDD.t1130 a_19203_7532# a_19637_7532# VDD.t346 sg13_lv_pmos ad=0.2128p pd=1.5u as=0.3808p ps=2.92u w=1.12u l=0.13u
X3536 VDD.t562 a_12037_4687# a_12505_3889# VDD.t0 sg13_lv_pmos ad=0.252p pd=1.57u as=0.3808p ps=2.92u w=1.12u l=0.13u
X3537 a_14513_4687# a_14317_4687# VDD.t873 VDD.t348 sg13_lv_pmos ad=0.3808p pd=2.92u as=0.2128p ps=1.5u w=1.12u l=0.13u
X3538 a_13231_16869# a_12993_16869# a_13123_16869# VSS.t1377 sg13_lv_nmos ad=0.1406p pd=1.12u as=0.2516p ps=2.16u w=0.74u l=0.2u
X3539 VDD.t200 VSS.t14 VDD.t288 VDD.t5 sg13_lv_pmos ad=0.34p pd=2.68u as=0 ps=0 w=1u l=1u
X3540 a_5631_5315# a_5393_4687# a_5523_4687# VDD.t348 sg13_lv_pmos ad=0.2128p pd=1.5u as=0.3808p ps=2.92u w=1.12u l=0.2u
X3541 VDD.t303 VSS.t229 VDD.t301 VDD.t90 sg13_lv_pmos ad=0.19p pd=1.38u as=0 ps=0 w=1u l=1u
X3542 VSS.t140 a_2019_6737.t9 a_4324_6698# VSS.t1709 sg13_lv_nmos ad=0.2516p pd=2.16u as=0.2516p ps=2.16u w=0.74u l=0.13u
X3543 VDD.t1053 a_18117_14024# a_18585_13226# VDD.t5 sg13_lv_pmos ad=0.252p pd=1.57u as=0.3808p ps=2.92u w=1.12u l=0.13u
X3544 VSS.t149 a_1544_12471# a_1815_12513# VSS.t150 sg13_lv_nmos ad=0.1331p pd=1.12u as=0.1216p ps=1.02u w=0.64u l=0.13u
X3545 a_16510_6734# a_3747_6737.t5 a_18795_6734# VSS.t1745 sg13_lv_nmos ad=0.2516p pd=2.16u as=0.1406p ps=1.12u w=0.74u l=0.13u
X3546 VSS.t1291 a_4187_1764.t150 a_13991_16869# VSS.t2258 sg13_lv_nmos ad=0.2516p pd=2.16u as=0.1406p ps=1.12u w=0.74u l=0.6u
X3547 a_24393_14024# a_24197_14024# VSS.t1299 VSS.t1298 sg13_lv_nmos ad=0.2516p pd=2.16u as=0.1406p ps=1.12u w=0.74u l=0.13u
X3548 a_15511_2470# a_15273_1842# a_15403_1842# VDD.t373 sg13_lv_pmos ad=0.2128p pd=1.5u as=0.3808p ps=2.92u w=1.12u l=0.2u
X3549 a_14751_17497# a_14513_16869# a_14643_16869# VDD.t368 sg13_lv_pmos ad=0.2128p pd=1.5u as=0.3808p ps=2.92u w=1.12u l=0.2u
X3550 a_19073_16869# a_18877_16869# VDD.t879 VDD.t368 sg13_lv_pmos ad=0.3808p pd=2.92u as=0.2128p ps=1.5u w=1.12u l=0.13u
X3551 a_22590_1044# a_24951_1008# a_24875_1044# VDD.t2 sg13_lv_pmos ad=0.3808p pd=2.92u as=0.2128p ps=1.5u w=1.12u l=0.13u
X3552 VSS.t565 VSS.t566 VSS.t565 VSS.t567 sg13_lv_nmos ad=0.1406p pd=1.12u as=0 ps=0 w=0.74u l=0.2u
X3553 VSS.t847 a_17683_14024# a_18117_14024# VSS.t846 sg13_lv_nmos ad=0.1406p pd=1.12u as=0.2516p ps=2.16u w=0.74u l=0.13u
X3554 VDD.t948 a_8563_7532# a_8997_7532# VDD.t346 sg13_lv_pmos ad=0.2128p pd=1.5u as=0.3808p ps=2.92u w=1.12u l=0.13u
X3555 VSS.t791 a_4187_1764.t109 a_20831_14024# VSS.t790 sg13_lv_nmos ad=0.2516p pd=2.16u as=0.1406p ps=1.12u w=0.74u l=0.6u
X3556 a_11848_13226# a_11277_14024# VDD.t1340 VDD.t5 sg13_lv_pmos ad=0.2128p pd=1.5u as=0.3808p ps=2.92u w=1.12u l=0.13u
X3557 VDD.t343 a_3171_13229.t2 a_27124_13190# VDD.t5 sg13_lv_pmos ad=0.3808p pd=2.92u as=0.3808p ps=2.92u w=1.12u l=0.13u
X3558 a_6126_9506# a_6126_9506# VSS.t47 VSS.t46 sg13_lv_nmos ad=0.38p pd=2.38u as=0.68p ps=4.68u w=2u l=1u
X3559 VSS.t911 a_4187_1764.t79 a_17791_7532# VSS.t1645 sg13_lv_nmos ad=0.2516p pd=2.16u as=0.1406p ps=1.12u w=0.74u l=0.6u
X3560 VSS.t466 VDD.t1617 VSS.t466 VSS.t468 sg13_lv_nmos ad=79.8f pd=0.8u as=0 ps=0 w=0.42u l=1u
X3561 VDD.t689 a_4187_2434# a_13231_8160# VDD.t346 sg13_lv_pmos ad=0.3808p pd=2.92u as=0.2128p ps=1.5u w=1.12u l=0.6u
X3562 VSS.t1105 a_3747_16074.t5 a_18871_16035# VSS.t1104 sg13_lv_nmos ad=0.2516p pd=2.16u as=0.2516p ps=2.16u w=0.74u l=0.13u
X3563 VSS.t282 a_2595_12493.t2 a_20905_12701# VSS.t990 sg13_lv_nmos ad=0.2516p pd=2.16u as=0.2516p ps=2.16u w=0.74u l=0.13u
X3564 a_4633_4687# a_4437_4687# VDD.t586 VDD.t348 sg13_lv_pmos ad=0.3808p pd=2.92u as=0.2128p ps=1.5u w=1.12u l=0.13u
X3565 a_13753_14024# a_13557_14024# VDD.t1341 VDD.t374 sg13_lv_pmos ad=0.3808p pd=2.92u as=0.2128p ps=1.5u w=1.12u l=0.13u
X3566 VSS.t1744 a_3747_15338.t2 a_26985_15546# VSS.t1743 sg13_lv_nmos ad=0.2516p pd=2.16u as=0.2516p ps=2.16u w=0.74u l=0.13u
X3567 VDD.t842 a_23003_7532# a_23437_7532# VDD.t346 sg13_lv_pmos ad=0.2128p pd=1.5u as=0.3808p ps=2.92u w=1.12u l=0.13u
X3568 a_22873_16869# a_22677_16869# VSS.t1703 VSS.t2315 sg13_lv_nmos ad=0.2516p pd=2.16u as=0.1406p ps=1.12u w=0.74u l=0.13u
X3569 VDD.t148 VSS.t301 VDD.t147 VDD.t5 sg13_lv_pmos ad=0.19p pd=1.38u as=0 ps=0 w=1u l=1u
X3570 VSS.t333 VDD.t1657 VSS.t333 VSS.t335 sg13_lv_nmos ad=0.1428p pd=1.52u as=0 ps=0 w=0.42u l=1u
X3571 VSS.t517 VSS.t509 VSS.t509 VSS.t510 sg13_lv_nmos ad=0.68p pd=4.68u as=0 ps=0 w=2u l=1u
X3572 a_10430_1044# a_2019_1047.t7 a_10328_1044# VSS.t2007 sg13_lv_nmos ad=0.2516p pd=2.16u as=0.1406p ps=1.12u w=0.74u l=0.13u
X3573 VSS.t326 VDD.t1659 VSS.t326 VSS.t331 sg13_lv_nmos ad=79.8f pd=0.8u as=0 ps=0 w=0.42u l=1u
X3574 a_4157_7003# REF_CLK VDD.t390 VDD.t67 sg13_lv_pmos ad=0.3808p pd=2.92u as=0.3808p ps=2.92u w=1.12u l=0.13u
X3575 VSS.t1458 a_16163_16869# a_16597_16869# VSS.t1629 sg13_lv_nmos ad=0.1406p pd=1.12u as=0.2516p ps=2.16u w=0.74u l=0.13u
X3576 VDD.t775 a_25717_1842# a_26185_1044# VDD.t2 sg13_lv_pmos ad=0.252p pd=1.57u as=0.3808p ps=2.92u w=1.12u l=0.13u
X3577 VSS.t379 a_2595_3156.t2 a_20905_3364# VSS.t785 sg13_lv_nmos ad=0.2516p pd=2.16u as=0.2516p ps=2.16u w=0.74u l=0.13u
X3578 VSS.t301 VDD.t1671 VSS.t301 VSS.t302 sg13_lv_nmos ad=0.1428p pd=1.52u as=0 ps=0 w=0.42u l=1u
X3579 VSS.t607 a_3171_16074.t6 a_14964_16035# VSS.t606 sg13_lv_nmos ad=0.2516p pd=2.16u as=0.2516p ps=2.16u w=0.74u l=0.13u
X3580 VSS.t319 a_3171_6001.t3 a_11785_6209# VSS.t1857 sg13_lv_nmos ad=0.2516p pd=2.16u as=0.2516p ps=2.16u w=0.74u l=0.13u
X3581 a_4633_14024# a_4437_14024# VSS.t1307 VSS.t1930 sg13_lv_nmos ad=0.2516p pd=2.16u as=0.1406p ps=1.12u w=0.74u l=0.13u
X3582 VSS.t1658 a_3171_13229.t7 a_11924_13190# VSS.t1657 sg13_lv_nmos ad=0.2516p pd=2.16u as=0.2516p ps=2.16u w=0.74u l=0.13u
X3583 VSS.t674 a_11603_16869# a_12037_16869# VSS.t2177 sg13_lv_nmos ad=0.1406p pd=1.12u as=0.2516p ps=2.16u w=0.74u l=0.13u
X3584 VSS.t235 a_2019_12493.t3 a_5705_12701# VSS.t1637 sg13_lv_nmos ad=0.2516p pd=2.16u as=0.2516p ps=2.16u w=0.74u l=0.13u
X3585 VDD.t1144 a_4437_1842# a_4905_1044# VDD.t2 sg13_lv_pmos ad=0.252p pd=1.57u as=0.3808p ps=2.92u w=1.12u l=0.13u
X3586 VDD.t1058 a_13883_1842# a_14317_1842# VDD.t373 sg13_lv_pmos ad=0.2128p pd=1.5u as=0.3808p ps=2.92u w=1.12u l=0.13u
X3587 VSS.t1259 a_4187_1764.t74 a_21591_7532# VSS.t1740 sg13_lv_nmos ad=0.2516p pd=2.16u as=0.1406p ps=1.12u w=0.74u l=0.6u
X3588 a_4157_1313# CHAN3_DELAY_IN VSS.t1079 VSS.t1178 sg13_lv_nmos ad=0.2516p pd=2.16u as=0.2553p ps=2.17u w=0.74u l=0.13u
X3589 a_7390_1044# a_3171_1047.t8 a_8808_1044# VSS.t1688 sg13_lv_nmos ad=0.2516p pd=2.16u as=0.1406p ps=1.12u w=0.74u l=0.13u
X3590 a_7390_3889# a_2595_3892.t8 a_8155_3889# VSS.t1463 sg13_lv_nmos ad=0.2516p pd=2.16u as=0.1406p ps=1.12u w=0.74u l=0.13u
X3591 VSS.t243 VDD.t1686 VSS.t243 VSS.t244 sg13_lv_nmos ad=79.8f pd=0.8u as=0 ps=0 w=0.42u l=1u
X3592 VSS.t1128 a_4187_1764.t121 a_11711_14024# VSS.t1127 sg13_lv_nmos ad=0.2516p pd=2.16u as=0.1406p ps=1.12u w=0.74u l=0.6u
X3593 a_22873_1842# a_22677_1842# VSS.t715 VSS.t1430 sg13_lv_nmos ad=0.2516p pd=2.16u as=0.1406p ps=1.12u w=0.74u l=0.13u
X3594 a_25391_14024# a_25153_14024# a_25283_14024# VSS.t2183 sg13_lv_nmos ad=0.1406p pd=1.12u as=0.2516p ps=2.16u w=0.74u l=0.2u
X3595 a_10328_3889# a_9757_4687# VDD.t365 VDD.t0 sg13_lv_pmos ad=0.2128p pd=1.5u as=0.3808p ps=2.92u w=1.12u l=0.13u
X3596 VSS.t2085 a_2019_15338.t2 a_17865_15546# VSS.t2084 sg13_lv_nmos ad=0.2516p pd=2.16u as=0.2516p ps=2.16u w=0.74u l=0.13u
X3597 VDD.t1190 a_3171_1047.t8 a_8884_1008# VDD.t2 sg13_lv_pmos ad=0.3808p pd=2.92u as=0.3808p ps=2.92u w=1.12u l=0.13u
X3598 VDD.t556 a_12037_16869# a_12505_16071# VDD.t90 sg13_lv_pmos ad=0.252p pd=1.57u as=0.3808p ps=2.92u w=1.12u l=0.13u
C0 a_15511_8160# VDD 0.01806f
C1 a_10713_4687# VDD 0.49555f
C2 a_17928_3889# VDD 0.17499f
C3 a_16108_5979# REF_MUX_OUT 0.24265f
C4 a_9757_16869# a_9323_16869# 0.6972f
C5 a_4187_2434# a_15273_16869# 0.11222f
C6 a_4187_2434# a_6153_7532# 0.11222f
C7 a_17357_14024# a_18004_13190# 0.02312f
C8 a_16108_15316# a_25717_14024# 0.01314f
C9 a_13753_14024# a_13883_14024# 0.70845f
C10 a_13306_10795# a_13880_10808# 0.31978f
C11 a_14111_10917# a_15108_11015# 0.03012f
C12 a_10430_13226# a_11785_12701# 0.02058f
C13 a_4187_2434# a_12993_4687# 0.11169f
C14 a_25717_14024# VDD 0.87095f
C15 a_6326_10280# VDD 7.58054f
C16 a_1256_15316# CHAN0_MUX_SEL2 0.33134f
C17 a_15545_6734# a_13470_6734# 0.03208f
C18 a_5731_5979# a_14513_4687# 0.01872f
C19 a_7477_4687# a_7043_4687# 0.69698f
C20 a_12037_1842# a_12233_1842# 0.77122f
C21 a_16108_3134# a_21353_1842# 0.01872f
C22 a_13368_3889# a_13470_3889# 0.37183f
C23 a_19448_1044# a_19524_1008# 0.01176f
C24 a_22488_6734# VDD 0.1824f
C25 a_23003_1842# VDD 0.48378f
C26 a_1544_3889# VDD 0.46485f
C27 a_15765_463# VDD 0.35368f
C28 a_26477_16869# a_27237_16869# 0.03319f
C29 a_13123_16869# a_13231_16869# 0.01163f
C30 a_5731_15316# a_9953_14024# 0.01872f
C31 a_5197_14024# a_4763_14024# 0.6972f
C32 a_4187_2434# a_27997_14024# 0.04001f
C33 a_7477_14024# a_7390_13226# 0.1088f
C34 a_10328_13226# a_10430_13226# 0.37183f
C35 a_19963_14024# a_20071_14024# 0.01163f
C36 a_26043_14024# a_26151_14652# 0.01697f
C37 a_17357_7532# a_18117_7532# 0.03319f
C38 a_4187_2434# a_25283_1842# 0.06627f
C39 a_7803_7532# a_7390_6734# 0.01012f
C40 a_20723_7532# a_20831_7532# 0.01163f
C41 a_6391_17497# VDD 0.01806f
C42 a_7043_14024# VDD 0.4999f
C43 a_13470_13226# VDD 0.87936f
C44 a_19833_7532# VDD 0.49294f
C45 a_10206_11525# DLL_RESETN 0.27343f
C46 a_10232_11561# CHAN1_MUX_OUT 0.01279f
C47 a_24523_7532# a_22590_6734# 0.01012f
C48 a_22590_6734# a_23945_6209# 0.02165f
C49 a_24957_4687# a_16108_3134# 0.0157f
C50 a_6425_3889# a_4350_3889# 0.03208f
C51 a_24197_4687# a_24957_4687# 0.02912f
C52 a_16108_3134# a_20905_3364# 0.2906f
C53 a_5731_3134# a_5523_1842# 0.01562f
C54 a_7390_1044# a_7364_1008# 0.277f
C55 a_23003_1842# a_23111_2470# 0.01697f
C56 a_16923_1842# a_17031_1842# 0.01163f
C57 a_26673_4687# VDD 0.49593f
C58 a_6425_6734# VDD 0.29722f
C59 a_5393_1842# VDD 0.49643f
C60 a_10404_1008# VDD 0.28633f
C61 a_2873_1395# CHAN3_MUX_SEL0 0.01504f
C62 a_4187_2434# a_9323_14024# 0.06627f
C63 a_17357_16869# a_17683_16869# 0.01427f
C64 CHAN0_MUX_SEL2 CHAN0_MUX_SEL4 0.01978f
C65 a_25630_16071# a_27915_16071# 0.39036f
C66 CHAN0_MUX_SEL1 CHAN0_MUX_OUT 0.09357f
C67 a_21917_14024# a_22677_14024# 0.06198f
C68 a_4187_2434# a_22113_7532# 0.11232f
C69 a_26477_14024# a_27124_13190# 0.02312f
C70 a_8237_7532# a_8563_7532# 0.01427f
C71 a_4187_2434# a_7673_1842# 0.11222f
C72 a_11277_16869# VDD 0.86926f
C73 a_17928_16071# VDD 0.17499f
C74 a_13880_10808# VDD 0.02994f
C75 a_16510_6734# a_18871_6698# 0.26208f
C76 a_19833_1842# a_20397_1842# 0.0114f
C77 a_13470_3889# a_14825_3364# 0.02058f
C78 a_9431_8160# VDD 0.01806f
C79 a_8997_4687# VDD 0.85996f
C80 a_14964_3853# VDD 0.28225f
C81 a_8433_16869# a_8997_16869# 0.0114f
C82 a_4187_2434# a_13557_16869# 0.04101f
C83 a_11277_16869# a_11271_16035# 0.02349f
C84 a_12037_16869# a_10430_16071# 0.05231f
C85 a_13470_16071# a_15831_16035# 0.26208f
C86 a_4187_2434# a_4437_7532# 0.04193f
C87 a_26185_16071# a_26395_16071# 0.09424f
C88 a_16597_14024# a_16510_13226# 0.1088f
C89 a_13306_10795# a_14111_10917# 0.097f
C90 a_13592_11113# a_14009_10774# 0.3749f
C91 a_4187_2434# a_11277_4687# 0.04141f
C92 a_16923_7532# a_16510_6734# 0.01012f
C93 a_1544_16071# VDD 0.46485f
C94 a_23003_14024# VDD 0.48375f
C95 a_15765_12645# VDD 0.35715f
C96 a_1544_13226# CHAN1_MUX_SEL4 0.02586f
C97 a_1256_13226# CHAN1_MUX_OUT 0.02466f
C98 a_2297_13577# CHAN1_MUX_SEL0 0.10655f
C99 a_4003_7532# REF_CLK 0.55467f
C100 a_27433_7532# a_27997_7532# 0.0114f
C101 a_5731_5979# a_12797_4687# 0.01307f
C102 a_6153_4687# a_6717_4687# 0.0114f
C103 a_15077_4687# a_15545_3889# 0.2079f
C104 a_9323_4687# a_7390_3889# 0.01012f
C105 a_11848_3889# a_11924_3853# 0.01176f
C106 a_21625_3889# a_21911_3853# 0.01885f
C107 a_16108_3134# a_19637_1842# 0.01314f
C108 a_10713_1842# a_10843_1842# 0.70845f
C109 a_4350_1044# a_5731_289# 0.41099f
C110 a_19550_6734# VDD 0.8993f
C111 a_21353_1842# VDD 0.49468f
C112 a_5731_289# VDD 0.6143f
C113 a_9757_1842# CHAN3_MUX_SEL4 0.01829f
C114 a_11603_16869# a_11711_16869# 0.01163f
C115 a_4187_2434# a_25283_14024# 0.06627f
C116 a_25717_16869# a_25283_16869# 0.69698f
C117 a_5731_15316# a_8237_14024# 0.01319f
C118 a_18443_14024# a_18551_14024# 0.01163f
C119 a_18585_13226# a_16510_13226# 0.03208f
C120 a_8808_13226# a_8884_13190# 0.01176f
C121 a_24523_14024# a_24631_14652# 0.01697f
C122 a_11748_11799# a_12158_11557# 0.10373f
C123 a_16597_7532# a_16163_7532# 0.69698f
C124 a_4187_2434# a_23633_1842# 0.11222f
C125 a_6717_7532# a_7288_6734# 0.10864f
C126 a_12037_7532# a_12505_6734# 0.2079f
C127 a_19203_7532# a_19311_7532# 0.01163f
C128 a_27237_16869# VDD 0.86022f
C129 a_10404_13190# VDD 0.28633f
C130 a_5393_14024# VDD 0.49643f
C131 a_18117_7532# VDD 0.85889f
C132 a_6854_11144# CHAN1_MUX_OUT 0.16652f
C133 a_6854_11676# REF_CLK 0.04119f
C134 a_6126_9506# DLL_RESETN 0.06398f
C135 a_1256_6734# a_1544_6734# 1.26509f
C136 a_23437_4687# a_23003_4687# 0.6972f
C137 a_21483_1842# a_21591_2470# 0.01697f
C138 a_15403_1842# a_15511_1842# 0.01163f
C139 a_12505_1044# a_12715_1044# 0.09424f
C140 a_24957_4687# VDD 0.88247f
C141 a_8155_1044# VDD 0.1539f
C142 a_20905_3364# VDD 0.29292f
C143 a_1256_1044# CHAN3_MUX_SEL0 0.3314f
C144 a_16597_16869# a_16793_16869# 0.73897f
C145 a_4187_2434# a_7673_14024# 0.11222f
C146 a_21157_16869# a_19550_16071# 0.05231f
C147 a_20397_16869# a_20391_16035# 0.02349f
C148 a_21157_14024# a_20723_14024# 0.6972f
C149 CHAN0_DELAY_IN CHAN0_MUX_SEL0 0.11907f
C150 a_4187_2434# a_20397_7532# 0.04176f
C151 a_25717_14024# a_25630_13226# 0.1088f
C152 a_7477_7532# a_7673_7532# 0.73897f
C153 a_4187_2434# a_27237_4687# 0.06254f
C154 a_4187_2434# a_5957_1842# 0.04141f
C155 a_8563_16869# VDD 0.49671f
C156 a_14964_16035# VDD 0.28225f
C157 a_14111_10917# VDD 0.33926f
C158 a_26803_7532# a_26911_7532# 0.01163f
C159 a_16408_6734# a_16510_6734# 0.37183f
C160 a_16108_5979# a_25913_4687# 0.01865f
C161 a_14317_4687# a_14513_4687# 0.76914f
C162 a_18443_4687# a_16510_3889# 0.01012f
C163 a_22488_3889# a_22564_3853# 0.01176f
C164 a_18877_1842# a_19637_1842# 0.06198f
C165 a_1256_289# a_2297_331# 0.04261f
C166 a_1544_289# a_1721_331# 0.36963f
C167 a_27563_7532# VDD 0.49811f
C168 a_12715_3889# VDD 0.15484f
C169 a_6283_4687# VDD 0.50001f
C170 a_5705_6209# REF_MUX_SEL4 0.03556f
C171 a_7477_16869# a_8237_16869# 0.01669f
C172 a_4187_2434# a_10843_16869# 0.06627f
C173 a_13368_16071# a_13470_16071# 0.37183f
C174 a_9757_16869# a_10404_16035# 0.02011f
C175 a_12037_14024# a_12233_14024# 0.77122f
C176 a_16108_15316# a_21353_14024# 0.01872f
C177 a_19448_13226# a_19524_13190# 0.01176f
C178 a_12907_11110# a_13132_11110# 0.02416f
C179 a_4187_2434# a_8563_4687# 0.06627f
C180 a_15837_7532# a_16408_6734# 0.10864f
C181 a_21353_14024# VDD 0.49468f
C182 a_5731_12471# VDD 0.84699f
C183 a_9465_6734# a_9675_6734# 0.09424f
C184 a_26477_7532# a_27237_7532# 0.03319f
C185 a_4248_6734# a_4324_6698# 0.01176f
C186 a_5731_5979# a_10083_4687# 0.01539f
C187 a_5197_4687# a_5957_4687# 0.03319f
C188 a_10430_3889# a_10404_3853# 0.277f
C189 a_20105_3889# a_19550_3889# 0.03209f
C190 a_9757_1842# a_10083_1842# 0.01427f
C191 a_16108_3134# a_16923_1842# 0.01073f
C192 a_16510_1044# a_17275_1044# 0.39037f
C193 a_16484_6698# VDD 0.28687f
C194 a_19637_1842# VDD 0.87095f
C195 a_2297_331# VDD 0.47304f
C196 a_13470_1044# CHAN3_MUX_SEL4 0.256f
C197 a_10083_16869# a_10191_16869# 0.01163f
C198 a_6425_16071# a_4350_16071# 0.03208f
C199 a_4187_2434# a_23633_14024# 0.11222f
C200 a_24393_16869# a_24957_16869# 0.0114f
C201 a_23003_14024# a_23111_14652# 0.01697f
C202 a_16923_14024# a_17031_14024# 0.01163f
C203 a_5731_15316# a_5523_14024# 0.01562f
C204 a_16108_15316# a_20905_15546# 0.2906f
C205 a_7390_13226# a_7364_13190# 0.277f
C206 a_10649_11568# a_10520_11982# 0.01562f
C207 a_6854_11676# a_13121_11521# 0.10045f
C208 a_15273_7532# a_15837_7532# 0.0114f
C209 a_10232_11561# a_10751_11568# 0.34102f
C210 a_4187_2434# a_21917_1842# 0.0414f
C211 a_6717_7532# a_4350_6734# 0.02479f
C212 a_17683_7532# a_17791_7532# 0.01163f
C213 a_24523_16869# VDD 0.4973f
C214 a_8155_13226# VDD 0.1539f
C215 a_20905_15546# VDD 0.29292f
C216 a_15403_7532# VDD 0.4973f
C217 a_22113_4687# a_22677_4687# 0.0114f
C218 a_27563_4687# a_25630_3889# 0.01024f
C219 a_5731_3134# a_14825_3364# 0.28056f
C220 a_26673_1842# a_26803_1842# 0.70845f
C221 a_19963_1842# a_20071_2470# 0.01697f
C222 a_13883_1842# a_13991_1842# 0.01163f
C223 a_4350_1044# a_5191_1008# 0.28268f
C224 a_22243_4687# VDD 0.95241f
C225 a_5191_1008# VDD 0.28565f
C226 a_4187_2434# a_26803_16869# 0.06627f
C227 a_15273_16869# a_15403_16869# 0.70845f
C228 a_4187_2434# a_5957_14024# 0.04141f
C229 a_13470_16071# a_14825_15546# 0.02058f
C230 a_18877_16869# a_19524_16035# 0.02011f
C231 a_4187_2434# a_17683_7532# 0.06661f
C232 a_19833_14024# a_20397_14024# 0.0114f
C233 a_6153_7532# a_6283_7532# 0.70845f
C234 a_4187_2434# a_22873_7532# 0.11231f
C235 a_4187_2434# a_24523_4687# 0.06627f
C236 a_6913_16869# VDD 0.49426f
C237 a_12715_16071# VDD 0.15484f
C238 a_13106_11047# VDD 0.09231f
C239 a_14888_6734# a_14964_6698# 0.01176f
C240 a_25283_7532# a_25391_7532# 0.01163f
C241 a_12993_4687# a_13123_4687# 0.70361f
C242 a_16108_5979# a_24197_4687# 0.01319f
C243 a_10430_3889# a_5731_3134# 0.41176f
C244 a_18117_1842# a_17683_1842# 0.6972f
C245 a_19550_1044# a_16108_289# 0.58202f
C246 a_25913_7532# VDD 0.49294f
C247 a_9751_3853# VDD 0.2822f
C248 a_4633_4687# VDD 0.49523f
C249 a_25391_2470# VDD 0.01806f
C250 a_1256_5979# REF_MUX_SEL2 0.33134f
C251 a_15765_463# CHAN3_MUX_SEL4 0.65508f
C252 a_6717_16869# a_6283_16869# 0.6972f
C253 a_4187_2434# a_9193_16869# 0.11222f
C254 a_21625_16071# a_21911_16035# 0.01885f
C255 a_11848_16071# a_11924_16035# 0.01176f
C256 a_8997_16869# a_8884_16035# 0.02055f
C257 a_10713_14024# a_10843_14024# 0.70845f
C258 a_16108_15316# a_19637_14024# 0.01314f
C259 a_4350_13226# a_5731_12471# 0.41099f
C260 a_13019_11521# a_15464_9374# 0.59875f
C261 a_4187_2434# a_6913_4687# 0.11222f
C262 a_15837_7532# a_13470_6734# 0.02479f
C263 a_2297_12513# VDD 0.47559f
C264 a_19637_14024# VDD 0.87095f
C265 a_25717_7532# a_25283_7532# 0.69698f
C266 a_5731_5979# a_8433_4687# 0.01872f
C267 a_4437_4687# a_4003_4687# 0.69698f
C268 a_17065_3889# a_17351_3853# 0.01885f
C269 a_12363_1842# a_10430_1044# 0.01012f
C270 a_19637_1842# a_20105_1044# 0.19203f
C271 a_8997_1842# a_9193_1842# 0.77122f
C272 a_27705_1044# a_27915_1044# 0.09424f
C273 a_14235_6734# VDD 0.15389f
C274 a_26471_1008# VDD 0.28336f
C275 a_16923_1842# VDD 0.4982f
C276 a_23437_16869# a_24197_16869# 0.03319f
C277 a_8563_16869# a_8671_16869# 0.01163f
C278 a_4187_2434# a_21917_14024# 0.0414f
C279 a_21483_14024# a_21591_14652# 0.01697f
C280 a_15403_14024# a_15511_14024# 0.01163f
C281 a_9946_11995# a_10206_11525# 0.75507f
C282 a_12505_13226# a_12715_13226# 0.09424f
C283 a_14317_7532# a_15077_7532# 0.03319f
C284 a_16163_7532# a_16271_7532# 0.01163f
C285 a_4187_2434# a_19203_1842# 0.06627f
C286 a_4437_7532# a_4324_6698# 0.05157f
C287 a_22243_7532# a_22351_8160# 0.01697f
C288 a_22873_16869# VDD 0.49388f
C289 a_13753_7532# VDD 0.49355f
C290 a_5191_13190# VDD 0.28575f
C291 a_4157_16340# CHAN0_DELAY_IN 0.50642f
C292 a_21157_4687# a_21917_4687# 0.02912f
C293 a_25528_6734# a_25604_6698# 0.01176f
C294 a_18877_4687# a_16108_3134# 0.0157f
C295 a_4437_1842# a_4905_1044# 0.19203f
C296 a_18443_1842# a_18551_2470# 0.01697f
C297 a_12363_1842# a_12471_1842# 0.01163f
C298 a_7945_1044# a_8155_1044# 0.09424f
C299 a_20593_4687# VDD 0.49594f
C300 a_24665_1044# VDD 0.29742f
C301 a_14317_16869# a_14643_16869# 0.01427f
C302 a_4187_2434# a_25153_16869# 0.11222f
C303 a_18117_16869# a_18004_16035# 0.02055f
C304 a_22488_16071# a_22564_16035# 0.01176f
C305 a_4187_2434# a_16033_7532# 0.11287f
C306 a_18877_14024# a_19637_14024# 0.06198f
C307 a_1544_12471# a_1721_12513# 0.36963f
C308 a_1256_12471# a_2297_12513# 0.04261f
C309 a_5197_7532# a_5523_7532# 0.01427f
C310 a_4187_2434# a_22873_4687# 0.11169f
C311 a_5197_16869# VDD 0.86919f
C312 a_9751_16035# VDD 0.2822f
C313 a_15108_11799# VDD 0.135f
C314 a_25391_14652# VDD 0.01806f
C315 a_13470_6734# a_13444_6698# 0.277f
C316 a_24665_6734# a_24875_6734# 0.09424f
C317 a_23763_7532# a_23871_7532# 0.01163f
C318 a_16108_5979# a_21483_4687# 0.01542f
C319 a_19550_3889# a_20315_3889# 0.39037f
C320 a_7390_3889# a_8745_3364# 0.01756f
C321 a_16793_1842# a_17357_1842# 0.0114f
C322 a_21483_1842# a_19550_1044# 0.01012f
C323 a_25630_1044# a_26471_1008# 0.28268f
C324 a_16510_1044# a_16851_309# 0.02131f
C325 a_16108_5979# VDD 1.64187f
C326 a_24197_7532# VDD 0.85892f
C327 a_7288_3889# VDD 0.17274f
C328 a_19311_2470# VDD 0.01806f
C329 a_2297_4240# CHAN2_MUX_SEL0 0.10655f
C330 a_1256_3889# CHAN2_MUX_OUT 0.02466f
C331 a_1544_3889# CHAN2_MUX_SEL4 0.02586f
C332 a_5731_289# CHAN3_MUX_SEL4 4.60702f
C333 a_4187_2434# a_7477_16869# 0.0414f
C334 a_13557_16869# a_14025_16071# 0.19203f
C335 a_5393_16869# a_5957_16869# 0.0114f
C336 a_8237_16869# a_7390_16071# 0.08038f
C337 a_26803_16869# a_26911_17497# 0.01697f
C338 a_16108_15316# a_16923_14024# 0.01073f
C339 a_20105_16071# a_19550_16071# 0.03209f
C340 a_10430_16071# a_10404_16035# 0.277f
C341 a_9757_14024# a_10083_14024# 0.01427f
C342 a_16510_13226# a_17275_13226# 0.39037f
C343 a_14111_11568# a_15304_10295# 0.01811f
C344 a_22113_7532# a_22243_7532# 0.70361f
C345 a_4187_2434# a_26477_7532# 0.04182f
C346 a_4187_2434# a_5197_4687# 0.04141f
C347 a_13557_7532# a_13444_6698# 0.05157f
C348 a_16923_14024# VDD 0.4982f
C349 a_26471_13190# VDD 0.28336f
C350 a_13132_11110# DLL_RESETN 0.01689f
C351 a_24393_7532# a_24957_7532# 0.0114f
C352 a_4905_6734# a_5191_6698# 0.01885f
C353 a_16108_5979# a_26985_6209# 0.27952f
C354 a_5731_5979# a_6717_4687# 0.01307f
C355 a_5197_4687# a_5768_3889# 0.10863f
C356 a_5731_3134# a_15403_1842# 0.01563f
C357 a_7390_3889# a_8231_3853# 0.28268f
C358 a_7673_1842# a_7803_1842# 0.70845f
C359 a_13470_1044# a_14888_1044# 0.38994f
C360 a_11271_6698# VDD 0.28357f
C361 a_15273_1842# VDD 0.4946f
C362 a_24008_1044# VDD 0.17499f
C363 a_22677_16869# a_22243_16869# 0.69698f
C364 a_7043_16869# a_7151_16869# 0.01163f
C365 a_5731_15316# a_14825_15546# 0.28056f
C366 a_4187_2434# a_19203_14024# 0.06627f
C367 a_27237_16869# a_27124_16035# 0.02055f
C368 a_13883_14024# a_13991_14024# 0.01163f
C369 a_4350_13226# a_5191_13190# 0.28268f
C370 a_26673_14024# a_26803_14024# 0.70845f
C371 a_19963_14024# a_20071_14652# 0.01697f
C372 a_9547_11632# a_9746_11495# 0.14994f
C373 a_13557_7532# a_13123_7532# 0.69698f
C374 a_14643_7532# a_14751_7532# 0.01163f
C375 a_4187_2434# a_17553_1842# 0.11222f
C376 a_20723_7532# a_20831_8160# 0.01697f
C377 a_21157_16869# VDD 0.85896f
C378 a_12037_7532# VDD 0.86065f
C379 a_24665_13226# VDD 0.29742f
C380 a_1544_16071# CHAN0_MUX_SEL1 0.1672f
C381 a_1721_16422# CHAN0_MUX_SEL0 0.01315f
C382 a_20397_4687# a_19963_4687# 0.6972f
C383 a_25630_3889# a_16108_3134# 0.52614f
C384 a_10843_1842# a_10951_1842# 0.01163f
C385 a_16923_1842# a_17031_2470# 0.01697f
C386 a_24957_1842# a_25153_1842# 0.76914f
C387 a_18877_4687# VDD 0.88247f
C388 a_1256_3134# VDD 0.45613f
C389 a_12505_1044# VDD 0.29876f
C390 a_17357_16869# a_16510_16071# 0.08038f
C391 a_4187_2434# a_23437_16869# 0.04012f
C392 a_27237_16869# a_27705_16071# 0.2079f
C393 a_13557_16869# a_13753_16869# 0.73897f
C394 a_10430_16071# a_5731_15316# 0.41176f
C395 a_18117_14024# a_17683_14024# 0.6972f
C396 a_4187_2434# a_14317_7532# 0.04317f
C397 a_4437_7532# a_4633_7532# 0.73897f
C398 a_19550_13226# a_16108_12471# 0.58202f
C399 a_4187_2434# a_21157_4687# 0.04152f
C400 a_22677_7532# a_22564_6698# 0.05157f
C401 a_7288_16071# VDD 0.17274f
C402 a_19311_14652# VDD 0.01806f
C403 a_13566_11525# VDD 0.09469f
C404 a_4437_14024# CHAN1_DELAY_IN 0.05007f
C405 a_4633_14024# CHAN0_MUX_SEL4 0.01287f
C406 a_16108_5979# a_19833_4687# 0.01865f
C407 a_14317_4687# a_14888_3889# 0.10863f
C408 a_11277_4687# a_11473_4687# 0.76914f
C409 a_15837_1842# a_16597_1842# 0.06198f
C410 a_24875_1044# a_24951_1008# 0.01194f
C411 a_4350_3889# VDD 0.87635f
C412 a_13231_2470# VDD 0.01806f
C413 a_2297_331# CHAN3_MUX_SEL4 0.04338f
C414 VDD CHAN1_MUX_SEL4 2.73441f
C415 a_2873_331# CHAN3_MUX_SEL3 0.12606f
C416 a_3449_331# CHAN3_MUX_SEL2 0.10741f
C417 a_4437_16869# a_5197_16869# 0.01669f
C418 a_4187_2434# a_4763_16869# 0.06627f
C419 a_6717_16869# a_6711_16035# 0.02354f
C420 a_25283_16869# a_25391_17497# 0.01697f
C421 a_8997_14024# a_9193_14024# 0.77122f
C422 a_17065_16071# a_17351_16035# 0.01885f
C423 a_19637_14024# a_20105_13226# 0.19203f
C424 a_12363_14024# a_10430_13226# 0.01012f
C425 a_27705_13226# a_27915_13226# 0.09424f
C426 a_6854_11144# a_5864_9057# 0.03661f
C427 a_13880_11982# a_14111_11568# 0.12701f
C428 a_14009_11568# a_14757_11918# 0.01058f
C429 a_4187_2434# a_23763_7532# 0.06661f
C430 a_15273_14024# VDD 0.4946f
C431 a_24008_13226# VDD 0.17499f
C432 a_23437_7532# a_24197_7532# 0.03319f
C433 a_15765_6153# a_15964_5979# 0.061f
C434 a_6635_3889# a_6711_3853# 0.01194f
C435 a_6717_1842# a_7043_1842# 0.01427f
C436 a_5731_3134# a_13753_1842# 0.01865f
C437 a_23145_1044# a_23355_1044# 0.09424f
C438 a_23111_5315# VDD 0.01806f
C439 a_8808_6734# VDD 0.17499f
C440 a_13557_1842# VDD 0.87029f
C441 a_21044_1008# VDD 0.28225f
C442 a_21353_16869# a_21917_16869# 0.0114f
C443 a_4187_2434# a_17553_14024# 0.11222f
C444 a_5523_16869# a_5631_16869# 0.01163f
C445 a_26477_16869# a_25630_16071# 0.08038f
C446 a_12363_14024# a_12471_14024# 0.01163f
C447 a_7945_13226# a_8155_13226# 0.09424f
C448 a_18443_14024# a_18551_14652# 0.01697f
C449 a_4437_14024# a_4905_13226# 0.19203f
C450 a_6326_10280# a_6854_11144# 1.25249f
C451 a_5974_11413# a_6126_9506# 1.74589f
C452 a_12233_7532# a_12797_7532# 0.0114f
C453 a_4187_2434# a_15837_1842# 0.0414f
C454 a_13123_7532# a_13231_7532# 0.01163f
C455 a_19203_7532# a_19311_8160# 0.01697f
C456 a_18443_16869# VDD 0.4973f
C457 a_12505_13226# VDD 0.29876f
C458 a_1256_15316# VDD 0.45613f
C459 a_9323_7532# VDD 0.4973f
C460 a_1544_12471# CHAN1_MUX_SEL3 0.15976f
C461 a_1256_12471# CHAN1_MUX_SEL4 0.65005f
C462 a_1721_12513# CHAN1_MUX_SEL2 0.01315f
C463 a_22590_6734# a_23355_6734# 0.39037f
C464 a_1544_3889# a_2297_4240# 0.28651f
C465 a_19073_4687# a_19637_4687# 0.0114f
C466 a_23437_4687# a_24008_3889# 0.10863f
C467 a_23633_1842# a_23763_1842# 0.70845f
C468 a_15403_1842# a_15511_2470# 0.01697f
C469 a_9323_1842# a_9431_1842# 0.01163f
C470 a_4157_1313# a_4248_1044# 0.11672f
C471 a_15964_289# a_16851_309# 0.16757f
C472 a_16163_4687# VDD 0.49822f
C473 a_25630_3889# VDD 0.90165f
C474 a_3449_1395# VDD 0.46731f
C475 a_12233_16869# a_12363_16869# 0.70361f
C476 a_4187_2434# a_20723_16869# 0.06627f
C477 a_15837_16869# a_15831_16035# 0.02354f
C478 a_19550_16071# a_20315_16071# 0.39037f
C479 a_7390_16071# a_8745_15546# 0.01756f
C480 a_16793_14024# a_17357_14024# 0.0114f
C481 a_4187_2434# a_11603_7532# 0.06627f
C482 a_16510_13226# a_16851_12491# 0.02131f
C483 a_25630_13226# a_26471_13190# 0.28268f
C484 a_21483_14024# a_19550_13226# 0.01012f
C485 a_4187_2434# a_18443_4687# 0.06627f
C486 a_4350_16071# VDD 0.87635f
C487 a_13231_14652# VDD 0.01806f
C488 a_12355_11557# VDD 0.39937f
C489 a_16108_15316# CHAN0_MUX_SEL4 0.1283f
C490 a_15964_15316# CHAN0_MUX_OUT 0.01307f
C491 a_4350_13226# CHAN1_MUX_SEL4 0.31434f
C492 a_12797_7532# DLL_RESETN 0.0106f
C493 a_26803_7532# a_26911_8160# 0.01697f
C494 a_16108_5979# a_18117_4687# 0.01644f
C495 a_9953_4687# a_10083_4687# 0.70845f
C496 a_20105_6734# a_20315_6734# 0.09424f
C497 a_10430_6734# a_11271_6698# 0.28268f
C498 a_16510_3889# a_17928_3889# 0.38994f
C499 a_15077_1842# a_14643_1842# 0.6972f
C500 a_16108_3134# a_26803_1842# 0.01192f
C501 a_22590_1044# a_24084_1008# 0.28279f
C502 a_23355_1044# a_23431_1008# 0.01194f
C503 a_20105_3889# VDD 0.30411f
C504 a_3449_6021# VDD 0.47499f
C505 a_7151_2470# VDD 0.01806f
C506 VDD CHAN0_MUX_SEL4 2.78283f
C507 a_5197_16869# a_5844_16035# 0.02312f
C508 a_23763_16869# a_23871_17497# 0.01697f
C509 a_7390_16071# a_8231_16035# 0.28268f
C510 a_5731_15316# a_15403_14024# 0.01563f
C511 a_7673_14024# a_7803_14024# 0.70845f
C512 a_13470_13226# a_14888_13226# 0.38994f
C513 a_12849_11557# a_14851_11918# 0.13392f
C514 a_20397_7532# a_20593_7532# 0.76914f
C515 a_13121_11521# a_15688_11557# 0.17255f
C516 a_11277_7532# a_11271_6698# 0.02349f
C517 a_12037_7532# a_10430_6734# 0.05231f
C518 a_23871_17497# VDD 0.01806f
C519 a_13557_14024# VDD 0.87029f
C520 a_21044_13190# VDD 0.28225f
C521 a_14009_11568# REF_CLK 0.25847f
C522 a_5731_5979# a_15964_5979# 0.2778f
C523 a_5115_3889# a_5191_3853# 0.01194f
C524 a_4350_3889# a_5844_3853# 0.28279f
C525 a_27237_4687# a_27433_4687# 0.77122f
C526 a_12505_3889# a_10430_3889# 0.03208f
C527 a_5731_3134# a_12037_1842# 0.01319f
C528 a_5957_1842# a_6153_1842# 0.77122f
C529 a_8237_1842# a_8808_1044# 0.10863f
C530 a_10430_1044# a_12715_1044# 0.39036f
C531 a_5844_6698# VDD 0.28225f
C532 a_17031_5315# VDD 0.01806f
C533 a_18795_1044# VDD 0.15407f
C534 a_10843_1842# VDD 0.50064f
C535 a_4003_16869# a_4111_16869# 0.01163f
C536 a_20397_16869# a_21157_16869# 0.03319f
C537 a_4187_2434# a_15837_14024# 0.0414f
C538 a_24957_16869# a_24951_16035# 0.02354f
C539 a_10843_14024# a_10951_14024# 0.01163f
C540 a_16923_14024# a_17031_14652# 0.01697f
C541 VDD CHAN3_DELAY_OUT_LAST 0.46919f
C542 DLL_RESETN REF_CLK 10.7467f
C543 a_25630_16071# a_16108_15316# 0.52614f
C544 a_24957_14024# a_25153_14024# 0.76914f
C545 a_11277_7532# a_12037_7532# 0.03319f
C546 a_4187_2434# a_13123_1842# 0.0643f
C547 a_11603_7532# a_11711_7532# 0.01163f
C548 a_17683_7532# a_17791_8160# 0.01697f
C549 a_16793_16869# VDD 0.49277f
C550 a_25630_16071# VDD 0.90165f
C551 a_3449_13577# VDD 0.46731f
C552 a_7673_7532# VDD 0.49294f
C553 a_15108_11015# REF_DELAY_OUT_LAST 0.01399f
C554 a_18117_4687# a_18877_4687# 0.02912f
C555 a_27915_3889# a_27991_3853# 0.01194f
C556 a_13883_1842# a_13991_2470# 0.01697f
C557 a_7803_1842# a_7911_1842# 0.01163f
C558 a_26911_8160# VDD 0.01806f
C559 a_22564_3853# VDD 0.28964f
C560 a_14513_4687# VDD 0.49593f
C561 a_4187_2434# a_19073_16869# 0.11222f
C562 a_11277_16869# a_11603_16869# 0.01427f
C563 a_14317_16869# a_14964_16035# 0.02312f
C564 a_15837_14024# a_16597_14024# 0.06198f
C565 a_4187_2434# a_9953_7532# 0.11222f
C566 a_24875_13226# a_24951_13190# 0.01194f
C567 a_4187_2434# a_16793_4687# 0.11222f
C568 a_20397_7532# a_20391_6698# 0.02349f
C569 a_21157_7532# a_19550_6734# 0.05231f
C570 a_20105_16071# VDD 0.30409f
C571 a_7151_14652# VDD 0.01806f
C572 a_9675_6734# a_9751_6698# 0.01194f
C573 a_25283_7532# a_25391_8160# 0.01697f
C574 a_13753_1842# a_14317_1842# 0.0114f
C575 a_16108_3134# a_25153_1842# 0.01872f
C576 a_17357_1842# a_17928_1044# 0.10863f
C577 a_27124_6698# VDD 0.28225f
C578 a_7945_3889# VDD 0.30411f
C579 a_26803_1842# VDD 0.49718f
C580 a_22243_16869# a_22351_17497# 0.01697f
C581 a_4437_16869# a_4350_16071# 0.1088f
C582 a_6635_16071# a_6711_16035# 0.01194f
C583 a_6717_14024# a_7043_14024# 0.01427f
C584 a_5731_15316# a_13753_14024# 0.01865f
C585 a_23145_13226# a_23355_13226# 0.09424f
C586 a_19073_7532# a_19203_7532# 0.70845f
C587 a_13121_11521# a_14009_11568# 0.01604f
C588 a_6854_11676# a_9444_10280# 0.05054f
C589 a_13306_11995# a_13566_11525# 0.75507f
C590 a_12849_11557# a_13592_11561# 0.38817f
C591 a_9757_7532# a_10404_6698# 0.02011f
C592 a_17791_17497# VDD 0.01806f
C593 a_10843_14024# VDD 0.50064f
C594 a_18795_13226# VDD 0.15407f
C595 a_4187_2434# CHAN0_MUX_OUT 1.28859f
C596 a_13019_11521# REF_CLK 0.35409f
C597 a_13121_11521# DLL_RESETN 0.04337f
C598 a_26043_7532# a_25630_6734# 0.01012f
C599 a_5731_5979# a_8745_6209# 0.28635f
C600 a_25913_4687# a_26043_4687# 0.70845f
C601 a_4633_1842# a_4763_1842# 0.70845f
C602 a_5731_3134# a_9323_1842# 0.01542f
C603 a_18585_1044# a_18871_1008# 0.01885f
C604 a_27705_6734# VDD 0.29962f
C605 a_9193_1842# VDD 0.4946f
C606 a_10951_5315# VDD 0.01806f
C607 a_15831_1008# VDD 0.2816f
C608 a_1721_7085# REF_MUX_SEL0 0.01315f
C609 a_1544_6734# REF_MUX_SEL1 0.1672f
C610 a_19637_16869# a_19203_16869# 0.69698f
C611 a_4187_2434# a_13123_14024# 0.0643f
C612 CHAN1_MUX_SEL2 CHAN1_MUX_SEL3 3.21891f
C613 CHAN1_MUX_SEL1 CHAN1_MUX_SEL4 0.03574f
C614 a_23437_16869# a_24084_16035# 0.02312f
C615 a_1544_16071# a_2297_16422# 0.28651f
C616 VDD CHAN2_DELAY_OUT_LAST 0.46919f
C617 a_23633_14024# a_23763_14024# 0.70845f
C618 a_9323_14024# a_9431_14024# 0.01163f
C619 a_15403_14024# a_15511_14652# 0.01697f
C620 a_5731_12471# a_6854_11144# 0.05419f
C621 a_4157_13495# a_4248_13226# 0.11672f
C622 a_15964_12471# a_16851_12491# 0.16757f
C623 a_10517_7532# a_10083_7532# 0.69698f
C624 a_10083_7532# a_10191_7532# 0.01163f
C625 a_16163_7532# a_16271_8160# 0.01697f
C626 a_4187_2434# a_11473_1842# 0.11222f
C627 a_22564_16035# VDD 0.28964f
C628 a_15077_16869# VDD 0.86016f
C629 a_5957_7532# VDD 0.85889f
C630 a_19550_6734# a_20968_6734# 0.38994f
C631 a_25717_7532# a_26185_6734# 0.19203f
C632 a_17357_4687# a_16923_4687# 0.6972f
C633 a_26395_3889# a_26471_3853# 0.01194f
C634 a_25630_3889# a_27124_3853# 0.28279f
C635 a_6283_1842# a_6391_1842# 0.01163f
C636 a_21917_1842# a_22113_1842# 0.76914f
C637 a_12363_1842# a_12471_2470# 0.01697f
C638 a_26477_1842# a_27048_1044# 0.10863f
C639 a_20831_8160# VDD 0.01806f
C640 a_20315_3889# VDD 0.1539f
C641 a_12797_4687# VDD 0.8835f
C642 a_4437_4687# CHAN2_DELAY_IN 0.05007f
C643 a_4633_4687# REF_MUX_SEL4 0.01287f
C644 a_10517_16869# a_10713_16869# 0.73897f
C645 a_4187_2434# a_17357_16869# 0.04141f
C646 a_16510_16071# a_17928_16071# 0.38994f
C647 a_13557_16869# a_13470_16071# 0.1088f
C648 a_15077_14024# a_14643_14024# 0.6972f
C649 a_4187_2434# a_8237_7532# 0.04141f
C650 a_16108_15316# a_26803_14024# 0.01192f
C651 a_22590_13226# a_24084_13190# 0.28279f
C652 a_23355_13226# a_23431_13190# 0.01194f
C653 a_4187_2434# a_15077_4687# 0.04194f
C654 a_18877_7532# a_19524_6698# 0.02011f
C655 a_7945_16071# VDD 0.30409f
C656 a_26803_14024# VDD 0.49718f
C657 a_9746_11495# VDD 0.0935f
C658 a_3449_15358# CHAN0_MUX_SEL4 0.05166f
C659 a_8155_6734# a_8231_6698# 0.01194f
C660 a_15545_6734# a_15831_6698# 0.01885f
C661 a_7390_6734# a_8884_6698# 0.28279f
C662 a_23763_7532# a_23871_8160# 0.01697f
C663 a_10843_4687# a_10430_3889# 0.01012f
C664 a_8237_4687# a_8433_4687# 0.76914f
C665 a_13470_3889# a_15755_3889# 0.39036f
C666 a_27705_3889# a_25630_3889# 0.03208f
C667 a_12797_1842# a_13557_1842# 0.05851f
C668 a_19550_1044# a_21911_1008# 0.26208f
C669 a_24875_6734# VDD 0.15406f
C670 a_2873_4240# VDD 0.46517f
C671 a_25153_1842# VDD 0.49655f
C672 a_26985_519# VDD 0.29292f
C673 a_20723_16869# a_20831_17497# 0.01697f
C674 a_12505_16071# a_10430_16071# 0.03208f
C675 a_4350_16071# a_5844_16035# 0.28279f
C676 a_5115_16071# a_5191_16035# 0.01194f
C677 a_5957_14024# a_6153_14024# 0.77122f
C678 a_5731_15316# a_12037_14024# 0.01319f
C679 a_8237_14024# a_8808_13226# 0.10863f
C680 a_13019_11521# a_13121_11521# 0.56469f
C681 a_10430_13226# a_12715_13226# 0.39036f
C682 a_12355_11557# a_13306_11995# 0.26489f
C683 a_12656_11554# a_12849_11557# 0.33075f
C684 a_4187_2434# a_27433_1842# 0.11222f
C685 a_8997_7532# a_8884_6698# 0.02055f
C686 a_9193_14024# VDD 0.4946f
C687 a_11711_17497# VDD 0.01806f
C688 a_15831_13190# VDD 0.2816f
C689 a_21917_7532# VDD 0.89148f
C690 a_11491_11918# DLL_RESETN 0.14622f
C691 a_11748_11799# REF_CLK 0.0148f
C692 a_24957_7532# a_25528_6734# 0.10864f
C693 a_24957_4687# a_25283_4687# 0.01427f
C694 a_5731_3134# a_7673_1842# 0.01865f
C695 a_6425_3889# a_6711_3853# 0.01885f
C696 a_17065_1044# a_16510_1044# 0.03209f
C697 a_15545_6734# VDD 0.29962f
C698 a_4871_5315# VDD 0.01806f
C699 a_7477_1842# VDD 0.87095f
C700 a_13368_1044# VDD 0.17274f
C701 a_1721_3176# CHAN2_MUX_SEL2 0.01315f
C702 a_1544_3134# CHAN2_MUX_SEL3 0.15976f
C703 a_1256_3134# CHAN2_MUX_SEL4 0.65005f
C704 a_18313_16869# a_18877_16869# 0.0114f
C705 a_22677_16869# a_22590_16071# 0.1088f
C706 a_27915_16071# a_27991_16035# 0.01194f
C707 VDD REF_DELAY_OUT_LAST 0.71342f
C708 a_4187_2434# a_11473_14024# 0.11222f
C709 a_13883_14024# a_13991_14652# 0.01697f
C710 a_7803_14024# a_7911_14024# 0.01163f
C711 a_9193_7532# a_9757_7532# 0.0114f
C712 a_4187_2434# a_9757_1842# 0.0414f
C713 a_8563_7532# a_8671_7532# 0.01163f
C714 a_14643_7532# a_14751_8160# 0.01697f
C715 a_12363_16869# VDD 0.92686f
C716 a_20315_16071# VDD 0.15389f
C717 a_9712_9602# VDD 0.21833f
C718 a_12797_14024# CHAN1_MUX_SEL4 0.01829f
C719 a_19963_4687# a_19550_3889# 0.01012f
C720 a_16033_4687# a_16597_4687# 0.0114f
C721 a_10843_1842# a_10951_2470# 0.01697f
C722 a_4763_1842# a_4871_1842# 0.01163f
C723 a_20593_1842# a_20723_1842# 0.70845f
C724 a_25630_1044# a_26985_519# 0.02195f
C725 a_10083_4687# VDD 0.49994f
C726 a_14751_8160# VDD 0.01806f
C727 a_17351_3853# VDD 0.28637f
C728 a_15964_5979# REF_MUX_OUT 0.01307f
C729 a_16108_5979# REF_MUX_SEL4 0.1283f
C730 a_4350_3889# CHAN2_MUX_SEL4 0.31434f
C731 a_4187_2434# a_14643_16869# 0.06627f
C732 a_9193_16869# a_9323_16869# 0.70845f
C733 a_4187_2434# a_5523_7532# 0.06627f
C734 a_16108_15316# a_25153_14024# 0.01872f
C735 a_13753_14024# a_14317_14024# 0.0114f
C736 a_17357_14024# a_17928_13226# 0.10863f
C737 a_14111_10917# a_14851_10872# 0.26905f
C738 a_4187_2434# a_12363_4687# 0.06482f
C739 a_18117_7532# a_18004_6698# 0.02055f
C740 a_25153_14024# VDD 0.49655f
C741 a_2873_16422# VDD 0.46517f
C742 a_26985_12701# VDD 0.29292f
C743 a_3449_13577# CHAN1_MUX_SEL1 0.29404f
C744 a_14025_6734# a_13470_6734# 0.03209f
C745 a_16597_4687# a_17065_3889# 0.19203f
C746 a_6913_4687# a_7043_4687# 0.70845f
C747 a_9757_4687# a_10328_3889# 0.10864f
C748 a_5731_5979# a_13883_4687# 0.01539f
C749 a_16108_3134# a_20723_1842# 0.01544f
C750 a_12037_1842# a_11603_1842# 0.6972f
C751 a_19448_1044# a_19550_1044# 0.37183f
C752 a_21911_6698# VDD 0.2822f
C753 a_23437_1842# VDD 0.87113f
C754 a_1256_3889# VDD 0.50942f
C755 a_14825_519# VDD 0.29292f
C756 a_26477_16869# a_26673_16869# 0.76914f
C757 a_19203_16869# a_19311_17497# 0.01697f
C758 a_5731_15316# a_9323_14024# 0.01542f
C759 a_4187_2434# a_27433_14024# 0.11222f
C760 a_4633_14024# a_4763_14024# 0.70845f
C761 a_18585_13226# a_18871_13190# 0.01885f
C762 a_17357_7532# a_17553_7532# 0.76914f
C763 a_4187_2434# a_25717_1842# 0.0414f
C764 a_13557_7532# a_14025_6734# 0.19203f
C765 a_8237_7532# a_7390_6734# 0.08038f
C766 a_5631_17497# VDD 0.01806f
C767 a_7477_14024# VDD 0.871f
C768 a_19203_7532# VDD 0.49737f
C769 a_13368_13226# VDD 0.17274f
C770 a_1256_6734# a_2873_7085# 0.28892f
C771 a_24957_7532# a_22590_6734# 0.02479f
C772 a_4905_3889# a_4350_3889# 0.03209f
C773 a_4157_4158# a_4324_3853# 0.02463f
C774 a_24197_4687# a_24393_4687# 0.77122f
C775 a_5731_3134# a_5957_1842# 0.01644f
C776 a_16108_3134# a_17865_3364# 0.29564f
C777 a_14025_1044# a_14311_1008# 0.01885f
C778 a_4763_1842# a_4350_1044# 0.01012f
C779 a_7288_1044# a_7364_1008# 0.01176f
C780 a_4905_6734# VDD 0.3017f
C781 a_26043_4687# VDD 0.50058f
C782 a_4763_1842# VDD 0.49875f
C783 a_10430_1044# VDD 1.08486f
C784 a_17357_16869# a_18117_16869# 0.03319f
C785 a_4187_2434# a_9757_14024# 0.0414f
C786 a_26395_16071# a_26471_16035# 0.01194f
C787 a_25630_16071# a_27124_16035# 0.28279f
C788 CHAN0_MUX_SEL2 CHAN0_MUX_SEL3 3.21891f
C789 CHAN0_MUX_SEL1 CHAN0_MUX_SEL4 0.03574f
C790 a_21917_14024# a_22113_14024# 0.76914f
C791 a_26477_14024# a_27048_13226# 0.10863f
C792 a_4187_2434# a_21483_7532# 0.06661f
C793 a_6283_14024# a_6391_14024# 0.01163f
C794 a_12363_14024# a_12471_14652# 0.01697f
C795 a_8237_7532# a_8997_7532# 0.03319f
C796 a_4187_2434# a_7043_1842# 0.06627f
C797 a_7043_7532# a_7151_7532# 0.01163f
C798 a_13123_7532# a_13231_8160# 0.01697f
C799 a_10713_16869# VDD 0.49296f
C800 a_17351_16035# VDD 0.28637f
C801 a_16510_6734# a_18795_6734# 0.39036f
C802 a_18877_4687# a_19448_3889# 0.10864f
C803 a_15077_4687# a_15837_4687# 0.02912f
C804 a_22590_3889# a_24951_3853# 0.26208f
C805 a_9323_1842# a_9431_2470# 0.01697f
C806 a_8671_8160# VDD 0.01806f
C807 a_8433_4687# VDD 0.49593f
C808 a_14888_3889# VDD 0.17499f
C809 a_8237_16869# a_8563_16869# 0.01427f
C810 a_4187_2434# a_12993_16869# 0.11169f
C811 a_27705_16071# a_25630_16071# 0.03208f
C812 a_12797_14024# a_13557_14024# 0.05851f
C813 a_4187_2434# a_5864_9057# 0.03252f
C814 a_13470_16071# a_15755_16071# 0.39036f
C815 a_19550_13226# a_21911_13190# 0.26208f
C816 a_13306_10795# a_14009_10774# 0.02454f
C817 REF_CLK REF_MUX_SEL1 0.01824f
C818 a_4187_2434# a_10713_4687# 0.11222f
C819 a_17357_7532# a_16510_6734# 0.08038f
C820 a_1256_16071# VDD 0.50942f
C821 a_23437_14024# VDD 0.87113f
C822 a_14825_12701# VDD 0.29292f
C823 a_1256_13226# CHAN1_MUX_SEL4 0.03691f
C824 a_4437_7532# REF_CLK 0.05209f
C825 a_10985_6734# a_11271_6698# 0.01885f
C826 a_5731_5979# a_12233_4687# 0.01121f
C827 a_4350_6734# a_6711_6698# 0.26208f
C828 a_9757_4687# a_7390_3889# 0.02479f
C829 a_21625_3889# a_21835_3889# 0.09424f
C830 a_10713_1842# a_11277_1842# 0.0114f
C831 a_16108_3134# a_19073_1842# 0.01872f
C832 a_17928_1044# a_18004_1008# 0.01176f
C833 a_13883_1842# a_13470_1044# 0.01012f
C834 a_19448_6734# VDD 0.17274f
C835 a_20723_1842# VDD 0.49691f
C836 a_17683_16869# a_17791_17497# 0.01697f
C837 a_4187_2434# a_25717_14024# 0.0414f
C838 a_6425_16071# a_6711_16035# 0.01885f
C839 a_25153_16869# a_25283_16869# 0.70845f
C840 a_5731_15316# a_7673_14024# 0.01865f
C841 a_17065_13226# a_16510_13226# 0.03209f
C842 a_16033_7532# a_16163_7532# 0.70845f
C843 a_11748_11799# a_11491_11918# 0.34468f
C844 CHAN2_MUX_OUT CHAN3_DELAY_IN 0.02679f
C845 a_4187_2434# a_23003_1842# 0.06391f
C846 a_6717_7532# a_6711_6698# 0.02354f
C847 a_26673_16869# VDD 0.49417f
C848 a_4763_14024# VDD 0.49875f
C849 a_10430_13226# VDD 1.08486f
C850 a_17553_7532# VDD 0.49417f
C851 a_27997_14024# CHAN1_DELAY_OUT_LAST 0.70955f
C852 a_6854_11676# DLL_RESETN 0.46676f
C853 a_22873_4687# a_23003_4687# 0.70361f
C854 a_27997_1842# a_27563_1842# 0.69646f
C855 a_7477_1842# a_7945_1044# 0.19203f
C856 a_2297_7085# VDD 0.47647f
C857 a_24393_4687# VDD 0.4946f
C858 a_17865_3364# VDD 0.29444f
C859 a_7364_1008# VDD 0.28633f
C860 a_16597_16869# a_16163_16869# 0.69698f
C861 a_4187_2434# a_7043_14024# 0.06627f
C862 a_4763_14024# a_4871_14024# 0.01163f
C863 a_4187_2434# a_19833_7532# 0.11284f
C864 a_10843_14024# a_10951_14652# 0.01697f
C865 a_20593_14024# a_20723_14024# 0.70845f
C866 a_25630_13226# a_26985_12701# 0.02195f
C867 a_7477_7532# a_7043_7532# 0.69698f
C868 a_4187_2434# a_26673_4687# 0.11222f
C869 a_4187_2434# a_5393_1842# 0.11222f
C870 a_11603_7532# a_11711_8160# 0.01697f
C871 a_5523_7532# a_5631_7532# 0.01163f
C872 a_14888_16071# VDD 0.17499f
C873 a_8997_16869# VDD 0.85889f
C874 a_14009_10774# VDD 0.31815f
C875 a_14317_4687# a_13883_4687# 0.6972f
C876 a_16108_5979# a_25283_4687# 0.01539f
C877 a_18877_4687# a_16510_3889# 0.02479f
C878 a_7803_1842# a_7911_2470# 0.01697f
C879 a_22488_3889# a_22590_3889# 0.37183f
C880 a_18877_1842# a_19073_1842# 0.76914f
C881 a_1256_289# a_1721_331# 0.13421f
C882 a_1544_1044# a_1721_1395# 0.38063f
C883 a_27997_7532# VDD 0.76025f
C884 a_6717_4687# VDD 0.88148f
C885 a_11924_3853# VDD 0.28225f
C886 a_3449_6021# REF_MUX_SEL4 0.05166f
C887 a_7477_16869# a_7673_16869# 0.73897f
C888 a_4187_2434# a_11277_16869# 0.04141f
C889 a_12037_14024# a_11603_14024# 0.6972f
C890 a_16108_15316# a_20723_14024# 0.01544f
C891 a_19448_13226# a_19550_13226# 0.37183f
C892 a_15304_10295# a_13592_11113# 0.01817f
C893 a_4187_2434# a_8997_4687# 0.04152f
C894 a_15837_7532# a_15831_6698# 0.02354f
C895 a_20723_14024# VDD 0.49691f
C896 a_26477_7532# a_26673_7532# 0.76914f
C897 a_4248_6734# a_4350_6734# 0.37183f
C898 a_5731_5979# a_10517_4687# 0.01314f
C899 a_5197_4687# a_5393_4687# 0.76914f
C900 a_7477_4687# a_7364_3853# 0.05157f
C901 a_10328_3889# a_10404_3853# 0.01176f
C902 a_16108_3134# a_17357_1842# 0.01319f
C903 a_12797_1842# a_13368_1044# 0.10864f
C904 a_21157_1842# a_21625_1044# 0.2079f
C905 a_9757_1842# a_10517_1842# 0.06198f
C906 a_16510_1044# a_16484_1008# 0.277f
C907 a_16510_6734# VDD 0.8795f
C908 a_19073_1842# VDD 0.49655f
C909 a_1721_331# VDD 0.45259f
C910 a_16163_16869# a_16271_17497# 0.01697f
C911 a_4905_16071# a_4350_16071# 0.03209f
C912 a_4157_16340# a_4324_16035# 0.02463f
C913 a_24957_16869# a_16108_15316# 0.0157f
C914 a_4187_2434# a_23003_14024# 0.06391f
C915 a_5731_15316# a_5957_14024# 0.01644f
C916 a_16108_15316# a_17865_15546# 0.29564f
C917 a_4763_14024# a_4350_13226# 0.01012f
C918 a_14025_13226# a_14311_13190# 0.01885f
C919 a_7288_13226# a_7364_13190# 0.01176f
C920 a_10232_11561# a_10520_11982# 0.43707f
C921 a_4187_2434# a_21353_1842# 0.11222f
C922 a_5197_7532# a_5844_6698# 0.02312f
C923 a_24957_16869# VDD 0.87825f
C924 a_7364_13190# VDD 0.28633f
C925 a_17865_15546# VDD 0.29444f
C926 a_15837_7532# VDD 0.87963f
C927 a_16851_12491# CHAN1_MUX_OUT 0.45865f
C928 a_25630_6734# a_27991_6698# 0.26208f
C929 a_21917_4687# a_22243_4687# 0.01427f
C930 a_5731_3134# a_11785_3364# 0.28056f
C931 a_26673_1842# a_27237_1842# 0.0114f
C932 a_5957_1842# a_6425_1044# 0.2079f
C933 a_4350_1044# a_5115_1044# 0.39037f
C934 a_22677_4687# VDD 0.9172f
C935 a_5115_1044# VDD 0.15389f
C936 a_12797_4687# CHAN2_MUX_SEL4 0.01829f
C937 a_15273_16869# a_15837_16869# 0.0114f
C938 a_4187_2434# a_27237_16869# 0.06254f
C939 a_4187_2434# a_5393_14024# 0.11222f
C940 a_22590_16071# a_24951_16035# 0.26208f
C941 a_9323_14024# a_9431_14652# 0.01697f
C942 a_4187_2434# a_18117_7532# 0.04188f
C943 a_6153_7532# a_6717_7532# 0.0114f
C944 a_4187_2434# a_24957_4687# 0.0414f
C945 a_10083_7532# a_10191_8160# 0.01697f
C946 a_4003_7532# a_4111_7532# 0.01163f
C947 a_6283_16869# VDD 0.4973f
C948 a_11924_16035# VDD 0.28225f
C949 a_6717_14024# CHAN1_MUX_SEL4 0.0195f
C950 a_26185_6734# a_26471_6698# 0.01885f
C951 a_16108_5979# a_23633_4687# 0.01872f
C952 a_12993_4687# a_13557_4687# 0.0114f
C953 a_20968_3889# a_21044_3853# 0.01176f
C954 a_16597_4687# a_16484_3853# 0.05157f
C955 a_17553_1842# a_17683_1842# 0.70845f
C956 a_6283_1842# a_6391_2470# 0.01697f
C957 a_21917_1842# a_22488_1044# 0.10864f
C958 a_25283_7532# VDD 0.49737f
C959 a_9675_3889# VDD 0.15407f
C960 a_4003_4687# VDD 0.61691f
C961 a_24631_2470# VDD 0.01806f
C962 a_3449_4240# CHAN2_MUX_SEL1 0.29404f
C963 a_14825_519# CHAN3_MUX_SEL4 0.03307f
C964 a_6153_16869# a_6283_16869# 0.70845f
C965 a_4187_2434# a_8563_16869# 0.06627f
C966 a_15077_16869# a_15545_16071# 0.2079f
C967 a_21625_16071# a_21835_16071# 0.09424f
C968 a_9323_16869# a_7390_16071# 0.01012f
C969 a_10713_14024# a_11277_14024# 0.0114f
C970 a_13883_14024# a_13470_13226# 0.01012f
C971 a_16108_15316# a_19073_14024# 0.01872f
C972 a_17928_13226# a_18004_13190# 0.01176f
C973 a_4187_2434# a_27563_7532# 0.06663f
C974 a_4187_2434# a_6283_4687# 0.06627f
C975 a_14317_7532# a_14964_6698# 0.02312f
C976 a_1721_12513# VDD 0.45352f
C977 a_19073_14024# VDD 0.49655f
C978 a_9444_10280# DLL_RESETN 0.10269f
C979 a_25153_7532# a_25283_7532# 0.70845f
C980 a_5731_5979# a_7803_4687# 0.01539f
C981 a_17065_3889# a_17275_3889# 0.09424f
C982 a_12797_1842# a_10430_1044# 0.02479f
C983 a_8997_1842# a_8563_1842# 0.6972f
C984 a_13444_6698# VDD 0.28633f
C985 a_17357_1842# VDD 0.87006f
C986 a_26395_1044# VDD 0.1539f
C987 a_10430_1044# CHAN3_MUX_SEL4 0.21179f
C988 a_23437_16869# a_23633_16869# 0.76914f
C989 a_14643_16869# a_14751_17497# 0.01697f
C990 a_4187_2434# a_21353_14024# 0.11222f
C991 a_27997_14024# a_27563_14024# 0.69646f
C992 a_7477_14024# a_7945_13226# 0.19203f
C993 a_14317_7532# a_14513_7532# 0.76914f
C994 REF_MUX_OUT CHAN2_DELAY_IN 0.02679f
C995 a_4187_2434# a_19637_1842# 0.0414f
C996 a_4437_7532# a_4350_6734# 0.1088f
C997 a_22243_16869# VDD 0.95024f
C998 a_13123_7532# VDD 0.48169f
C999 a_5115_13226# VDD 0.15389f
C1000 a_2873_16422# CHAN0_MUX_SEL1 0.13092f
C1001 a_3449_16422# CHAN0_DELAY_IN 0.01058f
C1002 a_25528_6734# a_25630_6734# 0.37183f
C1003 a_21157_4687# a_21353_4687# 0.77122f
C1004 a_25717_4687# a_25604_3853# 0.05157f
C1005 a_4437_1842# a_4157_1313# 0.01771f
C1006 a_25717_1842# a_26477_1842# 0.01669f
C1007 a_9465_1044# a_7390_1044# 0.03208f
C1008 a_19963_4687# VDD 0.50058f
C1009 a_23145_1044# VDD 0.30411f
C1010 a_4187_2434# a_24523_16869# 0.06627f
C1011 a_14317_16869# a_15077_16869# 0.03319f
C1012 a_18443_16869# a_16510_16071# 0.01012f
C1013 a_22488_16071# a_22590_16071# 0.37183f
C1014 a_18877_14024# a_19073_14024# 0.76914f
C1015 a_4187_2434# a_15403_7532# 0.06668f
C1016 a_1544_13226# a_1721_13577# 0.38063f
C1017 a_7803_14024# a_7911_14652# 0.01697f
C1018 a_1256_12471# a_1721_12513# 0.13421f
C1019 a_5197_7532# a_5957_7532# 0.03319f
C1020 a_4187_2434# a_22243_4687# 0.06315f
C1021 a_8563_7532# a_8671_8160# 0.01697f
C1022 a_4633_16869# VDD 0.49285f
C1023 a_9675_16071# VDD 0.15406f
C1024 a_24631_14652# VDD 0.01806f
C1025 a_14111_11568# VDD 0.21331f
C1026 a_13368_6734# a_13444_6698# 0.01176f
C1027 a_12037_4687# a_12797_4687# 0.02912f
C1028 a_16108_5979# a_21917_4687# 0.01307f
C1029 a_7390_3889# a_5731_3134# 0.41331f
C1030 a_19550_3889# a_19524_3853# 0.277f
C1031 a_21917_1842# a_19550_1044# 0.02479f
C1032 a_4763_1842# a_4871_2470# 0.01697f
C1033 a_25630_1044# a_26395_1044# 0.39037f
C1034 a_16510_1044# a_16108_289# 0.56108f
C1035 a_23633_7532# VDD 0.49425f
C1036 a_15964_5979# VDD 0.31771f
C1037 a_6711_3853# VDD 0.2822f
C1038 a_18551_2470# VDD 0.01806f
C1039 a_1256_3889# CHAN2_MUX_SEL4 0.03691f
C1040 a_4187_2434# a_6913_16869# 0.11222f
C1041 a_5197_16869# a_5523_16869# 0.01427f
C1042 a_16108_15316# a_17357_14024# 0.01319f
C1043 a_10328_16071# a_10404_16035# 0.01176f
C1044 a_9757_14024# a_10517_14024# 0.06198f
C1045 a_21157_14024# a_21625_13226# 0.2079f
C1046 a_12797_14024# a_13368_13226# 0.10864f
C1047 a_14851_11918# a_14757_11918# 0.28931f
C1048 a_16510_13226# a_16484_13190# 0.277f
C1049 a_12849_11557# a_14111_10917# 0.42064f
C1050 a_22113_7532# a_22677_7532# 0.0114f
C1051 a_4187_2434# a_25913_7532# 0.11284f
C1052 a_4187_2434# a_4633_4687# 0.11222f
C1053 a_13557_7532# a_13470_6734# 0.1088f
C1054 a_17357_14024# VDD 0.87006f
C1055 a_26395_13226# VDD 0.1539f
C1056 a_12907_11110# DLL_RESETN 0.04234f
C1057 a_4905_6734# a_5115_6734# 0.09424f
C1058 a_16108_5979# a_23945_6209# 0.2906f
C1059 a_5731_5979# a_6153_4687# 0.02026f
C1060 a_5197_4687# a_5191_3853# 0.02349f
C1061 a_5957_4687# a_4350_3889# 0.05231f
C1062 a_7390_3889# a_8155_3889# 0.39037f
C1063 a_7673_1842# a_8237_1842# 0.0114f
C1064 a_10517_1842# a_10404_1008# 0.05157f
C1065 a_13470_1044# a_14311_1008# 0.28268f
C1066 a_11195_6734# VDD 0.15389f
C1067 a_14643_1842# VDD 0.49684f
C1068 a_23431_1008# VDD 0.28336f
C1069 a_27997_4687# CHAN2_DELAY_OUT_LAST 0.70955f
C1070 a_4763_1842# CHAN2_MUX_SEL4 0.01225f
C1071 a_22113_16869# a_22243_16869# 0.70361f
C1072 a_13123_16869# a_13231_17497# 0.01697f
C1073 a_4187_2434# a_19637_14024# 0.0414f
C1074 a_5731_15316# a_11785_15546# 0.28056f
C1075 a_27563_16869# a_25630_16071# 0.01024f
C1076 a_4350_13226# a_5115_13226# 0.39037f
C1077 a_26673_14024# a_27237_14024# 0.0114f
C1078 a_5957_14024# a_6425_13226# 0.2079f
C1079 a_9547_11632# a_9547_11862# 0.1117f
C1080 a_5731_12471# a_12849_11557# 0.01811f
C1081 a_12993_7532# a_13123_7532# 0.70361f
C1082 a_4187_2434# a_16923_1842# 0.06627f
C1083 a_20593_16869# VDD 0.49419f
C1084 a_11473_7532# VDD 0.49426f
C1085 a_23145_13226# VDD 0.30411f
C1086 a_1544_16071# CHAN0_MUX_SEL0 0.07603f
C1087 a_1256_16071# CHAN0_MUX_SEL1 1.44243f
C1088 a_24008_6734# a_24084_6698# 0.01176f
C1089 a_19833_4687# a_19963_4687# 0.70845f
C1090 a_24957_1842# a_24523_1842# 0.6972f
C1091 a_18313_4687# VDD 0.4946f
C1092 a_27991_3853# VDD 0.28273f
C1093 a_10985_1044# VDD 0.30411f
C1094 a_13557_16869# a_13123_16869# 0.69698f
C1095 a_4187_2434# a_22873_16869# 0.11169f
C1096 a_17553_14024# a_17683_14024# 0.70845f
C1097 a_6283_14024# a_6391_14652# 0.01697f
C1098 a_20968_16071# a_21044_16035# 0.01176f
C1099 a_4187_2434# a_13753_7532# 0.11222f
C1100 a_21917_14024# a_22488_13226# 0.10864f
C1101 a_4437_7532# a_4003_7532# 0.69698f
C1102 a_4187_2434# a_20593_4687# 0.11222f
C1103 a_7043_7532# a_7151_8160# 0.01697f
C1104 a_22677_7532# a_22590_6734# 0.1088f
C1105 a_18551_14652# VDD 0.01806f
C1106 a_6711_16035# VDD 0.2822f
C1107 a_4003_14024# CHAN0_MUX_SEL4 0.01225f
C1108 a_14317_4687# a_14311_3853# 0.02349f
C1109 a_11277_4687# a_10843_4687# 0.6972f
C1110 a_16108_5979# a_19203_4687# 0.01539f
C1111 a_15077_4687# a_13470_3889# 0.05231f
C1112 a_15837_1842# a_16033_1842# 0.76914f
C1113 a_19637_1842# a_19524_1008# 0.05157f
C1114 a_8745_6209# VDD 0.29292f
C1115 a_4248_3889# VDD 0.17587f
C1116 a_12471_2470# VDD 0.02372f
C1117 VDD CHAN1_MUX_SEL3 0.41386f
C1118 a_1721_331# CHAN3_MUX_SEL4 0.05813f
C1119 a_2297_331# CHAN3_MUX_SEL3 0.01595f
C1120 a_1544_289# CHAN3_MUX_OUT 0.69943f
C1121 a_2873_331# CHAN3_MUX_SEL2 0.01422f
C1122 a_4187_2434# a_5197_16869# 0.04141f
C1123 a_4437_16869# a_4633_16869# 0.73897f
C1124 a_17065_16071# a_17275_16071# 0.09424f
C1125 a_8997_14024# a_8563_14024# 0.6972f
C1126 a_12797_14024# a_10430_13226# 0.02479f
C1127 a_6126_9506# a_5864_9057# 0.23738f
C1128 a_6854_11144# a_9712_9602# 0.67835f
C1129 a_13592_11561# a_14757_11918# 0.43239f
C1130 a_21157_7532# a_21917_7532# 0.02912f
C1131 a_4187_2434# a_24197_7532# 0.04188f
C1132 a_4187_2434# a_16108_5979# 0.21585f
C1133 a_14643_14024# VDD 0.49684f
C1134 a_23431_13190# VDD 0.28336f
C1135 a_23437_7532# a_23633_7532# 0.76914f
C1136 a_12505_3889# a_12791_3853# 0.01885f
C1137 a_6717_1842# a_7477_1842# 0.06198f
C1138 a_12715_1044# a_12791_1008# 0.01194f
C1139 a_24665_1044# a_22590_1044# 0.03208f
C1140 a_22351_5315# VDD 0.02349f
C1141 a_8231_6698# VDD 0.28357f
C1142 a_12993_1842# VDD 0.49665f
C1143 a_20968_1044# VDD 0.17499f
C1144 a_16851_3154# CHAN2_MUX_OUT 0.45865f
C1145 a_11603_16869# a_11711_17497# 0.01697f
C1146 a_18877_16869# a_16108_15316# 0.0157f
C1147 a_4187_2434# a_16923_14024# 0.06627f
C1148 a_25717_14024# a_26477_14024# 0.01669f
C1149 a_4437_14024# a_4157_13495# 0.01771f
C1150 a_9465_13226# a_7390_13226# 0.03208f
C1151 a_6326_10280# a_6126_9506# 2.84014f
C1152 a_5974_11413# a_6854_11676# 0.029f
C1153 a_4187_2434# a_15273_1842# 0.11222f
C1154 a_18877_16869# VDD 0.87825f
C1155 a_10985_13226# VDD 0.30411f
C1156 a_27991_16035# VDD 0.28273f
C1157 a_9757_7532# VDD 0.87771f
C1158 a_1544_12471# CHAN1_MUX_SEL2 0.07405f
C1159 a_1256_12471# CHAN1_MUX_SEL3 1.41161f
C1160 a_3449_12513# CHAN1_DELAY_IN 0.01017f
C1161 a_22590_6734# a_22564_6698# 0.277f
C1162 a_13470_6734# a_5731_5979# 0.41365f
C1163 a_1256_3889# a_2297_4240# 0.04619f
C1164 a_23437_4687# a_23431_3853# 0.02349f
C1165 a_24197_4687# a_22590_3889# 0.05231f
C1166 a_18877_4687# a_19203_4687# 0.01427f
C1167 a_23633_1842# a_24197_1842# 0.0114f
C1168 a_1256_3134# a_2873_3176# 0.27926f
C1169 a_22590_3889# a_16108_3134# 0.56869f
C1170 a_1544_3134# a_2297_3176# 0.27303f
C1171 a_15964_289# a_16108_289# 0.42202f
C1172 a_16597_4687# VDD 0.86971f
C1173 a_25528_3889# VDD 0.17274f
C1174 a_6717_4687# CHAN2_MUX_SEL4 0.0195f
C1175 a_12233_16869# a_12797_16869# 0.0114f
C1176 a_4187_2434# a_21157_16869# 0.04152f
C1177 a_19550_16071# a_19524_16035# 0.277f
C1178 a_4763_14024# a_4871_14652# 0.01697f
C1179 a_4187_2434# a_12037_7532# 0.04152f
C1180 a_7390_16071# a_5731_15316# 0.41331f
C1181 a_25630_13226# a_26395_13226# 0.39037f
C1182 a_21917_14024# a_19550_13226# 0.02479f
C1183 a_16510_13226# a_16108_12471# 0.56108f
C1184 a_4187_2434# a_18877_4687# 0.0414f
C1185 a_5523_7532# a_5631_8160# 0.01697f
C1186 a_4248_16071# VDD 0.17587f
C1187 a_12471_14652# VDD 0.02372f
C1188 a_15964_15316# CHAN0_MUX_SEL4 0.5544f
C1189 a_16108_5979# a_17553_4687# 0.01872f
C1190 a_10430_6734# a_11195_6734# 0.39037f
C1191 a_9953_4687# a_10517_4687# 0.0114f
C1192 a_21625_6734# a_19550_6734# 0.03208f
C1193 a_16510_3889# a_17351_3853# 0.28268f
C1194 a_27563_4687# a_27671_4687# 0.01163f
C1195 a_12797_4687# a_13444_3853# 0.02011f
C1196 a_14513_1842# a_14643_1842# 0.70845f
C1197 a_22590_1044# a_24008_1044# 0.38994f
C1198 a_18585_3889# VDD 0.29742f
C1199 a_2873_6021# VDD 0.46598f
C1200 a_6391_2470# VDD 0.01806f
C1201 VDD CHAN0_MUX_SEL3 0.41788f
C1202 a_7390_16071# a_8155_16071# 0.39037f
C1203 a_5197_16869# a_5768_16071# 0.10863f
C1204 a_7673_14024# a_8237_14024# 0.0114f
C1205 a_13470_13226# a_14311_13190# 0.28268f
C1206 a_10517_14024# a_10404_13190# 0.05157f
C1207 a_13306_11995# a_14111_11568# 0.097f
C1208 a_12849_11557# a_15108_11799# 0.10225f
C1209 a_20397_7532# a_19963_7532# 0.6972f
C1210 a_13121_11521# a_14851_11918# 0.03404f
C1211 a_13019_11521# a_15688_11557# 0.0195f
C1212 a_22677_7532# a_22873_7532# 0.73022f
C1213 a_23111_17497# VDD 0.01806f
C1214 a_12993_14024# VDD 0.49665f
C1215 a_20968_13226# VDD 0.17499f
C1216 a_13592_11561# REF_CLK 0.11539f
C1217 a_27237_7532# a_27124_6698# 0.02055f
C1218 a_5731_5979# a_15765_6153# 0.23301f
C1219 a_10985_3889# a_10430_3889# 0.03209f
C1220 a_4350_3889# a_5768_3889# 0.38994f
C1221 a_27237_4687# a_26803_4687# 0.6972f
C1222 a_5957_1842# a_5523_1842# 0.6972f
C1223 a_8237_1842# a_8231_1008# 0.02349f
C1224 a_5731_3134# a_11473_1842# 0.01872f
C1225 a_8997_1842# a_7390_1044# 0.05231f
C1226 a_10430_1044# a_11924_1008# 0.28279f
C1227 a_11195_1044# a_11271_1008# 0.01194f
C1228 a_5768_6734# VDD 0.17499f
C1229 a_16271_5315# VDD 0.01806f
C1230 a_18004_1008# VDD 0.28225f
C1231 a_11277_1842# VDD 0.87182f
C1232 a_2873_7085# REF_MUX_SEL1 0.13092f
C1233 a_10083_16869# a_10191_17497# 0.01697f
C1234 a_20397_16869# a_20593_16869# 0.76914f
C1235 a_4187_2434# a_15273_14024# 0.11222f
C1236 VDD CHAN3_DELAY_IN 1.50263f
C1237 CHAN1_MUX_OUT REF_CLK 0.0767f
C1238 a_24957_14024# a_24523_14024# 0.6972f
C1239 a_11277_7532# a_11473_7532# 0.76914f
C1240 a_4187_2434# a_13557_1842# 0.04101f
C1241 a_16163_16869# VDD 0.4973f
C1242 a_25528_16071# VDD 0.17274f
C1243 a_7043_7532# VDD 0.49723f
C1244 a_14851_10872# REF_DELAY_OUT_LAST 0.02109f
C1245 a_27237_7532# a_27705_6734# 0.2079f
C1246 a_18117_4687# a_18313_4687# 0.77122f
C1247 a_21917_4687# a_22564_3853# 0.02011f
C1248 a_22677_1842# a_23437_1842# 0.01323f
C1249 a_21917_1842# a_16108_289# 0.01053f
C1250 a_26151_8160# VDD 0.01806f
C1251 a_22590_3889# VDD 0.98586f
C1252 a_13883_4687# VDD 0.50061f
C1253 a_1721_1395# VDD 0.4533f
C1254 a_11277_16869# a_12037_16869# 0.03319f
C1255 a_4187_2434# a_18443_16869# 0.06627f
C1256 a_14317_16869# a_14888_16071# 0.10863f
C1257 a_15837_14024# a_16033_14024# 0.76914f
C1258 a_4187_2434# a_9323_7532# 0.06627f
C1259 a_19637_14024# a_19524_13190# 0.05157f
C1260 a_4187_2434# a_16163_4687# 0.06627f
C1261 a_4003_7532# a_4111_8160# 0.01697f
C1262 a_4187_2434# a_25630_3889# 0.02246f
C1263 a_18585_16071# VDD 0.29722f
C1264 a_6391_14652# VDD 0.01806f
C1265 a_5731_15316# CHAN0_MUX_OUT 1.04829f
C1266 a_8745_15546# CHAN0_MUX_SEL4 0.04472f
C1267 a_8997_4687# a_9757_4687# 0.02912f
C1268 a_12037_4687# a_11924_3853# 0.02055f
C1269 a_26043_4687# a_26151_4687# 0.01163f
C1270 a_27705_3889# a_27991_3853# 0.01885f
C1271 a_15755_3889# a_15831_3853# 0.01194f
C1272 a_17357_1842# a_17351_1008# 0.02349f
C1273 a_18117_1842# a_16510_1044# 0.05231f
C1274 a_16108_3134# a_24523_1842# 0.01542f
C1275 a_27048_6734# VDD 0.17499f
C1276 a_27237_1842# VDD 0.86278f
C1277 a_12505_16071# a_12791_16035# 0.01885f
C1278 a_6717_14024# a_7477_14024# 0.06198f
C1279 a_24665_13226# a_22590_13226# 0.03208f
C1280 a_12715_13226# a_12791_13190# 0.01194f
C1281 a_12849_11557# a_13566_11525# 0.27346f
C1282 a_13121_11521# a_13592_11561# 0.01445f
C1283 a_19073_7532# a_19637_7532# 0.0114f
C1284 a_17031_17497# VDD 0.01806f
C1285 a_18004_13190# VDD 0.28225f
C1286 a_11277_14024# VDD 0.87182f
C1287 a_4187_2434# CHAN0_MUX_SEL4 0.01921f
C1288 a_13019_11521# DLL_RESETN 0.01429f
C1289 a_12656_11554# REF_CLK 0.01215f
C1290 a_26477_7532# a_25630_6734# 0.08038f
C1291 a_25913_4687# a_26477_4687# 0.0114f
C1292 a_7945_3889# a_8231_3853# 0.01885f
C1293 a_6717_1842# a_7364_1008# 0.02011f
C1294 a_4633_1842# a_5197_1842# 0.0114f
C1295 a_5731_3134# a_9757_1842# 0.01307f
C1296 a_18585_1044# a_18795_1044# 0.09424f
C1297 a_26185_6734# VDD 0.30409f
C1298 a_8563_1842# VDD 0.49684f
C1299 a_10191_5315# VDD 0.01806f
C1300 a_15755_1044# VDD 0.15389f
C1301 a_1544_6734# REF_MUX_SEL0 0.07603f
C1302 a_1256_6734# REF_MUX_SEL1 1.44243f
C1303 a_8563_16869# a_8671_17497# 0.01697f
C1304 a_19073_16869# a_19203_16869# 0.70845f
C1305 VDD CHAN2_DELAY_IN 1.50753f
C1306 a_1256_16071# a_2297_16422# 0.04619f
C1307 a_23437_16869# a_24008_16071# 0.10863f
C1308 a_4187_2434# a_13557_14024# 0.04101f
C1309 a_1544_15316# a_2297_15358# 0.27303f
C1310 a_1256_15316# a_2873_15358# 0.27926f
C1311 a_22590_16071# a_16108_15316# 0.56869f
C1312 a_23633_14024# a_24197_14024# 0.0114f
C1313 a_5731_12471# a_6126_9506# 0.02557f
C1314 a_15964_12471# a_16108_12471# 0.42202f
C1315 a_9953_7532# a_10083_7532# 0.70845f
C1316 a_4187_2434# a_10843_1842# 0.06627f
C1317 a_22590_16071# VDD 0.98586f
C1318 a_14513_16869# VDD 0.49417f
C1319 a_1721_13577# VDD 0.4533f
C1320 a_5393_7532# VDD 0.49417f
C1321 a_4187_2434# CHAN3_DELAY_OUT_LAST 0.21225f
C1322 a_19550_6734# a_20391_6698# 0.28268f
C1323 a_16793_4687# a_16923_4687# 0.70845f
C1324 a_25630_3889# a_27048_3889# 0.38994f
C1325 a_21157_4687# a_21044_3853# 0.02055f
C1326 a_16510_3889# a_17865_3364# 0.02165f
C1327 a_26477_1842# a_26471_1008# 0.02349f
C1328 a_21917_1842# a_21483_1842# 0.6972f
C1329 a_27237_1842# a_25630_1044# 0.05253f
C1330 a_20071_8160# VDD 0.01806f
C1331 a_12233_4687# VDD 0.59884f
C1332 a_19524_3853# VDD 0.28633f
C1333 a_4003_4687# REF_MUX_SEL4 0.01225f
C1334 a_10517_16869# a_10083_16869# 0.69698f
C1335 a_4187_2434# a_16793_16869# 0.11222f
C1336 a_16510_16071# a_17351_16035# 0.28268f
C1337 a_4187_2434# a_25630_16071# 0.02246f
C1338 a_4187_2434# a_7673_7532# 0.11222f
C1339 a_14513_14024# a_14643_14024# 0.70845f
C1340 a_22590_13226# a_24008_13226# 0.38994f
C1341 a_4187_2434# a_14513_4687# 0.11222f
C1342 a_27237_14024# VDD 0.86278f
C1343 a_9547_11862# VDD 0.08951f
C1344 a_2873_15358# CHAN0_MUX_SEL4 0.04916f
C1345 a_3449_15358# CHAN0_MUX_SEL3 0.28429f
C1346 a_2297_15358# CHAN0_MUX_OUT 0.01179f
C1347 a_15545_6734# a_15755_6734# 0.09424f
C1348 a_7390_6734# a_8808_6734# 0.38994f
C1349 a_8237_4687# a_7803_4687# 0.6972f
C1350 a_18117_4687# a_18585_3889# 0.2079f
C1351 a_24523_4687# a_24631_4687# 0.01163f
C1352 a_11277_4687# a_10430_3889# 0.08038f
C1353 a_13470_3889# a_14964_3853# 0.28279f
C1354 a_14235_3889# a_14311_3853# 0.01194f
C1355 a_26185_3889# a_25630_3889# 0.03209f
C1356 a_15837_1842# a_16484_1008# 0.02011f
C1357 a_12797_1842# a_12993_1842# 0.74917f
C1358 a_16108_3134# a_22873_1842# 0.01865f
C1359 a_19550_1044# a_21835_1044# 0.39036f
C1360 a_24084_6698# VDD 0.28225f
C1361 a_24523_1842# VDD 0.50001f
C1362 a_23945_519# VDD 0.29292f
C1363 a_5957_14024# a_5523_14024# 0.6972f
C1364 a_10985_16071# a_10430_16071# 0.03209f
C1365 a_5731_15316# a_11473_14024# 0.01872f
C1366 a_4350_16071# a_5768_16071# 0.38994f
C1367 a_8237_14024# a_8231_13190# 0.02349f
C1368 a_8997_14024# a_7390_13226# 0.05231f
C1369 a_11195_13226# a_11271_13190# 0.01194f
C1370 a_12355_11557# a_12849_11557# 0.07687f
C1371 a_10430_13226# a_11924_13190# 0.28279f
C1372 a_18117_7532# a_18877_7532# 0.02912f
C1373 a_4187_2434# a_26803_1842# 0.06627f
C1374 a_9323_7532# a_7390_6734# 0.01012f
C1375 a_15077_7532# a_15545_6734# 0.2079f
C1376 a_10951_17497# VDD 0.01806f
C1377 a_8563_14024# VDD 0.49684f
C1378 a_21353_7532# VDD 0.49294f
C1379 a_15755_13226# VDD 0.15389f
C1380 a_11748_11799# DLL_RESETN 0.11133f
C1381 a_10751_11568# REF_CLK 0.01931f
C1382 a_24957_7532# a_24951_6698# 0.02354f
C1383 a_24957_4687# a_25717_4687# 0.06198f
C1384 a_5731_3134# a_7043_1842# 0.01539f
C1385 a_6425_3889# a_6635_3889# 0.09424f
C1386 a_5957_1842# a_5844_1008# 0.02055f
C1387 a_7390_1044# a_9751_1008# 0.26208f
C1388 a_14025_6734# VDD 0.30409f
C1389 a_4111_5315# VDD 0.01866f
C1390 a_6913_1842# VDD 0.49655f
C1391 a_12791_1008# VDD 0.28232f
C1392 a_3449_3176# CHAN2_DELAY_IN 0.01017f
C1393 a_1256_3134# CHAN2_MUX_SEL3 1.41161f
C1394 a_1544_3134# CHAN2_MUX_SEL2 0.07405f
C1395 a_7043_16869# a_7151_17497# 0.01697f
C1396 a_4187_2434# a_10843_14024# 0.06627f
C1397 a_21917_14024# a_16108_12471# 0.01053f
C1398 a_22677_14024# a_23437_14024# 0.01323f
C1399 a_4187_2434# a_9193_1842# 0.11222f
C1400 a_12797_16869# VDD 0.87928f
C1401 a_19524_16035# VDD 0.28633f
C1402 a_9444_9602# VDD 0.0107f
C1403 a_4187_2434# CHAN2_DELAY_OUT_LAST 0.21225f
C1404 a_18795_6734# a_18871_6698# 0.01194f
C1405 a_15837_4687# a_16163_4687# 0.01427f
C1406 a_20397_4687# a_19550_3889# 0.08038f
C1407 a_24957_1842# a_25604_1008# 0.02011f
C1408 a_20593_1842# a_21157_1842# 0.0114f
C1409 a_5705_519# a_5731_289# 0.28954f
C1410 a_13991_8160# VDD 0.01806f
C1411 a_10517_4687# VDD 0.871f
C1412 a_17275_3889# VDD 0.15389f
C1413 a_15964_5979# REF_MUX_SEL4 0.5544f
C1414 a_9193_16869# a_9757_16869# 0.0114f
C1415 a_4187_2434# a_15077_16869# 0.04194f
C1416 a_4187_2434# a_5957_7532# 0.04152f
C1417 a_15755_16071# a_15831_16035# 0.01194f
C1418 a_16108_15316# a_24523_14024# 0.01542f
C1419 a_27705_16071# a_27991_16035# 0.01885f
C1420 a_17357_14024# a_17351_13190# 0.02349f
C1421 a_18117_14024# a_16510_13226# 0.05231f
C1422 a_4187_2434# a_12797_4687# 0.0414f
C1423 a_18443_7532# a_16510_6734# 0.01012f
C1424 a_24523_14024# VDD 0.50001f
C1425 a_23945_12701# VDD 0.29292f
C1426 a_3449_13577# CHAN1_MUX_SEL0 0.10753f
C1427 a_6913_4687# a_7477_4687# 0.0114f
C1428 a_5731_5979# a_14317_4687# 0.01319f
C1429 a_9757_4687# a_9751_3853# 0.02354f
C1430 a_23003_4687# a_23111_4687# 0.01163f
C1431 a_11473_1842# a_11603_1842# 0.70845f
C1432 a_16108_3134# a_21157_1842# 0.01319f
C1433 a_23145_3889# a_23431_3853# 0.01885f
C1434 a_15077_1842# a_14964_1008# 0.02055f
C1435 a_21835_6734# VDD 0.15406f
C1436 a_22873_1842# VDD 0.49642f
C1437 a_11785_519# VDD 0.29292f
C1438 a_26477_16869# a_26043_16869# 0.6972f
C1439 a_4633_14024# a_5197_14024# 0.0114f
C1440 a_5731_15316# a_9757_14024# 0.01307f
C1441 a_4187_2434# a_26803_14024# 0.06627f
C1442 a_7945_16071# a_8231_16035# 0.01885f
C1443 a_6717_14024# a_7364_13190# 0.02011f
C1444 a_18585_13226# a_18795_13226# 0.09424f
C1445 a_12158_11557# a_12355_11557# 0.12454f
C1446 a_17357_7532# a_16923_7532# 0.6972f
C1447 CHAN3_DELAY_IN CHAN3_MUX_SEL4 0.0663f
C1448 CHAN3_MUX_SEL0 CHAN3_MUX_SEL2 0.01204f
C1449 a_4187_2434# a_25153_1842# 0.11222f
C1450 a_4871_17497# VDD 0.01806f
C1451 a_6913_14024# VDD 0.49655f
C1452 a_19637_7532# VDD 0.86712f
C1453 a_12791_13190# VDD 0.28232f
C1454 a_9946_11995# DLL_RESETN 0.09997f
C1455 a_23437_7532# a_24084_6698# 0.02312f
C1456 a_4157_4158# a_4350_3889# 0.04624f
C1457 a_24197_4687# a_23763_4687# 0.6972f
C1458 a_16108_3134# a_16851_3154# 0.06181f
C1459 a_5197_1842# a_4350_1044# 0.08038f
C1460 a_8997_1842# a_9465_1044# 0.2079f
C1461 a_14025_1044# a_14235_1044# 0.09424f
C1462 a_7288_1044# a_7390_1044# 0.37183f
C1463 a_4157_7003# VDD 0.48946f
C1464 a_26477_4687# VDD 0.87185f
C1465 a_5197_1842# VDD 0.87047f
C1466 a_10328_1044# VDD 0.17274f
C1467 a_1544_1044# CHAN3_MUX_OUT 0.04241f
C1468 a_2297_1395# CHAN3_MUX_SEL1 0.01995f
C1469 a_4187_2434# a_9193_14024# 0.11222f
C1470 a_5523_16869# a_5631_17497# 0.01697f
C1471 a_17357_16869# a_17553_16869# 0.76914f
C1472 a_21917_14024# a_21483_14024# 0.6972f
C1473 a_25630_16071# a_27048_16071# 0.38994f
C1474 a_16510_16071# a_17865_15546# 0.02165f
C1475 a_4187_2434# a_21917_7532# 0.04176f
C1476 a_26477_14024# a_26471_13190# 0.02349f
C1477 a_27237_14024# a_25630_13226# 0.05253f
C1478 a_8237_7532# a_8433_7532# 0.76914f
C1479 a_4187_2434# a_7477_1842# 0.0414f
C1480 a_10083_16869# VDD 0.49727f
C1481 a_17275_16071# VDD 0.15389f
C1482 a_15688_11093# VDD 0.30345f
C1483 a_4187_2434# REF_DELAY_OUT_LAST 1.08837f
C1484 a_4350_6734# a_5705_6209# 0.02005f
C1485 a_17275_6734# a_17351_6698# 0.01194f
C1486 a_16510_6734# a_18004_6698# 0.28279f
C1487 a_15077_4687# a_15273_4687# 0.77122f
C1488 a_18877_4687# a_18871_3853# 0.02354f
C1489 a_19637_1842# a_20397_1842# 0.01669f
C1490 a_22590_3889# a_24875_3889# 0.39036f
C1491 a_24197_1842# a_24084_1008# 0.02055f
C1492 a_7911_8160# VDD 0.01806f
C1493 a_7803_4687# VDD 0.50058f
C1494 a_14311_3853# VDD 0.28357f
C1495 a_8745_6209# REF_MUX_SEL4 0.04472f
C1496 a_5731_5979# REF_MUX_OUT 1.04829f
C1497 a_4187_2434# a_12363_16869# 0.06482f
C1498 a_8237_16869# a_8997_16869# 0.03319f
C1499 a_10843_16869# a_10430_16071# 0.01012f
C1500 a_16108_15316# a_22873_14024# 0.01865f
C1501 a_26185_16071# a_25630_16071# 0.03209f
C1502 a_12797_14024# a_12993_14024# 0.74917f
C1503 a_14235_16071# a_14311_16035# 0.01194f
C1504 a_4187_2434# a_9712_9602# 0.13545f
C1505 a_13470_16071# a_14964_16035# 0.28279f
C1506 a_15837_14024# a_16484_13190# 0.02011f
C1507 a_19550_13226# a_21835_13226# 0.39036f
C1508 a_13566_11018# a_14009_10774# 0.02242f
C1509 a_15304_10295# a_15108_11015# 0.01986f
C1510 a_13306_10795# a_13592_11113# 0.41329f
C1511 REF_CLK REF_MUX_SEL0 0.11907f
C1512 a_4187_2434# a_10083_4687# 0.06627f
C1513 a_22873_14024# VDD 0.49647f
C1514 a_11785_12701# VDD 0.29292f
C1515 a_10985_6734# a_11195_6734# 0.09424f
C1516 a_5731_5979# a_11603_4687# 0.01544f
C1517 a_5957_4687# a_6717_4687# 0.02912f
C1518 a_4350_6734# a_6635_6734# 0.39036f
C1519 a_10430_3889# a_12791_3853# 0.26208f
C1520 a_21483_4687# a_21591_4687# 0.01163f
C1521 a_27563_4687# a_27671_5315# 0.01697f
C1522 a_8237_4687# a_8884_3853# 0.02312f
C1523 a_16108_3134# a_18443_1842# 0.01542f
C1524 a_22677_1842# a_23145_1044# 0.19203f
C1525 a_14317_1842# a_13470_1044# 0.08038f
C1526 a_18871_6698# VDD 0.2822f
C1527 a_21157_1842# VDD 0.85962f
C1528 a_25153_16869# a_25717_16869# 0.0114f
C1529 a_4187_2434# a_25153_14024# 0.11222f
C1530 a_6425_16071# a_6635_16071# 0.09424f
C1531 a_5731_15316# a_7043_14024# 0.01539f
C1532 a_7390_13226# a_9751_13190# 0.26208f
C1533 a_5957_14024# a_5844_13190# 0.02055f
C1534 a_10751_11568# a_11491_11918# 0.26905f
C1535 a_16033_7532# a_16597_7532# 0.0114f
C1536 CHAN2_MUX_SEL4 CHAN3_DELAY_IN 0.01332f
C1537 a_4187_2434# a_23437_1842# 0.04012f
C1538 a_26043_16869# VDD 0.4973f
C1539 a_5197_14024# VDD 0.87049f
C1540 a_10328_13226# VDD 0.17274f
C1541 a_16923_7532# VDD 0.4973f
C1542 a_6854_11676# CHAN1_MUX_OUT 0.04362f
C1543 a_5974_11413# DLL_RESETN 0.02002f
C1544 a_9757_7532# REF_MUX_SEL4 0.01829f
C1545 a_19550_6734# a_20905_6209# 0.02165f
C1546 a_22873_4687# a_23437_4687# 0.0114f
C1547 a_27433_1842# a_27563_1842# 0.70845f
C1548 a_5768_1044# a_5844_1008# 0.01176f
C1549 a_23763_4687# VDD 0.49688f
C1550 a_7390_1044# VDD 0.8686f
C1551 a_16851_3154# VDD 0.52304f
C1552 a_16033_16869# a_16163_16869# 0.70845f
C1553 a_4003_16869# a_4111_17497# 0.01697f
C1554 a_4187_2434# a_7477_14024# 0.0414f
C1555 a_19963_16869# a_19550_16071# 0.01012f
C1556 a_20593_14024# a_21157_14024# 0.0114f
C1557 a_4187_2434# a_19203_7532# 0.06661f
C1558 a_5705_12701# a_5731_12471# 0.28954f
C1559 a_24957_14024# a_25604_13190# 0.02011f
C1560 a_6913_7532# a_7043_7532# 0.70845f
C1561 a_4187_2434# a_26043_4687# 0.06627f
C1562 a_4187_2434# a_4763_1842# 0.06627f
C1563 a_18877_7532# a_16108_5979# 0.0157f
C1564 a_8433_16869# VDD 0.49417f
C1565 a_14311_16035# VDD 0.28357f
C1566 a_13592_11113# VDD 0.11685f
C1567 a_12849_11557# REF_DELAY_OUT_LAST 0.01791f
C1568 a_16108_5979# a_25717_4687# 0.01314f
C1569 a_13753_4687# a_13883_4687# 0.70845f
C1570 a_10430_3889# a_11785_3364# 0.02058f
C1571 a_17357_4687# a_18004_3853# 0.02312f
C1572 a_18877_1842# a_18443_1842# 0.6972f
C1573 a_1256_289# a_1544_289# 1.25711f
C1574 a_1256_1044# a_1721_1395# 0.13421f
C1575 a_23437_1842# a_22590_1044# 0.08038f
C1576 a_27433_7532# VDD 0.49285f
C1577 a_11848_3889# VDD 0.17499f
C1578 a_6153_4687# VDD 0.4946f
C1579 a_2297_6021# REF_MUX_OUT 0.01179f
C1580 a_3449_6021# REF_MUX_SEL3 0.28429f
C1581 a_2873_6021# REF_MUX_SEL4 0.04916f
C1582 a_4187_2434# a_10713_16869# 0.11222f
C1583 a_7477_16869# a_7043_16869# 0.69698f
C1584 a_9757_16869# a_10328_16071# 0.10864f
C1585 a_16597_16869# a_17065_16071# 0.19203f
C1586 a_23145_16071# a_23431_16035# 0.01885f
C1587 a_11473_14024# a_11603_14024# 0.70845f
C1588 a_16108_15316# a_21157_14024# 0.01319f
C1589 a_15077_14024# a_14964_13190# 0.02055f
C1590 a_13106_11047# a_13132_11110# 0.1657f
C1591 a_12907_10876# a_12907_11110# 0.1117f
C1592 a_4187_2434# a_8433_4687# 0.11222f
C1593 a_21157_14024# VDD 0.85962f
C1594 a_26477_7532# a_26043_7532# 0.6972f
C1595 a_5731_5979# a_9953_4687# 0.01872f
C1596 a_5197_4687# a_4763_4687# 0.6972f
C1597 a_26043_4687# a_26151_5315# 0.01697f
C1598 a_10328_3889# a_10430_3889# 0.37183f
C1599 a_7477_4687# a_7390_3889# 0.1088f
C1600 a_19963_4687# a_20071_4687# 0.01163f
C1601 a_16108_3134# a_16793_1842# 0.01843f
C1602 a_9757_1842# a_9953_1842# 0.76914f
C1603 a_12797_1842# a_12791_1008# 0.02354f
C1604 a_16408_1044# a_16484_1008# 0.01176f
C1605 a_16408_6734# VDD 0.17274f
C1606 a_18443_1842# VDD 0.50001f
C1607 a_1544_289# VDD 0.39269f
C1608 a_24197_16869# a_24957_16869# 0.02912f
C1609 a_4157_16340# a_4350_16071# 0.04624f
C1610 a_4187_2434# a_23437_14024# 0.04011f
C1611 a_8997_14024# a_9465_13226# 0.2079f
C1612 a_16108_15316# a_16851_15336# 0.06181f
C1613 a_5197_14024# a_4350_13226# 0.08038f
C1614 a_7288_13226# a_7390_13226# 0.37183f
C1615 a_14025_13226# a_14235_13226# 0.09424f
C1616 a_15077_7532# a_15837_7532# 0.02912f
C1617 CHAN2_DELAY_IN CHAN2_MUX_SEL4 0.0663f
C1618 CHAN2_MUX_SEL0 CHAN2_MUX_SEL2 0.01204f
C1619 a_4187_2434# a_20723_1842# 0.06627f
C1620 a_5197_7532# a_5768_6734# 0.10863f
C1621 a_24393_16869# VDD 0.49285f
C1622 a_16851_15336# VDD 0.52304f
C1623 a_7390_13226# VDD 0.8686f
C1624 a_15273_7532# VDD 0.49298f
C1625 a_4157_16340# CHAN0_MUX_SEL4 0.08229f
C1626 a_16108_12471# CHAN1_MUX_OUT 0.24265f
C1627 a_21917_4687# a_22677_4687# 0.06198f
C1628 a_25630_6734# a_27915_6734# 0.39036f
C1629 a_26477_4687# a_27124_3853# 0.02312f
C1630 a_26477_1842# a_26803_1842# 0.01427f
C1631 a_9465_1044# a_9751_1008# 0.01885f
C1632 a_4350_1044# a_4324_1008# 0.277f
C1633 a_22113_4687# VDD 0.55574f
C1634 a_4324_1008# VDD 0.28597f
C1635 a_4187_2434# a_26673_16869# 0.11222f
C1636 a_22590_16071# a_24875_16071# 0.39036f
C1637 a_18877_16869# a_19448_16071# 0.10864f
C1638 a_4187_2434# a_4763_14024# 0.06627f
C1639 a_4187_2434# a_17553_7532# 0.11284f
C1640 a_19637_14024# a_20397_14024# 0.01669f
C1641 a_24197_14024# a_24084_13190# 0.02055f
C1642 a_4187_2434# a_24393_4687# 0.11222f
C1643 a_11848_16071# VDD 0.17499f
C1644 a_6717_16869# VDD 0.87726f
C1645 a_15304_10295# VDD 0.72158f
C1646 a_13470_6734# a_15831_6698# 0.26208f
C1647 a_26185_6734# a_26395_6734# 0.09424f
C1648 a_16597_4687# a_16510_3889# 0.1088f
C1649 a_21917_1842# a_21911_1008# 0.02354f
C1650 a_17553_1842# a_18117_1842# 0.0114f
C1651 a_27048_1044# a_27124_1008# 0.01176f
C1652 a_25717_7532# VDD 0.86712f
C1653 a_4437_4687# VDD 0.872f
C1654 a_8884_3853# VDD 0.28225f
C1655 a_23871_2470# VDD 0.01806f
C1656 a_3449_4240# CHAN2_MUX_SEL0 0.10753f
C1657 a_11785_519# CHAN3_MUX_SEL4 0.03255f
C1658 a_4187_2434# a_8997_16869# 0.04152f
C1659 a_9757_16869# a_7390_16071# 0.02479f
C1660 a_6153_16869# a_6717_16869# 0.0114f
C1661 a_10430_16071# a_12791_16035# 0.26208f
C1662 a_16108_15316# a_18443_14024# 0.01542f
C1663 a_14317_14024# a_13470_13226# 0.08038f
C1664 a_22677_14024# a_23145_13226# 0.19203f
C1665 a_4187_2434# a_27997_7532# 0.04038f
C1666 a_4187_2434# a_6717_4687# 0.0414f
C1667 a_14317_7532# a_14888_6734# 0.10863f
C1668 a_18443_14024# VDD 0.50001f
C1669 a_1544_12471# VDD 0.39529f
C1670 a_25153_7532# a_25717_7532# 0.0114f
C1671 a_18443_4687# a_18551_4687# 0.01163f
C1672 a_24523_4687# a_24631_5315# 0.01697f
C1673 a_5731_5979# a_8237_4687# 0.01319f
C1674 a_8808_3889# a_8884_3853# 0.01176f
C1675 a_18585_3889# a_16510_3889# 0.03208f
C1676 a_11277_1842# a_11924_1008# 0.02312f
C1677 a_8433_1842# a_8563_1842# 0.70845f
C1678 a_13470_6734# VDD 0.87936f
C1679 a_16793_1842# VDD 0.49408f
C1680 a_25604_1008# VDD 0.28633f
C1681 a_23437_16869# a_23003_16869# 0.6972f
C1682 a_4187_2434# a_20723_14024# 0.06627f
C1683 a_27433_14024# a_27563_14024# 0.70845f
C1684 a_5768_13226# a_5844_13190# 0.01176f
C1685 a_14317_7532# a_13883_7532# 0.6972f
C1686 REF_MUX_SEL4 CHAN2_DELAY_IN 0.01332f
C1687 a_4187_2434# a_19073_1842# 0.11222f
C1688 a_22677_16869# VDD 0.91482f
C1689 a_13557_7532# VDD 0.8672f
C1690 a_4324_13190# VDD 0.28607f
C1691 a_2873_16422# CHAN0_MUX_SEL0 0.01504f
C1692 a_5731_12471# REF_CLK 0.01996f
C1693 a_21157_4687# a_20723_4687# 0.6972f
C1694 a_25717_4687# a_25630_3889# 0.1088f
C1695 a_25717_1842# a_25913_1842# 0.73897f
C1696 a_7945_1044# a_7390_1044# 0.03209f
C1697 a_20397_4687# VDD 0.87185f
C1698 a_5705_3364# VDD 0.29556f
C1699 a_21625_1044# VDD 0.29742f
C1700 a_4187_2434# a_24957_16869# 0.0414f
C1701 a_14317_16869# a_14513_16869# 0.76914f
C1702 a_10430_16071# a_11785_15546# 0.02058f
C1703 a_18877_16869# a_16510_16071# 0.02479f
C1704 a_1256_13226# a_1721_13577# 0.13421f
C1705 a_23437_14024# a_22590_13226# 0.08038f
C1706 a_18877_14024# a_18443_14024# 0.6972f
C1707 a_4187_2434# a_15837_7532# 0.04182f
C1708 a_1256_12471# a_1544_12471# 1.25711f
C1709 a_5197_7532# a_5393_7532# 0.76914f
C1710 a_4187_2434# a_22677_4687# 0.04055f
C1711 a_4003_16869# VDD 0.61559f
C1712 a_8884_16035# VDD 0.28225f
C1713 a_23871_14652# VDD 0.01806f
C1714 a_13368_6734# a_13470_6734# 0.37183f
C1715 a_16108_5979# a_21353_4687# 0.01872f
C1716 a_12037_4687# a_12233_4687# 0.77122f
C1717 a_19448_3889# a_19524_3853# 0.01176f
C1718 a_20397_1842# a_21044_1008# 0.02312f
C1719 a_16597_1842# a_17357_1842# 0.01669f
C1720 a_25630_1044# a_25604_1008# 0.277f
C1721 a_16510_1044# a_15964_289# 0.05416f
C1722 a_15765_6153# VDD 0.36528f
C1723 a_23003_7532# VDD 0.48123f
C1724 a_6635_3889# VDD 0.15407f
C1725 a_17791_2470# VDD 0.01806f
C1726 a_5197_16869# a_5957_16869# 0.03319f
C1727 a_4187_2434# a_6283_16869# 0.06627f
C1728 a_7477_16869# a_7364_16035# 0.05157f
C1729 a_16108_15316# a_16793_14024# 0.01843f
C1730 a_10328_16071# a_10430_16071# 0.37183f
C1731 a_9757_14024# a_9953_14024# 0.76914f
C1732 a_12797_14024# a_12791_13190# 0.02354f
C1733 a_12849_11557# a_14009_10774# 0.03463f
C1734 a_14851_11918# a_15688_11557# 0.08776f
C1735 a_16408_13226# a_16484_13190# 0.01176f
C1736 a_21917_7532# a_22243_7532# 0.01427f
C1737 a_4187_2434# a_25283_7532# 0.06661f
C1738 a_4187_2434# a_4003_4687# 0.05992f
C1739 a_16793_14024# VDD 0.49408f
C1740 a_25604_13190# VDD 0.28633f
C1741 a_12907_10876# DLL_RESETN 0.02177f
C1742 a_24197_7532# a_24957_7532# 0.02912f
C1743 a_16108_5979# a_20905_6209# 0.2906f
C1744 a_24957_7532# a_16108_5979# 0.0157f
C1745 a_5731_5979# a_5523_4687# 0.01562f
C1746 a_6425_6734# a_4350_6734# 0.03208f
C1747 a_23003_4687# a_23111_5315# 0.01697f
C1748 a_16923_4687# a_17031_4687# 0.01163f
C1749 a_5731_3134# a_15273_1842# 0.01872f
C1750 a_7390_3889# a_7364_3853# 0.277f
C1751 a_24665_1044# a_24951_1008# 0.01885f
C1752 a_13470_1044# a_14235_1044# 0.39037f
C1753 a_10517_1842# a_10430_1044# 0.1088f
C1754 a_10404_6698# VDD 0.28633f
C1755 a_15077_1842# VDD 0.86069f
C1756 a_27671_5315# VDD 0.01806f
C1757 a_23355_1044# VDD 0.1539f
C1758 a_4003_1842# CHAN3_DELAY_IN 0.54998f
C1759 a_7390_1044# CHAN3_MUX_SEL4 0.34655f
C1760 a_22113_16869# a_22677_16869# 0.0114f
C1761 a_4187_2434# a_19073_14024# 0.11222f
C1762 a_9465_13226# a_9751_13190# 0.01885f
C1763 a_4350_13226# a_4324_13190# 0.277f
C1764 a_26477_14024# a_26803_14024# 0.01427f
C1765 a_5731_12471# a_13121_11521# 0.02284f
C1766 a_12993_7532# a_13557_7532# 0.0114f
C1767 REF_MUX_SEL0 REF_MUX_SEL2 0.01204f
C1768 a_4187_2434# a_17357_1842# 0.0414f
C1769 a_19963_16869# VDD 0.4973f
C1770 a_5705_15546# VDD 0.29556f
C1771 a_10843_7532# VDD 0.49736f
C1772 a_21625_13226# VDD 0.29742f
C1773 a_1256_16071# CHAN0_MUX_SEL0 0.3314f
C1774 a_5705_12701# CHAN1_MUX_SEL4 0.03556f
C1775 a_13470_6734# a_14825_6209# 0.02058f
C1776 a_19833_4687# a_20397_4687# 0.0114f
C1777 a_24393_1842# a_24523_1842# 0.70845f
C1778 a_17683_4687# VDD 0.49684f
C1779 a_9465_1044# VDD 0.29742f
C1780 a_27915_3889# VDD 0.15389f
C1781 a_16597_16869# a_16484_16035# 0.05157f
C1782 a_12993_16869# a_13123_16869# 0.70361f
C1783 a_4187_2434# a_22243_16869# 0.06315f
C1784 a_4187_2434# a_13123_7532# 0.0643f
C1785 a_17553_14024# a_18117_14024# 0.0114f
C1786 a_21917_14024# a_21911_13190# 0.02354f
C1787 a_27048_13226# a_27124_13190# 0.01176f
C1788 a_4187_2434# a_19963_4687# 0.06627f
C1789 a_6635_16071# VDD 0.15406f
C1790 a_17791_14652# VDD 0.01806f
C1791 a_16108_5979# a_19637_4687# 0.01314f
C1792 a_11848_6734# a_11924_6698# 0.01176f
C1793 a_21625_6734# a_21911_6698# 0.01885f
C1794 a_10713_4687# a_10843_4687# 0.70845f
C1795 a_4350_3889# a_5731_3134# 0.41099f
C1796 a_15837_1842# a_15403_1842# 0.6972f
C1797 a_19637_1842# a_19550_1044# 0.1088f
C1798 a_5731_5979# VDD 0.98095f
C1799 a_11711_2470# VDD 0.01806f
C1800 VDD CHAN1_MUX_SEL2 0.68063f
C1801 a_1544_289# CHAN3_MUX_SEL4 0.47529f
C1802 a_2297_331# CHAN3_MUX_SEL2 0.10655f
C1803 a_1256_289# CHAN3_MUX_OUT 0.1134f
C1804 a_4187_2434# a_4633_16869# 0.11222f
C1805 a_4437_16869# a_4003_16869# 0.69698f
C1806 a_18585_16071# a_16510_16071# 0.03208f
C1807 a_8808_16071# a_8884_16035# 0.01176f
C1808 a_8433_14024# a_8563_14024# 0.70845f
C1809 a_11277_14024# a_11924_13190# 0.02312f
C1810 a_6854_11144# a_9444_9602# 0.8486f
C1811 a_21157_7532# a_21353_7532# 0.77122f
C1812 a_4187_2434# a_23633_7532# 0.11286f
C1813 a_15077_14024# VDD 0.86069f
C1814 a_23355_13226# VDD 0.1539f
C1815 a_13470_16071# CHAN0_MUX_SEL4 0.256f
C1816 a_23437_7532# a_23003_7532# 0.6972f
C1817 a_21483_4687# a_21591_5315# 0.01697f
C1818 a_15403_4687# a_15511_4687# 0.01163f
C1819 a_12505_3889# a_12715_3889# 0.09424f
C1820 a_6717_1842# a_6913_1842# 0.76914f
C1821 a_23145_1044# a_22590_1044# 0.03209f
C1822 a_21591_5315# VDD 0.01806f
C1823 a_8155_6734# VDD 0.15389f
C1824 a_12363_1842# VDD 0.92885f
C1825 a_20391_1008# VDD 0.28336f
C1826 a_4157_7003# REF_MUX_SEL4 0.08229f
C1827 a_16108_3134# CHAN2_MUX_OUT 0.24265f
C1828 a_25717_16869# a_25604_16035# 0.05157f
C1829 a_4187_2434# a_17357_14024# 0.0414f
C1830 a_21157_16869# a_21917_16869# 0.02912f
C1831 a_25717_14024# a_25913_14024# 0.73897f
C1832 VDD CHAN3_MUX_OUT 0.3597f
C1833 a_7945_13226# a_7390_13226# 0.03209f
C1834 a_6326_10280# a_6854_11676# 1.31745f
C1835 a_12037_7532# a_12797_7532# 0.02912f
C1836 a_4187_2434# a_14643_1842# 0.06627f
C1837 a_18313_16869# VDD 0.49285f
C1838 a_27915_16071# VDD 0.15389f
C1839 a_9465_13226# VDD 0.29742f
C1840 a_9193_7532# VDD 0.49285f
C1841 a_1256_12471# CHAN1_MUX_SEL2 0.33134f
C1842 a_15464_9374# REF_DELAY_OUT_LAST 0.02565f
C1843 a_22488_6734# a_22564_6698# 0.01176f
C1844 a_18877_4687# a_19637_4687# 0.06198f
C1845 a_23437_1842# a_23763_1842# 0.01427f
C1846 a_1256_3134# a_2297_3176# 0.04261f
C1847 a_1544_3134# a_1721_3176# 0.36963f
C1848 a_15765_463# a_16108_289# 0.42004f
C1849 a_16033_4687# VDD 0.49413f
C1850 a_24951_3853# VDD 0.2822f
C1851 a_4187_2434# a_20593_16869# 0.11222f
C1852 a_4187_2434# a_11473_7532# 0.11222f
C1853 a_19448_16071# a_19524_16035# 0.01176f
C1854 a_16597_14024# a_17357_14024# 0.01669f
C1855 a_16510_13226# a_15964_12471# 0.05416f
C1856 a_25630_13226# a_25604_13190# 0.277f
C1857 a_20397_14024# a_21044_13190# 0.02312f
C1858 a_15464_9374# a_9712_9602# 0.01237f
C1859 a_4187_2434# a_18313_4687# 0.11222f
C1860 a_11711_14652# VDD 0.01806f
C1861 a_15765_15490# CHAN0_MUX_SEL4 0.65508f
C1862 a_10430_6734# a_10404_6698# 0.277f
C1863 a_16108_5979# a_16923_4687# 0.01073f
C1864 a_9757_4687# a_10083_4687# 0.01427f
C1865 a_20105_6734# a_19550_6734# 0.03209f
C1866 a_16510_3889# a_17275_3889# 0.39037f
C1867 a_16108_3134# a_26673_1842# 0.01872f
C1868 a_14513_1842# a_15077_1842# 0.0114f
C1869 a_22590_1044# a_23431_1008# 0.28268f
C1870 a_2297_6021# VDD 0.47572f
C1871 a_17065_3889# VDD 0.3023f
C1872 a_5631_2470# VDD 0.01806f
C1873 VDD CHAN0_MUX_SEL2 0.67328f
C1874 a_7390_16071# a_7364_16035# 0.277f
C1875 a_5957_16869# a_4350_16071# 0.05231f
C1876 a_5197_16869# a_5191_16035# 0.02349f
C1877 a_5731_15316# a_15273_14024# 0.01872f
C1878 a_24665_13226# a_24951_13190# 0.01885f
C1879 a_10517_14024# a_10430_13226# 0.1088f
C1880 a_13470_13226# a_14235_13226# 0.39037f
C1881 a_13306_11995# a_13880_11982# 0.31978f
C1882 a_13592_11561# a_14009_11568# 0.37583f
C1883 a_13019_11521# a_14851_11918# 0.01651f
C1884 a_19833_7532# a_19963_7532# 0.70845f
C1885 a_12849_11557# a_14111_11568# 0.42174f
C1886 a_13121_11521# a_15108_11799# 0.03701f
C1887 a_10843_7532# a_10430_6734# 0.01012f
C1888 a_22351_17497# VDD 0.02349f
C1889 a_20391_13190# VDD 0.28336f
C1890 a_12363_14024# VDD 0.92885f
C1891 a_13566_11525# REF_CLK 0.01538f
C1892 a_27563_7532# a_25630_6734# 0.01024f
C1893 a_5731_5979# a_14825_6209# 0.28056f
C1894 a_26673_4687# a_26803_4687# 0.70845f
C1895 a_19963_4687# a_20071_5315# 0.01697f
C1896 a_13883_4687# a_13991_4687# 0.01163f
C1897 a_4350_3889# a_5191_3853# 0.28268f
C1898 a_5731_3134# a_10843_1842# 0.01539f
C1899 a_5393_1842# a_5523_1842# 0.70845f
C1900 a_10430_1044# a_11848_1044# 0.38994f
C1901 a_20105_1044# a_20391_1008# 0.01885f
C1902 a_5191_6698# VDD 0.28637f
C1903 a_15511_5315# VDD 0.01806f
C1904 a_10713_1842# VDD 0.49555f
C1905 a_17928_1044# VDD 0.17499f
C1906 a_2873_7085# REF_MUX_SEL0 0.01504f
C1907 a_20397_16869# a_19963_16869# 0.6972f
C1908 a_4187_2434# a_14643_14024# 0.06627f
C1909 a_24393_14024# a_24523_14024# 0.70845f
C1910 VDD CHAN2_MUX_OUT 0.76779f
C1911 CHAN1_MUX_OUT DLL_RESETN 0.0503f
C1912 a_11277_7532# a_10843_7532# 0.6972f
C1913 a_4187_2434# a_12993_1842# 0.11169f
C1914 a_16597_16869# VDD 0.86886f
C1915 a_24951_16035# VDD 0.2822f
C1916 a_7477_7532# VDD 0.86712f
C1917 a_18117_4687# a_17683_4687# 0.6972f
C1918 a_10430_6734# a_5731_5979# 0.41176f
C1919 a_19550_3889# a_16108_3134# 0.58202f
C1920 a_22677_1842# a_22873_1842# 0.73022f
C1921 a_5731_289# a_16108_289# 0.01334f
C1922 a_25391_8160# VDD 0.01806f
C1923 a_22488_3889# VDD 0.1824f
C1924 a_14317_4687# VDD 0.87185f
C1925 a_1544_1044# VDD 0.46485f
C1926 a_4187_2434# a_18877_16869# 0.0414f
C1927 a_11277_16869# a_11473_16869# 0.76914f
C1928 a_15077_16869# a_13470_16071# 0.05231f
C1929 a_4350_16071# a_5731_15316# 0.41099f
C1930 a_14317_16869# a_14311_16035# 0.02349f
C1931 a_15837_14024# a_15403_14024# 0.6972f
C1932 a_4187_2434# a_9757_7532# 0.0414f
C1933 a_19637_14024# a_19550_13226# 0.1088f
C1934 a_9444_10280# a_5864_9057# 0.06832f
C1935 a_4187_2434# a_16597_4687# 0.0414f
C1936 a_19963_7532# a_19550_6734# 0.01012f
C1937 a_17065_16071# VDD 0.3023f
C1938 a_5631_14652# VDD 0.01806f
C1939 a_10649_11568# VDD 0.24892f
C1940 a_5731_15316# CHAN0_MUX_SEL4 4.60702f
C1941 a_17065_6734# a_17351_6698# 0.01885f
C1942 a_8997_4687# a_9193_4687# 0.77122f
C1943 a_12363_4687# a_10430_3889# 0.01012f
C1944 a_27705_3889# a_27915_3889# 0.09424f
C1945 a_19637_4687# a_20105_3889# 0.19203f
C1946 a_13557_1842# a_14317_1842# 0.01669f
C1947 a_16108_3134# a_24957_1842# 0.01307f
C1948 a_21835_1044# a_21911_1008# 0.01194f
C1949 a_26471_6698# VDD 0.28357f
C1950 a_6425_3889# VDD 0.29742f
C1951 a_26673_1842# VDD 0.49593f
C1952 a_12505_16071# a_12715_16071# 0.09424f
C1953 a_6717_14024# a_6913_14024# 0.76914f
C1954 a_6326_10280# a_9444_10280# 0.01269f
C1955 a_23145_13226# a_22590_13226# 0.03209f
C1956 a_13121_11521# a_13566_11525# 0.01158f
C1957 a_13019_11521# a_13592_11561# 0.04178f
C1958 a_18877_7532# a_19203_7532# 0.01427f
C1959 a_9757_7532# a_10328_6734# 0.10864f
C1960 a_16597_7532# a_17065_6734# 0.19203f
C1961 a_10713_14024# VDD 0.49555f
C1962 a_16271_17497# VDD 0.01806f
C1963 a_17928_13226# VDD 0.17499f
C1964 a_13019_11521# CHAN1_MUX_OUT 0.273f
C1965 a_12355_11557# REF_CLK 1.0042f
C1966 a_12656_11554# DLL_RESETN 0.11782f
C1967 a_18443_4687# a_18551_5315# 0.01697f
C1968 a_4437_4687# a_4905_3889# 0.19203f
C1969 a_12363_4687# a_12471_4687# 0.01163f
C1970 a_7945_3889# a_8155_3889# 0.09424f
C1971 a_5731_3134# a_9193_1842# 0.01872f
C1972 a_24665_6734# VDD 0.29722f
C1973 a_8997_1842# VDD 0.85955f
C1974 a_9431_5315# VDD 0.01806f
C1975 a_14964_1008# VDD 0.28225f
C1976 a_3449_6021# REF_CLK 0.01017f
C1977 a_1256_6734# REF_MUX_SEL0 0.3314f
C1978 a_5705_3364# CHAN2_MUX_SEL4 0.03556f
C1979 a_19073_16869# a_19637_16869# 0.0114f
C1980 a_23437_16869# a_23431_16035# 0.02349f
C1981 a_1256_15316# a_2297_15358# 0.04261f
C1982 VDD REF_MUX_OUT 0.76779f
C1983 a_24197_16869# a_22590_16071# 0.05231f
C1984 a_1544_15316# a_1721_15358# 0.36963f
C1985 a_4187_2434# a_12993_14024# 0.11169f
C1986 a_23437_14024# a_23763_14024# 0.01427f
C1987 a_5731_12471# a_6854_11676# 0.02306f
C1988 a_15765_12645# a_16108_12471# 0.42004f
C1989 a_9953_7532# a_10517_7532# 0.0114f
C1990 a_4187_2434# a_11277_1842# 0.0414f
C1991 a_22488_16071# VDD 0.1824f
C1992 a_13883_16869# VDD 0.49733f
C1993 a_1544_13226# VDD 0.46485f
C1994 a_4763_7532# VDD 0.4973f
C1995 a_4187_2434# CHAN3_DELAY_IN 0.07719f
C1996 a_7390_6734# a_8745_6209# 0.01756f
C1997 a_19550_6734# a_20315_6734# 0.39037f
C1998 a_16793_4687# a_17357_4687# 0.0114f
C1999 a_16510_3889# a_16851_3154# 0.02131f
C2000 a_21483_4687# a_19550_3889# 0.01012f
C2001 a_25630_3889# a_26471_3853# 0.28268f
C2002 a_21353_1842# a_21483_1842# 0.70845f
C2003 a_19311_8160# VDD 0.01806f
C2004 a_11603_4687# VDD 0.49753f
C2005 a_19550_3889# VDD 0.8993f
C2006 a_27563_16869# a_27671_16869# 0.01163f
C2007 a_12797_16869# a_13444_16035# 0.02011f
C2008 a_4187_2434# a_16163_16869# 0.06627f
C2009 a_9953_16869# a_10083_16869# 0.70845f
C2010 a_16510_16071# a_17275_16071# 0.39037f
C2011 a_16108_15316# a_26673_14024# 0.01872f
C2012 a_14513_14024# a_15077_14024# 0.0114f
C2013 a_4187_2434# a_7043_7532# 0.06627f
C2014 a_22590_13226# a_23431_13190# 0.28268f
C2015 a_14851_10872# a_15688_11093# 0.08776f
C2016 a_4187_2434# a_13883_4687# 0.06627f
C2017 a_18877_7532# a_19448_6734# 0.10864f
C2018 a_6425_16071# VDD 0.29722f
C2019 a_9547_11632# VDD 0.15246f
C2020 a_26673_14024# VDD 0.49593f
C2021 a_2297_15358# CHAN0_MUX_SEL4 0.04338f
C2022 a_3449_15358# CHAN0_MUX_SEL2 0.10741f
C2023 a_2873_15358# CHAN0_MUX_SEL3 0.12606f
C2024 a_7390_6734# a_8231_6698# 0.28268f
C2025 a_7673_4687# a_7803_4687# 0.70845f
C2026 a_5731_5979# a_15403_4687# 0.01563f
C2027 a_13470_3889# a_14888_3889# 0.38994f
C2028 a_12797_1842# a_12363_1842# 0.6972f
C2029 a_20315_1044# a_20391_1008# 0.01194f
C2030 a_19550_1044# a_21044_1008# 0.28279f
C2031 a_24008_6734# VDD 0.17499f
C2032 a_24957_1842# VDD 0.88247f
C2033 a_20905_519# VDD 0.29292f
C2034 a_13470_6734# REF_MUX_SEL4 0.256f
C2035 a_27237_16869# a_27433_16869# 0.77122f
C2036 a_5393_14024# a_5523_14024# 0.70845f
C2037 a_5731_15316# a_10843_14024# 0.01539f
C2038 a_4350_16071# a_5191_16035# 0.28268f
C2039 a_12656_11554# a_13019_11521# 0.04193f
C2040 a_10430_13226# a_11848_13226# 0.38994f
C2041 a_12355_11557# a_13121_11521# 0.05795f
C2042 a_20105_13226# a_20391_13190# 0.01885f
C2043 a_18117_7532# a_18313_7532# 0.77122f
C2044 CHAN3_MUX_SEL4 CHAN3_MUX_OUT 0.91933f
C2045 a_4187_2434# a_27237_1842# 0.06189f
C2046 a_9757_7532# a_7390_6734# 0.02479f
C2047 a_8997_14024# VDD 0.85955f
C2048 a_10191_17497# VDD 0.01806f
C2049 a_20723_7532# VDD 0.49677f
C2050 a_14964_13190# VDD 0.28225f
C2051 a_10751_11568# DLL_RESETN 0.45018f
C2052 a_25630_6734# a_16108_5979# 0.52614f
C2053 a_24957_4687# a_25153_4687# 0.76914f
C2054 a_16923_4687# a_17031_5315# 0.01697f
C2055 a_10843_4687# a_10951_4687# 0.01163f
C2056 a_5731_3134# a_7477_1842# 0.01314f
C2057 a_10517_1842# a_10985_1044# 0.19203f
C2058 a_7390_1044# a_9675_1044# 0.39036f
C2059 a_6283_1842# a_4350_1044# 0.01012f
C2060 a_12505_6734# VDD 0.29855f
C2061 a_6283_1842# VDD 0.50001f
C2062 a_27563_4687# VDD 0.50391f
C2063 a_12715_1044# VDD 0.15484f
C2064 a_1256_3134# CHAN2_MUX_SEL2 0.33134f
C2065 a_18117_16869# a_18877_16869# 0.02912f
C2066 a_19550_16071# a_16108_15316# 0.58202f
C2067 CHAN0_MUX_OUT CHAN1_DELAY_IN 0.02679f
C2068 a_4187_2434# a_11277_14024# 0.0414f
C2069 a_21917_16869# a_22564_16035# 0.02011f
C2070 a_22677_14024# a_22873_14024# 0.73022f
C2071 a_5731_12471# a_16108_12471# 0.01334f
C2072 a_8997_7532# a_9757_7532# 0.02912f
C2073 a_4187_2434# a_8563_1842# 0.06627f
C2074 a_12233_16869# VDD 0.59709f
C2075 a_19550_16071# VDD 0.8993f
C2076 a_4187_2434# CHAN2_DELAY_IN 0.07974f
C2077 a_15837_4687# a_16597_4687# 0.06198f
C2078 a_24875_3889# a_24951_3853# 0.01194f
C2079 a_20397_1842# a_20723_1842# 0.01427f
C2080 a_13231_8160# VDD 0.01806f
C2081 a_9953_4687# VDD 0.49655f
C2082 a_16484_3853# VDD 0.28687f
C2083 a_15765_6153# REF_MUX_SEL4 0.65508f
C2084 a_4187_2434# a_14513_16869# 0.11222f
C2085 a_12037_16869# a_11924_16035# 0.02055f
C2086 a_26043_16869# a_26151_16869# 0.01163f
C2087 a_13557_14024# a_14317_14024# 0.01669f
C2088 a_27705_16071# a_27915_16071# 0.09424f
C2089 a_4187_2434# a_5393_7532# 0.11222f
C2090 a_16108_15316# a_24957_14024# 0.01307f
C2091 a_21835_13226# a_21911_13190# 0.01194f
C2092 a_13592_11113# a_14851_10872# 0.01529f
C2093 a_4187_2434# a_12233_4687# 0.11169f
C2094 a_18877_7532# a_16510_6734# 0.02479f
C2095 a_24957_14024# VDD 0.88247f
C2096 a_20905_12701# VDD 0.29292f
C2097 a_4157_13495# CHAN1_DELAY_IN 0.50642f
C2098 a_6635_6734# a_6711_6698# 0.01194f
C2099 a_6717_4687# a_7043_4687# 0.01427f
C2100 a_5731_5979# a_13753_4687# 0.01865f
C2101 a_23145_3889# a_23355_3889# 0.09424f
C2102 a_11473_1842# a_12037_1842# 0.0114f
C2103 a_16108_3134# a_20593_1842# 0.01872f
C2104 a_15403_1842# a_13470_1044# 0.01012f
C2105 a_24197_1842# a_24665_1044# 0.2079f
C2106 a_21044_6698# VDD 0.28225f
C2107 a_22243_1842# VDD 0.95073f
C2108 a_25913_16869# a_26043_16869# 0.70845f
C2109 a_4187_2434# a_27237_14024# 0.06189f
C2110 a_7945_16071# a_8155_16071# 0.09424f
C2111 a_5731_15316# a_9193_14024# 0.01872f
C2112 a_16793_7532# a_16923_7532# 0.70845f
C2113 CHAN3_MUX_SEL0 CHAN3_MUX_SEL1 3.14917f
C2114 a_4187_2434# a_24523_1842# 0.06627f
C2115 a_7477_7532# a_7364_6698# 0.05157f
C2116 a_4111_17497# VDD 0.01866f
C2117 a_6283_14024# VDD 0.50001f
C2118 a_12715_13226# VDD 0.15484f
C2119 a_19073_7532# VDD 0.49426f
C2120 a_9772_11533# DLL_RESETN 0.06592f
C2121 a_1544_6734# a_2297_7085# 0.28651f
C2122 a_23437_7532# a_24008_6734# 0.10863f
C2123 a_4157_4158# a_4248_3889# 0.11672f
C2124 a_23633_4687# a_23763_4687# 0.70845f
C2125 a_15403_4687# a_15511_5315# 0.01697f
C2126 a_9323_4687# a_9431_4687# 0.01163f
C2127 a_15964_3134# a_16851_3154# 0.16757f
C2128 a_15545_1044# a_13470_1044# 0.03208f
C2129 a_3449_7085# VDD 0.46731f
C2130 a_25913_4687# VDD 0.49553f
C2131 a_9751_1008# VDD 0.2822f
C2132 a_4633_1842# VDD 0.49523f
C2133 a_1544_1044# CHAN3_MUX_SEL4 0.02586f
C2134 a_1256_1044# CHAN3_MUX_OUT 0.02466f
C2135 a_2297_1395# CHAN3_MUX_SEL0 0.10655f
C2136 a_21157_16869# a_21044_16035# 0.02055f
C2137 a_17357_16869# a_16923_16869# 0.6972f
C2138 a_4187_2434# a_8563_14024# 0.06627f
C2139 a_25630_16071# a_26471_16035# 0.28268f
C2140 a_21353_14024# a_21483_14024# 0.70845f
C2141 a_16510_16071# a_16851_15336# 0.02131f
C2142 a_4187_2434# a_21353_7532# 0.11284f
C2143 a_8237_7532# a_7803_7532# 0.6972f
C2144 a_4187_2434# a_6913_1842# 0.11222f
C2145 a_10517_16869# VDD 0.86712f
C2146 a_16484_16035# VDD 0.28687f
C2147 a_15108_11015# VDD 0.13728f
C2148 a_16108_5979# a_26803_4687# 0.01192f
C2149 a_15077_4687# a_14643_4687# 0.6972f
C2150 a_16510_6734# a_17928_6734# 0.38994f
C2151 a_19637_1842# a_19833_1842# 0.73897f
C2152 a_23355_3889# a_23431_3853# 0.01194f
C2153 a_22590_3889# a_24084_3853# 0.28279f
C2154 a_24523_1842# a_22590_1044# 0.01012f
C2155 a_15837_1842# a_15964_289# 0.02f
C2156 a_22590_1044# a_23945_519# 0.02165f
C2157 a_7151_8160# VDD 0.01806f
C2158 a_8237_4687# VDD 0.87185f
C2159 a_14235_3889# VDD 0.1539f
C2160 a_5731_5979# REF_MUX_SEL4 4.60702f
C2161 a_4187_2434# a_12797_16869# 0.0414f
C2162 a_8237_16869# a_8433_16869# 0.76914f
C2163 a_24523_16869# a_24631_16869# 0.01163f
C2164 a_18117_16869# a_18585_16071# 0.2079f
C2165 a_11277_16869# a_10430_16071# 0.08038f
C2166 a_12797_14024# a_12363_14024# 0.6972f
C2167 a_13470_16071# a_14888_16071# 0.38994f
C2168 a_20315_13226# a_20391_13190# 0.01194f
C2169 a_19550_13226# a_21044_13190# 0.28279f
C2170 a_15304_10295# a_14851_10872# 0.05156f
C2171 a_13566_11018# a_13592_11113# 0.36952f
C2172 a_4187_2434# a_10517_4687# 0.0414f
C2173 a_16597_7532# a_16484_6698# 0.05157f
C2174 a_22243_14024# VDD 0.95241f
C2175 a_1721_13577# CHAN1_MUX_SEL0 0.01315f
C2176 a_1544_13226# CHAN1_MUX_SEL1 0.1672f
C2177 a_5864_9057# DLL_RESETN 0.1727f
C2178 a_9712_9602# REF_CLK 0.05046f
C2179 a_27237_7532# a_27433_7532# 0.77122f
C2180 a_12505_6734# a_10430_6734# 0.03208f
C2181 a_5731_5979# a_12037_4687# 0.01319f
C2182 a_4350_6734# a_5844_6698# 0.28279f
C2183 a_5957_4687# a_6153_4687# 0.77122f
C2184 a_5115_6734# a_5191_6698# 0.01194f
C2185 a_10430_3889# a_12715_3889# 0.39036f
C2186 a_8237_4687# a_8808_3889# 0.10863f
C2187 a_16108_3134# a_18877_1842# 0.01307f
C2188 a_10517_1842# a_11277_1842# 0.01669f
C2189 a_16510_1044# a_18871_1008# 0.26208f
C2190 a_18795_6734# VDD 0.15406f
C2191 a_20593_1842# VDD 0.49594f
C2192 a_4187_2434# a_24523_14024# 0.06627f
C2193 a_24957_16869# a_25283_16869# 0.01427f
C2194 a_10517_14024# a_10985_13226# 0.19203f
C2195 a_6283_14024# a_4350_13226# 0.01012f
C2196 a_5731_15316# a_7477_14024# 0.01314f
C2197 a_7390_13226# a_9675_13226# 0.39036f
C2198 a_10649_11568# a_11397_11918# 0.01058f
C2199 a_10751_11568# a_11748_11799# 0.03061f
C2200 a_15837_7532# a_16163_7532# 0.01427f
C2201 CHAN2_MUX_SEL4 CHAN2_MUX_OUT 0.91933f
C2202 a_4187_2434# a_22873_1842# 0.11169f
C2203 a_26477_16869# VDD 0.86919f
C2204 a_9751_13190# VDD 0.2822f
C2205 a_4633_14024# VDD 0.49523f
C2206 a_17357_7532# VDD 0.86919f
C2207 a_27915_6734# a_27991_6698# 0.01194f
C2208 a_13883_4687# a_13991_5315# 0.01697f
C2209 a_7803_4687# a_7911_4687# 0.01163f
C2210 a_27433_1842# a_27997_1842# 0.0114f
C2211 a_24197_4687# VDD 0.85998f
C2212 a_7288_1044# VDD 0.17274f
C2213 a_16108_3134# VDD 1.64187f
C2214 a_16033_16869# a_16597_16869# 0.0114f
C2215 a_4187_2434# a_6913_14024# 0.11222f
C2216 a_20397_16869# a_19550_16071# 0.08038f
C2217 a_4187_2434# a_19637_7532# 0.04176f
C2218 a_20397_14024# a_20723_14024# 0.01427f
C2219 a_24875_16071# a_24951_16035# 0.01194f
C2220 a_6913_7532# a_7477_7532# 0.0114f
C2221 a_4187_2434# a_26477_4687# 0.04145f
C2222 a_4187_2434# a_5197_1842# 0.0414f
C2223 a_7803_16869# VDD 0.4973f
C2224 a_14235_16071# VDD 0.15389f
C2225 a_13306_10795# VDD 0.79687f
C2226 a_13121_11521# REF_DELAY_OUT_LAST 0.13178f
C2227 a_16108_5979# a_25153_4687# 0.01872f
C2228 a_13753_4687# a_14317_4687# 0.0114f
C2229 a_17357_4687# a_17928_3889# 0.10863f
C2230 a_18313_1842# a_18443_1842# 0.70845f
C2231 a_1256_1044# a_1544_1044# 1.26509f
C2232 a_26803_7532# VDD 0.49671f
C2233 a_5523_4687# VDD 0.49684f
C2234 a_11271_3853# VDD 0.28357f
C2235 a_2297_6021# REF_MUX_SEL4 0.04338f
C2236 a_3449_6021# REF_MUX_SEL2 0.10741f
C2237 a_2873_6021# REF_MUX_SEL3 0.12606f
C2238 a_6913_16869# a_7043_16869# 0.70845f
C2239 a_4187_2434# a_10083_16869# 0.06627f
C2240 a_23145_16071# a_23355_16071# 0.09424f
C2241 a_23003_16869# a_23111_16869# 0.01163f
C2242 a_9757_16869# a_9751_16035# 0.02354f
C2243 a_11473_14024# a_12037_14024# 0.0114f
C2244 a_16108_15316# a_20593_14024# 0.01872f
C2245 a_15403_14024# a_13470_13226# 0.01012f
C2246 a_24197_14024# a_24665_13226# 0.2079f
C2247 a_13106_11047# a_12907_11110# 0.14994f
C2248 a_4187_2434# a_7803_4687# 0.06627f
C2249 a_20593_14024# VDD 0.49594f
C2250 a_25913_7532# a_26043_7532# 0.70845f
C2251 a_5731_5979# a_9323_4687# 0.01542f
C2252 a_4633_4687# a_4763_4687# 0.70845f
C2253 a_18585_3889# a_18871_3853# 0.01885f
C2254 a_26803_1842# a_26911_1842# 0.01163f
C2255 a_16108_3134# a_16163_1842# 0.0155f
C2256 a_9757_1842# a_9323_1842# 0.6972f
C2257 a_16408_1044# a_16510_1044# 0.37183f
C2258 a_15831_6698# VDD 0.2816f
C2259 a_1256_289# VDD 0.40292f
C2260 a_18877_1842# VDD 0.88247f
C2261 a_24197_16869# a_24393_16869# 0.77122f
C2262 a_4187_2434# a_22873_14024# 0.11169f
C2263 a_4157_16340# a_4248_16071# 0.11672f
C2264 a_15964_15316# a_16851_15336# 0.16757f
C2265 a_9946_11995# a_10751_11568# 0.097f
C2266 a_10232_11561# a_10649_11568# 0.37583f
C2267 a_15545_13226# a_13470_13226# 0.03208f
C2268 a_15077_7532# a_15273_7532# 0.77122f
C2269 CHAN2_MUX_SEL0 CHAN2_MUX_SEL1 3.14917f
C2270 a_4187_2434# a_21157_1842# 0.04141f
C2271 a_5957_7532# a_4350_6734# 0.05231f
C2272 a_5197_7532# a_5191_6698# 0.02349f
C2273 a_16108_15316# VDD 1.64187f
C2274 a_23763_16869# VDD 0.49674f
C2275 a_7288_13226# VDD 0.17274f
C2276 a_14643_7532# VDD 0.49675f
C2277 a_16108_12471# CHAN1_MUX_SEL4 0.1283f
C2278 a_15964_12471# CHAN1_MUX_OUT 0.01307f
C2279 a_6283_4687# a_6391_4687# 0.01163f
C2280 a_12363_4687# a_12471_5315# 0.01697f
C2281 a_21917_4687# a_22113_4687# 0.76914f
C2282 a_26395_6734# a_26471_6698# 0.01194f
C2283 a_25630_6734# a_27124_6698# 0.28279f
C2284 a_26477_4687# a_27048_3889# 0.10863f
C2285 a_26477_1842# a_27237_1842# 0.03319f
C2286 a_4248_1044# a_4324_1008# 0.01176f
C2287 a_9465_1044# a_9675_1044# 0.09424f
C2288 a_21483_4687# VDD 0.50072f
C2289 a_4350_1044# VDD 0.87635f
C2290 a_15077_16869# a_15837_16869# 0.02912f
C2291 a_4187_2434# a_26043_16869# 0.06627f
C2292 a_18877_16869# a_18871_16035# 0.02354f
C2293 a_22590_16071# a_24084_16035# 0.28279f
C2294 a_23355_16071# a_23431_16035# 0.01194f
C2295 a_4187_2434# a_5197_14024# 0.0414f
C2296 a_19637_14024# a_19833_14024# 0.73897f
C2297 a_4187_2434# a_16923_7532# 0.06661f
C2298 a_24523_14024# a_22590_13226# 0.01012f
C2299 a_22590_13226# a_23945_12701# 0.02165f
C2300 a_15837_14024# a_15964_12471# 0.02f
C2301 a_5957_7532# a_6717_7532# 0.02912f
C2302 a_4187_2434# a_23763_4687# 0.06627f
C2303 a_6153_16869# VDD 0.49285f
C2304 a_11271_16035# VDD 0.28357f
C2305 a_27705_6734# a_25630_6734# 0.03208f
C2306 a_13470_6734# a_15755_6734# 0.39036f
C2307 a_12797_4687# a_13557_4687# 0.05851f
C2308 a_19550_3889# a_21911_3853# 0.26208f
C2309 a_17357_1842# a_17683_1842# 0.01427f
C2310 a_25153_7532# VDD 0.49426f
C2311 a_26985_6209# VDD 0.29292f
C2312 a_8808_3889# VDD 0.17499f
C2313 a_23111_2470# VDD 0.01806f
C2314 a_4157_4158# CHAN2_DELAY_IN 0.50642f
C2315 a_8237_16869# a_8884_16035# 0.02312f
C2316 a_21483_16869# a_21591_16869# 0.01163f
C2317 a_4187_2434# a_8433_16869# 0.11222f
C2318 a_10430_16071# a_12715_16071# 0.39036f
C2319 a_16108_15316# a_18877_14024# 0.01307f
C2320 a_10517_14024# a_11277_14024# 0.01669f
C2321 a_16510_13226# a_18871_13190# 0.26208f
C2322 a_4187_2434# a_27433_7532# 0.11284f
C2323 a_4187_2434# a_6153_4687# 0.11222f
C2324 a_14317_7532# a_14311_6698# 0.02349f
C2325 a_15077_7532# a_13470_6734# 0.05231f
C2326 a_18877_14024# VDD 0.88247f
C2327 a_1256_12471# VDD 0.45491f
C2328 a_24957_7532# a_25283_7532# 0.01427f
C2329 a_6425_6734# a_6711_6698# 0.01885f
C2330 a_5731_5979# a_7673_4687# 0.01865f
C2331 a_17065_3889# a_16510_3889# 0.03209f
C2332 a_25283_1842# a_25391_1842# 0.01163f
C2333 a_8433_1842# a_8997_1842# 0.0114f
C2334 a_11277_1842# a_11848_1044# 0.10863f
C2335 a_14888_1044# a_14964_1008# 0.01176f
C2336 a_13368_6734# VDD 0.17274f
C2337 a_16163_1842# VDD 0.49822f
C2338 a_25630_1044# VDD 0.89531f
C2339 a_22873_16869# a_23003_16869# 0.70361f
C2340 a_4187_2434# a_21157_14024# 0.04141f
C2341 a_27433_14024# a_27997_14024# 0.0114f
C2342 a_9772_11533# a_9946_11995# 0.27179f
C2343 a_13753_7532# a_13883_7532# 0.70845f
C2344 REF_MUX_SEL4 REF_MUX_OUT 0.91933f
C2345 a_4187_2434# a_18443_1842# 0.06627f
C2346 a_22113_16869# VDD 0.55345f
C2347 a_4350_13226# VDD 0.87638f
C2348 a_12993_7532# VDD 0.49436f
C2349 a_5731_12471# DLL_RESETN 0.02461f
C2350 a_20593_4687# a_20723_4687# 0.70845f
C2351 a_4763_4687# a_4871_4687# 0.01163f
C2352 a_10843_4687# a_10951_5315# 0.01697f
C2353 a_25630_3889# a_26985_3364# 0.02195f
C2354 a_25717_1842# a_25283_1842# 0.69698f
C2355 a_19833_4687# VDD 0.49553f
C2356 a_3449_3176# VDD 0.47499f
C2357 a_20105_1044# VDD 0.30411f
C2358 a_4187_2434# a_24393_16869# 0.11222f
C2359 a_14317_16869# a_13883_16869# 0.6972f
C2360 a_17357_16869# a_18004_16035# 0.02312f
C2361 a_18313_14024# a_18443_14024# 0.70845f
C2362 a_4187_2434# a_15273_7532# 0.11297f
C2363 a_1256_13226# a_1544_13226# 1.26509f
C2364 a_5197_7532# a_4763_7532# 0.6972f
C2365 a_4187_2434# a_22113_4687# 0.11169f
C2366 a_4437_16869# VDD 0.87051f
C2367 a_8808_16071# VDD 0.17499f
C2368 a_23111_14652# VDD 0.01806f
C2369 a_16108_5979# a_20723_4687# 0.01544f
C2370 a_12037_4687# a_11603_4687# 0.6972f
C2371 a_19448_3889# a_19550_3889# 0.37183f
C2372 a_20397_1842# a_20968_1044# 0.10863f
C2373 a_16597_1842# a_16793_1842# 0.73897f
C2374 a_25528_1044# a_25604_1008# 0.01176f
C2375 a_23437_7532# VDD 0.86929f
C2376 a_14825_6209# VDD 0.29292f
C2377 a_5844_3853# VDD 0.28225f
C2378 a_17031_2470# VDD 0.01806f
C2379 a_1544_3889# CHAN2_MUX_SEL1 0.1672f
C2380 a_1721_4240# CHAN2_MUX_SEL0 0.01315f
C2381 a_4187_2434# a_6717_16869# 0.0414f
C2382 a_5197_16869# a_5393_16869# 0.76914f
C2383 a_7477_16869# a_7390_16071# 0.1088f
C2384 a_19963_16869# a_20071_16869# 0.01163f
C2385 a_18585_16071# a_18871_16035# 0.01885f
C2386 a_9757_14024# a_9323_14024# 0.6972f
C2387 a_16108_15316# a_16163_14024# 0.0155f
C2388 a_26803_14024# a_26911_14024# 0.01163f
C2389 a_16408_13226# a_16510_13226# 0.37183f
C2390 a_12849_11557# a_13592_11113# 0.38497f
C2391 a_21917_7532# a_22677_7532# 0.06198f
C2392 a_4187_2434# a_25717_7532# 0.04176f
C2393 a_4187_2434# a_4437_4687# 0.04193f
C2394 a_12797_7532# a_13444_6698# 0.02011f
C2395 a_16163_14024# VDD 0.49822f
C2396 a_25630_13226# VDD 0.89531f
C2397 a_9757_16869# CHAN0_MUX_SEL4 0.01829f
C2398 a_13106_11047# DLL_RESETN 0.01263f
C2399 a_24197_7532# a_24393_7532# 0.77122f
C2400 a_16108_5979# a_17865_6209# 0.29564f
C2401 a_4157_7003# a_4324_6698# 0.02463f
C2402 a_4905_6734# a_4350_6734# 0.03209f
C2403 a_5731_5979# a_5957_4687# 0.01644f
C2404 a_4763_4687# a_4350_3889# 0.01012f
C2405 a_5731_3134# a_14643_1842# 0.01544f
C2406 a_7288_3889# a_7364_3853# 0.01176f
C2407 a_7477_1842# a_8237_1842# 0.01669f
C2408 a_14025_3889# a_14311_3853# 0.01885f
C2409 a_13470_1044# a_13444_1008# 0.277f
C2410 a_23763_1842# a_23871_1842# 0.01163f
C2411 a_24665_1044# a_24875_1044# 0.09424f
C2412 a_10430_6734# VDD 1.08486f
C2413 a_26911_5315# VDD 0.01806f
C2414 a_14513_1842# VDD 0.49593f
C2415 a_22564_1008# VDD 0.28964f
C2416 a_4437_1842# CHAN3_DELAY_IN 0.05007f
C2417 a_4633_1842# CHAN2_MUX_SEL4 0.01287f
C2418 a_21917_16869# a_22243_16869# 0.01427f
C2419 a_4187_2434# a_18443_14024# 0.06627f
C2420 a_26477_16869# a_27124_16035# 0.02312f
C2421 a_26477_14024# a_27237_14024# 0.03319f
C2422 a_9465_13226# a_9675_13226# 0.09424f
C2423 a_4248_13226# a_4324_13190# 0.01176f
C2424 a_5731_12471# a_13019_11521# 0.01515f
C2425 REF_MUX_SEL0 REF_MUX_SEL1 3.14917f
C2426 a_4187_2434# a_16793_1842# 0.11222f
C2427 a_20397_16869# VDD 0.86919f
C2428 a_3449_15358# VDD 0.47499f
C2429 a_11277_7532# VDD 0.86926f
C2430 a_20105_13226# VDD 0.30411f
C2431 a_3449_12513# CHAN1_MUX_SEL4 0.05166f
C2432 a_22590_6734# a_24951_6698# 0.26208f
C2433 a_9323_4687# a_9431_5315# 0.01697f
C2434 a_24393_1842# a_24957_1842# 0.0114f
C2435 a_4905_1044# a_5191_1008# 0.01885f
C2436 a_16108_289# a_26985_519# 0.27952f
C2437 a_18117_4687# VDD 0.85996f
C2438 a_27124_3853# VDD 0.28225f
C2439 a_7945_1044# VDD 0.30411f
C2440 a_12993_16869# a_13557_16869# 0.0114f
C2441 a_4187_2434# a_22677_16869# 0.04055f
C2442 a_16597_16869# a_16510_16071# 0.1088f
C2443 a_4187_2434# a_13557_7532# 0.04101f
C2444 a_17357_14024# a_17683_14024# 0.01427f
C2445 a_19550_16071# a_21911_16035# 0.26208f
C2446 a_4187_2434# a_20397_4687# 0.04141f
C2447 a_21917_7532# a_22564_6698# 0.02011f
C2448 a_17031_14652# VDD 0.01806f
C2449 a_5844_16035# VDD 0.28225f
C2450 a_13306_11995# VDD 0.77663f
C2451 a_6854_11676# REF_DELAY_OUT_LAST 0.08491f
C2452 a_10713_4687# a_11277_4687# 0.0114f
C2453 a_16108_5979# a_19073_4687# 0.01872f
C2454 a_21625_6734# a_21835_6734# 0.09424f
C2455 a_13883_4687# a_13470_3889# 0.01012f
C2456 a_17928_3889# a_18004_3853# 0.01176f
C2457 a_15273_1842# a_15403_1842# 0.70845f
C2458 a_27705_3889# VDD 0.29962f
C2459 a_10951_2470# VDD 0.01806f
C2460 a_1256_289# CHAN3_MUX_SEL4 0.65005f
C2461 a_1721_331# CHAN3_MUX_SEL2 0.01315f
C2462 a_1544_289# CHAN3_MUX_SEL3 0.15976f
C2463 VDD CHAN1_MUX_SEL1 0.50228f
C2464 a_4187_2434# a_4003_16869# 0.05992f
C2465 a_18443_16869# a_18551_16869# 0.01163f
C2466 a_17065_16071# a_16510_16071# 0.03209f
C2467 a_8433_14024# a_8997_14024# 0.0114f
C2468 a_11277_14024# a_11848_13226# 0.10863f
C2469 a_25283_14024# a_25391_14024# 0.01163f
C2470 a_14888_13226# a_14964_13190# 0.01176f
C2471 a_6126_9506# a_9444_9602# 0.25721f
C2472 a_6854_11144# a_5778_9057# 0.02695f
C2473 a_12849_11557# a_15304_10295# 0.0606f
C2474 a_6854_11676# a_9712_9602# 0.13962f
C2475 a_13592_11561# a_14851_11918# 0.01529f
C2476 a_5974_11413# a_5864_9057# 0.01697f
C2477 a_21157_7532# a_20723_7532# 0.6972f
C2478 a_4187_2434# a_23003_7532# 0.06405f
C2479 a_12037_7532# a_11924_6698# 0.02055f
C2480 a_27671_17497# VDD 0.01806f
C2481 a_14513_14024# VDD 0.49593f
C2482 a_22564_13190# VDD 0.28964f
C2483 a_14111_11568# REF_CLK 0.02263f
C2484 a_7477_4687# a_7945_3889# 0.19203f
C2485 a_27997_4687# a_27563_4687# 0.69646f
C2486 a_6717_1842# a_6283_1842# 0.6972f
C2487 a_5731_3134# a_12993_1842# 0.01688f
C2488 a_22243_1842# a_22351_1842# 0.01163f
C2489 a_20831_5315# VDD 0.01806f
C2490 a_7364_6698# VDD 0.28633f
C2491 a_12797_1842# VDD 0.8835f
C2492 a_20315_1044# VDD 0.1539f
C2493 a_4350_1044# CHAN3_MUX_SEL4 0.31434f
C2494 a_15964_3134# CHAN2_MUX_OUT 0.01307f
C2495 a_16108_3134# CHAN2_MUX_SEL4 0.1283f
C2496 a_25717_16869# a_25630_16071# 0.1088f
C2497 a_4187_2434# a_16793_14024# 0.11222f
C2498 a_21157_16869# a_21353_16869# 0.77122f
C2499 VDD CHAN3_MUX_SEL4 2.71831f
C2500 a_25717_14024# a_25283_14024# 0.69698f
C2501 a_25630_16071# a_26985_15546# 0.02195f
C2502 a_12037_7532# a_12233_7532# 0.77122f
C2503 a_6326_10280# a_5974_11413# 0.33136f
C2504 a_4187_2434# a_15077_1842# 0.04141f
C2505 a_17683_16869# VDD 0.49671f
C2506 a_27124_16035# VDD 0.28225f
C2507 a_7945_13226# VDD 0.30411f
C2508 a_8563_7532# VDD 0.49671f
C2509 a_7803_4687# a_7911_5315# 0.01697f
C2510 a_22488_6734# a_22590_6734# 0.37183f
C2511 a_18877_4687# a_19073_4687# 0.76914f
C2512 a_1544_3889# a_1721_4240# 0.38063f
C2513 a_1256_3134# a_1721_3176# 0.13421f
C2514 a_23437_1842# a_24197_1842# 0.03319f
C2515 a_15765_463# a_15964_289# 0.061f
C2516 a_15403_4687# VDD 0.4973f
C2517 a_24875_3889# VDD 0.15407f
C2518 a_2873_1395# VDD 0.46517f
C2519 a_4187_2434# a_19963_16869# 0.06627f
C2520 a_12037_16869# a_12797_16869# 0.02912f
C2521 a_16597_14024# a_16793_14024# 0.73897f
C2522 a_4187_2434# a_10843_7532# 0.06627f
C2523 a_19448_16071# a_19550_16071# 0.37183f
C2524 a_20397_14024# a_20968_13226# 0.10863f
C2525 a_25528_13226# a_25604_13190# 0.01176f
C2526 a_4187_2434# a_17683_4687# 0.06627f
C2527 a_21157_7532# a_21044_6698# 0.02055f
C2528 a_27705_16071# VDD 0.29962f
C2529 a_10951_14652# VDD 0.01806f
C2530 a_14825_15546# CHAN0_MUX_SEL4 0.03307f
C2531 a_16108_12471# REF_DELAY_OUT_LAST 0.01081f
C2532 a_9757_4687# a_10517_4687# 0.06198f
C2533 a_10328_6734# a_10404_6698# 0.01176f
C2534 a_16108_5979# a_17357_4687# 0.01319f
C2535 a_21157_4687# a_21625_3889# 0.2079f
C2536 a_16510_3889# a_16484_3853# 0.277f
C2537 a_12797_4687# a_13368_3889# 0.10864f
C2538 a_16108_3134# a_26043_1842# 0.01539f
C2539 a_14317_1842# a_14643_1842# 0.01427f
C2540 a_22590_1044# a_23355_1044# 0.39037f
C2541 a_1721_6021# VDD 0.45365f
C2542 a_15545_3889# VDD 0.29962f
C2543 a_4871_2470# VDD 0.01806f
C2544 VDD CHAN0_MUX_SEL1 0.50228f
C2545 a_16923_16869# a_17031_16869# 0.01163f
C2546 a_14025_16071# a_14311_16035# 0.01885f
C2547 a_7288_16071# a_7364_16035# 0.01176f
C2548 a_5731_15316# a_14643_14024# 0.01544f
C2549 a_7477_14024# a_8237_14024# 0.01669f
C2550 a_23763_14024# a_23871_14024# 0.01163f
C2551 a_24665_13226# a_24875_13226# 0.09424f
C2552 a_13470_13226# a_13444_13190# 0.277f
C2553 a_19833_7532# a_20397_7532# 0.0114f
C2554 a_13121_11521# a_14111_11568# 0.0235f
C2555 a_13566_11525# a_14009_11568# 0.02242f
C2556 a_4187_2434# a_5731_5979# 0.14779f
C2557 a_18117_7532# a_18585_6734# 0.2079f
C2558 a_11277_7532# a_10430_6734# 0.08038f
C2559 a_21591_17497# VDD 0.01806f
C2560 a_20315_13226# VDD 0.1539f
C2561 a_12797_14024# VDD 0.8835f
C2562 a_10430_16071# CHAN0_MUX_SEL4 0.21179f
C2563 a_5731_5979# a_11785_6209# 0.28056f
C2564 a_4350_3889# a_5115_3889# 0.39037f
C2565 a_26673_4687# a_27237_4687# 0.0114f
C2566 a_5957_4687# a_6425_3889# 0.2079f
C2567 a_26803_1842# a_26911_2470# 0.01697f
C2568 a_5393_1842# a_5957_1842# 0.0114f
C2569 a_20723_1842# a_20831_1842# 0.01163f
C2570 a_5731_3134# a_11277_1842# 0.01319f
C2571 a_7803_1842# a_7390_1044# 0.01012f
C2572 a_10430_1044# a_11271_1008# 0.28268f
C2573 a_20105_1044# a_20315_1044# 0.09424f
C2574 a_5115_6734# VDD 0.15389f
C2575 a_14751_5315# VDD 0.01806f
C2576 a_10083_1842# VDD 0.49994f
C2577 a_17351_1008# VDD 0.28565f
C2578 a_19833_16869# a_19963_16869# 0.70845f
C2579 a_4187_2434# a_15077_14024# 0.04141f
C2580 a_24393_14024# a_24957_14024# 0.0114f
C2581 VDD CHAN2_MUX_SEL4 2.78283f
C2582 a_4905_13226# a_5191_13190# 0.01885f
C2583 a_16108_12471# a_26985_12701# 0.27952f
C2584 a_10713_7532# a_10843_7532# 0.70845f
C2585 a_4187_2434# a_12363_1842# 0.06482f
C2586 a_24875_16071# VDD 0.15406f
C2587 a_16033_16869# VDD 0.49413f
C2588 a_2873_13577# VDD 0.46517f
C2589 a_6913_7532# VDD 0.49426f
C2590 a_17553_4687# a_17683_4687# 0.70845f
C2591 a_20968_6734# a_21044_6698# 0.01176f
C2592 a_6283_4687# a_6391_5315# 0.01697f
C2593 a_21917_4687# a_22488_3889# 0.10864f
C2594 a_22677_1842# a_22243_1842# 0.69698f
C2595 a_5731_289# a_15964_289# 0.2778f
C2596 a_24631_8160# VDD 0.01806f
C2597 a_13753_4687# VDD 0.49559f
C2598 a_21911_3853# VDD 0.2822f
C2599 a_1256_1044# VDD 0.50942f
C2600 a_11277_16869# a_10843_16869# 0.6972f
C2601 a_4187_2434# a_18313_16869# 0.11222f
C2602 a_17928_16071# a_18004_16035# 0.01176f
C2603 a_4187_2434# a_9193_7532# 0.11222f
C2604 a_15273_14024# a_15403_14024# 0.70845f
C2605 a_9444_10280# a_9712_9602# 0.68929f
C2606 a_15688_11093# a_15464_9374# 0.1999f
C2607 a_4187_2434# a_16033_4687# 0.11222f
C2608 a_20397_7532# a_19550_6734# 0.08038f
C2609 a_15545_16071# VDD 0.29962f
C2610 a_10232_11561# VDD 0.07564f
C2611 a_4871_14652# VDD 0.01806f
C2612 a_17065_6734# a_17275_6734# 0.09424f
C2613 a_8997_4687# a_8563_4687# 0.6972f
C2614 a_12797_4687# a_10430_3889# 0.02479f
C2615 a_13557_1842# a_13753_1842# 0.73897f
C2616 a_16108_3134# a_24393_1842# 0.01872f
C2617 a_16923_1842# a_16510_1044# 0.01012f
C2618 a_26395_6734# VDD 0.15389f
C2619 a_4905_3889# VDD 0.3017f
C2620 a_26043_1842# VDD 0.50058f
C2621 a_15403_16869# a_15511_16869# 0.01163f
C2622 a_22243_14024# a_22351_14024# 0.01163f
C2623 a_6717_14024# a_6283_14024# 0.6972f
C2624 a_5731_15316# a_12993_14024# 0.01688f
C2625 a_18877_7532# a_19637_7532# 0.06198f
C2626 a_9757_7532# a_9751_6698# 0.02354f
C2627 a_10083_14024# VDD 0.49994f
C2628 a_15511_17497# VDD 0.01806f
C2629 a_17351_13190# VDD 0.28565f
C2630 a_12355_11557# DLL_RESETN 0.04879f
C2631 a_25717_7532# a_25604_6698# 0.05157f
C2632 a_4437_4687# a_4157_4158# 0.01771f
C2633 a_25717_4687# a_26477_4687# 0.01669f
C2634 a_9465_3889# a_7390_3889# 0.03208f
C2635 a_4437_1842# a_5197_1842# 0.01669f
C2636 a_5731_3134# a_8563_1842# 0.01544f
C2637 a_25283_1842# a_25391_2470# 0.01697f
C2638 a_6717_1842# a_7288_1044# 0.10864f
C2639 a_19203_1842# a_19311_1842# 0.01163f
C2640 a_12037_1842# a_12505_1044# 0.2079f
C2641 a_9675_1044# a_9751_1008# 0.01194f
C2642 a_23145_6734# VDD 0.30409f
C2643 a_8433_1842# VDD 0.49593f
C2644 a_8671_5315# VDD 0.01806f
C2645 a_14888_1044# VDD 0.17499f
C2646 a_3449_3176# CHAN2_MUX_SEL4 0.05166f
C2647 a_18877_16869# a_19203_16869# 0.01427f
C2648 a_1256_15316# a_1721_15358# 0.13421f
C2649 a_1544_16071# a_1721_16422# 0.38063f
C2650 a_4187_2434# a_12363_14024# 0.06482f
C2651 VDD REF_MUX_SEL4 2.78283f
C2652 CHAN1_MUX_SEL0 CHAN1_MUX_SEL2 0.01204f
C2653 CHAN1_DELAY_IN CHAN1_MUX_SEL4 0.0663f
C2654 a_23437_14024# a_24197_14024# 0.03319f
C2655 a_15765_12645# a_15964_12471# 0.061f
C2656 a_5731_12471# a_5974_11413# 0.01167f
C2657 a_9757_7532# a_10083_7532# 0.01427f
C2658 a_4187_2434# a_10713_1842# 0.11222f
C2659 a_14317_16869# VDD 0.86919f
C2660 a_21911_16035# VDD 0.2822f
C2661 a_5197_7532# VDD 0.86919f
C2662 a_1256_13226# VDD 0.50942f
C2663 a_4187_2434# CHAN2_MUX_OUT 1.28859f
C2664 a_19550_6734# a_19524_6698# 0.277f
C2665 a_7390_6734# a_5731_5979# 0.41331f
C2666 a_4763_4687# a_4871_5315# 0.01697f
C2667 a_16510_3889# a_16108_3134# 0.56108f
C2668 a_21917_4687# a_19550_3889# 0.02479f
C2669 a_25630_3889# a_26395_3889# 0.39037f
C2670 a_21353_1842# a_21917_1842# 0.0114f
C2671 a_26043_1842# a_25630_1044# 0.01012f
C2672 a_5731_289# a_8745_519# 0.28635f
C2673 a_18551_8160# VDD 0.01806f
C2674 a_12037_4687# VDD 0.86172f
C2675 a_19448_3889# VDD 0.17274f
C2676 a_9953_16869# a_10517_16869# 0.0114f
C2677 a_4187_2434# a_16597_16869# 0.0414f
C2678 a_16510_16071# a_16484_16035# 0.277f
C2679 a_14317_14024# a_14643_14024# 0.01427f
C2680 a_16108_15316# a_26043_14024# 0.01539f
C2681 a_4187_2434# a_7477_7532# 0.0414f
C2682 a_14009_10774# a_14757_10872# 0.01058f
C2683 a_14851_10872# a_15108_11015# 0.29858f
C2684 a_22590_13226# a_23355_13226# 0.39037f
C2685 a_4187_2434# a_14317_4687# 0.04141f
C2686 a_18877_7532# a_18871_6698# 0.02354f
C2687 a_4905_16071# VDD 0.3017f
C2688 a_26043_14024# VDD 0.50058f
C2689 a_6854_11144# VDD 1.0388f
C2690 a_1721_15358# CHAN0_MUX_SEL4 0.05813f
C2691 a_2297_15358# CHAN0_MUX_SEL3 0.01595f
C2692 a_1544_15316# CHAN0_MUX_OUT 0.69943f
C2693 a_2873_15358# CHAN0_MUX_SEL2 0.01422f
C2694 a_7390_6734# a_8155_6734# 0.39037f
C2695 a_10517_4687# a_10404_3853# 0.05157f
C2696 a_7673_4687# a_8237_4687# 0.0114f
C2697 a_13470_3889# a_14311_3853# 0.28268f
C2698 a_25717_1842# a_26185_1044# 0.19203f
C2699 a_15837_1842# a_16408_1044# 0.10864f
C2700 a_12233_1842# a_12363_1842# 0.70361f
C2701 a_19550_1044# a_20968_1044# 0.38994f
C2702 a_23431_6698# VDD 0.28357f
C2703 a_24393_1842# VDD 0.4946f
C2704 a_2297_4240# VDD 0.47647f
C2705 a_17865_519# VDD 0.29444f
C2706 a_12797_1842# CHAN3_MUX_SEL4 0.01829f
C2707 a_27237_16869# a_26803_16869# 0.6972f
C2708 a_13883_16869# a_13991_16869# 0.01163f
C2709 a_5731_15316# a_11277_14024# 0.01319f
C2710 a_4350_16071# a_5115_16071# 0.39037f
C2711 a_5393_14024# a_5957_14024# 0.0114f
C2712 a_20723_14024# a_20831_14024# 0.01163f
C2713 a_26803_14024# a_26911_14652# 0.01697f
C2714 a_7803_14024# a_7390_13226# 0.01012f
C2715 a_10430_13226# a_11271_13190# 0.28268f
C2716 a_20105_13226# a_20315_13226# 0.09424f
C2717 a_12355_11557# a_13019_11521# 0.3846f
C2718 a_18117_7532# a_17683_7532# 0.6972f
C2719 CHAN3_MUX_SEL3 CHAN3_MUX_OUT 0.79533f
C2720 a_4187_2434# a_26673_1842# 0.11222f
C2721 a_21483_7532# a_21591_7532# 0.01163f
C2722 a_8237_7532# a_8884_6698# 0.02312f
C2723 a_8433_14024# VDD 0.49593f
C2724 a_9431_17497# VDD 0.01806f
C2725 a_21157_7532# VDD 0.85896f
C2726 a_14888_13226# VDD 0.17499f
C2727 a_24957_4687# a_24523_4687# 0.6972f
C2728 a_5731_3134# a_6913_1842# 0.01872f
C2729 a_8155_1044# a_8231_1008# 0.01194f
C2730 a_15545_1044# a_15831_1008# 0.01885f
C2731 a_17683_1842# a_17791_1842# 0.01163f
C2732 a_7390_1044# a_8884_1008# 0.28279f
C2733 a_23763_1842# a_23871_2470# 0.01697f
C2734 a_6717_1842# a_4350_1044# 0.02479f
C2735 a_10985_6734# VDD 0.30409f
C2736 a_6717_1842# VDD 0.88148f
C2737 a_27997_4687# VDD 0.76528f
C2738 a_11924_1008# VDD 0.28225f
C2739 a_3449_1395# CHAN3_MUX_SEL1 0.29404f
C2740 a_4187_2434# a_10713_14024# 0.11222f
C2741 a_18117_16869# a_18313_16869# 0.77122f
C2742 CHAN0_MUX_SEL4 CHAN1_DELAY_IN 0.01332f
C2743 a_22677_14024# a_22243_14024# 0.69698f
C2744 a_5731_12471# a_15964_12471# 0.2778f
C2745 a_8997_7532# a_9193_7532# 0.77122f
C2746 a_4187_2434# a_8997_1842# 0.04141f
C2747 a_11603_16869# VDD 0.49739f
C2748 a_19448_16071# VDD 0.17274f
C2749 a_4187_2434# REF_MUX_OUT 1.28859f
C2750 a_19637_4687# a_19524_3853# 0.05157f
C2751 a_15837_4687# a_16033_4687# 0.76914f
C2752 a_24957_1842# a_25528_1044# 0.10864f
C2753 a_20397_1842# a_21157_1842# 0.03319f
C2754 a_12471_8160# VDD 0.02372f
C2755 a_9323_4687# VDD 0.50001f
C2756 a_16510_3889# VDD 0.8795f
C2757 a_14825_6209# REF_MUX_SEL4 0.03307f
C2758 a_12363_16869# a_10430_16071# 0.01012f
C2759 a_4187_2434# a_13883_16869# 0.06627f
C2760 a_8997_16869# a_9757_16869# 0.02912f
C2761 a_19637_16869# a_20105_16071# 0.19203f
C2762 a_16108_15316# a_24393_14024# 0.01872f
C2763 a_4187_2434# a_4763_7532# 0.06627f
C2764 a_13557_14024# a_13753_14024# 0.73897f
C2765 a_16923_14024# a_16510_13226# 0.01012f
C2766 a_4187_2434# a_11603_4687# 0.06627f
C2767 a_17357_7532# a_18004_6698# 0.02312f
C2768 a_2297_16422# VDD 0.47647f
C2769 a_24393_14024# VDD 0.4946f
C2770 a_17865_12701# VDD 0.29444f
C2771 a_2873_13577# CHAN1_MUX_SEL1 0.13092f
C2772 a_3449_13577# CHAN1_DELAY_IN 0.01058f
C2773 a_12505_6734# a_12791_6698# 0.01885f
C2774 a_6717_4687# a_7477_4687# 0.06198f
C2775 a_24665_3889# a_22590_3889# 0.03208f
C2776 a_11277_1842# a_11603_1842# 0.01427f
C2777 a_12715_3889# a_12791_3853# 0.01194f
C2778 a_16108_3134# a_19963_1842# 0.01539f
C2779 a_15837_1842# a_13470_1044# 0.02479f
C2780 a_20968_6734# VDD 0.17499f
C2781 a_22677_1842# VDD 0.91655f
C2782 a_10430_6734# REF_MUX_SEL4 0.21179f
C2783 a_12363_16869# a_12471_16869# 0.01163f
C2784 a_4437_16869# a_4905_16071# 0.19203f
C2785 a_25913_16869# a_26477_16869# 0.0114f
C2786 a_4187_2434# a_26673_14024# 0.11222f
C2787 a_5731_15316# a_8563_14024# 0.01544f
C2788 a_9465_16071# a_7390_16071# 0.03208f
C2789 a_4437_14024# a_5197_14024# 0.01669f
C2790 a_9675_13226# a_9751_13190# 0.01194f
C2791 a_19203_14024# a_19311_14024# 0.01163f
C2792 a_25283_14024# a_25391_14652# 0.01697f
C2793 a_6717_14024# a_7288_13226# 0.10864f
C2794 a_12037_14024# a_12505_13226# 0.2079f
C2795 a_16793_7532# a_17357_7532# 0.0114f
C2796 a_4187_2434# a_24957_1842# 0.0414f
C2797 a_7477_7532# a_7390_6734# 0.1088f
C2798 a_19963_7532# a_20071_7532# 0.01163f
C2799 a_27563_16869# VDD 0.49811f
C2800 a_6717_14024# VDD 0.88148f
C2801 a_18443_7532# VDD 0.4973f
C2802 a_11924_13190# VDD 0.28225f
C2803 a_1256_5979# a_2873_6021# 0.27926f
C2804 a_1256_6734# a_2297_7085# 0.04619f
C2805 a_1544_5979# a_2297_6021# 0.27303f
C2806 a_23437_7532# a_23431_6698# 0.02349f
C2807 a_22590_6734# a_16108_5979# 0.56869f
C2808 a_24197_7532# a_22590_6734# 0.05231f
C2809 a_23633_4687# a_24197_4687# 0.0114f
C2810 a_15964_3134# a_16108_3134# 0.42202f
C2811 a_4437_1842# a_4324_1008# 0.05157f
C2812 a_16163_1842# a_16271_1842# 0.01163f
C2813 a_14025_1044# a_13470_1044# 0.03209f
C2814 a_22243_1842# a_22351_2470# 0.01697f
C2815 a_25283_4687# VDD 0.50004f
C2816 a_9675_1044# VDD 0.15407f
C2817 a_4003_1842# VDD 0.61691f
C2818 a_1256_1044# CHAN3_MUX_SEL4 0.03691f
C2819 a_21483_16869# a_19550_16071# 0.01012f
C2820 a_16793_16869# a_16923_16869# 0.70845f
C2821 a_4187_2434# a_8997_14024# 0.04141f
C2822 CHAN0_DELAY_IN CHAN0_MUX_SEL4 0.0663f
C2823 a_16510_16071# a_16108_15316# 0.56108f
C2824 a_21353_14024# a_21917_14024# 0.0114f
C2825 a_4187_2434# a_20723_7532# 0.06661f
C2826 CHAN0_MUX_SEL0 CHAN0_MUX_SEL2 0.01204f
C2827 a_25630_16071# a_26395_16071# 0.39037f
C2828 a_26043_14024# a_25630_13226# 0.01012f
C2829 a_7673_7532# a_7803_7532# 0.70845f
C2830 a_5731_12471# a_8745_12701# 0.28635f
C2831 a_4187_2434# a_27563_4687# 0.06629f
C2832 a_4187_2434# a_6283_1842# 0.06627f
C2833 a_9953_16869# VDD 0.49426f
C2834 a_16510_16071# VDD 0.8795f
C2835 a_14851_10872# VDD 0.26676f
C2836 a_27563_7532# a_27671_7532# 0.01163f
C2837 a_16510_6734# a_17351_6698# 0.28268f
C2838 a_14513_4687# a_14643_4687# 0.70845f
C2839 a_22590_3889# a_24008_3889# 0.38994f
C2840 a_19637_1842# a_19203_1842# 0.69698f
C2841 a_24957_1842# a_22590_1044# 0.02479f
C2842 a_1256_1044# a_2873_1395# 0.28892f
C2843 a_6391_8160# VDD 0.01806f
C2844 a_7673_4687# VDD 0.49553f
C2845 a_13444_3853# VDD 0.28633f
C2846 a_27997_1842# CHAN3_DELAY_OUT_LAST 0.70955f
C2847 a_8237_16869# a_7803_16869# 0.6972f
C2848 a_4187_2434# a_12233_16869# 0.11169f
C2849 a_12233_14024# a_12363_14024# 0.70361f
C2850 a_13470_16071# a_14311_16035# 0.28268f
C2851 a_15837_14024# a_16408_13226# 0.10864f
C2852 a_25717_14024# a_26185_13226# 0.19203f
C2853 a_19550_13226# a_20968_13226# 0.38994f
C2854 a_13566_11018# a_13306_10795# 0.75507f
C2855 a_4187_2434# a_9953_4687# 0.11222f
C2856 a_16597_7532# a_16510_6734# 0.1088f
C2857 a_22677_14024# VDD 0.91715f
C2858 a_1256_13226# CHAN1_MUX_SEL1 1.44243f
C2859 a_1544_13226# CHAN1_MUX_SEL0 0.07603f
C2860 a_9712_9602# DLL_RESETN 0.431f
C2861 a_27237_7532# a_26803_7532# 0.6972f
C2862 a_10985_6734# a_10430_6734# 0.03209f
C2863 a_5957_4687# a_5523_4687# 0.6972f
C2864 a_5731_5979# a_11473_4687# 0.01872f
C2865 a_4350_6734# a_5768_6734# 0.38994f
C2866 a_11195_3889# a_11271_3853# 0.01194f
C2867 a_10430_3889# a_11924_3853# 0.28279f
C2868 a_8237_4687# a_8231_3853# 0.02349f
C2869 a_8997_4687# a_7390_3889# 0.05231f
C2870 a_16108_3134# a_18313_1842# 0.02026f
C2871 a_10517_1842# a_10713_1842# 0.73897f
C2872 a_16510_1044# a_18795_1044# 0.39036f
C2873 a_13557_1842# a_13444_1008# 0.05157f
C2874 a_18004_6698# VDD 0.28225f
C2875 a_19963_1842# VDD 0.50058f
C2876 a_24957_16869# a_25717_16869# 0.06198f
C2877 a_10843_16869# a_10951_16869# 0.01163f
C2878 a_4187_2434# a_24957_14024# 0.0414f
C2879 a_5731_15316# a_6913_14024# 0.01872f
C2880 a_6717_14024# a_4350_13226# 0.02479f
C2881 a_23763_14024# a_23871_14652# 0.01697f
C2882 a_17683_14024# a_17791_14024# 0.01163f
C2883 a_7390_13226# a_8884_13190# 0.28279f
C2884 a_15545_13226# a_15831_13190# 0.01885f
C2885 a_8155_13226# a_8231_13190# 0.01194f
C2886 a_15837_7532# a_16597_7532# 0.06198f
C2887 a_10232_11561# a_11397_11918# 0.43239f
C2888 CHAN2_MUX_SEL2 CHAN3_DELAY_IN 0.2107f
C2889 CHAN2_MUX_SEL3 CHAN2_MUX_OUT 0.79533f
C2890 a_4187_2434# a_22243_1842# 0.06315f
C2891 a_18443_7532# a_18551_7532# 0.01163f
C2892 a_25913_16869# VDD 0.49294f
C2893 a_4003_14024# VDD 0.61691f
C2894 a_9675_13226# VDD 0.15407f
C2895 a_16793_7532# VDD 0.49277f
C2896 a_6326_10280# CHAN1_MUX_OUT 0.06947f
C2897 a_22677_4687# a_23437_4687# 0.01323f
C2898 a_21917_4687# a_16108_3134# 0.01053f
C2899 a_20723_1842# a_20831_2470# 0.01697f
C2900 a_14643_1842# a_14751_1842# 0.01163f
C2901 a_4350_1044# a_6711_1008# 0.26208f
C2902 a_10985_1044# a_11271_1008# 0.01885f
C2903 a_1721_7085# VDD 0.4533f
C2904 a_23633_4687# VDD 0.49601f
C2905 a_15964_3134# VDD 0.31771f
C2906 a_6711_1008# VDD 0.2822f
C2907 a_15837_16869# a_16163_16869# 0.01427f
C2908 a_4187_2434# a_6283_14024# 0.06627f
C2909 a_4187_2434# a_19073_7532# 0.11286f
C2910 a_20397_14024# a_21157_14024# 0.03319f
C2911 a_24957_14024# a_25528_13226# 0.10864f
C2912 a_6717_7532# a_7043_7532# 0.01427f
C2913 a_4187_2434# a_25913_4687# 0.11222f
C2914 a_4187_2434# a_4633_1842# 0.11222f
C2915 a_13444_16035# VDD 0.28633f
C2916 a_8237_16869# VDD 0.86919f
C2917 a_13566_11018# VDD 0.0947f
C2918 a_13019_11521# REF_DELAY_OUT_LAST 0.08017f
C2919 a_26043_7532# a_26151_7532# 0.01163f
C2920 a_16108_5979# a_24523_4687# 0.01542f
C2921 a_27705_6734# a_27991_6698# 0.01885f
C2922 a_15755_6734# a_15831_6698# 0.01194f
C2923 a_17357_4687# a_17351_3853# 0.02349f
C2924 a_18117_4687# a_16510_3889# 0.05231f
C2925 a_18313_1842# a_18877_1842# 0.0114f
C2926 a_22677_1842# a_22564_1008# 0.05157f
C2927 a_27237_7532# VDD 0.86022f
C2928 a_11195_3889# VDD 0.1539f
C2929 a_5957_4687# VDD 0.85996f
C2930 a_4157_7003# REF_CLK 0.50643f
C2931 a_2297_6021# REF_MUX_SEL3 0.01595f
C2932 a_2873_6021# REF_MUX_SEL2 0.01422f
C2933 a_1544_5979# REF_MUX_OUT 0.69943f
C2934 a_1721_6021# REF_MUX_SEL4 0.05813f
C2935 a_16851_309# CHAN3_MUX_OUT 0.45865f
C2936 a_6913_16869# a_7477_16869# 0.0114f
C2937 a_4187_2434# a_10517_16869# 0.0414f
C2938 a_12715_16071# a_12791_16035# 0.01194f
C2939 a_24665_16071# a_22590_16071# 0.03208f
C2940 a_15837_14024# a_13470_13226# 0.02479f
C2941 a_16108_15316# a_19963_14024# 0.01539f
C2942 a_11277_14024# a_11603_14024# 0.01427f
C2943 a_13106_11047# a_12907_10876# 0.02437f
C2944 a_13019_11521# a_9712_9602# 0.03275f
C2945 a_4187_2434# a_8237_4687# 0.04141f
C2946 a_19963_14024# VDD 0.50058f
C2947 a_7945_6734# a_8231_6698# 0.01885f
C2948 a_25913_7532# a_26477_7532# 0.0114f
C2949 a_5731_5979# a_9757_4687# 0.01307f
C2950 a_4633_4687# a_5197_4687# 0.0114f
C2951 a_18585_3889# a_18795_3889# 0.09424f
C2952 a_6717_4687# a_7364_3853# 0.02011f
C2953 a_9193_1842# a_9323_1842# 0.70845f
C2954 a_16108_3134# a_16597_1842# 0.01319f
C2955 a_15755_6734# VDD 0.15389f
C2956 a_18313_1842# VDD 0.4946f
C2957 a_27991_1008# VDD 0.28201f
C2958 a_6717_1842# CHAN3_MUX_SEL4 0.0195f
C2959 a_24197_16869# a_23763_16869# 0.6972f
C2960 a_9323_16869# a_9431_16869# 0.01163f
C2961 a_4187_2434# a_22243_14024# 0.06315f
C2962 a_22243_14024# a_22351_14652# 0.01697f
C2963 a_15964_15316# a_16108_15316# 0.42202f
C2964 a_16163_14024# a_16271_14024# 0.01163f
C2965 a_4437_14024# a_4324_13190# 0.05157f
C2966 a_10206_11525# a_10649_11568# 0.02242f
C2967 a_9946_11995# a_10520_11982# 0.31978f
C2968 a_14025_13226# a_13470_13226# 0.03209f
C2969 a_15077_7532# a_14643_7532# 0.6972f
C2970 a_4187_2434# a_20593_1842# 0.11222f
C2971 a_16923_7532# a_17031_7532# 0.01163f
C2972 a_24197_16869# VDD 0.85892f
C2973 a_15964_15316# VDD 0.31771f
C2974 a_6711_13190# VDD 0.2822f
C2975 a_15077_7532# VDD 0.86018f
C2976 a_15964_12471# CHAN1_MUX_SEL4 0.5544f
C2977 a_21917_4687# a_21483_4687# 0.6972f
C2978 a_25630_6734# a_27048_6734# 0.38994f
C2979 a_16510_6734# a_17865_6209# 0.02165f
C2980 a_27237_4687# a_25630_3889# 0.05253f
C2981 a_26477_4687# a_26471_3853# 0.02349f
C2982 a_13123_1842# a_13231_1842# 0.01163f
C2983 a_26477_1842# a_26673_1842# 0.76914f
C2984 a_19203_1842# a_19311_2470# 0.01697f
C2985 a_4248_1044# a_4350_1044# 0.37183f
C2986 a_21917_4687# VDD 0.8957f
C2987 a_8745_3364# VDD 0.29292f
C2988 a_4248_1044# VDD 0.17587f
C2989 a_15077_16869# a_15273_16869# 0.77122f
C2990 a_4187_2434# a_26477_16869# 0.04145f
C2991 a_22590_16071# a_24008_16071# 0.38994f
C2992 a_4187_2434# a_4633_14024# 0.11222f
C2993 a_4187_2434# a_17357_7532# 0.04176f
C2994 a_19637_14024# a_19203_14024# 0.69698f
C2995 a_24957_14024# a_22590_13226# 0.02479f
C2996 a_1256_13226# a_2873_13577# 0.28892f
C2997 a_5957_7532# a_6153_7532# 0.77122f
C2998 a_4187_2434# a_24197_4687# 0.04152f
C2999 a_4187_2434# a_16108_3134# 0.21585f
C3000 a_5523_16869# VDD 0.49671f
C3001 a_11195_16071# VDD 0.15389f
C3002 a_26185_6734# a_25630_6734# 0.03209f
C3003 a_24523_7532# a_24631_7532# 0.01163f
C3004 a_13470_6734# a_14964_6698# 0.28279f
C3005 a_14235_6734# a_14311_6698# 0.01194f
C3006 a_16108_5979# a_22873_4687# 0.01865f
C3007 a_12797_4687# a_12993_4687# 0.74917f
C3008 a_15837_4687# a_16484_3853# 0.02011f
C3009 a_19550_3889# a_21835_3889# 0.39036f
C3010 a_17357_1842# a_18117_1842# 0.03319f
C3011 a_25630_1044# a_27991_1008# 0.26208f
C3012 a_23945_6209# VDD 0.29292f
C3013 a_24523_7532# VDD 0.4973f
C3014 a_8231_3853# VDD 0.28357f
C3015 a_22351_2470# VDD 0.02353f
C3016 a_2873_4240# CHAN2_MUX_SEL1 0.13092f
C3017 a_3449_4240# CHAN2_DELAY_IN 0.01058f
C3018 a_8237_16869# a_8808_16071# 0.10863f
C3019 a_27563_16869# a_27671_17497# 0.01697f
C3020 a_4187_2434# a_7803_16869# 0.06627f
C3021 a_5957_16869# a_6717_16869# 0.02912f
C3022 a_11195_16071# a_11271_16035# 0.01194f
C3023 a_10430_16071# a_11924_16035# 0.28279f
C3024 a_10517_14024# a_10713_14024# 0.73897f
C3025 a_13557_14024# a_13444_13190# 0.05157f
C3026 a_16108_15316# a_18313_14024# 0.02026f
C3027 a_16510_13226# a_18795_13226# 0.39036f
C3028 a_13121_11521# a_15688_11093# 0.01441f
C3029 a_12849_11557# a_15108_11015# 0.10521f
C3030 a_4187_2434# a_26803_7532# 0.06661f
C3031 a_4187_2434# a_5523_4687# 0.06627f
C3032 a_18313_14024# VDD 0.4946f
C3033 a_27991_13190# VDD 0.28201f
C3034 a_13592_11113# REF_CLK 0.03445f
C3035 a_24957_7532# a_25717_7532# 0.06198f
C3036 a_6425_6734# a_6635_6734# 0.09424f
C3037 a_5957_4687# a_5844_3853# 0.02055f
C3038 a_5731_5979# a_7043_4687# 0.01539f
C3039 a_8237_1842# a_8563_1842# 0.01427f
C3040 a_7390_3889# a_9751_3853# 0.26208f
C3041 a_12037_1842# a_10430_1044# 0.05231f
C3042 a_11277_1842# a_11271_1008# 0.02349f
C3043 a_26185_1044# a_26471_1008# 0.01885f
C3044 a_12791_6698# VDD 0.28232f
C3045 a_16597_1842# VDD 0.86961f
C3046 a_25528_1044# VDD 0.17274f
C3047 a_7803_16869# a_7911_16869# 0.01163f
C3048 a_22873_16869# a_23437_16869# 0.0114f
C3049 a_4187_2434# a_20593_14024# 0.11222f
C3050 a_20723_14024# a_20831_14652# 0.01697f
C3051 a_14643_14024# a_14751_14024# 0.01163f
C3052 a_10985_13226# a_11271_13190# 0.01885f
C3053 a_4350_13226# a_6711_13190# 0.26208f
C3054 a_13753_7532# a_14317_7532# 0.0114f
C3055 REF_MUX_SEL3 REF_MUX_OUT 0.79533f
C3056 REF_MUX_SEL2 CHAN2_DELAY_IN 0.2107f
C3057 a_15403_7532# a_15511_7532# 0.01163f
C3058 a_21483_7532# a_21591_8160# 0.01697f
C3059 a_4187_2434# a_18877_1842# 0.0414f
C3060 a_8745_15546# VDD 0.29292f
C3061 a_21483_16869# VDD 0.49801f
C3062 a_4248_13226# VDD 0.17587f
C3063 a_12363_7532# VDD 0.92686f
C3064 a_2297_16422# CHAN0_MUX_SEL1 0.01995f
C3065 a_1544_16071# CHAN0_MUX_OUT 0.04241f
C3066 a_5731_12471# CHAN1_MUX_OUT 1.04829f
C3067 a_8745_12701# CHAN1_MUX_SEL4 0.04472f
C3068 a_20593_4687# a_21157_4687# 0.0114f
C3069 a_5705_3364# a_5731_3134# 0.28954f
C3070 a_24957_4687# a_25604_3853# 0.02011f
C3071 a_11603_1842# a_11711_1842# 0.01163f
C3072 a_17683_1842# a_17791_2470# 0.01697f
C3073 a_25153_1842# a_25283_1842# 0.70845f
C3074 a_19203_4687# VDD 0.50004f
C3075 a_2873_3176# VDD 0.46598f
C3076 a_18585_1044# VDD 0.29742f
C3077 a_4187_2434# a_23763_16869# 0.06627f
C3078 a_13753_16869# a_13883_16869# 0.70845f
C3079 a_4187_2434# a_16108_15316# 0.21585f
C3080 a_17357_16869# a_17928_16071# 0.10863f
C3081 a_4187_2434# a_14643_7532# 0.06668f
C3082 a_18313_14024# a_18877_14024# 0.0114f
C3083 a_22677_14024# a_22564_13190# 0.05157f
C3084 a_4633_7532# a_4763_7532# 0.70845f
C3085 a_4187_2434# a_21483_4687# 0.06627f
C3086 a_4187_2434# VDD 73.4081f
C3087 a_22351_14652# VDD 0.02349f
C3088 a_8231_16035# VDD 0.28357f
C3089 a_12943_11557# VDD 0.29488f
C3090 a_23003_7532# a_23111_7532# 0.01163f
C3091 a_23145_6734# a_23431_6698# 0.01885f
C3092 a_16108_5979# a_21157_4687# 0.01319f
C3093 a_15077_4687# a_14964_3853# 0.02055f
C3094 a_11473_4687# a_11603_4687# 0.70845f
C3095 a_20397_1842# a_20391_1008# 0.02349f
C3096 a_21157_1842# a_19550_1044# 0.05231f
C3097 a_16597_1842# a_16163_1842# 0.69698f
C3098 a_25528_1044# a_25630_1044# 0.37183f
C3099 a_11785_6209# VDD 0.29292f
C3100 a_16271_2470# VDD 0.01806f
C3101 a_5768_3889# VDD 0.17499f
C3102 a_1256_3889# CHAN2_MUX_SEL1 1.44243f
C3103 a_1544_3889# CHAN2_MUX_SEL0 0.07603f
C3104 a_4187_2434# a_6153_16869# 0.11222f
C3105 a_26043_16869# a_26151_17497# 0.01697f
C3106 a_5197_16869# a_4763_16869# 0.6972f
C3107 a_18585_16071# a_18795_16071# 0.09424f
C3108 a_16108_15316# a_16597_14024# 0.01319f
C3109 a_9193_14024# a_9323_14024# 0.70845f
C3110 a_15108_11799# a_14851_11918# 0.29858f
C3111 a_12849_11557# a_13306_10795# 0.10976f
C3112 a_21917_7532# a_22113_7532# 0.76914f
C3113 a_4187_2434# a_25153_7532# 0.11284f
C3114 a_16597_14024# VDD 0.86961f
C3115 a_25528_13226# VDD 0.17274f
C3116 a_15304_10295# REF_CLK 0.01066f
C3117 a_24197_7532# a_23763_7532# 0.6972f
C3118 a_4157_7003# a_4350_6734# 0.04624f
C3119 a_16108_5979# a_16851_5999# 0.06181f
C3120 a_8997_4687# a_9465_3889# 0.2079f
C3121 a_5197_4687# a_4350_3889# 0.08038f
C3122 a_7288_3889# a_7390_3889# 0.37183f
C3123 a_14025_3889# a_14235_3889# 0.09424f
C3124 a_5731_3134# a_15077_1842# 0.01319f
C3125 a_7477_1842# a_7673_1842# 0.73897f
C3126 a_9757_1842# a_10404_1008# 0.02011f
C3127 a_13368_1044# a_13444_1008# 0.01176f
C3128 a_10328_6734# VDD 0.17274f
C3129 a_13883_1842# VDD 0.50061f
C3130 a_26151_5315# VDD 0.01806f
C3131 a_22590_1044# VDD 0.98586f
C3132 a_4003_1842# CHAN2_MUX_SEL4 0.01225f
C3133 a_6283_16869# a_6391_16869# 0.01163f
C3134 a_4187_2434# a_18877_14024# 0.0414f
C3135 a_26477_16869# a_27048_16071# 0.10863f
C3136 a_21917_16869# a_22677_16869# 0.06198f
C3137 a_13123_14024# a_13231_14024# 0.01163f
C3138 a_19203_14024# a_19311_14652# 0.01697f
C3139 a_4248_13226# a_4350_13226# 0.37183f
C3140 a_26477_14024# a_26673_14024# 0.76914f
C3141 a_12797_7532# a_13557_7532# 0.05851f
C3142 a_4187_2434# a_16163_1842# 0.06627f
C3143 a_4187_2434# a_25630_1044# 0.01522f
C3144 a_19963_7532# a_20071_8160# 0.01697f
C3145 a_13883_7532# a_13991_7532# 0.01163f
C3146 a_19833_16869# VDD 0.49294f
C3147 a_2873_15358# VDD 0.46598f
C3148 a_18585_13226# VDD 0.29742f
C3149 a_10713_7532# VDD 0.49296f
C3150 a_2873_12513# CHAN1_MUX_SEL4 0.04916f
C3151 a_2297_12513# CHAN1_MUX_OUT 0.01179f
C3152 a_3449_12513# CHAN1_MUX_SEL3 0.28429f
C3153 a_22590_6734# a_24875_6734# 0.39036f
C3154 a_24197_4687# a_24084_3853# 0.02055f
C3155 a_19637_4687# a_20397_4687# 0.01669f
C3156 a_16163_1842# a_16271_2470# 0.01697f
C3157 a_4905_1044# a_5115_1044# 0.09424f
C3158 a_10083_1842# a_10191_1842# 0.01163f
C3159 a_16108_289# a_23945_519# 0.2906f
C3160 a_17553_4687# VDD 0.49593f
C3161 a_27048_3889# VDD 0.17499f
C3162 a_4187_2434# a_22113_16869# 0.11169f
C3163 a_19550_16071# a_21835_16071# 0.39036f
C3164 a_17357_14024# a_18117_14024# 0.03319f
C3165 a_4187_2434# a_12993_7532# 0.11169f
C3166 a_25630_13226# a_27991_13190# 0.26208f
C3167 a_4187_2434# a_19833_4687# 0.11222f
C3168 a_5768_16071# VDD 0.17499f
C3169 a_16271_14652# VDD 0.01806f
C3170 a_12849_11557# VDD 2.60064f
C3171 a_27563_7532# a_27671_8160# 0.01697f
C3172 a_16108_5979# a_18443_4687# 0.01542f
C3173 a_10430_6734# a_12791_6698# 0.26208f
C3174 a_14317_4687# a_13470_3889# 0.08038f
C3175 a_22677_4687# a_23145_3889# 0.19203f
C3176 a_15273_1842# a_15837_1842# 0.0114f
C3177 a_24008_1044# a_24084_1008# 0.01176f
C3178 a_18877_1842# a_19524_1008# 0.02011f
C3179 a_26185_3889# VDD 0.30411f
C3180 a_10191_2470# VDD 0.01806f
C3181 a_3449_331# CHAN3_DELAY_IN 0.01017f
C3182 VDD CHAN1_MUX_SEL0 0.58791f
C3183 a_1256_289# CHAN3_MUX_SEL3 1.41161f
C3184 a_1544_289# CHAN3_MUX_SEL2 0.07405f
C3185 a_4187_2434# a_4437_16869# 0.04193f
C3186 a_24523_16869# a_24631_17497# 0.01697f
C3187 a_8237_14024# a_8563_14024# 0.01427f
C3188 a_7390_16071# a_9751_16035# 0.26208f
C3189 a_26185_13226# a_26471_13190# 0.01885f
C3190 a_12037_14024# a_10430_13226# 0.05231f
C3191 a_11277_14024# a_11271_13190# 0.02349f
C3192 a_13121_11521# a_15304_10295# 0.40921f
C3193 a_5974_11413# a_9712_9602# 0.01152f
C3194 a_6326_10280# a_5864_9057# 0.01889f
C3195 a_6126_9506# a_5778_9057# 1.6143f
C3196 a_14009_11568# a_14111_11568# 0.47795f
C3197 a_6854_11676# a_9444_9602# 0.01142f
C3198 a_20593_7532# a_20723_7532# 0.70845f
C3199 a_4187_2434# a_23437_7532# 0.04013f
C3200 a_19637_7532# a_20105_6734# 0.19203f
C3201 a_12363_7532# a_10430_6734# 0.01012f
C3202 a_26911_17497# VDD 0.01806f
C3203 a_13883_14024# VDD 0.50061f
C3204 a_22590_13226# VDD 0.98586f
C3205 a_27433_4687# a_27563_4687# 0.70845f
C3206 a_5768_3889# a_5844_3853# 0.01176f
C3207 a_6153_1842# a_6283_1842# 0.70845f
C3208 a_8997_1842# a_8884_1008# 0.02055f
C3209 a_20071_5315# VDD 0.01806f
C3210 a_7390_6734# VDD 0.8686f
C3211 a_19524_1008# VDD 0.28633f
C3212 a_12233_1842# VDD 0.59884f
C3213 a_15964_3134# CHAN2_MUX_SEL4 0.5544f
C3214 a_4763_16869# a_4871_16869# 0.01163f
C3215 a_21157_16869# a_20723_16869# 0.6972f
C3216 a_4187_2434# a_16163_14024# 0.06627f
C3217 a_25153_14024# a_25283_14024# 0.70845f
C3218 a_4187_2434# a_25630_13226# 0.01522f
C3219 a_17683_14024# a_17791_14652# 0.01697f
C3220 VDD CHAN3_MUX_SEL3 0.4053f
C3221 a_5705_15546# a_5731_15316# 0.28954f
C3222 a_11603_14024# a_11711_14024# 0.01163f
C3223 a_12037_7532# a_11603_7532# 0.6972f
C3224 a_4187_2434# a_14513_1842# 0.11222f
C3225 a_18443_7532# a_18551_8160# 0.01697f
C3226 a_12363_7532# a_12471_7532# 0.01163f
C3227 a_4437_7532# a_4905_6734# 0.19203f
C3228 a_18117_16869# VDD 0.85889f
C3229 a_27048_16071# VDD 0.17499f
C3230 a_8997_7532# VDD 0.85889f
C3231 a_18877_4687# a_18443_4687# 0.6972f
C3232 a_10430_6734# a_11785_6209# 0.02058f
C3233 a_1256_3889# a_1721_4240# 0.13421f
C3234 a_23437_4687# a_22590_3889# 0.08038f
C3235 a_8563_1842# a_8671_1842# 0.01163f
C3236 a_1256_3134# a_1544_3134# 1.25711f
C3237 a_23437_1842# a_23633_1842# 0.76914f
C3238 a_14643_1842# a_14751_2470# 0.01697f
C3239 a_15837_4687# VDD 0.87964f
C3240 a_24084_3853# VDD 0.28225f
C3241 a_4187_2434# a_20397_16869# 0.04141f
C3242 a_12037_16869# a_12233_16869# 0.77122f
C3243 a_4187_2434# a_11277_7532# 0.04141f
C3244 a_16597_14024# a_16163_14024# 0.69698f
C3245 a_25528_13226# a_25630_13226# 0.37183f
C3246 a_20397_14024# a_20391_13190# 0.02349f
C3247 a_21157_14024# a_19550_13226# 0.05231f
C3248 a_4187_2434# a_18117_4687# 0.04152f
C3249 a_21483_7532# a_19550_6734# 0.01012f
C3250 a_26185_16071# VDD 0.30409f
C3251 a_10191_14652# VDD 0.01806f
C3252 a_12158_11557# VDD 0.37953f
C3253 a_11785_15546# CHAN0_MUX_SEL4 0.03255f
C3254 a_26043_7532# a_26151_8160# 0.01697f
C3255 a_10328_6734# a_10430_6734# 0.37183f
C3256 a_16108_5979# a_16793_4687# 0.01843f
C3257 a_9757_4687# a_9953_4687# 0.76914f
C3258 a_16408_3889# a_16484_3853# 0.01176f
C3259 a_12797_4687# a_12791_3853# 0.02354f
C3260 a_16108_3134# a_26477_1842# 0.01319f
C3261 a_14317_1842# a_15077_1842# 0.03319f
C3262 a_18117_1842# a_18004_1008# 0.02055f
C3263 a_13470_1044# a_5731_289# 0.41365f
C3264 a_22590_1044# a_22564_1008# 0.277f
C3265 a_14025_3889# VDD 0.30411f
C3266 a_1544_5979# VDD 0.3957f
C3267 a_4111_2470# VDD 0.01866f
C3268 VDD CHAN0_MUX_SEL0 0.58791f
C3269 a_23003_16869# a_23111_17497# 0.01697f
C3270 a_14025_16071# a_14235_16071# 0.09424f
C3271 a_4763_16869# a_4350_16071# 0.01012f
C3272 a_7288_16071# a_7390_16071# 0.37183f
C3273 a_5731_15316# a_15077_14024# 0.01319f
C3274 a_7477_14024# a_7673_14024# 0.73897f
C3275 a_9757_14024# a_10404_13190# 0.02011f
C3276 a_13368_13226# a_13444_13190# 0.01176f
C3277 a_13566_11525# a_13592_11561# 0.36952f
C3278 a_20831_17497# VDD 0.01806f
C3279 a_12233_14024# VDD 0.59884f
C3280 a_19524_13190# VDD 0.28633f
C3281 a_26477_7532# a_27124_6698# 0.02312f
C3282 a_26477_4687# a_26803_4687# 0.01427f
C3283 a_9465_3889# a_9751_3853# 0.01885f
C3284 a_4350_3889# a_4324_3853# 0.277f
C3285 a_13557_1842# a_14025_1044# 0.19203f
C3286 a_5731_3134# a_10713_1842# 0.01865f
C3287 a_8237_1842# a_7390_1044# 0.08038f
C3288 a_5197_1842# a_5523_1842# 0.01427f
C3289 a_21625_1044# a_19550_1044# 0.03208f
C3290 a_10430_1044# a_11195_1044# 0.39037f
C3291 a_4324_6698# VDD 0.28687f
C3292 a_13991_5315# VDD 0.01806f
C3293 a_10517_1842# VDD 0.87095f
C3294 a_17275_1044# VDD 0.15389f
C3295 a_2297_7085# REF_MUX_SEL1 0.01995f
C3296 a_1544_6734# REF_MUX_OUT 0.04241f
C3297 a_8745_3364# CHAN2_MUX_SEL4 0.04472f
C3298 a_5731_3134# CHAN2_MUX_OUT 1.04829f
C3299 a_19833_16869# a_20397_16869# 0.0114f
C3300 a_4187_2434# a_14513_14024# 0.11222f
C3301 VDD CHAN2_MUX_SEL3 0.41788f
C3302 CHAN1_MUX_SEL4 CHAN1_MUX_OUT 0.91933f
C3303 a_10083_14024# a_10191_14024# 0.01163f
C3304 a_16163_14024# a_16271_14652# 0.01697f
C3305 a_16108_12471# a_23945_12701# 0.2906f
C3306 a_4905_13226# a_5115_13226# 0.09424f
C3307 a_10713_7532# a_11277_7532# 0.0114f
C3308 a_4187_2434# a_12797_1842# 0.0414f
C3309 a_16923_7532# a_17031_8160# 0.01697f
C3310 a_10843_7532# a_10951_7532# 0.01163f
C3311 a_24084_16035# VDD 0.28225f
C3312 a_15403_16869# VDD 0.4973f
C3313 a_6283_7532# VDD 0.4973f
C3314 a_17553_4687# a_18117_4687# 0.0114f
C3315 a_27048_3889# a_27124_3853# 0.01176f
C3316 a_21917_4687# a_21911_3853# 0.02354f
C3317 a_13123_1842# a_13231_2470# 0.01697f
C3318 a_22113_1842# a_22243_1842# 0.70361f
C3319 a_7043_1842# a_7151_1842# 0.01163f
C3320 a_27237_1842# a_27124_1008# 0.02055f
C3321 a_5731_289# a_15765_463# 0.23301f
C3322 a_23871_8160# VDD 0.01806f
C3323 a_21835_3889# VDD 0.15407f
C3324 a_13123_4687# VDD 0.4839f
C3325 a_10713_16869# a_10843_16869# 0.70845f
C3326 a_4187_2434# a_17683_16869# 0.06627f
C3327 a_13883_16869# a_13470_16071# 0.01012f
C3328 a_4187_2434# a_8563_7532# 0.06627f
C3329 a_15273_14024# a_15837_14024# 0.0114f
C3330 a_18877_14024# a_19524_13190# 0.02011f
C3331 a_24008_13226# a_24084_13190# 0.01176f
C3332 a_9444_10280# a_9444_9602# 2.19249f
C3333 a_15108_11015# a_15464_9374# 0.12158f
C3334 a_4187_2434# a_15403_4687# 0.06627f
C3335 a_14025_16071# VDD 0.30409f
C3336 a_10206_11525# VDD 0.09398f
C3337 a_4111_14652# VDD 0.01866f
C3338 a_24523_7532# a_24631_8160# 0.01697f
C3339 a_18585_6734# a_16510_6734# 0.03208f
C3340 a_8808_6734# a_8884_6698# 0.01176f
C3341 a_8433_4687# a_8563_4687# 0.70845f
C3342 a_11277_4687# a_11924_3853# 0.02312f
C3343 a_17357_1842# a_16510_1044# 0.08038f
C3344 a_13557_1842# a_13123_1842# 0.69698f
C3345 a_27237_1842# a_27705_1044# 0.2079f
C3346 a_16108_3134# a_23763_1842# 0.01544f
C3347 a_25604_6698# VDD 0.28633f
C3348 a_4157_4158# VDD 0.48946f
C3349 a_26477_1842# VDD 0.87175f
C3350 a_21483_16869# a_21591_17497# 0.01697f
C3351 a_7477_16869# a_7945_16071# 0.19203f
C3352 a_5768_16071# a_5844_16035# 0.01176f
C3353 a_8997_14024# a_8884_13190# 0.02055f
C3354 a_6153_14024# a_6283_14024# 0.70845f
C3355 a_6854_11676# a_13592_11113# 0.01519f
C3356 a_12849_11557# a_13306_11995# 0.12097f
C3357 a_18877_7532# a_19073_7532# 0.76914f
C3358 a_10517_14024# VDD 0.87095f
C3359 a_14751_17497# VDD 0.01806f
C3360 a_17275_13226# VDD 0.15389f
C3361 a_22243_7532# VDD 0.95024f
C3362 a_7390_16071# CHAN0_MUX_SEL4 0.34655f
C3363 a_12355_11557# CHAN1_MUX_OUT 0.05703f
C3364 a_25717_7532# a_25630_6734# 0.1088f
C3365 a_25717_4687# a_25913_4687# 0.73897f
C3366 a_4437_1842# a_4633_1842# 0.73897f
C3367 a_5731_3134# a_8997_1842# 0.01319f
C3368 a_7945_3889# a_7390_3889# 0.03209f
C3369 a_6717_1842# a_6711_1008# 0.02354f
C3370 a_21625_6734# VDD 0.29722f
C3371 a_7911_5315# VDD 0.01806f
C3372 a_7803_1842# VDD 0.50058f
C3373 a_14311_1008# VDD 0.28336f
C3374 a_2297_3176# CHAN2_MUX_OUT 0.01179f
C3375 a_2873_3176# CHAN2_MUX_SEL4 0.04916f
C3376 a_3449_3176# CHAN2_MUX_SEL3 0.28429f
C3377 a_18877_16869# a_19637_16869# 0.06198f
C3378 CHAN1_MUX_SEL0 CHAN1_MUX_SEL1 3.14917f
C3379 VDD REF_MUX_SEL3 0.41788f
C3380 a_4187_2434# a_12797_14024# 0.0414f
C3381 a_1256_16071# a_1721_16422# 0.13421f
C3382 a_1256_15316# a_1544_15316# 1.25711f
C3383 a_23437_14024# a_23633_14024# 0.76914f
C3384 a_8563_14024# a_8671_14024# 0.01163f
C3385 a_14643_14024# a_14751_14652# 0.01697f
C3386 a_5731_12471# a_6326_10280# 0.11352f
C3387 a_9757_7532# a_10517_7532# 0.06198f
C3388 a_15403_7532# a_15511_8160# 0.01697f
C3389 a_4187_2434# a_10083_1842# 0.06627f
C3390 a_9323_7532# a_9431_7532# 0.01163f
C3391 a_13753_16869# VDD 0.493f
C3392 a_21835_16071# VDD 0.15406f
C3393 a_4633_7532# VDD 0.49285f
C3394 a_4187_2434# CHAN2_MUX_SEL4 0.01921f
C3395 a_19448_6734# a_19524_6698# 0.01176f
C3396 a_16597_4687# a_17357_4687# 0.01669f
C3397 a_20397_4687# a_21044_3853# 0.02312f
C3398 a_25630_3889# a_25604_3853# 0.277f
C3399 a_16510_3889# a_15964_3134# 0.05416f
C3400 a_11603_1842# a_11711_2470# 0.01697f
C3401 a_5523_1842# a_5631_1842# 0.01163f
C3402 a_26477_1842# a_25630_1044# 0.08038f
C3403 a_11473_4687# VDD 0.49601f
C3404 a_17791_8160# VDD 0.01806f
C3405 a_18871_3853# VDD 0.2822f
C3406 a_4187_2434# a_16033_16869# 0.11222f
C3407 a_21157_16869# a_21625_16071# 0.2079f
C3408 a_12797_16869# a_13368_16071# 0.10864f
C3409 a_9757_16869# a_10083_16869# 0.01427f
C3410 a_16408_16071# a_16484_16035# 0.01176f
C3411 a_4187_2434# a_6913_7532# 0.11222f
C3412 a_14317_14024# a_15077_14024# 0.03319f
C3413 a_18117_14024# a_18004_13190# 0.02055f
C3414 a_16108_15316# a_26477_14024# 0.01319f
C3415 a_13470_13226# a_5731_12471# 0.41365f
C3416 a_22590_13226# a_22564_13190# 0.277f
C3417 a_13592_11113# a_14757_10872# 0.43239f
C3418 a_14111_10917# a_13880_10808# 0.12701f
C3419 a_4187_2434# a_13753_4687# 0.11222f
C3420 a_4157_16340# VDD 0.48946f
C3421 a_26477_14024# VDD 0.87175f
C3422 a_6126_9506# VDD 0.84321f
C3423 a_1544_15316# CHAN0_MUX_SEL4 0.47529f
C3424 a_1256_15316# CHAN0_MUX_OUT 0.1134f
C3425 a_2297_15358# CHAN0_MUX_SEL2 0.10655f
C3426 a_4157_13495# CHAN1_MUX_SEL4 0.08229f
C3427 a_23003_7532# a_23111_8160# 0.01697f
C3428 a_7390_6734# a_7364_6698# 0.277f
C3429 a_10517_4687# a_10430_3889# 0.1088f
C3430 a_5731_5979# a_15273_4687# 0.01872f
C3431 a_24665_3889# a_24951_3853# 0.01885f
C3432 a_12233_1842# a_12797_1842# 0.0114f
C3433 a_16108_3134# a_22113_1842# 0.01872f
C3434 a_13470_3889# a_14235_3889# 0.39037f
C3435 a_15837_1842# a_15831_1008# 0.02354f
C3436 a_19550_1044# a_20391_1008# 0.28268f
C3437 a_23355_6734# VDD 0.15389f
C3438 a_23763_1842# VDD 0.49688f
C3439 a_16851_309# VDD 0.51536f
C3440 a_26673_16869# a_26803_16869# 0.70845f
C3441 a_19963_16869# a_20071_17497# 0.01697f
C3442 a_5957_16869# a_6425_16071# 0.2079f
C3443 a_4350_16071# a_4324_16035# 0.277f
C3444 a_9465_16071# a_9751_16035# 0.01885f
C3445 a_5197_14024# a_5523_14024# 0.01427f
C3446 a_5731_15316# a_10713_14024# 0.01865f
C3447 a_13557_14024# a_14025_13226# 0.19203f
C3448 a_8237_14024# a_7390_13226# 0.08038f
C3449 a_12355_11557# a_12656_11554# 0.03277f
C3450 a_21625_13226# a_19550_13226# 0.03208f
C3451 a_10430_13226# a_11195_13226# 0.39037f
C3452 a_6854_11676# a_15304_10295# 0.08165f
C3453 a_17553_7532# a_17683_7532# 0.70845f
C3454 CHAN3_MUX_SEL3 CHAN3_MUX_SEL4 0.75489f
C3455 CHAN3_MUX_SEL2 CHAN3_MUX_OUT 0.08497f
C3456 a_4187_2434# a_26043_1842# 0.06627f
C3457 a_8237_7532# a_8808_6734# 0.10863f
C3458 a_7803_14024# VDD 0.50058f
C3459 a_8671_17497# VDD 0.01806f
C3460 a_14311_13190# VDD 0.28336f
C3461 a_20593_7532# VDD 0.49419f
C3462 a_10649_11568# REF_CLK 0.25484f
C3463 a_24393_4687# a_24523_4687# 0.70845f
C3464 a_5731_3134# a_6283_1842# 0.01542f
C3465 a_5197_1842# a_5844_1008# 0.02312f
C3466 a_15545_1044# a_15755_1044# 0.09424f
C3467 a_7390_1044# a_8808_1044# 0.38994f
C3468 a_27433_4687# VDD 0.49998f
C3469 a_9465_6734# VDD 0.29722f
C3470 a_6153_1842# VDD 0.4946f
C3471 a_11848_1044# VDD 0.17499f
C3472 a_3449_1395# CHAN3_MUX_SEL0 0.10753f
C3473 a_18117_16869# a_17683_16869# 0.6972f
C3474 a_21917_16869# a_22488_16071# 0.10864f
C3475 a_4187_2434# a_10083_14024# 0.06627f
C3476 a_27048_16071# a_27124_16035# 0.01176f
C3477 CHAN0_MUX_SEL4 CHAN0_MUX_OUT 0.91933f
C3478 a_13123_14024# a_13231_14652# 0.01697f
C3479 a_22113_14024# a_22243_14024# 0.70361f
C3480 a_27237_14024# a_27124_13190# 0.02055f
C3481 a_7043_14024# a_7151_14024# 0.01163f
C3482 a_8997_7532# a_8563_7532# 0.6972f
C3483 a_5731_12471# a_15765_12645# 0.23301f
C3484 a_4187_2434# a_8433_1842# 0.11222f
C3485 a_13883_7532# a_13991_8160# 0.01697f
C3486 a_7803_7532# a_7911_7532# 0.01163f
C3487 a_12037_16869# VDD 0.86065f
C3488 a_18871_16035# VDD 0.2822f
C3489 a_15464_9374# VDD 0.52511f
C3490 a_4187_2434# REF_MUX_SEL4 0.01921f
C3491 a_4350_6734# a_5731_5979# 0.41099f
C3492 a_19637_4687# a_19550_3889# 0.1088f
C3493 a_15837_4687# a_15403_4687# 0.6972f
C3494 a_4003_1842# a_4111_1842# 0.01163f
C3495 a_10083_1842# a_10191_2470# 0.01697f
C3496 a_24957_1842# a_24951_1008# 0.02354f
C3497 a_20397_1842# a_20593_1842# 0.76914f
C3498 a_11711_8160# VDD 0.01806f
C3499 a_9757_4687# VDD 0.88193f
C3500 a_16408_3889# VDD 0.17274f
C3501 a_11785_6209# REF_MUX_SEL4 0.03255f
C3502 a_8997_16869# a_9193_16869# 0.77122f
C3503 a_12797_16869# a_10430_16071# 0.02479f
C3504 a_4187_2434# a_14317_16869# 0.04141f
C3505 a_4187_2434# a_5197_7532# 0.04141f
C3506 a_16108_15316# a_23763_14024# 0.01544f
C3507 a_13557_14024# a_13123_14024# 0.69698f
C3508 a_27237_14024# a_27705_13226# 0.2079f
C3509 a_17357_14024# a_16510_13226# 0.08038f
C3510 a_15304_10295# a_14757_10872# 0.02225f
C3511 a_4187_2434# a_12037_4687# 0.04152f
C3512 a_17357_7532# a_17928_6734# 0.10863f
C3513 a_23763_14024# VDD 0.49688f
C3514 a_16851_12491# VDD 0.51536f
C3515 a_2873_13577# CHAN1_MUX_SEL0 0.01504f
C3516 a_6717_4687# a_6913_4687# 0.76914f
C3517 a_12505_6734# a_12715_6734# 0.09424f
C3518 a_11277_1842# a_12037_1842# 0.03319f
C3519 a_16108_3134# a_20397_1842# 0.01319f
C3520 a_23145_3889# a_22590_3889# 0.03209f
C3521 a_14317_1842# a_14964_1008# 0.02312f
C3522 a_18795_1044# a_18871_1008# 0.01194f
C3523 a_20391_6698# VDD 0.28357f
C3524 a_22113_1842# VDD 0.55735f
C3525 a_4187_2434# a_26043_14024# 0.06627f
C3526 a_4437_16869# a_4157_16340# 0.01771f
C3527 a_7945_16071# a_7390_16071# 0.03209f
C3528 a_18443_16869# a_18551_17497# 0.01697f
C3529 a_5731_15316# a_8997_14024# 0.01319f
C3530 a_4437_14024# a_4633_14024# 0.73897f
C3531 a_6717_14024# a_6711_13190# 0.02354f
C3532 CHAN3_DELAY_IN CHAN3_MUX_SEL1 0.01824f
C3533 a_4187_2434# a_24393_1842# 0.11222f
C3534 a_27997_16869# VDD 0.76025f
C3535 a_6153_14024# VDD 0.4946f
C3536 a_11848_13226# VDD 0.17499f
C3537 a_18877_7532# VDD 0.87825f
C3538 a_1544_5979# a_1721_6021# 0.36963f
C3539 a_1256_5979# a_2297_6021# 0.04261f
C3540 a_23437_4687# a_23763_4687# 0.01427f
C3541 a_15765_3308# a_16108_3134# 0.42004f
C3542 a_4437_1842# a_4350_1044# 0.1088f
C3543 a_25717_4687# VDD 0.871f
C3544 a_8884_1008# VDD 0.28225f
C3545 a_4437_1842# VDD 0.87147f
C3546 a_21917_16869# a_19550_16071# 0.02479f
C3547 a_4187_2434# a_8433_14024# 0.11222f
C3548 a_16793_16869# a_17357_16869# 0.0114f
C3549 a_5523_14024# a_5631_14024# 0.01163f
C3550 CHAN0_MUX_SEL0 CHAN0_MUX_SEL1 3.14917f
C3551 a_25630_16071# a_25604_16035# 0.277f
C3552 a_11603_14024# a_11711_14652# 0.01697f
C3553 a_4187_2434# a_21157_7532# 0.04188f
C3554 a_16510_16071# a_15964_15316# 0.05416f
C3555 a_26477_14024# a_25630_13226# 0.08038f
C3556 a_7673_7532# a_8237_7532# 0.0114f
C3557 a_4187_2434# a_27997_4687# 0.04001f
C3558 a_4187_2434# a_6717_1842# 0.0414f
C3559 a_6283_7532# a_6391_7532# 0.01163f
C3560 a_12363_7532# a_12471_8160# 0.01697f
C3561 a_9323_16869# VDD 0.4973f
C3562 a_16408_16071# VDD 0.17274f
C3563 a_9757_14024# CHAN1_MUX_SEL4 0.01829f
C3564 a_16108_5979# a_26673_4687# 0.01872f
C3565 a_14513_4687# a_15077_4687# 0.0114f
C3566 a_16510_6734# a_17275_6734# 0.39037f
C3567 a_8563_1842# a_8671_2470# 0.01697f
C3568 a_22590_3889# a_23431_3853# 0.28268f
C3569 a_19073_1842# a_19203_1842# 0.70845f
C3570 a_23437_1842# a_24084_1008# 0.02312f
C3571 a_5631_8160# VDD 0.01806f
C3572 a_7043_4687# VDD 0.4999f
C3573 a_13470_3889# VDD 0.87936f
C3574 a_7673_16869# a_7803_16869# 0.70845f
C3575 a_4187_2434# a_11603_16869# 0.06627f
C3576 a_13470_16071# a_14235_16071# 0.39037f
C3577 a_10517_16869# a_10404_16035# 0.05157f
C3578 a_24665_16071# a_24951_16035# 0.01885f
C3579 a_16108_15316# a_22113_14024# 0.01872f
C3580 a_12233_14024# a_12797_14024# 0.0114f
C3581 a_15837_14024# a_15831_13190# 0.02354f
C3582 a_19550_13226# a_20391_13190# 0.28268f
C3583 a_13132_11110# a_13306_10795# 0.27179f
C3584 CHAN1_MUX_OUT REF_DELAY_OUT_LAST 0.02664f
C3585 a_4187_2434# a_9323_4687# 0.06627f
C3586 a_22113_14024# VDD 0.55574f
C3587 a_1256_13226# CHAN1_MUX_SEL0 0.3314f
C3588 a_9444_9602# DLL_RESETN 0.03031f
C3589 a_26673_7532# a_26803_7532# 0.70845f
C3590 a_5393_4687# a_5523_4687# 0.70845f
C3591 a_4350_6734# a_5191_6698# 0.28268f
C3592 a_5731_5979# a_10843_4687# 0.01539f
C3593 a_10430_3889# a_11848_3889# 0.38994f
C3594 a_20105_3889# a_20391_3853# 0.01885f
C3595 a_16108_3134# a_17683_1842# 0.01562f
C3596 a_10517_1842# a_10083_1842# 0.69698f
C3597 a_17275_1044# a_17351_1008# 0.01194f
C3598 a_16510_1044# a_18004_1008# 0.28279f
C3599 a_13557_1842# a_13470_1044# 0.1088f
C3600 a_4350_1044# a_5705_519# 0.02005f
C3601 a_17928_6734# VDD 0.17499f
C3602 a_20397_1842# VDD 0.87175f
C3603 a_5705_519# VDD 0.29556f
C3604 a_7390_6734# REF_MUX_SEL4 0.34655f
C3605 a_4187_2434# a_24393_14024# 0.11222f
C3606 a_16923_16869# a_17031_17497# 0.01697f
C3607 a_24957_16869# a_25153_16869# 0.76914f
C3608 a_5197_14024# a_5844_13190# 0.02312f
C3609 a_5731_15316# a_6283_14024# 0.01542f
C3610 a_15545_13226# a_15755_13226# 0.09424f
C3611 a_7390_13226# a_8808_13226# 0.38994f
C3612 a_10520_11982# a_10751_11568# 0.12701f
C3613 a_15837_7532# a_16033_7532# 0.76914f
C3614 CHAN2_MUX_SEL2 CHAN2_MUX_OUT 0.08497f
C3615 CHAN2_MUX_SEL3 CHAN2_MUX_SEL4 0.75489f
C3616 a_4187_2434# a_22677_1842# 0.04058f
C3617 a_25283_16869# VDD 0.49737f
C3618 a_4437_14024# VDD 0.87156f
C3619 a_8884_13190# VDD 0.28225f
C3620 a_16163_7532# VDD 0.4973f
C3621 a_22677_4687# a_22873_4687# 0.73022f
C3622 a_19550_6734# a_16108_5979# 0.58202f
C3623 a_5731_3134# a_16108_3134# 0.01334f
C3624 a_4350_1044# a_6635_1044# 0.39036f
C3625 a_10985_1044# a_11195_1044# 0.09424f
C3626 a_1544_6734# VDD 0.46485f
C3627 a_23003_4687# VDD 0.48375f
C3628 a_15765_3308# VDD 0.36528f
C3629 a_6635_1044# VDD 0.15407f
C3630 a_15837_16869# a_16597_16869# 0.06198f
C3631 a_4187_2434# a_27563_16869# 0.06629f
C3632 a_4187_2434# a_6717_14024# 0.0414f
C3633 a_19637_16869# a_19524_16035# 0.05157f
C3634 a_20397_14024# a_20593_14024# 0.76914f
C3635 a_4187_2434# a_18443_7532# 0.06661f
C3636 a_10083_14024# a_10191_14652# 0.01697f
C3637 a_4003_14024# a_4111_14024# 0.01163f
C3638 a_24957_14024# a_24951_13190# 0.02354f
C3639 a_6717_7532# a_7477_7532# 0.06198f
C3640 a_4187_2434# a_25283_4687# 0.06627f
C3641 a_10843_7532# a_10951_8160# 0.01697f
C3642 a_4763_7532# a_4871_7532# 0.01163f
C3643 a_4187_2434# a_4003_1842# 0.05992f
C3644 a_7673_16869# VDD 0.49294f
C3645 a_13470_16071# VDD 0.87936f
C3646 a_13132_11110# VDD 0.23866f
C3647 a_13470_13226# CHAN1_MUX_SEL4 0.256f
C3648 a_27705_6734# a_27915_6734# 0.09424f
C3649 a_16108_5979# a_24957_4687# 0.01307f
C3650 a_13557_4687# a_14317_4687# 0.01669f
C3651 a_21835_3889# a_21911_3853# 0.01194f
C3652 a_7043_1842# a_7151_2470# 0.01697f
C3653 a_22677_1842# a_22590_1044# 0.1088f
C3654 a_19550_1044# a_20905_519# 0.02165f
C3655 a_26673_7532# VDD 0.49417f
C3656 a_10404_3853# VDD 0.28633f
C3657 a_5393_4687# VDD 0.49643f
C3658 a_27671_2470# VDD 0.01806f
C3659 a_3449_7085# REF_CLK 0.01058f
C3660 a_1544_5979# REF_MUX_SEL4 0.47529f
C3661 a_1256_5979# REF_MUX_OUT 0.1134f
C3662 a_4157_4158# CHAN2_MUX_SEL4 0.08229f
C3663 a_2297_6021# REF_MUX_SEL2 0.10655f
C3664 a_16108_289# CHAN3_MUX_OUT 0.24265f
C3665 a_4187_2434# a_9953_16869# 0.11222f
C3666 a_6717_16869# a_7043_16869# 0.01427f
C3667 a_23145_16071# a_22590_16071# 0.03209f
C3668 a_16108_15316# a_20397_14024# 0.01319f
C3669 a_14317_14024# a_14964_13190# 0.02312f
C3670 a_11277_14024# a_12037_14024# 0.03319f
C3671 a_18795_13226# a_18871_13190# 0.01194f
C3672 a_4187_2434# a_7673_4687# 0.11222f
C3673 a_5705_12701# VDD 0.29556f
C3674 a_20397_14024# VDD 0.87175f
C3675 a_7945_6734# a_8155_6734# 0.09424f
C3676 a_5731_5979# a_9193_4687# 0.01872f
C3677 a_16108_3134# a_16033_1842# 0.01197f
C3678 a_9193_1842# a_9757_1842# 0.0114f
C3679 a_14964_6698# VDD 0.28225f
C3680 a_17683_1842# VDD 0.49684f
C3681 a_27915_1044# VDD 0.15389f
C3682 a_23633_16869# a_23763_16869# 0.70845f
C3683 a_15403_16869# a_15511_17497# 0.01697f
C3684 a_4187_2434# a_22677_14024# 0.04055f
C3685 a_4437_14024# a_4350_13226# 0.1088f
C3686 a_15765_15490# a_16108_15316# 0.42004f
C3687 a_10206_11525# a_10232_11561# 0.36952f
C3688 a_14513_7532# a_14643_7532# 0.70845f
C3689 CHAN2_DELAY_IN CHAN2_MUX_SEL1 0.01824f
C3690 a_4763_7532# a_4350_6734# 0.01012f
C3691 a_4187_2434# a_19963_1842# 0.06627f
C3692 a_15765_15490# VDD 0.36528f
C3693 a_23633_16869# VDD 0.49425f
C3694 a_6635_13226# VDD 0.15407f
C3695 a_14513_7532# VDD 0.49436f
C3696 a_15765_12645# CHAN1_MUX_SEL4 0.65508f
C3697 a_21353_4687# a_21483_4687# 0.70845f
C3698 a_16510_6734# a_16851_5999# 0.02131f
C3699 a_25630_6734# a_26471_6698# 0.28268f
C3700 a_26477_1842# a_26043_1842# 0.6972f
C3701 a_21353_4687# VDD 0.49468f
C3702 a_5731_3134# VDD 0.98095f
C3703 a_4187_2434# a_25913_16869# 0.11222f
C3704 a_15077_16869# a_14643_16869# 0.6972f
C3705 a_22590_16071# a_23431_16035# 0.28268f
C3706 a_4187_2434# a_4003_14024# 0.05992f
C3707 a_19073_14024# a_19203_14024# 0.70845f
C3708 a_8563_14024# a_8671_14652# 0.01697f
C3709 a_4187_2434# a_16793_7532# 0.11284f
C3710 a_23437_14024# a_24084_13190# 0.02312f
C3711 a_5957_7532# a_5523_7532# 0.6972f
C3712 a_4187_2434# a_23633_4687# 0.11222f
C3713 a_9323_7532# a_9431_8160# 0.01697f
C3714 a_5957_16869# VDD 0.85889f
C3715 a_10404_16035# VDD 0.28633f
C3716 a_27671_14652# VDD 0.01806f
C3717 a_13470_6734# a_14888_6734# 0.38994f
C3718 a_12797_4687# a_12363_4687# 0.6972f
C3719 a_20315_3889# a_20391_3853# 0.01194f
C3720 a_19550_3889# a_21044_3853# 0.28279f
C3721 a_17357_1842# a_17553_1842# 0.76914f
C3722 a_5523_1842# a_5631_2470# 0.01697f
C3723 a_25630_1044# a_27915_1044# 0.39036f
C3724 a_20905_6209# VDD 0.29292f
C3725 a_24957_7532# VDD 0.87825f
C3726 a_8155_3889# VDD 0.1539f
C3727 a_21591_2470# VDD 0.01806f
C3728 a_2873_4240# CHAN2_MUX_SEL0 0.01504f
C3729 a_8997_16869# a_7390_16071# 0.05231f
C3730 a_4187_2434# a_8237_16869# 0.04141f
C3731 a_8237_16869# a_8231_16035# 0.02349f
C3732 a_5957_16869# a_6153_16869# 0.77122f
C3733 a_10430_16071# a_11848_16071# 0.38994f
C3734 a_20105_16071# a_20391_16035# 0.01885f
C3735 a_13557_14024# a_13470_13226# 0.1088f
C3736 a_16108_15316# a_17683_14024# 0.01562f
C3737 a_10517_14024# a_10083_14024# 0.69698f
C3738 a_13019_11521# a_15688_11093# 0.1287f
C3739 a_12849_11557# a_14851_10872# 0.13376f
C3740 a_13121_11521# a_15108_11015# 0.05903f
C3741 a_16510_13226# a_18004_13190# 0.28279f
C3742 a_4350_13226# a_5705_12701# 0.02005f
C3743 a_15688_11557# a_15304_10295# 0.19136f
C3744 a_17275_13226# a_17351_13190# 0.01194f
C3745 a_4187_2434# a_27237_7532# 0.0629f
C3746 a_4187_2434# a_5957_4687# 0.04152f
C3747 a_13883_7532# a_13470_6734# 0.01012f
C3748 a_17683_14024# VDD 0.49684f
C3749 a_27915_13226# VDD 0.15389f
C3750 a_13306_10795# REF_CLK 0.06166f
C3751 a_24957_7532# a_25153_7532# 0.76914f
C3752 a_6283_4687# a_4350_3889# 0.01012f
C3753 a_5731_5979# a_7477_4687# 0.01314f
C3754 a_10517_4687# a_10985_3889# 0.19203f
C3755 a_8237_1842# a_8997_1842# 0.03319f
C3756 a_7390_3889# a_9675_3889# 0.39036f
C3757 a_26185_1044# a_26395_1044# 0.09424f
C3758 a_13470_1044# a_15831_1008# 0.26208f
C3759 a_12715_6734# VDD 0.15484f
C3760 a_16033_1842# VDD 0.49413f
C3761 a_24951_1008# VDD 0.2822f
C3762 a_13883_16869# a_13991_17497# 0.01697f
C3763 a_4187_2434# a_19963_14024# 0.06627f
C3764 a_5731_15316# a_16108_15316# 0.01334f
C3765 a_21917_16869# a_16108_15316# 0.01053f
C3766 a_10985_13226# a_11195_13226# 0.09424f
C3767 a_4350_13226# a_6635_13226# 0.39036f
C3768 a_9746_11495# a_9772_11533# 0.1657f
C3769 REF_MUX_SEL3 REF_MUX_SEL4 0.75489f
C3770 REF_MUX_SEL2 REF_MUX_OUT 0.08497f
C3771 a_7477_7532# a_7945_6734# 0.19203f
C3772 a_4187_2434# a_18313_1842# 0.11222f
C3773 a_21917_16869# VDD 0.89148f
C3774 a_5731_15316# VDD 0.98095f
C3775 a_12797_7532# VDD 0.87928f
C3776 a_1544_16071# CHAN0_MUX_SEL4 0.02586f
C3777 a_1256_16071# CHAN0_MUX_OUT 0.02466f
C3778 a_2297_16422# CHAN0_MUX_SEL0 0.10655f
C3779 a_5731_12471# CHAN1_MUX_SEL4 4.60702f
C3780 a_24875_6734# a_24951_6698# 0.01194f
C3781 a_20397_4687# a_20723_4687# 0.01427f
C3782 a_25153_1842# a_25717_1842# 0.0114f
C3783 a_19637_4687# VDD 0.871f
C3784 a_2297_3176# VDD 0.47572f
C3785 a_17065_1044# VDD 0.30218f
C3786 a_9757_4687# CHAN2_MUX_SEL4 0.01829f
C3787 a_4187_2434# a_24197_16869# 0.04152f
C3788 a_13753_16869# a_14317_16869# 0.0114f
C3789 a_18117_16869# a_16510_16071# 0.05231f
C3790 a_17357_16869# a_17351_16035# 0.02349f
C3791 a_21835_16071# a_21911_16035# 0.01194f
C3792 a_7043_14024# a_7151_14652# 0.01697f
C3793 a_4187_2434# a_15077_7532# 0.04237f
C3794 a_22677_14024# a_22590_13226# 0.1088f
C3795 a_19550_13226# a_20905_12701# 0.02165f
C3796 a_4633_7532# a_5197_7532# 0.0114f
C3797 a_4187_2434# a_21917_4687# 0.0414f
C3798 a_7803_7532# a_7911_8160# 0.01697f
C3799 a_21591_14652# VDD 0.01806f
C3800 a_8155_16071# VDD 0.15389f
C3801 a_23145_6734# a_23355_6734# 0.09424f
C3802 a_24197_4687# a_24665_3889# 0.2079f
C3803 a_11473_4687# a_12037_4687# 0.0114f
C3804 a_15403_4687# a_13470_3889# 0.01012f
C3805 a_16108_5979# a_20593_4687# 0.01872f
C3806 a_4003_1842# a_4111_2470# 0.01697f
C3807 a_16033_1842# a_16163_1842# 0.70845f
C3808 a_15511_2470# VDD 0.01806f
C3809 a_5191_3853# VDD 0.28637f
C3810 a_1256_3889# CHAN2_MUX_SEL0 0.3314f
C3811 a_5705_519# CHAN3_MUX_SEL4 0.03556f
C3812 VDD REF_CLK 2.53838f
C3813 a_6717_16869# a_7364_16035# 0.02011f
C3814 a_4187_2434# a_5523_16869# 0.06627f
C3815 a_4633_16869# a_4763_16869# 0.70845f
C3816 a_16108_15316# a_16033_14024# 0.01197f
C3817 a_9193_14024# a_9757_14024# 0.0114f
C3818 a_12849_11557# a_13566_11018# 0.26617f
C3819 a_14111_11568# a_14851_11918# 0.26905f
C3820 a_21917_7532# a_21483_7532# 0.6972f
C3821 a_4187_2434# a_24523_7532# 0.06661f
C3822 a_12797_7532# a_13368_6734# 0.10864f
C3823 a_21157_7532# a_21625_6734# 0.2079f
C3824 a_16033_14024# VDD 0.49413f
C3825 a_24951_13190# VDD 0.2822f
C3826 a_15304_10295# DLL_RESETN 0.03137f
C3827 a_23633_7532# a_23763_7532# 0.70845f
C3828 a_4157_7003# a_4248_6734# 0.11672f
C3829 a_15964_5979# a_16851_5999# 0.16757f
C3830 a_15545_3889# a_13470_3889# 0.03208f
C3831 a_5731_3134# a_14513_1842# 0.01872f
C3832 a_7477_1842# a_7043_1842# 0.69698f
C3833 a_13368_1044# a_13470_1044# 0.37183f
C3834 a_9751_6698# VDD 0.2822f
C3835 a_25391_5315# VDD 0.01806f
C3836 a_14317_1842# VDD 0.87175f
C3837 a_22488_1044# VDD 0.1824f
C3838 a_21917_16869# a_22113_16869# 0.76914f
C3839 a_26477_16869# a_26471_16035# 0.02349f
C3840 a_27237_16869# a_25630_16071# 0.05253f
C3841 a_4187_2434# a_18313_14024# 0.11222f
C3842 a_12363_16869# a_12471_17497# 0.01697f
C3843 a_26477_14024# a_26043_14024# 0.6972f
C3844 a_12797_7532# a_12993_7532# 0.74917f
C3845 a_6126_9506# a_6854_11144# 0.22705f
C3846 a_4187_2434# a_16597_1842# 0.0414f
C3847 a_5957_7532# a_6425_6734# 0.2079f
C3848 a_19203_16869# VDD 0.49737f
C3849 a_17065_13226# VDD 0.30218f
C3850 a_2297_15358# VDD 0.47572f
C3851 a_10083_7532# VDD 0.49727f
C3852 a_2297_12513# CHAN1_MUX_SEL4 0.04338f
C3853 a_2873_12513# CHAN1_MUX_SEL3 0.12606f
C3854 a_3449_12513# CHAN1_MUX_SEL2 0.10741f
C3855 a_22590_6734# a_24084_6698# 0.28279f
C3856 a_23355_6734# a_23431_6698# 0.01194f
C3857 a_24523_4687# a_22590_3889# 0.01012f
C3858 a_15837_4687# a_15964_3134# 0.02f
C3859 a_19637_4687# a_19833_4687# 0.73897f
C3860 a_22590_3889# a_23945_3364# 0.02165f
C3861 a_24197_1842# a_24957_1842# 0.02912f
C3862 a_24957_1842# a_16108_289# 0.0157f
C3863 a_6425_1044# a_4350_1044# 0.03208f
C3864 a_16108_289# a_20905_519# 0.2906f
C3865 a_16923_4687# VDD 0.4982f
C3866 a_6425_1044# VDD 0.29742f
C3867 a_26471_3853# VDD 0.28357f
C3868 a_13470_3889# CHAN2_MUX_SEL4 0.256f
C3869 a_4187_2434# a_21483_16869# 0.06627f
C3870 a_12797_16869# a_13557_16869# 0.05851f
C3871 a_15837_16869# a_16484_16035# 0.02011f
C3872 a_5523_14024# a_5631_14652# 0.01697f
C3873 a_4187_2434# a_12363_7532# 0.06482f
C3874 a_20315_16071# a_20391_16035# 0.01194f
C3875 a_17357_14024# a_17553_14024# 0.76914f
C3876 a_19550_16071# a_21044_16035# 0.28279f
C3877 a_25630_13226# a_27915_13226# 0.39036f
C3878 a_4187_2434# a_19203_4687# 0.06627f
C3879 a_21917_7532# a_22488_6734# 0.10864f
C3880 a_6283_7532# a_6391_8160# 0.01697f
C3881 a_5191_16035# VDD 0.28637f
C3882 a_15511_14652# VDD 0.01806f
C3883 a_13121_11521# VDD 0.99842f
C3884 a_10517_4687# a_11277_4687# 0.01669f
C3885 a_16108_5979# a_18877_4687# 0.01307f
C3886 a_10430_6734# a_12715_6734# 0.39036f
C3887 a_16510_3889# a_18871_3853# 0.26208f
C3888 a_13470_1044# a_14825_519# 0.02058f
C3889 a_24665_3889# VDD 0.29742f
C3890 a_9431_2470# VDD 0.01806f
C3891 VDD CHAN1_DELAY_OUT_LAST 0.46919f
C3892 a_1256_289# CHAN3_MUX_SEL2 0.33134f
C3893 a_5957_16869# a_5844_16035# 0.02055f
C3894 a_7390_16071# a_9675_16071# 0.39036f
C3895 a_8237_14024# a_8997_14024# 0.03319f
C3896 a_26185_13226# a_26395_13226# 0.09424f
C3897 a_13470_13226# a_15831_13190# 0.26208f
C3898 a_14009_11568# a_13880_11982# 0.01562f
C3899 a_13592_11561# a_14111_11568# 0.34102f
C3900 a_13019_11521# a_15304_10295# 0.07025f
C3901 a_6326_10280# a_9712_9602# 0.04737f
C3902 a_20593_7532# a_21157_7532# 0.0114f
C3903 a_12797_7532# a_10430_6734# 0.02479f
C3904 a_26151_17497# VDD 0.01806f
C3905 a_14317_14024# VDD 0.87175f
C3906 a_22488_13226# VDD 0.1824f
C3907 a_27433_4687# a_27997_4687# 0.0114f
C3908 a_6153_1842# a_6717_1842# 0.0114f
C3909 a_5731_3134# a_12797_1842# 0.01307f
C3910 a_15077_1842# a_15545_1044# 0.2079f
C3911 a_9323_1842# a_7390_1044# 0.01012f
C3912 a_11848_1044# a_11924_1008# 0.01176f
C3913 a_21625_1044# a_21911_1008# 0.01885f
C3914 a_19311_5315# VDD 0.01806f
C3915 a_7288_6734# VDD 0.17274f
C3916 a_19550_1044# VDD 0.8993f
C3917 a_11603_1842# VDD 0.49753f
C3918 a_15765_3308# CHAN2_MUX_SEL4 0.65508f
C3919 a_4187_2434# a_16597_14024# 0.0414f
C3920 a_20593_16869# a_20723_16869# 0.70845f
C3921 a_10843_16869# a_10951_17497# 0.01697f
C3922 a_24957_16869# a_25604_16035# 0.02011f
C3923 a_25153_14024# a_25717_14024# 0.0114f
C3924 VDD CHAN3_MUX_SEL2 0.51095f
C3925 a_11473_7532# a_11603_7532# 0.70845f
C3926 a_4187_2434# a_13883_1842# 0.06627f
C3927 a_4437_7532# a_4157_7003# 0.01771f
C3928 a_17553_16869# VDD 0.49417f
C3929 a_6425_13226# VDD 0.2975f
C3930 a_26471_16035# VDD 0.28357f
C3931 a_8433_7532# VDD 0.49417f
C3932 a_18313_4687# a_18443_4687# 0.70845f
C3933 a_1256_3889# a_1544_3889# 1.26509f
C3934 a_23437_1842# a_23003_1842# 0.6972f
C3935 a_15273_4687# VDD 0.4946f
C3936 a_24008_3889# VDD 0.17499f
C3937 a_4187_2434# a_19833_16869# 0.11222f
C3938 a_12037_16869# a_11603_16869# 0.6972f
C3939 a_15077_16869# a_14964_16035# 0.02055f
C3940 a_4187_2434# a_10713_7532# 0.11222f
C3941 a_4003_14024# a_4111_14652# 0.01697f
C3942 a_16033_14024# a_16163_14024# 0.70845f
C3943 a_4187_2434# a_17553_4687# 0.11222f
C3944 a_4763_7532# a_4871_8160# 0.01697f
C3945 a_21917_7532# a_19550_6734# 0.02479f
C3946 a_24665_16071# VDD 0.29722f
C3947 a_9431_14652# VDD 0.01806f
C3948 a_11491_11918# VDD 0.16908f
C3949 a_16108_5979# a_16163_4687# 0.0155f
C3950 a_18585_6734# a_18871_6698# 0.01885f
C3951 a_9757_4687# a_9323_4687# 0.6972f
C3952 a_16408_3889# a_16510_3889# 0.37183f
C3953 a_26803_4687# a_26911_4687# 0.01163f
C3954 a_14317_1842# a_14513_1842# 0.76914f
C3955 a_16108_3134# a_25913_1842# 0.01865f
C3956 a_22488_1044# a_22564_1008# 0.01176f
C3957 a_18443_1842# a_16510_1044# 0.01012f
C3958 a_12505_3889# VDD 0.29876f
C3959 a_1256_5979# VDD 0.45613f
C3960 a_27563_1842# VDD 0.50391f
C3961 VDD CHAN0_DELAY_OUT_LAST 0.46312f
C3962 a_8997_16869# a_9465_16071# 0.2079f
C3963 a_15545_16071# a_13470_16071# 0.03208f
C3964 a_5197_16869# a_4350_16071# 0.08038f
C3965 a_7477_14024# a_7043_14024# 0.69698f
C3966 a_5731_15316# a_14513_14024# 0.01872f
C3967 a_13368_13226# a_13470_13226# 0.37183f
C3968 a_19637_7532# a_20397_7532# 0.01669f
C3969 a_12849_11557# a_12943_11557# 0.16706f
C3970 a_10517_7532# a_10404_6698# 0.05157f
C3971 a_20071_17497# VDD 0.01806f
C3972 a_19550_13226# VDD 0.8993f
C3973 a_11603_14024# VDD 0.49753f
C3974 a_13306_11995# REF_CLK 0.05059f
C3975 a_26477_7532# a_27048_6734# 0.10863f
C3976 a_26477_4687# a_27237_4687# 0.03319f
C3977 a_9465_3889# a_9675_3889# 0.09424f
C3978 a_4248_3889# a_4324_3853# 0.01176f
C3979 a_5197_1842# a_5957_1842# 0.03319f
C3980 a_5731_3134# a_10083_1842# 0.01539f
C3981 a_20105_1044# a_19550_1044# 0.03209f
C3982 a_10430_1044# a_10404_1008# 0.277f
C3983 a_4350_6734# VDD 0.87635f
C3984 a_13231_5315# VDD 0.01806f
C3985 a_16484_1008# VDD 0.28597f
C3986 a_9953_1842# VDD 0.49655f
C3987 a_1544_6734# REF_MUX_SEL4 0.02586f
C3988 a_2297_7085# REF_MUX_SEL0 0.10655f
C3989 a_1256_6734# REF_MUX_OUT 0.02466f
C3990 a_5731_3134# CHAN2_MUX_SEL4 4.60702f
C3991 a_9323_16869# a_9431_17497# 0.01697f
C3992 VDD CHAN2_MUX_SEL2 0.67328f
C3993 CHAN1_MUX_SEL3 CHAN1_MUX_OUT 0.79533f
C3994 a_4187_2434# a_13883_14024# 0.06627f
C3995 a_24197_16869# a_24084_16035# 0.02055f
C3996 a_24197_14024# a_24957_14024# 0.02912f
C3997 a_22590_16071# a_23945_15546# 0.02165f
C3998 a_16108_12471# a_20905_12701# 0.2906f
C3999 a_24957_14024# a_16108_12471# 0.0157f
C4000 a_6425_13226# a_4350_13226# 0.03208f
C4001 a_4187_2434# a_12233_1842# 0.11169f
C4002 a_24008_16071# VDD 0.17499f
C4003 a_15837_16869# VDD 0.87963f
C4004 a_6717_7532# VDD 0.87726f
C4005 a_14111_10917# REF_DELAY_OUT_LAST 0.02024f
C4006 a_17357_4687# a_17683_4687# 0.01427f
C4007 a_19550_6734# a_21911_6698# 0.26208f
C4008 a_22113_1842# a_22677_1842# 0.0114f
C4009 a_5731_289# a_14825_519# 0.28056f
C4010 a_27563_1842# a_25630_1044# 0.01024f
C4011 a_23111_8160# VDD 0.01806f
C4012 a_21044_3853# VDD 0.28225f
C4013 a_13557_4687# VDD 0.87034f
C4014 a_10713_16869# a_11277_16869# 0.0114f
C4015 a_4187_2434# a_18117_16869# 0.04152f
C4016 a_14317_16869# a_13470_16071# 0.08038f
C4017 a_16510_16071# a_18871_16035# 0.26208f
C4018 a_22677_16869# a_23145_16071# 0.19203f
C4019 a_4187_2434# a_8997_7532# 0.04152f
C4020 a_13470_13226# a_14825_12701# 0.02058f
C4021 a_14851_10872# a_15464_9374# 0.04797f
C4022 a_9444_10280# a_5778_9057# 0.19787f
C4023 a_4187_2434# a_15837_4687# 0.0414f
C4024 a_19637_7532# a_19524_6698# 0.05157f
C4025 a_12505_16071# VDD 0.29855f
C4026 a_27563_14024# VDD 0.50391f
C4027 a_17065_6734# a_16510_6734# 0.03209f
C4028 a_11277_4687# a_11848_3889# 0.10863f
C4029 a_25283_4687# a_25391_4687# 0.01163f
C4030 a_8433_4687# a_8997_4687# 0.0114f
C4031 a_14888_3889# a_14964_3853# 0.01176f
C4032 a_12993_1842# a_13123_1842# 0.70361f
C4033 a_16108_3134# a_24197_1842# 0.01319f
C4034 a_10430_1044# a_5731_289# 0.41176f
C4035 a_25630_6734# VDD 0.90165f
C4036 a_3449_4240# VDD 0.46731f
C4037 a_25913_1842# VDD 0.49553f
C4038 a_27997_16869# a_27563_16869# 0.69646f
C4039 a_9323_14024# a_7390_13226# 0.01012f
C4040 a_5731_15316# a_12797_14024# 0.01307f
C4041 a_15077_14024# a_15545_13226# 0.2079f
C4042 a_6153_14024# a_6717_14024# 0.0114f
C4043 a_13019_11521# a_13045_11905# 0.01249f
C4044 a_11848_13226# a_11924_13190# 0.01176f
C4045 a_13121_11521# a_13306_11995# 0.01008f
C4046 a_21625_13226# a_21911_13190# 0.01885f
C4047 a_18877_7532# a_18443_7532# 0.6972f
C4048 a_9953_14024# VDD 0.49655f
C4049 a_13991_17497# VDD 0.01806f
C4050 a_16484_13190# VDD 0.28597f
C4051 a_22677_7532# VDD 0.91482f
C4052 a_4003_16869# CHAN0_DELAY_IN 0.54998f
C4053 a_25717_4687# a_25283_4687# 0.69698f
C4054 a_25630_6734# a_26985_6209# 0.02195f
C4055 a_4437_1842# a_4003_1842# 0.69698f
C4056 a_5731_3134# a_8433_1842# 0.01872f
C4057 a_17065_1044# a_17351_1008# 0.01885f
C4058 a_20105_6734# VDD 0.30409f
C4059 a_8237_1842# VDD 0.87175f
C4060 a_7151_5315# VDD 0.01806f
C4061 a_14235_1044# VDD 0.1539f
C4062 a_2297_3176# CHAN2_MUX_SEL4 0.04338f
C4063 a_3449_3176# CHAN2_MUX_SEL2 0.10741f
C4064 a_2873_3176# CHAN2_MUX_SEL3 0.12606f
C4065 a_18877_16869# a_19073_16869# 0.76914f
C4066 a_7803_16869# a_7911_17497# 0.01697f
C4067 VDD REF_MUX_SEL2 0.67328f
C4068 a_4187_2434# a_12233_14024# 0.11169f
C4069 a_1256_16071# a_1544_16071# 1.26509f
C4070 a_23437_16869# a_22590_16071# 0.08038f
C4071 a_23437_14024# a_23003_14024# 0.6972f
C4072 a_9757_7532# a_9953_7532# 0.76914f
C4073 a_4187_2434# a_10517_1842# 0.0414f
C4074 a_13123_16869# VDD 0.48169f
C4075 a_21044_16035# VDD 0.28225f
C4076 a_4003_7532# VDD 0.61559f
C4077 a_19448_6734# a_19550_6734# 0.37183f
C4078 a_16597_4687# a_16793_4687# 0.73897f
C4079 a_25528_3889# a_25604_3853# 0.01176f
C4080 a_20397_4687# a_20968_3889# 0.10863f
C4081 a_18877_1842# a_16108_289# 0.0157f
C4082 a_21157_1842# a_21917_1842# 0.02912f
C4083 a_10843_4687# VDD 0.50064f
C4084 a_17031_8160# VDD 0.01806f
C4085 a_18795_3889# VDD 0.15407f
C4086 a_9757_16869# a_10517_16869# 0.06198f
C4087 a_4187_2434# a_15403_16869# 0.06627f
C4088 a_12797_16869# a_12791_16035# 0.02354f
C4089 a_16408_16071# a_16510_16071# 0.37183f
C4090 a_4187_2434# a_6283_7532# 0.06627f
C4091 a_14317_14024# a_14513_14024# 0.76914f
C4092 a_16108_15316# a_25913_14024# 0.01865f
C4093 a_18443_14024# a_16510_13226# 0.01012f
C4094 a_22488_13226# a_22564_13190# 0.01176f
C4095 a_14009_10774# a_13880_10808# 0.01562f
C4096 a_4187_2434# a_13123_4687# 0.0643f
C4097 a_3449_16422# VDD 0.46731f
C4098 a_25913_14024# VDD 0.49553f
C4099 a_6854_11676# VDD 1.32146f
C4100 a_1544_15316# CHAN0_MUX_SEL3 0.15976f
C4101 a_1256_15316# CHAN0_MUX_SEL4 0.65005f
C4102 a_1721_15358# CHAN0_MUX_SEL2 0.01315f
C4103 a_7288_6734# a_7364_6698# 0.01176f
C4104 a_14025_6734# a_14311_6698# 0.01885f
C4105 a_5731_5979# a_14643_4687# 0.01544f
C4106 a_23763_4687# a_23871_4687# 0.01163f
C4107 a_7477_4687# a_8237_4687# 0.01669f
C4108 a_16108_3134# a_21483_1842# 0.01542f
C4109 a_24665_3889# a_24875_3889# 0.09424f
C4110 a_13470_3889# a_13444_3853# 0.277f
C4111 a_19550_1044# a_20315_1044# 0.39037f
C4112 a_7390_1044# a_8745_519# 0.01756f
C4113 a_22564_6698# VDD 0.28964f
C4114 a_24197_1842# VDD 0.85957f
C4115 a_16108_289# VDD 1.25511f
C4116 a_26673_16869# a_27237_16869# 0.0114f
C4117 a_5197_14024# a_5957_14024# 0.03319f
C4118 a_9465_16071# a_9675_16071# 0.09424f
C4119 a_4248_16071# a_4324_16035# 0.01176f
C4120 a_5731_15316# a_10083_14024# 0.01539f
C4121 a_10430_13226# a_10404_13190# 0.277f
C4122 a_20105_13226# a_19550_13226# 0.03209f
C4123 a_17553_7532# a_18117_7532# 0.0114f
C4124 CHAN3_MUX_SEL1 CHAN3_MUX_OUT 0.09357f
C4125 CHAN3_MUX_SEL2 CHAN3_MUX_SEL4 0.01978f
C4126 a_4187_2434# a_26477_1842# 0.04144f
C4127 a_8237_7532# a_8231_6698# 0.02349f
C4128 a_8997_7532# a_7390_6734# 0.05231f
C4129 a_8237_14024# VDD 0.87181f
C4130 a_7911_17497# VDD 0.01806f
C4131 a_14235_13226# VDD 0.1539f
C4132 a_19963_7532# VDD 0.4973f
C4133 a_4350_16071# CHAN0_MUX_SEL4 0.31434f
C4134 a_10649_11568# DLL_RESETN 0.05713f
C4135 a_10232_11561# REF_CLK 0.08086f
C4136 a_12797_7532# REF_MUX_SEL4 0.01829f
C4137 a_24393_4687# a_24957_4687# 0.0114f
C4138 a_5731_3134# a_6717_1842# 0.01307f
C4139 a_16108_3134# a_26985_3364# 0.27952f
C4140 a_4905_3889# a_5191_3853# 0.01885f
C4141 a_5197_1842# a_5768_1044# 0.10863f
C4142 a_7390_1044# a_8231_1008# 0.28268f
C4143 a_7945_6734# VDD 0.30409f
C4144 a_26803_4687# VDD 0.49718f
C4145 a_5523_1842# VDD 0.49684f
C4146 a_11271_1008# VDD 0.28336f
C4147 a_4157_1313# CHAN3_DELAY_IN 0.50642f
C4148 a_21917_16869# a_21911_16035# 0.02354f
C4149 a_6283_16869# a_6391_17497# 0.01697f
C4150 a_4187_2434# a_10517_14024# 0.0414f
C4151 a_17553_16869# a_17683_16869# 0.70845f
C4152 CHAN0_MUX_SEL2 CHAN1_DELAY_IN 0.2107f
C4153 CHAN0_MUX_SEL3 CHAN0_MUX_OUT 0.79533f
C4154 a_4187_2434# a_22243_7532# 0.06322f
C4155 a_27563_14024# a_25630_13226# 0.01024f
C4156 a_22113_14024# a_22677_14024# 0.0114f
C4157 a_8433_7532# a_8563_7532# 0.70845f
C4158 a_5731_12471# a_14825_12701# 0.28056f
C4159 a_4187_2434# a_7803_1842# 0.06627f
C4160 a_22677_7532# a_23437_7532# 0.01323f
C4161 a_21917_7532# a_16108_5979# 0.01053f
C4162 a_11473_16869# VDD 0.49426f
C4163 a_18795_16071# VDD 0.15406f
C4164 a_17928_6734# a_18004_6698# 0.01176f
C4165 a_15273_4687# a_15403_4687# 0.70845f
C4166 a_20397_1842# a_19963_1842# 0.6972f
C4167 a_25630_1044# a_16108_289# 0.52614f
C4168 a_9193_4687# VDD 0.4946f
C4169 a_10951_8160# VDD 0.01806f
C4170 a_15831_3853# VDD 0.2816f
C4171 a_11277_16869# a_11924_16035# 0.02312f
C4172 a_4187_2434# a_13753_16869# 0.11222f
C4173 a_8997_16869# a_8563_16869# 0.6972f
C4174 a_4187_2434# a_4633_7532# 0.11222f
C4175 a_14888_16071# a_14964_16035# 0.01176f
C4176 a_12993_14024# a_13123_14024# 0.70361f
C4177 a_16108_15316# a_24197_14024# 0.01319f
C4178 a_10430_13226# a_5731_12471# 0.41176f
C4179 a_14009_10774# a_14111_10917# 0.47622f
C4180 REF_CLK REF_MUX_SEL4 0.0663f
C4181 a_4187_2434# a_11473_4687# 0.11222f
C4182 a_18117_7532# a_16510_6734# 0.05231f
C4183 a_17357_7532# a_17351_6698# 0.02349f
C4184 a_24197_14024# VDD 0.85958f
C4185 a_16108_12471# VDD 1.25511f
C4186 a_27997_7532# a_27563_7532# 0.69646f
C4187 a_6717_4687# a_6283_4687# 0.6972f
C4188 a_5731_5979# a_12993_4687# 0.01688f
C4189 a_22243_4687# a_22351_4687# 0.01163f
C4190 a_16108_3134# a_19833_1842# 0.01865f
C4191 a_11277_1842# a_11473_1842# 0.76914f
C4192 a_14317_1842# a_14888_1044# 0.10863f
C4193 a_20315_6734# VDD 0.15389f
C4194 a_21483_1842# VDD 0.50072f
C4195 a_4187_2434# a_26477_14024# 0.04144f
C4196 a_25717_16869# a_26477_16869# 0.01669f
C4197 a_4437_14024# a_4003_14024# 0.69698f
C4198 a_4187_2434# a_6126_9506# 0.01821f
C4199 a_5731_15316# a_8433_14024# 0.01872f
C4200 a_17065_13226# a_17351_13190# 0.01885f
C4201 a_16597_7532# a_17357_7532# 0.01669f
C4202 a_11491_11918# a_11397_11918# 0.28931f
C4203 CHAN3_DELAY_IN CHAN3_MUX_SEL0 0.11907f
C4204 a_4187_2434# a_23763_1842# 0.06627f
C4205 a_6717_7532# a_7364_6698# 0.02011f
C4206 a_27433_16869# VDD 0.49285f
C4207 a_5523_14024# VDD 0.49684f
C4208 a_11271_13190# VDD 0.28336f
C4209 a_18313_7532# VDD 0.49285f
C4210 a_1544_6734# a_1721_7085# 0.38063f
C4211 a_1256_5979# a_1721_6021# 0.13421f
C4212 a_23437_4687# a_24197_4687# 0.03319f
C4213 a_15765_3308# a_15964_3134# 0.061f
C4214 a_6635_1044# a_6711_1008# 0.01194f
C4215 a_2873_7085# VDD 0.46517f
C4216 a_25153_4687# VDD 0.49655f
C4217 a_8808_1044# VDD 0.17499f
C4218 a_26985_3364# VDD 0.29292f
C4219 a_1721_1395# CHAN3_MUX_SEL0 0.01315f
C4220 a_1544_1044# CHAN3_MUX_SEL1 0.1672f
C4221 a_20397_16869# a_21044_16035# 0.02312f
C4222 a_4763_16869# a_4871_17497# 0.01697f
C4223 a_4187_2434# a_7803_14024# 0.06627f
C4224 a_21157_14024# a_21917_14024# 0.02912f
C4225 a_4187_2434# a_20593_7532# 0.11287f
C4226 a_25528_16071# a_25604_16035# 0.01176f
C4227 a_18877_14024# a_16108_12471# 0.0157f
C4228 a_4187_2434# a_27433_4687# 0.11222f
C4229 a_4187_2434# a_6153_1842# 0.11222f
C4230 a_9757_16869# VDD 0.87771f
C4231 a_15831_16035# VDD 0.2816f
C4232 a_9444_10280# VDD 0.01557f
C4233 a_16510_6734# a_16484_6698# 0.277f
C4234 a_14317_4687# a_14643_4687# 0.01427f
C4235 a_16108_5979# a_26043_4687# 0.01539f
C4236 a_19073_1842# a_19637_1842# 0.0114f
C4237 a_22590_3889# a_23355_3889# 0.39037f
C4238 a_1544_1044# a_2297_1395# 0.28651f
C4239 a_23437_1842# a_24008_1044# 0.10863f
C4240 a_4871_8160# VDD 0.01806f
C4241 a_7477_4687# VDD 0.871f
C4242 a_13368_3889# VDD 0.17274f
C4243 a_4187_2434# a_12037_16869# 0.04152f
C4244 a_7673_16869# a_8237_16869# 0.0114f
C4245 a_13470_16071# a_13444_16035# 0.277f
C4246 a_24665_16071# a_24875_16071# 0.09424f
C4247 a_10517_16869# a_10430_16071# 0.1088f
C4248 a_16108_15316# a_21483_14024# 0.01542f
C4249 a_19550_13226# a_20315_13226# 0.39037f
C4250 a_7390_13226# a_8745_12701# 0.01756f
C4251 a_4187_2434# a_9757_4687# 0.0414f
C4252 a_15837_7532# a_16484_6698# 0.02011f
C4253 a_21483_14024# VDD 0.50072f
C4254 a_5778_9057# DLL_RESETN 0.01215f
C4255 a_26673_7532# a_27237_7532# 0.0114f
C4256 a_4350_6734# a_5115_6734# 0.39037f
C4257 a_5731_5979# a_11277_4687# 0.01319f
C4258 a_5393_4687# a_5957_4687# 0.0114f
C4259 a_7803_4687# a_7390_3889# 0.01012f
C4260 a_10430_3889# a_11271_3853# 0.28268f
C4261 a_26803_4687# a_26911_5315# 0.01697f
C4262 a_20723_4687# a_20831_4687# 0.01163f
C4263 a_20105_3889# a_20315_3889# 0.09424f
C4264 a_16108_3134# a_18117_1842# 0.01644f
C4265 a_9953_1842# a_10083_1842# 0.70845f
C4266 a_16510_1044# a_17928_1044# 0.38994f
C4267 a_17351_6698# VDD 0.28637f
C4268 a_3449_331# VDD 0.46596f
C4269 a_19833_1842# VDD 0.49553f
C4270 a_4187_2434# a_23763_14024# 0.06627f
C4271 a_24957_16869# a_24523_16869# 0.6972f
C4272 a_4905_16071# a_5191_16035# 0.01885f
C4273 a_5731_15316# a_6717_14024# 0.01307f
C4274 a_16108_15316# a_26985_15546# 0.27952f
C4275 a_5197_14024# a_5768_13226# 0.10863f
C4276 a_7390_13226# a_8231_13190# 0.28268f
C4277 a_15837_7532# a_15403_7532# 0.6972f
C4278 a_10232_11561# a_11491_11918# 0.01529f
C4279 CHAN2_MUX_SEL2 CHAN2_MUX_SEL4 0.01978f
C4280 CHAN2_MUX_SEL1 CHAN2_MUX_OUT 0.09357f
C4281 a_4187_2434# a_22113_1842# 0.11169f
C4282 a_5957_7532# a_5844_6698# 0.02055f
C4283 a_25717_16869# VDD 0.86712f
C4284 a_8808_13226# VDD 0.17499f
C4285 a_26985_15546# VDD 0.29292f
C4286 a_16597_7532# VDD 0.86886f
C4287 a_22677_4687# a_22243_4687# 0.69698f
C4288 a_5731_3134# a_15964_3134# 0.2778f
C4289 a_27237_1842# a_27433_1842# 0.77122f
C4290 a_4350_1044# a_5844_1008# 0.28279f
C4291 a_5115_1044# a_5191_1008# 0.01194f
C4292 a_12505_1044# a_10430_1044# 0.03208f
C4293 a_1256_6734# VDD 0.50942f
C4294 a_23437_4687# VDD 0.87123f
C4295 a_5844_1008# VDD 0.28225f
C4296 a_14825_3364# VDD 0.29292f
C4297 a_4187_2434# a_27997_16869# 0.04001f
C4298 a_15837_16869# a_16033_16869# 0.76914f
C4299 a_4187_2434# a_6153_14024# 0.11222f
C4300 a_19637_16869# a_19550_16071# 0.1088f
C4301 a_4187_2434# a_18877_7532# 0.04176f
C4302 a_20397_14024# a_19963_14024# 0.6972f
C4303 a_25630_13226# a_16108_12471# 0.52614f
C4304 a_6717_7532# a_6913_7532# 0.76914f
C4305 a_4187_2434# a_25717_4687# 0.0414f
C4306 a_4187_2434# a_4437_1842# 0.0414f
C4307 a_13368_16071# VDD 0.17274f
C4308 a_7043_16869# VDD 0.49723f
C4309 a_12907_11110# VDD 0.07753f
C4310 a_22873_7532# a_23003_7532# 0.70361f
C4311 a_13557_4687# a_13753_4687# 0.73897f
C4312 a_16108_5979# a_24393_4687# 0.01872f
C4313 a_16923_4687# a_16510_3889# 0.01012f
C4314 a_18117_1842# a_18877_1842# 0.02912f
C4315 a_27915_1044# a_27991_1008# 0.01194f
C4316 a_26043_7532# VDD 0.4973f
C4317 a_4763_4687# VDD 0.49875f
C4318 a_10430_3889# VDD 1.08486f
C4319 a_26911_2470# VDD 0.01806f
C4320 a_1544_5979# REF_MUX_SEL3 0.15976f
C4321 a_1256_5979# REF_MUX_SEL4 0.65005f
C4322 a_1721_6021# REF_MUX_SEL2 0.01315f
C4323 a_15964_289# CHAN3_MUX_OUT 0.01307f
C4324 a_16108_289# CHAN3_MUX_SEL4 0.1283f
C4325 a_4187_2434# a_9323_16869# 0.06627f
C4326 a_6717_16869# a_7477_16869# 0.06198f
C4327 a_16108_15316# a_19833_14024# 0.01865f
C4328 a_11277_14024# a_11473_14024# 0.76914f
C4329 a_14317_14024# a_14888_13226# 0.10863f
C4330 a_4187_2434# a_7043_4687# 0.06627f
C4331 a_15077_7532# a_14964_6698# 0.02055f
C4332 a_3449_12513# VDD 0.46689f
C4333 a_19833_14024# VDD 0.49553f
C4334 a_25717_7532# a_26477_7532# 0.01669f
C4335 a_9465_6734# a_7390_6734# 0.03208f
C4336 a_12037_4687# a_12505_3889# 0.2079f
C4337 a_25283_4687# a_25391_5315# 0.01697f
C4338 a_19203_4687# a_19311_4687# 0.01163f
C4339 a_4437_4687# a_5197_4687# 0.01669f
C4340 a_6717_4687# a_7288_3889# 0.10864f
C4341 a_5731_5979# a_8563_4687# 0.01544f
C4342 a_9675_3889# a_9751_3853# 0.01194f
C4343 a_14888_6734# VDD 0.17499f
C4344 a_18117_1842# VDD 0.85955f
C4345 a_27124_1008# VDD 0.28225f
C4346 a_4350_6734# REF_MUX_SEL4 0.31434f
C4347 a_23633_16869# a_24197_16869# 0.0114f
C4348 a_4187_2434# a_22113_14024# 0.11169f
C4349 a_15765_15490# a_15964_15316# 0.061f
C4350 a_6635_13226# a_6711_13190# 0.01194f
C4351 a_9946_11995# a_10649_11568# 0.02432f
C4352 a_14513_7532# a_15077_7532# 0.0114f
C4353 CHAN2_DELAY_IN CHAN2_MUX_SEL0 0.11907f
C4354 a_5197_7532# a_4350_6734# 0.08038f
C4355 a_8997_7532# a_9465_6734# 0.2079f
C4356 a_4187_2434# a_20397_1842# 0.0414f
C4357 a_14825_15546# VDD 0.29292f
C4358 a_23003_16869# VDD 0.48123f
C4359 a_5844_13190# VDD 0.28225f
C4360 a_13883_7532# VDD 0.49744f
C4361 a_3449_16422# CHAN0_MUX_SEL1 0.29404f
C4362 a_14825_12701# CHAN1_MUX_SEL4 0.03307f
C4363 a_6717_7532# REF_MUX_SEL4 0.0195f
C4364 a_25630_6734# a_26395_6734# 0.39037f
C4365 a_21353_4687# a_21917_4687# 0.0114f
C4366 a_16510_6734# a_16108_5979# 0.56108f
C4367 a_5731_3134# a_8745_3364# 0.28635f
C4368 a_26043_4687# a_25630_3889# 0.01012f
C4369 a_25913_1842# a_26043_1842# 0.70845f
C4370 a_20723_4687# VDD 0.49691f
C4371 a_27705_1044# VDD 0.29918f
C4372 a_4187_2434# a_25283_16869# 0.06627f
C4373 a_14513_16869# a_14643_16869# 0.70845f
C4374 a_4187_2434# a_4437_14024# 0.0414f
C4375 a_22590_16071# a_23355_16071# 0.39037f
C4376 a_23437_14024# a_24008_13226# 0.10863f
C4377 a_4187_2434# a_16163_7532# 0.06661f
C4378 a_19073_14024# a_19637_14024# 0.0114f
C4379 a_1544_13226# a_2297_13577# 0.28651f
C4380 a_5393_7532# a_5523_7532# 0.70845f
C4381 a_4187_2434# a_23003_4687# 0.06391f
C4382 a_5393_16869# VDD 0.49417f
C4383 a_10430_16071# VDD 1.08486f
C4384 a_15688_11557# VDD 0.30345f
C4385 a_26911_14652# VDD 0.01806f
C4386 a_10430_13226# CHAN1_MUX_SEL4 0.21179f
C4387 a_13470_6734# a_14311_6698# 0.28268f
C4388 a_15837_4687# a_16408_3889# 0.10864f
C4389 a_25717_4687# a_26185_3889# 0.19203f
C4390 a_12233_4687# a_12363_4687# 0.70361f
C4391 a_19550_3889# a_20968_3889# 0.38994f
C4392 a_17357_1842# a_16923_1842# 0.6972f
C4393 a_26395_1044# a_26471_1008# 0.01194f
C4394 a_25630_1044# a_27124_1008# 0.28279f
C4395 a_17865_6209# VDD 0.29444f
C4396 a_24393_7532# VDD 0.49285f
C4397 a_7364_3853# VDD 0.28633f
C4398 a_20831_2470# VDD 0.01806f
C4399 a_5957_16869# a_5523_16869# 0.6972f
C4400 a_4187_2434# a_7673_16869# 0.11222f
C4401 a_20105_16071# a_20315_16071# 0.09424f
C4402 a_10430_16071# a_11271_16035# 0.28268f
C4403 a_16108_15316# a_18117_14024# 0.01644f
C4404 a_9953_14024# a_10083_14024# 0.70845f
C4405 a_14851_11918# a_15304_10295# 0.12139f
C4406 a_13121_11521# a_14851_10872# 0.03337f
C4407 a_16510_13226# a_17928_13226# 0.38994f
C4408 a_4187_2434# a_26673_7532# 0.11284f
C4409 a_4187_2434# a_5393_4687# 0.11222f
C4410 a_14317_7532# a_13470_6734# 0.08038f
C4411 a_22677_7532# a_23145_6734# 0.19203f
C4412 a_18117_14024# VDD 0.85955f
C4413 a_27124_13190# VDD 0.28225f
C4414 a_13566_11018# REF_CLK 0.01093f
C4415 a_24957_7532# a_24523_7532# 0.6972f
C4416 a_17683_4687# a_17791_4687# 0.01163f
C4417 a_6717_4687# a_4350_3889# 0.02479f
C4418 a_23763_4687# a_23871_5315# 0.01697f
C4419 a_5731_5979# a_6913_4687# 0.01872f
C4420 a_8237_1842# a_8433_1842# 0.76914f
C4421 a_8155_3889# a_8231_3853# 0.01194f
C4422 a_7390_3889# a_8884_3853# 0.28279f
C4423 a_15545_3889# a_15831_3853# 0.01885f
C4424 a_10843_1842# a_10430_1044# 0.01012f
C4425 a_13470_1044# a_15755_1044# 0.39036f
C4426 a_27705_1044# a_25630_1044# 0.03208f
C4427 a_11924_6698# VDD 0.28225f
C4428 a_15403_1842# VDD 0.4973f
C4429 a_24875_1044# VDD 0.15407f
C4430 a_22677_16869# a_23437_16869# 0.01323f
C4431 a_4187_2434# a_20397_14024# 0.0414f
C4432 a_5731_15316# a_15964_15316# 0.2778f
C4433 a_4350_13226# a_5844_13190# 0.28279f
C4434 a_12505_13226# a_10430_13226# 0.03208f
C4435 a_27237_14024# a_27433_14024# 0.77122f
C4436 a_5115_13226# a_5191_13190# 0.01194f
C4437 a_13557_7532# a_14317_7532# 0.01669f
C4438 REF_MUX_SEL1 REF_MUX_OUT 0.09357f
C4439 REF_MUX_SEL2 REF_MUX_SEL4 0.01978f
C4440 a_4187_2434# a_17683_1842# 0.06627f
C4441 a_21353_16869# VDD 0.49294f
C4442 a_12233_7532# VDD 0.59709f
C4443 a_27705_13226# VDD 0.29918f
C4444 a_1256_16071# CHAN0_MUX_SEL4 0.03691f
C4445 a_20397_4687# a_21157_4687# 0.03319f
C4446 a_24957_4687# a_25528_3889# 0.10864f
C4447 a_6425_1044# a_6711_1008# 0.01885f
C4448 a_24957_1842# a_25283_1842# 0.01427f
C4449 a_19073_4687# VDD 0.49655f
C4450 a_1721_3176# VDD 0.45365f
C4451 a_15545_1044# VDD 0.29918f
C4452 a_4187_2434# a_23633_16869# 0.11222f
C4453 a_4187_2434# a_14513_7532# 0.12091f
C4454 a_18117_14024# a_18877_14024# 0.02912f
C4455 a_27915_13226# a_27991_13190# 0.01194f
C4456 a_4187_2434# a_5731_3134# 0.14779f
C4457 a_4187_2434# a_21353_4687# 0.11222f
C4458 a_7364_16035# VDD 0.28633f
C4459 a_20831_14652# VDD 0.01806f
C4460 a_14009_11568# VDD 0.25384f
C4461 a_4763_14024# CHAN0_MUX_SEL4 0.01225f
C4462 a_24665_6734# a_22590_6734# 0.03208f
C4463 a_12715_6734# a_12791_6698# 0.01194f
C4464 a_11277_4687# a_11603_4687# 0.01427f
C4465 a_16108_5979# a_19963_4687# 0.01539f
C4466 a_15837_4687# a_13470_3889# 0.02479f
C4467 a_16033_1842# a_16597_1842# 0.0114f
C4468 a_19963_1842# a_19550_1044# 0.01012f
C4469 a_5115_3889# VDD 0.15389f
C4470 a_14751_2470# VDD 0.01806f
C4471 a_3449_331# CHAN3_MUX_SEL4 0.05166f
C4472 VDD DLL_RESETN 2.6785f
C4473 a_4187_2434# a_5957_16869# 0.04152f
C4474 a_4633_16869# a_5197_16869# 0.0114f
C4475 a_9675_16071# a_9751_16035# 0.01194f
C4476 a_14111_11568# a_15108_11799# 0.03093f
C4477 a_12849_11557# a_13132_11110# 0.06758f
C4478 a_21353_7532# a_21483_7532# 0.70845f
C4479 a_4187_2434# a_24957_7532# 0.04176f
C4480 a_12797_7532# a_12791_6698# 0.02354f
C4481 a_15403_14024# VDD 0.4973f
C4482 a_24875_13226# VDD 0.15407f
C4483 a_23633_7532# a_24197_7532# 0.0114f
C4484 a_15964_5979# a_16108_5979# 0.42202f
C4485 a_4437_4687# a_4324_3853# 0.05157f
C4486 a_22243_4687# a_22351_5315# 0.01697f
C4487 a_16163_4687# a_16271_4687# 0.01163f
C4488 a_14025_3889# a_13470_3889# 0.03209f
C4489 a_5731_3134# a_13883_1842# 0.01539f
C4490 a_6913_1842# a_7043_1842# 0.70845f
C4491 a_16597_1842# a_17065_1044# 0.19203f
C4492 a_9757_1842# a_10328_1044# 0.10864f
C4493 a_24631_5315# VDD 0.01806f
C4494 a_9675_6734# VDD 0.15406f
C4495 a_13753_1842# VDD 0.49559f
C4496 a_21911_1008# VDD 0.2822f
C4497 a_21917_16869# a_21483_16869# 0.6972f
C4498 a_4187_2434# a_17683_14024# 0.06627f
C4499 a_5731_15316# a_8745_15546# 0.28635f
C4500 a_25913_14024# a_26043_14024# 0.70845f
C4501 a_6854_11676# a_6854_11144# 0.30877f
C4502 a_12797_7532# a_12363_7532# 0.6972f
C4503 a_4187_2434# a_16033_1842# 0.11222f
C4504 a_19637_16869# VDD 0.86712f
C4505 a_1721_15358# VDD 0.45365f
C4506 a_15545_13226# VDD 0.29918f
C4507 a_10517_7532# VDD 0.86712f
C4508 a_1721_12513# CHAN1_MUX_SEL4 0.05813f
C4509 a_1544_12471# CHAN1_MUX_OUT 0.69943f
C4510 a_2297_12513# CHAN1_MUX_SEL3 0.01595f
C4511 a_2873_12513# CHAN1_MUX_SEL2 0.01422f
C4512 a_22590_6734# a_24008_6734# 0.38994f
C4513 a_19637_4687# a_19203_4687# 0.69698f
C4514 a_24957_4687# a_22590_3889# 0.02479f
C4515 a_1256_3889# a_2873_4240# 0.28892f
C4516 a_24197_1842# a_24393_1842# 0.77122f
C4517 a_4157_1313# a_4324_1008# 0.02463f
C4518 a_4905_1044# a_4350_1044# 0.03209f
C4519 a_16108_289# a_17865_519# 0.29564f
C4520 a_17357_4687# VDD 0.87016f
C4521 a_4905_1044# VDD 0.30126f
C4522 a_26395_3889# VDD 0.1539f
C4523 a_12797_16869# a_12993_16869# 0.74917f
C4524 a_4187_2434# a_5731_15316# 0.14779f
C4525 a_4187_2434# a_21917_16869# 0.0414f
C4526 a_19550_16071# a_20968_16071# 0.38994f
C4527 a_4187_2434# a_12797_7532# 0.0414f
C4528 a_17357_14024# a_16923_14024# 0.6972f
C4529 a_25630_13226# a_27124_13190# 0.28279f
C4530 a_26395_13226# a_26471_13190# 0.01194f
C4531 a_9444_9602# a_5864_9057# 0.02483f
C4532 a_4187_2434# a_19637_4687# 0.0414f
C4533 a_21917_7532# a_21911_6698# 0.02354f
C4534 a_5115_16071# VDD 0.15389f
C4535 a_14751_14652# VDD 0.01806f
C4536 a_13019_11521# VDD 0.42149f
C4537 a_16851_15336# CHAN0_MUX_OUT 0.45865f
C4538 a_10517_4687# a_10713_4687# 0.73897f
C4539 a_16108_5979# a_18313_4687# 0.02026f
C4540 a_10430_6734# a_11924_6698# 0.28279f
C4541 a_11195_6734# a_11271_6698# 0.01194f
C4542 a_13557_4687# a_13444_3853# 0.05157f
C4543 a_15077_1842# a_15837_1842# 0.02912f
C4544 a_16510_3889# a_18795_3889# 0.39036f
C4545 a_22590_1044# a_24951_1008# 0.26208f
C4546 a_18877_1842# a_19448_1044# 0.10864f
C4547 a_23145_3889# VDD 0.30411f
C4548 a_8671_2470# VDD 0.01806f
C4549 VDD CHAN1_DELAY_IN 1.50352f
C4550 a_10517_16869# a_10985_16071# 0.19203f
C4551 a_15545_16071# a_15831_16035# 0.01885f
C4552 a_7390_16071# a_8884_16035# 0.28279f
C4553 a_8155_16071# a_8231_16035# 0.01194f
C4554 a_6283_16869# a_4350_16071# 0.01012f
C4555 a_8237_14024# a_8433_14024# 0.76914f
C4556 a_10843_14024# a_10430_13226# 0.01012f
C4557 a_13470_13226# a_15755_13226# 0.39036f
C4558 a_27705_13226# a_25630_13226# 0.03208f
C4559 a_13592_11561# a_13880_11982# 0.43707f
C4560 a_20397_7532# a_20723_7532# 0.01427f
C4561 a_5974_11413# a_5778_9057# 2.88221f
C4562 a_11277_7532# a_11924_6698# 0.02312f
C4563 a_25391_17497# VDD 0.01806f
C4564 a_21911_13190# VDD 0.2822f
C4565 a_13753_14024# VDD 0.49559f
C4566 a_4187_2434# REF_CLK 2.0411f
C4567 a_10985_3889# a_11271_3853# 0.01885f
C4568 a_14643_4687# a_14751_4687# 0.01163f
C4569 a_4350_3889# a_6711_3853# 0.26208f
C4570 a_20723_4687# a_20831_5315# 0.01697f
C4571 a_5731_3134# a_12233_1842# 0.01121f
C4572 a_9757_1842# a_7390_1044# 0.02479f
C4573 a_21625_1044# a_21835_1044# 0.09424f
C4574 a_6711_6698# VDD 0.2822f
C4575 a_18551_5315# VDD 0.01806f
C4576 a_19448_1044# VDD 0.17274f
C4577 a_12037_1842# VDD 0.86131f
C4578 a_3449_7085# REF_MUX_SEL1 0.29404f
C4579 a_14825_3364# CHAN2_MUX_SEL4 0.03307f
C4580 a_20593_16869# a_21157_16869# 0.0114f
C4581 a_4187_2434# a_16033_14024# 0.11222f
C4582 a_24957_14024# a_25283_14024# 0.01427f
C4583 VDD CHAN3_MUX_SEL1 0.50228f
C4584 a_6425_13226# a_6711_13190# 0.01885f
C4585 a_11473_7532# a_12037_7532# 0.0114f
C4586 a_4187_2434# a_14317_1842# 0.0414f
C4587 a_16923_16869# VDD 0.4973f
C4588 a_26395_16071# VDD 0.15389f
C4589 a_4905_13226# VDD 0.3013f
C4590 a_7803_7532# VDD 0.4973f
C4591 a_18313_4687# a_18877_4687# 0.0114f
C4592 a_22677_4687# a_22564_3853# 0.05157f
C4593 a_22873_1842# a_23003_1842# 0.70361f
C4594 a_14643_4687# VDD 0.49684f
C4595 a_2297_1395# VDD 0.47647f
C4596 a_23431_3853# VDD 0.28357f
C4597 a_10430_3889# CHAN2_MUX_SEL4 0.21179f
C4598 a_11473_16869# a_11603_16869# 0.70845f
C4599 a_4187_2434# a_19203_16869# 0.06627f
C4600 a_15403_16869# a_13470_16071# 0.01012f
C4601 a_24197_16869# a_24665_16071# 0.2079f
C4602 a_4187_2434# a_10083_7532# 0.06627f
C4603 a_16033_14024# a_16597_14024# 0.0114f
C4604 a_19963_14024# a_19550_13226# 0.01012f
C4605 a_4187_2434# a_16923_4687# 0.06627f
C4606 a_20397_7532# a_21044_6698# 0.02312f
C4607 a_23145_16071# VDD 0.30409f
C4608 a_8671_14652# VDD 0.01806f
C4609 a_11748_11799# VDD 0.1686f
C4610 a_9193_4687# a_9323_4687# 0.70845f
C4611 a_16108_5979# a_16597_4687# 0.01319f
C4612 a_18585_6734# a_18795_6734# 0.09424f
C4613 a_16108_3134# a_25283_1842# 0.01539f
C4614 a_14317_1842# a_13883_1842# 0.6972f
C4615 a_22488_1044# a_22590_1044# 0.37183f
C4616 a_18877_1842# a_16510_1044# 0.02479f
C4617 a_10985_3889# VDD 0.30411f
C4618 a_27991_6698# VDD 0.28273f
C4619 a_27997_1842# VDD 0.76528f
C4620 VDD CHAN0_DELAY_IN 1.50022f
C4621 a_14025_16071# a_13470_16071# 0.03209f
C4622 a_9757_14024# a_10328_13226# 0.10864f
C4623 a_16597_14024# a_17065_13226# 0.19203f
C4624 a_6913_14024# a_7043_14024# 0.70845f
C4625 a_5731_15316# a_13883_14024# 0.01539f
C4626 a_13306_11995# a_14009_11568# 0.02432f
C4627 a_13121_11521# a_12943_11557# 0.09118f
C4628 a_6854_11144# a_9444_10280# 1.24134f
C4629 a_19637_7532# a_19833_7532# 0.73897f
C4630 a_10517_7532# a_10430_6734# 0.1088f
C4631 a_19311_17497# VDD 0.01806f
C4632 a_19448_13226# VDD 0.17274f
C4633 a_12037_14024# VDD 0.86131f
C4634 a_4187_2434# CHAN1_DELAY_OUT_LAST 0.21225f
C4635 a_12849_11557# REF_CLK 0.26363f
C4636 a_27237_7532# a_25630_6734# 0.05253f
C4637 a_26477_7532# a_26471_6698# 0.02349f
C4638 a_26477_4687# a_26673_4687# 0.76914f
C4639 a_13123_4687# a_13231_4687# 0.01163f
C4640 a_19203_4687# a_19311_5315# 0.01697f
C4641 a_4248_3889# a_4350_3889# 0.37183f
C4642 a_7477_1842# a_7364_1008# 0.05157f
C4643 a_5731_3134# a_10517_1842# 0.01314f
C4644 a_5197_1842# a_5393_1842# 0.76914f
C4645 a_10328_1044# a_10404_1008# 0.01176f
C4646 a_4248_6734# VDD 0.17587f
C4647 a_12471_5315# VDD 0.02372f
C4648 a_9323_1842# VDD 0.50001f
C4649 a_16510_1044# VDD 0.8795f
C4650 a_1256_6734# REF_MUX_SEL4 0.03691f
C4651 a_19637_16869# a_20397_16869# 0.01669f
C4652 VDD CHAN2_MUX_SEL1 0.50228f
C4653 a_1256_16071# a_2873_16422# 0.28892f
C4654 a_15837_16869# a_15964_15316# 0.02f
C4655 a_4187_2434# a_14317_14024# 0.0414f
C4656 CHAN1_MUX_SEL2 CHAN1_MUX_OUT 0.08497f
C4657 CHAN1_MUX_SEL3 CHAN1_MUX_SEL4 0.75489f
C4658 a_24523_16869# a_22590_16071# 0.01012f
C4659 a_24197_14024# a_24393_14024# 0.77122f
C4660 a_4905_13226# a_4350_13226# 0.03209f
C4661 a_4157_13495# a_4324_13190# 0.02463f
C4662 a_16108_12471# a_17865_12701# 0.29564f
C4663 a_10517_7532# a_11277_7532# 0.01669f
C4664 a_4187_2434# a_11603_1842# 0.06627f
C4665 a_23431_16035# VDD 0.28357f
C4666 a_15273_16869# VDD 0.49285f
C4667 a_2297_13577# VDD 0.47647f
C4668 a_6153_7532# VDD 0.49285f
C4669 a_14009_10774# REF_DELAY_OUT_LAST 0.25594f
C4670 a_17357_4687# a_18117_4687# 0.03319f
C4671 a_19550_6734# a_21835_6734# 0.39036f
C4672 a_25630_3889# a_27991_3853# 0.26208f
C4673 a_21917_1842# a_22243_1842# 0.01427f
C4674 a_5731_289# a_11785_519# 0.28056f
C4675 a_22351_8160# VDD 0.02349f
C4676 a_12993_4687# VDD 0.49665f
C4677 a_20968_3889# VDD 0.17499f
C4678 a_27997_7532# REF_DELAY_OUT_LAST 0.70957f
C4679 a_4763_4687# REF_MUX_SEL4 0.01225f
C4680 a_4187_2434# a_17553_16869# 0.11222f
C4681 a_16510_16071# a_18795_16071# 0.39036f
C4682 a_18877_14024# a_19448_13226# 0.10864f
C4683 a_4187_2434# a_8433_7532# 0.11222f
C4684 a_15077_14024# a_15837_14024# 0.02912f
C4685 a_22590_13226# a_24951_13190# 0.26208f
C4686 a_14851_10872# a_14757_10872# 0.28931f
C4687 a_4187_2434# a_15273_4687# 0.11222f
C4688 a_19637_7532# a_19550_6734# 0.1088f
C4689 a_10985_16071# VDD 0.30409f
C4690 a_27997_14024# VDD 0.76528f
C4691 a_9946_11995# VDD 0.77235f
C4692 a_7390_6734# a_9751_6698# 0.26208f
C4693 a_11277_4687# a_11271_3853# 0.02349f
C4694 a_8237_4687# a_8563_4687# 0.01427f
C4695 a_12037_4687# a_10430_3889# 0.05231f
C4696 a_26185_3889# a_26471_3853# 0.01885f
C4697 a_16597_1842# a_16484_1008# 0.05157f
C4698 a_16108_3134# a_23633_1842# 0.01872f
C4699 a_12993_1842# a_13557_1842# 0.0114f
C4700 a_20968_1044# a_21044_1008# 0.01176f
C4701 a_25528_6734# VDD 0.17274f
C4702 a_25283_1842# VDD 0.50004f
C4703 a_27433_16869# a_27563_16869# 0.70845f
C4704 a_10985_16071# a_11271_16035# 0.01885f
C4705 a_4350_16071# a_6711_16035# 0.26208f
C4706 a_9757_14024# a_7390_13226# 0.02479f
C4707 a_5731_15316# a_12233_14024# 0.01121f
C4708 a_13121_11521# a_12849_11557# 0.55272f
C4709 a_21625_13226# a_21835_13226# 0.09424f
C4710 a_18313_7532# a_18443_7532# 0.70845f
C4711 a_4187_2434# a_27563_1842# 0.06629f
C4712 a_13231_17497# VDD 0.01806f
C4713 a_9323_14024# VDD 0.50001f
C4714 a_16510_13226# VDD 0.8795f
C4715 a_22113_7532# VDD 0.55345f
C4716 a_4187_2434# CHAN0_DELAY_OUT_LAST 0.21225f
C4717 a_4437_16869# CHAN0_DELAY_IN 0.05007f
C4718 a_12158_11557# REF_CLK 0.01309f
C4719 a_24957_7532# a_25604_6698# 0.02011f
C4720 a_5705_6209# a_5731_5979# 0.28954f
C4721 a_11603_4687# a_11711_4687# 0.01163f
C4722 a_17683_4687# a_17791_5315# 0.01697f
C4723 a_25153_4687# a_25283_4687# 0.70845f
C4724 a_5731_3134# a_7803_1842# 0.01539f
C4725 a_17065_1044# a_17275_1044# 0.09424f
C4726 a_18585_6734# VDD 0.29722f
C4727 a_6391_5315# VDD 0.01806f
C4728 a_7673_1842# VDD 0.49553f
C4729 a_13444_1008# VDD 0.28633f
C4730 a_2873_3176# CHAN2_MUX_SEL2 0.01422f
C4731 a_1721_3176# CHAN2_MUX_SEL4 0.05813f
C4732 a_2297_3176# CHAN2_MUX_SEL3 0.01595f
C4733 a_1544_3134# CHAN2_MUX_OUT 0.69943f
C4734 a_18877_16869# a_18443_16869# 0.6972f
C4735 CHAN1_DELAY_IN CHAN1_MUX_SEL1 0.01824f
C4736 VDD REF_MUX_SEL1 0.50228f
C4737 a_4187_2434# a_11603_14024# 0.06627f
C4738 a_22873_14024# a_23003_14024# 0.70361f
C4739 a_9757_7532# a_9323_7532# 0.6972f
C4740 a_4187_2434# a_9953_1842# 0.11222f
C4741 a_13557_16869# VDD 0.8672f
C4742 a_20968_16071# VDD 0.17499f
C4743 a_4437_7532# VDD 0.87051f
C4744 a_16597_4687# a_16163_4687# 0.69698f
C4745 a_21157_4687# a_19550_3889# 0.05231f
C4746 a_20397_4687# a_20391_3853# 0.02349f
C4747 a_25528_3889# a_25630_3889# 0.37183f
C4748 a_25717_1842# a_25604_1008# 0.05157f
C4749 a_21157_1842# a_21353_1842# 0.77122f
C4750 a_11277_4687# VDD 0.87192f
C4751 a_16271_8160# VDD 0.01806f
C4752 a_18004_3853# VDD 0.28225f
C4753 a_16851_5999# REF_MUX_OUT 0.45865f
C4754 a_26803_16869# a_26911_16869# 0.01163f
C4755 a_9757_16869# a_9953_16869# 0.76914f
C4756 a_4187_2434# a_15837_16869# 0.0414f
C4757 a_4187_2434# a_6717_7532# 0.0414f
C4758 a_16108_15316# a_25283_14024# 0.01539f
C4759 a_18877_14024# a_16510_13226# 0.02479f
C4760 a_14317_14024# a_13883_14024# 0.6972f
C4761 a_22488_13226# a_22590_13226# 0.37183f
C4762 a_13592_11113# a_13880_10808# 0.43707f
C4763 a_4187_2434# a_13557_4687# 0.04101f
C4764 a_25283_14024# VDD 0.50004f
C4765 a_5974_11413# VDD 0.91632f
C4766 a_1544_15316# CHAN0_MUX_SEL2 0.07405f
C4767 a_1256_15316# CHAN0_MUX_SEL3 1.41161f
C4768 a_3449_15358# CHAN0_DELAY_IN 0.01017f
C4769 a_7288_6734# a_7390_6734# 0.37183f
C4770 a_14025_6734# a_14235_6734# 0.09424f
C4771 a_7477_4687# a_7673_4687# 0.73897f
C4772 a_5731_5979# a_15077_4687# 0.01319f
C4773 a_9757_4687# a_10404_3853# 0.02011f
C4774 a_13368_3889# a_13444_3853# 0.01176f
C4775 a_16108_3134# a_21917_1842# 0.01307f
C4776 a_12037_1842# a_12797_1842# 0.02912f
C4777 a_7390_1044# a_5731_289# 0.41331f
C4778 a_19550_1044# a_19524_1008# 0.277f
C4779 a_22590_6734# VDD 0.98586f
C4780 a_23633_1842# VDD 0.49601f
C4781 a_1721_4240# VDD 0.4533f
C4782 a_15964_289# VDD 0.31312f
C4783 a_26477_16869# a_26803_16869# 0.01427f
C4784 a_4187_2434# a_27563_14024# 0.06629f
C4785 a_5731_15316# a_10517_14024# 0.01314f
C4786 a_4248_16071# a_4350_16071# 0.37183f
C4787 a_5197_14024# a_5393_14024# 0.76914f
C4788 a_10328_13226# a_10404_13190# 0.01176f
C4789 a_7477_14024# a_7364_13190# 0.05157f
C4790 a_17357_7532# a_17683_7532# 0.01427f
C4791 CHAN3_MUX_SEL1 CHAN3_MUX_SEL4 0.03574f
C4792 CHAN3_MUX_SEL2 CHAN3_MUX_SEL3 3.21891f
C4793 a_4187_2434# a_25630_6734# 0.02246f
C4794 a_4187_2434# a_25913_1842# 0.11222f
C4795 a_7151_17497# VDD 0.01806f
C4796 a_7673_14024# VDD 0.49553f
C4797 a_20397_7532# VDD 0.86919f
C4798 a_13444_13190# VDD 0.28633f
C4799 a_10232_11561# DLL_RESETN 0.39088f
C4800 a_24197_7532# a_24084_6698# 0.02055f
C4801 a_16163_4687# a_16271_5315# 0.01697f
C4802 a_10083_4687# a_10191_4687# 0.01163f
C4803 a_4905_3889# a_5115_3889# 0.09424f
C4804 a_5731_3134# a_6153_1842# 0.02026f
C4805 a_16108_3134# a_23945_3364# 0.2906f
C4806 a_5957_1842# a_4350_1044# 0.05231f
C4807 a_5197_1842# a_5191_1008# 0.02349f
C4808 a_7390_1044# a_8155_1044# 0.39037f
C4809 a_27237_4687# VDD 0.86331f
C4810 a_5957_1842# VDD 0.85955f
C4811 a_11195_1044# VDD 0.1539f
C4812 a_2873_1395# CHAN3_MUX_SEL1 0.13092f
C4813 a_3449_1395# CHAN3_DELAY_IN 0.01058f
C4814 a_17553_16869# a_18117_16869# 0.0114f
C4815 a_4187_2434# a_9953_14024# 0.11222f
C4816 a_25630_16071# a_27991_16035# 0.26208f
C4817 CHAN0_MUX_SEL3 CHAN0_MUX_SEL4 0.75489f
C4818 CHAN0_MUX_SEL2 CHAN0_MUX_OUT 0.08497f
C4819 a_21917_14024# a_22243_14024# 0.01427f
C4820 a_4187_2434# a_22677_7532# 0.04065f
C4821 a_8433_7532# a_8997_7532# 0.0114f
C4822 a_5731_12471# a_11785_12701# 0.28056f
C4823 a_4187_2434# a_8237_1842# 0.0414f
C4824 a_10843_16869# VDD 0.49736f
C4825 a_18004_16035# VDD 0.28225f
C4826 a_18877_4687# a_19524_3853# 0.02011f
C4827 a_15273_4687# a_15837_4687# 0.0114f
C4828 a_19833_1842# a_19963_1842# 0.70845f
C4829 a_24008_3889# a_24084_3853# 0.01176f
C4830 a_10191_8160# VDD 0.01806f
C4831 a_8563_4687# VDD 0.49684f
C4832 a_15755_3889# VDD 0.15389f
C4833 a_4187_2434# a_13123_16869# 0.0643f
C4834 a_8433_16869# a_8563_16869# 0.70845f
C4835 a_25283_16869# a_25391_16869# 0.01163f
C4836 a_11277_16869# a_11848_16071# 0.10863f
C4837 a_26185_16071# a_26471_16035# 0.01885f
C4838 a_4187_2434# a_4003_7532# 0.05992f
C4839 a_12993_14024# a_13557_14024# 0.0114f
C4840 a_16108_15316# a_23633_14024# 0.01872f
C4841 a_16597_14024# a_16484_13190# 0.05157f
C4842 a_13592_11113# a_14111_10917# 0.34114f
C4843 a_20968_13226# a_21044_13190# 0.01176f
C4844 a_4187_2434# a_10843_4687# 0.06627f
C4845 a_23633_14024# VDD 0.49601f
C4846 a_1721_16422# VDD 0.4533f
C4847 a_15964_12471# VDD 0.31312f
C4848 a_1544_13226# CHAN1_MUX_OUT 0.04241f
C4849 a_2297_13577# CHAN1_MUX_SEL1 0.01995f
C4850 a_27433_7532# a_27563_7532# 0.70845f
C4851 a_6153_4687# a_6283_4687# 0.70845f
C4852 a_5768_6734# a_5844_6698# 0.01176f
C4853 a_8997_4687# a_8884_3853# 0.02055f
C4854 a_16108_3134# a_19203_1842# 0.01539f
C4855 a_11277_1842# a_10843_1842# 0.6972f
C4856 a_14317_1842# a_14311_1008# 0.02349f
C4857 a_15077_1842# a_13470_1044# 0.05231f
C4858 a_19524_6698# VDD 0.28633f
C4859 a_21917_1842# VDD 0.89571f
C4860 a_8745_519# VDD 0.29292f
C4861 a_4187_2434# a_25913_14024# 0.11222f
C4862 a_25717_16869# a_25913_16869# 0.73897f
C4863 a_4187_2434# a_6854_11676# 0.01478f
C4864 a_5731_15316# a_7803_14024# 0.01539f
C4865 a_17065_13226# a_17275_13226# 0.09424f
C4866 a_16597_7532# a_16793_7532# 0.73897f
C4867 a_11491_11918# a_12158_11557# 0.0894f
C4868 a_4187_2434# a_24197_1842# 0.04141f
C4869 a_26803_16869# VDD 0.49671f
C4870 a_11195_13226# VDD 0.1539f
C4871 a_5957_14024# VDD 0.86079f
C4872 a_17683_7532# VDD 0.49671f
C4873 a_6854_11144# DLL_RESETN 0.03626f
C4874 a_22873_7532# VDD 0.49388f
C4875 a_1256_6734# a_1721_7085# 0.13421f
C4876 a_23437_7532# a_22590_6734# 0.08038f
C4877 a_1256_5979# a_1544_5979# 1.25711f
C4878 a_23437_4687# a_23633_4687# 0.76914f
C4879 a_14643_4687# a_14751_5315# 0.01697f
C4880 a_8563_4687# a_8671_4687# 0.01163f
C4881 a_12505_1044# a_12791_1008# 0.01885f
C4882 a_24523_4687# VDD 0.50001f
C4883 a_23945_3364# VDD 0.29292f
C4884 a_8231_1008# VDD 0.28336f
C4885 a_1256_1044# CHAN3_MUX_SEL1 1.44243f
C4886 a_1544_1044# CHAN3_MUX_SEL0 0.07603f
C4887 a_20397_16869# a_20968_16071# 0.10863f
C4888 a_16597_16869# a_17357_16869# 0.01669f
C4889 a_4187_2434# a_8237_14024# 0.0414f
C4890 a_21157_14024# a_21353_14024# 0.77122f
C4891 CHAN0_DELAY_IN CHAN0_MUX_SEL1 0.01824f
C4892 a_4187_2434# a_19963_7532# 0.06661f
C4893 a_25528_16071# a_25630_16071# 0.37183f
C4894 a_25717_14024# a_25604_13190# 0.05157f
C4895 a_7477_7532# a_8237_7532# 0.01669f
C4896 a_4187_2434# a_26803_4687# 0.06627f
C4897 a_4187_2434# a_5523_1842# 0.06627f
C4898 a_9193_16869# VDD 0.49285f
C4899 a_15755_16071# VDD 0.15389f
C4900 a_14317_4687# a_15077_4687# 0.03319f
C4901 a_16408_6734# a_16484_6698# 0.01176f
C4902 a_16108_5979# a_26477_4687# 0.01319f
C4903 a_18117_4687# a_18004_3853# 0.02055f
C4904 a_13470_3889# a_5731_3134# 0.41365f
C4905 a_18877_1842# a_19203_1842# 0.01427f
C4906 a_22590_3889# a_22564_3853# 0.277f
C4907 a_1256_1044# a_2297_1395# 0.04619f
C4908 a_1256_289# a_2873_331# 0.27926f
C4909 a_22590_1044# a_16108_289# 0.56869f
C4910 a_24197_1842# a_22590_1044# 0.05231f
C4911 a_1544_289# a_2297_331# 0.27303f
C4912 a_23437_1842# a_23431_1008# 0.02349f
C4913 a_4111_8160# VDD 0.01866f
C4914 a_12791_3853# VDD 0.28232f
C4915 a_6913_4687# VDD 0.49655f
C4916 a_4187_2434# a_11473_16869# 0.11222f
C4917 a_13368_16071# a_13444_16035# 0.01176f
C4918 a_23763_16869# a_23871_16869# 0.01163f
C4919 a_16108_15316# a_21917_14024# 0.01307f
C4920 a_12037_14024# a_12797_14024# 0.02912f
C4921 a_7390_13226# a_5731_12471# 0.41331f
C4922 a_19550_13226# a_19524_13190# 0.277f
C4923 a_15304_10295# a_14111_10917# 0.01761f
C4924 a_4187_2434# a_9193_4687# 0.11222f
C4925 a_8745_12701# VDD 0.29292f
C4926 a_21917_14024# VDD 0.8957f
C4927 a_9465_6734# a_9751_6698# 0.01885f
C4928 a_26477_7532# a_26803_7532# 0.01427f
C4929 a_4350_6734# a_4324_6698# 0.277f
C4930 a_5731_5979# a_10713_4687# 0.01865f
C4931 a_5197_4687# a_5523_4687# 0.01427f
C4932 a_10430_3889# a_11195_3889# 0.39037f
C4933 a_8237_4687# a_7390_3889# 0.08038f
C4934 a_13557_4687# a_14025_3889# 0.19203f
C4935 a_21625_3889# a_19550_3889# 0.03208f
C4936 a_16108_3134# a_17553_1842# 0.01872f
C4937 a_9953_1842# a_10517_1842# 0.0114f
C4938 a_16510_1044# a_17351_1008# 0.28268f
C4939 a_12797_1842# a_13444_1008# 0.02011f
C4940 a_27563_1842# a_27671_1842# 0.01163f
C4941 a_17275_6734# VDD 0.15389f
C4942 a_19203_1842# VDD 0.50004f
C4943 a_2873_331# VDD 0.46491f
C4944 a_4187_2434# a_24197_14024# 0.04141f
C4945 a_4905_16071# a_5115_16071# 0.09424f
C4946 a_24393_16869# a_24523_16869# 0.70845f
C4947 a_5197_14024# a_5191_13190# 0.02349f
C4948 a_5731_15316# a_6153_14024# 0.02026f
C4949 a_5957_14024# a_4350_13226# 0.05231f
C4950 a_16108_15316# a_23945_15546# 0.2906f
C4951 a_7390_13226# a_8155_13226# 0.39037f
C4952 a_10649_11568# a_10751_11568# 0.47795f
C4953 a_6854_11676# a_12849_11557# 0.03615f
C4954 a_15273_7532# a_15403_7532# 0.70845f
C4955 a_5731_12471# a_15304_10295# 0.04235f
C4956 CHAN2_MUX_SEL1 CHAN2_MUX_SEL4 0.03574f
C4957 CHAN2_MUX_SEL2 CHAN2_MUX_SEL3 3.21891f
C4958 a_4187_2434# a_21483_1842# 0.06627f
C4959 a_10517_7532# a_10985_6734# 0.19203f
C4960 a_6283_7532# a_4350_6734# 0.01012f
C4961 a_25153_16869# VDD 0.49426f
C4962 a_23945_15546# VDD 0.29292f
C4963 a_8231_13190# VDD 0.28349f
C4964 a_16033_7532# VDD 0.49413f
C4965 a_7043_4687# a_7151_4687# 0.01163f
C4966 a_13123_4687# a_13231_5315# 0.01697f
C4967 a_22113_4687# a_22243_4687# 0.70361f
C4968 a_27048_6734# a_27124_6698# 0.01176f
C4969 a_27237_4687# a_27124_3853# 0.02055f
C4970 a_5731_3134# a_15765_3308# 0.23301f
C4971 a_27237_1842# a_26803_1842# 0.6972f
C4972 a_10985_1044# a_10430_1044# 0.03209f
C4973 a_4350_1044# a_5768_1044# 0.38994f
C4974 a_22873_4687# VDD 0.49647f
C4975 a_11785_3364# VDD 0.29292f
C4976 a_5768_1044# VDD 0.17499f
C4977 a_4187_2434# a_27433_16869# 0.11222f
C4978 a_15837_16869# a_15403_16869# 0.6972f
C4979 a_24008_16071# a_24084_16035# 0.01176f
C4980 a_4187_2434# a_5523_14024# 0.06627f
C4981 a_19833_14024# a_19963_14024# 0.70845f
C4982 a_4187_2434# a_18313_7532# 0.11284f
C4983 a_6717_7532# a_6283_7532# 0.6972f
C4984 a_4187_2434# a_25153_4687# 0.11222f
C4985 a_12791_16035# VDD 0.28232f
C4986 a_7477_16869# VDD 0.86712f
C4987 a_12907_10876# VDD 0.0638f
C4988 a_22873_7532# a_23437_7532# 0.0114f
C4989 a_13557_4687# a_13123_4687# 0.69698f
C4990 a_16108_5979# a_23763_4687# 0.01544f
C4991 a_17357_4687# a_16510_3889# 0.08038f
C4992 a_27237_4687# a_27705_3889# 0.2079f
C4993 a_18117_1842# a_18313_1842# 0.77122f
C4994 a_21917_1842# a_22564_1008# 0.02011f
C4995 a_26477_7532# VDD 0.86919f
C4996 a_5197_4687# VDD 0.87057f
C4997 a_10328_3889# VDD 0.17274f
C4998 a_26151_2470# VDD 0.01806f
C4999 a_1544_5979# REF_MUX_SEL2 0.07405f
C5000 a_1256_5979# REF_MUX_SEL3 1.41161f
C5001 a_15964_289# CHAN3_MUX_SEL4 0.5544f
C5002 a_4187_2434# a_9757_16869# 0.0414f
C5003 a_6717_16869# a_6913_16869# 0.76914f
C5004 a_22243_16869# a_22351_16869# 0.01163f
C5005 a_11277_14024# a_10843_14024# 0.6972f
C5006 a_15077_14024# a_13470_13226# 0.05231f
C5007 a_16108_15316# a_19203_14024# 0.01539f
C5008 a_14317_14024# a_14311_13190# 0.02349f
C5009 a_13121_11521# a_15464_9374# 0.33256f
C5010 a_4187_2434# a_7477_4687# 0.0414f
C5011 a_15403_7532# a_13470_6734# 0.01012f
C5012 a_19203_14024# VDD 0.50004f
C5013 a_2873_12513# VDD 0.46585f
C5014 a_12797_16869# CHAN0_MUX_SEL4 0.01829f
C5015 a_7945_6734# a_7390_6734# 0.03209f
C5016 a_25717_7532# a_25913_7532# 0.73897f
C5017 a_5731_5979# a_8997_4687# 0.01319f
C5018 a_4437_4687# a_4633_4687# 0.73897f
C5019 a_6717_4687# a_6711_3853# 0.02354f
C5020 a_8997_1842# a_9757_1842# 0.02912f
C5021 a_26043_1842# a_26151_1842# 0.01163f
C5022 a_12037_1842# a_11924_1008# 0.02055f
C5023 a_27705_1044# a_27991_1008# 0.01885f
C5024 a_15755_1044# a_15831_1008# 0.01194f
C5025 a_14311_6698# VDD 0.28357f
C5026 a_17553_1842# VDD 0.49593f
C5027 a_27048_1044# VDD 0.17499f
C5028 a_23437_16869# a_23763_16869# 0.01427f
C5029 a_4187_2434# a_21483_14024# 0.06627f
C5030 a_12505_13226# a_12791_13190# 0.01885f
C5031 a_9946_11995# a_10232_11561# 0.41329f
C5032 a_14317_7532# a_14643_7532# 0.01427f
C5033 a_4187_2434# a_19833_1842# 0.11222f
C5034 a_11785_15546# VDD 0.29292f
C5035 a_23437_16869# VDD 0.86929f
C5036 a_5768_13226# VDD 0.17499f
C5037 a_14317_7532# VDD 0.87239f
C5038 a_3449_16422# CHAN0_MUX_SEL0 0.10753f
C5039 a_11785_12701# CHAN1_MUX_SEL4 0.03255f
C5040 a_25630_6734# a_25604_6698# 0.277f
C5041 a_16510_6734# a_15964_5979# 0.05416f
C5042 a_5523_4687# a_5631_4687# 0.01163f
C5043 a_11603_4687# a_11711_5315# 0.01697f
C5044 a_26477_4687# a_25630_3889# 0.08038f
C5045 a_25913_1842# a_26477_1842# 0.0114f
C5046 a_7945_1044# a_8231_1008# 0.01885f
C5047 a_21157_4687# VDD 0.86003f
C5048 a_26185_1044# VDD 0.30411f
C5049 a_4187_2434# a_25717_16869# 0.0414f
C5050 a_14513_16869# a_15077_16869# 0.0114f
C5051 a_13470_16071# a_5731_15316# 0.41365f
C5052 a_22590_16071# a_22564_16035# 0.277f
C5053 a_4187_2434# a_16597_7532# 0.04176f
C5054 a_24197_14024# a_22590_13226# 0.05231f
C5055 a_23437_14024# a_23431_13190# 0.02349f
C5056 a_1256_13226# a_2297_13577# 0.04619f
C5057 a_18877_14024# a_19203_14024# 0.01427f
C5058 a_1256_12471# a_2873_12513# 0.27926f
C5059 a_1544_12471# a_2297_12513# 0.27303f
C5060 a_22590_13226# a_16108_12471# 0.56869f
C5061 a_5393_7532# a_5957_7532# 0.0114f
C5062 a_4187_2434# a_23437_4687# 0.04012f
C5063 a_15837_7532# a_15964_5979# 0.02f
C5064 a_4763_16869# VDD 0.4973f
C5065 a_10328_16071# VDD 0.17274f
C5066 a_14851_11918# VDD 0.25841f
C5067 a_26151_14652# VDD 0.01806f
C5068 a_24665_6734# a_24951_6698# 0.01885f
C5069 a_13470_6734# a_14235_6734# 0.39037f
C5070 a_16108_5979# a_22113_4687# 0.01872f
C5071 a_12233_4687# a_12797_4687# 0.0114f
C5072 a_15837_4687# a_15831_3853# 0.02354f
C5073 a_19550_3889# a_20391_3853# 0.28268f
C5074 a_21157_1842# a_21044_1008# 0.02055f
C5075 a_16793_1842# a_16923_1842# 0.70845f
C5076 a_16510_1044# a_17865_519# 0.02165f
C5077 a_25630_1044# a_27048_1044# 0.38994f
C5078 a_23763_7532# VDD 0.49674f
C5079 a_16851_5999# VDD 0.52304f
C5080 a_7390_3889# VDD 0.8686f
C5081 a_20071_2470# VDD 0.01806f
C5082 a_2297_4240# CHAN2_MUX_SEL1 0.01995f
C5083 a_1544_3889# CHAN2_MUX_OUT 0.04241f
C5084 a_5731_289# CHAN3_MUX_OUT 1.04829f
C5085 a_8745_519# CHAN3_MUX_SEL4 0.04472f
C5086 a_5393_16869# a_5523_16869# 0.70845f
C5087 a_7803_16869# a_7390_16071# 0.01012f
C5088 a_4187_2434# a_7043_16869# 0.06627f
C5089 a_20723_16869# a_20831_16869# 0.01163f
C5090 a_10430_16071# a_11195_16071# 0.39037f
C5091 a_21625_16071# a_19550_16071# 0.03208f
C5092 a_16108_15316# a_17553_14024# 0.01872f
C5093 a_27563_14024# a_27671_14024# 0.01163f
C5094 a_9953_14024# a_10517_14024# 0.0114f
C5095 a_12797_14024# a_13444_13190# 0.02011f
C5096 a_15108_11799# a_15304_10295# 0.17528f
C5097 a_16510_13226# a_17351_13190# 0.28268f
C5098 a_22677_7532# a_22243_7532# 0.69698f
C5099 a_4187_2434# a_26043_7532# 0.06661f
C5100 a_4187_2434# a_4763_4687# 0.06627f
C5101 a_17553_14024# VDD 0.49593f
C5102 a_27048_13226# VDD 0.17499f
C5103 a_13132_11110# REF_CLK 0.02025f
C5104 a_24393_7532# a_24523_7532# 0.70845f
C5105 a_5731_5979# a_6283_4687# 0.01542f
C5106 a_5197_4687# a_5844_3853# 0.02312f
C5107 a_7390_3889# a_8808_3889# 0.38994f
C5108 a_8237_1842# a_7803_1842# 0.6972f
C5109 a_15545_3889# a_15755_3889# 0.09424f
C5110 a_18117_1842# a_18585_1044# 0.2079f
C5111 a_24523_1842# a_24631_1842# 0.01163f
C5112 a_11277_1842# a_10430_1044# 0.08038f
C5113 a_14235_1044# a_14311_1008# 0.01194f
C5114 a_13470_1044# a_14964_1008# 0.28279f
C5115 a_26185_1044# a_25630_1044# 0.03209f
C5116 a_11848_6734# VDD 0.17499f
C5117 a_15837_1842# VDD 0.87964f
C5118 a_24084_1008# VDD 0.28225f
C5119 a_22677_16869# a_22873_16869# 0.73022f
C5120 a_4187_2434# a_19833_14024# 0.11222f
C5121 a_5731_15316# a_15765_15490# 0.23301f
C5122 a_4350_13226# a_5768_13226# 0.38994f
C5123 a_10985_13226# a_10430_13226# 0.03209f
C5124 a_27237_14024# a_26803_14024# 0.6972f
C5125 a_9547_11632# a_9772_11533# 0.02416f
C5126 a_9547_11862# a_9746_11495# 0.02437f
C5127 a_13557_7532# a_13753_7532# 0.73897f
C5128 REF_MUX_SEL1 REF_MUX_SEL4 0.03574f
C5129 REF_MUX_SEL2 REF_MUX_SEL3 3.21891f
C5130 a_4187_2434# a_18117_1842# 0.04141f
C5131 a_20723_16869# VDD 0.49677f
C5132 a_26185_13226# VDD 0.30411f
C5133 a_11603_7532# VDD 0.49739f
C5134 a_4003_4687# a_4111_4687# 0.01163f
C5135 a_10083_4687# a_10191_5315# 0.01697f
C5136 a_24957_4687# a_24951_3853# 0.02354f
C5137 a_20397_4687# a_20593_4687# 0.76914f
C5138 a_24957_1842# a_25717_1842# 0.06198f
C5139 a_6425_1044# a_6635_1044# 0.09424f
C5140 a_18443_4687# VDD 0.50001f
C5141 a_1544_3134# VDD 0.3957f
C5142 a_14025_1044# VDD 0.30411f
C5143 a_4187_2434# a_23003_16869# 0.06391f
C5144 a_16923_16869# a_16510_16071# 0.01012f
C5145 a_13557_16869# a_14317_16869# 0.01669f
C5146 a_18117_14024# a_18313_14024# 0.77122f
C5147 a_4187_2434# a_13883_7532# 0.06627f
C5148 a_21917_14024# a_22564_13190# 0.02011f
C5149 a_4437_7532# a_5197_7532# 0.01669f
C5150 a_4187_2434# a_20723_4687# 0.06627f
C5151 a_7390_16071# VDD 0.8686f
C5152 a_20071_14652# VDD 0.01806f
C5153 a_13592_11561# VDD 0.07382f
C5154 a_27997_16869# CHAN0_DELAY_OUT_LAST 0.70955f
C5155 a_4003_14024# CHAN1_DELAY_IN 0.54998f
C5156 a_7390_13226# CHAN1_MUX_SEL4 0.34655f
C5157 a_23145_6734# a_22590_6734# 0.03209f
C5158 a_14317_4687# a_14964_3853# 0.02312f
C5159 a_11277_4687# a_12037_4687# 0.03319f
C5160 a_16108_5979# a_20397_4687# 0.01319f
C5161 a_15837_1842# a_16163_1842# 0.01427f
C5162 a_18795_3889# a_18871_3853# 0.01194f
C5163 a_20397_1842# a_19550_1044# 0.08038f
C5164 a_4324_3853# VDD 0.28687f
C5165 a_13991_2470# VDD 0.01806f
C5166 VDD CHAN1_MUX_OUT 0.57463f
C5167 a_2297_331# CHAN3_MUX_OUT 0.01179f
C5168 a_2873_331# CHAN3_MUX_SEL4 0.04916f
C5169 a_3449_331# CHAN3_MUX_SEL3 0.28429f
C5170 a_4187_2434# a_5393_16869# 0.11222f
C5171 a_6717_16869# a_7288_16071# 0.10864f
C5172 a_12037_16869# a_12505_16071# 0.2079f
C5173 a_19203_16869# a_19311_16869# 0.01163f
C5174 a_8997_14024# a_9757_14024# 0.02912f
C5175 a_15755_13226# a_15831_13190# 0.01194f
C5176 a_26043_14024# a_26151_14024# 0.01163f
C5177 a_12037_14024# a_11924_13190# 0.02055f
C5178 a_27705_13226# a_27991_13190# 0.01885f
C5179 a_21353_7532# a_21917_7532# 0.0114f
C5180 a_4187_2434# a_24393_7532# 0.11284f
C5181 a_15837_14024# VDD 0.87964f
C5182 a_24084_13190# VDD 0.28225f
C5183 a_23437_7532# a_23763_7532# 0.01427f
C5184 a_15765_6153# a_16108_5979# 0.42004f
C5185 a_4437_4687# a_4350_3889# 0.1088f
C5186 a_6913_1842# a_7477_1842# 0.0114f
C5187 a_5731_3134# a_14317_1842# 0.01319f
C5188 a_23145_1044# a_23431_1008# 0.01885f
C5189 a_23003_1842# a_23111_1842# 0.01163f
C5190 a_9757_1842# a_9751_1008# 0.02354f
C5191 a_8884_6698# VDD 0.28225f
C5192 a_23871_5315# VDD 0.01806f
C5193 a_13123_1842# VDD 0.4839f
C5194 a_21835_1044# VDD 0.15407f
C5195 a_4187_2434# a_18117_14024# 0.04141f
C5196 a_26043_16869# a_25630_16071# 0.01012f
C5197 a_21353_16869# a_21483_16869# 0.70845f
C5198 a_25913_14024# a_26477_14024# 0.0114f
C5199 a_7945_13226# a_8231_13190# 0.01885f
C5200 a_12233_7532# a_12363_7532# 0.70361f
C5201 a_6854_11676# a_6126_9506# 0.18536f
C5202 a_5974_11413# a_6854_11144# 0.01757f
C5203 a_4187_2434# a_15403_1842# 0.06627f
C5204 a_19073_16869# VDD 0.49426f
C5205 a_1544_15316# VDD 0.3957f
C5206 a_14025_13226# VDD 0.30411f
C5207 a_9953_7532# VDD 0.49426f
C5208 a_1544_12471# CHAN1_MUX_SEL4 0.47529f
C5209 a_2297_12513# CHAN1_MUX_SEL2 0.10655f
C5210 a_1256_12471# CHAN1_MUX_OUT 0.1134f
C5211 a_22590_6734# a_23431_6698# 0.28268f
C5212 a_19073_4687# a_19203_4687# 0.70845f
C5213 a_8563_4687# a_8671_5315# 0.01697f
C5214 a_23437_4687# a_24084_3853# 0.02312f
C5215 a_24197_1842# a_23763_1842# 0.6972f
C5216 a_4157_1313# a_4350_1044# 0.04624f
C5217 a_16108_289# a_16851_309# 0.06181f
C5218 a_16793_4687# VDD 0.49408f
C5219 a_25604_3853# VDD 0.28633f
C5220 a_4157_1313# VDD 0.48939f
C5221 a_4187_2434# a_21353_16869# 0.11222f
C5222 a_12797_16869# a_12363_16869# 0.6972f
C5223 a_25717_16869# a_26185_16071# 0.19203f
C5224 a_15837_16869# a_16408_16071# 0.10864f
C5225 a_19550_16071# a_20391_16035# 0.28268f
C5226 a_4187_2434# a_12233_7532# 0.11169f
C5227 a_16793_14024# a_16923_14024# 0.70845f
C5228 a_21157_14024# a_21044_13190# 0.02055f
C5229 a_16510_13226# a_17865_12701# 0.02165f
C5230 a_5778_9057# a_5864_9057# 0.07306f
C5231 a_9444_9602# a_9712_9602# 0.81869f
C5232 a_25630_13226# a_27048_13226# 0.38994f
C5233 a_4187_2434# a_19073_4687# 0.11222f
C5234 a_13991_14652# VDD 0.01806f
C5235 a_4324_16035# VDD 0.28687f
C5236 a_12656_11554# VDD 0.27353f
C5237 a_16108_15316# CHAN0_MUX_OUT 0.24265f
C5238 a_10517_4687# a_10083_4687# 0.69698f
C5239 a_20105_6734# a_20391_6698# 0.01885f
C5240 a_10430_6734# a_11848_6734# 0.38994f
C5241 a_16108_5979# a_17683_4687# 0.01562f
C5242 a_13557_4687# a_13470_3889# 0.1088f
C5243 a_16510_3889# a_18004_3853# 0.28279f
C5244 a_4350_3889# a_5705_3364# 0.02005f
C5245 a_15077_1842# a_15273_1842# 0.77122f
C5246 a_17275_3889# a_17351_3853# 0.01194f
C5247 a_18877_1842# a_18871_1008# 0.02354f
C5248 a_22590_1044# a_24875_1044# 0.39036f
C5249 a_5705_6209# VDD 0.29556f
C5250 a_21625_3889# VDD 0.29742f
C5251 a_7911_2470# VDD 0.01806f
C5252 VDD CHAN0_MUX_OUT 0.76779f
C5253 a_15545_16071# a_15755_16071# 0.09424f
C5254 a_17683_16869# a_17791_16869# 0.01163f
C5255 a_6717_16869# a_4350_16071# 0.02479f
C5256 a_7390_16071# a_8808_16071# 0.38994f
C5257 a_8237_14024# a_7803_14024# 0.6972f
C5258 a_18117_14024# a_18585_13226# 0.2079f
C5259 a_24523_14024# a_24631_14024# 0.01163f
C5260 a_26185_13226# a_25630_13226# 0.03209f
C5261 a_13470_13226# a_14964_13190# 0.28279f
C5262 a_14235_13226# a_14311_13190# 0.01194f
C5263 a_11277_14024# a_10430_13226# 0.08038f
C5264 a_6326_10280# a_5778_9057# 0.8779f
C5265 a_20397_7532# a_21157_7532# 0.03319f
C5266 a_11277_7532# a_11848_6734# 0.10863f
C5267 a_24631_17497# VDD 0.01806f
C5268 a_13123_14024# VDD 0.4839f
C5269 a_21835_13226# VDD 0.15407f
C5270 a_4187_2434# DLL_RESETN 0.06929f
C5271 a_6717_16869# CHAN0_MUX_SEL4 0.0195f
C5272 a_12943_11557# DLL_RESETN 0.03616f
C5273 a_5731_5979# a_16108_5979# 0.01334f
C5274 a_10985_3889# a_11195_3889# 0.09424f
C5275 a_4350_3889# a_6635_3889# 0.39036f
C5276 a_8237_1842# a_8884_1008# 0.02312f
C5277 a_5957_1842# a_6717_1842# 0.02912f
C5278 a_21483_1842# a_21591_1842# 0.01163f
C5279 a_27563_1842# a_27671_2470# 0.01697f
C5280 a_5731_3134# a_11603_1842# 0.01544f
C5281 a_10430_1044# a_12791_1008# 0.26208f
C5282 a_17791_5315# VDD 0.01806f
C5283 a_6635_6734# VDD 0.15406f
C5284 a_11473_1842# VDD 0.49601f
C5285 a_18871_1008# VDD 0.2822f
C5286 a_3449_7085# REF_MUX_SEL0 0.10753f
C5287 a_11785_3364# CHAN2_MUX_SEL4 0.03255f
C5288 a_4187_2434# a_15403_14024# 0.06627f
C5289 a_20397_16869# a_20723_16869# 0.01427f
C5290 a_24957_16869# a_25528_16071# 0.10864f
C5291 VDD CHAN3_MUX_SEL0 0.58791f
C5292 a_24957_14024# a_25717_14024# 0.06198f
C5293 a_6425_13226# a_6635_13226# 0.09424f
C5294 a_11277_7532# a_11603_7532# 0.01427f
C5295 a_4187_2434# a_13753_1842# 0.11222f
C5296 a_17357_16869# VDD 0.86919f
C5297 a_25604_16035# VDD 0.28633f
C5298 a_4157_13495# VDD 0.48941f
C5299 a_8237_7532# VDD 0.86919f
C5300 a_15688_11093# REF_DELAY_OUT_LAST 0.01699f
C5301 a_21835_6734# a_21911_6698# 0.01194f
C5302 a_7043_4687# a_7151_5315# 0.01697f
C5303 a_22677_4687# a_22590_3889# 0.1088f
C5304 a_19550_3889# a_20905_3364# 0.02165f
C5305 a_22873_1842# a_23437_1842# 0.0114f
C5306 a_27671_8160# VDD 0.01806f
C5307 a_15077_4687# VDD 0.86122f
C5308 a_23355_3889# VDD 0.1539f
C5309 a_4187_2434# a_19637_16869# 0.0414f
C5310 a_11473_16869# a_12037_16869# 0.0114f
C5311 a_18795_16071# a_18871_16035# 0.01194f
C5312 a_15837_16869# a_13470_16071# 0.02479f
C5313 a_15837_14024# a_16163_14024# 0.01427f
C5314 a_4187_2434# a_10517_7532# 0.0414f
C5315 a_20397_14024# a_19550_13226# 0.08038f
C5316 a_4187_2434# a_17357_4687# 0.04141f
C5317 a_20397_7532# a_20968_6734# 0.10863f
C5318 a_21625_16071# VDD 0.29722f
C5319 a_10751_11568# VDD 0.20524f
C5320 a_7911_14652# VDD 0.01806f
C5321 a_16108_5979# a_16033_4687# 0.01197f
C5322 a_9193_4687# a_9757_4687# 0.0114f
C5323 a_13753_1842# a_13883_1842# 0.70845f
C5324 a_16108_3134# a_25717_1842# 0.01314f
C5325 a_10430_1044# a_11785_519# 0.02058f
C5326 a_17357_1842# a_18004_1008# 0.02312f
C5327 a_27915_6734# VDD 0.15389f
C5328 a_9465_3889# VDD 0.29742f
C5329 a_27433_1842# VDD 0.49998f
C5330 a_4437_16869# a_4324_16035# 0.05157f
C5331 a_16163_16869# a_16271_16869# 0.01163f
C5332 a_4187_2434# a_13019_11521# 0.02377f
C5333 a_5731_15316# a_14317_14024# 0.01319f
C5334 a_6913_14024# a_7477_14024# 0.0114f
C5335 a_9757_14024# a_9751_13190# 0.02354f
C5336 a_23003_14024# a_23111_14024# 0.01163f
C5337 a_23145_13226# a_23431_13190# 0.01885f
C5338 a_13306_11995# a_13592_11561# 0.41329f
C5339 a_19637_7532# a_19203_7532# 0.69698f
C5340 a_12849_11557# a_14009_11568# 0.03525f
C5341 a_6126_9506# a_9444_10280# 0.03029f
C5342 a_13019_11521# a_12943_11557# 0.03346f
C5343 a_18551_17497# VDD 0.01806f
C5344 a_11473_14024# VDD 0.49601f
C5345 a_18871_13190# VDD 0.2822f
C5346 a_4187_2434# CHAN1_DELAY_IN 0.07719f
C5347 a_13121_11521# REF_CLK 1.40135f
C5348 a_12849_11557# DLL_RESETN 0.35009f
C5349 a_26477_4687# a_26043_4687# 0.6972f
C5350 a_7477_1842# a_7390_1044# 0.1088f
C5351 a_26043_1842# a_26151_2470# 0.01697f
C5352 a_19963_1842# a_20071_1842# 0.01163f
C5353 a_5731_3134# a_9953_1842# 0.01872f
C5354 a_5197_1842# a_4763_1842# 0.6972f
C5355 a_10328_1044# a_10430_1044# 0.37183f
C5356 a_11711_5315# VDD 0.01806f
C5357 a_16408_1044# VDD 0.17274f
C5358 a_9757_1842# VDD 0.88193f
C5359 a_19637_16869# a_19833_16869# 0.73897f
C5360 CHAN1_MUX_SEL1 CHAN1_MUX_OUT 0.09357f
C5361 VDD CHAN2_MUX_SEL0 0.58791f
C5362 CHAN1_MUX_SEL2 CHAN1_MUX_SEL4 0.01978f
C5363 a_4187_2434# a_13753_14024# 0.11222f
C5364 a_24957_16869# a_22590_16071# 0.02479f
C5365 a_24197_14024# a_23763_14024# 0.6972f
C5366 a_16108_12471# a_16851_12491# 0.06181f
C5367 a_4157_13495# a_4350_13226# 0.04624f
C5368 a_10517_7532# a_10713_7532# 0.73897f
C5369 a_4187_2434# a_12037_1842# 0.04141f
C5370 a_23355_16071# VDD 0.15389f
C5371 a_14643_16869# VDD 0.49671f
C5372 a_5523_7532# VDD 0.49671f
C5373 a_13592_11113# REF_DELAY_OUT_LAST 0.08062f
C5374 a_5523_4687# a_5631_5315# 0.01697f
C5375 a_17357_4687# a_17553_4687# 0.76914f
C5376 a_20315_6734# a_20391_6698# 0.01194f
C5377 a_19550_6734# a_21044_6698# 0.28279f
C5378 a_25630_3889# a_27915_3889# 0.39036f
C5379 a_21917_1842# a_22677_1842# 0.06198f
C5380 a_26477_1842# a_27124_1008# 0.02312f
C5381 a_21591_8160# VDD 0.01806f
C5382 a_20391_3853# VDD 0.28357f
C5383 a_12363_4687# VDD 0.92885f
C5384 a_4003_4687# CHAN2_DELAY_IN 0.54998f
C5385 a_7390_3889# CHAN2_MUX_SEL4 0.34655f
C5386 a_10517_16869# a_11277_16869# 0.01669f
C5387 a_4187_2434# a_16923_16869# 0.06627f
C5388 a_16510_16071# a_18004_16035# 0.28279f
C5389 a_17275_16071# a_17351_16035# 0.01194f
C5390 a_4350_16071# a_5705_15546# 0.02005f
C5391 a_13557_16869# a_13444_16035# 0.05157f
C5392 a_15077_14024# a_15273_14024# 0.77122f
C5393 a_18877_14024# a_18871_13190# 0.02354f
C5394 a_4187_2434# a_7803_7532# 0.06627f
C5395 a_22590_13226# a_24875_13226# 0.39036f
C5396 a_4187_2434# a_14643_4687# 0.06627f
C5397 a_9465_16071# VDD 0.29722f
C5398 a_27433_14024# VDD 0.49998f
C5399 a_9772_11533# VDD 0.24887f
C5400 a_5705_15546# CHAN0_MUX_SEL4 0.03556f
C5401 a_7390_6734# a_9675_6734# 0.39036f
C5402 a_8237_4687# a_8997_4687# 0.03319f
C5403 a_13470_3889# a_15831_3853# 0.26208f
C5404 a_26185_3889# a_26395_3889# 0.09424f
C5405 a_16597_1842# a_16510_1044# 0.1088f
C5406 a_24951_6698# VDD 0.2822f
C5407 a_25717_1842# VDD 0.87095f
C5408 a_14643_16869# a_14751_16869# 0.01163f
C5409 a_27433_16869# a_27997_16869# 0.0114f
C5410 a_5957_14024# a_6717_14024# 0.02912f
C5411 a_10985_16071# a_11195_16071# 0.09424f
C5412 a_5731_15316# a_11603_14024# 0.01544f
C5413 a_4350_16071# a_6635_16071# 0.39036f
C5414 a_21483_14024# a_21591_14024# 0.01163f
C5415 a_8237_14024# a_8884_13190# 0.02312f
C5416 a_27563_14024# a_27671_14652# 0.01697f
C5417 a_13019_11521# a_12849_11557# 0.12838f
C5418 a_10430_13226# a_12791_13190# 0.26208f
C5419 a_18313_7532# a_18877_7532# 0.0114f
C5420 a_22243_7532# a_22351_7532# 0.01163f
C5421 a_4187_2434# a_27997_1842# 0.04001f
C5422 a_9757_14024# VDD 0.88193f
C5423 a_12471_17497# VDD 0.02372f
C5424 a_16408_13226# VDD 0.17274f
C5425 a_21483_7532# VDD 0.49801f
C5426 a_4187_2434# CHAN0_DELAY_IN 0.07974f
C5427 a_12158_11557# DLL_RESETN 0.02442f
C5428 a_11491_11918# REF_CLK 0.01827f
C5429 a_25153_4687# a_25717_4687# 0.0114f
C5430 a_5731_3134# a_8237_1842# 0.01319f
C5431 a_24523_1842# a_24631_2470# 0.01697f
C5432 a_18443_1842# a_18551_1842# 0.01163f
C5433 a_8808_1044# a_8884_1008# 0.01176f
C5434 a_18585_1044# a_16510_1044# 0.03208f
C5435 a_17065_6734# VDD 0.3023f
C5436 a_5631_5315# VDD 0.01806f
C5437 a_7043_1842# VDD 0.4999f
C5438 a_13470_1044# VDD 0.87936f
C5439 a_2297_3176# CHAN2_MUX_SEL2 0.10655f
C5440 a_1256_3134# CHAN2_MUX_OUT 0.1134f
C5441 a_1544_3134# CHAN2_MUX_SEL4 0.47529f
C5442 a_4157_1313# CHAN3_MUX_SEL4 0.08229f
C5443 a_18313_16869# a_18443_16869# 0.70845f
C5444 VDD REF_MUX_SEL0 0.58791f
C5445 CHAN1_DELAY_IN CHAN1_MUX_SEL0 0.11907f
C5446 a_22677_16869# a_22564_16035# 0.05157f
C5447 a_19550_16071# a_20905_15546# 0.02165f
C5448 a_4187_2434# a_12037_14024# 0.04141f
C5449 a_22873_14024# a_23437_14024# 0.0114f
C5450 a_9193_7532# a_9323_7532# 0.70845f
C5451 a_4187_2434# a_9323_1842# 0.06627f
C5452 a_12993_16869# VDD 0.49436f
C5453 a_20391_16035# VDD 0.28357f
C5454 a_5864_9057# VDD 0.13532f
C5455 a_15304_10295# REF_DELAY_OUT_LAST 0.05582f
C5456 a_24197_7532# a_24665_6734# 0.2079f
C5457 a_16033_4687# a_16163_4687# 0.70845f
C5458 a_4003_4687# a_4111_5315# 0.01697f
C5459 a_25717_1842# a_25630_1044# 0.1088f
C5460 a_21157_1842# a_20723_1842# 0.6972f
R0 VDD.n720 VDD.t867 17.3693
R1 VDD.n712 VDD.t404 17.3693
R2 VDD.n712 VDD.t408 17.3693
R3 VDD.n718 VDD.t357 17.3517
R4 VDD.n715 VDD.t846 17.3517
R5 VDD.n714 VDD.t384 17.3517
R6 VDD.n270 VDD.t777 17.2438
R7 VDD.n268 VDD.t1438 17.2438
R8 VDD.n266 VDD.t557 17.2438
R9 VDD.n264 VDD.t807 17.2438
R10 VDD.n262 VDD.t1445 17.2438
R11 VDD.n587 VDD.t841 17.2247
R12 VDD.n718 VDD.t537 17.0005
R13 VDD.n715 VDD.t406 17.0005
R14 VDD.n714 VDD.t403 17.0005
R15 VDD.t2 VDD.n1316 17.0005
R16 VDD.t2 VDD.n237 1.79211
R17 VDD.n274 VDD.n273 0.109113
R18 VDD.n1430 VDD.t2 17.0005
R19 VDD.t2 VDD.n1370 17.0005
R20 VDD.t2 VDD.n294 8.47732
R21 VDD.n1379 VDD.t2 17.0005
R22 VDD.n293 VDD.t2 8.47732
R23 VDD.t2 VDD.n1361 17.0005
R24 VDD.t2 VDD.n290 8.47732
R25 VDD.n1394 VDD.t2 17.0005
R26 VDD.n1405 VDD.t2 17.0005
R27 VDD.n244 VDD.t2 1.00226
R28 VDD.t2 VDD.n1353 17.0005
R29 VDD.t2 VDD.n288 8.47732
R30 VDD.n1420 VDD.t2 17.0005
R31 VDD.t2 VDD.n287 8.47732
R32 VDD.t373 VDD.n79 1.75579
R33 VDD.n598 VDD.t373 1.57542
R34 VDD.t373 VDD.n647 5.62581
R35 VDD.n86 VDD.n87 0.22368
R36 VDD.n89 VDD.n90 0.131036
R37 VDD.t373 VDD.n90 1.55338
R38 VDD.t373 VDD.n224 1.61271
R39 VDD.t373 VDD.n94 1.14105
R40 VDD.t373 VDD.n630 5.62581
R41 VDD.n99 VDD.n100 0.116663
R42 VDD.t373 VDD.n100 1.14105
R43 VDD.n103 VDD.t373 0.719008
R44 VDD.t373 VDD.n106 0.970152
R45 VDD.n112 VDD.t373 0.82947
R46 VDD.t373 VDD.n638 5.62581
R47 VDD.n613 VDD.n614 0.0944268
R48 VDD.t373 VDD.n64 8.47732
R49 VDD.n64 VDD.n63 0.0483676
R50 VDD.t373 VDD.n26 1.06315
R51 VDD.n26 VDD.n36 0.133774
R52 VDD.t0 VDD.n1556 17.0005
R53 VDD.t0 VDD.n235 1.79211
R54 VDD.n277 VDD.n276 0.109113
R55 VDD.n1670 VDD.t0 17.0005
R56 VDD.t0 VDD.n1610 17.0005
R57 VDD.t0 VDD.n302 8.47732
R58 VDD.n1619 VDD.t0 17.0005
R59 VDD.n301 VDD.t0 8.47732
R60 VDD.t0 VDD.n1602 17.0005
R61 VDD.t0 VDD.n298 8.47732
R62 VDD.n1634 VDD.t0 17.0005
R63 VDD.n1645 VDD.t0 17.0005
R64 VDD.n248 VDD.t0 1.00226
R65 VDD.t0 VDD.n1594 17.0005
R66 VDD.t0 VDD.n296 8.47732
R67 VDD.n1660 VDD.t0 17.0005
R68 VDD.t0 VDD.n295 8.47732
R69 VDD.n115 VDD.n114 0.116614
R70 VDD.t348 VDD.n643 2.32406
R71 VDD.t348 VDD.n628 5.62581
R72 VDD.n118 VDD.t348 1.55335
R73 VDD.n121 VDD.t348 1.55338
R74 VDD.n619 VDD.t348 5.62581
R75 VDD.t348 VDD.n602 1.57542
R76 VDD.n494 VDD.n493 0.0804275
R77 VDD.n493 VDD.t348 1.57527
R78 VDD.n129 VDD.n128 0.116644
R79 VDD.t348 VDD.n131 2.32403
R80 VDD.n137 VDD.n136 0.131036
R81 VDD.n143 VDD.n141 0.116645
R82 VDD.n141 VDD.t348 1.14097
R83 VDD.n147 VDD.n551 0.550302
R84 VDD.n147 VDD.t348 1.19612
R85 VDD.n640 VDD.t348 2.32429
R86 VDD.n150 VDD.n149 0.116649
R87 VDD.t348 VDD.n158 0.829413
R88 VDD.n659 VDD.t348 5.62581
R89 VDD.t348 VDD.n161 0.829348
R90 VDD.t348 VDD.n163 1.19254
R91 VDD.t348 VDD.n153 1.06789
R92 VDD.t348 VDD.n66 8.47732
R93 VDD.n66 VDD.n65 0.0483676
R94 VDD.t348 VDD.n22 0.667761
R95 VDD.n22 VDD.n37 0.107795
R96 VDD.t67 VDD.n1784 17.0005
R97 VDD.t67 VDD.n233 1.79211
R98 VDD.n280 VDD.n279 0.109113
R99 VDD.n1898 VDD.t67 17.0005
R100 VDD.t67 VDD.n1838 17.0005
R101 VDD.t67 VDD.n310 8.47732
R102 VDD.n1847 VDD.t67 17.0005
R103 VDD.n309 VDD.t67 8.47732
R104 VDD.t67 VDD.n1830 17.0005
R105 VDD.t67 VDD.n306 8.47732
R106 VDD.n1862 VDD.t67 17.0005
R107 VDD.n1873 VDD.t67 17.0005
R108 VDD.n252 VDD.t67 1.00226
R109 VDD.t67 VDD.n1822 17.0005
R110 VDD.t67 VDD.n304 8.47732
R111 VDD.n1888 VDD.t67 17.0005
R112 VDD.t67 VDD.n303 8.47732
R113 VDD.n17 VDD.t346 0.882997
R114 VDD.n625 VDD.t346 5.62581
R115 VDD.t346 VDD.n541 1.57516
R116 VDD.n166 VDD.n165 0.116701
R117 VDD.n166 VDD.t346 1.141
R118 VDD.n173 VDD.t346 1.14105
R119 VDD.t346 VDD.n603 1.57542
R120 VDD.n636 VDD.t346 5.62581
R121 VDD.n490 VDD.t346 1.57526
R122 VDD.t346 VDD.n176 1.20434
R123 VDD.n180 VDD.t346 0.829344
R124 VDD.n626 VDD.t346 5.62581
R125 VDD.n605 VDD.t346 1.57526
R126 VDD.n183 VDD.t346 1.55338
R127 VDD.n646 VDD.t346 5.62581
R128 VDD.n190 VDD.t346 0.829333
R129 VDD.n192 VDD.t346 2.32417
R130 VDD.n195 VDD.n194 0.116644
R131 VDD.n198 VDD.n197 0.131036
R132 VDD.n650 VDD.t346 5.62581
R133 VDD.n68 VDD.t346 8.47732
R134 VDD.n69 VDD.n68 0.0483676
R135 VDD.t5 VDD.n1197 17.0005
R136 VDD.t5 VDD.n231 1.79211
R137 VDD.n283 VDD.n282 0.109113
R138 VDD.n1312 VDD.t5 17.0005
R139 VDD.t5 VDD.n1252 17.0005
R140 VDD.t5 VDD.n318 8.47732
R141 VDD.n1261 VDD.t5 17.0005
R142 VDD.n317 VDD.t5 8.47732
R143 VDD.t5 VDD.n1243 17.0005
R144 VDD.t5 VDD.n314 8.47732
R145 VDD.n1276 VDD.t5 17.0005
R146 VDD.n1287 VDD.t5 17.0005
R147 VDD.n256 VDD.t5 1.00226
R148 VDD.t5 VDD.n1235 17.0005
R149 VDD.t5 VDD.n312 8.47732
R150 VDD.n1302 VDD.t5 17.0005
R151 VDD.t5 VDD.n311 8.47732
R152 VDD.t374 VDD.n466 1.57542
R153 VDD.n608 VDD.t374 1.57532
R154 VDD.n201 VDD.n200 0.130924
R155 VDD.t374 VDD.n460 1.57523
R156 VDD.n10 VDD.n462 0.551607
R157 VDD.n204 VDD.n203 0.116663
R158 VDD.n208 VDD.n207 0.130922
R159 VDD.n214 VDD.n213 0.130922
R160 VDD.n214 VDD.t374 1.55355
R161 VDD.n217 VDD.n216 0.131036
R162 VDD.t374 VDD.n609 1.57542
R163 VDD.n19 VDD.n444 0.604639
R164 VDD.n220 VDD.n219 0.116663
R165 VDD.n220 VDD.t374 1.14105
R166 VDD.n634 VDD.t374 5.62581
R167 VDD.n71 VDD.t374 8.47732
R168 VDD.n72 VDD.n71 0.0483676
R169 VDD.t90 VDD.n975 17.0005
R170 VDD.t90 VDD.n229 1.79211
R171 VDD.n286 VDD.n285 0.109113
R172 VDD.n1089 VDD.t90 17.0005
R173 VDD.t90 VDD.n1029 17.0005
R174 VDD.t90 VDD.n326 8.47732
R175 VDD.n1038 VDD.t90 17.0005
R176 VDD.n325 VDD.t90 8.47732
R177 VDD.t90 VDD.n1021 17.0005
R178 VDD.t90 VDD.n322 8.47732
R179 VDD.n1053 VDD.t90 17.0005
R180 VDD.n1064 VDD.t90 17.0005
R181 VDD.n260 VDD.t90 1.00226
R182 VDD.t90 VDD.n1013 17.0005
R183 VDD.t90 VDD.n320 8.47732
R184 VDD.n1079 VDD.t90 17.0005
R185 VDD.t90 VDD.n319 8.47732
R186 VDD.n74 VDD.n73 0.0483676
R187 VDD.t368 VDD.n74 8.47732
R188 VDD.t456 VDD.n55 1.30445
R189 VDD.n63 VDD.t494 15.1333
R190 VDD.n65 VDD.t483 15.1333
R191 VDD.n69 VDD.t472 15.1333
R192 VDD.n72 VDD.t438 15.1333
R193 VDD.n73 VDD.t426 15.1333
R194 VDD.n1522 VDD.t497 15.0005
R195 VDD.n222 VDD.t488 15.0005
R196 VDD.n1707 VDD.t486 15.0005
R197 VDD.n75 VDD.t477 15.0005
R198 VDD.n1912 VDD.t475 15.0005
R199 VDD.n1901 VDD.t466 15.0005
R200 VDD.n1100 VDD.t441 15.0005
R201 VDD.t374 VDD.t432 15.0005
R202 VDD.n765 VDD.t429 15.0005
R203 VDD.n31 VDD.t421 15.0005
R204 VDD.n54 VDD.t455 15.0005
R205 VDD.n58 VDD.t461 15.0005
R206 VDD.n62 VDD.t1531 17.9449
R207 VDD.n2013 VDD.t943 9.02285
R208 VDD.n709 VDD.n39 4.47071
R209 VDD.n41 VDD.t1502 8.95516
R210 VDD.n704 VDD.t912 8.76054
R211 VDD.n704 VDD.t1008 8.76054
R212 VDD.n1328 VDD.t1493 8.76054
R213 VDD.n1328 VDD.t398 8.76054
R214 VDD.n1329 VDD.t942 8.76054
R215 VDD.n1329 VDD.t798 8.76054
R216 VDD.n272 VDD.t1170 8.76054
R217 VDD.n272 VDD.t1414 8.76054
R218 VDD.n273 VDD.t941 8.76054
R219 VDD.n273 VDD.t797 8.76054
R220 VDD.n1331 VDD.t1163 8.76054
R221 VDD.n1331 VDD.t1453 8.76054
R222 VDD.n1333 VDD.t1279 8.76054
R223 VDD.n1333 VDD.t399 8.76054
R224 VDD.n1336 VDD.t1169 8.76054
R225 VDD.n1336 VDD.t1415 8.76054
R226 VDD.n1338 VDD.t868 8.76054
R227 VDD.n1338 VDD.t1260 8.76054
R228 VDD.n270 VDD.t1150 8.76054
R229 VDD.n1568 VDD.t1431 8.76054
R230 VDD.n1568 VDD.t513 8.76054
R231 VDD.n1569 VDD.t1425 8.76054
R232 VDD.n1569 VDD.t580 8.76054
R233 VDD.n275 VDD.t528 8.76054
R234 VDD.n275 VDD.t1562 8.76054
R235 VDD.n276 VDD.t1422 8.76054
R236 VDD.n276 VDD.t581 8.76054
R237 VDD.n1571 VDD.t805 8.76054
R238 VDD.n1571 VDD.t1155 8.76054
R239 VDD.n1573 VDD.t1410 8.76054
R240 VDD.n1573 VDD.t514 8.76054
R241 VDD.n1576 VDD.t527 8.76054
R242 VDD.n1576 VDD.t1563 8.76054
R243 VDD.n1578 VDD.t804 8.76054
R244 VDD.n1578 VDD.t1154 8.76054
R245 VDD.n268 VDD.t1439 8.76054
R246 VDD.n1796 VDD.t1528 8.76054
R247 VDD.n1796 VDD.t1133 8.76054
R248 VDD.n1797 VDD.t894 8.76054
R249 VDD.n1797 VDD.t876 8.76054
R250 VDD.n278 VDD.t1545 8.76054
R251 VDD.n278 VDD.t1467 8.76054
R252 VDD.n279 VDD.t893 8.76054
R253 VDD.n279 VDD.t781 8.76054
R254 VDD.n1799 VDD.t810 8.76054
R255 VDD.n1799 VDD.t1557 8.76054
R256 VDD.n1801 VDD.t1156 8.76054
R257 VDD.n1801 VDD.t1022 8.76054
R258 VDD.n1804 VDD.t1544 8.76054
R259 VDD.n1804 VDD.t1468 8.76054
R260 VDD.n1806 VDD.t388 8.76054
R261 VDD.n1806 VDD.t1073 8.76054
R262 VDD.n266 VDD.t558 8.76054
R263 VDD.n1209 VDD.t1141 8.76054
R264 VDD.n1209 VDD.t1307 8.76054
R265 VDD.n1210 VDD.t401 8.76054
R266 VDD.n1210 VDD.t958 8.76054
R267 VDD.n281 VDD.t1454 8.76054
R268 VDD.n281 VDD.t904 8.76054
R269 VDD.n282 VDD.t400 8.76054
R270 VDD.n282 VDD.t959 8.76054
R271 VDD.n1212 VDD.t566 8.76054
R272 VDD.n1212 VDD.t900 8.76054
R273 VDD.n1214 VDD.t877 8.76054
R274 VDD.n1214 VDD.t864 8.76054
R275 VDD.n1217 VDD.t1455 8.76054
R276 VDD.n1217 VDD.t903 8.76054
R277 VDD.n1219 VDD.t567 8.76054
R278 VDD.n1219 VDD.t901 8.76054
R279 VDD.n264 VDD.t1474 8.76054
R280 VDD.n987 VDD.t1416 8.76054
R281 VDD.n987 VDD.t1211 8.76054
R282 VDD.n988 VDD.t1426 8.76054
R283 VDD.n988 VDD.t1254 8.76054
R284 VDD.n284 VDD.t590 8.76054
R285 VDD.n284 VDD.t417 8.76054
R286 VDD.n285 VDD.t1433 8.76054
R287 VDD.n285 VDD.t1217 8.76054
R288 VDD.n990 VDD.t1466 8.76054
R289 VDD.n990 VDD.t352 8.76054
R290 VDD.n992 VDD.t1417 8.76054
R291 VDD.n992 VDD.t1210 8.76054
R292 VDD.n995 VDD.t589 8.76054
R293 VDD.n995 VDD.t418 8.76054
R294 VDD.n997 VDD.t1440 8.76054
R295 VDD.n997 VDD.t354 8.76054
R296 VDD.n262 VDD.t1446 8.76054
R297 VDD.n669 VDD.t2 4.21329
R298 VDD.t2 VDD.n668 4.21329
R299 VDD.n334 VDD.n667 0.0651609
R300 VDD.t2 VDD.n665 4.21329
R301 VDD.n329 VDD.n664 0.0651609
R302 VDD.t2 VDD.n662 4.21329
R303 VDD.n354 VDD.n678 0.0651609
R304 VDD.n676 VDD.n1628 0.0651609
R305 VDD.n349 VDD.n675 0.0651609
R306 VDD.n673 VDD.n1654 0.0651609
R307 VDD.n672 VDD.t0 4.21329
R308 VDD.t0 VDD.n671 4.21329
R309 VDD.n369 VDD.n686 0.0651609
R310 VDD.n684 VDD.n1856 0.0651609
R311 VDD.n364 VDD.n683 0.0651609
R312 VDD.n681 VDD.n1882 0.0651609
R313 VDD.n680 VDD.t67 4.21329
R314 VDD.n679 VDD.n1897 0.0651609
R315 VDD.n693 VDD.t5 4.21329
R316 VDD.t5 VDD.n692 4.21329
R317 VDD.n379 VDD.n691 0.0651609
R318 VDD.n689 VDD.n1296 0.0651609
R319 VDD.n688 VDD.t5 4.21329
R320 VDD.n687 VDD.n1311 0.0651609
R321 VDD.n399 VDD.n701 0.0651609
R322 VDD.n699 VDD.n1047 0.0651609
R323 VDD.n394 VDD.n698 0.0651609
R324 VDD.t90 VDD.n696 4.21329
R325 VDD.n695 VDD.t90 4.21329
R326 VDD.t90 VDD.n694 4.21329
R327 VDD.n34 VDD.t355 1.78925
R328 VDD.n413 VDD.n412 0.0624236
R329 VDD.t2 VDD.n1337 8.47732
R330 VDD.t2 VDD.n1334 8.47732
R331 VDD.t2 VDD.n274 2.01278
R332 VDD.t2 VDD.n1322 8.47732
R333 VDD.t2 VDD.n1330 8.47732
R334 VDD.t2 VDD.n1368 8.47732
R335 VDD.n669 VDD.n1366 0.1666
R336 VDD.n340 VDD.t2 1.64355
R337 VDD.n427 VDD.n294 0.147896
R338 VDD.n427 VDD.n425 0.0624233
R339 VDD.n1385 VDD.t2 8.47732
R340 VDD.n1386 VDD.n668 0.1666
R341 VDD.t2 VDD.n337 1.64355
R342 VDD.n293 VDD.n291 0.147896
R343 VDD.n424 VDD.n291 0.0624233
R344 VDD.t2 VDD.n1359 8.47732
R345 VDD.t2 VDD.n667 4.21329
R346 VDD.n335 VDD.t2 1.64355
R347 VDD.n422 VDD.n290 0.147896
R348 VDD.n422 VDD.n420 0.0624233
R349 VDD.n1411 VDD.t2 8.47732
R350 VDD.n1412 VDD.n665 0.1666
R351 VDD.t2 VDD.n332 1.64355
R352 VDD.t2 VDD.n1351 8.47732
R353 VDD.t2 VDD.n664 4.21329
R354 VDD.n330 VDD.t2 1.64355
R355 VDD.n419 VDD.n288 0.147896
R356 VDD.n419 VDD.n417 0.0624233
R357 VDD.n1426 VDD.t2 8.47732
R358 VDD.n1427 VDD.n662 0.1666
R359 VDD.t2 VDD.n327 1.64355
R360 VDD.n412 VDD.n287 0.147747
R361 VDD.n623 VDD.t373 2.3242
R362 VDD.n82 VDD.t373 0.82947
R363 VDD.n588 VDD.t373 1.57846
R364 VDD.n644 VDD.n1479 0.310289
R365 VDD.n670 VDD.t373 5.62581
R366 VDD.n84 VDD.t373 2.32406
R367 VDD.t373 VDD.n87 0.67711
R368 VDD.n627 VDD.t373 5.62581
R369 VDD.n1545 VDD.n89 0.354692
R370 VDD.n657 VDD.t373 2.32406
R371 VDD.n93 VDD.n94 0.116663
R372 VDD.n1544 VDD.n639 0.354692
R373 VDD.n639 VDD.t373 2.32417
R374 VDD.n589 VDD.n599 0.315947
R375 VDD.n589 VDD.t373 1.55333
R376 VDD.n97 VDD.t373 0.82932
R377 VDD.n1542 VDD.n624 0.35501
R378 VDD.n624 VDD.t373 2.32417
R379 VDD.n1539 VDD.n651 0.354557
R380 VDD.n651 VDD.t373 2.32425
R381 VDD.n637 VDD.t373 2.32425
R382 VDD.n600 VDD.t373 1.5752
R383 VDD.n102 VDD.n103 0.300972
R384 VDD.n105 VDD.n106 0.105726
R385 VDD.n601 VDD.t373 1.57517
R386 VDD.n108 VDD.n109 0.130979
R387 VDD.n109 VDD.t373 1.55344
R388 VDD.n112 VDD.n1515 0.595442
R389 VDD.n649 VDD.t373 2.32417
R390 VDD.n1527 VDD.n613 0.169888
R391 VDD.t373 VDD.n614 3.32623
R392 VDD.n1525 VDD.t373 8.47732
R393 VDD.t373 VDD.n1432 8.47732
R394 VDD.t373 VDD.n1452 8.47732
R395 VDD.n416 VDD.n415 0.0624236
R396 VDD.t0 VDD.n1577 8.47732
R397 VDD.t0 VDD.n1574 8.47732
R398 VDD.t0 VDD.n277 2.01278
R399 VDD.t0 VDD.n1562 8.47732
R400 VDD.t0 VDD.n1570 8.47732
R401 VDD.t0 VDD.n1608 8.47732
R402 VDD.t0 VDD.n678 4.21329
R403 VDD.n355 VDD.t0 1.64355
R404 VDD.n438 VDD.n302 0.147896
R405 VDD.n438 VDD.n436 0.0624233
R406 VDD.n1625 VDD.t0 8.47732
R407 VDD.n676 VDD.t0 4.21329
R408 VDD.t0 VDD.n352 1.64355
R409 VDD.n301 VDD.n299 0.147896
R410 VDD.n435 VDD.n299 0.0624233
R411 VDD.t0 VDD.n1600 8.47732
R412 VDD.t0 VDD.n675 4.21329
R413 VDD.n350 VDD.t0 1.64355
R414 VDD.n433 VDD.n298 0.147896
R415 VDD.n433 VDD.n431 0.0624233
R416 VDD.n1651 VDD.t0 8.47732
R417 VDD.n673 VDD.t0 4.21329
R418 VDD.t0 VDD.n347 1.64355
R419 VDD.t0 VDD.n1592 8.47732
R420 VDD.n672 VDD.n1590 0.1666
R421 VDD.n345 VDD.t0 1.64355
R422 VDD.n430 VDD.n296 0.147896
R423 VDD.n430 VDD.n428 0.0624233
R424 VDD.n1666 VDD.t0 8.47732
R425 VDD.n1667 VDD.n671 0.1666
R426 VDD.t0 VDD.n342 1.64355
R427 VDD.n415 VDD.n295 0.147747
R428 VDD.t348 VDD.n115 1.141
R429 VDD.n117 VDD.n1752 0.354847
R430 VDD.n120 VDD.n121 0.131036
R431 VDD.n120 VDD.n1761 0.354692
R432 VDD.n656 VDD.n1749 0.35501
R433 VDD.t348 VDD.n656 2.32417
R434 VDD.n1762 VDD.n641 0.354771
R435 VDD.n629 VDD.t348 2.32406
R436 VDD.n635 VDD.n1768 0.354557
R437 VDD.n1771 VDD.n561 0.35501
R438 VDD.n561 VDD.t348 2.32417
R439 VDD.t348 VDD.n648 5.62581
R440 VDD.n123 VDD.n124 0.116616
R441 VDD.t348 VDD.n124 1.14101
R442 VDD.n652 VDD.n1732 0.354557
R443 VDD.t348 VDD.n126 1.57542
R444 VDD.t348 VDD.n129 1.14093
R445 VDD.n134 VDD.n133 0.116663
R446 VDD.n134 VDD.t348 1.14105
R447 VDD.n1772 VDD.n136 0.354692
R448 VDD.n137 VDD.t348 1.55338
R449 VDD.n139 VDD.n140 0.130931
R450 VDD.n139 VDD.n1773 0.355071
R451 VDD.n140 VDD.t348 1.5534
R452 VDD.n552 VDD.t348 2.32417
R453 VDD.n1774 VDD.n552 0.354692
R454 VDD.n1775 VDD.n549 0.354557
R455 VDD.n549 VDD.t348 2.32425
R456 VDD.n150 VDD.t348 1.14094
R457 VDD.n1779 VDD.n163 0.48832
R458 VDD.t348 VDD.n1705 8.47732
R459 VDD.t348 VDD.n1685 8.47732
R460 VDD.n410 VDD.n409 0.0624236
R461 VDD.t67 VDD.n1805 8.47732
R462 VDD.t67 VDD.n1802 8.47732
R463 VDD.t67 VDD.n280 2.01278
R464 VDD.t67 VDD.n1790 8.47732
R465 VDD.t67 VDD.n1798 8.47732
R466 VDD.t67 VDD.n1836 8.47732
R467 VDD.t67 VDD.n686 4.21329
R468 VDD.n370 VDD.t67 1.64355
R469 VDD.n505 VDD.n310 0.147896
R470 VDD.n505 VDD.n503 0.0624233
R471 VDD.n1853 VDD.t67 8.47732
R472 VDD.n684 VDD.t67 4.21329
R473 VDD.t67 VDD.n367 1.64355
R474 VDD.n309 VDD.n307 0.147896
R475 VDD.n502 VDD.n307 0.0624233
R476 VDD.t67 VDD.n1828 8.47732
R477 VDD.t67 VDD.n683 4.21329
R478 VDD.n365 VDD.t67 1.64355
R479 VDD.n500 VDD.n306 0.147896
R480 VDD.n500 VDD.n498 0.0624233
R481 VDD.n1879 VDD.t67 8.47732
R482 VDD.n681 VDD.t67 4.21329
R483 VDD.t67 VDD.n362 1.64355
R484 VDD.t67 VDD.n1820 8.47732
R485 VDD.n680 VDD.n1818 0.1666
R486 VDD.n360 VDD.t67 1.64355
R487 VDD.n497 VDD.n304 0.147896
R488 VDD.n497 VDD.n495 0.0624233
R489 VDD.n1894 VDD.t67 8.47732
R490 VDD.n679 VDD.t67 4.21329
R491 VDD.t67 VDD.n357 1.64355
R492 VDD.n409 VDD.n303 0.147747
R493 VDD.t346 VDD.n631 2.74397
R494 VDD.n545 VDD.t346 2.32417
R495 VDD.n169 VDD.n170 0.130924
R496 VDD.t346 VDD.n170 1.55355
R497 VDD.n537 VDD.t346 2.32406
R498 VDD.n172 VDD.n173 0.116663
R499 VDD.n533 VDD.t346 2.32406
R500 VDD.n603 VDD.n1923 0.410004
R501 VDD.n529 VDD.t346 2.32425
R502 VDD.n1925 VDD.n529 0.354557
R503 VDD.n604 VDD.t346 1.57542
R504 VDD.n1926 VDD.n485 0.354692
R505 VDD.n485 VDD.t346 2.32417
R506 VDD.n658 VDD.t346 5.62581
R507 VDD.n182 VDD.n183 0.131036
R508 VDD.n1927 VDD.n182 0.354692
R509 VDD.n1928 VDD.n633 0.355071
R510 VDD.n633 VDD.t346 2.32406
R511 VDD.n661 VDD.t346 5.62581
R512 VDD.n482 VDD.t346 2.32406
R513 VDD.n606 VDD.t346 1.57526
R514 VDD.n480 VDD.t346 2.32417
R515 VDD.n477 VDD.t346 1.5752
R516 VDD.n186 VDD.n187 0.116663
R517 VDD.t346 VDD.n187 1.14105
R518 VDD.n654 VDD.t346 5.62581
R519 VDD.n195 VDD.t346 1.14093
R520 VDD.n1931 VDD.n197 0.354692
R521 VDD.n198 VDD.t346 1.55338
R522 VDD.n474 VDD.t346 2.32406
R523 VDD.n471 VDD.t346 1.57542
R524 VDD.n607 VDD.t346 1.5752
R525 VDD.t346 VDD.n655 5.62581
R526 VDD.n1934 VDD.t346 8.47732
R527 VDD.t346 VDD.n1936 8.47732
R528 VDD.n1938 VDD.t346 8.47732
R529 VDD.n1980 VDD.t346 8.47732
R530 VDD.n404 VDD.n403 0.0624236
R531 VDD.t5 VDD.n1218 8.47732
R532 VDD.t5 VDD.n1215 8.47732
R533 VDD.t5 VDD.n283 2.01278
R534 VDD.t5 VDD.n1203 8.47732
R535 VDD.t5 VDD.n1211 8.47732
R536 VDD.t5 VDD.n1250 8.47732
R537 VDD.n693 VDD.n1248 0.1666
R538 VDD.n385 VDD.t5 1.64355
R539 VDD.n517 VDD.n318 0.147896
R540 VDD.n517 VDD.n515 0.0624233
R541 VDD.n1267 VDD.t5 8.47732
R542 VDD.n1268 VDD.n692 0.1666
R543 VDD.t5 VDD.n382 1.64355
R544 VDD.n317 VDD.n315 0.147896
R545 VDD.n514 VDD.n315 0.0624233
R546 VDD.t5 VDD.n1241 8.47732
R547 VDD.t5 VDD.n691 4.21329
R548 VDD.n380 VDD.t5 1.64355
R549 VDD.n512 VDD.n314 0.147896
R550 VDD.n512 VDD.n510 0.0624233
R551 VDD.n1293 VDD.t5 8.47732
R552 VDD.n689 VDD.t5 4.21329
R553 VDD.t5 VDD.n377 1.64355
R554 VDD.t5 VDD.n1233 8.47732
R555 VDD.n688 VDD.n1231 0.1666
R556 VDD.n375 VDD.t5 1.64355
R557 VDD.n509 VDD.n312 0.147896
R558 VDD.n509 VDD.n507 0.0624233
R559 VDD.n1308 VDD.t5 8.47732
R560 VDD.n687 VDD.t5 4.21329
R561 VDD.t5 VDD.n372 1.64355
R562 VDD.n403 VDD.n311 0.147747
R563 VDD.n21 VDD.n4 0.137531
R564 VDD.n7 VDD.n8 0.376342
R565 VDD.n8 VDD.t374 0.599095
R566 VDD.n1106 VDD.n200 0.355147
R567 VDD.n201 VDD.t374 1.55355
R568 VDD.n621 VDD.t374 2.32406
R569 VDD.n1110 VDD.n463 0.354771
R570 VDD.n204 VDD.t374 1.14105
R571 VDD.n1111 VDD.n632 0.35501
R572 VDD.n632 VDD.t374 2.32417
R573 VDD.t374 VDD.n208 1.55355
R574 VDD.n456 VDD.t374 2.3242
R575 VDD.n210 VDD.n211 0.116616
R576 VDD.n211 VDD.t374 1.14093
R577 VDD.n1115 VDD.n216 0.354692
R578 VDD.t374 VDD.n217 1.55338
R579 VDD.n452 VDD.t374 2.3242
R580 VDD.n1118 VDD.n642 0.354692
R581 VDD.n642 VDD.t374 2.32417
R582 VDD.n642 VDD.n450 0.310155
R583 VDD.n610 VDD.t374 1.57542
R584 VDD.n610 VDD.n448 0.410004
R585 VDD.n611 VDD.t374 2.03143
R586 VDD.n1120 VDD.t374 8.47732
R587 VDD.n1123 VDD.n620 0.35501
R588 VDD.n620 VDD.t374 2.32417
R589 VDD.n445 VDD.t374 2.32406
R590 VDD.n442 VDD.t374 1.57517
R591 VDD.n19 VDD.n20 0.247338
R592 VDD.n20 VDD.t374 0.612695
R593 VDD.t374 VDD.n645 2.32406
R594 VDD.n617 VDD.n618 0.0944268
R595 VDD.n618 VDD.t374 3.32623
R596 VDD.n1129 VDD.t374 8.47732
R597 VDD.n1133 VDD.t374 8.47732
R598 VDD.n1175 VDD.t374 8.47732
R599 VDD.n407 VDD.n406 0.0624236
R600 VDD.t90 VDD.n996 8.47732
R601 VDD.t90 VDD.n993 8.47732
R602 VDD.t90 VDD.n286 2.01278
R603 VDD.t90 VDD.n981 8.47732
R604 VDD.t90 VDD.n989 8.47732
R605 VDD.t90 VDD.n1027 8.47732
R606 VDD.t90 VDD.n701 4.21329
R607 VDD.n400 VDD.t90 1.64355
R608 VDD.n528 VDD.n326 0.147896
R609 VDD.n528 VDD.n526 0.0624233
R610 VDD.n1044 VDD.t90 8.47732
R611 VDD.n699 VDD.t90 4.21329
R612 VDD.t90 VDD.n397 1.64355
R613 VDD.n325 VDD.n323 0.147896
R614 VDD.n525 VDD.n323 0.0624233
R615 VDD.t90 VDD.n1019 8.47732
R616 VDD.t90 VDD.n698 4.21329
R617 VDD.n395 VDD.t90 1.64355
R618 VDD.n523 VDD.n322 0.147896
R619 VDD.n523 VDD.n521 0.0624233
R620 VDD.n1070 VDD.t90 8.47732
R621 VDD.n1071 VDD.n696 0.1666
R622 VDD.t90 VDD.n392 1.64355
R623 VDD.t90 VDD.n1011 8.47732
R624 VDD.n695 VDD.n1009 0.1666
R625 VDD.n390 VDD.t90 1.64355
R626 VDD.n520 VDD.n320 0.147896
R627 VDD.n520 VDD.n518 0.0624233
R628 VDD.n1085 VDD.t90 8.47732
R629 VDD.n1086 VDD.n694 0.1666
R630 VDD.t90 VDD.n387 1.64355
R631 VDD.n406 VDD.n319 0.147747
R632 VDD.t368 VDD.n762 8.47732
R633 VDD.t368 VDD.n742 8.47732
R634 VDD.n11 VDD.n31 0.0889532
R635 VDD.t368 VDD.n903 8.47732
R636 VDD.t368 VDD.n823 8.47732
R637 VDD.t368 VDD.n772 8.47732
R638 VDD.t368 VDD.n768 8.47732
R639 VDD.t456 VDD.n60 0.383001
R640 VDD.t456 VDD.n61 2.03729
R641 VDD.n55 VDD.n54 0.241966
R642 VDD.n411 VDD.t1634 7.62594
R643 VDD.n1345 VDD.t1633 7.62594
R644 VDD.n1428 VDD.t1632 7.62594
R645 VDD.n418 VDD.t1631 7.62594
R646 VDD.n1417 VDD.t1630 7.62594
R647 VDD.n1416 VDD.t1629 7.62594
R648 VDD.n241 VDD.t1628 7.62594
R649 VDD.n1415 VDD.t1627 7.62594
R650 VDD.n1413 VDD.t1626 7.62594
R651 VDD.n421 VDD.t1625 7.62594
R652 VDD.n1391 VDD.t1624 7.62594
R653 VDD.n1390 VDD.t1623 7.62594
R654 VDD.n423 VDD.t1622 7.62594
R655 VDD.n1389 VDD.t1621 7.62594
R656 VDD.n1387 VDD.t1620 7.62594
R657 VDD.n426 VDD.t1619 7.62594
R658 VDD.n1376 VDD.t1618 7.62594
R659 VDD.n1375 VDD.t1617 7.62594
R660 VDD.n414 VDD.t1652 7.62594
R661 VDD.n1585 VDD.t1651 7.62594
R662 VDD.n1668 VDD.t1650 7.62594
R663 VDD.n429 VDD.t1649 7.62594
R664 VDD.n1657 VDD.t1648 7.62594
R665 VDD.n1656 VDD.t1647 7.62594
R666 VDD.n245 VDD.t1646 7.62594
R667 VDD.n1655 VDD.t1645 7.62594
R668 VDD.n1653 VDD.t1644 7.62594
R669 VDD.n432 VDD.t1643 7.62594
R670 VDD.n1631 VDD.t1642 7.62594
R671 VDD.n1630 VDD.t1641 7.62594
R672 VDD.n434 VDD.t1640 7.62594
R673 VDD.n1629 VDD.t1639 7.62594
R674 VDD.n1627 VDD.t1638 7.62594
R675 VDD.n437 VDD.t1637 7.62594
R676 VDD.n1616 VDD.t1636 7.62594
R677 VDD.n1615 VDD.t1635 7.62594
R678 VDD.n408 VDD.t1670 7.62594
R679 VDD.n1813 VDD.t1669 7.62594
R680 VDD.n1896 VDD.t1668 7.62594
R681 VDD.n496 VDD.t1667 7.62594
R682 VDD.n1885 VDD.t1666 7.62594
R683 VDD.n1884 VDD.t1665 7.62594
R684 VDD.n249 VDD.t1664 7.62594
R685 VDD.n1883 VDD.t1663 7.62594
R686 VDD.n1881 VDD.t1662 7.62594
R687 VDD.n499 VDD.t1661 7.62594
R688 VDD.n1859 VDD.t1660 7.62594
R689 VDD.n1858 VDD.t1659 7.62594
R690 VDD.n501 VDD.t1658 7.62594
R691 VDD.n1857 VDD.t1657 7.62594
R692 VDD.n1855 VDD.t1656 7.62594
R693 VDD.n504 VDD.t1655 7.62594
R694 VDD.n1844 VDD.t1654 7.62594
R695 VDD.n1843 VDD.t1653 7.62594
R696 VDD.n402 VDD.t1688 7.62594
R697 VDD.n1226 VDD.t1687 7.62594
R698 VDD.n1310 VDD.t1686 7.62594
R699 VDD.n508 VDD.t1685 7.62594
R700 VDD.n1299 VDD.t1684 7.62594
R701 VDD.n1298 VDD.t1683 7.62594
R702 VDD.n253 VDD.t1682 7.62594
R703 VDD.n1297 VDD.t1681 7.62594
R704 VDD.n1295 VDD.t1680 7.62594
R705 VDD.n511 VDD.t1679 7.62594
R706 VDD.n1273 VDD.t1678 7.62594
R707 VDD.n1272 VDD.t1677 7.62594
R708 VDD.n513 VDD.t1676 7.62594
R709 VDD.n1271 VDD.t1675 7.62594
R710 VDD.n1269 VDD.t1674 7.62594
R711 VDD.n516 VDD.t1673 7.62594
R712 VDD.n1258 VDD.t1672 7.62594
R713 VDD.n1257 VDD.t1671 7.62594
R714 VDD.n405 VDD.t1706 7.62594
R715 VDD.n1004 VDD.t1705 7.62594
R716 VDD.n1087 VDD.t1704 7.62594
R717 VDD.n519 VDD.t1703 7.62594
R718 VDD.n1076 VDD.t1702 7.62594
R719 VDD.n1075 VDD.t1701 7.62594
R720 VDD.n257 VDD.t1700 7.62594
R721 VDD.n1074 VDD.t1699 7.62594
R722 VDD.n1072 VDD.t1698 7.62594
R723 VDD.n522 VDD.t1697 7.62594
R724 VDD.n1050 VDD.t1696 7.62594
R725 VDD.n1049 VDD.t1695 7.62594
R726 VDD.n524 VDD.t1694 7.62594
R727 VDD.n1048 VDD.t1693 7.62594
R728 VDD.n1046 VDD.t1692 7.62594
R729 VDD.n527 VDD.t1691 7.62594
R730 VDD.n1035 VDD.t1690 7.62594
R731 VDD.n1034 VDD.t1689 7.62594
R732 VDD.n1374 VDD.t569 6.16445
R733 VDD.n1614 VDD.t1184 6.16445
R734 VDD.n1842 VDD.t1220 6.16445
R735 VDD.n1256 VDD.t1120 6.16445
R736 VDD.n1033 VDD.t1522 6.16445
R737 VDD.n1467 VDD.t1296 6.09901
R738 VDD.n1547 VDD.t1085 6.09901
R739 VDD.n81 VDD.t1298 6.09901
R740 VDD.n580 VDD.t1046 6.09901
R741 VDD.n578 VDD.t857 6.09901
R742 VDD.n1476 VDD.t927 6.09901
R743 VDD.n1546 VDD.t1299 6.09901
R744 VDD.n84 VDD.t975 6.09901
R745 VDD.n86 VDD.t792 6.09901
R746 VDD.n1545 VDD.t858 6.09901
R747 VDD.n1486 VDD.t954 6.09901
R748 VDD.n271 VDD.t795 6.09901
R749 VDD.n91 VDD.t538 6.09901
R750 VDD.n1544 VDD.t1058 6.09901
R751 VDD.n599 VDD.t932 6.09901
R752 VDD.n1543 VDD.t541 6.09901
R753 VDD.n96 VDD.t811 6.09901
R754 VDD.n575 VDD.t518 6.09901
R755 VDD.n1542 VDD.t935 6.09901
R756 VDD.n1539 VDD.t1113 6.09901
R757 VDD.n1536 VDD.t376 6.09901
R758 VDD.n573 VDD.t521 6.09901
R759 VDD.n571 VDD.t599 6.09901
R760 VDD.n102 VDD.t1011 6.09901
R761 VDD.n240 VDD.t1064 6.09901
R762 VDD.n1507 VDD.t1354 6.09901
R763 VDD.n569 VDD.t979 6.09901
R764 VDD.n1532 VDD.t957 6.09901
R765 VDD.n1531 VDD.t1071 6.09901
R766 VDD.n111 VDD.t936 6.09901
R767 VDD.n1530 VDD.t1357 6.09901
R768 VDD.n1527 VDD.t1118 6.09901
R769 VDD.n567 VDD.t586 6.09901
R770 VDD.n1756 VDD.t785 6.09901
R771 VDD.n1752 VDD.t802 6.09901
R772 VDD.n1761 VDD.t349 6.09901
R773 VDD.n1749 VDD.t1496 6.09901
R774 VDD.n1762 VDD.t1018 6.09901
R775 VDD.n1765 VDD.t532 6.09901
R776 VDD.n1768 VDD.t364 6.09901
R777 VDD.n565 VDD.t409 6.09901
R778 VDD.n1771 VDD.t504 6.09901
R779 VDD.n563 VDD.t561 6.09901
R780 VDD.n557 VDD.t358 6.09901
R781 VDD.n560 VDD.t907 6.09901
R782 VDD.n1732 VDD.t873 6.09901
R783 VDD.n556 VDD.t1014 6.09901
R784 VDD.n126 VDD.t544 6.09901
R785 VDD.n1728 VDD.t919 6.09901
R786 VDD.n131 VDD.t940 6.09901
R787 VDD.n1772 VDD.t778 6.09901
R788 VDD.n1773 VDD.t945 6.09901
R789 VDD.n1774 VDD.t501 6.09901
R790 VDD.n554 VDD.t559 6.09901
R791 VDD.n1775 VDD.t594 6.09901
R792 VDD.n551 VDD.t1503 6.09901
R793 VDD.n145 VDD.t1129 6.09901
R794 VDD.n548 VDD.t910 6.09901
R795 VDD.n1776 VDD.t1027 6.09901
R796 VDD.n157 VDD.t361 6.09901
R797 VDD.n1714 VDD.t1075 6.09901
R798 VDD.n160 VDD.t1248 6.09901
R799 VDD.n1779 VDD.t607 6.09901
R800 VDD.n163 VDD.t1029 6.09901
R801 VDD.n544 VDD.t547 6.09901
R802 VDD.n540 VDD.t351 6.09901
R803 VDD.n543 VDD.t380 6.09901
R804 VDD.n167 VDD.t382 6.09901
R805 VDD.n536 VDD.t784 6.09901
R806 VDD.n539 VDD.t896 6.09901
R807 VDD.n532 VDD.t948 6.09901
R808 VDD.n535 VDD.t402 6.09901
R809 VDD.n1925 VDD.t525 6.09901
R810 VDD.n531 VDD.t597 6.09901
R811 VDD.n492 VDD.t774 6.09901
R812 VDD.n178 VDD.t584 6.09901
R813 VDD.n179 VDD.t1548 6.09901
R814 VDD.n489 VDD.t367 6.09901
R815 VDD.n1926 VDD.t838 6.09901
R816 VDD.n487 VDD.t844 6.09901
R817 VDD.n1927 VDD.t1142 6.09901
R818 VDD.n1928 VDD.t397 6.09901
R819 VDD.n1929 VDD.t800 6.09901
R820 VDD.n484 VDD.t542 6.09901
R821 VDD.n479 VDD.t1130 6.09901
R822 VDD.n476 VDD.t564 6.09901
R823 VDD.n184 VDD.t347 6.09901
R824 VDD.n1918 VDD.t960 6.09901
R825 VDD.n189 VDD.t412 6.09901
R826 VDD.n1930 VDD.t842 6.09901
R827 VDD.n192 VDD.t803 6.09901
R828 VDD.n1931 VDD.t394 6.09901
R829 VDD.n1932 VDD.t414 6.09901
R830 VDD.n470 VDD.t845 6.09901
R831 VDD.n473 VDD.t1025 6.09901
R832 VDD.n1915 VDD.t419 6.09901
R833 VDD.t374 VDD.t980 6.09901
R834 VDD.n21 VDD.t1315 6.09901
R835 VDD.n465 VDD.t1322 6.09901
R836 VDD.n468 VDD.t1043 6.09901
R837 VDD.n1105 VDD.t1323 6.09901
R838 VDD.n7 VDD.t1002 6.09901
R839 VDD.n1106 VDD.t1000 6.09901
R840 VDD.n1107 VDD.t1108 6.09901
R841 VDD.n1110 VDD.t516 6.09901
R842 VDD.n459 VDD.t1336 6.09901
R843 VDD.n462 VDD.t953 6.09901
R844 VDD.n10 VDD.t929 6.09901
R845 VDD.n1 VDD.t1341 6.09901
R846 VDD.n1111 VDD.t375 6.09901
R847 VDD.n205 VDD.t769 6.09901
R848 VDD.n455 VDD.t791 6.09901
R849 VDD.n458 VDD.t771 6.09901
R850 VDD.n1114 VDD.t1087 6.09901
R851 VDD.n1115 VDD.t773 6.09901
R852 VDD.n451 VDD.t1054 6.09901
R853 VDD.n454 VDD.t861 6.09901
R854 VDD.n1118 VDD.t862 6.09901
R855 VDD.n450 VDD.t1110 6.09901
R856 VDD.n448 VDD.t1056 6.09901
R857 VDD.n1123 VDD.t540 6.09901
R858 VDD.n1126 VDD.t1059 6.09901
R859 VDD.n441 VDD.t976 6.09901
R860 VDD.n444 VDD.t978 6.09901
R861 VDD.n19 VDD.t598 6.09901
R862 VDD.n440 VDD.t882 6.09901
R863 VDD.n1127 VDD.t519 6.09901
R864 VDD.n615 VDD.t1265 6.09901
R865 VDD.n966 VDD.t788 6.09901
R866 VDD.n960 VDD.t848 6.09901
R867 VDD.n954 VDD.t1241 6.09901
R868 VDD.n948 VDD.t1100 6.09901
R869 VDD.n942 VDD.t1099 6.09901
R870 VDD.n936 VDD.t552 6.09901
R871 VDD.n930 VDD.t1101 6.09901
R872 VDD.n924 VDD.t369 6.09901
R873 VDD.n918 VDD.t553 6.09901
R874 VDD.n912 VDD.t920 6.09901
R875 VDD.n906 VDD.t555 6.09901
R876 VDD.n898 VDD.t1270 6.09901
R877 VDD.n892 VDD.t1034 6.09901
R878 VDD.n886 VDD.t972 6.09901
R879 VDD.n880 VDD.t508 6.09901
R880 VDD.n874 VDD.t507 6.09901
R881 VDD.n868 VDD.t1078 6.09901
R882 VDD.n862 VDD.t1458 6.09901
R883 VDD.n856 VDD.t973 6.09901
R884 VDD.n850 VDD.t879 6.09901
R885 VDD.n844 VDD.t1459 6.09901
R886 VDD.n838 VDD.t1212 6.09901
R887 VDD.n832 VDD.t924 6.09901
R888 VDD.n826 VDD.t923 6.09901
R889 VDD.n819 VDD.t1575 6.09901
R890 VDD.n813 VDD.t510 6.09901
R891 VDD.n807 VDD.t371 6.09901
R892 VDD.n801 VDD.t853 6.09901
R893 VDD.n795 VDD.t1581 6.09901
R894 VDD.n789 VDD.t925 6.09901
R895 VDD.n783 VDD.t512 6.09901
R896 VDD.n777 VDD.t372 6.09901
R897 VDD.n1429 VDD.t1006 5.99122
R898 VDD.n329 VDD.t1049 5.99122
R899 VDD.n1414 VDD.t539 5.99122
R900 VDD.n334 VDD.t377 5.99122
R901 VDD.n1388 VDD.t939 5.99122
R902 VDD.n339 VDD.t775 5.99122
R903 VDD.n1669 VDD.t1229 5.99122
R904 VDD.n344 VDD.t410 5.99122
R905 VDD.n1654 VDD.t906 5.99122
R906 VDD.n349 VDD.t1003 5.99122
R907 VDD.n1628 VDD.t1128 5.99122
R908 VDD.n354 VDD.t1160 5.99122
R909 VDD.n1897 VDD.t606 5.99122
R910 VDD.n359 VDD.t393 5.99122
R911 VDD.n1882 VDD.t1494 5.99122
R912 VDD.n364 VDD.t835 5.99122
R913 VDD.n1856 VDD.t411 5.99122
R914 VDD.n369 VDD.t413 5.99122
R915 VDD.n1311 VDD.t1326 5.99122
R916 VDD.n374 VDD.t515 5.99122
R917 VDD.n1296 VDD.t1344 5.99122
R918 VDD.n379 VDD.t860 5.99122
R919 VDD.n1270 VDD.t1429 5.99122
R920 VDD.n384 VDD.t813 5.99122
R921 VDD.n1088 VDD.t1386 5.99122
R922 VDD.n389 VDD.t554 5.99122
R923 VDD.n1073 VDD.t1036 5.99122
R924 VDD.n394 VDD.t1393 5.99122
R925 VDD.n1047 VDD.t1387 5.99122
R926 VDD.n399 VDD.t1362 5.99122
R927 VDD.n228 VDD.t356 5.9886
R928 VDD.n238 VDD.t915 5.98839
R929 VDD.n236 VDD.t1095 5.98839
R930 VDD.n234 VDD.t390 5.98839
R931 VDD.n232 VDD.t815 5.98839
R932 VDD.n230 VDD.t1233 5.98839
R933 VDD.n702 VDD.t914 5.97675
R934 VDD.n702 VDD.t814 5.97675
R935 VDD.n1323 VDD.t1235 5.97169
R936 VDD.n273 VDD.t1227 5.97169
R937 VDD.n1335 VDD.t1267 5.97169
R938 VDD.n238 VDD.t1261 5.97169
R939 VDD.n1563 VDD.t1081 5.97169
R940 VDD.n276 VDD.t1272 5.97169
R941 VDD.n1575 VDD.t1314 5.97169
R942 VDD.n236 VDD.t1274 5.97169
R943 VDD.n1791 VDD.t982 5.97169
R944 VDD.n279 VDD.t782 5.97169
R945 VDD.n1803 VDD.t1023 5.97169
R946 VDD.n234 VDD.t1074 5.97169
R947 VDD.n1204 VDD.t1364 5.97169
R948 VDD.n282 VDD.t1607 5.97169
R949 VDD.n1216 VDD.t865 5.97169
R950 VDD.n232 VDD.t1400 5.97169
R951 VDD.n982 VDD.t1366 5.97169
R952 VDD.n285 VDD.t1218 5.97169
R953 VDD.n994 VDD.t1246 5.97169
R954 VDD.n230 VDD.t1389 5.97169
R955 VDD.n1323 VDD.t1535 5.97146
R956 VDD.n273 VDD.t1097 5.97146
R957 VDD.n1335 VDD.t1280 5.97146
R958 VDD.n238 VDD.t869 5.97146
R959 VDD.n1563 VDD.t1437 5.97146
R960 VDD.n276 VDD.t1423 5.97146
R961 VDD.n1575 VDD.t1411 5.97146
R962 VDD.n236 VDD.t1406 5.97146
R963 VDD.n1791 VDD.t1533 5.97146
R964 VDD.n279 VDD.t1240 5.97146
R965 VDD.n1803 VDD.t1157 5.97146
R966 VDD.n234 VDD.t389 5.97146
R967 VDD.n1204 VDD.t1232 5.97146
R968 VDD.n282 VDD.t535 5.97146
R969 VDD.n1216 VDD.t878 5.97146
R970 VDD.n232 VDD.t938 5.97146
R971 VDD.n982 VDD.t1427 5.97146
R972 VDD.n285 VDD.t1598 5.97146
R973 VDD.n994 VDD.t1596 5.97146
R974 VDD.n230 VDD.t1441 5.97146
R975 VDD.n412 VDD.t42 5.96935
R976 VDD.n287 VDD.t323 5.96935
R977 VDD.n287 VDD.t95 5.96935
R978 VDD.n328 VDD.t153 5.96935
R979 VDD.n328 VDD.t239 5.96935
R980 VDD.n419 VDD.t59 5.96935
R981 VDD.n1427 VDD.t156 5.96935
R982 VDD.n288 VDD.t159 5.96935
R983 VDD.n288 VDD.t94 5.96935
R984 VDD.n331 VDD.t129 5.96935
R985 VDD.n331 VDD.t194 5.96935
R986 VDD.n243 VDD.t28 5.96935
R987 VDD.n663 VDD.t132 5.96935
R988 VDD.n242 VDD.t133 5.96935
R989 VDD.n242 VDD.t66 5.96935
R990 VDD.n333 VDD.t228 5.96935
R991 VDD.n333 VDD.t227 5.96935
R992 VDD.n422 VDD.t1616 5.96935
R993 VDD.n1412 VDD.t231 5.96935
R994 VDD.n290 VDD.t3 5.96935
R995 VDD.n290 VDD.t71 5.96935
R996 VDD.n336 VDD.t308 5.96935
R997 VDD.n336 VDD.t17 5.96935
R998 VDD.n291 VDD.t1615 5.96935
R999 VDD.n666 VDD.t311 5.96935
R1000 VDD.n293 VDD.t8 5.96935
R1001 VDD.n293 VDD.t19 5.96935
R1002 VDD.n338 VDD.t173 5.96935
R1003 VDD.n338 VDD.t15 5.96935
R1004 VDD.n427 VDD.t232 5.96935
R1005 VDD.n1386 VDD.t196 5.96935
R1006 VDD.n294 VDD.t312 5.96935
R1007 VDD.n294 VDD.t192 5.96935
R1008 VDD.n341 VDD.t326 5.96935
R1009 VDD.n341 VDD.t325 5.96935
R1010 VDD.n1366 VDD.t329 5.96935
R1011 VDD.n415 VDD.t48 5.96935
R1012 VDD.n295 VDD.t51 5.96935
R1013 VDD.n295 VDD.t50 5.96935
R1014 VDD.n343 VDD.t55 5.96935
R1015 VDD.n343 VDD.t54 5.96935
R1016 VDD.n430 VDD.t111 5.96935
R1017 VDD.n1667 VDD.t58 5.96935
R1018 VDD.n296 VDD.t115 5.96935
R1019 VDD.n296 VDD.t114 5.96935
R1020 VDD.n346 VDD.t119 5.96935
R1021 VDD.n346 VDD.t118 5.96935
R1022 VDD.n247 VDD.t30 5.96935
R1023 VDD.n1590 VDD.t122 5.96935
R1024 VDD.n246 VDD.t34 5.96935
R1025 VDD.n246 VDD.t33 5.96935
R1026 VDD.n348 VDD.t38 5.96935
R1027 VDD.n348 VDD.t37 5.96935
R1028 VDD.n433 VDD.t77 5.96935
R1029 VDD.n1652 VDD.t41 5.96935
R1030 VDD.n298 VDD.t81 5.96935
R1031 VDD.n298 VDD.t80 5.96935
R1032 VDD.n351 VDD.t85 5.96935
R1033 VDD.n351 VDD.t84 5.96935
R1034 VDD.n299 VDD.t137 5.96935
R1035 VDD.n674 VDD.t88 5.96935
R1036 VDD.n301 VDD.t141 5.96935
R1037 VDD.n301 VDD.t140 5.96935
R1038 VDD.n353 VDD.t145 5.96935
R1039 VDD.n353 VDD.t144 5.96935
R1040 VDD.n438 VDD.t72 5.96935
R1041 VDD.n1626 VDD.t234 5.96935
R1042 VDD.n302 VDD.t46 5.96935
R1043 VDD.n302 VDD.t45 5.96935
R1044 VDD.n356 VDD.t123 5.96935
R1045 VDD.n356 VDD.t76 5.96935
R1046 VDD.n677 VDD.t126 5.96935
R1047 VDD.n409 VDD.t96 5.96935
R1048 VDD.n303 VDD.t99 5.96935
R1049 VDD.n303 VDD.t98 5.96935
R1050 VDD.n358 VDD.t103 5.96935
R1051 VDD.n358 VDD.t102 5.96935
R1052 VDD.n497 VDD.t161 5.96935
R1053 VDD.n1895 VDD.t106 5.96935
R1054 VDD.n304 VDD.t165 5.96935
R1055 VDD.n304 VDD.t164 5.96935
R1056 VDD.n361 VDD.t169 5.96935
R1057 VDD.n361 VDD.t168 5.96935
R1058 VDD.n251 VDD.t214 5.96935
R1059 VDD.n1818 VDD.t172 5.96935
R1060 VDD.n250 VDD.t218 5.96935
R1061 VDD.n250 VDD.t217 5.96935
R1062 VDD.n363 VDD.t222 5.96935
R1063 VDD.n363 VDD.t221 5.96935
R1064 VDD.n500 VDD.t265 5.96935
R1065 VDD.n1880 VDD.t225 5.96935
R1066 VDD.n306 VDD.t269 5.96935
R1067 VDD.n306 VDD.t268 5.96935
R1068 VDD.n366 VDD.t273 5.96935
R1069 VDD.n366 VDD.t272 5.96935
R1070 VDD.n307 VDD.t277 5.96935
R1071 VDD.n682 VDD.t276 5.96935
R1072 VDD.n309 VDD.t281 5.96935
R1073 VDD.n309 VDD.t280 5.96935
R1074 VDD.n368 VDD.t285 5.96935
R1075 VDD.n368 VDD.t284 5.96935
R1076 VDD.n505 VDD.t237 5.96935
R1077 VDD.n1854 VDD.t69 5.96935
R1078 VDD.n310 VDD.t304 5.96935
R1079 VDD.n310 VDD.t128 5.96935
R1080 VDD.n371 VDD.t294 5.96935
R1081 VDD.n371 VDD.t293 5.96935
R1082 VDD.n685 VDD.t297 5.96935
R1083 VDD.n403 VDD.t6 5.96935
R1084 VDD.n311 VDD.t73 5.96935
R1085 VDD.n311 VDD.t89 5.96935
R1086 VDD.n373 VDD.t10 5.96935
R1087 VDD.n373 VDD.t110 5.96935
R1088 VDD.n509 VDD.t61 5.96935
R1089 VDD.n1309 VDD.t13 5.96935
R1090 VDD.n312 VDD.t240 5.96935
R1091 VDD.n312 VDD.t318 5.96935
R1092 VDD.n376 VDD.t22 5.96935
R1093 VDD.n376 VDD.t21 5.96935
R1094 VDD.n255 VDD.t63 5.96935
R1095 VDD.n1231 VDD.t25 5.96935
R1096 VDD.n254 VDD.t290 5.96935
R1097 VDD.n254 VDD.t236 5.96935
R1098 VDD.n378 VDD.t316 5.96935
R1099 VDD.n378 VDD.t315 5.96935
R1100 VDD.n512 VDD.t288 5.96935
R1101 VDD.n1294 VDD.t287 5.96935
R1102 VDD.n314 VDD.t26 5.96935
R1103 VDD.n314 VDD.t201 5.96935
R1104 VDD.n381 VDD.t187 5.96935
R1105 VDD.n381 VDD.t108 5.96935
R1106 VDD.n315 VDD.t135 5.96935
R1107 VDD.n690 VDD.t190 5.96935
R1108 VDD.n317 VDD.t289 5.96935
R1109 VDD.n317 VDD.t320 5.96935
R1110 VDD.n383 VDD.t262 5.96935
R1111 VDD.n383 VDD.t264 5.96935
R1112 VDD.n517 VDD.t157 5.96935
R1113 VDD.n1268 VDD.t199 5.96935
R1114 VDD.n318 VDD.t197 5.96935
R1115 VDD.n318 VDD.t322 5.96935
R1116 VDD.n386 VDD.t149 5.96935
R1117 VDD.n386 VDD.t148 5.96935
R1118 VDD.n1248 VDD.t152 5.96935
R1119 VDD.n406 VDD.t330 5.96935
R1120 VDD.n319 VDD.t333 5.96935
R1121 VDD.n319 VDD.t332 5.96935
R1122 VDD.n388 VDD.t337 5.96935
R1123 VDD.n388 VDD.t336 5.96935
R1124 VDD.n520 VDD.t250 5.96935
R1125 VDD.n1086 VDD.t340 5.96935
R1126 VDD.n320 VDD.t254 5.96935
R1127 VDD.n320 VDD.t253 5.96935
R1128 VDD.n391 VDD.t258 5.96935
R1129 VDD.n391 VDD.t257 5.96935
R1130 VDD.n259 VDD.t202 5.96935
R1131 VDD.n1009 VDD.t261 5.96935
R1132 VDD.n258 VDD.t206 5.96935
R1133 VDD.n258 VDD.t205 5.96935
R1134 VDD.n393 VDD.t210 5.96935
R1135 VDD.n393 VDD.t209 5.96935
R1136 VDD.n523 VDD.t175 5.96935
R1137 VDD.n1071 VDD.t213 5.96935
R1138 VDD.n322 VDD.t179 5.96935
R1139 VDD.n322 VDD.t178 5.96935
R1140 VDD.n396 VDD.t183 5.96935
R1141 VDD.n396 VDD.t182 5.96935
R1142 VDD.n323 VDD.t241 5.96935
R1143 VDD.n697 VDD.t186 5.96935
R1144 VDD.n325 VDD.t245 5.96935
R1145 VDD.n325 VDD.t244 5.96935
R1146 VDD.n398 VDD.t249 5.96935
R1147 VDD.n398 VDD.t248 5.96935
R1148 VDD.n528 VDD.t1614 5.96935
R1149 VDD.n1045 VDD.t92 5.96935
R1150 VDD.n326 VDD.t307 5.96935
R1151 VDD.n326 VDD.t306 5.96935
R1152 VDD.n401 VDD.t300 5.96935
R1153 VDD.n401 VDD.t299 5.96935
R1154 VDD.n700 VDD.t303 5.96935
R1155 VDD.n1314 VDD.t1413 5.96534
R1156 VDD.n1326 VDD.t1451 5.96534
R1157 VDD.n238 VDD.t536 5.96534
R1158 VDD.n1320 VDD.t1367 5.96534
R1159 VDD.n1318 VDD.t1144 5.96534
R1160 VDD.n1340 VDD.t1372 5.96534
R1161 VDD.n1342 VDD.t1294 5.96534
R1162 VDD.n1315 VDD.t577 5.96534
R1163 VDD.n412 VDD.t1333 5.96534
R1164 VDD.n287 VDD.t568 5.96534
R1165 VDD.n287 VDD.t1045 5.96534
R1166 VDD.n328 VDD.t385 5.96534
R1167 VDD.n1425 VDD.t573 5.96534
R1168 VDD.n1423 VDD.t928 5.96534
R1169 VDD.n1419 VDD.t1190 5.96534
R1170 VDD.n419 VDD.t847 5.96534
R1171 VDD.n288 VDD.t1277 5.96534
R1172 VDD.n288 VDD.t1050 5.96534
R1173 VDD.n331 VDD.t1370 5.96534
R1174 VDD.n1350 VDD.t574 5.96534
R1175 VDD.n1348 VDD.t859 5.96534
R1176 VDD.n1354 VDD.t1191 5.96534
R1177 VDD.n243 VDD.t897 5.96534
R1178 VDD.n242 VDD.t570 5.96534
R1179 VDD.n242 VDD.t794 5.96534
R1180 VDD.n333 VDD.t1373 5.96534
R1181 VDD.n1410 VDD.t578 5.96534
R1182 VDD.n1408 VDD.t1057 5.96534
R1183 VDD.n1404 VDD.t969 5.96534
R1184 VDD.n1402 VDD.t933 5.96534
R1185 VDD.n50 VDD.t1610 5.96534
R1186 VDD.n50 VDD.t1523 5.96534
R1187 VDD.n1401 VDD.t1368 5.96534
R1188 VDD.n270 VDD.t787 5.96534
R1189 VDD.n1399 VDD.t572 5.96534
R1190 VDD.n1397 VDD.t517 5.96534
R1191 VDD.n1393 VDD.t1189 5.96534
R1192 VDD.n422 VDD.t934 5.96534
R1193 VDD.n290 VDD.t971 5.96534
R1194 VDD.n290 VDD.t1114 5.96534
R1195 VDD.n336 VDD.t1369 5.96534
R1196 VDD.n1358 VDD.t575 5.96534
R1197 VDD.n1356 VDD.t520 5.96534
R1198 VDD.n1362 VDD.t1192 5.96534
R1199 VDD.n291 VDD.t600 5.96534
R1200 VDD.n293 VDD.t571 5.96534
R1201 VDD.n293 VDD.t1115 5.96534
R1202 VDD.n338 VDD.t1374 5.96534
R1203 VDD.n1384 VDD.t579 5.96534
R1204 VDD.n1382 VDD.t1355 5.96534
R1205 VDD.n1378 VDD.t970 5.96534
R1206 VDD.n427 VDD.t911 5.96534
R1207 VDD.n294 VDD.t1611 5.96534
R1208 VDD.n294 VDD.t1089 5.96534
R1209 VDD.n341 VDD.t825 5.96534
R1210 VDD.n1367 VDD.t1371 5.96534
R1211 VDD.n1364 VDD.t1485 5.96534
R1212 VDD.n1371 VDD.t576 5.96534
R1213 VDD.n1373 VDD.t961 5.96534
R1214 VDD.n1554 VDD.t1561 5.96534
R1215 VDD.n1566 VDD.t1153 5.96534
R1216 VDD.n236 VDD.t1216 5.96534
R1217 VDD.n1560 VDD.t1103 5.96534
R1218 VDD.n1558 VDD.t587 5.96534
R1219 VDD.n1580 VDD.t1375 5.96534
R1220 VDD.n1582 VDD.t786 5.96534
R1221 VDD.n1555 VDD.t822 5.96534
R1222 VDD.n415 VDD.t908 5.96534
R1223 VDD.n295 VDD.t1183 5.96534
R1224 VDD.n295 VDD.t350 5.96534
R1225 VDD.n343 VDD.t1310 5.96534
R1226 VDD.n1665 VDD.t1082 5.96534
R1227 VDD.n1663 VDD.t1019 5.96534
R1228 VDD.n1659 VDD.t1200 5.96534
R1229 VDD.n430 VDD.t1152 5.96534
R1230 VDD.n296 VDD.t1309 5.96534
R1231 VDD.n296 VDD.t365 5.96534
R1232 VDD.n346 VDD.t1106 5.96534
R1233 VDD.n1591 VDD.t1083 5.96534
R1234 VDD.n1588 VDD.t505 5.96534
R1235 VDD.n1595 VDD.t1201 5.96534
R1236 VDD.n247 VDD.t562 5.96534
R1237 VDD.n246 VDD.t1185 5.96534
R1238 VDD.n246 VDD.t1505 5.96534
R1239 VDD.n348 VDD.t1376 5.96534
R1240 VDD.n1650 VDD.t823 5.96534
R1241 VDD.n1648 VDD.t874 5.96534
R1242 VDD.n1644 VDD.t1203 5.96534
R1243 VDD.n1642 VDD.t1013 5.96534
R1244 VDD.n48 VDD.t1187 5.96534
R1245 VDD.n48 VDD.t545 5.96534
R1246 VDD.n1641 VDD.t1104 5.96534
R1247 VDD.n268 VDD.t1249 5.96534
R1248 VDD.n1639 VDD.t820 5.96534
R1249 VDD.n1637 VDD.t1016 5.96534
R1250 VDD.n1633 VDD.t1199 5.96534
R1251 VDD.n433 VDD.t779 5.96534
R1252 VDD.n298 VDD.t1166 5.96534
R1253 VDD.n298 VDD.t1136 5.96534
R1254 VDD.n351 VDD.t1105 5.96534
R1255 VDD.n1599 VDD.t1084 5.96534
R1256 VDD.n1597 VDD.t560 5.96534
R1257 VDD.n1603 VDD.t1202 5.96534
R1258 VDD.n299 VDD.t595 5.96534
R1259 VDD.n301 VDD.t1186 5.96534
R1260 VDD.n301 VDD.t1504 5.96534
R1261 VDD.n353 VDD.t1377 5.96534
R1262 VDD.n1624 VDD.t824 5.96534
R1263 VDD.n1622 VDD.t1021 5.96534
R1264 VDD.n1618 VDD.t1204 5.96534
R1265 VDD.n438 VDD.t1028 5.96534
R1266 VDD.n302 VDD.t1188 5.96534
R1267 VDD.n302 VDD.t360 5.96534
R1268 VDD.n356 VDD.t1311 5.96534
R1269 VDD.n1607 VDD.t1308 5.96534
R1270 VDD.n1605 VDD.t1252 5.96534
R1271 VDD.n1611 VDD.t821 5.96534
R1272 VDD.n1613 VDD.t1289 5.96534
R1273 VDD.n1782 VDD.t1469 5.96534
R1274 VDD.n1794 VDD.t1556 5.96534
R1275 VDD.n234 VDD.t395 5.96534
R1276 VDD.n1788 VDD.t1194 5.96534
R1277 VDD.n1786 VDD.t359 5.96534
R1278 VDD.n1808 VDD.t884 5.96534
R1279 VDD.n1810 VDD.t363 5.96534
R1280 VDD.n1783 VDD.t1065 5.96534
R1281 VDD.n409 VDD.t379 5.96534
R1282 VDD.n303 VDD.t1219 5.96534
R1283 VDD.n303 VDD.t383 5.96534
R1284 VDD.n358 VDD.t1526 5.96534
R1285 VDD.n1893 VDD.t1039 5.96534
R1286 VDD.n1891 VDD.t895 5.96534
R1287 VDD.n1887 VDD.t1443 5.96534
R1288 VDD.n497 VDD.t1148 5.96534
R1289 VDD.n304 VDD.t1291 5.96534
R1290 VDD.n304 VDD.t1472 5.96534
R1291 VDD.n361 VDD.t1195 5.96534
R1292 VDD.n1819 VDD.t1040 5.96534
R1293 VDD.n1816 VDD.t1256 5.96534
R1294 VDD.n1823 VDD.t1285 5.96534
R1295 VDD.n251 VDD.t415 5.96534
R1296 VDD.n250 VDD.t1221 5.96534
R1297 VDD.n250 VDD.t585 5.96534
R1298 VDD.n363 VDD.t885 5.96534
R1299 VDD.n1878 VDD.t1066 5.96534
R1300 VDD.n1876 VDD.t366 5.96534
R1301 VDD.n1872 VDD.t1287 5.96534
R1302 VDD.n1870 VDD.t837 5.96534
R1303 VDD.n46 VDD.t1236 5.96534
R1304 VDD.n46 VDD.t843 5.96534
R1305 VDD.n1869 VDD.t883 5.96534
R1306 VDD.n266 VDD.t898 5.96534
R1307 VDD.n1867 VDD.t1038 5.96534
R1308 VDD.n1865 VDD.t396 5.96534
R1309 VDD.n1861 VDD.t1442 5.96534
R1310 VDD.n500 VDD.t799 5.96534
R1311 VDD.n306 VDD.t1206 5.96534
R1312 VDD.n306 VDD.t543 5.96534
R1313 VDD.n366 VDD.t1196 5.96534
R1314 VDD.n1827 VDD.t1041 5.96534
R1315 VDD.n1825 VDD.t563 5.96534
R1316 VDD.n1831 VDD.t1286 5.96534
R1317 VDD.n307 VDD.t345 5.96534
R1318 VDD.n309 VDD.t1222 5.96534
R1319 VDD.n309 VDD.t1093 5.96534
R1320 VDD.n368 VDD.t886 5.96534
R1321 VDD.n1852 VDD.t1067 5.96534
R1322 VDD.n1850 VDD.t966 5.96534
R1323 VDD.n1846 VDD.t1288 5.96534
R1324 VDD.n505 VDD.t529 5.96534
R1325 VDD.n310 VDD.t1237 5.96534
R1326 VDD.n310 VDD.t1552 5.96534
R1327 VDD.n371 VDD.t1525 5.96534
R1328 VDD.n1835 VDD.t887 5.96534
R1329 VDD.n1833 VDD.t1537 5.96534
R1330 VDD.n1839 VDD.t1042 5.96534
R1331 VDD.n1841 VDD.t1026 5.96534
R1332 VDD.n1195 VDD.t902 5.96534
R1333 VDD.n1207 VDD.t899 5.96534
R1334 VDD.n232 VDD.t1390 5.96534
R1335 VDD.n1201 VDD.t1379 5.96534
R1336 VDD.n1199 VDD.t1319 5.96534
R1337 VDD.n1221 VDD.t1384 5.96534
R1338 VDD.n1223 VDD.t1316 5.96534
R1339 VDD.n1196 VDD.t342 5.96534
R1340 VDD.n403 VDD.t1395 5.96534
R1341 VDD.n311 VDD.t1119 5.96534
R1342 VDD.n311 VDD.t1044 5.96534
R1343 VDD.n373 VDD.t1198 5.96534
R1344 VDD.n1307 VDD.t832 5.96534
R1345 VDD.n1305 VDD.t1329 5.96534
R1346 VDD.n1301 VDD.t1179 5.96534
R1347 VDD.n509 VDD.t1001 5.96534
R1348 VDD.n312 VDD.t819 5.96534
R1349 VDD.n312 VDD.t1107 5.96534
R1350 VDD.n376 VDD.t1382 5.96534
R1351 VDD.n1232 VDD.t833 5.96534
R1352 VDD.n1229 VDD.t1340 5.96534
R1353 VDD.n1236 VDD.t1180 5.96534
R1354 VDD.n255 VDD.t1335 5.96534
R1355 VDD.n254 VDD.t1121 5.96534
R1356 VDD.n254 VDD.t1302 5.96534
R1357 VDD.n378 VDD.t1385 5.96534
R1358 VDD.n1292 VDD.t1181 5.96534
R1359 VDD.n1290 VDD.t930 5.96534
R1360 VDD.n1286 VDD.t1126 5.96534
R1361 VDD.n1284 VDD.t770 5.96534
R1362 VDD.n44 VDD.t1175 5.96534
R1363 VDD.n44 VDD.t790 5.96534
R1364 VDD.n1283 VDD.t1380 5.96534
R1365 VDD.n264 VDD.t772 5.96534
R1366 VDD.n1281 VDD.t831 5.96534
R1367 VDD.n1279 VDD.t1345 5.96534
R1368 VDD.n1275 VDD.t1178 5.96534
R1369 VDD.n512 VDD.t1053 5.96534
R1370 VDD.n314 VDD.t506 5.96534
R1371 VDD.n314 VDD.t1481 5.96534
R1372 VDD.n381 VDD.t1381 5.96534
R1373 VDD.n1240 VDD.t834 5.96534
R1374 VDD.n1238 VDD.t863 5.96534
R1375 VDD.n1244 VDD.t1174 5.96534
R1376 VDD.n315 VDD.t1111 5.96534
R1377 VDD.n317 VDD.t1122 5.96534
R1378 VDD.n317 VDD.t1055 5.96534
R1379 VDD.n383 VDD.t1378 5.96534
R1380 VDD.n1266 VDD.t1182 5.96534
R1381 VDD.n1264 VDD.t1588 5.96534
R1382 VDD.n1260 VDD.t1127 5.96534
R1383 VDD.n517 VDD.t977 5.96534
R1384 VDD.n318 VDD.t1176 5.96534
R1385 VDD.n318 VDD.t1060 5.96534
R1386 VDD.n386 VDD.t1197 5.96534
R1387 VDD.n1249 VDD.t1383 5.96534
R1388 VDD.n1246 VDD.t1348 5.96534
R1389 VDD.n1253 VDD.t343 5.96534
R1390 VDD.n1255 VDD.t1305 5.96534
R1391 VDD.n973 VDD.t416 5.96534
R1392 VDD.n985 VDD.t353 5.96534
R1393 VDD.n230 VDD.t1398 5.96534
R1394 VDD.n979 VDD.t1177 5.96534
R1395 VDD.n977 VDD.t789 5.96534
R1396 VDD.n999 VDD.t1284 5.96534
R1397 VDD.n1001 VDD.t849 5.96534
R1398 VDD.n974 VDD.t1207 5.96534
R1399 VDD.n406 VDD.t1243 5.96534
R1400 VDD.n319 VDD.t1521 5.96534
R1401 VDD.n319 VDD.t1476 5.96534
R1402 VDD.n388 VDD.t801 5.96534
R1403 VDD.n1084 VDD.t387 5.96534
R1404 VDD.n1082 VDD.t950 5.96534
R1405 VDD.n1078 VDD.t549 5.96534
R1406 VDD.n520 VDD.t1269 5.96534
R1407 VDD.n320 VDD.t1072 5.96534
R1408 VDD.n320 VDD.t1031 5.96534
R1409 VDD.n391 VDD.t1193 5.96534
R1410 VDD.n1010 VDD.t1608 5.96534
R1411 VDD.n1007 VDD.t1077 5.96534
R1412 VDD.n1014 VDD.t550 5.96534
R1413 VDD.n259 VDD.t556 5.96534
R1414 VDD.n258 VDD.t921 5.96534
R1415 VDD.n258 VDD.t1515 5.96534
R1416 VDD.n393 VDD.t1158 5.96534
R1417 VDD.n1069 VDD.t1124 5.96534
R1418 VDD.n1067 VDD.t1033 5.96534
R1419 VDD.n1063 VDD.t522 5.96534
R1420 VDD.n1061 VDD.t509 5.96534
R1421 VDD.n42 VDD.t502 5.96534
R1422 VDD.n42 VDD.t851 5.96534
R1423 VDD.n1060 VDD.t1613 5.96534
R1424 VDD.n262 VDD.t1079 5.96534
R1425 VDD.n1058 VDD.t386 5.96534
R1426 VDD.n1056 VDD.t1457 5.96534
R1427 VDD.n1052 VDD.t548 5.96534
R1428 VDD.n523 VDD.t974 5.96534
R1429 VDD.n322 VDD.t881 5.96534
R1430 VDD.n322 VDD.t1209 5.96534
R1431 VDD.n396 VDD.t1435 5.96534
R1432 VDD.n1018 VDD.t1609 5.96534
R1433 VDD.n1016 VDD.t1461 5.96534
R1434 VDD.n1022 VDD.t551 5.96534
R1435 VDD.n323 VDD.t1350 5.96534
R1436 VDD.n325 VDD.t922 5.96534
R1437 VDD.n325 VDD.t1516 5.96534
R1438 VDD.n398 VDD.t880 5.96534
R1439 VDD.n1043 VDD.t1125 5.96534
R1440 VDD.n1041 VDD.t511 5.96534
R1441 VDD.n1037 VDD.t523 5.96534
R1442 VDD.n528 VDD.t370 5.96534
R1443 VDD.n326 VDD.t503 5.96534
R1444 VDD.n326 VDD.t854 5.96534
R1445 VDD.n401 VDD.t1434 5.96534
R1446 VDD.n1026 VDD.t1508 5.96534
R1447 VDD.n1024 VDD.t1580 5.96534
R1448 VDD.n1030 VDD.t926 5.96534
R1449 VDD.n1032 VDD.t1360 5.96534
R1450 VDD.n1343 VDD.t892 5.96512
R1451 VDD.n1314 VDD.t1171 5.96512
R1452 VDD.n1326 VDD.t1162 5.96512
R1453 VDD.n1421 VDD.t889 5.96512
R1454 VDD.n1352 VDD.t1487 5.96512
R1455 VDD.n1395 VDD.t1489 5.96512
R1456 VDD.n50 VDD.t1612 5.96512
R1457 VDD.n1406 VDD.t1488 5.96512
R1458 VDD.n1360 VDD.t890 5.96512
R1459 VDD.n1380 VDD.t891 5.96512
R1460 VDD.n1369 VDD.t888 5.96512
R1461 VDD.n1583 VDD.t378 5.96512
R1462 VDD.n1554 VDD.t526 5.96512
R1463 VDD.n1566 VDD.t806 5.96512
R1464 VDD.n1661 VDD.t601 5.96512
R1465 VDD.n1593 VDD.t855 5.96512
R1466 VDD.n1635 VDD.t1 5.96512
R1467 VDD.n48 VDD.t1509 5.96512
R1468 VDD.n1646 VDD.t856 5.96512
R1469 VDD.n1601 VDD.t602 5.96512
R1470 VDD.n1620 VDD.t603 5.96512
R1471 VDD.n1609 VDD.t952 5.96512
R1472 VDD.n1811 VDD.t1292 5.96512
R1473 VDD.n1782 VDD.t1546 5.96512
R1474 VDD.n1794 VDD.t809 5.96512
R1475 VDD.n1889 VDD.t1091 5.96512
R1476 VDD.n1821 VDD.t1278 5.96512
R1477 VDD.n1863 VDD.t1282 5.96512
R1478 VDD.n46 VDD.t1024 5.96512
R1479 VDD.n1874 VDD.t1293 5.96512
R1480 VDD.n1829 VDD.t1092 5.96512
R1481 VDD.n1848 VDD.t596 5.96512
R1482 VDD.n1837 VDD.t1062 5.96512
R1483 VDD.n1224 VDD.t1173 5.96512
R1484 VDD.n1195 VDD.t1456 5.96512
R1485 VDD.n1207 VDD.t565 5.96512
R1486 VDD.n1303 VDD.t826 5.96512
R1487 VDD.n1234 VDD.t829 5.96512
R1488 VDD.n1277 VDD.t344 5.96512
R1489 VDD.n44 VDD.t591 5.96512
R1490 VDD.n1288 VDD.t830 5.96512
R1491 VDD.n1242 VDD.t827 5.96512
R1492 VDD.n1262 VDD.t828 5.96512
R1493 VDD.n1251 VDD.t341 5.96512
R1494 VDD.n1002 VDD.t1529 5.96512
R1495 VDD.n973 VDD.t588 5.96512
R1496 VDD.n985 VDD.t1464 5.96512
R1497 VDD.n1080 VDD.t817 5.96512
R1498 VDD.n1012 VDD.t1530 5.96512
R1499 VDD.n1054 VDD.t1412 5.96512
R1500 VDD.n42 VDD.t1463 5.96512
R1501 VDD.n1065 VDD.t1123 5.96512
R1502 VDD.n1020 VDD.t818 5.96512
R1503 VDD.n1039 VDD.t1132 5.96512
R1504 VDD.n1028 VDD.t1205 5.96512
R1505 VDD.n228 VDD.t1501 5.96478
R1506 VDD.n411 VDD.t43 5.65005
R1507 VDD.n1345 VDD.t238 5.65005
R1508 VDD.n1428 VDD.t154 5.65005
R1509 VDD.n418 VDD.t60 5.65005
R1510 VDD.n1417 VDD.t160 5.65005
R1511 VDD.n1416 VDD.t130 5.65005
R1512 VDD.n241 VDD.t29 5.65005
R1513 VDD.n1415 VDD.t134 5.65005
R1514 VDD.n1413 VDD.t229 5.65005
R1515 VDD.n421 VDD.t70 5.65005
R1516 VDD.n1391 VDD.t4 5.65005
R1517 VDD.n1390 VDD.t309 5.65005
R1518 VDD.n423 VDD.t18 5.65005
R1519 VDD.n1389 VDD.t9 5.65005
R1520 VDD.n1387 VDD.t174 5.65005
R1521 VDD.n426 VDD.t191 5.65005
R1522 VDD.n1376 VDD.t313 5.65005
R1523 VDD.n1375 VDD.t327 5.65005
R1524 VDD.n414 VDD.t49 5.65005
R1525 VDD.n1585 VDD.t52 5.65005
R1526 VDD.n1668 VDD.t56 5.65005
R1527 VDD.n429 VDD.t112 5.65005
R1528 VDD.n1657 VDD.t116 5.65005
R1529 VDD.n1656 VDD.t120 5.65005
R1530 VDD.n245 VDD.t31 5.65005
R1531 VDD.n1655 VDD.t35 5.65005
R1532 VDD.n1653 VDD.t39 5.65005
R1533 VDD.n432 VDD.t78 5.65005
R1534 VDD.n1631 VDD.t82 5.65005
R1535 VDD.n1630 VDD.t86 5.65005
R1536 VDD.n434 VDD.t138 5.65005
R1537 VDD.n1629 VDD.t142 5.65005
R1538 VDD.n1627 VDD.t146 5.65005
R1539 VDD.n437 VDD.t44 5.65005
R1540 VDD.n1616 VDD.t47 5.65005
R1541 VDD.n1615 VDD.t124 5.65005
R1542 VDD.n408 VDD.t97 5.65005
R1543 VDD.n1813 VDD.t100 5.65005
R1544 VDD.n1896 VDD.t104 5.65005
R1545 VDD.n496 VDD.t162 5.65005
R1546 VDD.n1885 VDD.t166 5.65005
R1547 VDD.n1884 VDD.t170 5.65005
R1548 VDD.n249 VDD.t215 5.65005
R1549 VDD.n1883 VDD.t219 5.65005
R1550 VDD.n1881 VDD.t223 5.65005
R1551 VDD.n499 VDD.t266 5.65005
R1552 VDD.n1859 VDD.t270 5.65005
R1553 VDD.n1858 VDD.t274 5.65005
R1554 VDD.n501 VDD.t278 5.65005
R1555 VDD.n1857 VDD.t282 5.65005
R1556 VDD.n1855 VDD.t68 5.65005
R1557 VDD.n504 VDD.t127 5.65005
R1558 VDD.n1844 VDD.t292 5.65005
R1559 VDD.n1843 VDD.t295 5.65005
R1560 VDD.n402 VDD.t7 5.65005
R1561 VDD.n1226 VDD.t74 5.65005
R1562 VDD.n1310 VDD.t11 5.65005
R1563 VDD.n508 VDD.t62 5.65005
R1564 VDD.n1299 VDD.t20 5.65005
R1565 VDD.n1298 VDD.t23 5.65005
R1566 VDD.n253 VDD.t64 5.65005
R1567 VDD.n1297 VDD.t291 5.65005
R1568 VDD.n1295 VDD.t286 5.65005
R1569 VDD.n511 VDD.t200 5.65005
R1570 VDD.n1273 VDD.t27 5.65005
R1571 VDD.n1272 VDD.t188 5.65005
R1572 VDD.n513 VDD.t136 5.65005
R1573 VDD.n1271 VDD.t263 5.65005
R1574 VDD.n1269 VDD.t198 5.65005
R1575 VDD.n516 VDD.t158 5.65005
R1576 VDD.n1258 VDD.t147 5.65005
R1577 VDD.n1257 VDD.t150 5.65005
R1578 VDD.n405 VDD.t331 5.65005
R1579 VDD.n1004 VDD.t334 5.65005
R1580 VDD.n1087 VDD.t338 5.65005
R1581 VDD.n519 VDD.t251 5.65005
R1582 VDD.n1076 VDD.t255 5.65005
R1583 VDD.n1075 VDD.t259 5.65005
R1584 VDD.n257 VDD.t203 5.65005
R1585 VDD.n1074 VDD.t207 5.65005
R1586 VDD.n1072 VDD.t211 5.65005
R1587 VDD.n522 VDD.t176 5.65005
R1588 VDD.n1050 VDD.t180 5.65005
R1589 VDD.n1049 VDD.t184 5.65005
R1590 VDD.n524 VDD.t242 5.65005
R1591 VDD.n1048 VDD.t246 5.65005
R1592 VDD.n1046 VDD.t91 5.65005
R1593 VDD.n527 VDD.t305 5.65005
R1594 VDD.n1035 VDD.t298 5.65005
R1595 VDD.n1034 VDD.t301 5.65005
R1596 VDD.t355 VDD.n2014 5.62581
R1597 VDD.t355 VDD.n2012 5.62581
R1598 VDD.t2 VDD.n1341 5.62581
R1599 VDD.t2 VDD.n1339 5.62581
R1600 VDD.t2 VDD.n1321 5.62581
R1601 VDD.t2 VDD.n1332 5.62581
R1602 VDD.t2 VDD.n1324 5.62581
R1603 VDD.t2 VDD.n1365 5.62581
R1604 VDD.n1383 VDD.t2 5.62581
R1605 VDD.t2 VDD.n1357 5.62581
R1606 VDD.n1398 VDD.t2 5.62581
R1607 VDD.n269 VDD.t2 1.79705
R1608 VDD.n1400 VDD.t2 5.62581
R1609 VDD.n50 VDD.n51 0.267832
R1610 VDD.n1409 VDD.t2 5.62581
R1611 VDD.t2 VDD.n1349 5.62581
R1612 VDD.n1424 VDD.t2 5.62581
R1613 VDD.n78 VDD.n79 0.133791
R1614 VDD.n1548 VDD.t373 5.62581
R1615 VDD.n644 VDD.t373 2.32429
R1616 VDD.n271 VDD.n657 0.354771
R1617 VDD.n1540 VDD.t373 5.62581
R1618 VDD.n1537 VDD.t373 5.62581
R1619 VDD.n622 VDD.t373 2.32437
R1620 VDD.n1533 VDD.t373 5.62581
R1621 VDD.n1528 VDD.t373 5.62581
R1622 VDD.t0 VDD.n1581 5.62581
R1623 VDD.t0 VDD.n1579 5.62581
R1624 VDD.t0 VDD.n1561 5.62581
R1625 VDD.t0 VDD.n1572 5.62581
R1626 VDD.t0 VDD.n1564 5.62581
R1627 VDD.t0 VDD.n1606 5.62581
R1628 VDD.n1623 VDD.t0 5.62581
R1629 VDD.t0 VDD.n1598 5.62581
R1630 VDD.n1638 VDD.t0 5.62581
R1631 VDD.n267 VDD.t0 1.79705
R1632 VDD.n1640 VDD.t0 5.62581
R1633 VDD.n48 VDD.n49 0.267832
R1634 VDD.n1649 VDD.t0 5.62581
R1635 VDD.t0 VDD.n1589 5.62581
R1636 VDD.n1664 VDD.t0 5.62581
R1637 VDD.n76 VDD.n37 0.252506
R1638 VDD.n118 VDD.n117 0.130983
R1639 VDD.n641 VDD.t348 2.32406
R1640 VDD.n1764 VDD.t348 5.62581
R1641 VDD.n1765 VDD.n629 0.354771
R1642 VDD.n1767 VDD.t348 5.62581
R1643 VDD.t348 VDD.n635 2.32425
R1644 VDD.n1770 VDD.t348 5.62581
R1645 VDD.n558 VDD.t348 2.32437
R1646 VDD.t348 VDD.n652 2.32425
R1647 VDD.n145 VDD.n640 0.354547
R1648 VDD.n1778 VDD.t348 5.62581
R1649 VDD.t67 VDD.n1809 5.62581
R1650 VDD.t67 VDD.n1807 5.62581
R1651 VDD.t67 VDD.n1789 5.62581
R1652 VDD.t67 VDD.n1800 5.62581
R1653 VDD.t67 VDD.n1792 5.62581
R1654 VDD.t67 VDD.n1834 5.62581
R1655 VDD.n1851 VDD.t67 5.62581
R1656 VDD.t67 VDD.n1826 5.62581
R1657 VDD.n1866 VDD.t67 5.62581
R1658 VDD.n265 VDD.t67 1.79705
R1659 VDD.n1868 VDD.t67 5.62581
R1660 VDD.n46 VDD.n47 0.267832
R1661 VDD.n1877 VDD.t67 5.62581
R1662 VDD.t67 VDD.n1817 5.62581
R1663 VDD.n1892 VDD.t67 5.62581
R1664 VDD.n1929 VDD.n482 0.354771
R1665 VDD.n1932 VDD.n474 0.354771
R1666 VDD.t5 VDD.n1222 5.62581
R1667 VDD.t5 VDD.n1220 5.62581
R1668 VDD.t5 VDD.n1202 5.62581
R1669 VDD.t5 VDD.n1213 5.62581
R1670 VDD.t5 VDD.n1205 5.62581
R1671 VDD.t5 VDD.n1247 5.62581
R1672 VDD.n1265 VDD.t5 5.62581
R1673 VDD.t5 VDD.n1239 5.62581
R1674 VDD.n1280 VDD.t5 5.62581
R1675 VDD.n263 VDD.t5 1.79705
R1676 VDD.n1282 VDD.t5 5.62581
R1677 VDD.n44 VDD.n45 0.267832
R1678 VDD.n1291 VDD.t5 5.62581
R1679 VDD.t5 VDD.n1230 5.62581
R1680 VDD.n1306 VDD.t5 5.62581
R1681 VDD.n465 VDD.n4 0.830453
R1682 VDD.n1104 VDD.t374 5.62581
R1683 VDD.n1105 VDD.n7 0.442371
R1684 VDD.n1107 VDD.n621 0.354771
R1685 VDD.n1109 VDD.t374 5.62581
R1686 VDD.n463 VDD.t374 2.32406
R1687 VDD.n1 VDD.t374 0.613643
R1688 VDD.n1113 VDD.t374 5.62581
R1689 VDD.n1114 VDD.n213 0.355153
R1690 VDD.n1117 VDD.t374 5.62581
R1691 VDD.n1122 VDD.t374 5.62581
R1692 VDD.n1125 VDD.t374 5.62581
R1693 VDD.n1126 VDD.n445 0.354771
R1694 VDD.n1127 VDD.n645 0.354771
R1695 VDD.t90 VDD.n1000 5.62581
R1696 VDD.t90 VDD.n998 5.62581
R1697 VDD.t90 VDD.n980 5.62581
R1698 VDD.t90 VDD.n991 5.62581
R1699 VDD.t90 VDD.n983 5.62581
R1700 VDD.t90 VDD.n1025 5.62581
R1701 VDD.n1042 VDD.t90 5.62581
R1702 VDD.t90 VDD.n1017 5.62581
R1703 VDD.n1057 VDD.t90 5.62581
R1704 VDD.n261 VDD.t90 1.79705
R1705 VDD.n1059 VDD.t90 5.62581
R1706 VDD.n42 VDD.n43 0.267832
R1707 VDD.n1068 VDD.t90 5.62581
R1708 VDD.t90 VDD.n1008 5.62581
R1709 VDD.n1083 VDD.t90 5.62581
R1710 VDD.t368 VDD.n967 5.62581
R1711 VDD.t368 VDD.n961 5.62581
R1712 VDD.t368 VDD.n955 5.62581
R1713 VDD.t368 VDD.n949 5.62581
R1714 VDD.t368 VDD.n943 5.62581
R1715 VDD.t368 VDD.n937 5.62581
R1716 VDD.t368 VDD.n931 5.62581
R1717 VDD.t368 VDD.n925 5.62581
R1718 VDD.t368 VDD.n919 5.62581
R1719 VDD.t368 VDD.n913 5.62581
R1720 VDD.t368 VDD.n907 5.62581
R1721 VDD.t368 VDD.n899 5.62581
R1722 VDD.t368 VDD.n893 5.62581
R1723 VDD.t368 VDD.n887 5.62581
R1724 VDD.t368 VDD.n881 5.62581
R1725 VDD.t368 VDD.n875 5.62581
R1726 VDD.t368 VDD.n869 5.62581
R1727 VDD.t368 VDD.n863 5.62581
R1728 VDD.t368 VDD.n857 5.62581
R1729 VDD.t368 VDD.n851 5.62581
R1730 VDD.t368 VDD.n845 5.62581
R1731 VDD.t368 VDD.n839 5.62581
R1732 VDD.t368 VDD.n833 5.62581
R1733 VDD.t368 VDD.n827 5.62581
R1734 VDD.t368 VDD.n820 5.62581
R1735 VDD.t368 VDD.n814 5.62581
R1736 VDD.t368 VDD.n808 5.62581
R1737 VDD.t368 VDD.n802 5.62581
R1738 VDD.t368 VDD.n796 5.62581
R1739 VDD.t368 VDD.n790 5.62581
R1740 VDD.t368 VDD.n784 5.62581
R1741 VDD.t368 VDD.n778 5.62581
R1742 VDD.t368 VDD.n776 5.62581
R1743 VDD.t381 VDD.n717 5.61485
R1744 VDD.t381 VDD.n227 2.01038
R1745 VDD.n1550 VDD.t490 5.60969
R1746 VDD.n1759 VDD.t479 5.60969
R1747 VDD.n15 VDD.t468 5.60969
R1748 VDD.t374 VDD.t434 5.71358
R1749 VDD.n12 VDD.t422 5.60969
R1750 VDD.n52 VDD.t457 5.60969
R1751 VDD.n707 VDD.t462 5.60969
R1752 VDD.n1523 VDD.t498 5.60347
R1753 VDD.n1520 VDD.t495 5.60347
R1754 VDD.n154 VDD.t487 5.60347
R1755 VDD.n152 VDD.t484 5.60347
R1756 VDD.n1913 VDD.t476 5.60347
R1757 VDD.n1911 VDD.t473 5.60347
R1758 VDD.n16 VDD.t471 5.60347
R1759 VDD.n1101 VDD.t442 5.60347
R1760 VDD.n1099 VDD.t439 5.60347
R1761 VDD.t374 VDD.t437 5.60347
R1762 VDD.n766 VDD.t431 5.60347
R1763 VDD.n13 VDD.t425 5.60347
R1764 VDD.n770 VDD.t428 5.60347
R1765 VDD.n57 VDD.t465 5.60347
R1766 VDD.n612 VDD.t496 5.59675
R1767 VDD.n1517 VDD.t766 5.59675
R1768 VDD.n1514 VDD.t767 5.59675
R1769 VDD.n110 VDD.t768 5.59675
R1770 VDD.n107 VDD.t760 5.59675
R1771 VDD.n1510 VDD.t763 5.59675
R1772 VDD.n568 VDD.t764 5.59675
R1773 VDD.n104 VDD.t765 5.59675
R1774 VDD.n239 VDD.t761 5.59675
R1775 VDD.n101 VDD.t759 5.59675
R1776 VDD.n570 VDD.t762 5.59675
R1777 VDD.n572 VDD.t758 5.59675
R1778 VDD.n1502 VDD.t747 5.59675
R1779 VDD.n1500 VDD.t757 5.59675
R1780 VDD.n98 VDD.t746 5.59675
R1781 VDD.n574 VDD.t748 5.59675
R1782 VDD.n95 VDD.t749 5.59675
R1783 VDD.n1494 VDD.t755 5.59675
R1784 VDD.n1491 VDD.t756 5.59675
R1785 VDD.n92 VDD.t754 5.59675
R1786 VDD.n576 VDD.t621 5.59675
R1787 VDD.n225 VDD.t753 5.59675
R1788 VDD.n88 VDD.t622 5.59675
R1789 VDD.n1483 VDD.t721 5.59675
R1790 VDD.n85 VDD.t745 5.59675
R1791 VDD.n83 VDD.t752 5.59675
R1792 VDD.n1478 VDD.t719 5.59675
R1793 VDD.n1474 VDD.t751 5.59675
R1794 VDD.n577 VDD.t728 5.59675
R1795 VDD.n579 VDD.t750 5.59675
R1796 VDD.n80 VDD.t620 5.59675
R1797 VDD.n1469 VDD.t612 5.59675
R1798 VDD.n77 VDD.t729 5.59675
R1799 VDD.n151 VDD.t485 5.59675
R1800 VDD.n162 VDD.t744 5.59675
R1801 VDD.n1712 VDD.t716 5.59675
R1802 VDD.n159 VDD.t742 5.59675
R1803 VDD.n1716 VDD.t743 5.59675
R1804 VDD.n156 VDD.t609 5.59675
R1805 VDD.n148 VDD.t720 5.59675
R1806 VDD.n547 VDD.t741 5.59675
R1807 VDD.n144 VDD.t718 5.59675
R1808 VDD.n550 VDD.t740 5.59675
R1809 VDD.n142 VDD.t739 5.59675
R1810 VDD.n553 VDD.t617 5.59675
R1811 VDD.n138 VDD.t715 5.59675
R1812 VDD.n135 VDD.t726 5.59675
R1813 VDD.n132 VDD.t727 5.59675
R1814 VDD.n130 VDD.t608 5.59675
R1815 VDD.n127 VDD.t735 5.59675
R1816 VDD.n125 VDD.t736 5.59675
R1817 VDD.n555 VDD.t737 5.59675
R1818 VDD.n122 VDD.t724 5.59675
R1819 VDD.n559 VDD.t738 5.59675
R1820 VDD.n1736 VDD.t722 5.59675
R1821 VDD.n562 VDD.t725 5.59675
R1822 VDD.n1740 VDD.t732 5.59675
R1823 VDD.n564 VDD.t733 5.59675
R1824 VDD.n1743 VDD.t734 5.59675
R1825 VDD.n1745 VDD.t623 5.59675
R1826 VDD.n1747 VDD.t730 5.59675
R1827 VDD.n119 VDD.t731 5.59675
R1828 VDD.n116 VDD.t717 5.59675
R1829 VDD.n1754 VDD.t723 5.59675
R1830 VDD.n113 VDD.t616 5.59675
R1831 VDD.n566 VDD.t628 5.59675
R1832 VDD.n1910 VDD.t474 5.59675
R1833 VDD.n1909 VDD.t713 5.59675
R1834 VDD.n472 VDD.t615 5.59675
R1835 VDD.n475 VDD.t712 5.59675
R1836 VDD.n196 VDD.t714 5.59675
R1837 VDD.n193 VDD.t686 5.59675
R1838 VDD.n191 VDD.t711 5.59675
R1839 VDD.n1908 VDD.t710 5.59675
R1840 VDD.n188 VDD.t709 5.59675
R1841 VDD.n185 VDD.t690 5.59675
R1842 VDD.n478 VDD.t708 5.59675
R1843 VDD.n481 VDD.t613 5.59675
R1844 VDD.n1907 VDD.t693 5.59675
R1845 VDD.n483 VDD.t703 5.59675
R1846 VDD.n1906 VDD.t705 5.59675
R1847 VDD.n181 VDD.t706 5.59675
R1848 VDD.n1905 VDD.t707 5.59675
R1849 VDD.n486 VDD.t695 5.59675
R1850 VDD.n1904 VDD.t704 5.59675
R1851 VDD.n488 VDD.t694 5.59675
R1852 VDD.n177 VDD.t689 5.59675
R1853 VDD.n174 VDD.t696 5.59675
R1854 VDD.n491 VDD.t702 5.59675
R1855 VDD.n530 VDD.t688 5.59675
R1856 VDD.n1903 VDD.t687 5.59675
R1857 VDD.n534 VDD.t692 5.59675
R1858 VDD.n171 VDD.t701 5.59675
R1859 VDD.n538 VDD.t700 5.59675
R1860 VDD.n168 VDD.t614 5.59675
R1861 VDD.n164 VDD.t697 5.59675
R1862 VDD.n542 VDD.t698 5.59675
R1863 VDD.n546 VDD.t699 5.59675
R1864 VDD.n1902 VDD.t691 5.59675
R1865 VDD.n616 VDD.t440 5.59675
R1866 VDD.n1098 VDD.t639 5.59675
R1867 VDD.n218 VDD.t648 5.59675
R1868 VDD.n439 VDD.t685 5.59675
R1869 VDD.n18 VDD.t684 5.59675
R1870 VDD.n443 VDD.t630 5.59675
R1871 VDD.n446 VDD.t632 5.59675
R1872 VDD.n1097 VDD.t674 5.59675
R1873 VDD.n593 VDD.t676 5.59675
R1874 VDD.n447 VDD.t673 5.59675
R1875 VDD.n449 VDD.t677 5.59675
R1876 VDD.n1096 VDD.t675 5.59675
R1877 VDD.n453 VDD.t683 5.59675
R1878 VDD.n215 VDD.t680 5.59675
R1879 VDD.n212 VDD.t681 5.59675
R1880 VDD.n209 VDD.t678 5.59675
R1881 VDD.n457 VDD.t679 5.59675
R1882 VDD.n206 VDD.t682 5.59675
R1883 VDD.n1095 VDD.t637 5.59675
R1884 VDD.n202 VDD.t640 5.59675
R1885 VDD.n0 VDD.t671 5.59675
R1886 VDD.n9 VDD.t672 5.59675
R1887 VDD.n461 VDD.t645 5.59675
R1888 VDD.n464 VDD.t670 5.59675
R1889 VDD.n1094 VDD.t626 5.59675
R1890 VDD.n199 VDD.t634 5.59675
R1891 VDD.n6 VDD.t669 5.59675
R1892 VDD.n5 VDD.t619 5.59675
R1893 VDD.n1093 VDD.t624 5.59675
R1894 VDD.n467 VDD.t668 5.59675
R1895 VDD.n469 VDD.t646 5.59675
R1896 VDD.n2 VDD.t647 5.59675
R1897 VDD.t374 VDD.t667 5.74834
R1898 VDD.n969 VDD.t631 5.59675
R1899 VDD.n963 VDD.t629 5.59675
R1900 VDD.n957 VDD.t625 5.59675
R1901 VDD.n951 VDD.t635 5.59675
R1902 VDD.n945 VDD.t642 5.59675
R1903 VDD.n939 VDD.t638 5.59675
R1904 VDD.n933 VDD.t636 5.59675
R1905 VDD.n927 VDD.t618 5.59675
R1906 VDD.n921 VDD.t610 5.59675
R1907 VDD.n915 VDD.t649 5.59675
R1908 VDD.n909 VDD.t644 5.59675
R1909 VDD.n901 VDD.t643 5.59675
R1910 VDD.n895 VDD.t651 5.59675
R1911 VDD.n889 VDD.t652 5.59675
R1912 VDD.n883 VDD.t650 5.59675
R1913 VDD.n877 VDD.t633 5.59675
R1914 VDD.n871 VDD.t611 5.59675
R1915 VDD.n865 VDD.t657 5.59675
R1916 VDD.n859 VDD.t654 5.59675
R1917 VDD.n853 VDD.t662 5.59675
R1918 VDD.n847 VDD.t661 5.59675
R1919 VDD.n841 VDD.t660 5.59675
R1920 VDD.n835 VDD.t659 5.59675
R1921 VDD.n829 VDD.t658 5.59675
R1922 VDD.n821 VDD.t664 5.59675
R1923 VDD.n816 VDD.t655 5.59675
R1924 VDD.n810 VDD.t665 5.59675
R1925 VDD.n804 VDD.t663 5.59675
R1926 VDD.n798 VDD.t653 5.59675
R1927 VDD.n792 VDD.t656 5.59675
R1928 VDD.n786 VDD.t666 5.59675
R1929 VDD.n780 VDD.t641 5.59675
R1930 VDD.n774 VDD.t427 5.59675
R1931 VDD.n56 VDD.t627 5.59675
R1932 VDD.n28 VDD.t489 5.59179
R1933 VDD.n24 VDD.t478 5.59179
R1934 VDD.n221 VDD.t467 5.59179
R1935 VDD.n30 VDD.t423 5.59179
R1936 VDD.n39 VDD.t458 5.59179
R1937 VDD.n708 VDD.t463 5.59179
R1938 VDD.n972 VDD.n33 5.21294
R1939 VDD.n1551 VDD.n1431 5.05219
R1940 VDD.n1553 VDD.n1552 5.05219
R1941 VDD.n1760 VDD.n1672 5.05219
R1942 VDD.n1781 VDD.n1780 5.05219
R1943 VDD.n2003 VDD.n1900 5.05219
R1944 VDD.n2005 VDD.n2004 5.05219
R1945 VDD.n1194 VDD.n1193 5.05219
R1946 VDD.n1092 VDD.n1091 5.05219
R1947 VDD.n972 VDD.n971 5.05219
R1948 VDD.n2010 VDD.n2009 5.04969
R1949 VDD.n2008 VDD.n2007 5.04869
R1950 VDD.n2051 VDD.t446 4.9462
R1951 VDD.n2023 VDD.t443 4.9462
R1952 VDD.n710 VDD.n709 4.90372
R1953 VDD.t2 VDD.n413 1.14009
R1954 VDD.t2 VDD.n1344 4.19244
R1955 VDD.t2 VDD.n1327 4.19244
R1956 VDD.t2 VDD.n1325 4.19244
R1957 VDD.t2 VDD.n1363 4.19244
R1958 VDD.n425 VDD.t2 1.14009
R1959 VDD.n1381 VDD.t2 4.19244
R1960 VDD.t2 VDD.n424 1.14009
R1961 VDD.t2 VDD.n1355 4.19244
R1962 VDD.n420 VDD.t2 1.14009
R1963 VDD.n1396 VDD.t2 4.19244
R1964 VDD.n1407 VDD.t2 4.19244
R1965 VDD.t2 VDD.n1347 4.19244
R1966 VDD.n417 VDD.t2 1.14009
R1967 VDD.n1422 VDD.t2 4.19244
R1968 VDD.t0 VDD.n416 1.14009
R1969 VDD.t0 VDD.n1584 4.19244
R1970 VDD.t0 VDD.n1567 4.19244
R1971 VDD.t0 VDD.n1565 4.19244
R1972 VDD.t0 VDD.n1604 4.19244
R1973 VDD.n436 VDD.t0 1.14009
R1974 VDD.n1621 VDD.t0 4.19244
R1975 VDD.t0 VDD.n435 1.14009
R1976 VDD.t0 VDD.n1596 4.19244
R1977 VDD.n431 VDD.t0 1.14009
R1978 VDD.n1636 VDD.t0 4.19244
R1979 VDD.n1647 VDD.t0 4.19244
R1980 VDD.t0 VDD.n1587 4.19244
R1981 VDD.n428 VDD.t0 1.14009
R1982 VDD.n1662 VDD.t0 4.19244
R1983 VDD.t67 VDD.n410 1.14009
R1984 VDD.t67 VDD.n1812 4.19244
R1985 VDD.t67 VDD.n1795 4.19244
R1986 VDD.t67 VDD.n1793 4.19244
R1987 VDD.t67 VDD.n1832 4.19244
R1988 VDD.n503 VDD.t67 1.14009
R1989 VDD.n1849 VDD.t67 4.19244
R1990 VDD.t67 VDD.n502 1.14009
R1991 VDD.t67 VDD.n1824 4.19244
R1992 VDD.n498 VDD.t67 1.14009
R1993 VDD.n1864 VDD.t67 4.19244
R1994 VDD.n1875 VDD.t67 4.19244
R1995 VDD.t67 VDD.n1815 4.19244
R1996 VDD.n495 VDD.t67 1.14009
R1997 VDD.n1890 VDD.t67 4.19244
R1998 VDD.t5 VDD.n404 1.14009
R1999 VDD.t5 VDD.n1225 4.19244
R2000 VDD.t5 VDD.n1208 4.19244
R2001 VDD.t5 VDD.n1206 4.19244
R2002 VDD.t5 VDD.n1245 4.19244
R2003 VDD.n515 VDD.t5 1.14009
R2004 VDD.n1263 VDD.t5 4.19244
R2005 VDD.t5 VDD.n514 1.14009
R2006 VDD.t5 VDD.n1237 4.19244
R2007 VDD.n510 VDD.t5 1.14009
R2008 VDD.n1278 VDD.t5 4.19244
R2009 VDD.n1289 VDD.t5 4.19244
R2010 VDD.t5 VDD.n1228 4.19244
R2011 VDD.n507 VDD.t5 1.14009
R2012 VDD.n1304 VDD.t5 4.19244
R2013 VDD.t90 VDD.n407 1.14009
R2014 VDD.t90 VDD.n1003 4.19244
R2015 VDD.t90 VDD.n986 4.19244
R2016 VDD.t90 VDD.n984 4.19244
R2017 VDD.t90 VDD.n1023 4.19244
R2018 VDD.n526 VDD.t90 1.14009
R2019 VDD.n1040 VDD.t90 4.19244
R2020 VDD.t90 VDD.n525 1.14009
R2021 VDD.t90 VDD.n1015 4.19244
R2022 VDD.n521 VDD.t90 1.14009
R2023 VDD.n1055 VDD.t90 4.19244
R2024 VDD.n1066 VDD.t90 4.19244
R2025 VDD.t90 VDD.n1006 4.19244
R2026 VDD.n518 VDD.t90 1.14009
R2027 VDD.n1081 VDD.t90 4.19244
R2028 VDD.t355 VDD.n727 4.19238
R2029 VDD.t355 VDD.n2043 4.19238
R2030 VDD.t355 VDD.n722 4.19225
R2031 VDD.t355 VDD.n2015 4.19225
R2032 VDD.n2011 VDD.n2010 4.123
R2033 VDD.n2007 VDD.n2006 4.123
R2034 VDD.n583 VDD 3.92864
R2035 VDD.n586 VDD 3.92864
R2036 VDD.n594 VDD 3.92864
R2037 VDD.n243 VDD 3.92317
R2038 VDD.n273 VDD 3.92317
R2039 VDD.n1453 VDD 3.92317
R2040 VDD.n1552 VDD 3.92317
R2041 VDD.n1551 VDD 3.92317
R2042 VDD.n247 VDD 3.92317
R2043 VDD.n276 VDD 3.92317
R2044 VDD.n1684 VDD 3.92317
R2045 VDD.n1780 VDD 3.92317
R2046 VDD.n1760 VDD 3.92317
R2047 VDD.n251 VDD 3.92317
R2048 VDD.n279 VDD 3.92317
R2049 VDD.n591 VDD 3.92317
R2050 VDD.n1981 VDD 3.92317
R2051 VDD.n2004 VDD 3.92317
R2052 VDD.n2003 VDD 3.92317
R2053 VDD.n255 VDD 3.92317
R2054 VDD.n282 VDD 3.92317
R2055 VDD.n1176 VDD 3.92317
R2056 VDD.n1092 VDD 3.92317
R2057 VDD.n1193 VDD 3.92317
R2058 VDD.n259 VDD 3.92317
R2059 VDD.n285 VDD 3.92317
R2060 VDD.n971 VDD 3.92317
R2061 VDD.n33 VDD 3.92317
R2062 VDD.n597 VDD 3.92317
R2063 VDD.n741 VDD 3.92317
R2064 VDD.n2007 VDD 3.92317
R2065 VDD.n2010 VDD 3.92317
R2066 VDD.n228 VDD 3.92317
R2067 VDD.n292 VDD 3.92023
R2068 VDD.n300 VDD 3.92023
R2069 VDD.n308 VDD 3.92023
R2070 VDD.n316 VDD 3.92023
R2071 VDD.n324 VDD 3.92023
R2072 VDD.n1535 VDD 3.90557
R2073 VDD.n146 VDD 3.90557
R2074 VDD.n189 VDD 3.90557
R2075 VDD.n1119 VDD 3.90557
R2076 VDD.n824 VDD 3.90557
R2077 VDD.n226 VDD 3.89823
R2078 VDD.n494 VDD 3.89823
R2079 VDD.n506 VDD 3.89823
R2080 VDD.n10 VDD 3.89823
R2081 VDD.n904 VDD 3.89823
R2082 VDD.n1431 VDD.n1430 3.64728
R2083 VDD.n237 VDD.n1320 0.393995
R2084 VDD.n1399 VDD.n269 0.341
R2085 VDD.n1401 VDD.n50 0.360407
R2086 VDD.n235 VDD.n1560 0.393995
R2087 VDD.n1639 VDD.n267 0.341
R2088 VDD.n1641 VDD.n48 0.360407
R2089 VDD.n233 VDD.n1788 0.393995
R2090 VDD.n1867 VDD.n265 0.341
R2091 VDD.n1869 VDD.n46 0.360407
R2092 VDD.n231 VDD.n1201 0.393995
R2093 VDD.n1281 VDD.n263 0.341
R2094 VDD.n1283 VDD.n44 0.360407
R2095 VDD.n229 VDD.n979 0.393995
R2096 VDD.n1058 VDD.n261 0.341
R2097 VDD.n1060 VDD.n42 0.360407
R2098 VDD.t368 VDD.n825 3.32633
R2099 VDD.t368 VDD.n905 3.32623
R2100 VDD.t381 VDD.n711 3.30706
R2101 VDD.t381 VDD.n713 3.30706
R2102 VDD.t381 VDD.n721 3.30688
R2103 VDD.n1671 VDD.n1670 3.24219
R2104 VDD.n1899 VDD.n1898 3.24219
R2105 VDD.n1313 VDD.n1312 3.24219
R2106 VDD.n1090 VDD.n1089 3.24219
R2107 VDD.t381 VDD.n703 2.7751
R2108 VDD.t2 VDD.n1317 2.74446
R2109 VDD.t2 VDD.n1319 2.74446
R2110 VDD.t2 VDD.n1372 2.74446
R2111 VDD.n51 VDD.t2 1.01804
R2112 VDD.n1403 VDD.t2 2.74446
R2113 VDD.t0 VDD.n1557 2.74446
R2114 VDD.t0 VDD.n1559 2.74446
R2115 VDD.t0 VDD.n1612 2.74446
R2116 VDD.n49 VDD.t0 1.01804
R2117 VDD.n1643 VDD.t0 2.74446
R2118 VDD.t67 VDD.n1785 2.74446
R2119 VDD.t67 VDD.n1787 2.74446
R2120 VDD.t67 VDD.n1840 2.74446
R2121 VDD.n47 VDD.t67 1.01804
R2122 VDD.n1871 VDD.t67 2.74446
R2123 VDD.t5 VDD.n1198 2.74446
R2124 VDD.t5 VDD.n1200 2.74446
R2125 VDD.t5 VDD.n1254 2.74446
R2126 VDD.n45 VDD.t5 1.01804
R2127 VDD.n1285 VDD.t5 2.74446
R2128 VDD.t90 VDD.n976 2.74446
R2129 VDD.t90 VDD.n978 2.74446
R2130 VDD.t90 VDD.n1031 2.74446
R2131 VDD.n43 VDD.t90 1.01804
R2132 VDD.n1062 VDD.t90 2.74446
R2133 VDD.t355 VDD.n728 2.74414
R2134 VDD.n31 VDD.n970 0.368386
R2135 VDD.t368 VDD.n11 0.661877
R2136 VDD.t373 VDD.n1433 2.74397
R2137 VDD.t373 VDD.n27 2.74397
R2138 VDD.t348 VDD.n1704 2.74397
R2139 VDD.t348 VDD.n23 2.74397
R2140 VDD.n1940 VDD.t346 2.74397
R2141 VDD.n1135 VDD.t374 2.74397
R2142 VDD.t368 VDD.n761 2.74397
R2143 VDD.n13 VDD.n968 0.379964
R2144 VDD.t381 VDD 1.47683
R2145 VDD.n2021 VDD.t451 2.69937
R2146 VDD.n2019 VDD.t445 2.69937
R2147 VDD.n2045 VDD.t453 2.69937
R2148 VDD.n2053 VDD.t448 2.69937
R2149 VDD.n2049 VDD.t454 2.6992
R2150 VDD.n2047 VDD.t447 2.6992
R2151 VDD.n2017 VDD.t450 2.6992
R2152 VDD.n2025 VDD.t444 2.6992
R2153 VDD.n2030 VDD.t987 2.6992
R2154 VDD.n2029 VDD.t984 2.6992
R2155 VDD.n2035 VDD.t990 2.6992
R2156 VDD.n2034 VDD.t985 2.6992
R2157 VDD.n2040 VDD.t992 2.6992
R2158 VDD.n2039 VDD.t997 2.6992
R2159 VDD.t368 VDD.n953 2.32439
R2160 VDD.t368 VDD.n947 2.32439
R2161 VDD.t368 VDD.n897 2.32439
R2162 VDD.t368 VDD.n861 2.32439
R2163 VDD.t368 VDD.n843 2.32439
R2164 VDD.t368 VDD.n818 2.32439
R2165 VDD.t368 VDD.n855 2.32432
R2166 VDD.t368 VDD.n965 2.32425
R2167 VDD.t368 VDD.n941 2.32425
R2168 VDD.t368 VDD.n788 2.32425
R2169 VDD.t368 VDD.n891 2.3242
R2170 VDD.t368 VDD.n879 2.3242
R2171 VDD.t368 VDD.n867 2.3242
R2172 VDD.t368 VDD.n959 2.32417
R2173 VDD.t368 VDD.n935 2.32417
R2174 VDD.t368 VDD.n911 2.32417
R2175 VDD.t368 VDD.n794 2.32417
R2176 VDD.t355 VDD.n723 2.32417
R2177 VDD.t355 VDD.n726 2.32417
R2178 VDD.t355 VDD.n2037 2.32417
R2179 VDD.n60 VDD.n62 0.450648
R2180 VDD.t368 VDD.n923 2.32417
R2181 VDD.t368 VDD.n885 2.32417
R2182 VDD.t368 VDD.n917 2.32414
R2183 VDD.t368 VDD.n873 2.32414
R2184 VDD.t368 VDD.n849 2.32414
R2185 VDD.t368 VDD.n837 2.32414
R2186 VDD.t368 VDD.n812 2.32414
R2187 VDD.t368 VDD.n806 2.32414
R2188 VDD.t368 VDD.n782 2.32414
R2189 VDD.t355 VDD.n724 2.32406
R2190 VDD.t355 VDD.n2042 2.32406
R2191 VDD.t355 VDD.n2027 2.32406
R2192 VDD.t368 VDD.n929 2.32406
R2193 VDD.t368 VDD.n831 2.32406
R2194 VDD.t368 VDD.n800 2.32406
R2195 VDD.t67 VDD.n1842 2.06576
R2196 VDD.t90 VDD.n1033 2.06542
R2197 VDD.t2 VDD.n1374 2.06465
R2198 VDD.t0 VDD.n1614 2.06415
R2199 VDD.t5 VDD.n1256 2.06391
R2200 VDD.t355 VDD.n725 2.0061
R2201 VDD.t373 VDD.n1454 2.0061
R2202 VDD.t348 VDD.n1683 2.0061
R2203 VDD.n1982 VDD.t346 2.0061
R2204 VDD.n1177 VDD.t374 2.0061
R2205 VDD.t368 VDD.n740 2.00599
R2206 VDD.t355 VDD.n2032 2.00592
R2207 VDD.n660 VDD.t346 1.56886
R2208 VDD.t355 VDD.n2055 1.75854
R2209 VDD.t373 VDD.n1465 1.56886
R2210 VDD.n1131 VDD.t374 1.56886
R2211 VDD.t368 VDD.n763 1.56865
R2212 VDD.t456 VDD.n38 1.5566
R2213 VDD.t368 VDD.n752 1.55381
R2214 VDD.t368 VDD.n745 1.55376
R2215 VDD.t368 VDD.n730 1.55375
R2216 VDD.t368 VDD.n748 1.55375
R2217 VDD.t373 VDD.n1435 1.55361
R2218 VDD.t373 VDD.n1436 1.55361
R2219 VDD.t373 VDD.n1437 1.55361
R2220 VDD.t373 VDD.n1438 1.55361
R2221 VDD.t373 VDD.n1439 1.55361
R2222 VDD.t373 VDD.n581 1.55361
R2223 VDD.t373 VDD.n582 1.55361
R2224 VDD.t373 VDD.n1440 1.55361
R2225 VDD.t373 VDD.n1441 1.55361
R2226 VDD.t373 VDD.n1442 1.55361
R2227 VDD.t373 VDD.n1443 1.55361
R2228 VDD.t373 VDD.n1444 1.55361
R2229 VDD.t373 VDD.n1445 1.55361
R2230 VDD.t373 VDD.n1446 1.55361
R2231 VDD.t373 VDD.n1447 1.55361
R2232 VDD.t373 VDD.n1448 1.55361
R2233 VDD.t373 VDD.n1449 1.55361
R2234 VDD.t373 VDD.n1450 1.55361
R2235 VDD.t373 VDD.n1451 1.55361
R2236 VDD.t373 VDD.n1455 1.55361
R2237 VDD.t373 VDD.n1456 1.55361
R2238 VDD.t373 VDD.n1457 1.55361
R2239 VDD.t373 VDD.n1458 1.55361
R2240 VDD.t373 VDD.n1459 1.55361
R2241 VDD.t373 VDD.n1460 1.55361
R2242 VDD.t373 VDD.n1461 1.55361
R2243 VDD.t373 VDD.n1462 1.55361
R2244 VDD.t373 VDD.n1463 1.55361
R2245 VDD.t373 VDD.n1464 1.55361
R2246 VDD.t348 VDD.n1702 1.55361
R2247 VDD.t348 VDD.n1701 1.55361
R2248 VDD.t348 VDD.n1700 1.55361
R2249 VDD.t348 VDD.n1699 1.55361
R2250 VDD.t348 VDD.n1698 1.55361
R2251 VDD.t348 VDD.n584 1.55361
R2252 VDD.t348 VDD.n585 1.55361
R2253 VDD.t348 VDD.n1697 1.55361
R2254 VDD.t348 VDD.n1696 1.55361
R2255 VDD.t348 VDD.n1695 1.55361
R2256 VDD.t348 VDD.n1694 1.55361
R2257 VDD.t348 VDD.n1693 1.55361
R2258 VDD.t348 VDD.n1692 1.55361
R2259 VDD.t348 VDD.n1691 1.55361
R2260 VDD.t348 VDD.n1690 1.55361
R2261 VDD.t348 VDD.n1689 1.55361
R2262 VDD.t348 VDD.n1688 1.55361
R2263 VDD.t348 VDD.n1687 1.55361
R2264 VDD.t348 VDD.n1686 1.55361
R2265 VDD.t348 VDD.n1682 1.55361
R2266 VDD.t348 VDD.n1681 1.55361
R2267 VDD.t348 VDD.n1680 1.55361
R2268 VDD.t348 VDD.n1679 1.55361
R2269 VDD.t348 VDD.n1678 1.55361
R2270 VDD.t348 VDD.n1677 1.55361
R2271 VDD.t348 VDD.n1676 1.55361
R2272 VDD.t348 VDD.n1675 1.55361
R2273 VDD.t348 VDD.n1674 1.55361
R2274 VDD.t348 VDD.n1673 1.55361
R2275 VDD.n1944 VDD.t346 1.55361
R2276 VDD.n1946 VDD.t346 1.55361
R2277 VDD.n1948 VDD.t346 1.55361
R2278 VDD.n1950 VDD.t346 1.55361
R2279 VDD.n1952 VDD.t346 1.55361
R2280 VDD.n590 VDD.t346 1.55361
R2281 VDD.n1954 VDD.t346 1.55361
R2282 VDD.n1956 VDD.t346 1.55361
R2283 VDD.n1958 VDD.t346 1.55361
R2284 VDD.n1960 VDD.t346 1.55361
R2285 VDD.n1962 VDD.t346 1.55361
R2286 VDD.n1964 VDD.t346 1.55361
R2287 VDD.n1966 VDD.t346 1.55361
R2288 VDD.n1968 VDD.t346 1.55361
R2289 VDD.n1970 VDD.t346 1.55361
R2290 VDD.n1972 VDD.t346 1.55361
R2291 VDD.n1974 VDD.t346 1.55361
R2292 VDD.n1976 VDD.t346 1.55361
R2293 VDD.n1978 VDD.t346 1.55361
R2294 VDD.n1984 VDD.t346 1.55361
R2295 VDD.n1986 VDD.t346 1.55361
R2296 VDD.n1988 VDD.t346 1.55361
R2297 VDD.n1990 VDD.t346 1.55361
R2298 VDD.n1992 VDD.t346 1.55361
R2299 VDD.n1994 VDD.t346 1.55361
R2300 VDD.n1996 VDD.t346 1.55361
R2301 VDD.n1998 VDD.t346 1.55361
R2302 VDD.n2000 VDD.t346 1.55361
R2303 VDD.n2002 VDD.t346 1.55361
R2304 VDD.n1139 VDD.t374 1.55361
R2305 VDD.n1141 VDD.t374 1.55361
R2306 VDD.n1143 VDD.t374 1.55361
R2307 VDD.n1145 VDD.t374 1.55361
R2308 VDD.n1147 VDD.t374 1.55361
R2309 VDD.n592 VDD.t374 1.55361
R2310 VDD.n1149 VDD.t374 1.55361
R2311 VDD.n1151 VDD.t374 1.55361
R2312 VDD.n1153 VDD.t374 1.55361
R2313 VDD.n1155 VDD.t374 1.55361
R2314 VDD.n1157 VDD.t374 1.55361
R2315 VDD.n1159 VDD.t374 1.55361
R2316 VDD.n1161 VDD.t374 1.55361
R2317 VDD.n1163 VDD.t374 1.55361
R2318 VDD.n1165 VDD.t374 1.55361
R2319 VDD.n1167 VDD.t374 1.55361
R2320 VDD.n1169 VDD.t374 1.55361
R2321 VDD.n1171 VDD.t374 1.55361
R2322 VDD.n1173 VDD.t374 1.55361
R2323 VDD.n1179 VDD.t374 1.55361
R2324 VDD.n1181 VDD.t374 1.55361
R2325 VDD.n1183 VDD.t374 1.55361
R2326 VDD.n1185 VDD.t374 1.55361
R2327 VDD.n1187 VDD.t374 1.55361
R2328 VDD.n1189 VDD.t374 1.55361
R2329 VDD.n1191 VDD.t374 1.55361
R2330 VDD.n3 VDD.t374 0.403734
R2331 VDD.t368 VDD.n733 1.55361
R2332 VDD.t368 VDD.n750 1.55361
R2333 VDD.t368 VDD.n759 1.55359
R2334 VDD.t368 VDD.n758 1.55357
R2335 VDD.t368 VDD.n736 1.55356
R2336 VDD.t368 VDD.n596 1.55355
R2337 VDD.t368 VDD.n749 1.55354
R2338 VDD.t368 VDD.n753 1.55354
R2339 VDD.t368 VDD.n744 1.55353
R2340 VDD.t368 VDD.n595 1.5535
R2341 VDD.t368 VDD.n760 1.5535
R2342 VDD.t368 VDD.n755 1.55347
R2343 VDD.t368 VDD.n754 1.55345
R2344 VDD.t368 VDD.n737 1.55342
R2345 VDD.t368 VDD.n757 1.5534
R2346 VDD.t368 VDD.n739 1.5534
R2347 VDD.t368 VDD.n747 1.55339
R2348 VDD.t368 VDD.n743 1.55338
R2349 VDD.t368 VDD.n751 1.55337
R2350 VDD.t368 VDD.n735 1.55335
R2351 VDD.t368 VDD.n746 1.55334
R2352 VDD.t368 VDD.n734 1.55333
R2353 VDD.t368 VDD.n738 1.55332
R2354 VDD.t368 VDD.n756 1.55332
R2355 VDD.t368 VDD.n731 1.55327
R2356 VDD.t368 VDD.n732 1.55327
R2357 VDD.n223 VDD.n1551 1.26425
R2358 VDD.n1552 VDD.n36 1.26425
R2359 VDD.n76 VDD.n1760 1.26425
R2360 VDD.n1780 VDD.n37 1.26425
R2361 VDD.n32 VDD.n2003 1.26425
R2362 VDD.n2004 VDD.n16 1.26425
R2363 VDD.n1193 VDD.t374 1.26425
R2364 VDD.n13 VDD.n33 1.26425
R2365 VDD.n971 VDD.n31 1.26425
R2366 VDD.t381 VDD.n705 1.20461
R2367 VDD.n60 VDD.n41 0.523335
R2368 VDD.n2030 VDD.n2029 1.11007
R2369 VDD.n2035 VDD.n2034 1.11007
R2370 VDD.n2040 VDD.n2039 1.11007
R2371 VDD.t355 VDD.n729 1.01993
R2372 VDD.n720 VDD.n653 0.975304
R2373 VDD.n653 VDD.n228 0.817678
R2374 VDD.n2008 VDD.n2005 0.72826
R2375 VDD.n710 VDD.n705 0.671512
R2376 VDD.n705 VDD.n704 0.6645
R2377 VDD.n2011 VDD.n729 0.632886
R2378 VDD.n2006 VDD.n729 0.618267
R2379 VDD.n2019 VDD.n2018 0.570444
R2380 VDD.n2054 VDD.n2053 0.570444
R2381 VDD.n2047 VDD.n2046 0.570274
R2382 VDD.n2026 VDD.n2025 0.570274
R2383 VDD.n2031 VDD.n2030 0.570274
R2384 VDD.n2036 VDD.n2035 0.570274
R2385 VDD.n2041 VDD.n2040 0.570274
R2386 VDD.n2049 VDD.n2048 0.569912
R2387 VDD.n2017 VDD.n2016 0.569912
R2388 VDD.n2029 VDD.n2028 0.569912
R2389 VDD.n2034 VDD.n2033 0.569912
R2390 VDD.n2039 VDD.n2038 0.569912
R2391 VDD.n2021 VDD.n2020 0.569733
R2392 VDD.n2045 VDD.n2044 0.569733
R2393 VDD.n29 VDD.n28 0.215244
R2394 VDD.n25 VDD.n24 0.215244
R2395 VDD.n32 VDD.n221 0.508375
R2396 VDD.n31 VDD.n30 0.508375
R2397 VDD.n708 VDD.n59 0.508375
R2398 VDD.t381 VDD.n653 0.49685
R2399 VDD.n612 VDD.n1518 0.495739
R2400 VDD.n1517 VDD.n1516 0.495739
R2401 VDD.n1514 VDD.n1513 0.495739
R2402 VDD.n110 VDD.n1512 0.495739
R2403 VDD.n107 VDD.n1511 0.495739
R2404 VDD.n1510 VDD.n1509 0.495739
R2405 VDD.n568 VDD.n1508 0.495739
R2406 VDD.n104 VDD.n1506 0.495739
R2407 VDD.n239 VDD.n583 0.495739
R2408 VDD.n101 VDD.n1505 0.495739
R2409 VDD.n570 VDD.n1504 0.495739
R2410 VDD.n572 VDD.n1503 0.495739
R2411 VDD.n1502 VDD.n1501 0.495739
R2412 VDD.n1500 VDD.n1499 0.495739
R2413 VDD.n98 VDD.n1498 0.495739
R2414 VDD.n574 VDD.n1497 0.495739
R2415 VDD.n95 VDD.n1496 0.495739
R2416 VDD.n1494 VDD.n1493 0.495739
R2417 VDD.n1491 VDD.n1490 0.495739
R2418 VDD.n92 VDD.n1489 0.495739
R2419 VDD.n576 VDD.n1488 0.495739
R2420 VDD.n225 VDD.n1487 0.495739
R2421 VDD.n88 VDD.n1485 0.495739
R2422 VDD.n1483 VDD.n1482 0.495739
R2423 VDD.n85 VDD.n1481 0.495739
R2424 VDD.n83 VDD.n1480 0.495739
R2425 VDD.n1478 VDD.n1477 0.495739
R2426 VDD.n1474 VDD.n1473 0.495739
R2427 VDD.n577 VDD.n1472 0.495739
R2428 VDD.n579 VDD.n1471 0.495739
R2429 VDD.n80 VDD.n1470 0.495739
R2430 VDD.n1469 VDD.n1468 0.495739
R2431 VDD.n77 VDD.n1466 0.495739
R2432 VDD.n151 VDD.n1709 0.495739
R2433 VDD.n162 VDD.n1710 0.495739
R2434 VDD.n1712 VDD.n1711 0.495739
R2435 VDD.n159 VDD.n1713 0.495739
R2436 VDD.n1716 VDD.n1715 0.495739
R2437 VDD.n156 VDD.n1718 0.495739
R2438 VDD.n148 VDD.n1719 0.495739
R2439 VDD.n547 VDD.n1720 0.495739
R2440 VDD.n144 VDD.n586 0.495739
R2441 VDD.n550 VDD.n1721 0.495739
R2442 VDD.n142 VDD.n1722 0.495739
R2443 VDD.n553 VDD.n1723 0.495739
R2444 VDD.n138 VDD.n1724 0.495739
R2445 VDD.n135 VDD.n1725 0.495739
R2446 VDD.n132 VDD.n1726 0.495739
R2447 VDD.n130 VDD.n1727 0.495739
R2448 VDD.n127 VDD.n1729 0.495739
R2449 VDD.n125 VDD.n1730 0.495739
R2450 VDD.n555 VDD.n1731 0.495739
R2451 VDD.n122 VDD.n1733 0.495739
R2452 VDD.n559 VDD.n1734 0.495739
R2453 VDD.n1736 VDD.n1735 0.495739
R2454 VDD.n562 VDD.n1738 0.495739
R2455 VDD.n1740 VDD.n1739 0.495739
R2456 VDD.n564 VDD.n1741 0.495739
R2457 VDD.n1743 VDD.n1742 0.495739
R2458 VDD.n1745 VDD.n1744 0.495739
R2459 VDD.n1747 VDD.n1746 0.495739
R2460 VDD.n119 VDD.n1750 0.495739
R2461 VDD.n116 VDD.n1751 0.495739
R2462 VDD.n1754 VDD.n1753 0.495739
R2463 VDD.n113 VDD.n1757 0.495739
R2464 VDD.n566 VDD.n1758 0.495739
R2465 VDD.n1939 VDD.n1910 0.495739
R2466 VDD.n1941 VDD.n1909 0.495739
R2467 VDD.n1943 VDD.n472 0.495739
R2468 VDD.n1945 VDD.n475 0.495739
R2469 VDD.n1947 VDD.n196 0.495739
R2470 VDD.n1949 VDD.n193 0.495739
R2471 VDD.n1951 VDD.n191 0.495739
R2472 VDD.n1953 VDD.n1908 0.495739
R2473 VDD.n591 VDD.n188 0.495739
R2474 VDD.n1955 VDD.n185 0.495739
R2475 VDD.n1957 VDD.n478 0.495739
R2476 VDD.n1959 VDD.n481 0.495739
R2477 VDD.n1961 VDD.n1907 0.495739
R2478 VDD.n1963 VDD.n483 0.495739
R2479 VDD.n1965 VDD.n1906 0.495739
R2480 VDD.n1967 VDD.n181 0.495739
R2481 VDD.n1969 VDD.n1905 0.495739
R2482 VDD.n1971 VDD.n486 0.495739
R2483 VDD.n1973 VDD.n1904 0.495739
R2484 VDD.n1975 VDD.n488 0.495739
R2485 VDD.n1977 VDD.n177 0.495739
R2486 VDD.n1979 VDD.n174 0.495739
R2487 VDD.n1983 VDD.n491 0.495739
R2488 VDD.n1985 VDD.n530 0.495739
R2489 VDD.n1987 VDD.n1903 0.495739
R2490 VDD.n1989 VDD.n534 0.495739
R2491 VDD.n1991 VDD.n171 0.495739
R2492 VDD.n1993 VDD.n538 0.495739
R2493 VDD.n1995 VDD.n168 0.495739
R2494 VDD.n1997 VDD.n164 0.495739
R2495 VDD.n1999 VDD.n542 0.495739
R2496 VDD.n2001 VDD.n546 0.495739
R2497 VDD.n14 VDD.n1902 0.495739
R2498 VDD.n1134 VDD.n616 0.495739
R2499 VDD.n1136 VDD.n1098 0.495739
R2500 VDD.n1138 VDD.n218 0.495739
R2501 VDD.n1140 VDD.n439 0.495739
R2502 VDD.n1142 VDD.n18 0.495739
R2503 VDD.n1144 VDD.n443 0.495739
R2504 VDD.n1146 VDD.n446 0.495739
R2505 VDD.n1148 VDD.n1097 0.495739
R2506 VDD.n594 VDD.n593 0.495739
R2507 VDD.n1150 VDD.n447 0.495739
R2508 VDD.n1152 VDD.n449 0.495739
R2509 VDD.n1154 VDD.n1096 0.495739
R2510 VDD.n1156 VDD.n453 0.495739
R2511 VDD.n1158 VDD.n215 0.495739
R2512 VDD.n1160 VDD.n212 0.495739
R2513 VDD.n1162 VDD.n209 0.495739
R2514 VDD.n1164 VDD.n457 0.495739
R2515 VDD.n1166 VDD.n206 0.495739
R2516 VDD.n1168 VDD.n1095 0.495739
R2517 VDD.n1170 VDD.n202 0.495739
R2518 VDD.n1172 VDD.n0 0.495739
R2519 VDD.n1174 VDD.n9 0.495739
R2520 VDD.n1178 VDD.n461 0.495739
R2521 VDD.n1180 VDD.n464 0.495739
R2522 VDD.n1182 VDD.n1094 0.495739
R2523 VDD.n1184 VDD.n199 0.495739
R2524 VDD.n1186 VDD.n6 0.495739
R2525 VDD.n1188 VDD.n5 0.495739
R2526 VDD.n1190 VDD.n1093 0.495739
R2527 VDD.n1192 VDD.n467 0.495739
R2528 VDD.n3 VDD.n469 0.617243
R2529 VDD.t374 VDD.n2 0.629622
R2530 VDD.n969 VDD.n968 0.495398
R2531 VDD.n963 VDD.n962 0.495398
R2532 VDD.n957 VDD.n956 0.495398
R2533 VDD.n951 VDD.n950 0.495398
R2534 VDD.n945 VDD.n944 0.495398
R2535 VDD.n939 VDD.n938 0.495398
R2536 VDD.n933 VDD.n932 0.495398
R2537 VDD.n927 VDD.n926 0.495398
R2538 VDD.n921 VDD.n920 0.495398
R2539 VDD.n915 VDD.n914 0.495398
R2540 VDD.n909 VDD.n908 0.495398
R2541 VDD.n901 VDD.n900 0.495398
R2542 VDD.n895 VDD.n894 0.495398
R2543 VDD.n889 VDD.n888 0.495398
R2544 VDD.n883 VDD.n882 0.495398
R2545 VDD.n877 VDD.n876 0.495398
R2546 VDD.n871 VDD.n870 0.495398
R2547 VDD.n865 VDD.n864 0.495398
R2548 VDD.n859 VDD.n858 0.495398
R2549 VDD.n853 VDD.n852 0.495398
R2550 VDD.n847 VDD.n846 0.495398
R2551 VDD.n841 VDD.n840 0.495398
R2552 VDD.n835 VDD.n834 0.495398
R2553 VDD.n829 VDD.n828 0.495398
R2554 VDD.n821 VDD.n597 0.495398
R2555 VDD.n816 VDD.n815 0.495398
R2556 VDD.n810 VDD.n809 0.495398
R2557 VDD.n804 VDD.n803 0.495398
R2558 VDD.n798 VDD.n797 0.495398
R2559 VDD.n792 VDD.n791 0.495398
R2560 VDD.n786 VDD.n785 0.495398
R2561 VDD.n780 VDD.n779 0.495398
R2562 VDD.n774 VDD.n773 0.495398
R2563 VDD.n56 VDD.n706 0.495398
R2564 VDD.n2022 VDD.n2021 0.492175
R2565 VDD.n2052 VDD.n2045 0.492175
R2566 VDD.n2050 VDD.n2049 0.492005
R2567 VDD.n2024 VDD.n2017 0.492005
R2568 VDD.n2050 VDD.n2047 0.491643
R2569 VDD.n2025 VDD.n2024 0.491643
R2570 VDD.n2022 VDD.n2019 0.491464
R2571 VDD.n2053 VDD.n2052 0.491464
R2572 VDD.n970 VDD.n969 0.478641
R2573 VDD.n964 VDD.n963 0.478641
R2574 VDD.n958 VDD.n957 0.478641
R2575 VDD.n952 VDD.n951 0.478641
R2576 VDD.n946 VDD.n945 0.478641
R2577 VDD.n940 VDD.n939 0.478641
R2578 VDD.n934 VDD.n933 0.478641
R2579 VDD.n928 VDD.n927 0.478641
R2580 VDD.n922 VDD.n921 0.478641
R2581 VDD.n916 VDD.n915 0.478641
R2582 VDD.n910 VDD.n909 0.478641
R2583 VDD.n902 VDD.n901 0.478641
R2584 VDD.n896 VDD.n895 0.478641
R2585 VDD.n890 VDD.n889 0.478641
R2586 VDD.n884 VDD.n883 0.478641
R2587 VDD.n878 VDD.n877 0.478641
R2588 VDD.n872 VDD.n871 0.478641
R2589 VDD.n866 VDD.n865 0.478641
R2590 VDD.n860 VDD.n859 0.478641
R2591 VDD.n854 VDD.n853 0.478641
R2592 VDD.n848 VDD.n847 0.478641
R2593 VDD.n842 VDD.n841 0.478641
R2594 VDD.n836 VDD.n835 0.478641
R2595 VDD.n830 VDD.n829 0.478641
R2596 VDD.n822 VDD.n821 0.478641
R2597 VDD.n817 VDD.n816 0.478641
R2598 VDD.n811 VDD.n810 0.478641
R2599 VDD.n805 VDD.n804 0.478641
R2600 VDD.n799 VDD.n798 0.478641
R2601 VDD.n793 VDD.n792 0.478641
R2602 VDD.n787 VDD.n786 0.478641
R2603 VDD.n781 VDD.n780 0.478641
R2604 VDD.n775 VDD.n774 0.478641
R2605 VDD.n59 VDD.n56 0.478641
R2606 VDD.n613 VDD.n612 0.478299
R2607 VDD.n1529 VDD.n1517 0.478299
R2608 VDD.n1515 VDD.n1514 0.478299
R2609 VDD.n111 VDD.n110 0.478299
R2610 VDD.n108 VDD.n107 0.478299
R2611 VDD.n1534 VDD.n1510 0.478299
R2612 VDD.n569 VDD.n568 0.478299
R2613 VDD.n105 VDD.n104 0.478299
R2614 VDD.n240 VDD.n239 0.478299
R2615 VDD.n102 VDD.n101 0.478299
R2616 VDD.n571 VDD.n570 0.478299
R2617 VDD.n573 VDD.n572 0.478299
R2618 VDD.n1538 VDD.n1502 0.478299
R2619 VDD.n1541 VDD.n1500 0.478299
R2620 VDD.n99 VDD.n98 0.478299
R2621 VDD.n575 VDD.n574 0.478299
R2622 VDD.n96 VDD.n95 0.478299
R2623 VDD.n1495 VDD.n1494 0.478299
R2624 VDD.n1492 VDD.n1491 0.478299
R2625 VDD.n93 VDD.n92 0.478299
R2626 VDD.n91 VDD.n576 0.478299
R2627 VDD.n226 VDD.n225 0.478299
R2628 VDD.n89 VDD.n88 0.478299
R2629 VDD.n1484 VDD.n1483 0.478299
R2630 VDD.n84 VDD.n83 0.478299
R2631 VDD.n1479 VDD.n1478 0.478299
R2632 VDD.n1475 VDD.n1474 0.478299
R2633 VDD.n578 VDD.n577 0.478299
R2634 VDD.n580 VDD.n579 0.478299
R2635 VDD.n81 VDD.n80 0.478299
R2636 VDD.n1549 VDD.n1469 0.478299
R2637 VDD.n78 VDD.n77 0.478299
R2638 VDD.n155 VDD.n151 0.478299
R2639 VDD.n1777 VDD.n1712 0.478299
R2640 VDD.n160 VDD.n159 0.478299
R2641 VDD.n1717 VDD.n1716 0.478299
R2642 VDD.n157 VDD.n156 0.478299
R2643 VDD.n149 VDD.n148 0.478299
R2644 VDD.n548 VDD.n547 0.478299
R2645 VDD.n146 VDD.n144 0.478299
R2646 VDD.n551 VDD.n550 0.478299
R2647 VDD.n143 VDD.n142 0.478299
R2648 VDD.n554 VDD.n553 0.478299
R2649 VDD.n139 VDD.n138 0.478299
R2650 VDD.n136 VDD.n135 0.478299
R2651 VDD.n133 VDD.n132 0.478299
R2652 VDD.n131 VDD.n130 0.478299
R2653 VDD.n128 VDD.n127 0.478299
R2654 VDD.n556 VDD.n555 0.478299
R2655 VDD.n123 VDD.n122 0.478299
R2656 VDD.n560 VDD.n559 0.478299
R2657 VDD.n1737 VDD.n1736 0.478299
R2658 VDD.n563 VDD.n562 0.478299
R2659 VDD.n1769 VDD.n1740 0.478299
R2660 VDD.n565 VDD.n564 0.478299
R2661 VDD.n1766 VDD.n1743 0.478299
R2662 VDD.n1763 VDD.n1745 0.478299
R2663 VDD.n1748 VDD.n1747 0.478299
R2664 VDD.n120 VDD.n119 0.478299
R2665 VDD.n117 VDD.n116 0.478299
R2666 VDD.n1755 VDD.n1754 0.478299
R2667 VDD.n114 VDD.n113 0.478299
R2668 VDD.n567 VDD.n566 0.478299
R2669 VDD.n1933 VDD.n1910 0.478299
R2670 VDD.n1916 VDD.n1909 0.478299
R2671 VDD.n473 VDD.n472 0.478299
R2672 VDD.n470 VDD.n475 0.478299
R2673 VDD.n197 VDD.n196 0.478299
R2674 VDD.n194 VDD.n193 0.478299
R2675 VDD.n192 VDD.n191 0.478299
R2676 VDD.n1917 VDD.n1908 0.478299
R2677 VDD.n189 VDD.n188 0.478299
R2678 VDD.n186 VDD.n185 0.478299
R2679 VDD.n184 VDD.n478 0.478299
R2680 VDD.n476 VDD.n481 0.478299
R2681 VDD.n1919 VDD.n1907 0.478299
R2682 VDD.n484 VDD.n483 0.478299
R2683 VDD.n1920 VDD.n1906 0.478299
R2684 VDD.n182 VDD.n181 0.478299
R2685 VDD.n1921 VDD.n1905 0.478299
R2686 VDD.n487 VDD.n486 0.478299
R2687 VDD.n1922 VDD.n1904 0.478299
R2688 VDD.n489 VDD.n488 0.478299
R2689 VDD.n179 VDD.n177 0.478299
R2690 VDD.n175 VDD.n174 0.478299
R2691 VDD.n492 VDD.n491 0.478299
R2692 VDD.n531 VDD.n530 0.478299
R2693 VDD.n1923 VDD.n1903 0.478299
R2694 VDD.n535 VDD.n534 0.478299
R2695 VDD.n172 VDD.n171 0.478299
R2696 VDD.n539 VDD.n538 0.478299
R2697 VDD.n169 VDD.n168 0.478299
R2698 VDD.n165 VDD.n164 0.478299
R2699 VDD.n543 VDD.n542 0.478299
R2700 VDD.n540 VDD.n546 0.478299
R2701 VDD.n1924 VDD.n1902 0.478299
R2702 VDD.n617 VDD.n616 0.478299
R2703 VDD.n1102 VDD.n1098 0.478299
R2704 VDD.n219 VDD.n218 0.478299
R2705 VDD.n440 VDD.n439 0.478299
R2706 VDD.n19 VDD.n18 0.478299
R2707 VDD.n444 VDD.n443 0.478299
R2708 VDD.n441 VDD.n446 0.478299
R2709 VDD.n1124 VDD.n1097 0.478299
R2710 VDD.n1121 VDD.n593 0.478299
R2711 VDD.n448 VDD.n447 0.478299
R2712 VDD.n450 VDD.n449 0.478299
R2713 VDD.n1116 VDD.n1096 0.478299
R2714 VDD.n454 VDD.n453 0.478299
R2715 VDD.n216 VDD.n215 0.478299
R2716 VDD.n213 VDD.n212 0.478299
R2717 VDD.n210 VDD.n209 0.478299
R2718 VDD.n458 VDD.n457 0.478299
R2719 VDD.n207 VDD.n206 0.478299
R2720 VDD.n1112 VDD.n1095 0.478299
R2721 VDD.n203 VDD.n202 0.478299
R2722 VDD.n1 VDD.n0 0.478299
R2723 VDD.n10 VDD.n9 0.478299
R2724 VDD.n462 VDD.n461 0.478299
R2725 VDD.n459 VDD.n464 0.478299
R2726 VDD.n1108 VDD.n1094 0.478299
R2727 VDD.n200 VDD.n199 0.478299
R2728 VDD.n7 VDD.n6 0.478299
R2729 VDD.n7 VDD.n5 0.478299
R2730 VDD.n1103 VDD.n1093 0.478299
R2731 VDD.n468 VDD.n467 0.478299
R2732 VDD.n465 VDD.n469 0.478299
R2733 VDD.n21 VDD.n2 0.478299
R2734 VDD.n846 VDD.n752 0.467341
R2735 VDD.n968 VDD.n730 0.467273
R2736 VDD.n870 VDD.n748 0.467273
R2737 VDD.n888 VDD.n745 0.467182
R2738 VDD.n1466 VDD.n1464 0.467143
R2739 VDD.n1468 VDD.n1463 0.467143
R2740 VDD.n1470 VDD.n1462 0.467143
R2741 VDD.n1471 VDD.n1461 0.467143
R2742 VDD.n1472 VDD.n1460 0.467143
R2743 VDD.n1473 VDD.n1459 0.467143
R2744 VDD.n1477 VDD.n1458 0.467143
R2745 VDD.n1480 VDD.n1457 0.467143
R2746 VDD.n1481 VDD.n1456 0.467143
R2747 VDD.n1482 VDD.n1455 0.467143
R2748 VDD.n1487 VDD.n1451 0.467143
R2749 VDD.n1488 VDD.n1450 0.467143
R2750 VDD.n1489 VDD.n1449 0.467143
R2751 VDD.n1490 VDD.n1448 0.467143
R2752 VDD.n1493 VDD.n1447 0.467143
R2753 VDD.n1496 VDD.n1446 0.467143
R2754 VDD.n1497 VDD.n1445 0.467143
R2755 VDD.n1498 VDD.n1444 0.467143
R2756 VDD.n1499 VDD.n1443 0.467143
R2757 VDD.n1501 VDD.n1442 0.467143
R2758 VDD.n1503 VDD.n1441 0.467143
R2759 VDD.n1504 VDD.n1440 0.467143
R2760 VDD.n1505 VDD.n582 0.467143
R2761 VDD.n583 VDD.n581 0.467143
R2762 VDD.n1506 VDD.n1439 0.467143
R2763 VDD.n1508 VDD.n1438 0.467143
R2764 VDD.n1509 VDD.n1437 0.467143
R2765 VDD.n1511 VDD.n1436 0.467143
R2766 VDD.n1512 VDD.n1435 0.467143
R2767 VDD.n1513 VDD.n1434 0.467143
R2768 VDD.n1758 VDD.n1673 0.467143
R2769 VDD.n1757 VDD.n1674 0.467143
R2770 VDD.n1753 VDD.n1675 0.467143
R2771 VDD.n1751 VDD.n1676 0.467143
R2772 VDD.n1750 VDD.n1677 0.467143
R2773 VDD.n1746 VDD.n1678 0.467143
R2774 VDD.n1744 VDD.n1679 0.467143
R2775 VDD.n1742 VDD.n1680 0.467143
R2776 VDD.n1741 VDD.n1681 0.467143
R2777 VDD.n1739 VDD.n1682 0.467143
R2778 VDD.n1735 VDD.n1686 0.467143
R2779 VDD.n1734 VDD.n1687 0.467143
R2780 VDD.n1733 VDD.n1688 0.467143
R2781 VDD.n1731 VDD.n1689 0.467143
R2782 VDD.n1730 VDD.n1690 0.467143
R2783 VDD.n1729 VDD.n1691 0.467143
R2784 VDD.n1727 VDD.n1692 0.467143
R2785 VDD.n1726 VDD.n1693 0.467143
R2786 VDD.n1725 VDD.n1694 0.467143
R2787 VDD.n1724 VDD.n1695 0.467143
R2788 VDD.n1723 VDD.n1696 0.467143
R2789 VDD.n1722 VDD.n1697 0.467143
R2790 VDD.n1721 VDD.n585 0.467143
R2791 VDD.n586 VDD.n584 0.467143
R2792 VDD.n1720 VDD.n1698 0.467143
R2793 VDD.n1719 VDD.n1699 0.467143
R2794 VDD.n1718 VDD.n1700 0.467143
R2795 VDD.n1715 VDD.n1701 0.467143
R2796 VDD.n1713 VDD.n1702 0.467143
R2797 VDD.n1711 VDD.n1703 0.467143
R2798 VDD.n14 VDD.n2002 0.467143
R2799 VDD.n2001 VDD.n2000 0.467143
R2800 VDD.n1999 VDD.n1998 0.467143
R2801 VDD.n1997 VDD.n1996 0.467143
R2802 VDD.n1995 VDD.n1994 0.467143
R2803 VDD.n1993 VDD.n1992 0.467143
R2804 VDD.n1991 VDD.n1990 0.467143
R2805 VDD.n1989 VDD.n1988 0.467143
R2806 VDD.n1987 VDD.n1986 0.467143
R2807 VDD.n1985 VDD.n1984 0.467143
R2808 VDD.n1979 VDD.n1978 0.467143
R2809 VDD.n1977 VDD.n1976 0.467143
R2810 VDD.n1975 VDD.n1974 0.467143
R2811 VDD.n1973 VDD.n1972 0.467143
R2812 VDD.n1971 VDD.n1970 0.467143
R2813 VDD.n1969 VDD.n1968 0.467143
R2814 VDD.n1967 VDD.n1966 0.467143
R2815 VDD.n1965 VDD.n1964 0.467143
R2816 VDD.n1963 VDD.n1962 0.467143
R2817 VDD.n1961 VDD.n1960 0.467143
R2818 VDD.n1959 VDD.n1958 0.467143
R2819 VDD.n1957 VDD.n1956 0.467143
R2820 VDD.n1955 VDD.n1954 0.467143
R2821 VDD.n591 VDD.n590 0.467143
R2822 VDD.n1953 VDD.n1952 0.467143
R2823 VDD.n1951 VDD.n1950 0.467143
R2824 VDD.n1949 VDD.n1948 0.467143
R2825 VDD.n1947 VDD.n1946 0.467143
R2826 VDD.n1945 VDD.n1944 0.467143
R2827 VDD.n1943 VDD.n1942 0.467143
R2828 VDD.n3 VDD.n1192 0.717111
R2829 VDD.n1192 VDD.n1191 0.467143
R2830 VDD.n1190 VDD.n1189 0.467143
R2831 VDD.n1188 VDD.n1187 0.467143
R2832 VDD.n1186 VDD.n1185 0.467143
R2833 VDD.n1184 VDD.n1183 0.467143
R2834 VDD.n1182 VDD.n1181 0.467143
R2835 VDD.n1180 VDD.n1179 0.467143
R2836 VDD.n1174 VDD.n1173 0.467143
R2837 VDD.n1172 VDD.n1171 0.467143
R2838 VDD.n1170 VDD.n1169 0.467143
R2839 VDD.n1168 VDD.n1167 0.467143
R2840 VDD.n1166 VDD.n1165 0.467143
R2841 VDD.n1164 VDD.n1163 0.467143
R2842 VDD.n1162 VDD.n1161 0.467143
R2843 VDD.n1160 VDD.n1159 0.467143
R2844 VDD.n1158 VDD.n1157 0.467143
R2845 VDD.n1156 VDD.n1155 0.467143
R2846 VDD.n1154 VDD.n1153 0.467143
R2847 VDD.n1152 VDD.n1151 0.467143
R2848 VDD.n1150 VDD.n1149 0.467143
R2849 VDD.n594 VDD.n592 0.467143
R2850 VDD.n1148 VDD.n1147 0.467143
R2851 VDD.n1146 VDD.n1145 0.467143
R2852 VDD.n1144 VDD.n1143 0.467143
R2853 VDD.n1142 VDD.n1141 0.467143
R2854 VDD.n1140 VDD.n1139 0.467143
R2855 VDD.n1138 VDD.n1137 0.467143
R2856 VDD.n858 VDD.n750 0.467143
R2857 VDD.n950 VDD.n733 0.467143
R2858 VDD.n840 VDD.n753 0.467079
R2859 VDD.n864 VDD.n749 0.467012
R2860 VDD.n797 VDD.n758 0.466963
R2861 VDD.n894 VDD.n744 0.466945
R2862 VDD.n815 VDD.n755 0.46682
R2863 VDD.n834 VDD.n754 0.466762
R2864 VDD.n926 VDD.n737 0.466622
R2865 VDD.n944 VDD.n734 0.466589
R2866 VDD.n791 VDD.n759 0.466555
R2867 VDD.n876 VDD.n747 0.46654
R2868 VDD.n914 VDD.n739 0.466497
R2869 VDD.n852 VDD.n751 0.466493
R2870 VDD.n956 VDD.n732 0.466464
R2871 VDD.n962 VDD.n731 0.46646
R2872 VDD.n597 VDD.n595 0.466426
R2873 VDD.n785 VDD.n760 0.466426
R2874 VDD.n920 VDD.n738 0.466314
R2875 VDD.n809 VDD.n756 0.466314
R2876 VDD.n882 VDD.n746 0.466253
R2877 VDD.n938 VDD.n735 0.466177
R2878 VDD.n900 VDD.n743 0.466113
R2879 VDD.n932 VDD.n736 0.466098
R2880 VDD.n803 VDD.n757 0.466025
R2881 VDD.n828 VDD.n596 0.465993
R2882 VDD.n797 VDD.n757 0.451904
R2883 VDD.n926 VDD.n736 0.451803
R2884 VDD.n894 VDD.n743 0.451801
R2885 VDD.n932 VDD.n735 0.451743
R2886 VDD.n876 VDD.n746 0.451699
R2887 VDD.n914 VDD.n738 0.451566
R2888 VDD.n803 VDD.n756 0.451566
R2889 VDD.n908 VDD.n739 0.451497
R2890 VDD.n779 VDD.n760 0.451477
R2891 VDD.n815 VDD.n595 0.451477
R2892 VDD.n956 VDD.n731 0.45146
R2893 VDD.n950 VDD.n732 0.451456
R2894 VDD.n938 VDD.n734 0.451368
R2895 VDD.n846 VDD.n751 0.451366
R2896 VDD.n785 VDD.n759 0.451324
R2897 VDD.n870 VDD.n747 0.451316
R2898 VDD.n920 VDD.n737 0.451269
R2899 VDD.n809 VDD.n755 0.451146
R2900 VDD.n828 VDD.n754 0.451126
R2901 VDD.n888 VDD.n744 0.451058
R2902 VDD.n791 VDD.n758 0.450967
R2903 VDD.n858 VDD.n749 0.450921
R2904 VDD.n834 VDD.n753 0.450883
R2905 VDD.n1512 VDD.n1436 0.450828
R2906 VDD.n1511 VDD.n1437 0.450828
R2907 VDD.n1508 VDD.n1439 0.450828
R2908 VDD.n1506 VDD.n581 0.450828
R2909 VDD.n1504 VDD.n1441 0.450828
R2910 VDD.n1497 VDD.n1446 0.450828
R2911 VDD.n1490 VDD.n1449 0.450828
R2912 VDD.n1485 VDD.n1455 0.450828
R2913 VDD.n1481 VDD.n1457 0.450828
R2914 VDD.n1477 VDD.n1459 0.450828
R2915 VDD.n1472 VDD.n1461 0.450828
R2916 VDD.n1468 VDD.n1464 0.450828
R2917 VDD.n1470 VDD.n1463 0.450828
R2918 VDD.n1471 VDD.n1462 0.450828
R2919 VDD.n1473 VDD.n1460 0.450828
R2920 VDD.n1480 VDD.n1458 0.450828
R2921 VDD.n1482 VDD.n1456 0.450828
R2922 VDD.n1488 VDD.n1451 0.450828
R2923 VDD.n1489 VDD.n1450 0.450828
R2924 VDD.n1493 VDD.n1448 0.450828
R2925 VDD.n1496 VDD.n1447 0.450828
R2926 VDD.n1498 VDD.n1445 0.450828
R2927 VDD.n1499 VDD.n1444 0.450828
R2928 VDD.n1501 VDD.n1443 0.450828
R2929 VDD.n1503 VDD.n1442 0.450828
R2930 VDD.n1505 VDD.n1440 0.450828
R2931 VDD.n1509 VDD.n1438 0.450828
R2932 VDD.n1513 VDD.n1435 0.450828
R2933 VDD.n1516 VDD.n1434 0.450828
R2934 VDD.n1710 VDD.n1703 0.450828
R2935 VDD.n1718 VDD.n1699 0.450828
R2936 VDD.n1719 VDD.n1698 0.450828
R2937 VDD.n1729 VDD.n1690 0.450828
R2938 VDD.n1730 VDD.n1689 0.450828
R2939 VDD.n1731 VDD.n1688 0.450828
R2940 VDD.n1739 VDD.n1681 0.450828
R2941 VDD.n1741 VDD.n1680 0.450828
R2942 VDD.n1742 VDD.n1679 0.450828
R2943 VDD.n1746 VDD.n1677 0.450828
R2944 VDD.n1750 VDD.n1676 0.450828
R2945 VDD.n1757 VDD.n1673 0.450828
R2946 VDD.n1753 VDD.n1674 0.450828
R2947 VDD.n1751 VDD.n1675 0.450828
R2948 VDD.n1744 VDD.n1678 0.450828
R2949 VDD.n1738 VDD.n1682 0.450828
R2950 VDD.n1734 VDD.n1686 0.450828
R2951 VDD.n1733 VDD.n1687 0.450828
R2952 VDD.n1727 VDD.n1691 0.450828
R2953 VDD.n1726 VDD.n1692 0.450828
R2954 VDD.n1725 VDD.n1693 0.450828
R2955 VDD.n1724 VDD.n1694 0.450828
R2956 VDD.n1723 VDD.n1695 0.450828
R2957 VDD.n1722 VDD.n1696 0.450828
R2958 VDD.n1721 VDD.n1697 0.450828
R2959 VDD.n1720 VDD.n584 0.450828
R2960 VDD.n1715 VDD.n1700 0.450828
R2961 VDD.n1713 VDD.n1701 0.450828
R2962 VDD.n1711 VDD.n1702 0.450828
R2963 VDD.n1942 VDD.n1941 0.450828
R2964 VDD.n1944 VDD.n1943 0.450828
R2965 VDD.n1946 VDD.n1945 0.450828
R2966 VDD.n1948 VDD.n1947 0.450828
R2967 VDD.n1952 VDD.n1951 0.450828
R2968 VDD.n1956 VDD.n1955 0.450828
R2969 VDD.n1960 VDD.n1959 0.450828
R2970 VDD.n1964 VDD.n1963 0.450828
R2971 VDD.n1968 VDD.n1967 0.450828
R2972 VDD.n1970 VDD.n1969 0.450828
R2973 VDD.n1972 VDD.n1971 0.450828
R2974 VDD.n1978 VDD.n1977 0.450828
R2975 VDD.n1984 VDD.n1983 0.450828
R2976 VDD.n1986 VDD.n1985 0.450828
R2977 VDD.n1990 VDD.n1989 0.450828
R2978 VDD.n1994 VDD.n1993 0.450828
R2979 VDD.n2002 VDD.n2001 0.450828
R2980 VDD.n2000 VDD.n1999 0.450828
R2981 VDD.n1998 VDD.n1997 0.450828
R2982 VDD.n1996 VDD.n1995 0.450828
R2983 VDD.n1992 VDD.n1991 0.450828
R2984 VDD.n1988 VDD.n1987 0.450828
R2985 VDD.n1976 VDD.n1975 0.450828
R2986 VDD.n1974 VDD.n1973 0.450828
R2987 VDD.n1966 VDD.n1965 0.450828
R2988 VDD.n1962 VDD.n1961 0.450828
R2989 VDD.n1958 VDD.n1957 0.450828
R2990 VDD.n590 VDD.n1953 0.450828
R2991 VDD.n1950 VDD.n1949 0.450828
R2992 VDD.n1137 VDD.n1136 0.450828
R2993 VDD.n1141 VDD.n1140 0.450828
R2994 VDD.n1143 VDD.n1142 0.450828
R2995 VDD.n1151 VDD.n1150 0.450828
R2996 VDD.n1153 VDD.n1152 0.450828
R2997 VDD.n1155 VDD.n1154 0.450828
R2998 VDD.n1161 VDD.n1160 0.450828
R2999 VDD.n1165 VDD.n1164 0.450828
R3000 VDD.n1167 VDD.n1166 0.450828
R3001 VDD.n1173 VDD.n1172 0.450828
R3002 VDD.n1181 VDD.n1180 0.450828
R3003 VDD.n1187 VDD.n1186 0.450828
R3004 VDD.n1191 VDD.n1190 0.450828
R3005 VDD.n1189 VDD.n1188 0.450828
R3006 VDD.n1185 VDD.n1184 0.450828
R3007 VDD.n1183 VDD.n1182 0.450828
R3008 VDD.n1179 VDD.n1178 0.450828
R3009 VDD.n1171 VDD.n1170 0.450828
R3010 VDD.n1169 VDD.n1168 0.450828
R3011 VDD.n1163 VDD.n1162 0.450828
R3012 VDD.n1159 VDD.n1158 0.450828
R3013 VDD.n1157 VDD.n1156 0.450828
R3014 VDD.n592 VDD.n1148 0.450828
R3015 VDD.n1147 VDD.n1146 0.450828
R3016 VDD.n1145 VDD.n1144 0.450828
R3017 VDD.n1139 VDD.n1138 0.450828
R3018 VDD.n944 VDD.n733 0.450828
R3019 VDD.n852 VDD.n750 0.450828
R3020 VDD.n882 VDD.n745 0.450768
R3021 VDD.n962 VDD.n730 0.450672
R3022 VDD.n864 VDD.n748 0.450672
R3023 VDD.n840 VDD.n752 0.450618
R3024 VDD.n1520 VDD.n1519 0.446112
R3025 VDD.n152 VDD.n1708 0.446112
R3026 VDD.n67 VDD.n1911 0.446112
R3027 VDD.n70 VDD.n1099 0.446112
R3028 VDD.n770 VDD.n769 0.446112
R3029 VDD.n2055 VDD.n2054 0.432202
R3030 VDD.n29 VDD.n223 0.135528
R3031 VDD.n25 VDD.n76 0.135528
R3032 VDD.n17 VDD.n16 0.216731
R3033 VDD.n13 VDD.n11 0.237106
R3034 VDD.n59 VDD.n57 0.429929
R3035 VDD.n1521 VDD.n1465 0.429766
R3036 VDD.n1706 VDD.n153 0.537959
R3037 VDD.n1132 VDD.n1131 0.429766
R3038 VDD.n764 VDD.n763 0.428915
R3039 VDD.n767 VDD.n763 0.426918
R3040 VDD.n1524 VDD.n1523 0.426806
R3041 VDD.n1526 VDD.n1520 0.426806
R3042 VDD.n155 VDD.n154 0.426806
R3043 VDD.n155 VDD.n152 0.426806
R3044 VDD.n1914 VDD.n1913 0.426806
R3045 VDD.n1935 VDD.n1911 0.426806
R3046 VDD.n1130 VDD.n1101 0.426806
R3047 VDD.n1128 VDD.n1099 0.426806
R3048 VDD.n767 VDD.n766 0.426806
R3049 VDD.n771 VDD.n770 0.426806
R3050 VDD.n1524 VDD.n1465 0.426171
R3051 VDD.n1131 VDD.n1130 0.426171
R3052 VDD.n39 VDD.n38 0.424842
R3053 VDD.n54 VDD.n38 0.424687
R3054 VDD.n1550 VDD.n28 0.413465
R3055 VDD.n1759 VDD.n24 0.413465
R3056 VDD.n16 VDD.n15 0.413465
R3057 VDD.n13 VDD.n12 0.413465
R3058 VDD.n52 VDD.n39 0.413465
R3059 VDD.n707 VDD.n41 0.413465
R3060 VDD.n1672 VDD.n1671 0.405593
R3061 VDD.n1900 VDD.n1899 0.405593
R3062 VDD.n1313 VDD.n1194 0.405593
R3063 VDD.n1090 VDD.n972 0.405593
R3064 VDD.n2055 VDD.n35 0.404675
R3065 VDD.n1937 VDD.n660 0.429766
R3066 VDD.n741 VDD.n740 0.383025
R3067 VDD.n1454 VDD.n1453 0.382697
R3068 VDD.n1684 VDD.n1683 0.382697
R3069 VDD.n1982 VDD.n1981 0.382697
R3070 VDD.n1177 VDD.n1176 0.382697
R3071 VDD.n1485 VDD.n1454 0.381004
R3072 VDD.n1738 VDD.n1683 0.381004
R3073 VDD.n1983 VDD.n1982 0.381004
R3074 VDD.n1178 VDD.n1177 0.381004
R3075 VDD.n908 VDD.n740 0.380674
R3076 VDD.n2037 VDD.n2036 0.372655
R3077 VDD.n2033 VDD.n724 0.372571
R3078 VDD.n819 VDD.n818 0.355452
R3079 VDD.n954 VDD.n953 0.355452
R3080 VDD.n948 VDD.n947 0.355452
R3081 VDD.n898 VDD.n897 0.355452
R3082 VDD.n862 VDD.n861 0.355452
R3083 VDD.n844 VDD.n843 0.355452
R3084 VDD.n856 VDD.n855 0.355386
R3085 VDD.n966 VDD.n965 0.355312
R3086 VDD.n789 VDD.n788 0.355312
R3087 VDD.n960 VDD.n959 0.355155
R3088 VDD.n912 VDD.n911 0.355155
R3089 VDD.n936 VDD.n935 0.355155
R3090 VDD.n795 VDD.n794 0.355155
R3091 VDD.n924 VDD.n923 0.35515
R3092 VDD.n886 VDD.n885 0.35501
R3093 VDD.n918 VDD.n917 0.354936
R3094 VDD.n874 VDD.n873 0.354936
R3095 VDD.n850 VDD.n849 0.354936
R3096 VDD.n838 VDD.n837 0.354936
R3097 VDD.n813 VDD.n812 0.354936
R3098 VDD.n807 VDD.n806 0.354936
R3099 VDD.n783 VDD.n782 0.354936
R3100 VDD.n892 VDD.n891 0.354903
R3101 VDD.n880 VDD.n879 0.354903
R3102 VDD.n868 VDD.n867 0.354903
R3103 VDD.n2031 VDD.n2027 0.354771
R3104 VDD.n930 VDD.n929 0.354771
R3105 VDD.n832 VDD.n831 0.354771
R3106 VDD.n801 VDD.n800 0.354771
R3107 VDD.n2028 VDD.n726 0.354692
R3108 VDD.n942 VDD.n941 0.354557
R3109 VDD.n1374 VDD.n1373 0.348249
R3110 VDD.n1614 VDD.n1613 0.348249
R3111 VDD.n1842 VDD.n1841 0.348249
R3112 VDD.n1256 VDD.n1255 0.348249
R3113 VDD.n1033 VDD.n1032 0.348249
R3114 VDD.n2038 VDD.n723 0.347655
R3115 VDD.n2042 VDD.n2041 0.347571
R3116 VDD.n2028 VDD.n725 0.347254
R3117 VDD.n2032 VDD.n2031 0.347039
R3118 VDD.n2009 VDD.n2008 0.342527
R3119 VDD.n721 VDD.n720 0.335799
R3120 VDD.n713 VDD.n712 0.335496
R3121 VDD.n2046 VDD.n2042 0.334771
R3122 VDD.n2048 VDD.n723 0.334692
R3123 VDD.n716 VDD.n713 0.332368
R3124 VDD.n721 VDD.n719 0.332058
R3125 VDD.n2044 VDD.n34 0.383516
R3126 VDD.n2036 VDD.n2032 0.329132
R3127 VDD.n2033 VDD.n725 0.328947
R3128 VDD.n2016 VDD.n726 0.327655
R3129 VDD.n2027 VDD.n2026 0.327571
R3130 VDD.n222 VDD.n1550 0.327154
R3131 VDD.n75 VDD.n1759 0.327154
R3132 VDD.n15 VDD.n1901 0.327154
R3133 VDD.n54 VDD.n52 0.327154
R3134 VDD.n58 VDD.n707 0.327154
R3135 VDD.n2020 VDD.n728 0.319294
R3136 VDD.n1523 VDD.n1522 0.313353
R3137 VDD.n154 VDD.n1707 0.313353
R3138 VDD.n1913 VDD.n1912 0.313353
R3139 VDD.n1101 VDD.n1100 0.313353
R3140 VDD.n766 VDD.n765 0.313353
R3141 VDD.n941 VDD.n940 0.310312
R3142 VDD.n929 VDD.n928 0.310071
R3143 VDD.n831 VDD.n830 0.310071
R3144 VDD.n800 VDD.n799 0.310071
R3145 VDD.n891 VDD.n890 0.309933
R3146 VDD.n879 VDD.n878 0.309933
R3147 VDD.n867 VDD.n866 0.309933
R3148 VDD.n917 VDD.n916 0.309928
R3149 VDD.n873 VDD.n872 0.309928
R3150 VDD.n849 VDD.n848 0.309928
R3151 VDD.n837 VDD.n836 0.309928
R3152 VDD.n812 VDD.n811 0.309928
R3153 VDD.n806 VDD.n805 0.309928
R3154 VDD.n782 VDD.n781 0.309928
R3155 VDD.n885 VDD.n884 0.309837
R3156 VDD.n2038 VDD.n724 0.309771
R3157 VDD.n923 VDD.n922 0.309697
R3158 VDD.n959 VDD.n958 0.309692
R3159 VDD.n2041 VDD.n2037 0.309692
R3160 VDD.n935 VDD.n934 0.309692
R3161 VDD.n911 VDD.n910 0.309692
R3162 VDD.n794 VDD.n793 0.309692
R3163 VDD.n965 VDD.n964 0.309557
R3164 VDD.n788 VDD.n787 0.309557
R3165 VDD.n855 VDD.n854 0.309483
R3166 VDD.n953 VDD.n952 0.309405
R3167 VDD.n947 VDD.n946 0.309405
R3168 VDD.n897 VDD.n896 0.309405
R3169 VDD.n861 VDD.n860 0.309405
R3170 VDD.n843 VDD.n842 0.309405
R3171 VDD.n818 VDD.n817 0.309405
R3172 VDD.n704 VDD.n703 0.306614
R3173 VDD.n719 VDD 0.423614
R3174 VDD.n221 VDD.n16 0.299294
R3175 VDD.t433 VDD.t374 5.72558
R3176 VDD.n711 VDD.n710 0.298721
R3177 VDD.n1516 VDD.n1433 0.291071
R3178 VDD.n1710 VDD.n1704 0.291071
R3179 VDD.n1941 VDD.n1940 0.291071
R3180 VDD.n1136 VDD.n1135 0.291071
R3181 VDD.n779 VDD.n761 0.291071
R3182 VDD.n560 VDD.n558 0.310446
R3183 VDD.n207 VDD.n205 0.355153
R3184 VDD.n17 VDD.n32 0.0957525
R3185 VDD.n1318 VDD.n1317 0.284268
R3186 VDD.n1402 VDD.n51 0.643681
R3187 VDD.n1558 VDD.n1557 0.284268
R3188 VDD.n1642 VDD.n49 0.643681
R3189 VDD.n1786 VDD.n1785 0.284268
R3190 VDD.n1870 VDD.n47 0.643681
R3191 VDD.n1199 VDD.n1198 0.284268
R3192 VDD.n1284 VDD.n45 0.643681
R3193 VDD.n977 VDD.n976 0.284268
R3194 VDD.n1061 VDD.n43 0.643681
R3195 VDD.n1319 VDD.n1318 0.282549
R3196 VDD.n1403 VDD.n1402 0.282549
R3197 VDD.n1373 VDD.n1372 0.282549
R3198 VDD.n1559 VDD.n1558 0.282549
R3199 VDD.n1643 VDD.n1642 0.282549
R3200 VDD.n1613 VDD.n1612 0.282549
R3201 VDD.n1787 VDD.n1786 0.282549
R3202 VDD.n1871 VDD.n1870 0.282549
R3203 VDD.n1841 VDD.n1840 0.282549
R3204 VDD.n1200 VDD.n1199 0.282549
R3205 VDD.n1285 VDD.n1284 0.282549
R3206 VDD.n1255 VDD.n1254 0.282549
R3207 VDD.n978 VDD.n977 0.282549
R3208 VDD.n1062 VDD.n1061 0.282549
R3209 VDD.n1032 VDD.n1031 0.282549
R3210 VDD.n227 VDD.n587 0.399778
R3211 VDD.n1466 VDD.n27 0.275718
R3212 VDD.n1758 VDD.n23 0.275718
R3213 VDD.n16 VDD.n14 0.379689
R3214 VDD.n28 VDD.n27 0.272321
R3215 VDD.n24 VDD.n23 0.272321
R3216 VDD.n1671 VDD.n1553 0.269193
R3217 VDD.n1899 VDD.n1781 0.269193
R3218 VDD.n2009 VDD.n1313 0.269193
R3219 VDD.n1091 VDD.n1090 0.269193
R3220 VDD.n1340 VDD.n1317 0.268799
R3221 VDD.n1580 VDD.n1557 0.268799
R3222 VDD.n1808 VDD.n1785 0.268799
R3223 VDD.n1221 VDD.n1198 0.268799
R3224 VDD.n999 VDD.n976 0.268799
R3225 VDD.n238 VDD.n237 0.145041
R3226 VDD.n236 VDD.n235 0.145041
R3227 VDD.n234 VDD.n233 0.145041
R3228 VDD.n232 VDD.n231 0.145041
R3229 VDD.n230 VDD.n229 0.145041
R3230 VDD.n826 VDD.n825 0.263915
R3231 VDD.n906 VDD.n905 0.263815
R3232 VDD.n712 VDD.n711 0.260496
R3233 VDD.n2006 VDD.n728 0.25999
R3234 VDD.n2051 VDD.n2050 0.253639
R3235 VDD.n2023 VDD.n2022 0.253639
R3236 VDD.t460 VDD.n53 5.6952
R3237 VDD.n57 VDD.n41 0.25333
R3238 VDD.n2052 VDD.n2051 0.253298
R3239 VDD.n2024 VDD.n2023 0.253298
R3240 VDD.n35 VDD.n34 0.192952
R3241 VDD.n773 VDD.n761 0.243218
R3242 VDD.n1518 VDD.n1433 0.243218
R3243 VDD.n1709 VDD.n1704 0.243218
R3244 VDD.n1940 VDD.n1939 0.243218
R3245 VDD.n1135 VDD.n1134 0.243218
R3246 VDD.n1320 VDD.n1319 0.241768
R3247 VDD.n1404 VDD.n1403 0.241768
R3248 VDD.n1372 VDD.n1371 0.241768
R3249 VDD.n1560 VDD.n1559 0.241768
R3250 VDD.n1644 VDD.n1643 0.241768
R3251 VDD.n1612 VDD.n1611 0.241768
R3252 VDD.n1788 VDD.n1787 0.241768
R3253 VDD.n1872 VDD.n1871 0.241768
R3254 VDD.n1840 VDD.n1839 0.241768
R3255 VDD.n1201 VDD.n1200 0.241768
R3256 VDD.n1286 VDD.n1285 0.241768
R3257 VDD.n1254 VDD.n1253 0.241768
R3258 VDD.n979 VDD.n978 0.241768
R3259 VDD.n1063 VDD.n1062 0.241768
R3260 VDD.n1031 VDD.n1030 0.241768
R3261 VDD.n709 VDD.n54 4.71183
R3262 VDD.t373 VDD.n1434 1.7101
R3263 VDD.n1137 VDD.t374 1.59181
R3264 VDD.n1942 VDD.t346 1.58834
R3265 VDD.t348 VDD.n1703 1.55361
R3266 VDD.n126 VDD.n125 0.887581
R3267 VDD.n86 VDD.n85 0.88746
R3268 VDD.n62 VDD.n59 0.706063
R3269 VDD.n155 VDD.n153 0.682342
R3270 VDD.n1930 VDD.n192 0.664347
R3271 VDD.n1531 VDD.n111 0.664347
R3272 VDD.n179 VDD.n178 0.664346
R3273 VDD.n1918 VDD.n189 0.664336
R3274 VDD.n1776 VDD.n157 0.664336
R3275 VDD.n160 VDD.n1714 0.664331
R3276 VDD.n1728 VDD.n131 0.66432
R3277 VDD.n163 VDD.n162 0.637585
R3278 VDD.n106 VDD.n1507 0.571964
R3279 VDD.n228 VDD.n227 0.575887
R3280 VDD.n1127 VDD.n220 0.531023
R3281 VDD.n163 VDD.n155 0.560875
R3282 VDD.n223 VDD.n222 0.540806
R3283 VDD.n76 VDD.n75 0.540806
R3284 VDD.n1901 VDD.n32 0.540806
R3285 VDD.n588 VDD.n580 0.5198
R3286 VDD.n601 VDD.n569 0.519701
R3287 VDD.n442 VDD.n441 0.519701
R3288 VDD.n567 VDD.n114 0.519694
R3289 VDD.n560 VDD.n123 0.51969
R3290 VDD.n180 VDD.n179 0.2741
R3291 VDD.n458 VDD.n210 0.519649
R3292 VDD.n600 VDD.n573 0.519606
R3293 VDD.n477 VDD.n476 0.519606
R3294 VDD.n190 VDD.n189 0.274063
R3295 VDD.n607 VDD.n473 0.519606
R3296 VDD.n96 VDD.n97 0.274027
R3297 VDD.n460 VDD.n459 0.519555
R3298 VDD.n554 VDD.n143 0.519536
R3299 VDD.n571 VDD.n102 0.519504
R3300 VDD.n128 VDD.n126 0.519504
R3301 VDD.n541 VDD.n540 0.519504
R3302 VDD.n194 VDD.n192 0.519504
R3303 VDD.n86 VDD.n84 0.519501
R3304 VDD.n93 VDD.n91 0.519501
R3305 VDD.n575 VDD.n99 0.519501
R3306 VDD.n133 VDD.n131 0.519501
R3307 VDD.n539 VDD.n172 0.519501
R3308 VDD.n186 VDD.n184 0.519501
R3309 VDD.n203 VDD.n1 0.519501
R3310 VDD.n440 VDD.n219 0.519501
R3311 VDD.n149 VDD.n548 0.519497
R3312 VDD.n161 VDD.n160 0.273963
R3313 VDD.n487 VDD.n605 0.519403
R3314 VDD.n484 VDD.n606 0.519403
R3315 VDD.n531 VDD.n490 0.5194
R3316 VDD.n158 VDD.n157 0.273955
R3317 VDD.n126 VDD.n556 0.519394
R3318 VDD.n468 VDD.n608 0.51931
R3319 VDD.n543 VDD.n165 0.519302
R3320 VDD.n81 VDD.n82 0.27386
R3321 VDD.n598 VDD.n578 0.519208
R3322 VDD.n112 VDD.n111 0.27386
R3323 VDD.n602 VDD.n565 0.519208
R3324 VDD.n603 VDD.n535 0.519208
R3325 VDD.n489 VDD.n604 0.519208
R3326 VDD.n471 VDD.n470 0.519208
R3327 VDD.n466 VDD.n465 0.519208
R3328 VDD.n454 VDD.n609 0.519208
R3329 VDD.n610 VDD.n450 0.519208
R3330 VDD.n1339 VDD.n238 0.493774
R3331 VDD.n1579 VDD.n236 0.493774
R3332 VDD.n1807 VDD.n234 0.493774
R3333 VDD.n1220 VDD.n232 0.493774
R3334 VDD.n998 VDD.n230 0.493774
R3335 VDD.n270 VDD.n269 0.484477
R3336 VDD.n268 VDD.n267 0.484477
R3337 VDD.n266 VDD.n265 0.484477
R3338 VDD.n264 VDD.n263 0.484477
R3339 VDD.n262 VDD.n261 0.484477
R3340 VDD.n1535 VDD.n240 0.477174
R3341 VDD.n1115 VDD.n214 0.432392
R3342 VDD.n259 VDD.n258 0.456429
R3343 VDD.n255 VDD.n254 0.456429
R3344 VDD.n251 VDD.n250 0.456429
R3345 VDD.n247 VDD.n246 0.456429
R3346 VDD.n243 VDD.n242 0.456429
R3347 VDD.n274 VDD.n1331 0.409829
R3348 VDD.n277 VDD.n1571 0.409829
R3349 VDD.n280 VDD.n1799 0.409829
R3350 VDD.n283 VDD.n1212 0.409829
R3351 VDD.n286 VDD.n990 0.409829
R3352 VDD.n597 VDD.n596 0.451985
R3353 VDD.n1149 VDD.n594 0.450828
R3354 VDD.n1954 VDD.n591 0.450828
R3355 VDD.n586 VDD.n585 0.450828
R3356 VDD.n583 VDD.n582 0.450828
R3357 VDD.n226 VDD.n224 0.448023
R3358 VDD.n223 VDD.n36 0.166871
R3359 VDD.n567 VDD.n76 0.264984
R3360 VDD.n651 VDD.n1538 0.310312
R3361 VDD.n1536 VDD.n637 0.354557
R3362 VDD.n1530 VDD.n649 0.35501
R3363 VDD.n551 VDD.n549 0.310312
R3364 VDD.n545 VDD.n544 0.35501
R3365 VDD.n480 VDD.n479 0.35501
R3366 VDD.n1103 VDD.n608 0.4099
R3367 VDD.n244 VDD.n243 0.0555064
R3368 VDD.n248 VDD.n247 0.0555064
R3369 VDD.n252 VDD.n251 0.0555064
R3370 VDD.n256 VDD.n255 0.0555064
R3371 VDD.n260 VDD.n259 0.0555064
R3372 VDD.n1344 VDD.n1342 0.221058
R3373 VDD.n1423 VDD.n1422 0.221058
R3374 VDD.n1348 VDD.n1347 0.221058
R3375 VDD.n1408 VDD.n1407 0.221058
R3376 VDD.n1397 VDD.n1396 0.221058
R3377 VDD.n1356 VDD.n1355 0.221058
R3378 VDD.n1382 VDD.n1381 0.221058
R3379 VDD.n1364 VDD.n1363 0.221058
R3380 VDD.n1584 VDD.n1582 0.221058
R3381 VDD.n1663 VDD.n1662 0.221058
R3382 VDD.n1588 VDD.n1587 0.221058
R3383 VDD.n1648 VDD.n1647 0.221058
R3384 VDD.n1637 VDD.n1636 0.221058
R3385 VDD.n1597 VDD.n1596 0.221058
R3386 VDD.n1622 VDD.n1621 0.221058
R3387 VDD.n1605 VDD.n1604 0.221058
R3388 VDD.n1812 VDD.n1810 0.221058
R3389 VDD.n1891 VDD.n1890 0.221058
R3390 VDD.n1816 VDD.n1815 0.221058
R3391 VDD.n1876 VDD.n1875 0.221058
R3392 VDD.n1865 VDD.n1864 0.221058
R3393 VDD.n1825 VDD.n1824 0.221058
R3394 VDD.n1850 VDD.n1849 0.221058
R3395 VDD.n1833 VDD.n1832 0.221058
R3396 VDD.n1225 VDD.n1223 0.221058
R3397 VDD.n1305 VDD.n1304 0.221058
R3398 VDD.n1229 VDD.n1228 0.221058
R3399 VDD.n1290 VDD.n1289 0.221058
R3400 VDD.n1279 VDD.n1278 0.221058
R3401 VDD.n1238 VDD.n1237 0.221058
R3402 VDD.n1264 VDD.n1263 0.221058
R3403 VDD.n1246 VDD.n1245 0.221058
R3404 VDD.n1003 VDD.n1001 0.221058
R3405 VDD.n1082 VDD.n1081 0.221058
R3406 VDD.n1007 VDD.n1006 0.221058
R3407 VDD.n1067 VDD.n1066 0.221058
R3408 VDD.n1056 VDD.n1055 0.221058
R3409 VDD.n1016 VDD.n1015 0.221058
R3410 VDD.n1041 VDD.n1040 0.221058
R3411 VDD.n1024 VDD.n1023 0.221058
R3412 VDD.n61 VDD.n39 0.136955
R3413 VDD.n905 VDD.n904 0.214653
R3414 VDD.n706 VDD.n61 0.349965
R3415 VDD.n825 VDD.n824 0.212047
R3416 VDD.n59 VDD.n55 0.21736
R3417 VDD.n1326 VDD.n1325 0.200293
R3418 VDD.n1566 VDD.n1565 0.200293
R3419 VDD.n1794 VDD.n1793 0.200293
R3420 VDD.n1207 VDD.n1206 0.200293
R3421 VDD.n985 VDD.n984 0.200293
R3422 VDD.n2016 VDD.n727 0.192052
R3423 VDD.n2026 VDD.n2015 0.191924
R3424 VDD.n598 VDD.n1475 0.410004
R3425 VDD.n240 VDD.n105 0.199253
R3426 VDD.n1766 VDD.n629 0.310071
R3427 VDD.n631 VDD.n32 0.271968
R3428 VDD.n539 VDD.n537 0.310071
R3429 VDD.n535 VDD.n533 0.310071
R3430 VDD.n484 VDD.n482 0.310071
R3431 VDD.n456 VDD.n455 0.354933
R3432 VDD.n452 VDD.n451 0.354933
R3433 VDD.n1486 VDD.n226 0.26361
R3434 VDD.n2046 VDD.n2043 0.184552
R3435 VDD.n2048 VDD.n722 0.184424
R3436 VDD.n1327 VDD.n1326 0.181058
R3437 VDD.n1567 VDD.n1566 0.181058
R3438 VDD.n1795 VDD.n1794 0.181058
R3439 VDD.n1208 VDD.n1207 0.181058
R3440 VDD.n986 VDD.n985 0.181058
R3441 VDD.n2018 VDD.n2014 0.179888
R3442 VDD.n587 VDD.n717 0.171736
R3443 VDD.n777 VDD.n776 0.169888
R3444 VDD.n2013 VDD.n2012 0.16955
R3445 VDD.n970 VDD.n967 0.162388
R3446 VDD.n964 VDD.n961 0.162388
R3447 VDD.n946 VDD.n943 0.162388
R3448 VDD.n940 VDD.n937 0.162388
R3449 VDD.n928 VDD.n925 0.162388
R3450 VDD.n916 VDD.n913 0.162388
R3451 VDD.n896 VDD.n893 0.162388
R3452 VDD.n878 VDD.n875 0.162388
R3453 VDD.n872 VDD.n869 0.162388
R3454 VDD.n854 VDD.n851 0.162388
R3455 VDD.n822 VDD.n820 0.162388
R3456 VDD.n805 VDD.n802 0.162388
R3457 VDD.n799 VDD.n796 0.162388
R3458 VDD.n781 VDD.n778 0.162388
R3459 VDD.n1549 VDD.n1548 0.16205
R3460 VDD.n1541 VDD.n1540 0.16205
R3461 VDD.n1538 VDD.n1537 0.16205
R3462 VDD.n1534 VDD.n1533 0.16205
R3463 VDD.n1529 VDD.n1528 0.16205
R3464 VDD.n1764 VDD.n1763 0.16205
R3465 VDD.n1767 VDD.n1766 0.16205
R3466 VDD.n1770 VDD.n1769 0.16205
R3467 VDD.n1778 VDD.n1777 0.16205
R3468 VDD.n1104 VDD.n1103 0.16205
R3469 VDD.n1109 VDD.n1108 0.16205
R3470 VDD.n1113 VDD.n1112 0.16205
R3471 VDD.n1117 VDD.n1116 0.16205
R3472 VDD.n1122 VDD.n1121 0.16205
R3473 VDD.n1125 VDD.n1124 0.16205
R3474 VDD.n958 VDD.n955 0.16205
R3475 VDD.n952 VDD.n949 0.16205
R3476 VDD.n934 VDD.n931 0.16205
R3477 VDD.n922 VDD.n919 0.16205
R3478 VDD.n910 VDD.n907 0.16205
R3479 VDD.n902 VDD.n899 0.16205
R3480 VDD.n890 VDD.n887 0.16205
R3481 VDD.n884 VDD.n881 0.16205
R3482 VDD.n866 VDD.n863 0.16205
R3483 VDD.n860 VDD.n857 0.16205
R3484 VDD.n848 VDD.n845 0.16205
R3485 VDD.n842 VDD.n839 0.16205
R3486 VDD.n836 VDD.n833 0.16205
R3487 VDD.n830 VDD.n827 0.16205
R3488 VDD.n817 VDD.n814 0.16205
R3489 VDD.n811 VDD.n808 0.16205
R3490 VDD.n793 VDD.n790 0.16205
R3491 VDD.n787 VDD.n784 0.16205
R3492 VDD.n2044 VDD.n722 0.161924
R3493 VDD.n2054 VDD.n2043 0.161793
R3494 VDD.n1553 VDD.n1431 0.161247
R3495 VDD.n1781 VDD.n1672 0.161247
R3496 VDD.n2005 VDD.n1900 0.161247
R3497 VDD.n1194 VDD.n1091 0.161247
R3498 VDD.n1325 VDD.n1314 0.161058
R3499 VDD.n1565 VDD.n1554 0.161058
R3500 VDD.n1793 VDD.n1782 0.161058
R3501 VDD.n1206 VDD.n1195 0.161058
R3502 VDD.n984 VDD.n973 0.161058
R3503 VDD.n1332 VDD.n1331 0.159888
R3504 VDD.n1572 VDD.n1571 0.159888
R3505 VDD.n1800 VDD.n1799 0.159888
R3506 VDD.n1213 VDD.n1212 0.159888
R3507 VDD.n991 VDD.n990 0.159888
R3508 VDD.n1328 VDD.n1327 0.159043
R3509 VDD.n1568 VDD.n1567 0.159043
R3510 VDD.n1796 VDD.n1795 0.159043
R3511 VDD.n1209 VDD.n1208 0.159043
R3512 VDD.n987 VDD.n986 0.159043
R3513 VDD.n1341 VDD.n1340 0.157388
R3514 VDD.n1425 VDD.n1424 0.157388
R3515 VDD.n1350 VDD.n1349 0.157388
R3516 VDD.n1410 VDD.n1409 0.157388
R3517 VDD.n1399 VDD.n1398 0.157388
R3518 VDD.n1358 VDD.n1357 0.157388
R3519 VDD.n1384 VDD.n1383 0.157388
R3520 VDD.n1367 VDD.n1365 0.157388
R3521 VDD.n1581 VDD.n1580 0.157388
R3522 VDD.n1665 VDD.n1664 0.157388
R3523 VDD.n1591 VDD.n1589 0.157388
R3524 VDD.n1650 VDD.n1649 0.157388
R3525 VDD.n1639 VDD.n1638 0.157388
R3526 VDD.n1599 VDD.n1598 0.157388
R3527 VDD.n1624 VDD.n1623 0.157388
R3528 VDD.n1607 VDD.n1606 0.157388
R3529 VDD.n1809 VDD.n1808 0.157388
R3530 VDD.n1893 VDD.n1892 0.157388
R3531 VDD.n1819 VDD.n1817 0.157388
R3532 VDD.n1878 VDD.n1877 0.157388
R3533 VDD.n1867 VDD.n1866 0.157388
R3534 VDD.n1827 VDD.n1826 0.157388
R3535 VDD.n1852 VDD.n1851 0.157388
R3536 VDD.n1835 VDD.n1834 0.157388
R3537 VDD.n1222 VDD.n1221 0.157388
R3538 VDD.n1307 VDD.n1306 0.157388
R3539 VDD.n1232 VDD.n1230 0.157388
R3540 VDD.n1292 VDD.n1291 0.157388
R3541 VDD.n1281 VDD.n1280 0.157388
R3542 VDD.n1240 VDD.n1239 0.157388
R3543 VDD.n1266 VDD.n1265 0.157388
R3544 VDD.n1249 VDD.n1247 0.157388
R3545 VDD.n1000 VDD.n999 0.157388
R3546 VDD.n1084 VDD.n1083 0.157388
R3547 VDD.n1010 VDD.n1008 0.157388
R3548 VDD.n1069 VDD.n1068 0.157388
R3549 VDD.n1058 VDD.n1057 0.157388
R3550 VDD.n1018 VDD.n1017 0.157388
R3551 VDD.n1043 VDD.n1042 0.157388
R3552 VDD.n1026 VDD.n1025 0.157388
R3553 VDD.n2018 VDD.n2015 0.154424
R3554 VDD.n2020 VDD.n727 0.154293
R3555 VDD.n1344 VDD.n1343 0.154043
R3556 VDD.n1422 VDD.n1421 0.154043
R3557 VDD.n1352 VDD.n1347 0.154043
R3558 VDD.n1407 VDD.n1406 0.154043
R3559 VDD.n1396 VDD.n1395 0.154043
R3560 VDD.n1360 VDD.n1355 0.154043
R3561 VDD.n1381 VDD.n1380 0.154043
R3562 VDD.n1369 VDD.n1363 0.154043
R3563 VDD.n1584 VDD.n1583 0.154043
R3564 VDD.n1662 VDD.n1661 0.154043
R3565 VDD.n1593 VDD.n1587 0.154043
R3566 VDD.n1647 VDD.n1646 0.154043
R3567 VDD.n1636 VDD.n1635 0.154043
R3568 VDD.n1601 VDD.n1596 0.154043
R3569 VDD.n1621 VDD.n1620 0.154043
R3570 VDD.n1609 VDD.n1604 0.154043
R3571 VDD.n1812 VDD.n1811 0.154043
R3572 VDD.n1890 VDD.n1889 0.154043
R3573 VDD.n1821 VDD.n1815 0.154043
R3574 VDD.n1875 VDD.n1874 0.154043
R3575 VDD.n1864 VDD.n1863 0.154043
R3576 VDD.n1829 VDD.n1824 0.154043
R3577 VDD.n1849 VDD.n1848 0.154043
R3578 VDD.n1837 VDD.n1832 0.154043
R3579 VDD.n1225 VDD.n1224 0.154043
R3580 VDD.n1304 VDD.n1303 0.154043
R3581 VDD.n1234 VDD.n1228 0.154043
R3582 VDD.n1289 VDD.n1288 0.154043
R3583 VDD.n1278 VDD.n1277 0.154043
R3584 VDD.n1242 VDD.n1237 0.154043
R3585 VDD.n1263 VDD.n1262 0.154043
R3586 VDD.n1251 VDD.n1245 0.154043
R3587 VDD.n1003 VDD.n1002 0.154043
R3588 VDD.n1081 VDD.n1080 0.154043
R3589 VDD.n1012 VDD.n1006 0.154043
R3590 VDD.n1066 VDD.n1065 0.154043
R3591 VDD.n1055 VDD.n1054 0.154043
R3592 VDD.n1020 VDD.n1015 0.154043
R3593 VDD.n1040 VDD.n1039 0.154043
R3594 VDD.n1028 VDD.n1023 0.154043
R3595 VDD.n719 VDD.n718 0.152808
R3596 VDD.n716 VDD.n715 0.152808
R3597 VDD.n716 VDD.n714 0.152808
R3598 VDD.n328 VDD.n327 0.0453327
R3599 VDD.n331 VDD.n330 0.0453327
R3600 VDD.n333 VDD.n332 0.0453327
R3601 VDD.n336 VDD.n335 0.0453327
R3602 VDD.n338 VDD.n337 0.0453327
R3603 VDD.n341 VDD.n340 0.0453327
R3604 VDD.n343 VDD.n342 0.0453327
R3605 VDD.n346 VDD.n345 0.0453327
R3606 VDD.n348 VDD.n347 0.0453327
R3607 VDD.n351 VDD.n350 0.0453327
R3608 VDD.n353 VDD.n352 0.0453327
R3609 VDD.n356 VDD.n355 0.0453327
R3610 VDD.n358 VDD.n357 0.0453327
R3611 VDD.n361 VDD.n360 0.0453327
R3612 VDD.n363 VDD.n362 0.0453327
R3613 VDD.n366 VDD.n365 0.0453327
R3614 VDD.n368 VDD.n367 0.0453327
R3615 VDD.n371 VDD.n370 0.0453327
R3616 VDD.n373 VDD.n372 0.0453327
R3617 VDD.n376 VDD.n375 0.0453327
R3618 VDD.n378 VDD.n377 0.0453327
R3619 VDD.n381 VDD.n380 0.0453327
R3620 VDD.n383 VDD.n382 0.0453327
R3621 VDD.n386 VDD.n385 0.0453327
R3622 VDD.n388 VDD.n387 0.0453327
R3623 VDD.n391 VDD.n390 0.0453327
R3624 VDD.n393 VDD.n392 0.0453327
R3625 VDD.n396 VDD.n395 0.0453327
R3626 VDD.n398 VDD.n397 0.0453327
R3627 VDD.n401 VDD.n400 0.0453327
R3628 VDD.n1338 VDD.n1321 0.15205
R3629 VDD.n1400 VDD.n270 0.15205
R3630 VDD.n1578 VDD.n1561 0.15205
R3631 VDD.n1640 VDD.n268 0.15205
R3632 VDD.n1806 VDD.n1789 0.15205
R3633 VDD.n1868 VDD.n266 0.15205
R3634 VDD.n1219 VDD.n1202 0.15205
R3635 VDD.n1282 VDD.n264 0.15205
R3636 VDD.n997 VDD.n980 0.15205
R3637 VDD.n1059 VDD.n262 0.15205
R3638 VDD.n1315 VDD.n413 0.305255
R3639 VDD.n1419 VDD.n417 0.305255
R3640 VDD.n244 VDD.n1354 0.314697
R3641 VDD.n1393 VDD.n420 0.305255
R3642 VDD.n424 VDD.n1362 0.305255
R3643 VDD.n1378 VDD.n425 0.305255
R3644 VDD.n1555 VDD.n416 0.305255
R3645 VDD.n1659 VDD.n428 0.305255
R3646 VDD.n248 VDD.n1595 0.314697
R3647 VDD.n1633 VDD.n431 0.305255
R3648 VDD.n435 VDD.n1603 0.305255
R3649 VDD.n1618 VDD.n436 0.305255
R3650 VDD.n1783 VDD.n410 0.305255
R3651 VDD.n1887 VDD.n495 0.305255
R3652 VDD.n252 VDD.n1823 0.314697
R3653 VDD.n1861 VDD.n498 0.305255
R3654 VDD.n502 VDD.n1831 0.305255
R3655 VDD.n1846 VDD.n503 0.305255
R3656 VDD.n1196 VDD.n404 0.305255
R3657 VDD.n1301 VDD.n507 0.305255
R3658 VDD.n256 VDD.n1236 0.314697
R3659 VDD.n1275 VDD.n510 0.305255
R3660 VDD.n514 VDD.n1244 0.305255
R3661 VDD.n1260 VDD.n515 0.305255
R3662 VDD.n974 VDD.n407 0.305255
R3663 VDD.n1078 VDD.n518 0.305255
R3664 VDD.n260 VDD.n1014 0.314697
R3665 VDD.n1052 VDD.n521 0.305255
R3666 VDD.n525 VDD.n1022 0.305255
R3667 VDD.n1037 VDD.n526 0.305255
R3668 VDD.n717 VDD.n716 0.147075
R3669 VDD.n1324 VDD.n1323 0.14705
R3670 VDD.n1564 VDD.n1563 0.14705
R3671 VDD.n1792 VDD.n1791 0.14705
R3672 VDD.n1205 VDD.n1204 0.14705
R3673 VDD.n983 VDD.n982 0.14705
R3674 VDD.n223 VDD.n78 0.272137
R3675 VDD.n1475 VDD.n647 0.16205
R3676 VDD.n639 VDD.n1492 0.310155
R3677 VDD.n1492 VDD.n599 0.162388
R3678 VDD.n589 VDD.n1495 0.440122
R3679 VDD.n563 VDD.n494 0.440065
R3680 VDD.n506 VDD.n492 0.440065
R3681 VDD.n448 VDD.n611 0.439947
R3682 VDD.n415 VDD.n414 0.439068
R3683 VDD.n412 VDD.n411 0.439068
R3684 VDD.n409 VDD.n408 0.439068
R3685 VDD.n406 VDD.n405 0.439068
R3686 VDD.n403 VDD.n402 0.439068
R3687 VDD.n528 VDD.n527 0.438917
R3688 VDD.n323 VDD.n524 0.438917
R3689 VDD.n523 VDD.n522 0.438917
R3690 VDD.n520 VDD.n519 0.438917
R3691 VDD.n517 VDD.n516 0.438917
R3692 VDD.n315 VDD.n513 0.438917
R3693 VDD.n512 VDD.n511 0.438917
R3694 VDD.n509 VDD.n508 0.438917
R3695 VDD.n505 VDD.n504 0.438917
R3696 VDD.n307 VDD.n501 0.438917
R3697 VDD.n500 VDD.n499 0.438917
R3698 VDD.n497 VDD.n496 0.438917
R3699 VDD.n438 VDD.n437 0.438917
R3700 VDD.n299 VDD.n434 0.438917
R3701 VDD.n433 VDD.n432 0.438917
R3702 VDD.n430 VDD.n429 0.438917
R3703 VDD.n427 VDD.n426 0.438917
R3704 VDD.n291 VDD.n423 0.438917
R3705 VDD.n422 VDD.n421 0.438917
R3706 VDD.n419 VDD.n418 0.438917
R3707 VDD.n1737 VDD.n493 0.409149
R3708 VDD.n1495 VDD.n630 0.16205
R3709 VDD.n1532 VDD.n108 0.354903
R3710 VDD.n1515 VDD.n638 0.16205
R3711 VDD.n1756 VDD.n643 0.354771
R3712 VDD.n1755 VDD.n628 0.16205
R3713 VDD.n619 VDD.n1748 0.16205
R3714 VDD.n554 VDD.n552 0.310155
R3715 VDD.n640 VDD.n548 0.310289
R3716 VDD.n659 VDD.n1717 0.16205
R3717 VDD.n625 VDD.n1924 0.16205
R3718 VDD.n543 VDD.n541 0.409632
R3719 VDD.n169 VDD.n167 0.355147
R3720 VDD.n537 VDD.n536 0.354771
R3721 VDD.n636 VDD.n1923 0.16205
R3722 VDD.n492 VDD.n490 0.409777
R3723 VDD.n489 VDD.n180 0.595032
R3724 VDD.n626 VDD.n1922 0.16205
R3725 VDD.n487 VDD.n485 0.310155
R3726 VDD.n1920 VDD.n633 0.309771
R3727 VDD.n646 VDD.n1919 0.16205
R3728 VDD.n650 VDD.n1915 0.16955
R3729 VDD.n634 VDD.n1102 0.16205
R3730 VDD.n617 VDD.n615 0.169888
R3731 VDD.n1334 VDD.n1333 0.142118
R3732 VDD.n1574 VDD.n1573 0.142118
R3733 VDD.n1802 VDD.n1801 0.142118
R3734 VDD.n1215 VDD.n1214 0.142118
R3735 VDD.n993 VDD.n992 0.142118
R3736 VDD.n1339 VDD.n1338 0.134888
R3737 VDD.n1579 VDD.n1578 0.134888
R3738 VDD.n1807 VDD.n1806 0.134888
R3739 VDD.n1220 VDD.n1219 0.134888
R3740 VDD.n998 VDD.n997 0.134888
R3741 VDD.n1337 VDD.n1336 0.134618
R3742 VDD.n1577 VDD.n1576 0.134618
R3743 VDD.n1805 VDD.n1804 0.134618
R3744 VDD.n1218 VDD.n1217 0.134618
R3745 VDD.n996 VDD.n995 0.134618
R3746 VDD.n1522 VDD.n1521 0.133259
R3747 VDD.n1707 VDD.n1706 0.133259
R3748 VDD.n1937 VDD.n1912 0.133259
R3749 VDD.n1132 VDD.n1100 0.133259
R3750 VDD.n765 VDD.n764 0.133259
R3751 VDD.n1330 VDD.n1329 0.129618
R3752 VDD.n1429 VDD.n662 0.0651609
R3753 VDD.n664 VDD.n663 0.1666
R3754 VDD.n1414 VDD.n665 0.0651609
R3755 VDD.n667 VDD.n666 0.1666
R3756 VDD.n1388 VDD.n668 0.0651609
R3757 VDD.n339 VDD.n669 0.0651609
R3758 VDD.n1570 VDD.n1569 0.129618
R3759 VDD.n1669 VDD.n671 0.0651609
R3760 VDD.n344 VDD.n672 0.0651609
R3761 VDD.n673 VDD.n1652 0.1666
R3762 VDD.n675 VDD.n674 0.1666
R3763 VDD.n676 VDD.n1626 0.1666
R3764 VDD.n678 VDD.n677 0.1666
R3765 VDD.n1798 VDD.n1797 0.129618
R3766 VDD.n679 VDD.n1895 0.1666
R3767 VDD.n359 VDD.n680 0.0651609
R3768 VDD.n681 VDD.n1880 0.1666
R3769 VDD.n683 VDD.n682 0.1666
R3770 VDD.n684 VDD.n1854 0.1666
R3771 VDD.n686 VDD.n685 0.1666
R3772 VDD.n1211 VDD.n1210 0.129618
R3773 VDD.n687 VDD.n1309 0.1666
R3774 VDD.n374 VDD.n688 0.0651609
R3775 VDD.n689 VDD.n1294 0.1666
R3776 VDD.n691 VDD.n690 0.1666
R3777 VDD.n1270 VDD.n692 0.0651609
R3778 VDD.n384 VDD.n693 0.0651609
R3779 VDD.n989 VDD.n988 0.129618
R3780 VDD.n1088 VDD.n694 0.0651609
R3781 VDD.n389 VDD.n695 0.0651609
R3782 VDD.n1073 VDD.n696 0.0651609
R3783 VDD.n698 VDD.n697 0.1666
R3784 VDD.n699 VDD.n1045 0.1666
R3785 VDD.n701 VDD.n700 0.1666
R3786 VDD.n1346 VDD.n1345 0.12922
R3787 VDD.n1429 VDD.n1428 0.12922
R3788 VDD.n1418 VDD.n1417 0.12922
R3789 VDD.n329 VDD.n1416 0.12922
R3790 VDD.n243 VDD.n241 0.12922
R3791 VDD.n289 VDD.n1415 0.12922
R3792 VDD.n1414 VDD.n1413 0.12922
R3793 VDD.n1392 VDD.n1391 0.12922
R3794 VDD.n334 VDD.n1390 0.12922
R3795 VDD.n292 VDD.n1389 0.12922
R3796 VDD.n1388 VDD.n1387 0.12922
R3797 VDD.n1377 VDD.n1376 0.12922
R3798 VDD.n339 VDD.n1375 0.12922
R3799 VDD.n1586 VDD.n1585 0.12922
R3800 VDD.n1669 VDD.n1668 0.12922
R3801 VDD.n1658 VDD.n1657 0.12922
R3802 VDD.n344 VDD.n1656 0.12922
R3803 VDD.n247 VDD.n245 0.12922
R3804 VDD.n297 VDD.n1655 0.12922
R3805 VDD.n1654 VDD.n1653 0.12922
R3806 VDD.n1632 VDD.n1631 0.12922
R3807 VDD.n349 VDD.n1630 0.12922
R3808 VDD.n300 VDD.n1629 0.12922
R3809 VDD.n1628 VDD.n1627 0.12922
R3810 VDD.n1617 VDD.n1616 0.12922
R3811 VDD.n354 VDD.n1615 0.12922
R3812 VDD.n1814 VDD.n1813 0.12922
R3813 VDD.n1897 VDD.n1896 0.12922
R3814 VDD.n1886 VDD.n1885 0.12922
R3815 VDD.n359 VDD.n1884 0.12922
R3816 VDD.n251 VDD.n249 0.12922
R3817 VDD.n305 VDD.n1883 0.12922
R3818 VDD.n1882 VDD.n1881 0.12922
R3819 VDD.n1860 VDD.n1859 0.12922
R3820 VDD.n364 VDD.n1858 0.12922
R3821 VDD.n308 VDD.n1857 0.12922
R3822 VDD.n1856 VDD.n1855 0.12922
R3823 VDD.n1845 VDD.n1844 0.12922
R3824 VDD.n369 VDD.n1843 0.12922
R3825 VDD.n1227 VDD.n1226 0.12922
R3826 VDD.n1311 VDD.n1310 0.12922
R3827 VDD.n1300 VDD.n1299 0.12922
R3828 VDD.n374 VDD.n1298 0.12922
R3829 VDD.n255 VDD.n253 0.12922
R3830 VDD.n313 VDD.n1297 0.12922
R3831 VDD.n1296 VDD.n1295 0.12922
R3832 VDD.n1274 VDD.n1273 0.12922
R3833 VDD.n379 VDD.n1272 0.12922
R3834 VDD.n316 VDD.n1271 0.12922
R3835 VDD.n1270 VDD.n1269 0.12922
R3836 VDD.n1259 VDD.n1258 0.12922
R3837 VDD.n384 VDD.n1257 0.12922
R3838 VDD.n1005 VDD.n1004 0.12922
R3839 VDD.n1088 VDD.n1087 0.12922
R3840 VDD.n1077 VDD.n1076 0.12922
R3841 VDD.n389 VDD.n1075 0.12922
R3842 VDD.n259 VDD.n257 0.12922
R3843 VDD.n321 VDD.n1074 0.12922
R3844 VDD.n1073 VDD.n1072 0.12922
R3845 VDD.n1051 VDD.n1050 0.12922
R3846 VDD.n394 VDD.n1049 0.12922
R3847 VDD.n324 VDD.n1048 0.12922
R3848 VDD.n1047 VDD.n1046 0.12922
R3849 VDD.n1036 VDD.n1035 0.12922
R3850 VDD.n399 VDD.n1034 0.12922
R3851 VDD.n703 VDD.n702 0.127628
R3852 VDD.n1330 VDD.n1328 0.127118
R3853 VDD.n1570 VDD.n1568 0.127118
R3854 VDD.n1798 VDD.n1796 0.127118
R3855 VDD.n1211 VDD.n1209 0.127118
R3856 VDD.n989 VDD.n987 0.127118
R3857 VDD.n637 VDD.n573 0.310312
R3858 VDD.n622 VDD.n569 0.310446
R3859 VDD.n635 VDD.n565 0.310312
R3860 VDD.n652 VDD.n556 0.310312
R3861 VDD.n1777 VDD.n161 0.595247
R3862 VDD.n531 VDD.n529 0.310312
R3863 VDD.n1934 VDD.n1933 0.124618
R3864 VDD.n775 VDD.n772 0.124618
R3865 VDD.n614 VDD.n1526 0.263403
R3866 VDD.n1935 VDD.n1934 0.122118
R3867 VDD.n1128 VDD.n618 0.263403
R3868 VDD.n772 VDD.n771 0.122118
R3869 VDD.n1120 VDD.n1119 0.120868
R3870 VDD.n824 VDD.n823 0.120868
R3871 VDD.n2012 VDD.n2011 0.119888
R3872 VDD.n273 VDD.n272 0.187842
R3873 VDD.n276 VDD.n275 0.187842
R3874 VDD.n279 VDD.n278 0.187842
R3875 VDD.n282 VDD.n281 0.187842
R3876 VDD.n285 VDD.n284 0.187842
R3877 VDD.n272 VDD.n1322 0.119618
R3878 VDD.n275 VDD.n1562 0.119618
R3879 VDD.n278 VDD.n1790 0.119618
R3880 VDD.n281 VDD.n1203 0.119618
R3881 VDD.n284 VDD.n981 0.119618
R3882 VDD.n1119 VDD.n611 0.307959
R3883 VDD.n904 VDD.n903 0.118368
R3884 VDD.n1548 VDD.n1547 0.117388
R3885 VDD.n1540 VDD.n1539 0.117388
R3886 VDD.n1537 VDD.n1536 0.117388
R3887 VDD.n1533 VDD.n1532 0.117388
R3888 VDD.n1528 VDD.n1527 0.117388
R3889 VDD.n1765 VDD.n1764 0.117388
R3890 VDD.n1768 VDD.n1767 0.117388
R3891 VDD.n1771 VDD.n1770 0.117388
R3892 VDD.n1779 VDD.n1778 0.117388
R3893 VDD.n1105 VDD.n1104 0.117388
R3894 VDD.n1110 VDD.n1109 0.117388
R3895 VDD.n205 VDD.n1113 0.117388
R3896 VDD.n1118 VDD.n1117 0.117388
R3897 VDD.n1123 VDD.n1122 0.117388
R3898 VDD.n1126 VDD.n1125 0.117388
R3899 VDD.n955 VDD.n954 0.117388
R3900 VDD.n949 VDD.n948 0.117388
R3901 VDD.n931 VDD.n930 0.117388
R3902 VDD.n919 VDD.n918 0.117388
R3903 VDD.n907 VDD.n906 0.117388
R3904 VDD.n899 VDD.n898 0.117388
R3905 VDD.n887 VDD.n886 0.117388
R3906 VDD.n881 VDD.n880 0.117388
R3907 VDD.n863 VDD.n862 0.117388
R3908 VDD.n857 VDD.n856 0.117388
R3909 VDD.n845 VDD.n844 0.117388
R3910 VDD.n839 VDD.n838 0.117388
R3911 VDD.n833 VDD.n832 0.117388
R3912 VDD.n827 VDD.n826 0.117388
R3913 VDD.n814 VDD.n813 0.117388
R3914 VDD.n808 VDD.n807 0.117388
R3915 VDD.n790 VDD.n789 0.117388
R3916 VDD.n784 VDD.n783 0.117388
R3917 VDD.n2014 VDD.n2013 0.11705
R3918 VDD.n967 VDD.n966 0.11705
R3919 VDD.n961 VDD.n960 0.11705
R3920 VDD.n943 VDD.n942 0.11705
R3921 VDD.n937 VDD.n936 0.11705
R3922 VDD.n925 VDD.n924 0.11705
R3923 VDD.n913 VDD.n912 0.11705
R3924 VDD.n893 VDD.n892 0.11705
R3925 VDD.n875 VDD.n874 0.11705
R3926 VDD.n869 VDD.n868 0.11705
R3927 VDD.n851 VDD.n850 0.11705
R3928 VDD.n820 VDD.n819 0.11705
R3929 VDD.n802 VDD.n801 0.11705
R3930 VDD.n796 VDD.n795 0.11705
R3931 VDD.n778 VDD.n777 0.11705
R3932 VDD.n1335 VDD.n1334 0.114618
R3933 VDD.n1575 VDD.n1574 0.114618
R3934 VDD.n1803 VDD.n1802 0.114618
R3935 VDD.n1216 VDD.n1215 0.114618
R3936 VDD.n994 VDD.n993 0.114618
R3937 VDD.n776 VDD.n775 0.11455
R3938 VDD.n1342 VDD.n1341 0.1133
R3939 VDD.n1424 VDD.n1423 0.1133
R3940 VDD.n1349 VDD.n1348 0.1133
R3941 VDD.n1409 VDD.n1408 0.1133
R3942 VDD.n1398 VDD.n1397 0.1133
R3943 VDD.n1357 VDD.n1356 0.1133
R3944 VDD.n1383 VDD.n1382 0.1133
R3945 VDD.n1365 VDD.n1364 0.1133
R3946 VDD.n1582 VDD.n1581 0.1133
R3947 VDD.n1664 VDD.n1663 0.1133
R3948 VDD.n1589 VDD.n1588 0.1133
R3949 VDD.n1649 VDD.n1648 0.1133
R3950 VDD.n1638 VDD.n1637 0.1133
R3951 VDD.n1598 VDD.n1597 0.1133
R3952 VDD.n1623 VDD.n1622 0.1133
R3953 VDD.n1606 VDD.n1605 0.1133
R3954 VDD.n1810 VDD.n1809 0.1133
R3955 VDD.n1892 VDD.n1891 0.1133
R3956 VDD.n1817 VDD.n1816 0.1133
R3957 VDD.n1877 VDD.n1876 0.1133
R3958 VDD.n1866 VDD.n1865 0.1133
R3959 VDD.n1826 VDD.n1825 0.1133
R3960 VDD.n1851 VDD.n1850 0.1133
R3961 VDD.n1834 VDD.n1833 0.1133
R3962 VDD.n1223 VDD.n1222 0.1133
R3963 VDD.n1306 VDD.n1305 0.1133
R3964 VDD.n1230 VDD.n1229 0.1133
R3965 VDD.n1291 VDD.n1290 0.1133
R3966 VDD.n1280 VDD.n1279 0.1133
R3967 VDD.n1239 VDD.n1238 0.1133
R3968 VDD.n1265 VDD.n1264 0.1133
R3969 VDD.n1247 VDD.n1246 0.1133
R3970 VDD.n1001 VDD.n1000 0.1133
R3971 VDD.n1083 VDD.n1082 0.1133
R3972 VDD.n1008 VDD.n1007 0.1133
R3973 VDD.n1068 VDD.n1067 0.1133
R3974 VDD.n1057 VDD.n1056 0.1133
R3975 VDD.n1017 VDD.n1016 0.1133
R3976 VDD.n1042 VDD.n1041 0.1133
R3977 VDD.n1025 VDD.n1024 0.1133
R3978 VDD.n1329 VDD.n1324 0.109888
R3979 VDD.n1569 VDD.n1564 0.109888
R3980 VDD.n1797 VDD.n1792 0.109888
R3981 VDD.n1210 VDD.n1205 0.109888
R3982 VDD.n988 VDD.n983 0.109888
R3983 VDD.n1336 VDD.n1321 0.104888
R3984 VDD.n1576 VDD.n1561 0.104888
R3985 VDD.n1804 VDD.n1789 0.104888
R3986 VDD.n1217 VDD.n1202 0.104888
R3987 VDD.n995 VDD.n980 0.104888
R3988 VDD.n1401 VDD.n1400 0.101138
R3989 VDD.n1641 VDD.n1640 0.101138
R3990 VDD.n1869 VDD.n1868 0.101138
R3991 VDD.n1283 VDD.n1282 0.101138
R3992 VDD.n1060 VDD.n1059 0.101138
R3993 VDD.n28 VDD.t491 15.0158
R3994 VDD.n24 VDD.t480 15.0158
R3995 VDD.n30 VDD.n13 0.336945
R3996 VDD.n39 VDD.t459 15.0172
R3997 VDD.t464 VDD.n40 15.0125
R3998 VDD.n1333 VDD.n1332 0.0970502
R3999 VDD.n1573 VDD.n1572 0.0970502
R4000 VDD.n1801 VDD.n1800 0.0970502
R4001 VDD.n1214 VDD.n1213 0.0970502
R4002 VDD.n992 VDD.n991 0.0970502
R4003 VDD.t469 VDD.n16 15.039
R4004 VDD.n41 VDD.n40 0.0720084
R4005 VDD.n1323 VDD.n1322 0.0921176
R4006 VDD.n1563 VDD.n1562 0.0921176
R4007 VDD.n1791 VDD.n1790 0.0921176
R4008 VDD.n1204 VDD.n1203 0.0921176
R4009 VDD.n982 VDD.n981 0.0921176
R4010 VDD.n1316 VDD.n1315 0.0905
R4011 VDD.n1420 VDD.n1419 0.0905
R4012 VDD.n1354 VDD.n1353 0.0905
R4013 VDD.n1405 VDD.n1404 0.0905
R4014 VDD.n1394 VDD.n1393 0.0905
R4015 VDD.n1362 VDD.n1361 0.0905
R4016 VDD.n1379 VDD.n1378 0.0905
R4017 VDD.n1371 VDD.n1370 0.0905
R4018 VDD.n1556 VDD.n1555 0.0905
R4019 VDD.n1660 VDD.n1659 0.0905
R4020 VDD.n1595 VDD.n1594 0.0905
R4021 VDD.n1645 VDD.n1644 0.0905
R4022 VDD.n1634 VDD.n1633 0.0905
R4023 VDD.n1603 VDD.n1602 0.0905
R4024 VDD.n1619 VDD.n1618 0.0905
R4025 VDD.n1611 VDD.n1610 0.0905
R4026 VDD.n1784 VDD.n1783 0.0905
R4027 VDD.n1888 VDD.n1887 0.0905
R4028 VDD.n1823 VDD.n1822 0.0905
R4029 VDD.n1873 VDD.n1872 0.0905
R4030 VDD.n1862 VDD.n1861 0.0905
R4031 VDD.n1831 VDD.n1830 0.0905
R4032 VDD.n1847 VDD.n1846 0.0905
R4033 VDD.n1839 VDD.n1838 0.0905
R4034 VDD.n1197 VDD.n1196 0.0905
R4035 VDD.n1302 VDD.n1301 0.0905
R4036 VDD.n1236 VDD.n1235 0.0905
R4037 VDD.n1287 VDD.n1286 0.0905
R4038 VDD.n1276 VDD.n1275 0.0905
R4039 VDD.n1244 VDD.n1243 0.0905
R4040 VDD.n1261 VDD.n1260 0.0905
R4041 VDD.n1253 VDD.n1252 0.0905
R4042 VDD.n975 VDD.n974 0.0905
R4043 VDD.n1079 VDD.n1078 0.0905
R4044 VDD.n1014 VDD.n1013 0.0905
R4045 VDD.n1064 VDD.n1063 0.0905
R4046 VDD.n1053 VDD.n1052 0.0905
R4047 VDD.n1022 VDD.n1021 0.0905
R4048 VDD.n1038 VDD.n1037 0.0905
R4049 VDD.n1030 VDD.n1029 0.0905
R4050 VDD.n1427 VDD.n1426 0.0896176
R4051 VDD.n1351 VDD.n663 0.0896176
R4052 VDD.n1412 VDD.n1411 0.0896176
R4053 VDD.n1359 VDD.n666 0.0896176
R4054 VDD.n1386 VDD.n1385 0.0896176
R4055 VDD.n1368 VDD.n1366 0.0896176
R4056 VDD.n1667 VDD.n1666 0.0896176
R4057 VDD.n1592 VDD.n1590 0.0896176
R4058 VDD.n1652 VDD.n1651 0.0896176
R4059 VDD.n1600 VDD.n674 0.0896176
R4060 VDD.n1626 VDD.n1625 0.0896176
R4061 VDD.n1608 VDD.n677 0.0896176
R4062 VDD.n1895 VDD.n1894 0.0896176
R4063 VDD.n1820 VDD.n1818 0.0896176
R4064 VDD.n1880 VDD.n1879 0.0896176
R4065 VDD.n1828 VDD.n682 0.0896176
R4066 VDD.n1854 VDD.n1853 0.0896176
R4067 VDD.n1836 VDD.n685 0.0896176
R4068 VDD.n1309 VDD.n1308 0.0896176
R4069 VDD.n1233 VDD.n1231 0.0896176
R4070 VDD.n1294 VDD.n1293 0.0896176
R4071 VDD.n1241 VDD.n690 0.0896176
R4072 VDD.n1268 VDD.n1267 0.0896176
R4073 VDD.n1250 VDD.n1248 0.0896176
R4074 VDD.n1086 VDD.n1085 0.0896176
R4075 VDD.n1011 VDD.n1009 0.0896176
R4076 VDD.n1071 VDD.n1070 0.0896176
R4077 VDD.n1019 VDD.n697 0.0896176
R4078 VDD.n1045 VDD.n1044 0.0896176
R4079 VDD.n1027 VDD.n700 0.0896176
R4080 VDD.n28 VDD.n26 0.373098
R4081 VDD.n24 VDD.n22 0.511523
R4082 VDD.n1487 VDD.n1452 0.0883676
R4083 VDD.n1735 VDD.n1685 0.0883676
R4084 VDD.n1980 VDD.n1979 0.0883676
R4085 VDD.n1175 VDD.n1174 0.0883676
R4086 VDD.n900 VDD.n742 0.0883676
R4087 VDD.n1518 VDD.n63 0.088
R4088 VDD.n1709 VDD.n65 0.088
R4089 VDD.n1939 VDD.n69 0.088
R4090 VDD.n1134 VDD.n72 0.088
R4091 VDD.n773 VDD.n73 0.088
R4092 VDD.n1453 VDD.n1452 0.0858676
R4093 VDD.n1685 VDD.n1684 0.0858676
R4094 VDD.n1981 VDD.n1980 0.0858676
R4095 VDD.n1176 VDD.n1175 0.0858676
R4096 VDD.n742 VDD.n741 0.0858676
R4097 VDD.n1343 VDD.n1316 0.08425
R4098 VDD.n1421 VDD.n1420 0.08425
R4099 VDD.n1353 VDD.n1352 0.08425
R4100 VDD.n1406 VDD.n1405 0.08425
R4101 VDD.n1395 VDD.n1394 0.08425
R4102 VDD.n1361 VDD.n1360 0.08425
R4103 VDD.n1380 VDD.n1379 0.08425
R4104 VDD.n1370 VDD.n1369 0.08425
R4105 VDD.n1583 VDD.n1556 0.08425
R4106 VDD.n1661 VDD.n1660 0.08425
R4107 VDD.n1594 VDD.n1593 0.08425
R4108 VDD.n1646 VDD.n1645 0.08425
R4109 VDD.n1635 VDD.n1634 0.08425
R4110 VDD.n1602 VDD.n1601 0.08425
R4111 VDD.n1620 VDD.n1619 0.08425
R4112 VDD.n1610 VDD.n1609 0.08425
R4113 VDD.n1811 VDD.n1784 0.08425
R4114 VDD.n1889 VDD.n1888 0.08425
R4115 VDD.n1822 VDD.n1821 0.08425
R4116 VDD.n1874 VDD.n1873 0.08425
R4117 VDD.n1863 VDD.n1862 0.08425
R4118 VDD.n1830 VDD.n1829 0.08425
R4119 VDD.n1848 VDD.n1847 0.08425
R4120 VDD.n1838 VDD.n1837 0.08425
R4121 VDD.n1224 VDD.n1197 0.08425
R4122 VDD.n1303 VDD.n1302 0.08425
R4123 VDD.n1235 VDD.n1234 0.08425
R4124 VDD.n1288 VDD.n1287 0.08425
R4125 VDD.n1277 VDD.n1276 0.08425
R4126 VDD.n1243 VDD.n1242 0.08425
R4127 VDD.n1262 VDD.n1261 0.08425
R4128 VDD.n1252 VDD.n1251 0.08425
R4129 VDD.n1002 VDD.n975 0.08425
R4130 VDD.n1080 VDD.n1079 0.08425
R4131 VDD.n1013 VDD.n1012 0.08425
R4132 VDD.n1065 VDD.n1064 0.08425
R4133 VDD.n1054 VDD.n1053 0.08425
R4134 VDD.n1021 VDD.n1020 0.08425
R4135 VDD.n1039 VDD.n1038 0.08425
R4136 VDD.n1029 VDD.n1028 0.08425
R4137 VDD.n1426 VDD.n1425 0.0821176
R4138 VDD.n1351 VDD.n1350 0.0821176
R4139 VDD.n1411 VDD.n1410 0.0821176
R4140 VDD.n1359 VDD.n1358 0.0821176
R4141 VDD.n1385 VDD.n1384 0.0821176
R4142 VDD.n1368 VDD.n1367 0.0821176
R4143 VDD.n1666 VDD.n1665 0.0821176
R4144 VDD.n1592 VDD.n1591 0.0821176
R4145 VDD.n1651 VDD.n1650 0.0821176
R4146 VDD.n1600 VDD.n1599 0.0821176
R4147 VDD.n1625 VDD.n1624 0.0821176
R4148 VDD.n1608 VDD.n1607 0.0821176
R4149 VDD.n1894 VDD.n1893 0.0821176
R4150 VDD.n1820 VDD.n1819 0.0821176
R4151 VDD.n1879 VDD.n1878 0.0821176
R4152 VDD.n1828 VDD.n1827 0.0821176
R4153 VDD.n1853 VDD.n1852 0.0821176
R4154 VDD.n1836 VDD.n1835 0.0821176
R4155 VDD.n1308 VDD.n1307 0.0821176
R4156 VDD.n1233 VDD.n1232 0.0821176
R4157 VDD.n1293 VDD.n1292 0.0821176
R4158 VDD.n1241 VDD.n1240 0.0821176
R4159 VDD.n1267 VDD.n1266 0.0821176
R4160 VDD.n1250 VDD.n1249 0.0821176
R4161 VDD.n1085 VDD.n1084 0.0821176
R4162 VDD.n1011 VDD.n1010 0.0821176
R4163 VDD.n1070 VDD.n1069 0.0821176
R4164 VDD.n1019 VDD.n1018 0.0821176
R4165 VDD.n1044 VDD.n1043 0.0821176
R4166 VDD.n1027 VDD.n1026 0.0821176
R4167 VDD.n1430 VDD.n1314 0.078
R4168 VDD.n1670 VDD.n1554 0.078
R4169 VDD.n1898 VDD.n1782 0.078
R4170 VDD.n1312 VDD.n1195 0.078
R4171 VDD.n1089 VDD.n973 0.078
R4172 VDD.n1337 VDD.n1335 0.0771176
R4173 VDD.n623 VDD.n1549 0.309903
R4174 VDD.n82 VDD.n580 0.595442
R4175 VDD.n588 VDD.n578 0.410237
R4176 VDD.n87 VDD.n1484 0.633189
R4177 VDD.n657 VDD.n91 0.310071
R4178 VDD.n97 VDD.n575 0.595127
R4179 VDD.n624 VDD.n1541 0.309837
R4180 VDD.n600 VDD.n571 0.409544
R4181 VDD.n601 VDD.n1534 0.409438
R4182 VDD.n649 VDD.n1529 0.309837
R4183 VDD.n1525 VDD.n1524 0.0771176
R4184 VDD.n1521 VDD.n1432 0.0771176
R4185 VDD.n1577 VDD.n1575 0.0771176
R4186 VDD.n643 VDD.n1755 0.310071
R4187 VDD.n656 VDD.n1748 0.309837
R4188 VDD.n1763 VDD.n641 0.310071
R4189 VDD.n1769 VDD.n602 0.410004
R4190 VDD.n563 VDD.n561 0.309837
R4191 VDD.n158 VDD.n1717 0.595267
R4192 VDD.n1706 VDD.n1705 0.0771176
R4193 VDD.n1805 VDD.n1803 0.0771176
R4194 VDD.n631 VDD.n1924 0.264821
R4195 VDD.n540 VDD.n545 0.309837
R4196 VDD.n604 VDD.n1922 0.410004
R4197 VDD.n605 VDD.n1921 0.409773
R4198 VDD.n606 VDD.n1919 0.409773
R4199 VDD.n476 VDD.n480 0.309837
R4200 VDD.n184 VDD.n477 0.409544
R4201 VDD.n190 VDD.n1917 0.595086
R4202 VDD.n1775 VDD.n141 0.530998
R4203 VDD.n167 VDD.n166 0.531168
R4204 VDD.n532 VDD.n173 0.531023
R4205 VDD.n470 VDD.n474 0.310071
R4206 VDD.n473 VDD.n471 0.410004
R4207 VDD.n607 VDD.n1916 0.409544
R4208 VDD.n1936 VDD.n1914 0.0771176
R4209 VDD.n1938 VDD.n1937 0.0771176
R4210 VDD.n1218 VDD.n1216 0.0771176
R4211 VDD.n468 VDD.n466 0.410004
R4212 VDD.n1108 VDD.n621 0.310071
R4213 VDD.n459 VDD.n463 0.310071
R4214 VDD.n462 VDD.n460 0.40959
R4215 VDD.n1112 VDD.n632 0.309837
R4216 VDD.n458 VDD.n456 0.309903
R4217 VDD.n454 VDD.n452 0.309903
R4218 VDD.n1116 VDD.n609 0.410004
R4219 VDD.n1121 VDD.n1120 0.0771176
R4220 VDD.n1124 VDD.n620 0.309837
R4221 VDD.n441 VDD.n445 0.310071
R4222 VDD.n444 VDD.n442 0.409438
R4223 VDD.n440 VDD.n20 0.80204
R4224 VDD.n645 VDD.n1102 0.310071
R4225 VDD.n1130 VDD.n1129 0.0771176
R4226 VDD.n1133 VDD.n1132 0.0771176
R4227 VDD.n996 VDD.n994 0.0771176
R4228 VDD.n764 VDD.n762 0.0771176
R4229 VDD.n903 VDD.n902 0.0771176
R4230 VDD.n823 VDD.n822 0.0771176
R4231 VDD.n768 VDD.n767 0.0771176
R4232 VDD.n1429 VDD.n327 0.181325
R4233 VDD.n330 VDD.n329 0.181325
R4234 VDD.n1414 VDD.n332 0.181325
R4235 VDD.n335 VDD.n334 0.181325
R4236 VDD.n1388 VDD.n337 0.181325
R4237 VDD.n340 VDD.n339 0.181325
R4238 VDD.n1669 VDD.n342 0.181325
R4239 VDD.n345 VDD.n344 0.181325
R4240 VDD.n1654 VDD.n347 0.181325
R4241 VDD.n350 VDD.n349 0.181325
R4242 VDD.n1628 VDD.n352 0.181325
R4243 VDD.n355 VDD.n354 0.181325
R4244 VDD.n1897 VDD.n357 0.181325
R4245 VDD.n360 VDD.n359 0.181325
R4246 VDD.n1882 VDD.n362 0.181325
R4247 VDD.n365 VDD.n364 0.181325
R4248 VDD.n1856 VDD.n367 0.181325
R4249 VDD.n370 VDD.n369 0.181325
R4250 VDD.n1311 VDD.n372 0.181325
R4251 VDD.n375 VDD.n374 0.181325
R4252 VDD.n1296 VDD.n377 0.181325
R4253 VDD.n380 VDD.n379 0.181325
R4254 VDD.n1270 VDD.n382 0.181325
R4255 VDD.n385 VDD.n384 0.181325
R4256 VDD.n1088 VDD.n387 0.181325
R4257 VDD.n390 VDD.n389 0.181325
R4258 VDD.n1073 VDD.n392 0.181325
R4259 VDD.n395 VDD.n394 0.181325
R4260 VDD.n1047 VDD.n397 0.181325
R4261 VDD.n400 VDD.n399 0.181325
R4262 VDD.n623 VDD.n1467 0.354933
R4263 VDD.n644 VDD.n1476 0.354547
R4264 VDD.n622 VDD.n1507 0.354412
R4265 VDD.n1519 VDD.n64 0.122118
R4266 VDD.n558 VDD.n557 0.354412
R4267 VDD.n1708 VDD.n66 0.122118
R4268 VDD.n533 VDD.n532 0.354771
R4269 VDD.n68 VDD.n67 0.122118
R4270 VDD.n71 VDD.n70 0.122118
R4271 VDD.n769 VDD.n74 0.122118
R4272 VDD.n706 VDD.n41 0.107656
R4273 VDD.n147 VDD.n146 0.18196
R4274 VDD.n647 VDD.n1476 0.117388
R4275 VDD.n670 VDD.n1546 0.117388
R4276 VDD.n627 VDD.n1545 0.117388
R4277 VDD.n224 VDD.n271 0.229935
R4278 VDD.n630 VDD.n1543 0.117388
R4279 VDD.n103 VDD.n1535 0.694175
R4280 VDD.n1547 VDD.n81 0.664347
R4281 VDD.n1543 VDD.n96 0.664342
R4282 VDD.n1546 VDD.n84 0.664342
R4283 VDD.n53 VDD.n39 0.64696
R4284 VDD.n54 VDD.n53 0.634673
R4285 VDD.n708 VDD.n40 0.373587
R4286 VDD.n59 VDD.n58 0.542938
R4287 VDD.n94 VDD.n1544 0.531023
R4288 VDD.n100 VDD.n1542 0.531023
R4289 VDD.n109 VDD.n1531 0.432547
R4290 VDD.n638 VDD.n1530 0.117388
R4291 VDD.n1526 VDD.n1525 0.0696176
R4292 VDD.n1519 VDD.n1432 0.0696176
R4293 VDD.n115 VDD.n1756 0.530884
R4294 VDD.n628 VDD.n1752 0.117388
R4295 VDD.n1762 VDD.n619 0.117388
R4296 VDD.n648 VDD.n557 0.117388
R4297 VDD.n124 VDD.n1732 0.530887
R4298 VDD.n129 VDD.n1728 0.531015
R4299 VDD.n1772 VDD.n134 0.531023
R4300 VDD.n1773 VDD.n137 0.432689
R4301 VDD.n1774 VDD.n140 0.432451
R4302 VDD.n1776 VDD.n150 0.531027
R4303 VDD.n659 VDD.n1714 0.117388
R4304 VDD.n1708 VDD.n1705 0.0696176
R4305 VDD.n544 VDD.n625 0.117388
R4306 VDD.n170 VDD.n536 0.432394
R4307 VDD.n1925 VDD.n636 0.117388
R4308 VDD.n176 VDD.n178 0.241335
R4309 VDD.n1926 VDD.n626 0.117388
R4310 VDD.n1927 VDD.n658 0.117388
R4311 VDD.n1929 VDD.n661 0.117388
R4312 VDD.n479 VDD.n646 0.117388
R4313 VDD.n187 VDD.n1918 0.531023
R4314 VDD.n1930 VDD.n654 0.117388
R4315 VDD.n1931 VDD.n195 0.531015
R4316 VDD.n1932 VDD.n198 0.432689
R4317 VDD.n655 VDD.n1915 0.117388
R4318 VDD.n1936 VDD.n1935 0.0696176
R4319 VDD.n67 VDD.n1938 0.0696176
R4320 VDD.n1106 VDD.n8 0.801341
R4321 VDD.n1107 VDD.n201 0.432394
R4322 VDD.n1111 VDD.n204 0.531023
R4323 VDD.n208 VDD.n455 0.432392
R4324 VDD.n1114 VDD.n211 0.530922
R4325 VDD.n506 VDD.n175 0.489077
R4326 VDD.n146 VDD.n145 0.475094
R4327 VDD.n90 VDD.n1486 0.432689
R4328 VDD.n1761 VDD.n118 0.432579
R4329 VDD.n1749 VDD.n121 0.432689
R4330 VDD.n1928 VDD.n183 0.432689
R4331 VDD.n217 VDD.n451 0.432689
R4332 VDD.n79 VDD.n1467 0.390179
R4333 VDD.n615 VDD.n634 0.117388
R4334 VDD.n1129 VDD.n1128 0.0696176
R4335 VDD.n70 VDD.n1133 0.0696176
R4336 VDD.n769 VDD.n762 0.0696176
R4337 VDD.n771 VDD.n768 0.0696176
R4338 VDD.n1933 VDD.n650 0.114888
R4339 VDD.n670 VDD.n1479 0.16205
R4340 VDD.n627 VDD.n1484 0.16205
R4341 VDD.n1737 VDD.n648 0.16205
R4342 VDD.n176 VDD.n175 0.0355581
R4343 VDD.n658 VDD.n1921 0.16205
R4344 VDD.n661 VDD.n1920 0.16205
R4345 VDD.n654 VDD.n1917 0.16205
R4346 VDD.n655 VDD.n1916 0.16205
R4347 VDD.n660 VDD.n1914 0.426171
R4348 VDD.n401 VDD.n1036 0.41707
R4349 VDD.n324 VDD.n398 0.41707
R4350 VDD.n396 VDD.n1051 0.41707
R4351 VDD.n321 VDD.n393 0.41707
R4352 VDD.n391 VDD.n1077 0.41707
R4353 VDD.n1005 VDD.n388 0.41707
R4354 VDD.n386 VDD.n1259 0.41707
R4355 VDD.n316 VDD.n383 0.41707
R4356 VDD.n381 VDD.n1274 0.41707
R4357 VDD.n313 VDD.n378 0.41707
R4358 VDD.n376 VDD.n1300 0.41707
R4359 VDD.n1227 VDD.n373 0.41707
R4360 VDD.n371 VDD.n1845 0.41707
R4361 VDD.n308 VDD.n368 0.41707
R4362 VDD.n366 VDD.n1860 0.41707
R4363 VDD.n305 VDD.n363 0.41707
R4364 VDD.n361 VDD.n1886 0.41707
R4365 VDD.n1814 VDD.n358 0.41707
R4366 VDD.n356 VDD.n1617 0.41707
R4367 VDD.n300 VDD.n353 0.41707
R4368 VDD.n351 VDD.n1632 0.41707
R4369 VDD.n297 VDD.n348 0.41707
R4370 VDD.n346 VDD.n1658 0.41707
R4371 VDD.n1586 VDD.n343 0.41707
R4372 VDD.n341 VDD.n1377 0.41707
R4373 VDD.n292 VDD.n338 0.41707
R4374 VDD.n336 VDD.n1392 0.41707
R4375 VDD.n289 VDD.n333 0.41707
R4376 VDD.n331 VDD.n1418 0.41707
R4377 VDD.n1346 VDD.n328 0.41707
R4378 VDD.n1036 VDD.n326 0.413221
R4379 VDD.n325 VDD.n324 0.413221
R4380 VDD.n1051 VDD.n322 0.413221
R4381 VDD.n258 VDD.n321 0.413221
R4382 VDD.n1077 VDD.n320 0.413221
R4383 VDD.n1005 VDD.n319 0.413221
R4384 VDD.n1259 VDD.n318 0.413221
R4385 VDD.n317 VDD.n316 0.413221
R4386 VDD.n1274 VDD.n314 0.413221
R4387 VDD.n254 VDD.n313 0.413221
R4388 VDD.n1300 VDD.n312 0.413221
R4389 VDD.n1227 VDD.n311 0.413221
R4390 VDD.n1845 VDD.n310 0.413221
R4391 VDD.n309 VDD.n308 0.413221
R4392 VDD.n1860 VDD.n306 0.413221
R4393 VDD.n250 VDD.n305 0.413221
R4394 VDD.n1886 VDD.n304 0.413221
R4395 VDD.n1814 VDD.n303 0.413221
R4396 VDD.n1617 VDD.n302 0.413221
R4397 VDD.n301 VDD.n300 0.413221
R4398 VDD.n1632 VDD.n298 0.413221
R4399 VDD.n246 VDD.n297 0.413221
R4400 VDD.n1658 VDD.n296 0.413221
R4401 VDD.n1586 VDD.n295 0.413221
R4402 VDD.n1377 VDD.n294 0.413221
R4403 VDD.n293 VDD.n292 0.413221
R4404 VDD.n1392 VDD.n290 0.413221
R4405 VDD.n242 VDD.n289 0.413221
R4406 VDD.n1418 VDD.n288 0.413221
R4407 VDD.n1346 VDD.n287 0.413221
R4408 VDD.t355 VDD.t381 0.383639
R4409 VDD VDD.n35 0.359597
R4410 VDD.n2052 VDD.n35 0.351319
R4411 VDD.t424 VDD.n13 15.0463
R4412 VDD.t435 VDD.t374 15.0485
R4413 VDD.n12 VDD.n31 0.749579
R4414 VDD.n29 VDD.t493 5.78513
R4415 VDD.n25 VDD.t482 5.78513
R4416 VDD.n1092 VDD.t374 1.39972
R4417 VDD.n4 VDD.t374 1.3158
R4418 VDD.n1 VDD.n10 1.09362
R4419 VSS.n2944 VSS.n2943 22369.4
R4420 VSS.n1558 VSS.n1555 8296.08
R4421 VSS.n3182 VSS.n3181 8239.28
R4422 VSS.n966 VSS.n147 8239.28
R4423 VSS.n643 VSS.n344 7963.82
R4424 VSS.n3006 VSS.n3005 6494.85
R4425 VSS.n753 VSS.n752 3524.8
R4426 VSS.n3027 VSS.n3026 3461.11
R4427 VSS.n3019 VSS.n1203 3456.87
R4428 VSS.n3020 VSS.n3019 2770.39
R4429 VSS.n3026 VSS.n753 2315.59
R4430 VSS.n3370 VSS.n753 891.294
R4431 VSS.n3026 VSS.n1051 891.294
R4432 VSS.n3019 VSS.n3018 891.294
R4433 VSS.n2185 VSS.t1175 849.322
R4434 VSS.t49 VSS.t46 571.348
R4435 VSS.n2841 VSS.n2328 560.237
R4436 VSS.n3177 VSS.n3176 560.236
R4437 VSS.n1562 VSS.n1561 560.236
R4438 VSS.n3328 VSS.n3327 560.236
R4439 VSS.n2862 VSS.n2861 544.269
R4440 VSS.n3171 VSS.n1097 544.265
R4441 VSS.n1565 VSS.n1250 544.265
R4442 VSS.n3333 VSS.n3332 544.265
R4443 VSS.n3174 VSS.n3173 544.264
R4444 VSS.n1567 VSS.n1564 544.264
R4445 VSS.n3331 VSS.n3330 544.264
R4446 VSS.n2852 VSS.n2851 544.25
R4447 VSS.n2851 VSS.n2323 544.249
R4448 VSS.n2189 VSS.t1807 539.653
R4449 VSS.t1354 VSS.n1082 537.304
R4450 VSS.t2149 VSS.n1234 537.304
R4451 VSS.t2229 VSS.n781 537.304
R4452 VSS.n2192 VSS.t472 522.508
R4453 VSS.t1305 VSS.n1108 520.833
R4454 VSS.t2132 VSS.n1261 520.833
R4455 VSS.t2123 VSS.n3344 520.833
R4456 VSS.n1107 VSS.t1266 502.603
R4457 VSS.n1260 VSS.t2129 502.603
R4458 VSS.n3343 VSS.t2122 502.603
R4459 VSS.n3178 VSS.t349 495.639
R4460 VSS.n1571 VSS.t231 495.639
R4461 VSS.n145 VSS.t394 495.639
R4462 VSS.n1070 VSS.t309 495.637
R4463 VSS.n1075 VSS.t316 495.637
R4464 VSS.n1080 VSS.t323 495.637
R4465 VSS.n1090 VSS.t330 495.637
R4466 VSS.n1095 VSS.t337 495.637
R4467 VSS.n1222 VSS.t192 495.637
R4468 VSS.n1227 VSS.t199 495.637
R4469 VSS.n1232 VSS.t206 495.637
R4470 VSS.n1242 VSS.t213 495.637
R4471 VSS.n1247 VSS.t220 495.637
R4472 VSS.n2842 VSS.t242 495.637
R4473 VSS.n769 VSS.t355 495.637
R4474 VSS.n774 VSS.t362 495.637
R4475 VSS.n779 VSS.t369 495.637
R4476 VSS.n789 VSS.t376 495.637
R4477 VSS.n794 VSS.t383 495.637
R4478 VSS.n2190 VSS.t474 491.87
R4479 VSS.n1125 VSS.t933 486.111
R4480 VSS.n1277 VSS.t2155 486.111
R4481 VSS.n3361 VSS.t924 486.111
R4482 VSS.n1119 VSS.t307 481.767
R4483 VSS.n1115 VSS.t314 481.767
R4484 VSS.n1111 VSS.t321 481.767
R4485 VSS.n1103 VSS.t328 481.767
R4486 VSS.n1099 VSS.t335 481.767
R4487 VSS.n1272 VSS.t190 481.767
R4488 VSS.n1268 VSS.t197 481.767
R4489 VSS.n1264 VSS.t204 481.767
R4490 VSS.n1256 VSS.t211 481.767
R4491 VSS.n1252 VSS.t218 481.767
R4492 VSS.n3355 VSS.t353 481.767
R4493 VSS.n3351 VSS.t360 481.767
R4494 VSS.n3347 VSS.t367 481.767
R4495 VSS.n3339 VSS.t374 481.767
R4496 VSS.n3335 VSS.t381 481.767
R4497 VSS.t345 VSS.n3174 481.764
R4498 VSS.n1564 VSS.t228 481.764
R4499 VSS.n3330 VSS.t391 481.764
R4500 VSS.n1108 VSS.t1353 479.168
R4501 VSS.n1261 VSS.t2148 479.168
R4502 VSS.n3344 VSS.t2228 479.168
R4503 VSS.t1345 VSS.n2187 470.019
R4504 VSS.n713 VSS.n592 469.784
R4505 VSS.n700 VSS.n601 469.784
R4506 VSS.n678 VSS.n609 469.784
R4507 VSS.n665 VSS.n619 469.784
R4508 VSS.n630 VSS.n628 469.784
R4509 VSS.n648 VSS.n647 469.783
R4510 VSS.n2852 VSS.t238 465.279
R4511 VSS.n731 VSS.n730 454.012
R4512 VSS.n718 VSS.n717 454.012
R4513 VSS.n705 VSS.n704 454.012
R4514 VSS.n691 VSS.n690 454.012
R4515 VSS.n670 VSS.n669 454.012
R4516 VSS.n635 VSS.n634 454.01
R4517 VSS.n742 VSS.t1623 453.986
R4518 VSS.n722 VSS.n721 453.986
R4519 VSS.n709 VSS.n708 453.986
R4520 VSS.n695 VSS.n694 453.986
R4521 VSS.n674 VSS.n673 453.986
R4522 VSS.n661 VSS.n660 453.986
R4523 VSS.n655 VSS.n654 453.986
R4524 VSS.n721 VSS.n587 453.986
R4525 VSS.n708 VSS.n596 453.986
R4526 VSS.n694 VSS.n605 453.986
R4527 VSS.n673 VSS.n614 453.986
R4528 VSS.n660 VSS.n623 453.986
R4529 VSS.n654 VSS.n638 453.986
R4530 VSS.t2375 VSS.n684 448.228
R4531 VSS.t510 VSS.n2863 446.527
R4532 VSS.t1860 VSS.n738 442.469
R4533 VSS.n683 VSS.t1577 431.863
R4534 VSS.t853 VSS.n685 419.464
R4535 VSS.t467 VSS.n645 413.68
R4536 VSS.n714 VSS.t406 413.678
R4537 VSS.n701 VSS.t418 413.678
R4538 VSS.n679 VSS.t431 413.678
R4539 VSS.n666 VSS.t442 413.678
R4540 VSS.n631 VSS.t454 413.678
R4541 VSS.n2941 VSS.n2940 412.522
R4542 VSS.n737 VSS.t1624 403.072
R4543 VSS.t1019 VSS.n2190 401.591
R4544 VSS.t244 VSS.n2842 398.416
R4545 VSS.t310 VSS.n1070 398.416
R4546 VSS.t317 VSS.n1075 398.416
R4547 VSS.t324 VSS.n1080 398.416
R4548 VSS.t331 VSS.n1090 398.416
R4549 VSS.t339 VSS.n1095 398.416
R4550 VSS.t193 VSS.n1222 398.416
R4551 VSS.t200 VSS.n1227 398.416
R4552 VSS.t207 VSS.n1232 398.416
R4553 VSS.t214 VSS.n1242 398.416
R4554 VSS.t222 VSS.n1247 398.416
R4555 VSS.t356 VSS.n769 398.416
R4556 VSS.t363 VSS.n774 398.416
R4557 VSS.t370 VSS.n779 398.416
R4558 VSS.t377 VSS.n789 398.416
R4559 VSS.t385 VSS.n794 398.416
R4560 VSS.t350 VSS.n3178 398.414
R4561 VSS.n1571 VSS.t232 398.414
R4562 VSS.n145 VSS.t396 398.414
R4563 VSS.t2374 VSS.n683 397.313
R4564 VSS.t1495 VSS.n743 391.555
R4565 VSS.t125 VSS.n1064 388.889
R4566 VSS.n1106 VSS.t677 388.889
R4567 VSS.t2116 VSS.n1216 388.889
R4568 VSS.n1259 VSS.t2126 388.889
R4569 VSS.t2076 VSS.n763 388.889
R4570 VSS.n3342 VSS.t2113 388.889
R4571 VSS.n2186 VSS.t1175 388.781
R4572 VSS.n722 VSS.t402 385.798
R4573 VSS.n709 VSS.t414 385.798
R4574 VSS.n695 VSS.t426 385.798
R4575 VSS.n674 VSS.t438 385.798
R4576 VSS.n661 VSS.t450 385.798
R4577 VSS.t463 VSS.n638 385.798
R4578 VSS.n750 VSS.t2204 384.889
R4579 VSS.t306 VSS.n1119 384.541
R4580 VSS.t313 VSS.n1115 384.541
R4581 VSS.t320 VSS.n1111 384.541
R4582 VSS.t327 VSS.n1103 384.541
R4583 VSS.t334 VSS.n1099 384.541
R4584 VSS.t189 VSS.n1272 384.541
R4585 VSS.t196 VSS.n1268 384.541
R4586 VSS.t203 VSS.n1264 384.541
R4587 VSS.t210 VSS.n1256 384.541
R4588 VSS.t217 VSS.n1252 384.541
R4589 VSS.t352 VSS.n3355 384.541
R4590 VSS.t359 VSS.n3351 384.541
R4591 VSS.t366 VSS.n3347 384.541
R4592 VSS.t373 VSS.n3339 384.541
R4593 VSS.t380 VSS.n3335 384.541
R4594 VSS.n747 VSS.t2274 380.038
R4595 VSS.n1121 VSS.t304 370.659
R4596 VSS.n1117 VSS.t311 370.659
R4597 VSS.n1113 VSS.t318 370.659
R4598 VSS.n1105 VSS.t325 370.659
R4599 VSS.n1101 VSS.t332 370.659
R4600 VSS.n1274 VSS.t187 370.659
R4601 VSS.n1270 VSS.t194 370.659
R4602 VSS.n1266 VSS.t201 370.659
R4603 VSS.n1258 VSS.t208 370.659
R4604 VSS.n1254 VSS.t215 370.659
R4605 VSS.n3357 VSS.t351 370.659
R4606 VSS.n3353 VSS.t357 370.659
R4607 VSS.n3349 VSS.t364 370.659
R4608 VSS.n3341 VSS.t371 370.659
R4609 VSS.n3337 VSS.t378 370.659
R4610 VSS.n3173 VSS.t343 368.057
R4611 VSS.n1567 VSS.t226 368.057
R4612 VSS.n2323 VSS.t236 368.057
R4613 VSS.n3331 VSS.t389 368.057
R4614 VSS.t162 VSS.t1174 359.769
R4615 VSS.t1229 VSS.n748 357.007
R4616 VSS.t340 VSS.n3171 354.168
R4617 VSS.t223 VSS.n1565 354.168
R4618 VSS.n2861 VSS.t233 354.168
R4619 VSS.n3332 VSS.t386 354.168
R4620 VSS.n3180 VSS.t1426 349.805
R4621 VSS.n1572 VSS.t1742 349.805
R4622 VSS.n144 VSS.t1242 349.805
R4623 VSS.n1066 VSS.t1889 349.803
R4624 VSS.t1485 VSS.n1071 349.803
R4625 VSS.t1856 VSS.n1076 349.803
R4626 VSS.t1891 VSS.n1081 349.803
R4627 VSS.n1086 VSS.t1864 349.803
R4628 VSS.t1488 VSS.n1091 349.803
R4629 VSS.t770 VSS.n1096 349.803
R4630 VSS.n1218 VSS.t2259 349.803
R4631 VSS.t947 VSS.n1223 349.803
R4632 VSS.t2267 VSS.n1228 349.803
R4633 VSS.t1548 VSS.n1233 349.803
R4634 VSS.n1238 VSS.t2083 349.803
R4635 VSS.t950 VSS.n1243 349.803
R4636 VSS.t1570 VSS.n1248 349.803
R4637 VSS.n2844 VSS.t987 349.803
R4638 VSS.n765 VSS.t84 349.803
R4639 VSS.t781 VSS.n770 349.803
R4640 VSS.t1057 VSS.n775 349.803
R4641 VSS.t1059 VSS.n780 349.803
R4642 VSS.n785 VSS.t0 349.803
R4643 VSS.t784 VSS.n790 349.803
R4644 VSS.t786 VSS.n795 349.803
R4645 VSS.n745 VSS.t1227 333.974
R4646 VSS.t408 VSS.n714 333.065
R4647 VSS.t420 VSS.n701 333.065
R4648 VSS.t432 VSS.n679 333.065
R4649 VSS.t444 VSS.n666 333.065
R4650 VSS.t457 VSS.n631 333.065
R4651 VSS.t1622 VSS.n750 333.063
R4652 VSS.n645 VSS.t468 333.063
R4653 VSS.n1122 VSS.t128 328.99
R4654 VSS.n1275 VSS.t1783 328.99
R4655 VSS.n3358 VSS.t1493 328.99
R4656 VSS.n2908 VSS.t46 327.81
R4657 VSS.t1078 VSS.n735 322.457
R4658 VSS.n687 VSS.t1604 322.457
R4659 VSS.t127 VSS.n1064 319.445
R4660 VSS.n1106 VSS.t679 319.445
R4661 VSS.t2117 VSS.n1216 319.445
R4662 VSS.n1259 VSS.t2128 319.445
R4663 VSS.t2077 VSS.n763 319.445
R4664 VSS.n3342 VSS.t2115 319.445
R4665 VSS.t510 VSS.n44 314.327
R4666 VSS.n2193 VSS.t471 313.659
R4667 VSS.n3181 VSS.t1427 308.159
R4668 VSS.t1743 VSS.n1558 308.159
R4669 VSS.t1243 VSS.n147 308.159
R4670 VSS.n1097 VSS.t771 308.154
R4671 VSS.n1250 VSS.t1571 308.154
R4672 VSS.n3333 VSS.t787 308.154
R4673 VSS.n1121 VSS.t1890 308.152
R4674 VSS.n1117 VSS.t1486 308.152
R4675 VSS.n1113 VSS.t1857 308.152
R4676 VSS.n1109 VSS.t1892 308.152
R4677 VSS.n1105 VSS.t1865 308.152
R4678 VSS.n1101 VSS.t1489 308.152
R4679 VSS.n1274 VSS.t2260 308.152
R4680 VSS.n1270 VSS.t948 308.152
R4681 VSS.n1266 VSS.t2268 308.152
R4682 VSS.n1262 VSS.t1549 308.152
R4683 VSS.n1258 VSS.t2084 308.152
R4684 VSS.n1254 VSS.t951 308.152
R4685 VSS.t1637 VSS.n2862 308.152
R4686 VSS.n2845 VSS.t988 308.152
R4687 VSS.n3357 VSS.t85 308.152
R4688 VSS.n3353 VSS.t782 308.152
R4689 VSS.n3349 VSS.t1058 308.152
R4690 VSS.n3345 VSS.t1060 308.152
R4691 VSS.n3341 VSS.t1 308.152
R4692 VSS.n3337 VSS.t785 308.152
R4693 VSS.n587 VSS.t400 305.183
R4694 VSS.n596 VSS.t412 305.183
R4695 VSS.n605 VSS.t424 305.183
R4696 VSS.n614 VSS.t436 305.183
R4697 VSS.n623 VSS.t448 305.183
R4698 VSS.n655 VSS.t461 305.183
R4699 VSS.t1806 VSS.n2192 299.735
R4700 VSS.n740 VSS.t1858 299.425
R4701 VSS.n730 VSS.t397 293.666
R4702 VSS.n718 VSS.t409 293.666
R4703 VSS.n705 VSS.t421 293.666
R4704 VSS.n691 VSS.t433 293.666
R4705 VSS.n670 VSS.t445 293.666
R4706 VSS.t458 VSS.n635 293.666
R4707 VSS.n649 VSS.t1131 292.757
R4708 VSS.t1140 VSS.n732 292.757
R4709 VSS.n716 VSS.t1134 292.757
R4710 VSS.n703 VSS.t2194 292.757
R4711 VSS.n681 VSS.t2196 292.757
R4712 VSS.n689 VSS.t2199 292.757
R4713 VSS.n668 VSS.t1136 292.757
R4714 VSS.n633 VSS.t1138 292.757
R4715 VSS.t2205 VSS.n740 287.909
R4716 VSS.t240 VSS.n2327 287.32
R4717 VSS.t308 VSS.n1068 287.32
R4718 VSS.t315 VSS.n1072 287.32
R4719 VSS.t322 VSS.n1078 287.32
R4720 VSS.t329 VSS.n1087 287.32
R4721 VSS.t336 VSS.n1093 287.32
R4722 VSS.t191 VSS.n1220 287.32
R4723 VSS.t198 VSS.n1224 287.32
R4724 VSS.t205 VSS.n1230 287.32
R4725 VSS.t212 VSS.n1239 287.32
R4726 VSS.t219 VSS.n1245 287.32
R4727 VSS.t354 VSS.n767 287.32
R4728 VSS.t361 VSS.n771 287.32
R4729 VSS.t368 VSS.n777 287.32
R4730 VSS.t375 VSS.n786 287.32
R4731 VSS.t382 VSS.n792 287.32
R4732 VSS.t348 VSS.n3175 287.32
R4733 VSS.n1563 VSS.t230 287.32
R4734 VSS.n3329 VSS.t392 287.32
R4735 VSS.t2285 VSS.n1124 277.779
R4736 VSS.n1647 VSS.t761 277.779
R4737 VSS.t618 VSS.n3360 277.779
R4738 VSS.n734 VSS.t1178 275.507
R4739 VSS.n3176 VSS.t348 273.432
R4740 VSS.t230 VSS.n1562 273.432
R4741 VSS.t392 VSS.n3328 273.432
R4742 VSS.n1069 VSS.t308 273.43
R4743 VSS.n1074 VSS.t315 273.43
R4744 VSS.n1079 VSS.t322 273.43
R4745 VSS.n1089 VSS.t329 273.43
R4746 VSS.n1094 VSS.t336 273.43
R4747 VSS.n1221 VSS.t191 273.43
R4748 VSS.n1226 VSS.t198 273.43
R4749 VSS.n1231 VSS.t205 273.43
R4750 VSS.n1241 VSS.t212 273.43
R4751 VSS.n1246 VSS.t219 273.43
R4752 VSS.n768 VSS.t354 273.43
R4753 VSS.n773 VSS.t361 273.43
R4754 VSS.n778 VSS.t368 273.43
R4755 VSS.n788 VSS.t375 273.43
R4756 VSS.n793 VSS.t382 273.43
R4757 VSS.n2328 VSS.t240 273.43
R4758 VSS.n738 VSS.t1633 269.726
R4759 VSS.n2770 VSS.n2769 265.116
R4760 VSS.n2848 VSS.n2847 265.116
R4761 VSS.n735 VSS.t1080 264.875
R4762 VSS.t1605 VSS.n687 264.875
R4763 VSS.n2798 VSS.n2371 258.741
R4764 VSS.t1132 VSS.n643 258.238
R4765 VSS.n634 VSS.t1139 258.231
R4766 VSS.t1141 VSS.n731 258.231
R4767 VSS.n717 VSS.t1135 258.231
R4768 VSS.n704 VSS.t2195 258.231
R4769 VSS.n682 VSS.t2197 258.231
R4770 VSS.n690 VSS.t2200 258.231
R4771 VSS.n669 VSS.t1137 258.231
R4772 VSS.t1496 VSS.n742 258.207
R4773 VSS.n2789 VSS.n2349 258.14
R4774 VSS.n2781 VSS.n2347 258.14
R4775 VSS.n2753 VSS.n2388 258.14
R4776 VSS.t1632 VSS.n745 253.359
R4777 VSS.t988 VSS.n2844 252.583
R4778 VSS.t1890 VSS.n1066 252.583
R4779 VSS.t1486 VSS.n1071 252.583
R4780 VSS.t1857 VSS.n1076 252.583
R4781 VSS.t1892 VSS.n1081 252.583
R4782 VSS.t1865 VSS.n1086 252.583
R4783 VSS.t1489 VSS.n1091 252.583
R4784 VSS.t771 VSS.n1096 252.583
R4785 VSS.t2260 VSS.n1218 252.583
R4786 VSS.t948 VSS.n1223 252.583
R4787 VSS.t2268 VSS.n1228 252.583
R4788 VSS.t1549 VSS.n1233 252.583
R4789 VSS.t2084 VSS.n1238 252.583
R4790 VSS.t951 VSS.n1243 252.583
R4791 VSS.t1571 VSS.n1248 252.583
R4792 VSS.t85 VSS.n765 252.583
R4793 VSS.t782 VSS.n770 252.583
R4794 VSS.t1058 VSS.n775 252.583
R4795 VSS.t1060 VSS.n780 252.583
R4796 VSS.t1 VSS.n785 252.583
R4797 VSS.t785 VSS.n790 252.583
R4798 VSS.t787 VSS.n795 252.583
R4799 VSS.t1427 VSS.n3180 252.582
R4800 VSS.n1572 VSS.t1743 252.582
R4801 VSS.n144 VSS.t1243 252.582
R4802 VSS.t1782 VSS.n1292 252.375
R4803 VSS.t1499 VSS.n1301 252.375
R4804 VSS.t1365 VSS.n1317 252.375
R4805 VSS.t1184 VSS.n1333 252.375
R4806 VSS.t1503 VSS.n1349 252.375
R4807 VSS.t1455 VSS.n1365 252.375
R4808 VSS.t1863 VSS.n1381 252.375
R4809 VSS.t1456 VSS.n1398 252.375
R4810 VSS.t1187 VSS.n1414 252.375
R4811 VSS.t1749 VSS.n1430 252.375
R4812 VSS.t1188 VSS.n1446 252.375
R4813 VSS.t740 VSS.n1462 252.375
R4814 VSS.t2317 VSS.n1478 252.375
R4815 VSS.t583 VSS.n1494 252.375
R4816 VSS.t2241 VSS.n1511 252.375
R4817 VSS.t73 VSS.n1527 252.375
R4818 VSS.t1296 VSS.n1543 252.375
R4819 VSS.t1451 VSS.n173 252.375
R4820 VSS.t2219 VSS.n167 252.375
R4821 VSS.n236 VSS.t1492 252.375
R4822 VSS.n234 VSS.t23 252.375
R4823 VSS.n231 VSS.t2206 252.375
R4824 VSS.n230 VSS.t693 252.375
R4825 VSS.n227 VSS.t621 252.375
R4826 VSS.n223 VSS.t1035 252.375
R4827 VSS.n222 VSS.t172 252.375
R4828 VSS.n219 VSS.t1821 252.375
R4829 VSS.n216 VSS.t1841 252.375
R4830 VSS.n212 VSS.t2156 252.375
R4831 VSS.t36 VSS.n165 252.375
R4832 VSS.n202 VSS.t2203 252.375
R4833 VSS.n198 VSS.t1158 252.375
R4834 VSS.t1452 VSS.n171 252.375
R4835 VSS.n560 VSS.t1928 252.375
R4836 VSS.t1948 VSS.n270 252.375
R4837 VSS.n521 VSS.t594 252.375
R4838 VSS.t1470 VSS.n285 252.375
R4839 VSS.n482 VSS.t935 252.375
R4840 VSS.t79 VSS.n303 252.375
R4841 VSS.n456 VSS.t1420 252.375
R4842 VSS.n442 VSS.t2187 252.375
R4843 VSS.n429 VSS.t1909 252.375
R4844 VSS.t1985 VSS.n324 252.375
R4845 VSS.n385 VSS.t1484 252.375
R4846 VSS.n371 VSS.t1254 252.375
R4847 VSS.n358 VSS.t2190 252.375
R4848 VSS.n3299 VSS.t2310 252.375
R4849 VSS.n3292 VSS.t1494 252.375
R4850 VSS.n3275 VSS.t1360 252.375
R4851 VSS.n3268 VSS.t1831 252.375
R4852 VSS.t1808 VSS.n3091 252.375
R4853 VSS.t1308 VSS.n3116 252.375
R4854 VSS.t902 VSS.n3143 252.375
R4855 VSS.t622 VSS.n184 252.374
R4856 VSS.n117 VSS.t943 252.374
R4857 VSS.n566 VSS.t1177 252.374
R4858 VSS.n534 VSS.t1966 252.374
R4859 VSS.n496 VSS.t895 252.374
R4860 VSS.n414 VSS.t1328 252.374
R4861 VSS.n3310 VSS.t131 252.374
R4862 VSS.t1084 VSS.n1146 252.374
R4863 VSS.n3284 VSS.t1785 252.374
R4864 VSS.n3259 VSS.t917 252.374
R4865 VSS.n3244 VSS.t1028 252.374
R4866 VSS.n3236 VSS.t2269 252.374
R4867 VSS.n3220 VSS.t1163 252.374
R4868 VSS.n3213 VSS.t610 252.374
R4869 VSS.n3197 VSS.t2166 252.374
R4870 VSS.n3189 VSS.t1257 252.374
R4871 VSS.t1944 VSS.n272 252.117
R4872 VSS.n526 VSS.t76 252.117
R4873 VSS.t1519 VSS.n287 252.117
R4874 VSS.n488 VSS.t1410 252.117
R4875 VSS.t1421 VSS.n305 252.117
R4876 VSS.n447 VSS.t2339 252.117
R4877 VSS.n434 VSS.t1425 252.117
R4878 VSS.n420 VSS.t1981 252.117
R4879 VSS.t1439 VSS.n328 252.117
R4880 VSS.n376 VSS.t1635 252.117
R4881 VSS.n363 VSS.t1253 252.117
R4882 VSS.n233 VSS.t1262 252.117
R4883 VSS.n229 VSS.t1578 252.117
R4884 VSS.n225 VSS.t1569 252.117
R4885 VSS.n221 VSS.t2383 252.117
R4886 VSS.n217 VSS.t647 252.117
R4887 VSS.n214 VSS.t942 252.117
R4888 VSS.n211 VSS.t179 252.117
R4889 VSS.n208 VSS.t2207 252.117
R4890 VSS.t1830 VSS.n168 252.117
R4891 VSS.n200 VSS.t1157 252.117
R4892 VSS.n197 VSS.t2165 252.117
R4893 VSS.n194 VSS.t1498 252.117
R4894 VSS.t1803 VSS.n1310 252.117
R4895 VSS.t571 VSS.n1326 252.117
R4896 VSS.t2176 VSS.n1342 252.117
R4897 VSS.t572 VSS.n1358 252.117
R4898 VSS.t1241 VSS.n1374 252.117
R4899 VSS.t1377 VSS.n1390 252.117
R4900 VSS.t1378 VSS.n1407 252.117
R4901 VSS.t709 VSS.n1423 252.117
R4902 VSS.t2348 VSS.n1439 252.117
R4903 VSS.t1196 VSS.n1455 252.117
R4904 VSS.t2178 VSS.n1471 252.117
R4905 VSS.t2153 VSS.n1487 252.117
R4906 VSS.t946 VSS.n1504 252.117
R4907 VSS.t774 VSS.n1520 252.117
R4908 VSS.t584 VSS.n1536 252.117
R4909 VSS.t1955 VSS.n267 252.115
R4910 VSS.t2243 VSS.n282 252.115
R4911 VSS.t640 VSS.n300 252.115
R4912 VSS.t1986 VSS.n321 252.115
R4913 VSS.n176 VSS.t1088 252.115
R4914 VSS.n178 VSS.t680 252.115
R4915 VSS.t749 VSS.n185 252.115
R4916 VSS.n3303 VSS.t469 252.115
R4917 VSS.t688 VSS.n3046 252.115
R4918 VSS.n3287 VSS.t1567 252.115
R4919 VSS.n3279 VSS.t611 252.115
R4920 VSS.t2346 VSS.n3070 252.115
R4921 VSS.n3263 VSS.t1595 252.115
R4922 VSS.n3254 VSS.t2125 252.115
R4923 VSS.t1591 VSS.n3095 252.115
R4924 VSS.n3239 VSS.t1091 252.115
R4925 VSS.n3231 VSS.t2302 252.115
R4926 VSS.n3223 VSS.t1794 252.115
R4927 VSS.n3216 VSS.t1236 252.115
R4928 VSS.n3208 VSS.t1159 252.115
R4929 VSS.n3200 VSS.t1590 252.115
R4930 VSS.n3193 VSS.t762 252.115
R4931 VSS.n2863 VSS.t1637 252.083
R4932 VSS.t1038 VSS.n563 250.837
R4933 VSS.t1337 VSS.n558 250.837
R4934 VSS.t1107 VSS.n550 250.837
R4935 VSS.t1109 VSS.n545 250.837
R4936 VSS.t981 VSS.n536 250.837
R4937 VSS.t993 VSS.n532 250.837
R4938 VSS.t1475 VSS.n523 250.837
R4939 VSS.t710 VSS.n519 250.837
R4940 VSS.t901 VSS.n511 250.837
R4941 VSS.t712 VSS.n506 250.837
R4942 VSS.t1477 VSS.n498 250.837
R4943 VSS.t123 VSS.n494 250.837
R4944 VSS.t996 VSS.n484 250.837
R4945 VSS.t970 VSS.n480 250.837
R4946 VSS.t121 VSS.n471 250.837
R4947 VSS.t1111 VSS.n467 250.837
R4948 VSS.t1473 VSS.n458 250.837
R4949 VSS.t1474 VSS.n453 250.837
R4950 VSS.t1664 VSS.n444 250.837
R4951 VSS.t979 VSS.n440 250.837
R4952 VSS.t972 VSS.n431 250.837
R4953 VSS.t997 VSS.n426 250.837
R4954 VSS.t1659 VSS.n416 250.837
R4955 VSS.t716 VSS.n411 250.837
R4956 VSS.t714 VSS.n402 250.837
R4957 VSS.t1660 VSS.n395 250.837
R4958 VSS.t1336 VSS.n387 250.837
R4959 VSS.t792 VSS.n382 250.837
R4960 VSS.t1663 VSS.n373 250.837
R4961 VSS.t1472 VSS.n369 250.837
R4962 VSS.t794 VSS.n360 250.837
R4963 VSS.t1194 VSS.n355 250.837
R4964 VSS.n1033 VSS.t927 250.837
R4965 VSS.n1032 VSS.t1867 250.837
R4966 VSS.n1029 VSS.t1218 250.837
R4967 VSS.n1028 VSS.t2382 250.837
R4968 VSS.n1025 VSS.t2381 250.837
R4969 VSS.n1024 VSS.t115 250.837
R4970 VSS.n1021 VSS.t113 250.837
R4971 VSS.n1020 VSS.t1823 250.837
R4972 VSS.n1017 VSS.t2051 250.837
R4973 VSS.n1016 VSS.t2124 250.837
R4974 VSS.n1013 VSS.t1162 250.837
R4975 VSS.n1012 VSS.t2157 250.837
R4976 VSS.n1008 VSS.t2266 250.837
R4977 VSS.n1007 VSS.t2265 250.837
R4978 VSS.n1004 VSS.t1408 250.837
R4979 VSS.n1003 VSS.t1407 250.837
R4980 VSS.n1000 VSS.t985 250.837
R4981 VSS.n999 VSS.t983 250.837
R4982 VSS.n996 VSS.t861 250.837
R4983 VSS.n995 VSS.t859 250.837
R4984 VSS.n992 VSS.t1727 250.837
R4985 VSS.n991 VSS.t93 250.837
R4986 VSS.n988 VSS.t91 250.837
R4987 VSS.n987 VSS.t2070 250.837
R4988 VSS.n984 VSS.t2069 250.837
R4989 VSS.n983 VSS.t111 250.837
R4990 VSS.n980 VSS.t1665 250.837
R4991 VSS.n979 VSS.t2225 250.837
R4992 VSS.n976 VSS.t1612 250.837
R4993 VSS.n975 VSS.t788 250.837
R4994 VSS.n972 VSS.t1853 250.837
R4995 VSS.n971 VSS.t1036 250.837
R4996 VSS.n3309 VSS.t2107 250.837
R4997 VSS.n3306 VSS.t2184 250.837
R4998 VSS.n3301 VSS.t875 250.837
R4999 VSS.n3297 VSS.t915 250.837
R5000 VSS.n3293 VSS.t1333 250.837
R5001 VSS.n3290 VSS.t2137 250.837
R5002 VSS.n3286 VSS.t1597 250.837
R5003 VSS.n3282 VSS.t633 250.837
R5004 VSS.n3277 VSS.t2257 250.837
R5005 VSS.n3273 VSS.t2263 250.837
R5006 VSS.n3269 VSS.t2261 250.837
R5007 VSS.n3266 VSS.t2359 250.837
R5008 VSS.n3261 VSS.t1587 250.837
R5009 VSS.n3257 VSS.t1704 250.837
R5010 VSS.n3252 VSS.t2357 250.837
R5011 VSS.n3249 VSS.t2191 250.837
R5012 VSS.n3245 VSS.t2364 250.837
R5013 VSS.n3242 VSS.t1694 250.837
R5014 VSS.n3238 VSS.t1645 250.837
R5015 VSS.n3234 VSS.t976 250.837
R5016 VSS.n3229 VSS.t2355 250.837
R5017 VSS.n3226 VSS.t2159 250.837
R5018 VSS.n3221 VSS.t896 250.837
R5019 VSS.n3219 VSS.t1740 250.837
R5020 VSS.n3215 VSS.t2379 250.837
R5021 VSS.n3211 VSS.t1095 250.837
R5022 VSS.n3206 VSS.t1129 250.837
R5023 VSS.n3203 VSS.t117 250.837
R5024 VSS.n3198 VSS.t1716 250.837
R5025 VSS.n3196 VSS.t744 250.837
R5026 VSS.n3191 VSS.t1870 250.837
R5027 VSS.n3187 VSS.t1125 250.837
R5028 VSS.n114 VSS.t1707 250.837
R5029 VSS.n1681 VSS.t2358 250.837
R5030 VSS.n1689 VSS.t2192 250.837
R5031 VSS.n1697 VSS.t2365 250.837
R5032 VSS.n1705 VSS.t1695 250.837
R5033 VSS.n1713 VSS.t1649 250.837
R5034 VSS.n1722 VSS.t977 250.837
R5035 VSS.n1729 VSS.t2356 250.837
R5036 VSS.n1738 VSS.t746 250.837
R5037 VSS.n1745 VSS.t1871 250.837
R5038 VSS.n1754 VSS.t1127 250.837
R5039 VSS.n1761 VSS.t928 250.837
R5040 VSS.n1770 VSS.t1868 250.837
R5041 VSS.n1779 VSS.t1219 250.837
R5042 VSS.n1788 VSS.t1547 250.837
R5043 VSS.n1795 VSS.t969 250.837
R5044 VSS.n1804 VSS.t1042 250.837
R5045 VSS.n1811 VSS.t1524 250.837
R5046 VSS.n1820 VSS.t995 250.837
R5047 VSS.n1827 VSS.t1662 250.837
R5048 VSS.n1835 VSS.t1715 250.837
R5049 VSS.n1843 VSS.t1240 250.837
R5050 VSS.n1852 VSS.t790 250.837
R5051 VSS.n1859 VSS.t899 250.837
R5052 VSS.n1868 VSS.t1545 250.837
R5053 VSS.n1876 VSS.t2151 250.837
R5054 VSS.n1885 VSS.t1697 250.837
R5055 VSS.n1893 VSS.t1001 250.837
R5056 VSS.n1902 VSS.t2384 250.837
R5057 VSS.n1909 VSS.t889 250.837
R5058 VSS.n1918 VSS.t796 250.837
R5059 VSS.n1925 VSS.t1700 250.837
R5060 VSS.n1297 VSS.t2158 250.837
R5061 VSS.n1304 VSS.t1717 250.837
R5062 VSS.n1313 VSS.t2160 250.837
R5063 VSS.n1320 VSS.t897 250.837
R5064 VSS.n1329 VSS.t1741 250.837
R5065 VSS.n1336 VSS.t2380 250.837
R5066 VSS.n1345 VSS.t1096 250.837
R5067 VSS.n1352 VSS.t1130 250.837
R5068 VSS.n1361 VSS.t119 250.837
R5069 VSS.n1368 VSS.t1589 250.837
R5070 VSS.n1377 VSS.t2138 250.837
R5071 VSS.n1384 VSS.t1598 250.837
R5072 VSS.t634 VSS.n1392 250.837
R5073 VSS.n1401 VSS.t2258 250.837
R5074 VSS.n1410 VSS.t2264 250.837
R5075 VSS.n1417 VSS.t2262 250.837
R5076 VSS.n1426 VSS.t2360 250.837
R5077 VSS.n1433 VSS.t797 250.837
R5078 VSS.n1442 VSS.t1546 250.837
R5079 VSS.n1449 VSS.t2152 250.837
R5080 VSS.n1458 VSS.t1698 250.837
R5081 VSS.n1465 VSS.t1003 250.837
R5082 VSS.n1474 VSS.t2385 250.837
R5083 VSS.n1481 VSS.t891 250.837
R5084 VSS.n1490 VSS.t1702 250.837
R5085 VSS.t1720 VSS.n1496 250.837
R5086 VSS.n1507 VSS.t835 250.837
R5087 VSS.n1514 VSS.t2110 250.837
R5088 VSS.n1523 VSS.t2185 250.837
R5089 VSS.n1530 VSS.t876 250.837
R5090 VSS.n1539 VSS.t916 250.837
R5091 VSS.n1546 VSS.t1334 250.837
R5092 VSS.n2830 VSS.n2390 248.252
R5093 VSS.n2784 VSS.n2373 244.186
R5094 VSS.n2824 VSS.n2345 244.186
R5095 VSS.t1929 VSS.n1678 244.148
R5096 VSS.t2133 VSS.n2018 244.148
R5097 VSS.t1942 VSS.n1694 244.148
R5098 VSS.t1309 VSS.n2013 244.148
R5099 VSS.t1312 VSS.n1710 244.148
R5100 VSS.t1951 VSS.n2008 244.148
R5101 VSS.t1947 VSS.n1726 244.148
R5102 VSS.t1899 VSS.n2003 244.148
R5103 VSS.t2353 VSS.n1742 244.148
R5104 VSS.t1900 VSS.n1998 244.148
R5105 VSS.t1247 VSS.n1758 244.148
R5106 VSS.t1246 VSS.n1993 244.148
R5107 VSS.t1062 VSS.n1776 244.148
R5108 VSS.t2328 VSS.n1987 244.148
R5109 VSS.t1471 VSS.n1792 244.148
R5110 VSS.t2329 VSS.n1982 244.148
R5111 VSS.t1973 VSS.n1808 244.148
R5112 VSS.t1409 VSS.n1977 244.148
R5113 VSS.t1833 VSS.n1824 244.148
R5114 VSS.t1210 VSS.n1972 244.148
R5115 VSS.t2330 VSS.n1840 244.148
R5116 VSS.t641 VSS.n1967 244.148
R5117 VSS.t934 VSS.n1856 244.148
R5118 VSS.t2249 VSS.n1962 244.148
R5119 VSS.t1835 VSS.n1872 244.148
R5120 VSS.t2332 VSS.n1957 244.148
R5121 VSS.t1527 VSS.n1890 244.148
R5122 VSS.t2183 VSS.n1952 244.148
R5123 VSS.t1525 VSS.n1906 244.148
R5124 VSS.t1581 VSS.n1947 244.148
R5125 VSS.t646 VSS.n1922 244.148
R5126 VSS.t404 VSS.n591 240.957
R5127 VSS.t416 VSS.n600 240.957
R5128 VSS.t429 VSS.n608 240.957
R5129 VSS.t440 VSS.n618 240.957
R5130 VSS.t452 VSS.n627 240.957
R5131 VSS.t465 VSS.n646 240.956
R5132 VSS.t1631 VSS.n751 240.954
R5133 VSS.t2352 VSS.n2766 240.698
R5134 VSS.n554 VSS.t1895 234.114
R5135 VSS.n541 VSS.t1396 234.114
R5136 VSS.n528 VSS.t1204 234.114
R5137 VSS.n515 VSS.t1403 234.114
R5138 VSS.n502 VSS.t1064 234.114
R5139 VSS.n490 VSS.t894 234.114
R5140 VSS.n476 VSS.t1417 234.114
R5141 VSS.n463 VSS.t2251 234.114
R5142 VSS.n449 VSS.t597 234.114
R5143 VSS.n436 VSS.t1528 234.114
R5144 VSS.n422 VSS.t603 234.114
R5145 VSS.n407 VSS.t1531 234.114
R5146 VSS.n392 VSS.t1983 234.114
R5147 VSS.n378 VSS.t1483 234.114
R5148 VSS.n365 VSS.t2188 234.114
R5149 VSS.n351 VSS.t1993 234.114
R5150 VSS.t869 VSS.n857 234.114
R5151 VSS.t19 VSS.n864 234.114
R5152 VSS.t1346 VSS.n871 234.114
R5153 VSS.t58 VSS.n878 234.114
R5154 VSS.t483 VSS.n885 234.114
R5155 VSS.t2223 VSS.n892 234.114
R5156 VSS.t1085 VSS.n899 234.114
R5157 VSS.t652 VSS.n906 234.114
R5158 VSS.t1343 VSS.n913 234.114
R5159 VSS.t1576 VSS.n920 234.114
R5160 VSS.t681 VSS.n927 234.114
R5161 VSS.t2220 VSS.n934 234.114
R5162 VSS.t1349 VSS.n943 234.114
R5163 VSS.t41 VSS.n950 234.114
R5164 VSS.t1814 VSS.n957 234.114
R5165 VSS.t2313 VSS.n964 234.114
R5166 VSS.t43 VSS.n3038 234.114
R5167 VSS.t97 VSS.n3045 234.114
R5168 VSS.t1146 VSS.n3054 234.114
R5169 VSS.t2168 VSS.n3062 234.114
R5170 VSS.t1820 VSS.n3069 234.114
R5171 VSS.t750 VSS.n3078 234.114
R5172 VSS.t64 VSS.n3086 234.114
R5173 VSS.t1033 VSS.n3094 234.114
R5174 VSS.t143 VSS.n3103 234.114
R5175 VSS.t648 VSS.n3111 234.114
R5176 VSS.t691 VSS.n3119 234.114
R5177 VSS.t1491 VSS.n3128 234.114
R5178 VSS.t1281 VSS.n3138 234.114
R5179 VSS.t2292 VSS.n3146 234.114
R5180 VSS.t2275 VSS.n3155 234.114
R5181 VSS.t1180 VSS.n3162 234.114
R5182 VSS.t1923 VSS.n1684 234.114
R5183 VSS.t1391 VSS.n1700 234.114
R5184 VSS.t1945 VSS.n1716 234.114
R5185 VSS.t1517 VSS.n1732 234.114
R5186 VSS.t1962 VSS.n1748 234.114
R5187 VSS.t1903 VSS.n1764 234.114
R5188 VSS.t1209 VSS.n1782 234.114
R5189 VSS.t884 VSS.n1798 234.114
R5190 VSS.t1971 VSS.n1814 234.114
R5191 VSS.t2179 VSS.n1830 234.114
R5192 VSS.t1070 VSS.n1846 234.114
R5193 VSS.t1415 VSS.n1862 234.114
R5194 VSS.t2334 VSS.n1879 234.114
R5195 VSS.t1424 VSS.n1896 234.114
R5196 VSS.t1976 VSS.n1912 234.114
R5197 VSS.t1837 VSS.n1929 234.114
R5198 VSS.t1047 VSS.n1308 234.114
R5199 VSS.t2172 VSS.n1323 234.114
R5200 VSS.t1239 VSS.n1339 234.114
R5201 VSS.t1368 VSS.n1355 234.114
R5202 VSS.t1453 VSS.n1372 234.114
R5203 VSS.t2235 VSS.n1388 234.114
R5204 VSS.t1371 VSS.n1404 234.114
R5205 VSS.t1051 VSS.n1420 234.114
R5206 VSS.t2143 VSS.n1437 234.114
R5207 VSS.t1750 VSS.n1452 234.114
R5208 VSS.t2147 VSS.n1468 234.114
R5209 VSS.t2238 VSS.n1484 234.114
R5210 VSS.t579 VSS.n1501 234.114
R5211 VSS.t1054 VSS.n1518 234.114
R5212 VSS.t2320 VSS.n1533 234.114
R5213 VSS.t2325 VSS.n1549 234.114
R5214 VSS.n2815 VSS.t250 233.721
R5215 VSS.t128 VSS.n1065 231.763
R5216 VSS.t1783 VSS.n1217 231.763
R5217 VSS.t1493 VSS.n764 231.763
R5218 VSS.n748 VSS.t2273 230.327
R5219 VSS.n2785 VSS.n2353 230.233
R5220 VSS.n2359 VSS.n2332 230.233
R5221 VSS.n2812 VSS.n2360 230.233
R5222 VSS.n647 VSS.t465 229.44
R5223 VSS.n592 VSS.t404 229.439
R5224 VSS.n601 VSS.t416 229.439
R5225 VSS.n609 VSS.t429 229.439
R5226 VSS.n619 VSS.t440 229.439
R5227 VSS.n628 VSS.t452 229.439
R5228 VSS.n752 VSS.t1631 228.827
R5229 VSS.t629 VSS.n262 225.361
R5230 VSS.t1894 VSS.n268 225.361
R5231 VSS.n539 VSS.t1395 225.361
R5232 VSS.t1205 VSS.n277 225.361
R5233 VSS.t1401 VSS.n283 225.361
R5234 VSS.t893 VSS.n293 225.361
R5235 VSS.n474 VSS.t1416 225.361
R5236 VSS.n461 VSS.t2250 225.361
R5237 VSS.t1529 VSS.n314 225.361
R5238 VSS.n419 VSS.t601 225.361
R5239 VSS.n405 VSS.t1530 225.361
R5240 VSS.n390 VSS.t1984 225.361
R5241 VSS.t2189 VSS.n337 225.361
R5242 VSS.t1759 VSS.n153 225.361
R5243 VSS.t871 VSS.n154 225.361
R5244 VSS.t21 VSS.n156 225.361
R5245 VSS.t60 VSS.n159 225.361
R5246 VSS.t485 VSS.n161 225.361
R5247 VSS.t1087 VSS.n164 225.361
R5248 VSS.n213 VSS.t654 225.361
R5249 VSS.n207 VSS.t1575 225.361
R5250 VSS.n205 VSS.t682 225.361
R5251 VSS.n203 VSS.t2221 225.361
R5252 VSS.n199 VSS.t1350 225.361
R5253 VSS.n193 VSS.t1815 225.361
R5254 VSS.t2065 VSS.n1294 225.361
R5255 VSS.t1049 VSS.n1311 225.361
R5256 VSS.t2173 VSS.n1327 225.361
R5257 VSS.t1238 VSS.n1343 225.361
R5258 VSS.t1369 VSS.n1359 225.361
R5259 VSS.t1454 VSS.n1375 225.361
R5260 VSS.t1372 VSS.n1408 225.361
R5261 VSS.t1052 VSS.n1424 225.361
R5262 VSS.t2142 VSS.n1440 225.361
R5263 VSS.t1751 VSS.n1456 225.361
R5264 VSS.t2146 VSS.n1472 225.361
R5265 VSS.t2237 VSS.n1488 225.361
R5266 VSS.t581 VSS.n1505 225.361
R5267 VSS.t1056 VSS.n1521 225.361
R5268 VSS.t2321 VSS.n1537 225.361
R5269 VSS.t1065 VSS.n288 225.359
R5270 VSS.t595 VSS.n309 225.359
R5271 VSS.t1482 VSS.n332 225.359
R5272 VSS.t1347 VSS.n177 225.359
R5273 VSS.t2222 VSS.n179 225.359
R5274 VSS.t1344 VSS.n183 225.359
R5275 VSS.t39 VSS.n188 225.359
R5276 VSS.n116 VSS.t2055 225.359
R5277 VSS.t2236 VSS.n1391 225.359
R5278 VSS.t139 VSS.n3030 225.359
R5279 VSS.n3302 VSS.t44 225.359
R5280 VSS.n3294 VSS.t99 225.359
R5281 VSS.t1144 VSS.n3055 225.359
R5282 VSS.n3278 VSS.t2169 225.359
R5283 VSS.n3270 VSS.t1819 225.359
R5284 VSS.t752 VSS.n3079 225.359
R5285 VSS.n3253 VSS.t62 225.359
R5286 VSS.n3246 VSS.t1031 225.359
R5287 VSS.t141 VSS.n3104 225.359
R5288 VSS.n3230 VSS.t650 225.359
R5289 VSS.n3222 VSS.t689 225.359
R5290 VSS.t1490 VSS.n3129 225.359
R5291 VSS.n3207 VSS.t1279 225.359
R5292 VSS.n3199 VSS.t2291 225.359
R5293 VSS.n3192 VSS.t2276 225.359
R5294 VSS.t679 VSS.n1085 224.82
R5295 VSS.t2128 VSS.n1237 224.82
R5296 VSS.t2115 VSS.n784 224.82
R5297 VSS.n1122 VSS.t127 224.82
R5298 VSS.n1275 VSS.t2117 224.82
R5299 VSS.n3358 VSS.t2077 224.82
R5300 VSS.n1125 VSS.t2285 222.222
R5301 VSS.t761 VSS.n1277 222.222
R5302 VSS.n3361 VSS.t618 222.222
R5303 VSS.n2017 VSS.t1925 217.392
R5304 VSS.n2012 VSS.t1393 217.392
R5305 VSS.n2007 VSS.t1946 217.392
R5306 VSS.n2002 VSS.t1516 217.392
R5307 VSS.n1997 VSS.t1963 217.392
R5308 VSS.n1992 VSS.t1904 217.392
R5309 VSS.n1986 VSS.t1207 217.392
R5310 VSS.n1981 VSS.t882 217.392
R5311 VSS.n1976 VSS.t1970 217.392
R5312 VSS.n1971 VSS.t2180 217.392
R5313 VSS.n1966 VSS.t1072 217.392
R5314 VSS.n1961 VSS.t1413 217.392
R5315 VSS.n1956 VSS.t2333 217.392
R5316 VSS.n1951 VSS.t1422 217.392
R5317 VSS.n1946 VSS.t1974 217.392
R5318 VSS.t129 VSS.n2756 216.784
R5319 VSS.n2788 VSS.n2377 216.28
R5320 VSS.n2775 VSS.n2382 216.28
R5321 VSS.n2752 VSS.n2341 216.28
R5322 VSS.n2809 VSS.n2364 216.28
R5323 VSS.n2897 VSS.t1043 215.731
R5324 VSS.t1043 VSS.n44 215.731
R5325 VSS.n732 VSS.t1141 212.143
R5326 VSS.t1135 VSS.n716 212.143
R5327 VSS.t2195 VSS.n703 212.143
R5328 VSS.t2197 VSS.n681 212.143
R5329 VSS.t2200 VSS.n689 212.143
R5330 VSS.t1137 VSS.n668 212.143
R5331 VSS.t1139 VSS.n633 212.143
R5332 VSS.n649 VSS.t1132 212.143
R5333 VSS.t2002 VSS.n306 211.982
R5334 VSS.t1285 VSS.n329 211.982
R5335 VSS.t1736 VSS.n180 211.982
R5336 VSS.t1509 VSS.n181 211.982
R5337 VSS.t1738 VSS.n186 211.982
R5338 VSS.t2000 VSS.n562 211.982
R5339 VSS.t731 VSS.n549 211.982
R5340 VSS.t102 VSS.n273 211.982
R5341 VSS.t1688 VSS.n278 211.982
R5342 VSS.t2007 VSS.n510 211.982
R5343 VSS.t1690 VSS.n289 211.982
R5344 VSS.t2013 VSS.n296 211.982
R5345 VSS.t1283 VSS.n302 211.982
R5346 VSS.t1686 VSS.n310 211.982
R5347 VSS.t2005 VSS.n316 211.982
R5348 VSS.t1692 VSS.n319 211.982
R5349 VSS.t2016 VSS.n323 211.982
R5350 VSS.t973 VSS.n333 211.982
R5351 VSS.t728 VSS.n339 211.982
R5352 VSS.t1506 VSS.n235 211.982
R5353 VSS.t961 VSS.n232 211.982
R5354 VSS.t1916 VSS.n157 211.982
R5355 VSS.t1730 VSS.n228 211.982
R5356 VSS.t1514 VSS.n224 211.982
R5357 VSS.t1732 VSS.n162 211.982
R5358 VSS.t2020 VSS.n220 211.982
R5359 VSS.t1728 VSS.n210 211.982
R5360 VSS.t1511 VSS.n166 211.982
R5361 VSS.t1734 VSS.n169 211.982
R5362 VSS.t2023 VSS.n170 211.982
R5363 VSS.t1918 VSS.n196 211.982
R5364 VSS.t958 VSS.n172 211.982
R5365 VSS.n1298 VSS.t1646 211.982
R5366 VSS.n1314 VSS.t1747 211.982
R5367 VSS.n1330 VSS.t912 211.982
R5368 VSS.n1346 VSS.t660 211.982
R5369 VSS.n1362 VSS.t1705 211.982
R5370 VSS.n1378 VSS.t662 211.982
R5371 VSS.n1395 VSS.t1616 211.982
R5372 VSS.n1411 VSS.t605 211.982
R5373 VSS.n1427 VSS.t2377 211.982
R5374 VSS.n1443 VSS.t658 211.982
R5375 VSS.n1459 VSS.t2108 211.982
R5376 VSS.n1475 VSS.t665 211.982
R5377 VSS.n1491 VSS.t1100 211.982
R5378 VSS.n1508 VSS.t608 211.982
R5379 VSS.n1524 VSS.t2105 211.982
R5380 VSS.n1540 VSS.t1201 211.982
R5381 VSS.t1708 VSS.n3308 211.982
R5382 VSS.t1431 VSS.n3300 211.982
R5383 VSS.t2120 VSS.n3285 211.982
R5384 VSS.t1710 VSS.n3276 211.982
R5385 VSS.t1116 VSS.n3260 211.982
R5386 VSS.t1880 VSS.n3251 211.982
R5387 VSS.t2118 VSS.n3237 211.982
R5388 VSS.t1713 VSS.n3228 211.982
R5389 VSS.t1119 VSS.n3214 211.982
R5390 VSS.t1882 VSS.n3205 211.982
R5391 VSS.t1389 VSS.n3190 211.982
R5392 VSS.t2254 VSS.n3049 211.982
R5393 VSS.t1876 VSS.n3073 211.982
R5394 VSS.t1112 VSS.n3098 211.982
R5395 VSS.t1878 VSS.n3122 211.982
R5396 VSS.t2252 VSS.n3149 211.982
R5397 VSS.t1889 VSS.n1065 210.948
R5398 VSS.t2259 VSS.n1217 210.948
R5399 VSS.t84 VSS.n764 210.948
R5400 VSS.t1864 VSS.n1085 210.939
R5401 VSS.t2083 VSS.n1237 210.939
R5402 VSS.t0 VSS.n784 210.939
R5403 VSS.t987 VSS.n2843 210.935
R5404 VSS.n1118 VSS.t1485 210.935
R5405 VSS.n1114 VSS.t1856 210.935
R5406 VSS.n1110 VSS.t1891 210.935
R5407 VSS.n1102 VSS.t1488 210.935
R5408 VSS.n1271 VSS.t947 210.935
R5409 VSS.n1267 VSS.t2267 210.935
R5410 VSS.n1263 VSS.t1548 210.935
R5411 VSS.n1255 VSS.t950 210.935
R5412 VSS.n3354 VSS.t781 210.935
R5413 VSS.n3350 VSS.t1057 210.935
R5414 VSS.n3346 VSS.t1059 210.935
R5415 VSS.n3338 VSS.t784 210.935
R5416 VSS.n1098 VSS.t770 210.931
R5417 VSS.n1251 VSS.t1570 210.931
R5418 VSS.n3334 VSS.t786 210.931
R5419 VSS.t1426 VSS.n3179 210.93
R5420 VSS.t1742 VSS.n1559 210.93
R5421 VSS.t1242 VSS.n146 210.93
R5422 VSS.n2191 VSS.t1019 208.828
R5423 VSS.t2273 VSS.n747 207.294
R5424 VSS.n2023 VSS.t2028 204.013
R5425 VSS.n2030 VSS.t6 204.013
R5426 VSS.n2037 VSS.t1724 204.013
R5427 VSS.n2044 VSS.t1653 204.013
R5428 VSS.n2051 VSS.t2037 204.013
R5429 VSS.n2058 VSS.t1656 204.013
R5430 VSS.n2066 VSS.t2044 204.013
R5431 VSS.n2073 VSS.t1555 204.013
R5432 VSS.n2080 VSS.t2031 204.013
R5433 VSS.n2087 VSS.t1650 204.013
R5434 VSS.n2094 VSS.t2034 204.013
R5435 VSS.n2101 VSS.t1638 204.013
R5436 VSS.n2108 VSS.t2025 204.013
R5437 VSS.n2115 VSS.t1558 204.013
R5438 VSS.n2122 VSS.t1721 204.013
R5439 VSS.n2129 VSS.t9 204.013
R5440 VSS.n2758 VSS.n2339 202.798
R5441 VSS.n2755 VSS.n2338 202.798
R5442 VSS.t254 VSS.n2782 202.798
R5443 VSS.n2193 VSS.t1806 202.362
R5444 VSS.n2819 VSS.n2379 202.327
R5445 VSS.n2777 VSS.n2380 202.327
R5446 VSS.n2805 VSS.n2368 202.327
R5447 VSS.n2806 VSS.n2370 202.327
R5448 VSS.n746 VSS.t1632 200.649
R5449 VSS.n2945 VSS.n2944 197.518
R5450 VSS.n743 VSS.t1496 195.778
R5451 VSS.t1933 VSS.n265 195.26
R5452 VSS.n547 VSS.t1953 195.26
R5453 VSS.t1902 VSS.n280 195.26
R5454 VSS.n508 VSS.t1399 195.26
R5455 VSS.t1250 VSS.n291 195.26
R5456 VSS.t638 VSS.n298 195.26
R5457 VSS.n469 VSS.t1212 195.26
R5458 VSS.n455 VSS.t2337 195.26
R5459 VSS.t1214 VSS.n312 195.26
R5460 VSS.n428 VSS.t82 195.26
R5461 VSS.n413 VSS.t779 195.26
R5462 VSS.n399 VSS.t1429 195.26
R5463 VSS.n384 VSS.t1437 195.26
R5464 VSS.t1440 VSS.n335 195.26
R5465 VSS.n357 VSS.t1990 195.26
R5466 VSS.t1168 VSS.n155 195.26
R5467 VSS.t2213 VSS.n158 195.26
R5468 VSS.n226 VSS.t1607 195.26
R5469 VSS.t166 VSS.n160 195.26
R5470 VSS.t686 VSS.n163 195.26
R5471 VSS.n218 VSS.t1164 195.26
R5472 VSS.n215 VSS.t1339 195.26
R5473 VSS.n209 VSS.t857 195.26
R5474 VSS.n206 VSS.t1321 195.26
R5475 VSS.n204 VSS.t768 195.26
R5476 VSS.n201 VSS.t1561 195.26
R5477 VSS.n195 VSS.t1620 195.26
R5478 VSS.n192 VSS.t2312 195.26
R5479 VSS.t880 VSS.n1302 195.26
R5480 VSS.t1800 VSS.n1318 195.26
R5481 VSS.t2175 VSS.n1334 195.26
R5482 VSS.t1843 VSS.n1350 195.26
R5483 VSS.t671 VSS.n1366 195.26
R5484 VSS.t675 VSS.n1382 195.26
R5485 VSS.t1375 VSS.n1399 195.26
R5486 VSS.t577 VSS.n1415 195.26
R5487 VSS.t1459 VSS.n1431 195.26
R5488 VSS.t1294 VSS.n1447 195.26
R5489 VSS.t2145 VSS.n1463 195.26
R5490 VSS.t2239 VSS.n1479 195.26
R5491 VSS.t69 VSS.n1512 195.26
R5492 VSS.t2324 VSS.n1528 195.26
R5493 VSS.t2327 VSS.n1544 195.26
R5494 VSS.t1325 VSS.n275 195.26
R5495 VSS.t756 VSS.n175 195.26
R5496 VSS.t2278 VSS.n182 195.26
R5497 VSS.t1363 VSS.n187 195.26
R5498 VSS.t2316 VSS.n1495 195.26
R5499 VSS.n3307 VSS.t765 195.26
R5500 VSS.n3298 VSS.t87 195.26
R5501 VSS.n3291 VSS.t866 195.26
R5502 VSS.n3283 VSS.t1601 195.26
R5503 VSS.n3274 VSS.t612 195.26
R5504 VSS.n3267 VSS.t1263 195.26
R5505 VSS.n3258 VSS.t2351 195.26
R5506 VSS.n3250 VSS.t1020 195.26
R5507 VSS.n3243 VSS.t1586 195.26
R5508 VSS.n3235 VSS.t908 195.26
R5509 VSS.n3227 VSS.t2288 195.26
R5510 VSS.t15 VSS.n3125 195.26
R5511 VSS.n3212 VSS.t168 195.26
R5512 VSS.n3204 VSS.t1024 195.26
R5513 VSS.t173 VSS.n3152 195.26
R5514 VSS.n3188 VSS.t1358 195.26
R5515 VSS.t1178 VSS.n733 194.891
R5516 VSS.n2952 VSS.t1175 194.514
R5517 VSS.n2797 VSS.t255 192.309
R5518 VSS.n132 VSS.t340 190.097
R5519 VSS.n1566 VSS.t223 190.097
R5520 VSS.n139 VSS.t386 190.097
R5521 VSS.t304 VSS.n1120 190.096
R5522 VSS.t311 VSS.n1116 190.096
R5523 VSS.t318 VSS.n1112 190.096
R5524 VSS.t325 VSS.n1104 190.096
R5525 VSS.t332 VSS.n1100 190.096
R5526 VSS.t187 VSS.n1273 190.096
R5527 VSS.t194 VSS.n1269 190.096
R5528 VSS.t201 VSS.n1265 190.096
R5529 VSS.t208 VSS.n1257 190.096
R5530 VSS.t215 VSS.n1253 190.096
R5531 VSS.n2322 VSS.t233 190.096
R5532 VSS.t351 VSS.n3356 190.096
R5533 VSS.t357 VSS.n3352 190.096
R5534 VSS.t364 VSS.n3348 190.096
R5535 VSS.t371 VSS.n3340 190.096
R5536 VSS.t378 VSS.n3336 190.096
R5537 VSS.n688 VSS.t1605 189.132
R5538 VSS.t1080 VSS.n734 189.132
R5539 VSS.n2783 VSS.n2356 188.811
R5540 VSS.n2760 VSS.n2340 188.373
R5541 VSS.t471 VSS.n2178 187.895
R5542 VSS.t1592 VSS.n556 187.292
R5543 VSS.t2293 VSS.n543 187.292
R5544 VSS.t2305 VSS.n530 187.292
R5545 VSS.t1045 VSS.n517 187.292
R5546 VSS.t1596 VSS.n504 187.292
R5547 VSS.t1148 VSS.n492 187.292
R5548 VSS.t2210 VSS.n478 187.292
R5549 VSS.t1332 VSS.n465 187.292
R5550 VSS.t873 VSS.n451 187.292
R5551 VSS.t1873 VSS.n438 187.292
R5552 VSS.t2233 VSS.n424 187.292
R5553 VSS.t2282 VSS.n409 187.292
R5554 VSS.t1224 VSS.n394 187.292
R5555 VSS.t1172 VSS.n380 187.292
R5556 VSS.t850 VSS.n367 187.292
R5557 VSS.t1260 VSS.n353 187.292
R5558 VSS.t1756 VSS.n856 187.292
R5559 VSS.t1793 VSS.n863 187.292
R5560 VSS.t1777 VSS.n870 187.292
R5561 VSS.t1852 VSS.n877 187.292
R5562 VSS.t1757 VSS.n884 187.292
R5563 VSS.t1851 VSS.n891 187.292
R5564 VSS.t1379 VSS.n898 187.292
R5565 VSS.t1772 VSS.n905 187.292
R5566 VSS.t1811 VSS.n912 187.292
R5567 VSS.t1758 VSS.n919 187.292
R5568 VSS.t1802 VSS.n926 187.292
R5569 VSS.t1813 VSS.n933 187.292
R5570 VSS.t1809 VSS.n942 187.292
R5571 VSS.t1779 VSS.n949 187.292
R5572 VSS.t1886 VSS.n956 187.292
R5573 VSS.t1884 VSS.n963 187.292
R5574 VSS.t37 VSS.n3037 187.292
R5575 VSS.t2298 VSS.n3044 187.292
R5576 VSS.t801 VSS.n3053 187.292
R5577 VSS.t1818 VSS.n3061 187.292
R5578 VSS.t132 VSS.n3068 187.292
R5579 VSS.t177 VSS.n3077 187.292
R5580 VSS.t2208 VSS.n3085 187.292
R5581 VSS.t1625 VSS.n3093 187.292
R5582 VSS.t1150 VSS.n3102 187.292
R5583 VSS.t1822 VSS.n3110 187.292
R5584 VSS.t1017 VSS.n3118 187.292
R5585 VSS.t626 VSS.n3127 187.292
R5586 VSS.t470 VSS.n3137 187.292
R5587 VSS.t619 VSS.n3145 187.292
R5588 VSS.t800 VSS.n3154 187.292
R5589 VSS.t2299 VSS.n3161 187.292
R5590 VSS.n2019 VSS.t1931 187.292
R5591 VSS.n1682 VSS.t2063 187.292
R5592 VSS.n2014 VSS.t2131 187.292
R5593 VSS.n1698 VSS.t2061 187.292
R5594 VSS.n2009 VSS.t1940 187.292
R5595 VSS.n1714 VSS.t2056 187.292
R5596 VSS.n2004 VSS.t1317 187.292
R5597 VSS.n1730 VSS.t2072 187.292
R5598 VSS.n1999 VSS.t590 187.292
R5599 VSS.n1746 VSS.t2089 187.292
R5600 VSS.n1994 VSS.t1957 187.292
R5601 VSS.n1762 VSS.t2075 187.292
R5602 VSS.n1988 VSS.t1968 187.292
R5603 VSS.n1780 VSS.t2080 187.292
R5604 VSS.n1983 VSS.t840 187.292
R5605 VSS.n1796 VSS.t2079 187.292
R5606 VSS.n1978 VSS.t844 187.292
R5607 VSS.n1812 VSS.t2078 187.292
R5608 VSS.n1973 VSS.t1405 187.292
R5609 VSS.n1828 VSS.t2074 187.292
R5610 VSS.n1968 VSS.t1066 187.292
R5611 VSS.n1844 VSS.t2090 187.292
R5612 VSS.n1963 VSS.t1522 187.292
R5613 VSS.n1860 VSS.t2345 187.292
R5614 VSS.n1958 VSS.t2336 187.292
R5615 VSS.n1877 VSS.t2100 187.292
R5616 VSS.n1953 VSS.t1300 187.292
R5617 VSS.n1894 VSS.t2092 187.292
R5618 VSS.n1948 VSS.t939 187.292
R5619 VSS.n1910 VSS.t2091 187.292
R5620 VSS.n1943 VSS.t1907 187.292
R5621 VSS.n1927 VSS.t2099 187.292
R5622 VSS.n1305 VSS.t2060 187.292
R5623 VSS.n1321 VSS.t2057 187.292
R5624 VSS.n1337 VSS.t2047 187.292
R5625 VSS.n1353 VSS.t1920 187.292
R5626 VSS.n1369 VSS.t1965 187.292
R5627 VSS.n1385 VSS.t1960 187.292
R5628 VSS.n1402 VSS.t1950 187.292
R5629 VSS.n1418 VSS.t1943 187.292
R5630 VSS.n1434 VSS.t1938 187.292
R5631 VSS.n1450 VSS.t1927 187.292
R5632 VSS.n1466 VSS.t2058 187.292
R5633 VSS.n1482 VSS.t1977 187.292
R5634 VSS.n1499 VSS.t2049 187.292
R5635 VSS.n1515 VSS.t2064 187.292
R5636 VSS.n1531 VSS.t1994 187.292
R5637 VSS.n1547 VSS.t1991 187.292
R5638 VSS.n2780 VSS.t259 184.885
R5639 VSS.t248 VSS.n2333 184.885
R5640 VSS.n2811 VSS.t631 184.885
R5641 VSS.t1633 VSS.n737 184.262
R5642 VSS.n3 VSS.t2270 177.714
R5643 VSS.n733 VSS.t1140 177.633
R5644 VSS.t2199 VSS.n688 177.624
R5645 VSS.t1134 VSS.n715 177.62
R5646 VSS.t2194 VSS.n702 177.62
R5647 VSS.t2196 VSS.n680 177.62
R5648 VSS.t1136 VSS.n667 177.62
R5649 VSS.t1138 VSS.n632 177.617
R5650 VSS.t1131 VSS.n644 177.615
R5651 VSS.t236 VSS.n2322 176.209
R5652 VSS.n1120 VSS.t306 176.209
R5653 VSS.n1116 VSS.t313 176.209
R5654 VSS.n1112 VSS.t320 176.209
R5655 VSS.n1104 VSS.t327 176.209
R5656 VSS.n1100 VSS.t334 176.209
R5657 VSS.n1273 VSS.t189 176.209
R5658 VSS.n1269 VSS.t196 176.209
R5659 VSS.n1265 VSS.t203 176.209
R5660 VSS.n1257 VSS.t210 176.209
R5661 VSS.n1253 VSS.t217 176.209
R5662 VSS.n3356 VSS.t352 176.209
R5663 VSS.n3352 VSS.t359 176.209
R5664 VSS.n3348 VSS.t366 176.209
R5665 VSS.n3340 VSS.t373 176.209
R5666 VSS.n3336 VSS.t380 176.209
R5667 VSS.n132 VSS.t343 176.208
R5668 VSS.t226 VSS.n1566 176.208
R5669 VSS.t389 VSS.n139 176.208
R5670 VSS.t156 VSS.n2834 175.31
R5671 VSS.n2795 VSS.n2354 174.419
R5672 VSS.n2771 VSS.n2342 174.419
R5673 VSS.n2357 VSS.n2336 174.419
R5674 VSS.n553 VSS.t2012 173.913
R5675 VSS.n540 VSS.t699 173.913
R5676 VSS.n527 VSS.t721 173.913
R5677 VSS.n514 VSS.t1855 173.913
R5678 VSS.n501 VSS.t724 173.913
R5679 VSS.n489 VSS.t704 173.913
R5680 VSS.n475 VSS.t735 173.913
R5681 VSS.n462 VSS.t2371 173.913
R5682 VSS.n448 VSS.t719 173.913
R5683 VSS.n435 VSS.t1288 173.913
R5684 VSS.n421 VSS.t727 173.913
R5685 VSS.n406 VSS.t707 173.913
R5686 VSS.n391 VSS.t738 173.913
R5687 VSS.n377 VSS.t2373 173.913
R5688 VSS.n364 VSS.t2010 173.913
R5689 VSS.n350 VSS.t701 173.913
R5690 VSS.n1030 VSS.t2019 173.913
R5691 VSS.n1026 VSS.t1672 173.913
R5692 VSS.n1022 VSS.t1464 173.913
R5693 VSS.n1018 VSS.t1915 173.913
R5694 VSS.n1014 VSS.t1466 173.913
R5695 VSS.n1010 VSS.t1677 173.913
R5696 VSS.n1005 VSS.t964 173.913
R5697 VSS.n1001 VSS.t1683 173.913
R5698 VSS.n997 VSS.t956 173.913
R5699 VSS.n993 VSS.t1628 173.913
R5700 VSS.n989 VSS.t1468 173.913
R5701 VSS.n985 VSS.t1680 173.913
R5702 VSS.n981 VSS.t967 173.913
R5703 VSS.n977 VSS.t1685 173.913
R5704 VSS.n973 VSS.t1913 173.913
R5705 VSS.n969 VSS.t1674 173.913
R5706 VSS.n967 VSS.n966 173.913
R5707 VSS.n3304 VSS.t1115 173.913
R5708 VSS.n3295 VSS.t1763 173.913
R5709 VSS.n3288 VSS.t1383 173.913
R5710 VSS.n3280 VSS.t1888 173.913
R5711 VSS.n3271 VSS.t1385 173.913
R5712 VSS.n3264 VSS.t1768 173.913
R5713 VSS.n3255 VSS.t1434 173.913
R5714 VSS.n3247 VSS.t1789 173.913
R5715 VSS.n3240 VSS.t1381 173.913
R5716 VSS.n3232 VSS.t1746 173.913
R5717 VSS.n3224 VSS.t1388 173.913
R5718 VSS.n3217 VSS.t1770 173.913
R5719 VSS.n3209 VSS.t1436 173.913
R5720 VSS.n3201 VSS.t1791 173.913
R5721 VSS.n3194 VSS.t1123 173.913
R5722 VSS.n3185 VSS.t1765 173.913
R5723 VSS.n3183 VSS.n3182 173.913
R5724 VSS.t2043 VSS.n1685 173.913
R5725 VSS.t1536 VSS.n1701 173.913
R5726 VSS.t1009 VSS.n1717 173.913
R5727 VSS.t953 VSS.n1733 173.913
R5728 VSS.t1012 VSS.n1749 173.913
R5729 VSS.t1541 VSS.n1765 173.913
R5730 VSS.t1667 VSS.n1783 173.913
R5731 VSS.t1642 VSS.n1799 173.913
R5732 VSS.t1006 VSS.n1815 173.913
R5733 VSS.t569 VSS.n1831 173.913
R5734 VSS.t1015 VSS.n1847 173.913
R5735 VSS.t1544 VSS.n1863 173.913
R5736 VSS.t1669 VSS.n1880 173.913
R5737 VSS.t1644 VSS.n1897 173.913
R5738 VSS.t2041 VSS.n1913 173.913
R5739 VSS.t1538 VSS.n1930 173.913
R5740 VSS.n3007 VSS.n3006 173.913
R5741 VSS.t1875 VSS.n1309 173.913
R5742 VSS.t2245 VSS.n1325 173.913
R5743 VSS.t109 VSS.n1341 173.913
R5744 VSS.t1444 VSS.n1357 173.913
R5745 VSS.t2367 VSS.n1373 173.913
R5746 VSS.t1190 VSS.n1389 173.913
R5747 VSS.t1552 VSS.n1406 173.913
R5748 VSS.t478 VSS.n1422 173.913
R5749 VSS.t106 VSS.n1438 173.913
R5750 VSS.t1104 VSS.n1454 173.913
R5751 VSS.t2369 VSS.n1470 173.913
R5752 VSS.t1193 VSS.n1486 173.913
R5753 VSS.t1554 VSS.n1503 173.913
R5754 VSS.t481 VSS.n1519 173.913
R5755 VSS.t2227 VSS.n1535 173.913
R5756 VSS.t2247 VSS.n1550 173.913
R5757 VSS.n2830 VSS.t66 173.119
R5758 VSS.n2794 VSS.t998 167.442
R5759 VSS.n741 VSS.t2205 165.488
R5760 VSS.t2001 VSS.t1934 163.881
R5761 VSS.t732 VSS.t1952 163.881
R5762 VSS.t103 VSS.t1324 163.881
R5763 VSS.t1689 VSS.t1901 163.881
R5764 VSS.t2008 VSS.t1398 163.881
R5765 VSS.t1691 VSS.t1248 163.881
R5766 VSS.t2014 VSS.t636 163.881
R5767 VSS.t1284 VSS.t1211 163.881
R5768 VSS.t2003 VSS.t2338 163.881
R5769 VSS.t1687 VSS.t1216 163.881
R5770 VSS.t2006 VSS.t80 163.881
R5771 VSS.t1693 VSS.t777 163.881
R5772 VSS.t2017 VSS.t1430 163.881
R5773 VSS.t1286 VSS.t1438 163.881
R5774 VSS.t974 VSS.t1441 163.881
R5775 VSS.t729 VSS.t1989 163.881
R5776 VSS.t754 VSS.t1507 163.881
R5777 VSS.t1170 VSS.t962 163.881
R5778 VSS.t2211 VSS.t1917 163.881
R5779 VSS.t1606 VSS.t1731 163.881
R5780 VSS.t164 VSS.t1515 163.881
R5781 VSS.t684 VSS.t1733 163.881
R5782 VSS.t1166 VSS.t2021 163.881
R5783 VSS.t1341 VSS.t1737 163.881
R5784 VSS.t2279 VSS.t1510 163.881
R5785 VSS.t1729 VSS.t855 163.881
R5786 VSS.t1512 VSS.t1323 163.881
R5787 VSS.t767 VSS.t1735 163.881
R5788 VSS.t1563 VSS.t2024 163.881
R5789 VSS.t1361 VSS.t1739 163.881
R5790 VSS.t1919 VSS.t1619 163.881
R5791 VSS.t959 VSS.t2311 163.881
R5792 VSS.t1709 VSS.t766 163.881
R5793 VSS.t89 VSS.t1432 163.881
R5794 VSS.t867 VSS.t2255 163.881
R5795 VSS.t1600 VSS.t2121 163.881
R5796 VSS.t613 VSS.t1711 163.881
R5797 VSS.t1264 VSS.t1877 163.881
R5798 VSS.t2350 VSS.t1117 163.881
R5799 VSS.t1022 VSS.t1881 163.881
R5800 VSS.t1584 VSS.t1113 163.881
R5801 VSS.t910 VSS.t2119 163.881
R5802 VSS.t2289 VSS.t1714 163.881
R5803 VSS.t17 VSS.t1879 163.881
R5804 VSS.t170 VSS.t1120 163.881
R5805 VSS.t1025 VSS.t1883 163.881
R5806 VSS.t175 VSS.t2253 163.881
R5807 VSS.t1356 VSS.t1390 163.881
R5808 VSS.t1930 VSS.t2029 163.881
R5809 VSS.t2130 VSS.t7 163.881
R5810 VSS.t1939 VSS.t1725 163.881
R5811 VSS.t1316 VSS.t1654 163.881
R5812 VSS.t592 VSS.t2038 163.881
R5813 VSS.t1956 VSS.t1657 163.881
R5814 VSS.t1967 VSS.t2045 163.881
R5815 VSS.t838 VSS.t1556 163.881
R5816 VSS.t842 VSS.t2032 163.881
R5817 VSS.t1404 VSS.t1651 163.881
R5818 VSS.t1068 VSS.t2035 163.881
R5819 VSS.t1521 VSS.t1639 163.881
R5820 VSS.t2335 VSS.t2026 163.881
R5821 VSS.t1298 VSS.t1559 163.881
R5822 VSS.t938 VSS.t1722 163.881
R5823 VSS.t1906 VSS.t10 163.881
R5824 VSS.t878 VSS.t1647 163.881
R5825 VSS.t1799 VSS.t1748 163.881
R5826 VSS.t2174 VSS.t913 163.881
R5827 VSS.t1842 VSS.t661 163.881
R5828 VSS.t670 VSS.t1706 163.881
R5829 VSS.t673 VSS.t663 163.881
R5830 VSS.t1374 VSS.t1617 163.881
R5831 VSS.t575 VSS.t606 163.881
R5832 VSS.t1457 VSS.t2378 163.881
R5833 VSS.t1292 VSS.t659 163.881
R5834 VSS.t2144 VSS.t2109 163.881
R5835 VSS.t2240 VSS.t666 163.881
R5836 VSS.t2315 VSS.t1101 163.881
R5837 VSS.t71 VSS.t609 163.881
R5838 VSS.t2323 VSS.t2106 163.881
R5839 VSS.t2326 VSS.t1202 163.881
R5840 VSS.n3179 VSS.t350 162.322
R5841 VSS.t232 VSS.n1559 162.322
R5842 VSS.t396 VSS.n146 162.322
R5843 VSS.n1098 VSS.t339 162.321
R5844 VSS.n1251 VSS.t222 162.321
R5845 VSS.n3334 VSS.t385 162.321
R5846 VSS.n1118 VSS.t310 162.32
R5847 VSS.n1114 VSS.t317 162.32
R5848 VSS.n1110 VSS.t324 162.32
R5849 VSS.n1102 VSS.t331 162.32
R5850 VSS.n1271 VSS.t193 162.32
R5851 VSS.n1267 VSS.t200 162.32
R5852 VSS.n1263 VSS.t207 162.32
R5853 VSS.n1255 VSS.t214 162.32
R5854 VSS.n2843 VSS.t244 162.32
R5855 VSS.n3354 VSS.t356 162.32
R5856 VSS.n3350 VSS.t363 162.32
R5857 VSS.n3346 VSS.t370 162.32
R5858 VSS.n3338 VSS.t377 162.32
R5859 VSS.n2771 VSS.n2385 160.465
R5860 VSS.n2810 VSS.n2361 160.465
R5861 VSS.n636 VSS.t458 160.341
R5862 VSS.n586 VSS.t397 160.34
R5863 VSS.t409 VSS.n595 160.34
R5864 VSS.t421 VSS.n604 160.34
R5865 VSS.t433 VSS.n613 160.34
R5866 VSS.t445 VSS.n622 160.34
R5867 VSS.n1194 VSS.t2296 157.601
R5868 VSS.t28 VSS.n1628 157.062
R5869 VSS.n2768 VSS.t1233 156.977
R5870 VSS.n2337 VSS.t245 156.977
R5871 VSS.n1190 VSS.t2164 156.464
R5872 VSS.t182 VSS.n1632 156.429
R5873 VSS.n562 VSS.t1896 155.126
R5874 VSS.n549 VSS.t1898 155.126
R5875 VSS.t1063 VSS.n273 155.126
R5876 VSS.t1961 VSS.n278 155.126
R5877 VSS.n510 VSS.t886 155.126
R5878 VSS.t1905 VSS.n289 155.126
R5879 VSS.t2331 VSS.n296 155.126
R5880 VSS.t1251 VSS.n302 155.126
R5881 VSS.t1630 VSS.n310 155.126
R5882 VSS.t1982 VSS.n316 155.126
R5883 VSS.t2340 VSS.n319 155.126
R5884 VSS.t1634 VSS.n323 155.126
R5885 VSS.t1532 VSS.n333 155.126
R5886 VSS.t1988 VSS.n339 155.126
R5887 VSS.n235 VSS.t799 155.126
R5888 VSS.n232 VSS.t918 155.126
R5889 VSS.t2281 VSS.n157 155.126
R5890 VSS.n228 VSS.t625 155.126
R5891 VSS.n224 VSS.t2231 155.126
R5892 VSS.t2234 VSS.n162 155.126
R5893 VSS.n220 VSS.t2304 155.126
R5894 VSS.n210 VSS.t1182 155.126
R5895 VSS.t475 VSS.n166 155.126
R5896 VSS.t1082 VSS.n169 155.126
R5897 VSS.t2290 VSS.n170 155.126
R5898 VSS.n196 VSS.t1449 155.126
R5899 VSS.t836 VSS.n172 155.126
R5900 VSS.t1626 VSS.n1298 155.126
R5901 VSS.t1797 VSS.n1314 155.126
R5902 VSS.t1500 VSS.n1330 155.126
R5903 VSS.t1504 VSS.n1346 155.126
R5904 VSS.t1505 VSS.n1362 155.126
R5905 VSS.t2177 VSS.n1378 155.126
R5906 VSS.t1373 VSS.n1395 155.126
R5907 VSS.t1053 VSS.n1411 155.126
R5908 VSS.t1629 VSS.n1427 155.126
R5909 VSS.t2314 VSS.n1443 155.126
R5910 VSS.t2193 VSS.n1459 155.126
R5911 VSS.t1198 VSS.n1475 155.126
R5912 VSS.t2318 VSS.n1491 155.126
R5913 VSS.t945 VSS.n1508 155.126
R5914 VSS.t2322 VSS.n1524 155.126
R5915 VSS.t585 VSS.n1540 155.126
R5916 VSS.t936 VSS.n306 155.125
R5917 VSS.t1303 VSS.n329 155.125
R5918 VSS.t2361 VSS.n180 155.125
R5919 VSS.t1183 VSS.n181 155.125
R5920 VSS.t2073 VSS.n186 155.125
R5921 VSS.n3308 VSS.t656 155.125
R5922 VSS.n3300 VSS.t1282 155.125
R5923 VSS.t1771 VSS.n3049 155.125
R5924 VSS.n3285 VSS.t1234 155.125
R5925 VSS.n3276 VSS.t1327 155.125
R5926 VSS.t848 VSS.n3073 155.125
R5927 VSS.n3260 VSS.t2287 155.125
R5928 VSS.n3251 VSS.t1179 155.125
R5929 VSS.t1594 VSS.n3098 155.125
R5930 VSS.n3237 VSS.t2303 155.125
R5931 VSS.n3228 VSS.t1565 155.125
R5932 VSS.t186 VSS.n3122 155.125
R5933 VSS.n3214 VSS.t1076 155.125
R5934 VSS.n3205 VSS.t920 155.125
R5935 VSS.t1776 VSS.n3149 155.125
R5936 VSS.n3190 VSS.t1497 155.125
R5937 VSS.n1123 VSS.t125 154.862
R5938 VSS.t677 VSS.n1084 154.862
R5939 VSS.n1276 VSS.t2116 154.862
R5940 VSS.t2126 VSS.n1236 154.862
R5941 VSS.n3359 VSS.t2076 154.862
R5942 VSS.t2113 VSS.n783 154.862
R5943 VSS.n2946 VSS.t521 154.613
R5944 VSS.n2949 VSS.t527 154.613
R5945 VSS.t1858 VSS.n739 153.971
R5946 VSS.t1352 VSS.n1190 153.851
R5947 VSS.n567 VSS.t1827 153.846
R5948 VSS.n556 VSS.t2011 153.846
R5949 VSS.n543 VSS.t698 153.846
R5950 VSS.n530 VSS.t720 153.846
R5951 VSS.n517 VSS.t1854 153.846
R5952 VSS.n504 VSS.t723 153.846
R5953 VSS.n492 VSS.t703 153.846
R5954 VSS.n478 VSS.t734 153.846
R5955 VSS.n465 VSS.t2370 153.846
R5956 VSS.n451 VSS.t718 153.846
R5957 VSS.n438 VSS.t1287 153.846
R5958 VSS.n424 VSS.t726 153.846
R5959 VSS.n409 VSS.t706 153.846
R5960 VSS.n394 VSS.t737 153.846
R5961 VSS.n380 VSS.t2372 153.846
R5962 VSS.n367 VSS.t2009 153.846
R5963 VSS.n353 VSS.t700 153.846
R5964 VSS.t1849 VSS.n849 153.846
R5965 VSS.t2018 VSS.n856 153.846
R5966 VSS.t1671 VSS.n863 153.846
R5967 VSS.t1463 VSS.n870 153.846
R5968 VSS.t1914 VSS.n877 153.846
R5969 VSS.t1465 VSS.n884 153.846
R5970 VSS.t1676 VSS.n891 153.846
R5971 VSS.t963 VSS.n898 153.846
R5972 VSS.t1682 VSS.n905 153.846
R5973 VSS.t955 VSS.n912 153.846
R5974 VSS.t1627 VSS.n919 153.846
R5975 VSS.t1467 VSS.n926 153.846
R5976 VSS.t1679 VSS.n933 153.846
R5977 VSS.t966 VSS.n942 153.846
R5978 VSS.t1684 VSS.n949 153.846
R5979 VSS.t1912 VSS.n956 153.846
R5980 VSS.t1673 VSS.n963 153.846
R5981 VSS.t1447 VSS.n3029 153.846
R5982 VSS.t1114 VSS.n3037 153.846
R5983 VSS.t1762 VSS.n3044 153.846
R5984 VSS.t1382 VSS.n3053 153.846
R5985 VSS.t1887 VSS.n3061 153.846
R5986 VSS.t1384 VSS.n3068 153.846
R5987 VSS.t1767 VSS.n3077 153.846
R5988 VSS.t1433 VSS.n3085 153.846
R5989 VSS.t1788 VSS.n3093 153.846
R5990 VSS.t1380 VSS.n3102 153.846
R5991 VSS.t1745 VSS.n3110 153.846
R5992 VSS.t1387 VSS.n3118 153.846
R5993 VSS.t1769 VSS.n3127 153.846
R5994 VSS.t1435 VSS.n3137 153.846
R5995 VSS.t1790 VSS.n3145 153.846
R5996 VSS.t1122 VSS.n3154 153.846
R5997 VSS.t1764 VSS.n3161 153.846
R5998 VSS.n1645 VSS.t2067 153.846
R5999 VSS.t2042 VSS.n1682 153.846
R6000 VSS.t1535 VSS.n1698 153.846
R6001 VSS.t1008 VSS.n1714 153.846
R6002 VSS.t952 VSS.n1730 153.846
R6003 VSS.t1011 VSS.n1746 153.846
R6004 VSS.t1540 VSS.n1762 153.846
R6005 VSS.t1666 VSS.n1780 153.846
R6006 VSS.t1641 VSS.n1796 153.846
R6007 VSS.t1005 VSS.n1812 153.846
R6008 VSS.t568 VSS.n1828 153.846
R6009 VSS.t1014 VSS.n1844 153.846
R6010 VSS.t1543 VSS.n1860 153.846
R6011 VSS.t1668 VSS.n1877 153.846
R6012 VSS.t1643 VSS.n1894 153.846
R6013 VSS.t2040 VSS.n1910 153.846
R6014 VSS.t1537 VSS.n1927 153.846
R6015 VSS.t2053 VSS.n1291 153.846
R6016 VSS.t1874 VSS.n1305 153.846
R6017 VSS.t2244 VSS.n1321 153.846
R6018 VSS.t108 VSS.n1337 153.846
R6019 VSS.t1443 VSS.n1353 153.846
R6020 VSS.t2366 VSS.n1369 153.846
R6021 VSS.t1189 VSS.n1385 153.846
R6022 VSS.t1551 VSS.n1402 153.846
R6023 VSS.t477 VSS.n1418 153.846
R6024 VSS.t105 VSS.n1434 153.846
R6025 VSS.t1103 VSS.n1450 153.846
R6026 VSS.t2368 VSS.n1466 153.846
R6027 VSS.t1192 VSS.n1482 153.846
R6028 VSS.t1553 VSS.n1499 153.846
R6029 VSS.t480 VSS.n1515 153.846
R6030 VSS.t2226 VSS.n1531 153.846
R6031 VSS.t2246 VSS.n1547 153.846
R6032 VSS.n1632 VSS.t1805 153.327
R6033 VSS.t2136 VSS.n256 153.236
R6034 VSS.t1610 VSS.n152 153.236
R6035 VSS.t2297 VSS.n1137 153.236
R6036 VSS.n119 VSS.t1155 153.236
R6037 VSS.n1636 VSS.t29 153.236
R6038 VSS.n2846 VSS.n2845 152.106
R6039 VSS.n2795 VSS.t1829 150
R6040 VSS.t400 VSS.n586 148.827
R6041 VSS.t412 VSS.n595 148.827
R6042 VSS.t424 VSS.n604 148.827
R6043 VSS.t436 VSS.n613 148.827
R6044 VSS.t448 VSS.n622 148.827
R6045 VSS.t461 VSS.n636 148.826
R6046 VSS.n2951 VSS.t1027 147.452
R6047 VSS.n555 VSS.t1469 147.157
R6048 VSS.n542 VSS.t1897 147.157
R6049 VSS.n529 VSS.t2354 147.157
R6050 VSS.n516 VSS.t1297 147.157
R6051 VSS.n503 VSS.t1478 147.157
R6052 VSS.n491 VSS.t1972 147.157
R6053 VSS.n477 VSS.t2181 147.157
R6054 VSS.n464 VSS.t644 147.157
R6055 VSS.n450 VSS.t1526 147.157
R6056 VSS.n437 VSS.t1979 147.157
R6057 VSS.n423 VSS.t748 147.157
R6058 VSS.n408 VSS.t1331 147.157
R6059 VSS.n393 VSS.t1987 147.157
R6060 VSS.n379 VSS.t1252 147.157
R6061 VSS.n366 VSS.t1220 147.157
R6062 VSS.n352 VSS.t1533 147.157
R6063 VSS.n1031 VSS.t2224 147.157
R6064 VSS.n1027 VSS.t1574 147.157
R6065 VSS.n1023 VSS.t1773 147.157
R6066 VSS.n1019 VSS.t623 147.157
R6067 VSS.n1015 VSS.t1824 147.157
R6068 VSS.n1011 VSS.t34 147.157
R6069 VSS.n1006 VSS.t2286 147.157
R6070 VSS.n1002 VSS.t1568 147.157
R6071 VSS.n998 VSS.t1226 147.157
R6072 VSS.n994 VSS.t1231 147.157
R6073 VSS.n990 VSS.t1081 147.157
R6074 VSS.n986 VSS.t2280 147.157
R6075 VSS.n982 VSS.t1171 147.157
R6076 VSS.n978 VSS.t903 147.157
R6077 VSS.n974 VSS.t1810 147.157
R6078 VSS.n970 VSS.t1366 147.157
R6079 VSS.n3305 VSS.t24 147.157
R6080 VSS.n3296 VSS.t2277 147.157
R6081 VSS.n3289 VSS.t2232 147.157
R6082 VSS.n3281 VSS.t151 147.157
R6083 VSS.n3272 VSS.t772 147.157
R6084 VSS.n3265 VSS.t852 147.157
R6085 VSS.n3256 VSS.t2294 147.157
R6086 VSS.n3248 VSS.t1230 147.157
R6087 VSS.n3241 VSS.t862 147.157
R6088 VSS.n3233 VSS.t2309 147.157
R6089 VSS.n3225 VSS.t2202 147.157
R6090 VSS.n3218 VSS.t1258 147.157
R6091 VSS.n3210 VSS.t1029 147.157
R6092 VSS.n3202 VSS.t134 147.157
R6093 VSS.n3195 VSS.t1040 147.157
R6094 VSS.n3186 VSS.t183 147.157
R6095 VSS.n2021 VSS.t1306 147.157
R6096 VSS.t2134 VSS.n1683 147.157
R6097 VSS.n2016 VSS.t1935 147.157
R6098 VSS.t1579 VSS.n1699 147.157
R6099 VSS.n2011 VSS.t1937 147.157
R6100 VSS.t1319 VSS.n1715 147.157
R6101 VSS.n2006 VSS.t1949 147.157
R6102 VSS.t1580 VSS.n1731 147.157
R6103 VSS.n2001 VSS.t747 147.157
R6104 VSS.t1959 VSS.n1747 147.157
R6105 VSS.n1996 VSS.t1245 147.157
R6106 VSS.t1206 VSS.n1763 147.157
R6107 VSS.n1990 VSS.t1964 147.157
R6108 VSS.t77 VSS.n1781 147.157
R6109 VSS.n1985 VSS.t888 147.157
R6110 VSS.t1397 VSS.n1797 147.157
R6111 VSS.n1980 VSS.t1481 147.157
R6112 VSS.t1479 VSS.n1813 147.157
R6113 VSS.n1975 VSS.t846 147.157
R6114 VSS.t1411 VSS.n1829 147.157
R6115 VSS.n1970 VSS.t1832 147.157
R6116 VSS.t2182 VSS.n1845 147.157
R6117 VSS.n1965 VSS.t1834 147.157
R6118 VSS.t1520 VSS.n1861 147.157
R6119 VSS.n1960 VSS.t642 147.157
R6120 VSS.t1418 VSS.n1878 147.157
R6121 VSS.n1955 VSS.t1836 147.157
R6122 VSS.t1302 VSS.n1895 147.157
R6123 VSS.n1950 VSS.t775 147.157
R6124 VSS.t1106 VSS.n1911 147.157
R6125 VSS.n1945 VSS.t599 147.157
R6126 VSS.t1980 VSS.n1928 147.157
R6127 VSS.t1237 VSS.n1307 147.157
R6128 VSS.t1502 VSS.n1322 147.157
R6129 VSS.t668 VSS.n1338 147.157
R6130 VSS.t67 VSS.n1354 147.157
R6131 VSS.t1185 VSS.n1370 147.157
R6132 VSS.t1845 VSS.n1387 147.157
R6133 VSS.t1290 VSS.n1403 147.157
R6134 VSS.t573 VSS.n1419 147.157
R6135 VSS.t2349 VSS.n1435 147.157
R6136 VSS.t1098 VSS.n1451 147.157
R6137 VSS.t1755 VSS.n1467 147.157
R6138 VSS.t1197 VSS.n1483 147.157
R6139 VSS.t2319 VSS.n1500 147.157
R6140 VSS.t2242 VSS.n1516 147.157
R6141 VSS.t1200 VSS.n1532 147.157
R6142 VSS.t74 VSS.n1548 147.157
R6143 VSS.t267 VSS.n2754 146.853
R6144 VSS.n2783 VSS.n2372 146.853
R6145 VSS.n2791 VSS.n2350 146.512
R6146 VSS.n2780 VSS.n2346 146.512
R6147 VSS.n2760 VSS.n2387 146.512
R6148 VSS.t567 VSS.n341 145.093
R6149 VSS.t542 VSS.n3164 145.093
R6150 VSS.t497 VSS.n1553 145.093
R6151 VSS.t555 VSS.n190 145.091
R6152 VSS.t261 VSS.n2383 143.024
R6153 VSS.n2791 VSS.t31 139.536
R6154 VSS.t1603 VSS.n2336 139.536
R6155 VSS.t563 VSS.n341 138.404
R6156 VSS.n3164 VSS.t538 138.404
R6157 VSS.n1553 VSS.t493 138.403
R6158 VSS.n190 VSS.t551 138.403
R6159 VSS.t468 VSS.n644 137.311
R6160 VSS.n751 VSS.t1622 137.31
R6161 VSS.n632 VSS.t457 137.31
R6162 VSS.n715 VSS.t408 137.309
R6163 VSS.n702 VSS.t420 137.309
R6164 VSS.n680 VSS.t432 137.309
R6165 VSS.n667 VSS.t444 137.309
R6166 VSS.n3008 VSS.t508 137.125
R6167 VSS.n2808 VSS.t252 136.048
R6168 VSS.t1752 VSS.n1620 134.661
R6169 VSS.n3360 VSS.t2087 133.78
R6170 VSS.n1124 VSS.t2301 133.78
R6171 VSS.t1161 VSS.n1647 133.78
R6172 VSS.n2834 VSS.n2833 132.891
R6173 VSS.n2755 VSS.n2389 132.868
R6174 VSS.n2805 VSS.n2369 132.559
R6175 VSS.n2806 VSS.n2369 132.559
R6176 VSS.t493 VSS.n1551 131.975
R6177 VSS.n348 VSS.t563 131.974
R6178 VSS.t538 VSS.n1181 131.974
R6179 VSS.t551 VSS.n189 131.971
R6180 VSS.n736 VSS.t1078 130.939
R6181 VSS.t1604 VSS.n686 130.939
R6182 VSS.n1939 VSS.t504 130.435
R6183 VSS.n2787 VSS.t2306 129.071
R6184 VSS.n2819 VSS.t2215 129.071
R6185 VSS.t158 VSS.n2384 129.071
R6186 VSS.n2767 VSS.t264 129.071
R6187 VSS.n2847 VSS.n2846 129.071
R6188 VSS.t2214 VSS.n2362 129.071
R6189 VSS.t863 VSS.n1195 127.421
R6190 VSS.n1627 VSS.t1760 126.945
R6191 VSS.t999 VSS.n2351 125.582
R6192 VSS.t1718 VSS.n2947 125.359
R6193 VSS.t504 VSS.n1932 123.746
R6194 VSS.n1199 VSS.t1311 123.674
R6195 VSS.t1999 VSS.n1623 123.212
R6196 VSS.n1555 VSS.t497 122.516
R6197 VSS.n344 VSS.t567 122.516
R6198 VSS.n2944 VSS.n2178 122.129
R6199 VSS.t252 VSS.n2367 122.094
R6200 VSS.n2187 VSS.t162 121.858
R6201 VSS.t2087 VSS.n256 120.691
R6202 VSS.t2301 VSS.n152 120.691
R6203 VSS.t2164 VSS.n1137 120.691
R6204 VSS.n119 VSS.t1161 120.691
R6205 VSS.n1636 VSS.t182 120.691
R6206 VSS.t1227 VSS.n744 119.422
R6207 VSS.n2793 VSS.t999 118.606
R6208 VSS.n2759 VSS.t267 118.606
R6209 VSS.n2809 VSS.n2365 118.606
R6210 VSS.t2295 VSS.n3024 118.249
R6211 VSS.n1620 VSS.t26 117.858
R6212 VSS.n967 VSS.t555 117.058
R6213 VSS.n3183 VSS.t542 117.058
R6214 VSS.t508 VSS.n3007 117.058
R6215 VSS.t1089 VSS.n1200 116.177
R6216 VSS.n1622 VSS.t1816 115.745
R6217 VSS.n2804 VSS.t2217 115.117
R6218 VSS.t2347 VSS.n2180 112.174
R6219 VSS.n1127 VSS.n802 112.15
R6220 VSS.t130 VSS.n2372 111.888
R6221 VSS.n761 VSS.t1840 109.198
R6222 VSS.t1615 VSS.n1062 109.198
R6223 VSS.n1652 VSS.t1075 109.198
R6224 VSS.n1197 VSS.t1090 108.683
R6225 VSS.t1817 VSS.n1625 108.276
R6226 VSS.t1896 VSS.n561 107.023
R6227 VSS.t1469 VSS.n554 107.023
R6228 VSS.t1898 VSS.n548 107.023
R6229 VSS.t1897 VSS.n541 107.023
R6230 VSS.n535 VSS.t1063 107.023
R6231 VSS.t2354 VSS.n528 107.023
R6232 VSS.n522 VSS.t1961 107.023
R6233 VSS.t1297 VSS.n515 107.023
R6234 VSS.t886 VSS.n509 107.023
R6235 VSS.t1478 VSS.n502 107.023
R6236 VSS.n497 VSS.t1905 107.023
R6237 VSS.t1972 VSS.n490 107.023
R6238 VSS.n483 VSS.t2331 107.023
R6239 VSS.t2181 VSS.n476 107.023
R6240 VSS.n470 VSS.t1251 107.023
R6241 VSS.t644 VSS.n463 107.023
R6242 VSS.n457 VSS.t936 107.023
R6243 VSS.t1526 VSS.n449 107.023
R6244 VSS.n443 VSS.t1630 107.023
R6245 VSS.t1979 VSS.n436 107.023
R6246 VSS.n430 VSS.t1982 107.023
R6247 VSS.t748 VSS.n422 107.023
R6248 VSS.n415 VSS.t2340 107.023
R6249 VSS.t1331 VSS.n407 107.023
R6250 VSS.n400 VSS.t1634 107.023
R6251 VSS.t1987 VSS.n392 107.023
R6252 VSS.n386 VSS.t1303 107.023
R6253 VSS.t1252 VSS.n378 107.023
R6254 VSS.n372 VSS.t1532 107.023
R6255 VSS.t1220 VSS.n365 107.023
R6256 VSS.n359 VSS.t1988 107.023
R6257 VSS.t1533 VSS.n351 107.023
R6258 VSS.t799 VSS.n854 107.023
R6259 VSS.t2224 VSS.n857 107.023
R6260 VSS.t918 VSS.n861 107.023
R6261 VSS.t1574 VSS.n864 107.023
R6262 VSS.n868 VSS.t2281 107.023
R6263 VSS.t1773 VSS.n871 107.023
R6264 VSS.t625 VSS.n875 107.023
R6265 VSS.t623 VSS.n878 107.023
R6266 VSS.t2231 VSS.n882 107.023
R6267 VSS.t1824 VSS.n885 107.023
R6268 VSS.n889 VSS.t2234 107.023
R6269 VSS.t34 VSS.n892 107.023
R6270 VSS.t2304 VSS.n896 107.023
R6271 VSS.t2286 VSS.n899 107.023
R6272 VSS.n903 VSS.t2361 107.023
R6273 VSS.t1568 VSS.n906 107.023
R6274 VSS.n910 VSS.t1183 107.023
R6275 VSS.t1226 VSS.n913 107.023
R6276 VSS.t1182 VSS.n917 107.023
R6277 VSS.t1231 VSS.n920 107.023
R6278 VSS.n924 VSS.t475 107.023
R6279 VSS.t1081 VSS.n927 107.023
R6280 VSS.n931 VSS.t1082 107.023
R6281 VSS.t2280 VSS.n934 107.023
R6282 VSS.n939 VSS.t2290 107.023
R6283 VSS.t1171 VSS.n943 107.023
R6284 VSS.n947 VSS.t2073 107.023
R6285 VSS.t903 VSS.n950 107.023
R6286 VSS.t1449 VSS.n954 107.023
R6287 VSS.t1810 VSS.n957 107.023
R6288 VSS.n961 VSS.t836 107.023
R6289 VSS.t1366 VSS.n964 107.023
R6290 VSS.t656 VSS.n3035 107.023
R6291 VSS.t24 VSS.n3038 107.023
R6292 VSS.t1282 VSS.n3042 107.023
R6293 VSS.t2277 VSS.n3045 107.023
R6294 VSS.n3051 VSS.t1771 107.023
R6295 VSS.t2232 VSS.n3054 107.023
R6296 VSS.t1234 VSS.n3059 107.023
R6297 VSS.t151 VSS.n3062 107.023
R6298 VSS.t1327 VSS.n3066 107.023
R6299 VSS.t772 VSS.n3069 107.023
R6300 VSS.n3075 VSS.t848 107.023
R6301 VSS.t852 VSS.n3078 107.023
R6302 VSS.t2287 VSS.n3083 107.023
R6303 VSS.t2294 VSS.n3086 107.023
R6304 VSS.t1179 VSS.n3090 107.023
R6305 VSS.t1230 VSS.n3094 107.023
R6306 VSS.n3100 VSS.t1594 107.023
R6307 VSS.t862 VSS.n3103 107.023
R6308 VSS.t2303 VSS.n3108 107.023
R6309 VSS.t2309 VSS.n3111 107.023
R6310 VSS.t1565 VSS.n3115 107.023
R6311 VSS.t2202 VSS.n3119 107.023
R6312 VSS.n3124 VSS.t186 107.023
R6313 VSS.t1258 VSS.n3128 107.023
R6314 VSS.t1076 VSS.n3134 107.023
R6315 VSS.t1029 VSS.n3138 107.023
R6316 VSS.t920 VSS.n3142 107.023
R6317 VSS.t134 VSS.n3146 107.023
R6318 VSS.n3151 VSS.t1776 107.023
R6319 VSS.t1040 VSS.n3155 107.023
R6320 VSS.t1497 VSS.n3159 107.023
R6321 VSS.t183 VSS.n3162 107.023
R6322 VSS.t1306 VSS.n1676 107.023
R6323 VSS.n1684 VSS.t2134 107.023
R6324 VSS.t1935 VSS.n1692 107.023
R6325 VSS.n1700 VSS.t1579 107.023
R6326 VSS.t1937 VSS.n1708 107.023
R6327 VSS.n1716 VSS.t1319 107.023
R6328 VSS.t1949 VSS.n1724 107.023
R6329 VSS.n1732 VSS.t1580 107.023
R6330 VSS.t747 VSS.n1740 107.023
R6331 VSS.n1748 VSS.t1959 107.023
R6332 VSS.t1245 VSS.n1756 107.023
R6333 VSS.n1764 VSS.t1206 107.023
R6334 VSS.t1964 VSS.n1773 107.023
R6335 VSS.n1782 VSS.t77 107.023
R6336 VSS.t888 VSS.n1790 107.023
R6337 VSS.n1798 VSS.t1397 107.023
R6338 VSS.t1481 VSS.n1806 107.023
R6339 VSS.n1814 VSS.t1479 107.023
R6340 VSS.t846 VSS.n1822 107.023
R6341 VSS.n1830 VSS.t1411 107.023
R6342 VSS.t1832 VSS.n1838 107.023
R6343 VSS.n1846 VSS.t2182 107.023
R6344 VSS.t1834 VSS.n1854 107.023
R6345 VSS.n1862 VSS.t1520 107.023
R6346 VSS.t642 VSS.n1870 107.023
R6347 VSS.n1879 VSS.t1418 107.023
R6348 VSS.t1836 VSS.n1888 107.023
R6349 VSS.n1896 VSS.t1302 107.023
R6350 VSS.t775 VSS.n1904 107.023
R6351 VSS.n1912 VSS.t1106 107.023
R6352 VSS.t599 VSS.n1920 107.023
R6353 VSS.n1929 VSS.t1980 107.023
R6354 VSS.n1300 VSS.t1626 107.023
R6355 VSS.n1308 VSS.t1237 107.023
R6356 VSS.n1316 VSS.t1797 107.023
R6357 VSS.n1323 VSS.t1502 107.023
R6358 VSS.n1331 VSS.t1500 107.023
R6359 VSS.n1339 VSS.t668 107.023
R6360 VSS.n1347 VSS.t1504 107.023
R6361 VSS.n1355 VSS.t67 107.023
R6362 VSS.n1363 VSS.t1505 107.023
R6363 VSS.n1372 VSS.t1185 107.023
R6364 VSS.n1380 VSS.t2177 107.023
R6365 VSS.n1388 VSS.t1845 107.023
R6366 VSS.n1396 VSS.t1373 107.023
R6367 VSS.n1404 VSS.t1290 107.023
R6368 VSS.n1412 VSS.t1053 107.023
R6369 VSS.n1420 VSS.t573 107.023
R6370 VSS.n1429 VSS.t1629 107.023
R6371 VSS.n1437 VSS.t2349 107.023
R6372 VSS.n1445 VSS.t2314 107.023
R6373 VSS.n1452 VSS.t1098 107.023
R6374 VSS.n1460 VSS.t2193 107.023
R6375 VSS.n1468 VSS.t1755 107.023
R6376 VSS.n1476 VSS.t1198 107.023
R6377 VSS.n1484 VSS.t1197 107.023
R6378 VSS.n1493 VSS.t2318 107.023
R6379 VSS.n1501 VSS.t2319 107.023
R6380 VSS.n1509 VSS.t945 107.023
R6381 VSS.n1518 VSS.t2242 107.023
R6382 VSS.n1526 VSS.t2322 107.023
R6383 VSS.n1533 VSS.t1200 107.023
R6384 VSS.n1541 VSS.t585 107.023
R6385 VSS.n1549 VSS.t74 107.023
R6386 VSS.n3023 VSS.t1572 106.808
R6387 VSS.n2785 VSS.n2374 104.651
R6388 VSS.n2794 VSS.n2352 104.651
R6389 VSS.n2775 VSS.t1026 104.651
R6390 VSS.n2773 VSS.n2344 104.651
R6391 VSS.n2767 VSS.n2385 104.651
R6392 VSS.n2358 VSS.n2332 104.651
R6393 VSS.n2188 VSS.t1345 103.538
R6394 VSS.n2196 VSS.t1041 103.379
R6395 VSS.n2773 VSS.t158 101.163
R6396 VSS.t264 VSS.n2343 101.163
R6397 VSS.n2804 VSS.t1077 101.163
R6398 VSS.n578 VSS.t1774 100.344
R6399 VSS.t1795 VSS.n1043 100.344
R6400 VSS.n122 VSS.t2343 100.344
R6401 VSS.n567 VSS.t558 100.335
R6402 VSS.t2011 VSS.n555 100.335
R6403 VSS.t698 VSS.n542 100.335
R6404 VSS.t720 VSS.n529 100.335
R6405 VSS.t1854 VSS.n516 100.335
R6406 VSS.t723 VSS.n503 100.335
R6407 VSS.t703 VSS.n491 100.335
R6408 VSS.t734 VSS.n477 100.335
R6409 VSS.t2370 VSS.n464 100.335
R6410 VSS.t718 VSS.n450 100.335
R6411 VSS.t1287 VSS.n437 100.335
R6412 VSS.t726 VSS.n423 100.335
R6413 VSS.t706 VSS.n408 100.335
R6414 VSS.t737 VSS.n393 100.335
R6415 VSS.t2372 VSS.n379 100.335
R6416 VSS.t2009 VSS.n366 100.335
R6417 VSS.t700 VSS.n352 100.335
R6418 VSS.n849 VSS.t545 100.335
R6419 VSS.n1031 VSS.t2018 100.335
R6420 VSS.n1027 VSS.t1671 100.335
R6421 VSS.n1023 VSS.t1463 100.335
R6422 VSS.n1019 VSS.t1914 100.335
R6423 VSS.n1015 VSS.t1465 100.335
R6424 VSS.n1011 VSS.t1676 100.335
R6425 VSS.n1006 VSS.t963 100.335
R6426 VSS.n1002 VSS.t1682 100.335
R6427 VSS.n998 VSS.t955 100.335
R6428 VSS.n994 VSS.t1627 100.335
R6429 VSS.n990 VSS.t1467 100.335
R6430 VSS.n986 VSS.t1679 100.335
R6431 VSS.n982 VSS.t966 100.335
R6432 VSS.n978 VSS.t1684 100.335
R6433 VSS.n974 VSS.t1912 100.335
R6434 VSS.n970 VSS.t1673 100.335
R6435 VSS.n3029 VSS.t533 100.335
R6436 VSS.n3305 VSS.t1114 100.335
R6437 VSS.n3296 VSS.t1762 100.335
R6438 VSS.n3289 VSS.t1382 100.335
R6439 VSS.n3281 VSS.t1887 100.335
R6440 VSS.n3272 VSS.t1384 100.335
R6441 VSS.n3265 VSS.t1767 100.335
R6442 VSS.n3256 VSS.t1433 100.335
R6443 VSS.n3248 VSS.t1788 100.335
R6444 VSS.n3241 VSS.t1380 100.335
R6445 VSS.n3233 VSS.t1745 100.335
R6446 VSS.n3225 VSS.t1387 100.335
R6447 VSS.n3218 VSS.t1769 100.335
R6448 VSS.n3210 VSS.t1435 100.335
R6449 VSS.n3202 VSS.t1790 100.335
R6450 VSS.n3195 VSS.t1122 100.335
R6451 VSS.n3186 VSS.t1764 100.335
R6452 VSS.t499 VSS.n1645 100.335
R6453 VSS.n1683 VSS.t2042 100.335
R6454 VSS.n1699 VSS.t1535 100.335
R6455 VSS.n1715 VSS.t1008 100.335
R6456 VSS.n1731 VSS.t952 100.335
R6457 VSS.n1747 VSS.t1011 100.335
R6458 VSS.n1763 VSS.t1540 100.335
R6459 VSS.n1781 VSS.t1666 100.335
R6460 VSS.n1797 VSS.t1641 100.335
R6461 VSS.n1813 VSS.t1005 100.335
R6462 VSS.n1829 VSS.t568 100.335
R6463 VSS.n1845 VSS.t1014 100.335
R6464 VSS.n1861 VSS.t1543 100.335
R6465 VSS.n1878 VSS.t1668 100.335
R6466 VSS.n1895 VSS.t1643 100.335
R6467 VSS.n1911 VSS.t2040 100.335
R6468 VSS.n1928 VSS.t1537 100.335
R6469 VSS.n1291 VSS.t488 100.335
R6470 VSS.n1307 VSS.t1874 100.335
R6471 VSS.n1322 VSS.t2244 100.335
R6472 VSS.n1338 VSS.t108 100.335
R6473 VSS.n1354 VSS.t1443 100.335
R6474 VSS.n1370 VSS.t2366 100.335
R6475 VSS.n1387 VSS.t1189 100.335
R6476 VSS.n1403 VSS.t1551 100.335
R6477 VSS.n1419 VSS.t477 100.335
R6478 VSS.n1435 VSS.t105 100.335
R6479 VSS.n1451 VSS.t1103 100.335
R6480 VSS.n1467 VSS.t2368 100.335
R6481 VSS.n1483 VSS.t1192 100.335
R6482 VSS.n1500 VSS.t1553 100.335
R6483 VSS.n1516 VSS.t480 100.335
R6484 VSS.n1532 VSS.t2226 100.335
R6485 VSS.n1548 VSS.t2246 100.335
R6486 VSS.t523 VSS.n2946 99.7511
R6487 VSS.t529 VSS.n2949 99.7511
R6488 VSS.n2195 VSS.t624 98.4633
R6489 VSS.n2947 VSS.t523 97.9266
R6490 VSS.n2950 VSS.t529 97.9266
R6491 VSS.n1192 VSS.t1351 97.4396
R6492 VSS.n581 VSS.t1787 97.3935
R6493 VSS.t1462 VSS.n1046 97.3935
R6494 VSS.n124 VSS.t1997 97.3935
R6495 VSS.t1804 VSS.n1630 97.0758
R6496 VSS.n749 VSS.t1229 96.3896
R6497 VSS.n583 VSS.t145 94.4422
R6498 VSS.t587 VSS.n1048 94.4422
R6499 VSS.n1284 VSS.t1910 94.4422
R6500 VSS.t266 VSS.n2387 94.1866
R6501 VSS.t865 VSS.n1194 93.8889
R6502 VSS.t1573 VSS.n1192 93.6919
R6503 VSS.n1628 VSS.t1761 93.5889
R6504 VSS.n1630 VSS.t1753 93.3421
R6505 VSS.t904 VSS.n246 91.4909
R6506 VSS.t743 VSS.n798 91.4909
R6507 VSS.t1256 VSS.n125 91.4909
R6508 VSS.n2758 VSS.t1232 90.9096
R6509 VSS.n2793 VSS.n2376 90.6982
R6510 VSS.n2824 VSS.n2383 90.6982
R6511 VSS.n2357 VSS.n2331 90.6982
R6512 VSS.n2811 VSS.n2362 90.6982
R6513 VSS.t1674 VSS.n189 88.495
R6514 VSS.t701 VSS.n348 88.4947
R6515 VSS.t1765 VSS.n1181 88.4945
R6516 VSS.n1551 VSS.t2247 88.4935
R6517 VSS.t2161 VSS.n3025 88.4111
R6518 VSS.t472 VSS.n2191 88.3462
R6519 VSS.t2012 VSS.n267 88.2366
R6520 VSS.t1855 VSS.n282 88.2366
R6521 VSS.t735 VSS.n300 88.2366
R6522 VSS.t707 VSS.n321 88.2366
R6523 VSS.t1672 VSS.n176 88.2366
R6524 VSS.t1466 VSS.n178 88.2366
R6525 VSS.t1680 VSS.n185 88.2366
R6526 VSS.t699 VSS.n272 88.2359
R6527 VSS.t721 VSS.n526 88.2359
R6528 VSS.t724 VSS.n287 88.2359
R6529 VSS.t704 VSS.n488 88.2359
R6530 VSS.t2371 VSS.n305 88.2359
R6531 VSS.t719 VSS.n447 88.2359
R6532 VSS.t1288 VSS.n434 88.2359
R6533 VSS.t727 VSS.n420 88.2359
R6534 VSS.t738 VSS.n328 88.2359
R6535 VSS.t2373 VSS.n376 88.2359
R6536 VSS.t2010 VSS.n363 88.2359
R6537 VSS.t2019 VSS.n233 88.2359
R6538 VSS.t1464 VSS.n229 88.2359
R6539 VSS.t1915 VSS.n225 88.2359
R6540 VSS.t1677 VSS.n221 88.2359
R6541 VSS.t964 VSS.n217 88.2359
R6542 VSS.t1683 VSS.n214 88.2359
R6543 VSS.t956 VSS.n211 88.2359
R6544 VSS.t1628 VSS.n208 88.2359
R6545 VSS.t1468 VSS.n168 88.2359
R6546 VSS.t967 VSS.n200 88.2359
R6547 VSS.t1685 VSS.n197 88.2359
R6548 VSS.t1913 VSS.n194 88.2359
R6549 VSS.n1310 VSS.t1875 88.2357
R6550 VSS.n1326 VSS.t2245 88.2357
R6551 VSS.n1342 VSS.t109 88.2357
R6552 VSS.n1358 VSS.t1444 88.2357
R6553 VSS.n1374 VSS.t2367 88.2357
R6554 VSS.n1390 VSS.t1190 88.2357
R6555 VSS.n1407 VSS.t1552 88.2357
R6556 VSS.n1423 VSS.t478 88.2357
R6557 VSS.n1439 VSS.t106 88.2357
R6558 VSS.n1455 VSS.t1104 88.2357
R6559 VSS.n1471 VSS.t2369 88.2357
R6560 VSS.n1487 VSS.t1193 88.2357
R6561 VSS.n1504 VSS.t1554 88.2357
R6562 VSS.n1520 VSS.t481 88.2357
R6563 VSS.n1536 VSS.t2227 88.2357
R6564 VSS.t1115 VSS.n3303 88.2357
R6565 VSS.t1383 VSS.n3287 88.2357
R6566 VSS.t1888 VSS.n3279 88.2357
R6567 VSS.t1768 VSS.n3263 88.2357
R6568 VSS.t1434 VSS.n3254 88.2357
R6569 VSS.t1381 VSS.n3239 88.2357
R6570 VSS.t1746 VSS.n3231 88.2357
R6571 VSS.t1388 VSS.n3223 88.2357
R6572 VSS.t1770 VSS.n3216 88.2357
R6573 VSS.t1436 VSS.n3208 88.2357
R6574 VSS.t1791 VSS.n3200 88.2357
R6575 VSS.t1123 VSS.n3193 88.2357
R6576 VSS.t1763 VSS.n3046 88.2357
R6577 VSS.t1385 VSS.n3070 88.2357
R6578 VSS.t1789 VSS.n3095 88.2357
R6579 VSS.n1619 VSS.t180 88.133
R6580 VSS.n966 VSS.n149 88.4708
R6581 VSS.n2787 VSS.t2218 87.2098
R6582 VSS.n2777 VSS.t256 87.2098
R6583 VSS.t101 VSS.n2344 87.2098
R6584 VSS.t33 VSS.n2361 87.2098
R6585 VSS.t558 VSS.t1825 86.957
R6586 VSS.t1827 VSS.t560 86.957
R6587 VSS.t545 VSS.t1848 86.957
R6588 VSS.t547 VSS.t1849 86.957
R6589 VSS.t533 VSS.t1445 86.957
R6590 VSS.t535 VSS.t1447 86.957
R6591 VSS.t2066 VSS.t499 86.957
R6592 VSS.t2067 VSS.t501 86.957
R6593 VSS.t488 VSS.t2052 86.957
R6594 VSS.t490 VSS.t2053 86.957
R6595 VSS.t906 VSS.n249 85.5883
R6596 VSS.t741 VSS.n800 85.5883
R6597 VSS.t1255 VSS.n123 85.5883
R6598 VSS.t2204 VSS.n749 84.8733
R6599 VSS.n3027 VSS.t2161 83.0562
R6600 VSS.t180 VSS.n1203 82.7875
R6601 VSS.t2163 VSS.n1197 82.449
R6602 VSS.n1625 VSS.t181 82.1411
R6603 VSS.t474 VSS.n2189 81.2384
R6604 VSS.n3367 VSS.t922 81.1613
R6605 VSS.n1132 VSS.t930 81.1613
R6606 VSS.n1663 VSS.t1152 81.1613
R6607 VSS.n2948 VSS.t1718 80.4704
R6608 VSS.n3182 VSS.n3166 80.2681
R6609 VSS.n2028 VSS.t2043 80.2681
R6610 VSS.n2035 VSS.t1536 80.2681
R6611 VSS.n2042 VSS.t1009 80.2681
R6612 VSS.n2049 VSS.t953 80.2681
R6613 VSS.n2056 VSS.t1012 80.2681
R6614 VSS.n2064 VSS.t1541 80.2681
R6615 VSS.n2071 VSS.t1667 80.2681
R6616 VSS.n2078 VSS.t1642 80.2681
R6617 VSS.n2085 VSS.t1006 80.2681
R6618 VSS.n2092 VSS.t569 80.2681
R6619 VSS.n2099 VSS.t1015 80.2681
R6620 VSS.n2106 VSS.t1544 80.2681
R6621 VSS.n2113 VSS.t1669 80.2681
R6622 VSS.n2120 VSS.t1644 80.2681
R6623 VSS.n2127 VSS.t2041 80.2681
R6624 VSS.n2133 VSS.t1538 80.2681
R6625 VSS.n3006 VSS.n1936 80.2681
R6626 VSS.n2335 VSS.t248 80.2331
R6627 VSS.n3175 VSS.t345 78.9866
R6628 VSS.t228 VSS.n1563 78.9866
R6629 VSS.t391 VSS.n3329 78.9866
R6630 VSS.t307 VSS.n1068 78.9856
R6631 VSS.t314 VSS.n1072 78.9856
R6632 VSS.t321 VSS.n1078 78.9856
R6633 VSS.t328 VSS.n1087 78.9856
R6634 VSS.t335 VSS.n1093 78.9856
R6635 VSS.t190 VSS.n1220 78.9856
R6636 VSS.t197 VSS.n1224 78.9856
R6637 VSS.t204 VSS.n1230 78.9856
R6638 VSS.t211 VSS.n1239 78.9856
R6639 VSS.t218 VSS.n1245 78.9856
R6640 VSS.t238 VSS.n2327 78.9856
R6641 VSS.t353 VSS.n767 78.9856
R6642 VSS.t360 VSS.n771 78.9856
R6643 VSS.t367 VSS.n777 78.9856
R6644 VSS.t374 VSS.n786 78.9856
R6645 VSS.t381 VSS.n792 78.9856
R6646 VSS.t135 VSS.n2262 77.8798
R6647 VSS.n2790 VSS.n2379 77.8593
R6648 VSS.n2779 VSS.n2380 77.8593
R6649 VSS.n2807 VSS.n2368 77.8593
R6650 VSS.n2941 VSS.t1265 77.2751
R6651 VSS.t153 VSS.t2201 77.2751
R6652 VSS.n2789 VSS.n2378 76.7447
R6653 VSS.n2753 VSS.n2340 76.7447
R6654 VSS.n2808 VSS.n2366 76.7447
R6655 VSS.n576 VSS.t1839 76.7344
R6656 VSS.t1613 VSS.n1041 76.7344
R6657 VSS.n121 VSS.t1073 76.7344
R6658 VSS.t1174 VSS.n2186 75.4357
R6659 VSS.n1198 VSS.t2163 75.2962
R6660 VSS.t181 VSS.n1624 75.0671
R6661 VSS.n1200 VSS.t1310 74.9537
R6662 VSS.t1825 VSS.n259 74.8587
R6663 VSS.t2052 VSS.n1289 74.8585
R6664 VSS.t1848 VSS.n174 74.8579
R6665 VSS.n118 VSS.t2066 74.8578
R6666 VSS.t1445 VSS.n3028 74.8578
R6667 VSS.t2308 VSS.n2832 74.7824
R6668 VSS.t1998 VSS.n1622 74.6738
R6669 VSS.t2274 VSS.n746 73.9682
R6670 VSS.n576 VSS.t146 73.7831
R6671 VSS.t588 VSS.n1041 73.7831
R6672 VSS.n121 VSS.t1911 73.7831
R6673 VSS.t155 VSS.n2181 73.536
R6674 VSS.n2943 VSS.n2942 73.536
R6675 VSS.t2218 VSS.n2352 73.2563
R6676 VSS.n2764 VSS.t101 73.2563
R6677 VSS.n561 VSS.t2001 70.2346
R6678 VSS.n548 VSS.t732 70.2346
R6679 VSS.n535 VSS.t103 70.2346
R6680 VSS.n522 VSS.t1689 70.2346
R6681 VSS.n509 VSS.t2008 70.2346
R6682 VSS.n497 VSS.t1691 70.2346
R6683 VSS.n483 VSS.t2014 70.2346
R6684 VSS.n470 VSS.t1284 70.2346
R6685 VSS.n457 VSS.t2003 70.2346
R6686 VSS.n443 VSS.t1687 70.2346
R6687 VSS.n430 VSS.t2006 70.2346
R6688 VSS.n415 VSS.t1693 70.2346
R6689 VSS.n400 VSS.t2017 70.2346
R6690 VSS.n386 VSS.t1286 70.2346
R6691 VSS.n372 VSS.t974 70.2346
R6692 VSS.n359 VSS.t729 70.2346
R6693 VSS.t1507 VSS.n854 70.2346
R6694 VSS.t962 VSS.n861 70.2346
R6695 VSS.t1917 VSS.n868 70.2346
R6696 VSS.t1731 VSS.n875 70.2346
R6697 VSS.t1515 VSS.n882 70.2346
R6698 VSS.t1733 VSS.n889 70.2346
R6699 VSS.t2021 VSS.n896 70.2346
R6700 VSS.t1737 VSS.n903 70.2346
R6701 VSS.t1510 VSS.n910 70.2346
R6702 VSS.n917 VSS.t1729 70.2346
R6703 VSS.n924 VSS.t1512 70.2346
R6704 VSS.t1735 VSS.n931 70.2346
R6705 VSS.t2024 VSS.n939 70.2346
R6706 VSS.t1739 VSS.n947 70.2346
R6707 VSS.n954 VSS.t1919 70.2346
R6708 VSS.n961 VSS.t959 70.2346
R6709 VSS.n3035 VSS.t1709 70.2346
R6710 VSS.t1432 VSS.n3042 70.2346
R6711 VSS.t2255 VSS.n3051 70.2346
R6712 VSS.t2121 VSS.n3059 70.2346
R6713 VSS.t1711 VSS.n3066 70.2346
R6714 VSS.t1877 VSS.n3075 70.2346
R6715 VSS.t1117 VSS.n3083 70.2346
R6716 VSS.t1881 VSS.n3090 70.2346
R6717 VSS.t1113 VSS.n3100 70.2346
R6718 VSS.t2119 VSS.n3108 70.2346
R6719 VSS.t1714 VSS.n3115 70.2346
R6720 VSS.t1879 VSS.n3124 70.2346
R6721 VSS.t1120 VSS.n3134 70.2346
R6722 VSS.t1883 VSS.n3142 70.2346
R6723 VSS.t2253 VSS.n3151 70.2346
R6724 VSS.t1390 VSS.n3159 70.2346
R6725 VSS.t2029 VSS.n1676 70.2346
R6726 VSS.t7 VSS.n1692 70.2346
R6727 VSS.t1725 VSS.n1708 70.2346
R6728 VSS.t1654 VSS.n1724 70.2346
R6729 VSS.t2038 VSS.n1740 70.2346
R6730 VSS.t1657 VSS.n1756 70.2346
R6731 VSS.t2045 VSS.n1773 70.2346
R6732 VSS.t1556 VSS.n1790 70.2346
R6733 VSS.t2032 VSS.n1806 70.2346
R6734 VSS.t1651 VSS.n1822 70.2346
R6735 VSS.t2035 VSS.n1838 70.2346
R6736 VSS.t1639 VSS.n1854 70.2346
R6737 VSS.t2026 VSS.n1870 70.2346
R6738 VSS.t1559 VSS.n1888 70.2346
R6739 VSS.t1722 VSS.n1904 70.2346
R6740 VSS.t10 VSS.n1920 70.2346
R6741 VSS.t1647 VSS.n1300 70.2346
R6742 VSS.t1748 VSS.n1316 70.2346
R6743 VSS.t913 VSS.n1331 70.2346
R6744 VSS.t661 VSS.n1347 70.2346
R6745 VSS.t1706 VSS.n1363 70.2346
R6746 VSS.t663 VSS.n1380 70.2346
R6747 VSS.t1617 VSS.n1396 70.2346
R6748 VSS.t606 VSS.n1412 70.2346
R6749 VSS.t2378 VSS.n1429 70.2346
R6750 VSS.t659 VSS.n1445 70.2346
R6751 VSS.t2109 VSS.n1460 70.2346
R6752 VSS.t666 VSS.n1476 70.2346
R6753 VSS.t1101 VSS.n1493 70.2346
R6754 VSS.t609 VSS.n1509 70.2346
R6755 VSS.t2106 VSS.n1526 70.2346
R6756 VSS.t1202 VSS.n1541 70.2346
R6757 VSS.n2940 VSS.n78 6.23647
R6758 VSS.t2307 VSS.n2350 69.7679
R6759 VSS.n2781 VSS.t1181 69.7679
R6760 VSS.t1274 VSS.n2278 69.1047
R6761 VSS.t695 VSS.n2874 68.9334
R6762 VSS.n646 VSS.t463 68.211
R6763 VSS.t402 VSS.n591 68.21
R6764 VSS.t414 VSS.n600 68.21
R6765 VSS.t426 VSS.n608 68.21
R6766 VSS.t438 VSS.n618 68.21
R6767 VSS.t450 VSS.n627 68.21
R6768 VSS.n2878 VSS.t1094 67.4615
R6769 VSS.t1310 VSS.n1199 67.4583
R6770 VSS.n1623 VSS.t1998 67.2065
R6771 VSS.n2303 VSS.t137 66.9109
R6772 VSS.n559 VSS.t1933 66.8901
R6773 VSS.n558 VSS.t1592 66.8901
R6774 VSS.t1953 VSS.n546 66.8901
R6775 VSS.n545 VSS.t2293 66.8901
R6776 VSS.n533 VSS.t1325 66.8901
R6777 VSS.n532 VSS.t2305 66.8901
R6778 VSS.n520 VSS.t1902 66.8901
R6779 VSS.n519 VSS.t1045 66.8901
R6780 VSS.t1399 VSS.n507 66.8901
R6781 VSS.n506 VSS.t1596 66.8901
R6782 VSS.n495 VSS.t1250 66.8901
R6783 VSS.n494 VSS.t1148 66.8901
R6784 VSS.n481 VSS.t638 66.8901
R6785 VSS.n480 VSS.t2210 66.8901
R6786 VSS.t1212 VSS.n468 66.8901
R6787 VSS.n467 VSS.t1332 66.8901
R6788 VSS.t2337 VSS.n454 66.8901
R6789 VSS.n453 VSS.t873 66.8901
R6790 VSS.n441 VSS.t1214 66.8901
R6791 VSS.n440 VSS.t1873 66.8901
R6792 VSS.t82 VSS.n427 66.8901
R6793 VSS.n426 VSS.t2233 66.8901
R6794 VSS.t779 VSS.n412 66.8901
R6795 VSS.n411 VSS.t2282 66.8901
R6796 VSS.t1429 VSS.n398 66.8901
R6797 VSS.n395 VSS.t1224 66.8901
R6798 VSS.t1437 VSS.n383 66.8901
R6799 VSS.n382 VSS.t1172 66.8901
R6800 VSS.n370 VSS.t1440 66.8901
R6801 VSS.n369 VSS.t850 66.8901
R6802 VSS.t1990 VSS.n356 66.8901
R6803 VSS.n355 VSS.t1260 66.8901
R6804 VSS.n855 VSS.t756 66.8901
R6805 VSS.n1032 VSS.t1756 66.8901
R6806 VSS.n862 VSS.t1168 66.8901
R6807 VSS.n1028 VSS.t1793 66.8901
R6808 VSS.n869 VSS.t2213 66.8901
R6809 VSS.n1024 VSS.t1777 66.8901
R6810 VSS.t1607 VSS.n876 66.8901
R6811 VSS.n1020 VSS.t1852 66.8901
R6812 VSS.n883 VSS.t166 66.8901
R6813 VSS.n1016 VSS.t1757 66.8901
R6814 VSS.n890 VSS.t686 66.8901
R6815 VSS.n1012 VSS.t1851 66.8901
R6816 VSS.t1164 VSS.n897 66.8901
R6817 VSS.n1007 VSS.t1379 66.8901
R6818 VSS.t1339 VSS.n904 66.8901
R6819 VSS.n1003 VSS.t1772 66.8901
R6820 VSS.n911 VSS.t2278 66.8901
R6821 VSS.n999 VSS.t1811 66.8901
R6822 VSS.t857 VSS.n918 66.8901
R6823 VSS.n995 VSS.t1758 66.8901
R6824 VSS.t1321 VSS.n925 66.8901
R6825 VSS.n991 VSS.t1802 66.8901
R6826 VSS.t768 VSS.n932 66.8901
R6827 VSS.n987 VSS.t1813 66.8901
R6828 VSS.t1561 VSS.n940 66.8901
R6829 VSS.n983 VSS.t1809 66.8901
R6830 VSS.n948 VSS.t1363 66.8901
R6831 VSS.n979 VSS.t1779 66.8901
R6832 VSS.t1620 VSS.n955 66.8901
R6833 VSS.n975 VSS.t1886 66.8901
R6834 VSS.t2312 VSS.n962 66.8901
R6835 VSS.n971 VSS.t1884 66.8901
R6836 VSS.t765 VSS.n3036 66.8901
R6837 VSS.n3306 VSS.t37 66.8901
R6838 VSS.t87 VSS.n3043 66.8901
R6839 VSS.n3297 VSS.t2298 66.8901
R6840 VSS.t866 VSS.n3052 66.8901
R6841 VSS.n3290 VSS.t801 66.8901
R6842 VSS.t1601 VSS.n3060 66.8901
R6843 VSS.n3282 VSS.t1818 66.8901
R6844 VSS.t612 VSS.n3067 66.8901
R6845 VSS.n3273 VSS.t132 66.8901
R6846 VSS.t1263 VSS.n3076 66.8901
R6847 VSS.n3266 VSS.t177 66.8901
R6848 VSS.t2351 VSS.n3084 66.8901
R6849 VSS.n3257 VSS.t2208 66.8901
R6850 VSS.t1020 VSS.n3092 66.8901
R6851 VSS.n3249 VSS.t1625 66.8901
R6852 VSS.t1586 VSS.n3101 66.8901
R6853 VSS.n3242 VSS.t1150 66.8901
R6854 VSS.t908 VSS.n3109 66.8901
R6855 VSS.n3234 VSS.t1822 66.8901
R6856 VSS.t2288 VSS.n3117 66.8901
R6857 VSS.n3226 VSS.t1017 66.8901
R6858 VSS.n3126 VSS.t15 66.8901
R6859 VSS.n3219 VSS.t626 66.8901
R6860 VSS.t168 VSS.n3135 66.8901
R6861 VSS.n3211 VSS.t470 66.8901
R6862 VSS.t1024 VSS.n3144 66.8901
R6863 VSS.n3203 VSS.t619 66.8901
R6864 VSS.n3153 VSS.t173 66.8901
R6865 VSS.n3196 VSS.t800 66.8901
R6866 VSS.t1358 VSS.n3160 66.8901
R6867 VSS.n3187 VSS.t2299 66.8901
R6868 VSS.t1931 VSS.n1680 66.8901
R6869 VSS.t2063 VSS.n1681 66.8901
R6870 VSS.t2131 VSS.n1696 66.8901
R6871 VSS.t2061 VSS.n1697 66.8901
R6872 VSS.t1940 VSS.n1712 66.8901
R6873 VSS.t2056 VSS.n1713 66.8901
R6874 VSS.t1317 VSS.n1728 66.8901
R6875 VSS.t2072 VSS.n1729 66.8901
R6876 VSS.t590 VSS.n1744 66.8901
R6877 VSS.t2089 VSS.n1745 66.8901
R6878 VSS.t1957 VSS.n1760 66.8901
R6879 VSS.t2075 VSS.n1761 66.8901
R6880 VSS.t1968 VSS.n1778 66.8901
R6881 VSS.t2080 VSS.n1779 66.8901
R6882 VSS.t840 VSS.n1794 66.8901
R6883 VSS.t2079 VSS.n1795 66.8901
R6884 VSS.t844 VSS.n1810 66.8901
R6885 VSS.t2078 VSS.n1811 66.8901
R6886 VSS.t1405 VSS.n1826 66.8901
R6887 VSS.t2074 VSS.n1827 66.8901
R6888 VSS.t1066 VSS.n1842 66.8901
R6889 VSS.t2090 VSS.n1843 66.8901
R6890 VSS.t1522 VSS.n1858 66.8901
R6891 VSS.t2345 VSS.n1859 66.8901
R6892 VSS.t2336 VSS.n1874 66.8901
R6893 VSS.t2100 VSS.n1876 66.8901
R6894 VSS.t1300 VSS.n1892 66.8901
R6895 VSS.t2092 VSS.n1893 66.8901
R6896 VSS.t939 VSS.n1908 66.8901
R6897 VSS.t2091 VSS.n1909 66.8901
R6898 VSS.t1907 VSS.n1924 66.8901
R6899 VSS.t2099 VSS.n1925 66.8901
R6900 VSS.n1303 VSS.t880 66.8901
R6901 VSS.t2060 VSS.n1304 66.8901
R6902 VSS.n1319 VSS.t1800 66.8901
R6903 VSS.t2057 VSS.n1320 66.8901
R6904 VSS.n1335 VSS.t2175 66.8901
R6905 VSS.t2047 VSS.n1336 66.8901
R6906 VSS.n1351 VSS.t1843 66.8901
R6907 VSS.t1920 VSS.n1352 66.8901
R6908 VSS.n1367 VSS.t671 66.8901
R6909 VSS.t1965 VSS.n1368 66.8901
R6910 VSS.n1383 VSS.t675 66.8901
R6911 VSS.t1960 VSS.n1384 66.8901
R6912 VSS.n1400 VSS.t1375 66.8901
R6913 VSS.t1950 VSS.n1401 66.8901
R6914 VSS.n1416 VSS.t577 66.8901
R6915 VSS.t1943 VSS.n1417 66.8901
R6916 VSS.n1432 VSS.t1459 66.8901
R6917 VSS.t1938 VSS.n1433 66.8901
R6918 VSS.n1448 VSS.t1294 66.8901
R6919 VSS.t1927 VSS.n1449 66.8901
R6920 VSS.n1464 VSS.t2145 66.8901
R6921 VSS.t2058 VSS.n1465 66.8901
R6922 VSS.n1480 VSS.t2239 66.8901
R6923 VSS.t1977 VSS.n1481 66.8901
R6924 VSS.n1584 VSS.t2316 66.8901
R6925 VSS.t2049 VSS.n1496 66.8901
R6926 VSS.n1513 VSS.t69 66.8901
R6927 VSS.t2064 VSS.n1514 66.8901
R6928 VSS.n1529 VSS.t2324 66.8901
R6929 VSS.t1994 VSS.n1530 66.8901
R6930 VSS.n1545 VSS.t2327 66.8901
R6931 VSS.t1991 VSS.n1546 66.8901
R6932 VSS.t309 VSS.n1069 65.1012
R6933 VSS.t316 VSS.n1074 65.1012
R6934 VSS.t323 VSS.n1079 65.1012
R6935 VSS.t330 VSS.n1089 65.1012
R6936 VSS.t337 VSS.n1094 65.1012
R6937 VSS.t192 VSS.n1221 65.1012
R6938 VSS.t199 VSS.n1226 65.1012
R6939 VSS.t206 VSS.n1231 65.1012
R6940 VSS.t213 VSS.n1241 65.1012
R6941 VSS.t220 VSS.n1246 65.1012
R6942 VSS.t355 VSS.n768 65.1012
R6943 VSS.t362 VSS.n773 65.1012
R6944 VSS.t369 VSS.n778 65.1012
R6945 VSS.t376 VSS.n788 65.1012
R6946 VSS.t383 VSS.n793 65.1012
R6947 VSS.t1353 VSS.n1082 65.0816
R6948 VSS.t2148 VSS.n1234 65.0816
R6949 VSS.t2228 VSS.n781 65.0816
R6950 VSS.t617 VSS.n249 64.9292
R6951 VSS.t2284 VSS.n800 64.9292
R6952 VSS.t760 VSS.n123 64.9292
R6953 VSS.t349 VSS.n3177 64.5832
R6954 VSS.t231 VSS.n1561 64.5832
R6955 VSS.t242 VSS.n2841 64.5832
R6956 VSS.n3327 VSS.t394 64.5832
R6957 VSS.n2796 VSS.n2355 64.0227
R6958 VSS.n2792 VSS.n2377 63.9058
R6959 VSS.n1195 VSS.t865 63.7107
R6960 VSS.t1761 VSS.n1627 63.4728
R6961 VSS.n2754 VSS.n2339 62.9376
R6962 VSS.n2757 VSS.n2338 62.9376
R6963 VSS.n2799 VSS.n2370 62.7912
R6964 VSS.n2799 VSS.t254 62.7912
R6965 VSS.n1193 VSS.t1573 62.4441
R6966 VSS.t1753 VSS.n1629 62.2523
R6967 VSS.n758 VSS.t1775 61.9779
R6968 VSS.n1058 VSS.t1796 61.9779
R6969 VSS.n1657 VSS.t2344 61.9779
R6970 VSS.n744 VSS.t1495 61.8407
R6971 VSS.n2943 VSS.n2179 59.3547
R6972 VSS.n2768 VSS.t160 59.3028
R6973 VSS.t245 VSS.t95 59.3028
R6974 VSS.t631 VSS.n2363 59.3028
R6975 VSS.t1786 VSS.n246 59.0266
R6976 VSS.t1461 VSS.n798 59.0266
R6977 VSS.t1996 VSS.n125 59.0266
R6978 VSS.t1351 VSS.n1191 58.6964
R6979 VSS.n1631 VSS.t1804 58.5186
R6980 VSS.t1270 VSS.n74 58.1358
R6981 VSS.n2833 VSS.t2308 58.1084
R6982 VSS.t1027 VSS.n2950 58.0281
R6983 VSS.t933 VSS.n1123 57.6388
R6984 VSS.t1266 VSS.n1084 57.6388
R6985 VSS.t2155 VSS.n1276 57.6388
R6986 VSS.t2129 VSS.n1236 57.6388
R6987 VSS.t924 VSS.n3359 57.6388
R6988 VSS.t2122 VSS.n783 57.6388
R6989 VSS.n585 VSS.t615 57.5509
R6990 VSS.n1134 VSS.t2283 57.5509
R6991 VSS.n1286 VSS.t758 57.5509
R6992 VSS.n684 VSS.t2374 56.6724
R6993 VSS.t406 VSS.n713 56.0825
R6994 VSS.t418 VSS.n700 56.0825
R6995 VSS.t431 VSS.n678 56.0825
R6996 VSS.t442 VSS.n665 56.0825
R6997 VSS.t454 VSS.n630 56.0825
R6998 VSS.n648 VSS.t467 56.0825
R6999 VSS.t1267 VSS.n2270 55.942
R7000 VSS.t1233 VSS.t185 55.8145
R7001 VSS.t1077 VSS.t1313 55.8145
R7002 VSS.n3025 VSS.t2295 54.6841
R7003 VSS.t615 VSS.n242 54.5996
R7004 VSS.n3323 VSS.t2283 54.5996
R7005 VSS.t758 VSS.n1204 54.5996
R7006 VSS.t26 VSS.n1619 54.532
R7007 VSS.t510 VSS.n70 53.7482
R7008 VSS.n3022 VSS.t694 53.4875
R7009 VSS.n581 VSS.t1786 53.124
R7010 VSS.n1046 VSS.t1461 53.124
R7011 VSS.n124 VSS.t1996 53.124
R7012 VSS.n2832 VSS.t1176 52.3478
R7013 VSS.t1083 VSS.n2375 52.3261
R7014 VSS.t696 VSS.n2879 51.4837
R7015 VSS.n2983 VSS.n2151 51.0224
R7016 VSS.n3005 VSS.n3004 51.0224
R7017 VSS.n2745 VSS.n2744 50.7482
R7018 VSS.n2743 VSS.n2400 50.7482
R7019 VSS.n2742 VSS.n2741 50.7482
R7020 VSS.n2740 VSS.n2401 50.7482
R7021 VSS.n2739 VSS.n2738 50.7482
R7022 VSS.n2737 VSS.n2402 50.7482
R7023 VSS.n2736 VSS.n2735 50.7482
R7024 VSS.n2733 VSS.n2732 50.7482
R7025 VSS.n2726 VSS.n2405 50.7482
R7026 VSS.n2725 VSS.n2724 50.7482
R7027 VSS.n2723 VSS.n2408 50.7482
R7028 VSS.n2722 VSS.n2721 50.7482
R7029 VSS.n2720 VSS.n2409 50.7482
R7030 VSS.n2719 VSS.n2718 50.7482
R7031 VSS.n2717 VSS.n2410 50.7482
R7032 VSS.n2716 VSS.n2715 50.7482
R7033 VSS.n2714 VSS.n2411 50.7482
R7034 VSS.n2711 VSS.n2412 50.7482
R7035 VSS.n2710 VSS.n2709 50.7482
R7036 VSS.n2707 VSS.n2706 50.7482
R7037 VSS.n2705 VSS.n2414 50.7482
R7038 VSS.n2422 VSS.n2421 50.7482
R7039 VSS.n2420 VSS.n2415 50.7482
R7040 VSS.n2419 VSS.n2418 50.7482
R7041 VSS.n2703 VSS.n2702 50.7482
R7042 VSS.n2700 VSS.n2699 50.7482
R7043 VSS.n2698 VSS.n2424 50.7482
R7044 VSS.n2697 VSS.n2696 50.7482
R7045 VSS.n2685 VSS.n2684 50.7482
R7046 VSS.n2687 VSS.n2686 50.7482
R7047 VSS.n2689 VSS.n2688 50.7482
R7048 VSS.n2691 VSS.n2690 50.7482
R7049 VSS.n2682 VSS.n2681 50.7482
R7050 VSS.n2680 VSS.n2429 50.7482
R7051 VSS.n2679 VSS.n2678 50.7482
R7052 VSS.n2676 VSS.n2675 50.7482
R7053 VSS.n2674 VSS.n2431 50.7482
R7054 VSS.n2673 VSS.n2672 50.7482
R7055 VSS.n2434 VSS.n2433 50.7482
R7056 VSS.n2668 VSS.t277 50.7482
R7057 VSS.n2667 VSS.n2436 50.7482
R7058 VSS.n2666 VSS.n2665 50.7482
R7059 VSS.n2663 VSS.n2662 50.7482
R7060 VSS.n2661 VSS.n2438 50.7482
R7061 VSS.n2660 VSS.n2659 50.7482
R7062 VSS.n2658 VSS.n2439 50.7482
R7063 VSS.n2657 VSS.n2656 50.7482
R7064 VSS.n2655 VSS.n2440 50.7482
R7065 VSS.n2652 VSS.n2441 50.7482
R7066 VSS.n2651 VSS.n2650 50.7482
R7067 VSS.n2648 VSS.n2647 50.7482
R7068 VSS.n2646 VSS.n2443 50.7482
R7069 VSS.n2452 VSS.n2451 50.7482
R7070 VSS.n2450 VSS.n2444 50.7482
R7071 VSS.n2447 VSS.n2445 50.7482
R7072 VSS.n2644 VSS.n2643 50.7482
R7073 VSS.n2641 VSS.n2640 50.7482
R7074 VSS.n2639 VSS.n2454 50.7482
R7075 VSS.n2638 VSS.n2637 50.7482
R7076 VSS.n2626 VSS.n2625 50.7482
R7077 VSS.n2628 VSS.n2627 50.7482
R7078 VSS.n2630 VSS.n2629 50.7482
R7079 VSS.n2632 VSS.n2631 50.7482
R7080 VSS.n2623 VSS.n2622 50.7482
R7081 VSS.n2621 VSS.n2459 50.7482
R7082 VSS.n2620 VSS.n2619 50.7482
R7083 VSS.n2617 VSS.n2616 50.7482
R7084 VSS.n2615 VSS.n2461 50.7482
R7085 VSS.n2612 VSS.n2611 50.7482
R7086 VSS.n2464 VSS.n2463 50.7482
R7087 VSS.n2609 VSS.t289 50.7482
R7088 VSS.n2608 VSS.n2465 50.7482
R7089 VSS.n2607 VSS.n2606 50.7482
R7090 VSS.n2604 VSS.n2603 50.7482
R7091 VSS.n2602 VSS.n2601 50.7482
R7092 VSS.n2600 VSS.n2599 50.7482
R7093 VSS.n2598 VSS.n2597 50.7482
R7094 VSS.n2596 VSS.n2595 50.7482
R7095 VSS.n2594 VSS.n2593 50.7482
R7096 VSS.n2590 VSS.n2589 50.7482
R7097 VSS.n2588 VSS.n2587 50.7482
R7098 VSS.n2584 VSS.n2583 50.7482
R7099 VSS.n2582 VSS.n2581 50.7482
R7100 VSS.n2580 VSS.n2475 50.7482
R7101 VSS.n2472 VSS.n2471 50.7482
R7102 VSS.n2470 VSS.n2468 50.7482
R7103 VSS.n2482 VSS.n2481 50.7482
R7104 VSS.n2486 VSS.n2485 50.7482
R7105 VSS.n2488 VSS.n2487 50.7482
R7106 VSS.n2490 VSS.n2489 50.7482
R7107 VSS.n2494 VSS.n2493 50.7482
R7108 VSS.n2480 VSS.n2479 50.7482
R7109 VSS.n2577 VSS.n2576 50.7482
R7110 VSS.n2575 VSS.n2574 50.7482
R7111 VSS.n2504 VSS.n2503 50.7482
R7112 VSS.n2502 VSS.n2500 50.7482
R7113 VSS.n2507 VSS.n2506 50.7482
R7114 VSS.n2510 VSS.n2509 50.7482
R7115 VSS.n2572 VSS.n2571 50.7482
R7116 VSS.n2570 VSS.n2569 50.7482
R7117 VSS.n2568 VSS.n2567 50.7482
R7118 VSS.t302 VSS.n2566 50.7482
R7119 VSS.n2565 VSS.n2564 50.7482
R7120 VSS.n2563 VSS.n2562 50.7482
R7121 VSS.n2559 VSS.n2558 50.7482
R7122 VSS.n2557 VSS.n2556 50.7482
R7123 VSS.n2555 VSS.n2554 50.7482
R7124 VSS.n2553 VSS.n2552 50.7482
R7125 VSS.n2551 VSS.n2550 50.7482
R7126 VSS.n2549 VSS.n2548 50.7482
R7127 VSS.n2545 VSS.n2544 50.7482
R7128 VSS.n2543 VSS.n2542 50.7482
R7129 VSS.n2539 VSS.n2538 50.7482
R7130 VSS.n2535 VSS.n2534 50.7482
R7131 VSS.n2533 VSS.n2532 50.7482
R7132 VSS.n2531 VSS.n2530 50.7482
R7133 VSS.n2529 VSS.n2528 50.7482
R7134 VSS.n2527 VSS.n2526 50.7482
R7135 VSS.n2525 VSS.n2524 50.7482
R7136 VSS.n2523 VSS.n2522 50.7482
R7137 VSS.n2521 VSS.n2520 50.7482
R7138 VSS.n2519 VSS.n2518 50.7482
R7139 VSS.n2517 VSS.n2516 50.7482
R7140 VSS.n2515 VSS.n2514 50.7482
R7141 VSS.t1624 VSS.n736 50.3244
R7142 VSS.n686 VSS.t853 50.3244
R7143 VSS.t1775 VSS.n578 50.1727
R7144 VSS.t1796 VSS.n1043 50.1727
R7145 VSS.t2344 VSS.n122 50.1727
R7146 VSS.n563 VSS.t2000 50.1677
R7147 VSS.n550 VSS.t731 50.1677
R7148 VSS.n536 VSS.t102 50.1677
R7149 VSS.n523 VSS.t1688 50.1677
R7150 VSS.n511 VSS.t2007 50.1677
R7151 VSS.n498 VSS.t1690 50.1677
R7152 VSS.n484 VSS.t2013 50.1677
R7153 VSS.n471 VSS.t1283 50.1677
R7154 VSS.n458 VSS.t2002 50.1677
R7155 VSS.n444 VSS.t1686 50.1677
R7156 VSS.n431 VSS.t2005 50.1677
R7157 VSS.n416 VSS.t1692 50.1677
R7158 VSS.n402 VSS.t2016 50.1677
R7159 VSS.n387 VSS.t1285 50.1677
R7160 VSS.n373 VSS.t973 50.1677
R7161 VSS.n360 VSS.t728 50.1677
R7162 VSS.n1033 VSS.t1506 50.1677
R7163 VSS.n1029 VSS.t961 50.1677
R7164 VSS.n1025 VSS.t1916 50.1677
R7165 VSS.n1021 VSS.t1730 50.1677
R7166 VSS.n1017 VSS.t1514 50.1677
R7167 VSS.n1013 VSS.t1732 50.1677
R7168 VSS.n1008 VSS.t2020 50.1677
R7169 VSS.n1004 VSS.t1736 50.1677
R7170 VSS.n1000 VSS.t1509 50.1677
R7171 VSS.n996 VSS.t1728 50.1677
R7172 VSS.n992 VSS.t1511 50.1677
R7173 VSS.n988 VSS.t1734 50.1677
R7174 VSS.n984 VSS.t2023 50.1677
R7175 VSS.n980 VSS.t1738 50.1677
R7176 VSS.n976 VSS.t1918 50.1677
R7177 VSS.n972 VSS.t958 50.1677
R7178 VSS.n3309 VSS.t1708 50.1677
R7179 VSS.n3301 VSS.t1431 50.1677
R7180 VSS.n3293 VSS.t2254 50.1677
R7181 VSS.n3286 VSS.t2120 50.1677
R7182 VSS.n3277 VSS.t1710 50.1677
R7183 VSS.n3269 VSS.t1876 50.1677
R7184 VSS.n3261 VSS.t1116 50.1677
R7185 VSS.n3252 VSS.t1880 50.1677
R7186 VSS.n3245 VSS.t1112 50.1677
R7187 VSS.n3238 VSS.t2118 50.1677
R7188 VSS.n3229 VSS.t1713 50.1677
R7189 VSS.n3221 VSS.t1878 50.1677
R7190 VSS.n3215 VSS.t1119 50.1677
R7191 VSS.n3206 VSS.t1882 50.1677
R7192 VSS.n3198 VSS.t2252 50.1677
R7193 VSS.n3191 VSS.t1389 50.1677
R7194 VSS.t2028 VSS.n114 50.1677
R7195 VSS.t6 VSS.n1689 50.1677
R7196 VSS.t1724 VSS.n1705 50.1677
R7197 VSS.t1653 VSS.n1722 50.1677
R7198 VSS.t2037 VSS.n1738 50.1677
R7199 VSS.t1656 VSS.n1754 50.1677
R7200 VSS.t2044 VSS.n1770 50.1677
R7201 VSS.t1555 VSS.n1788 50.1677
R7202 VSS.t2031 VSS.n1804 50.1677
R7203 VSS.t1650 VSS.n1820 50.1677
R7204 VSS.t2034 VSS.n1835 50.1677
R7205 VSS.t1638 VSS.n1852 50.1677
R7206 VSS.t2025 VSS.n1868 50.1677
R7207 VSS.t1558 VSS.n1885 50.1677
R7208 VSS.t1721 VSS.n1902 50.1677
R7209 VSS.t9 VSS.n1918 50.1677
R7210 VSS.t1646 VSS.n1297 50.1677
R7211 VSS.t1747 VSS.n1313 50.1677
R7212 VSS.t912 VSS.n1329 50.1677
R7213 VSS.t660 VSS.n1345 50.1677
R7214 VSS.t1705 VSS.n1361 50.1677
R7215 VSS.t662 VSS.n1377 50.1677
R7216 VSS.t1616 VSS.n1392 50.1677
R7217 VSS.t605 VSS.n1410 50.1677
R7218 VSS.t2377 VSS.n1426 50.1677
R7219 VSS.t658 VSS.n1442 50.1677
R7220 VSS.t2108 VSS.n1458 50.1677
R7221 VSS.t665 VSS.n1474 50.1677
R7222 VSS.t1100 VSS.n1490 50.1677
R7223 VSS.t608 VSS.n1507 50.1677
R7224 VSS.t2105 VSS.n1523 50.1677
R7225 VSS.t1201 VSS.n1539 50.1677
R7226 VSS.n2873 VSS.t627 50.0128
R7227 VSS.t763 VSS.n2398 50.0128
R7228 VSS.n2537 VSS.t817 50.0128
R7229 VSS.n2786 VSS.n2353 49.9524
R7230 VSS.n2786 VSS.n2375 49.9524
R7231 VSS.n2282 VSS.t513 49.3606
R7232 VSS.n2757 VSS.t129 48.9515
R7233 VSS.t1315 VSS.n2354 48.8377
R7234 VSS.n2788 VSS.t2307 48.8377
R7235 VSS.t31 VSS.n2378 48.8377
R7236 VSS.n2769 VSS.n2341 48.8377
R7237 VSS.n2802 VSS.n2364 48.8377
R7238 VSS.t1781 VSS.n2869 48.5418
R7239 VSS.t813 VSS.n2473 47.8063
R7240 VSS.t1090 VSS.n1196 47.4535
R7241 VSS.n1626 VSS.t1817 47.3176
R7242 VSS.n580 VSS.t617 47.2214
R7243 VSS.n1129 VSS.t2284 47.2214
R7244 VSS.n1282 VSS.t760 47.2214
R7245 VSS.n2264 VSS.t136 47.1669
R7246 VSS.t138 VSS.n71 47.1669
R7247 VSS.t944 VSS.n2882 46.737
R7248 VSS.n2734 VSS.t926 46.3354
R7249 VSS.n2195 VSS.t155 46.116
R7250 VSS.n2868 VSS.t150 45.5999
R7251 VSS.t2141 VSS.n2878 45.3982
R7252 VSS.t2306 VSS.n2376 45.3493
R7253 VSS.t256 VSS.n2348 45.3493
R7254 VSS.n2810 VSS.t2214 45.3493
R7255 VSS.n2290 VSS.t1272 44.9731
R7256 VSS.n2683 VSS.t273 44.129
R7257 VSS.n2671 VSS.t807 44.129
R7258 VSS.n2624 VSS.t285 44.129
R7259 VSS.t298 VSS.n2496 44.129
R7260 VSS.n2874 VSS.t628 43.9263
R7261 VSS.t527 VSS.n2948 43.0649
R7262 VSS.t521 VSS.n2945 43.0619
R7263 VSS.t148 VSS.n2871 42.658
R7264 VSS.t1265 VSS.n2180 42.3769
R7265 VSS.n3021 VSS.t2139 42.222
R7266 VSS.t1232 VSS.n2389 41.9585
R7267 VSS.t1314 VSS.n2356 41.9585
R7268 VSS.n3023 VSS.t1582 41.9225
R7269 VSS.n2784 VSS.t1315 41.861
R7270 VSS.n2881 VSS.t1222 41.1871
R7271 VSS.t2170 VSS.n2404 41.1871
R7272 VSS.n1201 VSS.t1089 39.9582
R7273 VSS.t1816 VSS.n1621 39.8503
R7274 VSS.t271 VSS.n2425 38.9806
R7275 VSS.n2449 VSS.t809 38.9806
R7276 VSS.t283 VSS.n2455 38.9806
R7277 VSS.n2492 VSS.t296 38.9806
R7278 VSS.t1272 VSS.n2276 38.3917
R7279 VSS.t146 VSS.n252 38.3674
R7280 VSS.n1060 VSS.t588 38.3674
R7281 VSS.t1911 VSS.n1213 38.3674
R7282 VSS.t1092 VSS.n2876 38.2452
R7283 VSS.t2139 VSS.n3020 37.7839
R7284 VSS.n2886 VSS.n2885 37.5097
R7285 VSS.t2140 VSS.n2870 37.0756
R7286 VSS.n565 VSS.t629 36.7898
R7287 VSS.n552 VSS.t1894 36.7898
R7288 VSS.t1395 VSS.n538 36.7898
R7289 VSS.n525 VSS.t1205 36.7898
R7290 VSS.n513 VSS.t1401 36.7898
R7291 VSS.n500 VSS.t1065 36.7898
R7292 VSS.n486 VSS.t893 36.7898
R7293 VSS.t1416 VSS.n473 36.7898
R7294 VSS.t2250 VSS.n460 36.7898
R7295 VSS.n446 VSS.t595 36.7898
R7296 VSS.n433 VSS.t1529 36.7898
R7297 VSS.t601 VSS.n418 36.7898
R7298 VSS.t1530 VSS.n404 36.7898
R7299 VSS.t1984 VSS.n389 36.7898
R7300 VSS.n375 VSS.t1482 36.7898
R7301 VSS.n362 VSS.t2189 36.7898
R7302 VSS.n850 VSS.t1759 36.7898
R7303 VSS.n858 VSS.t871 36.7898
R7304 VSS.n865 VSS.t21 36.7898
R7305 VSS.n872 VSS.t1347 36.7898
R7306 VSS.n879 VSS.t60 36.7898
R7307 VSS.n886 VSS.t485 36.7898
R7308 VSS.n893 VSS.t2222 36.7898
R7309 VSS.n900 VSS.t1087 36.7898
R7310 VSS.t654 VSS.n907 36.7898
R7311 VSS.n914 VSS.t1344 36.7898
R7312 VSS.t1575 VSS.n921 36.7898
R7313 VSS.t682 VSS.n928 36.7898
R7314 VSS.t2221 VSS.n935 36.7898
R7315 VSS.t1350 VSS.n944 36.7898
R7316 VSS.n951 VSS.t39 36.7898
R7317 VSS.t1815 VSS.n958 36.7898
R7318 VSS.n3031 VSS.t139 36.7898
R7319 VSS.t44 VSS.n3039 36.7898
R7320 VSS.t99 VSS.n3047 36.7898
R7321 VSS.n3056 VSS.t1144 36.7898
R7322 VSS.t2169 VSS.n3063 36.7898
R7323 VSS.t1819 VSS.n3071 36.7898
R7324 VSS.n3080 VSS.t752 36.7898
R7325 VSS.t62 VSS.n3087 36.7898
R7326 VSS.t1031 VSS.n3096 36.7898
R7327 VSS.n3105 VSS.t141 36.7898
R7328 VSS.t650 VSS.n3112 36.7898
R7329 VSS.t689 VSS.n3120 36.7898
R7330 VSS.n3130 VSS.t1490 36.7898
R7331 VSS.t1279 VSS.n3139 36.7898
R7332 VSS.t2291 VSS.n3147 36.7898
R7333 VSS.t2276 VSS.n3156 36.7898
R7334 VSS.t2055 VSS.n1642 36.7898
R7335 VSS.t1925 VSS.n1688 36.7898
R7336 VSS.t1393 VSS.n1704 36.7898
R7337 VSS.t1946 VSS.n1721 36.7898
R7338 VSS.t1516 VSS.n1737 36.7898
R7339 VSS.t1963 VSS.n1753 36.7898
R7340 VSS.t1904 VSS.n1769 36.7898
R7341 VSS.t1207 VSS.n1787 36.7898
R7342 VSS.t882 VSS.n1803 36.7898
R7343 VSS.t1970 VSS.n1819 36.7898
R7344 VSS.t2180 VSS.n1834 36.7898
R7345 VSS.t1072 VSS.n1851 36.7898
R7346 VSS.t1413 VSS.n1867 36.7898
R7347 VSS.t2333 VSS.n1884 36.7898
R7348 VSS.t1422 VSS.n1901 36.7898
R7349 VSS.t1974 VSS.n1917 36.7898
R7350 VSS.n1295 VSS.t2065 36.7898
R7351 VSS.n1312 VSS.t1049 36.7898
R7352 VSS.n1328 VSS.t2173 36.7898
R7353 VSS.n1344 VSS.t1238 36.7898
R7354 VSS.n1360 VSS.t1369 36.7898
R7355 VSS.n1376 VSS.t1454 36.7898
R7356 VSS.n1599 VSS.t2236 36.7898
R7357 VSS.n1409 VSS.t1372 36.7898
R7358 VSS.n1425 VSS.t1052 36.7898
R7359 VSS.n1441 VSS.t2142 36.7898
R7360 VSS.n1457 VSS.t1751 36.7898
R7361 VSS.n1473 VSS.t2146 36.7898
R7362 VSS.n1489 VSS.t2237 36.7898
R7363 VSS.n1506 VSS.t581 36.7898
R7364 VSS.n1522 VSS.t1056 36.7898
R7365 VSS.n1538 VSS.t2321 36.7898
R7366 VSS.n2876 VSS.t1583 36.7742
R7367 VSS.n2883 VSS.t944 36.4618
R7368 VSS.t1572 VSS.n1201 36.2105
R7369 VSS.n2898 VSS.t136 36.1979
R7370 VSS.n2300 VSS.t138 36.1979
R7371 VSS.n1621 VSS.t1752 36.1166
R7372 VSS.n2796 VSS.n2373 36.0019
R7373 VSS.n2792 VSS.n2351 35.9989
R7374 VSS.n2774 VSS.n2345 35.9989
R7375 VSS.n2882 VSS.t1223 35.702
R7376 VSS.t1839 VSS.n253 35.4161
R7377 VSS.n1061 VSS.t1613 35.4161
R7378 VSS.t1073 VSS.n1214 35.4161
R7379 VSS.n2713 VSS.t12 35.3033
R7380 VSS.n2664 VSS.t279 35.3033
R7381 VSS.n2654 VSS.t989 35.3033
R7382 VSS.t811 VSS.n2613 35.3033
R7383 VSS.n2605 VSS.t292 35.3033
R7384 VSS.t991 VSS.n2591 35.3033
R7385 VSS.n2561 VSS.t303 35.3033
R7386 VSS.t3 VSS.n2546 35.3033
R7387 VSS.n2884 VSS.n2883 35.2213
R7388 VSS.n2798 VSS.t1314 34.9655
R7389 VSS.t1862 VSS.n2382 34.8842
R7390 VSS.n2766 VSS.n2384 34.8842
R7391 VSS.n2772 VSS.n2343 34.8842
R7392 VSS.n2359 VSS.n2335 34.8842
R7393 VSS.n2360 VSS.n2333 34.8842
R7394 VSS.t1311 VSS.n1198 34.07
R7395 VSS.t513 VSS.n72 34.0042
R7396 VSS.n1624 VSS.t1999 33.9948
R7397 VSS.t1807 VSS.n2188 33.9067
R7398 VSS.t1223 VSS.n2881 33.8323
R7399 VSS.n2871 VSS.t2140 32.3614
R7400 VSS.n2701 VSS.t269 32.3614
R7401 VSS.n2642 VSS.t280 32.3614
R7402 VSS.t293 VSS.n2483 32.3614
R7403 VSS.n2764 VSS.t261 31.3958
R7404 VSS.t160 VSS.n2342 31.3958
R7405 VSS.t185 VSS.n2386 31.3958
R7406 VSS.t250 VSS.n2802 31.3958
R7407 VSS.t2217 VSS.n2365 31.3958
R7408 VSS.t1313 VSS.n2366 31.3958
R7409 VSS.t1041 VSS.n2181 31.1596
R7410 VSS.t922 VSS.n243 30.9892
R7411 VSS.t930 VSS.n1052 30.9892
R7412 VSS.t1152 VSS.n1205 30.9892
R7413 VSS.t13 VSS.n2413 30.8904
R7414 VSS.t990 VSS.n2442 30.8904
R7415 VSS.t992 VSS.n2585 30.8904
R7416 VSS.t4 VSS.n2540 30.8904
R7417 VSS.t805 VSS.n2416 30.1549
R7418 VSS.n2025 VSS.n1677 29.9901
R7419 VSS.n2032 VSS.n1693 29.9901
R7420 VSS.n2039 VSS.n1709 29.9901
R7421 VSS.n2046 VSS.n1725 29.9901
R7422 VSS.n2053 VSS.n1741 29.9901
R7423 VSS.n2060 VSS.n1757 29.9901
R7424 VSS.n2068 VSS.n1775 29.9901
R7425 VSS.n2075 VSS.n1791 29.9901
R7426 VSS.n2082 VSS.n1807 29.9901
R7427 VSS.n2089 VSS.n1823 29.9901
R7428 VSS.n2096 VSS.n1839 29.9901
R7429 VSS.n2103 VSS.n1855 29.9901
R7430 VSS.n2110 VSS.n1871 29.9901
R7431 VSS.n2117 VSS.n1889 29.9901
R7432 VSS.n2124 VSS.n1905 29.9901
R7433 VSS.n2131 VSS.n1921 29.9901
R7434 VSS.n1942 VSS.n1931 29.9901
R7435 VSS.t1583 VSS.n2875 29.6937
R7436 VSS.t1780 VSS.n2868 29.4195
R7437 VSS.n2774 VSS.t1862 29.0221
R7438 VSS.t694 VSS.n3021 28.9853
R7439 VSS.n1196 VSS.t863 28.7152
R7440 VSS.t2171 VSS.n2727 28.684
R7441 VSS.t1760 VSS.n1626 28.6493
R7442 VSS.n3024 VSS.n3023 28.3058
R7443 VSS.t1324 VSS.n534 28.2943
R7444 VSS.t1248 VSS.n496 28.2943
R7445 VSS.t777 VSS.n414 28.2943
R7446 VSS.t766 VSS.n1146 28.2943
R7447 VSS.n3284 VSS.t1600 28.2943
R7448 VSS.n3259 VSS.t2350 28.2943
R7449 VSS.n3244 VSS.t1584 28.2943
R7450 VSS.n3236 VSS.t910 28.2943
R7451 VSS.n3220 VSS.t17 28.2943
R7452 VSS.n3213 VSS.t170 28.2943
R7453 VSS.n3197 VSS.t175 28.2943
R7454 VSS.n3189 VSS.t1356 28.2943
R7455 VSS.t2338 VSS.n456 28.2941
R7456 VSS.t1216 VSS.n442 28.2941
R7457 VSS.t80 VSS.n429 28.2941
R7458 VSS.t1438 VSS.n385 28.2941
R7459 VSS.t1441 VSS.n371 28.2941
R7460 VSS.t1989 VSS.n358 28.2941
R7461 VSS.t1934 VSS.n560 28.2941
R7462 VSS.t1952 VSS.n270 28.2941
R7463 VSS.t1901 VSS.n521 28.2941
R7464 VSS.t1398 VSS.n285 28.2941
R7465 VSS.t636 VSS.n482 28.2941
R7466 VSS.t1211 VSS.n303 28.2941
R7467 VSS.t1430 VSS.n324 28.2941
R7468 VSS.n3299 VSS.t89 28.2941
R7469 VSS.n3292 VSS.t867 28.2941
R7470 VSS.n3275 VSS.t613 28.2941
R7471 VSS.n3268 VSS.t1264 28.2941
R7472 VSS.n3091 VSS.t1022 28.2941
R7473 VSS.n3116 VSS.t2289 28.2941
R7474 VSS.n3143 VSS.t1025 28.2941
R7475 VSS.n234 VSS.t754 28.2938
R7476 VSS.n230 VSS.t2211 28.2938
R7477 VSS.n227 VSS.t1606 28.2938
R7478 VSS.n222 VSS.t684 28.2938
R7479 VSS.n219 VSS.t1166 28.2938
R7480 VSS.n216 VSS.t1341 28.2938
R7481 VSS.n212 VSS.t2279 28.2938
R7482 VSS.t855 VSS.n165 28.2938
R7483 VSS.n202 VSS.t1563 28.2938
R7484 VSS.n198 VSS.t1361 28.2938
R7485 VSS.t1619 VSS.n171 28.2938
R7486 VSS.n231 VSS.t1170 28.2938
R7487 VSS.n223 VSS.t164 28.2938
R7488 VSS.t1323 VSS.n167 28.2938
R7489 VSS.t2311 VSS.n173 28.2938
R7490 VSS.n184 VSS.t767 28.2936
R7491 VSS.n1301 VSS.t878 28.2928
R7492 VSS.n1317 VSS.t1799 28.2928
R7493 VSS.n1333 VSS.t2174 28.2928
R7494 VSS.n1349 VSS.t1842 28.2928
R7495 VSS.n1365 VSS.t670 28.2928
R7496 VSS.n1381 VSS.t673 28.2928
R7497 VSS.n1398 VSS.t1374 28.2928
R7498 VSS.n1414 VSS.t575 28.2928
R7499 VSS.n1430 VSS.t1457 28.2928
R7500 VSS.n1446 VSS.t1292 28.2928
R7501 VSS.n1462 VSS.t2144 28.2928
R7502 VSS.n1478 VSS.t2240 28.2928
R7503 VSS.n1494 VSS.t2315 28.2928
R7504 VSS.n1511 VSS.t71 28.2928
R7505 VSS.n1527 VSS.t2323 28.2928
R7506 VSS.n1543 VSS.t2326 28.2928
R7507 VSS.n2877 VSS.t1092 28.2227
R7508 VSS.n174 VSS.t1610 28.0359
R7509 VSS.t1155 VSS.n118 28.0358
R7510 VSS.n259 VSS.t2136 28.0352
R7511 VSS.t29 VSS.n1289 28.035
R7512 VSS.n3028 VSS.t2297 28.035
R7513 VSS.t95 VSS.n2331 27.9075
R7514 VSS.t2270 VSS.n2951 27.7523
R7515 VSS.n2295 VSS.t1267 27.4228
R7516 VSS.n739 VSS.t1860 27.2918
R7517 VSS.t275 VSS.n2430 27.2131
R7518 VSS.t287 VSS.n2460 27.2131
R7519 VSS.t300 VSS.n2499 27.2131
R7520 VSS.n579 VSS.t906 26.5622
R7521 VSS.n1128 VSS.t741 26.5622
R7522 VSS.n1281 VSS.t1255 26.5622
R7523 VSS.n2869 VSS.t1780 26.4776
R7524 VSS.n2508 VSS.t815 26.4776
R7525 VSS.n754 VSS.n584 26.0918
R7526 VSS.n3364 VSS.n248 26.0918
R7527 VSS.n762 VSS.n254 26.0918
R7528 VSS.n755 VSS.n584 26.0918
R7529 VSS.n3366 VSS.n244 26.0918
R7530 VSS.n3363 VSS.n248 26.0918
R7531 VSS.n759 VSS.n577 26.0918
R7532 VSS.n759 VSS.n251 26.0918
R7533 VSS.n1131 VSS.n1049 26.0918
R7534 VSS.n1056 VSS.n799 26.0918
R7535 VSS.n1056 VSS.n1045 26.0918
R7536 VSS.n1063 VSS.n803 26.0918
R7537 VSS.n1133 VSS.n797 26.0918
R7538 VSS.n1133 VSS.n1050 26.0918
R7539 VSS.n1665 VSS.n1285 26.0918
R7540 VSS.n1660 VSS.n1210 26.0918
R7541 VSS.n1664 VSS.n1285 26.0918
R7542 VSS.n1662 VSS.n1206 26.0918
R7543 VSS.n1659 VSS.n1210 26.0918
R7544 VSS.n1656 VSS.n1280 26.0918
R7545 VSS.n1656 VSS.n1212 26.0918
R7546 VSS.n1649 VSS.n1278 26.0918
R7547 VSS.t1222 VSS.n2880 25.2808
R7548 VSS.n2272 VSS.t1270 25.229
R7549 VSS.t628 VSS.n2873 25.0066
R7550 VSS.t255 VSS.n2355 24.476
R7551 VSS.n2179 VSS.t153 24.4565
R7552 VSS.n2772 VSS.t2352 24.4191
R7553 VSS.n2752 VSS.t266 24.4191
R7554 VSS.t815 VSS.n2497 24.2712
R7555 VSS.n2872 VSS.t148 23.8099
R7556 VSS.n2879 VSS.t2141 23.5357
R7557 VSS.n2677 VSS.t275 23.5357
R7558 VSS.n2618 VSS.t287 23.5357
R7559 VSS.n2505 VSS.t300 23.5357
R7560 VSS.n1109 VSS.t1305 23.4405
R7561 VSS.n1262 VSS.t2132 23.4405
R7562 VSS.n3345 VSS.t2123 23.4405
R7563 VSS.n1107 VSS.t1354 23.4305
R7564 VSS.n1260 VSS.t2149 23.4305
R7565 VSS.n3343 VSS.t2229 23.4305
R7566 VSS.n2885 VSS.n2884 22.4784
R7567 VSS.n2196 VSS.t2347 22.3643
R7568 VSS.t1577 VSS.n682 22.1556
R7569 VSS.n685 VSS.t2375 22.1456
R7570 VSS.n2728 VSS.t2171 22.0647
R7571 VSS.n2790 VSS.n2349 22.0454
R7572 VSS.n2779 VSS.n2347 22.0454
R7573 VSS.n2807 VSS.n2367 22.0454
R7574 VSS.t560 VSS.n566 21.6054
R7575 VSS.n3310 VSS.t535 21.6054
R7576 VSS.t501 VSS.n117 21.605
R7577 VSS.n236 VSS.t547 21.6048
R7578 VSS.n1292 VSS.t490 21.6039
R7579 VSS.n2942 VSS.t624 21.1887
R7580 VSS.n2770 VSS.n2386 20.9307
R7581 VSS.n2848 VSS.n2337 20.9307
R7582 VSS.n2358 VSS.t1603 20.9307
R7583 VSS.n2815 VSS.n2363 20.9307
R7584 VSS.n2870 VSS.t1781 20.8932
R7585 VSS.t150 VSS.n2867 20.868
R7586 VSS.n582 VSS.t904 20.6596
R7587 VSS.n1130 VSS.t743 20.6596
R7588 VSS.n1283 VSS.t1256 20.6596
R7589 VSS.n2866 VSS.t1636 20.5938
R7590 VSS.n2417 VSS.t805 20.5938
R7591 VSS.t1895 VSS.n553 20.0674
R7592 VSS.t1396 VSS.n540 20.0674
R7593 VSS.t1204 VSS.n527 20.0674
R7594 VSS.t1403 VSS.n514 20.0674
R7595 VSS.t1064 VSS.n501 20.0674
R7596 VSS.t894 VSS.n489 20.0674
R7597 VSS.t1417 VSS.n475 20.0674
R7598 VSS.t2251 VSS.n462 20.0674
R7599 VSS.t597 VSS.n448 20.0674
R7600 VSS.t1528 VSS.n435 20.0674
R7601 VSS.t603 VSS.n421 20.0674
R7602 VSS.t1531 VSS.n406 20.0674
R7603 VSS.t1983 VSS.n391 20.0674
R7604 VSS.t1483 VSS.n377 20.0674
R7605 VSS.t2188 VSS.n364 20.0674
R7606 VSS.t1993 VSS.n350 20.0674
R7607 VSS.n1030 VSS.t869 20.0674
R7608 VSS.n1026 VSS.t19 20.0674
R7609 VSS.n1022 VSS.t1346 20.0674
R7610 VSS.n1018 VSS.t58 20.0674
R7611 VSS.n1014 VSS.t483 20.0674
R7612 VSS.n1010 VSS.t2223 20.0674
R7613 VSS.n1005 VSS.t1085 20.0674
R7614 VSS.n1001 VSS.t652 20.0674
R7615 VSS.n997 VSS.t1343 20.0674
R7616 VSS.n993 VSS.t1576 20.0674
R7617 VSS.n989 VSS.t681 20.0674
R7618 VSS.n985 VSS.t2220 20.0674
R7619 VSS.n981 VSS.t1349 20.0674
R7620 VSS.n977 VSS.t41 20.0674
R7621 VSS.n973 VSS.t1814 20.0674
R7622 VSS.n969 VSS.t2313 20.0674
R7623 VSS.n3304 VSS.t43 20.0674
R7624 VSS.n3295 VSS.t97 20.0674
R7625 VSS.n3288 VSS.t1146 20.0674
R7626 VSS.n3280 VSS.t2168 20.0674
R7627 VSS.n3271 VSS.t1820 20.0674
R7628 VSS.n3264 VSS.t750 20.0674
R7629 VSS.n3255 VSS.t64 20.0674
R7630 VSS.n3247 VSS.t1033 20.0674
R7631 VSS.n3240 VSS.t143 20.0674
R7632 VSS.n3232 VSS.t648 20.0674
R7633 VSS.n3224 VSS.t691 20.0674
R7634 VSS.n3217 VSS.t1491 20.0674
R7635 VSS.n3209 VSS.t1281 20.0674
R7636 VSS.n3201 VSS.t2292 20.0674
R7637 VSS.n3194 VSS.t2275 20.0674
R7638 VSS.n3185 VSS.t1180 20.0674
R7639 VSS.n2020 VSS.t1930 20.0674
R7640 VSS.n1685 VSS.t1923 20.0674
R7641 VSS.n2015 VSS.t2130 20.0674
R7642 VSS.n1701 VSS.t1391 20.0674
R7643 VSS.n2010 VSS.t1939 20.0674
R7644 VSS.n1717 VSS.t1945 20.0674
R7645 VSS.n2005 VSS.t1316 20.0674
R7646 VSS.n1733 VSS.t1517 20.0674
R7647 VSS.n2000 VSS.t592 20.0674
R7648 VSS.n1749 VSS.t1962 20.0674
R7649 VSS.n1995 VSS.t1956 20.0674
R7650 VSS.n1765 VSS.t1903 20.0674
R7651 VSS.n1989 VSS.t1967 20.0674
R7652 VSS.n1783 VSS.t1209 20.0674
R7653 VSS.n1984 VSS.t838 20.0674
R7654 VSS.n1799 VSS.t884 20.0674
R7655 VSS.n1979 VSS.t842 20.0674
R7656 VSS.n1815 VSS.t1971 20.0674
R7657 VSS.n1974 VSS.t1404 20.0674
R7658 VSS.n1831 VSS.t2179 20.0674
R7659 VSS.n1969 VSS.t1068 20.0674
R7660 VSS.n1847 VSS.t1070 20.0674
R7661 VSS.n1964 VSS.t1521 20.0674
R7662 VSS.n1863 VSS.t1415 20.0674
R7663 VSS.n1959 VSS.t2335 20.0674
R7664 VSS.n1880 VSS.t2334 20.0674
R7665 VSS.n1954 VSS.t1298 20.0674
R7666 VSS.n1897 VSS.t1424 20.0674
R7667 VSS.n1949 VSS.t938 20.0674
R7668 VSS.n1913 VSS.t1976 20.0674
R7669 VSS.n1944 VSS.t1906 20.0674
R7670 VSS.n1930 VSS.t1837 20.0674
R7671 VSS.n1309 VSS.t1047 20.0674
R7672 VSS.n1325 VSS.t2172 20.0674
R7673 VSS.n1341 VSS.t1239 20.0674
R7674 VSS.n1357 VSS.t1368 20.0674
R7675 VSS.n1373 VSS.t1453 20.0674
R7676 VSS.n1389 VSS.t2235 20.0674
R7677 VSS.n1406 VSS.t1371 20.0674
R7678 VSS.n1422 VSS.t1051 20.0674
R7679 VSS.n1438 VSS.t2143 20.0674
R7680 VSS.n1454 VSS.t1750 20.0674
R7681 VSS.n1470 VSS.t2147 20.0674
R7682 VSS.n1486 VSS.t2238 20.0674
R7683 VSS.n1503 VSS.t579 20.0674
R7684 VSS.n1519 VSS.t1054 20.0674
R7685 VSS.n1535 VSS.t2320 20.0674
R7686 VSS.n1550 VSS.t2325 20.0674
R7687 VSS.t1176 VSS.t1175 19.9423
R7688 VSS.n2708 VSS.t13 19.8583
R7689 VSS.n2649 VSS.t990 19.8583
R7690 VSS.n2586 VSS.t992 19.8583
R7691 VSS.n2541 VSS.t4 19.8583
R7692 VSS.n2867 VSS.t1582 19.397
R7693 VSS.n2886 VSS.n2866 18.3874
R7694 VSS.n2865 VSS.n2864 18.3874
R7695 VSS.t269 VSS.n2423 18.3874
R7696 VSS.t280 VSS.n2453 18.3874
R7697 VSS.n2484 VSS.t293 18.3874
R7698 VSS.n3023 VSS.n3022 18.1856
R7699 VSS.t1966 VSS.n275 18.0025
R7700 VSS.n288 VSS.t1519 18.0025
R7701 VSS.t2339 VSS.n309 18.0025
R7702 VSS.t1635 VSS.n332 18.0025
R7703 VSS.t23 VSS.n175 18.0025
R7704 VSS.t1578 VSS.n177 18.0025
R7705 VSS.t2383 VSS.n179 18.0025
R7706 VSS.t2156 VSS.n182 18.0025
R7707 VSS.t179 VSS.n183 18.0025
R7708 VSS.t1158 VSS.n187 18.0025
R7709 VSS.t2165 VSS.n188 18.0025
R7710 VSS.t943 VSS.n116 18.0023
R7711 VSS.n1391 VSS.t1377 18.0023
R7712 VSS.n1495 VSS.t583 18.0023
R7713 VSS.t1177 VSS.n262 18.0017
R7714 VSS.t1928 VSS.n265 18.0017
R7715 VSS.n268 VSS.t1955 18.0017
R7716 VSS.n547 VSS.t1948 18.0017
R7717 VSS.n539 VSS.t1944 18.0017
R7718 VSS.t76 VSS.n277 18.0017
R7719 VSS.t594 VSS.n280 18.0017
R7720 VSS.n283 VSS.t2243 18.0017
R7721 VSS.n508 VSS.t1470 18.0017
R7722 VSS.t895 VSS.n291 18.0017
R7723 VSS.t1410 VSS.n293 18.0017
R7724 VSS.t935 VSS.n298 18.0017
R7725 VSS.n474 VSS.t640 18.0017
R7726 VSS.n469 VSS.t79 18.0017
R7727 VSS.n461 VSS.t1421 18.0017
R7728 VSS.t1420 VSS.n455 18.0017
R7729 VSS.t2187 VSS.n312 18.0017
R7730 VSS.t1425 VSS.n314 18.0017
R7731 VSS.t1909 VSS.n428 18.0017
R7732 VSS.t1981 VSS.n419 18.0017
R7733 VSS.t1328 VSS.n413 18.0017
R7734 VSS.n405 VSS.t1986 18.0017
R7735 VSS.n399 VSS.t1985 18.0017
R7736 VSS.n390 VSS.t1439 18.0017
R7737 VSS.t1484 VSS.n384 18.0017
R7738 VSS.t1254 VSS.n335 18.0017
R7739 VSS.t1253 VSS.n337 18.0017
R7740 VSS.t2190 VSS.n357 18.0017
R7741 VSS.t1492 VSS.n153 18.0017
R7742 VSS.t1262 VSS.n154 18.0017
R7743 VSS.t2206 VSS.n155 18.0017
R7744 VSS.t1088 VSS.n156 18.0017
R7745 VSS.t693 VSS.n158 18.0017
R7746 VSS.t621 VSS.n226 18.0017
R7747 VSS.t1569 VSS.n159 18.0017
R7748 VSS.t1035 VSS.n160 18.0017
R7749 VSS.t680 VSS.n161 18.0017
R7750 VSS.t172 VSS.n163 18.0017
R7751 VSS.t1821 VSS.n218 18.0017
R7752 VSS.t647 VSS.n164 18.0017
R7753 VSS.t1841 VSS.n215 18.0017
R7754 VSS.t942 VSS.n213 18.0017
R7755 VSS.n209 VSS.t36 18.0017
R7756 VSS.t2207 VSS.n207 18.0017
R7757 VSS.n206 VSS.t2219 18.0017
R7758 VSS.n205 VSS.t1830 18.0017
R7759 VSS.n204 VSS.t622 18.0017
R7760 VSS.n203 VSS.t749 18.0017
R7761 VSS.t2203 VSS.n201 18.0017
R7762 VSS.t1157 VSS.n199 18.0017
R7763 VSS.n195 VSS.t1452 18.0017
R7764 VSS.t1498 VSS.n193 18.0017
R7765 VSS.n192 VSS.t1451 18.0017
R7766 VSS.n1294 VSS.t1782 18.0016
R7767 VSS.n1302 VSS.t1499 18.0016
R7768 VSS.n1311 VSS.t1803 18.0016
R7769 VSS.n1318 VSS.t1365 18.0016
R7770 VSS.n1327 VSS.t571 18.0016
R7771 VSS.n1334 VSS.t1184 18.0016
R7772 VSS.n1343 VSS.t2176 18.0016
R7773 VSS.n1350 VSS.t1503 18.0016
R7774 VSS.n1359 VSS.t572 18.0016
R7775 VSS.n1366 VSS.t1455 18.0016
R7776 VSS.n1375 VSS.t1241 18.0016
R7777 VSS.n1382 VSS.t1863 18.0016
R7778 VSS.n1399 VSS.t1456 18.0016
R7779 VSS.n1408 VSS.t1378 18.0016
R7780 VSS.n1415 VSS.t1187 18.0016
R7781 VSS.n1424 VSS.t709 18.0016
R7782 VSS.n1431 VSS.t1749 18.0016
R7783 VSS.n1440 VSS.t2348 18.0016
R7784 VSS.n1447 VSS.t1188 18.0016
R7785 VSS.n1456 VSS.t1196 18.0016
R7786 VSS.n1463 VSS.t740 18.0016
R7787 VSS.n1472 VSS.t2178 18.0016
R7788 VSS.n1479 VSS.t2317 18.0016
R7789 VSS.n1488 VSS.t2153 18.0016
R7790 VSS.n1505 VSS.t946 18.0016
R7791 VSS.n1512 VSS.t2241 18.0016
R7792 VSS.n1521 VSS.t774 18.0016
R7793 VSS.n1528 VSS.t73 18.0016
R7794 VSS.n1537 VSS.t584 18.0016
R7795 VSS.n1544 VSS.t1296 18.0016
R7796 VSS.n3307 VSS.t1084 18.0016
R7797 VSS.t469 VSS.n3302 18.0016
R7798 VSS.t2310 VSS.n3298 18.0016
R7799 VSS.n3294 VSS.t688 18.0016
R7800 VSS.t1494 VSS.n3291 18.0016
R7801 VSS.t1785 VSS.n3283 18.0016
R7802 VSS.t611 VSS.n3278 18.0016
R7803 VSS.t1360 VSS.n3274 18.0016
R7804 VSS.n3270 VSS.t2346 18.0016
R7805 VSS.t1831 VSS.n3267 18.0016
R7806 VSS.t917 VSS.n3258 18.0016
R7807 VSS.t2125 VSS.n3253 18.0016
R7808 VSS.n3250 VSS.t1808 18.0016
R7809 VSS.n3246 VSS.t1591 18.0016
R7810 VSS.t1028 VSS.n3243 18.0016
R7811 VSS.t2269 VSS.n3235 18.0016
R7812 VSS.t2302 VSS.n3230 18.0016
R7813 VSS.n3227 VSS.t1308 18.0016
R7814 VSS.t1794 VSS.n3222 18.0016
R7815 VSS.t610 VSS.n3212 18.0016
R7816 VSS.t1159 VSS.n3207 18.0016
R7817 VSS.n3204 VSS.t902 18.0016
R7818 VSS.t1590 VSS.n3199 18.0016
R7819 VSS.t762 VSS.n3192 18.0016
R7820 VSS.t1257 VSS.n3188 18.0016
R7821 VSS.t131 VSS.n3030 18.0016
R7822 VSS.t1567 VSS.n3055 18.0016
R7823 VSS.t1595 VSS.n3079 18.0016
R7824 VSS.t1091 VSS.n3104 18.0016
R7825 VSS.t1163 VSS.n3125 18.0016
R7826 VSS.t1236 VSS.n3129 18.0016
R7827 VSS.t2166 VSS.n3152 18.0016
R7828 VSS.t145 VSS.n245 17.7083
R7829 VSS.n1053 VSS.t587 17.7083
R7830 VSS.t1910 VSS.n1207 17.7083
R7831 VSS.n1191 VSS.t1352 17.4722
R7832 VSS.t1805 VSS.n1631 17.4483
R7833 VSS.n2812 VSS.t33 17.4424
R7834 VSS.n3009 VSS.n1936 17.0005
R7835 VSS.n3010 VSS.n3009 17.0005
R7836 VSS.n3009 VSS.n3008 17.0005
R7837 VSS.n3009 VSS.n1939 17.0005
R7838 VSS.n3009 VSS.n2133 17.0005
R7839 VSS.n3009 VSS.n1930 17.0005
R7840 VSS.n3009 VSS.n1929 17.0005
R7841 VSS.n3009 VSS.n1928 17.0005
R7842 VSS.n3009 VSS.n1927 17.0005
R7843 VSS.n3009 VSS.n1925 17.0005
R7844 VSS.n3009 VSS.n1924 17.0005
R7845 VSS.n3009 VSS.n1943 17.0005
R7846 VSS.n3009 VSS.n2132 17.0005
R7847 VSS.n3009 VSS.n1944 17.0005
R7848 VSS.n3009 VSS.n1920 17.0005
R7849 VSS.n3009 VSS.n1945 17.0005
R7850 VSS.n3009 VSS.n2129 17.0005
R7851 VSS.n3009 VSS.n1918 17.0005
R7852 VSS.n3009 VSS.n1917 17.0005
R7853 VSS.n3009 VSS.n1946 17.0005
R7854 VSS.n3009 VSS.n2128 17.0005
R7855 VSS.n3009 VSS.n1947 17.0005
R7856 VSS.n3009 VSS.n2127 17.0005
R7857 VSS.n3009 VSS.n1913 17.0005
R7858 VSS.n3009 VSS.n1912 17.0005
R7859 VSS.n3009 VSS.n1911 17.0005
R7860 VSS.n3009 VSS.n1910 17.0005
R7861 VSS.n3009 VSS.n1909 17.0005
R7862 VSS.n3009 VSS.n1908 17.0005
R7863 VSS.n3009 VSS.n1948 17.0005
R7864 VSS.n3009 VSS.n2125 17.0005
R7865 VSS.n3009 VSS.n1949 17.0005
R7866 VSS.n3009 VSS.n1904 17.0005
R7867 VSS.n3009 VSS.n1950 17.0005
R7868 VSS.n3009 VSS.n2122 17.0005
R7869 VSS.n3009 VSS.n1902 17.0005
R7870 VSS.n3009 VSS.n1901 17.0005
R7871 VSS.n3009 VSS.n1951 17.0005
R7872 VSS.n3009 VSS.n2121 17.0005
R7873 VSS.n3009 VSS.n1952 17.0005
R7874 VSS.n3009 VSS.n2120 17.0005
R7875 VSS.n3009 VSS.n1897 17.0005
R7876 VSS.n3009 VSS.n1896 17.0005
R7877 VSS.n3009 VSS.n1895 17.0005
R7878 VSS.n3009 VSS.n1894 17.0005
R7879 VSS.n3009 VSS.n1893 17.0005
R7880 VSS.n3009 VSS.n1892 17.0005
R7881 VSS.n3009 VSS.n1953 17.0005
R7882 VSS.n3009 VSS.n2118 17.0005
R7883 VSS.n3009 VSS.n1954 17.0005
R7884 VSS.n3009 VSS.n1888 17.0005
R7885 VSS.n3009 VSS.n1955 17.0005
R7886 VSS.n3009 VSS.n2115 17.0005
R7887 VSS.n3009 VSS.n1885 17.0005
R7888 VSS.n3009 VSS.n1884 17.0005
R7889 VSS.n3009 VSS.n1956 17.0005
R7890 VSS.n3009 VSS.n2114 17.0005
R7891 VSS.n3009 VSS.n1957 17.0005
R7892 VSS.n3009 VSS.n2113 17.0005
R7893 VSS.n3009 VSS.n1880 17.0005
R7894 VSS.n3009 VSS.n1879 17.0005
R7895 VSS.n3009 VSS.n1878 17.0005
R7896 VSS.n3009 VSS.n1877 17.0005
R7897 VSS.n3009 VSS.n1876 17.0005
R7898 VSS.n3009 VSS.n1874 17.0005
R7899 VSS.n3009 VSS.n1958 17.0005
R7900 VSS.n3009 VSS.n2111 17.0005
R7901 VSS.n3009 VSS.n1959 17.0005
R7902 VSS.n3009 VSS.n1870 17.0005
R7903 VSS.n3009 VSS.n1960 17.0005
R7904 VSS.n3009 VSS.n2108 17.0005
R7905 VSS.n3009 VSS.n1868 17.0005
R7906 VSS.n3009 VSS.n1867 17.0005
R7907 VSS.n3009 VSS.n1961 17.0005
R7908 VSS.n3009 VSS.n2107 17.0005
R7909 VSS.n3009 VSS.n1962 17.0005
R7910 VSS.n3009 VSS.n2106 17.0005
R7911 VSS.n3009 VSS.n1863 17.0005
R7912 VSS.n3009 VSS.n1862 17.0005
R7913 VSS.n3009 VSS.n1861 17.0005
R7914 VSS.n3009 VSS.n1860 17.0005
R7915 VSS.n3009 VSS.n1859 17.0005
R7916 VSS.n3009 VSS.n1858 17.0005
R7917 VSS.n3009 VSS.n1963 17.0005
R7918 VSS.n3009 VSS.n2104 17.0005
R7919 VSS.n3009 VSS.n1964 17.0005
R7920 VSS.n3009 VSS.n1854 17.0005
R7921 VSS.n3009 VSS.n1965 17.0005
R7922 VSS.n3009 VSS.n2101 17.0005
R7923 VSS.n3009 VSS.n1852 17.0005
R7924 VSS.n3009 VSS.n1851 17.0005
R7925 VSS.n3009 VSS.n1966 17.0005
R7926 VSS.n3009 VSS.n2100 17.0005
R7927 VSS.n3009 VSS.n1967 17.0005
R7928 VSS.n3009 VSS.n2099 17.0005
R7929 VSS.n3009 VSS.n1847 17.0005
R7930 VSS.n3009 VSS.n1846 17.0005
R7931 VSS.n3009 VSS.n1845 17.0005
R7932 VSS.n3009 VSS.n1844 17.0005
R7933 VSS.n3009 VSS.n1843 17.0005
R7934 VSS.n3009 VSS.n1842 17.0005
R7935 VSS.n3009 VSS.n1968 17.0005
R7936 VSS.n3009 VSS.n2097 17.0005
R7937 VSS.n3009 VSS.n1969 17.0005
R7938 VSS.n3009 VSS.n1838 17.0005
R7939 VSS.n3009 VSS.n1970 17.0005
R7940 VSS.n3009 VSS.n2094 17.0005
R7941 VSS.n3009 VSS.n1835 17.0005
R7942 VSS.n3009 VSS.n1834 17.0005
R7943 VSS.n3009 VSS.n1971 17.0005
R7944 VSS.n3009 VSS.n2093 17.0005
R7945 VSS.n3009 VSS.n1972 17.0005
R7946 VSS.n3009 VSS.n2092 17.0005
R7947 VSS.n3009 VSS.n1831 17.0005
R7948 VSS.n3009 VSS.n1830 17.0005
R7949 VSS.n3009 VSS.n1829 17.0005
R7950 VSS.n3009 VSS.n1828 17.0005
R7951 VSS.n3009 VSS.n1827 17.0005
R7952 VSS.n3009 VSS.n1826 17.0005
R7953 VSS.n3009 VSS.n1973 17.0005
R7954 VSS.n3009 VSS.n2090 17.0005
R7955 VSS.n3009 VSS.n1974 17.0005
R7956 VSS.n3009 VSS.n1822 17.0005
R7957 VSS.n3009 VSS.n1975 17.0005
R7958 VSS.n3009 VSS.n2087 17.0005
R7959 VSS.n3009 VSS.n1820 17.0005
R7960 VSS.n3009 VSS.n1819 17.0005
R7961 VSS.n3009 VSS.n1976 17.0005
R7962 VSS.n3009 VSS.n2086 17.0005
R7963 VSS.n3009 VSS.n1977 17.0005
R7964 VSS.n3009 VSS.n2085 17.0005
R7965 VSS.n3009 VSS.n1815 17.0005
R7966 VSS.n3009 VSS.n1814 17.0005
R7967 VSS.n3009 VSS.n1813 17.0005
R7968 VSS.n3009 VSS.n1812 17.0005
R7969 VSS.n3009 VSS.n1811 17.0005
R7970 VSS.n3009 VSS.n1810 17.0005
R7971 VSS.n3009 VSS.n1978 17.0005
R7972 VSS.n3009 VSS.n2083 17.0005
R7973 VSS.n3009 VSS.n1979 17.0005
R7974 VSS.n3009 VSS.n1806 17.0005
R7975 VSS.n3009 VSS.n1980 17.0005
R7976 VSS.n3009 VSS.n2080 17.0005
R7977 VSS.n3009 VSS.n1804 17.0005
R7978 VSS.n3009 VSS.n1803 17.0005
R7979 VSS.n3009 VSS.n1981 17.0005
R7980 VSS.n3009 VSS.n2079 17.0005
R7981 VSS.n3009 VSS.n1982 17.0005
R7982 VSS.n3009 VSS.n2078 17.0005
R7983 VSS.n3009 VSS.n1799 17.0005
R7984 VSS.n3009 VSS.n1798 17.0005
R7985 VSS.n3009 VSS.n1797 17.0005
R7986 VSS.n3009 VSS.n1796 17.0005
R7987 VSS.n3009 VSS.n1795 17.0005
R7988 VSS.n3009 VSS.n1794 17.0005
R7989 VSS.n3009 VSS.n1983 17.0005
R7990 VSS.n3009 VSS.n2076 17.0005
R7991 VSS.n3009 VSS.n1984 17.0005
R7992 VSS.n3009 VSS.n1790 17.0005
R7993 VSS.n3009 VSS.n1985 17.0005
R7994 VSS.n3009 VSS.n2073 17.0005
R7995 VSS.n3009 VSS.n1788 17.0005
R7996 VSS.n3009 VSS.n1787 17.0005
R7997 VSS.n3009 VSS.n1986 17.0005
R7998 VSS.n3009 VSS.n2072 17.0005
R7999 VSS.n3009 VSS.n1987 17.0005
R8000 VSS.n3009 VSS.n2071 17.0005
R8001 VSS.n3009 VSS.n1783 17.0005
R8002 VSS.n3009 VSS.n1782 17.0005
R8003 VSS.n3009 VSS.n1781 17.0005
R8004 VSS.n3009 VSS.n1780 17.0005
R8005 VSS.n3009 VSS.n1779 17.0005
R8006 VSS.n3009 VSS.n1778 17.0005
R8007 VSS.n3009 VSS.n1988 17.0005
R8008 VSS.n3009 VSS.n2069 17.0005
R8009 VSS.n3009 VSS.n1989 17.0005
R8010 VSS.n3009 VSS.n1773 17.0005
R8011 VSS.n3009 VSS.n1990 17.0005
R8012 VSS.n3009 VSS.n2066 17.0005
R8013 VSS.n3009 VSS.n1770 17.0005
R8014 VSS.n3009 VSS.n1769 17.0005
R8015 VSS.n3009 VSS.n1992 17.0005
R8016 VSS.n3009 VSS.n2065 17.0005
R8017 VSS.n3009 VSS.n1993 17.0005
R8018 VSS.n3009 VSS.n2064 17.0005
R8019 VSS.n3009 VSS.n1765 17.0005
R8020 VSS.n3009 VSS.n1764 17.0005
R8021 VSS.n3009 VSS.n1763 17.0005
R8022 VSS.n3009 VSS.n1762 17.0005
R8023 VSS.n3009 VSS.n1761 17.0005
R8024 VSS.n3009 VSS.n1760 17.0005
R8025 VSS.n3009 VSS.n1994 17.0005
R8026 VSS.n3009 VSS.n2061 17.0005
R8027 VSS.n3009 VSS.n1995 17.0005
R8028 VSS.n3009 VSS.n1756 17.0005
R8029 VSS.n3009 VSS.n1996 17.0005
R8030 VSS.n3009 VSS.n2058 17.0005
R8031 VSS.n3009 VSS.n1754 17.0005
R8032 VSS.n3009 VSS.n1753 17.0005
R8033 VSS.n3009 VSS.n1997 17.0005
R8034 VSS.n3009 VSS.n2057 17.0005
R8035 VSS.n3009 VSS.n1998 17.0005
R8036 VSS.n3009 VSS.n2056 17.0005
R8037 VSS.n3009 VSS.n1749 17.0005
R8038 VSS.n3009 VSS.n1748 17.0005
R8039 VSS.n3009 VSS.n1747 17.0005
R8040 VSS.n3009 VSS.n1746 17.0005
R8041 VSS.n3009 VSS.n1745 17.0005
R8042 VSS.n3009 VSS.n1744 17.0005
R8043 VSS.n3009 VSS.n1999 17.0005
R8044 VSS.n3009 VSS.n2054 17.0005
R8045 VSS.n3009 VSS.n2000 17.0005
R8046 VSS.n3009 VSS.n1740 17.0005
R8047 VSS.n3009 VSS.n2001 17.0005
R8048 VSS.n3009 VSS.n2051 17.0005
R8049 VSS.n3009 VSS.n1738 17.0005
R8050 VSS.n3009 VSS.n1737 17.0005
R8051 VSS.n3009 VSS.n2002 17.0005
R8052 VSS.n3009 VSS.n2050 17.0005
R8053 VSS.n3009 VSS.n2003 17.0005
R8054 VSS.n3009 VSS.n2049 17.0005
R8055 VSS.n3009 VSS.n1733 17.0005
R8056 VSS.n3009 VSS.n1732 17.0005
R8057 VSS.n3009 VSS.n1731 17.0005
R8058 VSS.n3009 VSS.n1730 17.0005
R8059 VSS.n3009 VSS.n1729 17.0005
R8060 VSS.n3009 VSS.n1728 17.0005
R8061 VSS.n3009 VSS.n2004 17.0005
R8062 VSS.n3009 VSS.n2047 17.0005
R8063 VSS.n3009 VSS.n2005 17.0005
R8064 VSS.n3009 VSS.n1724 17.0005
R8065 VSS.n3009 VSS.n2006 17.0005
R8066 VSS.n3009 VSS.n2044 17.0005
R8067 VSS.n3009 VSS.n1722 17.0005
R8068 VSS.n3009 VSS.n1721 17.0005
R8069 VSS.n3009 VSS.n2007 17.0005
R8070 VSS.n3009 VSS.n2043 17.0005
R8071 VSS.n3009 VSS.n2008 17.0005
R8072 VSS.n3009 VSS.n2042 17.0005
R8073 VSS.n3009 VSS.n1717 17.0005
R8074 VSS.n3009 VSS.n1716 17.0005
R8075 VSS.n3009 VSS.n1715 17.0005
R8076 VSS.n3009 VSS.n1714 17.0005
R8077 VSS.n3009 VSS.n1713 17.0005
R8078 VSS.n3009 VSS.n1712 17.0005
R8079 VSS.n3009 VSS.n2009 17.0005
R8080 VSS.n3009 VSS.n2040 17.0005
R8081 VSS.n3009 VSS.n2010 17.0005
R8082 VSS.n3009 VSS.n1708 17.0005
R8083 VSS.n3009 VSS.n2011 17.0005
R8084 VSS.n3009 VSS.n2037 17.0005
R8085 VSS.n3009 VSS.n1705 17.0005
R8086 VSS.n3009 VSS.n1704 17.0005
R8087 VSS.n3009 VSS.n2012 17.0005
R8088 VSS.n3009 VSS.n2036 17.0005
R8089 VSS.n3009 VSS.n2013 17.0005
R8090 VSS.n3009 VSS.n2035 17.0005
R8091 VSS.n3009 VSS.n1701 17.0005
R8092 VSS.n3009 VSS.n1700 17.0005
R8093 VSS.n3009 VSS.n1699 17.0005
R8094 VSS.n3009 VSS.n1698 17.0005
R8095 VSS.n3009 VSS.n1697 17.0005
R8096 VSS.n3009 VSS.n1696 17.0005
R8097 VSS.n3009 VSS.n2014 17.0005
R8098 VSS.n3009 VSS.n2033 17.0005
R8099 VSS.n3009 VSS.n2015 17.0005
R8100 VSS.n3009 VSS.n1692 17.0005
R8101 VSS.n3009 VSS.n2016 17.0005
R8102 VSS.n3009 VSS.n2030 17.0005
R8103 VSS.n3009 VSS.n1689 17.0005
R8104 VSS.n3009 VSS.n1688 17.0005
R8105 VSS.n3009 VSS.n2017 17.0005
R8106 VSS.n3009 VSS.n2029 17.0005
R8107 VSS.n3009 VSS.n2018 17.0005
R8108 VSS.n3009 VSS.n2028 17.0005
R8109 VSS.n3009 VSS.n1685 17.0005
R8110 VSS.n3009 VSS.n1684 17.0005
R8111 VSS.n3009 VSS.n1683 17.0005
R8112 VSS.n3009 VSS.n1682 17.0005
R8113 VSS.n3009 VSS.n1681 17.0005
R8114 VSS.n3009 VSS.n1680 17.0005
R8115 VSS.n3009 VSS.n2019 17.0005
R8116 VSS.n3009 VSS.n2026 17.0005
R8117 VSS.n3009 VSS.n2020 17.0005
R8118 VSS.n3009 VSS.n1676 17.0005
R8119 VSS.n3009 VSS.n2021 17.0005
R8120 VSS.n3009 VSS.n2023 17.0005
R8121 VSS.n3009 VSS.n2022 17.0005
R8122 VSS.n127 VSS.n1644 17.0005
R8123 VSS.n3012 VSS.n127 17.0005
R8124 VSS.n127 VSS.n1667 17.0005
R8125 VSS.n127 VSS.t2068 17.0005
R8126 VSS.n127 VSS.n1676 17.0005
R8127 VSS.n127 VSS.n1678 17.0005
R8128 VSS.n127 VSS.n1680 17.0005
R8129 VSS.n127 VSS.n1681 17.0005
R8130 VSS.n127 VSS.n1682 17.0005
R8131 VSS.n127 VSS.n1683 17.0005
R8132 VSS.n127 VSS.n1684 17.0005
R8133 VSS.n127 VSS.n1685 17.0005
R8134 VSS.n127 VSS.n1688 17.0005
R8135 VSS.n127 VSS.n1689 17.0005
R8136 VSS.n127 VSS.n1692 17.0005
R8137 VSS.n127 VSS.n1694 17.0005
R8138 VSS.n127 VSS.n1696 17.0005
R8139 VSS.n127 VSS.n1697 17.0005
R8140 VSS.n127 VSS.n1698 17.0005
R8141 VSS.n127 VSS.n1699 17.0005
R8142 VSS.n127 VSS.n1700 17.0005
R8143 VSS.n127 VSS.n1701 17.0005
R8144 VSS.n127 VSS.n1704 17.0005
R8145 VSS.n127 VSS.n1705 17.0005
R8146 VSS.n127 VSS.n1708 17.0005
R8147 VSS.n127 VSS.n1710 17.0005
R8148 VSS.n127 VSS.n1712 17.0005
R8149 VSS.n127 VSS.n1713 17.0005
R8150 VSS.n127 VSS.n1714 17.0005
R8151 VSS.n127 VSS.n1715 17.0005
R8152 VSS.n127 VSS.n1716 17.0005
R8153 VSS.n127 VSS.n1717 17.0005
R8154 VSS.n127 VSS.n1721 17.0005
R8155 VSS.n127 VSS.n1722 17.0005
R8156 VSS.n127 VSS.n1724 17.0005
R8157 VSS.n127 VSS.n1726 17.0005
R8158 VSS.n127 VSS.n1728 17.0005
R8159 VSS.n127 VSS.n1729 17.0005
R8160 VSS.n127 VSS.n1730 17.0005
R8161 VSS.n127 VSS.n1731 17.0005
R8162 VSS.n127 VSS.n1732 17.0005
R8163 VSS.n127 VSS.n1733 17.0005
R8164 VSS.n127 VSS.n1737 17.0005
R8165 VSS.n127 VSS.n1738 17.0005
R8166 VSS.n127 VSS.n1740 17.0005
R8167 VSS.n127 VSS.n1742 17.0005
R8168 VSS.n127 VSS.n1744 17.0005
R8169 VSS.n127 VSS.n1745 17.0005
R8170 VSS.n127 VSS.n1746 17.0005
R8171 VSS.n127 VSS.n1747 17.0005
R8172 VSS.n127 VSS.n1748 17.0005
R8173 VSS.n127 VSS.n1749 17.0005
R8174 VSS.n127 VSS.n1753 17.0005
R8175 VSS.n127 VSS.n1754 17.0005
R8176 VSS.n127 VSS.n1756 17.0005
R8177 VSS.n127 VSS.n1758 17.0005
R8178 VSS.n127 VSS.n1760 17.0005
R8179 VSS.n127 VSS.n1761 17.0005
R8180 VSS.n127 VSS.n1762 17.0005
R8181 VSS.n127 VSS.n1763 17.0005
R8182 VSS.n127 VSS.n1764 17.0005
R8183 VSS.n127 VSS.n1765 17.0005
R8184 VSS.n127 VSS.n1769 17.0005
R8185 VSS.n127 VSS.n1770 17.0005
R8186 VSS.n127 VSS.n1773 17.0005
R8187 VSS.n127 VSS.n1776 17.0005
R8188 VSS.n127 VSS.n1778 17.0005
R8189 VSS.n127 VSS.n1779 17.0005
R8190 VSS.n127 VSS.n1780 17.0005
R8191 VSS.n127 VSS.n1781 17.0005
R8192 VSS.n127 VSS.n1782 17.0005
R8193 VSS.n127 VSS.n1783 17.0005
R8194 VSS.n127 VSS.n1787 17.0005
R8195 VSS.n127 VSS.n1788 17.0005
R8196 VSS.n127 VSS.n1790 17.0005
R8197 VSS.n127 VSS.n1792 17.0005
R8198 VSS.n127 VSS.n1794 17.0005
R8199 VSS.n127 VSS.n1795 17.0005
R8200 VSS.n127 VSS.n1796 17.0005
R8201 VSS.n127 VSS.n1797 17.0005
R8202 VSS.n127 VSS.n1798 17.0005
R8203 VSS.n127 VSS.n1799 17.0005
R8204 VSS.n127 VSS.n1803 17.0005
R8205 VSS.n127 VSS.n1804 17.0005
R8206 VSS.n127 VSS.n1806 17.0005
R8207 VSS.n127 VSS.n1808 17.0005
R8208 VSS.n127 VSS.n1810 17.0005
R8209 VSS.n127 VSS.n1811 17.0005
R8210 VSS.n127 VSS.n1812 17.0005
R8211 VSS.n127 VSS.n1813 17.0005
R8212 VSS.n127 VSS.n1814 17.0005
R8213 VSS.n127 VSS.n1815 17.0005
R8214 VSS.n127 VSS.n1819 17.0005
R8215 VSS.n127 VSS.n1820 17.0005
R8216 VSS.n127 VSS.n1822 17.0005
R8217 VSS.n127 VSS.n1824 17.0005
R8218 VSS.n127 VSS.n1826 17.0005
R8219 VSS.n127 VSS.n1827 17.0005
R8220 VSS.n127 VSS.n1828 17.0005
R8221 VSS.n127 VSS.n1829 17.0005
R8222 VSS.n127 VSS.n1830 17.0005
R8223 VSS.n127 VSS.n1831 17.0005
R8224 VSS.n127 VSS.n1834 17.0005
R8225 VSS.n127 VSS.n1835 17.0005
R8226 VSS.n127 VSS.n1838 17.0005
R8227 VSS.n127 VSS.n1840 17.0005
R8228 VSS.n127 VSS.n1842 17.0005
R8229 VSS.n127 VSS.n1843 17.0005
R8230 VSS.n127 VSS.n1844 17.0005
R8231 VSS.n127 VSS.n1845 17.0005
R8232 VSS.n127 VSS.n1846 17.0005
R8233 VSS.n127 VSS.n1847 17.0005
R8234 VSS.n127 VSS.n1851 17.0005
R8235 VSS.n127 VSS.n1852 17.0005
R8236 VSS.n127 VSS.n1854 17.0005
R8237 VSS.n127 VSS.n1856 17.0005
R8238 VSS.n127 VSS.n1858 17.0005
R8239 VSS.n127 VSS.n1859 17.0005
R8240 VSS.n127 VSS.n1860 17.0005
R8241 VSS.n127 VSS.n1861 17.0005
R8242 VSS.n127 VSS.n1862 17.0005
R8243 VSS.n127 VSS.n1863 17.0005
R8244 VSS.n127 VSS.n1867 17.0005
R8245 VSS.n127 VSS.n1868 17.0005
R8246 VSS.n127 VSS.n1870 17.0005
R8247 VSS.n127 VSS.n1872 17.0005
R8248 VSS.n127 VSS.n1874 17.0005
R8249 VSS.n127 VSS.n1876 17.0005
R8250 VSS.n127 VSS.n1877 17.0005
R8251 VSS.n127 VSS.n1878 17.0005
R8252 VSS.n127 VSS.n1879 17.0005
R8253 VSS.n127 VSS.n1880 17.0005
R8254 VSS.n127 VSS.n1884 17.0005
R8255 VSS.n127 VSS.n1885 17.0005
R8256 VSS.n127 VSS.n1888 17.0005
R8257 VSS.n127 VSS.n1890 17.0005
R8258 VSS.n127 VSS.n1892 17.0005
R8259 VSS.n127 VSS.n1893 17.0005
R8260 VSS.n127 VSS.n1894 17.0005
R8261 VSS.n127 VSS.n1895 17.0005
R8262 VSS.n127 VSS.n1896 17.0005
R8263 VSS.n127 VSS.n1897 17.0005
R8264 VSS.n127 VSS.n1901 17.0005
R8265 VSS.n127 VSS.n1902 17.0005
R8266 VSS.n127 VSS.n1904 17.0005
R8267 VSS.n127 VSS.n1906 17.0005
R8268 VSS.n127 VSS.n1908 17.0005
R8269 VSS.n127 VSS.n1909 17.0005
R8270 VSS.n127 VSS.n1910 17.0005
R8271 VSS.n127 VSS.n1911 17.0005
R8272 VSS.n127 VSS.n1912 17.0005
R8273 VSS.n127 VSS.n1913 17.0005
R8274 VSS.n127 VSS.n1917 17.0005
R8275 VSS.n127 VSS.n1918 17.0005
R8276 VSS.n127 VSS.n1920 17.0005
R8277 VSS.n127 VSS.n1922 17.0005
R8278 VSS.n127 VSS.n1924 17.0005
R8279 VSS.n127 VSS.n1925 17.0005
R8280 VSS.n127 VSS.n1927 17.0005
R8281 VSS.n127 VSS.n1928 17.0005
R8282 VSS.n127 VSS.n1929 17.0005
R8283 VSS.n127 VSS.n1930 17.0005
R8284 VSS.n127 VSS.n1932 17.0005
R8285 VSS.n127 VSS.n1934 17.0005
R8286 VSS.n127 VSS.n1935 17.0005
R8287 VSS.n2514 VSS.n2134 17.0005
R8288 VSS.n2516 VSS.n2134 17.0005
R8289 VSS.n2518 VSS.n2134 17.0005
R8290 VSS.n2520 VSS.n2134 17.0005
R8291 VSS.n2522 VSS.n2134 17.0005
R8292 VSS.n2524 VSS.n2134 17.0005
R8293 VSS.n2526 VSS.n2134 17.0005
R8294 VSS.n2528 VSS.n2134 17.0005
R8295 VSS.n2530 VSS.n2134 17.0005
R8296 VSS.n2532 VSS.n2134 17.0005
R8297 VSS.n2534 VSS.n2134 17.0005
R8298 VSS.n2536 VSS.n2134 17.0005
R8299 VSS.n2538 VSS.n2134 17.0005
R8300 VSS.n2540 VSS.n2134 17.0005
R8301 VSS.n2542 VSS.n2134 17.0005
R8302 VSS.n2544 VSS.n2134 17.0005
R8303 VSS.n2546 VSS.n2134 17.0005
R8304 VSS.n2548 VSS.n2134 17.0005
R8305 VSS.n2550 VSS.n2134 17.0005
R8306 VSS.n2552 VSS.n2134 17.0005
R8307 VSS.n2554 VSS.n2134 17.0005
R8308 VSS.n2556 VSS.n2134 17.0005
R8309 VSS.n2558 VSS.n2134 17.0005
R8310 VSS.n2868 VSS.n1202 17.0005
R8311 VSS.n2869 VSS.n1202 17.0005
R8312 VSS.n2871 VSS.n1202 17.0005
R8313 VSS.n2873 VSS.n1202 17.0005
R8314 VSS.n2876 VSS.n1202 17.0005
R8315 VSS.n2879 VSS.n1202 17.0005
R8316 VSS.n2881 VSS.n1202 17.0005
R8317 VSS.n2885 VSS.n1202 17.0005
R8318 VSS.n2866 VSS.n1202 17.0005
R8319 VSS.n2864 VSS.n1202 17.0005
R8320 VSS.n2861 VSS.n2860 17.0005
R8321 VSS.n2860 VSS.n2323 17.0005
R8322 VSS.n2854 VSS.n2324 17.0005
R8323 VSS.n2853 VSS.n2852 17.0005
R8324 VSS.n2847 VSS.n2329 17.0005
R8325 VSS.n2849 VSS.n2848 17.0005
R8326 VSS.n2849 VSS.n2331 17.0005
R8327 VSS.n2849 VSS.n2336 17.0005
R8328 VSS.n2849 VSS.n2332 17.0005
R8329 VSS.n2849 VSS.n2335 17.0005
R8330 VSS.n2849 VSS.n2333 17.0005
R8331 VSS.n2813 VSS.n2812 17.0005
R8332 VSS.n2813 VSS.n2810 17.0005
R8333 VSS.n2803 VSS.n2813 17.0005
R8334 VSS.n2813 VSS.n2811 17.0005
R8335 VSS.n2816 VSS.n2815 17.0005
R8336 VSS.n2816 VSS.n2802 17.0005
R8337 VSS.n2816 VSS.n2809 17.0005
R8338 VSS.n2816 VSS.n2804 17.0005
R8339 VSS.n2816 VSS.n2808 17.0005
R8340 VSS.n2816 VSS.n2805 17.0005
R8341 VSS.n2816 VSS.n2806 17.0005
R8342 VSS.n2800 VSS.n2799 17.0005
R8343 VSS.n2800 VSS.n2782 17.0005
R8344 VSS.n2800 VSS.n2798 17.0005
R8345 VSS.n2800 VSS.n2783 17.0005
R8346 VSS.n2800 VSS.n2797 17.0005
R8347 VSS.n2800 VSS.n2784 17.0005
R8348 VSS.n2800 VSS.n2795 17.0005
R8349 VSS.n2800 VSS.n2785 17.0005
R8350 VSS.n2800 VSS.n2794 17.0005
R8351 VSS.n2800 VSS.n2787 17.0005
R8352 VSS.n2800 VSS.n2793 17.0005
R8353 VSS.n2800 VSS.n2788 17.0005
R8354 VSS.n2800 VSS.n2791 17.0005
R8355 VSS.n2800 VSS.n2789 17.0005
R8356 VSS.n2820 VSS.n2819 17.0005
R8357 VSS.n2820 VSS.n2777 17.0005
R8358 VSS.n2820 VSS.n2781 17.0005
R8359 VSS.n2820 VSS.n2780 17.0005
R8360 VSS.n2776 VSS.n2775 17.0005
R8361 VSS.n2822 VSS.n2776 17.0005
R8362 VSS.n2825 VSS.n2824 17.0005
R8363 VSS.n2825 VSS.n2764 17.0005
R8364 VSS.n2825 VSS.n2765 17.0005
R8365 VSS.n2825 VSS.n2773 17.0005
R8366 VSS.n2825 VSS.n2766 17.0005
R8367 VSS.n2825 VSS.n2772 17.0005
R8368 VSS.n2825 VSS.n2767 17.0005
R8369 VSS.n2825 VSS.n2771 17.0005
R8370 VSS.n2825 VSS.n2768 17.0005
R8371 VSS.n2825 VSS.n2770 17.0005
R8372 VSS.n2769 VSS.n2761 17.0005
R8373 VSS.n2761 VSS.n2752 17.0005
R8374 VSS.n2761 VSS.n2760 17.0005
R8375 VSS.n2761 VSS.n2753 17.0005
R8376 VSS.n2761 VSS.n2759 17.0005
R8377 VSS.n2761 VSS.n2754 17.0005
R8378 VSS.n2761 VSS.n2758 17.0005
R8379 VSS.n2761 VSS.n2755 17.0005
R8380 VSS.n2761 VSS.n2757 17.0005
R8381 VSS.n2761 VSS.n2756 17.0005
R8382 VSS.n2828 VSS.n2150 17.0005
R8383 VSS.n2828 VSS.n2399 17.0005
R8384 VSS.n2828 VSS.n2745 17.0005
R8385 VSS.n2828 VSS.n2400 17.0005
R8386 VSS.n2828 VSS.n2742 17.0005
R8387 VSS.n2828 VSS.n2401 17.0005
R8388 VSS.n2828 VSS.n2739 17.0005
R8389 VSS.n2828 VSS.n2402 17.0005
R8390 VSS.n2828 VSS.n2736 17.0005
R8391 VSS.n2828 VSS.n2403 17.0005
R8392 VSS.n2828 VSS.n2733 17.0005
R8393 VSS.n2828 VSS.n2404 17.0005
R8394 VSS.n2828 VSS.n2728 17.0005
R8395 VSS.n2828 VSS.n2405 17.0005
R8396 VSS.n2828 VSS.n2725 17.0005
R8397 VSS.n2828 VSS.n2408 17.0005
R8398 VSS.n2828 VSS.n2722 17.0005
R8399 VSS.n2828 VSS.n2409 17.0005
R8400 VSS.n2828 VSS.n2719 17.0005
R8401 VSS.n2828 VSS.n2410 17.0005
R8402 VSS.n2828 VSS.n2716 17.0005
R8403 VSS.n2828 VSS.n2411 17.0005
R8404 VSS.n2828 VSS.n2713 17.0005
R8405 VSS.n2828 VSS.n2412 17.0005
R8406 VSS.n2828 VSS.n2710 17.0005
R8407 VSS.n2828 VSS.n2413 17.0005
R8408 VSS.n2828 VSS.n2707 17.0005
R8409 VSS.n2828 VSS.n2414 17.0005
R8410 VSS.n2828 VSS.n2422 17.0005
R8411 VSS.n2828 VSS.n2415 17.0005
R8412 VSS.n2828 VSS.n2419 17.0005
R8413 VSS.n2828 VSS.n2416 17.0005
R8414 VSS.n2704 VSS.n2703 17.0005
R8415 VSS.n2704 VSS.n2423 17.0005
R8416 VSS.n2704 VSS.n2700 17.0005
R8417 VSS.n2704 VSS.n2424 17.0005
R8418 VSS.n2704 VSS.n2697 17.0005
R8419 VSS.n2704 VSS.n2425 17.0005
R8420 VSS.n2685 VSS.n2426 17.0005
R8421 VSS.n2687 VSS.n2426 17.0005
R8422 VSS.n2693 VSS.n2426 17.0005
R8423 VSS.n2689 VSS.n2426 17.0005
R8424 VSS.n2692 VSS.n2691 17.0005
R8425 VSS.n2692 VSS.n2428 17.0005
R8426 VSS.n2692 VSS.n2682 17.0005
R8427 VSS.n2692 VSS.n2429 17.0005
R8428 VSS.n2692 VSS.n2679 17.0005
R8429 VSS.n2692 VSS.n2430 17.0005
R8430 VSS.n2692 VSS.n2676 17.0005
R8431 VSS.n2692 VSS.n2431 17.0005
R8432 VSS.n2692 VSS.n2673 17.0005
R8433 VSS.n2670 VSS.n2669 17.0005
R8434 VSS.n2669 VSS.n2434 17.0005
R8435 VSS.n2669 VSS.n2668 17.0005
R8436 VSS.n2669 VSS.n2436 17.0005
R8437 VSS.n2669 VSS.n2666 17.0005
R8438 VSS.n2669 VSS.n2437 17.0005
R8439 VSS.n2669 VSS.n2663 17.0005
R8440 VSS.n2669 VSS.n2438 17.0005
R8441 VSS.n2669 VSS.n2660 17.0005
R8442 VSS.n2669 VSS.n2439 17.0005
R8443 VSS.n2669 VSS.n2657 17.0005
R8444 VSS.n2669 VSS.n2440 17.0005
R8445 VSS.n2669 VSS.n2654 17.0005
R8446 VSS.n2669 VSS.n2441 17.0005
R8447 VSS.n2669 VSS.n2651 17.0005
R8448 VSS.n2669 VSS.n2442 17.0005
R8449 VSS.n2669 VSS.n2648 17.0005
R8450 VSS.n2669 VSS.n2443 17.0005
R8451 VSS.n2669 VSS.n2452 17.0005
R8452 VSS.n2669 VSS.n2444 17.0005
R8453 VSS.n2669 VSS.n2449 17.0005
R8454 VSS.n2669 VSS.n2445 17.0005
R8455 VSS.n2645 VSS.n2644 17.0005
R8456 VSS.n2645 VSS.n2453 17.0005
R8457 VSS.n2645 VSS.n2641 17.0005
R8458 VSS.n2645 VSS.n2454 17.0005
R8459 VSS.n2645 VSS.n2638 17.0005
R8460 VSS.n2645 VSS.n2455 17.0005
R8461 VSS.n2626 VSS.n2456 17.0005
R8462 VSS.n2628 VSS.n2456 17.0005
R8463 VSS.n2634 VSS.n2456 17.0005
R8464 VSS.n2630 VSS.n2456 17.0005
R8465 VSS.n2633 VSS.n2632 17.0005
R8466 VSS.n2633 VSS.n2458 17.0005
R8467 VSS.n2633 VSS.n2623 17.0005
R8468 VSS.n2633 VSS.n2459 17.0005
R8469 VSS.n2633 VSS.n2620 17.0005
R8470 VSS.n2633 VSS.n2460 17.0005
R8471 VSS.n2633 VSS.n2617 17.0005
R8472 VSS.n2633 VSS.n2461 17.0005
R8473 VSS.n2633 VSS.n2614 17.0005
R8474 VSS.n2611 VSS.n2610 17.0005
R8475 VSS.n2610 VSS.n2464 17.0005
R8476 VSS.n2610 VSS.n2609 17.0005
R8477 VSS.n2610 VSS.n2465 17.0005
R8478 VSS.n2610 VSS.n2607 17.0005
R8479 VSS.n2610 VSS.n2467 17.0005
R8480 VSS.n2610 VSS.n2604 17.0005
R8481 VSS.n2560 VSS.n2134 17.0005
R8482 VSS.n2562 VSS.n2134 17.0005
R8483 VSS.n2564 VSS.n2134 17.0005
R8484 VSS.n2566 VSS.n2134 17.0005
R8485 VSS.n2567 VSS.n2134 17.0005
R8486 VSS.n2569 VSS.n2134 17.0005
R8487 VSS.n2573 VSS.n2572 17.0005
R8488 VSS.n2573 VSS.n2497 17.0005
R8489 VSS.n2573 VSS.n2510 17.0005
R8490 VSS.n2573 VSS.n2499 17.0005
R8491 VSS.n2573 VSS.n2507 17.0005
R8492 VSS.n2573 VSS.n2500 17.0005
R8493 VSS.n2573 VSS.n2504 17.0005
R8494 VSS.n2573 VSS.n2501 17.0005
R8495 VSS.n2574 VSS.n2573 17.0005
R8496 VSS.n2578 VSS.n2577 17.0005
R8497 VSS.n2578 VSS.n2479 17.0005
R8498 VSS.n2578 VSS.n2478 17.0005
R8499 VSS.n2578 VSS.n2494 17.0005
R8500 VSS.n2492 VSS.n2477 17.0005
R8501 VSS.n2490 VSS.n2477 17.0005
R8502 VSS.n2488 VSS.n2477 17.0005
R8503 VSS.n2486 VSS.n2477 17.0005
R8504 VSS.n2484 VSS.n2477 17.0005
R8505 VSS.n2482 VSS.n2477 17.0005
R8506 VSS.n2610 VSS.n2468 17.0005
R8507 VSS.n2610 VSS.n2471 17.0005
R8508 VSS.n2610 VSS.n2473 17.0005
R8509 VSS.n2610 VSS.n2475 17.0005
R8510 VSS.n2610 VSS.n2581 17.0005
R8511 VSS.n2610 VSS.n2583 17.0005
R8512 VSS.n2610 VSS.n2585 17.0005
R8513 VSS.n2610 VSS.n2587 17.0005
R8514 VSS.n2610 VSS.n2589 17.0005
R8515 VSS.n2610 VSS.n2591 17.0005
R8516 VSS.n2610 VSS.n2593 17.0005
R8517 VSS.n2610 VSS.n2595 17.0005
R8518 VSS.n2610 VSS.n2597 17.0005
R8519 VSS.n2610 VSS.n2599 17.0005
R8520 VSS.n2610 VSS.n2601 17.0005
R8521 VSS.n346 VSS.n3370 17.0005
R8522 VSS.n346 VSS.n242 17.0005
R8523 VSS.n346 VSS.n585 17.0005
R8524 VSS.n346 VSS.n243 17.0005
R8525 VSS.n346 VSS.n583 17.0005
R8526 VSS.n346 VSS.n245 17.0005
R8527 VSS.n346 VSS.n582 17.0005
R8528 VSS.n346 VSS.n246 17.0005
R8529 VSS.n346 VSS.n581 17.0005
R8530 VSS.n346 VSS.n247 17.0005
R8531 VSS.n346 VSS.n580 17.0005
R8532 VSS.n346 VSS.n249 17.0005
R8533 VSS.n346 VSS.n579 17.0005
R8534 VSS.n346 VSS.n250 17.0005
R8535 VSS.n346 VSS.n578 17.0005
R8536 VSS.n346 VSS.n252 17.0005
R8537 VSS.n346 VSS.n576 17.0005
R8538 VSS.n346 VSS.n253 17.0005
R8539 VSS.n346 VSS.n575 17.0005
R8540 VSS.n346 VSS.n255 17.0005
R8541 VSS.n346 VSS.n261 17.0005
R8542 VSS.n346 VSS.n258 17.0005
R8543 VSS.n346 VSS.t1828 17.0005
R8544 VSS.n346 VSS.n345 17.0005
R8545 VSS.n748 VSS.n239 17.0005
R8546 VSS.n747 VSS.n239 17.0005
R8547 VSS.n745 VSS.n239 17.0005
R8548 VSS.n743 VSS.n239 17.0005
R8549 VSS.n740 VSS.n239 17.0005
R8550 VSS.n737 VSS.n239 17.0005
R8551 VSS.n735 VSS.n239 17.0005
R8552 VSS.n730 VSS.n729 17.0005
R8553 VSS.n729 VSS.n587 17.0005
R8554 VSS.n724 VSS.n588 17.0005
R8555 VSS.n723 VSS.n722 17.0005
R8556 VSS.n719 VSS.n718 17.0005
R8557 VSS.n719 VSS.n596 17.0005
R8558 VSS.n711 VSS.n597 17.0005
R8559 VSS.n710 VSS.n709 17.0005
R8560 VSS.n706 VSS.n705 17.0005
R8561 VSS.n706 VSS.n605 17.0005
R8562 VSS.n698 VSS.n606 17.0005
R8563 VSS.n696 VSS.n695 17.0005
R8564 VSS.n697 VSS.n696 17.0005
R8565 VSS.n683 VSS.n611 17.0005
R8566 VSS.n687 VSS.n611 17.0005
R8567 VSS.n692 VSS.n691 17.0005
R8568 VSS.n692 VSS.n614 17.0005
R8569 VSS.n676 VSS.n615 17.0005
R8570 VSS.n675 VSS.n674 17.0005
R8571 VSS.n671 VSS.n670 17.0005
R8572 VSS.n671 VSS.n623 17.0005
R8573 VSS.n663 VSS.n624 17.0005
R8574 VSS.n662 VSS.n661 17.0005
R8575 VSS.n640 VSS.n638 17.0005
R8576 VSS.n653 VSS.n639 17.0005
R8577 VSS.n656 VSS.n655 17.0005
R8578 VSS.n656 VSS.n635 17.0005
R8579 VSS.n3368 VSS.n3367 17.0005
R8580 VSS.n3368 VSS.n246 17.0005
R8581 VSS.n3368 VSS.n581 17.0005
R8582 VSS.n3368 VSS.n249 17.0005
R8583 VSS.n3368 VSS.n578 17.0005
R8584 VSS.n3368 VSS.n758 17.0005
R8585 VSS.n3368 VSS.n576 17.0005
R8586 VSS.n3368 VSS.n761 17.0005
R8587 VSS.n3322 VSS.n1051 17.0005
R8588 VSS.n3323 VSS.n3322 17.0005
R8589 VSS.n3322 VSS.n1134 17.0005
R8590 VSS.n3322 VSS.n1052 17.0005
R8591 VSS.n3322 VSS.n1132 17.0005
R8592 VSS.n3322 VSS.n1053 17.0005
R8593 VSS.n3322 VSS.n1130 17.0005
R8594 VSS.n3322 VSS.n798 17.0005
R8595 VSS.n3322 VSS.n1046 17.0005
R8596 VSS.n3322 VSS.n1055 17.0005
R8597 VSS.n3322 VSS.n1129 17.0005
R8598 VSS.n3322 VSS.n800 17.0005
R8599 VSS.n3322 VSS.n1128 17.0005
R8600 VSS.n3322 VSS.n1057 17.0005
R8601 VSS.n3322 VSS.n1043 17.0005
R8602 VSS.n3322 VSS.n1058 17.0005
R8603 VSS.n3322 VSS.n1127 17.0005
R8604 VSS.n3322 VSS.n1060 17.0005
R8605 VSS.n3322 VSS.n1041 17.0005
R8606 VSS.n3322 VSS.n1061 17.0005
R8607 VSS.n3322 VSS.n1126 17.0005
R8608 VSS.n3322 VSS.n1062 17.0005
R8609 VSS.n151 VSS.n1048 17.0005
R8610 VSS.n151 VSS.n798 17.0005
R8611 VSS.n151 VSS.n1046 17.0005
R8612 VSS.n151 VSS.n800 17.0005
R8613 VSS.n151 VSS.n1043 17.0005
R8614 VSS.n151 VSS.n802 17.0005
R8615 VSS.n151 VSS.n1041 17.0005
R8616 VSS.n151 VSS.n804 17.0005
R8617 VSS.n151 VSS.n848 17.0005
R8618 VSS.n151 VSS.t1850 17.0005
R8619 VSS.n3325 VSS.n151 17.0005
R8620 VSS.n151 VSS.n191 17.0005
R8621 VSS.n151 VSS.n807 17.0005
R8622 VSS.n151 VSS.n805 17.0005
R8623 VSS.n3322 VSS.n1125 17.0005
R8624 VSS.n3322 VSS.n1064 17.0005
R8625 VSS.n3322 VSS.n1108 17.0005
R8626 VSS.n3322 VSS.n1106 17.0005
R8627 VSS.n3173 VSS.n133 17.0005
R8628 VSS.n133 VSS.n3171 17.0005
R8629 VSS.n3315 VSS.t1448 17.0005
R8630 VSS.n3315 VSS.n3165 17.0005
R8631 VSS.n3315 VSS.n3170 17.0005
R8632 VSS.n3315 VSS.n1143 17.0005
R8633 VSS.n3315 VSS.n1141 17.0005
R8634 VSS.n3315 VSS.n1200 17.0005
R8635 VSS.n3315 VSS.n1199 17.0005
R8636 VSS.n3315 VSS.n1197 17.0005
R8637 VSS.n3315 VSS.n1195 17.0005
R8638 VSS.n3315 VSS.n1192 17.0005
R8639 VSS.n3315 VSS.n1189 17.0005
R8640 VSS.n2218 VSS.n45 17.0005
R8641 VSS.n60 VSS.n2865 17.0005
R8642 VSS.n3018 VSS.n3017 17.0005
R8643 VSS.n3017 VSS.n1204 17.0005
R8644 VSS.n3017 VSS.n1286 17.0005
R8645 VSS.n3017 VSS.n1205 17.0005
R8646 VSS.n3017 VSS.n1284 17.0005
R8647 VSS.n3017 VSS.n1207 17.0005
R8648 VSS.n3017 VSS.n1283 17.0005
R8649 VSS.n3017 VSS.n125 17.0005
R8650 VSS.n3017 VSS.n124 17.0005
R8651 VSS.n3017 VSS.n1209 17.0005
R8652 VSS.n3017 VSS.n1282 17.0005
R8653 VSS.n3017 VSS.n123 17.0005
R8654 VSS.n3017 VSS.n1281 17.0005
R8655 VSS.n3017 VSS.n1211 17.0005
R8656 VSS.n3017 VSS.n122 17.0005
R8657 VSS.n3017 VSS.n1213 17.0005
R8658 VSS.n3017 VSS.n121 17.0005
R8659 VSS.n3017 VSS.n1214 17.0005
R8660 VSS.n3017 VSS.n1279 17.0005
R8661 VSS.n3017 VSS.n1215 17.0005
R8662 VSS.n127 VSS.n1663 17.0005
R8663 VSS.n127 VSS.n125 17.0005
R8664 VSS.n127 VSS.n124 17.0005
R8665 VSS.n127 VSS.n123 17.0005
R8666 VSS.n127 VSS.n122 17.0005
R8667 VSS.n127 VSS.n1657 17.0005
R8668 VSS.n127 VSS.n121 17.0005
R8669 VSS.n127 VSS.n1652 17.0005
R8670 VSS.n127 VSS.n1651 17.0005
R8671 VSS.n3017 VSS.n1277 17.0005
R8672 VSS.n3017 VSS.n1216 17.0005
R8673 VSS.n3017 VSS.n1261 17.0005
R8674 VSS.n3017 VSS.n1259 17.0005
R8675 VSS.n1568 VSS.n1567 17.0005
R8676 VSS.n1568 VSS.n1565 17.0005
R8677 VSS.n1639 VSS.n1638 17.0005
R8678 VSS.n1639 VSS.n1293 17.0005
R8679 VSS.n1639 VSS.n1618 17.0005
R8680 VSS.n1639 VSS.t2054 17.0005
R8681 VSS.n1639 VSS.n1573 17.0005
R8682 VSS.n1639 VSS.n1622 17.0005
R8683 VSS.n1639 VSS.n1623 17.0005
R8684 VSS.n1639 VSS.n1625 17.0005
R8685 VSS.n1639 VSS.n1627 17.0005
R8686 VSS.n1639 VSS.n1630 17.0005
R8687 VSS.n2602 VSS.n113 17.0005
R8688 VSS.n2600 VSS.n113 17.0005
R8689 VSS.n2598 VSS.n113 17.0005
R8690 VSS.n2596 VSS.n113 17.0005
R8691 VSS.n2594 VSS.n113 17.0005
R8692 VSS.n2592 VSS.n113 17.0005
R8693 VSS.n2590 VSS.n113 17.0005
R8694 VSS.n2588 VSS.n113 17.0005
R8695 VSS.n2586 VSS.n113 17.0005
R8696 VSS.n2584 VSS.n113 17.0005
R8697 VSS.n2582 VSS.n113 17.0005
R8698 VSS.n2580 VSS.n113 17.0005
R8699 VSS.n2474 VSS.n113 17.0005
R8700 VSS.n2472 VSS.n113 17.0005
R8701 VSS.n2470 VSS.n113 17.0005
R8702 VSS.n2481 VSS.n113 17.0005
R8703 VSS.n2483 VSS.n113 17.0005
R8704 VSS.n2485 VSS.n113 17.0005
R8705 VSS.n2487 VSS.n113 17.0005
R8706 VSS.n2489 VSS.n113 17.0005
R8707 VSS.n2491 VSS.n113 17.0005
R8708 VSS.n2493 VSS.n113 17.0005
R8709 VSS.n2480 VSS.n113 17.0005
R8710 VSS.n2576 VSS.n113 17.0005
R8711 VSS.n2575 VSS.n113 17.0005
R8712 VSS.n2496 VSS.n113 17.0005
R8713 VSS.n2503 VSS.n113 17.0005
R8714 VSS.n2502 VSS.n113 17.0005
R8715 VSS.n2506 VSS.n113 17.0005
R8716 VSS.n2505 VSS.n113 17.0005
R8717 VSS.n2509 VSS.n113 17.0005
R8718 VSS.n2508 VSS.n113 17.0005
R8719 VSS.n2571 VSS.n113 17.0005
R8720 VSS.n2570 VSS.n113 17.0005
R8721 VSS.n2568 VSS.n113 17.0005
R8722 VSS.t302 VSS.n113 17.0005
R8723 VSS.n2565 VSS.n113 17.0005
R8724 VSS.n2563 VSS.n113 17.0005
R8725 VSS.n2561 VSS.n113 17.0005
R8726 VSS.n2559 VSS.n113 17.0005
R8727 VSS.n2557 VSS.n113 17.0005
R8728 VSS.n2555 VSS.n113 17.0005
R8729 VSS.n2553 VSS.n113 17.0005
R8730 VSS.n2551 VSS.n113 17.0005
R8731 VSS.n2549 VSS.n113 17.0005
R8732 VSS.n2547 VSS.n113 17.0005
R8733 VSS.n2545 VSS.n113 17.0005
R8734 VSS.n2543 VSS.n113 17.0005
R8735 VSS.n2541 VSS.n113 17.0005
R8736 VSS.n2539 VSS.n113 17.0005
R8737 VSS.n2537 VSS.n113 17.0005
R8738 VSS.n2535 VSS.n113 17.0005
R8739 VSS.n2533 VSS.n113 17.0005
R8740 VSS.n2531 VSS.n113 17.0005
R8741 VSS.n2529 VSS.n113 17.0005
R8742 VSS.n2527 VSS.n113 17.0005
R8743 VSS.n2525 VSS.n113 17.0005
R8744 VSS.n2523 VSS.n113 17.0005
R8745 VSS.n2521 VSS.n113 17.0005
R8746 VSS.n2519 VSS.n113 17.0005
R8747 VSS.n2517 VSS.n113 17.0005
R8748 VSS.n2515 VSS.n113 17.0005
R8749 VSS.n2513 VSS.n113 17.0005
R8750 VSS.n2515 VSS.n98 17.0005
R8751 VSS.n2517 VSS.n98 17.0005
R8752 VSS.n2519 VSS.n98 17.0005
R8753 VSS.n2521 VSS.n98 17.0005
R8754 VSS.n2523 VSS.n98 17.0005
R8755 VSS.n2525 VSS.n98 17.0005
R8756 VSS.n2527 VSS.n98 17.0005
R8757 VSS.n2529 VSS.n98 17.0005
R8758 VSS.n2531 VSS.n98 17.0005
R8759 VSS.n2533 VSS.n98 17.0005
R8760 VSS.n2535 VSS.n98 17.0005
R8761 VSS.n2537 VSS.n98 17.0005
R8762 VSS.n2539 VSS.n98 17.0005
R8763 VSS.n2541 VSS.n98 17.0005
R8764 VSS.n2543 VSS.n98 17.0005
R8765 VSS.n2545 VSS.n98 17.0005
R8766 VSS.n2547 VSS.n98 17.0005
R8767 VSS.n2549 VSS.n98 17.0005
R8768 VSS.n2551 VSS.n98 17.0005
R8769 VSS.n2553 VSS.n98 17.0005
R8770 VSS.n2555 VSS.n98 17.0005
R8771 VSS.n2557 VSS.n98 17.0005
R8772 VSS.n2559 VSS.n98 17.0005
R8773 VSS.n2561 VSS.n98 17.0005
R8774 VSS.n2563 VSS.n98 17.0005
R8775 VSS.n2565 VSS.n98 17.0005
R8776 VSS.t302 VSS.n98 17.0005
R8777 VSS.n2568 VSS.n98 17.0005
R8778 VSS.n2570 VSS.n98 17.0005
R8779 VSS.n2571 VSS.n98 17.0005
R8780 VSS.n2508 VSS.n98 17.0005
R8781 VSS.n2509 VSS.n98 17.0005
R8782 VSS.n2505 VSS.n98 17.0005
R8783 VSS.n2506 VSS.n98 17.0005
R8784 VSS.n2502 VSS.n98 17.0005
R8785 VSS.n2503 VSS.n98 17.0005
R8786 VSS.n2496 VSS.n98 17.0005
R8787 VSS.n2575 VSS.n98 17.0005
R8788 VSS.n2576 VSS.n98 17.0005
R8789 VSS.n2480 VSS.n98 17.0005
R8790 VSS.n2493 VSS.n98 17.0005
R8791 VSS.n2491 VSS.n98 17.0005
R8792 VSS.n2489 VSS.n98 17.0005
R8793 VSS.n2487 VSS.n98 17.0005
R8794 VSS.n2485 VSS.n98 17.0005
R8795 VSS.n2483 VSS.n98 17.0005
R8796 VSS.n2481 VSS.n98 17.0005
R8797 VSS.n2470 VSS.n98 17.0005
R8798 VSS.n2472 VSS.n98 17.0005
R8799 VSS.n2474 VSS.n98 17.0005
R8800 VSS.n2580 VSS.n98 17.0005
R8801 VSS.n2582 VSS.n98 17.0005
R8802 VSS.n2584 VSS.n98 17.0005
R8803 VSS.n2586 VSS.n98 17.0005
R8804 VSS.n2588 VSS.n98 17.0005
R8805 VSS.n2590 VSS.n98 17.0005
R8806 VSS.n2592 VSS.n98 17.0005
R8807 VSS.n2594 VSS.n98 17.0005
R8808 VSS.n2596 VSS.n98 17.0005
R8809 VSS.n2598 VSS.n98 17.0005
R8810 VSS.n2600 VSS.n98 17.0005
R8811 VSS.n2602 VSS.n98 17.0005
R8812 VSS.n2987 VSS.n98 17.0005
R8813 VSS.n2603 VSS.n98 17.0005
R8814 VSS.n2605 VSS.n98 17.0005
R8815 VSS.n2606 VSS.n98 17.0005
R8816 VSS.n2608 VSS.n98 17.0005
R8817 VSS.t289 VSS.n98 17.0005
R8818 VSS.n2463 VSS.n98 17.0005
R8819 VSS.n2612 VSS.n98 17.0005
R8820 VSS.n2613 VSS.n98 17.0005
R8821 VSS.n2615 VSS.n98 17.0005
R8822 VSS.n2616 VSS.n98 17.0005
R8823 VSS.n2618 VSS.n98 17.0005
R8824 VSS.n2619 VSS.n98 17.0005
R8825 VSS.n2621 VSS.n98 17.0005
R8826 VSS.n2622 VSS.n98 17.0005
R8827 VSS.n2624 VSS.n98 17.0005
R8828 VSS.n2631 VSS.n98 17.0005
R8829 VSS.n2629 VSS.n98 17.0005
R8830 VSS.n2627 VSS.n98 17.0005
R8831 VSS.n2625 VSS.n98 17.0005
R8832 VSS.n2636 VSS.n98 17.0005
R8833 VSS.n2637 VSS.n98 17.0005
R8834 VSS.n2639 VSS.n98 17.0005
R8835 VSS.n2640 VSS.n98 17.0005
R8836 VSS.n2642 VSS.n98 17.0005
R8837 VSS.n2643 VSS.n98 17.0005
R8838 VSS.n2447 VSS.n98 17.0005
R8839 VSS.n2448 VSS.n98 17.0005
R8840 VSS.n2450 VSS.n98 17.0005
R8841 VSS.n2451 VSS.n98 17.0005
R8842 VSS.n2646 VSS.n98 17.0005
R8843 VSS.n2647 VSS.n98 17.0005
R8844 VSS.n2649 VSS.n98 17.0005
R8845 VSS.n2650 VSS.n98 17.0005
R8846 VSS.n2652 VSS.n98 17.0005
R8847 VSS.n2653 VSS.n98 17.0005
R8848 VSS.n2655 VSS.n98 17.0005
R8849 VSS.n2656 VSS.n98 17.0005
R8850 VSS.n2658 VSS.n98 17.0005
R8851 VSS.n2659 VSS.n98 17.0005
R8852 VSS.n2661 VSS.n98 17.0005
R8853 VSS.n2662 VSS.n98 17.0005
R8854 VSS.n2664 VSS.n98 17.0005
R8855 VSS.n2665 VSS.n98 17.0005
R8856 VSS.n2667 VSS.n98 17.0005
R8857 VSS.t277 VSS.n98 17.0005
R8858 VSS.n2433 VSS.n98 17.0005
R8859 VSS.n2671 VSS.n98 17.0005
R8860 VSS.n2672 VSS.n98 17.0005
R8861 VSS.n2674 VSS.n98 17.0005
R8862 VSS.n2675 VSS.n98 17.0005
R8863 VSS.n2677 VSS.n98 17.0005
R8864 VSS.n2678 VSS.n98 17.0005
R8865 VSS.n2680 VSS.n98 17.0005
R8866 VSS.n2681 VSS.n98 17.0005
R8867 VSS.n2683 VSS.n98 17.0005
R8868 VSS.n2690 VSS.n98 17.0005
R8869 VSS.n2688 VSS.n98 17.0005
R8870 VSS.n2686 VSS.n98 17.0005
R8871 VSS.n2684 VSS.n98 17.0005
R8872 VSS.n2695 VSS.n98 17.0005
R8873 VSS.n2696 VSS.n98 17.0005
R8874 VSS.n2698 VSS.n98 17.0005
R8875 VSS.n2699 VSS.n98 17.0005
R8876 VSS.n2701 VSS.n98 17.0005
R8877 VSS.n2702 VSS.n98 17.0005
R8878 VSS.n2417 VSS.n98 17.0005
R8879 VSS.n2418 VSS.n98 17.0005
R8880 VSS.n2420 VSS.n98 17.0005
R8881 VSS.n2421 VSS.n98 17.0005
R8882 VSS.n2705 VSS.n98 17.0005
R8883 VSS.n2706 VSS.n98 17.0005
R8884 VSS.n2708 VSS.n98 17.0005
R8885 VSS.n2709 VSS.n98 17.0005
R8886 VSS.n2711 VSS.n98 17.0005
R8887 VSS.n2712 VSS.n98 17.0005
R8888 VSS.n2714 VSS.n98 17.0005
R8889 VSS.n2715 VSS.n98 17.0005
R8890 VSS.n2717 VSS.n98 17.0005
R8891 VSS.n2718 VSS.n98 17.0005
R8892 VSS.n2720 VSS.n98 17.0005
R8893 VSS.n2721 VSS.n98 17.0005
R8894 VSS.n2723 VSS.n98 17.0005
R8895 VSS.n2724 VSS.n98 17.0005
R8896 VSS.n2726 VSS.n98 17.0005
R8897 VSS.n2727 VSS.n98 17.0005
R8898 VSS.n2731 VSS.n98 17.0005
R8899 VSS.n2732 VSS.n98 17.0005
R8900 VSS.n2734 VSS.n98 17.0005
R8901 VSS.n2735 VSS.n98 17.0005
R8902 VSS.n2737 VSS.n98 17.0005
R8903 VSS.n2738 VSS.n98 17.0005
R8904 VSS.n2740 VSS.n98 17.0005
R8905 VSS.n2741 VSS.n98 17.0005
R8906 VSS.n2743 VSS.n98 17.0005
R8907 VSS.n2744 VSS.n98 17.0005
R8908 VSS.n2398 VSS.n98 17.0005
R8909 VSS.n2398 VSS.n113 17.0005
R8910 VSS.n2744 VSS.n113 17.0005
R8911 VSS.n2743 VSS.n113 17.0005
R8912 VSS.n2741 VSS.n113 17.0005
R8913 VSS.n2740 VSS.n113 17.0005
R8914 VSS.n2738 VSS.n113 17.0005
R8915 VSS.n2737 VSS.n113 17.0005
R8916 VSS.n2735 VSS.n113 17.0005
R8917 VSS.n2734 VSS.n113 17.0005
R8918 VSS.n2732 VSS.n113 17.0005
R8919 VSS.n2731 VSS.n113 17.0005
R8920 VSS.n2727 VSS.n113 17.0005
R8921 VSS.n2726 VSS.n113 17.0005
R8922 VSS.n2724 VSS.n113 17.0005
R8923 VSS.n2723 VSS.n113 17.0005
R8924 VSS.n2721 VSS.n113 17.0005
R8925 VSS.n2720 VSS.n113 17.0005
R8926 VSS.n2718 VSS.n113 17.0005
R8927 VSS.n2717 VSS.n113 17.0005
R8928 VSS.n2715 VSS.n113 17.0005
R8929 VSS.n2714 VSS.n113 17.0005
R8930 VSS.n2712 VSS.n113 17.0005
R8931 VSS.n2711 VSS.n113 17.0005
R8932 VSS.n2709 VSS.n113 17.0005
R8933 VSS.n2708 VSS.n113 17.0005
R8934 VSS.n2706 VSS.n113 17.0005
R8935 VSS.n2705 VSS.n113 17.0005
R8936 VSS.n2421 VSS.n113 17.0005
R8937 VSS.n2420 VSS.n113 17.0005
R8938 VSS.n2418 VSS.n113 17.0005
R8939 VSS.n2417 VSS.n113 17.0005
R8940 VSS.n2702 VSS.n113 17.0005
R8941 VSS.n2701 VSS.n113 17.0005
R8942 VSS.n2699 VSS.n113 17.0005
R8943 VSS.n2698 VSS.n113 17.0005
R8944 VSS.n2696 VSS.n113 17.0005
R8945 VSS.n2695 VSS.n113 17.0005
R8946 VSS.n2684 VSS.n113 17.0005
R8947 VSS.n2686 VSS.n113 17.0005
R8948 VSS.n2688 VSS.n113 17.0005
R8949 VSS.n2690 VSS.n113 17.0005
R8950 VSS.n2683 VSS.n113 17.0005
R8951 VSS.n2681 VSS.n113 17.0005
R8952 VSS.n2680 VSS.n113 17.0005
R8953 VSS.n2678 VSS.n113 17.0005
R8954 VSS.n2677 VSS.n113 17.0005
R8955 VSS.n2675 VSS.n113 17.0005
R8956 VSS.n2674 VSS.n113 17.0005
R8957 VSS.n2672 VSS.n113 17.0005
R8958 VSS.n2671 VSS.n113 17.0005
R8959 VSS.n2433 VSS.n113 17.0005
R8960 VSS.t277 VSS.n113 17.0005
R8961 VSS.n2667 VSS.n113 17.0005
R8962 VSS.n2665 VSS.n113 17.0005
R8963 VSS.n2664 VSS.n113 17.0005
R8964 VSS.n2662 VSS.n113 17.0005
R8965 VSS.n2661 VSS.n113 17.0005
R8966 VSS.n2659 VSS.n113 17.0005
R8967 VSS.n2658 VSS.n113 17.0005
R8968 VSS.n2656 VSS.n113 17.0005
R8969 VSS.n2655 VSS.n113 17.0005
R8970 VSS.n2653 VSS.n113 17.0005
R8971 VSS.n2652 VSS.n113 17.0005
R8972 VSS.n2650 VSS.n113 17.0005
R8973 VSS.n2649 VSS.n113 17.0005
R8974 VSS.n2647 VSS.n113 17.0005
R8975 VSS.n2646 VSS.n113 17.0005
R8976 VSS.n2451 VSS.n113 17.0005
R8977 VSS.n2450 VSS.n113 17.0005
R8978 VSS.n2448 VSS.n113 17.0005
R8979 VSS.n2447 VSS.n113 17.0005
R8980 VSS.n2643 VSS.n113 17.0005
R8981 VSS.n2642 VSS.n113 17.0005
R8982 VSS.n2640 VSS.n113 17.0005
R8983 VSS.n2639 VSS.n113 17.0005
R8984 VSS.n2637 VSS.n113 17.0005
R8985 VSS.n2636 VSS.n113 17.0005
R8986 VSS.n2625 VSS.n113 17.0005
R8987 VSS.n2627 VSS.n113 17.0005
R8988 VSS.n2629 VSS.n113 17.0005
R8989 VSS.n2631 VSS.n113 17.0005
R8990 VSS.n2624 VSS.n113 17.0005
R8991 VSS.n2622 VSS.n113 17.0005
R8992 VSS.n2621 VSS.n113 17.0005
R8993 VSS.n2619 VSS.n113 17.0005
R8994 VSS.n2618 VSS.n113 17.0005
R8995 VSS.n2616 VSS.n113 17.0005
R8996 VSS.n2615 VSS.n113 17.0005
R8997 VSS.n2613 VSS.n113 17.0005
R8998 VSS.n2612 VSS.n113 17.0005
R8999 VSS.n2463 VSS.n113 17.0005
R9000 VSS.t289 VSS.n113 17.0005
R9001 VSS.n2603 VSS.n113 17.0005
R9002 VSS.n2605 VSS.n113 17.0005
R9003 VSS.n2606 VSS.n113 17.0005
R9004 VSS.n2608 VSS.n113 17.0005
R9005 VSS.n2832 VSS.n2831 17.0005
R9006 VSS.t96 VSS.n2390 17.0005
R9007 VSS.t96 VSS.n2338 17.0005
R9008 VSS.t96 VSS.n2389 17.0005
R9009 VSS.t96 VSS.n2339 17.0005
R9010 VSS.t96 VSS.n2388 17.0005
R9011 VSS.t96 VSS.n2340 17.0005
R9012 VSS.t96 VSS.n2387 17.0005
R9013 VSS.t96 VSS.n2341 17.0005
R9014 VSS.t96 VSS.n2386 17.0005
R9015 VSS.t96 VSS.n2342 17.0005
R9016 VSS.t96 VSS.n2385 17.0005
R9017 VSS.t96 VSS.n2343 17.0005
R9018 VSS.t96 VSS.n2384 17.0005
R9019 VSS.t96 VSS.n2344 17.0005
R9020 VSS.t96 VSS.n2383 17.0005
R9021 VSS.t96 VSS.n2345 17.0005
R9022 VSS.t96 VSS.n2382 17.0005
R9023 VSS.t96 VSS.n2346 17.0005
R9024 VSS.t96 VSS.n2381 17.0005
R9025 VSS.t96 VSS.n2347 17.0005
R9026 VSS.t96 VSS.n2380 17.0005
R9027 VSS.t96 VSS.n2348 17.0005
R9028 VSS.t96 VSS.n2379 17.0005
R9029 VSS.t96 VSS.n2349 17.0005
R9030 VSS.t96 VSS.n2378 17.0005
R9031 VSS.t96 VSS.n2350 17.0005
R9032 VSS.t96 VSS.n2377 17.0005
R9033 VSS.t96 VSS.n2351 17.0005
R9034 VSS.t96 VSS.n2376 17.0005
R9035 VSS.t96 VSS.n2352 17.0005
R9036 VSS.t96 VSS.n2375 17.0005
R9037 VSS.t96 VSS.n2353 17.0005
R9038 VSS.t96 VSS.n2374 17.0005
R9039 VSS.t96 VSS.n2354 17.0005
R9040 VSS.t96 VSS.n2373 17.0005
R9041 VSS.t96 VSS.n2355 17.0005
R9042 VSS.t96 VSS.n2372 17.0005
R9043 VSS.t96 VSS.n2356 17.0005
R9044 VSS.t96 VSS.n2371 17.0005
R9045 VSS.t96 VSS.n2370 17.0005
R9046 VSS.t96 VSS.n2369 17.0005
R9047 VSS.t96 VSS.n2368 17.0005
R9048 VSS.t96 VSS.n2367 17.0005
R9049 VSS.t96 VSS.n2366 17.0005
R9050 VSS.t96 VSS.n2365 17.0005
R9051 VSS.t96 VSS.n2364 17.0005
R9052 VSS.t96 VSS.n2363 17.0005
R9053 VSS.t96 VSS.n2362 17.0005
R9054 VSS.t96 VSS.n2361 17.0005
R9055 VSS.t96 VSS.n2360 17.0005
R9056 VSS.t96 VSS.n2359 17.0005
R9057 VSS.t96 VSS.n2358 17.0005
R9058 VSS.t96 VSS.n2357 17.0005
R9059 VSS.t96 VSS.n2337 17.0005
R9060 VSS.t473 VSS.n2941 17.0005
R9061 VSS.t473 VSS.n2180 17.0005
R9062 VSS.t473 VSS.n2181 17.0005
R9063 VSS.t473 VSS.n2195 17.0005
R9064 VSS.n2942 VSS.t473 17.0005
R9065 VSS.t473 VSS.n2193 17.0005
R9066 VSS.t473 VSS.n2186 17.0005
R9067 VSS.t473 VSS.n2187 17.0005
R9068 VSS.t473 VSS.n2189 17.0005
R9069 VSS.n2172 VSS.n1 17.0005
R9070 VSS.n2162 VSS.n1 17.0005
R9071 VSS.n2971 VSS.n1 17.0005
R9072 VSS.n2165 VSS.n1 17.0005
R9073 VSS.n2168 VSS.n1 17.0005
R9074 VSS.n2962 VSS.n1 17.0005
R9075 VSS.n77 VSS.n70 17.0005
R9076 VSS.n77 VSS.n2310 17.0005
R9077 VSS.n77 VSS.n2262 17.0005
R9078 VSS.n77 VSS.n2308 17.0005
R9079 VSS.n77 VSS.n2263 17.0005
R9080 VSS.n77 VSS.n2307 17.0005
R9081 VSS.n77 VSS.n2264 17.0005
R9082 VSS.n2898 VSS.n77 17.0005
R9083 VSS.n77 VSS.n2265 17.0005
R9084 VSS.n77 VSS.n2305 17.0005
R9085 VSS.n77 VSS.n2266 17.0005
R9086 VSS.n77 VSS.n2303 17.0005
R9087 VSS.n77 VSS.n2267 17.0005
R9088 VSS.n77 VSS.n2302 17.0005
R9089 VSS.n77 VSS.n2268 17.0005
R9090 VSS.n77 VSS.n2300 17.0005
R9091 VSS.n77 VSS.n71 17.0005
R9092 VSS.n77 VSS.n2299 17.0005
R9093 VSS.n77 VSS.n2269 17.0005
R9094 VSS.n77 VSS.n2297 17.0005
R9095 VSS.n77 VSS.n2270 17.0005
R9096 VSS.n77 VSS.n2295 17.0005
R9097 VSS.n77 VSS.n2271 17.0005
R9098 VSS.n77 VSS.n2294 17.0005
R9099 VSS.n77 VSS.n2272 17.0005
R9100 VSS.n77 VSS.n74 17.0005
R9101 VSS.n77 VSS.n2274 17.0005
R9102 VSS.n77 VSS.n2292 17.0005
R9103 VSS.n77 VSS.n2275 17.0005
R9104 VSS.n77 VSS.n2290 17.0005
R9105 VSS.n77 VSS.n2276 17.0005
R9106 VSS.n77 VSS.n2289 17.0005
R9107 VSS.n77 VSS.n2277 17.0005
R9108 VSS.n77 VSS.n2287 17.0005
R9109 VSS.n77 VSS.n2278 17.0005
R9110 VSS.n77 VSS.n2286 17.0005
R9111 VSS.n77 VSS.n2279 17.0005
R9112 VSS.n77 VSS.n2284 17.0005
R9113 VSS.n77 VSS.n72 17.0005
R9114 VSS.n77 VSS.n2282 17.0005
R9115 VSS.n77 VSS.n2281 17.0005
R9116 VSS.n78 VSS.n32 12.4712
R9117 VSS.n2262 VSS.n19 17.0005
R9118 VSS.n2308 VSS.n19 17.0005
R9119 VSS.n2264 VSS.n19 17.0005
R9120 VSS.n2303 VSS.n19 17.0005
R9121 VSS.n2267 VSS.n19 17.0005
R9122 VSS.n2300 VSS.n19 17.0005
R9123 VSS.n2270 VSS.n19 17.0005
R9124 VSS.n2295 VSS.n19 17.0005
R9125 VSS.n2272 VSS.n19 17.0005
R9126 VSS.n2932 VSS.n19 17.0005
R9127 VSS.n2290 VSS.n19 17.0005
R9128 VSS.n2276 VSS.n19 17.0005
R9129 VSS.n2287 VSS.n19 17.0005
R9130 VSS.n2278 VSS.n19 17.0005
R9131 VSS.n34 VSS.n70 17.0005
R9132 VSS.n34 VSS.n2898 17.0005
R9133 VSS.n34 VSS.n71 17.0005
R9134 VSS.n34 VSS.n74 17.0005
R9135 VSS.n34 VSS.n2253 17.0005
R9136 VSS.n34 VSS.n72 17.0005
R9137 VSS.n34 VSS.n32 17.0005
R9138 VSS.n20 VSS.n19 5.62581
R9139 VSS.n2282 VSS.n19 17.0005
R9140 VSS.n2936 VSS.n19 17.0005
R9141 VSS.n77 VSS.n73 17.0005
R9142 VSS.n3368 VSS.n3361 17.0005
R9143 VSS.n3368 VSS.n763 17.0005
R9144 VSS.n3368 VSS.n3344 17.0005
R9145 VSS.n3368 VSS.n3342 17.0005
R9146 VSS.n140 VSS.n3331 17.0005
R9147 VSS.n3332 VSS.n140 17.0005
R9148 VSS.t1636 VSS.n2865 16.9164
R9149 VSS.t627 VSS.n2872 16.4551
R9150 VSS.t137 VSS.n2267 16.4539
R9151 VSS.n127 VSS.n1936 15.8474
R9152 VSS.t1623 VSS.n741 15.7754
R9153 VSS.n2983 VSS.n2150 15.4455
R9154 VSS.t12 VSS.n2712 15.4455
R9155 VSS.t279 VSS.n2437 15.4455
R9156 VSS.t989 VSS.n2653 15.4455
R9157 VSS.n2614 VSS.t811 15.4455
R9158 VSS.t292 VSS.n2467 15.4455
R9159 VSS.n2592 VSS.t991 15.4455
R9160 VSS.t303 VSS.n2560 15.4455
R9161 VSS.n2547 VSS.t3 15.4455
R9162 VSS.n1942 VSS.n1932 14.9953
R9163 VSS.n2131 VSS.n1922 14.9953
R9164 VSS.n2124 VSS.n1906 14.9953
R9165 VSS.n2117 VSS.n1890 14.9953
R9166 VSS.n2110 VSS.n1872 14.9953
R9167 VSS.n2103 VSS.n1856 14.9953
R9168 VSS.n2096 VSS.n1840 14.9953
R9169 VSS.n2089 VSS.n1824 14.9953
R9170 VSS.n2082 VSS.n1808 14.9953
R9171 VSS.n2075 VSS.n1792 14.9953
R9172 VSS.n2068 VSS.n1776 14.9953
R9173 VSS.n2060 VSS.n1758 14.9953
R9174 VSS.n2053 VSS.n1742 14.9953
R9175 VSS.n2046 VSS.n1726 14.9953
R9176 VSS.n2039 VSS.n1710 14.9953
R9177 VSS.n2032 VSS.n1694 14.9953
R9178 VSS.n2025 VSS.n1678 14.9953
R9179 VSS.n2021 VSS.n1675 14.9953
R9180 VSS.n2019 VSS.n1679 14.9953
R9181 VSS.n2018 VSS.n1686 14.9953
R9182 VSS.n2017 VSS.n1687 14.9953
R9183 VSS.n2016 VSS.n1690 14.9953
R9184 VSS.n2014 VSS.n1695 14.9953
R9185 VSS.n2013 VSS.n1702 14.9953
R9186 VSS.n2012 VSS.n1703 14.9953
R9187 VSS.n2011 VSS.n1706 14.9953
R9188 VSS.n2009 VSS.n1711 14.9953
R9189 VSS.n2008 VSS.n1718 14.9953
R9190 VSS.n2007 VSS.n1719 14.9953
R9191 VSS.n2006 VSS.n1723 14.9953
R9192 VSS.n2004 VSS.n1727 14.9953
R9193 VSS.n2003 VSS.n1734 14.9953
R9194 VSS.n2002 VSS.n1735 14.9953
R9195 VSS.n2001 VSS.n1739 14.9953
R9196 VSS.n1999 VSS.n1743 14.9953
R9197 VSS.n1998 VSS.n1750 14.9953
R9198 VSS.n1997 VSS.n1751 14.9953
R9199 VSS.n1996 VSS.n1755 14.9953
R9200 VSS.n1994 VSS.n1759 14.9953
R9201 VSS.n1993 VSS.n1766 14.9953
R9202 VSS.n1992 VSS.n1768 14.9953
R9203 VSS.n1990 VSS.n1772 14.9953
R9204 VSS.n1988 VSS.n1777 14.9953
R9205 VSS.n1987 VSS.n1784 14.9953
R9206 VSS.n1986 VSS.n1785 14.9953
R9207 VSS.n1985 VSS.n1789 14.9953
R9208 VSS.n1983 VSS.n1793 14.9953
R9209 VSS.n1982 VSS.n1800 14.9953
R9210 VSS.n1981 VSS.n1801 14.9953
R9211 VSS.n1980 VSS.n1805 14.9953
R9212 VSS.n1978 VSS.n1809 14.9953
R9213 VSS.n1977 VSS.n1816 14.9953
R9214 VSS.n1976 VSS.n1818 14.9953
R9215 VSS.n1975 VSS.n1821 14.9953
R9216 VSS.n1973 VSS.n1825 14.9953
R9217 VSS.n1972 VSS.n1832 14.9953
R9218 VSS.n1971 VSS.n1833 14.9953
R9219 VSS.n1970 VSS.n1836 14.9953
R9220 VSS.n1968 VSS.n1841 14.9953
R9221 VSS.n1967 VSS.n1848 14.9953
R9222 VSS.n1966 VSS.n1849 14.9953
R9223 VSS.n1965 VSS.n1853 14.9953
R9224 VSS.n1963 VSS.n1857 14.9953
R9225 VSS.n1962 VSS.n1864 14.9953
R9226 VSS.n1961 VSS.n1866 14.9953
R9227 VSS.n1960 VSS.n1869 14.9953
R9228 VSS.n1958 VSS.n1873 14.9953
R9229 VSS.n1957 VSS.n1882 14.9953
R9230 VSS.n1956 VSS.n1883 14.9953
R9231 VSS.n1955 VSS.n1886 14.9953
R9232 VSS.n1953 VSS.n1891 14.9953
R9233 VSS.n1952 VSS.n1898 14.9953
R9234 VSS.n1951 VSS.n1899 14.9953
R9235 VSS.n1950 VSS.n1903 14.9953
R9236 VSS.n1948 VSS.n1907 14.9953
R9237 VSS.n1947 VSS.n1914 14.9953
R9238 VSS.n1946 VSS.n1916 14.9953
R9239 VSS.n1945 VSS.n1919 14.9953
R9240 VSS.n1943 VSS.n1923 14.9953
R9241 VSS.n3008 VSS.n1933 14.9953
R9242 VSS.n2023 VSS.n1675 14.9953
R9243 VSS.n2020 VSS.n1677 14.9953
R9244 VSS.n2026 VSS.n1679 14.9953
R9245 VSS.n2028 VSS.n1686 14.9953
R9246 VSS.n2029 VSS.n1687 14.9953
R9247 VSS.n2030 VSS.n1690 14.9953
R9248 VSS.n2015 VSS.n1693 14.9953
R9249 VSS.n2033 VSS.n1695 14.9953
R9250 VSS.n2035 VSS.n1702 14.9953
R9251 VSS.n2036 VSS.n1703 14.9953
R9252 VSS.n2037 VSS.n1706 14.9953
R9253 VSS.n2010 VSS.n1709 14.9953
R9254 VSS.n2040 VSS.n1711 14.9953
R9255 VSS.n2042 VSS.n1718 14.9953
R9256 VSS.n2043 VSS.n1719 14.9953
R9257 VSS.n2044 VSS.n1723 14.9953
R9258 VSS.n2005 VSS.n1725 14.9953
R9259 VSS.n2047 VSS.n1727 14.9953
R9260 VSS.n2049 VSS.n1734 14.9953
R9261 VSS.n2050 VSS.n1735 14.9953
R9262 VSS.n2051 VSS.n1739 14.9953
R9263 VSS.n2000 VSS.n1741 14.9953
R9264 VSS.n2054 VSS.n1743 14.9953
R9265 VSS.n2056 VSS.n1750 14.9953
R9266 VSS.n2057 VSS.n1751 14.9953
R9267 VSS.n2058 VSS.n1755 14.9953
R9268 VSS.n1995 VSS.n1757 14.9953
R9269 VSS.n2061 VSS.n1759 14.9953
R9270 VSS.n2064 VSS.n1766 14.9953
R9271 VSS.n2065 VSS.n1768 14.9953
R9272 VSS.n2066 VSS.n1772 14.9953
R9273 VSS.n1989 VSS.n1775 14.9953
R9274 VSS.n2069 VSS.n1777 14.9953
R9275 VSS.n2071 VSS.n1784 14.9953
R9276 VSS.n2072 VSS.n1785 14.9953
R9277 VSS.n2073 VSS.n1789 14.9953
R9278 VSS.n1984 VSS.n1791 14.9953
R9279 VSS.n2076 VSS.n1793 14.9953
R9280 VSS.n2078 VSS.n1800 14.9953
R9281 VSS.n2079 VSS.n1801 14.9953
R9282 VSS.n2080 VSS.n1805 14.9953
R9283 VSS.n1979 VSS.n1807 14.9953
R9284 VSS.n2083 VSS.n1809 14.9953
R9285 VSS.n2085 VSS.n1816 14.9953
R9286 VSS.n2086 VSS.n1818 14.9953
R9287 VSS.n2087 VSS.n1821 14.9953
R9288 VSS.n1974 VSS.n1823 14.9953
R9289 VSS.n2090 VSS.n1825 14.9953
R9290 VSS.n2092 VSS.n1832 14.9953
R9291 VSS.n2093 VSS.n1833 14.9953
R9292 VSS.n2094 VSS.n1836 14.9953
R9293 VSS.n1969 VSS.n1839 14.9953
R9294 VSS.n2097 VSS.n1841 14.9953
R9295 VSS.n2099 VSS.n1848 14.9953
R9296 VSS.n2100 VSS.n1849 14.9953
R9297 VSS.n2101 VSS.n1853 14.9953
R9298 VSS.n1964 VSS.n1855 14.9953
R9299 VSS.n2104 VSS.n1857 14.9953
R9300 VSS.n2106 VSS.n1864 14.9953
R9301 VSS.n2107 VSS.n1866 14.9953
R9302 VSS.n2108 VSS.n1869 14.9953
R9303 VSS.n1959 VSS.n1871 14.9953
R9304 VSS.n2111 VSS.n1873 14.9953
R9305 VSS.n2113 VSS.n1882 14.9953
R9306 VSS.n2114 VSS.n1883 14.9953
R9307 VSS.n2115 VSS.n1886 14.9953
R9308 VSS.n1954 VSS.n1889 14.9953
R9309 VSS.n2118 VSS.n1891 14.9953
R9310 VSS.n2120 VSS.n1898 14.9953
R9311 VSS.n2121 VSS.n1899 14.9953
R9312 VSS.n2122 VSS.n1903 14.9953
R9313 VSS.n1949 VSS.n1905 14.9953
R9314 VSS.n2125 VSS.n1907 14.9953
R9315 VSS.n2127 VSS.n1914 14.9953
R9316 VSS.n2128 VSS.n1916 14.9953
R9317 VSS.n2129 VSS.n1919 14.9953
R9318 VSS.n1944 VSS.n1921 14.9953
R9319 VSS.n2132 VSS.n1923 14.9953
R9320 VSS.n2133 VSS.n1931 14.9953
R9321 VSS.n1939 VSS.n1933 14.9953
R9322 VSS.n2880 VSS.t696 14.9842
R9323 VSS.t1787 VSS.n247 14.757
R9324 VSS.n1055 VSS.t1462 14.757
R9325 VSS.t1997 VSS.n1209 14.757
R9326 VSS.n2287 VSS.t1274 14.2601
R9327 VSS.t1026 VSS.n2346 13.954
R9328 VSS.t2296 VSS.n1193 13.7246
R9329 VSS.n1629 VSS.t28 13.7147
R9330 VSS.t510 VSS.t49 13.4836
R9331 VSS.n3367 VSS.n244 13.0461
R9332 VSS.n758 VSS.n577 13.0461
R9333 VSS.t923 VSS.n251 13.0461
R9334 VSS.n3370 VSS.n3369 13.0461
R9335 VSS.n754 VSS.n585 13.0461
R9336 VSS.n3365 VSS.n245 13.0461
R9337 VSS.n3364 VSS.n247 13.0461
R9338 VSS.n757 VSS.n579 13.0461
R9339 VSS.n760 VSS.t923 13.0461
R9340 VSS.n3362 VSS.n253 13.0461
R9341 VSS.n3369 VSS.n242 13.0461
R9342 VSS.n755 VSS.n243 13.0461
R9343 VSS.n3366 VSS.n583 13.0461
R9344 VSS.n3365 VSS.n582 13.0461
R9345 VSS.n3363 VSS.n580 13.0461
R9346 VSS.n757 VSS.n250 13.0461
R9347 VSS.n760 VSS.n252 13.0461
R9348 VSS.n3362 VSS.n575 13.0461
R9349 VSS.n761 VSS.n254 13.0461
R9350 VSS.n762 VSS.n255 13.0461
R9351 VSS.n1059 VSS.t932 13.0461
R9352 VSS.n3324 VSS.n3323 13.0461
R9353 VSS.n1134 VSS.n797 13.0461
R9354 VSS.n1052 VSS.n1050 13.0461
R9355 VSS.n1053 VSS.n1047 13.0461
R9356 VSS.n1057 VSS.n1044 13.0461
R9357 VSS.n1127 VSS.n801 13.0461
R9358 VSS.n1060 VSS.n1042 13.0461
R9359 VSS.n1061 VSS.n1040 13.0461
R9360 VSS.n3324 VSS.n1051 13.0461
R9361 VSS.n1132 VSS.n1049 13.0461
R9362 VSS.n1131 VSS.n1048 13.0461
R9363 VSS.n1130 VSS.n1047 13.0461
R9364 VSS.n1055 VSS.n799 13.0461
R9365 VSS.n1129 VSS.n1045 13.0461
R9366 VSS.n1128 VSS.n1044 13.0461
R9367 VSS.n1058 VSS.n801 13.0461
R9368 VSS.n1059 VSS.n802 13.0461
R9369 VSS.t932 VSS.n1042 13.0461
R9370 VSS.n1126 VSS.n1040 13.0461
R9371 VSS.n1062 VSS.n803 13.0461
R9372 VSS.n1063 VSS.n804 13.0461
R9373 VSS.n1663 VSS.n1206 13.0461
R9374 VSS.n1657 VSS.n1280 13.0461
R9375 VSS.t1154 VSS.n1212 13.0461
R9376 VSS.n1652 VSS.n1278 13.0461
R9377 VSS.n1204 VSS.n126 13.0461
R9378 VSS.n1664 VSS.n1205 13.0461
R9379 VSS.n1662 VSS.n1284 13.0461
R9380 VSS.n1661 VSS.n1283 13.0461
R9381 VSS.n1659 VSS.n1282 13.0461
R9382 VSS.n1658 VSS.n1211 13.0461
R9383 VSS.n1655 VSS.n1213 13.0461
R9384 VSS.n1654 VSS.n1279 13.0461
R9385 VSS.n1649 VSS.n1215 13.0461
R9386 VSS.n3018 VSS.n126 13.0461
R9387 VSS.n1665 VSS.n1286 13.0461
R9388 VSS.n1661 VSS.n1207 13.0461
R9389 VSS.n1660 VSS.n1209 13.0461
R9390 VSS.n1658 VSS.n1281 13.0461
R9391 VSS.n1655 VSS.t1154 13.0461
R9392 VSS.n1654 VSS.n1214 13.0461
R9393 VSS.n2309 VSS.n70 12.0761
R9394 VSS.n2306 VSS.n2263 12.0761
R9395 VSS.n2898 VSS.n2261 12.0761
R9396 VSS.n2304 VSS.n2266 12.0761
R9397 VSS.n2302 VSS.n2301 12.0761
R9398 VSS.n2298 VSS.n71 12.0761
R9399 VSS.n2296 VSS.n2269 12.0761
R9400 VSS.n2293 VSS.n2271 12.0761
R9401 VSS.n2274 VSS.n2273 12.0761
R9402 VSS.n2291 VSS.n2275 12.0761
R9403 VSS.n2288 VSS.n2277 12.0761
R9404 VSS.n2286 VSS.n2285 12.0761
R9405 VSS.n2310 VSS.n2224 12.0761
R9406 VSS.n2308 VSS.n2225 12.0761
R9407 VSS.n2307 VSS.n2226 12.0761
R9408 VSS.n2265 VSS.n2260 12.0761
R9409 VSS.n2266 VSS.n2259 12.0761
R9410 VSS.n2267 VSS.n2258 12.0761
R9411 VSS.n2268 VSS.n2257 12.0761
R9412 VSS.n2299 VSS.n2227 12.0761
R9413 VSS.n2297 VSS.n2228 12.0761
R9414 VSS.n2295 VSS.n2229 12.0761
R9415 VSS.n2294 VSS.n2230 12.0761
R9416 VSS.n2274 VSS.n2254 12.0761
R9417 VSS.n2275 VSS.n2251 12.0761
R9418 VSS.n2276 VSS.n2250 12.0761
R9419 VSS.n2277 VSS.n2249 12.0761
R9420 VSS.n2278 VSS.n2248 12.0761
R9421 VSS.n2279 VSS.n2235 12.0761
R9422 VSS.n2282 VSS.n2232 12.0761
R9423 VSS.n2283 VSS.n72 12.0761
R9424 VSS.n2280 VSS.n32 12.0761
R9425 VSS.n2310 VSS.n2309 12.0761
R9426 VSS.n2262 VSS.n2224 12.0761
R9427 VSS.n2263 VSS.n2225 12.0761
R9428 VSS.n2307 VSS.n2306 12.0761
R9429 VSS.n2264 VSS.n2226 12.0761
R9430 VSS.n2265 VSS.n2261 12.0761
R9431 VSS.n2305 VSS.n2260 12.0761
R9432 VSS.n2305 VSS.n2304 12.0761
R9433 VSS.n2303 VSS.n2259 12.0761
R9434 VSS.n2302 VSS.n2258 12.0761
R9435 VSS.n2301 VSS.n2268 12.0761
R9436 VSS.n2300 VSS.n2257 12.0761
R9437 VSS.n2299 VSS.n2298 12.0761
R9438 VSS.n2269 VSS.n2227 12.0761
R9439 VSS.n2297 VSS.n2296 12.0761
R9440 VSS.n2270 VSS.n2228 12.0761
R9441 VSS.n2271 VSS.n2229 12.0761
R9442 VSS.n2294 VSS.n2293 12.0761
R9443 VSS.n2272 VSS.n2230 12.0761
R9444 VSS.n2273 VSS.n74 12.0761
R9445 VSS.n2292 VSS.n2254 12.0761
R9446 VSS.n2292 VSS.n2291 12.0761
R9447 VSS.n2290 VSS.n2251 12.0761
R9448 VSS.n2289 VSS.n2250 12.0761
R9449 VSS.n2289 VSS.n2288 12.0761
R9450 VSS.n2287 VSS.n2249 12.0761
R9451 VSS.n2286 VSS.n2248 12.0761
R9452 VSS.n2285 VSS.n2279 12.0761
R9453 VSS.n2284 VSS.n2235 12.0761
R9454 VSS.n2284 VSS.n2283 12.0761
R9455 VSS.n2281 VSS.n2232 12.0761
R9456 VSS.n2281 VSS.n2280 12.0761
R9457 VSS.t1094 VSS.n2877 12.0423
R9458 VSS.n2834 VSS.n2151 12.0423
R9459 VSS.t1774 VSS.n250 11.8057
R9460 VSS.n1057 VSS.t1795 11.8057
R9461 VSS.t2343 VSS.n1211 11.8057
R9462 VSS.n2695 VSS.t271 11.7681
R9463 VSS.t809 VSS.n2448 11.7681
R9464 VSS.n2636 VSS.t283 11.7681
R9465 VSS.t296 VSS.n2491 11.7681
R9466 VSS.n2875 VSS.t695 10.5714
R9467 VSS.t1829 VSS.n2374 10.4656
R9468 VSS.t998 VSS.t1083 10.4656
R9469 VSS.n2864 VSS.t510 10.2971
R9470 VSS.n2026 VSS.t1929 10.0339
R9471 VSS.n2029 VSS.t2133 10.0339
R9472 VSS.n2033 VSS.t1942 10.0339
R9473 VSS.n2036 VSS.t1309 10.0339
R9474 VSS.n2040 VSS.t1312 10.0339
R9475 VSS.n2043 VSS.t1951 10.0339
R9476 VSS.n2047 VSS.t1947 10.0339
R9477 VSS.n2050 VSS.t1899 10.0339
R9478 VSS.n2054 VSS.t2353 10.0339
R9479 VSS.n2057 VSS.t1900 10.0339
R9480 VSS.n2061 VSS.t1247 10.0339
R9481 VSS.n2065 VSS.t1246 10.0339
R9482 VSS.n2069 VSS.t1062 10.0339
R9483 VSS.n2072 VSS.t2328 10.0339
R9484 VSS.n2076 VSS.t1471 10.0339
R9485 VSS.n2079 VSS.t2329 10.0339
R9486 VSS.n2083 VSS.t1973 10.0339
R9487 VSS.n2086 VSS.t1409 10.0339
R9488 VSS.n2090 VSS.t1833 10.0339
R9489 VSS.n2093 VSS.t1210 10.0339
R9490 VSS.n2097 VSS.t2330 10.0339
R9491 VSS.n2100 VSS.t641 10.0339
R9492 VSS.n2104 VSS.t934 10.0339
R9493 VSS.n2107 VSS.t2249 10.0339
R9494 VSS.n2111 VSS.t1835 10.0339
R9495 VSS.n2114 VSS.t2332 10.0339
R9496 VSS.n2118 VSS.t1527 10.0339
R9497 VSS.n2121 VSS.t2183 10.0339
R9498 VSS.n2125 VSS.t1525 10.0339
R9499 VSS.n2128 VSS.t1581 10.0339
R9500 VSS.n2132 VSS.t646 10.0339
R9501 VSS.n2731 VSS.t2170 9.56167
R9502 VSS.n2197 VSS.t154 9.5417
R9503 VSS.n2972 VSS.t1861 9.08698
R9504 VSS.n2970 VSS.t1861 9.0445
R9505 VSS.n2966 VSS.n2965 9.0005
R9506 VSS.n2966 VSS.n2177 9.0005
R9507 VSS.n2968 VSS.n2967 9.0005
R9508 VSS.n2967 VSS.n2175 9.0005
R9509 VSS.n3007 VSS.n127 8.501
R9510 VSS.n2859 VSS.t235 8.501
R9511 VSS.n2855 VSS.t237 8.501
R9512 VSS.t239 VSS.n2325 8.501
R9513 VSS.n2850 VSS.t243 8.501
R9514 VSS.t247 VSS.n2330 8.501
R9515 VSS.t249 VSS.n2334 8.501
R9516 VSS.n2814 VSS.t251 8.501
R9517 VSS.t253 VSS.n2817 8.501
R9518 VSS.n2818 VSS.t258 8.501
R9519 VSS.t260 VSS.n2821 8.501
R9520 VSS.n2823 VSS.t263 8.501
R9521 VSS.t265 VSS.n2826 8.501
R9522 VSS.t66 VSS.n2394 8.501
R9523 VSS.t66 VSS.n2393 8.501
R9524 VSS.t66 VSS.n2392 8.501
R9525 VSS.t14 VSS.n2406 8.501
R9526 VSS.n2694 VSS.t272 8.501
R9527 VSS.t274 VSS.n2427 8.501
R9528 VSS.t278 VSS.n2432 8.501
R9529 VSS.t282 VSS.n2446 8.501
R9530 VSS.n2635 VSS.t284 8.501
R9531 VSS.t286 VSS.n2457 8.501
R9532 VSS.n2462 VSS.t291 8.501
R9533 VSS.n2512 VSS.t301 8.501
R9534 VSS.t299 VSS.n2495 8.501
R9535 VSS.t297 VSS.n2579 8.501
R9536 VSS.t294 VSS.n2469 8.501
R9537 VSS.n728 VSS.t399 8.501
R9538 VSS.n725 VSS.t401 8.501
R9539 VSS.t403 VSS.n589 8.501
R9540 VSS.n720 VSS.t407 8.501
R9541 VSS.t411 VSS.n594 8.501
R9542 VSS.n712 VSS.t413 8.501
R9543 VSS.t415 VSS.n598 8.501
R9544 VSS.n707 VSS.t419 8.501
R9545 VSS.t423 VSS.n603 8.501
R9546 VSS.n699 VSS.t425 8.501
R9547 VSS.t428 VSS.n607 8.501
R9548 VSS.n693 VSS.t430 8.501
R9549 VSS.t435 VSS.n612 8.501
R9550 VSS.n677 VSS.t437 8.501
R9551 VSS.t439 VSS.n616 8.501
R9552 VSS.n672 VSS.t443 8.501
R9553 VSS.t447 VSS.n621 8.501
R9554 VSS.n664 VSS.t449 8.501
R9555 VSS.t451 VSS.n625 8.501
R9556 VSS.n659 VSS.t456 8.501
R9557 VSS.t466 VSS.n651 8.501
R9558 VSS.n652 VSS.t464 8.501
R9559 VSS.t462 VSS.n637 8.501
R9560 VSS.t459 VSS.n657 8.501
R9561 VSS.t346 VSS.n137 0.831559
R9562 VSS.n135 VSS.t344 0.264361
R9563 VSS.t342 VSS.n134 0.145945
R9564 VSS.n128 VSS.n3166 233.198
R9565 VSS.n128 VSS.n130 0.00235708
R9566 VSS.t229 VSS.n1560 8.501
R9567 VSS.n1569 VSS.t227 8.501
R9568 VSS.t225 VSS.n1249 8.501
R9569 VSS.n2984 VSS.n2983 8.501
R9570 VSS.n2983 VSS.n91 1.41718
R9571 VSS.n91 VSS.n92 0.00287409
R9572 VSS.n92 VSS.n93 0.00170812
R9573 VSS.n93 VSS.n94 0.00166658
R9574 VSS.n94 VSS.n95 0.00149997
R9575 VSS.n2983 VSS.n97 4.251
R9576 VSS.n97 VSS.n96 0.00149997
R9577 VSS.n99 VSS.n98 1.88412
R9578 VSS.n98 VSS.n100 0.00149997
R9579 VSS.n3004 VSS.n102 2.12578
R9580 VSS.n102 VSS.n103 0.00274975
R9581 VSS.n103 VSS.n104 0.00149997
R9582 VSS.n3004 VSS.n106 2.12569
R9583 VSS.n106 VSS.n105 0.00170812
R9584 VSS.n105 VSS.n107 0.00166658
R9585 VSS.n107 VSS.n108 0.00149997
R9586 VSS.n3004 VSS.n109 3.40102
R9587 VSS.n3004 VSS.n112 4.251
R9588 VSS.n112 VSS.n113 0.00149997
R9589 VSS.n2940 VSS.n33 3.4011
R9590 VSS.n2952 VSS.n3 5.41258
R9591 VSS.n2897 VSS.n60 2.83417
R9592 VSS.n2897 VSS.n62 3.40102
R9593 VSS.n2897 VSS.n64 2.42956
R9594 VSS.n2897 VSS.n66 4.251
R9595 VSS.n2897 VSS.n67 1.88985
R9596 VSS.n69 VSS.n11 0.00149997
R9597 VSS.n46 VSS.n44 1.41711
R9598 VSS.n47 VSS.n46 0.00173273
R9599 VSS.n48 VSS.n47 0.00172462
R9600 VSS.n49 VSS.n48 0.00170812
R9601 VSS.n50 VSS.n49 0.00166658
R9602 VSS.n51 VSS.n50 0.00149997
R9603 VSS.n15 VSS.n44 4.251
R9604 VSS.n14 VSS.n44 1.88972
R9605 VSS.n44 VSS.n53 3.40102
R9606 VSS.n44 VSS.n54 1.70064
R9607 VSS.n54 VSS.n57 0.00169968
R9608 VSS.n57 VSS.n58 0.00166651
R9609 VSS.n58 VSS.n36 0.00158329
R9610 VSS.n2908 VSS.n79 3.40102
R9611 VSS.n2908 VSS.n83 1.21468
R9612 VSS.n83 VSS.n84 0.00289862
R9613 VSS.n84 VSS.n85 0.00172462
R9614 VSS.n85 VSS.n86 0.00170812
R9615 VSS.n2908 VSS.n87 3.40102
R9616 VSS.n2908 VSS.n23 1.54591
R9617 VSS.n23 VSS.n30 0.00392329
R9618 VSS.n2908 VSS.n29 2.42928
R9619 VSS.n2940 VSS.n41 2.42928
R9620 VSS.n2940 VSS.n43 2.83417
R9621 VSS.n43 VSS.n42 0.00166658
R9622 VSS.n78 VSS.n77 1.51099
R9623 VSS.n2939 VSS.t1044 8.501
R9624 VSS.t395 VSS.n143 0.831118
R9625 VSS.t390 VSS.n142 0.263721
R9626 VSS.t387 VSS.n141 0.145945
R9627 VSS.n127 VSS.n1642 8.5005
R9628 VSS.n127 VSS.n1645 8.5005
R9629 VSS.n346 VSS.n567 8.5005
R9630 VSS.n346 VSS.n565 8.5005
R9631 VSS.n346 VSS.n563 8.5005
R9632 VSS.n346 VSS.n561 8.5005
R9633 VSS.n346 VSS.n559 8.5005
R9634 VSS.n346 VSS.n558 8.5005
R9635 VSS.n346 VSS.n556 8.5005
R9636 VSS.n346 VSS.n555 8.5005
R9637 VSS.n346 VSS.n554 8.5005
R9638 VSS.n346 VSS.n553 8.5005
R9639 VSS.n346 VSS.n552 8.5005
R9640 VSS.n346 VSS.n550 8.5005
R9641 VSS.n346 VSS.n548 8.5005
R9642 VSS.n346 VSS.n546 8.5005
R9643 VSS.n346 VSS.n545 8.5005
R9644 VSS.n346 VSS.n543 8.5005
R9645 VSS.n346 VSS.n542 8.5005
R9646 VSS.n346 VSS.n541 8.5005
R9647 VSS.n346 VSS.n540 8.5005
R9648 VSS.n346 VSS.n538 8.5005
R9649 VSS.n346 VSS.n536 8.5005
R9650 VSS.n346 VSS.n535 8.5005
R9651 VSS.n346 VSS.n533 8.5005
R9652 VSS.n346 VSS.n532 8.5005
R9653 VSS.n346 VSS.n530 8.5005
R9654 VSS.n346 VSS.n529 8.5005
R9655 VSS.n346 VSS.n528 8.5005
R9656 VSS.n346 VSS.n527 8.5005
R9657 VSS.n346 VSS.n525 8.5005
R9658 VSS.n346 VSS.n523 8.5005
R9659 VSS.n346 VSS.n522 8.5005
R9660 VSS.n346 VSS.n520 8.5005
R9661 VSS.n346 VSS.n519 8.5005
R9662 VSS.n346 VSS.n517 8.5005
R9663 VSS.n346 VSS.n516 8.5005
R9664 VSS.n346 VSS.n515 8.5005
R9665 VSS.n346 VSS.n514 8.5005
R9666 VSS.n346 VSS.n513 8.5005
R9667 VSS.n346 VSS.n511 8.5005
R9668 VSS.n346 VSS.n509 8.5005
R9669 VSS.n346 VSS.n507 8.5005
R9670 VSS.n346 VSS.n506 8.5005
R9671 VSS.n346 VSS.n504 8.5005
R9672 VSS.n346 VSS.n503 8.5005
R9673 VSS.n346 VSS.n502 8.5005
R9674 VSS.n346 VSS.n501 8.5005
R9675 VSS.n346 VSS.n500 8.5005
R9676 VSS.n346 VSS.n498 8.5005
R9677 VSS.n346 VSS.n497 8.5005
R9678 VSS.n346 VSS.n495 8.5005
R9679 VSS.n346 VSS.n494 8.5005
R9680 VSS.n346 VSS.n492 8.5005
R9681 VSS.n346 VSS.n491 8.5005
R9682 VSS.n346 VSS.n490 8.5005
R9683 VSS.n346 VSS.n489 8.5005
R9684 VSS.n346 VSS.n486 8.5005
R9685 VSS.n346 VSS.n484 8.5005
R9686 VSS.n346 VSS.n483 8.5005
R9687 VSS.n346 VSS.n481 8.5005
R9688 VSS.n346 VSS.n480 8.5005
R9689 VSS.n346 VSS.n478 8.5005
R9690 VSS.n346 VSS.n477 8.5005
R9691 VSS.n346 VSS.n476 8.5005
R9692 VSS.n346 VSS.n475 8.5005
R9693 VSS.n346 VSS.n473 8.5005
R9694 VSS.n346 VSS.n471 8.5005
R9695 VSS.n346 VSS.n470 8.5005
R9696 VSS.n346 VSS.n468 8.5005
R9697 VSS.n346 VSS.n467 8.5005
R9698 VSS.n346 VSS.n465 8.5005
R9699 VSS.n346 VSS.n464 8.5005
R9700 VSS.n346 VSS.n463 8.5005
R9701 VSS.n346 VSS.n462 8.5005
R9702 VSS.n346 VSS.n460 8.5005
R9703 VSS.n346 VSS.n458 8.5005
R9704 VSS.n346 VSS.n457 8.5005
R9705 VSS.n346 VSS.n454 8.5005
R9706 VSS.n346 VSS.n453 8.5005
R9707 VSS.n346 VSS.n451 8.5005
R9708 VSS.n346 VSS.n450 8.5005
R9709 VSS.n346 VSS.n449 8.5005
R9710 VSS.n346 VSS.n448 8.5005
R9711 VSS.n346 VSS.n446 8.5005
R9712 VSS.n346 VSS.n444 8.5005
R9713 VSS.n346 VSS.n443 8.5005
R9714 VSS.n346 VSS.n441 8.5005
R9715 VSS.n346 VSS.n440 8.5005
R9716 VSS.n346 VSS.n438 8.5005
R9717 VSS.n346 VSS.n437 8.5005
R9718 VSS.n346 VSS.n436 8.5005
R9719 VSS.n346 VSS.n435 8.5005
R9720 VSS.n346 VSS.n433 8.5005
R9721 VSS.n346 VSS.n431 8.5005
R9722 VSS.n346 VSS.n430 8.5005
R9723 VSS.n346 VSS.n427 8.5005
R9724 VSS.n346 VSS.n426 8.5005
R9725 VSS.n346 VSS.n424 8.5005
R9726 VSS.n346 VSS.n423 8.5005
R9727 VSS.n346 VSS.n422 8.5005
R9728 VSS.n346 VSS.n421 8.5005
R9729 VSS.n346 VSS.n418 8.5005
R9730 VSS.n346 VSS.n416 8.5005
R9731 VSS.n346 VSS.n415 8.5005
R9732 VSS.n346 VSS.n412 8.5005
R9733 VSS.n346 VSS.n411 8.5005
R9734 VSS.n346 VSS.n409 8.5005
R9735 VSS.n346 VSS.n408 8.5005
R9736 VSS.n346 VSS.n407 8.5005
R9737 VSS.n346 VSS.n406 8.5005
R9738 VSS.n346 VSS.n404 8.5005
R9739 VSS.n346 VSS.n402 8.5005
R9740 VSS.n346 VSS.n400 8.5005
R9741 VSS.n346 VSS.n398 8.5005
R9742 VSS.n346 VSS.n395 8.5005
R9743 VSS.n346 VSS.n394 8.5005
R9744 VSS.n346 VSS.n393 8.5005
R9745 VSS.n346 VSS.n392 8.5005
R9746 VSS.n346 VSS.n391 8.5005
R9747 VSS.n346 VSS.n389 8.5005
R9748 VSS.n346 VSS.n387 8.5005
R9749 VSS.n346 VSS.n386 8.5005
R9750 VSS.n346 VSS.n383 8.5005
R9751 VSS.n346 VSS.n382 8.5005
R9752 VSS.n346 VSS.n380 8.5005
R9753 VSS.n346 VSS.n379 8.5005
R9754 VSS.n346 VSS.n378 8.5005
R9755 VSS.n346 VSS.n377 8.5005
R9756 VSS.n346 VSS.n375 8.5005
R9757 VSS.n346 VSS.n373 8.5005
R9758 VSS.n346 VSS.n372 8.5005
R9759 VSS.n346 VSS.n370 8.5005
R9760 VSS.n346 VSS.n369 8.5005
R9761 VSS.n346 VSS.n367 8.5005
R9762 VSS.n346 VSS.n366 8.5005
R9763 VSS.n346 VSS.n365 8.5005
R9764 VSS.n346 VSS.n364 8.5005
R9765 VSS.n346 VSS.n362 8.5005
R9766 VSS.n346 VSS.n360 8.5005
R9767 VSS.n346 VSS.n359 8.5005
R9768 VSS.n346 VSS.n356 8.5005
R9769 VSS.n346 VSS.n355 8.5005
R9770 VSS.n346 VSS.n353 8.5005
R9771 VSS.n346 VSS.n352 8.5005
R9772 VSS.n346 VSS.n351 8.5005
R9773 VSS.n346 VSS.n350 8.5005
R9774 VSS.n151 VSS.n849 8.5005
R9775 VSS.n151 VSS.n850 8.5005
R9776 VSS.n151 VSS.n1033 8.5005
R9777 VSS.n151 VSS.n854 8.5005
R9778 VSS.n151 VSS.n855 8.5005
R9779 VSS.n151 VSS.n1032 8.5005
R9780 VSS.n151 VSS.n856 8.5005
R9781 VSS.n151 VSS.n1031 8.5005
R9782 VSS.n151 VSS.n857 8.5005
R9783 VSS.n151 VSS.n1030 8.5005
R9784 VSS.n151 VSS.n858 8.5005
R9785 VSS.n151 VSS.n1029 8.5005
R9786 VSS.n151 VSS.n861 8.5005
R9787 VSS.n151 VSS.n862 8.5005
R9788 VSS.n151 VSS.n1028 8.5005
R9789 VSS.n151 VSS.n863 8.5005
R9790 VSS.n151 VSS.n1027 8.5005
R9791 VSS.n151 VSS.n864 8.5005
R9792 VSS.n151 VSS.n1026 8.5005
R9793 VSS.n151 VSS.n865 8.5005
R9794 VSS.n151 VSS.n1025 8.5005
R9795 VSS.n151 VSS.n868 8.5005
R9796 VSS.n151 VSS.n869 8.5005
R9797 VSS.n151 VSS.n1024 8.5005
R9798 VSS.n151 VSS.n870 8.5005
R9799 VSS.n151 VSS.n1023 8.5005
R9800 VSS.n151 VSS.n871 8.5005
R9801 VSS.n151 VSS.n1022 8.5005
R9802 VSS.n151 VSS.n872 8.5005
R9803 VSS.n151 VSS.n1021 8.5005
R9804 VSS.n151 VSS.n875 8.5005
R9805 VSS.n151 VSS.n876 8.5005
R9806 VSS.n151 VSS.n1020 8.5005
R9807 VSS.n151 VSS.n877 8.5005
R9808 VSS.n151 VSS.n1019 8.5005
R9809 VSS.n151 VSS.n878 8.5005
R9810 VSS.n151 VSS.n1018 8.5005
R9811 VSS.n151 VSS.n879 8.5005
R9812 VSS.n151 VSS.n1017 8.5005
R9813 VSS.n151 VSS.n882 8.5005
R9814 VSS.n151 VSS.n883 8.5005
R9815 VSS.n151 VSS.n1016 8.5005
R9816 VSS.n151 VSS.n884 8.5005
R9817 VSS.n151 VSS.n1015 8.5005
R9818 VSS.n151 VSS.n885 8.5005
R9819 VSS.n151 VSS.n1014 8.5005
R9820 VSS.n151 VSS.n886 8.5005
R9821 VSS.n151 VSS.n1013 8.5005
R9822 VSS.n151 VSS.n889 8.5005
R9823 VSS.n151 VSS.n890 8.5005
R9824 VSS.n151 VSS.n1012 8.5005
R9825 VSS.n151 VSS.n891 8.5005
R9826 VSS.n151 VSS.n1011 8.5005
R9827 VSS.n151 VSS.n892 8.5005
R9828 VSS.n151 VSS.n1010 8.5005
R9829 VSS.n151 VSS.n893 8.5005
R9830 VSS.n151 VSS.n1008 8.5005
R9831 VSS.n151 VSS.n896 8.5005
R9832 VSS.n151 VSS.n897 8.5005
R9833 VSS.n151 VSS.n1007 8.5005
R9834 VSS.n151 VSS.n898 8.5005
R9835 VSS.n151 VSS.n1006 8.5005
R9836 VSS.n151 VSS.n899 8.5005
R9837 VSS.n151 VSS.n1005 8.5005
R9838 VSS.n151 VSS.n900 8.5005
R9839 VSS.n151 VSS.n1004 8.5005
R9840 VSS.n151 VSS.n903 8.5005
R9841 VSS.n151 VSS.n904 8.5005
R9842 VSS.n151 VSS.n1003 8.5005
R9843 VSS.n151 VSS.n905 8.5005
R9844 VSS.n151 VSS.n1002 8.5005
R9845 VSS.n151 VSS.n906 8.5005
R9846 VSS.n151 VSS.n1001 8.5005
R9847 VSS.n151 VSS.n907 8.5005
R9848 VSS.n151 VSS.n1000 8.5005
R9849 VSS.n151 VSS.n910 8.5005
R9850 VSS.n151 VSS.n911 8.5005
R9851 VSS.n151 VSS.n999 8.5005
R9852 VSS.n151 VSS.n912 8.5005
R9853 VSS.n151 VSS.n998 8.5005
R9854 VSS.n151 VSS.n913 8.5005
R9855 VSS.n151 VSS.n997 8.5005
R9856 VSS.n151 VSS.n914 8.5005
R9857 VSS.n151 VSS.n996 8.5005
R9858 VSS.n151 VSS.n917 8.5005
R9859 VSS.n151 VSS.n918 8.5005
R9860 VSS.n151 VSS.n995 8.5005
R9861 VSS.n151 VSS.n919 8.5005
R9862 VSS.n151 VSS.n994 8.5005
R9863 VSS.n151 VSS.n920 8.5005
R9864 VSS.n151 VSS.n993 8.5005
R9865 VSS.n151 VSS.n921 8.5005
R9866 VSS.n151 VSS.n992 8.5005
R9867 VSS.n151 VSS.n924 8.5005
R9868 VSS.n151 VSS.n925 8.5005
R9869 VSS.n151 VSS.n991 8.5005
R9870 VSS.n151 VSS.n926 8.5005
R9871 VSS.n151 VSS.n990 8.5005
R9872 VSS.n151 VSS.n927 8.5005
R9873 VSS.n151 VSS.n989 8.5005
R9874 VSS.n151 VSS.n928 8.5005
R9875 VSS.n151 VSS.n988 8.5005
R9876 VSS.n151 VSS.n931 8.5005
R9877 VSS.n151 VSS.n932 8.5005
R9878 VSS.n151 VSS.n987 8.5005
R9879 VSS.n151 VSS.n933 8.5005
R9880 VSS.n151 VSS.n986 8.5005
R9881 VSS.n151 VSS.n934 8.5005
R9882 VSS.n151 VSS.n985 8.5005
R9883 VSS.n151 VSS.n935 8.5005
R9884 VSS.n151 VSS.n984 8.5005
R9885 VSS.n151 VSS.n939 8.5005
R9886 VSS.n151 VSS.n940 8.5005
R9887 VSS.n151 VSS.n983 8.5005
R9888 VSS.n151 VSS.n942 8.5005
R9889 VSS.n151 VSS.n982 8.5005
R9890 VSS.n151 VSS.n943 8.5005
R9891 VSS.n151 VSS.n981 8.5005
R9892 VSS.n151 VSS.n944 8.5005
R9893 VSS.n151 VSS.n980 8.5005
R9894 VSS.n151 VSS.n947 8.5005
R9895 VSS.n151 VSS.n948 8.5005
R9896 VSS.n151 VSS.n979 8.5005
R9897 VSS.n151 VSS.n949 8.5005
R9898 VSS.n151 VSS.n978 8.5005
R9899 VSS.n151 VSS.n950 8.5005
R9900 VSS.n151 VSS.n977 8.5005
R9901 VSS.n151 VSS.n951 8.5005
R9902 VSS.n151 VSS.n976 8.5005
R9903 VSS.n151 VSS.n954 8.5005
R9904 VSS.n151 VSS.n955 8.5005
R9905 VSS.n151 VSS.n975 8.5005
R9906 VSS.n151 VSS.n956 8.5005
R9907 VSS.n151 VSS.n974 8.5005
R9908 VSS.n151 VSS.n957 8.5005
R9909 VSS.n151 VSS.n973 8.5005
R9910 VSS.n151 VSS.n958 8.5005
R9911 VSS.n151 VSS.n972 8.5005
R9912 VSS.n151 VSS.n961 8.5005
R9913 VSS.n151 VSS.n962 8.5005
R9914 VSS.n151 VSS.n971 8.5005
R9915 VSS.n151 VSS.n963 8.5005
R9916 VSS.n151 VSS.n970 8.5005
R9917 VSS.n151 VSS.n964 8.5005
R9918 VSS.n151 VSS.n969 8.5005
R9919 VSS.n151 VSS.n967 8.5005
R9920 VSS.n3315 VSS.n3029 8.5005
R9921 VSS.n3315 VSS.n3031 8.5005
R9922 VSS.n3315 VSS.n3309 8.5005
R9923 VSS.n3315 VSS.n3035 8.5005
R9924 VSS.n3315 VSS.n3036 8.5005
R9925 VSS.n3315 VSS.n3306 8.5005
R9926 VSS.n3315 VSS.n3037 8.5005
R9927 VSS.n3315 VSS.n3305 8.5005
R9928 VSS.n3315 VSS.n3038 8.5005
R9929 VSS.n3315 VSS.n3304 8.5005
R9930 VSS.n3315 VSS.n3039 8.5005
R9931 VSS.n3315 VSS.n3301 8.5005
R9932 VSS.n3315 VSS.n3042 8.5005
R9933 VSS.n3315 VSS.n3043 8.5005
R9934 VSS.n3315 VSS.n3297 8.5005
R9935 VSS.n3315 VSS.n3044 8.5005
R9936 VSS.n3315 VSS.n3296 8.5005
R9937 VSS.n3315 VSS.n3045 8.5005
R9938 VSS.n3315 VSS.n3295 8.5005
R9939 VSS.n3315 VSS.n3047 8.5005
R9940 VSS.n3315 VSS.n3293 8.5005
R9941 VSS.n3315 VSS.n3051 8.5005
R9942 VSS.n3315 VSS.n3052 8.5005
R9943 VSS.n3315 VSS.n3290 8.5005
R9944 VSS.n3315 VSS.n3053 8.5005
R9945 VSS.n3315 VSS.n3289 8.5005
R9946 VSS.n3315 VSS.n3054 8.5005
R9947 VSS.n3315 VSS.n3288 8.5005
R9948 VSS.n3315 VSS.n3056 8.5005
R9949 VSS.n3315 VSS.n3286 8.5005
R9950 VSS.n3315 VSS.n3059 8.5005
R9951 VSS.n3315 VSS.n3060 8.5005
R9952 VSS.n3315 VSS.n3282 8.5005
R9953 VSS.n3315 VSS.n3061 8.5005
R9954 VSS.n3315 VSS.n3281 8.5005
R9955 VSS.n3315 VSS.n3062 8.5005
R9956 VSS.n3315 VSS.n3280 8.5005
R9957 VSS.n3315 VSS.n3063 8.5005
R9958 VSS.n3315 VSS.n3277 8.5005
R9959 VSS.n3315 VSS.n3066 8.5005
R9960 VSS.n3315 VSS.n3067 8.5005
R9961 VSS.n3315 VSS.n3273 8.5005
R9962 VSS.n3315 VSS.n3068 8.5005
R9963 VSS.n3315 VSS.n3272 8.5005
R9964 VSS.n3315 VSS.n3069 8.5005
R9965 VSS.n3315 VSS.n3271 8.5005
R9966 VSS.n3315 VSS.n3071 8.5005
R9967 VSS.n3315 VSS.n3269 8.5005
R9968 VSS.n3315 VSS.n3075 8.5005
R9969 VSS.n3315 VSS.n3076 8.5005
R9970 VSS.n3315 VSS.n3266 8.5005
R9971 VSS.n3315 VSS.n3077 8.5005
R9972 VSS.n3315 VSS.n3265 8.5005
R9973 VSS.n3315 VSS.n3078 8.5005
R9974 VSS.n3315 VSS.n3264 8.5005
R9975 VSS.n3315 VSS.n3080 8.5005
R9976 VSS.n3315 VSS.n3261 8.5005
R9977 VSS.n3315 VSS.n3083 8.5005
R9978 VSS.n3315 VSS.n3084 8.5005
R9979 VSS.n3315 VSS.n3257 8.5005
R9980 VSS.n3315 VSS.n3085 8.5005
R9981 VSS.n3315 VSS.n3256 8.5005
R9982 VSS.n3315 VSS.n3086 8.5005
R9983 VSS.n3315 VSS.n3255 8.5005
R9984 VSS.n3315 VSS.n3087 8.5005
R9985 VSS.n3315 VSS.n3252 8.5005
R9986 VSS.n3315 VSS.n3090 8.5005
R9987 VSS.n3315 VSS.n3092 8.5005
R9988 VSS.n3315 VSS.n3249 8.5005
R9989 VSS.n3315 VSS.n3093 8.5005
R9990 VSS.n3315 VSS.n3248 8.5005
R9991 VSS.n3315 VSS.n3094 8.5005
R9992 VSS.n3315 VSS.n3247 8.5005
R9993 VSS.n3315 VSS.n3096 8.5005
R9994 VSS.n3315 VSS.n3245 8.5005
R9995 VSS.n3315 VSS.n3100 8.5005
R9996 VSS.n3315 VSS.n3101 8.5005
R9997 VSS.n3315 VSS.n3242 8.5005
R9998 VSS.n3315 VSS.n3102 8.5005
R9999 VSS.n3315 VSS.n3241 8.5005
R10000 VSS.n3315 VSS.n3103 8.5005
R10001 VSS.n3315 VSS.n3240 8.5005
R10002 VSS.n3315 VSS.n3105 8.5005
R10003 VSS.n3315 VSS.n3238 8.5005
R10004 VSS.n3315 VSS.n3108 8.5005
R10005 VSS.n3315 VSS.n3109 8.5005
R10006 VSS.n3315 VSS.n3234 8.5005
R10007 VSS.n3315 VSS.n3110 8.5005
R10008 VSS.n3315 VSS.n3233 8.5005
R10009 VSS.n3315 VSS.n3111 8.5005
R10010 VSS.n3315 VSS.n3232 8.5005
R10011 VSS.n3315 VSS.n3112 8.5005
R10012 VSS.n3315 VSS.n3229 8.5005
R10013 VSS.n3315 VSS.n3115 8.5005
R10014 VSS.n3315 VSS.n3117 8.5005
R10015 VSS.n3315 VSS.n3226 8.5005
R10016 VSS.n3315 VSS.n3118 8.5005
R10017 VSS.n3315 VSS.n3225 8.5005
R10018 VSS.n3315 VSS.n3119 8.5005
R10019 VSS.n3315 VSS.n3224 8.5005
R10020 VSS.n3315 VSS.n3120 8.5005
R10021 VSS.n3315 VSS.n3221 8.5005
R10022 VSS.n3315 VSS.n3124 8.5005
R10023 VSS.n3315 VSS.n3126 8.5005
R10024 VSS.n3315 VSS.n3219 8.5005
R10025 VSS.n3315 VSS.n3127 8.5005
R10026 VSS.n3315 VSS.n3218 8.5005
R10027 VSS.n3315 VSS.n3128 8.5005
R10028 VSS.n3315 VSS.n3217 8.5005
R10029 VSS.n3315 VSS.n3130 8.5005
R10030 VSS.n3315 VSS.n3215 8.5005
R10031 VSS.n3315 VSS.n3134 8.5005
R10032 VSS.n3315 VSS.n3135 8.5005
R10033 VSS.n3315 VSS.n3211 8.5005
R10034 VSS.n3315 VSS.n3137 8.5005
R10035 VSS.n3315 VSS.n3210 8.5005
R10036 VSS.n3315 VSS.n3138 8.5005
R10037 VSS.n3315 VSS.n3209 8.5005
R10038 VSS.n3315 VSS.n3139 8.5005
R10039 VSS.n3315 VSS.n3206 8.5005
R10040 VSS.n3315 VSS.n3142 8.5005
R10041 VSS.n3315 VSS.n3144 8.5005
R10042 VSS.n3315 VSS.n3203 8.5005
R10043 VSS.n3315 VSS.n3145 8.5005
R10044 VSS.n3315 VSS.n3202 8.5005
R10045 VSS.n3315 VSS.n3146 8.5005
R10046 VSS.n3315 VSS.n3201 8.5005
R10047 VSS.n3315 VSS.n3147 8.5005
R10048 VSS.n3315 VSS.n3198 8.5005
R10049 VSS.n3315 VSS.n3151 8.5005
R10050 VSS.n3315 VSS.n3153 8.5005
R10051 VSS.n3315 VSS.n3196 8.5005
R10052 VSS.n3315 VSS.n3154 8.5005
R10053 VSS.n3315 VSS.n3195 8.5005
R10054 VSS.n3315 VSS.n3155 8.5005
R10055 VSS.n3315 VSS.n3194 8.5005
R10056 VSS.n3315 VSS.n3156 8.5005
R10057 VSS.n3315 VSS.n3191 8.5005
R10058 VSS.n3315 VSS.n3159 8.5005
R10059 VSS.n3315 VSS.n3160 8.5005
R10060 VSS.n3315 VSS.n3187 8.5005
R10061 VSS.n3315 VSS.n3161 8.5005
R10062 VSS.n3315 VSS.n3186 8.5005
R10063 VSS.n3315 VSS.n3162 8.5005
R10064 VSS.n3315 VSS.n3185 8.5005
R10065 VSS.n3315 VSS.n3183 8.5005
R10066 VSS.n3315 VSS.n3166 8.5005
R10067 VSS.n2865 VSS.n45 8.5005
R10068 VSS.n1639 VSS.n1291 8.5005
R10069 VSS.n1639 VSS.n1295 8.5005
R10070 VSS.n1639 VSS.n1297 8.5005
R10071 VSS.n1639 VSS.n1300 8.5005
R10072 VSS.n1639 VSS.n1303 8.5005
R10073 VSS.n1639 VSS.n1304 8.5005
R10074 VSS.n1639 VSS.n1305 8.5005
R10075 VSS.n1639 VSS.n1307 8.5005
R10076 VSS.n1639 VSS.n1308 8.5005
R10077 VSS.n1639 VSS.n1309 8.5005
R10078 VSS.n1639 VSS.n1312 8.5005
R10079 VSS.n1639 VSS.n1313 8.5005
R10080 VSS.n1639 VSS.n1316 8.5005
R10081 VSS.n1639 VSS.n1319 8.5005
R10082 VSS.n1639 VSS.n1320 8.5005
R10083 VSS.n1639 VSS.n1321 8.5005
R10084 VSS.n1639 VSS.n1322 8.5005
R10085 VSS.n1639 VSS.n1323 8.5005
R10086 VSS.n1639 VSS.n1325 8.5005
R10087 VSS.n1639 VSS.n1328 8.5005
R10088 VSS.n1639 VSS.n1329 8.5005
R10089 VSS.n1639 VSS.n1331 8.5005
R10090 VSS.n1639 VSS.n1335 8.5005
R10091 VSS.n1639 VSS.n1336 8.5005
R10092 VSS.n1639 VSS.n1337 8.5005
R10093 VSS.n1639 VSS.n1338 8.5005
R10094 VSS.n1639 VSS.n1339 8.5005
R10095 VSS.n1639 VSS.n1341 8.5005
R10096 VSS.n1639 VSS.n1344 8.5005
R10097 VSS.n1639 VSS.n1345 8.5005
R10098 VSS.n1639 VSS.n1347 8.5005
R10099 VSS.n1639 VSS.n1351 8.5005
R10100 VSS.n1639 VSS.n1352 8.5005
R10101 VSS.n1639 VSS.n1353 8.5005
R10102 VSS.n1639 VSS.n1354 8.5005
R10103 VSS.n1639 VSS.n1355 8.5005
R10104 VSS.n1639 VSS.n1357 8.5005
R10105 VSS.n1639 VSS.n1360 8.5005
R10106 VSS.n1639 VSS.n1361 8.5005
R10107 VSS.n1639 VSS.n1363 8.5005
R10108 VSS.n1639 VSS.n1367 8.5005
R10109 VSS.n1639 VSS.n1368 8.5005
R10110 VSS.n1639 VSS.n1369 8.5005
R10111 VSS.n1639 VSS.n1370 8.5005
R10112 VSS.n1639 VSS.n1372 8.5005
R10113 VSS.n1639 VSS.n1373 8.5005
R10114 VSS.n1639 VSS.n1376 8.5005
R10115 VSS.n1639 VSS.n1377 8.5005
R10116 VSS.n1639 VSS.n1380 8.5005
R10117 VSS.n1639 VSS.n1383 8.5005
R10118 VSS.n1639 VSS.n1384 8.5005
R10119 VSS.n1639 VSS.n1385 8.5005
R10120 VSS.n1639 VSS.n1387 8.5005
R10121 VSS.n1639 VSS.n1388 8.5005
R10122 VSS.n1639 VSS.n1389 8.5005
R10123 VSS.n1639 VSS.n1392 8.5005
R10124 VSS.n1639 VSS.n1396 8.5005
R10125 VSS.n1639 VSS.n1400 8.5005
R10126 VSS.n1639 VSS.n1401 8.5005
R10127 VSS.n1639 VSS.n1402 8.5005
R10128 VSS.n1639 VSS.n1403 8.5005
R10129 VSS.n1639 VSS.n1404 8.5005
R10130 VSS.n1639 VSS.n1406 8.5005
R10131 VSS.n1639 VSS.n1409 8.5005
R10132 VSS.n1639 VSS.n1410 8.5005
R10133 VSS.n1639 VSS.n1412 8.5005
R10134 VSS.n1639 VSS.n1416 8.5005
R10135 VSS.n1639 VSS.n1417 8.5005
R10136 VSS.n1639 VSS.n1418 8.5005
R10137 VSS.n1639 VSS.n1419 8.5005
R10138 VSS.n1639 VSS.n1420 8.5005
R10139 VSS.n1639 VSS.n1422 8.5005
R10140 VSS.n1639 VSS.n1425 8.5005
R10141 VSS.n1639 VSS.n1426 8.5005
R10142 VSS.n1639 VSS.n1429 8.5005
R10143 VSS.n1639 VSS.n1432 8.5005
R10144 VSS.n1639 VSS.n1433 8.5005
R10145 VSS.n1639 VSS.n1434 8.5005
R10146 VSS.n1639 VSS.n1435 8.5005
R10147 VSS.n1639 VSS.n1437 8.5005
R10148 VSS.n1639 VSS.n1438 8.5005
R10149 VSS.n1639 VSS.n1441 8.5005
R10150 VSS.n1639 VSS.n1442 8.5005
R10151 VSS.n1639 VSS.n1445 8.5005
R10152 VSS.n1639 VSS.n1448 8.5005
R10153 VSS.n1639 VSS.n1449 8.5005
R10154 VSS.n1639 VSS.n1450 8.5005
R10155 VSS.n1639 VSS.n1451 8.5005
R10156 VSS.n1639 VSS.n1452 8.5005
R10157 VSS.n1639 VSS.n1454 8.5005
R10158 VSS.n1639 VSS.n1457 8.5005
R10159 VSS.n1639 VSS.n1458 8.5005
R10160 VSS.n1639 VSS.n1460 8.5005
R10161 VSS.n1639 VSS.n1464 8.5005
R10162 VSS.n1639 VSS.n1465 8.5005
R10163 VSS.n1639 VSS.n1466 8.5005
R10164 VSS.n1639 VSS.n1467 8.5005
R10165 VSS.n1639 VSS.n1468 8.5005
R10166 VSS.n1639 VSS.n1470 8.5005
R10167 VSS.n1639 VSS.n1473 8.5005
R10168 VSS.n1639 VSS.n1474 8.5005
R10169 VSS.n1639 VSS.n1476 8.5005
R10170 VSS.n1639 VSS.n1480 8.5005
R10171 VSS.n1639 VSS.n1481 8.5005
R10172 VSS.n1639 VSS.n1482 8.5005
R10173 VSS.n1639 VSS.n1483 8.5005
R10174 VSS.n1639 VSS.n1484 8.5005
R10175 VSS.n1639 VSS.n1486 8.5005
R10176 VSS.n1639 VSS.n1489 8.5005
R10177 VSS.n1639 VSS.n1490 8.5005
R10178 VSS.n1639 VSS.n1493 8.5005
R10179 VSS.n1639 VSS.n1496 8.5005
R10180 VSS.n1639 VSS.n1499 8.5005
R10181 VSS.n1639 VSS.n1500 8.5005
R10182 VSS.n1639 VSS.n1501 8.5005
R10183 VSS.n1639 VSS.n1503 8.5005
R10184 VSS.n1639 VSS.n1506 8.5005
R10185 VSS.n1639 VSS.n1507 8.5005
R10186 VSS.n1639 VSS.n1509 8.5005
R10187 VSS.n1639 VSS.n1513 8.5005
R10188 VSS.n1639 VSS.n1514 8.5005
R10189 VSS.n1639 VSS.n1515 8.5005
R10190 VSS.n1639 VSS.n1516 8.5005
R10191 VSS.n1639 VSS.n1518 8.5005
R10192 VSS.n1639 VSS.n1519 8.5005
R10193 VSS.n1639 VSS.n1522 8.5005
R10194 VSS.n1639 VSS.n1523 8.5005
R10195 VSS.n1639 VSS.n1526 8.5005
R10196 VSS.n1639 VSS.n1529 8.5005
R10197 VSS.n1639 VSS.n1530 8.5005
R10198 VSS.n1639 VSS.n1531 8.5005
R10199 VSS.n1639 VSS.n1532 8.5005
R10200 VSS.n1639 VSS.n1533 8.5005
R10201 VSS.n1639 VSS.n1535 8.5005
R10202 VSS.n1639 VSS.n1538 8.5005
R10203 VSS.n1639 VSS.n1539 8.5005
R10204 VSS.n1639 VSS.n1541 8.5005
R10205 VSS.n1639 VSS.n1545 8.5005
R10206 VSS.n1639 VSS.n1546 8.5005
R10207 VSS.n1639 VSS.n1547 8.5005
R10208 VSS.n1639 VSS.n1548 8.5005
R10209 VSS.n1639 VSS.n1549 8.5005
R10210 VSS.n1639 VSS.n1550 8.5005
R10211 VSS.n1639 VSS.n1599 8.5005
R10212 VSS.n1639 VSS.n1584 8.5005
R10213 VSS.n2949 VSS.n1 8.5005
R10214 VSS.n2946 VSS.n1 8.5005
R10215 VSS.n346 VSS.n343 8.49944
R10216 VSS.n3315 VSS.n1185 8.49944
R10217 VSS.n2243 VSS.n19 8.49913
R10218 VSS.n2158 VSS.n94 8.49109
R10219 VSS.n2963 VSS.n1 8.48883
R10220 VSS.n2174 VSS.n1 8.48883
R10221 VSS.n2938 VSS.n19 8.48385
R10222 VSS.n151 VSS.n965 8.48012
R10223 VSS.n3315 VSS.n3167 8.48012
R10224 VSS.t834 VSS.n100 8.47784
R10225 VSS.n2991 VSS.n2147 8.47784
R10226 VSS.n2992 VSS.n101 8.47784
R10227 VSS.n2993 VSS.n103 8.47784
R10228 VSS.n2994 VSS.n104 8.47784
R10229 VSS.n2995 VSS.n2146 8.47784
R10230 VSS.n2996 VSS.n105 8.47784
R10231 VSS.n2997 VSS.n107 8.47784
R10232 VSS.n2998 VSS.n108 8.47784
R10233 VSS.n3003 VSS.n110 8.47784
R10234 VSS.n2140 VSS.n2141 8.47784
R10235 VSS.n111 VSS.t818 8.47784
R10236 VSS.n3009 VSS.n1938 8.47732
R10237 VSS.n3009 VSS.n1941 8.47732
R10238 VSS.n3009 VSS.n1991 8.47732
R10239 VSS.n127 VSS.n1646 8.47732
R10240 VSS.n127 VSS.n1668 8.47732
R10241 VSS.n127 VSS.n1771 8.47732
R10242 VSS.n127 VSS.t2101 8.47732
R10243 VSS.n127 VSS.t503 8.47732
R10244 VSS.n2762 VSS.n2751 8.47732
R10245 VSS.n2749 VSS.n2750 8.47732
R10246 VSS.n2730 VSS.n2397 8.47732
R10247 VSS.n346 VSS.n574 8.47732
R10248 VSS.n346 VSS.n340 8.47732
R10249 VSS.n346 VSS.n326 8.47732
R10250 VSS.n346 VSS.n295 8.47732
R10251 VSS.n346 VSS.n260 8.47732
R10252 VSS.n346 VSS.n572 8.47732
R10253 VSS.n346 VSS.n485 8.47732
R10254 VSS.n346 VSS.t1225 8.47732
R10255 VSS.n346 VSS.t562 8.47732
R10256 VSS.n151 VSS.n1039 8.47732
R10257 VSS.n151 VSS.n1037 8.47732
R10258 VSS.n151 VSS.n894 8.47732
R10259 VSS.n151 VSS.t1562 8.47732
R10260 VSS.n151 VSS.t550 8.47732
R10261 VSS.n150 VSS.n149 4.19564
R10262 VSS.n151 VSS.n845 8.47732
R10263 VSS.n151 VSS.n844 8.47732
R10264 VSS.n151 VSS.n837 8.47732
R10265 VSS.n151 VSS.n822 8.47732
R10266 VSS.n151 VSS.n806 8.47732
R10267 VSS.n3315 VSS.n3314 8.47732
R10268 VSS.n3315 VSS.n3081 8.47732
R10269 VSS.n3315 VSS.t169 8.47732
R10270 VSS.n3315 VSS.t537 8.47732
R10271 VSS.n3168 VSS.n129 8.47732
R10272 VSS.n130 VSS.n3169 8.47732
R10273 VSS.n3315 VSS.n1183 8.47732
R10274 VSS.n3315 VSS.n1182 8.47732
R10275 VSS.n3315 VSS.n1174 8.47732
R10276 VSS.n3315 VSS.n1159 8.47732
R10277 VSS.n3315 VSS.n1142 8.47732
R10278 VSS.n3315 VSS.n1187 8.47732
R10279 VSS.n2220 VSS.n45 8.47732
R10280 VSS.n2214 VSS.n45 8.47732
R10281 VSS.n2213 VSS.n45 8.47732
R10282 VSS.n127 VSS.n1648 8.47732
R10283 VSS.n1639 VSS.n1290 8.47732
R10284 VSS.n1639 VSS.n1394 8.47732
R10285 VSS.n1639 VSS.n1498 8.47732
R10286 VSS.n1639 VSS.n1552 8.47732
R10287 VSS.n1639 VSS.n1617 8.47732
R10288 VSS.n1639 VSS.n1598 8.47732
R10289 VSS.n1639 VSS.t2050 8.47732
R10290 VSS.n1639 VSS.t492 8.47732
R10291 VSS.n1639 VSS.n1633 8.47732
R10292 VSS.n2169 VSS.n1 8.47732
R10293 VSS.n2164 VSS.n1 8.47732
R10294 VSS.n2159 VSS.n1 8.47732
R10295 VSS.n1 VSS.n0 8.47732
R10296 VSS.n2956 VSS.n1 8.47732
R10297 VSS.n2960 VSS.n1 8.47732
R10298 VSS.n2888 VSS.n61 8.47732
R10299 VSS.n2888 VSS.n5 0.332521
R10300 VSS.n2889 VSS.n63 8.47732
R10301 VSS.n2891 VSS.n65 8.47732
R10302 VSS.n8 VSS.n7 3.32623
R10303 VSS.n2893 VSS.n2319 8.47732
R10304 VSS.n2893 VSS.n10 0.332521
R10305 VSS.n2894 VSS.n68 8.47732
R10306 VSS.n2895 VSS.n69 8.47732
R10307 VSS.n12 VSS.n11 3.32623
R10308 VSS.n2317 VSS.n2313 8.47732
R10309 VSS.n47 VSS.t517 8.47732
R10310 VSS.t50 VSS.n48 8.47732
R10311 VSS.n2212 VSS.n49 8.47732
R10312 VSS.n2921 VSS.n50 8.47732
R10313 VSS.n2211 VSS.n51 8.47732
R10314 VSS.t51 VSS.n15 8.47732
R10315 VSS.t51 VSS.n17 0.332521
R10316 VSS.n17 VSS.n18 0.42774
R10317 VSS.n18 VSS.n13 4.19225
R10318 VSS.n52 VSS.n2210 8.47732
R10319 VSS.t55 VSS.n56 8.47732
R10320 VSS.n2925 VSS.n55 8.47732
R10321 VSS.n2926 VSS.n57 8.47732
R10322 VSS.n2206 VSS.n58 8.47732
R10323 VSS.n37 VSS.n36 4.19225
R10324 VSS.n2204 VSS.n19 8.47732
R10325 VSS.t511 VSS.n80 8.47732
R10326 VSS.n81 VSS.n2222 8.47732
R10327 VSS.n2902 VSS.n82 8.47732
R10328 VSS.n2903 VSS.n84 8.47732
R10329 VSS.n2904 VSS.n85 8.47732
R10330 VSS.n2905 VSS.n86 8.47732
R10331 VSS.n2905 VSS.n25 0.423674
R10332 VSS.t47 VSS.n88 8.47732
R10333 VSS.n2906 VSS.n21 8.47732
R10334 VSS.n2906 VSS.n38 0.286042
R10335 VSS.n38 VSS.n22 4.19225
R10336 VSS.n39 VSS.n30 3.32623
R10337 VSS.n2907 VSS.n2901 8.47732
R10338 VSS.n40 VSS.n28 3.32623
R10339 VSS.n34 VSS.n2247 8.47732
R10340 VSS.n2244 VSS.n42 8.47732
R10341 VSS.n2245 VSS.n26 8.47732
R10342 VSS.n2240 VSS.n2239 8.47732
R10343 VSS.n2986 VSS.n2985 8.47677
R10344 VSS.n90 VSS.n89 8.47677
R10345 VSS.n2156 VSS.n92 8.47677
R10346 VSS.n2157 VSS.n93 8.47677
R10347 VSS.n2976 VSS.n95 8.47677
R10348 VSS.n2977 VSS.n2155 8.47677
R10349 VSS.n2978 VSS.n96 8.47677
R10350 VSS.n34 VSS.n2233 8.46924
R10351 VSS.n2756 VSS.n2390 6.99351
R10352 VSS.n2782 VSS.n2371 6.99351
R10353 VSS.n2797 VSS.t130 6.99351
R10354 VSS.t1181 VSS.n2381 6.97724
R10355 VSS.n2759 VSS.n2388 6.97724
R10356 VSS.n1640 VSS.n1287 6.81476
R10357 VSS.n3373 VSS.n3372 6.67719
R10358 VSS.n2917 VSS.n2916 6.67719
R10359 VSS.n2915 VSS.n2217 6.67719
R10360 VSS.n2914 VSS.n2913 6.67719
R10361 VSS.n1139 VSS.n1135 6.67719
R10362 VSS.n3320 VSS.n3319 6.67719
R10363 VSS.n3015 VSS.n3014 6.67719
R10364 VSS.t273 VSS.n2428 6.61977
R10365 VSS.t807 VSS.n2670 6.61977
R10366 VSS.t285 VSS.n2458 6.61977
R10367 VSS.n2501 VSS.t298 6.61977
R10368 VSS.n2198 VSS.n2197 6.0005
R10369 VSS.n3360 VSS.n255 5.90311
R10370 VSS.n1124 VSS.n804 5.90311
R10371 VSS.n1647 VSS.n1215 5.90311
R10372 VSS.t66 VSS.n2395 5.66778
R10373 VSS.t66 VSS.n2391 5.66778
R10374 VSS.t66 VSS.n2396 5.66778
R10375 VSS.n59 VSS.n2886 5.66778
R10376 VSS.n2983 VSS.n2152 5.66778
R10377 VSS.n3004 VSS.n2136 5.66778
R10378 VSS.n3004 VSS.n2137 5.66778
R10379 VSS.n3004 VSS.n2135 5.66778
R10380 VSS.n3004 VSS.n2138 5.66778
R10381 VSS.n109 VSS.n2142 0.00229996
R10382 VSS.n62 VSS.n4 0.00229996
R10383 VSS.n64 VSS.n2321 0.00249991
R10384 VSS.n2897 VSS.n6 5.66778
R10385 VSS.n2897 VSS.n2315 5.66778
R10386 VSS.n67 VSS.n9 0.00261099
R10387 VSS.n2897 VSS.n2896 5.66778
R10388 VSS.n2897 VSS.n2314 5.66778
R10389 VSS.n16 VSS.n14 0.00327736
R10390 VSS.n2923 VSS.n44 5.66778
R10391 VSS.n2924 VSS.n53 0.00229996
R10392 VSS.n45 VSS.n79 0.00229996
R10393 VSS.n87 VSS.n24 0.00229996
R10394 VSS.n29 VSS.n28 0.00233299
R10395 VSS.n2940 VSS.n26 5.66778
R10396 VSS.n41 VSS.n2939 0.00399966
R10397 VSS.t66 VSS.n2829 5.66767
R10398 VSS.n2238 VSS.n34 5.64619
R10399 VSS.n3315 VSS.n1184 5.63915
R10400 VSS.n151 VSS.n846 5.63915
R10401 VSS.n2981 VSS.n2980 5.63173
R10402 VSS.n2990 VSS.n2148 5.62674
R10403 VSS.n2999 VSS.n2145 5.62674
R10404 VSS.n3000 VSS.n2144 5.62674
R10405 VSS.n3001 VSS.n2143 5.62674
R10406 VSS.n3002 VSS.n2142 5.62674
R10407 VSS.t1000 VSS.n2748 5.62581
R10408 VSS.n2827 VSS.n2747 5.62581
R10409 VSS.n2729 VSS.n2746 5.62581
R10410 VSS.n2610 VSS.n2466 5.62581
R10411 VSS.n626 VSS.n629 5.62581
R10412 VSS.n2887 VSS.n60 5.62581
R10413 VSS.n2909 VSS.n45 5.62581
R10414 VSS.n2973 VSS.n1 5.62581
R10415 VSS.n5 VSS.n4 3.32623
R10416 VSS.n2890 VSS.n2321 5.62581
R10417 VSS.n2892 VSS.n2320 5.62581
R10418 VSS.n10 VSS.n9 3.32623
R10419 VSS.n2318 VSS.n2316 5.62581
R10420 VSS.n17 VSS.n16 3.32623
R10421 VSS.n2922 VSS.n2209 5.62581
R10422 VSS.n2924 VSS.n2207 5.62581
R10423 VSS.n2927 VSS.n35 5.62581
R10424 VSS.n25 VSS.n24 2.32425
R10425 VSS.n2900 VSS.n27 5.62581
R10426 VSS.n2241 VSS.n26 5.62581
R10427 VSS.n2979 VSS.n2154 5.62484
R10428 VSS.n2308 VSS.t135 5.48496
R10429 VSS.n2398 VSS.n2150 5.14882
R10430 VSS.n2744 VSS.n2399 5.14882
R10431 VSS.n2745 VSS.n2743 5.14882
R10432 VSS.n2741 VSS.n2400 5.14882
R10433 VSS.n2742 VSS.n2740 5.14882
R10434 VSS.n2738 VSS.n2401 5.14882
R10435 VSS.n2739 VSS.n2737 5.14882
R10436 VSS.n2735 VSS.n2402 5.14882
R10437 VSS.n2736 VSS.n2734 5.14882
R10438 VSS.n2732 VSS.n2403 5.14882
R10439 VSS.n2733 VSS.n2731 5.14882
R10440 VSS.n2728 VSS.n2726 5.14882
R10441 VSS.n2724 VSS.n2405 5.14882
R10442 VSS.n2725 VSS.n2723 5.14882
R10443 VSS.n2721 VSS.n2408 5.14882
R10444 VSS.n2722 VSS.n2720 5.14882
R10445 VSS.n2718 VSS.n2409 5.14882
R10446 VSS.n2719 VSS.n2717 5.14882
R10447 VSS.n2715 VSS.n2410 5.14882
R10448 VSS.n2716 VSS.n2714 5.14882
R10449 VSS.n2712 VSS.n2411 5.14882
R10450 VSS.n2713 VSS.n2711 5.14882
R10451 VSS.n2709 VSS.n2412 5.14882
R10452 VSS.n2710 VSS.n2708 5.14882
R10453 VSS.n2706 VSS.n2413 5.14882
R10454 VSS.n2707 VSS.n2705 5.14882
R10455 VSS.n2421 VSS.n2414 5.14882
R10456 VSS.n2422 VSS.n2420 5.14882
R10457 VSS.n2418 VSS.n2415 5.14882
R10458 VSS.n2419 VSS.n2417 5.14882
R10459 VSS.n2702 VSS.n2416 5.14882
R10460 VSS.n2703 VSS.n2701 5.14882
R10461 VSS.n2699 VSS.n2423 5.14882
R10462 VSS.n2700 VSS.n2698 5.14882
R10463 VSS.n2696 VSS.n2424 5.14882
R10464 VSS.n2697 VSS.n2695 5.14882
R10465 VSS.n2684 VSS.n2425 5.14882
R10466 VSS.n2686 VSS.n2685 5.14882
R10467 VSS.n2688 VSS.n2687 5.14882
R10468 VSS.n2690 VSS.n2689 5.14882
R10469 VSS.n2691 VSS.n2683 5.14882
R10470 VSS.n2681 VSS.n2428 5.14882
R10471 VSS.n2682 VSS.n2680 5.14882
R10472 VSS.n2678 VSS.n2429 5.14882
R10473 VSS.n2679 VSS.n2677 5.14882
R10474 VSS.n2675 VSS.n2430 5.14882
R10475 VSS.n2676 VSS.n2674 5.14882
R10476 VSS.n2672 VSS.n2431 5.14882
R10477 VSS.n2673 VSS.n2671 5.14882
R10478 VSS.n2670 VSS.n2433 5.14882
R10479 VSS.t277 VSS.n2434 5.14882
R10480 VSS.n2668 VSS.n2667 5.14882
R10481 VSS.n2665 VSS.n2436 5.14882
R10482 VSS.n2666 VSS.n2664 5.14882
R10483 VSS.n2662 VSS.n2437 5.14882
R10484 VSS.n2663 VSS.n2661 5.14882
R10485 VSS.n2659 VSS.n2438 5.14882
R10486 VSS.n2660 VSS.n2658 5.14882
R10487 VSS.n2656 VSS.n2439 5.14882
R10488 VSS.n2657 VSS.n2655 5.14882
R10489 VSS.n2653 VSS.n2440 5.14882
R10490 VSS.n2654 VSS.n2652 5.14882
R10491 VSS.n2650 VSS.n2441 5.14882
R10492 VSS.n2651 VSS.n2649 5.14882
R10493 VSS.n2647 VSS.n2442 5.14882
R10494 VSS.n2648 VSS.n2646 5.14882
R10495 VSS.n2451 VSS.n2443 5.14882
R10496 VSS.n2452 VSS.n2450 5.14882
R10497 VSS.n2448 VSS.n2444 5.14882
R10498 VSS.n2449 VSS.n2447 5.14882
R10499 VSS.n2643 VSS.n2445 5.14882
R10500 VSS.n2644 VSS.n2642 5.14882
R10501 VSS.n2640 VSS.n2453 5.14882
R10502 VSS.n2641 VSS.n2639 5.14882
R10503 VSS.n2637 VSS.n2454 5.14882
R10504 VSS.n2638 VSS.n2636 5.14882
R10505 VSS.n2625 VSS.n2455 5.14882
R10506 VSS.n2627 VSS.n2626 5.14882
R10507 VSS.n2629 VSS.n2628 5.14882
R10508 VSS.n2631 VSS.n2630 5.14882
R10509 VSS.n2632 VSS.n2624 5.14882
R10510 VSS.n2622 VSS.n2458 5.14882
R10511 VSS.n2623 VSS.n2621 5.14882
R10512 VSS.n2619 VSS.n2459 5.14882
R10513 VSS.n2620 VSS.n2618 5.14882
R10514 VSS.n2616 VSS.n2460 5.14882
R10515 VSS.n2617 VSS.n2615 5.14882
R10516 VSS.n2613 VSS.n2461 5.14882
R10517 VSS.n2614 VSS.n2612 5.14882
R10518 VSS.n2611 VSS.n2463 5.14882
R10519 VSS.t289 VSS.n2464 5.14882
R10520 VSS.n2609 VSS.n2608 5.14882
R10521 VSS.n2606 VSS.n2465 5.14882
R10522 VSS.n2607 VSS.n2605 5.14882
R10523 VSS.n2603 VSS.n2467 5.14882
R10524 VSS.n2604 VSS.n2602 5.14882
R10525 VSS.n2601 VSS.n2600 5.14882
R10526 VSS.n2599 VSS.n2598 5.14882
R10527 VSS.n2597 VSS.n2596 5.14882
R10528 VSS.n2595 VSS.n2594 5.14882
R10529 VSS.n2593 VSS.n2592 5.14882
R10530 VSS.n2591 VSS.n2590 5.14882
R10531 VSS.n2589 VSS.n2588 5.14882
R10532 VSS.n2587 VSS.n2586 5.14882
R10533 VSS.n2585 VSS.n2584 5.14882
R10534 VSS.n2583 VSS.n2582 5.14882
R10535 VSS.n2581 VSS.n2580 5.14882
R10536 VSS.n2475 VSS.n2474 5.14882
R10537 VSS.n2473 VSS.n2472 5.14882
R10538 VSS.n2471 VSS.n2470 5.14882
R10539 VSS.n2481 VSS.n2468 5.14882
R10540 VSS.n2483 VSS.n2482 5.14882
R10541 VSS.n2485 VSS.n2484 5.14882
R10542 VSS.n2487 VSS.n2486 5.14882
R10543 VSS.n2489 VSS.n2488 5.14882
R10544 VSS.n2491 VSS.n2490 5.14882
R10545 VSS.n2493 VSS.n2492 5.14882
R10546 VSS.n2494 VSS.n2480 5.14882
R10547 VSS.n2576 VSS.n2479 5.14882
R10548 VSS.n2577 VSS.n2575 5.14882
R10549 VSS.n2574 VSS.n2496 5.14882
R10550 VSS.n2503 VSS.n2501 5.14882
R10551 VSS.n2504 VSS.n2502 5.14882
R10552 VSS.n2506 VSS.n2500 5.14882
R10553 VSS.n2507 VSS.n2505 5.14882
R10554 VSS.n2509 VSS.n2499 5.14882
R10555 VSS.n2510 VSS.n2508 5.14882
R10556 VSS.n2571 VSS.n2497 5.14882
R10557 VSS.n2572 VSS.n2570 5.14882
R10558 VSS.n2569 VSS.n2568 5.14882
R10559 VSS.n2567 VSS.t302 5.14882
R10560 VSS.n2566 VSS.n2565 5.14882
R10561 VSS.n2564 VSS.n2563 5.14882
R10562 VSS.n2562 VSS.n2561 5.14882
R10563 VSS.n2560 VSS.n2559 5.14882
R10564 VSS.n2558 VSS.n2557 5.14882
R10565 VSS.n2556 VSS.n2555 5.14882
R10566 VSS.n2554 VSS.n2553 5.14882
R10567 VSS.n2552 VSS.n2551 5.14882
R10568 VSS.n2550 VSS.n2549 5.14882
R10569 VSS.n2548 VSS.n2547 5.14882
R10570 VSS.n2546 VSS.n2545 5.14882
R10571 VSS.n2544 VSS.n2543 5.14882
R10572 VSS.n2542 VSS.n2541 5.14882
R10573 VSS.n2540 VSS.n2539 5.14882
R10574 VSS.n2538 VSS.n2537 5.14882
R10575 VSS.n2536 VSS.n2535 5.14882
R10576 VSS.n2534 VSS.n2533 5.14882
R10577 VSS.n2532 VSS.n2531 5.14882
R10578 VSS.n2530 VSS.n2529 5.14882
R10579 VSS.n2528 VSS.n2527 5.14882
R10580 VSS.n2526 VSS.n2525 5.14882
R10581 VSS.n2524 VSS.n2523 5.14882
R10582 VSS.n2522 VSS.n2521 5.14882
R10583 VSS.n2520 VSS.n2519 5.14882
R10584 VSS.n2518 VSS.n2517 5.14882
R10585 VSS.n2516 VSS.n2515 5.14882
R10586 VSS.n2514 VSS.n2513 5.14882
R10587 VSS.t161 VSS.n2173 5.13648
R10588 VSS.n2944 VSS.t2201 4.98596
R10589 VSS.n2966 VSS.n2149 4.63796
R10590 VSS.n2194 VSS.n2173 4.4712
R10591 VSS.t926 VSS.n2403 4.41335
R10592 VSS.n3371 VSS.t1228 4.28393
R10593 VSS.n2846 VSS.n2840 4.25123
R10594 VSS.n44 VSS.n2208 4.25119
R10595 VSS.n76 VSS.n2897 4.251
R10596 VSS.n34 VSS.n2234 4.19244
R10597 VSS.n2969 VSS.n1 4.19238
R10598 VSS.n2860 VSS.t234 4.19225
R10599 VSS.t246 VSS.n2849 4.19225
R10600 VSS.n2820 VSS.t257 4.19225
R10601 VSS.t270 VSS.n2704 4.19225
R10602 VSS.t281 VSS.n2645 4.19225
R10603 VSS.t295 VSS.n2477 4.19225
R10604 VSS.n729 VSS.t398 4.19225
R10605 VSS.t410 VSS.n719 4.19225
R10606 VSS.t422 VSS.n706 4.19225
R10607 VSS.t434 VSS.n692 4.19225
R10608 VSS.t446 VSS.n671 4.19225
R10609 VSS.n656 VSS.t460 4.19225
R10610 VSS.n133 VSS.n134 2.76051
R10611 VSS.t224 VSS.n1568 4.19225
R10612 VSS.n2200 VSS.n19 4.19225
R10613 VSS.n140 VSS.n141 2.76051
R10614 VSS.t473 VSS.n2182 4.17719
R10615 VSS.t473 VSS.n2183 4.17712
R10616 VSS.n2831 VSS.t163 4.177
R10617 VSS.n2513 VSS.n99 5.70402
R10618 VSS.n3004 VSS.n99 1.14163
R10619 VSS VSS.n3373 3.92317
R10620 VSS.t1859 VSS 3.92317
R10621 VSS.t427 VSS 3.92317
R10622 VSS.t455 VSS 3.92317
R10623 VSS.n1287 VSS 3.92317
R10624 VSS.t2088 VSS 3.92317
R10625 VSS.t202 VSS 3.92317
R10626 VSS.t221 VSS 3.92317
R10627 VSS.t1754 VSS 3.92317
R10628 VSS.n2913 VSS 3.92317
R10629 VSS.n2217 VSS 3.92317
R10630 VSS.n2917 VSS 3.92317
R10631 VSS.t828 VSS 3.92317
R10632 VSS.t159 VSS 3.92317
R10633 VSS.t812 VSS 3.92317
R10634 VSS.n1650 VSS 3.92317
R10635 VSS.n1139 VSS 3.92317
R10636 VSS.t1614 VSS 3.92317
R10637 VSS.t319 VSS 3.92317
R10638 VSS.t338 VSS 3.92317
R10639 VSS.n1188 VSS 3.92317
R10640 VSS.n3319 VSS 3.92317
R10641 VSS.t2081 VSS 3.92317
R10642 VSS.t365 VSS 3.92317
R10643 VSS.t384 VSS 3.92317
R10644 VSS.t589 VSS 3.92317
R10645 VSS.t147 VSS 3.92317
R10646 VSS.n3014 VSS 3.92317
R10647 VSS.t1093 VSS 3.92317
R10648 VSS.t262 VSS 3.92317
R10649 VSS.t290 VSS 3.92317
R10650 VSS.n1582 VSS 3.90557
R10651 VSS.n1497 VSS 3.90557
R10652 VSS.n3132 VSS 3.90557
R10653 VSS.n1173 VSS 3.90557
R10654 VSS.n836 VSS 3.90557
R10655 VSS.n937 VSS 3.90557
R10656 VSS.n396 VSS 3.90557
R10657 VSS.n325 VSS 3.90557
R10658 VSS.n1875 VSS 3.90557
R10659 VSS.t1191 VSS 3.89823
R10660 VSS.n1393 VSS 3.89823
R10661 VSS.t753 VSS 3.89823
R10662 VSS.n1158 VSS 3.89823
R10663 VSS.n821 VSS 3.89823
R10664 VSS.t1678 VSS 3.89823
R10665 VSS.t705 VSS 3.89823
R10666 VSS.n294 VSS 3.89823
R10667 VSS.t1542 VSS 3.89823
R10668 VSS.n2062 VSS 3.89823
R10669 VSS.n3371 VSS.t905 3.84219
R10670 VSS.n1640 VSS.t27 3.84219
R10671 VSS.t1153 VSS.n1641 3.84219
R10672 VSS.n3316 VSS.t2162 3.84219
R10673 VSS.n3317 VSS.t1609 3.84219
R10674 VSS.t149 VSS.n2219 3.84119
R10675 VSS.t759 VSS.n3016 3.84041
R10676 VSS.t931 VSS.n3321 3.84041
R10677 VSS.t616 VSS.n238 3.84041
R10678 VSS.n2311 VSS 3.75734
R10679 VSS.t2215 VSS.n2348 3.48887
R10680 VSS.t259 VSS.n2381 3.48887
R10681 VSS.n2908 VSS.n31 3.40112
R10682 VSS.t5 VSS.n2511 3.39224
R10683 VSS.t1428 VSS.n3172 3.3922
R10684 VSS.t496 VSS.t1744 3.3922
R10685 VSS.n565 VSS.t1038 3.34498
R10686 VSS.n559 VSS.t1337 3.34498
R10687 VSS.n552 VSS.t1107 3.34498
R10688 VSS.n546 VSS.t1109 3.34498
R10689 VSS.n538 VSS.t981 3.34498
R10690 VSS.n533 VSS.t993 3.34498
R10691 VSS.n525 VSS.t1475 3.34498
R10692 VSS.n520 VSS.t710 3.34498
R10693 VSS.n513 VSS.t901 3.34498
R10694 VSS.n507 VSS.t712 3.34498
R10695 VSS.n500 VSS.t1477 3.34498
R10696 VSS.n495 VSS.t123 3.34498
R10697 VSS.n486 VSS.t996 3.34498
R10698 VSS.n481 VSS.t970 3.34498
R10699 VSS.n473 VSS.t121 3.34498
R10700 VSS.n468 VSS.t1111 3.34498
R10701 VSS.n460 VSS.t1473 3.34498
R10702 VSS.n454 VSS.t1474 3.34498
R10703 VSS.n446 VSS.t1664 3.34498
R10704 VSS.n441 VSS.t979 3.34498
R10705 VSS.n433 VSS.t972 3.34498
R10706 VSS.n427 VSS.t997 3.34498
R10707 VSS.n418 VSS.t1659 3.34498
R10708 VSS.n412 VSS.t716 3.34498
R10709 VSS.n404 VSS.t714 3.34498
R10710 VSS.n398 VSS.t1660 3.34498
R10711 VSS.n389 VSS.t1336 3.34498
R10712 VSS.n383 VSS.t792 3.34498
R10713 VSS.n375 VSS.t1663 3.34498
R10714 VSS.n370 VSS.t1472 3.34498
R10715 VSS.n362 VSS.t794 3.34498
R10716 VSS.n356 VSS.t1194 3.34498
R10717 VSS.t927 VSS.n850 3.34498
R10718 VSS.t1867 VSS.n855 3.34498
R10719 VSS.t1218 VSS.n858 3.34498
R10720 VSS.t2382 VSS.n862 3.34498
R10721 VSS.t2381 VSS.n865 3.34498
R10722 VSS.t115 VSS.n869 3.34498
R10723 VSS.t113 VSS.n872 3.34498
R10724 VSS.t1823 VSS.n876 3.34498
R10725 VSS.t2051 VSS.n879 3.34498
R10726 VSS.t2124 VSS.n883 3.34498
R10727 VSS.t1162 VSS.n886 3.34498
R10728 VSS.t2157 VSS.n890 3.34498
R10729 VSS.t2266 VSS.n893 3.34498
R10730 VSS.t2265 VSS.n897 3.34498
R10731 VSS.t1408 VSS.n900 3.34498
R10732 VSS.t1407 VSS.n904 3.34498
R10733 VSS.t985 VSS.n907 3.34498
R10734 VSS.t983 VSS.n911 3.34498
R10735 VSS.t861 VSS.n914 3.34498
R10736 VSS.t859 VSS.n918 3.34498
R10737 VSS.t1727 VSS.n921 3.34498
R10738 VSS.t93 VSS.n925 3.34498
R10739 VSS.t91 VSS.n928 3.34498
R10740 VSS.t2070 VSS.n932 3.34498
R10741 VSS.t2069 VSS.n935 3.34498
R10742 VSS.t111 VSS.n940 3.34498
R10743 VSS.t1665 VSS.n944 3.34498
R10744 VSS.t2225 VSS.n948 3.34498
R10745 VSS.t1612 VSS.n951 3.34498
R10746 VSS.t788 VSS.n955 3.34498
R10747 VSS.t1853 VSS.n958 3.34498
R10748 VSS.t1036 VSS.n962 3.34498
R10749 VSS.t2107 VSS.n3031 3.34498
R10750 VSS.t2184 VSS.n3036 3.34498
R10751 VSS.t875 VSS.n3039 3.34498
R10752 VSS.t915 VSS.n3043 3.34498
R10753 VSS.t1333 VSS.n3047 3.34498
R10754 VSS.t2137 VSS.n3052 3.34498
R10755 VSS.t1597 VSS.n3056 3.34498
R10756 VSS.t633 VSS.n3060 3.34498
R10757 VSS.t2257 VSS.n3063 3.34498
R10758 VSS.t2263 VSS.n3067 3.34498
R10759 VSS.t2261 VSS.n3071 3.34498
R10760 VSS.t2359 VSS.n3076 3.34498
R10761 VSS.t1587 VSS.n3080 3.34498
R10762 VSS.t1704 VSS.n3084 3.34498
R10763 VSS.t2357 VSS.n3087 3.34498
R10764 VSS.t2191 VSS.n3092 3.34498
R10765 VSS.t2364 VSS.n3096 3.34498
R10766 VSS.t1694 VSS.n3101 3.34498
R10767 VSS.t1645 VSS.n3105 3.34498
R10768 VSS.t976 VSS.n3109 3.34498
R10769 VSS.t2355 VSS.n3112 3.34498
R10770 VSS.t2159 VSS.n3117 3.34498
R10771 VSS.t896 VSS.n3120 3.34498
R10772 VSS.t1740 VSS.n3126 3.34498
R10773 VSS.t2379 VSS.n3130 3.34498
R10774 VSS.t1095 VSS.n3135 3.34498
R10775 VSS.t1129 VSS.n3139 3.34498
R10776 VSS.t117 VSS.n3144 3.34498
R10777 VSS.t1716 VSS.n3147 3.34498
R10778 VSS.t744 VSS.n3153 3.34498
R10779 VSS.t1870 VSS.n3156 3.34498
R10780 VSS.t1125 VSS.n3160 3.34498
R10781 VSS.t1707 VSS.n1642 3.34498
R10782 VSS.t2358 VSS.n1680 3.34498
R10783 VSS.t2192 VSS.n1688 3.34498
R10784 VSS.t2365 VSS.n1696 3.34498
R10785 VSS.t1695 VSS.n1704 3.34498
R10786 VSS.t1649 VSS.n1712 3.34498
R10787 VSS.t977 VSS.n1721 3.34498
R10788 VSS.t2356 VSS.n1728 3.34498
R10789 VSS.t746 VSS.n1737 3.34498
R10790 VSS.t1871 VSS.n1744 3.34498
R10791 VSS.t1127 VSS.n1753 3.34498
R10792 VSS.t928 VSS.n1760 3.34498
R10793 VSS.t1868 VSS.n1769 3.34498
R10794 VSS.t1219 VSS.n1778 3.34498
R10795 VSS.t1547 VSS.n1787 3.34498
R10796 VSS.t969 VSS.n1794 3.34498
R10797 VSS.t1042 VSS.n1803 3.34498
R10798 VSS.t1524 VSS.n1810 3.34498
R10799 VSS.t995 VSS.n1819 3.34498
R10800 VSS.t1662 VSS.n1826 3.34498
R10801 VSS.t1715 VSS.n1834 3.34498
R10802 VSS.t1240 VSS.n1842 3.34498
R10803 VSS.t790 VSS.n1851 3.34498
R10804 VSS.t899 VSS.n1858 3.34498
R10805 VSS.t1545 VSS.n1867 3.34498
R10806 VSS.t2151 VSS.n1874 3.34498
R10807 VSS.t1697 VSS.n1884 3.34498
R10808 VSS.t1001 VSS.n1892 3.34498
R10809 VSS.t2384 VSS.n1901 3.34498
R10810 VSS.t889 VSS.n1908 3.34498
R10811 VSS.t796 VSS.n1917 3.34498
R10812 VSS.t1700 VSS.n1924 3.34498
R10813 VSS.t2158 VSS.n1295 3.34498
R10814 VSS.t1717 VSS.n1303 3.34498
R10815 VSS.t2160 VSS.n1312 3.34498
R10816 VSS.t897 VSS.n1319 3.34498
R10817 VSS.t1741 VSS.n1328 3.34498
R10818 VSS.t2380 VSS.n1335 3.34498
R10819 VSS.t1096 VSS.n1344 3.34498
R10820 VSS.t1130 VSS.n1351 3.34498
R10821 VSS.t119 VSS.n1360 3.34498
R10822 VSS.t1589 VSS.n1367 3.34498
R10823 VSS.t2138 VSS.n1376 3.34498
R10824 VSS.t1598 VSS.n1383 3.34498
R10825 VSS.n1599 VSS.t634 3.34498
R10826 VSS.t2258 VSS.n1400 3.34498
R10827 VSS.t2264 VSS.n1409 3.34498
R10828 VSS.t2262 VSS.n1416 3.34498
R10829 VSS.t2360 VSS.n1425 3.34498
R10830 VSS.t797 VSS.n1432 3.34498
R10831 VSS.t1546 VSS.n1441 3.34498
R10832 VSS.t2152 VSS.n1448 3.34498
R10833 VSS.t1698 VSS.n1457 3.34498
R10834 VSS.t1003 VSS.n1464 3.34498
R10835 VSS.t2385 VSS.n1473 3.34498
R10836 VSS.t891 VSS.n1480 3.34498
R10837 VSS.t1702 VSS.n1489 3.34498
R10838 VSS.n1584 VSS.t1720 3.34498
R10839 VSS.t835 VSS.n1506 3.34498
R10840 VSS.t2110 VSS.n1513 3.34498
R10841 VSS.t2185 VSS.n1522 3.34498
R10842 VSS.t876 VSS.n1529 3.34498
R10843 VSS.t916 VSS.n1538 3.34498
R10844 VSS.t1334 VSS.n1545 3.34498
R10845 VSS.t473 VSS.n2199 3.34182
R10846 VSS.n346 VSS.n257 3.32778
R10847 VSS.n3315 VSS.n1138 3.32778
R10848 VSS.n2176 VSS.n1 3.32697
R10849 VSS.n2919 VSS.n45 3.32633
R10850 VSS.n2167 VSS.n1 3.32623
R10851 VSS.n127 VSS.n1643 3.32615
R10852 VSS.n3326 VSS.t1244 3.30447
R10853 VSS.t566 VSS.t1133 3.28366
R10854 VSS.n3005 VSS.n2134 3.21582
R10855 VSS.n3020 VSS.n1202 3.21582
R10856 VSS.n2867 VSS.n1202 3.21582
R10857 VSS.n2872 VSS.n1202 3.21582
R10858 VSS.n2875 VSS.n1202 3.21582
R10859 VSS.n2877 VSS.n1202 3.21582
R10860 VSS.n2880 VSS.n1202 3.21582
R10861 VSS.n2828 VSS.n2151 3.21582
R10862 VSS.t1840 VSS.n575 2.9518
R10863 VSS.n1126 VSS.t1615 2.9518
R10864 VSS.t1075 VSS.n1279 2.9518
R10865 VSS.n2727 VSS.t803 2.9424
R10866 VSS.n2474 VSS.t813 2.9424
R10867 VSS.n1639 VSS.n1555 2.77723
R10868 VSS.n346 VSS.n344 2.77706
R10869 VSS.n2825 VSS.n2763 2.77181
R10870 VSS.n696 VSS.n610 2.77181
R10871 VSS.t819 VSS.n2149 2.7456
R10872 VSS.n151 VSS.n847 2.74446
R10873 VSS.n127 VSS.n120 2.74446
R10874 VSS.n1639 VSS.n1635 2.74446
R10875 VSS.n151 VSS.n968 2.7443
R10876 VSS.n3315 VSS.n3184 2.7443
R10877 VSS.n346 VSS.n349 2.74422
R10878 VSS.n127 VSS.n1926 2.74414
R10879 VSS.n3315 VSS.n1144 2.74414
R10880 VSS.n1639 VSS.n1575 2.74413
R10881 VSS.n151 VSS.t1367 2.74402
R10882 VSS.n1639 VSS.t75 2.74402
R10883 VSS.n151 VSS.n851 2.74397
R10884 VSS.n3315 VSS.n3032 2.74397
R10885 VSS.n127 VSS.n1674 2.74397
R10886 VSS.n346 VSS.n564 2.74397
R10887 VSS.n151 VSS.n808 2.74397
R10888 VSS.n1639 VSS.n1296 2.74397
R10889 VSS.n1639 VSS.n1612 2.74397
R10890 VSS.n2958 VSS.n1 2.74397
R10891 VSS.n3009 VSS.t1838 2.74394
R10892 VSS.n346 VSS.t1534 2.74386
R10893 VSS.n346 VSS.n263 2.74386
R10894 VSS.n3315 VSS.t184 2.74386
R10895 VSS.n2918 VSS.n2917 2.71425
R10896 VSS.n2920 VSS.n2217 2.71425
R10897 VSS.n2913 VSS.n2912 2.71425
R10898 VSS.n2309 VSS.n19 2.46343
R10899 VSS.n2306 VSS.n19 2.46343
R10900 VSS.n2261 VSS.n19 2.46343
R10901 VSS.n2304 VSS.n19 2.46343
R10902 VSS.n2301 VSS.n19 2.46343
R10903 VSS.n2298 VSS.n19 2.46343
R10904 VSS.n2296 VSS.n19 2.46343
R10905 VSS.n2293 VSS.n19 2.46343
R10906 VSS.n2273 VSS.n19 2.46343
R10907 VSS.n2291 VSS.n19 2.46343
R10908 VSS.n2288 VSS.n19 2.46343
R10909 VSS.n2285 VSS.n19 2.46343
R10910 VSS.n34 VSS.n2224 2.46343
R10911 VSS.n34 VSS.n2225 2.46343
R10912 VSS.n34 VSS.n2226 2.46343
R10913 VSS.n34 VSS.n2260 2.46343
R10914 VSS.n34 VSS.n2259 2.46343
R10915 VSS.n34 VSS.n2258 2.46343
R10916 VSS.n34 VSS.n2257 2.46343
R10917 VSS.n34 VSS.n2227 2.46343
R10918 VSS.n34 VSS.n2228 2.46343
R10919 VSS.n34 VSS.n2229 2.46343
R10920 VSS.n34 VSS.n2230 2.46343
R10921 VSS.n34 VSS.n2254 2.46343
R10922 VSS.n34 VSS.n2251 2.46343
R10923 VSS.n34 VSS.n2250 2.46343
R10924 VSS.n34 VSS.n2249 2.46343
R10925 VSS.n34 VSS.n2248 2.46343
R10926 VSS.n34 VSS.n2235 2.46343
R10927 VSS.n34 VSS.n2232 2.46343
R10928 VSS.n2283 VSS.n19 2.46343
R10929 VSS.n2280 VSS.n19 2.46343
R10930 VSS.n2816 VSS.n2801 2.34903
R10931 VSS.t241 VSS.n2853 2.34888
R10932 VSS.t276 VSS.n2692 2.34888
R10933 VSS.t288 VSS.n2633 2.34888
R10934 VSS.t405 VSS.n723 2.34888
R10935 VSS.t417 VSS.n710 2.34888
R10936 VSS.t441 VSS.n675 2.34888
R10937 VSS.t453 VSS.n662 2.34888
R10938 VSS.n2573 VSS.n2498 2.34876
R10939 VSS.n641 VSS.n640 2.34876
R10940 VSS.n2934 VSS.n19 2.32483
R10941 VSS.n34 VSS.n2231 2.32483
R10942 VSS.n2857 VSS.n1202 2.32411
R10943 VSS.n727 VSS.n239 2.32411
R10944 VSS.n2836 VSS.t96 2.29748
R10945 VSS.t803 VSS.n2404 2.20692
R10946 VSS.n2834 VSS.n2830 2.19188
R10947 VSS.n127 VSS.n3011 2.0197
R10948 VSS.n3322 VSS.n1083 2.00687
R10949 VSS.n3017 VSS.n1235 2.00687
R10950 VSS.n2930 VSS.n19 2.00687
R10951 VSS.n34 VSS.n2256 2.00687
R10952 VSS.n3368 VSS.n782 2.00687
R10953 VSS.n151 VSS.n938 2.00619
R10954 VSS.n3315 VSS.n3133 2.00619
R10955 VSS.n3009 VSS.n2063 2.006
R10956 VSS.n151 VSS.n1009 2.006
R10957 VSS.n3315 VSS.n3262 2.006
R10958 VSS.n127 VSS.n1865 2.00599
R10959 VSS.n1639 VSS.n1585 2.00599
R10960 VSS.n127 VSS.n1767 2.00599
R10961 VSS.n346 VSS.n487 2.00599
R10962 VSS.n1639 VSS.n1386 2.00599
R10963 VSS.n1639 VSS.n1492 2.00599
R10964 VSS.n1639 VSS.n1600 2.00599
R10965 VSS.n151 VSS.n835 2.00599
R10966 VSS.n151 VSS.n820 2.00599
R10967 VSS.n346 VSS.n322 2.00592
R10968 VSS.n346 VSS.n292 2.00592
R10969 VSS.n3315 VSS.n1172 2.00592
R10970 VSS.n3315 VSS.n1157 2.00592
R10971 VSS.n346 VSS.n401 2.0059
R10972 VSS.n346 VSS.n584 1.97843
R10973 VSS.n346 VSS.n244 1.97843
R10974 VSS.n346 VSS.n248 1.97843
R10975 VSS.n346 VSS.n577 1.97843
R10976 VSS.n346 VSS.n251 1.97843
R10977 VSS.n346 VSS.n254 1.97843
R10978 VSS.n3369 VSS.n3368 1.97843
R10979 VSS.n3368 VSS.n754 1.97843
R10980 VSS.n3368 VSS.n755 1.97843
R10981 VSS.n3368 VSS.n3366 1.97843
R10982 VSS.n3368 VSS.n3365 1.97843
R10983 VSS.n3368 VSS.n3364 1.97843
R10984 VSS.n3368 VSS.n3363 1.97843
R10985 VSS.n3368 VSS.n757 1.97843
R10986 VSS.n3368 VSS.n759 1.97843
R10987 VSS.n3368 VSS.n760 1.97843
R10988 VSS.n3368 VSS.n3362 1.97843
R10989 VSS.n3368 VSS.n762 1.97843
R10990 VSS.n3322 VSS.n1133 1.97843
R10991 VSS.n3322 VSS.n1131 1.97843
R10992 VSS.n3322 VSS.n1056 1.97843
R10993 VSS.n3322 VSS.n1059 1.97843
R10994 VSS.n3322 VSS.n1063 1.97843
R10995 VSS.n151 VSS.n3324 1.97843
R10996 VSS.n151 VSS.n797 1.97843
R10997 VSS.n151 VSS.n1050 1.97843
R10998 VSS.n151 VSS.n1049 1.97843
R10999 VSS.n151 VSS.n1047 1.97843
R11000 VSS.n151 VSS.n799 1.97843
R11001 VSS.n151 VSS.n1045 1.97843
R11002 VSS.n151 VSS.n1044 1.97843
R11003 VSS.n151 VSS.n801 1.97843
R11004 VSS.n151 VSS.n1042 1.97843
R11005 VSS.n151 VSS.n1040 1.97843
R11006 VSS.n151 VSS.n803 1.97843
R11007 VSS.n3017 VSS.n1285 1.97843
R11008 VSS.n3017 VSS.n1206 1.97843
R11009 VSS.n3017 VSS.n1210 1.97843
R11010 VSS.n3017 VSS.n1280 1.97843
R11011 VSS.n3017 VSS.n1212 1.97843
R11012 VSS.n3017 VSS.n1278 1.97843
R11013 VSS.n127 VSS.n126 1.97843
R11014 VSS.n127 VSS.n1665 1.97843
R11015 VSS.n127 VSS.n1664 1.97843
R11016 VSS.n127 VSS.n1662 1.97843
R11017 VSS.n127 VSS.n1661 1.97843
R11018 VSS.n127 VSS.n1660 1.97843
R11019 VSS.n127 VSS.n1659 1.97843
R11020 VSS.n127 VSS.n1658 1.97843
R11021 VSS.n127 VSS.n1656 1.97843
R11022 VSS.n127 VSS.n1655 1.97843
R11023 VSS.n127 VSS.n1654 1.97843
R11024 VSS.n127 VSS.n1649 1.97843
R11025 VSS.n2833 VSS.n2831 1.88189
R11026 VSS.t473 VSS.n2179 1.88189
R11027 VSS.n2840 VSS.t632 1.80531
R11028 VSS.n2216 VSS.n45 1.75596
R11029 VSS.n2911 VSS.n45 1.7558
R11030 VSS.n2954 VSS.n1 1.75507
R11031 VSS.n2242 VSS.n2175 1.66925
R11032 VSS.n1639 VSS.n1203 1.64417
R11033 VSS.n1639 VSS.n1621 1.64417
R11034 VSS.n1639 VSS.n1626 1.64417
R11035 VSS.n1639 VSS.n1629 1.64417
R11036 VSS.n1639 VSS.n1631 1.64417
R11037 VSS.n3315 VSS.n3027 1.63922
R11038 VSS.n3315 VSS.n1201 1.63922
R11039 VSS.n3315 VSS.n1196 1.63922
R11040 VSS.n3315 VSS.n1193 1.63922
R11041 VSS.n3315 VSS.n1191 1.63922
R11042 VSS.n142 VSS.n138 1.30186
R11043 VSS.n1556 VSS.n1570 1.59447
R11044 VSS.n135 VSS.n131 1.30167
R11045 VSS.t268 VSS.n2761 1.58672
R11046 VSS.n151 VSS.n853 1.55386
R11047 VSS.n151 VSS.n860 1.55386
R11048 VSS.n151 VSS.n867 1.55386
R11049 VSS.n151 VSS.n874 1.55386
R11050 VSS.n151 VSS.n881 1.55386
R11051 VSS.n151 VSS.n888 1.55386
R11052 VSS.n151 VSS.n895 1.55386
R11053 VSS.n151 VSS.n902 1.55386
R11054 VSS.n151 VSS.n909 1.55386
R11055 VSS.n151 VSS.n916 1.55386
R11056 VSS.n151 VSS.n923 1.55386
R11057 VSS.n151 VSS.n930 1.55386
R11058 VSS.n151 VSS.n946 1.55386
R11059 VSS.n151 VSS.n953 1.55386
R11060 VSS.n151 VSS.n960 1.55386
R11061 VSS.n3315 VSS.n3034 1.55386
R11062 VSS.n3315 VSS.n3041 1.55386
R11063 VSS.n3315 VSS.n3050 1.55386
R11064 VSS.n3315 VSS.n3058 1.55386
R11065 VSS.n3315 VSS.n3065 1.55386
R11066 VSS.n3315 VSS.n3074 1.55386
R11067 VSS.n3315 VSS.n3082 1.55386
R11068 VSS.n3315 VSS.n3089 1.55386
R11069 VSS.n3315 VSS.n3099 1.55386
R11070 VSS.n3315 VSS.n3107 1.55386
R11071 VSS.n3315 VSS.n3114 1.55386
R11072 VSS.n3315 VSS.n3123 1.55386
R11073 VSS.n3315 VSS.n3141 1.55386
R11074 VSS.n3315 VSS.n3150 1.55386
R11075 VSS.n3315 VSS.n3158 1.55386
R11076 VSS.n346 VSS.n466 1.55368
R11077 VSS.n346 VSS.n425 1.55368
R11078 VSS.n346 VSS.n381 1.55368
R11079 VSS.n1639 VSS.n1578 1.55368
R11080 VSS.n346 VSS.n544 1.55365
R11081 VSS.n346 VSS.n505 1.55365
R11082 VSS.n346 VSS.n479 1.55365
R11083 VSS.n346 VSS.n452 1.55365
R11084 VSS.n346 VSS.n410 1.55365
R11085 VSS.n346 VSS.n368 1.55365
R11086 VSS.n1639 VSS.n1607 1.55365
R11087 VSS.n1639 VSS.n1601 1.55365
R11088 VSS.n1639 VSS.n1597 1.55365
R11089 VSS.n1639 VSS.n1593 1.55365
R11090 VSS.n1639 VSS.n1591 1.55365
R11091 VSS.n1639 VSS.n1587 1.55365
R11092 VSS.n1639 VSS.n1576 1.55365
R11093 VSS.n346 VSS.n531 1.55363
R11094 VSS.n1639 VSS.n1609 1.55363
R11095 VSS.n1639 VSS.n1603 1.55363
R11096 VSS.n1639 VSS.n1595 1.55363
R11097 VSS.n346 VSS.n557 1.55363
R11098 VSS.n346 VSS.n493 1.55363
R11099 VSS.n1639 VSS.n1611 1.55363
R11100 VSS.n1639 VSS.n1605 1.55363
R11101 VSS.n346 VSS.n512 1.55361
R11102 VSS.n1639 VSS.n1608 1.55361
R11103 VSS.n1639 VSS.n1602 1.55361
R11104 VSS.n1639 VSS.n1594 1.55361
R11105 VSS.n1639 VSS.n1588 1.55361
R11106 VSS.n346 VSS.n518 1.55358
R11107 VSS.n346 VSS.n472 1.55358
R11108 VSS.n346 VSS.n439 1.55358
R11109 VSS.n346 VSS.n432 1.55358
R11110 VSS.n346 VSS.n388 1.55358
R11111 VSS.n346 VSS.n354 1.55358
R11112 VSS.n1639 VSS.n1589 1.55358
R11113 VSS.n1639 VSS.n1580 1.55358
R11114 VSS.n1639 VSS.n1579 1.55358
R11115 VSS.n346 VSS.n551 1.55354
R11116 VSS.n346 VSS.n499 1.55354
R11117 VSS.n346 VSS.n459 1.55354
R11118 VSS.n346 VSS.n417 1.55354
R11119 VSS.n346 VSS.n374 1.55354
R11120 VSS.n1639 VSS.n1606 1.55354
R11121 VSS.n1639 VSS.n1592 1.55354
R11122 VSS.n1639 VSS.n1586 1.55354
R11123 VSS.n1639 VSS.n1577 1.55354
R11124 VSS.n3009 VSS.n2109 1.55354
R11125 VSS.n3009 VSS.n2130 1.55353
R11126 VSS.n3009 VSS.n2126 1.55353
R11127 VSS.n3009 VSS.n2123 1.55353
R11128 VSS.n3009 VSS.n2119 1.55353
R11129 VSS.n3009 VSS.n2116 1.55353
R11130 VSS.n3009 VSS.n2112 1.55353
R11131 VSS.n3009 VSS.n2105 1.55353
R11132 VSS.n3009 VSS.n2102 1.55353
R11133 VSS.n3009 VSS.n2098 1.55353
R11134 VSS.n3009 VSS.n2095 1.55353
R11135 VSS.n3009 VSS.n2091 1.55353
R11136 VSS.n3009 VSS.n2088 1.55353
R11137 VSS.n3009 VSS.n2084 1.55353
R11138 VSS.n3009 VSS.n2081 1.55353
R11139 VSS.n3009 VSS.n2077 1.55353
R11140 VSS.n3009 VSS.n2074 1.55353
R11141 VSS.n3009 VSS.n2070 1.55353
R11142 VSS.n3009 VSS.n2067 1.55353
R11143 VSS.n3009 VSS.n2059 1.55353
R11144 VSS.n3009 VSS.n2055 1.55353
R11145 VSS.n3009 VSS.n2052 1.55353
R11146 VSS.n3009 VSS.n2048 1.55353
R11147 VSS.n3009 VSS.n2045 1.55353
R11148 VSS.n3009 VSS.n2041 1.55353
R11149 VSS.n3009 VSS.n2038 1.55353
R11150 VSS.n3009 VSS.n2034 1.55353
R11151 VSS.n3009 VSS.n2031 1.55353
R11152 VSS.n3009 VSS.n2027 1.55353
R11153 VSS.n3009 VSS.n2024 1.55353
R11154 VSS.n346 VSS.n524 1.5535
R11155 VSS.n346 VSS.n403 1.5535
R11156 VSS.n346 VSS.n361 1.5535
R11157 VSS.n346 VSS.n445 1.5535
R11158 VSS.n1639 VSS.n1590 1.5535
R11159 VSS.n1639 VSS.n1581 1.5535
R11160 VSS.n127 VSS.n1673 1.55349
R11161 VSS.n127 VSS.n1752 1.55349
R11162 VSS.n346 VSS.n537 1.55347
R11163 VSS.n1639 VSS.n1610 1.55347
R11164 VSS.n1639 VSS.n1604 1.55347
R11165 VSS.n1639 VSS.n1596 1.55347
R11166 VSS.n127 VSS.n1915 1.55347
R11167 VSS.n151 VSS.n859 1.55345
R11168 VSS.n151 VSS.n866 1.55345
R11169 VSS.n151 VSS.n873 1.55345
R11170 VSS.n151 VSS.n880 1.55345
R11171 VSS.n151 VSS.n887 1.55345
R11172 VSS.n151 VSS.n901 1.55345
R11173 VSS.n151 VSS.n908 1.55345
R11174 VSS.n151 VSS.n915 1.55345
R11175 VSS.n151 VSS.n922 1.55345
R11176 VSS.n151 VSS.n929 1.55345
R11177 VSS.n151 VSS.n936 1.55345
R11178 VSS.n151 VSS.n945 1.55345
R11179 VSS.n151 VSS.n952 1.55345
R11180 VSS.n151 VSS.n959 1.55345
R11181 VSS.n3315 VSS.n3040 1.55345
R11182 VSS.n3315 VSS.n3048 1.55345
R11183 VSS.n3315 VSS.n3057 1.55345
R11184 VSS.n3315 VSS.n3064 1.55345
R11185 VSS.n3315 VSS.n3072 1.55345
R11186 VSS.n3315 VSS.n3088 1.55345
R11187 VSS.n3315 VSS.n3097 1.55345
R11188 VSS.n3315 VSS.n3106 1.55345
R11189 VSS.n3315 VSS.n3113 1.55345
R11190 VSS.n3315 VSS.n3121 1.55345
R11191 VSS.n3315 VSS.n3131 1.55345
R11192 VSS.n3315 VSS.n3140 1.55345
R11193 VSS.n3315 VSS.n3148 1.55345
R11194 VSS.n3315 VSS.n3157 1.55345
R11195 VSS.n1639 VSS.n1534 1.55344
R11196 VSS.n127 VSS.n1774 1.55344
R11197 VSS.n127 VSS.n1817 1.55344
R11198 VSS.n127 VSS.n1736 1.55342
R11199 VSS.n127 VSS.n1802 1.55342
R11200 VSS.n127 VSS.n1850 1.55342
R11201 VSS.n127 VSS.n1900 1.55342
R11202 VSS.n127 VSS.n1707 1.55339
R11203 VSS.n127 VSS.n1720 1.55339
R11204 VSS.n127 VSS.n1786 1.55339
R11205 VSS.n127 VSS.n1837 1.55339
R11206 VSS.n127 VSS.n1887 1.55339
R11207 VSS.n1639 VSS.n1421 1.55339
R11208 VSS.n1639 VSS.n1485 1.55339
R11209 VSS.n1639 VSS.n1510 1.55339
R11210 VSS.n1639 VSS.n1324 1.55338
R11211 VSS.n1639 VSS.n1332 1.55338
R11212 VSS.n1639 VSS.n1453 1.55338
R11213 VSS.n1639 VSS.n1461 1.55338
R11214 VSS.n151 VSS.n843 1.55338
R11215 VSS.n151 VSS.n842 1.55338
R11216 VSS.n151 VSS.n841 1.55338
R11217 VSS.n151 VSS.n840 1.55338
R11218 VSS.n151 VSS.n839 1.55338
R11219 VSS.n151 VSS.n838 1.55338
R11220 VSS.n151 VSS.n834 1.55338
R11221 VSS.n151 VSS.n833 1.55338
R11222 VSS.n151 VSS.n832 1.55338
R11223 VSS.n151 VSS.n831 1.55338
R11224 VSS.n151 VSS.n830 1.55338
R11225 VSS.n151 VSS.n829 1.55338
R11226 VSS.n151 VSS.n828 1.55338
R11227 VSS.n151 VSS.n827 1.55338
R11228 VSS.n151 VSS.n826 1.55338
R11229 VSS.n151 VSS.n825 1.55338
R11230 VSS.n151 VSS.n824 1.55338
R11231 VSS.n151 VSS.n823 1.55338
R11232 VSS.n151 VSS.n819 1.55338
R11233 VSS.n151 VSS.n818 1.55338
R11234 VSS.n151 VSS.n817 1.55338
R11235 VSS.n151 VSS.n816 1.55338
R11236 VSS.n151 VSS.n815 1.55338
R11237 VSS.n151 VSS.n814 1.55338
R11238 VSS.n151 VSS.n813 1.55338
R11239 VSS.n151 VSS.n812 1.55338
R11240 VSS.n151 VSS.n811 1.55338
R11241 VSS.n151 VSS.n810 1.55338
R11242 VSS.n151 VSS.n809 1.55338
R11243 VSS.n1639 VSS.n1340 1.55338
R11244 VSS.n1639 VSS.n1348 1.55338
R11245 VSS.n1639 VSS.n1397 1.55338
R11246 VSS.n1639 VSS.n1469 1.55338
R11247 VSS.n1639 VSS.n1477 1.55338
R11248 VSS.n1639 VSS.n1542 1.55338
R11249 VSS.n127 VSS.t1007 1.55338
R11250 VSS.n127 VSS.t1414 1.55338
R11251 VSS.n127 VSS.t1975 1.55338
R11252 VSS.n127 VSS.n1691 1.55337
R11253 VSS.n346 VSS.n338 1.55337
R11254 VSS.n346 VSS.n336 1.55337
R11255 VSS.n346 VSS.n334 1.55337
R11256 VSS.n346 VSS.n331 1.55337
R11257 VSS.n346 VSS.n327 1.55337
R11258 VSS.n346 VSS.n320 1.55337
R11259 VSS.n346 VSS.n318 1.55337
R11260 VSS.n346 VSS.n317 1.55337
R11261 VSS.n346 VSS.n315 1.55337
R11262 VSS.n346 VSS.n313 1.55337
R11263 VSS.n346 VSS.n311 1.55337
R11264 VSS.n346 VSS.n308 1.55337
R11265 VSS.n346 VSS.n304 1.55337
R11266 VSS.n346 VSS.n301 1.55337
R11267 VSS.n346 VSS.n299 1.55337
R11268 VSS.n346 VSS.n290 1.55337
R11269 VSS.n346 VSS.n286 1.55337
R11270 VSS.n346 VSS.n284 1.55337
R11271 VSS.n346 VSS.n274 1.55337
R11272 VSS.n346 VSS.n271 1.55337
R11273 VSS.n346 VSS.n269 1.55337
R11274 VSS.n3315 VSS.n1179 1.55337
R11275 VSS.n3315 VSS.n1178 1.55337
R11276 VSS.n3315 VSS.n1177 1.55337
R11277 VSS.n3315 VSS.n1171 1.55337
R11278 VSS.n3315 VSS.n1170 1.55337
R11279 VSS.n3315 VSS.n1169 1.55337
R11280 VSS.n3315 VSS.n1165 1.55337
R11281 VSS.n3315 VSS.n1164 1.55337
R11282 VSS.n3315 VSS.n1163 1.55337
R11283 VSS.n3315 VSS.n1156 1.55337
R11284 VSS.n3315 VSS.n1155 1.55337
R11285 VSS.n3315 VSS.n1151 1.55337
R11286 VSS.n3315 VSS.n1150 1.55337
R11287 VSS.n3315 VSS.n1149 1.55337
R11288 VSS.n1639 VSS.n1306 1.55337
R11289 VSS.n1639 VSS.n1315 1.55337
R11290 VSS.n1639 VSS.n1436 1.55337
R11291 VSS.n1639 VSS.n1444 1.55337
R11292 VSS.n1639 VSS.n1517 1.55337
R11293 VSS.n3368 VSS.n756 1.55336
R11294 VSS.n3322 VSS.n1054 1.55336
R11295 VSS.n3017 VSS.n1208 1.55336
R11296 VSS.n127 VSS.t1013 1.55336
R11297 VSS.n1639 VSS.n1356 1.55335
R11298 VSS.n1639 VSS.n1364 1.55335
R11299 VSS.n1639 VSS.n1405 1.55335
R11300 VSS.n1639 VSS.n1413 1.55335
R11301 VSS.n1639 VSS.n1502 1.55335
R11302 VSS.n127 VSS.t1010 1.55333
R11303 VSS.n1639 VSS.n1299 1.55333
R11304 VSS.n1639 VSS.n1371 1.55333
R11305 VSS.n1639 VSS.n1379 1.55333
R11306 VSS.n1639 VSS.n1428 1.55333
R11307 VSS.n1639 VSS.n1525 1.55332
R11308 VSS.n127 VSS.t1423 1.55331
R11309 VSS.n346 VSS.n330 1.55328
R11310 VSS.n346 VSS.n307 1.55328
R11311 VSS.n346 VSS.n297 1.55328
R11312 VSS.n346 VSS.n281 1.55328
R11313 VSS.n346 VSS.n279 1.55328
R11314 VSS.n346 VSS.n276 1.55328
R11315 VSS.n346 VSS.n266 1.55328
R11316 VSS.n346 VSS.n264 1.55328
R11317 VSS.n3315 VSS.n1180 1.55328
R11318 VSS.n3315 VSS.n1176 1.55328
R11319 VSS.n3315 VSS.n1175 1.55328
R11320 VSS.n3315 VSS.n1168 1.55328
R11321 VSS.n3315 VSS.n1167 1.55328
R11322 VSS.n3315 VSS.n1166 1.55328
R11323 VSS.n3315 VSS.n1162 1.55328
R11324 VSS.n3315 VSS.n1161 1.55328
R11325 VSS.n3315 VSS.n1160 1.55328
R11326 VSS.n3315 VSS.n1154 1.55328
R11327 VSS.n3315 VSS.n1153 1.55328
R11328 VSS.n3315 VSS.n1152 1.55328
R11329 VSS.n3315 VSS.n1148 1.55328
R11330 VSS.n3315 VSS.n1147 1.55328
R11331 VSS.n3315 VSS.n1145 1.55328
R11332 VSS.n127 VSS.t1926 1.55327
R11333 VSS.n127 VSS.t1394 1.55327
R11334 VSS.n127 VSS.t1208 1.55327
R11335 VSS.n127 VSS.t570 1.55327
R11336 VSS.n127 VSS.t1670 1.55327
R11337 VSS.n127 VSS.t954 1.55324
R11338 VSS.n127 VSS.t883 1.55324
R11339 VSS.n127 VSS.t1016 1.55324
R11340 VSS.n2236 VSS.t512 1.43372
R11341 VSS.t514 VSS.n2202 1.43372
R11342 VSS.n2205 VSS.t512 1.42949
R11343 VSS.n2201 VSS.t514 1.42949
R11344 VSS.t1275 VSS.t1278 1.41892
R11345 VSS.t1273 VSS.t1277 1.41892
R11346 VSS.t1271 VSS.t1276 1.41892
R11347 VSS.t1269 VSS.t1268 1.41892
R11348 VSS.n2215 VSS.t509 1.37661
R11349 VSS.t509 VSS.n2221 1.37661
R11350 VSS.n1639 VSS.n1554 1.35632
R11351 VSS.n346 VSS.n342 1.35591
R11352 VSS.t2216 VSS.t96 1.34782
R11353 VSS.n1067 VSS.t126 1.31098
R11354 VSS.n1219 VSS.t1784 1.31098
R11355 VSS.n766 VSS.t925 1.31098
R11356 VSS.n2317 VSS.n75 1.28417
R11357 VSS.t834 VSS.t832 1.25614
R11358 VSS.n75 VSS.n2312 1.25238
R11359 VSS.n2837 VSS.t157 1.24155
R11360 VSS.t96 VSS.t156 1.21479
R11361 VSS.t806 VSS.t808 1.18174
R11362 VSS.t808 VSS.t810 1.17973
R11363 VSS.t814 VSS.t816 1.16698
R11364 VSS.t832 VSS.t830 1.16468
R11365 VSS.t157 VSS.t804 1.15733
R11366 VSS.t812 VSS.t814 1.15134
R11367 VSS.t824 VSS.t822 1.14864
R11368 VSS.t822 VSS.t820 1.13816
R11369 VSS.n2730 VSS.t764 1.13095
R11370 VSS.t828 VSS.t826 1.12987
R11371 VSS.t806 VSS.t804 1.12684
R11372 VSS.n2184 VSS.t163 1.12123
R11373 VSS.n2407 VSS.t14 1.10982
R11374 VSS.n2856 VSS.t697 1.09998
R11375 VSS.n726 VSS.t1079 1.09998
R11376 VSS.t826 VSS.t824 1.09781
R11377 VSS.n1240 VSS.t209 1.09741
R11378 VSS.n1088 VSS.t326 1.09741
R11379 VSS.n787 VSS.t372 1.09741
R11380 VSS.t632 VSS.n2835 1.09156
R11381 VSS.t235 VSS.n2856 1.08744
R11382 VSS.t399 VSS.n726 1.08744
R11383 VSS.n2858 VSS.t1093 1.06888
R11384 VSS.n240 VSS.t1859 1.06888
R11385 VSS.t1754 VSS.n1288 1.06842
R11386 VSS.t2088 VSS.t2097 1.0664
R11387 VSS.t1614 VSS.t1142 1.0664
R11388 VSS.t589 VSS.t742 1.0664
R11389 VSS.t2081 VSS.t2093 1.0664
R11390 VSS.t2198 VSS.t2376 1.06241
R11391 VSS.t1550 VSS.t2150 1.06241
R11392 VSS.t1893 VSS.t1355 1.06241
R11393 VSS.t1061 VSS.t2230 1.06241
R11394 VSS.t2085 VSS.t2127 1.05684
R11395 VSS.t1866 VSS.t678 1.05684
R11396 VSS.t2 VSS.t2114 1.05684
R11397 VSS.t147 VSS.t907 1.05008
R11398 VSS.n1136 VSS.t864 1.0371
R11399 VSS.t1074 VSS.n1653 1.03658
R11400 VSS.t949 VSS.t188 1.032
R11401 VSS.t1487 VSS.t305 1.032
R11402 VSS.t783 VSS.t86 1.032
R11403 VSS.n2312 VSS.n2311 1.02769
R11404 VSS.n2835 VSS.t32 1.02487
R11405 VSS.n1225 VSS.t195 1.02329
R11406 VSS.n1073 VSS.t312 1.02329
R11407 VSS.n772 VSS.t358 1.02329
R11408 VSS.n2837 VSS.t161 1.02273
R11409 VSS.t854 VSS.t435 1.02175
R11410 VSS.t216 VSS.t221 1.00748
R11411 VSS.t333 VSS.t338 1.00748
R11412 VSS.n2900 VSS.n2899 1.00681
R11413 VSS.t379 VSS.t384 1.00623
R11414 VSS.n3009 VSS.n1942 1.00384
R11415 VSS.n3009 VSS.n2131 1.00384
R11416 VSS.n3009 VSS.n2124 1.00384
R11417 VSS.n3009 VSS.n2117 1.00384
R11418 VSS.n3009 VSS.n2110 1.00384
R11419 VSS.n3009 VSS.n2103 1.00384
R11420 VSS.n3009 VSS.n2096 1.00384
R11421 VSS.n3009 VSS.n2089 1.00384
R11422 VSS.n3009 VSS.n2082 1.00384
R11423 VSS.n3009 VSS.n2075 1.00384
R11424 VSS.n3009 VSS.n2068 1.00384
R11425 VSS.n3009 VSS.n2060 1.00384
R11426 VSS.n3009 VSS.n2053 1.00384
R11427 VSS.n3009 VSS.n2046 1.00384
R11428 VSS.n3009 VSS.n2039 1.00384
R11429 VSS.n3009 VSS.n2032 1.00384
R11430 VSS.n3009 VSS.n2025 1.00384
R11431 VSS.n127 VSS.n1675 1.00384
R11432 VSS.n127 VSS.n1677 1.00384
R11433 VSS.n127 VSS.n1679 1.00384
R11434 VSS.n127 VSS.n1686 1.00384
R11435 VSS.n127 VSS.n1687 1.00384
R11436 VSS.n127 VSS.n1690 1.00384
R11437 VSS.n127 VSS.n1693 1.00384
R11438 VSS.n127 VSS.n1695 1.00384
R11439 VSS.n127 VSS.n1702 1.00384
R11440 VSS.n127 VSS.n1703 1.00384
R11441 VSS.n127 VSS.n1706 1.00384
R11442 VSS.n127 VSS.n1709 1.00384
R11443 VSS.n127 VSS.n1711 1.00384
R11444 VSS.n127 VSS.n1718 1.00384
R11445 VSS.n127 VSS.n1719 1.00384
R11446 VSS.n127 VSS.n1723 1.00384
R11447 VSS.n127 VSS.n1725 1.00384
R11448 VSS.n127 VSS.n1727 1.00384
R11449 VSS.n127 VSS.n1734 1.00384
R11450 VSS.n127 VSS.n1735 1.00384
R11451 VSS.n127 VSS.n1739 1.00384
R11452 VSS.n127 VSS.n1741 1.00384
R11453 VSS.n127 VSS.n1743 1.00384
R11454 VSS.n127 VSS.n1750 1.00384
R11455 VSS.n127 VSS.n1751 1.00384
R11456 VSS.n127 VSS.n1755 1.00384
R11457 VSS.n127 VSS.n1757 1.00384
R11458 VSS.n127 VSS.n1759 1.00384
R11459 VSS.n127 VSS.n1766 1.00384
R11460 VSS.n127 VSS.n1768 1.00384
R11461 VSS.n127 VSS.n1772 1.00384
R11462 VSS.n127 VSS.n1775 1.00384
R11463 VSS.n127 VSS.n1777 1.00384
R11464 VSS.n127 VSS.n1784 1.00384
R11465 VSS.n127 VSS.n1785 1.00384
R11466 VSS.n127 VSS.n1789 1.00384
R11467 VSS.n127 VSS.n1791 1.00384
R11468 VSS.n127 VSS.n1793 1.00384
R11469 VSS.n127 VSS.n1800 1.00384
R11470 VSS.n127 VSS.n1801 1.00384
R11471 VSS.n127 VSS.n1805 1.00384
R11472 VSS.n127 VSS.n1807 1.00384
R11473 VSS.n127 VSS.n1809 1.00384
R11474 VSS.n127 VSS.n1816 1.00384
R11475 VSS.n127 VSS.n1818 1.00384
R11476 VSS.n127 VSS.n1821 1.00384
R11477 VSS.n127 VSS.n1823 1.00384
R11478 VSS.n127 VSS.n1825 1.00384
R11479 VSS.n127 VSS.n1832 1.00384
R11480 VSS.n127 VSS.n1833 1.00384
R11481 VSS.n127 VSS.n1836 1.00384
R11482 VSS.n127 VSS.n1839 1.00384
R11483 VSS.n127 VSS.n1841 1.00384
R11484 VSS.n127 VSS.n1848 1.00384
R11485 VSS.n127 VSS.n1849 1.00384
R11486 VSS.n127 VSS.n1853 1.00384
R11487 VSS.n127 VSS.n1855 1.00384
R11488 VSS.n127 VSS.n1857 1.00384
R11489 VSS.n127 VSS.n1864 1.00384
R11490 VSS.n127 VSS.n1866 1.00384
R11491 VSS.n127 VSS.n1869 1.00384
R11492 VSS.n127 VSS.n1871 1.00384
R11493 VSS.n127 VSS.n1873 1.00384
R11494 VSS.n127 VSS.n1882 1.00384
R11495 VSS.n127 VSS.n1883 1.00384
R11496 VSS.n127 VSS.n1886 1.00384
R11497 VSS.n127 VSS.n1889 1.00384
R11498 VSS.n127 VSS.n1891 1.00384
R11499 VSS.n127 VSS.n1898 1.00384
R11500 VSS.n127 VSS.n1899 1.00384
R11501 VSS.n127 VSS.n1903 1.00384
R11502 VSS.n127 VSS.n1905 1.00384
R11503 VSS.n127 VSS.n1907 1.00384
R11504 VSS.n127 VSS.n1914 1.00384
R11505 VSS.n127 VSS.n1916 1.00384
R11506 VSS.n127 VSS.n1919 1.00384
R11507 VSS.n127 VSS.n1921 1.00384
R11508 VSS.n127 VSS.n1923 1.00384
R11509 VSS.n127 VSS.n1931 1.00384
R11510 VSS.n127 VSS.n1933 1.00384
R11511 VSS.t2376 VSS.t854 1.00366
R11512 VSS.t2097 VSS.t759 0.98859
R11513 VSS.t1142 VSS.t931 0.98859
R11514 VSS.t742 VSS.t1609 0.98859
R11515 VSS.t2093 VSS.t616 0.98859
R11516 VSS.t27 VSS.n1288 0.987244
R11517 VSS.t905 VSS.n241 0.987144
R11518 VSS.t149 VSS.n2858 0.986822
R11519 VSS.t1228 VSS.n240 0.986822
R11520 VSS.n2928 VSS.n2927 0.980375
R11521 VSS.t202 VSS.n1229 0.978587
R11522 VSS.t319 VSS.n1077 0.978587
R11523 VSS.t365 VSS.n776 0.978587
R11524 VSS.n1653 VSS.t1153 0.973388
R11525 VSS.n1136 VSS.t2162 0.972982
R11526 VSS.n2816 VSS.n2807 0.967179
R11527 VSS.n2800 VSS.n2786 0.967179
R11528 VSS.n2800 VSS.n2792 0.967179
R11529 VSS.n2800 VSS.n2790 0.967179
R11530 VSS.n2820 VSS.n2779 0.967179
R11531 VSS.n2776 VSS.n2774 0.967179
R11532 VSS.n2800 VSS.n2796 0.965685
R11533 VSS.t430 VSS.t2198 0.965284
R11534 VSS.n137 VSS.t1428 0.0285658
R11535 VSS.t1744 VSS.t229 0.951549
R11536 VSS.t301 VSS.t5 0.951385
R11537 VSS.t1244 VSS.n143 0.116908
R11538 VSS.t466 VSS.n642 0.950816
R11539 VSS.t818 VSS.n2139 0.945288
R11540 VSS.t830 VSS.n2989 0.940049
R11541 VSS.n2839 VSS.n113 0.9276
R11542 VSS.n2899 VSS.n2223 0.908953
R11543 VSS.t816 VSS.n2139 0.893792
R11544 VSS.n2184 VSS.n2194 0.885254
R11545 VSS.n2989 VSS.t828 0.883349
R11546 VSS.n2929 VSS.n2928 0.881792
R11547 VSS.n1219 VSS.t188 0.871751
R11548 VSS.n1067 VSS.t305 0.871751
R11549 VSS.n766 VSS.t86 0.871751
R11550 VSS.n1073 VSS.t319 0.871496
R11551 VSS.n1225 VSS.t202 0.871496
R11552 VSS.n772 VSS.t365 0.871496
R11553 VSS.t820 VSS.n2988 0.85539
R11554 VSS.n2988 VSS.t819 0.831292
R11555 VSS.t949 VSS.t195 0.825878
R11556 VSS.t1487 VSS.t312 0.825878
R11557 VSS.t783 VSS.t358 0.825878
R11558 VSS.n2983 VSS.n2982 0.810955
R11559 VSS.t487 VSS.t30 0.806856
R11560 VSS.t1446 VSS.t532 0.806855
R11561 VSS.n2964 VSS.t520 0.806855
R11562 VSS.t526 VSS.n2163 0.806855
R11563 VSS.t1156 VSS.t498 0.806855
R11564 VSS.t1611 VSS.t544 0.806855
R11565 VSS.t1826 VSS.t557 0.806855
R11566 VSS.t157 VSS.n2838 0.805602
R11567 VSS.t38 VSS.t25 0.802775
R11568 VSS.t88 VSS.t98 0.802775
R11569 VSS.t802 VSS.t1147 0.802775
R11570 VSS.t1602 VSS.t152 0.802775
R11571 VSS.t133 VSS.t773 0.802775
R11572 VSS.t178 VSS.t751 0.802775
R11573 VSS.t2209 VSS.t65 0.802775
R11574 VSS.t1021 VSS.t1034 0.802775
R11575 VSS.t1151 VSS.t144 0.802775
R11576 VSS.t909 VSS.t649 0.802775
R11577 VSS.t1018 VSS.t692 0.802775
R11578 VSS.t16 VSS.t1259 0.802775
R11579 VSS.n3136 VSS.t1030 0.802775
R11580 VSS.t620 VSS.t118 0.802775
R11581 VSS.t174 VSS.t745 0.802775
R11582 VSS.t1359 VSS.t1126 0.802775
R11583 VSS.t1766 VSS.t539 0.802775
R11584 VSS.t1124 VSS.t1357 0.802775
R11585 VSS.t1792 VSS.t176 0.802775
R11586 VSS.t1280 VSS.t921 0.802775
R11587 VSS.t1121 VSS.t171 0.802775
R11588 VSS.t690 VSS.t18 0.802775
R11589 VSS.t651 VSS.t1566 0.802775
R11590 VSS.t142 VSS.t911 0.802775
R11591 VSS.t1032 VSS.t1585 0.802775
R11592 VSS.t63 VSS.t1023 0.802775
R11593 VSS.t1118 VSS.t1588 0.802775
R11594 VSS.t1386 VSS.t849 0.802775
R11595 VSS.t1712 VSS.t614 0.802775
R11596 VSS.t1145 VSS.t1235 0.802775
R11597 VSS.t100 VSS.t868 0.802775
R11598 VSS.t45 VSS.t90 0.802775
R11599 VSS.t140 VSS.t657 0.802775
R11600 VSS.t1719 VSS.n2166 0.802775
R11601 VSS.t505 VSS.t1539 0.802775
R11602 VSS.t1701 VSS.t1908 0.802775
R11603 VSS.t600 VSS.t11 0.802775
R11604 VSS.t890 VSS.t940 0.802775
R11605 VSS.t776 VSS.t1723 0.802775
R11606 VSS.t1002 VSS.t1301 0.802775
R11607 VSS.t1299 VSS.t1560 0.802775
R11608 VSS.t1419 VSS.n1881 0.802775
R11609 VSS.t643 VSS.t2027 0.802775
R11610 VSS.t900 VSS.t1523 0.802775
R11611 VSS.t791 VSS.t1640 0.802775
R11612 VSS.t1071 VSS.t1067 0.802775
R11613 VSS.t1069 VSS.t2036 0.802775
R11614 VSS.t1412 VSS.t1406 0.802775
R11615 VSS.t847 VSS.t1652 0.802775
R11616 VSS.t1480 VSS.t845 0.802775
R11617 VSS.t843 VSS.t2033 0.802775
R11618 VSS.t885 VSS.t841 0.802775
R11619 VSS.t839 VSS.t1557 0.802775
R11620 VSS.t78 VSS.t1969 0.802775
R11621 VSS.t1869 VSS.t2046 0.802775
R11622 VSS.t929 VSS.t1958 0.802775
R11623 VSS.t1128 VSS.t1658 0.802775
R11624 VSS.t1872 VSS.t591 0.802775
R11625 VSS.t593 VSS.t2039 0.802775
R11626 VSS.t1518 VSS.t1318 0.802775
R11627 VSS.t978 VSS.t1655 0.802775
R11628 VSS.t1320 VSS.t1941 0.802775
R11629 VSS.t1696 VSS.t1726 0.802775
R11630 VSS.t1392 VSS.t2062 0.802775
R11631 VSS.t1936 VSS.t8 0.802775
R11632 VSS.t1924 VSS.t1932 0.802775
R11633 VSS.t1307 VSS.t2030 0.802775
R11634 VSS.t1648 VSS.t879 0.802775
R11635 VSS.t881 VSS.t1048 0.802775
R11636 VSS.t1050 VSS.t1798 0.802775
R11637 VSS.t1801 VSS.t898 0.802775
R11638 VSS.t914 VSS.t1501 0.802775
R11639 VSS.t2048 VSS.t669 0.802775
R11640 VSS.t110 VSS.t1097 0.802775
R11641 VSS.t1844 VSS.t68 0.802775
R11642 VSS.t1370 VSS.t120 0.802775
R11643 VSS.t672 VSS.t1186 0.802775
R11644 VSS.t664 VSS.t674 0.802775
R11645 VSS.t676 VSS.t1599 0.802775
R11646 VSS.t1618 VSS.t635 0.802775
R11647 VSS.t1376 VSS.t1291 0.802775
R11648 VSS.t607 VSS.t576 0.802775
R11649 VSS.t578 VSS.t574 0.802775
R11650 VSS.t479 VSS.t1458 0.802775
R11651 VSS.t1460 VSS.t798 0.802775
R11652 VSS.t107 VSS.t1293 0.802775
R11653 VSS.t1295 VSS.t1099 0.802775
R11654 VSS.t1105 VSS.t1699 0.802775
R11655 VSS.t2059 VSS.t1004 0.802775
R11656 VSS.t667 VSS.t1199 0.802775
R11657 VSS.t1978 VSS.t892 0.802775
R11658 VSS.t1102 VSS.t1703 0.802775
R11659 VSS.n1583 VSS.t580 0.802775
R11660 VSS.t582 VSS.t72 0.802775
R11661 VSS.t70 VSS.t1055 0.802775
R11662 VSS.t482 VSS.t2186 0.802775
R11663 VSS.t1995 VSS.t877 0.802775
R11664 VSS.t1203 VSS.t586 0.802775
R11665 VSS.t1992 VSS.t1335 0.802775
R11666 VSS.t2248 VSS.t494 0.802775
R11667 VSS.t757 VSS.t870 0.802775
R11668 VSS.t1169 VSS.t20 0.802775
R11669 VSS.t1778 VSS.t116 0.802775
R11670 VSS.t1608 VSS.t59 0.802775
R11671 VSS.t167 VSS.t484 0.802775
R11672 VSS.t687 VSS.t35 0.802775
R11673 VSS.t1165 VSS.t1086 0.802775
R11674 VSS.t1340 VSS.t653 0.802775
R11675 VSS.t1812 VSS.t984 0.802775
R11676 VSS.t858 VSS.t860 0.802775
R11677 VSS.t1322 VSS.t94 0.802775
R11678 VSS.t769 VSS.t2071 0.802775
R11679 VSS.n941 VSS.t112 0.802775
R11680 VSS.t1364 VSS.t42 0.802775
R11681 VSS.t1621 VSS.t789 0.802775
R11682 VSS.t1885 VSS.t1037 0.802775
R11683 VSS.t1675 VSS.t553 0.802775
R11684 VSS.t960 VSS.t837 0.802775
R11685 VSS.t40 VSS.t1450 0.802775
R11686 VSS.t968 VSS.t1362 0.802775
R11687 VSS.t1681 VSS.t1564 0.802775
R11688 VSS.t683 VSS.t92 0.802775
R11689 VSS.t1513 VSS.t476 0.802775
R11690 VSS.t957 VSS.t856 0.802775
R11691 VSS.t655 VSS.t986 0.802775
R11692 VSS.t965 VSS.t1342 0.802775
R11693 VSS.t2022 VSS.t1167 0.802775
R11694 VSS.t486 VSS.t685 0.802775
R11695 VSS.t61 VSS.t165 0.802775
R11696 VSS.t1348 VSS.t114 0.802775
R11697 VSS.t22 VSS.t2212 0.802775
R11698 VSS.t872 VSS.t919 0.802775
R11699 VSS.t1508 VSS.t755 0.802775
R11700 VSS.t630 VSS.t1039 0.802775
R11701 VSS.t1593 VSS.t1338 0.802775
R11702 VSS.t733 VSS.t1108 0.802775
R11703 VSS.t1954 VSS.t1110 0.802775
R11704 VSS.t104 VSS.t982 0.802775
R11705 VSS.t1326 VSS.t994 0.802775
R11706 VSS.t722 VSS.t1476 0.802775
R11707 VSS.t1046 VSS.t711 0.802775
R11708 VSS.t1402 VSS.t887 0.802775
R11709 VSS.t1400 VSS.t713 0.802775
R11710 VSS.t725 VSS.t1249 0.802775
R11711 VSS.t1149 VSS.t124 0.802775
R11712 VSS.t2015 VSS.t637 0.802775
R11713 VSS.t639 VSS.t971 0.802775
R11714 VSS.t736 VSS.t122 0.802775
R11715 VSS.t1213 VSS.t645 0.802775
R11716 VSS.t2004 VSS.t937 0.802775
R11717 VSS.t874 VSS.t598 0.802775
R11718 VSS.t596 VSS.t1217 0.802775
R11719 VSS.t1215 VSS.t980 0.802775
R11720 VSS.t1289 VSS.t81 0.802775
R11721 VSS.t83 VSS.t604 0.802775
R11722 VSS.t602 VSS.t778 0.802775
R11723 VSS.t780 VSS.t717 0.802775
R11724 VSS.t708 VSS.t715 0.802775
R11725 VSS.n397 VSS.t1661 0.802775
R11726 VSS.t739 VSS.t1304 0.802775
R11727 VSS.t1173 VSS.t793 0.802775
R11728 VSS.t975 VSS.t1442 0.802775
R11729 VSS.t851 VSS.t1221 0.802775
R11730 VSS.t730 VSS.t795 0.802775
R11731 VSS.t1261 VSS.t1195 0.802775
R11732 VSS.t702 VSS.t564 0.802775
R11733 VSS.n2311 VSS.n2149 0.794865
R11734 VSS.t258 VSS.n2778 0.790552
R11735 VSS.n2435 VSS.t282 0.790552
R11736 VSS.n2326 VSS.t247 0.789617
R11737 VSS.n590 VSS.t411 0.789617
R11738 VSS.n599 VSS.t423 0.789617
R11739 VSS.n617 VSS.t447 0.789617
R11740 VSS.n3017 VSS.n1244 0.789494
R11741 VSS.n3368 VSS.n791 0.789494
R11742 VSS.n3322 VSS.n1092 0.789337
R11743 VSS.n2610 VSS.n2476 0.789314
R11744 VSS.n658 VSS.n629 0.789156
R11745 VSS.t2085 VSS.t209 0.77594
R11746 VSS.t1866 VSS.t326 0.77594
R11747 VSS.t2 VSS.t372 0.77594
R11748 VSS.n2838 VSS.n2153 0.768682
R11749 VSS.n2399 VSS.t763 0.735974
R11750 VSS.t817 VSS.n2536 0.735974
R11751 VSS.t473 VSS.n2184 0.728354
R11752 VSS.t443 VSS.n617 0.723953
R11753 VSS.t419 VSS.n599 0.723953
R11754 VSS.t407 VSS.n590 0.723953
R11755 VSS.t243 VSS.n2326 0.723953
R11756 VSS.n3163 VSS.t540 0.723599
R11757 VSS.t541 VSS.t543 0.723599
R11758 VSS.t506 VSS.n1940 0.723599
R11759 VSS.n1937 VSS.t507 0.723599
R11760 VSS.n1574 VSS.t495 0.723599
R11761 VSS.t554 VSS.t556 0.723599
R11762 VSS.t552 VSS.n796 0.723599
R11763 VSS.n347 VSS.t565 0.723599
R11764 VSS.n2778 VSS.t253 0.723086
R11765 VSS.n2435 VSS.t278 0.723086
R11766 VSS.n2246 VSS.t1275 0.722582
R11767 VSS.n2252 VSS.t1273 0.722582
R11768 VSS.n2255 VSS.t1271 0.722582
R11769 VSS.n2223 VSS.t1269 0.722582
R11770 VSS.n2935 VSS.t1278 0.72222
R11771 VSS.n2933 VSS.t1277 0.72222
R11772 VSS.n2931 VSS.t1276 0.72222
R11773 VSS.n2929 VSS.t1268 0.72222
R11774 VSS.t342 VSS.n1092 0.70615
R11775 VSS.n1244 VSS.t225 0.705955
R11776 VSS.t387 VSS.n791 0.705955
R11777 VSS.n658 VSS.t459 0.705803
R11778 VSS.n2476 VSS.t294 0.705608
R11779 VSS.n2975 VSS.n2974 0.6955
R11780 VSS.n2839 VSS.t812 0.68903
R11781 VSS.t2216 VSS.t159 0.661453
R11782 VSS.n2838 VSS.n113 0.649291
R11783 VSS.t32 VSS.t2216 0.644023
R11784 VSS.n3022 VSS.n1202 0.631585
R11785 VSS.n2874 VSS.n1202 0.631585
R11786 VSS.n2878 VSS.n1202 0.631585
R11787 VSS.n2237 VSS.n2199 0.630114
R11788 VSS.n2778 VSS.n2800 0.620484
R11789 VSS.n2669 VSS.n2435 0.620484
R11790 VSS.n2326 VSS.n2329 0.620133
R11791 VSS.n590 VSS.n593 0.620133
R11792 VSS.n599 VSS.n602 0.620133
R11793 VSS.n617 VSS.n620 0.620133
R11794 VSS.n752 VSS.n239 0.613782
R11795 VSS.n749 VSS.n239 0.613782
R11796 VSS.n744 VSS.n239 0.613782
R11797 VSS.n741 VSS.n239 0.613782
R11798 VSS.n739 VSS.n239 0.613782
R11799 VSS.n736 VSS.n239 0.613782
R11800 VSS.n713 VSS.n593 0.613782
R11801 VSS.n700 VSS.n602 0.613782
R11802 VSS.n678 VSS.n611 0.613782
R11803 VSS.n686 VSS.n611 0.613782
R11804 VSS.n665 VSS.n620 0.613782
R11805 VSS.n630 VSS.n629 0.613782
R11806 VSS.n650 VSS.n648 0.613782
R11807 VSS.t810 VSS.n2839 0.613182
R11808 VSS.t536 VSS.n3312 0.595317
R11809 VSS.t534 VSS.n3311 0.595317
R11810 VSS.t522 VSS.n2171 0.595317
R11811 VSS.n2170 VSS.t525 0.595317
R11812 VSS.t528 VSS.n2161 0.595317
R11813 VSS.n2160 VSS.t531 0.595317
R11814 VSS.t502 VSS.n1672 0.595317
R11815 VSS.t500 VSS.n1671 0.595317
R11816 VSS.t491 VSS.n1614 0.595317
R11817 VSS.t489 VSS.n1613 0.595317
R11818 VSS.t549 VSS.n1035 0.595317
R11819 VSS.t546 VSS.n1034 0.595317
R11820 VSS.t561 VSS.n569 0.595317
R11821 VSS.t559 VSS.n568 0.595317
R11822 VSS.t384 VSS.n791 0.565704
R11823 VSS.n2476 VSS.t290 0.564737
R11824 VSS.t455 VSS.n658 0.564456
R11825 VSS.t221 VSS.n1244 0.564454
R11826 VSS.t338 VSS.n1092 0.564173
R11827 VSS.t473 VSS.n2178 0.557126
R11828 VSS.n346 VSS.n256 0.556788
R11829 VSS.n151 VSS.n152 0.556788
R11830 VSS.n3315 VSS.n1137 0.556788
R11831 VSS.n127 VSS.n119 0.556788
R11832 VSS.n1639 VSS.n1636 0.556788
R11833 VSS.n2928 VSS.n19 0.556483
R11834 VSS.n2988 VSS.n98 0.554136
R11835 VSS.n2954 VSS.n2953 0.52186
R11836 VSS.n2863 VSS.n1202 0.515438
R11837 VSS.n2841 VSS.n2329 0.515438
R11838 VSS.n3322 VSS.n1123 0.515438
R11839 VSS.n3322 VSS.n1084 0.515438
R11840 VSS.n3177 VSS.n136 0.515438
R11841 VSS.n3017 VSS.n1276 0.515438
R11842 VSS.n3017 VSS.n1236 0.515438
R11843 VSS.n1557 VSS.n1561 0.515438
R11844 VSS.n3368 VSS.n3359 0.515438
R11845 VSS.n3368 VSS.n783 0.515438
R11846 VSS.n3327 VSS.n148 0.515438
R11847 VSS.n2139 VSS.n113 0.513615
R11848 VSS.n2899 VSS.n34 0.51356
R11849 VSS.n2837 VSS.t96 0.506033
R11850 VSS.t512 VSS.t514 0.492336
R11851 VSS.n2762 VSS.t268 0.479217
R11852 VSS.n2109 VSS.t643 0.47828
R11853 VSS.n2130 VSS.t600 0.478238
R11854 VSS.n2126 VSS.t890 0.478238
R11855 VSS.n2123 VSS.t776 0.478238
R11856 VSS.n2119 VSS.t1002 0.478238
R11857 VSS.n2116 VSS.t1299 0.478238
R11858 VSS.n2112 VSS.t1419 0.478238
R11859 VSS.n2105 VSS.t900 0.478238
R11860 VSS.n2102 VSS.t791 0.478238
R11861 VSS.n2098 VSS.t1071 0.478238
R11862 VSS.n2095 VSS.t1069 0.478238
R11863 VSS.n2091 VSS.t1412 0.478238
R11864 VSS.n2088 VSS.t847 0.478238
R11865 VSS.n2084 VSS.t1480 0.478238
R11866 VSS.n2081 VSS.t843 0.478238
R11867 VSS.n2077 VSS.t885 0.478238
R11868 VSS.n2074 VSS.t839 0.478238
R11869 VSS.n2070 VSS.t78 0.478238
R11870 VSS.n2067 VSS.t1869 0.478238
R11871 VSS.n2059 VSS.t1128 0.478238
R11872 VSS.n2055 VSS.t1872 0.478238
R11873 VSS.n2052 VSS.t593 0.478238
R11874 VSS.n2048 VSS.t1518 0.478238
R11875 VSS.n2045 VSS.t978 0.478238
R11876 VSS.n2041 VSS.t1320 0.478238
R11877 VSS.n2038 VSS.t1696 0.478238
R11878 VSS.n2034 VSS.t1392 0.478238
R11879 VSS.n2031 VSS.t1936 0.478238
R11880 VSS.n2027 VSS.t1924 0.478238
R11881 VSS.n2024 VSS.t1307 0.478238
R11882 VSS.t72 VSS.n1510 0.477785
R11883 VSS.t892 VSS.n1485 0.477785
R11884 VSS.t574 VSS.n1421 0.477785
R11885 VSS.t1055 VSS.n1517 0.477743
R11886 VSS.n1444 VSS.t1293 0.477743
R11887 VSS.t798 VSS.n1436 0.477743
R11888 VSS.n1315 VSS.t1798 0.477743
R11889 VSS.n1306 VSS.t1048 0.477743
R11890 VSS.n1179 VSS.t745 0.477743
R11891 VSS.n1178 VSS.t176 0.477743
R11892 VSS.n1177 VSS.t118 0.477743
R11893 VSS.n1171 VSS.t1259 0.477743
R11894 VSS.n1170 VSS.t18 0.477743
R11895 VSS.n1169 VSS.t692 0.477743
R11896 VSS.n1165 VSS.t144 0.477743
R11897 VSS.n1164 VSS.t1585 0.477743
R11898 VSS.n1163 VSS.t1034 0.477743
R11899 VSS.n1156 VSS.t849 0.477743
R11900 VSS.n1155 VSS.t773 0.477743
R11901 VSS.n1151 VSS.t1147 0.477743
R11902 VSS.n1150 VSS.t868 0.477743
R11903 VSS.n1149 VSS.t98 0.477743
R11904 VSS.n338 VSS.t795 0.477743
R11905 VSS.n336 VSS.t1221 0.477743
R11906 VSS.n334 VSS.t1442 0.477743
R11907 VSS.n331 VSS.t793 0.477743
R11908 VSS.n327 VSS.t1661 0.477743
R11909 VSS.n320 VSS.t717 0.477743
R11910 VSS.n318 VSS.t778 0.477743
R11911 VSS.n317 VSS.t604 0.477743
R11912 VSS.n315 VSS.t81 0.477743
R11913 VSS.n313 VSS.t980 0.477743
R11914 VSS.n311 VSS.t1217 0.477743
R11915 VSS.n308 VSS.t598 0.477743
R11916 VSS.n304 VSS.t645 0.477743
R11917 VSS.n301 VSS.t122 0.477743
R11918 VSS.n299 VSS.t971 0.477743
R11919 VSS.n290 VSS.t1249 0.477743
R11920 VSS.n286 VSS.t713 0.477743
R11921 VSS.n284 VSS.t887 0.477743
R11922 VSS.n274 VSS.t982 0.477743
R11923 VSS.n271 VSS.t1110 0.477743
R11924 VSS.n269 VSS.t1108 0.477743
R11925 VSS.n1542 VSS.t586 0.477689
R11926 VSS.n1477 VSS.t1199 0.477689
R11927 VSS.n1469 VSS.t1004 0.477689
R11928 VSS.n1397 VSS.t635 0.477689
R11929 VSS.n1348 VSS.t1097 0.477689
R11930 VSS.n1340 VSS.t669 0.477689
R11931 VSS.t837 VSS.n843 0.477689
R11932 VSS.t789 VSS.n842 0.477689
R11933 VSS.t1450 VSS.n841 0.477689
R11934 VSS.t42 VSS.n840 0.477689
R11935 VSS.t1362 VSS.n839 0.477689
R11936 VSS.t112 VSS.n838 0.477689
R11937 VSS.t2071 VSS.n834 0.477689
R11938 VSS.t92 VSS.n833 0.477689
R11939 VSS.t94 VSS.n832 0.477689
R11940 VSS.t476 VSS.n831 0.477689
R11941 VSS.t860 VSS.n830 0.477689
R11942 VSS.t856 VSS.n829 0.477689
R11943 VSS.t984 VSS.n828 0.477689
R11944 VSS.t986 VSS.n827 0.477689
R11945 VSS.t653 VSS.n826 0.477689
R11946 VSS.t1342 VSS.n825 0.477689
R11947 VSS.t1086 VSS.n824 0.477689
R11948 VSS.t1167 VSS.n823 0.477689
R11949 VSS.t685 VSS.n819 0.477689
R11950 VSS.t484 VSS.n818 0.477689
R11951 VSS.t165 VSS.n817 0.477689
R11952 VSS.t59 VSS.n816 0.477689
R11953 VSS.t114 VSS.n815 0.477689
R11954 VSS.t116 VSS.n814 0.477689
R11955 VSS.t2212 VSS.n813 0.477689
R11956 VSS.t20 VSS.n812 0.477689
R11957 VSS.t919 VSS.n811 0.477689
R11958 VSS.t870 VSS.n810 0.477689
R11959 VSS.t755 VSS.n809 0.477689
R11960 VSS.t1699 VSS.n1461 0.477685
R11961 VSS.t1099 VSS.n1453 0.477685
R11962 VSS.t1501 VSS.n1332 0.477685
R11963 VSS.t898 VSS.n1324 0.477685
R11964 VSS.t1458 VSS.n1428 0.47766
R11965 VSS.t674 VSS.n1379 0.47766
R11966 VSS.t1186 VSS.n1371 0.47766
R11967 VSS.t879 VSS.n1299 0.47766
R11968 VSS.t580 VSS.n1502 0.47764
R11969 VSS.t576 VSS.n1413 0.47764
R11970 VSS.t1291 VSS.n1405 0.47764
R11971 VSS.t120 VSS.n1364 0.47764
R11972 VSS.t68 VSS.n1356 0.47764
R11973 VSS.n1525 VSS.t2186 0.47756
R11974 VSS.n1180 VSS.t1357 0.477515
R11975 VSS.n1176 VSS.t921 0.477515
R11976 VSS.n1175 VSS.t1030 0.477515
R11977 VSS.n1168 VSS.t1566 0.477515
R11978 VSS.n1167 VSS.t649 0.477515
R11979 VSS.n1166 VSS.t911 0.477515
R11980 VSS.n1162 VSS.t1023 0.477515
R11981 VSS.n1161 VSS.t65 0.477515
R11982 VSS.n1160 VSS.t1588 0.477515
R11983 VSS.n1154 VSS.t614 0.477515
R11984 VSS.n1153 VSS.t152 0.477515
R11985 VSS.n1152 VSS.t1235 0.477515
R11986 VSS.n1148 VSS.t90 0.477515
R11987 VSS.n1147 VSS.t25 0.477515
R11988 VSS.n1145 VSS.t657 0.477515
R11989 VSS.n330 VSS.t1304 0.477515
R11990 VSS.n307 VSS.t937 0.477515
R11991 VSS.n297 VSS.t637 0.477515
R11992 VSS.n281 VSS.t711 0.477515
R11993 VSS.n279 VSS.t1476 0.477515
R11994 VSS.n276 VSS.t994 0.477515
R11995 VSS.n266 VSS.t1338 0.477515
R11996 VSS.n264 VSS.t1039 0.477515
R11997 VSS.n1534 VSS.t877 0.477488
R11998 VSS.t473 VSS.n2190 0.477286
R11999 VSS.t473 VSS.n2191 0.472981
R12000 VSS.t639 VSS.n472 0.467137
R12001 VSS.t1215 VSS.n432 0.467137
R12002 VSS.n397 VSS.n388 0.467137
R12003 VSS.t70 VSS.n1579 0.467137
R12004 VSS.n551 VSS.t1593 0.467079
R12005 VSS.n459 VSS.t1213 0.467079
R12006 VSS.n417 VSS.t83 0.467079
R12007 VSS.n374 VSS.t1173 0.467079
R12008 VSS.t1400 VSS.n499 0.467079
R12009 VSS.n1592 VSS.t1460 0.467079
R12010 VSS.n1586 VSS.t1978 0.467079
R12011 VSS.n1577 VSS.t1995 0.467079
R12012 VSS.t2048 VSS.n1606 0.467079
R12013 VSS.n512 VSS.t1046 0.467049
R12014 VSS.n1608 VSS.t1801 0.467049
R12015 VSS.n1602 VSS.t672 0.467049
R12016 VSS.n1594 VSS.t578 0.467049
R12017 VSS.n1588 VSS.t2059 0.467049
R12018 VSS.t1954 VSS.n537 0.46695
R12019 VSS.t881 VSS.n1610 0.46695
R12020 VSS.t1844 VSS.n1604 0.46695
R12021 VSS.t1376 VSS.n1596 0.46695
R12022 VSS.t1050 VSS.n1609 0.466936
R12023 VSS.t1370 VSS.n1603 0.466936
R12024 VSS.t607 VSS.n1595 0.466936
R12025 VSS.t104 VSS.n531 0.466936
R12026 VSS.n505 VSS.t1402 0.466877
R12027 VSS.n1607 VSS.t914 0.466877
R12028 VSS.n1601 VSS.t664 0.466877
R12029 VSS.n1593 VSS.t479 0.466877
R12030 VSS.n1587 VSS.t667 0.466877
R12031 VSS.t1618 VSS.n1597 0.466877
R12032 VSS.t107 VSS.n1591 0.466877
R12033 VSS.t1203 VSS.n1576 0.466877
R12034 VSS.t733 VSS.n544 0.466877
R12035 VSS.t2015 VSS.n479 0.466877
R12036 VSS.t2004 VSS.n452 0.466877
R12037 VSS.t602 VSS.n410 0.466877
R12038 VSS.t975 VSS.n368 0.466877
R12039 VSS.t1326 VSS.n524 0.466867
R12040 VSS.t780 VSS.n403 0.466867
R12041 VSS.t851 VSS.n361 0.466867
R12042 VSS.t874 VSS.n445 0.466862
R12043 VSS.t1295 VSS.n1590 0.466862
R12044 VSS.n1583 VSS.n1581 0.466862
R12045 VSS.t1658 VSS.n1752 0.466802
R12046 VSS.t2030 VSS.n1673 0.466802
R12047 VSS.t1648 VSS.n1611 0.466777
R12048 VSS.t110 VSS.n1605 0.466777
R12049 VSS.t630 VSS.n557 0.466777
R12050 VSS.t725 VSS.n493 0.466777
R12051 VSS.t1105 VSS.n1589 0.466752
R12052 VSS.t582 VSS.n1580 0.466752
R12053 VSS.n518 VSS.t722 0.466752
R12054 VSS.t596 VSS.n439 0.466752
R12055 VSS.n354 VSS.t730 0.466752
R12056 VSS.t591 VSS.t1013 0.466734
R12057 VSS.t482 VSS.n1578 0.466686
R12058 VSS.t736 VSS.n466 0.466686
R12059 VSS.t1289 VSS.n425 0.466686
R12060 VSS.t739 VSS.n381 0.466686
R12061 VSS.t1723 VSS.n1900 0.466677
R12062 VSS.t1640 VSS.n1850 0.466677
R12063 VSS.t2033 VSS.n1802 0.466677
R12064 VSS.t2039 VSS.n1736 0.466677
R12065 VSS.t1301 VSS.t1423 0.466677
R12066 VSS.t940 VSS.t1975 0.466646
R12067 VSS.t1523 VSS.t1414 0.466646
R12068 VSS.t845 VSS.t1007 0.466646
R12069 VSS.t1652 VSS.n1817 0.466618
R12070 VSS.t2046 VSS.n1774 0.466618
R12071 VSS.t1941 VSS.t1010 0.466589
R12072 VSS.t1067 VSS.t1016 0.466548
R12073 VSS.t841 VSS.t883 0.466548
R12074 VSS.t1318 VSS.t954 0.466548
R12075 VSS.t174 VSS.n3157 0.466542
R12076 VSS.t620 VSS.n3148 0.466542
R12077 VSS.n3136 VSS.n3140 0.466542
R12078 VSS.t16 VSS.n3131 0.466542
R12079 VSS.t1018 VSS.n3121 0.466542
R12080 VSS.t909 VSS.n3113 0.466542
R12081 VSS.t1151 VSS.n3106 0.466542
R12082 VSS.t1021 VSS.n3097 0.466542
R12083 VSS.t2209 VSS.n3088 0.466542
R12084 VSS.t133 VSS.n3072 0.466542
R12085 VSS.t1602 VSS.n3064 0.466542
R12086 VSS.t802 VSS.n3057 0.466542
R12087 VSS.t88 VSS.n3048 0.466542
R12088 VSS.t38 VSS.n3040 0.466542
R12089 VSS.t1621 VSS.n959 0.466542
R12090 VSS.t1364 VSS.n952 0.466542
R12091 VSS.n941 VSS.n945 0.466542
R12092 VSS.t769 VSS.n936 0.466542
R12093 VSS.t1322 VSS.n929 0.466542
R12094 VSS.t858 VSS.n922 0.466542
R12095 VSS.t1812 VSS.n915 0.466542
R12096 VSS.t1340 VSS.n908 0.466542
R12097 VSS.t1165 VSS.n901 0.466542
R12098 VSS.t167 VSS.n887 0.466542
R12099 VSS.t1608 VSS.n880 0.466542
R12100 VSS.t1778 VSS.n873 0.466542
R12101 VSS.t1169 VSS.n866 0.466542
R12102 VSS.t757 VSS.n859 0.466542
R12103 VSS.n1887 VSS.t1560 0.46654
R12104 VSS.n1837 VSS.t2036 0.46654
R12105 VSS.t1557 VSS.n1786 0.46654
R12106 VSS.t1655 VSS.n1720 0.46654
R12107 VSS.n1707 VSS.t1726 0.46654
R12108 VSS.n1691 VSS.t8 0.466493
R12109 VSS.n1881 VSS.t1670 0.466464
R12110 VSS.t1406 VSS.t570 0.466464
R12111 VSS.t1969 VSS.t1208 0.466464
R12112 VSS.t2062 VSS.t1394 0.466464
R12113 VSS.t1926 VSS.t1932 0.466464
R12114 VSS.t11 VSS.n1915 0.466427
R12115 VSS.n3158 VSS.t1124 0.466192
R12116 VSS.n3150 VSS.t1792 0.466192
R12117 VSS.n3141 VSS.t1280 0.466192
R12118 VSS.n3123 VSS.t690 0.466192
R12119 VSS.n3114 VSS.t651 0.466192
R12120 VSS.n3107 VSS.t142 0.466192
R12121 VSS.n3099 VSS.t1032 0.466192
R12122 VSS.n3089 VSS.t63 0.466192
R12123 VSS.n3082 VSS.t1118 0.466192
R12124 VSS.n3074 VSS.t1386 0.466192
R12125 VSS.n3065 VSS.t1712 0.466192
R12126 VSS.n3058 VSS.t1145 0.466192
R12127 VSS.n3050 VSS.t100 0.466192
R12128 VSS.n3041 VSS.t45 0.466192
R12129 VSS.n3034 VSS.t140 0.466192
R12130 VSS.n960 VSS.t960 0.466192
R12131 VSS.n953 VSS.t40 0.466192
R12132 VSS.n946 VSS.t968 0.466192
R12133 VSS.n930 VSS.t683 0.466192
R12134 VSS.n923 VSS.t1513 0.466192
R12135 VSS.n916 VSS.t957 0.466192
R12136 VSS.n909 VSS.t655 0.466192
R12137 VSS.n902 VSS.t965 0.466192
R12138 VSS.n895 VSS.t2022 0.466192
R12139 VSS.n888 VSS.t486 0.466192
R12140 VSS.n881 VSS.t61 0.466192
R12141 VSS.n874 VSS.t1348 0.466192
R12142 VSS.n867 VSS.t22 0.466192
R12143 VSS.n860 VSS.t872 0.466192
R12144 VSS.n853 VSS.t1508 0.466192
R12145 VSS.n2153 VSS.t163 0.464894
R12146 VSS.n2835 VSS.t96 0.462947
R12147 VSS.n3034 VSS.t38 0.451785
R12148 VSS.n3041 VSS.t88 0.451785
R12149 VSS.n3050 VSS.t802 0.451785
R12150 VSS.n3058 VSS.t1602 0.451785
R12151 VSS.n3065 VSS.t133 0.451785
R12152 VSS.n3074 VSS.t178 0.451785
R12153 VSS.n3082 VSS.t2209 0.451785
R12154 VSS.n3089 VSS.t1021 0.451785
R12155 VSS.n3099 VSS.t1151 0.451785
R12156 VSS.n3107 VSS.t909 0.451785
R12157 VSS.n3114 VSS.t1018 0.451785
R12158 VSS.n3123 VSS.t16 0.451785
R12159 VSS.n3141 VSS.t620 0.451785
R12160 VSS.n3150 VSS.t174 0.451785
R12161 VSS.n3158 VSS.t1359 0.451785
R12162 VSS.n853 VSS.t757 0.451785
R12163 VSS.n860 VSS.t1169 0.451785
R12164 VSS.n867 VSS.t1778 0.451785
R12165 VSS.n874 VSS.t1608 0.451785
R12166 VSS.n881 VSS.t167 0.451785
R12167 VSS.n888 VSS.t687 0.451785
R12168 VSS.n895 VSS.t1165 0.451785
R12169 VSS.n902 VSS.t1340 0.451785
R12170 VSS.n909 VSS.t1812 0.451785
R12171 VSS.n916 VSS.t858 0.451785
R12172 VSS.n923 VSS.t1322 0.451785
R12173 VSS.n930 VSS.t769 0.451785
R12174 VSS.n946 VSS.t1364 0.451785
R12175 VSS.n953 VSS.t1621 0.451785
R12176 VSS.n960 VSS.t1885 0.451785
R12177 VSS.t1908 VSS.n1915 0.45149
R12178 VSS.t1560 VSS.t1670 0.451456
R12179 VSS.t2036 VSS.t570 0.451456
R12180 VSS.t1557 VSS.t1208 0.451456
R12181 VSS.t1726 VSS.t1394 0.451456
R12182 VSS.t8 VSS.t1926 0.451456
R12183 VSS.t1655 VSS.t1010 0.451368
R12184 VSS.t2062 VSS.n1691 0.451366
R12185 VSS.t1640 VSS.t1016 0.451356
R12186 VSS.t2033 VSS.t883 0.451356
R12187 VSS.t2039 VSS.t954 0.451356
R12188 VSS.t1124 VSS.n3157 0.451337
R12189 VSS.t1792 VSS.n3148 0.451337
R12190 VSS.t1280 VSS.n3140 0.451337
R12191 VSS.t1121 VSS.n3131 0.451337
R12192 VSS.t690 VSS.n3121 0.451337
R12193 VSS.t651 VSS.n3113 0.451337
R12194 VSS.t142 VSS.n3106 0.451337
R12195 VSS.t1032 VSS.n3097 0.451337
R12196 VSS.t63 VSS.n3088 0.451337
R12197 VSS.t1386 VSS.n3072 0.451337
R12198 VSS.t1712 VSS.n3064 0.451337
R12199 VSS.t1145 VSS.n3057 0.451337
R12200 VSS.t100 VSS.n3048 0.451337
R12201 VSS.t45 VSS.n3040 0.451337
R12202 VSS.t960 VSS.n959 0.451337
R12203 VSS.t40 VSS.n952 0.451337
R12204 VSS.t968 VSS.n945 0.451337
R12205 VSS.t1681 VSS.n936 0.451337
R12206 VSS.t683 VSS.n929 0.451337
R12207 VSS.t1513 VSS.n922 0.451337
R12208 VSS.t957 VSS.n915 0.451337
R12209 VSS.t655 VSS.n908 0.451337
R12210 VSS.t965 VSS.n901 0.451337
R12211 VSS.t486 VSS.n887 0.451337
R12212 VSS.t61 VSS.n880 0.451337
R12213 VSS.t1348 VSS.n873 0.451337
R12214 VSS.t22 VSS.n866 0.451337
R12215 VSS.t872 VSS.n859 0.451337
R12216 VSS.t11 VSS.t1975 0.451319
R12217 VSS.t2027 VSS.t1414 0.451319
R12218 VSS.t1652 VSS.t1007 0.451319
R12219 VSS.t1301 VSS.n1887 0.451316
R12220 VSS.t1067 VSS.n1837 0.451316
R12221 VSS.t841 VSS.n1786 0.451316
R12222 VSS.t1318 VSS.n1720 0.451316
R12223 VSS.t1941 VSS.n1707 0.451316
R12224 VSS.t1406 VSS.n1817 0.451277
R12225 VSS.t1969 VSS.n1774 0.451277
R12226 VSS.t1723 VSS.t1423 0.451265
R12227 VSS.n1578 VSS.t1995 0.451261
R12228 VSS.n466 VSS.t1213 0.451261
R12229 VSS.n425 VSS.t83 0.451261
R12230 VSS.n381 VSS.t1173 0.451261
R12231 VSS.t1658 VSS.t1013 0.451215
R12232 VSS.t940 VSS.n1900 0.451171
R12233 VSS.t1523 VSS.n1850 0.451171
R12234 VSS.t845 VSS.n1802 0.451171
R12235 VSS.t591 VSS.n1736 0.451171
R12236 VSS.n1611 VSS.t881 0.451143
R12237 VSS.n1605 VSS.t1844 0.451143
R12238 VSS.n557 VSS.t1593 0.451143
R12239 VSS.n493 VSS.t1149 0.451143
R12240 VSS.n1589 VSS.t2059 0.451136
R12241 VSS.n1580 VSS.t70 0.451136
R12242 VSS.n518 VSS.t1046 0.451136
R12243 VSS.n439 VSS.t1215 0.451136
R12244 VSS.n354 VSS.t1261 0.451136
R12245 VSS.t1958 VSS.n1752 0.451083
R12246 VSS.t1932 VSS.n1673 0.451083
R12247 VSS.n1590 VSS.t1105 0.451078
R12248 VSS.n1581 VSS.t582 0.451078
R12249 VSS.n445 VSS.t596 0.451078
R12250 VSS.n524 VSS.t722 0.451074
R12251 VSS.n403 VSS.t708 0.451074
R12252 VSS.n361 VSS.t730 0.451074
R12253 VSS.n1607 VSS.t2048 0.451048
R12254 VSS.n1601 VSS.t676 0.451048
R12255 VSS.n1593 VSS.t1460 0.451048
R12256 VSS.n1587 VSS.t1978 0.451048
R12257 VSS.n505 VSS.t1400 0.451048
R12258 VSS.n479 VSS.t639 0.451048
R12259 VSS.n1597 VSS.t1376 0.451048
R12260 VSS.n1591 VSS.t1295 0.451048
R12261 VSS.n1576 VSS.t1992 0.451048
R12262 VSS.n544 VSS.t1954 0.451048
R12263 VSS.n452 VSS.t874 0.451048
R12264 VSS.n410 VSS.t780 0.451048
R12265 VSS.n368 VSS.t851 0.451048
R12266 VSS.n1610 VSS.t1050 0.450975
R12267 VSS.n1604 VSS.t1370 0.450975
R12268 VSS.n1596 VSS.t607 0.450975
R12269 VSS.n537 VSS.t104 0.450975
R12270 VSS.n1609 VSS.t1801 0.450941
R12271 VSS.n1603 VSS.t672 0.450941
R12272 VSS.n1595 VSS.t578 0.450941
R12273 VSS.n531 VSS.t1326 0.450941
R12274 VSS.n1608 VSS.t914 0.450937
R12275 VSS.n1602 VSS.t664 0.450937
R12276 VSS.n1594 VSS.t479 0.450937
R12277 VSS.n1588 VSS.t667 0.450937
R12278 VSS.n512 VSS.t1402 0.450937
R12279 VSS.n1606 VSS.t110 0.450883
R12280 VSS.n1592 VSS.t107 0.450883
R12281 VSS.n1586 VSS.t1102 0.450883
R12282 VSS.n1577 VSS.t1203 0.450883
R12283 VSS.n551 VSS.t733 0.450883
R12284 VSS.n499 VSS.t725 0.450883
R12285 VSS.n459 VSS.t2004 0.450883
R12286 VSS.n417 VSS.t602 0.450883
R12287 VSS.n374 VSS.t975 0.450883
R12288 VSS.n1579 VSS.t482 0.450834
R12289 VSS.n472 VSS.t736 0.450834
R12290 VSS.n432 VSS.t1289 0.450834
R12291 VSS.n388 VSS.t739 0.450834
R12292 VSS.n2955 VSS.n2954 0.447348
R12293 VSS.n3317 VSS.n238 0.44402
R12294 VSS.n3321 VSS.n3316 0.44402
R12295 VSS.n2219 VSS.n1641 0.44402
R12296 VSS.n3016 VSS.n1640 0.44402
R12297 VSS.n1534 VSS.t586 0.440463
R12298 VSS.n330 VSS.t793 0.440369
R12299 VSS.n307 VSS.t598 0.440369
R12300 VSS.n297 VSS.t971 0.440369
R12301 VSS.n281 VSS.t887 0.440369
R12302 VSS.n279 VSS.t711 0.440369
R12303 VSS.n276 VSS.t1476 0.440369
R12304 VSS.n266 VSS.t1108 0.440369
R12305 VSS.n264 VSS.t1338 0.440369
R12306 VSS.n1180 VSS.t1126 0.440369
R12307 VSS.n1176 VSS.t118 0.440369
R12308 VSS.n1175 VSS.t921 0.440369
R12309 VSS.n1168 VSS.t692 0.440369
R12310 VSS.n1167 VSS.t1566 0.440369
R12311 VSS.n1166 VSS.t649 0.440369
R12312 VSS.n1162 VSS.t1034 0.440369
R12313 VSS.n1161 VSS.t1023 0.440369
R12314 VSS.n1160 VSS.t65 0.440369
R12315 VSS.n1154 VSS.t773 0.440369
R12316 VSS.n1153 VSS.t614 0.440369
R12317 VSS.n1152 VSS.t152 0.440369
R12318 VSS.n1148 VSS.t98 0.440369
R12319 VSS.n1147 VSS.t90 0.440369
R12320 VSS.n1145 VSS.t25 0.440369
R12321 VSS.t877 VSS.n1525 0.440319
R12322 VSS.t120 VSS.n1356 0.44028
R12323 VSS.t1186 VSS.n1364 0.44028
R12324 VSS.t576 VSS.n1405 0.44028
R12325 VSS.t574 VSS.n1413 0.44028
R12326 VSS.t72 VSS.n1502 0.44028
R12327 VSS.t1501 VSS.n1324 0.440231
R12328 VSS.t669 VSS.n1332 0.440231
R12329 VSS.t1699 VSS.n1453 0.440231
R12330 VSS.t1004 VSS.n1461 0.440231
R12331 VSS.t870 VSS.n809 0.440228
R12332 VSS.t116 VSS.n813 0.440228
R12333 VSS.t59 VSS.n815 0.440228
R12334 VSS.t35 VSS.n819 0.440228
R12335 VSS.t1086 VSS.n823 0.440228
R12336 VSS.t653 VSS.n825 0.440228
R12337 VSS.t94 VSS.n831 0.440228
R12338 VSS.t2071 VSS.n833 0.440228
R12339 VSS.t1564 VSS.n834 0.440228
R12340 VSS.t1037 VSS.n843 0.440228
R12341 VSS.t919 VSS.n810 0.440228
R12342 VSS.t20 VSS.n811 0.440228
R12343 VSS.t2212 VSS.n812 0.440228
R12344 VSS.t114 VSS.n814 0.440228
R12345 VSS.t165 VSS.n816 0.440228
R12346 VSS.t484 VSS.n817 0.440228
R12347 VSS.t685 VSS.n818 0.440228
R12348 VSS.t1342 VSS.n824 0.440228
R12349 VSS.t986 VSS.n826 0.440228
R12350 VSS.t984 VSS.n827 0.440228
R12351 VSS.t856 VSS.n828 0.440228
R12352 VSS.t860 VSS.n829 0.440228
R12353 VSS.t476 VSS.n830 0.440228
R12354 VSS.t92 VSS.n832 0.440228
R12355 VSS.t1362 VSS.n838 0.440228
R12356 VSS.t42 VSS.n839 0.440228
R12357 VSS.t1450 VSS.n840 0.440228
R12358 VSS.t789 VSS.n841 0.440228
R12359 VSS.t837 VSS.n842 0.440228
R12360 VSS.n1340 VSS.t1097 0.440228
R12361 VSS.n1348 VSS.t68 0.440228
R12362 VSS.n1397 VSS.t1291 0.440228
R12363 VSS.n1469 VSS.t1199 0.440228
R12364 VSS.n1477 VSS.t892 0.440228
R12365 VSS.n1542 VSS.t1335 0.440228
R12366 VSS.t1048 VSS.n1299 0.440225
R12367 VSS.t674 VSS.n1371 0.440225
R12368 VSS.t1599 VSS.n1379 0.440225
R12369 VSS.t798 VSS.n1428 0.440225
R12370 VSS.t1458 VSS.n1421 0.440136
R12371 VSS.t1703 VSS.n1485 0.440136
R12372 VSS.t1055 VSS.n1510 0.440136
R12373 VSS.t1798 VSS.n1306 0.440116
R12374 VSS.t898 VSS.n1315 0.440116
R12375 VSS.t1293 VSS.n1436 0.440116
R12376 VSS.t1099 VSS.n1444 0.440116
R12377 VSS.t2186 VSS.n1517 0.440116
R12378 VSS.t1110 VSS.n269 0.440116
R12379 VSS.t982 VSS.n271 0.440116
R12380 VSS.t994 VSS.n274 0.440116
R12381 VSS.t713 VSS.n284 0.440116
R12382 VSS.t1249 VSS.n286 0.440116
R12383 VSS.t124 VSS.n290 0.440116
R12384 VSS.t122 VSS.n299 0.440116
R12385 VSS.t645 VSS.n301 0.440116
R12386 VSS.t937 VSS.n304 0.440116
R12387 VSS.t1217 VSS.n308 0.440116
R12388 VSS.t980 VSS.n311 0.440116
R12389 VSS.t81 VSS.n313 0.440116
R12390 VSS.t604 VSS.n315 0.440116
R12391 VSS.t778 VSS.n317 0.440116
R12392 VSS.t717 VSS.n318 0.440116
R12393 VSS.t715 VSS.n320 0.440116
R12394 VSS.t1304 VSS.n327 0.440116
R12395 VSS.t1442 VSS.n331 0.440116
R12396 VSS.t1221 VSS.n334 0.440116
R12397 VSS.t795 VSS.n336 0.440116
R12398 VSS.t1195 VSS.n338 0.440116
R12399 VSS.t868 VSS.n1149 0.440116
R12400 VSS.t1147 VSS.n1150 0.440116
R12401 VSS.t1235 VSS.n1151 0.440116
R12402 VSS.t849 VSS.n1155 0.440116
R12403 VSS.t751 VSS.n1156 0.440116
R12404 VSS.t1585 VSS.n1163 0.440116
R12405 VSS.t144 VSS.n1164 0.440116
R12406 VSS.t911 VSS.n1165 0.440116
R12407 VSS.t18 VSS.n1169 0.440116
R12408 VSS.t1259 VSS.n1170 0.440116
R12409 VSS.t171 VSS.n1171 0.440116
R12410 VSS.t176 VSS.n1177 0.440116
R12411 VSS.t745 VSS.n1178 0.440116
R12412 VSS.t1357 VSS.n1179 0.440116
R12413 VSS.n2109 VSS.t1419 0.439648
R12414 VSS.n2112 VSS.t1299 0.439641
R12415 VSS.n2116 VSS.t1002 0.439641
R12416 VSS.n2119 VSS.t776 0.439641
R12417 VSS.n2123 VSS.t890 0.439641
R12418 VSS.n2126 VSS.t600 0.439641
R12419 VSS.n2130 VSS.t1701 0.439641
R12420 VSS.n2024 VSS.t1924 0.439641
R12421 VSS.n2027 VSS.t1936 0.439641
R12422 VSS.n2031 VSS.t1392 0.439641
R12423 VSS.n2034 VSS.t1696 0.439641
R12424 VSS.n2038 VSS.t1320 0.439641
R12425 VSS.n2041 VSS.t978 0.439641
R12426 VSS.n2045 VSS.t1518 0.439641
R12427 VSS.n2048 VSS.t593 0.439641
R12428 VSS.n2052 VSS.t1872 0.439641
R12429 VSS.n2055 VSS.t1128 0.439641
R12430 VSS.n2059 VSS.t929 0.439641
R12431 VSS.n2067 VSS.t78 0.439641
R12432 VSS.n2070 VSS.t839 0.439641
R12433 VSS.n2074 VSS.t885 0.439641
R12434 VSS.n2077 VSS.t843 0.439641
R12435 VSS.n2081 VSS.t1480 0.439641
R12436 VSS.n2084 VSS.t847 0.439641
R12437 VSS.n2088 VSS.t1412 0.439641
R12438 VSS.n2091 VSS.t1069 0.439641
R12439 VSS.n2095 VSS.t1071 0.439641
R12440 VSS.n2098 VSS.t791 0.439641
R12441 VSS.n2102 VSS.t900 0.439641
R12442 VSS.n2105 VSS.t643 0.439641
R12443 VSS.n2989 VSS.n98 0.436259
R12444 VSS.n2914 VSS.n2219 0.435807
R12445 VSS.t2081 VSS.n756 0.428989
R12446 VSS.t2088 VSS.n1208 0.428989
R12447 VSS.t1614 VSS.n1054 0.428989
R12448 VSS.n2915 VSS.n2914 0.427593
R12449 VSS.n2920 VSS.n2216 0.417043
R12450 VSS.n2911 VSS.n2910 0.416917
R12451 VSS.n2912 VSS.n2911 0.416191
R12452 VSS.n2910 VSS.n2216 0.416074
R12453 VSS.n2836 VSS.t161 0.411873
R12454 VSS.n2967 VSS.n2173 0.41014
R12455 VSS.n2063 VSS.t929 0.392129
R12456 VSS.n1172 VSS.t171 0.39181
R12457 VSS.n1157 VSS.t751 0.39181
R12458 VSS.n322 VSS.t715 0.39181
R12459 VSS.n292 VSS.t124 0.39181
R12460 VSS.t1564 VSS.n835 0.391779
R12461 VSS.t35 VSS.n820 0.391779
R12462 VSS.n1492 VSS.t1703 0.391516
R12463 VSS.n1386 VSS.t1599 0.391516
R12464 VSS.t268 VSS.t265 0.388215
R12465 VSS.t2127 VSS.n1235 0.383265
R12466 VSS.t678 VSS.n1083 0.383265
R12467 VSS.t2114 VSS.n782 0.383265
R12468 VSS.n487 VSS.t1149 0.380932
R12469 VSS.n1600 VSS.t676 0.380932
R12470 VSS.t2027 VSS.n1865 0.380703
R12471 VSS.t1102 VSS.n1585 0.380703
R12472 VSS.n1767 VSS.t1958 0.380674
R12473 VSS.t708 VSS.n401 0.380505
R12474 VSS.n3262 VSS.t178 0.380287
R12475 VSS.n1009 VSS.t687 0.380287
R12476 VSS.n3133 VSS.t1121 0.380025
R12477 VSS.n938 VSS.t1681 0.380025
R12478 VSS.n2935 VSS.n2934 0.376066
R12479 VSS.n2246 VSS.n2231 0.376066
R12480 VSS.t159 VSS.n2836 0.372074
R12481 VSS.n3011 VSS.n3010 0.356909
R12482 VSS.t2150 VSS.n1235 0.356769
R12483 VSS.t1355 VSS.n1083 0.356769
R12484 VSS.t2230 VSS.n782 0.356769
R12485 VSS.n3133 VSS.n3132 0.352462
R12486 VSS.n938 VSS.n937 0.352462
R12487 VSS.n1497 VSS.n1492 0.352182
R12488 VSS.n836 VSS.n835 0.351918
R12489 VSS.n1173 VSS.n1172 0.351842
R12490 VSS.n1875 VSS.n1865 0.351726
R12491 VSS.n1585 VSS.n1582 0.351726
R12492 VSS.n2951 VSS.n1 0.351198
R12493 VSS.n401 VSS.n396 0.350661
R12494 VSS.n325 VSS.n322 0.350592
R12495 VSS.n1393 VSS.n1386 0.349682
R12496 VSS.n3262 VSS.t753 0.349629
R12497 VSS.n1009 VSS.t1678 0.349629
R12498 VSS.n821 VSS.n820 0.349418
R12499 VSS.n294 VSS.n292 0.349342
R12500 VSS.n1158 VSS.n1157 0.349342
R12501 VSS.t1542 VSS.n1767 0.349275
R12502 VSS.n2063 VSS.n2062 0.349037
R12503 VSS.t395 VSS.t393 0.349031
R12504 VSS.n1600 VSS.t1191 0.349016
R12505 VSS.n487 VSS.t705 0.349016
R12506 VSS.t229 VSS.n1556 0.348497
R12507 VSS.t347 VSS.t346 0.348238
R12508 VSS.n3011 VSS.t507 0.346433
R12509 VSS.n2931 VSS.n2930 0.338265
R12510 VSS.n2256 VSS.n2255 0.338265
R12511 VSS.n2930 VSS.n2929 0.338019
R12512 VSS.n2256 VSS.n2223 0.338019
R12513 VSS.n3318 VSS.n847 0.330412
R12514 VSS.n3013 VSS.n120 0.330412
R12515 VSS.n1637 VSS.n1635 0.330412
R12516 VSS.n135 VSS.t347 0.0503834
R12517 VSS.t227 VSS.n1556 0.322977
R12518 VSS.t393 VSS.n142 0.0502676
R12519 VSS.n1054 VSS.t126 0.315787
R12520 VSS.n1208 VSS.t1784 0.315787
R12521 VSS.n756 VSS.t925 0.315787
R12522 VSS.n2959 VSS.n2958 0.312321
R12523 VSS.n2916 VSS.n1135 0.31114
R12524 VSS.t697 VSS.n2857 0.30763
R12525 VSS.t1079 VSS.n727 0.30763
R12526 VSS.n2498 VSS.t299 0.306378
R12527 VSS.t464 VSS.n641 0.306378
R12528 VSS.n2934 VSS.n2933 0.306341
R12529 VSS.n2252 VSS.n2231 0.306341
R12530 VSS.n2801 VSS.t251 0.306165
R12531 VSS.t288 VSS.t286 0.305925
R12532 VSS.t276 VSS.t274 0.305925
R12533 VSS.t241 VSS.t239 0.305925
R12534 VSS.t453 VSS.t451 0.305925
R12535 VSS.t441 VSS.t439 0.305925
R12536 VSS.t417 VSS.t415 0.305925
R12537 VSS.t405 VSS.t403 0.305925
R12538 VSS.t1838 VSS.t1701 0.302314
R12539 VSS.t75 VSS.t1335 0.302153
R12540 VSS.t1037 VSS.t1367 0.302153
R12541 VSS.t1126 VSS.t184 0.302137
R12542 VSS.t1195 VSS.t1534 0.302137
R12543 VSS.t495 VSS.n1554 0.301088
R12544 VSS.n342 VSS.t565 0.300523
R12545 VSS.n2857 VSS.t1093 0.298462
R12546 VSS.n727 VSS.t1859 0.298462
R12547 VSS.n1136 VSS.n3315 0.295829
R12548 VSS.n127 VSS.n1653 0.295456
R12549 VSS.t854 VSS.n611 0.295289
R12550 VSS.n2177 VSS.n2176 0.291601
R12551 VSS.t1261 VSS.n349 0.291418
R12552 VSS.t1908 VSS.n1926 0.29124
R12553 VSS.t1992 VSS.n1575 0.291234
R12554 VSS.n968 VSS.t1885 0.290734
R12555 VSS.n3184 VSS.t1359 0.290734
R12556 VSS.n573 VSS.n257 0.289639
R12557 VSS.n1186 VSS.n1138 0.289639
R12558 VSS.n2176 VSS.n2175 0.287886
R12559 VSS.n2207 VSS.n2209 0.286777
R12560 VSS.n2827 VSS.t1000 0.286439
R12561 VSS.n2729 VSS.n2827 0.286439
R12562 VSS.n2892 VSS.n8 0.380365
R12563 VSS.n12 VSS.n2318 0.380365
R12564 VSS.n40 VSS.n2900 0.380365
R12565 VSS.n2022 VSS.n1643 0.28485
R12566 VSS.n257 VSS.n237 0.28352
R12567 VSS.n1140 VSS.n1138 0.28352
R12568 VSS.n2980 VSS.n2979 0.282906
R12569 VSS.n148 VSS.n143 0.247594
R12570 VSS.n650 VSS.n642 0.282782
R12571 VSS.n137 VSS.n136 0.247384
R12572 VSS.t1744 VSS.n1557 0.282627
R12573 VSS.t5 VSS.n2134 0.282582
R12574 VSS.n3000 VSS.n2999 0.280152
R12575 VSS.n3001 VSS.n3000 0.280152
R12576 VSS.n3002 VSS.n3001 0.280152
R12577 VSS.t154 VSS.n2182 0.278261
R12578 VSS.t1719 VSS.n2167 0.276315
R12579 VSS.t140 VSS.n3032 0.275961
R12580 VSS.t1508 VSS.n851 0.275961
R12581 VSS.t2030 VSS.n1674 0.275718
R12582 VSS.n1612 VSS.t1648 0.275718
R12583 VSS.n564 VSS.t630 0.275718
R12584 VSS.n2858 VSS.n1202 0.273931
R12585 VSS.n240 VSS.n239 0.273931
R12586 VSS.n1639 VSS.n1288 0.27391
R12587 VSS.n346 VSS.n241 0.273747
R12588 VSS.n3368 VSS.t2093 0.273045
R12589 VSS.n3322 VSS.t1142 0.273045
R12590 VSS.n151 VSS.t742 0.273045
R12591 VSS.n3017 VSS.t2097 0.273045
R12592 VSS.n3312 VSS.n1144 0.27249
R12593 VSS.n1674 VSS.n1669 0.272321
R12594 VSS.n570 VSS.n564 0.272321
R12595 VSS.n1614 VSS.n1296 0.272321
R12596 VSS.n1615 VSS.n1612 0.272321
R12597 VSS.n1035 VSS.n808 0.272321
R12598 VSS.n569 VSS.n263 0.272137
R12599 VSS.n3032 VSS.n3033 0.272065
R12600 VSS.n851 VSS.n852 0.272065
R12601 VSS.n346 VSS.n341 0.267794
R12602 VSS.n346 VSS.n339 0.267794
R12603 VSS.n346 VSS.n337 0.267794
R12604 VSS.n346 VSS.n335 0.267794
R12605 VSS.n346 VSS.n333 0.267794
R12606 VSS.n346 VSS.n332 0.267794
R12607 VSS.n346 VSS.n329 0.267794
R12608 VSS.n346 VSS.n328 0.267794
R12609 VSS.n346 VSS.n323 0.267794
R12610 VSS.n346 VSS.n321 0.267794
R12611 VSS.n346 VSS.n319 0.267794
R12612 VSS.n346 VSS.n316 0.267794
R12613 VSS.n346 VSS.n314 0.267794
R12614 VSS.n346 VSS.n312 0.267794
R12615 VSS.n346 VSS.n310 0.267794
R12616 VSS.n346 VSS.n309 0.267794
R12617 VSS.n346 VSS.n306 0.267794
R12618 VSS.n346 VSS.n305 0.267794
R12619 VSS.n346 VSS.n302 0.267794
R12620 VSS.n346 VSS.n300 0.267794
R12621 VSS.n346 VSS.n298 0.267794
R12622 VSS.n346 VSS.n296 0.267794
R12623 VSS.n346 VSS.n293 0.267794
R12624 VSS.n346 VSS.n291 0.267794
R12625 VSS.n346 VSS.n289 0.267794
R12626 VSS.n346 VSS.n288 0.267794
R12627 VSS.n346 VSS.n287 0.267794
R12628 VSS.n346 VSS.n283 0.267794
R12629 VSS.n346 VSS.n282 0.267794
R12630 VSS.n346 VSS.n280 0.267794
R12631 VSS.n346 VSS.n278 0.267794
R12632 VSS.n346 VSS.n277 0.267794
R12633 VSS.n346 VSS.n275 0.267794
R12634 VSS.n346 VSS.n273 0.267794
R12635 VSS.n346 VSS.n272 0.267794
R12636 VSS.n346 VSS.n268 0.267794
R12637 VSS.n346 VSS.n267 0.267794
R12638 VSS.n346 VSS.n265 0.267794
R12639 VSS.n346 VSS.n262 0.267794
R12640 VSS.n346 VSS.n259 0.267794
R12641 VSS.n346 VSS.n562 0.267794
R12642 VSS.n346 VSS.n549 0.267794
R12643 VSS.n346 VSS.n547 0.267794
R12644 VSS.n346 VSS.n539 0.267794
R12645 VSS.n346 VSS.n526 0.267794
R12646 VSS.n346 VSS.n510 0.267794
R12647 VSS.n346 VSS.n508 0.267794
R12648 VSS.n346 VSS.n488 0.267794
R12649 VSS.n346 VSS.n474 0.267794
R12650 VSS.n346 VSS.n469 0.267794
R12651 VSS.n346 VSS.n461 0.267794
R12652 VSS.n346 VSS.n455 0.267794
R12653 VSS.n346 VSS.n447 0.267794
R12654 VSS.n346 VSS.n434 0.267794
R12655 VSS.n346 VSS.n428 0.267794
R12656 VSS.n346 VSS.n420 0.267794
R12657 VSS.n346 VSS.n419 0.267794
R12658 VSS.n346 VSS.n413 0.267794
R12659 VSS.n346 VSS.n405 0.267794
R12660 VSS.n346 VSS.n399 0.267794
R12661 VSS.n346 VSS.n390 0.267794
R12662 VSS.n346 VSS.n384 0.267794
R12663 VSS.n346 VSS.n376 0.267794
R12664 VSS.n346 VSS.n363 0.267794
R12665 VSS.n346 VSS.n357 0.267794
R12666 VSS.n151 VSS.n174 0.267794
R12667 VSS.n151 VSS.n235 0.267794
R12668 VSS.n151 VSS.n175 0.267794
R12669 VSS.n151 VSS.n233 0.267794
R12670 VSS.n151 VSS.n232 0.267794
R12671 VSS.n151 VSS.n176 0.267794
R12672 VSS.n151 VSS.n229 0.267794
R12673 VSS.n151 VSS.n177 0.267794
R12674 VSS.n151 VSS.n228 0.267794
R12675 VSS.n151 VSS.n226 0.267794
R12676 VSS.n151 VSS.n225 0.267794
R12677 VSS.n151 VSS.n224 0.267794
R12678 VSS.n151 VSS.n178 0.267794
R12679 VSS.n151 VSS.n221 0.267794
R12680 VSS.n151 VSS.n179 0.267794
R12681 VSS.n151 VSS.n220 0.267794
R12682 VSS.n151 VSS.n218 0.267794
R12683 VSS.n151 VSS.n217 0.267794
R12684 VSS.n151 VSS.n180 0.267794
R12685 VSS.n151 VSS.n215 0.267794
R12686 VSS.n151 VSS.n214 0.267794
R12687 VSS.n151 VSS.n213 0.267794
R12688 VSS.n151 VSS.n181 0.267794
R12689 VSS.n151 VSS.n182 0.267794
R12690 VSS.n151 VSS.n211 0.267794
R12691 VSS.n151 VSS.n183 0.267794
R12692 VSS.n151 VSS.n210 0.267794
R12693 VSS.n151 VSS.n209 0.267794
R12694 VSS.n151 VSS.n208 0.267794
R12695 VSS.n151 VSS.n207 0.267794
R12696 VSS.n151 VSS.n206 0.267794
R12697 VSS.n151 VSS.n205 0.267794
R12698 VSS.n151 VSS.n204 0.267794
R12699 VSS.n151 VSS.n185 0.267794
R12700 VSS.n151 VSS.n203 0.267794
R12701 VSS.n151 VSS.n201 0.267794
R12702 VSS.n151 VSS.n200 0.267794
R12703 VSS.n151 VSS.n199 0.267794
R12704 VSS.n151 VSS.n186 0.267794
R12705 VSS.n151 VSS.n187 0.267794
R12706 VSS.n151 VSS.n197 0.267794
R12707 VSS.n151 VSS.n188 0.267794
R12708 VSS.n151 VSS.n196 0.267794
R12709 VSS.n151 VSS.n195 0.267794
R12710 VSS.n151 VSS.n194 0.267794
R12711 VSS.n151 VSS.n193 0.267794
R12712 VSS.n151 VSS.n192 0.267794
R12713 VSS.n151 VSS.n172 0.267794
R12714 VSS.n151 VSS.n170 0.267794
R12715 VSS.n151 VSS.n169 0.267794
R12716 VSS.n151 VSS.n168 0.267794
R12717 VSS.n151 VSS.n166 0.267794
R12718 VSS.n151 VSS.n164 0.267794
R12719 VSS.n151 VSS.n163 0.267794
R12720 VSS.n151 VSS.n162 0.267794
R12721 VSS.n151 VSS.n161 0.267794
R12722 VSS.n151 VSS.n160 0.267794
R12723 VSS.n151 VSS.n159 0.267794
R12724 VSS.n151 VSS.n158 0.267794
R12725 VSS.n151 VSS.n157 0.267794
R12726 VSS.n151 VSS.n156 0.267794
R12727 VSS.n151 VSS.n155 0.267794
R12728 VSS.n151 VSS.n154 0.267794
R12729 VSS.n151 VSS.n153 0.267794
R12730 VSS.n3315 VSS.n3164 0.267794
R12731 VSS.n127 VSS.n116 0.267677
R12732 VSS.n127 VSS.n118 0.267677
R12733 VSS.n1639 VSS.n1289 0.267677
R12734 VSS.n1639 VSS.n1294 0.267677
R12735 VSS.n1639 VSS.n1298 0.267677
R12736 VSS.n1639 VSS.n1302 0.267677
R12737 VSS.n1639 VSS.n1310 0.267677
R12738 VSS.n1639 VSS.n1311 0.267677
R12739 VSS.n1639 VSS.n1314 0.267677
R12740 VSS.n1639 VSS.n1318 0.267677
R12741 VSS.n1639 VSS.n1326 0.267677
R12742 VSS.n1639 VSS.n1327 0.267677
R12743 VSS.n1639 VSS.n1330 0.267677
R12744 VSS.n1639 VSS.n1334 0.267677
R12745 VSS.n1639 VSS.n1342 0.267677
R12746 VSS.n1639 VSS.n1343 0.267677
R12747 VSS.n1639 VSS.n1346 0.267677
R12748 VSS.n1639 VSS.n1350 0.267677
R12749 VSS.n1639 VSS.n1358 0.267677
R12750 VSS.n1639 VSS.n1359 0.267677
R12751 VSS.n1639 VSS.n1362 0.267677
R12752 VSS.n1639 VSS.n1366 0.267677
R12753 VSS.n1639 VSS.n1374 0.267677
R12754 VSS.n1639 VSS.n1375 0.267677
R12755 VSS.n1639 VSS.n1378 0.267677
R12756 VSS.n1639 VSS.n1382 0.267677
R12757 VSS.n1639 VSS.n1390 0.267677
R12758 VSS.n1639 VSS.n1391 0.267677
R12759 VSS.n1639 VSS.n1395 0.267677
R12760 VSS.n1639 VSS.n1399 0.267677
R12761 VSS.n1639 VSS.n1407 0.267677
R12762 VSS.n1639 VSS.n1408 0.267677
R12763 VSS.n1639 VSS.n1411 0.267677
R12764 VSS.n1639 VSS.n1415 0.267677
R12765 VSS.n1639 VSS.n1423 0.267677
R12766 VSS.n1639 VSS.n1424 0.267677
R12767 VSS.n1639 VSS.n1427 0.267677
R12768 VSS.n1639 VSS.n1431 0.267677
R12769 VSS.n1639 VSS.n1439 0.267677
R12770 VSS.n1639 VSS.n1440 0.267677
R12771 VSS.n1639 VSS.n1443 0.267677
R12772 VSS.n1639 VSS.n1447 0.267677
R12773 VSS.n1639 VSS.n1455 0.267677
R12774 VSS.n1639 VSS.n1456 0.267677
R12775 VSS.n1639 VSS.n1459 0.267677
R12776 VSS.n1639 VSS.n1463 0.267677
R12777 VSS.n1639 VSS.n1471 0.267677
R12778 VSS.n1639 VSS.n1472 0.267677
R12779 VSS.n1639 VSS.n1475 0.267677
R12780 VSS.n1639 VSS.n1479 0.267677
R12781 VSS.n1639 VSS.n1487 0.267677
R12782 VSS.n1639 VSS.n1488 0.267677
R12783 VSS.n1639 VSS.n1491 0.267677
R12784 VSS.n1639 VSS.n1495 0.267677
R12785 VSS.n1639 VSS.n1504 0.267677
R12786 VSS.n1639 VSS.n1505 0.267677
R12787 VSS.n1639 VSS.n1508 0.267677
R12788 VSS.n1639 VSS.n1512 0.267677
R12789 VSS.n1639 VSS.n1520 0.267677
R12790 VSS.n1639 VSS.n1521 0.267677
R12791 VSS.n1639 VSS.n1524 0.267677
R12792 VSS.n1639 VSS.n1528 0.267677
R12793 VSS.n1639 VSS.n1536 0.267677
R12794 VSS.n1639 VSS.n1537 0.267677
R12795 VSS.n1639 VSS.n1540 0.267677
R12796 VSS.n1639 VSS.n1544 0.267677
R12797 VSS.n1639 VSS.n1553 0.267677
R12798 VSS.n151 VSS.n190 0.267428
R12799 VSS.n3315 VSS.n3028 0.267428
R12800 VSS.n3315 VSS.n3030 0.267428
R12801 VSS.n3315 VSS.n3308 0.267428
R12802 VSS.n3315 VSS.n3307 0.267428
R12803 VSS.n3315 VSS.n3303 0.267428
R12804 VSS.n3315 VSS.n3302 0.267428
R12805 VSS.n3315 VSS.n3300 0.267428
R12806 VSS.n3315 VSS.n3298 0.267428
R12807 VSS.n3315 VSS.n3046 0.267428
R12808 VSS.n3315 VSS.n3294 0.267428
R12809 VSS.n3315 VSS.n3049 0.267428
R12810 VSS.n3315 VSS.n3291 0.267428
R12811 VSS.n3315 VSS.n3287 0.267428
R12812 VSS.n3315 VSS.n3055 0.267428
R12813 VSS.n3315 VSS.n3285 0.267428
R12814 VSS.n3315 VSS.n3283 0.267428
R12815 VSS.n3315 VSS.n3279 0.267428
R12816 VSS.n3315 VSS.n3278 0.267428
R12817 VSS.n3315 VSS.n3276 0.267428
R12818 VSS.n3315 VSS.n3274 0.267428
R12819 VSS.n3315 VSS.n3070 0.267428
R12820 VSS.n3315 VSS.n3270 0.267428
R12821 VSS.n3315 VSS.n3073 0.267428
R12822 VSS.n3315 VSS.n3267 0.267428
R12823 VSS.n3315 VSS.n3263 0.267428
R12824 VSS.n3315 VSS.n3079 0.267428
R12825 VSS.n3315 VSS.n3260 0.267428
R12826 VSS.n3315 VSS.n3258 0.267428
R12827 VSS.n3315 VSS.n3254 0.267428
R12828 VSS.n3315 VSS.n3253 0.267428
R12829 VSS.n3315 VSS.n3251 0.267428
R12830 VSS.n3315 VSS.n3250 0.267428
R12831 VSS.n3315 VSS.n3095 0.267428
R12832 VSS.n3315 VSS.n3246 0.267428
R12833 VSS.n3315 VSS.n3098 0.267428
R12834 VSS.n3315 VSS.n3243 0.267428
R12835 VSS.n3315 VSS.n3239 0.267428
R12836 VSS.n3315 VSS.n3104 0.267428
R12837 VSS.n3315 VSS.n3237 0.267428
R12838 VSS.n3315 VSS.n3235 0.267428
R12839 VSS.n3315 VSS.n3231 0.267428
R12840 VSS.n3315 VSS.n3230 0.267428
R12841 VSS.n3315 VSS.n3228 0.267428
R12842 VSS.n3315 VSS.n3227 0.267428
R12843 VSS.n3315 VSS.n3223 0.267428
R12844 VSS.n3315 VSS.n3222 0.267428
R12845 VSS.n3315 VSS.n3122 0.267428
R12846 VSS.n3315 VSS.n3125 0.267428
R12847 VSS.n3315 VSS.n3216 0.267428
R12848 VSS.n3315 VSS.n3129 0.267428
R12849 VSS.n3315 VSS.n3214 0.267428
R12850 VSS.n3315 VSS.n3212 0.267428
R12851 VSS.n3315 VSS.n3208 0.267428
R12852 VSS.n3315 VSS.n3207 0.267428
R12853 VSS.n3315 VSS.n3205 0.267428
R12854 VSS.n3315 VSS.n3204 0.267428
R12855 VSS.n3315 VSS.n3200 0.267428
R12856 VSS.n3315 VSS.n3199 0.267428
R12857 VSS.n3315 VSS.n3149 0.267428
R12858 VSS.n3315 VSS.n3152 0.267428
R12859 VSS.n3315 VSS.n3193 0.267428
R12860 VSS.n3315 VSS.n3192 0.267428
R12861 VSS.n3315 VSS.n3190 0.267428
R12862 VSS.n3315 VSS.n3188 0.267428
R12863 VSS.n2167 VSS.n2170 0.265903
R12864 VSS.n2920 VSS.n2919 0.265797
R12865 VSS.t1039 VSS.n263 0.264637
R12866 VSS.t879 VSS.n1296 0.264468
R12867 VSS.t755 VSS.n808 0.264468
R12868 VSS.t657 VSS.n1144 0.264294
R12869 VSS.n2919 VSS.n2918 0.263915
R12870 VSS.t2198 VSS.n611 0.26243
R12871 VSS.n2183 VSS.n2198 0.260023
R12872 VSS.t291 VSS.t288 0.255774
R12873 VSS.t278 VSS.t276 0.255774
R12874 VSS.t243 VSS.t241 0.255774
R12875 VSS.t456 VSS.t453 0.255774
R12876 VSS.t443 VSS.t441 0.255774
R12877 VSS.t419 VSS.t417 0.255774
R12878 VSS.t407 VSS.t405 0.255774
R12879 VSS.n2801 VSS.t253 0.255548
R12880 VSS.n2498 VSS.t301 0.255324
R12881 VSS.n641 VSS.t466 0.255324
R12882 VSS.n2763 VSS.t262 0.254672
R12883 VSS.n610 VSS.t427 0.254672
R12884 VSS.t494 VSS.t75 0.254653
R12885 VSS.t553 VSS.t1367 0.254653
R12886 VSS.t564 VSS.t1534 0.254637
R12887 VSS.t539 VSS.t184 0.254637
R12888 VSS.t1838 VSS.t505 0.254476
R12889 VSS.t566 VSS.n342 0.254083
R12890 VSS.n3372 VSS.n238 0.25394
R12891 VSS.n3321 VSS.n3320 0.25394
R12892 VSS.n3016 VSS.n3015 0.25394
R12893 VSS.n1554 VSS.t496 0.25353
R12894 VSS.n2979 VSS.n2978 0.24416
R12895 VSS.n3184 VSS.t1766 0.24355
R12896 VSS.n968 VSS.t1675 0.24355
R12897 VSS.n1575 VSS.t2248 0.24305
R12898 VSS.t1539 VSS.n1926 0.243044
R12899 VSS.n349 VSS.t702 0.242883
R12900 VSS.n2182 VSS.n2194 0.240382
R12901 VSS.n1038 VSS.n847 0.239685
R12902 VSS.n1666 VSS.n120 0.239685
R12903 VSS.n1635 VSS.n1634 0.239685
R12904 VSS.n2730 VSS.n2729 0.239006
R12905 VSS.n2888 VSS.n2887 0.239006
R12906 VSS.n2889 VSS.n5 0.332933
R12907 VSS.n2891 VSS.n2890 0.239006
R12908 VSS.n2893 VSS.n2892 0.239006
R12909 VSS.n2894 VSS.n10 0.332933
R12910 VSS.n2318 VSS.n2317 0.239006
R12911 VSS.n2907 VSS.n39 0.332933
R12912 VSS.n2241 VSS.n2240 0.239006
R12913 VSS.n2909 VSS.t511 0.239006
R12914 VSS.t47 VSS.n25 0.42443
R12915 VSS.n2890 VSS.n2889 0.238668
R12916 VSS.n8 VSS.n2891 0.332521
R12917 VSS.n12 VSS.n2895 0.332521
R12918 VSS.n2210 VSS.n2209 0.238668
R12919 VSS.n2927 VSS.n37 0.333474
R12920 VSS.n39 VSS.t48 0.141785
R12921 VSS.n40 VSS.n2907 0.332521
R12922 VSS.t1000 VSS.n2749 0.238668
R12923 VSS.n2207 VSS.t55 0.238668
R12924 VSS.n2958 VSS.n2166 0.238218
R12925 VSS.n2991 VSS.n2990 0.233757
R12926 VSS.n3003 VSS.n3002 0.233757
R12927 VSS.n2990 VSS.t834 0.233419
R12928 VSS.n2999 VSS.n2998 0.233419
R12929 VSS.n1672 VSS.n1643 0.226107
R12930 VSS.n2970 VSS.n2969 0.225543
R12931 VSS.n3322 VSS.t1866 0.224842
R12932 VSS.n3017 VSS.t2085 0.224842
R12933 VSS.n3368 VSS.t2 0.224842
R12934 VSS.t284 VSS.t281 0.224424
R12935 VSS.t272 VSS.t270 0.224424
R12936 VSS.t260 VSS.t257 0.224424
R12937 VSS.t249 VSS.t246 0.224424
R12938 VSS.t237 VSS.t234 0.224424
R12939 VSS.t449 VSS.t446 0.224424
R12940 VSS.t437 VSS.t434 0.224424
R12941 VSS.t425 VSS.t422 0.224424
R12942 VSS.t413 VSS.t410 0.224424
R12943 VSS.t401 VSS.t398 0.224424
R12944 VSS.t341 VSS.t344 0.224424
R12945 VSS.t295 VSS.t297 0.224424
R12946 VSS.t227 VSS.t224 0.224424
R12947 VSS.t388 VSS.t390 0.224424
R12948 VSS.t462 VSS.t460 0.224424
R12949 VSS.n2199 VSS.n2198 0.224399
R12950 VSS.t341 VSS.n134 0.0724751
R12951 VSS.t258 VSS.t257 0.220674
R12952 VSS.t294 VSS.t295 0.220674
R12953 VSS.t281 VSS.t282 0.220674
R12954 VSS.t270 VSS.t14 0.220674
R12955 VSS.t246 VSS.t247 0.220674
R12956 VSS.t234 VSS.t235 0.220674
R12957 VSS.t224 VSS.t225 0.220674
R12958 VSS.t388 VSS.n141 0.0724751
R12959 VSS.t459 VSS.t460 0.220674
R12960 VSS.t446 VSS.t447 0.220674
R12961 VSS.t434 VSS.t435 0.220674
R12962 VSS.t422 VSS.t423 0.220674
R12963 VSS.t410 VSS.t411 0.220674
R12964 VSS.t398 VSS.t399 0.220674
R12965 VSS.n2969 VSS.n2160 0.219552
R12966 VSS.n2856 VSS.n1202 0.219405
R12967 VSS.n726 VSS.n239 0.219405
R12968 VSS.n2763 VSS.t265 0.215275
R12969 VSS.n610 VSS.t430 0.215275
R12970 VSS.t473 VSS.n2196 0.211735
R12971 VSS.n2240 VSS.n2238 0.208461
R12972 VSS.n2967 VSS.n2966 0.20686
R12973 VSS.n3169 VSS.n1184 0.202646
R12974 VSS.n150 VSS.n846 0.297117
R12975 VSS.t826 VSS.n98 0.201909
R12976 VSS.t154 VSS.n2183 0.201011
R12977 VSS.n2986 VSS.n89 0.195641
R12978 VSS.n2156 VSS.n89 0.195641
R12979 VSS.n2157 VSS.n2156 0.195641
R12980 VSS.n2977 VSS.n2976 0.195641
R12981 VSS.n2978 VSS.n2977 0.195641
R12982 VSS.n2749 VSS.n2762 0.191235
R12983 VSS.n2953 VSS.n0 0.191235
R12984 VSS.n2895 VSS.n2894 0.191235
R12985 VSS.t517 VSS.n2213 0.191235
R12986 VSS.n2921 VSS.n2212 0.191235
R12987 VSS.n2211 VSS.n2921 0.191235
R12988 VSS.n2925 VSS.t55 0.191235
R12989 VSS.n2926 VSS.n2925 0.191235
R12990 VSS.n2206 VSS.n2926 0.191235
R12991 VSS.n37 VSS.t57 0.0953067
R12992 VSS.t511 VSS.n2222 0.191235
R12993 VSS.n2902 VSS.n2222 0.191235
R12994 VSS.n2903 VSS.n2902 0.191235
R12995 VSS.n2904 VSS.n2903 0.191235
R12996 VSS.n2905 VSS.n2904 0.191235
R12997 VSS.n2906 VSS.t47 0.191235
R12998 VSS.n2245 VSS.n2244 0.191235
R12999 VSS.n3169 VSS.n3168 0.191235
R13000 VSS.n150 VSS.n965 0.23732
R13001 VSS.t57 VSS.n2206 0.191235
R13002 VSS.n2210 VSS.t53 0.191235
R13003 VSS.t53 VSS.n18 0.0953067
R13004 VSS.t51 VSS.n2211 0.191235
R13005 VSS.t48 VSS.n38 0.286042
R13006 VSS.t517 VSS.t50 0.191235
R13007 VSS.n2212 VSS.t50 0.191235
R13008 VSS.n2887 VSS.n2218 0.1908
R13009 VSS.t290 VSS.n2466 0.1883
R13010 VSS.n626 VSS.t455 0.1883
R13011 VSS.t534 VSS.t536 0.1875
R13012 VSS.t531 VSS.t528 0.1875
R13013 VSS.t525 VSS.t522 0.1875
R13014 VSS.t500 VSS.t502 0.1875
R13015 VSS.t489 VSS.t491 0.1875
R13016 VSS.t546 VSS.t549 0.1875
R13017 VSS.t559 VSS.t561 0.1875
R13018 VSS.n2828 VSS.n2407 0.187352
R13019 VSS.n2992 VSS.n2991 0.187025
R13020 VSS.n2993 VSS.n2992 0.187025
R13021 VSS.n2994 VSS.n2993 0.187025
R13022 VSS.n2995 VSS.n2994 0.187025
R13023 VSS.n2996 VSS.n2995 0.187025
R13024 VSS.n2997 VSS.n2996 0.187025
R13025 VSS.n2998 VSS.n2997 0.187025
R13026 VSS.n2140 VSS.n3003 0.187025
R13027 VSS.t818 VSS.n2140 0.187025
R13028 VSS.n3373 VSS.n237 0.18425
R13029 VSS.n1637 VSS.n1287 0.18425
R13030 VSS.n1140 VSS.n1139 0.18425
R13031 VSS.n3319 VSS.n3318 0.18425
R13032 VSS.n3014 VSS.n3013 0.18425
R13033 VSS.n2200 VSS.n2205 0.181924
R13034 VSS.n2236 VSS.n2234 0.181543
R13035 VSS.n2197 VSS 0.179433
R13036 VSS.n3322 VSS.n1073 0.171311
R13037 VSS.n3017 VSS.n1225 0.171311
R13038 VSS.n3368 VSS.n772 0.171311
R13039 VSS.n2910 VSS.t509 0.167615
R13040 VSS.n2158 VSS.n2157 0.167615
R13041 VSS.n2202 VSS.n2234 0.164808
R13042 VSS.n2201 VSS.n2200 0.164424
R13043 VSS.n1639 VSS.n1620 0.16137
R13044 VSS.n1639 VSS.n1628 0.16137
R13045 VSS.n1639 VSS.n1632 0.16137
R13046 VSS.n3322 VSS.t1487 0.16101
R13047 VSS.n3017 VSS.t949 0.16101
R13048 VSS.n3368 VSS.t783 0.16101
R13049 VSS.n3315 VSS.n3024 0.160396
R13050 VSS.n3315 VSS.n1194 0.160396
R13051 VSS.n3315 VSS.n1190 0.160396
R13052 VSS.n2884 VSS.n45 0.160336
R13053 VSS.n2221 VSS.n2909 0.15955
R13054 VSS.n3322 VSS.n1077 0.157243
R13055 VSS.n3017 VSS.n1229 0.157243
R13056 VSS.n3368 VSS.n776 0.157243
R13057 VSS.n2974 VSS.n2973 0.156138
R13058 VSS.n2916 VSS.n2915 0.150687
R13059 VSS.t808 VSS.n113 0.149232
R13060 VSS.n2244 VSS.n2243 0.147617
R13061 VSS.n2987 VSS.n2986 0.146675
R13062 VSS.n2203 VSS.n2241 0.14455
R13063 VSS.n20 VSS.n2937 0.1433
R13064 VSS.n3168 VSS.n3167 0.142513
R13065 VSS.n2237 VSS.n2233 0.142012
R13066 VSS.t556 VSS.n846 0.139294
R13067 VSS.t543 VSS.n1184 0.138956
R13068 VSS.t822 VSS.n98 0.13875
R13069 VSS.n2202 VSS.n2233 0.138262
R13070 VSS.n3372 VSS.n3371 0.138073
R13071 VSS.n3320 VSS.n3317 0.138073
R13072 VSS.n3316 VSS.n1135 0.138073
R13073 VSS.n3015 VSS.n1641 0.138073
R13074 VSS.t1766 VSS.t537 0.135868
R13075 VSS.t1539 VSS.t503 0.135868
R13076 VSS.t2248 VSS.t492 0.135868
R13077 VSS.t1675 VSS.t550 0.135868
R13078 VSS.t702 VSS.t562 0.135868
R13079 VSS.n2466 VSS.t291 0.133638
R13080 VSS.t456 VSS.n626 0.133638
R13081 VSS.n3021 VSS.n1202 0.124938
R13082 VSS.n2870 VSS.n1202 0.124938
R13083 VSS.t505 VSS.n1941 0.124618
R13084 VSS.t564 VSS.n340 0.124618
R13085 VSS.t494 VSS.n1552 0.124618
R13086 VSS.t539 VSS.n1182 0.124618
R13087 VSS.t553 VSS.n844 0.124618
R13088 VSS.n1941 VSS.t506 0.122118
R13089 VSS.n1940 VSS.t503 0.122118
R13090 VSS.t565 VSS.n340 0.122118
R13091 VSS.t562 VSS.n347 0.122118
R13092 VSS.t495 VSS.n1552 0.122118
R13093 VSS.t492 VSS.n1574 0.122118
R13094 VSS.t540 VSS.n1182 0.122118
R13095 VSS.t537 VSS.n3163 0.122118
R13096 VSS.t550 VSS.n796 0.122118
R13097 VSS.t552 VSS.n844 0.122118
R13098 VSS.n2242 VSS.n20 0.168638
R13099 VSS.n2062 VSS.n1991 0.119618
R13100 VSS.n1771 VSS.t1542 0.119618
R13101 VSS.n574 VSS.n573 0.119618
R13102 VSS.n295 VSS.n294 0.119618
R13103 VSS.t705 VSS.n485 0.119618
R13104 VSS.n1634 VSS.n1633 0.119618
R13105 VSS.n1394 VSS.n1393 0.119618
R13106 VSS.t1191 VSS.n1598 0.119618
R13107 VSS.n1666 VSS.n1648 0.119618
R13108 VSS.n1187 VSS.n1186 0.119618
R13109 VSS.n1159 VSS.n1158 0.119618
R13110 VSS.t753 VSS.n3081 0.119618
R13111 VSS.t1678 VSS.n894 0.119618
R13112 VSS.n822 VSS.n821 0.119618
R13113 VSS.n1039 VSS.n1038 0.119618
R13114 VSS.t804 VSS.n113 0.119272
R13115 VSS.n326 VSS.n325 0.118368
R13116 VSS.t1225 VSS.n396 0.118368
R13117 VSS.n1498 VSS.n1497 0.117118
R13118 VSS.n1174 VSS.n1173 0.117118
R13119 VSS.n837 VSS.n836 0.117118
R13120 VSS.n3132 VSS.t169 0.117118
R13121 VSS.t2101 VSS.n1875 0.117118
R13122 VSS.n1582 VSS.t2050 0.117118
R13123 VSS.n937 VSS.t1562 0.117118
R13124 VSS.t514 VSS.n2203 0.1171
R13125 VSS.n3322 VSS.n1067 0.115329
R13126 VSS.n3017 VSS.n1219 0.115329
R13127 VSS.n3368 VSS.n766 0.115329
R13128 VSS.n2213 VSS.n2215 0.112118
R13129 VSS.n2938 VSS.n2937 0.111556
R13130 VSS.t1133 VSS.n642 0.109701
R13131 VSS.t541 VSS.n3167 0.109642
R13132 VSS.n965 VSS.t554 0.109642
R13133 VSS.n2205 VSS.n2204 0.104618
R13134 VSS.n2247 VSS.n2236 0.104618
R13135 VSS.t832 VSS.n98 0.103851
R13136 VSS.t526 VSS.n2164 0.0971176
R13137 VSS.n2974 VSS.n0 0.0971176
R13138 VSS.t814 VSS.n113 0.0959946
R13139 VSS.n2973 VSS.n2972 0.0958002
R13140 VSS.n2972 VSS.n2971 0.0955
R13141 VSS.n2203 VSS.n2245 0.0946176
R13142 VSS.n77 VSS.n75 0.0940547
R13143 VSS.n2166 VSS.n2168 0.093
R13144 VSS.t1446 VSS.n1185 0.0928744
R13145 VSS.t1826 VSS.n343 0.0928744
R13146 VSS.n2976 VSS.n2975 0.0903963
R13147 VSS.n3012 VSS.t498 0.08925
R13148 VSS.t557 VSS.n258 0.08925
R13149 VSS.n1638 VSS.t487 0.08925
R13150 VSS.t532 VSS.n1141 0.08925
R13151 VSS.t544 VSS.n805 0.08925
R13152 VSS.t1156 VSS.n1667 0.08925
R13153 VSS.t30 VSS.n1618 0.08925
R13154 VSS.t1611 VSS.n848 0.08925
R13155 VSS.t2046 VSS.n1771 0.0883676
R13156 VSS.n1881 VSS.t2101 0.0883676
R13157 VSS.n485 VSS.t2015 0.0883676
R13158 VSS.t1225 VSS.n397 0.0883676
R13159 VSS.n1598 VSS.t1618 0.0883676
R13160 VSS.t2050 VSS.n1583 0.0883676
R13161 VSS.t1118 VSS.n3081 0.0883676
R13162 VSS.t169 VSS.n3136 0.0883676
R13163 VSS.t2022 VSS.n894 0.0883676
R13164 VSS.t1562 VSS.n941 0.0883676
R13165 VSS.n3322 VSS.n1088 0.0871478
R13166 VSS.n3017 VSS.n1240 0.0871478
R13167 VSS.n3368 VSS.n787 0.0871478
R13168 VSS.n1077 VSS.t1893 0.0867332
R13169 VSS.n1229 VSS.t1550 0.0867332
R13170 VSS.n776 VSS.t1061 0.0867332
R13171 VSS.n1616 VSS.t489 0.0851154
R13172 VSS.t491 VSS.n1615 0.0851154
R13173 VSS.n2957 VSS.t528 0.0851154
R13174 VSS.n2955 VSS.t531 0.0851154
R13175 VSS.n2961 VSS.t522 0.0851154
R13176 VSS.n2959 VSS.t525 0.0851154
R13177 VSS.n3313 VSS.t534 0.0851154
R13178 VSS.t536 VSS.n3033 0.0851154
R13179 VSS.n1036 VSS.t546 0.0851154
R13180 VSS.t549 VSS.n852 0.0851154
R13181 VSS.n571 VSS.t559 0.0851154
R13182 VSS.t561 VSS.n570 0.0851154
R13183 VSS.n1670 VSS.t500 0.0851154
R13184 VSS.t502 VSS.n1669 0.0851154
R13185 VSS.n2932 VSS.n2931 0.08425
R13186 VSS.n2255 VSS.n2253 0.08425
R13187 VSS.n2962 VSS.n2961 0.08175
R13188 VSS.n2165 VSS.n2957 0.08175
R13189 VSS.n2171 VSS.n2172 0.08175
R13190 VSS.n2161 VSS.n2162 0.08175
R13191 VSS.n2511 VSS.n1934 0.0805
R13192 VSS.t566 VSS.n345 0.0805
R13193 VSS.n1573 VSS.t496 0.0805
R13194 VSS.n2937 VSS.n2936 0.0805
R13195 VSS.n3172 VSS.n3165 0.0805
R13196 VSS.n3326 VSS.n3325 0.0805
R13197 VSS.n2215 VSS.n2214 0.0796176
R13198 VSS.n2221 VSS.n2220 0.0796176
R13199 VSS.n2980 VSS.n2153 0.0780484
R13200 VSS.n1651 VSS.n1650 0.078
R13201 VSS.n1189 VSS.n1188 0.078
R13202 VSS.t1869 VSS.n1991 0.0771176
R13203 VSS.n1938 VSS.n1937 0.0771176
R13204 VSS.t637 VSS.n295 0.0771176
R13205 VSS.t1661 VSS.n326 0.0771176
R13206 VSS.t635 VSS.n1394 0.0771176
R13207 VSS.t580 VSS.n1498 0.0771176
R13208 VSS.t1588 VSS.n1159 0.0771176
R13209 VSS.t1030 VSS.n1174 0.0771176
R13210 VSS.t543 VSS.n1183 0.0771176
R13211 VSS.t1167 VSS.n822 0.0771176
R13212 VSS.t112 VSS.n837 0.0771176
R13213 VSS.t556 VSS.n845 0.0771176
R13214 VSS.n2214 VSS.n2920 0.0758676
R13215 VSS.n2912 VSS.n2220 0.0758676
R13216 VSS.n1671 VSS.n1646 0.0746176
R13217 VSS.n1670 VSS.n1668 0.0746176
R13218 VSS.n568 VSS.n260 0.0746176
R13219 VSS.n572 VSS.n571 0.0746176
R13220 VSS.n1613 VSS.n1290 0.0746176
R13221 VSS.n1617 VSS.n1616 0.0746176
R13222 VSS.n3311 VSS.n1142 0.0746176
R13223 VSS.n3314 VSS.n3313 0.0746176
R13224 VSS.n1037 VSS.n1036 0.0746176
R13225 VSS.n1034 VSS.n806 0.0746176
R13226 VSS.n2312 VSS.n73 0.07425
R13227 VSS.n2936 VSS.n2201 0.07425
R13228 VSS.n2964 VSS.n2963 0.0740901
R13229 VSS.n2174 VSS.t520 0.0740901
R13230 VSS.n2407 VSS.t764 0.0724426
R13231 VSS.t1044 VSS.n73 0.07175
R13232 VSS.t506 VSS.n1938 0.0696176
R13233 VSS.t540 VSS.n1183 0.0696176
R13234 VSS.n845 VSS.t552 0.0696176
R13235 VSS.n1671 VSS.n1644 0.06925
R13236 VSS.t2068 VSS.n1670 0.06925
R13237 VSS.t299 VSS.n2478 0.06925
R13238 VSS.n2634 VSS.t286 0.06925
R13239 VSS.n2693 VSS.t274 0.06925
R13240 VSS.t263 VSS.n2822 0.06925
R13241 VSS.t251 VSS.n2803 0.06925
R13242 VSS.n2854 VSS.t239 0.06925
R13243 VSS.n568 VSS.n261 0.06925
R13244 VSS.n571 VSS.t1828 0.06925
R13245 VSS.t464 VSS.n639 0.06925
R13246 VSS.n663 VSS.t451 0.06925
R13247 VSS.n676 VSS.t439 0.06925
R13248 VSS.n698 VSS.t428 0.06925
R13249 VSS.n711 VSS.t415 0.06925
R13250 VSS.n724 VSS.t403 0.06925
R13251 VSS.n1613 VSS.n1293 0.06925
R13252 VSS.n1616 VSS.t2054 0.06925
R13253 VSS.n2933 VSS.n2932 0.06925
R13254 VSS.n2253 VSS.n2252 0.06925
R13255 VSS.n3311 VSS.n1143 0.06925
R13256 VSS.n3313 VSS.t1448 0.06925
R13257 VSS.n1036 VSS.t1850 0.06925
R13258 VSS.n1034 VSS.n807 0.06925
R13259 VSS.n2960 VSS.n2959 0.0671176
R13260 VSS.n2956 VSS.n2955 0.0671176
R13261 VSS.n2170 VSS.n2169 0.0671176
R13262 VSS.n2160 VSS.n2159 0.0671176
R13263 VSS.n3010 VSS.n1937 0.06675
R13264 VSS.n574 VSS.t147 0.0658676
R13265 VSS.n1633 VSS.t1754 0.0658676
R13266 VSS.n1650 VSS.n1648 0.0658676
R13267 VSS.n1188 VSS.n1187 0.0658676
R13268 VSS.n1039 VSS.t589 0.0658676
R13269 VSS.n2961 VSS.n2960 0.0621177
R13270 VSS.n2957 VSS.n2956 0.0621177
R13271 VSS.n2169 VSS.n2171 0.0621177
R13272 VSS.n2159 VSS.n2161 0.0621177
R13273 VSS.n1672 VSS.n1644 0.05925
R13274 VSS.n569 VSS.n261 0.05925
R13275 VSS.n1614 VSS.n1293 0.05925
R13276 VSS.n3312 VSS.n1143 0.05925
R13277 VSS.n1035 VSS.n807 0.05925
R13278 VSS.n3033 VSS.t1448 0.05925
R13279 VSS.n1669 VSS.t2068 0.05925
R13280 VSS.n1615 VSS.t2054 0.05925
R13281 VSS.n852 VSS.t1850 0.05925
R13282 VSS.n570 VSS.t1828 0.05925
R13283 VSS.t263 VSS.n2765 0.058
R13284 VSS.t428 VSS.n697 0.058
R13285 VSS.n2164 VSS.t1719 0.0571176
R13286 VSS.t819 VSS.n2987 0.0567791
R13287 VSS.n1646 VSS.t498 0.0546176
R13288 VSS.n1668 VSS.t1156 0.0546176
R13289 VSS.t557 VSS.n260 0.0546176
R13290 VSS.n572 VSS.t1826 0.0546176
R13291 VSS.t487 VSS.n1290 0.0546176
R13292 VSS.t30 VSS.n1617 0.0546176
R13293 VSS.t532 VSS.n1142 0.0546176
R13294 VSS.n3314 VSS.t1446 0.0546176
R13295 VSS.n1037 VSS.t1611 0.0546176
R13296 VSS.t544 VSS.n806 0.0546176
R13297 VSS.t297 VSS.n2478 0.05175
R13298 VSS.t284 VSS.n2634 0.05175
R13299 VSS.t272 VSS.n2693 0.05175
R13300 VSS.n2822 VSS.t260 0.05175
R13301 VSS.n2803 VSS.t249 0.05175
R13302 VSS.t237 VSS.n2854 0.05175
R13303 VSS.n639 VSS.t462 0.05175
R13304 VSS.t449 VSS.n663 0.05175
R13305 VSS.t437 VSS.n676 0.05175
R13306 VSS.t425 VSS.n698 0.05175
R13307 VSS.t413 VSS.n711 0.05175
R13308 VSS.t401 VSS.n724 0.05175
R13309 VSS.n2204 VSS.n2935 0.0496177
R13310 VSS.n2247 VSS.n2246 0.0496177
R13311 VSS.n2168 VSS.n2163 0.04925
R13312 VSS.n2163 VSS.n2165 0.04675
R13313 VSS.n2162 VSS.t526 0.04675
R13314 VSS.n3 VSS.n1 0.0160464
R13315 VSS.t262 VSS.n2765 0.038
R13316 VSS.n697 VSS.t427 0.038
R13317 VSS.t1044 VSS.n2938 0.0353056
R13318 VSS.n2238 VSS.n2237 0.0345427
R13319 VSS.n2965 VSS.n2962 0.0305
R13320 VSS.n2172 VSS.n2968 0.0305
R13321 VSS.t1307 VSS.n2022 0.02925
R13322 VSS.t507 VSS.n1935 0.02925
R13323 VSS.t1074 VSS.n1651 0.02925
R13324 VSS.t864 VSS.n1189 0.02925
R13325 VSS.n3170 VSS.t541 0.02925
R13326 VSS.t554 VSS.n191 0.02925
R13327 VSS.n2918 VSS.n2218 0.028
R13328 VSS.n2882 VSS.n1202 0.0254395
R13329 VSS.n2175 VSS.n2174 0.0253401
R13330 VSS.n2963 VSS.n2177 0.0253401
R13331 VSS.n650 VSS.n649 0.023135
R13332 VSS.n750 VSS.n239 0.023135
R13333 VSS.n742 VSS.n239 0.023135
R13334 VSS.n738 VSS.n239 0.023135
R13335 VSS.n732 VSS.n239 0.023135
R13336 VSS.n721 VSS.n588 0.023135
R13337 VSS.n714 VSS.n593 0.023135
R13338 VSS.n716 VSS.n593 0.023135
R13339 VSS.n708 VSS.n597 0.023135
R13340 VSS.n701 VSS.n602 0.023135
R13341 VSS.n703 VSS.n602 0.023135
R13342 VSS.n694 VSS.n606 0.023135
R13343 VSS.n679 VSS.n611 0.023135
R13344 VSS.n681 VSS.n611 0.023135
R13345 VSS.n684 VSS.n611 0.023135
R13346 VSS.n689 VSS.n611 0.023135
R13347 VSS.n673 VSS.n615 0.023135
R13348 VSS.n666 VSS.n620 0.023135
R13349 VSS.n668 VSS.n620 0.023135
R13350 VSS.n660 VSS.n624 0.023135
R13351 VSS.n631 VSS.n629 0.023135
R13352 VSS.n650 VSS.n645 0.023135
R13353 VSS.n654 VSS.n653 0.023135
R13354 VSS.n633 VSS.n629 0.023135
R13355 VSS.t379 VSS.n787 0.0228185
R13356 VSS.t333 VSS.n1088 0.0228185
R13357 VSS.t216 VSS.n1240 0.0228185
R13358 VSS.n1940 VSS.n1934 0.02175
R13359 VSS.n347 VSS.n345 0.02175
R13360 VSS.n1574 VSS.n1573 0.02175
R13361 VSS.n3163 VSS.n3165 0.02175
R13362 VSS.n3325 VSS.n796 0.02175
R13363 VSS.n2975 VSS.n2158 0.0214413
R13364 VSS.t907 VSS.n241 0.018087
R13365 VSS.t473 VSS.n2192 0.0173993
R13366 VSS.n2965 VSS.n2964 0.01675
R13367 VSS.n2968 VSS.t520 0.01675
R13368 VSS.n1639 VSS.n1619 0.0166972
R13369 VSS.n1639 VSS.n1624 0.0166972
R13370 VSS.n2851 VSS.n2324 0.0165968
R13371 VSS.n2842 VSS.n2329 0.0165968
R13372 VSS.n2844 VSS.n2329 0.0165968
R13373 VSS.n3322 VSS.n1066 0.0165968
R13374 VSS.n3322 VSS.n1070 0.0165968
R13375 VSS.n3322 VSS.n1071 0.0165968
R13376 VSS.n3322 VSS.n1075 0.0165968
R13377 VSS.n3322 VSS.n1076 0.0165968
R13378 VSS.n3322 VSS.n1080 0.0165968
R13379 VSS.n3322 VSS.n1081 0.0165968
R13380 VSS.n3322 VSS.n1082 0.0165968
R13381 VSS.n3322 VSS.n1086 0.0165968
R13382 VSS.n3322 VSS.n1090 0.0165968
R13383 VSS.n3322 VSS.n1091 0.0165968
R13384 VSS.n3322 VSS.n1095 0.0165968
R13385 VSS.n3180 VSS.n136 0.0165968
R13386 VSS.n3178 VSS.n136 0.0165968
R13387 VSS.n3322 VSS.n1096 0.0165968
R13388 VSS.n3017 VSS.n1218 0.0165968
R13389 VSS.n3017 VSS.n1222 0.0165968
R13390 VSS.n3017 VSS.n1223 0.0165968
R13391 VSS.n3017 VSS.n1227 0.0165968
R13392 VSS.n3017 VSS.n1228 0.0165968
R13393 VSS.n3017 VSS.n1232 0.0165968
R13394 VSS.n3017 VSS.n1233 0.0165968
R13395 VSS.n3017 VSS.n1234 0.0165968
R13396 VSS.n3017 VSS.n1238 0.0165968
R13397 VSS.n3017 VSS.n1242 0.0165968
R13398 VSS.n3017 VSS.n1243 0.0165968
R13399 VSS.n3017 VSS.n1247 0.0165968
R13400 VSS.n1557 VSS.n1572 0.0165968
R13401 VSS.n1557 VSS.n1571 0.0165968
R13402 VSS.n3017 VSS.n1248 0.0165968
R13403 VSS.n3368 VSS.n765 0.0165968
R13404 VSS.n3368 VSS.n769 0.0165968
R13405 VSS.n3368 VSS.n770 0.0165968
R13406 VSS.n3368 VSS.n774 0.0165968
R13407 VSS.n3368 VSS.n775 0.0165968
R13408 VSS.n3368 VSS.n779 0.0165968
R13409 VSS.n3368 VSS.n780 0.0165968
R13410 VSS.n3368 VSS.n781 0.0165968
R13411 VSS.n3368 VSS.n785 0.0165968
R13412 VSS.n3368 VSS.n789 0.0165968
R13413 VSS.n3368 VSS.n790 0.0165968
R13414 VSS.n3368 VSS.n794 0.0165968
R13415 VSS.n148 VSS.n144 0.0165968
R13416 VSS.n148 VSS.n145 0.0165968
R13417 VSS.n3368 VSS.n795 0.0165968
R13418 VSS.n3315 VSS.n3025 0.0165542
R13419 VSS.n3315 VSS.n1198 0.0165542
R13420 VSS.n2511 VSS.n1935 0.0155
R13421 VSS.n3172 VSS.n3170 0.0155
R13422 VSS.n3326 VSS.n191 0.0155
R13423 VSS.t473 VSS.n2188 0.0150892
R13424 VSS.n2971 VSS.n2970 0.013
R13425 VSS.n127 VSS.n117 0.00975656
R13426 VSS.n1639 VSS.n1292 0.0096403
R13427 VSS.n1639 VSS.n1301 0.0096403
R13428 VSS.n1639 VSS.n1317 0.0096403
R13429 VSS.n1639 VSS.n1333 0.0096403
R13430 VSS.n1639 VSS.n1349 0.0096403
R13431 VSS.n1639 VSS.n1365 0.0096403
R13432 VSS.n1639 VSS.n1381 0.0096403
R13433 VSS.n1639 VSS.n1398 0.0096403
R13434 VSS.n1639 VSS.n1414 0.0096403
R13435 VSS.n1639 VSS.n1430 0.0096403
R13436 VSS.n1639 VSS.n1446 0.0096403
R13437 VSS.n1639 VSS.n1462 0.0096403
R13438 VSS.n1639 VSS.n1478 0.0096403
R13439 VSS.n1639 VSS.n1494 0.0096403
R13440 VSS.n1639 VSS.n1511 0.0096403
R13441 VSS.n1639 VSS.n1527 0.0096403
R13442 VSS.n1639 VSS.n1543 0.0096403
R13443 VSS.n1639 VSS.n1551 0.0096403
R13444 VSS.n151 VSS.n184 0.00962826
R13445 VSS.n346 VSS.n566 0.00938635
R13446 VSS.n346 VSS.n534 0.00938635
R13447 VSS.n346 VSS.n496 0.00938635
R13448 VSS.n346 VSS.n414 0.00938635
R13449 VSS.n151 VSS.n189 0.00938635
R13450 VSS.n3315 VSS.n3310 0.00938635
R13451 VSS.n3315 VSS.n3284 0.00938635
R13452 VSS.n3315 VSS.n3259 0.00938635
R13453 VSS.n3315 VSS.n3244 0.00938635
R13454 VSS.n3315 VSS.n3236 0.00938635
R13455 VSS.n3315 VSS.n3220 0.00938635
R13456 VSS.n3315 VSS.n3213 0.00938635
R13457 VSS.n3315 VSS.n3197 0.00938635
R13458 VSS.n3315 VSS.n3189 0.00938635
R13459 VSS.n3315 VSS.n1146 0.00938635
R13460 VSS.n346 VSS.n348 0.00938222
R13461 VSS.n346 VSS.n324 0.00937856
R13462 VSS.n346 VSS.n303 0.00937856
R13463 VSS.n346 VSS.n285 0.00937856
R13464 VSS.n346 VSS.n270 0.00937856
R13465 VSS.n346 VSS.n456 0.00937856
R13466 VSS.n346 VSS.n442 0.00937856
R13467 VSS.n346 VSS.n429 0.00937856
R13468 VSS.n346 VSS.n385 0.00937856
R13469 VSS.n346 VSS.n371 0.00937856
R13470 VSS.n346 VSS.n358 0.00937856
R13471 VSS.n151 VSS.n231 0.00937856
R13472 VSS.n151 VSS.n223 0.00937856
R13473 VSS.n151 VSS.n173 0.00937856
R13474 VSS.n151 VSS.n167 0.00937856
R13475 VSS.n3315 VSS.n3292 0.00937856
R13476 VSS.n3315 VSS.n3268 0.00937856
R13477 VSS.n3315 VSS.n3091 0.00937856
R13478 VSS.n3315 VSS.n3116 0.00937856
R13479 VSS.n3315 VSS.n3143 0.00937856
R13480 VSS.n346 VSS.n560 0.00937856
R13481 VSS.n346 VSS.n521 0.00937856
R13482 VSS.n346 VSS.n482 0.00937856
R13483 VSS.n151 VSS.n236 0.00937856
R13484 VSS.n151 VSS.n234 0.00937856
R13485 VSS.n151 VSS.n230 0.00937856
R13486 VSS.n151 VSS.n227 0.00937856
R13487 VSS.n151 VSS.n222 0.00937856
R13488 VSS.n151 VSS.n219 0.00937856
R13489 VSS.n151 VSS.n216 0.00937856
R13490 VSS.n151 VSS.n212 0.00937856
R13491 VSS.n151 VSS.n202 0.00937856
R13492 VSS.n151 VSS.n198 0.00937856
R13493 VSS.n151 VSS.n171 0.00937856
R13494 VSS.n151 VSS.n165 0.00937856
R13495 VSS.n3315 VSS.n3299 0.00937856
R13496 VSS.n3315 VSS.n3275 0.00937856
R13497 VSS.n3315 VSS.n1181 0.00937856
R13498 VSS.n3013 VSS.n3012 0.00675
R13499 VSS.n1667 VSS.n1666 0.00675
R13500 VSS.n258 VSS.n237 0.00675
R13501 VSS.n1638 VSS.n1637 0.00675
R13502 VSS.n1634 VSS.n1618 0.00675
R13503 VSS.n1141 VSS.n1140 0.00675
R13504 VSS.n1038 VSS.n848 0.00675
R13505 VSS.n3318 VSS.n805 0.00675
R13506 VSS.n2243 VSS.n2242 0.00474917
R13507 VSS.n573 VSS.n343 0.00412443
R13508 VSS.n1186 VSS.n1185 0.00412443
R13509 VSS.n2945 VSS.n1 0.00296307
R13510 VSS.n149 VSS.n151 0.00105218
R13511 VSS.n34 VSS.n31 0.00199999
R13512 VSS.n27 VSS.n31 0.00199992
R13513 VSS.n751 VSS.n239 0.00181696
R13514 VSS.n746 VSS.n239 0.00181696
R13515 VSS.n729 VSS.n586 0.00181696
R13516 VSS.n723 VSS.n591 0.00181696
R13517 VSS.n723 VSS.n592 0.00181696
R13518 VSS.n719 VSS.n595 0.00181696
R13519 VSS.n710 VSS.n600 0.00181696
R13520 VSS.n710 VSS.n601 0.00181696
R13521 VSS.n706 VSS.n604 0.00181696
R13522 VSS.n696 VSS.n608 0.00181696
R13523 VSS.n696 VSS.n609 0.00181696
R13524 VSS.n692 VSS.n613 0.00181696
R13525 VSS.n675 VSS.n618 0.00181696
R13526 VSS.n675 VSS.n619 0.00181696
R13527 VSS.n671 VSS.n622 0.00181696
R13528 VSS.n662 VSS.n627 0.00181696
R13529 VSS.n662 VSS.n628 0.00181696
R13530 VSS.n647 VSS.n640 0.00179957
R13531 VSS.n646 VSS.n640 0.00179957
R13532 VSS.n656 VSS.n636 0.00179957
R13533 VSS.n76 VSS.n2313 0.00175
R13534 VSS.n2747 VSS.n2395 0.00166667
R13535 VSS.n2746 VSS.n2391 0.00166667
R13536 VSS.n2397 VSS.n2396 0.00166667
R13537 VSS.n60 VSS.n59 0.00166667
R13538 VSS.n2239 VSS.n26 0.00166667
R13539 VSS.n2239 VSS.n33 0.00249999
R13540 VSS.n2924 VSS.n2923 0.00166667
R13541 VSS.n56 VSS.n53 0.00169993
R13542 VSS.n63 VSS.n62 0.00169993
R13543 VSS.n65 VSS.n64 0.00149995
R13544 VSS.n2320 VSS.n6 0.00166667
R13545 VSS.n2319 VSS.n2315 0.00166667
R13546 VSS.n68 VSS.n67 0.00138884
R13547 VSS.n2896 VSS.n2316 0.00166667
R13548 VSS.n2314 VSS.n2313 0.00166667
R13549 VSS.n80 VSS.n79 0.00169993
R13550 VSS.n88 VSS.n87 0.00169993
R13551 VSS.n2901 VSS.n30 0.00166667
R13552 VSS.n28 VSS.n27 0.00166667
R13553 VSS.n2981 VSS.n2152 0.00166667
R13554 VSS.n2147 VSS.n2136 0.00166667
R13555 VSS.n2144 VSS.n2137 0.00166667
R13556 VSS.n2143 VSS.n2135 0.00166667
R13557 VSS.n2142 VSS.n2138 0.00166667
R13558 VSS.n110 VSS.n109 0.00169993
R13559 VSS.n2948 VSS.n1 0.00160675
R13560 VSS.n2982 VSS.n113 0.00152382
R13561 VSS.n2939 VSS.n77 0.0015
R13562 VSS.n148 VSS.n138 0.0015
R13563 VSS.n140 VSS.n138 0.0015
R13564 VSS.n3368 VSS.n140 0.0015
R13565 VSS.n136 VSS.n131 0.0015
R13566 VSS.n133 VSS.n131 0.0015
R13567 VSS.n3322 VSS.n133 0.0015
R13568 VSS.n129 VSS.n128 0.00214264
R13569 VSS.n3315 VSS.n129 0.0015
R13570 VSS.n127 VSS.n115 0.00125
R13571 VSS.n2860 VSS.n2322 0.00148755
R13572 VSS.n2853 VSS.n2327 0.00148755
R13573 VSS.n2853 VSS.n2328 0.00148755
R13574 VSS.n3322 VSS.n1120 0.00148755
R13575 VSS.n3322 VSS.n1068 0.00148755
R13576 VSS.n3322 VSS.n1116 0.00148755
R13577 VSS.n3322 VSS.n1072 0.00148755
R13578 VSS.n3322 VSS.n1112 0.00148755
R13579 VSS.n3322 VSS.n1078 0.00148755
R13580 VSS.n3322 VSS.n1104 0.00148755
R13581 VSS.n3322 VSS.n1087 0.00148755
R13582 VSS.n3322 VSS.n1100 0.00148755
R13583 VSS.n3322 VSS.n1093 0.00148755
R13584 VSS.n3017 VSS.n1273 0.00148755
R13585 VSS.n3017 VSS.n1220 0.00148755
R13586 VSS.n3017 VSS.n1269 0.00148755
R13587 VSS.n3017 VSS.n1224 0.00148755
R13588 VSS.n3017 VSS.n1265 0.00148755
R13589 VSS.n3017 VSS.n1230 0.00148755
R13590 VSS.n3017 VSS.n1257 0.00148755
R13591 VSS.n3017 VSS.n1239 0.00148755
R13592 VSS.n3017 VSS.n1253 0.00148755
R13593 VSS.n3017 VSS.n1245 0.00148755
R13594 VSS.n3368 VSS.n3356 0.00148755
R13595 VSS.n3368 VSS.n767 0.00148755
R13596 VSS.n3368 VSS.n3352 0.00148755
R13597 VSS.n3368 VSS.n771 0.00148755
R13598 VSS.n3368 VSS.n3348 0.00148755
R13599 VSS.n3368 VSS.n777 0.00148755
R13600 VSS.n3368 VSS.n3340 0.00148755
R13601 VSS.n3368 VSS.n786 0.00148755
R13602 VSS.n3368 VSS.n3336 0.00148755
R13603 VSS.n3368 VSS.n792 0.00148755
R13604 VSS.n2982 VSS.n2981 0.00147616
R13605 VSS.n3176 VSS.n131 0.00147287
R13606 VSS.n3175 VSS.n131 0.00147287
R13607 VSS.n3174 VSS.n131 0.00147287
R13608 VSS.n133 VSS.n132 0.00147287
R13609 VSS.n1570 VSS.n1562 0.00147287
R13610 VSS.n1570 VSS.n1563 0.00147287
R13611 VSS.n1570 VSS.n1564 0.00147287
R13612 VSS.n1568 VSS.n1566 0.00147287
R13613 VSS.n3328 VSS.n138 0.00147287
R13614 VSS.n3329 VSS.n138 0.00147287
R13615 VSS.n3330 VSS.n138 0.00147287
R13616 VSS.n140 VSS.n139 0.00147287
R13617 VSS.n2208 VSS.n35 0.00137498
R13618 VSS.n2748 VSS.n2395 0.00133332
R13619 VSS.n2747 VSS.n2391 0.00133332
R13620 VSS.n2746 VSS.n2396 0.00133332
R13621 VSS.n2154 VSS.n2152 0.00133332
R13622 VSS.n2148 VSS.n2136 0.00133332
R13623 VSS.n2145 VSS.n2137 0.00133332
R13624 VSS.n2144 VSS.n2135 0.00133332
R13625 VSS.n2143 VSS.n2138 0.00133332
R13626 VSS.n2320 VSS.n2315 0.00133332
R13627 VSS.n2316 VSS.n2314 0.00133332
R13628 VSS.n2923 VSS.n2922 0.00133332
R13629 VSS.n59 VSS.n45 0.00133332
R13630 VSS.n2950 VSS.n1 0.00128573
R13631 VSS.n2947 VSS.n1 0.00128573
R13632 VSS.n2840 VSS.t96 0.00126823
R13633 VSS.n2883 VSS.n1202 0.0011222
R13634 VSS.n734 VSS.n239 0.00104753
R13635 VSS.n3322 VSS.n1122 0.00102991
R13636 VSS.n3322 VSS.n1119 0.00102991
R13637 VSS.n3322 VSS.n1115 0.00102991
R13638 VSS.n3322 VSS.n1111 0.00102991
R13639 VSS.n3322 VSS.n1103 0.00102991
R13640 VSS.n3322 VSS.n1099 0.00102991
R13641 VSS.n3017 VSS.n1275 0.00102991
R13642 VSS.n3017 VSS.n1272 0.00102991
R13643 VSS.n3017 VSS.n1268 0.00102991
R13644 VSS.n3017 VSS.n1264 0.00102991
R13645 VSS.n3017 VSS.n1256 0.00102991
R13646 VSS.n3017 VSS.n1252 0.00102991
R13647 VSS.n3368 VSS.n3358 0.00102991
R13648 VSS.n3368 VSS.n3355 0.00102991
R13649 VSS.n3368 VSS.n3351 0.00102991
R13650 VSS.n3368 VSS.n3347 0.00102991
R13651 VSS.n3368 VSS.n3339 0.00102991
R13652 VSS.n3368 VSS.n3335 0.00102991
R13653 VSS.n731 VSS.n239 0.00101876
R13654 VSS.n715 VSS.n593 0.00101876
R13655 VSS.n717 VSS.n593 0.00101876
R13656 VSS.n702 VSS.n602 0.00101876
R13657 VSS.n704 VSS.n602 0.00101876
R13658 VSS.n680 VSS.n611 0.00101876
R13659 VSS.n690 VSS.n611 0.00101876
R13660 VSS.n667 VSS.n620 0.00101876
R13661 VSS.n669 VSS.n620 0.00101876
R13662 VSS.n685 VSS.n611 0.00101872
R13663 VSS.n733 VSS.n239 0.00101872
R13664 VSS.n682 VSS.n611 0.00101872
R13665 VSS.n688 VSS.n611 0.00101872
R13666 VSS.n650 VSS.n644 0.00101811
R13667 VSS.n2845 VSS.n2329 0.00101641
R13668 VSS.n3322 VSS.n1069 0.00101605
R13669 VSS.n3322 VSS.n1074 0.00101605
R13670 VSS.n3322 VSS.n1079 0.00101605
R13671 VSS.n3322 VSS.n1089 0.00101605
R13672 VSS.n3322 VSS.n1094 0.00101605
R13673 VSS.n3017 VSS.n1221 0.00101605
R13674 VSS.n3017 VSS.n1226 0.00101605
R13675 VSS.n3017 VSS.n1231 0.00101605
R13676 VSS.n3017 VSS.n1241 0.00101605
R13677 VSS.n3017 VSS.n1246 0.00101605
R13678 VSS.n3368 VSS.n768 0.00101605
R13679 VSS.n3368 VSS.n773 0.00101605
R13680 VSS.n3368 VSS.n778 0.00101605
R13681 VSS.n3368 VSS.n788 0.00101605
R13682 VSS.n3368 VSS.n793 0.00101605
R13683 VSS.n2862 VSS.n1202 0.00101563
R13684 VSS.n2843 VSS.n2329 0.00101563
R13685 VSS.n3322 VSS.n1118 0.00101563
R13686 VSS.n3322 VSS.n1114 0.00101563
R13687 VSS.n3322 VSS.n1110 0.00101563
R13688 VSS.n3322 VSS.n1102 0.00101563
R13689 VSS.n3017 VSS.n1271 0.00101563
R13690 VSS.n3017 VSS.n1267 0.00101563
R13691 VSS.n3017 VSS.n1263 0.00101563
R13692 VSS.n3017 VSS.n1255 0.00101563
R13693 VSS.n3368 VSS.n3354 0.00101563
R13694 VSS.n3368 VSS.n3350 0.00101563
R13695 VSS.n3368 VSS.n3346 0.00101563
R13696 VSS.n3368 VSS.n3338 0.00101563
R13697 VSS.n3322 VSS.n1121 0.00101562
R13698 VSS.n3322 VSS.n1117 0.00101562
R13699 VSS.n3322 VSS.n1113 0.00101562
R13700 VSS.n3322 VSS.n1107 0.00101562
R13701 VSS.n3322 VSS.n1105 0.00101562
R13702 VSS.n3322 VSS.n1101 0.00101562
R13703 VSS.n3017 VSS.n1274 0.00101562
R13704 VSS.n3017 VSS.n1270 0.00101562
R13705 VSS.n3017 VSS.n1266 0.00101562
R13706 VSS.n3017 VSS.n1260 0.00101562
R13707 VSS.n3017 VSS.n1258 0.00101562
R13708 VSS.n3017 VSS.n1254 0.00101562
R13709 VSS.n3368 VSS.n3357 0.00101562
R13710 VSS.n3368 VSS.n3353 0.00101562
R13711 VSS.n3368 VSS.n3349 0.00101562
R13712 VSS.n3368 VSS.n3343 0.00101562
R13713 VSS.n3368 VSS.n3341 0.00101562
R13714 VSS.n3368 VSS.n3337 0.00101562
R13715 VSS.n3322 VSS.n1065 0.00101562
R13716 VSS.n3322 VSS.n1109 0.00101562
R13717 VSS.n3322 VSS.n1085 0.00101562
R13718 VSS.n3017 VSS.n1217 0.00101562
R13719 VSS.n3017 VSS.n1262 0.00101562
R13720 VSS.n3017 VSS.n1237 0.00101562
R13721 VSS.n3368 VSS.n764 0.00101562
R13722 VSS.n3368 VSS.n3345 0.00101562
R13723 VSS.n3368 VSS.n784 0.00101562
R13724 VSS.n3179 VSS.n136 0.00101517
R13725 VSS.n1557 VSS.n1559 0.00101517
R13726 VSS.n148 VSS.n146 0.00101517
R13727 VSS.n634 VSS.n629 0.00100069
R13728 VSS.n650 VSS.n643 0.00100065
R13729 VSS.n3322 VSS.n1097 0.00100047
R13730 VSS.n3017 VSS.n1250 0.00100047
R13731 VSS.n3368 VSS.n3333 0.00100047
R13732 VSS.n3181 VSS.n136 0.00100046
R13733 VSS.n1557 VSS.n1558 0.00100046
R13734 VSS.n148 VSS.n147 0.00100046
R13735 VSS.n632 VSS.n629 0.00100006
R13736 VSS.n3322 VSS.n1098 0.00100003
R13737 VSS.n3017 VSS.n1251 0.00100003
R13738 VSS.n3368 VSS.n3334 0.00100003
R13739 VSS.n3009 VSS.n115 0.001125
R13740 VSS.n115 VSS.n114 8.50175
R13741 VSS.n83 VSS.n82 0.00499569
R13742 VSS.n46 VSS.n45 0.00516376
R13743 VSS.n91 VSS.n90 0.00424743
R13744 VSS.n68 VSS.n69 0.00399966
R13745 VSS.n60 VSS.n61 0.00399966
R13746 VSS.n55 VSS.n54 0.0042985
R13747 VSS.n106 VSS.n2146 0.00362425
R13748 VSS.n22 VSS.n21 0.00349994
R13749 VSS.n65 VSS.n7 0.00299994
R13750 VSS.n41 VSS.n19 0.00199975
R13751 VSS.n102 VSS.n101 0.00274942
R13752 VSS.n2984 VSS.n98 0.00249997
R13753 VSS.n43 VSS.n19 0.00283308
R13754 VSS.n34 VSS.n33 0.00249995
R13755 VSS.n2922 VSS.n52 0.00224999
R13756 VSS.n36 VSS.n35 0.00224999
R13757 VSS.n112 VSS.n111 0.00149997
R13758 VSS.n2141 VSS.n111 0.0015
R13759 VSS.n2141 VSS.n110 0.0015
R13760 VSS.n2147 VSS.n101 0.0015
R13761 VSS.n97 VSS.n2155 0.00199997
R13762 VSS.n2985 VSS.n90 0.0015
R13763 VSS.n29 VSS.n2901 0.00349972
R13764 VSS.n23 VSS.n22 0.00290808
R13765 VSS.n86 VSS.n24 0.00316655
R13766 VSS.n2208 VSS.n19 0.00312498
R13767 VSS.n42 VSS.n26 0.00283329
R13768 VSS.n52 VSS.n13 0.00274987
R13769 VSS.n14 VSS.n13 0.00172208
R13770 VSS.n51 VSS.n15 0.00249997
R13771 VSS.n77 VSS.n76 0.00174999
R13772 VSS.n21 VSS.n88 0.0015
R13773 VSS.n82 VSS.n81 0.0015
R13774 VSS.n81 VSS.n80 0.0015
R13775 VSS.n66 VSS.n2319 0.00199997
R13776 VSS.n16 VSS.n15 0.00199997
R13777 VSS.n66 VSS.n9 0.00199997
R13778 VSS.n61 VSS.n4 0.00199997
R13779 VSS.n2896 VSS.n11 0.00183332
R13780 VSS.n7 VSS.n6 0.00183332
R13781 VSS.n2321 VSS.n63 0.0015
R13782 VSS.n56 VSS.n55 0.0015
R13783 VSS.n2953 VSS.n2 8.47807
R13784 VSS.n2860 VSS.n2859 0.001
R13785 VSS.n2855 VSS.n2324 0.001
R13786 VSS.n2853 VSS.n2325 0.001
R13787 VSS.n2850 VSS.n2329 0.001
R13788 VSS.n2849 VSS.n2330 0.001
R13789 VSS.n2813 VSS.n2334 0.001
R13790 VSS.n2816 VSS.n2814 0.001
R13791 VSS.n2817 VSS.n2800 0.001
R13792 VSS.n2820 VSS.n2818 0.001
R13793 VSS.n2821 VSS.n2776 0.001
R13794 VSS.n2825 VSS.n2823 0.001
R13795 VSS.n2826 VSS.n2761 0.001
R13796 VSS.n2761 VSS.n2394 0.001
R13797 VSS.n2750 VSS.n2393 0.001
R13798 VSS.n2748 VSS.n2392 0.001
R13799 VSS.n2829 VSS.n2828 0.001
R13800 VSS.n2704 VSS.n2406 0.001
R13801 VSS.n2694 VSS.n2426 0.001
R13802 VSS.n2692 VSS.n2427 0.001
R13803 VSS.n2669 VSS.n2432 0.001
R13804 VSS.n2645 VSS.n2446 0.001
R13805 VSS.n2635 VSS.n2456 0.001
R13806 VSS.n2633 VSS.n2457 0.001
R13807 VSS.n2610 VSS.n2462 0.001
R13808 VSS.n2573 VSS.n2512 0.001
R13809 VSS.n2578 VSS.n2495 0.001
R13810 VSS.n2579 VSS.n2477 0.001
R13811 VSS.n2610 VSS.n2469 0.001
R13812 VSS.n2859 VSS.n1202 0.001
R13813 VSS.n2860 VSS.n2855 0.001
R13814 VSS.n2325 VSS.n2324 0.001
R13815 VSS.n2853 VSS.n2850 0.001
R13816 VSS.n2330 VSS.n2329 0.001
R13817 VSS.n2849 VSS.n2334 0.001
R13818 VSS.n2814 VSS.n2813 0.001
R13819 VSS.n2817 VSS.n2816 0.001
R13820 VSS.n2818 VSS.n2800 0.001
R13821 VSS.n2821 VSS.n2820 0.001
R13822 VSS.n2823 VSS.n2776 0.001
R13823 VSS.n2826 VSS.n2825 0.001
R13824 VSS.n2751 VSS.n2394 0.001
R13825 VSS.n2751 VSS.n2393 0.001
R13826 VSS.n2750 VSS.n2392 0.001
R13827 VSS.n2829 VSS.n2397 0.001
R13828 VSS.n2828 VSS.n2406 0.001
R13829 VSS.n2704 VSS.n2694 0.001
R13830 VSS.n2427 VSS.n2426 0.001
R13831 VSS.n2692 VSS.n2432 0.001
R13832 VSS.n2669 VSS.n2446 0.001
R13833 VSS.n2645 VSS.n2635 0.001
R13834 VSS.n2457 VSS.n2456 0.001
R13835 VSS.n2633 VSS.n2462 0.001
R13836 VSS.n2477 VSS.n2469 0.001
R13837 VSS.n2579 VSS.n2578 0.001
R13838 VSS.n2573 VSS.n2495 0.001
R13839 VSS.n2512 VSS.n2134 0.001
R13840 VSS.n729 VSS.n728 0.001
R13841 VSS.n725 VSS.n588 0.001
R13842 VSS.n723 VSS.n589 0.001
R13843 VSS.n720 VSS.n593 0.001
R13844 VSS.n719 VSS.n594 0.001
R13845 VSS.n712 VSS.n597 0.001
R13846 VSS.n710 VSS.n598 0.001
R13847 VSS.n707 VSS.n602 0.001
R13848 VSS.n706 VSS.n603 0.001
R13849 VSS.n699 VSS.n606 0.001
R13850 VSS.n696 VSS.n607 0.001
R13851 VSS.n693 VSS.n611 0.001
R13852 VSS.n692 VSS.n612 0.001
R13853 VSS.n677 VSS.n615 0.001
R13854 VSS.n675 VSS.n616 0.001
R13855 VSS.n672 VSS.n620 0.001
R13856 VSS.n671 VSS.n621 0.001
R13857 VSS.n664 VSS.n624 0.001
R13858 VSS.n662 VSS.n625 0.001
R13859 VSS.n659 VSS.n629 0.001
R13860 VSS.n651 VSS.n640 0.001
R13861 VSS.n653 VSS.n652 0.001
R13862 VSS.n656 VSS.n637 0.001
R13863 VSS.n657 VSS.n629 0.001
R13864 VSS.n728 VSS.n239 0.001
R13865 VSS.n729 VSS.n725 0.001
R13866 VSS.n589 VSS.n588 0.001
R13867 VSS.n723 VSS.n720 0.001
R13868 VSS.n594 VSS.n593 0.001
R13869 VSS.n719 VSS.n712 0.001
R13870 VSS.n598 VSS.n597 0.001
R13871 VSS.n710 VSS.n707 0.001
R13872 VSS.n603 VSS.n602 0.001
R13873 VSS.n706 VSS.n699 0.001
R13874 VSS.n607 VSS.n606 0.001
R13875 VSS.n696 VSS.n693 0.001
R13876 VSS.n612 VSS.n611 0.001
R13877 VSS.n692 VSS.n677 0.001
R13878 VSS.n616 VSS.n615 0.001
R13879 VSS.n675 VSS.n672 0.001
R13880 VSS.n621 VSS.n620 0.001
R13881 VSS.n671 VSS.n664 0.001
R13882 VSS.n625 VSS.n624 0.001
R13883 VSS.n662 VSS.n659 0.001
R13884 VSS.n657 VSS.n656 0.001
R13885 VSS.n653 VSS.n637 0.001
R13886 VSS.n652 VSS.n640 0.001
R13887 VSS.n651 VSS.n650 0.001
R13888 VSS.n3315 VSS.n130 0.001
R13889 VSS.n1570 VSS.n1560 0.001
R13890 VSS.n1569 VSS.n1568 0.001
R13891 VSS.n3017 VSS.n1249 0.001
R13892 VSS.n1568 VSS.n1249 0.001
R13893 VSS.n1570 VSS.n1569 0.001
R13894 VSS.n1557 VSS.n1560 0.001
R13895 VSS.n2985 VSS.n2984 0.001
R13896 VSS.n2155 VSS.n95 0.001
R13897 VSS.n2154 VSS.n96 0.001
R13898 VSS.n2148 VSS.n100 0.001
R13899 VSS.n2146 VSS.n104 0.001
R13900 VSS.n2145 VSS.n108 0.001
R13901 VSS.n2831 VSS.n2185 0.001
R13902 VSS.t473 VSS.n2185 0.001
R13903 VSS.n2 VSS.n1 0.00125
R13904 VSS.n2 VSS.n2952 8.50163
R13905 a_3747_311.n0 a_3747_311.t2 52.0388
R13906 a_3747_311.t1 a_3747_311.n0 35.4491
R13907 a_3747_311.n0 a_3747_311.t3 33.5891
R13908 a_3747_311.t0 a_3747_311.t1 5.61942
R13909 a_3171_311.n0 a_3171_311.t2 51.8377
R13910 a_3171_311.n0 a_3171_311.t3 33.3881
R13911 a_3171_311.t1 a_3171_311.n0 31.8923
R13912 a_3171_311.t0 a_3171_311.t1 5.61777
R13913 a_2595_311.n0 a_2595_311.t2 51.6367
R13914 a_2595_311.n0 a_2595_311.t3 33.187
R13915 a_2595_311.t1 a_2595_311.n0 27.993
R13916 a_2595_311.t0 a_2595_311.t1 5.73018
R13917 a_2019_311.t3 a_2019_311.t2 51.6139
R13918 a_2019_311.t1 a_2019_311.t3 24.5351
R13919 a_2019_311.t0 a_2019_311.t1 5.62052
R13920 a_3747_1047.n0 a_3747_1047.t2 38.0081
R13921 a_3747_1047.n0 a_3747_1047.t3 33.3957
R13922 a_3747_1047.n1 a_3747_1047.t4 33.3957
R13923 a_3747_1047.n2 a_3747_1047.t5 33.3957
R13924 a_3747_1047.n3 a_3747_1047.t6 33.3957
R13925 a_3747_1047.n4 a_3747_1047.t7 33.3957
R13926 a_3747_1047.n5 a_3747_1047.t8 33.3957
R13927 a_3747_1047.n6 a_3747_1047.t9 33.3957
R13928 a_3747_1047.t1 a_3747_1047.n6 23.2419
R13929 a_3747_1047.t0 a_3747_1047.t1 5.61942
R13930 a_3747_1047.n6 a_3747_1047.n5 4.61291
R13931 a_3747_1047.n5 a_3747_1047.n4 4.61291
R13932 a_3747_1047.n4 a_3747_1047.n3 4.61291
R13933 a_3747_1047.n3 a_3747_1047.n2 4.61291
R13934 a_3747_1047.n2 a_3747_1047.n1 4.61291
R13935 a_3747_1047.n1 a_3747_1047.n0 4.61291
R13936 a_3171_1047.n0 a_3171_1047.t2 37.8054
R13937 a_3171_1047.n0 a_3171_1047.t3 33.193
R13938 a_3171_1047.n1 a_3171_1047.t4 33.193
R13939 a_3171_1047.n2 a_3171_1047.t5 33.193
R13940 a_3171_1047.n3 a_3171_1047.t6 33.193
R13941 a_3171_1047.n4 a_3171_1047.t7 33.193
R13942 a_3171_1047.n5 a_3171_1047.t8 33.193
R13943 a_3171_1047.n6 a_3171_1047.t9 33.193
R13944 a_3171_1047.t1 a_3171_1047.n6 23.0313
R13945 a_3171_1047.t0 a_3171_1047.t1 5.61777
R13946 a_3171_1047.n6 a_3171_1047.n5 4.61291
R13947 a_3171_1047.n5 a_3171_1047.n4 4.61291
R13948 a_3171_1047.n4 a_3171_1047.n3 4.61291
R13949 a_3171_1047.n3 a_3171_1047.n2 4.61291
R13950 a_3171_1047.n2 a_3171_1047.n1 4.61291
R13951 a_3171_1047.n1 a_3171_1047.n0 4.61291
R13952 a_2595_1047.n0 a_2595_1047.t2 37.7691
R13953 a_2595_1047.n0 a_2595_1047.t3 33.1567
R13954 a_2595_1047.n1 a_2595_1047.t4 33.1567
R13955 a_2595_1047.n2 a_2595_1047.t5 33.1567
R13956 a_2595_1047.n3 a_2595_1047.t6 33.1567
R13957 a_2595_1047.n4 a_2595_1047.t7 33.1567
R13958 a_2595_1047.n5 a_2595_1047.t8 33.1567
R13959 a_2595_1047.n6 a_2595_1047.t9 33.1567
R13960 a_2595_1047.t1 a_2595_1047.n6 22.7941
R13961 a_2595_1047.t0 a_2595_1047.t1 5.65522
R13962 a_2595_1047.n6 a_2595_1047.n5 4.61291
R13963 a_2595_1047.n5 a_2595_1047.n4 4.61291
R13964 a_2595_1047.n4 a_2595_1047.n3 4.61291
R13965 a_2595_1047.n3 a_2595_1047.n2 4.61291
R13966 a_2595_1047.n2 a_2595_1047.n1 4.61291
R13967 a_2595_1047.n1 a_2595_1047.n0 4.61291
R13968 a_2019_1047.n0 a_2019_1047.t2 37.9701
R13969 a_2019_1047.n0 a_2019_1047.t3 33.3577
R13970 a_2019_1047.n1 a_2019_1047.t4 33.3577
R13971 a_2019_1047.n2 a_2019_1047.t5 33.3577
R13972 a_2019_1047.n3 a_2019_1047.t6 33.3577
R13973 a_2019_1047.n4 a_2019_1047.t7 33.3577
R13974 a_2019_1047.n5 a_2019_1047.t8 33.3577
R13975 a_2019_1047.t1 a_2019_1047.t9 22.5945
R13976 a_2019_1047.t0 a_2019_1047.t1 5.62052
R13977 a_2019_1047.t9 a_2019_1047.n5 4.61291
R13978 a_2019_1047.n5 a_2019_1047.n4 4.61291
R13979 a_2019_1047.n4 a_2019_1047.n3 4.61291
R13980 a_2019_1047.n3 a_2019_1047.n2 4.61291
R13981 a_2019_1047.n2 a_2019_1047.n1 4.61291
R13982 a_2019_1047.n1 a_2019_1047.n0 4.61291
R13983 a_3747_3156.n0 a_3747_3156.t2 52.0388
R13984 a_3747_3156.t1 a_3747_3156.n0 35.4491
R13985 a_3747_3156.n0 a_3747_3156.t3 33.5891
R13986 a_3747_3156.t0 a_3747_3156.t1 5.61942
R13987 a_3171_3156.n0 a_3171_3156.t2 51.8377
R13988 a_3171_3156.n0 a_3171_3156.t3 33.3881
R13989 a_3171_3156.t1 a_3171_3156.n0 31.8923
R13990 a_3171_3156.t0 a_3171_3156.t1 5.61777
R13991 a_2595_3156.n0 a_2595_3156.t2 51.6367
R13992 a_2595_3156.n0 a_2595_3156.t3 33.187
R13993 a_2595_3156.t1 a_2595_3156.n0 27.993
R13994 a_2595_3156.t0 a_2595_3156.t1 5.73018
R13995 a_2019_3156.t3 a_2019_3156.t2 51.6139
R13996 a_2019_3156.t1 a_2019_3156.t3 24.5351
R13997 a_2019_3156.t0 a_2019_3156.t1 5.62052
R13998 a_3747_3892.n0 a_3747_3892.t2 38.0081
R13999 a_3747_3892.n0 a_3747_3892.t3 33.3957
R14000 a_3747_3892.n1 a_3747_3892.t4 33.3957
R14001 a_3747_3892.n2 a_3747_3892.t5 33.3957
R14002 a_3747_3892.n3 a_3747_3892.t6 33.3957
R14003 a_3747_3892.n4 a_3747_3892.t7 33.3957
R14004 a_3747_3892.n5 a_3747_3892.t8 33.3957
R14005 a_3747_3892.n6 a_3747_3892.t9 33.3957
R14006 a_3747_3892.t1 a_3747_3892.n6 23.2419
R14007 a_3747_3892.t0 a_3747_3892.t1 5.61942
R14008 a_3747_3892.n6 a_3747_3892.n5 4.61291
R14009 a_3747_3892.n5 a_3747_3892.n4 4.61291
R14010 a_3747_3892.n4 a_3747_3892.n3 4.61291
R14011 a_3747_3892.n3 a_3747_3892.n2 4.61291
R14012 a_3747_3892.n2 a_3747_3892.n1 4.61291
R14013 a_3747_3892.n1 a_3747_3892.n0 4.61291
R14014 a_3171_3892.n0 a_3171_3892.t2 37.8054
R14015 a_3171_3892.n0 a_3171_3892.t3 33.193
R14016 a_3171_3892.n1 a_3171_3892.t4 33.193
R14017 a_3171_3892.n2 a_3171_3892.t5 33.193
R14018 a_3171_3892.n3 a_3171_3892.t6 33.193
R14019 a_3171_3892.n4 a_3171_3892.t7 33.193
R14020 a_3171_3892.n5 a_3171_3892.t8 33.193
R14021 a_3171_3892.n6 a_3171_3892.t9 33.193
R14022 a_3171_3892.t1 a_3171_3892.n6 23.0313
R14023 a_3171_3892.t0 a_3171_3892.t1 5.61777
R14024 a_3171_3892.n6 a_3171_3892.n5 4.61291
R14025 a_3171_3892.n5 a_3171_3892.n4 4.61291
R14026 a_3171_3892.n4 a_3171_3892.n3 4.61291
R14027 a_3171_3892.n3 a_3171_3892.n2 4.61291
R14028 a_3171_3892.n2 a_3171_3892.n1 4.61291
R14029 a_3171_3892.n1 a_3171_3892.n0 4.61291
R14030 a_2595_3892.n0 a_2595_3892.t2 37.7691
R14031 a_2595_3892.n0 a_2595_3892.t3 33.1567
R14032 a_2595_3892.n1 a_2595_3892.t4 33.1567
R14033 a_2595_3892.n2 a_2595_3892.t5 33.1567
R14034 a_2595_3892.n3 a_2595_3892.t6 33.1567
R14035 a_2595_3892.n4 a_2595_3892.t7 33.1567
R14036 a_2595_3892.n5 a_2595_3892.t8 33.1567
R14037 a_2595_3892.n6 a_2595_3892.t9 33.1567
R14038 a_2595_3892.t1 a_2595_3892.n6 22.7941
R14039 a_2595_3892.t0 a_2595_3892.t1 5.65522
R14040 a_2595_3892.n6 a_2595_3892.n5 4.61291
R14041 a_2595_3892.n5 a_2595_3892.n4 4.61291
R14042 a_2595_3892.n4 a_2595_3892.n3 4.61291
R14043 a_2595_3892.n3 a_2595_3892.n2 4.61291
R14044 a_2595_3892.n2 a_2595_3892.n1 4.61291
R14045 a_2595_3892.n1 a_2595_3892.n0 4.61291
R14046 a_2019_3892.n0 a_2019_3892.t2 37.9701
R14047 a_2019_3892.n0 a_2019_3892.t3 33.3577
R14048 a_2019_3892.n1 a_2019_3892.t4 33.3577
R14049 a_2019_3892.n2 a_2019_3892.t5 33.3577
R14050 a_2019_3892.n3 a_2019_3892.t6 33.3577
R14051 a_2019_3892.n4 a_2019_3892.t7 33.3577
R14052 a_2019_3892.n5 a_2019_3892.t8 33.3577
R14053 a_2019_3892.t1 a_2019_3892.t9 22.5945
R14054 a_2019_3892.t0 a_2019_3892.t1 5.62052
R14055 a_2019_3892.t9 a_2019_3892.n5 4.61291
R14056 a_2019_3892.n5 a_2019_3892.n4 4.61291
R14057 a_2019_3892.n4 a_2019_3892.n3 4.61291
R14058 a_2019_3892.n3 a_2019_3892.n2 4.61291
R14059 a_2019_3892.n2 a_2019_3892.n1 4.61291
R14060 a_2019_3892.n1 a_2019_3892.n0 4.61291
R14061 a_3747_6001.n0 a_3747_6001.t2 52.0388
R14062 a_3747_6001.t1 a_3747_6001.n0 35.4491
R14063 a_3747_6001.n0 a_3747_6001.t3 33.5891
R14064 a_3747_6001.t0 a_3747_6001.t1 5.61942
R14065 a_3171_6001.n0 a_3171_6001.t2 51.8377
R14066 a_3171_6001.n0 a_3171_6001.t3 33.3881
R14067 a_3171_6001.t1 a_3171_6001.n0 31.8923
R14068 a_3171_6001.t0 a_3171_6001.t1 5.61777
R14069 a_2595_6001.n0 a_2595_6001.t2 51.6367
R14070 a_2595_6001.n0 a_2595_6001.t3 33.187
R14071 a_2595_6001.t1 a_2595_6001.n0 27.993
R14072 a_2595_6001.t0 a_2595_6001.t1 5.73018
R14073 a_2019_6001.t3 a_2019_6001.t2 51.6139
R14074 a_2019_6001.t1 a_2019_6001.t3 24.5351
R14075 a_2019_6001.t0 a_2019_6001.t1 5.62052
R14076 a_3747_6737.n0 a_3747_6737.t2 38.0081
R14077 a_3747_6737.n0 a_3747_6737.t3 33.3957
R14078 a_3747_6737.n1 a_3747_6737.t4 33.3957
R14079 a_3747_6737.n2 a_3747_6737.t5 33.3957
R14080 a_3747_6737.n3 a_3747_6737.t6 33.3957
R14081 a_3747_6737.n4 a_3747_6737.t7 33.3957
R14082 a_3747_6737.n5 a_3747_6737.t8 33.3957
R14083 a_3747_6737.n6 a_3747_6737.t9 33.3957
R14084 a_3747_6737.t1 a_3747_6737.n6 23.2419
R14085 a_3747_6737.t0 a_3747_6737.t1 5.61942
R14086 a_3747_6737.n6 a_3747_6737.n5 4.61291
R14087 a_3747_6737.n5 a_3747_6737.n4 4.61291
R14088 a_3747_6737.n4 a_3747_6737.n3 4.61291
R14089 a_3747_6737.n3 a_3747_6737.n2 4.61291
R14090 a_3747_6737.n2 a_3747_6737.n1 4.61291
R14091 a_3747_6737.n1 a_3747_6737.n0 4.61291
R14092 a_3171_6737.n0 a_3171_6737.t2 37.8054
R14093 a_3171_6737.n0 a_3171_6737.t3 33.193
R14094 a_3171_6737.n1 a_3171_6737.t4 33.193
R14095 a_3171_6737.n2 a_3171_6737.t5 33.193
R14096 a_3171_6737.n3 a_3171_6737.t6 33.193
R14097 a_3171_6737.n4 a_3171_6737.t7 33.193
R14098 a_3171_6737.n5 a_3171_6737.t8 33.193
R14099 a_3171_6737.n6 a_3171_6737.t9 33.193
R14100 a_3171_6737.t1 a_3171_6737.n6 23.0313
R14101 a_3171_6737.t0 a_3171_6737.t1 5.61777
R14102 a_3171_6737.n6 a_3171_6737.n5 4.61291
R14103 a_3171_6737.n5 a_3171_6737.n4 4.61291
R14104 a_3171_6737.n4 a_3171_6737.n3 4.61291
R14105 a_3171_6737.n3 a_3171_6737.n2 4.61291
R14106 a_3171_6737.n2 a_3171_6737.n1 4.61291
R14107 a_3171_6737.n1 a_3171_6737.n0 4.61291
R14108 a_2595_6737.n0 a_2595_6737.t2 37.7691
R14109 a_2595_6737.n0 a_2595_6737.t3 33.1567
R14110 a_2595_6737.n1 a_2595_6737.t4 33.1567
R14111 a_2595_6737.n2 a_2595_6737.t5 33.1567
R14112 a_2595_6737.n3 a_2595_6737.t6 33.1567
R14113 a_2595_6737.n4 a_2595_6737.t7 33.1567
R14114 a_2595_6737.n5 a_2595_6737.t8 33.1567
R14115 a_2595_6737.n6 a_2595_6737.t9 33.1567
R14116 a_2595_6737.t1 a_2595_6737.n6 22.7941
R14117 a_2595_6737.t0 a_2595_6737.t1 5.65522
R14118 a_2595_6737.n6 a_2595_6737.n5 4.61291
R14119 a_2595_6737.n5 a_2595_6737.n4 4.61291
R14120 a_2595_6737.n4 a_2595_6737.n3 4.61291
R14121 a_2595_6737.n3 a_2595_6737.n2 4.61291
R14122 a_2595_6737.n2 a_2595_6737.n1 4.61291
R14123 a_2595_6737.n1 a_2595_6737.n0 4.61291
R14124 a_2019_6737.n0 a_2019_6737.t2 37.9701
R14125 a_2019_6737.n0 a_2019_6737.t3 33.3577
R14126 a_2019_6737.n1 a_2019_6737.t4 33.3577
R14127 a_2019_6737.n2 a_2019_6737.t5 33.3577
R14128 a_2019_6737.n3 a_2019_6737.t6 33.3577
R14129 a_2019_6737.n4 a_2019_6737.t7 33.3577
R14130 a_2019_6737.n5 a_2019_6737.t8 33.3577
R14131 a_2019_6737.t1 a_2019_6737.t9 22.5945
R14132 a_2019_6737.t0 a_2019_6737.t1 5.62052
R14133 a_2019_6737.t9 a_2019_6737.n5 4.61291
R14134 a_2019_6737.n5 a_2019_6737.n4 4.61291
R14135 a_2019_6737.n4 a_2019_6737.n3 4.61291
R14136 a_2019_6737.n3 a_2019_6737.n2 4.61291
R14137 a_2019_6737.n2 a_2019_6737.n1 4.61291
R14138 a_2019_6737.n1 a_2019_6737.n0 4.61291
R14139 a_3747_12493.n0 a_3747_12493.t2 52.0388
R14140 a_3747_12493.t1 a_3747_12493.n0 35.4491
R14141 a_3747_12493.n0 a_3747_12493.t3 33.5891
R14142 a_3747_12493.t0 a_3747_12493.t1 5.61942
R14143 a_3171_12493.n0 a_3171_12493.t2 51.8377
R14144 a_3171_12493.n0 a_3171_12493.t3 33.3881
R14145 a_3171_12493.t1 a_3171_12493.n0 31.8923
R14146 a_3171_12493.t0 a_3171_12493.t1 5.61777
R14147 a_2595_12493.n0 a_2595_12493.t2 51.6367
R14148 a_2595_12493.n0 a_2595_12493.t3 33.187
R14149 a_2595_12493.t1 a_2595_12493.n0 27.993
R14150 a_2595_12493.t0 a_2595_12493.t1 5.73018
R14151 a_2019_12493.t3 a_2019_12493.t2 51.6139
R14152 a_2019_12493.t1 a_2019_12493.t3 24.5351
R14153 a_2019_12493.t0 a_2019_12493.t1 5.62052
R14154 a_3747_13229.n0 a_3747_13229.t2 38.0081
R14155 a_3747_13229.n0 a_3747_13229.t3 33.3957
R14156 a_3747_13229.n1 a_3747_13229.t4 33.3957
R14157 a_3747_13229.n2 a_3747_13229.t5 33.3957
R14158 a_3747_13229.n3 a_3747_13229.t6 33.3957
R14159 a_3747_13229.n4 a_3747_13229.t7 33.3957
R14160 a_3747_13229.n5 a_3747_13229.t8 33.3957
R14161 a_3747_13229.n6 a_3747_13229.t9 33.3957
R14162 a_3747_13229.t1 a_3747_13229.n6 23.2419
R14163 a_3747_13229.t0 a_3747_13229.t1 5.61942
R14164 a_3747_13229.n6 a_3747_13229.n5 4.61291
R14165 a_3747_13229.n5 a_3747_13229.n4 4.61291
R14166 a_3747_13229.n4 a_3747_13229.n3 4.61291
R14167 a_3747_13229.n3 a_3747_13229.n2 4.61291
R14168 a_3747_13229.n2 a_3747_13229.n1 4.61291
R14169 a_3747_13229.n1 a_3747_13229.n0 4.61291
R14170 a_3171_13229.n0 a_3171_13229.t2 37.8054
R14171 a_3171_13229.n0 a_3171_13229.t3 33.193
R14172 a_3171_13229.n1 a_3171_13229.t4 33.193
R14173 a_3171_13229.n2 a_3171_13229.t5 33.193
R14174 a_3171_13229.n3 a_3171_13229.t6 33.193
R14175 a_3171_13229.n4 a_3171_13229.t7 33.193
R14176 a_3171_13229.n5 a_3171_13229.t8 33.193
R14177 a_3171_13229.n6 a_3171_13229.t9 33.193
R14178 a_3171_13229.t1 a_3171_13229.n6 23.0313
R14179 a_3171_13229.t0 a_3171_13229.t1 5.61777
R14180 a_3171_13229.n6 a_3171_13229.n5 4.61291
R14181 a_3171_13229.n5 a_3171_13229.n4 4.61291
R14182 a_3171_13229.n4 a_3171_13229.n3 4.61291
R14183 a_3171_13229.n3 a_3171_13229.n2 4.61291
R14184 a_3171_13229.n2 a_3171_13229.n1 4.61291
R14185 a_3171_13229.n1 a_3171_13229.n0 4.61291
R14186 a_2595_13229.n0 a_2595_13229.t2 37.7691
R14187 a_2595_13229.n0 a_2595_13229.t3 33.1567
R14188 a_2595_13229.n1 a_2595_13229.t4 33.1567
R14189 a_2595_13229.n2 a_2595_13229.t5 33.1567
R14190 a_2595_13229.n3 a_2595_13229.t6 33.1567
R14191 a_2595_13229.n4 a_2595_13229.t7 33.1567
R14192 a_2595_13229.n5 a_2595_13229.t8 33.1567
R14193 a_2595_13229.n6 a_2595_13229.t9 33.1567
R14194 a_2595_13229.t1 a_2595_13229.n6 22.7941
R14195 a_2595_13229.t0 a_2595_13229.t1 5.65522
R14196 a_2595_13229.n6 a_2595_13229.n5 4.61291
R14197 a_2595_13229.n5 a_2595_13229.n4 4.61291
R14198 a_2595_13229.n4 a_2595_13229.n3 4.61291
R14199 a_2595_13229.n3 a_2595_13229.n2 4.61291
R14200 a_2595_13229.n2 a_2595_13229.n1 4.61291
R14201 a_2595_13229.n1 a_2595_13229.n0 4.61291
R14202 a_2019_13229.n0 a_2019_13229.t2 37.9701
R14203 a_2019_13229.n0 a_2019_13229.t3 33.3577
R14204 a_2019_13229.n1 a_2019_13229.t4 33.3577
R14205 a_2019_13229.n2 a_2019_13229.t5 33.3577
R14206 a_2019_13229.n3 a_2019_13229.t6 33.3577
R14207 a_2019_13229.n4 a_2019_13229.t7 33.3577
R14208 a_2019_13229.n5 a_2019_13229.t8 33.3577
R14209 a_2019_13229.t1 a_2019_13229.t9 22.5945
R14210 a_2019_13229.t0 a_2019_13229.t1 5.62052
R14211 a_2019_13229.t9 a_2019_13229.n5 4.61291
R14212 a_2019_13229.n5 a_2019_13229.n4 4.61291
R14213 a_2019_13229.n4 a_2019_13229.n3 4.61291
R14214 a_2019_13229.n3 a_2019_13229.n2 4.61291
R14215 a_2019_13229.n2 a_2019_13229.n1 4.61291
R14216 a_2019_13229.n1 a_2019_13229.n0 4.61291
R14217 a_3747_15338.n0 a_3747_15338.t2 52.0388
R14218 a_3747_15338.t1 a_3747_15338.n0 35.4491
R14219 a_3747_15338.n0 a_3747_15338.t3 33.5891
R14220 a_3747_15338.t0 a_3747_15338.t1 5.61942
R14221 a_3171_15338.n0 a_3171_15338.t2 51.8377
R14222 a_3171_15338.n0 a_3171_15338.t3 33.3881
R14223 a_3171_15338.t1 a_3171_15338.n0 31.8923
R14224 a_3171_15338.t0 a_3171_15338.t1 5.61777
R14225 a_2595_15338.n0 a_2595_15338.t2 51.6367
R14226 a_2595_15338.n0 a_2595_15338.t3 33.187
R14227 a_2595_15338.t1 a_2595_15338.n0 27.993
R14228 a_2595_15338.t0 a_2595_15338.t1 5.73018
R14229 a_2019_15338.t3 a_2019_15338.t2 51.6139
R14230 a_2019_15338.t1 a_2019_15338.t3 24.5351
R14231 a_2019_15338.t0 a_2019_15338.t1 5.62052
R14232 a_3747_16074.n0 a_3747_16074.t2 38.0081
R14233 a_3747_16074.n0 a_3747_16074.t3 33.3957
R14234 a_3747_16074.n1 a_3747_16074.t4 33.3957
R14235 a_3747_16074.n2 a_3747_16074.t5 33.3957
R14236 a_3747_16074.n3 a_3747_16074.t6 33.3957
R14237 a_3747_16074.n4 a_3747_16074.t7 33.3957
R14238 a_3747_16074.n5 a_3747_16074.t8 33.3957
R14239 a_3747_16074.n6 a_3747_16074.t9 33.3957
R14240 a_3747_16074.t1 a_3747_16074.n6 23.2419
R14241 a_3747_16074.t0 a_3747_16074.t1 5.61942
R14242 a_3747_16074.n6 a_3747_16074.n5 4.61291
R14243 a_3747_16074.n5 a_3747_16074.n4 4.61291
R14244 a_3747_16074.n4 a_3747_16074.n3 4.61291
R14245 a_3747_16074.n3 a_3747_16074.n2 4.61291
R14246 a_3747_16074.n2 a_3747_16074.n1 4.61291
R14247 a_3747_16074.n1 a_3747_16074.n0 4.61291
R14248 a_3171_16074.n0 a_3171_16074.t2 37.8054
R14249 a_3171_16074.n0 a_3171_16074.t3 33.193
R14250 a_3171_16074.n1 a_3171_16074.t4 33.193
R14251 a_3171_16074.n2 a_3171_16074.t5 33.193
R14252 a_3171_16074.n3 a_3171_16074.t6 33.193
R14253 a_3171_16074.n4 a_3171_16074.t7 33.193
R14254 a_3171_16074.n5 a_3171_16074.t8 33.193
R14255 a_3171_16074.n6 a_3171_16074.t9 33.193
R14256 a_3171_16074.t1 a_3171_16074.n6 23.0313
R14257 a_3171_16074.t0 a_3171_16074.t1 5.61777
R14258 a_3171_16074.n6 a_3171_16074.n5 4.61291
R14259 a_3171_16074.n5 a_3171_16074.n4 4.61291
R14260 a_3171_16074.n4 a_3171_16074.n3 4.61291
R14261 a_3171_16074.n3 a_3171_16074.n2 4.61291
R14262 a_3171_16074.n2 a_3171_16074.n1 4.61291
R14263 a_3171_16074.n1 a_3171_16074.n0 4.61291
R14264 a_2595_16074.n0 a_2595_16074.t2 37.7691
R14265 a_2595_16074.n0 a_2595_16074.t3 33.1567
R14266 a_2595_16074.n1 a_2595_16074.t4 33.1567
R14267 a_2595_16074.n2 a_2595_16074.t5 33.1567
R14268 a_2595_16074.n3 a_2595_16074.t6 33.1567
R14269 a_2595_16074.n4 a_2595_16074.t7 33.1567
R14270 a_2595_16074.n5 a_2595_16074.t8 33.1567
R14271 a_2595_16074.n6 a_2595_16074.t9 33.1567
R14272 a_2595_16074.t1 a_2595_16074.n6 22.7941
R14273 a_2595_16074.t0 a_2595_16074.t1 5.65522
R14274 a_2595_16074.n6 a_2595_16074.n5 4.61291
R14275 a_2595_16074.n5 a_2595_16074.n4 4.61291
R14276 a_2595_16074.n4 a_2595_16074.n3 4.61291
R14277 a_2595_16074.n3 a_2595_16074.n2 4.61291
R14278 a_2595_16074.n2 a_2595_16074.n1 4.61291
R14279 a_2595_16074.n1 a_2595_16074.n0 4.61291
R14280 a_2019_16074.n0 a_2019_16074.t2 37.9701
R14281 a_2019_16074.n0 a_2019_16074.t3 33.3577
R14282 a_2019_16074.n1 a_2019_16074.t4 33.3577
R14283 a_2019_16074.n2 a_2019_16074.t5 33.3577
R14284 a_2019_16074.n3 a_2019_16074.t6 33.3577
R14285 a_2019_16074.n4 a_2019_16074.t7 33.3577
R14286 a_2019_16074.n5 a_2019_16074.t8 33.3577
R14287 a_2019_16074.t1 a_2019_16074.t9 22.5945
R14288 a_2019_16074.t0 a_2019_16074.t1 5.62052
R14289 a_2019_16074.t9 a_2019_16074.n5 4.61291
R14290 a_2019_16074.n5 a_2019_16074.n4 4.61291
R14291 a_2019_16074.n4 a_2019_16074.n3 4.61291
R14292 a_2019_16074.n3 a_2019_16074.n2 4.61291
R14293 a_2019_16074.n2 a_2019_16074.n1 4.61291
R14294 a_2019_16074.n1 a_2019_16074.n0 4.61291
R14295 a_4187_1764.n0 a_4187_1764.t163 34.3755
R14296 a_4187_1764.n31 a_4187_1764.t131 34.3755
R14297 a_4187_1764.n126 a_4187_1764.t97 34.3755
R14298 a_4187_1764.n94 a_4187_1764.t65 34.3755
R14299 a_4187_1764.n63 a_4187_1764.t33 34.3755
R14300 a_4187_1764.n0 a_4187_1764.t162 33.0005
R14301 a_4187_1764.n1 a_4187_1764.t161 33.0005
R14302 a_4187_1764.n2 a_4187_1764.t160 33.0005
R14303 a_4187_1764.n3 a_4187_1764.t159 33.0005
R14304 a_4187_1764.n4 a_4187_1764.t158 33.0005
R14305 a_4187_1764.n5 a_4187_1764.t157 33.0005
R14306 a_4187_1764.n6 a_4187_1764.t156 33.0005
R14307 a_4187_1764.n7 a_4187_1764.t155 33.0005
R14308 a_4187_1764.n8 a_4187_1764.t154 33.0005
R14309 a_4187_1764.n9 a_4187_1764.t153 33.0005
R14310 a_4187_1764.n10 a_4187_1764.t152 33.0005
R14311 a_4187_1764.n11 a_4187_1764.t151 33.0005
R14312 a_4187_1764.n12 a_4187_1764.t150 33.0005
R14313 a_4187_1764.n13 a_4187_1764.t149 33.0005
R14314 a_4187_1764.n14 a_4187_1764.t148 33.0005
R14315 a_4187_1764.n15 a_4187_1764.t147 33.0005
R14316 a_4187_1764.n16 a_4187_1764.t146 33.0005
R14317 a_4187_1764.n17 a_4187_1764.t145 33.0005
R14318 a_4187_1764.n18 a_4187_1764.t144 33.0005
R14319 a_4187_1764.n19 a_4187_1764.t143 33.0005
R14320 a_4187_1764.n20 a_4187_1764.t142 33.0005
R14321 a_4187_1764.n21 a_4187_1764.t141 33.0005
R14322 a_4187_1764.n22 a_4187_1764.t140 33.0005
R14323 a_4187_1764.n23 a_4187_1764.t139 33.0005
R14324 a_4187_1764.n24 a_4187_1764.t138 33.0005
R14325 a_4187_1764.n25 a_4187_1764.t137 33.0005
R14326 a_4187_1764.n26 a_4187_1764.t136 33.0005
R14327 a_4187_1764.n27 a_4187_1764.t135 33.0005
R14328 a_4187_1764.n28 a_4187_1764.t134 33.0005
R14329 a_4187_1764.n29 a_4187_1764.t133 33.0005
R14330 a_4187_1764.n30 a_4187_1764.t132 33.0005
R14331 a_4187_1764.n31 a_4187_1764.t130 33.0005
R14332 a_4187_1764.n32 a_4187_1764.t129 33.0005
R14333 a_4187_1764.n33 a_4187_1764.t128 33.0005
R14334 a_4187_1764.n34 a_4187_1764.t127 33.0005
R14335 a_4187_1764.n35 a_4187_1764.t126 33.0005
R14336 a_4187_1764.n36 a_4187_1764.t125 33.0005
R14337 a_4187_1764.n37 a_4187_1764.t124 33.0005
R14338 a_4187_1764.n38 a_4187_1764.t123 33.0005
R14339 a_4187_1764.n39 a_4187_1764.t122 33.0005
R14340 a_4187_1764.n40 a_4187_1764.t121 33.0005
R14341 a_4187_1764.n41 a_4187_1764.t120 33.0005
R14342 a_4187_1764.n42 a_4187_1764.t119 33.0005
R14343 a_4187_1764.n43 a_4187_1764.t118 33.0005
R14344 a_4187_1764.n44 a_4187_1764.t117 33.0005
R14345 a_4187_1764.n45 a_4187_1764.t116 33.0005
R14346 a_4187_1764.n46 a_4187_1764.t115 33.0005
R14347 a_4187_1764.n47 a_4187_1764.t114 33.0005
R14348 a_4187_1764.n48 a_4187_1764.t113 33.0005
R14349 a_4187_1764.n49 a_4187_1764.t112 33.0005
R14350 a_4187_1764.n50 a_4187_1764.t111 33.0005
R14351 a_4187_1764.n51 a_4187_1764.t110 33.0005
R14352 a_4187_1764.n52 a_4187_1764.t109 33.0005
R14353 a_4187_1764.n53 a_4187_1764.t108 33.0005
R14354 a_4187_1764.n54 a_4187_1764.t107 33.0005
R14355 a_4187_1764.n55 a_4187_1764.t106 33.0005
R14356 a_4187_1764.n56 a_4187_1764.t105 33.0005
R14357 a_4187_1764.n57 a_4187_1764.t104 33.0005
R14358 a_4187_1764.n58 a_4187_1764.t103 33.0005
R14359 a_4187_1764.n59 a_4187_1764.t102 33.0005
R14360 a_4187_1764.n60 a_4187_1764.t101 33.0005
R14361 a_4187_1764.n61 a_4187_1764.t100 33.0005
R14362 a_4187_1764.n126 a_4187_1764.t96 33.0005
R14363 a_4187_1764.n127 a_4187_1764.t95 33.0005
R14364 a_4187_1764.n128 a_4187_1764.t94 33.0005
R14365 a_4187_1764.n129 a_4187_1764.t93 33.0005
R14366 a_4187_1764.n130 a_4187_1764.t92 33.0005
R14367 a_4187_1764.n131 a_4187_1764.t91 33.0005
R14368 a_4187_1764.n132 a_4187_1764.t90 33.0005
R14369 a_4187_1764.n133 a_4187_1764.t89 33.0005
R14370 a_4187_1764.n134 a_4187_1764.t88 33.0005
R14371 a_4187_1764.n135 a_4187_1764.t87 33.0005
R14372 a_4187_1764.n136 a_4187_1764.t86 33.0005
R14373 a_4187_1764.n137 a_4187_1764.t85 33.0005
R14374 a_4187_1764.n138 a_4187_1764.t84 33.0005
R14375 a_4187_1764.n139 a_4187_1764.t83 33.0005
R14376 a_4187_1764.n140 a_4187_1764.t82 33.0005
R14377 a_4187_1764.n141 a_4187_1764.t81 33.0005
R14378 a_4187_1764.n142 a_4187_1764.t80 33.0005
R14379 a_4187_1764.n143 a_4187_1764.t79 33.0005
R14380 a_4187_1764.n144 a_4187_1764.t78 33.0005
R14381 a_4187_1764.n145 a_4187_1764.t77 33.0005
R14382 a_4187_1764.n146 a_4187_1764.t76 33.0005
R14383 a_4187_1764.n147 a_4187_1764.t75 33.0005
R14384 a_4187_1764.n148 a_4187_1764.t74 33.0005
R14385 a_4187_1764.n149 a_4187_1764.t73 33.0005
R14386 a_4187_1764.n150 a_4187_1764.t72 33.0005
R14387 a_4187_1764.n151 a_4187_1764.t71 33.0005
R14388 a_4187_1764.n152 a_4187_1764.t70 33.0005
R14389 a_4187_1764.n153 a_4187_1764.t69 33.0005
R14390 a_4187_1764.n154 a_4187_1764.t68 33.0005
R14391 a_4187_1764.n155 a_4187_1764.t67 33.0005
R14392 a_4187_1764.n156 a_4187_1764.t66 33.0005
R14393 a_4187_1764.n94 a_4187_1764.t64 33.0005
R14394 a_4187_1764.n95 a_4187_1764.t63 33.0005
R14395 a_4187_1764.n96 a_4187_1764.t62 33.0005
R14396 a_4187_1764.n97 a_4187_1764.t61 33.0005
R14397 a_4187_1764.n98 a_4187_1764.t60 33.0005
R14398 a_4187_1764.n99 a_4187_1764.t59 33.0005
R14399 a_4187_1764.n100 a_4187_1764.t58 33.0005
R14400 a_4187_1764.n101 a_4187_1764.t57 33.0005
R14401 a_4187_1764.n102 a_4187_1764.t56 33.0005
R14402 a_4187_1764.n103 a_4187_1764.t55 33.0005
R14403 a_4187_1764.n104 a_4187_1764.t54 33.0005
R14404 a_4187_1764.n105 a_4187_1764.t53 33.0005
R14405 a_4187_1764.n106 a_4187_1764.t52 33.0005
R14406 a_4187_1764.n107 a_4187_1764.t51 33.0005
R14407 a_4187_1764.n108 a_4187_1764.t50 33.0005
R14408 a_4187_1764.n109 a_4187_1764.t49 33.0005
R14409 a_4187_1764.n110 a_4187_1764.t48 33.0005
R14410 a_4187_1764.n111 a_4187_1764.t47 33.0005
R14411 a_4187_1764.n112 a_4187_1764.t46 33.0005
R14412 a_4187_1764.n113 a_4187_1764.t45 33.0005
R14413 a_4187_1764.n114 a_4187_1764.t44 33.0005
R14414 a_4187_1764.n115 a_4187_1764.t43 33.0005
R14415 a_4187_1764.n116 a_4187_1764.t42 33.0005
R14416 a_4187_1764.n117 a_4187_1764.t41 33.0005
R14417 a_4187_1764.n118 a_4187_1764.t40 33.0005
R14418 a_4187_1764.n119 a_4187_1764.t39 33.0005
R14419 a_4187_1764.n120 a_4187_1764.t38 33.0005
R14420 a_4187_1764.n121 a_4187_1764.t37 33.0005
R14421 a_4187_1764.n122 a_4187_1764.t36 33.0005
R14422 a_4187_1764.n123 a_4187_1764.t35 33.0005
R14423 a_4187_1764.n124 a_4187_1764.t34 33.0005
R14424 a_4187_1764.n63 a_4187_1764.t32 33.0005
R14425 a_4187_1764.n64 a_4187_1764.t31 33.0005
R14426 a_4187_1764.n65 a_4187_1764.t30 33.0005
R14427 a_4187_1764.n66 a_4187_1764.t29 33.0005
R14428 a_4187_1764.n67 a_4187_1764.t28 33.0005
R14429 a_4187_1764.n68 a_4187_1764.t27 33.0005
R14430 a_4187_1764.n69 a_4187_1764.t26 33.0005
R14431 a_4187_1764.n70 a_4187_1764.t25 33.0005
R14432 a_4187_1764.n71 a_4187_1764.t24 33.0005
R14433 a_4187_1764.n72 a_4187_1764.t23 33.0005
R14434 a_4187_1764.n73 a_4187_1764.t22 33.0005
R14435 a_4187_1764.n74 a_4187_1764.t21 33.0005
R14436 a_4187_1764.n75 a_4187_1764.t20 33.0005
R14437 a_4187_1764.n76 a_4187_1764.t19 33.0005
R14438 a_4187_1764.n77 a_4187_1764.t18 33.0005
R14439 a_4187_1764.n78 a_4187_1764.t17 33.0005
R14440 a_4187_1764.n79 a_4187_1764.t16 33.0005
R14441 a_4187_1764.n80 a_4187_1764.t15 33.0005
R14442 a_4187_1764.n81 a_4187_1764.t14 33.0005
R14443 a_4187_1764.n82 a_4187_1764.t13 33.0005
R14444 a_4187_1764.n83 a_4187_1764.t12 33.0005
R14445 a_4187_1764.n84 a_4187_1764.t11 33.0005
R14446 a_4187_1764.n85 a_4187_1764.t10 33.0005
R14447 a_4187_1764.n86 a_4187_1764.t9 33.0005
R14448 a_4187_1764.n87 a_4187_1764.t8 33.0005
R14449 a_4187_1764.n88 a_4187_1764.t7 33.0005
R14450 a_4187_1764.n89 a_4187_1764.t6 33.0005
R14451 a_4187_1764.n90 a_4187_1764.t5 33.0005
R14452 a_4187_1764.n91 a_4187_1764.t4 33.0005
R14453 a_4187_1764.n92 a_4187_1764.t3 33.0005
R14454 a_4187_1764.n93 a_4187_1764.t2 33.0005
R14455 a_4187_1764.n159 a_4187_1764.t99 25.0885
R14456 a_4187_1764.n125 a_4187_1764.n93 15.1797
R14457 a_4187_1764.n62 a_4187_1764.n30 15.1797
R14458 a_4187_1764.n158 a_4187_1764.t98 11.19
R14459 a_4187_1764.t0 a_4187_1764.n160 13.9108
R14460 a_4187_1764.n160 a_4187_1764.t1 12.9887
R14461 a_4187_1764.n62 a_4187_1764.n61 10.8632
R14462 a_4187_1764.n157 a_4187_1764.n156 10.8632
R14463 a_4187_1764.n125 a_4187_1764.n124 10.8632
R14464 a_4187_1764.n158 a_4187_1764.n62 5.26657
R14465 a_4187_1764.n158 a_4187_1764.n157 4.58443
R14466 a_4187_1764.n157 a_4187_1764.n125 4.31705
R14467 a_4187_1764.n30 a_4187_1764.n29 1.3755
R14468 a_4187_1764.n29 a_4187_1764.n28 1.3755
R14469 a_4187_1764.n28 a_4187_1764.n27 1.3755
R14470 a_4187_1764.n27 a_4187_1764.n26 1.3755
R14471 a_4187_1764.n26 a_4187_1764.n25 1.3755
R14472 a_4187_1764.n25 a_4187_1764.n24 1.3755
R14473 a_4187_1764.n24 a_4187_1764.n23 1.3755
R14474 a_4187_1764.n23 a_4187_1764.n22 1.3755
R14475 a_4187_1764.n22 a_4187_1764.n21 1.3755
R14476 a_4187_1764.n21 a_4187_1764.n20 1.3755
R14477 a_4187_1764.n20 a_4187_1764.n19 1.3755
R14478 a_4187_1764.n19 a_4187_1764.n18 1.3755
R14479 a_4187_1764.n18 a_4187_1764.n17 1.3755
R14480 a_4187_1764.n17 a_4187_1764.n16 1.3755
R14481 a_4187_1764.n16 a_4187_1764.n15 1.3755
R14482 a_4187_1764.n15 a_4187_1764.n14 1.3755
R14483 a_4187_1764.n14 a_4187_1764.n13 1.3755
R14484 a_4187_1764.n13 a_4187_1764.n12 1.3755
R14485 a_4187_1764.n12 a_4187_1764.n11 1.3755
R14486 a_4187_1764.n11 a_4187_1764.n10 1.3755
R14487 a_4187_1764.n10 a_4187_1764.n9 1.3755
R14488 a_4187_1764.n9 a_4187_1764.n8 1.3755
R14489 a_4187_1764.n8 a_4187_1764.n7 1.3755
R14490 a_4187_1764.n7 a_4187_1764.n6 1.3755
R14491 a_4187_1764.n6 a_4187_1764.n5 1.3755
R14492 a_4187_1764.n5 a_4187_1764.n4 1.3755
R14493 a_4187_1764.n4 a_4187_1764.n3 1.3755
R14494 a_4187_1764.n3 a_4187_1764.n2 1.3755
R14495 a_4187_1764.n2 a_4187_1764.n1 1.3755
R14496 a_4187_1764.n1 a_4187_1764.n0 1.3755
R14497 a_4187_1764.n61 a_4187_1764.n60 1.3755
R14498 a_4187_1764.n60 a_4187_1764.n59 1.3755
R14499 a_4187_1764.n59 a_4187_1764.n58 1.3755
R14500 a_4187_1764.n58 a_4187_1764.n57 1.3755
R14501 a_4187_1764.n57 a_4187_1764.n56 1.3755
R14502 a_4187_1764.n56 a_4187_1764.n55 1.3755
R14503 a_4187_1764.n55 a_4187_1764.n54 1.3755
R14504 a_4187_1764.n54 a_4187_1764.n53 1.3755
R14505 a_4187_1764.n53 a_4187_1764.n52 1.3755
R14506 a_4187_1764.n52 a_4187_1764.n51 1.3755
R14507 a_4187_1764.n51 a_4187_1764.n50 1.3755
R14508 a_4187_1764.n50 a_4187_1764.n49 1.3755
R14509 a_4187_1764.n49 a_4187_1764.n48 1.3755
R14510 a_4187_1764.n48 a_4187_1764.n47 1.3755
R14511 a_4187_1764.n47 a_4187_1764.n46 1.3755
R14512 a_4187_1764.n46 a_4187_1764.n45 1.3755
R14513 a_4187_1764.n45 a_4187_1764.n44 1.3755
R14514 a_4187_1764.n44 a_4187_1764.n43 1.3755
R14515 a_4187_1764.n43 a_4187_1764.n42 1.3755
R14516 a_4187_1764.n42 a_4187_1764.n41 1.3755
R14517 a_4187_1764.n41 a_4187_1764.n40 1.3755
R14518 a_4187_1764.n40 a_4187_1764.n39 1.3755
R14519 a_4187_1764.n39 a_4187_1764.n38 1.3755
R14520 a_4187_1764.n38 a_4187_1764.n37 1.3755
R14521 a_4187_1764.n37 a_4187_1764.n36 1.3755
R14522 a_4187_1764.n36 a_4187_1764.n35 1.3755
R14523 a_4187_1764.n35 a_4187_1764.n34 1.3755
R14524 a_4187_1764.n34 a_4187_1764.n33 1.3755
R14525 a_4187_1764.n33 a_4187_1764.n32 1.3755
R14526 a_4187_1764.n32 a_4187_1764.n31 1.3755
R14527 a_4187_1764.n156 a_4187_1764.n155 1.3755
R14528 a_4187_1764.n155 a_4187_1764.n154 1.3755
R14529 a_4187_1764.n154 a_4187_1764.n153 1.3755
R14530 a_4187_1764.n153 a_4187_1764.n152 1.3755
R14531 a_4187_1764.n152 a_4187_1764.n151 1.3755
R14532 a_4187_1764.n151 a_4187_1764.n150 1.3755
R14533 a_4187_1764.n150 a_4187_1764.n149 1.3755
R14534 a_4187_1764.n149 a_4187_1764.n148 1.3755
R14535 a_4187_1764.n148 a_4187_1764.n147 1.3755
R14536 a_4187_1764.n147 a_4187_1764.n146 1.3755
R14537 a_4187_1764.n146 a_4187_1764.n145 1.3755
R14538 a_4187_1764.n145 a_4187_1764.n144 1.3755
R14539 a_4187_1764.n144 a_4187_1764.n143 1.3755
R14540 a_4187_1764.n143 a_4187_1764.n142 1.3755
R14541 a_4187_1764.n142 a_4187_1764.n141 1.3755
R14542 a_4187_1764.n141 a_4187_1764.n140 1.3755
R14543 a_4187_1764.n140 a_4187_1764.n139 1.3755
R14544 a_4187_1764.n139 a_4187_1764.n138 1.3755
R14545 a_4187_1764.n138 a_4187_1764.n137 1.3755
R14546 a_4187_1764.n137 a_4187_1764.n136 1.3755
R14547 a_4187_1764.n136 a_4187_1764.n135 1.3755
R14548 a_4187_1764.n135 a_4187_1764.n134 1.3755
R14549 a_4187_1764.n134 a_4187_1764.n133 1.3755
R14550 a_4187_1764.n133 a_4187_1764.n132 1.3755
R14551 a_4187_1764.n132 a_4187_1764.n131 1.3755
R14552 a_4187_1764.n131 a_4187_1764.n130 1.3755
R14553 a_4187_1764.n130 a_4187_1764.n129 1.3755
R14554 a_4187_1764.n129 a_4187_1764.n128 1.3755
R14555 a_4187_1764.n128 a_4187_1764.n127 1.3755
R14556 a_4187_1764.n127 a_4187_1764.n126 1.3755
R14557 a_4187_1764.n124 a_4187_1764.n123 1.3755
R14558 a_4187_1764.n123 a_4187_1764.n122 1.3755
R14559 a_4187_1764.n122 a_4187_1764.n121 1.3755
R14560 a_4187_1764.n121 a_4187_1764.n120 1.3755
R14561 a_4187_1764.n120 a_4187_1764.n119 1.3755
R14562 a_4187_1764.n119 a_4187_1764.n118 1.3755
R14563 a_4187_1764.n118 a_4187_1764.n117 1.3755
R14564 a_4187_1764.n117 a_4187_1764.n116 1.3755
R14565 a_4187_1764.n116 a_4187_1764.n115 1.3755
R14566 a_4187_1764.n115 a_4187_1764.n114 1.3755
R14567 a_4187_1764.n114 a_4187_1764.n113 1.3755
R14568 a_4187_1764.n113 a_4187_1764.n112 1.3755
R14569 a_4187_1764.n112 a_4187_1764.n111 1.3755
R14570 a_4187_1764.n111 a_4187_1764.n110 1.3755
R14571 a_4187_1764.n110 a_4187_1764.n109 1.3755
R14572 a_4187_1764.n109 a_4187_1764.n108 1.3755
R14573 a_4187_1764.n108 a_4187_1764.n107 1.3755
R14574 a_4187_1764.n107 a_4187_1764.n106 1.3755
R14575 a_4187_1764.n106 a_4187_1764.n105 1.3755
R14576 a_4187_1764.n105 a_4187_1764.n104 1.3755
R14577 a_4187_1764.n104 a_4187_1764.n103 1.3755
R14578 a_4187_1764.n103 a_4187_1764.n102 1.3755
R14579 a_4187_1764.n102 a_4187_1764.n101 1.3755
R14580 a_4187_1764.n101 a_4187_1764.n100 1.3755
R14581 a_4187_1764.n100 a_4187_1764.n99 1.3755
R14582 a_4187_1764.n99 a_4187_1764.n98 1.3755
R14583 a_4187_1764.n98 a_4187_1764.n97 1.3755
R14584 a_4187_1764.n97 a_4187_1764.n96 1.3755
R14585 a_4187_1764.n96 a_4187_1764.n95 1.3755
R14586 a_4187_1764.n95 a_4187_1764.n94 1.3755
R14587 a_4187_1764.n93 a_4187_1764.n92 1.3755
R14588 a_4187_1764.n92 a_4187_1764.n91 1.3755
R14589 a_4187_1764.n91 a_4187_1764.n90 1.3755
R14590 a_4187_1764.n90 a_4187_1764.n89 1.3755
R14591 a_4187_1764.n89 a_4187_1764.n88 1.3755
R14592 a_4187_1764.n88 a_4187_1764.n87 1.3755
R14593 a_4187_1764.n87 a_4187_1764.n86 1.3755
R14594 a_4187_1764.n86 a_4187_1764.n85 1.3755
R14595 a_4187_1764.n85 a_4187_1764.n84 1.3755
R14596 a_4187_1764.n84 a_4187_1764.n83 1.3755
R14597 a_4187_1764.n83 a_4187_1764.n82 1.3755
R14598 a_4187_1764.n82 a_4187_1764.n81 1.3755
R14599 a_4187_1764.n81 a_4187_1764.n80 1.3755
R14600 a_4187_1764.n80 a_4187_1764.n79 1.3755
R14601 a_4187_1764.n79 a_4187_1764.n78 1.3755
R14602 a_4187_1764.n78 a_4187_1764.n77 1.3755
R14603 a_4187_1764.n77 a_4187_1764.n76 1.3755
R14604 a_4187_1764.n76 a_4187_1764.n75 1.3755
R14605 a_4187_1764.n75 a_4187_1764.n74 1.3755
R14606 a_4187_1764.n74 a_4187_1764.n73 1.3755
R14607 a_4187_1764.n73 a_4187_1764.n72 1.3755
R14608 a_4187_1764.n72 a_4187_1764.n71 1.3755
R14609 a_4187_1764.n71 a_4187_1764.n70 1.3755
R14610 a_4187_1764.n70 a_4187_1764.n69 1.3755
R14611 a_4187_1764.n69 a_4187_1764.n68 1.3755
R14612 a_4187_1764.n68 a_4187_1764.n67 1.3755
R14613 a_4187_1764.n67 a_4187_1764.n66 1.3755
R14614 a_4187_1764.n66 a_4187_1764.n65 1.3755
R14615 a_4187_1764.n65 a_4187_1764.n64 1.3755
R14616 a_4187_1764.n64 a_4187_1764.n63 1.3755
R14617 a_4187_1764.n160 a_4187_1764.n159 0.735818
R14618 a_4187_1764.n159 a_4187_1764.t98 7.58765
C5461 CHAN3_MUX_OUT VSS 3.4803f
C5462 CHAN3_MUX_SEL4 VSS 1.61242f
C5463 CHAN3_MUX_SEL3 VSS 0.911f
C5464 CHAN3_MUX_SEL2 VSS 2.10279f
C5465 CHAN3_MUX_SEL1 VSS 0.95663f
C5466 CHAN3_MUX_SEL0 VSS 1.84404f
C5467 CHAN3_DELAY_OUT_LAST VSS 0.38565f
C5468 CHAN3_DELAY_IN VSS 1.54622f
C5469 CHAN2_MUX_OUT VSS 1.73372f
C5470 CHAN2_MUX_SEL4 VSS 1.4129f
C5471 CHAN2_MUX_SEL3 VSS 0.89916f
C5472 CHAN2_MUX_SEL2 VSS 1.72548f
C5473 CHAN2_MUX_SEL1 VSS 0.95663f
C5474 CHAN2_MUX_SEL0 VSS 1.84404f
C5475 CHAN2_DELAY_OUT_LAST VSS 0.38565f
C5476 CHAN2_DELAY_IN VSS 1.53855f
C5477 REF_MUX_OUT VSS 1.73372f
C5478 REF_MUX_SEL4 VSS 1.4129f
C5479 REF_MUX_SEL3 VSS 0.89916f
C5480 REF_MUX_SEL2 VSS 1.72548f
C5481 REF_MUX_SEL1 VSS 0.96112f
C5482 REF_MUX_SEL0 VSS 1.85055f
C5483 REF_DELAY_OUT_LAST VSS 2.81565f
C5484 REF_CLK VSS 3.32521f
C5485 DLL_RESETN VSS 4.3462f
C5486 CHAN1_MUX_OUT VSS 2.27545f
C5487 CHAN1_MUX_SEL4 VSS 1.59616f
C5488 CHAN1_MUX_SEL3 VSS 0.90759f
C5489 CHAN1_MUX_SEL2 VSS 1.98915f
C5490 CHAN1_MUX_SEL1 VSS 0.95663f
C5491 CHAN1_MUX_SEL0 VSS 1.84404f
C5492 CHAN1_DELAY_OUT_LAST VSS 0.38565f
C5493 CHAN1_DELAY_IN VSS 1.54623f
C5494 CHAN0_MUX_OUT VSS 1.73372f
C5495 CHAN0_MUX_SEL4 VSS 1.4129f
C5496 CHAN0_MUX_SEL3 VSS 0.89916f
C5497 CHAN0_MUX_SEL2 VSS 1.72548f
C5498 CHAN0_MUX_SEL1 VSS 0.96112f
C5499 CHAN0_MUX_SEL0 VSS 1.85054f
C5500 CHAN0_DELAY_OUT_LAST VSS 0.39284f
C5501 CHAN0_DELAY_IN VSS 1.86355f
C5502 VDD VSS 0.27804p
C5503 a_26985_519# VSS 0.17928f ; **FLOATING
C5504 a_23945_519# VSS 0.17928f ; **FLOATING
C5505 a_20905_519# VSS 0.17928f ; **FLOATING
C5506 a_17865_519# VSS 0.17593f ; **FLOATING
C5507 a_16851_309# VSS 0.38699f ; **FLOATING
C5508 a_16108_289# VSS 3.75745f ; **FLOATING
C5509 a_15964_289# VSS 0.17613f ; **FLOATING
C5510 a_15765_463# VSS 0.36132f ; **FLOATING
C5511 a_14825_519# VSS 0.17928f ; **FLOATING
C5512 a_11785_519# VSS 0.17928f ; **FLOATING
C5513 a_8745_519# VSS 0.17928f ; **FLOATING
C5514 a_5731_289# VSS 3.43538f ; **FLOATING
C5515 a_5705_519# VSS 0.17638f ; **FLOATING
C5516 a_3449_331# VSS 0.18478f ; **FLOATING
C5517 a_2873_331# VSS 0.18345f ; **FLOATING
C5518 a_2297_331# VSS 0.18321f ; **FLOATING
C5519 a_1721_331# VSS 0.17001f ; **FLOATING
C5520 a_1544_289# VSS 0.30014f ; **FLOATING
C5521 a_1256_289# VSS 0.84266f ; **FLOATING
C5522 a_27991_1008# VSS 0.18706f ; **FLOATING
C5523 a_27915_1044# VSS 0.10926f ; **FLOATING
C5524 a_27124_1008# VSS 0.17878f ; **FLOATING
C5525 a_27048_1044# VSS 0.12122f ; **FLOATING
C5526 a_26471_1008# VSS 0.18175f ; **FLOATING
C5527 a_26395_1044# VSS 0.11073f ; **FLOATING
C5528 a_25604_1008# VSS 0.18087f ; **FLOATING
C5529 a_25630_1044# VSS 0.37805f ; **FLOATING
C5530 a_25528_1044# VSS 0.12433f ; **FLOATING
C5531 a_24951_1008# VSS 0.18335f ; **FLOATING
C5532 a_24875_1044# VSS 0.11016f ; **FLOATING
C5533 a_24084_1008# VSS 0.17878f ; **FLOATING
C5534 a_24008_1044# VSS 0.12122f ; **FLOATING
C5535 a_23431_1008# VSS 0.1818f ; **FLOATING
C5536 a_23355_1044# VSS 0.11554f ; **FLOATING
C5537 a_22564_1008# VSS 0.18087f ; **FLOATING
C5538 a_22590_1044# VSS 0.34379f ; **FLOATING
C5539 a_22488_1044# VSS 0.12433f ; **FLOATING
C5540 a_21911_1008# VSS 0.18335f ; **FLOATING
C5541 a_21835_1044# VSS 0.11016f ; **FLOATING
C5542 a_21044_1008# VSS 0.17878f ; **FLOATING
C5543 a_20968_1044# VSS 0.12122f ; **FLOATING
C5544 a_20391_1008# VSS 0.18175f ; **FLOATING
C5545 a_20315_1044# VSS 0.11073f ; **FLOATING
C5546 a_19524_1008# VSS 0.18087f ; **FLOATING
C5547 a_19550_1044# VSS 0.33343f ; **FLOATING
C5548 a_19448_1044# VSS 0.12433f ; **FLOATING
C5549 a_18871_1008# VSS 0.18335f ; **FLOATING
C5550 a_18795_1044# VSS 0.11016f ; **FLOATING
C5551 a_18004_1008# VSS 0.17878f ; **FLOATING
C5552 a_17928_1044# VSS 0.12122f ; **FLOATING
C5553 a_17351_1008# VSS 0.18022f ; **FLOATING
C5554 a_17275_1044# VSS 0.10926f ; **FLOATING
C5555 a_16484_1008# VSS 0.18023f ; **FLOATING
C5556 a_16510_1044# VSS 0.28935f ; **FLOATING
C5557 a_16408_1044# VSS 0.1229f ; **FLOATING
C5558 a_15831_1008# VSS 0.17846f ; **FLOATING
C5559 a_15755_1044# VSS 0.10926f ; **FLOATING
C5560 a_14964_1008# VSS 0.17878f ; **FLOATING
C5561 a_14888_1044# VSS 0.12122f ; **FLOATING
C5562 a_14311_1008# VSS 0.18175f ; **FLOATING
C5563 a_14235_1044# VSS 0.11073f ; **FLOATING
C5564 a_13444_1008# VSS 0.18205f ; **FLOATING
C5565 a_13470_1044# VSS 0.30999f ; **FLOATING
C5566 a_13368_1044# VSS 0.13246f ; **FLOATING
C5567 a_12791_1008# VSS 0.18335f ; **FLOATING
C5568 a_12715_1044# VSS 0.11016f ; **FLOATING
C5569 a_11924_1008# VSS 0.17878f ; **FLOATING
C5570 a_11848_1044# VSS 0.12122f ; **FLOATING
C5571 a_11271_1008# VSS 0.18175f ; **FLOATING
C5572 a_11195_1044# VSS 0.11073f ; **FLOATING
C5573 a_10404_1008# VSS 0.18087f ; **FLOATING
C5574 a_10430_1044# VSS 0.30746f ; **FLOATING
C5575 a_10328_1044# VSS 0.12433f ; **FLOATING
C5576 a_9751_1008# VSS 0.18335f ; **FLOATING
C5577 a_9675_1044# VSS 0.11016f ; **FLOATING
C5578 a_8884_1008# VSS 0.17878f ; **FLOATING
C5579 a_8808_1044# VSS 0.12122f ; **FLOATING
C5580 a_8231_1008# VSS 0.18175f ; **FLOATING
C5581 a_8155_1044# VSS 0.11073f ; **FLOATING
C5582 a_7364_1008# VSS 0.18087f ; **FLOATING
C5583 a_7390_1044# VSS 0.31357f ; **FLOATING
C5584 a_7288_1044# VSS 0.12433f ; **FLOATING
C5585 a_6711_1008# VSS 0.18335f ; **FLOATING
C5586 a_6635_1044# VSS 0.11016f ; **FLOATING
C5587 a_5844_1008# VSS 0.17878f ; **FLOATING
C5588 a_5768_1044# VSS 0.12122f ; **FLOATING
C5589 a_5191_1008# VSS 0.18022f ; **FLOATING
C5590 a_5115_1044# VSS 0.10926f ; **FLOATING
C5591 a_4324_1008# VSS 0.18023f ; **FLOATING
C5592 a_4350_1044# VSS 0.26655f ; **FLOATING
C5593 a_4248_1044# VSS 0.12443f ; **FLOATING
C5594 a_27705_1044# VSS 0.25297f ; **FLOATING
C5595 a_26185_1044# VSS 0.23475f ; **FLOATING
C5596 a_24665_1044# VSS 0.25405f ; **FLOATING
C5597 a_23145_1044# VSS 0.24628f ; **FLOATING
C5598 a_21625_1044# VSS 0.25405f ; **FLOATING
C5599 a_20105_1044# VSS 0.23475f ; **FLOATING
C5600 a_18585_1044# VSS 0.25405f ; **FLOATING
C5601 a_17065_1044# VSS 0.23387f ; **FLOATING
C5602 a_15545_1044# VSS 0.25297f ; **FLOATING
C5603 a_14025_1044# VSS 0.23475f ; **FLOATING
C5604 a_12505_1044# VSS 0.25405f ; **FLOATING
C5605 a_10985_1044# VSS 0.23475f ; **FLOATING
C5606 a_9465_1044# VSS 0.25405f ; **FLOATING
C5607 a_7945_1044# VSS 0.23475f ; **FLOATING
C5608 a_6425_1044# VSS 0.25405f ; **FLOATING
C5609 a_4905_1044# VSS 0.2355f ; **FLOATING
C5610 a_4157_1313# VSS 0.32875f ; **FLOATING
C5611 a_3449_1395# VSS 0.18619f ; **FLOATING
C5612 a_2873_1395# VSS 0.18345f ; **FLOATING
C5613 a_2297_1395# VSS 0.18296f ; **FLOATING
C5614 a_1721_1395# VSS 0.16976f ; **FLOATING
C5615 a_1544_1044# VSS 0.29775f ; **FLOATING
C5616 a_1256_1044# VSS 0.80175f ; **FLOATING
C5617 a_27671_1842# VSS 0.01336f ; **FLOATING
C5618 a_26911_1842# VSS 0.01336f ; **FLOATING
C5619 a_26151_1842# VSS 0.01336f ; **FLOATING
C5620 a_25391_1842# VSS 0.01336f ; **FLOATING
C5621 a_24631_1842# VSS 0.01336f ; **FLOATING
C5622 a_23871_1842# VSS 0.01336f ; **FLOATING
C5623 a_23111_1842# VSS 0.01733f ; **FLOATING
C5624 a_22351_1842# VSS 0.01336f ; **FLOATING
C5625 a_21591_1842# VSS 0.01336f ; **FLOATING
C5626 a_20831_1842# VSS 0.01336f ; **FLOATING
C5627 a_20071_1842# VSS 0.01336f ; **FLOATING
C5628 a_19311_1842# VSS 0.01336f ; **FLOATING
C5629 a_18551_1842# VSS 0.01336f ; **FLOATING
C5630 a_17791_1842# VSS 0.01336f ; **FLOATING
C5631 a_17031_1842# VSS 0.01336f ; **FLOATING
C5632 a_16271_1842# VSS 0.01336f ; **FLOATING
C5633 a_15511_1842# VSS 0.01336f ; **FLOATING
C5634 a_14751_1842# VSS 0.01336f ; **FLOATING
C5635 a_13991_1842# VSS 0.01336f ; **FLOATING
C5636 a_13231_1842# VSS 0.01733f ; **FLOATING
C5637 a_12471_1842# VSS 0.01336f ; **FLOATING
C5638 a_11711_1842# VSS 0.01336f ; **FLOATING
C5639 a_10951_1842# VSS 0.01336f ; **FLOATING
C5640 a_10191_1842# VSS 0.01336f ; **FLOATING
C5641 a_9431_1842# VSS 0.01336f ; **FLOATING
C5642 a_8671_1842# VSS 0.01336f ; **FLOATING
C5643 a_7911_1842# VSS 0.01336f ; **FLOATING
C5644 a_7151_1842# VSS 0.01336f ; **FLOATING
C5645 a_6391_1842# VSS 0.01336f ; **FLOATING
C5646 a_5631_1842# VSS 0.01336f ; **FLOATING
C5647 a_4871_1842# VSS 0.01336f ; **FLOATING
C5648 a_4111_1842# VSS 0.0139f ; **FLOATING
C5649 a_27563_1842# VSS 0.49473f ; **FLOATING
C5650 a_27997_1842# VSS 0.64441f ; **FLOATING
C5651 a_27433_1842# VSS 0.44435f ; **FLOATING
C5652 a_26803_1842# VSS 0.48676f ; **FLOATING
C5653 a_27237_1842# VSS 0.92458f ; **FLOATING
C5654 a_26673_1842# VSS 0.44348f ; **FLOATING
C5655 a_26043_1842# VSS 0.48774f ; **FLOATING
C5656 a_26477_1842# VSS 0.95131f ; **FLOATING
C5657 a_25913_1842# VSS 0.44619f ; **FLOATING
C5658 a_25283_1842# VSS 0.48565f ; **FLOATING
C5659 a_25717_1842# VSS 0.86118f ; **FLOATING
C5660 a_25153_1842# VSS 0.44417f ; **FLOATING
C5661 a_24523_1842# VSS 0.48747f ; **FLOATING
C5662 a_24957_1842# VSS 0.95519f ; **FLOATING
C5663 a_24393_1842# VSS 0.44145f ; **FLOATING
C5664 a_23763_1842# VSS 0.48687f ; **FLOATING
C5665 a_24197_1842# VSS 0.91985f ; **FLOATING
C5666 a_23633_1842# VSS 0.447f ; **FLOATING
C5667 a_23003_1842# VSS 0.9554f ; **FLOATING
C5668 a_23437_1842# VSS 1.07998f ; **FLOATING
C5669 a_22873_1842# VSS 0.56838f ; **FLOATING
C5670 a_22243_1842# VSS 0.46743f ; **FLOATING
C5671 a_22677_1842# VSS 0.88616f ; **FLOATING
C5672 a_22113_1842# VSS 0.44347f ; **FLOATING
C5673 a_21483_1842# VSS 0.4875f ; **FLOATING
C5674 a_21917_1842# VSS 0.95287f ; **FLOATING
C5675 a_21353_1842# VSS 0.44138f ; **FLOATING
C5676 a_20723_1842# VSS 0.48671f ; **FLOATING
C5677 a_21157_1842# VSS 0.91928f ; **FLOATING
C5678 a_20593_1842# VSS 0.44348f ; **FLOATING
C5679 a_19963_1842# VSS 0.48774f ; **FLOATING
C5680 a_20397_1842# VSS 0.95131f ; **FLOATING
C5681 a_19833_1842# VSS 0.44619f ; **FLOATING
C5682 a_19203_1842# VSS 0.48565f ; **FLOATING
C5683 a_19637_1842# VSS 0.86118f ; **FLOATING
C5684 a_19073_1842# VSS 0.44414f ; **FLOATING
C5685 a_18443_1842# VSS 0.48744f ; **FLOATING
C5686 a_18877_1842# VSS 0.95513f ; **FLOATING
C5687 a_18313_1842# VSS 0.44059f ; **FLOATING
C5688 a_17683_1842# VSS 0.48671f ; **FLOATING
C5689 a_18117_1842# VSS 0.91647f ; **FLOATING
C5690 a_17553_1842# VSS 0.44348f ; **FLOATING
C5691 a_16923_1842# VSS 0.4899f ; **FLOATING
C5692 a_17357_1842# VSS 0.95213f ; **FLOATING
C5693 a_16793_1842# VSS 0.44447f ; **FLOATING
C5694 a_16163_1842# VSS 0.48792f ; **FLOATING
C5695 a_16597_1842# VSS 0.85769f ; **FLOATING
C5696 a_16033_1842# VSS 0.4368f ; **FLOATING
C5697 a_15403_1842# VSS 0.48909f ; **FLOATING
C5698 a_15837_1842# VSS 0.94699f ; **FLOATING
C5699 a_15273_1842# VSS 0.44136f ; **FLOATING
C5700 a_14643_1842# VSS 0.48674f ; **FLOATING
C5701 a_15077_1842# VSS 0.91819f ; **FLOATING
C5702 a_14513_1842# VSS 0.44355f ; **FLOATING
C5703 a_13883_1842# VSS 0.48786f ; **FLOATING
C5704 a_14317_1842# VSS 0.95152f ; **FLOATING
C5705 a_13753_1842# VSS 0.44737f ; **FLOATING
C5706 a_13123_1842# VSS 0.94748f ; **FLOATING
C5707 a_13557_1842# VSS 0.9343f ; **FLOATING
C5708 a_12993_1842# VSS 0.56321f ; **FLOATING
C5709 a_12363_1842# VSS 0.46822f ; **FLOATING
C5710 a_12797_1842# VSS 1.11192f ; **FLOATING
C5711 a_12233_1842# VSS 0.4374f ; **FLOATING
C5712 a_11603_1842# VSS 0.48677f ; **FLOATING
C5713 a_12037_1842# VSS 0.9194f ; **FLOATING
C5714 a_11473_1842# VSS 0.4435f ; **FLOATING
C5715 a_10843_1842# VSS 0.48774f ; **FLOATING
C5716 a_11277_1842# VSS 0.95131f ; **FLOATING
C5717 a_10713_1842# VSS 0.44619f ; **FLOATING
C5718 a_10083_1842# VSS 0.48563f ; **FLOATING
C5719 a_10517_1842# VSS 0.86118f ; **FLOATING
C5720 a_9953_1842# VSS 0.44414f ; **FLOATING
C5721 a_9323_1842# VSS 0.48744f ; **FLOATING
C5722 a_9757_1842# VSS 0.95346f ; **FLOATING
C5723 a_9193_1842# VSS 0.44136f ; **FLOATING
C5724 a_8563_1842# VSS 0.48671f ; **FLOATING
C5725 a_8997_1842# VSS 0.91928f ; **FLOATING
C5726 a_8433_1842# VSS 0.44348f ; **FLOATING
C5727 a_7803_1842# VSS 0.48774f ; **FLOATING
C5728 a_8237_1842# VSS 0.95131f ; **FLOATING
C5729 a_7673_1842# VSS 0.44619f ; **FLOATING
C5730 a_7043_1842# VSS 0.48563f ; **FLOATING
C5731 a_7477_1842# VSS 0.86118f ; **FLOATING
C5732 a_6913_1842# VSS 0.44414f ; **FLOATING
C5733 a_6283_1842# VSS 0.48744f ; **FLOATING
C5734 a_6717_1842# VSS 0.95287f ; **FLOATING
C5735 a_6153_1842# VSS 0.44059f ; **FLOATING
C5736 a_5523_1842# VSS 0.48671f ; **FLOATING
C5737 a_5957_1842# VSS 0.91647f ; **FLOATING
C5738 a_5393_1842# VSS 0.44587f ; **FLOATING
C5739 a_4763_1842# VSS 0.49323f ; **FLOATING
C5740 a_5197_1842# VSS 0.95411f ; **FLOATING
C5741 a_4633_1842# VSS 0.44887f ; **FLOATING
C5742 a_4003_1842# VSS 0.57075f ; **FLOATING
C5743 a_4437_1842# VSS 0.86512f ; **FLOATING
C5744 a_26985_3364# VSS 0.17928f ; **FLOATING
C5745 a_23945_3364# VSS 0.17928f ; **FLOATING
C5746 a_20905_3364# VSS 0.17928f ; **FLOATING
C5747 a_17865_3364# VSS 0.17593f ; **FLOATING
C5748 a_16851_3154# VSS 0.37653f ; **FLOATING
C5749 a_16108_3134# VSS 2.50019f ; **FLOATING
C5750 a_15964_3134# VSS 0.17103f ; **FLOATING
C5751 a_15765_3308# VSS 0.33587f ; **FLOATING
C5752 a_14825_3364# VSS 0.17928f ; **FLOATING
C5753 a_11785_3364# VSS 0.17928f ; **FLOATING
C5754 a_8745_3364# VSS 0.17928f ; **FLOATING
C5755 a_5731_3134# VSS 2.24589f ; **FLOATING
C5756 a_5705_3364# VSS 0.17638f ; **FLOATING
C5757 a_3449_3176# VSS 0.17702f ; **FLOATING
C5758 a_2873_3176# VSS 0.18304f ; **FLOATING
C5759 a_2297_3176# VSS 0.1828f ; **FLOATING
C5760 a_1721_3176# VSS 0.1696f ; **FLOATING
C5761 a_1544_3134# VSS 0.29702f ; **FLOATING
C5762 a_1256_3134# VSS 0.78477f ; **FLOATING
C5763 a_27991_3853# VSS 0.18561f ; **FLOATING
C5764 a_27915_3889# VSS 0.10926f ; **FLOATING
C5765 a_27124_3853# VSS 0.17878f ; **FLOATING
C5766 a_27048_3889# VSS 0.12122f ; **FLOATING
C5767 a_26471_3853# VSS 0.18126f ; **FLOATING
C5768 a_26395_3889# VSS 0.11073f ; **FLOATING
C5769 a_25604_3853# VSS 0.18087f ; **FLOATING
C5770 a_25630_3889# VSS 0.33072f ; **FLOATING
C5771 a_25528_3889# VSS 0.12433f ; **FLOATING
C5772 a_24951_3853# VSS 0.18335f ; **FLOATING
C5773 a_24875_3889# VSS 0.11016f ; **FLOATING
C5774 a_24084_3853# VSS 0.17878f ; **FLOATING
C5775 a_24008_3889# VSS 0.12122f ; **FLOATING
C5776 a_23431_3853# VSS 0.18132f ; **FLOATING
C5777 a_23355_3889# VSS 0.11566f ; **FLOATING
C5778 a_22564_3853# VSS 0.18087f ; **FLOATING
C5779 a_22590_3889# VSS 0.34383f ; **FLOATING
C5780 a_22488_3889# VSS 0.12433f ; **FLOATING
C5781 a_21911_3853# VSS 0.18335f ; **FLOATING
C5782 a_21835_3889# VSS 0.11016f ; **FLOATING
C5783 a_21044_3853# VSS 0.17878f ; **FLOATING
C5784 a_20968_3889# VSS 0.12122f ; **FLOATING
C5785 a_20391_3853# VSS 0.18126f ; **FLOATING
C5786 a_20315_3889# VSS 0.11073f ; **FLOATING
C5787 a_19524_3853# VSS 0.18087f ; **FLOATING
C5788 a_19550_3889# VSS 0.33343f ; **FLOATING
C5789 a_19448_3889# VSS 0.12433f ; **FLOATING
C5790 a_18871_3853# VSS 0.18335f ; **FLOATING
C5791 a_18795_3889# VSS 0.11016f ; **FLOATING
C5792 a_18004_3853# VSS 0.17878f ; **FLOATING
C5793 a_17928_3889# VSS 0.12122f ; **FLOATING
C5794 a_17351_3853# VSS 0.17877f ; **FLOATING
C5795 a_17275_3889# VSS 0.10926f ; **FLOATING
C5796 a_16484_3853# VSS 0.17947f ; **FLOATING
C5797 a_16510_3889# VSS 0.28935f ; **FLOATING
C5798 a_16408_3889# VSS 0.1229f ; **FLOATING
C5799 a_15831_3853# VSS 0.17846f ; **FLOATING
C5800 a_15755_3889# VSS 0.10926f ; **FLOATING
C5801 a_14964_3853# VSS 0.17878f ; **FLOATING
C5802 a_14888_3889# VSS 0.12122f ; **FLOATING
C5803 a_14311_3853# VSS 0.18126f ; **FLOATING
C5804 a_14235_3889# VSS 0.11073f ; **FLOATING
C5805 a_13444_3853# VSS 0.18205f ; **FLOATING
C5806 a_13470_3889# VSS 0.30999f ; **FLOATING
C5807 a_13368_3889# VSS 0.13246f ; **FLOATING
C5808 a_12791_3853# VSS 0.18335f ; **FLOATING
C5809 a_12715_3889# VSS 0.11016f ; **FLOATING
C5810 a_11924_3853# VSS 0.17878f ; **FLOATING
C5811 a_11848_3889# VSS 0.12122f ; **FLOATING
C5812 a_11271_3853# VSS 0.18126f ; **FLOATING
C5813 a_11195_3889# VSS 0.11073f ; **FLOATING
C5814 a_10404_3853# VSS 0.18087f ; **FLOATING
C5815 a_10430_3889# VSS 0.30746f ; **FLOATING
C5816 a_10328_3889# VSS 0.12433f ; **FLOATING
C5817 a_9751_3853# VSS 0.18335f ; **FLOATING
C5818 a_9675_3889# VSS 0.11016f ; **FLOATING
C5819 a_8884_3853# VSS 0.17878f ; **FLOATING
C5820 a_8808_3889# VSS 0.12122f ; **FLOATING
C5821 a_8231_3853# VSS 0.18126f ; **FLOATING
C5822 a_8155_3889# VSS 0.11073f ; **FLOATING
C5823 a_7364_3853# VSS 0.18087f ; **FLOATING
C5824 a_7390_3889# VSS 0.31357f ; **FLOATING
C5825 a_7288_3889# VSS 0.12433f ; **FLOATING
C5826 a_6711_3853# VSS 0.18335f ; **FLOATING
C5827 a_6635_3889# VSS 0.11016f ; **FLOATING
C5828 a_5844_3853# VSS 0.17878f ; **FLOATING
C5829 a_5768_3889# VSS 0.12122f ; **FLOATING
C5830 a_5191_3853# VSS 0.17877f ; **FLOATING
C5831 a_5115_3889# VSS 0.10926f ; **FLOATING
C5832 a_4324_3853# VSS 0.17947f ; **FLOATING
C5833 a_4350_3889# VSS 0.26655f ; **FLOATING
C5834 a_4248_3889# VSS 0.12443f ; **FLOATING
C5835 a_27705_3889# VSS 0.25232f ; **FLOATING
C5836 a_26185_3889# VSS 0.23475f ; **FLOATING
C5837 a_24665_3889# VSS 0.25405f ; **FLOATING
C5838 a_23145_3889# VSS 0.24628f ; **FLOATING
C5839 a_21625_3889# VSS 0.25405f ; **FLOATING
C5840 a_20105_3889# VSS 0.23475f ; **FLOATING
C5841 a_18585_3889# VSS 0.25405f ; **FLOATING
C5842 a_17065_3889# VSS 0.23379f ; **FLOATING
C5843 a_15545_3889# VSS 0.25232f ; **FLOATING
C5844 a_14025_3889# VSS 0.23475f ; **FLOATING
C5845 a_12505_3889# VSS 0.25405f ; **FLOATING
C5846 a_10985_3889# VSS 0.23475f ; **FLOATING
C5847 a_9465_3889# VSS 0.25405f ; **FLOATING
C5848 a_7945_3889# VSS 0.23475f ; **FLOATING
C5849 a_6425_3889# VSS 0.25405f ; **FLOATING
C5850 a_4905_3889# VSS 0.23484f ; **FLOATING
C5851 a_4157_4158# VSS 0.32839f ; **FLOATING
C5852 a_3449_4240# VSS 0.18619f ; **FLOATING
C5853 a_2873_4240# VSS 0.18345f ; **FLOATING
C5854 a_2297_4240# VSS 0.18296f ; **FLOATING
C5855 a_1721_4240# VSS 0.16976f ; **FLOATING
C5856 a_1544_3889# VSS 0.29775f ; **FLOATING
C5857 a_1256_3889# VSS 0.80175f ; **FLOATING
C5858 a_27671_4687# VSS 0.01336f ; **FLOATING
C5859 a_26911_4687# VSS 0.01336f ; **FLOATING
C5860 a_26151_4687# VSS 0.01336f ; **FLOATING
C5861 a_25391_4687# VSS 0.01336f ; **FLOATING
C5862 a_24631_4687# VSS 0.01336f ; **FLOATING
C5863 a_23871_4687# VSS 0.01336f ; **FLOATING
C5864 a_23111_4687# VSS 0.01733f ; **FLOATING
C5865 a_22351_4687# VSS 0.01336f ; **FLOATING
C5866 a_21591_4687# VSS 0.01336f ; **FLOATING
C5867 a_20831_4687# VSS 0.01336f ; **FLOATING
C5868 a_20071_4687# VSS 0.01336f ; **FLOATING
C5869 a_19311_4687# VSS 0.01336f ; **FLOATING
C5870 a_18551_4687# VSS 0.01336f ; **FLOATING
C5871 a_17791_4687# VSS 0.01336f ; **FLOATING
C5872 a_17031_4687# VSS 0.01336f ; **FLOATING
C5873 a_16271_4687# VSS 0.01336f ; **FLOATING
C5874 a_15511_4687# VSS 0.01336f ; **FLOATING
C5875 a_14751_4687# VSS 0.01336f ; **FLOATING
C5876 a_13991_4687# VSS 0.01336f ; **FLOATING
C5877 a_13231_4687# VSS 0.01733f ; **FLOATING
C5878 a_12471_4687# VSS 0.01336f ; **FLOATING
C5879 a_11711_4687# VSS 0.01336f ; **FLOATING
C5880 a_10951_4687# VSS 0.01336f ; **FLOATING
C5881 a_10191_4687# VSS 0.01336f ; **FLOATING
C5882 a_9431_4687# VSS 0.01336f ; **FLOATING
C5883 a_8671_4687# VSS 0.01336f ; **FLOATING
C5884 a_7911_4687# VSS 0.01336f ; **FLOATING
C5885 a_7151_4687# VSS 0.01336f ; **FLOATING
C5886 a_6391_4687# VSS 0.01336f ; **FLOATING
C5887 a_5631_4687# VSS 0.01336f ; **FLOATING
C5888 a_4871_4687# VSS 0.01336f ; **FLOATING
C5889 a_4111_4687# VSS 0.0139f ; **FLOATING
C5890 a_27563_4687# VSS 0.49473f ; **FLOATING
C5891 a_27997_4687# VSS 0.64441f ; **FLOATING
C5892 a_27433_4687# VSS 0.44435f ; **FLOATING
C5893 a_26803_4687# VSS 0.48676f ; **FLOATING
C5894 a_27237_4687# VSS 0.92278f ; **FLOATING
C5895 a_26673_4687# VSS 0.44348f ; **FLOATING
C5896 a_26043_4687# VSS 0.48774f ; **FLOATING
C5897 a_26477_4687# VSS 0.95122f ; **FLOATING
C5898 a_25913_4687# VSS 0.44619f ; **FLOATING
C5899 a_25283_4687# VSS 0.48565f ; **FLOATING
C5900 a_25717_4687# VSS 0.86086f ; **FLOATING
C5901 a_25153_4687# VSS 0.44417f ; **FLOATING
C5902 a_24523_4687# VSS 0.48747f ; **FLOATING
C5903 a_24957_4687# VSS 0.95519f ; **FLOATING
C5904 a_24393_4687# VSS 0.44145f ; **FLOATING
C5905 a_23763_4687# VSS 0.48687f ; **FLOATING
C5906 a_24197_4687# VSS 0.91872f ; **FLOATING
C5907 a_23633_4687# VSS 0.44706f ; **FLOATING
C5908 a_23003_4687# VSS 0.95737f ; **FLOATING
C5909 a_23437_4687# VSS 1.08156f ; **FLOATING
C5910 a_22873_4687# VSS 0.56613f ; **FLOATING
C5911 a_22243_4687# VSS 0.46741f ; **FLOATING
C5912 a_22677_4687# VSS 0.88578f ; **FLOATING
C5913 a_22113_4687# VSS 0.4435f ; **FLOATING
C5914 a_21483_4687# VSS 0.4875f ; **FLOATING
C5915 a_21917_4687# VSS 0.95287f ; **FLOATING
C5916 a_21353_4687# VSS 0.44138f ; **FLOATING
C5917 a_20723_4687# VSS 0.48671f ; **FLOATING
C5918 a_21157_4687# VSS 0.91814f ; **FLOATING
C5919 a_20593_4687# VSS 0.44348f ; **FLOATING
C5920 a_19963_4687# VSS 0.48774f ; **FLOATING
C5921 a_20397_4687# VSS 0.95122f ; **FLOATING
C5922 a_19833_4687# VSS 0.44619f ; **FLOATING
C5923 a_19203_4687# VSS 0.48565f ; **FLOATING
C5924 a_19637_4687# VSS 0.86086f ; **FLOATING
C5925 a_19073_4687# VSS 0.44414f ; **FLOATING
C5926 a_18443_4687# VSS 0.48744f ; **FLOATING
C5927 a_18877_4687# VSS 0.95513f ; **FLOATING
C5928 a_18313_4687# VSS 0.44059f ; **FLOATING
C5929 a_17683_4687# VSS 0.48671f ; **FLOATING
C5930 a_18117_4687# VSS 0.91534f ; **FLOATING
C5931 a_17553_4687# VSS 0.44348f ; **FLOATING
C5932 a_16923_4687# VSS 0.4899f ; **FLOATING
C5933 a_17357_4687# VSS 0.95204f ; **FLOATING
C5934 a_16793_4687# VSS 0.44447f ; **FLOATING
C5935 a_16163_4687# VSS 0.48792f ; **FLOATING
C5936 a_16597_4687# VSS 0.85706f ; **FLOATING
C5937 a_16033_4687# VSS 0.4368f ; **FLOATING
C5938 a_15403_4687# VSS 0.48909f ; **FLOATING
C5939 a_15837_4687# VSS 0.94699f ; **FLOATING
C5940 a_15273_4687# VSS 0.44136f ; **FLOATING
C5941 a_14643_4687# VSS 0.48674f ; **FLOATING
C5942 a_15077_4687# VSS 0.91638f ; **FLOATING
C5943 a_14513_4687# VSS 0.44355f ; **FLOATING
C5944 a_13883_4687# VSS 0.48786f ; **FLOATING
C5945 a_14317_4687# VSS 0.95143f ; **FLOATING
C5946 a_13753_4687# VSS 0.44737f ; **FLOATING
C5947 a_13123_4687# VSS 0.94748f ; **FLOATING
C5948 a_13557_4687# VSS 0.93399f ; **FLOATING
C5949 a_12993_4687# VSS 0.56321f ; **FLOATING
C5950 a_12363_4687# VSS 0.46822f ; **FLOATING
C5951 a_12797_4687# VSS 1.11192f ; **FLOATING
C5952 a_12233_4687# VSS 0.4374f ; **FLOATING
C5953 a_11603_4687# VSS 0.48677f ; **FLOATING
C5954 a_12037_4687# VSS 0.91827f ; **FLOATING
C5955 a_11473_4687# VSS 0.4435f ; **FLOATING
C5956 a_10843_4687# VSS 0.48774f ; **FLOATING
C5957 a_11277_4687# VSS 0.95122f ; **FLOATING
C5958 a_10713_4687# VSS 0.44619f ; **FLOATING
C5959 a_10083_4687# VSS 0.48563f ; **FLOATING
C5960 a_10517_4687# VSS 0.86086f ; **FLOATING
C5961 a_9953_4687# VSS 0.44414f ; **FLOATING
C5962 a_9323_4687# VSS 0.48744f ; **FLOATING
C5963 a_9757_4687# VSS 0.95346f ; **FLOATING
C5964 a_9193_4687# VSS 0.44136f ; **FLOATING
C5965 a_8563_4687# VSS 0.48671f ; **FLOATING
C5966 a_8997_4687# VSS 0.91814f ; **FLOATING
C5967 a_8433_4687# VSS 0.44348f ; **FLOATING
C5968 a_7803_4687# VSS 0.48774f ; **FLOATING
C5969 a_8237_4687# VSS 0.95122f ; **FLOATING
C5970 a_7673_4687# VSS 0.44619f ; **FLOATING
C5971 a_7043_4687# VSS 0.48563f ; **FLOATING
C5972 a_7477_4687# VSS 0.86086f ; **FLOATING
C5973 a_6913_4687# VSS 0.44414f ; **FLOATING
C5974 a_6283_4687# VSS 0.48744f ; **FLOATING
C5975 a_6717_4687# VSS 0.95287f ; **FLOATING
C5976 a_6153_4687# VSS 0.44059f ; **FLOATING
C5977 a_5523_4687# VSS 0.48671f ; **FLOATING
C5978 a_5957_4687# VSS 0.91534f ; **FLOATING
C5979 a_5393_4687# VSS 0.44587f ; **FLOATING
C5980 a_4763_4687# VSS 0.49323f ; **FLOATING
C5981 a_5197_4687# VSS 0.95402f ; **FLOATING
C5982 a_4633_4687# VSS 0.44887f ; **FLOATING
C5983 a_4003_4687# VSS 0.57075f ; **FLOATING
C5984 a_4437_4687# VSS 0.86332f ; **FLOATING
C5985 a_26985_6209# VSS 0.17928f ; **FLOATING
C5986 a_23945_6209# VSS 0.17928f ; **FLOATING
C5987 a_20905_6209# VSS 0.17928f ; **FLOATING
C5988 a_17865_6209# VSS 0.17593f ; **FLOATING
C5989 a_16851_5999# VSS 0.37653f ; **FLOATING
C5990 a_16108_5979# VSS 2.50015f ; **FLOATING
C5991 a_15964_5979# VSS 0.17103f ; **FLOATING
C5992 a_15765_6153# VSS 0.33587f ; **FLOATING
C5993 a_14825_6209# VSS 0.17928f ; **FLOATING
C5994 a_11785_6209# VSS 0.17928f ; **FLOATING
C5995 a_8745_6209# VSS 0.17928f ; **FLOATING
C5996 a_5731_5979# VSS 2.24589f ; **FLOATING
C5997 a_5705_6209# VSS 0.17638f ; **FLOATING
C5998 a_3449_6021# VSS 0.17702f ; **FLOATING
C5999 a_2873_6021# VSS 0.18304f ; **FLOATING
C6000 a_2297_6021# VSS 0.1828f ; **FLOATING
C6001 a_1721_6021# VSS 0.1696f ; **FLOATING
C6002 a_1544_5979# VSS 0.29702f ; **FLOATING
C6003 a_1256_5979# VSS 0.78477f ; **FLOATING
C6004 a_27991_6698# VSS 0.18561f ; **FLOATING
C6005 a_27915_6734# VSS 0.10926f ; **FLOATING
C6006 a_27124_6698# VSS 0.17878f ; **FLOATING
C6007 a_27048_6734# VSS 0.12122f ; **FLOATING
C6008 a_26471_6698# VSS 0.18126f ; **FLOATING
C6009 a_26395_6734# VSS 0.11073f ; **FLOATING
C6010 a_25604_6698# VSS 0.18087f ; **FLOATING
C6011 a_25630_6734# VSS 0.33072f ; **FLOATING
C6012 a_25528_6734# VSS 0.12433f ; **FLOATING
C6013 a_24951_6698# VSS 0.18335f ; **FLOATING
C6014 a_24875_6734# VSS 0.11016f ; **FLOATING
C6015 a_24084_6698# VSS 0.17878f ; **FLOATING
C6016 a_24008_6734# VSS 0.12122f ; **FLOATING
C6017 a_23431_6698# VSS 0.18132f ; **FLOATING
C6018 a_23355_6734# VSS 0.11566f ; **FLOATING
C6019 a_22564_6698# VSS 0.18087f ; **FLOATING
C6020 a_22590_6734# VSS 0.34383f ; **FLOATING
C6021 a_22488_6734# VSS 0.12433f ; **FLOATING
C6022 a_21911_6698# VSS 0.18335f ; **FLOATING
C6023 a_21835_6734# VSS 0.11016f ; **FLOATING
C6024 a_21044_6698# VSS 0.17878f ; **FLOATING
C6025 a_20968_6734# VSS 0.12122f ; **FLOATING
C6026 a_20391_6698# VSS 0.18126f ; **FLOATING
C6027 a_20315_6734# VSS 0.11073f ; **FLOATING
C6028 a_19524_6698# VSS 0.18087f ; **FLOATING
C6029 a_19550_6734# VSS 0.33343f ; **FLOATING
C6030 a_19448_6734# VSS 0.12433f ; **FLOATING
C6031 a_18871_6698# VSS 0.18335f ; **FLOATING
C6032 a_18795_6734# VSS 0.11016f ; **FLOATING
C6033 a_18004_6698# VSS 0.17878f ; **FLOATING
C6034 a_17928_6734# VSS 0.12122f ; **FLOATING
C6035 a_17351_6698# VSS 0.17877f ; **FLOATING
C6036 a_17275_6734# VSS 0.10926f ; **FLOATING
C6037 a_16484_6698# VSS 0.17947f ; **FLOATING
C6038 a_16510_6734# VSS 0.28935f ; **FLOATING
C6039 a_16408_6734# VSS 0.1229f ; **FLOATING
C6040 a_15831_6698# VSS 0.17846f ; **FLOATING
C6041 a_15755_6734# VSS 0.10926f ; **FLOATING
C6042 a_14964_6698# VSS 0.17878f ; **FLOATING
C6043 a_14888_6734# VSS 0.12122f ; **FLOATING
C6044 a_14311_6698# VSS 0.18126f ; **FLOATING
C6045 a_14235_6734# VSS 0.11073f ; **FLOATING
C6046 a_13444_6698# VSS 0.18205f ; **FLOATING
C6047 a_13470_6734# VSS 0.30999f ; **FLOATING
C6048 a_13368_6734# VSS 0.13246f ; **FLOATING
C6049 a_12791_6698# VSS 0.18335f ; **FLOATING
C6050 a_12715_6734# VSS 0.11016f ; **FLOATING
C6051 a_11924_6698# VSS 0.17878f ; **FLOATING
C6052 a_11848_6734# VSS 0.12122f ; **FLOATING
C6053 a_11271_6698# VSS 0.18126f ; **FLOATING
C6054 a_11195_6734# VSS 0.11073f ; **FLOATING
C6055 a_10404_6698# VSS 0.18087f ; **FLOATING
C6056 a_10430_6734# VSS 0.30746f ; **FLOATING
C6057 a_10328_6734# VSS 0.12433f ; **FLOATING
C6058 a_9751_6698# VSS 0.18335f ; **FLOATING
C6059 a_9675_6734# VSS 0.11016f ; **FLOATING
C6060 a_8884_6698# VSS 0.17878f ; **FLOATING
C6061 a_8808_6734# VSS 0.12122f ; **FLOATING
C6062 a_8231_6698# VSS 0.18126f ; **FLOATING
C6063 a_8155_6734# VSS 0.11073f ; **FLOATING
C6064 a_7364_6698# VSS 0.18087f ; **FLOATING
C6065 a_7390_6734# VSS 0.31357f ; **FLOATING
C6066 a_7288_6734# VSS 0.12433f ; **FLOATING
C6067 a_6711_6698# VSS 0.18335f ; **FLOATING
C6068 a_6635_6734# VSS 0.11016f ; **FLOATING
C6069 a_5844_6698# VSS 0.17878f ; **FLOATING
C6070 a_5768_6734# VSS 0.12122f ; **FLOATING
C6071 a_5191_6698# VSS 0.17877f ; **FLOATING
C6072 a_5115_6734# VSS 0.10926f ; **FLOATING
C6073 a_4324_6698# VSS 0.17947f ; **FLOATING
C6074 a_4350_6734# VSS 0.26655f ; **FLOATING
C6075 a_4248_6734# VSS 0.12443f ; **FLOATING
C6076 a_27705_6734# VSS 0.25231f ; **FLOATING
C6077 a_26185_6734# VSS 0.23475f ; **FLOATING
C6078 a_24665_6734# VSS 0.25433f ; **FLOATING
C6079 a_23145_6734# VSS 0.24629f ; **FLOATING
C6080 a_21625_6734# VSS 0.25433f ; **FLOATING
C6081 a_20105_6734# VSS 0.23475f ; **FLOATING
C6082 a_18585_6734# VSS 0.25433f ; **FLOATING
C6083 a_17065_6734# VSS 0.23378f ; **FLOATING
C6084 a_15545_6734# VSS 0.25231f ; **FLOATING
C6085 a_14025_6734# VSS 0.23475f ; **FLOATING
C6086 a_12505_6734# VSS 0.25433f ; **FLOATING
C6087 a_10985_6734# VSS 0.23475f ; **FLOATING
C6088 a_9465_6734# VSS 0.25433f ; **FLOATING
C6089 a_7945_6734# VSS 0.23475f ; **FLOATING
C6090 a_6425_6734# VSS 0.25433f ; **FLOATING
C6091 a_4905_6734# VSS 0.23483f ; **FLOATING
C6092 a_4157_7003# VSS 0.32839f ; **FLOATING
C6093 a_3449_7085# VSS 0.18629f ; **FLOATING
C6094 a_2873_7085# VSS 0.18398f ; **FLOATING
C6095 a_2297_7085# VSS 0.18349f ; **FLOATING
C6096 a_1721_7085# VSS 0.17029f ; **FLOATING
C6097 a_1544_6734# VSS 0.29829f ; **FLOATING
C6098 a_1256_6734# VSS 0.80827f ; **FLOATING
C6099 a_27671_7532# VSS 0.01336f ; **FLOATING
C6100 a_26911_7532# VSS 0.01336f ; **FLOATING
C6101 a_26151_7532# VSS 0.01336f ; **FLOATING
C6102 a_25391_7532# VSS 0.01336f ; **FLOATING
C6103 a_24631_7532# VSS 0.01336f ; **FLOATING
C6104 a_23871_7532# VSS 0.01336f ; **FLOATING
C6105 a_23111_7532# VSS 0.01733f ; **FLOATING
C6106 a_22351_7532# VSS 0.01336f ; **FLOATING
C6107 a_21591_7532# VSS 0.01336f ; **FLOATING
C6108 a_20831_7532# VSS 0.01336f ; **FLOATING
C6109 a_20071_7532# VSS 0.01336f ; **FLOATING
C6110 a_19311_7532# VSS 0.01336f ; **FLOATING
C6111 a_18551_7532# VSS 0.01336f ; **FLOATING
C6112 a_17791_7532# VSS 0.01336f ; **FLOATING
C6113 a_17031_7532# VSS 0.01336f ; **FLOATING
C6114 a_16271_7532# VSS 0.01336f ; **FLOATING
C6115 a_15511_7532# VSS 0.01336f ; **FLOATING
C6116 a_14751_7532# VSS 0.01336f ; **FLOATING
C6117 a_13991_7532# VSS 0.01336f ; **FLOATING
C6118 a_13231_7532# VSS 0.01733f ; **FLOATING
C6119 a_12471_7532# VSS 0.01336f ; **FLOATING
C6120 a_11711_7532# VSS 0.01336f ; **FLOATING
C6121 a_10951_7532# VSS 0.01336f ; **FLOATING
C6122 a_10191_7532# VSS 0.01336f ; **FLOATING
C6123 a_9431_7532# VSS 0.01336f ; **FLOATING
C6124 a_8671_7532# VSS 0.01336f ; **FLOATING
C6125 a_7911_7532# VSS 0.01336f ; **FLOATING
C6126 a_7151_7532# VSS 0.01336f ; **FLOATING
C6127 a_6391_7532# VSS 0.01336f ; **FLOATING
C6128 a_5631_7532# VSS 0.01336f ; **FLOATING
C6129 a_4871_7532# VSS 0.01336f ; **FLOATING
C6130 a_4111_7532# VSS 0.0139f ; **FLOATING
C6131 a_27563_7532# VSS 0.50316f ; **FLOATING
C6132 a_27997_7532# VSS 0.6484f ; **FLOATING
C6133 a_27433_7532# VSS 0.4463f ; **FLOATING
C6134 a_26803_7532# VSS 0.49934f ; **FLOATING
C6135 a_27237_7532# VSS 0.92787f ; **FLOATING
C6136 a_26673_7532# VSS 0.4492f ; **FLOATING
C6137 a_26043_7532# VSS 0.50169f ; **FLOATING
C6138 a_26477_7532# VSS 0.9592f ; **FLOATING
C6139 a_25913_7532# VSS 0.4508f ; **FLOATING
C6140 a_25283_7532# VSS 0.49938f ; **FLOATING
C6141 a_25717_7532# VSS 0.86809f ; **FLOATING
C6142 a_25153_7532# VSS 0.45037f ; **FLOATING
C6143 a_24523_7532# VSS 0.50078f ; **FLOATING
C6144 a_24957_7532# VSS 0.96347f ; **FLOATING
C6145 a_24393_7532# VSS 0.44639f ; **FLOATING
C6146 a_23763_7532# VSS 0.49951f ; **FLOATING
C6147 a_24197_7532# VSS 0.92487f ; **FLOATING
C6148 a_23633_7532# VSS 0.45419f ; **FLOATING
C6149 a_23003_7532# VSS 0.96254f ; **FLOATING
C6150 a_23437_7532# VSS 1.07504f ; **FLOATING
C6151 a_22873_7532# VSS 0.57074f ; **FLOATING
C6152 a_22243_7532# VSS 0.47049f ; **FLOATING
C6153 a_22677_7532# VSS 0.88675f ; **FLOATING
C6154 a_22113_7532# VSS 0.45185f ; **FLOATING
C6155 a_21483_7532# VSS 0.50081f ; **FLOATING
C6156 a_21917_7532# VSS 0.96116f ; **FLOATING
C6157 a_21353_7532# VSS 0.44632f ; **FLOATING
C6158 a_20723_7532# VSS 0.49992f ; **FLOATING
C6159 a_21157_7532# VSS 0.92429f ; **FLOATING
C6160 a_20593_7532# VSS 0.45196f ; **FLOATING
C6161 a_19963_7532# VSS 0.50169f ; **FLOATING
C6162 a_20397_7532# VSS 0.95761f ; **FLOATING
C6163 a_19833_7532# VSS 0.4508f ; **FLOATING
C6164 a_19203_7532# VSS 0.5005f ; **FLOATING
C6165 a_19637_7532# VSS 0.86809f ; **FLOATING
C6166 a_19073_7532# VSS 0.44947f ; **FLOATING
C6167 a_18443_7532# VSS 0.50075f ; **FLOATING
C6168 a_18877_7532# VSS 0.96341f ; **FLOATING
C6169 a_18313_7532# VSS 0.4463f ; **FLOATING
C6170 a_17683_7532# VSS 0.50046f ; **FLOATING
C6171 a_18117_7532# VSS 0.92429f ; **FLOATING
C6172 a_17553_7532# VSS 0.44782f ; **FLOATING
C6173 a_16923_7532# VSS 0.50165f ; **FLOATING
C6174 a_17357_7532# VSS 0.95761f ; **FLOATING
C6175 a_16793_7532# VSS 0.45049f ; **FLOATING
C6176 a_16163_7532# VSS 0.4946f ; **FLOATING
C6177 a_16597_7532# VSS 0.86295f ; **FLOATING
C6178 a_16033_7532# VSS 0.44618f ; **FLOATING
C6179 a_15403_7532# VSS 0.49465f ; **FLOATING
C6180 a_15837_7532# VSS 0.95171f ; **FLOATING
C6181 a_15273_7532# VSS 0.44439f ; **FLOATING
C6182 a_14643_7532# VSS 0.49308f ; **FLOATING
C6183 a_15077_7532# VSS 0.9194f ; **FLOATING
C6184 a_14513_7532# VSS 0.44508f ; **FLOATING
C6185 a_13883_7532# VSS 0.50873f ; **FLOATING
C6186 a_14317_7532# VSS 0.96022f ; **FLOATING
C6187 a_13753_7532# VSS 0.46545f ; **FLOATING
C6188 a_13123_7532# VSS 0.94424f ; **FLOATING
C6189 a_13557_7532# VSS 0.94034f ; **FLOATING
C6190 a_12993_7532# VSS 0.57373f ; **FLOATING
C6191 a_12363_7532# VSS 0.47063f ; **FLOATING
C6192 a_12797_7532# VSS 1.11988f ; **FLOATING
C6193 a_12233_7532# VSS 0.44855f ; **FLOATING
C6194 a_11603_7532# VSS 0.50273f ; **FLOATING
C6195 a_12037_7532# VSS 0.92765f ; **FLOATING
C6196 a_11473_7532# VSS 0.45178f ; **FLOATING
C6197 a_10843_7532# VSS 0.50491f ; **FLOATING
C6198 a_11277_7532# VSS 0.96044f ; **FLOATING
C6199 a_10713_7532# VSS 0.44901f ; **FLOATING
C6200 a_10083_7532# VSS 0.50223f ; **FLOATING
C6201 a_10517_7532# VSS 0.87021f ; **FLOATING
C6202 a_9953_7532# VSS 0.44673f ; **FLOATING
C6203 a_9323_7532# VSS 0.5026f ; **FLOATING
C6204 a_9757_7532# VSS 0.96312f ; **FLOATING
C6205 a_9193_7532# VSS 0.44361f ; **FLOATING
C6206 a_8563_7532# VSS 0.49203f ; **FLOATING
C6207 a_8997_7532# VSS 0.92083f ; **FLOATING
C6208 a_8433_7532# VSS 0.44439f ; **FLOATING
C6209 a_7803_7532# VSS 0.49435f ; **FLOATING
C6210 a_8237_7532# VSS 0.95413f ; **FLOATING
C6211 a_7673_7532# VSS 0.44737f ; **FLOATING
C6212 a_7043_7532# VSS 0.49204f ; **FLOATING
C6213 a_7477_7532# VSS 0.86461f ; **FLOATING
C6214 a_6913_7532# VSS 0.44442f ; **FLOATING
C6215 a_6283_7532# VSS 0.49343f ; **FLOATING
C6216 a_6717_7532# VSS 0.95763f ; **FLOATING
C6217 a_6153_7532# VSS 0.44292f ; **FLOATING
C6218 a_5523_7532# VSS 0.50322f ; **FLOATING
C6219 a_5957_7532# VSS 0.92533f ; **FLOATING
C6220 a_5393_7532# VSS 0.4596f ; **FLOATING
C6221 a_4763_7532# VSS 0.51043f ; **FLOATING
C6222 a_5197_7532# VSS 0.96501f ; **FLOATING
C6223 a_4633_7532# VSS 0.46287f ; **FLOATING
C6224 a_4003_7532# VSS 0.58817f ; **FLOATING
C6225 a_4437_7532# VSS 0.87463f ; **FLOATING
C6226 a_9712_9602# VSS 1.28186f ; **FLOATING
C6227 a_9444_9602# VSS 2.12877f ; **FLOATING
C6228 a_5778_9057# VSS 5.22809f ; **FLOATING
C6229 a_15464_9374# VSS 0.75391f ; **FLOATING
C6230 a_14757_10872# VSS 0.09495f ; **FLOATING
C6231 a_13880_10808# VSS 0.06985f ; **FLOATING
C6232 a_15688_11093# VSS 0.26291f ; **FLOATING
C6233 a_15108_11015# VSS 0.24458f ; **FLOATING
C6234 a_14851_10872# VSS 0.38123f ; **FLOATING
C6235 a_9444_10280# VSS 6.03808f ; **FLOATING
C6236 a_14111_10917# VSS 0.19866f ; **FLOATING
C6237 a_14009_10774# VSS 0.44622f ; **FLOATING
C6238 a_13592_11113# VSS 1.58592f ; **FLOATING
C6239 a_13306_10795# VSS 0.30789f ; **FLOATING
C6240 a_13566_11018# VSS 0.16043f ; **FLOATING
C6241 a_13132_11110# VSS 0.14297f ; **FLOATING
C6242 a_12907_11110# VSS 0.14389f ; **FLOATING
C6243 a_12907_10876# VSS 0.14787f ; **FLOATING
C6244 a_13106_11047# VSS 0.07197f ; **FLOATING
C6245 a_15304_10295# VSS 0.32076f ; **FLOATING
C6246 a_14757_11918# VSS 0.09586f ; **FLOATING
C6247 a_15688_11557# VSS 0.26296f ; **FLOATING
C6248 a_14851_11918# VSS 0.39011f ; **FLOATING
C6249 a_15108_11799# VSS 0.24509f ; **FLOATING
C6250 a_14111_11568# VSS 0.21578f ; **FLOATING
C6251 a_13880_11982# VSS 0.07345f ; **FLOATING
C6252 a_14009_11568# VSS 0.46644f ; **FLOATING
C6253 a_13592_11561# VSS 1.58509f ; **FLOATING
C6254 a_13566_11525# VSS 0.15697f ; **FLOATING
C6255 a_13045_11905# VSS 0.01124f ; **FLOATING
C6256 a_13306_11995# VSS 0.32576f ; **FLOATING
C6257 a_12849_11557# VSS 1.39731f ; **FLOATING
C6258 a_13121_11521# VSS 0.77678f ; **FLOATING
C6259 a_13019_11521# VSS 2.13147f ; **FLOATING
C6260 a_12656_11554# VSS 0.28138f ; **FLOATING
C6261 a_12355_11557# VSS 0.54826f ; **FLOATING
C6262 a_11397_11918# VSS 0.09495f ; **FLOATING
C6263 a_12158_11557# VSS 0.25842f ; **FLOATING
C6264 a_11491_11918# VSS 0.29538f ; **FLOATING
C6265 a_11748_11799# VSS 0.16909f ; **FLOATING
C6266 a_10751_11568# VSS 0.1982f ; **FLOATING
C6267 a_10520_11982# VSS 0.03671f ; **FLOATING
C6268 a_10649_11568# VSS 0.46311f ; **FLOATING
C6269 a_10232_11561# VSS 1.51871f ; **FLOATING
C6270 a_10206_11525# VSS 0.08466f ; **FLOATING
C6271 a_9946_11995# VSS 0.18126f ; **FLOATING
C6272 a_9772_11533# VSS 0.12311f ; **FLOATING
C6273 a_9746_11495# VSS 0.06443f ; **FLOATING
C6274 a_9547_11862# VSS 0.15766f ; **FLOATING
C6275 a_9547_11632# VSS 0.11843f ; **FLOATING
C6276 a_6854_11144# VSS 3.39622f ; **FLOATING
C6277 a_6126_9506# VSS 13.5861f ; **FLOATING
C6278 a_6854_11676# VSS 1.6692f ; **FLOATING
C6279 a_5974_11413# VSS 2.38934f ; **FLOATING
C6280 a_6326_10280# VSS 0.86042f ; **FLOATING
C6281 a_26985_12701# VSS 0.17928f ; **FLOATING
C6282 a_23945_12701# VSS 0.17928f ; **FLOATING
C6283 a_20905_12701# VSS 0.17928f ; **FLOATING
C6284 a_17865_12701# VSS 0.17593f ; **FLOATING
C6285 a_16851_12491# VSS 0.3805f ; **FLOATING
C6286 a_16108_12471# VSS 3.17402f ; **FLOATING
C6287 a_15964_12471# VSS 0.17235f ; **FLOATING
C6288 a_15765_12645# VSS 0.34456f ; **FLOATING
C6289 a_14825_12701# VSS 0.17928f ; **FLOATING
C6290 a_11785_12701# VSS 0.17928f ; **FLOATING
C6291 a_8745_12701# VSS 0.17928f ; **FLOATING
C6292 a_5731_12471# VSS 2.6668f ; **FLOATING
C6293 a_5705_12701# VSS 0.17638f ; **FLOATING
C6294 a_3449_12513# VSS 0.18479f ; **FLOATING
C6295 a_2873_12513# VSS 0.18346f ; **FLOATING
C6296 a_2297_12513# VSS 0.18322f ; **FLOATING
C6297 a_1721_12513# VSS 0.17002f ; **FLOATING
C6298 a_1544_12471# VSS 0.29837f ; **FLOATING
C6299 a_1256_12471# VSS 0.79413f ; **FLOATING
C6300 a_27991_13190# VSS 0.18558f ; **FLOATING
C6301 a_27915_13226# VSS 0.10926f ; **FLOATING
C6302 a_27124_13190# VSS 0.17878f ; **FLOATING
C6303 a_27048_13226# VSS 0.12122f ; **FLOATING
C6304 a_26471_13190# VSS 0.18115f ; **FLOATING
C6305 a_26395_13226# VSS 0.11073f ; **FLOATING
C6306 a_25604_13190# VSS 0.18087f ; **FLOATING
C6307 a_25630_13226# VSS 0.3653f ; **FLOATING
C6308 a_25528_13226# VSS 0.12433f ; **FLOATING
C6309 a_24951_13190# VSS 0.18335f ; **FLOATING
C6310 a_24875_13226# VSS 0.11016f ; **FLOATING
C6311 a_24084_13190# VSS 0.17878f ; **FLOATING
C6312 a_24008_13226# VSS 0.12122f ; **FLOATING
C6313 a_23431_13190# VSS 0.18111f ; **FLOATING
C6314 a_23355_13226# VSS 0.11566f ; **FLOATING
C6315 a_22564_13190# VSS 0.18087f ; **FLOATING
C6316 a_22590_13226# VSS 0.34383f ; **FLOATING
C6317 a_22488_13226# VSS 0.12433f ; **FLOATING
C6318 a_21911_13190# VSS 0.18335f ; **FLOATING
C6319 a_21835_13226# VSS 0.11016f ; **FLOATING
C6320 a_21044_13190# VSS 0.17878f ; **FLOATING
C6321 a_20968_13226# VSS 0.12122f ; **FLOATING
C6322 a_20391_13190# VSS 0.18104f ; **FLOATING
C6323 a_20315_13226# VSS 0.11073f ; **FLOATING
C6324 a_19524_13190# VSS 0.18087f ; **FLOATING
C6325 a_19550_13226# VSS 0.33343f ; **FLOATING
C6326 a_19448_13226# VSS 0.12433f ; **FLOATING
C6327 a_18871_13190# VSS 0.18335f ; **FLOATING
C6328 a_18795_13226# VSS 0.11016f ; **FLOATING
C6329 a_18004_13190# VSS 0.17878f ; **FLOATING
C6330 a_17928_13226# VSS 0.12122f ; **FLOATING
C6331 a_17351_13190# VSS 0.17808f ; **FLOATING
C6332 a_17275_13226# VSS 0.10926f ; **FLOATING
C6333 a_16484_13190# VSS 0.17809f ; **FLOATING
C6334 a_16510_13226# VSS 0.28935f ; **FLOATING
C6335 a_16408_13226# VSS 0.1229f ; **FLOATING
C6336 a_15831_13190# VSS 0.17846f ; **FLOATING
C6337 a_15755_13226# VSS 0.10926f ; **FLOATING
C6338 a_14964_13190# VSS 0.17878f ; **FLOATING
C6339 a_14888_13226# VSS 0.12122f ; **FLOATING
C6340 a_14311_13190# VSS 0.18138f ; **FLOATING
C6341 a_14235_13226# VSS 0.11073f ; **FLOATING
C6342 a_13444_13190# VSS 0.18205f ; **FLOATING
C6343 a_13470_13226# VSS 0.30999f ; **FLOATING
C6344 a_13368_13226# VSS 0.13246f ; **FLOATING
C6345 a_12791_13190# VSS 0.18335f ; **FLOATING
C6346 a_12715_13226# VSS 0.11016f ; **FLOATING
C6347 a_11924_13190# VSS 0.17878f ; **FLOATING
C6348 a_11848_13226# VSS 0.12122f ; **FLOATING
C6349 a_11271_13190# VSS 0.18178f ; **FLOATING
C6350 a_11195_13226# VSS 0.11073f ; **FLOATING
C6351 a_10404_13190# VSS 0.18087f ; **FLOATING
C6352 a_10430_13226# VSS 0.30746f ; **FLOATING
C6353 a_10328_13226# VSS 0.12433f ; **FLOATING
C6354 a_9751_13190# VSS 0.18335f ; **FLOATING
C6355 a_9675_13226# VSS 0.11016f ; **FLOATING
C6356 a_8884_13190# VSS 0.17878f ; **FLOATING
C6357 a_8808_13226# VSS 0.12122f ; **FLOATING
C6358 a_8231_13190# VSS 0.1809f ; **FLOATING
C6359 a_8155_13226# VSS 0.11073f ; **FLOATING
C6360 a_7364_13190# VSS 0.18087f ; **FLOATING
C6361 a_7390_13226# VSS 0.31357f ; **FLOATING
C6362 a_7288_13226# VSS 0.12433f ; **FLOATING
C6363 a_6711_13190# VSS 0.18335f ; **FLOATING
C6364 a_6635_13226# VSS 0.11016f ; **FLOATING
C6365 a_5844_13190# VSS 0.17878f ; **FLOATING
C6366 a_5768_13226# VSS 0.12122f ; **FLOATING
C6367 a_5191_13190# VSS 0.18022f ; **FLOATING
C6368 a_5115_13226# VSS 0.10926f ; **FLOATING
C6369 a_4324_13190# VSS 0.18023f ; **FLOATING
C6370 a_4350_13226# VSS 0.26655f ; **FLOATING
C6371 a_4248_13226# VSS 0.12443f ; **FLOATING
C6372 a_27705_13226# VSS 0.25204f ; **FLOATING
C6373 a_26185_13226# VSS 0.23475f ; **FLOATING
C6374 a_24665_13226# VSS 0.25405f ; **FLOATING
C6375 a_23145_13226# VSS 0.24628f ; **FLOATING
C6376 a_21625_13226# VSS 0.25405f ; **FLOATING
C6377 a_20105_13226# VSS 0.23475f ; **FLOATING
C6378 a_18585_13226# VSS 0.25405f ; **FLOATING
C6379 a_17065_13226# VSS 0.23373f ; **FLOATING
C6380 a_15545_13226# VSS 0.25216f ; **FLOATING
C6381 a_14025_13226# VSS 0.23475f ; **FLOATING
C6382 a_12505_13226# VSS 0.25405f ; **FLOATING
C6383 a_10985_13226# VSS 0.23475f ; **FLOATING
C6384 a_9465_13226# VSS 0.25405f ; **FLOATING
C6385 a_7945_13226# VSS 0.23475f ; **FLOATING
C6386 a_6425_13226# VSS 0.25405f ; **FLOATING
C6387 a_4905_13226# VSS 0.2355f ; **FLOATING
C6388 a_4157_13495# VSS 0.32875f ; **FLOATING
C6389 a_3449_13577# VSS 0.18619f ; **FLOATING
C6390 a_2873_13577# VSS 0.18345f ; **FLOATING
C6391 a_2297_13577# VSS 0.18296f ; **FLOATING
C6392 a_1721_13577# VSS 0.16976f ; **FLOATING
C6393 a_1544_13226# VSS 0.29775f ; **FLOATING
C6394 a_1256_13226# VSS 0.80175f ; **FLOATING
C6395 a_27671_14024# VSS 0.01336f ; **FLOATING
C6396 a_26911_14024# VSS 0.01336f ; **FLOATING
C6397 a_26151_14024# VSS 0.01336f ; **FLOATING
C6398 a_25391_14024# VSS 0.01336f ; **FLOATING
C6399 a_24631_14024# VSS 0.01336f ; **FLOATING
C6400 a_23871_14024# VSS 0.01336f ; **FLOATING
C6401 a_23111_14024# VSS 0.01733f ; **FLOATING
C6402 a_22351_14024# VSS 0.01336f ; **FLOATING
C6403 a_21591_14024# VSS 0.01336f ; **FLOATING
C6404 a_20831_14024# VSS 0.01336f ; **FLOATING
C6405 a_20071_14024# VSS 0.01336f ; **FLOATING
C6406 a_19311_14024# VSS 0.01336f ; **FLOATING
C6407 a_18551_14024# VSS 0.01336f ; **FLOATING
C6408 a_17791_14024# VSS 0.01336f ; **FLOATING
C6409 a_17031_14024# VSS 0.01336f ; **FLOATING
C6410 a_16271_14024# VSS 0.01336f ; **FLOATING
C6411 a_15511_14024# VSS 0.01336f ; **FLOATING
C6412 a_14751_14024# VSS 0.01336f ; **FLOATING
C6413 a_13991_14024# VSS 0.01336f ; **FLOATING
C6414 a_13231_14024# VSS 0.01733f ; **FLOATING
C6415 a_12471_14024# VSS 0.01336f ; **FLOATING
C6416 a_11711_14024# VSS 0.01336f ; **FLOATING
C6417 a_10951_14024# VSS 0.01336f ; **FLOATING
C6418 a_10191_14024# VSS 0.01336f ; **FLOATING
C6419 a_9431_14024# VSS 0.01336f ; **FLOATING
C6420 a_8671_14024# VSS 0.01336f ; **FLOATING
C6421 a_7911_14024# VSS 0.01336f ; **FLOATING
C6422 a_7151_14024# VSS 0.01336f ; **FLOATING
C6423 a_6391_14024# VSS 0.01336f ; **FLOATING
C6424 a_5631_14024# VSS 0.01336f ; **FLOATING
C6425 a_4871_14024# VSS 0.01336f ; **FLOATING
C6426 a_4111_14024# VSS 0.0139f ; **FLOATING
C6427 a_27563_14024# VSS 0.49473f ; **FLOATING
C6428 a_27997_14024# VSS 0.64441f ; **FLOATING
C6429 a_27433_14024# VSS 0.44435f ; **FLOATING
C6430 a_26803_14024# VSS 0.48676f ; **FLOATING
C6431 a_27237_14024# VSS 0.92245f ; **FLOATING
C6432 a_26673_14024# VSS 0.44348f ; **FLOATING
C6433 a_26043_14024# VSS 0.48774f ; **FLOATING
C6434 a_26477_14024# VSS 0.951f ; **FLOATING
C6435 a_25913_14024# VSS 0.44619f ; **FLOATING
C6436 a_25283_14024# VSS 0.48565f ; **FLOATING
C6437 a_25717_14024# VSS 0.86092f ; **FLOATING
C6438 a_25153_14024# VSS 0.44417f ; **FLOATING
C6439 a_24523_14024# VSS 0.48747f ; **FLOATING
C6440 a_24957_14024# VSS 0.95519f ; **FLOATING
C6441 a_24393_14024# VSS 0.44145f ; **FLOATING
C6442 a_23763_14024# VSS 0.48687f ; **FLOATING
C6443 a_24197_14024# VSS 0.91826f ; **FLOATING
C6444 a_23633_14024# VSS 0.44706f ; **FLOATING
C6445 a_23003_14024# VSS 0.95737f ; **FLOATING
C6446 a_23437_14024# VSS 1.08134f ; **FLOATING
C6447 a_22873_14024# VSS 0.56613f ; **FLOATING
C6448 a_22243_14024# VSS 0.46741f ; **FLOATING
C6449 a_22677_14024# VSS 0.88584f ; **FLOATING
C6450 a_22113_14024# VSS 0.4435f ; **FLOATING
C6451 a_21483_14024# VSS 0.4875f ; **FLOATING
C6452 a_21917_14024# VSS 0.95287f ; **FLOATING
C6453 a_21353_14024# VSS 0.44138f ; **FLOATING
C6454 a_20723_14024# VSS 0.48671f ; **FLOATING
C6455 a_21157_14024# VSS 0.91769f ; **FLOATING
C6456 a_20593_14024# VSS 0.44348f ; **FLOATING
C6457 a_19963_14024# VSS 0.48774f ; **FLOATING
C6458 a_20397_14024# VSS 0.951f ; **FLOATING
C6459 a_19833_14024# VSS 0.44619f ; **FLOATING
C6460 a_19203_14024# VSS 0.48565f ; **FLOATING
C6461 a_19637_14024# VSS 0.86092f ; **FLOATING
C6462 a_19073_14024# VSS 0.44414f ; **FLOATING
C6463 a_18443_14024# VSS 0.48744f ; **FLOATING
C6464 a_18877_14024# VSS 0.95513f ; **FLOATING
C6465 a_18313_14024# VSS 0.44059f ; **FLOATING
C6466 a_17683_14024# VSS 0.48671f ; **FLOATING
C6467 a_18117_14024# VSS 0.91489f ; **FLOATING
C6468 a_17553_14024# VSS 0.44348f ; **FLOATING
C6469 a_16923_14024# VSS 0.4899f ; **FLOATING
C6470 a_17357_14024# VSS 0.95217f ; **FLOATING
C6471 a_16793_14024# VSS 0.44447f ; **FLOATING
C6472 a_16163_14024# VSS 0.48792f ; **FLOATING
C6473 a_16597_14024# VSS 0.85716f ; **FLOATING
C6474 a_16033_14024# VSS 0.4368f ; **FLOATING
C6475 a_15403_14024# VSS 0.48909f ; **FLOATING
C6476 a_15837_14024# VSS 0.94699f ; **FLOATING
C6477 a_15273_14024# VSS 0.44136f ; **FLOATING
C6478 a_14643_14024# VSS 0.48674f ; **FLOATING
C6479 a_15077_14024# VSS 0.91632f ; **FLOATING
C6480 a_14513_14024# VSS 0.44355f ; **FLOATING
C6481 a_13883_14024# VSS 0.48786f ; **FLOATING
C6482 a_14317_14024# VSS 0.95153f ; **FLOATING
C6483 a_13753_14024# VSS 0.44737f ; **FLOATING
C6484 a_13123_14024# VSS 0.94748f ; **FLOATING
C6485 a_13557_14024# VSS 0.93434f ; **FLOATING
C6486 a_12993_14024# VSS 0.56321f ; **FLOATING
C6487 a_12363_14024# VSS 0.46822f ; **FLOATING
C6488 a_12797_14024# VSS 1.11192f ; **FLOATING
C6489 a_12233_14024# VSS 0.4374f ; **FLOATING
C6490 a_11603_14024# VSS 0.48677f ; **FLOATING
C6491 a_12037_14024# VSS 0.91947f ; **FLOATING
C6492 a_11473_14024# VSS 0.4435f ; **FLOATING
C6493 a_10843_14024# VSS 0.48774f ; **FLOATING
C6494 a_11277_14024# VSS 0.95129f ; **FLOATING
C6495 a_10713_14024# VSS 0.44619f ; **FLOATING
C6496 a_10083_14024# VSS 0.48563f ; **FLOATING
C6497 a_10517_14024# VSS 0.86091f ; **FLOATING
C6498 a_9953_14024# VSS 0.44414f ; **FLOATING
C6499 a_9323_14024# VSS 0.48744f ; **FLOATING
C6500 a_9757_14024# VSS 0.95346f ; **FLOATING
C6501 a_9193_14024# VSS 0.44136f ; **FLOATING
C6502 a_8563_14024# VSS 0.48671f ; **FLOATING
C6503 a_8997_14024# VSS 0.91942f ; **FLOATING
C6504 a_8433_14024# VSS 0.44348f ; **FLOATING
C6505 a_7803_14024# VSS 0.48774f ; **FLOATING
C6506 a_8237_14024# VSS 0.95094f ; **FLOATING
C6507 a_7673_14024# VSS 0.44619f ; **FLOATING
C6508 a_7043_14024# VSS 0.48563f ; **FLOATING
C6509 a_7477_14024# VSS 0.86086f ; **FLOATING
C6510 a_6913_14024# VSS 0.44414f ; **FLOATING
C6511 a_6283_14024# VSS 0.48744f ; **FLOATING
C6512 a_6717_14024# VSS 0.95287f ; **FLOATING
C6513 a_6153_14024# VSS 0.44059f ; **FLOATING
C6514 a_5523_14024# VSS 0.48671f ; **FLOATING
C6515 a_5957_14024# VSS 0.91503f ; **FLOATING
C6516 a_5393_14024# VSS 0.44587f ; **FLOATING
C6517 a_4763_14024# VSS 0.49323f ; **FLOATING
C6518 a_5197_14024# VSS 0.95411f ; **FLOATING
C6519 a_4633_14024# VSS 0.44887f ; **FLOATING
C6520 a_4003_14024# VSS 0.57075f ; **FLOATING
C6521 a_4437_14024# VSS 0.86512f ; **FLOATING
C6522 a_26985_15546# VSS 0.17928f ; **FLOATING
C6523 a_23945_15546# VSS 0.17928f ; **FLOATING
C6524 a_20905_15546# VSS 0.17928f ; **FLOATING
C6525 a_17865_15546# VSS 0.17593f ; **FLOATING
C6526 a_16851_15336# VSS 0.37653f ; **FLOATING
C6527 a_16108_15316# VSS 2.50015f ; **FLOATING
C6528 a_15964_15316# VSS 0.17103f ; **FLOATING
C6529 a_15765_15490# VSS 0.33587f ; **FLOATING
C6530 a_14825_15546# VSS 0.17928f ; **FLOATING
C6531 a_11785_15546# VSS 0.17928f ; **FLOATING
C6532 a_8745_15546# VSS 0.17928f ; **FLOATING
C6533 a_5731_15316# VSS 2.24589f ; **FLOATING
C6534 a_5705_15546# VSS 0.17638f ; **FLOATING
C6535 a_3449_15358# VSS 0.17702f ; **FLOATING
C6536 a_2873_15358# VSS 0.18304f ; **FLOATING
C6537 a_2297_15358# VSS 0.1828f ; **FLOATING
C6538 a_1721_15358# VSS 0.1696f ; **FLOATING
C6539 a_1544_15316# VSS 0.29702f ; **FLOATING
C6540 a_1256_15316# VSS 0.78477f ; **FLOATING
C6541 a_27991_16035# VSS 0.18561f ; **FLOATING
C6542 a_27915_16071# VSS 0.10926f ; **FLOATING
C6543 a_27124_16035# VSS 0.17878f ; **FLOATING
C6544 a_27048_16071# VSS 0.12122f ; **FLOATING
C6545 a_26471_16035# VSS 0.18126f ; **FLOATING
C6546 a_26395_16071# VSS 0.11073f ; **FLOATING
C6547 a_25604_16035# VSS 0.18087f ; **FLOATING
C6548 a_25630_16071# VSS 0.33072f ; **FLOATING
C6549 a_25528_16071# VSS 0.12433f ; **FLOATING
C6550 a_24951_16035# VSS 0.18335f ; **FLOATING
C6551 a_24875_16071# VSS 0.11016f ; **FLOATING
C6552 a_24084_16035# VSS 0.17878f ; **FLOATING
C6553 a_24008_16071# VSS 0.12122f ; **FLOATING
C6554 a_23431_16035# VSS 0.18132f ; **FLOATING
C6555 a_23355_16071# VSS 0.11566f ; **FLOATING
C6556 a_22564_16035# VSS 0.18087f ; **FLOATING
C6557 a_22590_16071# VSS 0.34383f ; **FLOATING
C6558 a_22488_16071# VSS 0.12433f ; **FLOATING
C6559 a_21911_16035# VSS 0.18335f ; **FLOATING
C6560 a_21835_16071# VSS 0.11016f ; **FLOATING
C6561 a_21044_16035# VSS 0.17878f ; **FLOATING
C6562 a_20968_16071# VSS 0.12122f ; **FLOATING
C6563 a_20391_16035# VSS 0.18126f ; **FLOATING
C6564 a_20315_16071# VSS 0.11073f ; **FLOATING
C6565 a_19524_16035# VSS 0.18087f ; **FLOATING
C6566 a_19550_16071# VSS 0.33343f ; **FLOATING
C6567 a_19448_16071# VSS 0.12433f ; **FLOATING
C6568 a_18871_16035# VSS 0.18335f ; **FLOATING
C6569 a_18795_16071# VSS 0.11016f ; **FLOATING
C6570 a_18004_16035# VSS 0.17878f ; **FLOATING
C6571 a_17928_16071# VSS 0.12122f ; **FLOATING
C6572 a_17351_16035# VSS 0.17877f ; **FLOATING
C6573 a_17275_16071# VSS 0.10926f ; **FLOATING
C6574 a_16484_16035# VSS 0.17947f ; **FLOATING
C6575 a_16510_16071# VSS 0.28935f ; **FLOATING
C6576 a_16408_16071# VSS 0.1229f ; **FLOATING
C6577 a_15831_16035# VSS 0.17846f ; **FLOATING
C6578 a_15755_16071# VSS 0.10926f ; **FLOATING
C6579 a_14964_16035# VSS 0.17878f ; **FLOATING
C6580 a_14888_16071# VSS 0.12122f ; **FLOATING
C6581 a_14311_16035# VSS 0.18126f ; **FLOATING
C6582 a_14235_16071# VSS 0.11073f ; **FLOATING
C6583 a_13444_16035# VSS 0.18205f ; **FLOATING
C6584 a_13470_16071# VSS 0.30999f ; **FLOATING
C6585 a_13368_16071# VSS 0.13246f ; **FLOATING
C6586 a_12791_16035# VSS 0.18335f ; **FLOATING
C6587 a_12715_16071# VSS 0.11016f ; **FLOATING
C6588 a_11924_16035# VSS 0.17878f ; **FLOATING
C6589 a_11848_16071# VSS 0.12122f ; **FLOATING
C6590 a_11271_16035# VSS 0.18126f ; **FLOATING
C6591 a_11195_16071# VSS 0.11073f ; **FLOATING
C6592 a_10404_16035# VSS 0.18087f ; **FLOATING
C6593 a_10430_16071# VSS 0.30746f ; **FLOATING
C6594 a_10328_16071# VSS 0.12433f ; **FLOATING
C6595 a_9751_16035# VSS 0.18335f ; **FLOATING
C6596 a_9675_16071# VSS 0.11016f ; **FLOATING
C6597 a_8884_16035# VSS 0.17878f ; **FLOATING
C6598 a_8808_16071# VSS 0.12122f ; **FLOATING
C6599 a_8231_16035# VSS 0.18126f ; **FLOATING
C6600 a_8155_16071# VSS 0.11073f ; **FLOATING
C6601 a_7364_16035# VSS 0.18087f ; **FLOATING
C6602 a_7390_16071# VSS 0.31357f ; **FLOATING
C6603 a_7288_16071# VSS 0.12433f ; **FLOATING
C6604 a_6711_16035# VSS 0.18335f ; **FLOATING
C6605 a_6635_16071# VSS 0.11016f ; **FLOATING
C6606 a_5844_16035# VSS 0.17878f ; **FLOATING
C6607 a_5768_16071# VSS 0.12122f ; **FLOATING
C6608 a_5191_16035# VSS 0.17877f ; **FLOATING
C6609 a_5115_16071# VSS 0.10926f ; **FLOATING
C6610 a_4324_16035# VSS 0.17947f ; **FLOATING
C6611 a_4350_16071# VSS 0.26655f ; **FLOATING
C6612 a_4248_16071# VSS 0.12443f ; **FLOATING
C6613 a_27705_16071# VSS 0.25231f ; **FLOATING
C6614 a_26185_16071# VSS 0.23475f ; **FLOATING
C6615 a_24665_16071# VSS 0.25432f ; **FLOATING
C6616 a_23145_16071# VSS 0.24628f ; **FLOATING
C6617 a_21625_16071# VSS 0.25432f ; **FLOATING
C6618 a_20105_16071# VSS 0.23475f ; **FLOATING
C6619 a_18585_16071# VSS 0.25432f ; **FLOATING
C6620 a_17065_16071# VSS 0.23378f ; **FLOATING
C6621 a_15545_16071# VSS 0.25231f ; **FLOATING
C6622 a_14025_16071# VSS 0.23475f ; **FLOATING
C6623 a_12505_16071# VSS 0.25432f ; **FLOATING
C6624 a_10985_16071# VSS 0.23475f ; **FLOATING
C6625 a_9465_16071# VSS 0.25432f ; **FLOATING
C6626 a_7945_16071# VSS 0.23475f ; **FLOATING
C6627 a_6425_16071# VSS 0.25432f ; **FLOATING
C6628 a_4905_16071# VSS 0.23483f ; **FLOATING
C6629 a_4157_16340# VSS 0.32839f ; **FLOATING
C6630 a_3449_16422# VSS 0.18629f ; **FLOATING
C6631 a_2873_16422# VSS 0.18398f ; **FLOATING
C6632 a_2297_16422# VSS 0.18349f ; **FLOATING
C6633 a_1721_16422# VSS 0.17029f ; **FLOATING
C6634 a_1544_16071# VSS 0.29829f ; **FLOATING
C6635 a_1256_16071# VSS 0.8083f ; **FLOATING
C6636 a_27671_16869# VSS 0.01336f ; **FLOATING
C6637 a_26911_16869# VSS 0.01336f ; **FLOATING
C6638 a_26151_16869# VSS 0.01336f ; **FLOATING
C6639 a_25391_16869# VSS 0.01336f ; **FLOATING
C6640 a_24631_16869# VSS 0.01336f ; **FLOATING
C6641 a_23871_16869# VSS 0.01336f ; **FLOATING
C6642 a_23111_16869# VSS 0.01733f ; **FLOATING
C6643 a_22351_16869# VSS 0.01336f ; **FLOATING
C6644 a_21591_16869# VSS 0.01336f ; **FLOATING
C6645 a_20831_16869# VSS 0.01336f ; **FLOATING
C6646 a_20071_16869# VSS 0.01336f ; **FLOATING
C6647 a_19311_16869# VSS 0.01336f ; **FLOATING
C6648 a_18551_16869# VSS 0.01336f ; **FLOATING
C6649 a_17791_16869# VSS 0.01336f ; **FLOATING
C6650 a_17031_16869# VSS 0.01336f ; **FLOATING
C6651 a_16271_16869# VSS 0.01336f ; **FLOATING
C6652 a_15511_16869# VSS 0.01336f ; **FLOATING
C6653 a_14751_16869# VSS 0.01336f ; **FLOATING
C6654 a_13991_16869# VSS 0.01336f ; **FLOATING
C6655 a_13231_16869# VSS 0.01733f ; **FLOATING
C6656 a_12471_16869# VSS 0.01336f ; **FLOATING
C6657 a_11711_16869# VSS 0.01336f ; **FLOATING
C6658 a_10951_16869# VSS 0.01336f ; **FLOATING
C6659 a_10191_16869# VSS 0.01336f ; **FLOATING
C6660 a_9431_16869# VSS 0.01336f ; **FLOATING
C6661 a_8671_16869# VSS 0.01336f ; **FLOATING
C6662 a_7911_16869# VSS 0.01336f ; **FLOATING
C6663 a_7151_16869# VSS 0.01336f ; **FLOATING
C6664 a_6391_16869# VSS 0.01336f ; **FLOATING
C6665 a_5631_16869# VSS 0.01336f ; **FLOATING
C6666 a_4871_16869# VSS 0.01336f ; **FLOATING
C6667 a_4111_16869# VSS 0.0139f ; **FLOATING
C6668 a_27563_16869# VSS 0.51284f ; **FLOATING
C6669 a_27997_16869# VSS 0.6533f ; **FLOATING
C6670 a_27433_16869# VSS 0.45843f ; **FLOATING
C6671 a_26803_16869# VSS 0.50902f ; **FLOATING
C6672 a_27237_16869# VSS 0.93566f ; **FLOATING
C6673 a_26673_16869# VSS 0.45994f ; **FLOATING
C6674 a_26043_16869# VSS 0.51137f ; **FLOATING
C6675 a_26477_16869# VSS 0.9654f ; **FLOATING
C6676 a_25913_16869# VSS 0.46292f ; **FLOATING
C6677 a_25283_16869# VSS 0.50906f ; **FLOATING
C6678 a_25717_16869# VSS 0.87587f ; **FLOATING
C6679 a_25153_16869# VSS 0.45999f ; **FLOATING
C6680 a_24523_16869# VSS 0.51046f ; **FLOATING
C6681 a_24957_16869# VSS 0.97127f ; **FLOATING
C6682 a_24393_16869# VSS 0.45852f ; **FLOATING
C6683 a_23763_16869# VSS 0.50919f ; **FLOATING
C6684 a_24197_16869# VSS 0.93266f ; **FLOATING
C6685 a_23633_16869# VSS 0.46352f ; **FLOATING
C6686 a_23003_16869# VSS 0.96973f ; **FLOATING
C6687 a_23437_16869# VSS 1.07697f ; **FLOATING
C6688 a_22873_16869# VSS 0.58286f ; **FLOATING
C6689 a_22243_16869# VSS 0.47384f ; **FLOATING
C6690 a_22677_16869# VSS 0.88959f ; **FLOATING
C6691 a_22113_16869# VSS 0.45933f ; **FLOATING
C6692 a_21483_16869# VSS 0.51049f ; **FLOATING
C6693 a_21917_16869# VSS 0.96895f ; **FLOATING
C6694 a_21353_16869# VSS 0.45845f ; **FLOATING
C6695 a_20723_16869# VSS 0.50902f ; **FLOATING
C6696 a_21157_16869# VSS 0.93209f ; **FLOATING
C6697 a_20593_16869# VSS 0.45994f ; **FLOATING
C6698 a_19963_16869# VSS 0.51137f ; **FLOATING
C6699 a_20397_16869# VSS 0.9654f ; **FLOATING
C6700 a_19833_16869# VSS 0.46292f ; **FLOATING
C6701 a_19203_16869# VSS 0.50906f ; **FLOATING
C6702 a_19637_16869# VSS 0.87587f ; **FLOATING
C6703 a_19073_16869# VSS 0.45997f ; **FLOATING
C6704 a_18443_16869# VSS 0.51043f ; **FLOATING
C6705 a_18877_16869# VSS 0.97121f ; **FLOATING
C6706 a_18313_16869# VSS 0.45843f ; **FLOATING
C6707 a_17683_16869# VSS 0.50902f ; **FLOATING
C6708 a_18117_16869# VSS 0.93209f ; **FLOATING
C6709 a_17553_16869# VSS 0.45994f ; **FLOATING
C6710 a_16923_16869# VSS 0.51133f ; **FLOATING
C6711 a_17357_16869# VSS 0.9654f ; **FLOATING
C6712 a_16793_16869# VSS 0.46262f ; **FLOATING
C6713 a_16163_16869# VSS 0.50902f ; **FLOATING
C6714 a_16597_16869# VSS 0.87073f ; **FLOATING
C6715 a_16033_16869# VSS 0.45859f ; **FLOATING
C6716 a_15403_16869# VSS 0.51041f ; **FLOATING
C6717 a_15837_16869# VSS 0.9618f ; **FLOATING
C6718 a_15273_16869# VSS 0.45843f ; **FLOATING
C6719 a_14643_16869# VSS 0.50905f ; **FLOATING
C6720 a_15077_16869# VSS 0.93033f ; **FLOATING
C6721 a_14513_16869# VSS 0.46001f ; **FLOATING
C6722 a_13883_16869# VSS 0.51149f ; **FLOATING
C6723 a_14317_16869# VSS 0.96561f ; **FLOATING
C6724 a_13753_16869# VSS 0.4641f ; **FLOATING
C6725 a_13123_16869# VSS 0.95265f ; **FLOATING
C6726 a_13557_16869# VSS 0.94065f ; **FLOATING
C6727 a_12993_16869# VSS 0.57583f ; **FLOATING
C6728 a_12363_16869# VSS 0.47043f ; **FLOATING
C6729 a_12797_16869# VSS 1.128f ; **FLOATING
C6730 a_12233_16869# VSS 0.44863f ; **FLOATING
C6731 a_11603_16869# VSS 0.50908f ; **FLOATING
C6732 a_12037_16869# VSS 0.93221f ; **FLOATING
C6733 a_11473_16869# VSS 0.45996f ; **FLOATING
C6734 a_10843_16869# VSS 0.51137f ; **FLOATING
C6735 a_11277_16869# VSS 0.9654f ; **FLOATING
C6736 a_10713_16869# VSS 0.46292f ; **FLOATING
C6737 a_10083_16869# VSS 0.50904f ; **FLOATING
C6738 a_10517_16869# VSS 0.87587f ; **FLOATING
C6739 a_9953_16869# VSS 0.45997f ; **FLOATING
C6740 a_9323_16869# VSS 0.51043f ; **FLOATING
C6741 a_9757_16869# VSS 0.96954f ; **FLOATING
C6742 a_9193_16869# VSS 0.45843f ; **FLOATING
C6743 a_8563_16869# VSS 0.50902f ; **FLOATING
C6744 a_8997_16869# VSS 0.93209f ; **FLOATING
C6745 a_8433_16869# VSS 0.45994f ; **FLOATING
C6746 a_7803_16869# VSS 0.51137f ; **FLOATING
C6747 a_8237_16869# VSS 0.9654f ; **FLOATING
C6748 a_7673_16869# VSS 0.46292f ; **FLOATING
C6749 a_7043_16869# VSS 0.50904f ; **FLOATING
C6750 a_7477_16869# VSS 0.87587f ; **FLOATING
C6751 a_6913_16869# VSS 0.45997f ; **FLOATING
C6752 a_6283_16869# VSS 0.51043f ; **FLOATING
C6753 a_6717_16869# VSS 0.96895f ; **FLOATING
C6754 a_6153_16869# VSS 0.45843f ; **FLOATING
C6755 a_5523_16869# VSS 0.50902f ; **FLOATING
C6756 a_5957_16869# VSS 0.93209f ; **FLOATING
C6757 a_5393_16869# VSS 0.45994f ; **FLOATING
C6758 a_4763_16869# VSS 0.51134f ; **FLOATING
C6759 a_5197_16869# VSS 0.96541f ; **FLOATING
C6760 a_4633_16869# VSS 0.46295f ; **FLOATING
C6761 a_4003_16869# VSS 0.58908f ; **FLOATING
C6762 a_4437_16869# VSS 0.87501f ; **FLOATING
C6763 a_4187_2434# VSS 18.3371f ; **FLOATING
C6764 a_4187_1764.t98 VSS 69.5843f ; **FLOATING
C6765 a_4187_1764.t163 VSS 0.05831f ; **FLOATING
C6766 a_4187_1764.t162 VSS 0.0566f ; **FLOATING
C6767 a_4187_1764.n0 VSS 0.13395f ; **FLOATING
C6768 a_4187_1764.t161 VSS 0.0566f ; **FLOATING
C6769 a_4187_1764.n1 VSS 0.09291f ; **FLOATING
C6770 a_4187_1764.t160 VSS 0.0566f ; **FLOATING
C6771 a_4187_1764.n2 VSS 0.09291f ; **FLOATING
C6772 a_4187_1764.t159 VSS 0.0566f ; **FLOATING
C6773 a_4187_1764.n3 VSS 0.09291f ; **FLOATING
C6774 a_4187_1764.t158 VSS 0.0566f ; **FLOATING
C6775 a_4187_1764.n4 VSS 0.09291f ; **FLOATING
C6776 a_4187_1764.t157 VSS 0.0566f ; **FLOATING
C6777 a_4187_1764.n5 VSS 0.09291f ; **FLOATING
C6778 a_4187_1764.t156 VSS 0.0566f ; **FLOATING
C6779 a_4187_1764.n6 VSS 0.09291f ; **FLOATING
C6780 a_4187_1764.t155 VSS 0.0566f ; **FLOATING
C6781 a_4187_1764.n7 VSS 0.09291f ; **FLOATING
C6782 a_4187_1764.t154 VSS 0.0566f ; **FLOATING
C6783 a_4187_1764.n8 VSS 0.09291f ; **FLOATING
C6784 a_4187_1764.t153 VSS 0.0566f ; **FLOATING
C6785 a_4187_1764.n9 VSS 0.09291f ; **FLOATING
C6786 a_4187_1764.t152 VSS 0.0566f ; **FLOATING
C6787 a_4187_1764.n10 VSS 0.09291f ; **FLOATING
C6788 a_4187_1764.t151 VSS 0.0566f ; **FLOATING
C6789 a_4187_1764.n11 VSS 0.09291f ; **FLOATING
C6790 a_4187_1764.t150 VSS 0.0566f ; **FLOATING
C6791 a_4187_1764.n12 VSS 0.09291f ; **FLOATING
C6792 a_4187_1764.t149 VSS 0.0566f ; **FLOATING
C6793 a_4187_1764.n13 VSS 0.09291f ; **FLOATING
C6794 a_4187_1764.t148 VSS 0.0566f ; **FLOATING
C6795 a_4187_1764.n14 VSS 0.09291f ; **FLOATING
C6796 a_4187_1764.t147 VSS 0.0566f ; **FLOATING
C6797 a_4187_1764.n15 VSS 0.09291f ; **FLOATING
C6798 a_4187_1764.t146 VSS 0.0566f ; **FLOATING
C6799 a_4187_1764.n16 VSS 0.09291f ; **FLOATING
C6800 a_4187_1764.t145 VSS 0.0566f ; **FLOATING
C6801 a_4187_1764.n17 VSS 0.09291f ; **FLOATING
C6802 a_4187_1764.t144 VSS 0.0566f ; **FLOATING
C6803 a_4187_1764.n18 VSS 0.09291f ; **FLOATING
C6804 a_4187_1764.t143 VSS 0.0566f ; **FLOATING
C6805 a_4187_1764.n19 VSS 0.09291f ; **FLOATING
C6806 a_4187_1764.t142 VSS 0.0566f ; **FLOATING
C6807 a_4187_1764.n20 VSS 0.09291f ; **FLOATING
C6808 a_4187_1764.t141 VSS 0.0566f ; **FLOATING
C6809 a_4187_1764.n21 VSS 0.09291f ; **FLOATING
C6810 a_4187_1764.t140 VSS 0.0566f ; **FLOATING
C6811 a_4187_1764.n22 VSS 0.09291f ; **FLOATING
C6812 a_4187_1764.t139 VSS 0.0566f ; **FLOATING
C6813 a_4187_1764.n23 VSS 0.09291f ; **FLOATING
C6814 a_4187_1764.t138 VSS 0.0566f ; **FLOATING
C6815 a_4187_1764.n24 VSS 0.09291f ; **FLOATING
C6816 a_4187_1764.t137 VSS 0.0566f ; **FLOATING
C6817 a_4187_1764.n25 VSS 0.09291f ; **FLOATING
C6818 a_4187_1764.t136 VSS 0.0566f ; **FLOATING
C6819 a_4187_1764.n26 VSS 0.09291f ; **FLOATING
C6820 a_4187_1764.t135 VSS 0.0566f ; **FLOATING
C6821 a_4187_1764.n27 VSS 0.09291f ; **FLOATING
C6822 a_4187_1764.t134 VSS 0.0566f ; **FLOATING
C6823 a_4187_1764.n28 VSS 0.09291f ; **FLOATING
C6824 a_4187_1764.t133 VSS 0.0566f ; **FLOATING
C6825 a_4187_1764.n29 VSS 0.09291f ; **FLOATING
C6826 a_4187_1764.t132 VSS 0.0566f ; **FLOATING
C6827 a_4187_1764.n30 VSS 0.22761f ; **FLOATING
C6828 a_4187_1764.t131 VSS 0.05831f ; **FLOATING
C6829 a_4187_1764.t130 VSS 0.0566f ; **FLOATING
C6830 a_4187_1764.n31 VSS 0.13395f ; **FLOATING
C6831 a_4187_1764.t129 VSS 0.0566f ; **FLOATING
C6832 a_4187_1764.n32 VSS 0.09291f ; **FLOATING
C6833 a_4187_1764.t128 VSS 0.0566f ; **FLOATING
C6834 a_4187_1764.n33 VSS 0.09291f ; **FLOATING
C6835 a_4187_1764.t127 VSS 0.0566f ; **FLOATING
C6836 a_4187_1764.n34 VSS 0.09291f ; **FLOATING
C6837 a_4187_1764.t126 VSS 0.0566f ; **FLOATING
C6838 a_4187_1764.n35 VSS 0.09291f ; **FLOATING
C6839 a_4187_1764.t125 VSS 0.0566f ; **FLOATING
C6840 a_4187_1764.n36 VSS 0.09291f ; **FLOATING
C6841 a_4187_1764.t124 VSS 0.0566f ; **FLOATING
C6842 a_4187_1764.n37 VSS 0.09291f ; **FLOATING
C6843 a_4187_1764.t123 VSS 0.0566f ; **FLOATING
C6844 a_4187_1764.n38 VSS 0.09291f ; **FLOATING
C6845 a_4187_1764.t122 VSS 0.0566f ; **FLOATING
C6846 a_4187_1764.n39 VSS 0.09291f ; **FLOATING
C6847 a_4187_1764.t121 VSS 0.0566f ; **FLOATING
C6848 a_4187_1764.n40 VSS 0.09291f ; **FLOATING
C6849 a_4187_1764.t120 VSS 0.0566f ; **FLOATING
C6850 a_4187_1764.n41 VSS 0.09291f ; **FLOATING
C6851 a_4187_1764.t119 VSS 0.0566f ; **FLOATING
C6852 a_4187_1764.n42 VSS 0.09291f ; **FLOATING
C6853 a_4187_1764.t118 VSS 0.0566f ; **FLOATING
C6854 a_4187_1764.n43 VSS 0.09291f ; **FLOATING
C6855 a_4187_1764.t117 VSS 0.0566f ; **FLOATING
C6856 a_4187_1764.n44 VSS 0.09291f ; **FLOATING
C6857 a_4187_1764.t116 VSS 0.0566f ; **FLOATING
C6858 a_4187_1764.n45 VSS 0.09291f ; **FLOATING
C6859 a_4187_1764.t115 VSS 0.0566f ; **FLOATING
C6860 a_4187_1764.n46 VSS 0.09291f ; **FLOATING
C6861 a_4187_1764.t114 VSS 0.0566f ; **FLOATING
C6862 a_4187_1764.n47 VSS 0.09291f ; **FLOATING
C6863 a_4187_1764.t113 VSS 0.0566f ; **FLOATING
C6864 a_4187_1764.n48 VSS 0.09291f ; **FLOATING
C6865 a_4187_1764.t112 VSS 0.0566f ; **FLOATING
C6866 a_4187_1764.n49 VSS 0.09291f ; **FLOATING
C6867 a_4187_1764.t111 VSS 0.0566f ; **FLOATING
C6868 a_4187_1764.n50 VSS 0.09291f ; **FLOATING
C6869 a_4187_1764.t110 VSS 0.0566f ; **FLOATING
C6870 a_4187_1764.n51 VSS 0.09291f ; **FLOATING
C6871 a_4187_1764.t109 VSS 0.0566f ; **FLOATING
C6872 a_4187_1764.n52 VSS 0.09291f ; **FLOATING
C6873 a_4187_1764.t108 VSS 0.0566f ; **FLOATING
C6874 a_4187_1764.n53 VSS 0.09291f ; **FLOATING
C6875 a_4187_1764.t107 VSS 0.0566f ; **FLOATING
C6876 a_4187_1764.n54 VSS 0.09291f ; **FLOATING
C6877 a_4187_1764.t106 VSS 0.0566f ; **FLOATING
C6878 a_4187_1764.n55 VSS 0.09291f ; **FLOATING
C6879 a_4187_1764.t105 VSS 0.0566f ; **FLOATING
C6880 a_4187_1764.n56 VSS 0.09291f ; **FLOATING
C6881 a_4187_1764.t104 VSS 0.0566f ; **FLOATING
C6882 a_4187_1764.n57 VSS 0.09291f ; **FLOATING
C6883 a_4187_1764.t103 VSS 0.0566f ; **FLOATING
C6884 a_4187_1764.n58 VSS 0.09291f ; **FLOATING
C6885 a_4187_1764.t102 VSS 0.0566f ; **FLOATING
C6886 a_4187_1764.n59 VSS 0.09291f ; **FLOATING
C6887 a_4187_1764.t101 VSS 0.0566f ; **FLOATING
C6888 a_4187_1764.n60 VSS 0.09291f ; **FLOATING
C6889 a_4187_1764.t100 VSS 0.0566f ; **FLOATING
C6890 a_4187_1764.n61 VSS 0.13955f ; **FLOATING
C6891 a_4187_1764.n62 VSS 0.60639f ; **FLOATING
C6892 a_4187_1764.t33 VSS 0.05831f ; **FLOATING
C6893 a_4187_1764.t32 VSS 0.0566f ; **FLOATING
C6894 a_4187_1764.n63 VSS 0.13395f ; **FLOATING
C6895 a_4187_1764.t31 VSS 0.0566f ; **FLOATING
C6896 a_4187_1764.n64 VSS 0.09291f ; **FLOATING
C6897 a_4187_1764.t30 VSS 0.0566f ; **FLOATING
C6898 a_4187_1764.n65 VSS 0.09291f ; **FLOATING
C6899 a_4187_1764.t29 VSS 0.0566f ; **FLOATING
C6900 a_4187_1764.n66 VSS 0.09291f ; **FLOATING
C6901 a_4187_1764.t28 VSS 0.0566f ; **FLOATING
C6902 a_4187_1764.n67 VSS 0.09291f ; **FLOATING
C6903 a_4187_1764.t27 VSS 0.0566f ; **FLOATING
C6904 a_4187_1764.n68 VSS 0.09291f ; **FLOATING
C6905 a_4187_1764.t26 VSS 0.0566f ; **FLOATING
C6906 a_4187_1764.n69 VSS 0.09291f ; **FLOATING
C6907 a_4187_1764.t25 VSS 0.0566f ; **FLOATING
C6908 a_4187_1764.n70 VSS 0.09291f ; **FLOATING
C6909 a_4187_1764.t24 VSS 0.0566f ; **FLOATING
C6910 a_4187_1764.n71 VSS 0.09291f ; **FLOATING
C6911 a_4187_1764.t23 VSS 0.0566f ; **FLOATING
C6912 a_4187_1764.n72 VSS 0.09291f ; **FLOATING
C6913 a_4187_1764.t22 VSS 0.0566f ; **FLOATING
C6914 a_4187_1764.n73 VSS 0.09291f ; **FLOATING
C6915 a_4187_1764.t21 VSS 0.0566f ; **FLOATING
C6916 a_4187_1764.n74 VSS 0.09291f ; **FLOATING
C6917 a_4187_1764.t20 VSS 0.0566f ; **FLOATING
C6918 a_4187_1764.n75 VSS 0.09291f ; **FLOATING
C6919 a_4187_1764.t19 VSS 0.0566f ; **FLOATING
C6920 a_4187_1764.n76 VSS 0.09291f ; **FLOATING
C6921 a_4187_1764.t18 VSS 0.0566f ; **FLOATING
C6922 a_4187_1764.n77 VSS 0.09291f ; **FLOATING
C6923 a_4187_1764.t17 VSS 0.0566f ; **FLOATING
C6924 a_4187_1764.n78 VSS 0.09291f ; **FLOATING
C6925 a_4187_1764.t16 VSS 0.0566f ; **FLOATING
C6926 a_4187_1764.n79 VSS 0.09291f ; **FLOATING
C6927 a_4187_1764.t15 VSS 0.0566f ; **FLOATING
C6928 a_4187_1764.n80 VSS 0.09291f ; **FLOATING
C6929 a_4187_1764.t14 VSS 0.0566f ; **FLOATING
C6930 a_4187_1764.n81 VSS 0.09291f ; **FLOATING
C6931 a_4187_1764.t13 VSS 0.0566f ; **FLOATING
C6932 a_4187_1764.n82 VSS 0.09291f ; **FLOATING
C6933 a_4187_1764.t12 VSS 0.0566f ; **FLOATING
C6934 a_4187_1764.n83 VSS 0.09291f ; **FLOATING
C6935 a_4187_1764.t11 VSS 0.0566f ; **FLOATING
C6936 a_4187_1764.n84 VSS 0.09291f ; **FLOATING
C6937 a_4187_1764.t10 VSS 0.0566f ; **FLOATING
C6938 a_4187_1764.n85 VSS 0.09291f ; **FLOATING
C6939 a_4187_1764.t9 VSS 0.0566f ; **FLOATING
C6940 a_4187_1764.n86 VSS 0.09291f ; **FLOATING
C6941 a_4187_1764.t8 VSS 0.0566f ; **FLOATING
C6942 a_4187_1764.n87 VSS 0.09291f ; **FLOATING
C6943 a_4187_1764.t7 VSS 0.0566f ; **FLOATING
C6944 a_4187_1764.n88 VSS 0.09291f ; **FLOATING
C6945 a_4187_1764.t6 VSS 0.0566f ; **FLOATING
C6946 a_4187_1764.n89 VSS 0.09291f ; **FLOATING
C6947 a_4187_1764.t5 VSS 0.0566f ; **FLOATING
C6948 a_4187_1764.n90 VSS 0.09291f ; **FLOATING
C6949 a_4187_1764.t4 VSS 0.0566f ; **FLOATING
C6950 a_4187_1764.n91 VSS 0.09291f ; **FLOATING
C6951 a_4187_1764.t3 VSS 0.0566f ; **FLOATING
C6952 a_4187_1764.n92 VSS 0.09291f ; **FLOATING
C6953 a_4187_1764.t2 VSS 0.0566f ; **FLOATING
C6954 a_4187_1764.n93 VSS 0.25093f ; **FLOATING
C6955 a_4187_1764.t65 VSS 0.05831f ; **FLOATING
C6956 a_4187_1764.t64 VSS 0.0566f ; **FLOATING
C6957 a_4187_1764.n94 VSS 0.13395f ; **FLOATING
C6958 a_4187_1764.t63 VSS 0.0566f ; **FLOATING
C6959 a_4187_1764.n95 VSS 0.09291f ; **FLOATING
C6960 a_4187_1764.t62 VSS 0.0566f ; **FLOATING
C6961 a_4187_1764.n96 VSS 0.09291f ; **FLOATING
C6962 a_4187_1764.t61 VSS 0.0566f ; **FLOATING
C6963 a_4187_1764.n97 VSS 0.09291f ; **FLOATING
C6964 a_4187_1764.t60 VSS 0.0566f ; **FLOATING
C6965 a_4187_1764.n98 VSS 0.09291f ; **FLOATING
C6966 a_4187_1764.t59 VSS 0.0566f ; **FLOATING
C6967 a_4187_1764.n99 VSS 0.09291f ; **FLOATING
C6968 a_4187_1764.t58 VSS 0.0566f ; **FLOATING
C6969 a_4187_1764.n100 VSS 0.09291f ; **FLOATING
C6970 a_4187_1764.t57 VSS 0.0566f ; **FLOATING
C6971 a_4187_1764.n101 VSS 0.09291f ; **FLOATING
C6972 a_4187_1764.t56 VSS 0.0566f ; **FLOATING
C6973 a_4187_1764.n102 VSS 0.09291f ; **FLOATING
C6974 a_4187_1764.t55 VSS 0.0566f ; **FLOATING
C6975 a_4187_1764.n103 VSS 0.09291f ; **FLOATING
C6976 a_4187_1764.t54 VSS 0.0566f ; **FLOATING
C6977 a_4187_1764.n104 VSS 0.09291f ; **FLOATING
C6978 a_4187_1764.t53 VSS 0.0566f ; **FLOATING
C6979 a_4187_1764.n105 VSS 0.09291f ; **FLOATING
C6980 a_4187_1764.t52 VSS 0.0566f ; **FLOATING
C6981 a_4187_1764.n106 VSS 0.09291f ; **FLOATING
C6982 a_4187_1764.t51 VSS 0.0566f ; **FLOATING
C6983 a_4187_1764.n107 VSS 0.09291f ; **FLOATING
C6984 a_4187_1764.t50 VSS 0.0566f ; **FLOATING
C6985 a_4187_1764.n108 VSS 0.09291f ; **FLOATING
C6986 a_4187_1764.t49 VSS 0.0566f ; **FLOATING
C6987 a_4187_1764.n109 VSS 0.09291f ; **FLOATING
C6988 a_4187_1764.t48 VSS 0.0566f ; **FLOATING
C6989 a_4187_1764.n110 VSS 0.09291f ; **FLOATING
C6990 a_4187_1764.t47 VSS 0.0566f ; **FLOATING
C6991 a_4187_1764.n111 VSS 0.09291f ; **FLOATING
C6992 a_4187_1764.t46 VSS 0.0566f ; **FLOATING
C6993 a_4187_1764.n112 VSS 0.09291f ; **FLOATING
C6994 a_4187_1764.t45 VSS 0.0566f ; **FLOATING
C6995 a_4187_1764.n113 VSS 0.09291f ; **FLOATING
C6996 a_4187_1764.t44 VSS 0.0566f ; **FLOATING
C6997 a_4187_1764.n114 VSS 0.09291f ; **FLOATING
C6998 a_4187_1764.t43 VSS 0.0566f ; **FLOATING
C6999 a_4187_1764.n115 VSS 0.09291f ; **FLOATING
C7000 a_4187_1764.t42 VSS 0.0566f ; **FLOATING
C7001 a_4187_1764.n116 VSS 0.09291f ; **FLOATING
C7002 a_4187_1764.t41 VSS 0.0566f ; **FLOATING
C7003 a_4187_1764.n117 VSS 0.09291f ; **FLOATING
C7004 a_4187_1764.t40 VSS 0.0566f ; **FLOATING
C7005 a_4187_1764.n118 VSS 0.09291f ; **FLOATING
C7006 a_4187_1764.t39 VSS 0.0566f ; **FLOATING
C7007 a_4187_1764.n119 VSS 0.09291f ; **FLOATING
C7008 a_4187_1764.t38 VSS 0.0566f ; **FLOATING
C7009 a_4187_1764.n120 VSS 0.09291f ; **FLOATING
C7010 a_4187_1764.t37 VSS 0.0566f ; **FLOATING
C7011 a_4187_1764.n121 VSS 0.09291f ; **FLOATING
C7012 a_4187_1764.t36 VSS 0.0566f ; **FLOATING
C7013 a_4187_1764.n122 VSS 0.09291f ; **FLOATING
C7014 a_4187_1764.t35 VSS 0.0566f ; **FLOATING
C7015 a_4187_1764.n123 VSS 0.09291f ; **FLOATING
C7016 a_4187_1764.t34 VSS 0.0566f ; **FLOATING
C7017 a_4187_1764.n124 VSS 0.13955f ; **FLOATING
C7018 a_4187_1764.n125 VSS 0.62764f ; **FLOATING
C7019 a_4187_1764.t97 VSS 0.05831f ; **FLOATING
C7020 a_4187_1764.t96 VSS 0.0566f ; **FLOATING
C7021 a_4187_1764.n126 VSS 0.13395f ; **FLOATING
C7022 a_4187_1764.t95 VSS 0.0566f ; **FLOATING
C7023 a_4187_1764.n127 VSS 0.09291f ; **FLOATING
C7024 a_4187_1764.t94 VSS 0.0566f ; **FLOATING
C7025 a_4187_1764.n128 VSS 0.09291f ; **FLOATING
C7026 a_4187_1764.t93 VSS 0.0566f ; **FLOATING
C7027 a_4187_1764.n129 VSS 0.09291f ; **FLOATING
C7028 a_4187_1764.t92 VSS 0.0566f ; **FLOATING
C7029 a_4187_1764.n130 VSS 0.09291f ; **FLOATING
C7030 a_4187_1764.t91 VSS 0.0566f ; **FLOATING
C7031 a_4187_1764.n131 VSS 0.09291f ; **FLOATING
C7032 a_4187_1764.t90 VSS 0.0566f ; **FLOATING
C7033 a_4187_1764.n132 VSS 0.09291f ; **FLOATING
C7034 a_4187_1764.t89 VSS 0.0566f ; **FLOATING
C7035 a_4187_1764.n133 VSS 0.09291f ; **FLOATING
C7036 a_4187_1764.t88 VSS 0.0566f ; **FLOATING
C7037 a_4187_1764.n134 VSS 0.09291f ; **FLOATING
C7038 a_4187_1764.t87 VSS 0.0566f ; **FLOATING
C7039 a_4187_1764.n135 VSS 0.09291f ; **FLOATING
C7040 a_4187_1764.t86 VSS 0.0566f ; **FLOATING
C7041 a_4187_1764.n136 VSS 0.09291f ; **FLOATING
C7042 a_4187_1764.t85 VSS 0.0566f ; **FLOATING
C7043 a_4187_1764.n137 VSS 0.09291f ; **FLOATING
C7044 a_4187_1764.t84 VSS 0.0566f ; **FLOATING
C7045 a_4187_1764.n138 VSS 0.09291f ; **FLOATING
C7046 a_4187_1764.t83 VSS 0.0566f ; **FLOATING
C7047 a_4187_1764.n139 VSS 0.09291f ; **FLOATING
C7048 a_4187_1764.t82 VSS 0.0566f ; **FLOATING
C7049 a_4187_1764.n140 VSS 0.09291f ; **FLOATING
C7050 a_4187_1764.t81 VSS 0.0566f ; **FLOATING
C7051 a_4187_1764.n141 VSS 0.09291f ; **FLOATING
C7052 a_4187_1764.t80 VSS 0.0566f ; **FLOATING
C7053 a_4187_1764.n142 VSS 0.09291f ; **FLOATING
C7054 a_4187_1764.t79 VSS 0.0566f ; **FLOATING
C7055 a_4187_1764.n143 VSS 0.09291f ; **FLOATING
C7056 a_4187_1764.t78 VSS 0.0566f ; **FLOATING
C7057 a_4187_1764.n144 VSS 0.09291f ; **FLOATING
C7058 a_4187_1764.t77 VSS 0.0566f ; **FLOATING
C7059 a_4187_1764.n145 VSS 0.09291f ; **FLOATING
C7060 a_4187_1764.t76 VSS 0.0566f ; **FLOATING
C7061 a_4187_1764.n146 VSS 0.09291f ; **FLOATING
C7062 a_4187_1764.t75 VSS 0.0566f ; **FLOATING
C7063 a_4187_1764.n147 VSS 0.09291f ; **FLOATING
C7064 a_4187_1764.t74 VSS 0.0566f ; **FLOATING
C7065 a_4187_1764.n148 VSS 0.09291f ; **FLOATING
C7066 a_4187_1764.t73 VSS 0.0566f ; **FLOATING
C7067 a_4187_1764.n149 VSS 0.09291f ; **FLOATING
C7068 a_4187_1764.t72 VSS 0.0566f ; **FLOATING
C7069 a_4187_1764.n150 VSS 0.09291f ; **FLOATING
C7070 a_4187_1764.t71 VSS 0.0566f ; **FLOATING
C7071 a_4187_1764.n151 VSS 0.09291f ; **FLOATING
C7072 a_4187_1764.t70 VSS 0.0566f ; **FLOATING
C7073 a_4187_1764.n152 VSS 0.09291f ; **FLOATING
C7074 a_4187_1764.t69 VSS 0.0566f ; **FLOATING
C7075 a_4187_1764.n153 VSS 0.09291f ; **FLOATING
C7076 a_4187_1764.t68 VSS 0.0566f ; **FLOATING
C7077 a_4187_1764.n154 VSS 0.09291f ; **FLOATING
C7078 a_4187_1764.t67 VSS 0.0566f ; **FLOATING
C7079 a_4187_1764.n155 VSS 0.09291f ; **FLOATING
C7080 a_4187_1764.t66 VSS 0.0566f ; **FLOATING
C7081 a_4187_1764.n156 VSS 0.13955f ; **FLOATING
C7082 a_4187_1764.n157 VSS 0.35793f ; **FLOATING
C7083 a_4187_1764.n158 VSS 0.4796f ; **FLOATING
C7084 a_4187_1764.t99 VSS 0.05228f ; **FLOATING
C7085 a_4187_1764.n159 VSS 0.39749f ; **FLOATING
C7086 a_4187_1764.t1 VSS 0.0132f ; **FLOATING
C7087 a_4187_1764.n160 VSS 0.13499f ; **FLOATING
C7088 a_4187_1764.t0 VSS 0.03578f ; **FLOATING
C7089 a_2019_16074.t2 VSS 0.92614f ; **FLOATING
C7090 a_2019_16074.t3 VSS 0.7031f ; **FLOATING
C7091 a_2019_16074.n0 VSS 4.9866f ; **FLOATING
C7092 a_2019_16074.t4 VSS 0.7031f ; **FLOATING
C7093 a_2019_16074.n1 VSS 3.37357f ; **FLOATING
C7094 a_2019_16074.t5 VSS 0.7031f ; **FLOATING
C7095 a_2019_16074.n2 VSS 3.37357f ; **FLOATING
C7096 a_2019_16074.t6 VSS 0.7031f ; **FLOATING
C7097 a_2019_16074.n3 VSS 3.37357f ; **FLOATING
C7098 a_2019_16074.t7 VSS 0.7031f ; **FLOATING
C7099 a_2019_16074.n4 VSS 3.37357f ; **FLOATING
C7100 a_2019_16074.t8 VSS 0.7031f ; **FLOATING
C7101 a_2019_16074.n5 VSS 3.37357f ; **FLOATING
C7102 a_2019_16074.t9 VSS 5.43064f ; **FLOATING
C7103 a_2019_16074.t1 VSS 1.06781f ; **FLOATING
C7104 a_2019_16074.t0 VSS 0.3035f ; **FLOATING
C7105 a_2595_16074.t2 VSS 1.36812f ; **FLOATING
C7106 a_2595_16074.t3 VSS 1.02175f ; **FLOATING
C7107 a_2595_16074.n0 VSS 7.76742f ; **FLOATING
C7108 a_2595_16074.t4 VSS 1.02175f ; **FLOATING
C7109 a_2595_16074.n1 VSS 5.2776f ; **FLOATING
C7110 a_2595_16074.t5 VSS 1.02175f ; **FLOATING
C7111 a_2595_16074.n2 VSS 5.2776f ; **FLOATING
C7112 a_2595_16074.t6 VSS 1.02175f ; **FLOATING
C7113 a_2595_16074.n3 VSS 5.2776f ; **FLOATING
C7114 a_2595_16074.t7 VSS 1.02175f ; **FLOATING
C7115 a_2595_16074.n4 VSS 5.2776f ; **FLOATING
C7116 a_2595_16074.t8 VSS 1.02175f ; **FLOATING
C7117 a_2595_16074.n5 VSS 5.2776f ; **FLOATING
C7118 a_2595_16074.t9 VSS 1.02175f ; **FLOATING
C7119 a_2595_16074.n6 VSS 7.59152f ; **FLOATING
C7120 a_2595_16074.t1 VSS 1.75259f ; **FLOATING
C7121 a_2595_16074.t0 VSS 0.48265f ; **FLOATING
C7122 a_3171_16074.t2 VSS 1.38467f ; **FLOATING
C7123 a_3171_16074.t3 VSS 1.03752f ; **FLOATING
C7124 a_3171_16074.n0 VSS 7.77995f ; **FLOATING
C7125 a_3171_16074.t4 VSS 1.03752f ; **FLOATING
C7126 a_3171_16074.n1 VSS 5.28177f ; **FLOATING
C7127 a_3171_16074.t5 VSS 1.03752f ; **FLOATING
C7128 a_3171_16074.n2 VSS 5.28177f ; **FLOATING
C7129 a_3171_16074.t6 VSS 1.03752f ; **FLOATING
C7130 a_3171_16074.n3 VSS 5.28177f ; **FLOATING
C7131 a_3171_16074.t7 VSS 1.03752f ; **FLOATING
C7132 a_3171_16074.n4 VSS 5.28177f ; **FLOATING
C7133 a_3171_16074.t8 VSS 1.03752f ; **FLOATING
C7134 a_3171_16074.n5 VSS 5.28177f ; **FLOATING
C7135 a_3171_16074.t9 VSS 1.03752f ; **FLOATING
C7136 a_3171_16074.n6 VSS 7.68485f ; **FLOATING
C7137 a_3171_16074.t1 VSS 1.77058f ; **FLOATING
C7138 a_3171_16074.t0 VSS 0.48093f ; **FLOATING
C7139 a_3747_16074.t2 VSS 0.97174f ; **FLOATING
C7140 a_3747_16074.t3 VSS 0.7398f ; **FLOATING
C7141 a_3747_16074.n0 VSS 5.18289f ; **FLOATING
C7142 a_3747_16074.t4 VSS 0.7398f ; **FLOATING
C7143 a_3747_16074.n1 VSS 3.50356f ; **FLOATING
C7144 a_3747_16074.t5 VSS 0.7398f ; **FLOATING
C7145 a_3747_16074.n2 VSS 3.50356f ; **FLOATING
C7146 a_3747_16074.t6 VSS 0.7398f ; **FLOATING
C7147 a_3747_16074.n3 VSS 3.50356f ; **FLOATING
C7148 a_3747_16074.t7 VSS 0.7398f ; **FLOATING
C7149 a_3747_16074.n4 VSS 3.50356f ; **FLOATING
C7150 a_3747_16074.t8 VSS 0.7398f ; **FLOATING
C7151 a_3747_16074.n5 VSS 3.50356f ; **FLOATING
C7152 a_3747_16074.t9 VSS 0.7398f ; **FLOATING
C7153 a_3747_16074.n6 VSS 5.20238f ; **FLOATING
C7154 a_3747_16074.t1 VSS 1.18889f ; **FLOATING
C7155 a_3747_16074.t0 VSS 0.31431f ; **FLOATING
C7156 a_2019_15338.t2 VSS 4.07893f ; **FLOATING
C7157 a_2019_15338.t3 VSS 21.9515f ; **FLOATING
C7158 a_2019_15338.t1 VSS 1.99396f ; **FLOATING
C7159 a_2019_15338.t0 VSS 0.44771f ; **FLOATING
C7160 a_2595_15338.t1 VSS 3.30104f ; **FLOATING
C7161 a_2595_15338.t2 VSS 5.08874f ; **FLOATING
C7162 a_2595_15338.t3 VSS 1.21763f ; **FLOATING
C7163 a_2595_15338.n0 VSS 27.1188f ; **FLOATING
C7164 a_2595_15338.t0 VSS 0.50037f ; **FLOATING
C7165 a_3171_15338.t2 VSS 5.08045f ; **FLOATING
C7166 a_3171_15338.t3 VSS 1.21878f ; **FLOATING
C7167 a_3171_15338.n0 VSS 30.0294f ; **FLOATING
C7168 a_3171_15338.t1 VSS 4.63926f ; **FLOATING
C7169 a_3171_15338.t0 VSS 0.50029f ; **FLOATING
C7170 a_3747_15338.t2 VSS 3.14577f ; **FLOATING
C7171 a_3747_15338.t3 VSS 0.75716f ; **FLOATING
C7172 a_3747_15338.n0 VSS 20.2342f ; **FLOATING
C7173 a_3747_15338.t1 VSS 3.75304f ; **FLOATING
C7174 a_3747_15338.t0 VSS 0.31068f ; **FLOATING
C7175 a_2019_13229.t2 VSS 0.92623f ; **FLOATING
C7176 a_2019_13229.t3 VSS 0.70316f ; **FLOATING
C7177 a_2019_13229.n0 VSS 4.98708f ; **FLOATING
C7178 a_2019_13229.t4 VSS 0.70316f ; **FLOATING
C7179 a_2019_13229.n1 VSS 3.37389f ; **FLOATING
C7180 a_2019_13229.t5 VSS 0.70316f ; **FLOATING
C7181 a_2019_13229.n2 VSS 3.37389f ; **FLOATING
C7182 a_2019_13229.t6 VSS 0.70316f ; **FLOATING
C7183 a_2019_13229.n3 VSS 3.37389f ; **FLOATING
C7184 a_2019_13229.t7 VSS 0.70316f ; **FLOATING
C7185 a_2019_13229.n4 VSS 3.37389f ; **FLOATING
C7186 a_2019_13229.t8 VSS 0.70316f ; **FLOATING
C7187 a_2019_13229.n5 VSS 3.37389f ; **FLOATING
C7188 a_2019_13229.t9 VSS 5.43115f ; **FLOATING
C7189 a_2019_13229.t1 VSS 1.06791f ; **FLOATING
C7190 a_2019_13229.t0 VSS 0.30353f ; **FLOATING
C7191 a_2595_13229.t2 VSS 1.36813f ; **FLOATING
C7192 a_2595_13229.t3 VSS 1.02176f ; **FLOATING
C7193 a_2595_13229.n0 VSS 7.76748f ; **FLOATING
C7194 a_2595_13229.t4 VSS 1.02176f ; **FLOATING
C7195 a_2595_13229.n1 VSS 5.27764f ; **FLOATING
C7196 a_2595_13229.t5 VSS 1.02176f ; **FLOATING
C7197 a_2595_13229.n2 VSS 5.27764f ; **FLOATING
C7198 a_2595_13229.t6 VSS 1.02176f ; **FLOATING
C7199 a_2595_13229.n3 VSS 5.27764f ; **FLOATING
C7200 a_2595_13229.t7 VSS 1.02176f ; **FLOATING
C7201 a_2595_13229.n4 VSS 5.27764f ; **FLOATING
C7202 a_2595_13229.t8 VSS 1.02176f ; **FLOATING
C7203 a_2595_13229.n5 VSS 5.27764f ; **FLOATING
C7204 a_2595_13229.t9 VSS 1.02176f ; **FLOATING
C7205 a_2595_13229.n6 VSS 7.59158f ; **FLOATING
C7206 a_2595_13229.t1 VSS 1.7526f ; **FLOATING
C7207 a_2595_13229.t0 VSS 0.48266f ; **FLOATING
C7208 a_3171_13229.t2 VSS 1.38481f ; **FLOATING
C7209 a_3171_13229.t3 VSS 1.03763f ; **FLOATING
C7210 a_3171_13229.n0 VSS 7.78073f ; **FLOATING
C7211 a_3171_13229.t4 VSS 1.03763f ; **FLOATING
C7212 a_3171_13229.n1 VSS 5.2823f ; **FLOATING
C7213 a_3171_13229.t5 VSS 1.03763f ; **FLOATING
C7214 a_3171_13229.n2 VSS 5.2823f ; **FLOATING
C7215 a_3171_13229.t6 VSS 1.03763f ; **FLOATING
C7216 a_3171_13229.n3 VSS 5.2823f ; **FLOATING
C7217 a_3171_13229.t7 VSS 1.03763f ; **FLOATING
C7218 a_3171_13229.n4 VSS 5.2823f ; **FLOATING
C7219 a_3171_13229.t8 VSS 1.03763f ; **FLOATING
C7220 a_3171_13229.n5 VSS 5.2823f ; **FLOATING
C7221 a_3171_13229.t9 VSS 1.03763f ; **FLOATING
C7222 a_3171_13229.n6 VSS 7.68562f ; **FLOATING
C7223 a_3171_13229.t1 VSS 1.77076f ; **FLOATING
C7224 a_3171_13229.t0 VSS 0.48098f ; **FLOATING
C7225 a_3747_13229.t2 VSS 0.97097f ; **FLOATING
C7226 a_3747_13229.t3 VSS 0.73922f ; **FLOATING
C7227 a_3747_13229.n0 VSS 5.17879f ; **FLOATING
C7228 a_3747_13229.t4 VSS 0.73922f ; **FLOATING
C7229 a_3747_13229.n1 VSS 3.50079f ; **FLOATING
C7230 a_3747_13229.t5 VSS 0.73922f ; **FLOATING
C7231 a_3747_13229.n2 VSS 3.50079f ; **FLOATING
C7232 a_3747_13229.t6 VSS 0.73922f ; **FLOATING
C7233 a_3747_13229.n3 VSS 3.50079f ; **FLOATING
C7234 a_3747_13229.t7 VSS 0.73922f ; **FLOATING
C7235 a_3747_13229.n4 VSS 3.50079f ; **FLOATING
C7236 a_3747_13229.t8 VSS 0.73922f ; **FLOATING
C7237 a_3747_13229.n5 VSS 3.50079f ; **FLOATING
C7238 a_3747_13229.t9 VSS 0.73922f ; **FLOATING
C7239 a_3747_13229.n6 VSS 5.19826f ; **FLOATING
C7240 a_3747_13229.t1 VSS 1.18795f ; **FLOATING
C7241 a_3747_13229.t0 VSS 0.31406f ; **FLOATING
C7242 a_2019_12493.t2 VSS 4.07093f ; **FLOATING
C7243 a_2019_12493.t3 VSS 21.9084f ; **FLOATING
C7244 a_2019_12493.t1 VSS 1.99005f ; **FLOATING
C7245 a_2019_12493.t0 VSS 0.44683f ; **FLOATING
C7246 a_2595_12493.t1 VSS 3.28909f ; **FLOATING
C7247 a_2595_12493.t2 VSS 5.07032f ; **FLOATING
C7248 a_2595_12493.t3 VSS 1.21322f ; **FLOATING
C7249 a_2595_12493.n0 VSS 27.0207f ; **FLOATING
C7250 a_2595_12493.t0 VSS 0.49856f ; **FLOATING
C7251 a_3171_12493.t2 VSS 5.0648f ; **FLOATING
C7252 a_3171_12493.t3 VSS 1.21502f ; **FLOATING
C7253 a_3171_12493.n0 VSS 29.9369f ; **FLOATING
C7254 a_3171_12493.t1 VSS 4.62497f ; **FLOATING
C7255 a_3171_12493.t0 VSS 0.49875f ; **FLOATING
C7256 a_3747_12493.t2 VSS 3.13063f ; **FLOATING
C7257 a_3747_12493.t3 VSS 0.75351f ; **FLOATING
C7258 a_3747_12493.n0 VSS 20.1368f ; **FLOATING
C7259 a_3747_12493.t1 VSS 3.73498f ; **FLOATING
C7260 a_3747_12493.t0 VSS 0.30918f ; **FLOATING
C7261 a_2019_6737.t2 VSS 0.92624f ; **FLOATING
C7262 a_2019_6737.t3 VSS 0.70318f ; **FLOATING
C7263 a_2019_6737.n0 VSS 4.98715f ; **FLOATING
C7264 a_2019_6737.t4 VSS 0.70318f ; **FLOATING
C7265 a_2019_6737.n1 VSS 3.37394f ; **FLOATING
C7266 a_2019_6737.t5 VSS 0.70318f ; **FLOATING
C7267 a_2019_6737.n2 VSS 3.37394f ; **FLOATING
C7268 a_2019_6737.t6 VSS 0.70318f ; **FLOATING
C7269 a_2019_6737.n3 VSS 3.37394f ; **FLOATING
C7270 a_2019_6737.t7 VSS 0.70318f ; **FLOATING
C7271 a_2019_6737.n4 VSS 3.37394f ; **FLOATING
C7272 a_2019_6737.t8 VSS 0.70318f ; **FLOATING
C7273 a_2019_6737.n5 VSS 3.37394f ; **FLOATING
C7274 a_2019_6737.t9 VSS 5.43123f ; **FLOATING
C7275 a_2019_6737.t1 VSS 1.06793f ; **FLOATING
C7276 a_2019_6737.t0 VSS 0.30354f ; **FLOATING
C7277 a_2595_6737.t2 VSS 1.36812f ; **FLOATING
C7278 a_2595_6737.t3 VSS 1.02176f ; **FLOATING
C7279 a_2595_6737.n0 VSS 7.76746f ; **FLOATING
C7280 a_2595_6737.t4 VSS 1.02176f ; **FLOATING
C7281 a_2595_6737.n1 VSS 5.27763f ; **FLOATING
C7282 a_2595_6737.t5 VSS 1.02176f ; **FLOATING
C7283 a_2595_6737.n2 VSS 5.27763f ; **FLOATING
C7284 a_2595_6737.t6 VSS 1.02176f ; **FLOATING
C7285 a_2595_6737.n3 VSS 5.27763f ; **FLOATING
C7286 a_2595_6737.t7 VSS 1.02176f ; **FLOATING
C7287 a_2595_6737.n4 VSS 5.27763f ; **FLOATING
C7288 a_2595_6737.t8 VSS 1.02176f ; **FLOATING
C7289 a_2595_6737.n5 VSS 5.27763f ; **FLOATING
C7290 a_2595_6737.t9 VSS 1.02176f ; **FLOATING
C7291 a_2595_6737.n6 VSS 7.59155f ; **FLOATING
C7292 a_2595_6737.t1 VSS 1.75259f ; **FLOATING
C7293 a_2595_6737.t0 VSS 0.48265f ; **FLOATING
C7294 a_3171_6737.t2 VSS 1.38468f ; **FLOATING
C7295 a_3171_6737.t3 VSS 1.03753f ; **FLOATING
C7296 a_3171_6737.n0 VSS 7.78001f ; **FLOATING
C7297 a_3171_6737.t4 VSS 1.03753f ; **FLOATING
C7298 a_3171_6737.n1 VSS 5.28181f ; **FLOATING
C7299 a_3171_6737.t5 VSS 1.03753f ; **FLOATING
C7300 a_3171_6737.n2 VSS 5.28181f ; **FLOATING
C7301 a_3171_6737.t6 VSS 1.03753f ; **FLOATING
C7302 a_3171_6737.n3 VSS 5.28181f ; **FLOATING
C7303 a_3171_6737.t7 VSS 1.03753f ; **FLOATING
C7304 a_3171_6737.n4 VSS 5.28181f ; **FLOATING
C7305 a_3171_6737.t8 VSS 1.03753f ; **FLOATING
C7306 a_3171_6737.n5 VSS 5.28181f ; **FLOATING
C7307 a_3171_6737.t9 VSS 1.03753f ; **FLOATING
C7308 a_3171_6737.n6 VSS 7.6849f ; **FLOATING
C7309 a_3171_6737.t1 VSS 1.77059f ; **FLOATING
C7310 a_3171_6737.t0 VSS 0.48093f ; **FLOATING
C7311 a_3747_6737.t2 VSS 0.97175f ; **FLOATING
C7312 a_3747_6737.t3 VSS 0.73981f ; **FLOATING
C7313 a_3747_6737.n0 VSS 5.18293f ; **FLOATING
C7314 a_3747_6737.t4 VSS 0.73981f ; **FLOATING
C7315 a_3747_6737.n1 VSS 3.50359f ; **FLOATING
C7316 a_3747_6737.t5 VSS 0.73981f ; **FLOATING
C7317 a_3747_6737.n2 VSS 3.50359f ; **FLOATING
C7318 a_3747_6737.t6 VSS 0.73981f ; **FLOATING
C7319 a_3747_6737.n3 VSS 3.50359f ; **FLOATING
C7320 a_3747_6737.t7 VSS 0.73981f ; **FLOATING
C7321 a_3747_6737.n4 VSS 3.50359f ; **FLOATING
C7322 a_3747_6737.t8 VSS 0.73981f ; **FLOATING
C7323 a_3747_6737.n5 VSS 3.50359f ; **FLOATING
C7324 a_3747_6737.t9 VSS 0.73981f ; **FLOATING
C7325 a_3747_6737.n6 VSS 5.20242f ; **FLOATING
C7326 a_3747_6737.t1 VSS 1.1889f ; **FLOATING
C7327 a_3747_6737.t0 VSS 0.31431f ; **FLOATING
C7328 a_2019_6001.t2 VSS 4.07893f ; **FLOATING
C7329 a_2019_6001.t3 VSS 21.9515f ; **FLOATING
C7330 a_2019_6001.t1 VSS 1.99396f ; **FLOATING
C7331 a_2019_6001.t0 VSS 0.44771f ; **FLOATING
C7332 a_2595_6001.t1 VSS 3.30104f ; **FLOATING
C7333 a_2595_6001.t2 VSS 5.08874f ; **FLOATING
C7334 a_2595_6001.t3 VSS 1.21763f ; **FLOATING
C7335 a_2595_6001.n0 VSS 27.1188f ; **FLOATING
C7336 a_2595_6001.t0 VSS 0.50037f ; **FLOATING
C7337 a_3171_6001.t2 VSS 5.08045f ; **FLOATING
C7338 a_3171_6001.t3 VSS 1.21878f ; **FLOATING
C7339 a_3171_6001.n0 VSS 30.0294f ; **FLOATING
C7340 a_3171_6001.t1 VSS 4.63926f ; **FLOATING
C7341 a_3171_6001.t0 VSS 0.50029f ; **FLOATING
C7342 a_3747_6001.t2 VSS 3.14577f ; **FLOATING
C7343 a_3747_6001.t3 VSS 0.75716f ; **FLOATING
C7344 a_3747_6001.n0 VSS 20.2342f ; **FLOATING
C7345 a_3747_6001.t1 VSS 3.75304f ; **FLOATING
C7346 a_3747_6001.t0 VSS 0.31068f ; **FLOATING
C7347 a_2019_3892.t2 VSS 0.92626f ; **FLOATING
C7348 a_2019_3892.t3 VSS 0.70319f ; **FLOATING
C7349 a_2019_3892.n0 VSS 4.98725f ; **FLOATING
C7350 a_2019_3892.t4 VSS 0.70319f ; **FLOATING
C7351 a_2019_3892.n1 VSS 3.37401f ; **FLOATING
C7352 a_2019_3892.t5 VSS 0.70319f ; **FLOATING
C7353 a_2019_3892.n2 VSS 3.37401f ; **FLOATING
C7354 a_2019_3892.t6 VSS 0.70319f ; **FLOATING
C7355 a_2019_3892.n3 VSS 3.37401f ; **FLOATING
C7356 a_2019_3892.t7 VSS 0.70319f ; **FLOATING
C7357 a_2019_3892.n4 VSS 3.37401f ; **FLOATING
C7358 a_2019_3892.t8 VSS 0.70319f ; **FLOATING
C7359 a_2019_3892.n5 VSS 3.37401f ; **FLOATING
C7360 a_2019_3892.t9 VSS 5.43135f ; **FLOATING
C7361 a_2019_3892.t1 VSS 1.06795f ; **FLOATING
C7362 a_2019_3892.t0 VSS 0.30354f ; **FLOATING
C7363 a_2595_3892.t2 VSS 1.36815f ; **FLOATING
C7364 a_2595_3892.t3 VSS 1.02178f ; **FLOATING
C7365 a_2595_3892.n0 VSS 7.76762f ; **FLOATING
C7366 a_2595_3892.t4 VSS 1.02178f ; **FLOATING
C7367 a_2595_3892.n1 VSS 5.27774f ; **FLOATING
C7368 a_2595_3892.t5 VSS 1.02178f ; **FLOATING
C7369 a_2595_3892.n2 VSS 5.27774f ; **FLOATING
C7370 a_2595_3892.t6 VSS 1.02178f ; **FLOATING
C7371 a_2595_3892.n3 VSS 5.27774f ; **FLOATING
C7372 a_2595_3892.t7 VSS 1.02178f ; **FLOATING
C7373 a_2595_3892.n4 VSS 5.27774f ; **FLOATING
C7374 a_2595_3892.t8 VSS 1.02178f ; **FLOATING
C7375 a_2595_3892.n5 VSS 5.27774f ; **FLOATING
C7376 a_2595_3892.t9 VSS 1.02178f ; **FLOATING
C7377 a_2595_3892.n6 VSS 7.59171f ; **FLOATING
C7378 a_2595_3892.t1 VSS 1.75263f ; **FLOATING
C7379 a_2595_3892.t0 VSS 0.48266f ; **FLOATING
C7380 a_3171_3892.t2 VSS 1.38486f ; **FLOATING
C7381 a_3171_3892.t3 VSS 1.03766f ; **FLOATING
C7382 a_3171_3892.n0 VSS 7.78101f ; **FLOATING
C7383 a_3171_3892.t4 VSS 1.03766f ; **FLOATING
C7384 a_3171_3892.n1 VSS 5.28249f ; **FLOATING
C7385 a_3171_3892.t5 VSS 1.03766f ; **FLOATING
C7386 a_3171_3892.n2 VSS 5.28249f ; **FLOATING
C7387 a_3171_3892.t6 VSS 1.03766f ; **FLOATING
C7388 a_3171_3892.n3 VSS 5.28249f ; **FLOATING
C7389 a_3171_3892.t7 VSS 1.03766f ; **FLOATING
C7390 a_3171_3892.n4 VSS 5.28249f ; **FLOATING
C7391 a_3171_3892.t8 VSS 1.03766f ; **FLOATING
C7392 a_3171_3892.n5 VSS 5.28249f ; **FLOATING
C7393 a_3171_3892.t9 VSS 1.03766f ; **FLOATING
C7394 a_3171_3892.n6 VSS 7.68589f ; **FLOATING
C7395 a_3171_3892.t1 VSS 1.77082f ; **FLOATING
C7396 a_3171_3892.t0 VSS 0.48099f ; **FLOATING
C7397 a_3747_3892.t2 VSS 0.97186f ; **FLOATING
C7398 a_3747_3892.t3 VSS 0.73989f ; **FLOATING
C7399 a_3747_3892.n0 VSS 5.18349f ; **FLOATING
C7400 a_3747_3892.t4 VSS 0.73989f ; **FLOATING
C7401 a_3747_3892.n1 VSS 3.50397f ; **FLOATING
C7402 a_3747_3892.t5 VSS 0.73989f ; **FLOATING
C7403 a_3747_3892.n2 VSS 3.50397f ; **FLOATING
C7404 a_3747_3892.t6 VSS 0.73989f ; **FLOATING
C7405 a_3747_3892.n3 VSS 3.50397f ; **FLOATING
C7406 a_3747_3892.t7 VSS 0.73989f ; **FLOATING
C7407 a_3747_3892.n4 VSS 3.50397f ; **FLOATING
C7408 a_3747_3892.t8 VSS 0.73989f ; **FLOATING
C7409 a_3747_3892.n5 VSS 3.50397f ; **FLOATING
C7410 a_3747_3892.t9 VSS 0.73989f ; **FLOATING
C7411 a_3747_3892.n6 VSS 5.20299f ; **FLOATING
C7412 a_3747_3892.t1 VSS 1.18903f ; **FLOATING
C7413 a_3747_3892.t0 VSS 0.31435f ; **FLOATING
C7414 a_2019_3156.t2 VSS 4.07893f ; **FLOATING
C7415 a_2019_3156.t3 VSS 21.9515f ; **FLOATING
C7416 a_2019_3156.t1 VSS 1.99396f ; **FLOATING
C7417 a_2019_3156.t0 VSS 0.44771f ; **FLOATING
C7418 a_2595_3156.t1 VSS 3.30104f ; **FLOATING
C7419 a_2595_3156.t2 VSS 5.08874f ; **FLOATING
C7420 a_2595_3156.t3 VSS 1.21763f ; **FLOATING
C7421 a_2595_3156.n0 VSS 27.1188f ; **FLOATING
C7422 a_2595_3156.t0 VSS 0.50037f ; **FLOATING
C7423 a_3171_3156.t2 VSS 5.08045f ; **FLOATING
C7424 a_3171_3156.t3 VSS 1.21878f ; **FLOATING
C7425 a_3171_3156.n0 VSS 30.0294f ; **FLOATING
C7426 a_3171_3156.t1 VSS 4.63926f ; **FLOATING
C7427 a_3171_3156.t0 VSS 0.50029f ; **FLOATING
C7428 a_3747_3156.t2 VSS 3.14577f ; **FLOATING
C7429 a_3747_3156.t3 VSS 0.75716f ; **FLOATING
C7430 a_3747_3156.n0 VSS 20.2342f ; **FLOATING
C7431 a_3747_3156.t1 VSS 3.75304f ; **FLOATING
C7432 a_3747_3156.t0 VSS 0.31068f ; **FLOATING
C7433 a_2019_1047.t2 VSS 0.92612f ; **FLOATING
C7434 a_2019_1047.t3 VSS 0.70308f ; **FLOATING
C7435 a_2019_1047.n0 VSS 4.98649f ; **FLOATING
C7436 a_2019_1047.t4 VSS 0.70308f ; **FLOATING
C7437 a_2019_1047.n1 VSS 3.37349f ; **FLOATING
C7438 a_2019_1047.t5 VSS 0.70308f ; **FLOATING
C7439 a_2019_1047.n2 VSS 3.37349f ; **FLOATING
C7440 a_2019_1047.t6 VSS 0.70308f ; **FLOATING
C7441 a_2019_1047.n3 VSS 3.37349f ; **FLOATING
C7442 a_2019_1047.t7 VSS 0.70308f ; **FLOATING
C7443 a_2019_1047.n4 VSS 3.37349f ; **FLOATING
C7444 a_2019_1047.t8 VSS 0.70308f ; **FLOATING
C7445 a_2019_1047.n5 VSS 3.37349f ; **FLOATING
C7446 a_2019_1047.t9 VSS 5.43051f ; **FLOATING
C7447 a_2019_1047.t1 VSS 1.06779f ; **FLOATING
C7448 a_2019_1047.t0 VSS 0.3035f ; **FLOATING
C7449 a_2595_1047.t2 VSS 1.36799f ; **FLOATING
C7450 a_2595_1047.t3 VSS 1.02166f ; **FLOATING
C7451 a_2595_1047.n0 VSS 7.76669f ; **FLOATING
C7452 a_2595_1047.t4 VSS 1.02166f ; **FLOATING
C7453 a_2595_1047.n1 VSS 5.2771f ; **FLOATING
C7454 a_2595_1047.t5 VSS 1.02166f ; **FLOATING
C7455 a_2595_1047.n2 VSS 5.2771f ; **FLOATING
C7456 a_2595_1047.t6 VSS 1.02166f ; **FLOATING
C7457 a_2595_1047.n3 VSS 5.2771f ; **FLOATING
C7458 a_2595_1047.t7 VSS 1.02166f ; **FLOATING
C7459 a_2595_1047.n4 VSS 5.2771f ; **FLOATING
C7460 a_2595_1047.t8 VSS 1.02166f ; **FLOATING
C7461 a_2595_1047.n5 VSS 5.2771f ; **FLOATING
C7462 a_2595_1047.t9 VSS 1.02166f ; **FLOATING
C7463 a_2595_1047.n6 VSS 7.5908f ; **FLOATING
C7464 a_2595_1047.t1 VSS 1.75242f ; **FLOATING
C7465 a_2595_1047.t0 VSS 0.48261f ; **FLOATING
C7466 a_3171_1047.t2 VSS 1.38461f ; **FLOATING
C7467 a_3171_1047.t3 VSS 1.03748f ; **FLOATING
C7468 a_3171_1047.n0 VSS 7.77962f ; **FLOATING
C7469 a_3171_1047.t4 VSS 1.03748f ; **FLOATING
C7470 a_3171_1047.n1 VSS 5.28155f ; **FLOATING
C7471 a_3171_1047.t5 VSS 1.03748f ; **FLOATING
C7472 a_3171_1047.n2 VSS 5.28155f ; **FLOATING
C7473 a_3171_1047.t6 VSS 1.03748f ; **FLOATING
C7474 a_3171_1047.n3 VSS 5.28155f ; **FLOATING
C7475 a_3171_1047.t7 VSS 1.03748f ; **FLOATING
C7476 a_3171_1047.n4 VSS 5.28155f ; **FLOATING
C7477 a_3171_1047.t8 VSS 1.03748f ; **FLOATING
C7478 a_3171_1047.n5 VSS 5.28155f ; **FLOATING
C7479 a_3171_1047.t9 VSS 1.03748f ; **FLOATING
C7480 a_3171_1047.n6 VSS 7.68452f ; **FLOATING
C7481 a_3171_1047.t1 VSS 1.7705f ; **FLOATING
C7482 a_3171_1047.t0 VSS 0.48091f ; **FLOATING
C7483 a_3747_1047.t2 VSS 0.97062f ; **FLOATING
C7484 a_3747_1047.t3 VSS 0.73894f ; **FLOATING
C7485 a_3747_1047.n0 VSS 5.17688f ; **FLOATING
C7486 a_3747_1047.t4 VSS 0.73894f ; **FLOATING
C7487 a_3747_1047.n1 VSS 3.4995f ; **FLOATING
C7488 a_3747_1047.t5 VSS 0.73894f ; **FLOATING
C7489 a_3747_1047.n2 VSS 3.4995f ; **FLOATING
C7490 a_3747_1047.t6 VSS 0.73894f ; **FLOATING
C7491 a_3747_1047.n3 VSS 3.4995f ; **FLOATING
C7492 a_3747_1047.t7 VSS 0.73894f ; **FLOATING
C7493 a_3747_1047.n4 VSS 3.4995f ; **FLOATING
C7494 a_3747_1047.t8 VSS 0.73894f ; **FLOATING
C7495 a_3747_1047.n5 VSS 3.4995f ; **FLOATING
C7496 a_3747_1047.t9 VSS 0.73894f ; **FLOATING
C7497 a_3747_1047.n6 VSS 5.19635f ; **FLOATING
C7498 a_3747_1047.t1 VSS 1.18751f ; **FLOATING
C7499 a_3747_1047.t0 VSS 0.31395f ; **FLOATING
C7500 a_2019_311.t2 VSS 4.05298f ; **FLOATING
C7501 a_2019_311.t3 VSS 21.8118f ; **FLOATING
C7502 a_2019_311.t1 VSS 1.98128f ; **FLOATING
C7503 a_2019_311.t0 VSS 0.44486f ; **FLOATING
C7504 a_2595_311.t1 VSS 3.27376f ; **FLOATING
C7505 a_2595_311.t2 VSS 5.04668f ; **FLOATING
C7506 a_2595_311.t3 VSS 1.20757f ; **FLOATING
C7507 a_2595_311.n0 VSS 26.8947f ; **FLOATING
C7508 a_2595_311.t0 VSS 0.49623f ; **FLOATING
C7509 a_3171_311.t2 VSS 5.05105f ; **FLOATING
C7510 a_3171_311.t3 VSS 1.21172f ; **FLOATING
C7511 a_3171_311.n0 VSS 29.8556f ; **FLOATING
C7512 a_3171_311.t1 VSS 4.61241f ; **FLOATING
C7513 a_3171_311.t0 VSS 0.4974f ; **FLOATING
C7514 a_3747_311.t2 VSS 3.11824f ; **FLOATING
C7515 a_3747_311.t3 VSS 0.75053f ; **FLOATING
C7516 a_3747_311.n0 VSS 20.0572f ; **FLOATING
C7517 a_3747_311.t1 VSS 3.7202f ; **FLOATING
C7518 a_3747_311.t0 VSS 0.30796f ; **FLOATING
C7519 VSS.t1044 VSS 3.22049f ; **FLOATING
C7520 VDD.n0 VSS 0.02512f ; **FLOATING
C7521 VDD.n1 VSS 0.19668f ; **FLOATING
C7522 VDD.n2 VSS 0.05623f ; **FLOATING
C7523 VDD.t374 VSS 47.7549f ; **FLOATING
C7524 VDD.n3 VSS 0.13672f ; **FLOATING
C7525 VDD.n4 VSS 0.01355f ; **FLOATING
C7526 VDD.n5 VSS 0.02512f ; **FLOATING
C7527 VDD.n6 VSS 0.02512f ; **FLOATING
C7528 VDD.n7 VSS 0.28864f ; **FLOATING
C7529 VDD.n9 VSS 0.02512f ; **FLOATING
C7530 VDD.n10 VSS 0.23547f ; **FLOATING
C7531 VDD.n12 VSS 0.02299f ; **FLOATING
C7532 VDD.n13 VSS 0.34096f ; **FLOATING
C7533 VDD.n14 VSS 0.09984f ; **FLOATING
C7534 VDD.n15 VSS 0.02299f ; **FLOATING
C7535 VDD.n16 VSS 0.33527f ; **FLOATING
C7536 VDD.n18 VSS 0.02512f ; **FLOATING
C7537 VDD.n19 VSS 0.19275f ; **FLOATING
C7538 VDD.n20 VSS 0.01401f ; **FLOATING
C7539 VDD.n21 VSS 0.18944f ; **FLOATING
C7540 VDD.n23 VSS 0.02848f ; **FLOATING
C7541 VDD.n24 VSS 0.16783f ; **FLOATING
C7542 VDD.n25 VSS 0.01956f ; **FLOATING
C7543 VDD.n27 VSS 0.02848f ; **FLOATING
C7544 VDD.n28 VSS 0.16735f ; **FLOATING
C7545 VDD.n29 VSS 0.01956f ; **FLOATING
C7546 VDD.n30 VSS 0.01907f ; **FLOATING
C7547 VDD.n31 VSS 0.29804f ; **FLOATING
C7548 VDD.t491 VSS 0.01992f ; **FLOATING
C7549 VDD.t480 VSS 0.01992f ; **FLOATING
C7550 VDD.n32 VSS 0.26605f ; **FLOATING
C7551 VDD.n33 VSS 0.42249f ; **FLOATING
C7552 VDD.t346 VSS 46.6263f ; **FLOATING
C7553 VDD.n34 VSS 0.02911f ; **FLOATING
C7554 VDD.n35 VSS 0.12905f ; **FLOATING
C7555 VDD.n36 VSS 0.16586f ; **FLOATING
C7556 VDD.n37 VSS 0.16554f ; **FLOATING
C7557 VDD.n38 VSS 0.04959f ; **FLOATING
C7558 VDD.n39 VSS 0.20829f ; **FLOATING
C7559 VDD.n40 VSS 0.02117f ; **FLOATING
C7560 VDD.n41 VSS 0.23369f ; **FLOATING
C7561 VDD.n42 VSS 0.2116f ; **FLOATING
C7562 VDD.n43 VSS 0.01277f ; **FLOATING
C7563 VDD.n44 VSS 0.2116f ; **FLOATING
C7564 VDD.n45 VSS 0.01277f ; **FLOATING
C7565 VDD.n46 VSS 0.2116f ; **FLOATING
C7566 VDD.n47 VSS 0.01277f ; **FLOATING
C7567 VDD.n48 VSS 0.2116f ; **FLOATING
C7568 VDD.n49 VSS 0.01277f ; **FLOATING
C7569 VDD.n50 VSS 0.2116f ; **FLOATING
C7570 VDD.n51 VSS 0.01277f ; **FLOATING
C7571 VDD.n52 VSS 0.02299f ; **FLOATING
C7572 VDD.n53 VSS 0.01987f ; **FLOATING
C7573 VDD.n54 VSS 0.19205f ; **FLOATING
C7574 VDD.n55 VSS 0.01046f ; **FLOATING
C7575 VDD.n56 VSS 0.02512f ; **FLOATING
C7576 VDD.n57 VSS 0.02019f ; **FLOATING
C7577 VDD.n58 VSS 0.01683f ; **FLOATING
C7578 VDD.n59 VSS 0.17629f ; **FLOATING
C7579 VDD.t459 VSS 0.01992f ; **FLOATING
C7580 VDD.n60 VSS 0.04774f ; **FLOATING
C7581 VDD.n61 VSS 0.0196f ; **FLOATING
C7582 VDD.t90 VSS 53.2035f ; **FLOATING
C7583 VDD.t5 VSS 53.2035f ; **FLOATING
C7584 VDD.t67 VSS 53.2035f ; **FLOATING
C7585 VDD.t0 VSS 53.2035f ; **FLOATING
C7586 VDD.t2 VSS 53.2035f ; **FLOATING
C7587 VDD.n62 VSS 0.23277f ; **FLOATING
C7588 VDD.n63 VSS 0.03072f ; **FLOATING
C7589 VDD.n65 VSS 0.03072f ; **FLOATING
C7590 VDD.n67 VSS 0.03374f ; **FLOATING
C7591 VDD.n69 VSS 0.03072f ; **FLOATING
C7592 VDD.n70 VSS 0.03374f ; **FLOATING
C7593 VDD.n72 VSS 0.03072f ; **FLOATING
C7594 VDD.n73 VSS 0.03072f ; **FLOATING
C7595 VDD.n75 VSS 0.01683f ; **FLOATING
C7596 VDD.n76 VSS 0.28183f ; **FLOATING
C7597 VDD.n77 VSS 0.02512f ; **FLOATING
C7598 VDD.n78 VSS 0.08533f ; **FLOATING
C7599 VDD.n80 VSS 0.02512f ; **FLOATING
C7600 VDD.n81 VSS 0.19665f ; **FLOATING
C7601 VDD.n82 VSS 0.01887f ; **FLOATING
C7602 VDD.n83 VSS 0.02512f ; **FLOATING
C7603 VDD.n84 VSS 0.19669f ; **FLOATING
C7604 VDD.n85 VSS 0.02512f ; **FLOATING
C7605 VDD.n86 VSS 0.19661f ; **FLOATING
C7606 VDD.n87 VSS 0.01775f ; **FLOATING
C7607 VDD.n88 VSS 0.02512f ; **FLOATING
C7608 VDD.n89 VSS 0.0992f ; **FLOATING
C7609 VDD.n91 VSS 0.16041f ; **FLOATING
C7610 VDD.n92 VSS 0.02512f ; **FLOATING
C7611 VDD.n93 VSS 0.09915f ; **FLOATING
C7612 VDD.n95 VSS 0.02512f ; **FLOATING
C7613 VDD.n96 VSS 0.19666f ; **FLOATING
C7614 VDD.n97 VSS 0.01884f ; **FLOATING
C7615 VDD.n98 VSS 0.02512f ; **FLOATING
C7616 VDD.n99 VSS 0.09915f ; **FLOATING
C7617 VDD.n101 VSS 0.02512f ; **FLOATING
C7618 VDD.n102 VSS 0.18687f ; **FLOATING
C7619 VDD.n104 VSS 0.02512f ; **FLOATING
C7620 VDD.n105 VSS 0.09922f ; **FLOATING
C7621 VDD.n107 VSS 0.02512f ; **FLOATING
C7622 VDD.n108 VSS 0.09918f ; **FLOATING
C7623 VDD.n110 VSS 0.02512f ; **FLOATING
C7624 VDD.n111 VSS 0.19665f ; **FLOATING
C7625 VDD.n112 VSS 0.01887f ; **FLOATING
C7626 VDD.n113 VSS 0.02512f ; **FLOATING
C7627 VDD.n114 VSS 0.09918f ; **FLOATING
C7628 VDD.n116 VSS 0.02512f ; **FLOATING
C7629 VDD.n117 VSS 0.09918f ; **FLOATING
C7630 VDD.n119 VSS 0.02512f ; **FLOATING
C7631 VDD.n120 VSS 0.0992f ; **FLOATING
C7632 VDD.n122 VSS 0.02512f ; **FLOATING
C7633 VDD.n123 VSS 0.09918f ; **FLOATING
C7634 VDD.n125 VSS 0.02512f ; **FLOATING
C7635 VDD.n126 VSS 0.19659f ; **FLOATING
C7636 VDD.n127 VSS 0.02512f ; **FLOATING
C7637 VDD.n128 VSS 0.09918f ; **FLOATING
C7638 VDD.n130 VSS 0.02512f ; **FLOATING
C7639 VDD.n131 VSS 0.19665f ; **FLOATING
C7640 VDD.n132 VSS 0.02512f ; **FLOATING
C7641 VDD.n133 VSS 0.09915f ; **FLOATING
C7642 VDD.n135 VSS 0.02512f ; **FLOATING
C7643 VDD.n136 VSS 0.0992f ; **FLOATING
C7644 VDD.n138 VSS 0.02512f ; **FLOATING
C7645 VDD.n139 VSS 0.09922f ; **FLOATING
C7646 VDD.n142 VSS 0.02512f ; **FLOATING
C7647 VDD.n143 VSS 0.09918f ; **FLOATING
C7648 VDD.n144 VSS 0.02512f ; **FLOATING
C7649 VDD.n145 VSS 0.08797f ; **FLOATING
C7650 VDD.n146 VSS 0.13576f ; **FLOATING
C7651 VDD.n147 VSS 0.01399f ; **FLOATING
C7652 VDD.n148 VSS 0.02512f ; **FLOATING
C7653 VDD.n149 VSS 0.09919f ; **FLOATING
C7654 VDD.n151 VSS 0.02512f ; **FLOATING
C7655 VDD.n152 VSS 0.02746f ; **FLOATING
C7656 VDD.n153 VSS 0.0433f ; **FLOATING
C7657 VDD.n154 VSS 0.02249f ; **FLOATING
C7658 VDD.n155 VSS 0.17625f ; **FLOATING
C7659 VDD.n156 VSS 0.02512f ; **FLOATING
C7660 VDD.n157 VSS 0.19664f ; **FLOATING
C7661 VDD.n158 VSS 0.01884f ; **FLOATING
C7662 VDD.n159 VSS 0.02512f ; **FLOATING
C7663 VDD.n160 VSS 0.19662f ; **FLOATING
C7664 VDD.n161 VSS 0.01888f ; **FLOATING
C7665 VDD.n162 VSS 0.02512f ; **FLOATING
C7666 VDD.n163 VSS 0.17577f ; **FLOATING
C7667 VDD.n164 VSS 0.02512f ; **FLOATING
C7668 VDD.n165 VSS 0.09916f ; **FLOATING
C7669 VDD.n167 VSS 0.0942f ; **FLOATING
C7670 VDD.n168 VSS 0.02512f ; **FLOATING
C7671 VDD.n169 VSS 0.09918f ; **FLOATING
C7672 VDD.n171 VSS 0.02512f ; **FLOATING
C7673 VDD.n172 VSS 0.09915f ; **FLOATING
C7674 VDD.n174 VSS 0.02512f ; **FLOATING
C7675 VDD.n175 VSS 0.04923f ; **FLOATING
C7676 VDD.n177 VSS 0.02512f ; **FLOATING
C7677 VDD.n178 VSS 0.09033f ; **FLOATING
C7678 VDD.n179 VSS 0.19655f ; **FLOATING
C7679 VDD.n180 VSS 0.01887f ; **FLOATING
C7680 VDD.n181 VSS 0.02512f ; **FLOATING
C7681 VDD.n182 VSS 0.0992f ; **FLOATING
C7682 VDD.n184 VSS 0.16926f ; **FLOATING
C7683 VDD.n185 VSS 0.02512f ; **FLOATING
C7684 VDD.n186 VSS 0.09915f ; **FLOATING
C7685 VDD.n188 VSS 0.02512f ; **FLOATING
C7686 VDD.n189 VSS 0.24116f ; **FLOATING
C7687 VDD.n190 VSS 0.01886f ; **FLOATING
C7688 VDD.n191 VSS 0.02512f ; **FLOATING
C7689 VDD.n192 VSS 0.19664f ; **FLOATING
C7690 VDD.n193 VSS 0.02512f ; **FLOATING
C7691 VDD.n194 VSS 0.09918f ; **FLOATING
C7692 VDD.n196 VSS 0.02512f ; **FLOATING
C7693 VDD.n197 VSS 0.0992f ; **FLOATING
C7694 VDD.n199 VSS 0.02512f ; **FLOATING
C7695 VDD.n200 VSS 0.09918f ; **FLOATING
C7696 VDD.n202 VSS 0.02512f ; **FLOATING
C7697 VDD.n203 VSS 0.09915f ; **FLOATING
C7698 VDD.n205 VSS 0.08272f ; **FLOATING
C7699 VDD.n206 VSS 0.02512f ; **FLOATING
C7700 VDD.n207 VSS 0.09918f ; **FLOATING
C7701 VDD.n209 VSS 0.02512f ; **FLOATING
C7702 VDD.n210 VSS 0.09922f ; **FLOATING
C7703 VDD.n212 VSS 0.02512f ; **FLOATING
C7704 VDD.n213 VSS 0.09918f ; **FLOATING
C7705 VDD.n215 VSS 0.02512f ; **FLOATING
C7706 VDD.n216 VSS 0.0992f ; **FLOATING
C7707 VDD.n218 VSS 0.02512f ; **FLOATING
C7708 VDD.n219 VSS 0.09915f ; **FLOATING
C7709 VDD.n221 VSS 0.01708f ; **FLOATING
C7710 VDD.n222 VSS 0.01683f ; **FLOATING
C7711 VDD.n223 VSS 0.25458f ; **FLOATING
C7712 VDD.n225 VSS 0.02512f ; **FLOATING
C7713 VDD.n226 VSS 0.14161f ; **FLOATING
C7714 VDD.n227 VSS 0.0265f ; **FLOATING
C7715 VDD.n228 VSS 0.31365f ; **FLOATING
C7716 VDD.n229 VSS 0.02312f ; **FLOATING
C7717 VDD.n230 VSS 0.21722f ; **FLOATING
C7718 VDD.n231 VSS 0.02312f ; **FLOATING
C7719 VDD.n232 VSS 0.21722f ; **FLOATING
C7720 VDD.n233 VSS 0.02312f ; **FLOATING
C7721 VDD.n234 VSS 0.21722f ; **FLOATING
C7722 VDD.n235 VSS 0.02312f ; **FLOATING
C7723 VDD.n236 VSS 0.21722f ; **FLOATING
C7724 VDD.n237 VSS 0.02312f ; **FLOATING
C7725 VDD.n238 VSS 0.21722f ; **FLOATING
C7726 VDD.n239 VSS 0.02512f ; **FLOATING
C7727 VDD.n240 VSS 0.14698f ; **FLOATING
C7728 VDD.n241 VSS 0.14231f ; **FLOATING
C7729 VDD.n242 VSS 0.19074f ; **FLOATING
C7730 VDD.n243 VSS 0.23873f ; **FLOATING
C7731 VDD.n245 VSS 0.14231f ; **FLOATING
C7732 VDD.n246 VSS 0.19074f ; **FLOATING
C7733 VDD.n247 VSS 0.23873f ; **FLOATING
C7734 VDD.n249 VSS 0.14231f ; **FLOATING
C7735 VDD.n250 VSS 0.19074f ; **FLOATING
C7736 VDD.n251 VSS 0.23873f ; **FLOATING
C7737 VDD.n253 VSS 0.14231f ; **FLOATING
C7738 VDD.n254 VSS 0.19074f ; **FLOATING
C7739 VDD.n255 VSS 0.23873f ; **FLOATING
C7740 VDD.n257 VSS 0.14231f ; **FLOATING
C7741 VDD.n258 VSS 0.19074f ; **FLOATING
C7742 VDD.n259 VSS 0.23873f ; **FLOATING
C7743 VDD.n261 VSS 0.01808f ; **FLOATING
C7744 VDD.n262 VSS 0.16114f ; **FLOATING
C7745 VDD.n263 VSS 0.01808f ; **FLOATING
C7746 VDD.n264 VSS 0.16114f ; **FLOATING
C7747 VDD.n265 VSS 0.01808f ; **FLOATING
C7748 VDD.n266 VSS 0.16114f ; **FLOATING
C7749 VDD.n267 VSS 0.01808f ; **FLOATING
C7750 VDD.n268 VSS 0.16114f ; **FLOATING
C7751 VDD.n269 VSS 0.01808f ; **FLOATING
C7752 VDD.n270 VSS 0.16114f ; **FLOATING
C7753 VDD.n271 VSS 0.08992f ; **FLOATING
C7754 VDD.n272 VSS 0.07386f ; **FLOATING
C7755 VDD.n273 VSS 0.21384f ; **FLOATING
C7756 VDD.n275 VSS 0.07386f ; **FLOATING
C7757 VDD.n276 VSS 0.21384f ; **FLOATING
C7758 VDD.n278 VSS 0.07386f ; **FLOATING
C7759 VDD.n279 VSS 0.21384f ; **FLOATING
C7760 VDD.n281 VSS 0.07386f ; **FLOATING
C7761 VDD.n282 VSS 0.21384f ; **FLOATING
C7762 VDD.n284 VSS 0.07386f ; **FLOATING
C7763 VDD.n285 VSS 0.21384f ; **FLOATING
C7764 VDD.n287 VSS 0.19177f ; **FLOATING
C7765 VDD.n288 VSS 0.19175f ; **FLOATING
C7766 VDD.n289 VSS 0.08884f ; **FLOATING
C7767 VDD.n290 VSS 0.19175f ; **FLOATING
C7768 VDD.n291 VSS 0.20234f ; **FLOATING
C7769 VDD.n292 VSS 0.12418f ; **FLOATING
C7770 VDD.n293 VSS 0.19175f ; **FLOATING
C7771 VDD.n294 VSS 0.19175f ; **FLOATING
C7772 VDD.n295 VSS 0.19177f ; **FLOATING
C7773 VDD.n296 VSS 0.19175f ; **FLOATING
C7774 VDD.n297 VSS 0.08884f ; **FLOATING
C7775 VDD.n298 VSS 0.19175f ; **FLOATING
C7776 VDD.n299 VSS 0.20234f ; **FLOATING
C7777 VDD.n300 VSS 0.12418f ; **FLOATING
C7778 VDD.n301 VSS 0.19175f ; **FLOATING
C7779 VDD.n302 VSS 0.19175f ; **FLOATING
C7780 VDD.n303 VSS 0.19177f ; **FLOATING
C7781 VDD.n304 VSS 0.19175f ; **FLOATING
C7782 VDD.n305 VSS 0.08884f ; **FLOATING
C7783 VDD.n306 VSS 0.19175f ; **FLOATING
C7784 VDD.n307 VSS 0.20234f ; **FLOATING
C7785 VDD.n308 VSS 0.12418f ; **FLOATING
C7786 VDD.n309 VSS 0.19175f ; **FLOATING
C7787 VDD.n310 VSS 0.19175f ; **FLOATING
C7788 VDD.n311 VSS 0.19177f ; **FLOATING
C7789 VDD.n312 VSS 0.19175f ; **FLOATING
C7790 VDD.n313 VSS 0.08884f ; **FLOATING
C7791 VDD.n314 VSS 0.19175f ; **FLOATING
C7792 VDD.n315 VSS 0.20234f ; **FLOATING
C7793 VDD.n316 VSS 0.12418f ; **FLOATING
C7794 VDD.n317 VSS 0.19175f ; **FLOATING
C7795 VDD.n318 VSS 0.19175f ; **FLOATING
C7796 VDD.n319 VSS 0.19177f ; **FLOATING
C7797 VDD.n320 VSS 0.19175f ; **FLOATING
C7798 VDD.n321 VSS 0.08884f ; **FLOATING
C7799 VDD.n322 VSS 0.19175f ; **FLOATING
C7800 VDD.n323 VSS 0.20234f ; **FLOATING
C7801 VDD.n324 VSS 0.12418f ; **FLOATING
C7802 VDD.n325 VSS 0.19175f ; **FLOATING
C7803 VDD.n326 VSS 0.19175f ; **FLOATING
C7804 VDD.n328 VSS 0.15485f ; **FLOATING
C7805 VDD.n329 VSS 0.12416f ; **FLOATING
C7806 VDD.n331 VSS 0.15485f ; **FLOATING
C7807 VDD.n333 VSS 0.15485f ; **FLOATING
C7808 VDD.n334 VSS 0.12416f ; **FLOATING
C7809 VDD.n336 VSS 0.15485f ; **FLOATING
C7810 VDD.n338 VSS 0.15485f ; **FLOATING
C7811 VDD.n339 VSS 0.12416f ; **FLOATING
C7812 VDD.n341 VSS 0.15485f ; **FLOATING
C7813 VDD.n343 VSS 0.15485f ; **FLOATING
C7814 VDD.n344 VSS 0.12416f ; **FLOATING
C7815 VDD.n346 VSS 0.15485f ; **FLOATING
C7816 VDD.n348 VSS 0.15485f ; **FLOATING
C7817 VDD.n349 VSS 0.12416f ; **FLOATING
C7818 VDD.n351 VSS 0.15485f ; **FLOATING
C7819 VDD.n353 VSS 0.15485f ; **FLOATING
C7820 VDD.n354 VSS 0.12416f ; **FLOATING
C7821 VDD.n356 VSS 0.15485f ; **FLOATING
C7822 VDD.n358 VSS 0.15485f ; **FLOATING
C7823 VDD.n359 VSS 0.12416f ; **FLOATING
C7824 VDD.n361 VSS 0.15485f ; **FLOATING
C7825 VDD.n363 VSS 0.15485f ; **FLOATING
C7826 VDD.n364 VSS 0.12416f ; **FLOATING
C7827 VDD.n366 VSS 0.15485f ; **FLOATING
C7828 VDD.n368 VSS 0.15485f ; **FLOATING
C7829 VDD.n369 VSS 0.12416f ; **FLOATING
C7830 VDD.n371 VSS 0.15485f ; **FLOATING
C7831 VDD.n373 VSS 0.15485f ; **FLOATING
C7832 VDD.n374 VSS 0.12416f ; **FLOATING
C7833 VDD.n376 VSS 0.15485f ; **FLOATING
C7834 VDD.n378 VSS 0.15485f ; **FLOATING
C7835 VDD.n379 VSS 0.12416f ; **FLOATING
C7836 VDD.n381 VSS 0.15485f ; **FLOATING
C7837 VDD.n383 VSS 0.15485f ; **FLOATING
C7838 VDD.n384 VSS 0.12416f ; **FLOATING
C7839 VDD.n386 VSS 0.15485f ; **FLOATING
C7840 VDD.n388 VSS 0.15485f ; **FLOATING
C7841 VDD.n389 VSS 0.12416f ; **FLOATING
C7842 VDD.n391 VSS 0.15485f ; **FLOATING
C7843 VDD.n393 VSS 0.15485f ; **FLOATING
C7844 VDD.n394 VSS 0.12416f ; **FLOATING
C7845 VDD.n396 VSS 0.15485f ; **FLOATING
C7846 VDD.n398 VSS 0.15485f ; **FLOATING
C7847 VDD.n399 VSS 0.12416f ; **FLOATING
C7848 VDD.n401 VSS 0.15485f ; **FLOATING
C7849 VDD.n402 VSS 0.14231f ; **FLOATING
C7850 VDD.n403 VSS 0.20231f ; **FLOATING
C7851 VDD.n405 VSS 0.14231f ; **FLOATING
C7852 VDD.n406 VSS 0.20231f ; **FLOATING
C7853 VDD.n408 VSS 0.14231f ; **FLOATING
C7854 VDD.n409 VSS 0.20231f ; **FLOATING
C7855 VDD.n411 VSS 0.14231f ; **FLOATING
C7856 VDD.n412 VSS 0.20231f ; **FLOATING
C7857 VDD.n414 VSS 0.14231f ; **FLOATING
C7858 VDD.n415 VSS 0.20231f ; **FLOATING
C7859 VDD.n418 VSS 0.14231f ; **FLOATING
C7860 VDD.n419 VSS 0.20234f ; **FLOATING
C7861 VDD.n421 VSS 0.14231f ; **FLOATING
C7862 VDD.n422 VSS 0.20234f ; **FLOATING
C7863 VDD.n423 VSS 0.14231f ; **FLOATING
C7864 VDD.n426 VSS 0.14231f ; **FLOATING
C7865 VDD.n427 VSS 0.20234f ; **FLOATING
C7866 VDD.n429 VSS 0.14231f ; **FLOATING
C7867 VDD.n430 VSS 0.20234f ; **FLOATING
C7868 VDD.n432 VSS 0.14231f ; **FLOATING
C7869 VDD.n433 VSS 0.20234f ; **FLOATING
C7870 VDD.n434 VSS 0.14231f ; **FLOATING
C7871 VDD.n437 VSS 0.14231f ; **FLOATING
C7872 VDD.n438 VSS 0.20234f ; **FLOATING
C7873 VDD.n439 VSS 0.02512f ; **FLOATING
C7874 VDD.n440 VSS 0.18267f ; **FLOATING
C7875 VDD.n441 VSS 0.16035f ; **FLOATING
C7876 VDD.n442 VSS 0.02741f ; **FLOATING
C7877 VDD.n443 VSS 0.02512f ; **FLOATING
C7878 VDD.n444 VSS 0.17309f ; **FLOATING
C7879 VDD.n445 VSS 0.03627f ; **FLOATING
C7880 VDD.n446 VSS 0.02512f ; **FLOATING
C7881 VDD.n447 VSS 0.02512f ; **FLOATING
C7882 VDD.n448 VSS 0.15941f ; **FLOATING
C7883 VDD.n449 VSS 0.02512f ; **FLOATING
C7884 VDD.n450 VSS 0.1604f ; **FLOATING
C7885 VDD.n451 VSS 0.09346f ; **FLOATING
C7886 VDD.n452 VSS 0.03621f ; **FLOATING
C7887 VDD.n453 VSS 0.02512f ; **FLOATING
C7888 VDD.n454 VSS 0.16043f ; **FLOATING
C7889 VDD.n455 VSS 0.09346f ; **FLOATING
C7890 VDD.n456 VSS 0.03621f ; **FLOATING
C7891 VDD.n457 VSS 0.02512f ; **FLOATING
C7892 VDD.n458 VSS 0.16038f ; **FLOATING
C7893 VDD.n459 VSS 0.16038f ; **FLOATING
C7894 VDD.n460 VSS 0.02738f ; **FLOATING
C7895 VDD.n461 VSS 0.02512f ; **FLOATING
C7896 VDD.n462 VSS 0.16306f ; **FLOATING
C7897 VDD.n463 VSS 0.03627f ; **FLOATING
C7898 VDD.n464 VSS 0.02512f ; **FLOATING
C7899 VDD.n465 VSS 0.18312f ; **FLOATING
C7900 VDD.n466 VSS 0.02742f ; **FLOATING
C7901 VDD.n467 VSS 0.02512f ; **FLOATING
C7902 VDD.n468 VSS 0.16916f ; **FLOATING
C7903 VDD.n469 VSS 0.05072f ; **FLOATING
C7904 VDD.n470 VSS 0.16039f ; **FLOATING
C7905 VDD.n471 VSS 0.02742f ; **FLOATING
C7906 VDD.n472 VSS 0.02512f ; **FLOATING
C7907 VDD.n473 VSS 0.16917f ; **FLOATING
C7908 VDD.n474 VSS 0.03627f ; **FLOATING
C7909 VDD.n475 VSS 0.02512f ; **FLOATING
C7910 VDD.n476 VSS 0.16037f ; **FLOATING
C7911 VDD.n477 VSS 0.02741f ; **FLOATING
C7912 VDD.n478 VSS 0.02512f ; **FLOATING
C7913 VDD.n479 VSS 0.0827f ; **FLOATING
C7914 VDD.n480 VSS 0.03625f ; **FLOATING
C7915 VDD.n481 VSS 0.02512f ; **FLOATING
C7916 VDD.n482 VSS 0.03627f ; **FLOATING
C7917 VDD.n483 VSS 0.02512f ; **FLOATING
C7918 VDD.n484 VSS 0.16036f ; **FLOATING
C7919 VDD.n485 VSS 0.03626f ; **FLOATING
C7920 VDD.n486 VSS 0.02512f ; **FLOATING
C7921 VDD.n487 VSS 0.16037f ; **FLOATING
C7922 VDD.n488 VSS 0.02512f ; **FLOATING
C7923 VDD.n489 VSS 0.17781f ; **FLOATING
C7924 VDD.n490 VSS 0.02743f ; **FLOATING
C7925 VDD.n491 VSS 0.02512f ; **FLOATING
C7926 VDD.n492 VSS 0.15944f ; **FLOATING
C7927 VDD.n494 VSS 0.09241f ; **FLOATING
C7928 VDD.n496 VSS 0.14231f ; **FLOATING
C7929 VDD.n497 VSS 0.20234f ; **FLOATING
C7930 VDD.n499 VSS 0.14231f ; **FLOATING
C7931 VDD.n500 VSS 0.20234f ; **FLOATING
C7932 VDD.n501 VSS 0.14231f ; **FLOATING
C7933 VDD.n504 VSS 0.14231f ; **FLOATING
C7934 VDD.n505 VSS 0.20234f ; **FLOATING
C7935 VDD.n506 VSS 0.09241f ; **FLOATING
C7936 VDD.n508 VSS 0.14231f ; **FLOATING
C7937 VDD.n509 VSS 0.20234f ; **FLOATING
C7938 VDD.n511 VSS 0.14231f ; **FLOATING
C7939 VDD.n512 VSS 0.20234f ; **FLOATING
C7940 VDD.n513 VSS 0.14231f ; **FLOATING
C7941 VDD.n516 VSS 0.14231f ; **FLOATING
C7942 VDD.n517 VSS 0.20234f ; **FLOATING
C7943 VDD.n519 VSS 0.14231f ; **FLOATING
C7944 VDD.n520 VSS 0.20234f ; **FLOATING
C7945 VDD.n522 VSS 0.14231f ; **FLOATING
C7946 VDD.n523 VSS 0.20234f ; **FLOATING
C7947 VDD.n524 VSS 0.14231f ; **FLOATING
C7948 VDD.n527 VSS 0.14231f ; **FLOATING
C7949 VDD.n528 VSS 0.20234f ; **FLOATING
C7950 VDD.n529 VSS 0.0363f ; **FLOATING
C7951 VDD.n530 VSS 0.02512f ; **FLOATING
C7952 VDD.n531 VSS 0.16034f ; **FLOATING
C7953 VDD.n532 VSS 0.09417f ; **FLOATING
C7954 VDD.n533 VSS 0.03627f ; **FLOATING
C7955 VDD.n534 VSS 0.02512f ; **FLOATING
C7956 VDD.n535 VSS 0.16039f ; **FLOATING
C7957 VDD.n536 VSS 0.09343f ; **FLOATING
C7958 VDD.n537 VSS 0.03627f ; **FLOATING
C7959 VDD.n538 VSS 0.02512f ; **FLOATING
C7960 VDD.n539 VSS 0.16041f ; **FLOATING
C7961 VDD.n540 VSS 0.1604f ; **FLOATING
C7962 VDD.n541 VSS 0.02739f ; **FLOATING
C7963 VDD.n542 VSS 0.02512f ; **FLOATING
C7964 VDD.n543 VSS 0.16926f ; **FLOATING
C7965 VDD.n544 VSS 0.0827f ; **FLOATING
C7966 VDD.n545 VSS 0.03625f ; **FLOATING
C7967 VDD.n546 VSS 0.02512f ; **FLOATING
C7968 VDD.n547 VSS 0.02512f ; **FLOATING
C7969 VDD.n548 VSS 0.1604f ; **FLOATING
C7970 VDD.n549 VSS 0.0363f ; **FLOATING
C7971 VDD.n550 VSS 0.02512f ; **FLOATING
C7972 VDD.n551 VSS 0.15412f ; **FLOATING
C7973 VDD.n552 VSS 0.03626f ; **FLOATING
C7974 VDD.n553 VSS 0.02512f ; **FLOATING
C7975 VDD.n554 VSS 0.16038f ; **FLOATING
C7976 VDD.n555 VSS 0.02512f ; **FLOATING
C7977 VDD.n556 VSS 0.16039f ; **FLOATING
C7978 VDD.n557 VSS 0.08273f ; **FLOATING
C7979 VDD.n558 VSS 0.03623f ; **FLOATING
C7980 VDD.n559 VSS 0.02512f ; **FLOATING
C7981 VDD.n560 VSS 0.16038f ; **FLOATING
C7982 VDD.n561 VSS 0.03625f ; **FLOATING
C7983 VDD.n562 VSS 0.02512f ; **FLOATING
C7984 VDD.n563 VSS 0.15063f ; **FLOATING
C7985 VDD.n564 VSS 0.02512f ; **FLOATING
C7986 VDD.n565 VSS 0.16037f ; **FLOATING
C7987 VDD.n566 VSS 0.02512f ; **FLOATING
C7988 VDD.n567 VSS 0.15552f ; **FLOATING
C7989 VDD.n568 VSS 0.02512f ; **FLOATING
C7990 VDD.n569 VSS 0.16035f ; **FLOATING
C7991 VDD.n570 VSS 0.02512f ; **FLOATING
C7992 VDD.n571 VSS 0.16923f ; **FLOATING
C7993 VDD.n572 VSS 0.02512f ; **FLOATING
C7994 VDD.n573 VSS 0.16033f ; **FLOATING
C7995 VDD.n574 VSS 0.02512f ; **FLOATING
C7996 VDD.n575 VSS 0.17781f ; **FLOATING
C7997 VDD.n576 VSS 0.02512f ; **FLOATING
C7998 VDD.n577 VSS 0.02512f ; **FLOATING
C7999 VDD.n578 VSS 0.16922f ; **FLOATING
C8000 VDD.n579 VSS 0.02512f ; **FLOATING
C8001 VDD.n580 VSS 0.17775f ; **FLOATING
C8002 VDD.t373 VSS 46.6242f ; **FLOATING
C8003 VDD.n581 VSS 0.05149f ; **FLOATING
C8004 VDD.n582 VSS 0.0489f ; **FLOATING
C8005 VDD.n583 VSS 0.14874f ; **FLOATING
C8006 VDD.n584 VSS 0.05149f ; **FLOATING
C8007 VDD.n585 VSS 0.04904f ; **FLOATING
C8008 VDD.n586 VSS 0.14861f ; **FLOATING
C8009 VDD.n587 VSS 0.07931f ; **FLOATING
C8010 VDD.n588 VSS 0.0274f ; **FLOATING
C8011 VDD.n589 VSS 0.02987f ; **FLOATING
C8012 VDD.n590 VSS 0.05149f ; **FLOATING
C8013 VDD.n591 VSS 0.1491f ; **FLOATING
C8014 VDD.n592 VSS 0.05149f ; **FLOATING
C8015 VDD.n593 VSS 0.02512f ; **FLOATING
C8016 VDD.n594 VSS 0.14861f ; **FLOATING
C8017 VDD.n595 VSS 0.05143f ; **FLOATING
C8018 VDD.n596 VSS 0.04909f ; **FLOATING
C8019 VDD.n597 VSS 0.14908f ; **FLOATING
C8020 VDD.n598 VSS 0.02742f ; **FLOATING
C8021 VDD.n599 VSS 0.09127f ; **FLOATING
C8022 VDD.n600 VSS 0.02741f ; **FLOATING
C8023 VDD.n601 VSS 0.02741f ; **FLOATING
C8024 VDD.n602 VSS 0.02742f ; **FLOATING
C8025 VDD.n603 VSS 0.02742f ; **FLOATING
C8026 VDD.n604 VSS 0.02742f ; **FLOATING
C8027 VDD.n605 VSS 0.02743f ; **FLOATING
C8028 VDD.n606 VSS 0.02743f ; **FLOATING
C8029 VDD.n607 VSS 0.02741f ; **FLOATING
C8030 VDD.n608 VSS 0.02747f ; **FLOATING
C8031 VDD.n609 VSS 0.02742f ; **FLOATING
C8032 VDD.n610 VSS 0.02742f ; **FLOATING
C8033 VDD.n611 VSS 0.01754f ; **FLOATING
C8034 VDD.n612 VSS 0.02512f ; **FLOATING
C8035 VDD.n613 VSS 0.0534f ; **FLOATING
C8036 VDD.n615 VSS 0.06303f ; **FLOATING
C8037 VDD.n616 VSS 0.02512f ; **FLOATING
C8038 VDD.n617 VSS 0.0534f ; **FLOATING
C8039 VDD.t348 VSS 46.6242f ; **FLOATING
C8040 VDD.n619 VSS 0.01472f ; **FLOATING
C8041 VDD.n620 VSS 0.03625f ; **FLOATING
C8042 VDD.n621 VSS 0.03627f ; **FLOATING
C8043 VDD.n622 VSS 0.03623f ; **FLOATING
C8044 VDD.n623 VSS 0.03621f ; **FLOATING
C8045 VDD.n624 VSS 0.03625f ; **FLOATING
C8046 VDD.n625 VSS 0.01472f ; **FLOATING
C8047 VDD.n626 VSS 0.01472f ; **FLOATING
C8048 VDD.n627 VSS 0.01472f ; **FLOATING
C8049 VDD.n628 VSS 0.01472f ; **FLOATING
C8050 VDD.n629 VSS 0.03627f ; **FLOATING
C8051 VDD.n630 VSS 0.01472f ; **FLOATING
C8052 VDD.n631 VSS 0.02729f ; **FLOATING
C8053 VDD.n632 VSS 0.03625f ; **FLOATING
C8054 VDD.n633 VSS 0.03627f ; **FLOATING
C8055 VDD.n634 VSS 0.01472f ; **FLOATING
C8056 VDD.n635 VSS 0.0363f ; **FLOATING
C8057 VDD.n636 VSS 0.01472f ; **FLOATING
C8058 VDD.n637 VSS 0.0363f ; **FLOATING
C8059 VDD.n638 VSS 0.01472f ; **FLOATING
C8060 VDD.n639 VSS 0.03626f ; **FLOATING
C8061 VDD.n640 VSS 0.03619f ; **FLOATING
C8062 VDD.n641 VSS 0.03627f ; **FLOATING
C8063 VDD.n642 VSS 0.03626f ; **FLOATING
C8064 VDD.n643 VSS 0.03627f ; **FLOATING
C8065 VDD.n644 VSS 0.03619f ; **FLOATING
C8066 VDD.n645 VSS 0.03627f ; **FLOATING
C8067 VDD.n646 VSS 0.01472f ; **FLOATING
C8068 VDD.n647 VSS 0.01472f ; **FLOATING
C8069 VDD.n648 VSS 0.01472f ; **FLOATING
C8070 VDD.n649 VSS 0.03625f ; **FLOATING
C8071 VDD.n650 VSS 0.01515f ; **FLOATING
C8072 VDD.n651 VSS 0.0363f ; **FLOATING
C8073 VDD.n652 VSS 0.0363f ; **FLOATING
C8074 VDD.n653 VSS 0.14043f ; **FLOATING
C8075 VDD.t381 VSS 8.81334f ; **FLOATING
C8076 VDD.n654 VSS 0.01472f ; **FLOATING
C8077 VDD.n655 VSS 0.01472f ; **FLOATING
C8078 VDD.n656 VSS 0.03625f ; **FLOATING
C8079 VDD.n657 VSS 0.03627f ; **FLOATING
C8080 VDD.n658 VSS 0.01472f ; **FLOATING
C8081 VDD.n659 VSS 0.01472f ; **FLOATING
C8082 VDD.n660 VSS 0.05422f ; **FLOATING
C8083 VDD.n661 VSS 0.01472f ; **FLOATING
C8084 VDD.n663 VSS 0.05439f ; **FLOATING
C8085 VDD.n666 VSS 0.05439f ; **FLOATING
C8086 VDD.n670 VSS 0.01472f ; **FLOATING
C8087 VDD.n674 VSS 0.05439f ; **FLOATING
C8088 VDD.n677 VSS 0.05439f ; **FLOATING
C8089 VDD.n682 VSS 0.05439f ; **FLOATING
C8090 VDD.n685 VSS 0.05439f ; **FLOATING
C8091 VDD.n690 VSS 0.05439f ; **FLOATING
C8092 VDD.n697 VSS 0.05439f ; **FLOATING
C8093 VDD.n700 VSS 0.05439f ; **FLOATING
C8094 VDD.t814 VSS 0.03928f ; **FLOATING
C8095 VDD.t914 VSS 0.03928f ; **FLOATING
C8096 VDD.n702 VSS 0.13414f ; **FLOATING
C8097 VDD.n703 VSS 0.01687f ; **FLOATING
C8098 VDD.t1008 VSS 0.04751f ; **FLOATING
C8099 VDD.t912 VSS 0.04751f ; **FLOATING
C8100 VDD.n704 VSS 0.15126f ; **FLOATING
C8101 VDD.n705 VSS 0.08006f ; **FLOATING
C8102 VDD.t457 VSS 0.03387f ; **FLOATING
C8103 VDD.t455 VSS 0.02445f ; **FLOATING
C8104 VDD.t458 VSS 0.03785f ; **FLOATING
C8105 VDD.t460 VSS 0.03419f ; **FLOATING
C8106 VDD.t627 VSS 0.03387f ; **FLOATING
C8107 VDD.n706 VSS 0.05739f ; **FLOATING
C8108 VDD.t462 VSS 0.03387f ; **FLOATING
C8109 VDD.n707 VSS 0.02299f ; **FLOATING
C8110 VDD.t461 VSS 0.02445f ; **FLOATING
C8111 VDD.t463 VSS 0.03785f ; **FLOATING
C8112 VDD.n708 VSS 0.02062f ; **FLOATING
C8113 VDD.t464 VSS 0.01992f ; **FLOATING
C8114 VDD.t465 VSS 0.03387f ; **FLOATING
C8115 VDD.t1531 VSS 0.03718f ; **FLOATING
C8116 VDD.t1502 VSS 0.02529f ; **FLOATING
C8117 VDD.t456 VSS 3.55437f ; **FLOATING
C8118 VDD.n709 VSS 0.69209f ; **FLOATING
C8119 VDD.n710 VSS 0.1231f ; **FLOATING
C8120 VDD.n711 VSS 0.02908f ; **FLOATING
C8121 VDD.t408 VSS 0.02793f ; **FLOATING
C8122 VDD.t404 VSS 0.02793f ; **FLOATING
C8123 VDD.n712 VSS 0.08293f ; **FLOATING
C8124 VDD.n713 VSS 0.03935f ; **FLOATING
C8125 VDD.t384 VSS 0.01295f ; **FLOATING
C8126 VDD.t403 VSS 0.06445f ; **FLOATING
C8127 VDD.n714 VSS 0.02611f ; **FLOATING
C8128 VDD.t846 VSS 0.01295f ; **FLOATING
C8129 VDD.t406 VSS 0.06445f ; **FLOATING
C8130 VDD.n715 VSS 0.02611f ; **FLOATING
C8131 VDD.n716 VSS 0.05763f ; **FLOATING
C8132 VDD.n717 VSS 0.01532f ; **FLOATING
C8133 VDD.t841 VSS 0.03797f ; **FLOATING
C8134 VDD.t1501 VSS 0.03506f ; **FLOATING
C8135 VDD.t356 VSS 0.03928f ; **FLOATING
C8136 VDD.t357 VSS 0.01295f ; **FLOATING
C8137 VDD.t537 VSS 0.06445f ; **FLOATING
C8138 VDD.n718 VSS 0.02611f ; **FLOATING
C8139 VDD.n719 VSS 0.07856f ; **FLOATING
C8140 VDD.t867 VSS 0.02793f ; **FLOATING
C8141 VDD.n720 VSS 0.1572f ; **FLOATING
C8142 VDD.n721 VSS 0.03938f ; **FLOATING
C8143 VDD.n722 VSS 0.01677f ; **FLOATING
C8144 VDD.n723 VSS 0.03813f ; **FLOATING
C8145 VDD.n724 VSS 0.03801f ; **FLOATING
C8146 VDD.n725 VSS 0.03322f ; **FLOATING
C8147 VDD.n726 VSS 0.03811f ; **FLOATING
C8148 VDD.n727 VSS 0.01661f ; **FLOATING
C8149 VDD.n728 VSS 0.03152f ; **FLOATING
C8150 VDD.n729 VSS 0.07611f ; **FLOATING
C8151 VDD.n730 VSS 0.0514f ; **FLOATING
C8152 VDD.n731 VSS 0.05152f ; **FLOATING
C8153 VDD.n732 VSS 0.05152f ; **FLOATING
C8154 VDD.n733 VSS 0.05149f ; **FLOATING
C8155 VDD.n734 VSS 0.05156f ; **FLOATING
C8156 VDD.n735 VSS 0.0515f ; **FLOATING
C8157 VDD.n736 VSS 0.0514f ; **FLOATING
C8158 VDD.n737 VSS 0.05143f ; **FLOATING
C8159 VDD.n738 VSS 0.05145f ; **FLOATING
C8160 VDD.n739 VSS 0.0516f ; **FLOATING
C8161 VDD.n740 VSS 0.04263f ; **FLOATING
C8162 VDD.n741 VSS 0.08373f ; **FLOATING
C8163 VDD.n743 VSS 0.05148f ; **FLOATING
C8164 VDD.n744 VSS 0.05156f ; **FLOATING
C8165 VDD.n745 VSS 0.05141f ; **FLOATING
C8166 VDD.n746 VSS 0.05155f ; **FLOATING
C8167 VDD.n747 VSS 0.05138f ; **FLOATING
C8168 VDD.n748 VSS 0.0514f ; **FLOATING
C8169 VDD.n749 VSS 0.05145f ; **FLOATING
C8170 VDD.n750 VSS 0.05149f ; **FLOATING
C8171 VDD.n751 VSS 0.0514f ; **FLOATING
C8172 VDD.n752 VSS 0.0514f ; **FLOATING
C8173 VDD.n753 VSS 0.0515f ; **FLOATING
C8174 VDD.n754 VSS 0.05142f ; **FLOATING
C8175 VDD.n755 VSS 0.05153f ; **FLOATING
C8176 VDD.n756 VSS 0.05145f ; **FLOATING
C8177 VDD.n757 VSS 0.0515f ; **FLOATING
C8178 VDD.n758 VSS 0.05144f ; **FLOATING
C8179 VDD.n759 VSS 0.05136f ; **FLOATING
C8180 VDD.n760 VSS 0.05143f ; **FLOATING
C8181 VDD.n761 VSS 0.02689f ; **FLOATING
C8182 VDD.t426 VSS 0.07104f ; **FLOATING
C8183 VDD.n763 VSS 0.0541f ; **FLOATING
C8184 VDD.n764 VSS 0.06321f ; **FLOATING
C8185 VDD.t429 VSS 0.03273f ; **FLOATING
C8186 VDD.n765 VSS 0.01669f ; **FLOATING
C8187 VDD.t431 VSS 0.03387f ; **FLOATING
C8188 VDD.n766 VSS 0.02249f ; **FLOATING
C8189 VDD.n767 VSS 0.0744f ; **FLOATING
C8190 VDD.n769 VSS 0.03374f ; **FLOATING
C8191 VDD.t428 VSS 0.03785f ; **FLOATING
C8192 VDD.n770 VSS 0.02746f ; **FLOATING
C8193 VDD.n771 VSS 0.03456f ; **FLOATING
C8194 VDD.n772 VSS 0.01624f ; **FLOATING
C8195 VDD.t427 VSS 0.03387f ; **FLOATING
C8196 VDD.n773 VSS 0.04837f ; **FLOATING
C8197 VDD.n774 VSS 0.02512f ; **FLOATING
C8198 VDD.n775 VSS 0.03827f ; **FLOATING
C8199 VDD.n776 VSS 0.01513f ; **FLOATING
C8200 VDD.t372 VSS 0.03972f ; **FLOATING
C8201 VDD.n777 VSS 0.06306f ; **FLOATING
C8202 VDD.n778 VSS 0.0147f ; **FLOATING
C8203 VDD.t641 VSS 0.03387f ; **FLOATING
C8204 VDD.n779 VSS 0.0921f ; **FLOATING
C8205 VDD.n780 VSS 0.02512f ; **FLOATING
C8206 VDD.n781 VSS 0.06291f ; **FLOATING
C8207 VDD.n782 VSS 0.03631f ; **FLOATING
C8208 VDD.t512 VSS 0.03972f ; **FLOATING
C8209 VDD.n783 VSS 0.08267f ; **FLOATING
C8210 VDD.n784 VSS 0.01472f ; **FLOATING
C8211 VDD.t666 VSS 0.03387f ; **FLOATING
C8212 VDD.n785 VSS 0.11138f ; **FLOATING
C8213 VDD.n786 VSS 0.02512f ; **FLOATING
C8214 VDD.n787 VSS 0.06295f ; **FLOATING
C8215 VDD.n788 VSS 0.03629f ; **FLOATING
C8216 VDD.t925 VSS 0.03972f ; **FLOATING
C8217 VDD.n789 VSS 0.08267f ; **FLOATING
C8218 VDD.n790 VSS 0.01472f ; **FLOATING
C8219 VDD.t656 VSS 0.03387f ; **FLOATING
C8220 VDD.n791 VSS 0.11137f ; **FLOATING
C8221 VDD.n792 VSS 0.02512f ; **FLOATING
C8222 VDD.n793 VSS 0.06297f ; **FLOATING
C8223 VDD.n794 VSS 0.03625f ; **FLOATING
C8224 VDD.t1581 VSS 0.03972f ; **FLOATING
C8225 VDD.n795 VSS 0.08272f ; **FLOATING
C8226 VDD.n796 VSS 0.0147f ; **FLOATING
C8227 VDD.t653 VSS 0.03387f ; **FLOATING
C8228 VDD.n797 VSS 0.11126f ; **FLOATING
C8229 VDD.n798 VSS 0.02512f ; **FLOATING
C8230 VDD.n799 VSS 0.06293f ; **FLOATING
C8231 VDD.n800 VSS 0.03627f ; **FLOATING
C8232 VDD.t853 VSS 0.03972f ; **FLOATING
C8233 VDD.n801 VSS 0.08273f ; **FLOATING
C8234 VDD.n802 VSS 0.0147f ; **FLOATING
C8235 VDD.t663 VSS 0.03387f ; **FLOATING
C8236 VDD.n803 VSS 0.1113f ; **FLOATING
C8237 VDD.n804 VSS 0.02512f ; **FLOATING
C8238 VDD.n805 VSS 0.06291f ; **FLOATING
C8239 VDD.n806 VSS 0.03631f ; **FLOATING
C8240 VDD.t371 VSS 0.03972f ; **FLOATING
C8241 VDD.n807 VSS 0.08267f ; **FLOATING
C8242 VDD.n808 VSS 0.01472f ; **FLOATING
C8243 VDD.t665 VSS 0.03387f ; **FLOATING
C8244 VDD.n809 VSS 0.11128f ; **FLOATING
C8245 VDD.n810 VSS 0.02512f ; **FLOATING
C8246 VDD.n811 VSS 0.06292f ; **FLOATING
C8247 VDD.n812 VSS 0.03631f ; **FLOATING
C8248 VDD.t510 VSS 0.03972f ; **FLOATING
C8249 VDD.n813 VSS 0.08267f ; **FLOATING
C8250 VDD.n814 VSS 0.01472f ; **FLOATING
C8251 VDD.t655 VSS 0.03387f ; **FLOATING
C8252 VDD.n815 VSS 0.11127f ; **FLOATING
C8253 VDD.n816 VSS 0.02512f ; **FLOATING
C8254 VDD.n817 VSS 0.063f ; **FLOATING
C8255 VDD.n818 VSS 0.0362f ; **FLOATING
C8256 VDD.t1575 VSS 0.03972f ; **FLOATING
C8257 VDD.n819 VSS 0.08273f ; **FLOATING
C8258 VDD.n820 VSS 0.0147f ; **FLOATING
C8259 VDD.t664 VSS 0.03387f ; **FLOATING
C8260 VDD.n821 VSS 0.02512f ; **FLOATING
C8261 VDD.n822 VSS 0.03792f ; **FLOATING
C8262 VDD.n823 VSS 0.01153f ; **FLOATING
C8263 VDD.n824 VSS 0.06898f ; **FLOATING
C8264 VDD.n825 VSS 0.02535f ; **FLOATING
C8265 VDD.t923 VSS 0.03972f ; **FLOATING
C8266 VDD.n826 VSS 0.07295f ; **FLOATING
C8267 VDD.n827 VSS 0.01472f ; **FLOATING
C8268 VDD.t658 VSS 0.03387f ; **FLOATING
C8269 VDD.n828 VSS 0.11132f ; **FLOATING
C8270 VDD.n829 VSS 0.02512f ; **FLOATING
C8271 VDD.n830 VSS 0.06294f ; **FLOATING
C8272 VDD.n831 VSS 0.03627f ; **FLOATING
C8273 VDD.t924 VSS 0.03972f ; **FLOATING
C8274 VDD.n832 VSS 0.0827f ; **FLOATING
C8275 VDD.n833 VSS 0.01472f ; **FLOATING
C8276 VDD.t659 VSS 0.03387f ; **FLOATING
C8277 VDD.n834 VSS 0.11131f ; **FLOATING
C8278 VDD.n835 VSS 0.02512f ; **FLOATING
C8279 VDD.n836 VSS 0.06292f ; **FLOATING
C8280 VDD.n837 VSS 0.03631f ; **FLOATING
C8281 VDD.t1212 VSS 0.03972f ; **FLOATING
C8282 VDD.n838 VSS 0.08267f ; **FLOATING
C8283 VDD.n839 VSS 0.01472f ; **FLOATING
C8284 VDD.t660 VSS 0.03387f ; **FLOATING
C8285 VDD.n840 VSS 0.11132f ; **FLOATING
C8286 VDD.n841 VSS 0.02512f ; **FLOATING
C8287 VDD.n842 VSS 0.063f ; **FLOATING
C8288 VDD.n843 VSS 0.0362f ; **FLOATING
C8289 VDD.t1459 VSS 0.03972f ; **FLOATING
C8290 VDD.n844 VSS 0.0827f ; **FLOATING
C8291 VDD.n845 VSS 0.01472f ; **FLOATING
C8292 VDD.t661 VSS 0.03387f ; **FLOATING
C8293 VDD.n846 VSS 0.11133f ; **FLOATING
C8294 VDD.n847 VSS 0.02512f ; **FLOATING
C8295 VDD.n848 VSS 0.06292f ; **FLOATING
C8296 VDD.n849 VSS 0.03631f ; **FLOATING
C8297 VDD.t879 VSS 0.03972f ; **FLOATING
C8298 VDD.n850 VSS 0.0827f ; **FLOATING
C8299 VDD.n851 VSS 0.0147f ; **FLOATING
C8300 VDD.t662 VSS 0.03387f ; **FLOATING
C8301 VDD.n852 VSS 0.11133f ; **FLOATING
C8302 VDD.n853 VSS 0.02512f ; **FLOATING
C8303 VDD.n854 VSS 0.06296f ; **FLOATING
C8304 VDD.n855 VSS 0.03626f ; **FLOATING
C8305 VDD.t973 VSS 0.03972f ; **FLOATING
C8306 VDD.n856 VSS 0.08268f ; **FLOATING
C8307 VDD.n857 VSS 0.01472f ; **FLOATING
C8308 VDD.t654 VSS 0.03387f ; **FLOATING
C8309 VDD.n858 VSS 0.11128f ; **FLOATING
C8310 VDD.n859 VSS 0.02512f ; **FLOATING
C8311 VDD.n860 VSS 0.063f ; **FLOATING
C8312 VDD.n861 VSS 0.0362f ; **FLOATING
C8313 VDD.t1458 VSS 0.03972f ; **FLOATING
C8314 VDD.n862 VSS 0.0827f ; **FLOATING
C8315 VDD.n863 VSS 0.01472f ; **FLOATING
C8316 VDD.t657 VSS 0.03387f ; **FLOATING
C8317 VDD.n864 VSS 0.11134f ; **FLOATING
C8318 VDD.n865 VSS 0.02512f ; **FLOATING
C8319 VDD.n866 VSS 0.06298f ; **FLOATING
C8320 VDD.n867 VSS 0.03621f ; **FLOATING
C8321 VDD.t1078 VSS 0.03972f ; **FLOATING
C8322 VDD.n868 VSS 0.08275f ; **FLOATING
C8323 VDD.n869 VSS 0.0147f ; **FLOATING
C8324 VDD.t611 VSS 0.03387f ; **FLOATING
C8325 VDD.n870 VSS 0.11134f ; **FLOATING
C8326 VDD.n871 VSS 0.02512f ; **FLOATING
C8327 VDD.n872 VSS 0.06291f ; **FLOATING
C8328 VDD.n873 VSS 0.03631f ; **FLOATING
C8329 VDD.t507 VSS 0.03972f ; **FLOATING
C8330 VDD.n874 VSS 0.0827f ; **FLOATING
C8331 VDD.n875 VSS 0.0147f ; **FLOATING
C8332 VDD.t633 VSS 0.03387f ; **FLOATING
C8333 VDD.n876 VSS 0.11127f ; **FLOATING
C8334 VDD.n877 VSS 0.02512f ; **FLOATING
C8335 VDD.n878 VSS 0.06297f ; **FLOATING
C8336 VDD.n879 VSS 0.03621f ; **FLOATING
C8337 VDD.t508 VSS 0.03972f ; **FLOATING
C8338 VDD.n880 VSS 0.08272f ; **FLOATING
C8339 VDD.n881 VSS 0.01472f ; **FLOATING
C8340 VDD.t650 VSS 0.03387f ; **FLOATING
C8341 VDD.n882 VSS 0.11132f ; **FLOATING
C8342 VDD.n883 VSS 0.02512f ; **FLOATING
C8343 VDD.n884 VSS 0.06296f ; **FLOATING
C8344 VDD.n885 VSS 0.03625f ; **FLOATING
C8345 VDD.t972 VSS 0.03972f ; **FLOATING
C8346 VDD.n886 VSS 0.0827f ; **FLOATING
C8347 VDD.n887 VSS 0.01472f ; **FLOATING
C8348 VDD.t652 VSS 0.03387f ; **FLOATING
C8349 VDD.n888 VSS 0.11126f ; **FLOATING
C8350 VDD.n889 VSS 0.02512f ; **FLOATING
C8351 VDD.n890 VSS 0.06298f ; **FLOATING
C8352 VDD.n891 VSS 0.03621f ; **FLOATING
C8353 VDD.t1034 VSS 0.03972f ; **FLOATING
C8354 VDD.n892 VSS 0.08275f ; **FLOATING
C8355 VDD.n893 VSS 0.0147f ; **FLOATING
C8356 VDD.t651 VSS 0.03387f ; **FLOATING
C8357 VDD.n894 VSS 0.11121f ; **FLOATING
C8358 VDD.n895 VSS 0.02512f ; **FLOATING
C8359 VDD.n896 VSS 0.06299f ; **FLOATING
C8360 VDD.n897 VSS 0.0362f ; **FLOATING
C8361 VDD.t1270 VSS 0.03972f ; **FLOATING
C8362 VDD.n898 VSS 0.0827f ; **FLOATING
C8363 VDD.n899 VSS 0.01472f ; **FLOATING
C8364 VDD.t643 VSS 0.03387f ; **FLOATING
C8365 VDD.n900 VSS 0.07194f ; **FLOATING
C8366 VDD.n901 VSS 0.02512f ; **FLOATING
C8367 VDD.n902 VSS 0.03793f ; **FLOATING
C8368 VDD.n903 VSS 0.0113f ; **FLOATING
C8369 VDD.n904 VSS 0.06674f ; **FLOATING
C8370 VDD.n905 VSS 0.02569f ; **FLOATING
C8371 VDD.t555 VSS 0.03972f ; **FLOATING
C8372 VDD.n906 VSS 0.07293f ; **FLOATING
C8373 VDD.n907 VSS 0.01472f ; **FLOATING
C8374 VDD.t644 VSS 0.03387f ; **FLOATING
C8375 VDD.n908 VSS 0.1017f ; **FLOATING
C8376 VDD.n909 VSS 0.02512f ; **FLOATING
C8377 VDD.n910 VSS 0.06297f ; **FLOATING
C8378 VDD.n911 VSS 0.03625f ; **FLOATING
C8379 VDD.t920 VSS 0.03972f ; **FLOATING
C8380 VDD.n912 VSS 0.08272f ; **FLOATING
C8381 VDD.n913 VSS 0.0147f ; **FLOATING
C8382 VDD.t649 VSS 0.03387f ; **FLOATING
C8383 VDD.n914 VSS 0.11123f ; **FLOATING
C8384 VDD.n915 VSS 0.02512f ; **FLOATING
C8385 VDD.n916 VSS 0.06291f ; **FLOATING
C8386 VDD.n917 VSS 0.03631f ; **FLOATING
C8387 VDD.t553 VSS 0.03972f ; **FLOATING
C8388 VDD.n918 VSS 0.08267f ; **FLOATING
C8389 VDD.n919 VSS 0.01472f ; **FLOATING
C8390 VDD.t610 VSS 0.03387f ; **FLOATING
C8391 VDD.n920 VSS 0.11133f ; **FLOATING
C8392 VDD.n921 VSS 0.02512f ; **FLOATING
C8393 VDD.n922 VSS 0.06297f ; **FLOATING
C8394 VDD.n923 VSS 0.03625f ; **FLOATING
C8395 VDD.t369 VSS 0.03972f ; **FLOATING
C8396 VDD.n924 VSS 0.08272f ; **FLOATING
C8397 VDD.n925 VSS 0.0147f ; **FLOATING
C8398 VDD.t618 VSS 0.03387f ; **FLOATING
C8399 VDD.n926 VSS 0.11133f ; **FLOATING
C8400 VDD.n927 VSS 0.02512f ; **FLOATING
C8401 VDD.n928 VSS 0.06293f ; **FLOATING
C8402 VDD.n929 VSS 0.03627f ; **FLOATING
C8403 VDD.t1101 VSS 0.03972f ; **FLOATING
C8404 VDD.n930 VSS 0.0827f ; **FLOATING
C8405 VDD.n931 VSS 0.01472f ; **FLOATING
C8406 VDD.t636 VSS 0.03387f ; **FLOATING
C8407 VDD.n932 VSS 0.1113f ; **FLOATING
C8408 VDD.n933 VSS 0.02512f ; **FLOATING
C8409 VDD.n934 VSS 0.06297f ; **FLOATING
C8410 VDD.n935 VSS 0.03625f ; **FLOATING
C8411 VDD.t552 VSS 0.03972f ; **FLOATING
C8412 VDD.n936 VSS 0.08272f ; **FLOATING
C8413 VDD.n937 VSS 0.0147f ; **FLOATING
C8414 VDD.t638 VSS 0.03387f ; **FLOATING
C8415 VDD.n938 VSS 0.11124f ; **FLOATING
C8416 VDD.n939 VSS 0.02512f ; **FLOATING
C8417 VDD.n940 VSS 0.0629f ; **FLOATING
C8418 VDD.n941 VSS 0.0363f ; **FLOATING
C8419 VDD.t1099 VSS 0.03972f ; **FLOATING
C8420 VDD.n942 VSS 0.08272f ; **FLOATING
C8421 VDD.n943 VSS 0.0147f ; **FLOATING
C8422 VDD.t642 VSS 0.03387f ; **FLOATING
C8423 VDD.n944 VSS 0.11125f ; **FLOATING
C8424 VDD.n945 VSS 0.02512f ; **FLOATING
C8425 VDD.n946 VSS 0.06299f ; **FLOATING
C8426 VDD.n947 VSS 0.0362f ; **FLOATING
C8427 VDD.t1100 VSS 0.03972f ; **FLOATING
C8428 VDD.n948 VSS 0.0827f ; **FLOATING
C8429 VDD.n949 VSS 0.01472f ; **FLOATING
C8430 VDD.t635 VSS 0.03387f ; **FLOATING
C8431 VDD.n950 VSS 0.11123f ; **FLOATING
C8432 VDD.n951 VSS 0.02512f ; **FLOATING
C8433 VDD.n952 VSS 0.063f ; **FLOATING
C8434 VDD.n953 VSS 0.0362f ; **FLOATING
C8435 VDD.t1241 VSS 0.03972f ; **FLOATING
C8436 VDD.n954 VSS 0.0827f ; **FLOATING
C8437 VDD.n955 VSS 0.01472f ; **FLOATING
C8438 VDD.t625 VSS 0.03387f ; **FLOATING
C8439 VDD.n956 VSS 0.11124f ; **FLOATING
C8440 VDD.n957 VSS 0.02512f ; **FLOATING
C8441 VDD.n958 VSS 0.06297f ; **FLOATING
C8442 VDD.n959 VSS 0.03625f ; **FLOATING
C8443 VDD.t848 VSS 0.03972f ; **FLOATING
C8444 VDD.n960 VSS 0.08272f ; **FLOATING
C8445 VDD.n961 VSS 0.0147f ; **FLOATING
C8446 VDD.t629 VSS 0.03387f ; **FLOATING
C8447 VDD.n962 VSS 0.11133f ; **FLOATING
C8448 VDD.n963 VSS 0.02512f ; **FLOATING
C8449 VDD.n964 VSS 0.06294f ; **FLOATING
C8450 VDD.n965 VSS 0.03629f ; **FLOATING
C8451 VDD.t788 VSS 0.03972f ; **FLOATING
C8452 VDD.n966 VSS 0.0827f ; **FLOATING
C8453 VDD.n967 VSS 0.0147f ; **FLOATING
C8454 VDD.t631 VSS 0.03387f ; **FLOATING
C8455 VDD.n968 VSS 0.09983f ; **FLOATING
C8456 VDD.n969 VSS 0.02512f ; **FLOATING
C8457 VDD.n970 VSS 0.06581f ; **FLOATING
C8458 VDD.t425 VSS 0.03387f ; **FLOATING
C8459 VDD.t424 VSS 0.01993f ; **FLOATING
C8460 VDD.t423 VSS 0.03785f ; **FLOATING
C8461 VDD.t422 VSS 0.03387f ; **FLOATING
C8462 VDD.t421 VSS 0.02445f ; **FLOATING
C8463 VDD.t368 VSS 46.6265f ; **FLOATING
C8464 VDD.n971 VSS 0.41263f ; **FLOATING
C8465 VDD.n972 VSS 1.03404f ; **FLOATING
C8466 VDD.t416 VSS 0.03506f ; **FLOATING
C8467 VDD.t588 VSS 0.03506f ; **FLOATING
C8468 VDD.n973 VSS 0.08296f ; **FLOATING
C8469 VDD.t330 VSS 0.03148f ; **FLOATING
C8470 VDD.t1207 VSS 0.03506f ; **FLOATING
C8471 VDD.n974 VSS 0.06395f ; **FLOATING
C8472 VDD.n975 VSS 0.0136f ; **FLOATING
C8473 VDD.n976 VSS 0.02895f ; **FLOATING
C8474 VDD.t789 VSS 0.04602f ; **FLOATING
C8475 VDD.n977 VSS 0.08826f ; **FLOATING
C8476 VDD.n978 VSS 0.02582f ; **FLOATING
C8477 VDD.t1177 VSS 0.03506f ; **FLOATING
C8478 VDD.n979 VSS 0.09318f ; **FLOATING
C8479 VDD.n980 VSS 0.01229f ; **FLOATING
C8480 VDD.t1218 VSS 0.03908f ; **FLOATING
C8481 VDD.t1598 VSS 0.03908f ; **FLOATING
C8482 VDD.n981 VSS 0.01297f ; **FLOATING
C8483 VDD.t1366 VSS 0.03908f ; **FLOATING
C8484 VDD.t1427 VSS 0.03908f ; **FLOATING
C8485 VDD.n982 VSS 0.08331f ; **FLOATING
C8486 VDD.n983 VSS 0.01238f ; **FLOATING
C8487 VDD.n984 VSS 0.01826f ; **FLOATING
C8488 VDD.t353 VSS 0.03506f ; **FLOATING
C8489 VDD.t1464 VSS 0.03506f ; **FLOATING
C8490 VDD.n985 VSS 0.09793f ; **FLOATING
C8491 VDD.n986 VSS 0.01605f ; **FLOATING
C8492 VDD.t1211 VSS 0.02589f ; **FLOATING
C8493 VDD.t1416 VSS 0.02589f ; **FLOATING
C8494 VDD.n987 VSS 0.07458f ; **FLOATING
C8495 VDD.t1254 VSS 0.03461f ; **FLOATING
C8496 VDD.t1426 VSS 0.03461f ; **FLOATING
C8497 VDD.n988 VSS 0.06957f ; **FLOATING
C8498 VDD.n989 VSS 0.01714f ; **FLOATING
C8499 VDD.t417 VSS 0.02589f ; **FLOATING
C8500 VDD.t590 VSS 0.02589f ; **FLOATING
C8501 VDD.t1217 VSS 0.03461f ; **FLOATING
C8502 VDD.t1433 VSS 0.03461f ; **FLOATING
C8503 VDD.t352 VSS 0.02589f ; **FLOATING
C8504 VDD.t1466 VSS 0.02589f ; **FLOATING
C8505 VDD.n990 VSS 0.07942f ; **FLOATING
C8506 VDD.n991 VSS 0.01206f ; **FLOATING
C8507 VDD.t1210 VSS 0.03461f ; **FLOATING
C8508 VDD.t1417 VSS 0.03461f ; **FLOATING
C8509 VDD.n992 VSS 0.07004f ; **FLOATING
C8510 VDD.n993 VSS 0.01711f ; **FLOATING
C8511 VDD.t1246 VSS 0.03908f ; **FLOATING
C8512 VDD.t1596 VSS 0.03908f ; **FLOATING
C8513 VDD.n994 VSS 0.0783f ; **FLOATING
C8514 VDD.t418 VSS 0.02589f ; **FLOATING
C8515 VDD.t589 VSS 0.02589f ; **FLOATING
C8516 VDD.n995 VSS 0.06972f ; **FLOATING
C8517 VDD.n996 VSS 0.01276f ; **FLOATING
C8518 VDD.t354 VSS 0.03461f ; **FLOATING
C8519 VDD.t1440 VSS 0.03461f ; **FLOATING
C8520 VDD.n997 VSS 0.07424f ; **FLOATING
C8521 VDD.t1389 VSS 0.03908f ; **FLOATING
C8522 VDD.t1441 VSS 0.03908f ; **FLOATING
C8523 VDD.n998 VSS 0.01252f ; **FLOATING
C8524 VDD.t1398 VSS 0.03506f ; **FLOATING
C8525 VDD.t1233 VSS 0.03518f ; **FLOATING
C8526 VDD.t1284 VSS 0.03506f ; **FLOATING
C8527 VDD.n999 VSS 0.07345f ; **FLOATING
C8528 VDD.n1000 VSS 0.01379f ; **FLOATING
C8529 VDD.t849 VSS 0.03506f ; **FLOATING
C8530 VDD.n1001 VSS 0.06368f ; **FLOATING
C8531 VDD.t1529 VSS 0.03506f ; **FLOATING
C8532 VDD.n1002 VSS 0.0538f ; **FLOATING
C8533 VDD.n1003 VSS 0.01948f ; **FLOATING
C8534 VDD.t1521 VSS 0.03506f ; **FLOATING
C8535 VDD.t332 VSS 0.03147f ; **FLOATING
C8536 VDD.t333 VSS 0.03148f ; **FLOATING
C8537 VDD.t1476 VSS 0.03506f ; **FLOATING
C8538 VDD.t331 VSS 0.0338f ; **FLOATING
C8539 VDD.t1706 VSS 0.11628f ; **FLOATING
C8540 VDD.t1243 VSS 0.04602f ; **FLOATING
C8541 VDD.t334 VSS 0.0338f ; **FLOATING
C8542 VDD.t1705 VSS 0.11628f ; **FLOATING
C8543 VDD.n1004 VSS 0.14231f ; **FLOATING
C8544 VDD.n1005 VSS 0.08884f ; **FLOATING
C8545 VDD.t801 VSS 0.03506f ; **FLOATING
C8546 VDD.t336 VSS 0.03147f ; **FLOATING
C8547 VDD.t337 VSS 0.03148f ; **FLOATING
C8548 VDD.t340 VSS 0.03147f ; **FLOATING
C8549 VDD.t387 VSS 0.03506f ; **FLOATING
C8550 VDD.t950 VSS 0.03506f ; **FLOATING
C8551 VDD.t817 VSS 0.03506f ; **FLOATING
C8552 VDD.t549 VSS 0.03506f ; **FLOATING
C8553 VDD.t250 VSS 0.03148f ; **FLOATING
C8554 VDD.t1269 VSS 0.04602f ; **FLOATING
C8555 VDD.t1072 VSS 0.03506f ; **FLOATING
C8556 VDD.t253 VSS 0.03147f ; **FLOATING
C8557 VDD.t1031 VSS 0.03506f ; **FLOATING
C8558 VDD.t254 VSS 0.03148f ; **FLOATING
C8559 VDD.t1193 VSS 0.03506f ; **FLOATING
C8560 VDD.t257 VSS 0.03147f ; **FLOATING
C8561 VDD.t258 VSS 0.03148f ; **FLOATING
C8562 VDD.t554 VSS 0.04618f ; **FLOATING
C8563 VDD.n1006 VSS 0.01948f ; **FLOATING
C8564 VDD.t1077 VSS 0.03506f ; **FLOATING
C8565 VDD.n1007 VSS 0.06368f ; **FLOATING
C8566 VDD.n1008 VSS 0.01379f ; **FLOATING
C8567 VDD.t261 VSS 0.03147f ; **FLOATING
C8568 VDD.n1009 VSS 0.05439f ; **FLOATING
C8569 VDD.t1608 VSS 0.03506f ; **FLOATING
C8570 VDD.n1010 VSS 0.05325f ; **FLOATING
C8571 VDD.t1530 VSS 0.03506f ; **FLOATING
C8572 VDD.n1012 VSS 0.0538f ; **FLOATING
C8573 VDD.n1013 VSS 0.0136f ; **FLOATING
C8574 VDD.t550 VSS 0.03506f ; **FLOATING
C8575 VDD.n1014 VSS 0.06423f ; **FLOATING
C8576 VDD.t202 VSS 0.03148f ; **FLOATING
C8577 VDD.t556 VSS 0.04602f ; **FLOATING
C8578 VDD.t205 VSS 0.03147f ; **FLOATING
C8579 VDD.t921 VSS 0.03506f ; **FLOATING
C8580 VDD.t206 VSS 0.03148f ; **FLOATING
C8581 VDD.t1515 VSS 0.03506f ; **FLOATING
C8582 VDD.t1158 VSS 0.03506f ; **FLOATING
C8583 VDD.t209 VSS 0.03147f ; **FLOATING
C8584 VDD.t210 VSS 0.03148f ; **FLOATING
C8585 VDD.t213 VSS 0.03147f ; **FLOATING
C8586 VDD.t1124 VSS 0.03506f ; **FLOATING
C8587 VDD.t1033 VSS 0.03506f ; **FLOATING
C8588 VDD.t1123 VSS 0.03506f ; **FLOATING
C8589 VDD.t522 VSS 0.03506f ; **FLOATING
C8590 VDD.t509 VSS 0.04602f ; **FLOATING
C8591 VDD.t502 VSS 0.03506f ; **FLOATING
C8592 VDD.t851 VSS 0.03506f ; **FLOATING
C8593 VDD.t1463 VSS 0.03506f ; **FLOATING
C8594 VDD.t1613 VSS 0.03506f ; **FLOATING
C8595 VDD.t1445 VSS 0.03723f ; **FLOATING
C8596 VDD.t1079 VSS 0.04602f ; **FLOATING
C8597 VDD.t1446 VSS 0.06573f ; **FLOATING
C8598 VDD.t386 VSS 0.03506f ; **FLOATING
C8599 VDD.t1457 VSS 0.03506f ; **FLOATING
C8600 VDD.t1412 VSS 0.03506f ; **FLOATING
C8601 VDD.t548 VSS 0.03506f ; **FLOATING
C8602 VDD.t175 VSS 0.03148f ; **FLOATING
C8603 VDD.t974 VSS 0.04602f ; **FLOATING
C8604 VDD.t881 VSS 0.03506f ; **FLOATING
C8605 VDD.t178 VSS 0.03147f ; **FLOATING
C8606 VDD.t1209 VSS 0.03506f ; **FLOATING
C8607 VDD.t179 VSS 0.03148f ; **FLOATING
C8608 VDD.t1435 VSS 0.03506f ; **FLOATING
C8609 VDD.t182 VSS 0.03147f ; **FLOATING
C8610 VDD.t183 VSS 0.03148f ; **FLOATING
C8611 VDD.t1393 VSS 0.04618f ; **FLOATING
C8612 VDD.n1015 VSS 0.01948f ; **FLOATING
C8613 VDD.t1461 VSS 0.03506f ; **FLOATING
C8614 VDD.n1016 VSS 0.06368f ; **FLOATING
C8615 VDD.n1017 VSS 0.01379f ; **FLOATING
C8616 VDD.t186 VSS 0.03147f ; **FLOATING
C8617 VDD.t1609 VSS 0.03506f ; **FLOATING
C8618 VDD.n1018 VSS 0.05325f ; **FLOATING
C8619 VDD.t818 VSS 0.03506f ; **FLOATING
C8620 VDD.n1020 VSS 0.0538f ; **FLOATING
C8621 VDD.n1021 VSS 0.0136f ; **FLOATING
C8622 VDD.t551 VSS 0.03506f ; **FLOATING
C8623 VDD.n1022 VSS 0.06395f ; **FLOATING
C8624 VDD.t241 VSS 0.03148f ; **FLOATING
C8625 VDD.t1350 VSS 0.04602f ; **FLOATING
C8626 VDD.t244 VSS 0.03147f ; **FLOATING
C8627 VDD.t922 VSS 0.03506f ; **FLOATING
C8628 VDD.t245 VSS 0.03148f ; **FLOATING
C8629 VDD.t1516 VSS 0.03506f ; **FLOATING
C8630 VDD.t880 VSS 0.03506f ; **FLOATING
C8631 VDD.t248 VSS 0.03147f ; **FLOATING
C8632 VDD.t249 VSS 0.03148f ; **FLOATING
C8633 VDD.t92 VSS 0.03147f ; **FLOATING
C8634 VDD.t1125 VSS 0.03506f ; **FLOATING
C8635 VDD.t511 VSS 0.03506f ; **FLOATING
C8636 VDD.t1132 VSS 0.03506f ; **FLOATING
C8637 VDD.t523 VSS 0.03506f ; **FLOATING
C8638 VDD.t1614 VSS 0.03148f ; **FLOATING
C8639 VDD.t370 VSS 0.04602f ; **FLOATING
C8640 VDD.t503 VSS 0.03506f ; **FLOATING
C8641 VDD.t306 VSS 0.03147f ; **FLOATING
C8642 VDD.t854 VSS 0.03506f ; **FLOATING
C8643 VDD.t307 VSS 0.03148f ; **FLOATING
C8644 VDD.t1434 VSS 0.03506f ; **FLOATING
C8645 VDD.t299 VSS 0.03147f ; **FLOATING
C8646 VDD.t300 VSS 0.03148f ; **FLOATING
C8647 VDD.t1362 VSS 0.04618f ; **FLOATING
C8648 VDD.n1023 VSS 0.01948f ; **FLOATING
C8649 VDD.t1580 VSS 0.03506f ; **FLOATING
C8650 VDD.n1024 VSS 0.06368f ; **FLOATING
C8651 VDD.n1025 VSS 0.01379f ; **FLOATING
C8652 VDD.t303 VSS 0.03147f ; **FLOATING
C8653 VDD.t1508 VSS 0.03506f ; **FLOATING
C8654 VDD.n1026 VSS 0.05325f ; **FLOATING
C8655 VDD.t1205 VSS 0.03506f ; **FLOATING
C8656 VDD.n1028 VSS 0.0538f ; **FLOATING
C8657 VDD.n1029 VSS 0.0136f ; **FLOATING
C8658 VDD.t926 VSS 0.03506f ; **FLOATING
C8659 VDD.n1030 VSS 0.06379f ; **FLOATING
C8660 VDD.n1031 VSS 0.02582f ; **FLOATING
C8661 VDD.t1360 VSS 0.04602f ; **FLOATING
C8662 VDD.n1032 VSS 0.09359f ; **FLOATING
C8663 VDD.t1522 VSS 0.03844f ; **FLOATING
C8664 VDD.n1033 VSS 0.12474f ; **FLOATING
C8665 VDD.t301 VSS 0.0338f ; **FLOATING
C8666 VDD.t1689 VSS 0.11628f ; **FLOATING
C8667 VDD.n1034 VSS 0.14231f ; **FLOATING
C8668 VDD.t298 VSS 0.0338f ; **FLOATING
C8669 VDD.t1690 VSS 0.11628f ; **FLOATING
C8670 VDD.n1035 VSS 0.14231f ; **FLOATING
C8671 VDD.n1036 VSS 0.08884f ; **FLOATING
C8672 VDD.t305 VSS 0.0338f ; **FLOATING
C8673 VDD.t1691 VSS 0.11628f ; **FLOATING
C8674 VDD.n1037 VSS 0.06395f ; **FLOATING
C8675 VDD.n1038 VSS 0.0136f ; **FLOATING
C8676 VDD.n1039 VSS 0.0538f ; **FLOATING
C8677 VDD.n1040 VSS 0.01948f ; **FLOATING
C8678 VDD.n1041 VSS 0.06368f ; **FLOATING
C8679 VDD.n1042 VSS 0.01379f ; **FLOATING
C8680 VDD.n1043 VSS 0.05325f ; **FLOATING
C8681 VDD.n1045 VSS 0.05439f ; **FLOATING
C8682 VDD.t1387 VSS 0.04618f ; **FLOATING
C8683 VDD.t91 VSS 0.0338f ; **FLOATING
C8684 VDD.t1692 VSS 0.11628f ; **FLOATING
C8685 VDD.n1046 VSS 0.14231f ; **FLOATING
C8686 VDD.n1047 VSS 0.12416f ; **FLOATING
C8687 VDD.t246 VSS 0.0338f ; **FLOATING
C8688 VDD.t1693 VSS 0.11628f ; **FLOATING
C8689 VDD.n1048 VSS 0.14231f ; **FLOATING
C8690 VDD.t242 VSS 0.0338f ; **FLOATING
C8691 VDD.t1694 VSS 0.11628f ; **FLOATING
C8692 VDD.t184 VSS 0.0338f ; **FLOATING
C8693 VDD.t1695 VSS 0.11628f ; **FLOATING
C8694 VDD.n1049 VSS 0.14231f ; **FLOATING
C8695 VDD.t180 VSS 0.0338f ; **FLOATING
C8696 VDD.t1696 VSS 0.11628f ; **FLOATING
C8697 VDD.n1050 VSS 0.14231f ; **FLOATING
C8698 VDD.n1051 VSS 0.08884f ; **FLOATING
C8699 VDD.t176 VSS 0.0338f ; **FLOATING
C8700 VDD.t1697 VSS 0.11628f ; **FLOATING
C8701 VDD.n1052 VSS 0.06395f ; **FLOATING
C8702 VDD.n1053 VSS 0.0136f ; **FLOATING
C8703 VDD.n1054 VSS 0.0538f ; **FLOATING
C8704 VDD.n1055 VSS 0.01948f ; **FLOATING
C8705 VDD.n1056 VSS 0.06368f ; **FLOATING
C8706 VDD.n1057 VSS 0.01379f ; **FLOATING
C8707 VDD.n1058 VSS 0.0781f ; **FLOATING
C8708 VDD.n1059 VSS 0.01183f ; **FLOATING
C8709 VDD.n1060 VSS 0.07521f ; **FLOATING
C8710 VDD.n1061 VSS 0.10444f ; **FLOATING
C8711 VDD.n1062 VSS 0.02582f ; **FLOATING
C8712 VDD.n1063 VSS 0.06379f ; **FLOATING
C8713 VDD.n1064 VSS 0.0136f ; **FLOATING
C8714 VDD.n1065 VSS 0.0538f ; **FLOATING
C8715 VDD.n1066 VSS 0.01948f ; **FLOATING
C8716 VDD.n1067 VSS 0.06368f ; **FLOATING
C8717 VDD.n1068 VSS 0.01379f ; **FLOATING
C8718 VDD.n1069 VSS 0.05325f ; **FLOATING
C8719 VDD.n1071 VSS 0.05439f ; **FLOATING
C8720 VDD.t1036 VSS 0.04618f ; **FLOATING
C8721 VDD.t211 VSS 0.0338f ; **FLOATING
C8722 VDD.t1698 VSS 0.11628f ; **FLOATING
C8723 VDD.n1072 VSS 0.14231f ; **FLOATING
C8724 VDD.n1073 VSS 0.12416f ; **FLOATING
C8725 VDD.t207 VSS 0.0338f ; **FLOATING
C8726 VDD.t1699 VSS 0.11628f ; **FLOATING
C8727 VDD.n1074 VSS 0.14231f ; **FLOATING
C8728 VDD.t203 VSS 0.0338f ; **FLOATING
C8729 VDD.t1700 VSS 0.11628f ; **FLOATING
C8730 VDD.t259 VSS 0.0338f ; **FLOATING
C8731 VDD.t1701 VSS 0.11628f ; **FLOATING
C8732 VDD.n1075 VSS 0.14231f ; **FLOATING
C8733 VDD.t255 VSS 0.0338f ; **FLOATING
C8734 VDD.t1702 VSS 0.11628f ; **FLOATING
C8735 VDD.n1076 VSS 0.14231f ; **FLOATING
C8736 VDD.n1077 VSS 0.08884f ; **FLOATING
C8737 VDD.t251 VSS 0.0338f ; **FLOATING
C8738 VDD.t1703 VSS 0.11628f ; **FLOATING
C8739 VDD.n1078 VSS 0.06395f ; **FLOATING
C8740 VDD.n1079 VSS 0.0136f ; **FLOATING
C8741 VDD.n1080 VSS 0.0538f ; **FLOATING
C8742 VDD.n1081 VSS 0.01948f ; **FLOATING
C8743 VDD.n1082 VSS 0.06368f ; **FLOATING
C8744 VDD.n1083 VSS 0.01379f ; **FLOATING
C8745 VDD.n1084 VSS 0.05325f ; **FLOATING
C8746 VDD.n1086 VSS 0.05439f ; **FLOATING
C8747 VDD.t1386 VSS 0.04618f ; **FLOATING
C8748 VDD.t338 VSS 0.0338f ; **FLOATING
C8749 VDD.t1704 VSS 0.11628f ; **FLOATING
C8750 VDD.n1087 VSS 0.14231f ; **FLOATING
C8751 VDD.n1088 VSS 0.12416f ; **FLOATING
C8752 VDD.n1089 VSS 0.07777f ; **FLOATING
C8753 VDD.n1090 VSS 0.77067f ; **FLOATING
C8754 VDD.n1091 VSS 0.56914f ; **FLOATING
C8755 VDD.t434 VSS 0.03428f ; **FLOATING
C8756 VDD.t432 VSS 0.02445f ; **FLOATING
C8757 VDD.n1092 VSS 0.42876f ; **FLOATING
C8758 VDD.t437 VSS 0.03387f ; **FLOATING
C8759 VDD.t667 VSS 0.03453f ; **FLOATING
C8760 VDD.t647 VSS 0.03387f ; **FLOATING
C8761 VDD.t646 VSS 0.03387f ; **FLOATING
C8762 VDD.t668 VSS 0.03387f ; **FLOATING
C8763 VDD.t624 VSS 0.03387f ; **FLOATING
C8764 VDD.n1093 VSS 0.02512f ; **FLOATING
C8765 VDD.t619 VSS 0.03387f ; **FLOATING
C8766 VDD.t669 VSS 0.03387f ; **FLOATING
C8767 VDD.t634 VSS 0.03387f ; **FLOATING
C8768 VDD.t626 VSS 0.03387f ; **FLOATING
C8769 VDD.n1094 VSS 0.02512f ; **FLOATING
C8770 VDD.t670 VSS 0.03387f ; **FLOATING
C8771 VDD.t645 VSS 0.03387f ; **FLOATING
C8772 VDD.t672 VSS 0.03387f ; **FLOATING
C8773 VDD.t671 VSS 0.03387f ; **FLOATING
C8774 VDD.t640 VSS 0.03387f ; **FLOATING
C8775 VDD.t637 VSS 0.03387f ; **FLOATING
C8776 VDD.n1095 VSS 0.02512f ; **FLOATING
C8777 VDD.t682 VSS 0.03387f ; **FLOATING
C8778 VDD.t679 VSS 0.03387f ; **FLOATING
C8779 VDD.t678 VSS 0.03387f ; **FLOATING
C8780 VDD.t681 VSS 0.03387f ; **FLOATING
C8781 VDD.t680 VSS 0.03387f ; **FLOATING
C8782 VDD.t683 VSS 0.03387f ; **FLOATING
C8783 VDD.t675 VSS 0.03387f ; **FLOATING
C8784 VDD.n1096 VSS 0.02512f ; **FLOATING
C8785 VDD.t677 VSS 0.03387f ; **FLOATING
C8786 VDD.t673 VSS 0.03387f ; **FLOATING
C8787 VDD.t676 VSS 0.03387f ; **FLOATING
C8788 VDD.t674 VSS 0.03387f ; **FLOATING
C8789 VDD.n1097 VSS 0.02512f ; **FLOATING
C8790 VDD.t632 VSS 0.03387f ; **FLOATING
C8791 VDD.t630 VSS 0.03387f ; **FLOATING
C8792 VDD.t684 VSS 0.03387f ; **FLOATING
C8793 VDD.t685 VSS 0.03387f ; **FLOATING
C8794 VDD.t648 VSS 0.03387f ; **FLOATING
C8795 VDD.t639 VSS 0.03387f ; **FLOATING
C8796 VDD.n1098 VSS 0.02512f ; **FLOATING
C8797 VDD.t440 VSS 0.03387f ; **FLOATING
C8798 VDD.t438 VSS 0.07104f ; **FLOATING
C8799 VDD.t439 VSS 0.03785f ; **FLOATING
C8800 VDD.n1099 VSS 0.02746f ; **FLOATING
C8801 VDD.t441 VSS 0.03273f ; **FLOATING
C8802 VDD.n1100 VSS 0.01669f ; **FLOATING
C8803 VDD.t442 VSS 0.03387f ; **FLOATING
C8804 VDD.n1101 VSS 0.02249f ; **FLOATING
C8805 VDD.t1265 VSS 0.03972f ; **FLOATING
C8806 VDD.n1102 VSS 0.06293f ; **FLOATING
C8807 VDD.t519 VSS 0.03972f ; **FLOATING
C8808 VDD.t882 VSS 0.03972f ; **FLOATING
C8809 VDD.t598 VSS 0.03972f ; **FLOATING
C8810 VDD.t978 VSS 0.03972f ; **FLOATING
C8811 VDD.t976 VSS 0.03972f ; **FLOATING
C8812 VDD.t1059 VSS 0.03972f ; **FLOATING
C8813 VDD.t540 VSS 0.03972f ; **FLOATING
C8814 VDD.t1056 VSS 0.03972f ; **FLOATING
C8815 VDD.t1110 VSS 0.03972f ; **FLOATING
C8816 VDD.t862 VSS 0.03972f ; **FLOATING
C8817 VDD.t861 VSS 0.03972f ; **FLOATING
C8818 VDD.t1054 VSS 0.03972f ; **FLOATING
C8819 VDD.t773 VSS 0.03972f ; **FLOATING
C8820 VDD.t1087 VSS 0.03972f ; **FLOATING
C8821 VDD.t771 VSS 0.03972f ; **FLOATING
C8822 VDD.t791 VSS 0.03972f ; **FLOATING
C8823 VDD.t769 VSS 0.03972f ; **FLOATING
C8824 VDD.t375 VSS 0.03972f ; **FLOATING
C8825 VDD.t1341 VSS 0.03972f ; **FLOATING
C8826 VDD.t929 VSS 0.03972f ; **FLOATING
C8827 VDD.t953 VSS 0.03972f ; **FLOATING
C8828 VDD.t1336 VSS 0.03972f ; **FLOATING
C8829 VDD.t516 VSS 0.03972f ; **FLOATING
C8830 VDD.t1108 VSS 0.03972f ; **FLOATING
C8831 VDD.t1000 VSS 0.03972f ; **FLOATING
C8832 VDD.t1002 VSS 0.03972f ; **FLOATING
C8833 VDD.t1323 VSS 0.03972f ; **FLOATING
C8834 VDD.t1043 VSS 0.03972f ; **FLOATING
C8835 VDD.t1322 VSS 0.03972f ; **FLOATING
C8836 VDD.t1315 VSS 0.03972f ; **FLOATING
C8837 VDD.t980 VSS 0.03972f ; **FLOATING
C8838 VDD.n1103 VSS 0.07174f ; **FLOATING
C8839 VDD.n1104 VSS 0.01472f ; **FLOATING
C8840 VDD.n1105 VSS 0.08989f ; **FLOATING
C8841 VDD.n1106 VSS 0.09529f ; **FLOATING
C8842 VDD.n1107 VSS 0.09343f ; **FLOATING
C8843 VDD.n1108 VSS 0.06293f ; **FLOATING
C8844 VDD.n1109 VSS 0.01472f ; **FLOATING
C8845 VDD.n1110 VSS 0.0827f ; **FLOATING
C8846 VDD.n1111 VSS 0.09418f ; **FLOATING
C8847 VDD.n1112 VSS 0.06296f ; **FLOATING
C8848 VDD.n1113 VSS 0.01472f ; **FLOATING
C8849 VDD.n1114 VSS 0.09419f ; **FLOATING
C8850 VDD.n1115 VSS 0.09344f ; **FLOATING
C8851 VDD.n1116 VSS 0.07175f ; **FLOATING
C8852 VDD.n1117 VSS 0.01472f ; **FLOATING
C8853 VDD.n1118 VSS 0.08271f ; **FLOATING
C8854 VDD.n1119 VSS 0.0768f ; **FLOATING
C8855 VDD.n1120 VSS 0.01153f ; **FLOATING
C8856 VDD.n1121 VSS 0.03793f ; **FLOATING
C8857 VDD.n1122 VSS 0.01472f ; **FLOATING
C8858 VDD.n1123 VSS 0.0827f ; **FLOATING
C8859 VDD.n1124 VSS 0.06296f ; **FLOATING
C8860 VDD.n1125 VSS 0.01472f ; **FLOATING
C8861 VDD.n1126 VSS 0.0827f ; **FLOATING
C8862 VDD.n1127 VSS 0.09417f ; **FLOATING
C8863 VDD.n1128 VSS 0.04329f ; **FLOATING
C8864 VDD.n1130 VSS 0.07437f ; **FLOATING
C8865 VDD.n1131 VSS 0.05422f ; **FLOATING
C8866 VDD.n1132 VSS 0.06312f ; **FLOATING
C8867 VDD.n1134 VSS 0.04837f ; **FLOATING
C8868 VDD.n1135 VSS 0.02689f ; **FLOATING
C8869 VDD.n1136 VSS 0.09209f ; **FLOATING
C8870 VDD.n1137 VSS 0.05149f ; **FLOATING
C8871 VDD.n1138 VSS 0.11127f ; **FLOATING
C8872 VDD.n1139 VSS 0.05149f ; **FLOATING
C8873 VDD.n1140 VSS 0.11127f ; **FLOATING
C8874 VDD.n1141 VSS 0.05149f ; **FLOATING
C8875 VDD.n1142 VSS 0.11127f ; **FLOATING
C8876 VDD.n1143 VSS 0.05149f ; **FLOATING
C8877 VDD.n1144 VSS 0.11127f ; **FLOATING
C8878 VDD.n1145 VSS 0.05149f ; **FLOATING
C8879 VDD.n1146 VSS 0.11127f ; **FLOATING
C8880 VDD.n1147 VSS 0.05149f ; **FLOATING
C8881 VDD.n1148 VSS 0.11127f ; **FLOATING
C8882 VDD.n1149 VSS 0.04904f ; **FLOATING
C8883 VDD.n1150 VSS 0.11127f ; **FLOATING
C8884 VDD.n1151 VSS 0.05149f ; **FLOATING
C8885 VDD.n1152 VSS 0.11127f ; **FLOATING
C8886 VDD.n1153 VSS 0.05149f ; **FLOATING
C8887 VDD.n1154 VSS 0.11127f ; **FLOATING
C8888 VDD.n1155 VSS 0.05149f ; **FLOATING
C8889 VDD.n1156 VSS 0.11127f ; **FLOATING
C8890 VDD.n1157 VSS 0.05149f ; **FLOATING
C8891 VDD.n1158 VSS 0.11127f ; **FLOATING
C8892 VDD.n1159 VSS 0.05149f ; **FLOATING
C8893 VDD.n1160 VSS 0.11127f ; **FLOATING
C8894 VDD.n1161 VSS 0.05149f ; **FLOATING
C8895 VDD.n1162 VSS 0.11127f ; **FLOATING
C8896 VDD.n1163 VSS 0.05149f ; **FLOATING
C8897 VDD.n1164 VSS 0.11127f ; **FLOATING
C8898 VDD.n1165 VSS 0.05149f ; **FLOATING
C8899 VDD.n1166 VSS 0.11127f ; **FLOATING
C8900 VDD.n1167 VSS 0.05149f ; **FLOATING
C8901 VDD.n1168 VSS 0.11127f ; **FLOATING
C8902 VDD.n1169 VSS 0.05149f ; **FLOATING
C8903 VDD.n1170 VSS 0.11127f ; **FLOATING
C8904 VDD.n1171 VSS 0.05149f ; **FLOATING
C8905 VDD.n1172 VSS 0.11127f ; **FLOATING
C8906 VDD.n1173 VSS 0.05149f ; **FLOATING
C8907 VDD.n1174 VSS 0.07191f ; **FLOATING
C8908 VDD.n1176 VSS 0.08376f ; **FLOATING
C8909 VDD.n1177 VSS 0.04261f ; **FLOATING
C8910 VDD.n1178 VSS 0.10178f ; **FLOATING
C8911 VDD.n1179 VSS 0.05149f ; **FLOATING
C8912 VDD.n1180 VSS 0.11127f ; **FLOATING
C8913 VDD.n1181 VSS 0.05149f ; **FLOATING
C8914 VDD.n1182 VSS 0.11127f ; **FLOATING
C8915 VDD.n1183 VSS 0.05149f ; **FLOATING
C8916 VDD.n1184 VSS 0.11127f ; **FLOATING
C8917 VDD.n1185 VSS 0.05149f ; **FLOATING
C8918 VDD.n1186 VSS 0.11127f ; **FLOATING
C8919 VDD.n1187 VSS 0.05149f ; **FLOATING
C8920 VDD.n1188 VSS 0.11127f ; **FLOATING
C8921 VDD.n1189 VSS 0.05149f ; **FLOATING
C8922 VDD.n1190 VSS 0.11127f ; **FLOATING
C8923 VDD.n1191 VSS 0.05149f ; **FLOATING
C8924 VDD.n1192 VSS 0.13041f ; **FLOATING
C8925 VDD.t435 VSS 0.01993f ; **FLOATING
C8926 VDD.t433 VSS 0.03829f ; **FLOATING
C8927 VDD.n1193 VSS 0.41263f ; **FLOATING
C8928 VDD.n1194 VSS 0.72422f ; **FLOATING
C8929 VDD.t902 VSS 0.03506f ; **FLOATING
C8930 VDD.t1456 VSS 0.03506f ; **FLOATING
C8931 VDD.n1195 VSS 0.08296f ; **FLOATING
C8932 VDD.t6 VSS 0.03148f ; **FLOATING
C8933 VDD.t342 VSS 0.03506f ; **FLOATING
C8934 VDD.n1196 VSS 0.06395f ; **FLOATING
C8935 VDD.n1197 VSS 0.0136f ; **FLOATING
C8936 VDD.n1198 VSS 0.02895f ; **FLOATING
C8937 VDD.t1319 VSS 0.04602f ; **FLOATING
C8938 VDD.n1199 VSS 0.08826f ; **FLOATING
C8939 VDD.n1200 VSS 0.02582f ; **FLOATING
C8940 VDD.t1379 VSS 0.03506f ; **FLOATING
C8941 VDD.n1201 VSS 0.09318f ; **FLOATING
C8942 VDD.n1202 VSS 0.01229f ; **FLOATING
C8943 VDD.t1607 VSS 0.03908f ; **FLOATING
C8944 VDD.t535 VSS 0.03908f ; **FLOATING
C8945 VDD.n1203 VSS 0.01297f ; **FLOATING
C8946 VDD.t1364 VSS 0.03908f ; **FLOATING
C8947 VDD.t1232 VSS 0.03908f ; **FLOATING
C8948 VDD.n1204 VSS 0.08331f ; **FLOATING
C8949 VDD.n1205 VSS 0.01238f ; **FLOATING
C8950 VDD.n1206 VSS 0.01826f ; **FLOATING
C8951 VDD.t899 VSS 0.03506f ; **FLOATING
C8952 VDD.t565 VSS 0.03506f ; **FLOATING
C8953 VDD.n1207 VSS 0.09793f ; **FLOATING
C8954 VDD.n1208 VSS 0.01605f ; **FLOATING
C8955 VDD.t1307 VSS 0.02589f ; **FLOATING
C8956 VDD.t1141 VSS 0.02589f ; **FLOATING
C8957 VDD.n1209 VSS 0.07458f ; **FLOATING
C8958 VDD.t958 VSS 0.03461f ; **FLOATING
C8959 VDD.t401 VSS 0.03461f ; **FLOATING
C8960 VDD.n1210 VSS 0.06957f ; **FLOATING
C8961 VDD.n1211 VSS 0.01714f ; **FLOATING
C8962 VDD.t904 VSS 0.02589f ; **FLOATING
C8963 VDD.t1454 VSS 0.02589f ; **FLOATING
C8964 VDD.t959 VSS 0.03461f ; **FLOATING
C8965 VDD.t400 VSS 0.03461f ; **FLOATING
C8966 VDD.t900 VSS 0.02589f ; **FLOATING
C8967 VDD.t566 VSS 0.02589f ; **FLOATING
C8968 VDD.n1212 VSS 0.07942f ; **FLOATING
C8969 VDD.n1213 VSS 0.01206f ; **FLOATING
C8970 VDD.t864 VSS 0.03461f ; **FLOATING
C8971 VDD.t877 VSS 0.03461f ; **FLOATING
C8972 VDD.n1214 VSS 0.07004f ; **FLOATING
C8973 VDD.n1215 VSS 0.01711f ; **FLOATING
C8974 VDD.t865 VSS 0.03908f ; **FLOATING
C8975 VDD.t878 VSS 0.03908f ; **FLOATING
C8976 VDD.n1216 VSS 0.0783f ; **FLOATING
C8977 VDD.t903 VSS 0.02589f ; **FLOATING
C8978 VDD.t1455 VSS 0.02589f ; **FLOATING
C8979 VDD.n1217 VSS 0.06972f ; **FLOATING
C8980 VDD.n1218 VSS 0.01276f ; **FLOATING
C8981 VDD.t901 VSS 0.03461f ; **FLOATING
C8982 VDD.t567 VSS 0.03461f ; **FLOATING
C8983 VDD.n1219 VSS 0.07424f ; **FLOATING
C8984 VDD.t1400 VSS 0.03908f ; **FLOATING
C8985 VDD.t938 VSS 0.03908f ; **FLOATING
C8986 VDD.n1220 VSS 0.01252f ; **FLOATING
C8987 VDD.t1390 VSS 0.03506f ; **FLOATING
C8988 VDD.t815 VSS 0.03518f ; **FLOATING
C8989 VDD.t1384 VSS 0.03506f ; **FLOATING
C8990 VDD.n1221 VSS 0.07345f ; **FLOATING
C8991 VDD.n1222 VSS 0.01379f ; **FLOATING
C8992 VDD.t1316 VSS 0.03506f ; **FLOATING
C8993 VDD.n1223 VSS 0.06368f ; **FLOATING
C8994 VDD.t1173 VSS 0.03506f ; **FLOATING
C8995 VDD.n1224 VSS 0.0538f ; **FLOATING
C8996 VDD.n1225 VSS 0.01948f ; **FLOATING
C8997 VDD.t1119 VSS 0.03506f ; **FLOATING
C8998 VDD.t89 VSS 0.03147f ; **FLOATING
C8999 VDD.t73 VSS 0.03148f ; **FLOATING
C9000 VDD.t1044 VSS 0.03506f ; **FLOATING
C9001 VDD.t7 VSS 0.0338f ; **FLOATING
C9002 VDD.t1688 VSS 0.11628f ; **FLOATING
C9003 VDD.t1395 VSS 0.04602f ; **FLOATING
C9004 VDD.t74 VSS 0.0338f ; **FLOATING
C9005 VDD.t1687 VSS 0.11628f ; **FLOATING
C9006 VDD.n1226 VSS 0.14231f ; **FLOATING
C9007 VDD.n1227 VSS 0.08884f ; **FLOATING
C9008 VDD.t1198 VSS 0.03506f ; **FLOATING
C9009 VDD.t110 VSS 0.03147f ; **FLOATING
C9010 VDD.t10 VSS 0.03148f ; **FLOATING
C9011 VDD.t13 VSS 0.03147f ; **FLOATING
C9012 VDD.t832 VSS 0.03506f ; **FLOATING
C9013 VDD.t1329 VSS 0.03506f ; **FLOATING
C9014 VDD.t826 VSS 0.03506f ; **FLOATING
C9015 VDD.t1179 VSS 0.03506f ; **FLOATING
C9016 VDD.t61 VSS 0.03148f ; **FLOATING
C9017 VDD.t1001 VSS 0.04602f ; **FLOATING
C9018 VDD.t819 VSS 0.03506f ; **FLOATING
C9019 VDD.t318 VSS 0.03147f ; **FLOATING
C9020 VDD.t1107 VSS 0.03506f ; **FLOATING
C9021 VDD.t240 VSS 0.03148f ; **FLOATING
C9022 VDD.t1382 VSS 0.03506f ; **FLOATING
C9023 VDD.t21 VSS 0.03147f ; **FLOATING
C9024 VDD.t22 VSS 0.03148f ; **FLOATING
C9025 VDD.t515 VSS 0.04618f ; **FLOATING
C9026 VDD.n1228 VSS 0.01948f ; **FLOATING
C9027 VDD.t1340 VSS 0.03506f ; **FLOATING
C9028 VDD.n1229 VSS 0.06368f ; **FLOATING
C9029 VDD.n1230 VSS 0.01379f ; **FLOATING
C9030 VDD.t25 VSS 0.03147f ; **FLOATING
C9031 VDD.n1231 VSS 0.05439f ; **FLOATING
C9032 VDD.t833 VSS 0.03506f ; **FLOATING
C9033 VDD.n1232 VSS 0.05325f ; **FLOATING
C9034 VDD.t829 VSS 0.03506f ; **FLOATING
C9035 VDD.n1234 VSS 0.0538f ; **FLOATING
C9036 VDD.n1235 VSS 0.0136f ; **FLOATING
C9037 VDD.t1180 VSS 0.03506f ; **FLOATING
C9038 VDD.n1236 VSS 0.06423f ; **FLOATING
C9039 VDD.t63 VSS 0.03148f ; **FLOATING
C9040 VDD.t1335 VSS 0.04602f ; **FLOATING
C9041 VDD.t236 VSS 0.03147f ; **FLOATING
C9042 VDD.t1121 VSS 0.03506f ; **FLOATING
C9043 VDD.t290 VSS 0.03148f ; **FLOATING
C9044 VDD.t1302 VSS 0.03506f ; **FLOATING
C9045 VDD.t1385 VSS 0.03506f ; **FLOATING
C9046 VDD.t315 VSS 0.03147f ; **FLOATING
C9047 VDD.t316 VSS 0.03148f ; **FLOATING
C9048 VDD.t287 VSS 0.03147f ; **FLOATING
C9049 VDD.t1181 VSS 0.03506f ; **FLOATING
C9050 VDD.t930 VSS 0.03506f ; **FLOATING
C9051 VDD.t830 VSS 0.03506f ; **FLOATING
C9052 VDD.t1126 VSS 0.03506f ; **FLOATING
C9053 VDD.t770 VSS 0.04602f ; **FLOATING
C9054 VDD.t1175 VSS 0.03506f ; **FLOATING
C9055 VDD.t790 VSS 0.03506f ; **FLOATING
C9056 VDD.t591 VSS 0.03506f ; **FLOATING
C9057 VDD.t1380 VSS 0.03506f ; **FLOATING
C9058 VDD.t807 VSS 0.03723f ; **FLOATING
C9059 VDD.t772 VSS 0.04602f ; **FLOATING
C9060 VDD.t1474 VSS 0.06573f ; **FLOATING
C9061 VDD.t831 VSS 0.03506f ; **FLOATING
C9062 VDD.t1345 VSS 0.03506f ; **FLOATING
C9063 VDD.t344 VSS 0.03506f ; **FLOATING
C9064 VDD.t1178 VSS 0.03506f ; **FLOATING
C9065 VDD.t288 VSS 0.03148f ; **FLOATING
C9066 VDD.t1053 VSS 0.04602f ; **FLOATING
C9067 VDD.t506 VSS 0.03506f ; **FLOATING
C9068 VDD.t201 VSS 0.03147f ; **FLOATING
C9069 VDD.t1481 VSS 0.03506f ; **FLOATING
C9070 VDD.t26 VSS 0.03148f ; **FLOATING
C9071 VDD.t1381 VSS 0.03506f ; **FLOATING
C9072 VDD.t108 VSS 0.03147f ; **FLOATING
C9073 VDD.t187 VSS 0.03148f ; **FLOATING
C9074 VDD.t860 VSS 0.04618f ; **FLOATING
C9075 VDD.n1237 VSS 0.01948f ; **FLOATING
C9076 VDD.t863 VSS 0.03506f ; **FLOATING
C9077 VDD.n1238 VSS 0.06368f ; **FLOATING
C9078 VDD.n1239 VSS 0.01379f ; **FLOATING
C9079 VDD.t190 VSS 0.03147f ; **FLOATING
C9080 VDD.t834 VSS 0.03506f ; **FLOATING
C9081 VDD.n1240 VSS 0.05325f ; **FLOATING
C9082 VDD.t827 VSS 0.03506f ; **FLOATING
C9083 VDD.n1242 VSS 0.0538f ; **FLOATING
C9084 VDD.n1243 VSS 0.0136f ; **FLOATING
C9085 VDD.t1174 VSS 0.03506f ; **FLOATING
C9086 VDD.n1244 VSS 0.06395f ; **FLOATING
C9087 VDD.t135 VSS 0.03148f ; **FLOATING
C9088 VDD.t1111 VSS 0.04602f ; **FLOATING
C9089 VDD.t320 VSS 0.03147f ; **FLOATING
C9090 VDD.t1122 VSS 0.03506f ; **FLOATING
C9091 VDD.t289 VSS 0.03148f ; **FLOATING
C9092 VDD.t1055 VSS 0.03506f ; **FLOATING
C9093 VDD.t1378 VSS 0.03506f ; **FLOATING
C9094 VDD.t264 VSS 0.03147f ; **FLOATING
C9095 VDD.t262 VSS 0.03148f ; **FLOATING
C9096 VDD.t199 VSS 0.03147f ; **FLOATING
C9097 VDD.t1182 VSS 0.03506f ; **FLOATING
C9098 VDD.t1588 VSS 0.03506f ; **FLOATING
C9099 VDD.t828 VSS 0.03506f ; **FLOATING
C9100 VDD.t1127 VSS 0.03506f ; **FLOATING
C9101 VDD.t157 VSS 0.03148f ; **FLOATING
C9102 VDD.t977 VSS 0.04602f ; **FLOATING
C9103 VDD.t1176 VSS 0.03506f ; **FLOATING
C9104 VDD.t322 VSS 0.03147f ; **FLOATING
C9105 VDD.t1060 VSS 0.03506f ; **FLOATING
C9106 VDD.t197 VSS 0.03148f ; **FLOATING
C9107 VDD.t1197 VSS 0.03506f ; **FLOATING
C9108 VDD.t148 VSS 0.03147f ; **FLOATING
C9109 VDD.t149 VSS 0.03148f ; **FLOATING
C9110 VDD.t813 VSS 0.04618f ; **FLOATING
C9111 VDD.n1245 VSS 0.01948f ; **FLOATING
C9112 VDD.t1348 VSS 0.03506f ; **FLOATING
C9113 VDD.n1246 VSS 0.06368f ; **FLOATING
C9114 VDD.n1247 VSS 0.01379f ; **FLOATING
C9115 VDD.t152 VSS 0.03147f ; **FLOATING
C9116 VDD.n1248 VSS 0.05439f ; **FLOATING
C9117 VDD.t1383 VSS 0.03506f ; **FLOATING
C9118 VDD.n1249 VSS 0.05325f ; **FLOATING
C9119 VDD.t341 VSS 0.03506f ; **FLOATING
C9120 VDD.n1251 VSS 0.0538f ; **FLOATING
C9121 VDD.n1252 VSS 0.0136f ; **FLOATING
C9122 VDD.t343 VSS 0.03506f ; **FLOATING
C9123 VDD.n1253 VSS 0.06379f ; **FLOATING
C9124 VDD.n1254 VSS 0.02582f ; **FLOATING
C9125 VDD.t1305 VSS 0.04602f ; **FLOATING
C9126 VDD.n1255 VSS 0.09359f ; **FLOATING
C9127 VDD.t1120 VSS 0.03844f ; **FLOATING
C9128 VDD.n1256 VSS 0.12474f ; **FLOATING
C9129 VDD.t150 VSS 0.0338f ; **FLOATING
C9130 VDD.t1671 VSS 0.11628f ; **FLOATING
C9131 VDD.n1257 VSS 0.14231f ; **FLOATING
C9132 VDD.t147 VSS 0.0338f ; **FLOATING
C9133 VDD.t1672 VSS 0.11628f ; **FLOATING
C9134 VDD.n1258 VSS 0.14231f ; **FLOATING
C9135 VDD.n1259 VSS 0.08884f ; **FLOATING
C9136 VDD.t158 VSS 0.0338f ; **FLOATING
C9137 VDD.t1673 VSS 0.11628f ; **FLOATING
C9138 VDD.n1260 VSS 0.06395f ; **FLOATING
C9139 VDD.n1261 VSS 0.0136f ; **FLOATING
C9140 VDD.n1262 VSS 0.0538f ; **FLOATING
C9141 VDD.n1263 VSS 0.01948f ; **FLOATING
C9142 VDD.n1264 VSS 0.06368f ; **FLOATING
C9143 VDD.n1265 VSS 0.01379f ; **FLOATING
C9144 VDD.n1266 VSS 0.05325f ; **FLOATING
C9145 VDD.n1268 VSS 0.05439f ; **FLOATING
C9146 VDD.t1429 VSS 0.04618f ; **FLOATING
C9147 VDD.t198 VSS 0.0338f ; **FLOATING
C9148 VDD.t1674 VSS 0.11628f ; **FLOATING
C9149 VDD.n1269 VSS 0.14231f ; **FLOATING
C9150 VDD.n1270 VSS 0.12416f ; **FLOATING
C9151 VDD.t263 VSS 0.0338f ; **FLOATING
C9152 VDD.t1675 VSS 0.11628f ; **FLOATING
C9153 VDD.n1271 VSS 0.14231f ; **FLOATING
C9154 VDD.t136 VSS 0.0338f ; **FLOATING
C9155 VDD.t1676 VSS 0.11628f ; **FLOATING
C9156 VDD.t188 VSS 0.0338f ; **FLOATING
C9157 VDD.t1677 VSS 0.11628f ; **FLOATING
C9158 VDD.n1272 VSS 0.14231f ; **FLOATING
C9159 VDD.t27 VSS 0.0338f ; **FLOATING
C9160 VDD.t1678 VSS 0.11628f ; **FLOATING
C9161 VDD.n1273 VSS 0.14231f ; **FLOATING
C9162 VDD.n1274 VSS 0.08884f ; **FLOATING
C9163 VDD.t200 VSS 0.0338f ; **FLOATING
C9164 VDD.t1679 VSS 0.11628f ; **FLOATING
C9165 VDD.n1275 VSS 0.06395f ; **FLOATING
C9166 VDD.n1276 VSS 0.0136f ; **FLOATING
C9167 VDD.n1277 VSS 0.0538f ; **FLOATING
C9168 VDD.n1278 VSS 0.01948f ; **FLOATING
C9169 VDD.n1279 VSS 0.06368f ; **FLOATING
C9170 VDD.n1280 VSS 0.01379f ; **FLOATING
C9171 VDD.n1281 VSS 0.0781f ; **FLOATING
C9172 VDD.n1282 VSS 0.01183f ; **FLOATING
C9173 VDD.n1283 VSS 0.07521f ; **FLOATING
C9174 VDD.n1284 VSS 0.10444f ; **FLOATING
C9175 VDD.n1285 VSS 0.02582f ; **FLOATING
C9176 VDD.n1286 VSS 0.06379f ; **FLOATING
C9177 VDD.n1287 VSS 0.0136f ; **FLOATING
C9178 VDD.n1288 VSS 0.0538f ; **FLOATING
C9179 VDD.n1289 VSS 0.01948f ; **FLOATING
C9180 VDD.n1290 VSS 0.06368f ; **FLOATING
C9181 VDD.n1291 VSS 0.01379f ; **FLOATING
C9182 VDD.n1292 VSS 0.05325f ; **FLOATING
C9183 VDD.n1294 VSS 0.05439f ; **FLOATING
C9184 VDD.t1344 VSS 0.04618f ; **FLOATING
C9185 VDD.t286 VSS 0.0338f ; **FLOATING
C9186 VDD.t1680 VSS 0.11628f ; **FLOATING
C9187 VDD.n1295 VSS 0.14231f ; **FLOATING
C9188 VDD.n1296 VSS 0.12416f ; **FLOATING
C9189 VDD.t291 VSS 0.0338f ; **FLOATING
C9190 VDD.t1681 VSS 0.11628f ; **FLOATING
C9191 VDD.n1297 VSS 0.14231f ; **FLOATING
C9192 VDD.t64 VSS 0.0338f ; **FLOATING
C9193 VDD.t1682 VSS 0.11628f ; **FLOATING
C9194 VDD.t23 VSS 0.0338f ; **FLOATING
C9195 VDD.t1683 VSS 0.11628f ; **FLOATING
C9196 VDD.n1298 VSS 0.14231f ; **FLOATING
C9197 VDD.t20 VSS 0.0338f ; **FLOATING
C9198 VDD.t1684 VSS 0.11628f ; **FLOATING
C9199 VDD.n1299 VSS 0.14231f ; **FLOATING
C9200 VDD.n1300 VSS 0.08884f ; **FLOATING
C9201 VDD.t62 VSS 0.0338f ; **FLOATING
C9202 VDD.t1685 VSS 0.11628f ; **FLOATING
C9203 VDD.n1301 VSS 0.06395f ; **FLOATING
C9204 VDD.n1302 VSS 0.0136f ; **FLOATING
C9205 VDD.n1303 VSS 0.0538f ; **FLOATING
C9206 VDD.n1304 VSS 0.01948f ; **FLOATING
C9207 VDD.n1305 VSS 0.06368f ; **FLOATING
C9208 VDD.n1306 VSS 0.01379f ; **FLOATING
C9209 VDD.n1307 VSS 0.05325f ; **FLOATING
C9210 VDD.n1309 VSS 0.05439f ; **FLOATING
C9211 VDD.t1326 VSS 0.04618f ; **FLOATING
C9212 VDD.t11 VSS 0.0338f ; **FLOATING
C9213 VDD.t1686 VSS 0.11628f ; **FLOATING
C9214 VDD.n1310 VSS 0.14231f ; **FLOATING
C9215 VDD.n1311 VSS 0.12416f ; **FLOATING
C9216 VDD.n1312 VSS 0.07777f ; **FLOATING
C9217 VDD.n1313 VSS 0.77067f ; **FLOATING
C9218 VDD.t1413 VSS 0.03506f ; **FLOATING
C9219 VDD.t1171 VSS 0.03506f ; **FLOATING
C9220 VDD.n1314 VSS 0.08296f ; **FLOATING
C9221 VDD.t42 VSS 0.03148f ; **FLOATING
C9222 VDD.t577 VSS 0.03506f ; **FLOATING
C9223 VDD.n1315 VSS 0.06395f ; **FLOATING
C9224 VDD.n1316 VSS 0.0136f ; **FLOATING
C9225 VDD.n1317 VSS 0.02895f ; **FLOATING
C9226 VDD.t1144 VSS 0.04602f ; **FLOATING
C9227 VDD.n1318 VSS 0.08826f ; **FLOATING
C9228 VDD.n1319 VSS 0.02582f ; **FLOATING
C9229 VDD.t1367 VSS 0.03506f ; **FLOATING
C9230 VDD.n1320 VSS 0.09318f ; **FLOATING
C9231 VDD.n1321 VSS 0.01229f ; **FLOATING
C9232 VDD.t1227 VSS 0.03908f ; **FLOATING
C9233 VDD.t1097 VSS 0.03908f ; **FLOATING
C9234 VDD.n1322 VSS 0.01297f ; **FLOATING
C9235 VDD.t1235 VSS 0.03908f ; **FLOATING
C9236 VDD.t1535 VSS 0.03908f ; **FLOATING
C9237 VDD.n1323 VSS 0.08331f ; **FLOATING
C9238 VDD.n1324 VSS 0.01238f ; **FLOATING
C9239 VDD.n1325 VSS 0.01826f ; **FLOATING
C9240 VDD.t1451 VSS 0.03506f ; **FLOATING
C9241 VDD.t1162 VSS 0.03506f ; **FLOATING
C9242 VDD.n1326 VSS 0.09793f ; **FLOATING
C9243 VDD.n1327 VSS 0.01605f ; **FLOATING
C9244 VDD.t398 VSS 0.02589f ; **FLOATING
C9245 VDD.t1493 VSS 0.02589f ; **FLOATING
C9246 VDD.n1328 VSS 0.07458f ; **FLOATING
C9247 VDD.t798 VSS 0.03461f ; **FLOATING
C9248 VDD.t942 VSS 0.03461f ; **FLOATING
C9249 VDD.n1329 VSS 0.06957f ; **FLOATING
C9250 VDD.n1330 VSS 0.01714f ; **FLOATING
C9251 VDD.t1414 VSS 0.02589f ; **FLOATING
C9252 VDD.t1170 VSS 0.02589f ; **FLOATING
C9253 VDD.t797 VSS 0.03461f ; **FLOATING
C9254 VDD.t941 VSS 0.03461f ; **FLOATING
C9255 VDD.t1453 VSS 0.02589f ; **FLOATING
C9256 VDD.t1163 VSS 0.02589f ; **FLOATING
C9257 VDD.n1331 VSS 0.07942f ; **FLOATING
C9258 VDD.n1332 VSS 0.01206f ; **FLOATING
C9259 VDD.t399 VSS 0.03461f ; **FLOATING
C9260 VDD.t1279 VSS 0.03461f ; **FLOATING
C9261 VDD.n1333 VSS 0.07004f ; **FLOATING
C9262 VDD.n1334 VSS 0.01711f ; **FLOATING
C9263 VDD.t1267 VSS 0.03908f ; **FLOATING
C9264 VDD.t1280 VSS 0.03908f ; **FLOATING
C9265 VDD.n1335 VSS 0.0783f ; **FLOATING
C9266 VDD.t1415 VSS 0.02589f ; **FLOATING
C9267 VDD.t1169 VSS 0.02589f ; **FLOATING
C9268 VDD.n1336 VSS 0.06972f ; **FLOATING
C9269 VDD.n1337 VSS 0.01276f ; **FLOATING
C9270 VDD.t1260 VSS 0.03461f ; **FLOATING
C9271 VDD.t868 VSS 0.03461f ; **FLOATING
C9272 VDD.n1338 VSS 0.07424f ; **FLOATING
C9273 VDD.t1261 VSS 0.03908f ; **FLOATING
C9274 VDD.t869 VSS 0.03908f ; **FLOATING
C9275 VDD.n1339 VSS 0.01252f ; **FLOATING
C9276 VDD.t536 VSS 0.03506f ; **FLOATING
C9277 VDD.t915 VSS 0.03518f ; **FLOATING
C9278 VDD.t1372 VSS 0.03506f ; **FLOATING
C9279 VDD.n1340 VSS 0.07345f ; **FLOATING
C9280 VDD.n1341 VSS 0.01379f ; **FLOATING
C9281 VDD.t1294 VSS 0.03506f ; **FLOATING
C9282 VDD.n1342 VSS 0.06368f ; **FLOATING
C9283 VDD.t892 VSS 0.03506f ; **FLOATING
C9284 VDD.n1343 VSS 0.0538f ; **FLOATING
C9285 VDD.n1344 VSS 0.01948f ; **FLOATING
C9286 VDD.t568 VSS 0.03506f ; **FLOATING
C9287 VDD.t95 VSS 0.03147f ; **FLOATING
C9288 VDD.t323 VSS 0.03148f ; **FLOATING
C9289 VDD.t1045 VSS 0.03506f ; **FLOATING
C9290 VDD.t43 VSS 0.0338f ; **FLOATING
C9291 VDD.t1634 VSS 0.11628f ; **FLOATING
C9292 VDD.t1333 VSS 0.04602f ; **FLOATING
C9293 VDD.t238 VSS 0.0338f ; **FLOATING
C9294 VDD.t1633 VSS 0.11628f ; **FLOATING
C9295 VDD.n1345 VSS 0.14231f ; **FLOATING
C9296 VDD.n1346 VSS 0.08884f ; **FLOATING
C9297 VDD.t385 VSS 0.03506f ; **FLOATING
C9298 VDD.t239 VSS 0.03147f ; **FLOATING
C9299 VDD.t153 VSS 0.03148f ; **FLOATING
C9300 VDD.t156 VSS 0.03147f ; **FLOATING
C9301 VDD.t573 VSS 0.03506f ; **FLOATING
C9302 VDD.t928 VSS 0.03506f ; **FLOATING
C9303 VDD.t889 VSS 0.03506f ; **FLOATING
C9304 VDD.t1190 VSS 0.03506f ; **FLOATING
C9305 VDD.t59 VSS 0.03148f ; **FLOATING
C9306 VDD.t847 VSS 0.04602f ; **FLOATING
C9307 VDD.t1277 VSS 0.03506f ; **FLOATING
C9308 VDD.t94 VSS 0.03147f ; **FLOATING
C9309 VDD.t1050 VSS 0.03506f ; **FLOATING
C9310 VDD.t159 VSS 0.03148f ; **FLOATING
C9311 VDD.t1370 VSS 0.03506f ; **FLOATING
C9312 VDD.t194 VSS 0.03147f ; **FLOATING
C9313 VDD.t129 VSS 0.03148f ; **FLOATING
C9314 VDD.t1049 VSS 0.04618f ; **FLOATING
C9315 VDD.n1347 VSS 0.01948f ; **FLOATING
C9316 VDD.t859 VSS 0.03506f ; **FLOATING
C9317 VDD.n1348 VSS 0.06368f ; **FLOATING
C9318 VDD.n1349 VSS 0.01379f ; **FLOATING
C9319 VDD.t132 VSS 0.03147f ; **FLOATING
C9320 VDD.t574 VSS 0.03506f ; **FLOATING
C9321 VDD.n1350 VSS 0.05325f ; **FLOATING
C9322 VDD.t1487 VSS 0.03506f ; **FLOATING
C9323 VDD.n1352 VSS 0.0538f ; **FLOATING
C9324 VDD.n1353 VSS 0.0136f ; **FLOATING
C9325 VDD.t1191 VSS 0.03506f ; **FLOATING
C9326 VDD.n1354 VSS 0.06423f ; **FLOATING
C9327 VDD.t28 VSS 0.03148f ; **FLOATING
C9328 VDD.t897 VSS 0.04602f ; **FLOATING
C9329 VDD.t66 VSS 0.03147f ; **FLOATING
C9330 VDD.t570 VSS 0.03506f ; **FLOATING
C9331 VDD.t133 VSS 0.03148f ; **FLOATING
C9332 VDD.t794 VSS 0.03506f ; **FLOATING
C9333 VDD.t1373 VSS 0.03506f ; **FLOATING
C9334 VDD.t227 VSS 0.03147f ; **FLOATING
C9335 VDD.t228 VSS 0.03148f ; **FLOATING
C9336 VDD.t231 VSS 0.03147f ; **FLOATING
C9337 VDD.t578 VSS 0.03506f ; **FLOATING
C9338 VDD.t1057 VSS 0.03506f ; **FLOATING
C9339 VDD.t1488 VSS 0.03506f ; **FLOATING
C9340 VDD.t969 VSS 0.03506f ; **FLOATING
C9341 VDD.t933 VSS 0.04602f ; **FLOATING
C9342 VDD.t1610 VSS 0.03506f ; **FLOATING
C9343 VDD.t1523 VSS 0.03506f ; **FLOATING
C9344 VDD.t1612 VSS 0.03506f ; **FLOATING
C9345 VDD.t1368 VSS 0.03506f ; **FLOATING
C9346 VDD.t777 VSS 0.03723f ; **FLOATING
C9347 VDD.t787 VSS 0.04602f ; **FLOATING
C9348 VDD.t1150 VSS 0.06573f ; **FLOATING
C9349 VDD.t572 VSS 0.03506f ; **FLOATING
C9350 VDD.t517 VSS 0.03506f ; **FLOATING
C9351 VDD.t1489 VSS 0.03506f ; **FLOATING
C9352 VDD.t1189 VSS 0.03506f ; **FLOATING
C9353 VDD.t1616 VSS 0.03148f ; **FLOATING
C9354 VDD.t934 VSS 0.04602f ; **FLOATING
C9355 VDD.t971 VSS 0.03506f ; **FLOATING
C9356 VDD.t71 VSS 0.03147f ; **FLOATING
C9357 VDD.t1114 VSS 0.03506f ; **FLOATING
C9358 VDD.t3 VSS 0.03148f ; **FLOATING
C9359 VDD.t1369 VSS 0.03506f ; **FLOATING
C9360 VDD.t17 VSS 0.03147f ; **FLOATING
C9361 VDD.t308 VSS 0.03148f ; **FLOATING
C9362 VDD.t377 VSS 0.04618f ; **FLOATING
C9363 VDD.n1355 VSS 0.01948f ; **FLOATING
C9364 VDD.t520 VSS 0.03506f ; **FLOATING
C9365 VDD.n1356 VSS 0.06368f ; **FLOATING
C9366 VDD.n1357 VSS 0.01379f ; **FLOATING
C9367 VDD.t311 VSS 0.03147f ; **FLOATING
C9368 VDD.t575 VSS 0.03506f ; **FLOATING
C9369 VDD.n1358 VSS 0.05325f ; **FLOATING
C9370 VDD.t890 VSS 0.03506f ; **FLOATING
C9371 VDD.n1360 VSS 0.0538f ; **FLOATING
C9372 VDD.n1361 VSS 0.0136f ; **FLOATING
C9373 VDD.t1192 VSS 0.03506f ; **FLOATING
C9374 VDD.n1362 VSS 0.06395f ; **FLOATING
C9375 VDD.t1615 VSS 0.03148f ; **FLOATING
C9376 VDD.t600 VSS 0.04602f ; **FLOATING
C9377 VDD.t19 VSS 0.03147f ; **FLOATING
C9378 VDD.t571 VSS 0.03506f ; **FLOATING
C9379 VDD.t8 VSS 0.03148f ; **FLOATING
C9380 VDD.t1115 VSS 0.03506f ; **FLOATING
C9381 VDD.t1374 VSS 0.03506f ; **FLOATING
C9382 VDD.t15 VSS 0.03147f ; **FLOATING
C9383 VDD.t173 VSS 0.03148f ; **FLOATING
C9384 VDD.t196 VSS 0.03147f ; **FLOATING
C9385 VDD.t579 VSS 0.03506f ; **FLOATING
C9386 VDD.t1355 VSS 0.03506f ; **FLOATING
C9387 VDD.t891 VSS 0.03506f ; **FLOATING
C9388 VDD.t970 VSS 0.03506f ; **FLOATING
C9389 VDD.t232 VSS 0.03148f ; **FLOATING
C9390 VDD.t911 VSS 0.04602f ; **FLOATING
C9391 VDD.t1611 VSS 0.03506f ; **FLOATING
C9392 VDD.t192 VSS 0.03147f ; **FLOATING
C9393 VDD.t1089 VSS 0.03506f ; **FLOATING
C9394 VDD.t312 VSS 0.03148f ; **FLOATING
C9395 VDD.t825 VSS 0.03506f ; **FLOATING
C9396 VDD.t325 VSS 0.03147f ; **FLOATING
C9397 VDD.t326 VSS 0.03148f ; **FLOATING
C9398 VDD.t775 VSS 0.04618f ; **FLOATING
C9399 VDD.n1363 VSS 0.01948f ; **FLOATING
C9400 VDD.t1485 VSS 0.03506f ; **FLOATING
C9401 VDD.n1364 VSS 0.06368f ; **FLOATING
C9402 VDD.n1365 VSS 0.01379f ; **FLOATING
C9403 VDD.t329 VSS 0.03147f ; **FLOATING
C9404 VDD.n1366 VSS 0.05439f ; **FLOATING
C9405 VDD.t1371 VSS 0.03506f ; **FLOATING
C9406 VDD.n1367 VSS 0.05325f ; **FLOATING
C9407 VDD.t888 VSS 0.03506f ; **FLOATING
C9408 VDD.n1369 VSS 0.0538f ; **FLOATING
C9409 VDD.n1370 VSS 0.0136f ; **FLOATING
C9410 VDD.t576 VSS 0.03506f ; **FLOATING
C9411 VDD.n1371 VSS 0.06379f ; **FLOATING
C9412 VDD.n1372 VSS 0.02582f ; **FLOATING
C9413 VDD.t961 VSS 0.04602f ; **FLOATING
C9414 VDD.n1373 VSS 0.09359f ; **FLOATING
C9415 VDD.t569 VSS 0.03844f ; **FLOATING
C9416 VDD.n1374 VSS 0.12474f ; **FLOATING
C9417 VDD.t327 VSS 0.0338f ; **FLOATING
C9418 VDD.t1617 VSS 0.11628f ; **FLOATING
C9419 VDD.n1375 VSS 0.14231f ; **FLOATING
C9420 VDD.t313 VSS 0.0338f ; **FLOATING
C9421 VDD.t1618 VSS 0.11628f ; **FLOATING
C9422 VDD.n1376 VSS 0.14231f ; **FLOATING
C9423 VDD.n1377 VSS 0.08884f ; **FLOATING
C9424 VDD.t191 VSS 0.0338f ; **FLOATING
C9425 VDD.t1619 VSS 0.11628f ; **FLOATING
C9426 VDD.n1378 VSS 0.06395f ; **FLOATING
C9427 VDD.n1379 VSS 0.0136f ; **FLOATING
C9428 VDD.n1380 VSS 0.0538f ; **FLOATING
C9429 VDD.n1381 VSS 0.01948f ; **FLOATING
C9430 VDD.n1382 VSS 0.06368f ; **FLOATING
C9431 VDD.n1383 VSS 0.01379f ; **FLOATING
C9432 VDD.n1384 VSS 0.05325f ; **FLOATING
C9433 VDD.n1386 VSS 0.05439f ; **FLOATING
C9434 VDD.t939 VSS 0.04618f ; **FLOATING
C9435 VDD.t174 VSS 0.0338f ; **FLOATING
C9436 VDD.t1620 VSS 0.11628f ; **FLOATING
C9437 VDD.n1387 VSS 0.14231f ; **FLOATING
C9438 VDD.n1388 VSS 0.12416f ; **FLOATING
C9439 VDD.t9 VSS 0.0338f ; **FLOATING
C9440 VDD.t1621 VSS 0.11628f ; **FLOATING
C9441 VDD.n1389 VSS 0.14231f ; **FLOATING
C9442 VDD.t18 VSS 0.0338f ; **FLOATING
C9443 VDD.t1622 VSS 0.11628f ; **FLOATING
C9444 VDD.t309 VSS 0.0338f ; **FLOATING
C9445 VDD.t1623 VSS 0.11628f ; **FLOATING
C9446 VDD.n1390 VSS 0.14231f ; **FLOATING
C9447 VDD.t4 VSS 0.0338f ; **FLOATING
C9448 VDD.t1624 VSS 0.11628f ; **FLOATING
C9449 VDD.n1391 VSS 0.14231f ; **FLOATING
C9450 VDD.n1392 VSS 0.08884f ; **FLOATING
C9451 VDD.t70 VSS 0.0338f ; **FLOATING
C9452 VDD.t1625 VSS 0.11628f ; **FLOATING
C9453 VDD.n1393 VSS 0.06395f ; **FLOATING
C9454 VDD.n1394 VSS 0.0136f ; **FLOATING
C9455 VDD.n1395 VSS 0.0538f ; **FLOATING
C9456 VDD.n1396 VSS 0.01948f ; **FLOATING
C9457 VDD.n1397 VSS 0.06368f ; **FLOATING
C9458 VDD.n1398 VSS 0.01379f ; **FLOATING
C9459 VDD.n1399 VSS 0.0781f ; **FLOATING
C9460 VDD.n1400 VSS 0.01183f ; **FLOATING
C9461 VDD.n1401 VSS 0.07521f ; **FLOATING
C9462 VDD.n1402 VSS 0.10444f ; **FLOATING
C9463 VDD.n1403 VSS 0.02582f ; **FLOATING
C9464 VDD.n1404 VSS 0.06379f ; **FLOATING
C9465 VDD.n1405 VSS 0.0136f ; **FLOATING
C9466 VDD.n1406 VSS 0.0538f ; **FLOATING
C9467 VDD.n1407 VSS 0.01948f ; **FLOATING
C9468 VDD.n1408 VSS 0.06368f ; **FLOATING
C9469 VDD.n1409 VSS 0.01379f ; **FLOATING
C9470 VDD.n1410 VSS 0.05325f ; **FLOATING
C9471 VDD.n1412 VSS 0.05439f ; **FLOATING
C9472 VDD.t539 VSS 0.04618f ; **FLOATING
C9473 VDD.t229 VSS 0.0338f ; **FLOATING
C9474 VDD.t1626 VSS 0.11628f ; **FLOATING
C9475 VDD.n1413 VSS 0.14231f ; **FLOATING
C9476 VDD.n1414 VSS 0.12416f ; **FLOATING
C9477 VDD.t134 VSS 0.0338f ; **FLOATING
C9478 VDD.t1627 VSS 0.11628f ; **FLOATING
C9479 VDD.n1415 VSS 0.14231f ; **FLOATING
C9480 VDD.t29 VSS 0.0338f ; **FLOATING
C9481 VDD.t1628 VSS 0.11628f ; **FLOATING
C9482 VDD.t130 VSS 0.0338f ; **FLOATING
C9483 VDD.t1629 VSS 0.11628f ; **FLOATING
C9484 VDD.n1416 VSS 0.14231f ; **FLOATING
C9485 VDD.t160 VSS 0.0338f ; **FLOATING
C9486 VDD.t1630 VSS 0.11628f ; **FLOATING
C9487 VDD.n1417 VSS 0.14231f ; **FLOATING
C9488 VDD.n1418 VSS 0.08884f ; **FLOATING
C9489 VDD.t60 VSS 0.0338f ; **FLOATING
C9490 VDD.t1631 VSS 0.11628f ; **FLOATING
C9491 VDD.n1419 VSS 0.06395f ; **FLOATING
C9492 VDD.n1420 VSS 0.0136f ; **FLOATING
C9493 VDD.n1421 VSS 0.0538f ; **FLOATING
C9494 VDD.n1422 VSS 0.01948f ; **FLOATING
C9495 VDD.n1423 VSS 0.06368f ; **FLOATING
C9496 VDD.n1424 VSS 0.01379f ; **FLOATING
C9497 VDD.n1425 VSS 0.05325f ; **FLOATING
C9498 VDD.n1427 VSS 0.05439f ; **FLOATING
C9499 VDD.t1006 VSS 0.04618f ; **FLOATING
C9500 VDD.t154 VSS 0.0338f ; **FLOATING
C9501 VDD.t1632 VSS 0.11628f ; **FLOATING
C9502 VDD.n1428 VSS 0.14231f ; **FLOATING
C9503 VDD.n1429 VSS 0.12416f ; **FLOATING
C9504 VDD.n1430 VSS 0.19109f ; **FLOATING
C9505 VDD.n1431 VSS 1.63103f ; **FLOATING
C9506 VDD.t494 VSS 0.07104f ; **FLOATING
C9507 VDD.n1433 VSS 0.02689f ; **FLOATING
C9508 VDD.n1434 VSS 0.05149f ; **FLOATING
C9509 VDD.n1435 VSS 0.05149f ; **FLOATING
C9510 VDD.n1436 VSS 0.05149f ; **FLOATING
C9511 VDD.n1437 VSS 0.05149f ; **FLOATING
C9512 VDD.n1438 VSS 0.05149f ; **FLOATING
C9513 VDD.n1439 VSS 0.05149f ; **FLOATING
C9514 VDD.n1440 VSS 0.05149f ; **FLOATING
C9515 VDD.n1441 VSS 0.05149f ; **FLOATING
C9516 VDD.n1442 VSS 0.05149f ; **FLOATING
C9517 VDD.n1443 VSS 0.05149f ; **FLOATING
C9518 VDD.n1444 VSS 0.05149f ; **FLOATING
C9519 VDD.n1445 VSS 0.05149f ; **FLOATING
C9520 VDD.n1446 VSS 0.05149f ; **FLOATING
C9521 VDD.n1447 VSS 0.05149f ; **FLOATING
C9522 VDD.n1448 VSS 0.05149f ; **FLOATING
C9523 VDD.n1449 VSS 0.05149f ; **FLOATING
C9524 VDD.n1450 VSS 0.05149f ; **FLOATING
C9525 VDD.n1451 VSS 0.05149f ; **FLOATING
C9526 VDD.n1453 VSS 0.08376f ; **FLOATING
C9527 VDD.n1454 VSS 0.04261f ; **FLOATING
C9528 VDD.n1455 VSS 0.05149f ; **FLOATING
C9529 VDD.n1456 VSS 0.05149f ; **FLOATING
C9530 VDD.n1457 VSS 0.05149f ; **FLOATING
C9531 VDD.n1458 VSS 0.05149f ; **FLOATING
C9532 VDD.n1459 VSS 0.05149f ; **FLOATING
C9533 VDD.n1460 VSS 0.05149f ; **FLOATING
C9534 VDD.n1461 VSS 0.05149f ; **FLOATING
C9535 VDD.n1462 VSS 0.05149f ; **FLOATING
C9536 VDD.n1463 VSS 0.05149f ; **FLOATING
C9537 VDD.n1464 VSS 0.05149f ; **FLOATING
C9538 VDD.n1465 VSS 0.05422f ; **FLOATING
C9539 VDD.t493 VSS 0.0345f ; **FLOATING
C9540 VDD.n1466 VSS 0.09203f ; **FLOATING
C9541 VDD.t729 VSS 0.03387f ; **FLOATING
C9542 VDD.t1296 VSS 0.03972f ; **FLOATING
C9543 VDD.n1467 VSS 0.09303f ; **FLOATING
C9544 VDD.n1468 VSS 0.11127f ; **FLOATING
C9545 VDD.t612 VSS 0.03387f ; **FLOATING
C9546 VDD.n1469 VSS 0.02512f ; **FLOATING
C9547 VDD.t1085 VSS 0.03972f ; **FLOATING
C9548 VDD.n1470 VSS 0.11127f ; **FLOATING
C9549 VDD.t620 VSS 0.03387f ; **FLOATING
C9550 VDD.t1298 VSS 0.03972f ; **FLOATING
C9551 VDD.n1471 VSS 0.11127f ; **FLOATING
C9552 VDD.t750 VSS 0.03387f ; **FLOATING
C9553 VDD.t1046 VSS 0.03972f ; **FLOATING
C9554 VDD.n1472 VSS 0.11127f ; **FLOATING
C9555 VDD.t728 VSS 0.03387f ; **FLOATING
C9556 VDD.t857 VSS 0.03972f ; **FLOATING
C9557 VDD.n1473 VSS 0.11127f ; **FLOATING
C9558 VDD.t751 VSS 0.03387f ; **FLOATING
C9559 VDD.n1474 VSS 0.02512f ; **FLOATING
C9560 VDD.n1475 VSS 0.07175f ; **FLOATING
C9561 VDD.t927 VSS 0.03972f ; **FLOATING
C9562 VDD.n1476 VSS 0.08275f ; **FLOATING
C9563 VDD.n1477 VSS 0.11127f ; **FLOATING
C9564 VDD.t719 VSS 0.03387f ; **FLOATING
C9565 VDD.n1478 VSS 0.02512f ; **FLOATING
C9566 VDD.n1479 VSS 0.06297f ; **FLOATING
C9567 VDD.t1299 VSS 0.03972f ; **FLOATING
C9568 VDD.n1480 VSS 0.11127f ; **FLOATING
C9569 VDD.t752 VSS 0.03387f ; **FLOATING
C9570 VDD.t975 VSS 0.03972f ; **FLOATING
C9571 VDD.n1481 VSS 0.11127f ; **FLOATING
C9572 VDD.t745 VSS 0.03387f ; **FLOATING
C9573 VDD.t792 VSS 0.03972f ; **FLOATING
C9574 VDD.n1482 VSS 0.11127f ; **FLOATING
C9575 VDD.t721 VSS 0.03387f ; **FLOATING
C9576 VDD.n1483 VSS 0.02512f ; **FLOATING
C9577 VDD.n1484 VSS 0.08142f ; **FLOATING
C9578 VDD.t858 VSS 0.03972f ; **FLOATING
C9579 VDD.n1485 VSS 0.10178f ; **FLOATING
C9580 VDD.t622 VSS 0.03387f ; **FLOATING
C9581 VDD.t954 VSS 0.03972f ; **FLOATING
C9582 VDD.n1486 VSS 0.08373f ; **FLOATING
C9583 VDD.n1487 VSS 0.07191f ; **FLOATING
C9584 VDD.t753 VSS 0.03387f ; **FLOATING
C9585 VDD.t795 VSS 0.03972f ; **FLOATING
C9586 VDD.n1488 VSS 0.11127f ; **FLOATING
C9587 VDD.t621 VSS 0.03387f ; **FLOATING
C9588 VDD.t538 VSS 0.03972f ; **FLOATING
C9589 VDD.n1489 VSS 0.11127f ; **FLOATING
C9590 VDD.t754 VSS 0.03387f ; **FLOATING
C9591 VDD.t1058 VSS 0.03972f ; **FLOATING
C9592 VDD.n1490 VSS 0.11127f ; **FLOATING
C9593 VDD.t756 VSS 0.03387f ; **FLOATING
C9594 VDD.n1491 VSS 0.02512f ; **FLOATING
C9595 VDD.n1492 VSS 0.06293f ; **FLOATING
C9596 VDD.t932 VSS 0.03972f ; **FLOATING
C9597 VDD.n1493 VSS 0.11127f ; **FLOATING
C9598 VDD.t755 VSS 0.03387f ; **FLOATING
C9599 VDD.n1494 VSS 0.02512f ; **FLOATING
C9600 VDD.n1495 VSS 0.0755f ; **FLOATING
C9601 VDD.t541 VSS 0.03972f ; **FLOATING
C9602 VDD.n1496 VSS 0.11127f ; **FLOATING
C9603 VDD.t749 VSS 0.03387f ; **FLOATING
C9604 VDD.t811 VSS 0.03972f ; **FLOATING
C9605 VDD.n1497 VSS 0.11127f ; **FLOATING
C9606 VDD.t748 VSS 0.03387f ; **FLOATING
C9607 VDD.t518 VSS 0.03972f ; **FLOATING
C9608 VDD.n1498 VSS 0.11127f ; **FLOATING
C9609 VDD.t746 VSS 0.03387f ; **FLOATING
C9610 VDD.t935 VSS 0.03972f ; **FLOATING
C9611 VDD.n1499 VSS 0.11127f ; **FLOATING
C9612 VDD.t757 VSS 0.03387f ; **FLOATING
C9613 VDD.n1500 VSS 0.02512f ; **FLOATING
C9614 VDD.t1113 VSS 0.03972f ; **FLOATING
C9615 VDD.n1501 VSS 0.11127f ; **FLOATING
C9616 VDD.t747 VSS 0.03387f ; **FLOATING
C9617 VDD.n1502 VSS 0.02512f ; **FLOATING
C9618 VDD.t376 VSS 0.03972f ; **FLOATING
C9619 VDD.n1503 VSS 0.11127f ; **FLOATING
C9620 VDD.t758 VSS 0.03387f ; **FLOATING
C9621 VDD.t521 VSS 0.03972f ; **FLOATING
C9622 VDD.n1504 VSS 0.11127f ; **FLOATING
C9623 VDD.t762 VSS 0.03387f ; **FLOATING
C9624 VDD.t599 VSS 0.03972f ; **FLOATING
C9625 VDD.n1505 VSS 0.11127f ; **FLOATING
C9626 VDD.t759 VSS 0.03387f ; **FLOATING
C9627 VDD.t1011 VSS 0.03972f ; **FLOATING
C9628 VDD.t761 VSS 0.03387f ; **FLOATING
C9629 VDD.t1064 VSS 0.03972f ; **FLOATING
C9630 VDD.n1506 VSS 0.11127f ; **FLOATING
C9631 VDD.t765 VSS 0.03387f ; **FLOATING
C9632 VDD.t1354 VSS 0.03972f ; **FLOATING
C9633 VDD.n1507 VSS 0.09444f ; **FLOATING
C9634 VDD.n1508 VSS 0.11127f ; **FLOATING
C9635 VDD.t764 VSS 0.03387f ; **FLOATING
C9636 VDD.t979 VSS 0.03972f ; **FLOATING
C9637 VDD.n1509 VSS 0.11127f ; **FLOATING
C9638 VDD.t763 VSS 0.03387f ; **FLOATING
C9639 VDD.n1510 VSS 0.02512f ; **FLOATING
C9640 VDD.t957 VSS 0.03972f ; **FLOATING
C9641 VDD.n1511 VSS 0.11127f ; **FLOATING
C9642 VDD.t760 VSS 0.03387f ; **FLOATING
C9643 VDD.t1071 VSS 0.03972f ; **FLOATING
C9644 VDD.n1512 VSS 0.11127f ; **FLOATING
C9645 VDD.t768 VSS 0.03387f ; **FLOATING
C9646 VDD.t936 VSS 0.03972f ; **FLOATING
C9647 VDD.n1513 VSS 0.11127f ; **FLOATING
C9648 VDD.t767 VSS 0.03387f ; **FLOATING
C9649 VDD.n1514 VSS 0.02512f ; **FLOATING
C9650 VDD.n1515 VSS 0.0803f ; **FLOATING
C9651 VDD.t1357 VSS 0.03972f ; **FLOATING
C9652 VDD.n1516 VSS 0.09209f ; **FLOATING
C9653 VDD.t766 VSS 0.03387f ; **FLOATING
C9654 VDD.n1517 VSS 0.02512f ; **FLOATING
C9655 VDD.t1118 VSS 0.03972f ; **FLOATING
C9656 VDD.n1518 VSS 0.04837f ; **FLOATING
C9657 VDD.t496 VSS 0.03387f ; **FLOATING
C9658 VDD.n1519 VSS 0.03374f ; **FLOATING
C9659 VDD.t495 VSS 0.03785f ; **FLOATING
C9660 VDD.n1520 VSS 0.02746f ; **FLOATING
C9661 VDD.n1521 VSS 0.06312f ; **FLOATING
C9662 VDD.t497 VSS 0.03273f ; **FLOATING
C9663 VDD.n1522 VSS 0.01669f ; **FLOATING
C9664 VDD.t498 VSS 0.03387f ; **FLOATING
C9665 VDD.n1523 VSS 0.02249f ; **FLOATING
C9666 VDD.n1524 VSS 0.07437f ; **FLOATING
C9667 VDD.n1526 VSS 0.04329f ; **FLOATING
C9668 VDD.n1527 VSS 0.06303f ; **FLOATING
C9669 VDD.n1528 VSS 0.01472f ; **FLOATING
C9670 VDD.n1529 VSS 0.06296f ; **FLOATING
C9671 VDD.n1530 VSS 0.0827f ; **FLOATING
C9672 VDD.n1531 VSS 0.09345f ; **FLOATING
C9673 VDD.n1532 VSS 0.08272f ; **FLOATING
C9674 VDD.n1533 VSS 0.01472f ; **FLOATING
C9675 VDD.n1534 VSS 0.0718f ; **FLOATING
C9676 VDD.n1535 VSS 0.08652f ; **FLOATING
C9677 VDD.n1536 VSS 0.08269f ; **FLOATING
C9678 VDD.n1537 VSS 0.01472f ; **FLOATING
C9679 VDD.n1538 VSS 0.06291f ; **FLOATING
C9680 VDD.n1539 VSS 0.08269f ; **FLOATING
C9681 VDD.n1540 VSS 0.01472f ; **FLOATING
C9682 VDD.n1541 VSS 0.06296f ; **FLOATING
C9683 VDD.n1542 VSS 0.09418f ; **FLOATING
C9684 VDD.n1543 VSS 0.08269f ; **FLOATING
C9685 VDD.n1544 VSS 0.09418f ; **FLOATING
C9686 VDD.n1545 VSS 0.08271f ; **FLOATING
C9687 VDD.n1546 VSS 0.08269f ; **FLOATING
C9688 VDD.n1547 VSS 0.08271f ; **FLOATING
C9689 VDD.n1548 VSS 0.01472f ; **FLOATING
C9690 VDD.n1549 VSS 0.06297f ; **FLOATING
C9691 VDD.t489 VSS 0.03785f ; **FLOATING
C9692 VDD.t490 VSS 0.03387f ; **FLOATING
C9693 VDD.n1550 VSS 0.02299f ; **FLOATING
C9694 VDD.t488 VSS 0.02445f ; **FLOATING
C9695 VDD.n1551 VSS 0.41263f ; **FLOATING
C9696 VDD.n1552 VSS 0.41263f ; **FLOATING
C9697 VDD.n1553 VSS 0.56914f ; **FLOATING
C9698 VDD.t1561 VSS 0.03506f ; **FLOATING
C9699 VDD.t526 VSS 0.03506f ; **FLOATING
C9700 VDD.n1554 VSS 0.08296f ; **FLOATING
C9701 VDD.t48 VSS 0.03148f ; **FLOATING
C9702 VDD.t822 VSS 0.03506f ; **FLOATING
C9703 VDD.n1555 VSS 0.06395f ; **FLOATING
C9704 VDD.n1556 VSS 0.0136f ; **FLOATING
C9705 VDD.n1557 VSS 0.02895f ; **FLOATING
C9706 VDD.t587 VSS 0.04602f ; **FLOATING
C9707 VDD.n1558 VSS 0.08826f ; **FLOATING
C9708 VDD.n1559 VSS 0.02582f ; **FLOATING
C9709 VDD.t1103 VSS 0.03506f ; **FLOATING
C9710 VDD.n1560 VSS 0.09318f ; **FLOATING
C9711 VDD.n1561 VSS 0.01229f ; **FLOATING
C9712 VDD.t1272 VSS 0.03908f ; **FLOATING
C9713 VDD.t1423 VSS 0.03908f ; **FLOATING
C9714 VDD.n1562 VSS 0.01297f ; **FLOATING
C9715 VDD.t1081 VSS 0.03908f ; **FLOATING
C9716 VDD.t1437 VSS 0.03908f ; **FLOATING
C9717 VDD.n1563 VSS 0.08331f ; **FLOATING
C9718 VDD.n1564 VSS 0.01238f ; **FLOATING
C9719 VDD.n1565 VSS 0.01826f ; **FLOATING
C9720 VDD.t1153 VSS 0.03506f ; **FLOATING
C9721 VDD.t806 VSS 0.03506f ; **FLOATING
C9722 VDD.n1566 VSS 0.09793f ; **FLOATING
C9723 VDD.n1567 VSS 0.01605f ; **FLOATING
C9724 VDD.t513 VSS 0.02589f ; **FLOATING
C9725 VDD.t1431 VSS 0.02589f ; **FLOATING
C9726 VDD.n1568 VSS 0.07458f ; **FLOATING
C9727 VDD.t580 VSS 0.03461f ; **FLOATING
C9728 VDD.t1425 VSS 0.03461f ; **FLOATING
C9729 VDD.n1569 VSS 0.06957f ; **FLOATING
C9730 VDD.n1570 VSS 0.01714f ; **FLOATING
C9731 VDD.t1562 VSS 0.02589f ; **FLOATING
C9732 VDD.t528 VSS 0.02589f ; **FLOATING
C9733 VDD.t581 VSS 0.03461f ; **FLOATING
C9734 VDD.t1422 VSS 0.03461f ; **FLOATING
C9735 VDD.t1155 VSS 0.02589f ; **FLOATING
C9736 VDD.t805 VSS 0.02589f ; **FLOATING
C9737 VDD.n1571 VSS 0.07942f ; **FLOATING
C9738 VDD.n1572 VSS 0.01206f ; **FLOATING
C9739 VDD.t514 VSS 0.03461f ; **FLOATING
C9740 VDD.t1410 VSS 0.03461f ; **FLOATING
C9741 VDD.n1573 VSS 0.07004f ; **FLOATING
C9742 VDD.n1574 VSS 0.01711f ; **FLOATING
C9743 VDD.t1314 VSS 0.03908f ; **FLOATING
C9744 VDD.t1411 VSS 0.03908f ; **FLOATING
C9745 VDD.n1575 VSS 0.0783f ; **FLOATING
C9746 VDD.t1563 VSS 0.02589f ; **FLOATING
C9747 VDD.t527 VSS 0.02589f ; **FLOATING
C9748 VDD.n1576 VSS 0.06972f ; **FLOATING
C9749 VDD.n1577 VSS 0.01276f ; **FLOATING
C9750 VDD.t1154 VSS 0.03461f ; **FLOATING
C9751 VDD.t804 VSS 0.03461f ; **FLOATING
C9752 VDD.n1578 VSS 0.07424f ; **FLOATING
C9753 VDD.t1274 VSS 0.03908f ; **FLOATING
C9754 VDD.t1406 VSS 0.03908f ; **FLOATING
C9755 VDD.n1579 VSS 0.01252f ; **FLOATING
C9756 VDD.t1216 VSS 0.03506f ; **FLOATING
C9757 VDD.t1095 VSS 0.03518f ; **FLOATING
C9758 VDD.t1375 VSS 0.03506f ; **FLOATING
C9759 VDD.n1580 VSS 0.07345f ; **FLOATING
C9760 VDD.n1581 VSS 0.01379f ; **FLOATING
C9761 VDD.t786 VSS 0.03506f ; **FLOATING
C9762 VDD.n1582 VSS 0.06368f ; **FLOATING
C9763 VDD.t378 VSS 0.03506f ; **FLOATING
C9764 VDD.n1583 VSS 0.0538f ; **FLOATING
C9765 VDD.n1584 VSS 0.01948f ; **FLOATING
C9766 VDD.t1183 VSS 0.03506f ; **FLOATING
C9767 VDD.t50 VSS 0.03147f ; **FLOATING
C9768 VDD.t51 VSS 0.03148f ; **FLOATING
C9769 VDD.t350 VSS 0.03506f ; **FLOATING
C9770 VDD.t49 VSS 0.0338f ; **FLOATING
C9771 VDD.t1652 VSS 0.11628f ; **FLOATING
C9772 VDD.t908 VSS 0.04602f ; **FLOATING
C9773 VDD.t52 VSS 0.0338f ; **FLOATING
C9774 VDD.t1651 VSS 0.11628f ; **FLOATING
C9775 VDD.n1585 VSS 0.14231f ; **FLOATING
C9776 VDD.n1586 VSS 0.08884f ; **FLOATING
C9777 VDD.t1310 VSS 0.03506f ; **FLOATING
C9778 VDD.t54 VSS 0.03147f ; **FLOATING
C9779 VDD.t55 VSS 0.03148f ; **FLOATING
C9780 VDD.t58 VSS 0.03147f ; **FLOATING
C9781 VDD.t1082 VSS 0.03506f ; **FLOATING
C9782 VDD.t1019 VSS 0.03506f ; **FLOATING
C9783 VDD.t601 VSS 0.03506f ; **FLOATING
C9784 VDD.t1200 VSS 0.03506f ; **FLOATING
C9785 VDD.t111 VSS 0.03148f ; **FLOATING
C9786 VDD.t1152 VSS 0.04602f ; **FLOATING
C9787 VDD.t1309 VSS 0.03506f ; **FLOATING
C9788 VDD.t114 VSS 0.03147f ; **FLOATING
C9789 VDD.t365 VSS 0.03506f ; **FLOATING
C9790 VDD.t115 VSS 0.03148f ; **FLOATING
C9791 VDD.t1106 VSS 0.03506f ; **FLOATING
C9792 VDD.t118 VSS 0.03147f ; **FLOATING
C9793 VDD.t119 VSS 0.03148f ; **FLOATING
C9794 VDD.t410 VSS 0.04618f ; **FLOATING
C9795 VDD.n1587 VSS 0.01948f ; **FLOATING
C9796 VDD.t505 VSS 0.03506f ; **FLOATING
C9797 VDD.n1588 VSS 0.06368f ; **FLOATING
C9798 VDD.n1589 VSS 0.01379f ; **FLOATING
C9799 VDD.t122 VSS 0.03147f ; **FLOATING
C9800 VDD.n1590 VSS 0.05439f ; **FLOATING
C9801 VDD.t1083 VSS 0.03506f ; **FLOATING
C9802 VDD.n1591 VSS 0.05325f ; **FLOATING
C9803 VDD.t855 VSS 0.03506f ; **FLOATING
C9804 VDD.n1593 VSS 0.0538f ; **FLOATING
C9805 VDD.n1594 VSS 0.0136f ; **FLOATING
C9806 VDD.t1201 VSS 0.03506f ; **FLOATING
C9807 VDD.n1595 VSS 0.06423f ; **FLOATING
C9808 VDD.t30 VSS 0.03148f ; **FLOATING
C9809 VDD.t562 VSS 0.04602f ; **FLOATING
C9810 VDD.t33 VSS 0.03147f ; **FLOATING
C9811 VDD.t1185 VSS 0.03506f ; **FLOATING
C9812 VDD.t34 VSS 0.03148f ; **FLOATING
C9813 VDD.t1505 VSS 0.03506f ; **FLOATING
C9814 VDD.t1376 VSS 0.03506f ; **FLOATING
C9815 VDD.t37 VSS 0.03147f ; **FLOATING
C9816 VDD.t38 VSS 0.03148f ; **FLOATING
C9817 VDD.t41 VSS 0.03147f ; **FLOATING
C9818 VDD.t823 VSS 0.03506f ; **FLOATING
C9819 VDD.t874 VSS 0.03506f ; **FLOATING
C9820 VDD.t856 VSS 0.03506f ; **FLOATING
C9821 VDD.t1203 VSS 0.03506f ; **FLOATING
C9822 VDD.t1013 VSS 0.04602f ; **FLOATING
C9823 VDD.t1187 VSS 0.03506f ; **FLOATING
C9824 VDD.t545 VSS 0.03506f ; **FLOATING
C9825 VDD.t1509 VSS 0.03506f ; **FLOATING
C9826 VDD.t1104 VSS 0.03506f ; **FLOATING
C9827 VDD.t1438 VSS 0.03723f ; **FLOATING
C9828 VDD.t1249 VSS 0.04602f ; **FLOATING
C9829 VDD.t1439 VSS 0.06573f ; **FLOATING
C9830 VDD.t820 VSS 0.03506f ; **FLOATING
C9831 VDD.t1016 VSS 0.03506f ; **FLOATING
C9832 VDD.t1 VSS 0.03506f ; **FLOATING
C9833 VDD.t1199 VSS 0.03506f ; **FLOATING
C9834 VDD.t77 VSS 0.03148f ; **FLOATING
C9835 VDD.t779 VSS 0.04602f ; **FLOATING
C9836 VDD.t1166 VSS 0.03506f ; **FLOATING
C9837 VDD.t80 VSS 0.03147f ; **FLOATING
C9838 VDD.t1136 VSS 0.03506f ; **FLOATING
C9839 VDD.t81 VSS 0.03148f ; **FLOATING
C9840 VDD.t1105 VSS 0.03506f ; **FLOATING
C9841 VDD.t84 VSS 0.03147f ; **FLOATING
C9842 VDD.t85 VSS 0.03148f ; **FLOATING
C9843 VDD.t1003 VSS 0.04618f ; **FLOATING
C9844 VDD.n1596 VSS 0.01948f ; **FLOATING
C9845 VDD.t560 VSS 0.03506f ; **FLOATING
C9846 VDD.n1597 VSS 0.06368f ; **FLOATING
C9847 VDD.n1598 VSS 0.01379f ; **FLOATING
C9848 VDD.t88 VSS 0.03147f ; **FLOATING
C9849 VDD.t1084 VSS 0.03506f ; **FLOATING
C9850 VDD.n1599 VSS 0.05325f ; **FLOATING
C9851 VDD.t602 VSS 0.03506f ; **FLOATING
C9852 VDD.n1601 VSS 0.0538f ; **FLOATING
C9853 VDD.n1602 VSS 0.0136f ; **FLOATING
C9854 VDD.t1202 VSS 0.03506f ; **FLOATING
C9855 VDD.n1603 VSS 0.06395f ; **FLOATING
C9856 VDD.t137 VSS 0.03148f ; **FLOATING
C9857 VDD.t595 VSS 0.04602f ; **FLOATING
C9858 VDD.t140 VSS 0.03147f ; **FLOATING
C9859 VDD.t1186 VSS 0.03506f ; **FLOATING
C9860 VDD.t141 VSS 0.03148f ; **FLOATING
C9861 VDD.t1504 VSS 0.03506f ; **FLOATING
C9862 VDD.t1377 VSS 0.03506f ; **FLOATING
C9863 VDD.t144 VSS 0.03147f ; **FLOATING
C9864 VDD.t145 VSS 0.03148f ; **FLOATING
C9865 VDD.t234 VSS 0.03147f ; **FLOATING
C9866 VDD.t824 VSS 0.03506f ; **FLOATING
C9867 VDD.t1021 VSS 0.03506f ; **FLOATING
C9868 VDD.t603 VSS 0.03506f ; **FLOATING
C9869 VDD.t1204 VSS 0.03506f ; **FLOATING
C9870 VDD.t72 VSS 0.03148f ; **FLOATING
C9871 VDD.t1028 VSS 0.04602f ; **FLOATING
C9872 VDD.t1188 VSS 0.03506f ; **FLOATING
C9873 VDD.t45 VSS 0.03147f ; **FLOATING
C9874 VDD.t360 VSS 0.03506f ; **FLOATING
C9875 VDD.t46 VSS 0.03148f ; **FLOATING
C9876 VDD.t1311 VSS 0.03506f ; **FLOATING
C9877 VDD.t76 VSS 0.03147f ; **FLOATING
C9878 VDD.t123 VSS 0.03148f ; **FLOATING
C9879 VDD.t1160 VSS 0.04618f ; **FLOATING
C9880 VDD.n1604 VSS 0.01948f ; **FLOATING
C9881 VDD.t1252 VSS 0.03506f ; **FLOATING
C9882 VDD.n1605 VSS 0.06368f ; **FLOATING
C9883 VDD.n1606 VSS 0.01379f ; **FLOATING
C9884 VDD.t126 VSS 0.03147f ; **FLOATING
C9885 VDD.t1308 VSS 0.03506f ; **FLOATING
C9886 VDD.n1607 VSS 0.05325f ; **FLOATING
C9887 VDD.t952 VSS 0.03506f ; **FLOATING
C9888 VDD.n1609 VSS 0.0538f ; **FLOATING
C9889 VDD.n1610 VSS 0.0136f ; **FLOATING
C9890 VDD.t821 VSS 0.03506f ; **FLOATING
C9891 VDD.n1611 VSS 0.06379f ; **FLOATING
C9892 VDD.n1612 VSS 0.02582f ; **FLOATING
C9893 VDD.t1289 VSS 0.04602f ; **FLOATING
C9894 VDD.n1613 VSS 0.09359f ; **FLOATING
C9895 VDD.t1184 VSS 0.03844f ; **FLOATING
C9896 VDD.n1614 VSS 0.12474f ; **FLOATING
C9897 VDD.t124 VSS 0.0338f ; **FLOATING
C9898 VDD.t1635 VSS 0.11628f ; **FLOATING
C9899 VDD.n1615 VSS 0.14231f ; **FLOATING
C9900 VDD.t47 VSS 0.0338f ; **FLOATING
C9901 VDD.t1636 VSS 0.11628f ; **FLOATING
C9902 VDD.n1616 VSS 0.14231f ; **FLOATING
C9903 VDD.n1617 VSS 0.08884f ; **FLOATING
C9904 VDD.t44 VSS 0.0338f ; **FLOATING
C9905 VDD.t1637 VSS 0.11628f ; **FLOATING
C9906 VDD.n1618 VSS 0.06395f ; **FLOATING
C9907 VDD.n1619 VSS 0.0136f ; **FLOATING
C9908 VDD.n1620 VSS 0.0538f ; **FLOATING
C9909 VDD.n1621 VSS 0.01948f ; **FLOATING
C9910 VDD.n1622 VSS 0.06368f ; **FLOATING
C9911 VDD.n1623 VSS 0.01379f ; **FLOATING
C9912 VDD.n1624 VSS 0.05325f ; **FLOATING
C9913 VDD.n1626 VSS 0.05439f ; **FLOATING
C9914 VDD.t1128 VSS 0.04618f ; **FLOATING
C9915 VDD.t146 VSS 0.0338f ; **FLOATING
C9916 VDD.t1638 VSS 0.11628f ; **FLOATING
C9917 VDD.n1627 VSS 0.14231f ; **FLOATING
C9918 VDD.n1628 VSS 0.12416f ; **FLOATING
C9919 VDD.t142 VSS 0.0338f ; **FLOATING
C9920 VDD.t1639 VSS 0.11628f ; **FLOATING
C9921 VDD.n1629 VSS 0.14231f ; **FLOATING
C9922 VDD.t138 VSS 0.0338f ; **FLOATING
C9923 VDD.t1640 VSS 0.11628f ; **FLOATING
C9924 VDD.t86 VSS 0.0338f ; **FLOATING
C9925 VDD.t1641 VSS 0.11628f ; **FLOATING
C9926 VDD.n1630 VSS 0.14231f ; **FLOATING
C9927 VDD.t82 VSS 0.0338f ; **FLOATING
C9928 VDD.t1642 VSS 0.11628f ; **FLOATING
C9929 VDD.n1631 VSS 0.14231f ; **FLOATING
C9930 VDD.n1632 VSS 0.08884f ; **FLOATING
C9931 VDD.t78 VSS 0.0338f ; **FLOATING
C9932 VDD.t1643 VSS 0.11628f ; **FLOATING
C9933 VDD.n1633 VSS 0.06395f ; **FLOATING
C9934 VDD.n1634 VSS 0.0136f ; **FLOATING
C9935 VDD.n1635 VSS 0.0538f ; **FLOATING
C9936 VDD.n1636 VSS 0.01948f ; **FLOATING
C9937 VDD.n1637 VSS 0.06368f ; **FLOATING
C9938 VDD.n1638 VSS 0.01379f ; **FLOATING
C9939 VDD.n1639 VSS 0.0781f ; **FLOATING
C9940 VDD.n1640 VSS 0.01183f ; **FLOATING
C9941 VDD.n1641 VSS 0.07521f ; **FLOATING
C9942 VDD.n1642 VSS 0.10444f ; **FLOATING
C9943 VDD.n1643 VSS 0.02582f ; **FLOATING
C9944 VDD.n1644 VSS 0.06379f ; **FLOATING
C9945 VDD.n1645 VSS 0.0136f ; **FLOATING
C9946 VDD.n1646 VSS 0.0538f ; **FLOATING
C9947 VDD.n1647 VSS 0.01948f ; **FLOATING
C9948 VDD.n1648 VSS 0.06368f ; **FLOATING
C9949 VDD.n1649 VSS 0.01379f ; **FLOATING
C9950 VDD.n1650 VSS 0.05325f ; **FLOATING
C9951 VDD.n1652 VSS 0.05439f ; **FLOATING
C9952 VDD.t906 VSS 0.04618f ; **FLOATING
C9953 VDD.t39 VSS 0.0338f ; **FLOATING
C9954 VDD.t1644 VSS 0.11628f ; **FLOATING
C9955 VDD.n1653 VSS 0.14231f ; **FLOATING
C9956 VDD.n1654 VSS 0.12416f ; **FLOATING
C9957 VDD.t35 VSS 0.0338f ; **FLOATING
C9958 VDD.t1645 VSS 0.11628f ; **FLOATING
C9959 VDD.n1655 VSS 0.14231f ; **FLOATING
C9960 VDD.t31 VSS 0.0338f ; **FLOATING
C9961 VDD.t1646 VSS 0.11628f ; **FLOATING
C9962 VDD.t120 VSS 0.0338f ; **FLOATING
C9963 VDD.t1647 VSS 0.11628f ; **FLOATING
C9964 VDD.n1656 VSS 0.14231f ; **FLOATING
C9965 VDD.t116 VSS 0.0338f ; **FLOATING
C9966 VDD.t1648 VSS 0.11628f ; **FLOATING
C9967 VDD.n1657 VSS 0.14231f ; **FLOATING
C9968 VDD.n1658 VSS 0.08884f ; **FLOATING
C9969 VDD.t112 VSS 0.0338f ; **FLOATING
C9970 VDD.t1649 VSS 0.11628f ; **FLOATING
C9971 VDD.n1659 VSS 0.06395f ; **FLOATING
C9972 VDD.n1660 VSS 0.0136f ; **FLOATING
C9973 VDD.n1661 VSS 0.0538f ; **FLOATING
C9974 VDD.n1662 VSS 0.01948f ; **FLOATING
C9975 VDD.n1663 VSS 0.06368f ; **FLOATING
C9976 VDD.n1664 VSS 0.01379f ; **FLOATING
C9977 VDD.n1665 VSS 0.05325f ; **FLOATING
C9978 VDD.n1667 VSS 0.05439f ; **FLOATING
C9979 VDD.t1229 VSS 0.04618f ; **FLOATING
C9980 VDD.t56 VSS 0.0338f ; **FLOATING
C9981 VDD.t1650 VSS 0.11628f ; **FLOATING
C9982 VDD.n1668 VSS 0.14231f ; **FLOATING
C9983 VDD.n1669 VSS 0.12416f ; **FLOATING
C9984 VDD.n1670 VSS 0.07777f ; **FLOATING
C9985 VDD.n1671 VSS 0.77067f ; **FLOATING
C9986 VDD.n1672 VSS 0.72422f ; **FLOATING
C9987 VDD.n1673 VSS 0.05149f ; **FLOATING
C9988 VDD.n1674 VSS 0.05149f ; **FLOATING
C9989 VDD.n1675 VSS 0.05149f ; **FLOATING
C9990 VDD.n1676 VSS 0.05149f ; **FLOATING
C9991 VDD.n1677 VSS 0.05149f ; **FLOATING
C9992 VDD.n1678 VSS 0.05149f ; **FLOATING
C9993 VDD.n1679 VSS 0.05149f ; **FLOATING
C9994 VDD.n1680 VSS 0.05149f ; **FLOATING
C9995 VDD.n1681 VSS 0.05149f ; **FLOATING
C9996 VDD.n1682 VSS 0.05149f ; **FLOATING
C9997 VDD.n1683 VSS 0.04261f ; **FLOATING
C9998 VDD.n1684 VSS 0.08376f ; **FLOATING
C9999 VDD.n1686 VSS 0.05149f ; **FLOATING
C10000 VDD.n1687 VSS 0.05149f ; **FLOATING
C10001 VDD.n1688 VSS 0.05149f ; **FLOATING
C10002 VDD.n1689 VSS 0.05149f ; **FLOATING
C10003 VDD.n1690 VSS 0.05149f ; **FLOATING
C10004 VDD.n1691 VSS 0.05149f ; **FLOATING
C10005 VDD.n1692 VSS 0.05149f ; **FLOATING
C10006 VDD.n1693 VSS 0.05149f ; **FLOATING
C10007 VDD.n1694 VSS 0.05149f ; **FLOATING
C10008 VDD.n1695 VSS 0.05149f ; **FLOATING
C10009 VDD.n1696 VSS 0.05149f ; **FLOATING
C10010 VDD.n1697 VSS 0.05149f ; **FLOATING
C10011 VDD.n1698 VSS 0.05149f ; **FLOATING
C10012 VDD.n1699 VSS 0.05149f ; **FLOATING
C10013 VDD.n1700 VSS 0.05149f ; **FLOATING
C10014 VDD.n1701 VSS 0.05149f ; **FLOATING
C10015 VDD.n1702 VSS 0.05149f ; **FLOATING
C10016 VDD.n1703 VSS 0.05149f ; **FLOATING
C10017 VDD.n1704 VSS 0.02689f ; **FLOATING
C10018 VDD.t483 VSS 0.07104f ; **FLOATING
C10019 VDD.n1706 VSS 0.07403f ; **FLOATING
C10020 VDD.t486 VSS 0.03273f ; **FLOATING
C10021 VDD.n1707 VSS 0.01669f ; **FLOATING
C10022 VDD.t487 VSS 0.03387f ; **FLOATING
C10023 VDD.n1708 VSS 0.03374f ; **FLOATING
C10024 VDD.t484 VSS 0.03785f ; **FLOATING
C10025 VDD.n1709 VSS 0.04837f ; **FLOATING
C10026 VDD.t485 VSS 0.03387f ; **FLOATING
C10027 VDD.t1029 VSS 0.03972f ; **FLOATING
C10028 VDD.n1710 VSS 0.09209f ; **FLOATING
C10029 VDD.t744 VSS 0.03387f ; **FLOATING
C10030 VDD.t607 VSS 0.03972f ; **FLOATING
C10031 VDD.n1711 VSS 0.11127f ; **FLOATING
C10032 VDD.t716 VSS 0.03387f ; **FLOATING
C10033 VDD.n1712 VSS 0.02512f ; **FLOATING
C10034 VDD.t1248 VSS 0.03972f ; **FLOATING
C10035 VDD.n1713 VSS 0.11127f ; **FLOATING
C10036 VDD.t742 VSS 0.03387f ; **FLOATING
C10037 VDD.t1075 VSS 0.03972f ; **FLOATING
C10038 VDD.n1714 VSS 0.08271f ; **FLOATING
C10039 VDD.n1715 VSS 0.11127f ; **FLOATING
C10040 VDD.t743 VSS 0.03387f ; **FLOATING
C10041 VDD.n1716 VSS 0.02512f ; **FLOATING
C10042 VDD.n1717 VSS 0.08032f ; **FLOATING
C10043 VDD.t361 VSS 0.03972f ; **FLOATING
C10044 VDD.n1718 VSS 0.11127f ; **FLOATING
C10045 VDD.t609 VSS 0.03387f ; **FLOATING
C10046 VDD.t1027 VSS 0.03972f ; **FLOATING
C10047 VDD.n1719 VSS 0.11127f ; **FLOATING
C10048 VDD.t720 VSS 0.03387f ; **FLOATING
C10049 VDD.t910 VSS 0.03972f ; **FLOATING
C10050 VDD.n1720 VSS 0.11127f ; **FLOATING
C10051 VDD.t741 VSS 0.03387f ; **FLOATING
C10052 VDD.t1129 VSS 0.03972f ; **FLOATING
C10053 VDD.t718 VSS 0.03387f ; **FLOATING
C10054 VDD.t1503 VSS 0.03972f ; **FLOATING
C10055 VDD.n1721 VSS 0.11127f ; **FLOATING
C10056 VDD.t740 VSS 0.03387f ; **FLOATING
C10057 VDD.t594 VSS 0.03972f ; **FLOATING
C10058 VDD.n1722 VSS 0.11127f ; **FLOATING
C10059 VDD.t739 VSS 0.03387f ; **FLOATING
C10060 VDD.t559 VSS 0.03972f ; **FLOATING
C10061 VDD.n1723 VSS 0.11127f ; **FLOATING
C10062 VDD.t617 VSS 0.03387f ; **FLOATING
C10063 VDD.t501 VSS 0.03972f ; **FLOATING
C10064 VDD.n1724 VSS 0.11127f ; **FLOATING
C10065 VDD.t715 VSS 0.03387f ; **FLOATING
C10066 VDD.t945 VSS 0.03972f ; **FLOATING
C10067 VDD.n1725 VSS 0.11127f ; **FLOATING
C10068 VDD.t726 VSS 0.03387f ; **FLOATING
C10069 VDD.t778 VSS 0.03972f ; **FLOATING
C10070 VDD.n1726 VSS 0.11127f ; **FLOATING
C10071 VDD.t727 VSS 0.03387f ; **FLOATING
C10072 VDD.t940 VSS 0.03972f ; **FLOATING
C10073 VDD.n1727 VSS 0.11127f ; **FLOATING
C10074 VDD.t608 VSS 0.03387f ; **FLOATING
C10075 VDD.t919 VSS 0.03972f ; **FLOATING
C10076 VDD.n1728 VSS 0.0942f ; **FLOATING
C10077 VDD.n1729 VSS 0.11127f ; **FLOATING
C10078 VDD.t735 VSS 0.03387f ; **FLOATING
C10079 VDD.t544 VSS 0.03972f ; **FLOATING
C10080 VDD.n1730 VSS 0.11127f ; **FLOATING
C10081 VDD.t736 VSS 0.03387f ; **FLOATING
C10082 VDD.t1014 VSS 0.03972f ; **FLOATING
C10083 VDD.n1731 VSS 0.11127f ; **FLOATING
C10084 VDD.t737 VSS 0.03387f ; **FLOATING
C10085 VDD.t873 VSS 0.03972f ; **FLOATING
C10086 VDD.n1732 VSS 0.09417f ; **FLOATING
C10087 VDD.n1733 VSS 0.11127f ; **FLOATING
C10088 VDD.t724 VSS 0.03387f ; **FLOATING
C10089 VDD.t907 VSS 0.03972f ; **FLOATING
C10090 VDD.n1734 VSS 0.11127f ; **FLOATING
C10091 VDD.t738 VSS 0.03387f ; **FLOATING
C10092 VDD.t358 VSS 0.03972f ; **FLOATING
C10093 VDD.n1735 VSS 0.07191f ; **FLOATING
C10094 VDD.t722 VSS 0.03387f ; **FLOATING
C10095 VDD.n1736 VSS 0.02512f ; **FLOATING
C10096 VDD.n1737 VSS 0.04711f ; **FLOATING
C10097 VDD.t561 VSS 0.03972f ; **FLOATING
C10098 VDD.n1738 VSS 0.10178f ; **FLOATING
C10099 VDD.t725 VSS 0.03387f ; **FLOATING
C10100 VDD.t504 VSS 0.03972f ; **FLOATING
C10101 VDD.n1739 VSS 0.11127f ; **FLOATING
C10102 VDD.t732 VSS 0.03387f ; **FLOATING
C10103 VDD.n1740 VSS 0.02512f ; **FLOATING
C10104 VDD.t409 VSS 0.03972f ; **FLOATING
C10105 VDD.n1741 VSS 0.11127f ; **FLOATING
C10106 VDD.t733 VSS 0.03387f ; **FLOATING
C10107 VDD.t364 VSS 0.03972f ; **FLOATING
C10108 VDD.n1742 VSS 0.11127f ; **FLOATING
C10109 VDD.t734 VSS 0.03387f ; **FLOATING
C10110 VDD.n1743 VSS 0.02512f ; **FLOATING
C10111 VDD.t532 VSS 0.03972f ; **FLOATING
C10112 VDD.n1744 VSS 0.11127f ; **FLOATING
C10113 VDD.t623 VSS 0.03387f ; **FLOATING
C10114 VDD.n1745 VSS 0.02512f ; **FLOATING
C10115 VDD.t1018 VSS 0.03972f ; **FLOATING
C10116 VDD.n1746 VSS 0.11127f ; **FLOATING
C10117 VDD.t730 VSS 0.03387f ; **FLOATING
C10118 VDD.n1747 VSS 0.02512f ; **FLOATING
C10119 VDD.n1748 VSS 0.06296f ; **FLOATING
C10120 VDD.t1496 VSS 0.03972f ; **FLOATING
C10121 VDD.n1749 VSS 0.09344f ; **FLOATING
C10122 VDD.n1750 VSS 0.11127f ; **FLOATING
C10123 VDD.t731 VSS 0.03387f ; **FLOATING
C10124 VDD.t349 VSS 0.03972f ; **FLOATING
C10125 VDD.n1751 VSS 0.11127f ; **FLOATING
C10126 VDD.t717 VSS 0.03387f ; **FLOATING
C10127 VDD.t802 VSS 0.03972f ; **FLOATING
C10128 VDD.n1752 VSS 0.08272f ; **FLOATING
C10129 VDD.n1753 VSS 0.11127f ; **FLOATING
C10130 VDD.t723 VSS 0.03387f ; **FLOATING
C10131 VDD.n1754 VSS 0.02512f ; **FLOATING
C10132 VDD.n1755 VSS 0.06293f ; **FLOATING
C10133 VDD.t785 VSS 0.03972f ; **FLOATING
C10134 VDD.n1756 VSS 0.09417f ; **FLOATING
C10135 VDD.n1757 VSS 0.11127f ; **FLOATING
C10136 VDD.t616 VSS 0.03387f ; **FLOATING
C10137 VDD.t586 VSS 0.03972f ; **FLOATING
C10138 VDD.n1758 VSS 0.09203f ; **FLOATING
C10139 VDD.t628 VSS 0.03387f ; **FLOATING
C10140 VDD.t482 VSS 0.0345f ; **FLOATING
C10141 VDD.t478 VSS 0.03785f ; **FLOATING
C10142 VDD.t479 VSS 0.03387f ; **FLOATING
C10143 VDD.n1759 VSS 0.02299f ; **FLOATING
C10144 VDD.t477 VSS 0.02445f ; **FLOATING
C10145 VDD.n1760 VSS 0.41263f ; **FLOATING
C10146 VDD.n1761 VSS 0.09345f ; **FLOATING
C10147 VDD.n1762 VSS 0.0827f ; **FLOATING
C10148 VDD.n1763 VSS 0.06293f ; **FLOATING
C10149 VDD.n1764 VSS 0.01472f ; **FLOATING
C10150 VDD.n1765 VSS 0.0827f ; **FLOATING
C10151 VDD.n1766 VSS 0.06293f ; **FLOATING
C10152 VDD.n1767 VSS 0.01472f ; **FLOATING
C10153 VDD.n1768 VSS 0.08269f ; **FLOATING
C10154 VDD.n1769 VSS 0.07175f ; **FLOATING
C10155 VDD.n1770 VSS 0.01472f ; **FLOATING
C10156 VDD.n1771 VSS 0.0827f ; **FLOATING
C10157 VDD.n1772 VSS 0.09418f ; **FLOATING
C10158 VDD.n1773 VSS 0.09343f ; **FLOATING
C10159 VDD.n1774 VSS 0.09344f ; **FLOATING
C10160 VDD.n1775 VSS 0.09417f ; **FLOATING
C10161 VDD.n1776 VSS 0.0942f ; **FLOATING
C10162 VDD.n1777 VSS 0.08032f ; **FLOATING
C10163 VDD.n1778 VSS 0.01472f ; **FLOATING
C10164 VDD.n1779 VSS 0.09264f ; **FLOATING
C10165 VDD.n1780 VSS 0.41263f ; **FLOATING
C10166 VDD.n1781 VSS 0.56914f ; **FLOATING
C10167 VDD.t1469 VSS 0.03506f ; **FLOATING
C10168 VDD.t1546 VSS 0.03506f ; **FLOATING
C10169 VDD.n1782 VSS 0.08296f ; **FLOATING
C10170 VDD.t96 VSS 0.03148f ; **FLOATING
C10171 VDD.t1065 VSS 0.03506f ; **FLOATING
C10172 VDD.n1783 VSS 0.06395f ; **FLOATING
C10173 VDD.n1784 VSS 0.0136f ; **FLOATING
C10174 VDD.n1785 VSS 0.02895f ; **FLOATING
C10175 VDD.t359 VSS 0.04602f ; **FLOATING
C10176 VDD.n1786 VSS 0.08826f ; **FLOATING
C10177 VDD.n1787 VSS 0.02582f ; **FLOATING
C10178 VDD.t1194 VSS 0.03506f ; **FLOATING
C10179 VDD.n1788 VSS 0.09318f ; **FLOATING
C10180 VDD.n1789 VSS 0.01229f ; **FLOATING
C10181 VDD.t782 VSS 0.03908f ; **FLOATING
C10182 VDD.t1240 VSS 0.03908f ; **FLOATING
C10183 VDD.n1790 VSS 0.01297f ; **FLOATING
C10184 VDD.t982 VSS 0.03908f ; **FLOATING
C10185 VDD.t1533 VSS 0.03908f ; **FLOATING
C10186 VDD.n1791 VSS 0.08331f ; **FLOATING
C10187 VDD.n1792 VSS 0.01238f ; **FLOATING
C10188 VDD.n1793 VSS 0.01826f ; **FLOATING
C10189 VDD.t1556 VSS 0.03506f ; **FLOATING
C10190 VDD.t809 VSS 0.03506f ; **FLOATING
C10191 VDD.n1794 VSS 0.09793f ; **FLOATING
C10192 VDD.n1795 VSS 0.01605f ; **FLOATING
C10193 VDD.t1133 VSS 0.02589f ; **FLOATING
C10194 VDD.t1528 VSS 0.02589f ; **FLOATING
C10195 VDD.n1796 VSS 0.07458f ; **FLOATING
C10196 VDD.t876 VSS 0.03461f ; **FLOATING
C10197 VDD.t894 VSS 0.03461f ; **FLOATING
C10198 VDD.n1797 VSS 0.06957f ; **FLOATING
C10199 VDD.n1798 VSS 0.01714f ; **FLOATING
C10200 VDD.t1467 VSS 0.02589f ; **FLOATING
C10201 VDD.t1545 VSS 0.02589f ; **FLOATING
C10202 VDD.t781 VSS 0.03461f ; **FLOATING
C10203 VDD.t893 VSS 0.03461f ; **FLOATING
C10204 VDD.t1557 VSS 0.02589f ; **FLOATING
C10205 VDD.t810 VSS 0.02589f ; **FLOATING
C10206 VDD.n1799 VSS 0.07942f ; **FLOATING
C10207 VDD.n1800 VSS 0.01206f ; **FLOATING
C10208 VDD.t1022 VSS 0.03461f ; **FLOATING
C10209 VDD.t1156 VSS 0.03461f ; **FLOATING
C10210 VDD.n1801 VSS 0.07004f ; **FLOATING
C10211 VDD.n1802 VSS 0.01711f ; **FLOATING
C10212 VDD.t1023 VSS 0.03908f ; **FLOATING
C10213 VDD.t1157 VSS 0.03908f ; **FLOATING
C10214 VDD.n1803 VSS 0.0783f ; **FLOATING
C10215 VDD.t1468 VSS 0.02589f ; **FLOATING
C10216 VDD.t1544 VSS 0.02589f ; **FLOATING
C10217 VDD.n1804 VSS 0.06972f ; **FLOATING
C10218 VDD.n1805 VSS 0.01276f ; **FLOATING
C10219 VDD.t1073 VSS 0.03461f ; **FLOATING
C10220 VDD.t388 VSS 0.03461f ; **FLOATING
C10221 VDD.n1806 VSS 0.07424f ; **FLOATING
C10222 VDD.t1074 VSS 0.03908f ; **FLOATING
C10223 VDD.t389 VSS 0.03908f ; **FLOATING
C10224 VDD.n1807 VSS 0.01252f ; **FLOATING
C10225 VDD.t395 VSS 0.03506f ; **FLOATING
C10226 VDD.t390 VSS 0.03518f ; **FLOATING
C10227 VDD.t884 VSS 0.03506f ; **FLOATING
C10228 VDD.n1808 VSS 0.07345f ; **FLOATING
C10229 VDD.n1809 VSS 0.01379f ; **FLOATING
C10230 VDD.t363 VSS 0.03506f ; **FLOATING
C10231 VDD.n1810 VSS 0.06368f ; **FLOATING
C10232 VDD.t1292 VSS 0.03506f ; **FLOATING
C10233 VDD.n1811 VSS 0.0538f ; **FLOATING
C10234 VDD.n1812 VSS 0.01948f ; **FLOATING
C10235 VDD.t1219 VSS 0.03506f ; **FLOATING
C10236 VDD.t98 VSS 0.03147f ; **FLOATING
C10237 VDD.t99 VSS 0.03148f ; **FLOATING
C10238 VDD.t383 VSS 0.03506f ; **FLOATING
C10239 VDD.t97 VSS 0.0338f ; **FLOATING
C10240 VDD.t1670 VSS 0.11628f ; **FLOATING
C10241 VDD.t379 VSS 0.04602f ; **FLOATING
C10242 VDD.t100 VSS 0.0338f ; **FLOATING
C10243 VDD.t1669 VSS 0.11628f ; **FLOATING
C10244 VDD.n1813 VSS 0.14231f ; **FLOATING
C10245 VDD.n1814 VSS 0.08884f ; **FLOATING
C10246 VDD.t1526 VSS 0.03506f ; **FLOATING
C10247 VDD.t102 VSS 0.03147f ; **FLOATING
C10248 VDD.t103 VSS 0.03148f ; **FLOATING
C10249 VDD.t106 VSS 0.03147f ; **FLOATING
C10250 VDD.t1039 VSS 0.03506f ; **FLOATING
C10251 VDD.t895 VSS 0.03506f ; **FLOATING
C10252 VDD.t1091 VSS 0.03506f ; **FLOATING
C10253 VDD.t1443 VSS 0.03506f ; **FLOATING
C10254 VDD.t161 VSS 0.03148f ; **FLOATING
C10255 VDD.t1148 VSS 0.04602f ; **FLOATING
C10256 VDD.t1291 VSS 0.03506f ; **FLOATING
C10257 VDD.t164 VSS 0.03147f ; **FLOATING
C10258 VDD.t1472 VSS 0.03506f ; **FLOATING
C10259 VDD.t165 VSS 0.03148f ; **FLOATING
C10260 VDD.t1195 VSS 0.03506f ; **FLOATING
C10261 VDD.t168 VSS 0.03147f ; **FLOATING
C10262 VDD.t169 VSS 0.03148f ; **FLOATING
C10263 VDD.t393 VSS 0.04618f ; **FLOATING
C10264 VDD.n1815 VSS 0.01948f ; **FLOATING
C10265 VDD.t1256 VSS 0.03506f ; **FLOATING
C10266 VDD.n1816 VSS 0.06368f ; **FLOATING
C10267 VDD.n1817 VSS 0.01379f ; **FLOATING
C10268 VDD.t172 VSS 0.03147f ; **FLOATING
C10269 VDD.n1818 VSS 0.05439f ; **FLOATING
C10270 VDD.t1040 VSS 0.03506f ; **FLOATING
C10271 VDD.n1819 VSS 0.05325f ; **FLOATING
C10272 VDD.t1278 VSS 0.03506f ; **FLOATING
C10273 VDD.n1821 VSS 0.0538f ; **FLOATING
C10274 VDD.n1822 VSS 0.0136f ; **FLOATING
C10275 VDD.t1285 VSS 0.03506f ; **FLOATING
C10276 VDD.n1823 VSS 0.06423f ; **FLOATING
C10277 VDD.t214 VSS 0.03148f ; **FLOATING
C10278 VDD.t415 VSS 0.04602f ; **FLOATING
C10279 VDD.t217 VSS 0.03147f ; **FLOATING
C10280 VDD.t1221 VSS 0.03506f ; **FLOATING
C10281 VDD.t218 VSS 0.03148f ; **FLOATING
C10282 VDD.t585 VSS 0.03506f ; **FLOATING
C10283 VDD.t885 VSS 0.03506f ; **FLOATING
C10284 VDD.t221 VSS 0.03147f ; **FLOATING
C10285 VDD.t222 VSS 0.03148f ; **FLOATING
C10286 VDD.t225 VSS 0.03147f ; **FLOATING
C10287 VDD.t1066 VSS 0.03506f ; **FLOATING
C10288 VDD.t366 VSS 0.03506f ; **FLOATING
C10289 VDD.t1293 VSS 0.03506f ; **FLOATING
C10290 VDD.t1287 VSS 0.03506f ; **FLOATING
C10291 VDD.t837 VSS 0.04602f ; **FLOATING
C10292 VDD.t1236 VSS 0.03506f ; **FLOATING
C10293 VDD.t843 VSS 0.03506f ; **FLOATING
C10294 VDD.t1024 VSS 0.03506f ; **FLOATING
C10295 VDD.t883 VSS 0.03506f ; **FLOATING
C10296 VDD.t557 VSS 0.03723f ; **FLOATING
C10297 VDD.t898 VSS 0.04602f ; **FLOATING
C10298 VDD.t558 VSS 0.06573f ; **FLOATING
C10299 VDD.t1038 VSS 0.03506f ; **FLOATING
C10300 VDD.t396 VSS 0.03506f ; **FLOATING
C10301 VDD.t1282 VSS 0.03506f ; **FLOATING
C10302 VDD.t1442 VSS 0.03506f ; **FLOATING
C10303 VDD.t265 VSS 0.03148f ; **FLOATING
C10304 VDD.t799 VSS 0.04602f ; **FLOATING
C10305 VDD.t1206 VSS 0.03506f ; **FLOATING
C10306 VDD.t268 VSS 0.03147f ; **FLOATING
C10307 VDD.t543 VSS 0.03506f ; **FLOATING
C10308 VDD.t269 VSS 0.03148f ; **FLOATING
C10309 VDD.t1196 VSS 0.03506f ; **FLOATING
C10310 VDD.t272 VSS 0.03147f ; **FLOATING
C10311 VDD.t273 VSS 0.03148f ; **FLOATING
C10312 VDD.t835 VSS 0.04618f ; **FLOATING
C10313 VDD.n1824 VSS 0.01948f ; **FLOATING
C10314 VDD.t563 VSS 0.03506f ; **FLOATING
C10315 VDD.n1825 VSS 0.06368f ; **FLOATING
C10316 VDD.n1826 VSS 0.01379f ; **FLOATING
C10317 VDD.t276 VSS 0.03147f ; **FLOATING
C10318 VDD.t1041 VSS 0.03506f ; **FLOATING
C10319 VDD.n1827 VSS 0.05325f ; **FLOATING
C10320 VDD.t1092 VSS 0.03506f ; **FLOATING
C10321 VDD.n1829 VSS 0.0538f ; **FLOATING
C10322 VDD.n1830 VSS 0.0136f ; **FLOATING
C10323 VDD.t1286 VSS 0.03506f ; **FLOATING
C10324 VDD.n1831 VSS 0.06395f ; **FLOATING
C10325 VDD.t277 VSS 0.03148f ; **FLOATING
C10326 VDD.t345 VSS 0.04602f ; **FLOATING
C10327 VDD.t280 VSS 0.03147f ; **FLOATING
C10328 VDD.t1222 VSS 0.03506f ; **FLOATING
C10329 VDD.t281 VSS 0.03148f ; **FLOATING
C10330 VDD.t1093 VSS 0.03506f ; **FLOATING
C10331 VDD.t886 VSS 0.03506f ; **FLOATING
C10332 VDD.t284 VSS 0.03147f ; **FLOATING
C10333 VDD.t285 VSS 0.03148f ; **FLOATING
C10334 VDD.t69 VSS 0.03147f ; **FLOATING
C10335 VDD.t1067 VSS 0.03506f ; **FLOATING
C10336 VDD.t966 VSS 0.03506f ; **FLOATING
C10337 VDD.t596 VSS 0.03506f ; **FLOATING
C10338 VDD.t1288 VSS 0.03506f ; **FLOATING
C10339 VDD.t237 VSS 0.03148f ; **FLOATING
C10340 VDD.t529 VSS 0.04602f ; **FLOATING
C10341 VDD.t1237 VSS 0.03506f ; **FLOATING
C10342 VDD.t128 VSS 0.03147f ; **FLOATING
C10343 VDD.t1552 VSS 0.03506f ; **FLOATING
C10344 VDD.t304 VSS 0.03148f ; **FLOATING
C10345 VDD.t1525 VSS 0.03506f ; **FLOATING
C10346 VDD.t293 VSS 0.03147f ; **FLOATING
C10347 VDD.t294 VSS 0.03148f ; **FLOATING
C10348 VDD.t413 VSS 0.04618f ; **FLOATING
C10349 VDD.n1832 VSS 0.01948f ; **FLOATING
C10350 VDD.t1537 VSS 0.03506f ; **FLOATING
C10351 VDD.n1833 VSS 0.06368f ; **FLOATING
C10352 VDD.n1834 VSS 0.01379f ; **FLOATING
C10353 VDD.t297 VSS 0.03147f ; **FLOATING
C10354 VDD.t887 VSS 0.03506f ; **FLOATING
C10355 VDD.n1835 VSS 0.05325f ; **FLOATING
C10356 VDD.t1062 VSS 0.03506f ; **FLOATING
C10357 VDD.n1837 VSS 0.0538f ; **FLOATING
C10358 VDD.n1838 VSS 0.0136f ; **FLOATING
C10359 VDD.t1042 VSS 0.03506f ; **FLOATING
C10360 VDD.n1839 VSS 0.06379f ; **FLOATING
C10361 VDD.n1840 VSS 0.02582f ; **FLOATING
C10362 VDD.t1026 VSS 0.04602f ; **FLOATING
C10363 VDD.n1841 VSS 0.09359f ; **FLOATING
C10364 VDD.t1220 VSS 0.03844f ; **FLOATING
C10365 VDD.n1842 VSS 0.12474f ; **FLOATING
C10366 VDD.t295 VSS 0.0338f ; **FLOATING
C10367 VDD.t1653 VSS 0.11628f ; **FLOATING
C10368 VDD.n1843 VSS 0.14231f ; **FLOATING
C10369 VDD.t292 VSS 0.0338f ; **FLOATING
C10370 VDD.t1654 VSS 0.11628f ; **FLOATING
C10371 VDD.n1844 VSS 0.14231f ; **FLOATING
C10372 VDD.n1845 VSS 0.08884f ; **FLOATING
C10373 VDD.t127 VSS 0.0338f ; **FLOATING
C10374 VDD.t1655 VSS 0.11628f ; **FLOATING
C10375 VDD.n1846 VSS 0.06395f ; **FLOATING
C10376 VDD.n1847 VSS 0.0136f ; **FLOATING
C10377 VDD.n1848 VSS 0.0538f ; **FLOATING
C10378 VDD.n1849 VSS 0.01948f ; **FLOATING
C10379 VDD.n1850 VSS 0.06368f ; **FLOATING
C10380 VDD.n1851 VSS 0.01379f ; **FLOATING
C10381 VDD.n1852 VSS 0.05325f ; **FLOATING
C10382 VDD.n1854 VSS 0.05439f ; **FLOATING
C10383 VDD.t411 VSS 0.04618f ; **FLOATING
C10384 VDD.t68 VSS 0.0338f ; **FLOATING
C10385 VDD.t1656 VSS 0.11628f ; **FLOATING
C10386 VDD.n1855 VSS 0.14231f ; **FLOATING
C10387 VDD.n1856 VSS 0.12416f ; **FLOATING
C10388 VDD.t282 VSS 0.0338f ; **FLOATING
C10389 VDD.t1657 VSS 0.11628f ; **FLOATING
C10390 VDD.n1857 VSS 0.14231f ; **FLOATING
C10391 VDD.t278 VSS 0.0338f ; **FLOATING
C10392 VDD.t1658 VSS 0.11628f ; **FLOATING
C10393 VDD.t274 VSS 0.0338f ; **FLOATING
C10394 VDD.t1659 VSS 0.11628f ; **FLOATING
C10395 VDD.n1858 VSS 0.14231f ; **FLOATING
C10396 VDD.t270 VSS 0.0338f ; **FLOATING
C10397 VDD.t1660 VSS 0.11628f ; **FLOATING
C10398 VDD.n1859 VSS 0.14231f ; **FLOATING
C10399 VDD.n1860 VSS 0.08884f ; **FLOATING
C10400 VDD.t266 VSS 0.0338f ; **FLOATING
C10401 VDD.t1661 VSS 0.11628f ; **FLOATING
C10402 VDD.n1861 VSS 0.06395f ; **FLOATING
C10403 VDD.n1862 VSS 0.0136f ; **FLOATING
C10404 VDD.n1863 VSS 0.0538f ; **FLOATING
C10405 VDD.n1864 VSS 0.01948f ; **FLOATING
C10406 VDD.n1865 VSS 0.06368f ; **FLOATING
C10407 VDD.n1866 VSS 0.01379f ; **FLOATING
C10408 VDD.n1867 VSS 0.0781f ; **FLOATING
C10409 VDD.n1868 VSS 0.01183f ; **FLOATING
C10410 VDD.n1869 VSS 0.07521f ; **FLOATING
C10411 VDD.n1870 VSS 0.10444f ; **FLOATING
C10412 VDD.n1871 VSS 0.02582f ; **FLOATING
C10413 VDD.n1872 VSS 0.06379f ; **FLOATING
C10414 VDD.n1873 VSS 0.0136f ; **FLOATING
C10415 VDD.n1874 VSS 0.0538f ; **FLOATING
C10416 VDD.n1875 VSS 0.01948f ; **FLOATING
C10417 VDD.n1876 VSS 0.06368f ; **FLOATING
C10418 VDD.n1877 VSS 0.01379f ; **FLOATING
C10419 VDD.n1878 VSS 0.05325f ; **FLOATING
C10420 VDD.n1880 VSS 0.05439f ; **FLOATING
C10421 VDD.t1494 VSS 0.04618f ; **FLOATING
C10422 VDD.t223 VSS 0.0338f ; **FLOATING
C10423 VDD.t1662 VSS 0.11628f ; **FLOATING
C10424 VDD.n1881 VSS 0.14231f ; **FLOATING
C10425 VDD.n1882 VSS 0.12416f ; **FLOATING
C10426 VDD.t219 VSS 0.0338f ; **FLOATING
C10427 VDD.t1663 VSS 0.11628f ; **FLOATING
C10428 VDD.n1883 VSS 0.14231f ; **FLOATING
C10429 VDD.t215 VSS 0.0338f ; **FLOATING
C10430 VDD.t1664 VSS 0.11628f ; **FLOATING
C10431 VDD.t170 VSS 0.0338f ; **FLOATING
C10432 VDD.t1665 VSS 0.11628f ; **FLOATING
C10433 VDD.n1884 VSS 0.14231f ; **FLOATING
C10434 VDD.t166 VSS 0.0338f ; **FLOATING
C10435 VDD.t1666 VSS 0.11628f ; **FLOATING
C10436 VDD.n1885 VSS 0.14231f ; **FLOATING
C10437 VDD.n1886 VSS 0.08884f ; **FLOATING
C10438 VDD.t162 VSS 0.0338f ; **FLOATING
C10439 VDD.t1667 VSS 0.11628f ; **FLOATING
C10440 VDD.n1887 VSS 0.06395f ; **FLOATING
C10441 VDD.n1888 VSS 0.0136f ; **FLOATING
C10442 VDD.n1889 VSS 0.0538f ; **FLOATING
C10443 VDD.n1890 VSS 0.01948f ; **FLOATING
C10444 VDD.n1891 VSS 0.06368f ; **FLOATING
C10445 VDD.n1892 VSS 0.01379f ; **FLOATING
C10446 VDD.n1893 VSS 0.05325f ; **FLOATING
C10447 VDD.n1895 VSS 0.05439f ; **FLOATING
C10448 VDD.t606 VSS 0.04618f ; **FLOATING
C10449 VDD.t104 VSS 0.0338f ; **FLOATING
C10450 VDD.t1668 VSS 0.11628f ; **FLOATING
C10451 VDD.n1896 VSS 0.14231f ; **FLOATING
C10452 VDD.n1897 VSS 0.12416f ; **FLOATING
C10453 VDD.n1898 VSS 0.07777f ; **FLOATING
C10454 VDD.n1899 VSS 0.77067f ; **FLOATING
C10455 VDD.n1900 VSS 0.72422f ; **FLOATING
C10456 VDD.t471 VSS 0.03387f ; **FLOATING
C10457 VDD.t468 VSS 0.03387f ; **FLOATING
C10458 VDD.t466 VSS 0.02445f ; **FLOATING
C10459 VDD.n1901 VSS 0.01683f ; **FLOATING
C10460 VDD.t691 VSS 0.03387f ; **FLOATING
C10461 VDD.n1902 VSS 0.02512f ; **FLOATING
C10462 VDD.t699 VSS 0.03387f ; **FLOATING
C10463 VDD.t698 VSS 0.03387f ; **FLOATING
C10464 VDD.t697 VSS 0.03387f ; **FLOATING
C10465 VDD.t614 VSS 0.03387f ; **FLOATING
C10466 VDD.t700 VSS 0.03387f ; **FLOATING
C10467 VDD.t701 VSS 0.03387f ; **FLOATING
C10468 VDD.t692 VSS 0.03387f ; **FLOATING
C10469 VDD.t687 VSS 0.03387f ; **FLOATING
C10470 VDD.n1903 VSS 0.02512f ; **FLOATING
C10471 VDD.t688 VSS 0.03387f ; **FLOATING
C10472 VDD.t702 VSS 0.03387f ; **FLOATING
C10473 VDD.t696 VSS 0.03387f ; **FLOATING
C10474 VDD.t689 VSS 0.03387f ; **FLOATING
C10475 VDD.t694 VSS 0.03387f ; **FLOATING
C10476 VDD.t704 VSS 0.03387f ; **FLOATING
C10477 VDD.n1904 VSS 0.02512f ; **FLOATING
C10478 VDD.t695 VSS 0.03387f ; **FLOATING
C10479 VDD.t707 VSS 0.03387f ; **FLOATING
C10480 VDD.n1905 VSS 0.02512f ; **FLOATING
C10481 VDD.t706 VSS 0.03387f ; **FLOATING
C10482 VDD.t705 VSS 0.03387f ; **FLOATING
C10483 VDD.n1906 VSS 0.02512f ; **FLOATING
C10484 VDD.t703 VSS 0.03387f ; **FLOATING
C10485 VDD.t693 VSS 0.03387f ; **FLOATING
C10486 VDD.n1907 VSS 0.02512f ; **FLOATING
C10487 VDD.t613 VSS 0.03387f ; **FLOATING
C10488 VDD.t708 VSS 0.03387f ; **FLOATING
C10489 VDD.t690 VSS 0.03387f ; **FLOATING
C10490 VDD.t709 VSS 0.03387f ; **FLOATING
C10491 VDD.t710 VSS 0.03387f ; **FLOATING
C10492 VDD.n1908 VSS 0.02512f ; **FLOATING
C10493 VDD.t711 VSS 0.03387f ; **FLOATING
C10494 VDD.t686 VSS 0.03387f ; **FLOATING
C10495 VDD.t714 VSS 0.03387f ; **FLOATING
C10496 VDD.t712 VSS 0.03387f ; **FLOATING
C10497 VDD.t615 VSS 0.03387f ; **FLOATING
C10498 VDD.t713 VSS 0.03387f ; **FLOATING
C10499 VDD.n1909 VSS 0.02512f ; **FLOATING
C10500 VDD.t474 VSS 0.03387f ; **FLOATING
C10501 VDD.n1910 VSS 0.02512f ; **FLOATING
C10502 VDD.t472 VSS 0.07104f ; **FLOATING
C10503 VDD.t473 VSS 0.03785f ; **FLOATING
C10504 VDD.n1911 VSS 0.02746f ; **FLOATING
C10505 VDD.t475 VSS 0.03273f ; **FLOATING
C10506 VDD.n1912 VSS 0.01669f ; **FLOATING
C10507 VDD.t476 VSS 0.03387f ; **FLOATING
C10508 VDD.n1913 VSS 0.02249f ; **FLOATING
C10509 VDD.n1914 VSS 0.07437f ; **FLOATING
C10510 VDD.t419 VSS 0.03972f ; **FLOATING
C10511 VDD.n1915 VSS 0.06304f ; **FLOATING
C10512 VDD.n1916 VSS 0.07179f ; **FLOATING
C10513 VDD.t1025 VSS 0.03972f ; **FLOATING
C10514 VDD.t845 VSS 0.03972f ; **FLOATING
C10515 VDD.t414 VSS 0.03972f ; **FLOATING
C10516 VDD.t394 VSS 0.03972f ; **FLOATING
C10517 VDD.t803 VSS 0.03972f ; **FLOATING
C10518 VDD.t842 VSS 0.03972f ; **FLOATING
C10519 VDD.n1917 VSS 0.08035f ; **FLOATING
C10520 VDD.t412 VSS 0.03972f ; **FLOATING
C10521 VDD.t960 VSS 0.03972f ; **FLOATING
C10522 VDD.n1918 VSS 0.08447f ; **FLOATING
C10523 VDD.t347 VSS 0.03972f ; **FLOATING
C10524 VDD.t564 VSS 0.03972f ; **FLOATING
C10525 VDD.t1130 VSS 0.03972f ; **FLOATING
C10526 VDD.n1919 VSS 0.07176f ; **FLOATING
C10527 VDD.t542 VSS 0.03972f ; **FLOATING
C10528 VDD.t800 VSS 0.03972f ; **FLOATING
C10529 VDD.n1920 VSS 0.06295f ; **FLOATING
C10530 VDD.t397 VSS 0.03972f ; **FLOATING
C10531 VDD.t1142 VSS 0.03972f ; **FLOATING
C10532 VDD.n1921 VSS 0.07176f ; **FLOATING
C10533 VDD.t844 VSS 0.03972f ; **FLOATING
C10534 VDD.t838 VSS 0.03972f ; **FLOATING
C10535 VDD.n1922 VSS 0.07175f ; **FLOATING
C10536 VDD.t367 VSS 0.03972f ; **FLOATING
C10537 VDD.t1548 VSS 0.03972f ; **FLOATING
C10538 VDD.t584 VSS 0.03972f ; **FLOATING
C10539 VDD.t774 VSS 0.03972f ; **FLOATING
C10540 VDD.t597 VSS 0.03972f ; **FLOATING
C10541 VDD.t525 VSS 0.03972f ; **FLOATING
C10542 VDD.n1923 VSS 0.07175f ; **FLOATING
C10543 VDD.t402 VSS 0.03972f ; **FLOATING
C10544 VDD.t948 VSS 0.03972f ; **FLOATING
C10545 VDD.t896 VSS 0.03972f ; **FLOATING
C10546 VDD.t784 VSS 0.03972f ; **FLOATING
C10547 VDD.t382 VSS 0.03972f ; **FLOATING
C10548 VDD.t380 VSS 0.03972f ; **FLOATING
C10549 VDD.t351 VSS 0.03972f ; **FLOATING
C10550 VDD.t547 VSS 0.03972f ; **FLOATING
C10551 VDD.n1924 VSS 0.05805f ; **FLOATING
C10552 VDD.n1925 VSS 0.08269f ; **FLOATING
C10553 VDD.n1926 VSS 0.08271f ; **FLOATING
C10554 VDD.n1927 VSS 0.08271f ; **FLOATING
C10555 VDD.n1928 VSS 0.09343f ; **FLOATING
C10556 VDD.n1929 VSS 0.0827f ; **FLOATING
C10557 VDD.n1930 VSS 0.08271f ; **FLOATING
C10558 VDD.n1931 VSS 0.09418f ; **FLOATING
C10559 VDD.n1932 VSS 0.09344f ; **FLOATING
C10560 VDD.n1933 VSS 0.03824f ; **FLOATING
C10561 VDD.n1934 VSS 0.01624f ; **FLOATING
C10562 VDD.n1935 VSS 0.03456f ; **FLOATING
C10563 VDD.n1937 VSS 0.06312f ; **FLOATING
C10564 VDD.n1939 VSS 0.04837f ; **FLOATING
C10565 VDD.n1940 VSS 0.02689f ; **FLOATING
C10566 VDD.n1941 VSS 0.09209f ; **FLOATING
C10567 VDD.n1942 VSS 0.05149f ; **FLOATING
C10568 VDD.n1943 VSS 0.11127f ; **FLOATING
C10569 VDD.n1944 VSS 0.05149f ; **FLOATING
C10570 VDD.n1945 VSS 0.11127f ; **FLOATING
C10571 VDD.n1946 VSS 0.05149f ; **FLOATING
C10572 VDD.n1947 VSS 0.11127f ; **FLOATING
C10573 VDD.n1948 VSS 0.05149f ; **FLOATING
C10574 VDD.n1949 VSS 0.11127f ; **FLOATING
C10575 VDD.n1950 VSS 0.05149f ; **FLOATING
C10576 VDD.n1951 VSS 0.11127f ; **FLOATING
C10577 VDD.n1952 VSS 0.05149f ; **FLOATING
C10578 VDD.n1953 VSS 0.11127f ; **FLOATING
C10579 VDD.n1954 VSS 0.04904f ; **FLOATING
C10580 VDD.n1955 VSS 0.11127f ; **FLOATING
C10581 VDD.n1956 VSS 0.05149f ; **FLOATING
C10582 VDD.n1957 VSS 0.11127f ; **FLOATING
C10583 VDD.n1958 VSS 0.05149f ; **FLOATING
C10584 VDD.n1959 VSS 0.11127f ; **FLOATING
C10585 VDD.n1960 VSS 0.05149f ; **FLOATING
C10586 VDD.n1961 VSS 0.11127f ; **FLOATING
C10587 VDD.n1962 VSS 0.05149f ; **FLOATING
C10588 VDD.n1963 VSS 0.11127f ; **FLOATING
C10589 VDD.n1964 VSS 0.05149f ; **FLOATING
C10590 VDD.n1965 VSS 0.11127f ; **FLOATING
C10591 VDD.n1966 VSS 0.05149f ; **FLOATING
C10592 VDD.n1967 VSS 0.11127f ; **FLOATING
C10593 VDD.n1968 VSS 0.05149f ; **FLOATING
C10594 VDD.n1969 VSS 0.11127f ; **FLOATING
C10595 VDD.n1970 VSS 0.05149f ; **FLOATING
C10596 VDD.n1971 VSS 0.11127f ; **FLOATING
C10597 VDD.n1972 VSS 0.05149f ; **FLOATING
C10598 VDD.n1973 VSS 0.11127f ; **FLOATING
C10599 VDD.n1974 VSS 0.05149f ; **FLOATING
C10600 VDD.n1975 VSS 0.11127f ; **FLOATING
C10601 VDD.n1976 VSS 0.05149f ; **FLOATING
C10602 VDD.n1977 VSS 0.11127f ; **FLOATING
C10603 VDD.n1978 VSS 0.05149f ; **FLOATING
C10604 VDD.n1979 VSS 0.07191f ; **FLOATING
C10605 VDD.n1981 VSS 0.08376f ; **FLOATING
C10606 VDD.n1982 VSS 0.04261f ; **FLOATING
C10607 VDD.n1983 VSS 0.10178f ; **FLOATING
C10608 VDD.n1984 VSS 0.05149f ; **FLOATING
C10609 VDD.n1985 VSS 0.11127f ; **FLOATING
C10610 VDD.n1986 VSS 0.05149f ; **FLOATING
C10611 VDD.n1987 VSS 0.11127f ; **FLOATING
C10612 VDD.n1988 VSS 0.05149f ; **FLOATING
C10613 VDD.n1989 VSS 0.11127f ; **FLOATING
C10614 VDD.n1990 VSS 0.05149f ; **FLOATING
C10615 VDD.n1991 VSS 0.11127f ; **FLOATING
C10616 VDD.n1992 VSS 0.05149f ; **FLOATING
C10617 VDD.n1993 VSS 0.11127f ; **FLOATING
C10618 VDD.n1994 VSS 0.05149f ; **FLOATING
C10619 VDD.n1995 VSS 0.11127f ; **FLOATING
C10620 VDD.n1996 VSS 0.05149f ; **FLOATING
C10621 VDD.n1997 VSS 0.11127f ; **FLOATING
C10622 VDD.n1998 VSS 0.05149f ; **FLOATING
C10623 VDD.n1999 VSS 0.11127f ; **FLOATING
C10624 VDD.n2000 VSS 0.05149f ; **FLOATING
C10625 VDD.n2001 VSS 0.11127f ; **FLOATING
C10626 VDD.n2002 VSS 0.05149f ; **FLOATING
C10627 VDD.t469 VSS 0.01993f ; **FLOATING
C10628 VDD.t467 VSS 0.03785f ; **FLOATING
C10629 VDD.n2003 VSS 0.41263f ; **FLOATING
C10630 VDD.n2004 VSS 0.41263f ; **FLOATING
C10631 VDD.n2005 VSS 1.09108f ; **FLOATING
C10632 VDD.n2006 VSS 0.41779f ; **FLOATING
C10633 VDD.n2007 VSS 0.63633f ; **FLOATING
C10634 VDD.n2008 VSS 1.29722f ; **FLOATING
C10635 VDD.n2009 VSS 0.77527f ; **FLOATING
C10636 VDD.n2010 VSS 0.63634f ; **FLOATING
C10637 VDD.n2011 VSS 0.40378f ; **FLOATING
C10638 VDD.n2012 VSS 0.01572f ; **FLOATING
C10639 VDD.t943 VSS 0.02313f ; **FLOATING
C10640 VDD.n2013 VSS 0.0653f ; **FLOATING
C10641 VDD.n2014 VSS 0.01635f ; **FLOATING
C10642 VDD.n2015 VSS 0.01669f ; **FLOATING
C10643 VDD.n2016 VSS 0.07225f ; **FLOATING
C10644 VDD.t450 VSS 0.06759f ; **FLOATING
C10645 VDD.n2017 VSS 0.0236f ; **FLOATING
C10646 VDD.n2018 VSS 0.05287f ; **FLOATING
C10647 VDD.t445 VSS 0.06048f ; **FLOATING
C10648 VDD.n2019 VSS 0.02358f ; **FLOATING
C10649 VDD.t451 VSS 0.06048f ; **FLOATING
C10650 VDD.n2020 VSS 0.06772f ; **FLOATING
C10651 VDD.n2021 VSS 0.02358f ; **FLOATING
C10652 VDD.n2022 VSS 0.04776f ; **FLOATING
C10653 VDD.t443 VSS 0.38242f ; **FLOATING
C10654 VDD.n2023 VSS 0.01543f ; **FLOATING
C10655 VDD.n2024 VSS 0.04773f ; **FLOATING
C10656 VDD.t444 VSS 0.06759f ; **FLOATING
C10657 VDD.n2025 VSS 0.0236f ; **FLOATING
C10658 VDD.n2026 VSS 0.07222f ; **FLOATING
C10659 VDD.n2027 VSS 0.03813f ; **FLOATING
C10660 VDD.n2028 VSS 0.09193f ; **FLOATING
C10661 VDD.t984 VSS 0.06759f ; **FLOATING
C10662 VDD.n2029 VSS 0.04385f ; **FLOATING
C10663 VDD.t987 VSS 0.06759f ; **FLOATING
C10664 VDD.n2030 VSS 0.04386f ; **FLOATING
C10665 VDD.n2031 VSS 0.09193f ; **FLOATING
C10666 VDD.n2032 VSS 0.03321f ; **FLOATING
C10667 VDD.n2033 VSS 0.09215f ; **FLOATING
C10668 VDD.t985 VSS 0.06759f ; **FLOATING
C10669 VDD.n2034 VSS 0.04385f ; **FLOATING
C10670 VDD.t990 VSS 0.06759f ; **FLOATING
C10671 VDD.n2035 VSS 0.04386f ; **FLOATING
C10672 VDD.n2036 VSS 0.09215f ; **FLOATING
C10673 VDD.n2037 VSS 0.03799f ; **FLOATING
C10674 VDD.n2038 VSS 0.08705f ; **FLOATING
C10675 VDD.t997 VSS 0.06759f ; **FLOATING
C10676 VDD.n2039 VSS 0.04385f ; **FLOATING
C10677 VDD.t992 VSS 0.06759f ; **FLOATING
C10678 VDD.n2040 VSS 0.04386f ; **FLOATING
C10679 VDD.n2041 VSS 0.08706f ; **FLOATING
C10680 VDD.n2042 VSS 0.03815f ; **FLOATING
C10681 VDD.n2043 VSS 0.01669f ; **FLOATING
C10682 VDD.t448 VSS 0.06048f ; **FLOATING
C10683 VDD.t453 VSS 0.06048f ; **FLOATING
C10684 VDD.n2044 VSS 0.07835f ; **FLOATING
C10685 VDD.n2045 VSS 0.02358f ; **FLOATING
C10686 VDD.t447 VSS 0.06759f ; **FLOATING
C10687 VDD.n2046 VSS 0.07225f ; **FLOATING
C10688 VDD.n2047 VSS 0.0236f ; **FLOATING
C10689 VDD.n2048 VSS 0.07224f ; **FLOATING
C10690 VDD.t454 VSS 0.06759f ; **FLOATING
C10691 VDD.n2049 VSS 0.0236f ; **FLOATING
C10692 VDD.n2050 VSS 0.04773f ; **FLOATING
C10693 VDD.t446 VSS 0.38242f ; **FLOATING
C10694 VDD.n2051 VSS 0.01543f ; **FLOATING
C10695 VDD.n2052 VSS 0.05116f ; **FLOATING
C10696 VDD.n2053 VSS 0.02358f ; **FLOATING
C10697 VDD.n2054 VSS 0.08603f ; **FLOATING
C10698 VDD.n2055 VSS 0.05036f ; **FLOATING
C10699 VDD.t355 VSS 13.313f ; **FLOATING
.ends
