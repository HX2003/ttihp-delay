* NGSPICE file created from hx_delay_bank.ext - technology: ihp-sg13g2

.subckt hx_delay_bank VDD CHAN0_DELAY_OUT_LAST CHAN1_DELAY_OUT_LAST CHAN3_DELAY_OUT_LAST
+ CHAN2_DELAY_OUT_LAST REF_DELAY_OUT_LAST DLL_RESETN REF_CLK VSS CHAN0_DELAY_IN CHAN0_MUX_SEL0
+ CHAN0_MUX_SEL1 CHAN0_MUX_OUT CHAN0_MUX_SEL4 CHAN0_MUX_SEL2 CHAN0_MUX_SEL3 CHAN1_DELAY_IN
+ CHAN1_MUX_SEL0 CHAN1_MUX_SEL1 CHAN1_MUX_OUT CHAN1_MUX_SEL4 CHAN1_MUX_SEL2 CHAN1_MUX_SEL3
+ CHAN3_DELAY_IN CHAN2_DELAY_IN CHAN3_MUX_SEL0 CHAN2_MUX_SEL0 CHAN3_MUX_SEL1 CHAN2_MUX_SEL1
+ CHAN3_MUX_OUT CHAN2_MUX_OUT CHAN3_MUX_SEL4 CHAN2_MUX_SEL4 CHAN3_MUX_SEL2 CHAN2_MUX_SEL2
+ CHAN3_MUX_SEL3 CHAN2_MUX_SEL3 REF_MUX_SEL0 REF_MUX_SEL1 REF_MUX_OUT REF_MUX_SEL4
+ REF_MUX_SEL2 REF_MUX_SEL3
X0 VDD.t1457 a_4003_1842# a_4437_1842# VDD.t379 sg13_lv_pmos ad=0.2128p pd=1.5u as=0.3808p ps=2.92u w=1.12u l=0.13u
X1 VSS.t1365 a_4187_1764.t102 a_26151_14024# VSS.t1748 sg13_lv_nmos ad=0.2516p pd=2.16u as=0.1406p ps=1.12u w=0.74u l=0.6u
X2 a_22590_3889# a_22564_3853# a_22488_3889# VDD.t0 sg13_lv_pmos ad=0.3808p pd=2.92u as=0.2128p ps=1.5u w=1.12u l=0.13u
X3 a_15511_8160# a_15273_7532# a_15403_7532# VDD.t345 sg13_lv_pmos ad=0.2128p pd=1.5u as=0.3808p ps=2.92u w=1.12u l=0.2u
X4 a_5974_11413# a_6126_9506# VSS.t812 VSS.t806 sg13_lv_nmos ad=0.38p pd=2.38u as=0.68p ps=4.68u w=2u l=1u
X5 VDD.t1508 a_3171_16074.t4 a_21044_16035# VDD.t34 sg13_lv_pmos ad=0.3808p pd=2.92u as=0.3808p ps=2.92u w=1.12u l=0.13u
X6 a_14751_14652# a_14513_14024# a_14643_14024# VDD.t378 sg13_lv_pmos ad=0.2128p pd=1.5u as=0.3808p ps=2.92u w=1.12u l=0.2u
X7 VSS.t1595 VSS.t1593 VSS.t1592 VSS.t1594 sg13_lv_nmos ad=0.1406p pd=1.12u as=0 ps=0 w=0.74u l=0.2u
X8 a_18551_5315# a_18313_4687# a_18443_4687# VDD.t347 sg13_lv_pmos ad=0.2128p pd=1.5u as=0.3808p ps=2.92u w=1.12u l=0.2u
X9 a_5731_15316# a_14825_15546# a_13470_16071# VDD.t34 sg13_lv_pmos ad=0.3808p pd=2.92u as=0.3808p ps=2.92u w=1.12u l=0.13u
X10 a_19073_14024# a_18877_14024# VDD.t644 VDD.t378 sg13_lv_pmos ad=0.3808p pd=2.92u as=0.2128p ps=1.5u w=1.12u l=0.13u
X11 VDD.t95 VSS.t5 VDD.t94 VDD.t34 sg13_lv_pmos ad=0.34p pd=2.68u as=0 ps=0 w=1u l=1u
X12 VSS.t357 VDD.t1649 VSS.t357 VSS.t359 sg13_lv_nmos ad=0.1428p pd=1.52u as=0 ps=0 w=0.42u l=1u
X13 a_8808_3889# a_8237_4687# VDD.t751 VDD.t0 sg13_lv_pmos ad=0.2128p pd=1.5u as=0.3808p ps=2.92u w=1.12u l=0.13u
X14 a_25153_4687# a_24957_4687# VSS.t618 VSS.t617 sg13_lv_nmos ad=0.2516p pd=2.16u as=0.1406p ps=1.12u w=0.74u l=0.13u
X15 VDD.t364 a_15108_11799# a_15053_11680# VDD.t358 sg13_lv_pmos ad=1.10612p pd=6.66u as=93.45f ps=0.865u w=0.42u l=0.13u
X16 VSS.t143 a_12037_4687# a_12505_3889# VSS.t142 sg13_lv_nmos ad=0.1665p pd=1.19u as=0.2516p ps=2.16u w=0.74u l=0.13u
X17 a_23871_16869# a_23633_16869# a_23763_16869# VSS.t2219 sg13_lv_nmos ad=0.1406p pd=1.12u as=0.2516p ps=2.16u w=0.74u l=0.2u
X18 CHAN0_DELAY_OUT_LAST a_27997_16869# VSS.t497 VSS.t2335 sg13_lv_nmos ad=0.2516p pd=2.16u as=0.1406p ps=1.12u w=0.74u l=0.13u
X19 VSS.t1345 a_15077_1842# a_15545_1044# VSS.t1344 sg13_lv_nmos ad=0.1665p pd=1.19u as=0.2516p ps=2.16u w=0.74u l=0.13u
X20 a_15108_11015# a_12849_11557# VDD.t364 VDD.t358 sg13_lv_pmos ad=79.8f pd=0.8u as=1.03698p ps=6.245u w=0.42u l=0.13u
X21 a_3449_13577# CHAN1_MUX_SEL0 VDD.t1549 VDD.t2 sg13_lv_pmos ad=0.1596p pd=1.22u as=0.2856p ps=2.36u w=0.84u l=0.13u
X22 VDD.t215 VSS.t331 VDD.t214 VDD.t9 sg13_lv_pmos ad=0.34p pd=2.68u as=0 ps=0 w=1u l=1u
X23 VDD.t146 VSS.t324 VDD.t144 VDD.t9 sg13_lv_pmos ad=0.19p pd=1.38u as=0 ps=0 w=1u l=1u
X24 VDD.t714 a_16851_5999# REF_MUX_OUT VDD.t9 sg13_lv_pmos ad=0.7336p pd=3.55u as=0.2128p ps=1.5u w=1.12u l=0.13u
X25 VSS.t961 a_4187_1764.t136 a_24631_16869# VSS.t1747 sg13_lv_nmos ad=0.2516p pd=2.16u as=0.1406p ps=1.12u w=0.74u l=0.6u
X26 a_7390_6734# a_8231_6698# a_8155_6734# VDD.t9 sg13_lv_pmos ad=0.3808p pd=2.92u as=0.2128p ps=1.5u w=1.12u l=0.13u
X27 a_27915_1044# a_27705_1044# VDD.t397 VDD.t67 sg13_lv_pmos ad=0.2128p pd=1.5u as=0.252p ps=1.57u w=1.12u l=0.13u
X28 a_10430_6734# a_2019_6737.t7 a_10328_6734# VSS.t1062 sg13_lv_nmos ad=0.2516p pd=2.16u as=0.1406p ps=1.12u w=0.74u l=0.13u
X29 VDD.t1538 a_3747_16074.t6 a_15831_16035# VDD.t34 sg13_lv_pmos ad=0.3808p pd=2.92u as=0.3808p ps=2.92u w=1.12u l=0.13u
X30 a_25630_13226# a_3171_13229.t2 a_27048_13226# VSS.t2036 sg13_lv_nmos ad=0.2516p pd=2.16u as=0.1406p ps=1.12u w=0.74u l=0.13u
X31 VDD.t74 VSS.t248 VDD.t134 VDD.t2 sg13_lv_pmos ad=0.34p pd=2.68u as=0 ps=0 w=1u l=1u
X32 VSS.t1806 a_1721_16422# a_2019_16074.t1 VSS.t1874 sg13_lv_nmos ad=0.2812p pd=2.24u as=0.1406p ps=1.12u w=0.74u l=0.13u
X33 a_2873_16422# CHAN0_MUX_SEL1 VDD.t1494 VDD.t34 sg13_lv_pmos ad=0.1596p pd=1.22u as=0.2856p ps=2.36u w=0.84u l=0.13u
X34 a_22351_5315# a_22113_4687# a_22243_4687# VDD.t347 sg13_lv_pmos ad=0.2128p pd=1.5u as=0.3808p ps=2.92u w=1.12u l=0.2u
X35 a_1544_16071# CHAN0_MUX_SEL1 VDD.t1495 VDD.t34 sg13_lv_pmos ad=0.3808p pd=2.92u as=0.3808p ps=2.92u w=1.12u l=0.13u
X36 VDD.t412 a_13883_7532# a_14317_7532# VDD.t345 sg13_lv_pmos ad=0.2128p pd=1.5u as=0.3808p ps=2.92u w=1.12u l=0.13u
X37 VSS.t922 a_11748_11799# a_11397_11918# VSS.t1623 sg13_lv_nmos ad=79.8f pd=0.8u as=0.1428p ps=1.52u w=0.42u l=0.13u
X38 VDD.t687 a_16923_4687# a_17357_4687# VDD.t347 sg13_lv_pmos ad=0.2128p pd=1.5u as=0.3808p ps=2.92u w=1.12u l=0.13u
X39 VSS.t310 VDD.t1666 VSS.t310 VSS.t315 sg13_lv_nmos ad=79.8f pd=0.8u as=0 ps=0 w=0.42u l=1u
X40 a_13818_11982# a_12849_11557# VSS.t1185 VSS.t1184 sg13_lv_nmos ad=37.8f pd=0.6u as=0.1701p ps=1.65u w=0.42u l=0.13u
X41 a_7390_6734# a_3171_6737.t8 a_8808_6734# VSS.t1908 sg13_lv_nmos ad=0.2516p pd=2.16u as=0.1406p ps=1.12u w=0.74u l=0.13u
X42 VSS.t400 VDD.t1634 VSS.t402 VSS.t401 sg13_lv_nmos ad=79.8f pd=0.8u as=0 ps=0 w=0.42u l=1u
X43 a_8433_16869# a_8237_16869# VSS.t1100 VSS.t1827 sg13_lv_nmos ad=0.2516p pd=2.16u as=0.1406p ps=1.12u w=0.74u l=0.13u
X44 VSS.t522 a_2019_16074.t2 a_25604_16035# VSS.t521 sg13_lv_nmos ad=0.2516p pd=2.16u as=0.2516p ps=2.16u w=0.74u l=0.13u
X45 a_22873_7532# a_22677_7532# VSS.t864 VSS.t2181 sg13_lv_nmos ad=0.2516p pd=2.16u as=0.1406p ps=1.12u w=0.74u l=0.13u
X46 VSS.t2 VDD.t1641 VSS.t2 VSS.t378 sg13_lv_nmos ad=79.8f pd=0.8u as=0 ps=0 w=0.42u l=1u
X47 a_5115_13226# a_4905_13226# VSS.t1178 VSS.t1177 sg13_lv_nmos ad=0.1406p pd=1.12u as=0.1665p ps=1.19u w=0.74u l=0.13u
X48 a_6326_10280# a_6326_10280# VDD.t662 VDD.t358 sg13_lv_pmos ad=0.38p pd=2.38u as=0.38p ps=2.38u w=2u l=1u
X49 a_13566_11018# a_14009_10774# a_13306_10795# VSS.t530 sg13_lv_nmos ad=79.8f pd=0.8u as=0.1296p ps=1.52u w=0.42u l=0.13u
X50 VDD.t1415 a_27237_4687# a_27705_3889# VDD.t0 sg13_lv_pmos ad=0.252p pd=1.57u as=0.3808p ps=2.92u w=1.12u l=0.13u
X51 VSS.t317 VDD.t1665 VSS.t317 VSS.t318 sg13_lv_nmos ad=79.8f pd=0.8u as=0 ps=0 w=0.42u l=1u
X52 VSS.t638 a_3171_1047.t7 a_11924_1008# VSS.t637 sg13_lv_nmos ad=0.2516p pd=2.16u as=0.2516p ps=2.16u w=0.74u l=0.13u
X53 a_10951_2470# a_10713_1842# a_10843_1842# VDD.t379 sg13_lv_pmos ad=0.2128p pd=1.5u as=0.3808p ps=2.92u w=1.12u l=0.2u
X54 VSS.t2 a_1544_3134# a_2391_3176# VSS.t769 sg13_lv_nmos ad=0.1331p pd=1.12u as=0.1216p ps=1.02u w=0.64u l=0.13u
X55 VDD.t1198 a_12037_7532# a_12505_6734# VDD.t9 sg13_lv_pmos ad=0.252p pd=1.57u as=0.3808p ps=2.92u w=1.12u l=0.13u
X56 VDD.t172 VSS.t447 VDD.t171 VDD.t67 sg13_lv_pmos ad=0.34p pd=2.68u as=0 ps=0 w=1u l=1u
X57 a_1721_15358# a_1256_15316# VDD.t1433 VDD.t34 sg13_lv_pmos ad=0.1596p pd=1.22u as=0.2856p ps=2.36u w=0.84u l=0.13u
X58 a_6326_10280# a_6126_9506# a_5778_9057# VSS.t803 sg13_lv_nmos ad=0.38p pd=2.38u as=0.68p ps=4.68u w=2u l=1u
X59 VSS.t527 a_4187_1764.t148 a_15511_16869# VSS.t526 sg13_lv_nmos ad=0.2516p pd=2.16u as=0.1406p ps=1.12u w=0.74u l=0.6u
X60 a_25913_14024# a_25717_14024# VSS.t509 VSS.t1363 sg13_lv_nmos ad=0.2516p pd=2.16u as=0.1406p ps=1.12u w=0.74u l=0.13u
X61 VDD.t350 a_4003_7532# a_4437_7532# VDD.t345 sg13_lv_pmos ad=0.2128p pd=1.5u as=0.3808p ps=2.92u w=1.12u l=0.13u
X62 a_10191_16869# a_9953_16869# a_10083_16869# VSS.t1448 sg13_lv_nmos ad=0.1406p pd=1.12u as=0.2516p ps=2.16u w=0.74u l=0.2u
X63 VDD.t286 VSS.t218 VDD.t44 VDD.t34 sg13_lv_pmos ad=0.19p pd=1.38u as=0 ps=0 w=1u l=1u
X64 VSS.t404 VDD.t1633 VSS.t404 VSS.t403 sg13_lv_nmos ad=0.1428p pd=1.52u as=0 ps=0 w=0.42u l=1u
X65 VDD.t1069 a_4187_2434# a_10951_5315# VDD.t347 sg13_lv_pmos ad=0.3808p pd=2.92u as=0.2128p ps=1.5u w=1.12u l=0.6u
X66 VDD.t723 a_15077_14024# a_15545_13226# VDD.t2 sg13_lv_pmos ad=0.252p pd=1.57u as=0.3808p ps=2.92u w=1.12u l=0.13u
X67 VSS.t935 a_1256_1044# a_2967_1395# VSS.t934 sg13_lv_nmos ad=0.1331p pd=1.12u as=0.1216p ps=1.02u w=0.64u l=0.13u
X68 VSS.t1455 a_4187_1764.t154 a_10951_16869# VSS.t2273 sg13_lv_nmos ad=0.2516p pd=2.16u as=0.1406p ps=1.12u w=0.74u l=0.6u
X69 a_21353_14024# a_21157_14024# VSS.t578 VSS.t577 sg13_lv_nmos ad=0.2516p pd=2.16u as=0.1406p ps=1.12u w=0.74u l=0.13u
X70 a_9946_11995# a_9772_11533# VDD.t1497 VDD.t358 sg13_lv_pmos ad=79.8f pd=0.8u as=0.1428p ps=1.52u w=0.42u l=0.13u
X71 a_5731_3134# a_3747_3156.t3 a_13470_3889# VSS.t1218 sg13_lv_nmos ad=0.2516p pd=2.16u as=0.2516p ps=2.16u w=0.74u l=0.13u
X72 a_16033_16869# a_15837_16869# VDD.t916 VDD.t368 sg13_lv_pmos ad=0.3808p pd=2.92u as=0.2128p ps=1.5u w=1.12u l=0.13u
X73 VDD.t184 VSS.t420 VDD.t183 VDD.t67 sg13_lv_pmos ad=0.34p pd=2.68u as=0 ps=0 w=1u l=1u
X74 VSS.t911 a_14643_14024# a_15077_14024# VSS.t1222 sg13_lv_nmos ad=0.1406p pd=1.12u as=0.2516p ps=2.16u w=0.74u l=0.13u
X75 a_25153_1842# a_24957_1842# VSS.t1083 VSS.t2011 sg13_lv_nmos ad=0.2516p pd=2.16u as=0.1406p ps=1.12u w=0.74u l=0.13u
X76 a_10328_3889# a_9757_4687# VSS.t540 VSS.t539 sg13_lv_nmos ad=0.1406p pd=1.12u as=0.2516p ps=2.16u w=0.74u l=0.13u
X77 VDD.t357 a_20723_4687# a_21157_4687# VDD.t347 sg13_lv_pmos ad=0.2128p pd=1.5u as=0.3808p ps=2.92u w=1.12u l=0.13u
X78 VDD.t1225 a_3171_13229.t3 a_24084_13190# VDD.t2 sg13_lv_pmos ad=0.3808p pd=2.92u as=0.3808p ps=2.92u w=1.12u l=0.13u
X79 a_17791_4687# a_17553_4687# a_17683_4687# VSS.t621 sg13_lv_nmos ad=0.1406p pd=1.12u as=0.2516p ps=2.16u w=0.74u l=0.2u
X80 VSS.t998 a_15077_7532# a_15545_6734# VSS.t997 sg13_lv_nmos ad=0.1665p pd=1.19u as=0.2516p ps=2.16u w=0.74u l=0.13u
X81 a_22590_3889# a_2019_3892.t3 a_22488_3889# VSS.t1459 sg13_lv_nmos ad=0.2516p pd=2.16u as=0.1406p ps=1.12u w=0.74u l=0.13u
X82 VDD.t327 VSS.t2 VDD.t326 VDD.t0 sg13_lv_pmos ad=0.34p pd=2.68u as=0 ps=0 w=1u l=1u
X83 a_25630_1044# a_2019_1047.t2 a_25528_1044# VSS.t1878 sg13_lv_nmos ad=0.2516p pd=2.16u as=0.1406p ps=1.12u w=0.74u l=0.13u
X84 VDD.t201 VSS.t371 VDD.t199 VDD.t0 sg13_lv_pmos ad=0.19p pd=1.38u as=0 ps=0 w=1u l=1u
X85 VSS.t2297 a_9444_10280# a_9444_9602# VSS.t2296 sg13_lv_nmos ad=0.68p pd=4.68u as=0.38p ps=2.38u w=2u l=1u
X86 VDD.t1107 a_4187_2434# a_19311_2470# VDD.t379 sg13_lv_pmos ad=0.3808p pd=2.92u as=0.2128p ps=1.5u w=1.12u l=0.6u
X87 a_8808_3889# a_8237_4687# VSS.t1018 VSS.t1017 sg13_lv_nmos ad=0.1406p pd=1.12u as=0.2516p ps=2.16u w=0.74u l=0.13u
X88 VSS.t331 a_3747_6001.t2 a_26985_6209# VSS.t1485 sg13_lv_nmos ad=0.2516p pd=2.16u as=0.2516p ps=2.16u w=0.74u l=0.13u
X89 VSS.t1759 a_2019_13229.t6 a_13444_13190# VSS.t1758 sg13_lv_nmos ad=0.2516p pd=2.16u as=0.2516p ps=2.16u w=0.74u l=0.13u
X90 VDD.t311 VSS.t286 VDD.t310 VDD.t2 sg13_lv_pmos ad=0.19p pd=1.38u as=0 ps=0 w=1u l=1u
X91 VSS.t1406 a_13123_16869# a_13557_16869# VSS.t1405 sg13_lv_nmos ad=0.1406p pd=1.12u as=0.2516p ps=2.16u w=0.74u l=0.13u
X92 VDD.t1068 a_4187_2434# a_23871_5315# VDD.t347 sg13_lv_pmos ad=0.3808p pd=2.92u as=0.2128p ps=1.5u w=1.12u l=0.6u
X93 VSS.t898 a_3171_16074.t7 a_11924_16035# VSS.t2192 sg13_lv_nmos ad=0.2516p pd=2.16u as=0.2516p ps=2.16u w=0.74u l=0.13u
X94 VDD.t1220 a_3747_13229.t5 a_18871_13190# VDD.t2 sg13_lv_pmos ad=0.3808p pd=2.92u as=0.3808p ps=2.92u w=1.12u l=0.13u
X95 VSS.t529 a_14009_10774# a_14111_10917# VSS.t531 sg13_lv_nmos ad=1.45407p pd=9.445u as=0.2516p ps=2.16u w=0.74u l=0.13u
X96 a_6635_3889# a_6425_3889# VDD.t521 VDD.t0 sg13_lv_pmos ad=0.2128p pd=1.5u as=0.252p ps=1.57u w=1.12u l=0.13u
X97 VDD.t33 VSS.t310 VDD.t31 VDD.t9 sg13_lv_pmos ad=0.19p pd=1.38u as=0 ps=0 w=1u l=1u
X98 VDD.t1205 a_4763_16869# a_5197_16869# VDD.t368 sg13_lv_pmos ad=0.2128p pd=1.5u as=0.3808p ps=2.92u w=1.12u l=0.13u
X99 a_16108_289# a_2019_311# a_16510_1044# VSS.t148 sg13_lv_nmos ad=0.2516p pd=2.16u as=0.2516p ps=2.16u w=0.74u l=0.13u
X100 VSS.t303 a_2019_6001.t3 a_5705_6209# VSS.t1303 sg13_lv_nmos ad=0.2516p pd=2.16u as=0.2516p ps=2.16u w=0.74u l=0.13u
X101 VDD.t1307 a_3747_12493.t2 a_26985_12701# VDD.t2 sg13_lv_pmos ad=0.3808p pd=2.92u as=0.3808p ps=2.92u w=1.12u l=0.13u
X102 VDD.t1154 a_2595_3892.t9 a_5191_3853# VDD.t0 sg13_lv_pmos ad=0.3808p pd=2.92u as=0.3808p ps=2.92u w=1.12u l=0.13u
X103 VSS.t31 a_13121_11521# a_13045_11905# VSS.t30 sg13_lv_nmos ad=0.2516p pd=2.16u as=0.1406p ps=1.12u w=0.74u l=0.13u
X104 VDD.t964 a_4187_2434# a_9431_2470# VDD.t379 sg13_lv_pmos ad=0.3808p pd=2.92u as=0.2128p ps=1.5u w=1.12u l=0.6u
X105 a_21591_4687# a_21353_4687# a_21483_4687# VSS.t846 sg13_lv_nmos ad=0.1406p pd=1.12u as=0.2516p ps=2.16u w=0.74u l=0.2u
X106 VDD.t1181 a_2595_16074.t2 a_26471_16035# VDD.t34 sg13_lv_pmos ad=0.3808p pd=2.92u as=0.3808p ps=2.92u w=1.12u l=0.13u
X107 a_20315_3889# a_20105_3889# VDD.t773 VDD.t0 sg13_lv_pmos ad=0.2128p pd=1.5u as=0.252p ps=1.57u w=1.12u l=0.13u
X108 a_6153_4687# a_5957_4687# VSS.t1195 VSS.t1194 sg13_lv_nmos ad=0.2516p pd=2.16u as=0.1406p ps=1.12u w=0.74u l=0.13u
X109 VDD.t13 VSS.t317 VDD.t11 VDD.t9 sg13_lv_pmos ad=0.19p pd=1.38u as=0 ps=0 w=1u l=1u
X110 VSS.t303 VDD.t1670 VSS.t303 VSS.t306 sg13_lv_nmos ad=79.8f pd=0.8u as=0 ps=0 w=0.42u l=1u
X111 VSS.t456 VDD.t1620 VSS.t455 VSS.t454 sg13_lv_nmos ad=0.1428p pd=1.52u as=0 ps=0 w=0.42u l=1u
X112 a_25528_3889# a_24957_4687# VDD.t571 VDD.t0 sg13_lv_pmos ad=0.2128p pd=1.5u as=0.3808p ps=2.92u w=1.12u l=0.13u
X113 a_26911_14024# a_26673_14024# a_26803_14024# VSS.t1370 sg13_lv_nmos ad=0.1406p pd=1.12u as=0.2516p ps=2.16u w=0.74u l=0.2u
X114 a_15108_11799# a_14851_11918# a_15270_11995# VSS.t560 sg13_lv_nmos ad=0.1428p pd=1.52u as=37.8f ps=0.6u w=0.42u l=0.13u
X115 VSS.t480 a_16163_4687# a_16597_4687# VSS.t1505 sg13_lv_nmos ad=0.1406p pd=1.12u as=0.2516p ps=2.16u w=0.74u l=0.13u
X116 a_13231_5315# a_12993_4687# a_13123_4687# VDD.t347 sg13_lv_pmos ad=0.2128p pd=1.5u as=0.3808p ps=2.92u w=1.12u l=0.2u
X117 VDD.t1224 a_3171_13229.t6 a_14964_13190# VDD.t2 sg13_lv_pmos ad=0.3808p pd=2.92u as=0.3808p ps=2.92u w=1.12u l=0.13u
X118 CHAN1_MUX_OUT a_16851_12491# VSS.t820 VSS.t819 sg13_lv_nmos ad=0.1406p pd=1.12u as=0.1371p ps=1.12u w=0.74u l=0.13u
X119 a_10951_8160# a_10713_7532# a_10843_7532# VDD.t345 sg13_lv_pmos ad=0.2128p pd=1.5u as=0.3808p ps=2.92u w=1.12u l=0.2u
X120 VSS.t1109 a_3171_6737.t7 a_11924_6698# VSS.t1911 sg13_lv_nmos ad=0.2516p pd=2.16u as=0.2516p ps=2.16u w=0.74u l=0.13u
X121 a_10328_6734# a_9757_7532# VDD.t746 VDD.t9 sg13_lv_pmos ad=0.2128p pd=1.5u as=0.3808p ps=2.92u w=1.12u l=0.13u
X122 a_3449_6021# REF_MUX_SEL2 VDD.t426 VDD.t9 sg13_lv_pmos ad=0.1596p pd=1.22u as=0.2856p ps=2.36u w=0.84u l=0.13u
X123 VDD.t1108 a_4187_2434# a_23111_2470# VDD.t379 sg13_lv_pmos ad=0.3808p pd=2.92u as=0.2128p ps=1.5u w=1.12u l=0.6u
X124 VSS.t566 a_4187_1764.t100 a_27671_14024# VSS.t565 sg13_lv_nmos ad=0.2516p pd=2.16u as=0.1406p ps=1.12u w=0.74u l=0.6u
X125 a_22351_14024# a_22113_14024# a_22243_14024# VSS.t1478 sg13_lv_nmos ad=0.1406p pd=1.12u as=0.2516p ps=2.16u w=0.74u l=0.2u
X126 VSS.t1707 a_3747_15338.t3 a_14825_15546# VSS.t1706 sg13_lv_nmos ad=0.2516p pd=2.16u as=0.2516p ps=2.16u w=0.74u l=0.13u
X127 a_1721_12513# a_1256_12471# VDD.t858 VDD.t2 sg13_lv_pmos ad=0.1596p pd=1.22u as=0.2856p ps=2.36u w=0.84u l=0.13u
X128 VDD.t760 a_2019_16074.t3 a_22564_16035# VDD.t34 sg13_lv_pmos ad=0.3808p pd=2.92u as=0.3808p ps=2.92u w=1.12u l=0.13u
X129 a_22590_6734# a_22564_6698# a_22488_6734# VDD.t9 sg13_lv_pmos ad=0.3808p pd=2.92u as=0.2128p ps=1.5u w=1.12u l=0.13u
X130 a_7390_1044# a_8231_1008# a_8155_1044# VDD.t67 sg13_lv_pmos ad=0.3808p pd=2.92u as=0.2128p ps=1.5u w=1.12u l=0.13u
X131 VSS.t14 a_1256_6734# a_2967_7085# VSS.t13 sg13_lv_nmos ad=0.1331p pd=1.12u as=0.1216p ps=1.02u w=0.64u l=0.13u
X132 VSS.t388 VDD.t1637 VSS.t388 VSS.t389 sg13_lv_nmos ad=0.1428p pd=1.52u as=0 ps=0 w=0.42u l=1u
X133 a_10713_16869# a_10517_16869# VSS.t492 VSS.t1151 sg13_lv_nmos ad=0.2516p pd=2.16u as=0.1406p ps=1.12u w=0.74u l=0.13u
X134 VSS.t124 a_4187_1764.t57 a_10191_4687# VSS.t123 sg13_lv_nmos ad=0.2516p pd=2.16u as=0.1406p ps=1.12u w=0.74u l=0.6u
X135 a_12233_4687# a_12037_4687# VDD.t403 VDD.t347 sg13_lv_pmos ad=0.3808p pd=2.92u as=0.2128p ps=1.5u w=1.12u l=0.13u
X136 a_7390_16071# a_7364_16035# a_7288_16071# VDD.t34 sg13_lv_pmos ad=0.3808p pd=2.92u as=0.2128p ps=1.5u w=1.12u l=0.13u
X137 a_16108_15316# CHAN0_MUX_SEL4 a_15964_15316# VSS.t6 sg13_lv_nmos ad=0.2516p pd=2.16u as=0.2183p ps=1.33u w=0.74u l=0.13u
X138 a_16033_14024# a_15837_14024# VDD.t721 VDD.t378 sg13_lv_pmos ad=0.3808p pd=2.92u as=0.2128p ps=1.5u w=1.12u l=0.13u
X139 a_8808_6734# a_8237_7532# VDD.t1524 VDD.t9 sg13_lv_pmos ad=0.2128p pd=1.5u as=0.3808p ps=2.92u w=1.12u l=0.13u
X140 VSS.t408 a_2595_311.t3 a_8745_519# VSS.t1940 sg13_lv_nmos ad=0.2516p pd=2.16u as=0.2516p ps=2.16u w=0.74u l=0.13u
X141 VSS.t2073 a_27237_4687# a_27705_3889# VSS.t2315 sg13_lv_nmos ad=0.1665p pd=1.19u as=0.2516p ps=2.16u w=0.74u l=0.13u
X142 a_25153_7532# a_24957_7532# VSS.t519 VSS.t1439 sg13_lv_nmos ad=0.2516p pd=2.16u as=0.1406p ps=1.12u w=0.74u l=0.13u
X143 a_2297_15358# CHAN0_MUX_SEL2 VDD.t863 VDD.t34 sg13_lv_pmos ad=0.1596p pd=1.22u as=0.2856p ps=2.36u w=0.84u l=0.13u
X144 a_17791_1842# a_17553_1842# a_17683_1842# VSS.t1481 sg13_lv_nmos ad=0.1406p pd=1.12u as=0.2516p ps=2.16u w=0.74u l=0.2u
X145 VDD.t627 a_2019_12493.t2 a_17865_12701# VDD.t2 sg13_lv_pmos ad=0.3808p pd=2.92u as=0.3808p ps=2.92u w=1.12u l=0.13u
X146 a_14851_11918# a_14009_11568# a_13592_11561# VDD.t358 sg13_lv_pmos ad=0.2048p pd=1.63u as=0.34p ps=2.68u w=1u l=0.13u
X147 a_25153_16869# a_24957_16869# VSS.t961 VSS.t1255 sg13_lv_nmos ad=0.2516p pd=2.16u as=0.1406p ps=1.12u w=0.74u l=0.13u
X148 VSS.t913 a_19963_4687# a_20397_4687# VSS.t2308 sg13_lv_nmos ad=0.1406p pd=1.12u as=0.2516p ps=2.16u w=0.74u l=0.13u
X149 VDD.t668 a_6326_10280# a_6126_9506# VDD.t358 sg13_lv_pmos ad=0.38p pd=2.38u as=0.38p ps=2.38u w=2u l=1u
X150 VDD.t840 a_1721_12513# a_2019_12493.t0 VDD.t2 sg13_lv_pmos ad=0.4256p pd=3u as=0.2128p ps=1.5u w=1.12u l=0.13u
X151 a_12656_11554# DLL_RESETN VDD.t694 VDD.t358 sg13_lv_pmos ad=0.3808p pd=2.92u as=0.3808p ps=2.92u w=1.12u l=0.13u
X152 a_25630_6734# a_2019_6737.t2 a_25528_6734# VSS.t1074 sg13_lv_nmos ad=0.2516p pd=2.16u as=0.1406p ps=1.12u w=0.74u l=0.13u
X153 VDD.t624 a_2595_16074.t5 a_17351_16035# VDD.t34 sg13_lv_pmos ad=0.3808p pd=2.92u as=0.3808p ps=2.92u w=1.12u l=0.13u
X154 VDD.t1060 a_4187_2434# a_19311_8160# VDD.t345 sg13_lv_pmos ad=0.3808p pd=2.92u as=0.2128p ps=1.5u w=1.12u l=0.6u
X155 a_25630_16071# a_3171_16074.t2 a_27048_16071# VSS.t80 sg13_lv_nmos ad=0.2516p pd=2.16u as=0.1406p ps=1.12u w=0.74u l=0.13u
X156 VDD.t506 a_3747_16074.t7 a_12791_16035# VDD.t34 sg13_lv_pmos ad=0.3808p pd=2.92u as=0.3808p ps=2.92u w=1.12u l=0.13u
X157 a_2595_13229.t1 a_2297_13577# VSS.t703 VSS.t2017 sg13_lv_nmos ad=0.1406p pd=1.12u as=0.1331p ps=1.12u w=0.74u l=0.13u
X158 VDD.t650 a_12037_1842# a_12505_1044# VDD.t67 sg13_lv_pmos ad=0.252p pd=1.57u as=0.3808p ps=2.92u w=1.12u l=0.13u
X159 a_13231_14024# a_12993_14024# a_13123_14024# VSS.t1990 sg13_lv_nmos ad=0.1406p pd=1.12u as=0.2516p ps=2.16u w=0.74u l=0.2u
X160 VDD.t230 VSS.t357 VDD.t228 VDD.t0 sg13_lv_pmos ad=0.19p pd=1.38u as=0 ps=0 w=1u l=1u
X161 a_16510_1044# a_2019_1047.t5 a_16408_1044# VSS.t668 sg13_lv_nmos ad=0.2516p pd=2.16u as=0.1406p ps=1.12u w=0.74u l=0.13u
X162 VSS.t344 VDD.t1654 VSS.t344 VSS.t348 sg13_lv_nmos ad=79.8f pd=0.8u as=0 ps=0 w=0.42u l=1u
X163 VDD.t1469 a_4763_14024# a_5197_14024# VDD.t378 sg13_lv_pmos ad=0.2128p pd=1.5u as=0.3808p ps=2.92u w=1.12u l=0.13u
X164 VDD.t337 VSS.t303 VDD.t335 VDD.t9 sg13_lv_pmos ad=0.19p pd=1.38u as=0 ps=0 w=1u l=1u
X165 VSS.t1224 a_4187_1764.t118 a_13991_14024# VSS.t1900 sg13_lv_nmos ad=0.2516p pd=2.16u as=0.1406p ps=1.12u w=0.74u l=0.6u
X166 a_9953_16869# a_9757_16869# VSS.t488 VSS.t487 sg13_lv_nmos ad=0.2516p pd=2.16u as=0.1406p ps=1.12u w=0.74u l=0.13u
X167 VSS.t272 VDD.t1679 VSS.t272 VSS.t271 sg13_lv_nmos ad=0.1428p pd=1.52u as=0 ps=0 w=0.42u l=1u
X168 VDD.t994 a_4187_2434# a_9431_8160# VDD.t345 sg13_lv_pmos ad=0.3808p pd=2.92u as=0.2128p ps=1.5u w=1.12u l=0.6u
X169 a_21591_1842# a_21353_1842# a_21483_1842# VSS.t1649 sg13_lv_nmos ad=0.1406p pd=1.12u as=0.2516p ps=2.16u w=0.74u l=0.2u
X170 a_2873_3176# CHAN2_MUX_SEL3 VDD.t797 VDD.t0 sg13_lv_pmos ad=0.1596p pd=1.22u as=0.2856p ps=2.36u w=0.84u l=0.13u
X171 VSS.t331 a_2019_6001.t2 a_17865_6209# VSS.t1891 sg13_lv_nmos ad=0.2516p pd=2.16u as=0.2516p ps=2.16u w=0.74u l=0.13u
X172 a_6153_1842# a_5957_1842# VSS.t1268 VSS.t1961 sg13_lv_nmos ad=0.2516p pd=2.16u as=0.1406p ps=1.12u w=0.74u l=0.13u
X173 VDD.t251 VSS.t364 VDD.t249 VDD.t0 sg13_lv_pmos ad=0.19p pd=1.38u as=0 ps=0 w=1u l=1u
X174 a_5115_16071# a_4905_16071# VSS.t1317 VSS.t2021 sg13_lv_nmos ad=0.1406p pd=1.12u as=0.1665p ps=1.19u w=0.74u l=0.13u
X175 VSS.t1434 a_3171_1047.t2 a_27124_1008# VSS.t1723 sg13_lv_nmos ad=0.2516p pd=2.16u as=0.2516p ps=2.16u w=0.74u l=0.13u
X176 VSS.t974 a_16163_1842# a_16597_1842# VSS.t2202 sg13_lv_nmos ad=0.1406p pd=1.12u as=0.2516p ps=2.16u w=0.74u l=0.13u
X177 VDD.t612 a_2595_6001.t2 a_20905_6209# VDD.t9 sg13_lv_pmos ad=0.3808p pd=2.92u as=0.3808p ps=2.92u w=1.12u l=0.13u
X178 VDD.t367 a_27237_7532# a_27705_6734# VDD.t9 sg13_lv_pmos ad=0.252p pd=1.57u as=0.3808p ps=2.92u w=1.12u l=0.13u
X179 VDD.t1063 a_4187_2434# a_23111_8160# VDD.t345 sg13_lv_pmos ad=0.3808p pd=2.92u as=0.2128p ps=1.5u w=1.12u l=0.6u
X180 VDD.t658 a_11603_1842# a_12037_1842# VDD.t379 sg13_lv_pmos ad=0.2128p pd=1.5u as=0.3808p ps=2.92u w=1.12u l=0.13u
X181 a_6635_3889# a_6425_3889# VSS.t502 VSS.t501 sg13_lv_nmos ad=0.1406p pd=1.12u as=0.1665p ps=1.19u w=0.74u l=0.13u
X182 VSS.t331 a_1544_5979# a_2391_6021# VSS.t822 sg13_lv_nmos ad=0.1331p pd=1.12u as=0.1216p ps=1.02u w=0.64u l=0.13u
X183 a_11711_16869# a_11473_16869# a_11603_16869# VSS.t1453 sg13_lv_nmos ad=0.1406p pd=1.12u as=0.2516p ps=2.16u w=0.74u l=0.2u
X184 VDD.t617 a_3171_311.t3 a_11785_519# VDD.t67 sg13_lv_pmos ad=0.3808p pd=2.92u as=0.3808p ps=2.92u w=1.12u l=0.13u
X185 VDD.t1089 a_4187_2434# a_26151_5315# VDD.t347 sg13_lv_pmos ad=0.3808p pd=2.92u as=0.2128p ps=1.5u w=1.12u l=0.6u
X186 a_5731_289# a_2595_311.t3 a_7390_1044# VSS.t1939 sg13_lv_nmos ad=0.2516p pd=2.16u as=0.2516p ps=2.16u w=0.74u l=0.13u
X187 a_10430_1044# a_2595_1047.t7 a_11195_1044# VSS.t654 sg13_lv_nmos ad=0.2516p pd=2.16u as=0.1406p ps=1.12u w=0.74u l=0.13u
X188 VSS.t1117 a_2595_3892.t9 a_5191_3853# VSS.t1466 sg13_lv_nmos ad=0.2516p pd=2.16u as=0.2516p ps=2.16u w=0.74u l=0.13u
X189 a_6854_11676# a_6326_10280# VDD.t450 VDD.t358 sg13_lv_pmos ad=0.38p pd=2.38u as=0.38p ps=2.38u w=2u l=1u
X190 a_15464_9374# a_14851_10872# VSS.t39 VSS.t558 sg13_lv_nmos ad=0.2849p pd=2.25u as=0.2516p ps=2.16u w=0.74u l=0.13u
X191 a_24393_1842# a_24197_1842# VDD.t941 VDD.t379 sg13_lv_pmos ad=0.3808p pd=2.92u as=0.2128p ps=1.5u w=1.12u l=0.13u
X192 VSS.t1043 a_4187_1764.t152 a_12471_16869# VSS.t1042 sg13_lv_nmos ad=0.2516p pd=2.16u as=0.1406p ps=1.12u w=0.74u l=0.6u
X193 a_22873_14024# a_22677_14024# VSS.t593 VSS.t2341 sg13_lv_nmos ad=0.2516p pd=2.16u as=0.1406p ps=1.12u w=0.74u l=0.13u
X194 a_16408_3889# a_15837_4687# VDD.t414 VDD.t0 sg13_lv_pmos ad=0.2128p pd=1.5u as=0.3808p ps=2.92u w=1.12u l=0.13u
X195 a_20315_3889# a_20105_3889# VSS.t1089 VSS.t1887 sg13_lv_nmos ad=0.1406p pd=1.12u as=0.1665p ps=1.19u w=0.74u l=0.13u
X196 a_17553_16869# a_17357_16869# VDD.t517 VDD.t368 sg13_lv_pmos ad=0.3808p pd=2.92u as=0.2128p ps=1.5u w=1.12u l=0.13u
X197 VDD.t133 VSS.t207 VDD.t131 VDD.t34 sg13_lv_pmos ad=0.19p pd=1.38u as=0 ps=0 w=1u l=1u
X198 a_27048_16071# a_26477_16869# VDD.t625 VDD.t34 sg13_lv_pmos ad=0.2128p pd=1.5u as=0.3808p ps=2.92u w=1.12u l=0.13u
X199 VSS.t126 a_16163_14024# a_16597_14024# VSS.t1260 sg13_lv_nmos ad=0.1406p pd=1.12u as=0.2516p ps=2.16u w=0.74u l=0.13u
X200 a_23355_1044# a_23145_1044# VSS.t711 VSS.t710 sg13_lv_nmos ad=0.1406p pd=1.12u as=0.1665p ps=1.19u w=0.74u l=0.13u
X201 a_25528_3889# a_24957_4687# VSS.t64 VSS.t619 sg13_lv_nmos ad=0.1406p pd=1.12u as=0.2516p ps=2.16u w=0.74u l=0.13u
X202 VSS.t67 a_1256_3889# a_2967_4240# VSS.t66 sg13_lv_nmos ad=0.1331p pd=1.12u as=0.1216p ps=1.02u w=0.64u l=0.13u
X203 VDD.t1232 a_2019_13229.t2 a_25604_13190# VDD.t2 sg13_lv_pmos ad=0.3808p pd=2.92u as=0.3808p ps=2.92u w=1.12u l=0.13u
X204 VDD.t1066 a_4187_2434# a_4871_5315# VDD.t347 sg13_lv_pmos ad=0.3808p pd=2.92u as=0.2128p ps=1.5u w=1.12u l=0.6u
X205 VDD.t960 a_4187_2434# a_4111_17497# VDD.t368 sg13_lv_pmos ad=0.3808p pd=2.92u as=0.2128p ps=1.5u w=1.12u l=0.6u
X206 a_26151_16869# a_25913_16869# a_26043_16869# VSS.t854 sg13_lv_nmos ad=0.1406p pd=1.12u as=0.2516p ps=2.16u w=0.74u l=0.2u
X207 VSS.t1932 a_4187_1764.t25 a_10191_1842# VSS.t2373 sg13_lv_nmos ad=0.2516p pd=2.16u as=0.1406p ps=1.12u w=0.74u l=0.6u
X208 VSS.t317 VDD.t1663 VSS.t317 VSS.t321 sg13_lv_nmos ad=0.1428p pd=1.52u as=0 ps=0 w=0.42u l=1u
X209 VSS.t299 VDD.t1672 VSS.t299 VSS.t301 sg13_lv_nmos ad=79.8f pd=0.8u as=0 ps=0 w=0.42u l=1u
X210 VDD.t794 REF_MUX_SEL1 a_3449_7085# VDD.t9 sg13_lv_pmos ad=0.1918p pd=1.5u as=0.1596p ps=1.22u w=0.84u l=0.13u
X211 VSS.t515 a_3747_1047.t4 a_21911_1008# VSS.t689 sg13_lv_nmos ad=0.2516p pd=2.16u as=0.2516p ps=2.16u w=0.74u l=0.13u
X212 VSS.t1468 a_11603_14024# a_12037_14024# VSS.t1984 sg13_lv_nmos ad=0.1406p pd=1.12u as=0.2516p ps=2.16u w=0.74u l=0.13u
X213 a_9772_11533# a_9746_11495# VDD.t364 VDD.t358 sg13_lv_pmos ad=0.3927p pd=2.99u as=1.10612p ps=6.66u w=1.155u l=0.13u
X214 a_17791_7532# a_17553_7532# a_17683_7532# VSS.t2234 sg13_lv_nmos ad=0.1406p pd=1.12u as=0.2516p ps=2.16u w=0.74u l=0.2u
X215 VDD.t1104 a_4187_2434# a_14751_2470# VDD.t379 sg13_lv_pmos ad=0.3808p pd=2.92u as=0.2128p ps=1.5u w=1.12u l=0.6u
X216 a_2297_12513# CHAN1_MUX_SEL2 VDD.t417 VDD.t2 sg13_lv_pmos ad=0.1596p pd=1.22u as=0.2856p ps=2.36u w=0.84u l=0.13u
X217 a_10232_11561# a_10206_11525# VDD.t572 VDD.t358 sg13_lv_pmos ad=0.34p pd=2.68u as=0.36237p ps=2.605u w=1u l=0.13u
X218 a_11473_4687# a_11277_4687# VSS.t101 VSS.t1104 sg13_lv_nmos ad=0.2516p pd=2.16u as=0.1406p ps=1.12u w=0.74u l=0.13u
X219 VSS.t1860 a_19963_1842# a_20397_1842# VSS.t2002 sg13_lv_nmos ad=0.1406p pd=1.12u as=0.2516p ps=2.16u w=0.74u l=0.13u
X220 a_2967_15358# CHAN0_MUX_SEL3 a_2873_15358# VSS.t22 sg13_lv_nmos ad=0.1216p pd=1.02u as=0.2176p ps=1.96u w=0.64u l=0.13u
X221 VSS.t364 VDD.t1645 VSS.t364 VSS.t369 sg13_lv_nmos ad=79.8f pd=0.8u as=0 ps=0 w=0.42u l=1u
X222 a_7390_3889# a_9751_3853# a_9675_3889# VDD.t0 sg13_lv_pmos ad=0.3808p pd=2.92u as=0.2128p ps=1.5u w=1.12u l=0.13u
X223 VDD.t989 a_4187_2434# a_4111_2470# VDD.t379 sg13_lv_pmos ad=0.3808p pd=2.92u as=0.2128p ps=1.5u w=1.12u l=0.6u
X224 VSS.t882 a_2019_16074.t6 a_13444_16035# VSS.t881 sg13_lv_nmos ad=0.2516p pd=2.16u as=0.2516p ps=2.16u w=0.74u l=0.13u
X225 a_20968_1044# a_20397_1842# VSS.t641 VSS.t1858 sg13_lv_nmos ad=0.1406p pd=1.12u as=0.2516p ps=2.16u w=0.74u l=0.13u
X226 a_10328_1044# a_9757_1842# VDD.t522 VDD.t67 sg13_lv_pmos ad=0.2128p pd=1.5u as=0.3808p ps=2.92u w=1.12u l=0.13u
X227 VDD.t247 VSS.t344 VDD.t245 VDD.t9 sg13_lv_pmos ad=0.19p pd=1.38u as=0 ps=0 w=1u l=1u
X228 VSS.t1713 a_2019_13229.t7 a_10404_13190# VSS.t1712 sg13_lv_nmos ad=0.2516p pd=2.16u as=0.2516p ps=2.16u w=0.74u l=0.13u
X229 VDD.t565 a_6283_16869# a_6717_16869# VDD.t368 sg13_lv_pmos ad=0.2128p pd=1.5u as=0.3808p ps=2.92u w=1.12u l=0.13u
X230 a_6635_6734# a_6425_6734# VDD.t542 VDD.t9 sg13_lv_pmos ad=0.2128p pd=1.5u as=0.252p ps=1.57u w=1.12u l=0.13u
X231 a_16510_6734# a_2019_6737.t5 a_16408_6734# VSS.t1050 sg13_lv_nmos ad=0.2516p pd=2.16u as=0.1406p ps=1.12u w=0.74u l=0.13u
X232 a_22590_1044# a_22564_1008# a_22488_1044# VDD.t67 sg13_lv_pmos ad=0.3808p pd=2.92u as=0.2128p ps=1.5u w=1.12u l=0.13u
X233 VDD.t396 a_3747_15338.t2 a_26985_15546# VDD.t34 sg13_lv_pmos ad=0.3808p pd=2.92u as=0.3808p ps=2.92u w=1.12u l=0.13u
X234 VDD.t264 VSS.t414 VDD.t207 VDD.t67 sg13_lv_pmos ad=0.19p pd=1.38u as=0 ps=0 w=1u l=1u
X235 a_22590_16071# a_24084_16035# a_24008_16071# VDD.t34 sg13_lv_pmos ad=0.3808p pd=2.92u as=0.2128p ps=1.5u w=1.12u l=0.13u
X236 VDD.t56 VSS.t193 VDD.t54 VDD.t34 sg13_lv_pmos ad=0.19p pd=1.38u as=0 ps=0 w=1u l=1u
X237 VDD.t762 a_2595_6737.t9 a_5191_6698# VDD.t9 sg13_lv_pmos ad=0.3808p pd=2.92u as=0.3808p ps=2.92u w=1.12u l=0.13u
X238 VDD.t237 VSS.t350 VDD.t235 VDD.t0 sg13_lv_pmos ad=0.19p pd=1.38u as=0 ps=0 w=1u l=1u
X239 VDD.t1302 a_3449_4240# a_3747_3892.t0 VDD.t0 sg13_lv_pmos ad=0.4256p pd=3u as=0.2128p ps=1.5u w=1.12u l=0.13u
X240 a_21591_7532# a_21353_7532# a_21483_7532# VSS.t1241 sg13_lv_nmos ad=0.1406p pd=1.12u as=0.2516p ps=2.16u w=0.74u l=0.2u
X241 a_6153_7532# a_5957_7532# VSS.t602 VSS.t1625 sg13_lv_nmos ad=0.2516p pd=2.16u as=0.1406p ps=1.12u w=0.74u l=0.13u
X242 a_20315_6734# a_20105_6734# VDD.t539 VDD.t9 sg13_lv_pmos ad=0.2128p pd=1.5u as=0.252p ps=1.57u w=1.12u l=0.13u
X243 a_8808_1044# a_8237_1842# VDD.t1191 VDD.t67 sg13_lv_pmos ad=0.2128p pd=1.5u as=0.3808p ps=2.92u w=1.12u l=0.13u
X244 VDD.t490 VDD.t488 VDD.t489 VDD.t347 sg13_lv_pmos ad=0.3808p pd=2.92u as=0 ps=0 w=1.12u l=0.6u
X245 a_1256_12471# CHAN1_MUX_SEL2 VSS.t169 VSS.t168 sg13_lv_nmos ad=0.2516p pd=2.16u as=0.2516p ps=2.16u w=0.74u l=0.13u
X246 a_25528_6734# a_24957_7532# VDD.t1137 VDD.t9 sg13_lv_pmos ad=0.2128p pd=1.5u as=0.3808p ps=2.92u w=1.12u l=0.13u
X247 a_3171_13229.t1 a_2873_13577# VSS.t76 VSS.t75 sg13_lv_nmos ad=0.1406p pd=1.12u as=0.1331p ps=1.12u w=0.74u l=0.13u
X248 VSS.t10 a_16163_7532# a_16597_7532# VSS.t9 sg13_lv_nmos ad=0.1406p pd=1.12u as=0.2516p ps=2.16u w=0.74u l=0.13u
X249 VSS.t1081 a_3171_6737.t2 a_27124_6698# VSS.t1391 sg13_lv_nmos ad=0.2516p pd=2.16u as=0.2516p ps=2.16u w=0.74u l=0.13u
X250 VDD.t298 VSS.t200 VDD.t297 VDD.t34 sg13_lv_pmos ad=0.34p pd=2.68u as=0 ps=0 w=1u l=1u
X251 VDD.t553 a_2595_3156.t2 a_20905_3364# VDD.t0 sg13_lv_pmos ad=0.3808p pd=2.92u as=0.3808p ps=2.92u w=1.12u l=0.13u
X252 a_23871_14024# a_23633_14024# a_23763_14024# VSS.t2203 sg13_lv_nmos ad=0.1406p pd=1.12u as=0.2516p ps=2.16u w=0.74u l=0.2u
X253 VDD.t1286 a_11603_7532# a_12037_7532# VDD.t345 sg13_lv_pmos ad=0.2128p pd=1.5u as=0.3808p ps=2.92u w=1.12u l=0.13u
X254 a_18551_17497# a_18313_16869# a_18443_16869# VDD.t368 sg13_lv_pmos ad=0.2128p pd=1.5u as=0.3808p ps=2.92u w=1.12u l=0.2u
X255 CHAN1_DELAY_OUT_LAST a_27997_14024# VSS.t589 VSS.t852 sg13_lv_nmos ad=0.2516p pd=2.16u as=0.1406p ps=1.12u w=0.74u l=0.13u
X256 VDD.t1402 a_3171_13229.t7 a_11924_13190# VDD.t2 sg13_lv_pmos ad=0.3808p pd=2.92u as=0.3808p ps=2.92u w=1.12u l=0.13u
X257 VSS.t5 VDD.t1706 VSS.t5 VSS.t188 sg13_lv_nmos ad=0.1428p pd=1.52u as=0 ps=0 w=0.42u l=1u
X258 a_4350_13226# a_2595_13229.t9 a_5115_13226# VSS.t1754 sg13_lv_nmos ad=0.2516p pd=2.16u as=0.1406p ps=1.12u w=0.74u l=0.13u
X259 a_3449_4240# CHAN2_MUX_SEL0 VDD.t710 VDD.t0 sg13_lv_pmos ad=0.1596p pd=1.22u as=0.2856p ps=2.36u w=0.84u l=0.13u
X260 a_13880_10808# a_14111_10917# a_13566_11018# VSS.t2283 sg13_lv_nmos ad=0.2373p pd=1.97u as=79.8f ps=0.8u w=0.42u l=0.13u
X261 VSS.t117 a_4187_1764.t104 a_24631_14024# VSS.t116 sg13_lv_nmos ad=0.2516p pd=2.16u as=0.1406p ps=1.12u w=0.74u l=0.6u
X262 a_24393_7532# a_24197_7532# VDD.t394 VDD.t345 sg13_lv_pmos ad=0.3808p pd=2.92u as=0.2128p ps=1.5u w=1.12u l=0.13u
X263 a_10430_6734# a_2595_6737.t7 a_11195_6734# VSS.t1385 sg13_lv_nmos ad=0.2516p pd=2.16u as=0.1406p ps=1.12u w=0.74u l=0.13u
X264 VSS.t200 a_3171_15338.t3 a_11785_15546# VSS.t2360 sg13_lv_nmos ad=0.2516p pd=2.16u as=0.2516p ps=2.16u w=0.74u l=0.13u
X265 a_4157_1313# CHAN3_DELAY_IN VDD.t421 VDD.t67 sg13_lv_pmos ad=0.3808p pd=2.92u as=0.3808p ps=2.92u w=1.12u l=0.13u
X266 a_27433_4687# a_27237_4687# VDD.t1201 VDD.t347 sg13_lv_pmos ad=0.3808p pd=2.92u as=0.2128p ps=1.5u w=1.12u l=0.13u
X267 a_7390_16071# a_8884_16035# a_8808_16071# VDD.t34 sg13_lv_pmos ad=0.3808p pd=2.92u as=0.2128p ps=1.5u w=1.12u l=0.13u
X268 a_17031_2470# a_16793_1842# a_16923_1842# VDD.t379 sg13_lv_pmos ad=0.2128p pd=1.5u as=0.3808p ps=2.92u w=1.12u l=0.2u
X269 VSS.t1822 a_4187_1764.t37 a_25391_4687# VSS.t2201 sg13_lv_nmos ad=0.2516p pd=2.16u as=0.1406p ps=1.12u w=0.74u l=0.6u
X270 VDD.t19 VSS.t317 VDD.t18 VDD.t9 sg13_lv_pmos ad=0.34p pd=2.68u as=0 ps=0 w=1u l=1u
X271 VDD.t1421 a_1544_15316# a_1721_15358# VDD.t34 sg13_lv_pmos ad=0.1918p pd=1.5u as=0.1596p ps=1.22u w=0.84u l=0.13u
X272 a_17553_14024# a_17357_14024# VDD.t642 VDD.t378 sg13_lv_pmos ad=0.3808p pd=2.92u as=0.2128p ps=1.5u w=1.12u l=0.13u
X273 a_23355_6734# a_23145_6734# VSS.t1239 VSS.t1238 sg13_lv_nmos ad=0.1406p pd=1.12u as=0.1665p ps=1.19u w=0.74u l=0.13u
X274 VSS.t871 a_4187_1764.t89 a_10191_7532# VSS.t870 sg13_lv_nmos ad=0.2516p pd=2.16u as=0.1406p ps=1.12u w=0.74u l=0.6u
X275 VDD.t1015 a_4187_2434# a_4111_14652# VDD.t378 sg13_lv_pmos ad=0.3808p pd=2.92u as=0.2128p ps=1.5u w=1.12u l=0.6u
X276 VDD.t75 VSS.t250 VDD.t74 VDD.t2 sg13_lv_pmos ad=0.19p pd=1.38u as=0 ps=0 w=1u l=1u
X277 a_4350_16071# a_4324_16035# a_4248_16071# VDD.t34 sg13_lv_pmos ad=0.3808p pd=2.92u as=0.2128p ps=1.5u w=1.12u l=0.13u
X278 VSS.t798 a_3747_6737.t4 a_21911_6698# VSS.t1817 sg13_lv_nmos ad=0.2516p pd=2.16u as=0.2516p ps=2.16u w=0.74u l=0.13u
X279 VDD.t1207 a_3171_3892.t5 a_18004_3853# VDD.t0 sg13_lv_pmos ad=0.3808p pd=2.92u as=0.3808p ps=2.92u w=1.12u l=0.13u
X280 VDD.t1057 a_4187_2434# a_14751_8160# VDD.t345 sg13_lv_pmos ad=0.3808p pd=2.92u as=0.2128p ps=1.5u w=1.12u l=0.6u
X281 a_3171_3156.t0 a_2873_3176# VDD.t1423 VDD.t0 sg13_lv_pmos ad=0.2128p pd=1.5u as=0.1918p ps=1.5u w=1.12u l=0.13u
X282 a_26673_16869# a_26477_16869# VSS.t748 VSS.t747 sg13_lv_nmos ad=0.2516p pd=2.16u as=0.1406p ps=1.12u w=0.74u l=0.13u
X283 a_11473_1842# a_11277_1842# VSS.t782 VSS.t1983 sg13_lv_nmos ad=0.2516p pd=2.16u as=0.1406p ps=1.12u w=0.74u l=0.13u
X284 VDD.t1514 a_2019_15338.t2 a_17865_15546# VDD.t34 sg13_lv_pmos ad=0.3808p pd=2.92u as=0.3808p ps=2.92u w=1.12u l=0.13u
X285 VSS.t755 a_19963_7532# a_20397_7532# VSS.t2133 sg13_lv_nmos ad=0.1406p pd=1.12u as=0.2516p ps=2.16u w=0.74u l=0.13u
X286 VDD.t1440 a_2297_3176# a_2595_3156.t0 VDD.t0 sg13_lv_pmos ad=0.4256p pd=3u as=0.2128p ps=1.5u w=1.12u l=0.13u
X287 a_2967_12513# CHAN1_MUX_SEL3 a_2873_12513# VSS.t713 sg13_lv_nmos ad=0.1216p pd=1.02u as=0.2176p ps=1.96u w=0.64u l=0.13u
X288 VSS.t447 VDD.t1622 VSS.t449 VSS.t448 sg13_lv_nmos ad=79.8f pd=0.8u as=0 ps=0 w=0.42u l=1u
X289 VDD.t1520 a_3747_12493.t3 a_14825_12701# VDD.t2 sg13_lv_pmos ad=0.3808p pd=2.92u as=0.3808p ps=2.92u w=1.12u l=0.13u
X290 a_16408_3889# a_15837_4687# VSS.t61 VSS.t164 sg13_lv_nmos ad=0.1406p pd=1.12u as=0.2516p ps=2.16u w=0.74u l=0.13u
X291 VDD.t1426 a_1721_15358# a_2019_15338.t0 VDD.t34 sg13_lv_pmos ad=0.4256p pd=3u as=0.2128p ps=1.5u w=1.12u l=0.13u
X292 VSS.t2081 a_1721_15358# a_2019_15338.t1 VSS.t1938 sg13_lv_nmos ad=0.2812p pd=2.24u as=0.1406p ps=1.12u w=0.74u l=0.13u
X293 a_8433_14024# a_8237_14024# VSS.t757 VSS.t1924 sg13_lv_nmos ad=0.2516p pd=2.16u as=0.1406p ps=1.12u w=0.74u l=0.13u
X294 a_19448_1044# a_18877_1842# VSS.t673 VSS.t1359 sg13_lv_nmos ad=0.1406p pd=1.12u as=0.2516p ps=2.16u w=0.74u l=0.13u
X295 VDD.t771 a_2595_16074.t6 a_14311_16035# VDD.t34 sg13_lv_pmos ad=0.3808p pd=2.92u as=0.3808p ps=2.92u w=1.12u l=0.13u
X296 VSS.t232 VDD.t1689 VSS.t231 VSS.t230 sg13_lv_nmos ad=0.1428p pd=1.52u as=0 ps=0 w=0.42u l=1u
X297 a_25630_13226# a_2019_13229.t2 a_25528_13226# VSS.t1740 sg13_lv_nmos ad=0.2516p pd=2.16u as=0.1406p ps=1.12u w=0.74u l=0.13u
X298 a_15053_11680# a_14111_11568# a_14851_11918# VDD.t358 sg13_lv_pmos ad=93.45f pd=0.865u as=0.2048p ps=1.63u w=0.42u l=0.13u
X299 VDD.t968 a_4187_2434# a_4111_8160# VDD.t345 sg13_lv_pmos ad=0.3808p pd=2.92u as=0.2128p ps=1.5u w=1.12u l=0.6u
X300 a_10430_1044# a_3171_1047.t7 a_11848_1044# VSS.t636 sg13_lv_nmos ad=0.2516p pd=2.16u as=0.1406p ps=1.12u w=0.74u l=0.13u
X301 a_20968_6734# a_20397_7532# VSS.t1389 VSS.t1513 sg13_lv_nmos ad=0.1406p pd=1.12u as=0.2516p ps=2.16u w=0.74u l=0.13u
X302 VDD.t397 a_27237_1842# a_27705_1044# VDD.t67 sg13_lv_pmos ad=0.252p pd=1.57u as=0.3808p ps=2.92u w=1.12u l=0.13u
X303 a_14235_3889# a_14025_3889# VDD.t638 VDD.t0 sg13_lv_pmos ad=0.2128p pd=1.5u as=0.252p ps=1.57u w=1.12u l=0.13u
X304 a_5731_5979# a_14825_6209# a_13470_6734# VDD.t9 sg13_lv_pmos ad=0.3808p pd=2.92u as=0.3808p ps=2.92u w=1.12u l=0.13u
X305 a_19448_13226# a_18877_14024# VSS.t792 VSS.t791 sg13_lv_nmos ad=0.1406p pd=1.12u as=0.2516p ps=2.16u w=0.74u l=0.13u
X306 VDD.t1074 a_4187_2434# a_7151_5315# VDD.t347 sg13_lv_pmos ad=0.3808p pd=2.92u as=0.2128p ps=1.5u w=1.12u l=0.6u
X307 VSS.t2113 a_16851_15336# CHAN0_MUX_OUT VSS.t2114 sg13_lv_nmos ad=0.2516p pd=2.16u as=0.1406p ps=1.12u w=0.74u l=0.13u
X308 a_16108_12471# a_15765_12645# a_15964_12471# VDD.t2 sg13_lv_pmos ad=0.3808p pd=2.92u as=0.3304p ps=1.71u w=1.12u l=0.13u
X309 VDD.t666 a_6326_10280# a_6326_10280# VDD.t358 sg13_lv_pmos ad=0.38p pd=2.38u as=0.38p ps=2.38u w=2u l=1u
X310 VSS.t419 VDD.t1629 VSS.t422 VSS.t421 sg13_lv_nmos ad=79.8f pd=0.8u as=0 ps=0 w=0.42u l=1u
X311 VDD.t176 VSS.t393 VDD.t174 VDD.t0 sg13_lv_pmos ad=0.19p pd=1.38u as=0 ps=0 w=1u l=1u
X312 a_2595_16074.t1 a_2297_16422# VSS.t1806 VSS.t1805 sg13_lv_nmos ad=0.1406p pd=1.12u as=0.1331p ps=1.12u w=0.74u l=0.13u
X313 a_20831_2470# a_20593_1842# a_20723_1842# VDD.t379 sg13_lv_pmos ad=0.2128p pd=1.5u as=0.3808p ps=2.92u w=1.12u l=0.2u
X314 VDD.t1330 a_6283_14024# a_6717_14024# VDD.t378 sg13_lv_pmos ad=0.2128p pd=1.5u as=0.3808p ps=2.92u w=1.12u l=0.13u
X315 a_5393_1842# a_5197_1842# VDD.t1446 VDD.t379 sg13_lv_pmos ad=0.3808p pd=2.92u as=0.2128p ps=1.5u w=1.12u l=0.13u
X316 VDD.t371 a_3747_3892.t7 a_12791_3853# VDD.t0 sg13_lv_pmos ad=0.3808p pd=2.92u as=0.3808p ps=2.92u w=1.12u l=0.13u
X317 VSS.t830 a_4187_1764.t116 a_15511_14024# VSS.t829 sg13_lv_nmos ad=0.2516p pd=2.16u as=0.1406p ps=1.12u w=0.74u l=0.6u
X318 a_13949_11186# a_13592_11113# VDD.t829 VDD.t358 sg13_lv_pmos ad=63f pd=0.72u as=0.1563p ps=1.22u w=0.42u l=0.13u
X319 VDD.t1111 a_4187_2434# a_17031_2470# VDD.t379 sg13_lv_pmos ad=0.3808p pd=2.92u as=0.2128p ps=1.5u w=1.12u l=0.6u
X320 a_10191_14024# a_9953_14024# a_10083_14024# VSS.t1927 sg13_lv_nmos ad=0.1406p pd=1.12u as=0.2516p ps=2.16u w=0.74u l=0.2u
X321 VSS.t1274 a_4187_1764.t122 a_10951_14024# VSS.t2377 sg13_lv_nmos ad=0.2516p pd=2.16u as=0.1406p ps=1.12u w=0.74u l=0.6u
X322 a_7390_3889# a_3747_3892.t8 a_9675_3889# VSS.t1945 sg13_lv_nmos ad=0.2516p pd=2.16u as=0.1406p ps=1.12u w=0.74u l=0.13u
X323 a_25630_13226# a_27124_13190# a_27048_13226# VDD.t2 sg13_lv_pmos ad=0.3808p pd=2.92u as=0.2128p ps=1.5u w=1.12u l=0.13u
X324 VDD.t1163 a_26803_1842# a_27237_1842# VDD.t379 sg13_lv_pmos ad=0.2128p pd=1.5u as=0.3808p ps=2.92u w=1.12u l=0.13u
X325 VDD.t1289 CHAN3_MUX_SEL1 a_3449_1395# VDD.t67 sg13_lv_pmos ad=0.1918p pd=1.5u as=0.1596p ps=1.22u w=0.84u l=0.13u
X326 a_17275_16071# a_17065_16071# VDD.t1123 VDD.t34 sg13_lv_pmos ad=0.2128p pd=1.5u as=0.252p ps=1.57u w=1.12u l=0.13u
X327 a_11848_3889# a_11277_4687# VDD.t782 VDD.t0 sg13_lv_pmos ad=0.2128p pd=1.5u as=0.3808p ps=2.92u w=1.12u l=0.13u
X328 a_18551_14652# a_18313_14024# a_18443_14024# VDD.t378 sg13_lv_pmos ad=0.2128p pd=1.5u as=0.3808p ps=2.92u w=1.12u l=0.2u
X329 VSS.t39 a_15108_11015# a_14757_10872# VSS.t38 sg13_lv_nmos ad=79.8f pd=0.8u as=0.1428p ps=1.52u w=0.42u l=0.13u
X330 a_25630_1044# a_2595_1047.t2 a_26395_1044# VSS.t1918 sg13_lv_nmos ad=0.2516p pd=2.16u as=0.1406p ps=1.12u w=0.74u l=0.13u
X331 a_17031_8160# a_16793_7532# a_16923_7532# VDD.t345 sg13_lv_pmos ad=0.2128p pd=1.5u as=0.3808p ps=2.92u w=1.12u l=0.2u
X332 a_16408_6734# a_15837_7532# VDD.t1530 VDD.t9 sg13_lv_pmos ad=0.2128p pd=1.5u as=0.3808p ps=2.92u w=1.12u l=0.13u
X333 VSS.t324 VDD.t1660 VSS.t324 VSS.t328 sg13_lv_nmos ad=0.1428p pd=1.52u as=0 ps=0 w=0.42u l=1u
X334 a_27671_16869# a_27433_16869# a_27563_16869# VSS.t732 sg13_lv_nmos ad=0.1406p pd=1.12u as=0.2516p ps=2.16u w=0.74u l=0.2u
X335 a_16510_13226# a_2019_13229.t5 a_16408_13226# VSS.t1336 sg13_lv_nmos ad=0.2516p pd=2.16u as=0.1406p ps=1.12u w=0.74u l=0.13u
X336 VSS.t595 a_4187_1764.t5 a_25391_1842# VSS.t594 sg13_lv_nmos ad=0.2516p pd=2.16u as=0.1406p ps=1.12u w=0.74u l=0.6u
X337 VDD.t801 a_1544_12471# a_1721_12513# VDD.t2 sg13_lv_pmos ad=0.1918p pd=1.5u as=0.1596p ps=1.22u w=0.84u l=0.13u
X338 VDD.t257 VSS.t364 VDD.t256 VDD.t0 sg13_lv_pmos ad=0.34p pd=2.68u as=0 ps=0 w=1u l=1u
X339 VSS.t1288 a_13123_14024# a_13557_14024# VSS.t1287 sg13_lv_nmos ad=0.1406p pd=1.12u as=0.2516p ps=2.16u w=0.74u l=0.13u
X340 a_5115_13226# a_4905_13226# VDD.t823 VDD.t2 sg13_lv_pmos ad=0.2128p pd=1.5u as=0.252p ps=1.57u w=1.12u l=0.13u
X341 a_26673_4687# a_26477_4687# VSS.t1250 VSS.t1249 sg13_lv_nmos ad=0.2516p pd=2.16u as=0.1406p ps=1.12u w=0.74u l=0.13u
X342 a_6635_1044# a_6425_1044# VDD.t422 VDD.t67 sg13_lv_pmos ad=0.2128p pd=1.5u as=0.252p ps=1.57u w=1.12u l=0.13u
X343 a_11473_7532# a_11277_7532# VSS.t1111 VSS.t1110 sg13_lv_nmos ad=0.2516p pd=2.16u as=0.1406p ps=1.12u w=0.74u l=0.13u
X344 VSS.t288 VDD.t1675 VSS.t288 VSS.t290 sg13_lv_nmos ad=79.8f pd=0.8u as=0 ps=0 w=0.42u l=1u
X345 a_18313_4687# a_18117_4687# VDD.t1526 VDD.t347 sg13_lv_pmos ad=0.3808p pd=2.92u as=0.2128p ps=1.5u w=1.12u l=0.13u
X346 VDD.t592 a_2595_1047.t9 a_5191_1008# VDD.t67 sg13_lv_pmos ad=0.3808p pd=2.92u as=0.3808p ps=2.92u w=1.12u l=0.13u
X347 a_9431_5315# a_9193_4687# a_9323_4687# VDD.t347 sg13_lv_pmos ad=0.2128p pd=1.5u as=0.3808p ps=2.92u w=1.12u l=0.2u
X348 a_19448_6734# a_18877_7532# VSS.t92 VSS.t91 sg13_lv_nmos ad=0.1406p pd=1.12u as=0.2516p ps=2.16u w=0.74u l=0.13u
X349 a_20315_1044# a_20105_1044# VDD.t620 VDD.t67 sg13_lv_pmos ad=0.2128p pd=1.5u as=0.252p ps=1.57u w=1.12u l=0.13u
X350 a_13592_11113# a_14111_10917# a_14851_10872# VSS.t2284 sg13_lv_nmos ad=0.3473p pd=2.71u as=0.12665p ps=1.145u w=0.74u l=0.13u
X351 a_10430_6734# a_3171_6737.t7 a_11848_6734# VSS.t1910 sg13_lv_nmos ad=0.2516p pd=2.16u as=0.1406p ps=1.12u w=0.74u l=0.13u
X352 a_7390_6734# a_9751_6698# a_9675_6734# VDD.t9 sg13_lv_pmos ad=0.3808p pd=2.92u as=0.2128p ps=1.5u w=1.12u l=0.13u
X353 a_25528_1044# a_24957_1842# VDD.t1380 VDD.t67 sg13_lv_pmos ad=0.2128p pd=1.5u as=0.3808p ps=2.92u w=1.12u l=0.13u
X354 VSS.t768 a_1721_1395# a_2019_1047.t1 VSS.t1522 sg13_lv_nmos ad=0.2812p pd=2.24u as=0.1406p ps=1.12u w=0.74u l=0.13u
X355 a_19311_2470# a_19073_1842# a_19203_1842# VDD.t379 sg13_lv_pmos ad=0.2128p pd=1.5u as=0.3808p ps=2.92u w=1.12u l=0.2u
X356 a_5731_3134# a_14825_3364# a_13470_3889# VDD.t0 sg13_lv_pmos ad=0.3808p pd=2.92u as=0.3808p ps=2.92u w=1.12u l=0.13u
X357 VSS.t178 a_5957_1842# a_6425_1044# VSS.t1960 sg13_lv_nmos ad=0.1665p pd=1.19u as=0.2516p ps=2.16u w=0.74u l=0.13u
X358 VSS.t925 a_3171_3892.t5 a_18004_3853# VSS.t1643 sg13_lv_nmos ad=0.2516p pd=2.16u as=0.2516p ps=2.16u w=0.74u l=0.13u
X359 VSS.t490 a_2019_16074.t7 a_10404_16035# VSS.t856 sg13_lv_nmos ad=0.2516p pd=2.16u as=0.2516p ps=2.16u w=0.74u l=0.13u
X360 a_20831_8160# a_20593_7532# a_20723_7532# VDD.t345 sg13_lv_pmos ad=0.2128p pd=1.5u as=0.3808p ps=2.92u w=1.12u l=0.2u
X361 a_5393_7532# a_5197_7532# VDD.t731 VDD.t345 sg13_lv_pmos ad=0.3808p pd=2.92u as=0.2128p ps=1.5u w=1.12u l=0.13u
X362 a_23871_5315# a_23633_4687# a_23763_4687# VDD.t347 sg13_lv_pmos ad=0.2128p pd=1.5u as=0.3808p ps=2.92u w=1.12u l=0.2u
X363 VDD.t1059 a_4187_2434# a_17031_8160# VDD.t345 sg13_lv_pmos ad=0.3808p pd=2.92u as=0.2128p ps=1.5u w=1.12u l=0.6u
X364 VSS.t486 a_4187_1764.t62 a_6391_4687# VSS.t749 sg13_lv_nmos ad=0.2516p pd=2.16u as=0.1406p ps=1.12u w=0.74u l=0.6u
X365 a_8433_4687# a_8237_4687# VDD.t750 VDD.t347 sg13_lv_pmos ad=0.3808p pd=2.92u as=0.2128p ps=1.5u w=1.12u l=0.13u
X366 VSS.t703 a_2297_13577# a_2595_13229.t1 VSS.t2018 sg13_lv_nmos ad=0.2812p pd=2.24u as=0.1406p ps=1.12u w=0.74u l=0.13u
X367 VSS.t542 a_10649_11568# a_10751_11568# VSS.t1004 sg13_lv_nmos ad=2.39977p pd=15.495u as=0.2516p ps=2.16u w=0.74u l=0.13u
X368 VDD.t36 VSS.t122 VDD.t35 VDD.t34 sg13_lv_pmos ad=0.34p pd=2.68u as=0 ps=0 w=1u l=1u
X369 VDD.t398 a_18443_4687# a_18877_4687# VDD.t347 sg13_lv_pmos ad=0.2128p pd=1.5u as=0.3808p ps=2.92u w=1.12u l=0.13u
X370 a_19550_16071# a_21044_16035# a_20968_16071# VDD.t34 sg13_lv_pmos ad=0.3808p pd=2.92u as=0.2128p ps=1.5u w=1.12u l=0.13u
X371 a_10713_14024# a_10517_14024# VSS.t866 VSS.t1284 sg13_lv_nmos ad=0.2516p pd=2.16u as=0.1406p ps=1.12u w=0.74u l=0.13u
X372 VDD.t896 a_26803_7532# a_27237_7532# VDD.t345 sg13_lv_pmos ad=0.2128p pd=1.5u as=0.3808p ps=2.92u w=1.12u l=0.13u
X373 a_14235_3889# a_14025_3889# VSS.t778 VSS.t964 sg13_lv_nmos ad=0.1406p pd=1.12u as=0.1665p ps=1.19u w=0.74u l=0.13u
X374 a_22113_4687# a_21917_4687# VDD.t775 VDD.t347 sg13_lv_pmos ad=0.3808p pd=2.92u as=0.2128p ps=1.5u w=1.12u l=0.13u
X375 VSS.t1073 a_4187_1764.t143 a_19311_16869# VSS.t1072 sg13_lv_nmos ad=0.2516p pd=2.16u as=0.1406p ps=1.12u w=0.74u l=0.6u
X376 a_3171_16074.t1 a_2873_16422# VSS.t1279 VSS.t1280 sg13_lv_nmos ad=0.1406p pd=1.12u as=0.1331p ps=1.12u w=0.74u l=0.13u
X377 VDD.t1235 a_2019_13229.t6 a_13444_13190# VDD.t2 sg13_lv_pmos ad=0.3808p pd=2.92u as=0.3808p ps=2.92u w=1.12u l=0.13u
X378 VDD.t773 a_19637_4687# a_20105_3889# VDD.t0 sg13_lv_pmos ad=0.252p pd=1.57u as=0.3808p ps=2.92u w=1.12u l=0.13u
X379 VDD.t54 VSS.t193 VDD.t53 VDD.t34 sg13_lv_pmos ad=0.34p pd=2.68u as=0 ps=0 w=1u l=1u
X380 VSS.t662 a_2019_1047.t6 a_13444_1008# VSS.t661 sg13_lv_nmos ad=0.2516p pd=2.16u as=0.2516p ps=2.16u w=0.74u l=0.13u
X381 VSS.t55 a_3747_3892.t7 a_12791_3853# VSS.t54 sg13_lv_nmos ad=0.2516p pd=2.16u as=0.2516p ps=2.16u w=0.74u l=0.13u
X382 VSS.t29 a_4187_1764.t43 a_20831_4687# VSS.t1664 sg13_lv_nmos ad=0.2516p pd=2.16u as=0.1406p ps=1.12u w=0.74u l=0.6u
X383 VDD.t652 a_16851_12491# CHAN1_MUX_OUT VDD.t2 sg13_lv_pmos ad=0.7336p pd=3.55u as=0.2128p ps=1.5u w=1.12u l=0.13u
X384 a_25630_6734# a_2595_6737.t2 a_26395_6734# VSS.t1079 sg13_lv_nmos ad=0.2516p pd=2.16u as=0.1406p ps=1.12u w=0.74u l=0.13u
X385 a_4350_16071# a_2595_16074.t9 a_5115_16071# VSS.t872 sg13_lv_nmos ad=0.2516p pd=2.16u as=0.1406p ps=1.12u w=0.74u l=0.13u
X386 a_25153_14024# a_24957_14024# VSS.t117 VSS.t2348 sg13_lv_nmos ad=0.2516p pd=2.16u as=0.1406p ps=1.12u w=0.74u l=0.13u
X387 VSS.t400 VDD.t1634 VSS.t400 VSS.t399 sg13_lv_nmos ad=0.1428p pd=1.52u as=0 ps=0 w=0.42u l=1u
X388 a_23111_2470# a_22873_1842# a_23003_1842# VDD.t379 sg13_lv_pmos ad=0.2128p pd=1.5u as=0.3808p ps=2.92u w=1.12u l=0.2u
X389 VSS.t766 a_15964_289# a_16851_309# VSS.t765 sg13_lv_nmos ad=0.1371p pd=1.12u as=0.2176p ps=1.96u w=0.64u l=0.13u
X390 VDD.t144 VSS.t324 VDD.t143 VDD.t9 sg13_lv_pmos ad=0.34p pd=2.68u as=0 ps=0 w=1u l=1u
X391 a_16108_289# a_17865_519# a_16510_1044# VDD.t67 sg13_lv_pmos ad=0.3808p pd=2.92u as=0.3808p ps=2.92u w=1.12u l=0.13u
X392 VDD.t1077 a_4187_2434# a_12471_5315# VDD.t347 sg13_lv_pmos ad=0.3808p pd=2.92u as=0.2128p ps=1.5u w=1.12u l=0.6u
X393 VDD.t560 a_17683_1842# a_18117_1842# VDD.t379 sg13_lv_pmos ad=0.2128p pd=1.5u as=0.3808p ps=2.92u w=1.12u l=0.13u
X394 VSS.t1023 a_4187_1764.t69 a_25391_7532# VSS.t1022 sg13_lv_nmos ad=0.2516p pd=2.16u as=0.1406p ps=1.12u w=0.74u l=0.6u
X395 a_10713_1842# a_10517_1842# VDD.t1334 VDD.t379 sg13_lv_pmos ad=0.3808p pd=2.92u as=0.2128p ps=1.5u w=1.12u l=0.13u
X396 a_4350_16071# a_5844_16035# a_5768_16071# VDD.t34 sg13_lv_pmos ad=0.3808p pd=2.92u as=0.2128p ps=1.5u w=1.12u l=0.13u
X397 a_11848_3889# a_11277_4687# VSS.t1106 VSS.t1105 sg13_lv_nmos ad=0.1406p pd=1.12u as=0.2516p ps=2.16u w=0.74u l=0.13u
X398 a_10191_4687# a_9953_4687# a_10083_4687# VSS.t1504 sg13_lv_nmos ad=0.1406p pd=1.12u as=0.2516p ps=2.16u w=0.74u l=0.2u
X399 VSS.t1693 a_4187_1764.t98 VSS.t1691 VSS.t1676 sg13_lv_nmos ad=1.33p pd=7.38u as=0 ps=0 w=7u l=7u
X400 VDD.t1321 a_3171_6737.t5 a_18004_6698# VDD.t9 sg13_lv_pmos ad=0.3808p pd=2.92u as=0.3808p ps=2.92u w=1.12u l=0.13u
X401 a_26673_1842# a_26477_1842# VSS.t1230 VSS.t1435 sg13_lv_nmos ad=0.2516p pd=2.16u as=0.1406p ps=1.12u w=0.74u l=0.13u
X402 VDD.t705 a_22243_4687# a_22677_4687# VDD.t347 sg13_lv_pmos ad=0.2128p pd=1.5u as=0.3808p ps=2.92u w=1.12u l=0.13u
X403 VDD.t296 VSS.t200 VDD.t294 VDD.t34 sg13_lv_pmos ad=0.19p pd=1.38u as=0 ps=0 w=1u l=1u
X404 a_23633_16869# a_23437_16869# VSS.t119 VSS.t2242 sg13_lv_nmos ad=0.2516p pd=2.16u as=0.1406p ps=1.12u w=0.74u l=0.13u
X405 a_13019_11521# a_15688_11093# VSS.t39 VSS.t1298 sg13_lv_nmos ad=0.2516p pd=2.16u as=0.1406p ps=1.12u w=0.74u l=0.13u
X406 a_9953_14024# a_9757_14024# VSS.t762 VSS.t1972 sg13_lv_nmos ad=0.2516p pd=2.16u as=0.1406p ps=1.12u w=0.74u l=0.13u
X407 a_20315_13226# a_20105_13226# VSS.t1997 VSS.t2077 sg13_lv_nmos ad=0.1406p pd=1.12u as=0.1665p ps=1.19u w=0.74u l=0.13u
X408 a_16510_3889# a_17351_3853# a_17275_3889# VDD.t0 sg13_lv_pmos ad=0.3808p pd=2.92u as=0.2128p ps=1.5u w=1.12u l=0.13u
X409 VSS.t495 a_16923_16869# a_17357_16869# VSS.t494 sg13_lv_nmos ad=0.1406p pd=1.12u as=0.2516p ps=2.16u w=0.74u l=0.13u
X410 VDD.t1221 a_3747_15338.t3 a_14825_15546# VDD.t34 sg13_lv_pmos ad=0.3808p pd=2.92u as=0.3808p ps=2.92u w=1.12u l=0.13u
X411 VDD.t1192 a_7803_1842# a_8237_1842# VDD.t379 sg13_lv_pmos ad=0.2128p pd=1.5u as=0.3808p ps=2.92u w=1.12u l=0.13u
X412 VDD.t691 a_3171_12493.t3 a_11785_12701# VDD.t2 sg13_lv_pmos ad=0.3808p pd=2.92u as=0.3808p ps=2.92u w=1.12u l=0.13u
X413 VSS.t2 VDD.t1641 VSS.t2 VSS.t377 sg13_lv_nmos ad=0.1428p pd=1.52u as=0 ps=0 w=0.42u l=1u
X414 a_2595_12493.t0 a_2297_12513# VDD.t633 VDD.t2 sg13_lv_pmos ad=0.2128p pd=1.5u as=0.1918p ps=1.5u w=1.12u l=0.13u
X415 a_25630_16071# a_2019_16074.t2 a_25528_16071# VSS.t520 sg13_lv_nmos ad=0.2516p pd=2.16u as=0.1406p ps=1.12u w=0.74u l=0.13u
X416 a_19311_8160# a_19073_7532# a_19203_7532# VDD.t345 sg13_lv_pmos ad=0.2128p pd=1.5u as=0.3808p ps=2.92u w=1.12u l=0.2u
X417 VSS.t1630 a_1721_7085# a_2019_6737.t1 VSS.t1631 sg13_lv_nmos ad=0.2812p pd=2.24u as=0.1406p ps=1.12u w=0.74u l=0.13u
X418 a_4248_1044# a_4157_1313# VSS.t667 VSS.t1783 sg13_lv_nmos ad=0.1406p pd=1.12u as=0.2516p ps=2.16u w=0.74u l=0.13u
X419 VDD.t566 a_8563_16869# a_8997_16869# VDD.t368 sg13_lv_pmos ad=0.2128p pd=1.5u as=0.3808p ps=2.92u w=1.12u l=0.13u
X420 VSS.t317 VDD.t1665 VSS.t317 VSS.t316 sg13_lv_nmos ad=0.1428p pd=1.52u as=0 ps=0 w=0.42u l=1u
X421 a_19448_16071# a_18877_16869# VSS.t1021 VSS.t2326 sg13_lv_nmos ad=0.1406p pd=1.12u as=0.2516p ps=2.16u w=0.74u l=0.13u
X422 VDD.t689 a_2595_16074.t7 a_11271_16035# VDD.t34 sg13_lv_pmos ad=0.3808p pd=2.92u as=0.3808p ps=2.92u w=1.12u l=0.13u
X423 VSS.t554 a_5957_7532# a_6425_6734# VSS.t1624 sg13_lv_nmos ad=0.1665p pd=1.19u as=0.2516p ps=2.16u w=0.74u l=0.13u
X424 a_14235_6734# a_14025_6734# VDD.t391 VDD.t9 sg13_lv_pmos ad=0.2128p pd=1.5u as=0.252p ps=1.57u w=1.12u l=0.13u
X425 VSS.t193 VDD.t1704 VSS.t193 VSS.t192 sg13_lv_nmos ad=0.1428p pd=1.52u as=0 ps=0 w=0.42u l=1u
X426 a_16108_15316# a_15765_15490# a_15964_15316# VDD.t34 sg13_lv_pmos ad=0.3808p pd=2.92u as=0.3304p ps=1.71u w=1.12u l=0.13u
X427 a_16108_289# a_3171_311.t2 a_22590_1044# VSS.t1943 sg13_lv_nmos ad=0.2516p pd=2.16u as=0.2516p ps=2.16u w=0.74u l=0.13u
X428 VDD.t370 a_3747_3892.t2 a_27991_3853# VDD.t0 sg13_lv_pmos ad=0.3808p pd=2.92u as=0.3808p ps=2.92u w=1.12u l=0.13u
X429 a_11711_14024# a_11473_14024# a_11603_14024# VSS.t1977 sg13_lv_nmos ad=0.1406p pd=1.12u as=0.2516p ps=2.16u w=0.74u l=0.2u
X430 a_1721_6021# a_1256_5979# VDD.t805 VDD.t9 sg13_lv_pmos ad=0.1596p pd=1.22u as=0.2856p ps=2.36u w=0.84u l=0.13u
X431 VDD.t1266 a_3747_6737.t7 a_12791_6698# VDD.t9 sg13_lv_pmos ad=0.3808p pd=2.92u as=0.3808p ps=2.92u w=1.12u l=0.13u
X432 VSS.t2137 a_4187_1764.t30 a_6391_1842# VSS.t2151 sg13_lv_nmos ad=0.2516p pd=2.16u as=0.1406p ps=1.12u w=0.74u l=0.6u
X433 VSS.t696 a_4187_1764.t120 a_12471_14024# VSS.t750 sg13_lv_nmos ad=0.2516p pd=2.16u as=0.1406p ps=1.12u w=0.74u l=0.6u
X434 a_16408_1044# a_15837_1842# VDD.t1160 VDD.t67 sg13_lv_pmos ad=0.2128p pd=1.5u as=0.3808p ps=2.92u w=1.12u l=0.13u
X435 VDD.t369 a_3747_3892.t9 a_6711_3853# VDD.t0 sg13_lv_pmos ad=0.3808p pd=2.92u as=0.3808p ps=2.92u w=1.12u l=0.13u
X436 a_26151_14024# a_25913_14024# a_26043_14024# VSS.t2343 sg13_lv_nmos ad=0.1406p pd=1.12u as=0.2516p ps=2.16u w=0.74u l=0.2u
X437 VDD.t119 VSS.t257 VDD.t58 VDD.t2 sg13_lv_pmos ad=0.19p pd=1.38u as=0 ps=0 w=1u l=1u
X438 a_19550_1044# a_3747_1047.t4 a_21835_1044# VSS.t688 sg13_lv_nmos ad=0.2516p pd=2.16u as=0.1406p ps=1.12u w=0.74u l=0.13u
X439 a_7673_4687# a_7477_4687# VSS.t802 VSS.t2288 sg13_lv_nmos ad=0.2516p pd=2.16u as=0.1406p ps=1.12u w=0.74u l=0.13u
X440 VDD.t125 VSS.t207 VDD.t123 VDD.t34 sg13_lv_pmos ad=0.19p pd=1.38u as=0 ps=0 w=1u l=1u
X441 a_18795_16071# a_18585_16071# VDD.t813 VDD.t34 sg13_lv_pmos ad=0.2128p pd=1.5u as=0.252p ps=1.57u w=1.12u l=0.13u
X442 VSS.t1057 a_2019_6737.t6 a_13444_6698# VSS.t1056 sg13_lv_nmos ad=0.2516p pd=2.16u as=0.2516p ps=2.16u w=0.74u l=0.13u
X443 a_11848_6734# a_11277_7532# VDD.t783 VDD.t9 sg13_lv_pmos ad=0.2128p pd=1.5u as=0.3808p ps=2.92u w=1.12u l=0.13u
X444 a_3171_311.t0 a_2873_331# VDD.t351 VDD.t67 sg13_lv_pmos ad=0.2128p pd=1.5u as=0.1918p ps=1.5u w=1.12u l=0.13u
X445 VSS.t1264 a_4187_1764.t11 a_20831_1842# VSS.t2170 sg13_lv_nmos ad=0.2516p pd=2.16u as=0.1406p ps=1.12u w=0.74u l=0.6u
X446 a_14513_16869# a_14317_16869# VSS.t612 VSS.t1211 sg13_lv_nmos ad=0.2516p pd=2.16u as=0.1406p ps=1.12u w=0.74u l=0.13u
X447 a_13880_10808# a_13592_11113# a_13818_10808# VSS.t1883 sg13_lv_nmos ad=0.1428p pd=1.52u as=37.8f ps=0.6u w=0.42u l=0.13u
X448 a_23111_8160# a_22873_7532# a_23003_7532# VDD.t345 sg13_lv_pmos ad=0.2128p pd=1.5u as=0.3808p ps=2.92u w=1.12u l=0.2u
X449 a_14235_16071# a_14025_16071# VDD.t1121 VDD.t34 sg13_lv_pmos ad=0.2128p pd=1.5u as=0.252p ps=1.57u w=1.12u l=0.13u
X450 VDD.t199 VSS.t371 VDD.t198 VDD.t0 sg13_lv_pmos ad=0.34p pd=2.68u as=0 ps=0 w=1u l=1u
X451 VDD.t1439 a_1544_3134# a_2297_3176# VDD.t0 sg13_lv_pmos ad=0.1918p pd=1.5u as=0.1596p ps=1.22u w=0.84u l=0.13u
X452 a_26151_5315# a_25913_4687# a_26043_4687# VDD.t347 sg13_lv_pmos ad=0.2128p pd=1.5u as=0.3808p ps=2.92u w=1.12u l=0.2u
X453 a_3747_311.t0 a_3449_331# VDD.t1204 VDD.t67 sg13_lv_pmos ad=0.2128p pd=1.5u as=0.1918p ps=1.5u w=1.12u l=0.13u
X454 VDD.t604 a_17683_7532# a_18117_7532# VDD.t345 sg13_lv_pmos ad=0.2128p pd=1.5u as=0.3808p ps=2.92u w=1.12u l=0.13u
X455 a_7390_1044# a_9751_1008# a_9675_1044# VDD.t67 sg13_lv_pmos ad=0.3808p pd=2.92u as=0.2128p ps=1.5u w=1.12u l=0.13u
X456 a_16510_16071# a_2019_16074.t5 a_16408_16071# VSS.t1045 sg13_lv_nmos ad=0.2516p pd=2.16u as=0.1406p ps=1.12u w=0.74u l=0.13u
X457 a_25528_16071# a_24957_16869# VDD.t870 VDD.t34 sg13_lv_pmos ad=0.2128p pd=1.5u as=0.3808p ps=2.92u w=1.12u l=0.13u
X458 a_10713_7532# a_10517_7532# VDD.t1169 VDD.t345 sg13_lv_pmos ad=0.3808p pd=2.92u as=0.2128p ps=1.5u w=1.12u l=0.13u
X459 VSS.t1089 a_19637_4687# a_20105_3889# VSS.t1088 sg13_lv_nmos ad=0.1665p pd=1.19u as=0.2516p ps=2.16u w=0.74u l=0.13u
X460 a_13470_13226# a_2019_13229.t6 a_13368_13226# VSS.t1757 sg13_lv_nmos ad=0.2516p pd=2.16u as=0.1406p ps=1.12u w=0.74u l=0.13u
X461 VSS.t711 a_22677_1842# a_23145_1044# VSS.t736 sg13_lv_nmos ad=0.1665p pd=1.19u as=0.2516p ps=2.16u w=0.74u l=0.13u
X462 VSS.t141 a_4187_1764.t55 a_11711_4687# VSS.t1532 sg13_lv_nmos ad=0.2516p pd=2.16u as=0.1406p ps=1.12u w=0.74u l=0.6u
X463 a_13753_4687# a_13557_4687# VDD.t639 VDD.t347 sg13_lv_pmos ad=0.3808p pd=2.92u as=0.2128p ps=1.5u w=1.12u l=0.13u
X464 VDD.t868 a_19963_16869# a_20397_16869# VDD.t368 sg13_lv_pmos ad=0.2128p pd=1.5u as=0.3808p ps=2.92u w=1.12u l=0.13u
X465 a_4871_5315# a_4633_4687# a_4763_4687# VDD.t347 sg13_lv_pmos ad=0.2128p pd=1.5u as=0.3808p ps=2.92u w=1.12u l=0.2u
X466 a_26673_7532# a_26477_7532# VSS.t1098 VSS.t1797 sg13_lv_nmos ad=0.2516p pd=2.16u as=0.1406p ps=1.12u w=0.74u l=0.13u
X467 a_10191_1842# a_9953_1842# a_10083_1842# VSS.t1991 sg13_lv_nmos ad=0.1406p pd=1.12u as=0.2516p ps=2.16u w=0.74u l=0.2u
X468 VDD.t1338 a_1721_13577# a_2019_13229.t0 VDD.t2 sg13_lv_pmos ad=0.4256p pd=3u as=0.2128p ps=1.5u w=1.12u l=0.13u
X469 a_16108_12471# a_2019_12493.t2 a_16510_13226# VSS.t758 sg13_lv_nmos ad=0.2516p pd=2.16u as=0.2516p ps=2.16u w=0.74u l=0.13u
X470 a_14751_2470# a_14513_1842# a_14643_1842# VDD.t379 sg13_lv_pmos ad=0.2128p pd=1.5u as=0.3808p ps=2.92u w=1.12u l=0.2u
X471 VSS.t276 VDD.t1678 VSS.t276 VSS.t277 sg13_lv_nmos ad=79.8f pd=0.8u as=0 ps=0 w=0.42u l=1u
X472 a_5731_289# a_8745_519# a_7390_1044# VDD.t67 sg13_lv_pmos ad=0.3808p pd=2.92u as=0.3808p ps=2.92u w=1.12u l=0.13u
X473 VSS.t1092 a_21483_4687# a_21917_4687# VSS.t2173 sg13_lv_nmos ad=0.1406p pd=1.12u as=0.2516p ps=2.16u w=0.74u l=0.13u
X474 VDD.t1525 a_7803_7532# a_8237_7532# VDD.t345 sg13_lv_pmos ad=0.2128p pd=1.5u as=0.3808p ps=2.92u w=1.12u l=0.13u
X475 VDD.t11 VSS.t317 VDD.t10 VDD.t9 sg13_lv_pmos ad=0.34p pd=2.68u as=0 ps=0 w=1u l=1u
X476 VDD.t498 VDD.t496 VDD.t494 VDD.t379 sg13_lv_pmos ad=0.2128p pd=1.5u as=0 ps=0 w=1.12u l=0.13u
X477 VSS.t303 VDD.t1670 VSS.t303 VSS.t305 sg13_lv_nmos ad=0.1428p pd=1.52u as=0 ps=0 w=0.42u l=1u
X478 a_4248_6734# a_4157_7003# VSS.t709 VSS.t708 sg13_lv_nmos ad=0.1406p pd=1.12u as=0.2516p ps=2.16u w=0.74u l=0.13u
X479 VSS.t499 a_1721_4240# a_2019_3892.t1 VSS.t500 sg13_lv_nmos ad=0.2812p pd=2.24u as=0.1406p ps=1.12u w=0.74u l=0.13u
X480 VDD.t922 a_8563_14024# a_8997_14024# VDD.t378 sg13_lv_pmos ad=0.2128p pd=1.5u as=0.3808p ps=2.92u w=1.12u l=0.13u
X481 a_4111_2470# CHAN3_DELAY_IN a_4003_1842# VDD.t379 sg13_lv_pmos ad=0.2128p pd=1.5u as=0.3808p ps=2.92u w=1.12u l=0.2u
X482 VDD.t570 a_24523_4687# a_24957_4687# VDD.t347 sg13_lv_pmos ad=0.2128p pd=1.5u as=0.3808p ps=2.92u w=1.12u l=0.13u
X483 a_2019_12493.t1 a_1721_12513# VSS.t771 VSS.t1198 sg13_lv_nmos ad=0.1406p pd=1.12u as=0.1331p ps=1.12u w=0.74u l=0.13u
X484 VSS.t629 a_4187_1764.t94 a_6391_7532# VSS.t1746 sg13_lv_nmos ad=0.2516p pd=2.16u as=0.1406p ps=1.12u w=0.74u l=0.6u
X485 a_16510_3889# a_2595_3892.t5 a_17275_3889# VSS.t1418 sg13_lv_nmos ad=0.2516p pd=2.16u as=0.1406p ps=1.12u w=0.74u l=0.13u
X486 a_22590_16071# a_22564_16035# a_22488_16071# VDD.t34 sg13_lv_pmos ad=0.3808p pd=2.92u as=0.2128p ps=1.5u w=1.12u l=0.13u
X487 VSS.t1806 a_2297_16422# a_2595_16074.t1 VSS.t1807 sg13_lv_nmos ad=0.2812p pd=2.24u as=0.1406p ps=1.12u w=0.74u l=0.13u
X488 a_3171_12493.t0 a_2873_12513# VDD.t740 VDD.t2 sg13_lv_pmos ad=0.2128p pd=1.5u as=0.1918p ps=1.5u w=1.12u l=0.13u
X489 VSS.t357 VDD.t1649 VSS.t357 VSS.t360 sg13_lv_nmos ad=79.8f pd=0.8u as=0 ps=0 w=0.42u l=1u
X490 a_16408_16071# a_15837_16869# VDD.t918 VDD.t34 sg13_lv_pmos ad=0.2128p pd=1.5u as=0.3808p ps=2.92u w=1.12u l=0.13u
X491 a_15511_16869# a_15273_16869# a_15403_16869# VSS.t1864 sg13_lv_nmos ad=0.1406p pd=1.12u as=0.2516p ps=2.16u w=0.74u l=0.2u
X492 a_19550_6734# a_3747_6737.t4 a_21835_6734# VSS.t1816 sg13_lv_nmos ad=0.2516p pd=2.16u as=0.1406p ps=1.12u w=0.74u l=0.13u
X493 a_7673_1842# a_7477_1842# VSS.t1968 VSS.t1967 sg13_lv_nmos ad=0.2516p pd=2.16u as=0.1406p ps=1.12u w=0.74u l=0.13u
X494 VDD.t539 a_19637_7532# a_20105_6734# VDD.t9 sg13_lv_pmos ad=0.252p pd=1.57u as=0.3808p ps=2.92u w=1.12u l=0.13u
X495 VDD.t574 a_3171_1047.t5 a_18004_1008# VDD.t67 sg13_lv_pmos ad=0.3808p pd=2.92u as=0.3808p ps=2.92u w=1.12u l=0.13u
X496 VSS.t52 a_3747_3892.t2 a_27991_3853# VSS.t51 sg13_lv_nmos ad=0.2516p pd=2.16u as=0.2516p ps=2.16u w=0.74u l=0.13u
X497 VSS.t1232 CHAN1_MUX_SEL1 a_3543_13577# VSS.t2303 sg13_lv_nmos ad=0.1331p pd=1.12u as=0.1216p ps=1.02u w=0.64u l=0.13u
X498 VSS.t649 a_4187_1764.t147 a_16271_16869# VSS.t2365 sg13_lv_nmos ad=0.2516p pd=2.16u as=0.1406p ps=1.12u w=0.74u l=0.6u
X499 a_26673_14024# a_26477_14024# VSS.t1365 VSS.t1364 sg13_lv_nmos ad=0.2516p pd=2.16u as=0.1406p ps=1.12u w=0.74u l=0.13u
X500 VDD.t1223 a_2019_13229.t7 a_10404_13190# VDD.t2 sg13_lv_pmos ad=0.3808p pd=2.92u as=0.3808p ps=2.92u w=1.12u l=0.13u
X501 VDD.t645 a_13123_1842# a_13557_1842# VDD.t379 sg13_lv_pmos ad=0.2128p pd=1.5u as=0.3808p ps=2.92u w=1.12u l=0.13u
X502 VSS.t103 a_4187_1764.t75 a_20831_7532# VSS.t102 sg13_lv_nmos ad=0.2516p pd=2.16u as=0.1406p ps=1.12u w=0.74u l=0.6u
X503 VDD.t1453 a_16851_15336# CHAN0_MUX_OUT VDD.t34 sg13_lv_pmos ad=0.7336p pd=3.55u as=0.2128p ps=1.5u w=1.12u l=0.13u
X504 VDD.t1157 a_3747_311.t2 a_26985_519# VDD.t67 sg13_lv_pmos ad=0.3808p pd=2.92u as=0.3808p ps=2.92u w=1.12u l=0.13u
X505 VDD.t1088 a_4187_2434# a_27671_5315# VDD.t347 sg13_lv_pmos ad=0.3808p pd=2.92u as=0.2128p ps=1.5u w=1.12u l=0.6u
X506 VSS.t250 VDD.t1684 VSS.t250 VSS.t252 sg13_lv_nmos ad=79.8f pd=0.8u as=0 ps=0 w=0.42u l=1u
X507 a_7390_3889# a_7364_3853# a_7288_3889# VDD.t0 sg13_lv_pmos ad=0.3808p pd=2.92u as=0.2128p ps=1.5u w=1.12u l=0.13u
X508 a_16510_16071# a_17351_16035# a_17275_16071# VDD.t34 sg13_lv_pmos ad=0.3808p pd=2.92u as=0.2128p ps=1.5u w=1.12u l=0.13u
X509 a_10430_1044# a_3747_1047.t7 a_12715_1044# VSS.t685 sg13_lv_nmos ad=0.2516p pd=2.16u as=0.1406p ps=1.12u w=0.74u l=0.13u
X510 VSS.t49 a_3747_3892.t9 a_6711_3853# VSS.t48 sg13_lv_nmos ad=0.2516p pd=2.16u as=0.2516p ps=2.16u w=0.74u l=0.13u
X511 a_25913_1842# a_25717_1842# VDD.t877 VDD.t379 sg13_lv_pmos ad=0.3808p pd=2.92u as=0.2128p ps=1.5u w=1.12u l=0.13u
X512 VSS.t262 VDD.t1681 VSS.t262 VSS.t263 sg13_lv_nmos ad=0.1428p pd=1.52u as=0 ps=0 w=0.42u l=1u
X513 VSS.t1547 VSS.t1548 VSS.t1547 VSS.t1549 sg13_lv_nmos ad=0.1406p pd=1.12u as=0 ps=0 w=0.74u l=0.2u
X514 a_24875_1044# a_24665_1044# VSS.t1377 VSS.t2174 sg13_lv_nmos ad=0.1406p pd=1.12u as=0.1665p ps=1.19u w=0.74u l=0.13u
X515 a_14235_1044# a_14025_1044# VDD.t365 VDD.t67 sg13_lv_pmos ad=0.2128p pd=1.5u as=0.252p ps=1.57u w=1.12u l=0.13u
X516 a_25391_4687# a_25153_4687# a_25283_4687# VSS.t1841 sg13_lv_nmos ad=0.1406p pd=1.12u as=0.2516p ps=2.16u w=0.74u l=0.2u
X517 VSS.t1239 a_22677_7532# a_23145_6734# VSS.t2180 sg13_lv_nmos ad=0.1665p pd=1.19u as=0.2516p ps=2.16u w=0.74u l=0.13u
X518 VDD.t822 a_19963_14024# a_20397_14024# VDD.t378 sg13_lv_pmos ad=0.2128p pd=1.5u as=0.3808p ps=2.92u w=1.12u l=0.13u
X519 VSS.t1689 a_4187_1764.t98 VSS.t1687 VSS.t1672 sg13_lv_nmos ad=1.33p pd=7.38u as=0 ps=0 w=7u l=7u
X520 VSS.t837 a_4187_1764.t23 a_11711_1842# VSS.t2372 sg13_lv_nmos ad=0.2516p pd=2.16u as=0.1406p ps=1.12u w=0.74u l=0.6u
X521 a_10191_7532# a_9953_7532# a_10083_7532# VSS.t847 sg13_lv_nmos ad=0.1406p pd=1.12u as=0.2516p ps=2.16u w=0.74u l=0.2u
X522 VDD.t348 a_1256_6734# a_2873_7085# VDD.t9 sg13_lv_pmos ad=0.1918p pd=1.5u as=0.1596p ps=1.22u w=0.84u l=0.13u
X523 VSS.t647 a_2595_1047.t3 a_23431_1008# VSS.t1729 sg13_lv_nmos ad=0.2516p pd=2.16u as=0.2516p ps=2.16u w=0.74u l=0.13u
X524 VDD.t595 a_3747_1047.t7 a_12791_1008# VDD.t67 sg13_lv_pmos ad=0.3808p pd=2.92u as=0.3808p ps=2.92u w=1.12u l=0.13u
X525 VDD.t829 a_12849_11557# a_13566_11018# VDD.t358 sg13_lv_pmos ad=0.1563p pd=1.22u as=0.147p ps=1.54u w=0.42u l=0.13u
X526 a_4350_13226# a_5191_13190# a_5115_13226# VDD.t2 sg13_lv_pmos ad=0.3808p pd=2.92u as=0.2128p ps=1.5u w=1.12u l=0.13u
X527 a_14751_8160# a_14513_7532# a_14643_7532# VDD.t345 sg13_lv_pmos ad=0.2128p pd=1.5u as=0.3808p ps=2.92u w=1.12u l=0.2u
X528 a_12993_4687# a_12797_4687# VSS.t1026 VSS.t1025 sg13_lv_nmos ad=0.2516p pd=2.16u as=0.1406p ps=1.12u w=0.74u l=0.13u
X529 VSS.t1750 a_18443_16869# a_18877_16869# VSS.t1777 sg13_lv_nmos ad=0.1406p pd=1.12u as=0.2516p ps=2.16u w=0.74u l=0.13u
X530 a_2595_3892.t0 a_2297_4240# VDD.t815 VDD.t0 sg13_lv_pmos ad=0.2128p pd=1.5u as=0.1918p ps=1.5u w=1.12u l=0.13u
X531 VDD.t335 VSS.t303 VDD.t334 VDD.t9 sg13_lv_pmos ad=0.34p pd=2.68u as=0 ps=0 w=1u l=1u
X532 a_16510_6734# a_17351_6698# a_17275_6734# VDD.t9 sg13_lv_pmos ad=0.3808p pd=2.92u as=0.2128p ps=1.5u w=1.12u l=0.13u
X533 VSS.t517 a_21483_1842# a_21917_1842# VSS.t699 sg13_lv_nmos ad=0.1406p pd=1.12u as=0.2516p ps=2.16u w=0.74u l=0.13u
X534 a_20315_16071# a_20105_16071# VSS.t1774 VSS.t2063 sg13_lv_nmos ad=0.1406p pd=1.12u as=0.1665p ps=1.19u w=0.74u l=0.13u
X535 VDD.t1607 a_3171_15338.t3 a_11785_15546# VDD.t34 sg13_lv_pmos ad=0.3808p pd=2.92u as=0.3808p ps=2.92u w=1.12u l=0.13u
X536 VDD.t476 VDD.t474 VDD.t472 VDD.t345 sg13_lv_pmos ad=0.2128p pd=1.5u as=0 ps=0 w=1.12u l=0.13u
X537 VSS.t41 a_13557_1842# a_14025_1044# VSS.t2245 sg13_lv_nmos ad=0.1665p pd=1.19u as=0.2516p ps=2.16u w=0.74u l=0.13u
X538 VDD.t249 VSS.t364 VDD.t248 VDD.t0 sg13_lv_pmos ad=0.34p pd=2.68u as=0 ps=0 w=1u l=1u
X539 a_2595_15338.t0 a_2297_15358# VDD.t1422 VDD.t34 sg13_lv_pmos ad=0.2128p pd=1.5u as=0.1918p ps=1.5u w=1.12u l=0.13u
X540 a_2595_15338.t1 a_2297_15358# VSS.t122 VSS.t2017 sg13_lv_nmos ad=0.1406p pd=1.12u as=0.1331p ps=1.12u w=0.74u l=0.13u
X541 a_17928_13226# a_17357_14024# VSS.t788 VSS.t787 sg13_lv_nmos ad=0.1406p pd=1.12u as=0.2516p ps=2.16u w=0.74u l=0.13u
X542 a_4111_8160# REF_CLK a_4003_7532# VDD.t345 sg13_lv_pmos ad=0.2128p pd=1.5u as=0.3808p ps=2.92u w=1.12u l=0.2u
X543 a_11848_1044# a_11277_1842# VDD.t1364 VDD.t67 sg13_lv_pmos ad=0.2128p pd=1.5u as=0.3808p ps=2.92u w=1.12u l=0.13u
X544 VDD.t912 a_5523_16869# a_5957_16869# VDD.t368 sg13_lv_pmos ad=0.2128p pd=1.5u as=0.3808p ps=2.92u w=1.12u l=0.13u
X545 VSS.t723 a_4187_1764.t52 a_13991_4687# VSS.t1734 sg13_lv_nmos ad=0.2516p pd=2.16u as=0.1406p ps=1.12u w=0.74u l=0.6u
X546 a_16033_4687# a_15837_4687# VDD.t413 VDD.t347 sg13_lv_pmos ad=0.3808p pd=2.92u as=0.2128p ps=1.5u w=1.12u l=0.13u
X547 VDD.t1265 a_3747_6737.t2 a_27991_6698# VDD.t9 sg13_lv_pmos ad=0.3808p pd=2.92u as=0.3808p ps=2.92u w=1.12u l=0.13u
X548 a_7151_5315# a_6913_4687# a_7043_4687# VDD.t347 sg13_lv_pmos ad=0.2128p pd=1.5u as=0.3808p ps=2.92u w=1.12u l=0.2u
X549 a_1721_4240# a_1256_3889# VDD.t375 VDD.t0 sg13_lv_pmos ad=0.1596p pd=1.22u as=0.2856p ps=2.36u w=0.84u l=0.13u
X550 VDD.t110 VSS.t462 VDD.t69 VDD.t67 sg13_lv_pmos ad=0.19p pd=1.38u as=0 ps=0 w=1u l=1u
X551 a_27671_14024# a_27433_14024# a_27563_14024# VSS.t2252 sg13_lv_nmos ad=0.1406p pd=1.12u as=0.2516p ps=2.16u w=0.74u l=0.2u
X552 VDD.t1264 a_3747_6737.t9 a_6711_6698# VDD.t9 sg13_lv_pmos ad=0.3808p pd=2.92u as=0.3808p ps=2.92u w=1.12u l=0.13u
X553 VSS.t989 a_23763_4687# a_24197_4687# VSS.t1523 sg13_lv_nmos ad=0.1406p pd=1.12u as=0.2516p ps=2.16u w=0.74u l=0.13u
X554 a_7673_7532# a_7477_7532# VSS.t1292 VSS.t1291 sg13_lv_nmos ad=0.2516p pd=2.16u as=0.1406p ps=1.12u w=0.74u l=0.13u
X555 a_25630_13226# a_25604_13190# a_25528_13226# VDD.t2 sg13_lv_pmos ad=0.3808p pd=2.92u as=0.2128p ps=1.5u w=1.12u l=0.13u
X556 VSS.t350 VDD.t1653 VSS.t350 VSS.t351 sg13_lv_nmos ad=79.8f pd=0.8u as=0 ps=0 w=0.42u l=1u
X557 a_19448_13226# a_18877_14024# VDD.t643 VDD.t2 sg13_lv_pmos ad=0.2128p pd=1.5u as=0.3808p ps=2.92u w=1.12u l=0.13u
X558 VDD.t304 VSS.t299 VDD.t303 VDD.t2 sg13_lv_pmos ad=0.34p pd=2.68u as=0 ps=0 w=1u l=1u
X559 a_15755_16071# a_15545_16071# VDD.t1125 VDD.t34 sg13_lv_pmos ad=0.2128p pd=1.5u as=0.252p ps=1.57u w=1.12u l=0.13u
X560 VDD.t392 a_13123_7532# a_13557_7532# VDD.t345 sg13_lv_pmos ad=0.2128p pd=1.5u as=0.3808p ps=2.92u w=1.12u l=0.13u
X561 a_11473_16869# a_11277_16869# VSS.t1455 VSS.t1454 sg13_lv_nmos ad=0.2516p pd=2.16u as=0.1406p ps=1.12u w=0.74u l=0.13u
X562 a_25913_7532# a_25717_7532# VDD.t907 VDD.t345 sg13_lv_pmos ad=0.3808p pd=2.92u as=0.2128p ps=1.5u w=1.12u l=0.13u
X563 a_10430_6734# a_3747_6737.t7 a_12715_6734# VSS.t1813 sg13_lv_nmos ad=0.2516p pd=2.16u as=0.1406p ps=1.12u w=0.74u l=0.13u
X564 a_13470_13226# a_3171_13229.t6 a_14888_13226# VSS.t1714 sg13_lv_nmos ad=0.2516p pd=2.16u as=0.1406p ps=1.12u w=0.74u l=0.13u
X565 VSS.t1500 a_4187_1764.t35 a_26911_4687# VSS.t1499 sg13_lv_nmos ad=0.2516p pd=2.16u as=0.1406p ps=1.12u w=0.74u l=0.6u
X566 VDD.t1486 a_21483_16869# a_21917_16869# VDD.t368 sg13_lv_pmos ad=0.2128p pd=1.5u as=0.3808p ps=2.92u w=1.12u l=0.13u
X567 VDD.t160 VSS.t240 VDD.t158 VDD.t2 sg13_lv_pmos ad=0.19p pd=1.38u as=0 ps=0 w=1u l=1u
X568 a_24875_6734# a_24665_6734# VSS.t109 VSS.t2286 sg13_lv_nmos ad=0.1406p pd=1.12u as=0.1665p ps=1.19u w=0.74u l=0.13u
X569 a_25391_1842# a_25153_1842# a_25283_1842# VSS.t2009 sg13_lv_nmos ad=0.1406p pd=1.12u as=0.2516p ps=2.16u w=0.74u l=0.2u
X570 a_13470_16071# a_2019_16074.t6 a_13368_16071# VSS.t880 sg13_lv_nmos ad=0.2516p pd=2.16u as=0.1406p ps=1.12u w=0.74u l=0.13u
X571 VSS.t1679 a_4187_1764.t98 VSS.t1681 VSS.t1680 sg13_lv_nmos ad=1.33p pd=7.38u as=0 ps=0 w=7u l=7u
X572 a_6326_10280# a_5974_11413# a_6126_9506# VSS.t806 sg13_lv_nmos ad=0.38p pd=2.38u as=0.68p ps=4.68u w=2u l=1u
X573 VSS.t858 a_4187_1764.t87 a_11711_7532# VSS.t857 sg13_lv_nmos ad=0.2516p pd=2.16u as=0.1406p ps=1.12u w=0.74u l=0.6u
X574 VDD.t836 a_5523_4687# a_5957_4687# VDD.t347 sg13_lv_pmos ad=0.2128p pd=1.5u as=0.3808p ps=2.92u w=1.12u l=0.13u
X575 a_10430_13226# a_2019_13229.t7 a_10328_13226# VSS.t1711 sg13_lv_nmos ad=0.2516p pd=2.16u as=0.1406p ps=1.12u w=0.74u l=0.13u
X576 VSS.t31 a_12849_11557# a_13400_11995# VSS.t1183 sg13_lv_nmos ad=0.1626p pd=1.415u as=60.89999f ps=0.71u w=0.42u l=0.13u
X577 VSS.t1323 a_2595_6737.t3 a_23431_6698# VSS.t1322 sg13_lv_nmos ad=0.2516p pd=2.16u as=0.2516p ps=2.16u w=0.74u l=0.13u
X578 VDD.t1152 a_2019_3892.t4 a_19524_3853# VDD.t0 sg13_lv_pmos ad=0.3808p pd=2.92u as=0.3808p ps=2.92u w=1.12u l=0.13u
X579 a_12993_1842# a_12797_1842# VSS.t1014 VSS.t1171 sg13_lv_nmos ad=0.2516p pd=2.16u as=0.1406p ps=1.12u w=0.74u l=0.13u
X580 VDD.t235 VSS.t350 VDD.t234 VDD.t0 sg13_lv_pmos ad=0.34p pd=2.68u as=0 ps=0 w=1u l=1u
X581 a_7390_3889# a_2019_3892.t8 a_7288_3889# VSS.t1947 sg13_lv_nmos ad=0.2516p pd=2.16u as=0.1406p ps=1.12u w=0.74u l=0.13u
X582 VSS.t570 a_21483_7532# a_21917_7532# VSS.t569 sg13_lv_nmos ad=0.1406p pd=1.12u as=0.2516p ps=2.16u w=0.74u l=0.13u
X583 a_5731_12471# a_3747_12493.t3 a_13470_13226# VSS.t940 sg13_lv_nmos ad=0.2516p pd=2.16u as=0.2516p ps=2.16u w=0.74u l=0.13u
X584 VSS.t97 a_13557_7532# a_14025_6734# VSS.t96 sg13_lv_nmos ad=0.1665p pd=1.19u as=0.2516p ps=2.16u w=0.74u l=0.13u
X585 VDD.t112 VSS.t462 VDD.t111 VDD.t67 sg13_lv_pmos ad=0.34p pd=2.68u as=0 ps=0 w=1u l=1u
X586 a_3543_3176# CHAN2_MUX_SEL2 a_3449_3176# VSS.t2153 sg13_lv_nmos ad=0.1216p pd=1.02u as=0.2176p ps=1.96u w=0.64u l=0.13u
X587 a_16108_5979# a_3171_6001.t2 a_22590_6734# VSS.t720 sg13_lv_nmos ad=0.2516p pd=2.16u as=0.2516p ps=2.16u w=0.74u l=0.13u
X588 a_2873_15358# CHAN0_MUX_SEL3 VDD.t355 VDD.t34 sg13_lv_pmos ad=0.1596p pd=1.22u as=0.2856p ps=2.36u w=0.84u l=0.13u
X589 a_16510_13226# a_16484_13190# a_16408_13226# VDD.t2 sg13_lv_pmos ad=0.3808p pd=2.92u as=0.2128p ps=1.5u w=1.12u l=0.13u
X590 CHAN3_DELAY_OUT_LAST a_27997_1842# VDD.t569 VDD.t379 sg13_lv_pmos ad=0.3808p pd=2.92u as=0.2128p ps=1.5u w=1.12u l=0.13u
X591 VSS.t1431 a_4187_1764.t111 a_19311_14024# VSS.t1901 sg13_lv_nmos ad=0.2516p pd=2.16u as=0.1406p ps=1.12u w=0.74u l=0.6u
X592 VDD.t620 a_19637_1842# a_20105_1044# VDD.t67 sg13_lv_pmos ad=0.252p pd=1.57u as=0.3808p ps=2.92u w=1.12u l=0.13u
X593 VSS.t122 VDD.t1694 VSS.t122 VSS.t215 sg13_lv_nmos ad=0.1428p pd=1.52u as=0 ps=0 w=0.42u l=1u
X594 a_19550_13226# a_2595_13229.t4 a_20315_13226# VSS.t1496 sg13_lv_nmos ad=0.2516p pd=2.16u as=0.1406p ps=1.12u w=0.74u l=0.13u
X595 VSS.t976 a_5957_14024# a_6425_13226# VSS.t2129 sg13_lv_nmos ad=0.1665p pd=1.19u as=0.2516p ps=2.16u w=0.74u l=0.13u
X596 a_22590_1044# a_3171_1047.t3 a_24008_1044# VSS.t645 sg13_lv_nmos ad=0.2516p pd=2.16u as=0.1406p ps=1.12u w=0.74u l=0.13u
X597 a_15755_3889# a_15545_3889# VDD.t531 VDD.t0 sg13_lv_pmos ad=0.2128p pd=1.5u as=0.252p ps=1.57u w=1.12u l=0.13u
X598 VSS.t447 VDD.t1622 VSS.t447 VSS.t446 sg13_lv_nmos ad=0.1428p pd=1.52u as=0 ps=0 w=0.42u l=1u
X599 VDD.t1079 a_4187_2434# a_8671_5315# VDD.t347 sg13_lv_pmos ad=0.3808p pd=2.92u as=0.2128p ps=1.5u w=1.12u l=0.6u
X600 VDD.t1467 a_5523_14024# a_5957_14024# VDD.t378 sg13_lv_pmos ad=0.2128p pd=1.5u as=0.3808p ps=2.92u w=1.12u l=0.13u
X601 VDD.t634 a_2297_12513# a_2595_12493.t0 VDD.t2 sg13_lv_pmos ad=0.4256p pd=3u as=0.2128p ps=1.5u w=1.12u l=0.13u
X602 a_12943_11557# a_12656_11554# a_12849_11557# VDD.t358 sg13_lv_pmos ad=0.2128p pd=1.5u as=0.3808p ps=2.92u w=1.12u l=0.13u
X603 VSS.t1029 a_4187_1764.t20 a_13991_1842# VSS.t1028 sg13_lv_nmos ad=0.2516p pd=2.16u as=0.1406p ps=1.12u w=0.74u l=0.6u
X604 VSS.t32 a_13121_11521# a_6854_11676# VDD.t360 sg13_lv_pmos ad=0.232p pd=2.08u as=0.136p ps=1.14u w=0.4u l=0.2u
X605 VDD.t1262 a_1544_16071# a_2297_16422# VDD.t34 sg13_lv_pmos ad=0.1918p pd=1.5u as=0.1596p ps=1.22u w=0.84u l=0.13u
X606 a_6913_1842# a_6717_1842# VDD.t1471 VDD.t379 sg13_lv_pmos ad=0.3808p pd=2.92u as=0.2128p ps=1.5u w=1.12u l=0.13u
X607 VDD.t1239 a_2595_3892.t6 a_14311_3853# VDD.t0 sg13_lv_pmos ad=0.3808p pd=2.92u as=0.3808p ps=2.92u w=1.12u l=0.13u
X608 VDD.t1112 a_4187_2434# a_18551_2470# VDD.t379 sg13_lv_pmos ad=0.3808p pd=2.92u as=0.2128p ps=1.5u w=1.12u l=0.6u
X609 VSS.t391 VDD.t1637 VSS.t388 VSS.t390 sg13_lv_nmos ad=79.8f pd=0.8u as=0 ps=0 w=0.42u l=1u
X610 a_15273_4687# a_15077_4687# VSS.t536 VSS.t535 sg13_lv_nmos ad=0.2516p pd=2.16u as=0.1406p ps=1.12u w=0.74u l=0.13u
X611 a_17031_16869# a_16793_16869# a_16923_16869# VSS.t1158 sg13_lv_nmos ad=0.1406p pd=1.12u as=0.2516p ps=2.16u w=0.74u l=0.2u
X612 a_6391_4687# a_6153_4687# a_6283_4687# VSS.t1248 sg13_lv_nmos ad=0.1406p pd=1.12u as=0.2516p ps=2.16u w=0.74u l=0.2u
X613 a_3171_15338.t0 a_2873_15358# VDD.t1434 VDD.t34 sg13_lv_pmos ad=0.2128p pd=1.5u as=0.1918p ps=1.5u w=1.12u l=0.13u
X614 a_3171_15338.t1 a_2873_15358# VSS.t122 VSS.t75 sg13_lv_nmos ad=0.1406p pd=1.12u as=0.1331p ps=1.12u w=0.74u l=0.13u
X615 VSS.t1375 a_23763_1842# a_24197_1842# VSS.t1653 sg13_lv_nmos ad=0.1406p pd=1.12u as=0.2516p ps=2.16u w=0.74u l=0.13u
X616 a_5115_3889# a_4905_3889# VDD.t377 VDD.t0 sg13_lv_pmos ad=0.2128p pd=1.5u as=0.252p ps=1.57u w=1.12u l=0.13u
X617 VDD.t454 VDD.t452 VDD.t453 VDD.t358 sg13_lv_pmos ad=0.38p pd=2.38u as=0 ps=0 w=2u l=1u
X618 VSS.t420 VDD.t1629 VSS.t419 VSS.t418 sg13_lv_nmos ad=0.1428p pd=1.52u as=0 ps=0 w=0.42u l=1u
X619 a_13368_16071# a_12797_16869# VDD.t1509 VDD.t34 sg13_lv_pmos ad=0.2128p pd=1.5u as=0.3808p ps=2.92u w=1.12u l=0.13u
X620 a_12471_16869# a_12233_16869# a_12363_16869# VSS.t46 sg13_lv_nmos ad=0.1406p pd=1.12u as=0.2516p ps=2.16u w=0.74u l=0.2u
X621 VSS.t958 a_4187_1764.t145 a_17791_16869# VSS.t1035 sg13_lv_nmos ad=0.2516p pd=2.16u as=0.1406p ps=1.12u w=0.74u l=0.6u
X622 VDD.t704 a_1256_1044# a_2873_1395# VDD.t67 sg13_lv_pmos ad=0.1918p pd=1.5u as=0.1596p ps=1.22u w=0.84u l=0.13u
X623 VDD.t696 DLL_RESETN a_10206_11525# VDD.t358 sg13_lv_pmos ad=0.1563p pd=1.22u as=0.147p ps=1.54u w=0.42u l=0.13u
X624 VSS.t1540 CHAN0_MUX_SEL1 a_3543_16422# VSS.t2177 sg13_lv_nmos ad=0.1331p pd=1.12u as=0.1216p ps=1.02u w=0.64u l=0.13u
X625 VDD.t352 a_2873_331# a_3171_311.t0 VDD.t67 sg13_lv_pmos ad=0.4256p pd=3u as=0.2128p ps=1.5u w=1.12u l=0.13u
X626 VSS.t951 a_15964_5979# a_16851_5999# VSS.t2316 sg13_lv_nmos ad=0.1371p pd=1.12u as=0.2176p ps=1.96u w=0.64u l=0.13u
X627 a_4111_17497# CHAN0_DELAY_IN a_4003_16869# VDD.t368 sg13_lv_pmos ad=0.2128p pd=1.5u as=0.3808p ps=2.92u w=1.12u l=0.2u
X628 VSS.t1406 a_4187_1764.t151 a_13231_16869# VSS.t1633 sg13_lv_nmos ad=0.2516p pd=2.16u as=0.1406p ps=1.12u w=0.74u l=0.6u
X629 a_23633_14024# a_23437_14024# VSS.t1358 VSS.t1357 sg13_lv_nmos ad=0.2516p pd=2.16u as=0.1406p ps=1.12u w=0.74u l=0.13u
X630 VSS.t280 VDD.t1677 VSS.t279 VSS.t278 sg13_lv_nmos ad=0.1428p pd=1.52u as=0 ps=0 w=0.42u l=1u
X631 a_9712_9602# a_6854_11144# a_9444_9602# VSS.t1206 sg13_lv_nmos ad=0.38p pd=2.38u as=0.68p ps=4.68u w=2u l=1u
X632 a_3171_311.t1 a_2873_331# VSS.t18 VSS.t17 sg13_lv_nmos ad=0.1406p pd=1.12u as=0.1331p ps=1.12u w=0.74u l=0.13u
X633 a_16510_16071# a_18871_16035# a_18795_16071# VDD.t34 sg13_lv_pmos ad=0.3808p pd=2.92u as=0.2128p ps=1.5u w=1.12u l=0.13u
X634 a_25630_1044# a_3747_1047.t2 a_27915_1044# VSS.t682 sg13_lv_nmos ad=0.2516p pd=2.16u as=0.1406p ps=1.12u w=0.74u l=0.13u
X635 a_16510_1044# a_17351_1008# a_17275_1044# VDD.t67 sg13_lv_pmos ad=0.3808p pd=2.92u as=0.2128p ps=1.5u w=1.12u l=0.13u
X636 VSS.t790 a_16923_14024# a_17357_14024# VSS.t1343 sg13_lv_nmos ad=0.1406p pd=1.12u as=0.2516p ps=2.16u w=0.74u l=0.13u
X637 a_7390_6734# a_7364_6698# a_7288_6734# VDD.t9 sg13_lv_pmos ad=0.3808p pd=2.92u as=0.2128p ps=1.5u w=1.12u l=0.13u
X638 VDD.t1251 a_3449_331# a_3747_311.t0 VDD.t67 sg13_lv_pmos ad=0.4256p pd=3u as=0.2128p ps=1.5u w=1.12u l=0.13u
X639 a_1256_16071# CHAN0_MUX_SEL0 VDD.t635 VDD.t34 sg13_lv_pmos ad=0.3808p pd=2.92u as=0.3808p ps=2.92u w=1.12u l=0.13u
X640 VSS.t200 VDD.t1699 VSS.t200 VSS.t205 sg13_lv_nmos ad=79.8f pd=0.8u as=0 ps=0 w=0.42u l=1u
X641 VSS.t163 a_15403_4687# a_15837_4687# VSS.t996 sg13_lv_nmos ad=0.1406p pd=1.12u as=0.2516p ps=2.16u w=0.74u l=0.13u
X642 a_12471_5315# a_12233_4687# a_12363_4687# VDD.t347 sg13_lv_pmos ad=0.2128p pd=1.5u as=0.3808p ps=2.92u w=1.12u l=0.2u
X643 a_13470_16071# a_14311_16035# a_14235_16071# VDD.t34 sg13_lv_pmos ad=0.3808p pd=2.92u as=0.2128p ps=1.5u w=1.12u l=0.13u
X644 VDD.t851 a_21483_14024# a_21917_14024# VDD.t378 sg13_lv_pmos ad=0.2128p pd=1.5u as=0.3808p ps=2.92u w=1.12u l=0.13u
X645 a_3747_311.t1 a_3449_331# VSS.t176 VSS.t1786 sg13_lv_nmos ad=0.1406p pd=1.12u as=0.1331p ps=1.12u w=0.74u l=0.13u
X646 VSS.t1487 a_4187_1764.t3 a_26911_1842# VSS.t1665 sg13_lv_nmos ad=0.2516p pd=2.16u as=0.1406p ps=1.12u w=0.74u l=0.6u
X647 VSS.t1541 VSS.t1541 VSS.t1543 VSS.t1542 sg13_lv_nmos ad=0.1406p pd=1.12u as=0 ps=0 w=0.74u l=0.13u
X648 a_25391_7532# a_25153_7532# a_25283_7532# VSS.t1782 sg13_lv_nmos ad=0.1406p pd=1.12u as=0.2516p ps=2.16u w=0.74u l=0.2u
X649 VDD.t594 a_3747_1047.t2 a_27991_1008# VDD.t67 sg13_lv_pmos ad=0.3808p pd=2.92u as=0.3808p ps=2.92u w=1.12u l=0.13u
X650 VDD.t1110 a_4187_2434# a_22351_2470# VDD.t379 sg13_lv_pmos ad=0.3808p pd=2.92u as=0.2128p ps=1.5u w=1.12u l=0.6u
X651 VSS.t250 VDD.t1684 VSS.t250 VSS.t251 sg13_lv_nmos ad=0.1428p pd=1.52u as=0 ps=0 w=0.42u l=1u
X652 VDD.t108 VSS.t398 VDD.t205 VDD.t67 sg13_lv_pmos ad=0.19p pd=1.38u as=0 ps=0 w=1u l=1u
X653 VSS.t193 VDD.t1704 VSS.t193 VSS.t194 sg13_lv_nmos ad=79.8f pd=0.8u as=0 ps=0 w=0.42u l=1u
X654 VDD.t1518 a_3171_16074.t8 a_8884_16035# VDD.t34 sg13_lv_pmos ad=0.3808p pd=2.92u as=0.3808p ps=2.92u w=1.12u l=0.13u
X655 a_12993_7532# a_12797_7532# VSS.t1041 VSS.t2358 sg13_lv_nmos ad=0.2516p pd=2.16u as=0.1406p ps=1.12u w=0.74u l=0.13u
X656 VSS.t152 a_4763_4687# a_5197_4687# VSS.t151 sg13_lv_nmos ad=0.1406p pd=1.12u as=0.2516p ps=2.16u w=0.74u l=0.13u
X657 VDD.t550 a_1721_6021# a_2019_6001.t0 VDD.t9 sg13_lv_pmos ad=0.4256p pd=3u as=0.2128p ps=1.5u w=1.12u l=0.13u
X658 VSS.t527 a_15403_16869# a_15837_16869# VSS.t1328 sg13_lv_nmos ad=0.1406p pd=1.12u as=0.2516p ps=2.16u w=0.74u l=0.13u
X659 VDD.t364 a_11491_11918# a_11748_11799# VDD.t358 sg13_lv_pmos ad=1.10612p pd=6.66u as=79.8f ps=0.8u w=0.42u l=0.13u
X660 VDD.t593 a_3747_1047.t9 a_6711_1008# VDD.t67 sg13_lv_pmos ad=0.3808p pd=2.92u as=0.3808p ps=2.92u w=1.12u l=0.13u
X661 VDD.t364 a_10649_11568# a_10751_11568# VDD.t358 sg13_lv_pmos ad=1.10612p pd=6.66u as=0.3864p ps=2.93u w=1.12u l=0.13u
X662 a_2873_12513# CHAN1_MUX_SEL3 VDD.t608 VDD.t2 sg13_lv_pmos ad=0.1596p pd=1.22u as=0.2856p ps=2.36u w=0.84u l=0.13u
X663 REF_DELAY_OUT_LAST a_27997_7532# VDD.t788 VDD.t345 sg13_lv_pmos ad=0.3808p pd=2.92u as=0.2128p ps=1.5u w=1.12u l=0.13u
X664 VDD.t716 a_7043_16869# a_7477_16869# VDD.t368 sg13_lv_pmos ad=0.2128p pd=1.5u as=0.3808p ps=2.92u w=1.12u l=0.13u
X665 a_17928_16071# a_17357_16869# VSS.t745 VSS.t1647 sg13_lv_nmos ad=0.1406p pd=1.12u as=0.2516p ps=2.16u w=0.74u l=0.13u
X666 a_22590_6734# a_3171_6737.t3 a_24008_6734# VSS.t1916 sg13_lv_nmos ad=0.2516p pd=2.16u as=0.1406p ps=1.12u w=0.74u l=0.13u
X667 VSS.t167 a_2019_3892.t4 a_19524_3853# VSS.t1462 sg13_lv_nmos ad=0.2516p pd=2.16u as=0.2516p ps=2.16u w=0.74u l=0.13u
X668 VSS.t259 VDD.t1682 VSS.t262 VSS.t261 sg13_lv_nmos ad=79.8f pd=0.8u as=0 ps=0 w=0.42u l=1u
X669 a_12355_11557# a_12158_11557# VSS.t922 VSS.t1269 sg13_lv_nmos ad=0.2516p pd=2.16u as=0.1406p ps=1.12u w=0.74u l=0.13u
X670 VSS.t160 a_4187_1764.t84 a_13991_7532# VSS.t817 sg13_lv_nmos ad=0.2516p pd=2.16u as=0.1406p ps=1.12u w=0.74u l=0.6u
X671 a_14513_14024# a_14317_14024# VSS.t1224 VSS.t2362 sg13_lv_nmos ad=0.2516p pd=2.16u as=0.1406p ps=1.12u w=0.74u l=0.13u
X672 VSS.t207 VDD.t1697 VSS.t207 VSS.t210 sg13_lv_nmos ad=79.8f pd=0.8u as=0 ps=0 w=0.42u l=1u
X673 a_6913_7532# a_6717_7532# VDD.t573 VDD.t345 sg13_lv_pmos ad=0.3808p pd=2.92u as=0.2128p ps=1.5u w=1.12u l=0.13u
X674 VDD.t979 a_4187_2434# a_18551_8160# VDD.t345 sg13_lv_pmos ad=0.3808p pd=2.92u as=0.2128p ps=1.5u w=1.12u l=0.6u
X675 VSS.t1016 a_4187_1764.t60 a_7911_4687# VSS.t1899 sg13_lv_nmos ad=0.2516p pd=2.16u as=0.1406p ps=1.12u w=0.74u l=0.6u
X676 VDD.t393 a_10843_4687# a_11277_4687# VDD.t347 sg13_lv_pmos ad=0.2128p pd=1.5u as=0.3808p ps=2.92u w=1.12u l=0.13u
X677 a_9953_4687# a_9757_4687# VDD.t533 VDD.t347 sg13_lv_pmos ad=0.3808p pd=2.92u as=0.2128p ps=1.5u w=1.12u l=0.13u
X678 a_20315_13226# a_20105_13226# VDD.t1372 VDD.t2 sg13_lv_pmos ad=0.2128p pd=1.5u as=0.252p ps=1.57u w=1.12u l=0.13u
X679 a_15273_1842# a_15077_1842# VSS.t72 VSS.t1346 sg13_lv_nmos ad=0.2516p pd=2.16u as=0.1406p ps=1.12u w=0.74u l=0.13u
X680 VSS.t107 a_23763_7532# a_24197_7532# VSS.t483 sg13_lv_nmos ad=0.1406p pd=1.12u as=0.2516p ps=2.16u w=0.74u l=0.13u
X681 a_6391_1842# a_6153_1842# a_6283_1842# VSS.t1954 sg13_lv_nmos ad=0.1406p pd=1.12u as=0.2516p ps=2.16u w=0.74u l=0.2u
X682 a_19833_1842# a_19637_1842# VDD.t525 VDD.t379 sg13_lv_pmos ad=0.3808p pd=2.92u as=0.2128p ps=1.5u w=1.12u l=0.13u
X683 a_15755_3889# a_15545_3889# VSS.t534 VSS.t1167 sg13_lv_nmos ad=0.1406p pd=1.12u as=0.1665p ps=1.19u w=0.74u l=0.13u
X684 VDD.t1241 a_21157_4687# a_21625_3889# VDD.t0 sg13_lv_pmos ad=0.252p pd=1.57u as=0.3808p ps=2.92u w=1.12u l=0.13u
X685 VDD.t884 a_1256_16071# a_2873_16422# VDD.t34 sg13_lv_pmos ad=0.1918p pd=1.5u as=0.1596p ps=1.22u w=0.84u l=0.13u
X686 a_12993_16869# a_12797_16869# VSS.t1043 VSS.t2199 sg13_lv_nmos ad=0.2516p pd=2.16u as=0.1406p ps=1.12u w=0.74u l=0.13u
X687 a_16108_289# a_23945_519# a_22590_1044# VDD.t67 sg13_lv_pmos ad=0.3808p pd=2.92u as=0.3808p ps=2.92u w=1.12u l=0.13u
X688 VSS.t1182 a_2595_3892.t6 a_14311_3853# VSS.t1768 sg13_lv_nmos ad=0.2516p pd=2.16u as=0.2516p ps=2.16u w=0.74u l=0.13u
X689 a_4111_14652# CHAN1_DELAY_IN a_4003_14024# VDD.t378 sg13_lv_pmos ad=0.2128p pd=1.5u as=0.3808p ps=2.92u w=1.12u l=0.2u
X690 a_25630_6734# a_3747_6737.t2 a_27915_6734# VSS.t1810 sg13_lv_nmos ad=0.2516p pd=2.16u as=0.1406p ps=1.12u w=0.74u l=0.13u
X691 a_24631_2470# a_24393_1842# a_24523_1842# VDD.t379 sg13_lv_pmos ad=0.2128p pd=1.5u as=0.3808p ps=2.92u w=1.12u l=0.2u
X692 a_3747_13229.t1 a_3449_13577# VSS.t1232 VSS.t1231 sg13_lv_nmos ad=0.1406p pd=1.12u as=0.1331p ps=1.12u w=0.74u l=0.13u
X693 a_9193_1842# a_8997_1842# VDD.t880 VDD.t379 sg13_lv_pmos ad=0.3808p pd=2.92u as=0.2128p ps=1.5u w=1.12u l=0.13u
X694 a_5115_3889# a_4905_3889# VSS.t69 VSS.t68 sg13_lv_nmos ad=0.1406p pd=1.12u as=0.1665p ps=1.19u w=0.74u l=0.13u
X695 a_13470_16071# a_3171_16074.t6 a_14888_16071# VSS.t2208 sg13_lv_nmos ad=0.2516p pd=2.16u as=0.1406p ps=1.12u w=0.74u l=0.13u
X696 VSS.t267 VDD.t1680 VSS.t270 VSS.t269 sg13_lv_nmos ad=79.8f pd=0.8u as=0 ps=0 w=0.42u l=1u
X697 VSS.t849 a_15403_1842# a_15837_1842# VSS.t848 sg13_lv_nmos ad=0.1406p pd=1.12u as=0.2516p ps=2.16u w=0.74u l=0.13u
X698 VSS.t825 a_4187_1764.t67 a_26911_7532# VSS.t824 sg13_lv_nmos ad=0.2516p pd=2.16u as=0.1406p ps=1.12u w=0.74u l=0.6u
X699 a_8155_1044# a_7945_1044# VSS.t544 VSS.t543 sg13_lv_nmos ad=0.1406p pd=1.12u as=0.1665p ps=1.19u w=0.74u l=0.13u
X700 VSS.t350 VDD.t1651 VSS.t350 VSS.t354 sg13_lv_nmos ad=0.1428p pd=1.52u as=0 ps=0 w=0.42u l=1u
X701 a_10430_13226# a_3171_13229.t7 a_11848_13226# VSS.t2053 sg13_lv_nmos ad=0.2516p pd=2.16u as=0.1406p ps=1.12u w=0.74u l=0.13u
X702 VDD.t958 a_4187_2434# a_22351_8160# VDD.t345 sg13_lv_pmos ad=0.3808p pd=2.92u as=0.2128p ps=1.5u w=1.12u l=0.6u
X703 a_27433_16869# a_27237_16869# VSS.t1215 VSS.t1214 sg13_lv_nmos ad=0.2516p pd=2.16u as=0.1406p ps=1.12u w=0.74u l=0.13u
X704 a_10430_16071# a_2019_16074.t7 a_10328_16071# VSS.t855 sg13_lv_nmos ad=0.2516p pd=2.16u as=0.1406p ps=1.12u w=0.74u l=0.13u
X705 a_11711_4687# a_11473_4687# a_11603_4687# VSS.t827 sg13_lv_nmos ad=0.1406p pd=1.12u as=0.2516p ps=2.16u w=0.74u l=0.2u
X706 VDD.t767 a_2019_6737.t4 a_19524_6698# VDD.t9 sg13_lv_pmos ad=0.3808p pd=2.92u as=0.3808p ps=2.92u w=1.12u l=0.13u
X707 a_23633_1842# a_23437_1842# VDD.t1336 VDD.t379 sg13_lv_pmos ad=0.3808p pd=2.92u as=0.2128p ps=1.5u w=1.12u l=0.13u
X708 VDD.t1150 a_2019_3892.t9 a_4324_3853# VDD.t0 sg13_lv_pmos ad=0.3808p pd=2.92u as=0.3808p ps=2.92u w=1.12u l=0.13u
X709 VSS.t2113 a_15964_15316# a_16851_15336# VSS.t2121 sg13_lv_nmos ad=0.1371p pd=1.12u as=0.2176p ps=1.96u w=0.64u l=0.13u
X710 a_2595_13229.t0 a_2297_13577# VDD.t603 VDD.t2 sg13_lv_pmos ad=0.2128p pd=1.5u as=0.1918p ps=1.5u w=1.12u l=0.13u
X711 a_27048_1044# a_26477_1842# VSS.t1434 VSS.t1433 sg13_lv_nmos ad=0.1406p pd=1.12u as=0.2516p ps=2.16u w=0.74u l=0.13u
X712 VSS.t556 a_4763_1842# a_5197_1842# VSS.t2135 sg13_lv_nmos ad=0.1406p pd=1.12u as=0.2516p ps=2.16u w=0.74u l=0.13u
X713 a_16510_3889# a_18871_3853# a_18795_3889# VDD.t0 sg13_lv_pmos ad=0.3808p pd=2.92u as=0.2128p ps=1.5u w=1.12u l=0.13u
X714 VSS.t2094 a_1721_3176# a_2019_3156.t1 VSS.t1522 sg13_lv_nmos ad=0.2812p pd=2.24u as=0.1406p ps=1.12u w=0.74u l=0.13u
X715 a_15511_14024# a_15273_14024# a_15403_14024# VSS.t1993 sg13_lv_nmos ad=0.1406p pd=1.12u as=0.2516p ps=2.16u w=0.74u l=0.2u
X716 VDD.t523 a_9323_1842# a_9757_1842# VDD.t379 sg13_lv_pmos ad=0.2128p pd=1.5u as=0.3808p ps=2.92u w=1.12u l=0.13u
X717 a_3543_6021# REF_MUX_SEL2 a_3449_6021# VSS.t184 sg13_lv_nmos ad=0.1216p pd=1.02u as=0.2176p ps=1.96u w=0.64u l=0.13u
X718 a_2019_16074.t0 a_1721_16422# VDD.t1305 VDD.t34 sg13_lv_pmos ad=0.2128p pd=1.5u as=0.1918p ps=1.5u w=1.12u l=0.13u
X719 VSS.t331 a_2595_6001.t2 a_20905_6209# VSS.t719 sg13_lv_nmos ad=0.2516p pd=2.16u as=0.2516p ps=2.16u w=0.74u l=0.13u
X720 a_19550_16071# a_2595_16074.t4 a_20315_16071# VSS.t899 sg13_lv_nmos ad=0.2516p pd=2.16u as=0.1406p ps=1.12u w=0.74u l=0.13u
X721 VDD.t1329 a_7043_14024# a_7477_14024# VDD.t378 sg13_lv_pmos ad=0.2128p pd=1.5u as=0.3808p ps=2.92u w=1.12u l=0.13u
X722 a_13470_13226# a_13444_13190# a_13368_13226# VDD.t2 sg13_lv_pmos ad=0.3808p pd=2.92u as=0.2128p ps=1.5u w=1.12u l=0.13u
X723 a_5768_1044# a_5197_1842# VSS.t678 VSS.t2104 sg13_lv_nmos ad=0.1406p pd=1.12u as=0.2516p ps=2.16u w=0.74u l=0.13u
X724 VSS.t1834 a_5957_16869# a_6425_16071# VSS.t1833 sg13_lv_nmos ad=0.1665p pd=1.19u as=0.2516p ps=2.16u w=0.74u l=0.13u
X725 VSS.t126 a_4187_1764.t115 a_16271_14024# VSS.t125 sg13_lv_nmos ad=0.2516p pd=2.16u as=0.1406p ps=1.12u w=0.74u l=0.6u
X726 a_15755_6734# a_15545_6734# VDD.t743 VDD.t9 sg13_lv_pmos ad=0.2128p pd=1.5u as=0.252p ps=1.57u w=1.12u l=0.13u
X727 VDD.t1456 a_2297_15358# a_2595_15338.t0 VDD.t34 sg13_lv_pmos ad=0.4256p pd=3u as=0.2128p ps=1.5u w=1.12u l=0.13u
X728 VSS.t122 a_2297_15358# a_2595_15338.t1 VSS.t2018 sg13_lv_nmos ad=0.2812p pd=2.24u as=0.1406p ps=1.12u w=0.74u l=0.13u
X729 VDD.t913 a_2595_6737.t6 a_14311_6698# VDD.t9 sg13_lv_pmos ad=0.3808p pd=2.92u as=0.3808p ps=2.92u w=1.12u l=0.13u
X730 a_7390_1044# a_7364_1008# a_7288_1044# VDD.t67 sg13_lv_pmos ad=0.3808p pd=2.92u as=0.2128p ps=1.5u w=1.12u l=0.13u
X731 VDD.t1123 a_16597_16869# a_17065_16071# VDD.t34 sg13_lv_pmos ad=0.252p pd=1.57u as=0.3808p ps=2.92u w=1.12u l=0.13u
X732 a_15273_7532# a_15077_7532# VSS.t1000 VSS.t999 sg13_lv_nmos ad=0.2516p pd=2.16u as=0.1406p ps=1.12u w=0.74u l=0.13u
X733 VSS.t79 a_4187_1764.t28 a_7911_1842# VSS.t78 sg13_lv_nmos ad=0.2516p pd=2.16u as=0.1406p ps=1.12u w=0.74u l=0.6u
X734 a_14888_16071# a_14317_16869# VDD.t844 VDD.t34 sg13_lv_pmos ad=0.2128p pd=1.5u as=0.3808p ps=2.92u w=1.12u l=0.13u
X735 a_13306_11995# a_12355_11557# VDD.t366 VDD.t358 sg13_lv_pmos ad=79.8f pd=0.8u as=0.1428p ps=1.52u w=0.42u l=0.13u
X736 a_6391_7532# a_6153_7532# a_6283_7532# VSS.t2324 sg13_lv_nmos ad=0.1406p pd=1.12u as=0.2516p ps=2.16u w=0.74u l=0.2u
X737 a_5115_6734# a_4905_6734# VDD.t702 VDD.t9 sg13_lv_pmos ad=0.2128p pd=1.5u as=0.252p ps=1.57u w=1.12u l=0.13u
X738 a_13991_16869# a_13753_16869# a_13883_16869# VSS.t1154 sg13_lv_nmos ad=0.1406p pd=1.12u as=0.2516p ps=2.16u w=0.74u l=0.2u
X739 VSS.t1559 VSS.t1559 VSS.t1558 VSS.t1560 sg13_lv_nmos ad=0.1406p pd=1.12u as=0 ps=0 w=0.74u l=0.2u
X740 a_19833_7532# a_19637_7532# VDD.t780 VDD.t345 sg13_lv_pmos ad=0.3808p pd=2.92u as=0.2128p ps=1.5u w=1.12u l=0.13u
X741 a_18313_16869# a_18117_16869# VSS.t958 VSS.t1155 sg13_lv_nmos ad=0.2516p pd=2.16u as=0.1406p ps=1.12u w=0.74u l=0.13u
X742 VSS.t124 a_10083_4687# a_10517_4687# VSS.t2115 sg13_lv_nmos ad=0.1406p pd=1.12u as=0.2516p ps=2.16u w=0.74u l=0.13u
X743 a_10328_16071# a_9757_16869# VDD.t515 VDD.t34 sg13_lv_pmos ad=0.2128p pd=1.5u as=0.3808p ps=2.92u w=1.12u l=0.13u
X744 a_5631_17497# a_5393_16869# a_5523_16869# VDD.t368 sg13_lv_pmos ad=0.2128p pd=1.5u as=0.3808p ps=2.92u w=1.12u l=0.2u
X745 VSS.t1332 a_4187_1764.t149 a_14751_16869# VSS.t2368 sg13_lv_nmos ad=0.2516p pd=2.16u as=0.1406p ps=1.12u w=0.74u l=0.6u
X746 a_19833_16869# a_19637_16869# VDD.t1243 VDD.t368 sg13_lv_pmos ad=0.3808p pd=2.92u as=0.2128p ps=1.5u w=1.12u l=0.13u
X747 VSS.t794 a_18443_14024# a_18877_14024# VSS.t1432 sg13_lv_nmos ad=0.1406p pd=1.12u as=0.2516p ps=2.16u w=0.74u l=0.13u
X748 a_24631_8160# a_24393_7532# a_24523_7532# VDD.t345 sg13_lv_pmos ad=0.2128p pd=1.5u as=0.3808p ps=2.92u w=1.12u l=0.2u
X749 VDD.t1017 a_4187_2434# a_6391_17497# VDD.t368 sg13_lv_pmos ad=0.3808p pd=2.92u as=0.2128p ps=1.5u w=1.12u l=0.6u
X750 VDD.t755 a_23763_16869# a_24197_16869# VDD.t368 sg13_lv_pmos ad=0.2128p pd=1.5u as=0.3808p ps=2.92u w=1.12u l=0.13u
X751 a_9193_7532# a_8997_7532# VDD.t1288 VDD.t345 sg13_lv_pmos ad=0.3808p pd=2.92u as=0.2128p ps=1.5u w=1.12u l=0.13u
X752 a_27671_5315# a_27433_4687# a_27563_4687# VDD.t347 sg13_lv_pmos ad=0.2128p pd=1.5u as=0.3808p ps=2.92u w=1.12u l=0.2u
X753 a_13470_16071# a_15831_16035# a_15755_16071# VDD.t34 sg13_lv_pmos ad=0.3808p pd=2.92u as=0.2128p ps=1.5u w=1.12u l=0.13u
X754 VSS.t222 VDD.t1692 VSS.t221 VSS.t220 sg13_lv_nmos ad=0.1428p pd=1.52u as=0 ps=0 w=0.42u l=1u
X755 VDD.t116 VSS.t272 VDD.t161 VDD.t2 sg13_lv_pmos ad=0.34p pd=2.68u as=0 ps=0 w=1u l=1u
X756 VSS.t136 a_15403_7532# a_15837_7532# VSS.t135 sg13_lv_nmos ad=0.1406p pd=1.12u as=0.2516p ps=2.16u w=0.74u l=0.13u
X757 a_8155_6734# a_7945_6734# VSS.t1140 VSS.t1139 sg13_lv_nmos ad=0.1406p pd=1.12u as=0.1665p ps=1.19u w=0.74u l=0.13u
X758 VDD.t277 VSS.t427 VDD.t275 VDD.t67 sg13_lv_pmos ad=0.19p pd=1.38u as=0 ps=0 w=1u l=1u
X759 VSS.t1772 a_21157_4687# a_21625_3889# VSS.t2356 sg13_lv_nmos ad=0.1665p pd=1.19u as=0.2516p ps=2.16u w=0.74u l=0.13u
X760 VSS.t310 VDD.t1667 VSS.t310 VSS.t312 sg13_lv_nmos ad=0.1428p pd=1.52u as=0 ps=0 w=0.42u l=1u
X761 VSS.t1377 a_24197_1842# a_24665_1044# VSS.t1376 sg13_lv_nmos ad=0.1665p pd=1.19u as=0.2516p ps=2.16u w=0.74u l=0.13u
X762 VSS.t561 a_4187_1764.t98 VSS.t1667 VSS.t1666 sg13_lv_nmos ad=2.38p pd=14.68u as=0 ps=0 w=7u l=7u
X763 a_11711_1842# a_11473_1842# a_11603_1842# VSS.t838 sg13_lv_nmos ad=0.1406p pd=1.12u as=0.2516p ps=2.16u w=0.74u l=0.2u
X764 a_23633_7532# a_23437_7532# VDD.t908 VDD.t345 sg13_lv_pmos ad=0.3808p pd=2.92u as=0.2128p ps=1.5u w=1.12u l=0.13u
X765 a_16510_1044# a_3171_1047.t5 a_17928_1044# VSS.t630 sg13_lv_nmos ad=0.2516p pd=2.16u as=0.1406p ps=1.12u w=0.74u l=0.13u
X766 VSS.t980 a_4763_7532# a_5197_7532# VSS.t1120 sg13_lv_nmos ad=0.1406p pd=1.12u as=0.2516p ps=2.16u w=0.74u l=0.13u
X767 a_27048_6734# a_26477_7532# VSS.t1081 VSS.t1798 sg13_lv_nmos ad=0.1406p pd=1.12u as=0.2516p ps=2.16u w=0.74u l=0.13u
X768 VSS.t412 VDD.t1631 VSS.t414 VSS.t413 sg13_lv_nmos ad=79.8f pd=0.8u as=0 ps=0 w=0.42u l=1u
X769 VSS.t618 a_4187_1764.t38 a_24631_4687# VSS.t724 sg13_lv_nmos ad=0.2516p pd=2.16u as=0.1406p ps=1.12u w=0.74u l=0.6u
X770 VSS.t5 VDD.t1707 VSS.t5 VSS.t187 sg13_lv_nmos ad=79.8f pd=0.8u as=0 ps=0 w=0.42u l=1u
X771 VSS.t371 VDD.t1643 VSS.t371 VSS.t374 sg13_lv_nmos ad=79.8f pd=0.8u as=0 ps=0 w=0.42u l=1u
X772 VDD.t508 a_9323_7532# a_9757_7532# VDD.t345 sg13_lv_pmos ad=0.2128p pd=1.5u as=0.3808p ps=2.92u w=1.12u l=0.13u
X773 VSS.t122 a_1544_15316# a_2391_15358# VSS.t702 sg13_lv_nmos ad=0.1331p pd=1.12u as=0.1216p ps=1.02u w=0.64u l=0.13u
X774 VDD.t1083 a_4187_2434# a_16271_5315# VDD.t347 sg13_lv_pmos ad=0.3808p pd=2.92u as=0.2128p ps=1.5u w=1.12u l=0.6u
X775 a_5768_6734# a_5197_7532# VSS.t982 VSS.t981 sg13_lv_nmos ad=0.1406p pd=1.12u as=0.2516p ps=2.16u w=0.74u l=0.13u
X776 a_14513_1842# a_14317_1842# VDD.t928 VDD.t379 sg13_lv_pmos ad=0.3808p pd=2.92u as=0.2128p ps=1.5u w=1.12u l=0.13u
X777 VDD.t640 a_4003_16869# a_4437_16869# VDD.t368 sg13_lv_pmos ad=0.2128p pd=1.5u as=0.3808p ps=2.92u w=1.12u l=0.13u
X778 a_6854_11676# a_6326_10280# VDD.t674 VDD.t358 sg13_lv_pmos ad=0.38p pd=2.38u as=0.38p ps=2.38u w=2u l=1u
X779 a_5631_2470# a_5393_1842# a_5523_1842# VDD.t379 sg13_lv_pmos ad=0.2128p pd=1.5u as=0.3808p ps=2.92u w=1.12u l=0.2u
X780 a_3171_13229.t0 a_2873_13577# VDD.t382 VDD.t2 sg13_lv_pmos ad=0.2128p pd=1.5u as=0.1918p ps=1.5u w=1.12u l=0.13u
X781 VDD.t306 VSS.t299 VDD.t304 VDD.t2 sg13_lv_pmos ad=0.19p pd=1.38u as=0 ps=0 w=1u l=1u
X782 VDD.t1200 a_1721_7085# a_2019_6737.t0 VDD.t9 sg13_lv_pmos ad=0.4256p pd=3u as=0.2128p ps=1.5u w=1.12u l=0.13u
X783 VSS.t1259 a_2019_3892.t9 a_4324_3853# VSS.t1458 sg13_lv_nmos ad=0.2516p pd=2.16u as=0.2516p ps=2.16u w=0.74u l=0.13u
X784 a_19311_16869# a_19073_16869# a_19203_16869# VSS.t1776 sg13_lv_nmos ad=0.1406p pd=1.12u as=0.2516p ps=2.16u w=0.74u l=0.2u
X785 VDD.t865 a_26043_4687# a_26477_4687# VDD.t347 sg13_lv_pmos ad=0.2128p pd=1.5u as=0.3808p ps=2.92u w=1.12u l=0.13u
X786 a_11473_14024# a_11277_14024# VSS.t1274 VSS.t1273 sg13_lv_nmos ad=0.2516p pd=2.16u as=0.1406p ps=1.12u w=0.74u l=0.13u
X787 VSS.t1683 a_4187_1764.t98 VSS.t1682 VSS.t1666 sg13_lv_nmos ad=2.38p pd=14.68u as=0 ps=0 w=7u l=7u
X788 VSS.t891 a_4187_1764.t92 a_7911_7532# VSS.t890 sg13_lv_nmos ad=0.2516p pd=2.16u as=0.1406p ps=1.12u w=0.74u l=0.6u
X789 a_16510_3889# a_3747_3892.t5 a_18795_3889# VSS.t2033 sg13_lv_nmos ad=0.2516p pd=2.16u as=0.1406p ps=1.12u w=0.74u l=0.13u
X790 a_10430_3889# a_10404_3853# a_10328_3889# VDD.t0 sg13_lv_pmos ad=0.3808p pd=2.92u as=0.2128p ps=1.5u w=1.12u l=0.13u
X791 VSS.t331 VDD.t1659 VSS.t331 VSS.t332 sg13_lv_nmos ad=79.8f pd=0.8u as=0 ps=0 w=0.42u l=1u
X792 VSS.t641 a_3171_1047.t4 a_21044_1008# VSS.t640 sg13_lv_nmos ad=0.2516p pd=2.16u as=0.2516p ps=2.16u w=0.74u l=0.13u
X793 VSS.t1932 a_10083_1842# a_10517_1842# VSS.t1986 sg13_lv_nmos ad=0.1406p pd=1.12u as=0.2516p ps=2.16u w=0.74u l=0.13u
X794 a_3747_3156.t0 a_3449_3176# VDD.t798 VDD.t0 sg13_lv_pmos ad=0.2128p pd=1.5u as=0.1918p ps=1.5u w=1.12u l=0.13u
X795 a_17928_13226# a_17357_14024# VDD.t641 VDD.t2 sg13_lv_pmos ad=0.2128p pd=1.5u as=0.3808p ps=2.92u w=1.12u l=0.13u
X796 VDD.t748 a_21157_7532# a_21625_6734# VDD.t9 sg13_lv_pmos ad=0.252p pd=1.57u as=0.3808p ps=2.92u w=1.12u l=0.13u
X797 a_4633_1842# a_4437_1842# VDD.t1457 VDD.t379 sg13_lv_pmos ad=0.3808p pd=2.92u as=0.2128p ps=1.5u w=1.12u l=0.13u
X798 VDD.t590 a_2019_1047.t4 a_19524_1008# VDD.t67 sg13_lv_pmos ad=0.3808p pd=2.92u as=0.3808p ps=2.92u w=1.12u l=0.13u
X799 a_5631_14652# a_5393_14024# a_5523_14024# VDD.t378 sg13_lv_pmos ad=0.2128p pd=1.5u as=0.3808p ps=2.92u w=1.12u l=0.2u
X800 VSS.t1877 a_3747_12493.t2 a_26985_12701# VSS.t1876 sg13_lv_nmos ad=0.2516p pd=2.16u as=0.2516p ps=2.16u w=0.74u l=0.13u
X801 a_6854_11676# a_15304_10295# a_4187_1764.t0 VDD.t360 sg13_lv_pmos ad=0.136p pd=1.14u as=0.158p ps=1.245u w=0.4u l=0.2u
X802 a_19833_14024# a_19637_14024# VDD.t1133 VDD.t378 sg13_lv_pmos ad=0.3808p pd=2.92u as=0.2128p ps=1.5u w=1.12u l=0.13u
X803 VDD.t1085 a_4187_2434# a_20071_5315# VDD.t347 sg13_lv_pmos ad=0.3808p pd=2.92u as=0.2128p ps=1.5u w=1.12u l=0.6u
X804 VSS.t18 a_2873_331# a_3171_311.t1 VSS.t19 sg13_lv_nmos ad=0.2812p pd=2.24u as=0.1406p ps=1.12u w=0.74u l=0.13u
X805 VDD.t1034 a_4187_2434# a_6391_14652# VDD.t378 sg13_lv_pmos ad=0.3808p pd=2.92u as=0.2128p ps=1.5u w=1.12u l=0.6u
X806 a_3747_16074.t1 a_3449_16422# VSS.t1540 VSS.t2022 sg13_lv_nmos ad=0.1406p pd=1.12u as=0.1331p ps=1.12u w=0.74u l=0.13u
X807 VDD.t381 a_23763_14024# a_24197_14024# VDD.t378 sg13_lv_pmos ad=0.2128p pd=1.5u as=0.3808p ps=2.92u w=1.12u l=0.13u
X808 a_7390_3889# a_8884_3853# a_8808_3889# VDD.t0 sg13_lv_pmos ad=0.3808p pd=2.92u as=0.2128p ps=1.5u w=1.12u l=0.13u
X809 a_13306_10795# a_13132_11110# VDD.t1600 VDD.t358 sg13_lv_pmos ad=79.8f pd=0.8u as=0.1428p ps=1.52u w=0.42u l=0.13u
X810 a_16108_3134# a_3171_3156.t2 a_22590_3889# VSS.t575 sg13_lv_nmos ad=0.2516p pd=2.16u as=0.2516p ps=2.16u w=0.74u l=0.13u
X811 VDD.t27 VSS.t310 VDD.t26 VDD.t9 sg13_lv_pmos ad=0.34p pd=2.68u as=0 ps=0 w=1u l=1u
X812 VSS.t1997 a_19637_14024# a_20105_13226# VSS.t1996 sg13_lv_nmos ad=0.1665p pd=1.19u as=0.2516p ps=2.16u w=0.74u l=0.13u
X813 VSS.t176 a_3449_331# a_3747_311.t1 VSS.t1787 sg13_lv_nmos ad=0.2812p pd=2.24u as=0.1406p ps=1.12u w=0.74u l=0.13u
X814 VSS.t1596 VSS.t1596 VSS.t1598 VSS.t1597 sg13_lv_nmos ad=0.2516p pd=2.16u as=0 ps=0 w=0.74u l=0.13u
X815 a_10430_16071# a_3171_16074.t7 a_11848_16071# VSS.t2191 sg13_lv_nmos ad=0.2516p pd=2.16u as=0.1406p ps=1.12u w=0.74u l=0.13u
X816 a_15755_1044# a_15545_1044# VDD.t925 VDD.t67 sg13_lv_pmos ad=0.2128p pd=1.5u as=0.252p ps=1.57u w=1.12u l=0.13u
X817 a_26911_4687# a_26673_4687# a_26803_4687# VSS.t1044 sg13_lv_nmos ad=0.1406p pd=1.12u as=0.2516p ps=2.16u w=0.74u l=0.2u
X818 VSS.t109 a_24197_7532# a_24665_6734# VSS.t108 sg13_lv_nmos ad=0.1665p pd=1.19u as=0.2516p ps=2.16u w=0.74u l=0.13u
X819 VSS.t2049 a_3171_13229.t5 a_18004_13190# VSS.t2048 sg13_lv_nmos ad=0.2516p pd=2.16u as=0.2516p ps=2.16u w=0.74u l=0.13u
X820 VDD.t663 a_6326_10280# a_6854_11144# VDD.t358 sg13_lv_pmos ad=0.38p pd=2.38u as=0.38p ps=2.38u w=2u l=1u
X821 a_11711_7532# a_11473_7532# a_11603_7532# VSS.t616 sg13_lv_nmos ad=0.1406p pd=1.12u as=0.2516p ps=2.16u w=0.74u l=0.2u
X822 a_16510_6734# a_3171_6737.t5 a_17928_6734# VSS.t1906 sg13_lv_nmos ad=0.2516p pd=2.16u as=0.1406p ps=1.12u w=0.74u l=0.13u
X823 VDD.t1229 a_2595_1047.t6 a_14311_1008# VDD.t67 sg13_lv_pmos ad=0.3808p pd=2.92u as=0.3808p ps=2.92u w=1.12u l=0.13u
X824 VDD.t98 VSS.t5 VDD.t97 VDD.t34 sg13_lv_pmos ad=0.34p pd=2.68u as=0 ps=0 w=1u l=1u
X825 VDD.t765 a_2019_6737.t9 a_4324_6698# VDD.t9 sg13_lv_pmos ad=0.3808p pd=2.92u as=0.3808p ps=2.92u w=1.12u l=0.13u
X826 a_17031_14024# a_16793_14024# a_16923_14024# VSS.t2336 sg13_lv_nmos ad=0.1406p pd=1.12u as=0.2516p ps=2.16u w=0.74u l=0.2u
X827 a_5974_11413# a_6126_9506# VSS.t808 VSS.t806 sg13_lv_nmos ad=0.38p pd=2.38u as=0.68p ps=4.68u w=2u l=1u
X828 VSS.t1083 a_4187_1764.t6 a_24631_1842# VSS.t1082 sg13_lv_nmos ad=0.2516p pd=2.16u as=0.1406p ps=1.12u w=0.74u l=0.6u
X829 a_16510_6734# a_18871_6698# a_18795_6734# VDD.t9 sg13_lv_pmos ad=0.3808p pd=2.92u as=0.2128p ps=1.5u w=1.12u l=0.13u
X830 a_5115_1044# a_4905_1044# VDD.t564 VDD.t67 sg13_lv_pmos ad=0.2128p pd=1.5u as=0.252p ps=1.57u w=1.12u l=0.13u
X831 VSS.t563 a_1721_6021# a_2019_6001.t1 VSS.t500 sg13_lv_nmos ad=0.2812p pd=2.24u as=0.1406p ps=1.12u w=0.74u l=0.13u
X832 a_13470_13226# a_14964_13190# a_14888_13226# VDD.t2 sg13_lv_pmos ad=0.3808p pd=2.92u as=0.2128p ps=1.5u w=1.12u l=0.13u
X833 a_12471_14024# a_12233_14024# a_12363_14024# VSS.t70 sg13_lv_nmos ad=0.1406p pd=1.12u as=0.2516p ps=2.16u w=0.74u l=0.2u
X834 VSS.t832 a_4187_1764.t113 a_17791_14024# VSS.t906 sg13_lv_nmos ad=0.2516p pd=2.16u as=0.1406p ps=1.12u w=0.74u l=0.6u
X835 VSS.t771 a_1544_12471# a_2391_12513# VSS.t1135 sg13_lv_nmos ad=0.1331p pd=1.12u as=0.1216p ps=1.02u w=0.64u l=0.13u
X836 VSS.t1178 a_4437_14024# a_4905_13226# VSS.t2141 sg13_lv_nmos ad=0.1665p pd=1.19u as=0.2516p ps=2.16u w=0.74u l=0.13u
X837 a_14513_7532# a_14317_7532# VDD.t412 VDD.t345 sg13_lv_pmos ad=0.3808p pd=2.92u as=0.2128p ps=1.5u w=1.12u l=0.13u
X838 VDD.t996 a_4187_2434# a_23111_17497# VDD.t368 sg13_lv_pmos ad=0.3808p pd=2.92u as=0.2128p ps=1.5u w=1.12u l=0.6u
X839 VDD.t1475 a_4003_14024# a_4437_14024# VDD.t378 sg13_lv_pmos ad=0.2128p pd=1.5u as=0.3808p ps=2.92u w=1.12u l=0.13u
X840 a_10430_13226# a_10404_13190# a_10328_13226# VDD.t2 sg13_lv_pmos ad=0.3808p pd=2.92u as=0.2128p ps=1.5u w=1.12u l=0.13u
X841 VSS.t268 a_2019_12493.t2 a_17865_12701# VSS.t759 sg13_lv_nmos ad=0.2516p pd=2.16u as=0.2516p ps=2.16u w=0.74u l=0.13u
X842 a_5631_8160# a_5393_7532# a_5523_7532# VDD.t345 sg13_lv_pmos ad=0.2128p pd=1.5u as=0.3808p ps=2.92u w=1.12u l=0.2u
X843 VSS.t2123 a_15964_3134# a_16851_3154# VSS.t2128 sg13_lv_nmos ad=0.1371p pd=1.12u as=0.2176p ps=1.96u w=0.64u l=0.13u
X844 VDD.t531 a_15077_4687# a_15545_3889# VDD.t0 sg13_lv_pmos ad=0.252p pd=1.57u as=0.3808p ps=2.92u w=1.12u l=0.13u
X845 VSS.t163 a_4187_1764.t50 a_15511_4687# VSS.t1848 sg13_lv_nmos ad=0.2516p pd=2.16u as=0.1406p ps=1.12u w=0.74u l=0.6u
X846 a_17553_4687# a_17357_4687# VDD.t687 VDD.t347 sg13_lv_pmos ad=0.3808p pd=2.92u as=0.2128p ps=1.5u w=1.12u l=0.13u
X847 VSS.t1288 a_4187_1764.t119 a_13231_14024# VSS.t1752 sg13_lv_nmos ad=0.2516p pd=2.16u as=0.1406p ps=1.12u w=0.74u l=0.6u
X848 a_8671_5315# a_8433_4687# a_8563_4687# VDD.t347 sg13_lv_pmos ad=0.2128p pd=1.5u as=0.3808p ps=2.92u w=1.12u l=0.2u
X849 VDD.t813 a_18117_16869# a_18585_16071# VDD.t34 sg13_lv_pmos ad=0.252p pd=1.57u as=0.3808p ps=2.92u w=1.12u l=0.13u
X850 a_13566_11525# a_14009_11568# a_13306_11995# VSS.t1510 sg13_lv_nmos ad=79.8f pd=0.8u as=0.1296p ps=1.52u w=0.42u l=0.13u
X851 VDD.t213 VSS.t331 VDD.t211 VDD.t9 sg13_lv_pmos ad=0.19p pd=1.38u as=0 ps=0 w=1u l=1u
X852 VSS.t122 a_1256_15316# a_2967_15358# VSS.t1397 sg13_lv_nmos ad=0.1331p pd=1.12u as=0.1216p ps=1.02u w=0.64u l=0.13u
X853 a_18551_2470# a_18313_1842# a_18443_1842# VDD.t379 sg13_lv_pmos ad=0.2128p pd=1.5u as=0.3808p ps=2.92u w=1.12u l=0.2u
X854 VSS.t1552 VSS.t1552 VSS.t1554 VSS.t1553 sg13_lv_nmos ad=0.1406p pd=1.12u as=0 ps=0 w=0.74u l=0.13u
X855 VSS.t1822 a_25283_4687# a_25717_4687# VSS.t1821 sg13_lv_nmos ad=0.1406p pd=1.12u as=0.2516p ps=2.16u w=0.74u l=0.13u
X856 VDD.t384 a_3171_16074.t2 a_27124_16035# VDD.t34 sg13_lv_pmos ad=0.3808p pd=2.92u as=0.3808p ps=2.92u w=1.12u l=0.13u
X857 a_11848_16071# a_11277_16869# VDD.t1149 VDD.t34 sg13_lv_pmos ad=0.2128p pd=1.5u as=0.3808p ps=2.92u w=1.12u l=0.13u
X858 VDD.t93 VSS.t232 VDD.t342 VDD.t2 sg13_lv_pmos ad=0.34p pd=2.68u as=0 ps=0 w=1u l=1u
X859 VSS.t1389 a_3171_6737.t4 a_21044_6698# VSS.t1913 sg13_lv_nmos ad=0.2516p pd=2.16u as=0.2516p ps=2.16u w=0.74u l=0.13u
X860 a_10951_16869# a_10713_16869# a_10843_16869# VSS.t1884 sg13_lv_nmos ad=0.1406p pd=1.12u as=0.2516p ps=2.16u w=0.74u l=0.2u
X861 a_19550_13226# a_20391_13190# a_20315_13226# VDD.t2 sg13_lv_pmos ad=0.3808p pd=2.92u as=0.2128p ps=1.5u w=1.12u l=0.13u
X862 VSS.t871 a_10083_7532# a_10517_7532# VSS.t2301 sg13_lv_nmos ad=0.1406p pd=1.12u as=0.2516p ps=2.16u w=0.74u l=0.13u
X863 VDD.t169 VSS.t445 VDD.t168 VDD.t67 sg13_lv_pmos ad=0.19p pd=1.38u as=0 ps=0 w=1u l=1u
X864 a_15273_16869# a_15077_16869# VSS.t1332 VSS.t1413 sg13_lv_nmos ad=0.2516p pd=2.16u as=0.1406p ps=1.12u w=0.74u l=0.13u
X865 a_13592_11561# a_13566_11525# VDD.t827 VDD.t358 sg13_lv_pmos ad=0.34p pd=2.68u as=0.36237p ps=2.605u w=1u l=0.13u
X866 a_4633_7532# a_4437_7532# VDD.t350 VDD.t345 sg13_lv_pmos ad=0.3808p pd=2.92u as=0.2128p ps=1.5u w=1.12u l=0.13u
X867 VDD.t728 a_5957_14024# a_6425_13226# VDD.t2 sg13_lv_pmos ad=0.252p pd=1.57u as=0.3808p ps=2.92u w=1.12u l=0.13u
X868 VSS.t1195 a_4187_1764.t63 a_5631_4687# VSS.t1902 sg13_lv_nmos ad=0.2516p pd=2.16u as=0.1406p ps=1.12u w=0.74u l=0.6u
X869 VDD.t1020 a_4187_2434# a_7911_17497# VDD.t368 sg13_lv_pmos ad=0.3808p pd=2.92u as=0.2128p ps=1.5u w=1.12u l=0.6u
X870 VDD.t1583 a_25283_16869# a_25717_16869# VDD.t368 sg13_lv_pmos ad=0.2128p pd=1.5u as=0.3808p ps=2.92u w=1.12u l=0.13u
X871 a_3171_1047.t1 a_2873_1395# VSS.t935 VSS.t2082 sg13_lv_nmos ad=0.1406p pd=1.12u as=0.1331p ps=1.12u w=0.74u l=0.13u
X872 VSS.t830 a_15403_14024# a_15837_14024# VSS.t965 sg13_lv_nmos ad=0.1406p pd=1.12u as=0.2516p ps=2.16u w=0.74u l=0.13u
X873 VSS.t1493 a_2595_13229.t8 a_8231_13190# VSS.t1492 sg13_lv_nmos ad=0.2516p pd=2.16u as=0.2516p ps=2.16u w=0.74u l=0.13u
X874 VSS.t94 a_2297_1395# a_2595_1047.t1 VSS.t95 sg13_lv_nmos ad=0.2812p pd=2.24u as=0.1406p ps=1.12u w=0.74u l=0.13u
X875 VDD.t224 VSS.t357 VDD.t223 VDD.t0 sg13_lv_pmos ad=0.34p pd=2.68u as=0 ps=0 w=1u l=1u
X876 a_10430_3889# a_2019_3892.t7 a_10328_3889# VSS.t1463 sg13_lv_nmos ad=0.2516p pd=2.16u as=0.1406p ps=1.12u w=0.74u l=0.13u
X877 a_21353_4687# a_21157_4687# VDD.t357 VDD.t347 sg13_lv_pmos ad=0.3808p pd=2.92u as=0.2128p ps=1.5u w=1.12u l=0.13u
X878 VDD.t1487 a_20723_16869# a_21157_16869# VDD.t368 sg13_lv_pmos ad=0.2128p pd=1.5u as=0.3808p ps=2.92u w=1.12u l=0.13u
X879 VSS.t345 VDD.t1655 VSS.t344 VSS.t343 sg13_lv_nmos ad=0.1428p pd=1.52u as=0 ps=0 w=0.42u l=1u
X880 VSS.t1611 VSS.t1609 VSS.t1609 VSS.t1610 sg13_lv_nmos ad=0.2516p pd=2.16u as=0 ps=0 w=0.74u l=0.13u
X881 a_1815_3176# a_1256_3134# a_1721_3176# VSS.t933 sg13_lv_nmos ad=0.1216p pd=1.02u as=0.2176p ps=1.96u w=0.64u l=0.13u
X882 a_26911_1842# a_26673_1842# a_26803_1842# VSS.t1662 sg13_lv_nmos ad=0.1406p pd=1.12u as=0.2516p ps=2.16u w=0.74u l=0.2u
X883 VSS.t420 a_3171_311.t3 a_11785_519# VSS.t728 sg13_lv_nmos ad=0.2516p pd=2.16u as=0.2516p ps=2.16u w=0.74u l=0.13u
X884 VDD.t649 a_7043_4687# a_7477_4687# VDD.t347 sg13_lv_pmos ad=0.2128p pd=1.5u as=0.3808p ps=2.92u w=1.12u l=0.13u
X885 VDD.t1183 a_1721_1395# a_2019_1047.t0 VDD.t67 sg13_lv_pmos ad=0.4256p pd=3u as=0.2128p ps=1.5u w=1.12u l=0.13u
X886 a_22351_2470# a_22113_1842# a_22243_1842# VDD.t379 sg13_lv_pmos ad=0.2128p pd=1.5u as=0.3808p ps=2.92u w=1.12u l=0.2u
X887 VDD.t1215 a_3171_3892.t7 a_11924_3853# VDD.t0 sg13_lv_pmos ad=0.3808p pd=2.92u as=0.3808p ps=2.92u w=1.12u l=0.13u
X888 a_2391_1395# CHAN3_MUX_SEL0 a_2297_1395# VSS.t2091 sg13_lv_nmos ad=0.1216p pd=1.02u as=0.2176p ps=1.96u w=0.64u l=0.13u
X889 VDD.t559 a_16923_1842# a_17357_1842# VDD.t379 sg13_lv_pmos ad=0.2128p pd=1.5u as=0.3808p ps=2.92u w=1.12u l=0.13u
X890 VSS.t519 a_4187_1764.t70 a_24631_7532# VSS.t518 sg13_lv_nmos ad=0.2516p pd=2.16u as=0.1406p ps=1.12u w=0.74u l=0.6u
X891 a_7390_3889# a_3171_3892.t8 a_8808_3889# VSS.t1644 sg13_lv_nmos ad=0.2516p pd=2.16u as=0.1406p ps=1.12u w=0.74u l=0.13u
X892 a_13368_1044# a_12797_1842# VSS.t687 VSS.t1172 sg13_lv_nmos ad=0.1406p pd=1.12u as=0.2516p ps=2.16u w=0.74u l=0.13u
X893 VSS.t768 a_1544_1044# a_1815_1395# VSS.t767 sg13_lv_nmos ad=0.1331p pd=1.12u as=0.1216p ps=1.02u w=0.64u l=0.13u
X894 VSS.t350 VDD.t1653 VSS.t350 VSS.t349 sg13_lv_nmos ad=0.1428p pd=1.52u as=0 ps=0 w=0.42u l=1u
X895 VDD.t1386 a_2297_13577# a_2595_13229.t0 VDD.t2 sg13_lv_pmos ad=0.4256p pd=3u as=0.2128p ps=1.5u w=1.12u l=0.13u
X896 a_14009_10774# REF_DELAY_OUT_LAST VDD.t364 VDD.t358 sg13_lv_pmos ad=0.4088p pd=2.97u as=1.10612p ps=6.66u w=1.12u l=0.13u
X897 VDD.t808 a_21157_1842# a_21625_1044# VDD.t67 sg13_lv_pmos ad=0.252p pd=1.57u as=0.3808p ps=2.92u w=1.12u l=0.13u
X898 a_5974_11413# a_6126_9506# VSS.t810 VSS.t806 sg13_lv_nmos ad=0.38p pd=2.38u as=0.68p ps=4.68u w=2u l=1u
X899 a_5731_289# a_3171_311.t3 a_10430_1044# VSS.t727 sg13_lv_nmos ad=0.2516p pd=2.16u as=0.2516p ps=2.16u w=0.74u l=0.13u
X900 VDD.t1004 a_4187_2434# a_23111_14652# VDD.t378 sg13_lv_pmos ad=0.3808p pd=2.92u as=0.2128p ps=1.5u w=1.12u l=0.6u
X901 a_12993_14024# a_12797_14024# VSS.t696 VSS.t695 sg13_lv_nmos ad=0.2516p pd=2.16u as=0.1406p ps=1.12u w=0.74u l=0.13u
X902 VSS.t849 a_4187_1764.t18 a_15511_1842# VSS.t2164 sg13_lv_nmos ad=0.2516p pd=2.16u as=0.1406p ps=1.12u w=0.74u l=0.6u
X903 VDD.t1101 a_4187_2434# a_10951_2470# VDD.t379 sg13_lv_pmos ad=0.3808p pd=2.92u as=0.2128p ps=1.5u w=1.12u l=0.6u
X904 VDD.t321 VSS.t288 VDD.t316 VDD.t2 sg13_lv_pmos ad=0.19p pd=1.38u as=0 ps=0 w=1u l=1u
X905 a_16271_16869# a_16033_16869# a_16163_16869# VSS.t1327 sg13_lv_nmos ad=0.1406p pd=1.12u as=0.2516p ps=2.16u w=0.74u l=0.2u
X906 a_25630_3889# a_25604_3853# a_25528_3889# VDD.t0 sg13_lv_pmos ad=0.3808p pd=2.92u as=0.2128p ps=1.5u w=1.12u l=0.13u
X907 VDD.t325 VSS.t2 VDD.t323 VDD.t0 sg13_lv_pmos ad=0.19p pd=1.38u as=0 ps=0 w=1u l=1u
X908 a_16793_4687# a_16597_4687# VSS.t480 VSS.t479 sg13_lv_nmos ad=0.2516p pd=2.16u as=0.1406p ps=1.12u w=0.74u l=0.13u
X909 VSS.t771 a_1256_12471# a_2967_12513# VSS.t1237 sg13_lv_nmos ad=0.1331p pd=1.12u as=0.1216p ps=1.02u w=0.64u l=0.13u
X910 a_18551_8160# a_18313_7532# a_18443_7532# VDD.t345 sg13_lv_pmos ad=0.2128p pd=1.5u as=0.3808p ps=2.92u w=1.12u l=0.2u
X911 a_7911_4687# a_7673_4687# a_7803_4687# VSS.t2178 sg13_lv_nmos ad=0.1406p pd=1.12u as=0.2516p ps=2.16u w=0.74u l=0.2u
X912 a_10430_6734# a_10404_6698# a_10328_6734# VDD.t9 sg13_lv_pmos ad=0.3808p pd=2.92u as=0.2128p ps=1.5u w=1.12u l=0.13u
X913 VSS.t200 VDD.t1701 VSS.t200 VSS.t199 sg13_lv_nmos ad=0.1428p pd=1.52u as=0 ps=0 w=0.42u l=1u
X914 a_4350_1044# a_3747_1047.t9 a_6635_1044# VSS.t679 sg13_lv_nmos ad=0.2516p pd=2.16u as=0.1406p ps=1.12u w=0.74u l=0.13u
X915 VSS.t595 a_25283_1842# a_25717_1842# VSS.t1266 sg13_lv_nmos ad=0.1406p pd=1.12u as=0.2516p ps=2.16u w=0.74u l=0.13u
X916 VDD.t363 REF_MUX_SEL3 a_3449_6021# VDD.t9 sg13_lv_pmos ad=0.1918p pd=1.5u as=0.1596p ps=1.22u w=0.84u l=0.13u
X917 VSS.t495 a_4187_1764.t146 a_17031_16869# VSS.t2379 sg13_lv_nmos ad=0.2516p pd=2.16u as=0.1406p ps=1.12u w=0.74u l=0.6u
X918 a_27433_14024# a_27237_14024# VSS.t1071 VSS.t1369 sg13_lv_nmos ad=0.2516p pd=2.16u as=0.1406p ps=1.12u w=0.74u l=0.13u
X919 VDD.t876 a_20723_1842# a_21157_1842# VDD.t379 sg13_lv_pmos ad=0.2128p pd=1.5u as=0.3808p ps=2.92u w=1.12u l=0.13u
X920 VDD.t545 a_14851_10872# a_15688_11093# VDD.t358 sg13_lv_pmos ad=0.2128p pd=1.5u as=0.3864p ps=2.93u w=1.12u l=0.13u
X921 VSS.t534 a_15077_4687# a_15545_3889# VSS.t533 sg13_lv_nmos ad=0.1665p pd=1.19u as=0.2516p ps=2.16u w=0.74u l=0.13u
X922 a_3747_12493.t0 a_3449_12513# VDD.t610 VDD.t2 sg13_lv_pmos ad=0.2128p pd=1.5u as=0.1918p ps=1.5u w=1.12u l=0.13u
X923 VDD.t588 a_2019_1047.t9 a_4324_1008# VDD.t67 sg13_lv_pmos ad=0.3808p pd=2.92u as=0.3808p ps=2.92u w=1.12u l=0.13u
X924 VSS.t1268 a_4187_1764.t31 a_5631_1842# VSS.t2150 sg13_lv_nmos ad=0.2516p pd=2.16u as=0.1406p ps=1.12u w=0.74u l=0.6u
X925 a_3449_16422# CHAN0_MUX_SEL0 VDD.t637 VDD.t34 sg13_lv_pmos ad=0.1596p pd=1.22u as=0.2856p ps=2.36u w=0.84u l=0.13u
X926 VDD.t1452 a_15964_15316# a_16851_15336# VDD.t34 sg13_lv_pmos ad=0.2086p pd=1.5u as=0.34p ps=2.68u w=1u l=0.13u
X927 VDD.t1036 a_4187_2434# a_7911_14652# VDD.t378 sg13_lv_pmos ad=0.3808p pd=2.92u as=0.2128p ps=1.5u w=1.12u l=0.6u
X928 VDD.t524 a_25283_14024# a_25717_14024# VDD.t378 sg13_lv_pmos ad=0.2128p pd=1.5u as=0.3808p ps=2.92u w=1.12u l=0.13u
X929 a_19550_1044# a_2595_1047.t4 a_20315_1044# VSS.t1720 sg13_lv_nmos ad=0.2516p pd=2.16u as=0.1406p ps=1.12u w=0.74u l=0.13u
X930 a_3171_6737.t1 a_2873_7085# VSS.t14 VSS.t1124 sg13_lv_nmos ad=0.1406p pd=1.12u as=0.1331p ps=1.12u w=0.74u l=0.13u
X931 VDD.t165 VSS.t345 VDD.t164 VDD.t9 sg13_lv_pmos ad=0.34p pd=2.68u as=0 ps=0 w=1u l=1u
X932 a_16510_1044# a_18871_1008# a_18795_1044# VDD.t67 sg13_lv_pmos ad=0.3808p pd=2.92u as=0.2128p ps=1.5u w=1.12u l=0.13u
X933 a_7390_6734# a_8884_6698# a_8808_6734# VDD.t9 sg13_lv_pmos ad=0.3808p pd=2.92u as=0.2128p ps=1.5u w=1.12u l=0.13u
X934 VSS.t580 a_21157_14024# a_21625_13226# VSS.t579 sg13_lv_nmos ad=0.1665p pd=1.19u as=0.2516p ps=2.16u w=0.74u l=0.13u
X935 VSS.t1095 a_2297_7085# a_2595_6737.t1 VSS.t1096 sg13_lv_nmos ad=0.2812p pd=2.24u as=0.1406p ps=1.12u w=0.74u l=0.13u
X936 VDD.t555 a_20723_14024# a_21157_14024# VDD.t378 sg13_lv_pmos ad=0.2128p pd=1.5u as=0.3808p ps=2.92u w=1.12u l=0.13u
X937 a_13991_5315# a_13753_4687# a_13883_4687# VDD.t347 sg13_lv_pmos ad=0.2128p pd=1.5u as=0.3808p ps=2.92u w=1.12u l=0.2u
X938 VSS.t1774 a_19637_16869# a_20105_16071# VSS.t1773 sg13_lv_nmos ad=0.1665p pd=1.19u as=0.2516p ps=2.16u w=0.74u l=0.13u
X939 VSS.t1586 VSS.t1584 VSS.t1584 VSS.t1585 sg13_lv_nmos ad=0.2516p pd=2.16u as=0 ps=0 w=0.74u l=0.13u
X940 VSS.t1404 a_27563_4687# a_27997_4687# VSS.t1836 sg13_lv_nmos ad=0.1406p pd=1.12u as=0.2516p ps=2.16u w=0.74u l=0.13u
X941 a_26911_7532# a_26673_7532# a_26803_7532# VSS.t916 sg13_lv_nmos ad=0.1406p pd=1.12u as=0.2516p ps=2.16u w=0.74u l=0.2u
X942 VSS.t544 a_7477_1842# a_7945_1044# VSS.t1966 sg13_lv_nmos ad=0.1665p pd=1.19u as=0.2516p ps=2.16u w=0.74u l=0.13u
X943 VDD.t1109 a_4187_2434# a_23871_2470# VDD.t379 sg13_lv_pmos ad=0.3808p pd=2.92u as=0.2128p ps=1.5u w=1.12u l=0.6u
X944 VSS.t1710 a_2019_13229.t4 a_19524_13190# VSS.t1709 sg13_lv_nmos ad=0.2516p pd=2.16u as=0.2516p ps=2.16u w=0.74u l=0.13u
X945 a_20593_4687# a_20397_4687# VSS.t913 VSS.t1443 sg13_lv_nmos ad=0.2516p pd=2.16u as=0.1406p ps=1.12u w=0.74u l=0.13u
X946 VSS.t1073 a_19203_16869# a_19637_16869# VSS.t2154 sg13_lv_nmos ad=0.1406p pd=1.12u as=0.2516p ps=2.16u w=0.74u l=0.13u
X947 a_22351_8160# a_22113_7532# a_22243_7532# VDD.t345 sg13_lv_pmos ad=0.2128p pd=1.5u as=0.3808p ps=2.92u w=1.12u l=0.2u
X948 VSS.t745 a_3171_16074.t5 a_18004_16035# VSS.t2213 sg13_lv_nmos ad=0.2516p pd=2.16u as=0.2516p ps=2.16u w=0.74u l=0.13u
X949 VSS.t382 VDD.t1639 VSS.t382 VSS.t383 sg13_lv_nmos ad=79.8f pd=0.8u as=0 ps=0 w=0.42u l=1u
X950 VDD.t541 a_16923_7532# a_17357_7532# VDD.t345 sg13_lv_pmos ad=0.2128p pd=1.5u as=0.3808p ps=2.92u w=1.12u l=0.13u
X951 a_2391_7085# REF_MUX_SEL0 a_2297_7085# VSS.t1525 sg13_lv_nmos ad=0.1216p pd=1.02u as=0.2176p ps=1.96u w=0.64u l=0.13u
X952 VSS.t486 a_6283_4687# a_6717_4687# VSS.t841 sg13_lv_nmos ad=0.1406p pd=1.12u as=0.2516p ps=2.16u w=0.74u l=0.13u
X953 VSS.t317 VDD.t1663 VSS.t317 VSS.t322 sg13_lv_nmos ad=79.8f pd=0.8u as=0 ps=0 w=0.42u l=1u
X954 a_13368_6734# a_12797_7532# VSS.t1815 VSS.t2357 sg13_lv_nmos ad=0.1406p pd=1.12u as=0.2516p ps=2.16u w=0.74u l=0.13u
X955 VSS.t1220 a_3747_3156.t3 a_14825_3364# VSS.t1219 sg13_lv_nmos ad=0.2516p pd=2.16u as=0.2516p ps=2.16u w=0.74u l=0.13u
X956 a_13991_14024# a_13753_14024# a_13883_14024# VSS.t1985 sg13_lv_nmos ad=0.1406p pd=1.12u as=0.2516p ps=2.16u w=0.74u l=0.2u
X957 a_18313_14024# a_18117_14024# VSS.t832 VSS.t831 sg13_lv_nmos ad=0.2516p pd=2.16u as=0.1406p ps=1.12u w=0.74u l=0.13u
X958 VSS.t1630 a_1544_6734# a_1815_7085# VSS.t1803 sg13_lv_nmos ad=0.1331p pd=1.12u as=0.1216p ps=1.02u w=0.64u l=0.13u
X959 VDD.t108 VSS.t147 VDD.t107 VDD.t67 sg13_lv_pmos ad=0.34p pd=2.68u as=0 ps=0 w=1u l=1u
X960 a_13231_2470# a_12993_1842# a_13123_1842# VDD.t379 sg13_lv_pmos ad=0.2128p pd=1.5u as=0.3808p ps=2.92u w=1.12u l=0.2u
X961 a_10430_13226# a_11924_13190# a_11848_13226# VDD.t2 sg13_lv_pmos ad=0.3808p pd=2.92u as=0.2128p ps=1.5u w=1.12u l=0.13u
X962 VSS.t911 a_4187_1764.t117 a_14751_14024# VSS.t910 sg13_lv_nmos ad=0.2516p pd=2.16u as=0.1406p ps=1.12u w=0.74u l=0.6u
X963 a_3449_3176# CHAN2_MUX_SEL2 VDD.t1483 VDD.t0 sg13_lv_pmos ad=0.1596p pd=1.22u as=0.2856p ps=2.36u w=0.84u l=0.13u
X964 VSS.t1106 a_3171_3892.t7 a_11924_3853# VSS.t1655 sg13_lv_nmos ad=0.2516p pd=2.16u as=0.2516p ps=2.16u w=0.74u l=0.13u
X965 VSS.t1317 a_4437_16869# a_4905_16071# VSS.t1316 sg13_lv_nmos ad=0.1665p pd=1.19u as=0.2516p ps=2.16u w=0.74u l=0.13u
X966 VSS.t2268 a_3747_13229.t3 a_24951_13190# VSS.t2267 sg13_lv_nmos ad=0.2516p pd=2.16u as=0.2516p ps=2.16u w=0.74u l=0.13u
X967 a_13880_11982# a_13592_11561# a_13818_11982# VSS.t1313 sg13_lv_nmos ad=0.1428p pd=1.52u as=37.8f ps=0.6u w=0.42u l=0.13u
X968 VDD.t973 a_4187_2434# a_20071_17497# VDD.t368 sg13_lv_pmos ad=0.3808p pd=2.92u as=0.2128p ps=1.5u w=1.12u l=0.6u
X969 VSS.t136 a_4187_1764.t82 a_15511_7532# VSS.t525 sg13_lv_nmos ad=0.2516p pd=2.16u as=0.1406p ps=1.12u w=0.74u l=0.6u
X970 VDD.t743 a_15077_7532# a_15545_6734# VDD.t9 sg13_lv_pmos ad=0.252p pd=1.57u as=0.3808p ps=2.92u w=1.12u l=0.13u
X971 VSS.t2221 a_3747_12493.t3 a_14825_12701# VSS.t940 sg13_lv_nmos ad=0.2516p pd=2.16u as=0.2516p ps=2.16u w=0.74u l=0.13u
X972 VDD.t993 a_4187_2434# a_10951_8160# VDD.t345 sg13_lv_pmos ad=0.3808p pd=2.92u as=0.2128p ps=1.5u w=1.12u l=0.6u
X973 VSS.t1685 a_4187_1764.t98 VSS.t1683 VSS.t1668 sg13_lv_nmos ad=1.33p pd=7.38u as=0 ps=0 w=7u l=7u
X974 VDD.t1125 a_15077_16869# a_15545_16071# VDD.t34 sg13_lv_pmos ad=0.252p pd=1.57u as=0.3808p ps=2.92u w=1.12u l=0.13u
X975 VDD.t753 a_12363_4687# a_12797_4687# VDD.t347 sg13_lv_pmos ad=0.2128p pd=1.5u as=0.3808p ps=2.92u w=1.12u l=0.13u
X976 a_16793_1842# a_16597_1842# VSS.t974 VSS.t973 sg13_lv_nmos ad=0.2516p pd=2.16u as=0.1406p ps=1.12u w=0.74u l=0.13u
X977 VSS.t1023 a_25283_7532# a_25717_7532# VSS.t2307 sg13_lv_nmos ad=0.1406p pd=1.12u as=0.2516p ps=2.16u w=0.74u l=0.13u
X978 a_7911_1842# a_7673_1842# a_7803_1842# VSS.t1342 sg13_lv_nmos ad=0.1406p pd=1.12u as=0.2516p ps=2.16u w=0.74u l=0.2u
X979 a_12233_1842# a_12037_1842# VDD.t658 VDD.t379 sg13_lv_pmos ad=0.3808p pd=2.92u as=0.2128p ps=1.5u w=1.12u l=0.13u
X980 a_16793_16869# a_16597_16869# VSS.t649 VSS.t1410 sg13_lv_nmos ad=0.2516p pd=2.16u as=0.1406p ps=1.12u w=0.74u l=0.13u
X981 a_4350_6734# a_3747_6737.t9 a_6635_6734# VSS.t1808 sg13_lv_nmos ad=0.2516p pd=2.16u as=0.1406p ps=1.12u w=0.74u l=0.13u
X982 VSS.t221 VDD.t1692 VSS.t224 VSS.t223 sg13_lv_nmos ad=79.8f pd=0.8u as=0 ps=0 w=0.42u l=1u
X983 a_16108_12471# CHAN1_MUX_SEL4 a_15964_12471# VSS.t940 sg13_lv_nmos ad=0.2516p pd=2.16u as=0.2183p ps=1.33u w=0.74u l=0.13u
X984 VDD.t660 a_20723_7532# a_21157_7532# VDD.t345 sg13_lv_pmos ad=0.2128p pd=1.5u as=0.3808p ps=2.92u w=1.12u l=0.13u
X985 VDD.t1516 a_3171_16074.t3 a_24084_16035# VDD.t34 sg13_lv_pmos ad=0.3808p pd=2.92u as=0.3808p ps=2.92u w=1.12u l=0.13u
X986 VSS.t357 VDD.t1648 VSS.t357 VSS.t361 sg13_lv_nmos ad=0.1428p pd=1.52u as=0 ps=0 w=0.42u l=1u
X987 a_12233_16869# a_12037_16869# VSS.t862 VSS.t1450 sg13_lv_nmos ad=0.2516p pd=2.16u as=0.1406p ps=1.12u w=0.74u l=0.13u
X988 VDD.t46 VSS.t193 VDD.t45 VDD.t34 sg13_lv_pmos ad=0.34p pd=2.68u as=0 ps=0 w=1u l=1u
X989 VSS.t602 a_4187_1764.t95 a_5631_7532# VSS.t1006 sg13_lv_nmos ad=0.2516p pd=2.16u as=0.1406p ps=1.12u w=0.74u l=0.6u
X990 a_19550_6734# a_2595_6737.t4 a_20315_6734# VSS.t1387 sg13_lv_nmos ad=0.2516p pd=2.16u as=0.1406p ps=1.12u w=0.74u l=0.13u
X991 VDD.t618 a_3747_311.t3 a_14825_519# VDD.t67 sg13_lv_pmos ad=0.3808p pd=2.92u as=0.3808p ps=2.92u w=1.12u l=0.13u
X992 a_16510_3889# a_16484_3853# a_16408_3889# VDD.t0 sg13_lv_pmos ad=0.3808p pd=2.92u as=0.2128p ps=1.5u w=1.12u l=0.13u
X993 VSS.t1702 a_3747_13229.t8 a_9751_13190# VSS.t1701 sg13_lv_nmos ad=0.2516p pd=2.16u as=0.2516p ps=2.16u w=0.74u l=0.13u
X994 VDD.t998 a_4187_2434# a_4871_17497# VDD.t368 sg13_lv_pmos ad=0.3808p pd=2.92u as=0.2128p ps=1.5u w=1.12u l=0.6u
X995 a_25630_3889# a_2019_3892.t2 a_25528_3889# VSS.t1951 sg13_lv_nmos ad=0.2516p pd=2.16u as=0.1406p ps=1.12u w=0.74u l=0.13u
X996 a_3171_3892.t1 a_2873_4240# VSS.t67 VSS.t977 sg13_lv_nmos ad=0.1406p pd=1.12u as=0.1331p ps=1.12u w=0.74u l=0.13u
X997 VDD.t585 a_22243_16869# a_22677_16869# VDD.t368 sg13_lv_pmos ad=0.2128p pd=1.5u as=0.3808p ps=2.92u w=1.12u l=0.13u
X998 VDD.t179 VSS.t388 VDD.t187 VDD.t0 sg13_lv_pmos ad=0.34p pd=2.68u as=0 ps=0 w=1u l=1u
X999 VSS.t1518 a_2595_16074.t8 a_8231_16035# VSS.t1517 sg13_lv_nmos ad=0.2516p pd=2.16u as=0.2516p ps=2.16u w=0.74u l=0.13u
X1000 VSS.t1756 a_2595_13229.t9 a_5191_13190# VSS.t1755 sg13_lv_nmos ad=0.2516p pd=2.16u as=0.2516p ps=2.16u w=0.74u l=0.13u
X1001 VSS.t1166 a_2297_4240# a_2595_3892.t1 VSS.t546 sg13_lv_nmos ad=0.2812p pd=2.24u as=0.1406p ps=1.12u w=0.74u l=0.13u
X1002 a_19073_4687# a_18877_4687# VSS.t132 VSS.t165 sg13_lv_nmos ad=0.2516p pd=2.16u as=0.1406p ps=1.12u w=0.74u l=0.13u
X1003 a_9675_1044# a_9465_1044# VSS.t1535 VSS.t2366 sg13_lv_nmos ad=0.1406p pd=1.12u as=0.1665p ps=1.19u w=0.74u l=0.13u
X1004 VDD.t1237 a_3171_3892.t2 a_27124_3853# VDD.t0 sg13_lv_pmos ad=0.3808p pd=2.92u as=0.3808p ps=2.92u w=1.12u l=0.13u
X1005 a_1815_6021# a_1256_5979# a_1721_6021# VSS.t65 sg13_lv_nmos ad=0.1216p pd=1.02u as=0.2176p ps=1.96u w=0.64u l=0.13u
X1006 VDD.t965 a_4187_2434# a_23871_8160# VDD.t345 sg13_lv_pmos ad=0.3808p pd=2.92u as=0.2128p ps=1.5u w=1.12u l=0.6u
X1007 VSS.t1140 a_7477_7532# a_7945_6734# VSS.t1290 sg13_lv_nmos ad=0.1665p pd=1.19u as=0.2516p ps=2.16u w=0.74u l=0.13u
X1008 VSS.t614 a_27563_1842# a_27997_1842# VSS.t1488 sg13_lv_nmos ad=0.1406p pd=1.12u as=0.2516p ps=2.16u w=0.74u l=0.13u
X1009 VDD.t1319 a_3747_16074.t5 a_18871_16035# VDD.t34 sg13_lv_pmos ad=0.3808p pd=2.92u as=0.3808p ps=2.92u w=1.12u l=0.13u
X1010 VDD.t1323 a_3171_6737.t7 a_11924_6698# VDD.t9 sg13_lv_pmos ad=0.3808p pd=2.92u as=0.3808p ps=2.92u w=1.12u l=0.13u
X1011 a_20593_1842# a_20397_1842# VSS.t1860 VSS.t1859 sg13_lv_nmos ad=0.2516p pd=2.16u as=0.1406p ps=1.12u w=0.74u l=0.13u
X1012 VDD.t713 a_15964_5979# a_16851_5999# VDD.t9 sg13_lv_pmos ad=0.2086p pd=1.5u as=0.34p ps=2.68u w=1u l=0.13u
X1013 VSS.t635 a_2595_1047.t8 a_8231_1008# VSS.t653 sg13_lv_nmos ad=0.2516p pd=2.16u as=0.2516p ps=2.16u w=0.74u l=0.13u
X1014 a_19311_14024# a_19073_14024# a_19203_14024# VSS.t1999 sg13_lv_nmos ad=0.1406p pd=1.12u as=0.2516p ps=2.16u w=0.74u l=0.2u
X1015 VDD.t21 VSS.t317 VDD.t19 VDD.t9 sg13_lv_pmos ad=0.19p pd=1.38u as=0 ps=0 w=1u l=1u
X1016 VSS.t2137 a_6283_1842# a_6717_1842# VSS.t2136 sg13_lv_nmos ad=0.1406p pd=1.12u as=0.2516p ps=2.16u w=0.74u l=0.13u
X1017 a_10430_3889# a_11271_3853# a_11195_3889# VDD.t0 sg13_lv_pmos ad=0.3808p pd=2.92u as=0.2128p ps=1.5u w=1.12u l=0.13u
X1018 a_2391_4240# CHAN2_MUX_SEL0 a_2297_4240# VSS.t183 sg13_lv_nmos ad=0.1216p pd=1.02u as=0.2176p ps=1.96u w=0.64u l=0.13u
X1019 a_10430_1044# a_10404_1008# a_10328_1044# VDD.t67 sg13_lv_pmos ad=0.3808p pd=2.92u as=0.2128p ps=1.5u w=1.12u l=0.13u
X1020 a_23355_3889# a_23145_3889# VDD.t706 VDD.t0 sg13_lv_pmos ad=0.2128p pd=1.5u as=0.252p ps=1.57u w=1.12u l=0.13u
X1021 VSS.t499 a_1544_3889# a_1815_4240# VSS.t823 sg13_lv_nmos ad=0.1331p pd=1.12u as=0.1216p ps=1.02u w=0.64u l=0.13u
X1022 a_16108_5979# a_23945_6209# a_22590_6734# VDD.t9 sg13_lv_pmos ad=0.3808p pd=2.92u as=0.3808p ps=2.92u w=1.12u l=0.13u
X1023 a_13231_8160# a_12993_7532# a_13123_7532# VDD.t345 sg13_lv_pmos ad=0.2128p pd=1.5u as=0.3808p ps=2.92u w=1.12u l=0.2u
X1024 VDD.t1515 a_3171_16074.t6 a_14964_16035# VDD.t34 sg13_lv_pmos ad=0.3808p pd=2.92u as=0.3808p ps=2.92u w=1.12u l=0.13u
X1025 VSS.t915 a_19203_4687# a_19637_4687# VSS.t986 sg13_lv_nmos ad=0.1406p pd=1.12u as=0.2516p ps=2.16u w=0.74u l=0.13u
X1026 a_16271_5315# a_16033_4687# a_16163_4687# VDD.t347 sg13_lv_pmos ad=0.2128p pd=1.5u as=0.3808p ps=2.92u w=1.12u l=0.2u
X1027 a_15108_11799# a_12849_11557# VDD.t364 VDD.t358 sg13_lv_pmos ad=79.8f pd=0.8u as=1.03698p ps=6.245u w=0.42u l=0.13u
X1028 VDD.t372 a_3747_3892.t4 a_21911_3853# VDD.t0 sg13_lv_pmos ad=0.3808p pd=2.92u as=0.3808p ps=2.92u w=1.12u l=0.13u
X1029 a_8155_13226# a_7945_13226# VSS.t1957 VSS.t2064 sg13_lv_nmos ad=0.1406p pd=1.12u as=0.1665p ps=1.19u w=0.74u l=0.13u
X1030 a_5778_9057# a_6126_9506# a_6326_10280# VSS.t803 sg13_lv_nmos ad=0.68p pd=4.68u as=0.38p ps=2.38u w=2u l=1u
X1031 VDD.t1116 a_4187_2434# a_26151_2470# VDD.t379 sg13_lv_pmos ad=0.3808p pd=2.92u as=0.2128p ps=1.5u w=1.12u l=0.6u
X1032 VDD.t543 a_14851_10872# a_15108_11015# VDD.t358 sg13_lv_pmos ad=0.2639p pd=1.81u as=79.8f ps=0.8u w=0.42u l=0.13u
X1033 a_17791_16869# a_17553_16869# a_17683_16869# VSS.t959 sg13_lv_nmos ad=0.1406p pd=1.12u as=0.2516p ps=2.16u w=0.74u l=0.2u
X1034 VDD.t1045 a_4187_2434# a_20071_14652# VDD.t378 sg13_lv_pmos ad=0.3808p pd=2.92u as=0.2128p ps=1.5u w=1.12u l=0.6u
X1035 VDD.t854 CHAN1_MUX_SEL1 a_3449_13577# VDD.t2 sg13_lv_pmos ad=0.1918p pd=1.5u as=0.1596p ps=1.22u w=0.84u l=0.13u
X1036 a_7390_1044# a_8884_1008# a_8808_1044# VDD.t67 sg13_lv_pmos ad=0.3808p pd=2.92u as=0.2128p ps=1.5u w=1.12u l=0.13u
X1037 VDD.t91 VSS.t276 VDD.t89 VDD.t2 sg13_lv_pmos ad=0.19p pd=1.38u as=0 ps=0 w=1u l=1u
X1038 a_25630_6734# a_25604_6698# a_25528_6734# VDD.t9 sg13_lv_pmos ad=0.3808p pd=2.92u as=0.2128p ps=1.5u w=1.12u l=0.13u
X1039 a_9431_17497# a_9193_16869# a_9323_16869# VDD.t368 sg13_lv_pmos ad=0.2128p pd=1.5u as=0.3808p ps=2.92u w=1.12u l=0.2u
X1040 VSS.t1750 a_4187_1764.t144 a_18551_16869# VSS.t1749 sg13_lv_nmos ad=0.2516p pd=2.16u as=0.1406p ps=1.12u w=0.74u l=0.6u
X1041 a_16793_7532# a_16597_7532# VSS.t10 VSS.t137 sg13_lv_nmos ad=0.2516p pd=2.16u as=0.1406p ps=1.12u w=0.74u l=0.13u
X1042 VSS.t156 a_8563_4687# a_8997_4687# VSS.t2224 sg13_lv_nmos ad=0.1406p pd=1.12u as=0.2516p ps=2.16u w=0.74u l=0.13u
X1043 a_12233_7532# a_12037_7532# VDD.t1286 VDD.t345 sg13_lv_pmos ad=0.3808p pd=2.92u as=0.2128p ps=1.5u w=1.12u l=0.13u
X1044 a_7911_7532# a_7673_7532# a_7803_7532# VSS.t1512 sg13_lv_nmos ad=0.1406p pd=1.12u as=0.2516p ps=2.16u w=0.74u l=0.2u
X1045 VDD.t1095 a_4187_2434# a_4871_2470# VDD.t379 sg13_lv_pmos ad=0.3808p pd=2.92u as=0.2128p ps=1.5u w=1.12u l=0.6u
X1046 VSS.t780 a_4187_1764.t53 a_13231_4687# VSS.t2035 sg13_lv_nmos ad=0.2516p pd=2.16u as=0.1406p ps=1.12u w=0.74u l=0.6u
X1047 a_20968_3889# a_20397_4687# VDD.t1141 VDD.t0 sg13_lv_pmos ad=0.2128p pd=1.5u as=0.3808p ps=2.92u w=1.12u l=0.13u
X1048 VDD.t1175 CHAN2_MUX_SEL1 a_3449_4240# VDD.t0 sg13_lv_pmos ad=0.1918p pd=1.5u as=0.1596p ps=1.22u w=0.84u l=0.13u
X1049 VDD.t518 a_27563_16869# a_27997_16869# VDD.t368 sg13_lv_pmos ad=0.2128p pd=1.5u as=0.3808p ps=2.92u w=1.12u l=0.13u
X1050 a_13880_11982# a_14111_11568# a_13566_11525# VSS.t1510 sg13_lv_nmos ad=0.2373p pd=1.97u as=79.8f ps=0.8u w=0.42u l=0.13u
X1051 a_13949_11604# a_13592_11561# VDD.t831 VDD.t358 sg13_lv_pmos ad=63f pd=0.72u as=0.1563p ps=1.22u w=0.42u l=0.13u
X1052 a_3747_15338.t0 a_3449_15358# VDD.t354 VDD.t34 sg13_lv_pmos ad=0.2128p pd=1.5u as=0.1918p ps=1.5u w=1.12u l=0.13u
X1053 a_3449_331# CHAN3_MUX_SEL2 VDD.t1212 VDD.t67 sg13_lv_pmos ad=0.1596p pd=1.22u as=0.2856p ps=2.36u w=0.84u l=0.13u
X1054 a_3747_15338.t1 a_3449_15358# VSS.t24 VSS.t2107 sg13_lv_nmos ad=0.1406p pd=1.12u as=0.1331p ps=1.12u w=0.74u l=0.13u
X1055 VSS.t111 a_23003_4687# a_23437_4687# VSS.t144 sg13_lv_nmos ad=0.1406p pd=1.12u as=0.2516p ps=2.16u w=0.74u l=0.13u
X1056 a_20071_5315# a_19833_4687# a_19963_4687# VDD.t347 sg13_lv_pmos ad=0.2128p pd=1.5u as=0.3808p ps=2.92u w=1.12u l=0.2u
X1057 VDD.t1033 a_4187_2434# a_4871_14652# VDD.t378 sg13_lv_pmos ad=0.3808p pd=2.92u as=0.2128p ps=1.5u w=1.12u l=0.6u
X1058 a_11910_11995# DLL_RESETN VSS.t922 VSS.t921 sg13_lv_nmos ad=37.8f pd=0.6u as=79.8f ps=0.8u w=0.42u l=0.13u
X1059 VDD.t1512 a_22243_14024# a_22677_14024# VDD.t378 sg13_lv_pmos ad=0.2128p pd=1.5u as=0.3808p ps=2.92u w=1.12u l=0.13u
X1060 VDD.t548 a_14851_11918# a_15688_11557# VDD.t358 sg13_lv_pmos ad=0.2128p pd=1.5u as=0.3864p ps=2.93u w=1.12u l=0.13u
X1061 VSS.t1970 a_21157_16869# a_21625_16071# VSS.t2158 sg13_lv_nmos ad=0.1665p pd=1.19u as=0.2516p ps=2.16u w=0.74u l=0.13u
X1062 VDD.t154 VSS.t439 VDD.t152 VDD.t67 sg13_lv_pmos ad=0.19p pd=1.38u as=0 ps=0 w=1u l=1u
X1063 a_19073_1842# a_18877_1842# VSS.t1067 VSS.t1360 sg13_lv_nmos ad=0.2516p pd=2.16u as=0.1406p ps=1.12u w=0.74u l=0.13u
X1064 VDD.t1424 a_2873_3176# a_3171_3156.t0 VDD.t0 sg13_lv_pmos ad=0.4256p pd=3u as=0.2128p ps=1.5u w=1.12u l=0.13u
X1065 VDD.t532 a_14643_4687# a_15077_4687# VDD.t347 sg13_lv_pmos ad=0.2128p pd=1.5u as=0.3808p ps=2.92u w=1.12u l=0.13u
X1066 a_9675_6734# a_9465_6734# VSS.t134 VSS.t133 sg13_lv_nmos ad=0.1406p pd=1.12u as=0.1665p ps=1.19u w=0.74u l=0.13u
X1067 VSS.t1119 a_27563_7532# a_27997_7532# VSS.t1118 sg13_lv_nmos ad=0.1406p pd=1.12u as=0.2516p ps=2.16u w=0.74u l=0.13u
X1068 VSS.t1021 a_2019_16074.t4 a_19524_16035# VSS.t1020 sg13_lv_nmos ad=0.2516p pd=2.16u as=0.2516p ps=2.16u w=0.74u l=0.13u
X1069 a_20593_7532# a_20397_7532# VSS.t755 VSS.t1514 sg13_lv_nmos ad=0.2516p pd=2.16u as=0.1406p ps=1.12u w=0.74u l=0.13u
X1070 VDD.t925 a_15077_1842# a_15545_1044# VDD.t67 sg13_lv_pmos ad=0.252p pd=1.57u as=0.3808p ps=2.92u w=1.12u l=0.13u
X1071 VDD.t1461 a_15964_3134# a_16851_3154# VDD.t0 sg13_lv_pmos ad=0.2086p pd=1.5u as=0.34p ps=2.68u w=1u l=0.13u
X1072 VSS.t1338 a_2019_13229.t5 a_16484_13190# VSS.t1337 sg13_lv_nmos ad=0.2516p pd=2.16u as=0.2516p ps=2.16u w=0.74u l=0.13u
X1073 VSS.t1384 a_2595_6737.t8 a_8231_6698# VSS.t1383 sg13_lv_nmos ad=0.2516p pd=2.16u as=0.2516p ps=2.16u w=0.74u l=0.13u
X1074 a_16510_3889# a_2019_3892.t5 a_16408_3889# VSS.t2029 sg13_lv_nmos ad=0.2516p pd=2.16u as=0.1406p ps=1.12u w=0.74u l=0.13u
X1075 VDD.t259 VSS.t364 VDD.t257 VDD.t0 sg13_lv_pmos ad=0.19p pd=1.38u as=0 ps=0 w=1u l=1u
X1076 a_19550_1044# a_2019_1047.t4 a_19448_1044# VSS.t671 sg13_lv_nmos ad=0.2516p pd=2.16u as=0.1406p ps=1.12u w=0.74u l=0.13u
X1077 VDD.t79 VSS.t250 VDD.t77 VDD.t2 sg13_lv_pmos ad=0.19p pd=1.38u as=0 ps=0 w=1u l=1u
X1078 VSS.t629 a_6283_7532# a_6717_7532# VSS.t628 sg13_lv_nmos ad=0.1406p pd=1.12u as=0.2516p ps=2.16u w=0.74u l=0.13u
X1079 VSS.t462 VDD.t1619 VSS.t460 VSS.t461 sg13_lv_nmos ad=79.8f pd=0.8u as=0 ps=0 w=0.42u l=1u
X1080 VDD.t1275 a_7803_16869# a_8237_16869# VDD.t368 sg13_lv_pmos ad=0.2128p pd=1.5u as=0.3808p ps=2.92u w=1.12u l=0.13u
X1081 VDD.t501 VDD.t499 VDD.t500 VDD.t379 sg13_lv_pmos ad=0.3808p pd=2.92u as=0 ps=0 w=1.12u l=0.6u
X1082 a_20831_17497# a_20593_16869# a_20723_16869# VDD.t368 sg13_lv_pmos ad=0.2128p pd=1.5u as=0.3808p ps=2.92u w=1.12u l=0.2u
X1083 VDD.t572 DLL_RESETN a_9946_11995# VDD.t358 sg13_lv_pmos ad=0.36237p pd=2.605u as=79.8f ps=0.8u w=0.42u l=0.13u
X1084 VDD.t163 VSS.t437 VDD.t150 VDD.t67 sg13_lv_pmos ad=0.19p pd=1.38u as=0 ps=0 w=1u l=1u
X1085 a_5731_5979# a_2595_6001.t3 a_7390_6734# VSS.t716 sg13_lv_nmos ad=0.2516p pd=2.16u as=0.2516p ps=2.16u w=0.74u l=0.13u
X1086 a_16108_3134# a_23945_3364# a_22590_3889# VDD.t0 sg13_lv_pmos ad=0.3808p pd=2.92u as=0.3808p ps=2.92u w=1.12u l=0.13u
X1087 VSS.t1252 a_3171_3892.t2 a_27124_3853# VSS.t1764 sg13_lv_nmos ad=0.2516p pd=2.16u as=0.2516p ps=2.16u w=0.74u l=0.13u
X1088 a_10951_14024# a_10713_14024# a_10843_14024# VSS.t1980 sg13_lv_nmos ad=0.1406p pd=1.12u as=0.2516p ps=2.16u w=0.74u l=0.2u
X1089 VDD.t1372 a_19637_14024# a_20105_13226# VDD.t2 sg13_lv_pmos ad=0.252p pd=1.57u as=0.3808p ps=2.92u w=1.12u l=0.13u
X1090 VDD.t84 VSS.t262 VDD.t83 VDD.t2 sg13_lv_pmos ad=0.34p pd=2.68u as=0 ps=0 w=1u l=1u
X1091 VDD.t1080 a_4187_2434# a_17791_5315# VDD.t347 sg13_lv_pmos ad=0.3808p pd=2.92u as=0.2128p ps=1.5u w=1.12u l=0.6u
X1092 a_15273_14024# a_15077_14024# VSS.t911 VSS.t966 sg13_lv_nmos ad=0.2516p pd=2.16u as=0.1406p ps=1.12u w=0.74u l=0.13u
X1093 VSS.t511 a_19203_1842# a_19637_1842# VSS.t510 sg13_lv_nmos ad=0.1406p pd=1.12u as=0.2516p ps=2.16u w=0.74u l=0.13u
X1094 VSS.t2 a_2595_3156.t3 a_8745_3364# VSS.t572 sg13_lv_nmos ad=0.2516p pd=2.16u as=0.2516p ps=2.16u w=0.74u l=0.13u
X1095 VDD.t997 a_4187_2434# a_21591_17497# VDD.t368 sg13_lv_pmos ad=0.3808p pd=2.92u as=0.2128p ps=1.5u w=1.12u l=0.6u
X1096 a_2019_3156.t0 a_1721_3176# VDD.t1435 VDD.t0 sg13_lv_pmos ad=0.2128p pd=1.5u as=0.1918p ps=1.5u w=1.12u l=0.13u
X1097 VDD.t1064 a_4187_2434# a_26151_8160# VDD.t345 sg13_lv_pmos ad=0.3808p pd=2.92u as=0.2128p ps=1.5u w=1.12u l=0.6u
X1098 VDD.t267 VSS.t416 VDD.t266 VDD.t67 sg13_lv_pmos ad=0.34p pd=2.68u as=0 ps=0 w=1u l=1u
X1099 VSS.t522 a_3747_16074.t3 a_24951_16035# VSS.t2250 sg13_lv_nmos ad=0.2516p pd=2.16u as=0.2516p ps=2.16u w=0.74u l=0.13u
X1100 VDD.t1400 a_3171_13229.t5 a_18004_13190# VDD.t2 sg13_lv_pmos ad=0.3808p pd=2.92u as=0.3808p ps=2.92u w=1.12u l=0.13u
X1101 VSS.t236 VDD.t1688 VSS.t236 VSS.t235 sg13_lv_nmos ad=0.1428p pd=1.52u as=0 ps=0 w=0.42u l=1u
X1102 VSS.t1228 a_3747_13229.t4 a_21911_13190# VSS.t2263 sg13_lv_nmos ad=0.2516p pd=2.16u as=0.2516p ps=2.16u w=0.74u l=0.13u
X1103 a_10430_3889# a_2595_3892.t7 a_11195_3889# VSS.t1422 sg13_lv_nmos ad=0.2516p pd=2.16u as=0.1406p ps=1.12u w=0.74u l=0.13u
X1104 a_15511_4687# a_15273_4687# a_15403_4687# VSS.t1784 sg13_lv_nmos ad=0.1406p pd=1.12u as=0.2516p ps=2.16u w=0.74u l=0.2u
X1105 VSS.t255 a_3171_12493.t3 a_11785_12701# VSS.t903 sg13_lv_nmos ad=0.2516p pd=2.16u as=0.2516p ps=2.16u w=0.74u l=0.13u
X1106 a_13470_1044# a_2595_1047.t6 a_14235_1044# VSS.t1726 sg13_lv_nmos ad=0.2516p pd=2.16u as=0.1406p ps=1.12u w=0.74u l=0.13u
X1107 VDD.t351 a_1256_289# a_2873_331# VDD.t67 sg13_lv_pmos ad=0.1918p pd=1.5u as=0.1596p ps=1.22u w=0.84u l=0.13u
X1108 a_27433_1842# a_27237_1842# VDD.t1163 VDD.t379 sg13_lv_pmos ad=0.3808p pd=2.92u as=0.2128p ps=1.5u w=1.12u l=0.13u
X1109 a_9431_14652# a_9193_14024# a_9323_14024# VDD.t378 sg13_lv_pmos ad=0.2128p pd=1.5u as=0.3808p ps=2.92u w=1.12u l=0.2u
X1110 VSS.t742 a_8563_1842# a_8997_1842# VSS.t1270 sg13_lv_nmos ad=0.1406p pd=1.12u as=0.2516p ps=2.16u w=0.74u l=0.13u
X1111 a_19448_3889# a_18877_4687# VDD.t416 VDD.t0 sg13_lv_pmos ad=0.2128p pd=1.5u as=0.3808p ps=2.92u w=1.12u l=0.13u
X1112 a_23355_3889# a_23145_3889# VSS.t939 VSS.t1835 sg13_lv_nmos ad=0.1406p pd=1.12u as=0.1665p ps=1.19u w=0.74u l=0.13u
X1113 VDD.t1050 a_4187_2434# a_4871_8160# VDD.t345 sg13_lv_pmos ad=0.3808p pd=2.92u as=0.2128p ps=1.5u w=1.12u l=0.6u
X1114 VDD.t529 a_2019_16074.t2 a_25604_16035# VDD.t34 sg13_lv_pmos ad=0.3808p pd=2.92u as=0.3808p ps=2.92u w=1.12u l=0.13u
X1115 a_3543_15358# CHAN0_MUX_SEL2 a_3449_15358# VSS.t1245 sg13_lv_nmos ad=0.1216p pd=1.02u as=0.2176p ps=1.96u w=0.64u l=0.13u
X1116 VDD.t364 a_14009_10774# a_14111_10917# VDD.t358 sg13_lv_pmos ad=1.10612p pd=6.66u as=0.3864p ps=2.93u w=1.12u l=0.13u
X1117 a_10430_3889# a_11924_3853# a_11848_3889# VDD.t0 sg13_lv_pmos ad=0.3808p pd=2.92u as=0.2128p ps=1.5u w=1.12u l=0.13u
X1118 VSS.t796 a_4187_1764.t21 a_13231_1842# VSS.t2168 sg13_lv_nmos ad=0.2516p pd=2.16u as=0.1406p ps=1.12u w=0.74u l=0.6u
X1119 VSS.t58 a_3747_3892.t4 a_21911_3853# VSS.t57 sg13_lv_nmos ad=0.2516p pd=2.16u as=0.2516p ps=2.16u w=0.74u l=0.13u
X1120 a_13753_16869# a_13557_16869# VSS.t1406 VSS.t1407 sg13_lv_nmos ad=0.2516p pd=2.16u as=0.1406p ps=1.12u w=0.74u l=0.13u
X1121 VSS.t122 VDD.t1695 VSS.t122 VSS.t214 sg13_lv_nmos ad=79.8f pd=0.8u as=0 ps=0 w=0.42u l=1u
X1122 VDD.t823 a_4437_14024# a_4905_13226# VDD.t2 sg13_lv_pmos ad=0.252p pd=1.57u as=0.3808p ps=2.92u w=1.12u l=0.13u
X1123 VSS.t515 a_2019_1047.t3 a_22564_1008# VSS.t664 sg13_lv_nmos ad=0.2516p pd=2.16u as=0.2516p ps=2.16u w=0.74u l=0.13u
X1124 VDD.t576 a_3171_1047.t7 a_11924_1008# VDD.t67 sg13_lv_pmos ad=0.3808p pd=2.92u as=0.3808p ps=2.92u w=1.12u l=0.13u
X1125 VDD.t561 a_27563_14024# a_27997_14024# VDD.t378 sg13_lv_pmos ad=0.2128p pd=1.5u as=0.3808p ps=2.92u w=1.12u l=0.13u
X1126 a_16510_6734# a_16484_6698# a_16408_6734# VDD.t9 sg13_lv_pmos ad=0.3808p pd=2.92u as=0.2128p ps=1.5u w=1.12u l=0.13u
X1127 a_5393_16869# a_5197_16869# VDD.t1205 VDD.t368 sg13_lv_pmos ad=0.3808p pd=2.92u as=0.2128p ps=1.5u w=1.12u l=0.13u
X1128 VDD.t959 a_4187_2434# a_21591_5315# VDD.t347 sg13_lv_pmos ad=0.3808p pd=2.92u as=0.2128p ps=1.5u w=1.12u l=0.6u
X1129 VSS.t490 a_3747_16074.t8 a_9751_16035# VSS.t1896 sg13_lv_nmos ad=0.2516p pd=2.16u as=0.2516p ps=2.16u w=0.74u l=0.13u
X1130 VSS.t591 a_23003_1842# a_23437_1842# VSS.t1936 sg13_lv_nmos ad=0.1406p pd=1.12u as=0.2516p ps=2.16u w=0.74u l=0.13u
X1131 VSS.t371 VDD.t1643 VSS.t371 VSS.t373 sg13_lv_nmos ad=0.1428p pd=1.52u as=0 ps=0 w=0.42u l=1u
X1132 VSS.t1964 a_3747_13229.t9 a_6711_13190# VSS.t2256 sg13_lv_nmos ad=0.2516p pd=2.16u as=0.2516p ps=2.16u w=0.74u l=0.13u
X1133 VSS.t771 a_1721_12513# a_2019_12493.t1 VSS.t1199 sg13_lv_nmos ad=0.2812p pd=2.24u as=0.1406p ps=1.12u w=0.74u l=0.13u
X1134 VSS.t462 VDD.t1618 VSS.t462 VSS.t463 sg13_lv_nmos ad=0.1428p pd=1.52u as=0 ps=0 w=0.42u l=1u
X1135 VSS.t85 a_2595_16074.t9 a_5191_16035# VSS.t873 sg13_lv_nmos ad=0.2516p pd=2.16u as=0.2516p ps=2.16u w=0.74u l=0.13u
X1136 a_19073_7532# a_18877_7532# VSS.t90 VSS.t89 sg13_lv_nmos ad=0.2516p pd=2.16u as=0.1406p ps=1.12u w=0.74u l=0.13u
X1137 VDD.t1093 a_4187_2434# a_7151_2470# VDD.t379 sg13_lv_pmos ad=0.3808p pd=2.92u as=0.2128p ps=1.5u w=1.12u l=0.6u
X1138 a_20968_3889# a_20397_4687# VSS.t1426 VSS.t1442 sg13_lv_nmos ad=0.1406p pd=1.12u as=0.2516p ps=2.16u w=0.74u l=0.13u
X1139 VDD.t948 a_3171_6737.t2 a_27124_6698# VDD.t9 sg13_lv_pmos ad=0.3808p pd=2.92u as=0.3808p ps=2.92u w=1.12u l=0.13u
X1140 VSS.t820 a_16851_12491# CHAN1_MUX_OUT VSS.t821 sg13_lv_nmos ad=0.2516p pd=2.16u as=0.1406p ps=1.12u w=0.74u l=0.13u
X1141 VSS.t723 a_13883_4687# a_14317_4687# VSS.t722 sg13_lv_nmos ad=0.1406p pd=1.12u as=0.2516p ps=2.16u w=0.74u l=0.13u
X1142 a_11491_11918# a_10649_11568# a_11397_11918# VSS.t1005 sg13_lv_nmos ad=0.12665p pd=1.145u as=0.1428p ps=1.52u w=0.42u l=0.13u
X1143 a_25630_3889# a_26471_3853# a_26395_3889# VDD.t0 sg13_lv_pmos ad=0.3808p pd=2.92u as=0.2128p ps=1.5u w=1.12u l=0.13u
X1144 a_19550_6734# a_2019_6737.t4 a_19448_6734# VSS.t1064 sg13_lv_nmos ad=0.2516p pd=2.16u as=0.1406p ps=1.12u w=0.74u l=0.13u
X1145 a_16271_14024# a_16033_14024# a_16163_14024# VSS.t969 sg13_lv_nmos ad=0.1406p pd=1.12u as=0.2516p ps=2.16u w=0.74u l=0.2u
X1146 a_25630_1044# a_25604_1008# a_25528_1044# VDD.t67 sg13_lv_pmos ad=0.3808p pd=2.92u as=0.2128p ps=1.5u w=1.12u l=0.13u
X1147 a_10430_6734# a_11271_6698# a_11195_6734# VDD.t9 sg13_lv_pmos ad=0.3808p pd=2.92u as=0.2128p ps=1.5u w=1.12u l=0.13u
X1148 VDD.t1166 a_2595_13229.t8 a_8231_13190# VDD.t2 sg13_lv_pmos ad=0.3808p pd=2.92u as=0.3808p ps=2.92u w=1.12u l=0.13u
X1149 VDD.t489 VDD.t491 VDD.t492 VDD.t347 sg13_lv_pmos ad=0.2128p pd=1.5u as=0 ps=0 w=1.12u l=0.2u
X1150 VDD.t881 a_7803_14024# a_8237_14024# VDD.t378 sg13_lv_pmos ad=0.2128p pd=1.5u as=0.3808p ps=2.92u w=1.12u l=0.13u
X1151 VDD.t479 VDD.t477 VDD.t478 VDD.t345 sg13_lv_pmos ad=0.3808p pd=2.92u as=0 ps=0 w=1.12u l=0.6u
X1152 a_20831_14652# a_20593_14024# a_20723_14024# VDD.t378 sg13_lv_pmos ad=0.2128p pd=1.5u as=0.3808p ps=2.92u w=1.12u l=0.2u
X1153 VSS.t331 VDD.t1659 VSS.t331 VSS.t330 sg13_lv_nmos ad=0.1428p pd=1.52u as=0 ps=0 w=0.42u l=1u
X1154 VSS.t790 a_4187_1764.t114 a_17031_14024# VSS.t1069 sg13_lv_nmos ad=0.2516p pd=2.16u as=0.1406p ps=1.12u w=0.74u l=0.6u
X1155 a_23355_6734# a_23145_6734# VDD.t859 VDD.t9 sg13_lv_pmos ad=0.2128p pd=1.5u as=0.252p ps=1.57u w=1.12u l=0.13u
X1156 a_9675_13226# a_9465_13226# VSS.t1341 VSS.t2061 sg13_lv_nmos ad=0.1406p pd=1.12u as=0.1665p ps=1.19u w=0.74u l=0.13u
X1157 VSS.t113 a_19203_7532# a_19637_7532# VSS.t1235 sg13_lv_nmos ad=0.1406p pd=1.12u as=0.2516p ps=2.16u w=0.74u l=0.13u
X1158 VDD.t1507 a_3171_16074.t7 a_11924_16035# VDD.t34 sg13_lv_pmos ad=0.3808p pd=2.92u as=0.3808p ps=2.92u w=1.12u l=0.13u
X1159 VDD.t1422 a_1544_15316# a_2297_15358# VDD.t34 sg13_lv_pmos ad=0.1918p pd=1.5u as=0.1596p ps=1.22u w=0.84u l=0.13u
X1160 VDD.t1008 a_4187_2434# a_21591_14652# VDD.t378 sg13_lv_pmos ad=0.3808p pd=2.92u as=0.2128p ps=1.5u w=1.12u l=0.6u
X1161 VDD.t1267 a_3747_6737.t4 a_21911_6698# VDD.t9 sg13_lv_pmos ad=0.3808p pd=2.92u as=0.3808p ps=2.92u w=1.12u l=0.13u
X1162 a_8155_16071# a_7945_16071# VSS.t1447 VSS.t1780 sg13_lv_nmos ad=0.1406p pd=1.12u as=0.1665p ps=1.19u w=0.74u l=0.13u
X1163 VSS.t87 a_4003_4687# a_4437_4687# VSS.t86 sg13_lv_nmos ad=0.1406p pd=1.12u as=0.2516p ps=2.16u w=0.74u l=0.13u
X1164 a_14851_10872# a_14009_10774# a_14757_10872# VSS.t532 sg13_lv_nmos ad=0.12665p pd=1.145u as=0.1428p ps=1.52u w=0.42u l=0.13u
X1165 a_15511_1842# a_15273_1842# a_15403_1842# VSS.t1935 sg13_lv_nmos ad=0.1406p pd=1.12u as=0.2516p ps=2.16u w=0.74u l=0.2u
X1166 a_14751_16869# a_14513_16869# a_14643_16869# VSS.t1326 sg13_lv_nmos ad=0.1406p pd=1.12u as=0.2516p ps=2.16u w=0.74u l=0.2u
X1167 a_27433_7532# a_27237_7532# VDD.t896 VDD.t345 sg13_lv_pmos ad=0.3808p pd=2.92u as=0.2128p ps=1.5u w=1.12u l=0.13u
X1168 a_13470_6734# a_2595_6737.t6 a_14235_6734# VSS.t1319 sg13_lv_nmos ad=0.2516p pd=2.16u as=0.1406p ps=1.12u w=0.74u l=0.13u
X1169 VDD.t516 a_10083_16869# a_10517_16869# VDD.t368 sg13_lv_pmos ad=0.2128p pd=1.5u as=0.3808p ps=2.92u w=1.12u l=0.13u
X1170 a_19073_16869# a_18877_16869# VSS.t1750 VSS.t2325 sg13_lv_nmos ad=0.2516p pd=2.16u as=0.1406p ps=1.12u w=0.74u l=0.13u
X1171 VSS.t1349 a_8563_7532# a_8997_7532# VSS.t1843 sg13_lv_nmos ad=0.1406p pd=1.12u as=0.2516p ps=2.16u w=0.74u l=0.13u
X1172 VDD.t940 a_3747_6001.t3 a_14825_6209# VDD.t9 sg13_lv_pmos ad=0.3808p pd=2.92u as=0.3808p ps=2.92u w=1.12u l=0.13u
X1173 a_6391_17497# a_6153_16869# a_6283_16869# VDD.t368 sg13_lv_pmos ad=0.2128p pd=1.5u as=0.3808p ps=2.92u w=1.12u l=0.2u
X1174 VSS.t2300 a_9444_10280# a_9444_10280# VSS.t2296 sg13_lv_nmos ad=0.68p pd=4.68u as=0.38p ps=2.38u w=2u l=1u
X1175 a_3543_12513# CHAN1_MUX_SEL2 a_3449_12513# VSS.t171 sg13_lv_nmos ad=0.1216p pd=1.02u as=0.2176p ps=1.96u w=0.64u l=0.13u
X1176 VSS.t99 a_4187_1764.t85 a_13231_7532# VSS.t1632 sg13_lv_nmos ad=0.2516p pd=2.16u as=0.1406p ps=1.12u w=0.74u l=0.6u
X1177 VSS.t798 a_2019_6737.t3 a_22564_6698# VSS.t1059 sg13_lv_nmos ad=0.2516p pd=2.16u as=0.2516p ps=2.16u w=0.74u l=0.13u
X1178 a_20968_6734# a_20397_7532# VDD.t1177 VDD.t9 sg13_lv_pmos ad=0.2128p pd=1.5u as=0.3808p ps=2.92u w=1.12u l=0.13u
X1179 VDD.t521 a_5957_4687# a_6425_3889# VDD.t0 sg13_lv_pmos ad=0.252p pd=1.57u as=0.3808p ps=2.92u w=1.12u l=0.13u
X1180 VDD.t40 VSS.t122 VDD.t39 VDD.t34 sg13_lv_pmos ad=0.34p pd=2.68u as=0 ps=0 w=1u l=1u
X1181 VSS.t1431 a_19203_14024# a_19637_14024# VSS.t1430 sg13_lv_nmos ad=0.1406p pd=1.12u as=0.2516p ps=2.16u w=0.74u l=0.13u
X1182 a_3171_6001.t0 a_2873_6021# VDD.t729 VDD.t9 sg13_lv_pmos ad=0.2128p pd=1.5u as=0.1918p ps=1.5u w=1.12u l=0.13u
X1183 VSS.t1578 VSS.t1578 VSS.t1580 VSS.t1579 sg13_lv_nmos ad=0.2516p pd=2.16u as=0 ps=0 w=0.74u l=0.13u
X1184 VSS.t396 VDD.t1635 VSS.t398 VSS.t397 sg13_lv_nmos ad=79.8f pd=0.8u as=0 ps=0 w=0.42u l=1u
X1185 VDD.t982 a_4187_2434# a_7151_17497# VDD.t368 sg13_lv_pmos ad=0.3808p pd=2.92u as=0.2128p ps=1.5u w=1.12u l=0.6u
X1186 a_16510_13226# a_3171_13229.t5 a_17928_13226# VSS.t2047 sg13_lv_nmos ad=0.2516p pd=2.16u as=0.1406p ps=1.12u w=0.74u l=0.13u
X1187 a_5731_289# a_11785_519# a_10430_1044# VDD.t67 sg13_lv_pmos ad=0.3808p pd=2.92u as=0.3808p ps=2.92u w=1.12u l=0.13u
X1188 VDD.t718 a_24523_16869# a_24957_16869# VDD.t368 sg13_lv_pmos ad=0.2128p pd=1.5u as=0.3808p ps=2.92u w=1.12u l=0.13u
X1189 VSS.t1577 VSS.t1574 VSS.t1574 VSS.t1575 sg13_lv_nmos ad=0.1406p pd=1.12u as=0 ps=0 w=0.74u l=0.13u
X1190 a_18313_1842# a_18117_1842# VDD.t560 VDD.t379 sg13_lv_pmos ad=0.3808p pd=2.92u as=0.2128p ps=1.5u w=1.12u l=0.13u
X1191 a_5393_14024# a_5197_14024# VDD.t1469 VDD.t378 sg13_lv_pmos ad=0.3808p pd=2.92u as=0.2128p ps=1.5u w=1.12u l=0.13u
X1192 VDD.t538 a_2297_6021# a_2595_6001.t0 VDD.t9 sg13_lv_pmos ad=0.4256p pd=3u as=0.2128p ps=1.5u w=1.12u l=0.13u
X1193 VDD.t364 a_12907_10876# a_12907_11110# VDD.t358 sg13_lv_pmos ad=1.10612p pd=6.66u as=0.2442p ps=2.06u w=0.66u l=0.13u
X1194 VSS.t1312 a_23003_7532# a_23437_7532# VSS.t1311 sg13_lv_nmos ad=0.1406p pd=1.12u as=0.2516p ps=2.16u w=0.74u l=0.13u
X1195 a_9431_2470# a_9193_1842# a_9323_1842# VDD.t379 sg13_lv_pmos ad=0.2128p pd=1.5u as=0.3808p ps=2.92u w=1.12u l=0.2u
X1196 a_17275_1044# a_17065_1044# VSS.t600 VSS.t599 sg13_lv_nmos ad=0.1406p pd=1.12u as=0.1665p ps=1.19u w=0.74u l=0.13u
X1197 a_19448_3889# a_18877_4687# VSS.t167 VSS.t166 sg13_lv_nmos ad=0.1406p pd=1.12u as=0.2516p ps=2.16u w=0.74u l=0.13u
X1198 VDD.t168 VSS.t443 VDD.t170 VDD.t67 sg13_lv_pmos ad=0.34p pd=2.68u as=0 ps=0 w=1u l=1u
X1199 a_10430_3889# a_3171_3892.t7 a_11848_3889# VSS.t1654 sg13_lv_nmos ad=0.2516p pd=2.16u as=0.1406p ps=1.12u w=0.74u l=0.13u
X1200 a_22873_4687# a_22677_4687# VDD.t705 VDD.t347 sg13_lv_pmos ad=0.3808p pd=2.92u as=0.2128p ps=1.5u w=1.12u l=0.13u
X1201 VDD.t992 a_4187_2434# a_7151_8160# VDD.t345 sg13_lv_pmos ad=0.3808p pd=2.92u as=0.2128p ps=1.5u w=1.12u l=0.6u
X1202 VSS.t670 a_3747_1047.t6 a_15831_1008# VSS.t691 sg13_lv_nmos ad=0.2516p pd=2.16u as=0.2516p ps=2.16u w=0.74u l=0.13u
X1203 VSS.t1473 a_3747_311.t2 a_26985_519# VSS.t1472 sg13_lv_nmos ad=0.2516p pd=2.16u as=0.2516p ps=2.16u w=0.74u l=0.13u
X1204 VSS.t1047 a_2019_16074.t5 a_16484_16035# VSS.t1046 sg13_lv_nmos ad=0.2516p pd=2.16u as=0.2516p ps=2.16u w=0.74u l=0.13u
X1205 a_5778_9057# VSS.t887 VSS.t886 rppd l=32u w=1u
X1206 VSS.t1029 a_13883_1842# a_14317_1842# VSS.t1352 sg13_lv_nmos ad=0.1406p pd=1.12u as=0.2516p ps=2.16u w=0.74u l=0.13u
X1207 a_23871_2470# a_23633_1842# a_23763_1842# VDD.t379 sg13_lv_pmos ad=0.2128p pd=1.5u as=0.3808p ps=2.92u w=1.12u l=0.2u
X1208 VDD.t1393 a_2019_3892.t6 a_13444_3853# VDD.t0 sg13_lv_pmos ad=0.3808p pd=2.92u as=0.3808p ps=2.92u w=1.12u l=0.13u
X1209 a_8433_1842# a_8237_1842# VDD.t1192 VDD.t379 sg13_lv_pmos ad=0.3808p pd=2.92u as=0.2128p ps=1.5u w=1.12u l=0.13u
X1210 VDD.t514 a_9323_16869# a_9757_16869# VDD.t368 sg13_lv_pmos ad=0.2128p pd=1.5u as=0.3808p ps=2.92u w=1.12u l=0.13u
X1211 VDD.t308 VSS.t280 VDD.t312 VDD.t2 sg13_lv_pmos ad=0.34p pd=2.68u as=0 ps=0 w=1u l=1u
X1212 VDD.t211 VSS.t331 VDD.t210 VDD.t9 sg13_lv_pmos ad=0.34p pd=2.68u as=0 ps=0 w=1u l=1u
X1213 VDD.t874 a_18443_1842# a_18877_1842# VDD.t379 sg13_lv_pmos ad=0.2128p pd=1.5u as=0.3808p ps=2.92u w=1.12u l=0.13u
X1214 a_4350_1044# a_2019_1047.t9 a_4248_1044# VSS.t665 sg13_lv_nmos ad=0.2516p pd=2.16u as=0.1406p ps=1.12u w=0.74u l=0.13u
X1215 a_7288_13226# a_6717_14024# VSS.t1964 VSS.t1963 sg13_lv_nmos ad=0.1406p pd=1.12u as=0.2516p ps=2.16u w=0.74u l=0.13u
X1216 a_25630_16071# a_27124_16035# a_27048_16071# VDD.t34 sg13_lv_pmos ad=0.3808p pd=2.92u as=0.2128p ps=1.5u w=1.12u l=0.13u
X1217 a_16793_14024# a_16597_14024# VSS.t126 VSS.t2338 sg13_lv_nmos ad=0.2516p pd=2.16u as=0.1406p ps=1.12u w=0.74u l=0.13u
X1218 VDD.t556 a_21157_14024# a_21625_13226# VDD.t2 sg13_lv_pmos ad=0.252p pd=1.57u as=0.3808p ps=2.92u w=1.12u l=0.13u
X1219 a_14888_1044# a_14317_1842# VSS.t644 VSS.t2001 sg13_lv_nmos ad=0.1406p pd=1.12u as=0.2516p ps=2.16u w=0.74u l=0.13u
X1220 VDD.t300 VSS.t200 VDD.t298 VDD.t34 sg13_lv_pmos ad=0.19p pd=1.38u as=0 ps=0 w=1u l=1u
X1221 a_22113_1842# a_21917_1842# VDD.t528 VDD.t379 sg13_lv_pmos ad=0.3808p pd=2.92u as=0.2128p ps=1.5u w=1.12u l=0.13u
X1222 a_10951_4687# a_10713_4687# a_10843_4687# VSS.t1112 sg13_lv_nmos ad=0.1406p pd=1.12u as=0.2516p ps=2.16u w=0.74u l=0.2u
X1223 a_22113_16869# a_21917_16869# VDD.t1486 VDD.t368 sg13_lv_pmos ad=0.3808p pd=2.92u as=0.2128p ps=1.5u w=1.12u l=0.13u
X1224 VDD.t1222 a_2019_13229.t4 a_19524_13190# VDD.t2 sg13_lv_pmos ad=0.3808p pd=2.92u as=0.3808p ps=2.92u w=1.12u l=0.13u
X1225 a_12233_14024# a_12037_14024# VSS.t1468 VSS.t1467 sg13_lv_nmos ad=0.2516p pd=2.16u as=0.1406p ps=1.12u w=0.74u l=0.13u
X1226 VDD.t77 VSS.t250 VDD.t76 VDD.t2 sg13_lv_pmos ad=0.34p pd=2.68u as=0 ps=0 w=1u l=1u
X1227 a_16108_289# a_3747_311.t2 a_25630_1044# VSS.t1471 sg13_lv_nmos ad=0.2516p pd=2.16u as=0.2516p ps=2.16u w=0.74u l=0.13u
X1228 VSS.t1356 a_2595_13229.t3 a_23431_13190# VSS.t2046 sg13_lv_nmos ad=0.2516p pd=2.16u as=0.2516p ps=2.16u w=0.74u l=0.13u
X1229 VDD.t633 a_1544_12471# a_2297_12513# VDD.t2 sg13_lv_pmos ad=0.1918p pd=1.5u as=0.1596p ps=1.22u w=0.84u l=0.13u
X1230 a_16510_1044# a_16484_1008# a_16408_1044# VDD.t67 sg13_lv_pmos ad=0.3808p pd=2.92u as=0.2128p ps=1.5u w=1.12u l=0.13u
X1231 VSS.t1871 a_4003_1842# a_4437_1842# VSS.t2118 sg13_lv_nmos ad=0.1406p pd=1.12u as=0.2516p ps=2.16u w=0.74u l=0.13u
X1232 a_25630_3889# a_2595_3892.t2 a_26395_3889# VSS.t1949 sg13_lv_nmos ad=0.2516p pd=2.16u as=0.1406p ps=1.12u w=0.74u l=0.13u
X1233 VDD.t48 VSS.t193 VDD.t46 VDD.t34 sg13_lv_pmos ad=0.19p pd=1.38u as=0 ps=0 w=1u l=1u
X1234 VSS.t476 a_3747_16074.t4 a_21911_16035# VSS.t475 sg13_lv_nmos ad=0.2516p pd=2.16u as=0.2516p ps=2.16u w=0.74u l=0.13u
X1235 a_15511_7532# a_15273_7532# a_15403_7532# VSS.t2237 sg13_lv_nmos ad=0.1406p pd=1.12u as=0.2516p ps=2.16u w=0.74u l=0.2u
X1236 VDD.t1102 a_4187_2434# a_12471_2470# VDD.t379 sg13_lv_pmos ad=0.3808p pd=2.92u as=0.2128p ps=1.5u w=1.12u l=0.6u
X1237 a_7390_13226# a_2595_13229.t8 a_8155_13226# VSS.t1491 sg13_lv_nmos ad=0.2516p pd=2.16u as=0.1406p ps=1.12u w=0.74u l=0.13u
X1238 VSS.t310 VDD.t1667 VSS.t310 VSS.t313 sg13_lv_nmos ad=79.8f pd=0.8u as=0 ps=0 w=0.42u l=1u
X1239 VDD.t889 a_10083_14024# a_10517_14024# VDD.t378 sg13_lv_pmos ad=0.2128p pd=1.5u as=0.3808p ps=2.92u w=1.12u l=0.13u
X1240 a_19448_6734# a_18877_7532# VDD.t388 VDD.t9 sg13_lv_pmos ad=0.2128p pd=1.5u as=0.3808p ps=2.92u w=1.12u l=0.13u
X1241 VDD.t847 a_3747_3156.t3 a_14825_3364# VDD.t0 sg13_lv_pmos ad=0.3808p pd=2.92u as=0.3808p ps=2.92u w=1.12u l=0.13u
X1242 a_5115_16071# a_4905_16071# VDD.t911 VDD.t34 sg13_lv_pmos ad=0.2128p pd=1.5u as=0.252p ps=1.57u w=1.12u l=0.13u
X1243 a_3747_13229.t0 a_3449_13577# VDD.t854 VDD.t2 sg13_lv_pmos ad=0.2128p pd=1.5u as=0.1918p ps=1.5u w=1.12u l=0.13u
X1244 a_10430_6734# a_11924_6698# a_11848_6734# VDD.t9 sg13_lv_pmos ad=0.3808p pd=2.92u as=0.2128p ps=1.5u w=1.12u l=0.13u
X1245 VDD.t1227 a_3171_1047.t2 a_27124_1008# VDD.t67 sg13_lv_pmos ad=0.3808p pd=2.92u as=0.3808p ps=2.92u w=1.12u l=0.13u
X1246 VDD.t729 a_1256_5979# a_2873_6021# VDD.t9 sg13_lv_pmos ad=0.1918p pd=1.5u as=0.1596p ps=1.22u w=0.84u l=0.13u
X1247 a_6391_14652# a_6153_14024# a_6283_14024# VDD.t378 sg13_lv_pmos ad=0.2128p pd=1.5u as=0.3808p ps=2.92u w=1.12u l=0.2u
X1248 a_4248_3889# a_4157_4158# VDD.t872 VDD.t0 sg13_lv_pmos ad=0.2128p pd=1.5u as=0.3808p ps=2.92u w=1.12u l=0.13u
X1249 VDD.t1434 a_1256_15316# a_2873_15358# VDD.t34 sg13_lv_pmos ad=0.1918p pd=1.5u as=0.1596p ps=1.22u w=0.84u l=0.13u
X1250 VDD.t526 a_22243_1842# a_22677_1842# VDD.t379 sg13_lv_pmos ad=0.2128p pd=1.5u as=0.3808p ps=2.92u w=1.12u l=0.13u
X1251 a_6913_16869# a_6717_16869# VDD.t565 VDD.t368 sg13_lv_pmos ad=0.3808p pd=2.92u as=0.2128p ps=1.5u w=1.12u l=0.13u
X1252 VDD.t1547 a_3747_13229.t3 a_24951_13190# VDD.t2 sg13_lv_pmos ad=0.3808p pd=2.92u as=0.3808p ps=2.92u w=1.12u l=0.13u
X1253 a_3171_3156.t1 a_2873_3176# VSS.t2 VSS.t2082 sg13_lv_nmos ad=0.1406p pd=1.12u as=0.1331p ps=1.12u w=0.74u l=0.13u
X1254 VDD.t1035 a_4187_2434# a_7151_14652# VDD.t378 sg13_lv_pmos ad=0.3808p pd=2.92u as=0.2128p ps=1.5u w=1.12u l=0.6u
X1255 VDD.t678 a_24523_14024# a_24957_14024# VDD.t378 sg13_lv_pmos ad=0.2128p pd=1.5u as=0.3808p ps=2.92u w=1.12u l=0.13u
X1256 VDD.t82 VSS.t262 VDD.t71 VDD.t2 sg13_lv_pmos ad=0.19p pd=1.38u as=0 ps=0 w=1u l=1u
X1257 a_10206_11525# a_10649_11568# a_10589_11604# VDD.t358 sg13_lv_pmos ad=79.8f pd=0.8u as=63f ps=0.72u w=0.42u l=0.13u
X1258 a_18313_7532# a_18117_7532# VDD.t604 VDD.t345 sg13_lv_pmos ad=0.3808p pd=2.92u as=0.2128p ps=1.5u w=1.12u l=0.13u
X1259 a_2595_311.t0 a_2297_331# VDD.t615 VDD.t67 sg13_lv_pmos ad=0.2128p pd=1.5u as=0.1918p ps=1.5u w=1.12u l=0.13u
X1260 VDD.t1204 CHAN3_MUX_SEL3 a_3449_331# VDD.t67 sg13_lv_pmos ad=0.1918p pd=1.5u as=0.1596p ps=1.22u w=0.84u l=0.13u
X1261 VDD.t359 a_13019_11521# a_12943_11557# VDD.t358 sg13_lv_pmos ad=0.2128p pd=1.5u as=0.2128p ps=1.5u w=1.12u l=0.13u
X1262 a_9431_8160# a_9193_7532# a_9323_7532# VDD.t345 sg13_lv_pmos ad=0.2128p pd=1.5u as=0.3808p ps=2.92u w=1.12u l=0.2u
X1263 a_10430_1044# a_11271_1008# a_11195_1044# VDD.t67 sg13_lv_pmos ad=0.3808p pd=2.92u as=0.2128p ps=1.5u w=1.12u l=0.13u
X1264 VDD.t129 VSS.t207 VDD.t127 VDD.t34 sg13_lv_pmos ad=0.19p pd=1.38u as=0 ps=0 w=1u l=1u
X1265 VSS.t2 a_2297_3176# a_2595_3156.t1 VSS.t95 sg13_lv_nmos ad=0.2812p pd=2.24u as=0.1406p ps=1.12u w=0.74u l=0.13u
X1266 VSS.t915 a_4187_1764.t45 a_19311_4687# VSS.t914 sg13_lv_nmos ad=0.2516p pd=2.16u as=0.1406p ps=1.12u w=0.74u l=0.6u
X1267 VSS.t467 a_3747_16074.t9 a_6711_16035# VSS.t466 sg13_lv_nmos ad=0.2516p pd=2.16u as=0.2516p ps=2.16u w=0.74u l=0.13u
X1268 a_26395_13226# a_26185_13226# VSS.t1362 VSS.t2079 sg13_lv_nmos ad=0.1406p pd=1.12u as=0.1665p ps=1.19u w=0.74u l=0.13u
X1269 a_17275_6734# a_17065_6734# VSS.t139 VSS.t2222 sg13_lv_nmos ad=0.1406p pd=1.12u as=0.1665p ps=1.19u w=0.74u l=0.13u
X1270 VSS.t2293 a_9444_10280# a_9444_10280# VSS.t2292 sg13_lv_nmos ad=0.68p pd=4.68u as=0.38p ps=2.38u w=2u l=1u
X1271 a_23355_1044# a_23145_1044# VDD.t607 VDD.t67 sg13_lv_pmos ad=0.2128p pd=1.5u as=0.252p ps=1.57u w=1.12u l=0.13u
X1272 a_19550_3889# a_21911_3853# a_21835_3889# VDD.t0 sg13_lv_pmos ad=0.3808p pd=2.92u as=0.2128p ps=1.5u w=1.12u l=0.13u
X1273 VSS.t76 a_2873_13577# a_3171_13229.t1 VSS.t77 sg13_lv_nmos ad=0.2812p pd=2.24u as=0.1406p ps=1.12u w=0.74u l=0.13u
X1274 VSS.t1052 a_3747_6737.t6 a_15831_6698# VSS.t1789 sg13_lv_nmos ad=0.2516p pd=2.16u as=0.2516p ps=2.16u w=0.74u l=0.13u
X1275 VSS.t502 a_5957_4687# a_6425_3889# VSS.t1193 sg13_lv_nmos ad=0.1665p pd=1.19u as=0.2516p ps=2.16u w=0.74u l=0.13u
X1276 VSS.t244 VDD.t1686 VSS.t243 VSS.t242 sg13_lv_nmos ad=0.1428p pd=1.52u as=0 ps=0 w=0.42u l=1u
X1277 a_10649_11568# REF_CLK VSS.t542 VSS.t1305 sg13_lv_nmos ad=0.2516p pd=2.16u as=1.9998p ps=12.915u w=0.74u l=0.13u
X1278 VDD.t596 a_3747_1047.t4 a_21911_1008# VDD.t67 sg13_lv_pmos ad=0.3808p pd=2.92u as=0.3808p ps=2.92u w=1.12u l=0.13u
X1279 VSS.t1535 a_8997_1842# a_9465_1044# VSS.t1534 sg13_lv_nmos ad=0.1665p pd=1.19u as=0.2516p ps=2.16u w=0.74u l=0.13u
X1280 a_17791_14024# a_17553_14024# a_17683_14024# VSS.t1428 sg13_lv_nmos ad=0.1406p pd=1.12u as=0.2516p ps=2.16u w=0.74u l=0.2u
X1281 a_23871_8160# a_23633_7532# a_23763_7532# VDD.t345 sg13_lv_pmos ad=0.2128p pd=1.5u as=0.3808p ps=2.92u w=1.12u l=0.2u
X1282 VSS.t160 a_13883_7532# a_14317_7532# VSS.t172 sg13_lv_nmos ad=0.1406p pd=1.12u as=0.2516p ps=2.16u w=0.74u l=0.13u
X1283 a_1721_3176# a_1256_3134# VDD.t1444 VDD.t0 sg13_lv_pmos ad=0.1596p pd=1.22u as=0.2856p ps=2.36u w=0.84u l=0.13u
X1284 a_8433_7532# a_8237_7532# VDD.t1525 VDD.t345 sg13_lv_pmos ad=0.3808p pd=2.92u as=0.2128p ps=1.5u w=1.12u l=0.13u
X1285 a_25630_6734# a_26471_6698# a_26395_6734# VDD.t9 sg13_lv_pmos ad=0.3808p pd=2.92u as=0.2128p ps=1.5u w=1.12u l=0.13u
X1286 a_23111_17497# a_22873_16869# a_23003_16869# VDD.t368 sg13_lv_pmos ad=0.2128p pd=1.5u as=0.3808p ps=2.92u w=1.12u l=0.2u
X1287 VDD.t1357 a_9323_14024# a_9757_14024# VDD.t378 sg13_lv_pmos ad=0.2128p pd=1.5u as=0.3808p ps=2.92u w=1.12u l=0.13u
X1288 VDD.t1219 a_3747_13229.t8 a_9751_13190# VDD.t2 sg13_lv_pmos ad=0.3808p pd=2.92u as=0.3808p ps=2.92u w=1.12u l=0.13u
X1289 VSS.t538 a_4187_1764.t58 a_9431_4687# VSS.t828 sg13_lv_nmos ad=0.2516p pd=2.16u as=0.1406p ps=1.12u w=0.74u l=0.6u
X1290 VDD.t387 a_18443_7532# a_18877_7532# VDD.t345 sg13_lv_pmos ad=0.2128p pd=1.5u as=0.3808p ps=2.92u w=1.12u l=0.13u
X1291 VDD.t323 VSS.t2 VDD.t322 VDD.t0 sg13_lv_pmos ad=0.34p pd=2.68u as=0 ps=0 w=1u l=1u
X1292 VSS.t794 a_4187_1764.t112 a_18551_14024# VSS.t905 sg13_lv_nmos ad=0.2516p pd=2.16u as=0.1406p ps=1.12u w=0.74u l=0.6u
X1293 a_4350_6734# a_2019_6737.t9 a_4248_6734# VSS.t1060 sg13_lv_nmos ad=0.2516p pd=2.16u as=0.1406p ps=1.12u w=0.74u l=0.13u
X1294 a_22113_7532# a_21917_7532# VDD.t551 VDD.t345 sg13_lv_pmos ad=0.3808p pd=2.92u as=0.2128p ps=1.5u w=1.12u l=0.13u
X1295 a_14888_6734# a_14317_7532# VSS.t158 VSS.t157 sg13_lv_nmos ad=0.1406p pd=1.12u as=0.2516p ps=2.16u w=0.74u l=0.13u
X1296 VDD.t1234 a_2595_13229.t9 a_5191_13190# VDD.t2 sg13_lv_pmos ad=0.3808p pd=2.92u as=0.3808p ps=2.92u w=1.12u l=0.13u
X1297 VDD.t73 VSS.t270 VDD.t72 VDD.t2 sg13_lv_pmos ad=0.19p pd=1.38u as=0 ps=0 w=1u l=1u
X1298 VDD.t686 a_2019_16074.t6 a_13444_16035# VDD.t34 sg13_lv_pmos ad=0.3808p pd=2.92u as=0.3808p ps=2.92u w=1.12u l=0.13u
X1299 a_20968_1044# a_20397_1842# VDD.t1296 VDD.t67 sg13_lv_pmos ad=0.2128p pd=1.5u as=0.3808p ps=2.92u w=1.12u l=0.13u
X1300 a_25153_4687# a_24957_4687# VDD.t570 VDD.t347 sg13_lv_pmos ad=0.3808p pd=2.92u as=0.2128p ps=1.5u w=1.12u l=0.13u
X1301 a_9675_16071# a_9465_16071# VSS.t610 VSS.t2062 sg13_lv_nmos ad=0.1406p pd=1.12u as=0.1665p ps=1.19u w=0.74u l=0.13u
X1302 VDD.t831 a_12849_11557# a_13566_11525# VDD.t358 sg13_lv_pmos ad=0.1563p pd=1.22u as=0.147p ps=1.54u w=0.42u l=0.13u
X1303 a_10951_1842# a_10713_1842# a_10843_1842# VSS.t1929 sg13_lv_nmos ad=0.1406p pd=1.12u as=0.2516p ps=2.16u w=0.74u l=0.2u
X1304 VDD.t706 a_22677_4687# a_23145_3889# VDD.t0 sg13_lv_pmos ad=0.252p pd=1.57u as=0.3808p ps=2.92u w=1.12u l=0.13u
X1305 VSS.t111 a_4187_1764.t40 a_23111_4687# VSS.t110 sg13_lv_nmos ad=0.2516p pd=2.16u as=0.1406p ps=1.12u w=0.74u l=0.6u
X1306 a_22113_14024# a_21917_14024# VDD.t851 VDD.t378 sg13_lv_pmos ad=0.3808p pd=2.92u as=0.2128p ps=1.5u w=1.12u l=0.13u
X1307 a_6635_13226# a_6425_13226# VSS.t976 VSS.t975 sg13_lv_nmos ad=0.1406p pd=1.12u as=0.1665p ps=1.19u w=0.74u l=0.13u
X1308 VSS.t2028 a_2019_3892.t6 a_13444_3853# VSS.t2027 sg13_lv_nmos ad=0.2516p pd=2.16u as=0.2516p ps=2.16u w=0.74u l=0.13u
X1309 VSS.t16 a_4003_7532# a_4437_7532# VSS.t15 sg13_lv_nmos ad=0.1406p pd=1.12u as=0.2516p ps=2.16u w=0.74u l=0.13u
X1310 VSS.t670 a_2019_1047.t5 a_16484_1008# VSS.t669 sg13_lv_nmos ad=0.2516p pd=2.16u as=0.2516p ps=2.16u w=0.74u l=0.13u
X1311 VDD.t29 VSS.t310 VDD.t27 VDD.t9 sg13_lv_pmos ad=0.19p pd=1.38u as=0 ps=0 w=1u l=1u
X1312 a_26151_2470# a_25913_1842# a_26043_1842# VDD.t379 sg13_lv_pmos ad=0.2128p pd=1.5u as=0.3808p ps=2.92u w=1.12u l=0.2u
X1313 VDD.t991 a_4187_2434# a_12471_8160# VDD.t345 sg13_lv_pmos ad=0.3808p pd=2.92u as=0.2128p ps=1.5u w=1.12u l=0.6u
X1314 VDD.t1567 a_1721_331# a_2019_311# VDD.t67 sg13_lv_pmos ad=0.4256p pd=3u as=0.2128p ps=1.5u w=1.12u l=0.13u
X1315 a_7911_17497# a_7673_16869# a_7803_16869# VDD.t368 sg13_lv_pmos ad=0.2128p pd=1.5u as=0.3808p ps=2.92u w=1.12u l=0.2u
X1316 a_16033_16869# a_15837_16869# VSS.t527 VSS.t1329 sg13_lv_nmos ad=0.2516p pd=2.16u as=0.1406p ps=1.12u w=0.74u l=0.13u
X1317 a_13753_1842# a_13557_1842# VDD.t645 VDD.t379 sg13_lv_pmos ad=0.3808p pd=2.92u as=0.2128p ps=1.5u w=1.12u l=0.13u
X1318 VSS.t303 VDD.t1671 VSS.t303 VSS.t304 sg13_lv_nmos ad=79.8f pd=0.8u as=0 ps=0 w=0.42u l=1u
X1319 VSS.t427 VDD.t1627 VSS.t427 VSS.t429 sg13_lv_nmos ad=79.8f pd=0.8u as=0 ps=0 w=0.42u l=1u
X1320 VSS.t678 a_3171_1047.t9 a_5844_1008# VSS.t1725 sg13_lv_nmos ad=0.2516p pd=2.16u as=0.2516p ps=2.16u w=0.74u l=0.13u
X1321 a_4871_2470# a_4633_1842# a_4763_1842# VDD.t379 sg13_lv_pmos ad=0.2128p pd=1.5u as=0.3808p ps=2.92u w=1.12u l=0.2u
X1322 VDD.t1019 a_4187_2434# a_8671_17497# VDD.t368 sg13_lv_pmos ad=0.3808p pd=2.92u as=0.2128p ps=1.5u w=1.12u l=0.6u
X1323 a_19550_13226# a_2019_13229.t4 a_19448_13226# VSS.t1708 sg13_lv_nmos ad=0.2516p pd=2.16u as=0.1406p ps=1.12u w=0.74u l=0.13u
X1324 VDD.t740 a_1256_12471# a_2873_12513# VDD.t2 sg13_lv_pmos ad=0.1918p pd=1.5u as=0.1596p ps=1.22u w=0.84u l=0.13u
X1325 VDD.t1499 a_22243_7532# a_22677_7532# VDD.t345 sg13_lv_pmos ad=0.2128p pd=1.5u as=0.3808p ps=2.92u w=1.12u l=0.13u
X1326 VDD.t1340 a_2595_311.t2 a_20905_519# VDD.t67 sg13_lv_pmos ad=0.3808p pd=2.92u as=0.3808p ps=2.92u w=1.12u l=0.13u
X1327 VDD.t626 a_26043_16869# a_26477_16869# VDD.t368 sg13_lv_pmos ad=0.2128p pd=1.5u as=0.3808p ps=2.92u w=1.12u l=0.13u
X1328 VDD.t542 a_5957_7532# a_6425_6734# VDD.t9 sg13_lv_pmos ad=0.252p pd=1.57u as=0.3808p ps=2.92u w=1.12u l=0.13u
X1329 VDD.t616 a_2297_331# a_2595_311.t0 VDD.t67 sg13_lv_pmos ad=0.4256p pd=3u as=0.2128p ps=1.5u w=1.12u l=0.13u
X1330 VDD.t611 a_2595_6001.t3 a_8745_6209# VDD.t9 sg13_lv_pmos ad=0.3808p pd=2.92u as=0.3808p ps=2.92u w=1.12u l=0.13u
X1331 a_16510_16071# a_3171_16074.t5 a_17928_16071# VSS.t2212 sg13_lv_nmos ad=0.2516p pd=2.16u as=0.1406p ps=1.12u w=0.74u l=0.13u
X1332 a_6913_14024# a_6717_14024# VDD.t1330 VDD.t378 sg13_lv_pmos ad=0.3808p pd=2.92u as=0.2128p ps=1.5u w=1.12u l=0.13u
X1333 a_8155_13226# a_7945_13226# VDD.t1348 VDD.t2 sg13_lv_pmos ad=0.2128p pd=1.5u as=0.252p ps=1.57u w=1.12u l=0.13u
X1334 VSS.t2 VDD.t1639 VSS.t382 VSS.t381 sg13_lv_nmos ad=0.1428p pd=1.52u as=0 ps=0 w=0.42u l=1u
X1335 VSS.t1566 VSS.t1564 VSS.t1564 VSS.t1565 sg13_lv_nmos ad=0.68p pd=4.68u as=0 ps=0 w=2u l=1u
X1336 VSS.t638 a_2595_1047.t7 a_11271_1008# VSS.t655 sg13_lv_nmos ad=0.2516p pd=2.16u as=0.2516p ps=2.16u w=0.74u l=0.13u
X1337 VSS.t511 a_4187_1764.t13 a_19311_1842# VSS.t1030 sg13_lv_nmos ad=0.2516p pd=2.16u as=0.1406p ps=1.12u w=0.74u l=0.6u
X1338 a_5731_3134# a_2595_3156.t3 a_7390_3889# VSS.t571 sg13_lv_nmos ad=0.2516p pd=2.16u as=0.2516p ps=2.16u w=0.74u l=0.13u
X1339 VSS.t386 VDD.t1638 VSS.t385 VSS.t384 sg13_lv_nmos ad=0.1428p pd=1.52u as=0 ps=0 w=0.42u l=1u
X1340 a_3171_6737.t0 a_2873_7085# VDD.t348 VDD.t9 sg13_lv_pmos ad=0.2128p pd=1.5u as=0.1918p ps=1.5u w=1.12u l=0.13u
X1341 a_4248_3889# a_4157_4158# VSS.t1259 VSS.t1258 sg13_lv_nmos ad=0.1406p pd=1.12u as=0.2516p ps=2.16u w=0.74u l=0.13u
X1342 a_1815_13577# a_1256_13226# a_1721_13577# VSS.t1396 sg13_lv_nmos ad=0.1216p pd=1.02u as=0.2176p ps=1.96u w=0.64u l=0.13u
X1343 VSS.t134 a_8997_7532# a_9465_6734# VSS.t2119 sg13_lv_nmos ad=0.1665p pd=1.19u as=0.2516p ps=2.16u w=0.74u l=0.13u
X1344 VDD.t778 a_2297_7085# a_2595_6737.t0 VDD.t9 sg13_lv_pmos ad=0.4256p pd=3u as=0.2128p ps=1.5u w=1.12u l=0.13u
X1345 VDD.t894 a_24523_1842# a_24957_1842# VDD.t379 sg13_lv_pmos ad=0.2128p pd=1.5u as=0.3808p ps=2.92u w=1.12u l=0.13u
X1346 VSS.t627 a_4763_16869# a_5197_16869# VSS.t1838 sg13_lv_nmos ad=0.1406p pd=1.12u as=0.2516p ps=2.16u w=0.74u l=0.13u
X1347 VDD.t763 a_2019_6737.t6 a_13444_6698# VDD.t9 sg13_lv_pmos ad=0.3808p pd=2.92u as=0.3808p ps=2.92u w=1.12u l=0.13u
X1348 a_15270_10795# a_12849_11557# VSS.t39 VSS.t1189 sg13_lv_nmos ad=37.8f pd=0.6u as=79.8f ps=0.8u w=0.42u l=0.13u
X1349 VSS.t504 a_3747_1047.t8 a_9751_1008# VSS.t1731 sg13_lv_nmos ad=0.2516p pd=2.16u as=0.2516p ps=2.16u w=0.74u l=0.13u
X1350 VSS.t529 a_12907_10876# a_12907_10876# VSS.t2225 sg13_lv_nmos ad=1.45407p pd=9.445u as=0.111p ps=1.34u w=0.3u l=0.13u
X1351 a_8808_13226# a_8237_14024# VSS.t1493 VSS.t1925 sg13_lv_nmos ad=0.1406p pd=1.12u as=0.2516p ps=2.16u w=0.74u l=0.13u
X1352 a_23111_14652# a_22873_14024# a_23003_14024# VDD.t378 sg13_lv_pmos ad=0.2128p pd=1.5u as=0.3808p ps=2.92u w=1.12u l=0.2u
X1353 a_6126_9506# a_5974_11413# a_6326_10280# VSS.t806 sg13_lv_nmos ad=0.68p pd=4.68u as=0.38p ps=2.38u w=2u l=1u
X1354 VSS.t506 a_4187_1764.t26 a_9431_1842# VSS.t2371 sg13_lv_nmos ad=0.2516p pd=2.16u as=0.1406p ps=1.12u w=0.74u l=0.6u
X1355 a_19448_1044# a_18877_1842# VDD.t932 VDD.t67 sg13_lv_pmos ad=0.2128p pd=1.5u as=0.3808p ps=2.92u w=1.12u l=0.13u
X1356 a_10430_3889# a_12791_3853# a_12715_3889# VDD.t0 sg13_lv_pmos ad=0.3808p pd=2.92u as=0.2128p ps=1.5u w=1.12u l=0.13u
X1357 a_7288_16071# a_6717_16869# VSS.t467 VSS.t1824 sg13_lv_nmos ad=0.1406p pd=1.12u as=0.2516p ps=2.16u w=0.74u l=0.13u
X1358 a_10430_1044# a_11924_1008# a_11848_1044# VDD.t67 sg13_lv_pmos ad=0.3808p pd=2.92u as=0.2128p ps=1.5u w=1.12u l=0.13u
X1359 a_19550_3889# a_3747_3892.t4 a_21835_3889# VSS.t56 sg13_lv_nmos ad=0.2516p pd=2.16u as=0.1406p ps=1.12u w=0.74u l=0.13u
X1360 VDD.t85 VSS.t222 VDD.t115 VDD.t34 sg13_lv_pmos ad=0.34p pd=2.68u as=0 ps=0 w=1u l=1u
X1361 a_4248_13226# a_4157_13495# VSS.t1335 VSS.t2019 sg13_lv_nmos ad=0.1406p pd=1.12u as=0.2516p ps=2.16u w=0.74u l=0.13u
X1362 a_2297_7085# REF_MUX_SEL0 VDD.t1186 VDD.t9 sg13_lv_pmos ad=0.1596p pd=1.22u as=0.2856p ps=2.36u w=0.84u l=0.13u
X1363 a_24875_3889# a_24665_3889# VDD.t738 VDD.t0 sg13_lv_pmos ad=0.2128p pd=1.5u as=0.252p ps=1.57u w=1.12u l=0.13u
X1364 a_13753_14024# a_13557_14024# VSS.t1288 VSS.t1987 sg13_lv_nmos ad=0.2516p pd=2.16u as=0.1406p ps=1.12u w=0.74u l=0.13u
X1365 VSS.t141 a_11603_4687# a_12037_4687# VSS.t2238 sg13_lv_nmos ad=0.1406p pd=1.12u as=0.2516p ps=2.16u w=0.74u l=0.13u
X1366 a_10951_7532# a_10713_7532# a_10843_7532# VSS.t620 sg13_lv_nmos ad=0.1406p pd=1.12u as=0.2516p ps=2.16u w=0.74u l=0.2u
X1367 VSS.t591 a_4187_1764.t8 a_23111_1842# VSS.t590 sg13_lv_nmos ad=0.2516p pd=2.16u as=0.1406p ps=1.12u w=0.74u l=0.6u
X1368 a_17791_5315# a_17553_4687# a_17683_4687# VDD.t347 sg13_lv_pmos ad=0.2128p pd=1.5u as=0.3808p ps=2.92u w=1.12u l=0.2u
X1369 VDD.t1199 a_1544_6734# a_1721_7085# VDD.t9 sg13_lv_pmos ad=0.1918p pd=1.5u as=0.1596p ps=1.22u w=0.84u l=0.13u
X1370 VDD.t1240 a_2595_3892.t3 a_23431_3853# VDD.t0 sg13_lv_pmos ad=0.3808p pd=2.92u as=0.3808p ps=2.92u w=1.12u l=0.13u
X1371 VSS.t895 a_2595_16074.t3 a_23431_16035# VSS.t894 sg13_lv_nmos ad=0.2516p pd=2.16u as=0.2516p ps=2.16u w=0.74u l=0.13u
X1372 VDD.t921 a_2019_13229.t5 a_16484_13190# VDD.t2 sg13_lv_pmos ad=0.3808p pd=2.92u as=0.3808p ps=2.92u w=1.12u l=0.13u
X1373 VSS.t1052 a_2019_6737.t5 a_16484_6698# VSS.t1051 sg13_lv_nmos ad=0.2516p pd=2.16u as=0.2516p ps=2.16u w=0.74u l=0.13u
X1374 VDD.t1118 a_4187_2434# a_27671_2470# VDD.t379 sg13_lv_pmos ad=0.3808p pd=2.92u as=0.2128p ps=1.5u w=1.12u l=0.6u
X1375 a_24393_4687# a_24197_4687# VSS.t989 VSS.t988 sg13_lv_nmos ad=0.2516p pd=2.16u as=0.1406p ps=1.12u w=0.74u l=0.13u
X1376 a_7390_13226# a_3747_13229.t8 a_9675_13226# VSS.t1700 sg13_lv_nmos ad=0.2516p pd=2.16u as=0.1406p ps=1.12u w=0.74u l=0.13u
X1377 VSS.t1498 a_2595_13229.t4 a_20391_13190# VSS.t1497 sg13_lv_nmos ad=0.2516p pd=2.16u as=0.2516p ps=2.16u w=0.74u l=0.13u
X1378 a_26151_8160# a_25913_7532# a_26043_7532# VDD.t345 sg13_lv_pmos ad=0.2128p pd=1.5u as=0.3808p ps=2.92u w=1.12u l=0.2u
X1379 VDD.t226 VSS.t357 VDD.t224 VDD.t0 sg13_lv_pmos ad=0.19p pd=1.38u as=0 ps=0 w=1u l=1u
X1380 VSS.t344 VDD.t1655 VSS.t344 VSS.t346 sg13_lv_nmos ad=79.8f pd=0.8u as=0 ps=0 w=0.42u l=1u
X1381 a_7390_16071# a_2595_16074.t8 a_8155_16071# VSS.t1516 sg13_lv_nmos ad=0.2516p pd=2.16u as=0.1406p ps=1.12u w=0.74u l=0.13u
X1382 VDD.t95 VSS.t5 VDD.t96 VDD.t34 sg13_lv_pmos ad=0.19p pd=1.38u as=0 ps=0 w=1u l=1u
X1383 a_9444_10280# a_6854_11144# a_6854_11144# VSS.t1207 sg13_lv_nmos ad=0.68p pd=4.68u as=0.38p ps=2.38u w=2u l=1u
X1384 VDD.t332 VSS.t303 VDD.t333 VDD.t9 sg13_lv_pmos ad=0.19p pd=1.38u as=0 ps=0 w=1u l=1u
X1385 a_7911_14652# a_7673_14024# a_7803_14024# VDD.t378 sg13_lv_pmos ad=0.2128p pd=1.5u as=0.3808p ps=2.92u w=1.12u l=0.2u
X1386 VDD.t638 a_13557_4687# a_14025_3889# VDD.t0 sg13_lv_pmos ad=0.252p pd=1.57u as=0.3808p ps=2.92u w=1.12u l=0.13u
X1387 a_13753_7532# a_13557_7532# VDD.t392 VDD.t345 sg13_lv_pmos ad=0.3808p pd=2.92u as=0.2128p ps=1.5u w=1.12u l=0.13u
X1388 VSS.t1671 a_4187_1764.t98 VSS.t1673 VSS.t1672 sg13_lv_nmos ad=1.33p pd=7.38u as=0 ps=0 w=7u l=7u
X1389 a_4871_8160# a_4633_7532# a_4763_7532# VDD.t345 sg13_lv_pmos ad=0.2128p pd=1.5u as=0.3808p ps=2.92u w=1.12u l=0.2u
X1390 VSS.t982 a_3171_6737.t9 a_5844_6698# VSS.t1393 sg13_lv_nmos ad=0.2516p pd=2.16u as=0.2516p ps=2.16u w=0.74u l=0.13u
X1391 a_4248_6734# a_4157_7003# VDD.t606 VDD.t9 sg13_lv_pmos ad=0.2128p pd=1.5u as=0.3808p ps=2.92u w=1.12u l=0.13u
X1392 VSS.t939 a_22677_4687# a_23145_3889# VSS.t938 sg13_lv_nmos ad=0.1665p pd=1.19u as=0.2516p ps=2.16u w=0.74u l=0.13u
X1393 VSS.t536 a_4187_1764.t51 a_14751_4687# VSS.t1753 sg13_lv_nmos ad=0.2516p pd=2.16u as=0.1406p ps=1.12u w=0.74u l=0.6u
X1394 VDD.t1306 a_1721_16422# a_2019_16074.t0 VDD.t34 sg13_lv_pmos ad=0.4256p pd=3u as=0.2128p ps=1.5u w=1.12u l=0.13u
X1395 VDD.t985 a_4187_2434# a_8671_14652# VDD.t378 sg13_lv_pmos ad=0.3808p pd=2.92u as=0.2128p ps=1.5u w=1.12u l=0.6u
X1396 VDD.t376 a_1256_3889# a_2873_4240# VDD.t0 sg13_lv_pmos ad=0.1918p pd=1.5u as=0.1596p ps=1.22u w=0.84u l=0.13u
X1397 VDD.t936 a_26043_14024# a_26477_14024# VDD.t378 sg13_lv_pmos ad=0.2128p pd=1.5u as=0.3808p ps=2.92u w=1.12u l=0.13u
X1398 VDD.t552 a_2595_3156.t3 a_8745_3364# VDD.t0 sg13_lv_pmos ad=0.3808p pd=2.92u as=0.3808p ps=2.92u w=1.12u l=0.13u
X1399 a_25630_1044# a_26471_1008# a_26395_1044# VDD.t67 sg13_lv_pmos ad=0.3808p pd=2.92u as=0.2128p ps=1.5u w=1.12u l=0.13u
X1400 a_3171_6001.t1 a_2873_6021# VSS.t331 VSS.t977 sg13_lv_nmos ad=0.1406p pd=1.12u as=0.1331p ps=1.12u w=0.74u l=0.13u
X1401 a_27915_13226# a_27705_13226# VSS.t1368 VSS.t2078 sg13_lv_nmos ad=0.1406p pd=1.12u as=0.1665p ps=1.19u w=0.74u l=0.13u
X1402 VDD.t1545 a_3747_13229.t4 a_21911_13190# VDD.t2 sg13_lv_pmos ad=0.3808p pd=2.92u as=0.3808p ps=2.92u w=1.12u l=0.13u
X1403 VSS.t1109 a_2595_6737.t7 a_11271_6698# VSS.t1386 sg13_lv_nmos ad=0.2516p pd=2.16u as=0.2516p ps=2.16u w=0.74u l=0.13u
X1404 VSS.t113 a_4187_1764.t77 a_19311_7532# VSS.t112 sg13_lv_nmos ad=0.2516p pd=2.16u as=0.1406p ps=1.12u w=0.74u l=0.6u
X1405 a_21591_5315# a_21353_4687# a_21483_4687# VDD.t347 sg13_lv_pmos ad=0.2128p pd=1.5u as=0.3808p ps=2.92u w=1.12u l=0.2u
X1406 VSS.t331 a_2297_6021# a_2595_6001.t1 VSS.t546 sg13_lv_nmos ad=0.2812p pd=2.24u as=0.1406p ps=1.12u w=0.74u l=0.13u
X1407 a_26395_16071# a_26185_16071# VSS.t2004 VSS.t2003 sg13_lv_nmos ad=0.1406p pd=1.12u as=0.1665p ps=1.19u w=0.74u l=0.13u
X1408 VSS.t1561 VSS.t1561 VSS.t1563 VSS.t1562 sg13_lv_nmos ad=0.68p pd=4.68u as=0 ps=0 w=2u l=1u
X1409 VSS.t1673 a_4187_1764.t98 VSS.t1675 VSS.t1674 sg13_lv_nmos ad=1.33p pd=7.38u as=0 ps=0 w=7u l=7u
X1410 VSS.t87 a_4187_1764.t65 a_4111_4687# VSS.t1163 sg13_lv_nmos ad=0.2516p pd=2.16u as=0.1406p ps=1.12u w=0.74u l=0.6u
X1411 a_6153_4687# a_5957_4687# VDD.t836 VDD.t347 sg13_lv_pmos ad=0.3808p pd=2.92u as=0.2128p ps=1.5u w=1.12u l=0.13u
X1412 a_23355_13226# a_23145_13226# VSS.t2098 VSS.t2097 sg13_lv_nmos ad=0.1406p pd=1.12u as=0.1665p ps=1.19u w=0.74u l=0.13u
X1413 a_2595_12493.t1 a_2297_12513# VSS.t771 VSS.t770 sg13_lv_nmos ad=0.1406p pd=1.12u as=0.1331p ps=1.12u w=0.74u l=0.13u
X1414 a_19550_6734# a_21911_6698# a_21835_6734# VDD.t9 sg13_lv_pmos ad=0.3808p pd=2.92u as=0.2128p ps=1.5u w=1.12u l=0.13u
X1415 VSS.t1279 a_2873_16422# a_3171_16074.t1 VSS.t1281 sg13_lv_nmos ad=0.2812p pd=2.24u as=0.1406p ps=1.12u w=0.74u l=0.13u
X1416 VDD.t509 a_16163_4687# a_16597_4687# VDD.t347 sg13_lv_pmos ad=0.2128p pd=1.5u as=0.3808p ps=2.92u w=1.12u l=0.13u
X1417 a_16033_1842# a_15837_1842# VDD.t677 VDD.t379 sg13_lv_pmos ad=0.3808p pd=2.92u as=0.2128p ps=1.5u w=1.12u l=0.13u
X1418 VDD.t1138 a_24523_7532# a_24957_7532# VDD.t345 sg13_lv_pmos ad=0.2128p pd=1.5u as=0.3808p ps=2.92u w=1.12u l=0.13u
X1419 a_7151_2470# a_6913_1842# a_7043_1842# VDD.t379 sg13_lv_pmos ad=0.2128p pd=1.5u as=0.3808p ps=2.92u w=1.12u l=0.2u
X1420 VDD.t630 a_15964_289# a_16851_309# VDD.t67 sg13_lv_pmos ad=0.2086p pd=1.5u as=0.34p ps=2.68u w=1u l=0.13u
X1421 a_24631_17497# a_24393_16869# a_24523_16869# VDD.t368 sg13_lv_pmos ad=0.2128p pd=1.5u as=0.3808p ps=2.92u w=1.12u l=0.2u
X1422 VSS.t1003 a_3747_6737.t8 a_9751_6698# VSS.t1869 sg13_lv_nmos ad=0.2516p pd=2.16u as=0.2516p ps=2.16u w=0.74u l=0.13u
X1423 VDD.t152 VSS.t439 VDD.t151 VDD.t67 sg13_lv_pmos ad=0.34p pd=2.68u as=0 ps=0 w=1u l=1u
X1424 VSS.t27 CHAN2_MUX_SEL3 a_3543_3176# VSS.t1134 sg13_lv_nmos ad=0.1331p pd=1.12u as=0.1216p ps=1.02u w=0.64u l=0.13u
X1425 a_14751_14024# a_14513_14024# a_14643_14024# VSS.t507 sg13_lv_nmos ad=0.1406p pd=1.12u as=0.2516p ps=2.16u w=0.74u l=0.2u
X1426 a_19073_14024# a_18877_14024# VSS.t794 VSS.t793 sg13_lv_nmos ad=0.2516p pd=2.16u as=0.1406p ps=1.12u w=0.74u l=0.13u
X1427 VSS.t478 a_4187_1764.t90 a_9431_7532# VSS.t2276 sg13_lv_nmos ad=0.2516p pd=2.16u as=0.1406p ps=1.12u w=0.74u l=0.6u
X1428 VDD.t1029 a_4187_2434# a_25391_17497# VDD.t368 sg13_lv_pmos ad=0.3808p pd=2.92u as=0.2128p ps=1.5u w=1.12u l=0.6u
X1429 VDD.t1542 a_3747_13229.t9 a_6711_13190# VDD.t2 sg13_lv_pmos ad=0.3808p pd=2.92u as=0.3808p ps=2.92u w=1.12u l=0.13u
X1430 VSS.t364 VDD.t1646 VSS.t364 VSS.t367 sg13_lv_nmos ad=79.8f pd=0.8u as=0 ps=0 w=0.42u l=1u
X1431 a_20071_17497# a_19833_16869# a_19963_16869# VDD.t368 sg13_lv_pmos ad=0.2128p pd=1.5u as=0.3808p ps=2.92u w=1.12u l=0.2u
X1432 a_2391_13577# CHAN1_MUX_SEL0 a_2297_13577# VSS.t1244 sg13_lv_nmos ad=0.1216p pd=1.02u as=0.2176p ps=1.96u w=0.64u l=0.13u
X1433 VDD.t1071 a_4187_2434# a_10191_5315# VDD.t347 sg13_lv_pmos ad=0.3808p pd=2.92u as=0.2128p ps=1.5u w=1.12u l=0.6u
X1434 VDD.t422 a_5957_1842# a_6425_1044# VDD.t67 sg13_lv_pmos ad=0.252p pd=1.57u as=0.3808p ps=2.92u w=1.12u l=0.13u
X1435 VSS.t442 VDD.t1623 VSS.t445 VSS.t444 sg13_lv_nmos ad=79.8f pd=0.8u as=0 ps=0 w=0.42u l=1u
X1436 VSS.t837 a_11603_1842# a_12037_1842# VSS.t1173 sg13_lv_nmos ad=0.1406p pd=1.12u as=0.2516p ps=2.16u w=0.74u l=0.13u
X1437 VSS.t1312 a_4187_1764.t72 a_23111_7532# VSS.t2376 sg13_lv_nmos ad=0.2516p pd=2.16u as=0.1406p ps=1.12u w=0.74u l=0.6u
X1438 VDD.t859 a_22677_7532# a_23145_6734# VDD.t9 sg13_lv_pmos ad=0.252p pd=1.57u as=0.3808p ps=2.92u w=1.12u l=0.13u
X1439 VDD.t681 a_2019_16074.t7 a_10404_16035# VDD.t34 sg13_lv_pmos ad=0.3808p pd=2.92u as=0.3808p ps=2.92u w=1.12u l=0.13u
X1440 VDD.t207 VSS.t412 VDD.t206 VDD.t67 sg13_lv_pmos ad=0.34p pd=2.68u as=0 ps=0 w=1u l=1u
X1441 VDD.t243 VSS.t344 VDD.t165 VDD.t9 sg13_lv_pmos ad=0.19p pd=1.38u as=0 ps=0 w=1u l=1u
X1442 a_6635_16071# a_6425_16071# VSS.t1834 VSS.t1894 sg13_lv_nmos ad=0.1406p pd=1.12u as=0.1665p ps=1.19u w=0.74u l=0.13u
X1443 VDD.t978 a_4187_2434# a_27671_8160# VDD.t345 sg13_lv_pmos ad=0.3808p pd=2.92u as=0.2128p ps=1.5u w=1.12u l=0.6u
X1444 a_3747_1047.t1 a_3449_1395# VSS.t1845 VSS.t1844 sg13_lv_nmos ad=0.1406p pd=1.12u as=0.1331p ps=1.12u w=0.74u l=0.13u
X1445 a_24393_1842# a_24197_1842# VSS.t1375 VSS.t1374 sg13_lv_nmos ad=0.2516p pd=2.16u as=0.1406p ps=1.12u w=0.74u l=0.13u
X1446 VDD.t1142 a_19963_4687# a_20397_4687# VDD.t347 sg13_lv_pmos ad=0.2128p pd=1.5u as=0.3808p ps=2.92u w=1.12u l=0.13u
X1447 VSS.t122 VDD.t1693 VSS.t218 VSS.t217 sg13_lv_nmos ad=0.1428p pd=1.52u as=0 ps=0 w=0.42u l=1u
X1448 VDD.t150 VSS.t435 VDD.t149 VDD.t67 sg13_lv_pmos ad=0.34p pd=2.68u as=0 ps=0 w=1u l=1u
X1449 a_1544_1044# CHAN3_MUX_SEL1 VSS.t2090 VSS.t1131 sg13_lv_nmos ad=0.2516p pd=2.16u as=0.2516p ps=2.16u w=0.74u l=0.13u
X1450 a_10430_3889# a_3747_3892.t7 a_12715_3889# VSS.t53 sg13_lv_nmos ad=0.2516p pd=2.16u as=0.1406p ps=1.12u w=0.74u l=0.13u
X1451 a_17031_4687# a_16793_4687# a_16923_4687# VSS.t843 sg13_lv_nmos ad=0.1406p pd=1.12u as=0.2516p ps=2.16u w=0.74u l=0.2u
X1452 a_17553_16869# a_17357_16869# VSS.t495 VSS.t1646 sg13_lv_nmos ad=0.2516p pd=2.16u as=0.1406p ps=1.12u w=0.74u l=0.13u
X1453 VDD.t457 VDD.t449 VDD.t456 VDD.t358 sg13_lv_pmos ad=0.68p pd=4.68u as=0 ps=0 w=2u l=1u
X1454 a_13470_1044# a_3747_1047.t6 a_15755_1044# VSS.t690 sg13_lv_nmos ad=0.2516p pd=2.16u as=0.1406p ps=1.12u w=0.74u l=0.13u
X1455 VDD.t232 VSS.t350 VDD.t233 VDD.t0 sg13_lv_pmos ad=0.19p pd=1.38u as=0 ps=0 w=1u l=1u
X1456 a_3171_1047.t0 a_2873_1395# VDD.t704 VDD.t67 sg13_lv_pmos ad=0.2128p pd=1.5u as=0.1918p ps=1.5u w=1.12u l=0.13u
X1457 a_24875_3889# a_24665_3889# VSS.t991 VSS.t1799 sg13_lv_nmos ad=0.1406p pd=1.12u as=0.1665p ps=1.19u w=0.74u l=0.13u
X1458 a_4871_17497# a_4633_16869# a_4763_16869# VDD.t368 sg13_lv_pmos ad=0.2128p pd=1.5u as=0.3808p ps=2.92u w=1.12u l=0.2u
X1459 VSS.t786 a_4187_1764.t163 a_4111_16869# VSS.t1739 sg13_lv_nmos ad=0.2516p pd=2.16u as=0.1406p ps=1.12u w=0.74u l=0.6u
X1460 a_9193_16869# a_8997_16869# VDD.t566 VDD.t368 sg13_lv_pmos ad=0.3808p pd=2.92u as=0.2128p ps=1.5u w=1.12u l=0.13u
X1461 VDD.t878 a_5523_1842# a_5957_1842# VDD.t379 sg13_lv_pmos ad=0.2128p pd=1.5u as=0.3808p ps=2.92u w=1.12u l=0.13u
X1462 a_9675_13226# a_9465_13226# VDD.t923 VDD.t2 sg13_lv_pmos ad=0.2128p pd=1.5u as=0.252p ps=1.57u w=1.12u l=0.13u
X1463 VSS.t2196 a_4187_1764.t99 a_4187_2434# VSS.t2195 sg13_lv_nmos ad=0.2516p pd=2.16u as=0.6808p ps=3.32u w=0.74u l=0.6u
X1464 VDD.t390 a_2297_1395# a_2595_1047.t0 VDD.t67 sg13_lv_pmos ad=0.4256p pd=3u as=0.2128p ps=1.5u w=1.12u l=0.13u
X1465 a_22590_3889# a_24084_3853# a_24008_3889# VDD.t0 sg13_lv_pmos ad=0.3808p pd=2.92u as=0.2128p ps=1.5u w=1.12u l=0.13u
X1466 a_19550_16071# a_2019_16074.t4 a_19448_16071# VSS.t1019 sg13_lv_nmos ad=0.2516p pd=2.16u as=0.1406p ps=1.12u w=0.74u l=0.13u
X1467 VDD.t586 a_2019_1047.t6 a_13444_1008# VDD.t67 sg13_lv_pmos ad=0.3808p pd=2.92u as=0.3808p ps=2.92u w=1.12u l=0.13u
X1468 VSS.t72 a_4187_1764.t19 a_14751_1842# VSS.t1012 sg13_lv_nmos ad=0.2516p pd=2.16u as=0.1406p ps=1.12u w=0.74u l=0.6u
X1469 VSS.t1203 a_2595_3892.t3 a_23431_3853# VSS.t1770 sg13_lv_nmos ad=0.2516p pd=2.16u as=0.2516p ps=2.16u w=0.74u l=0.13u
X1470 VDD.t987 a_4187_2434# a_5631_17497# VDD.t368 sg13_lv_pmos ad=0.3808p pd=2.92u as=0.2128p ps=1.5u w=1.12u l=0.6u
X1471 VDD.t756 a_23003_16869# a_23437_16869# VDD.t368 sg13_lv_pmos ad=0.2128p pd=1.5u as=0.3808p ps=2.92u w=1.12u l=0.13u
X1472 a_4350_16071# a_5191_16035# a_5115_16071# VDD.t34 sg13_lv_pmos ad=0.3808p pd=2.92u as=0.2128p ps=1.5u w=1.12u l=0.13u
X1473 VSS.t1434 a_2595_1047.t2 a_26471_1008# VSS.t1919 sg13_lv_nmos ad=0.2516p pd=2.16u as=0.2516p ps=2.16u w=0.74u l=0.13u
X1474 a_4350_1044# a_2595_1047.t9 a_5115_1044# VSS.t676 sg13_lv_nmos ad=0.2516p pd=2.16u as=0.1406p ps=1.12u w=0.74u l=0.13u
X1475 a_2967_1395# CHAN3_MUX_SEL1 a_2873_1395# VSS.t1133 sg13_lv_nmos ad=0.1216p pd=1.02u as=0.2176p ps=1.96u w=0.64u l=0.13u
X1476 VSS.t1143 CHAN2_MUX_SEL4 a_15765_3308# VSS.t1142 sg13_lv_nmos ad=0.2516p pd=2.16u as=0.2516p ps=2.16u w=0.74u l=0.13u
X1477 a_2595_311.t1 a_2297_331# VSS.t18 VSS.t725 sg13_lv_nmos ad=0.1406p pd=1.12u as=0.1331p ps=1.12u w=0.74u l=0.13u
X1478 VSS.t5 VDD.t1705 VSS.t5 VSS.t190 sg13_lv_nmos ad=0.1428p pd=1.52u as=0 ps=0 w=0.42u l=1u
X1479 VSS.t778 a_13557_4687# a_14025_3889# VSS.t777 sg13_lv_nmos ad=0.1665p pd=1.19u as=0.2516p ps=2.16u w=0.74u l=0.13u
X1480 a_9946_11995# a_10751_11568# a_10206_11525# VDD.t358 sg13_lv_pmos ad=0.1428p pd=1.52u as=79.8f ps=0.8u w=0.42u l=0.13u
X1481 VSS.t600 a_16597_1842# a_17065_1044# VSS.t972 sg13_lv_nmos ad=0.1665p pd=1.19u as=0.2516p ps=2.16u w=0.74u l=0.13u
X1482 a_2297_1395# CHAN3_MUX_SEL0 VDD.t1430 VDD.t67 sg13_lv_pmos ad=0.1596p pd=1.22u as=0.2856p ps=2.36u w=0.84u l=0.13u
X1483 VSS.t1871 a_4187_1764.t33 a_4111_1842# VSS.t1870 sg13_lv_nmos ad=0.2516p pd=2.16u as=0.1406p ps=1.12u w=0.74u l=0.6u
X1484 VSS.t284 VDD.t1676 VSS.t284 VSS.t283 sg13_lv_nmos ad=0.1428p pd=1.52u as=0 ps=0 w=0.42u l=1u
X1485 a_12943_11557# a_13121_11521# VDD.t359 VDD.t358 sg13_lv_pmos ad=0.3808p pd=2.92u as=0.2128p ps=1.5u w=1.12u l=0.13u
X1486 VSS.t303 VDD.t1669 VSS.t303 VSS.t307 sg13_lv_nmos ad=0.1428p pd=1.52u as=0 ps=0 w=0.42u l=1u
X1487 VSS.t524 a_6283_16869# a_6717_16869# VSS.t606 sg13_lv_nmos ad=0.1406p pd=1.12u as=0.2516p ps=2.16u w=0.74u l=0.13u
X1488 a_25630_13226# a_2595_13229.t2 a_26395_13226# VSS.t1299 sg13_lv_nmos ad=0.2516p pd=2.16u as=0.1406p ps=1.12u w=0.74u l=0.13u
X1489 a_16033_7532# a_15837_7532# VDD.t400 VDD.t345 sg13_lv_pmos ad=0.3808p pd=2.92u as=0.2128p ps=1.5u w=1.12u l=0.13u
X1490 VDD.t632 a_1544_1044# a_1721_1395# VDD.t67 sg13_lv_pmos ad=0.1918p pd=1.5u as=0.1596p ps=1.22u w=0.84u l=0.13u
X1491 VDD.t1097 a_4187_2434# a_8671_2470# VDD.t379 sg13_lv_pmos ad=0.3808p pd=2.92u as=0.2128p ps=1.5u w=1.12u l=0.6u
X1492 a_20831_4687# a_20593_4687# a_20723_4687# VSS.t2223 sg13_lv_nmos ad=0.1406p pd=1.12u as=0.2516p ps=2.16u w=0.74u l=0.2u
X1493 a_1815_16422# a_1256_16071# a_1721_16422# VSS.t1277 sg13_lv_nmos ad=0.1216p pd=1.02u as=0.2176p ps=1.96u w=0.64u l=0.13u
X1494 VSS.t561 a_15108_11799# a_14757_11918# VSS.t560 sg13_lv_nmos ad=79.8f pd=0.8u as=0.1428p ps=1.52u w=0.42u l=0.13u
X1495 a_7151_8160# a_6913_7532# a_7043_7532# VDD.t345 sg13_lv_pmos ad=0.2128p pd=1.5u as=0.3808p ps=2.92u w=1.12u l=0.2u
X1496 a_5393_4687# a_5197_4687# VSS.t152 VSS.t1115 sg13_lv_nmos ad=0.2516p pd=2.16u as=0.1406p ps=1.12u w=0.74u l=0.13u
X1497 VSS.t889 a_4187_1764.t48 a_17031_4687# VSS.t1738 sg13_lv_nmos ad=0.2516p pd=2.16u as=0.1406p ps=1.12u w=0.74u l=0.6u
X1498 a_16510_13226# a_18004_13190# a_17928_13226# VDD.t2 sg13_lv_pmos ad=0.3808p pd=2.92u as=0.2128p ps=1.5u w=1.12u l=0.13u
X1499 VDD.t189 VSS.t410 VDD.t188 VDD.t67 sg13_lv_pmos ad=0.19p pd=1.38u as=0 ps=0 w=1u l=1u
X1500 a_24631_14652# a_24393_14024# a_24523_14024# VDD.t378 sg13_lv_pmos ad=0.2128p pd=1.5u as=0.3808p ps=2.92u w=1.12u l=0.2u
X1501 VSS.t350 VDD.t1651 VSS.t350 VSS.t355 sg13_lv_nmos ad=79.8f pd=0.8u as=0 ps=0 w=0.42u l=1u
X1502 a_25630_3889# a_27991_3853# a_27915_3889# VDD.t0 sg13_lv_pmos ad=0.3808p pd=2.92u as=0.2128p ps=1.5u w=1.12u l=0.13u
X1503 a_8808_16071# a_8237_16869# VSS.t1518 VSS.t1828 sg13_lv_nmos ad=0.1406p pd=1.12u as=0.2516p ps=2.16u w=0.74u l=0.13u
X1504 VSS.t1957 a_7477_14024# a_7945_13226# VSS.t1956 sg13_lv_nmos ad=0.1665p pd=1.19u as=0.2516p ps=2.16u w=0.74u l=0.13u
X1505 a_3171_12493.t1 a_2873_12513# VSS.t771 VSS.t993 sg13_lv_nmos ad=0.1406p pd=1.12u as=0.1331p ps=1.12u w=0.74u l=0.13u
X1506 a_10430_6734# a_12791_6698# a_12715_6734# VDD.t9 sg13_lv_pmos ad=0.3808p pd=2.92u as=0.2128p ps=1.5u w=1.12u l=0.13u
X1507 a_20071_14652# a_19833_14024# a_19963_14024# VDD.t378 sg13_lv_pmos ad=0.2128p pd=1.5u as=0.3808p ps=2.92u w=1.12u l=0.2u
X1508 VDD.t1048 a_4187_2434# a_25391_14652# VDD.t378 sg13_lv_pmos ad=0.3808p pd=2.92u as=0.2128p ps=1.5u w=1.12u l=0.6u
X1509 a_5768_13226# a_5197_14024# VSS.t1756 VSS.t2138 sg13_lv_nmos ad=0.1406p pd=1.12u as=0.2516p ps=2.16u w=0.74u l=0.13u
X1510 VSS.t1500 a_26803_4687# a_27237_4687# VSS.t1634 sg13_lv_nmos ad=0.1406p pd=1.12u as=0.2516p ps=2.16u w=0.74u l=0.13u
X1511 a_25630_16071# a_25604_16035# a_25528_16071# VDD.t34 sg13_lv_pmos ad=0.3808p pd=2.92u as=0.2128p ps=1.5u w=1.12u l=0.13u
X1512 a_4248_1044# a_4157_1313# VDD.t1248 VDD.t67 sg13_lv_pmos ad=0.2128p pd=1.5u as=0.3808p ps=2.92u w=1.12u l=0.13u
X1513 a_4248_16071# a_4157_16340# VSS.t1283 VSS.t1282 sg13_lv_nmos ad=0.1406p pd=1.12u as=0.2516p ps=2.16u w=0.74u l=0.13u
X1514 a_19448_16071# a_18877_16869# VDD.t1580 VDD.t34 sg13_lv_pmos ad=0.2128p pd=1.5u as=0.3808p ps=2.92u w=1.12u l=0.13u
X1515 VSS.t858 a_11603_7532# a_12037_7532# VSS.t2285 sg13_lv_nmos ad=0.1406p pd=1.12u as=0.2516p ps=2.16u w=0.74u l=0.13u
X1516 a_24875_6734# a_24665_6734# VDD.t395 VDD.t9 sg13_lv_pmos ad=0.2128p pd=1.5u as=0.252p ps=1.57u w=1.12u l=0.13u
X1517 a_20593_16869# a_20397_16869# VDD.t868 VDD.t368 sg13_lv_pmos ad=0.3808p pd=2.92u as=0.2128p ps=1.5u w=1.12u l=0.13u
X1518 a_18551_16869# a_18313_16869# a_18443_16869# VSS.t493 sg13_lv_nmos ad=0.1406p pd=1.12u as=0.2516p ps=2.16u w=0.74u l=0.2u
X1519 VDD.t568 a_13883_16869# a_14317_16869# VDD.t368 sg13_lv_pmos ad=0.2128p pd=1.5u as=0.3808p ps=2.92u w=1.12u l=0.13u
X1520 VDD.t180 VSS.t391 VDD.t179 VDD.t0 sg13_lv_pmos ad=0.19p pd=1.38u as=0 ps=0 w=1u l=1u
X1521 a_3747_6737.t1 a_3449_7085# VSS.t1127 VSS.t1126 sg13_lv_nmos ad=0.1406p pd=1.12u as=0.1331p ps=1.12u w=0.74u l=0.13u
X1522 a_11473_4687# a_11277_4687# VDD.t393 VDD.t347 sg13_lv_pmos ad=0.3808p pd=2.92u as=0.2128p ps=1.5u w=1.12u l=0.13u
X1523 VDD.t914 a_2595_6737.t3 a_23431_6698# VDD.t9 sg13_lv_pmos ad=0.3808p pd=2.92u as=0.3808p ps=2.92u w=1.12u l=0.13u
X1524 a_7390_16071# a_3747_16074.t8 a_9675_16071# VSS.t1895 sg13_lv_nmos ad=0.2516p pd=2.16u as=0.1406p ps=1.12u w=0.74u l=0.13u
X1525 a_24393_7532# a_24197_7532# VSS.t107 VSS.t106 sg13_lv_nmos ad=0.2516p pd=2.16u as=0.1406p ps=1.12u w=0.74u l=0.13u
X1526 VSS.t901 a_2595_16074.t4 a_20391_16035# VSS.t900 sg13_lv_nmos ad=0.2516p pd=2.16u as=0.2516p ps=2.16u w=0.74u l=0.13u
X1527 a_1544_6734# REF_MUX_SEL1 VSS.t1400 VSS.t1399 sg13_lv_nmos ad=0.2516p pd=2.16u as=0.2516p ps=2.16u w=0.74u l=0.13u
X1528 a_4350_13226# a_3747_13229.t9 a_6635_13226# VSS.t2255 sg13_lv_nmos ad=0.2516p pd=2.16u as=0.1406p ps=1.12u w=0.74u l=0.13u
X1529 a_17031_1842# a_16793_1842# a_16923_1842# VSS.t1477 sg13_lv_nmos ad=0.1406p pd=1.12u as=0.2516p ps=2.16u w=0.74u l=0.2u
X1530 a_13470_6734# a_3747_6737.t6 a_15755_6734# VSS.t1788 sg13_lv_nmos ad=0.2516p pd=2.16u as=0.1406p ps=1.12u w=0.74u l=0.13u
X1531 a_7288_13226# a_6717_14024# VDD.t1353 VDD.t2 sg13_lv_pmos ad=0.2128p pd=1.5u as=0.3808p ps=2.92u w=1.12u l=0.13u
X1532 VSS.t262 VDD.t1681 VSS.t265 VSS.t264 sg13_lv_nmos ad=79.8f pd=0.8u as=0 ps=0 w=0.42u l=1u
X1533 a_12471_2470# a_12233_1842# a_12363_1842# VDD.t379 sg13_lv_pmos ad=0.2128p pd=1.5u as=0.3808p ps=2.92u w=1.12u l=0.2u
X1534 a_13592_11561# a_14111_11568# a_14851_11918# VSS.t560 sg13_lv_nmos ad=0.3473p pd=2.71u as=0.12665p ps=1.145u w=0.74u l=0.13u
X1535 VDD.t391 a_13557_7532# a_14025_6734# VDD.t9 sg13_lv_pmos ad=0.252p pd=1.57u as=0.3808p ps=2.92u w=1.12u l=0.13u
X1536 a_19550_1044# a_21911_1008# a_21835_1044# VDD.t67 sg13_lv_pmos ad=0.3808p pd=2.92u as=0.2128p ps=1.5u w=1.12u l=0.13u
X1537 VSS.t18 a_1721_331# a_2019_311# VSS.t2310 sg13_lv_nmos ad=0.2812p pd=2.24u as=0.1406p ps=1.12u w=0.74u l=0.13u
X1538 a_4871_14652# a_4633_14024# a_4763_14024# VDD.t378 sg13_lv_pmos ad=0.2128p pd=1.5u as=0.3808p ps=2.92u w=1.12u l=0.2u
X1539 VDD.t807 a_15464_9374# a_9712_9602# VSS.t1145 sg13_lv_nmos ad=0.232p pd=2.08u as=0.136p ps=1.14u w=0.4u l=0.2u
X1540 a_9193_14024# a_8997_14024# VDD.t922 VDD.t378 sg13_lv_pmos ad=0.3808p pd=2.92u as=0.2128p ps=1.5u w=1.12u l=0.13u
X1541 VDD.t563 a_5523_7532# a_5957_7532# VDD.t345 sg13_lv_pmos ad=0.2128p pd=1.5u as=0.3808p ps=2.92u w=1.12u l=0.13u
X1542 a_14851_10872# a_14009_10774# a_13592_11113# VDD.t358 sg13_lv_pmos ad=0.2048p pd=1.63u as=0.34p ps=2.68u w=1u l=0.13u
X1543 VSS.t1000 a_4187_1764.t83 a_14751_7532# VSS.t2367 sg13_lv_nmos ad=0.2516p pd=2.16u as=0.1406p ps=1.12u w=0.74u l=0.6u
X1544 a_3449_15358# CHAN0_MUX_SEL2 VDD.t862 VDD.t34 sg13_lv_pmos ad=0.1596p pd=1.22u as=0.2856p ps=2.36u w=0.84u l=0.13u
X1545 a_6854_11144# a_6326_10280# VDD.t668 VDD.t358 sg13_lv_pmos ad=0.38p pd=2.38u as=0.38p ps=2.38u w=2u l=1u
X1546 VDD.t995 a_4187_2434# a_5631_14652# VDD.t378 sg13_lv_pmos ad=0.3808p pd=2.92u as=0.2128p ps=1.5u w=1.12u l=0.6u
X1547 VDD.t1399 a_2595_13229.t3 a_23431_13190# VDD.t2 sg13_lv_pmos ad=0.3808p pd=2.92u as=0.3808p ps=2.92u w=1.12u l=0.13u
X1548 VSS.t243 VDD.t1686 VSS.t246 VSS.t245 sg13_lv_nmos ad=79.8f pd=0.8u as=0 ps=0 w=0.42u l=1u
X1549 VSS.t1081 a_2595_6737.t2 a_26471_6698# VSS.t1080 sg13_lv_nmos ad=0.2516p pd=2.16u as=0.2516p ps=2.16u w=0.74u l=0.13u
X1550 VSS.t18 a_2297_331# a_2595_311.t1 VSS.t726 sg13_lv_nmos ad=0.2812p pd=2.24u as=0.1406p ps=1.12u w=0.74u l=0.13u
X1551 VDD.t931 a_23003_14024# a_23437_14024# VDD.t378 sg13_lv_pmos ad=0.2128p pd=1.5u as=0.3808p ps=2.92u w=1.12u l=0.13u
X1552 a_2967_7085# REF_MUX_SEL1 a_2873_7085# VSS.t1401 sg13_lv_nmos ad=0.1216p pd=1.02u as=0.2176p ps=1.96u w=0.64u l=0.13u
X1553 a_4350_6734# a_2595_6737.t9 a_5115_6734# VSS.t1053 sg13_lv_nmos ad=0.2516p pd=2.16u as=0.1406p ps=1.12u w=0.74u l=0.13u
X1554 a_16108_289# a_26985_519# a_25630_1044# VDD.t67 sg13_lv_pmos ad=0.3808p pd=2.92u as=0.3808p ps=2.92u w=1.12u l=0.13u
X1555 a_27915_16071# a_27705_16071# VSS.t1217 VSS.t1998 sg13_lv_nmos ad=0.1406p pd=1.12u as=0.1665p ps=1.19u w=0.74u l=0.13u
X1556 VDD.t339 VSS.t303 VDD.t338 VDD.t9 sg13_lv_pmos ad=0.34p pd=2.68u as=0 ps=0 w=1u l=1u
X1557 a_24875_13226# a_24665_13226# VSS.t583 VSS.t2096 sg13_lv_nmos ad=0.1406p pd=1.12u as=0.1665p ps=1.19u w=0.74u l=0.13u
X1558 a_7390_13226# a_8231_13190# a_8155_13226# VDD.t2 sg13_lv_pmos ad=0.3808p pd=2.92u as=0.2128p ps=1.5u w=1.12u l=0.13u
X1559 VDD.t741 a_2873_12513# a_3171_12493.t0 VDD.t2 sg13_lv_pmos ad=0.4256p pd=3u as=0.2128p ps=1.5u w=1.12u l=0.13u
X1560 a_16510_16071# a_16484_16035# a_16408_16071# VDD.t34 sg13_lv_pmos ad=0.3808p pd=2.92u as=0.2128p ps=1.5u w=1.12u l=0.13u
X1561 VSS.t16 a_4187_1764.t97 a_4111_7532# VSS.t1732 sg13_lv_nmos ad=0.2516p pd=2.16u as=0.1406p ps=1.12u w=0.74u l=0.6u
X1562 a_18795_1044# a_18585_1044# VSS.t1138 VSS.t1137 sg13_lv_nmos ad=0.1406p pd=1.12u as=0.1665p ps=1.19u w=0.74u l=0.13u
X1563 a_19311_4687# a_19073_4687# a_19203_4687# VSS.t624 sg13_lv_nmos ad=0.1406p pd=1.12u as=0.2516p ps=2.16u w=0.74u l=0.2u
X1564 VSS.t139 a_16597_7532# a_17065_6734# VSS.t138 sg13_lv_nmos ad=0.1665p pd=1.19u as=0.2516p ps=2.16u w=0.74u l=0.13u
X1565 a_23355_16071# a_23145_16071# VSS.t657 VSS.t2013 sg13_lv_nmos ad=0.1406p pd=1.12u as=0.1665p ps=1.19u w=0.74u l=0.13u
X1566 VSS.t147 VDD.t1635 VSS.t396 VSS.t395 sg13_lv_nmos ad=0.1428p pd=1.52u as=0 ps=0 w=0.42u l=1u
X1567 VDD.t290 VSS.t200 VDD.t289 VDD.t34 sg13_lv_pmos ad=0.34p pd=2.68u as=0 ps=0 w=1u l=1u
X1568 VDD.t607 a_22677_1842# a_23145_1044# VDD.t67 sg13_lv_pmos ad=0.252p pd=1.57u as=0.3808p ps=2.92u w=1.12u l=0.13u
X1569 a_22590_3889# a_3171_3892.t3 a_24008_3889# VSS.t1660 sg13_lv_nmos ad=0.2516p pd=2.16u as=0.1406p ps=1.12u w=0.74u l=0.13u
X1570 VDD.t1053 a_4187_2434# a_8671_8160# VDD.t345 sg13_lv_pmos ad=0.3808p pd=2.92u as=0.2128p ps=1.5u w=1.12u l=0.6u
X1571 VSS.t632 a_2595_1047.t5 a_17351_1008# VSS.t651 sg13_lv_nmos ad=0.2516p pd=2.16u as=0.2516p ps=2.16u w=0.74u l=0.13u
X1572 a_20831_1842# a_20593_1842# a_20723_1842# VSS.t1483 sg13_lv_nmos ad=0.1406p pd=1.12u as=0.2516p ps=2.16u w=0.74u l=0.2u
X1573 a_25630_1044# a_3171_1047.t2 a_27048_1044# VSS.t1722 sg13_lv_nmos ad=0.2516p pd=2.16u as=0.1406p ps=1.12u w=0.74u l=0.13u
X1574 a_5393_1842# a_5197_1842# VSS.t556 VSS.t2105 sg13_lv_nmos ad=0.2516p pd=2.16u as=0.1406p ps=1.12u w=0.74u l=0.13u
X1575 VSS.t272 VDD.t1679 VSS.t274 VSS.t273 sg13_lv_nmos ad=79.8f pd=0.8u as=0 ps=0 w=0.42u l=1u
X1576 VSS.t585 a_4187_1764.t16 a_17031_1842# VSS.t2370 sg13_lv_nmos ad=0.2516p pd=2.16u as=0.1406p ps=1.12u w=0.74u l=0.6u
X1577 a_5731_15316# a_2595_15338.t3 a_7390_16071# VSS.t1036 sg13_lv_nmos ad=0.2516p pd=2.16u as=0.2516p ps=2.16u w=0.74u l=0.13u
X1578 VSS.t701 a_1544_13226# a_1815_13577# VSS.t700 sg13_lv_nmos ad=0.1331p pd=1.12u as=0.1216p ps=1.02u w=0.64u l=0.13u
X1579 a_9953_1842# a_9757_1842# VDD.t523 VDD.t379 sg13_lv_pmos ad=0.3808p pd=2.92u as=0.2128p ps=1.5u w=1.12u l=0.13u
X1580 VSS.t37 REF_MUX_SEL3 a_3543_6021# VSS.t36 sg13_lv_nmos ad=0.1331p pd=1.12u as=0.1216p ps=1.02u w=0.64u l=0.13u
X1581 a_21591_17497# a_21353_16869# a_21483_16869# VDD.t368 sg13_lv_pmos ad=0.2128p pd=1.5u as=0.3808p ps=2.92u w=1.12u l=0.2u
X1582 VDD.t1030 a_4187_2434# a_26911_17497# VDD.t368 sg13_lv_pmos ad=0.3808p pd=2.92u as=0.2128p ps=1.5u w=1.12u l=0.6u
X1583 VDD.t848 a_10843_1842# a_11277_1842# VDD.t379 sg13_lv_pmos ad=0.2128p pd=1.5u as=0.3808p ps=2.92u w=1.12u l=0.13u
X1584 a_26395_13226# a_26185_13226# VDD.t934 VDD.t2 sg13_lv_pmos ad=0.2128p pd=1.5u as=0.252p ps=1.57u w=1.12u l=0.13u
X1585 VDD.t1091 a_4187_2434# a_25391_5315# VDD.t347 sg13_lv_pmos ad=0.3808p pd=2.92u as=0.2128p ps=1.5u w=1.12u l=0.6u
X1586 VSS.t324 VDD.t1661 VSS.t324 VSS.t327 sg13_lv_nmos ad=79.8f pd=0.8u as=0 ps=0 w=0.42u l=1u
X1587 a_16033_14024# a_15837_14024# VSS.t830 VSS.t1170 sg13_lv_nmos ad=0.2516p pd=2.16u as=0.1406p ps=1.12u w=0.74u l=0.13u
X1588 a_4350_1044# a_3171_1047.t9 a_5768_1044# VSS.t1724 sg13_lv_nmos ad=0.2516p pd=2.16u as=0.1406p ps=1.12u w=0.74u l=0.13u
X1589 a_9444_10280# a_9444_10280# VSS.t2299 VSS.t2294 sg13_lv_nmos ad=0.38p pd=2.38u as=0.68p ps=4.68u w=2u l=1u
X1590 VSS.t1487 a_26803_1842# a_27237_1842# VSS.t1486 sg13_lv_nmos ad=0.1406p pd=1.12u as=0.2516p ps=2.16u w=0.74u l=0.13u
X1591 a_8155_3889# a_7945_3889# VDD.t1311 VDD.t0 sg13_lv_pmos ad=0.2128p pd=1.5u as=0.252p ps=1.57u w=1.12u l=0.13u
X1592 a_5731_5979# a_8745_6209# a_7390_6734# VDD.t9 sg13_lv_pmos ad=0.3808p pd=2.92u as=0.3808p ps=2.92u w=1.12u l=0.13u
X1593 VDD.t988 a_4187_2434# a_22351_17497# VDD.t368 sg13_lv_pmos ad=0.3808p pd=2.92u as=0.2128p ps=1.5u w=1.12u l=0.6u
X1594 a_2391_16422# CHAN0_MUX_SEL0 a_2297_16422# VSS.t775 sg13_lv_nmos ad=0.1216p pd=1.02u as=0.2176p ps=1.96u w=0.64u l=0.13u
X1595 a_20593_14024# a_20397_14024# VDD.t822 VDD.t378 sg13_lv_pmos ad=0.3808p pd=2.92u as=0.2128p ps=1.5u w=1.12u l=0.13u
X1596 a_23111_4687# a_22873_4687# a_23003_4687# VSS.t1093 sg13_lv_nmos ad=0.1406p pd=1.12u as=0.2516p ps=2.16u w=0.74u l=0.2u
X1597 VDD.t850 a_13883_14024# a_14317_14024# VDD.t378 sg13_lv_pmos ad=0.2128p pd=1.5u as=0.3808p ps=2.92u w=1.12u l=0.13u
X1598 VDD.t662 a_6326_10280# a_6854_11676# VDD.t358 sg13_lv_pmos ad=0.38p pd=2.38u as=0.38p ps=2.38u w=2u l=1u
X1599 a_25630_3889# a_3747_3892.t2 a_27915_3889# VSS.t50 sg13_lv_nmos ad=0.2516p pd=2.16u as=0.1406p ps=1.12u w=0.74u l=0.13u
X1600 a_3747_3892.t1 a_3449_4240# VSS.t1509 VSS.t1865 sg13_lv_nmos ad=0.1406p pd=1.12u as=0.1331p ps=1.12u w=0.74u l=0.13u
X1601 a_27048_3889# a_26477_4687# VDD.t866 VDD.t0 sg13_lv_pmos ad=0.2128p pd=1.5u as=0.3808p ps=2.92u w=1.12u l=0.13u
X1602 VSS.t2231 a_17683_4687# a_18117_4687# VSS.t2230 sg13_lv_nmos ad=0.1406p pd=1.12u as=0.2516p ps=2.16u w=0.74u l=0.13u
X1603 a_17031_7532# a_16793_7532# a_16923_7532# VSS.t844 sg13_lv_nmos ad=0.1406p pd=1.12u as=0.2516p ps=2.16u w=0.74u l=0.2u
X1604 VSS.t207 VDD.t1696 VSS.t207 VSS.t211 sg13_lv_nmos ad=0.1428p pd=1.52u as=0 ps=0 w=0.42u l=1u
X1605 a_12471_8160# a_12233_7532# a_12363_7532# VDD.t345 sg13_lv_pmos ad=0.2128p pd=1.5u as=0.3808p ps=2.92u w=1.12u l=0.2u
X1606 a_10713_4687# a_10517_4687# VSS.t124 VSS.t928 sg13_lv_nmos ad=0.2516p pd=2.16u as=0.1406p ps=1.12u w=0.74u l=0.13u
X1607 a_11195_13226# a_10985_13226# VSS.t1286 VSS.t2076 sg13_lv_nmos ad=0.1406p pd=1.12u as=0.1665p ps=1.19u w=0.74u l=0.13u
X1608 a_5768_3889# a_5197_4687# VDD.t787 VDD.t0 sg13_lv_pmos ad=0.2128p pd=1.5u as=0.3808p ps=2.92u w=1.12u l=0.13u
X1609 a_6153_16869# a_5957_16869# VDD.t912 VDD.t368 sg13_lv_pmos ad=0.3808p pd=2.92u as=0.2128p ps=1.5u w=1.12u l=0.13u
X1610 a_22590_6734# a_24084_6698# a_24008_6734# VDD.t9 sg13_lv_pmos ad=0.3808p pd=2.92u as=0.2128p ps=1.5u w=1.12u l=0.13u
X1611 VSS.t1162 a_4763_14024# a_5197_14024# VSS.t2134 sg13_lv_nmos ad=0.1406p pd=1.12u as=0.2516p ps=2.16u w=0.74u l=0.13u
X1612 a_6635_13226# a_6425_13226# VDD.t728 VDD.t2 sg13_lv_pmos ad=0.2128p pd=1.5u as=0.252p ps=1.57u w=1.12u l=0.13u
X1613 a_3449_12513# CHAN1_MUX_SEL2 VDD.t418 VDD.t2 sg13_lv_pmos ad=0.1596p pd=1.22u as=0.2856p ps=2.36u w=0.84u l=0.13u
X1614 a_10649_11568# REF_CLK VDD.t364 VDD.t358 sg13_lv_pmos ad=0.4088p pd=2.97u as=1.03698p ps=6.245u w=1.12u l=0.13u
X1615 a_22488_13226# a_21917_14024# VSS.t1228 VSS.t1227 sg13_lv_nmos ad=0.1406p pd=1.12u as=0.2516p ps=2.16u w=0.74u l=0.13u
X1616 VSS.t820 a_15964_12471# a_16851_12491# VSS.t1114 sg13_lv_nmos ad=0.1371p pd=1.12u as=0.2176p ps=1.96u w=0.64u l=0.13u
X1617 a_2967_4240# CHAN2_MUX_SEL1 a_2873_4240# VSS.t35 sg13_lv_nmos ad=0.1216p pd=1.02u as=0.2176p ps=1.96u w=0.64u l=0.13u
X1618 a_10430_1044# a_12791_1008# a_12715_1044# VDD.t67 sg13_lv_pmos ad=0.3808p pd=2.92u as=0.2128p ps=1.5u w=1.12u l=0.13u
X1619 VSS.t1016 a_7803_4687# a_8237_4687# VSS.t1441 sg13_lv_nmos ad=0.1406p pd=1.12u as=0.2516p ps=2.16u w=0.74u l=0.13u
X1620 VDD.t239 VSS.t350 VDD.t238 VDD.t0 sg13_lv_pmos ad=0.34p pd=2.68u as=0 ps=0 w=1u l=1u
X1621 a_18795_6734# a_18585_6734# VSS.t707 VSS.t2232 sg13_lv_nmos ad=0.1406p pd=1.12u as=0.1665p ps=1.19u w=0.74u l=0.13u
X1622 a_19311_1842# a_19073_1842# a_19203_1842# VSS.t2251 sg13_lv_nmos ad=0.1406p pd=1.12u as=0.2516p ps=2.16u w=0.74u l=0.2u
X1623 a_25630_13226# a_3747_13229.t2 a_27915_13226# VSS.t2257 sg13_lv_nmos ad=0.2516p pd=2.16u as=0.1406p ps=1.12u w=0.74u l=0.13u
X1624 a_24875_1044# a_24665_1044# VDD.t942 VDD.t67 sg13_lv_pmos ad=0.2128p pd=1.5u as=0.252p ps=1.57u w=1.12u l=0.13u
X1625 a_25630_16071# a_2595_16074.t2 a_26395_16071# VSS.t1519 sg13_lv_nmos ad=0.2516p pd=2.16u as=0.1406p ps=1.12u w=0.74u l=0.13u
X1626 VDD.t86 VSS.t224 VDD.t85 VDD.t34 sg13_lv_pmos ad=0.19p pd=1.38u as=0 ps=0 w=1u l=1u
X1627 a_19550_13226# a_19524_13190# a_19448_13226# VDD.t2 sg13_lv_pmos ad=0.3808p pd=2.92u as=0.2128p ps=1.5u w=1.12u l=0.13u
X1628 a_20831_7532# a_20593_7532# a_20723_7532# VSS.t1781 sg13_lv_nmos ad=0.1406p pd=1.12u as=0.2516p ps=2.16u w=0.74u l=0.2u
X1629 VSS.t550 a_2595_6737.t5 a_17351_6698# VSS.t1381 sg13_lv_nmos ad=0.2516p pd=2.16u as=0.2516p ps=2.16u w=0.74u l=0.13u
X1630 a_5393_7532# a_5197_7532# VSS.t980 VSS.t979 sg13_lv_nmos ad=0.2516p pd=2.16u as=0.1406p ps=1.12u w=0.74u l=0.13u
X1631 a_25630_6734# a_3171_6737.t2 a_27048_6734# VSS.t1390 sg13_lv_nmos ad=0.2516p pd=2.16u as=0.1406p ps=1.12u w=0.74u l=0.13u
X1632 VDD.t1230 a_2595_1047.t3 a_23431_1008# VDD.t67 sg13_lv_pmos ad=0.3808p pd=2.92u as=0.3808p ps=2.92u w=1.12u l=0.13u
X1633 a_22590_13226# a_2595_13229.t3 a_23355_13226# VSS.t2045 sg13_lv_nmos ad=0.2516p pd=2.16u as=0.1406p ps=1.12u w=0.74u l=0.13u
X1634 VSS.t224 VDD.t1691 VSS.t226 VSS.t225 sg13_lv_nmos ad=0.1428p pd=1.52u as=0 ps=0 w=0.42u l=1u
X1635 VSS.t771 a_2297_12513# a_2595_12493.t1 VSS.t772 sg13_lv_nmos ad=0.2812p pd=2.24u as=0.1406p ps=1.12u w=0.74u l=0.13u
X1636 VSS.t552 a_4187_1764.t80 a_17031_7532# VSS.t2272 sg13_lv_nmos ad=0.2516p pd=2.16u as=0.1406p ps=1.12u w=0.74u l=0.6u
X1637 VSS.t1341 a_8997_14024# a_9465_13226# VSS.t1340 sg13_lv_nmos ad=0.1665p pd=1.19u as=0.2516p ps=2.16u w=0.74u l=0.13u
X1638 VDD.t142 VSS.t324 VDD.t140 VDD.t9 sg13_lv_pmos ad=0.19p pd=1.38u as=0 ps=0 w=1u l=1u
X1639 a_9953_7532# a_9757_7532# VDD.t508 VDD.t345 sg13_lv_pmos ad=0.3808p pd=2.92u as=0.2128p ps=1.5u w=1.12u l=0.13u
X1640 a_25630_6734# a_27991_6698# a_27915_6734# VDD.t9 sg13_lv_pmos ad=0.3808p pd=2.92u as=0.2128p ps=1.5u w=1.12u l=0.13u
X1641 a_20315_16071# a_20105_16071# VDD.t1242 VDD.t34 sg13_lv_pmos ad=0.2128p pd=1.5u as=0.252p ps=1.57u w=1.12u l=0.13u
X1642 VDD.t1049 a_4187_2434# a_26911_14652# VDD.t378 sg13_lv_pmos ad=0.3808p pd=2.92u as=0.2128p ps=1.5u w=1.12u l=0.6u
X1643 VDD.t784 a_10843_7532# a_11277_7532# VDD.t345 sg13_lv_pmos ad=0.2128p pd=1.5u as=0.3808p ps=2.92u w=1.12u l=0.13u
X1644 VSS.t1447 a_7477_16869# a_7945_16071# VSS.t1446 sg13_lv_nmos ad=0.1665p pd=1.19u as=0.2516p ps=2.16u w=0.74u l=0.13u
X1645 a_21591_14652# a_21353_14024# a_21483_14024# VDD.t378 sg13_lv_pmos ad=0.2128p pd=1.5u as=0.3808p ps=2.92u w=1.12u l=0.2u
X1646 a_16108_5979# a_2019_6001.t2 a_16510_6734# VSS.t1890 sg13_lv_nmos ad=0.2516p pd=2.16u as=0.2516p ps=2.16u w=0.74u l=0.13u
X1647 a_4350_6734# a_3171_6737.t9 a_5768_6734# VSS.t1392 sg13_lv_nmos ad=0.2516p pd=2.16u as=0.1406p ps=1.12u w=0.74u l=0.13u
X1648 VDD.t365 a_13557_1842# a_14025_1044# VDD.t67 sg13_lv_pmos ad=0.252p pd=1.57u as=0.3808p ps=2.92u w=1.12u l=0.13u
X1649 CHAN2_MUX_OUT a_16851_3154# VDD.t1461 VDD.t0 sg13_lv_pmos ad=0.2128p pd=1.5u as=0.2086p ps=1.5u w=1.12u l=0.13u
X1650 a_5768_16071# a_5197_16869# VSS.t85 VSS.t1641 sg13_lv_nmos ad=0.1406p pd=1.12u as=0.2516p ps=2.16u w=0.74u l=0.13u
X1651 VSS.t825 a_26803_7532# a_27237_7532# VSS.t1398 sg13_lv_nmos ad=0.1406p pd=1.12u as=0.2516p ps=2.16u w=0.74u l=0.13u
X1652 a_5731_3134# a_8745_3364# a_7390_3889# VDD.t0 sg13_lv_pmos ad=0.3808p pd=2.92u as=0.3808p ps=2.92u w=1.12u l=0.13u
X1653 VDD.t1014 a_4187_2434# a_22351_14652# VDD.t378 sg13_lv_pmos ad=0.3808p pd=2.92u as=0.2128p ps=1.5u w=1.12u l=0.6u
X1654 VSS.t5 VDD.t1706 VSS.t5 VSS.t189 sg13_lv_nmos ad=79.8f pd=0.8u as=0 ps=0 w=0.42u l=1u
X1655 a_26673_4687# a_26477_4687# VDD.t865 VDD.t347 sg13_lv_pmos ad=0.3808p pd=2.92u as=0.2128p ps=1.5u w=1.12u l=0.13u
X1656 VDD.t738 a_24197_4687# a_24665_3889# VDD.t0 sg13_lv_pmos ad=0.252p pd=1.57u as=0.3808p ps=2.92u w=1.12u l=0.13u
X1657 VDD.t364 a_9547_11862# a_9547_11632# VDD.t358 sg13_lv_pmos ad=1.10612p pd=6.66u as=0.2442p ps=2.06u w=0.66u l=0.13u
X1658 a_23111_1842# a_22873_1842# a_23003_1842# VSS.t1265 sg13_lv_nmos ad=0.1406p pd=1.12u as=0.2516p ps=2.16u w=0.74u l=0.2u
X1659 a_16510_3889# a_18004_3853# a_17928_3889# VDD.t0 sg13_lv_pmos ad=0.3808p pd=2.92u as=0.2128p ps=1.5u w=1.12u l=0.13u
X1660 VDD.t1148 a_10843_16869# a_11277_16869# VDD.t368 sg13_lv_pmos ad=0.2128p pd=1.5u as=0.3808p ps=2.92u w=1.12u l=0.13u
X1661 a_8808_13226# a_8237_14024# VDD.t1332 VDD.t2 sg13_lv_pmos ad=0.2128p pd=1.5u as=0.3808p ps=2.92u w=1.12u l=0.13u
X1662 VSS.t587 a_17683_1842# a_18117_1842# VSS.t586 sg13_lv_nmos ad=0.1406p pd=1.12u as=0.2516p ps=2.16u w=0.74u l=0.13u
X1663 a_27671_2470# a_27433_1842# a_27563_1842# VDD.t379 sg13_lv_pmos ad=0.2128p pd=1.5u as=0.3808p ps=2.92u w=1.12u l=0.2u
X1664 a_7151_17497# a_6913_16869# a_7043_16869# VDD.t368 sg13_lv_pmos ad=0.2128p pd=1.5u as=0.3808p ps=2.92u w=1.12u l=0.2u
X1665 a_4350_16071# a_3747_16074.t9 a_6635_16071# VSS.t465 sg13_lv_nmos ad=0.2516p pd=2.16u as=0.1406p ps=1.12u w=0.74u l=0.13u
X1666 VSS.t293 VDD.t1674 VSS.t292 VSS.t291 sg13_lv_nmos ad=0.1428p pd=1.52u as=0 ps=0 w=0.42u l=1u
X1667 VSS.t439 VDD.t1624 VSS.t439 VSS.t440 sg13_lv_nmos ad=79.8f pd=0.8u as=0 ps=0 w=0.42u l=1u
X1668 a_10713_1842# a_10517_1842# VSS.t1932 VSS.t1931 sg13_lv_nmos ad=0.2516p pd=2.16u as=0.1406p ps=1.12u w=0.74u l=0.13u
X1669 VDD.t1429 a_3449_3176# a_3747_3156.t0 VDD.t0 sg13_lv_pmos ad=0.4256p pd=3u as=0.2128p ps=1.5u w=1.12u l=0.13u
X1670 a_8155_3889# a_7945_3889# VSS.t1886 VSS.t1885 sg13_lv_nmos ad=0.1406p pd=1.12u as=0.1665p ps=1.19u w=0.74u l=0.13u
X1671 a_4248_13226# a_4157_13495# VDD.t1387 VDD.t2 sg13_lv_pmos ad=0.2128p pd=1.5u as=0.3808p ps=2.92u w=1.12u l=0.13u
X1672 VSS.t681 a_2019_1047.t8 a_7364_1008# VSS.t1881 sg13_lv_nmos ad=0.2516p pd=2.16u as=0.2516p ps=2.16u w=0.74u l=0.13u
X1673 a_6153_14024# a_5957_14024# VDD.t1467 VDD.t378 sg13_lv_pmos ad=0.3808p pd=2.92u as=0.2128p ps=1.5u w=1.12u l=0.13u
X1674 a_14751_4687# a_14513_4687# a_14643_4687# VSS.t2059 sg13_lv_nmos ad=0.1406p pd=1.12u as=0.2516p ps=2.16u w=0.74u l=0.2u
X1675 a_2595_16074.t0 a_2297_16422# VDD.t1262 VDD.t34 sg13_lv_pmos ad=0.2128p pd=1.5u as=0.1918p ps=1.5u w=1.12u l=0.13u
X1676 a_27048_3889# a_26477_4687# VSS.t1252 VSS.t1251 sg13_lv_nmos ad=0.1406p pd=1.12u as=0.2516p ps=2.16u w=0.74u l=0.13u
X1677 a_7390_13226# a_9751_13190# a_9675_13226# VDD.t2 sg13_lv_pmos ad=0.3808p pd=2.92u as=0.2128p ps=1.5u w=1.12u l=0.13u
X1678 VDD.t1168 a_2595_13229.t4 a_20391_13190# VDD.t2 sg13_lv_pmos ad=0.3808p pd=2.92u as=0.3808p ps=2.92u w=1.12u l=0.13u
X1679 VSS.t231 VDD.t1689 VSS.t234 VSS.t233 sg13_lv_nmos ad=79.8f pd=0.8u as=0 ps=0 w=0.42u l=1u
X1680 VDD.t1075 a_4187_2434# a_6391_5315# VDD.t347 sg13_lv_pmos ad=0.3808p pd=2.92u as=0.2128p ps=1.5u w=1.12u l=0.6u
X1681 VSS.t79 a_7803_1842# a_8237_1842# VSS.t1976 sg13_lv_nmos ad=0.1406p pd=1.12u as=0.2516p ps=2.16u w=0.74u l=0.13u
X1682 VSS.t1601 VSS.t1598 VSS.t1598 VSS.t1599 sg13_lv_nmos ad=0.1406p pd=1.12u as=0 ps=0 w=0.74u l=0.13u
X1683 a_24875_16071# a_24665_16071# VSS.t2008 VSS.t2007 sg13_lv_nmos ad=0.1406p pd=1.12u as=0.1665p ps=1.19u w=0.74u l=0.13u
X1684 VDD.t1451 a_2873_15358# a_3171_15338.t0 VDD.t34 sg13_lv_pmos ad=0.4256p pd=3u as=0.2128p ps=1.5u w=1.12u l=0.13u
X1685 VSS.t435 VDD.t1625 VSS.t437 VSS.t436 sg13_lv_nmos ad=79.8f pd=0.8u as=0 ps=0 w=0.42u l=1u
X1686 VSS.t122 a_2873_15358# a_3171_15338.t1 VSS.t77 sg13_lv_nmos ad=0.2812p pd=2.24u as=0.1406p ps=1.12u w=0.74u l=0.13u
X1687 a_19311_7532# a_19073_7532# a_19203_7532# VSS.t1802 sg13_lv_nmos ad=0.1406p pd=1.12u as=0.2516p ps=2.16u w=0.74u l=0.2u
X1688 VDD.t976 a_4187_2434# a_16271_2470# VDD.t379 sg13_lv_pmos ad=0.3808p pd=2.92u as=0.2128p ps=1.5u w=1.12u l=0.6u
X1689 VSS.t608 a_8563_16869# a_8997_16869# VSS.t2190 sg13_lv_nmos ad=0.1406p pd=1.12u as=0.2516p ps=2.16u w=0.74u l=0.13u
X1690 a_21835_13226# a_21625_13226# VSS.t580 VSS.t2106 sg13_lv_nmos ad=0.1406p pd=1.12u as=0.1665p ps=1.19u w=0.74u l=0.13u
X1691 a_13470_16071# a_13444_16035# a_13368_16071# VDD.t34 sg13_lv_pmos ad=0.3808p pd=2.92u as=0.2128p ps=1.5u w=1.12u l=0.13u
X1692 a_5768_3889# a_5197_4687# VSS.t1117 VSS.t1116 sg13_lv_nmos ad=0.1406p pd=1.12u as=0.2516p ps=2.16u w=0.74u l=0.13u
X1693 a_4111_4687# CHAN2_DELAY_IN a_4003_4687# VSS.t25 sg13_lv_nmos ad=0.1406p pd=1.12u as=0.2516p ps=2.16u w=0.74u l=0.2u
X1694 VDD.t1216 a_3171_3892.t4 a_21044_3853# VDD.t0 sg13_lv_pmos ad=0.3808p pd=2.92u as=0.3808p ps=2.92u w=1.12u l=0.13u
X1695 VSS.t416 VDD.t1630 VSS.t416 VSS.t415 sg13_lv_nmos ad=0.1428p pd=1.52u as=0 ps=0 w=0.42u l=1u
X1696 VDD.t520 a_1721_4240# a_2019_3892.t0 VDD.t0 sg13_lv_pmos ad=0.4256p pd=3u as=0.2128p ps=1.5u w=1.12u l=0.13u
X1697 VDD.t1073 a_4187_2434# a_20831_5315# VDD.t347 sg13_lv_pmos ad=0.3808p pd=2.92u as=0.2128p ps=1.5u w=1.12u l=0.6u
X1698 VDD.t853 a_26043_1842# a_26477_1842# VDD.t379 sg13_lv_pmos ad=0.2128p pd=1.5u as=0.3808p ps=2.92u w=1.12u l=0.13u
X1699 a_27915_13226# a_27705_13226# VDD.t938 VDD.t2 sg13_lv_pmos ad=0.2128p pd=1.5u as=0.252p ps=1.57u w=1.12u l=0.13u
X1700 VDD.t197 VSS.t371 VDD.t195 VDD.t0 sg13_lv_pmos ad=0.19p pd=1.38u as=0 ps=0 w=1u l=1u
X1701 VSS.t1806 a_1544_16071# a_1815_16422# VSS.t1892 sg13_lv_nmos ad=0.1331p pd=1.12u as=0.1216p ps=1.02u w=0.64u l=0.13u
X1702 a_17553_14024# a_17357_14024# VSS.t790 VSS.t789 sg13_lv_nmos ad=0.2516p pd=2.16u as=0.1406p ps=1.12u w=0.74u l=0.13u
X1703 a_5731_15316# a_2019_15338.t3 a_4350_16071# VSS.t3 sg13_lv_nmos ad=0.2516p pd=2.16u as=0.2516p ps=2.16u w=0.74u l=0.13u
X1704 a_22488_1044# a_21917_1842# VSS.t515 VSS.t514 sg13_lv_nmos ad=0.1406p pd=1.12u as=0.2516p ps=2.16u w=0.74u l=0.13u
X1705 VDD.t712 REF_MUX_SEL4 a_15765_6153# VDD.t9 sg13_lv_pmos ad=0.3808p pd=2.92u as=0.3808p ps=2.92u w=1.12u l=0.13u
X1706 VDD.t1026 a_4187_2434# a_23871_17497# VDD.t368 sg13_lv_pmos ad=0.3808p pd=2.92u as=0.2128p ps=1.5u w=1.12u l=0.6u
X1707 VSS.t875 a_4187_1764.t131 a_4111_14024# VSS.t874 sg13_lv_nmos ad=0.2516p pd=2.16u as=0.1406p ps=1.12u w=0.74u l=0.6u
X1708 a_3543_331# CHAN3_MUX_SEL2 a_3449_331# VSS.t1652 sg13_lv_nmos ad=0.1216p pd=1.02u as=0.2176p ps=1.96u w=0.64u l=0.13u
X1709 VSS.t303 VDD.t1671 VSS.t303 VSS.t302 sg13_lv_nmos ad=0.1428p pd=1.52u as=0 ps=0 w=0.42u l=1u
X1710 a_23355_13226# a_23145_13226# VDD.t1438 VDD.t2 sg13_lv_pmos ad=0.2128p pd=1.5u as=0.252p ps=1.57u w=1.12u l=0.13u
X1711 a_8155_6734# a_7945_6734# VDD.t803 VDD.t9 sg13_lv_pmos ad=0.2128p pd=1.5u as=0.252p ps=1.57u w=1.12u l=0.13u
X1712 a_22590_1044# a_24084_1008# a_24008_1044# VDD.t67 sg13_lv_pmos ad=0.3808p pd=2.92u as=0.2128p ps=1.5u w=1.12u l=0.13u
X1713 VDD.t282 VSS.t404 VDD.t280 VDD.t67 sg13_lv_pmos ad=0.19p pd=1.38u as=0 ps=0 w=1u l=1u
X1714 VSS.t780 a_13123_4687# a_13557_4687# VSS.t1179 sg13_lv_nmos ad=0.1406p pd=1.12u as=0.2516p ps=2.16u w=0.74u l=0.13u
X1715 a_10191_5315# a_9953_4687# a_10083_4687# VDD.t347 sg13_lv_pmos ad=0.2128p pd=1.5u as=0.3808p ps=2.92u w=1.12u l=0.2u
X1716 a_23111_7532# a_22873_7532# a_23003_7532# VSS.t2227 sg13_lv_nmos ad=0.1406p pd=1.12u as=0.2516p ps=2.16u w=0.74u l=0.2u
X1717 a_13106_11047# a_12907_11110# VSS.t529 VSS.t528 sg13_lv_nmos ad=0.27427p pd=2.28u as=1.45407p ps=9.445u w=0.795u l=0.13u
X1718 VDD.t1113 a_4187_2434# a_20071_2470# VDD.t379 sg13_lv_pmos ad=0.3808p pd=2.92u as=0.2128p ps=1.5u w=1.12u l=0.6u
X1719 VDD.t882 a_10843_14024# a_11277_14024# VDD.t378 sg13_lv_pmos ad=0.2128p pd=1.5u as=0.3808p ps=2.92u w=1.12u l=0.13u
X1720 a_25913_4687# a_25717_4687# VSS.t1822 VSS.t2182 sg13_lv_nmos ad=0.2516p pd=2.16u as=0.1406p ps=1.12u w=0.74u l=0.13u
X1721 a_27048_6734# a_26477_7532# VDD.t1257 VDD.t9 sg13_lv_pmos ad=0.2128p pd=1.5u as=0.3808p ps=2.92u w=1.12u l=0.13u
X1722 a_5731_12471# a_8745_12701# a_7390_13226# VDD.t2 sg13_lv_pmos ad=0.3808p pd=2.92u as=0.3808p ps=2.92u w=1.12u l=0.13u
X1723 a_27671_8160# a_27433_7532# a_27563_7532# VDD.t345 sg13_lv_pmos ad=0.2128p pd=1.5u as=0.3808p ps=2.92u w=1.12u l=0.2u
X1724 VSS.t705 a_17683_7532# a_18117_7532# VSS.t2233 sg13_lv_nmos ad=0.1406p pd=1.12u as=0.2516p ps=2.16u w=0.74u l=0.13u
X1725 a_7151_14652# a_6913_14024# a_7043_14024# VDD.t378 sg13_lv_pmos ad=0.2128p pd=1.5u as=0.3808p ps=2.92u w=1.12u l=0.2u
X1726 a_10713_7532# a_10517_7532# VSS.t871 VSS.t1501 sg13_lv_nmos ad=0.2516p pd=2.16u as=0.1406p ps=1.12u w=0.74u l=0.13u
X1727 VDD.t429 VDD.t427 VDD.t428 VDD.t368 sg13_lv_pmos ad=0.3808p pd=2.92u as=0 ps=0 w=1.12u l=0.13u
X1728 a_12715_13226# a_12505_13226# VSS.t1470 VSS.t2066 sg13_lv_nmos ad=0.1406p pd=1.12u as=0.1665p ps=1.19u w=0.74u l=0.13u
X1729 VSS.t568 a_19963_16869# a_20397_16869# VSS.t1254 sg13_lv_nmos ad=0.1406p pd=1.12u as=0.2516p ps=2.16u w=0.74u l=0.13u
X1730 a_7673_16869# a_7477_16869# VDD.t716 VDD.t368 sg13_lv_pmos ad=0.3808p pd=2.92u as=0.2128p ps=1.5u w=1.12u l=0.13u
X1731 a_11195_16071# a_10985_16071# VSS.t1153 VSS.t1955 sg13_lv_nmos ad=0.1406p pd=1.12u as=0.1665p ps=1.19u w=0.74u l=0.13u
X1732 VSS.t753 a_6283_14024# a_6717_14024# VSS.t1923 sg13_lv_nmos ad=0.1406p pd=1.12u as=0.2516p ps=2.16u w=0.74u l=0.13u
X1733 VSS.t1362 a_25717_14024# a_26185_13226# VSS.t1361 sg13_lv_nmos ad=0.1665p pd=1.19u as=0.2516p ps=2.16u w=0.74u l=0.13u
X1734 VSS.t985 a_2019_6737.t8 a_7364_6698# VSS.t1078 sg13_lv_nmos ad=0.2516p pd=2.16u as=0.2516p ps=2.16u w=0.74u l=0.13u
X1735 a_5768_6734# a_5197_7532# VDD.t732 VDD.t9 sg13_lv_pmos ad=0.2128p pd=1.5u as=0.3808p ps=2.92u w=1.12u l=0.13u
X1736 VSS.t991 a_24197_4687# a_24665_3889# VSS.t990 sg13_lv_nmos ad=0.1665p pd=1.19u as=0.2516p ps=2.16u w=0.74u l=0.13u
X1737 a_24008_13226# a_23437_14024# VSS.t1356 VSS.t1355 sg13_lv_nmos ad=0.1406p pd=1.12u as=0.2516p ps=2.16u w=0.74u l=0.13u
X1738 VDD.t1617 VSS.t458 VDD.t106 VDD.t67 sg13_lv_pmos ad=0.19p pd=1.38u as=0 ps=0 w=1u l=1u
X1739 VSS.t935 a_2873_1395# a_3171_1047.t1 VSS.t2083 sg13_lv_nmos ad=0.2812p pd=2.24u as=0.1406p ps=1.12u w=0.74u l=0.13u
X1740 a_16510_3889# a_3171_3892.t5 a_17928_3889# VSS.t1642 sg13_lv_nmos ad=0.2516p pd=2.16u as=0.1406p ps=1.12u w=0.74u l=0.13u
X1741 a_14751_1842# a_14513_1842# a_14643_1842# VSS.t1351 sg13_lv_nmos ad=0.1406p pd=1.12u as=0.2516p ps=2.16u w=0.74u l=0.2u
X1742 a_22488_16071# a_21917_16869# VSS.t476 VSS.t2160 sg13_lv_nmos ad=0.1406p pd=1.12u as=0.2516p ps=2.16u w=0.74u l=0.13u
X1743 a_25630_1044# a_27991_1008# a_27915_1044# VDD.t67 sg13_lv_pmos ad=0.3808p pd=2.92u as=0.2128p ps=1.5u w=1.12u l=0.13u
X1744 VDD.t60 VSS.t236 VDD.t59 VDD.t2 sg13_lv_pmos ad=0.34p pd=2.68u as=0 ps=0 w=1u l=1u
X1745 VSS.t1695 a_4187_1764.t98 VSS.t1693 VSS.t1678 sg13_lv_nmos ad=1.33p pd=7.38u as=0 ps=0 w=7u l=7u
X1746 VSS.t891 a_7803_7532# a_8237_7532# VSS.t2322 sg13_lv_nmos ad=0.1406p pd=1.12u as=0.2516p ps=2.16u w=0.74u l=0.13u
X1747 a_13132_11110# a_13106_11047# VDD.t364 VDD.t358 sg13_lv_pmos ad=0.3927p pd=2.99u as=1.10612p ps=6.66u w=1.155u l=0.13u
X1748 VSS.t1611 VSS.t1611 VSS.t1613 VSS.t1612 sg13_lv_nmos ad=0.1406p pd=1.12u as=0 ps=0 w=0.74u l=0.13u
X1749 VDD.t1058 a_4187_2434# a_16271_8160# VDD.t345 sg13_lv_pmos ad=0.3808p pd=2.92u as=0.2128p ps=1.5u w=1.12u l=0.6u
X1750 a_7673_4687# a_7477_4687# VDD.t649 VDD.t347 sg13_lv_pmos ad=0.3808p pd=2.92u as=0.2128p ps=1.5u w=1.12u l=0.13u
X1751 VDD.t434 VDD.t432 VDD.t433 VDD.t368 sg13_lv_pmos ad=0.3808p pd=2.92u as=0 ps=0 w=1.12u l=0.6u
X1752 a_25630_16071# a_3747_16074.t2 a_27915_16071# VSS.t468 sg13_lv_nmos ad=0.2516p pd=2.16u as=0.1406p ps=1.12u w=0.74u l=0.13u
X1753 VDD.t1016 a_4187_2434# a_10191_17497# VDD.t368 sg13_lv_pmos ad=0.3808p pd=2.92u as=0.2128p ps=1.5u w=1.12u l=0.6u
X1754 a_4111_1842# CHAN3_DELAY_IN a_4003_1842# VSS.t174 sg13_lv_nmos ad=0.1406p pd=1.12u as=0.2516p ps=2.16u w=0.74u l=0.2u
X1755 a_18551_14024# a_18313_14024# a_18443_14024# VSS.t840 sg13_lv_nmos ad=0.1406p pd=1.12u as=0.2516p ps=2.16u w=0.74u l=0.2u
X1756 a_22590_13226# a_3747_13229.t3 a_24875_13226# VSS.t2266 sg13_lv_nmos ad=0.2516p pd=2.16u as=0.1406p ps=1.12u w=0.74u l=0.13u
X1757 a_3171_16074.t0 a_2873_16422# VDD.t884 VDD.t34 sg13_lv_pmos ad=0.2128p pd=1.5u as=0.1918p ps=1.5u w=1.12u l=0.13u
X1758 VSS.t731 a_3747_311.t3 a_14825_519# VSS.t730 sg13_lv_nmos ad=0.2516p pd=2.16u as=0.2516p ps=2.16u w=0.74u l=0.13u
X1759 a_17553_1842# a_17357_1842# VDD.t559 VDD.t379 sg13_lv_pmos ad=0.3808p pd=2.92u as=0.2128p ps=1.5u w=1.12u l=0.13u
X1760 VDD.t38 VSS.t122 VDD.t36 VDD.t34 sg13_lv_pmos ad=0.19p pd=1.38u as=0 ps=0 w=1u l=1u
X1761 VSS.t18 a_1256_289# a_2967_331# VSS.t2321 sg13_lv_nmos ad=0.1331p pd=1.12u as=0.1216p ps=1.02u w=0.64u l=0.13u
X1762 VSS.t94 a_1544_1044# a_2391_1395# VSS.t769 sg13_lv_nmos ad=0.1331p pd=1.12u as=0.1216p ps=1.02u w=0.64u l=0.13u
X1763 a_22590_16071# a_2595_16074.t3 a_23355_16071# VSS.t893 sg13_lv_nmos ad=0.2516p pd=2.16u as=0.1406p ps=1.12u w=0.74u l=0.13u
X1764 VDD.t1256 a_26043_7532# a_26477_7532# VDD.t345 sg13_lv_pmos ad=0.2128p pd=1.5u as=0.3808p ps=2.92u w=1.12u l=0.13u
X1765 a_8671_2470# a_8433_1842# a_8563_1842# VDD.t379 sg13_lv_pmos ad=0.2128p pd=1.5u as=0.3808p ps=2.92u w=1.12u l=0.2u
X1766 VSS.t610 a_8997_16869# a_9465_16071# VSS.t609 sg13_lv_nmos ad=0.1665p pd=1.19u as=0.2516p ps=2.16u w=0.74u l=0.13u
X1767 a_13470_1044# a_2019_1047.t6 a_13368_1044# VSS.t660 sg13_lv_nmos ad=0.2516p pd=2.16u as=0.1406p ps=1.12u w=0.74u l=0.13u
X1768 a_2019_1047.t1 a_1721_1395# VSS.t768 VSS.t1521 sg13_lv_nmos ad=0.1406p pd=1.12u as=0.1331p ps=1.12u w=0.74u l=0.13u
X1769 VSS.t336 VDD.t1657 VSS.t336 VSS.t337 sg13_lv_nmos ad=79.8f pd=0.8u as=0 ps=0 w=0.42u l=1u
X1770 a_6854_11144# a_6854_11144# a_9444_10280# VSS.t1206 sg13_lv_nmos ad=0.38p pd=2.38u as=0.68p ps=4.68u w=2u l=1u
X1771 a_22488_6734# a_21917_7532# VSS.t798 VSS.t797 sg13_lv_nmos ad=0.1406p pd=1.12u as=0.2516p ps=2.16u w=0.74u l=0.13u
X1772 VSS.t385 a_3171_3156.t2 a_23945_3364# VSS.t576 sg13_lv_nmos ad=0.2516p pd=2.16u as=0.2516p ps=2.16u w=0.74u l=0.13u
X1773 VSS.t2 a_1256_3134# a_2967_3176# VSS.t934 sg13_lv_nmos ad=0.1331p pd=1.12u as=0.1216p ps=1.02u w=0.64u l=0.13u
X1774 VDD.t332 VSS.t303 VDD.t331 VDD.t9 sg13_lv_pmos ad=0.34p pd=2.68u as=0 ps=0 w=1u l=1u
X1775 VSS.t1234 a_3449_13577# a_3747_13229.t1 VSS.t1233 sg13_lv_nmos ad=0.2812p pd=2.24u as=0.1406p ps=1.12u w=0.74u l=0.13u
X1776 a_15964_289# a_15765_463# a_5731_289# VSS.t1200 sg13_lv_nmos ad=0.2183p pd=1.33u as=0.2516p ps=2.16u w=0.74u l=0.13u
X1777 VDD.t804 CHAN2_MUX_SEL4 a_15765_3308# VDD.t0 sg13_lv_pmos ad=0.3808p pd=2.92u as=0.3808p ps=2.92u w=1.12u l=0.13u
X1778 VSS.t1373 a_3747_6001.t3 a_14825_6209# VSS.t1372 sg13_lv_nmos ad=0.2516p pd=2.16u as=0.2516p ps=2.16u w=0.74u l=0.13u
X1779 VDD.t1010 a_4187_2434# a_23871_14652# VDD.t378 sg13_lv_pmos ad=0.3808p pd=2.92u as=0.2128p ps=1.5u w=1.12u l=0.6u
X1780 VSS.t1426 a_3171_3892.t4 a_21044_3853# VSS.t1657 sg13_lv_nmos ad=0.2516p pd=2.16u as=0.2516p ps=2.16u w=0.74u l=0.13u
X1781 a_17928_16071# a_17357_16869# VDD.t1210 VDD.t34 sg13_lv_pmos ad=0.2128p pd=1.5u as=0.3808p ps=2.92u w=1.12u l=0.13u
X1782 VDD.t1078 a_4187_2434# a_11711_5315# VDD.t347 sg13_lv_pmos ad=0.3808p pd=2.92u as=0.2128p ps=1.5u w=1.12u l=0.6u
X1783 a_3747_6001.t0 a_3449_6021# VDD.t363 VDD.t9 sg13_lv_pmos ad=0.2128p pd=1.5u as=0.1918p ps=1.5u w=1.12u l=0.13u
X1784 a_25630_13226# a_26471_13190# a_26395_13226# VDD.t2 sg13_lv_pmos ad=0.3808p pd=2.92u as=0.2128p ps=1.5u w=1.12u l=0.13u
X1785 VSS.t647 a_3171_1047.t3 a_24084_1008# VSS.t646 sg13_lv_nmos ad=0.2516p pd=2.16u as=0.2516p ps=2.16u w=0.74u l=0.13u
X1786 VSS.t796 a_13123_1842# a_13557_1842# VSS.t795 sg13_lv_nmos ad=0.1406p pd=1.12u as=0.2516p ps=2.16u w=0.74u l=0.13u
X1787 VDD.t395 a_24197_7532# a_24665_6734# VDD.t9 sg13_lv_pmos ad=0.252p pd=1.57u as=0.3808p ps=2.92u w=1.12u l=0.13u
X1788 VDD.t867 a_12363_16869# a_12797_16869# VDD.t368 sg13_lv_pmos ad=0.2128p pd=1.5u as=0.3808p ps=2.92u w=1.12u l=0.13u
X1789 VDD.t977 a_4187_2434# a_20071_8160# VDD.t345 sg13_lv_pmos ad=0.3808p pd=2.92u as=0.2128p ps=1.5u w=1.12u l=0.6u
X1790 VDD.t69 VSS.t460 VDD.t68 VDD.t67 sg13_lv_pmos ad=0.34p pd=2.68u as=0 ps=0 w=1u l=1u
X1791 a_16510_6734# a_18004_6698# a_17928_6734# VDD.t9 sg13_lv_pmos ad=0.3808p pd=2.92u as=0.2128p ps=1.5u w=1.12u l=0.13u
X1792 a_8671_17497# a_8433_16869# a_8563_16869# VDD.t368 sg13_lv_pmos ad=0.2128p pd=1.5u as=0.3808p ps=2.92u w=1.12u l=0.2u
X1793 a_25913_1842# a_25717_1842# VSS.t595 VSS.t1297 sg13_lv_nmos ad=0.2516p pd=2.16u as=0.1406p ps=1.12u w=0.74u l=0.13u
X1794 VDD.t775 a_21483_4687# a_21917_4687# VDD.t347 sg13_lv_pmos ad=0.2128p pd=1.5u as=0.3808p ps=2.92u w=1.12u l=0.13u
X1795 VDD.t1348 a_7477_14024# a_7945_13226# VDD.t2 sg13_lv_pmos ad=0.252p pd=1.57u as=0.3808p ps=2.92u w=1.12u l=0.13u
X1796 a_2297_331# CHAN3_MUX_SEL2 VDD.t1211 VDD.t67 sg13_lv_pmos ad=0.1596p pd=1.22u as=0.2856p ps=2.36u w=0.84u l=0.13u
X1797 a_4187_1764.t0 DLL_RESETN VDD.t693 VDD.t360 sg13_lv_pmos ad=0.158p pd=1.245u as=0.272p ps=2.28u w=0.8u l=0.2u
X1798 VSS.t443 VDD.t1623 VSS.t442 VSS.t441 sg13_lv_nmos ad=0.1428p pd=1.52u as=0 ps=0 w=0.42u l=1u
X1799 a_21353_1842# a_21157_1842# VDD.t876 VDD.t379 sg13_lv_pmos ad=0.3808p pd=2.92u as=0.2128p ps=1.5u w=1.12u l=0.13u
X1800 VDD.t440 VDD.t438 VDD.t439 VDD.t378 sg13_lv_pmos ad=0.3808p pd=2.92u as=0 ps=0 w=1.12u l=0.13u
X1801 a_5768_13226# a_5197_14024# VDD.t1472 VDD.t2 sg13_lv_pmos ad=0.2128p pd=1.5u as=0.3808p ps=2.92u w=1.12u l=0.13u
X1802 a_13368_3889# a_12797_4687# VDD.t754 VDD.t0 sg13_lv_pmos ad=0.2128p pd=1.5u as=0.3808p ps=2.92u w=1.12u l=0.13u
X1803 VDD.t1018 a_4187_2434# a_9431_17497# VDD.t368 sg13_lv_pmos ad=0.3808p pd=2.92u as=0.2128p ps=1.5u w=1.12u l=0.6u
X1804 VDD.t845 a_26803_16869# a_27237_16869# VDD.t368 sg13_lv_pmos ad=0.2128p pd=1.5u as=0.3808p ps=2.92u w=1.12u l=0.13u
X1805 a_16108_15316# a_3747_15338.t2 a_25630_16071# VSS.t120 sg13_lv_nmos ad=0.2516p pd=2.16u as=0.2516p ps=2.16u w=0.74u l=0.13u
X1806 a_7673_14024# a_7477_14024# VDD.t1329 VDD.t378 sg13_lv_pmos ad=0.3808p pd=2.92u as=0.2128p ps=1.5u w=1.12u l=0.13u
X1807 a_2873_331# CHAN3_MUX_SEL3 VDD.t1202 VDD.t67 sg13_lv_pmos ad=0.1596p pd=1.22u as=0.2856p ps=2.36u w=0.84u l=0.13u
X1808 VDD.t1355 a_7043_1842# a_7477_1842# VDD.t379 sg13_lv_pmos ad=0.2128p pd=1.5u as=0.3808p ps=2.92u w=1.12u l=0.13u
X1809 a_15464_9374# a_14851_10872# VDD.t543 VDD.t358 sg13_lv_pmos ad=0.4312p pd=3.01u as=0.2639p ps=1.81u w=1.12u l=0.13u
X1810 VSS.t14 a_2873_7085# a_3171_6737.t1 VSS.t1125 sg13_lv_nmos ad=0.2812p pd=2.24u as=0.1406p ps=1.12u w=0.74u l=0.13u
X1811 VSS.t310 VDD.t1666 VSS.t310 VSS.t314 sg13_lv_nmos ad=0.1428p pd=1.52u as=0 ps=0 w=0.42u l=1u
X1812 a_10430_13226# a_2595_13229.t7 a_11195_13226# VSS.t1494 sg13_lv_nmos ad=0.2516p pd=2.16u as=0.1406p ps=1.12u w=0.74u l=0.13u
X1813 a_14751_7532# a_14513_7532# a_14643_7532# VSS.t2226 sg13_lv_nmos ad=0.1406p pd=1.12u as=0.2516p ps=2.16u w=0.74u l=0.2u
X1814 VSS.t200 VDD.t1700 VSS.t200 VSS.t202 sg13_lv_nmos ad=0.1428p pd=1.52u as=0 ps=0 w=0.42u l=1u
X1815 a_6326_10280# a_6326_10280# VDD.t664 VDD.t358 sg13_lv_pmos ad=0.38p pd=2.38u as=0.38p ps=2.38u w=2u l=1u
X1816 a_5778_9057# a_6126_9506# a_6326_10280# VSS.t803 sg13_lv_nmos ad=0.68p pd=4.68u as=0.42p ps=2.42u w=2u l=1u
X1817 VSS.t1586 VSS.t1586 VSS.t1588 VSS.t1587 sg13_lv_nmos ad=0.1406p pd=1.12u as=0 ps=0 w=0.74u l=0.13u
X1818 VSS.t364 VDD.t1646 VSS.t364 VSS.t366 sg13_lv_nmos ad=0.1428p pd=1.52u as=0 ps=0 w=0.42u l=1u
X1819 a_4350_13226# a_6711_13190# a_6635_13226# VDD.t2 sg13_lv_pmos ad=0.3808p pd=2.92u as=0.2128p ps=1.5u w=1.12u l=0.13u
X1820 VDD.t827 a_12849_11557# a_13306_11995# VDD.t358 sg13_lv_pmos ad=0.36237p pd=2.605u as=79.8f ps=0.8u w=0.42u l=0.13u
X1821 CHAN2_DELAY_OUT_LAST a_27997_4687# VSS.t1404 VSS.t1403 sg13_lv_nmos ad=0.2516p pd=2.16u as=0.1406p ps=1.12u w=0.74u l=0.13u
X1822 a_13470_16071# a_14964_16035# a_14888_16071# VDD.t34 sg13_lv_pmos ad=0.3808p pd=2.92u as=0.2128p ps=1.5u w=1.12u l=0.13u
X1823 a_8155_1044# a_7945_1044# VDD.t536 VDD.t67 sg13_lv_pmos ad=0.2128p pd=1.5u as=0.252p ps=1.57u w=1.12u l=0.13u
X1824 a_21835_16071# a_21625_16071# VSS.t1970 VSS.t1969 sg13_lv_nmos ad=0.1406p pd=1.12u as=0.1665p ps=1.19u w=0.74u l=0.13u
X1825 a_4350_3889# a_6711_3853# a_6635_3889# VDD.t0 sg13_lv_pmos ad=0.3808p pd=2.92u as=0.2128p ps=1.5u w=1.12u l=0.13u
X1826 VDD.t446 VDD.t444 VDD.t445 VDD.t378 sg13_lv_pmos ad=0.3808p pd=2.92u as=0 ps=0 w=1.12u l=0.6u
X1827 VSS.t2041 a_3171_13229.t9 a_5844_13190# VSS.t2040 sg13_lv_nmos ad=0.2516p pd=2.16u as=0.2516p ps=2.16u w=0.74u l=0.13u
X1828 VSS.t1138 a_18117_1842# a_18585_1044# VSS.t2345 sg13_lv_nmos ad=0.1665p pd=1.19u as=0.2516p ps=2.16u w=0.74u l=0.13u
X1829 VSS.t885 a_5523_16869# a_5957_16869# VSS.t1318 sg13_lv_nmos ad=0.1406p pd=1.12u as=0.2516p ps=2.16u w=0.74u l=0.13u
X1830 VDD.t963 a_4187_2434# a_10191_14652# VDD.t378 sg13_lv_pmos ad=0.3808p pd=2.92u as=0.2128p ps=1.5u w=1.12u l=0.6u
X1831 a_4111_7532# REF_CLK a_4003_7532# VSS.t1307 sg13_lv_nmos ad=0.1406p pd=1.12u as=0.2516p ps=2.16u w=0.74u l=0.2u
X1832 VDD.t1324 a_3171_6737.t4 a_21044_6698# VDD.t9 sg13_lv_pmos ad=0.3808p pd=2.92u as=0.3808p ps=2.92u w=1.12u l=0.13u
X1833 a_10430_16071# a_10404_16035# a_10328_16071# VDD.t34 sg13_lv_pmos ad=0.3808p pd=2.92u as=0.2128p ps=1.5u w=1.12u l=0.13u
X1834 a_17553_7532# a_17357_7532# VDD.t541 VDD.t345 sg13_lv_pmos ad=0.3808p pd=2.92u as=0.2128p ps=1.5u w=1.12u l=0.13u
X1835 VSS.t1095 a_1544_6734# a_2391_7085# VSS.t1804 sg13_lv_nmos ad=0.1331p pd=1.12u as=0.1216p ps=1.02u w=0.64u l=0.13u
X1836 VDD.t178 VSS.t336 VDD.t177 VDD.t9 sg13_lv_pmos ad=0.19p pd=1.38u as=0 ps=0 w=1u l=1u
X1837 a_8671_8160# a_8433_7532# a_8563_7532# VDD.t345 sg13_lv_pmos ad=0.2128p pd=1.5u as=0.3808p ps=2.92u w=1.12u l=0.2u
X1838 a_6913_4687# a_6717_4687# VSS.t486 VSS.t485 sg13_lv_nmos ad=0.2516p pd=2.16u as=0.1406p ps=1.12u w=0.74u l=0.13u
X1839 VSS.t132 a_4187_1764.t46 a_18551_4687# VSS.t2270 sg13_lv_nmos ad=0.2516p pd=2.16u as=0.1406p ps=1.12u w=0.74u l=0.6u
X1840 a_27048_1044# a_26477_1842# VDD.t1135 VDD.t67 sg13_lv_pmos ad=0.2128p pd=1.5u as=0.3808p ps=2.92u w=1.12u l=0.13u
X1841 a_19550_3889# a_20391_3853# a_20315_3889# VDD.t0 sg13_lv_pmos ad=0.3808p pd=2.92u as=0.2128p ps=1.5u w=1.12u l=0.13u
X1842 a_2019_6737.t1 a_1721_7085# VSS.t1630 VSS.t1629 sg13_lv_nmos ad=0.1406p pd=1.12u as=0.1331p ps=1.12u w=0.74u l=0.13u
X1843 a_13470_6734# a_2019_6737.t6 a_13368_6734# VSS.t1055 sg13_lv_nmos ad=0.2516p pd=2.16u as=0.1406p ps=1.12u w=0.74u l=0.13u
X1844 a_24393_16869# a_24197_16869# VDD.t755 VDD.t368 sg13_lv_pmos ad=0.3808p pd=2.92u as=0.2128p ps=1.5u w=1.12u l=0.13u
X1845 VDD.t232 VSS.t350 VDD.t231 VDD.t0 sg13_lv_pmos ad=0.34p pd=2.68u as=0 ps=0 w=1u l=1u
X1846 a_24875_13226# a_24665_13226# VDD.t558 VDD.t2 sg13_lv_pmos ad=0.2128p pd=1.5u as=0.252p ps=1.57u w=1.12u l=0.13u
X1847 VDD.t717 a_17683_16869# a_18117_16869# VDD.t368 sg13_lv_pmos ad=0.2128p pd=1.5u as=0.3808p ps=2.92u w=1.12u l=0.13u
X1848 VSS.t255 VDD.t1683 VSS.t254 VSS.t253 sg13_lv_nmos ad=0.1428p pd=1.52u as=0 ps=0 w=0.42u l=1u
X1849 VDD.t798 CHAN2_MUX_SEL3 a_3449_3176# VDD.t0 sg13_lv_pmos ad=0.1918p pd=1.5u as=0.1596p ps=1.22u w=0.84u l=0.13u
X1850 VDD.t1025 a_4187_2434# a_20831_17497# VDD.t368 sg13_lv_pmos ad=0.3808p pd=2.92u as=0.2128p ps=1.5u w=1.12u l=0.6u
X1851 a_6326_10280# a_6126_9506# a_5778_9057# VSS.t803 sg13_lv_nmos ad=0.38p pd=2.38u as=0.68p ps=4.68u w=2u l=1u
X1852 a_25391_5315# a_25153_4687# a_25283_4687# VDD.t347 sg13_lv_pmos ad=0.2128p pd=1.5u as=0.3808p ps=2.92u w=1.12u l=0.2u
X1853 a_19550_16071# a_20391_16035# a_20315_16071# VDD.t34 sg13_lv_pmos ad=0.3808p pd=2.92u as=0.2128p ps=1.5u w=1.12u l=0.13u
X1854 VSS.t207 VDD.t1698 VSS.t207 VSS.t206 sg13_lv_nmos ad=0.1428p pd=1.52u as=0 ps=0 w=0.42u l=1u
X1855 a_5768_1044# a_5197_1842# VDD.t1445 VDD.t67 sg13_lv_pmos ad=0.2128p pd=1.5u as=0.3808p ps=2.92u w=1.12u l=0.13u
X1856 VSS.t1323 a_3171_6737.t3 a_24084_6698# VSS.t1917 sg13_lv_nmos ad=0.2516p pd=2.16u as=0.2516p ps=2.16u w=0.74u l=0.13u
X1857 VDD.t1311 a_7477_4687# a_7945_3889# VDD.t0 sg13_lv_pmos ad=0.252p pd=1.57u as=0.3808p ps=2.92u w=1.12u l=0.13u
X1858 VDD.t1282 a_5957_16869# a_6425_16071# VDD.t34 sg13_lv_pmos ad=0.252p pd=1.57u as=0.3808p ps=2.92u w=1.12u l=0.13u
X1859 VSS.t99 a_13123_7532# a_13557_7532# VSS.t2171 sg13_lv_nmos ad=0.1406p pd=1.12u as=0.2516p ps=2.16u w=0.74u l=0.13u
X1860 a_3747_3156.t1 a_3449_3176# VSS.t27 VSS.t2087 sg13_lv_nmos ad=0.1406p pd=1.12u as=0.1331p ps=1.12u w=0.74u l=0.13u
X1861 VDD.t599 a_12363_14024# a_12797_14024# VDD.t378 sg13_lv_pmos ad=0.2128p pd=1.5u as=0.3808p ps=2.92u w=1.12u l=0.13u
X1862 VDD.t651 a_15964_12471# a_16851_12491# VDD.t2 sg13_lv_pmos ad=0.2086p pd=1.5u as=0.34p ps=2.68u w=1u l=0.13u
X1863 a_12993_4687# a_12797_4687# VDD.t753 VDD.t347 sg13_lv_pmos ad=0.3808p pd=2.92u as=0.2128p ps=1.5u w=1.12u l=0.13u
X1864 a_8671_14652# a_8433_14024# a_8563_14024# VDD.t378 sg13_lv_pmos ad=0.2128p pd=1.5u as=0.3808p ps=2.92u w=1.12u l=0.2u
X1865 a_25913_7532# a_25717_7532# VSS.t1023 VSS.t1310 sg13_lv_nmos ad=0.2516p pd=2.16u as=0.1406p ps=1.12u w=0.74u l=0.13u
X1866 VSS.t388 VDD.t1638 VSS.t386 VSS.t387 sg13_lv_nmos ad=79.8f pd=0.8u as=0 ps=0 w=0.42u l=1u
X1867 a_5731_15316# a_8745_15546# a_7390_16071# VDD.t34 sg13_lv_pmos ad=0.3808p pd=2.92u as=0.3808p ps=2.92u w=1.12u l=0.13u
X1868 a_21353_7532# a_21157_7532# VDD.t660 VDD.t345 sg13_lv_pmos ad=0.3808p pd=2.92u as=0.2128p ps=1.5u w=1.12u l=0.13u
X1869 VSS.t1699 a_21483_16869# a_21917_16869# VSS.t2155 sg13_lv_nmos ad=0.1406p pd=1.12u as=0.2516p ps=2.16u w=0.74u l=0.13u
X1870 a_12715_16071# a_12505_16071# VSS.t1452 VSS.t2025 sg13_lv_nmos ad=0.1406p pd=1.12u as=0.1665p ps=1.19u w=0.74u l=0.13u
X1871 a_5731_12471# a_5705_12701# a_4350_13226# VDD.t2 sg13_lv_pmos ad=0.3808p pd=2.92u as=0.3808p ps=2.92u w=1.12u l=0.13u
X1872 VSS.t644 a_3171_1047.t6 a_14964_1008# VSS.t643 sg13_lv_nmos ad=0.2516p pd=2.16u as=0.2516p ps=2.16u w=0.74u l=0.13u
X1873 VSS.t937 a_4187_1764.t41 a_22351_4687# VSS.t1032 sg13_lv_nmos ad=0.2516p pd=2.16u as=0.1406p ps=1.12u w=0.74u l=0.6u
X1874 VDD.t1037 a_4187_2434# a_9431_14652# VDD.t378 sg13_lv_pmos ad=0.3808p pd=2.92u as=0.2128p ps=1.5u w=1.12u l=0.6u
X1875 VSS.t1368 a_27237_14024# a_27705_13226# VSS.t1367 sg13_lv_nmos ad=0.1665p pd=1.19u as=0.2516p ps=2.16u w=0.74u l=0.13u
X1876 a_13991_2470# a_13753_1842# a_13883_1842# VDD.t379 sg13_lv_pmos ad=0.2128p pd=1.5u as=0.3808p ps=2.92u w=1.12u l=0.2u
X1877 VDD.t31 VSS.t310 VDD.t30 VDD.t9 sg13_lv_pmos ad=0.34p pd=2.68u as=0 ps=0 w=1u l=1u
X1878 VDD.t939 a_26803_14024# a_27237_14024# VDD.t378 sg13_lv_pmos ad=0.2128p pd=1.5u as=0.3808p ps=2.92u w=1.12u l=0.13u
X1879 a_10232_11561# a_10206_11525# VSS.t623 VSS.t622 sg13_lv_nmos ad=0.2516p pd=2.16u as=0.1626p ps=1.415u w=0.74u l=0.13u
X1880 VSS.t2004 a_25717_16869# a_26185_16071# VSS.t2332 sg13_lv_nmos ad=0.1665p pd=1.19u as=0.2516p ps=2.16u w=0.74u l=0.13u
X1881 VDD.t893 a_7043_7532# a_7477_7532# VDD.t345 sg13_lv_pmos ad=0.2128p pd=1.5u as=0.3808p ps=2.92u w=1.12u l=0.13u
X1882 a_4633_16869# a_4437_16869# VDD.t640 VDD.t368 sg13_lv_pmos ad=0.3808p pd=2.92u as=0.2128p ps=1.5u w=1.12u l=0.13u
X1883 a_24008_16071# a_23437_16869# VSS.t895 VSS.t2243 sg13_lv_nmos ad=0.1406p pd=1.12u as=0.2516p ps=2.16u w=0.74u l=0.13u
X1884 VSS.t67 a_2873_4240# a_3171_3892.t1 VSS.t978 sg13_lv_nmos ad=0.2812p pd=2.24u as=0.1406p ps=1.12u w=0.74u l=0.13u
X1885 VDD.t1076 a_4187_2434# a_13991_5315# VDD.t347 sg13_lv_pmos ad=0.3808p pd=2.92u as=0.2128p ps=1.5u w=1.12u l=0.6u
X1886 VSS.t2098 a_22677_14024# a_23145_13226# VSS.t2342 sg13_lv_nmos ad=0.1665p pd=1.19u as=0.2516p ps=2.16u w=0.74u l=0.13u
X1887 VDD.t383 a_2873_13577# a_3171_13229.t0 VDD.t2 sg13_lv_pmos ad=0.4256p pd=3u as=0.2128p ps=1.5u w=1.12u l=0.13u
X1888 a_6854_11144# a_6854_11144# a_9444_10280# VSS.t1204 sg13_lv_nmos ad=0.38p pd=2.38u as=0.68p ps=4.68u w=2u l=1u
X1889 a_20968_13226# a_20397_14024# VSS.t1498 VSS.t2340 sg13_lv_nmos ad=0.1406p pd=1.12u as=0.2516p ps=2.16u w=0.74u l=0.13u
X1890 VDD.t407 a_2019_311# a_17865_519# VDD.t67 sg13_lv_pmos ad=0.3808p pd=2.92u as=0.3808p ps=2.92u w=1.12u l=0.13u
X1891 VSS.t226 VDD.t1691 VSS.t226 VSS.t227 sg13_lv_nmos ad=79.8f pd=0.8u as=0 ps=0 w=0.42u l=1u
X1892 a_15964_5979# a_15765_6153# a_5731_5979# VSS.t173 sg13_lv_nmos ad=0.2183p pd=1.33u as=0.2516p ps=2.16u w=0.74u l=0.13u
X1893 a_16108_3134# a_2019_3156.t2 a_16510_3889# VSS.t0 sg13_lv_nmos ad=0.2516p pd=2.16u as=0.2516p ps=2.16u w=0.74u l=0.13u
X1894 a_11195_1044# a_10985_1044# VSS.t1801 VSS.t1800 sg13_lv_nmos ad=0.1406p pd=1.12u as=0.1665p ps=1.19u w=0.74u l=0.13u
X1895 CHAN3_DELAY_OUT_LAST a_27997_1842# VSS.t614 VSS.t613 sg13_lv_nmos ad=0.2516p pd=2.16u as=0.1406p ps=1.12u w=0.74u l=0.13u
X1896 a_13368_3889# a_12797_4687# VSS.t55 VSS.t1027 sg13_lv_nmos ad=0.1406p pd=1.12u as=0.2516p ps=2.16u w=0.74u l=0.13u
X1897 VDD.t737 a_23763_4687# a_24197_4687# VDD.t347 sg13_lv_pmos ad=0.2128p pd=1.5u as=0.3808p ps=2.92u w=1.12u l=0.13u
X1898 VDD.t1021 a_4187_2434# a_11711_17497# VDD.t368 sg13_lv_pmos ad=0.3808p pd=2.92u as=0.2128p ps=1.5u w=1.12u l=0.6u
X1899 VDD.t1263 a_2297_16422# a_2595_16074.t0 VDD.t34 sg13_lv_pmos ad=0.4256p pd=3u as=0.2128p ps=1.5u w=1.12u l=0.13u
X1900 VSS.t357 VDD.t1650 VSS.t357 VSS.t356 sg13_lv_nmos ad=0.1428p pd=1.52u as=0 ps=0 w=0.42u l=1u
X1901 VSS.t707 a_18117_7532# a_18585_6734# VSS.t706 sg13_lv_nmos ad=0.1665p pd=1.19u as=0.2516p ps=2.16u w=0.74u l=0.13u
X1902 a_11195_13226# a_10985_13226# VDD.t890 VDD.t2 sg13_lv_pmos ad=0.2128p pd=1.5u as=0.252p ps=1.57u w=1.12u l=0.13u
X1903 a_25391_17497# a_25153_16869# a_25283_16869# VDD.t368 sg13_lv_pmos ad=0.2128p pd=1.5u as=0.3808p ps=2.92u w=1.12u l=0.2u
X1904 a_22590_16071# a_3747_16074.t3 a_24875_16071# VSS.t2249 sg13_lv_nmos ad=0.2516p pd=2.16u as=0.1406p ps=1.12u w=0.74u l=0.13u
X1905 VDD.t942 a_24197_1842# a_24665_1044# VDD.t67 sg13_lv_pmos ad=0.252p pd=1.57u as=0.3808p ps=2.92u w=1.12u l=0.13u
X1906 a_19550_13226# a_3747_13229.t4 a_21835_13226# VSS.t2262 sg13_lv_nmos ad=0.2516p pd=2.16u as=0.1406p ps=1.12u w=0.74u l=0.13u
X1907 a_16510_1044# a_18004_1008# a_17928_1044# VDD.t67 sg13_lv_pmos ad=0.3808p pd=2.92u as=0.2128p ps=1.5u w=1.12u l=0.13u
X1908 VDD.t262 VSS.t382 VDD.t261 VDD.t0 sg13_lv_pmos ad=0.19p pd=1.38u as=0 ps=0 w=1u l=1u
X1909 VSS.t1166 a_1544_3889# a_2391_4240# VSS.t822 sg13_lv_nmos ad=0.1331p pd=1.12u as=0.1216p ps=1.02u w=0.64u l=0.13u
X1910 a_6913_1842# a_6717_1842# VSS.t2137 VSS.t2146 sg13_lv_nmos ad=0.2516p pd=2.16u as=0.1406p ps=1.12u w=0.74u l=0.13u
X1911 a_22488_13226# a_21917_14024# VDD.t852 VDD.t2 sg13_lv_pmos ad=0.2128p pd=1.5u as=0.3808p ps=2.92u w=1.12u l=0.13u
X1912 VSS.t1067 a_4187_1764.t14 a_18551_1842# VSS.t1066 sg13_lv_nmos ad=0.2516p pd=2.16u as=0.1406p ps=1.12u w=0.74u l=0.6u
X1913 VDD.t1028 a_4187_2434# a_26151_17497# VDD.t368 sg13_lv_pmos ad=0.3808p pd=2.92u as=0.2128p ps=1.5u w=1.12u l=0.6u
X1914 a_2019_3892.t1 a_1721_4240# VSS.t499 VSS.t498 sg13_lv_nmos ad=0.1406p pd=1.12u as=0.1331p ps=1.12u w=0.74u l=0.13u
X1915 VSS.t331 a_1256_5979# a_2967_6021# VSS.t66 sg13_lv_nmos ad=0.1331p pd=1.12u as=0.1216p ps=1.02u w=0.64u l=0.13u
X1916 VSS.t2024 a_3449_16422# a_3747_16074.t1 VSS.t2023 sg13_lv_nmos ad=0.2812p pd=2.24u as=0.1406p ps=1.12u w=0.74u l=0.13u
X1917 a_24393_14024# a_24197_14024# VDD.t381 VDD.t378 sg13_lv_pmos ad=0.3808p pd=2.92u as=0.2128p ps=1.5u w=1.12u l=0.13u
X1918 VDD.t819 a_12363_1842# a_12797_1842# VDD.t379 sg13_lv_pmos ad=0.2128p pd=1.5u as=0.3808p ps=2.92u w=1.12u l=0.13u
X1919 VDD.t830 a_12849_11557# a_13306_10795# VDD.t358 sg13_lv_pmos ad=0.36237p pd=2.605u as=79.8f ps=0.8u w=0.42u l=0.13u
X1920 a_19833_4687# a_19637_4687# VSS.t915 VSS.t1087 sg13_lv_nmos ad=0.2516p pd=2.16u as=0.1406p ps=1.12u w=0.74u l=0.13u
X1921 a_4350_3889# a_3747_3892.t9 a_6635_3889# VSS.t47 sg13_lv_nmos ad=0.2516p pd=2.16u as=0.1406p ps=1.12u w=0.74u l=0.13u
X1922 VDD.t1090 a_4187_2434# a_26911_5315# VDD.t347 sg13_lv_pmos ad=0.3808p pd=2.92u as=0.2128p ps=1.5u w=1.12u l=0.6u
X1923 VDD.t655 a_17683_14024# a_18117_14024# VDD.t378 sg13_lv_pmos ad=0.2128p pd=1.5u as=0.3808p ps=2.92u w=1.12u l=0.13u
X1924 VDD.t1031 a_4187_2434# a_20831_14652# VDD.t378 sg13_lv_pmos ad=0.3808p pd=2.92u as=0.2128p ps=1.5u w=1.12u l=0.6u
X1925 a_25630_13226# a_27991_13190# a_27915_13226# VDD.t2 sg13_lv_pmos ad=0.3808p pd=2.92u as=0.2128p ps=1.5u w=1.12u l=0.13u
X1926 VSS.t295 VDD.t1674 VSS.t293 VSS.t294 sg13_lv_nmos ad=79.8f pd=0.8u as=0 ps=0 w=0.42u l=1u
X1927 VDD.t460 a_6326_10280# a_6854_11676# VDD.t358 sg13_lv_pmos ad=0.38p pd=2.38u as=0.38p ps=2.38u w=2u l=1u
X1928 VSS.t176 CHAN3_MUX_SEL3 a_3543_331# VSS.t1638 sg13_lv_nmos ad=0.1331p pd=1.12u as=0.1216p ps=1.02u w=0.64u l=0.13u
X1929 a_9675_3889# a_9465_3889# VDD.t409 VDD.t0 sg13_lv_pmos ad=0.2128p pd=1.5u as=0.252p ps=1.57u w=1.12u l=0.13u
X1930 VSS.t1989 a_13557_14024# a_14025_13226# VSS.t1988 sg13_lv_nmos ad=0.1665p pd=1.19u as=0.2516p ps=2.16u w=0.74u l=0.13u
X1931 VSS.t331 a_2595_6001.t3 a_8745_6209# VSS.t717 sg13_lv_nmos ad=0.2516p pd=2.16u as=0.2516p ps=2.16u w=0.74u l=0.13u
X1932 VDD.t4 VSS.t244 VDD.t3 VDD.t2 sg13_lv_pmos ad=0.34p pd=2.68u as=0 ps=0 w=1u l=1u
X1933 a_4111_16869# CHAN0_DELAY_IN a_4003_16869# VSS.t2186 sg13_lv_nmos ad=0.1406p pd=1.12u as=0.2516p ps=2.16u w=0.74u l=0.2u
X1934 VDD.t1129 a_2595_3892.t8 a_8231_3853# VDD.t0 sg13_lv_pmos ad=0.3808p pd=2.92u as=0.3808p ps=2.92u w=1.12u l=0.13u
X1935 a_22590_13226# a_23431_13190# a_23355_13226# VDD.t2 sg13_lv_pmos ad=0.3808p pd=2.92u as=0.2128p ps=1.5u w=1.12u l=0.13u
X1936 a_19550_3889# a_2595_3892.t4 a_20315_3889# VSS.t1424 sg13_lv_nmos ad=0.2516p pd=2.16u as=0.1406p ps=1.12u w=0.74u l=0.13u
X1937 a_24631_4687# a_24393_4687# a_24523_4687# VSS.t1208 sg13_lv_nmos ad=0.1406p pd=1.12u as=0.2516p ps=2.16u w=0.74u l=0.2u
X1938 a_9193_4687# a_8997_4687# VSS.t156 VSS.t155 sg13_lv_nmos ad=0.2516p pd=2.16u as=0.1406p ps=1.12u w=0.74u l=0.13u
X1939 VDD.t923 a_8997_14024# a_9465_13226# VDD.t2 sg13_lv_pmos ad=0.252p pd=1.57u as=0.3808p ps=2.92u w=1.12u l=0.13u
X1940 a_22590_1044# a_2595_1047.t3 a_23355_1044# VSS.t1728 sg13_lv_nmos ad=0.2516p pd=2.16u as=0.1406p ps=1.12u w=0.74u l=0.13u
X1941 a_2967_13577# CHAN1_MUX_SEL1 a_2873_13577# VSS.t22 sg13_lv_nmos ad=0.1216p pd=1.02u as=0.2176p ps=1.96u w=0.64u l=0.13u
X1942 a_3747_6737.t0 a_3449_7085# VDD.t794 VDD.t9 sg13_lv_pmos ad=0.2128p pd=1.5u as=0.1918p ps=1.5u w=1.12u l=0.13u
X1943 VSS.t105 a_8563_14024# a_8997_14024# VSS.t1427 sg13_lv_nmos ad=0.1406p pd=1.12u as=0.2516p ps=2.16u w=0.74u l=0.13u
X1944 a_13991_8160# a_13753_7532# a_13883_7532# VDD.t345 sg13_lv_pmos ad=0.2128p pd=1.5u as=0.3808p ps=2.92u w=1.12u l=0.2u
X1945 VSS.t158 a_3171_6737.t6 a_14964_6698# VSS.t1915 sg13_lv_nmos ad=0.2516p pd=2.16u as=0.2516p ps=2.16u w=0.74u l=0.13u
X1946 a_13368_6734# a_12797_7532# VDD.t1605 VDD.t9 sg13_lv_pmos ad=0.2128p pd=1.5u as=0.3808p ps=2.92u w=1.12u l=0.13u
X1947 VSS.t513 a_4187_1764.t9 a_22351_1842# VSS.t783 sg13_lv_nmos ad=0.2516p pd=2.16u as=0.1406p ps=1.12u w=0.74u l=0.6u
X1948 VDD.t577 a_3171_1047.t4 a_21044_1008# VDD.t67 sg13_lv_pmos ad=0.3808p pd=2.92u as=0.3808p ps=2.92u w=1.12u l=0.13u
X1949 VDD.t228 VSS.t357 VDD.t227 VDD.t0 sg13_lv_pmos ad=0.34p pd=2.68u as=0 ps=0 w=1u l=1u
X1950 VSS.t1886 a_7477_4687# a_7945_3889# VSS.t2287 sg13_lv_nmos ad=0.1665p pd=1.19u as=0.2516p ps=2.16u w=0.74u l=0.13u
X1951 a_16108_15316# a_3171_15338.t2 a_22590_16071# VSS.t738 sg13_lv_nmos ad=0.2516p pd=2.16u as=0.2516p ps=2.16u w=0.74u l=0.13u
X1952 a_4633_14024# a_4437_14024# VDD.t1475 VDD.t378 sg13_lv_pmos ad=0.3808p pd=2.92u as=0.2128p ps=1.5u w=1.12u l=0.13u
X1953 a_10430_13226# a_3747_13229.t7 a_12715_13226# VSS.t2260 sg13_lv_nmos ad=0.2516p pd=2.16u as=0.1406p ps=1.12u w=0.74u l=0.13u
X1954 a_23633_4687# a_23437_4687# VSS.t111 VSS.t1201 sg13_lv_nmos ad=0.2516p pd=2.16u as=0.1406p ps=1.12u w=0.74u l=0.13u
X1955 a_10430_16071# a_2595_16074.t7 a_11195_16071# VSS.t896 sg13_lv_nmos ad=0.2516p pd=2.16u as=0.1406p ps=1.12u w=0.74u l=0.13u
X1956 a_1721_13577# a_1256_13226# VDD.t952 VDD.t2 sg13_lv_pmos ad=0.1596p pd=1.22u as=0.2856p ps=2.36u w=0.84u l=0.13u
X1957 VSS.t542 a_9547_11862# a_9547_11862# VSS.t541 sg13_lv_nmos ad=2.39977p pd=15.495u as=0.111p ps=1.34u w=0.3u l=0.13u
X1958 VSS.t193 VDD.t1703 VSS.t193 VSS.t195 sg13_lv_nmos ad=0.1428p pd=1.52u as=0 ps=0 w=0.42u l=1u
X1959 a_15273_4687# a_15077_4687# VDD.t532 VDD.t347 sg13_lv_pmos ad=0.3808p pd=2.92u as=0.2128p ps=1.5u w=1.12u l=0.13u
X1960 VSS.t538 a_9323_4687# a_9757_4687# VSS.t1308 sg13_lv_nmos ad=0.1406p pd=1.12u as=0.2516p ps=2.16u w=0.74u l=0.13u
X1961 a_6391_5315# a_6153_4687# a_6283_4687# VDD.t347 sg13_lv_pmos ad=0.2128p pd=1.5u as=0.3808p ps=2.92u w=1.12u l=0.2u
X1962 VSS.t324 VDD.t1661 VSS.t324 VSS.t326 sg13_lv_nmos ad=0.1428p pd=1.52u as=0 ps=0 w=0.42u l=1u
X1963 VSS.t1745 a_2019_13229.t8 a_7364_13190# VSS.t1744 sg13_lv_nmos ad=0.2516p pd=2.16u as=0.2516p ps=2.16u w=0.74u l=0.13u
X1964 REF_DELAY_OUT_LAST a_27997_7532# VSS.t1119 VSS.t1444 sg13_lv_nmos ad=0.2516p pd=2.16u as=0.1406p ps=1.12u w=0.74u l=0.13u
X1965 a_11195_6734# a_10985_6734# VSS.t1503 VSS.t1785 sg13_lv_nmos ad=0.1406p pd=1.12u as=0.1665p ps=1.19u w=0.74u l=0.13u
X1966 a_2873_7085# REF_MUX_SEL1 VDD.t954 VDD.t9 sg13_lv_pmos ad=0.1596p pd=1.22u as=0.2856p ps=2.36u w=0.84u l=0.13u
X1967 VSS.t956 a_7043_16869# a_7477_16869# VSS.t955 sg13_lv_nmos ad=0.1406p pd=1.12u as=0.2516p ps=2.16u w=0.74u l=0.13u
X1968 VDD.t983 a_4187_2434# a_11711_14652# VDD.t378 sg13_lv_pmos ad=0.3808p pd=2.92u as=0.2128p ps=1.5u w=1.12u l=0.6u
X1969 VDD.t204 VSS.t451 VDD.t167 VDD.t67 sg13_lv_pmos ad=0.19p pd=1.38u as=0 ps=0 w=1u l=1u
X1970 VSS.t85 a_3171_16074.t9 a_5844_16035# VSS.t84 sg13_lv_nmos ad=0.2516p pd=2.16u as=0.2516p ps=2.16u w=0.74u l=0.13u
X1971 a_10430_16071# a_11924_16035# a_11848_16071# VDD.t34 sg13_lv_pmos ad=0.3808p pd=2.92u as=0.2128p ps=1.5u w=1.12u l=0.13u
X1972 a_15304_10295# a_14851_11918# VDD.t546 VDD.t358 sg13_lv_pmos ad=0.4312p pd=3.01u as=0.2639p ps=1.81u w=1.12u l=0.13u
X1973 a_4350_6734# a_6711_6698# a_6635_6734# VDD.t9 sg13_lv_pmos ad=0.3808p pd=2.92u as=0.2128p ps=1.5u w=1.12u l=0.13u
X1974 a_16108_12471# a_26985_12701# a_25630_13226# VDD.t2 sg13_lv_pmos ad=0.3808p pd=2.92u as=0.3808p ps=2.92u w=1.12u l=0.13u
X1975 a_16271_2470# a_16033_1842# a_16163_1842# VDD.t379 sg13_lv_pmos ad=0.2128p pd=1.5u as=0.3808p ps=2.92u w=1.12u l=0.2u
X1976 a_25391_14652# a_25153_14024# a_25283_14024# VDD.t378 sg13_lv_pmos ad=0.2128p pd=1.5u as=0.3808p ps=2.92u w=1.12u l=0.2u
X1977 a_13566_11018# a_14009_10774# a_13949_11186# VDD.t358 sg13_lv_pmos ad=79.8f pd=0.8u as=63f ps=0.72u w=0.42u l=0.13u
X1978 a_6913_7532# a_6717_7532# VSS.t629 VSS.t983 sg13_lv_nmos ad=0.2516p pd=2.16u as=0.1406p ps=1.12u w=0.74u l=0.13u
X1979 VDD.t364 a_11748_11799# a_11693_11680# VDD.t358 sg13_lv_pmos ad=1.10612p pd=6.66u as=93.45f ps=0.865u w=0.42u l=0.13u
X1980 a_25913_16869# a_25717_16869# VDD.t1583 VDD.t368 sg13_lv_pmos ad=0.3808p pd=2.92u as=0.2128p ps=1.5u w=1.12u l=0.13u
X1981 VDD.t790 a_11491_11918# a_12158_11557# VDD.t358 sg13_lv_pmos ad=0.2128p pd=1.5u as=0.3864p ps=2.93u w=1.12u l=0.13u
X1982 VSS.t90 a_4187_1764.t78 a_18551_7532# VSS.t751 sg13_lv_nmos ad=0.2516p pd=2.16u as=0.1406p ps=1.12u w=0.74u l=0.6u
X1983 a_19550_6734# a_20391_6698# a_20315_6734# VDD.t9 sg13_lv_pmos ad=0.3808p pd=2.92u as=0.2128p ps=1.5u w=1.12u l=0.13u
X1984 VDD.t1047 a_4187_2434# a_26151_14652# VDD.t378 sg13_lv_pmos ad=0.3808p pd=2.92u as=0.2128p ps=1.5u w=1.12u l=0.6u
X1985 VDD.t273 VSS.t427 VDD.t272 VDD.t67 sg13_lv_pmos ad=0.19p pd=1.38u as=0 ps=0 w=1u l=1u
X1986 VDD.t796 a_12363_7532# a_12797_7532# VDD.t345 sg13_lv_pmos ad=0.2128p pd=1.5u as=0.3808p ps=2.92u w=1.12u l=0.13u
X1987 a_2595_3156.t0 a_2297_3176# VDD.t1439 VDD.t0 sg13_lv_pmos ad=0.2128p pd=1.5u as=0.1918p ps=1.5u w=1.12u l=0.13u
X1988 VDD.t413 a_15403_4687# a_15837_4687# VDD.t347 sg13_lv_pmos ad=0.2128p pd=1.5u as=0.3808p ps=2.92u w=1.12u l=0.13u
X1989 a_21353_16869# a_21157_16869# VDD.t1487 VDD.t368 sg13_lv_pmos ad=0.3808p pd=2.92u as=0.2128p ps=1.5u w=1.12u l=0.13u
X1990 a_19833_1842# a_19637_1842# VSS.t511 VSS.t733 sg13_lv_nmos ad=0.2516p pd=2.16u as=0.1406p ps=1.12u w=0.74u l=0.13u
X1991 VSS.t1176 a_19963_14024# a_20397_14024# VSS.t1175 sg13_lv_nmos ad=0.1406p pd=1.12u as=0.2516p ps=2.16u w=0.74u l=0.13u
X1992 a_21835_13226# a_21625_13226# VDD.t556 VDD.t2 sg13_lv_pmos ad=0.2128p pd=1.5u as=0.252p ps=1.57u w=1.12u l=0.13u
X1993 VDD.t406 a_2019_311# a_5705_519# VDD.t67 sg13_lv_pmos ad=0.3808p pd=2.92u as=0.3808p ps=2.92u w=1.12u l=0.13u
X1994 VDD.t919 a_14643_16869# a_15077_16869# VDD.t368 sg13_lv_pmos ad=0.2128p pd=1.5u as=0.3808p ps=2.92u w=1.12u l=0.13u
X1995 VDD.t803 a_7477_7532# a_7945_6734# VDD.t9 sg13_lv_pmos ad=0.252p pd=1.57u as=0.3808p ps=2.92u w=1.12u l=0.13u
X1996 a_3747_6001.t1 a_3449_6021# VSS.t37 VSS.t1829 sg13_lv_nmos ad=0.1406p pd=1.12u as=0.1331p ps=1.12u w=0.74u l=0.13u
X1997 a_3747_12493.t1 a_3449_12513# VSS.t715 VSS.t1191 sg13_lv_nmos ad=0.1406p pd=1.12u as=0.1331p ps=1.12u w=0.74u l=0.13u
X1998 VSS.t504 a_2019_1047.t7 a_10404_1008# VSS.t675 sg13_lv_nmos ad=0.2516p pd=2.16u as=0.2516p ps=2.16u w=0.74u l=0.13u
X1999 VDD.t275 VSS.t427 VDD.t274 VDD.t67 sg13_lv_pmos ad=0.34p pd=2.68u as=0 ps=0 w=1u l=1u
X2000 a_24631_1842# a_24393_1842# a_24523_1842# VSS.t2012 sg13_lv_nmos ad=0.1406p pd=1.12u as=0.2516p ps=2.16u w=0.74u l=0.2u
X2001 a_22590_6734# a_2595_6737.t3 a_23355_6734# VSS.t1321 sg13_lv_nmos ad=0.2516p pd=2.16u as=0.1406p ps=1.12u w=0.74u l=0.13u
X2002 a_19550_3889# a_19524_3853# a_19448_3889# VDD.t0 sg13_lv_pmos ad=0.3808p pd=2.92u as=0.2128p ps=1.5u w=1.12u l=0.13u
X2003 VDD.t408 a_4763_4687# a_5197_4687# VDD.t347 sg13_lv_pmos ad=0.2128p pd=1.5u as=0.3808p ps=2.92u w=1.12u l=0.13u
X2004 a_9193_1842# a_8997_1842# VSS.t742 VSS.t1533 sg13_lv_nmos ad=0.2516p pd=2.16u as=0.1406p ps=1.12u w=0.74u l=0.13u
X2005 a_20071_2470# a_19833_1842# a_19963_1842# VDD.t379 sg13_lv_pmos ad=0.2128p pd=1.5u as=0.3808p ps=2.92u w=1.12u l=0.2u
X2006 VDD.t613 a_3171_6001.t2 a_23945_6209# VDD.t9 sg13_lv_pmos ad=0.3808p pd=2.92u as=0.3808p ps=2.92u w=1.12u l=0.13u
X2007 a_1544_5979# REF_MUX_SEL3 VSS.t34 VSS.t33 sg13_lv_nmos ad=0.2516p pd=2.16u as=0.2516p ps=2.16u w=0.74u l=0.13u
X2008 VDD.t615 a_1544_289# a_2297_331# VDD.t67 sg13_lv_pmos ad=0.1918p pd=1.5u as=0.1596p ps=1.22u w=0.84u l=0.13u
X2009 a_5731_15316# a_5705_15546# a_4350_16071# VDD.t34 sg13_lv_pmos ad=0.3808p pd=2.92u as=0.3808p ps=2.92u w=1.12u l=0.13u
X2010 VDD.t380 a_14643_1842# a_15077_1842# VDD.t379 sg13_lv_pmos ad=0.2128p pd=1.5u as=0.3808p ps=2.92u w=1.12u l=0.13u
X2011 VSS.t1217 a_27237_16869# a_27705_16071# VSS.t1216 sg13_lv_nmos ad=0.1665p pd=1.19u as=0.2516p ps=2.16u w=0.74u l=0.13u
X2012 VSS.t864 a_4187_1764.t73 a_22351_7532# VSS.t863 sg13_lv_nmos ad=0.2516p pd=2.16u as=0.1406p ps=1.12u w=0.74u l=0.6u
X2013 a_9675_3889# a_9465_3889# VSS.t154 VSS.t2020 sg13_lv_nmos ad=0.1406p pd=1.12u as=0.1665p ps=1.19u w=0.74u l=0.13u
X2014 a_14009_11568# REF_CLK VSS.t542 VSS.t1306 sg13_lv_nmos ad=0.2516p pd=2.16u as=1.9998p ps=12.915u w=0.74u l=0.13u
X2015 VSS.t583 a_24197_14024# a_24665_13226# VSS.t582 sg13_lv_nmos ad=0.1665p pd=1.19u as=0.2516p ps=2.16u w=0.74u l=0.13u
X2016 a_2019_311# a_1721_331# VDD.t629 VDD.t67 sg13_lv_pmos ad=0.2128p pd=1.5u as=0.1918p ps=1.5u w=1.12u l=0.13u
X2017 VSS.t1018 a_2595_3892.t8 a_8231_3853# VSS.t1421 sg13_lv_nmos ad=0.2516p pd=2.16u as=0.2516p ps=2.16u w=0.74u l=0.13u
X2018 VSS.t657 a_22677_16869# a_23145_16071# VSS.t656 sg13_lv_nmos ad=0.1665p pd=1.19u as=0.2516p ps=2.16u w=0.74u l=0.13u
X2019 a_23633_1842# a_23437_1842# VSS.t591 VSS.t2254 sg13_lv_nmos ad=0.2516p pd=2.16u as=0.1406p ps=1.12u w=0.74u l=0.13u
X2020 VDD.t140 VSS.t324 VDD.t139 VDD.t9 sg13_lv_pmos ad=0.34p pd=2.68u as=0 ps=0 w=1u l=1u
X2021 a_20968_16071# a_20397_16869# VSS.t901 VSS.t2352 sg13_lv_nmos ad=0.1406p pd=1.12u as=0.2516p ps=2.16u w=0.74u l=0.13u
X2022 VSS.t439 VDD.t1624 VSS.t439 VSS.t438 sg13_lv_nmos ad=0.1428p pd=1.52u as=0 ps=0 w=0.42u l=1u
X2023 a_26395_1044# a_26185_1044# VSS.t180 VSS.t179 sg13_lv_nmos ad=0.1406p pd=1.12u as=0.1665p ps=1.19u w=0.74u l=0.13u
X2024 VDD.t1070 a_4187_2434# a_7911_5315# VDD.t347 sg13_lv_pmos ad=0.3808p pd=2.92u as=0.2128p ps=1.5u w=1.12u l=0.6u
X2025 VSS.t122 VDD.t1694 VSS.t122 VSS.t216 sg13_lv_nmos ad=79.8f pd=0.8u as=0 ps=0 w=0.42u l=1u
X2026 VSS.t506 a_9323_1842# a_9757_1842# VSS.t2361 sg13_lv_nmos ad=0.1406p pd=1.12u as=0.2516p ps=2.16u w=0.74u l=0.13u
X2027 a_13470_3889# a_14311_3853# a_14235_3889# VDD.t0 sg13_lv_pmos ad=0.3808p pd=2.92u as=0.2128p ps=1.5u w=1.12u l=0.13u
X2028 a_12715_13226# a_12505_13226# VDD.t1156 VDD.t2 sg13_lv_pmos ad=0.2128p pd=1.5u as=0.252p ps=1.57u w=1.12u l=0.13u
X2029 VSS.t694 a_3747_1047.t3 a_24951_1008# VSS.t693 sg13_lv_nmos ad=0.2516p pd=2.16u as=0.2516p ps=2.16u w=0.74u l=0.13u
X2030 a_26911_17497# a_26673_16869# a_26803_16869# VDD.t368 sg13_lv_pmos ad=0.2128p pd=1.5u as=0.3808p ps=2.92u w=1.12u l=0.2u
X2031 VDD.t975 a_4187_2434# a_17791_2470# VDD.t379 sg13_lv_pmos ad=0.3808p pd=2.92u as=0.2128p ps=1.5u w=1.12u l=0.6u
X2032 a_14513_4687# a_14317_4687# VSS.t723 VSS.t1180 sg13_lv_nmos ad=0.2516p pd=2.16u as=0.1406p ps=1.12u w=0.74u l=0.13u
X2033 a_13019_11521# a_15688_11093# VDD.t545 VDD.t358 sg13_lv_pmos ad=0.3808p pd=2.92u as=0.2128p ps=1.5u w=1.12u l=0.13u
X2034 a_16271_8160# a_16033_7532# a_16163_7532# VDD.t345 sg13_lv_pmos ad=0.2128p pd=1.5u as=0.3808p ps=2.92u w=1.12u l=0.2u
X2035 a_5631_4687# a_5393_4687# a_5523_4687# VSS.t185 sg13_lv_nmos ad=0.1406p pd=1.12u as=0.2516p ps=2.16u w=0.74u l=0.2u
X2036 VDD.t934 a_25717_14024# a_26185_13226# VDD.t2 sg13_lv_pmos ad=0.252p pd=1.57u as=0.3808p ps=2.92u w=1.12u l=0.13u
X2037 VSS.t412 VDD.t1631 VSS.t412 VSS.t411 sg13_lv_nmos ad=0.1428p pd=1.52u as=0 ps=0 w=0.42u l=1u
X2038 VDD.t1151 a_2019_3892.t3 a_22564_3853# VDD.t0 sg13_lv_pmos ad=0.3808p pd=2.92u as=0.3808p ps=2.92u w=1.12u l=0.13u
X2039 a_2297_13577# CHAN1_MUX_SEL0 VDD.t1551 VDD.t2 sg13_lv_pmos ad=0.1596p pd=1.22u as=0.2856p ps=2.36u w=0.84u l=0.13u
X2040 a_24008_13226# a_23437_14024# VDD.t930 VDD.t2 sg13_lv_pmos ad=0.2128p pd=1.5u as=0.3808p ps=2.92u w=1.12u l=0.13u
X2041 a_22351_17497# a_22113_16869# a_22243_16869# VDD.t368 sg13_lv_pmos ad=0.2128p pd=1.5u as=0.3808p ps=2.92u w=1.12u l=0.2u
X2042 VDD.t1012 a_4187_2434# a_27671_17497# VDD.t368 sg13_lv_pmos ad=0.3808p pd=2.92u as=0.2128p ps=1.5u w=1.12u l=0.6u
X2043 a_19550_16071# a_3747_16074.t4 a_21835_16071# VSS.t474 sg13_lv_nmos ad=0.2516p pd=2.16u as=0.1406p ps=1.12u w=0.74u l=0.13u
X2044 VDD.t834 a_3449_12513# a_3747_12493.t0 VDD.t2 sg13_lv_pmos ad=0.4256p pd=3u as=0.2128p ps=1.5u w=1.12u l=0.13u
X2045 VDD.t1390 CHAN0_MUX_SEL1 a_3449_16422# VDD.t34 sg13_lv_pmos ad=0.1918p pd=1.5u as=0.1596p ps=1.22u w=0.84u l=0.13u
X2046 VSS.t435 VDD.t1625 VSS.t435 VSS.t434 sg13_lv_nmos ad=0.1428p pd=1.52u as=0 ps=0 w=0.42u l=1u
X2047 a_25913_14024# a_25717_14024# VDD.t524 VDD.t378 sg13_lv_pmos ad=0.3808p pd=2.92u as=0.2128p ps=1.5u w=1.12u l=0.13u
X2048 VSS.t2259 a_3747_13229.t2 a_27991_13190# VSS.t2258 sg13_lv_nmos ad=0.2516p pd=2.16u as=0.2516p ps=2.16u w=0.74u l=0.13u
X2049 VDD.t1005 a_4187_2434# a_4187_2434# VDD.t360 sg13_lv_pmos ad=0.3808p pd=2.92u as=1.0304p ps=4.08u w=1.12u l=0.6u
X2050 a_3747_1047.t0 a_3449_1395# VDD.t1289 VDD.t67 sg13_lv_pmos ad=0.2128p pd=1.5u as=0.1918p ps=1.5u w=1.12u l=0.13u
X2051 a_24008_1044# a_23437_1842# VSS.t647 VSS.t2253 sg13_lv_nmos ad=0.1406p pd=1.12u as=0.2516p ps=2.16u w=0.74u l=0.13u
X2052 a_13368_1044# a_12797_1842# VDD.t820 VDD.t67 sg13_lv_pmos ad=0.2128p pd=1.5u as=0.3808p ps=2.92u w=1.12u l=0.13u
X2053 a_19833_7532# a_19637_7532# VSS.t113 VSS.t1102 sg13_lv_nmos ad=0.2516p pd=2.16u as=0.1406p ps=1.12u w=0.74u l=0.13u
X2054 VSS.t371 VDD.t1644 VSS.t371 VSS.t372 sg13_lv_nmos ad=79.8f pd=0.8u as=0 ps=0 w=0.42u l=1u
X2055 a_21353_14024# a_21157_14024# VDD.t555 VDD.t378 sg13_lv_pmos ad=0.3808p pd=2.92u as=0.2128p ps=1.5u w=1.12u l=0.13u
X2056 a_9675_6734# a_9465_6734# VDD.t399 VDD.t9 sg13_lv_pmos ad=0.2128p pd=1.5u as=0.252p ps=1.57u w=1.12u l=0.13u
X2057 a_4633_4687# a_4437_4687# VSS.t87 VSS.t1862 sg13_lv_nmos ad=0.2516p pd=2.16u as=0.1406p ps=1.12u w=0.74u l=0.13u
X2058 a_5631_16869# a_5393_16869# a_5523_16869# VSS.t1837 sg13_lv_nmos ad=0.1406p pd=1.12u as=0.2516p ps=2.16u w=0.74u l=0.2u
X2059 VDD.t722 a_14643_14024# a_15077_14024# VDD.t378 sg13_lv_pmos ad=0.2128p pd=1.5u as=0.3808p ps=2.92u w=1.12u l=0.13u
X2060 a_9444_9602# a_6854_11144# a_9712_9602# VSS.t1207 sg13_lv_nmos ad=0.68p pd=4.68u as=0.38p ps=2.38u w=2u l=1u
X2061 a_22590_13226# a_24951_13190# a_24875_13226# VDD.t2 sg13_lv_pmos ad=0.3808p pd=2.92u as=0.2128p ps=1.5u w=1.12u l=0.13u
X2062 VSS.t279 VDD.t1677 VSS.t282 VSS.t281 sg13_lv_nmos ad=79.8f pd=0.8u as=0 ps=0 w=0.42u l=1u
X2063 a_19833_16869# a_19637_16869# VSS.t1073 VSS.t1775 sg13_lv_nmos ad=0.2516p pd=2.16u as=0.1406p ps=1.12u w=0.74u l=0.13u
X2064 VSS.t1409 a_13557_16869# a_14025_16071# VSS.t1408 sg13_lv_nmos ad=0.1665p pd=1.19u as=0.2516p ps=2.16u w=0.74u l=0.13u
X2065 a_11711_5315# a_11473_4687# a_11603_4687# VDD.t347 sg13_lv_pmos ad=0.2128p pd=1.5u as=0.3808p ps=2.92u w=1.12u l=0.2u
X2066 VDD.t945 a_2595_6737.t8 a_8231_6698# VDD.t9 sg13_lv_pmos ad=0.3808p pd=2.92u as=0.3808p ps=2.92u w=1.12u l=0.13u
X2067 VSS.t1286 a_10517_14024# a_10985_13226# VSS.t1285 sg13_lv_nmos ad=0.1665p pd=1.19u as=0.2516p ps=2.16u w=0.74u l=0.13u
X2068 a_24631_7532# a_24393_7532# a_24523_7532# VSS.t2282 sg13_lv_nmos ad=0.1406p pd=1.12u as=0.2516p ps=2.16u w=0.74u l=0.2u
X2069 VSS.t1003 a_2019_6737.t7 a_10404_6698# VSS.t1063 sg13_lv_nmos ad=0.2516p pd=2.16u as=0.2516p ps=2.16u w=0.74u l=0.13u
X2070 VSS.t524 a_4187_1764.t160 a_6391_16869# VSS.t523 sg13_lv_nmos ad=0.2516p pd=2.16u as=0.1406p ps=1.12u w=0.74u l=0.6u
X2071 VDD.t1114 a_4187_2434# a_21591_2470# VDD.t379 sg13_lv_pmos ad=0.3808p pd=2.92u as=0.2128p ps=1.5u w=1.12u l=0.6u
X2072 VSS.t1008 a_23763_16869# a_24197_16869# VSS.t1031 sg13_lv_nmos ad=0.1406p pd=1.12u as=0.2516p ps=2.16u w=0.74u l=0.13u
X2073 a_20071_8160# a_19833_7532# a_19963_7532# VDD.t345 sg13_lv_pmos ad=0.2128p pd=1.5u as=0.3808p ps=2.92u w=1.12u l=0.2u
X2074 a_9193_7532# a_8997_7532# VSS.t1349 VSS.t2120 sg13_lv_nmos ad=0.2516p pd=2.16u as=0.1406p ps=1.12u w=0.74u l=0.13u
X2075 a_2967_16422# CHAN0_MUX_SEL1 a_2873_16422# VSS.t2176 sg13_lv_nmos ad=0.1216p pd=1.02u as=0.2176p ps=1.96u w=0.64u l=0.13u
X2076 VDD.t776 a_5974_11413# a_5974_11413# VDD.t358 sg13_lv_pmos ad=0.2448p pd=2.08u as=0.2826p ps=2.29u w=0.36u l=2u
X2077 a_2873_1395# CHAN3_MUX_SEL1 VDD.t1481 VDD.t67 sg13_lv_pmos ad=0.1596p pd=1.22u as=0.2856p ps=2.36u w=0.84u l=0.13u
X2078 VDD.t554 a_3171_3156.t2 a_23945_3364# VDD.t0 sg13_lv_pmos ad=0.3808p pd=2.92u as=0.3808p ps=2.92u w=1.12u l=0.13u
X2079 VDD.t744 a_14643_7532# a_15077_7532# VDD.t345 sg13_lv_pmos ad=0.2128p pd=1.5u as=0.3808p ps=2.92u w=1.12u l=0.13u
X2080 a_4350_1044# a_6711_1008# a_6635_1044# VDD.t67 sg13_lv_pmos ad=0.3808p pd=2.92u as=0.2128p ps=1.5u w=1.12u l=0.13u
X2081 a_15964_289# CHAN3_MUX_SEL4 a_5731_289# VDD.t67 sg13_lv_pmos ad=0.3304p pd=1.71u as=0.3808p ps=2.92u w=1.12u l=0.13u
X2082 VDD.t730 a_2873_6021# a_3171_6001.t0 VDD.t9 sg13_lv_pmos ad=0.4256p pd=3u as=0.2128p ps=1.5u w=1.12u l=0.13u
X2083 VSS.t869 a_5523_14024# a_5957_14024# VSS.t2350 sg13_lv_nmos ad=0.1406p pd=1.12u as=0.2516p ps=2.16u w=0.74u l=0.13u
X2084 a_13231_17497# a_12993_16869# a_13123_16869# VDD.t368 sg13_lv_pmos ad=0.2128p pd=1.5u as=0.3808p ps=2.92u w=1.12u l=0.2u
X2085 a_10430_16071# a_3747_16074.t7 a_12715_16071# VSS.t471 sg13_lv_nmos ad=0.2516p pd=2.16u as=0.1406p ps=1.12u w=0.74u l=0.13u
X2086 a_11748_11799# a_11491_11918# a_11910_11995# VSS.t1121 sg13_lv_nmos ad=0.1428p pd=1.52u as=37.8f ps=0.6u w=0.42u l=0.13u
X2087 a_16108_15316# a_2595_15338.t2 a_19550_16071# VSS.t1038 sg13_lv_nmos ad=0.2516p pd=2.16u as=0.2516p ps=2.16u w=0.74u l=0.13u
X2088 a_23633_7532# a_23437_7532# VSS.t1312 VSS.t2381 sg13_lv_nmos ad=0.2516p pd=2.16u as=0.1406p ps=1.12u w=0.74u l=0.13u
X2089 VSS.t407 VDD.t1632 VSS.t410 VSS.t409 sg13_lv_nmos ad=79.8f pd=0.8u as=0 ps=0 w=0.42u l=1u
X2090 a_19550_1044# a_20391_1008# a_20315_1044# VDD.t67 sg13_lv_pmos ad=0.3808p pd=2.92u as=0.2128p ps=1.5u w=1.12u l=0.13u
X2091 VDD.t195 VSS.t371 VDD.t194 VDD.t0 sg13_lv_pmos ad=0.34p pd=2.68u as=0 ps=0 w=1u l=1u
X2092 a_19550_3889# a_2019_3892.t4 a_19448_3889# VSS.t1461 sg13_lv_nmos ad=0.2516p pd=2.16u as=0.1406p ps=1.12u w=0.74u l=0.13u
X2093 a_26395_6734# a_26185_6734# VSS.t954 VSS.t953 sg13_lv_nmos ad=0.1406p pd=1.12u as=0.1665p ps=1.19u w=0.74u l=0.13u
X2094 a_1256_1044# CHAN3_MUX_SEL0 VSS.t2090 VSS.t2089 sg13_lv_nmos ad=0.2516p pd=2.16u as=0.2516p ps=2.16u w=0.74u l=0.13u
X2095 VDD.t999 a_4187_2434# a_13991_17497# VDD.t368 sg13_lv_pmos ad=0.3808p pd=2.92u as=0.2128p ps=1.5u w=1.12u l=0.6u
X2096 VDD.t44 VSS.t122 VDD.t43 VDD.t34 sg13_lv_pmos ad=0.34p pd=2.68u as=0 ps=0 w=1u l=1u
X2097 VSS.t478 a_9323_7532# a_9757_7532# VSS.t477 sg13_lv_nmos ad=0.1406p pd=1.12u as=0.2516p ps=2.16u w=0.74u l=0.13u
X2098 VDD.t500 VDD.t502 VDD.t503 VDD.t379 sg13_lv_pmos ad=0.2128p pd=1.5u as=0 ps=0 w=1.12u l=0.2u
X2099 VSS.t467 a_2019_16074.t8 a_7364_16035# VSS.t860 sg13_lv_nmos ad=0.2516p pd=2.16u as=0.2516p ps=2.16u w=0.74u l=0.13u
X2100 VSS.t1076 a_3747_6737.t3 a_24951_6698# VSS.t1791 sg13_lv_nmos ad=0.2516p pd=2.16u as=0.2516p ps=2.16u w=0.74u l=0.13u
X2101 VDD.t1242 a_19637_16869# a_20105_16071# VDD.t34 sg13_lv_pmos ad=0.252p pd=1.57u as=0.3808p ps=2.92u w=1.12u l=0.13u
X2102 VDD.t981 a_4187_2434# a_17791_8160# VDD.t345 sg13_lv_pmos ad=0.3808p pd=2.92u as=0.2128p ps=1.5u w=1.12u l=0.6u
X2103 VSS.t443 a_2595_311.t2 a_20905_519# VSS.t1942 sg13_lv_nmos ad=0.2516p pd=2.16u as=0.2516p ps=2.16u w=0.74u l=0.13u
X2104 a_26911_14652# a_26673_14024# a_26803_14024# VDD.t378 sg13_lv_pmos ad=0.2128p pd=1.5u as=0.3808p ps=2.92u w=1.12u l=0.2u
X2105 VSS.t1335 a_2019_13229.t9 a_4324_13190# VSS.t1334 sg13_lv_nmos ad=0.2516p pd=2.16u as=0.2516p ps=2.16u w=0.74u l=0.13u
X2106 VDD.t536 a_7477_1842# a_7945_1044# VDD.t67 sg13_lv_pmos ad=0.252p pd=1.57u as=0.3808p ps=2.92u w=1.12u l=0.13u
X2107 VDD.t700 a_10083_4687# a_10517_4687# VDD.t347 sg13_lv_pmos ad=0.2128p pd=1.5u as=0.3808p ps=2.92u w=1.12u l=0.13u
X2108 VSS.t786 a_4003_16869# a_4437_16869# VSS.t785 sg13_lv_nmos ad=0.1406p pd=1.12u as=0.2516p ps=2.16u w=0.74u l=0.13u
X2109 VSS.t8 CHAN0_MUX_SEL4 a_15765_15490# VSS.t7 sg13_lv_nmos ad=0.2516p pd=2.16u as=0.2516p ps=2.16u w=0.74u l=0.13u
X2110 a_16108_15316# a_26985_15546# a_25630_16071# VDD.t34 sg13_lv_pmos ad=0.3808p pd=2.92u as=0.3808p ps=2.92u w=1.12u l=0.13u
X2111 a_14513_1842# a_14317_1842# VSS.t1029 VSS.t2000 sg13_lv_nmos ad=0.2516p pd=2.16u as=0.1406p ps=1.12u w=0.74u l=0.13u
X2112 a_5631_1842# a_5393_1842# a_5523_1842# VSS.t1271 sg13_lv_nmos ad=0.1406p pd=1.12u as=0.2516p ps=2.16u w=0.74u l=0.2u
X2113 a_16108_12471# a_23945_12701# a_22590_13226# VDD.t2 sg13_lv_pmos ad=0.3808p pd=2.92u as=0.3808p ps=2.92u w=1.12u l=0.13u
X2114 a_2019_6001.t0 a_1721_6021# VDD.t549 VDD.t9 sg13_lv_pmos ad=0.2128p pd=1.5u as=0.1918p ps=1.5u w=1.12u l=0.13u
X2115 VDD.t1517 a_3171_16074.t5 a_18004_16035# VDD.t34 sg13_lv_pmos ad=0.3808p pd=2.92u as=0.3808p ps=2.92u w=1.12u l=0.13u
X2116 a_22351_14652# a_22113_14024# a_22243_14024# VDD.t378 sg13_lv_pmos ad=0.2128p pd=1.5u as=0.3808p ps=2.92u w=1.12u l=0.2u
X2117 VDD.t1006 a_4187_2434# a_27671_14652# VDD.t378 sg13_lv_pmos ad=0.3808p pd=2.92u as=0.2128p ps=1.5u w=1.12u l=0.6u
X2118 a_10430_13226# a_11271_13190# a_11195_13226# VDD.t2 sg13_lv_pmos ad=0.3808p pd=2.92u as=0.2128p ps=1.5u w=1.12u l=0.13u
X2119 a_22873_16869# a_22677_16869# VDD.t585 VDD.t368 sg13_lv_pmos ad=0.3808p pd=2.92u as=0.2128p ps=1.5u w=1.12u l=0.13u
X2120 a_13470_1044# a_3171_1047.t6 a_14888_1044# VSS.t642 sg13_lv_nmos ad=0.2516p pd=2.16u as=0.1406p ps=1.12u w=0.74u l=0.13u
X2121 a_13470_3889# a_2595_3892.t6 a_14235_3889# VSS.t1767 sg13_lv_nmos ad=0.2516p pd=2.16u as=0.1406p ps=1.12u w=0.74u l=0.13u
X2122 a_18551_4687# a_18313_4687# a_18443_4687# VSS.t1437 sg13_lv_nmos ad=0.1406p pd=1.12u as=0.2516p ps=2.16u w=0.74u l=0.2u
X2123 VSS.t1226 a_21483_14024# a_21917_14024# VSS.t1853 sg13_lv_nmos ad=0.1406p pd=1.12u as=0.2516p ps=2.16u w=0.74u l=0.13u
X2124 a_24008_6734# a_23437_7532# VSS.t1323 VSS.t2380 sg13_lv_nmos ad=0.1406p pd=1.12u as=0.2516p ps=2.16u w=0.74u l=0.13u
X2125 a_17275_3889# a_17065_3889# VDD.t510 VDD.t0 sg13_lv_pmos ad=0.2128p pd=1.5u as=0.252p ps=1.57u w=1.12u l=0.13u
X2126 a_16108_5979# a_17865_6209# a_16510_6734# VDD.t9 sg13_lv_pmos ad=0.3808p pd=2.92u as=0.3808p ps=2.92u w=1.12u l=0.13u
X2127 a_9444_9602# a_9444_10280# VSS.t2295 VSS.t2294 sg13_lv_nmos ad=0.38p pd=2.38u as=0.68p ps=4.68u w=2u l=1u
X2128 VDD.t580 a_16163_16869# a_16597_16869# VDD.t368 sg13_lv_pmos ad=0.2128p pd=1.5u as=0.3808p ps=2.92u w=1.12u l=0.13u
X2129 VDD.t102 VSS.t5 VDD.t101 VDD.t34 sg13_lv_pmos ad=0.34p pd=2.68u as=0 ps=0 w=1u l=1u
X2130 a_1256_289# CHAN3_MUX_SEL2 VSS.t1636 VSS.t1650 sg13_lv_nmos ad=0.2516p pd=2.16u as=0.2516p ps=2.16u w=0.74u l=0.13u
X2131 VDD.t1397 a_3171_13229.t9 a_5844_13190# VDD.t2 sg13_lv_pmos ad=0.3808p pd=2.92u as=0.3808p ps=2.92u w=1.12u l=0.13u
X2132 VDD.t373 a_3747_3892.t6 a_15831_3853# VDD.t0 sg13_lv_pmos ad=0.3808p pd=2.92u as=0.3808p ps=2.92u w=1.12u l=0.13u
X2133 VDD.t310 VSS.t284 VDD.t319 VDD.t2 sg13_lv_pmos ad=0.34p pd=2.68u as=0 ps=0 w=1u l=1u
X2134 a_4633_1842# a_4437_1842# VSS.t1871 VSS.t2127 sg13_lv_nmos ad=0.2516p pd=2.16u as=0.1406p ps=1.12u w=0.74u l=0.13u
X2135 VSS.t58 a_2019_3892.t3 a_22564_3853# VSS.t1460 sg13_lv_nmos ad=0.2516p pd=2.16u as=0.2516p ps=2.16u w=0.74u l=0.13u
X2136 VDD.t911 a_4437_16869# a_4905_16071# VDD.t34 sg13_lv_pmos ad=0.252p pd=1.57u as=0.3808p ps=2.92u w=1.12u l=0.13u
X2137 a_5731_15316# a_3171_15338.t3 a_10430_16071# VSS.t2359 sg13_lv_nmos ad=0.2516p pd=2.16u as=0.2516p ps=2.16u w=0.74u l=0.13u
X2138 VDD.t915 a_11603_16869# a_12037_16869# VDD.t368 sg13_lv_pmos ad=0.2128p pd=1.5u as=0.3808p ps=2.92u w=1.12u l=0.13u
X2139 VSS.t694 a_2019_1047.t2 a_25604_1008# VSS.t1879 sg13_lv_nmos ad=0.2516p pd=2.16u as=0.2516p ps=2.16u w=0.74u l=0.13u
X2140 VDD.t966 a_4187_2434# a_21591_8160# VDD.t345 sg13_lv_pmos ad=0.3808p pd=2.92u as=0.2128p ps=1.5u w=1.12u l=0.6u
X2141 a_16108_289# CHAN3_MUX_SEL4 a_15964_289# VSS.t1474 sg13_lv_nmos ad=0.2516p pd=2.16u as=0.2183p ps=1.33u w=0.74u l=0.13u
X2142 a_15964_3134# a_15765_3308# a_5731_3134# VSS.t2125 sg13_lv_nmos ad=0.2183p pd=1.33u as=0.2516p ps=2.16u w=0.74u l=0.13u
X2143 a_19550_6734# a_19524_6698# a_19448_6734# VDD.t9 sg13_lv_pmos ad=0.3808p pd=2.92u as=0.2128p ps=1.5u w=1.12u l=0.13u
X2144 VDD.t971 a_4187_2434# a_24631_5315# VDD.t347 sg13_lv_pmos ad=0.3808p pd=2.92u as=0.2128p ps=1.5u w=1.12u l=0.6u
X2145 a_4350_3889# a_4324_3853# a_4248_3889# VDD.t0 sg13_lv_pmos ad=0.3808p pd=2.92u as=0.2128p ps=1.5u w=1.12u l=0.13u
X2146 a_22873_1842# a_22677_1842# VDD.t526 VDD.t379 sg13_lv_pmos ad=0.3808p pd=2.92u as=0.2128p ps=1.5u w=1.12u l=0.13u
X2147 a_14888_3889# a_14317_4687# VDD.t826 VDD.t0 sg13_lv_pmos ad=0.2128p pd=1.5u as=0.3808p ps=2.92u w=1.12u l=0.13u
X2148 VSS.t2 a_2873_3176# a_3171_3156.t1 VSS.t2083 sg13_lv_nmos ad=0.2812p pd=2.24u as=0.1406p ps=1.12u w=0.74u l=0.13u
X2149 VSS.t2008 a_24197_16869# a_24665_16071# VSS.t2240 sg13_lv_nmos ad=0.1665p pd=1.19u as=0.2516p ps=2.16u w=0.74u l=0.13u
X2150 a_21835_1044# a_21625_1044# VSS.t1147 VSS.t1146 sg13_lv_nmos ad=0.1406p pd=1.12u as=0.1665p ps=1.19u w=0.74u l=0.13u
X2151 a_22351_4687# a_22113_4687# a_22243_4687# VSS.t2172 sg13_lv_nmos ad=0.1406p pd=1.12u as=0.2516p ps=2.16u w=0.74u l=0.2u
X2152 VDD.t546 a_14851_11918# a_15108_11799# VDD.t358 sg13_lv_pmos ad=0.2639p pd=1.81u as=79.8f ps=0.8u w=0.42u l=0.13u
X2153 VSS.t1675 a_4187_1764.t98 VSS.t1677 VSS.t1676 sg13_lv_nmos ad=1.33p pd=7.38u as=0 ps=0 w=7u l=7u
X2154 a_13231_14652# a_12993_14024# a_13123_14024# VDD.t378 sg13_lv_pmos ad=0.2128p pd=1.5u as=0.3808p ps=2.92u w=1.12u l=0.2u
X2155 VSS.t641 a_2595_1047.t4 a_20391_1008# VSS.t1721 sg13_lv_nmos ad=0.2516p pd=2.16u as=0.2516p ps=2.16u w=0.74u l=0.13u
X2156 VSS.t889 a_16923_4687# a_17357_4687# VSS.t888 sg13_lv_nmos ad=0.1406p pd=1.12u as=0.2516p ps=2.16u w=0.74u l=0.13u
X2157 VSS.t331 VDD.t1657 VSS.t336 VSS.t335 sg13_lv_nmos ad=0.1428p pd=1.52u as=0 ps=0 w=0.42u l=1u
X2158 a_1256_6734# REF_MUX_SEL0 VSS.t1400 VSS.t1524 sg13_lv_nmos ad=0.2516p pd=2.16u as=0.2516p ps=2.16u w=0.74u l=0.13u
X2159 VDD.t1041 a_4187_2434# a_13991_14652# VDD.t378 sg13_lv_pmos ad=0.3808p pd=2.92u as=0.2128p ps=1.5u w=1.12u l=0.6u
X2160 VDD.t478 VDD.t480 VDD.t481 VDD.t345 sg13_lv_pmos ad=0.2128p pd=1.5u as=0 ps=0 w=1.12u l=0.2u
X2161 VDD.t1180 a_2595_16074.t8 a_8231_16035# VDD.t34 sg13_lv_pmos ad=0.3808p pd=2.92u as=0.3808p ps=2.92u w=1.12u l=0.13u
X2162 a_13470_6734# a_14311_6698# a_14235_6734# VDD.t9 sg13_lv_pmos ad=0.3808p pd=2.92u as=0.2128p ps=1.5u w=1.12u l=0.13u
X2163 a_2297_6021# REF_MUX_SEL2 VDD.t424 VDD.t9 sg13_lv_pmos ad=0.1596p pd=1.22u as=0.2856p ps=2.36u w=0.84u l=0.13u
X2164 VDD.t602 a_1544_13226# a_1721_13577# VDD.t2 sg13_lv_pmos ad=0.1918p pd=1.5u as=0.1596p ps=1.22u w=0.84u l=0.13u
X2165 a_13400_10795# a_13132_11110# a_13306_10795# VSS.t2351 sg13_lv_nmos ad=60.89999f pd=0.71u as=0.1428p ps=1.52u w=0.42u l=0.13u
X2166 VDD.t938 a_27237_14024# a_27705_13226# VDD.t2 sg13_lv_pmos ad=0.252p pd=1.57u as=0.3808p ps=2.92u w=1.12u l=0.13u
X2167 VDD.t148 VSS.t265 VDD.t84 VDD.t2 sg13_lv_pmos ad=0.19p pd=1.38u as=0 ps=0 w=1u l=1u
X2168 VSS.t1801 a_10517_1842# a_10985_1044# VSS.t1930 sg13_lv_nmos ad=0.1665p pd=1.19u as=0.2516p ps=2.16u w=0.74u l=0.13u
X2169 a_9675_1044# a_9465_1044# VDD.t1190 VDD.t67 sg13_lv_pmos ad=0.2128p pd=1.5u as=0.252p ps=1.57u w=1.12u l=0.13u
X2170 VSS.t340 VDD.t1656 VSS.t339 VSS.t338 sg13_lv_nmos ad=0.1428p pd=1.52u as=0 ps=0 w=0.42u l=1u
X2171 VDD.t549 a_1544_5979# a_1721_6021# VDD.t9 sg13_lv_pmos ad=0.1918p pd=1.5u as=0.1596p ps=1.22u w=0.84u l=0.13u
X2172 VSS.t119 a_4187_1764.t138 a_23111_16869# VSS.t118 sg13_lv_nmos ad=0.2516p pd=2.16u as=0.1406p ps=1.12u w=0.74u l=0.6u
X2173 a_14513_7532# a_14317_7532# VSS.t160 VSS.t159 sg13_lv_nmos ad=0.2516p pd=2.16u as=0.1406p ps=1.12u w=0.74u l=0.13u
X2174 a_23871_17497# a_23633_16869# a_23763_16869# VDD.t368 sg13_lv_pmos ad=0.2128p pd=1.5u as=0.3808p ps=2.92u w=1.12u l=0.2u
X2175 a_5631_7532# a_5393_7532# a_5523_7532# VSS.t43 sg13_lv_nmos ad=0.1406p pd=1.12u as=0.2516p ps=2.16u w=0.74u l=0.2u
X2176 VDD.t764 a_2019_6737.t3 a_22564_6698# VDD.t9 sg13_lv_pmos ad=0.3808p pd=2.92u as=0.3808p ps=2.92u w=1.12u l=0.13u
X2177 CHAN0_DELAY_OUT_LAST a_27997_16869# VDD.t518 VDD.t368 sg13_lv_pmos ad=0.3808p pd=2.92u as=0.2128p ps=1.5u w=1.12u l=0.13u
X2178 a_4111_14024# CHAN1_DELAY_IN a_4003_14024# VSS.t1795 sg13_lv_nmos ad=0.1406p pd=1.12u as=0.2516p ps=2.16u w=0.74u l=0.2u
X2179 VDD.t582 a_2595_1047.t8 a_8231_1008# VDD.t67 sg13_lv_pmos ad=0.3808p pd=2.92u as=0.3808p ps=2.92u w=1.12u l=0.13u
X2180 VDD.t1449 a_3449_15358# a_3747_15338.t0 VDD.t34 sg13_lv_pmos ad=0.4256p pd=3u as=0.2128p ps=1.5u w=1.12u l=0.13u
X2181 a_1544_15316# CHAN0_MUX_SEL3 VSS.t21 VSS.t20 sg13_lv_nmos ad=0.2516p pd=2.16u as=0.2516p ps=2.16u w=0.74u l=0.13u
X2182 VDD.t1438 a_22677_14024# a_23145_13226# VDD.t2 sg13_lv_pmos ad=0.252p pd=1.57u as=0.3808p ps=2.92u w=1.12u l=0.13u
X2183 a_2019_3156.t1 a_1721_3176# VSS.t2094 VSS.t1521 sg13_lv_nmos ad=0.1406p pd=1.12u as=0.1331p ps=1.12u w=0.74u l=0.13u
X2184 VSS.t101 a_4187_1764.t56 a_10951_4687# VSS.t1068 sg13_lv_nmos ad=0.2516p pd=2.16u as=0.1406p ps=1.12u w=0.74u l=0.6u
X2185 VDD.t1027 a_4187_2434# a_24631_17497# VDD.t368 sg13_lv_pmos ad=0.3808p pd=2.92u as=0.2128p ps=1.5u w=1.12u l=0.6u
X2186 VSS.t24 a_3449_15358# a_3747_15338.t1 VSS.t2108 sg13_lv_nmos ad=0.2812p pd=2.24u as=0.1406p ps=1.12u w=0.74u l=0.13u
X2187 a_20968_13226# a_20397_14024# VDD.t1592 VDD.t2 sg13_lv_pmos ad=0.2128p pd=1.5u as=0.3808p ps=2.92u w=1.12u l=0.13u
X2188 VDD.t6 VSS.t246 VDD.t4 VDD.t2 sg13_lv_pmos ad=0.19p pd=1.38u as=0 ps=0 w=1u l=1u
X2189 VSS.t470 a_3747_16074.t2 a_27991_16035# VSS.t469 sg13_lv_nmos ad=0.2516p pd=2.16u as=0.2516p ps=2.16u w=0.74u l=0.13u
X2190 VSS.t623 DLL_RESETN a_10040_11995# VSS.t919 sg13_lv_nmos ad=0.1626p pd=1.415u as=60.89999f ps=0.71u w=0.42u l=0.13u
X2191 a_13306_10795# a_14111_10917# a_13566_11018# VDD.t358 sg13_lv_pmos ad=0.1428p pd=1.52u as=79.8f ps=0.8u w=0.42u l=0.13u
X2192 a_13470_6734# a_3171_6737.t6 a_14888_6734# VSS.t1914 sg13_lv_nmos ad=0.2516p pd=2.16u as=0.1406p ps=1.12u w=0.74u l=0.13u
X2193 a_18551_1842# a_18313_1842# a_18443_1842# VSS.t2344 sg13_lv_nmos ad=0.1406p pd=1.12u as=0.2516p ps=2.16u w=0.74u l=0.2u
X2194 a_22873_14024# a_22677_14024# VDD.t1512 VDD.t378 sg13_lv_pmos ad=0.3808p pd=2.92u as=0.2128p ps=1.5u w=1.12u l=0.13u
X2195 a_16108_3134# a_17865_3364# a_16510_3889# VDD.t0 sg13_lv_pmos ad=0.3808p pd=2.92u as=0.3808p ps=2.92u w=1.12u l=0.13u
X2196 VDD.t873 a_16163_14024# a_16597_14024# VDD.t378 sg13_lv_pmos ad=0.2128p pd=1.5u as=0.3808p ps=2.92u w=1.12u l=0.13u
X2197 a_13121_11521# a_15688_11557# VDD.t548 VDD.t358 sg13_lv_pmos ad=0.3808p pd=2.92u as=0.2128p ps=1.5u w=1.12u l=0.13u
X2198 VDD.t1423 a_1256_3134# a_2873_3176# VDD.t0 sg13_lv_pmos ad=0.1918p pd=1.5u as=0.1596p ps=1.22u w=0.84u l=0.13u
X2199 VSS.t29 a_20723_4687# a_21157_4687# VSS.t28 sg13_lv_nmos ad=0.1406p pd=1.12u as=0.2516p ps=2.16u w=0.74u l=0.13u
X2200 VDD.t484 VDD.t482 VDD.t483 VDD.t347 sg13_lv_pmos ad=0.3808p pd=2.92u as=0 ps=0 w=1.12u l=0.13u
X2201 a_4633_7532# a_4437_7532# VSS.t16 VSS.t1851 sg13_lv_nmos ad=0.2516p pd=2.16u as=0.1406p ps=1.12u w=0.74u l=0.13u
X2202 a_26911_5315# a_26673_4687# a_26803_4687# VDD.t347 sg13_lv_pmos ad=0.2128p pd=1.5u as=0.3808p ps=2.92u w=1.12u l=0.2u
X2203 VSS.t1470 a_12037_14024# a_12505_13226# VSS.t1469 sg13_lv_nmos ad=0.1665p pd=1.19u as=0.2516p ps=2.16u w=0.74u l=0.13u
X2204 VSS.t1076 a_2019_6737.t2 a_25604_6698# VSS.t1075 sg13_lv_nmos ad=0.2516p pd=2.16u as=0.2516p ps=2.16u w=0.74u l=0.13u
X2205 VDD.t409 a_8997_4687# a_9465_3889# VDD.t0 sg13_lv_pmos ad=0.252p pd=1.57u as=0.3808p ps=2.92u w=1.12u l=0.13u
X2206 VSS.t1100 a_4187_1764.t158 a_7911_16869# VSS.t1099 sg13_lv_nmos ad=0.2516p pd=2.16u as=0.1406p ps=1.12u w=0.74u l=0.6u
X2207 VDD.t1155 a_11603_14024# a_12037_14024# VDD.t378 sg13_lv_pmos ad=0.2128p pd=1.5u as=0.3808p ps=2.92u w=1.12u l=0.13u
X2208 VSS.t1529 a_25283_16869# a_25717_16869# VSS.t2330 sg13_lv_nmos ad=0.1406p pd=1.12u as=0.2516p ps=2.16u w=0.74u l=0.13u
X2209 a_19550_13226# a_21911_13190# a_21835_13226# VDD.t2 sg13_lv_pmos ad=0.3808p pd=2.92u as=0.2128p ps=1.5u w=1.12u l=0.13u
X2210 VSS.t1153 a_10517_16869# a_10985_16071# VSS.t1152 sg13_lv_nmos ad=0.1665p pd=1.19u as=0.2516p ps=2.16u w=0.74u l=0.13u
X2211 VDD.t117 VSS.t274 VDD.t116 VDD.t2 sg13_lv_pmos ad=0.19p pd=1.38u as=0 ps=0 w=1u l=1u
X2212 VSS.t561 a_14851_11918# a_15688_11557# VSS.t560 sg13_lv_nmos ad=0.1406p pd=1.12u as=0.2516p ps=2.16u w=0.74u l=0.13u
X2213 VSS.t2058 a_3171_13229.t4 a_21044_13190# VSS.t2057 sg13_lv_nmos ad=0.2516p pd=2.16u as=0.2516p ps=2.16u w=0.74u l=0.13u
X2214 a_17275_3889# a_17065_3889# VSS.t482 VSS.t1953 sg13_lv_nmos ad=0.1406p pd=1.12u as=0.1665p ps=1.19u w=0.74u l=0.13u
X2215 VSS.t2157 a_20723_16869# a_21157_16869# VSS.t2217 sg13_lv_nmos ad=0.1406p pd=1.12u as=0.2516p ps=2.16u w=0.74u l=0.13u
X2216 a_8433_16869# a_8237_16869# VDD.t1275 VDD.t368 sg13_lv_pmos ad=0.3808p pd=2.92u as=0.2128p ps=1.5u w=1.12u l=0.13u
X2217 VSS.t193 VDD.t1703 VSS.t193 VSS.t196 sg13_lv_nmos ad=79.8f pd=0.8u as=0 ps=0 w=0.42u l=1u
X2218 a_22873_7532# a_22677_7532# VDD.t1499 VDD.t345 sg13_lv_pmos ad=0.3808p pd=2.92u as=0.2128p ps=1.5u w=1.12u l=0.13u
X2219 VSS.t115 a_7043_14024# a_7477_14024# VSS.t1922 sg13_lv_nmos ad=0.1406p pd=1.12u as=0.2516p ps=2.16u w=0.74u l=0.13u
X2220 VSS.t61 a_3747_3892.t6 a_15831_3853# VSS.t60 sg13_lv_nmos ad=0.2516p pd=2.16u as=0.2516p ps=2.16u w=0.74u l=0.13u
X2221 VSS.t989 a_4187_1764.t39 a_23871_4687# VSS.t1648 sg13_lv_nmos ad=0.2516p pd=2.16u as=0.1406p ps=1.12u w=0.74u l=0.6u
X2222 a_21835_6734# a_21625_6734# VSS.t1010 VSS.t1196 sg13_lv_nmos ad=0.1406p pd=1.12u as=0.1665p ps=1.19u w=0.74u l=0.13u
X2223 VSS.t673 a_3747_1047.t5 a_18871_1008# VSS.t1247 sg13_lv_nmos ad=0.2516p pd=2.16u as=0.2516p ps=2.16u w=0.74u l=0.13u
X2224 a_22351_1842# a_22113_1842# a_22243_1842# VSS.t2006 sg13_lv_nmos ad=0.1406p pd=1.12u as=0.2516p ps=2.16u w=0.74u l=0.2u
X2225 VDD.t1341 a_3171_311.t2 a_23945_519# VDD.t67 sg13_lv_pmos ad=0.3808p pd=2.92u as=0.3808p ps=2.92u w=1.12u l=0.13u
X2226 VDD.t177 VSS.t331 VDD.t218 VDD.t9 sg13_lv_pmos ad=0.34p pd=2.68u as=0 ps=0 w=1u l=1u
X2227 VDD.t1369 a_13557_14024# a_14025_13226# VDD.t2 sg13_lv_pmos ad=0.252p pd=1.57u as=0.3808p ps=2.92u w=1.12u l=0.13u
X2228 VDD.t1084 a_4187_2434# a_15511_5315# VDD.t347 sg13_lv_pmos ad=0.3808p pd=2.92u as=0.2128p ps=1.5u w=1.12u l=0.6u
X2229 a_10191_17497# a_9953_16869# a_10083_16869# VDD.t368 sg13_lv_pmos ad=0.2128p pd=1.5u as=0.3808p ps=2.92u w=1.12u l=0.2u
X2230 VDD.t1002 a_4187_2434# a_15511_17497# VDD.t368 sg13_lv_pmos ad=0.3808p pd=2.92u as=0.2128p ps=1.5u w=1.12u l=0.6u
X2231 VSS.t805 a_6126_9506# a_6126_9506# VSS.t803 sg13_lv_nmos ad=0.68p pd=4.68u as=0.38p ps=2.38u w=2u l=1u
X2232 VSS.t1389 a_2595_6737.t4 a_20391_6698# VSS.t1388 sg13_lv_nmos ad=0.2516p pd=2.16u as=0.2516p ps=2.16u w=0.74u l=0.13u
X2233 a_2019_311# a_1721_331# VSS.t18 VSS.t2309 sg13_lv_nmos ad=0.1406p pd=1.12u as=0.1331p ps=1.12u w=0.74u l=0.13u
X2234 VSS.t585 a_16923_1842# a_17357_1842# VSS.t584 sg13_lv_nmos ad=0.1406p pd=1.12u as=0.2516p ps=2.16u w=0.74u l=0.13u
X2235 VDD.t1394 a_2019_3892.t5 a_16484_3853# VDD.t0 sg13_lv_pmos ad=0.3808p pd=2.92u as=0.3808p ps=2.92u w=1.12u l=0.13u
X2236 REF_MUX_OUT a_16851_5999# VSS.t951 VSS.t950 sg13_lv_nmos ad=0.1406p pd=1.12u as=0.1371p ps=1.12u w=0.74u l=0.13u
X2237 VDD.t793 a_2873_7085# a_3171_6737.t0 VDD.t9 sg13_lv_pmos ad=0.4256p pd=3u as=0.2128p ps=1.5u w=1.12u l=0.13u
X2238 a_4350_3889# a_2019_3892.t9 a_4248_3889# VSS.t1457 sg13_lv_nmos ad=0.2516p pd=2.16u as=0.1406p ps=1.12u w=0.74u l=0.13u
X2239 VDD.t182 VSS.t340 VDD.t181 VDD.t9 sg13_lv_pmos ad=0.34p pd=2.68u as=0 ps=0 w=1u l=1u
X2240 VSS.t1169 a_3747_13229.t6 a_15831_13190# VSS.t2265 sg13_lv_nmos ad=0.2516p pd=2.16u as=0.2516p ps=2.16u w=0.74u l=0.13u
X2241 VDD.t961 a_4187_2434# a_10951_17497# VDD.t368 sg13_lv_pmos ad=0.3808p pd=2.92u as=0.2128p ps=1.5u w=1.12u l=0.6u
X2242 VDD.t1356 a_21157_16869# a_21625_16071# VDD.t34 sg13_lv_pmos ad=0.252p pd=1.57u as=0.3808p ps=2.92u w=1.12u l=0.13u
X2243 VDD.t451 VDD.t449 VDD.t450 VDD.t358 sg13_lv_pmos ad=0.68p pd=4.68u as=0 ps=0 w=2u l=1u
X2244 VDD.t131 VSS.t207 VDD.t130 VDD.t34 sg13_lv_pmos ad=0.34p pd=2.68u as=0 ps=0 w=1u l=1u
X2245 VSS.t542 a_14009_11568# a_14111_11568# VSS.t1511 sg13_lv_nmos ad=2.39977p pd=15.495u as=0.2516p ps=2.16u w=0.74u l=0.13u
X2246 a_12715_1044# a_12505_1044# VSS.t816 VSS.t815 sg13_lv_nmos ad=0.1406p pd=1.12u as=0.1665p ps=1.19u w=0.74u l=0.13u
X2247 a_14888_3889# a_14317_4687# VSS.t1182 VSS.t1181 sg13_lv_nmos ad=0.1406p pd=1.12u as=0.2516p ps=2.16u w=0.74u l=0.13u
X2248 a_13231_4687# a_12993_4687# a_13123_4687# VSS.t1103 sg13_lv_nmos ad=0.1406p pd=1.12u as=0.2516p ps=2.16u w=0.74u l=0.2u
X2249 VDD.t1271 a_25283_4687# a_25717_4687# VDD.t347 sg13_lv_pmos ad=0.2128p pd=1.5u as=0.3808p ps=2.92u w=1.12u l=0.13u
X2250 VSS.t1503 a_10517_7532# a_10985_6734# VSS.t1502 sg13_lv_nmos ad=0.1665p pd=1.19u as=0.2516p ps=2.16u w=0.74u l=0.13u
X2251 a_17928_1044# a_17357_1842# VSS.t632 VSS.t970 sg13_lv_nmos ad=0.1406p pd=1.12u as=0.2516p ps=2.16u w=0.74u l=0.13u
X2252 a_16108_5979# a_2595_6001.t2 a_19550_6734# VSS.t718 sg13_lv_nmos ad=0.2516p pd=2.16u as=0.2516p ps=2.16u w=0.74u l=0.13u
X2253 VSS.t1283 a_2019_16074.t9 a_4324_16035# VSS.t2375 sg13_lv_nmos ad=0.2516p pd=2.16u as=0.2516p ps=2.16u w=0.74u l=0.13u
X2254 VSS.t24 CHAN0_MUX_SEL3 a_3543_15358# VSS.t23 sg13_lv_nmos ad=0.1331p pd=1.12u as=0.1216p ps=1.02u w=0.64u l=0.13u
X2255 a_25153_1842# a_24957_1842# VDD.t894 VDD.t379 sg13_lv_pmos ad=0.3808p pd=2.92u as=0.2128p ps=1.5u w=1.12u l=0.13u
X2256 VDD.t752 a_2019_16074.t4 a_19524_16035# VDD.t34 sg13_lv_pmos ad=0.3808p pd=2.92u as=0.3808p ps=2.92u w=1.12u l=0.13u
X2257 VDD.t1238 a_3171_3892.t9 a_5844_3853# VDD.t0 sg13_lv_pmos ad=0.3808p pd=2.92u as=0.3808p ps=2.92u w=1.12u l=0.13u
X2258 a_23871_14652# a_23633_14024# a_23763_14024# VDD.t378 sg13_lv_pmos ad=0.2128p pd=1.5u as=0.3808p ps=2.92u w=1.12u l=0.2u
X2259 a_1544_13226# CHAN1_MUX_SEL1 VSS.t2279 VSS.t20 sg13_lv_nmos ad=0.2516p pd=2.16u as=0.2516p ps=2.16u w=0.74u l=0.13u
X2260 a_16108_15316# a_23945_15546# a_22590_16071# VDD.t34 sg13_lv_pmos ad=0.3808p pd=2.92u as=0.3808p ps=2.92u w=1.12u l=0.13u
X2261 CHAN1_DELAY_OUT_LAST a_27997_14024# VDD.t561 VDD.t378 sg13_lv_pmos ad=0.3808p pd=2.92u as=0.2128p ps=1.5u w=1.12u l=0.13u
X2262 a_10430_13226# a_12791_13190# a_12715_13226# VDD.t2 sg13_lv_pmos ad=0.3808p pd=2.92u as=0.2128p ps=1.5u w=1.12u l=0.13u
X2263 a_19550_1044# a_3171_1047.t4 a_20968_1044# VSS.t639 sg13_lv_nmos ad=0.2516p pd=2.16u as=0.1406p ps=1.12u w=0.74u l=0.13u
X2264 VDD.t1158 CHAN3_MUX_SEL4 a_15765_463# VDD.t67 sg13_lv_pmos ad=0.3808p pd=2.92u as=0.3808p ps=2.92u w=1.12u l=0.13u
X2265 VDD.t984 a_4187_2434# a_5631_5315# VDD.t347 sg13_lv_pmos ad=0.3808p pd=2.92u as=0.2128p ps=1.5u w=1.12u l=0.6u
X2266 a_16108_12471# a_20905_12701# a_19550_13226# VDD.t2 sg13_lv_pmos ad=0.3808p pd=2.92u as=0.3808p ps=2.92u w=1.12u l=0.13u
X2267 a_19550_1044# a_19524_1008# a_19448_1044# VDD.t67 sg13_lv_pmos ad=0.3808p pd=2.92u as=0.2128p ps=1.5u w=1.12u l=0.13u
X2268 VSS.t782 a_4187_1764.t24 a_10951_1842# VSS.t781 sg13_lv_nmos ad=0.2516p pd=2.16u as=0.1406p ps=1.12u w=0.74u l=0.6u
X2269 VDD.t1046 a_4187_2434# a_24631_14652# VDD.t378 sg13_lv_pmos ad=0.3808p pd=2.92u as=0.2128p ps=1.5u w=1.12u l=0.6u
X2270 VSS.t2 VDD.t1640 VSS.t2 VSS.t380 sg13_lv_nmos ad=79.8f pd=0.8u as=0 ps=0 w=0.42u l=1u
X2271 VDD.t1130 a_2595_3892.t7 a_11271_3853# VDD.t0 sg13_lv_pmos ad=0.3808p pd=2.92u as=0.3808p ps=2.92u w=1.12u l=0.13u
X2272 a_18551_7532# a_18313_7532# a_18443_7532# VSS.t615 sg13_lv_nmos ad=0.1406p pd=1.12u as=0.2516p ps=2.16u w=0.74u l=0.2u
X2273 VDD.t777 a_1544_6734# a_2297_7085# VDD.t9 sg13_lv_pmos ad=0.1918p pd=1.5u as=0.1596p ps=1.22u w=0.84u l=0.13u
X2274 a_7288_1044# a_6717_1842# VSS.t681 VSS.t2145 sg13_lv_nmos ad=0.1406p pd=1.12u as=0.2516p ps=2.16u w=0.74u l=0.13u
X2275 a_1544_3134# CHAN2_MUX_SEL3 VSS.t1132 VSS.t1131 sg13_lv_nmos ad=0.2516p pd=2.16u as=0.2516p ps=2.16u w=0.74u l=0.13u
X2276 a_12233_4687# a_12037_4687# VSS.t141 VSS.t140 sg13_lv_nmos ad=0.2516p pd=2.16u as=0.1406p ps=1.12u w=0.74u l=0.13u
X2277 a_17275_6734# a_17065_6734# VDD.t402 VDD.t9 sg13_lv_pmos ad=0.2128p pd=1.5u as=0.252p ps=1.57u w=1.12u l=0.13u
X2278 VSS.t317 VDD.t1664 VSS.t317 VSS.t320 sg13_lv_nmos ad=79.8f pd=0.8u as=0 ps=0 w=0.42u l=1u
X2279 a_3747_16074.t0 a_3449_16422# VDD.t1390 VDD.t34 sg13_lv_pmos ad=0.2128p pd=1.5u as=0.1918p ps=1.5u w=1.12u l=0.13u
X2280 VDD.t1233 a_2019_13229.t8 a_7364_13190# VDD.t2 sg13_lv_pmos ad=0.3808p pd=2.92u as=0.3808p ps=2.92u w=1.12u l=0.13u
X2281 VSS.t1264 a_20723_1842# a_21157_1842# VSS.t2205 sg13_lv_nmos ad=0.1406p pd=1.12u as=0.2516p ps=2.16u w=0.74u l=0.13u
X2282 a_2019_6737.t0 a_1721_7085# VDD.t1199 VDD.t9 sg13_lv_pmos ad=0.2128p pd=1.5u as=0.1918p ps=1.5u w=1.12u l=0.13u
X2283 VDD.t1119 a_13123_16869# a_13557_16869# VDD.t368 sg13_lv_pmos ad=0.2128p pd=1.5u as=0.3808p ps=2.92u w=1.12u l=0.13u
X2284 VDD.t1252 a_3747_6737.t6 a_15831_6698# VDD.t9 sg13_lv_pmos ad=0.3808p pd=2.92u as=0.3808p ps=2.92u w=1.12u l=0.13u
X2285 a_11693_11680# a_10751_11568# a_11491_11918# VDD.t358 sg13_lv_pmos ad=93.45f pd=0.865u as=0.2048p ps=1.63u w=0.42u l=0.13u
X2286 VDD.t707 CHAN1_MUX_SEL4 a_15765_12645# VDD.t2 sg13_lv_pmos ad=0.3808p pd=2.92u as=0.3808p ps=2.92u w=1.12u l=0.13u
X2287 VDD.t1539 a_3747_16074.t3 a_24951_16035# VDD.t34 sg13_lv_pmos ad=0.3808p pd=2.92u as=0.3808p ps=2.92u w=1.12u l=0.13u
X2288 a_1544_289# CHAN3_MUX_SEL3 VSS.t1636 VSS.t1635 sg13_lv_nmos ad=0.2516p pd=2.16u as=0.2516p ps=2.16u w=0.74u l=0.13u
X2289 VDD.t1342 a_3747_3892.t8 a_9751_3853# VDD.t0 sg13_lv_pmos ad=0.3808p pd=2.92u as=0.3808p ps=2.92u w=1.12u l=0.13u
X2290 VDD.t61 VSS.t224 VDD.t87 VDD.t34 sg13_lv_pmos ad=0.34p pd=2.68u as=0 ps=0 w=1u l=1u
X2291 a_22590_1044# a_3747_1047.t3 a_24875_1044# VSS.t692 sg13_lv_nmos ad=0.2516p pd=2.16u as=0.1406p ps=1.12u w=0.74u l=0.13u
X2292 a_13470_1044# a_14311_1008# a_14235_1044# VDD.t67 sg13_lv_pmos ad=0.3808p pd=2.92u as=0.2128p ps=1.5u w=1.12u l=0.13u
X2293 a_4350_6734# a_4324_6698# a_4248_6734# VDD.t9 sg13_lv_pmos ad=0.3808p pd=2.92u as=0.2128p ps=1.5u w=1.12u l=0.13u
X2294 a_8433_14024# a_8237_14024# VDD.t881 VDD.t378 sg13_lv_pmos ad=0.3808p pd=2.92u as=0.2128p ps=1.5u w=1.12u l=0.13u
X2295 a_3171_3892.t0 a_2873_4240# VDD.t376 VDD.t0 sg13_lv_pmos ad=0.2128p pd=1.5u as=0.1918p ps=1.5u w=1.12u l=0.13u
X2296 a_14888_6734# a_14317_7532# VDD.t411 VDD.t9 sg13_lv_pmos ad=0.2128p pd=1.5u as=0.3808p ps=2.92u w=1.12u l=0.13u
X2297 VSS.t1375 a_4187_1764.t7 a_23871_1842# VSS.t2149 sg13_lv_nmos ad=0.2516p pd=2.16u as=0.1406p ps=1.12u w=0.74u l=0.6u
X2298 a_22351_7532# a_22113_7532# a_22243_7532# VSS.t603 sg13_lv_nmos ad=0.1406p pd=1.12u as=0.2516p ps=2.16u w=0.74u l=0.2u
X2299 VSS.t92 a_3747_6737.t5 a_18871_6698# VSS.t1379 sg13_lv_nmos ad=0.2516p pd=2.16u as=0.2516p ps=2.16u w=0.74u l=0.13u
X2300 VDD.t587 a_2019_1047.t3 a_22564_1008# VDD.t67 sg13_lv_pmos ad=0.3808p pd=2.92u as=0.3808p ps=2.92u w=1.12u l=0.13u
X2301 VSS.t154 a_8997_4687# a_9465_3889# VSS.t153 sg13_lv_nmos ad=0.1665p pd=1.19u as=0.2516p ps=2.16u w=0.74u l=0.13u
X2302 VSS.t331 a_2873_6021# a_3171_6001.t1 VSS.t978 sg13_lv_nmos ad=0.2812p pd=2.24u as=0.1406p ps=1.12u w=0.74u l=0.13u
X2303 VDD.t261 VSS.t2 VDD.t330 VDD.t0 sg13_lv_pmos ad=0.34p pd=2.68u as=0 ps=0 w=1u l=1u
X2304 VDD.t1587 a_2297_4240# a_2595_3892.t0 VDD.t0 sg13_lv_pmos ad=0.4256p pd=3u as=0.2128p ps=1.5u w=1.12u l=0.13u
X2305 VDD.t100 VSS.t5 VDD.t98 VDD.t34 sg13_lv_pmos ad=0.19p pd=1.38u as=0 ps=0 w=1u l=1u
X2306 a_5731_12471# a_11785_12701# a_10430_13226# VDD.t2 sg13_lv_pmos ad=0.3808p pd=2.92u as=0.3808p ps=2.92u w=1.12u l=0.13u
X2307 a_15964_15316# a_15765_15490# a_5731_15316# VSS.t2349 sg13_lv_nmos ad=0.2183p pd=1.33u as=0.2516p ps=2.16u w=0.74u l=0.13u
X2308 VSS.t552 a_16923_7532# a_17357_7532# VSS.t2305 sg13_lv_nmos ad=0.1406p pd=1.12u as=0.2516p ps=2.16u w=0.74u l=0.13u
X2309 VDD.t1318 a_3747_16074.t8 a_9751_16035# VDD.t34 sg13_lv_pmos ad=0.3808p pd=2.92u as=0.3808p ps=2.92u w=1.12u l=0.13u
X2310 a_10191_14652# a_9953_14024# a_10083_14024# VDD.t378 sg13_lv_pmos ad=0.2128p pd=1.5u as=0.3808p ps=2.92u w=1.12u l=0.2u
X2311 VDD.t1042 a_4187_2434# a_15511_14652# VDD.t378 sg13_lv_pmos ad=0.3808p pd=2.92u as=0.2128p ps=1.5u w=1.12u l=0.6u
X2312 VSS.t949 REF_MUX_SEL4 a_15765_6153# VSS.t948 sg13_lv_nmos ad=0.2516p pd=2.16u as=0.2516p ps=2.16u w=0.74u l=0.13u
X2313 a_10713_16869# a_10517_16869# VDD.t516 VDD.t368 sg13_lv_pmos ad=0.3808p pd=2.92u as=0.2128p ps=1.5u w=1.12u l=0.13u
X2314 VDD.t185 VSS.t385 VDD.t202 VDD.t0 sg13_lv_pmos ad=0.34p pd=2.68u as=0 ps=0 w=1u l=1u
X2315 a_16793_4687# a_16597_4687# VDD.t509 VDD.t347 sg13_lv_pmos ad=0.3808p pd=2.92u as=0.2128p ps=1.5u w=1.12u l=0.13u
X2316 VSS.t180 a_25717_1842# a_26185_1044# VSS.t1296 sg13_lv_nmos ad=0.1665p pd=1.19u as=0.2516p ps=2.16u w=0.74u l=0.13u
X2317 a_7911_5315# a_7673_4687# a_7803_4687# VDD.t347 sg13_lv_pmos ad=0.2128p pd=1.5u as=0.3808p ps=2.92u w=1.12u l=0.2u
X2318 VDD.t683 a_2595_16074.t9 a_5191_16035# VDD.t34 sg13_lv_pmos ad=0.3808p pd=2.92u as=0.3808p ps=2.92u w=1.12u l=0.13u
X2319 VDD.t1038 a_4187_2434# a_10951_14652# VDD.t378 sg13_lv_pmos ad=0.3808p pd=2.92u as=0.2128p ps=1.5u w=1.12u l=0.6u
X2320 VDD.t314 VSS.t292 VDD.t313 VDD.t2 sg13_lv_pmos ad=0.34p pd=2.68u as=0 ps=0 w=1u l=1u
X2321 a_12715_6734# a_12505_6734# VSS.t1627 VSS.t1626 sg13_lv_nmos ad=0.1406p pd=1.12u as=0.1665p ps=1.19u w=0.74u l=0.13u
X2322 a_13231_1842# a_12993_1842# a_13123_1842# VSS.t1992 sg13_lv_nmos ad=0.1406p pd=1.12u as=0.2516p ps=2.16u w=0.74u l=0.2u
X2323 a_2297_4240# CHAN2_MUX_SEL0 VDD.t711 VDD.t0 sg13_lv_pmos ad=0.1596p pd=1.22u as=0.2856p ps=2.36u w=0.84u l=0.13u
X2324 a_25153_7532# a_24957_7532# VDD.t1138 VDD.t345 sg13_lv_pmos ad=0.3808p pd=2.92u as=0.2128p ps=1.5u w=1.12u l=0.13u
X2325 a_17928_6734# a_17357_7532# VSS.t550 VSS.t549 sg13_lv_nmos ad=0.1406p pd=1.12u as=0.2516p ps=2.16u w=0.74u l=0.13u
X2326 a_5631_14024# a_5393_14024# a_5523_14024# VSS.t2131 sg13_lv_nmos ad=0.1406p pd=1.12u as=0.2516p ps=2.16u w=0.74u l=0.2u
X2327 VSS.t715 CHAN1_MUX_SEL3 a_3543_12513# VSS.t714 sg13_lv_nmos ad=0.1331p pd=1.12u as=0.1216p ps=1.02u w=0.64u l=0.13u
X2328 VSS.t404 VDD.t1633 VSS.t404 VSS.t405 sg13_lv_nmos ad=79.8f pd=0.8u as=0 ps=0 w=0.42u l=1u
X2329 VDD.t558 a_24197_14024# a_24665_13226# VDD.t2 sg13_lv_pmos ad=0.252p pd=1.57u as=0.3808p ps=2.92u w=1.12u l=0.13u
X2330 a_19833_14024# a_19637_14024# VSS.t1431 VSS.t1995 sg13_lv_nmos ad=0.2516p pd=2.16u as=0.1406p ps=1.12u w=0.74u l=0.13u
X2331 a_17791_2470# a_17553_1842# a_17683_1842# VDD.t379 sg13_lv_pmos ad=0.2128p pd=1.5u as=0.3808p ps=2.92u w=1.12u l=0.2u
X2332 VDD.t519 a_1544_3889# a_1721_4240# VDD.t0 sg13_lv_pmos ad=0.1918p pd=1.5u as=0.1596p ps=1.22u w=0.84u l=0.13u
X2333 VSS.t1250 a_4187_1764.t36 a_26151_4687# VSS.t2200 sg13_lv_nmos ad=0.2516p pd=2.16u as=0.1406p ps=1.12u w=0.74u l=0.6u
X2334 a_19550_6734# a_3171_6737.t4 a_20968_6734# VSS.t1912 sg13_lv_nmos ad=0.2516p pd=2.16u as=0.1406p ps=1.12u w=0.74u l=0.13u
X2335 VSS.t568 a_4187_1764.t142 a_20071_16869# VSS.t567 sg13_lv_nmos ad=0.2516p pd=2.16u as=0.1406p ps=1.12u w=0.74u l=0.6u
X2336 VSS.t605 a_4437_1842# a_4905_1044# VSS.t2126 sg13_lv_nmos ad=0.1665p pd=1.19u as=0.2516p ps=2.16u w=0.74u l=0.13u
X2337 VSS.t61 a_2019_3892.t5 a_16484_3853# VSS.t2030 sg13_lv_nmos ad=0.2516p pd=2.16u as=0.2516p ps=2.16u w=0.74u l=0.13u
X2338 a_25153_16869# a_24957_16869# VDD.t718 VDD.t368 sg13_lv_pmos ad=0.3808p pd=2.92u as=0.2128p ps=1.5u w=1.12u l=0.13u
X2339 VSS.t753 a_4187_1764.t128 a_6391_14024# VSS.t752 sg13_lv_nmos ad=0.2516p pd=2.16u as=0.1406p ps=1.12u w=0.74u l=0.6u
X2340 VSS.t1111 a_4187_1764.t88 a_10951_7532# VSS.t1160 sg13_lv_nmos ad=0.2516p pd=2.16u as=0.1406p ps=1.12u w=0.74u l=0.6u
X2341 a_2019_6001.t1 a_1721_6021# VSS.t563 VSS.t498 sg13_lv_nmos ad=0.1406p pd=1.12u as=0.1331p ps=1.12u w=0.74u l=0.13u
X2342 VSS.t74 a_23763_14024# a_24197_14024# VSS.t73 sg13_lv_nmos ad=0.1406p pd=1.12u as=0.2516p ps=2.16u w=0.74u l=0.13u
X2343 VDD.t17 VSS.t317 VDD.t15 VDD.t9 sg13_lv_pmos ad=0.19p pd=1.38u as=0 ps=0 w=1u l=1u
X2344 VSS.t303 VDD.t1669 VSS.t303 VSS.t308 sg13_lv_nmos ad=79.8f pd=0.8u as=0 ps=0 w=0.42u l=1u
X2345 VSS.t1301 a_2595_13229.t2 a_26471_13190# VSS.t1300 sg13_lv_nmos ad=0.2516p pd=2.16u as=0.2516p ps=2.16u w=0.74u l=0.13u
X2346 VDD.t93 VSS.t234 VDD.t92 VDD.t2 sg13_lv_pmos ad=0.19p pd=1.38u as=0 ps=0 w=1u l=1u
X2347 a_7288_6734# a_6717_7532# VSS.t985 VSS.t984 sg13_lv_nmos ad=0.1406p pd=1.12u as=0.2516p ps=2.16u w=0.74u l=0.13u
X2348 VDD.t167 VSS.t452 VDD.t166 VDD.t67 sg13_lv_pmos ad=0.34p pd=2.68u as=0 ps=0 w=1u l=1u
X2349 VSS.t152 a_4187_1764.t64 a_4871_4687# VSS.t625 sg13_lv_nmos ad=0.2516p pd=2.16u as=0.1406p ps=1.12u w=0.74u l=0.6u
X2350 a_5731_5979# a_3171_6001.t3 a_10430_6734# VSS.t1920 sg13_lv_nmos ad=0.2516p pd=2.16u as=0.2516p ps=2.16u w=0.74u l=0.13u
X2351 a_12233_1842# a_12037_1842# VSS.t837 VSS.t836 sg13_lv_nmos ad=0.2516p pd=2.16u as=0.1406p ps=1.12u w=0.74u l=0.13u
X2352 VSS.t103 a_20723_7532# a_21157_7532# VSS.t842 sg13_lv_nmos ad=0.1406p pd=1.12u as=0.2516p ps=2.16u w=0.74u l=0.13u
X2353 VSS.t1117 a_3171_3892.t9 a_5844_3853# VSS.t1766 sg13_lv_nmos ad=0.2516p pd=2.16u as=0.2516p ps=2.16u w=0.74u l=0.13u
X2354 VDD.t957 a_27563_4687# a_27997_4687# VDD.t347 sg13_lv_pmos ad=0.2128p pd=1.5u as=0.3808p ps=2.92u w=1.12u l=0.13u
X2355 VDD.t891 a_13123_14024# a_13557_14024# VDD.t378 sg13_lv_pmos ad=0.2128p pd=1.5u as=0.3808p ps=2.92u w=1.12u l=0.13u
X2356 VSS.t635 a_3171_1047.t8 a_8884_1008# VSS.t634 sg13_lv_nmos ad=0.2516p pd=2.16u as=0.2516p ps=2.16u w=0.74u l=0.13u
X2357 VSS.t458 VDD.t1620 VSS.t456 VSS.t457 sg13_lv_nmos ad=79.8f pd=0.8u as=0 ps=0 w=0.42u l=1u
X2358 VSS.t1847 a_3449_1395# a_3747_1047.t1 VSS.t1846 sg13_lv_nmos ad=0.2812p pd=2.24u as=0.1406p ps=1.12u w=0.74u l=0.13u
X2359 VSS.t1452 a_12037_16869# a_12505_16071# VSS.t1451 sg13_lv_nmos ad=0.1665p pd=1.19u as=0.2516p ps=2.16u w=0.74u l=0.13u
X2360 a_20593_4687# a_20397_4687# VDD.t1142 VDD.t347 sg13_lv_pmos ad=0.3808p pd=2.92u as=0.2128p ps=1.5u w=1.12u l=0.13u
X2361 a_8155_16071# a_7945_16071# VDD.t1145 VDD.t34 sg13_lv_pmos ad=0.2128p pd=1.5u as=0.252p ps=1.57u w=1.12u l=0.13u
X2362 a_14009_11568# REF_CLK VDD.t364 VDD.t358 sg13_lv_pmos ad=0.4088p pd=2.97u as=1.03698p ps=6.245u w=1.12u l=0.13u
X2363 VDD.t399 a_8997_7532# a_9465_6734# VDD.t9 sg13_lv_pmos ad=0.252p pd=1.57u as=0.3808p ps=2.92u w=1.12u l=0.13u
X2364 VDD.t272 VSS.t425 VDD.t278 VDD.t67 sg13_lv_pmos ad=0.34p pd=2.68u as=0 ps=0 w=1u l=1u
X2365 VDD.t156 VSS.t433 VDD.t155 VDD.t67 sg13_lv_pmos ad=0.19p pd=1.38u as=0 ps=0 w=1u l=1u
X2366 VSS.t1762 a_2019_13229.t3 a_22564_13190# VSS.t1761 sg13_lv_nmos ad=0.2516p pd=2.16u as=0.2516p ps=2.16u w=0.74u l=0.13u
X2367 VSS.t627 a_4187_1764.t162 a_4871_16869# VSS.t626 sg13_lv_nmos ad=0.2516p pd=2.16u as=0.1406p ps=1.12u w=0.74u l=0.6u
X2368 a_1544_12471# CHAN1_MUX_SEL3 VDD.t609 VDD.t2 sg13_lv_pmos ad=0.3808p pd=2.92u as=0.3808p ps=2.92u w=1.12u l=0.13u
X2369 VDD.t1503 a_2873_1395# a_3171_1047.t0 VDD.t67 sg13_lv_pmos ad=0.4256p pd=3u as=0.2128p ps=1.5u w=1.12u l=0.13u
X2370 VSS.t393 VDD.t1636 VSS.t393 VSS.t392 sg13_lv_nmos ad=0.1428p pd=1.52u as=0 ps=0 w=0.42u l=1u
X2371 VSS.t1106 a_2595_3892.t7 a_11271_3853# VSS.t1423 sg13_lv_nmos ad=0.2516p pd=2.16u as=0.2516p ps=2.16u w=0.74u l=0.13u
X2372 a_9953_16869# a_9757_16869# VDD.t514 VDD.t368 sg13_lv_pmos ad=0.3808p pd=2.92u as=0.2128p ps=1.5u w=1.12u l=0.13u
X2373 VSS.t659 a_22243_16869# a_22677_16869# VSS.t2329 sg13_lv_nmos ad=0.1406p pd=1.12u as=0.2516p ps=2.16u w=0.74u l=0.13u
X2374 a_22590_6734# a_3747_6737.t3 a_24875_6734# VSS.t1790 sg13_lv_nmos ad=0.2516p pd=2.16u as=0.1406p ps=1.12u w=0.74u l=0.13u
X2375 VDD.t513 a_6283_4687# a_6717_4687# VDD.t347 sg13_lv_pmos ad=0.2128p pd=1.5u as=0.3808p ps=2.92u w=1.12u l=0.13u
X2376 VSS.t901 a_3171_16074.t4 a_21044_16035# VSS.t2194 sg13_lv_nmos ad=0.2516p pd=2.16u as=0.2516p ps=2.16u w=0.74u l=0.13u
X2377 VDD.t1543 a_3747_13229.t2 a_27991_13190# VDD.t2 sg13_lv_pmos ad=0.3808p pd=2.92u as=0.3808p ps=2.92u w=1.12u l=0.13u
X2378 a_21591_2470# a_21353_1842# a_21483_1842# VDD.t379 sg13_lv_pmos ad=0.2128p pd=1.5u as=0.3808p ps=2.92u w=1.12u l=0.2u
X2379 a_6153_1842# a_5957_1842# VDD.t878 VDD.t379 sg13_lv_pmos ad=0.3808p pd=2.92u as=0.2128p ps=1.5u w=1.12u l=0.13u
X2380 a_7390_13226# a_2019_13229.t8 a_7288_13226# VSS.t1743 sg13_lv_nmos ad=0.2516p pd=2.16u as=0.1406p ps=1.12u w=0.74u l=0.13u
X2381 a_3543_1395# CHAN3_MUX_SEL0 a_3449_1395# VSS.t2092 sg13_lv_nmos ad=0.1216p pd=1.02u as=0.2176p ps=1.96u w=0.64u l=0.13u
X2382 VDD.t727 a_16163_1842# a_16597_1842# VDD.t379 sg13_lv_pmos ad=0.2128p pd=1.5u as=0.3808p ps=2.92u w=1.12u l=0.13u
X2383 VSS.t875 a_4003_14024# a_4437_14024# VSS.t2143 sg13_lv_nmos ad=0.1406p pd=1.12u as=0.2516p ps=2.16u w=0.74u l=0.13u
X2384 VSS.t107 a_4187_1764.t71 a_23871_7532# VSS.t883 sg13_lv_nmos ad=0.2516p pd=2.16u as=0.1406p ps=1.12u w=0.74u l=0.6u
X2385 a_11711_17497# a_11473_16869# a_11603_16869# VDD.t368 sg13_lv_pmos ad=0.2128p pd=1.5u as=0.3808p ps=2.92u w=1.12u l=0.2u
X2386 VSS.t540 a_3747_3892.t8 a_9751_3853# VSS.t1946 sg13_lv_nmos ad=0.2516p pd=2.16u as=0.2516p ps=2.16u w=0.74u l=0.13u
X2387 VDD.t890 a_10517_14024# a_10985_13226# VDD.t2 sg13_lv_pmos ad=0.252p pd=1.57u as=0.3808p ps=2.92u w=1.12u l=0.13u
X2388 VDD.t761 a_2019_6737.t5 a_16484_6698# VDD.t9 sg13_lv_pmos ad=0.3808p pd=2.92u as=0.3808p ps=2.92u w=1.12u l=0.13u
X2389 VSS.t788 a_2595_13229.t5 a_17351_13190# VSS.t1490 sg13_lv_nmos ad=0.2516p pd=2.16u as=0.2516p ps=2.16u w=0.74u l=0.13u
X2390 VDD.t1011 a_4187_2434# a_12471_17497# VDD.t368 sg13_lv_pmos ad=0.3808p pd=2.92u as=0.2128p ps=1.5u w=1.12u l=0.6u
X2391 VDD.t389 a_1544_1044# a_2297_1395# VDD.t67 sg13_lv_pmos ad=0.1918p pd=1.5u as=0.1596p ps=1.22u w=0.84u l=0.13u
X2392 a_1544_3889# CHAN2_MUX_SEL1 VDD.t1173 VDD.t0 sg13_lv_pmos ad=0.3808p pd=2.92u as=0.3808p ps=2.92u w=1.12u l=0.13u
X2393 a_15964_5979# REF_MUX_SEL4 a_5731_5979# VDD.t9 sg13_lv_pmos ad=0.3304p pd=1.71u as=0.3808p ps=2.92u w=1.12u l=0.13u
X2394 a_27915_1044# a_27705_1044# VSS.t130 VSS.t129 sg13_lv_nmos ad=0.1406p pd=1.12u as=0.1665p ps=1.19u w=0.74u l=0.13u
X2395 a_17275_1044# a_17065_1044# VDD.t562 VDD.t67 sg13_lv_pmos ad=0.2128p pd=1.5u as=0.252p ps=1.57u w=1.12u l=0.13u
X2396 VSS.t1605 VSS.t1602 VSS.t1604 VSS.t1603 sg13_lv_nmos ad=0.2516p pd=2.16u as=0 ps=0 w=0.74u l=0.6u
X2397 VSS.t1047 a_3747_16074.t6 a_15831_16035# VSS.t2248 sg13_lv_nmos ad=0.2516p pd=2.16u as=0.2516p ps=2.16u w=0.74u l=0.13u
X2398 VSS.t954 a_25717_7532# a_26185_6734# VSS.t1309 sg13_lv_nmos ad=0.1665p pd=1.19u as=0.2516p ps=2.16u w=0.74u l=0.13u
X2399 a_10713_14024# a_10517_14024# VDD.t889 VDD.t378 sg13_lv_pmos ad=0.3808p pd=2.92u as=0.2128p ps=1.5u w=1.12u l=0.13u
X2400 a_13470_3889# a_15831_3853# a_15755_3889# VDD.t0 sg13_lv_pmos ad=0.3808p pd=2.92u as=0.2128p ps=1.5u w=1.12u l=0.13u
X2401 a_26151_17497# a_25913_16869# a_26043_16869# VDD.t368 sg13_lv_pmos ad=0.2128p pd=1.5u as=0.3808p ps=2.92u w=1.12u l=0.2u
X2402 VSS.t222 a_3171_15338.t2 a_23945_15546# VSS.t739 sg13_lv_nmos ad=0.2516p pd=2.16u as=0.2516p ps=2.16u w=0.74u l=0.13u
X2403 VSS.t698 a_3747_13229.t7 a_12791_13190# VSS.t2261 sg13_lv_nmos ad=0.2516p pd=2.16u as=0.2516p ps=2.16u w=0.74u l=0.13u
X2404 VDD.t468 VDD.t466 VDD.t467 VDD.t360 sg13_lv_pmos ad=0.3808p pd=2.92u as=0 ps=0 w=1.12u l=0.13u
X2405 a_13231_7532# a_12993_7532# a_13123_7532# VSS.t1842 sg13_lv_nmos ad=0.1406p pd=1.12u as=0.2516p ps=2.16u w=0.74u l=0.2u
X2406 a_2019_1047.t0 a_1721_1395# VDD.t632 VDD.t67 sg13_lv_pmos ad=0.2128p pd=1.5u as=0.1918p ps=1.5u w=1.12u l=0.13u
X2407 VDD.t974 a_4187_2434# a_10191_2470# VDD.t379 sg13_lv_pmos ad=0.3808p pd=2.92u as=0.2128p ps=1.5u w=1.12u l=0.6u
X2408 a_16108_5979# REF_MUX_SEL4 a_15964_5979# VSS.t947 sg13_lv_nmos ad=0.2516p pd=2.16u as=0.2183p ps=1.33u w=0.74u l=0.13u
X2409 VDD.t855 a_3449_13577# a_3747_13229.t0 VDD.t2 sg13_lv_pmos ad=0.4256p pd=3u as=0.2128p ps=1.5u w=1.12u l=0.13u
X2410 VDD.t597 a_3747_1047.t6 a_15831_1008# VDD.t67 sg13_lv_pmos ad=0.3808p pd=2.92u as=0.3808p ps=2.92u w=1.12u l=0.13u
X2411 a_15108_11015# a_14851_10872# a_15270_10795# VSS.t557 sg13_lv_nmos ad=0.1428p pd=1.52u as=37.8f ps=0.6u w=0.42u l=0.13u
X2412 a_17791_8160# a_17553_7532# a_17683_7532# VDD.t345 sg13_lv_pmos ad=0.2128p pd=1.5u as=0.3808p ps=2.92u w=1.12u l=0.2u
X2413 VDD.t949 a_3171_6737.t9 a_5844_6698# VDD.t9 sg13_lv_pmos ad=0.3808p pd=2.92u as=0.3808p ps=2.92u w=1.12u l=0.13u
X2414 VSS.t1230 a_4187_1764.t4 a_26151_1842# VSS.t2165 sg13_lv_nmos ad=0.2516p pd=2.16u as=0.1406p ps=1.12u w=0.74u l=0.6u
X2415 a_1544_16071# CHAN0_MUX_SEL1 VSS.t774 VSS.t2175 sg13_lv_nmos ad=0.2516p pd=2.16u as=0.2516p ps=2.16u w=0.74u l=0.13u
X2416 VDD.t759 a_2019_16074.t5 a_16484_16035# VDD.t34 sg13_lv_pmos ad=0.3808p pd=2.92u as=0.3808p ps=2.92u w=1.12u l=0.13u
X2417 VSS.t1667 a_4187_1764.t98 VSS.t1669 VSS.t1668 sg13_lv_nmos ad=1.33p pd=7.38u as=0 ps=0 w=7u l=7u
X2418 VSS.t460 VDD.t1619 VSS.t460 VSS.t459 sg13_lv_nmos ad=0.1428p pd=1.52u as=0 ps=0 w=0.42u l=1u
X2419 VDD.t341 VSS.t303 VDD.t339 VDD.t9 sg13_lv_pmos ad=0.19p pd=1.38u as=0 ps=0 w=1u l=1u
X2420 VSS.t932 a_4437_7532# a_4905_6734# VSS.t1850 sg13_lv_nmos ad=0.1665p pd=1.19u as=0.2516p ps=2.16u w=0.74u l=0.13u
X2421 VDD.t1344 a_2595_3892.t2 a_26471_3853# VDD.t0 sg13_lv_pmos ad=0.3808p pd=2.92u as=0.3808p ps=2.92u w=1.12u l=0.13u
X2422 a_25153_14024# a_24957_14024# VDD.t678 VDD.t378 sg13_lv_pmos ad=0.3808p pd=2.92u as=0.2128p ps=1.5u w=1.12u l=0.13u
X2423 VDD.t1297 a_19963_1842# a_20397_1842# VDD.t379 sg13_lv_pmos ad=0.2128p pd=1.5u as=0.3808p ps=2.92u w=1.12u l=0.13u
X2424 a_16108_15316# a_20905_15546# a_19550_16071# VDD.t34 sg13_lv_pmos ad=0.3808p pd=2.92u as=0.3808p ps=2.92u w=1.12u l=0.13u
X2425 VSS.t289 VDD.t1675 VSS.t288 VSS.t287 sg13_lv_nmos ad=0.1428p pd=1.52u as=0 ps=0 w=0.42u l=1u
X2426 a_4350_3889# a_5191_3853# a_5115_3889# VDD.t0 sg13_lv_pmos ad=0.3808p pd=2.92u as=0.2128p ps=1.5u w=1.12u l=0.13u
X2427 a_27433_4687# a_27237_4687# VSS.t1500 VSS.t2314 sg13_lv_nmos ad=0.2516p pd=2.16u as=0.1406p ps=1.12u w=0.74u l=0.13u
X2428 VSS.t200 VDD.t1701 VSS.t200 VSS.t201 sg13_lv_nmos ad=79.8f pd=0.8u as=0 ps=0 w=0.42u l=1u
X2429 VDD.t946 a_2595_6737.t7 a_11271_6698# VDD.t9 sg13_lv_pmos ad=0.3808p pd=2.92u as=0.3808p ps=2.92u w=1.12u l=0.13u
X2430 VDD.t255 VSS.t364 VDD.t253 VDD.t0 sg13_lv_pmos ad=0.19p pd=1.38u as=0 ps=0 w=1u l=1u
X2431 a_9431_16869# a_9193_16869# a_9323_16869# VSS.t1449 sg13_lv_nmos ad=0.1406p pd=1.12u as=0.2516p ps=2.16u w=0.74u l=0.2u
X2432 a_4350_1044# a_4324_1008# a_4248_1044# VDD.t67 sg13_lv_pmos ad=0.3808p pd=2.92u as=0.2128p ps=1.5u w=1.12u l=0.13u
X2433 a_12233_7532# a_12037_7532# VSS.t858 VSS.t1839 sg13_lv_nmos ad=0.2516p pd=2.16u as=0.1406p ps=1.12u w=0.74u l=0.13u
X2434 a_14888_1044# a_14317_1842# VDD.t1375 VDD.t67 sg13_lv_pmos ad=0.2128p pd=1.5u as=0.3808p ps=2.92u w=1.12u l=0.13u
X2435 VSS.t556 a_4187_1764.t32 a_4871_1842# VSS.t555 sg13_lv_nmos ad=0.2516p pd=2.16u as=0.1406p ps=1.12u w=0.74u l=0.6u
X2436 a_19073_4687# a_18877_4687# VDD.t398 VDD.t347 sg13_lv_pmos ad=0.3808p pd=2.92u as=0.2128p ps=1.5u w=1.12u l=0.13u
X2437 VDD.t510 a_16597_4687# a_17065_3889# VDD.t0 sg13_lv_pmos ad=0.252p pd=1.57u as=0.3808p ps=2.92u w=1.12u l=0.13u
X2438 VSS.t122 a_2595_15338.t3 a_8745_15546# VSS.t1037 sg13_lv_nmos ad=0.2516p pd=2.16u as=0.2516p ps=2.16u w=0.74u l=0.13u
X2439 VDD.t920 a_2019_13229.t9 a_4324_13190# VDD.t2 sg13_lv_pmos ad=0.3808p pd=2.92u as=0.3808p ps=2.92u w=1.12u l=0.13u
X2440 VSS.t1129 a_3449_7085# a_3747_6737.t1 VSS.t1128 sg13_lv_nmos ad=0.2812p pd=2.24u as=0.1406p ps=1.12u w=0.74u l=0.13u
X2441 VSS.t497 a_27563_16869# a_27997_16869# VSS.t496 sg13_lv_nmos ad=0.1406p pd=1.12u as=0.2516p ps=2.16u w=0.74u l=0.13u
X2442 VDD.t364 a_15108_11015# a_15053_11110# VDD.t358 sg13_lv_pmos ad=1.10612p pd=6.66u as=93.45f ps=0.865u w=0.42u l=0.13u
X2443 VSS.t1384 a_3171_6737.t8 a_8884_6698# VSS.t1909 sg13_lv_nmos ad=0.2516p pd=2.16u as=0.2516p ps=2.16u w=0.74u l=0.13u
X2444 VDD.t344 CHAN0_MUX_SEL4 a_15765_15490# VDD.t34 sg13_lv_pmos ad=0.3808p pd=2.92u as=0.3808p ps=2.92u w=1.12u l=0.13u
X2445 VDD.t1303 a_3747_6737.t8 a_9751_6698# VDD.t9 sg13_lv_pmos ad=0.3808p pd=2.92u as=0.3808p ps=2.92u w=1.12u l=0.13u
X2446 VDD.t507 a_3747_16074.t4 a_21911_16035# VDD.t34 sg13_lv_pmos ad=0.3808p pd=2.92u as=0.3808p ps=2.92u w=1.12u l=0.13u
X2447 a_9953_14024# a_9757_14024# VDD.t1357 VDD.t378 sg13_lv_pmos ad=0.3808p pd=2.92u as=0.2128p ps=1.5u w=1.12u l=0.13u
X2448 a_21591_8160# a_21353_7532# a_21483_7532# VDD.t345 sg13_lv_pmos ad=0.2128p pd=1.5u as=0.3808p ps=2.92u w=1.12u l=0.2u
X2449 VSS.t357 VDD.t1650 VSS.t357 VSS.t358 sg13_lv_nmos ad=79.8f pd=0.8u as=0 ps=0 w=0.42u l=1u
X2450 a_27048_13226# a_26477_14024# VSS.t1301 VSS.t1366 sg13_lv_nmos ad=0.1406p pd=1.12u as=0.2516p ps=2.16u w=0.74u l=0.13u
X2451 VSS.t240 VDD.t1687 VSS.t240 VSS.t239 sg13_lv_nmos ad=0.1428p pd=1.52u as=0 ps=0 w=0.42u l=1u
X2452 a_6153_7532# a_5957_7532# VDD.t563 VDD.t345 sg13_lv_pmos ad=0.3808p pd=2.92u as=0.2128p ps=1.5u w=1.12u l=0.13u
X2453 a_3543_7085# REF_MUX_SEL0 a_3449_7085# VSS.t1526 sg13_lv_nmos ad=0.1216p pd=1.02u as=0.2176p ps=1.96u w=0.64u l=0.13u
X2454 VSS.t802 a_4187_1764.t61 a_7151_4687# VSS.t1751 sg13_lv_nmos ad=0.2516p pd=2.16u as=0.1406p ps=1.12u w=0.74u l=0.6u
X2455 VDD.t346 a_16163_7532# a_16597_7532# VDD.t345 sg13_lv_pmos ad=0.2128p pd=1.5u as=0.3808p ps=2.92u w=1.12u l=0.13u
X2456 VSS.t1358 a_4187_1764.t106 a_23111_14024# VSS.t1905 sg13_lv_nmos ad=0.2516p pd=2.16u as=0.1406p ps=1.12u w=0.74u l=0.6u
X2457 a_1256_289# CHAN3_MUX_SEL2 VDD.t1213 VDD.t67 sg13_lv_pmos ad=0.3808p pd=2.92u as=0.3808p ps=2.92u w=1.12u l=0.13u
X2458 VDD.t735 a_19203_4687# a_19637_4687# VDD.t347 sg13_lv_pmos ad=0.2128p pd=1.5u as=0.3808p ps=2.92u w=1.12u l=0.13u
X2459 a_11711_14652# a_11473_14024# a_11603_14024# VDD.t378 sg13_lv_pmos ad=0.2128p pd=1.5u as=0.3808p ps=2.92u w=1.12u l=0.2u
X2460 a_5731_15316# a_11785_15546# a_10430_16071# VDD.t34 sg13_lv_pmos ad=0.3808p pd=2.92u as=0.3808p ps=2.92u w=1.12u l=0.13u
X2461 VSS.t1100 a_7803_16869# a_8237_16869# VSS.t1826 sg13_lv_nmos ad=0.1406p pd=1.12u as=0.2516p ps=2.16u w=0.74u l=0.13u
X2462 VDD.t504 a_3747_16074.t9 a_6711_16035# VDD.t34 sg13_lv_pmos ad=0.3808p pd=2.92u as=0.3808p ps=2.92u w=1.12u l=0.13u
X2463 VDD.t1040 a_4187_2434# a_12471_14652# VDD.t378 sg13_lv_pmos ad=0.3808p pd=2.92u as=0.2128p ps=1.5u w=1.12u l=0.6u
X2464 a_27915_6734# a_27705_6734# VSS.t45 VSS.t44 sg13_lv_nmos ad=0.1406p pd=1.12u as=0.1665p ps=1.19u w=0.74u l=0.13u
X2465 a_16108_289# a_15765_463# a_15964_289# VDD.t67 sg13_lv_pmos ad=0.3808p pd=2.92u as=0.3304p ps=1.71u w=1.12u l=0.13u
X2466 VSS.t1617 VSS.t1614 VSS.t1616 VSS.t1615 sg13_lv_nmos ad=0.2516p pd=2.16u as=0 ps=0 w=0.74u l=0.6u
X2467 a_15964_3134# CHAN2_MUX_SEL4 a_5731_3134# VDD.t0 sg13_lv_pmos ad=0.3304p pd=1.71u as=0.3808p ps=2.92u w=1.12u l=0.13u
X2468 a_20831_16869# a_20593_16869# a_20723_16869# VSS.t2159 sg13_lv_nmos ad=0.1406p pd=1.12u as=0.2516p ps=2.16u w=0.74u l=0.2u
X2469 VSS.t371 VDD.t1644 VSS.t371 VSS.t370 sg13_lv_nmos ad=0.1428p pd=1.52u as=0 ps=0 w=0.42u l=1u
X2470 VDD.t410 a_8563_4687# a_8997_4687# VDD.t347 sg13_lv_pmos ad=0.2128p pd=1.5u as=0.3808p ps=2.92u w=1.12u l=0.13u
X2471 VDD.t1054 a_4187_2434# a_10191_8160# VDD.t345 sg13_lv_pmos ad=0.3808p pd=2.92u as=0.2128p ps=1.5u w=1.12u l=0.6u
X2472 a_26151_14652# a_25913_14024# a_26043_14024# VDD.t378 sg13_lv_pmos ad=0.2128p pd=1.5u as=0.3808p ps=2.92u w=1.12u l=0.2u
X2473 VDD.t1081 a_4187_2434# a_13231_5315# VDD.t347 sg13_lv_pmos ad=0.3808p pd=2.92u as=0.2128p ps=1.5u w=1.12u l=0.6u
X2474 VSS.t1699 a_4187_1764.t140 a_21591_16869# VSS.t1698 sg13_lv_nmos ad=0.2516p pd=2.16u as=0.1406p ps=1.12u w=0.74u l=0.6u
X2475 VDD.t1190 a_8997_1842# a_9465_1044# VDD.t67 sg13_lv_pmos ad=0.252p pd=1.57u as=0.3808p ps=2.92u w=1.12u l=0.13u
X2476 a_26673_16869# a_26477_16869# VDD.t626 VDD.t368 sg13_lv_pmos ad=0.3808p pd=2.92u as=0.2128p ps=1.5u w=1.12u l=0.13u
X2477 VSS.t757 a_4187_1764.t126 a_7911_14024# VSS.t756 sg13_lv_nmos ad=0.2516p pd=2.16u as=0.1406p ps=1.12u w=0.74u l=0.6u
X2478 VSS.t1098 a_4187_1764.t68 a_26151_7532# VSS.t1097 sg13_lv_nmos ad=0.2516p pd=2.16u as=0.1406p ps=1.12u w=0.74u l=0.6u
X2479 VSS.t509 a_25283_14024# a_25717_14024# VSS.t508 sg13_lv_nmos ad=0.1406p pd=1.12u as=0.2516p ps=2.16u w=0.74u l=0.13u
X2480 a_11473_1842# a_11277_1842# VDD.t848 VDD.t379 sg13_lv_pmos ad=0.3808p pd=2.92u as=0.2128p ps=1.5u w=1.12u l=0.13u
X2481 VDD.t241 VSS.t350 VDD.t239 VDD.t0 sg13_lv_pmos ad=0.19p pd=1.38u as=0 ps=0 w=1u l=1u
X2482 a_2391_331# CHAN3_MUX_SEL2 a_2297_331# VSS.t1651 sg13_lv_nmos ad=0.1216p pd=1.02u as=0.2176p ps=1.96u w=0.64u l=0.13u
X2483 a_22590_13226# a_3171_13229.t3 a_24008_13226# VSS.t1717 sg13_lv_nmos ad=0.2516p pd=2.16u as=0.1406p ps=1.12u w=0.74u l=0.13u
X2484 VDD.t1178 a_19963_7532# a_20397_7532# VDD.t345 sg13_lv_pmos ad=0.2128p pd=1.5u as=0.3808p ps=2.92u w=1.12u l=0.13u
X2485 a_1544_3889# CHAN2_MUX_SEL1 VSS.t945 VSS.t33 sg13_lv_nmos ad=0.2516p pd=2.16u as=0.2516p ps=2.16u w=0.74u l=0.13u
X2486 a_16108_5979# a_3747_6001.t2 a_25630_6734# VSS.t1484 sg13_lv_nmos ad=0.2516p pd=2.16u as=0.2516p ps=2.16u w=0.74u l=0.13u
X2487 VDD.t294 VSS.t200 VDD.t293 VDD.t34 sg13_lv_pmos ad=0.34p pd=2.68u as=0 ps=0 w=1u l=1u
X2488 a_15964_12471# CHAN1_MUX_SEL4 a_5731_12471# VDD.t2 sg13_lv_pmos ad=0.3304p pd=1.71u as=0.3808p ps=2.92u w=1.12u l=0.13u
X2489 a_27433_1842# a_27237_1842# VSS.t1487 VSS.t2015 sg13_lv_nmos ad=0.2516p pd=2.16u as=0.1406p ps=1.12u w=0.74u l=0.13u
X2490 VDD.t405 a_23003_4687# a_23437_4687# VDD.t347 sg13_lv_pmos ad=0.2128p pd=1.5u as=0.3808p ps=2.92u w=1.12u l=0.13u
X2491 VSS.t82 a_2595_16074.t2 a_26471_16035# VSS.t1520 sg13_lv_nmos ad=0.2516p pd=2.16u as=0.2516p ps=2.16u w=0.74u l=0.13u
X2492 VSS.t578 a_20723_14024# a_21157_14024# VSS.t1353 sg13_lv_nmos ad=0.1406p pd=1.12u as=0.2516p ps=2.16u w=0.74u l=0.13u
X2493 VSS.t980 a_4187_1764.t96 a_4871_7532# VSS.t2378 sg13_lv_nmos ad=0.2516p pd=2.16u as=0.1406p ps=1.12u w=0.74u l=0.6u
X2494 a_4157_4158# CHAN2_DELAY_IN VDD.t356 VDD.t0 sg13_lv_pmos ad=0.3808p pd=2.92u as=0.3808p ps=2.92u w=1.12u l=0.13u
X2495 a_13470_3889# a_3747_3892.t6 a_15755_3889# VSS.t59 sg13_lv_nmos ad=0.2516p pd=2.16u as=0.1406p ps=1.12u w=0.74u l=0.13u
X2496 a_13592_11113# a_13566_11018# VDD.t830 VDD.t358 sg13_lv_pmos ad=0.34p pd=2.68u as=0.36237p ps=2.605u w=1u l=0.13u
X2497 a_2967_331# CHAN3_MUX_SEL3 a_2873_331# VSS.t1637 sg13_lv_nmos ad=0.1216p pd=1.02u as=0.2176p ps=1.96u w=0.64u l=0.13u
X2498 a_18795_3889# a_18585_3889# VDD.t1313 VDD.t0 sg13_lv_pmos ad=0.2128p pd=1.5u as=0.252p ps=1.57u w=1.12u l=0.13u
X2499 a_9675_16071# a_9465_16071# VDD.t567 VDD.t34 sg13_lv_pmos ad=0.2128p pd=1.5u as=0.252p ps=1.57u w=1.12u l=0.13u
X2500 VDD.t1128 a_2595_3892.t5 a_17351_3853# VDD.t0 sg13_lv_pmos ad=0.3808p pd=2.92u as=0.3808p ps=2.92u w=1.12u l=0.13u
X2501 VSS.t1867 a_3449_4240# a_3747_3892.t1 VSS.t1866 sg13_lv_nmos ad=0.2812p pd=2.24u as=0.1406p ps=1.12u w=0.74u l=0.13u
X2502 a_25630_3889# a_27124_3853# a_27048_3889# VDD.t0 sg13_lv_pmos ad=0.3808p pd=2.92u as=0.2128p ps=1.5u w=1.12u l=0.13u
X2503 VSS.t1252 a_2595_3892.t2 a_26471_3853# VSS.t1950 sg13_lv_nmos ad=0.2516p pd=2.16u as=0.2516p ps=2.16u w=0.74u l=0.13u
X2504 a_18313_4687# a_18117_4687# VSS.t2231 VSS.t2311 sg13_lv_nmos ad=0.2516p pd=2.16u as=0.1406p ps=1.12u w=0.74u l=0.13u
X2505 a_5393_16869# a_5197_16869# VSS.t627 VSS.t1640 sg13_lv_nmos ad=0.2516p pd=2.16u as=0.1406p ps=1.12u w=0.74u l=0.13u
X2506 VDD.t589 a_2019_1047.t5 a_16484_1008# VDD.t67 sg13_lv_pmos ad=0.3808p pd=2.92u as=0.3808p ps=2.92u w=1.12u l=0.13u
X2507 a_9431_4687# a_9193_4687# a_9323_4687# VSS.t2323 sg13_lv_nmos ad=0.1406p pd=1.12u as=0.2516p ps=2.16u w=0.74u l=0.2u
X2508 a_4350_3889# a_2595_3892.t9 a_5115_3889# VSS.t1465 sg13_lv_nmos ad=0.2516p pd=2.16u as=0.1406p ps=1.12u w=0.74u l=0.13u
X2509 VSS.t476 a_2019_16074.t3 a_22564_16035# VSS.t1049 sg13_lv_nmos ad=0.2516p pd=2.16u as=0.2516p ps=2.16u w=0.74u l=0.13u
X2510 a_1544_15316# CHAN0_MUX_SEL3 VDD.t353 VDD.t34 sg13_lv_pmos ad=0.3808p pd=2.92u as=0.3808p ps=2.92u w=1.12u l=0.13u
X2511 a_7390_1044# a_2595_1047.t8 a_8155_1044# VSS.t652 sg13_lv_nmos ad=0.2516p pd=2.16u as=0.1406p ps=1.12u w=0.74u l=0.13u
X2512 CHAN2_MUX_OUT a_16851_3154# VSS.t2123 VSS.t2122 sg13_lv_nmos ad=0.1406p pd=1.12u as=0.1371p ps=1.12u w=0.74u l=0.13u
X2513 a_7390_13226# a_3171_13229.t8 a_8808_13226# VSS.t2050 sg13_lv_nmos ad=0.2516p pd=2.16u as=0.1406p ps=1.12u w=0.74u l=0.13u
X2514 a_1544_5979# REF_MUX_SEL3 VDD.t361 VDD.t9 sg13_lv_pmos ad=0.3808p pd=2.92u as=0.3808p ps=2.92u w=1.12u l=0.13u
X2515 a_7390_16071# a_2019_16074.t8 a_7288_16071# VSS.t859 sg13_lv_nmos ad=0.2516p pd=2.16u as=0.1406p ps=1.12u w=0.74u l=0.13u
X2516 a_4350_3889# a_5844_3853# a_5768_3889# VDD.t0 sg13_lv_pmos ad=0.3808p pd=2.92u as=0.2128p ps=1.5u w=1.12u l=0.13u
X2517 a_16108_3134# a_2595_3156.t2 a_19550_3889# VSS.t573 sg13_lv_nmos ad=0.2516p pd=2.16u as=0.2516p ps=2.16u w=0.74u l=0.13u
X2518 VSS.t482 a_16597_4687# a_17065_3889# VSS.t481 sg13_lv_nmos ad=0.1665p pd=1.19u as=0.2516p ps=2.16u w=0.74u l=0.13u
X2519 a_3543_4240# CHAN2_MUX_SEL0 a_3449_4240# VSS.t946 sg13_lv_nmos ad=0.1216p pd=1.02u as=0.2176p ps=1.96u w=0.64u l=0.13u
X2520 a_4350_13226# a_2019_13229.t9 a_4248_13226# VSS.t1333 sg13_lv_nmos ad=0.2516p pd=2.16u as=0.1406p ps=1.12u w=0.74u l=0.13u
X2521 VDD.t58 VSS.t255 VDD.t57 VDD.t2 sg13_lv_pmos ad=0.34p pd=2.68u as=0 ps=0 w=1u l=1u
X2522 VDD.t1228 a_3171_1047.t9 a_5844_1008# VDD.t67 sg13_lv_pmos ad=0.3808p pd=2.92u as=0.3808p ps=2.92u w=1.12u l=0.13u
X2523 VSS.t1968 a_4187_1764.t29 a_7151_1842# VSS.t2163 sg13_lv_nmos ad=0.2516p pd=2.16u as=0.1406p ps=1.12u w=0.74u l=0.6u
X2524 VDD.t123 VSS.t207 VDD.t122 VDD.t34 sg13_lv_pmos ad=0.34p pd=2.68u as=0 ps=0 w=1u l=1u
X2525 VDD.t1156 a_12037_14024# a_12505_13226# VDD.t2 sg13_lv_pmos ad=0.252p pd=1.57u as=0.3808p ps=2.92u w=1.12u l=0.13u
X2526 a_23871_4687# a_23633_4687# a_23763_4687# VSS.t11 sg13_lv_nmos ad=0.1406p pd=1.12u as=0.2516p ps=2.16u w=0.74u l=0.2u
X2527 a_16510_16071# a_18004_16035# a_17928_16071# VDD.t34 sg13_lv_pmos ad=0.3808p pd=2.92u as=0.2128p ps=1.5u w=1.12u l=0.13u
X2528 a_8433_4687# a_8237_4687# VSS.t1016 VSS.t1015 sg13_lv_nmos ad=0.2516p pd=2.16u as=0.1406p ps=1.12u w=0.74u l=0.13u
X2529 a_5731_12471# a_2595_12493.t3 a_7390_13226# VSS.t876 sg13_lv_nmos ad=0.2516p pd=2.16u as=0.2516p ps=2.16u w=0.74u l=0.13u
X2530 a_12656_11554# DLL_RESETN VSS.t918 VSS.t917 sg13_lv_nmos ad=0.2516p pd=2.16u as=0.2516p ps=2.16u w=0.74u l=0.13u
X2531 VDD.t583 a_2595_1047.t7 a_11271_1008# VDD.t67 sg13_lv_pmos ad=0.3808p pd=2.92u as=0.3808p ps=2.92u w=1.12u l=0.13u
X2532 VSS.t132 a_18443_4687# a_18877_4687# VSS.t131 sg13_lv_nmos ad=0.1406p pd=1.12u as=0.2516p ps=2.16u w=0.74u l=0.13u
X2533 a_15511_5315# a_15273_4687# a_15403_4687# VDD.t347 sg13_lv_pmos ad=0.2128p pd=1.5u as=0.3808p ps=2.92u w=1.12u l=0.2u
X2534 VSS.t745 a_2595_16074.t5 a_17351_16035# VSS.t744 sg13_lv_nmos ad=0.2516p pd=2.16u as=0.2516p ps=2.16u w=0.74u l=0.13u
X2535 VDD.t1403 a_3171_13229.t4 a_21044_13190# VDD.t2 sg13_lv_pmos ad=0.3808p pd=2.92u as=0.3808p ps=2.92u w=1.12u l=0.13u
X2536 VSS.t1592 VSS.t1589 VSS.t1591 VSS.t1590 sg13_lv_nmos ad=0.2516p pd=2.16u as=0 ps=0 w=0.74u l=0.6u
X2537 a_1544_6734# REF_MUX_SEL1 VDD.t955 VDD.t9 sg13_lv_pmos ad=0.3808p pd=2.92u as=0.3808p ps=2.92u w=1.12u l=0.13u
X2538 a_27671_17497# a_27433_16869# a_27563_16869# VDD.t368 sg13_lv_pmos ad=0.2128p pd=1.5u as=0.3808p ps=2.92u w=1.12u l=0.2u
X2539 VSS.t2044 a_2595_13229.t6 a_14311_13190# VSS.t2043 sg13_lv_nmos ad=0.2516p pd=2.16u as=0.2516p ps=2.16u w=0.74u l=0.13u
X2540 VDD.t1105 a_4187_2434# a_25391_2470# VDD.t379 sg13_lv_pmos ad=0.3808p pd=2.92u as=0.2128p ps=1.5u w=1.12u l=0.6u
X2541 a_22113_4687# a_21917_4687# VSS.t1092 VSS.t1091 sg13_lv_nmos ad=0.2516p pd=2.16u as=0.1406p ps=1.12u w=0.74u l=0.13u
X2542 a_13470_6734# a_15831_6698# a_15755_6734# VDD.t9 sg13_lv_pmos ad=0.3808p pd=2.92u as=0.2128p ps=1.5u w=1.12u l=0.13u
X2543 VDD.t269 VSS.t416 VDD.t267 VDD.t67 sg13_lv_pmos ad=0.19p pd=1.38u as=0 ps=0 w=1u l=1u
X2544 VSS.t473 a_3747_16074.t7 a_12791_16035# VSS.t472 sg13_lv_nmos ad=0.2516p pd=2.16u as=0.2516p ps=2.16u w=0.74u l=0.13u
X2545 VSS.t816 a_12037_1842# a_12505_1044# VSS.t835 sg13_lv_nmos ad=0.1665p pd=1.19u as=0.2516p ps=2.16u w=0.74u l=0.13u
X2546 VSS.t122 a_2595_15338.t2 a_20905_15546# VSS.t1039 sg13_lv_nmos ad=0.2516p pd=2.16u as=0.2516p ps=2.16u w=0.74u l=0.13u
X2547 a_26673_14024# a_26477_14024# VDD.t936 VDD.t378 sg13_lv_pmos ad=0.3808p pd=2.92u as=0.2128p ps=1.5u w=1.12u l=0.13u
X2548 a_11473_7532# a_11277_7532# VDD.t784 VDD.t345 sg13_lv_pmos ad=0.3808p pd=2.92u as=0.2128p ps=1.5u w=1.12u l=0.13u
X2549 VDD.t1231 a_3747_1047.t8 a_9751_1008# VDD.t67 sg13_lv_pmos ad=0.3808p pd=2.92u as=0.3808p ps=2.92u w=1.12u l=0.13u
X2550 VDD.t1462 a_16851_3154# CHAN2_MUX_OUT VDD.t0 sg13_lv_pmos ad=0.7336p pd=3.55u as=0.2128p ps=1.5u w=1.12u l=0.13u
X2551 VSS.t1026 a_4187_1764.t54 a_12471_4687# VSS.t1531 sg13_lv_nmos ad=0.2516p pd=2.16u as=0.1406p ps=1.12u w=0.74u l=0.6u
X2552 VDD.t770 a_2595_6737.t2 a_26471_6698# VDD.t9 sg13_lv_pmos ad=0.3808p pd=2.92u as=0.3808p ps=2.92u w=1.12u l=0.13u
X2553 a_4350_6734# a_5191_6698# a_5115_6734# VDD.t9 sg13_lv_pmos ad=0.3808p pd=2.92u as=0.2128p ps=1.5u w=1.12u l=0.13u
X2554 a_27433_7532# a_27237_7532# VSS.t825 VSS.t1295 sg13_lv_nmos ad=0.2516p pd=2.16u as=0.1406p ps=1.12u w=0.74u l=0.13u
X2555 VSS.t492 a_10083_16869# a_10517_16869# VSS.t491 sg13_lv_nmos ad=0.1406p pd=1.12u as=0.2516p ps=2.16u w=0.74u l=0.13u
X2556 VDD.t62 VSS.t226 VDD.t61 VDD.t34 sg13_lv_pmos ad=0.19p pd=1.38u as=0 ps=0 w=1u l=1u
X2557 a_7288_16071# a_6717_16869# VDD.t1273 VDD.t34 sg13_lv_pmos ad=0.2128p pd=1.5u as=0.3808p ps=2.92u w=1.12u l=0.13u
X2558 VDD.t1546 a_3747_13229.t6 a_15831_13190# VDD.t2 sg13_lv_pmos ad=0.3808p pd=2.92u as=0.3808p ps=2.92u w=1.12u l=0.13u
X2559 VSS.t276 VDD.t1678 VSS.t276 VSS.t275 sg13_lv_nmos ad=0.1428p pd=1.52u as=0 ps=0 w=0.42u l=1u
X2560 a_6391_16869# a_6153_16869# a_6283_16869# VSS.t1639 sg13_lv_nmos ad=0.1406p pd=1.12u as=0.2516p ps=2.16u w=0.74u l=0.2u
X2561 VSS.t226 VDD.t1690 VSS.t226 VSS.t228 sg13_lv_nmos ad=0.1428p pd=1.52u as=0 ps=0 w=0.42u l=1u
X2562 a_2873_13577# CHAN1_MUX_SEL1 VDD.t1559 VDD.t2 sg13_lv_pmos ad=0.1596p pd=1.22u as=0.2856p ps=2.36u w=0.84u l=0.13u
X2563 VDD.t402 a_16597_7532# a_17065_6734# VDD.t9 sg13_lv_pmos ad=0.252p pd=1.57u as=0.3808p ps=2.92u w=1.12u l=0.13u
X2564 VSS.t937 a_22243_4687# a_22677_4687# VSS.t1515 sg13_lv_nmos ad=0.1406p pd=1.12u as=0.2516p ps=2.16u w=0.74u l=0.13u
X2565 VDD.t1548 a_3171_12493.t2 a_23945_12701# VDD.t2 sg13_lv_pmos ad=0.3808p pd=2.92u as=0.3808p ps=2.92u w=1.12u l=0.13u
X2566 a_17275_13226# a_17065_13226# VSS.t2069 VSS.t2068 sg13_lv_nmos ad=0.1406p pd=1.12u as=0.1665p ps=1.19u w=0.74u l=0.13u
X2567 VSS.t956 a_4187_1764.t159 a_7151_16869# VSS.t1024 sg13_lv_nmos ad=0.2516p pd=2.16u as=0.1406p ps=1.12u w=0.74u l=0.6u
X2568 a_1544_13226# CHAN1_MUX_SEL1 VDD.t1558 VDD.t2 sg13_lv_pmos ad=0.3808p pd=2.92u as=0.3808p ps=2.92u w=1.12u l=0.13u
X2569 VSS.t961 a_24523_16869# a_24957_16869# VSS.t960 sg13_lv_nmos ad=0.1406p pd=1.12u as=0.2516p ps=2.16u w=0.74u l=0.13u
X2570 VDD.t688 a_2595_16074.t3 a_23431_16035# VDD.t34 sg13_lv_pmos ad=0.3808p pd=2.92u as=0.3808p ps=2.92u w=1.12u l=0.13u
X2571 VSS.t5 a_2019_15338.t3 a_5705_15546# VSS.t4 sg13_lv_nmos ad=0.2516p pd=2.16u as=0.2516p ps=2.16u w=0.74u l=0.13u
X2572 a_18313_1842# a_18117_1842# VSS.t587 VSS.t2346 sg13_lv_nmos ad=0.2516p pd=2.16u as=0.1406p ps=1.12u w=0.74u l=0.13u
X2573 VDD.t614 a_13883_4687# a_14317_4687# VDD.t347 sg13_lv_pmos ad=0.2128p pd=1.5u as=0.3808p ps=2.92u w=1.12u l=0.13u
X2574 CHAN3_MUX_OUT a_16851_309# VSS.t766 VSS.t1819 sg13_lv_nmos ad=0.1406p pd=1.12u as=0.1371p ps=1.12u w=0.74u l=0.13u
X2575 a_9431_1842# a_9193_1842# a_9323_1842# VSS.t1928 sg13_lv_nmos ad=0.1406p pd=1.12u as=0.2516p ps=2.16u w=0.74u l=0.2u
X2576 a_7390_6734# a_2595_6737.t8 a_8155_6734# VSS.t1382 sg13_lv_nmos ad=0.2516p pd=2.16u as=0.1406p ps=1.12u w=0.74u l=0.13u
X2577 a_7390_16071# a_8231_16035# a_8155_16071# VDD.t34 sg13_lv_pmos ad=0.3808p pd=2.92u as=0.2128p ps=1.5u w=1.12u l=0.13u
X2578 VSS.t5 VDD.t1705 VSS.t5 VSS.t191 sg13_lv_nmos ad=79.8f pd=0.8u as=0 ps=0 w=0.42u l=1u
X2579 a_27048_16071# a_26477_16869# VSS.t82 VSS.t746 sg13_lv_nmos ad=0.1406p pd=1.12u as=0.2516p ps=2.16u w=0.74u l=0.13u
X2580 a_18795_3889# a_18585_3889# VSS.t1889 VSS.t1888 sg13_lv_nmos ad=0.1406p pd=1.12u as=0.1665p ps=1.19u w=0.74u l=0.13u
X2581 VSS.t810 a_6126_9506# a_5974_11413# VSS.t806 sg13_lv_nmos ad=0.68p pd=4.68u as=0.38p ps=2.38u w=2u l=1u
X2582 VSS.t451 VDD.t1621 VSS.t451 VSS.t453 sg13_lv_nmos ad=79.8f pd=0.8u as=0 ps=0 w=0.42u l=1u
X2583 a_1544_3134# CHAN2_MUX_SEL3 VDD.t799 VDD.t0 sg13_lv_pmos ad=0.3808p pd=2.92u as=0.3808p ps=2.92u w=1.12u l=0.13u
X2584 VDD.t1023 a_4187_2434# a_19311_17497# VDD.t368 sg13_lv_pmos ad=0.3808p pd=2.92u as=0.2128p ps=1.5u w=1.12u l=0.6u
X2585 VSS.t703 a_1544_13226# a_2391_13577# VSS.t702 sg13_lv_nmos ad=0.1331p pd=1.12u as=0.1216p ps=1.02u w=0.64u l=0.13u
X2586 VSS.t1292 a_4187_1764.t93 a_7151_7532# VSS.t1527 sg13_lv_nmos ad=0.2516p pd=2.16u as=0.1406p ps=1.12u w=0.74u l=0.6u
X2587 VDD.t318 VSS.t295 VDD.t314 VDD.t2 sg13_lv_pmos ad=0.19p pd=1.38u as=0 ps=0 w=1u l=1u
X2588 VSS.t925 a_2595_3892.t5 a_17351_3853# VSS.t1419 sg13_lv_nmos ad=0.2516p pd=2.16u as=0.2516p ps=2.16u w=0.74u l=0.13u
X2589 a_25630_3889# a_3171_3892.t2 a_27048_3889# VSS.t1763 sg13_lv_nmos ad=0.2516p pd=2.16u as=0.1406p ps=1.12u w=0.74u l=0.13u
X2590 VSS.t1176 a_4187_1764.t110 a_20071_14024# VSS.t2075 sg13_lv_nmos ad=0.2516p pd=2.16u as=0.1406p ps=1.12u w=0.74u l=0.6u
X2591 VDD.t684 a_2595_12493.t3 a_8745_12701# VDD.t2 sg13_lv_pmos ad=0.3808p pd=2.92u as=0.3808p ps=2.92u w=1.12u l=0.13u
X2592 VDD.t364 a_14009_11568# a_14111_11568# VDD.t358 sg13_lv_pmos ad=1.10612p pd=6.66u as=0.3864p ps=2.93u w=1.12u l=0.13u
X2593 a_23871_1842# a_23633_1842# a_23763_1842# VSS.t2014 sg13_lv_nmos ad=0.1406p pd=1.12u as=0.2516p ps=2.16u w=0.74u l=0.2u
X2594 VSS.t297 VDD.t1673 VSS.t297 VSS.t296 sg13_lv_nmos ad=0.1428p pd=1.52u as=0 ps=0 w=0.42u l=1u
X2595 VDD.t386 a_4003_4687# a_4437_4687# VDD.t347 sg13_lv_pmos ad=0.2128p pd=1.5u as=0.3808p ps=2.92u w=1.12u l=0.13u
X2596 a_8433_1842# a_8237_1842# VSS.t79 VSS.t1537 sg13_lv_nmos ad=0.2516p pd=2.16u as=0.1406p ps=1.12u w=0.74u l=0.13u
X2597 VSS.t488 a_9323_16869# a_9757_16869# VSS.t2189 sg13_lv_nmos ad=0.1406p pd=1.12u as=0.2516p ps=2.16u w=0.74u l=0.13u
X2598 VSS.t424 VDD.t1628 VSS.t427 VSS.t426 sg13_lv_nmos ad=79.8f pd=0.8u as=0 ps=0 w=0.42u l=1u
X2599 VSS.t1067 a_18443_1842# a_18877_1842# VSS.t1261 sg13_lv_nmos ad=0.1406p pd=1.12u as=0.2516p ps=2.16u w=0.74u l=0.13u
X2600 a_1544_289# CHAN3_MUX_SEL3 VDD.t1203 VDD.t67 sg13_lv_pmos ad=0.3808p pd=2.92u as=0.3808p ps=2.92u w=1.12u l=0.13u
X2601 a_5731_3134# a_3171_3156.t3 a_10430_3889# VSS.t962 sg13_lv_nmos ad=0.2516p pd=2.16u as=0.2516p ps=2.16u w=0.74u l=0.13u
X2602 a_26395_16071# a_26185_16071# VDD.t1377 VDD.t34 sg13_lv_pmos ad=0.2128p pd=1.5u as=0.252p ps=1.57u w=1.12u l=0.13u
X2603 VDD.t1065 a_4187_2434# a_25391_8160# VDD.t345 sg13_lv_pmos ad=0.3808p pd=2.92u as=0.2128p ps=1.5u w=1.12u l=0.6u
X2604 a_27671_14652# a_27433_14024# a_27563_14024# VDD.t378 sg13_lv_pmos ad=0.2128p pd=1.5u as=0.3808p ps=2.92u w=1.12u l=0.2u
X2605 a_4350_3889# a_3171_3892.t9 a_5768_3889# VSS.t1765 sg13_lv_nmos ad=0.2516p pd=2.16u as=0.1406p ps=1.12u w=0.74u l=0.13u
X2606 a_22113_1842# a_21917_1842# VSS.t517 VSS.t516 sg13_lv_nmos ad=0.2516p pd=2.16u as=0.1406p ps=1.12u w=0.74u l=0.13u
X2607 a_10328_1044# a_9757_1842# VSS.t504 VSS.t503 sg13_lv_nmos ad=0.1406p pd=1.12u as=0.2516p ps=2.16u w=0.74u l=0.13u
X2608 a_22113_16869# a_21917_16869# VSS.t1699 VSS.t2161 sg13_lv_nmos ad=0.2516p pd=2.16u as=0.1406p ps=1.12u w=0.74u l=0.13u
X2609 VSS.t236 VDD.t1688 VSS.t238 VSS.t237 sg13_lv_nmos ad=79.8f pd=0.8u as=0 ps=0 w=0.42u l=1u
X2610 VSS.t1627 a_12037_7532# a_12505_6734# VSS.t1840 sg13_lv_nmos ad=0.1665p pd=1.19u as=0.2516p ps=2.16u w=0.74u l=0.13u
X2611 a_26673_1842# a_26477_1842# VDD.t853 VDD.t379 sg13_lv_pmos ad=0.3808p pd=2.92u as=0.2128p ps=1.5u w=1.12u l=0.13u
X2612 VDD.t1343 a_2019_3892.t8 a_7364_3853# VDD.t0 sg13_lv_pmos ad=0.3808p pd=2.92u as=0.3808p ps=2.92u w=1.12u l=0.13u
X2613 VDD.t468 VDD.t469 VDD.t470 VDD.t360 sg13_lv_pmos ad=0.2128p pd=1.5u as=0 ps=0 w=1.12u l=0.13u
X2614 VSS.t427 VDD.t1627 VSS.t427 VSS.t428 sg13_lv_nmos ad=0.1428p pd=1.52u as=0 ps=0 w=0.42u l=1u
X2615 a_22590_1044# a_2019_1047.t3 a_22488_1044# VSS.t663 sg13_lv_nmos ad=0.2516p pd=2.16u as=0.1406p ps=1.12u w=0.74u l=0.13u
X2616 a_26151_4687# a_25913_4687# a_26043_4687# VSS.t1314 sg13_lv_nmos ad=0.1406p pd=1.12u as=0.2516p ps=2.16u w=0.74u l=0.2u
X2617 a_23633_16869# a_23437_16869# VDD.t756 VDD.t368 sg13_lv_pmos ad=0.3808p pd=2.92u as=0.2128p ps=1.5u w=1.12u l=0.13u
X2618 a_22590_16071# a_3171_16074.t3 a_24008_16071# VSS.t2210 sg13_lv_nmos ad=0.2516p pd=2.16u as=0.1406p ps=1.12u w=0.74u l=0.13u
X2619 VSS.t1162 a_4187_1764.t130 a_4871_14024# VSS.t1161 sg13_lv_nmos ad=0.2516p pd=2.16u as=0.1406p ps=1.12u w=0.74u l=0.6u
X2620 VSS.t593 a_22243_14024# a_22677_14024# VSS.t2204 sg13_lv_nmos ad=0.1406p pd=1.12u as=0.2516p ps=2.16u w=0.74u l=0.13u
X2621 a_6126_9506# a_6326_10280# VDD.t666 VDD.t358 sg13_lv_pmos ad=0.38p pd=2.38u as=0.38p ps=2.38u w=2u l=1u
X2622 VSS.t1014 a_4187_1764.t22 a_12471_1842# VSS.t1013 sg13_lv_nmos ad=0.2516p pd=2.16u as=0.1406p ps=1.12u w=0.74u l=0.6u
X2623 VDD.t517 a_16923_16869# a_17357_16869# VDD.t368 sg13_lv_pmos ad=0.2128p pd=1.5u as=0.3808p ps=2.92u w=1.12u l=0.13u
X2624 a_15964_15316# CHAN0_MUX_SEL4 a_5731_15316# VDD.t34 sg13_lv_pmos ad=0.3304p pd=1.71u as=0.3808p ps=2.92u w=1.12u l=0.13u
X2625 a_19550_13226# a_3171_13229.t4 a_20968_13226# VSS.t2056 sg13_lv_nmos ad=0.2516p pd=2.16u as=0.1406p ps=1.12u w=0.74u l=0.13u
X2626 VSS.t340 a_3171_6001.t2 a_23945_6209# VSS.t721 sg13_lv_nmos ad=0.2516p pd=2.16u as=0.2516p ps=2.16u w=0.74u l=0.13u
X2627 VDD.t50 VSS.t193 VDD.t49 VDD.t34 sg13_lv_pmos ad=0.34p pd=2.68u as=0 ps=0 w=1u l=1u
X2628 a_8808_1044# a_8237_1842# VSS.t635 VSS.t1536 sg13_lv_nmos ad=0.1406p pd=1.12u as=0.2516p ps=2.16u w=0.74u l=0.13u
X2629 a_13753_4687# a_13557_4687# VSS.t780 VSS.t779 sg13_lv_nmos ad=0.2516p pd=2.16u as=0.1406p ps=1.12u w=0.74u l=0.13u
X2630 a_13592_11561# a_13566_11525# VSS.t31 VSS.t1831 sg13_lv_nmos ad=0.2516p pd=2.16u as=0.1626p ps=1.415u w=0.74u l=0.13u
X2631 a_5778_9057# a_6126_9506# a_6326_10280# VSS.t803 sg13_lv_nmos ad=0.68p pd=4.68u as=0.38p ps=2.38u w=2u l=1u
X2632 a_18795_6734# a_18585_6734# VDD.t605 VDD.t9 sg13_lv_pmos ad=0.2128p pd=1.5u as=0.252p ps=1.57u w=1.12u l=0.13u
X2633 a_4871_4687# a_4633_4687# a_4763_4687# VSS.t995 sg13_lv_nmos ad=0.1406p pd=1.12u as=0.2516p ps=2.16u w=0.74u l=0.2u
X2634 VSS.t513 a_22243_1842# a_22677_1842# VSS.t512 sg13_lv_nmos ad=0.1406p pd=1.12u as=0.2516p ps=2.16u w=0.74u l=0.13u
X2635 a_6913_16869# a_6717_16869# VSS.t524 VSS.t1825 sg13_lv_nmos ad=0.2516p pd=2.16u as=0.1406p ps=1.12u w=0.74u l=0.13u
X2636 a_15270_11995# a_12849_11557# VSS.t561 VSS.t560 sg13_lv_nmos ad=37.8f pd=0.6u as=79.8f ps=0.8u w=0.42u l=0.13u
X2637 VDD.t944 a_2595_6737.t5 a_17351_6698# VDD.t9 sg13_lv_pmos ad=0.3808p pd=2.92u as=0.3808p ps=2.92u w=1.12u l=0.13u
X2638 a_6635_16071# a_6425_16071# VDD.t1282 VDD.t34 sg13_lv_pmos ad=0.2128p pd=1.5u as=0.252p ps=1.57u w=1.12u l=0.13u
X2639 a_25630_6734# a_27124_6698# a_27048_6734# VDD.t9 sg13_lv_pmos ad=0.3808p pd=2.92u as=0.2128p ps=1.5u w=1.12u l=0.13u
X2640 a_18313_7532# a_18117_7532# VSS.t705 VSS.t704 sg13_lv_nmos ad=0.2516p pd=2.16u as=0.1406p ps=1.12u w=0.74u l=0.13u
X2641 a_9431_7532# a_9193_7532# a_9323_7532# VSS.t845 sg13_lv_nmos ad=0.1406p pd=1.12u as=0.2516p ps=2.16u w=0.74u l=0.2u
X2642 VDD.t1094 a_4187_2434# a_6391_2470# VDD.t379 sg13_lv_pmos ad=0.3808p pd=2.92u as=0.2128p ps=1.5u w=1.12u l=0.6u
X2643 a_1544_1044# CHAN3_MUX_SEL1 VDD.t1479 VDD.t67 sg13_lv_pmos ad=0.3808p pd=2.92u as=0.3808p ps=2.92u w=1.12u l=0.13u
X2644 a_7390_16071# a_3171_16074.t8 a_8808_16071# VSS.t2214 sg13_lv_nmos ad=0.2516p pd=2.16u as=0.1406p ps=1.12u w=0.74u l=0.13u
X2645 VDD.t900 a_2595_13229.t2 a_26471_13190# VDD.t2 sg13_lv_pmos ad=0.3808p pd=2.92u as=0.3808p ps=2.92u w=1.12u l=0.13u
X2646 a_13470_1044# a_15831_1008# a_15755_1044# VDD.t67 sg13_lv_pmos ad=0.3808p pd=2.92u as=0.2128p ps=1.5u w=1.12u l=0.13u
X2647 a_22488_3889# a_21917_4687# VDD.t774 VDD.t0 sg13_lv_pmos ad=0.2128p pd=1.5u as=0.3808p ps=2.92u w=1.12u l=0.13u
X2648 a_10520_11982# a_10232_11561# a_10458_11982# VSS.t992 sg13_lv_nmos ad=0.1428p pd=1.52u as=37.8f ps=0.6u w=0.42u l=0.13u
X2649 a_16108_3134# CHAN2_MUX_SEL4 a_15964_3134# VSS.t1141 sg13_lv_nmos ad=0.2516p pd=2.16u as=0.2183p ps=1.33u w=0.74u l=0.13u
X2650 a_4350_13226# a_3171_13229.t9 a_5768_13226# VSS.t2039 sg13_lv_nmos ad=0.2516p pd=2.16u as=0.1406p ps=1.12u w=0.74u l=0.13u
X2651 VSS.t771 a_2873_12513# a_3171_12493.t1 VSS.t994 sg13_lv_nmos ad=0.2812p pd=2.24u as=0.1406p ps=1.12u w=0.74u l=0.13u
X2652 a_4350_6734# a_5844_6698# a_5768_6734# VDD.t9 sg13_lv_pmos ad=0.3808p pd=2.92u as=0.2128p ps=1.5u w=1.12u l=0.13u
X2653 a_4350_16071# a_2019_16074.t9 a_4248_16071# VSS.t2374 sg13_lv_nmos ad=0.2516p pd=2.16u as=0.1406p ps=1.12u w=0.74u l=0.13u
X2654 VDD.t1013 a_4187_2434# a_19311_14652# VDD.t378 sg13_lv_pmos ad=0.3808p pd=2.92u as=0.2128p ps=1.5u w=1.12u l=0.6u
X2655 a_10951_5315# a_10713_4687# a_10843_4687# VDD.t347 sg13_lv_pmos ad=0.2128p pd=1.5u as=0.3808p ps=2.92u w=1.12u l=0.2u
X2656 a_19550_16071# a_19524_16035# a_19448_16071# VDD.t34 sg13_lv_pmos ad=0.3808p pd=2.92u as=0.2128p ps=1.5u w=1.12u l=0.13u
X2657 VSS.t618 a_24523_4687# a_24957_4687# VSS.t987 sg13_lv_nmos ad=0.1406p pd=1.12u as=0.2516p ps=2.16u w=0.74u l=0.13u
X2658 a_23871_7532# a_23633_7532# a_23763_7532# VSS.t944 sg13_lv_nmos ad=0.1406p pd=1.12u as=0.2516p ps=2.16u w=0.74u l=0.2u
X2659 VDD.t1115 a_4187_2434# a_20831_2470# VDD.t379 sg13_lv_pmos ad=0.3808p pd=2.92u as=0.2128p ps=1.5u w=1.12u l=0.6u
X2660 a_14513_16869# a_14317_16869# VDD.t568 VDD.t368 sg13_lv_pmos ad=0.3808p pd=2.92u as=0.2128p ps=1.5u w=1.12u l=0.13u
X2661 a_8433_7532# a_8237_7532# VSS.t891 VSS.t2229 sg13_lv_nmos ad=0.2516p pd=2.16u as=0.1406p ps=1.12u w=0.74u l=0.13u
X2662 VDD.t1327 a_2595_1047.t2 a_26471_1008# VDD.t67 sg13_lv_pmos ad=0.3808p pd=2.92u as=0.3808p ps=2.92u w=1.12u l=0.13u
X2663 a_4350_1044# a_5191_1008# a_5115_1044# VDD.t67 sg13_lv_pmos ad=0.3808p pd=2.92u as=0.2128p ps=1.5u w=1.12u l=0.13u
X2664 VDD.t1236 a_2019_13229.t3 a_22564_13190# VDD.t2 sg13_lv_pmos ad=0.3808p pd=2.92u as=0.3808p ps=2.92u w=1.12u l=0.13u
X2665 a_23111_16869# a_22873_16869# a_23003_16869# VSS.t2220 sg13_lv_nmos ad=0.1406p pd=1.12u as=0.2516p ps=2.16u w=0.74u l=0.2u
X2666 VSS.t90 a_18443_7532# a_18877_7532# VSS.t1622 sg13_lv_nmos ad=0.1406p pd=1.12u as=0.2516p ps=2.16u w=0.74u l=0.13u
X2667 VSS.t2 VDD.t1640 VSS.t2 VSS.t379 sg13_lv_nmos ad=0.1428p pd=1.52u as=0 ps=0 w=0.42u l=1u
X2668 a_9431_14024# a_9193_14024# a_9323_14024# VSS.t1926 sg13_lv_nmos ad=0.1406p pd=1.12u as=0.2516p ps=2.16u w=0.74u l=0.2u
X2669 a_5731_12471# a_2019_12493.t3 a_4350_13226# VSS.t907 sg13_lv_nmos ad=0.2516p pd=2.16u as=0.2516p ps=2.16u w=0.74u l=0.13u
X2670 VSS.t808 a_6126_9506# a_5974_11413# VSS.t806 sg13_lv_nmos ad=0.68p pd=4.68u as=0.38p ps=2.38u w=2u l=1u
X2671 VSS.t371 VDD.t1642 VSS.t371 VSS.t376 sg13_lv_nmos ad=79.8f pd=0.8u as=0 ps=0 w=0.42u l=1u
X2672 REF_MUX_OUT a_16851_5999# VDD.t713 VDD.t9 sg13_lv_pmos ad=0.2128p pd=1.5u as=0.2086p ps=1.5u w=1.12u l=0.13u
X2673 a_1256_5979# REF_MUX_SEL2 VSS.t34 VSS.t182 sg13_lv_nmos ad=0.2516p pd=2.16u as=0.2516p ps=2.16u w=0.74u l=0.13u
X2674 VSS.t1086 a_2595_16074.t6 a_14311_16035# VSS.t1085 sg13_lv_nmos ad=0.2516p pd=2.16u as=0.2516p ps=2.16u w=0.74u l=0.13u
X2675 VSS.t317 VDD.t1664 VSS.t317 VSS.t319 sg13_lv_nmos ad=0.1428p pd=1.52u as=0 ps=0 w=0.42u l=1u
X2676 VSS.t76 a_1256_13226# a_2967_13577# VSS.t1397 sg13_lv_nmos ad=0.1331p pd=1.12u as=0.1216p ps=1.02u w=0.64u l=0.13u
X2677 a_7390_13226# a_7364_13190# a_7288_13226# VDD.t2 sg13_lv_pmos ad=0.3808p pd=2.92u as=0.2128p ps=1.5u w=1.12u l=0.13u
X2678 a_22113_7532# a_21917_7532# VSS.t570 VSS.t799 sg13_lv_nmos ad=0.2516p pd=2.16u as=0.1406p ps=1.12u w=0.74u l=0.13u
X2679 VSS.t130 a_27237_1842# a_27705_1044# VSS.t2016 sg13_lv_nmos ad=0.1665p pd=1.19u as=0.2516p ps=2.16u w=0.74u l=0.13u
X2680 VDD.t562 a_16597_1842# a_17065_1044# VDD.t67 sg13_lv_pmos ad=0.252p pd=1.57u as=0.3808p ps=2.92u w=1.12u l=0.13u
X2681 VSS.t1276 a_2595_13229.t7 a_11271_13190# VSS.t1495 sg13_lv_nmos ad=0.2516p pd=2.16u as=0.2516p ps=2.16u w=0.74u l=0.13u
X2682 a_10328_6734# a_9757_7532# VSS.t1003 VSS.t1002 sg13_lv_nmos ad=0.1406p pd=1.12u as=0.2516p ps=2.16u w=0.74u l=0.13u
X2683 VSS.t364 a_3171_3156.t3 a_11785_3364# VSS.t963 sg13_lv_nmos ad=0.2516p pd=2.16u as=0.2516p ps=2.16u w=0.74u l=0.13u
X2684 a_2595_1047.t1 a_2297_1395# VSS.t94 VSS.t93 sg13_lv_nmos ad=0.1406p pd=1.12u as=0.1331p ps=1.12u w=0.74u l=0.13u
X2685 VSS.t589 a_27563_14024# a_27997_14024# VSS.t588 sg13_lv_nmos ad=0.1406p pd=1.12u as=0.2516p ps=2.16u w=0.74u l=0.13u
X2686 a_26673_7532# a_26477_7532# VDD.t1256 VDD.t345 sg13_lv_pmos ad=0.3808p pd=2.92u as=0.2128p ps=1.5u w=1.12u l=0.13u
X2687 a_10191_2470# a_9953_1842# a_10083_1842# VDD.t379 sg13_lv_pmos ad=0.2128p pd=1.5u as=0.3808p ps=2.92u w=1.12u l=0.2u
X2688 VSS.t2032 a_4187_1764.t34 a_27671_4687# VSS.t2031 sg13_lv_nmos ad=0.2516p pd=2.16u as=0.1406p ps=1.12u w=0.74u l=0.6u
X2689 VDD.t354 CHAN0_MUX_SEL3 a_3449_15358# VDD.t34 sg13_lv_pmos ad=0.1918p pd=1.5u as=0.1596p ps=1.22u w=0.84u l=0.13u
X2690 VSS.t150 a_2019_311# a_17865_519# VSS.t149 sg13_lv_nmos ad=0.2516p pd=2.16u as=0.2516p ps=2.16u w=0.74u l=0.13u
X2691 a_22590_6734# a_2019_6737.t3 a_22488_6734# VSS.t1058 sg13_lv_nmos ad=0.2516p pd=2.16u as=0.1406p ps=1.12u w=0.74u l=0.13u
X2692 a_26151_1842# a_25913_1842# a_26043_1842# VSS.t1436 sg13_lv_nmos ad=0.1406p pd=1.12u as=0.2516p ps=2.16u w=0.74u l=0.2u
X2693 a_23633_14024# a_23437_14024# VDD.t931 VDD.t378 sg13_lv_pmos ad=0.3808p pd=2.92u as=0.2128p ps=1.5u w=1.12u l=0.13u
X2694 VSS.t18 a_1544_289# a_2391_331# VSS.t763 sg13_lv_nmos ad=0.1331p pd=1.12u as=0.1216p ps=1.02u w=0.64u l=0.13u
X2695 VSS.t1041 a_4187_1764.t86 a_12471_7532# VSS.t1040 sg13_lv_nmos ad=0.2516p pd=2.16u as=0.1406p ps=1.12u w=0.74u l=0.6u
X2696 a_8808_16071# a_8237_16869# VDD.t1277 VDD.t34 sg13_lv_pmos ad=0.2128p pd=1.5u as=0.3808p ps=2.92u w=1.12u l=0.13u
X2697 VDD.t642 a_16923_14024# a_17357_14024# VDD.t378 sg13_lv_pmos ad=0.2128p pd=1.5u as=0.3808p ps=2.92u w=1.12u l=0.13u
X2698 VDD.t1165 a_2595_13229.t5 a_17351_13190# VDD.t2 sg13_lv_pmos ad=0.3808p pd=2.92u as=0.3808p ps=2.92u w=1.12u l=0.13u
X2699 a_6326_10280# a_6126_9506# a_5778_9057# VSS.t803 sg13_lv_nmos ad=0.42p pd=2.42u as=0.68p ps=4.68u w=2u l=1u
X2700 VDD.t980 a_4187_2434# a_19311_5315# VDD.t347 sg13_lv_pmos ad=0.3808p pd=2.92u as=0.2128p ps=1.5u w=1.12u l=0.6u
X2701 a_7911_16869# a_7673_16869# a_7803_16869# VSS.t1209 sg13_lv_nmos ad=0.1406p pd=1.12u as=0.2516p ps=2.16u w=0.74u l=0.2u
X2702 a_8808_6734# a_8237_7532# VSS.t1384 VSS.t2228 sg13_lv_nmos ad=0.1406p pd=1.12u as=0.2516p ps=2.16u w=0.74u l=0.13u
X2703 VDD.t1279 a_3449_6021# a_3747_6001.t0 VDD.t9 sg13_lv_pmos ad=0.4256p pd=3u as=0.2128p ps=1.5u w=1.12u l=0.13u
X2704 VDD.t42 VSS.t122 VDD.t40 VDD.t34 sg13_lv_pmos ad=0.19p pd=1.38u as=0 ps=0 w=1u l=1u
X2705 a_18795_13226# a_18585_13226# VSS.t834 VSS.t2065 sg13_lv_nmos ad=0.1406p pd=1.12u as=0.1665p ps=1.19u w=0.74u l=0.13u
X2706 a_13753_1842# a_13557_1842# VSS.t796 VSS.t2246 sg13_lv_nmos ad=0.2516p pd=2.16u as=0.1406p ps=1.12u w=0.74u l=0.13u
X2707 a_4248_16071# a_4157_16340# VDD.t888 VDD.t34 sg13_lv_pmos ad=0.2128p pd=1.5u as=0.3808p ps=2.92u w=1.12u l=0.13u
X2708 VDD.t1544 a_3747_13229.t7 a_12791_13190# VDD.t2 sg13_lv_pmos ad=0.3808p pd=2.92u as=0.3808p ps=2.92u w=1.12u l=0.13u
X2709 VSS.t864 a_22243_7532# a_22677_7532# VSS.t2306 sg13_lv_nmos ad=0.1406p pd=1.12u as=0.2516p ps=2.16u w=0.74u l=0.13u
X2710 a_1815_1395# a_1256_1044# a_1721_1395# VSS.t933 sg13_lv_nmos ad=0.1216p pd=1.02u as=0.2176p ps=1.96u w=0.64u l=0.13u
X2711 a_4871_1842# a_4633_1842# a_4763_1842# VSS.t2109 sg13_lv_nmos ad=0.1406p pd=1.12u as=0.2516p ps=2.16u w=0.74u l=0.2u
X2712 VSS.t608 a_4187_1764.t157 a_8671_16869# VSS.t826 sg13_lv_nmos ad=0.2516p pd=2.16u as=0.1406p ps=1.12u w=0.74u l=0.6u
X2713 VSS.t748 a_26043_16869# a_26477_16869# VSS.t853 sg13_lv_nmos ad=0.1406p pd=1.12u as=0.2516p ps=2.16u w=0.74u l=0.13u
X2714 VDD.t623 a_3171_15338.t2 a_23945_15546# VDD.t34 sg13_lv_pmos ad=0.3808p pd=2.92u as=0.3808p ps=2.92u w=1.12u l=0.13u
X2715 a_17275_16071# a_17065_16071# VSS.t1412 VSS.t2060 sg13_lv_nmos ad=0.1406p pd=1.12u as=0.1665p ps=1.19u w=0.74u l=0.13u
X2716 VSS.t49 a_2019_3892.t8 a_7364_3853# VSS.t1948 sg13_lv_nmos ad=0.2516p pd=2.16u as=0.2516p ps=2.16u w=0.74u l=0.13u
X2717 VDD.t685 a_2595_12493.t2 a_20905_12701# VDD.t2 sg13_lv_pmos ad=0.3808p pd=2.92u as=0.3808p ps=2.92u w=1.12u l=0.13u
X2718 a_14235_13226# a_14025_13226# VSS.t1989 VSS.t2071 sg13_lv_nmos ad=0.1406p pd=1.12u as=0.1665p ps=1.19u w=0.74u l=0.13u
X2719 a_2391_3176# CHAN2_MUX_SEL2 a_2297_3176# VSS.t2091 sg13_lv_nmos ad=0.1216p pd=1.02u as=0.2176p ps=1.96u w=0.64u l=0.13u
X2720 a_7390_16071# a_9751_16035# a_9675_16071# VDD.t34 sg13_lv_pmos ad=0.3808p pd=2.92u as=0.2128p ps=1.5u w=1.12u l=0.13u
X2721 VDD.t1051 a_4187_2434# a_6391_8160# VDD.t345 sg13_lv_pmos ad=0.3808p pd=2.92u as=0.2128p ps=1.5u w=1.12u l=0.6u
X2722 VDD.t690 a_2595_16074.t4 a_20391_16035# VDD.t34 sg13_lv_pmos ad=0.3808p pd=2.92u as=0.3808p ps=2.92u w=1.12u l=0.13u
X2723 a_13470_3889# a_13444_3853# a_13368_3889# VDD.t0 sg13_lv_pmos ad=0.3808p pd=2.92u as=0.2128p ps=1.5u w=1.12u l=0.13u
X2724 VSS.t757 a_7803_14024# a_8237_14024# VSS.t1272 sg13_lv_nmos ad=0.1406p pd=1.12u as=0.2516p ps=2.16u w=0.74u l=0.13u
X2725 a_2019_13229.t1 a_1721_13577# VSS.t701 VSS.t1937 sg13_lv_nmos ad=0.1406p pd=1.12u as=0.1331p ps=1.12u w=0.74u l=0.13u
X2726 VSS.t2094 a_1544_3134# a_1815_3176# VSS.t767 sg13_lv_nmos ad=0.1331p pd=1.12u as=0.1216p ps=1.02u w=0.64u l=0.13u
X2727 VDD.t970 a_4187_2434# a_9431_5315# VDD.t347 sg13_lv_pmos ad=0.3808p pd=2.92u as=0.2128p ps=1.5u w=1.12u l=0.6u
X2728 a_20831_14024# a_20593_14024# a_20723_14024# VSS.t1854 sg13_lv_nmos ad=0.1406p pd=1.12u as=0.2516p ps=2.16u w=0.74u l=0.2u
X2729 a_25528_13226# a_24957_14024# VSS.t2268 VSS.t2347 sg13_lv_nmos ad=0.1406p pd=1.12u as=0.2516p ps=2.16u w=0.74u l=0.13u
X2730 VSS.t339 VDD.t1656 VSS.t342 VSS.t341 sg13_lv_nmos ad=79.8f pd=0.8u as=0 ps=0 w=0.42u l=1u
X2731 a_15511_17497# a_15273_16869# a_15403_16869# VDD.t368 sg13_lv_pmos ad=0.2128p pd=1.5u as=0.3808p ps=2.92u w=1.12u l=0.2u
X2732 a_10040_11995# a_9772_11533# a_9946_11995# VSS.t2179 sg13_lv_nmos ad=60.89999f pd=0.71u as=0.1428p ps=1.52u w=0.42u l=0.13u
X2733 a_1721_331# a_1256_289# VDD.t1577 VDD.t67 sg13_lv_pmos ad=0.1596p pd=1.22u as=0.2856p ps=2.36u w=0.84u l=0.13u
X2734 a_7673_1842# a_7477_1842# VDD.t1355 VDD.t379 sg13_lv_pmos ad=0.3808p pd=2.92u as=0.2128p ps=1.5u w=1.12u l=0.13u
X2735 a_12849_11557# a_12656_11554# VSS.t31 VSS.t1123 sg13_lv_nmos ad=0.1406p pd=1.12u as=0.2516p ps=2.16u w=0.74u l=0.13u
X2736 a_15053_11110# a_14111_10917# a_14851_10872# VDD.t358 sg13_lv_pmos ad=93.45f pd=0.865u as=0.2048p ps=1.63u w=0.42u l=0.13u
X2737 VSS.t1806 a_1544_16071# a_2391_16422# VSS.t1893 sg13_lv_nmos ad=0.1331p pd=1.12u as=0.1216p ps=1.02u w=0.64u l=0.13u
X2738 CHAN0_MUX_OUT a_16851_15336# VSS.t2113 VSS.t2112 sg13_lv_nmos ad=0.1406p pd=1.12u as=0.1371p ps=1.12u w=0.74u l=0.13u
X2739 a_16033_4687# a_15837_4687# VSS.t163 VSS.t162 sg13_lv_nmos ad=0.2516p pd=2.16u as=0.1406p ps=1.12u w=0.74u l=0.13u
X2740 VSS.t1226 a_4187_1764.t108 a_21591_14024# VSS.t2167 sg13_lv_nmos ad=0.2516p pd=2.16u as=0.1406p ps=1.12u w=0.74u l=0.6u
X2741 VDD.t453 a_6326_10280# a_6854_11144# VDD.t358 sg13_lv_pmos ad=0.38p pd=2.38u as=0.38p ps=2.38u w=2u l=1u
X2742 VDD.t155 VSS.t150 VDD.t307 VDD.t67 sg13_lv_pmos ad=0.34p pd=2.68u as=0 ps=0 w=1u l=1u
X2743 a_7151_4687# a_6913_4687# a_7043_4687# VSS.t2269 sg13_lv_nmos ad=0.1406p pd=1.12u as=0.2516p ps=2.16u w=0.74u l=0.2u
X2744 VDD.t1086 a_4187_2434# a_23111_5315# VDD.t347 sg13_lv_pmos ad=0.3808p pd=2.92u as=0.2128p ps=1.5u w=1.12u l=0.6u
X2745 VDD.t1000 a_4187_2434# a_16271_17497# VDD.t368 sg13_lv_pmos ad=0.3808p pd=2.92u as=0.2128p ps=1.5u w=1.12u l=0.6u
X2746 a_6635_1044# a_6425_1044# VSS.t178 VSS.t177 sg13_lv_nmos ad=0.1406p pd=1.12u as=0.1665p ps=1.19u w=0.74u l=0.13u
X2747 VDD.t1218 a_3171_3892.t3 a_24084_3853# VDD.t0 sg13_lv_pmos ad=0.3808p pd=2.92u as=0.3808p ps=2.92u w=1.12u l=0.13u
X2748 VDD.t757 a_2595_15338.t3 a_8745_15546# VDD.t34 sg13_lv_pmos ad=0.3808p pd=2.92u as=0.3808p ps=2.92u w=1.12u l=0.13u
X2749 VDD.t1061 a_4187_2434# a_20831_8160# VDD.t345 sg13_lv_pmos ad=0.3808p pd=2.92u as=0.2128p ps=1.5u w=1.12u l=0.6u
X2750 VSS.t1083 a_24523_1842# a_24957_1842# VSS.t1293 sg13_lv_nmos ad=0.1406p pd=1.12u as=0.2516p ps=2.16u w=0.74u l=0.13u
X2751 VDD.t309 VSS.t282 VDD.t308 VDD.t2 sg13_lv_pmos ad=0.19p pd=1.38u as=0 ps=0 w=1u l=1u
X2752 a_14513_14024# a_14317_14024# VDD.t850 VDD.t378 sg13_lv_pmos ad=0.3808p pd=2.92u as=0.2128p ps=1.5u w=1.12u l=0.13u
X2753 VDD.t692 a_2019_12493.t3 a_5705_12701# VDD.t2 sg13_lv_pmos ad=0.3808p pd=2.92u as=0.3808p ps=2.92u w=1.12u l=0.13u
X2754 VSS.t678 a_2595_1047.t9 a_5191_1008# VSS.t677 sg13_lv_nmos ad=0.2516p pd=2.16u as=0.2516p ps=2.16u w=0.74u l=0.13u
X2755 a_16108_3134# a_3747_3156.t2 a_25630_3889# VSS.t1148 sg13_lv_nmos ad=0.2516p pd=2.16u as=0.2516p ps=2.16u w=0.74u l=0.13u
X2756 VDD.t15 VSS.t317 VDD.t14 VDD.t9 sg13_lv_pmos ad=0.34p pd=2.68u as=0 ps=0 w=1u l=1u
X2757 a_27915_16071# a_27705_16071# VDD.t846 VDD.t34 sg13_lv_pmos ad=0.2128p pd=1.5u as=0.252p ps=1.57u w=1.12u l=0.13u
X2758 a_10589_11604# a_10232_11561# VDD.t696 VDD.t358 sg13_lv_pmos ad=63f pd=0.72u as=0.1563p ps=1.22u w=0.42u l=0.13u
X2759 a_20315_1044# a_20105_1044# VSS.t735 VSS.t1506 sg13_lv_nmos ad=0.1406p pd=1.12u as=0.1665p ps=1.19u w=0.74u l=0.13u
X2760 a_22488_3889# a_21917_4687# VSS.t58 VSS.t1090 sg13_lv_nmos ad=0.1406p pd=1.12u as=0.2516p ps=2.16u w=0.74u l=0.13u
X2761 a_27048_13226# a_26477_14024# VDD.t937 VDD.t2 sg13_lv_pmos ad=0.2128p pd=1.5u as=0.3808p ps=2.92u w=1.12u l=0.13u
X2762 a_25528_1044# a_24957_1842# VSS.t694 VSS.t2010 sg13_lv_nmos ad=0.1406p pd=1.12u as=0.2516p ps=2.16u w=0.74u l=0.13u
X2763 a_18795_1044# a_18585_1044# VDD.t802 VDD.t67 sg13_lv_pmos ad=0.2128p pd=1.5u as=0.252p ps=1.57u w=1.12u l=0.13u
X2764 VDD.t463 VDD.t461 VDD.t462 VDD.t360 sg13_lv_pmos ad=0.3808p pd=2.92u as=0 ps=0 w=1.12u l=0.13u
X2765 VSS.t45 a_27237_7532# a_27705_6734# VSS.t1294 sg13_lv_nmos ad=0.1665p pd=1.19u as=0.2516p ps=2.16u w=0.74u l=0.13u
X2766 VDD.t437 VDD.t435 VDD.t434 VDD.t368 sg13_lv_pmos ad=0.2128p pd=1.5u as=0 ps=0 w=1.12u l=0.2u
X2767 a_23355_16071# a_23145_16071# VDD.t584 VDD.t34 sg13_lv_pmos ad=0.2128p pd=1.5u as=0.252p ps=1.57u w=1.12u l=0.13u
X2768 VSS.t1669 a_4187_1764.t98 VSS.t1671 VSS.t1670 sg13_lv_nmos ad=1.33p pd=7.38u as=0 ps=0 w=7u l=7u
X2769 a_2595_6737.t1 a_2297_7085# VSS.t1095 VSS.t1094 sg13_lv_nmos ad=0.1406p pd=1.12u as=0.1331p ps=1.12u w=0.74u l=0.13u
X2770 VDD.t1100 a_4187_2434# a_11711_2470# VDD.t379 sg13_lv_pmos ad=0.3808p pd=2.92u as=0.2128p ps=1.5u w=1.12u l=0.6u
X2771 a_16108_5979# a_20905_6209# a_19550_6734# VDD.t9 sg13_lv_pmos ad=0.3808p pd=2.92u as=0.3808p ps=2.92u w=1.12u l=0.13u
X2772 VSS.t310 VDD.t1668 VSS.t310 VSS.t309 sg13_lv_nmos ad=0.1428p pd=1.52u as=0 ps=0 w=0.42u l=1u
X2773 a_10191_8160# a_9953_7532# a_10083_7532# VDD.t345 sg13_lv_pmos ad=0.2128p pd=1.5u as=0.3808p ps=2.92u w=1.12u l=0.2u
X2774 VDD.t581 a_2595_1047.t5 a_17351_1008# VDD.t67 sg13_lv_pmos ad=0.3808p pd=2.92u as=0.3808p ps=2.92u w=1.12u l=0.13u
X2775 a_25630_1044# a_27124_1008# a_27048_1044# VDD.t67 sg13_lv_pmos ad=0.3808p pd=2.92u as=0.2128p ps=1.5u w=1.12u l=0.13u
X2776 VDD.t769 a_2019_6737.t8 a_7364_6698# VDD.t9 sg13_lv_pmos ad=0.3808p pd=2.92u as=0.3808p ps=2.92u w=1.12u l=0.13u
X2777 a_5731_289# a_3747_311.t3 a_13470_1044# VSS.t729 sg13_lv_nmos ad=0.2516p pd=2.16u as=0.2516p ps=2.16u w=0.74u l=0.13u
X2778 a_5393_14024# a_5197_14024# VSS.t1162 VSS.t2139 sg13_lv_nmos ad=0.2516p pd=2.16u as=0.1406p ps=1.12u w=0.74u l=0.13u
X2779 VSS.t128 a_4187_1764.t2 a_27671_1842# VSS.t127 sg13_lv_nmos ad=0.2516p pd=2.16u as=0.1406p ps=1.12u w=0.74u l=0.6u
X2780 VDD.t1244 a_18443_16869# a_18877_16869# VDD.t368 sg13_lv_pmos ad=0.2128p pd=1.5u as=0.3808p ps=2.92u w=1.12u l=0.13u
X2781 VDD.t610 CHAN1_MUX_SEL3 a_3449_12513# VDD.t2 sg13_lv_pmos ad=0.1918p pd=1.5u as=0.1596p ps=1.22u w=0.84u l=0.13u
X2782 a_26151_7532# a_25913_7532# a_26043_7532# VSS.t2162 sg13_lv_nmos ad=0.1406p pd=1.12u as=0.2516p ps=2.16u w=0.74u l=0.2u
X2783 VSS.t357 VDD.t1648 VSS.t357 VSS.t362 sg13_lv_nmos ad=79.8f pd=0.8u as=0 ps=0 w=0.42u l=1u
X2784 a_22590_13226# a_2019_13229.t3 a_22488_13226# VSS.t1760 sg13_lv_nmos ad=0.2516p pd=2.16u as=0.1406p ps=1.12u w=0.74u l=0.13u
X2785 VDD.t528 a_21483_1842# a_21917_1842# VDD.t379 sg13_lv_pmos ad=0.2128p pd=1.5u as=0.3808p ps=2.92u w=1.12u l=0.13u
X2786 a_16408_13226# a_15837_14024# VSS.t1169 VSS.t1168 sg13_lv_nmos ad=0.1406p pd=1.12u as=0.2516p ps=2.16u w=0.74u l=0.13u
X2787 a_19550_16071# a_3171_16074.t4 a_20968_16071# VSS.t2193 sg13_lv_nmos ad=0.2516p pd=2.16u as=0.1406p ps=1.12u w=0.74u l=0.13u
X2788 a_4350_1044# a_5844_1008# a_5768_1044# VDD.t67 sg13_lv_pmos ad=0.3808p pd=2.92u as=0.2128p ps=1.5u w=1.12u l=0.13u
X2789 a_16108_12471# a_3747_12493.t2 a_25630_13226# VSS.t1875 sg13_lv_nmos ad=0.2516p pd=2.16u as=0.2516p ps=2.16u w=0.74u l=0.13u
X2790 a_13753_7532# a_13557_7532# VSS.t99 VSS.t98 sg13_lv_nmos ad=0.2516p pd=2.16u as=0.1406p ps=1.12u w=0.74u l=0.13u
X2791 VSS.t364 VDD.t1647 VSS.t364 VSS.t365 sg13_lv_nmos ad=79.8f pd=0.8u as=0 ps=0 w=0.42u l=1u
X2792 VSS.t27 a_3449_3176# a_3747_3156.t1 VSS.t2088 sg13_lv_nmos ad=0.2812p pd=2.24u as=0.1406p ps=1.12u w=0.74u l=0.13u
X2793 VSS.t1195 a_5523_4687# a_5957_4687# VSS.t1872 sg13_lv_nmos ad=0.1406p pd=1.12u as=0.2516p ps=2.16u w=0.74u l=0.13u
X2794 a_4871_7532# a_4633_7532# a_4763_7532# VSS.t2313 sg13_lv_nmos ad=0.1406p pd=1.12u as=0.2516p ps=2.16u w=0.74u l=0.2u
X2795 a_1815_7085# a_1256_6734# a_1721_7085# VSS.t12 sg13_lv_nmos ad=0.1216p pd=1.02u as=0.2176p ps=1.96u w=0.64u l=0.13u
X2796 VDD.t1313 a_18117_4687# a_18585_3889# VDD.t0 sg13_lv_pmos ad=0.252p pd=1.57u as=0.3808p ps=2.92u w=1.12u l=0.13u
X2797 VSS.t260 VDD.t1682 VSS.t259 VSS.t258 sg13_lv_nmos ad=0.1428p pd=1.52u as=0 ps=0 w=0.42u l=1u
X2798 VDD.t284 VSS.t342 VDD.t182 VDD.t9 sg13_lv_pmos ad=0.19p pd=1.38u as=0 ps=0 w=1u l=1u
X2799 a_22590_13226# a_24084_13190# a_24008_13226# VDD.t2 sg13_lv_pmos ad=0.3808p pd=2.92u as=0.2128p ps=1.5u w=1.12u l=0.13u
X2800 VSS.t207 VDD.t1697 VSS.t207 VSS.t209 sg13_lv_nmos ad=0.1428p pd=1.52u as=0 ps=0 w=0.42u l=1u
X2801 a_16510_13226# a_2595_13229.t5 a_17275_13226# VSS.t1489 sg13_lv_nmos ad=0.2516p pd=2.16u as=0.1406p ps=1.12u w=0.74u l=0.13u
X2802 a_6326_10280# a_6126_9506# a_5778_9057# VSS.t803 sg13_lv_nmos ad=0.38p pd=2.38u as=0.68p ps=4.68u w=2u l=1u
X2803 VSS.t766 a_16851_309# CHAN3_MUX_OUT VSS.t1820 sg13_lv_nmos ad=0.2516p pd=2.16u as=0.1406p ps=1.12u w=0.74u l=0.13u
X2804 a_2873_6021# REF_MUX_SEL3 VDD.t362 VDD.t9 sg13_lv_pmos ad=0.1596p pd=1.22u as=0.2856p ps=2.36u w=0.84u l=0.13u
X2805 a_22488_6734# a_21917_7532# VDD.t646 VDD.t9 sg13_lv_pmos ad=0.2128p pd=1.5u as=0.3808p ps=2.92u w=1.12u l=0.13u
X2806 VDD.t629 a_1544_289# a_1721_331# VDD.t67 sg13_lv_pmos ad=0.1918p pd=1.5u as=0.1596p ps=1.22u w=0.84u l=0.13u
X2807 VSS.t147 a_2019_311# a_5705_519# VSS.t146 sg13_lv_nmos ad=0.2516p pd=2.16u as=0.2516p ps=2.16u w=0.74u l=0.13u
X2808 a_4350_16071# a_3171_16074.t9 a_5768_16071# VSS.t83 sg13_lv_nmos ad=0.2516p pd=2.16u as=0.1406p ps=1.12u w=0.74u l=0.13u
X2809 a_15511_14652# a_15273_14024# a_15403_14024# VDD.t378 sg13_lv_pmos ad=0.2128p pd=1.5u as=0.3808p ps=2.92u w=1.12u l=0.2u
X2810 a_7673_7532# a_7477_7532# VDD.t893 VDD.t345 sg13_lv_pmos ad=0.3808p pd=2.92u as=0.2128p ps=1.5u w=1.12u l=0.13u
X2811 VSS.t156 a_4187_1764.t59 a_8671_4687# VSS.t909 sg13_lv_nmos ad=0.2516p pd=2.16u as=0.1406p ps=1.12u w=0.74u l=0.6u
X2812 a_16033_1842# a_15837_1842# VSS.t849 VSS.t1479 sg13_lv_nmos ad=0.2516p pd=2.16u as=0.1406p ps=1.12u w=0.74u l=0.13u
X2813 VDD.t403 a_11603_4687# a_12037_4687# VDD.t347 sg13_lv_pmos ad=0.2128p pd=1.5u as=0.3808p ps=2.92u w=1.12u l=0.13u
X2814 VSS.t519 a_24523_7532# a_24957_7532# VSS.t2304 sg13_lv_nmos ad=0.1406p pd=1.12u as=0.2516p ps=2.16u w=0.74u l=0.13u
X2815 a_6635_6734# a_6425_6734# VSS.t554 VSS.t553 sg13_lv_nmos ad=0.1406p pd=1.12u as=0.1665p ps=1.19u w=0.74u l=0.13u
X2816 a_7151_1842# a_6913_1842# a_7043_1842# VSS.t2132 sg13_lv_nmos ad=0.1406p pd=1.12u as=0.2516p ps=2.16u w=0.74u l=0.2u
X2817 VDD.t1001 a_4187_2434# a_16271_14652# VDD.t378 sg13_lv_pmos ad=0.3808p pd=2.92u as=0.2128p ps=1.5u w=1.12u l=0.6u
X2818 a_9746_11495# a_9547_11632# VSS.t542 VSS.t598 sg13_lv_nmos ad=0.27427p pd=2.28u as=2.39977p ps=15.495u w=0.795u l=0.13u
X2819 a_24631_16869# a_24393_16869# a_24523_16869# VSS.t2218 sg13_lv_nmos ad=0.1406p pd=1.12u as=0.2516p ps=2.16u w=0.74u l=0.2u
X2820 VSS.t982 a_2595_6737.t9 a_5191_6698# VSS.t1054 sg13_lv_nmos ad=0.2516p pd=2.16u as=0.2516p ps=2.16u w=0.74u l=0.13u
X2821 VDD.t253 VSS.t364 VDD.t252 VDD.t0 sg13_lv_pmos ad=0.34p pd=2.68u as=0 ps=0 w=1u l=1u
X2822 a_13470_3889# a_2019_3892.t6 a_13368_3889# VSS.t2026 sg13_lv_nmos ad=0.2516p pd=2.16u as=0.1406p ps=1.12u w=0.74u l=0.13u
X2823 a_24393_4687# a_24197_4687# VDD.t737 VDD.t347 sg13_lv_pmos ad=0.3808p pd=2.92u as=0.2128p ps=1.5u w=1.12u l=0.13u
X2824 a_11473_16869# a_11277_16869# VDD.t1148 VDD.t368 sg13_lv_pmos ad=0.3808p pd=2.92u as=0.2128p ps=1.5u w=1.12u l=0.13u
X2825 VSS.t866 a_10083_14024# a_10517_14024# VSS.t1981 sg13_lv_nmos ad=0.1406p pd=1.12u as=0.2516p ps=2.16u w=0.74u l=0.13u
X2826 a_20315_6734# a_20105_6734# VSS.t548 VSS.t547 sg13_lv_nmos ad=0.1406p pd=1.12u as=0.1665p ps=1.19u w=0.74u l=0.13u
X2827 a_20071_16869# a_19833_16869# a_19963_16869# VSS.t2354 sg13_lv_nmos ad=0.1406p pd=1.12u as=0.2516p ps=2.16u w=0.74u l=0.2u
X2828 VSS.t1529 a_4187_1764.t135 a_25391_16869# VSS.t1528 sg13_lv_nmos ad=0.2516p pd=2.16u as=0.1406p ps=1.12u w=0.74u l=0.6u
X2829 a_7390_13226# a_8884_13190# a_8808_13226# VDD.t2 sg13_lv_pmos ad=0.3808p pd=2.92u as=0.2128p ps=1.5u w=1.12u l=0.13u
X2830 a_25528_6734# a_24957_7532# VSS.t1076 VSS.t1438 sg13_lv_nmos ad=0.1406p pd=1.12u as=0.2516p ps=2.16u w=0.74u l=0.13u
X2831 CHAN3_MUX_OUT a_16851_309# VDD.t630 VDD.t67 sg13_lv_pmos ad=0.2128p pd=1.5u as=0.2086p ps=1.5u w=1.12u l=0.13u
X2832 VSS.t1150 a_3747_3156.t2 a_26985_3364# VSS.t1149 sg13_lv_nmos ad=0.2516p pd=2.16u as=0.2516p ps=2.16u w=0.74u l=0.13u
X2833 VDD.t23 VSS.t310 VDD.t22 VDD.t9 sg13_lv_pmos ad=0.34p pd=2.68u as=0 ps=0 w=1u l=1u
X2834 a_6126_9506# a_6326_10280# VDD.t663 VDD.t358 sg13_lv_pmos ad=0.38p pd=2.38u as=0.38p ps=2.38u w=2u l=1u
X2835 VSS.t1279 a_1256_16071# a_2967_16422# VSS.t1278 sg13_lv_nmos ad=0.1331p pd=1.12u as=0.1216p ps=1.02u w=0.64u l=0.13u
X2836 a_6391_14024# a_6153_14024# a_6283_14024# VSS.t1965 sg13_lv_nmos ad=0.1406p pd=1.12u as=0.2516p ps=2.16u w=0.74u l=0.2u
X2837 VSS.t898 a_2595_16074.t7 a_11271_16035# VSS.t897 sg13_lv_nmos ad=0.2516p pd=2.16u as=0.2516p ps=2.16u w=0.74u l=0.13u
X2838 a_25391_2470# a_25153_1842# a_25283_1842# VDD.t379 sg13_lv_pmos ad=0.2128p pd=1.5u as=0.3808p ps=2.92u w=1.12u l=0.2u
X2839 VDD.t1217 a_3171_3892.t6 a_14964_3853# VDD.t0 sg13_lv_pmos ad=0.3808p pd=2.92u as=0.3808p ps=2.92u w=1.12u l=0.13u
X2840 a_5731_5979# a_2019_6001.t3 a_4350_6734# VSS.t1302 sg13_lv_nmos ad=0.2516p pd=2.16u as=0.2516p ps=2.16u w=0.74u l=0.13u
X2841 VDD.t445 VDD.t447 VDD.t448 VDD.t378 sg13_lv_pmos ad=0.2128p pd=1.5u as=0 ps=0 w=1.12u l=0.2u
X2842 VSS.t268 VDD.t1680 VSS.t267 VSS.t266 sg13_lv_nmos ad=0.1428p pd=1.52u as=0 ps=0 w=0.42u l=1u
X2843 VDD.t969 a_4187_2434# a_11711_8160# VDD.t345 sg13_lv_pmos ad=0.3808p pd=2.92u as=0.2128p ps=1.5u w=1.12u l=0.6u
X2844 VDD.t188 VSS.t408 VDD.t265 VDD.t67 sg13_lv_pmos ad=0.34p pd=2.68u as=0 ps=0 w=1u l=1u
X2845 a_16108_3134# a_20905_3364# a_19550_3889# VDD.t0 sg13_lv_pmos ad=0.3808p pd=2.92u as=0.3808p ps=2.92u w=1.12u l=0.13u
X2846 a_2595_3892.t1 a_2297_4240# VSS.t1166 VSS.t545 sg13_lv_nmos ad=0.1406p pd=1.12u as=0.1331p ps=1.12u w=0.74u l=0.13u
X2847 VSS.t226 VDD.t1690 VSS.t226 VSS.t229 sg13_lv_nmos ad=79.8f pd=0.8u as=0 ps=0 w=0.42u l=1u
X2848 a_4350_13226# a_4324_13190# a_4248_13226# VDD.t2 sg13_lv_pmos ad=0.3808p pd=2.92u as=0.2128p ps=1.5u w=1.12u l=0.13u
X2849 VSS.t1203 a_3171_3892.t3 a_24084_3853# VSS.t1661 sg13_lv_nmos ad=0.2516p pd=2.16u as=0.2516p ps=2.16u w=0.74u l=0.13u
X2850 a_25630_16071# a_26471_16035# a_26395_16071# VDD.t34 sg13_lv_pmos ad=0.3808p pd=2.92u as=0.2128p ps=1.5u w=1.12u l=0.13u
X2851 VSS.t115 a_4187_1764.t127 a_7151_14024# VSS.t114 sg13_lv_nmos ad=0.2516p pd=2.16u as=0.1406p ps=1.12u w=0.74u l=0.6u
X2852 CHAN1_MUX_OUT a_16851_12491# VDD.t651 VDD.t2 sg13_lv_pmos ad=0.2128p pd=1.5u as=0.2086p ps=1.5u w=1.12u l=0.13u
X2853 VSS.t1691 a_4187_1764.t98 VSS.t1689 VSS.t1674 sg13_lv_nmos ad=1.33p pd=7.38u as=0 ps=0 w=7u l=7u
X2854 VDD.t1067 a_4187_2434# a_14751_5315# VDD.t347 sg13_lv_pmos ad=0.3808p pd=2.92u as=0.2128p ps=1.5u w=1.12u l=0.6u
X2855 VSS.t117 a_24523_14024# a_24957_14024# VSS.t851 sg13_lv_nmos ad=0.1406p pd=1.12u as=0.2516p ps=2.16u w=0.74u l=0.13u
X2856 VSS.t350 a_2019_3156.t3 a_5705_3364# VSS.t2328 sg13_lv_nmos ad=0.2516p pd=2.16u as=0.2516p ps=2.16u w=0.74u l=0.13u
X2857 VSS.t1736 a_4187_1764.t66 a_27671_7532# VSS.t1735 sg13_lv_nmos ad=0.2516p pd=2.16u as=0.1406p ps=1.12u w=0.74u l=0.6u
X2858 a_12993_1842# a_12797_1842# VDD.t819 VDD.t379 sg13_lv_pmos ad=0.3808p pd=2.92u as=0.2128p ps=1.5u w=1.12u l=0.13u
X2859 VDD.t644 a_18443_14024# a_18877_14024# VDD.t378 sg13_lv_pmos ad=0.2128p pd=1.5u as=0.3808p ps=2.92u w=1.12u l=0.13u
X2860 a_16408_1044# a_15837_1842# VSS.t670 VSS.t1480 sg13_lv_nmos ad=0.1406p pd=1.12u as=0.2516p ps=2.16u w=0.74u l=0.13u
X2861 VDD.t551 a_21483_7532# a_21917_7532# VDD.t345 sg13_lv_pmos ad=0.2128p pd=1.5u as=0.3808p ps=2.92u w=1.12u l=0.13u
X2862 VDD.t1145 a_7477_16869# a_7945_16071# VDD.t34 sg13_lv_pmos ad=0.252p pd=1.57u as=0.3808p ps=2.92u w=1.12u l=0.13u
X2863 VSS.t350 VDD.t1652 VSS.t350 VSS.t353 sg13_lv_nmos ad=79.8f pd=0.8u as=0 ps=0 w=0.42u l=1u
X2864 a_12471_4687# a_12233_4687# a_12363_4687# VSS.t1628 sg13_lv_nmos ad=0.1406p pd=1.12u as=0.2516p ps=2.16u w=0.74u l=0.2u
X2865 a_5768_16071# a_5197_16869# VDD.t1206 VDD.t34 sg13_lv_pmos ad=0.2128p pd=1.5u as=0.3808p ps=2.92u w=1.12u l=0.13u
X2866 VDD.t1398 a_2595_13229.t6 a_14311_13190# VDD.t2 sg13_lv_pmos ad=0.3808p pd=2.92u as=0.3808p ps=2.92u w=1.12u l=0.13u
X2867 a_11195_3889# a_10985_3889# VDD.t701 VDD.t0 sg13_lv_pmos ad=0.2128p pd=1.5u as=0.252p ps=1.57u w=1.12u l=0.13u
X2868 a_5731_5979# a_11785_6209# a_10430_6734# VDD.t9 sg13_lv_pmos ad=0.3808p pd=2.92u as=0.3808p ps=2.92u w=1.12u l=0.13u
X2869 a_4871_16869# a_4633_16869# a_4763_16869# VSS.t1324 sg13_lv_nmos ad=0.1406p pd=1.12u as=0.2516p ps=2.16u w=0.74u l=0.2u
X2870 VDD.t1007 a_4187_2434# a_4111_5315# VDD.t347 sg13_lv_pmos ad=0.3808p pd=2.92u as=0.2128p ps=1.5u w=1.12u l=0.6u
X2871 a_9193_16869# a_8997_16869# VSS.t608 VSS.t607 sg13_lv_nmos ad=0.2516p pd=2.16u as=0.1406p ps=1.12u w=0.74u l=0.13u
X2872 a_18795_16071# a_18585_16071# VSS.t1157 VSS.t2074 sg13_lv_nmos ad=0.1406p pd=1.12u as=0.1665p ps=1.19u w=0.74u l=0.13u
X2873 VSS.t1268 a_5523_1842# a_5957_1842# VSS.t1267 sg13_lv_nmos ad=0.1406p pd=1.12u as=0.2516p ps=2.16u w=0.74u l=0.13u
X2874 a_13566_11525# a_14009_11568# a_13949_11604# VDD.t358 sg13_lv_pmos ad=79.8f pd=0.8u as=63f ps=0.72u w=0.42u l=0.13u
X2875 a_15755_13226# a_15545_13226# VSS.t968 VSS.t2070 sg13_lv_nmos ad=0.1406p pd=1.12u as=0.1665p ps=1.19u w=0.74u l=0.13u
X2876 a_1815_4240# a_1256_3889# a_1721_4240# VSS.t65 sg13_lv_nmos ad=0.1216p pd=1.02u as=0.2176p ps=1.96u w=0.64u l=0.13u
X2877 a_5731_289# a_2019_311# a_4350_1044# VSS.t145 sg13_lv_nmos ad=0.2516p pd=2.16u as=0.2516p ps=2.16u w=0.74u l=0.13u
X2878 VDD.t1103 a_4187_2434# a_13991_2470# VDD.t379 sg13_lv_pmos ad=0.3808p pd=2.92u as=0.2128p ps=1.5u w=1.12u l=0.6u
X2879 VSS.t885 a_4187_1764.t161 a_5631_16869# VSS.t884 sg13_lv_nmos ad=0.2516p pd=2.16u as=0.1406p ps=1.12u w=0.74u l=0.6u
X2880 VDD.t758 a_2595_15338.t2 a_20905_15546# VDD.t34 sg13_lv_pmos ad=0.3808p pd=2.92u as=0.3808p ps=2.92u w=1.12u l=0.13u
X2881 VSS.t39 a_14851_10872# a_15688_11093# VSS.t559 sg13_lv_nmos ad=0.1406p pd=1.12u as=0.2516p ps=2.16u w=0.74u l=0.13u
X2882 VSS.t119 a_23003_16869# a_23437_16869# VSS.t1033 sg13_lv_nmos ad=0.1406p pd=1.12u as=0.2516p ps=2.16u w=0.74u l=0.13u
X2883 a_14235_16071# a_14025_16071# VSS.t1409 VSS.t2086 sg13_lv_nmos ad=0.1406p pd=1.12u as=0.1665p ps=1.19u w=0.74u l=0.13u
X2884 VSS.t762 a_9323_14024# a_9757_14024# VSS.t1971 sg13_lv_nmos ad=0.1406p pd=1.12u as=0.2516p ps=2.16u w=0.74u l=0.13u
X2885 VDD.t186 VSS.t388 VDD.t185 VDD.t0 sg13_lv_pmos ad=0.19p pd=1.38u as=0 ps=0 w=1u l=1u
X2886 a_2391_6021# REF_MUX_SEL2 a_2297_6021# VSS.t183 sg13_lv_nmos ad=0.1216p pd=1.02u as=0.2176p ps=1.96u w=0.64u l=0.13u
X2887 VSS.t299 VDD.t1673 VSS.t297 VSS.t298 sg13_lv_nmos ad=79.8f pd=0.8u as=0 ps=0 w=0.42u l=1u
X2888 VDD.t795 a_3449_7085# a_3747_6737.t0 VDD.t9 sg13_lv_pmos ad=0.4256p pd=3u as=0.2128p ps=1.5u w=1.12u l=0.13u
X2889 a_13470_6734# a_13444_6698# a_13368_6734# VDD.t9 sg13_lv_pmos ad=0.3808p pd=2.92u as=0.2128p ps=1.5u w=1.12u l=0.13u
X2890 a_17031_17497# a_16793_16869# a_16923_16869# VDD.t368 sg13_lv_pmos ad=0.2128p pd=1.5u as=0.3808p ps=2.92u w=1.12u l=0.2u
X2891 a_2019_16074.t1 a_1721_16422# VSS.t1806 VSS.t1873 sg13_lv_nmos ad=0.1406p pd=1.12u as=0.1331p ps=1.12u w=0.74u l=0.13u
X2892 a_10458_11982# DLL_RESETN VSS.t623 VSS.t920 sg13_lv_nmos ad=37.8f pd=0.6u as=0.1701p ps=1.65u w=0.42u l=0.13u
X2893 a_7390_1044# a_3747_1047.t8 a_9675_1044# VSS.t1730 sg13_lv_nmos ad=0.2516p pd=2.16u as=0.1406p ps=1.12u w=0.74u l=0.13u
X2894 VSS.t563 a_1544_5979# a_1815_6021# VSS.t823 sg13_lv_nmos ad=0.1331p pd=1.12u as=0.1216p ps=1.02u w=0.64u l=0.13u
X2895 a_4350_16071# a_6711_16035# a_6635_16071# VDD.t34 sg13_lv_pmos ad=0.3808p pd=2.92u as=0.2128p ps=1.5u w=1.12u l=0.13u
X2896 VDD.t941 a_23763_1842# a_24197_1842# VDD.t379 sg13_lv_pmos ad=0.2128p pd=1.5u as=0.3808p ps=2.92u w=1.12u l=0.13u
X2897 a_25528_16071# a_24957_16869# VSS.t522 VSS.t1256 sg13_lv_nmos ad=0.1406p pd=1.12u as=0.2516p ps=2.16u w=0.74u l=0.13u
X2898 a_1256_15316# CHAN0_MUX_SEL2 VSS.t21 VSS.t1243 sg13_lv_nmos ad=0.2516p pd=2.16u as=0.2516p ps=2.16u w=0.74u l=0.13u
X2899 a_22113_14024# a_21917_14024# VSS.t1226 VSS.t1225 sg13_lv_nmos ad=0.2516p pd=2.16u as=0.1406p ps=1.12u w=0.74u l=0.13u
X2900 VSS.t1889 a_18117_4687# a_18585_3889# VSS.t2312 sg13_lv_nmos ad=0.1665p pd=1.19u as=0.2516p ps=2.16u w=0.74u l=0.13u
X2901 a_12471_17497# a_12233_16869# a_12363_16869# VDD.t368 sg13_lv_pmos ad=0.2128p pd=1.5u as=0.3808p ps=2.92u w=1.12u l=0.2u
X2902 VDD.t962 a_4187_2434# a_17791_17497# VDD.t368 sg13_lv_pmos ad=0.3808p pd=2.92u as=0.2128p ps=1.5u w=1.12u l=0.6u
X2903 a_16033_7532# a_15837_7532# VSS.t136 VSS.t2235 sg13_lv_nmos ad=0.2516p pd=2.16u as=0.1406p ps=1.12u w=0.74u l=0.13u
X2904 VDD.t1309 a_2019_1047.t8 a_7364_1008# VDD.t67 sg13_lv_pmos ad=0.3808p pd=2.92u as=0.3808p ps=2.92u w=1.12u l=0.13u
X2905 VSS.t742 a_4187_1764.t27 a_8671_1842# VSS.t741 sg13_lv_nmos ad=0.2516p pd=2.16u as=0.1406p ps=1.12u w=0.74u l=0.6u
X2906 a_17275_13226# a_17065_13226# VDD.t1412 VDD.t2 sg13_lv_pmos ad=0.2128p pd=1.5u as=0.252p ps=1.57u w=1.12u l=0.13u
X2907 a_7151_7532# a_6913_7532# a_7043_7532# VSS.t1882 sg13_lv_nmos ad=0.1406p pd=1.12u as=0.2516p ps=2.16u w=0.74u l=0.2u
X2908 VDD.t1326 a_3171_6737.t3 a_24084_6698# VDD.t9 sg13_lv_pmos ad=0.3808p pd=2.92u as=0.3808p ps=2.92u w=1.12u l=0.13u
X2909 a_3449_7085# REF_MUX_SEL0 VDD.t1187 VDD.t9 sg13_lv_pmos ad=0.1596p pd=1.22u as=0.2856p ps=2.36u w=0.84u l=0.13u
X2910 VDD.t1003 a_4187_2434# a_13231_17497# VDD.t368 sg13_lv_pmos ad=0.3808p pd=2.92u as=0.2128p ps=1.5u w=1.12u l=0.6u
X2911 a_9953_4687# a_9757_4687# VSS.t538 VSS.t537 sg13_lv_nmos ad=0.2516p pd=2.16u as=0.1406p ps=1.12u w=0.74u l=0.13u
X2912 VDD.t343 a_2019_15338.t3 a_5705_15546# VDD.t34 sg13_lv_pmos ad=0.3808p pd=2.92u as=0.3808p ps=2.92u w=1.12u l=0.13u
X2913 VSS.t101 a_10843_4687# a_11277_4687# VSS.t100 sg13_lv_nmos ad=0.1406p pd=1.12u as=0.2516p ps=2.16u w=0.74u l=0.13u
X2914 a_11473_14024# a_11277_14024# VDD.t882 VDD.t378 sg13_lv_pmos ad=0.3808p pd=2.92u as=0.2128p ps=1.5u w=1.12u l=0.13u
X2915 a_22590_3889# a_23431_3853# a_23355_3889# VDD.t0 sg13_lv_pmos ad=0.3808p pd=2.92u as=0.2128p ps=1.5u w=1.12u l=0.13u
X2916 a_17031_5315# a_16793_4687# a_16923_4687# VDD.t347 sg13_lv_pmos ad=0.2128p pd=1.5u as=0.3808p ps=2.92u w=1.12u l=0.2u
X2917 a_24875_16071# a_24665_16071# VDD.t1379 VDD.t34 sg13_lv_pmos ad=0.2128p pd=1.5u as=0.252p ps=1.57u w=1.12u l=0.13u
X2918 VDD.t220 VSS.t357 VDD.t219 VDD.t0 sg13_lv_pmos ad=0.34p pd=2.68u as=0 ps=0 w=1u l=1u
X2919 VDD.t429 VDD.t430 VDD.t431 VDD.t368 sg13_lv_pmos ad=0.2128p pd=1.5u as=0 ps=0 w=1.12u l=0.13u
X2920 a_4157_13495# CHAN1_DELAY_IN VSS.t715 VSS.t1796 sg13_lv_nmos ad=0.2516p pd=2.16u as=0.2553p ps=2.17u w=0.74u l=0.13u
X2921 VDD.t1117 a_4187_2434# a_26911_2470# VDD.t379 sg13_lv_pmos ad=0.3808p pd=2.92u as=0.2128p ps=1.5u w=1.12u l=0.6u
X2922 VDD.t52 VSS.t193 VDD.t50 VDD.t34 sg13_lv_pmos ad=0.19p pd=1.38u as=0 ps=0 w=1u l=1u
X2923 a_25391_8160# a_25153_7532# a_25283_7532# VDD.t345 sg13_lv_pmos ad=0.2128p pd=1.5u as=0.3808p ps=2.92u w=1.12u l=0.2u
X2924 a_16108_5979# a_15765_6153# a_15964_5979# VDD.t9 sg13_lv_pmos ad=0.3808p pd=2.92u as=0.3304p ps=1.71u w=1.12u l=0.13u
X2925 a_20593_16869# a_20397_16869# VSS.t568 VSS.t2353 sg13_lv_nmos ad=0.2516p pd=2.16u as=0.1406p ps=1.12u w=0.74u l=0.13u
X2926 VDD.t114 VSS.t462 VDD.t112 VDD.t67 sg13_lv_pmos ad=0.19p pd=1.38u as=0 ps=0 w=1u l=1u
X2927 VSS.t612 a_13883_16869# a_14317_16869# VSS.t611 sg13_lv_nmos ad=0.1406p pd=1.12u as=0.2516p ps=2.16u w=0.74u l=0.13u
X2928 a_6913_14024# a_6717_14024# VSS.t753 VSS.t1962 sg13_lv_nmos ad=0.2516p pd=2.16u as=0.1406p ps=1.12u w=0.74u l=0.13u
X2929 VSS.t393 VDD.t1636 VSS.t393 VSS.t394 sg13_lv_nmos ad=79.8f pd=0.8u as=0 ps=0 w=0.42u l=1u
X2930 a_12993_7532# a_12797_7532# VDD.t796 VDD.t345 sg13_lv_pmos ad=0.3808p pd=2.92u as=0.2128p ps=1.5u w=1.12u l=0.13u
X2931 a_22590_16071# a_2019_16074.t3 a_22488_16071# VSS.t1048 sg13_lv_nmos ad=0.2516p pd=2.16u as=0.1406p ps=1.12u w=0.74u l=0.13u
X2932 a_16408_6734# a_15837_7532# VSS.t1052 VSS.t2236 sg13_lv_nmos ad=0.1406p pd=1.12u as=0.2516p ps=2.16u w=0.74u l=0.13u
X2933 VSS.t2 a_2019_3156.t2 a_17865_3364# VSS.t1 sg13_lv_nmos ad=0.2516p pd=2.16u as=0.2516p ps=2.16u w=0.74u l=0.13u
X2934 VDD.t916 a_15403_16869# a_15837_16869# VDD.t368 sg13_lv_pmos ad=0.2128p pd=1.5u as=0.3808p ps=2.92u w=1.12u l=0.13u
X2935 a_22488_1044# a_21917_1842# VDD.t527 VDD.t67 sg13_lv_pmos ad=0.2128p pd=1.5u as=0.3808p ps=2.92u w=1.12u l=0.13u
X2936 a_16408_16071# a_15837_16869# VSS.t1047 VSS.t1330 sg13_lv_nmos ad=0.1406p pd=1.12u as=0.2516p ps=2.16u w=0.74u l=0.13u
X2937 VSS.t5 VDD.t1707 VSS.t5 VSS.t186 sg13_lv_nmos ad=0.1428p pd=1.52u as=0 ps=0 w=0.42u l=1u
X2938 a_12471_1842# a_12233_1842# a_12363_1842# VSS.t1934 sg13_lv_nmos ad=0.1406p pd=1.12u as=0.2516p ps=2.16u w=0.74u l=0.2u
X2939 a_3747_3892.t0 a_3449_4240# VDD.t1175 VDD.t0 sg13_lv_pmos ad=0.2128p pd=1.5u as=0.1918p ps=1.5u w=1.12u l=0.13u
X2940 a_5731_3134# a_11785_3364# a_10430_3889# VDD.t0 sg13_lv_pmos ad=0.3808p pd=2.92u as=0.3808p ps=2.92u w=1.12u l=0.13u
X2941 a_13368_13226# a_12797_14024# VSS.t698 VSS.t697 sg13_lv_nmos ad=0.1406p pd=1.12u as=0.2516p ps=2.16u w=0.74u l=0.13u
X2942 VSS.t1182 a_3171_3892.t6 a_14964_3853# VSS.t1659 sg13_lv_nmos ad=0.2516p pd=2.16u as=0.2516p ps=2.16u w=0.74u l=0.13u
X2943 VSS.t602 a_5523_7532# a_5957_7532# VSS.t601 sg13_lv_nmos ad=0.1406p pd=1.12u as=0.2516p ps=2.16u w=0.74u l=0.13u
X2944 VSS.t324 VDD.t1662 VSS.t324 VSS.t325 sg13_lv_nmos ad=79.8f pd=0.8u as=0 ps=0 w=0.42u l=1u
X2945 VSS.t37 a_3449_6021# a_3747_6001.t1 VSS.t1830 sg13_lv_nmos ad=0.2812p pd=2.24u as=0.1406p ps=1.12u w=0.74u l=0.13u
X2946 VSS.t632 a_3171_1047.t5 a_18004_1008# VSS.t631 sg13_lv_nmos ad=0.2516p pd=2.16u as=0.2516p ps=2.16u w=0.74u l=0.13u
X2947 VDD.t1339 a_2595_311.t3 a_8745_519# VDD.t67 sg13_lv_pmos ad=0.3808p pd=2.92u as=0.3808p ps=2.92u w=1.12u l=0.13u
X2948 VDD.t1328 a_3171_6001.t3 a_11785_6209# VDD.t9 sg13_lv_pmos ad=0.3808p pd=2.92u as=0.3808p ps=2.92u w=1.12u l=0.13u
X2949 a_16108_12471# a_3171_12493.t2 a_22590_13226# VSS.t2274 sg13_lv_nmos ad=0.2516p pd=2.16u as=0.2516p ps=2.16u w=0.74u l=0.13u
X2950 VDD.t605 a_18117_7532# a_18585_6734# VDD.t9 sg13_lv_pmos ad=0.252p pd=1.57u as=0.3808p ps=2.92u w=1.12u l=0.13u
X2951 a_20831_5315# a_20593_4687# a_20723_4687# VDD.t347 sg13_lv_pmos ad=0.2128p pd=1.5u as=0.3808p ps=2.92u w=1.12u l=0.2u
X2952 VSS.t1187 a_12849_11557# a_13400_10795# VSS.t1186 sg13_lv_nmos ad=0.1626p pd=1.415u as=60.89999f ps=0.71u w=0.42u l=0.13u
X2953 VDD.t1055 a_4187_2434# a_13991_8160# VDD.t345 sg13_lv_pmos ad=0.3808p pd=2.92u as=0.2128p ps=1.5u w=1.12u l=0.6u
X2954 a_5393_4687# a_5197_4687# VDD.t408 VDD.t347 sg13_lv_pmos ad=0.3808p pd=2.92u as=0.2128p ps=1.5u w=1.12u l=0.13u
X2955 VDD.t887 a_2873_16422# a_3171_16074.t0 VDD.t34 sg13_lv_pmos ad=0.4256p pd=3u as=0.2128p ps=1.5u w=1.12u l=0.13u
X2956 a_16510_13226# a_3747_13229.t5 a_18795_13226# VSS.t1703 sg13_lv_nmos ad=0.2516p pd=2.16u as=0.1406p ps=1.12u w=0.74u l=0.13u
X2957 VDD.t674 a_6326_10280# a_6326_10280# VDD.t358 sg13_lv_pmos ad=0.38p pd=2.38u as=0.38p ps=2.38u w=2u l=1u
X2958 VDD.t1082 a_4187_2434# a_17031_5315# VDD.t347 sg13_lv_pmos ad=0.3808p pd=2.92u as=0.2128p ps=1.5u w=1.12u l=0.6u
X2959 a_23111_14024# a_22873_14024# a_23003_14024# VSS.t850 sg13_lv_nmos ad=0.1406p pd=1.12u as=0.2516p ps=2.16u w=0.74u l=0.2u
X2960 VSS.t1697 a_4187_1764.t98 VSS.t1695 VSS.t1680 sg13_lv_nmos ad=1.33p pd=7.38u as=0 ps=0 w=7u l=7u
X2961 a_16510_16071# a_2595_16074.t5 a_17275_16071# VSS.t743 sg13_lv_nmos ad=0.2516p pd=2.16u as=0.1406p ps=1.12u w=0.74u l=0.13u
X2962 a_15273_1842# a_15077_1842# VDD.t380 VDD.t379 sg13_lv_pmos ad=0.3808p pd=2.92u as=0.2128p ps=1.5u w=1.12u l=0.13u
X2963 a_17031_14652# a_16793_14024# a_16923_14024# VDD.t378 sg13_lv_pmos ad=0.2128p pd=1.5u as=0.3808p ps=2.92u w=1.12u l=0.2u
X2964 VSS.t248 VDD.t1685 VSS.t248 VSS.t247 sg13_lv_nmos ad=0.1428p pd=1.52u as=0 ps=0 w=0.42u l=1u
X2965 a_9444_9602# a_6854_11144# a_9712_9602# VSS.t1205 sg13_lv_nmos ad=0.68p pd=4.68u as=0.38p ps=2.38u w=2u l=1u
X2966 a_7390_6734# a_3747_6737.t8 a_9675_6734# VSS.t1868 sg13_lv_nmos ad=0.2516p pd=2.16u as=0.1406p ps=1.12u w=0.74u l=0.13u
X2967 a_1256_3134# CHAN2_MUX_SEL2 VSS.t1132 VSS.t2089 sg13_lv_nmos ad=0.2516p pd=2.16u as=0.2516p ps=2.16u w=0.74u l=0.13u
X2968 a_1256_13226# CHAN1_MUX_SEL0 VSS.t2279 VSS.t1243 sg13_lv_nmos ad=0.2516p pd=2.16u as=0.2516p ps=2.16u w=0.74u l=0.13u
X2969 a_13470_13226# a_2595_13229.t6 a_14235_13226# VSS.t2042 sg13_lv_nmos ad=0.2516p pd=2.16u as=0.1406p ps=1.12u w=0.74u l=0.13u
X2970 a_19550_13226# a_21044_13190# a_20968_13226# VDD.t2 sg13_lv_pmos ad=0.3808p pd=2.92u as=0.2128p ps=1.5u w=1.12u l=0.13u
X2971 VDD.t394 a_23763_7532# a_24197_7532# VDD.t345 sg13_lv_pmos ad=0.2128p pd=1.5u as=0.3808p ps=2.92u w=1.12u l=0.13u
X2972 a_6391_2470# a_6153_1842# a_6283_1842# VDD.t379 sg13_lv_pmos ad=0.2128p pd=1.5u as=0.3808p ps=2.92u w=1.12u l=0.2u
X2973 a_11195_3889# a_10985_3889# VSS.t930 VSS.t1779 sg13_lv_nmos ad=0.1406p pd=1.12u as=0.1665p ps=1.19u w=0.74u l=0.13u
X2974 a_2873_4240# CHAN2_MUX_SEL1 VDD.t1174 VDD.t0 sg13_lv_pmos ad=0.1596p pd=1.22u as=0.2856p ps=2.36u w=0.84u l=0.13u
X2975 a_14235_1044# a_14025_1044# VSS.t41 VSS.t40 sg13_lv_nmos ad=0.1406p pd=1.12u as=0.1665p ps=1.19u w=0.74u l=0.13u
X2976 VSS.t364 VDD.t1645 VSS.t364 VSS.t368 sg13_lv_nmos ad=0.1428p pd=1.52u as=0 ps=0 w=0.42u l=1u
X2977 VDD.t1201 a_26803_4687# a_27237_4687# VDD.t347 sg13_lv_pmos ad=0.2128p pd=1.5u as=0.3808p ps=2.92u w=1.12u l=0.13u
X2978 a_11195_16071# a_10985_16071# VDD.t811 VDD.t34 sg13_lv_pmos ad=0.2128p pd=1.5u as=0.252p ps=1.57u w=1.12u l=0.13u
X2979 a_12471_14652# a_12233_14024# a_12363_14024# VDD.t378 sg13_lv_pmos ad=0.2128p pd=1.5u as=0.3808p ps=2.92u w=1.12u l=0.2u
X2980 VDD.t1032 a_4187_2434# a_17791_14652# VDD.t378 sg13_lv_pmos ad=0.3808p pd=2.92u as=0.2128p ps=1.5u w=1.12u l=0.6u
X2981 a_10206_11525# a_10649_11568# a_9946_11995# VSS.t926 sg13_lv_nmos ad=79.8f pd=0.8u as=0.1296p ps=1.52u w=0.42u l=0.13u
X2982 VSS.t1349 a_4187_1764.t91 a_8671_7532# VSS.t1348 sg13_lv_nmos ad=0.2516p pd=2.16u as=0.1406p ps=1.12u w=0.74u l=0.6u
X2983 a_9444_10280# a_9444_10280# VSS.t2291 VSS.t2289 sg13_lv_nmos ad=0.38p pd=2.38u as=0.68p ps=4.68u w=2u l=1u
X2984 VSS.t687 a_3747_1047.t7 a_12791_1008# VSS.t686 sg13_lv_nmos ad=0.2516p pd=2.16u as=0.2516p ps=2.16u w=0.74u l=0.13u
X2985 a_12993_16869# a_12797_16869# VDD.t867 VDD.t368 sg13_lv_pmos ad=0.3808p pd=2.92u as=0.2128p ps=1.5u w=1.12u l=0.13u
X2986 VSS.t2052 a_3171_13229.t8 a_8884_13190# VSS.t2051 sg13_lv_nmos ad=0.2516p pd=2.16u as=0.2516p ps=2.16u w=0.74u l=0.13u
X2987 a_22488_16071# a_21917_16869# VDD.t1489 VDD.t34 sg13_lv_pmos ad=0.2128p pd=1.5u as=0.3808p ps=2.92u w=1.12u l=0.13u
X2988 VDD.t1039 a_4187_2434# a_13231_14652# VDD.t378 sg13_lv_pmos ad=0.3808p pd=2.92u as=0.2128p ps=1.5u w=1.12u l=0.6u
X2989 VDD.t1153 a_2019_3892.t7 a_10404_3853# VDD.t0 sg13_lv_pmos ad=0.3808p pd=2.92u as=0.3808p ps=2.92u w=1.12u l=0.13u
X2990 a_21591_16869# a_21353_16869# a_21483_16869# VSS.t1159 sg13_lv_nmos ad=0.1406p pd=1.12u as=0.2516p ps=2.16u w=0.74u l=0.2u
X2991 VSS.t1215 a_4187_1764.t133 a_26911_16869# VSS.t1350 sg13_lv_nmos ad=0.2516p pd=2.16u as=0.1406p ps=1.12u w=0.74u l=0.6u
X2992 VSS.t782 a_10843_1842# a_11277_1842# VSS.t1221 sg13_lv_nmos ad=0.1406p pd=1.12u as=0.2516p ps=2.16u w=0.74u l=0.13u
X2993 a_9953_1842# a_9757_1842# VSS.t506 VSS.t505 sg13_lv_nmos ad=0.2516p pd=2.16u as=0.1406p ps=1.12u w=0.74u l=0.13u
X2994 VSS.t452 VDD.t1621 VSS.t451 VSS.t450 sg13_lv_nmos ad=0.1428p pd=1.52u as=0 ps=0 w=0.42u l=1u
X2995 a_7911_14024# a_7673_14024# a_7803_14024# VSS.t2144 sg13_lv_nmos ad=0.1406p pd=1.12u as=0.2516p ps=2.16u w=0.74u l=0.2u
X2996 VDD.t967 a_4187_2434# a_26911_8160# VDD.t345 sg13_lv_pmos ad=0.3808p pd=2.92u as=0.2128p ps=1.5u w=1.12u l=0.6u
X2997 VDD.t677 a_15403_1842# a_15837_1842# VDD.t379 sg13_lv_pmos ad=0.2128p pd=1.5u as=0.3808p ps=2.92u w=1.12u l=0.13u
X2998 VSS.t659 a_4187_1764.t139 a_22351_16869# VSS.t1733 sg13_lv_nmos ad=0.2516p pd=2.16u as=0.1406p ps=1.12u w=0.74u l=0.6u
X2999 a_4350_13226# a_5844_13190# a_5768_13226# VDD.t2 sg13_lv_pmos ad=0.3808p pd=2.92u as=0.2128p ps=1.5u w=1.12u l=0.13u
X3000 a_27433_16869# a_27237_16869# VDD.t845 VDD.t368 sg13_lv_pmos ad=0.3808p pd=2.92u as=0.2128p ps=1.5u w=1.12u l=0.13u
X3001 a_25630_16071# a_27991_16035# a_27915_16071# VDD.t34 sg13_lv_pmos ad=0.3808p pd=2.92u as=0.2128p ps=1.5u w=1.12u l=0.13u
X3002 VDD.t443 VDD.t441 VDD.t439 VDD.t378 sg13_lv_pmos ad=0.2128p pd=1.5u as=0 ps=0 w=1.12u l=0.13u
X3003 VDD.t1325 a_3171_6737.t6 a_14964_6698# VDD.t9 sg13_lv_pmos ad=0.3808p pd=2.92u as=0.3808p ps=2.92u w=1.12u l=0.13u
X3004 a_16108_3134# a_15765_3308# a_15964_3134# VDD.t0 sg13_lv_pmos ad=0.3808p pd=2.92u as=0.3304p ps=1.71u w=1.12u l=0.13u
X3005 VSS.t105 a_4187_1764.t125 a_8671_14024# VSS.t104 sg13_lv_nmos ad=0.2516p pd=2.16u as=0.1406p ps=1.12u w=0.74u l=0.6u
X3006 VSS.t1365 a_26043_14024# a_26477_14024# VSS.t2005 sg13_lv_nmos ad=0.1406p pd=1.12u as=0.2516p ps=2.16u w=0.74u l=0.13u
X3007 a_3543_13577# CHAN1_MUX_SEL0 a_3449_13577# VSS.t2280 sg13_lv_nmos ad=0.1216p pd=1.02u as=0.2176p ps=1.96u w=0.64u l=0.13u
X3008 a_11848_1044# a_11277_1842# VSS.t638 VSS.t1982 sg13_lv_nmos ad=0.1406p pd=1.12u as=0.2516p ps=2.16u w=0.74u l=0.13u
X3009 CHAN0_MUX_OUT a_16851_15336# VDD.t1452 VDD.t34 sg13_lv_pmos ad=0.2128p pd=1.5u as=0.2086p ps=1.5u w=1.12u l=0.13u
X3010 VSS.t218 VDD.t1693 VSS.t218 VSS.t219 sg13_lv_nmos ad=79.8f pd=0.8u as=0 ps=0 w=0.42u l=1u
X3011 VDD.t463 VDD.t464 VDD.t465 VDD.t360 sg13_lv_pmos ad=0.2128p pd=1.5u as=0 ps=0 w=1.12u l=0.13u
X3012 VSS.t425 VDD.t1628 VSS.t424 VSS.t423 sg13_lv_nmos ad=0.1428p pd=1.52u as=0 ps=0 w=0.42u l=1u
X3013 a_22590_16071# a_23431_16035# a_23355_16071# VDD.t34 sg13_lv_pmos ad=0.3808p pd=2.92u as=0.2128p ps=1.5u w=1.12u l=0.13u
X3014 a_11491_11918# a_10649_11568# a_10232_11561# VDD.t358 sg13_lv_pmos ad=0.2048p pd=1.63u as=0.34p ps=2.68u w=1u l=0.13u
X3015 VSS.t431 VDD.t1626 VSS.t433 VSS.t432 sg13_lv_nmos ad=79.8f pd=0.8u as=0 ps=0 w=0.42u l=1u
X3016 a_6854_11144# a_6326_10280# VDD.t456 VDD.t358 sg13_lv_pmos ad=0.38p pd=2.38u as=0.38p ps=2.38u w=2u l=1u
X3017 VDD.t1290 a_3449_1395# a_3747_1047.t0 VDD.t67 sg13_lv_pmos ad=0.4256p pd=3u as=0.2128p ps=1.5u w=1.12u l=0.13u
X3018 VDD.t567 a_8997_16869# a_9465_16071# VDD.t34 sg13_lv_pmos ad=0.252p pd=1.57u as=0.3808p ps=2.92u w=1.12u l=0.13u
X3019 a_13470_1044# a_13444_1008# a_13368_1044# VDD.t67 sg13_lv_pmos ad=0.3808p pd=2.92u as=0.2128p ps=1.5u w=1.12u l=0.13u
X3020 VDD.t1446 a_4763_1842# a_5197_1842# VDD.t379 sg13_lv_pmos ad=0.2128p pd=1.5u as=0.3808p ps=2.92u w=1.12u l=0.13u
X3021 a_22590_3889# a_2595_3892.t3 a_23355_3889# VSS.t1769 sg13_lv_nmos ad=0.2516p pd=2.16u as=0.1406p ps=1.12u w=0.74u l=0.13u
X3022 a_27671_4687# a_27433_4687# a_27563_4687# VSS.t88 sg13_lv_nmos ad=0.1406p pd=1.12u as=0.2516p ps=2.16u w=0.74u l=0.2u
X3023 a_16108_5979# a_26985_6209# a_25630_6734# VDD.t9 sg13_lv_pmos ad=0.3808p pd=2.92u as=0.3808p ps=2.92u w=1.12u l=0.13u
X3024 VDD.t721 a_15403_14024# a_15837_14024# VDD.t378 sg13_lv_pmos ad=0.2128p pd=1.5u as=0.3808p ps=2.92u w=1.12u l=0.13u
X3025 a_26395_3889# a_26185_3889# VDD.t1254 VDD.t0 sg13_lv_pmos ad=0.2128p pd=1.5u as=0.252p ps=1.57u w=1.12u l=0.13u
X3026 VDD.t138 VSS.t324 VDD.t136 VDD.t9 sg13_lv_pmos ad=0.19p pd=1.38u as=0 ps=0 w=1u l=1u
X3027 a_12471_7532# a_12233_7532# a_12363_7532# VSS.t1621 sg13_lv_nmos ad=0.1406p pd=1.12u as=0.2516p ps=2.16u w=0.74u l=0.2u
X3028 a_19311_5315# a_19073_4687# a_19203_4687# VDD.t347 sg13_lv_pmos ad=0.2128p pd=1.5u as=0.3808p ps=2.92u w=1.12u l=0.2u
X3029 a_11195_6734# a_10985_6734# VDD.t1170 VDD.t9 sg13_lv_pmos ad=0.2128p pd=1.5u as=0.252p ps=1.57u w=1.12u l=0.13u
X3030 VDD.t374 a_3747_3892.t3 a_24951_3853# VDD.t0 sg13_lv_pmos ad=0.3808p pd=2.92u as=0.3808p ps=2.92u w=1.12u l=0.13u
X3031 VDD.t1167 a_2595_13229.t7 a_11271_13190# VDD.t2 sg13_lv_pmos ad=0.3808p pd=2.92u as=0.3808p ps=2.92u w=1.12u l=0.13u
X3032 VSS.t550 a_3171_6737.t5 a_18004_6698# VSS.t1907 sg13_lv_nmos ad=0.2516p pd=2.16u as=0.2516p ps=2.16u w=0.74u l=0.13u
X3033 VDD.t719 a_3171_3156.t3 a_11785_3364# VDD.t0 sg13_lv_pmos ad=0.3808p pd=2.92u as=0.3808p ps=2.92u w=1.12u l=0.13u
X3034 VDD.t579 a_3171_1047.t3 a_24084_1008# VDD.t67 sg13_lv_pmos ad=0.3808p pd=2.92u as=0.3808p ps=2.92u w=1.12u l=0.13u
X3035 a_6153_16869# a_5957_16869# VSS.t885 VSS.t1832 sg13_lv_nmos ad=0.2516p pd=2.16u as=0.1406p ps=1.12u w=0.74u l=0.13u
X3036 a_15755_16071# a_15545_16071# VSS.t1415 VSS.t2067 sg13_lv_nmos ad=0.1406p pd=1.12u as=0.1665p ps=1.19u w=0.74u l=0.13u
X3037 a_3449_1395# CHAN3_MUX_SEL0 VDD.t1432 VDD.t67 sg13_lv_pmos ad=0.1596p pd=1.22u as=0.2856p ps=2.36u w=0.84u l=0.13u
X3038 a_2019_12493.t0 a_1721_12513# VDD.t801 VDD.t2 sg13_lv_pmos ad=0.2128p pd=1.5u as=0.1918p ps=1.5u w=1.12u l=0.13u
X3039 a_1721_16422# a_1256_16071# VDD.t885 VDD.t34 sg13_lv_pmos ad=0.1596p pd=1.22u as=0.2856p ps=2.36u w=0.84u l=0.13u
X3040 a_15273_7532# a_15077_7532# VDD.t744 VDD.t345 sg13_lv_pmos ad=0.3808p pd=2.92u as=0.2128p ps=1.5u w=1.12u l=0.13u
X3041 VDD.t1092 a_4187_2434# a_7911_2470# VDD.t379 sg13_lv_pmos ad=0.3808p pd=2.92u as=0.2128p ps=1.5u w=1.12u l=0.6u
X3042 a_13818_10808# a_12849_11557# VSS.t1187 VSS.t1190 sg13_lv_nmos ad=37.8f pd=0.6u as=0.1701p ps=1.65u w=0.42u l=0.13u
X3043 a_6391_8160# a_6153_7532# a_6283_7532# VDD.t345 sg13_lv_pmos ad=0.2128p pd=1.5u as=0.3808p ps=2.92u w=1.12u l=0.2u
X3044 VDD.t209 VSS.t402 VDD.t208 VDD.t67 sg13_lv_pmos ad=0.19p pd=1.38u as=0 ps=0 w=1u l=1u
X3045 VSS.t284 VDD.t1676 VSS.t286 VSS.t285 sg13_lv_nmos ad=79.8f pd=0.8u as=0 ps=0 w=0.42u l=1u
X3046 VSS.t480 a_4187_1764.t49 a_16271_4687# VSS.t904 sg13_lv_nmos ad=0.2516p pd=2.16u as=0.1406p ps=1.12u w=0.74u l=0.6u
X3047 a_13991_17497# a_13753_16869# a_13883_16869# VDD.t368 sg13_lv_pmos ad=0.2128p pd=1.5u as=0.3808p ps=2.92u w=1.12u l=0.2u
X3048 a_24008_3889# a_23437_4687# VDD.t842 VDD.t0 sg13_lv_pmos ad=0.2128p pd=1.5u as=0.3808p ps=2.92u w=1.12u l=0.13u
X3049 a_18313_16869# a_18117_16869# VDD.t717 VDD.t368 sg13_lv_pmos ad=0.3808p pd=2.92u as=0.2128p ps=1.5u w=1.12u l=0.13u
X3050 a_14235_6734# a_14025_6734# VSS.t97 VSS.t1904 sg13_lv_nmos ad=0.1406p pd=1.12u as=0.1665p ps=1.19u w=0.74u l=0.13u
X3051 a_18795_13226# a_18585_13226# VDD.t656 VDD.t2 sg13_lv_pmos ad=0.2128p pd=1.5u as=0.252p ps=1.57u w=1.12u l=0.13u
X3052 VDD.t1022 a_4187_2434# a_14751_17497# VDD.t368 sg13_lv_pmos ad=0.3808p pd=2.92u as=0.2128p ps=1.5u w=1.12u l=0.6u
X3053 VSS.t1815 a_3747_6737.t7 a_12791_6698# VSS.t1814 sg13_lv_nmos ad=0.2516p pd=2.16u as=0.2516p ps=2.16u w=0.74u l=0.13u
X3054 VSS.t1250 a_26043_4687# a_26477_4687# VSS.t1394 sg13_lv_nmos ad=0.1406p pd=1.12u as=0.2516p ps=2.16u w=0.74u l=0.13u
X3055 a_12993_14024# a_12797_14024# VDD.t599 VDD.t378 sg13_lv_pmos ad=0.3808p pd=2.92u as=0.2128p ps=1.5u w=1.12u l=0.13u
X3056 a_14235_13226# a_14025_13226# VDD.t1369 VDD.t2 sg13_lv_pmos ad=0.2128p pd=1.5u as=0.252p ps=1.57u w=1.12u l=0.13u
X3057 a_23111_5315# a_22873_4687# a_23003_4687# VDD.t347 sg13_lv_pmos ad=0.2128p pd=1.5u as=0.3808p ps=2.92u w=1.12u l=0.2u
X3058 a_9953_7532# a_9757_7532# VSS.t478 VSS.t1001 sg13_lv_nmos ad=0.2516p pd=2.16u as=0.1406p ps=1.12u w=0.74u l=0.13u
X3059 VDD.t280 VSS.t404 VDD.t279 VDD.t67 sg13_lv_pmos ad=0.34p pd=2.68u as=0 ps=0 w=1u l=1u
X3060 VSS.t1111 a_10843_7532# a_11277_7532# VSS.t1823 sg13_lv_nmos ad=0.1406p pd=1.12u as=0.2516p ps=2.16u w=0.74u l=0.13u
X3061 VSS.t1572 VSS.t1572 VSS.t1574 VSS.t1573 sg13_lv_nmos ad=0.2516p pd=2.16u as=0 ps=0 w=0.74u l=0.13u
X3062 a_22590_6734# a_23431_6698# a_23355_6734# VDD.t9 sg13_lv_pmos ad=0.3808p pd=2.92u as=0.2128p ps=1.5u w=1.12u l=0.13u
X3063 VDD.t1526 a_17683_4687# a_18117_4687# VDD.t347 sg13_lv_pmos ad=0.2128p pd=1.5u as=0.3808p ps=2.92u w=1.12u l=0.13u
X3064 a_4157_7003# REF_CLK VSS.t37 VSS.t1304 sg13_lv_nmos ad=0.2516p pd=2.16u as=0.2553p ps=2.17u w=0.74u l=0.13u
X3065 a_2595_6001.t0 a_2297_6021# VDD.t537 VDD.t9 sg13_lv_pmos ad=0.2128p pd=1.5u as=0.1918p ps=1.5u w=1.12u l=0.13u
X3066 a_25528_13226# a_24957_14024# VDD.t1597 VDD.t2 sg13_lv_pmos ad=0.2128p pd=1.5u as=0.3808p ps=2.92u w=1.12u l=0.13u
X3067 VDD.t400 a_15403_7532# a_15837_7532# VDD.t345 sg13_lv_pmos ad=0.2128p pd=1.5u as=0.3808p ps=2.92u w=1.12u l=0.13u
X3068 VSS.t735 a_19637_1842# a_20105_1044# VSS.t734 sg13_lv_nmos ad=0.1665p pd=1.19u as=0.2516p ps=2.16u w=0.74u l=0.13u
X3069 VDD.t1270 a_16851_309# CHAN3_MUX_OUT VDD.t67 sg13_lv_pmos ad=0.7336p pd=3.55u as=0.2128p ps=1.5u w=1.12u l=0.13u
X3070 a_10713_4687# a_10517_4687# VDD.t700 VDD.t347 sg13_lv_pmos ad=0.3808p pd=2.92u as=0.2128p ps=1.5u w=1.12u l=0.13u
X3071 a_21835_16071# a_21625_16071# VDD.t1356 VDD.t34 sg13_lv_pmos ad=0.2128p pd=1.5u as=0.252p ps=1.57u w=1.12u l=0.13u
X3072 a_4157_16340# CHAN0_DELAY_IN VSS.t24 VSS.t2187 sg13_lv_nmos ad=0.2516p pd=2.16u as=0.2553p ps=2.17u w=0.74u l=0.13u
X3073 a_1256_12471# CHAN1_MUX_SEL2 VDD.t419 VDD.t2 sg13_lv_pmos ad=0.3808p pd=2.92u as=0.3808p ps=2.92u w=1.12u l=0.13u
X3074 VDD.t802 a_18117_1842# a_18585_1044# VDD.t67 sg13_lv_pmos ad=0.252p pd=1.57u as=0.3808p ps=2.92u w=1.12u l=0.13u
X3075 a_27433_14024# a_27237_14024# VDD.t939 VDD.t378 sg13_lv_pmos ad=0.3808p pd=2.92u as=0.2128p ps=1.5u w=1.12u l=0.13u
X3076 a_11848_6734# a_11277_7532# VSS.t1109 VSS.t1108 sg13_lv_nmos ad=0.1406p pd=1.12u as=0.2516p ps=2.16u w=0.74u l=0.13u
X3077 VSS.t455 a_3171_311.t2 a_23945_519# VSS.t1944 sg13_lv_nmos ad=0.2516p pd=2.16u as=0.2516p ps=2.16u w=0.74u l=0.13u
X3078 VSS.t913 a_4187_1764.t44 a_20071_4687# VSS.t912 sg13_lv_nmos ad=0.2516p pd=2.16u as=0.1406p ps=1.12u w=0.74u l=0.6u
X3079 a_11711_2470# a_11473_1842# a_11603_1842# VDD.t379 sg13_lv_pmos ad=0.2128p pd=1.5u as=0.3808p ps=2.92u w=1.12u l=0.2u
X3080 VSS.t540 a_2019_3892.t7 a_10404_3853# VSS.t1464 sg13_lv_nmos ad=0.2516p pd=2.16u as=0.2516p ps=2.16u w=0.74u l=0.13u
X3081 VSS.t1455 a_10843_16869# a_11277_16869# VSS.t1863 sg13_lv_nmos ad=0.1406p pd=1.12u as=0.2516p ps=2.16u w=0.74u l=0.13u
X3082 VSS.t2069 a_16597_14024# a_17065_13226# VSS.t2337 sg13_lv_nmos ad=0.1665p pd=1.19u as=0.2516p ps=2.16u w=0.74u l=0.13u
X3083 VDD.t731 a_4763_7532# a_5197_7532# VDD.t345 sg13_lv_pmos ad=0.2128p pd=1.5u as=0.3808p ps=2.92u w=1.12u l=0.13u
X3084 a_27671_1842# a_27433_1842# a_27563_1842# VSS.t1395 sg13_lv_nmos ad=0.1406p pd=1.12u as=0.2516p ps=2.16u w=0.74u l=0.2u
X3085 VDD.t750 a_7803_4687# a_8237_4687# VDD.t347 sg13_lv_pmos ad=0.2128p pd=1.5u as=0.3808p ps=2.92u w=1.12u l=0.13u
X3086 a_7151_16869# a_6913_16869# a_7043_16869# VSS.t2188 sg13_lv_nmos ad=0.1406p pd=1.12u as=0.2516p ps=2.16u w=0.74u l=0.2u
X3087 a_14888_13226# a_14317_14024# VSS.t2044 VSS.t2363 sg13_lv_nmos ad=0.1406p pd=1.12u as=0.2516p ps=2.16u w=0.74u l=0.13u
X3088 a_16108_3134# a_26985_3364# a_25630_3889# VDD.t0 sg13_lv_pmos ad=0.3808p pd=2.92u as=0.3808p ps=2.92u w=1.12u l=0.13u
X3089 VDD.t193 VSS.t371 VDD.t191 VDD.t0 sg13_lv_pmos ad=0.19p pd=1.38u as=0 ps=0 w=1u l=1u
X3090 a_1256_3889# CHAN2_MUX_SEL0 VDD.t709 VDD.t0 sg13_lv_pmos ad=0.3808p pd=2.92u as=0.3808p ps=2.92u w=1.12u l=0.13u
X3091 VDD.t1162 a_3747_6001.t2 a_26985_6209# VDD.t9 sg13_lv_pmos ad=0.3808p pd=2.92u as=0.3808p ps=2.92u w=1.12u l=0.13u
X3092 a_13368_16071# a_12797_16869# VSS.t473 VSS.t2198 sg13_lv_nmos ad=0.1406p pd=1.12u as=0.2516p ps=2.16u w=0.74u l=0.13u
X3093 VSS.t1583 VSS.t1580 VSS.t1580 VSS.t1581 sg13_lv_nmos ad=0.1406p pd=1.12u as=0 ps=0 w=0.74u l=0.13u
X3094 a_10328_13226# a_9757_14024# VSS.t1702 VSS.t1973 sg13_lv_nmos ad=0.1406p pd=1.12u as=0.2516p ps=2.16u w=0.74u l=0.13u
X3095 VSS.t1476 CHAN3_MUX_SEL4 a_15765_463# VSS.t1475 sg13_lv_nmos ad=0.2516p pd=2.16u as=0.2516p ps=2.16u w=0.74u l=0.13u
X3096 a_24631_14024# a_24393_14024# a_24523_14024# VSS.t1857 sg13_lv_nmos ad=0.1406p pd=1.12u as=0.2516p ps=2.16u w=0.74u l=0.2u
X3097 a_16108_12471# a_2595_12493.t2 a_19550_13226# VSS.t878 sg13_lv_nmos ad=0.2516p pd=2.16u as=0.2516p ps=2.16u w=0.74u l=0.13u
X3098 a_19311_17497# a_19073_16869# a_19203_16869# VDD.t368 sg13_lv_pmos ad=0.2128p pd=1.5u as=0.3808p ps=2.92u w=1.12u l=0.2u
X3099 a_16510_1044# a_2595_1047.t5 a_17275_1044# VSS.t650 sg13_lv_nmos ad=0.2516p pd=2.16u as=0.1406p ps=1.12u w=0.74u l=0.13u
X3100 a_5731_289# a_14825_519# a_13470_1044# VDD.t67 sg13_lv_pmos ad=0.3808p pd=2.92u as=0.3808p ps=2.92u w=1.12u l=0.13u
X3101 a_16510_16071# a_3747_16074.t5 a_18795_16071# VSS.t1897 sg13_lv_nmos ad=0.2516p pd=2.16u as=0.1406p ps=1.12u w=0.74u l=0.13u
X3102 a_13306_11995# a_14111_11568# a_13566_11525# VDD.t358 sg13_lv_pmos ad=0.1428p pd=1.52u as=79.8f ps=0.8u w=0.42u l=0.13u
X3103 VDD.t901 a_2019_6001.t3 a_5705_6209# VDD.t9 sg13_lv_pmos ad=0.3808p pd=2.92u as=0.3808p ps=2.92u w=1.12u l=0.13u
X3104 a_22590_13226# a_22564_13190# a_22488_13226# VDD.t2 sg13_lv_pmos ad=0.3808p pd=2.92u as=0.2128p ps=1.5u w=1.12u l=0.13u
X3105 a_13470_13226# a_3747_13229.t6 a_15755_13226# VSS.t2264 sg13_lv_nmos ad=0.2516p pd=2.16u as=0.1406p ps=1.12u w=0.74u l=0.13u
X3106 a_5974_11413# a_6126_9506# VSS.t807 VSS.t806 sg13_lv_nmos ad=0.38p pd=2.38u as=0.68p ps=4.68u w=2u l=1u
X3107 VDD.t990 a_4187_2434# a_7911_8160# VDD.t345 sg13_lv_pmos ad=0.3808p pd=2.92u as=0.2128p ps=1.5u w=1.12u l=0.6u
X3108 VSS.t371 VDD.t1642 VSS.t371 VSS.t375 sg13_lv_nmos ad=0.1428p pd=1.52u as=0 ps=0 w=0.42u l=1u
X3109 a_26395_3889# a_26185_3889# VSS.t1793 VSS.t1792 sg13_lv_nmos ad=0.1406p pd=1.12u as=0.1665p ps=1.19u w=0.74u l=0.13u
X3110 a_20071_14024# a_19833_14024# a_19963_14024# VSS.t1429 sg13_lv_nmos ad=0.1406p pd=1.12u as=0.2516p ps=2.16u w=0.74u l=0.2u
X3111 VSS.t509 a_4187_1764.t103 a_25391_14024# VSS.t1034 sg13_lv_nmos ad=0.2516p pd=2.16u as=0.1406p ps=1.12u w=0.74u l=0.6u
X3112 a_16408_13226# a_15837_14024# VDD.t817 VDD.t2 sg13_lv_pmos ad=0.2128p pd=1.5u as=0.3808p ps=2.92u w=1.12u l=0.13u
X3113 VDD.t316 VSS.t289 VDD.t315 VDD.t2 sg13_lv_pmos ad=0.34p pd=2.68u as=0 ps=0 w=1u l=1u
X3114 a_13470_3889# a_14964_3853# a_14888_3889# VDD.t0 sg13_lv_pmos ad=0.3808p pd=2.92u as=0.2128p ps=1.5u w=1.12u l=0.13u
X3115 a_1256_16071# CHAN0_MUX_SEL0 VSS.t774 VSS.t773 sg13_lv_nmos ad=0.2516p pd=2.16u as=0.2516p ps=2.16u w=0.74u l=0.13u
X3116 VDD.t292 VSS.t200 VDD.t290 VDD.t34 sg13_lv_pmos ad=0.19p pd=1.38u as=0 ps=0 w=1u l=1u
X3117 a_13470_16071# a_2595_16074.t6 a_14235_16071# VSS.t1084 sg13_lv_nmos ad=0.2516p pd=2.16u as=0.1406p ps=1.12u w=0.74u l=0.13u
X3118 a_12715_16071# a_12505_16071# VDD.t1147 VDD.t34 sg13_lv_pmos ad=0.2128p pd=1.5u as=0.252p ps=1.57u w=1.12u l=0.13u
X3119 VDD.t106 VSS.t455 VDD.t105 VDD.t67 sg13_lv_pmos ad=0.34p pd=2.68u as=0 ps=0 w=1u l=1u
X3120 VSS.t974 a_4187_1764.t17 a_16271_1842# VSS.t2369 sg13_lv_nmos ad=0.2516p pd=2.16u as=0.1406p ps=1.12u w=0.74u l=0.6u
X3121 VSS.t64 a_3747_3892.t3 a_24951_3853# VSS.t63 sg13_lv_nmos ad=0.2516p pd=2.16u as=0.2516p ps=2.16u w=0.74u l=0.13u
X3122 a_13991_14652# a_13753_14024# a_13883_14024# VDD.t378 sg13_lv_pmos ad=0.2128p pd=1.5u as=0.3808p ps=2.92u w=1.12u l=0.2u
X3123 VDD.t578 a_3171_1047.t6 a_14964_1008# VDD.t67 sg13_lv_pmos ad=0.3808p pd=2.92u as=0.3808p ps=2.92u w=1.12u l=0.13u
X3124 a_5731_3134# a_2019_3156.t3 a_4350_3889# VSS.t2327 sg13_lv_nmos ad=0.2516p pd=2.16u as=0.2516p ps=2.16u w=0.74u l=0.13u
X3125 a_18313_14024# a_18117_14024# VDD.t655 VDD.t378 sg13_lv_pmos ad=0.3808p pd=2.92u as=0.2128p ps=1.5u w=1.12u l=0.13u
X3126 VDD.t664 a_6326_10280# a_6126_9506# VDD.t358 sg13_lv_pmos ad=0.38p pd=2.38u as=0.38p ps=2.38u w=2u l=1u
X3127 VSS.t684 a_3747_1047.t2 a_27991_1008# VSS.t683 sg13_lv_nmos ad=0.2516p pd=2.16u as=0.2516p ps=2.16u w=0.74u l=0.13u
X3128 VDD.t1334 a_10083_1842# a_10517_1842# VDD.t379 sg13_lv_pmos ad=0.2128p pd=1.5u as=0.3808p ps=2.92u w=1.12u l=0.13u
X3129 VDD.t1377 a_25717_16869# a_26185_16071# VDD.t34 sg13_lv_pmos ad=0.252p pd=1.57u as=0.3808p ps=2.92u w=1.12u l=0.13u
X3130 VSS.t820 CHAN1_MUX_SEL4 a_15765_12645# VSS.t941 sg13_lv_nmos ad=0.2516p pd=2.16u as=0.2516p ps=2.16u w=0.74u l=0.13u
X3131 a_9444_10280# a_6854_11144# a_6854_11144# VSS.t1205 sg13_lv_nmos ad=0.68p pd=4.68u as=0.38p ps=2.38u w=2u l=1u
X3132 a_17553_4687# a_17357_4687# VSS.t889 VSS.t923 sg13_lv_nmos ad=0.2516p pd=2.16u as=0.1406p ps=1.12u w=0.74u l=0.13u
X3133 a_2297_16422# CHAN0_MUX_SEL0 VDD.t636 VDD.t34 sg13_lv_pmos ad=0.1596p pd=1.22u as=0.2856p ps=2.36u w=0.84u l=0.13u
X3134 a_24008_16071# a_23437_16869# VDD.t1535 VDD.t34 sg13_lv_pmos ad=0.2128p pd=1.5u as=0.3808p ps=2.92u w=1.12u l=0.13u
X3135 a_8671_4687# a_8433_4687# a_8563_4687# VSS.t1107 sg13_lv_nmos ad=0.1406p pd=1.12u as=0.2516p ps=2.16u w=0.74u l=0.2u
X3136 VDD.t1043 a_4187_2434# a_14751_14652# VDD.t378 sg13_lv_pmos ad=0.3808p pd=2.92u as=0.2128p ps=1.5u w=1.12u l=0.6u
X3137 VDD.t1345 a_2019_3892.t2 a_25604_3853# VDD.t0 sg13_lv_pmos ad=0.3808p pd=2.92u as=0.3808p ps=2.92u w=1.12u l=0.13u
X3138 VSS.t1518 a_3171_16074.t8 a_8884_16035# VSS.t2215 sg13_lv_nmos ad=0.2516p pd=2.16u as=0.2516p ps=2.16u w=0.74u l=0.13u
X3139 VSS.t1230 a_26043_1842# a_26477_1842# VSS.t1229 sg13_lv_nmos ad=0.1406p pd=1.12u as=0.2516p ps=2.16u w=0.74u l=0.13u
X3140 VDD.t537 a_1544_5979# a_2297_6021# VDD.t9 sg13_lv_pmos ad=0.1918p pd=1.5u as=0.1596p ps=1.22u w=0.84u l=0.13u
X3141 VDD.t766 a_2019_6737.t7 a_10404_6698# VDD.t9 sg13_lv_pmos ad=0.3808p pd=2.92u as=0.3808p ps=2.92u w=1.12u l=0.13u
X3142 a_16510_13226# a_17351_13190# a_17275_13226# VDD.t2 sg13_lv_pmos ad=0.3808p pd=2.92u as=0.2128p ps=1.5u w=1.12u l=0.13u
X3143 VSS.t681 a_3747_1047.t9 a_6711_1008# VSS.t680 sg13_lv_nmos ad=0.2516p pd=2.16u as=0.2516p ps=2.16u w=0.74u l=0.13u
X3144 VSS.t1008 a_4187_1764.t137 a_23871_16869# VSS.t1007 sg13_lv_nmos ad=0.2516p pd=2.16u as=0.1406p ps=1.12u w=0.74u l=0.6u
X3145 a_11195_1044# a_10985_1044# VDD.t1259 VDD.t67 sg13_lv_pmos ad=0.2128p pd=1.5u as=0.252p ps=1.57u w=1.12u l=0.13u
X3146 a_24008_3889# a_23437_4687# VSS.t1203 VSS.t1202 sg13_lv_nmos ad=0.1406p pd=1.12u as=0.2516p ps=2.16u w=0.74u l=0.13u
X3147 a_4871_14024# a_4633_14024# a_4763_14024# VSS.t2140 sg13_lv_nmos ad=0.1406p pd=1.12u as=0.2516p ps=2.16u w=0.74u l=0.2u
X3148 VDD.t158 VSS.t240 VDD.t157 VDD.t2 sg13_lv_pmos ad=0.34p pd=2.68u as=0 ps=0 w=1u l=1u
X3149 VSS.t548 a_19637_7532# a_20105_6734# VSS.t1101 sg13_lv_nmos ad=0.1665p pd=1.19u as=0.2516p ps=2.16u w=0.74u l=0.13u
X3150 a_2595_3156.t1 a_2297_3176# VSS.t2 VSS.t93 sg13_lv_nmos ad=0.1406p pd=1.12u as=0.1331p ps=1.12u w=0.74u l=0.13u
X3151 a_9193_14024# a_8997_14024# VSS.t105 VSS.t1339 sg13_lv_nmos ad=0.2516p pd=2.16u as=0.1406p ps=1.12u w=0.74u l=0.13u
X3152 a_16108_289# a_2595_311.t2 a_19550_1044# VSS.t1941 sg13_lv_nmos ad=0.2516p pd=2.16u as=0.2516p ps=2.16u w=0.74u l=0.13u
X3153 a_3543_16422# CHAN0_MUX_SEL0 a_3449_16422# VSS.t776 sg13_lv_nmos ad=0.1216p pd=1.02u as=0.2176p ps=1.96u w=0.64u l=0.13u
X3154 a_22590_16071# a_24951_16035# a_24875_16071# VDD.t34 sg13_lv_pmos ad=0.3808p pd=2.92u as=0.2128p ps=1.5u w=1.12u l=0.13u
X3155 a_21835_3889# a_21625_3889# VDD.t1241 VDD.t0 sg13_lv_pmos ad=0.2128p pd=1.5u as=0.252p ps=1.57u w=1.12u l=0.13u
X3156 VSS.t869 a_4187_1764.t129 a_5631_14024# VSS.t868 sg13_lv_nmos ad=0.2516p pd=2.16u as=0.1406p ps=1.12u w=0.74u l=0.6u
X3157 a_5731_12471# a_3171_12493.t3 a_10430_13226# VSS.t902 sg13_lv_nmos ad=0.2516p pd=2.16u as=0.2516p ps=2.16u w=0.74u l=0.13u
X3158 a_11711_8160# a_11473_7532# a_11603_7532# VDD.t345 sg13_lv_pmos ad=0.2128p pd=1.5u as=0.3808p ps=2.92u w=1.12u l=0.2u
X3159 VSS.t1358 a_23003_14024# a_23437_14024# VSS.t1855 sg13_lv_nmos ad=0.1406p pd=1.12u as=0.2516p ps=2.16u w=0.74u l=0.13u
X3160 VSS.t1860 a_4187_1764.t12 a_20071_1842# VSS.t2169 sg13_lv_nmos ad=0.2516p pd=2.16u as=0.1406p ps=1.12u w=0.74u l=0.6u
X3161 a_16108_15316# a_2019_15338.t2 a_16510_16071# VSS.t2206 sg13_lv_nmos ad=0.2516p pd=2.16u as=0.2516p ps=2.16u w=0.74u l=0.13u
X3162 a_14751_5315# a_14513_4687# a_14643_4687# VDD.t347 sg13_lv_pmos ad=0.2128p pd=1.5u as=0.3808p ps=2.92u w=1.12u l=0.2u
X3163 VDD.t1131 a_2595_3892.t4 a_20391_3853# VDD.t0 sg13_lv_pmos ad=0.3808p pd=2.92u as=0.3808p ps=2.92u w=1.12u l=0.13u
X3164 VSS.t207 VDD.t1696 VSS.t207 VSS.t212 sg13_lv_nmos ad=79.8f pd=0.8u as=0 ps=0 w=0.42u l=1u
X3165 a_27671_7532# a_27433_7532# a_27563_7532# VSS.t1289 sg13_lv_nmos ad=0.1406p pd=1.12u as=0.2516p ps=2.16u w=0.74u l=0.2u
X3166 VDD.t1106 a_4187_2434# a_24631_2470# VDD.t379 sg13_lv_pmos ad=0.3808p pd=2.92u as=0.2128p ps=1.5u w=1.12u l=0.6u
X3167 a_21353_4687# a_21157_4687# VSS.t29 VSS.t2355 sg13_lv_nmos ad=0.2516p pd=2.16u as=0.1406p ps=1.12u w=0.74u l=0.13u
X3168 VSS.t331 VDD.t1658 VSS.t331 VSS.t334 sg13_lv_nmos ad=79.8f pd=0.8u as=0 ps=0 w=0.42u l=1u
X3169 a_26395_6734# a_26185_6734# VDD.t715 VDD.t9 sg13_lv_pmos ad=0.2128p pd=1.5u as=0.252p ps=1.57u w=1.12u l=0.13u
X3170 VSS.t1541 VSS.t1538 VSS.t1540 VSS.t1539 sg13_lv_nmos ad=0.2516p pd=2.16u as=0 ps=0 w=0.74u l=0.13u
X3171 VDD.t487 VDD.t485 VDD.t483 VDD.t347 sg13_lv_pmos ad=0.2128p pd=1.5u as=0 ps=0 w=1.12u l=0.13u
X3172 VDD.t809 a_3747_3156.t2 a_26985_3364# VDD.t0 sg13_lv_pmos ad=0.3808p pd=2.92u as=0.3808p ps=2.92u w=1.12u l=0.13u
X3173 a_7673_16869# a_7477_16869# VSS.t956 VSS.t1445 sg13_lv_nmos ad=0.2516p pd=2.16u as=0.1406p ps=1.12u w=0.74u l=0.13u
X3174 VDD.t701 a_10517_4687# a_10985_3889# VDD.t0 sg13_lv_pmos ad=0.252p pd=1.57u as=0.3808p ps=2.92u w=1.12u l=0.13u
X3175 VDD.t1253 a_3747_6737.t3 a_24951_6698# VDD.t9 sg13_lv_pmos ad=0.3808p pd=2.92u as=0.3808p ps=2.92u w=1.12u l=0.13u
X3176 VSS.t802 a_7043_4687# a_7477_4687# VSS.t801 sg13_lv_nmos ad=0.1406p pd=1.12u as=0.2516p ps=2.16u w=0.74u l=0.13u
X3177 a_4111_5315# CHAN2_DELAY_IN a_4003_4687# VDD.t347 sg13_lv_pmos ad=0.2128p pd=1.5u as=0.3808p ps=2.92u w=1.12u l=0.2u
X3178 a_2019_15338.t0 a_1721_15358# VDD.t1421 VDD.t34 sg13_lv_pmos ad=0.2128p pd=1.5u as=0.1918p ps=1.5u w=1.12u l=0.13u
X3179 a_16510_6734# a_2595_6737.t5 a_17275_6734# VSS.t1380 sg13_lv_nmos ad=0.2516p pd=2.16u as=0.1406p ps=1.12u w=0.74u l=0.13u
X3180 a_2019_15338.t1 a_1721_15358# VSS.t2081 VSS.t1937 sg13_lv_nmos ad=0.1406p pd=1.12u as=0.1331p ps=1.12u w=0.74u l=0.13u
X3181 a_19311_14652# a_19073_14024# a_19203_14024# VDD.t378 sg13_lv_pmos ad=0.2128p pd=1.5u as=0.3808p ps=2.92u w=1.12u l=0.2u
X3182 a_11748_11799# DLL_RESETN VDD.t364 VDD.t358 sg13_lv_pmos ad=79.8f pd=0.8u as=1.10612p ps=6.66u w=0.42u l=0.13u
X3183 VDD.t1581 a_2019_3156.t3 a_5705_3364# VDD.t0 sg13_lv_pmos ad=0.3808p pd=2.92u as=0.3808p ps=2.92u w=1.12u l=0.13u
X3184 a_12355_11557# a_12158_11557# VDD.t790 VDD.t358 sg13_lv_pmos ad=0.3808p pd=2.92u as=0.2128p ps=1.5u w=1.12u l=0.13u
X3185 a_22590_1044# a_23431_1008# a_23355_1044# VDD.t67 sg13_lv_pmos ad=0.3808p pd=2.92u as=0.2128p ps=1.5u w=1.12u l=0.13u
X3186 a_1256_3889# CHAN2_MUX_SEL0 VSS.t945 VSS.t182 sg13_lv_nmos ad=0.2516p pd=2.16u as=0.2516p ps=2.16u w=0.74u l=0.13u
X3187 VDD.t1314 a_2019_6001.t2 a_17865_6209# VDD.t9 sg13_lv_pmos ad=0.3808p pd=2.92u as=0.3808p ps=2.92u w=1.12u l=0.13u
X3188 a_15304_10295# a_14851_11918# VSS.t561 VSS.t560 sg13_lv_nmos ad=0.2849p pd=2.25u as=0.2516p ps=2.16u w=0.74u l=0.13u
X3189 a_2297_3176# CHAN2_MUX_SEL2 VDD.t1484 VDD.t0 sg13_lv_pmos ad=0.1596p pd=1.22u as=0.2856p ps=2.36u w=0.84u l=0.13u
X3190 a_14851_11918# a_14009_11568# a_14757_11918# VSS.t560 sg13_lv_nmos ad=0.12665p pd=1.145u as=0.1428p ps=1.52u w=0.42u l=0.13u
X3191 VSS.t10 a_4187_1764.t81 a_16271_7532# VSS.t2364 sg13_lv_nmos ad=0.2516p pd=2.16u as=0.1406p ps=1.12u w=0.74u l=0.6u
X3192 a_24008_6734# a_23437_7532# VDD.t1614 VDD.t9 sg13_lv_pmos ad=0.2128p pd=1.5u as=0.3808p ps=2.92u w=1.12u l=0.13u
X3193 VSS.t1547 VSS.t1544 VSS.t1546 VSS.t1545 sg13_lv_nmos ad=0.2516p pd=2.16u as=0 ps=0 w=0.74u l=0.6u
X3194 VSS.t416 VDD.t1630 VSS.t416 VSS.t417 sg13_lv_nmos ad=79.8f pd=0.8u as=0 ps=0 w=0.42u l=1u
X3195 VSS.t492 a_4187_1764.t155 a_10191_16869# VSS.t1164 sg13_lv_nmos ad=0.2516p pd=2.16u as=0.1406p ps=1.12u w=0.74u l=0.6u
X3196 a_20593_14024# a_20397_14024# VSS.t1176 VSS.t2339 sg13_lv_nmos ad=0.2516p pd=2.16u as=0.1406p ps=1.12u w=0.74u l=0.13u
X3197 VSS.t1812 a_3747_6737.t2 a_27991_6698# VSS.t1811 sg13_lv_nmos ad=0.2516p pd=2.16u as=0.2516p ps=2.16u w=0.74u l=0.13u
X3198 VDD.t1435 a_1544_3134# a_1721_3176# VDD.t0 sg13_lv_pmos ad=0.1918p pd=1.5u as=0.1596p ps=1.22u w=0.84u l=0.13u
X3199 a_10951_17497# a_10713_16869# a_10843_16869# VDD.t368 sg13_lv_pmos ad=0.2128p pd=1.5u as=0.3808p ps=2.92u w=1.12u l=0.2u
X3200 VDD.t1169 a_10083_7532# a_10517_7532# VDD.t345 sg13_lv_pmos ad=0.2128p pd=1.5u as=0.3808p ps=2.92u w=1.12u l=0.13u
X3201 a_15273_16869# a_15077_16869# VDD.t919 VDD.t368 sg13_lv_pmos ad=0.3808p pd=2.92u as=0.2128p ps=1.5u w=1.12u l=0.13u
X3202 VSS.t1224 a_13883_14024# a_14317_14024# VSS.t1223 sg13_lv_nmos ad=0.1406p pd=1.12u as=0.2516p ps=2.16u w=0.74u l=0.13u
X3203 VSS.t922 a_11491_11918# a_12158_11557# VSS.t1122 sg13_lv_nmos ad=0.1406p pd=1.12u as=0.2516p ps=2.16u w=0.74u l=0.13u
X3204 VDD.t639 a_13123_4687# a_13557_4687# VDD.t347 sg13_lv_pmos ad=0.2128p pd=1.5u as=0.3808p ps=2.92u w=1.12u l=0.13u
X3205 a_15755_13226# a_15545_13226# VDD.t723 VDD.t2 sg13_lv_pmos ad=0.2128p pd=1.5u as=0.252p ps=1.57u w=1.12u l=0.13u
X3206 a_17553_1842# a_17357_1842# VSS.t585 VSS.t971 sg13_lv_nmos ad=0.2516p pd=2.16u as=0.1406p ps=1.12u w=0.74u l=0.13u
X3207 VSS.t1098 a_26043_7532# a_26477_7532# VSS.t2319 sg13_lv_nmos ad=0.1406p pd=1.12u as=0.2516p ps=2.16u w=0.74u l=0.13u
X3208 a_8671_1842# a_8433_1842# a_8563_1842# VSS.t1974 sg13_lv_nmos ad=0.1406p pd=1.12u as=0.2516p ps=2.16u w=0.74u l=0.2u
X3209 VSS.t951 a_16851_5999# REF_MUX_OUT VSS.t952 sg13_lv_nmos ad=0.2516p pd=2.16u as=0.1406p ps=1.12u w=0.74u l=0.13u
X3210 VSS.t193 VDD.t1702 VSS.t193 VSS.t198 sg13_lv_nmos ad=79.8f pd=0.8u as=0 ps=0 w=0.42u l=1u
X3211 a_1544_12471# CHAN1_MUX_SEL3 VSS.t169 VSS.t712 sg13_lv_nmos ad=0.2516p pd=2.16u as=0.2516p ps=2.16u w=0.74u l=0.13u
X3212 a_5731_289# a_5705_519# a_4350_1044# VDD.t67 sg13_lv_pmos ad=0.3808p pd=2.92u as=0.3808p ps=2.92u w=1.12u l=0.13u
X3213 a_10430_16071# a_11271_16035# a_11195_16071# VDD.t34 sg13_lv_pmos ad=0.3808p pd=2.92u as=0.2128p ps=1.5u w=1.12u l=0.13u
X3214 VSS.t715 a_3449_12513# a_3747_12493.t1 VSS.t1192 sg13_lv_nmos ad=0.2812p pd=2.24u as=0.1406p ps=1.12u w=0.74u l=0.13u
X3215 a_10520_11982# a_10751_11568# a_10206_11525# VSS.t926 sg13_lv_nmos ad=0.2373p pd=1.97u as=79.8f ps=0.8u w=0.42u l=0.13u
X3216 a_9712_9602# a_13019_11521# a_4187_1764.t1 VSS.t943 sg13_lv_nmos ad=0.136p pd=1.14u as=0.232p ps=2.08u w=0.4u l=0.2u
X3217 VSS.t985 a_3747_6737.t9 a_6711_6698# VSS.t1809 sg13_lv_nmos ad=0.2516p pd=2.16u as=0.2516p ps=2.16u w=0.74u l=0.13u
X3218 a_13470_3889# a_3171_3892.t6 a_14888_3889# VSS.t1658 sg13_lv_nmos ad=0.2516p pd=2.16u as=0.1406p ps=1.12u w=0.74u l=0.13u
X3219 a_25913_4687# a_25717_4687# VDD.t1271 VDD.t347 sg13_lv_pmos ad=0.3808p pd=2.92u as=0.2128p ps=1.5u w=1.12u l=0.13u
X3220 VSS.t814 a_6126_9506# a_5974_11413# VSS.t806 sg13_lv_nmos ad=0.68p pd=4.68u as=0.38p ps=2.38u w=2u l=1u
X3221 VSS.t200 VDD.t1699 VSS.t200 VSS.t204 sg13_lv_nmos ad=0.1428p pd=1.52u as=0 ps=0 w=0.42u l=1u
X3222 VSS.t364 VDD.t1647 VSS.t364 VSS.t363 sg13_lv_nmos ad=0.1428p pd=1.52u as=0 ps=0 w=0.42u l=1u
X3223 a_1256_5979# REF_MUX_SEL2 VDD.t425 VDD.t9 sg13_lv_pmos ad=0.3808p pd=2.92u as=0.3808p ps=2.92u w=1.12u l=0.13u
X3224 VDD.t495 VDD.t493 VDD.t494 VDD.t379 sg13_lv_pmos ad=0.3808p pd=2.92u as=0 ps=0 w=1.12u l=0.13u
X3225 VDD.t385 a_3171_16074.t9 a_5844_16035# VDD.t34 sg13_lv_pmos ad=0.3808p pd=2.92u as=0.3808p ps=2.92u w=1.12u l=0.13u
X3226 a_1256_15316# CHAN0_MUX_SEL2 VDD.t861 VDD.t34 sg13_lv_pmos ad=0.3808p pd=2.92u as=0.3808p ps=2.92u w=1.12u l=0.13u
X3227 a_26911_2470# a_26673_1842# a_26803_1842# VDD.t379 sg13_lv_pmos ad=0.2128p pd=1.5u as=0.3808p ps=2.92u w=1.12u l=0.2u
X3228 VDD.t1395 a_3747_3892.t5 a_18871_3853# VDD.t0 sg13_lv_pmos ad=0.3808p pd=2.92u as=0.3808p ps=2.92u w=1.12u l=0.13u
X3229 VSS.t1043 a_12363_16869# a_12797_16869# VSS.t1253 sg13_lv_nmos ad=0.1406p pd=1.12u as=0.2516p ps=2.16u w=0.74u l=0.13u
X3230 VSS.t64 a_2019_3892.t2 a_25604_3853# VSS.t1952 sg13_lv_nmos ad=0.2516p pd=2.16u as=0.2516p ps=2.16u w=0.74u l=0.13u
X3231 VSS.t755 a_4187_1764.t76 a_20071_7532# VSS.t754 sg13_lv_nmos ad=0.2516p pd=2.16u as=0.1406p ps=1.12u w=0.74u l=0.6u
X3232 VSS.t834 a_18117_14024# a_18585_13226# VSS.t833 sg13_lv_nmos ad=0.1665p pd=1.19u as=0.2516p ps=2.16u w=0.74u l=0.13u
X3233 VDD.t217 VSS.t331 VDD.t215 VDD.t9 sg13_lv_pmos ad=0.19p pd=1.38u as=0 ps=0 w=1u l=1u
X3234 a_8671_16869# a_8433_16869# a_8563_16869# VSS.t1210 sg13_lv_nmos ad=0.1406p pd=1.12u as=0.2516p ps=2.16u w=0.74u l=0.2u
X3235 a_2595_6737.t0 a_2297_7085# VDD.t777 VDD.t9 sg13_lv_pmos ad=0.2128p pd=1.5u as=0.1918p ps=1.5u w=1.12u l=0.13u
X3236 a_7390_1044# a_2019_1047.t8 a_7288_1044# VSS.t1880 sg13_lv_nmos ad=0.2516p pd=2.16u as=0.1406p ps=1.12u w=0.74u l=0.13u
X3237 VDD.t1062 a_4187_2434# a_24631_8160# VDD.t345 sg13_lv_pmos ad=0.3808p pd=2.92u as=0.2128p ps=1.5u w=1.12u l=0.6u
X3238 VSS.t1412 a_16597_16869# a_17065_16071# VSS.t1411 sg13_lv_nmos ad=0.1665p pd=1.19u as=0.2516p ps=2.16u w=0.74u l=0.13u
X3239 a_14888_16071# a_14317_16869# VSS.t1086 VSS.t1212 sg13_lv_nmos ad=0.1406p pd=1.12u as=0.2516p ps=2.16u w=0.74u l=0.13u
X3240 a_1256_6734# REF_MUX_SEL0 VDD.t1185 VDD.t9 sg13_lv_pmos ad=0.3808p pd=2.92u as=0.3808p ps=2.92u w=1.12u l=0.13u
X3241 a_21353_1842# a_21157_1842# VSS.t1264 VSS.t1263 sg13_lv_nmos ad=0.2516p pd=2.16u as=0.1406p ps=1.12u w=0.74u l=0.13u
X3242 VSS.t2038 a_3171_13229.t2 a_27124_13190# VSS.t2037 sg13_lv_nmos ad=0.2516p pd=2.16u as=0.2516p ps=2.16u w=0.74u l=0.13u
X3243 a_13991_4687# a_13753_4687# a_13883_4687# VSS.t1240 sg13_lv_nmos ad=0.1406p pd=1.12u as=0.2516p ps=2.16u w=0.74u l=0.2u
X3244 VSS.t488 a_4187_1764.t156 a_9431_16869# VSS.t1737 sg13_lv_nmos ad=0.2516p pd=2.16u as=0.1406p ps=1.12u w=0.74u l=0.6u
X3245 a_11848_13226# a_11277_14024# VSS.t1276 VSS.t1275 sg13_lv_nmos ad=0.1406p pd=1.12u as=0.2516p ps=2.16u w=0.74u l=0.13u
X3246 VSS.t248 VDD.t1685 VSS.t250 VSS.t249 sg13_lv_nmos ad=79.8f pd=0.8u as=0 ps=0 w=0.42u l=1u
X3247 VSS.t1215 a_26803_16869# a_27237_16869# VSS.t1257 sg13_lv_nmos ad=0.1406p pd=1.12u as=0.2516p ps=2.16u w=0.74u l=0.13u
X3248 a_12715_3889# a_12505_3889# VDD.t404 VDD.t0 sg13_lv_pmos ad=0.2128p pd=1.5u as=0.252p ps=1.57u w=1.12u l=0.13u
X3249 a_1815_15358# a_1256_15316# a_1721_15358# VSS.t1396 sg13_lv_nmos ad=0.1216p pd=1.02u as=0.2176p ps=1.96u w=0.64u l=0.13u
X3250 a_10328_16071# a_9757_16869# VSS.t490 VSS.t489 sg13_lv_nmos ad=0.1406p pd=1.12u as=0.2516p ps=2.16u w=0.74u l=0.13u
X3251 a_4157_13495# CHAN1_DELAY_IN VDD.t1255 VDD.t2 sg13_lv_pmos ad=0.3808p pd=2.92u as=0.3808p ps=2.92u w=1.12u l=0.13u
X3252 VSS.t1968 a_7043_1842# a_7477_1842# VSS.t1979 sg13_lv_nmos ad=0.1406p pd=1.12u as=0.2516p ps=2.16u w=0.74u l=0.13u
X3253 a_17928_3889# a_17357_4687# VDD.t699 VDD.t0 sg13_lv_pmos ad=0.2128p pd=1.5u as=0.3808p ps=2.92u w=1.12u l=0.13u
X3254 a_21835_3889# a_21625_3889# VSS.t1772 VSS.t1771 sg13_lv_nmos ad=0.1406p pd=1.12u as=0.1665p ps=1.19u w=0.74u l=0.13u
X3255 VDD.t603 a_1544_13226# a_2297_13577# VDD.t2 sg13_lv_pmos ad=0.1918p pd=1.5u as=0.1596p ps=1.22u w=0.84u l=0.13u
X3256 VDD.t1098 a_4187_2434# a_15511_2470# VDD.t379 sg13_lv_pmos ad=0.3808p pd=2.92u as=0.2128p ps=1.5u w=1.12u l=0.6u
X3257 a_19550_3889# a_21044_3853# a_20968_3889# VDD.t0 sg13_lv_pmos ad=0.3808p pd=2.92u as=0.2128p ps=1.5u w=1.12u l=0.13u
X3258 VDD.t591 a_2019_1047.t7 a_10404_1008# VDD.t67 sg13_lv_pmos ad=0.3808p pd=2.92u as=0.3808p ps=2.92u w=1.12u l=0.13u
X3259 VSS.t1426 a_2595_3892.t4 a_20391_3853# VSS.t1425 sg13_lv_nmos ad=0.2516p pd=2.16u as=0.2516p ps=2.16u w=0.74u l=0.13u
X3260 a_21591_14024# a_21353_14024# a_21483_14024# VSS.t1174 sg13_lv_nmos ad=0.1406p pd=1.12u as=0.2516p ps=2.16u w=0.74u l=0.2u
X3261 VSS.t1071 a_4187_1764.t101 a_26911_14024# VSS.t1070 sg13_lv_nmos ad=0.2516p pd=2.16u as=0.1406p ps=1.12u w=0.74u l=0.6u
X3262 a_1721_7085# a_1256_6734# VDD.t349 VDD.t9 sg13_lv_pmos ad=0.1596p pd=1.22u as=0.2856p ps=2.36u w=0.84u l=0.13u
X3263 a_16271_17497# a_16033_16869# a_16163_16869# VDD.t368 sg13_lv_pmos ad=0.2128p pd=1.5u as=0.3808p ps=2.92u w=1.12u l=0.2u
X3264 a_13470_16071# a_3747_16074.t6 a_15755_16071# VSS.t2247 sg13_lv_nmos ad=0.2516p pd=2.16u as=0.1406p ps=1.12u w=0.74u l=0.13u
X3265 VDD.t1127 a_2873_4240# a_3171_3892.t0 VDD.t0 sg13_lv_pmos ad=0.4256p pd=3u as=0.2128p ps=1.5u w=1.12u l=0.13u
X3266 VSS.t344 VDD.t1654 VSS.t344 VSS.t347 sg13_lv_nmos ad=0.1428p pd=1.52u as=0 ps=0 w=0.42u l=1u
X3267 a_13470_6734# a_14964_6698# a_14888_6734# VDD.t9 sg13_lv_pmos ad=0.3808p pd=2.92u as=0.2128p ps=1.5u w=1.12u l=0.13u
X3268 VDD.t1 a_2019_3156.t2 a_17865_3364# VDD.t0 sg13_lv_pmos ad=0.3808p pd=2.92u as=0.3808p ps=2.92u w=1.12u l=0.13u
X3269 a_7288_3889# a_6717_4687# VDD.t512 VDD.t0 sg13_lv_pmos ad=0.2128p pd=1.5u as=0.3808p ps=2.92u w=1.12u l=0.13u
X3270 VDD.t1305 a_1544_16071# a_1721_16422# VDD.t34 sg13_lv_pmos ad=0.1918p pd=1.5u as=0.1596p ps=1.22u w=0.84u l=0.13u
X3271 VSS.t593 a_4187_1764.t107 a_22351_14024# VSS.t592 sg13_lv_nmos ad=0.2516p pd=2.16u as=0.1406p ps=1.12u w=0.74u l=0.6u
X3272 VDD.t877 a_25283_1842# a_25717_1842# VDD.t379 sg13_lv_pmos ad=0.2128p pd=1.5u as=0.3808p ps=2.92u w=1.12u l=0.13u
X3273 VDD.t846 a_27237_16869# a_27705_16071# VDD.t34 sg13_lv_pmos ad=0.252p pd=1.57u as=0.3808p ps=2.92u w=1.12u l=0.13u
X3274 a_13368_13226# a_12797_14024# VDD.t600 VDD.t2 sg13_lv_pmos ad=0.2128p pd=1.5u as=0.3808p ps=2.92u w=1.12u l=0.13u
X3275 VDD.t89 VSS.t276 VDD.t88 VDD.t2 sg13_lv_pmos ad=0.34p pd=2.68u as=0 ps=0 w=1u l=1u
X3276 VSS.t930 a_10517_4687# a_10985_3889# VSS.t929 sg13_lv_nmos ad=0.1665p pd=1.19u as=0.2516p ps=2.16u w=0.74u l=0.13u
X3277 VDD.t972 a_4187_2434# a_17031_17497# VDD.t368 sg13_lv_pmos ad=0.3808p pd=2.92u as=0.2128p ps=1.5u w=1.12u l=0.6u
X3278 VDD.t64 VSS.t226 VDD.t63 VDD.t34 sg13_lv_pmos ad=0.34p pd=2.68u as=0 ps=0 w=1u l=1u
X3279 a_10951_14652# a_10713_14024# a_10843_14024# VDD.t378 sg13_lv_pmos ad=0.2128p pd=1.5u as=0.3808p ps=2.92u w=1.12u l=0.2u
X3280 a_15273_14024# a_15077_14024# VDD.t722 VDD.t378 sg13_lv_pmos ad=0.3808p pd=2.92u as=0.2128p ps=1.5u w=1.12u l=0.13u
X3281 VSS.t812 a_6126_9506# a_5974_11413# VSS.t806 sg13_lv_nmos ad=0.76p pd=4.76u as=0.38p ps=2.38u w=2u l=1u
X3282 a_17553_7532# a_17357_7532# VSS.t552 VSS.t551 sg13_lv_nmos ad=0.2516p pd=2.16u as=0.1406p ps=1.12u w=0.74u l=0.13u
X3283 VDD.t584 a_22677_16869# a_23145_16071# VDD.t34 sg13_lv_pmos ad=0.252p pd=1.57u as=0.3808p ps=2.92u w=1.12u l=0.13u
X3284 a_8671_7532# a_8433_7532# a_8563_7532# VSS.t1620 sg13_lv_nmos ad=0.1406p pd=1.12u as=0.2516p ps=2.16u w=0.74u l=0.2u
X3285 VDD.t1096 a_4187_2434# a_5631_2470# VDD.t379 sg13_lv_pmos ad=0.3808p pd=2.92u as=0.2128p ps=1.5u w=1.12u l=0.6u
X3286 VDD.t768 a_2019_6737.t2 a_25604_6698# VDD.t9 sg13_lv_pmos ad=0.3808p pd=2.92u as=0.3808p ps=2.92u w=1.12u l=0.13u
X3287 a_20968_16071# a_20397_16869# VDD.t1601 VDD.t34 sg13_lv_pmos ad=0.2128p pd=1.5u as=0.3808p ps=2.92u w=1.12u l=0.13u
X3288 a_16510_13226# a_18871_13190# a_18795_13226# VDD.t2 sg13_lv_pmos ad=0.3808p pd=2.92u as=0.2128p ps=1.5u w=1.12u l=0.13u
X3289 a_10232_11561# a_10751_11568# a_11491_11918# VSS.t927 sg13_lv_nmos ad=0.3473p pd=2.71u as=0.12665p ps=1.145u w=0.74u l=0.13u
X3290 a_26395_1044# a_26185_1044# VDD.t423 VDD.t67 sg13_lv_pmos ad=0.2128p pd=1.5u as=0.252p ps=1.57u w=1.12u l=0.13u
X3291 a_24393_16869# a_24197_16869# VSS.t1008 VSS.t2241 sg13_lv_nmos ad=0.2516p pd=2.16u as=0.1406p ps=1.12u w=0.74u l=0.13u
X3292 VSS.t350 VDD.t1652 VSS.t350 VSS.t352 sg13_lv_nmos ad=0.1428p pd=1.52u as=0 ps=0 w=0.42u l=1u
X3293 VSS.t1026 a_12363_4687# a_12797_4687# VSS.t1440 sg13_lv_nmos ad=0.1406p pd=1.12u as=0.2516p ps=2.16u w=0.74u l=0.13u
X3294 a_22590_3889# a_24951_3853# a_24875_3889# VDD.t0 sg13_lv_pmos ad=0.3808p pd=2.92u as=0.2128p ps=1.5u w=1.12u l=0.13u
X3295 VDD.t815 a_1544_3889# a_2297_4240# VDD.t0 sg13_lv_pmos ad=0.1918p pd=1.5u as=0.1596p ps=1.22u w=0.84u l=0.13u
X3296 VSS.t958 a_17683_16869# a_18117_16869# VSS.t957 sg13_lv_nmos ad=0.1406p pd=1.12u as=0.2516p ps=2.16u w=0.74u l=0.13u
X3297 a_1256_13226# CHAN1_MUX_SEL0 VDD.t1550 VDD.t2 sg13_lv_pmos ad=0.3808p pd=2.92u as=0.3808p ps=2.92u w=1.12u l=0.13u
X3298 VDD.t104 VSS.t5 VDD.t102 VDD.t34 sg13_lv_pmos ad=0.19p pd=1.38u as=0 ps=0 w=1u l=1u
X3299 a_13470_13226# a_14311_13190# a_14235_13226# VDD.t2 sg13_lv_pmos ad=0.3808p pd=2.92u as=0.2128p ps=1.5u w=1.12u l=0.13u
X3300 VDD.t598 a_3747_1047.t3 a_24951_1008# VDD.t67 sg13_lv_pmos ad=0.3808p pd=2.92u as=0.3808p ps=2.92u w=1.12u l=0.13u
X3301 a_1256_3134# CHAN2_MUX_SEL2 VDD.t1482 VDD.t0 sg13_lv_pmos ad=0.3808p pd=2.92u as=0.3808p ps=2.92u w=1.12u l=0.13u
X3302 a_2595_6001.t1 a_2297_6021# VSS.t331 VSS.t545 sg13_lv_nmos ad=0.1406p pd=1.12u as=0.1331p ps=1.12u w=0.74u l=0.13u
X3303 VSS.t2157 a_4187_1764.t141 a_20831_16869# VSS.t2197 sg13_lv_nmos ad=0.2516p pd=2.16u as=0.1406p ps=1.12u w=0.74u l=0.6u
X3304 a_2019_3892.t0 a_1721_4240# VDD.t519 VDD.t0 sg13_lv_pmos ad=0.2128p pd=1.5u as=0.1918p ps=1.5u w=1.12u l=0.13u
X3305 VDD.t473 VDD.t471 VDD.t472 VDD.t345 sg13_lv_pmos ad=0.3808p pd=2.92u as=0 ps=0 w=1.12u l=0.13u
X3306 a_6153_14024# a_5957_14024# VSS.t869 VSS.t2130 sg13_lv_nmos ad=0.2516p pd=2.16u as=0.1406p ps=1.12u w=0.74u l=0.13u
X3307 a_26911_8160# a_26673_7532# a_26803_7532# VDD.t345 sg13_lv_pmos ad=0.2128p pd=1.5u as=0.3808p ps=2.92u w=1.12u l=0.2u
X3308 VDD.t1243 a_19203_16869# a_19637_16869# VDD.t368 sg13_lv_pmos ad=0.2128p pd=1.5u as=0.3808p ps=2.92u w=1.12u l=0.13u
X3309 a_21835_6734# a_21625_6734# VDD.t748 VDD.t9 sg13_lv_pmos ad=0.2128p pd=1.5u as=0.252p ps=1.57u w=1.12u l=0.13u
X3310 a_19550_16071# a_21911_16035# a_21835_16071# VDD.t34 sg13_lv_pmos ad=0.3808p pd=2.92u as=0.2128p ps=1.5u w=1.12u l=0.13u
X3311 VDD.t1401 a_3171_13229.t8 a_8884_13190# VDD.t2 sg13_lv_pmos ad=0.3808p pd=2.92u as=0.3808p ps=2.92u w=1.12u l=0.13u
X3312 VDD.t8 VSS.t297 VDD.t7 VDD.t2 sg13_lv_pmos ad=0.34p pd=2.68u as=0 ps=0 w=1u l=1u
X3313 a_7390_6734# a_2019_6737.t8 a_7288_6734# VSS.t1077 sg13_lv_nmos ad=0.2516p pd=2.16u as=0.1406p ps=1.12u w=0.74u l=0.13u
X3314 VDD.t288 VSS.t449 VDD.t172 VDD.t67 sg13_lv_pmos ad=0.19p pd=1.38u as=0 ps=0 w=1u l=1u
X3315 VDD.t329 VSS.t2 VDD.t327 VDD.t0 sg13_lv_pmos ad=0.19p pd=1.38u as=0 ps=0 w=1u l=1u
X3316 a_5731_15316# a_3747_15338.t3 a_13470_16071# VSS.t1705 sg13_lv_nmos ad=0.2516p pd=2.16u as=0.2516p ps=2.16u w=0.74u l=0.13u
X3317 VDD.t947 a_2595_6737.t4 a_20391_6698# VDD.t9 sg13_lv_pmos ad=0.3808p pd=2.92u as=0.3808p ps=2.92u w=1.12u l=0.13u
X3318 VDD.t1436 a_1721_3176# a_2019_3156.t0 VDD.t0 sg13_lv_pmos ad=0.4256p pd=3u as=0.2128p ps=1.5u w=1.12u l=0.13u
X3319 a_21353_7532# a_21157_7532# VSS.t103 VSS.t1011 sg13_lv_nmos ad=0.2516p pd=2.16u as=0.1406p ps=1.12u w=0.74u l=0.13u
X3320 a_24008_1044# a_23437_1842# VDD.t1540 VDD.t67 sg13_lv_pmos ad=0.2128p pd=1.5u as=0.3808p ps=2.92u w=1.12u l=0.13u
X3321 CHAN2_DELAY_OUT_LAST a_27997_4687# VDD.t957 VDD.t347 sg13_lv_pmos ad=0.3808p pd=2.92u as=0.2128p ps=1.5u w=1.12u l=0.13u
X3322 a_13991_1842# a_13753_1842# a_13883_1842# VSS.t839 sg13_lv_nmos ad=0.1406p pd=1.12u as=0.2516p ps=2.16u w=0.74u l=0.2u
X3323 VDD.t1254 a_25717_4687# a_26185_3889# VDD.t0 sg13_lv_pmos ad=0.252p pd=1.57u as=0.3808p ps=2.92u w=1.12u l=0.13u
X3324 a_1815_12513# a_1256_12471# a_1721_12513# VSS.t1236 sg13_lv_nmos ad=0.1216p pd=1.02u as=0.2176p ps=1.96u w=0.64u l=0.13u
X3325 VSS.t1292 a_7043_7532# a_7477_7532# VSS.t2281 sg13_lv_nmos ad=0.1406p pd=1.12u as=0.2516p ps=2.16u w=0.74u l=0.13u
X3326 VDD.t1170 a_10517_7532# a_10985_6734# VDD.t9 sg13_lv_pmos ad=0.252p pd=1.57u as=0.3808p ps=2.92u w=1.12u l=0.13u
X3327 VSS.t673 a_2019_1047.t4 a_19524_1008# VSS.t672 sg13_lv_nmos ad=0.2516p pd=2.16u as=0.2516p ps=2.16u w=0.74u l=0.13u
X3328 VSS.t167 a_3747_3892.t5 a_18871_3853# VSS.t2034 sg13_lv_nmos ad=0.2516p pd=2.16u as=0.2516p ps=2.16u w=0.74u l=0.13u
X3329 a_4633_16869# a_4437_16869# VSS.t786 VSS.t1315 sg13_lv_nmos ad=0.2516p pd=2.16u as=0.1406p ps=1.12u w=0.74u l=0.13u
X3330 VDD.t271 VSS.t422 VDD.t184 VDD.t67 sg13_lv_pmos ad=0.19p pd=1.38u as=0 ps=0 w=1u l=1u
X3331 VDD.t1121 a_13557_16869# a_14025_16071# VDD.t34 sg13_lv_pmos ad=0.252p pd=1.57u as=0.3808p ps=2.92u w=1.12u l=0.13u
X3332 VDD.t121 VSS.t238 VDD.t60 VDD.t2 sg13_lv_pmos ad=0.19p pd=1.38u as=0 ps=0 w=1u l=1u
X3333 VDD.t986 a_4187_2434# a_15511_8160# VDD.t345 sg13_lv_pmos ad=0.3808p pd=2.92u as=0.2128p ps=1.5u w=1.12u l=0.6u
X3334 VDD.t245 VSS.t344 VDD.t244 VDD.t9 sg13_lv_pmos ad=0.34p pd=2.68u as=0 ps=0 w=1u l=1u
X3335 VDD.t377 a_4437_4687# a_4905_3889# VDD.t0 sg13_lv_pmos ad=0.252p pd=1.57u as=0.3808p ps=2.92u w=1.12u l=0.13u
X3336 a_6913_4687# a_6717_4687# VDD.t513 VDD.t347 sg13_lv_pmos ad=0.3808p pd=2.92u as=0.2128p ps=1.5u w=1.12u l=0.13u
X3337 a_16108_12471# a_17865_12701# a_16510_13226# VDD.t2 sg13_lv_pmos ad=0.3808p pd=2.92u as=0.3808p ps=2.92u w=1.12u l=0.13u
X3338 a_15964_12471# a_15765_12645# a_5731_12471# VSS.t940 sg13_lv_nmos ad=0.2183p pd=1.33u as=0.2516p ps=2.16u w=0.74u l=0.13u
X3339 VDD.t1072 a_4187_2434# a_18551_5315# VDD.t347 sg13_lv_pmos ad=0.3808p pd=2.92u as=0.2128p ps=1.5u w=1.12u l=0.6u
X3340 a_16271_14652# a_16033_14024# a_16163_14024# VDD.t378 sg13_lv_pmos ad=0.2128p pd=1.5u as=0.3808p ps=2.92u w=1.12u l=0.2u
X3341 VSS.t2298 a_9444_10280# a_9444_9602# VSS.t2292 sg13_lv_nmos ad=0.68p pd=4.68u as=0.38p ps=2.38u w=2u l=1u
X3342 VSS.t1845 CHAN3_MUX_SEL1 a_3543_1395# VSS.t2148 sg13_lv_nmos ad=0.1331p pd=1.12u as=0.1216p ps=1.02u w=0.64u l=0.13u
X3343 a_4157_4158# CHAN2_DELAY_IN VSS.t27 VSS.t26 sg13_lv_nmos ad=0.2516p pd=2.16u as=0.2553p ps=2.17u w=0.74u l=0.13u
X3344 a_16793_1842# a_16597_1842# VDD.t727 VDD.t379 sg13_lv_pmos ad=0.3808p pd=2.92u as=0.2128p ps=1.5u w=1.12u l=0.13u
X3345 a_2391_15358# CHAN0_MUX_SEL2 a_2297_15358# VSS.t1244 sg13_lv_nmos ad=0.1216p pd=1.02u as=0.2176p ps=1.96u w=0.64u l=0.13u
X3346 a_7911_2470# a_7673_1842# a_7803_1842# VDD.t379 sg13_lv_pmos ad=0.2128p pd=1.5u as=0.3808p ps=2.92u w=1.12u l=0.2u
X3347 VSS.t310 VDD.t1668 VSS.t310 VSS.t311 sg13_lv_nmos ad=79.8f pd=0.8u as=0 ps=0 w=0.42u l=1u
X3348 VSS.t862 a_4187_1764.t153 a_11711_16869# VSS.t861 sg13_lv_nmos ad=0.2516p pd=2.16u as=0.1406p ps=1.12u w=0.74u l=0.6u
X3349 VDD.t907 a_25283_7532# a_25717_7532# VDD.t345 sg13_lv_pmos ad=0.2128p pd=1.5u as=0.3808p ps=2.92u w=1.12u l=0.13u
X3350 a_12715_3889# a_12505_3889# VSS.t143 VSS.t1778 sg13_lv_nmos ad=0.1406p pd=1.12u as=0.1665p ps=1.19u w=0.74u l=0.13u
X3351 a_16793_16869# a_16597_16869# VDD.t580 VDD.t368 sg13_lv_pmos ad=0.3808p pd=2.92u as=0.2128p ps=1.5u w=1.12u l=0.13u
X3352 VDD.t1044 a_4187_2434# a_17031_14652# VDD.t378 sg13_lv_pmos ad=0.3808p pd=2.92u as=0.2128p ps=1.5u w=1.12u l=0.6u
X3353 a_15755_1044# a_15545_1044# VSS.t1345 VSS.t1849 sg13_lv_nmos ad=0.1406p pd=1.12u as=0.1665p ps=1.19u w=0.74u l=0.13u
X3354 a_17928_3889# a_17357_4687# VSS.t925 VSS.t924 sg13_lv_nmos ad=0.1406p pd=1.12u as=0.2516p ps=2.16u w=0.74u l=0.13u
X3355 a_16271_4687# a_16033_4687# a_16163_4687# VSS.t1113 sg13_lv_nmos ad=0.1406p pd=1.12u as=0.2516p ps=2.16u w=0.74u l=0.2u
X3356 a_25391_16869# a_25153_16869# a_25283_16869# VSS.t1213 sg13_lv_nmos ad=0.1406p pd=1.12u as=0.2516p ps=2.16u w=0.74u l=0.2u
X3357 VDD.t382 a_1256_13226# a_2873_13577# VDD.t2 sg13_lv_pmos ad=0.1918p pd=1.5u as=0.1596p ps=1.22u w=0.84u l=0.13u
X3358 a_10430_16071# a_12791_16035# a_12715_16071# VDD.t34 sg13_lv_pmos ad=0.3808p pd=2.92u as=0.2128p ps=1.5u w=1.12u l=0.13u
X3359 VDD.t1208 a_3171_3892.t8 a_8884_3853# VDD.t0 sg13_lv_pmos ad=0.3808p pd=2.92u as=0.3808p ps=2.92u w=1.12u l=0.13u
X3360 a_19550_3889# a_3171_3892.t4 a_20968_3889# VSS.t1656 sg13_lv_nmos ad=0.2516p pd=2.16u as=0.1406p ps=1.12u w=0.74u l=0.13u
X3361 a_12233_16869# a_12037_16869# VDD.t915 VDD.t368 sg13_lv_pmos ad=0.3808p pd=2.92u as=0.2128p ps=1.5u w=1.12u l=0.13u
X3362 VDD.t1052 a_4187_2434# a_5631_8160# VDD.t345 sg13_lv_pmos ad=0.3808p pd=2.92u as=0.2128p ps=1.5u w=1.12u l=0.6u
X3363 VSS.t644 a_2595_1047.t6 a_14311_1008# VSS.t1727 sg13_lv_nmos ad=0.2516p pd=2.16u as=0.2516p ps=2.16u w=0.74u l=0.13u
X3364 a_2595_1047.t0 a_2297_1395# VDD.t389 VDD.t67 sg13_lv_pmos ad=0.2128p pd=1.5u as=0.1918p ps=1.5u w=1.12u l=0.13u
X3365 VSS.t122 VDD.t1695 VSS.t122 VSS.t213 sg13_lv_nmos ad=0.1428p pd=1.52u as=0 ps=0 w=0.42u l=1u
X3366 VSS.t1274 a_10843_14024# a_11277_14024# VSS.t1978 sg13_lv_nmos ad=0.1406p pd=1.12u as=0.2516p ps=2.16u w=0.74u l=0.13u
X3367 VSS.t748 a_4187_1764.t134 a_26151_16869# VSS.t892 sg13_lv_nmos ad=0.2516p pd=2.16u as=0.1406p ps=1.12u w=0.74u l=0.6u
X3368 a_1256_1044# CHAN3_MUX_SEL0 VDD.t1431 VDD.t67 sg13_lv_pmos ad=0.3808p pd=2.92u as=0.3808p ps=2.92u w=1.12u l=0.13u
X3369 a_7151_14024# a_6913_14024# a_7043_14024# VSS.t1959 sg13_lv_nmos ad=0.1406p pd=1.12u as=0.2516p ps=2.16u w=0.74u l=0.2u
X3370 VSS.t1014 a_12363_1842# a_12797_1842# VSS.t1994 sg13_lv_nmos ad=0.1406p pd=1.12u as=0.2516p ps=2.16u w=0.74u l=0.13u
X3371 a_5115_1044# a_4905_1044# VSS.t605 VSS.t604 sg13_lv_nmos ad=0.1406p pd=1.12u as=0.1665p ps=1.19u w=0.74u l=0.13u
X3372 a_7288_3889# a_6717_4687# VSS.t49 VSS.t484 sg13_lv_nmos ad=0.1406p pd=1.12u as=0.2516p ps=2.16u w=0.74u l=0.13u
X3373 VDD.t682 a_2019_16074.t8 a_7364_16035# VDD.t34 sg13_lv_pmos ad=0.3808p pd=2.92u as=0.3808p ps=2.92u w=1.12u l=0.13u
X3374 VSS.t324 VDD.t1662 VSS.t324 VSS.t323 sg13_lv_nmos ad=0.1428p pd=1.52u as=0 ps=0 w=0.42u l=1u
X3375 VDD.t1087 a_4187_2434# a_22351_5315# VDD.t347 sg13_lv_pmos ad=0.3808p pd=2.92u as=0.2128p ps=1.5u w=1.12u l=0.6u
X3376 VSS.t193 VDD.t1702 VSS.t193 VSS.t197 sg13_lv_nmos ad=0.1428p pd=1.52u as=0 ps=0 w=0.42u l=1u
X3377 VDD.t569 a_27563_1842# a_27997_1842# VDD.t379 sg13_lv_pmos ad=0.2128p pd=1.5u as=0.3808p ps=2.92u w=1.12u l=0.13u
X3378 a_5731_5979# a_5705_6209# a_4350_6734# VDD.t9 sg13_lv_pmos ad=0.3808p pd=2.92u as=0.3808p ps=2.92u w=1.12u l=0.13u
X3379 a_20593_1842# a_20397_1842# VDD.t1297 VDD.t379 sg13_lv_pmos ad=0.3808p pd=2.92u as=0.2128p ps=1.5u w=1.12u l=0.13u
X3380 VDD.t1133 a_19203_14024# a_19637_14024# VDD.t378 sg13_lv_pmos ad=0.2128p pd=1.5u as=0.3808p ps=2.92u w=1.12u l=0.13u
X3381 VDD.t943 a_3747_6737.t5 a_18871_6698# VDD.t9 sg13_lv_pmos ad=0.3808p pd=2.92u as=0.3808p ps=2.92u w=1.12u l=0.13u
X3382 a_2967_3176# CHAN2_MUX_SEL3 a_2873_3176# VSS.t1133 sg13_lv_nmos ad=0.1216p pd=1.02u as=0.2176p ps=1.96u w=0.64u l=0.13u
X3383 VSS.t1157 a_18117_16869# a_18585_16071# VSS.t1156 sg13_lv_nmos ad=0.1665p pd=1.19u as=0.2516p ps=2.16u w=0.74u l=0.13u
X3384 a_1721_1395# a_1256_1044# VDD.t703 VDD.t67 sg13_lv_pmos ad=0.1596p pd=1.22u as=0.2856p ps=2.36u w=0.84u l=0.13u
X3385 a_20071_4687# a_19833_4687# a_19963_4687# VSS.t161 sg13_lv_nmos ad=0.1406p pd=1.12u as=0.2516p ps=2.16u w=0.74u l=0.2u
X3386 VSS.t968 a_15077_14024# a_15545_13226# VSS.t967 sg13_lv_nmos ad=0.1665p pd=1.19u as=0.2516p ps=2.16u w=0.74u l=0.13u
X3387 a_13470_1044# a_14964_1008# a_14888_1044# VDD.t67 sg13_lv_pmos ad=0.3808p pd=2.92u as=0.2128p ps=1.5u w=1.12u l=0.13u
X3388 VDD.t1471 a_6283_1842# a_6717_1842# VDD.t379 sg13_lv_pmos ad=0.2128p pd=1.5u as=0.3808p ps=2.92u w=1.12u l=0.13u
X3389 a_22590_3889# a_3747_3892.t3 a_24875_3889# VSS.t62 sg13_lv_nmos ad=0.2516p pd=2.16u as=0.1406p ps=1.12u w=0.74u l=0.13u
X3390 a_27915_3889# a_27705_3889# VDD.t1415 VDD.t0 sg13_lv_pmos ad=0.2128p pd=1.5u as=0.252p ps=1.57u w=1.12u l=0.13u
X3391 VSS.t536 a_14643_4687# a_15077_4687# VSS.t800 sg13_lv_nmos ad=0.1406p pd=1.12u as=0.2516p ps=2.16u w=0.74u l=0.13u
X3392 VSS.t82 a_3171_16074.t2 a_27124_16035# VSS.t81 sg13_lv_nmos ad=0.2516p pd=2.16u as=0.2516p ps=2.16u w=0.74u l=0.13u
X3393 a_13991_7532# a_13753_7532# a_13883_7532# VSS.t2166 sg13_lv_nmos ad=0.1406p pd=1.12u as=0.2516p ps=2.16u w=0.74u l=0.2u
X3394 a_11848_16071# a_11277_16869# VSS.t898 VSS.t1456 sg13_lv_nmos ad=0.1406p pd=1.12u as=0.2516p ps=2.16u w=0.74u l=0.13u
X3395 a_2019_13229.t0 a_1721_13577# VDD.t602 VDD.t2 sg13_lv_pmos ad=0.2128p pd=1.5u as=0.1918p ps=1.5u w=1.12u l=0.13u
X3396 a_12715_6734# a_12505_6734# VDD.t1198 VDD.t9 sg13_lv_pmos ad=0.2128p pd=1.5u as=0.252p ps=1.57u w=1.12u l=0.13u
X3397 VSS.t1719 a_3171_13229.t3 a_24084_13190# VSS.t1718 sg13_lv_nmos ad=0.2516p pd=2.16u as=0.2516p ps=2.16u w=0.74u l=0.13u
X3398 VSS.t150 VDD.t1626 VSS.t431 VSS.t430 sg13_lv_nmos ad=0.1428p pd=1.52u as=0 ps=0 w=0.42u l=1u
X3399 a_4157_16340# CHAN0_DELAY_IN VDD.t1504 VDD.t34 sg13_lv_pmos ad=0.3808p pd=2.92u as=0.3808p ps=2.92u w=1.12u l=0.13u
X3400 VSS.t92 a_2019_6737.t4 a_19524_6698# VSS.t1065 sg13_lv_nmos ad=0.2516p pd=2.16u as=0.2516p ps=2.16u w=0.74u l=0.13u
X3401 a_17928_6734# a_17357_7532# VDD.t540 VDD.t9 sg13_lv_pmos ad=0.2128p pd=1.5u as=0.3808p ps=2.92u w=1.12u l=0.13u
X3402 VSS.t200 VDD.t1700 VSS.t200 VSS.t203 sg13_lv_nmos ad=79.8f pd=0.8u as=0 ps=0 w=0.42u l=1u
X3403 VDD.t1308 a_2019_1047.t2 a_25604_1008# VDD.t67 sg13_lv_pmos ad=0.3808p pd=2.92u as=0.3808p ps=2.92u w=1.12u l=0.13u
X3404 VDD.t174 VSS.t393 VDD.t173 VDD.t0 sg13_lv_pmos ad=0.34p pd=2.68u as=0 ps=0 w=1u l=1u
X3405 a_17791_17497# a_17553_16869# a_17683_16869# VDD.t368 sg13_lv_pmos ad=0.2128p pd=1.5u as=0.3808p ps=2.92u w=1.12u l=0.2u
X3406 a_19550_6734# a_21044_6698# a_20968_6734# VDD.t9 sg13_lv_pmos ad=0.3808p pd=2.92u as=0.2128p ps=1.5u w=1.12u l=0.13u
X3407 VDD.t25 VSS.t310 VDD.t23 VDD.t9 sg13_lv_pmos ad=0.19p pd=1.38u as=0 ps=0 w=1u l=1u
X3408 VSS.t74 a_4187_1764.t105 a_23871_14024# VSS.t740 sg13_lv_nmos ad=0.2516p pd=2.16u as=0.1406p ps=1.12u w=0.74u l=0.6u
X3409 VDD.t1412 a_16597_14024# a_17065_13226# VDD.t2 sg13_lv_pmos ad=0.252p pd=1.57u as=0.3808p ps=2.92u w=1.12u l=0.13u
X3410 VSS.t1127 REF_MUX_SEL1 a_3543_7085# VSS.t1402 sg13_lv_nmos ad=0.1331p pd=1.12u as=0.1216p ps=1.02u w=0.64u l=0.13u
X3411 a_14888_13226# a_14317_14024# VDD.t1610 VDD.t2 sg13_lv_pmos ad=0.2128p pd=1.5u as=0.3808p ps=2.92u w=1.12u l=0.13u
X3412 a_16793_7532# a_16597_7532# VDD.t346 VDD.t345 sg13_lv_pmos ad=0.3808p pd=2.92u as=0.2128p ps=1.5u w=1.12u l=0.13u
X3413 VDD.t1024 a_4187_2434# a_18551_17497# VDD.t368 sg13_lv_pmos ad=0.3808p pd=2.92u as=0.2128p ps=1.5u w=1.12u l=0.6u
X3414 a_7911_8160# a_7673_7532# a_7803_7532# VDD.t345 sg13_lv_pmos ad=0.2128p pd=1.5u as=0.3808p ps=2.92u w=1.12u l=0.2u
X3415 a_7288_6734# a_6717_7532# VDD.t734 VDD.t9 sg13_lv_pmos ad=0.2128p pd=1.5u as=0.3808p ps=2.92u w=1.12u l=0.13u
X3416 VSS.t1793 a_25717_4687# a_26185_3889# VSS.t2183 sg13_lv_nmos ad=0.1665p pd=1.19u as=0.2516p ps=2.16u w=0.74u l=0.13u
X3417 a_2391_12513# CHAN1_MUX_SEL2 a_2297_12513# VSS.t170 sg13_lv_nmos ad=0.1216p pd=1.02u as=0.2176p ps=1.96u w=0.64u l=0.13u
X3418 a_9712_9602# a_6854_11144# a_9444_9602# VSS.t1204 sg13_lv_nmos ad=0.38p pd=2.38u as=0.68p ps=4.68u w=2u l=1u
X3419 VSS.t2231 a_4187_1764.t47 a_17791_4687# VSS.t2271 sg13_lv_nmos ad=0.2516p pd=2.16u as=0.1406p ps=1.12u w=0.74u l=0.6u
X3420 a_19833_4687# a_19637_4687# VDD.t735 VDD.t347 sg13_lv_pmos ad=0.3808p pd=2.92u as=0.2128p ps=1.5u w=1.12u l=0.13u
X3421 a_16793_14024# a_16597_14024# VDD.t873 VDD.t378 sg13_lv_pmos ad=0.3808p pd=2.92u as=0.2128p ps=1.5u w=1.12u l=0.13u
X3422 VSS.t292 a_3171_12493.t2 a_23945_12701# VSS.t2275 sg13_lv_nmos ad=0.2516p pd=2.16u as=0.2516p ps=2.16u w=0.74u l=0.13u
X3423 a_15755_6734# a_15545_6734# VSS.t998 VSS.t1818 sg13_lv_nmos ad=0.1406p pd=1.12u as=0.1665p ps=1.19u w=0.74u l=0.13u
X3424 a_16271_1842# a_16033_1842# a_16163_1842# VSS.t1354 sg13_lv_nmos ad=0.1406p pd=1.12u as=0.2516p ps=2.16u w=0.74u l=0.2u
X3425 VSS.t792 a_3747_13229.t5 a_18871_13190# VSS.t1704 sg13_lv_nmos ad=0.2516p pd=2.16u as=0.2516p ps=2.16u w=0.74u l=0.13u
X3426 a_10328_13226# a_9757_14024# VDD.t1359 VDD.t2 sg13_lv_pmos ad=0.2128p pd=1.5u as=0.3808p ps=2.92u w=1.12u l=0.13u
X3427 a_21835_1044# a_21625_1044# VDD.t808 VDD.t67 sg13_lv_pmos ad=0.2128p pd=1.5u as=0.252p ps=1.57u w=1.12u l=0.13u
X3428 VDD.t1379 a_24197_16869# a_24665_16071# VDD.t34 sg13_lv_pmos ad=0.252p pd=1.57u as=0.3808p ps=2.92u w=1.12u l=0.13u
X3429 a_12233_14024# a_12037_14024# VDD.t1155 VDD.t378 sg13_lv_pmos ad=0.3808p pd=2.92u as=0.2128p ps=1.5u w=1.12u l=0.13u
X3430 VSS.t158 a_2595_6737.t6 a_14311_6698# VSS.t1320 sg13_lv_nmos ad=0.2516p pd=2.16u as=0.2516p ps=2.16u w=0.74u l=0.13u
X3431 VSS.t69 a_4437_4687# a_4905_3889# VSS.t1861 sg13_lv_nmos ad=0.1665p pd=1.19u as=0.2516p ps=2.16u w=0.74u l=0.13u
X3432 a_25913_16869# a_25717_16869# VSS.t1529 VSS.t2331 sg13_lv_nmos ad=0.2516p pd=2.16u as=0.1406p ps=1.12u w=0.74u l=0.13u
X3433 VDD.t1226 a_2595_1047.t4 a_20391_1008# VDD.t67 sg13_lv_pmos ad=0.3808p pd=2.92u as=0.3808p ps=2.92u w=1.12u l=0.13u
X3434 VDD.t208 VSS.t400 VDD.t260 VDD.t67 sg13_lv_pmos ad=0.34p pd=2.68u as=0 ps=0 w=1u l=1u
X3435 a_24631_5315# a_24393_4687# a_24523_4687# VDD.t347 sg13_lv_pmos ad=0.2128p pd=1.5u as=0.3808p ps=2.92u w=1.12u l=0.2u
X3436 a_13121_11521# a_15688_11557# VSS.t561 VSS.t560 sg13_lv_nmos ad=0.2516p pd=2.16u as=0.1406p ps=1.12u w=0.74u l=0.13u
X3437 a_9193_4687# a_8997_4687# VDD.t410 VDD.t347 sg13_lv_pmos ad=0.3808p pd=2.92u as=0.2128p ps=1.5u w=1.12u l=0.13u
X3438 VDD.t136 VSS.t324 VDD.t135 VDD.t9 sg13_lv_pmos ad=0.34p pd=2.68u as=0 ps=0 w=1u l=1u
X3439 a_13470_13226# a_15831_13190# a_15755_13226# VDD.t2 sg13_lv_pmos ad=0.3808p pd=2.92u as=0.2128p ps=1.5u w=1.12u l=0.13u
X3440 VSS.t254 VDD.t1683 VSS.t257 VSS.t256 sg13_lv_nmos ad=79.8f pd=0.8u as=0 ps=0 w=0.42u l=1u
X3441 a_5778_9057# a_6126_9506# a_6326_10280# VSS.t803 sg13_lv_nmos ad=0.68p pd=4.68u as=0.38p ps=2.38u w=2u l=1u
X3442 VSS.t1041 a_12363_7532# a_12797_7532# VSS.t1130 sg13_lv_nmos ad=0.1406p pd=1.12u as=0.2516p ps=2.16u w=0.74u l=0.13u
X3443 VSS.t1552 VSS.t1550 VSS.t1550 VSS.t1551 sg13_lv_nmos ad=0.2516p pd=2.16u as=0 ps=0 w=0.74u l=0.13u
X3444 a_5115_6734# a_4905_6734# VSS.t932 VSS.t931 sg13_lv_nmos ad=0.1406p pd=1.12u as=0.1665p ps=1.19u w=0.74u l=0.13u
X3445 a_22590_6734# a_24951_6698# a_24875_6734# VDD.t9 sg13_lv_pmos ad=0.3808p pd=2.92u as=0.2128p ps=1.5u w=1.12u l=0.13u
X3446 a_21353_16869# a_21157_16869# VSS.t2157 VSS.t2156 sg13_lv_nmos ad=0.2516p pd=2.16u as=0.1406p ps=1.12u w=0.74u l=0.13u
X3447 VSS.t207 VDD.t1698 VSS.t207 VSS.t208 sg13_lv_nmos ad=79.8f pd=0.8u as=0 ps=0 w=0.42u l=1u
X3448 VSS.t1716 a_3171_13229.t6 a_14964_13190# VSS.t1715 sg13_lv_nmos ad=0.2516p pd=2.16u as=0.2516p ps=2.16u w=0.74u l=0.13u
X3449 a_5731_5979# a_3747_6001.t3 a_13470_6734# VSS.t1371 sg13_lv_nmos ad=0.2516p pd=2.16u as=0.2516p ps=2.16u w=0.74u l=0.13u
X3450 a_7673_14024# a_7477_14024# VSS.t115 VSS.t1958 sg13_lv_nmos ad=0.2516p pd=2.16u as=0.1406p ps=1.12u w=0.74u l=0.13u
X3451 a_9444_9602# a_9444_10280# VSS.t2290 VSS.t2289 sg13_lv_nmos ad=0.38p pd=2.38u as=0.68p ps=4.68u w=2u l=1u
X3452 VSS.t1687 a_4187_1764.t98 VSS.t1685 VSS.t1670 sg13_lv_nmos ad=1.33p pd=7.38u as=0 ps=0 w=7u l=7u
X3453 VSS.t1147 a_21157_1842# a_21625_1044# VSS.t1262 sg13_lv_nmos ad=0.1665p pd=1.19u as=0.2516p ps=2.16u w=0.74u l=0.13u
X3454 VDD.t1259 a_10517_1842# a_10985_1044# VDD.t67 sg13_lv_pmos ad=0.252p pd=1.57u as=0.3808p ps=2.92u w=1.12u l=0.13u
X3455 a_19073_1842# a_18877_1842# VDD.t874 VDD.t379 sg13_lv_pmos ad=0.3808p pd=2.92u as=0.2128p ps=1.5u w=1.12u l=0.13u
X3456 VSS.t1332 a_14643_16869# a_15077_16869# VSS.t1331 sg13_lv_nmos ad=0.1406p pd=1.12u as=0.2516p ps=2.16u w=0.74u l=0.13u
X3457 VDD.t788 a_27563_7532# a_27997_7532# VDD.t345 sg13_lv_pmos ad=0.2128p pd=1.5u as=0.3808p ps=2.92u w=1.12u l=0.13u
X3458 VSS.t244 a_2595_12493.t3 a_8745_12701# VSS.t877 sg13_lv_nmos ad=0.2516p pd=2.16u as=0.2516p ps=2.16u w=0.74u l=0.13u
X3459 a_5731_3134# a_5705_3364# a_4350_3889# VDD.t0 sg13_lv_pmos ad=0.3808p pd=2.92u as=0.3808p ps=2.92u w=1.12u l=0.13u
X3460 a_20593_7532# a_20397_7532# VDD.t1178 VDD.t345 sg13_lv_pmos ad=0.3808p pd=2.92u as=0.2128p ps=1.5u w=1.12u l=0.13u
X3461 VSS.t1018 a_3171_3892.t8 a_8884_3853# VSS.t1645 sg13_lv_nmos ad=0.2516p pd=2.16u as=0.2516p ps=2.16u w=0.74u l=0.13u
X3462 VSS.t1092 a_4187_1764.t42 a_21591_4687# VSS.t1663 sg13_lv_nmos ad=0.2516p pd=2.16u as=0.1406p ps=1.12u w=0.74u l=0.6u
X3463 a_23633_4687# a_23437_4687# VDD.t405 VDD.t347 sg13_lv_pmos ad=0.3808p pd=2.92u as=0.2128p ps=1.5u w=1.12u l=0.13u
X3464 a_20071_1842# a_19833_1842# a_19963_1842# VSS.t597 sg13_lv_nmos ad=0.1406p pd=1.12u as=0.2516p ps=2.16u w=0.74u l=0.2u
X3465 a_1815_331# a_1256_289# a_1721_331# VSS.t2320 sg13_lv_nmos ad=0.1216p pd=1.02u as=0.2176p ps=1.96u w=0.64u l=0.13u
X3466 VDD.t505 a_3747_16074.t2 a_27991_16035# VDD.t34 sg13_lv_pmos ad=0.3808p pd=2.92u as=0.3808p ps=2.92u w=1.12u l=0.13u
X3467 VDD.t573 a_6283_7532# a_6717_7532# VDD.t345 sg13_lv_pmos ad=0.2128p pd=1.5u as=0.3808p ps=2.92u w=1.12u l=0.13u
X3468 VDD.t533 a_9323_4687# a_9757_4687# VDD.t347 sg13_lv_pmos ad=0.2128p pd=1.5u as=0.3808p ps=2.92u w=1.12u l=0.13u
X3469 VSS.t72 a_14643_1842# a_15077_1842# VSS.t71 sg13_lv_nmos ad=0.1406p pd=1.12u as=0.2516p ps=2.16u w=0.74u l=0.13u
X3470 VSS.t1558 VSS.t1555 VSS.t1557 VSS.t1556 sg13_lv_nmos ad=0.2516p pd=2.16u as=0 ps=0 w=0.74u l=0.6u
X3471 VDD.t715 a_25717_7532# a_26185_6734# VDD.t9 sg13_lv_pmos ad=0.252p pd=1.57u as=0.3808p ps=2.92u w=1.12u l=0.13u
X3472 VSS.t866 a_4187_1764.t123 a_10191_14024# VSS.t865 sg13_lv_nmos ad=0.2516p pd=2.16u as=0.1406p ps=1.12u w=0.74u l=0.6u
X3473 VDD.t525 a_19203_1842# a_19637_1842# VDD.t379 sg13_lv_pmos ad=0.2128p pd=1.5u as=0.3808p ps=2.92u w=1.12u l=0.13u
X3474 a_16108_289# a_20905_519# a_19550_1044# VDD.t67 sg13_lv_pmos ad=0.3808p pd=2.92u as=0.3808p ps=2.92u w=1.12u l=0.13u
X3475 VSS.t2123 a_16851_3154# CHAN2_MUX_OUT VSS.t2124 sg13_lv_nmos ad=0.2516p pd=2.16u as=0.1406p ps=1.12u w=0.74u l=0.13u
X3476 VSS.t667 a_2019_1047.t9 a_4324_1008# VSS.t666 sg13_lv_nmos ad=0.2516p pd=2.16u as=0.2516p ps=2.16u w=0.74u l=0.13u
X3477 VDD.t811 a_10517_16869# a_10985_16071# VDD.t34 sg13_lv_pmos ad=0.252p pd=1.57u as=0.3808p ps=2.92u w=1.12u l=0.13u
X3478 VSS.t2081 a_1544_15316# a_1815_15358# VSS.t700 sg13_lv_nmos ad=0.1331p pd=1.12u as=0.1216p ps=1.02u w=0.64u l=0.13u
X3479 a_17791_14652# a_17553_14024# a_17683_14024# VDD.t378 sg13_lv_pmos ad=0.2128p pd=1.5u as=0.3808p ps=2.92u w=1.12u l=0.2u
X3480 VDD.t702 a_4437_7532# a_4905_6734# VDD.t9 sg13_lv_pmos ad=0.252p pd=1.57u as=0.3808p ps=2.92u w=1.12u l=0.13u
X3481 a_16510_1044# a_3747_1047.t5 a_18795_1044# VSS.t1246 sg13_lv_nmos ad=0.2516p pd=2.16u as=0.1406p ps=1.12u w=0.74u l=0.13u
X3482 VDD.t222 VSS.t357 VDD.t220 VDD.t0 sg13_lv_pmos ad=0.19p pd=1.38u as=0 ps=0 w=1u l=1u
X3483 a_16108_15316# a_17865_15546# a_16510_16071# VDD.t34 sg13_lv_pmos ad=0.3808p pd=2.92u as=0.3808p ps=2.92u w=1.12u l=0.13u
X3484 VSS.t1604 VSS.t1606 VSS.t1608 VSS.t1607 sg13_lv_nmos ad=0.1406p pd=1.12u as=0 ps=0 w=0.74u l=0.2u
X3485 a_27915_3889# a_27705_3889# VSS.t2073 VSS.t2072 sg13_lv_nmos ad=0.1406p pd=1.12u as=0.1665p ps=1.19u w=0.74u l=0.13u
X3486 VSS.t1509 CHAN2_MUX_SEL1 a_3543_4240# VSS.t1508 sg13_lv_nmos ad=0.1331p pd=1.12u as=0.1216p ps=1.02u w=0.64u l=0.13u
X3487 a_5731_12471# a_14825_12701# a_13470_13226# VDD.t2 sg13_lv_pmos ad=0.3808p pd=2.92u as=0.3808p ps=2.92u w=1.12u l=0.13u
X3488 VDD.t1009 a_4187_2434# a_18551_14652# VDD.t378 sg13_lv_pmos ad=0.3808p pd=2.92u as=0.2128p ps=1.5u w=1.12u l=0.6u
X3489 VDD.t880 a_8563_1842# a_8997_1842# VDD.t379 sg13_lv_pmos ad=0.2128p pd=1.5u as=0.3808p ps=2.92u w=1.12u l=0.13u
X3490 a_26911_16869# a_26673_16869# a_26803_16869# VSS.t2244 sg13_lv_nmos ad=0.1406p pd=1.12u as=0.2516p ps=2.16u w=0.74u l=0.2u
X3491 VDD.t1391 a_3449_16422# a_3747_16074.t0 VDD.t34 sg13_lv_pmos ad=0.4256p pd=3u as=0.2128p ps=1.5u w=1.12u l=0.13u
X3492 VSS.t587 a_4187_1764.t15 a_17791_1842# VSS.t596 sg13_lv_nmos ad=0.2516p pd=2.16u as=0.1406p ps=1.12u w=0.74u l=0.6u
X3493 a_16271_7532# a_16033_7532# a_16163_7532# VSS.t181 sg13_lv_nmos ad=0.1406p pd=1.12u as=0.2516p ps=2.16u w=0.74u l=0.2u
X3494 VSS.t408 VDD.t1632 VSS.t407 VSS.t406 sg13_lv_nmos ad=0.1428p pd=1.52u as=0 ps=0 w=0.42u l=1u
X3495 VDD.t1099 a_4187_2434# a_13231_2470# VDD.t379 sg13_lv_pmos ad=0.3808p pd=2.92u as=0.2128p ps=1.5u w=1.12u l=0.6u
X3496 a_13753_16869# a_13557_16869# VDD.t1119 VDD.t368 sg13_lv_pmos ad=0.3808p pd=2.92u as=0.2128p ps=1.5u w=1.12u l=0.13u
X3497 VDD.t864 a_3747_1047.t5 a_18871_1008# VDD.t67 sg13_lv_pmos ad=0.3808p pd=2.92u as=0.3808p ps=2.92u w=1.12u l=0.13u
X3498 VSS.t696 a_12363_14024# a_12797_14024# VSS.t1933 sg13_lv_nmos ad=0.1406p pd=1.12u as=0.2516p ps=2.16u w=0.74u l=0.13u
X3499 VSS.t2278 a_4187_1764.t132 a_27671_16869# VSS.t2277 sg13_lv_nmos ad=0.2516p pd=2.16u as=0.1406p ps=1.12u w=0.74u l=0.6u
X3500 a_14009_10774# REF_DELAY_OUT_LAST VSS.t529 VSS.t1242 sg13_lv_nmos ad=0.2516p pd=2.16u as=1.45407p ps=9.445u w=0.74u l=0.13u
X3501 VDD.t1322 a_3171_6737.t8 a_8884_6698# VDD.t9 sg13_lv_pmos ad=0.3808p pd=2.92u as=0.3808p ps=2.92u w=1.12u l=0.13u
X3502 a_22351_16869# a_22113_16869# a_22243_16869# VSS.t2216 sg13_lv_nmos ad=0.1406p pd=1.12u as=0.2516p ps=2.16u w=0.74u l=0.2u
X3503 a_8671_14024# a_8433_14024# a_8563_14024# VSS.t1975 sg13_lv_nmos ad=0.1406p pd=1.12u as=0.2516p ps=2.16u w=0.74u l=0.2u
X3504 VSS.t1677 a_4187_1764.t98 VSS.t1679 VSS.t1678 sg13_lv_nmos ad=1.33p pd=7.38u as=0 ps=0 w=7u l=7u
X3505 VDD.t71 VSS.t260 VDD.t70 VDD.t2 sg13_lv_pmos ad=0.34p pd=2.68u as=0 ps=0 w=1u l=1u
X3506 VDD.t1336 a_23003_1842# a_23437_1842# VDD.t379 sg13_lv_pmos ad=0.2128p pd=1.5u as=0.3808p ps=2.92u w=1.12u l=0.13u
X3507 VDD.t191 VSS.t371 VDD.t190 VDD.t0 sg13_lv_pmos ad=0.34p pd=2.68u as=0 ps=0 w=1u l=1u
X3508 a_7390_3889# a_8231_3853# a_8155_3889# VDD.t0 sg13_lv_pmos ad=0.3808p pd=2.92u as=0.2128p ps=1.5u w=1.12u l=0.13u
X3509 VDD.t127 VSS.t207 VDD.t126 VDD.t34 sg13_lv_pmos ad=0.34p pd=2.68u as=0 ps=0 w=1u l=1u
X3510 VSS.t762 a_4187_1764.t124 a_9431_14024# VSS.t761 sg13_lv_nmos ad=0.2516p pd=2.16u as=0.1406p ps=1.12u w=0.74u l=0.6u
X3511 VDD.t460 VDD.t452 VDD.t459 VDD.t358 sg13_lv_pmos ad=0.38p pd=2.38u as=0 ps=0 w=2u l=1u
X3512 VSS.t1071 a_26803_14024# a_27237_14024# VSS.t1482 sg13_lv_nmos ad=0.1406p pd=1.12u as=0.2516p ps=2.16u w=0.74u l=0.13u
X3513 VSS.t701 a_1721_13577# a_2019_13229.t1 VSS.t1938 sg13_lv_nmos ad=0.2812p pd=2.24u as=0.1406p ps=1.12u w=0.74u l=0.13u
X3514 a_19073_7532# a_18877_7532# VDD.t387 VDD.t345 sg13_lv_pmos ad=0.3808p pd=2.92u as=0.2128p ps=1.5u w=1.12u l=0.13u
X3515 a_12715_1044# a_12505_1044# VDD.t650 VDD.t67 sg13_lv_pmos ad=0.2128p pd=1.5u as=0.252p ps=1.57u w=1.12u l=0.13u
X3516 VSS.t1010 a_21157_7532# a_21625_6734# VSS.t1009 sg13_lv_nmos ad=0.1665p pd=1.19u as=0.2516p ps=2.16u w=0.74u l=0.13u
X3517 VDD.t1613 a_2019_16074.t9 a_4324_16035# VDD.t34 sg13_lv_pmos ad=0.3808p pd=2.92u as=0.3808p ps=2.92u w=1.12u l=0.13u
X3518 a_17928_1044# a_17357_1842# VDD.t724 VDD.t67 sg13_lv_pmos ad=0.2128p pd=1.5u as=0.3808p ps=2.92u w=1.12u l=0.13u
X3519 a_13045_11905# a_13019_11521# a_12849_11557# VSS.t942 sg13_lv_nmos ad=0.1406p pd=1.12u as=0.1406p ps=1.12u w=0.74u l=0.13u
X3520 a_19550_1044# a_21044_1008# a_20968_1044# VDD.t67 sg13_lv_pmos ad=0.3808p pd=2.92u as=0.2128p ps=1.5u w=1.12u l=0.13u
X3521 a_2967_6021# REF_MUX_SEL3 a_2873_6021# VSS.t35 sg13_lv_nmos ad=0.1216p pd=1.02u as=0.2176p ps=1.96u w=0.64u l=0.13u
X3522 VSS.t18 a_1544_289# a_1815_331# VSS.t764 sg13_lv_nmos ad=0.1331p pd=1.12u as=0.1216p ps=1.02u w=0.64u l=0.13u
X3523 VSS.t517 a_4187_1764.t10 a_21591_1842# VSS.t784 sg13_lv_nmos ad=0.2516p pd=2.16u as=0.1406p ps=1.12u w=0.74u l=0.6u
X3524 a_20071_7532# a_19833_7532# a_19963_7532# VSS.t1794 sg13_lv_nmos ad=0.1406p pd=1.12u as=0.2516p ps=2.16u w=0.74u l=0.2u
X3525 VSS.t1415 a_15077_16869# a_15545_16071# VSS.t1414 sg13_lv_nmos ad=0.1665p pd=1.19u as=0.2516p ps=2.16u w=0.74u l=0.13u
X3526 a_13592_11113# a_13566_11018# VSS.t1187 VSS.t1197 sg13_lv_nmos ad=0.2516p pd=2.16u as=0.1626p ps=1.415u w=0.74u l=0.13u
X3527 a_7288_1044# a_6717_1842# VDD.t1477 VDD.t67 sg13_lv_pmos ad=0.2128p pd=1.5u as=0.3808p ps=2.92u w=1.12u l=0.13u
X3528 a_22873_4687# a_22677_4687# VSS.t937 VSS.t936 sg13_lv_nmos ad=0.2516p pd=2.16u as=0.1406p ps=1.12u w=0.74u l=0.13u
X3529 VSS.t1742 a_2019_13229.t2 a_25604_13190# VSS.t1741 sg13_lv_nmos ad=0.2516p pd=2.16u as=0.2516p ps=2.16u w=0.74u l=0.13u
X3530 a_13400_11995# a_12355_11557# a_13306_11995# VSS.t42 sg13_lv_nmos ad=60.89999f pd=0.71u as=0.1428p ps=1.52u w=0.42u l=0.13u
X3531 VSS.t1566 VSS.t1564 VSS.t1564 VSS.t1565 sg13_lv_nmos ad=0.68p pd=4.68u as=0 ps=0 w=2u l=1u
X3532 VSS.t1000 a_14643_7532# a_15077_7532# VSS.t2317 sg13_lv_nmos ad=0.1406p pd=1.12u as=0.2516p ps=2.16u w=0.74u l=0.13u
X3533 a_27915_6734# a_27705_6734# VDD.t367 VDD.t9 sg13_lv_pmos ad=0.2128p pd=1.5u as=0.252p ps=1.57u w=1.12u l=0.13u
X3534 VSS.t895 a_3171_16074.t3 a_24084_16035# VSS.t2211 sg13_lv_nmos ad=0.2516p pd=2.16u as=0.2516p ps=2.16u w=0.74u l=0.13u
X3535 VDD.t780 a_19203_7532# a_19637_7532# VDD.t345 sg13_lv_pmos ad=0.2128p pd=1.5u as=0.3808p ps=2.92u w=1.12u l=0.13u
X3536 VDD.t404 a_12037_4687# a_12505_3889# VDD.t0 sg13_lv_pmos ad=0.252p pd=1.57u as=0.3808p ps=2.92u w=1.12u l=0.13u
X3537 a_14513_4687# a_14317_4687# VDD.t614 VDD.t347 sg13_lv_pmos ad=0.3808p pd=2.92u as=0.2128p ps=1.5u w=1.12u l=0.13u
X3538 a_13231_16869# a_12993_16869# a_13123_16869# VSS.t2239 sg13_lv_nmos ad=0.1406p pd=1.12u as=0.2516p ps=2.16u w=0.74u l=0.2u
X3539 VDD.t72 VSS.t268 VDD.t80 VDD.t2 sg13_lv_pmos ad=0.34p pd=2.68u as=0 ps=0 w=1u l=1u
X3540 a_5631_5315# a_5393_4687# a_5523_4687# VDD.t347 sg13_lv_pmos ad=0.2128p pd=1.5u as=0.3808p ps=2.92u w=1.12u l=0.2u
X3541 VDD.t66 VSS.t226 VDD.t64 VDD.t34 sg13_lv_pmos ad=0.19p pd=1.38u as=0 ps=0 w=1u l=1u
X3542 VSS.t709 a_2019_6737.t9 a_4324_6698# VSS.t1061 sg13_lv_nmos ad=0.2516p pd=2.16u as=0.2516p ps=2.16u w=0.74u l=0.13u
X3543 VDD.t656 a_18117_14024# a_18585_13226# VDD.t2 sg13_lv_pmos ad=0.252p pd=1.57u as=0.3808p ps=2.92u w=1.12u l=0.13u
X3544 VSS.t771 a_1544_12471# a_1815_12513# VSS.t1136 sg13_lv_nmos ad=0.1331p pd=1.12u as=0.1216p ps=1.02u w=0.64u l=0.13u
X3545 a_16510_6734# a_3747_6737.t5 a_18795_6734# VSS.t1378 sg13_lv_nmos ad=0.2516p pd=2.16u as=0.1406p ps=1.12u w=0.74u l=0.13u
X3546 VSS.t612 a_4187_1764.t150 a_13991_16869# VSS.t818 sg13_lv_nmos ad=0.2516p pd=2.16u as=0.1406p ps=1.12u w=0.74u l=0.6u
X3547 a_24393_14024# a_24197_14024# VSS.t74 VSS.t581 sg13_lv_nmos ad=0.2516p pd=2.16u as=0.1406p ps=1.12u w=0.74u l=0.13u
X3548 a_15511_2470# a_15273_1842# a_15403_1842# VDD.t379 sg13_lv_pmos ad=0.2128p pd=1.5u as=0.3808p ps=2.92u w=1.12u l=0.2u
X3549 a_14751_17497# a_14513_16869# a_14643_16869# VDD.t368 sg13_lv_pmos ad=0.2128p pd=1.5u as=0.3808p ps=2.92u w=1.12u l=0.2u
X3550 a_19073_16869# a_18877_16869# VDD.t1244 VDD.t368 sg13_lv_pmos ad=0.3808p pd=2.92u as=0.2128p ps=1.5u w=1.12u l=0.13u
X3551 a_22590_1044# a_24951_1008# a_24875_1044# VDD.t67 sg13_lv_pmos ad=0.3808p pd=2.92u as=0.2128p ps=1.5u w=1.12u l=0.13u
X3552 VSS.t1617 VSS.t1618 VSS.t1617 VSS.t1619 sg13_lv_nmos ad=0.1406p pd=1.12u as=0 ps=0 w=0.74u l=0.2u
X3553 VSS.t832 a_17683_14024# a_18117_14024# VSS.t1347 sg13_lv_nmos ad=0.1406p pd=1.12u as=0.2516p ps=2.16u w=0.74u l=0.13u
X3554 VDD.t1288 a_8563_7532# a_8997_7532# VDD.t345 sg13_lv_pmos ad=0.2128p pd=1.5u as=0.3808p ps=2.92u w=1.12u l=0.13u
X3555 VSS.t578 a_4187_1764.t109 a_20831_14024# VSS.t1852 sg13_lv_nmos ad=0.2516p pd=2.16u as=0.1406p ps=1.12u w=0.74u l=0.6u
X3556 a_11848_13226# a_11277_14024# VDD.t883 VDD.t2 sg13_lv_pmos ad=0.2128p pd=1.5u as=0.3808p ps=2.92u w=1.12u l=0.13u
X3557 VDD.t1396 a_3171_13229.t2 a_27124_13190# VDD.t2 sg13_lv_pmos ad=0.3808p pd=2.92u as=0.3808p ps=2.92u w=1.12u l=0.13u
X3558 a_6126_9506# a_6126_9506# VSS.t804 VSS.t803 sg13_lv_nmos ad=0.38p pd=2.38u as=0.68p ps=4.68u w=2u l=1u
X3559 VSS.t705 a_4187_1764.t79 a_17791_7532# VSS.t867 sg13_lv_nmos ad=0.2516p pd=2.16u as=0.1406p ps=1.12u w=0.74u l=0.6u
X3560 VSS.t462 VDD.t1618 VSS.t462 VSS.t464 sg13_lv_nmos ad=79.8f pd=0.8u as=0 ps=0 w=0.42u l=1u
X3561 VDD.t1056 a_4187_2434# a_13231_8160# VDD.t345 sg13_lv_pmos ad=0.3808p pd=2.92u as=0.2128p ps=1.5u w=1.12u l=0.6u
X3562 VSS.t1021 a_3747_16074.t5 a_18871_16035# VSS.t1898 sg13_lv_nmos ad=0.2516p pd=2.16u as=0.2516p ps=2.16u w=0.74u l=0.13u
X3563 VSS.t280 a_2595_12493.t2 a_20905_12701# VSS.t879 sg13_lv_nmos ad=0.2516p pd=2.16u as=0.2516p ps=2.16u w=0.74u l=0.13u
X3564 a_4633_4687# a_4437_4687# VDD.t386 VDD.t347 sg13_lv_pmos ad=0.3808p pd=2.92u as=0.2128p ps=1.5u w=1.12u l=0.13u
X3565 a_13753_14024# a_13557_14024# VDD.t891 VDD.t378 sg13_lv_pmos ad=0.3808p pd=2.92u as=0.2128p ps=1.5u w=1.12u l=0.13u
X3566 VSS.t122 a_3747_15338.t2 a_26985_15546# VSS.t121 sg13_lv_nmos ad=0.2516p pd=2.16u as=0.2516p ps=2.16u w=0.74u l=0.13u
X3567 VDD.t908 a_23003_7532# a_23437_7532# VDD.t345 sg13_lv_pmos ad=0.2128p pd=1.5u as=0.3808p ps=2.92u w=1.12u l=0.13u
X3568 a_22873_16869# a_22677_16869# VSS.t659 VSS.t658 sg13_lv_nmos ad=0.2516p pd=2.16u as=0.1406p ps=1.12u w=0.74u l=0.13u
X3569 VDD.t302 VSS.t299 VDD.t8 VDD.t2 sg13_lv_pmos ad=0.19p pd=1.38u as=0 ps=0 w=1u l=1u
X3570 VSS.t331 VDD.t1658 VSS.t331 VSS.t333 sg13_lv_nmos ad=0.1428p pd=1.52u as=0 ps=0 w=0.42u l=1u
X3571 VSS.t1569 VSS.t1561 VSS.t1561 VSS.t1562 sg13_lv_nmos ad=0.68p pd=4.68u as=0 ps=0 w=2u l=1u
X3572 a_10430_1044# a_2019_1047.t7 a_10328_1044# VSS.t674 sg13_lv_nmos ad=0.2516p pd=2.16u as=0.1406p ps=1.12u w=0.74u l=0.13u
X3573 VSS.t324 VDD.t1660 VSS.t324 VSS.t329 sg13_lv_nmos ad=79.8f pd=0.8u as=0 ps=0 w=0.42u l=1u
X3574 a_4157_7003# REF_CLK VDD.t902 VDD.t9 sg13_lv_pmos ad=0.3808p pd=2.92u as=0.3808p ps=2.92u w=1.12u l=0.13u
X3575 VSS.t649 a_16163_16869# a_16597_16869# VSS.t648 sg13_lv_nmos ad=0.1406p pd=1.12u as=0.2516p ps=2.16u w=0.74u l=0.13u
X3576 VDD.t423 a_25717_1842# a_26185_1044# VDD.t67 sg13_lv_pmos ad=0.252p pd=1.57u as=0.3808p ps=2.92u w=1.12u l=0.13u
X3577 VSS.t2 a_2595_3156.t2 a_20905_3364# VSS.t574 sg13_lv_nmos ad=0.2516p pd=2.16u as=0.2516p ps=2.16u w=0.74u l=0.13u
X3578 VSS.t299 VDD.t1672 VSS.t299 VSS.t300 sg13_lv_nmos ad=0.1428p pd=1.52u as=0 ps=0 w=0.42u l=1u
X3579 VSS.t1086 a_3171_16074.t6 a_14964_16035# VSS.t2209 sg13_lv_nmos ad=0.2516p pd=2.16u as=0.2516p ps=2.16u w=0.74u l=0.13u
X3580 VSS.t317 a_3171_6001.t3 a_11785_6209# VSS.t1921 sg13_lv_nmos ad=0.2516p pd=2.16u as=0.2516p ps=2.16u w=0.74u l=0.13u
X3581 a_4633_14024# a_4437_14024# VSS.t875 VSS.t2142 sg13_lv_nmos ad=0.2516p pd=2.16u as=0.1406p ps=1.12u w=0.74u l=0.13u
X3582 VSS.t2055 a_3171_13229.t7 a_11924_13190# VSS.t2054 sg13_lv_nmos ad=0.2516p pd=2.16u as=0.2516p ps=2.16u w=0.74u l=0.13u
X3583 VSS.t862 a_11603_16869# a_12037_16869# VSS.t1325 sg13_lv_nmos ad=0.1406p pd=1.12u as=0.2516p ps=2.16u w=0.74u l=0.13u
X3584 VSS.t232 a_2019_12493.t3 a_5705_12701# VSS.t908 sg13_lv_nmos ad=0.2516p pd=2.16u as=0.2516p ps=2.16u w=0.74u l=0.13u
X3585 VDD.t564 a_4437_1842# a_4905_1044# VDD.t67 sg13_lv_pmos ad=0.252p pd=1.57u as=0.3808p ps=2.92u w=1.12u l=0.13u
X3586 VDD.t928 a_13883_1842# a_14317_1842# VDD.t379 sg13_lv_pmos ad=0.2128p pd=1.5u as=0.3808p ps=2.92u w=1.12u l=0.13u
X3587 VSS.t570 a_4187_1764.t74 a_21591_7532# VSS.t760 sg13_lv_nmos ad=0.2516p pd=2.16u as=0.1406p ps=1.12u w=0.74u l=0.6u
X3588 a_4157_1313# CHAN3_DELAY_IN VSS.t176 VSS.t175 sg13_lv_nmos ad=0.2516p pd=2.16u as=0.2553p ps=2.17u w=0.74u l=0.13u
X3589 a_7390_1044# a_3171_1047.t8 a_8808_1044# VSS.t633 sg13_lv_nmos ad=0.2516p pd=2.16u as=0.1406p ps=1.12u w=0.74u l=0.13u
X3590 a_7390_3889# a_2595_3892.t8 a_8155_3889# VSS.t1420 sg13_lv_nmos ad=0.2516p pd=2.16u as=0.1406p ps=1.12u w=0.74u l=0.13u
X3591 VSS.t240 VDD.t1687 VSS.t240 VSS.t241 sg13_lv_nmos ad=79.8f pd=0.8u as=0 ps=0 w=0.42u l=1u
X3592 VSS.t1468 a_4187_1764.t121 a_11711_14024# VSS.t1903 sg13_lv_nmos ad=0.2516p pd=2.16u as=0.1406p ps=1.12u w=0.74u l=0.6u
X3593 a_22873_1842# a_22677_1842# VSS.t513 VSS.t737 sg13_lv_nmos ad=0.2516p pd=2.16u as=0.1406p ps=1.12u w=0.74u l=0.13u
X3594 a_25391_14024# a_25153_14024# a_25283_14024# VSS.t1856 sg13_lv_nmos ad=0.1406p pd=1.12u as=0.2516p ps=2.16u w=0.74u l=0.2u
X3595 a_10328_3889# a_9757_4687# VDD.t534 VDD.t0 sg13_lv_pmos ad=0.2128p pd=1.5u as=0.3808p ps=2.92u w=1.12u l=0.13u
X3596 VSS.t122 a_2019_15338.t2 a_17865_15546# VSS.t2207 sg13_lv_nmos ad=0.2516p pd=2.16u as=0.2516p ps=2.16u w=0.74u l=0.13u
X3597 VDD.t575 a_3171_1047.t8 a_8884_1008# VDD.t67 sg13_lv_pmos ad=0.3808p pd=2.92u as=0.3808p ps=2.92u w=1.12u l=0.13u
X3598 VDD.t1147 a_12037_16869# a_12505_16071# VDD.t34 sg13_lv_pmos ad=0.252p pd=1.57u as=0.3808p ps=2.92u w=1.12u l=0.13u
C0 a_15765_3308# a_16108_3134# 0.42004f
C1 a_21353_1842# a_21917_1842# 0.0114f
C2 a_5731_289# a_8745_519# 0.28635f
C3 a_26043_1842# a_25630_1044# 0.01012f
C4 a_15077_1842# a_5731_3134# 0.01319f
C5 a_10404_1008# a_9757_1842# 0.02011f
C6 VDD a_14317_16869# 0.86919f
C7 VDD a_21911_16035# 0.2822f
C8 VDD a_5197_7532# 0.86919f
C9 VDD a_1256_13226# 0.48292f
C10 VDD a_10328_6734# 0.17274f
C11 VDD a_13883_1842# 0.50061f
C12 VDD a_26151_5315# 0.01806f
C13 CHAN2_MUX_OUT a_4187_2434# 1.28859f
C14 CHAN2_MUX_SEL4 a_4003_1842# 0.01225f
C15 a_18877_16869# a_19203_16869# 0.01427f
C16 a_1544_16071# a_1721_16422# 0.38063f
C17 a_1256_15316# a_1721_15358# 0.13421f
C18 a_4187_2434# a_12363_14024# 0.06482f
C19 a_4187_2434# a_25153_7532# 0.11284f
C20 a_23437_14024# a_24197_14024# 0.03319f
C21 a_15765_12645# a_15964_12471# 0.061f
C22 a_5731_12471# a_5974_11413# 0.01167f
C23 a_9757_7532# a_10083_7532# 0.01427f
C24 a_16510_6734# a_17275_6734# 0.39037f
C25 a_16108_5979# a_26673_4687# 0.01872f
C26 a_14513_4687# a_15077_4687# 0.0114f
C27 a_22590_3889# a_23431_3853# 0.28268f
C28 a_15837_1842# a_16408_1044# 0.10864f
C29 a_25717_1842# a_26185_1044# 0.19203f
C30 a_19550_1044# a_20968_1044# 0.38994f
C31 a_24393_1842# VDD 0.4946f
C32 a_17865_519# VDD 0.29444f
C33 a_10191_1842# a_10083_1842# 0.01163f
C34 VDD a_4905_16071# 0.3017f
C35 VDD a_26043_14024# 0.50058f
C36 VDD a_6854_11144# 1.0388f
C37 VDD a_17553_4687# 0.49593f
C38 VDD a_27048_3889# 0.17499f
C39 CHAN3_MUX_SEL3 CHAN3_MUX_OUT 0.79533f
C40 CHAN0_MUX_SEL4 a_1721_15358# 0.05813f
C41 CHAN0_MUX_SEL3 a_2297_15358# 0.01595f
C42 CHAN0_MUX_OUT a_1544_15316# 0.69943f
C43 CHAN0_MUX_SEL2 a_2873_15358# 0.01422f
C44 a_9953_16869# a_10517_16869# 0.0114f
C45 a_4187_2434# a_16597_16869# 0.0414f
C46 a_16510_16071# a_16484_16035# 0.277f
C47 a_14317_14024# a_14643_14024# 0.01427f
C48 a_4187_2434# a_7477_7532# 0.0414f
C49 a_16108_15316# a_26043_14024# 0.01539f
C50 a_14851_10872# a_15108_11015# 0.29858f
C51 a_22590_13226# a_23355_13226# 0.39037f
C52 a_14009_10774# a_14757_10872# 0.01058f
C53 a_13883_7532# a_13991_7532# 0.01163f
C54 a_26673_7532# a_26803_7532# 0.70845f
C55 a_19963_7532# a_20071_8160# 0.01697f
C56 a_4350_6734# a_5191_6698# 0.28268f
C57 a_5393_4687# a_5523_4687# 0.70845f
C58 a_5731_5979# a_10843_4687# 0.01539f
C59 a_10517_1842# a_10083_1842# 0.69698f
C60 a_10430_3889# a_11848_3889# 0.38994f
C61 a_20105_3889# a_20391_3853# 0.01885f
C62 a_17683_1842# a_17791_1842# 0.01163f
C63 a_23763_1842# a_23871_2470# 0.01697f
C64 a_15545_1044# a_15831_1008# 0.01885f
C65 a_8155_1044# a_8231_1008# 0.01194f
C66 a_7390_1044# a_8884_1008# 0.28279f
C67 a_11924_1008# VDD 0.28225f
C68 a_3449_1395# CHAN3_MUX_SEL1 0.29404f
C69 CHAN0_MUX_SEL2 CHAN1_MUX_SEL0 0.0126f
C70 CHAN0_MUX_SEL4 CHAN1_DELAY_IN 0.01327f
C71 a_26673_1842# a_4187_2434# 0.11222f
C72 VDD a_8433_14024# 0.49593f
C73 VDD a_9431_17497# 0.01806f
C74 VDD a_14888_13226# 0.17499f
C75 VDD a_21157_7532# 0.85896f
C76 VDD a_26185_3889# 0.30411f
C77 a_13883_16869# a_13991_16869# 0.01163f
C78 a_27237_16869# a_26803_16869# 0.6972f
C79 a_5731_15316# a_11277_14024# 0.01319f
C80 a_4350_16071# a_5115_16071# 0.39037f
C81 a_5393_14024# a_5957_14024# 0.0114f
C82 a_20723_14024# a_20831_14024# 0.01163f
C83 a_7803_14024# a_7390_13226# 0.01012f
C84 a_26803_14024# a_26911_14652# 0.01697f
C85 a_4187_2434# a_19833_4687# 0.11222f
C86 a_12355_11557# a_13019_11521# 0.3846f
C87 a_20105_13226# a_20315_13226# 0.09424f
C88 a_10430_13226# a_11271_13190# 0.28268f
C89 a_18117_7532# a_17683_7532# 0.6972f
C90 a_19550_6734# a_16108_5979# 0.58202f
C91 a_22677_4687# a_22873_4687# 0.73022f
C92 a_5731_3134# a_16108_3134# 0.01334f
C93 a_20397_1842# a_21157_1842# 0.03319f
C94 a_24957_1842# a_25528_1044# 0.10864f
C95 VDD a_11603_16869# 0.49739f
C96 a_8884_1008# a_8997_1842# 0.02055f
C97 VDD a_19448_16071# 0.17274f
C98 VDD a_20071_5315# 0.01806f
C99 VDD a_7390_6734# 0.8686f
C100 VDD a_12233_1842# 0.59884f
C101 REF_MUX_OUT a_4187_2434# 1.28859f
C102 CHAN2_MUX_SEL4 a_15964_3134# 0.5544f
C103 a_18117_16869# a_18313_16869# 0.77122f
C104 a_4187_2434# a_10713_14024# 0.11222f
C105 a_22677_14024# a_22243_14024# 0.69698f
C106 a_4187_2434# a_23437_7532# 0.04013f
C107 a_5731_12471# a_15964_12471# 0.2778f
C108 a_12363_7532# a_10430_6734# 0.01012f
C109 a_19637_7532# a_20105_6734# 0.19203f
C110 a_8997_7532# a_9193_7532# 0.77122f
C111 a_27705_6734# a_27915_6734# 0.09424f
C112 a_13557_4687# a_14317_4687# 0.01669f
C113 a_16108_5979# a_24957_4687# 0.01307f
C114 a_21835_3889# a_21911_3853# 0.01194f
C115 a_15837_1842# a_13470_1044# 0.02479f
C116 a_22677_1842# VDD 0.91655f
C117 a_8671_1842# a_8563_1842# 0.01163f
C118 VDD a_24393_14024# 0.4946f
C119 VDD a_2297_16422# 0.46536f
C120 VDD a_17865_12701# 0.29444f
C121 VDD a_15837_4687# 0.87964f
C122 VDD a_24084_3853# 0.28225f
C123 CHAN1_DELAY_IN a_3449_13577# 0.01058f
C124 CHAN1_MUX_SEL1 a_2873_13577# 0.13092f
C125 a_19637_16869# a_20105_16071# 0.19203f
C126 a_4187_2434# a_13883_16869# 0.06627f
C127 a_8997_16869# a_9757_16869# 0.02912f
C128 a_12363_16869# a_10430_16071# 0.01012f
C129 a_16108_15316# a_24393_14024# 0.01872f
C130 a_4187_2434# a_4763_7532# 0.06627f
C131 a_13557_14024# a_13753_14024# 0.73897f
C132 a_16923_14024# a_16510_13226# 0.01012f
C133 a_4187_2434# a_14513_1842# 0.11222f
C134 a_18443_7532# a_18551_8160# 0.01697f
C135 a_4437_7532# a_4905_6734# 0.19203f
C136 a_12363_7532# a_12471_7532# 0.01163f
C137 a_7945_6734# a_8155_6734# 0.09424f
C138 a_5731_5979# a_9193_4687# 0.01872f
C139 a_9193_1842# a_9757_1842# 0.0114f
C140 a_14025_1044# a_13470_1044# 0.03209f
C141 a_22243_1842# a_22351_2470# 0.01697f
C142 a_16163_1842# a_16271_1842# 0.01163f
C143 a_9675_1044# VDD 0.15407f
C144 a_1256_1044# CHAN3_MUX_SEL4 0.04785f
C145 CHAN0_DELAY_IN CHAN0_MUX_SEL4 0.0663f
C146 a_24957_1842# a_4187_2434# 0.0414f
C147 a_15077_1842# a_14317_1842# 0.03319f
C148 a_26477_1842# a_16108_3134# 0.01319f
C149 VDD a_27563_16869# 0.49811f
C150 VDD a_6717_14024# 0.88148f
C151 VDD a_18443_7532# 0.4973f
C152 VDD a_11924_13190# 0.28225f
C153 VDD a_1544_5979# 0.39372f
C154 VDD a_14025_3889# 0.30411f
C155 a_4437_16869# a_4905_16071# 0.19203f
C156 a_9465_16071# a_7390_16071# 0.03208f
C157 a_12363_16869# a_12471_16869# 0.01163f
C158 a_4187_2434# a_26673_14024# 0.11222f
C159 a_25913_16869# a_26477_16869# 0.0114f
C160 a_4437_14024# a_5197_14024# 0.01669f
C161 a_5731_15316# a_8563_14024# 0.01544f
C162 a_25283_14024# a_25391_14652# 0.01697f
C163 a_6717_14024# a_7288_13226# 0.10864f
C164 a_9675_13226# a_9751_13190# 0.01194f
C165 a_12037_14024# a_12505_13226# 0.2079f
C166 a_4187_2434# a_18117_4687# 0.04152f
C167 a_19203_14024# a_19311_14024# 0.01163f
C168 a_16793_7532# a_17357_7532# 0.0114f
C169 a_21483_7532# a_19550_6734# 0.01012f
C170 a_16510_6734# a_16851_5999# 0.02131f
C171 a_25630_6734# a_26471_6698# 0.28268f
C172 a_21353_4687# a_21483_4687# 0.70845f
C173 a_19637_1842# a_19203_1842# 0.69698f
C174 a_24957_1842# a_22590_1044# 0.02479f
C175 a_1256_1044# a_2873_1395# 0.28892f
C176 a_1256_289# a_2019_311# 0.02904f
C177 a_27997_1842# CHAN3_DELAY_OUT_LAST 0.70955f
C178 a_7390_1044# a_8237_1842# 0.08038f
C179 a_14025_1044# a_13557_1842# 0.19203f
C180 VDD a_9953_16869# 0.49426f
C181 VDD a_16510_16071# 0.8795f
C182 VDD a_14851_10872# 0.26676f
C183 VDD a_13991_5315# 0.01806f
C184 VDD a_4324_6698# 0.28687f
C185 VDD a_10517_1842# 0.87095f
C186 REF_MUX_SEL1 a_2297_7085# 0.01995f
C187 REF_MUX_OUT a_1544_6734# 0.04258f
C188 CHAN2_MUX_OUT a_5731_3134# 1.04829f
C189 CHAN2_MUX_SEL4 a_8745_3364# 0.04472f
C190 a_4187_2434# a_8997_14024# 0.04141f
C191 a_21483_16869# a_19550_16071# 0.01012f
C192 a_16793_16869# a_16923_16869# 0.70845f
C193 a_4187_2434# a_20723_7532# 0.06661f
C194 a_25630_16071# a_26395_16071# 0.39037f
C195 a_21353_14024# a_21917_14024# 0.0114f
C196 a_16510_16071# a_16108_15316# 0.56108f
C197 a_26043_14024# a_25630_13226# 0.01012f
C198 a_5731_12471# a_8745_12701# 0.28635f
C199 a_7673_7532# a_7803_7532# 0.70845f
C200 a_13470_6734# a_14888_6734# 0.38994f
C201 a_12797_4687# a_12363_4687# 0.6972f
C202 a_19550_3889# a_21044_3853# 0.28279f
C203 a_20315_3889# a_20391_3853# 0.01194f
C204 a_4350_1044# a_2019_311# 0.02042f
C205 a_16510_1044# a_18795_1044# 0.39036f
C206 a_19963_1842# VDD 0.50058f
C207 a_2019_311# VDD 1.43004f
C208 a_13231_2470# a_13123_1842# 0.01697f
C209 a_7151_1842# a_7043_1842# 0.01163f
C210 VDD a_22677_14024# 0.91715f
C211 VDD a_23871_8160# 0.01806f
C212 VDD a_21835_3889# 0.15407f
C213 VDD a_13123_4687# 0.4839f
C214 CHAN2_MUX_SEL3 CHAN2_MUX_OUT 0.79533f
C215 CHAN2_MUX_SEL2 CHAN3_DELAY_IN 0.1765f
C216 CHAN1_MUX_SEL1 a_1256_13226# 1.44243f
C217 CHAN1_MUX_SEL0 a_1544_13226# 0.07603f
C218 DLL_RESETN a_9712_9602# 0.431f
C219 a_4187_2434# a_12233_16869# 0.11169f
C220 a_8237_16869# a_7803_16869# 0.6972f
C221 a_12233_14024# a_12363_14024# 0.70361f
C222 a_13470_16071# a_14311_16035# 0.28268f
C223 a_19550_13226# a_20968_13226# 0.38994f
C224 a_15837_14024# a_16408_13226# 0.10864f
C225 a_25717_14024# a_26185_13226# 0.19203f
C226 a_13566_11018# a_13306_10795# 0.75507f
C227 a_4187_2434# a_12797_1842# 0.0414f
C228 a_10843_7532# a_10951_7532# 0.01163f
C229 a_16923_7532# a_17031_8160# 0.01697f
C230 a_24957_7532# a_25153_7532# 0.76914f
C231 a_6283_4687# a_4350_3889# 0.01012f
C232 a_10517_4687# a_10985_3889# 0.19203f
C233 a_5731_5979# a_7477_4687# 0.01314f
C234 a_7390_3889# a_9675_3889# 0.39036f
C235 a_8237_1842# a_8997_1842# 0.03319f
C236 a_20723_1842# a_20831_2470# 0.01697f
C237 a_14643_1842# a_14751_1842# 0.01163f
C238 a_10985_1044# a_11271_1008# 0.01885f
C239 a_4350_1044# a_6711_1008# 0.26208f
C240 a_6711_1008# VDD 0.2822f
C241 a_22243_1842# a_4187_2434# 0.06315f
C242 a_23763_1842# a_16108_3134# 0.01544f
C243 VDD a_25913_16869# 0.49294f
C244 VDD a_9675_13226# 0.15407f
C245 VDD a_4003_14024# 0.61691f
C246 VDD a_16793_7532# 0.49277f
C247 VDD a_25604_6698# 0.28633f
C248 VDD a_4157_4158# 0.48942f
C249 CHAN1_MUX_OUT a_6326_10280# 0.06947f
C250 a_4187_2434# a_24957_14024# 0.0414f
C251 a_24957_16869# a_25717_16869# 0.06198f
C252 a_10843_16869# a_10951_16869# 0.01163f
C253 a_17683_14024# a_17791_14024# 0.01163f
C254 a_5731_15316# a_6913_14024# 0.01872f
C255 a_6717_14024# a_4350_13226# 0.02479f
C256 a_23763_14024# a_23871_14652# 0.01697f
C257 a_4187_2434# a_15403_4687# 0.06627f
C258 a_15545_13226# a_15831_13190# 0.01885f
C259 a_7390_13226# a_8884_13190# 0.28279f
C260 a_8155_13226# a_8231_13190# 0.01194f
C261 a_15837_7532# a_16597_7532# 0.06198f
C262 a_10232_11561# a_11397_11918# 0.43239f
C263 a_24875_6734# a_24951_6698# 0.01194f
C264 a_20397_4687# a_20723_4687# 0.01427f
C265 a_18313_1842# a_18877_1842# 0.0114f
C266 a_22677_1842# a_22564_1008# 0.05157f
C267 a_16851_309# CHAN3_MUX_OUT 0.45865f
C268 a_6711_1008# a_6717_1842# 0.02354f
C269 VDD a_13444_16035# 0.28633f
C270 VDD a_8237_16869# 0.86919f
C271 VDD a_21625_6734# 0.29722f
C272 VDD a_13566_11018# 0.0947f
C273 VDD a_7911_5315# 0.01806f
C274 VDD a_7803_1842# 0.50058f
C275 REF_DELAY_OUT_LAST a_13019_11521# 0.08017f
C276 CHAN2_MUX_SEL3 a_3449_3176# 0.28429f
C277 CHAN2_MUX_SEL4 a_2873_3176# 0.04916f
C278 CHAN2_MUX_OUT a_2297_3176# 0.01179f
C279 a_15837_16869# a_16163_16869# 0.01427f
C280 a_4187_2434# a_6283_14024# 0.06627f
C281 a_4187_2434# a_19073_7532# 0.11286f
C282 a_20397_14024# a_21157_14024# 0.03319f
C283 a_24957_14024# a_25528_13226# 0.10864f
C284 a_6717_7532# a_7043_7532# 0.01427f
C285 a_23145_6734# a_23355_6734# 0.09424f
C286 a_15403_4687# a_13470_3889# 0.01012f
C287 a_16108_5979# a_20593_4687# 0.01872f
C288 a_11473_4687# a_12037_4687# 0.0114f
C289 a_24197_4687# a_24665_3889# 0.2079f
C290 a_18313_1842# VDD 0.4946f
C291 a_27991_1008# VDD 0.28201f
C292 a_5631_1842# a_5523_1842# 0.01163f
C293 a_11711_2470# a_11603_1842# 0.01697f
C294 VDD a_19963_14024# 0.50058f
C295 VDD a_17791_8160# 0.01806f
C296 VDD a_11473_4687# 0.49601f
C297 VDD a_18871_3853# 0.2822f
C298 a_6913_16869# a_7477_16869# 0.0114f
C299 a_4187_2434# a_10517_16869# 0.0414f
C300 a_12715_16071# a_12791_16035# 0.01194f
C301 a_24665_16071# a_22590_16071# 0.03208f
C302 a_16108_15316# a_19963_14024# 0.01539f
C303 a_11277_14024# a_11603_14024# 0.01427f
C304 a_15837_14024# a_13470_13226# 0.02479f
C305 a_4187_2434# a_10083_1842# 0.06627f
C306 a_13019_11521# a_9712_9602# 0.03275f
C307 a_13106_11047# a_12907_10876# 0.02437f
C308 a_9323_7532# a_9431_7532# 0.01163f
C309 a_15403_7532# a_15511_8160# 0.01697f
C310 a_23633_7532# a_23763_7532# 0.70845f
C311 a_4157_7003# a_4248_6734# 0.11672f
C312 a_15964_5979# a_16851_5999# 0.16757f
C313 a_15545_3889# a_13470_3889# 0.03208f
C314 a_7477_1842# a_7043_1842# 0.69698f
C315 a_5731_3134# a_14513_1842# 0.01872f
C316 a_26477_1842# a_26673_1842# 0.76914f
C317 a_19203_1842# a_19311_2470# 0.01697f
C318 a_4248_1044# a_4350_1044# 0.37183f
C319 a_4248_1044# VDD 0.17587f
C320 a_20593_1842# a_4187_2434# 0.11222f
C321 a_22113_1842# a_16108_3134# 0.01872f
C322 VDD a_24197_16869# 0.85892f
C323 VDD a_15964_15316# 0.31771f
C324 VDD a_6711_13190# 0.2822f
C325 VDD a_23355_6734# 0.15389f
C326 VDD a_15077_7532# 0.86018f
C327 CHAN1_MUX_SEL4 a_15964_12471# 0.5544f
C328 a_9323_16869# a_9431_16869# 0.01163f
C329 a_24197_16869# a_23763_16869# 0.6972f
C330 a_4187_2434# a_22243_14024# 0.06315f
C331 a_4437_14024# a_4324_13190# 0.05157f
C332 a_22243_14024# a_22351_14652# 0.01697f
C333 a_15964_15316# a_16108_15316# 0.42202f
C334 a_16163_14024# a_16271_14024# 0.01163f
C335 a_9946_11995# a_10520_11982# 0.31978f
C336 a_10206_11525# a_10649_11568# 0.02242f
C337 a_14025_13226# a_13470_13226# 0.03209f
C338 a_4187_2434# a_13753_4687# 0.11222f
C339 a_15077_7532# a_14643_7532# 0.6972f
C340 a_23355_6734# a_23431_6698# 0.01194f
C341 a_22590_6734# a_24084_6698# 0.28279f
C342 a_15837_4687# a_15964_3134# 0.02f
C343 a_24523_4687# a_22590_3889# 0.01012f
C344 a_19637_4687# a_19833_4687# 0.73897f
C345 a_22590_3889# a_23945_3364# 0.02165f
C346 a_17357_1842# a_18117_1842# 0.03319f
C347 a_25630_1044# a_27991_1008# 0.26208f
C348 a_22351_2470# VDD 0.02353f
C349 a_5844_1008# a_5197_1842# 0.02312f
C350 VDD a_5523_16869# 0.49671f
C351 VDD a_11195_16071# 0.15389f
C352 VDD a_9465_6734# 0.29722f
C353 VDD a_27433_4687# 0.49998f
C354 VDD a_6153_1842# 0.4946f
C355 a_4187_2434# a_26477_16869# 0.04145f
C356 a_15077_16869# a_15273_16869# 0.77122f
C357 a_4187_2434# a_4633_14024# 0.11222f
C358 a_22590_16071# a_24008_16071# 0.38994f
C359 a_19637_14024# a_19203_14024# 0.69698f
C360 a_4187_2434# a_17357_7532# 0.04176f
C361 a_1256_13226# a_2873_13577# 0.28892f
C362 a_24957_14024# a_22590_13226# 0.02479f
C363 a_5957_7532# a_6153_7532# 0.77122f
C364 a_8237_7532# a_8808_6734# 0.10863f
C365 a_10430_6734# a_12715_6734# 0.39036f
C366 a_16108_5979# a_18877_4687# 0.01307f
C367 a_10517_4687# a_11277_4687# 0.01669f
C368 a_16510_3889# a_18871_3853# 0.26208f
C369 a_26185_1044# a_26471_1008# 0.01885f
C370 a_25528_1044# VDD 0.17274f
C371 a_16597_1842# VDD 0.86961f
C372 a_10191_2470# a_10083_1842# 0.01697f
C373 a_4111_1842# a_4003_1842# 0.01163f
C374 VDD a_18313_14024# 0.4946f
C375 VDD a_27991_13190# 0.28201f
C376 VDD a_11711_8160# 0.01806f
C377 VDD a_9757_4687# 0.88193f
C378 REF_MUX_SEL2 CHAN2_DELAY_IN 0.1765f
C379 REF_MUX_SEL3 REF_MUX_OUT 0.79533f
C380 VDD a_16408_3889# 0.17274f
C381 REF_CLK a_13592_11113# 0.03445f
C382 REF_MUX_SEL4 a_11785_6209# 0.03255f
C383 a_5957_16869# a_6717_16869# 0.02912f
C384 a_4187_2434# a_7803_16869# 0.06627f
C385 a_8237_16869# a_8808_16071# 0.10863f
C386 a_27563_16869# a_27671_17497# 0.01697f
C387 a_10430_16071# a_11924_16035# 0.28279f
C388 a_11195_16071# a_11271_16035# 0.01194f
C389 a_13557_14024# a_13444_13190# 0.05157f
C390 a_16108_15316# a_18313_14024# 0.02026f
C391 a_10517_14024# a_10713_14024# 0.73897f
C392 a_13121_11521# a_15688_11093# 0.01441f
C393 a_12849_11557# a_15108_11015# 0.10521f
C394 a_4187_2434# a_8433_1842# 0.11222f
C395 a_16510_13226# a_18795_13226# 0.39036f
C396 a_13883_7532# a_13991_8160# 0.01697f
C397 a_7803_7532# a_7911_7532# 0.01163f
C398 a_27433_4687# a_27997_4687# 0.0114f
C399 a_6153_1842# a_6717_1842# 0.0114f
C400 a_5731_3134# a_12797_1842# 0.01307f
C401 a_17683_1842# a_17791_2470# 0.01697f
C402 a_25153_1842# a_25283_1842# 0.70845f
C403 a_18585_1044# VDD 0.29742f
C404 a_18877_1842# a_4187_2434# 0.0414f
C405 a_20397_1842# a_16108_3134# 0.01319f
C406 a_14964_1008# a_14317_1842# 0.02312f
C407 VDD a_8745_15546# 0.29292f
C408 VDD a_21483_16869# 0.49801f
C409 VDD a_12363_7532# 0.92686f
C410 VDD a_4248_13226# 0.17587f
C411 VDD a_20391_6698# 0.28357f
C412 CHAN0_MUX_OUT a_1544_16071# 0.04258f
C413 CHAN0_MUX_SEL1 a_2297_16422# 0.01995f
C414 CHAN1_MUX_SEL4 a_8745_12701# 0.04472f
C415 CHAN1_MUX_OUT a_5731_12471# 1.04829f
C416 a_22873_16869# a_23437_16869# 0.0114f
C417 a_7803_16869# a_7911_16869# 0.01163f
C418 a_4187_2434# a_20593_14024# 0.11222f
C419 a_20723_14024# a_20831_14652# 0.01697f
C420 a_14643_14024# a_14751_14024# 0.01163f
C421 a_10985_13226# a_11271_13190# 0.01885f
C422 a_4350_13226# a_6711_13190# 0.26208f
C423 a_4187_2434# a_12037_4687# 0.04152f
C424 a_17357_7532# a_17928_6734# 0.10863f
C425 a_13753_7532# a_14317_7532# 0.0114f
C426 a_18313_4687# a_18443_4687# 0.70845f
C427 a_1256_3889# a_1544_3889# 1.26509f
C428 a_16597_1842# a_16163_1842# 0.69698f
C429 a_21157_1842# a_19550_1044# 0.05231f
C430 a_20397_1842# a_20391_1008# 0.02349f
C431 a_25528_1044# a_25630_1044# 0.37183f
C432 a_16271_2470# VDD 0.01806f
C433 a_2019_311# CHAN3_MUX_SEL4 0.90276f
C434 a_4350_1044# a_4437_1842# 0.1088f
C435 VDD a_4187_2434# 73.4081f
C436 VDD a_8231_16035# 0.28357f
C437 VDD a_22351_14652# 0.02349f
C438 VDD a_12943_11557# 0.29488f
C439 VDD a_25717_4687# 0.871f
C440 VDD a_4437_1842# 0.87147f
C441 a_4187_2434# a_16108_15316# 0.21585f
C442 a_17357_16869# a_17928_16071# 0.10863f
C443 a_13753_16869# a_13883_16869# 0.70845f
C444 a_4187_2434# a_23763_16869# 0.06627f
C445 a_22677_14024# a_22564_13190# 0.05157f
C446 a_18313_14024# a_18877_14024# 0.0114f
C447 a_4187_2434# a_14643_7532# 0.06668f
C448 a_4633_7532# a_4763_7532# 0.70845f
C449 a_9757_4687# a_9323_4687# 0.6972f
C450 a_18585_6734# a_18871_6698# 0.01885f
C451 a_16108_5979# a_16163_4687# 0.0155f
C452 a_26803_4687# a_26911_4687# 0.01163f
C453 a_16408_3889# a_16510_3889# 0.37183f
C454 a_14317_1842# a_14513_1842# 0.76914f
C455 a_13368_1044# a_13444_1008# 0.01176f
C456 a_22590_1044# VDD 0.98586f
C457 a_8671_2470# a_8563_1842# 0.01697f
C458 VDD a_16597_14024# 0.86961f
C459 VDD a_25528_13226# 0.17274f
C460 VDD a_5631_8160# 0.01806f
C461 VDD a_7043_4687# 0.4999f
C462 VDD a_13470_3889# 0.87936f
C463 REF_CLK a_15304_10295# 0.01066f
C464 a_4187_2434# a_6153_16869# 0.11222f
C465 a_5197_16869# a_4763_16869# 0.6972f
C466 a_26043_16869# a_26151_17497# 0.01697f
C467 a_18585_16071# a_18795_16071# 0.09424f
C468 a_16108_15316# a_16597_14024# 0.01319f
C469 a_9193_14024# a_9323_14024# 0.70845f
C470 a_12849_11557# a_13306_10795# 0.10976f
C471 a_4187_2434# a_6717_1842# 0.0414f
C472 a_4187_2434# a_27997_4687# 0.04001f
C473 a_15108_11799# a_14851_11918# 0.29858f
C474 a_12363_7532# a_12471_8160# 0.01697f
C475 a_21917_7532# a_22113_7532# 0.76914f
C476 a_6283_7532# a_6391_7532# 0.01163f
C477 a_26477_7532# a_27048_6734# 0.10863f
C478 a_26477_4687# a_27237_4687# 0.03319f
C479 a_4248_3889# a_4324_3853# 0.01176f
C480 a_9465_3889# a_9675_3889# 0.09424f
C481 a_5731_3134# a_10083_1842# 0.01539f
C482 a_5197_1842# a_5957_1842# 0.03319f
C483 a_4905_1044# a_5115_1044# 0.09424f
C484 a_16163_1842# a_16271_2470# 0.01697f
C485 a_16108_289# a_23945_519# 0.2906f
C486 a_16163_1842# a_4187_2434# 0.06627f
C487 a_25630_1044# a_4187_2434# 0.01522f
C488 a_17683_1842# a_16108_3134# 0.01562f
C489 a_13470_1044# a_13557_1842# 0.1088f
C490 VDD a_19833_16869# 0.49294f
C491 VDD a_2873_15358# 0.46598f
C492 VDD a_18585_13226# 0.29742f
C493 VDD a_10713_7532# 0.49296f
C494 VDD a_17928_6734# 0.17499f
C495 CHAN1_MUX_SEL4 a_2873_12513# 0.04916f
C496 CHAN1_MUX_OUT a_2297_12513# 0.01179f
C497 CHAN1_MUX_SEL3 a_3449_12513# 0.28429f
C498 REF_MUX_SEL4 a_7390_6734# 0.34655f
C499 a_21917_16869# a_22677_16869# 0.06198f
C500 a_6283_16869# a_6391_16869# 0.01163f
C501 a_26477_16869# a_27048_16071# 0.10863f
C502 a_4187_2434# a_18877_14024# 0.0414f
C503 a_26477_14024# a_26673_14024# 0.76914f
C504 a_13123_14024# a_13231_14024# 0.01163f
C505 a_19203_14024# a_19311_14652# 0.01697f
C506 a_4187_2434# a_9323_4687# 0.06627f
C507 a_4248_13226# a_4350_13226# 0.37183f
C508 a_12797_7532# a_13557_7532# 0.05851f
C509 a_17357_4687# a_17683_4687# 0.01427f
C510 a_19550_6734# a_21911_6698# 0.26208f
C511 a_15273_1842# a_15837_1842# 0.0114f
C512 a_18877_1842# a_19524_1008# 0.02011f
C513 a_24008_1044# a_24084_1008# 0.01176f
C514 a_10191_2470# VDD 0.01806f
C515 a_3449_331# CHAN3_DELAY_IN 0.01017f
C516 VDD CHAN1_MUX_SEL0 0.60193f
C517 a_1256_289# CHAN3_MUX_SEL3 1.41161f
C518 a_1544_289# CHAN3_MUX_SEL2 0.07405f
C519 VDD a_16271_14652# 0.01806f
C520 VDD a_5768_16071# 0.17499f
C521 VDD a_12849_11557# 2.60064f
C522 VDD a_1544_6734# 0.45079f
C523 VDD a_23003_4687# 0.48375f
C524 VDD a_15765_3308# 0.36528f
C525 a_4187_2434# a_22113_16869# 0.11169f
C526 a_19550_16071# a_21835_16071# 0.39036f
C527 a_4187_2434# a_12993_7532# 0.11169f
C528 a_17357_14024# a_18117_14024# 0.03319f
C529 a_25630_13226# a_27991_13190# 0.26208f
C530 a_17065_6734# a_16510_6734# 0.03209f
C531 a_8433_4687# a_8997_4687# 0.0114f
C532 a_25283_4687# a_25391_4687# 0.01163f
C533 a_14888_3889# a_14964_3853# 0.01176f
C534 a_11277_4687# a_11848_3889# 0.10863f
C535 a_12993_1842# a_13123_1842# 0.70361f
C536 a_19524_1008# VDD 0.28633f
C537 VDD CHAN3_MUX_SEL3 0.40634f
C538 a_7151_2470# a_7043_1842# 0.01697f
C539 VDD a_26911_17497# 0.01806f
C540 VDD a_13883_14024# 0.50061f
C541 VDD a_22590_13226# 0.98586f
C542 VDD a_26673_7532# 0.49417f
C543 VDD a_5393_4687# 0.49643f
C544 VDD a_10404_3853# 0.28633f
C545 REF_CLK a_3449_7085# 0.01058f
C546 CHAN2_MUX_SEL4 a_4157_4158# 0.08229f
C547 REF_MUX_SEL2 a_2297_6021# 0.10655f
C548 REF_MUX_OUT a_1256_5979# 0.1134f
C549 REF_MUX_SEL4 a_1544_5979# 0.47529f
C550 a_4187_2434# a_4437_16869# 0.04193f
C551 a_7390_16071# a_9751_16035# 0.26208f
C552 a_24523_16869# a_24631_17497# 0.01697f
C553 a_8237_14024# a_8563_14024# 0.01427f
C554 a_11277_14024# a_11271_13190# 0.02349f
C555 a_12037_14024# a_10430_13226# 0.05231f
C556 a_26185_13226# a_26471_13190# 0.01885f
C557 a_4187_2434# a_25283_4687# 0.06627f
C558 a_6854_11676# a_9444_9602# 0.01142f
C559 a_6126_9506# a_5778_9057# 1.6143f
C560 a_14009_11568# a_14111_11568# 0.47795f
C561 a_5974_11413# a_9712_9602# 0.01152f
C562 a_6326_10280# a_5864_9057# 0.01889f
C563 a_4187_2434# a_4003_1842# 0.05992f
C564 a_13121_11521# a_15304_10295# 0.40921f
C565 a_10843_7532# a_10951_8160# 0.01697f
C566 a_4763_7532# a_4871_7532# 0.01163f
C567 a_20593_7532# a_20723_7532# 0.70845f
C568 a_25630_6734# a_26985_6209# 0.02195f
C569 a_25717_4687# a_25283_4687# 0.69698f
C570 a_4437_1842# a_4003_1842# 0.69698f
C571 a_5731_3134# a_8433_1842# 0.01872f
C572 a_14643_1842# a_14751_2470# 0.01697f
C573 a_23437_1842# a_23633_1842# 0.76914f
C574 a_16033_1842# a_16108_3134# 0.01197f
C575 VDD a_18117_16869# 0.85889f
C576 VDD a_27048_16071# 0.17499f
C577 VDD a_8997_7532# 0.85889f
C578 VDD a_14964_6698# 0.28225f
C579 a_4187_2434# a_16163_14024# 0.06627f
C580 a_4763_16869# a_4871_16869# 0.01163f
C581 a_21157_16869# a_20723_16869# 0.6972f
C582 a_4187_2434# a_25630_13226# 0.01522f
C583 a_5705_15546# a_5731_15316# 0.28954f
C584 a_25153_14024# a_25283_14024# 0.70845f
C585 a_17683_14024# a_17791_14652# 0.01697f
C586 a_11603_14024# a_11711_14024# 0.01163f
C587 a_4187_2434# a_7673_4687# 0.11222f
C588 a_12037_7532# a_11603_7532# 0.6972f
C589 a_19448_6734# a_19550_6734# 0.37183f
C590 a_16597_4687# a_16793_4687# 0.73897f
C591 a_25528_3889# a_25604_3853# 0.01176f
C592 a_20397_4687# a_20968_3889# 0.10863f
C593 a_13470_1044# a_5731_289# 0.41365f
C594 a_18117_1842# a_18004_1008# 0.02055f
C595 a_22590_1044# a_22564_1008# 0.277f
C596 a_4111_2470# VDD 0.01866f
C597 VDD CHAN0_MUX_SEL0 0.60193f
C598 VDD a_26185_16071# 0.30409f
C599 VDD a_10191_14652# 0.01806f
C600 VDD a_12158_11557# 0.37953f
C601 VDD a_21353_4687# 0.49468f
C602 VDD a_5731_3134# 0.98095f
C603 CHAN0_MUX_SEL4 a_11785_15546# 0.03255f
C604 a_12037_16869# a_12233_16869# 0.77122f
C605 a_4187_2434# a_20397_16869# 0.04141f
C606 a_4187_2434# a_11277_7532# 0.04141f
C607 a_16597_14024# a_16163_14024# 0.69698f
C608 a_20397_14024# a_20391_13190# 0.02349f
C609 a_25528_13226# a_25630_13226# 0.37183f
C610 a_21157_14024# a_19550_13226# 0.05231f
C611 a_7288_6734# a_7364_6698# 0.01176f
C612 a_4763_7532# a_4350_6734# 0.01012f
C613 a_14025_6734# a_14311_6698# 0.01885f
C614 a_23763_4687# a_23871_4687# 0.01163f
C615 a_5731_5979# a_14643_4687# 0.01544f
C616 a_7477_4687# a_8237_4687# 0.01669f
C617 a_13470_3889# a_13444_3853# 0.277f
C618 a_24665_3889# a_24875_3889# 0.09424f
C619 a_10430_1044# a_11195_1044# 0.39037f
C620 a_21625_1044# a_19550_1044# 0.03208f
C621 a_17275_1044# VDD 0.15389f
C622 VDD CHAN2_MUX_SEL3 0.421f
C623 CHAN1_MUX_SEL4 CHAN1_MUX_OUT 0.91933f
C624 a_5631_2470# a_5523_1842# 0.01697f
C625 VDD a_20831_17497# 0.01806f
C626 VDD a_19524_13190# 0.28633f
C627 VDD a_12233_14024# 0.59884f
C628 VDD a_24957_7532# 0.87825f
C629 VDD a_8155_3889# 0.1539f
C630 VDD a_20905_6209# 0.29292f
C631 CHAN2_MUX_SEL0 a_2873_4240# 0.01504f
C632 a_4763_16869# a_4350_16071# 0.01012f
C633 a_14025_16071# a_14235_16071# 0.09424f
C634 a_23003_16869# a_23111_17497# 0.01697f
C635 a_7288_16071# a_7390_16071# 0.37183f
C636 a_9757_14024# a_10404_13190# 0.02011f
C637 a_5731_15316# a_15077_14024# 0.01319f
C638 a_7477_14024# a_7673_14024# 0.73897f
C639 a_13368_13226# a_13444_13190# 0.01176f
C640 a_4187_2434# a_23633_4687# 0.11222f
C641 a_9323_7532# a_9431_8160# 0.01697f
C642 a_13566_11525# a_13592_11561# 0.36952f
C643 a_24393_4687# a_24957_4687# 0.0114f
C644 a_4905_3889# a_5191_3853# 0.01885f
C645 a_5731_3134# a_6717_1842# 0.01307f
C646 a_16108_3134# a_26985_3364# 0.27952f
C647 a_22113_1842# a_22243_1842# 0.70361f
C648 a_5731_289# a_15765_463# 0.23301f
C649 a_2019_311# a_17865_519# 0.13959f
C650 a_27237_1842# a_27124_1008# 0.02055f
C651 VDD a_15403_16869# 0.4973f
C652 VDD a_24084_16035# 0.28225f
C653 VDD a_6283_7532# 0.4973f
C654 VDD a_12715_6734# 0.15484f
C655 a_19833_16869# a_20397_16869# 0.0114f
C656 a_4187_2434# a_14513_14024# 0.11222f
C657 a_16163_14024# a_16271_14652# 0.01697f
C658 a_10083_14024# a_10191_14024# 0.01163f
C659 a_4187_2434# a_27237_7532# 0.0629f
C660 a_16108_12471# a_23945_12701# 0.2906f
C661 a_4187_2434# a_5957_4687# 0.04152f
C662 a_4905_13226# a_5115_13226# 0.09424f
C663 a_10713_7532# a_11277_7532# 0.0114f
C664 a_13883_7532# a_13470_6734# 0.01012f
C665 a_17928_6734# a_18004_6698# 0.01176f
C666 a_15273_4687# a_15403_4687# 0.70845f
C667 a_17357_1842# a_16510_1044# 0.08038f
C668 a_27237_1842# a_27705_1044# 0.2079f
C669 a_26477_1842# VDD 0.87175f
C670 VDD a_14025_16071# 0.30409f
C671 VDD a_10206_11525# 0.09398f
C672 VDD a_4111_14652# 0.01866f
C673 VDD a_19637_4687# 0.871f
C674 VDD a_2297_3176# 0.46603f
C675 CHAN2_MUX_SEL4 a_9757_4687# 0.01829f
C676 a_10713_16869# a_10843_16869# 0.70845f
C677 a_4187_2434# a_17683_16869# 0.06627f
C678 a_13883_16869# a_13470_16071# 0.01012f
C679 a_4187_2434# a_8563_7532# 0.06627f
C680 a_18877_14024# a_19524_13190# 0.02011f
C681 a_15273_14024# a_15837_14024# 0.0114f
C682 a_24008_13226# a_24084_13190# 0.01176f
C683 a_9444_10280# a_9444_9602# 2.19249f
C684 a_7477_7532# a_7945_6734# 0.19203f
C685 a_27997_7532# a_27563_7532# 0.69646f
C686 a_15108_11015# a_15464_9374# 0.12158f
C687 a_6717_4687# a_6283_4687# 0.6972f
C688 a_5731_5979# a_12993_4687# 0.01688f
C689 a_22243_4687# a_22351_4687# 0.01163f
C690 a_11277_1842# a_11473_1842# 0.76914f
C691 a_14311_1008# VDD 0.28336f
C692 CHAN1_MUX_SEL0 CHAN1_MUX_SEL1 3.14917f
C693 VDD REF_MUX_SEL3 0.421f
C694 a_4111_2470# a_4003_1842# 0.01697f
C695 VDD a_14751_17497# 0.01806f
C696 VDD a_10517_14024# 0.87095f
C697 VDD a_17275_13226# 0.15389f
C698 VDD a_22243_7532# 0.95024f
C699 VDD a_5191_3853# 0.28637f
C700 CHAN0_MUX_SEL4 a_7390_16071# 0.34655f
C701 CHAN1_MUX_OUT a_12355_11557# 0.05703f
C702 CHAN2_MUX_SEL0 a_1256_3889# 0.3314f
C703 a_7477_16869# a_7945_16071# 0.19203f
C704 a_21483_16869# a_21591_17497# 0.01697f
C705 a_5768_16071# a_5844_16035# 0.01176f
C706 a_6153_14024# a_6283_14024# 0.70845f
C707 a_8997_14024# a_8884_13190# 0.02055f
C708 a_12849_11557# a_13306_11995# 0.12097f
C709 a_6854_11676# a_13592_11113# 0.01519f
C710 a_4187_2434# a_21917_4687# 0.0414f
C711 a_7803_7532# a_7911_8160# 0.01697f
C712 a_18877_7532# a_19073_7532# 0.76914f
C713 a_1544_6734# a_1721_7085# 0.38063f
C714 a_1256_5979# a_1721_6021# 0.13421f
C715 a_23437_4687# a_24197_4687# 0.03319f
C716 a_15765_3308# a_15964_3134# 0.061f
C717 a_26477_1842# a_25630_1044# 0.08038f
C718 VDD a_13753_16869# 0.493f
C719 VDD a_21835_16071# 0.15406f
C720 VDD a_4633_7532# 0.49285f
C721 VDD a_9751_6698# 0.2822f
C722 VDD a_25391_5315# 0.01806f
C723 VDD a_14317_1842# 0.87175f
C724 CHAN2_MUX_SEL4 a_4187_2434# 0.01921f
C725 a_18877_16869# a_19637_16869# 0.06198f
C726 a_1256_16071# a_1721_16422# 0.13421f
C727 a_1256_15316# a_1544_15316# 1.25711f
C728 a_4187_2434# a_12797_14024# 0.0414f
C729 a_14643_14024# a_14751_14652# 0.01697f
C730 a_8563_14024# a_8671_14024# 0.01163f
C731 a_4187_2434# a_24523_7532# 0.06661f
C732 a_23437_14024# a_23633_14024# 0.76914f
C733 a_5731_12471# a_6326_10280# 0.11352f
C734 a_21157_7532# a_21625_6734# 0.2079f
C735 a_12797_7532# a_13368_6734# 0.10864f
C736 a_9757_7532# a_10517_7532# 0.06198f
C737 a_16510_6734# a_16484_6698# 0.277f
C738 a_14317_4687# a_14643_4687# 0.01427f
C739 a_16108_5979# a_26043_4687# 0.01539f
C740 a_22590_3889# a_23355_3889# 0.39037f
C741 a_15837_1842# a_15831_1008# 0.02354f
C742 a_19550_1044# a_20391_1008# 0.28268f
C743 a_16851_309# VDD 0.51536f
C744 a_23763_1842# VDD 0.49688f
C745 VDD a_4157_16340# 0.48942f
C746 VDD a_6126_9506# 0.84321f
C747 VDD a_26477_14024# 0.87175f
C748 VDD a_16923_4687# 0.4982f
C749 CHAN3_MUX_SEL3 CHAN3_MUX_SEL4 0.75489f
C750 VDD a_26471_3853# 0.28357f
C751 CHAN3_MUX_SEL2 CHAN3_MUX_OUT 0.08497f
C752 CHAN0_MUX_SEL4 a_1544_15316# 0.47529f
C753 CHAN0_MUX_OUT a_1256_15316# 0.1134f
C754 CHAN0_MUX_SEL2 a_2297_15358# 0.10655f
C755 CHAN1_MUX_SEL4 a_4157_13495# 0.08229f
C756 CHAN2_MUX_SEL4 a_13470_3889# 0.256f
C757 a_12797_16869# a_13368_16071# 0.10864f
C758 a_21157_16869# a_21625_16071# 0.2079f
C759 a_9757_16869# a_10083_16869# 0.01427f
C760 a_4187_2434# a_16033_16869# 0.11222f
C761 a_16408_16071# a_16484_16035# 0.01176f
C762 a_18117_14024# a_18004_13190# 0.02055f
C763 a_14317_14024# a_15077_14024# 0.03319f
C764 a_16108_15316# a_26477_14024# 0.01319f
C765 a_4187_2434# a_6913_7532# 0.11222f
C766 a_22590_13226# a_22564_13190# 0.277f
C767 a_13592_11113# a_14757_10872# 0.43239f
C768 a_14111_10917# a_13880_10808# 0.12701f
C769 a_13470_13226# a_5731_12471# 0.41365f
C770 a_5957_7532# a_6425_6734# 0.2079f
C771 a_26673_7532# a_27237_7532# 0.0114f
C772 a_4350_6734# a_5115_6734# 0.39037f
C773 a_5393_4687# a_5957_4687# 0.0114f
C774 a_5731_5979# a_11277_4687# 0.01319f
C775 a_26803_4687# a_26911_5315# 0.01697f
C776 a_20723_4687# a_20831_4687# 0.01163f
C777 a_20105_3889# a_20315_3889# 0.09424f
C778 a_7803_4687# a_7390_3889# 0.01012f
C779 a_10430_3889# a_11271_3853# 0.28268f
C780 a_9953_1842# a_10083_1842# 0.70845f
C781 a_15545_1044# a_15755_1044# 0.09424f
C782 a_7390_1044# a_8808_1044# 0.38994f
C783 a_11848_1044# VDD 0.17499f
C784 a_3449_1395# CHAN3_MUX_SEL0 0.10753f
C785 a_26043_1842# a_4187_2434# 0.06627f
C786 CHAN0_MUX_SEL4 CHAN0_MUX_OUT 0.91933f
C787 VDD a_7803_14024# 0.50058f
C788 VDD a_8671_17497# 0.01806f
C789 VDD a_20593_7532# 0.49419f
C790 VDD a_14311_13190# 0.28336f
C791 VDD a_24665_3889# 0.29742f
C792 REF_CLK a_10649_11568# 0.25484f
C793 a_5957_16869# a_6425_16071# 0.2079f
C794 a_26673_16869# a_26803_16869# 0.70845f
C795 a_19963_16869# a_20071_17497# 0.01697f
C796 a_4350_16071# a_4324_16035# 0.277f
C797 a_9465_16071# a_9751_16035# 0.01885f
C798 a_5197_14024# a_5523_14024# 0.01427f
C799 a_5731_15316# a_10713_14024# 0.01865f
C800 a_13557_14024# a_14025_13226# 0.19203f
C801 a_8237_14024# a_7390_13226# 0.08038f
C802 a_21625_13226# a_19550_13226# 0.03208f
C803 a_10430_13226# a_11195_13226# 0.39037f
C804 a_4187_2434# a_19203_4687# 0.06627f
C805 a_12355_11557# a_12656_11554# 0.03277f
C806 a_6854_11676# a_15304_10295# 0.08165f
C807 a_17553_7532# a_17683_7532# 0.70845f
C808 a_21917_7532# a_22488_6734# 0.10864f
C809 a_6283_7532# a_6391_8160# 0.01697f
C810 a_22677_4687# a_22243_4687# 0.69698f
C811 a_5731_3134# a_15964_3134# 0.2778f
C812 a_20397_1842# a_20593_1842# 0.76914f
C813 a_24957_1842# a_24951_1008# 0.02354f
C814 VDD a_12037_16869# 0.86065f
C815 a_7390_1044# a_9323_1842# 0.01012f
C816 VDD a_18871_16035# 0.2822f
C817 VDD a_15464_9374# 0.52511f
C818 VDD a_7288_6734# 0.17274f
C819 VDD a_19311_5315# 0.01806f
C820 VDD a_11603_1842# 0.49753f
C821 REF_MUX_SEL4 a_4187_2434# 0.01921f
C822 CHAN2_MUX_SEL4 a_15765_3308# 0.65508f
C823 a_21917_16869# a_22488_16071# 0.10864f
C824 a_4187_2434# a_10083_14024# 0.06627f
C825 a_18117_16869# a_17683_16869# 0.6972f
C826 a_27048_16071# a_27124_16035# 0.01176f
C827 a_7043_14024# a_7151_14024# 0.01163f
C828 a_13123_14024# a_13231_14652# 0.01697f
C829 a_22113_14024# a_22243_14024# 0.70361f
C830 a_27237_14024# a_27124_13190# 0.02055f
C831 a_4187_2434# a_22873_7532# 0.11231f
C832 a_5731_12471# a_15765_12645# 0.23301f
C833 a_8997_7532# a_8563_7532# 0.6972f
C834 a_12797_7532# a_10430_6734# 0.02479f
C835 a_16108_5979# a_24393_4687# 0.01872f
C836 a_13557_4687# a_13753_4687# 0.73897f
C837 a_16923_4687# a_16510_3889# 0.01012f
C838 a_18795_1044# a_18871_1008# 0.01194f
C839 a_22113_1842# VDD 0.55735f
C840 VDD a_23763_14024# 0.49688f
C841 VDD a_16851_12491# 0.51536f
C842 VDD a_15273_4687# 0.4946f
C843 CHAN3_DELAY_IN CHAN3_MUX_SEL1 0.01858f
C844 VDD a_24008_3889# 0.17499f
C845 CHAN1_MUX_SEL0 a_2873_13577# 0.01504f
C846 a_4187_2434# a_14317_16869# 0.04141f
C847 a_8997_16869# a_9193_16869# 0.77122f
C848 a_12797_16869# a_10430_16071# 0.02479f
C849 a_16108_15316# a_23763_14024# 0.01544f
C850 a_13557_14024# a_13123_14024# 0.69698f
C851 a_4187_2434# a_5197_7532# 0.04141f
C852 a_17357_14024# a_16510_13226# 0.08038f
C853 a_27237_14024# a_27705_13226# 0.2079f
C854 a_4187_2434# a_13883_1842# 0.06627f
C855 a_15304_10295# a_14757_10872# 0.02225f
C856 a_9465_6734# a_7390_6734# 0.03208f
C857 a_4437_7532# a_4157_7003# 0.01771f
C858 a_25717_7532# a_26477_7532# 0.01669f
C859 a_5731_5979# a_8563_4687# 0.01544f
C860 a_4437_4687# a_5197_4687# 0.01669f
C861 a_9675_3889# a_9751_3853# 0.01194f
C862 a_19203_4687# a_19311_4687# 0.01163f
C863 a_12037_4687# a_12505_3889# 0.2079f
C864 a_25283_4687# a_25391_5315# 0.01697f
C865 a_6717_4687# a_7288_3889# 0.10864f
C866 a_8884_1008# VDD 0.28225f
C867 a_24393_1842# a_4187_2434# 0.11222f
C868 CHAN0_MUX_SEL0 CHAN0_MUX_SEL1 3.14917f
C869 a_25913_1842# a_16108_3134# 0.01865f
C870 VDD a_27997_16869# 0.76025f
C871 VDD a_6153_14024# 0.4946f
C872 VDD a_18877_7532# 0.87825f
C873 VDD a_11848_13226# 0.17499f
C874 VDD a_1256_5979# 0.4205f
C875 VDD a_12505_3889# 0.29876f
C876 a_4437_16869# a_4157_16340# 0.01771f
C877 a_18443_16869# a_18551_17497# 0.01697f
C878 a_7945_16071# a_7390_16071# 0.03209f
C879 a_4187_2434# a_26043_14024# 0.06627f
C880 a_4437_14024# a_4633_14024# 0.73897f
C881 a_5731_15316# a_8997_14024# 0.01319f
C882 a_6717_14024# a_6711_13190# 0.02354f
C883 a_4187_2434# a_17553_4687# 0.11222f
C884 a_4763_7532# a_4871_8160# 0.01697f
C885 a_21917_7532# a_19550_6734# 0.02479f
C886 a_21353_4687# a_21917_4687# 0.0114f
C887 a_25630_6734# a_26395_6734# 0.39037f
C888 a_16510_6734# a_16108_5979# 0.56108f
C889 a_26043_4687# a_25630_3889# 0.01012f
C890 a_5731_3134# a_8745_3364# 0.28635f
C891 a_19073_1842# a_19203_1842# 0.70845f
C892 a_23437_1842# a_24084_1008# 0.02312f
C893 CHAN1_MUX_OUT REF_DELAY_OUT_LAST 0.02664f
C894 VDD a_9323_16869# 0.4973f
C895 VDD a_16408_16071# 0.17274f
C896 VDD a_13231_5315# 0.01806f
C897 VDD a_4350_6734# 0.87635f
C898 VDD a_9953_1842# 0.49655f
C899 CHAN1_MUX_SEL4 a_9757_14024# 0.01829f
C900 REF_MUX_OUT a_1256_6734# 0.02199f
C901 REF_MUX_SEL0 a_2297_7085# 0.10655f
C902 REF_MUX_SEL4 a_1544_6734# 0.03407f
C903 CHAN2_MUX_SEL4 a_5731_3134# 4.60702f
C904 a_4187_2434# a_8433_14024# 0.11222f
C905 a_21917_16869# a_19550_16071# 0.02479f
C906 a_16793_16869# a_17357_16869# 0.0114f
C907 a_11603_14024# a_11711_14652# 0.01697f
C908 a_4187_2434# a_21157_7532# 0.04188f
C909 a_25630_16071# a_25604_16035# 0.277f
C910 a_5523_14024# a_5631_14024# 0.01163f
C911 a_16510_16071# a_15964_15316# 0.05416f
C912 a_26477_14024# a_25630_13226# 0.08038f
C913 a_7673_7532# a_8237_7532# 0.0114f
C914 a_13470_6734# a_14311_6698# 0.28268f
C915 a_10517_7532# a_10404_6698# 0.05157f
C916 a_12233_4687# a_12363_4687# 0.70361f
C917 a_25717_4687# a_26185_3889# 0.19203f
C918 a_19550_3889# a_20968_3889# 0.38994f
C919 a_15837_4687# a_16408_3889# 0.10864f
C920 a_17275_1044# a_17351_1008# 0.01194f
C921 a_16510_1044# a_18004_1008# 0.28279f
C922 a_4350_1044# a_5705_519# 0.02005f
C923 a_20397_1842# VDD 0.87175f
C924 a_5705_519# VDD 0.29556f
C925 VDD a_22113_14024# 0.55574f
C926 VDD a_23111_8160# 0.01806f
C927 VDD a_13557_4687# 0.87034f
C928 VDD a_21044_3853# 0.28225f
C929 CHAN2_MUX_SEL2 CHAN2_MUX_OUT 0.08497f
C930 CHAN2_MUX_SEL3 CHAN2_MUX_SEL4 0.75489f
C931 CHAN1_MUX_SEL0 a_1256_13226# 0.3314f
C932 DLL_RESETN a_9444_9602# 0.03031f
C933 a_7673_16869# a_7803_16869# 0.70845f
C934 a_4187_2434# a_11603_16869# 0.06627f
C935 a_24665_16071# a_24951_16035# 0.01885f
C936 a_10517_16869# a_10404_16035# 0.05157f
C937 a_13470_16071# a_14235_16071# 0.39037f
C938 a_16108_15316# a_22113_14024# 0.01872f
C939 a_12233_14024# a_12797_14024# 0.0114f
C940 a_19550_13226# a_20391_13190# 0.28268f
C941 a_15837_14024# a_15831_13190# 0.02354f
C942 a_4187_2434# a_12233_1842# 0.11169f
C943 a_13132_11110# a_13306_10795# 0.27179f
C944 a_24957_7532# a_24523_7532# 0.6972f
C945 a_17683_4687# a_17791_4687# 0.01163f
C946 a_23763_4687# a_23871_5315# 0.01697f
C947 a_5731_5979# a_6913_4687# 0.01872f
C948 a_6717_4687# a_4350_3889# 0.02479f
C949 a_7390_3889# a_8884_3853# 0.28279f
C950 a_15545_3889# a_15831_3853# 0.01885f
C951 a_8155_3889# a_8231_3853# 0.01194f
C952 a_8237_1842# a_8433_1842# 0.76914f
C953 a_10985_1044# a_11195_1044# 0.09424f
C954 a_4350_1044# a_6635_1044# 0.39036f
C955 a_6635_1044# VDD 0.15407f
C956 a_22677_1842# a_4187_2434# 0.04058f
C957 a_24197_1842# a_16108_3134# 0.01319f
C958 VDD a_25283_16869# 0.49737f
C959 VDD a_8884_13190# 0.28225f
C960 VDD a_4437_14024# 0.87156f
C961 VDD a_16163_7532# 0.4973f
C962 VDD a_3449_4240# 0.46731f
C963 VDD a_25630_6734# 0.90165f
C964 a_4187_2434# a_24393_14024# 0.11222f
C965 a_16923_16869# a_17031_17497# 0.01697f
C966 a_24957_16869# a_25153_16869# 0.76914f
C967 a_5731_15316# a_6283_14024# 0.01542f
C968 a_5197_14024# a_5844_13190# 0.02312f
C969 a_4187_2434# a_15837_4687# 0.0414f
C970 a_7390_13226# a_8808_13226# 0.38994f
C971 a_15545_13226# a_15755_13226# 0.09424f
C972 a_10520_11982# a_10751_11568# 0.12701f
C973 a_15837_7532# a_16033_7532# 0.76914f
C974 a_19637_7532# a_19524_6698# 0.05157f
C975 a_20397_4687# a_21157_4687# 0.03319f
C976 a_24957_4687# a_25528_3889# 0.10864f
C977 a_19550_1044# a_20905_519# 0.02165f
C978 a_22677_1842# a_22590_1044# 0.1088f
C979 a_27671_2470# VDD 0.01806f
C980 a_16108_289# CHAN3_MUX_OUT 0.24265f
C981 VDD a_13470_16071# 0.87936f
C982 VDD a_7673_16869# 0.49294f
C983 VDD a_13132_11110# 0.23866f
C984 VDD a_20105_6734# 0.30409f
C985 VDD a_8237_1842# 0.87175f
C986 VDD a_7151_5315# 0.01806f
C987 CHAN1_MUX_SEL4 a_13470_13226# 0.256f
C988 CHAN2_MUX_SEL3 a_2873_3176# 0.12606f
C989 CHAN2_MUX_SEL2 a_3449_3176# 0.10741f
C990 CHAN2_MUX_SEL4 a_2297_3176# 0.04338f
C991 a_4187_2434# a_27563_16869# 0.06629f
C992 a_15837_16869# a_16597_16869# 0.06198f
C993 a_19637_16869# a_19524_16035# 0.05157f
C994 a_4187_2434# a_6717_14024# 0.0414f
C995 a_4187_2434# a_18443_7532# 0.06661f
C996 a_10083_14024# a_10191_14652# 0.01697f
C997 a_20397_14024# a_20593_14024# 0.76914f
C998 a_4003_14024# a_4111_14024# 0.01163f
C999 a_24957_14024# a_24951_13190# 0.02354f
C1000 a_6717_7532# a_7477_7532# 0.06198f
C1001 a_24665_6734# a_22590_6734# 0.03208f
C1002 a_12715_6734# a_12791_6698# 0.01194f
C1003 a_15837_4687# a_13470_3889# 0.02479f
C1004 a_11277_4687# a_11603_4687# 0.01427f
C1005 a_16108_5979# a_19963_4687# 0.01539f
C1006 a_17683_1842# VDD 0.49684f
C1007 a_27915_1044# VDD 0.15389f
C1008 VDD a_5705_12701# 0.29556f
C1009 VDD a_20397_14024# 0.87175f
C1010 VDD a_17031_8160# 0.01806f
C1011 VDD a_18795_3889# 0.15407f
C1012 VDD a_10843_4687# 0.50064f
C1013 CHAN2_DELAY_IN CHAN2_MUX_SEL1 0.01858f
C1014 a_6717_16869# a_7043_16869# 0.01427f
C1015 a_4187_2434# a_9953_16869# 0.11222f
C1016 a_23145_16071# a_22590_16071# 0.03209f
C1017 a_14317_14024# a_14964_13190# 0.02312f
C1018 a_16108_15316# a_20397_14024# 0.01319f
C1019 a_11277_14024# a_12037_14024# 0.03319f
C1020 a_18795_13226# a_18871_13190# 0.01194f
C1021 a_23633_7532# a_24197_7532# 0.0114f
C1022 a_4187_2434# a_10517_1842# 0.0414f
C1023 a_15964_5979# a_16108_5979# 0.42202f
C1024 a_22243_4687# a_22351_5315# 0.01697f
C1025 a_4437_4687# a_4324_3853# 0.05157f
C1026 a_16163_4687# a_16271_4687# 0.01163f
C1027 a_5731_3134# a_13883_1842# 0.01539f
C1028 a_6913_1842# a_7043_1842# 0.70845f
C1029 a_14025_3889# a_13470_3889# 0.03209f
C1030 a_26477_1842# a_26043_1842# 0.6972f
C1031 a_19963_1842# a_4187_2434# 0.06627f
C1032 a_21483_1842# a_16108_3134# 0.01542f
C1033 VDD a_15765_15490# 0.36528f
C1034 VDD a_23633_16869# 0.49425f
C1035 VDD a_6635_13226# 0.15407f
C1036 VDD a_14513_7532# 0.49436f
C1037 VDD a_22564_6698# 0.28964f
C1038 CHAN1_MUX_SEL4 a_15765_12645# 0.65508f
C1039 a_15403_16869# a_15511_17497# 0.01697f
C1040 a_23633_16869# a_23763_16869# 0.70845f
C1041 a_4187_2434# a_22677_14024# 0.04055f
C1042 a_4437_14024# a_4350_13226# 0.1088f
C1043 a_15765_15490# a_16108_15316# 0.42004f
C1044 a_10206_11525# a_10232_11561# 0.36952f
C1045 a_4187_2434# a_13123_4687# 0.0643f
C1046 a_14513_7532# a_14643_7532# 0.70845f
C1047 a_22590_6734# a_24008_6734# 0.38994f
C1048 a_1256_3889# a_2873_4240# 0.28892f
C1049 a_19637_4687# a_19203_4687# 0.69698f
C1050 a_24957_4687# a_22590_3889# 0.02479f
C1051 a_17357_1842# a_17553_1842# 0.76914f
C1052 a_25630_1044# a_27915_1044# 0.39036f
C1053 a_21591_2470# VDD 0.01806f
C1054 a_5768_1044# a_5197_1842# 0.10863f
C1055 VDD a_10404_16035# 0.28633f
C1056 VDD a_5957_16869# 0.85889f
C1057 VDD a_27671_14652# 0.01806f
C1058 VDD a_7945_6734# 0.30409f
C1059 VDD a_26803_4687# 0.49718f
C1060 VDD a_5523_1842# 0.49684f
C1061 a_4187_2434# a_25913_16869# 0.11222f
C1062 a_15077_16869# a_14643_16869# 0.6972f
C1063 a_4187_2434# a_4003_14024# 0.05992f
C1064 a_22590_16071# a_23431_16035# 0.28268f
C1065 a_19073_14024# a_19203_14024# 0.70845f
C1066 a_8563_14024# a_8671_14652# 0.01697f
C1067 a_4187_2434# a_16793_7532# 0.11284f
C1068 a_23437_14024# a_24084_13190# 0.02312f
C1069 a_8997_7532# a_7390_6734# 0.05231f
C1070 a_8237_7532# a_8231_6698# 0.02349f
C1071 a_5957_7532# a_5523_7532# 0.6972f
C1072 a_11195_6734# a_11271_6698# 0.01194f
C1073 a_10430_6734# a_11924_6698# 0.28279f
C1074 a_10517_4687# a_10713_4687# 0.73897f
C1075 a_13557_4687# a_13444_3853# 0.05157f
C1076 a_16108_5979# a_18313_4687# 0.02026f
C1077 a_16510_3889# a_18795_3889# 0.39036f
C1078 a_26185_1044# a_26395_1044# 0.09424f
C1079 a_13470_1044# a_15831_1008# 0.26208f
C1080 a_24951_1008# VDD 0.2822f
C1081 a_16033_1842# VDD 0.49413f
C1082 VDD a_17683_14024# 0.49684f
C1083 VDD a_27915_13226# 0.15389f
C1084 VDD a_9193_4687# 0.4946f
C1085 VDD a_10951_8160# 0.01806f
C1086 REF_MUX_SEL2 REF_MUX_OUT 0.08497f
C1087 VDD a_15831_3853# 0.2816f
C1088 REF_MUX_SEL3 REF_MUX_SEL4 0.75489f
C1089 REF_CLK a_13306_10795# 0.06166f
C1090 a_8997_16869# a_7390_16071# 0.05231f
C1091 a_8237_16869# a_8231_16035# 0.02349f
C1092 a_4187_2434# a_8237_16869# 0.04141f
C1093 a_5957_16869# a_6153_16869# 0.77122f
C1094 a_10430_16071# a_11848_16071# 0.38994f
C1095 a_20105_16071# a_20391_16035# 0.01885f
C1096 a_13557_14024# a_13470_13226# 0.1088f
C1097 a_16108_15316# a_17683_14024# 0.01562f
C1098 a_10517_14024# a_10083_14024# 0.69698f
C1099 a_13019_11521# a_15688_11093# 0.1287f
C1100 a_17275_13226# a_17351_13190# 0.01194f
C1101 a_4350_13226# a_5705_12701# 0.02005f
C1102 a_15688_11557# a_15304_10295# 0.19136f
C1103 a_12849_11557# a_14851_10872# 0.13376f
C1104 a_16510_13226# a_18004_13190# 0.28279f
C1105 a_4187_2434# a_7803_1842# 0.06627f
C1106 a_13121_11521# a_15108_11015# 0.05903f
C1107 a_22677_7532# a_23437_7532# 0.01323f
C1108 a_21917_7532# a_16108_5979# 0.01053f
C1109 a_4350_3889# a_6711_3853# 0.26208f
C1110 a_14643_4687# a_14751_4687# 0.01163f
C1111 a_10985_3889# a_11271_3853# 0.01885f
C1112 a_20723_4687# a_20831_5315# 0.01697f
C1113 a_5731_3134# a_12233_1842# 0.01121f
C1114 a_25153_1842# a_25717_1842# 0.0114f
C1115 a_17065_1044# VDD 0.30218f
C1116 a_18313_1842# a_4187_2434# 0.11222f
C1117 a_19833_1842# a_16108_3134# 0.01865f
C1118 a_14888_1044# a_14317_1842# 0.10863f
C1119 VDD a_5731_15316# 0.98095f
C1120 VDD a_21917_16869# 0.89148f
C1121 VDD a_12797_7532# 0.87928f
C1122 VDD a_20315_6734# 0.15389f
C1123 CHAN0_MUX_SEL4 a_1544_16071# 0.03407f
C1124 CHAN0_MUX_OUT a_1256_16071# 0.02199f
C1125 CHAN0_MUX_SEL0 a_2297_16422# 0.10655f
C1126 CHAN1_MUX_SEL4 a_5731_12471# 4.60702f
C1127 a_13883_16869# a_13991_17497# 0.01697f
C1128 a_21917_16869# a_16108_15316# 0.01053f
C1129 a_4187_2434# a_19963_14024# 0.06627f
C1130 a_5731_15316# a_16108_15316# 0.01334f
C1131 a_4187_2434# a_11473_4687# 0.11222f
C1132 a_4350_13226# a_6635_13226# 0.39036f
C1133 a_9746_11495# a_9772_11533# 0.1657f
C1134 a_10985_13226# a_11195_13226# 0.09424f
C1135 a_18117_7532# a_16510_6734# 0.05231f
C1136 a_17357_7532# a_17351_6698# 0.02349f
C1137 a_18313_4687# a_18877_4687# 0.0114f
C1138 a_22677_4687# a_22564_3853# 0.05157f
C1139 a_16033_1842# a_16163_1842# 0.70845f
C1140 a_15511_2470# VDD 0.01806f
C1141 a_5705_519# CHAN3_MUX_SEL4 0.03556f
C1142 VDD REF_CLK 2.53971f
C1143 a_2019_311# CHAN3_MUX_SEL3 0.06209f
C1144 VDD a_8155_16071# 0.15389f
C1145 VDD a_21591_14652# 0.01806f
C1146 VDD a_2873_7085# 0.46517f
C1147 VDD a_25153_4687# 0.49655f
C1148 VDD a_26985_3364# 0.29292f
C1149 a_4187_2434# a_24197_16869# 0.04152f
C1150 a_17357_16869# a_17351_16035# 0.02349f
C1151 a_18117_16869# a_16510_16071# 0.05231f
C1152 a_13753_16869# a_14317_16869# 0.0114f
C1153 a_21835_16071# a_21911_16035# 0.01194f
C1154 a_7043_14024# a_7151_14652# 0.01697f
C1155 a_4187_2434# a_15077_7532# 0.04237f
C1156 a_22677_14024# a_22590_13226# 0.1088f
C1157 a_19550_13226# a_20905_12701# 0.02165f
C1158 a_4633_7532# a_5197_7532# 0.0114f
C1159 a_6717_7532# a_7364_6698# 0.02011f
C1160 a_9193_4687# a_9323_4687# 0.70845f
C1161 a_16108_5979# a_16597_4687# 0.01319f
C1162 a_18585_6734# a_18795_6734# 0.09424f
C1163 a_14317_1842# a_13883_1842# 0.6972f
C1164 a_13368_1044# a_13470_1044# 0.37183f
C1165 a_22488_1044# VDD 0.1824f
C1166 VDD a_16033_14024# 0.49413f
C1167 VDD a_24951_13190# 0.2822f
C1168 VDD a_4871_8160# 0.01806f
C1169 VDD a_7477_4687# 0.871f
C1170 VDD a_13368_3889# 0.17274f
C1171 DLL_RESETN a_15304_10295# 0.03137f
C1172 a_4187_2434# a_5523_16869# 0.06627f
C1173 a_6717_16869# a_7364_16035# 0.02011f
C1174 a_4633_16869# a_4763_16869# 0.70845f
C1175 a_9193_14024# a_9757_14024# 0.0114f
C1176 a_16108_15316# a_16033_14024# 0.01197f
C1177 a_12849_11557# a_13566_11018# 0.26617f
C1178 a_4187_2434# a_27433_4687# 0.11222f
C1179 a_14111_11568# a_14851_11918# 0.26905f
C1180 a_4187_2434# a_6153_1842# 0.11222f
C1181 a_26477_7532# a_26471_6698# 0.02349f
C1182 a_21917_7532# a_21483_7532# 0.6972f
C1183 a_27237_7532# a_25630_6734# 0.05253f
C1184 a_26477_4687# a_26673_4687# 0.76914f
C1185 a_13123_4687# a_13231_4687# 0.01163f
C1186 a_19203_4687# a_19311_5315# 0.01697f
C1187 a_4248_3889# a_4350_3889# 0.37183f
C1188 a_5197_1842# a_5393_1842# 0.76914f
C1189 a_5731_3134# a_10517_1842# 0.01314f
C1190 a_24197_1842# a_24957_1842# 0.02912f
C1191 a_6425_1044# a_4350_1044# 0.03208f
C1192 a_24957_1842# a_16108_289# 0.0157f
C1193 a_16108_289# a_20905_519# 0.2906f
C1194 a_6425_1044# VDD 0.29742f
C1195 a_16597_1842# a_4187_2434# 0.0414f
C1196 a_18117_1842# a_16108_3134# 0.01644f
C1197 VDD a_19203_16869# 0.49737f
C1198 VDD a_2297_15358# 0.46603f
C1199 VDD a_10083_7532# 0.49727f
C1200 VDD a_17065_13226# 0.30218f
C1201 VDD a_17351_6698# 0.28637f
C1202 CHAN1_MUX_SEL2 a_3449_12513# 0.10741f
C1203 CHAN1_MUX_SEL3 a_2873_12513# 0.12606f
C1204 CHAN1_MUX_SEL4 a_2297_12513# 0.04338f
C1205 a_4187_2434# a_18313_14024# 0.11222f
C1206 a_12363_16869# a_12471_17497# 0.01697f
C1207 a_21917_16869# a_22113_16869# 0.76914f
C1208 a_26477_16869# a_26471_16035# 0.02349f
C1209 a_27237_16869# a_25630_16071# 0.05253f
C1210 a_26477_14024# a_26043_14024# 0.6972f
C1211 a_4187_2434# a_9757_4687# 0.0414f
C1212 a_6126_9506# a_6854_11144# 0.22705f
C1213 a_12797_7532# a_12993_7532# 0.74917f
C1214 a_15837_7532# a_16484_6698# 0.02011f
C1215 a_19550_6734# a_21835_6734# 0.39036f
C1216 a_17357_4687# a_18117_4687# 0.03319f
C1217 a_25630_3889# a_27991_3853# 0.26208f
C1218 a_13470_1044# a_14825_519# 0.02058f
C1219 a_9431_2470# VDD 0.01806f
C1220 VDD CHAN1_DELAY_OUT_LAST 0.46919f
C1221 a_1256_289# CHAN3_MUX_SEL2 0.33134f
C1222 VDD a_5191_16035# 0.28637f
C1223 VDD a_15511_14652# 0.01806f
C1224 VDD a_1256_6734# 0.48292f
C1225 VDD a_13121_11521# 0.99842f
C1226 VDD a_23437_4687# 0.87123f
C1227 VDD a_14825_3364# 0.29292f
C1228 a_12797_16869# a_13557_16869# 0.05851f
C1229 a_15837_16869# a_16484_16035# 0.02011f
C1230 a_4187_2434# a_21483_16869# 0.06627f
C1231 a_19550_16071# a_21044_16035# 0.28279f
C1232 a_4187_2434# a_12363_7532# 0.06482f
C1233 a_5523_14024# a_5631_14652# 0.01697f
C1234 a_20315_16071# a_20391_16035# 0.01194f
C1235 a_17357_14024# a_17553_14024# 0.76914f
C1236 a_25630_13226# a_27915_13226# 0.39036f
C1237 a_5957_7532# a_5844_6698# 0.02055f
C1238 a_7390_6734# a_9751_6698# 0.26208f
C1239 a_8237_4687# a_8563_4687# 0.01427f
C1240 a_26185_3889# a_26471_3853# 0.01885f
C1241 a_11277_4687# a_11271_3853# 0.02349f
C1242 a_12037_4687# a_10430_3889# 0.05231f
C1243 a_12993_1842# a_13557_1842# 0.0114f
C1244 a_15077_1842# a_15545_1044# 0.2079f
C1245 a_21625_1044# a_21911_1008# 0.01885f
C1246 a_11848_1044# a_11924_1008# 0.01176f
C1247 a_19550_1044# VDD 0.8993f
C1248 VDD CHAN3_MUX_SEL2 0.51768f
C1249 VDD a_26151_17497# 0.01806f
C1250 VDD a_14317_14024# 0.87175f
C1251 VDD a_26043_7532# 0.4973f
C1252 VDD a_22488_13226# 0.1824f
C1253 VDD a_4763_4687# 0.49875f
C1254 VDD a_10430_3889# 1.08486f
C1255 REF_MUX_SEL4 a_1256_5979# 0.65005f
C1256 REF_MUX_SEL3 a_1544_5979# 0.15976f
C1257 REF_MUX_SEL2 a_1721_6021# 0.01315f
C1258 a_5957_16869# a_5844_16035# 0.02055f
C1259 a_7390_16071# a_9675_16071# 0.39036f
C1260 a_8237_14024# a_8997_14024# 0.03319f
C1261 a_26185_13226# a_26395_13226# 0.09424f
C1262 a_4187_2434# a_25717_4687# 0.0414f
C1263 a_13470_13226# a_15831_13190# 0.26208f
C1264 a_4187_2434# a_4437_1842# 0.0414f
C1265 a_13592_11561# a_14111_11568# 0.34102f
C1266 a_6326_10280# a_9712_9602# 0.04737f
C1267 a_14009_11568# a_13880_11982# 0.01562f
C1268 a_20593_7532# a_21157_7532# 0.0114f
C1269 a_13019_11521# a_15304_10295# 0.07025f
C1270 a_24957_7532# a_25604_6698# 0.02011f
C1271 a_25153_4687# a_25283_4687# 0.70845f
C1272 a_5705_6209# a_5731_5979# 0.28954f
C1273 a_17683_4687# a_17791_5315# 0.01697f
C1274 a_11603_4687# a_11711_4687# 0.01163f
C1275 a_5731_3134# a_7803_1842# 0.01539f
C1276 a_23437_1842# a_23003_1842# 0.6972f
C1277 VDD a_17553_16869# 0.49417f
C1278 VDD a_6425_13226# 0.2975f
C1279 VDD a_26471_16035# 0.28357f
C1280 VDD a_8433_7532# 0.49417f
C1281 VDD a_14888_6734# 0.17499f
C1282 REF_MUX_SEL4 a_4350_6734# 0.31434f
C1283 a_20593_16869# a_20723_16869# 0.70845f
C1284 a_10843_16869# a_10951_17497# 0.01697f
C1285 a_24957_16869# a_25604_16035# 0.02011f
C1286 a_4187_2434# a_16597_14024# 0.0414f
C1287 a_25153_14024# a_25717_14024# 0.0114f
C1288 a_4187_2434# a_7043_4687# 0.06627f
C1289 a_11473_7532# a_11603_7532# 0.70845f
C1290 a_15077_7532# a_14964_6698# 0.02055f
C1291 a_16597_4687# a_16163_4687# 0.69698f
C1292 a_20397_4687# a_20391_3853# 0.02349f
C1293 a_21157_4687# a_19550_3889# 0.05231f
C1294 a_25528_3889# a_25630_3889# 0.37183f
C1295 a_22488_1044# a_22564_1008# 0.01176f
C1296 a_18443_1842# a_16510_1044# 0.01012f
C1297 a_27563_1842# VDD 0.50391f
C1298 VDD CHAN0_DELAY_OUT_LAST 0.46312f
C1299 VDD a_24665_16071# 0.29722f
C1300 VDD a_9431_14652# 0.01806f
C1301 VDD a_11491_11918# 0.16908f
C1302 VDD a_20723_4687# 0.49691f
C1303 a_4187_2434# a_19833_16869# 0.11222f
C1304 a_12037_16869# a_11603_16869# 0.6972f
C1305 a_15077_16869# a_14964_16035# 0.02055f
C1306 a_4003_14024# a_4111_14652# 0.01697f
C1307 a_4187_2434# a_10713_7532# 0.11222f
C1308 a_16033_14024# a_16163_14024# 0.70845f
C1309 a_8997_7532# a_9465_6734# 0.2079f
C1310 a_14025_6734# a_14235_6734# 0.09424f
C1311 a_5197_7532# a_4350_6734# 0.08038f
C1312 a_7288_6734# a_7390_6734# 0.37183f
C1313 a_7477_4687# a_7673_4687# 0.73897f
C1314 a_5731_5979# a_15077_4687# 0.01319f
C1315 a_9757_4687# a_10404_3853# 0.02011f
C1316 a_13368_3889# a_13444_3853# 0.01176f
C1317 a_12037_1842# a_12797_1842# 0.02912f
C1318 a_10430_1044# a_10404_1008# 0.277f
C1319 a_20105_1044# a_19550_1044# 0.03209f
C1320 a_16484_1008# VDD 0.28597f
C1321 VDD CHAN2_MUX_SEL2 0.692f
C1322 CHAN1_MUX_SEL3 CHAN1_MUX_OUT 0.79533f
C1323 VDD a_20071_17497# 0.01806f
C1324 VDD a_11603_14024# 0.49753f
C1325 VDD a_19550_13226# 0.8993f
C1326 VDD a_24393_7532# 0.49285f
C1327 VDD a_17865_6209# 0.29444f
C1328 VDD a_7364_3853# 0.28633f
C1329 REF_CLK a_13306_11995# 0.05059f
C1330 a_8997_16869# a_9465_16071# 0.2079f
C1331 a_15545_16071# a_13470_16071# 0.03208f
C1332 a_5197_16869# a_4350_16071# 0.08038f
C1333 a_5731_15316# a_14513_14024# 0.01872f
C1334 a_7477_14024# a_7043_14024# 0.69698f
C1335 a_13368_13226# a_13470_13226# 0.37183f
C1336 a_4187_2434# a_23003_4687# 0.06391f
C1337 a_19637_7532# a_20397_7532# 0.01669f
C1338 a_12849_11557# a_12943_11557# 0.16706f
C1339 a_24197_7532# a_24084_6698# 0.02055f
C1340 a_10083_4687# a_10191_4687# 0.01163f
C1341 a_16163_4687# a_16271_5315# 0.01697f
C1342 a_4905_3889# a_5115_3889# 0.09424f
C1343 a_5731_3134# a_6153_1842# 0.02026f
C1344 a_16108_3134# a_23945_3364# 0.2906f
C1345 a_22113_1842# a_22677_1842# 0.0114f
C1346 a_2019_311# a_16851_309# 0.01299f
C1347 a_5731_289# a_14825_519# 0.28056f
C1348 a_27563_1842# a_25630_1044# 0.01024f
C1349 a_10430_1044# a_10843_1842# 0.01012f
C1350 VDD a_24008_16071# 0.17499f
C1351 VDD a_15837_16869# 0.87963f
C1352 VDD a_11924_6698# 0.28225f
C1353 VDD a_6717_7532# 0.87726f
C1354 REF_DELAY_OUT_LAST a_14111_10917# 0.02024f
C1355 a_9323_16869# a_9431_17497# 0.01697f
C1356 a_24197_16869# a_24084_16035# 0.02055f
C1357 a_4187_2434# a_13883_14024# 0.06627f
C1358 a_22590_16071# a_23945_15546# 0.02165f
C1359 a_4187_2434# a_26673_7532# 0.11284f
C1360 a_24197_14024# a_24957_14024# 0.02912f
C1361 a_24957_14024# a_16108_12471# 0.0157f
C1362 a_6425_13226# a_4350_13226# 0.03208f
C1363 a_16108_12471# a_20905_12701# 0.2906f
C1364 a_4187_2434# a_5393_4687# 0.11222f
C1365 a_14317_7532# a_13470_6734# 0.08038f
C1366 a_22677_7532# a_23145_6734# 0.19203f
C1367 a_15273_4687# a_15837_4687# 0.0114f
C1368 a_18877_4687# a_19524_3853# 0.02011f
C1369 a_24008_3889# a_24084_3853# 0.01176f
C1370 a_10430_1044# a_5731_289# 0.41176f
C1371 a_25913_1842# VDD 0.49553f
C1372 VDD a_12505_16071# 0.29855f
C1373 VDD a_27563_14024# 0.50391f
C1374 VDD a_19073_4687# 0.49655f
C1375 VDD a_1721_3176# 0.45365f
C1376 a_10713_16869# a_11277_16869# 0.0114f
C1377 a_4187_2434# a_18117_16869# 0.04152f
C1378 a_22677_16869# a_23145_16071# 0.19203f
C1379 a_14317_16869# a_13470_16071# 0.08038f
C1380 a_16510_16071# a_18871_16035# 0.26208f
C1381 a_4187_2434# a_8997_7532# 0.04152f
C1382 a_13470_13226# a_14825_12701# 0.02058f
C1383 a_14851_10872# a_15464_9374# 0.04797f
C1384 a_27433_7532# a_27563_7532# 0.70845f
C1385 a_9444_10280# a_5778_9057# 0.19787f
C1386 a_5768_6734# a_5844_6698# 0.01176f
C1387 a_6153_4687# a_6283_4687# 0.70845f
C1388 a_8997_4687# a_8884_3853# 0.02055f
C1389 a_11277_1842# a_10843_1842# 0.6972f
C1390 a_17065_1044# a_17351_1008# 0.01885f
C1391 a_14235_1044# VDD 0.1539f
C1392 VDD REF_MUX_SEL2 0.692f
C1393 VDD a_9953_14024# 0.49655f
C1394 VDD a_13991_17497# 0.01806f
C1395 VDD a_16484_13190# 0.28597f
C1396 VDD a_22677_7532# 0.91482f
C1397 VDD a_5115_3889# 0.15389f
C1398 CHAN0_DELAY_IN a_4003_16869# 0.54998f
C1399 a_27997_16869# a_27563_16869# 0.69646f
C1400 a_6153_14024# a_6717_14024# 0.0114f
C1401 a_5731_15316# a_12797_14024# 0.01307f
C1402 a_15077_14024# a_15545_13226# 0.2079f
C1403 a_9323_14024# a_7390_13226# 0.01012f
C1404 a_21625_13226# a_21911_13190# 0.01885f
C1405 a_4187_2434# a_5731_3134# 0.14779f
C1406 a_13019_11521# a_13045_11905# 0.01249f
C1407 a_11848_13226# a_11924_13190# 0.01176f
C1408 a_13121_11521# a_13306_11995# 0.01008f
C1409 a_4187_2434# a_21353_4687# 0.11222f
C1410 a_18877_7532# a_18443_7532# 0.6972f
C1411 a_1256_6734# a_1721_7085# 0.13421f
C1412 a_1256_5979# a_1544_5979# 1.25711f
C1413 a_23437_7532# a_22590_6734# 0.08038f
C1414 a_23437_4687# a_23633_4687# 0.76914f
C1415 a_8563_4687# a_8671_4687# 0.01163f
C1416 a_14643_4687# a_14751_5315# 0.01697f
C1417 a_21157_1842# a_21917_1842# 0.02912f
C1418 a_18877_1842# a_16108_289# 0.0157f
C1419 a_10328_1044# a_9757_1842# 0.10864f
C1420 VDD a_21044_16035# 0.28225f
C1421 VDD a_13123_16869# 0.48169f
C1422 VDD a_4003_7532# 0.61559f
C1423 VDD a_9675_6734# 0.15406f
C1424 VDD a_13753_1842# 0.49559f
C1425 VDD a_24631_5315# 0.01806f
C1426 a_18877_16869# a_19073_16869# 0.76914f
C1427 a_7803_16869# a_7911_17497# 0.01697f
C1428 a_4187_2434# a_12233_14024# 0.11169f
C1429 a_1256_16071# a_1544_16071# 1.26509f
C1430 a_23437_16869# a_22590_16071# 0.08038f
C1431 a_4187_2434# a_24957_7532# 0.04176f
C1432 a_23437_14024# a_23003_14024# 0.6972f
C1433 a_12797_7532# a_12791_6698# 0.02354f
C1434 a_9757_7532# a_9953_7532# 0.76914f
C1435 a_16408_6734# a_16484_6698# 0.01176f
C1436 a_18117_4687# a_18004_3853# 0.02055f
C1437 a_16108_5979# a_26477_4687# 0.01319f
C1438 a_14317_4687# a_15077_4687# 0.03319f
C1439 a_13470_3889# a_5731_3134# 0.41365f
C1440 a_22590_3889# a_22564_3853# 0.277f
C1441 a_7390_1044# a_8745_519# 0.01756f
C1442 a_19550_1044# a_20315_1044# 0.39037f
C1443 a_24197_1842# VDD 0.85957f
C1444 a_16108_289# VDD 1.25511f
C1445 VDD a_3449_16422# 0.46731f
C1446 VDD a_25913_14024# 0.49553f
C1447 VDD a_6854_11676# 1.32146f
C1448 VDD a_17357_4687# 0.87016f
C1449 CHAN3_MUX_SEL2 CHAN3_MUX_SEL4 0.01978f
C1450 CHAN3_MUX_SEL1 CHAN3_MUX_OUT 0.05651f
C1451 VDD a_26395_3889# 0.1539f
C1452 CHAN0_MUX_SEL2 a_1721_15358# 0.01315f
C1453 CHAN0_MUX_SEL4 a_1256_15316# 0.65005f
C1454 CHAN0_MUX_SEL3 a_1544_15316# 0.15976f
C1455 a_9757_16869# a_10517_16869# 0.06198f
C1456 a_12797_16869# a_12791_16035# 0.02354f
C1457 a_4187_2434# a_15403_16869# 0.06627f
C1458 a_16408_16071# a_16510_16071# 0.37183f
C1459 a_14317_14024# a_14513_14024# 0.76914f
C1460 a_18443_14024# a_16510_13226# 0.01012f
C1461 a_4187_2434# a_6283_7532# 0.06627f
C1462 a_16108_15316# a_25913_14024# 0.01865f
C1463 a_14009_10774# a_13880_10808# 0.01562f
C1464 a_22488_13226# a_22564_13190# 0.01176f
C1465 a_26477_7532# a_26803_7532# 0.01427f
C1466 a_5731_5979# a_10713_4687# 0.01865f
C1467 a_9465_6734# a_9751_6698# 0.01885f
C1468 a_4350_6734# a_4324_6698# 0.277f
C1469 a_5197_4687# a_5523_4687# 0.01427f
C1470 a_21625_3889# a_19550_3889# 0.03208f
C1471 a_10430_3889# a_11195_3889# 0.39037f
C1472 a_13557_4687# a_14025_3889# 0.19203f
C1473 a_8237_4687# a_7390_3889# 0.08038f
C1474 a_9953_1842# a_10517_1842# 0.0114f
C1475 a_7390_1044# a_8231_1008# 0.28268f
C1476 a_11271_1008# VDD 0.28336f
C1477 a_4157_1313# CHAN3_DELAY_IN 0.50642f
C1478 CHAN0_MUX_SEL3 CHAN0_MUX_OUT 0.79533f
C1479 CHAN0_MUX_SEL2 CHAN1_DELAY_IN 0.1765f
C1480 a_26477_1842# a_4187_2434# 0.04144f
C1481 VDD a_8237_14024# 0.87181f
C1482 VDD a_7911_17497# 0.01806f
C1483 VDD a_14235_13226# 0.1539f
C1484 VDD a_19963_7532# 0.4973f
C1485 VDD a_23145_3889# 0.30411f
C1486 CHAN0_MUX_SEL4 a_4350_16071# 0.31434f
C1487 DLL_RESETN a_10649_11568# 0.05713f
C1488 REF_CLK a_10232_11561# 0.08086f
C1489 REF_MUX_SEL4 a_12797_7532# 0.01829f
C1490 a_26673_16869# a_27237_16869# 0.0114f
C1491 a_5731_15316# a_10083_14024# 0.01539f
C1492 a_5197_14024# a_5957_14024# 0.03319f
C1493 a_9465_16071# a_9675_16071# 0.09424f
C1494 a_4248_16071# a_4324_16035# 0.01176f
C1495 a_4187_2434# a_19637_4687# 0.0414f
C1496 a_20105_13226# a_19550_13226# 0.03209f
C1497 a_10430_13226# a_10404_13190# 0.277f
C1498 a_21917_7532# a_21911_6698# 0.02354f
C1499 a_17553_7532# a_18117_7532# 0.0114f
C1500 a_27048_6734# a_27124_6698# 0.01176f
C1501 a_22113_4687# a_22243_4687# 0.70361f
C1502 a_7043_4687# a_7151_4687# 0.01163f
C1503 a_27237_4687# a_27124_3853# 0.02055f
C1504 a_13123_4687# a_13231_5315# 0.01697f
C1505 a_5731_3134# a_15765_3308# 0.23301f
C1506 a_20397_1842# a_19963_1842# 0.6972f
C1507 a_5705_519# a_2019_311# 0.13872f
C1508 a_25630_1044# a_16108_289# 0.52614f
C1509 REF_CLK REF_MUX_SEL4 0.0663f
C1510 VDD a_11473_16869# 0.49426f
C1511 a_7390_1044# a_9757_1842# 0.02479f
C1512 VDD a_18795_16071# 0.15406f
C1513 VDD a_6711_6698# 0.2822f
C1514 VDD a_18551_5315# 0.01806f
C1515 VDD a_12037_1842# 0.86131f
C1516 REF_MUX_SEL1 a_3449_7085# 0.29404f
C1517 CHAN2_MUX_SEL4 a_14825_3364# 0.03307f
C1518 a_17553_16869# a_17683_16869# 0.70845f
C1519 a_4187_2434# a_10517_14024# 0.0414f
C1520 a_21917_16869# a_21911_16035# 0.02354f
C1521 a_6283_16869# a_6391_17497# 0.01697f
C1522 a_4187_2434# a_22243_7532# 0.06322f
C1523 a_22113_14024# a_22677_14024# 0.0114f
C1524 a_27563_14024# a_25630_13226# 0.01024f
C1525 a_8433_7532# a_8563_7532# 0.70845f
C1526 a_5731_12471# a_14825_12701# 0.28056f
C1527 a_11277_7532# a_11924_6698# 0.02312f
C1528 a_16108_5979# a_23763_4687# 0.01544f
C1529 a_13557_4687# a_13123_4687# 0.69698f
C1530 a_17357_4687# a_16510_3889# 0.08038f
C1531 a_27237_4687# a_27705_3889# 0.2079f
C1532 a_21483_1842# VDD 0.50072f
C1533 VDD a_24197_14024# 0.85958f
C1534 VDD a_16108_12471# 1.25511f
C1535 VDD a_14643_4687# 0.49684f
C1536 CHAN3_DELAY_IN CHAN3_MUX_SEL0 0.10102f
C1537 VDD a_23431_3853# 0.28357f
C1538 CHAN2_MUX_SEL4 a_10430_3889# 0.21179f
C1539 a_8997_16869# a_8563_16869# 0.6972f
C1540 a_4187_2434# a_13753_16869# 0.11222f
C1541 a_11277_16869# a_11924_16035# 0.02312f
C1542 a_14888_16071# a_14964_16035# 0.01176f
C1543 a_4187_2434# a_4633_7532# 0.11222f
C1544 a_16108_15316# a_24197_14024# 0.01319f
C1545 a_12993_14024# a_13123_14024# 0.70361f
C1546 a_4187_2434# a_14317_1842# 0.0414f
C1547 a_10430_13226# a_5731_12471# 0.41176f
C1548 a_14009_10774# a_14111_10917# 0.47622f
C1549 a_7945_6734# a_7390_6734# 0.03209f
C1550 a_25717_7532# a_25913_7532# 0.73897f
C1551 a_4437_4687# a_4633_4687# 0.73897f
C1552 a_5731_5979# a_8997_4687# 0.01319f
C1553 a_6717_4687# a_6711_3853# 0.02354f
C1554 a_8997_1842# a_9757_1842# 0.02912f
C1555 a_6635_1044# a_6711_1008# 0.01194f
C1556 a_8808_1044# VDD 0.17499f
C1557 a_1544_1044# CHAN3_MUX_SEL1 0.1672f
C1558 a_1721_1395# CHAN3_MUX_SEL0 0.01315f
C1559 a_23763_1842# a_4187_2434# 0.06627f
C1560 a_25283_1842# a_16108_3134# 0.01539f
C1561 VDD a_27433_16869# 0.49285f
C1562 VDD a_5523_14024# 0.49684f
C1563 VDD a_18313_7532# 0.49285f
C1564 VDD a_11271_13190# 0.28336f
C1565 VDD a_10985_3889# 0.30411f
C1566 VDD a_27991_6698# 0.28273f
C1567 a_25717_16869# a_26477_16869# 0.01669f
C1568 a_4187_2434# a_26477_14024# 0.04144f
C1569 a_4437_14024# a_4003_14024# 0.69698f
C1570 a_4187_2434# a_6126_9506# 0.01821f
C1571 a_5731_15316# a_8433_14024# 0.01872f
C1572 a_17065_13226# a_17351_13190# 0.01885f
C1573 a_4187_2434# a_16923_4687# 0.06627f
C1574 a_16597_7532# a_17357_7532# 0.01669f
C1575 a_11491_11918# a_11397_11918# 0.28931f
C1576 a_20397_7532# a_21044_6698# 0.02312f
C1577 a_11603_4687# a_11711_5315# 0.01697f
C1578 a_25630_6734# a_25604_6698# 0.277f
C1579 a_5523_4687# a_5631_4687# 0.01163f
C1580 a_16510_6734# a_15964_5979# 0.05416f
C1581 a_26477_4687# a_25630_3889# 0.08038f
C1582 a_19073_1842# a_19637_1842# 0.0114f
C1583 a_1544_1044# a_2297_1395# 0.28651f
C1584 a_23437_1842# a_24008_1044# 0.10863f
C1585 a_7364_1008# a_7477_1842# 0.05157f
C1586 VDD a_9757_16869# 0.87771f
C1587 VDD a_15831_16035# 0.2816f
C1588 VDD a_9444_10280# 0.01557f
C1589 VDD a_4248_6734# 0.17587f
C1590 VDD a_12471_5315# 0.02372f
C1591 VDD a_9323_1842# 0.50001f
C1592 REF_MUX_SEL4 a_1256_6734# 0.04785f
C1593 a_20397_16869# a_21044_16035# 0.02312f
C1594 a_4187_2434# a_7803_14024# 0.06627f
C1595 a_4763_16869# a_4871_17497# 0.01697f
C1596 a_25528_16071# a_25604_16035# 0.01176f
C1597 a_4187_2434# a_20593_7532# 0.11287f
C1598 a_21157_14024# a_21917_14024# 0.02912f
C1599 a_18877_14024# a_16108_12471# 0.0157f
C1600 a_10517_7532# a_10430_6734# 0.1088f
C1601 a_24665_6734# a_24951_6698# 0.01885f
C1602 a_13470_6734# a_14235_6734# 0.39037f
C1603 a_12233_4687# a_12797_4687# 0.0114f
C1604 a_16108_5979# a_22113_4687# 0.01872f
C1605 a_19550_3889# a_20391_3853# 0.28268f
C1606 a_15837_4687# a_15831_3853# 0.02354f
C1607 a_16510_1044# a_17928_1044# 0.38994f
C1608 a_19833_1842# VDD 0.49553f
C1609 a_3449_331# VDD 0.46596f
C1610 VDD a_21483_14024# 0.50072f
C1611 VDD a_22351_8160# 0.02349f
C1612 VDD a_20968_3889# 0.17499f
C1613 VDD a_12993_4687# 0.49665f
C1614 CHAN2_MUX_SEL2 CHAN2_MUX_SEL4 0.01978f
C1615 CHAN2_MUX_SEL1 CHAN2_MUX_OUT 0.05651f
C1616 DLL_RESETN a_5778_9057# 0.01215f
C1617 REF_DELAY_OUT_LAST a_27997_7532# 0.70957f
C1618 REF_MUX_SEL4 a_4763_4687# 0.01225f
C1619 a_4187_2434# a_12037_16869# 0.04152f
C1620 a_7673_16869# a_8237_16869# 0.0114f
C1621 a_24665_16071# a_24875_16071# 0.09424f
C1622 a_13470_16071# a_13444_16035# 0.277f
C1623 a_10517_16869# a_10430_16071# 0.1088f
C1624 a_16108_15316# a_21483_14024# 0.01542f
C1625 a_19550_13226# a_20315_13226# 0.39037f
C1626 a_7390_13226# a_8745_12701# 0.01756f
C1627 a_24393_7532# a_24523_7532# 0.70845f
C1628 a_4187_2434# a_11603_1842# 0.06627f
C1629 a_5197_4687# a_5844_3853# 0.02312f
C1630 a_5731_5979# a_6283_4687# 0.01542f
C1631 a_7390_3889# a_8808_3889# 0.38994f
C1632 a_15545_3889# a_15755_3889# 0.09424f
C1633 a_8237_1842# a_7803_1842# 0.6972f
C1634 a_27237_1842# a_27433_1842# 0.77122f
C1635 a_12505_1044# a_10430_1044# 0.03208f
C1636 a_4350_1044# a_5844_1008# 0.28279f
C1637 a_5115_1044# a_5191_1008# 0.01194f
C1638 a_5844_1008# VDD 0.28225f
C1639 a_22113_1842# a_4187_2434# 0.11169f
C1640 a_23633_1842# a_16108_3134# 0.01872f
C1641 VDD a_25717_16869# 0.86712f
C1642 VDD a_26985_15546# 0.29292f
C1643 VDD a_8808_13226# 0.17499f
C1644 VDD a_16597_7532# 0.86886f
C1645 VDD a_25528_6734# 0.17274f
C1646 a_4905_16071# a_5191_16035# 0.01885f
C1647 a_4187_2434# a_23763_14024# 0.06627f
C1648 a_24957_16869# a_24523_16869# 0.6972f
C1649 a_5731_15316# a_6717_14024# 0.01307f
C1650 a_16108_15316# a_26985_15546# 0.27952f
C1651 a_5197_14024# a_5768_13226# 0.10863f
C1652 a_4187_2434# a_15273_4687# 0.11222f
C1653 a_7390_13226# a_8231_13190# 0.28268f
C1654 a_15837_7532# a_15403_7532# 0.6972f
C1655 a_10232_11561# a_11491_11918# 0.01529f
C1656 a_19637_7532# a_19550_6734# 0.1088f
C1657 a_10083_4687# a_10191_5315# 0.01697f
C1658 a_20397_4687# a_20593_4687# 0.76914f
C1659 a_4003_4687# a_4111_4687# 0.01163f
C1660 a_24957_4687# a_24951_3853# 0.02354f
C1661 a_18117_1842# a_18877_1842# 0.02912f
C1662 a_27915_1044# a_27991_1008# 0.01194f
C1663 a_26911_2470# VDD 0.01806f
C1664 a_15964_289# CHAN3_MUX_OUT 0.01307f
C1665 a_16108_289# CHAN3_MUX_SEL4 0.1283f
C1666 VDD a_13368_16071# 0.17274f
C1667 VDD a_7043_16869# 0.49723f
C1668 VDD a_18585_6734# 0.29722f
C1669 VDD a_12907_11110# 0.07753f
C1670 VDD a_7673_1842# 0.49553f
C1671 VDD a_6391_5315# 0.01806f
C1672 CHAN2_MUX_OUT a_1544_3134# 0.69943f
C1673 CHAN2_MUX_SEL2 a_2873_3176# 0.01422f
C1674 CHAN2_MUX_SEL4 a_1721_3176# 0.05813f
C1675 CHAN2_MUX_SEL3 a_2297_3176# 0.01595f
C1676 a_15837_16869# a_16033_16869# 0.76914f
C1677 a_4187_2434# a_27997_16869# 0.04001f
C1678 a_19637_16869# a_19550_16071# 0.1088f
C1679 a_4187_2434# a_6153_14024# 0.11222f
C1680 a_4187_2434# a_18877_7532# 0.04176f
C1681 a_20397_14024# a_19963_14024# 0.6972f
C1682 a_25630_13226# a_16108_12471# 0.52614f
C1683 a_6717_7532# a_6913_7532# 0.76914f
C1684 a_23145_6734# a_22590_6734# 0.03209f
C1685 a_16108_5979# a_20397_4687# 0.01319f
C1686 a_11277_4687# a_12037_4687# 0.03319f
C1687 a_14317_4687# a_14964_3853# 0.02312f
C1688 a_18795_3889# a_18871_3853# 0.01194f
C1689 a_18117_1842# VDD 0.85955f
C1690 a_27124_1008# VDD 0.28225f
C1691 VDD a_19833_14024# 0.49553f
C1692 VDD a_3449_12513# 0.46689f
C1693 VDD a_16271_8160# 0.01806f
C1694 VDD a_18004_3853# 0.28225f
C1695 VDD a_11277_4687# 0.87192f
C1696 CHAN2_DELAY_IN CHAN2_MUX_SEL0 0.10102f
C1697 REF_MUX_OUT a_16851_5999# 0.45865f
C1698 a_4187_2434# a_9323_16869# 0.06627f
C1699 a_6717_16869# a_7477_16869# 0.06198f
C1700 a_16108_15316# a_19833_14024# 0.01865f
C1701 a_14317_14024# a_14888_13226# 0.10863f
C1702 a_11277_14024# a_11473_14024# 0.76914f
C1703 a_23437_7532# a_23763_7532# 0.01427f
C1704 a_4187_2434# a_9953_1842# 0.11222f
C1705 a_15765_6153# a_16108_5979# 0.42004f
C1706 a_4437_4687# a_4350_3889# 0.1088f
C1707 a_5731_3134# a_14317_1842# 0.01319f
C1708 a_6913_1842# a_7477_1842# 0.0114f
C1709 a_25913_1842# a_26043_1842# 0.70845f
C1710 a_27705_1044# VDD 0.29918f
C1711 a_20397_1842# a_4187_2434# 0.0414f
C1712 a_21917_1842# a_16108_3134# 0.01307f
C1713 VDD a_14825_15546# 0.29292f
C1714 VDD a_23003_16869# 0.48123f
C1715 VDD a_5844_13190# 0.28225f
C1716 VDD a_22590_6734# 0.98586f
C1717 VDD a_13883_7532# 0.49744f
C1718 VDD a_1721_4240# 0.4533f
C1719 CHAN0_MUX_SEL1 a_3449_16422# 0.29404f
C1720 CHAN1_MUX_SEL4 a_14825_12701# 0.03307f
C1721 REF_MUX_SEL4 a_6717_7532# 0.0195f
C1722 a_23633_16869# a_24197_16869# 0.0114f
C1723 a_4187_2434# a_22113_14024# 0.11169f
C1724 a_15765_15490# a_15964_15316# 0.061f
C1725 a_4187_2434# a_13557_4687# 0.04101f
C1726 a_9946_11995# a_10649_11568# 0.02432f
C1727 a_6635_13226# a_6711_13190# 0.01194f
C1728 a_14513_7532# a_15077_7532# 0.0114f
C1729 a_22590_6734# a_23431_6698# 0.28268f
C1730 a_19073_4687# a_19203_4687# 0.70845f
C1731 a_23437_4687# a_24084_3853# 0.02312f
C1732 a_8563_4687# a_8671_5315# 0.01697f
C1733 a_17357_1842# a_16923_1842# 0.6972f
C1734 a_25630_1044# a_27124_1008# 0.28279f
C1735 a_26395_1044# a_26471_1008# 0.01194f
C1736 a_20831_2470# VDD 0.01806f
C1737 a_4350_1044# a_5957_1842# 0.05231f
C1738 a_5191_1008# a_5197_1842# 0.02349f
C1739 VDD a_5393_16869# 0.49417f
C1740 VDD a_10430_16071# 1.08486f
C1741 VDD a_15688_11557# 0.30345f
C1742 VDD a_26911_14652# 0.01806f
C1743 VDD a_27237_4687# 0.86331f
C1744 VDD a_5957_1842# 0.85955f
C1745 CHAN1_MUX_SEL4 a_10430_13226# 0.21179f
C1746 a_4187_2434# a_25283_16869# 0.06627f
C1747 a_14513_16869# a_14643_16869# 0.70845f
C1748 a_4187_2434# a_4437_14024# 0.0414f
C1749 a_22590_16071# a_23355_16071# 0.39037f
C1750 a_4187_2434# a_16163_7532# 0.06661f
C1751 a_19073_14024# a_19637_14024# 0.0114f
C1752 a_1544_13226# a_2297_13577# 0.28651f
C1753 a_4187_2434# a_25630_6734# 0.02246f
C1754 a_23437_14024# a_24008_13226# 0.10863f
C1755 a_5393_7532# a_5523_7532# 0.70845f
C1756 a_10517_4687# a_10083_4687# 0.69698f
C1757 a_16108_5979# a_17683_4687# 0.01562f
C1758 a_20105_6734# a_20391_6698# 0.01885f
C1759 a_10430_6734# a_11848_6734# 0.38994f
C1760 a_13557_4687# a_13470_3889# 0.1088f
C1761 a_16510_3889# a_18004_3853# 0.28279f
C1762 a_4350_3889# a_5705_3364# 0.02005f
C1763 a_17275_3889# a_17351_3853# 0.01194f
C1764 a_27705_1044# a_25630_1044# 0.03208f
C1765 a_13470_1044# a_15755_1044# 0.39036f
C1766 a_15403_1842# VDD 0.4973f
C1767 a_24875_1044# VDD 0.15407f
C1768 VDD a_18117_14024# 0.85955f
C1769 VDD a_27124_13190# 0.28225f
C1770 VDD a_8563_4687# 0.49684f
C1771 VDD a_10191_8160# 0.01806f
C1772 REF_MUX_SEL1 REF_MUX_OUT 0.05651f
C1773 VDD a_15755_3889# 0.15389f
C1774 REF_MUX_SEL2 REF_MUX_SEL4 0.01978f
C1775 REF_CLK a_13566_11018# 0.01093f
C1776 a_4187_2434# a_7673_16869# 0.11222f
C1777 a_5957_16869# a_5523_16869# 0.6972f
C1778 a_20105_16071# a_20315_16071# 0.09424f
C1779 a_10430_16071# a_11271_16035# 0.28268f
C1780 a_9953_14024# a_10083_14024# 0.70845f
C1781 a_16108_15316# a_18117_14024# 0.01644f
C1782 a_16510_13226# a_17928_13226# 0.38994f
C1783 a_13121_11521# a_14851_10872# 0.03337f
C1784 a_14851_11918# a_15304_10295# 0.12139f
C1785 a_4187_2434# a_8237_1842# 0.0414f
C1786 a_22677_7532# a_22873_7532# 0.73022f
C1787 a_5731_5979# a_16108_5979# 0.01334f
C1788 a_10985_3889# a_11195_3889# 0.09424f
C1789 a_4350_3889# a_6635_3889# 0.39036f
C1790 a_5957_1842# a_6717_1842# 0.02912f
C1791 a_5731_3134# a_11603_1842# 0.01544f
C1792 a_24957_1842# a_25283_1842# 0.01427f
C1793 a_6425_1044# a_6711_1008# 0.01885f
C1794 a_15545_1044# VDD 0.29918f
C1795 a_17683_1842# a_4187_2434# 0.06627f
C1796 a_19203_1842# a_16108_3134# 0.01539f
C1797 a_14311_1008# a_14317_1842# 0.02349f
C1798 VDD a_21353_16869# 0.49294f
C1799 VDD a_12233_7532# 0.59709f
C1800 VDD a_27705_13226# 0.29918f
C1801 VDD a_19524_6698# 0.28633f
C1802 CHAN0_MUX_SEL4 a_1256_16071# 0.04785f
C1803 a_22677_16869# a_23437_16869# 0.01323f
C1804 a_5731_15316# a_15964_15316# 0.2778f
C1805 a_4187_2434# a_20397_14024# 0.0414f
C1806 a_5115_13226# a_5191_13190# 0.01194f
C1807 a_27237_14024# a_27433_14024# 0.77122f
C1808 a_12505_13226# a_10430_13226# 0.03208f
C1809 a_4350_13226# a_5844_13190# 0.28279f
C1810 a_4187_2434# a_10843_4687# 0.06627f
C1811 a_13557_7532# a_14317_7532# 0.01669f
C1812 a_21835_6734# a_21911_6698# 0.01194f
C1813 a_7043_4687# a_7151_5315# 0.01697f
C1814 a_22677_4687# a_22590_3889# 0.1088f
C1815 a_19550_3889# a_20905_3364# 0.02165f
C1816 a_19963_1842# a_19550_1044# 0.01012f
C1817 a_16033_1842# a_16597_1842# 0.0114f
C1818 a_14751_2470# VDD 0.01806f
C1819 a_3449_331# CHAN3_MUX_SEL4 0.05166f
C1820 VDD DLL_RESETN 2.68496f
C1821 VDD a_7364_16035# 0.28633f
C1822 VDD a_20831_14652# 0.01806f
C1823 VDD a_14009_11568# 0.25384f
C1824 VDD a_24523_4687# 0.50001f
C1825 VDD a_23945_3364# 0.29292f
C1826 CHAN0_MUX_SEL4 a_4763_14024# 0.01225f
C1827 a_4187_2434# a_23633_16869# 0.11222f
C1828 a_4187_2434# a_14513_7532# 0.12091f
C1829 a_18117_14024# a_18877_14024# 0.02912f
C1830 a_27915_13226# a_27991_13190# 0.01194f
C1831 a_9193_4687# a_9757_4687# 0.0114f
C1832 a_16108_5979# a_16033_4687# 0.01197f
C1833 a_13753_1842# a_13883_1842# 0.70845f
C1834 a_16597_1842# a_17065_1044# 0.19203f
C1835 a_21911_1008# VDD 0.2822f
C1836 VDD a_15403_14024# 0.4973f
C1837 VDD a_4111_8160# 0.01866f
C1838 VDD a_24875_13226# 0.15407f
C1839 VDD a_6913_4687# 0.49655f
C1840 VDD a_12791_3853# 0.28232f
C1841 a_4187_2434# a_5957_16869# 0.04152f
C1842 a_4633_16869# a_5197_16869# 0.0114f
C1843 a_9675_16071# a_9751_16035# 0.01194f
C1844 a_14111_11568# a_15108_11799# 0.03093f
C1845 a_4187_2434# a_5523_1842# 0.06627f
C1846 a_12849_11557# a_13132_11110# 0.06758f
C1847 a_4187_2434# a_26803_4687# 0.06627f
C1848 a_21353_7532# a_21483_7532# 0.70845f
C1849 a_26477_4687# a_26043_4687# 0.6972f
C1850 a_5197_1842# a_4763_1842# 0.6972f
C1851 a_5731_3134# a_9953_1842# 0.01872f
C1852 a_4905_1044# a_4350_1044# 0.03209f
C1853 a_4157_1313# a_4324_1008# 0.02463f
C1854 a_24197_1842# a_24393_1842# 0.77122f
C1855 a_16108_289# a_17865_519# 0.29564f
C1856 a_4905_1044# VDD 0.30126f
C1857 a_16033_1842# a_4187_2434# 0.11222f
C1858 a_17553_1842# a_16108_3134# 0.01872f
C1859 VDD a_19637_16869# 0.86712f
C1860 a_13444_1008# a_12797_1842# 0.02011f
C1861 VDD a_1721_15358# 0.45365f
C1862 VDD a_10517_7532# 0.86712f
C1863 VDD a_15545_13226# 0.29918f
C1864 VDD a_17275_6734# 0.15389f
C1865 CHAN1_MUX_SEL3 a_2297_12513# 0.01595f
C1866 CHAN1_MUX_OUT a_1544_12471# 0.69943f
C1867 CHAN1_MUX_SEL4 a_1721_12513# 0.05813f
C1868 CHAN1_MUX_SEL2 a_2873_12513# 0.01422f
C1869 a_4187_2434# a_17683_14024# 0.06627f
C1870 a_21917_16869# a_21483_16869# 0.6972f
C1871 a_5731_15316# a_8745_15546# 0.28635f
C1872 a_25913_14024# a_26043_14024# 0.70845f
C1873 a_4187_2434# a_9193_4687# 0.11222f
C1874 a_12797_7532# a_12363_7532# 0.6972f
C1875 a_6854_11676# a_6854_11144# 0.30877f
C1876 a_19550_6734# a_21044_6698# 0.28279f
C1877 a_5523_4687# a_5631_5315# 0.01697f
C1878 a_17357_4687# a_17553_4687# 0.76914f
C1879 a_20315_6734# a_20391_6698# 0.01194f
C1880 a_25630_3889# a_27915_3889# 0.39036f
C1881 a_15077_1842# a_15837_1842# 0.02912f
C1882 a_18877_1842# a_19448_1044# 0.10864f
C1883 a_22590_1044# a_24951_1008# 0.26208f
C1884 a_8671_2470# VDD 0.01806f
C1885 VDD CHAN1_DELAY_IN 1.50497f
C1886 VDD a_5115_16071# 0.15389f
C1887 VDD a_14751_14652# 0.01806f
C1888 VDD a_13019_11521# 0.42149f
C1889 VDD a_22873_4687# 0.49647f
C1890 VDD a_11785_3364# 0.29292f
C1891 CHAN0_MUX_OUT a_16851_15336# 0.45865f
C1892 a_4187_2434# a_21917_16869# 0.0414f
C1893 a_12797_16869# a_12993_16869# 0.74917f
C1894 a_4187_2434# a_5731_15316# 0.14779f
C1895 a_19550_16071# a_20968_16071# 0.38994f
C1896 a_17357_14024# a_16923_14024# 0.6972f
C1897 a_4187_2434# a_12797_7532# 0.0414f
C1898 a_9444_9602# a_5864_9057# 0.02483f
C1899 a_26395_13226# a_26471_13190# 0.01194f
C1900 a_25630_13226# a_27124_13190# 0.28279f
C1901 a_6283_7532# a_4350_6734# 0.01012f
C1902 a_10517_7532# a_10985_6734# 0.19203f
C1903 a_7390_6734# a_9675_6734# 0.39036f
C1904 a_8237_4687# a_8997_4687# 0.03319f
C1905 a_13470_3889# a_15831_3853# 0.26208f
C1906 a_26185_3889# a_26395_3889# 0.09424f
C1907 a_21625_1044# a_21835_1044# 0.09424f
C1908 a_19448_1044# VDD 0.17274f
C1909 VDD CHAN3_MUX_SEL1 0.5478f
C1910 VDD a_25391_17497# 0.01806f
C1911 VDD a_13753_14024# 0.49559f
C1912 VDD a_26477_7532# 0.86919f
C1913 VDD a_21911_13190# 0.2822f
C1914 VDD a_5197_4687# 0.87057f
C1915 VDD a_10328_3889# 0.17274f
C1916 REF_CLK a_4187_2434# 2.0411f
C1917 REF_MUX_SEL2 a_1544_5979# 0.07405f
C1918 REF_MUX_SEL3 a_1256_5979# 1.41161f
C1919 a_10517_16869# a_10985_16071# 0.19203f
C1920 a_15545_16071# a_15831_16035# 0.01885f
C1921 a_7390_16071# a_8884_16035# 0.28279f
C1922 a_8155_16071# a_8231_16035# 0.01194f
C1923 a_6283_16869# a_4350_16071# 0.01012f
C1924 a_8237_14024# a_8433_14024# 0.76914f
C1925 a_13470_13226# a_15755_13226# 0.39036f
C1926 a_27705_13226# a_25630_13226# 0.03208f
C1927 a_10843_14024# a_10430_13226# 0.01012f
C1928 a_4187_2434# a_25153_4687# 0.11222f
C1929 a_13592_11561# a_13880_11982# 0.43707f
C1930 a_20397_7532# a_20723_7532# 0.01427f
C1931 a_5974_11413# a_5778_9057# 2.88221f
C1932 a_25153_4687# a_25717_4687# 0.0114f
C1933 a_5731_3134# a_8237_1842# 0.01319f
C1934 a_22873_1842# a_23003_1842# 0.70361f
C1935 a_2297_1395# VDD 0.46536f
C1936 a_11924_1008# a_12037_1842# 0.02055f
C1937 VDD a_16923_16869# 0.4973f
C1938 VDD a_4905_13226# 0.3013f
C1939 VDD a_26395_16071# 0.15389f
C1940 VDD a_7803_7532# 0.4973f
C1941 VDD a_14311_6698# 0.28357f
C1942 a_20593_16869# a_21157_16869# 0.0114f
C1943 a_4187_2434# a_16033_14024# 0.11222f
C1944 a_24957_14024# a_25283_14024# 0.01427f
C1945 a_6425_13226# a_6711_13190# 0.01885f
C1946 a_4187_2434# a_7477_4687# 0.0414f
C1947 a_11473_7532# a_12037_7532# 0.0114f
C1948 a_15403_7532# a_13470_6734# 0.01012f
C1949 a_24197_7532# a_24665_6734# 0.2079f
C1950 a_4003_4687# a_4111_5315# 0.01697f
C1951 a_16033_4687# a_16163_4687# 0.70845f
C1952 a_18877_1842# a_16510_1044# 0.02479f
C1953 a_22488_1044# a_22590_1044# 0.37183f
C1954 a_27997_1842# VDD 0.76528f
C1955 VDD CHAN0_DELAY_IN 1.50763f
C1956 VDD a_23145_16071# 0.30409f
C1957 VDD a_8671_14652# 0.01806f
C1958 VDD a_11748_11799# 0.1686f
C1959 VDD a_21157_4687# 0.86003f
C1960 a_4187_2434# a_19203_16869# 0.06627f
C1961 a_11473_16869# a_11603_16869# 0.70845f
C1962 a_24197_16869# a_24665_16071# 0.2079f
C1963 a_15403_16869# a_13470_16071# 0.01012f
C1964 a_4187_2434# a_10083_7532# 0.06627f
C1965 a_16033_14024# a_16597_14024# 0.0114f
C1966 a_19963_14024# a_19550_13226# 0.01012f
C1967 a_15545_6734# a_13470_6734# 0.03208f
C1968 a_7477_4687# a_7043_4687# 0.69698f
C1969 a_5731_5979# a_14513_4687# 0.01872f
C1970 a_13368_3889# a_13470_3889# 0.37183f
C1971 a_12037_1842# a_12233_1842# 0.77122f
C1972 a_10328_1044# a_10404_1008# 0.01176f
C1973 a_16510_1044# VDD 0.8795f
C1974 CHAN1_MUX_SEL3 CHAN1_MUX_SEL4 0.75489f
C1975 CHAN1_MUX_SEL2 CHAN1_MUX_OUT 0.08497f
C1976 VDD CHAN2_MUX_SEL1 0.5478f
C1977 VDD a_19311_17497# 0.01806f
C1978 VDD a_19448_13226# 0.17274f
C1979 VDD a_12037_14024# 0.86131f
C1980 VDD a_23763_7532# 0.49674f
C1981 VDD a_16851_5999# 0.52304f
C1982 VDD a_7390_3889# 0.8686f
C1983 CHAN1_DELAY_OUT_LAST a_4187_2434# 0.21225f
C1984 REF_CLK a_12849_11557# 0.26363f
C1985 CHAN2_MUX_SEL1 a_2297_4240# 0.01995f
C1986 CHAN2_MUX_OUT a_1544_3889# 0.04258f
C1987 a_14025_16071# a_13470_16071# 0.03209f
C1988 a_9757_14024# a_10328_13226# 0.10864f
C1989 a_6913_14024# a_7043_14024# 0.70845f
C1990 a_5731_15316# a_13883_14024# 0.01539f
C1991 a_16597_14024# a_17065_13226# 0.19203f
C1992 a_4187_2434# a_23437_4687# 0.04012f
C1993 a_13121_11521# a_12943_11557# 0.09118f
C1994 a_19637_7532# a_19833_7532# 0.73897f
C1995 a_13306_11995# a_14009_11568# 0.02432f
C1996 a_6854_11144# a_9444_10280# 1.24134f
C1997 a_24523_7532# a_22590_6734# 0.01012f
C1998 a_15837_7532# a_15964_5979# 0.02f
C1999 a_22590_6734# a_23945_6209# 0.02165f
C2000 a_24197_4687# a_24957_4687# 0.02912f
C2001 a_16108_3134# a_20905_3364# 0.2906f
C2002 a_5731_3134# a_5523_1842# 0.01562f
C2003 a_6425_3889# a_4350_3889# 0.03208f
C2004 a_24957_4687# a_16108_3134# 0.0157f
C2005 a_21917_1842# a_22243_1842# 0.01427f
C2006 a_2019_311# a_16108_289# 0.33889f
C2007 a_5731_289# a_11785_519# 0.28056f
C2008 a_10430_1044# a_11277_1842# 0.08038f
C2009 VDD a_23431_16035# 0.28357f
C2010 VDD a_15273_16869# 0.49285f
C2011 VDD a_2297_13577# 0.46536f
C2012 VDD a_6153_7532# 0.49285f
C2013 VDD a_11848_6734# 0.17499f
C2014 REF_DELAY_OUT_LAST a_14009_10774# 0.25594f
C2015 a_19637_16869# a_20397_16869# 0.01669f
C2016 a_4187_2434# a_14317_14024# 0.0414f
C2017 a_1256_16071# a_2873_16422# 0.28892f
C2018 a_15837_16869# a_15964_15316# 0.02f
C2019 a_24523_16869# a_22590_16071# 0.01012f
C2020 a_24197_14024# a_24393_14024# 0.77122f
C2021 a_4187_2434# a_26043_7532# 0.06661f
C2022 a_4187_2434# a_4763_4687# 0.06627f
C2023 a_16108_12471# a_17865_12701# 0.29564f
C2024 a_4157_13495# a_4324_13190# 0.02463f
C2025 a_4905_13226# a_4350_13226# 0.03209f
C2026 a_10517_7532# a_11277_7532# 0.01669f
C2027 a_16510_6734# a_18871_6698# 0.26208f
C2028 a_13470_3889# a_14825_3364# 0.02058f
C2029 a_16597_1842# a_16484_1008# 0.05157f
C2030 a_20968_1044# a_21044_1008# 0.01176f
C2031 a_25283_1842# VDD 0.50004f
C2032 VDD a_10985_16071# 0.30409f
C2033 VDD a_9946_11995# 0.77235f
C2034 VDD a_27997_14024# 0.76528f
C2035 VDD a_18443_4687# 0.50001f
C2036 VDD a_1544_3134# 0.39372f
C2037 a_4187_2434# a_17553_16869# 0.11222f
C2038 a_16510_16071# a_18795_16071# 0.39036f
C2039 a_15077_14024# a_15837_14024# 0.02912f
C2040 a_4187_2434# a_8433_7532# 0.11222f
C2041 a_18877_14024# a_19448_13226# 0.10864f
C2042 a_22590_13226# a_24951_13190# 0.26208f
C2043 a_14851_10872# a_14757_10872# 0.28931f
C2044 a_27433_7532# a_27997_7532# 0.0114f
C2045 a_5731_5979# a_12797_4687# 0.01307f
C2046 a_6153_4687# a_6717_4687# 0.0114f
C2047 a_9323_4687# a_7390_3889# 0.01012f
C2048 a_15077_4687# a_15545_3889# 0.2079f
C2049 a_11848_3889# a_11924_3853# 0.01176f
C2050 a_10713_1842# a_10843_1842# 0.70845f
C2051 a_21625_3889# a_21911_3853# 0.01885f
C2052 a_17065_1044# a_17275_1044# 0.09424f
C2053 a_13444_1008# VDD 0.28633f
C2054 a_27563_1842# a_4187_2434# 0.06629f
C2055 CHAN1_DELAY_IN CHAN1_MUX_SEL1 0.01858f
C2056 VDD REF_MUX_SEL1 0.5478f
C2057 VDD a_13231_17497# 0.01806f
C2058 VDD a_9323_14024# 0.50001f
C2059 VDD a_16510_13226# 0.8795f
C2060 VDD a_22113_7532# 0.55345f
C2061 VDD a_4324_3853# 0.28687f
C2062 CHAN0_DELAY_OUT_LAST a_4187_2434# 0.21225f
C2063 CHAN0_DELAY_IN a_4437_16869# 0.05007f
C2064 REF_CLK a_12158_11557# 0.01309f
C2065 a_27433_16869# a_27563_16869# 0.70845f
C2066 a_4350_16071# a_6711_16035# 0.26208f
C2067 a_10985_16071# a_11271_16035# 0.01885f
C2068 a_5731_15316# a_12233_14024# 0.01121f
C2069 a_9757_14024# a_7390_13226# 0.02479f
C2070 a_13121_11521# a_12849_11557# 0.55272f
C2071 a_4187_2434# a_20723_4687# 0.06627f
C2072 a_21625_13226# a_21835_13226# 0.09424f
C2073 a_18313_7532# a_18443_7532# 0.70845f
C2074 a_1256_6734# a_1544_6734# 1.26509f
C2075 a_23437_4687# a_23003_4687# 0.6972f
C2076 a_21157_1842# a_21353_1842# 0.77122f
C2077 a_25717_1842# a_25604_1008# 0.05157f
C2078 a_9751_1008# a_9757_1842# 0.02354f
C2079 VDD a_13557_16869# 0.8672f
C2080 VDD a_20968_16071# 0.17499f
C2081 VDD a_4437_7532# 0.87051f
C2082 VDD a_8884_6698# 0.28225f
C2083 VDD a_23871_5315# 0.01806f
C2084 VDD a_13123_1842# 0.4839f
C2085 a_18877_16869# a_18443_16869# 0.6972f
C2086 a_4187_2434# a_11603_14024# 0.06627f
C2087 a_22873_14024# a_23003_14024# 0.70361f
C2088 a_4187_2434# a_24393_7532# 0.11284f
C2089 a_26803_7532# a_26911_7532# 0.01163f
C2090 a_9757_7532# a_9323_7532# 0.6972f
C2091 a_16108_5979# a_25913_4687# 0.01865f
C2092 a_16408_6734# a_16510_6734# 0.37183f
C2093 a_14317_4687# a_14513_4687# 0.76914f
C2094 a_18443_4687# a_16510_3889# 0.01012f
C2095 a_22488_3889# a_22564_3853# 0.01176f
C2096 a_7390_1044# a_5731_289# 0.41331f
C2097 a_19550_1044# a_19524_1008# 0.277f
C2098 a_23633_1842# VDD 0.49601f
C2099 a_15964_289# VDD 0.31312f
C2100 VDD a_25283_14024# 0.50004f
C2101 VDD a_5974_11413# 0.91632f
C2102 VDD a_16793_4687# 0.49408f
C2103 CHAN3_MUX_SEL1 CHAN3_MUX_SEL4 0.03574f
C2104 VDD a_25604_3853# 0.28633f
C2105 CHAN3_MUX_SEL2 CHAN3_MUX_SEL3 3.21891f
C2106 CHAN0_MUX_SEL3 a_1256_15316# 1.41161f
C2107 CHAN0_MUX_SEL2 a_1544_15316# 0.07405f
C2108 CHAN0_DELAY_IN a_3449_15358# 0.01017f
C2109 a_4187_2434# a_15837_16869# 0.0414f
C2110 a_9757_16869# a_9953_16869# 0.76914f
C2111 a_26803_16869# a_26911_16869# 0.01163f
C2112 a_16108_15316# a_25283_14024# 0.01539f
C2113 a_4187_2434# a_6717_7532# 0.0414f
C2114 a_18877_14024# a_16510_13226# 0.02479f
C2115 a_14317_14024# a_13883_14024# 0.6972f
C2116 a_22488_13226# a_22590_13226# 0.37183f
C2117 a_13592_11113# a_13880_10808# 0.43707f
C2118 a_26477_7532# a_27237_7532# 0.03319f
C2119 a_5731_5979# a_10083_4687# 0.01539f
C2120 a_9465_6734# a_9675_6734# 0.09424f
C2121 a_4248_6734# a_4324_6698# 0.01176f
C2122 a_5197_4687# a_5957_4687# 0.03319f
C2123 a_10430_3889# a_10404_3853# 0.277f
C2124 a_20105_3889# a_19550_3889# 0.03209f
C2125 a_9757_1842# a_10083_1842# 0.01427f
C2126 a_7390_1044# a_8155_1044# 0.39037f
C2127 a_11195_1044# VDD 0.1539f
C2128 a_3449_1395# CHAN3_DELAY_IN 0.01058f
C2129 a_2873_1395# CHAN3_MUX_SEL1 0.13092f
C2130 CHAN0_MUX_SEL3 CHAN0_MUX_SEL4 0.75489f
C2131 CHAN0_MUX_SEL2 CHAN0_MUX_OUT 0.08497f
C2132 a_25913_1842# a_4187_2434# 0.11222f
C2133 VDD a_7673_14024# 0.49553f
C2134 VDD a_7151_17497# 0.01806f
C2135 VDD a_13444_13190# 0.28633f
C2136 VDD a_20397_7532# 0.86919f
C2137 VDD a_5705_6209# 0.29556f
C2138 VDD a_21625_3889# 0.29742f
C2139 DLL_RESETN a_10232_11561# 0.39088f
C2140 a_26477_16869# a_26803_16869# 0.01427f
C2141 a_4187_2434# a_27563_14024# 0.06629f
C2142 a_5197_14024# a_5393_14024# 0.76914f
C2143 a_5731_15316# a_10517_14024# 0.01314f
C2144 a_4248_16071# a_4350_16071# 0.37183f
C2145 a_4187_2434# a_19073_4687# 0.11222f
C2146 a_7477_14024# a_7364_13190# 0.05157f
C2147 a_10328_13226# a_10404_13190# 0.01176f
C2148 a_17357_7532# a_17683_7532# 0.01427f
C2149 a_22113_4687# a_22677_4687# 0.0114f
C2150 a_27563_4687# a_25630_3889# 0.01024f
C2151 a_5731_3134# a_14825_3364# 0.28056f
C2152 a_19833_1842# a_19963_1842# 0.70845f
C2153 a_3449_331# a_2019_311# 0.01176f
C2154 VDD a_10843_16869# 0.49736f
C2155 a_8884_1008# a_8237_1842# 0.02312f
C2156 VDD a_18004_16035# 0.28225f
C2157 VDD a_17791_5315# 0.01806f
C2158 VDD a_6635_6734# 0.15406f
C2159 VDD a_11473_1842# 0.49601f
C2160 REF_MUX_SEL0 a_3449_7085# 0.10753f
C2161 CHAN2_MUX_SEL4 a_11785_3364# 0.03255f
C2162 a_4187_2434# a_9953_14024# 0.11222f
C2163 a_17553_16869# a_18117_16869# 0.0114f
C2164 a_25630_16071# a_27991_16035# 0.26208f
C2165 a_4187_2434# a_22677_7532# 0.04065f
C2166 a_21917_14024# a_22243_14024# 0.01427f
C2167 a_5731_12471# a_11785_12701# 0.28056f
C2168 a_8433_7532# a_8997_7532# 0.0114f
C2169 a_25283_7532# a_25391_7532# 0.01163f
C2170 a_11277_7532# a_11848_6734# 0.10863f
C2171 a_12993_4687# a_13123_4687# 0.70361f
C2172 a_16108_5979# a_24197_4687# 0.01319f
C2173 a_14888_6734# a_14964_6698# 0.01176f
C2174 a_10430_3889# a_5731_3134# 0.41176f
C2175 a_15077_1842# a_13470_1044# 0.05231f
C2176 a_21917_1842# VDD 0.89571f
C2177 a_8745_519# VDD 0.29292f
C2178 VDD a_1721_16422# 0.4533f
C2179 VDD a_23633_14024# 0.49601f
C2180 VDD a_27671_8160# 0.01806f
C2181 VDD a_15964_12471# 0.31312f
C2182 VDD a_15077_4687# 0.86122f
C2183 VDD a_23355_3889# 0.1539f
C2184 CHAN1_MUX_SEL1 a_2297_13577# 0.01995f
C2185 CHAN1_MUX_OUT a_1544_13226# 0.04258f
C2186 a_8433_16869# a_8563_16869# 0.70845f
C2187 a_4187_2434# a_13123_16869# 0.0643f
C2188 a_25283_16869# a_25391_16869# 0.01163f
C2189 a_11277_16869# a_11848_16071# 0.10863f
C2190 a_26185_16071# a_26471_16035# 0.01885f
C2191 a_16108_15316# a_23633_14024# 0.01872f
C2192 a_4187_2434# a_4003_7532# 0.05992f
C2193 a_12993_14024# a_13557_14024# 0.0114f
C2194 a_16597_14024# a_16484_13190# 0.05157f
C2195 a_13592_11113# a_14111_10917# 0.34114f
C2196 a_4187_2434# a_13753_1842# 0.11222f
C2197 a_20968_13226# a_21044_13190# 0.01176f
C2198 a_25717_7532# a_25283_7532# 0.69698f
C2199 a_4437_4687# a_4003_4687# 0.69698f
C2200 a_5731_5979# a_8433_4687# 0.01872f
C2201 a_17065_3889# a_17351_3853# 0.01885f
C2202 a_8997_1842# a_9193_1842# 0.77122f
C2203 a_12505_1044# a_12791_1008# 0.01885f
C2204 a_8231_1008# VDD 0.28336f
C2205 a_1256_1044# CHAN3_MUX_SEL1 1.44243f
C2206 a_1544_1044# CHAN3_MUX_SEL0 0.07603f
C2207 a_24197_1842# a_4187_2434# 0.04141f
C2208 CHAN0_DELAY_IN CHAN0_MUX_SEL1 0.01858f
C2209 a_25717_1842# a_16108_3134# 0.01314f
C2210 VDD a_26803_16869# 0.49671f
C2211 VDD a_5957_14024# 0.86079f
C2212 VDD a_17683_7532# 0.49671f
C2213 VDD a_11195_13226# 0.1539f
C2214 VDD a_9465_3889# 0.29742f
C2215 VDD a_27915_6734# 0.15389f
C2216 DLL_RESETN a_6854_11144# 0.03626f
C2217 a_25717_16869# a_25913_16869# 0.73897f
C2218 a_4187_2434# a_25913_14024# 0.11222f
C2219 a_5731_15316# a_7803_14024# 0.01539f
C2220 a_4187_2434# a_6854_11676# 0.01478f
C2221 a_17065_13226# a_17275_13226# 0.09424f
C2222 a_4187_2434# a_17357_4687# 0.04141f
C2223 a_16597_7532# a_16793_7532# 0.73897f
C2224 a_11491_11918# a_12158_11557# 0.0894f
C2225 a_20397_7532# a_20968_6734# 0.10863f
C2226 a_25528_6734# a_25604_6698# 0.01176f
C2227 a_21157_4687# a_21917_4687# 0.02912f
C2228 a_18877_4687# a_16108_3134# 0.0157f
C2229 a_18877_1842# a_19203_1842# 0.01427f
C2230 a_1256_1044# a_2297_1395# 0.04619f
C2231 a_24197_1842# a_22590_1044# 0.05231f
C2232 a_23437_1842# a_23431_1008# 0.02349f
C2233 a_1544_289# a_2297_331# 0.27303f
C2234 a_22590_1044# a_16108_289# 0.56869f
C2235 a_1256_289# a_2873_331# 0.27926f
C2236 a_7390_1044# a_7477_1842# 0.1088f
C2237 VDD a_9193_16869# 0.49285f
C2238 VDD a_15755_16071# 0.15389f
C2239 VDD a_11711_5315# 0.01806f
C2240 VDD a_9757_1842# 0.88193f
C2241 a_4187_2434# a_8237_14024# 0.0414f
C2242 a_20397_16869# a_20968_16071# 0.10863f
C2243 a_16597_16869# a_17357_16869# 0.01669f
C2244 a_25528_16071# a_25630_16071# 0.37183f
C2245 a_21157_14024# a_21353_14024# 0.77122f
C2246 a_4187_2434# a_19963_7532# 0.06661f
C2247 a_25717_14024# a_25604_13190# 0.05157f
C2248 a_7477_7532# a_8237_7532# 0.01669f
C2249 a_13470_6734# a_13444_6698# 0.277f
C2250 a_23763_7532# a_23871_7532# 0.01163f
C2251 a_24665_6734# a_24875_6734# 0.09424f
C2252 a_16108_5979# a_21483_4687# 0.01542f
C2253 a_7390_3889# a_8745_3364# 0.01756f
C2254 a_19550_3889# a_20315_3889# 0.39037f
C2255 a_27563_1842# a_27671_1842# 0.01163f
C2256 a_16510_1044# a_17351_1008# 0.28268f
C2257 a_19203_1842# VDD 0.50004f
C2258 a_2873_331# VDD 0.46491f
C2259 VDD a_21917_14024# 0.8957f
C2260 VDD a_8745_12701# 0.29292f
C2261 VDD a_21591_8160# 0.01806f
C2262 VDD a_20391_3853# 0.28357f
C2263 VDD a_12363_4687# 0.92885f
C2264 CHAN2_MUX_SEL2 CHAN2_MUX_SEL3 3.21891f
C2265 CHAN2_MUX_SEL1 CHAN2_MUX_SEL4 0.03574f
C2266 CHAN2_MUX_SEL4 a_7390_3889# 0.34655f
C2267 CHAN2_DELAY_IN a_4003_4687# 0.54998f
C2268 a_4187_2434# a_11473_16869# 0.11222f
C2269 a_23763_16869# a_23871_16869# 0.01163f
C2270 a_13368_16071# a_13444_16035# 0.01176f
C2271 a_16108_15316# a_21917_14024# 0.01307f
C2272 a_12037_14024# a_12797_14024# 0.02912f
C2273 a_19550_13226# a_19524_13190# 0.277f
C2274 a_7390_13226# a_5731_12471# 0.41331f
C2275 a_15304_10295# a_14111_10917# 0.01761f
C2276 a_24393_7532# a_24957_7532# 0.0114f
C2277 a_4187_2434# a_12037_1842# 0.04141f
C2278 a_4905_6734# a_5191_6698# 0.01885f
C2279 a_5197_4687# a_5768_3889# 0.10863f
C2280 a_16108_5979# a_26985_6209# 0.27952f
C2281 a_5731_5979# a_6717_4687# 0.01307f
C2282 a_7390_3889# a_8231_3853# 0.28268f
C2283 a_7673_1842# a_7803_1842# 0.70845f
C2284 a_27237_1842# a_26803_1842# 0.6972f
C2285 a_4350_1044# a_5768_1044# 0.38994f
C2286 a_10985_1044# a_10430_1044# 0.03209f
C2287 a_5768_1044# VDD 0.17499f
C2288 a_21483_1842# a_4187_2434# 0.06627f
C2289 VDD a_25153_16869# 0.49426f
C2290 VDD a_23945_15546# 0.29292f
C2291 VDD a_8231_13190# 0.28349f
C2292 VDD a_24951_6698# 0.2822f
C2293 VDD a_16033_7532# 0.49413f
C2294 a_24393_16869# a_24523_16869# 0.70845f
C2295 a_4905_16071# a_5115_16071# 0.09424f
C2296 a_4187_2434# a_24197_14024# 0.04141f
C2297 a_16108_15316# a_23945_15546# 0.2906f
C2298 a_5731_15316# a_6153_14024# 0.02026f
C2299 a_5957_14024# a_4350_13226# 0.05231f
C2300 a_5197_14024# a_5191_13190# 0.02349f
C2301 a_4187_2434# a_14643_4687# 0.06627f
C2302 a_7390_13226# a_8155_13226# 0.39037f
C2303 a_6854_11676# a_12849_11557# 0.03615f
C2304 a_5731_12471# a_15304_10295# 0.04235f
C2305 a_15273_7532# a_15403_7532# 0.70845f
C2306 a_10649_11568# a_10751_11568# 0.47795f
C2307 a_20397_4687# a_19963_4687# 0.6972f
C2308 a_25630_3889# a_16108_3134# 0.52614f
C2309 a_18117_1842# a_18313_1842# 0.77122f
C2310 a_21917_1842# a_22564_1008# 0.02011f
C2311 a_26151_2470# VDD 0.01806f
C2312 a_15964_289# CHAN3_MUX_SEL4 0.5544f
C2313 VDD a_7477_16869# 0.86712f
C2314 VDD a_12791_16035# 0.28232f
C2315 VDD a_17065_6734# 0.3023f
C2316 VDD a_12907_10876# 0.0638f
C2317 VDD a_7043_1842# 0.4999f
C2318 VDD a_5631_5315# 0.01806f
C2319 CHAN2_MUX_SEL2 a_2297_3176# 0.10655f
C2320 CHAN2_MUX_OUT a_1256_3134# 0.1134f
C2321 CHAN2_MUX_SEL4 a_1544_3134# 0.47529f
C2322 a_4187_2434# a_27433_16869# 0.11222f
C2323 a_15837_16869# a_15403_16869# 0.6972f
C2324 a_4187_2434# a_5523_14024# 0.06627f
C2325 a_24008_16071# a_24084_16035# 0.01176f
C2326 a_4187_2434# a_18313_7532# 0.11284f
C2327 a_19833_14024# a_19963_14024# 0.70845f
C2328 a_6717_7532# a_6283_7532# 0.6972f
C2329 a_22243_7532# a_22351_7532# 0.01163f
C2330 a_11277_4687# a_11473_4687# 0.76914f
C2331 a_16108_5979# a_19833_4687# 0.01865f
C2332 a_14317_4687# a_14888_3889# 0.10863f
C2333 a_26043_1842# a_26151_1842# 0.01163f
C2334 a_15755_1044# a_15831_1008# 0.01194f
C2335 a_27705_1044# a_27991_1008# 0.01885f
C2336 a_27048_1044# VDD 0.17499f
C2337 a_17553_1842# VDD 0.49593f
C2338 VDD a_2873_12513# 0.46585f
C2339 VDD a_19203_14024# 0.50004f
C2340 VDD a_15511_8160# 0.01806f
C2341 VDD a_17928_3889# 0.17499f
C2342 VDD a_10713_4687# 0.49555f
C2343 CHAN0_MUX_SEL4 a_12797_16869# 0.01829f
C2344 REF_MUX_OUT a_16108_5979# 0.24265f
C2345 a_4187_2434# a_9757_16869# 0.0414f
C2346 a_6717_16869# a_6913_16869# 0.76914f
C2347 a_22243_16869# a_22351_16869# 0.01163f
C2348 a_15077_14024# a_13470_13226# 0.05231f
C2349 a_14317_14024# a_14311_13190# 0.02349f
C2350 a_16108_15316# a_19203_14024# 0.01539f
C2351 a_11277_14024# a_10843_14024# 0.6972f
C2352 a_4187_2434# a_9323_1842# 0.06627f
C2353 a_23437_7532# a_24197_7532# 0.03319f
C2354 a_13121_11521# a_15464_9374# 0.33256f
C2355 a_15765_6153# a_15964_5979# 0.061f
C2356 a_5731_3134# a_13753_1842# 0.01865f
C2357 a_6635_3889# a_6711_3853# 0.01194f
C2358 a_6717_1842# a_7043_1842# 0.01427f
C2359 a_25913_1842# a_26477_1842# 0.0114f
C2360 a_7945_1044# a_8231_1008# 0.01885f
C2361 a_26185_1044# VDD 0.30411f
C2362 a_19833_1842# a_4187_2434# 0.11222f
C2363 a_21353_1842# a_16108_3134# 0.01872f
C2364 VDD a_23437_16869# 0.86929f
C2365 VDD a_11785_15546# 0.29292f
C2366 VDD a_5768_13226# 0.17499f
C2367 VDD a_22488_6734# 0.1824f
C2368 VDD a_14317_7532# 0.87239f
C2369 VDD a_1544_3889# 0.45079f
C2370 CHAN0_MUX_SEL0 a_3449_16422# 0.10753f
C2371 CHAN1_MUX_SEL4 a_11785_12701# 0.03255f
C2372 a_23437_16869# a_23763_16869# 0.01427f
C2373 a_4187_2434# a_21483_14024# 0.06627f
C2374 a_9946_11995# a_10232_11561# 0.41329f
C2375 a_4187_2434# a_12993_4687# 0.11169f
C2376 a_12505_13226# a_12791_13190# 0.01885f
C2377 a_14317_7532# a_14643_7532# 0.01427f
C2378 a_22590_6734# a_23355_6734# 0.39037f
C2379 a_23437_4687# a_24008_3889# 0.10863f
C2380 a_19073_4687# a_19637_4687# 0.0114f
C2381 a_1544_3889# a_2297_4240# 0.28651f
C2382 a_21157_1842# a_21044_1008# 0.02055f
C2383 a_16793_1842# a_16923_1842# 0.70845f
C2384 a_16510_1044# a_17865_519# 0.02165f
C2385 a_25630_1044# a_27048_1044# 0.38994f
C2386 a_20071_2470# VDD 0.01806f
C2387 a_8745_519# CHAN3_MUX_SEL4 0.04472f
C2388 a_5731_289# CHAN3_MUX_OUT 1.04829f
C2389 VDD a_10328_16071# 0.17274f
C2390 VDD a_4763_16869# 0.4973f
C2391 VDD a_14851_11918# 0.25841f
C2392 VDD a_26151_14652# 0.01806f
C2393 VDD a_6425_6734# 0.29722f
C2394 VDD a_5393_1842# 0.49643f
C2395 VDD a_26673_4687# 0.49593f
C2396 a_14513_16869# a_15077_16869# 0.0114f
C2397 a_4187_2434# a_25717_16869# 0.0414f
C2398 a_22590_16071# a_22564_16035# 0.277f
C2399 a_13470_16071# a_5731_15316# 0.41365f
C2400 a_1256_13226# a_2297_13577# 0.04619f
C2401 a_18877_14024# a_19203_14024# 0.01427f
C2402 a_23437_14024# a_23431_13190# 0.02349f
C2403 a_4187_2434# a_16597_7532# 0.04176f
C2404 a_24197_14024# a_22590_13226# 0.05231f
C2405 a_1256_12471# a_2873_12513# 0.27926f
C2406 a_22590_13226# a_16108_12471# 0.56869f
C2407 a_1544_12471# a_2297_12513# 0.27303f
C2408 a_26803_7532# a_26911_8160# 0.01697f
C2409 a_7803_7532# a_7390_6734# 0.01012f
C2410 a_20723_7532# a_20831_7532# 0.01163f
C2411 a_5393_7532# a_5957_7532# 0.0114f
C2412 a_16108_5979# a_18117_4687# 0.01644f
C2413 a_9953_4687# a_10083_4687# 0.70845f
C2414 a_20105_6734# a_20315_6734# 0.09424f
C2415 a_10430_6734# a_11271_6698# 0.28268f
C2416 a_16510_3889# a_17928_3889# 0.38994f
C2417 a_18117_1842# a_18585_1044# 0.2079f
C2418 a_24523_1842# a_24631_1842# 0.01163f
C2419 a_14235_1044# a_14311_1008# 0.01194f
C2420 a_13470_1044# a_14964_1008# 0.28279f
C2421 a_26185_1044# a_25630_1044# 0.03209f
C2422 a_15837_1842# VDD 0.87964f
C2423 a_24084_1008# VDD 0.28225f
C2424 VDD a_17553_14024# 0.49593f
C2425 VDD a_27048_13226# 0.17499f
C2426 VDD a_9431_8160# 0.01806f
C2427 VDD a_8997_4687# 0.85996f
C2428 REF_MUX_SEL2 REF_MUX_SEL3 3.21891f
C2429 VDD a_14964_3853# 0.28225f
C2430 REF_MUX_SEL1 REF_MUX_SEL4 0.03574f
C2431 REF_CLK a_13132_11110# 0.02025f
C2432 a_4187_2434# a_7043_16869# 0.06627f
C2433 a_5393_16869# a_5523_16869# 0.70845f
C2434 a_20723_16869# a_20831_16869# 0.01163f
C2435 a_7803_16869# a_7390_16071# 0.01012f
C2436 a_10430_16071# a_11195_16071# 0.39037f
C2437 a_21625_16071# a_19550_16071# 0.03208f
C2438 a_27563_14024# a_27671_14024# 0.01163f
C2439 a_16108_15316# a_17553_14024# 0.01872f
C2440 a_9953_14024# a_10517_14024# 0.0114f
C2441 a_12797_14024# a_13444_13190# 0.02011f
C2442 a_15108_11799# a_15304_10295# 0.17528f
C2443 a_16510_13226# a_17351_13190# 0.28268f
C2444 a_4187_2434# a_7673_1842# 0.11222f
C2445 a_22677_7532# a_22243_7532# 0.69698f
C2446 a_5731_5979# a_15964_5979# 0.2778f
C2447 a_27237_4687# a_27433_4687# 0.77122f
C2448 a_4350_3889# a_5844_3853# 0.28279f
C2449 a_12505_3889# a_10430_3889# 0.03208f
C2450 a_5115_3889# a_5191_3853# 0.01194f
C2451 a_5957_1842# a_6153_1842# 0.77122f
C2452 a_5731_3134# a_12037_1842# 0.01319f
C2453 a_6425_1044# a_6635_1044# 0.09424f
C2454 a_24957_1842# a_25717_1842# 0.06198f
C2455 a_14025_1044# VDD 0.30411f
C2456 a_18117_1842# a_4187_2434# 0.04141f
C2457 a_19637_1842# a_16108_3134# 0.01314f
C2458 VDD a_20723_16869# 0.49677f
C2459 VDD a_26185_13226# 0.30411f
C2460 VDD a_11603_7532# 0.49739f
C2461 VDD a_19550_6734# 0.8993f
C2462 CHAN3_MUX_SEL4 a_9757_1842# 0.01829f
C2463 a_22677_16869# a_22873_16869# 0.73022f
C2464 a_4187_2434# a_19833_14024# 0.11222f
C2465 a_5731_15316# a_15765_15490# 0.23301f
C2466 a_27237_14024# a_26803_14024# 0.6972f
C2467 a_10985_13226# a_10430_13226# 0.03209f
C2468 a_4187_2434# a_11277_4687# 0.04141f
C2469 a_4350_13226# a_5768_13226# 0.38994f
C2470 a_9547_11632# a_9772_11533# 0.02416f
C2471 a_9547_11862# a_9746_11495# 0.02437f
C2472 a_16923_7532# a_16510_6734# 0.01012f
C2473 a_13557_7532# a_13753_7532# 0.73897f
C2474 a_18117_4687# a_18877_4687# 0.02912f
C2475 a_27915_3889# a_27991_3853# 0.01194f
C2476 a_15837_1842# a_16163_1842# 0.01427f
C2477 a_20397_1842# a_19550_1044# 0.08038f
C2478 a_13991_2470# VDD 0.01806f
C2479 VDD CHAN1_MUX_OUT 0.78107f
C2480 a_2873_331# CHAN3_MUX_SEL4 0.04916f
C2481 a_2297_331# CHAN3_MUX_OUT 0.01179f
C2482 a_3449_331# CHAN3_MUX_SEL3 0.28429f
C2483 VDD a_7390_16071# 0.8686f
C2484 VDD a_20071_14652# 0.01806f
C2485 VDD a_13592_11561# 0.07382f
C2486 VDD a_24957_4687# 0.88247f
C2487 VDD a_20905_3364# 0.29292f
C2488 CHAN1_DELAY_IN a_4003_14024# 0.54998f
C2489 CHAN0_DELAY_OUT_LAST a_27997_16869# 0.70955f
C2490 CHAN1_MUX_SEL4 a_7390_13226# 0.34655f
C2491 a_16923_16869# a_16510_16071# 0.01012f
C2492 a_4187_2434# a_23003_16869# 0.06391f
C2493 a_13557_16869# a_14317_16869# 0.01669f
C2494 a_18117_14024# a_18313_14024# 0.77122f
C2495 a_21917_14024# a_22564_13190# 0.02011f
C2496 a_4187_2434# a_13883_7532# 0.06627f
C2497 a_4437_7532# a_5197_7532# 0.01669f
C2498 a_6717_7532# a_7288_6734# 0.10864f
C2499 a_12037_7532# a_12505_6734# 0.2079f
C2500 a_25283_7532# a_25391_8160# 0.01697f
C2501 a_19203_7532# a_19311_7532# 0.01163f
C2502 a_9675_6734# a_9751_6698# 0.01194f
C2503 a_13753_1842# a_14317_1842# 0.0114f
C2504 a_23003_1842# a_23111_1842# 0.01163f
C2505 a_23145_1044# a_23431_1008# 0.01885f
C2506 a_21835_1044# VDD 0.15407f
C2507 VDD a_15837_14024# 0.87964f
C2508 VDD a_27563_7532# 0.49811f
C2509 VDD a_24084_13190# 0.28225f
C2510 VDD a_6283_4687# 0.50001f
C2511 VDD a_12715_3889# 0.15484f
C2512 REF_MUX_SEL4 a_5705_6209# 0.03556f
C2513 a_4187_2434# a_5393_16869# 0.11222f
C2514 a_6717_16869# a_7288_16071# 0.10864f
C2515 a_12037_16869# a_12505_16071# 0.2079f
C2516 a_19203_16869# a_19311_16869# 0.01163f
C2517 a_8997_14024# a_9757_14024# 0.02912f
C2518 a_12037_14024# a_11924_13190# 0.02055f
C2519 a_4187_2434# a_27237_4687# 0.06254f
C2520 a_26043_14024# a_26151_14024# 0.01163f
C2521 a_27705_13226# a_27991_13190# 0.01885f
C2522 a_15755_13226# a_15831_13190# 0.01194f
C2523 a_4187_2434# a_5957_1842# 0.04141f
C2524 a_26043_7532# a_25630_6734# 0.01012f
C2525 a_21353_7532# a_21917_7532# 0.0114f
C2526 a_5731_5979# a_8745_6209# 0.28635f
C2527 a_25913_4687# a_26043_4687# 0.70845f
C2528 a_5731_3134# a_9323_1842# 0.01542f
C2529 a_4633_1842# a_4763_1842# 0.70845f
C2530 a_24197_1842# a_23763_1842# 0.6972f
C2531 a_4157_1313# a_4350_1044# 0.04624f
C2532 a_16108_289# a_16851_309# 0.06181f
C2533 a_4157_1313# VDD 0.48935f
C2534 a_15403_1842# a_4187_2434# 0.06627f
C2535 a_16923_1842# a_16108_3134# 0.01073f
C2536 VDD a_19073_16869# 0.49426f
C2537 VDD a_1544_15316# 0.39372f
C2538 VDD a_14025_13226# 0.30411f
C2539 VDD a_9953_7532# 0.49426f
C2540 VDD a_16484_6698# 0.28687f
C2541 CHAN1_MUX_SEL4 a_1544_12471# 0.47529f
C2542 CHAN1_MUX_SEL2 a_2297_12513# 0.10655f
C2543 CHAN1_MUX_OUT a_1256_12471# 0.1134f
C2544 a_4187_2434# a_18117_14024# 0.04141f
C2545 a_26043_16869# a_25630_16071# 0.01012f
C2546 a_21353_16869# a_21483_16869# 0.70845f
C2547 a_4187_2434# a_8563_4687# 0.06627f
C2548 a_25913_14024# a_26477_14024# 0.0114f
C2549 a_7945_13226# a_8231_13190# 0.01885f
C2550 a_12233_7532# a_12363_7532# 0.70361f
C2551 a_6854_11676# a_6126_9506# 0.18536f
C2552 a_5974_11413# a_6854_11144# 0.01757f
C2553 a_25717_7532# a_26185_6734# 0.19203f
C2554 a_15837_7532# a_16408_6734# 0.10864f
C2555 a_19550_6734# a_20968_6734# 0.38994f
C2556 a_17357_4687# a_16923_4687# 0.6972f
C2557 a_25630_3889# a_27124_3853# 0.28279f
C2558 a_26395_3889# a_26471_3853# 0.01194f
C2559 a_15077_1842# a_15273_1842# 0.77122f
C2560 a_18877_1842# a_18871_1008# 0.02354f
C2561 a_22590_1044# a_24875_1044# 0.39036f
C2562 a_16510_1044# a_2019_311# 0.03139f
C2563 a_7911_2470# VDD 0.01806f
C2564 VDD CHAN0_MUX_OUT 0.97728f
C2565 a_13991_1842# a_13883_1842# 0.01163f
C2566 VDD a_4324_16035# 0.28687f
C2567 VDD a_13991_14652# 0.01806f
C2568 VDD a_12656_11554# 0.27353f
C2569 VDD a_22243_4687# 0.95241f
C2570 CHAN0_MUX_OUT a_16108_15316# 0.24265f
C2571 a_12797_16869# a_12363_16869# 0.6972f
C2572 a_4187_2434# a_21353_16869# 0.11222f
C2573 a_15837_16869# a_16408_16071# 0.10864f
C2574 a_25717_16869# a_26185_16071# 0.19203f
C2575 a_4187_2434# a_12233_7532# 0.11169f
C2576 a_19550_16071# a_20391_16035# 0.28268f
C2577 a_16793_14024# a_16923_14024# 0.70845f
C2578 a_21157_14024# a_21044_13190# 0.02055f
C2579 a_5778_9057# a_5864_9057# 0.07306f
C2580 a_25630_13226# a_27048_13226# 0.38994f
C2581 a_9444_9602# a_9712_9602# 0.81869f
C2582 a_16510_13226# a_17865_12701# 0.02165f
C2583 a_15545_6734# a_15831_6698# 0.01885f
C2584 a_7390_6734# a_8884_6698# 0.28279f
C2585 a_8155_6734# a_8231_6698# 0.01194f
C2586 a_6717_7532# a_4350_6734# 0.02479f
C2587 a_17683_7532# a_17791_7532# 0.01163f
C2588 a_23763_7532# a_23871_8160# 0.01697f
C2589 a_8237_4687# a_8433_4687# 0.76914f
C2590 a_13470_3889# a_15755_3889# 0.39036f
C2591 a_10843_4687# a_10430_3889# 0.01012f
C2592 a_27705_3889# a_25630_3889# 0.03208f
C2593 a_12797_1842# a_13557_1842# 0.05851f
C2594 a_27563_1842# a_27671_2470# 0.01697f
C2595 a_21483_1842# a_21591_1842# 0.01163f
C2596 a_10430_1044# a_12791_1008# 0.26208f
C2597 a_18871_1008# VDD 0.2822f
C2598 VDD CHAN3_MUX_SEL0 0.60193f
C2599 VDD a_24631_17497# 0.01806f
C2600 VDD a_13123_14024# 0.4839f
C2601 VDD a_25913_7532# 0.49294f
C2602 VDD a_21835_13226# 0.15407f
C2603 VDD a_4633_4687# 0.49523f
C2604 VDD a_9751_3853# 0.2822f
C2605 DLL_RESETN a_4187_2434# 0.06929f
C2606 CHAN0_MUX_SEL4 a_6717_16869# 0.0195f
C2607 DLL_RESETN a_12943_11557# 0.03616f
C2608 REF_MUX_SEL2 a_1256_5979# 0.33134f
C2609 a_15545_16071# a_15755_16071# 0.09424f
C2610 a_6717_16869# a_4350_16071# 0.02479f
C2611 a_17683_16869# a_17791_16869# 0.01163f
C2612 a_7390_16071# a_8808_16071# 0.38994f
C2613 a_8237_14024# a_7803_14024# 0.6972f
C2614 a_18117_14024# a_18585_13226# 0.2079f
C2615 a_11277_14024# a_10430_13226# 0.08038f
C2616 a_26185_13226# a_25630_13226# 0.03209f
C2617 a_13470_13226# a_14964_13190# 0.28279f
C2618 a_24523_14024# a_24631_14024# 0.01163f
C2619 a_4187_2434# a_24523_4687# 0.06627f
C2620 a_14235_13226# a_14311_13190# 0.01194f
C2621 a_6326_10280# a_5778_9057# 0.8779f
C2622 a_20397_7532# a_21157_7532# 0.03319f
C2623 a_24957_7532# a_25528_6734# 0.10864f
C2624 a_24957_4687# a_25283_4687# 0.01427f
C2625 a_6425_3889# a_6711_3853# 0.01885f
C2626 a_5731_3134# a_7673_1842# 0.01865f
C2627 a_22873_1842# a_23437_1842# 0.0114f
C2628 a_10430_1044# a_12363_1842# 0.01012f
C2629 VDD a_17357_16869# 0.86919f
C2630 VDD a_25604_16035# 0.28633f
C2631 VDD a_4157_13495# 0.48936f
C2632 VDD a_14235_6734# 0.15389f
C2633 VDD a_8237_7532# 0.86919f
C2634 REF_DELAY_OUT_LAST a_15688_11093# 0.01699f
C2635 a_24957_16869# a_25528_16071# 0.10864f
C2636 a_20397_16869# a_20723_16869# 0.01427f
C2637 a_4187_2434# a_15403_14024# 0.06627f
C2638 a_24957_14024# a_25717_14024# 0.06198f
C2639 a_4187_2434# a_6913_4687# 0.11222f
C2640 a_6425_13226# a_6635_13226# 0.09424f
C2641 a_11277_7532# a_11603_7532# 0.01427f
C2642 a_15837_7532# a_13470_6734# 0.02479f
C2643 a_16033_4687# a_16597_4687# 0.0114f
C2644 a_19963_4687# a_19550_3889# 0.01012f
C2645 a_10430_1044# a_11785_519# 0.02058f
C2646 a_17357_1842# a_18004_1008# 0.02312f
C2647 a_27433_1842# VDD 0.49998f
C2648 a_12471_1842# a_12363_1842# 0.01163f
C2649 a_4905_1044# a_4437_1842# 0.19203f
C2650 VDD a_21625_16071# 0.29722f
C2651 VDD a_7911_14652# 0.01806f
C2652 VDD a_10751_11568# 0.20524f
C2653 VDD a_20593_4687# 0.49594f
C2654 a_4187_2434# a_19637_16869# 0.0414f
C2655 a_11473_16869# a_12037_16869# 0.0114f
C2656 a_18795_16071# a_18871_16035# 0.01194f
C2657 a_15837_16869# a_13470_16071# 0.02479f
C2658 a_15837_14024# a_16163_14024# 0.01427f
C2659 a_4187_2434# a_10517_7532# 0.0414f
C2660 a_20397_14024# a_19550_13226# 0.08038f
C2661 a_4437_7532# a_4324_6698# 0.05157f
C2662 a_16163_7532# a_16271_7532# 0.01163f
C2663 a_22243_7532# a_22351_8160# 0.01697f
C2664 a_14025_6734# a_13470_6734# 0.03209f
C2665 a_5731_5979# a_13883_4687# 0.01539f
C2666 a_6913_4687# a_7043_4687# 0.70845f
C2667 a_16597_4687# a_17065_3889# 0.19203f
C2668 a_9757_4687# a_10328_3889# 0.10864f
C2669 a_12037_1842# a_11603_1842# 0.6972f
C2670 a_26043_1842# a_26151_2470# 0.01697f
C2671 a_19963_1842# a_20071_1842# 0.01163f
C2672 a_10328_1044# a_10430_1044# 0.37183f
C2673 a_16408_1044# VDD 0.17274f
C2674 VDD CHAN2_MUX_SEL0 0.60193f
C2675 CHAN1_MUX_SEL2 CHAN1_MUX_SEL4 0.01978f
C2676 CHAN1_MUX_SEL1 CHAN1_MUX_OUT 0.05651f
C2677 VDD a_18551_17497# 0.01806f
C2678 VDD a_11473_14024# 0.49601f
C2679 VDD a_18871_13190# 0.2822f
C2680 VDD a_16108_5979# 1.64187f
C2681 VDD a_24197_7532# 0.85892f
C2682 VDD a_7288_3889# 0.17274f
C2683 CHAN1_DELAY_IN a_4187_2434# 0.07719f
C2684 REF_CLK a_13121_11521# 1.40135f
C2685 DLL_RESETN a_12849_11557# 0.35009f
C2686 CHAN2_MUX_SEL4 a_1544_3889# 0.03407f
C2687 CHAN2_MUX_SEL0 a_2297_4240# 0.10655f
C2688 CHAN2_MUX_OUT a_1256_3889# 0.02199f
C2689 a_4437_16869# a_4324_16035# 0.05157f
C2690 a_16163_16869# a_16271_16869# 0.01163f
C2691 a_9757_14024# a_9751_13190# 0.02354f
C2692 a_23003_14024# a_23111_14024# 0.01163f
C2693 a_4187_2434# a_13019_11521# 0.02377f
C2694 a_5731_15316# a_14317_14024# 0.01319f
C2695 a_6913_14024# a_7477_14024# 0.0114f
C2696 a_4187_2434# a_22873_4687# 0.11169f
C2697 a_23145_13226# a_23431_13190# 0.01885f
C2698 a_13019_11521# a_12943_11557# 0.03346f
C2699 a_12849_11557# a_14009_11568# 0.03525f
C2700 a_19637_7532# a_19203_7532# 0.69698f
C2701 a_13306_11995# a_13592_11561# 0.41329f
C2702 a_6126_9506# a_9444_10280# 0.03029f
C2703 a_24957_7532# a_22590_6734# 0.02479f
C2704 a_1256_6734# a_2873_7085# 0.28892f
C2705 a_24197_4687# a_24393_4687# 0.77122f
C2706 a_16108_3134# a_17865_3364# 0.29564f
C2707 a_4905_3889# a_4350_3889# 0.03209f
C2708 a_5731_3134# a_5957_1842# 0.01644f
C2709 a_4157_4158# a_4324_3853# 0.02463f
C2710 a_21917_1842# a_22677_1842# 0.06198f
C2711 a_26477_1842# a_27124_1008# 0.02312f
C2712 a_2019_311# a_15964_289# 0.02413f
C2713 a_15403_1842# a_5731_3134# 0.01563f
C2714 VDD a_23355_16071# 0.15389f
C2715 VDD a_14643_16869# 0.49671f
C2716 VDD a_11271_6698# 0.28357f
C2717 VDD a_5523_7532# 0.49671f
C2718 REF_DELAY_OUT_LAST a_13592_11113# 0.08062f
C2719 a_19637_16869# a_19833_16869# 0.73897f
C2720 a_24957_16869# a_22590_16071# 0.02479f
C2721 a_4187_2434# a_13753_14024# 0.11222f
C2722 a_4187_2434# a_26477_7532# 0.04182f
C2723 a_24197_14024# a_23763_14024# 0.6972f
C2724 a_4187_2434# a_5197_4687# 0.04141f
C2725 a_16108_12471# a_16851_12491# 0.06181f
C2726 a_4157_13495# a_4350_13226# 0.04624f
C2727 a_13557_7532# a_13444_6698# 0.05157f
C2728 a_10517_7532# a_10713_7532# 0.73897f
C2729 a_16510_6734# a_18795_6734# 0.39036f
C2730 a_15077_4687# a_15837_4687# 0.02912f
C2731 a_18877_4687# a_19448_3889# 0.10864f
C2732 a_22590_3889# a_24951_3853# 0.26208f
C2733 a_16597_1842# a_16510_1044# 0.1088f
C2734 a_25717_1842# VDD 0.87095f
C2735 a_10951_1842# a_10843_1842# 0.01163f
C2736 VDD a_9465_16071# 0.29722f
C2737 VDD a_9772_11533# 0.24887f
C2738 VDD a_27433_14024# 0.49998f
C2739 VDD a_18877_4687# 0.88247f
C2740 VDD a_1256_3134# 0.4205f
C2741 CHAN0_MUX_SEL4 a_5705_15546# 0.03556f
C2742 a_4187_2434# a_16923_16869# 0.06627f
C2743 a_10517_16869# a_11277_16869# 0.01669f
C2744 a_13557_16869# a_13444_16035# 0.05157f
C2745 a_16510_16071# a_18004_16035# 0.28279f
C2746 a_17275_16071# a_17351_16035# 0.01194f
C2747 a_4350_16071# a_5705_15546# 0.02005f
C2748 a_18877_14024# a_18871_13190# 0.02354f
C2749 a_15077_14024# a_15273_14024# 0.77122f
C2750 a_4187_2434# a_7803_7532# 0.06627f
C2751 a_22590_13226# a_24875_13226# 0.39036f
C2752 a_20723_7532# a_20831_8160# 0.01697f
C2753 a_14643_7532# a_14751_7532# 0.01163f
C2754 a_4350_6734# a_6711_6698# 0.26208f
C2755 a_5731_5979# a_12233_4687# 0.01121f
C2756 a_10985_6734# a_11271_6698# 0.01885f
C2757 a_9757_4687# a_7390_3889# 0.02479f
C2758 a_21625_3889# a_21835_3889# 0.09424f
C2759 a_10713_1842# a_11277_1842# 0.0114f
C2760 a_18443_1842# a_18551_1842# 0.01163f
C2761 a_24523_1842# a_24631_2470# 0.01697f
C2762 a_18585_1044# a_16510_1044# 0.03208f
C2763 a_8808_1044# a_8884_1008# 0.01176f
C2764 a_13470_1044# VDD 0.87936f
C2765 a_4157_1313# CHAN3_MUX_SEL4 0.08229f
C2766 a_27997_1842# a_4187_2434# 0.04001f
C2767 CHAN1_DELAY_IN CHAN1_MUX_SEL0 0.10102f
C2768 VDD REF_MUX_SEL0 0.60193f
C2769 VDD a_12471_17497# 0.02372f
C2770 VDD a_9757_14024# 0.88193f
C2771 VDD a_16408_13226# 0.17274f
C2772 VDD a_21483_7532# 0.49801f
C2773 VDD a_4350_3889# 0.87635f
C2774 CHAN0_DELAY_IN a_4187_2434# 0.07974f
C2775 DLL_RESETN a_12158_11557# 0.02442f
C2776 REF_CLK a_11491_11918# 0.01827f
C2777 a_27433_16869# a_27997_16869# 0.0114f
C2778 a_14643_16869# a_14751_16869# 0.01163f
C2779 a_4350_16071# a_6635_16071# 0.39036f
C2780 a_5731_15316# a_11603_14024# 0.01544f
C2781 a_5957_14024# a_6717_14024# 0.02912f
C2782 a_10985_16071# a_11195_16071# 0.09424f
C2783 a_8237_14024# a_8884_13190# 0.02312f
C2784 a_21483_14024# a_21591_14024# 0.01163f
C2785 a_27563_14024# a_27671_14652# 0.01697f
C2786 a_4187_2434# a_21157_4687# 0.04152f
C2787 a_13019_11521# a_12849_11557# 0.12838f
C2788 a_10430_13226# a_12791_13190# 0.26208f
C2789 a_18313_7532# a_18877_7532# 0.0114f
C2790 a_22677_7532# a_22564_6698# 0.05157f
C2791 a_22873_4687# a_23003_4687# 0.70361f
C2792 a_21157_1842# a_20723_1842# 0.6972f
C2793 a_25717_1842# a_25630_1044# 0.1088f
C2794 VDD a_12993_16869# 0.49436f
C2795 VDD a_20391_16035# 0.28357f
C2796 VDD a_5864_9057# 0.13532f
C2797 VDD a_8808_6734# 0.17499f
C2798 VDD a_23111_5315# 0.01806f
C2799 VDD a_13557_1842# 0.87029f
C2800 REF_DELAY_OUT_LAST a_15304_10295# 0.05582f
C2801 a_18313_16869# a_18443_16869# 0.70845f
C2802 a_19550_16071# a_20905_15546# 0.02165f
C2803 a_4187_2434# a_12037_14024# 0.04141f
C2804 a_22677_16869# a_22564_16035# 0.05157f
C2805 a_22873_14024# a_23437_14024# 0.0114f
C2806 a_4187_2434# a_23763_7532# 0.06661f
C2807 a_9193_7532# a_9323_7532# 0.70845f
C2808 a_16108_5979# a_25283_4687# 0.01539f
C2809 a_14317_4687# a_13883_4687# 0.6972f
C2810 a_18877_4687# a_16510_3889# 0.02479f
C2811 a_22488_3889# a_22590_3889# 0.37183f
C2812 a_19448_1044# a_19524_1008# 0.01176f
C2813 a_23003_1842# VDD 0.48378f
C2814 a_15765_463# VDD 0.35368f
C2815 a_9431_1842# a_9323_1842# 0.01163f
C2816 VDD a_25717_14024# 0.87095f
C2817 VDD a_6326_10280# 7.58054f
C2818 VDD a_16163_4687# 0.49822f
C2819 VDD a_25630_3889# 0.90165f
C2820 CHAN0_MUX_SEL2 a_1256_15316# 0.33134f
C2821 a_9757_16869# a_9323_16869# 0.6972f
C2822 a_4187_2434# a_15273_16869# 0.11222f
C2823 a_13753_14024# a_13883_14024# 0.70845f
C2824 a_16108_15316# a_25717_14024# 0.01314f
C2825 a_17357_14024# a_18004_13190# 0.02312f
C2826 a_4187_2434# a_6153_7532# 0.11222f
C2827 a_13306_10795# a_13880_10808# 0.31978f
C2828 a_14111_10917# a_15108_11015# 0.03012f
C2829 a_10430_13226# a_11785_12701# 0.02058f
C2830 a_13123_7532# a_13231_7532# 0.01163f
C2831 a_19203_7532# a_19311_8160# 0.01697f
C2832 a_26477_7532# a_26673_7532# 0.76914f
C2833 a_5197_4687# a_5393_4687# 0.76914f
C2834 a_5731_5979# a_10517_4687# 0.01314f
C2835 a_4248_6734# a_4350_6734# 0.37183f
C2836 a_10328_3889# a_10404_3853# 0.01176f
C2837 a_7477_4687# a_7364_3853# 0.05157f
C2838 a_9757_1842# a_10517_1842# 0.06198f
C2839 a_23003_1842# a_23111_2470# 0.01697f
C2840 a_16923_1842# a_17031_1842# 0.01163f
C2841 a_7390_1044# a_7364_1008# 0.277f
C2842 a_10404_1008# VDD 0.28633f
C2843 a_2873_1395# CHAN3_MUX_SEL0 0.01504f
C2844 a_25283_1842# a_4187_2434# 0.06627f
C2845 CHAN0_MUX_SEL1 CHAN0_MUX_OUT 0.05651f
C2846 CHAN0_MUX_SEL2 CHAN0_MUX_SEL4 0.01978f
C2847 a_26803_1842# a_16108_3134# 0.01192f
C2848 VDD a_6391_17497# 0.01806f
C2849 VDD a_7043_14024# 0.4999f
C2850 VDD a_19833_7532# 0.49294f
C2851 VDD a_13470_13226# 0.87936f
C2852 VDD a_3449_6021# 0.47499f
C2853 VDD a_20105_3889# 0.30411f
C2854 CHAN1_MUX_OUT a_10232_11561# 0.01279f
C2855 DLL_RESETN a_10206_11525# 0.27343f
C2856 a_26477_16869# a_27237_16869# 0.03319f
C2857 a_13123_16869# a_13231_16869# 0.01163f
C2858 a_4187_2434# a_27997_14024# 0.04001f
C2859 a_5731_15316# a_9953_14024# 0.01872f
C2860 a_5197_14024# a_4763_14024# 0.6972f
C2861 a_19963_14024# a_20071_14024# 0.01163f
C2862 a_4187_2434# a_18443_4687# 0.06627f
C2863 a_26043_14024# a_26151_14652# 0.01697f
C2864 a_7477_14024# a_7390_13226# 0.1088f
C2865 a_10328_13226# a_10430_13226# 0.37183f
C2866 a_17357_7532# a_18117_7532# 0.03319f
C2867 a_25630_6734# a_27991_6698# 0.26208f
C2868 a_21917_4687# a_22243_4687# 0.01427f
C2869 a_5731_3134# a_11785_3364# 0.28056f
C2870 a_19833_1842# a_20397_1842# 0.0114f
C2871 VDD a_11277_16869# 0.86926f
C2872 a_8808_1044# a_8237_1842# 0.10863f
C2873 VDD a_17928_16071# 0.17499f
C2874 VDD a_13880_10808# 0.02994f
C2875 VDD a_5844_6698# 0.28225f
C2876 VDD a_17031_5315# 0.01806f
C2877 VDD a_10843_1842# 0.50064f
C2878 a_17357_16869# a_17683_16869# 0.01427f
C2879 a_4187_2434# a_9323_14024# 0.06627f
C2880 a_25630_16071# a_27915_16071# 0.39036f
C2881 a_26477_14024# a_27124_13190# 0.02312f
C2882 a_21917_14024# a_22677_14024# 0.06198f
C2883 a_4187_2434# a_22113_7532# 0.11232f
C2884 a_8237_7532# a_8563_7532# 0.01427f
C2885 a_11277_7532# a_11271_6698# 0.02349f
C2886 a_12037_7532# a_10430_6734# 0.05231f
C2887 a_12993_4687# a_13557_4687# 0.0114f
C2888 a_26185_6734# a_26471_6698# 0.01885f
C2889 a_16108_5979# a_23633_4687# 0.01872f
C2890 a_16597_4687# a_16484_3853# 0.05157f
C2891 a_20968_3889# a_21044_3853# 0.01176f
C2892 a_4350_1044# a_5731_289# 0.41099f
C2893 a_21353_1842# VDD 0.49468f
C2894 a_5731_289# VDD 0.6143f
C2895 a_7911_1842# a_7803_1842# 0.01163f
C2896 a_13991_2470# a_13883_1842# 0.01697f
C2897 VDD a_1544_16071# 0.45079f
C2898 VDD a_23003_14024# 0.48375f
C2899 VDD a_15765_12645# 0.35715f
C2900 VDD a_26911_8160# 0.01806f
C2901 VDD a_14513_4687# 0.49593f
C2902 VDD a_22564_3853# 0.28964f
C2903 CHAN1_MUX_SEL4 a_1544_13226# 0.03407f
C2904 CHAN1_MUX_SEL0 a_2297_13577# 0.10655f
C2905 CHAN1_MUX_OUT a_1256_13226# 0.02199f
C2906 REF_CLK a_4003_7532# 0.55467f
C2907 a_4187_2434# a_13557_16869# 0.04101f
C2908 a_8433_16869# a_8997_16869# 0.0114f
C2909 a_11277_16869# a_11271_16035# 0.02349f
C2910 a_12037_16869# a_10430_16071# 0.05231f
C2911 a_26185_16071# a_26395_16071# 0.09424f
C2912 a_4187_2434# a_4437_7532# 0.04193f
C2913 a_13470_16071# a_15831_16035# 0.26208f
C2914 a_16597_14024# a_16510_13226# 0.1088f
C2915 a_13592_11113# a_14009_10774# 0.3749f
C2916 a_13306_10795# a_14111_10917# 0.097f
C2917 a_4187_2434# a_13123_1842# 0.0643f
C2918 a_17683_7532# a_17791_8160# 0.01697f
C2919 a_11603_7532# a_11711_7532# 0.01163f
C2920 a_25153_7532# a_25283_7532# 0.70845f
C2921 a_5731_5979# a_7803_4687# 0.01539f
C2922 a_17065_3889# a_17275_3889# 0.09424f
C2923 a_8997_1842# a_8563_1842# 0.6972f
C2924 a_15403_1842# a_15511_1842# 0.01163f
C2925 a_12505_1044# a_12715_1044# 0.09424f
C2926 a_21483_1842# a_21591_2470# 0.01697f
C2927 a_8155_1044# VDD 0.1539f
C2928 a_1256_1044# CHAN3_MUX_SEL0 0.3314f
C2929 a_23633_1842# a_4187_2434# 0.11222f
C2930 CHAN0_DELAY_IN CHAN0_MUX_SEL0 0.10102f
C2931 a_25153_1842# a_16108_3134# 0.01872f
C2932 VDD a_27237_16869# 0.86022f
C2933 VDD a_10404_13190# 0.28633f
C2934 VDD a_5393_14024# 0.49643f
C2935 VDD a_18117_7532# 0.85889f
C2936 VDD a_27124_6698# 0.28225f
C2937 VDD a_7945_3889# 0.30411f
C2938 REF_CLK a_6854_11676# 0.04119f
C2939 CHAN1_MUX_OUT a_6854_11144# 0.16652f
C2940 DLL_RESETN a_6126_9506# 0.06398f
C2941 a_11603_16869# a_11711_16869# 0.01163f
C2942 a_4187_2434# a_25283_14024# 0.06627f
C2943 a_25717_16869# a_25283_16869# 0.69698f
C2944 a_5731_15316# a_8237_14024# 0.01319f
C2945 a_24523_14024# a_24631_14652# 0.01697f
C2946 a_18585_13226# a_16510_13226# 0.03208f
C2947 a_4187_2434# a_16793_4687# 0.11222f
C2948 a_8808_13226# a_8884_13190# 0.01176f
C2949 a_18443_14024# a_18551_14024# 0.01163f
C2950 a_11748_11799# a_12158_11557# 0.10373f
C2951 a_16597_7532# a_16163_7532# 0.69698f
C2952 a_21157_7532# a_19550_6734# 0.05231f
C2953 a_20397_7532# a_20391_6698# 0.02349f
C2954 a_25528_6734# a_25630_6734# 0.37183f
C2955 a_21157_4687# a_21353_4687# 0.77122f
C2956 a_25717_4687# a_25604_3853# 0.05157f
C2957 a_18877_1842# a_19637_1842# 0.06198f
C2958 a_1544_289# a_1721_331# 0.36963f
C2959 a_1256_289# a_2297_331# 0.04261f
C2960 VDD a_8563_16869# 0.49671f
C2961 VDD a_14964_16035# 0.28225f
C2962 VDD a_27705_6734# 0.29962f
C2963 VDD a_14111_10917# 0.33926f
C2964 VDD a_10951_5315# 0.01806f
C2965 VDD a_9193_1842# 0.4946f
C2966 REF_MUX_SEL1 a_1544_6734# 0.1672f
C2967 REF_MUX_SEL0 a_1721_7085# 0.01315f
C2968 a_16597_16869# a_16793_16869# 0.73897f
C2969 a_4187_2434# a_7673_14024# 0.11222f
C2970 a_21157_16869# a_19550_16071# 0.05231f
C2971 a_20397_16869# a_20391_16035# 0.02349f
C2972 a_21157_14024# a_20723_14024# 0.6972f
C2973 a_4187_2434# a_20397_7532# 0.04176f
C2974 a_25717_14024# a_25630_13226# 0.1088f
C2975 a_7477_7532# a_7673_7532# 0.73897f
C2976 a_9757_7532# a_10404_6698# 0.02011f
C2977 a_13368_6734# a_13444_6698# 0.01176f
C2978 a_16108_5979# a_21917_4687# 0.01307f
C2979 a_12037_4687# a_12797_4687# 0.02912f
C2980 a_19550_3889# a_19524_3853# 0.277f
C2981 a_7390_3889# a_5731_3134# 0.41331f
C2982 a_16510_1044# a_17275_1044# 0.39037f
C2983 a_19637_1842# VDD 0.87095f
C2984 a_2297_331# VDD 0.46496f
C2985 a_13470_1044# CHAN3_MUX_SEL4 0.256f
C2986 a_12471_2470# a_12363_1842# 0.01697f
C2987 a_6391_1842# a_6283_1842# 0.01163f
C2988 VDD a_21353_14024# 0.49468f
C2989 VDD a_5731_12471# 0.84699f
C2990 VDD a_20831_8160# 0.01806f
C2991 VDD a_12797_4687# 0.8835f
C2992 VDD a_20315_3889# 0.1539f
C2993 CHAN2_DELAY_IN a_4437_4687# 0.05007f
C2994 REF_MUX_SEL4 a_4633_4687# 0.01287f
C2995 a_7477_16869# a_8237_16869# 0.01669f
C2996 a_4187_2434# a_10843_16869# 0.06627f
C2997 a_13368_16071# a_13470_16071# 0.37183f
C2998 a_9757_16869# a_10404_16035# 0.02011f
C2999 a_16108_15316# a_21353_14024# 0.01872f
C3000 a_12037_14024# a_12233_14024# 0.77122f
C3001 a_19448_13226# a_19524_13190# 0.01176f
C3002 a_4187_2434# a_11473_1842# 0.11222f
C3003 a_10083_7532# a_10191_7532# 0.01163f
C3004 a_12907_11110# a_13132_11110# 0.02416f
C3005 a_16163_7532# a_16271_8160# 0.01697f
C3006 a_4905_6734# a_5115_6734# 0.09424f
C3007 a_5731_5979# a_6153_4687# 0.02026f
C3008 a_16108_5979# a_23945_6209# 0.2906f
C3009 a_5197_4687# a_5191_3853# 0.02349f
C3010 a_5957_4687# a_4350_3889# 0.05231f
C3011 a_7673_1842# a_8237_1842# 0.0114f
C3012 a_7390_3889# a_8155_3889# 0.39037f
C3013 a_26673_1842# a_26803_1842# 0.70845f
C3014 a_19963_1842# a_20071_2470# 0.01697f
C3015 a_4350_1044# a_5191_1008# 0.28268f
C3016 a_5191_1008# VDD 0.28565f
C3017 a_21917_1842# a_4187_2434# 0.0414f
C3018 VDD a_24523_16869# 0.4973f
C3019 VDD a_20905_15546# 0.29292f
C3020 VDD a_8155_13226# 0.1539f
C3021 VDD a_24875_6734# 0.15406f
C3022 VDD a_15403_7532# 0.4973f
C3023 VDD a_2873_4240# 0.46517f
C3024 a_24393_16869# a_24957_16869# 0.0114f
C3025 a_4187_2434# a_23633_14024# 0.11222f
C3026 a_10083_16869# a_10191_16869# 0.01163f
C3027 a_6425_16071# a_4350_16071# 0.03208f
C3028 a_16923_14024# a_17031_14024# 0.01163f
C3029 a_5731_15316# a_5523_14024# 0.01562f
C3030 a_23003_14024# a_23111_14652# 0.01697f
C3031 a_16108_15316# a_20905_15546# 0.2906f
C3032 a_4187_2434# a_15077_4687# 0.04194f
C3033 a_7390_13226# a_7364_13190# 0.277f
C3034 a_10649_11568# a_10520_11982# 0.01562f
C3035 a_6854_11676# a_13121_11521# 0.10045f
C3036 a_10232_11561# a_10751_11568# 0.34102f
C3037 a_15273_7532# a_15837_7532# 0.0114f
C3038 a_24008_6734# a_24084_6698# 0.01176f
C3039 a_18877_7532# a_19524_6698# 0.02011f
C3040 a_19833_4687# a_19963_4687# 0.70845f
C3041 a_18117_1842# a_17683_1842# 0.6972f
C3042 a_19550_1044# a_16108_289# 0.58202f
C3043 a_25391_2470# VDD 0.01806f
C3044 a_15765_463# CHAN3_MUX_SEL4 0.65508f
C3045 VDD a_12715_16071# 0.15484f
C3046 VDD a_6913_16869# 0.49426f
C3047 VDD a_13106_11047# 0.09231f
C3048 VDD a_15545_6734# 0.29962f
C3049 VDD a_7477_1842# 0.87095f
C3050 VDD a_4871_5315# 0.01806f
C3051 CHAN2_MUX_SEL4 a_1256_3134# 0.65005f
C3052 CHAN2_MUX_SEL2 a_1721_3176# 0.01315f
C3053 CHAN2_MUX_SEL3 a_1544_3134# 0.15976f
C3054 a_15273_16869# a_15403_16869# 0.70845f
C3055 a_4187_2434# a_26803_16869# 0.06627f
C3056 a_18877_16869# a_19524_16035# 0.02011f
C3057 a_13470_16071# a_14825_15546# 0.02058f
C3058 a_4187_2434# a_5957_14024# 0.04141f
C3059 a_4187_2434# a_17683_7532# 0.06661f
C3060 a_19833_14024# a_20397_14024# 0.0114f
C3061 a_6153_7532# a_6283_7532# 0.70845f
C3062 a_8997_7532# a_8884_6698# 0.02055f
C3063 a_15077_4687# a_13470_3889# 0.05231f
C3064 a_16108_5979# a_19203_4687# 0.01539f
C3065 a_11277_4687# a_10843_4687# 0.6972f
C3066 a_14317_4687# a_14311_3853# 0.02349f
C3067 a_19637_1842# a_20105_1044# 0.19203f
C3068 a_27705_1044# a_27915_1044# 0.09424f
C3069 a_26471_1008# VDD 0.28336f
C3070 a_16923_1842# VDD 0.4982f
C3071 a_10951_2470# a_10843_1842# 0.01697f
C3072 a_4871_1842# a_4763_1842# 0.01163f
C3073 VDD a_2297_12513# 0.4659f
C3074 VDD a_19637_14024# 0.87095f
C3075 VDD a_10083_4687# 0.49994f
C3076 VDD a_14751_8160# 0.01806f
C3077 VDD a_17351_3853# 0.28637f
C3078 REF_MUX_SEL4 a_16108_5979# 0.1283f
C3079 REF_MUX_OUT a_15964_5979# 0.01307f
C3080 CHAN2_MUX_SEL4 a_4350_3889# 0.31434f
C3081 a_6717_16869# a_6283_16869# 0.6972f
C3082 a_4187_2434# a_9193_16869# 0.11222f
C3083 a_21625_16071# a_21911_16035# 0.01885f
C3084 a_11848_16071# a_11924_16035# 0.01176f
C3085 a_8997_16869# a_8884_16035# 0.02055f
C3086 a_16108_15316# a_19637_14024# 0.01314f
C3087 a_10713_14024# a_10843_14024# 0.70845f
C3088 a_4350_13226# a_5731_12471# 0.41099f
C3089 a_4187_2434# a_9757_1842# 0.0414f
C3090 a_23437_7532# a_23633_7532# 0.76914f
C3091 a_8563_7532# a_8671_7532# 0.01163f
C3092 a_14643_7532# a_14751_8160# 0.01697f
C3093 a_13019_11521# a_15464_9374# 0.59875f
C3094 a_6717_1842# a_7477_1842# 0.06198f
C3095 a_12505_3889# a_12791_3853# 0.01885f
C3096 a_18443_1842# a_18551_2470# 0.01697f
C3097 a_7945_1044# a_8155_1044# 0.09424f
C3098 a_24665_1044# VDD 0.29742f
C3099 a_19203_1842# a_4187_2434# 0.06627f
C3100 a_20723_1842# a_16108_3134# 0.01544f
C3101 VDD a_22873_16869# 0.49388f
C3102 VDD a_5191_13190# 0.28575f
C3103 VDD a_13753_7532# 0.49355f
C3104 VDD a_21911_6698# 0.2822f
C3105 VDD a_1256_3889# 0.48292f
C3106 CHAN0_DELAY_IN a_4157_16340# 0.50642f
C3107 a_8563_16869# a_8671_16869# 0.01163f
C3108 a_23437_16869# a_24197_16869# 0.03319f
C3109 a_4187_2434# a_21917_14024# 0.0414f
C3110 a_15403_14024# a_15511_14024# 0.01163f
C3111 a_21483_14024# a_21591_14652# 0.01697f
C3112 a_12505_13226# a_12715_13226# 0.09424f
C3113 a_4187_2434# a_12363_4687# 0.06482f
C3114 a_9946_11995# a_10206_11525# 0.75507f
C3115 a_14317_7532# a_15077_7532# 0.03319f
C3116 a_18117_7532# a_18004_6698# 0.02055f
C3117 a_22590_6734# a_22564_6698# 0.277f
C3118 a_13470_6734# a_5731_5979# 0.41365f
C3119 a_1256_3889# a_2297_4240# 0.04619f
C3120 a_18877_4687# a_19203_4687# 0.01427f
C3121 a_23437_4687# a_23431_3853# 0.02349f
C3122 a_24197_4687# a_22590_3889# 0.05231f
C3123 a_1544_3134# a_2297_3176# 0.27303f
C3124 a_22590_3889# a_16108_3134# 0.56869f
C3125 a_1256_3134# a_2873_3176# 0.27926f
C3126 a_21483_1842# a_19550_1044# 0.01012f
C3127 a_16793_1842# a_17357_1842# 0.0114f
C3128 a_25630_1044# a_26471_1008# 0.28268f
C3129 a_16510_1044# a_16851_309# 0.02131f
C3130 a_19311_2470# VDD 0.01806f
C3131 a_5731_289# CHAN3_MUX_SEL4 4.60702f
C3132 a_4350_1044# a_4763_1842# 0.01012f
C3133 VDD a_5197_16869# 0.86919f
C3134 VDD a_9751_16035# 0.2822f
C3135 VDD a_15108_11799# 0.135f
C3136 VDD a_25391_14652# 0.01806f
C3137 VDD a_4905_6734# 0.3017f
C3138 VDD a_4763_1842# 0.49875f
C3139 VDD a_26043_4687# 0.50058f
C3140 a_4187_2434# a_25153_16869# 0.11222f
C3141 a_14317_16869# a_14643_16869# 0.01427f
C3142 a_18117_16869# a_18004_16035# 0.02055f
C3143 a_22488_16071# a_22564_16035# 0.01176f
C3144 a_18877_14024# a_19637_14024# 0.06198f
C3145 a_4187_2434# a_16033_7532# 0.11287f
C3146 a_1256_12471# a_2297_12513# 0.04261f
C3147 a_1544_12471# a_1721_12513# 0.36963f
C3148 a_13557_7532# a_14025_6734# 0.19203f
C3149 a_8237_7532# a_7390_6734# 0.08038f
C3150 a_5197_7532# a_5523_7532# 0.01427f
C3151 a_9953_4687# a_10517_4687# 0.0114f
C3152 a_21625_6734# a_19550_6734# 0.03208f
C3153 a_10430_6734# a_11195_6734# 0.39037f
C3154 a_16108_5979# a_17553_4687# 0.01872f
C3155 a_27563_4687# a_27671_4687# 0.01163f
C3156 a_12797_4687# a_13444_3853# 0.02011f
C3157 a_16510_3889# a_17351_3853# 0.28268f
C3158 a_13470_1044# a_14888_1044# 0.38994f
C3159 a_4157_1313# a_2019_311# 0.01018f
C3160 a_15273_1842# VDD 0.4946f
C3161 a_24008_1044# VDD 0.17499f
C3162 a_9431_2470# a_9323_1842# 0.01697f
C3163 VDD a_16923_14024# 0.4982f
C3164 VDD a_26471_13190# 0.28336f
C3165 VDD a_8433_4687# 0.49593f
C3166 VDD a_8671_8160# 0.01806f
C3167 VDD a_14888_3889# 0.17499f
C3168 DLL_RESETN a_13132_11110# 0.01689f
C3169 a_4187_2434# a_7477_16869# 0.0414f
C3170 a_5393_16869# a_5957_16869# 0.0114f
C3171 a_8237_16869# a_7390_16071# 0.08038f
C3172 a_13557_16869# a_14025_16071# 0.19203f
C3173 a_26803_16869# a_26911_17497# 0.01697f
C3174 a_16108_15316# a_16923_14024# 0.01073f
C3175 a_9757_14024# a_10083_14024# 0.01427f
C3176 a_20105_16071# a_19550_16071# 0.03209f
C3177 a_10430_16071# a_10404_16035# 0.277f
C3178 a_14111_11568# a_15304_10295# 0.01811f
C3179 a_16510_13226# a_17275_13226# 0.39037f
C3180 a_4187_2434# a_7043_1842# 0.06627f
C3181 a_7043_7532# a_7151_7532# 0.01163f
C3182 a_13123_7532# a_13231_8160# 0.01697f
C3183 a_22113_7532# a_22243_7532# 0.70361f
C3184 a_5731_5979# a_15765_6153# 0.23301f
C3185 a_27237_7532# a_27124_6698# 0.02055f
C3186 a_10985_3889# a_10430_3889# 0.03209f
C3187 a_4350_3889# a_5768_3889# 0.38994f
C3188 a_27237_4687# a_26803_4687# 0.6972f
C3189 a_5731_3134# a_11473_1842# 0.01872f
C3190 a_5957_1842# a_5523_1842# 0.6972f
C3191 a_24957_1842# a_25153_1842# 0.76914f
C3192 a_16923_1842# a_17031_2470# 0.01697f
C3193 a_12505_1044# VDD 0.29876f
C3194 a_17553_1842# a_4187_2434# 0.11222f
C3195 a_19073_1842# a_16108_3134# 0.01872f
C3196 a_13470_1044# a_13883_1842# 0.01012f
C3197 VDD a_21157_16869# 0.85896f
C3198 VDD a_24665_13226# 0.29742f
C3199 VDD a_12037_7532# 0.86065f
C3200 VDD a_19448_6734# 0.17274f
C3201 CHAN0_MUX_SEL0 a_1721_16422# 0.01315f
C3202 CHAN0_MUX_SEL1 a_1544_16071# 0.1672f
C3203 a_22677_16869# a_22243_16869# 0.69698f
C3204 a_7043_16869# a_7151_16869# 0.01163f
C3205 a_27237_16869# a_27124_16035# 0.02055f
C3206 a_4187_2434# a_19203_14024# 0.06627f
C3207 a_5731_15316# a_14825_15546# 0.28056f
C3208 a_26673_14024# a_26803_14024# 0.70845f
C3209 a_4187_2434# a_10713_4687# 0.11222f
C3210 a_13883_14024# a_13991_14024# 0.01163f
C3211 a_19963_14024# a_20071_14652# 0.01697f
C3212 a_4350_13226# a_5191_13190# 0.28268f
C3213 a_9547_11632# a_9746_11495# 0.14994f
C3214 a_13557_7532# a_13123_7532# 0.69698f
C3215 a_17357_7532# a_16510_6734# 0.08038f
C3216 a_27237_7532# a_27705_6734# 0.2079f
C3217 a_18117_4687# a_18313_4687# 0.77122f
C3218 a_21917_4687# a_22564_3853# 0.02011f
C3219 a_15837_1842# a_16597_1842# 0.06198f
C3220 a_24875_1044# a_24951_1008# 0.01194f
C3221 a_13231_2470# VDD 0.01806f
C3222 a_2297_331# CHAN3_MUX_SEL4 0.04338f
C3223 VDD CHAN1_MUX_SEL4 2.69974f
C3224 a_2873_331# CHAN3_MUX_SEL3 0.12606f
C3225 a_3449_331# CHAN3_MUX_SEL2 0.10741f
C3226 a_7945_1044# a_7477_1842# 0.19203f
C3227 VDD a_7288_16071# 0.17274f
C3228 VDD a_19311_14652# 0.01806f
C3229 VDD a_13566_11525# 0.09469f
C3230 VDD a_2297_7085# 0.46536f
C3231 VDD a_24393_4687# 0.4946f
C3232 VDD a_17865_3364# 0.29444f
C3233 CHAN0_MUX_SEL4 a_4633_14024# 0.01287f
C3234 CHAN1_DELAY_IN a_4437_14024# 0.05007f
C3235 a_13557_16869# a_13753_16869# 0.73897f
C3236 a_17357_16869# a_16510_16071# 0.08038f
C3237 a_27237_16869# a_27705_16071# 0.2079f
C3238 a_4187_2434# a_23437_16869# 0.04012f
C3239 a_10430_16071# a_5731_15316# 0.41176f
C3240 a_4187_2434# a_14317_7532# 0.04317f
C3241 a_18117_14024# a_17683_14024# 0.6972f
C3242 a_4437_7532# a_4633_7532# 0.73897f
C3243 a_19550_13226# a_16108_12471# 0.58202f
C3244 a_6717_7532# a_6711_6698# 0.02354f
C3245 a_8997_4687# a_9757_4687# 0.02912f
C3246 a_27705_3889# a_27991_3853# 0.01885f
C3247 a_12037_4687# a_11924_3853# 0.02055f
C3248 a_26043_4687# a_26151_4687# 0.01163f
C3249 a_15755_3889# a_15831_3853# 0.01194f
C3250 a_23145_1044# a_23355_1044# 0.09424f
C3251 a_21044_1008# VDD 0.28225f
C3252 a_7911_2470# a_7803_1842# 0.01697f
C3253 VDD a_15273_14024# 0.4946f
C3254 VDD a_24008_13226# 0.17499f
C3255 VDD a_27997_7532# 0.76025f
C3256 VDD a_6717_4687# 0.88148f
C3257 VDD a_11924_3853# 0.28225f
C3258 REF_MUX_SEL4 a_3449_6021# 0.05166f
C3259 a_4187_2434# a_4763_16869# 0.06627f
C3260 a_4437_16869# a_5197_16869# 0.01669f
C3261 a_6717_16869# a_6711_16035# 0.02354f
C3262 a_25283_16869# a_25391_17497# 0.01697f
C3263 a_17065_16071# a_17351_16035# 0.01885f
C3264 a_8997_14024# a_9193_14024# 0.77122f
C3265 a_4187_2434# a_26673_4687# 0.11222f
C3266 a_27705_13226# a_27915_13226# 0.09424f
C3267 a_19637_14024# a_20105_13226# 0.19203f
C3268 a_12363_14024# a_10430_13226# 0.01012f
C3269 a_4187_2434# a_5393_1842# 0.11222f
C3270 a_6854_11144# a_5864_9057# 0.03661f
C3271 a_13880_11982# a_14111_11568# 0.12701f
C3272 a_14009_11568# a_14757_11918# 0.01058f
C3273 a_11603_7532# a_11711_8160# 0.01697f
C3274 a_5523_7532# a_5631_7532# 0.01163f
C3275 a_26477_7532# a_25630_6734# 0.08038f
C3276 a_25913_4687# a_26477_4687# 0.0114f
C3277 a_7945_3889# a_8231_3853# 0.01885f
C3278 a_5731_3134# a_9757_1842# 0.01307f
C3279 a_4633_1842# a_5197_1842# 0.0114f
C3280 a_23633_1842# a_23763_1842# 0.70845f
C3281 a_15403_1842# a_15511_2470# 0.01697f
C3282 a_4157_1313# a_4248_1044# 0.11672f
C3283 a_15964_289# a_16851_309# 0.16757f
C3284 a_3449_1395# VDD 0.46731f
C3285 a_15837_1842# a_4187_2434# 0.0414f
C3286 a_17357_1842# a_16108_3134# 0.01319f
C3287 a_13368_1044# a_12797_1842# 0.10864f
C3288 VDD a_18443_16869# 0.4973f
C3289 VDD a_12505_13226# 0.29876f
C3290 VDD a_1256_15316# 0.4205f
C3291 VDD a_9323_7532# 0.4973f
C3292 VDD a_16510_6734# 0.8795f
C3293 CHAN1_MUX_SEL3 a_1544_12471# 0.15976f
C3294 CHAN1_MUX_SEL4 a_1256_12471# 0.65005f
C3295 CHAN1_MUX_SEL2 a_1721_12513# 0.01315f
C3296 a_26477_16869# a_25630_16071# 0.08038f
C3297 a_21353_16869# a_21917_16869# 0.0114f
C3298 a_5523_16869# a_5631_16869# 0.01163f
C3299 a_4187_2434# a_17553_14024# 0.11222f
C3300 a_4437_14024# a_4905_13226# 0.19203f
C3301 a_12363_14024# a_12471_14024# 0.01163f
C3302 a_18443_14024# a_18551_14652# 0.01697f
C3303 a_4187_2434# a_8997_4687# 0.04152f
C3304 a_7945_13226# a_8155_13226# 0.09424f
C3305 a_12233_7532# a_12797_7532# 0.0114f
C3306 a_5974_11413# a_6126_9506# 1.74589f
C3307 a_6326_10280# a_6854_11144# 1.25249f
C3308 a_15837_7532# a_15831_6698# 0.02354f
C3309 a_19550_6734# a_20391_6698# 0.28268f
C3310 a_16793_4687# a_16923_4687# 0.70845f
C3311 a_16510_3889# a_17865_3364# 0.02165f
C3312 a_25630_3889# a_27048_3889# 0.38994f
C3313 a_21157_4687# a_21044_3853# 0.02055f
C3314 a_15077_1842# a_14643_1842# 0.6972f
C3315 a_22590_1044# a_24084_1008# 0.28279f
C3316 a_23355_1044# a_23431_1008# 0.01194f
C3317 a_7151_2470# VDD 0.01806f
C3318 VDD CHAN0_MUX_SEL4 2.7481f
C3319 a_6425_1044# a_5957_1842# 0.2079f
C3320 VDD a_13231_14652# 0.01806f
C3321 VDD a_4350_16071# 0.87635f
C3322 VDD a_12355_11557# 0.39937f
C3323 VDD a_22677_4687# 0.9172f
C3324 CHAN0_MUX_SEL4 a_16108_15316# 0.1283f
C3325 CHAN1_MUX_SEL4 a_4350_13226# 0.31434f
C3326 CHAN0_MUX_OUT a_15964_15316# 0.01307f
C3327 DLL_RESETN a_12797_7532# 0.0106f
C3328 CHAN2_MUX_SEL4 a_12797_4687# 0.01829f
C3329 a_4187_2434# a_20723_16869# 0.06627f
C3330 a_12233_16869# a_12363_16869# 0.70361f
C3331 a_15837_16869# a_15831_16035# 0.02354f
C3332 a_16793_14024# a_17357_14024# 0.0114f
C3333 a_7390_16071# a_8745_15546# 0.01756f
C3334 a_19550_16071# a_20315_16071# 0.39037f
C3335 a_4187_2434# a_11603_7532# 0.06627f
C3336 a_25630_13226# a_26471_13190# 0.28268f
C3337 a_21483_14024# a_19550_13226# 0.01012f
C3338 a_16510_13226# a_16851_12491# 0.02131f
C3339 a_15545_6734# a_15755_6734# 0.09424f
C3340 a_5197_7532# a_5844_6698# 0.02312f
C3341 a_7390_6734# a_8808_6734# 0.38994f
C3342 a_8237_4687# a_7803_4687# 0.6972f
C3343 a_18117_4687# a_18585_3889# 0.2079f
C3344 a_24523_4687# a_24631_4687# 0.01163f
C3345 a_13470_3889# a_14964_3853# 0.28279f
C3346 a_11277_4687# a_10430_3889# 0.08038f
C3347 a_14235_3889# a_14311_3853# 0.01194f
C3348 a_26185_3889# a_25630_3889# 0.03209f
C3349 a_12797_1842# a_12993_1842# 0.74917f
C3350 a_10430_1044# a_12715_1044# 0.39036f
C3351 a_18795_1044# VDD 0.15407f
C3352 DLL_RESETN REF_CLK 10.7375f
C3353 VDD CHAN3_DELAY_OUT_LAST 0.46919f
C3354 a_6391_2470# a_6283_1842# 0.01697f
C3355 VDD a_23871_17497# 0.01806f
C3356 VDD a_13557_14024# 0.87029f
C3357 VDD a_21044_13190# 0.28225f
C3358 VDD a_25283_7532# 0.49737f
C3359 VDD a_9675_3889# 0.15407f
C3360 VDD a_4003_4687# 0.61691f
C3361 REF_CLK a_14009_11568# 0.25847f
C3362 CHAN2_MUX_SEL1 a_3449_4240# 0.29404f
C3363 a_7390_16071# a_8231_16035# 0.28268f
C3364 a_5197_16869# a_5844_16035# 0.02312f
C3365 a_23763_16869# a_23871_17497# 0.01697f
C3366 a_5731_15316# a_15403_14024# 0.01563f
C3367 a_7673_14024# a_7803_14024# 0.70845f
C3368 a_4187_2434# a_24957_4687# 0.0414f
C3369 a_13470_13226# a_14888_13226# 0.38994f
C3370 a_12849_11557# a_14851_11918# 0.13392f
C3371 a_4003_7532# a_4111_7532# 0.01163f
C3372 a_20397_7532# a_20593_7532# 0.76914f
C3373 a_13121_11521# a_15688_11557# 0.17255f
C3374 a_10083_7532# a_10191_8160# 0.01697f
C3375 a_24957_7532# a_24951_6698# 0.02354f
C3376 a_24957_4687# a_25717_4687# 0.06198f
C3377 a_6425_3889# a_6635_3889# 0.09424f
C3378 a_5731_3134# a_7043_1842# 0.01539f
C3379 a_10430_1044# a_12797_1842# 0.02479f
C3380 VDD a_16793_16869# 0.49277f
C3381 VDD a_25630_16071# 0.90165f
C3382 VDD a_3449_13577# 0.46731f
C3383 VDD a_13444_6698# 0.28633f
C3384 VDD a_7673_7532# 0.49294f
C3385 REF_DELAY_OUT_LAST a_15108_11015# 0.01399f
C3386 a_20397_16869# a_21157_16869# 0.03319f
C3387 a_4003_16869# a_4111_16869# 0.01163f
C3388 a_24957_16869# a_24951_16035# 0.02354f
C3389 a_4187_2434# a_15837_14024# 0.0414f
C3390 a_16923_14024# a_17031_14652# 0.01697f
C3391 a_4187_2434# a_27563_7532# 0.06663f
C3392 a_24957_14024# a_25153_14024# 0.76914f
C3393 a_10843_14024# a_10951_14024# 0.01163f
C3394 a_25630_16071# a_16108_15316# 0.52614f
C3395 a_4187_2434# a_6283_4687# 0.06627f
C3396 a_11277_7532# a_12037_7532# 0.03319f
C3397 a_18795_6734# a_18871_6698# 0.01194f
C3398 a_14317_7532# a_14964_6698# 0.02312f
C3399 a_15837_4687# a_16163_4687# 0.01427f
C3400 a_20397_4687# a_19550_3889# 0.08038f
C3401 a_17357_1842# a_17928_1044# 0.10863f
C3402 a_26803_1842# VDD 0.49718f
C3403 a_4157_1313# a_4437_1842# 0.01771f
C3404 VDD a_20105_16071# 0.30409f
C3405 VDD a_7151_14652# 0.01806f
C3406 VDD a_19963_4687# 0.50058f
C3407 a_11277_16869# a_11603_16869# 0.01427f
C3408 a_4187_2434# a_19073_16869# 0.11222f
C3409 a_14317_16869# a_14964_16035# 0.02312f
C3410 a_15837_14024# a_16597_14024# 0.06198f
C3411 a_4187_2434# a_9953_7532# 0.11222f
C3412 a_24875_13226# a_24951_13190# 0.01194f
C3413 a_4437_7532# a_4350_6734# 0.1088f
C3414 a_5731_5979# a_14317_4687# 0.01319f
C3415 a_6913_4687# a_7477_4687# 0.0114f
C3416 a_9757_4687# a_9751_3853# 0.02354f
C3417 a_23003_4687# a_23111_4687# 0.01163f
C3418 a_11473_1842# a_11603_1842# 0.70845f
C3419 a_23145_3889# a_23431_3853# 0.01885f
C3420 a_18585_1044# a_18871_1008# 0.01885f
C3421 a_15831_1008# VDD 0.2816f
C3422 CHAN1_MUX_SEL2 CHAN1_MUX_SEL3 3.21891f
C3423 CHAN1_MUX_SEL1 CHAN1_MUX_SEL4 0.03574f
C3424 VDD CHAN2_DELAY_OUT_LAST 0.46919f
C3425 a_4871_2470# a_4763_1842# 0.01697f
C3426 VDD a_17791_17497# 0.01806f
C3427 VDD a_18795_13226# 0.15407f
C3428 VDD a_10843_14024# 0.50064f
C3429 VDD a_23633_7532# 0.49425f
C3430 VDD a_15964_5979# 0.31771f
C3431 VDD a_6711_3853# 0.2822f
C3432 CHAN0_MUX_OUT a_4187_2434# 1.28859f
C3433 REF_CLK a_13019_11521# 0.35409f
C3434 DLL_RESETN a_13121_11521# 0.04337f
C3435 CHAN2_MUX_SEL4 a_1256_3889# 0.04785f
C3436 a_22243_16869# a_22351_17497# 0.01697f
C3437 a_4437_16869# a_4350_16071# 0.1088f
C3438 a_6635_16071# a_6711_16035# 0.01194f
C3439 a_6717_14024# a_7043_14024# 0.01427f
C3440 a_5731_15316# a_13753_14024# 0.01865f
C3441 a_4187_2434# a_22243_4687# 0.06315f
C3442 a_23145_13226# a_23355_13226# 0.09424f
C3443 a_13306_11995# a_13566_11525# 0.75507f
C3444 a_12849_11557# a_13592_11561# 0.38817f
C3445 a_6854_11676# a_9444_10280# 0.05054f
C3446 a_13121_11521# a_14009_11568# 0.01604f
C3447 a_8563_7532# a_8671_8160# 0.01697f
C3448 a_19073_7532# a_19203_7532# 0.70845f
C3449 a_23437_7532# a_24084_6698# 0.02312f
C3450 a_24197_4687# a_23763_4687# 0.6972f
C3451 a_4157_4158# a_4350_3889# 0.04624f
C3452 a_16108_3134# a_16851_3154# 0.06181f
C3453 a_21917_1842# a_22113_1842# 0.76914f
C3454 a_26477_1842# a_27048_1044# 0.10863f
C3455 a_2019_311# a_15765_463# 0.05969f
C3456 a_10404_1008# a_10517_1842# 0.05157f
C3457 VDD a_22564_16035# 0.28964f
C3458 VDD a_15077_16869# 0.86016f
C3459 VDD a_11195_6734# 0.15389f
C3460 VDD a_5957_7532# 0.85889f
C3461 CHAN2_DELAY_OUT_LAST a_27997_4687# 0.70955f
C3462 CHAN2_MUX_SEL4 a_4763_1842# 0.01225f
C3463 a_19637_16869# a_19203_16869# 0.69698f
C3464 a_1544_16071# a_2297_16422# 0.28651f
C3465 a_4187_2434# a_13123_14024# 0.0643f
C3466 a_23437_16869# a_24084_16035# 0.02312f
C3467 a_9323_14024# a_9431_14024# 0.01163f
C3468 a_23633_14024# a_23763_14024# 0.70845f
C3469 a_15403_14024# a_15511_14652# 0.01697f
C3470 a_4187_2434# a_25913_7532# 0.11284f
C3471 a_4187_2434# a_4633_4687# 0.11222f
C3472 a_4157_13495# a_4248_13226# 0.11672f
C3473 a_15964_12471# a_16851_12491# 0.16757f
C3474 a_5731_12471# a_6854_11144# 0.05419f
C3475 a_10517_7532# a_10083_7532# 0.69698f
C3476 a_13557_7532# a_13470_6734# 0.1088f
C3477 a_16510_6734# a_18004_6698# 0.28279f
C3478 a_4350_6734# a_5705_6209# 0.02005f
C3479 a_17275_6734# a_17351_6698# 0.01194f
C3480 a_15077_4687# a_15273_4687# 0.77122f
C3481 a_18877_4687# a_18871_3853# 0.02354f
C3482 a_22590_3889# a_24875_3889# 0.39036f
C3483 a_19550_1044# a_21911_1008# 0.26208f
C3484 a_26985_519# VDD 0.29292f
C3485 a_25153_1842# VDD 0.49655f
C3486 VDD a_7945_16071# 0.30409f
C3487 VDD a_26803_14024# 0.49718f
C3488 VDD a_9746_11495# 0.0935f
C3489 VDD a_18313_4687# 0.4946f
C3490 VDD a_27991_3853# 0.28273f
C3491 CHAN0_MUX_SEL4 a_3449_15358# 0.05166f
C3492 a_10517_16869# a_10713_16869# 0.73897f
C3493 a_4187_2434# a_17357_16869# 0.04141f
C3494 a_16510_16071# a_17928_16071# 0.38994f
C3495 a_13557_16869# a_13470_16071# 0.1088f
C3496 a_15077_14024# a_14643_14024# 0.6972f
C3497 a_16108_15316# a_26803_14024# 0.01192f
C3498 a_4187_2434# a_8237_7532# 0.04141f
C3499 a_23355_13226# a_23431_13190# 0.01194f
C3500 a_22590_13226# a_24084_13190# 0.28279f
C3501 a_5731_5979# a_11603_4687# 0.01544f
C3502 a_5957_4687# a_6717_4687# 0.02912f
C3503 a_10985_6734# a_11195_6734# 0.09424f
C3504 a_4350_6734# a_6635_6734# 0.39036f
C3505 a_8237_4687# a_8884_3853# 0.02312f
C3506 a_21483_4687# a_21591_4687# 0.01163f
C3507 a_27563_4687# a_27671_5315# 0.01697f
C3508 a_10430_3889# a_12791_3853# 0.26208f
C3509 a_17065_1044# a_16510_1044# 0.03209f
C3510 a_13368_1044# VDD 0.17274f
C3511 VDD REF_DELAY_OUT_LAST 0.71342f
C3512 a_27433_1842# a_4187_2434# 0.11222f
C3513 VDD a_9193_14024# 0.4946f
C3514 VDD a_11711_17497# 0.01806f
C3515 VDD a_15831_13190# 0.2816f
C3516 VDD a_21917_7532# 0.89148f
C3517 VDD a_8745_6209# 0.29292f
C3518 VDD a_4248_3889# 0.17587f
C3519 REF_CLK a_11748_11799# 0.0148f
C3520 DLL_RESETN a_11491_11918# 0.14622f
C3521 a_20723_16869# a_20831_17497# 0.01697f
C3522 a_5957_14024# a_6153_14024# 0.77122f
C3523 a_5731_15316# a_12037_14024# 0.01319f
C3524 a_12505_16071# a_10430_16071# 0.03208f
C3525 a_4350_16071# a_5844_16035# 0.28279f
C3526 a_5115_16071# a_5191_16035# 0.01194f
C3527 a_8237_14024# a_8808_13226# 0.10863f
C3528 a_13019_11521# a_13121_11521# 0.56469f
C3529 a_4187_2434# a_20593_4687# 0.11222f
C3530 a_12656_11554# a_12849_11557# 0.33075f
C3531 a_12355_11557# a_13306_11995# 0.26489f
C3532 a_10430_13226# a_12715_13226# 0.39036f
C3533 a_7043_7532# a_7151_8160# 0.01697f
C3534 a_22677_7532# a_22590_6734# 0.1088f
C3535 a_19550_6734# a_20905_6209# 0.02165f
C3536 a_22873_4687# a_23437_4687# 0.0114f
C3537 a_20593_1842# a_20723_1842# 0.70845f
C3538 a_2019_311# a_5731_289# 1.15781f
C3539 a_25630_1044# a_26985_519# 0.02195f
C3540 VDD a_12363_16869# 0.92686f
C3541 VDD a_20315_16071# 0.15389f
C3542 VDD a_9712_9602# 0.21833f
C3543 VDD a_8231_6698# 0.28357f
C3544 VDD a_22351_5315# 0.02349f
C3545 VDD a_12993_1842# 0.49665f
C3546 CHAN1_MUX_SEL4 a_12797_14024# 0.01829f
C3547 CHAN2_MUX_OUT a_16851_3154# 0.45865f
C3548 a_18313_16869# a_18877_16869# 0.0114f
C3549 a_22677_16869# a_22590_16071# 0.1088f
C3550 a_4187_2434# a_11473_14024# 0.11222f
C3551 a_27915_16071# a_27991_16035# 0.01194f
C3552 a_4187_2434# a_24197_7532# 0.04188f
C3553 a_7803_14024# a_7911_14024# 0.01163f
C3554 a_13883_14024# a_13991_14652# 0.01697f
C3555 a_4187_2434# a_16108_5979# 0.21585f
C3556 a_9193_7532# a_9757_7532# 0.0114f
C3557 a_16108_5979# a_25717_4687# 0.01314f
C3558 a_13753_4687# a_13883_4687# 0.70845f
C3559 a_17357_4687# a_18004_3853# 0.02312f
C3560 a_10430_3889# a_11785_3364# 0.02058f
C3561 a_19448_1044# a_19550_1044# 0.37183f
C3562 a_23437_1842# VDD 0.87113f
C3563 a_14825_519# VDD 0.29292f
C3564 VDD a_2873_16422# 0.46517f
C3565 VDD a_25153_14024# 0.49655f
C3566 VDD a_26985_12701# 0.29292f
C3567 VDD a_16597_4687# 0.86971f
C3568 VDD a_25528_3889# 0.17274f
C3569 CHAN1_MUX_SEL1 a_3449_13577# 0.29404f
C3570 CHAN2_MUX_SEL4 a_6717_4687# 0.0195f
C3571 a_9193_16869# a_9323_16869# 0.70845f
C3572 a_4187_2434# a_14643_16869# 0.06627f
C3573 a_16108_15316# a_25153_14024# 0.01872f
C3574 a_4187_2434# a_5523_7532# 0.06627f
C3575 a_13753_14024# a_14317_14024# 0.0114f
C3576 a_17357_14024# a_17928_13226# 0.10863f
C3577 a_14111_10917# a_14851_10872# 0.26905f
C3578 a_26477_7532# a_26043_7532# 0.6972f
C3579 a_5731_5979# a_9953_4687# 0.01872f
C3580 a_5197_4687# a_4763_4687# 0.6972f
C3581 a_19963_4687# a_20071_4687# 0.01163f
C3582 a_26043_4687# a_26151_5315# 0.01697f
C3583 a_10328_3889# a_10430_3889# 0.37183f
C3584 a_7477_4687# a_7390_3889# 0.1088f
C3585 a_9757_1842# a_9953_1842# 0.76914f
C3586 a_14025_1044# a_14311_1008# 0.01885f
C3587 a_7288_1044# a_7364_1008# 0.01176f
C3588 a_10430_1044# VDD 1.08486f
C3589 CHAN0_MUX_SEL1 CHAN0_MUX_SEL4 0.03574f
C3590 a_25717_1842# a_4187_2434# 0.0414f
C3591 CHAN0_MUX_SEL2 CHAN0_MUX_SEL3 3.21891f
C3592 a_14643_1842# a_14513_1842# 0.70845f
C3593 VDD a_5631_17497# 0.01806f
C3594 VDD a_7477_14024# 0.871f
C3595 VDD a_13368_13226# 0.17274f
C3596 VDD a_19203_7532# 0.49737f
C3597 VDD a_2873_6021# 0.46598f
C3598 VDD a_18585_3889# 0.29742f
C3599 a_19203_16869# a_19311_17497# 0.01697f
C3600 a_26477_16869# a_26673_16869# 0.76914f
C3601 a_4633_14024# a_4763_14024# 0.70845f
C3602 a_5731_15316# a_9323_14024# 0.01542f
C3603 a_4187_2434# a_27433_14024# 0.11222f
C3604 a_4187_2434# a_18877_4687# 0.0414f
C3605 a_18585_13226# a_18871_13190# 0.01885f
C3606 a_17357_7532# a_17553_7532# 0.76914f
C3607 a_5523_7532# a_5631_8160# 0.01697f
C3608 a_21917_4687# a_22677_4687# 0.06198f
C3609 a_25630_6734# a_27915_6734# 0.39036f
C3610 a_26477_4687# a_27124_3853# 0.02312f
C3611 a_2297_331# a_2019_311# 0.04011f
C3612 REF_CLK REF_MUX_SEL1 0.01858f
C3613 VDD a_10713_16869# 0.49296f
C3614 a_7390_1044# a_8997_1842# 0.05231f
C3615 a_8231_1008# a_8237_1842# 0.02349f
C3616 VDD a_17351_16035# 0.28637f
C3617 VDD a_5768_6734# 0.17499f
C3618 VDD a_16271_5315# 0.01806f
C3619 VDD a_11277_1842# 0.87182f
C3620 REF_MUX_SEL1 a_2873_7085# 0.13092f
C3621 a_4187_2434# a_9757_14024# 0.0414f
C3622 a_17357_16869# a_18117_16869# 0.03319f
C3623 a_26395_16071# a_26471_16035# 0.01194f
C3624 a_25630_16071# a_27124_16035# 0.28279f
C3625 a_12363_14024# a_12471_14652# 0.01697f
C3626 a_26477_14024# a_27048_13226# 0.10863f
C3627 a_4187_2434# a_21483_7532# 0.06661f
C3628 a_6283_14024# a_6391_14024# 0.01163f
C3629 a_21917_14024# a_22113_14024# 0.76914f
C3630 a_8237_7532# a_8997_7532# 0.03319f
C3631 a_13470_6734# a_15831_6698# 0.26208f
C3632 a_26185_6734# a_26395_6734# 0.09424f
C3633 a_16597_4687# a_16510_3889# 0.1088f
C3634 a_17928_1044# a_18004_1008# 0.01176f
C3635 a_20723_1842# VDD 0.49691f
C3636 VDD a_1256_16071# 0.48292f
C3637 VDD a_23437_14024# 0.87113f
C3638 VDD a_14825_12701# 0.29292f
C3639 VDD a_26151_8160# 0.01806f
C3640 VDD a_13883_4687# 0.50061f
C3641 CHAN2_MUX_OUT CHAN3_DELAY_IN 0.05155f
C3642 VDD a_22590_3889# 0.98586f
C3643 CHAN1_MUX_SEL4 a_1256_13226# 0.04785f
C3644 REF_CLK a_4437_7532# 0.05209f
C3645 a_8237_16869# a_8563_16869# 0.01427f
C3646 a_4187_2434# a_12993_16869# 0.11169f
C3647 a_12797_14024# a_13557_14024# 0.05851f
C3648 a_27705_16071# a_25630_16071# 0.03208f
C3649 a_4187_2434# a_5864_9057# 0.03252f
C3650 a_13470_16071# a_15755_16071# 0.39036f
C3651 a_19550_13226# a_21911_13190# 0.26208f
C3652 a_13306_10795# a_14009_10774# 0.02454f
C3653 a_4187_2434# a_13557_1842# 0.04101f
C3654 a_25153_7532# a_25717_7532# 0.0114f
C3655 a_24523_4687# a_24631_5315# 0.01697f
C3656 a_18443_4687# a_18551_4687# 0.01163f
C3657 a_5731_5979# a_8237_4687# 0.01319f
C3658 a_18585_3889# a_16510_3889# 0.03208f
C3659 a_8808_3889# a_8884_3853# 0.01176f
C3660 a_8433_1842# a_8563_1842# 0.70845f
C3661 a_27997_1842# a_27563_1842# 0.69646f
C3662 a_7364_1008# VDD 0.28633f
C3663 a_23003_1842# a_4187_2434# 0.06391f
C3664 a_24523_1842# a_16108_3134# 0.01542f
C3665 VDD a_26673_16869# 0.49417f
C3666 VDD a_4763_14024# 0.49875f
C3667 VDD a_10430_13226# 1.08486f
C3668 VDD a_17553_7532# 0.49417f
C3669 VDD a_27048_6734# 0.17499f
C3670 CHAN1_DELAY_OUT_LAST a_27997_14024# 0.70955f
C3671 DLL_RESETN a_6854_11676# 0.46676f
C3672 a_25153_16869# a_25283_16869# 0.70845f
C3673 a_17683_16869# a_17791_17497# 0.01697f
C3674 a_4187_2434# a_25717_14024# 0.0414f
C3675 a_6425_16071# a_6711_16035# 0.01885f
C3676 a_5731_15316# a_7673_14024# 0.01865f
C3677 a_17065_13226# a_16510_13226# 0.03209f
C3678 a_4187_2434# a_16163_4687# 0.06627f
C3679 a_11748_11799# a_11491_11918# 0.34468f
C3680 a_16033_7532# a_16163_7532# 0.70845f
C3681 a_4187_2434# a_25630_3889# 0.02246f
C3682 a_4003_7532# a_4111_8160# 0.01697f
C3683 a_21157_4687# a_20723_4687# 0.6972f
C3684 a_25717_4687# a_25630_3889# 0.1088f
C3685 a_18877_1842# a_19073_1842# 0.76914f
C3686 a_1544_1044# a_1721_1395# 0.38063f
C3687 a_1256_289# a_1721_331# 0.13421f
C3688 a_7364_1008# a_6717_1842# 0.02011f
C3689 VDD a_8997_16869# 0.85889f
C3690 VDD a_14888_16071# 0.17499f
C3691 VDD a_14009_10774# 0.31815f
C3692 VDD a_26185_6734# 0.30409f
C3693 VDD a_10191_5315# 0.01806f
C3694 VDD a_8563_1842# 0.49684f
C3695 REF_MUX_SEL0 a_1544_6734# 0.07603f
C3696 REF_MUX_SEL1 a_1256_6734# 1.44243f
C3697 a_16597_16869# a_16163_16869# 0.69698f
C3698 a_4187_2434# a_7043_14024# 0.06627f
C3699 a_4187_2434# a_19833_7532# 0.11284f
C3700 a_4763_14024# a_4871_14024# 0.01163f
C3701 a_20593_14024# a_20723_14024# 0.70845f
C3702 a_10843_14024# a_10951_14652# 0.01697f
C3703 a_25630_13226# a_26985_12701# 0.02195f
C3704 a_7477_7532# a_7043_7532# 0.69698f
C3705 a_13368_6734# a_13470_6734# 0.37183f
C3706 a_12037_4687# a_12233_4687# 0.77122f
C3707 a_16108_5979# a_21353_4687# 0.01872f
C3708 a_19448_3889# a_19524_3853# 0.01176f
C3709 a_21157_1842# a_21625_1044# 0.2079f
C3710 a_16510_1044# a_16484_1008# 0.277f
C3711 a_19073_1842# VDD 0.49655f
C3712 a_1721_331# VDD 0.45259f
C3713 VDD a_20723_14024# 0.49691f
C3714 VDD a_20071_8160# 0.01806f
C3715 VDD a_12233_4687# 0.59884f
C3716 VDD a_19524_3853# 0.28633f
C3717 REF_MUX_SEL4 a_4003_4687# 0.01225f
C3718 a_4187_2434# a_11277_16869# 0.04141f
C3719 a_7477_16869# a_7673_16869# 0.73897f
C3720 a_16108_15316# a_20723_14024# 0.01544f
C3721 a_12037_14024# a_11603_14024# 0.6972f
C3722 a_19448_13226# a_19550_13226# 0.37183f
C3723 a_4187_2434# a_10843_1842# 0.06627f
C3724 a_24197_7532# a_24957_7532# 0.02912f
C3725 a_15304_10295# a_13592_11113# 0.01817f
C3726 a_6425_6734# a_4350_6734# 0.03208f
C3727 a_24957_7532# a_16108_5979# 0.0157f
C3728 a_16108_5979# a_20905_6209# 0.2906f
C3729 a_5731_5979# a_5523_4687# 0.01562f
C3730 a_23003_4687# a_23111_5315# 0.01697f
C3731 a_16923_4687# a_17031_4687# 0.01163f
C3732 a_7390_3889# a_7364_3853# 0.277f
C3733 a_26673_1842# a_27237_1842# 0.0114f
C3734 a_4350_1044# a_5115_1044# 0.39037f
C3735 a_5115_1044# VDD 0.15389f
C3736 a_21353_1842# a_4187_2434# 0.11222f
C3737 a_22873_1842# a_16108_3134# 0.01865f
C3738 VDD a_24957_16869# 0.87825f
C3739 VDD a_7364_13190# 0.28633f
C3740 VDD a_17865_15546# 0.29444f
C3741 VDD a_24084_6698# 0.28225f
C3742 VDD a_15837_7532# 0.87963f
C3743 CHAN1_MUX_OUT a_16851_12491# 0.45865f
C3744 a_16163_16869# a_16271_17497# 0.01697f
C3745 a_4905_16071# a_4350_16071# 0.03209f
C3746 a_4157_16340# a_4324_16035# 0.02463f
C3747 a_4187_2434# a_23003_14024# 0.06391f
C3748 a_24957_16869# a_16108_15316# 0.0157f
C3749 a_4763_14024# a_4350_13226# 0.01012f
C3750 a_16108_15316# a_17865_15546# 0.29564f
C3751 a_5731_15316# a_5957_14024# 0.01644f
C3752 a_7288_13226# a_7364_13190# 0.01176f
C3753 a_14025_13226# a_14311_13190# 0.01885f
C3754 a_4187_2434# a_14513_4687# 0.11222f
C3755 a_10232_11561# a_10520_11982# 0.43707f
C3756 a_13470_6734# a_14825_6209# 0.02058f
C3757 a_19833_4687# a_20397_4687# 0.0114f
C3758 a_17553_1842# a_17683_1842# 0.70845f
C3759 a_21917_1842# a_22488_1044# 0.10864f
C3760 a_24631_2470# VDD 0.01806f
C3761 a_14825_519# CHAN3_MUX_SEL4 0.03307f
C3762 a_5844_1008# a_5957_1842# 0.02055f
C3763 VDD a_11924_16035# 0.28225f
C3764 VDD a_6283_16869# 0.4973f
C3765 VDD a_14025_6734# 0.30409f
C3766 VDD a_6913_1842# 0.49655f
C3767 VDD a_4111_5315# 0.01866f
C3768 CHAN1_MUX_SEL4 a_6717_14024# 0.0195f
C3769 CHAN2_MUX_SEL3 a_1256_3134# 1.41161f
C3770 CHAN2_MUX_SEL2 a_1544_3134# 0.07405f
C3771 CHAN2_DELAY_IN a_3449_3176# 0.01017f
C3772 a_4187_2434# a_27237_16869# 0.06254f
C3773 a_15273_16869# a_15837_16869# 0.0114f
C3774 a_4187_2434# a_5393_14024# 0.11222f
C3775 a_22590_16071# a_24951_16035# 0.26208f
C3776 a_9323_14024# a_9431_14652# 0.01697f
C3777 a_4187_2434# a_18117_7532# 0.04188f
C3778 a_15077_7532# a_15545_6734# 0.2079f
C3779 a_6153_7532# a_6717_7532# 0.0114f
C3780 a_9323_7532# a_7390_6734# 0.01012f
C3781 a_21625_6734# a_21911_6698# 0.01885f
C3782 a_11848_6734# a_11924_6698# 0.01176f
C3783 a_16108_5979# a_19637_4687# 0.01314f
C3784 a_10713_4687# a_10843_4687# 0.70845f
C3785 a_4350_3889# a_5731_3134# 0.41099f
C3786 a_26395_1044# VDD 0.1539f
C3787 a_17357_1842# VDD 0.87006f
C3788 a_10430_1044# CHAN3_MUX_SEL4 0.21179f
C3789 VDD a_1721_12513# 0.45352f
C3790 VDD a_19073_14024# 0.49655f
C3791 VDD a_13991_8160# 0.01806f
C3792 VDD a_10517_4687# 0.871f
C3793 VDD a_17275_3889# 0.15389f
C3794 REF_MUX_OUT CHAN2_DELAY_IN 0.05155f
C3795 DLL_RESETN a_9444_10280# 0.10269f
C3796 REF_MUX_SEL4 a_15964_5979# 0.5544f
C3797 a_4187_2434# a_8563_16869# 0.06627f
C3798 a_6153_16869# a_6283_16869# 0.70845f
C3799 a_9323_16869# a_7390_16071# 0.01012f
C3800 a_15077_16869# a_15545_16071# 0.2079f
C3801 a_21625_16071# a_21835_16071# 0.09424f
C3802 a_10713_14024# a_11277_14024# 0.0114f
C3803 a_13883_14024# a_13470_13226# 0.01012f
C3804 a_16108_15316# a_19073_14024# 0.01872f
C3805 a_17928_13226# a_18004_13190# 0.01176f
C3806 a_4187_2434# a_9193_1842# 0.11222f
C3807 a_23437_7532# a_23003_7532# 0.6972f
C3808 a_21483_4687# a_21591_5315# 0.01697f
C3809 a_15403_4687# a_15511_4687# 0.01163f
C3810 a_6717_1842# a_6913_1842# 0.76914f
C3811 a_12505_3889# a_12715_3889# 0.09424f
C3812 a_25717_1842# a_26477_1842# 0.01669f
C3813 a_9465_1044# a_7390_1044# 0.03208f
C3814 a_23145_1044# VDD 0.30411f
C3815 a_19637_1842# a_4187_2434# 0.0414f
C3816 a_21157_1842# a_16108_3134# 0.01319f
C3817 VDD a_22243_16869# 0.95024f
C3818 VDD a_5115_13226# 0.15389f
C3819 VDD a_21835_6734# 0.15406f
C3820 VDD a_13123_7532# 0.48169f
C3821 CHAN0_MUX_SEL1 a_2873_16422# 0.13092f
C3822 CHAN0_DELAY_IN a_3449_16422# 0.01058f
C3823 a_23437_16869# a_23633_16869# 0.76914f
C3824 a_14643_16869# a_14751_17497# 0.01697f
C3825 a_4187_2434# a_21353_14024# 0.11222f
C3826 a_27997_14024# a_27563_14024# 0.69646f
C3827 a_7477_14024# a_7945_13226# 0.19203f
C3828 a_4187_2434# a_12797_4687# 0.0414f
C3829 a_14317_7532# a_14513_7532# 0.76914f
C3830 a_18443_7532# a_16510_6734# 0.01012f
C3831 a_22488_6734# a_22564_6698# 0.01176f
C3832 a_18877_4687# a_19637_4687# 0.06198f
C3833 a_1544_3134# a_1721_3176# 0.36963f
C3834 a_1256_3134# a_2297_3176# 0.04261f
C3835 a_21917_1842# a_19550_1044# 0.02479f
C3836 a_25630_1044# a_26395_1044# 0.39037f
C3837 a_16510_1044# a_16108_289# 0.56108f
C3838 a_18551_2470# VDD 0.01806f
C3839 VDD a_4633_16869# 0.49285f
C3840 a_4350_1044# a_5197_1842# 0.08038f
C3841 a_9465_1044# a_8997_1842# 0.2079f
C3842 VDD a_9675_16071# 0.15406f
C3843 VDD a_24631_14652# 0.01806f
C3844 VDD a_14111_11568# 0.21331f
C3845 VDD a_4157_7003# 0.48942f
C3846 VDD a_26477_4687# 0.87185f
C3847 VDD a_5197_1842# 0.87047f
C3848 a_14317_16869# a_15077_16869# 0.03319f
C3849 a_4187_2434# a_24523_16869# 0.06627f
C3850 a_18443_16869# a_16510_16071# 0.01012f
C3851 a_22488_16071# a_22590_16071# 0.37183f
C3852 a_4187_2434# a_15403_7532# 0.06668f
C3853 a_1544_13226# a_1721_13577# 0.38063f
C3854 a_18877_14024# a_19073_14024# 0.76914f
C3855 a_7803_14024# a_7911_14652# 0.01697f
C3856 a_1256_12471# a_1721_12513# 0.13421f
C3857 a_5197_7532# a_5957_7532# 0.03319f
C3858 a_16108_5979# a_16923_4687# 0.01073f
C3859 a_20105_6734# a_19550_6734# 0.03209f
C3860 a_9757_4687# a_10083_4687# 0.01427f
C3861 a_10430_6734# a_10404_6698# 0.277f
C3862 a_16510_3889# a_17275_3889# 0.39037f
C3863 a_13470_1044# a_14311_1008# 0.28268f
C3864 a_14643_1842# VDD 0.49684f
C3865 a_23431_1008# VDD 0.28336f
C3866 VDD a_17357_14024# 0.87006f
C3867 VDD a_26395_13226# 0.1539f
C3868 VDD a_7803_4687# 0.50058f
C3869 VDD a_7911_8160# 0.01806f
C3870 VDD a_14311_3853# 0.28357f
C3871 DLL_RESETN a_12907_11110# 0.04234f
C3872 REF_MUX_OUT a_5731_5979# 1.04829f
C3873 REF_MUX_SEL4 a_8745_6209# 0.04472f
C3874 a_5197_16869# a_5523_16869# 0.01427f
C3875 a_4187_2434# a_6913_16869# 0.11222f
C3876 a_16108_15316# a_17357_14024# 0.01319f
C3877 a_10328_16071# a_10404_16035# 0.01176f
C3878 a_9757_14024# a_10517_14024# 0.06198f
C3879 a_21157_14024# a_21625_13226# 0.2079f
C3880 a_12797_14024# a_13368_13226# 0.10864f
C3881 a_16510_13226# a_16484_13190# 0.277f
C3882 a_4187_2434# a_7477_1842# 0.0414f
C3883 a_12849_11557# a_14111_10917# 0.42064f
C3884 a_14851_11918# a_14757_11918# 0.28931f
C3885 a_27563_7532# a_25630_6734# 0.01024f
C3886 a_22113_7532# a_22677_7532# 0.0114f
C3887 a_5731_5979# a_14825_6209# 0.28056f
C3888 a_13883_4687# a_13991_4687# 0.01163f
C3889 a_19963_4687# a_20071_5315# 0.01697f
C3890 a_4350_3889# a_5191_3853# 0.28268f
C3891 a_26673_4687# a_26803_4687# 0.70845f
C3892 a_5731_3134# a_10843_1842# 0.01539f
C3893 a_5393_1842# a_5523_1842# 0.70845f
C3894 a_24957_1842# a_24523_1842# 0.6972f
C3895 a_10985_1044# VDD 0.30411f
C3896 a_16923_1842# a_4187_2434# 0.06627f
C3897 a_18443_1842# a_16108_3134# 0.01542f
C3898 a_13470_1044# a_14317_1842# 0.08038f
C3899 VDD a_20593_16869# 0.49419f
C3900 VDD a_23145_13226# 0.30411f
C3901 VDD a_11473_7532# 0.49426f
C3902 VDD a_18871_6698# 0.2822f
C3903 CHAN0_MUX_SEL0 a_1544_16071# 0.07603f
C3904 CHAN0_MUX_SEL1 a_1256_16071# 1.44243f
C3905 a_13123_16869# a_13231_17497# 0.01697f
C3906 a_22113_16869# a_22243_16869# 0.70361f
C3907 a_5731_15316# a_11785_15546# 0.28056f
C3908 a_27563_16869# a_25630_16071# 0.01024f
C3909 a_4187_2434# a_19637_14024# 0.0414f
C3910 a_4350_13226# a_5115_13226# 0.39037f
C3911 a_26673_14024# a_27237_14024# 0.0114f
C3912 a_5957_14024# a_6425_13226# 0.2079f
C3913 a_4187_2434# a_10083_4687# 0.06627f
C3914 a_5731_12471# a_12849_11557# 0.01811f
C3915 a_9547_11632# a_9547_11862# 0.1117f
C3916 a_12993_7532# a_13123_7532# 0.70361f
C3917 a_10430_6734# a_5731_5979# 0.41176f
C3918 a_18117_4687# a_17683_4687# 0.6972f
C3919 a_19550_3889# a_16108_3134# 0.58202f
C3920 a_19637_1842# a_19524_1008# 0.05157f
C3921 a_15837_1842# a_16033_1842# 0.76914f
C3922 a_12471_2470# VDD 0.02372f
C3923 a_2873_331# CHAN3_MUX_SEL2 0.01422f
C3924 a_1544_289# CHAN3_MUX_OUT 0.69943f
C3925 a_1721_331# CHAN3_MUX_SEL4 0.05813f
C3926 VDD CHAN1_MUX_SEL3 0.41538f
C3927 a_2297_331# CHAN3_MUX_SEL3 0.01595f
C3928 VDD a_6711_16035# 0.2822f
C3929 VDD a_18551_14652# 0.01806f
C3930 VDD a_23763_4687# 0.49688f
C3931 VDD a_16851_3154# 0.52304f
C3932 CHAN0_MUX_SEL4 a_4003_14024# 0.01225f
C3933 a_13557_16869# a_13123_16869# 0.69698f
C3934 a_4187_2434# a_22873_16869# 0.11169f
C3935 a_6283_14024# a_6391_14652# 0.01697f
C3936 a_17553_14024# a_17683_14024# 0.70845f
C3937 a_4187_2434# a_13753_7532# 0.11222f
C3938 a_20968_16071# a_21044_16035# 0.01176f
C3939 a_21917_14024# a_22488_13226# 0.10864f
C3940 a_4437_7532# a_4003_7532# 0.69698f
C3941 a_8997_4687# a_9193_4687# 0.77122f
C3942 a_17065_6734# a_17351_6698# 0.01885f
C3943 a_27705_3889# a_27915_3889# 0.09424f
C3944 a_12363_4687# a_10430_3889# 0.01012f
C3945 a_19637_4687# a_20105_3889# 0.19203f
C3946 a_13557_1842# a_14317_1842# 0.01669f
C3947 a_24665_1044# a_22590_1044# 0.03208f
C3948 a_12715_1044# a_12791_1008# 0.01194f
C3949 a_20968_1044# VDD 0.17499f
C3950 VDD a_14643_14024# 0.49684f
C3951 VDD a_23431_13190# 0.28336f
C3952 VDD a_27433_7532# 0.49285f
C3953 VDD a_6153_4687# 0.4946f
C3954 VDD a_11848_3889# 0.17499f
C3955 REF_MUX_SEL4 a_2873_6021# 0.04916f
C3956 REF_MUX_OUT a_2297_6021# 0.01179f
C3957 REF_MUX_SEL3 a_3449_6021# 0.28429f
C3958 a_4437_16869# a_4633_16869# 0.73897f
C3959 a_4187_2434# a_5197_16869# 0.04141f
C3960 a_8997_14024# a_8563_14024# 0.6972f
C3961 a_17065_16071# a_17275_16071# 0.09424f
C3962 a_4187_2434# a_26043_4687# 0.06627f
C3963 a_12797_14024# a_10430_13226# 0.02479f
C3964 a_4187_2434# a_4763_1842# 0.06627f
C3965 a_13592_11561# a_14757_11918# 0.43239f
C3966 a_6854_11144# a_9712_9602# 0.67835f
C3967 a_6126_9506# a_5864_9057# 0.23738f
C3968 a_18877_7532# a_16108_5979# 0.0157f
C3969 a_21157_7532# a_21917_7532# 0.02912f
C3970 a_4437_4687# a_4905_3889# 0.19203f
C3971 a_18443_4687# a_18551_5315# 0.01697f
C3972 a_12363_4687# a_12471_4687# 0.01163f
C3973 a_7945_3889# a_8155_3889# 0.09424f
C3974 a_5731_3134# a_9193_1842# 0.01872f
C3975 a_23633_1842# a_24197_1842# 0.0114f
C3976 a_15964_289# a_16108_289# 0.42202f
C3977 a_15273_1842# a_4187_2434# 0.11222f
C3978 a_16793_1842# a_16108_3134# 0.01843f
C3979 a_12791_1008# a_12797_1842# 0.02354f
C3980 VDD a_18877_16869# 0.87825f
C3981 VDD a_27991_16035# 0.28273f
C3982 VDD a_10985_13226# 0.30411f
C3983 VDD a_9757_7532# 0.87771f
C3984 VDD a_16408_6734# 0.17274f
C3985 CHAN1_DELAY_IN a_3449_12513# 0.01017f
C3986 CHAN1_MUX_SEL3 a_1256_12471# 1.41161f
C3987 CHAN1_MUX_SEL2 a_1544_12471# 0.07405f
C3988 a_4187_2434# a_16923_14024# 0.06627f
C3989 a_11603_16869# a_11711_17497# 0.01697f
C3990 a_18877_16869# a_16108_15316# 0.0157f
C3991 a_25717_14024# a_26477_14024# 0.01669f
C3992 a_4437_14024# a_4157_13495# 0.01771f
C3993 a_4187_2434# a_8433_4687# 0.11222f
C3994 a_9465_13226# a_7390_13226# 0.03208f
C3995 a_5974_11413# a_6854_11676# 0.029f
C3996 a_6326_10280# a_6126_9506# 2.84014f
C3997 a_19550_6734# a_20315_6734# 0.39037f
C3998 a_16793_4687# a_17357_4687# 0.0114f
C3999 a_7390_6734# a_8745_6209# 0.01756f
C4000 a_21483_4687# a_19550_3889# 0.01012f
C4001 a_16510_3889# a_16851_3154# 0.02131f
C4002 a_25630_3889# a_26471_3853# 0.28268f
C4003 a_22590_1044# a_24008_1044# 0.38994f
C4004 a_6391_2470# VDD 0.01806f
C4005 VDD CHAN0_MUX_SEL3 0.421f
C4006 VDD a_12471_14652# 0.02372f
C4007 VDD a_4248_16071# 0.17587f
C4008 VDD a_22113_4687# 0.55574f
C4009 CHAN0_MUX_SEL4 a_15964_15316# 0.5544f
C4010 a_12233_16869# a_12797_16869# 0.0114f
C4011 a_4187_2434# a_21157_16869# 0.04152f
C4012 a_4763_14024# a_4871_14652# 0.01697f
C4013 a_19550_16071# a_19524_16035# 0.277f
C4014 a_4187_2434# a_12037_7532# 0.04152f
C4015 a_7390_16071# a_5731_15316# 0.41331f
C4016 a_21917_14024# a_19550_13226# 0.02479f
C4017 a_25630_13226# a_26395_13226# 0.39037f
C4018 a_16510_13226# a_16108_12471# 0.56108f
C4019 a_7390_6734# a_8231_6698# 0.28268f
C4020 a_5197_7532# a_5768_6734# 0.10863f
C4021 a_5731_5979# a_15403_4687# 0.01563f
C4022 a_7673_4687# a_7803_4687# 0.70845f
C4023 a_13470_3889# a_14888_3889# 0.38994f
C4024 a_12797_1842# a_12363_1842# 0.6972f
C4025 a_10430_1044# a_11924_1008# 0.28279f
C4026 a_11195_1044# a_11271_1008# 0.01194f
C4027 a_18004_1008# VDD 0.28225f
C4028 VDD CHAN3_DELAY_IN 1.50408f
C4029 CHAN1_MUX_OUT REF_CLK 0.0767f
C4030 VDD a_23111_17497# 0.01806f
C4031 VDD a_20968_13226# 0.17499f
C4032 VDD a_12993_14024# 0.49665f
C4033 VDD a_25717_7532# 0.86712f
C4034 VDD a_8884_3853# 0.28225f
C4035 VDD a_4437_4687# 0.872f
C4036 REF_CLK a_13592_11561# 0.11539f
C4037 CHAN2_MUX_SEL0 a_3449_4240# 0.10753f
C4038 a_7390_16071# a_8155_16071# 0.39037f
C4039 a_5197_16869# a_5768_16071# 0.10863f
C4040 a_7673_14024# a_8237_14024# 0.0114f
C4041 a_10517_14024# a_10404_13190# 0.05157f
C4042 a_4187_2434# a_24393_4687# 0.11222f
C4043 a_13470_13226# a_14311_13190# 0.28268f
C4044 a_12849_11557# a_15108_11799# 0.10225f
C4045 a_13306_11995# a_14111_11568# 0.097f
C4046 a_20397_7532# a_19963_7532# 0.6972f
C4047 a_13121_11521# a_14851_11918# 0.03404f
C4048 a_13019_11521# a_15688_11557# 0.0195f
C4049 a_24957_4687# a_25153_4687# 0.76914f
C4050 a_16923_4687# a_17031_5315# 0.01697f
C4051 a_25630_6734# a_16108_5979# 0.52614f
C4052 a_10843_4687# a_10951_4687# 0.01163f
C4053 a_5731_3134# a_7477_1842# 0.01314f
C4054 a_22677_1842# a_23437_1842# 0.01323f
C4055 a_21917_1842# a_16108_289# 0.01053f
C4056 a_1721_1395# VDD 0.4533f
C4057 a_11924_1008# a_11277_1842# 0.02312f
C4058 VDD a_16163_16869# 0.4973f
C4059 VDD a_25528_16071# 0.17274f
C4060 VDD a_7043_7532# 0.49723f
C4061 VDD a_13470_6734# 0.87936f
C4062 REF_DELAY_OUT_LAST a_14851_10872# 0.02109f
C4063 a_10083_16869# a_10191_17497# 0.01697f
C4064 a_20397_16869# a_20593_16869# 0.76914f
C4065 a_4187_2434# a_15273_14024# 0.11222f
C4066 a_24957_14024# a_24523_14024# 0.6972f
C4067 a_4187_2434# a_27997_7532# 0.04038f
C4068 a_4187_2434# a_6717_4687# 0.0414f
C4069 a_11277_7532# a_11473_7532# 0.76914f
C4070 a_14317_7532# a_14888_6734# 0.10863f
C4071 a_15837_4687# a_16597_4687# 0.06198f
C4072 a_24875_3889# a_24951_3853# 0.01194f
C4073 a_18117_1842# a_16510_1044# 0.05231f
C4074 a_17357_1842# a_17351_1008# 0.02349f
C4075 a_27237_1842# VDD 0.86278f
C4076 VDD a_18585_16071# 0.29722f
C4077 VDD a_6391_14652# 0.01806f
C4078 VDD a_5705_3364# 0.29556f
C4079 VDD a_20397_4687# 0.87185f
C4080 CHAN0_MUX_OUT a_5731_15316# 1.04829f
C4081 CHAN0_MUX_SEL4 a_8745_15546# 0.04472f
C4082 a_11277_16869# a_12037_16869# 0.03319f
C4083 a_4187_2434# a_18443_16869# 0.06627f
C4084 a_14317_16869# a_14888_16071# 0.10863f
C4085 a_15837_14024# a_16033_14024# 0.76914f
C4086 a_4187_2434# a_9323_7532# 0.06627f
C4087 a_19637_14024# a_19524_13190# 0.05157f
C4088 a_6635_6734# a_6711_6698# 0.01194f
C4089 a_5731_5979# a_13753_4687# 0.01865f
C4090 a_6717_4687# a_7043_4687# 0.01427f
C4091 a_23145_3889# a_23355_3889# 0.09424f
C4092 a_11473_1842# a_12037_1842# 0.0114f
C4093 a_18585_1044# a_18795_1044# 0.09424f
C4094 a_15755_1044# VDD 0.15389f
C4095 VDD CHAN2_DELAY_IN 1.50899f
C4096 VDD a_17031_17497# 0.01806f
C4097 VDD a_11277_14024# 0.87182f
C4098 VDD a_18004_13190# 0.28225f
C4099 VDD a_15765_6153# 0.36528f
C4100 VDD a_23003_7532# 0.48123f
C4101 VDD a_6635_3889# 0.15407f
C4102 CHAN0_MUX_SEL4 a_4187_2434# 0.01921f
C4103 DLL_RESETN a_13019_11521# 0.01429f
C4104 REF_CLK a_12656_11554# 0.01215f
C4105 a_12505_16071# a_12791_16035# 0.01885f
C4106 a_6717_14024# a_7477_14024# 0.06198f
C4107 a_4187_2434# a_22677_4687# 0.04055f
C4108 a_24665_13226# a_22590_13226# 0.03208f
C4109 a_12715_13226# a_12791_13190# 0.01194f
C4110 a_19073_7532# a_19637_7532# 0.0114f
C4111 a_13121_11521# a_13592_11561# 0.01445f
C4112 a_12849_11557# a_13566_11525# 0.27346f
C4113 a_23437_7532# a_24008_6734# 0.10863f
C4114 a_1544_6734# a_2297_7085# 0.28651f
C4115 a_23633_4687# a_23763_4687# 0.70845f
C4116 a_9323_4687# a_9431_4687# 0.01163f
C4117 a_15403_4687# a_15511_5315# 0.01697f
C4118 a_4157_4158# a_4248_3889# 0.11672f
C4119 a_15964_3134# a_16851_3154# 0.16757f
C4120 a_21917_1842# a_21483_1842# 0.6972f
C4121 a_27237_1842# a_25630_1044# 0.05253f
C4122 a_26477_1842# a_26471_1008# 0.02349f
C4123 a_15273_1842# a_5731_3134# 0.01872f
C4124 a_10430_1044# a_10517_1842# 0.1088f
C4125 VDD a_22590_16071# 0.98586f
C4126 VDD a_14513_16869# 0.49417f
C4127 VDD a_1721_13577# 0.4533f
C4128 VDD a_5393_7532# 0.49417f
C4129 VDD a_10404_6698# 0.28633f
C4130 VDD a_27671_5315# 0.01806f
C4131 CHAN3_DELAY_OUT_LAST a_4187_2434# 0.21225f
C4132 CHAN3_DELAY_IN a_4003_1842# 0.54998f
C4133 a_19073_16869# a_19203_16869# 0.70845f
C4134 a_8563_16869# a_8671_17497# 0.01697f
C4135 a_22590_16071# a_16108_15316# 0.56869f
C4136 a_1256_16071# a_2297_16422# 0.04619f
C4137 a_23437_16869# a_24008_16071# 0.10863f
C4138 a_1544_15316# a_2297_15358# 0.27303f
C4139 a_1256_15316# a_2873_15358# 0.27926f
C4140 a_4187_2434# a_13557_14024# 0.04101f
C4141 a_4187_2434# a_25283_7532# 0.06661f
C4142 a_23633_14024# a_24197_14024# 0.0114f
C4143 a_5731_12471# a_6126_9506# 0.02557f
C4144 a_15964_12471# a_16108_12471# 0.42202f
C4145 a_4187_2434# a_4003_4687# 0.05992f
C4146 a_9953_7532# a_10083_7532# 0.70845f
C4147 a_16510_6734# a_17928_6734# 0.38994f
C4148 a_15077_4687# a_14643_4687# 0.6972f
C4149 a_16108_5979# a_26803_4687# 0.01192f
C4150 a_22590_3889# a_24084_3853# 0.28279f
C4151 a_23355_3889# a_23431_3853# 0.01194f
C4152 a_15837_1842# a_16484_1008# 0.02011f
C4153 a_19550_1044# a_21835_1044# 0.39036f
C4154 a_23945_519# VDD 0.29292f
C4155 a_24523_1842# VDD 0.50001f
C4156 VDD a_9547_11862# 0.08951f
C4157 VDD a_27237_14024# 0.86278f
C4158 VDD a_17683_4687# 0.49684f
C4159 VDD a_27915_3889# 0.15389f
C4160 CHAN0_MUX_OUT a_2297_15358# 0.01179f
C4161 CHAN0_MUX_SEL3 a_3449_15358# 0.28429f
C4162 CHAN0_MUX_SEL4 a_2873_15358# 0.04916f
C4163 a_10517_16869# a_10083_16869# 0.69698f
C4164 a_4187_2434# a_16793_16869# 0.11222f
C4165 a_4187_2434# a_25630_16071# 0.02246f
C4166 a_16510_16071# a_17351_16035# 0.28268f
C4167 a_4187_2434# a_7673_7532# 0.11222f
C4168 a_14513_14024# a_14643_14024# 0.70845f
C4169 a_22590_13226# a_24008_13226# 0.38994f
C4170 a_27237_7532# a_27433_7532# 0.77122f
C4171 a_5115_6734# a_5191_6698# 0.01194f
C4172 a_5731_5979# a_12037_4687# 0.01319f
C4173 a_12505_6734# a_10430_6734# 0.03208f
C4174 a_4350_6734# a_5844_6698# 0.28279f
C4175 a_5957_4687# a_6153_4687# 0.77122f
C4176 a_8237_4687# a_8808_3889# 0.10863f
C4177 a_10430_3889# a_12715_3889# 0.39036f
C4178 a_10517_1842# a_11277_1842# 0.01669f
C4179 a_7390_1044# a_9751_1008# 0.26208f
C4180 a_12791_1008# VDD 0.28232f
C4181 a_26803_1842# a_4187_2434# 0.06627f
C4182 VDD a_10951_17497# 0.01806f
C4183 VDD a_8563_14024# 0.49684f
C4184 VDD a_15755_13226# 0.15389f
C4185 VDD a_21353_7532# 0.49294f
C4186 VDD a_5731_5979# 0.98095f
C4187 DLL_RESETN a_11748_11799# 0.11133f
C4188 REF_CLK a_10751_11568# 0.01931f
C4189 a_10985_16071# a_10430_16071# 0.03209f
C4190 a_4350_16071# a_5768_16071# 0.38994f
C4191 a_5731_15316# a_11473_14024# 0.01872f
C4192 a_5957_14024# a_5523_14024# 0.6972f
C4193 a_8237_14024# a_8231_13190# 0.02349f
C4194 a_8997_14024# a_7390_13226# 0.05231f
C4195 a_4187_2434# a_19963_4687# 0.06627f
C4196 a_12355_11557# a_12849_11557# 0.07687f
C4197 a_11195_13226# a_11271_13190# 0.01194f
C4198 a_10430_13226# a_11924_13190# 0.28279f
C4199 a_18117_7532# a_18877_7532# 0.02912f
C4200 a_27915_6734# a_27991_6698# 0.01194f
C4201 a_13883_4687# a_13991_5315# 0.01697f
C4202 a_7803_4687# a_7911_4687# 0.01163f
C4203 a_20593_1842# a_21157_1842# 0.0114f
C4204 a_24957_1842# a_25604_1008# 0.02011f
C4205 a_5705_519# a_5731_289# 0.28954f
C4206 VDD a_12797_16869# 0.87928f
C4207 VDD a_19524_16035# 0.28633f
C4208 VDD a_9444_9602# 0.0107f
C4209 VDD a_8155_6734# 0.15389f
C4210 VDD a_21591_5315# 0.01806f
C4211 VDD a_12363_1842# 0.92885f
C4212 CHAN2_DELAY_OUT_LAST a_4187_2434# 0.21225f
C4213 REF_MUX_SEL4 a_4157_7003# 0.08229f
C4214 CHAN2_MUX_OUT a_16108_3134# 0.24265f
C4215 a_7043_16869# a_7151_17497# 0.01697f
C4216 a_4187_2434# a_10843_14024# 0.06627f
C4217 a_21917_14024# a_16108_12471# 0.01053f
C4218 a_22677_14024# a_23437_14024# 0.01323f
C4219 a_4187_2434# a_23633_7532# 0.11286f
C4220 a_16108_5979# a_25153_4687# 0.01872f
C4221 a_13753_4687# a_14317_4687# 0.0114f
C4222 a_17357_4687# a_17928_3889# 0.10863f
C4223 a_15077_1842# a_14964_1008# 0.02055f
C4224 a_22873_1842# VDD 0.49642f
C4225 a_11785_519# VDD 0.29292f
C4226 VDD a_24523_14024# 0.50001f
C4227 VDD a_23945_12701# 0.29292f
C4228 VDD a_16033_4687# 0.49413f
C4229 VDD a_24951_3853# 0.2822f
C4230 CHAN3_DELAY_IN CHAN3_MUX_SEL4 0.0663f
C4231 CHAN1_MUX_SEL0 a_3449_13577# 0.10753f
C4232 a_9193_16869# a_9757_16869# 0.0114f
C4233 a_4187_2434# a_15077_16869# 0.04194f
C4234 a_27705_16071# a_27991_16035# 0.01885f
C4235 a_16108_15316# a_24523_14024# 0.01542f
C4236 a_4187_2434# a_5957_7532# 0.04152f
C4237 a_15755_16071# a_15831_16035# 0.01194f
C4238 a_18117_14024# a_16510_13226# 0.05231f
C4239 a_17357_14024# a_17351_13190# 0.02349f
C4240 a_25913_7532# a_26043_7532# 0.70845f
C4241 a_5731_5979# a_9323_4687# 0.01542f
C4242 a_4633_4687# a_4763_4687# 0.70845f
C4243 a_18585_3889# a_18871_3853# 0.01885f
C4244 a_9757_1842# a_9323_1842# 0.6972f
C4245 a_7288_1044# a_7390_1044# 0.37183f
C4246 a_14025_1044# a_14235_1044# 0.09424f
C4247 a_10328_1044# VDD 0.17274f
C4248 a_2297_1395# CHAN3_MUX_SEL1 0.01995f
C4249 a_1544_1044# CHAN3_MUX_OUT 0.04258f
C4250 a_25153_1842# a_4187_2434# 0.11222f
C4251 a_15077_1842# a_14513_1842# 0.0114f
C4252 a_26673_1842# a_16108_3134# 0.01872f
C4253 VDD a_4871_17497# 0.01806f
C4254 VDD a_6913_14024# 0.49655f
C4255 VDD a_19637_7532# 0.86712f
C4256 VDD a_12791_13190# 0.28232f
C4257 VDD a_2297_6021# 0.46603f
C4258 VDD a_17065_3889# 0.3023f
C4259 DLL_RESETN a_9946_11995# 0.09997f
C4260 a_26477_16869# a_26043_16869# 0.6972f
C4261 a_7945_16071# a_8231_16035# 0.01885f
C4262 a_4633_14024# a_5197_14024# 0.0114f
C4263 a_5731_15316# a_9757_14024# 0.01307f
C4264 a_4187_2434# a_26803_14024# 0.06627f
C4265 a_4187_2434# a_18313_4687# 0.11222f
C4266 a_18585_13226# a_18795_13226# 0.09424f
C4267 a_6717_14024# a_7364_13190# 0.02011f
C4268 a_12158_11557# a_12355_11557# 0.12454f
C4269 a_17357_7532# a_16923_7532# 0.6972f
C4270 a_25630_6734# a_27124_6698# 0.28279f
C4271 a_26395_6734# a_26471_6698# 0.01194f
C4272 a_6283_4687# a_6391_4687# 0.01163f
C4273 a_21917_4687# a_22113_4687# 0.76914f
C4274 a_12363_4687# a_12471_5315# 0.01697f
C4275 a_26477_4687# a_27048_3889# 0.10863f
C4276 a_24197_1842# a_24084_1008# 0.02055f
C4277 a_19637_1842# a_20397_1842# 0.01669f
C4278 a_1721_331# a_2019_311# 0.18452f
C4279 VDD a_10083_16869# 0.49727f
C4280 REF_CLK REF_MUX_SEL0 0.10102f
C4281 VDD a_17275_16071# 0.15389f
C4282 VDD a_15688_11093# 0.30345f
C4283 VDD a_15511_5315# 0.01806f
C4284 VDD a_5191_6698# 0.28637f
C4285 VDD a_10713_1842# 0.49555f
C4286 REF_DELAY_OUT_LAST a_4187_2434# 1.08837f
C4287 REF_MUX_SEL0 a_2873_7085# 0.01504f
C4288 a_5523_16869# a_5631_17497# 0.01697f
C4289 a_4187_2434# a_9193_14024# 0.11222f
C4290 a_17357_16869# a_17553_16869# 0.76914f
C4291 a_21917_14024# a_21483_14024# 0.6972f
C4292 a_25630_16071# a_27048_16071# 0.38994f
C4293 a_16510_16071# a_17865_15546# 0.02165f
C4294 a_4187_2434# a_21917_7532# 0.04176f
C4295 a_27237_14024# a_25630_13226# 0.05253f
C4296 a_26477_14024# a_26471_13190# 0.02349f
C4297 a_8237_7532# a_8433_7532# 0.76914f
C4298 a_10843_7532# a_10430_6734# 0.01012f
C4299 a_27705_6734# a_25630_6734# 0.03208f
C4300 a_12797_4687# a_13557_4687# 0.05851f
C4301 a_13470_6734# a_15755_6734# 0.39036f
C4302 a_19550_3889# a_21911_3853# 0.26208f
C4303 a_22677_1842# a_23145_1044# 0.19203f
C4304 a_21157_1842# VDD 0.85962f
C4305 VDD a_22873_14024# 0.49647f
C4306 VDD a_25391_8160# 0.01806f
C4307 VDD a_11785_12701# 0.29292f
C4308 VDD a_14317_4687# 0.87185f
C4309 VDD a_22488_3889# 0.1824f
C4310 CHAN2_MUX_SEL2 CHAN3_MUX_SEL0 0.0126f
C4311 CHAN2_MUX_SEL4 CHAN3_DELAY_IN 0.01327f
C4312 a_4187_2434# a_12363_16869# 0.06482f
C4313 a_8237_16869# a_8997_16869# 0.03319f
C4314 a_10843_16869# a_10430_16071# 0.01012f
C4315 a_13470_16071# a_14964_16035# 0.28279f
C4316 a_4187_2434# a_9712_9602# 0.13545f
C4317 a_26185_16071# a_25630_16071# 0.03209f
C4318 a_16108_15316# a_22873_14024# 0.01865f
C4319 a_12797_14024# a_12993_14024# 0.74917f
C4320 a_14235_16071# a_14311_16035# 0.01194f
C4321 a_19550_13226# a_21835_13226# 0.39036f
C4322 a_15837_14024# a_16484_13190# 0.02011f
C4323 a_13566_11018# a_14009_10774# 0.02242f
C4324 a_15304_10295# a_15108_11015# 0.01986f
C4325 a_4187_2434# a_12993_1842# 0.11169f
C4326 a_13306_10795# a_13592_11113# 0.41329f
C4327 a_6425_6734# a_6711_6698# 0.01885f
C4328 a_24957_7532# a_25283_7532# 0.01427f
C4329 a_5731_5979# a_7673_4687# 0.01865f
C4330 a_17065_3889# a_16510_3889# 0.03209f
C4331 a_8433_1842# a_8997_1842# 0.0114f
C4332 a_5768_1044# a_5844_1008# 0.01176f
C4333 a_27433_1842# a_27563_1842# 0.70845f
C4334 a_7390_1044# VDD 0.8686f
C4335 a_23437_1842# a_4187_2434# 0.04012f
C4336 a_24957_1842# a_16108_3134# 0.01307f
C4337 VDD a_26043_16869# 0.4973f
C4338 VDD a_5197_14024# 0.87049f
C4339 VDD a_10328_13226# 0.17274f
C4340 VDD a_16923_7532# 0.4973f
C4341 VDD a_26471_6698# 0.28357f
C4342 VDD a_6425_3889# 0.29742f
C4343 DLL_RESETN a_5974_11413# 0.02002f
C4344 CHAN1_MUX_OUT a_6854_11676# 0.04362f
C4345 REF_MUX_SEL4 a_9757_7532# 0.01829f
C4346 a_25153_16869# a_25717_16869# 0.0114f
C4347 a_4187_2434# a_25153_14024# 0.11222f
C4348 a_6425_16071# a_6635_16071# 0.09424f
C4349 a_5731_15316# a_7043_14024# 0.01539f
C4350 a_5957_14024# a_5844_13190# 0.02055f
C4351 a_4187_2434# a_16597_4687# 0.0414f
C4352 a_7390_13226# a_9751_13190# 0.26208f
C4353 a_10751_11568# a_11491_11918# 0.26905f
C4354 a_16033_7532# a_16597_7532# 0.0114f
C4355 a_19963_7532# a_19550_6734# 0.01012f
C4356 a_4763_4687# a_4871_4687# 0.01163f
C4357 a_20593_4687# a_20723_4687# 0.70845f
C4358 a_10843_4687# a_10951_5315# 0.01697f
C4359 a_25630_3889# a_26985_3364# 0.02195f
C4360 a_18877_1842# a_18443_1842# 0.6972f
C4361 a_23437_1842# a_22590_1044# 0.08038f
C4362 a_1256_289# a_1544_289# 1.25711f
C4363 a_1256_1044# a_1721_1395# 0.13421f
C4364 VDD a_8433_16869# 0.49417f
C4365 VDD a_14311_16035# 0.28357f
C4366 VDD a_13592_11113# 0.11685f
C4367 VDD a_24665_6734# 0.29722f
C4368 VDD a_9431_5315# 0.01806f
C4369 VDD a_8997_1842# 0.85955f
C4370 REF_CLK a_3449_6021# 0.01017f
C4371 REF_MUX_SEL0 a_1256_6734# 0.3314f
C4372 REF_DELAY_OUT_LAST a_12849_11557# 0.01791f
C4373 a_4003_16869# a_4111_17497# 0.01697f
C4374 a_16033_16869# a_16163_16869# 0.70845f
C4375 CHAN2_MUX_SEL4 a_5705_3364# 0.03556f
C4376 a_4187_2434# a_7477_14024# 0.0414f
C4377 a_19963_16869# a_19550_16071# 0.01012f
C4378 a_4187_2434# a_19203_7532# 0.06661f
C4379 a_20593_14024# a_21157_14024# 0.0114f
C4380 a_5705_12701# a_5731_12471# 0.28954f
C4381 a_24957_14024# a_25604_13190# 0.02011f
C4382 a_6913_7532# a_7043_7532# 0.70845f
C4383 a_16597_7532# a_17065_6734# 0.19203f
C4384 a_9757_7532# a_10328_6734# 0.10864f
C4385 a_16108_5979# a_20723_4687# 0.01544f
C4386 a_12037_4687# a_11603_4687# 0.6972f
C4387 a_19448_3889# a_19550_3889# 0.37183f
C4388 a_16408_1044# a_16484_1008# 0.01176f
C4389 a_1544_289# VDD 0.39113f
C4390 a_18443_1842# VDD 0.50001f
C4391 VDD a_21157_14024# 0.85962f
C4392 VDD a_19311_8160# 0.01806f
C4393 VDD a_11603_4687# 0.49753f
C4394 VDD a_19550_3889# 0.8993f
C4395 CHAN2_DELAY_IN CHAN2_MUX_SEL4 0.0663f
C4396 a_7477_16869# a_7043_16869# 0.69698f
C4397 a_4187_2434# a_10713_16869# 0.11222f
C4398 a_16597_16869# a_17065_16071# 0.19203f
C4399 a_9757_16869# a_10328_16071# 0.10864f
C4400 a_23145_16071# a_23431_16035# 0.01885f
C4401 a_16108_15316# a_21157_14024# 0.01319f
C4402 a_11473_14024# a_11603_14024# 0.70845f
C4403 a_15077_14024# a_14964_13190# 0.02055f
C4404 a_24197_7532# a_24393_7532# 0.77122f
C4405 a_4187_2434# a_11277_1842# 0.0414f
C4406 a_12907_10876# a_12907_11110# 0.1117f
C4407 a_13106_11047# a_13132_11110# 0.1657f
C4408 a_4905_6734# a_4350_6734# 0.03209f
C4409 a_4157_7003# a_4324_6698# 0.02463f
C4410 a_5731_5979# a_5957_4687# 0.01644f
C4411 a_16108_5979# a_17865_6209# 0.29564f
C4412 a_4763_4687# a_4350_3889# 0.01012f
C4413 a_14025_3889# a_14311_3853# 0.01885f
C4414 a_7288_3889# a_7364_3853# 0.01176f
C4415 a_7477_1842# a_8237_1842# 0.01669f
C4416 a_26477_1842# a_26803_1842# 0.01427f
C4417 a_9465_1044# a_9751_1008# 0.01885f
C4418 a_4350_1044# a_4324_1008# 0.277f
C4419 a_4324_1008# VDD 0.28597f
C4420 a_20723_1842# a_4187_2434# 0.06627f
C4421 VDD a_24393_16869# 0.49285f
C4422 VDD a_7390_13226# 0.8686f
C4423 VDD a_16851_15336# 0.52304f
C4424 VDD a_24008_6734# 0.17499f
C4425 VDD a_15273_7532# 0.49298f
C4426 CHAN0_MUX_SEL4 a_4157_16340# 0.08229f
C4427 CHAN1_MUX_OUT a_16108_12471# 0.24265f
C4428 REF_MUX_SEL4 a_13470_6734# 0.256f
C4429 a_24197_16869# a_24957_16869# 0.02912f
C4430 a_4157_16340# a_4350_16071# 0.04624f
C4431 a_4187_2434# a_23437_14024# 0.04011f
C4432 a_8997_14024# a_9465_13226# 0.2079f
C4433 a_16108_15316# a_16851_15336# 0.06181f
C4434 a_5197_14024# a_4350_13226# 0.08038f
C4435 a_14025_13226# a_14235_13226# 0.09424f
C4436 a_4187_2434# a_13883_4687# 0.06627f
C4437 a_7288_13226# a_7390_13226# 0.37183f
C4438 a_15077_7532# a_15837_7532# 0.02912f
C4439 a_18877_7532# a_19448_6734# 0.10864f
C4440 a_22590_6734# a_24951_6698# 0.26208f
C4441 a_9323_4687# a_9431_5315# 0.01697f
C4442 a_17553_1842# a_18117_1842# 0.0114f
C4443 a_27048_1044# a_27124_1008# 0.01176f
C4444 a_21917_1842# a_21911_1008# 0.02354f
C4445 a_23871_2470# VDD 0.01806f
C4446 a_11785_519# CHAN3_MUX_SEL4 0.03255f
C4447 a_10985_1044# a_10517_1842# 0.19203f
C4448 a_4350_1044# a_6283_1842# 0.01012f
C4449 VDD a_11848_16071# 0.17499f
C4450 VDD a_6717_16869# 0.87726f
C4451 VDD a_15304_10295# 0.72158f
C4452 VDD a_12505_6734# 0.29855f
C4453 VDD a_6283_1842# 0.50001f
C4454 VDD a_27563_4687# 0.50391f
C4455 CHAN2_MUX_SEL2 a_1256_3134# 0.33134f
C4456 a_4187_2434# a_26673_16869# 0.11222f
C4457 a_4187_2434# a_4763_14024# 0.06627f
C4458 a_22590_16071# a_24875_16071# 0.39036f
C4459 a_18877_16869# a_19448_16071# 0.10864f
C4460 a_19637_14024# a_20397_14024# 0.01669f
C4461 a_4187_2434# a_17553_7532# 0.11284f
C4462 a_24197_14024# a_24084_13190# 0.02055f
C4463 a_9757_7532# a_7390_6734# 0.02479f
C4464 a_21625_6734# a_21835_6734# 0.09424f
C4465 a_13883_4687# a_13470_3889# 0.01012f
C4466 a_10713_4687# a_11277_4687# 0.0114f
C4467 a_16108_5979# a_19073_4687# 0.01872f
C4468 a_17928_3889# a_18004_3853# 0.01176f
C4469 a_25604_1008# VDD 0.28633f
C4470 a_16793_1842# VDD 0.49408f
C4471 VDD a_1544_12471# 0.39332f
C4472 VDD a_18443_14024# 0.50001f
C4473 VDD a_13231_8160# 0.01806f
C4474 VDD a_9953_4687# 0.49655f
C4475 VDD a_16484_3853# 0.28687f
C4476 REF_MUX_SEL2 CHAN2_MUX_SEL0 0.0126f
C4477 REF_MUX_SEL4 CHAN2_DELAY_IN 0.01327f
C4478 REF_MUX_SEL4 a_15765_6153# 0.65508f
C4479 a_9757_16869# a_7390_16071# 0.02479f
C4480 a_6153_16869# a_6717_16869# 0.0114f
C4481 a_4187_2434# a_8997_16869# 0.04152f
C4482 a_10430_16071# a_12791_16035# 0.26208f
C4483 a_14317_14024# a_13470_13226# 0.08038f
C4484 a_16108_15316# a_18443_14024# 0.01542f
C4485 a_22677_14024# a_23145_13226# 0.19203f
C4486 a_22873_7532# a_23003_7532# 0.70361f
C4487 a_4187_2434# a_8563_1842# 0.06627f
C4488 a_7477_4687# a_7945_3889# 0.19203f
C4489 a_27997_4687# a_27563_4687# 0.69646f
C4490 a_6717_1842# a_6283_1842# 0.6972f
C4491 a_5731_3134# a_12993_1842# 0.01688f
C4492 a_25717_1842# a_25913_1842# 0.73897f
C4493 a_7945_1044# a_7390_1044# 0.03209f
C4494 a_21625_1044# VDD 0.29742f
C4495 a_19073_1842# a_4187_2434# 0.11222f
C4496 a_20593_1842# a_16108_3134# 0.01872f
C4497 VDD a_22677_16869# 0.91482f
C4498 VDD a_4324_13190# 0.28607f
C4499 VDD a_13557_7532# 0.8672f
C4500 VDD a_21044_6698# 0.28225f
C4501 CHAN0_MUX_SEL0 a_2873_16422# 0.01504f
C4502 REF_CLK a_5731_12471# 0.01996f
C4503 a_23437_16869# a_23003_16869# 0.6972f
C4504 a_4187_2434# a_20723_14024# 0.06627f
C4505 a_27433_14024# a_27563_14024# 0.70845f
C4506 a_4187_2434# a_12233_4687# 0.11169f
C4507 a_5768_13226# a_5844_13190# 0.01176f
C4508 a_18877_7532# a_16510_6734# 0.02479f
C4509 a_14317_7532# a_13883_7532# 0.6972f
C4510 a_22488_6734# a_22590_6734# 0.37183f
C4511 a_1544_3889# a_1721_4240# 0.38063f
C4512 a_18877_4687# a_19073_4687# 0.76914f
C4513 a_7803_4687# a_7911_5315# 0.01697f
C4514 a_1256_3134# a_1721_3176# 0.13421f
C4515 a_20397_1842# a_21044_1008# 0.02312f
C4516 a_16597_1842# a_17357_1842# 0.01669f
C4517 a_25630_1044# a_25604_1008# 0.277f
C4518 a_16510_1044# a_15964_289# 0.05416f
C4519 a_17791_2470# VDD 0.01806f
C4520 VDD a_4003_16869# 0.61559f
C4521 VDD a_8884_16035# 0.28225f
C4522 VDD a_23871_14652# 0.01806f
C4523 VDD a_3449_7085# 0.46731f
C4524 VDD a_25913_4687# 0.49553f
C4525 VDD a_4633_1842# 0.49523f
C4526 a_14317_16869# a_14513_16869# 0.76914f
C4527 a_4187_2434# a_24957_16869# 0.0414f
C4528 a_18877_16869# a_16510_16071# 0.02479f
C4529 a_10430_16071# a_11785_15546# 0.02058f
C4530 a_18877_14024# a_18443_14024# 0.6972f
C4531 a_23437_14024# a_22590_13226# 0.08038f
C4532 a_4187_2434# a_15837_7532# 0.04182f
C4533 a_1256_13226# a_1721_13577# 0.13421f
C4534 a_1256_12471# a_1544_12471# 1.25711f
C4535 a_5197_7532# a_5393_7532# 0.76914f
C4536 a_7477_7532# a_7364_6698# 0.05157f
C4537 a_9757_4687# a_10517_4687# 0.06198f
C4538 a_16108_5979# a_17357_4687# 0.01319f
C4539 a_10328_6734# a_10404_6698# 0.01176f
C4540 a_21157_4687# a_21625_3889# 0.2079f
C4541 a_12797_4687# a_13368_3889# 0.10864f
C4542 a_16510_3889# a_16484_3853# 0.277f
C4543 a_24665_1044# a_24951_1008# 0.01885f
C4544 a_13470_1044# a_14235_1044# 0.39037f
C4545 a_15077_1842# VDD 0.86069f
C4546 a_23355_1044# VDD 0.1539f
C4547 a_7390_1044# CHAN3_MUX_SEL4 0.34655f
C4548 VDD a_16793_14024# 0.49408f
C4549 VDD a_25604_13190# 0.28633f
C4550 VDD a_8237_4687# 0.87185f
C4551 VDD a_7151_8160# 0.01806f
C4552 VDD a_14235_3889# 0.1539f
C4553 DLL_RESETN a_12907_10876# 0.02177f
C4554 REF_MUX_SEL4 a_5731_5979# 4.60702f
C4555 a_4187_2434# a_6283_16869# 0.06627f
C4556 a_7477_16869# a_7364_16035# 0.05157f
C4557 a_5197_16869# a_5957_16869# 0.03319f
C4558 a_16108_15316# a_16793_14024# 0.01843f
C4559 a_10328_16071# a_10430_16071# 0.37183f
C4560 a_9757_14024# a_9953_14024# 0.76914f
C4561 a_12797_14024# a_12791_13190# 0.02354f
C4562 a_12849_11557# a_14009_10774# 0.03463f
C4563 a_4187_2434# a_6913_1842# 0.11222f
C4564 a_14851_11918# a_15688_11557# 0.08776f
C4565 a_16408_13226# a_16484_13190# 0.01176f
C4566 a_21917_7532# a_22243_7532# 0.01427f
C4567 a_5731_5979# a_11785_6209# 0.28056f
C4568 a_5957_4687# a_6425_3889# 0.2079f
C4569 a_26673_4687# a_27237_4687# 0.0114f
C4570 a_4350_3889# a_5115_3889# 0.39037f
C4571 a_5393_1842# a_5957_1842# 0.0114f
C4572 a_5731_3134# a_11277_1842# 0.01319f
C4573 a_24393_1842# a_24523_1842# 0.70845f
C4574 a_9465_1044# VDD 0.29742f
C4575 a_17357_1842# a_4187_2434# 0.0414f
C4576 a_18877_1842# a_16108_3134# 0.01307f
C4577 VDD a_19963_16869# 0.4973f
C4578 VDD a_5705_15546# 0.29556f
C4579 VDD a_21625_13226# 0.29742f
C4580 VDD a_10843_7532# 0.49736f
C4581 VDD a_18795_6734# 0.15406f
C4582 CHAN0_MUX_SEL0 a_1256_16071# 0.3314f
C4583 CHAN1_MUX_SEL4 a_5705_12701# 0.03556f
C4584 a_22113_16869# a_22677_16869# 0.0114f
C4585 a_4187_2434# a_19073_14024# 0.11222f
C4586 a_26477_14024# a_26803_14024# 0.01427f
C4587 a_9465_13226# a_9751_13190# 0.01885f
C4588 a_4350_13226# a_4324_13190# 0.277f
C4589 a_4187_2434# a_10517_4687# 0.0414f
C4590 a_5731_12471# a_13121_11521# 0.02284f
C4591 a_12993_7532# a_13557_7532# 0.0114f
C4592 a_16597_7532# a_16484_6698# 0.05157f
C4593 a_6283_4687# a_6391_5315# 0.01697f
C4594 a_20968_6734# a_21044_6698# 0.01176f
C4595 a_17553_4687# a_17683_4687# 0.70845f
C4596 a_21917_4687# a_22488_3889# 0.10864f
C4597 a_15837_1842# a_15403_1842# 0.6972f
C4598 a_19637_1842# a_19550_1044# 0.1088f
C4599 a_11711_2470# VDD 0.01806f
C4600 a_2297_331# CHAN3_MUX_SEL2 0.10655f
C4601 VDD CHAN1_MUX_SEL2 0.68512f
C4602 a_1256_289# CHAN3_MUX_OUT 0.1134f
C4603 a_1544_289# CHAN3_MUX_SEL4 0.47529f
C4604 VDD a_6635_16071# 0.15406f
C4605 VDD a_17791_14652# 0.01806f
C4606 VDD a_24197_4687# 0.85998f
C4607 VDD a_16108_3134# 1.64187f
C4608 a_16597_16869# a_16484_16035# 0.05157f
C4609 a_12993_16869# a_13123_16869# 0.70361f
C4610 a_4187_2434# a_22243_16869# 0.06315f
C4611 a_4187_2434# a_13123_7532# 0.0643f
C4612 a_17553_14024# a_18117_14024# 0.0114f
C4613 a_21917_14024# a_21911_13190# 0.02354f
C4614 a_27048_13226# a_27124_13190# 0.01176f
C4615 a_17065_6734# a_17275_6734# 0.09424f
C4616 a_8997_4687# a_8563_4687# 0.6972f
C4617 a_12797_4687# a_10430_3889# 0.02479f
C4618 a_13557_1842# a_13753_1842# 0.73897f
C4619 a_23145_1044# a_22590_1044# 0.03209f
C4620 a_20391_1008# VDD 0.28336f
C4621 VDD CHAN3_MUX_OUT 0.55963f
C4622 VDD a_15077_14024# 0.86069f
C4623 VDD a_23355_13226# 0.1539f
C4624 VDD a_26803_7532# 0.49671f
C4625 VDD a_5523_4687# 0.49684f
C4626 VDD a_11271_3853# 0.28357f
C4627 CHAN0_MUX_SEL4 a_13470_16071# 0.256f
C4628 REF_MUX_SEL2 a_3449_6021# 0.10741f
C4629 REF_MUX_SEL4 a_2297_6021# 0.04338f
C4630 REF_MUX_SEL3 a_2873_6021# 0.12606f
C4631 a_4437_16869# a_4003_16869# 0.69698f
C4632 a_4187_2434# a_4633_16869# 0.11222f
C4633 a_8433_14024# a_8563_14024# 0.70845f
C4634 a_8808_16071# a_8884_16035# 0.01176f
C4635 a_18585_16071# a_16510_16071# 0.03208f
C4636 a_4187_2434# a_26477_4687# 0.04145f
C4637 a_11277_14024# a_11924_13190# 0.02312f
C4638 a_4187_2434# a_5197_1842# 0.0414f
C4639 a_6854_11144# a_9444_9602# 0.8486f
C4640 a_25717_7532# a_25604_6698# 0.05157f
C4641 a_21157_7532# a_21353_7532# 0.77122f
C4642 a_4437_4687# a_4157_4158# 0.01771f
C4643 a_25717_4687# a_26477_4687# 0.01669f
C4644 a_9465_3889# a_7390_3889# 0.03208f
C4645 a_4437_1842# a_5197_1842# 0.01669f
C4646 a_5731_3134# a_8563_1842# 0.01544f
C4647 a_23437_1842# a_23763_1842# 0.01427f
C4648 a_15765_463# a_16108_289# 0.42004f
C4649 a_14643_1842# a_4187_2434# 0.06627f
C4650 a_16163_1842# a_16108_3134# 0.0155f
C4651 VDD a_18313_16869# 0.49285f
C4652 VDD a_27915_16071# 0.15389f
C4653 VDD a_9465_13226# 0.29742f
C4654 VDD a_9193_7532# 0.49285f
C4655 VDD a_15831_6698# 0.2816f
C4656 CHAN1_MUX_SEL2 a_1256_12471# 0.33134f
C4657 REF_DELAY_OUT_LAST a_15464_9374# 0.02565f
C4658 a_25717_16869# a_25604_16035# 0.05157f
C4659 a_4187_2434# a_17357_14024# 0.0414f
C4660 a_21157_16869# a_21917_16869# 0.02912f
C4661 a_25717_14024# a_25913_14024# 0.73897f
C4662 a_7945_13226# a_7390_13226# 0.03209f
C4663 a_4187_2434# a_7803_4687# 0.06627f
C4664 a_6326_10280# a_6854_11676# 1.31745f
C4665 a_12037_7532# a_12797_7532# 0.02912f
C4666 a_4763_4687# a_4871_5315# 0.01697f
C4667 a_19550_6734# a_19524_6698# 0.277f
C4668 a_7390_6734# a_5731_5979# 0.41331f
C4669 a_16510_3889# a_16108_3134# 0.56108f
C4670 a_21917_4687# a_19550_3889# 0.02479f
C4671 a_25630_3889# a_26395_3889# 0.39037f
C4672 a_22590_1044# a_23431_1008# 0.28268f
C4673 a_5631_2470# VDD 0.01806f
C4674 VDD CHAN0_MUX_SEL2 0.692f
C4675 VDD a_11711_14652# 0.01806f
C4676 VDD a_21483_4687# 0.50072f
C4677 CHAN0_MUX_SEL4 a_15765_15490# 0.65508f
C4678 a_4187_2434# a_20593_16869# 0.11222f
C4679 a_16597_14024# a_17357_14024# 0.01669f
C4680 a_19448_16071# a_19524_16035# 0.01176f
C4681 a_4187_2434# a_11473_7532# 0.11222f
C4682 a_20397_14024# a_21044_13190# 0.02312f
C4683 a_16510_13226# a_15964_12471# 0.05416f
C4684 a_25630_13226# a_25604_13190# 0.277f
C4685 a_15464_9374# a_9712_9602# 0.01237f
C4686 a_5957_7532# a_4350_6734# 0.05231f
C4687 a_7390_6734# a_8155_6734# 0.39037f
C4688 a_5197_7532# a_5191_6698# 0.02349f
C4689 a_10517_4687# a_10404_3853# 0.05157f
C4690 a_7673_4687# a_8237_4687# 0.0114f
C4691 a_13470_3889# a_14311_3853# 0.28268f
C4692 a_12233_1842# a_12363_1842# 0.70361f
C4693 a_10430_1044# a_11848_1044# 0.38994f
C4694 a_20105_1044# a_20391_1008# 0.01885f
C4695 a_17928_1044# VDD 0.17499f
C4696 VDD CHAN2_MUX_OUT 0.97728f
C4697 CHAN1_MUX_OUT DLL_RESETN 0.0503f
C4698 VDD a_22351_17497# 0.02349f
C4699 VDD a_12363_14024# 0.92885f
C4700 VDD a_20391_13190# 0.28336f
C4701 VDD a_25153_7532# 0.49426f
C4702 VDD a_8808_3889# 0.17499f
C4703 VDD a_26985_6209# 0.29292f
C4704 REF_CLK a_13566_11525# 0.01538f
C4705 CHAN2_DELAY_IN a_4157_4158# 0.50642f
C4706 a_7390_16071# a_7364_16035# 0.277f
C4707 a_5197_16869# a_5191_16035# 0.02349f
C4708 a_5957_16869# a_4350_16071# 0.05231f
C4709 a_5731_15316# a_15273_14024# 0.01872f
C4710 a_10517_14024# a_10430_13226# 0.1088f
C4711 a_13470_13226# a_14235_13226# 0.39037f
C4712 a_24665_13226# a_24951_13190# 0.01885f
C4713 a_4187_2434# a_23763_4687# 0.06627f
C4714 a_13019_11521# a_14851_11918# 0.01651f
C4715 a_13306_11995# a_13880_11982# 0.31978f
C4716 a_13592_11561# a_14009_11568# 0.37583f
C4717 a_19833_7532# a_19963_7532# 0.70845f
C4718 a_13121_11521# a_15108_11799# 0.03701f
C4719 a_12849_11557# a_14111_11568# 0.42174f
C4720 a_24957_4687# a_24523_4687# 0.6972f
C4721 a_5731_3134# a_6913_1842# 0.01872f
C4722 a_22677_1842# a_22873_1842# 0.73022f
C4723 a_5731_289# a_16108_289# 0.01334f
C4724 a_1544_1044# VDD 0.45079f
C4725 a_11848_1044# a_11277_1842# 0.10863f
C4726 VDD a_16597_16869# 0.86886f
C4727 VDD a_24951_16035# 0.2822f
C4728 VDD a_13368_6734# 0.17274f
C4729 VDD a_7477_7532# 0.86712f
C4730 a_20397_16869# a_19963_16869# 0.6972f
C4731 a_4187_2434# a_14643_14024# 0.06627f
C4732 a_24393_14024# a_24523_14024# 0.70845f
C4733 a_4187_2434# a_27433_7532# 0.11284f
C4734 a_4187_2434# a_6153_4687# 0.11222f
C4735 a_11277_7532# a_10843_7532# 0.6972f
C4736 a_14317_7532# a_14311_6698# 0.02349f
C4737 a_15077_7532# a_13470_6734# 0.05231f
C4738 a_19637_4687# a_19524_3853# 0.05157f
C4739 a_15837_4687# a_16033_4687# 0.76914f
C4740 a_21835_1044# a_21911_1008# 0.01194f
C4741 a_26673_1842# VDD 0.49593f
C4742 VDD a_17065_16071# 0.3023f
C4743 VDD a_5631_14652# 0.01806f
C4744 VDD a_10649_11568# 0.24892f
C4745 VDD a_19833_4687# 0.49553f
C4746 VDD a_3449_3176# 0.47499f
C4747 CHAN0_MUX_SEL4 a_5731_15316# 4.60702f
C4748 a_4187_2434# a_18877_16869# 0.0414f
C4749 a_11277_16869# a_11473_16869# 0.76914f
C4750 a_14317_16869# a_14311_16035# 0.02349f
C4751 a_15077_16869# a_13470_16071# 0.05231f
C4752 a_4350_16071# a_5731_15316# 0.41099f
C4753 a_4187_2434# a_9757_7532# 0.0414f
C4754 a_15837_14024# a_15403_14024# 0.6972f
C4755 a_19637_14024# a_19550_13226# 0.1088f
C4756 a_9444_10280# a_5864_9057# 0.06832f
C4757 a_12505_6734# a_12791_6698# 0.01885f
C4758 a_6717_4687# a_7477_4687# 0.06198f
C4759 a_12715_3889# a_12791_3853# 0.01194f
C4760 a_24665_3889# a_22590_3889# 0.03208f
C4761 a_11277_1842# a_11603_1842# 0.01427f
C4762 a_14964_1008# VDD 0.28225f
C4763 VDD REF_MUX_OUT 0.97728f
C4764 VDD a_16271_17497# 0.01806f
C4765 VDD a_17928_13226# 0.17499f
C4766 VDD a_10713_14024# 0.49555f
C4767 VDD a_23437_7532# 0.86929f
C4768 VDD a_14825_6209# 0.29292f
C4769 VDD a_5844_3853# 0.28225f
C4770 DLL_RESETN a_12656_11554# 0.11782f
C4771 CHAN1_MUX_OUT a_13019_11521# 0.273f
C4772 REF_CLK a_12355_11557# 1.0042f
C4773 CHAN2_MUX_SEL1 a_1544_3889# 0.1672f
C4774 CHAN2_MUX_SEL0 a_1721_4240# 0.01315f
C4775 a_12505_16071# a_12715_16071# 0.09424f
C4776 a_6717_14024# a_6913_14024# 0.76914f
C4777 a_6326_10280# a_9444_10280# 0.01269f
C4778 a_4187_2434# a_22113_4687# 0.11169f
C4779 a_13121_11521# a_13566_11525# 0.01158f
C4780 a_23145_13226# a_22590_13226# 0.03209f
C4781 a_13019_11521# a_13592_11561# 0.04178f
C4782 a_18877_7532# a_19203_7532# 0.01427f
C4783 a_1256_6734# a_2297_7085# 0.04619f
C4784 a_1256_5979# a_2873_6021# 0.27926f
C4785 a_22590_6734# a_16108_5979# 0.56869f
C4786 a_1544_5979# a_2297_6021# 0.27303f
C4787 a_24197_7532# a_22590_6734# 0.05231f
C4788 a_23437_7532# a_23431_6698# 0.02349f
C4789 a_23633_4687# a_24197_4687# 0.0114f
C4790 a_15964_3134# a_16108_3134# 0.42202f
C4791 a_21353_1842# a_21483_1842# 0.70845f
C4792 a_14643_1842# a_5731_3134# 0.01544f
C4793 VDD a_13883_16869# 0.49733f
C4794 VDD a_22488_16071# 0.1824f
C4795 VDD a_4763_7532# 0.4973f
C4796 VDD a_1544_13226# 0.45079f
C4797 VDD a_10430_6734# 1.08486f
C4798 VDD a_14513_1842# 0.49593f
C4799 VDD a_26911_5315# 0.01806f
C4800 CHAN3_DELAY_IN a_4187_2434# 0.07719f
C4801 CHAN3_DELAY_IN a_4437_1842# 0.05007f
C4802 CHAN2_MUX_SEL4 a_4633_1842# 0.01287f
C4803 a_19073_16869# a_19637_16869# 0.0114f
C4804 a_1256_15316# a_2297_15358# 0.04261f
C4805 a_1544_15316# a_1721_15358# 0.36963f
C4806 a_23437_16869# a_23431_16035# 0.02349f
C4807 a_4187_2434# a_12993_14024# 0.11169f
C4808 a_24197_16869# a_22590_16071# 0.05231f
C4809 a_4187_2434# a_25717_7532# 0.04176f
C4810 a_23437_14024# a_23763_14024# 0.01427f
C4811 a_5731_12471# a_6854_11676# 0.02306f
C4812 a_4187_2434# a_4437_4687# 0.04193f
C4813 a_15765_12645# a_16108_12471# 0.42004f
C4814 a_12797_7532# a_13444_6698# 0.02011f
C4815 a_9953_7532# a_10517_7532# 0.0114f
C4816 a_27563_7532# a_27671_7532# 0.01163f
C4817 a_16510_6734# a_17351_6698# 0.28268f
C4818 a_14513_4687# a_14643_4687# 0.70845f
C4819 a_22590_3889# a_24008_3889# 0.38994f
C4820 a_20315_1044# a_20391_1008# 0.01194f
C4821 a_19550_1044# a_21044_1008# 0.28279f
C4822 a_20905_519# VDD 0.29292f
C4823 a_24957_1842# VDD 0.88247f
C4824 VDD a_6425_16071# 0.29722f
C4825 VDD a_26673_14024# 0.49593f
C4826 VDD a_9547_11632# 0.15246f
C4827 VDD a_18117_4687# 0.85996f
C4828 VDD a_27124_3853# 0.28225f
C4829 CHAN3_MUX_SEL4 CHAN3_MUX_OUT 0.91933f
C4830 CHAN0_MUX_SEL4 a_2297_15358# 0.04338f
C4831 CHAN0_MUX_SEL3 a_2873_15358# 0.12606f
C4832 CHAN0_MUX_SEL2 a_3449_15358# 0.10741f
C4833 a_4187_2434# a_16163_16869# 0.06627f
C4834 a_9953_16869# a_10083_16869# 0.70845f
C4835 a_27563_16869# a_27671_16869# 0.01163f
C4836 a_12797_16869# a_13444_16035# 0.02011f
C4837 a_16510_16071# a_17275_16071# 0.39037f
C4838 a_14513_14024# a_15077_14024# 0.0114f
C4839 a_4187_2434# a_7043_7532# 0.06627f
C4840 a_16108_15316# a_26673_14024# 0.01872f
C4841 a_22590_13226# a_23431_13190# 0.28268f
C4842 a_27237_7532# a_26803_7532# 0.6972f
C4843 a_14851_10872# a_15688_11093# 0.08776f
C4844 a_5731_5979# a_11473_4687# 0.01872f
C4845 a_10985_6734# a_10430_6734# 0.03209f
C4846 a_5957_4687# a_5523_4687# 0.6972f
C4847 a_4350_6734# a_5768_6734# 0.38994f
C4848 a_8237_4687# a_8231_3853# 0.02349f
C4849 a_8997_4687# a_7390_3889# 0.05231f
C4850 a_11195_3889# a_11271_3853# 0.01194f
C4851 a_10517_1842# a_10713_1842# 0.73897f
C4852 a_10430_3889# a_11924_3853# 0.28279f
C4853 a_7390_1044# a_9675_1044# 0.39036f
C4854 a_12715_1044# VDD 0.15484f
C4855 CHAN0_MUX_OUT CHAN1_DELAY_IN 0.05155f
C4856 a_27237_1842# a_4187_2434# 0.06189f
C4857 VDD a_10191_17497# 0.01806f
C4858 VDD a_8997_14024# 0.85955f
C4859 VDD a_14964_13190# 0.28225f
C4860 VDD a_20723_7532# 0.49677f
C4861 VDD a_27705_3889# 0.29962f
C4862 DLL_RESETN a_10751_11568# 0.45018f
C4863 a_27237_16869# a_27433_16869# 0.77122f
C4864 a_5393_14024# a_5523_14024# 0.70845f
C4865 a_5731_15316# a_10843_14024# 0.01539f
C4866 a_4350_16071# a_5191_16035# 0.28268f
C4867 a_12656_11554# a_13019_11521# 0.04193f
C4868 a_4187_2434# a_20397_4687# 0.04141f
C4869 a_10430_13226# a_11848_13226# 0.38994f
C4870 a_12355_11557# a_13121_11521# 0.05795f
C4871 a_20105_13226# a_20391_13190# 0.01885f
C4872 a_21917_7532# a_22564_6698# 0.02011f
C4873 a_18117_7532# a_18313_7532# 0.77122f
C4874 a_22677_4687# a_23437_4687# 0.01323f
C4875 a_21917_4687# a_16108_3134# 0.01053f
C4876 a_20397_1842# a_20723_1842# 0.01427f
C4877 VDD a_12233_16869# 0.59709f
C4878 VDD a_19550_16071# 0.8993f
C4879 VDD a_20831_5315# 0.01806f
C4880 VDD a_7364_6698# 0.28633f
C4881 VDD a_12797_1842# 0.8835f
C4882 CHAN2_DELAY_IN a_4187_2434# 0.07974f
C4883 CHAN2_MUX_OUT a_15964_3134# 0.01307f
C4884 CHAN2_MUX_SEL4 a_16108_3134# 0.1283f
C4885 a_18117_16869# a_18877_16869# 0.02912f
C4886 a_19550_16071# a_16108_15316# 0.58202f
C4887 a_21917_16869# a_22564_16035# 0.02011f
C4888 a_4187_2434# a_11277_14024# 0.0414f
C4889 a_4187_2434# a_23003_7532# 0.06405f
C4890 a_22677_14024# a_22873_14024# 0.73022f
C4891 a_5731_12471# a_16108_12471# 0.01334f
C4892 a_26043_7532# a_26151_7532# 0.01163f
C4893 a_12037_7532# a_11924_6698# 0.02055f
C4894 a_8997_7532# a_9757_7532# 0.02912f
C4895 a_16108_5979# a_24523_4687# 0.01542f
C4896 a_15755_6734# a_15831_6698# 0.01194f
C4897 a_27705_6734# a_27991_6698# 0.01885f
C4898 a_18117_4687# a_16510_3889# 0.05231f
C4899 a_17357_4687# a_17351_3853# 0.02349f
C4900 a_15403_1842# a_13470_1044# 0.01012f
C4901 a_24197_1842# a_24665_1044# 0.2079f
C4902 a_22243_1842# VDD 0.95073f
C4903 VDD a_24957_14024# 0.88247f
C4904 VDD a_20905_12701# 0.29292f
C4905 VDD a_15403_4687# 0.4973f
C4906 VDD a_24875_3889# 0.15407f
C4907 CHAN3_MUX_SEL0 CHAN3_MUX_SEL1 3.14917f
C4908 CHAN1_DELAY_IN a_4157_13495# 0.50642f
C4909 a_12037_16869# a_11924_16035# 0.02055f
C4910 a_4187_2434# a_14513_16869# 0.11222f
C4911 a_26043_16869# a_26151_16869# 0.01163f
C4912 a_4187_2434# a_5393_7532# 0.11222f
C4913 a_16108_15316# a_24957_14024# 0.01307f
C4914 a_13557_14024# a_14317_14024# 0.01669f
C4915 a_27705_16071# a_27915_16071# 0.09424f
C4916 a_21835_13226# a_21911_13190# 0.01194f
C4917 a_13592_11113# a_14851_10872# 0.01529f
C4918 a_25913_7532# a_26477_7532# 0.0114f
C4919 a_7945_6734# a_8231_6698# 0.01885f
C4920 a_4633_4687# a_5197_4687# 0.0114f
C4921 a_5731_5979# a_9757_4687# 0.01307f
C4922 a_18585_3889# a_18795_3889# 0.09424f
C4923 a_6717_4687# a_7364_3853# 0.02011f
C4924 a_9193_1842# a_9323_1842# 0.70845f
C4925 a_15545_1044# a_13470_1044# 0.03208f
C4926 a_9751_1008# VDD 0.2822f
C4927 a_1544_1044# CHAN3_MUX_SEL4 0.03407f
C4928 a_1256_1044# CHAN3_MUX_OUT 0.02199f
C4929 a_2297_1395# CHAN3_MUX_SEL0 0.10655f
C4930 a_24523_1842# a_4187_2434# 0.06627f
C4931 a_14643_1842# a_14317_1842# 0.01427f
C4932 a_26043_1842# a_16108_3134# 0.01539f
C4933 VDD a_4111_17497# 0.01866f
C4934 VDD a_6283_14024# 0.50001f
C4935 VDD a_12715_13226# 0.15484f
C4936 VDD a_19073_7532# 0.49426f
C4937 VDD a_15545_3889# 0.29962f
C4938 VDD a_1721_6021# 0.45365f
C4939 DLL_RESETN a_9772_11533# 0.06592f
C4940 a_25913_16869# a_26043_16869# 0.70845f
C4941 a_5731_15316# a_9193_14024# 0.01872f
C4942 a_4187_2434# a_27237_14024# 0.06189f
C4943 a_7945_16071# a_8155_16071# 0.09424f
C4944 a_4187_2434# a_17683_4687# 0.06627f
C4945 a_16793_7532# a_16923_7532# 0.70845f
C4946 a_21157_7532# a_21044_6698# 0.02055f
C4947 a_25630_6734# a_27048_6734# 0.38994f
C4948 a_21917_4687# a_21483_4687# 0.6972f
C4949 a_16510_6734# a_17865_6209# 0.02165f
C4950 a_26477_4687# a_26471_3853# 0.02349f
C4951 a_27237_4687# a_25630_3889# 0.05253f
C4952 a_19637_1842# a_19833_1842# 0.73897f
C4953 a_15837_1842# a_15964_289# 0.02f
C4954 a_24523_1842# a_22590_1044# 0.01012f
C4955 a_22590_1044# a_23945_519# 0.02165f
C4956 a_1544_289# a_2019_311# 0.01747f
C4957 VDD a_10517_16869# 0.86712f
C4958 a_7390_1044# a_7803_1842# 0.01012f
C4959 VDD a_16484_16035# 0.28687f
C4960 VDD a_15108_11015# 0.13728f
C4961 VDD a_5115_6734# 0.15389f
C4962 VDD a_14751_5315# 0.01806f
C4963 VDD a_10083_1842# 0.49994f
C4964 a_17357_16869# a_16923_16869# 0.6972f
C4965 a_4187_2434# a_8563_14024# 0.06627f
C4966 a_21157_16869# a_21044_16035# 0.02055f
C4967 a_21353_14024# a_21483_14024# 0.70845f
C4968 a_25630_16071# a_26471_16035# 0.28268f
C4969 a_4187_2434# a_21353_7532# 0.11284f
C4970 a_16510_16071# a_16851_15336# 0.02131f
C4971 a_4187_2434# a_5731_5979# 0.14779f
C4972 a_8237_7532# a_7803_7532# 0.6972f
C4973 a_13470_6734# a_14964_6698# 0.28279f
C4974 a_18117_7532# a_18585_6734# 0.2079f
C4975 a_14235_6734# a_14311_6698# 0.01194f
C4976 a_11277_7532# a_10430_6734# 0.08038f
C4977 a_24523_7532# a_24631_7532# 0.01163f
C4978 a_26185_6734# a_25630_6734# 0.03209f
C4979 a_12797_4687# a_12993_4687# 0.74917f
C4980 a_16108_5979# a_22873_4687# 0.01865f
C4981 a_19550_3889# a_21835_3889# 0.39036f
C4982 a_15837_4687# a_16484_3853# 0.02011f
C4983 a_16510_1044# a_18871_1008# 0.26208f
C4984 a_20593_1842# VDD 0.49594f
C4985 VDD a_22243_14024# 0.95241f
C4986 VDD a_24631_8160# 0.01806f
C4987 VDD a_13753_4687# 0.49559f
C4988 VDD a_21911_3853# 0.2822f
C4989 CHAN2_MUX_SEL4 CHAN2_MUX_OUT 0.91933f
C4990 CHAN1_MUX_SEL1 a_1544_13226# 0.1672f
C4991 CHAN1_MUX_SEL0 a_1721_13577# 0.01315f
C4992 REF_CLK a_9712_9602# 0.05046f
C4993 DLL_RESETN a_5864_9057# 0.1727f
C4994 a_4187_2434# a_12797_16869# 0.0414f
C4995 a_8237_16869# a_8433_16869# 0.76914f
C4996 a_11277_16869# a_10430_16071# 0.08038f
C4997 a_24523_16869# a_24631_16869# 0.01163f
C4998 a_18117_16869# a_18585_16071# 0.2079f
C4999 a_12797_14024# a_12363_14024# 0.6972f
C5000 a_13470_16071# a_14888_16071# 0.38994f
C5001 a_20315_13226# a_20391_13190# 0.01194f
C5002 a_19550_13226# a_21044_13190# 0.28279f
C5003 a_15304_10295# a_14851_10872# 0.05156f
C5004 a_4187_2434# a_12363_1842# 0.06482f
C5005 a_13566_11018# a_13592_11113# 0.36952f
C5006 a_24957_7532# a_25717_7532# 0.06198f
C5007 a_6425_6734# a_6635_6734# 0.09424f
C5008 a_5957_4687# a_5844_3853# 0.02055f
C5009 a_5731_5979# a_7043_4687# 0.01539f
C5010 a_7390_3889# a_9751_3853# 0.26208f
C5011 a_8237_1842# a_8563_1842# 0.01427f
C5012 a_27433_1842# a_27997_1842# 0.0114f
C5013 a_7288_1044# VDD 0.17274f
C5014 a_22873_1842# a_4187_2434# 0.11169f
C5015 a_24393_1842# a_16108_3134# 0.01872f
C5016 VDD a_26477_16869# 0.86919f
C5017 VDD a_4633_14024# 0.49523f
C5018 VDD a_9751_13190# 0.2822f
C5019 VDD a_17357_7532# 0.86919f
C5020 VDD a_26395_6734# 0.15389f
C5021 VDD a_4905_3889# 0.3017f
C5022 a_4187_2434# a_24523_14024# 0.06627f
C5023 a_24957_16869# a_25283_16869# 0.01427f
C5024 a_6283_14024# a_4350_13226# 0.01012f
C5025 a_5731_15316# a_7477_14024# 0.01314f
C5026 a_10517_14024# a_10985_13226# 0.19203f
C5027 a_4187_2434# a_16033_4687# 0.11222f
C5028 a_7390_13226# a_9675_13226# 0.39036f
C5029 a_10649_11568# a_11397_11918# 0.01058f
C5030 a_15837_7532# a_16163_7532# 0.01427f
C5031 a_10751_11568# a_11748_11799# 0.03061f
C5032 a_20397_7532# a_19550_6734# 0.08038f
C5033 a_20593_4687# a_21157_4687# 0.0114f
C5034 a_5705_3364# a_5731_3134# 0.28954f
C5035 a_24957_4687# a_25604_3853# 0.02011f
C5036 a_18313_1842# a_18443_1842# 0.70845f
C5037 a_1256_1044# a_1544_1044# 1.26509f
C5038 a_7288_1044# a_6717_1842# 0.10864f
C5039 a_12505_1044# a_12037_1842# 0.2079f
C5040 VDD a_7803_16869# 0.4973f
C5041 VDD a_14235_16071# 0.15389f
C5042 VDD a_13306_10795# 0.79687f
C5043 VDD a_23145_6734# 0.30409f
C5044 VDD a_8671_5315# 0.01806f
C5045 VDD a_8433_1842# 0.49593f
C5046 REF_DELAY_OUT_LAST a_13121_11521# 0.13178f
C5047 CHAN2_MUX_SEL4 a_3449_3176# 0.05166f
C5048 a_16033_16869# a_16597_16869# 0.0114f
C5049 a_20397_16869# a_19550_16071# 0.08038f
C5050 a_4187_2434# a_6913_14024# 0.11222f
C5051 a_4187_2434# a_19637_7532# 0.04176f
C5052 a_20397_14024# a_20723_14024# 0.01427f
C5053 a_24875_16071# a_24951_16035# 0.01194f
C5054 a_6913_7532# a_7477_7532# 0.0114f
C5055 a_23003_7532# a_23111_7532# 0.01163f
C5056 a_9757_7532# a_9751_6698# 0.02354f
C5057 a_23145_6734# a_23431_6698# 0.01885f
C5058 a_16108_5979# a_21157_4687# 0.01319f
C5059 a_15077_4687# a_14964_3853# 0.02055f
C5060 a_11473_4687# a_11603_4687# 0.70845f
C5061 a_16408_1044# a_16510_1044# 0.37183f
C5062 a_26803_1842# a_26911_1842# 0.01163f
C5063 a_1256_289# VDD 0.40593f
C5064 a_18877_1842# VDD 0.88247f
C5065 VDD a_20593_14024# 0.49594f
C5066 VDD a_18551_8160# 0.01806f
C5067 VDD a_19448_3889# 0.17274f
C5068 VDD a_12037_4687# 0.86172f
C5069 CHAN2_MUX_SEL0 CHAN2_MUX_SEL1 3.14917f
C5070 a_6913_16869# a_7043_16869# 0.70845f
C5071 a_4187_2434# a_10083_16869# 0.06627f
C5072 a_23003_16869# a_23111_16869# 0.01163f
C5073 a_9757_16869# a_9751_16035# 0.02354f
C5074 a_23145_16071# a_23355_16071# 0.09424f
C5075 a_16108_15316# a_20593_14024# 0.01872f
C5076 a_11473_14024# a_12037_14024# 0.0114f
C5077 a_24197_14024# a_24665_13226# 0.2079f
C5078 a_15403_14024# a_13470_13226# 0.01012f
C5079 a_4187_2434# a_10713_1842# 0.11222f
C5080 a_13106_11047# a_12907_11110# 0.14994f
C5081 a_24197_7532# a_23763_7532# 0.6972f
C5082 a_4157_7003# a_4350_6734# 0.04624f
C5083 a_8997_4687# a_9465_3889# 0.2079f
C5084 a_5197_4687# a_4350_3889# 0.08038f
C5085 a_16108_5979# a_16851_5999# 0.06181f
C5086 a_14025_3889# a_14235_3889# 0.09424f
C5087 a_7477_1842# a_7673_1842# 0.73897f
C5088 a_7288_3889# a_7390_3889# 0.37183f
C5089 a_26477_1842# a_27237_1842# 0.03319f
C5090 a_9465_1044# a_9675_1044# 0.09424f
C5091 a_4248_1044# a_4324_1008# 0.01176f
C5092 a_4350_1044# VDD 0.87635f
C5093 a_21157_1842# a_4187_2434# 0.04141f
C5094 VDD a_23763_16869# 0.49674f
C5095 VDD a_16108_15316# 1.64187f
C5096 VDD a_7288_13226# 0.17274f
C5097 VDD a_14643_7532# 0.49675f
C5098 VDD a_23431_6698# 0.28357f
C5099 VDD a_2297_4240# 0.46536f
C5100 CHAN1_MUX_SEL4 a_16108_12471# 0.1283f
C5101 CHAN1_MUX_OUT a_15964_12471# 0.01307f
C5102 a_24197_16869# a_24393_16869# 0.77122f
C5103 CHAN3_MUX_SEL4 a_12797_1842# 0.01829f
C5104 a_4157_16340# a_4248_16071# 0.11672f
C5105 a_4187_2434# a_22873_14024# 0.11169f
C5106 a_15964_15316# a_16851_15336# 0.16757f
C5107 a_4187_2434# a_14317_4687# 0.04141f
C5108 a_10232_11561# a_10649_11568# 0.37583f
C5109 a_15545_13226# a_13470_13226# 0.03208f
C5110 a_9946_11995# a_10751_11568# 0.097f
C5111 a_15077_7532# a_15273_7532# 0.77122f
C5112 a_22590_6734# a_24875_6734# 0.39036f
C5113 a_18877_7532# a_18871_6698# 0.02354f
C5114 a_24197_4687# a_24084_3853# 0.02055f
C5115 a_19637_4687# a_20397_4687# 0.01669f
C5116 a_17357_1842# a_17683_1842# 0.01427f
C5117 a_23111_2470# VDD 0.01806f
C5118 a_4350_1044# a_6717_1842# 0.02479f
C5119 VDD a_11271_16035# 0.28357f
C5120 VDD a_6153_16869# 0.49285f
C5121 VDD a_10985_6734# 0.30409f
C5122 VDD a_6717_1842# 0.88148f
C5123 VDD a_27997_4687# 0.76528f
C5124 a_4187_2434# a_26043_16869# 0.06627f
C5125 a_15077_16869# a_15837_16869# 0.02912f
C5126 a_18877_16869# a_18871_16035# 0.02354f
C5127 a_22590_16071# a_24084_16035# 0.28279f
C5128 a_23355_16071# a_23431_16035# 0.01194f
C5129 a_4187_2434# a_5197_14024# 0.0414f
C5130 a_19637_14024# a_19833_14024# 0.73897f
C5131 a_4187_2434# a_16923_7532# 0.06661f
C5132 a_22590_13226# a_23945_12701# 0.02165f
C5133 a_24523_14024# a_22590_13226# 0.01012f
C5134 a_15837_14024# a_15964_12471# 0.02f
C5135 a_21483_7532# a_21591_7532# 0.01163f
C5136 a_8237_7532# a_8884_6698# 0.02312f
C5137 a_5957_7532# a_6717_7532# 0.02912f
C5138 a_27563_7532# a_27671_8160# 0.01697f
C5139 a_10430_6734# a_12791_6698# 0.26208f
C5140 a_22677_4687# a_23145_3889# 0.19203f
C5141 a_14317_4687# a_13470_3889# 0.08038f
C5142 a_16108_5979# a_18443_4687# 0.01542f
C5143 a_25283_1842# a_25391_1842# 0.01163f
C5144 a_14888_1044# a_14964_1008# 0.01176f
C5145 a_16163_1842# VDD 0.49822f
C5146 a_25630_1044# VDD 0.89531f
C5147 VDD a_18877_14024# 0.88247f
C5148 VDD a_1256_12471# 0.4192f
C5149 VDD a_9323_4687# 0.50001f
C5150 VDD a_12471_8160# 0.02372f
C5151 VDD a_16510_3889# 0.8795f
C5152 REF_MUX_SEL4 REF_MUX_OUT 0.91933f
C5153 REF_MUX_SEL4 a_14825_6209# 0.03307f
C5154 a_8237_16869# a_8884_16035# 0.02312f
C5155 a_4187_2434# a_8433_16869# 0.11222f
C5156 a_21483_16869# a_21591_16869# 0.01163f
C5157 a_10430_16071# a_12715_16071# 0.39036f
C5158 a_10517_14024# a_11277_14024# 0.01669f
C5159 a_16108_15316# a_18877_14024# 0.01307f
C5160 a_16510_13226# a_18871_13190# 0.26208f
C5161 a_4187_2434# a_8997_1842# 0.04141f
C5162 a_22873_7532# a_23437_7532# 0.0114f
C5163 a_27433_4687# a_27563_4687# 0.70845f
C5164 a_5768_3889# a_5844_3853# 0.01176f
C5165 a_6153_1842# a_6283_1842# 0.70845f
C5166 a_25717_1842# a_25283_1842# 0.69698f
C5167 a_20105_1044# VDD 0.30411f
C5168 a_18443_1842# a_4187_2434# 0.06627f
C5169 a_19963_1842# a_16108_3134# 0.01539f
C5170 VDD a_22113_16869# 0.55345f
C5171 VDD a_4350_13226# 0.87638f
C5172 VDD a_12993_7532# 0.49436f
C5173 VDD a_20968_6734# 0.17499f
C5174 DLL_RESETN a_5731_12471# 0.02461f
C5175 REF_MUX_SEL4 a_10430_6734# 0.21179f
C5176 a_22873_16869# a_23003_16869# 0.70361f
C5177 a_4187_2434# a_21157_14024# 0.04141f
C5178 a_27433_14024# a_27997_14024# 0.0114f
C5179 a_4187_2434# a_11603_4687# 0.06627f
C5180 a_9772_11533# a_9946_11995# 0.27179f
C5181 a_13753_7532# a_13883_7532# 0.70845f
C5182 a_17357_7532# a_18004_6698# 0.02312f
C5183 a_10430_6734# a_11785_6209# 0.02058f
C5184 a_23437_4687# a_22590_3889# 0.08038f
C5185 a_1256_3889# a_1721_4240# 0.13421f
C5186 a_18877_4687# a_18443_4687# 0.6972f
C5187 a_1256_3134# a_1544_3134# 1.25711f
C5188 a_16597_1842# a_16793_1842# 0.73897f
C5189 a_20397_1842# a_20968_1044# 0.10863f
C5190 a_25528_1044# a_25604_1008# 0.01176f
C5191 a_17031_2470# VDD 0.01806f
C5192 a_2019_311# CHAN3_MUX_OUT 8.45486f
C5193 VDD a_4437_16869# 0.87051f
C5194 a_4324_1008# a_4437_1842# 0.05157f
C5195 VDD a_8808_16071# 0.17499f
C5196 VDD a_23111_14652# 0.01806f
C5197 VDD a_25283_4687# 0.50004f
C5198 VDD a_4003_1842# 0.61691f
C5199 a_17357_16869# a_18004_16035# 0.02312f
C5200 a_4187_2434# a_24393_16869# 0.11222f
C5201 a_14317_16869# a_13883_16869# 0.6972f
C5202 a_4187_2434# a_15273_7532# 0.11297f
C5203 a_1256_13226# a_1544_13226# 1.26509f
C5204 a_18313_14024# a_18443_14024# 0.70845f
C5205 a_7477_7532# a_7390_6734# 0.1088f
C5206 a_5197_7532# a_4763_7532# 0.6972f
C5207 a_19963_7532# a_20071_7532# 0.01163f
C5208 a_26043_7532# a_26151_8160# 0.01697f
C5209 a_10328_6734# a_10430_6734# 0.37183f
C5210 a_16108_5979# a_16793_4687# 0.01843f
C5211 a_9757_4687# a_9953_4687# 0.76914f
C5212 a_12797_4687# a_12791_3853# 0.02354f
C5213 a_16408_3889# a_16484_3853# 0.01176f
C5214 a_23763_1842# a_23871_1842# 0.01163f
C5215 a_24665_1044# a_24875_1044# 0.09424f
C5216 a_13470_1044# a_13444_1008# 0.277f
C5217 a_22564_1008# VDD 0.28964f
C5218 VDD a_16163_14024# 0.49822f
C5219 VDD a_25630_13226# 0.89531f
C5220 VDD a_6391_8160# 0.01806f
C5221 VDD a_7673_4687# 0.49553f
C5222 REF_MUX_SEL0 REF_MUX_SEL1 3.14917f
C5223 VDD a_13444_3853# 0.28633f
C5224 CHAN0_MUX_SEL4 a_9757_16869# 0.01829f
C5225 DLL_RESETN a_13106_11047# 0.01263f
C5226 a_7477_16869# a_7390_16071# 0.1088f
C5227 a_5197_16869# a_5393_16869# 0.76914f
C5228 a_4187_2434# a_6717_16869# 0.0414f
C5229 a_19963_16869# a_20071_16869# 0.01163f
C5230 a_16108_15316# a_16163_14024# 0.0155f
C5231 a_9757_14024# a_9323_14024# 0.6972f
C5232 a_18585_16071# a_18871_16035# 0.01885f
C5233 a_26803_14024# a_26911_14024# 0.01163f
C5234 a_4187_2434# a_6283_1842# 0.06627f
C5235 a_12849_11557# a_13592_11113# 0.38497f
C5236 a_4187_2434# a_27563_4687# 0.06629f
C5237 a_16408_13226# a_16510_13226# 0.37183f
C5238 a_26477_7532# a_27124_6698# 0.02312f
C5239 a_21917_7532# a_22677_7532# 0.06198f
C5240 a_4350_3889# a_4324_3853# 0.277f
C5241 a_26477_4687# a_26803_4687# 0.01427f
C5242 a_9465_3889# a_9751_3853# 0.01885f
C5243 a_5731_3134# a_10713_1842# 0.01865f
C5244 a_5197_1842# a_5523_1842# 0.01427f
C5245 a_24393_1842# a_24957_1842# 0.0114f
C5246 a_4905_1044# a_5191_1008# 0.01885f
C5247 a_16108_289# a_26985_519# 0.27952f
C5248 a_7945_1044# VDD 0.30411f
C5249 a_16793_1842# a_4187_2434# 0.11222f
C5250 a_18313_1842# a_16108_3134# 0.02026f
C5251 a_13444_1008# a_13557_1842# 0.05157f
C5252 VDD a_20397_16869# 0.86919f
C5253 VDD a_3449_15358# 0.47499f
C5254 VDD a_20105_13226# 0.30411f
C5255 VDD a_11277_7532# 0.86926f
C5256 VDD a_18004_6698# 0.28225f
C5257 CHAN1_MUX_SEL4 a_3449_12513# 0.05166f
C5258 a_26477_16869# a_27124_16035# 0.02312f
C5259 a_21917_16869# a_22243_16869# 0.01427f
C5260 a_4187_2434# a_18443_14024# 0.06627f
C5261 a_9465_13226# a_9675_13226# 0.09424f
C5262 a_26477_14024# a_27237_14024# 0.03319f
C5263 a_4187_2434# a_9953_4687# 0.11222f
C5264 a_4248_13226# a_4324_13190# 0.01176f
C5265 a_5731_12471# a_13019_11521# 0.01515f
C5266 a_16597_7532# a_16510_6734# 0.1088f
C5267 a_17553_4687# a_18117_4687# 0.0114f
C5268 a_21917_4687# a_21911_3853# 0.02354f
C5269 a_27048_3889# a_27124_3853# 0.01176f
C5270 a_15273_1842# a_15403_1842# 0.70845f
C5271 a_10951_2470# VDD 0.01806f
C5272 a_1256_289# CHAN3_MUX_SEL4 0.65005f
C5273 a_1721_331# CHAN3_MUX_SEL2 0.01315f
C5274 a_1544_289# CHAN3_MUX_SEL3 0.15976f
C5275 VDD CHAN1_MUX_SEL1 0.5478f
C5276 VDD a_17031_14652# 0.01806f
C5277 VDD a_5844_16035# 0.28225f
C5278 VDD a_13306_11995# 0.77663f
C5279 VDD a_23633_4687# 0.49601f
C5280 VDD a_1721_7085# 0.4533f
C5281 VDD a_15964_3134# 0.31771f
C5282 REF_DELAY_OUT_LAST a_6854_11676# 0.08491f
C5283 a_16597_16869# a_16510_16071# 0.1088f
C5284 a_4187_2434# a_22677_16869# 0.04055f
C5285 a_12993_16869# a_13557_16869# 0.0114f
C5286 a_4187_2434# a_13557_7532# 0.04101f
C5287 a_17357_14024# a_17683_14024# 0.01427f
C5288 a_19550_16071# a_21911_16035# 0.26208f
C5289 a_18585_6734# a_16510_6734# 0.03208f
C5290 a_18443_7532# a_18551_7532# 0.01163f
C5291 a_8808_6734# a_8884_6698# 0.01176f
C5292 a_24523_7532# a_24631_8160# 0.01697f
C5293 a_8433_4687# a_8563_4687# 0.70845f
C5294 a_11277_4687# a_11924_3853# 0.02312f
C5295 a_13557_1842# a_13123_1842# 0.69698f
C5296 a_22243_1842# a_22351_1842# 0.01163f
C5297 a_20315_1044# VDD 0.1539f
C5298 a_4350_1044# CHAN3_MUX_SEL4 0.31434f
C5299 VDD CHAN3_MUX_SEL4 2.68337f
C5300 VDD a_27671_17497# 0.01806f
C5301 VDD a_14513_14024# 0.49593f
C5302 VDD a_27237_7532# 0.86022f
C5303 VDD a_22564_13190# 0.28964f
C5304 VDD a_5957_4687# 0.85996f
C5305 VDD a_11195_3889# 0.1539f
C5306 REF_CLK a_14111_11568# 0.02263f
C5307 REF_CLK a_4157_7003# 0.50643f
C5308 REF_MUX_SEL3 a_2297_6021# 0.01595f
C5309 REF_MUX_SEL4 a_1721_6021# 0.05813f
C5310 REF_MUX_SEL2 a_2873_6021# 0.01422f
C5311 REF_MUX_OUT a_1544_5979# 0.69943f
C5312 a_4187_2434# a_4003_16869# 0.05992f
C5313 a_18443_16869# a_18551_16869# 0.01163f
C5314 a_8433_14024# a_8997_14024# 0.0114f
C5315 a_17065_16071# a_16510_16071# 0.03209f
C5316 a_14888_13226# a_14964_13190# 0.01176f
C5317 a_11277_14024# a_11848_13226# 0.10863f
C5318 a_25283_14024# a_25391_14024# 0.01163f
C5319 a_4187_2434# a_25913_4687# 0.11222f
C5320 a_12849_11557# a_15304_10295# 0.0606f
C5321 a_4187_2434# a_4633_1842# 0.11222f
C5322 a_6854_11144# a_5778_9057# 0.02695f
C5323 a_6854_11676# a_9712_9602# 0.13962f
C5324 a_5974_11413# a_5864_9057# 0.01697f
C5325 a_13592_11561# a_14851_11918# 0.01529f
C5326 a_6126_9506# a_9444_9602# 0.25721f
C5327 a_21157_7532# a_20723_7532# 0.6972f
C5328 a_25717_7532# a_25630_6734# 0.1088f
C5329 a_25717_4687# a_25913_4687# 0.73897f
C5330 a_7945_3889# a_7390_3889# 0.03209f
C5331 a_5731_3134# a_8997_1842# 0.01319f
C5332 a_4437_1842# a_4633_1842# 0.73897f
C5333 a_23437_1842# a_24197_1842# 0.03319f
C5334 a_15765_463# a_15964_289# 0.061f
C5335 a_2873_1395# VDD 0.46517f
C5336 a_15077_1842# a_4187_2434# 0.04141f
C5337 a_16597_1842# a_16108_3134# 0.01319f
C5338 VDD a_17683_16869# 0.49671f
C5339 VDD a_7945_13226# 0.30411f
C5340 VDD a_27124_16035# 0.28225f
C5341 VDD a_8563_7532# 0.49671f
C5342 VDD a_15755_6734# 0.15389f
C5343 CHAN3_MUX_SEL4 a_6717_1842# 0.0195f
C5344 a_25717_16869# a_25630_16071# 0.1088f
C5345 a_4187_2434# a_16793_14024# 0.11222f
C5346 a_21157_16869# a_21353_16869# 0.77122f
C5347 a_25717_14024# a_25283_14024# 0.69698f
C5348 a_25630_16071# a_26985_15546# 0.02195f
C5349 a_4187_2434# a_8237_4687# 0.04141f
C5350 a_6326_10280# a_5974_11413# 0.33136f
C5351 a_12037_7532# a_12233_7532# 0.77122f
C5352 a_19448_6734# a_19524_6698# 0.01176f
C5353 a_16597_4687# a_17357_4687# 0.01669f
C5354 a_20397_4687# a_21044_3853# 0.02312f
C5355 a_25630_3889# a_25604_3853# 0.277f
C5356 a_16510_3889# a_15964_3134# 0.05416f
C5357 a_22590_1044# a_23355_1044# 0.39037f
C5358 a_4871_2470# VDD 0.01806f
C5359 VDD CHAN0_MUX_SEL1 0.5478f
C5360 a_13231_1842# a_13123_1842# 0.01163f
C5361 VDD a_27705_16071# 0.29962f
C5362 VDD a_10951_14652# 0.01806f
C5363 VDD a_21917_4687# 0.8957f
C5364 VDD a_8745_3364# 0.29292f
C5365 CHAN0_MUX_SEL4 a_14825_15546# 0.03307f
C5366 REF_DELAY_OUT_LAST a_16108_12471# 0.01081f
C5367 a_12037_16869# a_12797_16869# 0.02912f
C5368 a_4187_2434# a_19963_16869# 0.06627f
C5369 a_16597_14024# a_16793_14024# 0.73897f
C5370 a_4187_2434# a_10843_7532# 0.06627f
C5371 a_19448_16071# a_19550_16071# 0.37183f
C5372 a_20397_14024# a_20968_13226# 0.10863f
C5373 a_25528_13226# a_25604_13190# 0.01176f
C5374 a_16923_7532# a_17031_7532# 0.01163f
C5375 a_23003_7532# a_23111_8160# 0.01697f
C5376 a_7390_6734# a_7364_6698# 0.277f
C5377 a_10517_4687# a_10430_3889# 0.1088f
C5378 a_5731_5979# a_15273_4687# 0.01872f
C5379 a_24665_3889# a_24951_3853# 0.01885f
C5380 a_13470_3889# a_14235_3889# 0.39037f
C5381 a_12233_1842# a_12797_1842# 0.0114f
C5382 a_10430_1044# a_11271_1008# 0.28268f
C5383 a_26803_1842# a_26911_2470# 0.01697f
C5384 a_20723_1842# a_20831_1842# 0.01163f
C5385 a_20105_1044# a_20315_1044# 0.09424f
C5386 a_17351_1008# VDD 0.28565f
C5387 VDD CHAN2_MUX_SEL4 2.7481f
C5388 VDD a_21591_17497# 0.01806f
C5389 VDD a_12797_14024# 0.8835f
C5390 VDD a_20315_13226# 0.1539f
C5391 VDD a_24523_7532# 0.4973f
C5392 VDD a_8231_3853# 0.28357f
C5393 VDD a_23945_6209# 0.29292f
C5394 CHAN0_MUX_SEL4 a_10430_16071# 0.21179f
C5395 CHAN2_MUX_SEL1 a_2873_4240# 0.13092f
C5396 CHAN2_DELAY_IN a_3449_4240# 0.01058f
C5397 a_7288_16071# a_7364_16035# 0.01176f
C5398 a_16923_16869# a_17031_16869# 0.01163f
C5399 a_14025_16071# a_14311_16035# 0.01885f
C5400 a_23763_14024# a_23871_14024# 0.01163f
C5401 a_5731_15316# a_14643_14024# 0.01544f
C5402 a_7477_14024# a_8237_14024# 0.01669f
C5403 a_4187_2434# a_24197_4687# 0.04152f
C5404 a_24665_13226# a_24875_13226# 0.09424f
C5405 a_13470_13226# a_13444_13190# 0.277f
C5406 a_13566_11525# a_14009_11568# 0.02242f
C5407 a_4187_2434# a_16108_3134# 0.21585f
C5408 a_19833_7532# a_20397_7532# 0.0114f
C5409 a_13121_11521# a_14111_11568# 0.0235f
C5410 a_24393_4687# a_24523_4687# 0.70845f
C5411 a_5731_3134# a_6283_1842# 0.01542f
C5412 a_22677_1842# a_22243_1842# 0.69698f
C5413 a_5731_289# a_15964_289# 0.2778f
C5414 a_1256_1044# VDD 0.48292f
C5415 a_10430_1044# a_12037_1842# 0.05231f
C5416 a_11271_1008# a_11277_1842# 0.02349f
C5417 VDD a_16033_16869# 0.49413f
C5418 VDD a_2873_13577# 0.46517f
C5419 VDD a_24875_16071# 0.15406f
C5420 VDD a_12791_6698# 0.28232f
C5421 VDD a_6913_7532# 0.49426f
C5422 a_19833_16869# a_19963_16869# 0.70845f
C5423 a_4187_2434# a_15077_14024# 0.04141f
C5424 a_24393_14024# a_24957_14024# 0.0114f
C5425 a_4187_2434# a_26803_7532# 0.06661f
C5426 a_16108_12471# a_26985_12701# 0.27952f
C5427 a_4187_2434# a_5523_4687# 0.06627f
C5428 a_4905_13226# a_5191_13190# 0.01885f
C5429 a_10713_7532# a_10843_7532# 0.70845f
C5430 a_4350_6734# a_5731_5979# 0.41099f
C5431 a_15837_4687# a_15403_4687# 0.6972f
C5432 a_19637_4687# a_19550_3889# 0.1088f
C5433 a_16923_1842# a_16510_1044# 0.01012f
C5434 a_26043_1842# VDD 0.50058f
C5435 a_11711_1842# a_11603_1842# 0.01163f
C5436 VDD a_15545_16071# 0.29962f
C5437 VDD a_10232_11561# 0.07564f
C5438 VDD a_4871_14652# 0.01806f
C5439 VDD a_2873_3176# 0.46598f
C5440 VDD a_19203_4687# 0.50004f
C5441 a_11277_16869# a_10843_16869# 0.6972f
C5442 a_4187_2434# a_18313_16869# 0.11222f
C5443 a_17928_16071# a_18004_16035# 0.01176f
C5444 a_4187_2434# a_9193_7532# 0.11222f
C5445 a_15273_14024# a_15403_14024# 0.70845f
C5446 a_21483_7532# a_21591_8160# 0.01697f
C5447 a_9444_10280# a_9712_9602# 0.68929f
C5448 a_15403_7532# a_15511_7532# 0.01163f
C5449 a_15688_11093# a_15464_9374# 0.1999f
C5450 a_12505_6734# a_12715_6734# 0.09424f
C5451 a_6717_4687# a_6913_4687# 0.76914f
C5452 a_23145_3889# a_22590_3889# 0.03209f
C5453 a_11277_1842# a_12037_1842# 0.03319f
C5454 a_25283_1842# a_25391_2470# 0.01697f
C5455 a_19203_1842# a_19311_1842# 0.01163f
C5456 a_9675_1044# a_9751_1008# 0.01194f
C5457 a_14888_1044# VDD 0.17499f
C5458 VDD REF_MUX_SEL4 2.7481f
C5459 CHAN1_DELAY_IN CHAN1_MUX_SEL4 0.0663f
C5460 VDD a_15511_17497# 0.01806f
C5461 VDD a_17351_13190# 0.28565f
C5462 VDD a_10083_14024# 0.49994f
C5463 VDD a_11785_6209# 0.29292f
C5464 VDD a_22873_7532# 0.49388f
C5465 VDD a_5768_3889# 0.17499f
C5466 DLL_RESETN a_12355_11557# 0.04879f
C5467 CHAN2_MUX_SEL1 a_1256_3889# 1.44243f
C5468 CHAN2_MUX_SEL0 a_1544_3889# 0.07603f
C5469 a_15403_16869# a_15511_16869# 0.01163f
C5470 a_5731_15316# a_12993_14024# 0.01688f
C5471 a_22243_14024# a_22351_14024# 0.01163f
C5472 a_6717_14024# a_6283_14024# 0.6972f
C5473 a_4187_2434# a_21483_4687# 0.06627f
C5474 a_18877_7532# a_19637_7532# 0.06198f
C5475 a_1544_5979# a_1721_6021# 0.36963f
C5476 a_1256_5979# a_2297_6021# 0.04261f
C5477 a_23437_4687# a_23763_4687# 0.01427f
R0 VDD.n731 VDD.t696 17.3693
R1 VDD.n724 VDD.t829 17.3693
R2 VDD.n724 VDD.t831 17.3693
R3 VDD.n730 VDD.t1497 17.3517
R4 VDD.n727 VDD.t1600 17.3517
R5 VDD.n726 VDD.t366 17.3517
R6 VDD.n254 VDD.t630 17.2438
R7 VDD.n252 VDD.t1461 17.2438
R8 VDD.n250 VDD.t713 17.2438
R9 VDD.n248 VDD.t651 17.2438
R10 VDD.n246 VDD.t1452 17.2438
R11 VDD.n588 VDD.t359 17.2247
R12 VDD.n730 VDD.t572 17.0005
R13 VDD.n727 VDD.t830 17.0005
R14 VDD.n726 VDD.t827 17.0005
R15 VDD.t67 VDD.n1316 17.0005
R16 VDD.t67 VDD.n217 1.79211
R17 VDD.n621 VDD.n560 0.189847
R18 VDD.t67 VDD.n1373 17.0005
R19 VDD.t67 VDD.n266 8.47732
R20 VDD.n1382 VDD.t67 17.0005
R21 VDD.n265 VDD.t67 8.47732
R22 VDD.t67 VDD.n1365 17.0005
R23 VDD.t67 VDD.n262 8.47732
R24 VDD.n1397 VDD.t67 17.0005
R25 VDD.n1410 VDD.t67 17.0005
R26 VDD.n228 VDD.t67 1.00226
R27 VDD.t67 VDD.n1357 17.0005
R28 VDD.t67 VDD.n260 8.47732
R29 VDD.n1425 VDD.t67 17.0005
R30 VDD.t67 VDD.n259 8.47732
R31 VDD.n7 VDD.t379 0.882917
R32 VDD.n75 VDD.n74 0.133791
R33 VDD.t379 VDD.n594 1.57542
R34 VDD.n78 VDD.n77 0.131036
R35 VDD.n81 VDD.n82 0.22366
R36 VDD.t379 VDD.n82 0.677049
R37 VDD.n637 VDD.t379 5.62581
R38 VDD.n644 VDD.t379 2.32435
R39 VDD.n655 VDD.t379 5.62581
R40 VDD.n86 VDD.t379 0.970199
R41 VDD.n643 VDD.t379 5.62581
R42 VDD.n89 VDD.n88 0.116644
R43 VDD.n89 VDD.t379 1.14093
R44 VDD.n660 VDD.t379 5.62581
R45 VDD.n596 VDD.t379 1.57524
R46 VDD.t379 VDD.n597 1.57519
R47 VDD.n632 VDD.t379 5.62581
R48 VDD.n92 VDD.t379 1.55355
R49 VDD.n657 VDD.t379 2.32411
R50 VDD.n100 VDD.t379 1.14105
R51 VDD.n679 VDD.t379 5.62581
R52 VDD.n104 VDD.t379 1.14093
R53 VDD.n60 VDD.t379 8.47732
R54 VDD.n61 VDD.n60 0.0483676
R55 VDD.t0 VDD.n1557 17.0005
R56 VDD.t0 VDD.n215 1.79211
R57 VDD.n620 VDD.n562 0.189847
R58 VDD.t0 VDD.n1613 17.0005
R59 VDD.t0 VDD.n274 8.47732
R60 VDD.n1622 VDD.t0 17.0005
R61 VDD.n273 VDD.t0 8.47732
R62 VDD.t0 VDD.n1605 17.0005
R63 VDD.t0 VDD.n270 8.47732
R64 VDD.n1637 VDD.t0 17.0005
R65 VDD.n1650 VDD.t0 17.0005
R66 VDD.n232 VDD.t0 1.00226
R67 VDD.t0 VDD.n1597 17.0005
R68 VDD.t0 VDD.n268 8.47732
R69 VDD.n1665 VDD.t0 17.0005
R70 VDD.t0 VDD.n267 8.47732
R71 VDD.t347 VDD.n530 1.57542
R72 VDD.n108 VDD.n107 0.116663
R73 VDD.n108 VDD.t347 1.14105
R74 VDD.n113 VDD.n114 0.131004
R75 VDD.n665 VDD.t347 5.62581
R76 VDD.n668 VDD.t347 5.62581
R77 VDD.n118 VDD.t347 0.603617
R78 VDD.n659 VDD.t347 5.62581
R79 VDD.t347 VDD.n599 1.57542
R80 VDD.n667 VDD.t347 5.62581
R81 VDD.n128 VDD.n127 0.131036
R82 VDD.n131 VDD.t347 0.829345
R83 VDD.n613 VDD.t347 5.62581
R84 VDD.n134 VDD.n133 0.131036
R85 VDD.t347 VDD.n135 1.61265
R86 VDD.n515 VDD.t347 2.32437
R87 VDD.n624 VDD.t347 2.32439
R88 VDD.t347 VDD.n258 0.847286
R89 VDD.n63 VDD.t347 8.47732
R90 VDD.n64 VDD.n63 0.0483676
R91 VDD.t9 VDD.n1779 17.0005
R92 VDD.t9 VDD.n213 1.79211
R93 VDD.n618 VDD.n564 0.189847
R94 VDD.t9 VDD.n1837 17.0005
R95 VDD.t9 VDD.n282 8.47732
R96 VDD.n1846 VDD.t9 17.0005
R97 VDD.n281 VDD.t9 8.47732
R98 VDD.t9 VDD.n1828 17.0005
R99 VDD.t9 VDD.n278 8.47732
R100 VDD.n1861 VDD.t9 17.0005
R101 VDD.n1874 VDD.t9 17.0005
R102 VDD.n236 VDD.t9 1.00226
R103 VDD.t9 VDD.n1820 17.0005
R104 VDD.t9 VDD.n276 8.47732
R105 VDD.n1889 VDD.t9 17.0005
R106 VDD.t9 VDD.n275 8.47732
R107 VDD.t345 VDD.n4 0.406272
R108 VDD.t345 VDD.n501 1.57542
R109 VDD.t345 VDD.n602 1.57542
R110 VDD.n145 VDD.n144 0.116687
R111 VDD.n627 VDD.t345 5.62581
R112 VDD.n20 VDD.n492 0.604603
R113 VDD.t345 VDD.n650 5.62581
R114 VDD.t345 VDD.n658 5.62581
R115 VDD.n152 VDD.n484 0.550414
R116 VDD.t345 VDD.n152 1.19611
R117 VDD.n154 VDD.n155 0.131047
R118 VDD.n639 VDD.t345 5.62581
R119 VDD.t345 VDD.n605 1.57523
R120 VDD.n158 VDD.n157 0.116616
R121 VDD.t345 VDD.n158 1.14093
R122 VDD.n571 VDD.n612 0.0944268
R123 VDD.n572 VDD.n571 0.0919971
R124 VDD.t345 VDD.n66 8.47732
R125 VDD.n66 VDD.n65 0.0483676
R126 VDD.t2 VDD.n1195 17.0005
R127 VDD.t2 VDD.n211 1.79211
R128 VDD.n616 VDD.n566 0.189847
R129 VDD.t2 VDD.n1252 17.0005
R130 VDD.t2 VDD.n290 8.47732
R131 VDD.n1261 VDD.t2 17.0005
R132 VDD.n289 VDD.t2 8.47732
R133 VDD.t2 VDD.n1244 17.0005
R134 VDD.t2 VDD.n286 8.47732
R135 VDD.n1276 VDD.t2 17.0005
R136 VDD.n1289 VDD.t2 17.0005
R137 VDD.n240 VDD.t2 1.00226
R138 VDD.t2 VDD.n1236 17.0005
R139 VDD.t2 VDD.n284 8.47732
R140 VDD.n1304 VDD.t2 17.0005
R141 VDD.t2 VDD.n283 8.47732
R142 VDD.n170 VDD.n169 0.131036
R143 VDD.n170 VDD.t378 1.55338
R144 VDD.t378 VDD.n185 1.61635
R145 VDD.n187 VDD.n188 0.131076
R146 VDD.n191 VDD.n190 0.130931
R147 VDD.t378 VDD.n194 1.57542
R148 VDD.t378 VDD.n197 0.677003
R149 VDD.n649 VDD.t378 5.62581
R150 VDD.n446 VDD.t378 1.55338
R151 VDD.n449 VDD.n448 0.130924
R152 VDD.n450 VDD.t378 0.829408
R153 VDD.n648 VDD.t378 5.62581
R154 VDD.n453 VDD.n452 0.130979
R155 VDD.n453 VDD.t378 1.55344
R156 VDD.n456 VDD.n455 0.131036
R157 VDD.n580 VDD.t378 1.06517
R158 VDD.n68 VDD.t378 8.47732
R159 VDD.n69 VDD.n68 0.0483676
R160 VDD.t34 VDD.n983 17.0005
R161 VDD.t34 VDD.n209 1.79211
R162 VDD.n615 VDD.n568 0.189847
R163 VDD.t34 VDD.n1040 17.0005
R164 VDD.t34 VDD.n298 8.47732
R165 VDD.n1049 VDD.t34 17.0005
R166 VDD.n297 VDD.t34 8.47732
R167 VDD.t34 VDD.n1031 17.0005
R168 VDD.t34 VDD.n294 8.47732
R169 VDD.n1064 VDD.t34 17.0005
R170 VDD.n1077 VDD.t34 17.0005
R171 VDD.n244 VDD.t34 1.00226
R172 VDD.t34 VDD.n1023 17.0005
R173 VDD.t34 VDD.n292 8.47732
R174 VDD.n1092 VDD.t34 17.0005
R175 VDD.t34 VDD.n291 8.47732
R176 VDD.n71 VDD.n70 0.0483676
R177 VDD.t368 VDD.n71 8.47732
R178 VDD.n61 VDD.t499 15.1333
R179 VDD.n64 VDD.t488 15.1333
R180 VDD.n65 VDD.t477 15.1333
R181 VDD.n69 VDD.t444 15.1333
R182 VDD.n70 VDD.t432 15.1333
R183 VDD.n1450 VDD.t502 15.0005
R184 VDD.n1435 VDD.t493 15.0005
R185 VDD.n1685 VDD.t491 15.0005
R186 VDD.n13 VDD.t482 15.0005
R187 VDD.n1932 VDD.t480 15.0005
R188 VDD.t345 VDD.t471 15.0005
R189 VDD.n1108 VDD.t447 15.0005
R190 VDD.t378 VDD.t438 15.0005
R191 VDD.n776 VDD.t435 15.0005
R192 VDD.n36 VDD.t427 15.0005
R193 VDD.n720 VDD.t461 15.0005
R194 VDD.n23 VDD.t469 15.0005
R195 VDD.n23 VDD.t807 18.1344
R196 VDD.n2000 VDD.t776 9.02285
R197 VDD.n721 VDD.n24 4.47071
R198 VDD.n23 VDD.t693 8.95516
R199 VDD.n715 VDD.t543 8.76054
R200 VDD.n715 VDD.t546 8.76054
R201 VDD.n1328 VDD.t1577 8.76054
R202 VDD.n1328 VDD.t703 8.76054
R203 VDD.n1329 VDD.t629 8.76054
R204 VDD.n1329 VDD.t632 8.76054
R205 VDD.n1331 VDD.t1211 8.76054
R206 VDD.n1331 VDD.t1430 8.76054
R207 VDD.n1332 VDD.t615 8.76054
R208 VDD.n1332 VDD.t389 8.76054
R209 VDD.n1334 VDD.t1202 8.76054
R210 VDD.n1334 VDD.t1481 8.76054
R211 VDD.n1336 VDD.t351 8.76054
R212 VDD.n1336 VDD.t704 8.76054
R213 VDD.n1339 VDD.t1212 8.76054
R214 VDD.n1339 VDD.t1432 8.76054
R215 VDD.n1341 VDD.t1204 8.76054
R216 VDD.n1341 VDD.t1289 8.76054
R217 VDD.n254 VDD.t1270 8.76054
R218 VDD.n1569 VDD.t1444 8.76054
R219 VDD.n1569 VDD.t375 8.76054
R220 VDD.n1570 VDD.t1435 8.76054
R221 VDD.n1570 VDD.t519 8.76054
R222 VDD.n1572 VDD.t1484 8.76054
R223 VDD.n1572 VDD.t711 8.76054
R224 VDD.n1573 VDD.t1439 8.76054
R225 VDD.n1573 VDD.t815 8.76054
R226 VDD.n1575 VDD.t797 8.76054
R227 VDD.n1575 VDD.t1174 8.76054
R228 VDD.n1577 VDD.t1423 8.76054
R229 VDD.n1577 VDD.t376 8.76054
R230 VDD.n1580 VDD.t1483 8.76054
R231 VDD.n1580 VDD.t710 8.76054
R232 VDD.n1582 VDD.t798 8.76054
R233 VDD.n1582 VDD.t1175 8.76054
R234 VDD.n252 VDD.t1462 8.76054
R235 VDD.n1791 VDD.t805 8.76054
R236 VDD.n1791 VDD.t349 8.76054
R237 VDD.n1792 VDD.t549 8.76054
R238 VDD.n1792 VDD.t1199 8.76054
R239 VDD.n1794 VDD.t424 8.76054
R240 VDD.n1794 VDD.t1186 8.76054
R241 VDD.n1795 VDD.t537 8.76054
R242 VDD.n1795 VDD.t777 8.76054
R243 VDD.n1797 VDD.t362 8.76054
R244 VDD.n1797 VDD.t954 8.76054
R245 VDD.n1799 VDD.t729 8.76054
R246 VDD.n1799 VDD.t348 8.76054
R247 VDD.n1802 VDD.t426 8.76054
R248 VDD.n1802 VDD.t1187 8.76054
R249 VDD.n1804 VDD.t363 8.76054
R250 VDD.n1804 VDD.t794 8.76054
R251 VDD.n250 VDD.t714 8.76054
R252 VDD.n1207 VDD.t858 8.76054
R253 VDD.n1207 VDD.t952 8.76054
R254 VDD.n1208 VDD.t801 8.76054
R255 VDD.n1208 VDD.t602 8.76054
R256 VDD.n1210 VDD.t417 8.76054
R257 VDD.n1210 VDD.t1551 8.76054
R258 VDD.n1211 VDD.t633 8.76054
R259 VDD.n1211 VDD.t603 8.76054
R260 VDD.n1213 VDD.t608 8.76054
R261 VDD.n1213 VDD.t1559 8.76054
R262 VDD.n1215 VDD.t740 8.76054
R263 VDD.n1215 VDD.t382 8.76054
R264 VDD.n1218 VDD.t418 8.76054
R265 VDD.n1218 VDD.t1549 8.76054
R266 VDD.n1220 VDD.t610 8.76054
R267 VDD.n1220 VDD.t854 8.76054
R268 VDD.n248 VDD.t652 8.76054
R269 VDD.n995 VDD.t1433 8.76054
R270 VDD.n995 VDD.t885 8.76054
R271 VDD.n996 VDD.t1421 8.76054
R272 VDD.n996 VDD.t1305 8.76054
R273 VDD.n998 VDD.t863 8.76054
R274 VDD.n998 VDD.t636 8.76054
R275 VDD.n999 VDD.t1422 8.76054
R276 VDD.n999 VDD.t1262 8.76054
R277 VDD.n1001 VDD.t355 8.76054
R278 VDD.n1001 VDD.t1494 8.76054
R279 VDD.n1003 VDD.t1434 8.76054
R280 VDD.n1003 VDD.t884 8.76054
R281 VDD.n1006 VDD.t862 8.76054
R282 VDD.n1006 VDD.t637 8.76054
R283 VDD.n1008 VDD.t354 8.76054
R284 VDD.n1008 VDD.t1390 8.76054
R285 VDD.n246 VDD.t1453 8.76054
R286 VDD.n311 VDD.n676 0.0651609
R287 VDD.t67 VDD.n674 4.21329
R288 VDD.n306 VDD.n673 0.0651609
R289 VDD.t67 VDD.n671 4.21329
R290 VDD.n670 VDD.t67 4.21329
R291 VDD.t67 VDD.n669 4.21329
R292 VDD.n326 VDD.n688 0.0651609
R293 VDD.n686 VDD.n1631 0.0651609
R294 VDD.n321 VDD.n685 0.0651609
R295 VDD.t0 VDD.n683 4.21329
R296 VDD.n316 VDD.n682 0.0651609
R297 VDD.t0 VDD.n680 4.21329
R298 VDD.n695 VDD.t9 4.21329
R299 VDD.n694 VDD.n1855 0.0651609
R300 VDD.n336 VDD.n693 0.0651609
R301 VDD.t9 VDD.n691 4.21329
R302 VDD.n690 VDD.t9 4.21329
R303 VDD.t9 VDD.n689 4.21329
R304 VDD.n356 VDD.n704 0.0651609
R305 VDD.n702 VDD.n1270 0.0651609
R306 VDD.n351 VDD.n701 0.0651609
R307 VDD.t2 VDD.n699 4.21329
R308 VDD.n698 VDD.t2 4.21329
R309 VDD.n697 VDD.n1313 0.0651609
R310 VDD.n712 VDD.t34 4.21329
R311 VDD.n711 VDD.n1058 0.0651609
R312 VDD.n366 VDD.n710 0.0651609
R313 VDD.n708 VDD.n1086 0.0651609
R314 VDD.n361 VDD.n707 0.0651609
R315 VDD.n705 VDD.n1101 0.0651609
R316 VDD.n41 VDD.t358 1.78925
R317 VDD.n376 VDD.n375 0.0624236
R318 VDD.t67 VDD.n1340 8.47732
R319 VDD.t67 VDD.n1337 8.47732
R320 VDD.t67 VDD.n1322 8.47732
R321 VDD.t67 VDD.n1325 8.47732
R322 VDD.t67 VDD.n1330 8.47732
R323 VDD.t67 VDD.n1371 8.47732
R324 VDD.t67 VDD.n676 4.21329
R325 VDD.n312 VDD.t67 1.64355
R326 VDD.n399 VDD.n266 0.147896
R327 VDD.n399 VDD.n397 0.0624233
R328 VDD.n1388 VDD.t67 8.47732
R329 VDD.n1389 VDD.n674 0.1666
R330 VDD.t67 VDD.n309 1.64355
R331 VDD.n265 VDD.n263 0.147896
R332 VDD.n396 VDD.n263 0.0624233
R333 VDD.t67 VDD.n1363 8.47732
R334 VDD.t67 VDD.n673 4.21329
R335 VDD.n307 VDD.t67 1.64355
R336 VDD.n394 VDD.n262 0.147896
R337 VDD.n394 VDD.n392 0.0624233
R338 VDD.n1416 VDD.t67 8.47732
R339 VDD.n1417 VDD.n671 0.1666
R340 VDD.t67 VDD.n304 1.64355
R341 VDD.t67 VDD.n1355 8.47732
R342 VDD.n670 VDD.n1353 0.1666
R343 VDD.n302 VDD.t67 1.64355
R344 VDD.n391 VDD.n260 0.147896
R345 VDD.n391 VDD.n389 0.0624233
R346 VDD.n1431 VDD.t67 8.47732
R347 VDD.n1432 VDD.n669 0.1666
R348 VDD.t67 VDD.n299 1.64355
R349 VDD.n375 VDD.n259 0.147747
R350 VDD.t379 VDD.n75 1.75579
R351 VDD.n558 VDD.t379 2.32439
R352 VDD.n554 VDD.t379 1.57523
R353 VDD.n629 VDD.t379 5.62581
R354 VDD.n1464 VDD.n77 0.354692
R355 VDD.n78 VDD.t379 1.55338
R356 VDD.n551 VDD.t379 2.32417
R357 VDD.n595 VDD.t379 1.5752
R358 VDD.n1467 VDD.n645 0.354692
R359 VDD.n645 VDD.t379 2.32417
R360 VDD.n645 VDD.n1460 0.310155
R361 VDD.n1468 VDD.n677 0.263403
R362 VDD.n85 VDD.n86 0.105694
R363 VDD.t379 VDD.n663 2.32406
R364 VDD.n545 VDD.t379 2.32417
R365 VDD.n647 VDD.t379 2.32439
R366 VDD.n541 VDD.t379 2.32429
R367 VDD.n678 VDD.t379 5.62581
R368 VDD.n537 VDD.t379 2.32406
R369 VDD.n91 VDD.n92 0.130924
R370 VDD.n1474 VDD.n91 0.355147
R371 VDD.n626 VDD.t379 3.32623
R372 VDD.n96 VDD.t379 0.603617
R373 VDD.n1480 VDD.n535 0.355071
R374 VDD.n535 VDD.t379 2.32406
R375 VDD.n99 VDD.n100 0.116663
R376 VDD.n1481 VDD.n634 0.354692
R377 VDD.n634 VDD.t379 2.32417
R378 VDD.n634 VDD.n1453 0.310155
R379 VDD.n636 VDD.n101 0.310289
R380 VDD.n103 VDD.n104 0.116644
R381 VDD.n1485 VDD.t379 8.47732
R382 VDD.n1487 VDD.t379 8.47732
R383 VDD.n1491 VDD.t379 8.47732
R384 VDD.n1533 VDD.t379 8.47732
R385 VDD.n379 VDD.n378 0.0624236
R386 VDD.t0 VDD.n1581 8.47732
R387 VDD.t0 VDD.n1578 8.47732
R388 VDD.t0 VDD.n1563 8.47732
R389 VDD.t0 VDD.n1566 8.47732
R390 VDD.t0 VDD.n1571 8.47732
R391 VDD.t0 VDD.n1611 8.47732
R392 VDD.t0 VDD.n688 4.21329
R393 VDD.n327 VDD.t0 1.64355
R394 VDD.n410 VDD.n274 0.147896
R395 VDD.n410 VDD.n408 0.0624233
R396 VDD.n1628 VDD.t0 8.47732
R397 VDD.n686 VDD.t0 4.21329
R398 VDD.t0 VDD.n324 1.64355
R399 VDD.n273 VDD.n271 0.147896
R400 VDD.n407 VDD.n271 0.0624233
R401 VDD.t0 VDD.n1603 8.47732
R402 VDD.t0 VDD.n685 4.21329
R403 VDD.n322 VDD.t0 1.64355
R404 VDD.n405 VDD.n270 0.147896
R405 VDD.n405 VDD.n403 0.0624233
R406 VDD.n1656 VDD.t0 8.47732
R407 VDD.n1657 VDD.n683 0.1666
R408 VDD.t0 VDD.n319 1.64355
R409 VDD.t0 VDD.n1595 8.47732
R410 VDD.t0 VDD.n682 4.21329
R411 VDD.n317 VDD.t0 1.64355
R412 VDD.n402 VDD.n268 0.147896
R413 VDD.n402 VDD.n400 0.0624233
R414 VDD.n1671 VDD.t0 8.47732
R415 VDD.n1672 VDD.n680 0.1666
R416 VDD.t0 VDD.n314 1.64355
R417 VDD.n378 VDD.n267 0.147747
R418 VDD.n664 VDD.t347 5.62581
R419 VDD.n532 VDD.t347 2.32425
R420 VDD.n1700 VDD.n532 0.354557
R421 VDD.n527 VDD.t347 1.57519
R422 VDD.n110 VDD.n111 0.131036
R423 VDD.n1701 VDD.n110 0.354692
R424 VDD.t347 VDD.n111 1.55338
R425 VDD.n1698 VDD.n113 0.354861
R426 VDD.n114 VDD.t347 1.55357
R427 VDD.n656 VDD.t347 2.32417
R428 VDD.n662 VDD.t347 5.62581
R429 VDD.n646 VDD.t347 2.32439
R430 VDD.n523 VDD.t347 2.32439
R431 VDD.n598 VDD.t347 2.03149
R432 VDD.n635 VDD.t347 5.62581
R433 VDD.n1704 VDD.n642 0.354771
R434 VDD.n1705 VDD.n519 0.354557
R435 VDD.n120 VDD.t347 2.32417
R436 VDD.n122 VDD.n123 0.116644
R437 VDD.n123 VDD.t347 1.14093
R438 VDD.n1707 VDD.n127 0.354692
R439 VDD.n128 VDD.t347 1.55338
R440 VDD.n600 VDD.t347 1.57526
R441 VDD.n1709 VDD.n133 0.354692
R442 VDD.n134 VDD.t347 1.55338
R443 VDD.n1710 VDD.n125 0.2636
R444 VDD.n512 VDD.t347 1.57519
R445 VDD.n137 VDD.n138 0.116616
R446 VDD.t347 VDD.n138 1.14093
R447 VDD.n1688 VDD.n624 0.354405
R448 VDD.n654 VDD.t347 5.62581
R449 VDD.n508 VDD.t347 2.32417
R450 VDD.n140 VDD.n141 0.116616
R451 VDD.n141 VDD.t347 1.14093
R452 VDD.n1711 VDD.n661 0.354771
R453 VDD.n640 VDD.t347 5.62581
R454 VDD.n1713 VDD.t347 8.47732
R455 VDD.n1755 VDD.t347 8.47732
R456 VDD.n382 VDD.n381 0.0624236
R457 VDD.t9 VDD.n1803 8.47732
R458 VDD.t9 VDD.n1800 8.47732
R459 VDD.t9 VDD.n1785 8.47732
R460 VDD.t9 VDD.n1788 8.47732
R461 VDD.t9 VDD.n1793 8.47732
R462 VDD.t9 VDD.n1835 8.47732
R463 VDD.n695 VDD.n1833 0.1666
R464 VDD.n342 VDD.t9 1.64355
R465 VDD.n421 VDD.n282 0.147896
R466 VDD.n421 VDD.n419 0.0624233
R467 VDD.n1852 VDD.t9 8.47732
R468 VDD.n694 VDD.t9 4.21329
R469 VDD.t9 VDD.n339 1.64355
R470 VDD.n281 VDD.n279 0.147896
R471 VDD.n418 VDD.n279 0.0624233
R472 VDD.t9 VDD.n1826 8.47732
R473 VDD.t9 VDD.n693 4.21329
R474 VDD.n337 VDD.t9 1.64355
R475 VDD.n416 VDD.n278 0.147896
R476 VDD.n416 VDD.n414 0.0624233
R477 VDD.n1880 VDD.t9 8.47732
R478 VDD.n1881 VDD.n691 0.1666
R479 VDD.t9 VDD.n334 1.64355
R480 VDD.t9 VDD.n1818 8.47732
R481 VDD.n690 VDD.n1816 0.1666
R482 VDD.n332 VDD.t9 1.64355
R483 VDD.n413 VDD.n276 0.147896
R484 VDD.n413 VDD.n411 0.0624233
R485 VDD.n1895 VDD.t9 8.47732
R486 VDD.n1896 VDD.n689 0.1666
R487 VDD.t9 VDD.n329 1.64355
R488 VDD.n381 VDD.n275 0.147747
R489 VDD.n16 VDD.n504 0.604459
R490 VDD.n17 VDD.n16 0.247299
R491 VDD.n17 VDD.n502 0.802375
R492 VDD.n26 VDD.n1983 0.442317
R493 VDD.n26 VDD.n27 0.282306
R494 VDD.n1992 VDD.n651 0.354936
R495 VDD.t345 VDD.n145 1.14105
R496 VDD.n696 VDD.n1976 0.263403
R497 VDD.t345 VDD.n1974 8.47732
R498 VDD.n147 VDD.n148 0.116687
R499 VDD.n148 VDD.t345 1.14105
R500 VDD.n1993 VDD.n490 0.35501
R501 VDD.n490 VDD.t345 2.32417
R502 VDD.t345 VDD.n20 1.16521
R503 VDD.n18 VDD.n29 0.282355
R504 VDD.t345 VDD.n603 1.57523
R505 VDD.t345 VDD.n666 2.32417
R506 VDD.t345 VDD.n652 2.32414
R507 VDD.n1950 VDD.n622 0.354933
R508 VDD.t345 VDD.n622 2.3242
R509 VDD.t345 VDD.n486 1.57542
R510 VDD.t345 VDD.n155 1.55354
R511 VDD.t345 VDD.n623 2.32417
R512 VDD.t345 VDD.n604 1.57526
R513 VDD.n638 VDD.t345 2.32417
R514 VDD.t345 VDD.n160 1.58372
R515 VDD.t345 VDD.n572 2.32425
R516 VDD.t345 VDD.n1899 8.47732
R517 VDD.t345 VDD.n1919 8.47732
R518 VDD.n385 VDD.n384 0.0624236
R519 VDD.t2 VDD.n1219 8.47732
R520 VDD.t2 VDD.n1216 8.47732
R521 VDD.t2 VDD.n1201 8.47732
R522 VDD.t2 VDD.n1204 8.47732
R523 VDD.t2 VDD.n1209 8.47732
R524 VDD.t2 VDD.n1250 8.47732
R525 VDD.t2 VDD.n704 4.21329
R526 VDD.n357 VDD.t2 1.64355
R527 VDD.n432 VDD.n290 0.147896
R528 VDD.n432 VDD.n430 0.0624233
R529 VDD.n1267 VDD.t2 8.47732
R530 VDD.n702 VDD.t2 4.21329
R531 VDD.t2 VDD.n354 1.64355
R532 VDD.n289 VDD.n287 0.147896
R533 VDD.n429 VDD.n287 0.0624233
R534 VDD.t2 VDD.n1242 8.47732
R535 VDD.t2 VDD.n701 4.21329
R536 VDD.n352 VDD.t2 1.64355
R537 VDD.n427 VDD.n286 0.147896
R538 VDD.n427 VDD.n425 0.0624233
R539 VDD.n1295 VDD.t2 8.47732
R540 VDD.n1296 VDD.n699 0.1666
R541 VDD.t2 VDD.n349 1.64355
R542 VDD.t2 VDD.n1234 8.47732
R543 VDD.n698 VDD.n1232 0.1666
R544 VDD.n347 VDD.t2 1.64355
R545 VDD.n424 VDD.n284 0.147896
R546 VDD.n424 VDD.n422 0.0624233
R547 VDD.n1310 VDD.t2 8.47732
R548 VDD.n697 VDD.t2 4.21329
R549 VDD.t2 VDD.n344 1.64355
R550 VDD.n384 VDD.n283 0.147747
R551 VDD.n163 VDD.n164 0.116616
R552 VDD.n164 VDD.t378 1.14101
R553 VDD.n166 VDD.n167 0.130931
R554 VDD.n1113 VDD.n166 0.355071
R555 VDD.n167 VDD.t378 1.5534
R556 VDD.n1114 VDD.n169 0.354692
R557 VDD.n1115 VDD.n475 0.354557
R558 VDD.n475 VDD.t378 2.32425
R559 VDD.n473 VDD.t378 1.57535
R560 VDD.n173 VDD.n174 0.22375
R561 VDD.n174 VDD.t378 0.676971
R562 VDD.n176 VDD.n177 0.116663
R563 VDD.n177 VDD.t378 1.14105
R564 VDD.n180 VDD.n181 0.130924
R565 VDD.t378 VDD.n181 1.55355
R566 VDD.n1112 VDD.n185 0.367506
R567 VDD.n188 VDD.t378 1.55342
R568 VDD.n630 VDD.t378 2.32425
R569 VDD.n1119 VDD.n190 0.355071
R570 VDD.n191 VDD.t378 1.5534
R571 VDD.n32 VDD.n33 0.282315
R572 VDD.n196 VDD.n197 0.223737
R573 VDD.n606 VDD.t378 1.57526
R574 VDD.n445 VDD.n446 0.131036
R575 VDD.n1120 VDD.n445 0.354692
R576 VDD.n641 VDD.t378 2.32417
R577 VDD.n1123 VDD.n448 0.355147
R578 VDD.n449 VDD.t378 1.55355
R579 VDD.n625 VDD.t378 2.32417
R580 VDD.n461 VDD.t378 1.5752
R581 VDD.n607 VDD.t378 1.57519
R582 VDD.n1130 VDD.n452 0.354903
R583 VDD.n1131 VDD.n455 0.354692
R584 VDD.t378 VDD.n456 1.55338
R585 VDD.n205 VDD.t378 5.62581
R586 VDD.n1133 VDD.t378 8.47732
R587 VDD.n1175 VDD.t378 8.47732
R588 VDD.n388 VDD.n387 0.0624236
R589 VDD.t34 VDD.n1007 8.47732
R590 VDD.t34 VDD.n1004 8.47732
R591 VDD.t34 VDD.n989 8.47732
R592 VDD.t34 VDD.n992 8.47732
R593 VDD.t34 VDD.n997 8.47732
R594 VDD.t34 VDD.n1038 8.47732
R595 VDD.n712 VDD.n1036 0.1666
R596 VDD.n372 VDD.t34 1.64355
R597 VDD.n443 VDD.n298 0.147896
R598 VDD.n443 VDD.n441 0.0624233
R599 VDD.n1055 VDD.t34 8.47732
R600 VDD.n711 VDD.t34 4.21329
R601 VDD.t34 VDD.n369 1.64355
R602 VDD.n297 VDD.n295 0.147896
R603 VDD.n440 VDD.n295 0.0624233
R604 VDD.t34 VDD.n1029 8.47732
R605 VDD.t34 VDD.n710 4.21329
R606 VDD.n367 VDD.t34 1.64355
R607 VDD.n438 VDD.n294 0.147896
R608 VDD.n438 VDD.n436 0.0624233
R609 VDD.n1083 VDD.t34 8.47732
R610 VDD.n708 VDD.t34 4.21329
R611 VDD.t34 VDD.n364 1.64355
R612 VDD.t34 VDD.n1021 8.47732
R613 VDD.t34 VDD.n707 4.21329
R614 VDD.n362 VDD.t34 1.64355
R615 VDD.n435 VDD.n292 0.147896
R616 VDD.n435 VDD.n433 0.0624233
R617 VDD.n1098 VDD.t34 8.47732
R618 VDD.n705 VDD.t34 4.21329
R619 VDD.t34 VDD.n359 1.64355
R620 VDD.n387 VDD.n291 0.147747
R621 VDD.t368 VDD.n773 8.47732
R622 VDD.t368 VDD.n753 8.47732
R623 VDD.n5 VDD.n36 0.0889311
R624 VDD.t368 VDD.n914 8.47732
R625 VDD.t368 VDD.n834 8.47732
R626 VDD.t368 VDD.n783 8.47732
R627 VDD.t368 VDD.n779 8.47732
R628 VDD.t360 VDD.n22 2.03723
R629 VDD.n21 VDD.n48 0.535837
R630 VDD.n1998 VDD.n459 7.8004
R631 VDD.n457 VDD.n1314 7.79846
R632 VDD.n374 VDD.t1635 7.62594
R633 VDD.n1348 VDD.t1634 7.62594
R634 VDD.n1433 VDD.t1633 7.62594
R635 VDD.n390 VDD.t1632 7.62594
R636 VDD.n1422 VDD.t1631 7.62594
R637 VDD.n1421 VDD.t1630 7.62594
R638 VDD.n225 VDD.t1629 7.62594
R639 VDD.n1420 VDD.t1628 7.62594
R640 VDD.n1418 VDD.t1627 7.62594
R641 VDD.n393 VDD.t1626 7.62594
R642 VDD.n1394 VDD.t1625 7.62594
R643 VDD.n1393 VDD.t1624 7.62594
R644 VDD.n395 VDD.t1623 7.62594
R645 VDD.n1392 VDD.t1622 7.62594
R646 VDD.n1390 VDD.t1621 7.62594
R647 VDD.n398 VDD.t1620 7.62594
R648 VDD.n1379 VDD.t1619 7.62594
R649 VDD.n1378 VDD.t1618 7.62594
R650 VDD.n377 VDD.t1653 7.62594
R651 VDD.n1589 VDD.t1652 7.62594
R652 VDD.n1673 VDD.t1651 7.62594
R653 VDD.n401 VDD.t1650 7.62594
R654 VDD.n1662 VDD.t1649 7.62594
R655 VDD.n1661 VDD.t1648 7.62594
R656 VDD.n229 VDD.t1647 7.62594
R657 VDD.n1660 VDD.t1646 7.62594
R658 VDD.n1658 VDD.t1645 7.62594
R659 VDD.n404 VDD.t1644 7.62594
R660 VDD.n1634 VDD.t1643 7.62594
R661 VDD.n1633 VDD.t1642 7.62594
R662 VDD.n406 VDD.t1641 7.62594
R663 VDD.n1632 VDD.t1640 7.62594
R664 VDD.n1630 VDD.t1639 7.62594
R665 VDD.n409 VDD.t1638 7.62594
R666 VDD.n1619 VDD.t1637 7.62594
R667 VDD.n1618 VDD.t1636 7.62594
R668 VDD.n380 VDD.t1671 7.62594
R669 VDD.n1811 VDD.t1670 7.62594
R670 VDD.n1897 VDD.t1669 7.62594
R671 VDD.n412 VDD.t1668 7.62594
R672 VDD.n1886 VDD.t1667 7.62594
R673 VDD.n1885 VDD.t1666 7.62594
R674 VDD.n233 VDD.t1665 7.62594
R675 VDD.n1884 VDD.t1664 7.62594
R676 VDD.n1882 VDD.t1663 7.62594
R677 VDD.n415 VDD.t1662 7.62594
R678 VDD.n1858 VDD.t1661 7.62594
R679 VDD.n1857 VDD.t1660 7.62594
R680 VDD.n417 VDD.t1659 7.62594
R681 VDD.n1856 VDD.t1658 7.62594
R682 VDD.n1854 VDD.t1657 7.62594
R683 VDD.n420 VDD.t1656 7.62594
R684 VDD.n1843 VDD.t1655 7.62594
R685 VDD.n1842 VDD.t1654 7.62594
R686 VDD.n383 VDD.t1689 7.62594
R687 VDD.n1227 VDD.t1688 7.62594
R688 VDD.n1312 VDD.t1687 7.62594
R689 VDD.n423 VDD.t1686 7.62594
R690 VDD.n1301 VDD.t1685 7.62594
R691 VDD.n1300 VDD.t1684 7.62594
R692 VDD.n237 VDD.t1683 7.62594
R693 VDD.n1299 VDD.t1682 7.62594
R694 VDD.n1297 VDD.t1681 7.62594
R695 VDD.n426 VDD.t1680 7.62594
R696 VDD.n1273 VDD.t1679 7.62594
R697 VDD.n1272 VDD.t1678 7.62594
R698 VDD.n428 VDD.t1677 7.62594
R699 VDD.n1271 VDD.t1676 7.62594
R700 VDD.n1269 VDD.t1675 7.62594
R701 VDD.n431 VDD.t1674 7.62594
R702 VDD.n1258 VDD.t1673 7.62594
R703 VDD.n1257 VDD.t1672 7.62594
R704 VDD.n386 VDD.t1707 7.62594
R705 VDD.n1015 VDD.t1706 7.62594
R706 VDD.n1100 VDD.t1705 7.62594
R707 VDD.n434 VDD.t1704 7.62594
R708 VDD.n1089 VDD.t1703 7.62594
R709 VDD.n1088 VDD.t1702 7.62594
R710 VDD.n241 VDD.t1701 7.62594
R711 VDD.n1087 VDD.t1700 7.62594
R712 VDD.n1085 VDD.t1699 7.62594
R713 VDD.n437 VDD.t1698 7.62594
R714 VDD.n1061 VDD.t1697 7.62594
R715 VDD.n1060 VDD.t1696 7.62594
R716 VDD.n439 VDD.t1695 7.62594
R717 VDD.n1059 VDD.t1694 7.62594
R718 VDD.n1057 VDD.t1693 7.62594
R719 VDD.n442 VDD.t1692 7.62594
R720 VDD.n1046 VDD.t1691 7.62594
R721 VDD.n1045 VDD.t1690 7.62594
R722 VDD.n1377 VDD.t594 6.16445
R723 VDD.n1617 VDD.t370 6.16445
R724 VDD.n1841 VDD.t1265 6.16445
R725 VDD.n1256 VDD.t1543 6.16445
R726 VDD.n1044 VDD.t505 6.16445
R727 VDD.n557 VDD.t1457 6.09901
R728 VDD.n553 VDD.t1446 6.09901
R729 VDD.n556 VDD.t878 6.09901
R730 VDD.n1464 VDD.t1471 6.09901
R731 VDD.n550 VDD.t1355 6.09901
R732 VDD.n79 VDD.t1192 6.09901
R733 VDD.n81 VDD.t880 6.09901
R734 VDD.n549 VDD.t523 6.09901
R735 VDD.n1461 VDD.t1334 6.09901
R736 VDD.n1467 VDD.t848 6.09901
R737 VDD.n1468 VDD.t658 6.09901
R738 VDD.n83 VDD.t819 6.09901
R739 VDD.n1469 VDD.t645 6.09901
R740 VDD.n544 VDD.t928 6.09901
R741 VDD.n547 VDD.t380 6.09901
R742 VDD.n1458 VDD.t677 6.09901
R743 VDD.n540 VDD.t727 6.09901
R744 VDD.n543 VDD.t559 6.09901
R745 VDD.n1470 VDD.t560 6.09901
R746 VDD.n1473 VDD.t874 6.09901
R747 VDD.n539 VDD.t525 6.09901
R748 VDD.n1474 VDD.t1297 6.09901
R749 VDD.n1454 VDD.t876 6.09901
R750 VDD.n1477 VDD.t528 6.09901
R751 VDD.n94 VDD.t526 6.09901
R752 VDD.n95 VDD.t1336 6.09901
R753 VDD.n1480 VDD.t941 6.09901
R754 VDD.n97 VDD.t894 6.09901
R755 VDD.n1481 VDD.t877 6.09901
R756 VDD.n1452 VDD.t853 6.09901
R757 VDD.n101 VDD.t1163 6.09901
R758 VDD.n1482 VDD.t569 6.09901
R759 VDD.n1700 VDD.t386 6.09901
R760 VDD.n529 VDD.t408 6.09901
R761 VDD.n526 VDD.t836 6.09901
R762 VDD.n105 VDD.t513 6.09901
R763 VDD.n1701 VDD.t649 6.09901
R764 VDD.n1698 VDD.t750 6.09901
R765 VDD.n1702 VDD.t410 6.09901
R766 VDD.n1703 VDD.t533 6.09901
R767 VDD.n1695 VDD.t700 6.09901
R768 VDD.n522 VDD.t393 6.09901
R769 VDD.n525 VDD.t403 6.09901
R770 VDD.n116 VDD.t753 6.09901
R771 VDD.n117 VDD.t639 6.09901
R772 VDD.n1704 VDD.t614 6.09901
R773 VDD.n1705 VDD.t532 6.09901
R774 VDD.n521 VDD.t413 6.09901
R775 VDD.n1706 VDD.t509 6.09901
R776 VDD.n120 VDD.t687 6.09901
R777 VDD.n1707 VDD.t1526 6.09901
R778 VDD.n1708 VDD.t398 6.09901
R779 VDD.n130 VDD.t735 6.09901
R780 VDD.n518 VDD.t1142 6.09901
R781 VDD.n1709 VDD.t357 6.09901
R782 VDD.n1710 VDD.t775 6.09901
R783 VDD.n1689 VDD.t705 6.09901
R784 VDD.n511 VDD.t405 6.09901
R785 VDD.n514 VDD.t737 6.09901
R786 VDD.n1688 VDD.t570 6.09901
R787 VDD.n507 VDD.t1271 6.09901
R788 VDD.n510 VDD.t865 6.09901
R789 VDD.n1711 VDD.t1201 6.09901
R790 VDD.n608 VDD.t957 6.09901
R791 VDD.t345 VDD.t350 6.09901
R792 VDD.n506 VDD.t731 6.09901
R793 VDD.n504 VDD.t563 6.09901
R794 VDD.n16 VDD.t573 6.09901
R795 VDD.n502 VDD.t893 6.09901
R796 VDD.n1983 VDD.t1525 6.09901
R797 VDD.n26 VDD.t1288 6.09901
R798 VDD.n499 VDD.t508 6.09901
R799 VDD.n1992 VDD.t1169 6.09901
R800 VDD.n142 VDD.t784 6.09901
R801 VDD.n1976 VDD.t1286 6.09901
R802 VDD.n493 VDD.t796 6.09901
R803 VDD.n496 VDD.t392 6.09901
R804 VDD.n1993 VDD.t412 6.09901
R805 VDD.n492 VDD.t744 6.09901
R806 VDD.n20 VDD.t400 6.09901
R807 VDD.n18 VDD.t346 6.09901
R808 VDD.n489 VDD.t541 6.09901
R809 VDD.n1996 VDD.t604 6.09901
R810 VDD.n1959 VDD.t387 6.09901
R811 VDD.n1954 VDD.t780 6.09901
R812 VDD.n1950 VDD.t1178 6.09901
R813 VDD.n487 VDD.t660 6.09901
R814 VDD.n484 VDD.t551 6.09901
R815 VDD.n150 VDD.t1499 6.09901
R816 VDD.n1946 VDD.t908 6.09901
R817 VDD.n482 VDD.t394 6.09901
R818 VDD.n1997 VDD.t1138 6.09901
R819 VDD.n480 VDD.t907 6.09901
R820 VDD.n478 VDD.t1256 6.09901
R821 VDD.n1938 VDD.t896 6.09901
R822 VDD.n160 VDD.t788 6.09901
R823 VDD.t378 VDD.t1475 6.09901
R824 VDD.n161 VDD.t1469 6.09901
R825 VDD.n1113 VDD.t1467 6.09901
R826 VDD.n1114 VDD.t1330 6.09901
R827 VDD.n1115 VDD.t1329 6.09901
R828 VDD.n472 VDD.t881 6.09901
R829 VDD.n171 VDD.t922 6.09901
R830 VDD.n173 VDD.t1357 6.09901
R831 VDD.n471 VDD.t889 6.09901
R832 VDD.n178 VDD.t882 6.09901
R833 VDD.n1112 VDD.t1155 6.09901
R834 VDD.n183 VDD.t599 6.09901
R835 VDD.n1116 VDD.t891 6.09901
R836 VDD.n1119 VDD.t850 6.09901
R837 VDD.n30 VDD.t722 6.09901
R838 VDD.n32 VDD.t721 6.09901
R839 VDD.n192 VDD.t873 6.09901
R840 VDD.n194 VDD.t642 6.09901
R841 VDD.n196 VDD.t655 6.09901
R842 VDD.n468 VDD.t644 6.09901
R843 VDD.n1120 VDD.t1133 6.09901
R844 VDD.n1110 VDD.t822 6.09901
R845 VDD.n1123 VDD.t555 6.09901
R846 VDD.n1124 VDD.t851 6.09901
R847 VDD.n200 VDD.t1512 6.09901
R848 VDD.n1127 VDD.t931 6.09901
R849 VDD.n464 VDD.t381 6.09901
R850 VDD.n460 VDD.t678 6.09901
R851 VDD.n463 VDD.t524 6.09901
R852 VDD.n1130 VDD.t936 6.09901
R853 VDD.n1131 VDD.t939 6.09901
R854 VDD.n204 VDD.t561 6.09901
R855 VDD.n977 VDD.t640 6.09901
R856 VDD.n971 VDD.t1205 6.09901
R857 VDD.n965 VDD.t912 6.09901
R858 VDD.n959 VDD.t565 6.09901
R859 VDD.n953 VDD.t716 6.09901
R860 VDD.n947 VDD.t1275 6.09901
R861 VDD.n941 VDD.t566 6.09901
R862 VDD.n935 VDD.t514 6.09901
R863 VDD.n929 VDD.t516 6.09901
R864 VDD.n923 VDD.t1148 6.09901
R865 VDD.n917 VDD.t915 6.09901
R866 VDD.n909 VDD.t867 6.09901
R867 VDD.n903 VDD.t1119 6.09901
R868 VDD.n897 VDD.t568 6.09901
R869 VDD.n891 VDD.t919 6.09901
R870 VDD.n885 VDD.t916 6.09901
R871 VDD.n879 VDD.t580 6.09901
R872 VDD.n873 VDD.t517 6.09901
R873 VDD.n867 VDD.t717 6.09901
R874 VDD.n861 VDD.t1244 6.09901
R875 VDD.n855 VDD.t1243 6.09901
R876 VDD.n849 VDD.t868 6.09901
R877 VDD.n843 VDD.t1487 6.09901
R878 VDD.n837 VDD.t1486 6.09901
R879 VDD.n830 VDD.t585 6.09901
R880 VDD.n824 VDD.t756 6.09901
R881 VDD.n818 VDD.t755 6.09901
R882 VDD.n812 VDD.t718 6.09901
R883 VDD.n806 VDD.t1583 6.09901
R884 VDD.n800 VDD.t626 6.09901
R885 VDD.n794 VDD.t845 6.09901
R886 VDD.n788 VDD.t518 6.09901
R887 VDD.n1434 VDD.t536 5.99122
R888 VDD.n301 VDD.t1259 5.99122
R889 VDD.n1419 VDD.t365 5.99122
R890 VDD.n306 VDD.t620 5.99122
R891 VDD.n1391 VDD.t607 5.99122
R892 VDD.n311 VDD.t423 5.99122
R893 VDD.n1674 VDD.t1311 5.99122
R894 VDD.n316 VDD.t701 5.99122
R895 VDD.n1659 VDD.t638 5.99122
R896 VDD.n321 VDD.t773 5.99122
R897 VDD.n1631 VDD.t706 5.99122
R898 VDD.n326 VDD.t1254 5.99122
R899 VDD.n1898 VDD.t803 5.99122
R900 VDD.n331 VDD.t1170 5.99122
R901 VDD.n1883 VDD.t391 5.99122
R902 VDD.n336 VDD.t539 5.99122
R903 VDD.n1855 VDD.t859 5.99122
R904 VDD.n341 VDD.t715 5.99122
R905 VDD.n1313 VDD.t1348 5.99122
R906 VDD.n346 VDD.t890 5.99122
R907 VDD.n1298 VDD.t1369 5.99122
R908 VDD.n351 VDD.t1372 5.99122
R909 VDD.n1270 VDD.t1438 5.99122
R910 VDD.n356 VDD.t934 5.99122
R911 VDD.n1101 VDD.t1145 5.99122
R912 VDD.n361 VDD.t811 5.99122
R913 VDD.n1086 VDD.t1121 5.99122
R914 VDD.n366 VDD.t1242 5.99122
R915 VDD.n1058 VDD.t584 5.99122
R916 VDD.n371 VDD.t1377 5.99122
R917 VDD.n208 VDD.t790 5.9886
R918 VDD.n218 VDD.t421 5.98839
R919 VDD.n216 VDD.t356 5.98839
R920 VDD.n214 VDD.t902 5.98839
R921 VDD.n212 VDD.t1255 5.98839
R922 VDD.n210 VDD.t1504 5.98839
R923 VDD.n713 VDD.t545 5.97675
R924 VDD.n713 VDD.t548 5.97675
R925 VDD.n1326 VDD.t1183 5.97169
R926 VDD.n1323 VDD.t390 5.97169
R927 VDD.n1338 VDD.t1503 5.97169
R928 VDD.n218 VDD.t1290 5.97169
R929 VDD.n1567 VDD.t520 5.97169
R930 VDD.n1564 VDD.t1587 5.97169
R931 VDD.n1579 VDD.t1127 5.97169
R932 VDD.n216 VDD.t1302 5.97169
R933 VDD.n1789 VDD.t1200 5.97169
R934 VDD.n1786 VDD.t778 5.97169
R935 VDD.n1801 VDD.t793 5.97169
R936 VDD.n214 VDD.t795 5.97169
R937 VDD.n1205 VDD.t1338 5.97169
R938 VDD.n1202 VDD.t1386 5.97169
R939 VDD.n1217 VDD.t383 5.97169
R940 VDD.n212 VDD.t855 5.97169
R941 VDD.n993 VDD.t1306 5.97169
R942 VDD.n990 VDD.t1263 5.97169
R943 VDD.n1005 VDD.t887 5.97169
R944 VDD.n210 VDD.t1391 5.97169
R945 VDD.n1326 VDD.t1567 5.97146
R946 VDD.n1323 VDD.t616 5.97146
R947 VDD.n1338 VDD.t352 5.97146
R948 VDD.n218 VDD.t1251 5.97146
R949 VDD.n1567 VDD.t1436 5.97146
R950 VDD.n1564 VDD.t1440 5.97146
R951 VDD.n1579 VDD.t1424 5.97146
R952 VDD.n216 VDD.t1429 5.97146
R953 VDD.n1789 VDD.t550 5.97146
R954 VDD.n1786 VDD.t538 5.97146
R955 VDD.n1801 VDD.t730 5.97146
R956 VDD.n214 VDD.t1279 5.97146
R957 VDD.n1205 VDD.t840 5.97146
R958 VDD.n1202 VDD.t634 5.97146
R959 VDD.n1217 VDD.t741 5.97146
R960 VDD.n212 VDD.t834 5.97146
R961 VDD.n993 VDD.t1426 5.97146
R962 VDD.n990 VDD.t1456 5.97146
R963 VDD.n1005 VDD.t1451 5.97146
R964 VDD.n210 VDD.t1449 5.97146
R965 VDD.n375 VDD.t107 5.96935
R966 VDD.n259 VDD.t260 5.96935
R967 VDD.n259 VDD.t205 5.96935
R968 VDD.n300 VDD.t279 5.96935
R969 VDD.n300 VDD.t209 5.96935
R970 VDD.n391 VDD.t265 5.96935
R971 VDD.n1432 VDD.t282 5.96935
R972 VDD.n260 VDD.t206 5.96935
R973 VDD.n260 VDD.t189 5.96935
R974 VDD.n303 VDD.t266 5.96935
R975 VDD.n303 VDD.t264 5.96935
R976 VDD.n227 VDD.t183 5.96935
R977 VDD.n1353 VDD.t269 5.96935
R978 VDD.n226 VDD.t278 5.96935
R979 VDD.n226 VDD.t271 5.96935
R980 VDD.n305 VDD.t274 5.96935
R981 VDD.n305 VDD.t273 5.96935
R982 VDD.n394 VDD.t307 5.96935
R983 VDD.n1417 VDD.t277 5.96935
R984 VDD.n262 VDD.t149 5.96935
R985 VDD.n262 VDD.t156 5.96935
R986 VDD.n308 VDD.t151 5.96935
R987 VDD.n308 VDD.t163 5.96935
R988 VDD.n263 VDD.t170 5.96935
R989 VDD.n672 VDD.t154 5.96935
R990 VDD.n265 VDD.t171 5.96935
R991 VDD.n265 VDD.t169 5.96935
R992 VDD.n310 VDD.t166 5.96935
R993 VDD.n310 VDD.t288 5.96935
R994 VDD.n399 VDD.t105 5.96935
R995 VDD.n1389 VDD.t204 5.96935
R996 VDD.n266 VDD.t68 5.96935
R997 VDD.n266 VDD.t1617 5.96935
R998 VDD.n313 VDD.t111 5.96935
R999 VDD.n313 VDD.t110 5.96935
R1000 VDD.n675 VDD.t114 5.96935
R1001 VDD.n378 VDD.t231 5.96935
R1002 VDD.n267 VDD.t234 5.96935
R1003 VDD.n267 VDD.t233 5.96935
R1004 VDD.n315 VDD.t238 5.96935
R1005 VDD.n315 VDD.t237 5.96935
R1006 VDD.n402 VDD.t219 5.96935
R1007 VDD.n1672 VDD.t241 5.96935
R1008 VDD.n268 VDD.t223 5.96935
R1009 VDD.n268 VDD.t222 5.96935
R1010 VDD.n318 VDD.t227 5.96935
R1011 VDD.n318 VDD.t226 5.96935
R1012 VDD.n231 VDD.t248 5.96935
R1013 VDD.n681 VDD.t230 5.96935
R1014 VDD.n230 VDD.t252 5.96935
R1015 VDD.n230 VDD.t251 5.96935
R1016 VDD.n320 VDD.t256 5.96935
R1017 VDD.n320 VDD.t255 5.96935
R1018 VDD.n405 VDD.t190 5.96935
R1019 VDD.n1657 VDD.t259 5.96935
R1020 VDD.n270 VDD.t194 5.96935
R1021 VDD.n270 VDD.t193 5.96935
R1022 VDD.n323 VDD.t198 5.96935
R1023 VDD.n323 VDD.t197 5.96935
R1024 VDD.n271 VDD.t322 5.96935
R1025 VDD.n684 VDD.t201 5.96935
R1026 VDD.n273 VDD.t326 5.96935
R1027 VDD.n273 VDD.t325 5.96935
R1028 VDD.n325 VDD.t330 5.96935
R1029 VDD.n325 VDD.t329 5.96935
R1030 VDD.n410 VDD.t202 5.96935
R1031 VDD.n1629 VDD.t262 5.96935
R1032 VDD.n274 VDD.t187 5.96935
R1033 VDD.n274 VDD.t186 5.96935
R1034 VDD.n328 VDD.t173 5.96935
R1035 VDD.n328 VDD.t180 5.96935
R1036 VDD.n687 VDD.t176 5.96935
R1037 VDD.n381 VDD.t331 5.96935
R1038 VDD.n275 VDD.t334 5.96935
R1039 VDD.n275 VDD.t333 5.96935
R1040 VDD.n330 VDD.t338 5.96935
R1041 VDD.n330 VDD.t337 5.96935
R1042 VDD.n413 VDD.t22 5.96935
R1043 VDD.n1896 VDD.t341 5.96935
R1044 VDD.n276 VDD.t26 5.96935
R1045 VDD.n276 VDD.t25 5.96935
R1046 VDD.n333 VDD.t30 5.96935
R1047 VDD.n333 VDD.t29 5.96935
R1048 VDD.n235 VDD.t10 5.96935
R1049 VDD.n1816 VDD.t33 5.96935
R1050 VDD.n234 VDD.t14 5.96935
R1051 VDD.n234 VDD.t13 5.96935
R1052 VDD.n335 VDD.t18 5.96935
R1053 VDD.n335 VDD.t17 5.96935
R1054 VDD.n416 VDD.t135 5.96935
R1055 VDD.n1881 VDD.t21 5.96935
R1056 VDD.n278 VDD.t139 5.96935
R1057 VDD.n278 VDD.t138 5.96935
R1058 VDD.n338 VDD.t143 5.96935
R1059 VDD.n338 VDD.t142 5.96935
R1060 VDD.n279 VDD.t210 5.96935
R1061 VDD.n692 VDD.t146 5.96935
R1062 VDD.n281 VDD.t214 5.96935
R1063 VDD.n281 VDD.t213 5.96935
R1064 VDD.n340 VDD.t218 5.96935
R1065 VDD.n340 VDD.t217 5.96935
R1066 VDD.n421 VDD.t181 5.96935
R1067 VDD.n1853 VDD.t178 5.96935
R1068 VDD.n282 VDD.t164 5.96935
R1069 VDD.n282 VDD.t284 5.96935
R1070 VDD.n343 VDD.t244 5.96935
R1071 VDD.n343 VDD.t243 5.96935
R1072 VDD.n1833 VDD.t247 5.96935
R1073 VDD.n384 VDD.t342 5.96935
R1074 VDD.n283 VDD.t59 5.96935
R1075 VDD.n283 VDD.t92 5.96935
R1076 VDD.n345 VDD.t157 5.96935
R1077 VDD.n345 VDD.t121 5.96935
R1078 VDD.n424 VDD.t3 5.96935
R1079 VDD.n1311 VDD.t160 5.96935
R1080 VDD.n284 VDD.t134 5.96935
R1081 VDD.n284 VDD.t6 5.96935
R1082 VDD.n348 VDD.t76 5.96935
R1083 VDD.n348 VDD.t75 5.96935
R1084 VDD.n239 VDD.t57 5.96935
R1085 VDD.n1232 VDD.t79 5.96935
R1086 VDD.n238 VDD.t70 5.96935
R1087 VDD.n238 VDD.t119 5.96935
R1088 VDD.n350 VDD.t83 5.96935
R1089 VDD.n350 VDD.t82 5.96935
R1090 VDD.n427 VDD.t80 5.96935
R1091 VDD.n1296 VDD.t148 5.96935
R1092 VDD.n286 VDD.t161 5.96935
R1093 VDD.n286 VDD.t73 5.96935
R1094 VDD.n353 VDD.t88 5.96935
R1095 VDD.n353 VDD.t117 5.96935
R1096 VDD.n287 VDD.t312 5.96935
R1097 VDD.n700 VDD.t91 5.96935
R1098 VDD.n289 VDD.t319 5.96935
R1099 VDD.n289 VDD.t309 5.96935
R1100 VDD.n355 VDD.t315 5.96935
R1101 VDD.n355 VDD.t311 5.96935
R1102 VDD.n432 VDD.t313 5.96935
R1103 VDD.n1268 VDD.t321 5.96935
R1104 VDD.n290 VDD.t7 5.96935
R1105 VDD.n290 VDD.t318 5.96935
R1106 VDD.n358 VDD.t303 5.96935
R1107 VDD.n358 VDD.t302 5.96935
R1108 VDD.n703 VDD.t306 5.96935
R1109 VDD.n387 VDD.t94 5.96935
R1110 VDD.n291 VDD.t97 5.96935
R1111 VDD.n291 VDD.t96 5.96935
R1112 VDD.n360 VDD.t101 5.96935
R1113 VDD.n360 VDD.t100 5.96935
R1114 VDD.n435 VDD.t45 5.96935
R1115 VDD.n1099 VDD.t104 5.96935
R1116 VDD.n292 VDD.t49 5.96935
R1117 VDD.n292 VDD.t48 5.96935
R1118 VDD.n363 VDD.t53 5.96935
R1119 VDD.n363 VDD.t52 5.96935
R1120 VDD.n243 VDD.t289 5.96935
R1121 VDD.n706 VDD.t56 5.96935
R1122 VDD.n242 VDD.t293 5.96935
R1123 VDD.n242 VDD.t292 5.96935
R1124 VDD.n365 VDD.t297 5.96935
R1125 VDD.n365 VDD.t296 5.96935
R1126 VDD.n438 VDD.t122 5.96935
R1127 VDD.n1084 VDD.t300 5.96935
R1128 VDD.n294 VDD.t126 5.96935
R1129 VDD.n294 VDD.t125 5.96935
R1130 VDD.n368 VDD.t130 5.96935
R1131 VDD.n368 VDD.t129 5.96935
R1132 VDD.n295 VDD.t35 5.96935
R1133 VDD.n709 VDD.t133 5.96935
R1134 VDD.n297 VDD.t39 5.96935
R1135 VDD.n297 VDD.t38 5.96935
R1136 VDD.n370 VDD.t43 5.96935
R1137 VDD.n370 VDD.t42 5.96935
R1138 VDD.n443 VDD.t115 5.96935
R1139 VDD.n1056 VDD.t286 5.96935
R1140 VDD.n298 VDD.t87 5.96935
R1141 VDD.n298 VDD.t86 5.96935
R1142 VDD.n373 VDD.t63 5.96935
R1143 VDD.n373 VDD.t62 5.96935
R1144 VDD.n1036 VDD.t66 5.96935
R1145 VDD.n621 VDD.t1431 5.96534
R1146 VDD.n560 VDD.t1479 5.96534
R1147 VDD.n218 VDD.t1248 5.96534
R1148 VDD.n1320 VDD.t588 5.96534
R1149 VDD.n1318 VDD.t564 5.96534
R1150 VDD.n1343 VDD.t592 5.96534
R1151 VDD.n1345 VDD.t1445 5.96534
R1152 VDD.n1315 VDD.t1228 5.96534
R1153 VDD.n375 VDD.t422 5.96534
R1154 VDD.n259 VDD.t593 5.96534
R1155 VDD.n259 VDD.t1477 5.96534
R1156 VDD.n300 VDD.t1309 5.96534
R1157 VDD.n1430 VDD.t582 5.96534
R1158 VDD.n1428 VDD.t1191 5.96534
R1159 VDD.n1424 VDD.t575 5.96534
R1160 VDD.n391 VDD.t1190 5.96534
R1161 VDD.n260 VDD.t1231 5.96534
R1162 VDD.n260 VDD.t522 5.96534
R1163 VDD.n303 VDD.t591 5.96534
R1164 VDD.n1354 VDD.t583 5.96534
R1165 VDD.n1351 VDD.t1364 5.96534
R1166 VDD.n1358 VDD.t576 5.96534
R1167 VDD.n227 VDD.t650 5.96534
R1168 VDD.n226 VDD.t595 5.96534
R1169 VDD.n226 VDD.t820 5.96534
R1170 VDD.n305 VDD.t586 5.96534
R1171 VDD.n1415 VDD.t1229 5.96534
R1172 VDD.n1413 VDD.t1375 5.96534
R1173 VDD.n1409 VDD.t578 5.96534
R1174 VDD.n1407 VDD.t925 5.96534
R1175 VDD.n1405 VDD.t597 5.96534
R1176 VDD.n58 VDD.t1160 5.96534
R1177 VDD.n1404 VDD.t589 5.96534
R1178 VDD.n254 VDD.t562 5.96534
R1179 VDD.n1402 VDD.t581 5.96534
R1180 VDD.n1400 VDD.t724 5.96534
R1181 VDD.n1396 VDD.t574 5.96534
R1182 VDD.n394 VDD.t802 5.96534
R1183 VDD.n262 VDD.t864 5.96534
R1184 VDD.n262 VDD.t932 5.96534
R1185 VDD.n308 VDD.t590 5.96534
R1186 VDD.n1362 VDD.t1226 5.96534
R1187 VDD.n1360 VDD.t1296 5.96534
R1188 VDD.n1366 VDD.t577 5.96534
R1189 VDD.n263 VDD.t808 5.96534
R1190 VDD.n265 VDD.t596 5.96534
R1191 VDD.n265 VDD.t527 5.96534
R1192 VDD.n310 VDD.t587 5.96534
R1193 VDD.n1387 VDD.t1230 5.96534
R1194 VDD.n1385 VDD.t1540 5.96534
R1195 VDD.n1381 VDD.t579 5.96534
R1196 VDD.n399 VDD.t942 5.96534
R1197 VDD.n266 VDD.t598 5.96534
R1198 VDD.n266 VDD.t1380 5.96534
R1199 VDD.n313 VDD.t1308 5.96534
R1200 VDD.n1370 VDD.t1327 5.96534
R1201 VDD.n1368 VDD.t1135 5.96534
R1202 VDD.n1374 VDD.t1227 5.96534
R1203 VDD.n1376 VDD.t397 5.96534
R1204 VDD.n620 VDD.t709 5.96534
R1205 VDD.n562 VDD.t1173 5.96534
R1206 VDD.n216 VDD.t872 5.96534
R1207 VDD.n1561 VDD.t1150 5.96534
R1208 VDD.n1559 VDD.t377 5.96534
R1209 VDD.n1584 VDD.t1154 5.96534
R1210 VDD.n1586 VDD.t787 5.96534
R1211 VDD.n1556 VDD.t1238 5.96534
R1212 VDD.n378 VDD.t521 5.96534
R1213 VDD.n267 VDD.t369 5.96534
R1214 VDD.n267 VDD.t512 5.96534
R1215 VDD.n315 VDD.t1343 5.96534
R1216 VDD.n1670 VDD.t1129 5.96534
R1217 VDD.n1668 VDD.t751 5.96534
R1218 VDD.n1664 VDD.t1208 5.96534
R1219 VDD.n402 VDD.t409 5.96534
R1220 VDD.n268 VDD.t1342 5.96534
R1221 VDD.n268 VDD.t534 5.96534
R1222 VDD.n318 VDD.t1153 5.96534
R1223 VDD.n1594 VDD.t1130 5.96534
R1224 VDD.n1592 VDD.t782 5.96534
R1225 VDD.n1598 VDD.t1215 5.96534
R1226 VDD.n231 VDD.t404 5.96534
R1227 VDD.n230 VDD.t371 5.96534
R1228 VDD.n230 VDD.t754 5.96534
R1229 VDD.n320 VDD.t1393 5.96534
R1230 VDD.n1655 VDD.t1239 5.96534
R1231 VDD.n1653 VDD.t826 5.96534
R1232 VDD.n1649 VDD.t1217 5.96534
R1233 VDD.n1647 VDD.t531 5.96534
R1234 VDD.n1645 VDD.t373 5.96534
R1235 VDD.n56 VDD.t414 5.96534
R1236 VDD.n1644 VDD.t1394 5.96534
R1237 VDD.n252 VDD.t510 5.96534
R1238 VDD.n1642 VDD.t1128 5.96534
R1239 VDD.n1640 VDD.t699 5.96534
R1240 VDD.n1636 VDD.t1207 5.96534
R1241 VDD.n405 VDD.t1313 5.96534
R1242 VDD.n270 VDD.t1395 5.96534
R1243 VDD.n270 VDD.t416 5.96534
R1244 VDD.n323 VDD.t1152 5.96534
R1245 VDD.n1602 VDD.t1131 5.96534
R1246 VDD.n1600 VDD.t1141 5.96534
R1247 VDD.n1606 VDD.t1216 5.96534
R1248 VDD.n271 VDD.t1241 5.96534
R1249 VDD.n273 VDD.t372 5.96534
R1250 VDD.n273 VDD.t774 5.96534
R1251 VDD.n325 VDD.t1151 5.96534
R1252 VDD.n1627 VDD.t1240 5.96534
R1253 VDD.n1625 VDD.t842 5.96534
R1254 VDD.n1621 VDD.t1218 5.96534
R1255 VDD.n410 VDD.t738 5.96534
R1256 VDD.n274 VDD.t374 5.96534
R1257 VDD.n274 VDD.t571 5.96534
R1258 VDD.n328 VDD.t1345 5.96534
R1259 VDD.n1610 VDD.t1344 5.96534
R1260 VDD.n1608 VDD.t866 5.96534
R1261 VDD.n1614 VDD.t1237 5.96534
R1262 VDD.n1616 VDD.t1415 5.96534
R1263 VDD.n618 VDD.t1185 5.96534
R1264 VDD.n564 VDD.t955 5.96534
R1265 VDD.n214 VDD.t606 5.96534
R1266 VDD.n1783 VDD.t765 5.96534
R1267 VDD.n1781 VDD.t702 5.96534
R1268 VDD.n1806 VDD.t762 5.96534
R1269 VDD.n1808 VDD.t732 5.96534
R1270 VDD.n1778 VDD.t949 5.96534
R1271 VDD.n381 VDD.t542 5.96534
R1272 VDD.n275 VDD.t1264 5.96534
R1273 VDD.n275 VDD.t734 5.96534
R1274 VDD.n330 VDD.t769 5.96534
R1275 VDD.n1894 VDD.t945 5.96534
R1276 VDD.n1892 VDD.t1524 5.96534
R1277 VDD.n1888 VDD.t1322 5.96534
R1278 VDD.n413 VDD.t399 5.96534
R1279 VDD.n276 VDD.t1303 5.96534
R1280 VDD.n276 VDD.t746 5.96534
R1281 VDD.n333 VDD.t766 5.96534
R1282 VDD.n1817 VDD.t946 5.96534
R1283 VDD.n1814 VDD.t783 5.96534
R1284 VDD.n1821 VDD.t1323 5.96534
R1285 VDD.n235 VDD.t1198 5.96534
R1286 VDD.n234 VDD.t1266 5.96534
R1287 VDD.n234 VDD.t1605 5.96534
R1288 VDD.n335 VDD.t763 5.96534
R1289 VDD.n1879 VDD.t913 5.96534
R1290 VDD.n1877 VDD.t411 5.96534
R1291 VDD.n1873 VDD.t1325 5.96534
R1292 VDD.n1871 VDD.t743 5.96534
R1293 VDD.n1869 VDD.t1252 5.96534
R1294 VDD.n54 VDD.t1530 5.96534
R1295 VDD.n1868 VDD.t761 5.96534
R1296 VDD.n250 VDD.t402 5.96534
R1297 VDD.n1866 VDD.t944 5.96534
R1298 VDD.n1864 VDD.t540 5.96534
R1299 VDD.n1860 VDD.t1321 5.96534
R1300 VDD.n416 VDD.t605 5.96534
R1301 VDD.n278 VDD.t943 5.96534
R1302 VDD.n278 VDD.t388 5.96534
R1303 VDD.n338 VDD.t767 5.96534
R1304 VDD.n1825 VDD.t947 5.96534
R1305 VDD.n1823 VDD.t1177 5.96534
R1306 VDD.n1829 VDD.t1324 5.96534
R1307 VDD.n279 VDD.t748 5.96534
R1308 VDD.n281 VDD.t1267 5.96534
R1309 VDD.n281 VDD.t646 5.96534
R1310 VDD.n340 VDD.t764 5.96534
R1311 VDD.n1851 VDD.t914 5.96534
R1312 VDD.n1849 VDD.t1614 5.96534
R1313 VDD.n1845 VDD.t1326 5.96534
R1314 VDD.n421 VDD.t395 5.96534
R1315 VDD.n282 VDD.t1253 5.96534
R1316 VDD.n282 VDD.t1137 5.96534
R1317 VDD.n343 VDD.t768 5.96534
R1318 VDD.n1834 VDD.t770 5.96534
R1319 VDD.n1831 VDD.t1257 5.96534
R1320 VDD.n1838 VDD.t948 5.96534
R1321 VDD.n1840 VDD.t367 5.96534
R1322 VDD.n616 VDD.t1550 5.96534
R1323 VDD.n566 VDD.t1558 5.96534
R1324 VDD.n212 VDD.t1387 5.96534
R1325 VDD.n1199 VDD.t920 5.96534
R1326 VDD.n1197 VDD.t823 5.96534
R1327 VDD.n1222 VDD.t1234 5.96534
R1328 VDD.n1224 VDD.t1472 5.96534
R1329 VDD.n1194 VDD.t1397 5.96534
R1330 VDD.n384 VDD.t728 5.96534
R1331 VDD.n283 VDD.t1542 5.96534
R1332 VDD.n283 VDD.t1353 5.96534
R1333 VDD.n345 VDD.t1233 5.96534
R1334 VDD.n1309 VDD.t1166 5.96534
R1335 VDD.n1307 VDD.t1332 5.96534
R1336 VDD.n1303 VDD.t1401 5.96534
R1337 VDD.n424 VDD.t923 5.96534
R1338 VDD.n284 VDD.t1219 5.96534
R1339 VDD.n284 VDD.t1359 5.96534
R1340 VDD.n348 VDD.t1223 5.96534
R1341 VDD.n1233 VDD.t1167 5.96534
R1342 VDD.n1230 VDD.t883 5.96534
R1343 VDD.n1237 VDD.t1402 5.96534
R1344 VDD.n239 VDD.t1156 5.96534
R1345 VDD.n238 VDD.t1544 5.96534
R1346 VDD.n238 VDD.t600 5.96534
R1347 VDD.n350 VDD.t1235 5.96534
R1348 VDD.n1294 VDD.t1398 5.96534
R1349 VDD.n1292 VDD.t1610 5.96534
R1350 VDD.n1288 VDD.t1224 5.96534
R1351 VDD.n1286 VDD.t723 5.96534
R1352 VDD.n1284 VDD.t1546 5.96534
R1353 VDD.n52 VDD.t817 5.96534
R1354 VDD.n1283 VDD.t921 5.96534
R1355 VDD.n248 VDD.t1412 5.96534
R1356 VDD.n1281 VDD.t1165 5.96534
R1357 VDD.n1279 VDD.t641 5.96534
R1358 VDD.n1275 VDD.t1400 5.96534
R1359 VDD.n427 VDD.t656 5.96534
R1360 VDD.n286 VDD.t1220 5.96534
R1361 VDD.n286 VDD.t643 5.96534
R1362 VDD.n353 VDD.t1222 5.96534
R1363 VDD.n1241 VDD.t1168 5.96534
R1364 VDD.n1239 VDD.t1592 5.96534
R1365 VDD.n1245 VDD.t1403 5.96534
R1366 VDD.n287 VDD.t556 5.96534
R1367 VDD.n289 VDD.t1545 5.96534
R1368 VDD.n289 VDD.t852 5.96534
R1369 VDD.n355 VDD.t1236 5.96534
R1370 VDD.n1266 VDD.t1399 5.96534
R1371 VDD.n1264 VDD.t930 5.96534
R1372 VDD.n1260 VDD.t1225 5.96534
R1373 VDD.n432 VDD.t558 5.96534
R1374 VDD.n290 VDD.t1547 5.96534
R1375 VDD.n290 VDD.t1597 5.96534
R1376 VDD.n358 VDD.t1232 5.96534
R1377 VDD.n1249 VDD.t900 5.96534
R1378 VDD.n1247 VDD.t937 5.96534
R1379 VDD.n1253 VDD.t1396 5.96534
R1380 VDD.n1255 VDD.t938 5.96534
R1381 VDD.n615 VDD.t635 5.96534
R1382 VDD.n568 VDD.t1495 5.96534
R1383 VDD.n210 VDD.t888 5.96534
R1384 VDD.n987 VDD.t1613 5.96534
R1385 VDD.n985 VDD.t911 5.96534
R1386 VDD.n1010 VDD.t683 5.96534
R1387 VDD.n1012 VDD.t1206 5.96534
R1388 VDD.n982 VDD.t385 5.96534
R1389 VDD.n387 VDD.t1282 5.96534
R1390 VDD.n291 VDD.t504 5.96534
R1391 VDD.n291 VDD.t1273 5.96534
R1392 VDD.n360 VDD.t682 5.96534
R1393 VDD.n1097 VDD.t1180 5.96534
R1394 VDD.n1095 VDD.t1277 5.96534
R1395 VDD.n1091 VDD.t1518 5.96534
R1396 VDD.n435 VDD.t567 5.96534
R1397 VDD.n292 VDD.t1318 5.96534
R1398 VDD.n292 VDD.t515 5.96534
R1399 VDD.n363 VDD.t681 5.96534
R1400 VDD.n1020 VDD.t689 5.96534
R1401 VDD.n1018 VDD.t1149 5.96534
R1402 VDD.n1024 VDD.t1507 5.96534
R1403 VDD.n243 VDD.t1147 5.96534
R1404 VDD.n242 VDD.t506 5.96534
R1405 VDD.n242 VDD.t1509 5.96534
R1406 VDD.n365 VDD.t686 5.96534
R1407 VDD.n1082 VDD.t771 5.96534
R1408 VDD.n1080 VDD.t844 5.96534
R1409 VDD.n1076 VDD.t1515 5.96534
R1410 VDD.n1074 VDD.t1125 5.96534
R1411 VDD.n1072 VDD.t1538 5.96534
R1412 VDD.n50 VDD.t918 5.96534
R1413 VDD.n1071 VDD.t759 5.96534
R1414 VDD.n246 VDD.t1123 5.96534
R1415 VDD.n1069 VDD.t624 5.96534
R1416 VDD.n1067 VDD.t1210 5.96534
R1417 VDD.n1063 VDD.t1517 5.96534
R1418 VDD.n438 VDD.t813 5.96534
R1419 VDD.n294 VDD.t1319 5.96534
R1420 VDD.n294 VDD.t1580 5.96534
R1421 VDD.n368 VDD.t752 5.96534
R1422 VDD.n1028 VDD.t690 5.96534
R1423 VDD.n1026 VDD.t1601 5.96534
R1424 VDD.n1032 VDD.t1508 5.96534
R1425 VDD.n295 VDD.t1356 5.96534
R1426 VDD.n297 VDD.t507 5.96534
R1427 VDD.n297 VDD.t1489 5.96534
R1428 VDD.n370 VDD.t760 5.96534
R1429 VDD.n1054 VDD.t688 5.96534
R1430 VDD.n1052 VDD.t1535 5.96534
R1431 VDD.n1048 VDD.t1516 5.96534
R1432 VDD.n443 VDD.t1379 5.96534
R1433 VDD.n298 VDD.t1539 5.96534
R1434 VDD.n298 VDD.t870 5.96534
R1435 VDD.n373 VDD.t529 5.96534
R1436 VDD.n1037 VDD.t1181 5.96534
R1437 VDD.n1034 VDD.t625 5.96534
R1438 VDD.n1041 VDD.t384 5.96534
R1439 VDD.n1043 VDD.t846 5.96534
R1440 VDD.n1346 VDD.t406 5.96512
R1441 VDD.n621 VDD.t1213 5.96512
R1442 VDD.n560 VDD.t1203 5.96512
R1443 VDD.n1426 VDD.t1339 5.96512
R1444 VDD.n1356 VDD.t617 5.96512
R1445 VDD.n1398 VDD.t407 5.96512
R1446 VDD.n58 VDD.t1158 5.96512
R1447 VDD.n1411 VDD.t618 5.96512
R1448 VDD.n1364 VDD.t1340 5.96512
R1449 VDD.n1383 VDD.t1341 5.96512
R1450 VDD.n1372 VDD.t1157 5.96512
R1451 VDD.n1587 VDD.t1581 5.96512
R1452 VDD.n620 VDD.t1482 5.96512
R1453 VDD.n562 VDD.t799 5.96512
R1454 VDD.n1666 VDD.t552 5.96512
R1455 VDD.n1596 VDD.t719 5.96512
R1456 VDD.n1638 VDD.t1 5.96512
R1457 VDD.n56 VDD.t804 5.96512
R1458 VDD.n1651 VDD.t847 5.96512
R1459 VDD.n1604 VDD.t553 5.96512
R1460 VDD.n1623 VDD.t554 5.96512
R1461 VDD.n1612 VDD.t809 5.96512
R1462 VDD.n1809 VDD.t901 5.96512
R1463 VDD.n618 VDD.t425 5.96512
R1464 VDD.n564 VDD.t361 5.96512
R1465 VDD.n1890 VDD.t611 5.96512
R1466 VDD.n1819 VDD.t1328 5.96512
R1467 VDD.n1862 VDD.t1314 5.96512
R1468 VDD.n54 VDD.t712 5.96512
R1469 VDD.n1875 VDD.t940 5.96512
R1470 VDD.n1827 VDD.t612 5.96512
R1471 VDD.n1847 VDD.t613 5.96512
R1472 VDD.n1836 VDD.t1162 5.96512
R1473 VDD.n1225 VDD.t692 5.96512
R1474 VDD.n616 VDD.t419 5.96512
R1475 VDD.n566 VDD.t609 5.96512
R1476 VDD.n1305 VDD.t684 5.96512
R1477 VDD.n1235 VDD.t691 5.96512
R1478 VDD.n1277 VDD.t627 5.96512
R1479 VDD.n52 VDD.t707 5.96512
R1480 VDD.n1290 VDD.t1520 5.96512
R1481 VDD.n1243 VDD.t685 5.96512
R1482 VDD.n1262 VDD.t1548 5.96512
R1483 VDD.n1251 VDD.t1307 5.96512
R1484 VDD.n1013 VDD.t343 5.96512
R1485 VDD.n615 VDD.t861 5.96512
R1486 VDD.n568 VDD.t353 5.96512
R1487 VDD.n1093 VDD.t757 5.96512
R1488 VDD.n1022 VDD.t1607 5.96512
R1489 VDD.n1065 VDD.t1514 5.96512
R1490 VDD.n50 VDD.t344 5.96512
R1491 VDD.n1078 VDD.t1221 5.96512
R1492 VDD.n1030 VDD.t758 5.96512
R1493 VDD.n1050 VDD.t623 5.96512
R1494 VDD.n1039 VDD.t396 5.96512
R1495 VDD.n208 VDD.t694 5.96478
R1496 VDD.n374 VDD.t108 5.65005
R1497 VDD.n1348 VDD.t208 5.65005
R1498 VDD.n1433 VDD.t280 5.65005
R1499 VDD.n390 VDD.t188 5.65005
R1500 VDD.n1422 VDD.t207 5.65005
R1501 VDD.n1421 VDD.t267 5.65005
R1502 VDD.n225 VDD.t184 5.65005
R1503 VDD.n1420 VDD.t272 5.65005
R1504 VDD.n1418 VDD.t275 5.65005
R1505 VDD.n393 VDD.t155 5.65005
R1506 VDD.n1394 VDD.t150 5.65005
R1507 VDD.n1393 VDD.t152 5.65005
R1508 VDD.n395 VDD.t168 5.65005
R1509 VDD.n1392 VDD.t172 5.65005
R1510 VDD.n1390 VDD.t167 5.65005
R1511 VDD.n398 VDD.t106 5.65005
R1512 VDD.n1379 VDD.t69 5.65005
R1513 VDD.n1378 VDD.t112 5.65005
R1514 VDD.n377 VDD.t232 5.65005
R1515 VDD.n1589 VDD.t235 5.65005
R1516 VDD.n1673 VDD.t239 5.65005
R1517 VDD.n401 VDD.t220 5.65005
R1518 VDD.n1662 VDD.t224 5.65005
R1519 VDD.n1661 VDD.t228 5.65005
R1520 VDD.n229 VDD.t249 5.65005
R1521 VDD.n1660 VDD.t253 5.65005
R1522 VDD.n1658 VDD.t257 5.65005
R1523 VDD.n404 VDD.t191 5.65005
R1524 VDD.n1634 VDD.t195 5.65005
R1525 VDD.n1633 VDD.t199 5.65005
R1526 VDD.n406 VDD.t323 5.65005
R1527 VDD.n1632 VDD.t327 5.65005
R1528 VDD.n1630 VDD.t261 5.65005
R1529 VDD.n409 VDD.t185 5.65005
R1530 VDD.n1619 VDD.t179 5.65005
R1531 VDD.n1618 VDD.t174 5.65005
R1532 VDD.n380 VDD.t332 5.65005
R1533 VDD.n1811 VDD.t335 5.65005
R1534 VDD.n1897 VDD.t339 5.65005
R1535 VDD.n412 VDD.t23 5.65005
R1536 VDD.n1886 VDD.t27 5.65005
R1537 VDD.n1885 VDD.t31 5.65005
R1538 VDD.n233 VDD.t11 5.65005
R1539 VDD.n1884 VDD.t15 5.65005
R1540 VDD.n1882 VDD.t19 5.65005
R1541 VDD.n415 VDD.t136 5.65005
R1542 VDD.n1858 VDD.t140 5.65005
R1543 VDD.n1857 VDD.t144 5.65005
R1544 VDD.n417 VDD.t211 5.65005
R1545 VDD.n1856 VDD.t215 5.65005
R1546 VDD.n1854 VDD.t177 5.65005
R1547 VDD.n420 VDD.t182 5.65005
R1548 VDD.n1843 VDD.t165 5.65005
R1549 VDD.n1842 VDD.t245 5.65005
R1550 VDD.n383 VDD.t93 5.65005
R1551 VDD.n1227 VDD.t60 5.65005
R1552 VDD.n1312 VDD.t158 5.65005
R1553 VDD.n423 VDD.t4 5.65005
R1554 VDD.n1301 VDD.t74 5.65005
R1555 VDD.n1300 VDD.t77 5.65005
R1556 VDD.n237 VDD.t58 5.65005
R1557 VDD.n1299 VDD.t71 5.65005
R1558 VDD.n1297 VDD.t84 5.65005
R1559 VDD.n426 VDD.t72 5.65005
R1560 VDD.n1273 VDD.t116 5.65005
R1561 VDD.n1272 VDD.t89 5.65005
R1562 VDD.n428 VDD.t308 5.65005
R1563 VDD.n1271 VDD.t310 5.65005
R1564 VDD.n1269 VDD.t316 5.65005
R1565 VDD.n431 VDD.t314 5.65005
R1566 VDD.n1258 VDD.t8 5.65005
R1567 VDD.n1257 VDD.t304 5.65005
R1568 VDD.n386 VDD.t95 5.65005
R1569 VDD.n1015 VDD.t98 5.65005
R1570 VDD.n1100 VDD.t102 5.65005
R1571 VDD.n434 VDD.t46 5.65005
R1572 VDD.n1089 VDD.t50 5.65005
R1573 VDD.n1088 VDD.t54 5.65005
R1574 VDD.n241 VDD.t290 5.65005
R1575 VDD.n1087 VDD.t294 5.65005
R1576 VDD.n1085 VDD.t298 5.65005
R1577 VDD.n437 VDD.t123 5.65005
R1578 VDD.n1061 VDD.t127 5.65005
R1579 VDD.n1060 VDD.t131 5.65005
R1580 VDD.n439 VDD.t36 5.65005
R1581 VDD.n1059 VDD.t40 5.65005
R1582 VDD.n1057 VDD.t44 5.65005
R1583 VDD.n442 VDD.t85 5.65005
R1584 VDD.n1046 VDD.t61 5.65005
R1585 VDD.n1045 VDD.t64 5.65005
R1586 VDD.t358 VDD.n2001 5.62581
R1587 VDD.t358 VDD.n1999 5.62581
R1588 VDD.t67 VDD.n1344 5.62581
R1589 VDD.t67 VDD.n1342 5.62581
R1590 VDD.t67 VDD.n1321 5.62581
R1591 VDD.t67 VDD.n1335 5.62581
R1592 VDD.t67 VDD.n1324 5.62581
R1593 VDD.t67 VDD.n1333 5.62581
R1594 VDD.t67 VDD.n1327 5.62581
R1595 VDD.t67 VDD.n1369 5.62581
R1596 VDD.n1386 VDD.t67 5.62581
R1597 VDD.t67 VDD.n1361 5.62581
R1598 VDD.n1401 VDD.t67 5.62581
R1599 VDD.n253 VDD.t67 1.79705
R1600 VDD.n1403 VDD.t67 5.62581
R1601 VDD.n57 VDD.t67 2.04048
R1602 VDD.n1414 VDD.t67 5.62581
R1603 VDD.t67 VDD.n1352 5.62581
R1604 VDD.n1429 VDD.t67 5.62581
R1605 VDD.n1466 VDD.t379 5.62581
R1606 VDD.n677 VDD.t379 3.32623
R1607 VDD.n1469 VDD.n663 0.354771
R1608 VDD.n633 VDD.t379 2.32417
R1609 VDD.n1472 VDD.t379 5.62581
R1610 VDD.n1473 VDD.n537 0.354771
R1611 VDD.n1476 VDD.t379 5.62581
R1612 VDD.n1479 VDD.t379 5.62581
R1613 VDD.n636 VDD.t379 2.32429
R1614 VDD.n1483 VDD.t379 5.62581
R1615 VDD.t0 VDD.n1585 5.62581
R1616 VDD.t0 VDD.n1583 5.62581
R1617 VDD.t0 VDD.n1562 5.62581
R1618 VDD.t0 VDD.n1576 5.62581
R1619 VDD.t0 VDD.n1565 5.62581
R1620 VDD.t0 VDD.n1574 5.62581
R1621 VDD.t0 VDD.n1568 5.62581
R1622 VDD.t0 VDD.n1609 5.62581
R1623 VDD.n1626 VDD.t0 5.62581
R1624 VDD.t0 VDD.n1601 5.62581
R1625 VDD.n1641 VDD.t0 5.62581
R1626 VDD.n251 VDD.t0 1.79705
R1627 VDD.n1643 VDD.t0 5.62581
R1628 VDD.n55 VDD.t0 2.04048
R1629 VDD.n1654 VDD.t0 5.62581
R1630 VDD.t0 VDD.n1593 5.62581
R1631 VDD.n1669 VDD.t0 5.62581
R1632 VDD.n628 VDD.t347 2.32406
R1633 VDD.n642 VDD.t347 2.32406
R1634 VDD.n519 VDD.t347 2.32425
R1635 VDD.n1689 VDD.n515 0.354412
R1636 VDD.n661 VDD.t347 2.32406
R1637 VDD.t9 VDD.n1807 5.62581
R1638 VDD.t9 VDD.n1805 5.62581
R1639 VDD.t9 VDD.n1784 5.62581
R1640 VDD.t9 VDD.n1798 5.62581
R1641 VDD.t9 VDD.n1787 5.62581
R1642 VDD.t9 VDD.n1796 5.62581
R1643 VDD.t9 VDD.n1790 5.62581
R1644 VDD.t9 VDD.n1832 5.62581
R1645 VDD.n1850 VDD.t9 5.62581
R1646 VDD.t9 VDD.n1824 5.62581
R1647 VDD.n1865 VDD.t9 5.62581
R1648 VDD.n249 VDD.t9 1.79705
R1649 VDD.n1867 VDD.t9 5.62581
R1650 VDD.n53 VDD.t9 2.04048
R1651 VDD.n1878 VDD.t9 5.62581
R1652 VDD.t9 VDD.n1815 5.62581
R1653 VDD.n1893 VDD.t9 5.62581
R1654 VDD.t345 VDD.n1984 5.62581
R1655 VDD.n27 VDD.t345 0.775326
R1656 VDD.n1991 VDD.t345 5.62581
R1657 VDD.t345 VDD.n651 2.32414
R1658 VDD.t345 VDD.n696 3.32623
R1659 VDD.n494 VDD.t345 2.32417
R1660 VDD.t345 VDD.n29 0.775343
R1661 VDD.n1995 VDD.t345 5.62581
R1662 VDD.t345 VDD.n1955 5.62581
R1663 VDD.t345 VDD.n631 2.32406
R1664 VDD.t2 VDD.n1223 5.62581
R1665 VDD.t2 VDD.n1221 5.62581
R1666 VDD.t2 VDD.n1200 5.62581
R1667 VDD.t2 VDD.n1214 5.62581
R1668 VDD.t2 VDD.n1203 5.62581
R1669 VDD.t2 VDD.n1212 5.62581
R1670 VDD.t2 VDD.n1206 5.62581
R1671 VDD.t2 VDD.n1248 5.62581
R1672 VDD.n1265 VDD.t2 5.62581
R1673 VDD.t2 VDD.n1240 5.62581
R1674 VDD.n1280 VDD.t2 5.62581
R1675 VDD.n247 VDD.t2 1.79705
R1676 VDD.n1282 VDD.t2 5.62581
R1677 VDD.n51 VDD.t2 2.04048
R1678 VDD.n1293 VDD.t2 5.62581
R1679 VDD.t2 VDD.n1231 5.62581
R1680 VDD.n1308 VDD.t2 5.62581
R1681 VDD.n183 VDD.n187 0.354547
R1682 VDD.n1118 VDD.t378 5.62581
R1683 VDD.n33 VDD.t378 0.775359
R1684 VDD.n1122 VDD.t378 5.62581
R1685 VDD.n1126 VDD.t378 5.62581
R1686 VDD.n1129 VDD.t378 5.62581
R1687 VDD.n465 VDD.t378 2.32406
R1688 VDD.t34 VDD.n1011 5.62581
R1689 VDD.t34 VDD.n1009 5.62581
R1690 VDD.t34 VDD.n988 5.62581
R1691 VDD.t34 VDD.n1002 5.62581
R1692 VDD.t34 VDD.n991 5.62581
R1693 VDD.t34 VDD.n1000 5.62581
R1694 VDD.t34 VDD.n994 5.62581
R1695 VDD.t34 VDD.n1035 5.62581
R1696 VDD.n1053 VDD.t34 5.62581
R1697 VDD.t34 VDD.n1027 5.62581
R1698 VDD.n1068 VDD.t34 5.62581
R1699 VDD.n245 VDD.t34 1.79705
R1700 VDD.n1070 VDD.t34 5.62581
R1701 VDD.n49 VDD.t34 2.04048
R1702 VDD.n1081 VDD.t34 5.62581
R1703 VDD.t34 VDD.n1019 5.62581
R1704 VDD.n1096 VDD.t34 5.62581
R1705 VDD.t368 VDD.n978 5.62581
R1706 VDD.t368 VDD.n972 5.62581
R1707 VDD.t368 VDD.n966 5.62581
R1708 VDD.t368 VDD.n960 5.62581
R1709 VDD.t368 VDD.n954 5.62581
R1710 VDD.t368 VDD.n948 5.62581
R1711 VDD.t368 VDD.n942 5.62581
R1712 VDD.t368 VDD.n936 5.62581
R1713 VDD.t368 VDD.n930 5.62581
R1714 VDD.t368 VDD.n924 5.62581
R1715 VDD.t368 VDD.n918 5.62581
R1716 VDD.t368 VDD.n910 5.62581
R1717 VDD.t368 VDD.n904 5.62581
R1718 VDD.t368 VDD.n898 5.62581
R1719 VDD.t368 VDD.n892 5.62581
R1720 VDD.t368 VDD.n886 5.62581
R1721 VDD.t368 VDD.n880 5.62581
R1722 VDD.t368 VDD.n874 5.62581
R1723 VDD.t368 VDD.n868 5.62581
R1724 VDD.t368 VDD.n862 5.62581
R1725 VDD.t368 VDD.n856 5.62581
R1726 VDD.t368 VDD.n850 5.62581
R1727 VDD.t368 VDD.n844 5.62581
R1728 VDD.t368 VDD.n838 5.62581
R1729 VDD.t368 VDD.n831 5.62581
R1730 VDD.t368 VDD.n825 5.62581
R1731 VDD.t368 VDD.n819 5.62581
R1732 VDD.t368 VDD.n813 5.62581
R1733 VDD.t368 VDD.n807 5.62581
R1734 VDD.t368 VDD.n801 5.62581
R1735 VDD.t368 VDD.n795 5.62581
R1736 VDD.t368 VDD.n789 5.62581
R1737 VDD.t368 VDD.n787 5.62581
R1738 VDD.t364 VDD.n729 5.61485
R1739 VDD.t364 VDD.n207 2.01052
R1740 VDD.n9 VDD.t495 5.60969
R1741 VDD.n38 VDD.t484 5.60969
R1742 VDD.n35 VDD.t428 5.60969
R1743 VDD.n719 VDD.t462 5.60969
R1744 VDD.n1451 VDD.t503 5.60347
R1745 VDD.n1449 VDD.t500 5.60347
R1746 VDD.n10 VDD.t498 5.60347
R1747 VDD.n256 VDD.t492 5.60347
R1748 VDD.n255 VDD.t489 5.60347
R1749 VDD.n1933 VDD.t481 5.60347
R1750 VDD.n570 VDD.t478 5.60347
R1751 VDD.n201 VDD.t448 5.60347
R1752 VDD.n202 VDD.t445 5.60347
R1753 VDD.t378 VDD.t443 5.60347
R1754 VDD.n777 VDD.t437 5.60347
R1755 VDD.n6 VDD.t431 5.60347
R1756 VDD.n781 VDD.t434 5.60347
R1757 VDD.n46 VDD.t465 5.60347
R1758 VDD.n1448 VDD.t501 5.59675
R1759 VDD.n102 VDD.t1118 5.59675
R1760 VDD.n534 VDD.t1117 5.59675
R1761 VDD.n1447 VDD.t1116 5.59675
R1762 VDD.n98 VDD.t1105 5.59675
R1763 VDD.n536 VDD.t1106 5.59675
R1764 VDD.n1446 VDD.t1109 5.59675
R1765 VDD.n93 VDD.t1108 5.59675
R1766 VDD.n221 VDD.t1110 5.59675
R1767 VDD.n1445 VDD.t1114 5.59675
R1768 VDD.n90 VDD.t1115 5.59675
R1769 VDD.n1444 VDD.t1113 5.59675
R1770 VDD.n538 VDD.t1107 5.59675
R1771 VDD.n1443 VDD.t1112 5.59675
R1772 VDD.n1442 VDD.t975 5.59675
R1773 VDD.n542 VDD.t1111 5.59675
R1774 VDD.n1441 VDD.t976 5.59675
R1775 VDD.n87 VDD.t1098 5.59675
R1776 VDD.n546 VDD.t1104 5.59675
R1777 VDD.n1440 VDD.t1103 5.59675
R1778 VDD.n84 VDD.t1099 5.59675
R1779 VDD.n219 VDD.t1102 5.59675
R1780 VDD.n1439 VDD.t1100 5.59675
R1781 VDD.n1438 VDD.t1101 5.59675
R1782 VDD.n1437 VDD.t974 5.59675
R1783 VDD.n548 VDD.t964 5.59675
R1784 VDD.n80 VDD.t1097 5.59675
R1785 VDD.n552 VDD.t1092 5.59675
R1786 VDD.n76 VDD.t1093 5.59675
R1787 VDD.n1436 VDD.t1094 5.59675
R1788 VDD.n555 VDD.t1096 5.59675
R1789 VDD.n559 VDD.t1095 5.59675
R1790 VDD.n73 VDD.t989 5.59675
R1791 VDD.n609 VDD.t490 5.59675
R1792 VDD.n1684 VDD.t1088 5.59675
R1793 VDD.n139 VDD.t1090 5.59675
R1794 VDD.n509 VDD.t1089 5.59675
R1795 VDD.n1683 VDD.t1091 5.59675
R1796 VDD.n136 VDD.t971 5.59675
R1797 VDD.n513 VDD.t1068 5.59675
R1798 VDD.n516 VDD.t1086 5.59675
R1799 VDD.n124 VDD.t1087 5.59675
R1800 VDD.n132 VDD.t959 5.59675
R1801 VDD.n1682 VDD.t1073 5.59675
R1802 VDD.n517 VDD.t1085 5.59675
R1803 VDD.n129 VDD.t980 5.59675
R1804 VDD.n126 VDD.t1072 5.59675
R1805 VDD.n121 VDD.t1080 5.59675
R1806 VDD.n119 VDD.t1082 5.59675
R1807 VDD.n1681 VDD.t1083 5.59675
R1808 VDD.n520 VDD.t1084 5.59675
R1809 VDD.n1680 VDD.t1067 5.59675
R1810 VDD.n1679 VDD.t1076 5.59675
R1811 VDD.n115 VDD.t1081 5.59675
R1812 VDD.n223 VDD.t1077 5.59675
R1813 VDD.n524 VDD.t1078 5.59675
R1814 VDD.n1678 VDD.t1069 5.59675
R1815 VDD.n1677 VDD.t1071 5.59675
R1816 VDD.n1676 VDD.t970 5.59675
R1817 VDD.n112 VDD.t1079 5.59675
R1818 VDD.n109 VDD.t1070 5.59675
R1819 VDD.n106 VDD.t1074 5.59675
R1820 VDD.n528 VDD.t1075 5.59675
R1821 VDD.n531 VDD.t984 5.59675
R1822 VDD.n533 VDD.t1066 5.59675
R1823 VDD.n1675 VDD.t1007 5.59675
R1824 VDD.n611 VDD.t479 5.59675
R1825 VDD.n159 VDD.t978 5.59675
R1826 VDD.n156 VDD.t967 5.59675
R1827 VDD.n477 VDD.t1064 5.59675
R1828 VDD.n479 VDD.t1065 5.59675
R1829 VDD.n1943 VDD.t1062 5.59675
R1830 VDD.n481 VDD.t965 5.59675
R1831 VDD.n153 VDD.t1063 5.59675
R1832 VDD.n149 VDD.t958 5.59675
R1833 VDD.n483 VDD.t966 5.59675
R1834 VDD.n485 VDD.t1061 5.59675
R1835 VDD.n1952 VDD.t977 5.59675
R1836 VDD.n1957 VDD.t1060 5.59675
R1837 VDD.n1961 VDD.t979 5.59675
R1838 VDD.n1964 VDD.t981 5.59675
R1839 VDD.n488 VDD.t1059 5.59675
R1840 VDD.n28 VDD.t1058 5.59675
R1841 VDD.n19 VDD.t986 5.59675
R1842 VDD.n491 VDD.t1057 5.59675
R1843 VDD.n146 VDD.t1055 5.59675
R1844 VDD.n495 VDD.t1056 5.59675
R1845 VDD.n1972 VDD.t991 5.59675
R1846 VDD.n143 VDD.t969 5.59675
R1847 VDD.n497 VDD.t993 5.59675
R1848 VDD.n1980 VDD.t1054 5.59675
R1849 VDD.n498 VDD.t994 5.59675
R1850 VDD.n25 VDD.t1053 5.59675
R1851 VDD.n1986 VDD.t990 5.59675
R1852 VDD.n500 VDD.t992 5.59675
R1853 VDD.n15 VDD.t1051 5.59675
R1854 VDD.n503 VDD.t1052 5.59675
R1855 VDD.n505 VDD.t1050 5.59675
R1856 VDD.n203 VDD.t446 5.59675
R1857 VDD.n454 VDD.t1006 5.59675
R1858 VDD.n451 VDD.t1049 5.59675
R1859 VDD.n1107 VDD.t1047 5.59675
R1860 VDD.n462 VDD.t1048 5.59675
R1861 VDD.n466 VDD.t1046 5.59675
R1862 VDD.n1106 VDD.t1010 5.59675
R1863 VDD.n1105 VDD.t1004 5.59675
R1864 VDD.n199 VDD.t1014 5.59675
R1865 VDD.n447 VDD.t1008 5.59675
R1866 VDD.n1104 VDD.t1031 5.59675
R1867 VDD.n444 VDD.t1045 5.59675
R1868 VDD.n1103 VDD.t1013 5.59675
R1869 VDD.n467 VDD.t1009 5.59675
R1870 VDD.n195 VDD.t1032 5.59675
R1871 VDD.n193 VDD.t1044 5.59675
R1872 VDD.n469 VDD.t1001 5.59675
R1873 VDD.n31 VDD.t1042 5.59675
R1874 VDD.n189 VDD.t1043 5.59675
R1875 VDD.n1102 VDD.t1041 5.59675
R1876 VDD.n186 VDD.t1039 5.59675
R1877 VDD.n182 VDD.t1040 5.59675
R1878 VDD.n179 VDD.t983 5.59675
R1879 VDD.n175 VDD.t1038 5.59675
R1880 VDD.n470 VDD.t963 5.59675
R1881 VDD.n172 VDD.t1037 5.59675
R1882 VDD.n474 VDD.t985 5.59675
R1883 VDD.n476 VDD.t1036 5.59675
R1884 VDD.n168 VDD.t1035 5.59675
R1885 VDD.n165 VDD.t1034 5.59675
R1886 VDD.n162 VDD.t995 5.59675
R1887 VDD.n0 VDD.t1033 5.59675
R1888 VDD.t378 VDD.t1015 5.73593
R1889 VDD.n980 VDD.t960 5.59675
R1890 VDD.n974 VDD.t998 5.59675
R1891 VDD.n968 VDD.t987 5.59675
R1892 VDD.n962 VDD.t1017 5.59675
R1893 VDD.n956 VDD.t982 5.59675
R1894 VDD.n950 VDD.t1020 5.59675
R1895 VDD.n944 VDD.t1019 5.59675
R1896 VDD.n938 VDD.t1018 5.59675
R1897 VDD.n932 VDD.t1016 5.59675
R1898 VDD.n926 VDD.t961 5.59675
R1899 VDD.n920 VDD.t1021 5.59675
R1900 VDD.n912 VDD.t1011 5.59675
R1901 VDD.n906 VDD.t1003 5.59675
R1902 VDD.n900 VDD.t999 5.59675
R1903 VDD.n894 VDD.t1022 5.59675
R1904 VDD.n888 VDD.t1002 5.59675
R1905 VDD.n882 VDD.t1000 5.59675
R1906 VDD.n876 VDD.t972 5.59675
R1907 VDD.n870 VDD.t962 5.59675
R1908 VDD.n864 VDD.t1024 5.59675
R1909 VDD.n858 VDD.t1023 5.59675
R1910 VDD.n852 VDD.t973 5.59675
R1911 VDD.n846 VDD.t1025 5.59675
R1912 VDD.n840 VDD.t997 5.59675
R1913 VDD.n832 VDD.t988 5.59675
R1914 VDD.n827 VDD.t996 5.59675
R1915 VDD.n821 VDD.t1026 5.59675
R1916 VDD.n815 VDD.t1027 5.59675
R1917 VDD.n809 VDD.t1029 5.59675
R1918 VDD.n803 VDD.t1028 5.59675
R1919 VDD.n797 VDD.t1030 5.59675
R1920 VDD.n791 VDD.t1012 5.59675
R1921 VDD.n785 VDD.t433 5.59675
R1922 VDD.n198 VDD.t494 5.59179
R1923 VDD.n12 VDD.t483 5.59179
R1924 VDD.t345 VDD.t472 5.59179
R1925 VDD.n34 VDD.t429 5.59179
R1926 VDD.n47 VDD.t463 5.59179
R1927 VDD.n23 VDD.t468 5.59179
R1928 VDD.n2038 VDD.t452 4.9462
R1929 VDD.n2010 VDD.t449 4.9462
R1930 VDD.n36 VDD.n40 4.9425
R1931 VDD.n40 VDD.n6 4.94216
R1932 VDD.n587 VDD.n10 4.94216
R1933 VDD.n72 VDD.n587 4.94216
R1934 VDD.n585 VDD.n39 4.94216
R1935 VDD.n13 VDD.n585 4.94216
R1936 VDD.n583 VDD.t345 2.4024
R1937 VDD.t378 VDD.n458 2.4024
R1938 VDD.n722 VDD.n721 4.90372
R1939 VDD.t67 VDD.n376 1.14009
R1940 VDD.t67 VDD.n1347 4.19244
R1941 VDD.t67 VDD.n561 1.75575
R1942 VDD.n561 VDD.n560 0.179918
R1943 VDD.t67 VDD.n1367 4.19244
R1944 VDD.n397 VDD.t67 1.14009
R1945 VDD.n1384 VDD.t67 4.19244
R1946 VDD.t67 VDD.n396 1.14009
R1947 VDD.t67 VDD.n1359 4.19244
R1948 VDD.n392 VDD.t67 1.14009
R1949 VDD.n1399 VDD.t67 4.19244
R1950 VDD.n1412 VDD.t67 4.19244
R1951 VDD.t67 VDD.n1350 4.19244
R1952 VDD.n389 VDD.t67 1.14009
R1953 VDD.n1427 VDD.t67 4.19244
R1954 VDD.t0 VDD.n379 1.14009
R1955 VDD.t0 VDD.n1588 4.19244
R1956 VDD.t0 VDD.n563 1.75575
R1957 VDD.n563 VDD.n562 0.179918
R1958 VDD.t0 VDD.n1607 4.19244
R1959 VDD.n408 VDD.t0 1.14009
R1960 VDD.n1624 VDD.t0 4.19244
R1961 VDD.t0 VDD.n407 1.14009
R1962 VDD.t0 VDD.n1599 4.19244
R1963 VDD.n403 VDD.t0 1.14009
R1964 VDD.n1639 VDD.t0 4.19244
R1965 VDD.n1652 VDD.t0 4.19244
R1966 VDD.t0 VDD.n1591 4.19244
R1967 VDD.n400 VDD.t0 1.14009
R1968 VDD.n1667 VDD.t0 4.19244
R1969 VDD.t9 VDD.n382 1.14009
R1970 VDD.t9 VDD.n1810 4.19244
R1971 VDD.t9 VDD.n565 1.75575
R1972 VDD.n565 VDD.n564 0.179918
R1973 VDD.t9 VDD.n1830 4.19244
R1974 VDD.n419 VDD.t9 1.14009
R1975 VDD.n1848 VDD.t9 4.19244
R1976 VDD.t9 VDD.n418 1.14009
R1977 VDD.t9 VDD.n1822 4.19244
R1978 VDD.n414 VDD.t9 1.14009
R1979 VDD.n1863 VDD.t9 4.19244
R1980 VDD.n1876 VDD.t9 4.19244
R1981 VDD.t9 VDD.n1813 4.19244
R1982 VDD.n411 VDD.t9 1.14009
R1983 VDD.n1891 VDD.t9 4.19244
R1984 VDD.t2 VDD.n385 1.14009
R1985 VDD.t2 VDD.n1226 4.19244
R1986 VDD.t2 VDD.n567 1.75575
R1987 VDD.n567 VDD.n566 0.179918
R1988 VDD.t2 VDD.n1246 4.19244
R1989 VDD.n430 VDD.t2 1.14009
R1990 VDD.n1263 VDD.t2 4.19244
R1991 VDD.t2 VDD.n429 1.14009
R1992 VDD.t2 VDD.n1238 4.19244
R1993 VDD.n425 VDD.t2 1.14009
R1994 VDD.n1278 VDD.t2 4.19244
R1995 VDD.n1291 VDD.t2 4.19244
R1996 VDD.t2 VDD.n1229 4.19244
R1997 VDD.n422 VDD.t2 1.14009
R1998 VDD.n1306 VDD.t2 4.19244
R1999 VDD.t34 VDD.n388 1.14009
R2000 VDD.t34 VDD.n1014 4.19244
R2001 VDD.t34 VDD.n569 1.75575
R2002 VDD.n569 VDD.n568 0.179918
R2003 VDD.t34 VDD.n1033 4.19244
R2004 VDD.n441 VDD.t34 1.14009
R2005 VDD.n1051 VDD.t34 4.19244
R2006 VDD.t34 VDD.n440 1.14009
R2007 VDD.t34 VDD.n1025 4.19244
R2008 VDD.n436 VDD.t34 1.14009
R2009 VDD.n1066 VDD.t34 4.19244
R2010 VDD.n1079 VDD.t34 4.19244
R2011 VDD.t34 VDD.n1017 4.19244
R2012 VDD.n433 VDD.t34 1.14009
R2013 VDD.n1094 VDD.t34 4.19244
R2014 VDD.t358 VDD.n738 4.19238
R2015 VDD.t358 VDD.n2030 4.19238
R2016 VDD.t358 VDD.n733 4.19225
R2017 VDD.t358 VDD.n2002 4.19225
R2018 VDD.n574 VDD 3.92864
R2019 VDD.n576 VDD 3.92864
R2020 VDD.n590 VDD 3.92864
R2021 VDD.n227 VDD 3.92317
R2022 VDD.n1534 VDD 3.92317
R2023 VDD.n231 VDD 3.92317
R2024 VDD.n1756 VDD 3.92317
R2025 VDD.n235 VDD 3.92317
R2026 VDD.n579 VDD 3.92317
R2027 VDD.n1920 VDD 3.92317
R2028 VDD.n239 VDD 3.92317
R2029 VDD.n1176 VDD 3.92317
R2030 VDD.n243 VDD 3.92317
R2031 VDD.n593 VDD 3.92317
R2032 VDD.n752 VDD 3.92317
R2033 VDD.n208 VDD 3.92317
R2034 VDD.n264 VDD 3.92023
R2035 VDD.n272 VDD 3.92023
R2036 VDD.n280 VDD 3.92023
R2037 VDD.n288 VDD 3.92023
R2038 VDD.n296 VDD 3.92023
R2039 VDD.n222 VDD 3.90557
R2040 VDD.n125 VDD 3.90557
R2041 VDD.n151 VDD 3.90557
R2042 VDD.n200 VDD 3.90557
R2043 VDD.n835 VDD 3.90557
R2044 VDD.n220 VDD 3.89823
R2045 VDD.n224 VDD 3.89823
R2046 VDD.n1975 VDD 3.89823
R2047 VDD.n184 VDD 3.89823
R2048 VDD.n915 VDD 3.89823
R2049 VDD.n217 VDD.n1320 0.393995
R2050 VDD.n1402 VDD.n253 0.341
R2051 VDD.n1404 VDD.n57 0.360407
R2052 VDD.n215 VDD.n1561 0.393995
R2053 VDD.n1642 VDD.n251 0.341
R2054 VDD.n1644 VDD.n55 0.360407
R2055 VDD.n213 VDD.n1783 0.393995
R2056 VDD.n1866 VDD.n249 0.341
R2057 VDD.n1868 VDD.n53 0.360407
R2058 VDD.n211 VDD.n1199 0.393995
R2059 VDD.n1281 VDD.n247 0.341
R2060 VDD.n1283 VDD.n51 0.360407
R2061 VDD.n209 VDD.n987 0.393995
R2062 VDD.n1069 VDD.n245 0.341
R2063 VDD.n1071 VDD.n49 0.360407
R2064 VDD.t368 VDD.n916 3.32633
R2065 VDD.t368 VDD.n836 3.32615
R2066 VDD.t364 VDD.n723 3.30706
R2067 VDD.t364 VDD.n725 3.30688
R2068 VDD.t364 VDD.n732 3.30688
R2069 VDD.n584 VDD.n619 0.0192234
R2070 VDD.n582 VDD.n617 0.0192234
R2071 VDD.n581 VDD.n614 0.0192234
R2072 VDD.t364 VDD.n714 2.77509
R2073 VDD.t67 VDD.n1317 2.74446
R2074 VDD.t67 VDD.n1319 2.74446
R2075 VDD.t67 VDD.n1375 2.74446
R2076 VDD.n1406 VDD.t67 2.74446
R2077 VDD.n1408 VDD.t67 2.74446
R2078 VDD.t0 VDD.n1558 2.74446
R2079 VDD.t0 VDD.n1560 2.74446
R2080 VDD.t0 VDD.n1615 2.74446
R2081 VDD.n1646 VDD.t0 2.74446
R2082 VDD.n1648 VDD.t0 2.74446
R2083 VDD.t9 VDD.n1780 2.74446
R2084 VDD.t9 VDD.n1782 2.74446
R2085 VDD.t9 VDD.n1839 2.74446
R2086 VDD.n1870 VDD.t9 2.74446
R2087 VDD.n1872 VDD.t9 2.74446
R2088 VDD.t2 VDD.n1196 2.74446
R2089 VDD.t2 VDD.n1198 2.74446
R2090 VDD.t2 VDD.n1254 2.74446
R2091 VDD.n1285 VDD.t2 2.74446
R2092 VDD.n1287 VDD.t2 2.74446
R2093 VDD.t34 VDD.n984 2.74446
R2094 VDD.t34 VDD.n986 2.74446
R2095 VDD.t34 VDD.n1042 2.74446
R2096 VDD.n1073 VDD.t34 2.74446
R2097 VDD.n1075 VDD.t34 2.74446
R2098 VDD.t358 VDD.n739 2.74414
R2099 VDD.n36 VDD.n981 0.368386
R2100 VDD.n1493 VDD.t379 2.74397
R2101 VDD.n1715 VDD.t347 2.74397
R2102 VDD.t345 VDD.n1900 2.74397
R2103 VDD.n1135 VDD.t378 2.74397
R2104 VDD.n6 VDD.n979 0.379745
R2105 VDD.n7 VDD.n72 0.0957236
R2106 VDD.n14 VDD.t347 0.446551
R2107 VDD.t368 VDD.n772 2.74386
R2108 VDD.t368 VDD.n5 0.661855
R2109 VDD.t364 VDD 1.47683
R2110 VDD.n2008 VDD.t457 2.69937
R2111 VDD.n2006 VDD.t451 2.69937
R2112 VDD.n2032 VDD.t459 2.69937
R2113 VDD.n2040 VDD.t454 2.69937
R2114 VDD.n2036 VDD.t460 2.6992
R2115 VDD.n2034 VDD.t453 2.6992
R2116 VDD.n2004 VDD.t456 2.6992
R2117 VDD.n2012 VDD.t450 2.6992
R2118 VDD.n2017 VDD.t662 2.6992
R2119 VDD.n2016 VDD.t663 2.6992
R2120 VDD.n2022 VDD.t666 2.6992
R2121 VDD.n2021 VDD.t664 2.6992
R2122 VDD.n2027 VDD.t668 2.6992
R2123 VDD.n2026 VDD.t674 2.6992
R2124 VDD.t368 VDD.n958 2.32446
R2125 VDD.t358 VDD.n2014 2.32439
R2126 VDD.t368 VDD.n946 2.32439
R2127 VDD.t368 VDD.n922 2.32439
R2128 VDD.t368 VDD.n890 2.32439
R2129 VDD.t368 VDD.n878 2.32439
R2130 VDD.t368 VDD.n811 2.32439
R2131 VDD.t368 VDD.n799 2.32439
R2132 VDD.t368 VDD.n964 2.32432
R2133 VDD.t368 VDD.n854 2.32432
R2134 VDD.t368 VDD.n908 2.32425
R2135 VDD.t368 VDD.n896 2.32425
R2136 VDD.t368 VDD.n872 2.32425
R2137 VDD.t368 VDD.n793 2.32425
R2138 VDD.t368 VDD.n952 2.32417
R2139 VDD.t368 VDD.n884 2.32417
R2140 VDD.t368 VDD.n860 2.32417
R2141 VDD.t368 VDD.n829 2.32417
R2142 VDD.t358 VDD.n734 2.32417
R2143 VDD.t358 VDD.n737 2.32417
R2144 VDD.t358 VDD.n2024 2.32417
R2145 VDD.t368 VDD.n976 2.32417
R2146 VDD.t368 VDD.n934 2.32417
R2147 VDD.t368 VDD.n928 2.32417
R2148 VDD.t368 VDD.n866 2.32417
R2149 VDD.t368 VDD.n848 2.32417
R2150 VDD.t368 VDD.n805 2.32414
R2151 VDD.t368 VDD.n823 2.32407
R2152 VDD.t358 VDD.n735 2.32406
R2153 VDD.t358 VDD.n2029 2.32406
R2154 VDD.t368 VDD.n970 2.32406
R2155 VDD.t368 VDD.n940 2.32406
R2156 VDD.t368 VDD.n902 2.32406
R2157 VDD.t368 VDD.n842 2.32406
R2158 VDD.t368 VDD.n817 2.32406
R2159 VDD.t34 VDD.n1044 2.06484
R2160 VDD.t2 VDD.n1256 2.06467
R2161 VDD.t9 VDD.n1841 2.06463
R2162 VDD.t67 VDD.n1377 2.06391
R2163 VDD.t0 VDD.n1617 2.06333
R2164 VDD.n459 VDD 2.04405
R2165 VDD.n587 VDD 2.04404
R2166 VDD.n587 VDD 2.04404
R2167 VDD.n585 VDD 2.04404
R2168 VDD.n585 VDD 2.04404
R2169 VDD.n583 VDD 2.04404
R2170 VDD.n583 VDD 2.04404
R2171 VDD.n458 VDD 2.04404
R2172 VDD.n458 VDD 2.04404
R2173 VDD.n457 VDD 2.04399
R2174 VDD.n40 VDD 2.04374
R2175 VDD.n40 VDD 2.04374
R2176 VDD.t358 VDD.n736 2.0061
R2177 VDD.n1535 VDD.t379 2.0061
R2178 VDD.n1757 VDD.t347 2.0061
R2179 VDD.t345 VDD.n1921 2.0061
R2180 VDD.n1177 VDD.t378 2.0061
R2181 VDD.t368 VDD.n751 2.00599
R2182 VDD.t358 VDD.n2019 2.00592
R2183 VDD.t358 VDD.n2042 1.75882
R2184 VDD.n1489 VDD.t379 1.56886
R2185 VDD.t345 VDD.n1930 1.56886
R2186 VDD.t368 VDD.n774 1.56865
R2187 VDD.t360 VDD.n717 1.5566
R2188 VDD.t368 VDD.n760 1.55402
R2189 VDD.t368 VDD.n763 1.55388
R2190 VDD.t368 VDD.n771 1.55376
R2191 VDD.n1497 VDD.t379 1.55361
R2192 VDD.n1499 VDD.t379 1.55361
R2193 VDD.n1501 VDD.t379 1.55361
R2194 VDD.n1503 VDD.t379 1.55361
R2195 VDD.n1505 VDD.t379 1.55361
R2196 VDD.n573 VDD.t379 1.55361
R2197 VDD.n1507 VDD.t379 1.55361
R2198 VDD.n1509 VDD.t379 1.55361
R2199 VDD.n1511 VDD.t379 1.55361
R2200 VDD.n1513 VDD.t379 1.55361
R2201 VDD.n1515 VDD.t379 1.55361
R2202 VDD.n1517 VDD.t379 1.55361
R2203 VDD.n1519 VDD.t379 1.55361
R2204 VDD.n1521 VDD.t379 1.55361
R2205 VDD.n1523 VDD.t379 1.55361
R2206 VDD.n1525 VDD.t379 1.55361
R2207 VDD.n1527 VDD.t379 1.55361
R2208 VDD.n1529 VDD.t379 1.55361
R2209 VDD.n1531 VDD.t379 1.55361
R2210 VDD.n1537 VDD.t379 1.55361
R2211 VDD.n1539 VDD.t379 1.55361
R2212 VDD.n1541 VDD.t379 1.55361
R2213 VDD.n1543 VDD.t379 1.55361
R2214 VDD.n1545 VDD.t379 1.55361
R2215 VDD.n1547 VDD.t379 1.55361
R2216 VDD.n1549 VDD.t379 1.55361
R2217 VDD.n1551 VDD.t379 1.55361
R2218 VDD.n1553 VDD.t379 1.55361
R2219 VDD.n1555 VDD.t379 1.55361
R2220 VDD.n1719 VDD.t347 1.55361
R2221 VDD.n1721 VDD.t347 1.55361
R2222 VDD.n1723 VDD.t347 1.55361
R2223 VDD.n1725 VDD.t347 1.55361
R2224 VDD.n1727 VDD.t347 1.55361
R2225 VDD.n575 VDD.t347 1.55361
R2226 VDD.n1729 VDD.t347 1.55361
R2227 VDD.n1731 VDD.t347 1.55361
R2228 VDD.n1733 VDD.t347 1.55361
R2229 VDD.n1735 VDD.t347 1.55361
R2230 VDD.n1737 VDD.t347 1.55361
R2231 VDD.n1739 VDD.t347 1.55361
R2232 VDD.n1741 VDD.t347 1.55361
R2233 VDD.n1743 VDD.t347 1.55361
R2234 VDD.n1745 VDD.t347 1.55361
R2235 VDD.n1747 VDD.t347 1.55361
R2236 VDD.n1749 VDD.t347 1.55361
R2237 VDD.n1751 VDD.t347 1.55361
R2238 VDD.n1753 VDD.t347 1.55361
R2239 VDD.n1759 VDD.t347 1.55361
R2240 VDD.n1761 VDD.t347 1.55361
R2241 VDD.n1763 VDD.t347 1.55361
R2242 VDD.n1765 VDD.t347 1.55361
R2243 VDD.n1767 VDD.t347 1.55361
R2244 VDD.n1769 VDD.t347 1.55361
R2245 VDD.n1771 VDD.t347 1.55361
R2246 VDD.n1773 VDD.t347 1.55361
R2247 VDD.n1775 VDD.t347 1.55361
R2248 VDD.n1777 VDD.t347 1.55361
R2249 VDD.t345 VDD.n1902 1.55361
R2250 VDD.t345 VDD.n1903 1.55361
R2251 VDD.t345 VDD.n1904 1.55361
R2252 VDD.t345 VDD.n1905 1.55361
R2253 VDD.t345 VDD.n1906 1.55361
R2254 VDD.t345 VDD.n577 1.55361
R2255 VDD.t345 VDD.n578 1.55361
R2256 VDD.t345 VDD.n1907 1.55361
R2257 VDD.t345 VDD.n1908 1.55361
R2258 VDD.t345 VDD.n1909 1.55361
R2259 VDD.t345 VDD.n1910 1.55361
R2260 VDD.t345 VDD.n1911 1.55361
R2261 VDD.t345 VDD.n1912 1.55361
R2262 VDD.t345 VDD.n1913 1.55361
R2263 VDD.t345 VDD.n1914 1.55361
R2264 VDD.t345 VDD.n1915 1.55361
R2265 VDD.t345 VDD.n1916 1.55361
R2266 VDD.t345 VDD.n1917 1.55361
R2267 VDD.t345 VDD.n1918 1.55361
R2268 VDD.t345 VDD.n1922 1.55361
R2269 VDD.t345 VDD.n1923 1.55361
R2270 VDD.t345 VDD.n1924 1.55361
R2271 VDD.t345 VDD.n1925 1.55361
R2272 VDD.t345 VDD.n1926 1.55361
R2273 VDD.t345 VDD.n1927 1.55361
R2274 VDD.t345 VDD.n1928 1.55361
R2275 VDD.t345 VDD.n1929 1.55361
R2276 VDD.t345 VDD.n3 0.431013
R2277 VDD.n1139 VDD.t378 1.55361
R2278 VDD.n1141 VDD.t378 1.55361
R2279 VDD.n1143 VDD.t378 1.55361
R2280 VDD.n1145 VDD.t378 1.55361
R2281 VDD.n1147 VDD.t378 1.55361
R2282 VDD.n589 VDD.t378 1.55361
R2283 VDD.n1149 VDD.t378 1.55361
R2284 VDD.n1151 VDD.t378 1.55361
R2285 VDD.n1153 VDD.t378 1.55361
R2286 VDD.n1155 VDD.t378 1.55361
R2287 VDD.n1157 VDD.t378 1.55361
R2288 VDD.n1159 VDD.t378 1.55361
R2289 VDD.n1161 VDD.t378 1.55361
R2290 VDD.n1163 VDD.t378 1.55361
R2291 VDD.n1165 VDD.t378 1.55361
R2292 VDD.n1167 VDD.t378 1.55361
R2293 VDD.n1169 VDD.t378 1.55361
R2294 VDD.n1171 VDD.t378 1.55361
R2295 VDD.n1173 VDD.t378 1.55361
R2296 VDD.n1179 VDD.t378 1.55361
R2297 VDD.n1181 VDD.t378 1.55361
R2298 VDD.n1183 VDD.t378 1.55361
R2299 VDD.n1185 VDD.t378 1.55361
R2300 VDD.n1187 VDD.t378 1.55361
R2301 VDD.n1189 VDD.t378 1.55361
R2302 VDD.n1191 VDD.t378 1.55361
R2303 VDD.n1193 VDD.t378 1.55361
R2304 VDD.t368 VDD.n741 1.55361
R2305 VDD.t368 VDD.n744 1.55361
R2306 VDD.t368 VDD.n757 1.55361
R2307 VDD.t368 VDD.n758 1.55361
R2308 VDD.t368 VDD.n769 1.55361
R2309 VDD.t368 VDD.n742 1.55358
R2310 VDD.t368 VDD.n759 1.55357
R2311 VDD.t368 VDD.n764 1.55354
R2312 VDD.t368 VDD.n755 1.55354
R2313 VDD.t368 VDD.n761 1.55352
R2314 VDD.t368 VDD.n591 1.5535
R2315 VDD.t368 VDD.n770 1.5535
R2316 VDD.t368 VDD.n754 1.55347
R2317 VDD.t368 VDD.n592 1.55347
R2318 VDD.t368 VDD.n767 1.55347
R2319 VDD.t368 VDD.n745 1.55346
R2320 VDD.t368 VDD.n749 1.55342
R2321 VDD.t368 VDD.n746 1.55341
R2322 VDD.t368 VDD.n750 1.5534
R2323 VDD.t368 VDD.n743 1.55339
R2324 VDD.t368 VDD.n747 1.55334
R2325 VDD.t368 VDD.n762 1.55334
R2326 VDD.t368 VDD.n766 1.55332
R2327 VDD.t368 VDD.n765 1.55329
R2328 VDD.t368 VDD.n748 1.55327
R2329 VDD.t368 VDD.n756 1.55327
R2330 VDD.t368 VDD.n768 1.55327
R2331 VDD.t364 VDD.n716 1.20461
R2332 VDD.n2017 VDD.n2016 1.11007
R2333 VDD.n2022 VDD.n2021 1.11007
R2334 VDD.n2027 VDD.n2026 1.11007
R2335 VDD.t358 VDD.n740 1.01993
R2336 VDD.n731 VDD.n653 0.975304
R2337 VDD.n653 VDD.n208 0.817678
R2338 VDD.n457 VDD.n583 0.72826
R2339 VDD.n722 VDD.n716 0.671512
R2340 VDD.n716 VDD.n715 0.6645
R2341 VDD.n1998 VDD.n740 0.632886
R2342 VDD.n1314 VDD.n740 0.618267
R2343 VDD.n2006 VDD.n2005 0.570444
R2344 VDD.n2041 VDD.n2040 0.570444
R2345 VDD.n2034 VDD.n2033 0.570274
R2346 VDD.n2013 VDD.n2012 0.570274
R2347 VDD.n2018 VDD.n2017 0.570274
R2348 VDD.n2023 VDD.n2022 0.570274
R2349 VDD.n2028 VDD.n2027 0.570274
R2350 VDD.n2036 VDD.n2035 0.569912
R2351 VDD.n2004 VDD.n2003 0.569912
R2352 VDD.n2016 VDD.n2015 0.569912
R2353 VDD.n2021 VDD.n2020 0.569912
R2354 VDD.n2026 VDD.n2025 0.569912
R2355 VDD.n2008 VDD.n2007 0.569733
R2356 VDD.n2032 VDD.n2031 0.569733
R2357 VDD.n72 VDD.n198 0.508375
R2358 VDD.n13 VDD.n12 0.508375
R2359 VDD.n36 VDD.n34 0.508375
R2360 VDD.n48 VDD.n47 0.508375
R2361 VDD.t364 VDD.n653 0.49685
R2362 VDD.n1492 VDD.n1448 0.495739
R2363 VDD.n1494 VDD.n102 0.495739
R2364 VDD.n1496 VDD.n534 0.495739
R2365 VDD.n1498 VDD.n1447 0.495739
R2366 VDD.n1500 VDD.n98 0.495739
R2367 VDD.n1502 VDD.n536 0.495739
R2368 VDD.n1504 VDD.n1446 0.495739
R2369 VDD.n1506 VDD.n93 0.495739
R2370 VDD.n574 VDD.n221 0.495739
R2371 VDD.n1508 VDD.n1445 0.495739
R2372 VDD.n1510 VDD.n90 0.495739
R2373 VDD.n1512 VDD.n1444 0.495739
R2374 VDD.n1514 VDD.n538 0.495739
R2375 VDD.n1516 VDD.n1443 0.495739
R2376 VDD.n1518 VDD.n1442 0.495739
R2377 VDD.n1520 VDD.n542 0.495739
R2378 VDD.n1522 VDD.n1441 0.495739
R2379 VDD.n1524 VDD.n87 0.495739
R2380 VDD.n1526 VDD.n546 0.495739
R2381 VDD.n1528 VDD.n1440 0.495739
R2382 VDD.n1530 VDD.n84 0.495739
R2383 VDD.n1532 VDD.n219 0.495739
R2384 VDD.n1536 VDD.n1439 0.495739
R2385 VDD.n1538 VDD.n1438 0.495739
R2386 VDD.n1540 VDD.n1437 0.495739
R2387 VDD.n1542 VDD.n548 0.495739
R2388 VDD.n1544 VDD.n80 0.495739
R2389 VDD.n1546 VDD.n552 0.495739
R2390 VDD.n1548 VDD.n76 0.495739
R2391 VDD.n1550 VDD.n1436 0.495739
R2392 VDD.n1552 VDD.n555 0.495739
R2393 VDD.n1554 VDD.n559 0.495739
R2394 VDD.n8 VDD.n73 0.495739
R2395 VDD.n1714 VDD.n609 0.495739
R2396 VDD.n1716 VDD.n1684 0.495739
R2397 VDD.n1718 VDD.n139 0.495739
R2398 VDD.n1720 VDD.n509 0.495739
R2399 VDD.n1722 VDD.n1683 0.495739
R2400 VDD.n1724 VDD.n136 0.495739
R2401 VDD.n1726 VDD.n513 0.495739
R2402 VDD.n1728 VDD.n516 0.495739
R2403 VDD.n576 VDD.n124 0.495739
R2404 VDD.n1730 VDD.n132 0.495739
R2405 VDD.n1732 VDD.n1682 0.495739
R2406 VDD.n1734 VDD.n517 0.495739
R2407 VDD.n1736 VDD.n129 0.495739
R2408 VDD.n1738 VDD.n126 0.495739
R2409 VDD.n1740 VDD.n121 0.495739
R2410 VDD.n1742 VDD.n119 0.495739
R2411 VDD.n1744 VDD.n1681 0.495739
R2412 VDD.n1746 VDD.n520 0.495739
R2413 VDD.n1748 VDD.n1680 0.495739
R2414 VDD.n1750 VDD.n1679 0.495739
R2415 VDD.n1752 VDD.n115 0.495739
R2416 VDD.n1754 VDD.n223 0.495739
R2417 VDD.n1758 VDD.n524 0.495739
R2418 VDD.n1760 VDD.n1678 0.495739
R2419 VDD.n1762 VDD.n1677 0.495739
R2420 VDD.n1764 VDD.n1676 0.495739
R2421 VDD.n1766 VDD.n112 0.495739
R2422 VDD.n1768 VDD.n109 0.495739
R2423 VDD.n1770 VDD.n106 0.495739
R2424 VDD.n1772 VDD.n528 0.495739
R2425 VDD.n1774 VDD.n531 0.495739
R2426 VDD.n1776 VDD.n533 0.495739
R2427 VDD.n37 VDD.n1675 0.495739
R2428 VDD.n611 VDD.n1936 0.495739
R2429 VDD.n159 VDD.n1937 0.495739
R2430 VDD.n156 VDD.n1939 0.495739
R2431 VDD.n477 VDD.n1940 0.495739
R2432 VDD.n479 VDD.n1941 0.495739
R2433 VDD.n1943 VDD.n1942 0.495739
R2434 VDD.n481 VDD.n1945 0.495739
R2435 VDD.n153 VDD.n1947 0.495739
R2436 VDD.n149 VDD.n579 0.495739
R2437 VDD.n483 VDD.n1948 0.495739
R2438 VDD.n485 VDD.n1949 0.495739
R2439 VDD.n1952 VDD.n1951 0.495739
R2440 VDD.n1957 VDD.n1956 0.495739
R2441 VDD.n1961 VDD.n1960 0.495739
R2442 VDD.n1964 VDD.n1963 0.495739
R2443 VDD.n488 VDD.n1965 0.495739
R2444 VDD.n28 VDD.n1966 0.495739
R2445 VDD.n19 VDD.n1967 0.495739
R2446 VDD.n491 VDD.n1968 0.495739
R2447 VDD.n146 VDD.n1969 0.495739
R2448 VDD.n495 VDD.n1970 0.495739
R2449 VDD.n1972 VDD.n1971 0.495739
R2450 VDD.n143 VDD.n1977 0.495739
R2451 VDD.n497 VDD.n1978 0.495739
R2452 VDD.n1980 VDD.n1979 0.495739
R2453 VDD.n498 VDD.n1981 0.495739
R2454 VDD.n25 VDD.n1982 0.495739
R2455 VDD.n1986 VDD.n1985 0.495739
R2456 VDD.n500 VDD.n1987 0.495739
R2457 VDD.n15 VDD.n1988 0.495739
R2458 VDD.n503 VDD.n1989 0.495739
R2459 VDD.n505 VDD.n3 0.625439
R2460 VDD.t968 VDD.t345 5.86322
R2461 VDD.n1134 VDD.n203 0.495739
R2462 VDD.n1136 VDD.n454 0.495739
R2463 VDD.n1138 VDD.n451 0.495739
R2464 VDD.n1140 VDD.n1107 0.495739
R2465 VDD.n1142 VDD.n462 0.495739
R2466 VDD.n1144 VDD.n466 0.495739
R2467 VDD.n1146 VDD.n1106 0.495739
R2468 VDD.n1148 VDD.n1105 0.495739
R2469 VDD.n590 VDD.n199 0.495739
R2470 VDD.n1150 VDD.n447 0.495739
R2471 VDD.n1152 VDD.n1104 0.495739
R2472 VDD.n1154 VDD.n444 0.495739
R2473 VDD.n1156 VDD.n1103 0.495739
R2474 VDD.n1158 VDD.n467 0.495739
R2475 VDD.n1160 VDD.n195 0.495739
R2476 VDD.n1162 VDD.n193 0.495739
R2477 VDD.n1164 VDD.n469 0.495739
R2478 VDD.n1166 VDD.n31 0.495739
R2479 VDD.n1168 VDD.n189 0.495739
R2480 VDD.n1170 VDD.n1102 0.495739
R2481 VDD.n1172 VDD.n186 0.495739
R2482 VDD.n1174 VDD.n182 0.495739
R2483 VDD.n1178 VDD.n179 0.495739
R2484 VDD.n1180 VDD.n175 0.495739
R2485 VDD.n1182 VDD.n470 0.495739
R2486 VDD.n1184 VDD.n172 0.495739
R2487 VDD.n1186 VDD.n474 0.495739
R2488 VDD.n1188 VDD.n476 0.495739
R2489 VDD.n1190 VDD.n168 0.495739
R2490 VDD.n1192 VDD.n165 0.495739
R2491 VDD.n1 VDD.n162 0.495739
R2492 VDD.n2 VDD.n0 0.648187
R2493 VDD.n980 VDD.n979 0.495398
R2494 VDD.n974 VDD.n973 0.495398
R2495 VDD.n968 VDD.n967 0.495398
R2496 VDD.n962 VDD.n961 0.495398
R2497 VDD.n956 VDD.n955 0.495398
R2498 VDD.n950 VDD.n949 0.495398
R2499 VDD.n944 VDD.n943 0.495398
R2500 VDD.n938 VDD.n937 0.495398
R2501 VDD.n932 VDD.n931 0.495398
R2502 VDD.n926 VDD.n925 0.495398
R2503 VDD.n920 VDD.n919 0.495398
R2504 VDD.n912 VDD.n911 0.495398
R2505 VDD.n906 VDD.n905 0.495398
R2506 VDD.n900 VDD.n899 0.495398
R2507 VDD.n894 VDD.n893 0.495398
R2508 VDD.n888 VDD.n887 0.495398
R2509 VDD.n882 VDD.n881 0.495398
R2510 VDD.n876 VDD.n875 0.495398
R2511 VDD.n870 VDD.n869 0.495398
R2512 VDD.n864 VDD.n863 0.495398
R2513 VDD.n858 VDD.n857 0.495398
R2514 VDD.n852 VDD.n851 0.495398
R2515 VDD.n846 VDD.n845 0.495398
R2516 VDD.n840 VDD.n839 0.495398
R2517 VDD.n832 VDD.n593 0.495398
R2518 VDD.n827 VDD.n826 0.495398
R2519 VDD.n821 VDD.n820 0.495398
R2520 VDD.n815 VDD.n814 0.495398
R2521 VDD.n809 VDD.n808 0.495398
R2522 VDD.n803 VDD.n802 0.495398
R2523 VDD.n797 VDD.n796 0.495398
R2524 VDD.n791 VDD.n790 0.495398
R2525 VDD.n785 VDD.n784 0.495398
R2526 VDD.n23 VDD.n22 0.527554
R2527 VDD.n2009 VDD.n2008 0.492175
R2528 VDD.n2039 VDD.n2032 0.492175
R2529 VDD.n2037 VDD.n2036 0.492005
R2530 VDD.n2011 VDD.n2004 0.492005
R2531 VDD.n2037 VDD.n2034 0.491643
R2532 VDD.n2012 VDD.n2011 0.491643
R2533 VDD.n2009 VDD.n2006 0.491464
R2534 VDD.n2040 VDD.n2039 0.491464
R2535 VDD.n981 VDD.n980 0.478641
R2536 VDD.n975 VDD.n974 0.478641
R2537 VDD.n969 VDD.n968 0.478641
R2538 VDD.n963 VDD.n962 0.478641
R2539 VDD.n957 VDD.n956 0.478641
R2540 VDD.n951 VDD.n950 0.478641
R2541 VDD.n945 VDD.n944 0.478641
R2542 VDD.n939 VDD.n938 0.478641
R2543 VDD.n933 VDD.n932 0.478641
R2544 VDD.n927 VDD.n926 0.478641
R2545 VDD.n921 VDD.n920 0.478641
R2546 VDD.n913 VDD.n912 0.478641
R2547 VDD.n907 VDD.n906 0.478641
R2548 VDD.n901 VDD.n900 0.478641
R2549 VDD.n895 VDD.n894 0.478641
R2550 VDD.n889 VDD.n888 0.478641
R2551 VDD.n883 VDD.n882 0.478641
R2552 VDD.n877 VDD.n876 0.478641
R2553 VDD.n871 VDD.n870 0.478641
R2554 VDD.n865 VDD.n864 0.478641
R2555 VDD.n859 VDD.n858 0.478641
R2556 VDD.n853 VDD.n852 0.478641
R2557 VDD.n847 VDD.n846 0.478641
R2558 VDD.n841 VDD.n840 0.478641
R2559 VDD.n833 VDD.n832 0.478641
R2560 VDD.n828 VDD.n827 0.478641
R2561 VDD.n822 VDD.n821 0.478641
R2562 VDD.n816 VDD.n815 0.478641
R2563 VDD.n810 VDD.n809 0.478641
R2564 VDD.n804 VDD.n803 0.478641
R2565 VDD.n798 VDD.n797 0.478641
R2566 VDD.n792 VDD.n791 0.478641
R2567 VDD.n786 VDD.n785 0.478641
R2568 VDD.n23 VDD.t1005 5.75335
R2569 VDD.n1484 VDD.n1448 0.478299
R2570 VDD.n103 VDD.n102 0.478299
R2571 VDD.n101 VDD.n534 0.478299
R2572 VDD.n1453 VDD.n1447 0.478299
R2573 VDD.n99 VDD.n98 0.478299
R2574 VDD.n97 VDD.n536 0.478299
R2575 VDD.n1478 VDD.n1446 0.478299
R2576 VDD.n95 VDD.n93 0.478299
R2577 VDD.n94 VDD.n221 0.478299
R2578 VDD.n1475 VDD.n1445 0.478299
R2579 VDD.n91 VDD.n90 0.478299
R2580 VDD.n1455 VDD.n1444 0.478299
R2581 VDD.n539 VDD.n538 0.478299
R2582 VDD.n1471 VDD.n1443 0.478299
R2583 VDD.n1456 VDD.n1442 0.478299
R2584 VDD.n543 VDD.n542 0.478299
R2585 VDD.n1457 VDD.n1441 0.478299
R2586 VDD.n88 VDD.n87 0.478299
R2587 VDD.n547 VDD.n546 0.478299
R2588 VDD.n1459 VDD.n1440 0.478299
R2589 VDD.n85 VDD.n84 0.478299
R2590 VDD.n83 VDD.n219 0.478299
R2591 VDD.n1460 VDD.n1439 0.478299
R2592 VDD.n1465 VDD.n1438 0.478299
R2593 VDD.n1462 VDD.n1437 0.478299
R2594 VDD.n549 VDD.n548 0.478299
R2595 VDD.n79 VDD.n552 0.478299
R2596 VDD.n77 VDD.n76 0.478299
R2597 VDD.n1463 VDD.n1436 0.478299
R2598 VDD.n556 VDD.n555 0.478299
R2599 VDD.n553 VDD.n559 0.478299
R2600 VDD.n74 VDD.n73 0.478299
R2601 VDD.n610 VDD.n609 0.478299
R2602 VDD.n1686 VDD.n1684 0.478299
R2603 VDD.n140 VDD.n139 0.478299
R2604 VDD.n510 VDD.n509 0.478299
R2605 VDD.n1687 VDD.n1683 0.478299
R2606 VDD.n137 VDD.n136 0.478299
R2607 VDD.n514 VDD.n513 0.478299
R2608 VDD.n511 VDD.n516 0.478299
R2609 VDD.n125 VDD.n124 0.478299
R2610 VDD.n133 VDD.n132 0.478299
R2611 VDD.n1690 VDD.n1682 0.478299
R2612 VDD.n518 VDD.n517 0.478299
R2613 VDD.n130 VDD.n129 0.478299
R2614 VDD.n127 VDD.n126 0.478299
R2615 VDD.n122 VDD.n121 0.478299
R2616 VDD.n120 VDD.n119 0.478299
R2617 VDD.n1691 VDD.n1681 0.478299
R2618 VDD.n521 VDD.n520 0.478299
R2619 VDD.n1692 VDD.n1680 0.478299
R2620 VDD.n1693 VDD.n1679 0.478299
R2621 VDD.n117 VDD.n115 0.478299
R2622 VDD.n116 VDD.n223 0.478299
R2623 VDD.n525 VDD.n524 0.478299
R2624 VDD.n1694 VDD.n1678 0.478299
R2625 VDD.n1696 VDD.n1677 0.478299
R2626 VDD.n1697 VDD.n1676 0.478299
R2627 VDD.n113 VDD.n112 0.478299
R2628 VDD.n110 VDD.n109 0.478299
R2629 VDD.n107 VDD.n106 0.478299
R2630 VDD.n105 VDD.n528 0.478299
R2631 VDD.n526 VDD.n531 0.478299
R2632 VDD.n529 VDD.n533 0.478299
R2633 VDD.n1699 VDD.n1675 0.478299
R2634 VDD.n612 VDD.n611 0.478299
R2635 VDD.n160 VDD.n159 0.478299
R2636 VDD.n157 VDD.n156 0.478299
R2637 VDD.n478 VDD.n477 0.478299
R2638 VDD.n480 VDD.n479 0.478299
R2639 VDD.n1944 VDD.n1943 0.478299
R2640 VDD.n482 VDD.n481 0.478299
R2641 VDD.n154 VDD.n153 0.478299
R2642 VDD.n151 VDD.n149 0.478299
R2643 VDD.n484 VDD.n483 0.478299
R2644 VDD.n487 VDD.n485 0.478299
R2645 VDD.n1953 VDD.n1952 0.478299
R2646 VDD.n1958 VDD.n1957 0.478299
R2647 VDD.n1962 VDD.n1961 0.478299
R2648 VDD.n1994 VDD.n1964 0.478299
R2649 VDD.n489 VDD.n488 0.478299
R2650 VDD.n18 VDD.n28 0.478299
R2651 VDD.n20 VDD.n19 0.478299
R2652 VDD.n492 VDD.n491 0.478299
R2653 VDD.n147 VDD.n146 0.478299
R2654 VDD.n496 VDD.n495 0.478299
R2655 VDD.n1973 VDD.n1972 0.478299
R2656 VDD.n144 VDD.n143 0.478299
R2657 VDD.n142 VDD.n497 0.478299
R2658 VDD.n1990 VDD.n1980 0.478299
R2659 VDD.n499 VDD.n498 0.478299
R2660 VDD.n26 VDD.n25 0.478299
R2661 VDD.n601 VDD.n1986 0.478299
R2662 VDD.n502 VDD.n500 0.478299
R2663 VDD.n16 VDD.n15 0.478299
R2664 VDD.n504 VDD.n503 0.478299
R2665 VDD.n506 VDD.n505 0.478299
R2666 VDD.n206 VDD.n203 0.478299
R2667 VDD.n455 VDD.n454 0.478299
R2668 VDD.n452 VDD.n451 0.478299
R2669 VDD.n1109 VDD.n1107 0.478299
R2670 VDD.n463 VDD.n462 0.478299
R2671 VDD.n460 VDD.n466 0.478299
R2672 VDD.n1128 VDD.n1106 0.478299
R2673 VDD.n1125 VDD.n1105 0.478299
R2674 VDD.n200 VDD.n199 0.478299
R2675 VDD.n448 VDD.n447 0.478299
R2676 VDD.n1121 VDD.n1104 0.478299
R2677 VDD.n445 VDD.n444 0.478299
R2678 VDD.n1111 VDD.n1103 0.478299
R2679 VDD.n468 VDD.n467 0.478299
R2680 VDD.n192 VDD.n469 0.478299
R2681 VDD.n32 VDD.n31 0.478299
R2682 VDD.n190 VDD.n189 0.478299
R2683 VDD.n1117 VDD.n1102 0.478299
R2684 VDD.n187 VDD.n186 0.478299
R2685 VDD.n184 VDD.n182 0.478299
R2686 VDD.n180 VDD.n179 0.478299
R2687 VDD.n176 VDD.n175 0.478299
R2688 VDD.n471 VDD.n470 0.478299
R2689 VDD.n171 VDD.n474 0.478299
R2690 VDD.n472 VDD.n476 0.478299
R2691 VDD.n169 VDD.n168 0.478299
R2692 VDD.n166 VDD.n165 0.478299
R2693 VDD.n163 VDD.n162 0.478299
R2694 VDD.n161 VDD.n0 0.478299
R2695 VDD.n875 VDD.n760 0.467635
R2696 VDD.n857 VDD.n763 0.467466
R2697 VDD.n796 VDD.n771 0.467303
R2698 VDD.n8 VDD.n1555 0.467143
R2699 VDD.n1554 VDD.n1553 0.467143
R2700 VDD.n1552 VDD.n1551 0.467143
R2701 VDD.n1550 VDD.n1549 0.467143
R2702 VDD.n1548 VDD.n1547 0.467143
R2703 VDD.n1546 VDD.n1545 0.467143
R2704 VDD.n1544 VDD.n1543 0.467143
R2705 VDD.n1542 VDD.n1541 0.467143
R2706 VDD.n1540 VDD.n1539 0.467143
R2707 VDD.n1538 VDD.n1537 0.467143
R2708 VDD.n1532 VDD.n1531 0.467143
R2709 VDD.n1530 VDD.n1529 0.467143
R2710 VDD.n1528 VDD.n1527 0.467143
R2711 VDD.n1526 VDD.n1525 0.467143
R2712 VDD.n1524 VDD.n1523 0.467143
R2713 VDD.n1522 VDD.n1521 0.467143
R2714 VDD.n1520 VDD.n1519 0.467143
R2715 VDD.n1518 VDD.n1517 0.467143
R2716 VDD.n1516 VDD.n1515 0.467143
R2717 VDD.n1514 VDD.n1513 0.467143
R2718 VDD.n1512 VDD.n1511 0.467143
R2719 VDD.n1510 VDD.n1509 0.467143
R2720 VDD.n1508 VDD.n1507 0.467143
R2721 VDD.n574 VDD.n573 0.467143
R2722 VDD.n1506 VDD.n1505 0.467143
R2723 VDD.n1504 VDD.n1503 0.467143
R2724 VDD.n1502 VDD.n1501 0.467143
R2725 VDD.n1500 VDD.n1499 0.467143
R2726 VDD.n1498 VDD.n1497 0.467143
R2727 VDD.n1496 VDD.n1495 0.467143
R2728 VDD.n37 VDD.n1777 0.467143
R2729 VDD.n1776 VDD.n1775 0.467143
R2730 VDD.n1774 VDD.n1773 0.467143
R2731 VDD.n1772 VDD.n1771 0.467143
R2732 VDD.n1770 VDD.n1769 0.467143
R2733 VDD.n1768 VDD.n1767 0.467143
R2734 VDD.n1766 VDD.n1765 0.467143
R2735 VDD.n1764 VDD.n1763 0.467143
R2736 VDD.n1762 VDD.n1761 0.467143
R2737 VDD.n1760 VDD.n1759 0.467143
R2738 VDD.n1754 VDD.n1753 0.467143
R2739 VDD.n1752 VDD.n1751 0.467143
R2740 VDD.n1750 VDD.n1749 0.467143
R2741 VDD.n1748 VDD.n1747 0.467143
R2742 VDD.n1746 VDD.n1745 0.467143
R2743 VDD.n1744 VDD.n1743 0.467143
R2744 VDD.n1742 VDD.n1741 0.467143
R2745 VDD.n1740 VDD.n1739 0.467143
R2746 VDD.n1738 VDD.n1737 0.467143
R2747 VDD.n1736 VDD.n1735 0.467143
R2748 VDD.n1734 VDD.n1733 0.467143
R2749 VDD.n1732 VDD.n1731 0.467143
R2750 VDD.n1730 VDD.n1729 0.467143
R2751 VDD.n576 VDD.n575 0.467143
R2752 VDD.n1728 VDD.n1727 0.467143
R2753 VDD.n1726 VDD.n1725 0.467143
R2754 VDD.n1724 VDD.n1723 0.467143
R2755 VDD.n1722 VDD.n1721 0.467143
R2756 VDD.n1720 VDD.n1719 0.467143
R2757 VDD.n1718 VDD.n1717 0.467143
R2758 VDD.n3 VDD.n1989 0.710808
R2759 VDD.n1989 VDD.n1929 0.467143
R2760 VDD.n1988 VDD.n1928 0.467143
R2761 VDD.n1987 VDD.n1927 0.467143
R2762 VDD.n1985 VDD.n1926 0.467143
R2763 VDD.n1982 VDD.n1925 0.467143
R2764 VDD.n1981 VDD.n1924 0.467143
R2765 VDD.n1979 VDD.n1923 0.467143
R2766 VDD.n1978 VDD.n1922 0.467143
R2767 VDD.n1971 VDD.n1918 0.467143
R2768 VDD.n1970 VDD.n1917 0.467143
R2769 VDD.n1969 VDD.n1916 0.467143
R2770 VDD.n1968 VDD.n1915 0.467143
R2771 VDD.n1967 VDD.n1914 0.467143
R2772 VDD.n1966 VDD.n1913 0.467143
R2773 VDD.n1965 VDD.n1912 0.467143
R2774 VDD.n1963 VDD.n1911 0.467143
R2775 VDD.n1960 VDD.n1910 0.467143
R2776 VDD.n1956 VDD.n1909 0.467143
R2777 VDD.n1951 VDD.n1908 0.467143
R2778 VDD.n1949 VDD.n1907 0.467143
R2779 VDD.n1948 VDD.n578 0.467143
R2780 VDD.n579 VDD.n577 0.467143
R2781 VDD.n1947 VDD.n1906 0.467143
R2782 VDD.n1945 VDD.n1905 0.467143
R2783 VDD.n1942 VDD.n1904 0.467143
R2784 VDD.n1941 VDD.n1903 0.467143
R2785 VDD.n1940 VDD.n1902 0.467143
R2786 VDD.n1939 VDD.n1901 0.467143
R2787 VDD.n1 VDD.n1193 0.467143
R2788 VDD.n1192 VDD.n1191 0.467143
R2789 VDD.n1190 VDD.n1189 0.467143
R2790 VDD.n1188 VDD.n1187 0.467143
R2791 VDD.n1186 VDD.n1185 0.467143
R2792 VDD.n1184 VDD.n1183 0.467143
R2793 VDD.n1182 VDD.n1181 0.467143
R2794 VDD.n1180 VDD.n1179 0.467143
R2795 VDD.n1174 VDD.n1173 0.467143
R2796 VDD.n1172 VDD.n1171 0.467143
R2797 VDD.n1170 VDD.n1169 0.467143
R2798 VDD.n1168 VDD.n1167 0.467143
R2799 VDD.n1166 VDD.n1165 0.467143
R2800 VDD.n1164 VDD.n1163 0.467143
R2801 VDD.n1162 VDD.n1161 0.467143
R2802 VDD.n1160 VDD.n1159 0.467143
R2803 VDD.n1158 VDD.n1157 0.467143
R2804 VDD.n1156 VDD.n1155 0.467143
R2805 VDD.n1154 VDD.n1153 0.467143
R2806 VDD.n1152 VDD.n1151 0.467143
R2807 VDD.n1150 VDD.n1149 0.467143
R2808 VDD.n590 VDD.n589 0.467143
R2809 VDD.n1148 VDD.n1147 0.467143
R2810 VDD.n1146 VDD.n1145 0.467143
R2811 VDD.n1144 VDD.n1143 0.467143
R2812 VDD.n1142 VDD.n1141 0.467143
R2813 VDD.n1140 VDD.n1139 0.467143
R2814 VDD.n1138 VDD.n1137 0.467143
R2815 VDD.n893 VDD.n757 0.467143
R2816 VDD.n979 VDD.n741 0.467143
R2817 VDD.n887 VDD.n758 0.467143
R2818 VDD.n961 VDD.n744 0.467143
R2819 VDD.n808 VDD.n769 0.467143
R2820 VDD.n869 VDD.n761 0.467091
R2821 VDD.n973 VDD.n742 0.467003
R2822 VDD.n881 VDD.n759 0.466963
R2823 VDD.n911 VDD.n754 0.466955
R2824 VDD.n851 VDD.n764 0.466912
R2825 VDD.n905 VDD.n755 0.466912
R2826 VDD.n949 VDD.n746 0.466909
R2827 VDD.n839 VDD.n592 0.46682
R2828 VDD.n820 VDD.n767 0.46682
R2829 VDD.n967 VDD.n743 0.466761
R2830 VDD.n863 VDD.n762 0.466699
R2831 VDD.n943 VDD.n747 0.466699
R2832 VDD.n931 VDD.n749 0.466622
R2833 VDD.n845 VDD.n765 0.466523
R2834 VDD.n925 VDD.n750 0.466497
R2835 VDD.n937 VDD.n748 0.466464
R2836 VDD.n814 VDD.n768 0.466464
R2837 VDD.n899 VDD.n756 0.466439
R2838 VDD.n593 VDD.n591 0.466426
R2839 VDD.n955 VDD.n745 0.466319
R2840 VDD.n826 VDD.n766 0.466314
R2841 VDD.n802 VDD.n770 0.466226
R2842 VDD.n796 VDD.n770 0.451677
R2843 VDD.n949 VDD.n745 0.45157
R2844 VDD.n820 VDD.n766 0.451566
R2845 VDD.n919 VDD.n750 0.451497
R2846 VDD.n826 VDD.n591 0.451477
R2847 VDD.n893 VDD.n756 0.451469
R2848 VDD.n931 VDD.n748 0.451456
R2849 VDD.n808 VDD.n768 0.451456
R2850 VDD.n839 VDD.n765 0.451359
R2851 VDD.n925 VDD.n749 0.451269
R2852 VDD.n937 VDD.n747 0.451252
R2853 VDD.n857 VDD.n762 0.451252
R2854 VDD.n961 VDD.n743 0.451204
R2855 VDD.n814 VDD.n767 0.451146
R2856 VDD.n943 VDD.n746 0.451022
R2857 VDD.n899 VDD.n755 0.451015
R2858 VDD.n845 VDD.n764 0.451015
R2859 VDD.n967 VDD.n742 0.451009
R2860 VDD.n905 VDD.n754 0.450971
R2861 VDD.n875 VDD.n759 0.450967
R2862 VDD.n863 VDD.n761 0.450884
R2863 VDD.n1497 VDD.n1496 0.450828
R2864 VDD.n1511 VDD.n1510 0.450828
R2865 VDD.n1515 VDD.n1514 0.450828
R2866 VDD.n1517 VDD.n1516 0.450828
R2867 VDD.n1519 VDD.n1518 0.450828
R2868 VDD.n1523 VDD.n1522 0.450828
R2869 VDD.n1531 VDD.n1530 0.450828
R2870 VDD.n1537 VDD.n1536 0.450828
R2871 VDD.n1547 VDD.n1546 0.450828
R2872 VDD.n1549 VDD.n1548 0.450828
R2873 VDD.n1555 VDD.n1554 0.450828
R2874 VDD.n1553 VDD.n1552 0.450828
R2875 VDD.n1551 VDD.n1550 0.450828
R2876 VDD.n1545 VDD.n1544 0.450828
R2877 VDD.n1543 VDD.n1542 0.450828
R2878 VDD.n1541 VDD.n1540 0.450828
R2879 VDD.n1539 VDD.n1538 0.450828
R2880 VDD.n1529 VDD.n1528 0.450828
R2881 VDD.n1527 VDD.n1526 0.450828
R2882 VDD.n1525 VDD.n1524 0.450828
R2883 VDD.n1521 VDD.n1520 0.450828
R2884 VDD.n1513 VDD.n1512 0.450828
R2885 VDD.n1509 VDD.n1508 0.450828
R2886 VDD.n573 VDD.n1506 0.450828
R2887 VDD.n1505 VDD.n1504 0.450828
R2888 VDD.n1503 VDD.n1502 0.450828
R2889 VDD.n1501 VDD.n1500 0.450828
R2890 VDD.n1499 VDD.n1498 0.450828
R2891 VDD.n1495 VDD.n1494 0.450828
R2892 VDD.n1717 VDD.n1716 0.450828
R2893 VDD.n1725 VDD.n1724 0.450828
R2894 VDD.n1727 VDD.n1726 0.450828
R2895 VDD.n1735 VDD.n1734 0.450828
R2896 VDD.n1737 VDD.n1736 0.450828
R2897 VDD.n1739 VDD.n1738 0.450828
R2898 VDD.n1741 VDD.n1740 0.450828
R2899 VDD.n1747 VDD.n1746 0.450828
R2900 VDD.n1749 VDD.n1748 0.450828
R2901 VDD.n1751 VDD.n1750 0.450828
R2902 VDD.n1753 VDD.n1752 0.450828
R2903 VDD.n1759 VDD.n1758 0.450828
R2904 VDD.n1767 VDD.n1766 0.450828
R2905 VDD.n1769 VDD.n1768 0.450828
R2906 VDD.n1771 VDD.n1770 0.450828
R2907 VDD.n1777 VDD.n1776 0.450828
R2908 VDD.n1775 VDD.n1774 0.450828
R2909 VDD.n1773 VDD.n1772 0.450828
R2910 VDD.n1765 VDD.n1764 0.450828
R2911 VDD.n1763 VDD.n1762 0.450828
R2912 VDD.n1761 VDD.n1760 0.450828
R2913 VDD.n1745 VDD.n1744 0.450828
R2914 VDD.n1743 VDD.n1742 0.450828
R2915 VDD.n1733 VDD.n1732 0.450828
R2916 VDD.n1731 VDD.n1730 0.450828
R2917 VDD.n575 VDD.n1728 0.450828
R2918 VDD.n1723 VDD.n1722 0.450828
R2919 VDD.n1721 VDD.n1720 0.450828
R2920 VDD.n1719 VDD.n1718 0.450828
R2921 VDD.n1939 VDD.n1902 0.450828
R2922 VDD.n1941 VDD.n1904 0.450828
R2923 VDD.n1949 VDD.n1908 0.450828
R2924 VDD.n1951 VDD.n1909 0.450828
R2925 VDD.n1956 VDD.n1910 0.450828
R2926 VDD.n1965 VDD.n1913 0.450828
R2927 VDD.n1967 VDD.n1915 0.450828
R2928 VDD.n1968 VDD.n1916 0.450828
R2929 VDD.n1969 VDD.n1917 0.450828
R2930 VDD.n1978 VDD.n1923 0.450828
R2931 VDD.n1982 VDD.n1926 0.450828
R2932 VDD.n1988 VDD.n1929 0.450828
R2933 VDD.n1987 VDD.n1928 0.450828
R2934 VDD.n1985 VDD.n1927 0.450828
R2935 VDD.n1981 VDD.n1925 0.450828
R2936 VDD.n1979 VDD.n1924 0.450828
R2937 VDD.n1977 VDD.n1922 0.450828
R2938 VDD.n1970 VDD.n1918 0.450828
R2939 VDD.n1966 VDD.n1914 0.450828
R2940 VDD.n1963 VDD.n1912 0.450828
R2941 VDD.n1960 VDD.n1911 0.450828
R2942 VDD.n1948 VDD.n1907 0.450828
R2943 VDD.n1947 VDD.n577 0.450828
R2944 VDD.n1945 VDD.n1906 0.450828
R2945 VDD.n1942 VDD.n1905 0.450828
R2946 VDD.n1940 VDD.n1903 0.450828
R2947 VDD.n1937 VDD.n1901 0.450828
R2948 VDD.n1139 VDD.n1138 0.450828
R2949 VDD.n1147 VDD.n1146 0.450828
R2950 VDD.n1155 VDD.n1154 0.450828
R2951 VDD.n1157 VDD.n1156 0.450828
R2952 VDD.n1159 VDD.n1158 0.450828
R2953 VDD.n1161 VDD.n1160 0.450828
R2954 VDD.n1163 VDD.n1162 0.450828
R2955 VDD.n1165 VDD.n1164 0.450828
R2956 VDD.n1167 VDD.n1166 0.450828
R2957 VDD.n1169 VDD.n1168 0.450828
R2958 VDD.n1179 VDD.n1178 0.450828
R2959 VDD.n1181 VDD.n1180 0.450828
R2960 VDD.n1183 VDD.n1182 0.450828
R2961 VDD.n1185 VDD.n1184 0.450828
R2962 VDD.n1189 VDD.n1188 0.450828
R2963 VDD.n1191 VDD.n1190 0.450828
R2964 VDD.n1193 VDD.n1192 0.450828
R2965 VDD.n2 VDD.n1 0.693316
R2966 VDD.t378 VDD.n2 0.506723
R2967 VDD.n1187 VDD.n1186 0.450828
R2968 VDD.n1173 VDD.n1172 0.450828
R2969 VDD.n1171 VDD.n1170 0.450828
R2970 VDD.n1153 VDD.n1152 0.450828
R2971 VDD.n1151 VDD.n1150 0.450828
R2972 VDD.n589 VDD.n1148 0.450828
R2973 VDD.n1145 VDD.n1144 0.450828
R2974 VDD.n1143 VDD.n1142 0.450828
R2975 VDD.n1141 VDD.n1140 0.450828
R2976 VDD.n1137 VDD.n1136 0.450828
R2977 VDD.n973 VDD.n741 0.450828
R2978 VDD.n887 VDD.n757 0.450828
R2979 VDD.n955 VDD.n744 0.450828
R2980 VDD.n881 VDD.n758 0.450828
R2981 VDD.n802 VDD.n769 0.450828
R2982 VDD.n790 VDD.n771 0.450676
R2983 VDD.n851 VDD.n763 0.45053
R2984 VDD.n869 VDD.n760 0.450381
R2985 VDD.n59 VDD.n1449 0.446112
R2986 VDD.n62 VDD.n255 0.446112
R2987 VDD.n570 VDD.n1935 0.446112
R2988 VDD.n67 VDD.n202 0.446112
R2989 VDD.n781 VDD.n780 0.446112
R2990 VDD.n2042 VDD.n2041 0.43209
R2991 VDD.n10 VDD.n7 0.216758
R2992 VDD.n13 VDD.n11 0.226851
R2993 VDD.n6 VDD.n5 0.23714
R2994 VDD.n48 VDD.n46 0.429929
R2995 VDD.n1490 VDD.n1489 0.429766
R2996 VDD.n1931 VDD.n1930 0.429766
R2997 VDD.n1132 VDD.n580 0.537896
R2998 VDD.n775 VDD.n774 0.428915
R2999 VDD.n778 VDD.n774 0.426918
R3000 VDD.n1488 VDD.n1451 0.426806
R3001 VDD.n1486 VDD.n1449 0.426806
R3002 VDD.n257 VDD.n256 0.426806
R3003 VDD.n257 VDD.n255 0.426806
R3004 VDD.n1934 VDD.n1933 0.426806
R3005 VDD.n571 VDD.n570 0.426806
R3006 VDD.n206 VDD.n201 0.426806
R3007 VDD.n206 VDD.n202 0.426806
R3008 VDD.n778 VDD.n777 0.426806
R3009 VDD.n782 VDD.n781 0.426806
R3010 VDD.n1489 VDD.n1488 0.426171
R3011 VDD.n1934 VDD.n1930 0.426171
R3012 VDD.n580 VDD.n206 0.289828
R3013 VDD.n718 VDD.n717 0.424842
R3014 VDD.n45 VDD.n717 0.424687
R3015 VDD.n10 VDD.n9 0.413465
R3016 VDD.n39 VDD.n38 0.413465
R3017 VDD.t473 VDD.t345 5.99423
R3018 VDD.t378 VDD.t440 5.6892
R3019 VDD.n35 VDD.n6 0.413465
R3020 VDD.n719 VDD.n718 0.413465
R3021 VDD.t467 VDD.n23 5.7154
R3022 VDD.n587 VDD.n586 0.424317
R3023 VDD.n585 VDD.n584 0.405593
R3024 VDD.n459 VDD.n458 0.405593
R3025 VDD.n2042 VDD.n42 0.404795
R3026 VDD.n1712 VDD.n258 0.584408
R3027 VDD.n752 VDD.n751 0.383025
R3028 VDD.n1535 VDD.n1534 0.382697
R3029 VDD.n1757 VDD.n1756 0.382697
R3030 VDD.n1921 VDD.n1920 0.382697
R3031 VDD.n1177 VDD.n1176 0.382697
R3032 VDD.n1536 VDD.n1535 0.381004
R3033 VDD.n1758 VDD.n1757 0.381004
R3034 VDD.n1977 VDD.n1921 0.381004
R3035 VDD.n1178 VDD.n1177 0.381004
R3036 VDD.n919 VDD.n751 0.380674
R3037 VDD.n2024 VDD.n2023 0.372655
R3038 VDD.n2020 VDD.n735 0.372571
R3039 VDD.n959 VDD.n958 0.35553
R3040 VDD.n812 VDD.n811 0.355452
R3041 VDD.n800 VDD.n799 0.355452
R3042 VDD.n947 VDD.n946 0.355452
R3043 VDD.n923 VDD.n922 0.355452
R3044 VDD.n891 VDD.n890 0.355452
R3045 VDD.n879 VDD.n878 0.355452
R3046 VDD.n965 VDD.n964 0.355386
R3047 VDD.n855 VDD.n854 0.355386
R3048 VDD.n794 VDD.n793 0.355312
R3049 VDD.n909 VDD.n908 0.355312
R3050 VDD.n873 VDD.n872 0.355312
R3051 VDD.n953 VDD.n952 0.355155
R3052 VDD.n885 VDD.n884 0.355155
R3053 VDD.n861 VDD.n860 0.355155
R3054 VDD.n830 VDD.n829 0.355155
R3055 VDD.n867 VDD.n866 0.35501
R3056 VDD.n806 VDD.n805 0.354936
R3057 VDD.n824 VDD.n823 0.354838
R3058 VDD.n935 VDD.n934 0.354837
R3059 VDD.n971 VDD.n970 0.354771
R3060 VDD.n941 VDD.n940 0.354771
R3061 VDD.n903 VDD.n902 0.354771
R3062 VDD.n843 VDD.n842 0.354771
R3063 VDD.n818 VDD.n817 0.354771
R3064 VDD.n977 VDD.n976 0.354697
R3065 VDD.n929 VDD.n928 0.354697
R3066 VDD.n849 VDD.n848 0.354697
R3067 VDD.n2015 VDD.n737 0.354692
R3068 VDD.n897 VDD.n896 0.354557
R3069 VDD.n2018 VDD.n2014 0.354405
R3070 VDD.n1377 VDD.n1376 0.348249
R3071 VDD.n1617 VDD.n1616 0.348249
R3072 VDD.n1841 VDD.n1840 0.348249
R3073 VDD.n1256 VDD.n1255 0.348249
R3074 VDD.n1044 VDD.n1043 0.348249
R3075 VDD.n2025 VDD.n734 0.347655
R3076 VDD.n2029 VDD.n2028 0.347571
R3077 VDD.n2015 VDD.n736 0.347254
R3078 VDD.n2019 VDD.n2018 0.347039
R3079 VDD.n725 VDD.n724 0.335808
R3080 VDD.n732 VDD.n731 0.335799
R3081 VDD.n2033 VDD.n2029 0.334771
R3082 VDD.n2035 VDD.n734 0.334692
R3083 VDD.n732 VDD.n43 0.332058
R3084 VDD.n728 VDD.n725 0.332049
R3085 VDD.n2031 VDD.n41 0.383516
R3086 VDD.n2023 VDD.n2019 0.329132
R3087 VDD.n2020 VDD.n736 0.328947
R3088 VDD.n2014 VDD.n2013 0.327952
R3089 VDD.n2003 VDD.n737 0.327655
R3090 VDD.n9 VDD.n1435 0.327154
R3091 VDD.n38 VDD.n13 0.327154
R3092 VDD.n720 VDD.n719 0.327154
R3093 VDD.t466 VDD.n23 15.1392
R3094 VDD.n2007 VDD.n739 0.319294
R3095 VDD.n1451 VDD.n1450 0.313353
R3096 VDD.n256 VDD.n1685 0.313353
R3097 VDD.n1933 VDD.n1932 0.313353
R3098 VDD.n201 VDD.n1108 0.313353
R3099 VDD.n777 VDD.n776 0.313353
R3100 VDD.n896 VDD.n895 0.310312
R3101 VDD.n848 VDD.n847 0.31015
R3102 VDD.n976 VDD.n975 0.31015
R3103 VDD.n928 VDD.n927 0.31015
R3104 VDD.n970 VDD.n969 0.310071
R3105 VDD.n940 VDD.n939 0.310071
R3106 VDD.n902 VDD.n901 0.310071
R3107 VDD.n842 VDD.n841 0.310071
R3108 VDD.n817 VDD.n816 0.310071
R3109 VDD.n934 VDD.n933 0.31001
R3110 VDD.n823 VDD.n822 0.309994
R3111 VDD.n805 VDD.n804 0.309928
R3112 VDD.n866 VDD.n865 0.309837
R3113 VDD.n2025 VDD.n735 0.309771
R3114 VDD.n860 VDD.n859 0.309692
R3115 VDD.n2028 VDD.n2024 0.309692
R3116 VDD.n952 VDD.n951 0.309692
R3117 VDD.n884 VDD.n883 0.309692
R3118 VDD.n829 VDD.n828 0.309692
R3119 VDD.n908 VDD.n907 0.309557
R3120 VDD.n872 VDD.n871 0.309557
R3121 VDD.n793 VDD.n792 0.309557
R3122 VDD.n964 VDD.n963 0.309483
R3123 VDD.n854 VDD.n853 0.309483
R3124 VDD.n946 VDD.n945 0.309405
R3125 VDD.n922 VDD.n921 0.309405
R3126 VDD.n890 VDD.n889 0.309405
R3127 VDD.n878 VDD.n877 0.309405
R3128 VDD.n811 VDD.n810 0.309405
R3129 VDD.n799 VDD.n798 0.309405
R3130 VDD.n958 VDD.n957 0.309333
R3131 VDD.n715 VDD.n714 0.306263
R3132 VDD.n198 VDD.n10 0.299294
R3133 VDD.n12 VDD.n39 0.299294
R3134 VDD.t439 VDD.t378 5.82579
R3135 VDD.n723 VDD.n722 0.298721
R3136 VDD.n1494 VDD.n1493 0.291071
R3137 VDD.n1716 VDD.n1715 0.291071
R3138 VDD.n1937 VDD.n1900 0.291071
R3139 VDD.n1136 VDD.n1135 0.291071
R3140 VDD.n790 VDD.n772 0.290887
R3141 VDD VDD.n43 0.423614
R3142 VDD.n1318 VDD.n1317 0.284268
R3143 VDD.n1407 VDD.n1406 0.284268
R3144 VDD.n1559 VDD.n1558 0.284268
R3145 VDD.n1647 VDD.n1646 0.284268
R3146 VDD.n1781 VDD.n1780 0.284268
R3147 VDD.n1871 VDD.n1870 0.284268
R3148 VDD.n1197 VDD.n1196 0.284268
R3149 VDD.n1286 VDD.n1285 0.284268
R3150 VDD.n985 VDD.n984 0.284268
R3151 VDD.n1074 VDD.n1073 0.284268
R3152 VDD.n207 VDD.n588 0.39999
R3153 VDD.n1319 VDD.n1318 0.282549
R3154 VDD.n1408 VDD.n1407 0.282549
R3155 VDD.n1376 VDD.n1375 0.282549
R3156 VDD.n1560 VDD.n1559 0.282549
R3157 VDD.n1648 VDD.n1647 0.282549
R3158 VDD.n1616 VDD.n1615 0.282549
R3159 VDD.n1782 VDD.n1781 0.282549
R3160 VDD.n1872 VDD.n1871 0.282549
R3161 VDD.n1840 VDD.n1839 0.282549
R3162 VDD.n1198 VDD.n1197 0.282549
R3163 VDD.n1287 VDD.n1286 0.282549
R3164 VDD.n1255 VDD.n1254 0.282549
R3165 VDD.n986 VDD.n985 0.282549
R3166 VDD.n1075 VDD.n1074 0.282549
R3167 VDD.n1043 VDD.n1042 0.282549
R3168 VDD.n10 VDD.n8 0.379689
R3169 VDD.n39 VDD.n37 0.379689
R3170 VDD.n1343 VDD.n1317 0.268799
R3171 VDD.n1406 VDD.n1405 0.268799
R3172 VDD.n1584 VDD.n1558 0.268799
R3173 VDD.n1646 VDD.n1645 0.268799
R3174 VDD.n1806 VDD.n1780 0.268799
R3175 VDD.n1870 VDD.n1869 0.268799
R3176 VDD.n1222 VDD.n1196 0.268799
R3177 VDD.n1285 VDD.n1284 0.268799
R3178 VDD.n1010 VDD.n984 0.268799
R3179 VDD.n1073 VDD.n1072 0.268799
R3180 VDD.n218 VDD.n217 0.145041
R3181 VDD.n216 VDD.n215 0.145041
R3182 VDD.n214 VDD.n213 0.145041
R3183 VDD.n212 VDD.n211 0.145041
R3184 VDD.n210 VDD.n209 0.145041
R3185 VDD.n917 VDD.n916 0.263915
R3186 VDD.n837 VDD.n836 0.263607
R3187 VDD.n724 VDD.n723 0.260496
R3188 VDD.n1314 VDD.n739 0.25999
R3189 VDD.n2038 VDD.n2037 0.253639
R3190 VDD.n2010 VDD.n2009 0.253639
R3191 VDD.n11 VDD.t487 5.68728
R3192 VDD.n46 VDD.n24 0.25333
R3193 VDD.t470 VDD.n23 5.6952
R3194 VDD.n2039 VDD.n2038 0.253298
R3195 VDD.n2011 VDD.n2010 0.253298
R3196 VDD.n42 VDD.n41 0.192952
R3197 VDD.n784 VDD.n772 0.243387
R3198 VDD.n1493 VDD.n1492 0.243218
R3199 VDD.n1715 VDD.n1714 0.243218
R3200 VDD.n1936 VDD.n1900 0.243218
R3201 VDD.n1135 VDD.n1134 0.243218
R3202 VDD.n1320 VDD.n1319 0.241768
R3203 VDD.n1409 VDD.n1408 0.241768
R3204 VDD.n1375 VDD.n1374 0.241768
R3205 VDD.n1561 VDD.n1560 0.241768
R3206 VDD.n1649 VDD.n1648 0.241768
R3207 VDD.n1615 VDD.n1614 0.241768
R3208 VDD.n1783 VDD.n1782 0.241768
R3209 VDD.n1873 VDD.n1872 0.241768
R3210 VDD.n1839 VDD.n1838 0.241768
R3211 VDD.n1199 VDD.n1198 0.241768
R3212 VDD.n1288 VDD.n1287 0.241768
R3213 VDD.n1254 VDD.n1253 0.241768
R3214 VDD.n987 VDD.n986 0.241768
R3215 VDD.n1076 VDD.n1075 0.241768
R3216 VDD.n1042 VDD.n1041 0.241768
R3217 VDD.n721 VDD.n48 4.71183
R3218 VDD.n633 VDD.n1470 0.35501
R3219 VDD.n494 VDD.n493 0.355155
R3220 VDD.n545 VDD.n544 0.35501
R3221 VDD.n626 VDD.n1477 0.263403
R3222 VDD.n526 VDD.n530 0.409782
R3223 VDD.n656 VDD.n1702 0.35501
R3224 VDD.n508 VDD.n507 0.35501
R3225 VDD.n1996 VDD.n666 0.35501
R3226 VDD.n154 VDD.n150 0.354697
R3227 VDD.n1946 VDD.n623 0.35501
R3228 VDD.n472 VDD.n475 0.310312
R3229 VDD.n630 VDD.n1116 0.354557
R3230 VDD.n32 VDD.n30 0.442549
R3231 VDD.n625 VDD.n1127 0.35501
R3232 VDD.n228 VDD.n227 0.0555064
R3233 VDD.n232 VDD.n231 0.0555064
R3234 VDD.n236 VDD.n235 0.0555064
R3235 VDD.n240 VDD.n239 0.0555064
R3236 VDD.n244 VDD.n243 0.0555064
R3237 VDD.n58 VDD.n57 0.137421
R3238 VDD.n56 VDD.n55 0.137421
R3239 VDD.n54 VDD.n53 0.137421
R3240 VDD.n52 VDD.n51 0.137421
R3241 VDD.n50 VDD.n49 0.137421
R3242 VDD.n1347 VDD.n1345 0.221058
R3243 VDD.n1428 VDD.n1427 0.221058
R3244 VDD.n1351 VDD.n1350 0.221058
R3245 VDD.n1413 VDD.n1412 0.221058
R3246 VDD.n1400 VDD.n1399 0.221058
R3247 VDD.n1360 VDD.n1359 0.221058
R3248 VDD.n1385 VDD.n1384 0.221058
R3249 VDD.n1368 VDD.n1367 0.221058
R3250 VDD.n1588 VDD.n1586 0.221058
R3251 VDD.n1668 VDD.n1667 0.221058
R3252 VDD.n1592 VDD.n1591 0.221058
R3253 VDD.n1653 VDD.n1652 0.221058
R3254 VDD.n1640 VDD.n1639 0.221058
R3255 VDD.n1600 VDD.n1599 0.221058
R3256 VDD.n1625 VDD.n1624 0.221058
R3257 VDD.n1608 VDD.n1607 0.221058
R3258 VDD.n1810 VDD.n1808 0.221058
R3259 VDD.n1892 VDD.n1891 0.221058
R3260 VDD.n1814 VDD.n1813 0.221058
R3261 VDD.n1877 VDD.n1876 0.221058
R3262 VDD.n1864 VDD.n1863 0.221058
R3263 VDD.n1823 VDD.n1822 0.221058
R3264 VDD.n1849 VDD.n1848 0.221058
R3265 VDD.n1831 VDD.n1830 0.221058
R3266 VDD.n1226 VDD.n1224 0.221058
R3267 VDD.n1307 VDD.n1306 0.221058
R3268 VDD.n1230 VDD.n1229 0.221058
R3269 VDD.n1292 VDD.n1291 0.221058
R3270 VDD.n1279 VDD.n1278 0.221058
R3271 VDD.n1239 VDD.n1238 0.221058
R3272 VDD.n1264 VDD.n1263 0.221058
R3273 VDD.n1247 VDD.n1246 0.221058
R3274 VDD.n1014 VDD.n1012 0.221058
R3275 VDD.n1095 VDD.n1094 0.221058
R3276 VDD.n1018 VDD.n1017 0.221058
R3277 VDD.n1080 VDD.n1079 0.221058
R3278 VDD.n1067 VDD.n1066 0.221058
R3279 VDD.n1026 VDD.n1025 0.221058
R3280 VDD.n1052 VDD.n1051 0.221058
R3281 VDD.n1034 VDD.n1033 0.221058
R3282 VDD.n22 VDD.n24 0.137077
R3283 VDD.n586 VDD 2.04432
R3284 VDD.n619 VDD 2.04432
R3285 VDD.n617 VDD 2.04432
R3286 VDD.n459 VDD 2.04432
R3287 VDD.n614 VDD 2.04432
R3288 VDD.n916 VDD.n915 0.214547
R3289 VDD.n836 VDD.n835 0.21235
R3290 VDD.n2013 VDD.n2002 0.191924
R3291 VDD.n2003 VDD.n738 0.191793
R3292 VDD.n553 VDD.n558 0.310452
R3293 VDD.n551 VDD.n550 0.355155
R3294 VDD.n644 VDD.n1461 0.354699
R3295 VDD.n85 VDD.n83 0.199443
R3296 VDD.n1457 VDD.n647 0.310452
R3297 VDD.n539 VDD.n537 0.310071
R3298 VDD.n628 VDD.n1703 0.354771
R3299 VDD.n1694 VDD.n646 0.310452
R3300 VDD.n525 VDD.n523 0.310452
R3301 VDD.n224 VDD.n598 0.310523
R3302 VDD.n1691 VDD.n599 0.410004
R3303 VDD.n514 VDD.n512 0.40971
R3304 VDD.n1687 VDD.n624 0.310452
R3305 VDD.n1959 VDD.n652 0.354936
R3306 VDD.n1954 VDD.n631 0.354771
R3307 VDD.n486 VDD.n484 0.410004
R3308 VDD.n638 VDD.n1997 0.355155
R3309 VDD.n465 VDD.n464 0.354771
R3310 VDD.n657 VDD.n1454 0.354712
R3311 VDD.n2033 VDD.n2030 0.184552
R3312 VDD.n2035 VDD.n733 0.184424
R3313 VDD.n2005 VDD.n2001 0.179888
R3314 VDD.n588 VDD.n729 0.171736
R3315 VDD.n2000 VDD.n1999 0.16955
R3316 VDD.n1483 VDD.n1482 0.16955
R3317 VDD.n788 VDD.n787 0.16955
R3318 VDD.n975 VDD.n972 0.162388
R3319 VDD.n963 VDD.n960 0.162388
R3320 VDD.n951 VDD.n948 0.162388
R3321 VDD.n933 VDD.n930 0.162388
R3322 VDD.n927 VDD.n924 0.162388
R3323 VDD.n901 VDD.n898 0.162388
R3324 VDD.n895 VDD.n892 0.162388
R3325 VDD.n883 VDD.n880 0.162388
R3326 VDD.n865 VDD.n862 0.162388
R3327 VDD.n847 VDD.n844 0.162388
R3328 VDD.n804 VDD.n801 0.162388
R3329 VDD.n1466 VDD.n1465 0.16205
R3330 VDD.n1472 VDD.n1471 0.16205
R3331 VDD.n1476 VDD.n1475 0.16205
R3332 VDD.n1479 VDD.n1478 0.16205
R3333 VDD.n601 VDD.n1984 0.16205
R3334 VDD.n1991 VDD.n1990 0.16205
R3335 VDD.n1995 VDD.n1994 0.16205
R3336 VDD.n1958 VDD.n1955 0.16205
R3337 VDD.n1118 VDD.n1117 0.16205
R3338 VDD.n1122 VDD.n1121 0.16205
R3339 VDD.n1126 VDD.n1125 0.16205
R3340 VDD.n1129 VDD.n1128 0.16205
R3341 VDD.n981 VDD.n978 0.16205
R3342 VDD.n969 VDD.n966 0.16205
R3343 VDD.n957 VDD.n954 0.16205
R3344 VDD.n945 VDD.n942 0.16205
R3345 VDD.n939 VDD.n936 0.16205
R3346 VDD.n921 VDD.n918 0.16205
R3347 VDD.n913 VDD.n910 0.16205
R3348 VDD.n907 VDD.n904 0.16205
R3349 VDD.n889 VDD.n886 0.16205
R3350 VDD.n877 VDD.n874 0.16205
R3351 VDD.n871 VDD.n868 0.16205
R3352 VDD.n859 VDD.n856 0.16205
R3353 VDD.n853 VDD.n850 0.16205
R3354 VDD.n841 VDD.n838 0.16205
R3355 VDD.n833 VDD.n831 0.16205
R3356 VDD.n828 VDD.n825 0.16205
R3357 VDD.n822 VDD.n819 0.16205
R3358 VDD.n816 VDD.n813 0.16205
R3359 VDD.n810 VDD.n807 0.16205
R3360 VDD.n798 VDD.n795 0.16205
R3361 VDD.n792 VDD.n789 0.16205
R3362 VDD.n2031 VDD.n733 0.161924
R3363 VDD.n2041 VDD.n2030 0.161793
R3364 VDD.n1335 VDD.n1334 0.159888
R3365 VDD.n1576 VDD.n1575 0.159888
R3366 VDD.n1798 VDD.n1797 0.159888
R3367 VDD.n1214 VDD.n1213 0.159888
R3368 VDD.n1002 VDD.n1001 0.159888
R3369 VDD.n1344 VDD.n1343 0.157388
R3370 VDD.n1430 VDD.n1429 0.157388
R3371 VDD.n1354 VDD.n1352 0.157388
R3372 VDD.n1415 VDD.n1414 0.157388
R3373 VDD.n1402 VDD.n1401 0.157388
R3374 VDD.n1362 VDD.n1361 0.157388
R3375 VDD.n1387 VDD.n1386 0.157388
R3376 VDD.n1370 VDD.n1369 0.157388
R3377 VDD.n1585 VDD.n1584 0.157388
R3378 VDD.n1670 VDD.n1669 0.157388
R3379 VDD.n1594 VDD.n1593 0.157388
R3380 VDD.n1655 VDD.n1654 0.157388
R3381 VDD.n1642 VDD.n1641 0.157388
R3382 VDD.n1602 VDD.n1601 0.157388
R3383 VDD.n1627 VDD.n1626 0.157388
R3384 VDD.n1610 VDD.n1609 0.157388
R3385 VDD.n1807 VDD.n1806 0.157388
R3386 VDD.n1894 VDD.n1893 0.157388
R3387 VDD.n1817 VDD.n1815 0.157388
R3388 VDD.n1879 VDD.n1878 0.157388
R3389 VDD.n1866 VDD.n1865 0.157388
R3390 VDD.n1825 VDD.n1824 0.157388
R3391 VDD.n1851 VDD.n1850 0.157388
R3392 VDD.n1834 VDD.n1832 0.157388
R3393 VDD.n1223 VDD.n1222 0.157388
R3394 VDD.n1309 VDD.n1308 0.157388
R3395 VDD.n1233 VDD.n1231 0.157388
R3396 VDD.n1294 VDD.n1293 0.157388
R3397 VDD.n1281 VDD.n1280 0.157388
R3398 VDD.n1241 VDD.n1240 0.157388
R3399 VDD.n1266 VDD.n1265 0.157388
R3400 VDD.n1249 VDD.n1248 0.157388
R3401 VDD.n1011 VDD.n1010 0.157388
R3402 VDD.n1097 VDD.n1096 0.157388
R3403 VDD.n1020 VDD.n1019 0.157388
R3404 VDD.n1082 VDD.n1081 0.157388
R3405 VDD.n1069 VDD.n1068 0.157388
R3406 VDD.n1028 VDD.n1027 0.157388
R3407 VDD.n1054 VDD.n1053 0.157388
R3408 VDD.n1037 VDD.n1035 0.157388
R3409 VDD.n2007 VDD.n738 0.154552
R3410 VDD.n2005 VDD.n2002 0.154424
R3411 VDD.n1347 VDD.n1346 0.154043
R3412 VDD.n1427 VDD.n1426 0.154043
R3413 VDD.n1356 VDD.n1350 0.154043
R3414 VDD.n1412 VDD.n1411 0.154043
R3415 VDD.n1399 VDD.n1398 0.154043
R3416 VDD.n1364 VDD.n1359 0.154043
R3417 VDD.n1384 VDD.n1383 0.154043
R3418 VDD.n1372 VDD.n1367 0.154043
R3419 VDD.n1588 VDD.n1587 0.154043
R3420 VDD.n1667 VDD.n1666 0.154043
R3421 VDD.n1596 VDD.n1591 0.154043
R3422 VDD.n1652 VDD.n1651 0.154043
R3423 VDD.n1639 VDD.n1638 0.154043
R3424 VDD.n1604 VDD.n1599 0.154043
R3425 VDD.n1624 VDD.n1623 0.154043
R3426 VDD.n1612 VDD.n1607 0.154043
R3427 VDD.n1810 VDD.n1809 0.154043
R3428 VDD.n1891 VDD.n1890 0.154043
R3429 VDD.n1819 VDD.n1813 0.154043
R3430 VDD.n1876 VDD.n1875 0.154043
R3431 VDD.n1863 VDD.n1862 0.154043
R3432 VDD.n1827 VDD.n1822 0.154043
R3433 VDD.n1848 VDD.n1847 0.154043
R3434 VDD.n1836 VDD.n1830 0.154043
R3435 VDD.n1226 VDD.n1225 0.154043
R3436 VDD.n1306 VDD.n1305 0.154043
R3437 VDD.n1235 VDD.n1229 0.154043
R3438 VDD.n1291 VDD.n1290 0.154043
R3439 VDD.n1278 VDD.n1277 0.154043
R3440 VDD.n1243 VDD.n1238 0.154043
R3441 VDD.n1263 VDD.n1262 0.154043
R3442 VDD.n1251 VDD.n1246 0.154043
R3443 VDD.n1014 VDD.n1013 0.154043
R3444 VDD.n1094 VDD.n1093 0.154043
R3445 VDD.n1022 VDD.n1017 0.154043
R3446 VDD.n1079 VDD.n1078 0.154043
R3447 VDD.n1066 VDD.n1065 0.154043
R3448 VDD.n1030 VDD.n1025 0.154043
R3449 VDD.n1051 VDD.n1050 0.154043
R3450 VDD.n1039 VDD.n1033 0.154043
R3451 VDD.n43 VDD.n730 0.152808
R3452 VDD.n728 VDD.n727 0.152808
R3453 VDD.n728 VDD.n726 0.152808
R3454 VDD.n300 VDD.n299 0.0453327
R3455 VDD.n303 VDD.n302 0.0453327
R3456 VDD.n305 VDD.n304 0.0453327
R3457 VDD.n308 VDD.n307 0.0453327
R3458 VDD.n310 VDD.n309 0.0453327
R3459 VDD.n313 VDD.n312 0.0453327
R3460 VDD.n315 VDD.n314 0.0453327
R3461 VDD.n318 VDD.n317 0.0453327
R3462 VDD.n320 VDD.n319 0.0453327
R3463 VDD.n323 VDD.n322 0.0453327
R3464 VDD.n325 VDD.n324 0.0453327
R3465 VDD.n328 VDD.n327 0.0453327
R3466 VDD.n330 VDD.n329 0.0453327
R3467 VDD.n333 VDD.n332 0.0453327
R3468 VDD.n335 VDD.n334 0.0453327
R3469 VDD.n338 VDD.n337 0.0453327
R3470 VDD.n340 VDD.n339 0.0453327
R3471 VDD.n343 VDD.n342 0.0453327
R3472 VDD.n345 VDD.n344 0.0453327
R3473 VDD.n348 VDD.n347 0.0453327
R3474 VDD.n350 VDD.n349 0.0453327
R3475 VDD.n353 VDD.n352 0.0453327
R3476 VDD.n355 VDD.n354 0.0453327
R3477 VDD.n358 VDD.n357 0.0453327
R3478 VDD.n360 VDD.n359 0.0453327
R3479 VDD.n363 VDD.n362 0.0453327
R3480 VDD.n365 VDD.n364 0.0453327
R3481 VDD.n368 VDD.n367 0.0453327
R3482 VDD.n370 VDD.n369 0.0453327
R3483 VDD.n373 VDD.n372 0.0453327
R3484 VDD.n1341 VDD.n1321 0.15205
R3485 VDD.n1403 VDD.n254 0.15205
R3486 VDD.n1582 VDD.n1562 0.15205
R3487 VDD.n1643 VDD.n252 0.15205
R3488 VDD.n1804 VDD.n1784 0.15205
R3489 VDD.n1867 VDD.n250 0.15205
R3490 VDD.n1220 VDD.n1200 0.15205
R3491 VDD.n1282 VDD.n248 0.15205
R3492 VDD.n1008 VDD.n988 0.15205
R3493 VDD.n1070 VDD.n246 0.15205
R3494 VDD.n1332 VDD.n1324 0.149888
R3495 VDD.n1573 VDD.n1565 0.149888
R3496 VDD.n1795 VDD.n1787 0.149888
R3497 VDD.n1211 VDD.n1203 0.149888
R3498 VDD.n999 VDD.n991 0.149888
R3499 VDD.n1315 VDD.n376 0.305255
R3500 VDD.n1424 VDD.n389 0.305255
R3501 VDD.n228 VDD.n1358 0.314697
R3502 VDD.n1396 VDD.n392 0.305255
R3503 VDD.n396 VDD.n1366 0.305255
R3504 VDD.n1381 VDD.n397 0.305255
R3505 VDD.n1556 VDD.n379 0.305255
R3506 VDD.n1664 VDD.n400 0.305255
R3507 VDD.n232 VDD.n1598 0.314697
R3508 VDD.n1636 VDD.n403 0.305255
R3509 VDD.n407 VDD.n1606 0.305255
R3510 VDD.n1621 VDD.n408 0.305255
R3511 VDD.n1778 VDD.n382 0.305255
R3512 VDD.n1888 VDD.n411 0.305255
R3513 VDD.n236 VDD.n1821 0.314697
R3514 VDD.n1860 VDD.n414 0.305255
R3515 VDD.n418 VDD.n1829 0.305255
R3516 VDD.n1845 VDD.n419 0.305255
R3517 VDD.n1194 VDD.n385 0.305255
R3518 VDD.n1303 VDD.n422 0.305255
R3519 VDD.n240 VDD.n1237 0.314697
R3520 VDD.n1275 VDD.n425 0.305255
R3521 VDD.n429 VDD.n1245 0.305255
R3522 VDD.n1260 VDD.n430 0.305255
R3523 VDD.n982 VDD.n388 0.305255
R3524 VDD.n1091 VDD.n433 0.305255
R3525 VDD.n244 VDD.n1024 0.314697
R3526 VDD.n1063 VDD.n436 0.305255
R3527 VDD.n440 VDD.n1032 0.305255
R3528 VDD.n1048 VDD.n441 0.305255
R3529 VDD.n729 VDD.n728 0.147075
R3530 VDD.n1327 VDD.n1326 0.14705
R3531 VDD.n1568 VDD.n1567 0.14705
R3532 VDD.n1790 VDD.n1789 0.14705
R3533 VDD.n1206 VDD.n1205 0.14705
R3534 VDD.n994 VDD.n993 0.14705
R3535 VDD.n74 VDD.n72 0.272137
R3536 VDD.n637 VDD.n1462 0.16205
R3537 VDD.n655 VDD.n1460 0.16205
R3538 VDD.n643 VDD.n1459 0.16205
R3539 VDD.n660 VDD.n1457 0.16205
R3540 VDD.n543 VDD.n541 0.310289
R3541 VDD.n1456 VDD.n596 0.409612
R3542 VDD.n632 VDD.n1455 0.16205
R3543 VDD.n97 VDD.n535 0.309771
R3544 VDD.n679 VDD.n1453 0.16205
R3545 VDD.n665 VDD.n1696 0.16205
R3546 VDD.n668 VDD.n1694 0.16205
R3547 VDD.n659 VDD.n1692 0.16205
R3548 VDD.n667 VDD.n1691 0.16205
R3549 VDD.n613 VDD.n1690 0.16205
R3550 VDD.n610 VDD.n608 0.169888
R3551 VDD.n627 VDD.n1973 0.16205
R3552 VDD.n1962 VDD.n650 0.16205
R3553 VDD.n1953 VDD.n658 0.16205
R3554 VDD.n639 VDD.n1944 0.16205
R3555 VDD.n180 VDD.n178 0.355147
R3556 VDD.n649 VDD.n1111 0.16205
R3557 VDD.n641 VDD.n1110 0.355155
R3558 VDD.n648 VDD.n1109 0.16205
R3559 VDD.n1337 VDD.n1336 0.142118
R3560 VDD.n1578 VDD.n1577 0.142118
R3561 VDD.n1800 VDD.n1799 0.142118
R3562 VDD.n1216 VDD.n1215 0.142118
R3563 VDD.n1004 VDD.n1003 0.142118
R3564 VDD.n1333 VDD.n1332 0.13705
R3565 VDD.n1574 VDD.n1573 0.13705
R3566 VDD.n1796 VDD.n1795 0.13705
R3567 VDD.n1212 VDD.n1211 0.13705
R3568 VDD.n1000 VDD.n999 0.13705
R3569 VDD.n1342 VDD.n1341 0.134888
R3570 VDD.n1583 VDD.n1582 0.134888
R3571 VDD.n1805 VDD.n1804 0.134888
R3572 VDD.n1221 VDD.n1220 0.134888
R3573 VDD.n1009 VDD.n1008 0.134888
R3574 VDD.n1340 VDD.n1339 0.134618
R3575 VDD.n1581 VDD.n1580 0.134618
R3576 VDD.n1803 VDD.n1802 0.134618
R3577 VDD.n1219 VDD.n1218 0.134618
R3578 VDD.n1007 VDD.n1006 0.134618
R3579 VDD.n1490 VDD.n1450 0.133259
R3580 VDD.n1712 VDD.n1685 0.133259
R3581 VDD.n1932 VDD.n1931 0.133259
R3582 VDD.n1132 VDD.n1108 0.133259
R3583 VDD.n776 VDD.n775 0.133259
R3584 VDD.n45 VDD.n720 0.133259
R3585 VDD.n621 VDD.n586 1.90206
R3586 VDD.n620 VDD.n619 1.90206
R3587 VDD.n618 VDD.n617 1.90206
R3588 VDD.n616 VDD.n459 1.90206
R3589 VDD.n615 VDD.n614 1.90206
R3590 VDD.n1717 VDD.t347 1.65237
R3591 VDD.n1495 VDD.t379 1.59934
R3592 VDD.t345 VDD.n1901 1.55361
R3593 VDD.n1137 VDD.t378 1.55361
R3594 VDD.n194 VDD.n193 0.887581
R3595 VDD.n196 VDD.n195 0.887431
R3596 VDD.n173 VDD.n172 0.887431
R3597 VDD.n81 VDD.n80 0.88729
R3598 VDD.n459 VDD.n457 0.668379
R3599 VDD.n1708 VDD.n130 0.664347
R3600 VDD.n1706 VDD.n120 0.664347
R3601 VDD.n1124 VDD.n200 0.664347
R3602 VDD.n1938 VDD.n160 0.653723
R3603 VDD.n117 VDD.n116 0.645601
R3604 VDD.n581 VDD.n40 0.604342
R3605 VDD.n583 VDD.n582 0.60434
R3606 VDD.n163 VDD.n161 0.51969
R3607 VDD.n81 VDD.n79 0.519649
R3608 VDD.n514 VDD.n137 0.519649
R3609 VDD.n510 VDD.n140 0.519649
R3610 VDD.n478 VDD.n157 0.519649
R3611 VDD.n595 VDD.n549 0.519606
R3612 VDD.n461 VDD.n460 0.519606
R3613 VDD.n554 VDD.n553 0.519555
R3614 VDD.n605 VDD.n480 0.519555
R3615 VDD.n543 VDD.n596 0.519536
R3616 VDD.n547 VDD.n88 0.519504
R3617 VDD.n103 VDD.n101 0.519504
R3618 VDD.n120 VDD.n122 0.519504
R3619 VDD.n173 VDD.n171 0.519504
R3620 VDD.n196 VDD.n194 0.519504
R3621 VDD.n99 VDD.n97 0.519501
R3622 VDD.n107 VDD.n105 0.519501
R3623 VDD.n471 VDD.n176 0.519501
R3624 VDD.n597 VDD.n539 0.519454
R3625 VDD.n527 VDD.n526 0.519454
R3626 VDD.n131 VDD.n130 0.273989
R3627 VDD.n512 VDD.n511 0.519454
R3628 VDD.n463 VDD.n607 0.519454
R3629 VDD.n603 VDD.n489 0.519414
R3630 VDD.n518 VDD.n600 0.519403
R3631 VDD.n604 VDD.n482 0.519403
R3632 VDD.n468 VDD.n606 0.519403
R3633 VDD.n473 VDD.n472 0.5194
R3634 VDD.n450 VDD.n200 0.273954
R3635 VDD.n530 VDD.n529 0.519394
R3636 VDD.n144 VDD.n142 0.519394
R3637 VDD.n496 VDD.n147 0.519394
R3638 VDD.n194 VDD.n192 0.519394
R3639 VDD.n594 VDD.n556 0.519208
R3640 VDD.n95 VDD.n96 0.199474
R3641 VDD.n117 VDD.n118 0.199474
R3642 VDD.n599 VDD.n521 0.519208
R3643 VDD.n502 VDD.n501 0.519208
R3644 VDD.n602 VDD.n499 0.519208
R3645 VDD.n487 VDD.n486 0.519208
R3646 VDD.n1131 VDD.n453 0.432547
R3647 VDD.n584 VDD.n587 0.46794
R3648 VDD.n582 VDD.n585 0.46794
R3649 VDD.n458 VDD.n581 0.46794
R3650 VDD.n593 VDD.n592 0.451146
R3651 VDD.n1149 VDD.n590 0.450828
R3652 VDD.n579 VDD.n578 0.450828
R3653 VDD.n1729 VDD.n576 0.450828
R3654 VDD.n1507 VDD.n574 0.450828
R3655 VDD.n612 VDD.n160 0.448327
R3656 VDD.n598 VDD.n525 0.439882
R3657 VDD.n1328 VDD.n561 0.385051
R3658 VDD.n1569 VDD.n563 0.385051
R3659 VDD.n1791 VDD.n565 0.385051
R3660 VDD.n1207 VDD.n567 0.385051
R3661 VDD.n995 VDD.n569 0.385051
R3662 VDD.n1323 VDD.n1322 0.132118
R3663 VDD.n1564 VDD.n1563 0.132118
R3664 VDD.n1786 VDD.n1785 0.132118
R3665 VDD.n1202 VDD.n1201 0.132118
R3666 VDD.n990 VDD.n989 0.132118
R3667 VDD.n1330 VDD.n1329 0.129618
R3668 VDD.n1434 VDD.n669 0.0651609
R3669 VDD.n301 VDD.n670 0.0651609
R3670 VDD.n1419 VDD.n671 0.0651609
R3671 VDD.n673 VDD.n672 0.1666
R3672 VDD.n1391 VDD.n674 0.0651609
R3673 VDD.n676 VDD.n675 0.1666
R3674 VDD.n1571 VDD.n1570 0.129618
R3675 VDD.n1674 VDD.n680 0.0651609
R3676 VDD.n682 VDD.n681 0.1666
R3677 VDD.n1659 VDD.n683 0.0651609
R3678 VDD.n685 VDD.n684 0.1666
R3679 VDD.n686 VDD.n1629 0.1666
R3680 VDD.n688 VDD.n687 0.1666
R3681 VDD.n1793 VDD.n1792 0.129618
R3682 VDD.n1898 VDD.n689 0.0651609
R3683 VDD.n331 VDD.n690 0.0651609
R3684 VDD.n1883 VDD.n691 0.0651609
R3685 VDD.n693 VDD.n692 0.1666
R3686 VDD.n694 VDD.n1853 0.1666
R3687 VDD.n341 VDD.n695 0.0651609
R3688 VDD.n1209 VDD.n1208 0.129618
R3689 VDD.n697 VDD.n1311 0.1666
R3690 VDD.n346 VDD.n698 0.0651609
R3691 VDD.n1298 VDD.n699 0.0651609
R3692 VDD.n701 VDD.n700 0.1666
R3693 VDD.n702 VDD.n1268 0.1666
R3694 VDD.n704 VDD.n703 0.1666
R3695 VDD.n997 VDD.n996 0.129618
R3696 VDD.n705 VDD.n1099 0.1666
R3697 VDD.n707 VDD.n706 0.1666
R3698 VDD.n708 VDD.n1084 0.1666
R3699 VDD.n710 VDD.n709 0.1666
R3700 VDD.n711 VDD.n1056 0.1666
R3701 VDD.n371 VDD.n712 0.0651609
R3702 VDD.n1349 VDD.n1348 0.12922
R3703 VDD.n1434 VDD.n1433 0.12922
R3704 VDD.n1423 VDD.n1422 0.12922
R3705 VDD.n301 VDD.n1421 0.12922
R3706 VDD.n227 VDD.n225 0.12922
R3707 VDD.n261 VDD.n1420 0.12922
R3708 VDD.n1419 VDD.n1418 0.12922
R3709 VDD.n1395 VDD.n1394 0.12922
R3710 VDD.n306 VDD.n1393 0.12922
R3711 VDD.n264 VDD.n1392 0.12922
R3712 VDD.n1391 VDD.n1390 0.12922
R3713 VDD.n1380 VDD.n1379 0.12922
R3714 VDD.n311 VDD.n1378 0.12922
R3715 VDD.n1590 VDD.n1589 0.12922
R3716 VDD.n1674 VDD.n1673 0.12922
R3717 VDD.n1663 VDD.n1662 0.12922
R3718 VDD.n316 VDD.n1661 0.12922
R3719 VDD.n231 VDD.n229 0.12922
R3720 VDD.n269 VDD.n1660 0.12922
R3721 VDD.n1659 VDD.n1658 0.12922
R3722 VDD.n1635 VDD.n1634 0.12922
R3723 VDD.n321 VDD.n1633 0.12922
R3724 VDD.n272 VDD.n1632 0.12922
R3725 VDD.n1631 VDD.n1630 0.12922
R3726 VDD.n1620 VDD.n1619 0.12922
R3727 VDD.n326 VDD.n1618 0.12922
R3728 VDD.n1812 VDD.n1811 0.12922
R3729 VDD.n1898 VDD.n1897 0.12922
R3730 VDD.n1887 VDD.n1886 0.12922
R3731 VDD.n331 VDD.n1885 0.12922
R3732 VDD.n235 VDD.n233 0.12922
R3733 VDD.n277 VDD.n1884 0.12922
R3734 VDD.n1883 VDD.n1882 0.12922
R3735 VDD.n1859 VDD.n1858 0.12922
R3736 VDD.n336 VDD.n1857 0.12922
R3737 VDD.n280 VDD.n1856 0.12922
R3738 VDD.n1855 VDD.n1854 0.12922
R3739 VDD.n1844 VDD.n1843 0.12922
R3740 VDD.n341 VDD.n1842 0.12922
R3741 VDD.n1228 VDD.n1227 0.12922
R3742 VDD.n1313 VDD.n1312 0.12922
R3743 VDD.n1302 VDD.n1301 0.12922
R3744 VDD.n346 VDD.n1300 0.12922
R3745 VDD.n239 VDD.n237 0.12922
R3746 VDD.n285 VDD.n1299 0.12922
R3747 VDD.n1298 VDD.n1297 0.12922
R3748 VDD.n1274 VDD.n1273 0.12922
R3749 VDD.n351 VDD.n1272 0.12922
R3750 VDD.n288 VDD.n1271 0.12922
R3751 VDD.n1270 VDD.n1269 0.12922
R3752 VDD.n1259 VDD.n1258 0.12922
R3753 VDD.n356 VDD.n1257 0.12922
R3754 VDD.n1016 VDD.n1015 0.12922
R3755 VDD.n1101 VDD.n1100 0.12922
R3756 VDD.n1090 VDD.n1089 0.12922
R3757 VDD.n361 VDD.n1088 0.12922
R3758 VDD.n243 VDD.n241 0.12922
R3759 VDD.n293 VDD.n1087 0.12922
R3760 VDD.n1086 VDD.n1085 0.12922
R3761 VDD.n1062 VDD.n1061 0.12922
R3762 VDD.n366 VDD.n1060 0.12922
R3763 VDD.n296 VDD.n1059 0.12922
R3764 VDD.n1058 VDD.n1057 0.12922
R3765 VDD.n1047 VDD.n1046 0.12922
R3766 VDD.n371 VDD.n1045 0.12922
R3767 VDD.n714 VDD.n713 0.127973
R3768 VDD.n1330 VDD.n1328 0.127118
R3769 VDD.n1571 VDD.n1569 0.127118
R3770 VDD.n1793 VDD.n1791 0.127118
R3771 VDD.n1209 VDD.n1207 0.127118
R3772 VDD.n997 VDD.n995 0.127118
R3773 VDD.n1475 VDD.n657 0.31013
R3774 VDD.n529 VDD.n532 0.310312
R3775 VDD.n521 VDD.n519 0.310312
R3776 VDD.n511 VDD.n515 0.310446
R3777 VDD.n506 VDD.n4 0.134478
R3778 VDD.n651 VDD.n142 0.309928
R3779 VDD.n29 VDD.n489 0.723331
R3780 VDD.n1994 VDD.n603 0.409756
R3781 VDD.n652 VDD.n1958 0.309928
R3782 VDD.n471 VDD.n174 0.633015
R3783 VDD.n1117 VDD.n630 0.310312
R3784 VDD.n1485 VDD.n1484 0.124618
R3785 VDD.n786 VDD.n783 0.124618
R3786 VDD.n1486 VDD.n1485 0.122118
R3787 VDD.n783 VDD.n782 0.122118
R3788 VDD.n220 VDD.n677 0.215065
R3789 VDD.n696 VDD.n1975 0.215065
R3790 VDD.n835 VDD.n834 0.120868
R3791 VDD.n1999 VDD.n1998 0.119888
R3792 VDD.n1333 VDD.n1331 0.119888
R3793 VDD.n1574 VDD.n1572 0.119888
R3794 VDD.n1796 VDD.n1794 0.119888
R3795 VDD.n1212 VDD.n1210 0.119888
R3796 VDD.n1000 VDD.n998 0.119888
R3797 VDD.n1331 VDD.n1325 0.119618
R3798 VDD.n1572 VDD.n1566 0.119618
R3799 VDD.n1794 VDD.n1788 0.119618
R3800 VDD.n1210 VDD.n1204 0.119618
R3801 VDD.n998 VDD.n992 0.119618
R3802 VDD.n1975 VDD.n1974 0.118368
R3803 VDD.n915 VDD.n914 0.118368
R3804 VDD.n1467 VDD.n1466 0.117388
R3805 VDD.n1473 VDD.n1472 0.117388
R3806 VDD.n1477 VDD.n1476 0.117388
R3807 VDD.n222 VDD.n626 0.211315
R3808 VDD.n1480 VDD.n1479 0.117388
R3809 VDD.n1984 VDD.n1983 0.117388
R3810 VDD.n1992 VDD.n1991 0.117388
R3811 VDD.n1996 VDD.n1995 0.117388
R3812 VDD.n1955 VDD.n1954 0.117388
R3813 VDD.n1119 VDD.n1118 0.117388
R3814 VDD.n1123 VDD.n1122 0.117388
R3815 VDD.n1127 VDD.n1126 0.117388
R3816 VDD.n464 VDD.n1129 0.117388
R3817 VDD.n978 VDD.n977 0.117388
R3818 VDD.n966 VDD.n965 0.117388
R3819 VDD.n954 VDD.n953 0.117388
R3820 VDD.n942 VDD.n941 0.117388
R3821 VDD.n936 VDD.n935 0.117388
R3822 VDD.n918 VDD.n917 0.117388
R3823 VDD.n910 VDD.n909 0.117388
R3824 VDD.n904 VDD.n903 0.117388
R3825 VDD.n886 VDD.n885 0.117388
R3826 VDD.n874 VDD.n873 0.117388
R3827 VDD.n868 VDD.n867 0.117388
R3828 VDD.n856 VDD.n855 0.117388
R3829 VDD.n850 VDD.n849 0.117388
R3830 VDD.n838 VDD.n837 0.117388
R3831 VDD.n831 VDD.n830 0.117388
R3832 VDD.n825 VDD.n824 0.117388
R3833 VDD.n819 VDD.n818 0.117388
R3834 VDD.n813 VDD.n812 0.117388
R3835 VDD.n807 VDD.n806 0.117388
R3836 VDD.n795 VDD.n794 0.117388
R3837 VDD.n789 VDD.n788 0.117388
R3838 VDD.n2001 VDD.n2000 0.11705
R3839 VDD.n972 VDD.n971 0.11705
R3840 VDD.n960 VDD.n959 0.11705
R3841 VDD.n948 VDD.n947 0.11705
R3842 VDD.n930 VDD.n929 0.11705
R3843 VDD.n924 VDD.n923 0.11705
R3844 VDD.n898 VDD.n897 0.11705
R3845 VDD.n892 VDD.n891 0.11705
R3846 VDD.n880 VDD.n879 0.11705
R3847 VDD.n862 VDD.n861 0.11705
R3848 VDD.n844 VDD.n843 0.11705
R3849 VDD.n801 VDD.n800 0.11705
R3850 VDD.n1484 VDD.n1483 0.114888
R3851 VDD.n787 VDD.n786 0.114888
R3852 VDD.n1338 VDD.n1337 0.114618
R3853 VDD.n1579 VDD.n1578 0.114618
R3854 VDD.n1801 VDD.n1800 0.114618
R3855 VDD.n1217 VDD.n1216 0.114618
R3856 VDD.n1005 VDD.n1004 0.114618
R3857 VDD.n1345 VDD.n1344 0.1133
R3858 VDD.n1429 VDD.n1428 0.1133
R3859 VDD.n1352 VDD.n1351 0.1133
R3860 VDD.n1414 VDD.n1413 0.1133
R3861 VDD.n1401 VDD.n1400 0.1133
R3862 VDD.n1361 VDD.n1360 0.1133
R3863 VDD.n1386 VDD.n1385 0.1133
R3864 VDD.n1369 VDD.n1368 0.1133
R3865 VDD.n1586 VDD.n1585 0.1133
R3866 VDD.n1669 VDD.n1668 0.1133
R3867 VDD.n1593 VDD.n1592 0.1133
R3868 VDD.n1654 VDD.n1653 0.1133
R3869 VDD.n1641 VDD.n1640 0.1133
R3870 VDD.n1601 VDD.n1600 0.1133
R3871 VDD.n1626 VDD.n1625 0.1133
R3872 VDD.n1609 VDD.n1608 0.1133
R3873 VDD.n1808 VDD.n1807 0.1133
R3874 VDD.n1893 VDD.n1892 0.1133
R3875 VDD.n1815 VDD.n1814 0.1133
R3876 VDD.n1878 VDD.n1877 0.1133
R3877 VDD.n1865 VDD.n1864 0.1133
R3878 VDD.n1824 VDD.n1823 0.1133
R3879 VDD.n1850 VDD.n1849 0.1133
R3880 VDD.n1832 VDD.n1831 0.1133
R3881 VDD.n1224 VDD.n1223 0.1133
R3882 VDD.n1308 VDD.n1307 0.1133
R3883 VDD.n1231 VDD.n1230 0.1133
R3884 VDD.n1293 VDD.n1292 0.1133
R3885 VDD.n1280 VDD.n1279 0.1133
R3886 VDD.n1240 VDD.n1239 0.1133
R3887 VDD.n1265 VDD.n1264 0.1133
R3888 VDD.n1248 VDD.n1247 0.1133
R3889 VDD.n1012 VDD.n1011 0.1133
R3890 VDD.n1096 VDD.n1095 0.1133
R3891 VDD.n1019 VDD.n1018 0.1133
R3892 VDD.n1081 VDD.n1080 0.1133
R3893 VDD.n1068 VDD.n1067 0.1133
R3894 VDD.n1027 VDD.n1026 0.1133
R3895 VDD.n1053 VDD.n1052 0.1133
R3896 VDD.n1035 VDD.n1034 0.1133
R3897 VDD.n1329 VDD.n1327 0.109888
R3898 VDD.n1570 VDD.n1568 0.109888
R3899 VDD.n1792 VDD.n1790 0.109888
R3900 VDD.n1208 VDD.n1206 0.109888
R3901 VDD.n996 VDD.n994 0.109888
R3902 VDD.n1324 VDD.n1323 0.10705
R3903 VDD.n1565 VDD.n1564 0.10705
R3904 VDD.n1787 VDD.n1786 0.10705
R3905 VDD.n1203 VDD.n1202 0.10705
R3906 VDD.n991 VDD.n990 0.10705
R3907 VDD.n1339 VDD.n1321 0.104888
R3908 VDD.n1580 VDD.n1562 0.104888
R3909 VDD.n1802 VDD.n1784 0.104888
R3910 VDD.n1218 VDD.n1200 0.104888
R3911 VDD.n1006 VDD.n988 0.104888
R3912 VDD.n1404 VDD.n1403 0.101138
R3913 VDD.n1644 VDD.n1643 0.101138
R3914 VDD.n1868 VDD.n1867 0.101138
R3915 VDD.n1283 VDD.n1282 0.101138
R3916 VDD.n1071 VDD.n1070 0.101138
R3917 VDD.t345 VDD.t474 15.0158
R3918 VDD.n34 VDD.n6 0.336945
R3919 VDD.n44 VDD.t464 15.0172
R3920 VDD.n1336 VDD.n1335 0.0970502
R3921 VDD.n1577 VDD.n1576 0.0970502
R3922 VDD.n1799 VDD.n1798 0.0970502
R3923 VDD.n1215 VDD.n1214 0.0970502
R3924 VDD.n1003 VDD.n1002 0.0970502
R3925 VDD.t496 VDD.n10 15.039
R3926 VDD.t485 VDD.n39 15.039
R3927 VDD.n44 VDD.n24 0.0627591
R3928 VDD.n1326 VDD.n1325 0.0921176
R3929 VDD.n1567 VDD.n1566 0.0921176
R3930 VDD.n1789 VDD.n1788 0.0921176
R3931 VDD.n1205 VDD.n1204 0.0921176
R3932 VDD.n993 VDD.n992 0.0921176
R3933 VDD.n1316 VDD.n1315 0.0905
R3934 VDD.n1425 VDD.n1424 0.0905
R3935 VDD.n1358 VDD.n1357 0.0905
R3936 VDD.n1410 VDD.n1409 0.0905
R3937 VDD.n1397 VDD.n1396 0.0905
R3938 VDD.n1366 VDD.n1365 0.0905
R3939 VDD.n1382 VDD.n1381 0.0905
R3940 VDD.n1374 VDD.n1373 0.0905
R3941 VDD.n1557 VDD.n1556 0.0905
R3942 VDD.n1665 VDD.n1664 0.0905
R3943 VDD.n1598 VDD.n1597 0.0905
R3944 VDD.n1650 VDD.n1649 0.0905
R3945 VDD.n1637 VDD.n1636 0.0905
R3946 VDD.n1606 VDD.n1605 0.0905
R3947 VDD.n1622 VDD.n1621 0.0905
R3948 VDD.n1614 VDD.n1613 0.0905
R3949 VDD.n1779 VDD.n1778 0.0905
R3950 VDD.n1889 VDD.n1888 0.0905
R3951 VDD.n1821 VDD.n1820 0.0905
R3952 VDD.n1874 VDD.n1873 0.0905
R3953 VDD.n1861 VDD.n1860 0.0905
R3954 VDD.n1829 VDD.n1828 0.0905
R3955 VDD.n1846 VDD.n1845 0.0905
R3956 VDD.n1838 VDD.n1837 0.0905
R3957 VDD.n1195 VDD.n1194 0.0905
R3958 VDD.n1304 VDD.n1303 0.0905
R3959 VDD.n1237 VDD.n1236 0.0905
R3960 VDD.n1289 VDD.n1288 0.0905
R3961 VDD.n1276 VDD.n1275 0.0905
R3962 VDD.n1245 VDD.n1244 0.0905
R3963 VDD.n1261 VDD.n1260 0.0905
R3964 VDD.n1253 VDD.n1252 0.0905
R3965 VDD.n983 VDD.n982 0.0905
R3966 VDD.n1092 VDD.n1091 0.0905
R3967 VDD.n1024 VDD.n1023 0.0905
R3968 VDD.n1077 VDD.n1076 0.0905
R3969 VDD.n1064 VDD.n1063 0.0905
R3970 VDD.n1032 VDD.n1031 0.0905
R3971 VDD.n1049 VDD.n1048 0.0905
R3972 VDD.n1041 VDD.n1040 0.0905
R3973 VDD.n1432 VDD.n1431 0.0896176
R3974 VDD.n1355 VDD.n1353 0.0896176
R3975 VDD.n1417 VDD.n1416 0.0896176
R3976 VDD.n1363 VDD.n672 0.0896176
R3977 VDD.n1389 VDD.n1388 0.0896176
R3978 VDD.n1371 VDD.n675 0.0896176
R3979 VDD.n1672 VDD.n1671 0.0896176
R3980 VDD.n1595 VDD.n681 0.0896176
R3981 VDD.n1657 VDD.n1656 0.0896176
R3982 VDD.n1603 VDD.n684 0.0896176
R3983 VDD.n1629 VDD.n1628 0.0896176
R3984 VDD.n1611 VDD.n687 0.0896176
R3985 VDD.n1896 VDD.n1895 0.0896176
R3986 VDD.n1818 VDD.n1816 0.0896176
R3987 VDD.n1881 VDD.n1880 0.0896176
R3988 VDD.n1826 VDD.n692 0.0896176
R3989 VDD.n1853 VDD.n1852 0.0896176
R3990 VDD.n1835 VDD.n1833 0.0896176
R3991 VDD.n1311 VDD.n1310 0.0896176
R3992 VDD.n1234 VDD.n1232 0.0896176
R3993 VDD.n1296 VDD.n1295 0.0896176
R3994 VDD.n1242 VDD.n700 0.0896176
R3995 VDD.n1268 VDD.n1267 0.0896176
R3996 VDD.n1250 VDD.n703 0.0896176
R3997 VDD.n1099 VDD.n1098 0.0896176
R3998 VDD.n1021 VDD.n706 0.0896176
R3999 VDD.n1084 VDD.n1083 0.0896176
R4000 VDD.n1029 VDD.n709 0.0896176
R4001 VDD.n1056 VDD.n1055 0.0896176
R4002 VDD.n1038 VDD.n1036 0.0896176
R4003 VDD.n1533 VDD.n1532 0.0883676
R4004 VDD.n1755 VDD.n1754 0.0883676
R4005 VDD.n1971 VDD.n1919 0.0883676
R4006 VDD.n1175 VDD.n1174 0.0883676
R4007 VDD.n911 VDD.n753 0.0883676
R4008 VDD.n1492 VDD.n61 0.088
R4009 VDD.n1714 VDD.n64 0.088
R4010 VDD.n1936 VDD.n65 0.088
R4011 VDD.n1134 VDD.n69 0.088
R4012 VDD.n784 VDD.n70 0.088
R4013 VDD.n1534 VDD.n1533 0.0858676
R4014 VDD.n1756 VDD.n1755 0.0858676
R4015 VDD.n1920 VDD.n1919 0.0858676
R4016 VDD.n1176 VDD.n1175 0.0858676
R4017 VDD.n753 VDD.n752 0.0858676
R4018 VDD.n1346 VDD.n1316 0.08425
R4019 VDD.n1426 VDD.n1425 0.08425
R4020 VDD.n1357 VDD.n1356 0.08425
R4021 VDD.n1411 VDD.n1410 0.08425
R4022 VDD.n1398 VDD.n1397 0.08425
R4023 VDD.n1365 VDD.n1364 0.08425
R4024 VDD.n1383 VDD.n1382 0.08425
R4025 VDD.n1373 VDD.n1372 0.08425
R4026 VDD.n1587 VDD.n1557 0.08425
R4027 VDD.n1666 VDD.n1665 0.08425
R4028 VDD.n1597 VDD.n1596 0.08425
R4029 VDD.n1651 VDD.n1650 0.08425
R4030 VDD.n1638 VDD.n1637 0.08425
R4031 VDD.n1605 VDD.n1604 0.08425
R4032 VDD.n1623 VDD.n1622 0.08425
R4033 VDD.n1613 VDD.n1612 0.08425
R4034 VDD.n1809 VDD.n1779 0.08425
R4035 VDD.n1890 VDD.n1889 0.08425
R4036 VDD.n1820 VDD.n1819 0.08425
R4037 VDD.n1875 VDD.n1874 0.08425
R4038 VDD.n1862 VDD.n1861 0.08425
R4039 VDD.n1828 VDD.n1827 0.08425
R4040 VDD.n1847 VDD.n1846 0.08425
R4041 VDD.n1837 VDD.n1836 0.08425
R4042 VDD.n1225 VDD.n1195 0.08425
R4043 VDD.n1305 VDD.n1304 0.08425
R4044 VDD.n1236 VDD.n1235 0.08425
R4045 VDD.n1290 VDD.n1289 0.08425
R4046 VDD.n1277 VDD.n1276 0.08425
R4047 VDD.n1244 VDD.n1243 0.08425
R4048 VDD.n1262 VDD.n1261 0.08425
R4049 VDD.n1252 VDD.n1251 0.08425
R4050 VDD.n1013 VDD.n983 0.08425
R4051 VDD.n1093 VDD.n1092 0.08425
R4052 VDD.n1023 VDD.n1022 0.08425
R4053 VDD.n1078 VDD.n1077 0.08425
R4054 VDD.n1065 VDD.n1064 0.08425
R4055 VDD.n1031 VDD.n1030 0.08425
R4056 VDD.n1050 VDD.n1049 0.08425
R4057 VDD.n1040 VDD.n1039 0.08425
R4058 VDD.n1431 VDD.n1430 0.0821176
R4059 VDD.n1355 VDD.n1354 0.0821176
R4060 VDD.n1416 VDD.n1415 0.0821176
R4061 VDD.n1363 VDD.n1362 0.0821176
R4062 VDD.n1388 VDD.n1387 0.0821176
R4063 VDD.n1371 VDD.n1370 0.0821176
R4064 VDD.n1671 VDD.n1670 0.0821176
R4065 VDD.n1595 VDD.n1594 0.0821176
R4066 VDD.n1656 VDD.n1655 0.0821176
R4067 VDD.n1603 VDD.n1602 0.0821176
R4068 VDD.n1628 VDD.n1627 0.0821176
R4069 VDD.n1611 VDD.n1610 0.0821176
R4070 VDD.n1895 VDD.n1894 0.0821176
R4071 VDD.n1818 VDD.n1817 0.0821176
R4072 VDD.n1880 VDD.n1879 0.0821176
R4073 VDD.n1826 VDD.n1825 0.0821176
R4074 VDD.n1852 VDD.n1851 0.0821176
R4075 VDD.n1835 VDD.n1834 0.0821176
R4076 VDD.n1310 VDD.n1309 0.0821176
R4077 VDD.n1234 VDD.n1233 0.0821176
R4078 VDD.n1295 VDD.n1294 0.0821176
R4079 VDD.n1242 VDD.n1241 0.0821176
R4080 VDD.n1267 VDD.n1266 0.0821176
R4081 VDD.n1250 VDD.n1249 0.0821176
R4082 VDD.n1098 VDD.n1097 0.0821176
R4083 VDD.n1021 VDD.n1020 0.0821176
R4084 VDD.n1083 VDD.n1082 0.0821176
R4085 VDD.n1029 VDD.n1028 0.0821176
R4086 VDD.n1055 VDD.n1054 0.0821176
R4087 VDD.n1038 VDD.n1037 0.0821176
R4088 VDD.n1334 VDD.n1322 0.0796176
R4089 VDD.n1575 VDD.n1563 0.0796176
R4090 VDD.n1797 VDD.n1785 0.0796176
R4091 VDD.n1213 VDD.n1201 0.0796176
R4092 VDD.n1001 VDD.n989 0.0796176
R4093 VDD.n1340 VDD.n1338 0.0771176
R4094 VDD.n556 VDD.n554 0.40959
R4095 VDD.n594 VDD.n1463 0.410004
R4096 VDD.n79 VDD.n551 0.309692
R4097 VDD.n549 VDD.n82 0.633204
R4098 VDD.n595 VDD.n1462 0.409544
R4099 VDD.n1465 VDD.n644 0.310147
R4100 VDD.n663 VDD.n1459 0.310071
R4101 VDD.n547 VDD.n545 0.309837
R4102 VDD.n1471 VDD.n633 0.309837
R4103 VDD.n597 VDD.n1455 0.40971
R4104 VDD.n1478 VDD.n96 0.651398
R4105 VDD.n1488 VDD.n1487 0.0771176
R4106 VDD.n1491 VDD.n1490 0.0771176
R4107 VDD.n1581 VDD.n1579 0.0771176
R4108 VDD.n14 VDD.n1699 0.719542
R4109 VDD.n105 VDD.n527 0.40971
R4110 VDD.n656 VDD.n1697 0.309837
R4111 VDD.n628 VDD.n1696 0.310071
R4112 VDD.n118 VDD.n1693 0.651398
R4113 VDD.n95 VDD.n94 0.645601
R4114 VDD.n642 VDD.n1692 0.310071
R4115 VDD.n518 VDD.n131 0.595208
R4116 VDD.n600 VDD.n1690 0.409773
R4117 VDD.n510 VDD.n508 0.309837
R4118 VDD.n661 VDD.n1686 0.310071
R4119 VDD.n1713 VDD.n1712 0.0771176
R4120 VDD.n1803 VDD.n1801 0.0771176
R4121 VDD.n504 VDD.n4 0.700291
R4122 VDD.n501 VDD.n601 0.410004
R4123 VDD.n1990 VDD.n602 0.410004
R4124 VDD.n1974 VDD.n1973 0.0771176
R4125 VDD.n496 VDD.n494 0.309692
R4126 VDD.n492 VDD.n490 0.309837
R4127 VDD.n666 VDD.n1962 0.309837
R4128 VDD.n631 VDD.n1953 0.310071
R4129 VDD.n622 VDD.n487 0.309903
R4130 VDD.n623 VDD.n482 0.309837
R4131 VDD.n604 VDD.n1944 0.409773
R4132 VDD.n638 VDD.n480 0.309692
R4133 VDD.n605 VDD.n478 0.40959
R4134 VDD.n572 VDD.n1934 0.309557
R4135 VDD.n1931 VDD.n1899 0.0771176
R4136 VDD.n1219 VDD.n1217 0.0771176
R4137 VDD.n171 VDD.n473 0.409776
R4138 VDD.n468 VDD.n197 0.633039
R4139 VDD.n1469 VDD.n86 0.571813
R4140 VDD.n606 VDD.n1111 0.409773
R4141 VDD.n1121 VDD.n641 0.309692
R4142 VDD.n1125 VDD.n450 0.595268
R4143 VDD.n208 VDD.n207 0.5757
R4144 VDD.n1458 VDD.n89 0.531015
R4145 VDD.n1481 VDD.n100 0.531023
R4146 VDD.n1482 VDD.n104 0.531015
R4147 VDD.n1701 VDD.n108 0.531023
R4148 VDD.n158 VDD.n1938 0.530922
R4149 VDD.n1435 VDD.n72 0.540806
R4150 VDD.n206 VDD.n205 0.506493
R4151 VDD.n257 VDD.n610 0.498337
R4152 VDD.n1342 VDD.n218 0.493774
R4153 VDD.n1583 VDD.n216 0.493774
R4154 VDD.n1805 VDD.n214 0.493774
R4155 VDD.n1221 VDD.n212 0.493774
R4156 VDD.n1009 VDD.n210 0.493774
R4157 VDD.n254 VDD.n253 0.484477
R4158 VDD.n252 VDD.n251 0.484477
R4159 VDD.n250 VDD.n249 0.484477
R4160 VDD.n248 VDD.n247 0.484477
R4161 VDD.n246 VDD.n245 0.484477
R4162 VDD.n94 VDD.n222 0.477174
R4163 VDD.n116 VDD.n224 0.473424
R4164 VDD.n83 VDD.n220 0.473424
R4165 VDD.n184 VDD.n183 0.472594
R4166 VDD.n243 VDD.n242 0.456429
R4167 VDD.n239 VDD.n238 0.456429
R4168 VDD.n235 VDD.n234 0.456429
R4169 VDD.n231 VDD.n230 0.456429
R4170 VDD.n227 VDD.n226 0.456429
R4171 VDD.n387 VDD.n386 0.439068
R4172 VDD.n384 VDD.n383 0.439068
R4173 VDD.n381 VDD.n380 0.439068
R4174 VDD.n378 VDD.n377 0.439068
R4175 VDD.n375 VDD.n374 0.439068
R4176 VDD.n443 VDD.n442 0.438917
R4177 VDD.n295 VDD.n439 0.438917
R4178 VDD.n438 VDD.n437 0.438917
R4179 VDD.n435 VDD.n434 0.438917
R4180 VDD.n432 VDD.n431 0.438917
R4181 VDD.n287 VDD.n428 0.438917
R4182 VDD.n427 VDD.n426 0.438917
R4183 VDD.n424 VDD.n423 0.438917
R4184 VDD.n421 VDD.n420 0.438917
R4185 VDD.n279 VDD.n417 0.438917
R4186 VDD.n416 VDD.n415 0.438917
R4187 VDD.n413 VDD.n412 0.438917
R4188 VDD.n410 VDD.n409 0.438917
R4189 VDD.n271 VDD.n406 0.438917
R4190 VDD.n405 VDD.n404 0.438917
R4191 VDD.n402 VDD.n401 0.438917
R4192 VDD.n399 VDD.n398 0.438917
R4193 VDD.n263 VDD.n395 0.438917
R4194 VDD.n394 VDD.n393 0.438917
R4195 VDD.n391 VDD.n390 0.438917
R4196 VDD.n1110 VDD.n446 0.432689
R4197 VDD.n1128 VDD.n625 0.309837
R4198 VDD.n460 VDD.n465 0.310071
R4199 VDD.n463 VDD.n461 0.409544
R4200 VDD.n607 VDD.n1109 0.40971
R4201 VDD.n1133 VDD.n1132 0.0771176
R4202 VDD.n1007 VDD.n1005 0.0771176
R4203 VDD.n775 VDD.n773 0.0771176
R4204 VDD.n914 VDD.n913 0.0771176
R4205 VDD.n834 VDD.n833 0.0771176
R4206 VDD.n779 VDD.n778 0.0771176
R4207 VDD.n1434 VDD.n299 0.181325
R4208 VDD.n302 VDD.n301 0.181325
R4209 VDD.n1419 VDD.n304 0.181325
R4210 VDD.n307 VDD.n306 0.181325
R4211 VDD.n1391 VDD.n309 0.181325
R4212 VDD.n312 VDD.n311 0.181325
R4213 VDD.n1674 VDD.n314 0.181325
R4214 VDD.n317 VDD.n316 0.181325
R4215 VDD.n1659 VDD.n319 0.181325
R4216 VDD.n322 VDD.n321 0.181325
R4217 VDD.n1631 VDD.n324 0.181325
R4218 VDD.n327 VDD.n326 0.181325
R4219 VDD.n1898 VDD.n329 0.181325
R4220 VDD.n332 VDD.n331 0.181325
R4221 VDD.n1883 VDD.n334 0.181325
R4222 VDD.n337 VDD.n336 0.181325
R4223 VDD.n1855 VDD.n339 0.181325
R4224 VDD.n342 VDD.n341 0.181325
R4225 VDD.n1313 VDD.n344 0.181325
R4226 VDD.n347 VDD.n346 0.181325
R4227 VDD.n1298 VDD.n349 0.181325
R4228 VDD.n352 VDD.n351 0.181325
R4229 VDD.n1270 VDD.n354 0.181325
R4230 VDD.n357 VDD.n356 0.181325
R4231 VDD.n1101 VDD.n359 0.181325
R4232 VDD.n362 VDD.n361 0.181325
R4233 VDD.n1086 VDD.n364 0.181325
R4234 VDD.n367 VDD.n366 0.181325
R4235 VDD.n1058 VDD.n369 0.181325
R4236 VDD.n372 VDD.n371 0.181325
R4237 VDD.n558 VDD.n557 0.354405
R4238 VDD.n647 VDD.n1458 0.354405
R4239 VDD.n541 VDD.n540 0.354547
R4240 VDD.n636 VDD.n1452 0.354547
R4241 VDD.n60 VDD.n59 0.122118
R4242 VDD.n646 VDD.n1695 0.354405
R4243 VDD.n523 VDD.n522 0.354405
R4244 VDD.n63 VDD.n62 0.122118
R4245 VDD.n1935 VDD.n66 0.122118
R4246 VDD.n205 VDD.n204 0.16955
R4247 VDD.n68 VDD.n67 0.122118
R4248 VDD.n780 VDD.n71 0.122118
R4249 VDD.n185 VDD.n184 0.105263
R4250 VDD.n718 VDD.n24 0.112835
R4251 VDD.n152 VDD.n151 0.181847
R4252 VDD.n75 VDD.n557 0.390179
R4253 VDD.n1464 VDD.n629 0.117388
R4254 VDD.n550 VDD.n78 0.432689
R4255 VDD.n637 VDD.n1461 0.117388
R4256 VDD.n1468 VDD.n655 0.117388
R4257 VDD.n544 VDD.n643 0.117388
R4258 VDD.n660 VDD.n540 0.117388
R4259 VDD.n1470 VDD.n678 0.117388
R4260 VDD.n1474 VDD.n632 0.117388
R4261 VDD.n679 VDD.n1452 0.117388
R4262 VDD.n1487 VDD.n1486 0.0696176
R4263 VDD.n59 VDD.n1491 0.0696176
R4264 VDD.n1700 VDD.n664 0.117388
R4265 VDD.n111 VDD.n1698 0.432689
R4266 VDD.n1702 VDD.n114 0.432569
R4267 VDD.n1703 VDD.n662 0.117388
R4268 VDD.n665 VDD.n1695 0.117388
R4269 VDD.n668 VDD.n522 0.117388
R4270 VDD.n1704 VDD.n635 0.117388
R4271 VDD.n1705 VDD.n659 0.117388
R4272 VDD.n1706 VDD.n667 0.117388
R4273 VDD.n1707 VDD.n123 0.531015
R4274 VDD.n1708 VDD.n128 0.432689
R4275 VDD.n1709 VDD.n613 0.117388
R4276 VDD.n1710 VDD.n134 0.432689
R4277 VDD.n135 VDD.n1689 0.229937
R4278 VDD.n138 VDD.n1688 0.530922
R4279 VDD.n507 VDD.n654 0.117388
R4280 VDD.n1711 VDD.n141 0.530922
R4281 VDD.n608 VDD.n640 0.117388
R4282 VDD.n62 VDD.n1713 0.0696176
R4283 VDD.n145 VDD.n1976 0.531102
R4284 VDD.n493 VDD.n627 0.117388
R4285 VDD.n1993 VDD.n148 0.531102
R4286 VDD.n650 VDD.n1959 0.117388
R4287 VDD.n658 VDD.n1950 0.117388
R4288 VDD.n155 VDD.n1946 0.432673
R4289 VDD.n1997 VDD.n639 0.117388
R4290 VDD.n1935 VDD.n1899 0.0696176
R4291 VDD.n1113 VDD.n164 0.530887
R4292 VDD.n1114 VDD.n167 0.432451
R4293 VDD.n178 VDD.n177 0.531023
R4294 VDD.n151 VDD.n150 0.475094
R4295 VDD.n1454 VDD.n92 0.432394
R4296 VDD.n135 VDD.n125 0.448031
R4297 VDD.n1115 VDD.n170 0.432689
R4298 VDD.n181 VDD.n1112 0.432394
R4299 VDD.n1116 VDD.n188 0.432768
R4300 VDD.n30 VDD.n191 0.432451
R4301 VDD.n1120 VDD.n649 0.117388
R4302 VDD.n1124 VDD.n449 0.432394
R4303 VDD.n1130 VDD.n648 0.117388
R4304 VDD.n456 VDD.n204 0.432689
R4305 VDD.n67 VDD.n1133 0.0696176
R4306 VDD.n780 VDD.n773 0.0696176
R4307 VDD.n782 VDD.n779 0.0696176
R4308 VDD.n629 VDD.n1463 0.16205
R4309 VDD.n678 VDD.n1456 0.16205
R4310 VDD.n664 VDD.n1699 0.16205
R4311 VDD.n662 VDD.n1697 0.16205
R4312 VDD.n635 VDD.n1693 0.16205
R4313 VDD.n654 VDD.n1687 0.16205
R4314 VDD.n640 VDD.n1686 0.16205
R4315 VDD.n258 VDD.n257 0.230692
R4316 VDD.n373 VDD.n1047 0.41707
R4317 VDD.n296 VDD.n370 0.41707
R4318 VDD.n368 VDD.n1062 0.41707
R4319 VDD.n293 VDD.n365 0.41707
R4320 VDD.n363 VDD.n1090 0.41707
R4321 VDD.n1016 VDD.n360 0.41707
R4322 VDD.n358 VDD.n1259 0.41707
R4323 VDD.n288 VDD.n355 0.41707
R4324 VDD.n353 VDD.n1274 0.41707
R4325 VDD.n285 VDD.n350 0.41707
R4326 VDD.n348 VDD.n1302 0.41707
R4327 VDD.n1228 VDD.n345 0.41707
R4328 VDD.n343 VDD.n1844 0.41707
R4329 VDD.n280 VDD.n340 0.41707
R4330 VDD.n338 VDD.n1859 0.41707
R4331 VDD.n277 VDD.n335 0.41707
R4332 VDD.n333 VDD.n1887 0.41707
R4333 VDD.n1812 VDD.n330 0.41707
R4334 VDD.n328 VDD.n1620 0.41707
R4335 VDD.n272 VDD.n325 0.41707
R4336 VDD.n323 VDD.n1635 0.41707
R4337 VDD.n269 VDD.n320 0.41707
R4338 VDD.n318 VDD.n1663 0.41707
R4339 VDD.n1590 VDD.n315 0.41707
R4340 VDD.n313 VDD.n1380 0.41707
R4341 VDD.n264 VDD.n310 0.41707
R4342 VDD.n308 VDD.n1395 0.41707
R4343 VDD.n261 VDD.n305 0.41707
R4344 VDD.n303 VDD.n1423 0.41707
R4345 VDD.n1349 VDD.n300 0.41707
R4346 VDD.n1047 VDD.n298 0.413221
R4347 VDD.n297 VDD.n296 0.413221
R4348 VDD.n1062 VDD.n294 0.413221
R4349 VDD.n242 VDD.n293 0.413221
R4350 VDD.n1090 VDD.n292 0.413221
R4351 VDD.n1016 VDD.n291 0.413221
R4352 VDD.n1259 VDD.n290 0.413221
R4353 VDD.n289 VDD.n288 0.413221
R4354 VDD.n1274 VDD.n286 0.413221
R4355 VDD.n238 VDD.n285 0.413221
R4356 VDD.n1302 VDD.n284 0.413221
R4357 VDD.n1228 VDD.n283 0.413221
R4358 VDD.n1844 VDD.n282 0.413221
R4359 VDD.n281 VDD.n280 0.413221
R4360 VDD.n1859 VDD.n278 0.413221
R4361 VDD.n234 VDD.n277 0.413221
R4362 VDD.n1887 VDD.n276 0.413221
R4363 VDD.n1812 VDD.n275 0.413221
R4364 VDD.n1620 VDD.n274 0.413221
R4365 VDD.n273 VDD.n272 0.413221
R4366 VDD.n1635 VDD.n270 0.413221
R4367 VDD.n230 VDD.n269 0.413221
R4368 VDD.n1663 VDD.n268 0.413221
R4369 VDD.n1590 VDD.n267 0.413221
R4370 VDD.n1380 VDD.n266 0.413221
R4371 VDD.n265 VDD.n264 0.413221
R4372 VDD.n1395 VDD.n262 0.413221
R4373 VDD.n226 VDD.n261 0.413221
R4374 VDD.n1423 VDD.n260 0.413221
R4375 VDD.n1349 VDD.n259 0.413221
R4376 VDD.t358 VDD.t364 0.383639
R4377 VDD.n47 VDD.n44 0.363975
R4378 VDD VDD.n42 0.359597
R4379 VDD.n2039 VDD.n42 0.351319
R4380 VDD.n48 VDD.n45 0.318161
R4381 VDD.n1405 VDD.n58 0.315189
R4382 VDD.n1645 VDD.n56 0.315189
R4383 VDD.n1869 VDD.n54 0.315189
R4384 VDD.n1284 VDD.n52 0.315189
R4385 VDD.n1072 VDD.n50 0.315189
R4386 VDD.t430 VDD.n6 15.0463
R4387 VDD.t441 VDD.t378 15.0485
R4388 VDD.n20 VDD.n18 1.02382
R4389 VDD.n39 VDD.n11 0.157424
R4390 VDD.t360 VDD.n21 0.461428
R4391 VDD.n27 VDD.n499 0.723412
R4392 VDD.n192 VDD.n33 0.723195
R4393 VDD.n36 VDD.n35 0.749579
R4394 VDD.n13 VDD.n14 0.196061
R4395 VDD.n23 VDD.n21 0.246524
R4396 VDD.t345 VDD.t476 5.83749
R4397 VDD.n17 VDD.t345 1.11743
R4398 VDD.n161 VDD.t378 1.05113
R4399 VSS.n2748 VSS.n2747 22369.4
R4400 VSS.t122 VSS.n89 8296.08
R4401 VSS.n2924 VSS.t331 8239.28
R4402 VSS.n1236 VSS.t2 8239.28
R4403 VSS.n87 VSS.n81 7963.82
R4404 VSS.n2786 VSS.n2785 6494.85
R4405 VSS.n1058 VSS.n1057 3524.8
R4406 VSS.n2997 VSS.n2996 3461.11
R4407 VSS.n2797 VSS.n1394 3456.87
R4408 VSS.n2798 VSS.n2797 2770.39
R4409 VSS.n2997 VSS.n1058 2315.59
R4410 VSS.n3015 VSS.n1058 891.294
R4411 VSS.n2998 VSS.n2997 891.294
R4412 VSS.n2797 VSS.n2796 891.294
R4413 VSS.n470 VSS.t558 263.087
R4414 VSS.t806 VSS.t803 571.348
R4415 VSS.t239 VSS.n17 65.1009
R4416 VSS.n18 VSS.n2611 558.342
R4417 VSS.n2611 VSS.n26 555.396
R4418 VSS.n2130 VSS.t2284 539.653
R4419 VSS.t7 VSS.t122 22.4514
R4420 VSS.t1142 VSS.t2 22.4514
R4421 VSS.n464 VSS.t531 522.508
R4422 VSS.t2349 VSS.t122 22.3797
R4423 VSS.t2125 VSS.t2 22.3797
R4424 VSS.t331 VSS.n31 0.462537
R4425 VSS.n1 VSS.t2121 51.6619
R4426 VSS.t2 VSS.n27 0.462537
R4427 VSS.t331 VSS.t347 57.5429
R4428 VSS.t122 VSS.t228 57.5429
R4429 VSS.t2 VSS.t392 57.5429
R4430 VSS.t331 VSS.t328 57.5441
R4431 VSS.t122 VSS.t197 57.5441
R4432 VSS.n466 VSS.t532 491.87
R4433 VSS.n1331 VSS.t36 486.111
R4434 VSS.n1406 VSS.t23 486.111
R4435 VSS.n3007 VSS.t1134 486.111
R4436 VSS.t331 VSS.t319 67.8617
R4437 VSS.t331 VSS.t326 67.8611
R4438 VSS.t122 VSS.t202 67.8617
R4439 VSS.t122 VSS.t209 67.8611
R4440 VSS.t122 VSS.t215 67.8612
R4441 VSS.t2 VSS.t373 67.8611
R4442 VSS.t2 VSS.t379 67.8612
R4443 VSS.t331 VSS.t947 57.4585
R4444 VSS.t38 VSS.n2129 470.019
R4445 VSS.n1036 VSS.n309 469.784
R4446 VSS.n1033 VSS.n319 469.784
R4447 VSS.n1029 VSS.n329 469.784
R4448 VSS.n83 VSS.n1022 469.783
R4449 VSS.n18 VSS.t235 65.4784
R4450 VSS.n32 VSS.n62 0.00196391
R4451 VSS.n64 VSS.n44 0.00196391
R4452 VSS.n65 VSS.n41 0.00196391
R4453 VSS.n21 VSS.n47 0.00246394
R4454 VSS.n67 VSS.n19 0.00196391
R4455 VSS.n79 VSS.n78 0.00196391
R4456 VSS.n1047 VSS.t1637 453.986
R4457 VSS.n1038 VSS.n1037 453.986
R4458 VSS.n1035 VSS.n1034 453.986
R4459 VSS.n1031 VSS.n1030 453.986
R4460 VSS.n1027 VSS.n1026 453.986
R4461 VSS.n1024 VSS.n1023 453.986
R4462 VSS.n1037 VSS.n1014 453.986
R4463 VSS.n1034 VSS.n1015 453.986
R4464 VSS.n1030 VSS.n1016 453.986
R4465 VSS.n22 VSS.t432 321.575
R4466 VSS.n1026 VSS.n1017 453.986
R4467 VSS.n1023 VSS.n347 453.986
R4468 VSS.n69 VSS.t1474 56.6945
R4469 VSS.t1562 VSS.n2614 446.527
R4470 VSS.t19 VSS.n1043 442.469
R4471 VSS.n50 VSS.t1200 20.3143
R4472 VSS.t765 VSS.n68 44.8756
R4473 VSS.t463 VSS.n84 413.68
R4474 VSS.n1019 VSS.t450 413.678
R4475 VSS.n2745 VSS.n2744 412.522
R4476 VSS.n1042 VSS.t1638 403.072
R4477 VSS.t1242 VSS.n466 401.591
R4478 VSS.t241 VSS.n71 115.329
R4479 VSS.t331 VSS.t307 57.5432
R4480 VSS.t315 VSS.t331 115.334
R4481 VSS.t322 VSS.t331 115.335
R4482 VSS.t329 VSS.t331 115.334
R4483 VSS.t337 VSS.t331 115.335
R4484 VSS.t191 VSS.t122 115.335
R4485 VSS.t122 VSS.t204 57.5432
R4486 VSS.t122 VSS.t211 57.5441
R4487 VSS.t219 VSS.t122 115.335
R4488 VSS.t355 VSS.t2 115.335
R4489 VSS.t362 VSS.t2 115.335
R4490 VSS.t2 VSS.t368 57.5432
R4491 VSS.t2 VSS.t375 57.5441
R4492 VSS.t383 VSS.t2 115.335
R4493 VSS.t1474 VSS.n50 412.901
R4494 VSS.t725 VSS.n1048 391.555
R4495 VSS.t1829 VSS.n37 398.565
R4496 VSS.t2107 VSS.n36 398.565
R4497 VSS.n73 VSS.t2112 398.565
R4498 VSS.n74 VSS.t2122 398.565
R4499 VSS.t557 VSS.n470 80.7021
R4500 VSS.n1038 VSS.t399 385.798
R4501 VSS.n1035 VSS.t411 385.798
R4502 VSS.n1031 VSS.t423 385.798
R4503 VSS.n22 VSS.t434 58.3192
R4504 VSS.n1027 VSS.t446 385.798
R4505 VSS.t459 VSS.n347 385.798
R4506 VSS.n1055 VSS.t2320 384.889
R4507 VSS.t187 VSS.t122 120.838
R4508 VSS.t201 VSS.t122 120.838
R4509 VSS.t208 VSS.t122 120.838
R4510 VSS.t358 VSS.t2 120.84
R4511 VSS.t365 VSS.t2 120.838
R4512 VSS.t372 VSS.t2 120.838
R4513 VSS.t378 VSS.t2 120.838
R4514 VSS.n1052 VSS.t2310 380.038
R4515 VSS.t331 VSS.t309 125.654
R4516 VSS.t331 VSS.t323 125.656
R4517 VSS.t331 VSS.t330 125.654
R4518 VSS.t2 VSS.t377 125.654
R4519 VSS.t331 VSS.t341 120.84
R4520 VSS.t122 VSS.t223 120.84
R4521 VSS.n26 VSS.t233 115.552
R4522 VSS.t2 VSS.t387 120.84
R4523 VSS.t1189 VSS.t557 359.769
R4524 VSS.t764 VSS.n1053 357.007
R4525 VSS.t338 VSS.t331 125.656
R4526 VSS.t220 VSS.t122 125.656
R4527 VSS.n24 VSS.t230 125.653
R4528 VSS.t2 VSS.t384 125.656
R4529 VSS.t331 VSS.t1484 131.584
R4530 VSS.t122 VSS.t120 131.584
R4531 VSS.t2 VSS.t1148 131.584
R4532 VSS.t716 VSS.t331 131.588
R4533 VSS.t331 VSS.t1890 131.589
R4534 VSS.t720 VSS.t331 131.585
R4535 VSS.t738 VSS.t122 131.585
R4536 VSS.t571 VSS.t2 131.588
R4537 VSS.t575 VSS.t2 131.585
R4538 VSS.n1050 VSS.t763 333.974
R4539 VSS.t405 VSS.n45 97.2224
R4540 VSS.t417 VSS.n42 97.2224
R4541 VSS.t429 VSS.n49 97.2224
R4542 VSS.t440 VSS.n39 97.2224
R4543 VSS.t453 VSS.n1019 333.065
R4544 VSS.t1635 VSS.n1055 333.063
R4545 VSS.n84 VSS.t464 333.063
R4546 VSS.t331 VSS.t1304 135.975
R4547 VSS.t122 VSS.t2187 135.975
R4548 VSS.n2716 VSS.t803 327.81
R4549 VSS.t1786 VSS.n33 332.017
R4550 VSS.t1830 VSS.n37 127.957
R4551 VSS.t950 VSS.n72 398.565
R4552 VSS.t2108 VSS.n36 127.957
R4553 VSS.n73 VSS.t2114 127.957
R4554 VSS.n35 VSS.t2087 398.565
R4555 VSS.n74 VSS.t2124 127.957
R4556 VSS.t1562 VSS.n54 314.327
R4557 VSS.n2131 VSS.t530 313.659
R4558 VSS.t331 VSS.t721 138.811
R4559 VSS.t2 VSS.t576 138.81
R4560 VSS.t331 VSS.t717 138.81
R4561 VSS.t331 VSS.t1372 138.81
R4562 VSS.t331 VSS.t719 138.81
R4563 VSS.t122 VSS.t1037 138.81
R4564 VSS.t122 VSS.t2207 138.81
R4565 VSS.n16 VSS.n30 0.00460222
R4566 VSS.t2 VSS.t572 138.81
R4567 VSS.t2 VSS.t1 138.81
R4568 VSS.n1014 VSS.t397 305.183
R4569 VSS.n1015 VSS.t409 305.183
R4570 VSS.n1016 VSS.t421 305.183
R4571 VSS.n1017 VSS.t444 305.183
R4572 VSS.n1024 VSS.t457 305.183
R4573 VSS.t2283 VSS.n464 299.735
R4574 VSS.n1045 VSS.t17 299.425
R4575 VSS.n62 VSS.t395 310.053
R4576 VSS.n64 VSS.t406 310.053
R4577 VSS.n65 VSS.t418 310.053
R4578 VSS.n21 VSS.n38 0.00186806
R4579 VSS.n67 VSS.t441 310.053
R4580 VSS.t454 VSS.n79 310.053
R4581 VSS.n88 VSS.t1471 292.769
R4582 VSS.t2321 VSS.n1045 287.909
R4583 VSS.n17 VSS.n16 0.00331622
R4584 VSS.t334 VSS.t331 140.102
R4585 VSS.t210 VSS.t122 140.103
R4586 VSS.t380 VSS.t2 140.102
R4587 VSS.t184 VSS.n1330 277.779
R4588 VSS.n1757 VSS.t1245 277.779
R4589 VSS.t2153 VSS.n3006 277.779
R4590 VSS.n32 VSS.n34 0.00222117
R4591 VSS.t331 VSS.t313 140.102
R4592 VSS.t122 VSS.t189 140.102
R4593 VSS.t122 VSS.t196 140.102
R4594 VSS.t2 VSS.t353 140.102
R4595 VSS.t2 VSS.t367 140.102
R4596 VSS.n1043 VSS.t1652 269.726
R4597 VSS.n2567 VSS.n2566 265.116
R4598 VSS.n33 VSS.t1787 106.361
R4599 VSS.n70 VSS.t1819 332.017
R4600 VSS.n2587 VSS.n2211 258.741
R4601 VSS.n88 VSS.n87 0.013426
R4602 VSS.n80 VSS.t1944 116.46
R4603 VSS.t146 VSS.n63 116.46
R4604 VSS.n47 VSS.n66 0.00596644
R4605 VSS.t726 VSS.n1047 258.207
R4606 VSS.n2581 VSS.n2189 258.14
R4607 VSS.n2574 VSS.n2187 258.14
R4608 VSS.n2552 VSS.n2228 258.14
R4609 VSS.t1651 VSS.n1050 253.359
R4610 VSS.t877 VSS.n30 138.81
R4611 VSS.t1303 VSS.t331 138.81
R4612 VSS.t1921 VSS.t331 138.81
R4613 VSS.t331 VSS.t1371 131.587
R4614 VSS.t1891 VSS.t331 138.81
R4615 VSS.t331 VSS.t718 131.587
R4616 VSS.t4 VSS.t122 138.81
R4617 VSS.t122 VSS.t1036 131.588
R4618 VSS.t2360 VSS.t122 138.81
R4619 VSS.t1706 VSS.t122 138.81
R4620 VSS.t122 VSS.t2206 131.589
R4621 VSS.t1039 VSS.t122 138.81
R4622 VSS.t739 VSS.t122 138.811
R4623 VSS.t2328 VSS.t2 138.81
R4624 VSS.t963 VSS.t2 138.81
R4625 VSS.t1219 VSS.t2 138.81
R4626 VSS.t2 VSS.t0 131.589
R4627 VSS.t574 VSS.t2 138.81
R4628 VSS.t1485 VSS.t331 138.811
R4629 VSS.t122 VSS.t121 138.811
R4630 VSS.t2 VSS.t1149 138.811
R4631 VSS.t2186 VSS.n1421 252.375
R4632 VSS.t1324 VSS.n1430 252.375
R4633 VSS.t1639 VSS.n1446 252.375
R4634 VSS.t1209 VSS.n1462 252.375
R4635 VSS.t1449 VSS.n1478 252.375
R4636 VSS.t1884 VSS.n1494 252.375
R4637 VSS.t46 VSS.n1510 252.375
R4638 VSS.t1154 VSS.n1527 252.375
R4639 VSS.t1864 VSS.n1543 252.375
R4640 VSS.t1158 VSS.n1559 252.375
R4641 VSS.t493 VSS.n1575 252.375
R4642 VSS.t2354 VSS.n1591 252.375
R4643 VSS.t1159 VSS.n1607 252.375
R4644 VSS.t2220 VSS.n1623 252.375
R4645 VSS.t2218 VSS.n1640 252.375
R4646 VSS.t854 VSS.n1656 252.375
R4647 VSS.t732 VSS.n1672 252.375
R4648 VSS.t88 VSS.n613 252.375
R4649 VSS.t161 VSS.n606 252.375
R4650 VSS.n674 VSS.t25 252.375
R4651 VSS.n672 VSS.t995 252.375
R4652 VSS.n668 VSS.t1248 252.375
R4653 VSS.n667 VSS.t2178 252.375
R4654 VSS.n664 VSS.t2323 252.375
R4655 VSS.n660 VSS.t1112 252.375
R4656 VSS.n659 VSS.t1628 252.375
R4657 VSS.n656 VSS.t1240 252.375
R4658 VSS.n653 VSS.t1784 252.375
R4659 VSS.n649 VSS.t843 252.375
R4660 VSS.t1437 VSS.n604 252.375
R4661 VSS.n640 VSS.t1093 252.375
R4662 VSS.n636 VSS.t1208 252.375
R4663 VSS.t1314 VSS.n611 252.375
R4664 VSS.t174 VSS.n693 252.375
R4665 VSS.t1342 VSS.n708 252.375
R4666 VSS.t1934 VSS.n723 252.375
R4667 VSS.n901 VSS.t1935 252.375
R4668 VSS.n886 VSS.t1477 252.375
R4669 VSS.t2344 VSS.n743 252.375
R4670 VSS.n859 VSS.t597 252.375
R4671 VSS.n845 VSS.t1649 252.375
R4672 VSS.n831 VSS.t1265 252.375
R4673 VSS.n815 VSS.t2012 252.375
R4674 VSS.t1436 VSS.n766 252.375
R4675 VSS.n788 VSS.t1395 252.375
R4676 VSS.n430 VSS.t2324 252.375
R4677 VSS.t620 VSS.n364 252.375
R4678 VSS.t2237 VSS.n368 252.375
R4679 VSS.t1794 VSS.n372 252.375
R4680 VSS.t2282 VSS.n375 252.375
R4681 VSS.t846 VSS.n623 252.374
R4682 VSS.n572 VSS.t1795 252.374
R4683 VSS.n992 VSS.t2109 252.374
R4684 VSS.n980 VSS.t1954 252.374
R4685 VSS.n953 VSS.t1928 252.374
R4686 VSS.n941 VSS.t1929 252.374
R4687 VSS.n913 VSS.t839 252.374
R4688 VSS.n437 VSS.t1307 252.374
R4689 VSS.n435 VSS.t2313 252.374
R4690 VSS.t1512 VSS.n350 252.374
R4691 VSS.n424 VSS.t845 252.374
R4692 VSS.t1621 VSS.n351 252.374
R4693 VSS.n414 VSS.t2166 252.374
R4694 VSS.t844 VSS.n352 252.374
R4695 VSS.n404 VSS.t615 252.374
R4696 VSS.n396 VSS.t1241 252.374
R4697 VSS.n392 VSS.t2227 252.374
R4698 VSS.n384 VSS.t2162 252.374
R4699 VSS.n380 VSS.t1289 252.374
R4700 VSS.t1271 VSS.n700 252.117
R4701 VSS.n972 VSS.t2132 252.117
R4702 VSS.t1974 VSS.n710 252.117
R4703 VSS.t1991 VSS.n715 252.117
R4704 VSS.n933 VSS.t838 252.117
R4705 VSS.t1992 VSS.n725 252.117
R4706 VSS.t1351 VSS.n732 252.117
R4707 VSS.n892 VSS.t1354 252.117
R4708 VSS.t2251 VSS.n745 252.117
R4709 VSS.n850 VSS.t1483 252.117
R4710 VSS.n837 VSS.t2006 252.117
R4711 VSS.n821 VSS.t2014 252.117
R4712 VSS.t1662 VSS.n768 252.117
R4713 VSS.n670 VSS.t185 252.117
R4714 VSS.n666 VSS.t1107 252.117
R4715 VSS.n662 VSS.t1504 252.117
R4716 VSS.n658 VSS.t1103 252.117
R4717 VSS.n654 VSS.t2059 252.117
R4718 VSS.n651 VSS.t1113 252.117
R4719 VSS.n648 VSS.t621 252.117
R4720 VSS.n646 VSS.t624 252.117
R4721 VSS.t2223 VSS.n607 252.117
R4722 VSS.n638 VSS.t11 252.117
R4723 VSS.n635 VSS.t1841 252.117
R4724 VSS.n633 VSS.t1044 252.117
R4725 VSS.t1837 VSS.n1439 252.117
R4726 VSS.t2188 VSS.n1455 252.117
R4727 VSS.t1210 VSS.n1471 252.117
R4728 VSS.t1448 VSS.n1487 252.117
R4729 VSS.t1453 VSS.n1503 252.117
R4730 VSS.t2239 VSS.n1519 252.117
R4731 VSS.t1326 VSS.n1536 252.117
R4732 VSS.t1327 VSS.n1552 252.117
R4733 VSS.t959 VSS.n1568 252.117
R4734 VSS.t1776 VSS.n1584 252.117
R4735 VSS.t2159 VSS.n1600 252.117
R4736 VSS.t2216 VSS.n1616 252.117
R4737 VSS.t2219 VSS.n1633 252.117
R4738 VSS.t1213 VSS.n1649 252.117
R4739 VSS.t2244 VSS.n1665 252.117
R4740 VSS.t1481 VSS.n740 252.115
R4741 VSS.t2009 VSS.n763 252.115
R4742 VSS.n616 VSS.t2269 252.115
R4743 VSS.n618 VSS.t827 252.115
R4744 VSS.t2172 VSS.n624 252.115
R4745 VSS.n433 VSS.t43 252.115
R4746 VSS.t1882 VSS.n361 252.115
R4747 VSS.n426 VSS.t1620 252.115
R4748 VSS.n422 VSS.t847 252.115
R4749 VSS.t616 VSS.n365 252.115
R4750 VSS.n416 VSS.t1842 252.115
R4751 VSS.n412 VSS.t2226 252.115
R4752 VSS.n408 VSS.t181 252.115
R4753 VSS.n406 VSS.t2234 252.115
R4754 VSS.n402 VSS.t1802 252.115
R4755 VSS.n398 VSS.t1781 252.115
R4756 VSS.n395 VSS.t603 252.115
R4757 VSS.n390 VSS.t944 252.115
R4758 VSS.n386 VSS.t1782 252.115
R4759 VSS.n383 VSS.t916 252.115
R4760 VSS.n2614 VSS.t908 252.083
R4761 VSS.t1870 VSS.n994 250.837
R4762 VSS.t555 VSS.n990 250.837
R4763 VSS.t2150 VSS.n982 250.837
R4764 VSS.t2151 VSS.n978 250.837
R4765 VSS.t2163 VSS.n969 250.837
R4766 VSS.t78 VSS.n964 250.837
R4767 VSS.t741 VSS.n956 250.837
R4768 VSS.t2371 VSS.n951 250.837
R4769 VSS.t2373 VSS.n943 250.837
R4770 VSS.t781 VSS.n939 250.837
R4771 VSS.t2372 VSS.n930 250.837
R4772 VSS.t1013 VSS.n925 250.837
R4773 VSS.t2168 VSS.n915 250.837
R4774 VSS.t1028 VSS.n911 250.837
R4775 VSS.t1012 VSS.n903 250.837
R4776 VSS.t2164 VSS.n898 250.837
R4777 VSS.t2369 VSS.n888 250.837
R4778 VSS.t2370 VSS.n883 250.837
R4779 VSS.t596 VSS.n874 250.837
R4780 VSS.t1066 VSS.n870 250.837
R4781 VSS.t1030 VSS.n861 250.837
R4782 VSS.t2169 VSS.n856 250.837
R4783 VSS.t2170 VSS.n847 250.837
R4784 VSS.t784 VSS.n843 250.837
R4785 VSS.t783 VSS.n834 250.837
R4786 VSS.t590 VSS.n826 250.837
R4787 VSS.t2149 VSS.n817 250.837
R4788 VSS.t1082 VSS.n812 250.837
R4789 VSS.t594 VSS.n803 250.837
R4790 VSS.t2165 VSS.n799 250.837
R4791 VSS.t1665 VSS.n790 250.837
R4792 VSS.t127 VSS.n785 250.837
R4793 VSS.n1303 VSS.t1163 250.837
R4794 VSS.n1302 VSS.t625 250.837
R4795 VSS.n1299 VSS.t1902 250.837
R4796 VSS.n1298 VSS.t749 250.837
R4797 VSS.n1295 VSS.t1751 250.837
R4798 VSS.n1294 VSS.t1899 250.837
R4799 VSS.n1291 VSS.t909 250.837
R4800 VSS.n1290 VSS.t828 250.837
R4801 VSS.n1287 VSS.t123 250.837
R4802 VSS.n1286 VSS.t1068 250.837
R4803 VSS.n1283 VSS.t1532 250.837
R4804 VSS.n1282 VSS.t1531 250.837
R4805 VSS.n1278 VSS.t2035 250.837
R4806 VSS.n1277 VSS.t1734 250.837
R4807 VSS.n1274 VSS.t1753 250.837
R4808 VSS.n1273 VSS.t1848 250.837
R4809 VSS.n1270 VSS.t904 250.837
R4810 VSS.n1269 VSS.t1738 250.837
R4811 VSS.n1266 VSS.t2271 250.837
R4812 VSS.n1265 VSS.t2270 250.837
R4813 VSS.n1262 VSS.t914 250.837
R4814 VSS.n1261 VSS.t912 250.837
R4815 VSS.n1258 VSS.t1664 250.837
R4816 VSS.n1257 VSS.t1663 250.837
R4817 VSS.n1254 VSS.t1032 250.837
R4818 VSS.n1253 VSS.t110 250.837
R4819 VSS.n1250 VSS.t1648 250.837
R4820 VSS.n1249 VSS.t724 250.837
R4821 VSS.n1246 VSS.t2201 250.837
R4822 VSS.n1245 VSS.t2200 250.837
R4823 VSS.n1242 VSS.t1499 250.837
R4824 VSS.n1241 VSS.t2031 250.837
R4825 VSS.n2991 VSS.t1732 250.837
R4826 VSS.n2990 VSS.t2378 250.837
R4827 VSS.n2987 VSS.t1006 250.837
R4828 VSS.n2986 VSS.t1746 250.837
R4829 VSS.n2983 VSS.t1527 250.837
R4830 VSS.n2982 VSS.t890 250.837
R4831 VSS.n2979 VSS.t1348 250.837
R4832 VSS.n2978 VSS.t2276 250.837
R4833 VSS.n2975 VSS.t870 250.837
R4834 VSS.n2974 VSS.t1160 250.837
R4835 VSS.n2971 VSS.t857 250.837
R4836 VSS.n2970 VSS.t1040 250.837
R4837 VSS.n2966 VSS.t1632 250.837
R4838 VSS.n2965 VSS.t817 250.837
R4839 VSS.n2962 VSS.t2367 250.837
R4840 VSS.n2961 VSS.t525 250.837
R4841 VSS.n2958 VSS.t2364 250.837
R4842 VSS.n2957 VSS.t2272 250.837
R4843 VSS.n2954 VSS.t867 250.837
R4844 VSS.n2953 VSS.t751 250.837
R4845 VSS.n2950 VSS.t112 250.837
R4846 VSS.n2949 VSS.t754 250.837
R4847 VSS.n2946 VSS.t102 250.837
R4848 VSS.n2945 VSS.t760 250.837
R4849 VSS.n2942 VSS.t863 250.837
R4850 VSS.n2941 VSS.t2376 250.837
R4851 VSS.n2938 VSS.t883 250.837
R4852 VSS.n2937 VSS.t518 250.837
R4853 VSS.n2934 VSS.t1022 250.837
R4854 VSS.n2933 VSS.t1097 250.837
R4855 VSS.n2930 VSS.t824 250.837
R4856 VSS.n2929 VSS.t1735 250.837
R4857 VSS.n1987 VSS.t874 250.837
R4858 VSS.n163 VSS.t1161 250.837
R4859 VSS.n161 VSS.t868 250.837
R4860 VSS.n160 VSS.t752 250.837
R4861 VSS.n157 VSS.t114 250.837
R4862 VSS.n156 VSS.t756 250.837
R4863 VSS.n153 VSS.t104 250.837
R4864 VSS.n152 VSS.t761 250.837
R4865 VSS.n149 VSS.t865 250.837
R4866 VSS.n148 VSS.t2377 250.837
R4867 VSS.n145 VSS.t1903 250.837
R4868 VSS.n144 VSS.t750 250.837
R4869 VSS.n141 VSS.t1752 250.837
R4870 VSS.n140 VSS.t1900 250.837
R4871 VSS.n137 VSS.t910 250.837
R4872 VSS.n136 VSS.t829 250.837
R4873 VSS.n133 VSS.t125 250.837
R4874 VSS.n132 VSS.t1069 250.837
R4875 VSS.n129 VSS.t906 250.837
R4876 VSS.n128 VSS.t905 250.837
R4877 VSS.n125 VSS.t1901 250.837
R4878 VSS.n124 VSS.t2075 250.837
R4879 VSS.n121 VSS.t1852 250.837
R4880 VSS.n120 VSS.t2167 250.837
R4881 VSS.n117 VSS.t592 250.837
R4882 VSS.n116 VSS.t1905 250.837
R4883 VSS.n113 VSS.t740 250.837
R4884 VSS.n112 VSS.t116 250.837
R4885 VSS.n109 VSS.t1034 250.837
R4886 VSS.n108 VSS.t1748 250.837
R4887 VSS.n105 VSS.t1070 250.837
R4888 VSS.n104 VSS.t565 250.837
R4889 VSS.n1426 VSS.t1739 250.837
R4890 VSS.n1433 VSS.t626 250.837
R4891 VSS.n1442 VSS.t884 250.837
R4892 VSS.n1449 VSS.t523 250.837
R4893 VSS.n1458 VSS.t1024 250.837
R4894 VSS.n1465 VSS.t1099 250.837
R4895 VSS.n1474 VSS.t826 250.837
R4896 VSS.n1481 VSS.t1737 250.837
R4897 VSS.n1490 VSS.t1164 250.837
R4898 VSS.n1497 VSS.t2273 250.837
R4899 VSS.n1506 VSS.t861 250.837
R4900 VSS.n1513 VSS.t1042 250.837
R4901 VSS.t1633 VSS.n1521 250.837
R4902 VSS.n1530 VSS.t818 250.837
R4903 VSS.n1539 VSS.t2368 250.837
R4904 VSS.n1546 VSS.t526 250.837
R4905 VSS.n1555 VSS.t2365 250.837
R4906 VSS.n1562 VSS.t2379 250.837
R4907 VSS.n1571 VSS.t1035 250.837
R4908 VSS.n1578 VSS.t1749 250.837
R4909 VSS.n1587 VSS.t1072 250.837
R4910 VSS.n1594 VSS.t567 250.837
R4911 VSS.n1603 VSS.t2197 250.837
R4912 VSS.n1610 VSS.t1698 250.837
R4913 VSS.n1619 VSS.t1733 250.837
R4914 VSS.t118 VSS.n1625 250.837
R4915 VSS.n1636 VSS.t1007 250.837
R4916 VSS.n1643 VSS.t1747 250.837
R4917 VSS.n1652 VSS.t1528 250.837
R4918 VSS.n1659 VSS.t892 250.837
R4919 VSS.n1668 VSS.t1350 250.837
R4920 VSS.n1675 VSS.t2277 250.837
R4921 VSS.n2602 VSS.n2230 248.252
R4922 VSS.n2577 VSS.n2213 244.186
R4923 VSS.n2600 VSS.n2185 244.186
R4924 VSS.t2140 VSS.n1783 244.148
R4925 VSS.t2131 VSS.n1982 244.148
R4926 VSS.t1965 VSS.n1790 244.148
R4927 VSS.t1959 VSS.n1977 244.148
R4928 VSS.t2144 VSS.n1797 244.148
R4929 VSS.t1975 VSS.n1972 244.148
R4930 VSS.t1926 VSS.n1804 244.148
R4931 VSS.t1927 VSS.n1967 244.148
R4932 VSS.t1980 VSS.n1811 244.148
R4933 VSS.t1977 VSS.n1962 244.148
R4934 VSS.t70 VSS.n1818 244.148
R4935 VSS.t1990 VSS.n1957 244.148
R4936 VSS.t1985 VSS.n1827 244.148
R4937 VSS.t507 VSS.n1951 244.148
R4938 VSS.t1993 VSS.n1834 244.148
R4939 VSS.t969 VSS.n1946 244.148
R4940 VSS.t2336 VSS.n1841 244.148
R4941 VSS.t1428 VSS.n1941 244.148
R4942 VSS.t840 VSS.n1848 244.148
R4943 VSS.t1999 VSS.n1936 244.148
R4944 VSS.t1429 VSS.n1855 244.148
R4945 VSS.t1854 VSS.n1931 244.148
R4946 VSS.t1174 VSS.n1862 244.148
R4947 VSS.t1478 VSS.n1926 244.148
R4948 VSS.t850 VSS.n1869 244.148
R4949 VSS.t2203 VSS.n1921 244.148
R4950 VSS.t1857 VSS.n1878 244.148
R4951 VSS.t1856 VSS.n1916 244.148
R4952 VSS.t2343 VSS.n1885 244.148
R4953 VSS.t1370 VSS.n1911 244.148
R4954 VSS.t2252 VSS.n1892 244.148
R4955 VSS.t401 VSS.n308 240.957
R4956 VSS.t413 VSS.n318 240.957
R4957 VSS.t426 VSS.n328 240.957
R4958 VSS.t436 VSS.n20 117.528
R4959 VSS.t448 VSS.n77 240.957
R4960 VSS.t461 VSS.n1021 240.956
R4961 VSS.t1650 VSS.n1056 240.954
R4962 VSS.t1831 VSS.n2563 240.698
R4963 VSS.n986 VSS.t2105 234.114
R4964 VSS.n974 VSS.t2146 234.114
R4965 VSS.n960 VSS.t1537 234.114
R4966 VSS.n947 VSS.t505 234.114
R4967 VSS.n935 VSS.t1983 234.114
R4968 VSS.n921 VSS.t1171 234.114
R4969 VSS.n907 VSS.t2000 234.114
R4970 VSS.n894 VSS.t1479 234.114
R4971 VSS.n879 VSS.t971 234.114
R4972 VSS.n866 VSS.t1360 234.114
R4973 VSS.n852 VSS.t1859 234.114
R4974 VSS.n839 VSS.t516 234.114
R4975 VSS.n823 VSS.t2254 234.114
R4976 VSS.n808 VSS.t2011 234.114
R4977 VSS.n795 VSS.t1435 234.114
R4978 VSS.n781 VSS.t613 234.114
R4979 VSS.t1115 VSS.n1127 234.114
R4980 VSS.t485 VSS.n1134 234.114
R4981 VSS.t1015 VSS.n1141 234.114
R4982 VSS.t537 VSS.n1148 234.114
R4983 VSS.t1104 VSS.n1155 234.114
R4984 VSS.t1025 VSS.n1162 234.114
R4985 VSS.t1180 VSS.n1169 234.114
R4986 VSS.t162 VSS.n1176 234.114
R4987 VSS.t923 VSS.n1183 234.114
R4988 VSS.t165 VSS.n1190 234.114
R4989 VSS.t1443 VSS.n1197 234.114
R4990 VSS.t1091 VSS.n1204 234.114
R4991 VSS.t1201 VSS.n1213 234.114
R4992 VSS.t617 VSS.n1220 234.114
R4993 VSS.t1249 VSS.n1227 234.114
R4994 VSS.t1403 VSS.n1234 234.114
R4995 VSS.t979 VSS.n2810 234.114
R4996 VSS.t983 VSS.n2817 234.114
R4997 VSS.t2229 VSS.n2824 234.114
R4998 VSS.t1001 VSS.n2831 234.114
R4999 VSS.t1110 VSS.n2838 234.114
R5000 VSS.t2358 VSS.n2845 234.114
R5001 VSS.t159 VSS.n2852 234.114
R5002 VSS.t2235 VSS.n2859 234.114
R5003 VSS.t551 VSS.n2866 234.114
R5004 VSS.t89 VSS.n2873 234.114
R5005 VSS.t1514 VSS.n2880 234.114
R5006 VSS.t799 VSS.n2887 234.114
R5007 VSS.t2381 VSS.n2896 234.114
R5008 VSS.t1439 VSS.n2903 234.114
R5009 VSS.t1797 VSS.n2910 234.114
R5010 VSS.t1444 VSS.n2917 234.114
R5011 VSS.t2139 VSS.n167 234.114
R5012 VSS.t1962 VSS.n172 234.114
R5013 VSS.t1924 VSS.n177 234.114
R5014 VSS.t1972 VSS.n182 234.114
R5015 VSS.t1273 VSS.n187 234.114
R5016 VSS.t695 VSS.n192 234.114
R5017 VSS.t2362 VSS.n197 234.114
R5018 VSS.t1170 VSS.n202 234.114
R5019 VSS.t789 VSS.n207 234.114
R5020 VSS.t793 VSS.n212 234.114
R5021 VSS.t2339 VSS.n217 234.114
R5022 VSS.t1225 VSS.n222 234.114
R5023 VSS.t1357 VSS.n227 234.114
R5024 VSS.t2348 VSS.n232 234.114
R5025 VSS.t1364 VSS.n237 234.114
R5026 VSS.t852 VSS.n242 234.114
R5027 VSS.t1640 VSS.n1437 234.114
R5028 VSS.t1825 VSS.n1453 234.114
R5029 VSS.t1827 VSS.n1468 234.114
R5030 VSS.t487 VSS.n1484 234.114
R5031 VSS.t1454 VSS.n1500 234.114
R5032 VSS.t2199 VSS.n1517 234.114
R5033 VSS.t1211 VSS.n1533 234.114
R5034 VSS.t1329 VSS.n1549 234.114
R5035 VSS.t1646 VSS.n1566 234.114
R5036 VSS.t2325 VSS.n1582 234.114
R5037 VSS.t2353 VSS.n1597 234.114
R5038 VSS.t2161 VSS.n1613 234.114
R5039 VSS.t2242 VSS.n1630 234.114
R5040 VSS.t1255 VSS.n1647 234.114
R5041 VSS.t747 VSS.n1662 234.114
R5042 VSS.t2335 VSS.n1678 234.114
R5043 VSS.n2598 VSS.t247 233.721
R5044 VSS.t331 VSS.t1302 131.593
R5045 VSS.t122 VSS.t3 131.593
R5046 VSS.t26 VSS.t2 135.975
R5047 VSS.n1053 VSS.t2309 230.327
R5048 VSS.n2578 VSS.n2193 230.233
R5049 VSS.n2199 VSS.n2174 230.233
R5050 VSS.n2597 VSS.n2200 230.233
R5051 VSS.n1022 VSS.t461 229.44
R5052 VSS.n309 VSS.t401 229.439
R5053 VSS.n319 VSS.t413 229.439
R5054 VSS.n329 VSS.t426 229.439
R5055 VSS.n1028 VSS.n20 469.784
R5056 VSS.n76 VSS.t448 229.44
R5057 VSS.n1057 VSS.t1650 228.827
R5058 VSS.n997 VSS.t1783 225.361
R5059 VSS.t2104 VSS.n701 225.361
R5060 VSS.t2145 VSS.n706 225.361
R5061 VSS.n958 VSS.t1536 225.361
R5062 VSS.t503 VSS.n716 225.361
R5063 VSS.t1982 VSS.n721 225.361
R5064 VSS.n919 VSS.t1172 225.361
R5065 VSS.t2001 VSS.n733 225.361
R5066 VSS.n891 VSS.t1480 225.361
R5067 VSS.n877 VSS.t970 225.361
R5068 VSS.n864 VSS.t1359 225.361
R5069 VSS.t514 VSS.n754 225.361
R5070 VSS.n820 VSS.t2253 225.361
R5071 VSS.n806 VSS.t2010 225.361
R5072 VSS.n793 VSS.t1433 225.361
R5073 VSS.t1116 VSS.n591 225.361
R5074 VSS.t484 VSS.n593 225.361
R5075 VSS.t539 VSS.n596 225.361
R5076 VSS.t1105 VSS.n598 225.361
R5077 VSS.t1181 VSS.n601 225.361
R5078 VSS.t164 VSS.n602 225.361
R5079 VSS.n645 VSS.t166 225.361
R5080 VSS.n643 VSS.t1442 225.361
R5081 VSS.n641 VSS.t1090 225.361
R5082 VSS.t1202 VSS.n609 225.361
R5083 VSS.n632 VSS.t1251 225.361
R5084 VSS.t1282 VSS.n1423 225.361
R5085 VSS.t1641 VSS.n1440 225.361
R5086 VSS.t1824 VSS.n1456 225.361
R5087 VSS.t1828 VSS.n1472 225.361
R5088 VSS.t489 VSS.n1488 225.361
R5089 VSS.t1456 VSS.n1504 225.361
R5090 VSS.t1212 VSS.n1537 225.361
R5091 VSS.t1330 VSS.n1553 225.361
R5092 VSS.t1647 VSS.n1569 225.361
R5093 VSS.t2326 VSS.n1585 225.361
R5094 VSS.t2352 VSS.n1601 225.361
R5095 VSS.t2160 VSS.n1617 225.361
R5096 VSS.t2243 VSS.n1634 225.361
R5097 VSS.t1256 VSS.n1650 225.361
R5098 VSS.t746 VSS.n1666 225.361
R5099 VSS.t1858 VSS.n749 225.359
R5100 VSS.t1258 VSS.n615 225.359
R5101 VSS.t1017 VSS.n617 225.359
R5102 VSS.t1027 VSS.n619 225.359
R5103 VSS.t924 VSS.n622 225.359
R5104 VSS.t619 VSS.n627 225.359
R5105 VSS.n571 VSS.t2019 225.359
R5106 VSS.t2198 VSS.n1520 225.359
R5107 VSS.t708 VSS.n360 225.359
R5108 VSS.n432 VSS.t981 225.359
R5109 VSS.n428 VSS.t984 225.359
R5110 VSS.t2228 VSS.n363 225.359
R5111 VSS.n421 VSS.t1002 225.359
R5112 VSS.n418 VSS.t1108 225.359
R5113 VSS.t2357 VSS.n367 225.359
R5114 VSS.n411 VSS.t157 225.359
R5115 VSS.n407 VSS.t2236 225.359
R5116 VSS.t549 VSS.n371 225.359
R5117 VSS.n401 VSS.t91 225.359
R5118 VSS.n397 VSS.t1513 225.359
R5119 VSS.n394 VSS.t797 225.359
R5120 VSS.n389 VSS.t2380 225.359
R5121 VSS.n385 VSS.t1438 225.359
R5122 VSS.n382 VSS.t1798 225.359
R5123 VSS.t952 VSS.n72 127.957
R5124 VSS.n73 VSS.t122 6.8105
R5125 VSS.n74 VSS.t2 6.8105
R5126 VSS.t331 VSS.n37 6.8105
R5127 VSS.t122 VSS.n36 6.8105
R5128 VSS.n35 VSS.t2088 127.957
R5129 VSS.n1331 VSS.t184 222.222
R5130 VSS.t1245 VSS.n1406 222.222
R5131 VSS.n3007 VSS.t2153 222.222
R5132 VSS.n1981 VSS.t2138 217.392
R5133 VSS.n1976 VSS.t1963 217.392
R5134 VSS.n1971 VSS.t1925 217.392
R5135 VSS.n1966 VSS.t1973 217.392
R5136 VSS.n1961 VSS.t1275 217.392
R5137 VSS.n1956 VSS.t697 217.392
R5138 VSS.n1950 VSS.t2363 217.392
R5139 VSS.n1945 VSS.t1168 217.392
R5140 VSS.n1940 VSS.t787 217.392
R5141 VSS.n1935 VSS.t791 217.392
R5142 VSS.n1930 VSS.t2340 217.392
R5143 VSS.n1925 VSS.t1227 217.392
R5144 VSS.n1920 VSS.t1355 217.392
R5145 VSS.n1915 VSS.t2347 217.392
R5146 VSS.n1910 VSS.t1366 217.392
R5147 VSS.t1306 VSS.n2555 216.784
R5148 VSS.n2580 VSS.n2217 216.28
R5149 VSS.n2571 VSS.n2222 216.28
R5150 VSS.n2551 VSS.n2181 216.28
R5151 VSS.n2594 VSS.n2204 216.28
R5152 VSS.n2669 VSS.t886 215.731
R5153 VSS.t886 VSS.n54 215.731
R5154 VSS.t145 VSS.n63 292.767
R5155 VSS.t1940 VSS.n46 116.469
R5156 VSS.t728 VSS.n43 116.469
R5157 VSS.t730 VSS.n48 116.469
R5158 VSS.t149 VSS.n66 116.468
R5159 VSS.t1942 VSS.n40 116.469
R5160 VSS.n80 VSS.t1943 292.767
R5161 VSS.n88 VSS.t1472 116.46
R5162 VSS.t665 VSS.n696 211.982
R5163 VSS.t671 VSS.n746 211.982
R5164 VSS.t1722 VSS.n769 211.982
R5165 VSS.t1658 VSS.n620 211.982
R5166 VSS.t1459 VSS.n625 211.982
R5167 VSS.t1724 VSS.n702 211.982
R5168 VSS.t1880 VSS.n968 211.982
R5169 VSS.t633 VSS.n711 211.982
R5170 VSS.t674 VSS.n717 211.982
R5171 VSS.t636 VSS.n929 211.982
R5172 VSS.t660 VSS.n728 211.982
R5173 VSS.t642 VSS.n735 211.982
R5174 VSS.t668 VSS.n738 211.982
R5175 VSS.t630 VSS.n742 211.982
R5176 VSS.t639 VSS.n750 211.982
R5177 VSS.t663 VSS.n756 211.982
R5178 VSS.t645 VSS.n761 211.982
R5179 VSS.t1878 VSS.n765 211.982
R5180 VSS.t1457 VSS.n673 211.982
R5181 VSS.t1765 VSS.n669 211.982
R5182 VSS.t1947 VSS.n594 211.982
R5183 VSS.t1644 VSS.n665 211.982
R5184 VSS.t1463 VSS.n661 211.982
R5185 VSS.t1654 VSS.n599 211.982
R5186 VSS.t2026 VSS.n657 211.982
R5187 VSS.t2029 VSS.n650 211.982
R5188 VSS.t1642 VSS.n603 211.982
R5189 VSS.t1461 VSS.n605 211.982
R5190 VSS.t1656 VSS.n608 211.982
R5191 VSS.t1660 VSS.n637 211.982
R5192 VSS.t1951 VSS.n610 211.982
R5193 VSS.t1763 VSS.n612 211.982
R5194 VSS.n1427 VSS.t2374 211.982
R5195 VSS.n1443 VSS.t83 211.982
R5196 VSS.n1459 VSS.t859 211.982
R5197 VSS.n1475 VSS.t2214 211.982
R5198 VSS.n1491 VSS.t855 211.982
R5199 VSS.n1507 VSS.t2191 211.982
R5200 VSS.n1524 VSS.t880 211.982
R5201 VSS.n1540 VSS.t2208 211.982
R5202 VSS.n1556 VSS.t1045 211.982
R5203 VSS.n1572 VSS.t2212 211.982
R5204 VSS.n1588 VSS.t1019 211.982
R5205 VSS.n1604 VSS.t2193 211.982
R5206 VSS.n1620 VSS.t1048 211.982
R5207 VSS.n1637 VSS.t2210 211.982
R5208 VSS.n1653 VSS.t520 211.982
R5209 VSS.n1669 VSS.t80 211.982
R5210 VSS.t1060 VSS.n436 211.982
R5211 VSS.t1392 VSS.n431 211.982
R5212 VSS.t1908 VSS.n425 211.982
R5213 VSS.t1062 VSS.n420 211.982
R5214 VSS.t1055 VSS.n415 211.982
R5215 VSS.t1914 VSS.n410 211.982
R5216 VSS.t1906 VSS.n405 211.982
R5217 VSS.t1064 VSS.n400 211.982
R5218 VSS.t1058 VSS.n393 211.982
R5219 VSS.t1916 VSS.n388 211.982
R5220 VSS.t1390 VSS.n381 211.982
R5221 VSS.t1077 VSS.n362 211.982
R5222 VSS.t1910 VSS.n366 211.982
R5223 VSS.t1050 VSS.n369 211.982
R5224 VSS.t1912 VSS.n373 211.982
R5225 VSS.t1074 VSS.n376 211.982
R5226 VSS.t876 VSS.n30 131.588
R5227 VSS.t331 VSS.t1920 131.587
R5228 VSS.t122 VSS.t2359 131.587
R5229 VSS.t122 VSS.t1038 131.587
R5230 VSS.t2 VSS.t962 131.587
R5231 VSS.t2 VSS.t1218 131.587
R5232 VSS.t2 VSS.t573 131.588
R5233 VSS.n465 VSS.t1242 208.828
R5234 VSS.t2309 VSS.n1052 207.294
R5235 VSS.n1988 VSS.t1333 204.013
R5236 VSS.n1995 VSS.t2039 204.013
R5237 VSS.n2002 VSS.t1743 204.013
R5238 VSS.n2009 VSS.t2050 204.013
R5239 VSS.n2016 VSS.t1711 204.013
R5240 VSS.n2023 VSS.t2053 204.013
R5241 VSS.n2031 VSS.t1757 204.013
R5242 VSS.n2038 VSS.t1714 204.013
R5243 VSS.n2045 VSS.t1336 204.013
R5244 VSS.n2052 VSS.t2047 204.013
R5245 VSS.n2059 VSS.t1708 204.013
R5246 VSS.n2066 VSS.t2056 204.013
R5247 VSS.n2073 VSS.t1760 204.013
R5248 VSS.n2080 VSS.t1717 204.013
R5249 VSS.n2087 VSS.t1740 204.013
R5250 VSS.n2094 VSS.t2036 204.013
R5251 VSS.n2557 VSS.n2179 202.798
R5252 VSS.n2554 VSS.n2178 202.798
R5253 VSS.t251 VSS.n2575 202.798
R5254 VSS.n2131 VSS.t2283 202.362
R5255 VSS.n2599 VSS.n2219 202.327
R5256 VSS.n2572 VSS.n2220 202.327
R5257 VSS.n2591 VSS.n2208 202.327
R5258 VSS.n2592 VSS.n2210 202.327
R5259 VSS.n1051 VSS.t1651 200.649
R5260 VSS.n8 VSS.n2748 197.518
R5261 VSS.n1048 VSS.t726 195.778
R5262 VSS.t1960 VSS.n704 195.26
R5263 VSS.n966 VSS.t1966 195.26
R5264 VSS.t1930 VSS.n719 195.26
R5265 VSS.n927 VSS.t835 195.26
R5266 VSS.n900 VSS.t1344 195.26
R5267 VSS.n885 VSS.t972 195.26
R5268 VSS.n872 VSS.t2345 195.26
R5269 VSS.n858 VSS.t734 195.26
R5270 VSS.n830 VSS.t736 195.26
R5271 VSS.n814 VSS.t1376 195.26
R5272 VSS.n801 VSS.t1296 195.26
R5273 VSS.n787 VSS.t2016 195.26
R5274 VSS.n671 VSS.t1861 195.26
R5275 VSS.t1193 VSS.n592 195.26
R5276 VSS.t2287 VSS.n595 195.26
R5277 VSS.n663 VSS.t153 195.26
R5278 VSS.t929 VSS.n597 195.26
R5279 VSS.t142 VSS.n600 195.26
R5280 VSS.n655 VSS.t777 195.26
R5281 VSS.n652 VSS.t533 195.26
R5282 VSS.n647 VSS.t2312 195.26
R5283 VSS.n644 VSS.t1088 195.26
R5284 VSS.n642 VSS.t2356 195.26
R5285 VSS.n639 VSS.t938 195.26
R5286 VSS.n634 VSS.t2183 195.26
R5287 VSS.n631 VSS.t2315 195.26
R5288 VSS.t1316 VSS.n1431 195.26
R5289 VSS.t1833 VSS.n1447 195.26
R5290 VSS.t1446 VSS.n1463 195.26
R5291 VSS.t609 VSS.n1479 195.26
R5292 VSS.t1152 VSS.n1495 195.26
R5293 VSS.t1451 VSS.n1511 195.26
R5294 VSS.t1408 VSS.n1528 195.26
R5295 VSS.t1414 VSS.n1544 195.26
R5296 VSS.t1411 VSS.n1560 195.26
R5297 VSS.t1156 VSS.n1576 195.26
R5298 VSS.t1773 VSS.n1592 195.26
R5299 VSS.t2158 VSS.n1608 195.26
R5300 VSS.t2240 VSS.n1641 195.26
R5301 VSS.t2332 VSS.n1657 195.26
R5302 VSS.t1216 VSS.n1673 195.26
R5303 VSS.t2126 VSS.n698 195.26
R5304 VSS.t1534 VSS.n713 195.26
R5305 VSS.t2245 VSS.n730 195.26
R5306 VSS.t1262 VSS.n752 195.26
R5307 VSS.t481 VSS.n621 195.26
R5308 VSS.t990 VSS.n626 195.26
R5309 VSS.t656 VSS.n1624 195.26
R5310 VSS.n434 VSS.t1850 195.26
R5311 VSS.n429 VSS.t1624 195.26
R5312 VSS.n427 VSS.t1290 195.26
R5313 VSS.n423 VSS.t2119 195.26
R5314 VSS.n419 VSS.t1502 195.26
R5315 VSS.n417 VSS.t1840 195.26
R5316 VSS.n413 VSS.t96 195.26
R5317 VSS.n409 VSS.t997 195.26
R5318 VSS.t138 VSS.n370 195.26
R5319 VSS.n403 VSS.t706 195.26
R5320 VSS.n399 VSS.t1101 195.26
R5321 VSS.t1009 VSS.n374 195.26
R5322 VSS.n391 VSS.t2180 195.26
R5323 VSS.n387 VSS.t108 195.26
R5324 VSS.t1309 VSS.n377 195.26
R5325 VSS.n379 VSS.t1294 195.26
R5326 VSS.t175 VSS.n34 114.145
R5327 VSS.n8 VSS.t558 197.819
R5328 VSS.n2586 VSS.t252 192.309
R5329 VSS.t302 VSS.t331 125.656
R5330 VSS.t331 VSS.t311 120.84
R5331 VSS.t316 VSS.t331 125.656
R5332 VSS.t331 VSS.t325 120.838
R5333 VSS.t331 VSS.t332 120.84
R5334 VSS.t186 VSS.t122 125.656
R5335 VSS.t199 VSS.t122 125.656
R5336 VSS.t206 VSS.t122 125.656
R5337 VSS.n25 VSS.n24 0.00206464
R5338 VSS.t349 VSS.t2 125.656
R5339 VSS.t356 VSS.t2 125.654
R5340 VSS.t363 VSS.t2 125.656
R5341 VSS.t370 VSS.t2 125.656
R5342 VSS.n70 VSS.t1820 106.361
R5343 VSS.n33 VSS.n32 6.82731
R5344 VSS.n2576 VSS.n2196 188.811
R5345 VSS.n2559 VSS.n2180 188.373
R5346 VSS.t530 VSS.n468 187.895
R5347 VSS.t604 VSS.n988 187.292
R5348 VSS.t177 VSS.n976 187.292
R5349 VSS.t543 VSS.n962 187.292
R5350 VSS.t2366 VSS.n949 187.292
R5351 VSS.t1800 VSS.n937 187.292
R5352 VSS.t815 VSS.n923 187.292
R5353 VSS.t40 VSS.n909 187.292
R5354 VSS.t1849 VSS.n896 187.292
R5355 VSS.t599 VSS.n881 187.292
R5356 VSS.t1137 VSS.n868 187.292
R5357 VSS.t1506 VSS.n854 187.292
R5358 VSS.t1146 VSS.n841 187.292
R5359 VSS.t710 VSS.n825 187.292
R5360 VSS.t2174 VSS.n810 187.292
R5361 VSS.t179 VSS.n797 187.292
R5362 VSS.t129 VSS.n783 187.292
R5363 VSS.t68 VSS.n1126 187.292
R5364 VSS.t501 VSS.n1133 187.292
R5365 VSS.t1885 VSS.n1140 187.292
R5366 VSS.t2020 VSS.n1147 187.292
R5367 VSS.t1779 VSS.n1154 187.292
R5368 VSS.t1778 VSS.n1161 187.292
R5369 VSS.t964 VSS.n1168 187.292
R5370 VSS.t1167 VSS.n1175 187.292
R5371 VSS.t1953 VSS.n1182 187.292
R5372 VSS.t1888 VSS.n1189 187.292
R5373 VSS.t1887 VSS.n1196 187.292
R5374 VSS.t1771 VSS.n1203 187.292
R5375 VSS.t1835 VSS.n1212 187.292
R5376 VSS.t1799 VSS.n1219 187.292
R5377 VSS.t1792 VSS.n1226 187.292
R5378 VSS.t2072 VSS.n1233 187.292
R5379 VSS.t931 VSS.n2809 187.292
R5380 VSS.t553 VSS.n2816 187.292
R5381 VSS.t1139 VSS.n2823 187.292
R5382 VSS.t133 VSS.n2830 187.292
R5383 VSS.t1785 VSS.n2837 187.292
R5384 VSS.t1626 VSS.n2844 187.292
R5385 VSS.t1904 VSS.n2851 187.292
R5386 VSS.t1818 VSS.n2858 187.292
R5387 VSS.t2222 VSS.n2865 187.292
R5388 VSS.t2232 VSS.n2872 187.292
R5389 VSS.t547 VSS.n2879 187.292
R5390 VSS.t1196 VSS.n2886 187.292
R5391 VSS.t1238 VSS.n2895 187.292
R5392 VSS.t2286 VSS.n2902 187.292
R5393 VSS.t953 VSS.n2909 187.292
R5394 VSS.t44 VSS.n2916 187.292
R5395 VSS.n1983 VSS.t2141 187.292
R5396 VSS.n166 VSS.t1177 187.292
R5397 VSS.n1978 VSS.t2129 187.292
R5398 VSS.n171 VSS.t975 187.292
R5399 VSS.n1973 VSS.t1956 187.292
R5400 VSS.n176 VSS.t2064 187.292
R5401 VSS.n1968 VSS.t1340 187.292
R5402 VSS.n181 VSS.t2061 187.292
R5403 VSS.n1963 VSS.t1285 187.292
R5404 VSS.n186 VSS.t2076 187.292
R5405 VSS.n1958 VSS.t1469 187.292
R5406 VSS.n191 VSS.t2066 187.292
R5407 VSS.n1952 VSS.t1988 187.292
R5408 VSS.n196 VSS.t2071 187.292
R5409 VSS.n1947 VSS.t967 187.292
R5410 VSS.n201 VSS.t2070 187.292
R5411 VSS.n1942 VSS.t2337 187.292
R5412 VSS.n206 VSS.t2068 187.292
R5413 VSS.n1937 VSS.t833 187.292
R5414 VSS.n211 VSS.t2065 187.292
R5415 VSS.n1932 VSS.t1996 187.292
R5416 VSS.n216 VSS.t2077 187.292
R5417 VSS.n1927 VSS.t579 187.292
R5418 VSS.n221 VSS.t2106 187.292
R5419 VSS.n1922 VSS.t2342 187.292
R5420 VSS.n226 VSS.t2097 187.292
R5421 VSS.n1917 VSS.t582 187.292
R5422 VSS.n231 VSS.t2096 187.292
R5423 VSS.n1912 VSS.t1361 187.292
R5424 VSS.n236 VSS.t2079 187.292
R5425 VSS.n1907 VSS.t1367 187.292
R5426 VSS.n241 VSS.t2078 187.292
R5427 VSS.n1434 VSS.t2021 187.292
R5428 VSS.n1450 VSS.t1894 187.292
R5429 VSS.n1466 VSS.t1780 187.292
R5430 VSS.n1482 VSS.t2062 187.292
R5431 VSS.n1498 VSS.t1955 187.292
R5432 VSS.n1514 VSS.t2025 187.292
R5433 VSS.n1531 VSS.t2086 187.292
R5434 VSS.n1547 VSS.t2067 187.292
R5435 VSS.n1563 VSS.t2060 187.292
R5436 VSS.n1579 VSS.t2074 187.292
R5437 VSS.n1595 VSS.t2063 187.292
R5438 VSS.n1611 VSS.t1969 187.292
R5439 VSS.n1628 VSS.t2013 187.292
R5440 VSS.n1644 VSS.t2007 187.292
R5441 VSS.n1660 VSS.t2003 187.292
R5442 VSS.n1676 VSS.t1998 187.292
R5443 VSS.n2573 VSS.t256 184.885
R5444 VSS.t245 VSS.n2175 184.885
R5445 VSS.n2596 VSS.t622 184.885
R5446 VSS.t1652 VSS.n1042 184.262
R5447 VSS.n8 VSS.t1145 24.1792
R5448 VSS.t148 VSS.n66 110.549
R5449 VSS.n46 VSS.n44 0.0058807
R5450 VSS.n43 VSS.n41 0.0058807
R5451 VSS.t729 VSS.n48 110.549
R5452 VSS.n40 VSS.n19 0.0058807
R5453 VSS.t1943 VSS.n1020 177.617
R5454 VSS.t1471 VSS.n85 177.615
R5455 VSS.n26 VSS.n25 5.33816
R5456 VSS.t122 VSS.t194 120.84
R5457 VSS.t122 VSS.t214 120.84
R5458 VSS.t560 VSS.n2606 175.31
R5459 VSS.n2585 VSS.n2194 174.419
R5460 VSS.n2568 VSS.n2182 174.419
R5461 VSS.n2197 VSS.n2177 174.419
R5462 VSS.n985 VSS.t677 173.913
R5463 VSS.n973 VSS.t680 173.913
R5464 VSS.n959 VSS.t653 173.913
R5465 VSS.n946 VSS.t1731 173.913
R5466 VSS.n934 VSS.t655 173.913
R5467 VSS.n920 VSS.t686 173.913
R5468 VSS.n906 VSS.t1727 173.913
R5469 VSS.n893 VSS.t691 173.913
R5470 VSS.n878 VSS.t651 173.913
R5471 VSS.n865 VSS.t1247 173.913
R5472 VSS.n851 VSS.t1721 173.913
R5473 VSS.n838 VSS.t689 173.913
R5474 VSS.n822 VSS.t1729 173.913
R5475 VSS.n807 VSS.t693 173.913
R5476 VSS.n794 VSS.t1919 173.913
R5477 VSS.n780 VSS.t683 173.913
R5478 VSS.n1300 VSS.t1466 173.913
R5479 VSS.n1296 VSS.t48 173.913
R5480 VSS.n1292 VSS.t1421 173.913
R5481 VSS.n1288 VSS.t1946 173.913
R5482 VSS.n1284 VSS.t1423 173.913
R5483 VSS.n1280 VSS.t54 173.913
R5484 VSS.n1275 VSS.t1768 173.913
R5485 VSS.n1271 VSS.t60 173.913
R5486 VSS.n1267 VSS.t1419 173.913
R5487 VSS.n1263 VSS.t2034 173.913
R5488 VSS.n1259 VSS.t1425 173.913
R5489 VSS.n1255 VSS.t57 173.913
R5490 VSS.n1251 VSS.t1770 173.913
R5491 VSS.n1247 VSS.t63 173.913
R5492 VSS.n1243 VSS.t1950 173.913
R5493 VSS.n1239 VSS.t51 173.913
R5494 VSS.n1237 VSS.n1236 173.913
R5495 VSS.n2988 VSS.t1054 173.913
R5496 VSS.n2984 VSS.t1809 173.913
R5497 VSS.n2980 VSS.t1383 173.913
R5498 VSS.n2976 VSS.t1869 173.913
R5499 VSS.n2972 VSS.t1386 173.913
R5500 VSS.n2968 VSS.t1814 173.913
R5501 VSS.n2963 VSS.t1320 173.913
R5502 VSS.n2959 VSS.t1789 173.913
R5503 VSS.n2955 VSS.t1381 173.913
R5504 VSS.n2951 VSS.t1379 173.913
R5505 VSS.n2947 VSS.t1388 173.913
R5506 VSS.n2943 VSS.t1817 173.913
R5507 VSS.n2939 VSS.t1322 173.913
R5508 VSS.n2935 VSS.t1791 173.913
R5509 VSS.n2931 VSS.t1080 173.913
R5510 VSS.n2927 VSS.t1811 173.913
R5511 VSS.n2925 VSS.n2924 173.913
R5512 VSS.t1755 VSS.n100 173.913
R5513 VSS.t2256 VSS.n158 173.913
R5514 VSS.t1492 VSS.n154 173.913
R5515 VSS.t1701 VSS.n150 173.913
R5516 VSS.t1495 VSS.n146 173.913
R5517 VSS.t2261 VSS.n142 173.913
R5518 VSS.t2043 VSS.n138 173.913
R5519 VSS.t2265 VSS.n134 173.913
R5520 VSS.t1490 VSS.n130 173.913
R5521 VSS.t1704 VSS.n126 173.913
R5522 VSS.t1497 VSS.n122 173.913
R5523 VSS.t2263 VSS.n118 173.913
R5524 VSS.t2046 VSS.n114 173.913
R5525 VSS.t2267 VSS.n110 173.913
R5526 VSS.t1300 VSS.n106 173.913
R5527 VSS.t2258 VSS.n102 173.913
R5528 VSS.n2787 VSS.n2786 173.913
R5529 VSS.t873 VSS.n1438 173.913
R5530 VSS.t466 VSS.n1454 173.913
R5531 VSS.t1517 VSS.n1470 173.913
R5532 VSS.t1896 VSS.n1486 173.913
R5533 VSS.t897 VSS.n1502 173.913
R5534 VSS.t472 VSS.n1518 173.913
R5535 VSS.t1085 VSS.n1535 173.913
R5536 VSS.t2248 VSS.n1551 173.913
R5537 VSS.t744 VSS.n1567 173.913
R5538 VSS.t1898 VSS.n1583 173.913
R5539 VSS.t900 VSS.n1599 173.913
R5540 VSS.t475 VSS.n1615 173.913
R5541 VSS.t894 VSS.n1632 173.913
R5542 VSS.t2250 VSS.n1648 173.913
R5543 VSS.t1520 VSS.n1664 173.913
R5544 VSS.t469 VSS.n1679 173.913
R5545 VSS.n2602 VSS.t940 173.119
R5546 VSS.n2584 VSS.t902 167.442
R5547 VSS.n1046 VSS.t2321 165.488
R5548 VSS.t666 VSS.t2127 163.881
R5549 VSS.t1725 VSS.t1961 163.881
R5550 VSS.t1881 VSS.t1967 163.881
R5551 VSS.t634 VSS.t1533 163.881
R5552 VSS.t675 VSS.t1931 163.881
R5553 VSS.t637 VSS.t836 163.881
R5554 VSS.t661 VSS.t2246 163.881
R5555 VSS.t643 VSS.t1346 163.881
R5556 VSS.t669 VSS.t973 163.881
R5557 VSS.t631 VSS.t2346 163.881
R5558 VSS.t672 VSS.t733 163.881
R5559 VSS.t640 VSS.t1263 163.881
R5560 VSS.t664 VSS.t737 163.881
R5561 VSS.t646 VSS.t1374 163.881
R5562 VSS.t1879 VSS.t1297 163.881
R5563 VSS.t1723 VSS.t2015 163.881
R5564 VSS.t1862 VSS.t1458 163.881
R5565 VSS.t1194 VSS.t1766 163.881
R5566 VSS.t2288 VSS.t1948 163.881
R5567 VSS.t155 VSS.t1645 163.881
R5568 VSS.t928 VSS.t1464 163.881
R5569 VSS.t140 VSS.t1655 163.881
R5570 VSS.t779 VSS.t2027 163.881
R5571 VSS.t535 VSS.t1659 163.881
R5572 VSS.t479 VSS.t2030 163.881
R5573 VSS.t1643 VSS.t2311 163.881
R5574 VSS.t1462 VSS.t1087 163.881
R5575 VSS.t2355 VSS.t1657 163.881
R5576 VSS.t936 VSS.t1460 163.881
R5577 VSS.t988 VSS.t1661 163.881
R5578 VSS.t1952 VSS.t2182 163.881
R5579 VSS.t1764 VSS.t2314 163.881
R5580 VSS.t1851 VSS.t1061 163.881
R5581 VSS.t1625 VSS.t1393 163.881
R5582 VSS.t1078 VSS.t1291 163.881
R5583 VSS.t2120 VSS.t1909 163.881
R5584 VSS.t1501 VSS.t1063 163.881
R5585 VSS.t1911 VSS.t1839 163.881
R5586 VSS.t98 VSS.t1056 163.881
R5587 VSS.t999 VSS.t1915 163.881
R5588 VSS.t1051 VSS.t137 163.881
R5589 VSS.t704 VSS.t1907 163.881
R5590 VSS.t1102 VSS.t1065 163.881
R5591 VSS.t1011 VSS.t1913 163.881
R5592 VSS.t2181 VSS.t1059 163.881
R5593 VSS.t106 VSS.t1917 163.881
R5594 VSS.t1310 VSS.t1075 163.881
R5595 VSS.t1295 VSS.t1391 163.881
R5596 VSS.t2142 VSS.t1334 163.881
R5597 VSS.t2130 VSS.t2040 163.881
R5598 VSS.t1958 VSS.t1744 163.881
R5599 VSS.t1339 VSS.t2051 163.881
R5600 VSS.t1284 VSS.t1712 163.881
R5601 VSS.t1467 VSS.t2054 163.881
R5602 VSS.t1987 VSS.t1758 163.881
R5603 VSS.t966 VSS.t1715 163.881
R5604 VSS.t2338 VSS.t1337 163.881
R5605 VSS.t831 VSS.t2048 163.881
R5606 VSS.t1995 VSS.t1709 163.881
R5607 VSS.t577 VSS.t2057 163.881
R5608 VSS.t2341 VSS.t1761 163.881
R5609 VSS.t581 VSS.t1718 163.881
R5610 VSS.t1363 VSS.t1741 163.881
R5611 VSS.t1369 VSS.t2037 163.881
R5612 VSS.t1315 VSS.t2375 163.881
R5613 VSS.t1832 VSS.t84 163.881
R5614 VSS.t1445 VSS.t860 163.881
R5615 VSS.t607 VSS.t2215 163.881
R5616 VSS.t1151 VSS.t856 163.881
R5617 VSS.t1450 VSS.t2192 163.881
R5618 VSS.t1407 VSS.t881 163.881
R5619 VSS.t1413 VSS.t2209 163.881
R5620 VSS.t1410 VSS.t1046 163.881
R5621 VSS.t1155 VSS.t2213 163.881
R5622 VSS.t1775 VSS.t1020 163.881
R5623 VSS.t2156 VSS.t2194 163.881
R5624 VSS.t658 VSS.t1049 163.881
R5625 VSS.t2241 VSS.t2211 163.881
R5626 VSS.t2331 VSS.t521 163.881
R5627 VSS.t1214 VSS.t81 163.881
R5628 VSS.t331 VSS.t308 115.335
R5629 VSS.t122 VSS.t198 115.334
R5630 VSS.t122 VSS.t205 115.335
R5631 VSS.t122 VSS.t212 115.334
R5632 VSS.n16 VSS.n71 0.00565951
R5633 VSS.t2 VSS.t369 115.335
R5634 VSS.t2 VSS.t376 115.334
R5635 VSS.n2568 VSS.n2225 160.465
R5636 VSS.n2595 VSS.n2201 160.465
R5637 VSS.n343 VSS.t454 160.341
R5638 VSS.n304 VSS.t395 160.34
R5639 VSS.t406 VSS.n314 160.34
R5640 VSS.t418 VSS.n324 160.34
R5641 VSS.t430 VSS.n38 105.686
R5642 VSS.t441 VSS.n337 160.34
R5643 VSS.n356 VSS.t1401 157.601
R5644 VSS.t2176 VSS.n1739 157.062
R5645 VSS.n2565 VSS.t1313 156.977
R5646 VSS.n28 VSS.t242 161.692
R5647 VSS.n355 VSS.t1526 156.464
R5648 VSS.t776 VSS.n1744 156.429
R5649 VSS.t1267 VSS.n702 155.126
R5650 VSS.n968 VSS.t1979 155.126
R5651 VSS.t1270 VSS.n711 155.126
R5652 VSS.t1986 VSS.n717 155.126
R5653 VSS.n929 VSS.t1173 155.126
R5654 VSS.t795 VSS.n728 155.126
R5655 VSS.t71 VSS.n735 155.126
R5656 VSS.t2202 VSS.n738 155.126
R5657 VSS.t586 VSS.n742 155.126
R5658 VSS.t2205 VSS.n750 155.126
R5659 VSS.t512 VSS.n756 155.126
R5660 VSS.t1653 VSS.n761 155.126
R5661 VSS.t1266 VSS.n765 155.126
R5662 VSS.n673 VSS.t86 155.126
R5663 VSS.n669 VSS.t1872 155.126
R5664 VSS.t801 VSS.n594 155.126
R5665 VSS.n665 VSS.t2224 155.126
R5666 VSS.n661 VSS.t2115 155.126
R5667 VSS.t2238 VSS.n599 155.126
R5668 VSS.n657 VSS.t1179 155.126
R5669 VSS.n650 VSS.t1505 155.126
R5670 VSS.t2230 VSS.n603 155.126
R5671 VSS.t986 VSS.n605 155.126
R5672 VSS.t28 VSS.n608 155.126
R5673 VSS.n637 VSS.t1523 155.126
R5674 VSS.t1821 VSS.n610 155.126
R5675 VSS.t1634 VSS.n612 155.126
R5676 VSS.t785 VSS.n1427 155.126
R5677 VSS.t1318 VSS.n1443 155.126
R5678 VSS.t955 VSS.n1459 155.126
R5679 VSS.t2190 VSS.n1475 155.126
R5680 VSS.t491 VSS.n1491 155.126
R5681 VSS.t1325 VSS.n1507 155.126
R5682 VSS.t1405 VSS.n1524 155.126
R5683 VSS.t1331 VSS.n1540 155.126
R5684 VSS.t648 VSS.n1556 155.126
R5685 VSS.t957 VSS.n1572 155.126
R5686 VSS.t2154 VSS.n1588 155.126
R5687 VSS.t2217 VSS.n1604 155.126
R5688 VSS.t2329 VSS.n1620 155.126
R5689 VSS.t1031 VSS.n1637 155.126
R5690 VSS.t2330 VSS.n1653 155.126
R5691 VSS.t1257 VSS.n1669 155.126
R5692 VSS.t2118 VSS.n696 155.125
R5693 VSS.t510 VSS.n746 155.125
R5694 VSS.t1486 VSS.n769 155.125
R5695 VSS.t800 VSS.n620 155.125
R5696 VSS.t1515 VSS.n625 155.125
R5697 VSS.n436 VSS.t15 155.125
R5698 VSS.n431 VSS.t601 155.125
R5699 VSS.t2281 VSS.n362 155.125
R5700 VSS.n425 VSS.t1843 155.125
R5701 VSS.n420 VSS.t2301 155.125
R5702 VSS.t2285 VSS.n366 155.125
R5703 VSS.n415 VSS.t2171 155.125
R5704 VSS.n410 VSS.t2317 155.125
R5705 VSS.t9 VSS.n369 155.125
R5706 VSS.n405 VSS.t2233 155.125
R5707 VSS.n400 VSS.t1235 155.125
R5708 VSS.t842 VSS.n373 155.125
R5709 VSS.n393 VSS.t2306 155.125
R5710 VSS.n388 VSS.t483 155.125
R5711 VSS.t2307 VSS.n376 155.125
R5712 VSS.n381 VSS.t1398 155.125
R5713 VSS.n2 VSS.t1829 154.862
R5714 VSS.n0 VSS.t2107 154.862
R5715 VSS.n3 VSS.t2087 154.862
R5716 VSS.t17 VSS.n1044 153.971
R5717 VSS.t1125 VSS.n355 153.851
R5718 VSS.n998 VSS.t1846 153.846
R5719 VSS.n988 VSS.t676 153.846
R5720 VSS.n976 VSS.t679 153.846
R5721 VSS.n962 VSS.t652 153.846
R5722 VSS.n949 VSS.t1730 153.846
R5723 VSS.n937 VSS.t654 153.846
R5724 VSS.n923 VSS.t685 153.846
R5725 VSS.n909 VSS.t1726 153.846
R5726 VSS.n896 VSS.t690 153.846
R5727 VSS.n881 VSS.t650 153.846
R5728 VSS.n868 VSS.t1246 153.846
R5729 VSS.n854 VSS.t1720 153.846
R5730 VSS.n841 VSS.t688 153.846
R5731 VSS.n825 VSS.t1728 153.846
R5732 VSS.n810 VSS.t692 153.846
R5733 VSS.n797 VSS.t1918 153.846
R5734 VSS.n783 VSS.t682 153.846
R5735 VSS.t1866 VSS.n1119 153.846
R5736 VSS.t1465 VSS.n1126 153.846
R5737 VSS.t47 VSS.n1133 153.846
R5738 VSS.t1420 VSS.n1140 153.846
R5739 VSS.t1945 VSS.n1147 153.846
R5740 VSS.t1422 VSS.n1154 153.846
R5741 VSS.t53 VSS.n1161 153.846
R5742 VSS.t1767 VSS.n1168 153.846
R5743 VSS.t59 VSS.n1175 153.846
R5744 VSS.t1418 VSS.n1182 153.846
R5745 VSS.t2033 VSS.n1189 153.846
R5746 VSS.t1424 VSS.n1196 153.846
R5747 VSS.t56 VSS.n1203 153.846
R5748 VSS.t1769 VSS.n1212 153.846
R5749 VSS.t62 VSS.n1219 153.846
R5750 VSS.t1949 VSS.n1226 153.846
R5751 VSS.t50 VSS.n1233 153.846
R5752 VSS.t1128 VSS.n2802 153.846
R5753 VSS.t1053 VSS.n2809 153.846
R5754 VSS.t1808 VSS.n2816 153.846
R5755 VSS.t1382 VSS.n2823 153.846
R5756 VSS.t1868 VSS.n2830 153.846
R5757 VSS.t1385 VSS.n2837 153.846
R5758 VSS.t1813 VSS.n2844 153.846
R5759 VSS.t1319 VSS.n2851 153.846
R5760 VSS.t1788 VSS.n2858 153.846
R5761 VSS.t1380 VSS.n2865 153.846
R5762 VSS.t1378 VSS.n2872 153.846
R5763 VSS.t1387 VSS.n2879 153.846
R5764 VSS.t1816 VSS.n2886 153.846
R5765 VSS.t1321 VSS.n2895 153.846
R5766 VSS.t1790 VSS.n2902 153.846
R5767 VSS.t1079 VSS.n2909 153.846
R5768 VSS.t1810 VSS.n2916 153.846
R5769 VSS.n1755 VSS.t1233 153.846
R5770 VSS.t1754 VSS.n166 153.846
R5771 VSS.t2255 VSS.n171 153.846
R5772 VSS.t1491 VSS.n176 153.846
R5773 VSS.t1700 VSS.n181 153.846
R5774 VSS.t1494 VSS.n186 153.846
R5775 VSS.t2260 VSS.n191 153.846
R5776 VSS.t2042 VSS.n196 153.846
R5777 VSS.t2264 VSS.n201 153.846
R5778 VSS.t1489 VSS.n206 153.846
R5779 VSS.t1703 VSS.n211 153.846
R5780 VSS.t1496 VSS.n216 153.846
R5781 VSS.t2262 VSS.n221 153.846
R5782 VSS.t2045 VSS.n226 153.846
R5783 VSS.t2266 VSS.n231 153.846
R5784 VSS.t1299 VSS.n236 153.846
R5785 VSS.t2257 VSS.n241 153.846
R5786 VSS.t2023 VSS.n1420 153.846
R5787 VSS.t872 VSS.n1434 153.846
R5788 VSS.t465 VSS.n1450 153.846
R5789 VSS.t1516 VSS.n1466 153.846
R5790 VSS.t1895 VSS.n1482 153.846
R5791 VSS.t896 VSS.n1498 153.846
R5792 VSS.t471 VSS.n1514 153.846
R5793 VSS.t1084 VSS.n1531 153.846
R5794 VSS.t2247 VSS.n1547 153.846
R5795 VSS.t743 VSS.n1563 153.846
R5796 VSS.t1897 VSS.n1579 153.846
R5797 VSS.t899 VSS.n1595 153.846
R5798 VSS.t474 VSS.n1611 153.846
R5799 VSS.t893 VSS.n1628 153.846
R5800 VSS.t2249 VSS.n1644 153.846
R5801 VSS.t1519 VSS.n1660 153.846
R5802 VSS.t468 VSS.n1676 153.846
R5803 VSS.n1744 VSS.t1281 153.327
R5804 VSS.t2148 VSS.n690 153.236
R5805 VSS.t1508 VSS.n590 153.236
R5806 VSS.t1402 VSS.n349 153.236
R5807 VSS.n574 VSS.t2303 153.236
R5808 VSS.n1746 VSS.t2177 153.236
R5809 VSS.n2585 VSS.t927 150
R5810 VSS.t397 VSS.n304 148.827
R5811 VSS.t409 VSS.n314 148.827
R5812 VSS.t421 VSS.n324 148.827
R5813 VSS.t444 VSS.n337 148.827
R5814 VSS.t457 VSS.n343 148.826
R5815 VSS.n8 VSS.t943 41.5868
R5816 VSS.n987 VSS.t2135 147.157
R5817 VSS.n975 VSS.t2136 147.157
R5818 VSS.n961 VSS.t1976 147.157
R5819 VSS.n948 VSS.t2361 147.157
R5820 VSS.n936 VSS.t1221 147.157
R5821 VSS.n922 VSS.t1994 147.157
R5822 VSS.n908 VSS.t1352 147.157
R5823 VSS.n895 VSS.t848 147.157
R5824 VSS.n880 VSS.t584 147.157
R5825 VSS.n867 VSS.t1261 147.157
R5826 VSS.n853 VSS.t2002 147.157
R5827 VSS.n840 VSS.t699 147.157
R5828 VSS.n824 VSS.t1936 147.157
R5829 VSS.n809 VSS.t1293 147.157
R5830 VSS.n796 VSS.t1229 147.157
R5831 VSS.n782 VSS.t1488 147.157
R5832 VSS.n1301 VSS.t151 147.157
R5833 VSS.n1297 VSS.t841 147.157
R5834 VSS.n1293 VSS.t1441 147.157
R5835 VSS.n1289 VSS.t1308 147.157
R5836 VSS.n1285 VSS.t100 147.157
R5837 VSS.n1281 VSS.t1440 147.157
R5838 VSS.n1276 VSS.t722 147.157
R5839 VSS.n1272 VSS.t996 147.157
R5840 VSS.n1268 VSS.t888 147.157
R5841 VSS.n1264 VSS.t131 147.157
R5842 VSS.n1260 VSS.t2308 147.157
R5843 VSS.n1256 VSS.t2173 147.157
R5844 VSS.n1252 VSS.t144 147.157
R5845 VSS.n1248 VSS.t987 147.157
R5846 VSS.n1244 VSS.t1394 147.157
R5847 VSS.n1240 VSS.t1836 147.157
R5848 VSS.n2989 VSS.t1120 147.157
R5849 VSS.n2985 VSS.t628 147.157
R5850 VSS.n2981 VSS.t2322 147.157
R5851 VSS.n2977 VSS.t477 147.157
R5852 VSS.n2973 VSS.t1823 147.157
R5853 VSS.n2969 VSS.t1130 147.157
R5854 VSS.n2964 VSS.t172 147.157
R5855 VSS.n2960 VSS.t135 147.157
R5856 VSS.n2956 VSS.t2305 147.157
R5857 VSS.n2952 VSS.t1622 147.157
R5858 VSS.n2948 VSS.t2133 147.157
R5859 VSS.n2944 VSS.t569 147.157
R5860 VSS.n2940 VSS.t1311 147.157
R5861 VSS.n2936 VSS.t2304 147.157
R5862 VSS.n2932 VSS.t2319 147.157
R5863 VSS.n2928 VSS.t1118 147.157
R5864 VSS.n1985 VSS.t2143 147.157
R5865 VSS.t2134 VSS.n162 147.157
R5866 VSS.n1980 VSS.t2350 147.157
R5867 VSS.t1923 VSS.n159 147.157
R5868 VSS.n1975 VSS.t1922 147.157
R5869 VSS.t1272 VSS.n155 147.157
R5870 VSS.n1970 VSS.t1427 147.157
R5871 VSS.t1971 VSS.n151 147.157
R5872 VSS.n1965 VSS.t1981 147.157
R5873 VSS.t1978 VSS.n147 147.157
R5874 VSS.n1960 VSS.t1984 147.157
R5875 VSS.t1933 VSS.n143 147.157
R5876 VSS.n1954 VSS.t1287 147.157
R5877 VSS.t1223 VSS.n139 147.157
R5878 VSS.n1949 VSS.t1222 147.157
R5879 VSS.t965 VSS.n135 147.157
R5880 VSS.n1944 VSS.t1260 147.157
R5881 VSS.t1343 VSS.n131 147.157
R5882 VSS.n1939 VSS.t1347 147.157
R5883 VSS.t1432 VSS.n127 147.157
R5884 VSS.n1934 VSS.t1430 147.157
R5885 VSS.t1175 VSS.n123 147.157
R5886 VSS.n1929 VSS.t1353 147.157
R5887 VSS.t1853 VSS.n119 147.157
R5888 VSS.n1924 VSS.t2204 147.157
R5889 VSS.t1855 VSS.n115 147.157
R5890 VSS.n1919 VSS.t73 147.157
R5891 VSS.t851 VSS.n111 147.157
R5892 VSS.n1914 VSS.t508 147.157
R5893 VSS.t2005 VSS.n107 147.157
R5894 VSS.n1909 VSS.t1482 147.157
R5895 VSS.t588 VSS.n103 147.157
R5896 VSS.t1838 VSS.n1435 147.157
R5897 VSS.t606 VSS.n1452 147.157
R5898 VSS.t1826 VSS.n1467 147.157
R5899 VSS.t2189 VSS.n1483 147.157
R5900 VSS.t1863 VSS.n1499 147.157
R5901 VSS.t1253 VSS.n1515 147.157
R5902 VSS.t611 VSS.n1532 147.157
R5903 VSS.t1328 VSS.n1548 147.157
R5904 VSS.t494 VSS.n1564 147.157
R5905 VSS.t1777 VSS.n1581 147.157
R5906 VSS.t1254 VSS.n1596 147.157
R5907 VSS.t2155 VSS.n1612 147.157
R5908 VSS.t1033 VSS.n1629 147.157
R5909 VSS.t960 VSS.n1645 147.157
R5910 VSS.t853 VSS.n1661 147.157
R5911 VSS.t496 VSS.n1677 147.157
R5912 VSS.t264 VSS.n2553 146.853
R5913 VSS.n2576 VSS.n2212 146.853
R5914 VSS.n2582 VSS.n2190 146.512
R5915 VSS.n2573 VSS.n2186 146.512
R5916 VSS.n2559 VSS.n2227 146.512
R5917 VSS.n776 VSS.t1619 145.093
R5918 VSS.t1594 VSS.n354 145.093
R5919 VSS.t1549 VSS.n1682 145.093
R5920 VSS.t1607 VSS.n629 145.091
R5921 VSS.t258 VSS.n2223 143.024
R5922 VSS.n2582 VSS.t1269 139.536
R5923 VSS.t598 VSS.n2177 139.536
R5924 VSS.t1615 VSS.n776 138.404
R5925 VSS.n354 VSS.t1590 138.404
R5926 VSS.n1682 VSS.t1545 138.403
R5927 VSS.n629 VSS.t1603 138.403
R5928 VSS.t464 VSS.n85 137.311
R5929 VSS.n1056 VSS.t1635 137.31
R5930 VSS.n1020 VSS.t453 137.31
R5931 VSS.n44 VSS.n45 0.00760716
R5932 VSS.n41 VSS.n42 0.00760716
R5933 VSS.n47 VSS.n49 0.00760716
R5934 VSS.n19 VSS.n39 0.00760716
R5935 VSS.n2788 VSS.t1560 137.125
R5936 VSS.n2593 VSS.t249 136.048
R5937 VSS.t1277 VSS.n1731 134.661
R5938 VSS.n3006 VSS.t2092 133.78
R5939 VSS.n1330 VSS.t946 133.78
R5940 VSS.t2280 VSS.n1757 133.78
R5941 VSS.n2606 VSS.n2605 132.891
R5942 VSS.n2554 VSS.n2229 132.868
R5943 VSS.n2591 VSS.n2209 132.559
R5944 VSS.n2592 VSS.n2209 132.559
R5945 VSS.t1545 VSS.n1680 131.975
R5946 VSS.n778 VSS.t1615 131.974
R5947 VSS.t1590 VSS.n353 131.974
R5948 VSS.t1603 VSS.n628 131.971
R5949 VSS.n1041 VSS.t1786 130.939
R5950 VSS.n1903 VSS.t1556 130.435
R5951 VSS.n2579 VSS.t1121 129.071
R5952 VSS.n2599 VSS.t917 129.071
R5953 VSS.t1183 VSS.n2224 129.071
R5954 VSS.n2564 VSS.t261 129.071
R5955 VSS.n28 VSS.t542 10.0882
R5956 VSS.t919 VSS.n2202 129.071
R5957 VSS.t1094 VSS.n1388 127.421
R5958 VSS.n1738 VSS.t1805 126.945
R5959 VSS.t903 VSS.n2191 125.582
R5960 VSS.t1556 VSS.n1897 123.746
R5961 VSS.n1391 VSS.t1631 123.674
R5962 VSS.t1874 VSS.n1734 123.212
R5963 VSS.n89 VSS.t1549 122.516
R5964 VSS.t1619 VSS.n81 122.516
R5965 VSS.n2748 VSS.n468 122.129
R5966 VSS.t249 VSS.n2207 122.094
R5967 VSS.n2129 VSS.t1189 121.858
R5968 VSS.t2092 VSS.n690 120.691
R5969 VSS.t946 VSS.n590 120.691
R5970 VSS.t1526 VSS.n349 120.691
R5971 VSS.n574 VSS.t2280 120.691
R5972 VSS.n1746 VSS.t776 120.691
R5973 VSS.t763 VSS.n1049 119.422
R5974 VSS.n2583 VSS.t903 118.606
R5975 VSS.n2558 VSS.t264 118.606
R5976 VSS.n2594 VSS.n2205 118.606
R5977 VSS.t1399 VSS.n358 118.249
R5978 VSS.n1731 VSS.t2175 117.858
R5979 VSS.n1237 VSS.t1607 117.058
R5980 VSS.n2925 VSS.t1594 117.058
R5981 VSS.t1560 VSS.n2787 117.058
R5982 VSS.t1803 VSS.n1392 116.177
R5983 VSS.n1733 VSS.t1892 115.745
R5984 VSS.n2590 VSS.t920 115.117
R5985 VSS.t528 VSS.n2124 112.174
R5986 VSS.n1334 VSS.n1073 112.15
R5987 VSS.t1305 VSS.n2212 111.888
R5988 VSS.n1065 VSS.t2083 109.198
R5989 VSS.t978 VSS.n1075 109.198
R5990 VSS.n1759 VSS.t77 109.198
R5991 VSS.n1390 VSS.t1804 108.683
R5992 VSS.t1893 VSS.n1736 108.276
R5993 VSS.n993 VSS.t2118 107.023
R5994 VSS.t2135 VSS.n986 107.023
R5995 VSS.n981 VSS.t1267 107.023
R5996 VSS.t2136 VSS.n974 107.023
R5997 VSS.t1979 VSS.n967 107.023
R5998 VSS.t1976 VSS.n960 107.023
R5999 VSS.n954 VSS.t1270 107.023
R6000 VSS.t2361 VSS.n947 107.023
R6001 VSS.n942 VSS.t1986 107.023
R6002 VSS.t1221 VSS.n935 107.023
R6003 VSS.t1173 VSS.n928 107.023
R6004 VSS.t1994 VSS.n921 107.023
R6005 VSS.n914 VSS.t795 107.023
R6006 VSS.t1352 VSS.n907 107.023
R6007 VSS.n902 VSS.t71 107.023
R6008 VSS.t848 VSS.n894 107.023
R6009 VSS.n887 VSS.t2202 107.023
R6010 VSS.t584 VSS.n879 107.023
R6011 VSS.n873 VSS.t586 107.023
R6012 VSS.t1261 VSS.n866 107.023
R6013 VSS.n860 VSS.t510 107.023
R6014 VSS.t2002 VSS.n852 107.023
R6015 VSS.n846 VSS.t2205 107.023
R6016 VSS.t699 VSS.n839 107.023
R6017 VSS.n833 VSS.t512 107.023
R6018 VSS.t1936 VSS.n823 107.023
R6019 VSS.n816 VSS.t1653 107.023
R6020 VSS.t1293 VSS.n808 107.023
R6021 VSS.n802 VSS.t1266 107.023
R6022 VSS.t1229 VSS.n795 107.023
R6023 VSS.n789 VSS.t1486 107.023
R6024 VSS.t1488 VSS.n781 107.023
R6025 VSS.t86 VSS.n1124 107.023
R6026 VSS.t151 VSS.n1127 107.023
R6027 VSS.t1872 VSS.n1131 107.023
R6028 VSS.t841 VSS.n1134 107.023
R6029 VSS.n1138 VSS.t801 107.023
R6030 VSS.t1441 VSS.n1141 107.023
R6031 VSS.t2224 VSS.n1145 107.023
R6032 VSS.t1308 VSS.n1148 107.023
R6033 VSS.t2115 VSS.n1152 107.023
R6034 VSS.t100 VSS.n1155 107.023
R6035 VSS.n1159 VSS.t2238 107.023
R6036 VSS.t1440 VSS.n1162 107.023
R6037 VSS.t1179 VSS.n1166 107.023
R6038 VSS.t722 VSS.n1169 107.023
R6039 VSS.n1173 VSS.t800 107.023
R6040 VSS.t996 VSS.n1176 107.023
R6041 VSS.t1505 VSS.n1180 107.023
R6042 VSS.t888 VSS.n1183 107.023
R6043 VSS.n1187 VSS.t2230 107.023
R6044 VSS.t131 VSS.n1190 107.023
R6045 VSS.n1194 VSS.t986 107.023
R6046 VSS.t2308 VSS.n1197 107.023
R6047 VSS.n1201 VSS.t28 107.023
R6048 VSS.t2173 VSS.n1204 107.023
R6049 VSS.n1209 VSS.t1515 107.023
R6050 VSS.t144 VSS.n1213 107.023
R6051 VSS.t1523 VSS.n1217 107.023
R6052 VSS.t987 VSS.n1220 107.023
R6053 VSS.n1224 VSS.t1821 107.023
R6054 VSS.t1394 VSS.n1227 107.023
R6055 VSS.n1231 VSS.t1634 107.023
R6056 VSS.t1836 VSS.n1234 107.023
R6057 VSS.t15 VSS.n2807 107.023
R6058 VSS.t1120 VSS.n2810 107.023
R6059 VSS.t601 VSS.n2814 107.023
R6060 VSS.t628 VSS.n2817 107.023
R6061 VSS.n2821 VSS.t2281 107.023
R6062 VSS.t2322 VSS.n2824 107.023
R6063 VSS.t1843 VSS.n2828 107.023
R6064 VSS.t477 VSS.n2831 107.023
R6065 VSS.t2301 VSS.n2835 107.023
R6066 VSS.t1823 VSS.n2838 107.023
R6067 VSS.n2842 VSS.t2285 107.023
R6068 VSS.t1130 VSS.n2845 107.023
R6069 VSS.t2171 VSS.n2849 107.023
R6070 VSS.t172 VSS.n2852 107.023
R6071 VSS.t2317 VSS.n2856 107.023
R6072 VSS.t135 VSS.n2859 107.023
R6073 VSS.n2863 VSS.t9 107.023
R6074 VSS.t2305 VSS.n2866 107.023
R6075 VSS.t2233 VSS.n2870 107.023
R6076 VSS.t1622 VSS.n2873 107.023
R6077 VSS.t1235 VSS.n2877 107.023
R6078 VSS.t2133 VSS.n2880 107.023
R6079 VSS.n2884 VSS.t842 107.023
R6080 VSS.t569 VSS.n2887 107.023
R6081 VSS.t2306 VSS.n2892 107.023
R6082 VSS.t1311 VSS.n2896 107.023
R6083 VSS.t483 VSS.n2900 107.023
R6084 VSS.t2304 VSS.n2903 107.023
R6085 VSS.n2907 VSS.t2307 107.023
R6086 VSS.t2319 VSS.n2910 107.023
R6087 VSS.t1398 VSS.n2914 107.023
R6088 VSS.t1118 VSS.n2917 107.023
R6089 VSS.t2143 VSS.n164 107.023
R6090 VSS.n167 VSS.t2134 107.023
R6091 VSS.t2350 VSS.n169 107.023
R6092 VSS.n172 VSS.t1923 107.023
R6093 VSS.t1922 VSS.n174 107.023
R6094 VSS.n177 VSS.t1272 107.023
R6095 VSS.t1427 VSS.n179 107.023
R6096 VSS.n182 VSS.t1971 107.023
R6097 VSS.t1981 VSS.n184 107.023
R6098 VSS.n187 VSS.t1978 107.023
R6099 VSS.t1984 VSS.n189 107.023
R6100 VSS.n192 VSS.t1933 107.023
R6101 VSS.t1287 VSS.n194 107.023
R6102 VSS.n197 VSS.t1223 107.023
R6103 VSS.t1222 VSS.n199 107.023
R6104 VSS.n202 VSS.t965 107.023
R6105 VSS.t1260 VSS.n204 107.023
R6106 VSS.n207 VSS.t1343 107.023
R6107 VSS.t1347 VSS.n209 107.023
R6108 VSS.n212 VSS.t1432 107.023
R6109 VSS.t1430 VSS.n214 107.023
R6110 VSS.n217 VSS.t1175 107.023
R6111 VSS.t1353 VSS.n219 107.023
R6112 VSS.n222 VSS.t1853 107.023
R6113 VSS.t2204 VSS.n224 107.023
R6114 VSS.n227 VSS.t1855 107.023
R6115 VSS.t73 VSS.n229 107.023
R6116 VSS.n232 VSS.t851 107.023
R6117 VSS.t508 VSS.n234 107.023
R6118 VSS.n237 VSS.t2005 107.023
R6119 VSS.t1482 VSS.n239 107.023
R6120 VSS.n242 VSS.t588 107.023
R6121 VSS.n1429 VSS.t785 107.023
R6122 VSS.n1437 VSS.t1838 107.023
R6123 VSS.n1445 VSS.t1318 107.023
R6124 VSS.n1453 VSS.t606 107.023
R6125 VSS.n1460 VSS.t955 107.023
R6126 VSS.n1468 VSS.t1826 107.023
R6127 VSS.n1476 VSS.t2190 107.023
R6128 VSS.n1484 VSS.t2189 107.023
R6129 VSS.n1492 VSS.t491 107.023
R6130 VSS.n1500 VSS.t1863 107.023
R6131 VSS.n1509 VSS.t1325 107.023
R6132 VSS.n1517 VSS.t1253 107.023
R6133 VSS.n1525 VSS.t1405 107.023
R6134 VSS.n1533 VSS.t611 107.023
R6135 VSS.n1541 VSS.t1331 107.023
R6136 VSS.n1549 VSS.t1328 107.023
R6137 VSS.n1558 VSS.t648 107.023
R6138 VSS.n1566 VSS.t494 107.023
R6139 VSS.n1574 VSS.t957 107.023
R6140 VSS.n1582 VSS.t1777 107.023
R6141 VSS.n1589 VSS.t2154 107.023
R6142 VSS.n1597 VSS.t1254 107.023
R6143 VSS.n1605 VSS.t2217 107.023
R6144 VSS.n1613 VSS.t2155 107.023
R6145 VSS.n1622 VSS.t2329 107.023
R6146 VSS.n1630 VSS.t1033 107.023
R6147 VSS.n1638 VSS.t1031 107.023
R6148 VSS.n1647 VSS.t960 107.023
R6149 VSS.n1655 VSS.t2330 107.023
R6150 VSS.n1662 VSS.t853 107.023
R6151 VSS.n1670 VSS.t1257 107.023
R6152 VSS.n1678 VSS.t496 107.023
R6153 VSS.n2801 VSS.t12 106.808
R6154 VSS.n2578 VSS.n2214 104.651
R6155 VSS.n2584 VSS.n2192 104.651
R6156 VSS.n2571 VSS.t942 104.651
R6157 VSS.n2570 VSS.n2184 104.651
R6158 VSS.n2564 VSS.n2225 104.651
R6159 VSS.n2198 VSS.n2174 104.651
R6160 VSS.n467 VSS.t38 103.538
R6161 VSS.n463 VSS.t2351 103.379
R6162 VSS.n2570 VSS.t1183 101.163
R6163 VSS.t261 VSS.n2183 101.163
R6164 VSS.n2590 VSS.t992 101.163
R6165 VSS.n98 VSS.t93 100.344
R6166 VSS.t545 VSS.n93 100.344
R6167 VSS.n577 VSS.t2017 100.344
R6168 VSS.t1610 VSS.n998 100.335
R6169 VSS.t676 VSS.n987 100.335
R6170 VSS.t679 VSS.n975 100.335
R6171 VSS.t652 VSS.n961 100.335
R6172 VSS.t1730 VSS.n948 100.335
R6173 VSS.t654 VSS.n936 100.335
R6174 VSS.t685 VSS.n922 100.335
R6175 VSS.t1726 VSS.n908 100.335
R6176 VSS.t690 VSS.n895 100.335
R6177 VSS.t650 VSS.n880 100.335
R6178 VSS.t1246 VSS.n867 100.335
R6179 VSS.t1720 VSS.n853 100.335
R6180 VSS.t688 VSS.n840 100.335
R6181 VSS.t1728 VSS.n824 100.335
R6182 VSS.t692 VSS.n809 100.335
R6183 VSS.t1918 VSS.n796 100.335
R6184 VSS.t682 VSS.n782 100.335
R6185 VSS.n1119 VSS.t1597 100.335
R6186 VSS.n1301 VSS.t1465 100.335
R6187 VSS.n1297 VSS.t47 100.335
R6188 VSS.n1293 VSS.t1420 100.335
R6189 VSS.n1289 VSS.t1945 100.335
R6190 VSS.n1285 VSS.t1422 100.335
R6191 VSS.n1281 VSS.t53 100.335
R6192 VSS.n1276 VSS.t1767 100.335
R6193 VSS.n1272 VSS.t59 100.335
R6194 VSS.n1268 VSS.t1418 100.335
R6195 VSS.n1264 VSS.t2033 100.335
R6196 VSS.n1260 VSS.t1424 100.335
R6197 VSS.n1256 VSS.t56 100.335
R6198 VSS.n1252 VSS.t1769 100.335
R6199 VSS.n1248 VSS.t62 100.335
R6200 VSS.n1244 VSS.t1949 100.335
R6201 VSS.n1240 VSS.t50 100.335
R6202 VSS.t1585 VSS.n2802 100.335
R6203 VSS.n2989 VSS.t1053 100.335
R6204 VSS.n2985 VSS.t1808 100.335
R6205 VSS.n2981 VSS.t1382 100.335
R6206 VSS.n2977 VSS.t1868 100.335
R6207 VSS.n2973 VSS.t1385 100.335
R6208 VSS.n2969 VSS.t1813 100.335
R6209 VSS.n2964 VSS.t1319 100.335
R6210 VSS.n2960 VSS.t1788 100.335
R6211 VSS.n2956 VSS.t1380 100.335
R6212 VSS.n2952 VSS.t1378 100.335
R6213 VSS.n2948 VSS.t1387 100.335
R6214 VSS.n2944 VSS.t1816 100.335
R6215 VSS.n2940 VSS.t1321 100.335
R6216 VSS.n2936 VSS.t1790 100.335
R6217 VSS.n2932 VSS.t1079 100.335
R6218 VSS.n2928 VSS.t1810 100.335
R6219 VSS.t1551 VSS.n1755 100.335
R6220 VSS.n162 VSS.t1754 100.335
R6221 VSS.n159 VSS.t2255 100.335
R6222 VSS.n155 VSS.t1491 100.335
R6223 VSS.n151 VSS.t1700 100.335
R6224 VSS.n147 VSS.t1494 100.335
R6225 VSS.n143 VSS.t2260 100.335
R6226 VSS.n139 VSS.t2042 100.335
R6227 VSS.n135 VSS.t2264 100.335
R6228 VSS.n131 VSS.t1489 100.335
R6229 VSS.n127 VSS.t1703 100.335
R6230 VSS.n123 VSS.t1496 100.335
R6231 VSS.n119 VSS.t2262 100.335
R6232 VSS.n115 VSS.t2045 100.335
R6233 VSS.n111 VSS.t2266 100.335
R6234 VSS.n107 VSS.t1299 100.335
R6235 VSS.n103 VSS.t2257 100.335
R6236 VSS.n1420 VSS.t1539 100.335
R6237 VSS.n1435 VSS.t872 100.335
R6238 VSS.n1452 VSS.t465 100.335
R6239 VSS.n1467 VSS.t1516 100.335
R6240 VSS.n1483 VSS.t1895 100.335
R6241 VSS.n1499 VSS.t896 100.335
R6242 VSS.n1515 VSS.t471 100.335
R6243 VSS.n1532 VSS.t1084 100.335
R6244 VSS.n1548 VSS.t2247 100.335
R6245 VSS.n1564 VSS.t743 100.335
R6246 VSS.n1581 VSS.t1897 100.335
R6247 VSS.n1596 VSS.t899 100.335
R6248 VSS.n1612 VSS.t474 100.335
R6249 VSS.n1629 VSS.t893 100.335
R6250 VSS.n1645 VSS.t2249 100.335
R6251 VSS.n1661 VSS.t1519 100.335
R6252 VSS.n1677 VSS.t468 100.335
R6253 VSS.t1575 VSS.n8 50.4932
R6254 VSS.t1581 VSS.n23 50.4931
R6255 VSS.n2133 VSS.t1197 98.4633
R6256 VSS.n1386 VSS.t1124 97.4396
R6257 VSS.n99 VSS.t1522 97.3935
R6258 VSS.t500 VSS.n94 97.3935
R6259 VSS.n579 VSS.t1938 97.3935
R6260 VSS.t1280 VSS.n1742 97.0758
R6261 VSS.n1054 VSS.t764 96.3896
R6262 VSS.n1010 VSS.t933 94.4422
R6263 VSS.n1338 VSS.t65 94.4422
R6264 VSS.n1413 VSS.t1396 94.4422
R6265 VSS.t263 VSS.n2227 94.1866
R6266 VSS.t1096 VSS.n356 93.8889
R6267 VSS.t13 VSS.n1386 93.6919
R6268 VSS.n1739 VSS.t1807 93.5889
R6269 VSS.n1742 VSS.t1278 93.3421
R6270 VSS.t767 VSS.n95 91.4909
R6271 VSS.t823 VSS.n90 91.4909
R6272 VSS.t700 VSS.n580 91.4909
R6273 VSS.n2557 VSS.t1511 90.9096
R6274 VSS.n2583 VSS.n2216 90.6982
R6275 VSS.n2600 VSS.n2223 90.6982
R6276 VSS.n2197 VSS.n2173 90.6982
R6277 VSS.n2596 VSS.n2202 90.6982
R6278 VSS.t51 VSS.n628 88.495
R6279 VSS.t683 VSS.n778 88.4947
R6280 VSS.t1811 VSS.n353 88.4945
R6281 VSS.n1680 VSS.t469 88.4935
R6282 VSS.n359 VSS.t1524 88.4111
R6283 VSS.t531 VSS.n465 88.3462
R6284 VSS.t651 VSS.n740 88.2366
R6285 VSS.t693 VSS.n763 88.2366
R6286 VSS.t48 VSS.n616 88.2366
R6287 VSS.t1423 VSS.n618 88.2366
R6288 VSS.t57 VSS.n624 88.2366
R6289 VSS.t677 VSS.n700 88.2359
R6290 VSS.t680 VSS.n972 88.2359
R6291 VSS.t653 VSS.n710 88.2359
R6292 VSS.t1731 VSS.n715 88.2359
R6293 VSS.t655 VSS.n933 88.2359
R6294 VSS.t686 VSS.n725 88.2359
R6295 VSS.t1727 VSS.n732 88.2359
R6296 VSS.t691 VSS.n892 88.2359
R6297 VSS.t1247 VSS.n745 88.2359
R6298 VSS.t1721 VSS.n850 88.2359
R6299 VSS.t689 VSS.n837 88.2359
R6300 VSS.t1729 VSS.n821 88.2359
R6301 VSS.t1919 VSS.n768 88.2359
R6302 VSS.t1466 VSS.n670 88.2359
R6303 VSS.t1421 VSS.n666 88.2359
R6304 VSS.t1946 VSS.n662 88.2359
R6305 VSS.t54 VSS.n658 88.2359
R6306 VSS.t1768 VSS.n654 88.2359
R6307 VSS.t60 VSS.n651 88.2359
R6308 VSS.t1419 VSS.n648 88.2359
R6309 VSS.t2034 VSS.n646 88.2359
R6310 VSS.t1425 VSS.n607 88.2359
R6311 VSS.t1770 VSS.n638 88.2359
R6312 VSS.t63 VSS.n635 88.2359
R6313 VSS.t1950 VSS.n633 88.2359
R6314 VSS.n1439 VSS.t873 88.2357
R6315 VSS.n1455 VSS.t466 88.2357
R6316 VSS.n1471 VSS.t1517 88.2357
R6317 VSS.n1487 VSS.t1896 88.2357
R6318 VSS.n1503 VSS.t897 88.2357
R6319 VSS.n1519 VSS.t472 88.2357
R6320 VSS.n1536 VSS.t1085 88.2357
R6321 VSS.n1552 VSS.t2248 88.2357
R6322 VSS.n1568 VSS.t744 88.2357
R6323 VSS.n1584 VSS.t1898 88.2357
R6324 VSS.n1600 VSS.t900 88.2357
R6325 VSS.n1616 VSS.t475 88.2357
R6326 VSS.n1633 VSS.t894 88.2357
R6327 VSS.n1649 VSS.t2250 88.2357
R6328 VSS.n1665 VSS.t1520 88.2357
R6329 VSS.t1054 VSS.n433 88.2357
R6330 VSS.t1383 VSS.n426 88.2357
R6331 VSS.t1869 VSS.n422 88.2357
R6332 VSS.t1814 VSS.n416 88.2357
R6333 VSS.t1320 VSS.n412 88.2357
R6334 VSS.t1789 VSS.n408 88.2357
R6335 VSS.t1381 VSS.n406 88.2357
R6336 VSS.t1379 VSS.n402 88.2357
R6337 VSS.t1388 VSS.n398 88.2357
R6338 VSS.t1817 VSS.n395 88.2357
R6339 VSS.t1322 VSS.n390 88.2357
R6340 VSS.t1791 VSS.n386 88.2357
R6341 VSS.t1080 VSS.n383 88.2357
R6342 VSS.t1809 VSS.n361 88.2357
R6343 VSS.t1386 VSS.n365 88.2357
R6344 VSS.n1730 VSS.t773 88.133
R6345 VSS.n1236 VSS.n587 88.4708
R6346 VSS.n2579 VSS.t921 87.2098
R6347 VSS.n2572 VSS.t253 87.2098
R6348 VSS.t42 VSS.n2184 87.2098
R6349 VSS.t2179 VSS.n2201 87.2098
R6350 VSS.t1844 VSS.t1610 86.957
R6351 VSS.t1846 VSS.t1612 86.957
R6352 VSS.t1597 VSS.t1865 86.957
R6353 VSS.t1599 VSS.t1866 86.957
R6354 VSS.t1126 VSS.t1585 86.957
R6355 VSS.t1587 VSS.t1128 86.957
R6356 VSS.t1231 VSS.t1551 86.957
R6357 VSS.t1233 VSS.t1553 86.957
R6358 VSS.t1539 VSS.t2022 86.957
R6359 VSS.t1542 VSS.t2023 86.957
R6360 VSS.t769 VSS.n96 85.5883
R6361 VSS.t822 VSS.n91 85.5883
R6362 VSS.t702 VSS.n578 85.5883
R6363 VSS.t2320 VSS.n1054 84.8733
R6364 VSS.n2996 VSS.t1524 83.0562
R6365 VSS.t773 VSS.n1394 82.7875
R6366 VSS.t1525 VSS.n1390 82.449
R6367 VSS.n1736 VSS.t775 82.1411
R6368 VSS.t532 VSS.n2130 81.2384
R6369 VSS.n3013 VSS.t1131 81.1613
R6370 VSS.t33 VSS.n1316 81.1613
R6371 VSS.n1770 VSS.t20 81.1613
R6372 VSS.n8 VSS.t2195 49.0107
R6373 VSS.n1993 VSS.t1755 80.2681
R6374 VSS.n2000 VSS.t2256 80.2681
R6375 VSS.n2007 VSS.t1492 80.2681
R6376 VSS.n2014 VSS.t1701 80.2681
R6377 VSS.n2021 VSS.t1495 80.2681
R6378 VSS.n2029 VSS.t2261 80.2681
R6379 VSS.n2036 VSS.t2043 80.2681
R6380 VSS.n2043 VSS.t2265 80.2681
R6381 VSS.n2050 VSS.t1490 80.2681
R6382 VSS.n2057 VSS.t1704 80.2681
R6383 VSS.n2064 VSS.t1497 80.2681
R6384 VSS.n2071 VSS.t2263 80.2681
R6385 VSS.n2078 VSS.t2046 80.2681
R6386 VSS.n2085 VSS.t2267 80.2681
R6387 VSS.n2092 VSS.t1300 80.2681
R6388 VSS.n2098 VSS.t2258 80.2681
R6389 VSS.n2786 VSS.n243 80.2681
R6390 VSS.n2176 VSS.t245 80.2331
R6391 VSS.t331 VSS.t343 67.8627
R6392 VSS.t225 VSS.t122 67.8627
R6393 VSS.t389 VSS.t2 67.8627
R6394 VSS.t305 VSS.t331 67.8617
R6395 VSS.t312 VSS.t331 67.8615
R6396 VSS.t331 VSS.t320 140.102
R6397 VSS.t331 VSS.t327 140.103
R6398 VSS.t188 VSS.t122 67.8617
R6399 VSS.t195 VSS.t122 67.8615
R6400 VSS.t122 VSS.t203 140.102
R6401 VSS.t122 VSS.t216 140.102
R6402 VSS.n18 VSS.n16 2.39337
R6403 VSS.t352 VSS.t2 67.8617
R6404 VSS.t359 VSS.t2 67.862
R6405 VSS.t366 VSS.t2 67.8617
R6406 VSS.t2 VSS.t374 140.103
R6407 VSS.n2663 VSS.t1204 77.8798
R6408 VSS.n263 VSS.n2219 77.8593
R6409 VSS.n266 VSS.n2220 77.8593
R6410 VSS.n257 VSS.n2208 77.8593
R6411 VSS.n2745 VSS.t2225 77.2751
R6412 VSS.t1190 VSS.t1883 77.2751
R6413 VSS.n2581 VSS.n2218 76.7447
R6414 VSS.n2552 VSS.n2180 76.7447
R6415 VSS.n2593 VSS.n2206 76.7447
R6416 VSS.n97 VSS.t2082 76.7344
R6417 VSS.t977 VSS.n92 76.7344
R6418 VSS.n576 VSS.t75 76.7344
R6419 VSS.n357 VSS.t1525 75.2962
R6420 VSS.t775 VSS.n1735 75.0671
R6421 VSS.n1392 VSS.t1629 74.9537
R6422 VSS.n1004 VSS.t1844 74.8587
R6423 VSS.t2022 VSS.n1418 74.8585
R6424 VSS.t1865 VSS.n614 74.8579
R6425 VSS.n573 VSS.t1231 74.8578
R6426 VSS.n438 VSS.t1126 74.8578
R6427 VSS.t1298 VSS.n2604 74.7824
R6428 VSS.t1873 VSS.n1733 74.6738
R6429 VSS.t2310 VSS.n1051 73.9682
R6430 VSS.n97 VSS.t934 73.7831
R6431 VSS.t66 VSS.n92 73.7831
R6432 VSS.n576 VSS.t1397 73.7831
R6433 VSS.t1186 VSS.n2125 73.536
R6434 VSS.n2747 VSS.n2746 73.536
R6435 VSS.t921 VSS.n2192 73.2563
R6436 VSS.n2561 VSS.t42 73.2563
R6437 VSS.n993 VSS.t666 70.2346
R6438 VSS.n981 VSS.t1725 70.2346
R6439 VSS.n967 VSS.t1881 70.2346
R6440 VSS.n954 VSS.t634 70.2346
R6441 VSS.n942 VSS.t675 70.2346
R6442 VSS.n928 VSS.t637 70.2346
R6443 VSS.n914 VSS.t661 70.2346
R6444 VSS.n902 VSS.t643 70.2346
R6445 VSS.n887 VSS.t669 70.2346
R6446 VSS.n873 VSS.t631 70.2346
R6447 VSS.n860 VSS.t672 70.2346
R6448 VSS.n846 VSS.t640 70.2346
R6449 VSS.n833 VSS.t664 70.2346
R6450 VSS.n816 VSS.t646 70.2346
R6451 VSS.n802 VSS.t1879 70.2346
R6452 VSS.n789 VSS.t1723 70.2346
R6453 VSS.t1458 VSS.n1124 70.2346
R6454 VSS.t1766 VSS.n1131 70.2346
R6455 VSS.t1948 VSS.n1138 70.2346
R6456 VSS.t1645 VSS.n1145 70.2346
R6457 VSS.t1464 VSS.n1152 70.2346
R6458 VSS.t1655 VSS.n1159 70.2346
R6459 VSS.t2027 VSS.n1166 70.2346
R6460 VSS.t1659 VSS.n1173 70.2346
R6461 VSS.t2030 VSS.n1180 70.2346
R6462 VSS.n1187 VSS.t1643 70.2346
R6463 VSS.n1194 VSS.t1462 70.2346
R6464 VSS.t1657 VSS.n1201 70.2346
R6465 VSS.t1460 VSS.n1209 70.2346
R6466 VSS.t1661 VSS.n1217 70.2346
R6467 VSS.n1224 VSS.t1952 70.2346
R6468 VSS.n1231 VSS.t1764 70.2346
R6469 VSS.t1061 VSS.n2807 70.2346
R6470 VSS.t1393 VSS.n2814 70.2346
R6471 VSS.n2821 VSS.t1078 70.2346
R6472 VSS.t1909 VSS.n2828 70.2346
R6473 VSS.t1063 VSS.n2835 70.2346
R6474 VSS.n2842 VSS.t1911 70.2346
R6475 VSS.t1056 VSS.n2849 70.2346
R6476 VSS.t1915 VSS.n2856 70.2346
R6477 VSS.n2863 VSS.t1051 70.2346
R6478 VSS.t1907 VSS.n2870 70.2346
R6479 VSS.t1065 VSS.n2877 70.2346
R6480 VSS.t1913 VSS.n2884 70.2346
R6481 VSS.t1059 VSS.n2892 70.2346
R6482 VSS.t1917 VSS.n2900 70.2346
R6483 VSS.t1075 VSS.n2907 70.2346
R6484 VSS.t1391 VSS.n2914 70.2346
R6485 VSS.t1334 VSS.n164 70.2346
R6486 VSS.t2040 VSS.n169 70.2346
R6487 VSS.t1744 VSS.n174 70.2346
R6488 VSS.t2051 VSS.n179 70.2346
R6489 VSS.t1712 VSS.n184 70.2346
R6490 VSS.t2054 VSS.n189 70.2346
R6491 VSS.t1758 VSS.n194 70.2346
R6492 VSS.t1715 VSS.n199 70.2346
R6493 VSS.t1337 VSS.n204 70.2346
R6494 VSS.t2048 VSS.n209 70.2346
R6495 VSS.t1709 VSS.n214 70.2346
R6496 VSS.t2057 VSS.n219 70.2346
R6497 VSS.t1761 VSS.n224 70.2346
R6498 VSS.t1718 VSS.n229 70.2346
R6499 VSS.t1741 VSS.n234 70.2346
R6500 VSS.t2037 VSS.n239 70.2346
R6501 VSS.t2375 VSS.n1429 70.2346
R6502 VSS.t84 VSS.n1445 70.2346
R6503 VSS.t860 VSS.n1460 70.2346
R6504 VSS.t2215 VSS.n1476 70.2346
R6505 VSS.t856 VSS.n1492 70.2346
R6506 VSS.t2192 VSS.n1509 70.2346
R6507 VSS.t881 VSS.n1525 70.2346
R6508 VSS.t2209 VSS.n1541 70.2346
R6509 VSS.t1046 VSS.n1558 70.2346
R6510 VSS.t2213 VSS.n1574 70.2346
R6511 VSS.t1020 VSS.n1589 70.2346
R6512 VSS.t2194 VSS.n1605 70.2346
R6513 VSS.t1049 VSS.n1622 70.2346
R6514 VSS.t2211 VSS.n1638 70.2346
R6515 VSS.t521 VSS.n1655 70.2346
R6516 VSS.t81 VSS.n1670 70.2346
R6517 VSS.n2744 VSS.n546 6.23647
R6518 VSS.t1122 VSS.n2190 69.7679
R6519 VSS.n2574 VSS.t1123 69.7679
R6520 VSS.n2639 VSS.t2296 69.1047
R6521 VSS.t713 VSS.n2677 68.9334
R6522 VSS.n1021 VSS.t459 68.211
R6523 VSS.t399 VSS.n308 68.21
R6524 VSS.t411 VSS.n318 68.21
R6525 VSS.t423 VSS.n328 68.21
R6526 VSS.n22 VSS.n21 0.00164082
R6527 VSS.t446 VSS.n77 68.21
R6528 VSS.n2681 VSS.t994 67.4615
R6529 VSS.t1629 VSS.n1391 67.4583
R6530 VSS.n1734 VSS.t1873 67.2065
R6531 VSS.t1206 VSS.n2619 66.9109
R6532 VSS.n991 VSS.t2126 66.8901
R6533 VSS.n990 VSS.t604 66.8901
R6534 VSS.n979 VSS.t1960 66.8901
R6535 VSS.n978 VSS.t177 66.8901
R6536 VSS.t1966 VSS.n965 66.8901
R6537 VSS.n964 VSS.t543 66.8901
R6538 VSS.n952 VSS.t1534 66.8901
R6539 VSS.n951 VSS.t2366 66.8901
R6540 VSS.n940 VSS.t1930 66.8901
R6541 VSS.n939 VSS.t1800 66.8901
R6542 VSS.t835 VSS.n926 66.8901
R6543 VSS.n925 VSS.t815 66.8901
R6544 VSS.n912 VSS.t2245 66.8901
R6545 VSS.n911 VSS.t40 66.8901
R6546 VSS.t1344 VSS.n899 66.8901
R6547 VSS.n898 VSS.t1849 66.8901
R6548 VSS.t972 VSS.n884 66.8901
R6549 VSS.n883 VSS.t599 66.8901
R6550 VSS.t2345 VSS.n871 66.8901
R6551 VSS.n870 VSS.t1137 66.8901
R6552 VSS.t734 VSS.n857 66.8901
R6553 VSS.n856 VSS.t1506 66.8901
R6554 VSS.n844 VSS.t1262 66.8901
R6555 VSS.n843 VSS.t1146 66.8901
R6556 VSS.t736 VSS.n829 66.8901
R6557 VSS.n826 VSS.t710 66.8901
R6558 VSS.t1376 VSS.n813 66.8901
R6559 VSS.n812 VSS.t2174 66.8901
R6560 VSS.t1296 VSS.n800 66.8901
R6561 VSS.n799 VSS.t179 66.8901
R6562 VSS.t2016 VSS.n786 66.8901
R6563 VSS.n785 VSS.t129 66.8901
R6564 VSS.t1861 VSS.n1125 66.8901
R6565 VSS.n1302 VSS.t68 66.8901
R6566 VSS.n1132 VSS.t1193 66.8901
R6567 VSS.n1298 VSS.t501 66.8901
R6568 VSS.n1139 VSS.t2287 66.8901
R6569 VSS.n1294 VSS.t1885 66.8901
R6570 VSS.t153 VSS.n1146 66.8901
R6571 VSS.n1290 VSS.t2020 66.8901
R6572 VSS.n1153 VSS.t929 66.8901
R6573 VSS.n1286 VSS.t1779 66.8901
R6574 VSS.n1160 VSS.t142 66.8901
R6575 VSS.n1282 VSS.t1778 66.8901
R6576 VSS.t777 VSS.n1167 66.8901
R6577 VSS.n1277 VSS.t964 66.8901
R6578 VSS.t533 VSS.n1174 66.8901
R6579 VSS.n1273 VSS.t1167 66.8901
R6580 VSS.n1181 VSS.t481 66.8901
R6581 VSS.n1269 VSS.t1953 66.8901
R6582 VSS.t2312 VSS.n1188 66.8901
R6583 VSS.n1265 VSS.t1888 66.8901
R6584 VSS.t1088 VSS.n1195 66.8901
R6585 VSS.n1261 VSS.t1887 66.8901
R6586 VSS.t2356 VSS.n1202 66.8901
R6587 VSS.n1257 VSS.t1771 66.8901
R6588 VSS.t938 VSS.n1210 66.8901
R6589 VSS.n1253 VSS.t1835 66.8901
R6590 VSS.n1218 VSS.t990 66.8901
R6591 VSS.n1249 VSS.t1799 66.8901
R6592 VSS.t2183 VSS.n1225 66.8901
R6593 VSS.n1245 VSS.t1792 66.8901
R6594 VSS.t2315 VSS.n1232 66.8901
R6595 VSS.n1241 VSS.t2072 66.8901
R6596 VSS.t1850 VSS.n2808 66.8901
R6597 VSS.n2990 VSS.t931 66.8901
R6598 VSS.t1624 VSS.n2815 66.8901
R6599 VSS.n2986 VSS.t553 66.8901
R6600 VSS.t1290 VSS.n2822 66.8901
R6601 VSS.n2982 VSS.t1139 66.8901
R6602 VSS.t2119 VSS.n2829 66.8901
R6603 VSS.n2978 VSS.t133 66.8901
R6604 VSS.t1502 VSS.n2836 66.8901
R6605 VSS.n2974 VSS.t1785 66.8901
R6606 VSS.t1840 VSS.n2843 66.8901
R6607 VSS.n2970 VSS.t1626 66.8901
R6608 VSS.t96 VSS.n2850 66.8901
R6609 VSS.n2965 VSS.t1904 66.8901
R6610 VSS.t997 VSS.n2857 66.8901
R6611 VSS.n2961 VSS.t1818 66.8901
R6612 VSS.n2864 VSS.t138 66.8901
R6613 VSS.n2957 VSS.t2222 66.8901
R6614 VSS.t706 VSS.n2871 66.8901
R6615 VSS.n2953 VSS.t2232 66.8901
R6616 VSS.t1101 VSS.n2878 66.8901
R6617 VSS.n2949 VSS.t547 66.8901
R6618 VSS.n2885 VSS.t1009 66.8901
R6619 VSS.n2945 VSS.t1196 66.8901
R6620 VSS.t2180 VSS.n2893 66.8901
R6621 VSS.n2941 VSS.t1238 66.8901
R6622 VSS.t108 VSS.n2901 66.8901
R6623 VSS.n2937 VSS.t2286 66.8901
R6624 VSS.n2908 VSS.t1309 66.8901
R6625 VSS.n2933 VSS.t953 66.8901
R6626 VSS.t1294 VSS.n2915 66.8901
R6627 VSS.n2929 VSS.t44 66.8901
R6628 VSS.t2141 VSS.n165 66.8901
R6629 VSS.t1177 VSS.n163 66.8901
R6630 VSS.t2129 VSS.n170 66.8901
R6631 VSS.t975 VSS.n160 66.8901
R6632 VSS.t1956 VSS.n175 66.8901
R6633 VSS.t2064 VSS.n156 66.8901
R6634 VSS.t1340 VSS.n180 66.8901
R6635 VSS.t2061 VSS.n152 66.8901
R6636 VSS.t1285 VSS.n185 66.8901
R6637 VSS.t2076 VSS.n148 66.8901
R6638 VSS.t1469 VSS.n190 66.8901
R6639 VSS.t2066 VSS.n144 66.8901
R6640 VSS.t1988 VSS.n195 66.8901
R6641 VSS.t2071 VSS.n140 66.8901
R6642 VSS.t967 VSS.n200 66.8901
R6643 VSS.t2070 VSS.n136 66.8901
R6644 VSS.t2337 VSS.n205 66.8901
R6645 VSS.t2068 VSS.n132 66.8901
R6646 VSS.t833 VSS.n210 66.8901
R6647 VSS.t2065 VSS.n128 66.8901
R6648 VSS.t1996 VSS.n215 66.8901
R6649 VSS.t2077 VSS.n124 66.8901
R6650 VSS.t579 VSS.n220 66.8901
R6651 VSS.t2106 VSS.n120 66.8901
R6652 VSS.t2342 VSS.n225 66.8901
R6653 VSS.t2097 VSS.n116 66.8901
R6654 VSS.t582 VSS.n230 66.8901
R6655 VSS.t2096 VSS.n112 66.8901
R6656 VSS.t1361 VSS.n235 66.8901
R6657 VSS.t2079 VSS.n108 66.8901
R6658 VSS.t1367 VSS.n1894 66.8901
R6659 VSS.t2078 VSS.n104 66.8901
R6660 VSS.n1432 VSS.t1316 66.8901
R6661 VSS.t2021 VSS.n1433 66.8901
R6662 VSS.n1448 VSS.t1833 66.8901
R6663 VSS.t1894 VSS.n1449 66.8901
R6664 VSS.n1464 VSS.t1446 66.8901
R6665 VSS.t1780 VSS.n1465 66.8901
R6666 VSS.n1480 VSS.t609 66.8901
R6667 VSS.t2062 VSS.n1481 66.8901
R6668 VSS.n1496 VSS.t1152 66.8901
R6669 VSS.t1955 VSS.n1497 66.8901
R6670 VSS.n1512 VSS.t1451 66.8901
R6671 VSS.t2025 VSS.n1513 66.8901
R6672 VSS.n1529 VSS.t1408 66.8901
R6673 VSS.t2086 VSS.n1530 66.8901
R6674 VSS.n1545 VSS.t1414 66.8901
R6675 VSS.t2067 VSS.n1546 66.8901
R6676 VSS.n1561 VSS.t1411 66.8901
R6677 VSS.t2060 VSS.n1562 66.8901
R6678 VSS.n1577 VSS.t1156 66.8901
R6679 VSS.t2074 VSS.n1578 66.8901
R6680 VSS.n1593 VSS.t1773 66.8901
R6681 VSS.t2063 VSS.n1594 66.8901
R6682 VSS.n1609 VSS.t2158 66.8901
R6683 VSS.t1969 VSS.n1610 66.8901
R6684 VSS.n1695 VSS.t656 66.8901
R6685 VSS.t2013 VSS.n1625 66.8901
R6686 VSS.n1642 VSS.t2240 66.8901
R6687 VSS.t2007 VSS.n1643 66.8901
R6688 VSS.n1658 VSS.t2332 66.8901
R6689 VSS.t2003 VSS.n1659 66.8901
R6690 VSS.n1674 VSS.t1216 66.8901
R6691 VSS.t1998 VSS.n1675 66.8901
R6692 VSS.t314 VSS.t331 57.5441
R6693 VSS.t321 VSS.t331 57.5432
R6694 VSS.t190 VSS.t122 57.5432
R6695 VSS.t217 VSS.t122 57.5432
R6696 VSS.t354 VSS.t2 57.5432
R6697 VSS.t361 VSS.t2 57.5432
R6698 VSS.t381 VSS.t2 57.5432
R6699 VSS.t2091 VSS.n96 64.9292
R6700 VSS.t183 VSS.n91 64.9292
R6701 VSS.t1244 VSS.n578 64.9292
R6702 VSS.n261 VSS.n2195 64.0227
R6703 VSS.n262 VSS.n2217 63.9058
R6704 VSS.n1388 VSS.t1096 63.7107
R6705 VSS.t1807 VSS.n1738 63.4728
R6706 VSS.n2553 VSS.n2179 62.9376
R6707 VSS.n2556 VSS.n2178 62.9376
R6708 VSS.n2588 VSS.n2210 62.7912
R6709 VSS.n2588 VSS.t251 62.7912
R6710 VSS.n1387 VSS.t13 62.4441
R6711 VSS.t1278 VSS.n1741 62.2523
R6712 VSS.n1062 VSS.t95 61.9779
R6713 VSS.n1325 VSS.t546 61.9779
R6714 VSS.n1764 VSS.t2018 61.9779
R6715 VSS.n1049 VSS.t725 61.8407
R6716 VSS.n2747 VSS.n469 59.3547
R6717 VSS.n2565 VSS.t1184 59.3028
R6718 VSS.t242 VSS.t541 59.3028
R6719 VSS.t622 VSS.n2203 59.3028
R6720 VSS.t1521 VSS.n95 59.0266
R6721 VSS.t498 VSS.n90 59.0266
R6722 VSS.t1937 VSS.n580 59.0266
R6723 VSS.t1124 VSS.n1385 58.6964
R6724 VSS.n1743 VSS.t1280 58.5186
R6725 VSS.t2292 VSS.n540 58.1358
R6726 VSS.n2605 VSS.t1298 58.1084
R6727 VSS.t36 VSS.n2 57.6388
R6728 VSS.t2316 VSS.n31 51.6619
R6729 VSS.t23 VSS.n0 57.6388
R6730 VSS.n1 VSS.t2112 154.915
R6731 VSS.t1134 VSS.n3 57.6388
R6732 VSS.t2128 VSS.n27 51.6619
R6733 VSS.n1013 VSS.t2089 57.5509
R6734 VSS.n1340 VSS.t182 57.5509
R6735 VSS.n1415 VSS.t1243 57.5509
R6736 VSS.t403 VSS.n1036 56.0825
R6737 VSS.t415 VSS.n1033 56.0825
R6738 VSS.t428 VSS.n1029 56.0825
R6739 VSS.t438 VSS.n1028 56.0825
R6740 VSS.n83 VSS.t463 56.0825
R6741 VSS.n2650 VSS.t2289 55.942
R6742 VSS.t1313 VSS.t1510 55.8145
R6743 VSS.t992 VSS.t926 55.8145
R6744 VSS.n359 VSS.t1399 54.6841
R6745 VSS.t2089 VSS.n678 54.5996
R6746 VSS.t182 VSS.n1318 54.5996
R6747 VSS.t1243 VSS.n1395 54.5996
R6748 VSS.t2175 VSS.n1730 54.532
R6749 VSS.n2692 VSS.t1562 53.7482
R6750 VSS.n2800 VSS.t712 53.4875
R6751 VSS.n99 VSS.t1521 53.124
R6752 VSS.n94 VSS.t498 53.124
R6753 VSS.n579 VSS.t1937 53.124
R6754 VSS.n2604 VSS.t559 52.3478
R6755 VSS.t1623 VSS.n2215 52.3261
R6756 VSS.t714 VSS.n2682 51.4837
R6757 VSS.n2772 VSS.n280 51.0224
R6758 VSS.n2785 VSS.n2784 51.0224
R6759 VSS.n2549 VSS.n2548 50.7482
R6760 VSS.n2547 VSS.n2233 50.7482
R6761 VSS.n2546 VSS.n2545 50.7482
R6762 VSS.n2544 VSS.n2234 50.7482
R6763 VSS.n2543 VSS.n2542 50.7482
R6764 VSS.n2541 VSS.n2235 50.7482
R6765 VSS.n2540 VSS.n2539 50.7482
R6766 VSS.n2537 VSS.n2536 50.7482
R6767 VSS.n2530 VSS.n2238 50.7482
R6768 VSS.n2529 VSS.n2528 50.7482
R6769 VSS.n2527 VSS.n2239 50.7482
R6770 VSS.n2526 VSS.n2525 50.7482
R6771 VSS.n2524 VSS.n2240 50.7482
R6772 VSS.n2523 VSS.n2522 50.7482
R6773 VSS.n2521 VSS.n2241 50.7482
R6774 VSS.n2520 VSS.n2519 50.7482
R6775 VSS.n2518 VSS.n2242 50.7482
R6776 VSS.n2515 VSS.n2243 50.7482
R6777 VSS.n2514 VSS.n2513 50.7482
R6778 VSS.n2511 VSS.n2510 50.7482
R6779 VSS.n2509 VSS.n2245 50.7482
R6780 VSS.n2253 VSS.n2252 50.7482
R6781 VSS.n2251 VSS.n2246 50.7482
R6782 VSS.n2250 VSS.n2249 50.7482
R6783 VSS.n2508 VSS.n2507 50.7482
R6784 VSS.n2505 VSS.n2504 50.7482
R6785 VSS.n2503 VSS.n2255 50.7482
R6786 VSS.n2502 VSS.n2501 50.7482
R6787 VSS.n2493 VSS.n2492 50.7482
R6788 VSS.n2495 VSS.n2494 50.7482
R6789 VSS.n2497 VSS.n2496 50.7482
R6790 VSS.n2499 VSS.n2498 50.7482
R6791 VSS.n2490 VSS.n2489 50.7482
R6792 VSS.n2488 VSS.n2258 50.7482
R6793 VSS.n2487 VSS.n2486 50.7482
R6794 VSS.n2484 VSS.n2483 50.7482
R6795 VSS.n2482 VSS.n2260 50.7482
R6796 VSS.n2481 VSS.n2480 50.7482
R6797 VSS.n2262 VSS.n2261 50.7482
R6798 VSS.n2477 VSS.t275 50.7482
R6799 VSS.n2476 VSS.n2263 50.7482
R6800 VSS.n2475 VSS.n2474 50.7482
R6801 VSS.n2472 VSS.n2471 50.7482
R6802 VSS.n2470 VSS.n2265 50.7482
R6803 VSS.n2469 VSS.n2468 50.7482
R6804 VSS.n2467 VSS.n2266 50.7482
R6805 VSS.n2466 VSS.n2465 50.7482
R6806 VSS.n2464 VSS.n2267 50.7482
R6807 VSS.n2461 VSS.n2268 50.7482
R6808 VSS.n2460 VSS.n2459 50.7482
R6809 VSS.n2457 VSS.n2456 50.7482
R6810 VSS.n2455 VSS.n2270 50.7482
R6811 VSS.n2278 VSS.n2277 50.7482
R6812 VSS.n2276 VSS.n2271 50.7482
R6813 VSS.n2273 VSS.n2272 50.7482
R6814 VSS.n2454 VSS.n2453 50.7482
R6815 VSS.n2451 VSS.n2450 50.7482
R6816 VSS.n2449 VSS.n2280 50.7482
R6817 VSS.n2448 VSS.n2447 50.7482
R6818 VSS.n2439 VSS.n2438 50.7482
R6819 VSS.n2441 VSS.n2440 50.7482
R6820 VSS.n2443 VSS.n2442 50.7482
R6821 VSS.n2445 VSS.n2444 50.7482
R6822 VSS.n2436 VSS.n2435 50.7482
R6823 VSS.n2434 VSS.n2283 50.7482
R6824 VSS.n2433 VSS.n2432 50.7482
R6825 VSS.n2430 VSS.n2429 50.7482
R6826 VSS.n2428 VSS.n2285 50.7482
R6827 VSS.n2425 VSS.n2424 50.7482
R6828 VSS.n2287 VSS.n2286 50.7482
R6829 VSS.n2423 VSS.t287 50.7482
R6830 VSS.n2422 VSS.n2288 50.7482
R6831 VSS.n2421 VSS.n2420 50.7482
R6832 VSS.n2418 VSS.n2417 50.7482
R6833 VSS.n2416 VSS.n2415 50.7482
R6834 VSS.n2414 VSS.n2413 50.7482
R6835 VSS.n2412 VSS.n2411 50.7482
R6836 VSS.n2410 VSS.n2409 50.7482
R6837 VSS.n2408 VSS.n2407 50.7482
R6838 VSS.n2404 VSS.n2403 50.7482
R6839 VSS.n2402 VSS.n2401 50.7482
R6840 VSS.n2398 VSS.n2397 50.7482
R6841 VSS.n2396 VSS.n2395 50.7482
R6842 VSS.n2394 VSS.n2297 50.7482
R6843 VSS.n2294 VSS.n2293 50.7482
R6844 VSS.n2292 VSS.n2291 50.7482
R6845 VSS.n2302 VSS.n2301 50.7482
R6846 VSS.n2306 VSS.n2305 50.7482
R6847 VSS.n2308 VSS.n2307 50.7482
R6848 VSS.n2310 VSS.n2309 50.7482
R6849 VSS.n2314 VSS.n2313 50.7482
R6850 VSS.n2300 VSS.n2299 50.7482
R6851 VSS.n2393 VSS.n2392 50.7482
R6852 VSS.n2391 VSS.n2390 50.7482
R6853 VSS.n2322 VSS.n2321 50.7482
R6854 VSS.n2320 VSS.n2318 50.7482
R6855 VSS.n2325 VSS.n2324 50.7482
R6856 VSS.n2328 VSS.n2327 50.7482
R6857 VSS.n2389 VSS.n2388 50.7482
R6858 VSS.n2387 VSS.n2386 50.7482
R6859 VSS.n2385 VSS.n2384 50.7482
R6860 VSS.t300 VSS.n2383 50.7482
R6861 VSS.n2382 VSS.n2381 50.7482
R6862 VSS.n2380 VSS.n2379 50.7482
R6863 VSS.n2376 VSS.n2375 50.7482
R6864 VSS.n2374 VSS.n2373 50.7482
R6865 VSS.n2372 VSS.n2371 50.7482
R6866 VSS.n2370 VSS.n2369 50.7482
R6867 VSS.n2368 VSS.n2367 50.7482
R6868 VSS.n2366 VSS.n2365 50.7482
R6869 VSS.n2362 VSS.n2361 50.7482
R6870 VSS.n2360 VSS.n2359 50.7482
R6871 VSS.n2356 VSS.n2355 50.7482
R6872 VSS.n2352 VSS.n2351 50.7482
R6873 VSS.n2350 VSS.n2349 50.7482
R6874 VSS.n2348 VSS.n2347 50.7482
R6875 VSS.n2346 VSS.n2345 50.7482
R6876 VSS.n2344 VSS.n2343 50.7482
R6877 VSS.n2342 VSS.n2341 50.7482
R6878 VSS.n2340 VSS.n2339 50.7482
R6879 VSS.n2338 VSS.n2337 50.7482
R6880 VSS.n2336 VSS.n2335 50.7482
R6881 VSS.n2334 VSS.n2333 50.7482
R6882 VSS.n2332 VSS.n2331 50.7482
R6883 VSS.t1638 VSS.n1041 50.3244
R6884 VSS.t1819 VSS.n68 131.005
R6885 VSS.t95 VSS.n98 50.1727
R6886 VSS.t546 VSS.n93 50.1727
R6887 VSS.t2018 VSS.n577 50.1727
R6888 VSS.n994 VSS.t665 50.1677
R6889 VSS.n982 VSS.t1724 50.1677
R6890 VSS.n969 VSS.t1880 50.1677
R6891 VSS.n956 VSS.t633 50.1677
R6892 VSS.n943 VSS.t674 50.1677
R6893 VSS.n930 VSS.t636 50.1677
R6894 VSS.n915 VSS.t660 50.1677
R6895 VSS.n903 VSS.t642 50.1677
R6896 VSS.n888 VSS.t668 50.1677
R6897 VSS.n874 VSS.t630 50.1677
R6898 VSS.n861 VSS.t671 50.1677
R6899 VSS.n847 VSS.t639 50.1677
R6900 VSS.n834 VSS.t663 50.1677
R6901 VSS.n817 VSS.t645 50.1677
R6902 VSS.n803 VSS.t1878 50.1677
R6903 VSS.n790 VSS.t1722 50.1677
R6904 VSS.n1303 VSS.t1457 50.1677
R6905 VSS.n1299 VSS.t1765 50.1677
R6906 VSS.n1295 VSS.t1947 50.1677
R6907 VSS.n1291 VSS.t1644 50.1677
R6908 VSS.n1287 VSS.t1463 50.1677
R6909 VSS.n1283 VSS.t1654 50.1677
R6910 VSS.n1278 VSS.t2026 50.1677
R6911 VSS.n1274 VSS.t1658 50.1677
R6912 VSS.n1270 VSS.t2029 50.1677
R6913 VSS.n1266 VSS.t1642 50.1677
R6914 VSS.n1262 VSS.t1461 50.1677
R6915 VSS.n1258 VSS.t1656 50.1677
R6916 VSS.n1254 VSS.t1459 50.1677
R6917 VSS.n1250 VSS.t1660 50.1677
R6918 VSS.n1246 VSS.t1951 50.1677
R6919 VSS.n1242 VSS.t1763 50.1677
R6920 VSS.n2991 VSS.t1060 50.1677
R6921 VSS.n2987 VSS.t1392 50.1677
R6922 VSS.n2983 VSS.t1077 50.1677
R6923 VSS.n2979 VSS.t1908 50.1677
R6924 VSS.n2975 VSS.t1062 50.1677
R6925 VSS.n2971 VSS.t1910 50.1677
R6926 VSS.n2966 VSS.t1055 50.1677
R6927 VSS.n2962 VSS.t1914 50.1677
R6928 VSS.n2958 VSS.t1050 50.1677
R6929 VSS.n2954 VSS.t1906 50.1677
R6930 VSS.n2950 VSS.t1064 50.1677
R6931 VSS.n2946 VSS.t1912 50.1677
R6932 VSS.n2942 VSS.t1058 50.1677
R6933 VSS.n2938 VSS.t1916 50.1677
R6934 VSS.n2934 VSS.t1074 50.1677
R6935 VSS.n2930 VSS.t1390 50.1677
R6936 VSS.t1333 VSS.n1987 50.1677
R6937 VSS.t2039 VSS.n161 50.1677
R6938 VSS.t1743 VSS.n157 50.1677
R6939 VSS.t2050 VSS.n153 50.1677
R6940 VSS.t1711 VSS.n149 50.1677
R6941 VSS.t2053 VSS.n145 50.1677
R6942 VSS.t1757 VSS.n141 50.1677
R6943 VSS.t1714 VSS.n137 50.1677
R6944 VSS.t1336 VSS.n133 50.1677
R6945 VSS.t2047 VSS.n129 50.1677
R6946 VSS.t1708 VSS.n125 50.1677
R6947 VSS.t2056 VSS.n121 50.1677
R6948 VSS.t1760 VSS.n117 50.1677
R6949 VSS.t1717 VSS.n113 50.1677
R6950 VSS.t1740 VSS.n109 50.1677
R6951 VSS.t2036 VSS.n105 50.1677
R6952 VSS.t2374 VSS.n1426 50.1677
R6953 VSS.t83 VSS.n1442 50.1677
R6954 VSS.t859 VSS.n1458 50.1677
R6955 VSS.t2214 VSS.n1474 50.1677
R6956 VSS.t855 VSS.n1490 50.1677
R6957 VSS.t2191 VSS.n1506 50.1677
R6958 VSS.t880 VSS.n1521 50.1677
R6959 VSS.t2208 VSS.n1539 50.1677
R6960 VSS.t1045 VSS.n1555 50.1677
R6961 VSS.t2212 VSS.n1571 50.1677
R6962 VSS.t1019 VSS.n1587 50.1677
R6963 VSS.t2193 VSS.n1603 50.1677
R6964 VSS.t1048 VSS.n1619 50.1677
R6965 VSS.t2210 VSS.n1636 50.1677
R6966 VSS.t520 VSS.n1652 50.1677
R6967 VSS.t80 VSS.n1668 50.1677
R6968 VSS.n2676 VSS.t770 50.0128
R6969 VSS.t941 VSS.n2231 50.0128
R6970 VSS.n2354 VSS.t1680 50.0128
R6971 VSS.n264 VSS.n2193 49.9524
R6972 VSS.n264 VSS.n2215 49.9524
R6973 VSS.n2634 VSS.t1565 49.3606
R6974 VSS.n2556 VSS.t1306 48.9515
R6975 VSS.t1005 VSS.n2194 48.8377
R6976 VSS.n2580 VSS.t1122 48.8377
R6977 VSS.t1269 VSS.n2218 48.8377
R6978 VSS.n2566 VSS.n2181 48.8377
R6979 VSS.n2589 VSS.n2204 48.8377
R6980 VSS.t1199 VSS.n2672 48.5418
R6981 VSS.t1676 VSS.n2295 47.8063
R6982 VSS.t1804 VSS.n1389 47.4535
R6983 VSS.n1737 VSS.t1893 47.3176
R6984 VSS.n1007 VSS.t2091 47.2214
R6985 VSS.n1336 VSS.t183 47.2214
R6986 VSS.n1411 VSS.t1244 47.2214
R6987 VSS.n2660 VSS.t1205 47.1669
R6988 VSS.t1207 VSS.n543 47.1669
R6989 VSS.n2538 VSS.t1114 46.3354
R6990 VSS.n2133 VSS.t1186 46.116
R6991 VSS.n2671 VSS.t1136 45.5999
R6992 VSS.t171 VSS.n2681 45.3982
R6993 VSS.t1121 VSS.n2216 45.3493
R6994 VSS.t253 VSS.n2188 45.3493
R6995 VSS.n2595 VSS.t919 45.3493
R6996 VSS.t2294 VSS.n2628 44.9731
R6997 VSS.n2491 VSS.t271 44.129
R6998 VSS.n2479 VSS.t1670 44.129
R6999 VSS.n2437 VSS.t283 44.129
R7000 VSS.t296 VSS.n2315 44.129
R7001 VSS.n2677 VSS.t772 43.9263
R7002 VSS.t1135 VSS.n2674 42.658
R7003 VSS.t2225 VSS.n2124 42.3769
R7004 VSS.n2799 VSS.t168 42.222
R7005 VSS.t1511 VSS.n2229 41.9585
R7006 VSS.t1004 VSS.n2196 41.9585
R7007 VSS.n2801 VSS.t1236 41.9225
R7008 VSS.n2577 VSS.t1005 41.861
R7009 VSS.n2684 VSS.t1191 41.1871
R7010 VSS.t819 VSS.n2237 41.1871
R7011 VSS.n1393 VSS.t1803 39.9582
R7012 VSS.t1892 VSS.n1732 39.8503
R7013 VSS.t269 VSS.n2256 38.9806
R7014 VSS.n2275 VSS.t1672 38.9806
R7015 VSS.t281 VSS.n2281 38.9806
R7016 VSS.n2312 VSS.t294 38.9806
R7017 VSS.n2642 VSS.t2294 38.3917
R7018 VSS.t934 VSS.n685 38.3674
R7019 VSS.n1327 VSS.t66 38.3674
R7020 VSS.t1397 VSS.n1403 38.3674
R7021 VSS.t993 VSS.n2679 38.2452
R7022 VSS.t168 VSS.n2798 37.7839
R7023 VSS.t170 VSS.n2673 37.0756
R7024 VSS.t1783 VSS.n996 36.7898
R7025 VSS.n984 VSS.t2104 36.7898
R7026 VSS.n971 VSS.t2145 36.7898
R7027 VSS.t1536 VSS.n957 36.7898
R7028 VSS.n945 VSS.t503 36.7898
R7029 VSS.n932 VSS.t1982 36.7898
R7030 VSS.t1172 VSS.n917 36.7898
R7031 VSS.n905 VSS.t2001 36.7898
R7032 VSS.t1480 VSS.n890 36.7898
R7033 VSS.t970 VSS.n876 36.7898
R7034 VSS.t1359 VSS.n863 36.7898
R7035 VSS.n849 VSS.t1858 36.7898
R7036 VSS.n836 VSS.t514 36.7898
R7037 VSS.t2253 VSS.n819 36.7898
R7038 VSS.t2010 VSS.n805 36.7898
R7039 VSS.t1433 VSS.n792 36.7898
R7040 VSS.n1120 VSS.t1258 36.7898
R7041 VSS.n1128 VSS.t1116 36.7898
R7042 VSS.n1135 VSS.t484 36.7898
R7043 VSS.n1142 VSS.t1017 36.7898
R7044 VSS.n1149 VSS.t539 36.7898
R7045 VSS.n1156 VSS.t1105 36.7898
R7046 VSS.n1163 VSS.t1027 36.7898
R7047 VSS.n1170 VSS.t1181 36.7898
R7048 VSS.n1177 VSS.t164 36.7898
R7049 VSS.n1184 VSS.t924 36.7898
R7050 VSS.t166 VSS.n1191 36.7898
R7051 VSS.t1442 VSS.n1198 36.7898
R7052 VSS.t1090 VSS.n1205 36.7898
R7053 VSS.n1214 VSS.t1202 36.7898
R7054 VSS.n1221 VSS.t619 36.7898
R7055 VSS.t1251 VSS.n1228 36.7898
R7056 VSS.n2803 VSS.t708 36.7898
R7057 VSS.t981 VSS.n2811 36.7898
R7058 VSS.t984 VSS.n2818 36.7898
R7059 VSS.n2825 VSS.t2228 36.7898
R7060 VSS.t1002 VSS.n2832 36.7898
R7061 VSS.t1108 VSS.n2839 36.7898
R7062 VSS.n2846 VSS.t2357 36.7898
R7063 VSS.t157 VSS.n2853 36.7898
R7064 VSS.t2236 VSS.n2860 36.7898
R7065 VSS.n2867 VSS.t549 36.7898
R7066 VSS.t91 VSS.n2874 36.7898
R7067 VSS.t1513 VSS.n2881 36.7898
R7068 VSS.t797 VSS.n2888 36.7898
R7069 VSS.t2380 VSS.n2897 36.7898
R7070 VSS.t1438 VSS.n2904 36.7898
R7071 VSS.t1798 VSS.n2911 36.7898
R7072 VSS.t2019 VSS.n1752 36.7898
R7073 VSS.t2138 VSS.n168 36.7898
R7074 VSS.t1963 VSS.n173 36.7898
R7075 VSS.t1925 VSS.n178 36.7898
R7076 VSS.t1973 VSS.n183 36.7898
R7077 VSS.t1275 VSS.n188 36.7898
R7078 VSS.t697 VSS.n193 36.7898
R7079 VSS.t2363 VSS.n198 36.7898
R7080 VSS.t1168 VSS.n203 36.7898
R7081 VSS.t787 VSS.n208 36.7898
R7082 VSS.t791 VSS.n213 36.7898
R7083 VSS.t2340 VSS.n218 36.7898
R7084 VSS.t1227 VSS.n223 36.7898
R7085 VSS.t1355 VSS.n228 36.7898
R7086 VSS.t2347 VSS.n233 36.7898
R7087 VSS.t1366 VSS.n238 36.7898
R7088 VSS.n1424 VSS.t1282 36.7898
R7089 VSS.n1441 VSS.t1641 36.7898
R7090 VSS.n1457 VSS.t1824 36.7898
R7091 VSS.n1473 VSS.t1828 36.7898
R7092 VSS.n1489 VSS.t489 36.7898
R7093 VSS.n1505 VSS.t1456 36.7898
R7094 VSS.n1710 VSS.t2198 36.7898
R7095 VSS.n1538 VSS.t1212 36.7898
R7096 VSS.n1554 VSS.t1330 36.7898
R7097 VSS.n1570 VSS.t1647 36.7898
R7098 VSS.n1586 VSS.t2326 36.7898
R7099 VSS.n1602 VSS.t2352 36.7898
R7100 VSS.n1618 VSS.t2160 36.7898
R7101 VSS.n1635 VSS.t2243 36.7898
R7102 VSS.n1651 VSS.t1256 36.7898
R7103 VSS.n1667 VSS.t746 36.7898
R7104 VSS.n2679 VSS.t1237 36.7742
R7105 VSS.n61 VSS.t1796 20.4771
R7106 VSS.t12 VSS.n1393 36.2105
R7107 VSS.t1205 VSS.n539 36.1979
R7108 VSS.n2621 VSS.t1207 36.1979
R7109 VSS.n1732 VSS.t1277 36.1166
R7110 VSS.n261 VSS.n2213 36.0019
R7111 VSS.n262 VSS.n2191 35.9989
R7112 VSS.n270 VSS.n2185 35.9989
R7113 VSS.n61 VSS.t1192 35.7165
R7114 VSS.t2082 VSS.n686 35.4161
R7115 VSS.n1328 VSS.t977 35.4161
R7116 VSS.t75 VSS.n1404 35.4161
R7117 VSS.n2517 VSS.t758 35.3033
R7118 VSS.n2473 VSS.t277 35.3033
R7119 VSS.n2463 VSS.t878 35.3033
R7120 VSS.t1674 VSS.n2426 35.3033
R7121 VSS.n2419 VSS.t290 35.3033
R7122 VSS.t2274 VSS.n2405 35.3033
R7123 VSS.n2378 VSS.t301 35.3033
R7124 VSS.t1875 VSS.n2363 35.3033
R7125 VSS.n2587 VSS.t1004 34.9655
R7126 VSS.t30 VSS.n2222 34.8842
R7127 VSS.n2563 VSS.n2224 34.8842
R7128 VSS.n2569 VSS.n2183 34.8842
R7129 VSS.n2199 VSS.n2176 34.8842
R7130 VSS.n2200 VSS.n2175 34.8842
R7131 VSS.t1631 VSS.n357 34.07
R7132 VSS.t1565 VSS.n542 34.0042
R7133 VSS.n1735 VSS.t1874 33.9948
R7134 VSS.t2284 VSS.n467 33.9067
R7135 VSS.t1192 VSS.n2684 33.8323
R7136 VSS.n2674 VSS.t170 32.3614
R7137 VSS.n2506 VSS.t266 32.3614
R7138 VSS.n2452 VSS.t278 32.3614
R7139 VSS.t291 VSS.n2303 32.3614
R7140 VSS.n2561 VSS.t258 31.3958
R7141 VSS.t1184 VSS.n2182 31.3958
R7142 VSS.t1510 VSS.n2226 31.3958
R7143 VSS.t247 VSS.n2589 31.3958
R7144 VSS.t920 VSS.n2205 31.3958
R7145 VSS.t926 VSS.n2206 31.3958
R7146 VSS.t2351 VSS.n2125 31.1596
R7147 VSS.t1131 VSS.n679 30.9892
R7148 VSS.n1319 VSS.t33 30.9892
R7149 VSS.t20 VSS.n1396 30.9892
R7150 VSS.t759 VSS.n2244 30.8904
R7151 VSS.t879 VSS.n2269 30.8904
R7152 VSS.t2275 VSS.n2399 30.8904
R7153 VSS.t1876 VSS.n2357 30.8904
R7154 VSS.t1668 VSS.n2247 30.1549
R7155 VSS.n1990 VSS.n1782 29.9901
R7156 VSS.n1997 VSS.n1789 29.9901
R7157 VSS.n2004 VSS.n1796 29.9901
R7158 VSS.n2011 VSS.n1803 29.9901
R7159 VSS.n2018 VSS.n1810 29.9901
R7160 VSS.n2025 VSS.n1817 29.9901
R7161 VSS.n2033 VSS.n1826 29.9901
R7162 VSS.n2040 VSS.n1833 29.9901
R7163 VSS.n2047 VSS.n1840 29.9901
R7164 VSS.n2054 VSS.n1847 29.9901
R7165 VSS.n2061 VSS.n1854 29.9901
R7166 VSS.n2068 VSS.n1861 29.9901
R7167 VSS.n2075 VSS.n1868 29.9901
R7168 VSS.n2082 VSS.n1877 29.9901
R7169 VSS.n2089 VSS.n1884 29.9901
R7170 VSS.n2096 VSS.n1891 29.9901
R7171 VSS.n1906 VSS.n1895 29.9901
R7172 VSS.t1237 VSS.n2678 29.6937
R7173 VSS.t1198 VSS.n2671 29.4195
R7174 VSS.n270 VSS.t30 29.0221
R7175 VSS.t712 VSS.n2799 28.9853
R7176 VSS.n1389 VSS.t1094 28.7152
R7177 VSS.t821 VSS.n2531 28.684
R7178 VSS.t1805 VSS.n1737 28.6493
R7179 VSS.n358 VSS.n2801 28.3058
R7180 VSS.t2127 VSS.n992 28.2943
R7181 VSS.t1961 VSS.n980 28.2943
R7182 VSS.t1533 VSS.n953 28.2943
R7183 VSS.t1931 VSS.n941 28.2943
R7184 VSS.t2246 VSS.n913 28.2943
R7185 VSS.n435 VSS.t1851 28.2943
R7186 VSS.t1291 VSS.n350 28.2943
R7187 VSS.n424 VSS.t2120 28.2943
R7188 VSS.t1839 VSS.n351 28.2943
R7189 VSS.n414 VSS.t98 28.2943
R7190 VSS.t137 VSS.n352 28.2943
R7191 VSS.n404 VSS.t704 28.2943
R7192 VSS.n396 VSS.t1011 28.2943
R7193 VSS.n392 VSS.t2181 28.2943
R7194 VSS.n384 VSS.t1310 28.2943
R7195 VSS.n380 VSS.t1295 28.2943
R7196 VSS.t1346 VSS.n901 28.2941
R7197 VSS.t733 VSS.n859 28.2941
R7198 VSS.t1263 VSS.n845 28.2941
R7199 VSS.t737 VSS.n831 28.2941
R7200 VSS.t2015 VSS.n788 28.2941
R7201 VSS.t1967 VSS.n708 28.2941
R7202 VSS.t836 VSS.n723 28.2941
R7203 VSS.t973 VSS.n886 28.2941
R7204 VSS.t2346 VSS.n743 28.2941
R7205 VSS.t1374 VSS.n815 28.2941
R7206 VSS.t1297 VSS.n766 28.2941
R7207 VSS.n430 VSS.t1625 28.2941
R7208 VSS.n364 VSS.t1501 28.2941
R7209 VSS.n368 VSS.t999 28.2941
R7210 VSS.n372 VSS.t1102 28.2941
R7211 VSS.n375 VSS.t106 28.2941
R7212 VSS.n672 VSS.t1862 28.2938
R7213 VSS.n667 VSS.t2288 28.2938
R7214 VSS.n664 VSS.t155 28.2938
R7215 VSS.n659 VSS.t140 28.2938
R7216 VSS.n656 VSS.t779 28.2938
R7217 VSS.n653 VSS.t535 28.2938
R7218 VSS.n649 VSS.t479 28.2938
R7219 VSS.t2311 VSS.n604 28.2938
R7220 VSS.n640 VSS.t936 28.2938
R7221 VSS.n636 VSS.t988 28.2938
R7222 VSS.t2182 VSS.n611 28.2938
R7223 VSS.n668 VSS.t1194 28.2938
R7224 VSS.n660 VSS.t928 28.2938
R7225 VSS.t1087 VSS.n606 28.2938
R7226 VSS.t2314 VSS.n613 28.2938
R7227 VSS.n623 VSS.t2355 28.2936
R7228 VSS.n1430 VSS.t1315 28.2928
R7229 VSS.n1446 VSS.t1832 28.2928
R7230 VSS.n1462 VSS.t1445 28.2928
R7231 VSS.n1478 VSS.t607 28.2928
R7232 VSS.n1494 VSS.t1151 28.2928
R7233 VSS.n1510 VSS.t1450 28.2928
R7234 VSS.n1527 VSS.t1407 28.2928
R7235 VSS.n1543 VSS.t1413 28.2928
R7236 VSS.n1559 VSS.t1410 28.2928
R7237 VSS.n1575 VSS.t1155 28.2928
R7238 VSS.n1591 VSS.t1775 28.2928
R7239 VSS.n1607 VSS.t2156 28.2928
R7240 VSS.n1623 VSS.t658 28.2928
R7241 VSS.n1640 VSS.t2241 28.2928
R7242 VSS.n1656 VSS.t2331 28.2928
R7243 VSS.n1672 VSS.t1214 28.2928
R7244 VSS.n2680 VSS.t993 28.2227
R7245 VSS.n614 VSS.t1508 28.0359
R7246 VSS.t2303 VSS.n573 28.0358
R7247 VSS.n1004 VSS.t2148 28.0352
R7248 VSS.t2177 VSS.n1418 28.035
R7249 VSS.n438 VSS.t1402 28.035
R7250 VSS.t541 VSS.n2173 27.9075
R7251 VSS.t2289 VSS.n2625 27.4228
R7252 VSS.n1044 VSS.t19 27.2918
R7253 VSS.t273 VSS.n2259 27.2131
R7254 VSS.t285 VSS.n2284 27.2131
R7255 VSS.t298 VSS.n2317 27.2131
R7256 VSS.n1006 VSS.t769 26.5622
R7257 VSS.n1335 VSS.t822 26.5622
R7258 VSS.n1410 VSS.t702 26.5622
R7259 VSS.n2672 VSS.t1198 26.4776
R7260 VSS.n2326 VSS.t1678 26.4776
R7261 VSS.n1059 VSS.n1012 26.0918
R7262 VSS.n3012 VSS.n1011 26.0918
R7263 VSS.n3009 VSS.n1008 26.0918
R7264 VSS.n1063 VSS.n683 26.0918
R7265 VSS.n1066 VSS.n688 26.0918
R7266 VSS.n1060 VSS.n1012 26.0918
R7267 VSS.n3010 VSS.n1008 26.0918
R7268 VSS.n1063 VSS.n684 26.0918
R7269 VSS.n1339 VSS.n1070 26.0918
R7270 VSS.n1320 VSS.n1315 26.0918
R7271 VSS.n1323 VSS.n1312 26.0918
R7272 VSS.n1339 VSS.n1069 26.0918
R7273 VSS.n1323 VSS.n1313 26.0918
R7274 VSS.n1332 VSS.n1308 26.0918
R7275 VSS.n1772 VSS.n1414 26.0918
R7276 VSS.n1767 VSS.n1400 26.0918
R7277 VSS.n1771 VSS.n1414 26.0918
R7278 VSS.n1769 VSS.n1397 26.0918
R7279 VSS.n1766 VSS.n1400 26.0918
R7280 VSS.n1763 VSS.n1409 26.0918
R7281 VSS.n1763 VSS.n1402 26.0918
R7282 VSS.n1758 VSS.n1407 26.0918
R7283 VSS.t1191 VSS.n2683 25.2808
R7284 VSS.n2647 VSS.t2292 25.229
R7285 VSS.t772 VSS.n2676 25.0066
R7286 VSS.t252 VSS.n2195 24.476
R7287 VSS.n469 VSS.t1190 24.4565
R7288 VSS.n2569 VSS.t1831 24.4191
R7289 VSS.n2551 VSS.t263 24.4191
R7290 VSS.t1678 VSS.n2316 24.2712
R7291 VSS.n2675 VSS.t1135 23.8099
R7292 VSS.n2682 VSS.t171 23.5357
R7293 VSS.n2485 VSS.t273 23.5357
R7294 VSS.n2431 VSS.t285 23.5357
R7295 VSS.n2323 VSS.t298 23.5357
R7296 VSS.t331 VSS.t173 22.3797
R7297 VSS.t331 VSS.t948 22.4514
R7298 VSS.n463 VSS.t528 22.3643
R7299 VSS.n50 VSS.n47 0.800623
R7300 VSS.n69 VSS.t1475 21.1025
R7301 VSS.n2532 VSS.t821 22.0647
R7302 VSS.n263 VSS.n2189 22.0454
R7303 VSS.n266 VSS.n2187 22.0454
R7304 VSS.n257 VSS.n2207 22.0454
R7305 VSS.n437 VSS.t1587 21.6054
R7306 VSS.t1612 VSS.n693 21.6051
R7307 VSS.t1553 VSS.n572 21.605
R7308 VSS.n674 VSS.t1599 21.6048
R7309 VSS.n1421 VSS.t1542 21.6039
R7310 VSS.n2746 VSS.t1197 21.1887
R7311 VSS.n2567 VSS.n2226 20.9307
R7312 VSS.n16 VSS.n28 22.1341
R7313 VSS.n2198 VSS.t598 20.9307
R7314 VSS.n2598 VSS.n2203 20.9307
R7315 VSS.n2673 VSS.t1199 20.8932
R7316 VSS.t1136 VSS.n2670 20.868
R7317 VSS.n1009 VSS.t767 20.6596
R7318 VSS.n1337 VSS.t823 20.6596
R7319 VSS.n1412 VSS.t700 20.6596
R7320 VSS.n60 VSS.t907 27.5093
R7321 VSS.n2248 VSS.t1668 20.5938
R7322 VSS.t2105 VSS.n985 20.0674
R7323 VSS.t2146 VSS.n973 20.0674
R7324 VSS.t1537 VSS.n959 20.0674
R7325 VSS.t505 VSS.n946 20.0674
R7326 VSS.t1983 VSS.n934 20.0674
R7327 VSS.t1171 VSS.n920 20.0674
R7328 VSS.t2000 VSS.n906 20.0674
R7329 VSS.t1479 VSS.n893 20.0674
R7330 VSS.t971 VSS.n878 20.0674
R7331 VSS.t1360 VSS.n865 20.0674
R7332 VSS.t1859 VSS.n851 20.0674
R7333 VSS.t516 VSS.n838 20.0674
R7334 VSS.t2254 VSS.n822 20.0674
R7335 VSS.t2011 VSS.n807 20.0674
R7336 VSS.t1435 VSS.n794 20.0674
R7337 VSS.t613 VSS.n780 20.0674
R7338 VSS.n1300 VSS.t1115 20.0674
R7339 VSS.n1296 VSS.t485 20.0674
R7340 VSS.n1292 VSS.t1015 20.0674
R7341 VSS.n1288 VSS.t537 20.0674
R7342 VSS.n1284 VSS.t1104 20.0674
R7343 VSS.n1280 VSS.t1025 20.0674
R7344 VSS.n1275 VSS.t1180 20.0674
R7345 VSS.n1271 VSS.t162 20.0674
R7346 VSS.n1267 VSS.t923 20.0674
R7347 VSS.n1263 VSS.t165 20.0674
R7348 VSS.n1259 VSS.t1443 20.0674
R7349 VSS.n1255 VSS.t1091 20.0674
R7350 VSS.n1251 VSS.t1201 20.0674
R7351 VSS.n1247 VSS.t617 20.0674
R7352 VSS.n1243 VSS.t1249 20.0674
R7353 VSS.n1239 VSS.t1403 20.0674
R7354 VSS.n2988 VSS.t979 20.0674
R7355 VSS.n2984 VSS.t983 20.0674
R7356 VSS.n2980 VSS.t2229 20.0674
R7357 VSS.n2976 VSS.t1001 20.0674
R7358 VSS.n2972 VSS.t1110 20.0674
R7359 VSS.n2968 VSS.t2358 20.0674
R7360 VSS.n2963 VSS.t159 20.0674
R7361 VSS.n2959 VSS.t2235 20.0674
R7362 VSS.n2955 VSS.t551 20.0674
R7363 VSS.n2951 VSS.t89 20.0674
R7364 VSS.n2947 VSS.t1514 20.0674
R7365 VSS.n2943 VSS.t799 20.0674
R7366 VSS.n2939 VSS.t2381 20.0674
R7367 VSS.n2935 VSS.t1439 20.0674
R7368 VSS.n2931 VSS.t1797 20.0674
R7369 VSS.n2927 VSS.t1444 20.0674
R7370 VSS.n1984 VSS.t2142 20.0674
R7371 VSS.n100 VSS.t2139 20.0674
R7372 VSS.n1979 VSS.t2130 20.0674
R7373 VSS.n158 VSS.t1962 20.0674
R7374 VSS.n1974 VSS.t1958 20.0674
R7375 VSS.n154 VSS.t1924 20.0674
R7376 VSS.n1969 VSS.t1339 20.0674
R7377 VSS.n150 VSS.t1972 20.0674
R7378 VSS.n1964 VSS.t1284 20.0674
R7379 VSS.n146 VSS.t1273 20.0674
R7380 VSS.n1959 VSS.t1467 20.0674
R7381 VSS.n142 VSS.t695 20.0674
R7382 VSS.n1953 VSS.t1987 20.0674
R7383 VSS.n138 VSS.t2362 20.0674
R7384 VSS.n1948 VSS.t966 20.0674
R7385 VSS.n134 VSS.t1170 20.0674
R7386 VSS.n1943 VSS.t2338 20.0674
R7387 VSS.n130 VSS.t789 20.0674
R7388 VSS.n1938 VSS.t831 20.0674
R7389 VSS.n126 VSS.t793 20.0674
R7390 VSS.n1933 VSS.t1995 20.0674
R7391 VSS.n122 VSS.t2339 20.0674
R7392 VSS.n1928 VSS.t577 20.0674
R7393 VSS.n118 VSS.t1225 20.0674
R7394 VSS.n1923 VSS.t2341 20.0674
R7395 VSS.n114 VSS.t1357 20.0674
R7396 VSS.n1918 VSS.t581 20.0674
R7397 VSS.n110 VSS.t2348 20.0674
R7398 VSS.n1913 VSS.t1363 20.0674
R7399 VSS.n106 VSS.t1364 20.0674
R7400 VSS.n1908 VSS.t1369 20.0674
R7401 VSS.n102 VSS.t852 20.0674
R7402 VSS.n1438 VSS.t1640 20.0674
R7403 VSS.n1454 VSS.t1825 20.0674
R7404 VSS.n1470 VSS.t1827 20.0674
R7405 VSS.n1486 VSS.t487 20.0674
R7406 VSS.n1502 VSS.t1454 20.0674
R7407 VSS.n1518 VSS.t2199 20.0674
R7408 VSS.n1535 VSS.t1211 20.0674
R7409 VSS.n1551 VSS.t1329 20.0674
R7410 VSS.n1567 VSS.t1646 20.0674
R7411 VSS.n1583 VSS.t2325 20.0674
R7412 VSS.n1599 VSS.t2353 20.0674
R7413 VSS.n1615 VSS.t2161 20.0674
R7414 VSS.n1632 VSS.t2242 20.0674
R7415 VSS.n1648 VSS.t1255 20.0674
R7416 VSS.n1664 VSS.t747 20.0674
R7417 VSS.n1679 VSS.t2335 20.0674
R7418 VSS.t559 VSS.t558 19.9423
R7419 VSS.n2512 VSS.t759 19.8583
R7420 VSS.n2458 VSS.t879 19.8583
R7421 VSS.n2400 VSS.t2275 19.8583
R7422 VSS.n2358 VSS.t1876 19.8583
R7423 VSS.n2670 VSS.t1236 19.397
R7424 VSS.n2667 VSS.n2666 18.3874
R7425 VSS.t266 VSS.n2254 18.3874
R7426 VSS.t278 VSS.n2279 18.3874
R7427 VSS.n2304 VSS.t291 18.3874
R7428 VSS.n2801 VSS.n2800 18.1856
R7429 VSS.t2109 VSS.n698 18.0025
R7430 VSS.t1928 VSS.n713 18.0025
R7431 VSS.t839 VSS.n730 18.0025
R7432 VSS.t1483 VSS.n749 18.0025
R7433 VSS.t1649 VSS.n752 18.0025
R7434 VSS.t25 VSS.n615 18.0025
R7435 VSS.t1107 VSS.n617 18.0025
R7436 VSS.t1103 VSS.n619 18.0025
R7437 VSS.t843 VSS.n621 18.0025
R7438 VSS.t621 VSS.n622 18.0025
R7439 VSS.t1208 VSS.n626 18.0025
R7440 VSS.t1841 VSS.n627 18.0025
R7441 VSS.t1795 VSS.n571 18.0023
R7442 VSS.n1520 VSS.t2239 18.0023
R7443 VSS.n1624 VSS.t2220 18.0023
R7444 VSS.n997 VSS.t174 18.0017
R7445 VSS.n701 VSS.t1271 18.0017
R7446 VSS.t1954 VSS.n704 18.0017
R7447 VSS.t2132 VSS.n706 18.0017
R7448 VSS.n966 VSS.t1342 18.0017
R7449 VSS.n958 VSS.t1974 18.0017
R7450 VSS.n716 VSS.t1991 18.0017
R7451 VSS.t1929 VSS.n719 18.0017
R7452 VSS.t838 VSS.n721 18.0017
R7453 VSS.n927 VSS.t1934 18.0017
R7454 VSS.n919 VSS.t1992 18.0017
R7455 VSS.n733 VSS.t1351 18.0017
R7456 VSS.t1935 VSS.n900 18.0017
R7457 VSS.t1354 VSS.n891 18.0017
R7458 VSS.t1477 VSS.n885 18.0017
R7459 VSS.n877 VSS.t1481 18.0017
R7460 VSS.n872 VSS.t2344 18.0017
R7461 VSS.n864 VSS.t2251 18.0017
R7462 VSS.t597 VSS.n858 18.0017
R7463 VSS.t2006 VSS.n754 18.0017
R7464 VSS.t1265 VSS.n830 18.0017
R7465 VSS.t2014 VSS.n820 18.0017
R7466 VSS.t2012 VSS.n814 18.0017
R7467 VSS.n806 VSS.t2009 18.0017
R7468 VSS.n801 VSS.t1436 18.0017
R7469 VSS.n793 VSS.t1662 18.0017
R7470 VSS.t1395 VSS.n787 18.0017
R7471 VSS.t995 VSS.n671 18.0017
R7472 VSS.t185 VSS.n591 18.0017
R7473 VSS.t1248 VSS.n592 18.0017
R7474 VSS.t2269 VSS.n593 18.0017
R7475 VSS.t2178 VSS.n595 18.0017
R7476 VSS.t2323 VSS.n663 18.0017
R7477 VSS.t1504 VSS.n596 18.0017
R7478 VSS.t1112 VSS.n597 18.0017
R7479 VSS.t827 VSS.n598 18.0017
R7480 VSS.t1628 VSS.n600 18.0017
R7481 VSS.t1240 VSS.n655 18.0017
R7482 VSS.t2059 VSS.n601 18.0017
R7483 VSS.t1784 VSS.n652 18.0017
R7484 VSS.t1113 VSS.n602 18.0017
R7485 VSS.n647 VSS.t1437 18.0017
R7486 VSS.t624 VSS.n645 18.0017
R7487 VSS.n644 VSS.t161 18.0017
R7488 VSS.n643 VSS.t2223 18.0017
R7489 VSS.n642 VSS.t846 18.0017
R7490 VSS.n641 VSS.t2172 18.0017
R7491 VSS.t1093 VSS.n639 18.0017
R7492 VSS.t11 VSS.n609 18.0017
R7493 VSS.n634 VSS.t1314 18.0017
R7494 VSS.t1044 VSS.n632 18.0017
R7495 VSS.n631 VSS.t88 18.0017
R7496 VSS.n1423 VSS.t2186 18.0016
R7497 VSS.n1431 VSS.t1324 18.0016
R7498 VSS.n1440 VSS.t1837 18.0016
R7499 VSS.n1447 VSS.t1639 18.0016
R7500 VSS.n1456 VSS.t2188 18.0016
R7501 VSS.n1463 VSS.t1209 18.0016
R7502 VSS.n1472 VSS.t1210 18.0016
R7503 VSS.n1479 VSS.t1449 18.0016
R7504 VSS.n1488 VSS.t1448 18.0016
R7505 VSS.n1495 VSS.t1884 18.0016
R7506 VSS.n1504 VSS.t1453 18.0016
R7507 VSS.n1511 VSS.t46 18.0016
R7508 VSS.n1528 VSS.t1154 18.0016
R7509 VSS.n1537 VSS.t1326 18.0016
R7510 VSS.n1544 VSS.t1864 18.0016
R7511 VSS.n1553 VSS.t1327 18.0016
R7512 VSS.n1560 VSS.t1158 18.0016
R7513 VSS.n1569 VSS.t959 18.0016
R7514 VSS.n1576 VSS.t493 18.0016
R7515 VSS.n1585 VSS.t1776 18.0016
R7516 VSS.n1592 VSS.t2354 18.0016
R7517 VSS.n1601 VSS.t2159 18.0016
R7518 VSS.n1608 VSS.t1159 18.0016
R7519 VSS.n1617 VSS.t2216 18.0016
R7520 VSS.n1634 VSS.t2219 18.0016
R7521 VSS.n1641 VSS.t2218 18.0016
R7522 VSS.n1650 VSS.t1213 18.0016
R7523 VSS.n1657 VSS.t854 18.0016
R7524 VSS.n1666 VSS.t2244 18.0016
R7525 VSS.n1673 VSS.t732 18.0016
R7526 VSS.t2313 VSS.n434 18.0016
R7527 VSS.t43 VSS.n432 18.0016
R7528 VSS.t2324 VSS.n429 18.0016
R7529 VSS.n428 VSS.t1882 18.0016
R7530 VSS.n427 VSS.t1512 18.0016
R7531 VSS.t845 VSS.n423 18.0016
R7532 VSS.t847 VSS.n421 18.0016
R7533 VSS.n419 VSS.t620 18.0016
R7534 VSS.n418 VSS.t616 18.0016
R7535 VSS.n417 VSS.t1621 18.0016
R7536 VSS.t2166 VSS.n413 18.0016
R7537 VSS.t2226 VSS.n411 18.0016
R7538 VSS.n409 VSS.t2237 18.0016
R7539 VSS.t181 VSS.n407 18.0016
R7540 VSS.t615 VSS.n403 18.0016
R7541 VSS.t1802 VSS.n401 18.0016
R7542 VSS.n399 VSS.t1794 18.0016
R7543 VSS.t1781 VSS.n397 18.0016
R7544 VSS.t603 VSS.n394 18.0016
R7545 VSS.t2227 VSS.n391 18.0016
R7546 VSS.t944 VSS.n389 18.0016
R7547 VSS.n387 VSS.t2282 18.0016
R7548 VSS.t1782 VSS.n385 18.0016
R7549 VSS.t916 VSS.n382 18.0016
R7550 VSS.t1289 VSS.n379 18.0016
R7551 VSS.t1307 VSS.n360 18.0016
R7552 VSS.t1620 VSS.n363 18.0016
R7553 VSS.t1842 VSS.n367 18.0016
R7554 VSS.n370 VSS.t844 18.0016
R7555 VSS.t2234 VSS.n371 18.0016
R7556 VSS.t1241 VSS.n374 18.0016
R7557 VSS.t2162 VSS.n377 18.0016
R7558 VSS.t933 VSS.n680 17.7083
R7559 VSS.t65 VSS.n1321 17.7083
R7560 VSS.t1396 VSS.n1398 17.7083
R7561 VSS.n1385 VSS.t1125 17.4722
R7562 VSS.t1281 VSS.n1743 17.4483
R7563 VSS.n2597 VSS.t2179 17.4424
R7564 VSS.n244 VSS.n243 17.0005
R7565 VSS.n2789 VSS.n244 17.0005
R7566 VSS.n244 VSS.n2788 17.0005
R7567 VSS.n244 VSS.n1903 17.0005
R7568 VSS.n244 VSS.n2098 17.0005
R7569 VSS.n244 VSS.n102 17.0005
R7570 VSS.n244 VSS.n242 17.0005
R7571 VSS.n244 VSS.n103 17.0005
R7572 VSS.n244 VSS.n241 17.0005
R7573 VSS.n244 VSS.n104 17.0005
R7574 VSS.n244 VSS.n240 0.00149998
R7575 VSS.n244 VSS.n1907 17.0005
R7576 VSS.n244 VSS.n2097 17.0005
R7577 VSS.n244 VSS.n1908 17.0005
R7578 VSS.n244 VSS.n239 17.0005
R7579 VSS.n244 VSS.n1909 17.0005
R7580 VSS.n244 VSS.n2094 17.0005
R7581 VSS.n244 VSS.n105 17.0005
R7582 VSS.n244 VSS.n238 17.0005
R7583 VSS.n244 VSS.n1910 17.0005
R7584 VSS.n244 VSS.n2093 17.0005
R7585 VSS.n244 VSS.n1911 17.0005
R7586 VSS.n244 VSS.n2092 17.0005
R7587 VSS.n244 VSS.n106 17.0005
R7588 VSS.n244 VSS.n237 17.0005
R7589 VSS.n244 VSS.n107 17.0005
R7590 VSS.n244 VSS.n236 17.0005
R7591 VSS.n244 VSS.n108 17.0005
R7592 VSS.n244 VSS.n235 17.0005
R7593 VSS.n244 VSS.n1912 17.0005
R7594 VSS.n244 VSS.n2090 17.0005
R7595 VSS.n244 VSS.n1913 17.0005
R7596 VSS.n244 VSS.n234 17.0005
R7597 VSS.n244 VSS.n1914 17.0005
R7598 VSS.n244 VSS.n2087 17.0005
R7599 VSS.n244 VSS.n109 17.0005
R7600 VSS.n244 VSS.n233 17.0005
R7601 VSS.n244 VSS.n1915 17.0005
R7602 VSS.n244 VSS.n2086 17.0005
R7603 VSS.n244 VSS.n1916 17.0005
R7604 VSS.n244 VSS.n2085 17.0005
R7605 VSS.n244 VSS.n110 17.0005
R7606 VSS.n244 VSS.n232 17.0005
R7607 VSS.n244 VSS.n111 17.0005
R7608 VSS.n244 VSS.n231 17.0005
R7609 VSS.n244 VSS.n112 17.0005
R7610 VSS.n244 VSS.n230 17.0005
R7611 VSS.n244 VSS.n1917 17.0005
R7612 VSS.n244 VSS.n2083 17.0005
R7613 VSS.n244 VSS.n1918 17.0005
R7614 VSS.n244 VSS.n229 17.0005
R7615 VSS.n244 VSS.n1919 17.0005
R7616 VSS.n244 VSS.n2080 17.0005
R7617 VSS.n244 VSS.n113 17.0005
R7618 VSS.n244 VSS.n228 17.0005
R7619 VSS.n244 VSS.n1920 17.0005
R7620 VSS.n244 VSS.n2079 17.0005
R7621 VSS.n244 VSS.n1921 17.0005
R7622 VSS.n244 VSS.n2078 17.0005
R7623 VSS.n244 VSS.n114 17.0005
R7624 VSS.n244 VSS.n227 17.0005
R7625 VSS.n244 VSS.n115 17.0005
R7626 VSS.n244 VSS.n226 17.0005
R7627 VSS.n244 VSS.n116 17.0005
R7628 VSS.n244 VSS.n225 17.0005
R7629 VSS.n244 VSS.n1922 17.0005
R7630 VSS.n244 VSS.n2076 17.0005
R7631 VSS.n244 VSS.n1923 17.0005
R7632 VSS.n244 VSS.n224 17.0005
R7633 VSS.n244 VSS.n1924 17.0005
R7634 VSS.n244 VSS.n2073 17.0005
R7635 VSS.n244 VSS.n117 17.0005
R7636 VSS.n244 VSS.n223 17.0005
R7637 VSS.n244 VSS.n1925 17.0005
R7638 VSS.n244 VSS.n2072 17.0005
R7639 VSS.n244 VSS.n1926 17.0005
R7640 VSS.n244 VSS.n2071 17.0005
R7641 VSS.n244 VSS.n118 17.0005
R7642 VSS.n244 VSS.n222 17.0005
R7643 VSS.n244 VSS.n119 17.0005
R7644 VSS.n244 VSS.n221 17.0005
R7645 VSS.n244 VSS.n120 17.0005
R7646 VSS.n244 VSS.n220 17.0005
R7647 VSS.n244 VSS.n1927 17.0005
R7648 VSS.n244 VSS.n2069 17.0005
R7649 VSS.n244 VSS.n1928 17.0005
R7650 VSS.n244 VSS.n219 17.0005
R7651 VSS.n244 VSS.n1929 17.0005
R7652 VSS.n244 VSS.n2066 17.0005
R7653 VSS.n244 VSS.n121 17.0005
R7654 VSS.n244 VSS.n218 17.0005
R7655 VSS.n244 VSS.n1930 17.0005
R7656 VSS.n244 VSS.n2065 17.0005
R7657 VSS.n244 VSS.n1931 17.0005
R7658 VSS.n244 VSS.n2064 17.0005
R7659 VSS.n244 VSS.n122 17.0005
R7660 VSS.n244 VSS.n217 17.0005
R7661 VSS.n244 VSS.n123 17.0005
R7662 VSS.n244 VSS.n216 17.0005
R7663 VSS.n244 VSS.n124 17.0005
R7664 VSS.n244 VSS.n215 17.0005
R7665 VSS.n244 VSS.n1932 17.0005
R7666 VSS.n244 VSS.n2062 17.0005
R7667 VSS.n244 VSS.n1933 17.0005
R7668 VSS.n244 VSS.n214 17.0005
R7669 VSS.n244 VSS.n1934 17.0005
R7670 VSS.n244 VSS.n2059 17.0005
R7671 VSS.n244 VSS.n125 17.0005
R7672 VSS.n244 VSS.n213 17.0005
R7673 VSS.n244 VSS.n1935 17.0005
R7674 VSS.n244 VSS.n2058 17.0005
R7675 VSS.n244 VSS.n1936 17.0005
R7676 VSS.n244 VSS.n2057 17.0005
R7677 VSS.n244 VSS.n126 17.0005
R7678 VSS.n244 VSS.n212 17.0005
R7679 VSS.n244 VSS.n127 17.0005
R7680 VSS.n244 VSS.n211 17.0005
R7681 VSS.n244 VSS.n128 17.0005
R7682 VSS.n244 VSS.n210 17.0005
R7683 VSS.n244 VSS.n1937 17.0005
R7684 VSS.n244 VSS.n2055 17.0005
R7685 VSS.n244 VSS.n1938 17.0005
R7686 VSS.n244 VSS.n209 17.0005
R7687 VSS.n244 VSS.n1939 17.0005
R7688 VSS.n244 VSS.n2052 17.0005
R7689 VSS.n244 VSS.n129 17.0005
R7690 VSS.n244 VSS.n208 17.0005
R7691 VSS.n244 VSS.n1940 17.0005
R7692 VSS.n244 VSS.n2051 17.0005
R7693 VSS.n244 VSS.n1941 17.0005
R7694 VSS.n244 VSS.n2050 17.0005
R7695 VSS.n244 VSS.n130 17.0005
R7696 VSS.n244 VSS.n207 17.0005
R7697 VSS.n244 VSS.n131 17.0005
R7698 VSS.n244 VSS.n206 17.0005
R7699 VSS.n244 VSS.n132 17.0005
R7700 VSS.n244 VSS.n205 17.0005
R7701 VSS.n244 VSS.n1942 17.0005
R7702 VSS.n244 VSS.n2048 17.0005
R7703 VSS.n244 VSS.n1943 17.0005
R7704 VSS.n244 VSS.n204 17.0005
R7705 VSS.n244 VSS.n1944 17.0005
R7706 VSS.n244 VSS.n2045 17.0005
R7707 VSS.n244 VSS.n133 17.0005
R7708 VSS.n244 VSS.n203 17.0005
R7709 VSS.n244 VSS.n1945 17.0005
R7710 VSS.n244 VSS.n2044 17.0005
R7711 VSS.n244 VSS.n1946 17.0005
R7712 VSS.n244 VSS.n2043 17.0005
R7713 VSS.n244 VSS.n134 17.0005
R7714 VSS.n244 VSS.n202 17.0005
R7715 VSS.n244 VSS.n135 17.0005
R7716 VSS.n244 VSS.n201 17.0005
R7717 VSS.n244 VSS.n136 17.0005
R7718 VSS.n244 VSS.n200 17.0005
R7719 VSS.n244 VSS.n1947 17.0005
R7720 VSS.n244 VSS.n2041 17.0005
R7721 VSS.n244 VSS.n1948 17.0005
R7722 VSS.n244 VSS.n199 17.0005
R7723 VSS.n244 VSS.n1949 17.0005
R7724 VSS.n244 VSS.n2038 17.0005
R7725 VSS.n244 VSS.n137 17.0005
R7726 VSS.n244 VSS.n198 17.0005
R7727 VSS.n244 VSS.n1950 17.0005
R7728 VSS.n244 VSS.n2037 17.0005
R7729 VSS.n244 VSS.n1951 17.0005
R7730 VSS.n244 VSS.n2036 17.0005
R7731 VSS.n244 VSS.n138 17.0005
R7732 VSS.n244 VSS.n197 17.0005
R7733 VSS.n244 VSS.n139 17.0005
R7734 VSS.n244 VSS.n196 17.0005
R7735 VSS.n244 VSS.n140 17.0005
R7736 VSS.n244 VSS.n195 17.0005
R7737 VSS.n244 VSS.n1952 17.0005
R7738 VSS.n244 VSS.n2034 17.0005
R7739 VSS.n244 VSS.n1953 17.0005
R7740 VSS.n244 VSS.n194 17.0005
R7741 VSS.n244 VSS.n1954 17.0005
R7742 VSS.n244 VSS.n2031 17.0005
R7743 VSS.n244 VSS.n141 17.0005
R7744 VSS.n244 VSS.n193 17.0005
R7745 VSS.n244 VSS.n1956 17.0005
R7746 VSS.n244 VSS.n2030 17.0005
R7747 VSS.n244 VSS.n1957 17.0005
R7748 VSS.n244 VSS.n2029 17.0005
R7749 VSS.n244 VSS.n142 17.0005
R7750 VSS.n244 VSS.n192 17.0005
R7751 VSS.n244 VSS.n143 17.0005
R7752 VSS.n244 VSS.n191 17.0005
R7753 VSS.n244 VSS.n144 17.0005
R7754 VSS.n244 VSS.n190 17.0005
R7755 VSS.n244 VSS.n1958 17.0005
R7756 VSS.n244 VSS.n2026 17.0005
R7757 VSS.n244 VSS.n1959 17.0005
R7758 VSS.n244 VSS.n189 17.0005
R7759 VSS.n244 VSS.n1960 17.0005
R7760 VSS.n244 VSS.n2023 17.0005
R7761 VSS.n244 VSS.n145 17.0005
R7762 VSS.n244 VSS.n188 17.0005
R7763 VSS.n244 VSS.n1961 17.0005
R7764 VSS.n244 VSS.n2022 17.0005
R7765 VSS.n244 VSS.n1962 17.0005
R7766 VSS.n244 VSS.n2021 17.0005
R7767 VSS.n244 VSS.n146 17.0005
R7768 VSS.n244 VSS.n187 17.0005
R7769 VSS.n244 VSS.n147 17.0005
R7770 VSS.n244 VSS.n186 17.0005
R7771 VSS.n244 VSS.n148 17.0005
R7772 VSS.n244 VSS.n185 17.0005
R7773 VSS.n244 VSS.n1963 17.0005
R7774 VSS.n244 VSS.n2019 17.0005
R7775 VSS.n244 VSS.n1964 17.0005
R7776 VSS.n244 VSS.n184 17.0005
R7777 VSS.n244 VSS.n1965 17.0005
R7778 VSS.n244 VSS.n2016 17.0005
R7779 VSS.n244 VSS.n149 17.0005
R7780 VSS.n244 VSS.n183 17.0005
R7781 VSS.n244 VSS.n1966 17.0005
R7782 VSS.n244 VSS.n2015 17.0005
R7783 VSS.n244 VSS.n1967 17.0005
R7784 VSS.n244 VSS.n2014 17.0005
R7785 VSS.n244 VSS.n150 17.0005
R7786 VSS.n244 VSS.n182 17.0005
R7787 VSS.n244 VSS.n151 17.0005
R7788 VSS.n244 VSS.n181 17.0005
R7789 VSS.n244 VSS.n152 17.0005
R7790 VSS.n244 VSS.n180 17.0005
R7791 VSS.n244 VSS.n1968 17.0005
R7792 VSS.n244 VSS.n2012 17.0005
R7793 VSS.n244 VSS.n1969 17.0005
R7794 VSS.n244 VSS.n179 17.0005
R7795 VSS.n244 VSS.n1970 17.0005
R7796 VSS.n244 VSS.n2009 17.0005
R7797 VSS.n244 VSS.n153 17.0005
R7798 VSS.n244 VSS.n178 17.0005
R7799 VSS.n244 VSS.n1971 17.0005
R7800 VSS.n244 VSS.n2008 17.0005
R7801 VSS.n244 VSS.n1972 17.0005
R7802 VSS.n244 VSS.n2007 17.0005
R7803 VSS.n244 VSS.n154 17.0005
R7804 VSS.n244 VSS.n177 17.0005
R7805 VSS.n244 VSS.n155 17.0005
R7806 VSS.n244 VSS.n176 17.0005
R7807 VSS.n244 VSS.n156 17.0005
R7808 VSS.n244 VSS.n175 17.0005
R7809 VSS.n244 VSS.n1973 17.0005
R7810 VSS.n244 VSS.n2005 17.0005
R7811 VSS.n244 VSS.n1974 17.0005
R7812 VSS.n244 VSS.n174 17.0005
R7813 VSS.n244 VSS.n1975 17.0005
R7814 VSS.n244 VSS.n2002 17.0005
R7815 VSS.n244 VSS.n157 17.0005
R7816 VSS.n244 VSS.n173 17.0005
R7817 VSS.n244 VSS.n1976 17.0005
R7818 VSS.n244 VSS.n2001 17.0005
R7819 VSS.n244 VSS.n1977 17.0005
R7820 VSS.n244 VSS.n2000 17.0005
R7821 VSS.n244 VSS.n158 17.0005
R7822 VSS.n244 VSS.n172 17.0005
R7823 VSS.n244 VSS.n159 17.0005
R7824 VSS.n244 VSS.n171 17.0005
R7825 VSS.n244 VSS.n160 17.0005
R7826 VSS.n244 VSS.n170 17.0005
R7827 VSS.n244 VSS.n1978 17.0005
R7828 VSS.n244 VSS.n1998 17.0005
R7829 VSS.n244 VSS.n1979 17.0005
R7830 VSS.n244 VSS.n169 17.0005
R7831 VSS.n244 VSS.n1980 17.0005
R7832 VSS.n244 VSS.n1995 17.0005
R7833 VSS.n244 VSS.n161 17.0005
R7834 VSS.n244 VSS.n168 17.0005
R7835 VSS.n244 VSS.n1981 17.0005
R7836 VSS.n244 VSS.n1994 17.0005
R7837 VSS.n244 VSS.n1982 17.0005
R7838 VSS.n244 VSS.n1993 17.0005
R7839 VSS.n101 VSS.n100 8.50087
R7840 VSS.n244 VSS.n167 17.0005
R7841 VSS.n244 VSS.n162 17.0005
R7842 VSS.n244 VSS.n166 17.0005
R7843 VSS.n244 VSS.n163 17.0005
R7844 VSS.n244 VSS.n165 17.0005
R7845 VSS.n244 VSS.n1983 17.0005
R7846 VSS.n244 VSS.n1991 17.0005
R7847 VSS.n244 VSS.n1984 17.0005
R7848 VSS.n244 VSS.n164 17.0005
R7849 VSS.n244 VSS.n1985 17.0005
R7850 VSS.n244 VSS.n1988 17.0005
R7851 VSS.n244 VSS.n1986 17.0005
R7852 VSS.n582 VSS.n1754 17.0005
R7853 VSS.n2791 VSS.n582 17.0005
R7854 VSS.n582 VSS.n1773 17.0005
R7855 VSS.n582 VSS.t1234 17.0005
R7856 VSS.n582 VSS.n164 17.0005
R7857 VSS.n582 VSS.n1783 17.0005
R7858 VSS.n582 VSS.n165 17.0005
R7859 VSS.n582 VSS.n163 17.0005
R7860 VSS.n582 VSS.n166 17.0005
R7861 VSS.n582 VSS.n162 17.0005
R7862 VSS.n582 VSS.n167 17.0005
R7863 VSS.n582 VSS.n101 0.00125
R7864 VSS.n582 VSS.n168 17.0005
R7865 VSS.n582 VSS.n161 17.0005
R7866 VSS.n582 VSS.n169 17.0005
R7867 VSS.n582 VSS.n1790 17.0005
R7868 VSS.n582 VSS.n170 17.0005
R7869 VSS.n582 VSS.n160 17.0005
R7870 VSS.n582 VSS.n171 17.0005
R7871 VSS.n582 VSS.n159 17.0005
R7872 VSS.n582 VSS.n172 17.0005
R7873 VSS.n582 VSS.n158 17.0005
R7874 VSS.n582 VSS.n173 17.0005
R7875 VSS.n582 VSS.n157 17.0005
R7876 VSS.n582 VSS.n174 17.0005
R7877 VSS.n582 VSS.n1797 17.0005
R7878 VSS.n582 VSS.n175 17.0005
R7879 VSS.n582 VSS.n156 17.0005
R7880 VSS.n582 VSS.n176 17.0005
R7881 VSS.n582 VSS.n155 17.0005
R7882 VSS.n582 VSS.n177 17.0005
R7883 VSS.n582 VSS.n154 17.0005
R7884 VSS.n582 VSS.n178 17.0005
R7885 VSS.n582 VSS.n153 17.0005
R7886 VSS.n582 VSS.n179 17.0005
R7887 VSS.n582 VSS.n1804 17.0005
R7888 VSS.n582 VSS.n180 17.0005
R7889 VSS.n582 VSS.n152 17.0005
R7890 VSS.n582 VSS.n181 17.0005
R7891 VSS.n582 VSS.n151 17.0005
R7892 VSS.n582 VSS.n182 17.0005
R7893 VSS.n582 VSS.n150 17.0005
R7894 VSS.n582 VSS.n183 17.0005
R7895 VSS.n582 VSS.n149 17.0005
R7896 VSS.n582 VSS.n184 17.0005
R7897 VSS.n582 VSS.n1811 17.0005
R7898 VSS.n582 VSS.n185 17.0005
R7899 VSS.n582 VSS.n148 17.0005
R7900 VSS.n582 VSS.n186 17.0005
R7901 VSS.n582 VSS.n147 17.0005
R7902 VSS.n582 VSS.n187 17.0005
R7903 VSS.n582 VSS.n146 17.0005
R7904 VSS.n582 VSS.n188 17.0005
R7905 VSS.n582 VSS.n145 17.0005
R7906 VSS.n582 VSS.n189 17.0005
R7907 VSS.n582 VSS.n1818 17.0005
R7908 VSS.n582 VSS.n190 17.0005
R7909 VSS.n582 VSS.n144 17.0005
R7910 VSS.n582 VSS.n191 17.0005
R7911 VSS.n582 VSS.n143 17.0005
R7912 VSS.n582 VSS.n192 17.0005
R7913 VSS.n582 VSS.n142 17.0005
R7914 VSS.n582 VSS.n193 17.0005
R7915 VSS.n582 VSS.n141 17.0005
R7916 VSS.n582 VSS.n194 17.0005
R7917 VSS.n582 VSS.n1827 17.0005
R7918 VSS.n582 VSS.n195 17.0005
R7919 VSS.n582 VSS.n140 17.0005
R7920 VSS.n582 VSS.n196 17.0005
R7921 VSS.n582 VSS.n139 17.0005
R7922 VSS.n582 VSS.n197 17.0005
R7923 VSS.n582 VSS.n138 17.0005
R7924 VSS.n582 VSS.n198 17.0005
R7925 VSS.n582 VSS.n137 17.0005
R7926 VSS.n582 VSS.n199 17.0005
R7927 VSS.n582 VSS.n1834 17.0005
R7928 VSS.n582 VSS.n200 17.0005
R7929 VSS.n582 VSS.n136 17.0005
R7930 VSS.n582 VSS.n201 17.0005
R7931 VSS.n582 VSS.n135 17.0005
R7932 VSS.n582 VSS.n202 17.0005
R7933 VSS.n582 VSS.n134 17.0005
R7934 VSS.n582 VSS.n203 17.0005
R7935 VSS.n582 VSS.n133 17.0005
R7936 VSS.n582 VSS.n204 17.0005
R7937 VSS.n582 VSS.n1841 17.0005
R7938 VSS.n582 VSS.n205 17.0005
R7939 VSS.n582 VSS.n132 17.0005
R7940 VSS.n582 VSS.n206 17.0005
R7941 VSS.n582 VSS.n131 17.0005
R7942 VSS.n582 VSS.n207 17.0005
R7943 VSS.n582 VSS.n130 17.0005
R7944 VSS.n582 VSS.n208 17.0005
R7945 VSS.n582 VSS.n129 17.0005
R7946 VSS.n582 VSS.n209 17.0005
R7947 VSS.n582 VSS.n1848 17.0005
R7948 VSS.n582 VSS.n210 17.0005
R7949 VSS.n582 VSS.n128 17.0005
R7950 VSS.n582 VSS.n211 17.0005
R7951 VSS.n582 VSS.n127 17.0005
R7952 VSS.n582 VSS.n212 17.0005
R7953 VSS.n582 VSS.n126 17.0005
R7954 VSS.n582 VSS.n213 17.0005
R7955 VSS.n582 VSS.n125 17.0005
R7956 VSS.n582 VSS.n214 17.0005
R7957 VSS.n582 VSS.n1855 17.0005
R7958 VSS.n582 VSS.n215 17.0005
R7959 VSS.n582 VSS.n124 17.0005
R7960 VSS.n582 VSS.n216 17.0005
R7961 VSS.n582 VSS.n123 17.0005
R7962 VSS.n582 VSS.n217 17.0005
R7963 VSS.n582 VSS.n122 17.0005
R7964 VSS.n582 VSS.n218 17.0005
R7965 VSS.n582 VSS.n121 17.0005
R7966 VSS.n582 VSS.n219 17.0005
R7967 VSS.n582 VSS.n1862 17.0005
R7968 VSS.n582 VSS.n220 17.0005
R7969 VSS.n582 VSS.n120 17.0005
R7970 VSS.n582 VSS.n221 17.0005
R7971 VSS.n582 VSS.n119 17.0005
R7972 VSS.n582 VSS.n222 17.0005
R7973 VSS.n582 VSS.n118 17.0005
R7974 VSS.n582 VSS.n223 17.0005
R7975 VSS.n582 VSS.n117 17.0005
R7976 VSS.n582 VSS.n224 17.0005
R7977 VSS.n582 VSS.n1869 17.0005
R7978 VSS.n582 VSS.n225 17.0005
R7979 VSS.n582 VSS.n116 17.0005
R7980 VSS.n582 VSS.n226 17.0005
R7981 VSS.n582 VSS.n115 17.0005
R7982 VSS.n582 VSS.n227 17.0005
R7983 VSS.n582 VSS.n114 17.0005
R7984 VSS.n582 VSS.n228 17.0005
R7985 VSS.n582 VSS.n113 17.0005
R7986 VSS.n582 VSS.n229 17.0005
R7987 VSS.n582 VSS.n1878 17.0005
R7988 VSS.n582 VSS.n230 17.0005
R7989 VSS.n582 VSS.n112 17.0005
R7990 VSS.n582 VSS.n231 17.0005
R7991 VSS.n582 VSS.n111 17.0005
R7992 VSS.n582 VSS.n232 17.0005
R7993 VSS.n582 VSS.n110 17.0005
R7994 VSS.n582 VSS.n233 17.0005
R7995 VSS.n582 VSS.n109 17.0005
R7996 VSS.n582 VSS.n234 17.0005
R7997 VSS.n582 VSS.n1885 17.0005
R7998 VSS.n582 VSS.n235 17.0005
R7999 VSS.n582 VSS.n108 17.0005
R8000 VSS.n582 VSS.n236 17.0005
R8001 VSS.n582 VSS.n107 17.0005
R8002 VSS.n582 VSS.n237 17.0005
R8003 VSS.n582 VSS.n106 17.0005
R8004 VSS.n582 VSS.n238 17.0005
R8005 VSS.n582 VSS.n105 17.0005
R8006 VSS.n582 VSS.n239 17.0005
R8007 VSS.n582 VSS.n1892 17.0005
R8008 VSS.n240 VSS.n1894 8.50075
R8009 VSS.n582 VSS.n104 17.0005
R8010 VSS.n582 VSS.n241 17.0005
R8011 VSS.n582 VSS.n103 17.0005
R8012 VSS.n582 VSS.n242 17.0005
R8013 VSS.n582 VSS.n102 17.0005
R8014 VSS.n582 VSS.n1897 17.0005
R8015 VSS.n582 VSS.n1899 17.0005
R8016 VSS.n582 VSS.n1900 17.0005
R8017 VSS.n2331 VSS.n299 17.0005
R8018 VSS.n2333 VSS.n299 17.0005
R8019 VSS.n2335 VSS.n299 17.0005
R8020 VSS.n2337 VSS.n299 17.0005
R8021 VSS.n2339 VSS.n299 17.0005
R8022 VSS.n2341 VSS.n299 17.0005
R8023 VSS.n2343 VSS.n299 17.0005
R8024 VSS.n2345 VSS.n299 17.0005
R8025 VSS.n2347 VSS.n299 17.0005
R8026 VSS.n2349 VSS.n299 17.0005
R8027 VSS.n2351 VSS.n299 17.0005
R8028 VSS.n2353 VSS.n299 17.0005
R8029 VSS.n2355 VSS.n299 17.0005
R8030 VSS.n2357 VSS.n299 17.0005
R8031 VSS.n2359 VSS.n299 17.0005
R8032 VSS.n2361 VSS.n299 17.0005
R8033 VSS.n2363 VSS.n299 17.0005
R8034 VSS.n2365 VSS.n299 17.0005
R8035 VSS.n2367 VSS.n299 17.0005
R8036 VSS.n2369 VSS.n299 17.0005
R8037 VSS.n2371 VSS.n299 17.0005
R8038 VSS.n2373 VSS.n299 17.0005
R8039 VSS.n2375 VSS.n299 17.0005
R8040 VSS.n2671 VSS.n25 17.0005
R8041 VSS.n2672 VSS.n25 17.0005
R8042 VSS.n2674 VSS.n25 17.0005
R8043 VSS.n2676 VSS.n25 17.0005
R8044 VSS.n2679 VSS.n25 17.0005
R8045 VSS.n2682 VSS.n25 17.0005
R8046 VSS.n2684 VSS.n25 17.0005
R8047 VSS.n60 VSS.n25 4.85624
R8048 VSS.n2666 VSS.n25 17.0005
R8049 VSS.n16 VSS.n2173 17.0005
R8050 VSS.n16 VSS.n2177 17.0005
R8051 VSS.n16 VSS.n2174 17.0005
R8052 VSS.n16 VSS.n2176 17.0005
R8053 VSS.n16 VSS.n2175 17.0005
R8054 VSS.n16 VSS.n2597 17.0005
R8055 VSS.n16 VSS.n2595 17.0005
R8056 VSS.n256 VSS.n16 5.65265
R8057 VSS.n16 VSS.n2596 17.0005
R8058 VSS.n260 VSS.n2598 17.0005
R8059 VSS.n260 VSS.n2589 17.0005
R8060 VSS.n260 VSS.n2594 17.0005
R8061 VSS.n260 VSS.n2590 17.0005
R8062 VSS.n260 VSS.n2593 17.0005
R8063 VSS.n260 VSS.n2591 17.0005
R8064 VSS.n260 VSS.n2592 17.0005
R8065 VSS.n259 VSS.n2588 17.0005
R8066 VSS.n259 VSS.n2575 17.0005
R8067 VSS.n259 VSS.n2587 17.0005
R8068 VSS.n259 VSS.n2576 17.0005
R8069 VSS.n259 VSS.n2586 17.0005
R8070 VSS.n259 VSS.n2577 17.0005
R8071 VSS.n259 VSS.n2585 17.0005
R8072 VSS.n259 VSS.n2578 17.0005
R8073 VSS.n259 VSS.n2584 17.0005
R8074 VSS.n259 VSS.n2579 17.0005
R8075 VSS.n259 VSS.n2583 17.0005
R8076 VSS.n259 VSS.n2580 17.0005
R8077 VSS.n259 VSS.n2582 17.0005
R8078 VSS.n259 VSS.n2581 17.0005
R8079 VSS.n268 VSS.n2599 17.0005
R8080 VSS.n268 VSS.n2572 17.0005
R8081 VSS.n268 VSS.n2574 17.0005
R8082 VSS.n268 VSS.n2573 17.0005
R8083 VSS.n267 VSS.n2571 17.0005
R8084 VSS.n271 VSS.n267 5.65265
R8085 VSS.n274 VSS.n2600 17.0005
R8086 VSS.n274 VSS.n2561 17.0005
R8087 VSS.n274 VSS.n2562 17.0005
R8088 VSS.n274 VSS.n2570 17.0005
R8089 VSS.n274 VSS.n2563 17.0005
R8090 VSS.n274 VSS.n2569 17.0005
R8091 VSS.n274 VSS.n2564 17.0005
R8092 VSS.n274 VSS.n2568 17.0005
R8093 VSS.n274 VSS.n2565 17.0005
R8094 VSS.n274 VSS.n2567 17.0005
R8095 VSS.n2566 VSS.n273 17.0005
R8096 VSS.n273 VSS.n2551 17.0005
R8097 VSS.n273 VSS.n2559 17.0005
R8098 VSS.n273 VSS.n2552 17.0005
R8099 VSS.n273 VSS.n2558 17.0005
R8100 VSS.n273 VSS.n2553 17.0005
R8101 VSS.n273 VSS.n2557 17.0005
R8102 VSS.n273 VSS.n2554 17.0005
R8103 VSS.n273 VSS.n2556 17.0005
R8104 VSS.n273 VSS.n2555 17.0005
R8105 VSS.n278 VSS.n281 17.0005
R8106 VSS.n278 VSS.n2232 17.0005
R8107 VSS.n278 VSS.n2549 17.0005
R8108 VSS.n278 VSS.n2233 17.0005
R8109 VSS.n278 VSS.n2546 17.0005
R8110 VSS.n278 VSS.n2234 17.0005
R8111 VSS.n278 VSS.n2543 17.0005
R8112 VSS.n278 VSS.n2235 17.0005
R8113 VSS.n278 VSS.n2540 17.0005
R8114 VSS.n278 VSS.n2236 17.0005
R8115 VSS.n278 VSS.n2537 17.0005
R8116 VSS.n278 VSS.n2237 17.0005
R8117 VSS.n278 VSS.n2532 17.0005
R8118 VSS.n278 VSS.n2238 17.0005
R8119 VSS.n278 VSS.n2529 17.0005
R8120 VSS.n278 VSS.n2239 17.0005
R8121 VSS.n278 VSS.n2526 17.0005
R8122 VSS.n278 VSS.n2240 17.0005
R8123 VSS.n278 VSS.n2523 17.0005
R8124 VSS.n278 VSS.n2241 17.0005
R8125 VSS.n278 VSS.n2520 17.0005
R8126 VSS.n278 VSS.n2242 17.0005
R8127 VSS.n278 VSS.n2517 17.0005
R8128 VSS.n278 VSS.n2243 17.0005
R8129 VSS.n278 VSS.n2514 17.0005
R8130 VSS.n278 VSS.n2244 17.0005
R8131 VSS.n278 VSS.n2511 17.0005
R8132 VSS.n278 VSS.n2245 17.0005
R8133 VSS.n278 VSS.n2253 17.0005
R8134 VSS.n278 VSS.n2246 17.0005
R8135 VSS.n278 VSS.n2250 17.0005
R8136 VSS.n278 VSS.n2247 17.0005
R8137 VSS.n284 VSS.n2508 17.0005
R8138 VSS.n284 VSS.n2254 17.0005
R8139 VSS.n284 VSS.n2505 17.0005
R8140 VSS.n284 VSS.n2255 17.0005
R8141 VSS.n284 VSS.n2502 17.0005
R8142 VSS.n284 VSS.n2256 17.0005
R8143 VSS.n2493 VSS.n283 17.0005
R8144 VSS.n2495 VSS.n283 17.0005
R8145 VSS.n2497 VSS.n283 17.0005
R8146 VSS.n287 VSS.n2499 17.0005
R8147 VSS.n287 VSS.n2257 17.0005
R8148 VSS.n287 VSS.n2490 17.0005
R8149 VSS.n287 VSS.n2258 17.0005
R8150 VSS.n287 VSS.n2487 17.0005
R8151 VSS.n287 VSS.n2259 17.0005
R8152 VSS.n287 VSS.n2484 17.0005
R8153 VSS.n287 VSS.n2260 17.0005
R8154 VSS.n287 VSS.n2481 17.0005
R8155 VSS.n2478 VSS.n289 17.0005
R8156 VSS.n289 VSS.n2262 17.0005
R8157 VSS.n289 VSS.n2477 17.0005
R8158 VSS.n289 VSS.n2263 17.0005
R8159 VSS.n289 VSS.n2475 17.0005
R8160 VSS.n289 VSS.n2264 17.0005
R8161 VSS.n289 VSS.n2472 17.0005
R8162 VSS.n289 VSS.n2265 17.0005
R8163 VSS.n289 VSS.n2469 17.0005
R8164 VSS.n289 VSS.n2266 17.0005
R8165 VSS.n289 VSS.n2466 17.0005
R8166 VSS.n289 VSS.n2267 17.0005
R8167 VSS.n289 VSS.n2463 17.0005
R8168 VSS.n289 VSS.n2268 17.0005
R8169 VSS.n289 VSS.n2460 17.0005
R8170 VSS.n289 VSS.n2269 17.0005
R8171 VSS.n289 VSS.n2457 17.0005
R8172 VSS.n289 VSS.n2270 17.0005
R8173 VSS.n289 VSS.n2278 17.0005
R8174 VSS.n289 VSS.n2271 17.0005
R8175 VSS.n289 VSS.n2275 17.0005
R8176 VSS.n289 VSS.n2272 17.0005
R8177 VSS.n291 VSS.n2454 17.0005
R8178 VSS.n291 VSS.n2279 17.0005
R8179 VSS.n291 VSS.n2451 17.0005
R8180 VSS.n291 VSS.n2280 17.0005
R8181 VSS.n291 VSS.n2448 17.0005
R8182 VSS.n291 VSS.n2281 17.0005
R8183 VSS.n2439 VSS.n247 17.0005
R8184 VSS.n2441 VSS.n247 17.0005
R8185 VSS.n2443 VSS.n247 17.0005
R8186 VSS.n249 VSS.n2445 17.0005
R8187 VSS.n249 VSS.n2282 17.0005
R8188 VSS.n249 VSS.n2436 17.0005
R8189 VSS.n249 VSS.n2283 17.0005
R8190 VSS.n249 VSS.n2433 17.0005
R8191 VSS.n249 VSS.n2284 17.0005
R8192 VSS.n249 VSS.n2430 17.0005
R8193 VSS.n249 VSS.n2285 17.0005
R8194 VSS.n249 VSS.n2427 17.0005
R8195 VSS.n2424 VSS.n249 17.0005
R8196 VSS.n249 VSS.n2287 17.0005
R8197 VSS.n249 VSS.n2423 17.0005
R8198 VSS.n249 VSS.n2288 17.0005
R8199 VSS.n249 VSS.n2421 17.0005
R8200 VSS.n249 VSS.n2290 17.0005
R8201 VSS.n249 VSS.n2418 17.0005
R8202 VSS.n2377 VSS.n299 17.0005
R8203 VSS.n2379 VSS.n299 17.0005
R8204 VSS.n2381 VSS.n299 17.0005
R8205 VSS.n2383 VSS.n299 17.0005
R8206 VSS.n2384 VSS.n299 17.0005
R8207 VSS.n2386 VSS.n299 17.0005
R8208 VSS.n296 VSS.n2389 17.0005
R8209 VSS.n296 VSS.n2316 17.0005
R8210 VSS.n296 VSS.n2328 17.0005
R8211 VSS.n296 VSS.n2317 17.0005
R8212 VSS.n296 VSS.n2325 17.0005
R8213 VSS.n296 VSS.n2318 17.0005
R8214 VSS.n296 VSS.n2322 17.0005
R8215 VSS.n296 VSS.n2319 17.0005
R8216 VSS.n2390 VSS.n296 17.0005
R8217 VSS.n298 VSS.n2393 17.0005
R8218 VSS.n298 VSS.n2299 17.0005
R8219 VSS.n298 VSS.n297 5.65652
R8220 VSS.n298 VSS.n2314 17.0005
R8221 VSS.n2312 VSS.n248 17.0005
R8222 VSS.n2310 VSS.n248 17.0005
R8223 VSS.n2308 VSS.n248 17.0005
R8224 VSS.n2306 VSS.n248 17.0005
R8225 VSS.n2304 VSS.n248 17.0005
R8226 VSS.n2302 VSS.n248 17.0005
R8227 VSS.n249 VSS.n2291 17.0005
R8228 VSS.n249 VSS.n2293 17.0005
R8229 VSS.n249 VSS.n2295 17.0005
R8230 VSS.n249 VSS.n2297 17.0005
R8231 VSS.n249 VSS.n2395 17.0005
R8232 VSS.n249 VSS.n2397 17.0005
R8233 VSS.n249 VSS.n2399 17.0005
R8234 VSS.n249 VSS.n2401 17.0005
R8235 VSS.n249 VSS.n2403 17.0005
R8236 VSS.n249 VSS.n2405 17.0005
R8237 VSS.n249 VSS.n2407 17.0005
R8238 VSS.n249 VSS.n2409 17.0005
R8239 VSS.n249 VSS.n2411 17.0005
R8240 VSS.n249 VSS.n2413 17.0005
R8241 VSS.n249 VSS.n2415 17.0005
R8242 VSS.n775 VSS.n3015 17.0005
R8243 VSS.n775 VSS.n678 17.0005
R8244 VSS.n775 VSS.n1013 17.0005
R8245 VSS.n775 VSS.n679 17.0005
R8246 VSS.n775 VSS.n1010 17.0005
R8247 VSS.n775 VSS.n680 17.0005
R8248 VSS.n775 VSS.n1009 17.0005
R8249 VSS.n775 VSS.n95 17.0005
R8250 VSS.n775 VSS.n99 17.0005
R8251 VSS.n775 VSS.n681 17.0005
R8252 VSS.n775 VSS.n1007 17.0005
R8253 VSS.n775 VSS.n96 17.0005
R8254 VSS.n775 VSS.n1006 17.0005
R8255 VSS.n775 VSS.n682 17.0005
R8256 VSS.n775 VSS.n98 17.0005
R8257 VSS.n775 VSS.n685 17.0005
R8258 VSS.n775 VSS.n97 17.0005
R8259 VSS.n775 VSS.n686 17.0005
R8260 VSS.n775 VSS.n1005 17.0005
R8261 VSS.n775 VSS.n689 17.0005
R8262 VSS.n775 VSS.n694 17.0005
R8263 VSS.n775 VSS.n691 17.0005
R8264 VSS.n775 VSS.t1847 17.0005
R8265 VSS.n775 VSS.n774 17.0005
R8266 VSS.n1053 VSS.n32 17.0005
R8267 VSS.n1052 VSS.n32 17.0005
R8268 VSS.n1050 VSS.n32 17.0005
R8269 VSS.n1048 VSS.n32 17.0005
R8270 VSS.n1045 VSS.n32 17.0005
R8271 VSS.n1042 VSS.n32 17.0005
R8272 VSS.n305 VSS.n1014 17.0005
R8273 VSS.n310 VSS.n1038 17.0005
R8274 VSS.n315 VSS.n1015 17.0005
R8275 VSS.n320 VSS.n1035 17.0005
R8276 VSS.n325 VSS.n1016 17.0005
R8277 VSS.n330 VSS.n1031 17.0005
R8278 VSS.n1032 VSS.n330 17.0005
R8279 VSS.n70 VSS.n47 6.82731
R8280 VSS.n338 VSS.n1017 17.0005
R8281 VSS.n78 VSS.n1027 17.0005
R8282 VSS.n86 VSS.n347 17.0005
R8283 VSS.n342 VSS.n346 5.65652
R8284 VSS.n344 VSS.n1024 17.0005
R8285 VSS.t2 VSS.n3013 17.0005
R8286 VSS.t2 VSS.n95 17.0005
R8287 VSS.t2 VSS.n99 17.0005
R8288 VSS.t2 VSS.n96 17.0005
R8289 VSS.t2 VSS.n98 17.0005
R8290 VSS.t2 VSS.n1062 17.0005
R8291 VSS.t2 VSS.n97 17.0005
R8292 VSS.t2 VSS.n1065 17.0005
R8293 VSS.t331 VSS.n2998 17.0005
R8294 VSS.t331 VSS.n1318 17.0005
R8295 VSS.t331 VSS.n1340 17.0005
R8296 VSS.t331 VSS.n1319 17.0005
R8297 VSS.t331 VSS.n1338 17.0005
R8298 VSS.t331 VSS.n1321 17.0005
R8299 VSS.t331 VSS.n1337 17.0005
R8300 VSS.t331 VSS.n90 17.0005
R8301 VSS.t331 VSS.n94 17.0005
R8302 VSS.t331 VSS.n1322 17.0005
R8303 VSS.t331 VSS.n1336 17.0005
R8304 VSS.t331 VSS.n91 17.0005
R8305 VSS.t331 VSS.n1335 17.0005
R8306 VSS.t331 VSS.n1324 17.0005
R8307 VSS.t331 VSS.n93 17.0005
R8308 VSS.t331 VSS.n1325 17.0005
R8309 VSS.t331 VSS.n1334 17.0005
R8310 VSS.t331 VSS.n1327 17.0005
R8311 VSS.t331 VSS.n92 17.0005
R8312 VSS.t331 VSS.n1328 17.0005
R8313 VSS.t331 VSS.n1333 17.0005
R8314 VSS.t331 VSS.n1329 17.0005
R8315 VSS.n589 VSS.n1316 17.0005
R8316 VSS.n589 VSS.n90 17.0005
R8317 VSS.n589 VSS.n94 17.0005
R8318 VSS.n589 VSS.n91 17.0005
R8319 VSS.n589 VSS.n93 17.0005
R8320 VSS.n589 VSS.n1073 17.0005
R8321 VSS.n589 VSS.n92 17.0005
R8322 VSS.n589 VSS.n1075 17.0005
R8323 VSS.n589 VSS.n1118 17.0005
R8324 VSS.n589 VSS.t1867 17.0005
R8325 VSS.n3004 VSS.n589 17.0005
R8326 VSS.n589 VSS.n630 17.0005
R8327 VSS.n589 VSS.n1078 17.0005
R8328 VSS.n589 VSS.n1076 17.0005
R8329 VSS.t331 VSS.n1331 17.0005
R8330 VSS.t331 VSS.n72 6.8105
R8331 VSS.n439 VSS.t1129 17.0005
R8332 VSS.n439 VSS.n2919 17.0005
R8333 VSS.n439 VSS.n2922 17.0005
R8334 VSS.n439 VSS.n1344 17.0005
R8335 VSS.n439 VSS.n1342 17.0005
R8336 VSS.n439 VSS.n1392 17.0005
R8337 VSS.n439 VSS.n1391 17.0005
R8338 VSS.n439 VSS.n1390 17.0005
R8339 VSS.n439 VSS.n1388 17.0005
R8340 VSS.n439 VSS.n1386 17.0005
R8341 VSS.n2150 VSS.n508 17.0005
R8342 VSS.n509 VSS.n2667 5.66689
R8343 VSS.n2796 VSS.t122 17.0005
R8344 VSS.t122 VSS.n1395 17.0005
R8345 VSS.t122 VSS.n1415 17.0005
R8346 VSS.t122 VSS.n1396 17.0005
R8347 VSS.t122 VSS.n1413 17.0005
R8348 VSS.t122 VSS.n1398 17.0005
R8349 VSS.t122 VSS.n1412 17.0005
R8350 VSS.t122 VSS.n580 17.0005
R8351 VSS.t122 VSS.n579 17.0005
R8352 VSS.t122 VSS.n1399 17.0005
R8353 VSS.t122 VSS.n1411 17.0005
R8354 VSS.t122 VSS.n578 17.0005
R8355 VSS.t122 VSS.n1410 17.0005
R8356 VSS.t122 VSS.n1401 17.0005
R8357 VSS.t122 VSS.n577 17.0005
R8358 VSS.t122 VSS.n1403 17.0005
R8359 VSS.t122 VSS.n576 17.0005
R8360 VSS.t122 VSS.n1404 17.0005
R8361 VSS.t122 VSS.n1408 17.0005
R8362 VSS.t122 VSS.n1405 17.0005
R8363 VSS.n582 VSS.n1770 17.0005
R8364 VSS.n582 VSS.n580 17.0005
R8365 VSS.n582 VSS.n579 17.0005
R8366 VSS.n582 VSS.n578 17.0005
R8367 VSS.n582 VSS.n577 17.0005
R8368 VSS.n582 VSS.n1764 17.0005
R8369 VSS.n582 VSS.n576 17.0005
R8370 VSS.n582 VSS.n1759 17.0005
R8371 VSS.t122 VSS.n1406 17.0005
R8372 VSS.n1749 VSS.n1748 17.0005
R8373 VSS.n1749 VSS.n1422 17.0005
R8374 VSS.n1749 VSS.n1729 17.0005
R8375 VSS.n1749 VSS.t2024 17.0005
R8376 VSS.n1749 VSS.n1684 17.0005
R8377 VSS.n1749 VSS.n1733 17.0005
R8378 VSS.n1749 VSS.n1734 17.0005
R8379 VSS.n1749 VSS.n1736 17.0005
R8380 VSS.n1749 VSS.n1738 17.0005
R8381 VSS.n1749 VSS.n1742 17.0005
R8382 VSS.n2416 VSS.n559 17.0005
R8383 VSS.n2414 VSS.n559 17.0005
R8384 VSS.n2412 VSS.n559 17.0005
R8385 VSS.n2410 VSS.n559 17.0005
R8386 VSS.n2408 VSS.n559 17.0005
R8387 VSS.n2406 VSS.n559 17.0005
R8388 VSS.n2404 VSS.n559 17.0005
R8389 VSS.n2402 VSS.n559 17.0005
R8390 VSS.n2400 VSS.n559 17.0005
R8391 VSS.n2398 VSS.n559 17.0005
R8392 VSS.n2396 VSS.n559 17.0005
R8393 VSS.n2394 VSS.n559 17.0005
R8394 VSS.n2296 VSS.n559 17.0005
R8395 VSS.n2294 VSS.n559 17.0005
R8396 VSS.n2292 VSS.n559 17.0005
R8397 VSS.n2301 VSS.n559 17.0005
R8398 VSS.n2303 VSS.n559 17.0005
R8399 VSS.n2305 VSS.n559 17.0005
R8400 VSS.n2307 VSS.n559 17.0005
R8401 VSS.n2309 VSS.n559 17.0005
R8402 VSS.n2311 VSS.n559 17.0005
R8403 VSS.n2313 VSS.n559 17.0005
R8404 VSS.n2300 VSS.n559 17.0005
R8405 VSS.n2392 VSS.n559 17.0005
R8406 VSS.n2391 VSS.n559 17.0005
R8407 VSS.n2315 VSS.n559 17.0005
R8408 VSS.n2321 VSS.n559 17.0005
R8409 VSS.n2320 VSS.n559 17.0005
R8410 VSS.n2324 VSS.n559 17.0005
R8411 VSS.n2323 VSS.n559 17.0005
R8412 VSS.n2327 VSS.n559 17.0005
R8413 VSS.n2326 VSS.n559 17.0005
R8414 VSS.n2388 VSS.n559 17.0005
R8415 VSS.n2387 VSS.n559 17.0005
R8416 VSS.n2385 VSS.n559 17.0005
R8417 VSS.t300 VSS.n559 17.0005
R8418 VSS.n2382 VSS.n559 17.0005
R8419 VSS.n2380 VSS.n559 17.0005
R8420 VSS.n2378 VSS.n559 17.0005
R8421 VSS.n2376 VSS.n559 17.0005
R8422 VSS.n2374 VSS.n559 17.0005
R8423 VSS.n2372 VSS.n559 17.0005
R8424 VSS.n2370 VSS.n559 17.0005
R8425 VSS.n2368 VSS.n559 17.0005
R8426 VSS.n2366 VSS.n559 17.0005
R8427 VSS.n2364 VSS.n559 17.0005
R8428 VSS.n2362 VSS.n559 17.0005
R8429 VSS.n2360 VSS.n559 17.0005
R8430 VSS.n2358 VSS.n559 17.0005
R8431 VSS.n2356 VSS.n559 17.0005
R8432 VSS.n2354 VSS.n559 17.0005
R8433 VSS.n2352 VSS.n559 17.0005
R8434 VSS.n2350 VSS.n559 17.0005
R8435 VSS.n2348 VSS.n559 17.0005
R8436 VSS.n2346 VSS.n559 17.0005
R8437 VSS.n2344 VSS.n559 17.0005
R8438 VSS.n2342 VSS.n559 17.0005
R8439 VSS.n2340 VSS.n559 17.0005
R8440 VSS.n2338 VSS.n559 17.0005
R8441 VSS.n2336 VSS.n559 17.0005
R8442 VSS.n2334 VSS.n559 17.0005
R8443 VSS.n2332 VSS.n559 17.0005
R8444 VSS.n2330 VSS.n559 17.0005
R8445 VSS.n2332 VSS.n442 17.0005
R8446 VSS.n2334 VSS.n442 17.0005
R8447 VSS.n2336 VSS.n442 17.0005
R8448 VSS.n2338 VSS.n442 17.0005
R8449 VSS.n2340 VSS.n442 17.0005
R8450 VSS.n2342 VSS.n442 17.0005
R8451 VSS.n2344 VSS.n442 17.0005
R8452 VSS.n2346 VSS.n442 17.0005
R8453 VSS.n2348 VSS.n442 17.0005
R8454 VSS.n2350 VSS.n442 17.0005
R8455 VSS.n2352 VSS.n442 17.0005
R8456 VSS.n2354 VSS.n442 17.0005
R8457 VSS.n2356 VSS.n442 17.0005
R8458 VSS.n2358 VSS.n442 17.0005
R8459 VSS.n2360 VSS.n442 17.0005
R8460 VSS.n2362 VSS.n442 17.0005
R8461 VSS.n2364 VSS.n442 17.0005
R8462 VSS.n2366 VSS.n442 17.0005
R8463 VSS.n2368 VSS.n442 17.0005
R8464 VSS.n2370 VSS.n442 17.0005
R8465 VSS.n2372 VSS.n442 17.0005
R8466 VSS.n2374 VSS.n442 17.0005
R8467 VSS.n2376 VSS.n442 17.0005
R8468 VSS.n2378 VSS.n442 17.0005
R8469 VSS.n2380 VSS.n442 17.0005
R8470 VSS.n2382 VSS.n442 17.0005
R8471 VSS.t300 VSS.n442 17.0005
R8472 VSS.n2385 VSS.n442 17.0005
R8473 VSS.n2387 VSS.n442 17.0005
R8474 VSS.n2388 VSS.n442 17.0005
R8475 VSS.n2326 VSS.n442 17.0005
R8476 VSS.n2327 VSS.n442 17.0005
R8477 VSS.n2323 VSS.n442 17.0005
R8478 VSS.n2324 VSS.n442 17.0005
R8479 VSS.n2320 VSS.n442 17.0005
R8480 VSS.n2321 VSS.n442 17.0005
R8481 VSS.n2315 VSS.n442 17.0005
R8482 VSS.n2391 VSS.n442 17.0005
R8483 VSS.n2392 VSS.n442 17.0005
R8484 VSS.n2300 VSS.n442 17.0005
R8485 VSS.n2313 VSS.n442 17.0005
R8486 VSS.n2311 VSS.n442 17.0005
R8487 VSS.n2309 VSS.n442 17.0005
R8488 VSS.n2307 VSS.n442 17.0005
R8489 VSS.n2305 VSS.n442 17.0005
R8490 VSS.n2303 VSS.n442 17.0005
R8491 VSS.n2301 VSS.n442 17.0005
R8492 VSS.n2292 VSS.n442 17.0005
R8493 VSS.n2294 VSS.n442 17.0005
R8494 VSS.n2296 VSS.n442 17.0005
R8495 VSS.n2394 VSS.n442 17.0005
R8496 VSS.n2396 VSS.n442 17.0005
R8497 VSS.n2398 VSS.n442 17.0005
R8498 VSS.n2400 VSS.n442 17.0005
R8499 VSS.n2402 VSS.n442 17.0005
R8500 VSS.n2404 VSS.n442 17.0005
R8501 VSS.n2406 VSS.n442 17.0005
R8502 VSS.n2408 VSS.n442 17.0005
R8503 VSS.n2410 VSS.n442 17.0005
R8504 VSS.n2412 VSS.n442 17.0005
R8505 VSS.n2414 VSS.n442 17.0005
R8506 VSS.n2416 VSS.n442 17.0005
R8507 VSS.n2774 VSS.n442 17.0005
R8508 VSS.n2417 VSS.n442 17.0005
R8509 VSS.n2419 VSS.n442 17.0005
R8510 VSS.n2420 VSS.n442 17.0005
R8511 VSS.n2422 VSS.n442 17.0005
R8512 VSS.t287 VSS.n442 17.0005
R8513 VSS.n2286 VSS.n442 17.0005
R8514 VSS.n2425 VSS.n442 17.0005
R8515 VSS.n2426 VSS.n442 17.0005
R8516 VSS.n2428 VSS.n442 17.0005
R8517 VSS.n2429 VSS.n442 17.0005
R8518 VSS.n2431 VSS.n442 17.0005
R8519 VSS.n2432 VSS.n442 17.0005
R8520 VSS.n2434 VSS.n442 17.0005
R8521 VSS.n2435 VSS.n442 17.0005
R8522 VSS.n2437 VSS.n442 17.0005
R8523 VSS.n2444 VSS.n442 17.0005
R8524 VSS.n2442 VSS.n442 17.0005
R8525 VSS.n2440 VSS.n442 17.0005
R8526 VSS.n2438 VSS.n442 17.0005
R8527 VSS.n2446 VSS.n442 17.0005
R8528 VSS.n2447 VSS.n442 17.0005
R8529 VSS.n2449 VSS.n442 17.0005
R8530 VSS.n2450 VSS.n442 17.0005
R8531 VSS.n2452 VSS.n442 17.0005
R8532 VSS.n2453 VSS.n442 17.0005
R8533 VSS.n2273 VSS.n442 17.0005
R8534 VSS.n2274 VSS.n442 17.0005
R8535 VSS.n2276 VSS.n442 17.0005
R8536 VSS.n2277 VSS.n442 17.0005
R8537 VSS.n2455 VSS.n442 17.0005
R8538 VSS.n2456 VSS.n442 17.0005
R8539 VSS.n2458 VSS.n442 17.0005
R8540 VSS.n2459 VSS.n442 17.0005
R8541 VSS.n2461 VSS.n442 17.0005
R8542 VSS.n2462 VSS.n442 17.0005
R8543 VSS.n2464 VSS.n442 17.0005
R8544 VSS.n2465 VSS.n442 17.0005
R8545 VSS.n2467 VSS.n442 17.0005
R8546 VSS.n2468 VSS.n442 17.0005
R8547 VSS.n2470 VSS.n442 17.0005
R8548 VSS.n2471 VSS.n442 17.0005
R8549 VSS.n2473 VSS.n442 17.0005
R8550 VSS.n2474 VSS.n442 17.0005
R8551 VSS.n2476 VSS.n442 17.0005
R8552 VSS.t275 VSS.n442 17.0005
R8553 VSS.n2261 VSS.n442 17.0005
R8554 VSS.n2479 VSS.n442 17.0005
R8555 VSS.n2480 VSS.n442 17.0005
R8556 VSS.n2482 VSS.n442 17.0005
R8557 VSS.n2483 VSS.n442 17.0005
R8558 VSS.n2485 VSS.n442 17.0005
R8559 VSS.n2486 VSS.n442 17.0005
R8560 VSS.n2488 VSS.n442 17.0005
R8561 VSS.n2489 VSS.n442 17.0005
R8562 VSS.n2491 VSS.n442 17.0005
R8563 VSS.n2498 VSS.n442 17.0005
R8564 VSS.n2496 VSS.n442 17.0005
R8565 VSS.n2494 VSS.n442 17.0005
R8566 VSS.n2492 VSS.n442 17.0005
R8567 VSS.n2500 VSS.n442 17.0005
R8568 VSS.n2501 VSS.n442 17.0005
R8569 VSS.n2503 VSS.n442 17.0005
R8570 VSS.n2504 VSS.n442 17.0005
R8571 VSS.n2506 VSS.n442 17.0005
R8572 VSS.n2507 VSS.n442 17.0005
R8573 VSS.n2248 VSS.n442 17.0005
R8574 VSS.n2249 VSS.n442 17.0005
R8575 VSS.n2251 VSS.n442 17.0005
R8576 VSS.n2252 VSS.n442 17.0005
R8577 VSS.n2509 VSS.n442 17.0005
R8578 VSS.n2510 VSS.n442 17.0005
R8579 VSS.n2512 VSS.n442 17.0005
R8580 VSS.n2513 VSS.n442 17.0005
R8581 VSS.n2515 VSS.n442 17.0005
R8582 VSS.n2516 VSS.n442 17.0005
R8583 VSS.n2518 VSS.n442 17.0005
R8584 VSS.n2519 VSS.n442 17.0005
R8585 VSS.n2521 VSS.n442 17.0005
R8586 VSS.n2522 VSS.n442 17.0005
R8587 VSS.n2524 VSS.n442 17.0005
R8588 VSS.n2525 VSS.n442 17.0005
R8589 VSS.n2527 VSS.n442 17.0005
R8590 VSS.n2528 VSS.n442 17.0005
R8591 VSS.n2530 VSS.n442 17.0005
R8592 VSS.n2531 VSS.n442 17.0005
R8593 VSS.n2535 VSS.n442 17.0005
R8594 VSS.n2536 VSS.n442 17.0005
R8595 VSS.n2538 VSS.n442 17.0005
R8596 VSS.n2539 VSS.n442 17.0005
R8597 VSS.n2541 VSS.n442 17.0005
R8598 VSS.n2542 VSS.n442 17.0005
R8599 VSS.n2544 VSS.n442 17.0005
R8600 VSS.n2545 VSS.n442 17.0005
R8601 VSS.n2547 VSS.n442 17.0005
R8602 VSS.n2548 VSS.n442 17.0005
R8603 VSS.n2231 VSS.n442 17.0005
R8604 VSS.n2231 VSS.n559 17.0005
R8605 VSS.n2548 VSS.n559 17.0005
R8606 VSS.n2547 VSS.n559 17.0005
R8607 VSS.n2545 VSS.n559 17.0005
R8608 VSS.n2544 VSS.n559 17.0005
R8609 VSS.n2542 VSS.n559 17.0005
R8610 VSS.n2541 VSS.n559 17.0005
R8611 VSS.n2539 VSS.n559 17.0005
R8612 VSS.n2538 VSS.n559 17.0005
R8613 VSS.n2536 VSS.n559 17.0005
R8614 VSS.n2535 VSS.n559 17.0005
R8615 VSS.n2531 VSS.n559 17.0005
R8616 VSS.n2530 VSS.n559 17.0005
R8617 VSS.n2528 VSS.n559 17.0005
R8618 VSS.n2527 VSS.n559 17.0005
R8619 VSS.n2525 VSS.n559 17.0005
R8620 VSS.n2524 VSS.n559 17.0005
R8621 VSS.n2522 VSS.n559 17.0005
R8622 VSS.n2521 VSS.n559 17.0005
R8623 VSS.n2519 VSS.n559 17.0005
R8624 VSS.n2518 VSS.n559 17.0005
R8625 VSS.n2516 VSS.n559 17.0005
R8626 VSS.n2515 VSS.n559 17.0005
R8627 VSS.n2513 VSS.n559 17.0005
R8628 VSS.n2512 VSS.n559 17.0005
R8629 VSS.n2510 VSS.n559 17.0005
R8630 VSS.n2509 VSS.n559 17.0005
R8631 VSS.n2252 VSS.n559 17.0005
R8632 VSS.n2251 VSS.n559 17.0005
R8633 VSS.n2249 VSS.n559 17.0005
R8634 VSS.n2248 VSS.n559 17.0005
R8635 VSS.n2507 VSS.n559 17.0005
R8636 VSS.n2506 VSS.n559 17.0005
R8637 VSS.n2504 VSS.n559 17.0005
R8638 VSS.n2503 VSS.n559 17.0005
R8639 VSS.n2501 VSS.n559 17.0005
R8640 VSS.n2500 VSS.n559 17.0005
R8641 VSS.n2492 VSS.n559 17.0005
R8642 VSS.n2494 VSS.n559 17.0005
R8643 VSS.n2496 VSS.n559 17.0005
R8644 VSS.n2498 VSS.n559 17.0005
R8645 VSS.n2491 VSS.n559 17.0005
R8646 VSS.n2489 VSS.n559 17.0005
R8647 VSS.n2488 VSS.n559 17.0005
R8648 VSS.n2486 VSS.n559 17.0005
R8649 VSS.n2485 VSS.n559 17.0005
R8650 VSS.n2483 VSS.n559 17.0005
R8651 VSS.n2482 VSS.n559 17.0005
R8652 VSS.n2480 VSS.n559 17.0005
R8653 VSS.n2479 VSS.n559 17.0005
R8654 VSS.n2261 VSS.n559 17.0005
R8655 VSS.t275 VSS.n559 17.0005
R8656 VSS.n2476 VSS.n559 17.0005
R8657 VSS.n2474 VSS.n559 17.0005
R8658 VSS.n2473 VSS.n559 17.0005
R8659 VSS.n2471 VSS.n559 17.0005
R8660 VSS.n2470 VSS.n559 17.0005
R8661 VSS.n2468 VSS.n559 17.0005
R8662 VSS.n2467 VSS.n559 17.0005
R8663 VSS.n2465 VSS.n559 17.0005
R8664 VSS.n2464 VSS.n559 17.0005
R8665 VSS.n2462 VSS.n559 17.0005
R8666 VSS.n2461 VSS.n559 17.0005
R8667 VSS.n2459 VSS.n559 17.0005
R8668 VSS.n2458 VSS.n559 17.0005
R8669 VSS.n2456 VSS.n559 17.0005
R8670 VSS.n2455 VSS.n559 17.0005
R8671 VSS.n2277 VSS.n559 17.0005
R8672 VSS.n2276 VSS.n559 17.0005
R8673 VSS.n2274 VSS.n559 17.0005
R8674 VSS.n2273 VSS.n559 17.0005
R8675 VSS.n2453 VSS.n559 17.0005
R8676 VSS.n2452 VSS.n559 17.0005
R8677 VSS.n2450 VSS.n559 17.0005
R8678 VSS.n2449 VSS.n559 17.0005
R8679 VSS.n2447 VSS.n559 17.0005
R8680 VSS.n2446 VSS.n559 17.0005
R8681 VSS.n2438 VSS.n559 17.0005
R8682 VSS.n2440 VSS.n559 17.0005
R8683 VSS.n2442 VSS.n559 17.0005
R8684 VSS.n2444 VSS.n559 17.0005
R8685 VSS.n2437 VSS.n559 17.0005
R8686 VSS.n2435 VSS.n559 17.0005
R8687 VSS.n2434 VSS.n559 17.0005
R8688 VSS.n2432 VSS.n559 17.0005
R8689 VSS.n2431 VSS.n559 17.0005
R8690 VSS.n2429 VSS.n559 17.0005
R8691 VSS.n2428 VSS.n559 17.0005
R8692 VSS.n2426 VSS.n559 17.0005
R8693 VSS.n2425 VSS.n559 17.0005
R8694 VSS.n2286 VSS.n559 17.0005
R8695 VSS.t287 VSS.n559 17.0005
R8696 VSS.n2417 VSS.n559 17.0005
R8697 VSS.n2419 VSS.n559 17.0005
R8698 VSS.n2420 VSS.n559 17.0005
R8699 VSS.n2422 VSS.n559 17.0005
R8700 VSS.n2604 VSS.n2603 17.0005
R8701 VSS.t542 VSS.n2230 17.0005
R8702 VSS.t542 VSS.n2178 17.0005
R8703 VSS.t542 VSS.n2229 17.0005
R8704 VSS.t542 VSS.n2179 17.0005
R8705 VSS.t542 VSS.n2228 17.0005
R8706 VSS.t542 VSS.n2180 17.0005
R8707 VSS.t542 VSS.n2227 17.0005
R8708 VSS.t542 VSS.n2181 17.0005
R8709 VSS.t542 VSS.n2226 17.0005
R8710 VSS.t542 VSS.n2182 17.0005
R8711 VSS.t542 VSS.n2225 17.0005
R8712 VSS.t542 VSS.n2183 17.0005
R8713 VSS.t542 VSS.n2224 17.0005
R8714 VSS.t542 VSS.n2184 17.0005
R8715 VSS.t542 VSS.n2223 17.0005
R8716 VSS.t542 VSS.n2185 17.0005
R8717 VSS.t542 VSS.n2222 17.0005
R8718 VSS.t542 VSS.n2186 17.0005
R8719 VSS.t542 VSS.n2221 17.0005
R8720 VSS.t542 VSS.n2187 17.0005
R8721 VSS.t542 VSS.n2220 17.0005
R8722 VSS.t542 VSS.n2188 17.0005
R8723 VSS.t542 VSS.n2219 17.0005
R8724 VSS.t542 VSS.n2189 17.0005
R8725 VSS.t542 VSS.n2218 17.0005
R8726 VSS.t542 VSS.n2190 17.0005
R8727 VSS.t542 VSS.n2217 17.0005
R8728 VSS.t542 VSS.n2191 17.0005
R8729 VSS.t542 VSS.n2216 17.0005
R8730 VSS.t542 VSS.n2192 17.0005
R8731 VSS.t542 VSS.n2215 17.0005
R8732 VSS.t542 VSS.n2193 17.0005
R8733 VSS.t542 VSS.n2214 17.0005
R8734 VSS.t542 VSS.n2194 17.0005
R8735 VSS.t542 VSS.n2213 17.0005
R8736 VSS.t542 VSS.n2195 17.0005
R8737 VSS.t542 VSS.n2212 17.0005
R8738 VSS.t542 VSS.n2196 17.0005
R8739 VSS.t542 VSS.n2211 17.0005
R8740 VSS.t542 VSS.n2210 17.0005
R8741 VSS.t542 VSS.n2209 17.0005
R8742 VSS.t542 VSS.n2208 17.0005
R8743 VSS.t542 VSS.n2207 17.0005
R8744 VSS.t542 VSS.n2206 17.0005
R8745 VSS.t542 VSS.n2205 17.0005
R8746 VSS.t542 VSS.n2204 17.0005
R8747 VSS.t542 VSS.n2203 17.0005
R8748 VSS.t542 VSS.n2202 17.0005
R8749 VSS.t542 VSS.n2201 17.0005
R8750 VSS.t542 VSS.n2200 17.0005
R8751 VSS.t542 VSS.n2199 17.0005
R8752 VSS.t542 VSS.n2198 17.0005
R8753 VSS.t542 VSS.n2197 17.0005
R8754 VSS.t529 VSS.n2745 17.0005
R8755 VSS.t529 VSS.n2124 17.0005
R8756 VSS.t529 VSS.n2125 17.0005
R8757 VSS.t529 VSS.n2133 17.0005
R8758 VSS.n2746 VSS.t529 17.0005
R8759 VSS.t529 VSS.n2131 17.0005
R8760 VSS.t529 VSS.n470 11.5048
R8761 VSS.t529 VSS.n2129 17.0005
R8762 VSS.t529 VSS.n2130 17.0005
R8763 VSS.n2118 VSS.n8 17.0005
R8764 VSS.n2108 VSS.n8 17.0005
R8765 VSS.n2765 VSS.n8 17.0005
R8766 VSS.n2111 VSS.n8 17.0005
R8767 VSS.n2114 VSS.n8 17.0005
R8768 VSS.n2756 VSS.n8 17.0005
R8769 VSS.n2757 VSS.n8 17.0005
R8770 VSS.n2692 VSS.n545 17.0005
R8771 VSS.n545 VSS.n2615 17.0005
R8772 VSS.n545 VSS.n2663 17.0005
R8773 VSS.n545 VSS.n2616 17.0005
R8774 VSS.n545 VSS.n2662 17.0005
R8775 VSS.n545 VSS.n2617 17.0005
R8776 VSS.n545 VSS.n2660 17.0005
R8777 VSS.n545 VSS.n539 17.0005
R8778 VSS.n545 VSS.n2659 17.0005
R8779 VSS.n545 VSS.n2618 17.0005
R8780 VSS.n545 VSS.n2657 17.0005
R8781 VSS.n545 VSS.n2619 17.0005
R8782 VSS.n545 VSS.n2655 17.0005
R8783 VSS.n545 VSS.n2620 17.0005
R8784 VSS.n545 VSS.n2654 17.0005
R8785 VSS.n545 VSS.n2621 17.0005
R8786 VSS.n545 VSS.n543 17.0005
R8787 VSS.n545 VSS.n2623 17.0005
R8788 VSS.n545 VSS.n2652 17.0005
R8789 VSS.n545 VSS.n2624 17.0005
R8790 VSS.n545 VSS.n2650 17.0005
R8791 VSS.n545 VSS.n2625 17.0005
R8792 VSS.n545 VSS.n2649 17.0005
R8793 VSS.n545 VSS.n2626 17.0005
R8794 VSS.n545 VSS.n2647 17.0005
R8795 VSS.n545 VSS.n540 17.0005
R8796 VSS.n545 VSS.n2646 17.0005
R8797 VSS.n545 VSS.n2627 17.0005
R8798 VSS.n545 VSS.n2644 17.0005
R8799 VSS.n545 VSS.n2628 17.0005
R8800 VSS.n545 VSS.n2642 17.0005
R8801 VSS.n545 VSS.n2629 17.0005
R8802 VSS.n545 VSS.n2641 17.0005
R8803 VSS.n545 VSS.n2630 17.0005
R8804 VSS.n545 VSS.n2639 17.0005
R8805 VSS.n545 VSS.n2631 17.0005
R8806 VSS.n545 VSS.n2638 17.0005
R8807 VSS.n545 VSS.n2633 17.0005
R8808 VSS.n545 VSS.n542 17.0005
R8809 VSS.n545 VSS.n2634 17.0005
R8810 VSS.n545 VSS.n2636 17.0005
R8811 VSS.n546 VSS.n519 12.4712
R8812 VSS.n2663 VSS.n529 17.0005
R8813 VSS.n2616 VSS.n529 17.0005
R8814 VSS.n2660 VSS.n529 17.0005
R8815 VSS.n2619 VSS.n529 17.0005
R8816 VSS.n2655 VSS.n529 17.0005
R8817 VSS.n2621 VSS.n529 17.0005
R8818 VSS.n2650 VSS.n529 17.0005
R8819 VSS.n2625 VSS.n529 17.0005
R8820 VSS.n2647 VSS.n529 17.0005
R8821 VSS.n2736 VSS.n529 17.0005
R8822 VSS.n2628 VSS.n529 17.0005
R8823 VSS.n2642 VSS.n529 17.0005
R8824 VSS.n2630 VSS.n529 17.0005
R8825 VSS.n2639 VSS.n529 17.0005
R8826 VSS.n504 VSS.n2692 17.0005
R8827 VSS.n504 VSS.n539 17.0005
R8828 VSS.n504 VSS.n543 17.0005
R8829 VSS.n504 VSS.n540 17.0005
R8830 VSS.n2707 VSS.n504 17.0005
R8831 VSS.n504 VSS.n542 17.0005
R8832 VSS.n504 VSS.n519 17.0005
R8833 VSS.n2137 VSS.n529 17.0005
R8834 VSS.n2700 VSS.n503 17.0005
R8835 VSS.n2634 VSS.n529 17.0005
R8836 VSS.n2740 VSS.n529 17.0005
R8837 VSS.n545 VSS.n541 17.0005
R8838 VSS.n2742 VSS.n529 17.0005
R8839 VSS.t2 VSS.n3007 17.0005
R8840 VSS.t2 VSS.n35 6.8105
R8841 VSS.t907 VSS.n2667 16.9164
R8842 VSS.t770 VSS.n2675 16.4551
R8843 VSS.n2655 VSS.t1206 16.4539
R8844 VSS.n582 VSS.n243 15.8474
R8845 VSS.t1637 VSS.n1046 15.7754
R8846 VSS.n2772 VSS.n281 15.4455
R8847 VSS.t758 VSS.n2516 15.4455
R8848 VSS.t277 VSS.n2264 15.4455
R8849 VSS.t878 VSS.n2462 15.4455
R8850 VSS.n2427 VSS.t1674 15.4455
R8851 VSS.t290 VSS.n2290 15.4455
R8852 VSS.n2406 VSS.t2274 15.4455
R8853 VSS.t301 VSS.n2377 15.4455
R8854 VSS.n2364 VSS.t1875 15.4455
R8855 VSS.n1906 VSS.n1897 14.9953
R8856 VSS.n2096 VSS.n1892 14.9953
R8857 VSS.n2089 VSS.n1885 14.9953
R8858 VSS.n2082 VSS.n1878 14.9953
R8859 VSS.n2075 VSS.n1869 14.9953
R8860 VSS.n2068 VSS.n1862 14.9953
R8861 VSS.n2061 VSS.n1855 14.9953
R8862 VSS.n2054 VSS.n1848 14.9953
R8863 VSS.n2047 VSS.n1841 14.9953
R8864 VSS.n2040 VSS.n1834 14.9953
R8865 VSS.n2033 VSS.n1827 14.9953
R8866 VSS.n2025 VSS.n1818 14.9953
R8867 VSS.n2018 VSS.n1811 14.9953
R8868 VSS.n2011 VSS.n1804 14.9953
R8869 VSS.n2004 VSS.n1797 14.9953
R8870 VSS.n1997 VSS.n1790 14.9953
R8871 VSS.n1990 VSS.n1783 14.9953
R8872 VSS.n1985 VSS.n1781 14.9953
R8873 VSS.n1983 VSS.n1784 14.9953
R8874 VSS.n1982 VSS.n1785 14.9953
R8875 VSS.n1981 VSS.n1787 14.9953
R8876 VSS.n1980 VSS.n1788 14.9953
R8877 VSS.n1978 VSS.n1791 14.9953
R8878 VSS.n1977 VSS.n1792 14.9953
R8879 VSS.n1976 VSS.n1793 14.9953
R8880 VSS.n1975 VSS.n1794 14.9953
R8881 VSS.n1973 VSS.n1798 14.9953
R8882 VSS.n1972 VSS.n1799 14.9953
R8883 VSS.n1971 VSS.n1800 14.9953
R8884 VSS.n1970 VSS.n1802 14.9953
R8885 VSS.n1968 VSS.n1805 14.9953
R8886 VSS.n1967 VSS.n1806 14.9953
R8887 VSS.n1966 VSS.n1807 14.9953
R8888 VSS.n1965 VSS.n1809 14.9953
R8889 VSS.n1963 VSS.n1812 14.9953
R8890 VSS.n1962 VSS.n1813 14.9953
R8891 VSS.n1961 VSS.n1814 14.9953
R8892 VSS.n1960 VSS.n1816 14.9953
R8893 VSS.n1958 VSS.n1819 14.9953
R8894 VSS.n1957 VSS.n1820 14.9953
R8895 VSS.n1956 VSS.n1822 14.9953
R8896 VSS.n1954 VSS.n1824 14.9953
R8897 VSS.n1952 VSS.n1828 14.9953
R8898 VSS.n1951 VSS.n1829 14.9953
R8899 VSS.n1950 VSS.n1830 14.9953
R8900 VSS.n1949 VSS.n1831 14.9953
R8901 VSS.n1947 VSS.n1835 14.9953
R8902 VSS.n1946 VSS.n1836 14.9953
R8903 VSS.n1945 VSS.n1837 14.9953
R8904 VSS.n1944 VSS.n1839 14.9953
R8905 VSS.n1942 VSS.n1842 14.9953
R8906 VSS.n1941 VSS.n1843 14.9953
R8907 VSS.n1940 VSS.n1845 14.9953
R8908 VSS.n1939 VSS.n1846 14.9953
R8909 VSS.n1937 VSS.n1849 14.9953
R8910 VSS.n1936 VSS.n1850 14.9953
R8911 VSS.n1935 VSS.n1851 14.9953
R8912 VSS.n1934 VSS.n1852 14.9953
R8913 VSS.n1932 VSS.n1856 14.9953
R8914 VSS.n1931 VSS.n1857 14.9953
R8915 VSS.n1930 VSS.n1858 14.9953
R8916 VSS.n1929 VSS.n1860 14.9953
R8917 VSS.n1927 VSS.n1863 14.9953
R8918 VSS.n1926 VSS.n1864 14.9953
R8919 VSS.n1925 VSS.n1866 14.9953
R8920 VSS.n1924 VSS.n1867 14.9953
R8921 VSS.n1922 VSS.n1870 14.9953
R8922 VSS.n1921 VSS.n1873 14.9953
R8923 VSS.n1920 VSS.n1874 14.9953
R8924 VSS.n1919 VSS.n1875 14.9953
R8925 VSS.n1917 VSS.n1879 14.9953
R8926 VSS.n1916 VSS.n1880 14.9953
R8927 VSS.n1915 VSS.n1881 14.9953
R8928 VSS.n1914 VSS.n1883 14.9953
R8929 VSS.n1912 VSS.n1886 14.9953
R8930 VSS.n1911 VSS.n1887 14.9953
R8931 VSS.n1910 VSS.n1889 14.9953
R8932 VSS.n1909 VSS.n1890 14.9953
R8933 VSS.n1907 VSS.n1893 14.9953
R8934 VSS.n2788 VSS.n1898 14.9953
R8935 VSS.n1988 VSS.n1781 14.9953
R8936 VSS.n1984 VSS.n1782 14.9953
R8937 VSS.n1991 VSS.n1784 14.9953
R8938 VSS.n1993 VSS.n1785 14.9953
R8939 VSS.n1994 VSS.n1787 14.9953
R8940 VSS.n1995 VSS.n1788 14.9953
R8941 VSS.n1979 VSS.n1789 14.9953
R8942 VSS.n1998 VSS.n1791 14.9953
R8943 VSS.n2000 VSS.n1792 14.9953
R8944 VSS.n2001 VSS.n1793 14.9953
R8945 VSS.n2002 VSS.n1794 14.9953
R8946 VSS.n1974 VSS.n1796 14.9953
R8947 VSS.n2005 VSS.n1798 14.9953
R8948 VSS.n2007 VSS.n1799 14.9953
R8949 VSS.n2008 VSS.n1800 14.9953
R8950 VSS.n2009 VSS.n1802 14.9953
R8951 VSS.n1969 VSS.n1803 14.9953
R8952 VSS.n2012 VSS.n1805 14.9953
R8953 VSS.n2014 VSS.n1806 14.9953
R8954 VSS.n2015 VSS.n1807 14.9953
R8955 VSS.n2016 VSS.n1809 14.9953
R8956 VSS.n1964 VSS.n1810 14.9953
R8957 VSS.n2019 VSS.n1812 14.9953
R8958 VSS.n2021 VSS.n1813 14.9953
R8959 VSS.n2022 VSS.n1814 14.9953
R8960 VSS.n2023 VSS.n1816 14.9953
R8961 VSS.n1959 VSS.n1817 14.9953
R8962 VSS.n2026 VSS.n1819 14.9953
R8963 VSS.n2029 VSS.n1820 14.9953
R8964 VSS.n2030 VSS.n1822 14.9953
R8965 VSS.n2031 VSS.n1824 14.9953
R8966 VSS.n1953 VSS.n1826 14.9953
R8967 VSS.n2034 VSS.n1828 14.9953
R8968 VSS.n2036 VSS.n1829 14.9953
R8969 VSS.n2037 VSS.n1830 14.9953
R8970 VSS.n2038 VSS.n1831 14.9953
R8971 VSS.n1948 VSS.n1833 14.9953
R8972 VSS.n2041 VSS.n1835 14.9953
R8973 VSS.n2043 VSS.n1836 14.9953
R8974 VSS.n2044 VSS.n1837 14.9953
R8975 VSS.n2045 VSS.n1839 14.9953
R8976 VSS.n1943 VSS.n1840 14.9953
R8977 VSS.n2048 VSS.n1842 14.9953
R8978 VSS.n2050 VSS.n1843 14.9953
R8979 VSS.n2051 VSS.n1845 14.9953
R8980 VSS.n2052 VSS.n1846 14.9953
R8981 VSS.n1938 VSS.n1847 14.9953
R8982 VSS.n2055 VSS.n1849 14.9953
R8983 VSS.n2057 VSS.n1850 14.9953
R8984 VSS.n2058 VSS.n1851 14.9953
R8985 VSS.n2059 VSS.n1852 14.9953
R8986 VSS.n1933 VSS.n1854 14.9953
R8987 VSS.n2062 VSS.n1856 14.9953
R8988 VSS.n2064 VSS.n1857 14.9953
R8989 VSS.n2065 VSS.n1858 14.9953
R8990 VSS.n2066 VSS.n1860 14.9953
R8991 VSS.n1928 VSS.n1861 14.9953
R8992 VSS.n2069 VSS.n1863 14.9953
R8993 VSS.n2071 VSS.n1864 14.9953
R8994 VSS.n2072 VSS.n1866 14.9953
R8995 VSS.n2073 VSS.n1867 14.9953
R8996 VSS.n1923 VSS.n1868 14.9953
R8997 VSS.n2076 VSS.n1870 14.9953
R8998 VSS.n2078 VSS.n1873 14.9953
R8999 VSS.n2079 VSS.n1874 14.9953
R9000 VSS.n2080 VSS.n1875 14.9953
R9001 VSS.n1918 VSS.n1877 14.9953
R9002 VSS.n2083 VSS.n1879 14.9953
R9003 VSS.n2085 VSS.n1880 14.9953
R9004 VSS.n2086 VSS.n1881 14.9953
R9005 VSS.n2087 VSS.n1883 14.9953
R9006 VSS.n1913 VSS.n1884 14.9953
R9007 VSS.n2090 VSS.n1886 14.9953
R9008 VSS.n2092 VSS.n1887 14.9953
R9009 VSS.n2093 VSS.n1889 14.9953
R9010 VSS.n2094 VSS.n1890 14.9953
R9011 VSS.n1908 VSS.n1891 14.9953
R9012 VSS.n2097 VSS.n1893 14.9953
R9013 VSS.n2098 VSS.n1895 14.9953
R9014 VSS.n1903 VSS.n1898 14.9953
R9015 VSS.n2683 VSS.t714 14.9842
R9016 VSS.t1522 VSS.n681 14.757
R9017 VSS.n1322 VSS.t500 14.757
R9018 VSS.t1938 VSS.n1399 14.757
R9019 VSS.t2296 VSS.n2630 14.2601
R9020 VSS.t942 VSS.n2186 13.954
R9021 VSS.t1401 VSS.n1387 13.7246
R9022 VSS.n1741 VSS.t2176 13.7147
R9023 VSS.t1562 VSS.t806 13.4836
R9024 VSS.t1133 VSS.n684 13.0461
R9025 VSS.n3015 VSS.n3014 13.0461
R9026 VSS.n1059 VSS.n1013 13.0461
R9027 VSS.n3011 VSS.n680 13.0461
R9028 VSS.n3010 VSS.n681 13.0461
R9029 VSS.n1061 VSS.n1006 13.0461
R9030 VSS.n1064 VSS.t1133 13.0461
R9031 VSS.n3008 VSS.n686 13.0461
R9032 VSS.n3014 VSS.n678 13.0461
R9033 VSS.n1060 VSS.n679 13.0461
R9034 VSS.n3013 VSS.n1011 13.0461
R9035 VSS.n3012 VSS.n1010 13.0461
R9036 VSS.n3011 VSS.n1009 13.0461
R9037 VSS.n3009 VSS.n1007 13.0461
R9038 VSS.n1061 VSS.n682 13.0461
R9039 VSS.n1062 VSS.n683 13.0461
R9040 VSS.n1064 VSS.n685 13.0461
R9041 VSS.n3008 VSS.n1005 13.0461
R9042 VSS.n1065 VSS.n688 13.0461
R9043 VSS.n1066 VSS.n689 13.0461
R9044 VSS.n1320 VSS.n1316 13.0461
R9045 VSS.n1326 VSS.t35 13.0461
R9046 VSS.n1332 VSS.n1075 13.0461
R9047 VSS.n2998 VSS.n1068 13.0461
R9048 VSS.n1340 VSS.n1069 13.0461
R9049 VSS.n1321 VSS.n1314 13.0461
R9050 VSS.n1322 VSS.n1313 13.0461
R9051 VSS.n1324 VSS.n1311 13.0461
R9052 VSS.n1334 VSS.n1072 13.0461
R9053 VSS.n1327 VSS.n1310 13.0461
R9054 VSS.n1328 VSS.n1309 13.0461
R9055 VSS.n1329 VSS.n1308 13.0461
R9056 VSS.n1318 VSS.n1068 13.0461
R9057 VSS.n1319 VSS.n1070 13.0461
R9058 VSS.n1338 VSS.n1315 13.0461
R9059 VSS.n1337 VSS.n1314 13.0461
R9060 VSS.n1336 VSS.n1312 13.0461
R9061 VSS.n1335 VSS.n1311 13.0461
R9062 VSS.n1325 VSS.n1072 13.0461
R9063 VSS.n1326 VSS.n1073 13.0461
R9064 VSS.t35 VSS.n1310 13.0461
R9065 VSS.n1333 VSS.n1309 13.0461
R9066 VSS.n1770 VSS.n1397 13.0461
R9067 VSS.n1764 VSS.n1409 13.0461
R9068 VSS.t22 VSS.n1402 13.0461
R9069 VSS.n1759 VSS.n1407 13.0461
R9070 VSS.n1395 VSS.n581 13.0461
R9071 VSS.n1771 VSS.n1396 13.0461
R9072 VSS.n1769 VSS.n1413 13.0461
R9073 VSS.n1768 VSS.n1412 13.0461
R9074 VSS.n1766 VSS.n1411 13.0461
R9075 VSS.n1765 VSS.n1401 13.0461
R9076 VSS.n1762 VSS.n1403 13.0461
R9077 VSS.n1761 VSS.n1408 13.0461
R9078 VSS.n1758 VSS.n1405 13.0461
R9079 VSS.n2796 VSS.n581 13.0461
R9080 VSS.n1772 VSS.n1415 13.0461
R9081 VSS.n1768 VSS.n1398 13.0461
R9082 VSS.n1767 VSS.n1399 13.0461
R9083 VSS.n1765 VSS.n1410 13.0461
R9084 VSS.n1762 VSS.t22 13.0461
R9085 VSS.n1761 VSS.n1404 13.0461
R9086 VSS.n2692 VSS.n2172 12.0761
R9087 VSS.n2661 VSS.n2617 12.0761
R9088 VSS.n2658 VSS.n539 12.0761
R9089 VSS.n2656 VSS.n2618 12.0761
R9090 VSS.n2654 VSS.n2653 12.0761
R9091 VSS.n2622 VSS.n543 12.0761
R9092 VSS.n2651 VSS.n2624 12.0761
R9093 VSS.n2649 VSS.n2648 12.0761
R9094 VSS.n2645 VSS.n540 12.0761
R9095 VSS.n2644 VSS.n2643 12.0761
R9096 VSS.n2640 VSS.n2629 12.0761
R9097 VSS.n2638 VSS.n2637 12.0761
R9098 VSS.n2615 VSS.n2171 12.0761
R9099 VSS.n2616 VSS.n2170 12.0761
R9100 VSS.n2617 VSS.n2169 12.0761
R9101 VSS.n2659 VSS.n2154 12.0761
R9102 VSS.n2657 VSS.n2155 12.0761
R9103 VSS.n2655 VSS.n2156 12.0761
R9104 VSS.n2654 VSS.n2157 12.0761
R9105 VSS.n2623 VSS.n2168 12.0761
R9106 VSS.n2624 VSS.n2167 12.0761
R9107 VSS.n2625 VSS.n2166 12.0761
R9108 VSS.n2626 VSS.n2165 12.0761
R9109 VSS.n2646 VSS.n2158 12.0761
R9110 VSS.n2644 VSS.n2159 12.0761
R9111 VSS.n2642 VSS.n2160 12.0761
R9112 VSS.n2641 VSS.n2161 12.0761
R9113 VSS.n2639 VSS.n2162 12.0761
R9114 VSS.n2638 VSS.n2163 12.0761
R9115 VSS.n2634 VSS.n2164 12.0761
R9116 VSS.n2632 VSS.n542 12.0761
R9117 VSS.n2635 VSS.n519 12.0761
R9118 VSS.n2615 VSS.n2172 12.0761
R9119 VSS.n2663 VSS.n2171 12.0761
R9120 VSS.n2662 VSS.n2170 12.0761
R9121 VSS.n2662 VSS.n2661 12.0761
R9122 VSS.n2660 VSS.n2169 12.0761
R9123 VSS.n2659 VSS.n2658 12.0761
R9124 VSS.n2618 VSS.n2154 12.0761
R9125 VSS.n2657 VSS.n2656 12.0761
R9126 VSS.n2619 VSS.n2155 12.0761
R9127 VSS.n2620 VSS.n2156 12.0761
R9128 VSS.n2653 VSS.n2620 12.0761
R9129 VSS.n2621 VSS.n2157 12.0761
R9130 VSS.n2623 VSS.n2622 12.0761
R9131 VSS.n2652 VSS.n2168 12.0761
R9132 VSS.n2652 VSS.n2651 12.0761
R9133 VSS.n2650 VSS.n2167 12.0761
R9134 VSS.n2649 VSS.n2166 12.0761
R9135 VSS.n2648 VSS.n2626 12.0761
R9136 VSS.n2647 VSS.n2165 12.0761
R9137 VSS.n2646 VSS.n2645 12.0761
R9138 VSS.n2627 VSS.n2158 12.0761
R9139 VSS.n2643 VSS.n2627 12.0761
R9140 VSS.n2628 VSS.n2159 12.0761
R9141 VSS.n2629 VSS.n2160 12.0761
R9142 VSS.n2641 VSS.n2640 12.0761
R9143 VSS.n2630 VSS.n2161 12.0761
R9144 VSS.n2631 VSS.n2162 12.0761
R9145 VSS.n2637 VSS.n2631 12.0761
R9146 VSS.n2633 VSS.n2163 12.0761
R9147 VSS.n2633 VSS.n2632 12.0761
R9148 VSS.n2636 VSS.n2164 12.0761
R9149 VSS.n2636 VSS.n2635 12.0761
R9150 VSS.t994 VSS.n2680 12.0423
R9151 VSS.n2606 VSS.n280 12.0423
R9152 VSS.t93 VSS.n682 11.8057
R9153 VSS.n1324 VSS.t545 11.8057
R9154 VSS.t2017 VSS.n1401 11.8057
R9155 VSS.n2500 VSS.t269 11.7681
R9156 VSS.t1672 VSS.n2274 11.7681
R9157 VSS.n2446 VSS.t281 11.7681
R9158 VSS.t294 VSS.n2311 11.7681
R9159 VSS.n2678 VSS.t713 10.5714
R9160 VSS.t927 VSS.n2214 10.4656
R9161 VSS.t902 VSS.t1623 10.4656
R9162 VSS.n2666 VSS.t1562 10.2971
R9163 VSS.n1991 VSS.t2140 10.0339
R9164 VSS.n1994 VSS.t2131 10.0339
R9165 VSS.n1998 VSS.t1965 10.0339
R9166 VSS.n2001 VSS.t1959 10.0339
R9167 VSS.n2005 VSS.t2144 10.0339
R9168 VSS.n2008 VSS.t1975 10.0339
R9169 VSS.n2012 VSS.t1926 10.0339
R9170 VSS.n2015 VSS.t1927 10.0339
R9171 VSS.n2019 VSS.t1980 10.0339
R9172 VSS.n2022 VSS.t1977 10.0339
R9173 VSS.n2026 VSS.t70 10.0339
R9174 VSS.n2030 VSS.t1990 10.0339
R9175 VSS.n2034 VSS.t1985 10.0339
R9176 VSS.n2037 VSS.t507 10.0339
R9177 VSS.n2041 VSS.t1993 10.0339
R9178 VSS.n2044 VSS.t969 10.0339
R9179 VSS.n2048 VSS.t2336 10.0339
R9180 VSS.n2051 VSS.t1428 10.0339
R9181 VSS.n2055 VSS.t840 10.0339
R9182 VSS.n2058 VSS.t1999 10.0339
R9183 VSS.n2062 VSS.t1429 10.0339
R9184 VSS.n2065 VSS.t1854 10.0339
R9185 VSS.n2069 VSS.t1174 10.0339
R9186 VSS.n2072 VSS.t1478 10.0339
R9187 VSS.n2076 VSS.t850 10.0339
R9188 VSS.n2079 VSS.t2203 10.0339
R9189 VSS.n2083 VSS.t1857 10.0339
R9190 VSS.n2086 VSS.t1856 10.0339
R9191 VSS.n2090 VSS.t2343 10.0339
R9192 VSS.n2093 VSS.t1370 10.0339
R9193 VSS.n2097 VSS.t2252 10.0339
R9194 VSS.n2535 VSS.t819 9.56167
R9195 VSS.n2134 VSS.t1187 9.5417
R9196 VSS.n2766 VSS.t32 9.08698
R9197 VSS.n2764 VSS.t32 9.0445
R9198 VSS.n2760 VSS.n2759 9.0005
R9199 VSS.n2760 VSS.n2123 9.0005
R9200 VSS.n2762 VSS.n2761 9.0005
R9201 VSS.n2761 VSS.n2121 9.0005
R9202 VSS.n1987 VSS.n244 8.501
R9203 VSS.n2787 VSS.n582 8.501
R9204 VSS.n25 VSS.n250 0.190755
R9205 VSS.n25 VSS.n251 2.75971
R9206 VSS.n252 VSS.n15 5.65265
R9207 VSS.n16 VSS.n253 1.79874
R9208 VSS.t244 VSS.n254 0.677932
R9209 VSS.t246 VSS.n255 0.148371
R9210 VSS.n256 VSS.t248 0.0238559
R9211 VSS.t250 VSS.n258 0.196247
R9212 VSS.n265 VSS.t255 0.678646
R9213 VSS.t257 VSS.n269 0.148371
R9214 VSS.n271 VSS.t260 0.0238559
R9215 VSS.t262 VSS.n272 0.159942
R9216 VSS.t940 VSS.n276 2.83417
R9217 VSS.n276 VSS.n275 0.00166658
R9218 VSS.n275 VSS.n245 0.00149997
R9219 VSS.t268 VSS.n282 0.963546
R9220 VSS.n285 VSS.t270 0.148371
R9221 VSS.n286 VSS.n283 5.65265
R9222 VSS.t276 VSS.n288 0.196418
R9223 VSS.t280 VSS.n290 0.678646
R9224 VSS.n292 VSS.t282 0.148371
R9225 VSS.n293 VSS.n247 5.65265
R9226 VSS.n294 VSS.t289 0.196418
R9227 VSS.n299 VSS.n301 0.24735
R9228 VSS.t297 VSS.n300 0.234097
R9229 VSS.t295 VSS.n297 0.0180497
R9230 VSS.n295 VSS.n248 2.76051
R9231 VSS.n32 VSS.n302 0.190755
R9232 VSS.n305 VSS.n306 2.75971
R9233 VSS.n307 VSS.n303 5.65265
R9234 VSS.n310 VSS.n311 1.79874
R9235 VSS.n312 VSS.n44 0.532543
R9236 VSS.n315 VSS.n316 2.75971
R9237 VSS.n317 VSS.n313 5.65265
R9238 VSS.n320 VSS.n321 1.79874
R9239 VSS.n322 VSS.n41 0.532543
R9240 VSS.n325 VSS.n326 2.75971
R9241 VSS.n327 VSS.n323 5.65265
R9242 VSS.n330 VSS.n331 2.05187
R9243 VSS.t150 VSS.n332 0.885338
R9244 VSS.n21 VSS.n333 2.75971
R9245 VSS.n334 VSS.n21 5.65265
R9246 VSS.n21 VSS.n335 1.79874
R9247 VSS.n336 VSS.n19 0.532543
R9248 VSS.n338 VSS.n339 2.75971
R9249 VSS.n340 VSS.n75 5.65265
R9250 VSS.n78 VSS.n341 1.79874
R9251 VSS.t462 VSS.n82 0.830968
R9252 VSS.n348 VSS.t460 0.234097
R9253 VSS.t458 VSS.n346 0.0180497
R9254 VSS.t455 VSS.n345 0.145945
R9255 VSS.t344 VSS.t331 0.831559
R9256 VSS.n584 VSS.t342 0.264361
R9257 VSS.t340 VSS.n583 0.145945
R9258 VSS.n4 VSS.t122 0.428406
R9259 VSS.n4 VSS.t224 0.469256
R9260 VSS.t222 VSS.n441 0.145945
R9261 VSS.n444 VSS.n2772 8.501
R9262 VSS.n2772 VSS.n552 1.41718
R9263 VSS.n552 VSS.n553 0.00287409
R9264 VSS.n553 VSS.n554 0.00170812
R9265 VSS.n554 VSS.n555 0.00166658
R9266 VSS.n2772 VSS.n557 2.12569
R9267 VSS.n557 VSS.n556 0.00170812
R9268 VSS.n556 VSS.n558 0.00166658
R9269 VSS.n2784 VSS.n560 1.14163
R9270 VSS.n2784 VSS.n561 2.12578
R9271 VSS.n561 VSS.n562 0.00274975
R9272 VSS.n2784 VSS.n564 1.70056
R9273 VSS.n564 VSS.n563 0.00172462
R9274 VSS.n563 VSS.n565 0.00170812
R9275 VSS.n565 VSS.n566 0.00166658
R9276 VSS.n2784 VSS.n567 4.251
R9277 VSS.n2784 VSS.n568 2.42956
R9278 VSS.n2784 VSS.n570 2.83428
R9279 VSS.n570 VSS.n461 0.00249992
R9280 VSS.n2784 VSS.n559 8.501
R9281 VSS.n2744 VSS.n518 3.40102
R9282 VSS.n2669 VSS.n535 3.40102
R9283 VSS.n473 VSS.n472 0.00203548
R9284 VSS.n2669 VSS.n536 2.83428
R9285 VSS.n536 VSS.n537 0.00158329
R9286 VSS.n477 VSS.n476 0.00203548
R9287 VSS.n2669 VSS.n538 3.40102
R9288 VSS.n484 VSS.n479 0.00187482
R9289 VSS.n2669 VSS.n484 2.12588
R9290 VSS.n531 VSS.n54 1.70056
R9291 VSS.n498 VSS.n531 0.00172462
R9292 VSS.n499 VSS.n54 2.42928
R9293 VSS.n495 VSS.n54 3.40102
R9294 VSS.n54 VSS.n532 3.40102
R9295 VSS.n54 VSS.n534 2.4296
R9296 VSS.n508 VSS.n516 0.00174985
R9297 VSS.n2716 VSS.n516 2.12588
R9298 VSS.n2716 VSS.n547 1.88985
R9299 VSS.n550 VSS.n549 0.00216959
R9300 VSS.n2716 VSS.n511 1.88933
R9301 VSS.n2716 VSS.n506 1.70038
R9302 VSS.n530 VSS.n529 0.00131813
R9303 VSS.n2744 VSS.n520 3.40102
R9304 VSS.n546 VSS.n545 1.51099
R9305 VSS.t393 VSS.t2 0.831118
R9306 VSS.t388 VSS.n586 0.263721
R9307 VSS.t385 VSS.n585 0.145945
R9308 VSS.n582 VSS.n1752 8.5005
R9309 VSS.n582 VSS.n1755 8.5005
R9310 VSS.n775 VSS.n998 8.5005
R9311 VSS.n775 VSS.n996 8.5005
R9312 VSS.n775 VSS.n994 8.5005
R9313 VSS.n775 VSS.n993 8.5005
R9314 VSS.n775 VSS.n991 8.5005
R9315 VSS.n775 VSS.n990 8.5005
R9316 VSS.n775 VSS.n988 8.5005
R9317 VSS.n775 VSS.n987 8.5005
R9318 VSS.n775 VSS.n986 8.5005
R9319 VSS.n775 VSS.n985 8.5005
R9320 VSS.n775 VSS.n984 8.5005
R9321 VSS.n775 VSS.n982 8.5005
R9322 VSS.n775 VSS.n981 8.5005
R9323 VSS.n775 VSS.n979 8.5005
R9324 VSS.n775 VSS.n978 8.5005
R9325 VSS.n775 VSS.n976 8.5005
R9326 VSS.n775 VSS.n975 8.5005
R9327 VSS.n775 VSS.n974 8.5005
R9328 VSS.n775 VSS.n973 8.5005
R9329 VSS.n775 VSS.n971 8.5005
R9330 VSS.n775 VSS.n969 8.5005
R9331 VSS.n775 VSS.n967 8.5005
R9332 VSS.n775 VSS.n965 8.5005
R9333 VSS.n775 VSS.n964 8.5005
R9334 VSS.n775 VSS.n962 8.5005
R9335 VSS.n775 VSS.n961 8.5005
R9336 VSS.n775 VSS.n960 8.5005
R9337 VSS.n775 VSS.n959 8.5005
R9338 VSS.n775 VSS.n957 8.5005
R9339 VSS.n775 VSS.n956 8.5005
R9340 VSS.n775 VSS.n954 8.5005
R9341 VSS.n775 VSS.n952 8.5005
R9342 VSS.n775 VSS.n951 8.5005
R9343 VSS.n775 VSS.n949 8.5005
R9344 VSS.n775 VSS.n948 8.5005
R9345 VSS.n775 VSS.n947 8.5005
R9346 VSS.n775 VSS.n946 8.5005
R9347 VSS.n775 VSS.n945 8.5005
R9348 VSS.n775 VSS.n943 8.5005
R9349 VSS.n775 VSS.n942 8.5005
R9350 VSS.n775 VSS.n940 8.5005
R9351 VSS.n775 VSS.n939 8.5005
R9352 VSS.n775 VSS.n937 8.5005
R9353 VSS.n775 VSS.n936 8.5005
R9354 VSS.n775 VSS.n935 8.5005
R9355 VSS.n775 VSS.n934 8.5005
R9356 VSS.n775 VSS.n932 8.5005
R9357 VSS.n775 VSS.n930 8.5005
R9358 VSS.n775 VSS.n928 8.5005
R9359 VSS.n775 VSS.n926 8.5005
R9360 VSS.n775 VSS.n925 8.5005
R9361 VSS.n775 VSS.n923 8.5005
R9362 VSS.n775 VSS.n922 8.5005
R9363 VSS.n775 VSS.n921 8.5005
R9364 VSS.n775 VSS.n920 8.5005
R9365 VSS.n775 VSS.n917 8.5005
R9366 VSS.n775 VSS.n915 8.5005
R9367 VSS.n775 VSS.n914 8.5005
R9368 VSS.n775 VSS.n912 8.5005
R9369 VSS.n775 VSS.n911 8.5005
R9370 VSS.n775 VSS.n909 8.5005
R9371 VSS.n775 VSS.n908 8.5005
R9372 VSS.n775 VSS.n907 8.5005
R9373 VSS.n775 VSS.n906 8.5005
R9374 VSS.n775 VSS.n905 8.5005
R9375 VSS.n775 VSS.n903 8.5005
R9376 VSS.n775 VSS.n902 8.5005
R9377 VSS.n775 VSS.n899 8.5005
R9378 VSS.n775 VSS.n898 8.5005
R9379 VSS.n775 VSS.n896 8.5005
R9380 VSS.n775 VSS.n895 8.5005
R9381 VSS.n775 VSS.n894 8.5005
R9382 VSS.n775 VSS.n893 8.5005
R9383 VSS.n775 VSS.n890 8.5005
R9384 VSS.n775 VSS.n888 8.5005
R9385 VSS.n775 VSS.n887 8.5005
R9386 VSS.n775 VSS.n884 8.5005
R9387 VSS.n775 VSS.n883 8.5005
R9388 VSS.n775 VSS.n881 8.5005
R9389 VSS.n775 VSS.n880 8.5005
R9390 VSS.n775 VSS.n879 8.5005
R9391 VSS.n775 VSS.n878 8.5005
R9392 VSS.n775 VSS.n876 8.5005
R9393 VSS.n775 VSS.n874 8.5005
R9394 VSS.n775 VSS.n873 8.5005
R9395 VSS.n775 VSS.n871 8.5005
R9396 VSS.n775 VSS.n870 8.5005
R9397 VSS.n775 VSS.n868 8.5005
R9398 VSS.n775 VSS.n867 8.5005
R9399 VSS.n775 VSS.n866 8.5005
R9400 VSS.n775 VSS.n865 8.5005
R9401 VSS.n775 VSS.n863 8.5005
R9402 VSS.n775 VSS.n861 8.5005
R9403 VSS.n775 VSS.n860 8.5005
R9404 VSS.n775 VSS.n857 8.5005
R9405 VSS.n775 VSS.n856 8.5005
R9406 VSS.n775 VSS.n854 8.5005
R9407 VSS.n775 VSS.n853 8.5005
R9408 VSS.n775 VSS.n852 8.5005
R9409 VSS.n775 VSS.n851 8.5005
R9410 VSS.n775 VSS.n849 8.5005
R9411 VSS.n775 VSS.n847 8.5005
R9412 VSS.n775 VSS.n846 8.5005
R9413 VSS.n775 VSS.n844 8.5005
R9414 VSS.n775 VSS.n843 8.5005
R9415 VSS.n775 VSS.n841 8.5005
R9416 VSS.n775 VSS.n840 8.5005
R9417 VSS.n775 VSS.n839 8.5005
R9418 VSS.n775 VSS.n838 8.5005
R9419 VSS.n775 VSS.n836 8.5005
R9420 VSS.n775 VSS.n834 8.5005
R9421 VSS.n775 VSS.n833 8.5005
R9422 VSS.n775 VSS.n829 8.5005
R9423 VSS.n775 VSS.n826 8.5005
R9424 VSS.n775 VSS.n825 8.5005
R9425 VSS.n775 VSS.n824 8.5005
R9426 VSS.n775 VSS.n823 8.5005
R9427 VSS.n775 VSS.n822 8.5005
R9428 VSS.n775 VSS.n819 8.5005
R9429 VSS.n775 VSS.n817 8.5005
R9430 VSS.n775 VSS.n816 8.5005
R9431 VSS.n775 VSS.n813 8.5005
R9432 VSS.n775 VSS.n812 8.5005
R9433 VSS.n775 VSS.n810 8.5005
R9434 VSS.n775 VSS.n809 8.5005
R9435 VSS.n775 VSS.n808 8.5005
R9436 VSS.n775 VSS.n807 8.5005
R9437 VSS.n775 VSS.n805 8.5005
R9438 VSS.n775 VSS.n803 8.5005
R9439 VSS.n775 VSS.n802 8.5005
R9440 VSS.n775 VSS.n800 8.5005
R9441 VSS.n775 VSS.n799 8.5005
R9442 VSS.n775 VSS.n797 8.5005
R9443 VSS.n775 VSS.n796 8.5005
R9444 VSS.n775 VSS.n795 8.5005
R9445 VSS.n775 VSS.n794 8.5005
R9446 VSS.n775 VSS.n792 8.5005
R9447 VSS.n775 VSS.n790 8.5005
R9448 VSS.n775 VSS.n789 8.5005
R9449 VSS.n775 VSS.n786 8.5005
R9450 VSS.n775 VSS.n785 8.5005
R9451 VSS.n775 VSS.n783 8.5005
R9452 VSS.n775 VSS.n782 8.5005
R9453 VSS.n775 VSS.n781 8.5005
R9454 VSS.n775 VSS.n780 8.5005
R9455 VSS.n589 VSS.n1119 8.5005
R9456 VSS.n589 VSS.n1120 8.5005
R9457 VSS.n589 VSS.n1303 8.5005
R9458 VSS.n589 VSS.n1124 8.5005
R9459 VSS.n589 VSS.n1125 8.5005
R9460 VSS.n589 VSS.n1302 8.5005
R9461 VSS.n589 VSS.n1126 8.5005
R9462 VSS.n589 VSS.n1301 8.5005
R9463 VSS.n589 VSS.n1127 8.5005
R9464 VSS.n589 VSS.n1300 8.5005
R9465 VSS.n589 VSS.n1128 8.5005
R9466 VSS.n589 VSS.n1299 8.5005
R9467 VSS.n589 VSS.n1131 8.5005
R9468 VSS.n589 VSS.n1132 8.5005
R9469 VSS.n589 VSS.n1298 8.5005
R9470 VSS.n589 VSS.n1133 8.5005
R9471 VSS.n589 VSS.n1297 8.5005
R9472 VSS.n589 VSS.n1134 8.5005
R9473 VSS.n589 VSS.n1296 8.5005
R9474 VSS.n589 VSS.n1135 8.5005
R9475 VSS.n589 VSS.n1295 8.5005
R9476 VSS.n589 VSS.n1138 8.5005
R9477 VSS.n589 VSS.n1139 8.5005
R9478 VSS.n589 VSS.n1294 8.5005
R9479 VSS.n589 VSS.n1140 8.5005
R9480 VSS.n589 VSS.n1293 8.5005
R9481 VSS.n589 VSS.n1141 8.5005
R9482 VSS.n589 VSS.n1292 8.5005
R9483 VSS.n589 VSS.n1142 8.5005
R9484 VSS.n589 VSS.n1291 8.5005
R9485 VSS.n589 VSS.n1145 8.5005
R9486 VSS.n589 VSS.n1146 8.5005
R9487 VSS.n589 VSS.n1290 8.5005
R9488 VSS.n589 VSS.n1147 8.5005
R9489 VSS.n589 VSS.n1289 8.5005
R9490 VSS.n589 VSS.n1148 8.5005
R9491 VSS.n589 VSS.n1288 8.5005
R9492 VSS.n589 VSS.n1149 8.5005
R9493 VSS.n589 VSS.n1287 8.5005
R9494 VSS.n589 VSS.n1152 8.5005
R9495 VSS.n589 VSS.n1153 8.5005
R9496 VSS.n589 VSS.n1286 8.5005
R9497 VSS.n589 VSS.n1154 8.5005
R9498 VSS.n589 VSS.n1285 8.5005
R9499 VSS.n589 VSS.n1155 8.5005
R9500 VSS.n589 VSS.n1284 8.5005
R9501 VSS.n589 VSS.n1156 8.5005
R9502 VSS.n589 VSS.n1283 8.5005
R9503 VSS.n589 VSS.n1159 8.5005
R9504 VSS.n589 VSS.n1160 8.5005
R9505 VSS.n589 VSS.n1282 8.5005
R9506 VSS.n589 VSS.n1161 8.5005
R9507 VSS.n589 VSS.n1281 8.5005
R9508 VSS.n589 VSS.n1162 8.5005
R9509 VSS.n589 VSS.n1280 8.5005
R9510 VSS.n589 VSS.n1163 8.5005
R9511 VSS.n589 VSS.n1278 8.5005
R9512 VSS.n589 VSS.n1166 8.5005
R9513 VSS.n589 VSS.n1167 8.5005
R9514 VSS.n589 VSS.n1277 8.5005
R9515 VSS.n589 VSS.n1168 8.5005
R9516 VSS.n589 VSS.n1276 8.5005
R9517 VSS.n589 VSS.n1169 8.5005
R9518 VSS.n589 VSS.n1275 8.5005
R9519 VSS.n589 VSS.n1170 8.5005
R9520 VSS.n589 VSS.n1274 8.5005
R9521 VSS.n589 VSS.n1173 8.5005
R9522 VSS.n589 VSS.n1174 8.5005
R9523 VSS.n589 VSS.n1273 8.5005
R9524 VSS.n589 VSS.n1175 8.5005
R9525 VSS.n589 VSS.n1272 8.5005
R9526 VSS.n589 VSS.n1176 8.5005
R9527 VSS.n589 VSS.n1271 8.5005
R9528 VSS.n589 VSS.n1177 8.5005
R9529 VSS.n589 VSS.n1270 8.5005
R9530 VSS.n589 VSS.n1180 8.5005
R9531 VSS.n589 VSS.n1181 8.5005
R9532 VSS.n589 VSS.n1269 8.5005
R9533 VSS.n589 VSS.n1182 8.5005
R9534 VSS.n589 VSS.n1268 8.5005
R9535 VSS.n589 VSS.n1183 8.5005
R9536 VSS.n589 VSS.n1267 8.5005
R9537 VSS.n589 VSS.n1184 8.5005
R9538 VSS.n589 VSS.n1266 8.5005
R9539 VSS.n589 VSS.n1187 8.5005
R9540 VSS.n589 VSS.n1188 8.5005
R9541 VSS.n589 VSS.n1265 8.5005
R9542 VSS.n589 VSS.n1189 8.5005
R9543 VSS.n589 VSS.n1264 8.5005
R9544 VSS.n589 VSS.n1190 8.5005
R9545 VSS.n589 VSS.n1263 8.5005
R9546 VSS.n589 VSS.n1191 8.5005
R9547 VSS.n589 VSS.n1262 8.5005
R9548 VSS.n589 VSS.n1194 8.5005
R9549 VSS.n589 VSS.n1195 8.5005
R9550 VSS.n589 VSS.n1261 8.5005
R9551 VSS.n589 VSS.n1196 8.5005
R9552 VSS.n589 VSS.n1260 8.5005
R9553 VSS.n589 VSS.n1197 8.5005
R9554 VSS.n589 VSS.n1259 8.5005
R9555 VSS.n589 VSS.n1198 8.5005
R9556 VSS.n589 VSS.n1258 8.5005
R9557 VSS.n589 VSS.n1201 8.5005
R9558 VSS.n589 VSS.n1202 8.5005
R9559 VSS.n589 VSS.n1257 8.5005
R9560 VSS.n589 VSS.n1203 8.5005
R9561 VSS.n589 VSS.n1256 8.5005
R9562 VSS.n589 VSS.n1204 8.5005
R9563 VSS.n589 VSS.n1255 8.5005
R9564 VSS.n589 VSS.n1205 8.5005
R9565 VSS.n589 VSS.n1254 8.5005
R9566 VSS.n589 VSS.n1209 8.5005
R9567 VSS.n589 VSS.n1210 8.5005
R9568 VSS.n589 VSS.n1253 8.5005
R9569 VSS.n589 VSS.n1212 8.5005
R9570 VSS.n589 VSS.n1252 8.5005
R9571 VSS.n589 VSS.n1213 8.5005
R9572 VSS.n589 VSS.n1251 8.5005
R9573 VSS.n589 VSS.n1214 8.5005
R9574 VSS.n589 VSS.n1250 8.5005
R9575 VSS.n589 VSS.n1217 8.5005
R9576 VSS.n589 VSS.n1218 8.5005
R9577 VSS.n589 VSS.n1249 8.5005
R9578 VSS.n589 VSS.n1219 8.5005
R9579 VSS.n589 VSS.n1248 8.5005
R9580 VSS.n589 VSS.n1220 8.5005
R9581 VSS.n589 VSS.n1247 8.5005
R9582 VSS.n589 VSS.n1221 8.5005
R9583 VSS.n589 VSS.n1246 8.5005
R9584 VSS.n589 VSS.n1224 8.5005
R9585 VSS.n589 VSS.n1225 8.5005
R9586 VSS.n589 VSS.n1245 8.5005
R9587 VSS.n589 VSS.n1226 8.5005
R9588 VSS.n589 VSS.n1244 8.5005
R9589 VSS.n589 VSS.n1227 8.5005
R9590 VSS.n589 VSS.n1243 8.5005
R9591 VSS.n589 VSS.n1228 8.5005
R9592 VSS.n589 VSS.n1242 8.5005
R9593 VSS.n589 VSS.n1231 8.5005
R9594 VSS.n589 VSS.n1232 8.5005
R9595 VSS.n589 VSS.n1241 8.5005
R9596 VSS.n589 VSS.n1233 8.5005
R9597 VSS.n589 VSS.n1240 8.5005
R9598 VSS.n589 VSS.n1234 8.5005
R9599 VSS.n589 VSS.n1239 8.5005
R9600 VSS.n589 VSS.n1237 8.5005
R9601 VSS.n439 VSS.n2802 8.5005
R9602 VSS.n439 VSS.n2803 8.5005
R9603 VSS.n439 VSS.n2991 8.5005
R9604 VSS.n439 VSS.n2807 8.5005
R9605 VSS.n439 VSS.n2808 8.5005
R9606 VSS.n439 VSS.n2990 8.5005
R9607 VSS.n439 VSS.n2809 8.5005
R9608 VSS.n439 VSS.n2989 8.5005
R9609 VSS.n439 VSS.n2810 8.5005
R9610 VSS.n439 VSS.n2988 8.5005
R9611 VSS.n439 VSS.n2811 8.5005
R9612 VSS.n439 VSS.n2987 8.5005
R9613 VSS.n439 VSS.n2814 8.5005
R9614 VSS.n439 VSS.n2815 8.5005
R9615 VSS.n439 VSS.n2986 8.5005
R9616 VSS.n439 VSS.n2816 8.5005
R9617 VSS.n439 VSS.n2985 8.5005
R9618 VSS.n439 VSS.n2817 8.5005
R9619 VSS.n439 VSS.n2984 8.5005
R9620 VSS.n439 VSS.n2818 8.5005
R9621 VSS.n439 VSS.n2983 8.5005
R9622 VSS.n439 VSS.n2821 8.5005
R9623 VSS.n439 VSS.n2822 8.5005
R9624 VSS.n439 VSS.n2982 8.5005
R9625 VSS.n439 VSS.n2823 8.5005
R9626 VSS.n439 VSS.n2981 8.5005
R9627 VSS.n439 VSS.n2824 8.5005
R9628 VSS.n439 VSS.n2980 8.5005
R9629 VSS.n439 VSS.n2825 8.5005
R9630 VSS.n439 VSS.n2979 8.5005
R9631 VSS.n439 VSS.n2828 8.5005
R9632 VSS.n439 VSS.n2829 8.5005
R9633 VSS.n439 VSS.n2978 8.5005
R9634 VSS.n439 VSS.n2830 8.5005
R9635 VSS.n439 VSS.n2977 8.5005
R9636 VSS.n439 VSS.n2831 8.5005
R9637 VSS.n439 VSS.n2976 8.5005
R9638 VSS.n439 VSS.n2832 8.5005
R9639 VSS.n439 VSS.n2975 8.5005
R9640 VSS.n439 VSS.n2835 8.5005
R9641 VSS.n439 VSS.n2836 8.5005
R9642 VSS.n439 VSS.n2974 8.5005
R9643 VSS.n439 VSS.n2837 8.5005
R9644 VSS.n439 VSS.n2973 8.5005
R9645 VSS.n439 VSS.n2838 8.5005
R9646 VSS.n439 VSS.n2972 8.5005
R9647 VSS.n439 VSS.n2839 8.5005
R9648 VSS.n439 VSS.n2971 8.5005
R9649 VSS.n439 VSS.n2842 8.5005
R9650 VSS.n439 VSS.n2843 8.5005
R9651 VSS.n439 VSS.n2970 8.5005
R9652 VSS.n439 VSS.n2844 8.5005
R9653 VSS.n439 VSS.n2969 8.5005
R9654 VSS.n439 VSS.n2845 8.5005
R9655 VSS.n439 VSS.n2968 8.5005
R9656 VSS.n439 VSS.n2846 8.5005
R9657 VSS.n439 VSS.n2966 8.5005
R9658 VSS.n439 VSS.n2849 8.5005
R9659 VSS.n439 VSS.n2850 8.5005
R9660 VSS.n439 VSS.n2965 8.5005
R9661 VSS.n439 VSS.n2851 8.5005
R9662 VSS.n439 VSS.n2964 8.5005
R9663 VSS.n439 VSS.n2852 8.5005
R9664 VSS.n439 VSS.n2963 8.5005
R9665 VSS.n439 VSS.n2853 8.5005
R9666 VSS.n439 VSS.n2962 8.5005
R9667 VSS.n439 VSS.n2856 8.5005
R9668 VSS.n439 VSS.n2857 8.5005
R9669 VSS.n439 VSS.n2961 8.5005
R9670 VSS.n439 VSS.n2858 8.5005
R9671 VSS.n439 VSS.n2960 8.5005
R9672 VSS.n439 VSS.n2859 8.5005
R9673 VSS.n439 VSS.n2959 8.5005
R9674 VSS.n439 VSS.n2860 8.5005
R9675 VSS.n439 VSS.n2958 8.5005
R9676 VSS.n439 VSS.n2863 8.5005
R9677 VSS.n439 VSS.n2864 8.5005
R9678 VSS.n439 VSS.n2957 8.5005
R9679 VSS.n439 VSS.n2865 8.5005
R9680 VSS.n439 VSS.n2956 8.5005
R9681 VSS.n439 VSS.n2866 8.5005
R9682 VSS.n439 VSS.n2955 8.5005
R9683 VSS.n439 VSS.n2867 8.5005
R9684 VSS.n439 VSS.n2954 8.5005
R9685 VSS.n439 VSS.n2870 8.5005
R9686 VSS.n439 VSS.n2871 8.5005
R9687 VSS.n439 VSS.n2953 8.5005
R9688 VSS.n439 VSS.n2872 8.5005
R9689 VSS.n439 VSS.n2952 8.5005
R9690 VSS.n439 VSS.n2873 8.5005
R9691 VSS.n439 VSS.n2951 8.5005
R9692 VSS.n439 VSS.n2874 8.5005
R9693 VSS.n439 VSS.n2950 8.5005
R9694 VSS.n439 VSS.n2877 8.5005
R9695 VSS.n439 VSS.n2878 8.5005
R9696 VSS.n439 VSS.n2949 8.5005
R9697 VSS.n439 VSS.n2879 8.5005
R9698 VSS.n439 VSS.n2948 8.5005
R9699 VSS.n439 VSS.n2880 8.5005
R9700 VSS.n439 VSS.n2947 8.5005
R9701 VSS.n439 VSS.n2881 8.5005
R9702 VSS.n439 VSS.n2946 8.5005
R9703 VSS.n439 VSS.n2884 8.5005
R9704 VSS.n439 VSS.n2885 8.5005
R9705 VSS.n439 VSS.n2945 8.5005
R9706 VSS.n439 VSS.n2886 8.5005
R9707 VSS.n439 VSS.n2944 8.5005
R9708 VSS.n439 VSS.n2887 8.5005
R9709 VSS.n439 VSS.n2943 8.5005
R9710 VSS.n439 VSS.n2888 8.5005
R9711 VSS.n439 VSS.n2942 8.5005
R9712 VSS.n439 VSS.n2892 8.5005
R9713 VSS.n439 VSS.n2893 8.5005
R9714 VSS.n439 VSS.n2941 8.5005
R9715 VSS.n439 VSS.n2895 8.5005
R9716 VSS.n439 VSS.n2940 8.5005
R9717 VSS.n439 VSS.n2896 8.5005
R9718 VSS.n439 VSS.n2939 8.5005
R9719 VSS.n439 VSS.n2897 8.5005
R9720 VSS.n439 VSS.n2938 8.5005
R9721 VSS.n439 VSS.n2900 8.5005
R9722 VSS.n439 VSS.n2901 8.5005
R9723 VSS.n439 VSS.n2937 8.5005
R9724 VSS.n439 VSS.n2902 8.5005
R9725 VSS.n439 VSS.n2936 8.5005
R9726 VSS.n439 VSS.n2903 8.5005
R9727 VSS.n439 VSS.n2935 8.5005
R9728 VSS.n439 VSS.n2904 8.5005
R9729 VSS.n439 VSS.n2934 8.5005
R9730 VSS.n439 VSS.n2907 8.5005
R9731 VSS.n439 VSS.n2908 8.5005
R9732 VSS.n439 VSS.n2933 8.5005
R9733 VSS.n439 VSS.n2909 8.5005
R9734 VSS.n439 VSS.n2932 8.5005
R9735 VSS.n439 VSS.n2910 8.5005
R9736 VSS.n439 VSS.n2931 8.5005
R9737 VSS.n439 VSS.n2911 8.5005
R9738 VSS.n439 VSS.n2930 8.5005
R9739 VSS.n439 VSS.n2914 8.5005
R9740 VSS.n439 VSS.n2915 8.5005
R9741 VSS.n439 VSS.n2929 8.5005
R9742 VSS.n439 VSS.n2916 8.5005
R9743 VSS.n439 VSS.n2928 8.5005
R9744 VSS.n439 VSS.n2917 8.5005
R9745 VSS.n439 VSS.n2927 8.5005
R9746 VSS.n439 VSS.n2925 8.5005
R9747 VSS.n378 VSS.n2924 88.4696
R9748 VSS.n509 VSS.n508 0.00216649
R9749 VSS.n1749 VSS.n1420 8.5005
R9750 VSS.n1749 VSS.n1424 8.5005
R9751 VSS.n1749 VSS.n1426 8.5005
R9752 VSS.n1749 VSS.n1429 8.5005
R9753 VSS.n1749 VSS.n1432 8.5005
R9754 VSS.n1749 VSS.n1433 8.5005
R9755 VSS.n1749 VSS.n1434 8.5005
R9756 VSS.n1749 VSS.n1435 8.5005
R9757 VSS.n1749 VSS.n1437 8.5005
R9758 VSS.n1749 VSS.n1438 8.5005
R9759 VSS.n1749 VSS.n1441 8.5005
R9760 VSS.n1749 VSS.n1442 8.5005
R9761 VSS.n1749 VSS.n1445 8.5005
R9762 VSS.n1749 VSS.n1448 8.5005
R9763 VSS.n1749 VSS.n1449 8.5005
R9764 VSS.n1749 VSS.n1450 8.5005
R9765 VSS.n1749 VSS.n1452 8.5005
R9766 VSS.n1749 VSS.n1453 8.5005
R9767 VSS.n1749 VSS.n1454 8.5005
R9768 VSS.n1749 VSS.n1457 8.5005
R9769 VSS.n1749 VSS.n1458 8.5005
R9770 VSS.n1749 VSS.n1460 8.5005
R9771 VSS.n1749 VSS.n1464 8.5005
R9772 VSS.n1749 VSS.n1465 8.5005
R9773 VSS.n1749 VSS.n1466 8.5005
R9774 VSS.n1749 VSS.n1467 8.5005
R9775 VSS.n1749 VSS.n1468 8.5005
R9776 VSS.n1749 VSS.n1470 8.5005
R9777 VSS.n1749 VSS.n1473 8.5005
R9778 VSS.n1749 VSS.n1474 8.5005
R9779 VSS.n1749 VSS.n1476 8.5005
R9780 VSS.n1749 VSS.n1480 8.5005
R9781 VSS.n1749 VSS.n1481 8.5005
R9782 VSS.n1749 VSS.n1482 8.5005
R9783 VSS.n1749 VSS.n1483 8.5005
R9784 VSS.n1749 VSS.n1484 8.5005
R9785 VSS.n1749 VSS.n1486 8.5005
R9786 VSS.n1749 VSS.n1489 8.5005
R9787 VSS.n1749 VSS.n1490 8.5005
R9788 VSS.n1749 VSS.n1492 8.5005
R9789 VSS.n1749 VSS.n1496 8.5005
R9790 VSS.n1749 VSS.n1497 8.5005
R9791 VSS.n1749 VSS.n1498 8.5005
R9792 VSS.n1749 VSS.n1499 8.5005
R9793 VSS.n1749 VSS.n1500 8.5005
R9794 VSS.n1749 VSS.n1502 8.5005
R9795 VSS.n1749 VSS.n1505 8.5005
R9796 VSS.n1749 VSS.n1506 8.5005
R9797 VSS.n1749 VSS.n1509 8.5005
R9798 VSS.n1749 VSS.n1512 8.5005
R9799 VSS.n1749 VSS.n1513 8.5005
R9800 VSS.n1749 VSS.n1514 8.5005
R9801 VSS.n1749 VSS.n1515 8.5005
R9802 VSS.n1749 VSS.n1517 8.5005
R9803 VSS.n1749 VSS.n1518 8.5005
R9804 VSS.n1749 VSS.n1521 8.5005
R9805 VSS.n1749 VSS.n1525 8.5005
R9806 VSS.n1749 VSS.n1529 8.5005
R9807 VSS.n1749 VSS.n1530 8.5005
R9808 VSS.n1749 VSS.n1531 8.5005
R9809 VSS.n1749 VSS.n1532 8.5005
R9810 VSS.n1749 VSS.n1533 8.5005
R9811 VSS.n1749 VSS.n1535 8.5005
R9812 VSS.n1749 VSS.n1538 8.5005
R9813 VSS.n1749 VSS.n1539 8.5005
R9814 VSS.n1749 VSS.n1541 8.5005
R9815 VSS.n1749 VSS.n1545 8.5005
R9816 VSS.n1749 VSS.n1546 8.5005
R9817 VSS.n1749 VSS.n1547 8.5005
R9818 VSS.n1749 VSS.n1548 8.5005
R9819 VSS.n1749 VSS.n1549 8.5005
R9820 VSS.n1749 VSS.n1551 8.5005
R9821 VSS.n1749 VSS.n1554 8.5005
R9822 VSS.n1749 VSS.n1555 8.5005
R9823 VSS.n1749 VSS.n1558 8.5005
R9824 VSS.n1749 VSS.n1561 8.5005
R9825 VSS.n1749 VSS.n1562 8.5005
R9826 VSS.n1749 VSS.n1563 8.5005
R9827 VSS.n1749 VSS.n1564 8.5005
R9828 VSS.n1749 VSS.n1566 8.5005
R9829 VSS.n1749 VSS.n1567 8.5005
R9830 VSS.n1749 VSS.n1570 8.5005
R9831 VSS.n1749 VSS.n1571 8.5005
R9832 VSS.n1749 VSS.n1574 8.5005
R9833 VSS.n1749 VSS.n1577 8.5005
R9834 VSS.n1749 VSS.n1578 8.5005
R9835 VSS.n1749 VSS.n1579 8.5005
R9836 VSS.n1749 VSS.n1581 8.5005
R9837 VSS.n1749 VSS.n1582 8.5005
R9838 VSS.n1749 VSS.n1583 8.5005
R9839 VSS.n1749 VSS.n1586 8.5005
R9840 VSS.n1749 VSS.n1587 8.5005
R9841 VSS.n1749 VSS.n1589 8.5005
R9842 VSS.n1749 VSS.n1593 8.5005
R9843 VSS.n1749 VSS.n1594 8.5005
R9844 VSS.n1749 VSS.n1595 8.5005
R9845 VSS.n1749 VSS.n1596 8.5005
R9846 VSS.n1749 VSS.n1597 8.5005
R9847 VSS.n1749 VSS.n1599 8.5005
R9848 VSS.n1749 VSS.n1602 8.5005
R9849 VSS.n1749 VSS.n1603 8.5005
R9850 VSS.n1749 VSS.n1605 8.5005
R9851 VSS.n1749 VSS.n1609 8.5005
R9852 VSS.n1749 VSS.n1610 8.5005
R9853 VSS.n1749 VSS.n1611 8.5005
R9854 VSS.n1749 VSS.n1612 8.5005
R9855 VSS.n1749 VSS.n1613 8.5005
R9856 VSS.n1749 VSS.n1615 8.5005
R9857 VSS.n1749 VSS.n1618 8.5005
R9858 VSS.n1749 VSS.n1619 8.5005
R9859 VSS.n1749 VSS.n1622 8.5005
R9860 VSS.n1749 VSS.n1625 8.5005
R9861 VSS.n1749 VSS.n1628 8.5005
R9862 VSS.n1749 VSS.n1629 8.5005
R9863 VSS.n1749 VSS.n1630 8.5005
R9864 VSS.n1749 VSS.n1632 8.5005
R9865 VSS.n1749 VSS.n1635 8.5005
R9866 VSS.n1749 VSS.n1636 8.5005
R9867 VSS.n1749 VSS.n1638 8.5005
R9868 VSS.n1749 VSS.n1642 8.5005
R9869 VSS.n1749 VSS.n1643 8.5005
R9870 VSS.n1749 VSS.n1644 8.5005
R9871 VSS.n1749 VSS.n1645 8.5005
R9872 VSS.n1749 VSS.n1647 8.5005
R9873 VSS.n1749 VSS.n1648 8.5005
R9874 VSS.n1749 VSS.n1651 8.5005
R9875 VSS.n1749 VSS.n1652 8.5005
R9876 VSS.n1749 VSS.n1655 8.5005
R9877 VSS.n1749 VSS.n1658 8.5005
R9878 VSS.n1749 VSS.n1659 8.5005
R9879 VSS.n1749 VSS.n1660 8.5005
R9880 VSS.n1749 VSS.n1661 8.5005
R9881 VSS.n1749 VSS.n1662 8.5005
R9882 VSS.n1749 VSS.n1664 8.5005
R9883 VSS.n1749 VSS.n1667 8.5005
R9884 VSS.n1749 VSS.n1668 8.5005
R9885 VSS.n1749 VSS.n1670 8.5005
R9886 VSS.n1749 VSS.n1674 8.5005
R9887 VSS.n1749 VSS.n1675 8.5005
R9888 VSS.n1749 VSS.n1676 8.5005
R9889 VSS.n1749 VSS.n1677 8.5005
R9890 VSS.n1749 VSS.n1678 8.5005
R9891 VSS.n1749 VSS.n1679 8.5005
R9892 VSS.n1749 VSS.n1710 8.5005
R9893 VSS.n1749 VSS.n1695 8.5005
R9894 VSS.t1579 VSS.n23 33.2104
R9895 VSS.t1573 VSS.n8 33.2086
R9896 VSS.n2701 VSS.n504 8.50038
R9897 VSS.n775 VSS.n773 8.49944
R9898 VSS.n439 VSS.n1383 8.49944
R9899 VSS.n2104 VSS.n555 8.49109
R9900 VSS.n2120 VSS.n8 8.48883
R9901 VSS.n447 VSS.n448 4.19663
R9902 VSS.n589 VSS.n1235 8.48012
R9903 VSS.n439 VSS.n2920 8.48012
R9904 VSS.t1697 VSS.n451 0.0932475
R9905 VSS.n451 VSS.n450 4.19355
R9906 VSS.n2777 VSS.n449 8.47784
R9907 VSS.n2778 VSS.n562 8.47784
R9908 VSS.n2778 VSS.n453 0.279772
R9909 VSS.n453 VSS.n452 4.19355
R9910 VSS.n2779 VSS.n563 8.47784
R9911 VSS.n2780 VSS.n565 8.47784
R9912 VSS.n2781 VSS.n566 8.47784
R9913 VSS.n2781 VSS.n455 0.279772
R9914 VSS.n455 VSS.n454 4.19355
R9915 VSS.n455 VSS.n457 0.418
R9916 VSS.n2782 VSS.n569 8.47784
R9917 VSS.n460 VSS.n459 4.19355
R9918 VSS.n2783 VSS.n458 8.47784
R9919 VSS.n462 VSS.n461 4.19355
R9920 VSS.n462 VSS.t1681 0.0932475
R9921 VSS.n244 VSS.n1902 8.47732
R9922 VSS.n244 VSS.n1905 8.47732
R9923 VSS.n244 VSS.n1955 8.47732
R9924 VSS.n582 VSS.n1756 8.47732
R9925 VSS.n582 VSS.n1774 8.47732
R9926 VSS.n582 VSS.n1823 8.47732
R9927 VSS.n582 VSS.t2098 8.47732
R9928 VSS.n582 VSS.t1555 8.47732
R9929 VSS.n2560 VSS.n275 8.47732
R9930 VSS.n246 VSS.n245 3.32623
R9931 VSS.n2534 VSS.n279 8.47732
R9932 VSS.n775 VSS.n771 8.47732
R9933 VSS.n775 VSS.n758 8.47732
R9934 VSS.n775 VSS.n727 8.47732
R9935 VSS.n775 VSS.n692 8.47732
R9936 VSS.n775 VSS.n1003 8.47732
R9937 VSS.n775 VSS.n916 8.47732
R9938 VSS.n775 VSS.t711 8.47732
R9939 VSS.n775 VSS.t1614 8.47732
R9940 VSS.n589 VSS.n1307 8.47732
R9941 VSS.n589 VSS.n1164 8.47732
R9942 VSS.n589 VSS.t939 8.47732
R9943 VSS.n589 VSS.t1602 8.47732
R9944 VSS.n588 VSS.n587 4.19564
R9945 VSS.n589 VSS.n1116 8.47732
R9946 VSS.n589 VSS.n1115 8.47732
R9947 VSS.n589 VSS.n1108 8.47732
R9948 VSS.n589 VSS.n1093 8.47732
R9949 VSS.n589 VSS.n1077 8.47732
R9950 VSS.n439 VSS.n2995 8.47732
R9951 VSS.n439 VSS.n2847 8.47732
R9952 VSS.n439 VSS.t1239 8.47732
R9953 VSS.n439 VSS.t1589 8.47732
R9954 VSS.n2921 VSS.n378 8.47983
R9955 VSS.n440 VSS.n2921 0.311417
R9956 VSS.n439 VSS.n1382 8.47732
R9957 VSS.n439 VSS.n1381 8.47732
R9958 VSS.n439 VSS.n1374 8.47732
R9959 VSS.n439 VSS.n1359 8.47732
R9960 VSS.n439 VSS.n1343 8.47732
R9961 VSS.n2152 VSS.n508 8.47732
R9962 VSS.n2717 VSS.n508 8.47732
R9963 VSS.n2146 VSS.n508 8.47732
R9964 VSS.n2145 VSS.n508 8.47732
R9965 VSS.n1749 VSS.n1419 8.47732
R9966 VSS.n1749 VSS.n1523 8.47732
R9967 VSS.n1749 VSS.n1627 8.47732
R9968 VSS.n1749 VSS.n1681 8.47732
R9969 VSS.n1749 VSS.n1728 8.47732
R9970 VSS.n1749 VSS.n1709 8.47732
R9971 VSS.n1749 VSS.t657 8.47732
R9972 VSS.n1749 VSS.t1544 8.47732
R9973 VSS.n2115 VSS.n8 8.47732
R9974 VSS.n2110 VSS.n8 8.47732
R9975 VSS.n2105 VSS.n8 8.47732
R9976 VSS.n2750 VSS.n8 8.47732
R9977 VSS.n2754 VSS.n8 8.47732
R9978 VSS.n490 VSS.n489 3.32623
R9979 VSS.n490 VSS.n474 0.42774
R9980 VSS.n474 VSS.n472 4.19225
R9981 VSS.n2687 VSS.n471 8.47732
R9982 VSS.n2688 VSS.n537 8.47732
R9983 VSS.n2688 VSS.n488 0.332521
R9984 VSS.n488 VSS.n478 0.42774
R9985 VSS.n478 VSS.n476 4.19225
R9986 VSS.n486 VSS.n485 3.32623
R9987 VSS.n486 VSS.n480 0.42774
R9988 VSS.n480 VSS.n479 4.19225
R9989 VSS.n483 VSS.n482 4.19225
R9990 VSS.n2691 VSS.n523 8.47732
R9991 VSS.n498 VSS.t1569 8.47732
R9992 VSS.t807 VSS.n500 0.277329
R9993 VSS.n500 VSS.n499 2.0061
R9994 VSS.n525 VSS.n517 3.32623
R9995 VSS.n496 VSS.n497 3.32623
R9996 VSS.n2142 VSS.n494 0.380291
R9997 VSS.t814 VSS.n533 8.47732
R9998 VSS.n492 VSS.n491 3.32623
R9999 VSS.n2140 VSS.n529 8.47732
R10000 VSS.n526 VSS.t1563 0.0953067
R10001 VSS.n526 VSS.n508 4.19225
R10002 VSS.n526 VSS.n528 0.427327
R10003 VSS.n2714 VSS.n548 8.47732
R10004 VSS.n2714 VSS.n515 0.423674
R10005 VSS.n2713 VSS.n549 8.47732
R10006 VSS.t804 VSS.n502 0.277329
R10007 VSS.n502 VSS.n501 2.0061
R10008 VSS.t805 VSS.n512 0.232939
R10009 VSS.n512 VSS.n510 2.32425
R10010 VSS.n2715 VSS.n2712 8.47732
R10011 VSS.n2715 VSS.n507 0.423674
R10012 VSS.n507 VSS.n505 2.32425
R10013 VSS.n2703 VSS.n504 8.47732
R10014 VSS.n2698 VSS.n503 8.47732
R10015 VSS.n503 VSS.n513 2.75566
R10016 VSS.n2700 VSS.n522 0.284653
R10017 VSS.n2773 VSS.n444 8.47677
R10018 VSS.n443 VSS.n551 8.47677
R10019 VSS.n2102 VSS.n553 8.47677
R10020 VSS.n2103 VSS.n554 8.47677
R10021 VSS.n2769 VSS.n446 0.187357
R10022 VSS.n446 VSS.n445 4.1909
R10023 VSS.n2770 VSS.n556 8.47677
R10024 VSS.n2771 VSS.n558 8.47677
R10025 VSS.n2771 VSS.n448 0.285089
R10026 VSS.n2695 VSS.n504 8.46924
R10027 VSS.n2555 VSS.n2230 6.99351
R10028 VSS.n2575 VSS.n2211 6.99351
R10029 VSS.n2586 VSS.t1305 6.99351
R10030 VSS.t1123 VSS.n2221 6.97724
R10031 VSS.n2558 VSS.n2228 6.97724
R10032 VSS.t271 VSS.n2257 6.61977
R10033 VSS.t1670 VSS.n2478 6.61977
R10034 VSS.t283 VSS.n2282 6.61977
R10035 VSS.n2319 VSS.t296 6.61977
R10036 VSS.n442 VSS.n560 1.88412
R10037 VSS.n2135 VSS.n2134 6.0005
R10038 VSS.n3006 VSS.n689 5.90311
R10039 VSS.n1330 VSS.n1329 5.90311
R10040 VSS.n1757 VSS.n1405 5.90311
R10041 VSS.t940 VSS.n52 2.83414
R10042 VSS.n52 VSS.n51 0.00199982
R10043 VSS.n277 VSS.n2550 0.0024166
R10044 VSS.n568 VSS.n456 0.00249991
R10045 VSS.n2685 VSS.n535 0.00229996
R10046 VSS.n2669 VSS.n473 2.4293
R10047 VSS.n2669 VSS.n477 2.4293
R10048 VSS.n538 VSS.n475 0.00229996
R10049 VSS.n2669 VSS.n2668 5.66778
R10050 VSS.n524 VSS.n481 0.0024166
R10051 VSS.n55 VSS.n54 5.66778
R10052 VSS.n53 VSS.n495 0.00229996
R10053 VSS.n58 VSS.n54 2.83414
R10054 VSS.n58 VSS.n57 0.00199982
R10055 VSS.n532 VSS.n56 0.00229996
R10056 VSS.n534 VSS.n493 0.0024999
R10057 VSS.n547 VSS.n527 0.00261099
R10058 VSS.n2716 VSS.n550 1.54575
R10059 VSS.n511 VSS.n510 0.00333228
R10060 VSS.n520 VSS.n503 0.00229996
R10061 VSS.n518 VSS.n521 0.00229996
R10062 VSS.n2743 VSS.t887 5.66778
R10063 VSS.n2744 VSS.n530 1.54637
R10064 VSS.t940 VSS.n277 2.83432
R10065 VSS.n2669 VSS.n524 2.83432
R10066 VSS.n439 VSS.n440 3.33939
R10067 VSS.n589 VSS.n1117 5.63915
R10068 VSS.n457 VSS.n456 3.32786
R10069 VSS.t2221 VSS.n246 0.0944268
R10070 VSS.n2601 VSS.n51 5.62581
R10071 VSS.n2533 VSS.n2550 5.62581
R10072 VSS.n249 VSS.n2289 5.62581
R10073 VSS.n1018 VSS.n78 5.62581
R10074 VSS.n2767 VSS.n8 5.62581
R10075 VSS.n488 VSS.n487 3.32623
R10076 VSS.n2689 VSS.n475 5.62581
R10077 VSS.n2690 VSS.n481 5.62581
R10078 VSS.n2144 VSS.n55 5.62581
R10079 VSS.t810 VSS.n53 5.62581
R10080 VSS.t812 VSS.n57 5.62581
R10081 VSS.n2142 VSS.n56 5.62581
R10082 VSS.n494 VSS.n493 3.32623
R10083 VSS.n528 VSS.n527 3.32623
R10084 VSS.n515 VSS.n514 2.32425
R10085 VSS.n522 VSS.n521 3.32623
R10086 VSS.t1204 VSS.n2616 5.48496
R10087 VSS.n1750 VSS.n1416 5.45726
R10088 VSS.n3018 VSS.n3017 5.31969
R10089 VSS.n2728 VSS.n2727 5.31969
R10090 VSS.n2723 VSS.n2149 5.31969
R10091 VSS.n2722 VSS.n2721 5.31969
R10092 VSS.n2726 VSS.n2725 5.31969
R10093 VSS.n3002 VSS.n3001 5.31969
R10094 VSS.n2794 VSS.n2793 5.31969
R10095 VSS.n2231 VSS.n281 5.14882
R10096 VSS.n2548 VSS.n2232 5.14882
R10097 VSS.n2549 VSS.n2547 5.14882
R10098 VSS.n2545 VSS.n2233 5.14882
R10099 VSS.n2546 VSS.n2544 5.14882
R10100 VSS.n2542 VSS.n2234 5.14882
R10101 VSS.n2543 VSS.n2541 5.14882
R10102 VSS.n2539 VSS.n2235 5.14882
R10103 VSS.n2540 VSS.n2538 5.14882
R10104 VSS.n2536 VSS.n2236 5.14882
R10105 VSS.n2537 VSS.n2535 5.14882
R10106 VSS.n2532 VSS.n2530 5.14882
R10107 VSS.n2528 VSS.n2238 5.14882
R10108 VSS.n2529 VSS.n2527 5.14882
R10109 VSS.n2525 VSS.n2239 5.14882
R10110 VSS.n2526 VSS.n2524 5.14882
R10111 VSS.n2522 VSS.n2240 5.14882
R10112 VSS.n2523 VSS.n2521 5.14882
R10113 VSS.n2519 VSS.n2241 5.14882
R10114 VSS.n2520 VSS.n2518 5.14882
R10115 VSS.n2516 VSS.n2242 5.14882
R10116 VSS.n2517 VSS.n2515 5.14882
R10117 VSS.n2513 VSS.n2243 5.14882
R10118 VSS.n2514 VSS.n2512 5.14882
R10119 VSS.n2510 VSS.n2244 5.14882
R10120 VSS.n2511 VSS.n2509 5.14882
R10121 VSS.n2252 VSS.n2245 5.14882
R10122 VSS.n2253 VSS.n2251 5.14882
R10123 VSS.n2249 VSS.n2246 5.14882
R10124 VSS.n2250 VSS.n2248 5.14882
R10125 VSS.n2507 VSS.n2247 5.14882
R10126 VSS.n2508 VSS.n2506 5.14882
R10127 VSS.n2504 VSS.n2254 5.14882
R10128 VSS.n2505 VSS.n2503 5.14882
R10129 VSS.n2501 VSS.n2255 5.14882
R10130 VSS.n2502 VSS.n2500 5.14882
R10131 VSS.n2492 VSS.n2256 5.14882
R10132 VSS.n2494 VSS.n2493 5.14882
R10133 VSS.n2496 VSS.n2495 5.14882
R10134 VSS.n2498 VSS.n2497 5.14882
R10135 VSS.n2499 VSS.n2491 5.14882
R10136 VSS.n2489 VSS.n2257 5.14882
R10137 VSS.n2490 VSS.n2488 5.14882
R10138 VSS.n2486 VSS.n2258 5.14882
R10139 VSS.n2487 VSS.n2485 5.14882
R10140 VSS.n2483 VSS.n2259 5.14882
R10141 VSS.n2484 VSS.n2482 5.14882
R10142 VSS.n2480 VSS.n2260 5.14882
R10143 VSS.n2481 VSS.n2479 5.14882
R10144 VSS.n2478 VSS.n2261 5.14882
R10145 VSS.t275 VSS.n2262 5.14882
R10146 VSS.n2477 VSS.n2476 5.14882
R10147 VSS.n2474 VSS.n2263 5.14882
R10148 VSS.n2475 VSS.n2473 5.14882
R10149 VSS.n2471 VSS.n2264 5.14882
R10150 VSS.n2472 VSS.n2470 5.14882
R10151 VSS.n2468 VSS.n2265 5.14882
R10152 VSS.n2469 VSS.n2467 5.14882
R10153 VSS.n2465 VSS.n2266 5.14882
R10154 VSS.n2466 VSS.n2464 5.14882
R10155 VSS.n2462 VSS.n2267 5.14882
R10156 VSS.n2463 VSS.n2461 5.14882
R10157 VSS.n2459 VSS.n2268 5.14882
R10158 VSS.n2460 VSS.n2458 5.14882
R10159 VSS.n2456 VSS.n2269 5.14882
R10160 VSS.n2457 VSS.n2455 5.14882
R10161 VSS.n2277 VSS.n2270 5.14882
R10162 VSS.n2278 VSS.n2276 5.14882
R10163 VSS.n2274 VSS.n2271 5.14882
R10164 VSS.n2275 VSS.n2273 5.14882
R10165 VSS.n2453 VSS.n2272 5.14882
R10166 VSS.n2454 VSS.n2452 5.14882
R10167 VSS.n2450 VSS.n2279 5.14882
R10168 VSS.n2451 VSS.n2449 5.14882
R10169 VSS.n2447 VSS.n2280 5.14882
R10170 VSS.n2448 VSS.n2446 5.14882
R10171 VSS.n2438 VSS.n2281 5.14882
R10172 VSS.n2440 VSS.n2439 5.14882
R10173 VSS.n2442 VSS.n2441 5.14882
R10174 VSS.n2444 VSS.n2443 5.14882
R10175 VSS.n2445 VSS.n2437 5.14882
R10176 VSS.n2435 VSS.n2282 5.14882
R10177 VSS.n2436 VSS.n2434 5.14882
R10178 VSS.n2432 VSS.n2283 5.14882
R10179 VSS.n2433 VSS.n2431 5.14882
R10180 VSS.n2429 VSS.n2284 5.14882
R10181 VSS.n2430 VSS.n2428 5.14882
R10182 VSS.n2426 VSS.n2285 5.14882
R10183 VSS.n2427 VSS.n2425 5.14882
R10184 VSS.n2424 VSS.n2286 5.14882
R10185 VSS.t287 VSS.n2287 5.14882
R10186 VSS.n2423 VSS.n2422 5.14882
R10187 VSS.n2420 VSS.n2288 5.14882
R10188 VSS.n2421 VSS.n2419 5.14882
R10189 VSS.n2417 VSS.n2290 5.14882
R10190 VSS.n2418 VSS.n2416 5.14882
R10191 VSS.n2415 VSS.n2414 5.14882
R10192 VSS.n2413 VSS.n2412 5.14882
R10193 VSS.n2411 VSS.n2410 5.14882
R10194 VSS.n2409 VSS.n2408 5.14882
R10195 VSS.n2407 VSS.n2406 5.14882
R10196 VSS.n2405 VSS.n2404 5.14882
R10197 VSS.n2403 VSS.n2402 5.14882
R10198 VSS.n2401 VSS.n2400 5.14882
R10199 VSS.n2399 VSS.n2398 5.14882
R10200 VSS.n2397 VSS.n2396 5.14882
R10201 VSS.n2395 VSS.n2394 5.14882
R10202 VSS.n2297 VSS.n2296 5.14882
R10203 VSS.n2295 VSS.n2294 5.14882
R10204 VSS.n2293 VSS.n2292 5.14882
R10205 VSS.n2301 VSS.n2291 5.14882
R10206 VSS.n2303 VSS.n2302 5.14882
R10207 VSS.n2305 VSS.n2304 5.14882
R10208 VSS.n2307 VSS.n2306 5.14882
R10209 VSS.n2309 VSS.n2308 5.14882
R10210 VSS.n2311 VSS.n2310 5.14882
R10211 VSS.n2313 VSS.n2312 5.14882
R10212 VSS.n2314 VSS.n2300 5.14882
R10213 VSS.n2392 VSS.n2299 5.14882
R10214 VSS.n2393 VSS.n2391 5.14882
R10215 VSS.n2390 VSS.n2315 5.14882
R10216 VSS.n2321 VSS.n2319 5.14882
R10217 VSS.n2322 VSS.n2320 5.14882
R10218 VSS.n2324 VSS.n2318 5.14882
R10219 VSS.n2325 VSS.n2323 5.14882
R10220 VSS.n2327 VSS.n2317 5.14882
R10221 VSS.n2328 VSS.n2326 5.14882
R10222 VSS.n2388 VSS.n2316 5.14882
R10223 VSS.n2389 VSS.n2387 5.14882
R10224 VSS.n2386 VSS.n2385 5.14882
R10225 VSS.n2384 VSS.t300 5.14882
R10226 VSS.n2383 VSS.n2382 5.14882
R10227 VSS.n2381 VSS.n2380 5.14882
R10228 VSS.n2379 VSS.n2378 5.14882
R10229 VSS.n2377 VSS.n2376 5.14882
R10230 VSS.n2375 VSS.n2374 5.14882
R10231 VSS.n2373 VSS.n2372 5.14882
R10232 VSS.n2371 VSS.n2370 5.14882
R10233 VSS.n2369 VSS.n2368 5.14882
R10234 VSS.n2367 VSS.n2366 5.14882
R10235 VSS.n2365 VSS.n2364 5.14882
R10236 VSS.n2363 VSS.n2362 5.14882
R10237 VSS.n2361 VSS.n2360 5.14882
R10238 VSS.n2359 VSS.n2358 5.14882
R10239 VSS.n2357 VSS.n2356 5.14882
R10240 VSS.n2355 VSS.n2354 5.14882
R10241 VSS.n2353 VSS.n2352 5.14882
R10242 VSS.n2351 VSS.n2350 5.14882
R10243 VSS.n2349 VSS.n2348 5.14882
R10244 VSS.n2347 VSS.n2346 5.14882
R10245 VSS.n2345 VSS.n2344 5.14882
R10246 VSS.n2343 VSS.n2342 5.14882
R10247 VSS.n2341 VSS.n2340 5.14882
R10248 VSS.n2339 VSS.n2338 5.14882
R10249 VSS.n2337 VSS.n2336 5.14882
R10250 VSS.n2335 VSS.n2334 5.14882
R10251 VSS.n2333 VSS.n2332 5.14882
R10252 VSS.n2331 VSS.n2330 5.14882
R10253 VSS.t1185 VSS.n2119 5.13648
R10254 VSS.n2748 VSS.t1883 4.98596
R10255 VSS.n2760 VSS.n2100 4.63796
R10256 VSS.n2132 VSS.n2119 4.4712
R10257 VSS.t1114 VSS.n2236 4.41335
R10258 VSS.n3016 VSS.t1636 4.28393
R10259 VSS.n54 VSS.n2143 4.25119
R10260 VSS.n506 VSS.n505 0.0031239
R10261 VSS.n2686 VSS.n2685 4.19244
R10262 VSS.n2693 VSS.n504 4.19244
R10263 VSS.n251 VSS.t231 0.0736713
R10264 VSS.n255 VSS.n16 2.75971
R10265 VSS.n268 VSS.n269 2.75971
R10266 VSS.n285 VSS.n284 2.75971
R10267 VSS.n292 VSS.n291 2.75971
R10268 VSS.t293 VSS.n295 0.0724751
R10269 VSS.n306 VSS.t396 0.0736713
R10270 VSS.t407 VSS.n316 0.0736713
R10271 VSS.t419 VSS.n326 0.0736713
R10272 VSS.t431 VSS.n333 0.0736713
R10273 VSS.t442 VSS.n339 0.0736713
R10274 VSS.n344 VSS.n345 2.76051
R10275 VSS.t331 VSS.n583 2.76051
R10276 VSS.n441 VSS.t122 2.76051
R10277 VSS.n2763 VSS.n8 4.19225
R10278 VSS.n2138 VSS.n529 4.19225
R10279 VSS.t2 VSS.n585 2.76051
R10280 VSS.t529 VSS.n2126 4.17719
R10281 VSS.t529 VSS.n2127 4.17712
R10282 VSS.n2603 VSS.t39 4.177
R10283 VSS.n2729 VSS.n2728 4.07175
R10284 VSS.n2731 VSS.n2149 4.07175
R10285 VSS.n2721 VSS.n2720 4.07175
R10286 VSS.n2330 VSS.n560 5.70402
R10287 VSS VSS.n3018 3.92317
R10288 VSS.t18 VSS 3.92317
R10289 VSS.t424 VSS 3.92317
R10290 VSS.t451 VSS 3.92317
R10291 VSS.n1416 VSS 3.92317
R10292 VSS.t2081 VSS 3.92317
R10293 VSS.t200 VSS 3.92317
R10294 VSS.t218 VSS 3.92317
R10295 VSS.t1806 VSS 3.92317
R10296 VSS.n2721 VSS 3.92317
R10297 VSS.n2149 VSS 3.92317
R10298 VSS.n2728 VSS 3.92317
R10299 VSS.t1691 VSS 3.92317
R10300 VSS.t31 VSS 3.92317
R10301 VSS.t1675 VSS 3.92317
R10302 VSS.t701 VSS 3.92317
R10303 VSS.n2725 VSS 3.92317
R10304 VSS.t563 VSS 3.92317
R10305 VSS.t317 VSS 3.92317
R10306 VSS.t336 VSS 3.92317
R10307 VSS.t1630 VSS 3.92317
R10308 VSS.n3001 VSS 3.92317
R10309 VSS.t2094 VSS 3.92317
R10310 VSS.t364 VSS 3.92317
R10311 VSS.t382 VSS 3.92317
R10312 VSS.t499 VSS 3.92317
R10313 VSS.t768 VSS 3.92317
R10314 VSS.n2793 VSS 3.92317
R10315 VSS.t771 VSS 3.92317
R10316 VSS.t259 VSS 3.92317
R10317 VSS.t288 VSS 3.92317
R10318 VSS.n1693 VSS 3.90557
R10319 VSS.n1626 VSS 3.90557
R10320 VSS.n2890 VSS 3.90557
R10321 VSS.n1373 VSS 3.90557
R10322 VSS.n1107 VSS 3.90557
R10323 VSS.n1207 VSS 3.90557
R10324 VSS.n827 VSS 3.90557
R10325 VSS.n757 VSS 3.90557
R10326 VSS.n1871 VSS 3.90557
R10327 VSS.t473 VSS 3.89823
R10328 VSS.n1522 VSS 3.89823
R10329 VSS.t1815 VSS 3.89823
R10330 VSS.n1358 VSS 3.89823
R10331 VSS.n1092 VSS 3.89823
R10332 VSS.t55 VSS 3.89823
R10333 VSS.t687 VSS 3.89823
R10334 VSS.n726 VSS 3.89823
R10335 VSS.t698 VSS 3.89823
R10336 VSS.n2027 VSS 3.89823
R10337 VSS.n3016 VSS.t2090 3.84219
R10338 VSS.n1750 VSS.t774 3.84219
R10339 VSS.t2279 VSS.n1751 3.84219
R10340 VSS.t1400 VSS.n1317 3.84219
R10341 VSS.t945 VSS.n3003 3.84219
R10342 VSS.t169 VSS.n2151 3.84119
R10343 VSS.t21 VSS.n2795 3.84041
R10344 VSS.n2999 VSS.t34 3.84041
R10345 VSS.t1132 VSS.n676 3.84041
R10346 VSS.n2664 VSS 3.75734
R10347 VSS.t917 VSS.n2188 3.48887
R10348 VSS.t256 VSS.n2221 3.48887
R10349 VSS.t1877 VSS.n2329 3.39224
R10350 VSS.t331 VSS.n2923 3.3922
R10351 VSS.t1548 VSS.t122 3.3922
R10352 VSS.n996 VSS.t1870 3.34498
R10353 VSS.n991 VSS.t555 3.34498
R10354 VSS.n984 VSS.t2150 3.34498
R10355 VSS.n979 VSS.t2151 3.34498
R10356 VSS.n971 VSS.t2163 3.34498
R10357 VSS.n965 VSS.t78 3.34498
R10358 VSS.n957 VSS.t741 3.34498
R10359 VSS.n952 VSS.t2371 3.34498
R10360 VSS.n945 VSS.t2373 3.34498
R10361 VSS.n940 VSS.t781 3.34498
R10362 VSS.n932 VSS.t2372 3.34498
R10363 VSS.n926 VSS.t1013 3.34498
R10364 VSS.n917 VSS.t2168 3.34498
R10365 VSS.n912 VSS.t1028 3.34498
R10366 VSS.n905 VSS.t1012 3.34498
R10367 VSS.n899 VSS.t2164 3.34498
R10368 VSS.n890 VSS.t2369 3.34498
R10369 VSS.n884 VSS.t2370 3.34498
R10370 VSS.n876 VSS.t596 3.34498
R10371 VSS.n871 VSS.t1066 3.34498
R10372 VSS.n863 VSS.t1030 3.34498
R10373 VSS.n857 VSS.t2169 3.34498
R10374 VSS.n849 VSS.t2170 3.34498
R10375 VSS.n844 VSS.t784 3.34498
R10376 VSS.n836 VSS.t783 3.34498
R10377 VSS.n829 VSS.t590 3.34498
R10378 VSS.n819 VSS.t2149 3.34498
R10379 VSS.n813 VSS.t1082 3.34498
R10380 VSS.n805 VSS.t594 3.34498
R10381 VSS.n800 VSS.t2165 3.34498
R10382 VSS.n792 VSS.t1665 3.34498
R10383 VSS.n786 VSS.t127 3.34498
R10384 VSS.t1163 VSS.n1120 3.34498
R10385 VSS.t625 VSS.n1125 3.34498
R10386 VSS.t1902 VSS.n1128 3.34498
R10387 VSS.t749 VSS.n1132 3.34498
R10388 VSS.t1751 VSS.n1135 3.34498
R10389 VSS.t1899 VSS.n1139 3.34498
R10390 VSS.t909 VSS.n1142 3.34498
R10391 VSS.t828 VSS.n1146 3.34498
R10392 VSS.t123 VSS.n1149 3.34498
R10393 VSS.t1068 VSS.n1153 3.34498
R10394 VSS.t1532 VSS.n1156 3.34498
R10395 VSS.t1531 VSS.n1160 3.34498
R10396 VSS.t2035 VSS.n1163 3.34498
R10397 VSS.t1734 VSS.n1167 3.34498
R10398 VSS.t1753 VSS.n1170 3.34498
R10399 VSS.t1848 VSS.n1174 3.34498
R10400 VSS.t904 VSS.n1177 3.34498
R10401 VSS.t1738 VSS.n1181 3.34498
R10402 VSS.t2271 VSS.n1184 3.34498
R10403 VSS.t2270 VSS.n1188 3.34498
R10404 VSS.t914 VSS.n1191 3.34498
R10405 VSS.t912 VSS.n1195 3.34498
R10406 VSS.t1664 VSS.n1198 3.34498
R10407 VSS.t1663 VSS.n1202 3.34498
R10408 VSS.t1032 VSS.n1205 3.34498
R10409 VSS.t110 VSS.n1210 3.34498
R10410 VSS.t1648 VSS.n1214 3.34498
R10411 VSS.t724 VSS.n1218 3.34498
R10412 VSS.t2201 VSS.n1221 3.34498
R10413 VSS.t2200 VSS.n1225 3.34498
R10414 VSS.t1499 VSS.n1228 3.34498
R10415 VSS.t2031 VSS.n1232 3.34498
R10416 VSS.t1732 VSS.n2803 3.34498
R10417 VSS.t2378 VSS.n2808 3.34498
R10418 VSS.t1006 VSS.n2811 3.34498
R10419 VSS.t1746 VSS.n2815 3.34498
R10420 VSS.t1527 VSS.n2818 3.34498
R10421 VSS.t890 VSS.n2822 3.34498
R10422 VSS.t1348 VSS.n2825 3.34498
R10423 VSS.t2276 VSS.n2829 3.34498
R10424 VSS.t870 VSS.n2832 3.34498
R10425 VSS.t1160 VSS.n2836 3.34498
R10426 VSS.t857 VSS.n2839 3.34498
R10427 VSS.t1040 VSS.n2843 3.34498
R10428 VSS.t1632 VSS.n2846 3.34498
R10429 VSS.t817 VSS.n2850 3.34498
R10430 VSS.t2367 VSS.n2853 3.34498
R10431 VSS.t525 VSS.n2857 3.34498
R10432 VSS.t2364 VSS.n2860 3.34498
R10433 VSS.t2272 VSS.n2864 3.34498
R10434 VSS.t867 VSS.n2867 3.34498
R10435 VSS.t751 VSS.n2871 3.34498
R10436 VSS.t112 VSS.n2874 3.34498
R10437 VSS.t754 VSS.n2878 3.34498
R10438 VSS.t102 VSS.n2881 3.34498
R10439 VSS.t760 VSS.n2885 3.34498
R10440 VSS.t863 VSS.n2888 3.34498
R10441 VSS.t2376 VSS.n2893 3.34498
R10442 VSS.t883 VSS.n2897 3.34498
R10443 VSS.t518 VSS.n2901 3.34498
R10444 VSS.t1022 VSS.n2904 3.34498
R10445 VSS.t1097 VSS.n2908 3.34498
R10446 VSS.t824 VSS.n2911 3.34498
R10447 VSS.t1735 VSS.n2915 3.34498
R10448 VSS.t874 VSS.n1752 3.34498
R10449 VSS.t1161 VSS.n165 3.34498
R10450 VSS.t868 VSS.n168 3.34498
R10451 VSS.t752 VSS.n170 3.34498
R10452 VSS.t114 VSS.n173 3.34498
R10453 VSS.t756 VSS.n175 3.34498
R10454 VSS.t104 VSS.n178 3.34498
R10455 VSS.t761 VSS.n180 3.34498
R10456 VSS.t865 VSS.n183 3.34498
R10457 VSS.t2377 VSS.n185 3.34498
R10458 VSS.t1903 VSS.n188 3.34498
R10459 VSS.t750 VSS.n190 3.34498
R10460 VSS.t1752 VSS.n193 3.34498
R10461 VSS.t1900 VSS.n195 3.34498
R10462 VSS.t910 VSS.n198 3.34498
R10463 VSS.t829 VSS.n200 3.34498
R10464 VSS.t125 VSS.n203 3.34498
R10465 VSS.t1069 VSS.n205 3.34498
R10466 VSS.t906 VSS.n208 3.34498
R10467 VSS.t905 VSS.n210 3.34498
R10468 VSS.t1901 VSS.n213 3.34498
R10469 VSS.t2075 VSS.n215 3.34498
R10470 VSS.t1852 VSS.n218 3.34498
R10471 VSS.t2167 VSS.n220 3.34498
R10472 VSS.t592 VSS.n223 3.34498
R10473 VSS.t1905 VSS.n225 3.34498
R10474 VSS.t740 VSS.n228 3.34498
R10475 VSS.t116 VSS.n230 3.34498
R10476 VSS.t1034 VSS.n233 3.34498
R10477 VSS.t1748 VSS.n235 3.34498
R10478 VSS.t1070 VSS.n238 3.34498
R10479 VSS.t565 VSS.n1894 3.34498
R10480 VSS.t1739 VSS.n1424 3.34498
R10481 VSS.t626 VSS.n1432 3.34498
R10482 VSS.t884 VSS.n1441 3.34498
R10483 VSS.t523 VSS.n1448 3.34498
R10484 VSS.t1024 VSS.n1457 3.34498
R10485 VSS.t1099 VSS.n1464 3.34498
R10486 VSS.t826 VSS.n1473 3.34498
R10487 VSS.t1737 VSS.n1480 3.34498
R10488 VSS.t1164 VSS.n1489 3.34498
R10489 VSS.t2273 VSS.n1496 3.34498
R10490 VSS.t861 VSS.n1505 3.34498
R10491 VSS.t1042 VSS.n1512 3.34498
R10492 VSS.n1710 VSS.t1633 3.34498
R10493 VSS.t818 VSS.n1529 3.34498
R10494 VSS.t2368 VSS.n1538 3.34498
R10495 VSS.t526 VSS.n1545 3.34498
R10496 VSS.t2365 VSS.n1554 3.34498
R10497 VSS.t2379 VSS.n1561 3.34498
R10498 VSS.t1035 VSS.n1570 3.34498
R10499 VSS.t1749 VSS.n1577 3.34498
R10500 VSS.t1072 VSS.n1586 3.34498
R10501 VSS.t567 VSS.n1593 3.34498
R10502 VSS.t2197 VSS.n1602 3.34498
R10503 VSS.t1698 VSS.n1609 3.34498
R10504 VSS.t1733 VSS.n1618 3.34498
R10505 VSS.n1695 VSS.t118 3.34498
R10506 VSS.t1007 VSS.n1635 3.34498
R10507 VSS.t1747 VSS.n1642 3.34498
R10508 VSS.t1528 VSS.n1651 3.34498
R10509 VSS.t892 VSS.n1658 3.34498
R10510 VSS.t1350 VSS.n1667 3.34498
R10511 VSS.t2277 VSS.n1674 3.34498
R10512 VSS.t529 VSS.n2136 3.34182
R10513 VSS.n775 VSS.n687 3.32778
R10514 VSS.n439 VSS.n1341 3.32778
R10515 VSS.n2730 VSS.n508 3.32633
R10516 VSS.n2113 VSS.n8 3.32633
R10517 VSS.n582 VSS.n1753 3.32615
R10518 VSS.n3005 VSS.t1150 3.30447
R10519 VSS.t1618 VSS.t1473 3.28366
R10520 VSS.n2785 VSS.n299 3.21582
R10521 VSS.n2798 VSS.n25 3.21582
R10522 VSS.n2670 VSS.n25 3.21582
R10523 VSS.n2675 VSS.n25 3.21582
R10524 VSS.n2678 VSS.n25 3.21582
R10525 VSS.n2680 VSS.n25 3.21582
R10526 VSS.n2683 VSS.n25 3.21582
R10527 VSS.n278 VSS.n280 3.21582
R10528 VSS.t2083 VSS.n1005 2.9518
R10529 VSS.n1333 VSS.t978 2.9518
R10530 VSS.t77 VSS.n1408 2.9518
R10531 VSS.n2531 VSS.t1666 2.9424
R10532 VSS.n2296 VSS.t1676 2.9424
R10533 VSS.n1749 VSS.n89 2.77723
R10534 VSS.n775 VSS.n81 2.77706
R10535 VSS.n274 VSS.n272 2.05187
R10536 VSS.n331 VSS.t424 0.30699
R10537 VSS.t1682 VSS.n2100 2.7456
R10538 VSS.n589 VSS.n1074 2.74446
R10539 VSS.n582 VSS.n575 2.74446
R10540 VSS.n1749 VSS.n1745 2.74446
R10541 VSS.n589 VSS.n1238 2.7443
R10542 VSS.n439 VSS.n2926 2.7443
R10543 VSS.n582 VSS.n1896 2.74414
R10544 VSS.n775 VSS.n695 2.74414
R10545 VSS.n439 VSS.n1345 2.74414
R10546 VSS.n775 VSS.n779 2.74413
R10547 VSS.n1749 VSS.n1686 2.74413
R10548 VSS.n775 VSS.n995 2.74405
R10549 VSS.n589 VSS.t1404 2.74402
R10550 VSS.n1749 VSS.t497 2.74402
R10551 VSS.n589 VSS.n1121 2.74397
R10552 VSS.n439 VSS.n2804 2.74397
R10553 VSS.n582 VSS.n1780 2.74397
R10554 VSS.n589 VSS.n1079 2.74397
R10555 VSS.n1749 VSS.n1425 2.74397
R10556 VSS.n1749 VSS.n1723 2.74397
R10557 VSS.n2752 VSS.n8 2.74397
R10558 VSS.n244 VSS.t589 2.74394
R10559 VSS.n775 VSS.t614 2.74386
R10560 VSS.n439 VSS.t1119 2.74386
R10561 VSS.n2122 VSS.n8 2.74364
R10562 VSS.n2172 VSS.n529 2.46343
R10563 VSS.n2661 VSS.n529 2.46343
R10564 VSS.n2658 VSS.n529 2.46343
R10565 VSS.n2656 VSS.n529 2.46343
R10566 VSS.n2653 VSS.n529 2.46343
R10567 VSS.n2622 VSS.n529 2.46343
R10568 VSS.n2651 VSS.n529 2.46343
R10569 VSS.n2648 VSS.n529 2.46343
R10570 VSS.n2645 VSS.n529 2.46343
R10571 VSS.n2643 VSS.n529 2.46343
R10572 VSS.n2640 VSS.n529 2.46343
R10573 VSS.n2637 VSS.n529 2.46343
R10574 VSS.n504 VSS.n2171 2.46343
R10575 VSS.n504 VSS.n2170 2.46343
R10576 VSS.n504 VSS.n2169 2.46343
R10577 VSS.n504 VSS.n2154 2.46343
R10578 VSS.n504 VSS.n2155 2.46343
R10579 VSS.n504 VSS.n2156 2.46343
R10580 VSS.n504 VSS.n2157 2.46343
R10581 VSS.n504 VSS.n2168 2.46343
R10582 VSS.n504 VSS.n2167 2.46343
R10583 VSS.n504 VSS.n2166 2.46343
R10584 VSS.n504 VSS.n2165 2.46343
R10585 VSS.n504 VSS.n2158 2.46343
R10586 VSS.n504 VSS.n2159 2.46343
R10587 VSS.n504 VSS.n2160 2.46343
R10588 VSS.n504 VSS.n2161 2.46343
R10589 VSS.n504 VSS.n2162 2.46343
R10590 VSS.n504 VSS.n2163 2.46343
R10591 VSS.n504 VSS.n2164 2.46343
R10592 VSS.n2632 VSS.n529 2.46343
R10593 VSS.n2635 VSS.n529 2.46343
R10594 VSS.n260 VSS.n258 1.79887
R10595 VSS.t238 VSS.n253 0.054987
R10596 VSS.n288 VSS.n287 1.79874
R10597 VSS.n294 VSS.n249 1.79874
R10598 VSS.t402 VSS.n311 0.054987
R10599 VSS.t414 VSS.n321 0.054987
R10600 VSS.t437 VSS.n335 0.054987
R10601 VSS.t449 VSS.n341 0.054987
R10602 VSS.n296 VSS.n300 1.79052
R10603 VSS.n348 VSS.n86 1.79052
R10604 VSS.n2738 VSS.n529 2.32483
R10605 VSS.n2705 VSS.n504 2.32483
R10606 VSS.n2607 VSS.t542 2.29748
R10607 VSS.t1666 VSS.n2237 2.20692
R10608 VSS.n2606 VSS.n2602 2.19188
R10609 VSS.n582 VSS.n2790 2.0197
R10610 VSS.t331 VSS.n10 0.616127
R10611 VSS.n11 VSS.t8 0.580161
R10612 VSS.n2734 VSS.n529 2.00687
R10613 VSS.n2709 VSS.n504 2.00687
R10614 VSS.t2 VSS.n9 0.616127
R10615 VSS.n589 VSS.n1208 2.00619
R10616 VSS.n439 VSS.n2891 2.00619
R10617 VSS.n244 VSS.n2028 2.006
R10618 VSS.n589 VSS.n1279 2.006
R10619 VSS.n439 VSS.n2967 2.006
R10620 VSS.n1749 VSS.n1696 2.00599
R10621 VSS.n582 VSS.n1821 2.00599
R10622 VSS.n582 VSS.n1865 2.00599
R10623 VSS.n775 VSS.n918 2.00599
R10624 VSS.n1749 VSS.n1516 2.00599
R10625 VSS.n1749 VSS.n1621 2.00599
R10626 VSS.n1749 VSS.n1711 2.00599
R10627 VSS.n775 VSS.n832 2.00599
R10628 VSS.n589 VSS.n1106 2.00599
R10629 VSS.n589 VSS.n1091 2.00599
R10630 VSS.n775 VSS.n755 2.00592
R10631 VSS.n439 VSS.n1372 2.00592
R10632 VSS.n439 VSS.n1357 2.00592
R10633 VSS.n775 VSS.n724 2.00592
R10634 VSS.n775 VSS.n1012 1.97843
R10635 VSS.n775 VSS.n1011 1.97843
R10636 VSS.n775 VSS.n1008 1.97843
R10637 VSS.n775 VSS.n683 1.97843
R10638 VSS.n775 VSS.n684 1.97843
R10639 VSS.n775 VSS.n688 1.97843
R10640 VSS.n3014 VSS.t2 1.97843
R10641 VSS.t2 VSS.n1059 1.97843
R10642 VSS.t2 VSS.n1060 1.97843
R10643 VSS.t2 VSS.n3012 1.97843
R10644 VSS.t2 VSS.n3011 1.97843
R10645 VSS.t2 VSS.n3010 1.97843
R10646 VSS.t2 VSS.n3009 1.97843
R10647 VSS.t2 VSS.n1061 1.97843
R10648 VSS.t2 VSS.n1063 1.97843
R10649 VSS.t2 VSS.n1064 1.97843
R10650 VSS.t2 VSS.n3008 1.97843
R10651 VSS.t2 VSS.n1066 1.97843
R10652 VSS.t331 VSS.n1339 1.97843
R10653 VSS.t331 VSS.n1320 1.97843
R10654 VSS.t331 VSS.n1323 1.97843
R10655 VSS.t331 VSS.n1326 1.97843
R10656 VSS.t331 VSS.n1332 1.97843
R10657 VSS.n589 VSS.n1068 1.97843
R10658 VSS.n589 VSS.n1069 1.97843
R10659 VSS.n589 VSS.n1070 1.97843
R10660 VSS.n589 VSS.n1315 1.97843
R10661 VSS.n589 VSS.n1314 1.97843
R10662 VSS.n589 VSS.n1313 1.97843
R10663 VSS.n589 VSS.n1312 1.97843
R10664 VSS.n589 VSS.n1311 1.97843
R10665 VSS.n589 VSS.n1072 1.97843
R10666 VSS.n589 VSS.n1310 1.97843
R10667 VSS.n589 VSS.n1309 1.97843
R10668 VSS.n589 VSS.n1308 1.97843
R10669 VSS.t122 VSS.n1414 1.97843
R10670 VSS.t122 VSS.n1397 1.97843
R10671 VSS.t122 VSS.n1400 1.97843
R10672 VSS.t122 VSS.n1409 1.97843
R10673 VSS.t122 VSS.n1402 1.97843
R10674 VSS.t122 VSS.n1407 1.97843
R10675 VSS.n582 VSS.n581 1.97843
R10676 VSS.n582 VSS.n1772 1.97843
R10677 VSS.n582 VSS.n1771 1.97843
R10678 VSS.n582 VSS.n1769 1.97843
R10679 VSS.n582 VSS.n1768 1.97843
R10680 VSS.n582 VSS.n1767 1.97843
R10681 VSS.n582 VSS.n1766 1.97843
R10682 VSS.n582 VSS.n1765 1.97843
R10683 VSS.n582 VSS.n1763 1.97843
R10684 VSS.n582 VSS.n1762 1.97843
R10685 VSS.n582 VSS.n1761 1.97843
R10686 VSS.n582 VSS.n1758 1.97843
R10687 VSS.n2605 VSS.n2603 1.88189
R10688 VSS.t529 VSS.n469 1.88189
R10689 VSS.t542 VSS.n59 0.249882
R10690 VSS.n2148 VSS.n508 1.75596
R10691 VSS.n2719 VSS.n508 1.7558
R10692 VSS.n2749 VSS.n29 0.612583
R10693 VSS.n2699 VSS.n2121 1.66925
R10694 VSS.n1749 VSS.n1394 1.64417
R10695 VSS.n1749 VSS.n1732 1.64417
R10696 VSS.n1749 VSS.n1737 1.64417
R10697 VSS.n1749 VSS.n1741 1.64417
R10698 VSS.n1749 VSS.n1743 1.64417
R10699 VSS.n2996 VSS.n439 1.63922
R10700 VSS.n439 VSS.n1393 1.63922
R10701 VSS.n439 VSS.n1389 1.63922
R10702 VSS.n439 VSS.n1387 1.63922
R10703 VSS.n439 VSS.n1385 1.63922
R10704 VSS.n586 VSS.t2 1.30186
R10705 VSS.n584 VSS.t331 1.30167
R10706 VSS.t265 VSS.n273 1.58672
R10707 VSS.n589 VSS.n1123 1.55386
R10708 VSS.n589 VSS.n1130 1.55386
R10709 VSS.n589 VSS.n1137 1.55386
R10710 VSS.n589 VSS.n1144 1.55386
R10711 VSS.n589 VSS.n1151 1.55386
R10712 VSS.n589 VSS.n1158 1.55386
R10713 VSS.n589 VSS.n1165 1.55386
R10714 VSS.n589 VSS.n1172 1.55386
R10715 VSS.n589 VSS.n1179 1.55386
R10716 VSS.n589 VSS.n1186 1.55386
R10717 VSS.n589 VSS.n1193 1.55386
R10718 VSS.n589 VSS.n1200 1.55386
R10719 VSS.n589 VSS.n1216 1.55386
R10720 VSS.n589 VSS.n1223 1.55386
R10721 VSS.n589 VSS.n1230 1.55386
R10722 VSS.n439 VSS.n2806 1.55386
R10723 VSS.n439 VSS.n2813 1.55386
R10724 VSS.n439 VSS.n2820 1.55386
R10725 VSS.n439 VSS.n2827 1.55386
R10726 VSS.n439 VSS.n2834 1.55386
R10727 VSS.n439 VSS.n2841 1.55386
R10728 VSS.n439 VSS.n2848 1.55386
R10729 VSS.n439 VSS.n2855 1.55386
R10730 VSS.n439 VSS.n2862 1.55386
R10731 VSS.n439 VSS.n2869 1.55386
R10732 VSS.n439 VSS.n2876 1.55386
R10733 VSS.n439 VSS.n2883 1.55386
R10734 VSS.n439 VSS.n2899 1.55386
R10735 VSS.n439 VSS.n2906 1.55386
R10736 VSS.n439 VSS.n2913 1.55386
R10737 VSS.n775 VSS.n855 1.5537
R10738 VSS.n775 VSS.n811 1.5537
R10739 VSS.n775 VSS.n963 1.55365
R10740 VSS.n775 VSS.n938 1.55365
R10741 VSS.n775 VSS.n897 1.55365
R10742 VSS.n1749 VSS.n1712 1.55365
R10743 VSS.n1749 VSS.n1704 1.55365
R10744 VSS.n1749 VSS.n1702 1.55365
R10745 VSS.n1749 VSS.n1698 1.55365
R10746 VSS.n1749 VSS.n1689 1.55365
R10747 VSS.n1749 VSS.n1687 1.55365
R10748 VSS.n775 VSS.n989 1.55363
R10749 VSS.n775 VSS.n924 1.55363
R10750 VSS.n1749 VSS.n1720 1.55363
R10751 VSS.n1749 VSS.n1714 1.55363
R10752 VSS.n1749 VSS.n1706 1.55363
R10753 VSS.n1749 VSS.n1700 1.55363
R10754 VSS.n775 VSS.n950 1.55363
R10755 VSS.n775 VSS.n910 1.55363
R10756 VSS.n775 VSS.n869 1.55363
R10757 VSS.n775 VSS.n784 1.55363
R10758 VSS.n1749 VSS.n1722 1.55363
R10759 VSS.n1749 VSS.n1716 1.55363
R10760 VSS.n1749 VSS.n1708 1.55363
R10761 VSS.n775 VSS.n970 1.55361
R10762 VSS.n1749 VSS.n1713 1.55361
R10763 VSS.n1749 VSS.n1705 1.55361
R10764 VSS.n1749 VSS.n1699 1.55361
R10765 VSS.n1749 VSS.n1690 1.55361
R10766 VSS.n775 VSS.n977 1.55358
R10767 VSS.n775 VSS.n882 1.55358
R10768 VSS.n775 VSS.n842 1.55358
R10769 VSS.n775 VSS.n798 1.55358
R10770 VSS.n1749 VSS.n1718 1.55358
R10771 VSS.n1749 VSS.n1691 1.55358
R10772 VSS.n775 VSS.n955 1.55354
R10773 VSS.n775 VSS.n944 1.55354
R10774 VSS.n775 VSS.n904 1.55354
R10775 VSS.n775 VSS.n875 1.55354
R10776 VSS.n775 VSS.n835 1.55354
R10777 VSS.n775 VSS.n791 1.55354
R10778 VSS.n1749 VSS.n1717 1.55354
R10779 VSS.n1749 VSS.n1703 1.55354
R10780 VSS.n1749 VSS.n1697 1.55354
R10781 VSS.n1749 VSS.n1688 1.55354
R10782 VSS.n244 VSS.n2074 1.55354
R10783 VSS.n244 VSS.n2095 1.55353
R10784 VSS.n244 VSS.n2091 1.55353
R10785 VSS.n244 VSS.n2088 1.55353
R10786 VSS.n244 VSS.n2084 1.55353
R10787 VSS.n244 VSS.n2081 1.55353
R10788 VSS.n244 VSS.n2077 1.55353
R10789 VSS.n244 VSS.n2070 1.55353
R10790 VSS.n244 VSS.n2067 1.55353
R10791 VSS.n244 VSS.n2063 1.55353
R10792 VSS.n244 VSS.n2060 1.55353
R10793 VSS.n244 VSS.n2056 1.55353
R10794 VSS.n244 VSS.n2053 1.55353
R10795 VSS.n244 VSS.n2049 1.55353
R10796 VSS.n244 VSS.n2046 1.55353
R10797 VSS.n244 VSS.n2042 1.55353
R10798 VSS.n244 VSS.n2039 1.55353
R10799 VSS.n244 VSS.n2035 1.55353
R10800 VSS.n244 VSS.n2032 1.55353
R10801 VSS.n244 VSS.n2024 1.55353
R10802 VSS.n244 VSS.n2020 1.55353
R10803 VSS.n244 VSS.n2017 1.55353
R10804 VSS.n244 VSS.n2013 1.55353
R10805 VSS.n244 VSS.n2010 1.55353
R10806 VSS.n244 VSS.n2006 1.55353
R10807 VSS.n244 VSS.n2003 1.55353
R10808 VSS.n244 VSS.n1999 1.55353
R10809 VSS.n244 VSS.n1996 1.55353
R10810 VSS.n244 VSS.n1992 1.55353
R10811 VSS.n244 VSS.n1989 1.55353
R10812 VSS.n775 VSS.n983 1.5535
R10813 VSS.n775 VSS.n889 1.5535
R10814 VSS.n775 VSS.n848 1.5535
R10815 VSS.n775 VSS.n804 1.5535
R10816 VSS.n1749 VSS.n1719 1.5535
R10817 VSS.n1749 VSS.n1692 1.5535
R10818 VSS.n582 VSS.n1779 1.55349
R10819 VSS.n582 VSS.n1815 1.55349
R10820 VSS.n775 VSS.n931 1.55347
R10821 VSS.n775 VSS.n862 1.55347
R10822 VSS.n775 VSS.n818 1.55347
R10823 VSS.n1749 VSS.n1721 1.55347
R10824 VSS.n1749 VSS.n1715 1.55347
R10825 VSS.n1749 VSS.n1707 1.55347
R10826 VSS.n1749 VSS.n1701 1.55347
R10827 VSS.n582 VSS.n1844 1.55347
R10828 VSS.n582 VSS.n1888 1.55347
R10829 VSS.n589 VSS.n1129 1.55345
R10830 VSS.n589 VSS.n1136 1.55345
R10831 VSS.n589 VSS.n1143 1.55345
R10832 VSS.n589 VSS.n1150 1.55345
R10833 VSS.n589 VSS.n1157 1.55345
R10834 VSS.n589 VSS.n1171 1.55345
R10835 VSS.n589 VSS.n1178 1.55345
R10836 VSS.n589 VSS.n1185 1.55345
R10837 VSS.n589 VSS.n1192 1.55345
R10838 VSS.n589 VSS.n1199 1.55345
R10839 VSS.n589 VSS.n1206 1.55345
R10840 VSS.n589 VSS.n1215 1.55345
R10841 VSS.n589 VSS.n1222 1.55345
R10842 VSS.n589 VSS.n1229 1.55345
R10843 VSS.n439 VSS.n2812 1.55345
R10844 VSS.n439 VSS.n2819 1.55345
R10845 VSS.n439 VSS.n2826 1.55345
R10846 VSS.n439 VSS.n2833 1.55345
R10847 VSS.n439 VSS.n2840 1.55345
R10848 VSS.n439 VSS.n2854 1.55345
R10849 VSS.n439 VSS.n2861 1.55345
R10850 VSS.n439 VSS.n2868 1.55345
R10851 VSS.n439 VSS.n2875 1.55345
R10852 VSS.n439 VSS.n2882 1.55345
R10853 VSS.n439 VSS.n2889 1.55345
R10854 VSS.n439 VSS.n2898 1.55345
R10855 VSS.n439 VSS.n2905 1.55345
R10856 VSS.n439 VSS.n2912 1.55345
R10857 VSS.n1749 VSS.n1598 1.55344
R10858 VSS.n582 VSS.n1786 1.55344
R10859 VSS.n582 VSS.n1825 1.55344
R10860 VSS.n582 VSS.n1838 1.55342
R10861 VSS.n582 VSS.n1859 1.55342
R10862 VSS.n1749 VSS.n1534 1.5534
R10863 VSS.n1749 VSS.n1614 1.5534
R10864 VSS.n582 VSS.n1801 1.55339
R10865 VSS.n582 VSS.n1832 1.55339
R10866 VSS.n582 VSS.n1853 1.55339
R10867 VSS.n582 VSS.n1876 1.55339
R10868 VSS.n1749 VSS.n1501 1.55339
R10869 VSS.n1749 VSS.n1550 1.55339
R10870 VSS.n1749 VSS.n1639 1.55339
R10871 VSS.n1749 VSS.n1461 1.55338
R10872 VSS.n1749 VSS.n1590 1.55338
R10873 VSS.n1749 VSS.n1663 1.55338
R10874 VSS.n589 VSS.n1114 1.55338
R10875 VSS.n589 VSS.n1113 1.55338
R10876 VSS.n589 VSS.n1112 1.55338
R10877 VSS.n589 VSS.n1111 1.55338
R10878 VSS.n589 VSS.n1110 1.55338
R10879 VSS.n589 VSS.n1109 1.55338
R10880 VSS.n589 VSS.n1105 1.55338
R10881 VSS.n589 VSS.n1104 1.55338
R10882 VSS.n589 VSS.n1103 1.55338
R10883 VSS.n589 VSS.n1102 1.55338
R10884 VSS.n589 VSS.n1101 1.55338
R10885 VSS.n589 VSS.n1100 1.55338
R10886 VSS.n589 VSS.n1099 1.55338
R10887 VSS.n589 VSS.n1098 1.55338
R10888 VSS.n589 VSS.n1097 1.55338
R10889 VSS.n589 VSS.n1096 1.55338
R10890 VSS.n589 VSS.n1095 1.55338
R10891 VSS.n589 VSS.n1094 1.55338
R10892 VSS.n589 VSS.n1090 1.55338
R10893 VSS.n589 VSS.n1089 1.55338
R10894 VSS.n589 VSS.n1088 1.55338
R10895 VSS.n589 VSS.n1087 1.55338
R10896 VSS.n589 VSS.n1086 1.55338
R10897 VSS.n589 VSS.n1085 1.55338
R10898 VSS.n589 VSS.n1084 1.55338
R10899 VSS.n589 VSS.n1083 1.55338
R10900 VSS.n589 VSS.n1082 1.55338
R10901 VSS.n589 VSS.n1081 1.55338
R10902 VSS.n589 VSS.n1080 1.55338
R10903 VSS.n1749 VSS.n1469 1.55338
R10904 VSS.n1749 VSS.n1477 1.55338
R10905 VSS.n1749 VSS.n1526 1.55338
R10906 VSS.n1749 VSS.n1606 1.55338
R10907 VSS.n1749 VSS.n1671 1.55338
R10908 VSS.n582 VSS.t788 1.55338
R10909 VSS.n582 VSS.t1228 1.55338
R10910 VSS.n582 VSS.t1301 1.55338
R10911 VSS.n582 VSS.n1795 1.55337
R10912 VSS.n775 VSS.n767 1.55337
R10913 VSS.n775 VSS.n764 1.55337
R10914 VSS.n775 VSS.n762 1.55337
R10915 VSS.n775 VSS.n760 1.55337
R10916 VSS.n775 VSS.n759 1.55337
R10917 VSS.n775 VSS.n753 1.55337
R10918 VSS.n775 VSS.n751 1.55337
R10919 VSS.n775 VSS.n744 1.55337
R10920 VSS.n775 VSS.n741 1.55337
R10921 VSS.n775 VSS.n739 1.55337
R10922 VSS.n775 VSS.n737 1.55337
R10923 VSS.n775 VSS.n736 1.55337
R10924 VSS.n775 VSS.n734 1.55337
R10925 VSS.n775 VSS.n731 1.55337
R10926 VSS.n775 VSS.n729 1.55337
R10927 VSS.n775 VSS.n722 1.55337
R10928 VSS.n775 VSS.n712 1.55337
R10929 VSS.n775 VSS.n709 1.55337
R10930 VSS.n775 VSS.n707 1.55337
R10931 VSS.n775 VSS.n697 1.55337
R10932 VSS.n439 VSS.n1379 1.55337
R10933 VSS.n439 VSS.n1378 1.55337
R10934 VSS.n439 VSS.n1377 1.55337
R10935 VSS.n439 VSS.n1376 1.55337
R10936 VSS.n439 VSS.n1371 1.55337
R10937 VSS.n439 VSS.n1370 1.55337
R10938 VSS.n439 VSS.n1369 1.55337
R10939 VSS.n439 VSS.n1368 1.55337
R10940 VSS.n439 VSS.n1365 1.55337
R10941 VSS.n439 VSS.n1364 1.55337
R10942 VSS.n439 VSS.n1363 1.55337
R10943 VSS.n439 VSS.n1356 1.55337
R10944 VSS.n439 VSS.n1355 1.55337
R10945 VSS.n439 VSS.n1351 1.55337
R10946 VSS.n439 VSS.n1350 1.55337
R10947 VSS.n439 VSS.n1349 1.55337
R10948 VSS.n1749 VSS.n1436 1.55337
R10949 VSS.n1749 VSS.n1444 1.55337
R10950 VSS.n1749 VSS.n1565 1.55337
R10951 VSS.n1749 VSS.n1573 1.55337
R10952 VSS.n1749 VSS.n1646 1.55337
R10953 VSS.n1749 VSS.n1654 1.55337
R10954 VSS.n582 VSS.n1808 1.55336
R10955 VSS.n582 VSS.n1882 1.55336
R10956 VSS.n582 VSS.t1276 1.55336
R10957 VSS.n1749 VSS.n1485 1.55335
R10958 VSS.n1749 VSS.n1493 1.55335
R10959 VSS.n1749 VSS.n1542 1.55335
R10960 VSS.n1749 VSS.n1631 1.55335
R10961 VSS.n582 VSS.t1493 1.55333
R10962 VSS.n1749 VSS.n1428 1.55333
R10963 VSS.n1749 VSS.n1508 1.55333
R10964 VSS.n1749 VSS.n1557 1.55333
R10965 VSS.n1749 VSS.n1451 1.55332
R10966 VSS.n1749 VSS.n1580 1.55332
R10967 VSS.n582 VSS.t1498 1.55331
R10968 VSS.n582 VSS.t2268 1.55331
R10969 VSS.n775 VSS.n770 1.55328
R10970 VSS.n775 VSS.n748 1.55328
R10971 VSS.n775 VSS.n747 1.55328
R10972 VSS.n775 VSS.n720 1.55328
R10973 VSS.n775 VSS.n718 1.55328
R10974 VSS.n775 VSS.n714 1.55328
R10975 VSS.n775 VSS.n705 1.55328
R10976 VSS.n775 VSS.n703 1.55328
R10977 VSS.n775 VSS.n699 1.55328
R10978 VSS.n439 VSS.n1380 1.55328
R10979 VSS.n439 VSS.n1375 1.55328
R10980 VSS.n439 VSS.n1367 1.55328
R10981 VSS.n439 VSS.n1366 1.55328
R10982 VSS.n439 VSS.n1362 1.55328
R10983 VSS.n439 VSS.n1361 1.55328
R10984 VSS.n439 VSS.n1360 1.55328
R10985 VSS.n439 VSS.n1354 1.55328
R10986 VSS.n439 VSS.n1353 1.55328
R10987 VSS.n439 VSS.n1352 1.55328
R10988 VSS.n439 VSS.n1348 1.55328
R10989 VSS.n439 VSS.n1347 1.55328
R10990 VSS.n439 VSS.n1346 1.55328
R10991 VSS.n582 VSS.t1756 1.55327
R10992 VSS.n582 VSS.t1964 1.55327
R10993 VSS.n582 VSS.t2044 1.55327
R10994 VSS.n582 VSS.t792 1.55327
R10995 VSS.n582 VSS.t1356 1.55327
R10996 VSS.n582 VSS.t1702 1.55324
R10997 VSS.n582 VSS.t1169 1.55324
R10998 VSS.n3018 VSS.n675 1.54175
R10999 VSS.n1747 VSS.n1416 1.54175
R11000 VSS.n2725 VSS.n2724 1.54175
R11001 VSS.n3001 VSS.n3000 1.54175
R11002 VSS.n2793 VSS.n2792 1.54175
R11003 VSS.n2696 VSS.t1566 1.43372
R11004 VSS.n2694 VSS.t1564 1.43372
R11005 VSS.n2141 VSS.t1564 1.42949
R11006 VSS.n2139 VSS.t1566 1.42949
R11007 VSS.t2297 VSS.t2300 1.41892
R11008 VSS.t2295 VSS.t2299 1.41892
R11009 VSS.t2293 VSS.t2298 1.41892
R11010 VSS.t2291 VSS.t2290 1.41892
R11011 VSS.n2147 VSS.t1561 1.37661
R11012 VSS.t1561 VSS.n2153 1.37661
R11013 VSS.n1749 VSS.n1683 1.35632
R11014 VSS.n775 VSS.n772 1.35591
R11015 VSS.t918 VSS.t542 1.34782
R11016 VSS.t331 VSS.t37 0.403514
R11017 VSS.t122 VSS.t24 0.403514
R11018 VSS.t2 VSS.t27 0.403514
R11019 VSS.n544 VSS.n2691 1.27788
R11020 VSS.t1697 VSS.t1695 1.25614
R11021 VSS.n544 VSS.n2665 1.24515
R11022 VSS.n2608 VSS.t561 1.24155
R11023 VSS.t542 VSS.t560 1.21479
R11024 VSS.t1669 VSS.t1671 1.18105
R11025 VSS.t1671 VSS.t1673 1.18033
R11026 VSS.t1677 VSS.t1679 1.16698
R11027 VSS.t1695 VSS.t1693 1.16468
R11028 VSS.t561 VSS.t1667 1.15657
R11029 VSS.t1675 VSS.t1677 1.15134
R11030 VSS.t1687 VSS.t1685 1.14864
R11031 VSS.t1685 VSS.t1683 1.13816
R11032 VSS.n2534 VSS.t820 1.13095
R11033 VSS.t1691 VSS.t1689 1.12987
R11034 VSS.t1667 VSS.t1669 1.12751
R11035 VSS.n2128 VSS.t39 1.12123
R11036 VSS.t820 VSS.n282 0.0941006
R11037 VSS.t1689 VSS.t1687 1.09781
R11038 VSS.t122 VSS.t207 0.406681
R11039 VSS.t623 VSS.n59 0.587219
R11040 VSS.t232 VSS.n250 0.943197
R11041 VSS.t147 VSS.n302 0.943197
R11042 VSS.t731 VSS.t1476 1.06241
R11043 VSS.t1707 VSS.t8 1.06241
R11044 VSS.t1373 VSS.t949 1.06241
R11045 VSS.t1220 VSS.t1143 1.06241
R11046 VSS.t122 VSS.n11 0.616127
R11047 VSS.n10 VSS.t951 0.11835
R11048 VSS.n9 VSS.t2123 0.11835
R11049 VSS.t122 VSS.t5 0.43657
R11050 VSS.n2665 VSS.n2664 1.02769
R11051 VSS.t122 VSS.t193 0.419127
R11052 VSS.t331 VSS.t310 0.419127
R11053 VSS.t2 VSS.t357 0.419127
R11054 VSS.n2608 VSS.t1185 1.02273
R11055 VSS.t766 VSS.n332 0.031668
R11056 VSS.n13 VSS.t218 0.241639
R11057 VSS.n14 VSS.t336 0.241564
R11058 VSS.t2 VSS.n12 0.337246
R11059 VSS.n244 VSS.n1906 1.00384
R11060 VSS.n244 VSS.n2096 1.00384
R11061 VSS.n244 VSS.n2089 1.00384
R11062 VSS.n244 VSS.n2082 1.00384
R11063 VSS.n244 VSS.n2075 1.00384
R11064 VSS.n244 VSS.n2068 1.00384
R11065 VSS.n244 VSS.n2061 1.00384
R11066 VSS.n244 VSS.n2054 1.00384
R11067 VSS.n244 VSS.n2047 1.00384
R11068 VSS.n244 VSS.n2040 1.00384
R11069 VSS.n244 VSS.n2033 1.00384
R11070 VSS.n244 VSS.n2025 1.00384
R11071 VSS.n244 VSS.n2018 1.00384
R11072 VSS.n244 VSS.n2011 1.00384
R11073 VSS.n244 VSS.n2004 1.00384
R11074 VSS.n244 VSS.n1997 1.00384
R11075 VSS.n244 VSS.n1990 1.00384
R11076 VSS.n582 VSS.n1781 1.00384
R11077 VSS.n582 VSS.n1782 1.00384
R11078 VSS.n582 VSS.n1784 1.00384
R11079 VSS.n582 VSS.n1785 1.00384
R11080 VSS.n582 VSS.n1787 1.00384
R11081 VSS.n582 VSS.n1788 1.00384
R11082 VSS.n582 VSS.n1789 1.00384
R11083 VSS.n582 VSS.n1791 1.00384
R11084 VSS.n582 VSS.n1792 1.00384
R11085 VSS.n582 VSS.n1793 1.00384
R11086 VSS.n582 VSS.n1794 1.00384
R11087 VSS.n582 VSS.n1796 1.00384
R11088 VSS.n582 VSS.n1798 1.00384
R11089 VSS.n582 VSS.n1799 1.00384
R11090 VSS.n582 VSS.n1800 1.00384
R11091 VSS.n582 VSS.n1802 1.00384
R11092 VSS.n582 VSS.n1803 1.00384
R11093 VSS.n582 VSS.n1805 1.00384
R11094 VSS.n582 VSS.n1806 1.00384
R11095 VSS.n582 VSS.n1807 1.00384
R11096 VSS.n582 VSS.n1809 1.00384
R11097 VSS.n582 VSS.n1810 1.00384
R11098 VSS.n582 VSS.n1812 1.00384
R11099 VSS.n582 VSS.n1813 1.00384
R11100 VSS.n582 VSS.n1814 1.00384
R11101 VSS.n582 VSS.n1816 1.00384
R11102 VSS.n582 VSS.n1817 1.00384
R11103 VSS.n582 VSS.n1819 1.00384
R11104 VSS.n582 VSS.n1820 1.00384
R11105 VSS.n582 VSS.n1822 1.00384
R11106 VSS.n582 VSS.n1824 1.00384
R11107 VSS.n582 VSS.n1826 1.00384
R11108 VSS.n582 VSS.n1828 1.00384
R11109 VSS.n582 VSS.n1829 1.00384
R11110 VSS.n582 VSS.n1830 1.00384
R11111 VSS.n582 VSS.n1831 1.00384
R11112 VSS.n582 VSS.n1833 1.00384
R11113 VSS.n582 VSS.n1835 1.00384
R11114 VSS.n582 VSS.n1836 1.00384
R11115 VSS.n582 VSS.n1837 1.00384
R11116 VSS.n582 VSS.n1839 1.00384
R11117 VSS.n582 VSS.n1840 1.00384
R11118 VSS.n582 VSS.n1842 1.00384
R11119 VSS.n582 VSS.n1843 1.00384
R11120 VSS.n582 VSS.n1845 1.00384
R11121 VSS.n582 VSS.n1846 1.00384
R11122 VSS.n582 VSS.n1847 1.00384
R11123 VSS.n582 VSS.n1849 1.00384
R11124 VSS.n582 VSS.n1850 1.00384
R11125 VSS.n582 VSS.n1851 1.00384
R11126 VSS.n582 VSS.n1852 1.00384
R11127 VSS.n582 VSS.n1854 1.00384
R11128 VSS.n582 VSS.n1856 1.00384
R11129 VSS.n582 VSS.n1857 1.00384
R11130 VSS.n582 VSS.n1858 1.00384
R11131 VSS.n582 VSS.n1860 1.00384
R11132 VSS.n582 VSS.n1861 1.00384
R11133 VSS.n582 VSS.n1863 1.00384
R11134 VSS.n582 VSS.n1864 1.00384
R11135 VSS.n582 VSS.n1866 1.00384
R11136 VSS.n582 VSS.n1867 1.00384
R11137 VSS.n582 VSS.n1868 1.00384
R11138 VSS.n582 VSS.n1870 1.00384
R11139 VSS.n582 VSS.n1873 1.00384
R11140 VSS.n582 VSS.n1874 1.00384
R11141 VSS.n582 VSS.n1875 1.00384
R11142 VSS.n582 VSS.n1877 1.00384
R11143 VSS.n582 VSS.n1879 1.00384
R11144 VSS.n582 VSS.n1880 1.00384
R11145 VSS.n582 VSS.n1881 1.00384
R11146 VSS.n582 VSS.n1883 1.00384
R11147 VSS.n582 VSS.n1884 1.00384
R11148 VSS.n582 VSS.n1886 1.00384
R11149 VSS.n582 VSS.n1887 1.00384
R11150 VSS.n582 VSS.n1889 1.00384
R11151 VSS.n582 VSS.n1890 1.00384
R11152 VSS.n582 VSS.n1891 1.00384
R11153 VSS.n582 VSS.n1893 1.00384
R11154 VSS.n582 VSS.n1895 1.00384
R11155 VSS.n582 VSS.n1898 1.00384
R11156 VSS.t1476 VSS.t766 1.00366
R11157 VSS.n2732 VSS.n492 1.0743
R11158 VSS.t122 VSS.t1707 0.408735
R11159 VSS.t331 VSS.t1373 0.408735
R11160 VSS.t2 VSS.t1220 0.411123
R11161 VSS.n260 VSS.n257 0.967179
R11162 VSS.n259 VSS.n264 0.967179
R11163 VSS.n259 VSS.n262 0.967179
R11164 VSS.n259 VSS.n263 0.967179
R11165 VSS.n268 VSS.n266 0.967179
R11166 VSS.n267 VSS.n270 0.967179
R11167 VSS.n259 VSS.n261 0.965685
R11168 VSS.t427 VSS.t731 0.965284
R11169 VSS.t299 VSS.n301 0.831434
R11170 VSS.n82 VSS.t1473 0.137762
R11171 VSS.t1681 VSS.n2099 0.945288
R11172 VSS.t1693 VSS.n2776 0.940049
R11173 VSS.n2610 VSS.n559 0.927587
R11174 VSS.t563 VSS.n7 0.25868
R11175 VSS.n5 VSS.t2 0.316919
R11176 VSS.t1679 VSS.n2099 0.893792
R11177 VSS.n2128 VSS.n2132 0.885254
R11178 VSS.n2776 VSS.t1691 0.883349
R11179 VSS.n2733 VSS.n2732 0.881792
R11180 VSS.n2711 VSS.n2710 0.881792
R11181 VSS.t331 VSS.t303 0.43657
R11182 VSS.t2 VSS.t350 0.43657
R11183 VSS.t1683 VSS.n2775 0.85539
R11184 VSS.n2772 VSS.n559 0.851
R11185 VSS.n2613 VSS.n25 0.8471
R11186 VSS.n677 VSS.n775 0.8471
R11187 VSS.n1040 VSS.n32 0.8471
R11188 VSS.n1749 VSS.n1417 0.847095
R11189 VSS.n439 VSS.t1095 0.847022
R11190 VSS.n5 VSS.t1132 0.879173
R11191 VSS.n589 VSS.n1071 0.847021
R11192 VSS.n6 VSS.t21 0.879173
R11193 VSS.n775 VSS.t94 0.847018
R11194 VSS.n589 VSS.t1166 0.847018
R11195 VSS.n1749 VSS.t1279 0.846989
R11196 VSS.n582 VSS.t703 0.846961
R11197 VSS.n439 VSS.n1384 0.84688
R11198 VSS.n582 VSS.n1760 0.84687
R11199 VSS.n2612 VSS.t771 0.837563
R11200 VSS.n1039 VSS.t18 0.837563
R11201 VSS.n2775 VSS.t1682 0.831292
R11202 VSS.n2612 VSS.t715 0.821725
R11203 VSS.n1039 VSS.t176 0.821725
R11204 VSS.t1538 VSS.t1540 0.806856
R11205 VSS.t1127 VSS.t1584 0.806855
R11206 VSS.n2758 VSS.t1572 0.806855
R11207 VSS.t1578 VSS.n2109 0.806855
R11208 VSS.t1232 VSS.t1550 0.806855
R11209 VSS.t1509 VSS.t1596 0.806855
R11210 VSS.t1845 VSS.t1609 0.806855
R11211 VSS.t561 VSS.n2609 0.805602
R11212 VSS.t932 VSS.t980 0.802775
R11213 VSS.t554 VSS.t629 0.802775
R11214 VSS.t1140 VSS.t891 0.802775
R11215 VSS.t134 VSS.t478 0.802775
R11216 VSS.t1503 VSS.t1111 0.802775
R11217 VSS.t1627 VSS.t1041 0.802775
R11218 VSS.t97 VSS.t160 0.802775
R11219 VSS.t998 VSS.t136 0.802775
R11220 VSS.t139 VSS.t552 0.802775
R11221 VSS.t707 VSS.t90 0.802775
R11222 VSS.t548 VSS.t755 0.802775
R11223 VSS.t1010 VSS.t570 0.802775
R11224 VSS.n2894 VSS.t1312 0.802775
R11225 VSS.t109 VSS.t519 0.802775
R11226 VSS.t954 VSS.t1098 0.802775
R11227 VSS.t45 VSS.t1736 0.802775
R11228 VSS.t1812 VSS.t1591 0.802775
R11229 VSS.t1081 VSS.t825 0.802775
R11230 VSS.t1076 VSS.t1023 0.802775
R11231 VSS.t1323 VSS.t107 0.802775
R11232 VSS.t798 VSS.t864 0.802775
R11233 VSS.t1389 VSS.t103 0.802775
R11234 VSS.t92 VSS.t113 0.802775
R11235 VSS.t550 VSS.t705 0.802775
R11236 VSS.t1052 VSS.t10 0.802775
R11237 VSS.t158 VSS.t1000 0.802775
R11238 VSS.t1057 VSS.t99 0.802775
R11239 VSS.t1109 VSS.t858 0.802775
R11240 VSS.t1003 VSS.t871 0.802775
R11241 VSS.t1384 VSS.t1349 0.802775
R11242 VSS.t985 VSS.t1292 0.802775
R11243 VSS.t982 VSS.t602 0.802775
R11244 VSS.t709 VSS.t16 0.802775
R11245 VSS.t2196 VSS.n2112 0.802775
R11246 VSS.t1557 VSS.t2259 0.802775
R11247 VSS.t566 VSS.t1368 0.802775
R11248 VSS.t1071 VSS.t2038 0.802775
R11249 VSS.t1365 VSS.t1362 0.802775
R11250 VSS.t509 VSS.t1742 0.802775
R11251 VSS.t117 VSS.t583 0.802775
R11252 VSS.t74 VSS.t1719 0.802775
R11253 VSS.t1358 VSS.n1872 0.802775
R11254 VSS.t593 VSS.t1762 0.802775
R11255 VSS.t1226 VSS.t580 0.802775
R11256 VSS.t578 VSS.t2058 0.802775
R11257 VSS.t1176 VSS.t1997 0.802775
R11258 VSS.t1431 VSS.t1710 0.802775
R11259 VSS.t794 VSS.t834 0.802775
R11260 VSS.t832 VSS.t2049 0.802775
R11261 VSS.t790 VSS.t2069 0.802775
R11262 VSS.t126 VSS.t1338 0.802775
R11263 VSS.t830 VSS.t968 0.802775
R11264 VSS.t911 VSS.t1716 0.802775
R11265 VSS.t1224 VSS.t1989 0.802775
R11266 VSS.t1288 VSS.t1759 0.802775
R11267 VSS.t696 VSS.t1470 0.802775
R11268 VSS.t1468 VSS.t2055 0.802775
R11269 VSS.t1274 VSS.t1286 0.802775
R11270 VSS.t866 VSS.t1713 0.802775
R11271 VSS.t762 VSS.t1341 0.802775
R11272 VSS.t105 VSS.t2052 0.802775
R11273 VSS.t757 VSS.t1957 0.802775
R11274 VSS.t115 VSS.t1745 0.802775
R11275 VSS.t753 VSS.t976 0.802775
R11276 VSS.t869 VSS.t2041 0.802775
R11277 VSS.t1162 VSS.t1178 0.802775
R11278 VSS.t875 VSS.t1335 0.802775
R11279 VSS.t1283 VSS.t786 0.802775
R11280 VSS.t1317 VSS.t627 0.802775
R11281 VSS.t85 VSS.t885 0.802775
R11282 VSS.t1834 VSS.t524 0.802775
R11283 VSS.t467 VSS.t956 0.802775
R11284 VSS.t1447 VSS.t1100 0.802775
R11285 VSS.t1518 VSS.t608 0.802775
R11286 VSS.t610 VSS.t488 0.802775
R11287 VSS.t490 VSS.t492 0.802775
R11288 VSS.t1153 VSS.t1455 0.802775
R11289 VSS.t898 VSS.t862 0.802775
R11290 VSS.t1452 VSS.t1043 0.802775
R11291 VSS.t882 VSS.t1406 0.802775
R11292 VSS.t1409 VSS.t612 0.802775
R11293 VSS.t1086 VSS.t1332 0.802775
R11294 VSS.t1415 VSS.t527 0.802775
R11295 VSS.t1047 VSS.t649 0.802775
R11296 VSS.t1412 VSS.t495 0.802775
R11297 VSS.t745 VSS.t958 0.802775
R11298 VSS.t1157 VSS.t1750 0.802775
R11299 VSS.t1021 VSS.t1073 0.802775
R11300 VSS.t1774 VSS.t568 0.802775
R11301 VSS.t901 VSS.t2157 0.802775
R11302 VSS.t1970 VSS.t1699 0.802775
R11303 VSS.t476 VSS.t659 0.802775
R11304 VSS.n1694 VSS.t119 0.802775
R11305 VSS.t895 VSS.t1008 0.802775
R11306 VSS.t2008 VSS.t961 0.802775
R11307 VSS.t522 VSS.t1529 0.802775
R11308 VSS.t2004 VSS.t748 0.802775
R11309 VSS.t82 VSS.t1215 0.802775
R11310 VSS.t1217 VSS.t2278 0.802775
R11311 VSS.t470 VSS.t1546 0.802775
R11312 VSS.t69 VSS.t152 0.802775
R11313 VSS.t502 VSS.t486 0.802775
R11314 VSS.t1886 VSS.t1016 0.802775
R11315 VSS.t154 VSS.t538 0.802775
R11316 VSS.t930 VSS.t101 0.802775
R11317 VSS.t143 VSS.t1026 0.802775
R11318 VSS.t778 VSS.t723 0.802775
R11319 VSS.t534 VSS.t163 0.802775
R11320 VSS.t482 VSS.t889 0.802775
R11321 VSS.t1889 VSS.t132 0.802775
R11322 VSS.t1089 VSS.t913 0.802775
R11323 VSS.t1772 VSS.t1092 0.802775
R11324 VSS.n1211 VSS.t111 0.802775
R11325 VSS.t991 VSS.t618 0.802775
R11326 VSS.t1793 VSS.t1250 0.802775
R11327 VSS.t2073 VSS.t2032 0.802775
R11328 VSS.t52 VSS.t1605 0.802775
R11329 VSS.t1252 VSS.t1500 0.802775
R11330 VSS.t64 VSS.t1822 0.802775
R11331 VSS.t1203 VSS.t989 0.802775
R11332 VSS.t58 VSS.t937 0.802775
R11333 VSS.t1426 VSS.t29 0.802775
R11334 VSS.t167 VSS.t915 0.802775
R11335 VSS.t925 VSS.t2231 0.802775
R11336 VSS.t61 VSS.t480 0.802775
R11337 VSS.t1182 VSS.t536 0.802775
R11338 VSS.t2028 VSS.t780 0.802775
R11339 VSS.t1106 VSS.t141 0.802775
R11340 VSS.t540 VSS.t124 0.802775
R11341 VSS.t1018 VSS.t156 0.802775
R11342 VSS.t49 VSS.t802 0.802775
R11343 VSS.t1117 VSS.t1195 0.802775
R11344 VSS.t1259 VSS.t87 0.802775
R11345 VSS.t667 VSS.t1871 0.802775
R11346 VSS.t605 VSS.t556 0.802775
R11347 VSS.t678 VSS.t1268 0.802775
R11348 VSS.t178 VSS.t2137 0.802775
R11349 VSS.t681 VSS.t1968 0.802775
R11350 VSS.t544 VSS.t79 0.802775
R11351 VSS.t635 VSS.t742 0.802775
R11352 VSS.t1535 VSS.t506 0.802775
R11353 VSS.t504 VSS.t1932 0.802775
R11354 VSS.t1801 VSS.t782 0.802775
R11355 VSS.t638 VSS.t837 0.802775
R11356 VSS.t816 VSS.t1014 0.802775
R11357 VSS.t662 VSS.t796 0.802775
R11358 VSS.t41 VSS.t1029 0.802775
R11359 VSS.t644 VSS.t72 0.802775
R11360 VSS.t1345 VSS.t849 0.802775
R11361 VSS.t670 VSS.t974 0.802775
R11362 VSS.t600 VSS.t585 0.802775
R11363 VSS.t632 VSS.t587 0.802775
R11364 VSS.t1138 VSS.t1067 0.802775
R11365 VSS.t673 VSS.t511 0.802775
R11366 VSS.t735 VSS.t1860 0.802775
R11367 VSS.t641 VSS.t1264 0.802775
R11368 VSS.t1147 VSS.t517 0.802775
R11369 VSS.t515 VSS.t513 0.802775
R11370 VSS.n828 VSS.t591 0.802775
R11371 VSS.t647 VSS.t1375 0.802775
R11372 VSS.t1377 VSS.t1083 0.802775
R11373 VSS.t694 VSS.t595 0.802775
R11374 VSS.t180 VSS.t1230 0.802775
R11375 VSS.t1434 VSS.t1487 0.802775
R11376 VSS.t130 VSS.t128 0.802775
R11377 VSS.t684 VSS.t1616 0.802775
R11378 VSS.n2664 VSS.n2100 0.794865
R11379 VSS.t240 VSS.n254 0.773797
R11380 VSS.n312 VSS.t408 0.677932
R11381 VSS.n322 VSS.t420 0.677932
R11382 VSS.n336 VSS.t443 0.677932
R11383 VSS.t122 VSS.n13 0.337664
R11384 VSS.t331 VSS.n14 0.33766
R11385 VSS.n249 VSS.n2298 0.789314
R11386 VSS.n1025 VSS.n78 0.789156
R11387 VSS.t331 VSS.t324 0.406681
R11388 VSS.t2 VSS.t371 0.406681
R11389 VSS.n2609 VSS.n2101 0.768682
R11390 VSS.n2232 VSS.t941 0.735974
R11391 VSS.t1680 VSS.n2353 0.735974
R11392 VSS.t529 VSS.n2128 0.728354
R11393 VSS.n2918 VSS.t1592 0.723599
R11394 VSS.t1593 VSS.t1595 0.723599
R11395 VSS.t1558 VSS.n1904 0.723599
R11396 VSS.n1901 VSS.t1559 0.723599
R11397 VSS.n1685 VSS.t1547 0.723599
R11398 VSS.t1606 VSS.t1608 0.723599
R11399 VSS.t1604 VSS.n1067 0.723599
R11400 VSS.n777 VSS.t1617 0.723599
R11401 VSS.n265 VSS.t250 0.773011
R11402 VSS.n290 VSS.t276 0.773011
R11403 VSS.n2704 VSS.t2297 0.722582
R11404 VSS.n2706 VSS.t2295 0.722582
R11405 VSS.n2708 VSS.t2293 0.722582
R11406 VSS.n2710 VSS.t2291 0.722582
R11407 VSS.n2739 VSS.t2300 0.72222
R11408 VSS.n2737 VSS.t2299 0.72222
R11409 VSS.n2735 VSS.t2298 0.72222
R11410 VSS.n2733 VSS.t2290 0.72222
R11411 VSS.n1740 VSS.t1279 0.71221
R11412 VSS.t67 VSS.t1166 0.711103
R11413 VSS.t935 VSS.t94 0.711103
R11414 VSS.t1095 VSS.t14 0.710836
R11415 VSS.t703 VSS.t76 0.710782
R11416 VSS.t340 VSS.n14 0.8951
R11417 VSS.n13 VSS.t222 0.895001
R11418 VSS.t385 VSS.n12 0.895419
R11419 VSS.n1025 VSS.t455 0.705803
R11420 VSS.n2298 VSS.t292 0.705608
R11421 VSS.n2769 VSS.n2768 0.6955
R11422 VSS.t771 VSS.n2613 0.691359
R11423 VSS.n677 VSS.t768 0.691359
R11424 VSS.t18 VSS.n1040 0.691359
R11425 VSS.t1806 VSS.n1417 0.691051
R11426 VSS.n6 VSS.t2081 0.258334
R11427 VSS.n1071 VSS.t499 0.69004
R11428 VSS.n5 VSS.t2094 0.258334
R11429 VSS.t701 VSS.n1760 0.689942
R11430 VSS.t1630 VSS.n1384 0.689807
R11431 VSS.n2610 VSS.t1675 0.689282
R11432 VSS.t1095 VSS.t1630 0.686143
R11433 VSS.t701 VSS.t703 0.6861
R11434 VSS.t1166 VSS.t499 0.685835
R11435 VSS.t94 VSS.t768 0.685835
R11436 VSS.t1279 VSS.t1806 0.684793
R11437 VSS.t918 VSS.t31 0.661453
R11438 VSS.n2609 VSS.n559 0.649291
R11439 VSS.t922 VSS.t918 0.644023
R11440 VSS.n1384 VSS.t1400 0.640672
R11441 VSS.n1760 VSS.t2279 0.640535
R11442 VSS.n1071 VSS.t945 0.640485
R11443 VSS.t774 VSS.n1417 0.639568
R11444 VSS.n2613 VSS.t169 0.639194
R11445 VSS.n677 VSS.t2090 0.639194
R11446 VSS.n1040 VSS.t1636 0.639194
R11447 VSS.n7 VSS.t34 0.878224
R11448 VSS.n2800 VSS.n25 0.631585
R11449 VSS.n2677 VSS.n25 0.631585
R11450 VSS.n2681 VSS.n25 0.631585
R11451 VSS.n2702 VSS.n2136 0.630114
R11452 VSS.n265 VSS.n259 0.532775
R11453 VSS.n289 VSS.n290 0.532775
R11454 VSS.n254 VSS.n16 0.532543
R11455 VSS.t404 VSS.n312 0.773797
R11456 VSS.t416 VSS.n322 0.773797
R11457 VSS.t439 VSS.n336 0.773797
R11458 VSS.n1057 VSS.n32 0.613782
R11459 VSS.n1054 VSS.n32 0.613782
R11460 VSS.n1049 VSS.n32 0.613782
R11461 VSS.n1046 VSS.n32 0.613782
R11462 VSS.n1044 VSS.n32 0.613782
R11463 VSS.n1041 VSS.n32 0.613782
R11464 VSS.n1036 VSS.n44 0.613782
R11465 VSS.n1033 VSS.n41 0.613782
R11466 VSS.n1029 VSS.n47 0.613782
R11467 VSS.n68 VSS.n47 0.547873
R11468 VSS.n1028 VSS.n19 0.613782
R11469 VSS.t450 VSS.n76 56.6955
R11470 VSS.n87 VSS.n83 0.613782
R11471 VSS.t1673 VSS.n2610 0.613
R11472 VSS.t1588 VSS.n2993 0.595317
R11473 VSS.t1586 VSS.n2992 0.595317
R11474 VSS.t1574 VSS.n2117 0.595317
R11475 VSS.n2116 VSS.t1577 0.595317
R11476 VSS.t1580 VSS.n2107 0.595317
R11477 VSS.n2106 VSS.t1583 0.595317
R11478 VSS.t1554 VSS.n1778 0.595317
R11479 VSS.t1552 VSS.n1777 0.595317
R11480 VSS.t1543 VSS.n1725 0.595317
R11481 VSS.t1541 VSS.n1724 0.595317
R11482 VSS.t1601 VSS.n1305 0.595317
R11483 VSS.t1598 VSS.n1304 0.595317
R11484 VSS.t1613 VSS.n1000 0.595317
R11485 VSS.t1611 VSS.n999 0.595317
R11486 VSS.t382 VSS.n12 0.241873
R11487 VSS.n2298 VSS.t288 0.564737
R11488 VSS.t451 VSS.n1025 0.564456
R11489 VSS.t529 VSS.n468 0.557126
R11490 VSS.n775 VSS.n690 0.556788
R11491 VSS.n589 VSS.n590 0.556788
R11492 VSS.n439 VSS.n349 0.556788
R11493 VSS.n582 VSS.n574 0.556788
R11494 VSS.n1749 VSS.n1746 0.556788
R11495 VSS.n2732 VSS.n529 0.556483
R11496 VSS.n2711 VSS.n504 0.556483
R11497 VSS.n2775 VSS.n442 0.554136
R11498 VSS.n2612 VSS.n25 0.553637
R11499 VSS.n1039 VSS.n32 0.553637
R11500 VSS.n2614 VSS.n25 0.515438
R11501 VSS.t331 VSS.n2 0.515438
R11502 VSS.n31 VSS.t950 154.915
R11503 VSS.t122 VSS.n0 0.515438
R11504 VSS.t122 VSS.n1 0.462537
R11505 VSS.t2 VSS.n3 0.515438
R11506 VSS.n27 VSS.t2122 154.915
R11507 VSS.n2099 VSS.n559 0.513615
R11508 VSS.n2608 VSS.t542 0.506033
R11509 VSS.t1566 VSS.t1564 0.492336
R11510 VSS.n2560 VSS.t265 0.479217
R11511 VSS.n2074 VSS.t593 0.47828
R11512 VSS.n2095 VSS.t1071 0.478238
R11513 VSS.n2091 VSS.t1365 0.478238
R11514 VSS.n2088 VSS.t509 0.478238
R11515 VSS.n2084 VSS.t117 0.478238
R11516 VSS.n2081 VSS.t74 0.478238
R11517 VSS.n2077 VSS.t1358 0.478238
R11518 VSS.n2070 VSS.t1226 0.478238
R11519 VSS.n2067 VSS.t578 0.478238
R11520 VSS.n2063 VSS.t1176 0.478238
R11521 VSS.n2060 VSS.t1431 0.478238
R11522 VSS.n2056 VSS.t794 0.478238
R11523 VSS.n2053 VSS.t832 0.478238
R11524 VSS.n2049 VSS.t790 0.478238
R11525 VSS.n2046 VSS.t126 0.478238
R11526 VSS.n2042 VSS.t830 0.478238
R11527 VSS.n2039 VSS.t911 0.478238
R11528 VSS.n2035 VSS.t1224 0.478238
R11529 VSS.n2032 VSS.t1288 0.478238
R11530 VSS.n2024 VSS.t1468 0.478238
R11531 VSS.n2020 VSS.t1274 0.478238
R11532 VSS.n2017 VSS.t866 0.478238
R11533 VSS.n2013 VSS.t762 0.478238
R11534 VSS.n2010 VSS.t105 0.478238
R11535 VSS.n2006 VSS.t757 0.478238
R11536 VSS.n2003 VSS.t115 0.478238
R11537 VSS.n1999 VSS.t753 0.478238
R11538 VSS.n1996 VSS.t869 0.478238
R11539 VSS.n1992 VSS.t1162 0.478238
R11540 VSS.n1989 VSS.t875 0.478238
R11541 VSS.t1008 VSS.n1639 0.477785
R11542 VSS.t527 VSS.n1550 0.477785
R11543 VSS.t1455 VSS.n1501 0.477785
R11544 VSS.n1654 VSS.t1529 0.477743
R11545 VSS.t961 VSS.n1646 0.477743
R11546 VSS.n1573 VSS.t958 0.477743
R11547 VSS.t495 VSS.n1565 0.477743
R11548 VSS.n1444 VSS.t885 0.477743
R11549 VSS.t627 VSS.n1436 0.477743
R11550 VSS.n1379 VSS.t1098 0.477743
R11551 VSS.n1378 VSS.t1023 0.477743
R11552 VSS.n1377 VSS.t519 0.477743
R11553 VSS.n1376 VSS.t107 0.477743
R11554 VSS.n1371 VSS.t570 0.477743
R11555 VSS.n1370 VSS.t103 0.477743
R11556 VSS.n1369 VSS.t755 0.477743
R11557 VSS.n1368 VSS.t113 0.477743
R11558 VSS.n1365 VSS.t552 0.477743
R11559 VSS.n1364 VSS.t10 0.477743
R11560 VSS.n1363 VSS.t136 0.477743
R11561 VSS.n1356 VSS.t858 0.477743
R11562 VSS.n1355 VSS.t1111 0.477743
R11563 VSS.n1351 VSS.t891 0.477743
R11564 VSS.n1350 VSS.t1292 0.477743
R11565 VSS.n1349 VSS.t629 0.477743
R11566 VSS.n767 VSS.t1230 0.477743
R11567 VSS.n764 VSS.t595 0.477743
R11568 VSS.n762 VSS.t1083 0.477743
R11569 VSS.n760 VSS.t1375 0.477743
R11570 VSS.n759 VSS.t591 0.477743
R11571 VSS.n753 VSS.t517 0.477743
R11572 VSS.n751 VSS.t1264 0.477743
R11573 VSS.n744 VSS.t1067 0.477743
R11574 VSS.n741 VSS.t587 0.477743
R11575 VSS.n739 VSS.t585 0.477743
R11576 VSS.n737 VSS.t974 0.477743
R11577 VSS.n736 VSS.t849 0.477743
R11578 VSS.n734 VSS.t72 0.477743
R11579 VSS.n731 VSS.t1029 0.477743
R11580 VSS.n729 VSS.t796 0.477743
R11581 VSS.n722 VSS.t837 0.477743
R11582 VSS.n712 VSS.t742 0.477743
R11583 VSS.n709 VSS.t79 0.477743
R11584 VSS.n707 VSS.t1968 0.477743
R11585 VSS.n697 VSS.t1871 0.477743
R11586 VSS.n1671 VSS.t1215 0.477689
R11587 VSS.n1606 VSS.t2157 0.477689
R11588 VSS.n1526 VSS.t1406 0.477689
R11589 VSS.n1477 VSS.t608 0.477689
R11590 VSS.n1469 VSS.t1100 0.477689
R11591 VSS.t1500 VSS.n1114 0.477689
R11592 VSS.t1250 VSS.n1113 0.477689
R11593 VSS.t1822 VSS.n1112 0.477689
R11594 VSS.t618 VSS.n1111 0.477689
R11595 VSS.t989 VSS.n1110 0.477689
R11596 VSS.t111 VSS.n1109 0.477689
R11597 VSS.t1092 VSS.n1105 0.477689
R11598 VSS.t29 VSS.n1104 0.477689
R11599 VSS.t913 VSS.n1103 0.477689
R11600 VSS.t915 VSS.n1102 0.477689
R11601 VSS.t132 VSS.n1101 0.477689
R11602 VSS.t2231 VSS.n1100 0.477689
R11603 VSS.t889 VSS.n1099 0.477689
R11604 VSS.t480 VSS.n1098 0.477689
R11605 VSS.t163 VSS.n1097 0.477689
R11606 VSS.t536 VSS.n1096 0.477689
R11607 VSS.t723 VSS.n1095 0.477689
R11608 VSS.t780 VSS.n1094 0.477689
R11609 VSS.t141 VSS.n1090 0.477689
R11610 VSS.t101 VSS.n1089 0.477689
R11611 VSS.t124 VSS.n1088 0.477689
R11612 VSS.t538 VSS.n1087 0.477689
R11613 VSS.t156 VSS.n1086 0.477689
R11614 VSS.t1016 VSS.n1085 0.477689
R11615 VSS.t802 VSS.n1084 0.477689
R11616 VSS.t486 VSS.n1083 0.477689
R11617 VSS.t1195 VSS.n1082 0.477689
R11618 VSS.t152 VSS.n1081 0.477689
R11619 VSS.t87 VSS.n1080 0.477689
R11620 VSS.t748 VSS.n1663 0.477685
R11621 VSS.t1073 VSS.n1590 0.477685
R11622 VSS.t956 VSS.n1461 0.477685
R11623 VSS.t649 VSS.n1557 0.47766
R11624 VSS.t862 VSS.n1508 0.47766
R11625 VSS.t786 VSS.n1428 0.47766
R11626 VSS.t119 VSS.n1631 0.47764
R11627 VSS.t1332 VSS.n1542 0.47764
R11628 VSS.t492 VSS.n1493 0.47764
R11629 VSS.t488 VSS.n1485 0.47764
R11630 VSS.n1580 VSS.t1750 0.47756
R11631 VSS.n1451 VSS.t524 0.47756
R11632 VSS.n1380 VSS.t825 0.477515
R11633 VSS.n1375 VSS.t1312 0.477515
R11634 VSS.n1367 VSS.t90 0.477515
R11635 VSS.n1366 VSS.t705 0.477515
R11636 VSS.n1362 VSS.t1000 0.477515
R11637 VSS.n1361 VSS.t160 0.477515
R11638 VSS.n1360 VSS.t99 0.477515
R11639 VSS.n1354 VSS.t871 0.477515
R11640 VSS.n1353 VSS.t478 0.477515
R11641 VSS.n1352 VSS.t1349 0.477515
R11642 VSS.n1348 VSS.t602 0.477515
R11643 VSS.n1347 VSS.t980 0.477515
R11644 VSS.n1346 VSS.t16 0.477515
R11645 VSS.n770 VSS.t1487 0.477515
R11646 VSS.n748 VSS.t1860 0.477515
R11647 VSS.n747 VSS.t511 0.477515
R11648 VSS.n720 VSS.t782 0.477515
R11649 VSS.n718 VSS.t1932 0.477515
R11650 VSS.n714 VSS.t506 0.477515
R11651 VSS.n705 VSS.t2137 0.477515
R11652 VSS.n703 VSS.t1268 0.477515
R11653 VSS.n699 VSS.t556 0.477515
R11654 VSS.n1598 VSS.t568 0.477488
R11655 VSS.t1699 VSS.n1614 0.477451
R11656 VSS.t612 VSS.n1534 0.477451
R11657 VSS.t529 VSS.n466 0.477286
R11658 VSS.t529 VSS.n465 0.472981
R11659 VSS.n944 VSS.t1535 0.467079
R11660 VSS.n904 VSS.t41 0.467079
R11661 VSS.t544 VSS.n955 0.467079
R11662 VSS.t600 VSS.n875 0.467079
R11663 VSS.t1147 VSS.n835 0.467079
R11664 VSS.t180 VSS.n791 0.467079
R11665 VSS.n1703 VSS.t1412 0.467079
R11666 VSS.n1697 VSS.t1970 0.467079
R11667 VSS.n1688 VSS.t2004 0.467079
R11668 VSS.t1447 VSS.n1717 0.467079
R11669 VSS.t673 VSS.n855 0.467061
R11670 VSS.t647 VSS.n811 0.467061
R11671 VSS.n970 VSS.t178 0.467049
R11672 VSS.n1713 VSS.t1153 0.467049
R11673 VSS.n1705 VSS.t1415 0.467049
R11674 VSS.n1699 VSS.t1774 0.467049
R11675 VSS.n1690 VSS.t2008 0.467049
R11676 VSS.t1801 VSS.n931 0.46695
R11677 VSS.t1138 VSS.n862 0.46695
R11678 VSS.n828 VSS.n818 0.46695
R11679 VSS.t1317 VSS.n1721 0.46695
R11680 VSS.t610 VSS.n1715 0.46695
R11681 VSS.t1409 VSS.n1707 0.46695
R11682 VSS.t1157 VSS.n1701 0.46695
R11683 VSS.t85 VSS.n1720 0.466936
R11684 VSS.t490 VSS.n1714 0.466936
R11685 VSS.t1086 VSS.n1706 0.466936
R11686 VSS.t1021 VSS.n1700 0.466936
R11687 VSS.t667 VSS.n989 0.466936
R11688 VSS.t638 VSS.n924 0.466936
R11689 VSS.n963 VSS.t681 0.466877
R11690 VSS.n1712 VSS.t898 0.466877
R11691 VSS.n1704 VSS.t1047 0.466877
R11692 VSS.n1698 VSS.t901 0.466877
R11693 VSS.n1689 VSS.t522 0.466877
R11694 VSS.t745 VSS.n1702 0.466877
R11695 VSS.t82 VSS.n1687 0.466877
R11696 VSS.t504 VSS.n938 0.466877
R11697 VSS.t644 VSS.n897 0.466877
R11698 VSS.n804 VSS.t1377 0.466867
R11699 VSS.t605 VSS.n983 0.466867
R11700 VSS.t1345 VSS.n889 0.466867
R11701 VSS.t735 VSS.n848 0.466867
R11702 VSS.n1719 VSS.t1834 0.466867
R11703 VSS.n1694 VSS.n1692 0.466862
R11704 VSS.t2055 VSS.n1815 0.466802
R11705 VSS.t1335 VSS.n1779 0.466802
R11706 VSS.t1283 VSS.n1722 0.466777
R11707 VSS.t1518 VSS.n1716 0.466777
R11708 VSS.t882 VSS.n1708 0.466777
R11709 VSS.t635 VSS.n950 0.466777
R11710 VSS.t662 VSS.n910 0.466777
R11711 VSS.t632 VSS.n869 0.466777
R11712 VSS.t1434 VSS.n784 0.466777
R11713 VSS.n798 VSS.t694 0.466752
R11714 VSS.n1718 VSS.t467 0.466752
R11715 VSS.t895 VSS.n1691 0.466752
R11716 VSS.n977 VSS.t678 0.466752
R11717 VSS.n882 VSS.t670 0.466752
R11718 VSS.n842 VSS.t641 0.466752
R11719 VSS.t1286 VSS.t1276 0.466734
R11720 VSS.t2058 VSS.n1859 0.466677
R11721 VSS.t1338 VSS.n1838 0.466677
R11722 VSS.t583 VSS.t2268 0.466677
R11723 VSS.t1997 VSS.t1498 0.466677
R11724 VSS.t1362 VSS.t1301 0.466646
R11725 VSS.t580 VSS.t1228 0.466646
R11726 VSS.t2069 VSS.t788 0.466646
R11727 VSS.t1759 VSS.n1825 0.466618
R11728 VSS.t2041 VSS.n1786 0.466618
R11729 VSS.t1957 VSS.t1493 0.466589
R11730 VSS.t968 VSS.t1169 0.466548
R11731 VSS.t1341 VSS.t1702 0.466548
R11732 VSS.t954 VSS.n2912 0.466542
R11733 VSS.t109 VSS.n2905 0.466542
R11734 VSS.n2894 VSS.n2898 0.466542
R11735 VSS.t1010 VSS.n2889 0.466542
R11736 VSS.t548 VSS.n2882 0.466542
R11737 VSS.t707 VSS.n2875 0.466542
R11738 VSS.t139 VSS.n2868 0.466542
R11739 VSS.t998 VSS.n2861 0.466542
R11740 VSS.t97 VSS.n2854 0.466542
R11741 VSS.t1503 VSS.n2840 0.466542
R11742 VSS.t134 VSS.n2833 0.466542
R11743 VSS.t1140 VSS.n2826 0.466542
R11744 VSS.t554 VSS.n2819 0.466542
R11745 VSS.t932 VSS.n2812 0.466542
R11746 VSS.t1793 VSS.n1229 0.466542
R11747 VSS.t991 VSS.n1222 0.466542
R11748 VSS.n1211 VSS.n1215 0.466542
R11749 VSS.t1772 VSS.n1206 0.466542
R11750 VSS.t1089 VSS.n1199 0.466542
R11751 VSS.t1889 VSS.n1192 0.466542
R11752 VSS.t482 VSS.n1185 0.466542
R11753 VSS.t534 VSS.n1178 0.466542
R11754 VSS.t778 VSS.n1171 0.466542
R11755 VSS.t930 VSS.n1157 0.466542
R11756 VSS.t154 VSS.n1150 0.466542
R11757 VSS.t1886 VSS.n1143 0.466542
R11758 VSS.t502 VSS.n1136 0.466542
R11759 VSS.t69 VSS.n1129 0.466542
R11760 VSS.n1876 VSS.t1719 0.46654
R11761 VSS.n1853 VSS.t1710 0.46654
R11762 VSS.n1832 VSS.t1716 0.46654
R11763 VSS.t2052 VSS.n1801 0.46654
R11764 VSS.n1795 VSS.t1745 0.466493
R11765 VSS.n1872 VSS.t1356 0.466464
R11766 VSS.t834 VSS.t792 0.466464
R11767 VSS.t1989 VSS.t2044 0.466464
R11768 VSS.t976 VSS.t1964 0.466464
R11769 VSS.t1756 VSS.t1178 0.466464
R11770 VSS.t2038 VSS.n1888 0.466427
R11771 VSS.t2049 VSS.n1844 0.466427
R11772 VSS.t1742 VSS.n1882 0.466393
R11773 VSS.t1713 VSS.n1808 0.466393
R11774 VSS.n2913 VSS.t1081 0.466192
R11775 VSS.n2906 VSS.t1076 0.466192
R11776 VSS.n2899 VSS.t1323 0.466192
R11777 VSS.n2883 VSS.t1389 0.466192
R11778 VSS.n2876 VSS.t92 0.466192
R11779 VSS.n2869 VSS.t550 0.466192
R11780 VSS.n2862 VSS.t1052 0.466192
R11781 VSS.n2855 VSS.t158 0.466192
R11782 VSS.n2848 VSS.t1057 0.466192
R11783 VSS.n2841 VSS.t1109 0.466192
R11784 VSS.n2834 VSS.t1003 0.466192
R11785 VSS.n2827 VSS.t1384 0.466192
R11786 VSS.n2820 VSS.t985 0.466192
R11787 VSS.n2813 VSS.t982 0.466192
R11788 VSS.n2806 VSS.t709 0.466192
R11789 VSS.n1230 VSS.t1252 0.466192
R11790 VSS.n1223 VSS.t64 0.466192
R11791 VSS.n1216 VSS.t1203 0.466192
R11792 VSS.n1200 VSS.t1426 0.466192
R11793 VSS.n1193 VSS.t167 0.466192
R11794 VSS.n1186 VSS.t925 0.466192
R11795 VSS.n1179 VSS.t61 0.466192
R11796 VSS.n1172 VSS.t1182 0.466192
R11797 VSS.n1165 VSS.t2028 0.466192
R11798 VSS.n1158 VSS.t1106 0.466192
R11799 VSS.n1151 VSS.t540 0.466192
R11800 VSS.n1144 VSS.t1018 0.466192
R11801 VSS.n1137 VSS.t49 0.466192
R11802 VSS.n1130 VSS.t1117 0.466192
R11803 VSS.n1123 VSS.t1259 0.466192
R11804 VSS.n2101 VSS.t39 0.464894
R11805 VSS.n2806 VSS.t932 0.451785
R11806 VSS.n2813 VSS.t554 0.451785
R11807 VSS.n2820 VSS.t1140 0.451785
R11808 VSS.n2827 VSS.t134 0.451785
R11809 VSS.n2834 VSS.t1503 0.451785
R11810 VSS.n2841 VSS.t1627 0.451785
R11811 VSS.n2848 VSS.t97 0.451785
R11812 VSS.n2855 VSS.t998 0.451785
R11813 VSS.n2862 VSS.t139 0.451785
R11814 VSS.n2869 VSS.t707 0.451785
R11815 VSS.n2876 VSS.t548 0.451785
R11816 VSS.n2883 VSS.t1010 0.451785
R11817 VSS.n2899 VSS.t109 0.451785
R11818 VSS.n2906 VSS.t954 0.451785
R11819 VSS.n2913 VSS.t45 0.451785
R11820 VSS.n1123 VSS.t69 0.451785
R11821 VSS.n1130 VSS.t502 0.451785
R11822 VSS.n1137 VSS.t1886 0.451785
R11823 VSS.n1144 VSS.t154 0.451785
R11824 VSS.n1151 VSS.t930 0.451785
R11825 VSS.n1158 VSS.t143 0.451785
R11826 VSS.n1165 VSS.t778 0.451785
R11827 VSS.n1172 VSS.t534 0.451785
R11828 VSS.n1179 VSS.t482 0.451785
R11829 VSS.n1186 VSS.t1889 0.451785
R11830 VSS.n1193 VSS.t1089 0.451785
R11831 VSS.n1200 VSS.t1772 0.451785
R11832 VSS.n1216 VSS.t991 0.451785
R11833 VSS.n1223 VSS.t1793 0.451785
R11834 VSS.n1230 VSS.t2073 0.451785
R11835 VSS.t1368 VSS.n1888 0.45149
R11836 VSS.t834 VSS.n1844 0.45149
R11837 VSS.t1362 VSS.n1882 0.451461
R11838 VSS.t1286 VSS.n1808 0.451461
R11839 VSS.t1719 VSS.t1356 0.451456
R11840 VSS.t1710 VSS.t792 0.451456
R11841 VSS.t1716 VSS.t2044 0.451456
R11842 VSS.t1745 VSS.t1964 0.451456
R11843 VSS.t2041 VSS.t1756 0.451456
R11844 VSS.t2052 VSS.t1493 0.451368
R11845 VSS.t1957 VSS.n1795 0.451366
R11846 VSS.t1338 VSS.t1169 0.451356
R11847 VSS.t1713 VSS.t1702 0.451356
R11848 VSS.t1081 VSS.n2912 0.451337
R11849 VSS.t1076 VSS.n2905 0.451337
R11850 VSS.t1323 VSS.n2898 0.451337
R11851 VSS.t798 VSS.n2889 0.451337
R11852 VSS.t1389 VSS.n2882 0.451337
R11853 VSS.t92 VSS.n2875 0.451337
R11854 VSS.t550 VSS.n2868 0.451337
R11855 VSS.t1052 VSS.n2861 0.451337
R11856 VSS.t158 VSS.n2854 0.451337
R11857 VSS.t1109 VSS.n2840 0.451337
R11858 VSS.t1003 VSS.n2833 0.451337
R11859 VSS.t1384 VSS.n2826 0.451337
R11860 VSS.t985 VSS.n2819 0.451337
R11861 VSS.t982 VSS.n2812 0.451337
R11862 VSS.t1252 VSS.n1229 0.451337
R11863 VSS.t64 VSS.n1222 0.451337
R11864 VSS.t1203 VSS.n1215 0.451337
R11865 VSS.t58 VSS.n1206 0.451337
R11866 VSS.t1426 VSS.n1199 0.451337
R11867 VSS.t167 VSS.n1192 0.451337
R11868 VSS.t925 VSS.n1185 0.451337
R11869 VSS.t61 VSS.n1178 0.451337
R11870 VSS.t1182 VSS.n1171 0.451337
R11871 VSS.t1106 VSS.n1157 0.451337
R11872 VSS.t540 VSS.n1150 0.451337
R11873 VSS.t1018 VSS.n1143 0.451337
R11874 VSS.t49 VSS.n1136 0.451337
R11875 VSS.t1117 VSS.n1129 0.451337
R11876 VSS.t2038 VSS.t1301 0.451319
R11877 VSS.t1762 VSS.t1228 0.451319
R11878 VSS.t2049 VSS.t788 0.451319
R11879 VSS.t583 VSS.n1876 0.451316
R11880 VSS.t1997 VSS.n1853 0.451316
R11881 VSS.t968 VSS.n1832 0.451316
R11882 VSS.t1341 VSS.n1801 0.451316
R11883 VSS.t1989 VSS.n1825 0.451277
R11884 VSS.t976 VSS.n1786 0.451277
R11885 VSS.t1742 VSS.t2268 0.451265
R11886 VSS.t2058 VSS.t1498 0.451265
R11887 VSS.t2055 VSS.t1276 0.451215
R11888 VSS.t580 VSS.n1859 0.451171
R11889 VSS.t2069 VSS.n1838 0.451171
R11890 VSS.n1722 VSS.t1317 0.451143
R11891 VSS.n1716 VSS.t610 0.451143
R11892 VSS.n1708 VSS.t1409 0.451143
R11893 VSS.n950 VSS.t1535 0.451143
R11894 VSS.n910 VSS.t41 0.451143
R11895 VSS.n869 VSS.t1138 0.451143
R11896 VSS.n784 VSS.t130 0.451143
R11897 VSS.n1718 VSS.t1447 0.451136
R11898 VSS.n1691 VSS.t2008 0.451136
R11899 VSS.n977 VSS.t178 0.451136
R11900 VSS.n882 VSS.t600 0.451136
R11901 VSS.n842 VSS.t1147 0.451136
R11902 VSS.n798 VSS.t180 0.451136
R11903 VSS.t1470 VSS.n1815 0.451083
R11904 VSS.t1178 VSS.n1779 0.451083
R11905 VSS.n1692 VSS.t895 0.451078
R11906 VSS.n1719 VSS.t467 0.451074
R11907 VSS.n983 VSS.t678 0.451074
R11908 VSS.n889 VSS.t670 0.451074
R11909 VSS.n848 VSS.t641 0.451074
R11910 VSS.n804 VSS.t694 0.451074
R11911 VSS.n1712 VSS.t1452 0.451048
R11912 VSS.n1704 VSS.t1412 0.451048
R11913 VSS.n1698 VSS.t1970 0.451048
R11914 VSS.n1689 VSS.t2004 0.451048
R11915 VSS.n963 VSS.t544 0.451048
R11916 VSS.n1702 VSS.t1157 0.451048
R11917 VSS.n1687 VSS.t1217 0.451048
R11918 VSS.n938 VSS.t1801 0.451048
R11919 VSS.n897 VSS.t1345 0.451048
R11920 VSS.n1721 VSS.t85 0.450975
R11921 VSS.n1715 VSS.t490 0.450975
R11922 VSS.n1707 VSS.t1086 0.450975
R11923 VSS.n1701 VSS.t1021 0.450975
R11924 VSS.n931 VSS.t638 0.450975
R11925 VSS.n862 VSS.t673 0.450975
R11926 VSS.n818 VSS.t647 0.450975
R11927 VSS.n1720 VSS.t1834 0.450941
R11928 VSS.n1714 VSS.t1153 0.450941
R11929 VSS.n1706 VSS.t1415 0.450941
R11930 VSS.n1700 VSS.t1774 0.450941
R11931 VSS.n989 VSS.t605 0.450941
R11932 VSS.n924 VSS.t816 0.450941
R11933 VSS.n1713 VSS.t898 0.450937
R11934 VSS.n1705 VSS.t1047 0.450937
R11935 VSS.n1699 VSS.t901 0.450937
R11936 VSS.n1690 VSS.t522 0.450937
R11937 VSS.n970 VSS.t681 0.450937
R11938 VSS.n1717 VSS.t1518 0.450883
R11939 VSS.n1703 VSS.t745 0.450883
R11940 VSS.n1697 VSS.t476 0.450883
R11941 VSS.n1688 VSS.t82 0.450883
R11942 VSS.n955 VSS.t635 0.450883
R11943 VSS.n944 VSS.t504 0.450883
R11944 VSS.n904 VSS.t644 0.450883
R11945 VSS.n875 VSS.t632 0.450883
R11946 VSS.n835 VSS.t515 0.450883
R11947 VSS.n791 VSS.t1434 0.450883
R11948 VSS.n855 VSS.t735 0.450853
R11949 VSS.n811 VSS.t1377 0.450853
R11950 VSS.n3003 VSS.n676 0.44402
R11951 VSS.n2999 VSS.n1317 0.44402
R11952 VSS.n2151 VSS.n1751 0.44402
R11953 VSS.n2795 VSS.n1750 0.44402
R11954 VSS.t1332 VSS.n1534 0.440502
R11955 VSS.t659 VSS.n1614 0.440502
R11956 VSS.n1598 VSS.t2157 0.440463
R11957 VSS.n770 VSS.t128 0.440369
R11958 VSS.n748 VSS.t1264 0.440369
R11959 VSS.n747 VSS.t1860 0.440369
R11960 VSS.n720 VSS.t837 0.440369
R11961 VSS.n718 VSS.t782 0.440369
R11962 VSS.n714 VSS.t1932 0.440369
R11963 VSS.n705 VSS.t1968 0.440369
R11964 VSS.n703 VSS.t2137 0.440369
R11965 VSS.n699 VSS.t1268 0.440369
R11966 VSS.n1380 VSS.t1736 0.440369
R11967 VSS.n1375 VSS.t107 0.440369
R11968 VSS.n1367 VSS.t113 0.440369
R11969 VSS.n1366 VSS.t90 0.440369
R11970 VSS.n1362 VSS.t136 0.440369
R11971 VSS.n1361 VSS.t1000 0.440369
R11972 VSS.n1360 VSS.t160 0.440369
R11973 VSS.n1354 VSS.t1111 0.440369
R11974 VSS.n1353 VSS.t871 0.440369
R11975 VSS.n1352 VSS.t478 0.440369
R11976 VSS.n1348 VSS.t629 0.440369
R11977 VSS.n1347 VSS.t602 0.440369
R11978 VSS.n1346 VSS.t980 0.440369
R11979 VSS.t956 VSS.n1451 0.440319
R11980 VSS.t1073 VSS.n1580 0.440319
R11981 VSS.t492 VSS.n1485 0.44028
R11982 VSS.t1455 VSS.n1493 0.44028
R11983 VSS.t527 VSS.n1542 0.44028
R11984 VSS.t1008 VSS.n1631 0.44028
R11985 VSS.t1100 VSS.n1461 0.440231
R11986 VSS.t568 VSS.n1590 0.440231
R11987 VSS.t1215 VSS.n1663 0.440231
R11988 VSS.t152 VSS.n1080 0.440228
R11989 VSS.t1016 VSS.n1084 0.440228
R11990 VSS.t156 VSS.n1085 0.440228
R11991 VSS.t538 VSS.n1086 0.440228
R11992 VSS.t1026 VSS.n1090 0.440228
R11993 VSS.t163 VSS.n1096 0.440228
R11994 VSS.t913 VSS.n1102 0.440228
R11995 VSS.t1092 VSS.n1104 0.440228
R11996 VSS.t937 VSS.n1105 0.440228
R11997 VSS.t2032 VSS.n1114 0.440228
R11998 VSS.t1195 VSS.n1081 0.440228
R11999 VSS.t486 VSS.n1082 0.440228
R12000 VSS.t802 VSS.n1083 0.440228
R12001 VSS.t124 VSS.n1087 0.440228
R12002 VSS.t101 VSS.n1088 0.440228
R12003 VSS.t141 VSS.n1089 0.440228
R12004 VSS.t723 VSS.n1094 0.440228
R12005 VSS.t536 VSS.n1095 0.440228
R12006 VSS.t480 VSS.n1097 0.440228
R12007 VSS.t889 VSS.n1098 0.440228
R12008 VSS.t2231 VSS.n1099 0.440228
R12009 VSS.t132 VSS.n1100 0.440228
R12010 VSS.t915 VSS.n1101 0.440228
R12011 VSS.t29 VSS.n1103 0.440228
R12012 VSS.t989 VSS.n1109 0.440228
R12013 VSS.t618 VSS.n1110 0.440228
R12014 VSS.t1822 VSS.n1111 0.440228
R12015 VSS.t1250 VSS.n1112 0.440228
R12016 VSS.t1500 VSS.n1113 0.440228
R12017 VSS.n1469 VSS.t608 0.440228
R12018 VSS.n1477 VSS.t488 0.440228
R12019 VSS.n1526 VSS.t612 0.440228
R12020 VSS.n1606 VSS.t1699 0.440228
R12021 VSS.n1671 VSS.t2278 0.440228
R12022 VSS.t627 VSS.n1428 0.440225
R12023 VSS.t1043 VSS.n1508 0.440225
R12024 VSS.t495 VSS.n1557 0.440225
R12025 VSS.t862 VSS.n1501 0.440136
R12026 VSS.t649 VSS.n1550 0.440136
R12027 VSS.t961 VSS.n1639 0.440136
R12028 VSS.t885 VSS.n1436 0.440116
R12029 VSS.t524 VSS.n1444 0.440116
R12030 VSS.t958 VSS.n1565 0.440116
R12031 VSS.t1750 VSS.n1573 0.440116
R12032 VSS.t1529 VSS.n1646 0.440116
R12033 VSS.t748 VSS.n1654 0.440116
R12034 VSS.t556 VSS.n697 0.440116
R12035 VSS.t79 VSS.n707 0.440116
R12036 VSS.t742 VSS.n709 0.440116
R12037 VSS.t506 VSS.n712 0.440116
R12038 VSS.t1014 VSS.n722 0.440116
R12039 VSS.t1029 VSS.n729 0.440116
R12040 VSS.t72 VSS.n731 0.440116
R12041 VSS.t849 VSS.n734 0.440116
R12042 VSS.t974 VSS.n736 0.440116
R12043 VSS.t585 VSS.n737 0.440116
R12044 VSS.t587 VSS.n739 0.440116
R12045 VSS.t1067 VSS.n741 0.440116
R12046 VSS.t511 VSS.n744 0.440116
R12047 VSS.t517 VSS.n751 0.440116
R12048 VSS.t513 VSS.n753 0.440116
R12049 VSS.t1375 VSS.n759 0.440116
R12050 VSS.t1083 VSS.n760 0.440116
R12051 VSS.t595 VSS.n762 0.440116
R12052 VSS.t1230 VSS.n764 0.440116
R12053 VSS.t1487 VSS.n767 0.440116
R12054 VSS.t1292 VSS.n1349 0.440116
R12055 VSS.t891 VSS.n1350 0.440116
R12056 VSS.t1349 VSS.n1351 0.440116
R12057 VSS.t858 VSS.n1355 0.440116
R12058 VSS.t1041 VSS.n1356 0.440116
R12059 VSS.t10 VSS.n1363 0.440116
R12060 VSS.t552 VSS.n1364 0.440116
R12061 VSS.t705 VSS.n1365 0.440116
R12062 VSS.t755 VSS.n1368 0.440116
R12063 VSS.t103 VSS.n1369 0.440116
R12064 VSS.t570 VSS.n1370 0.440116
R12065 VSS.t864 VSS.n1371 0.440116
R12066 VSS.t519 VSS.n1376 0.440116
R12067 VSS.t1023 VSS.n1377 0.440116
R12068 VSS.t1098 VSS.n1378 0.440116
R12069 VSS.t825 VSS.n1379 0.440116
R12070 VSS.n2074 VSS.t1358 0.439648
R12071 VSS.n2077 VSS.t74 0.439641
R12072 VSS.n2081 VSS.t117 0.439641
R12073 VSS.n2084 VSS.t509 0.439641
R12074 VSS.n2088 VSS.t1365 0.439641
R12075 VSS.n2091 VSS.t1071 0.439641
R12076 VSS.n2095 VSS.t566 0.439641
R12077 VSS.n1989 VSS.t1162 0.439641
R12078 VSS.n1992 VSS.t869 0.439641
R12079 VSS.n1996 VSS.t753 0.439641
R12080 VSS.n1999 VSS.t115 0.439641
R12081 VSS.n2003 VSS.t757 0.439641
R12082 VSS.n2006 VSS.t105 0.439641
R12083 VSS.n2010 VSS.t762 0.439641
R12084 VSS.n2013 VSS.t866 0.439641
R12085 VSS.n2017 VSS.t1274 0.439641
R12086 VSS.n2020 VSS.t1468 0.439641
R12087 VSS.n2024 VSS.t696 0.439641
R12088 VSS.n2032 VSS.t1224 0.439641
R12089 VSS.n2035 VSS.t911 0.439641
R12090 VSS.n2039 VSS.t830 0.439641
R12091 VSS.n2042 VSS.t126 0.439641
R12092 VSS.n2046 VSS.t790 0.439641
R12093 VSS.n2049 VSS.t832 0.439641
R12094 VSS.n2053 VSS.t794 0.439641
R12095 VSS.n2056 VSS.t1431 0.439641
R12096 VSS.n2060 VSS.t1176 0.439641
R12097 VSS.n2063 VSS.t578 0.439641
R12098 VSS.n2067 VSS.t1226 0.439641
R12099 VSS.n2070 VSS.t593 0.439641
R12100 VSS.n2776 VSS.n442 0.436259
R12101 VSS.n2722 VSS.n2151 0.435807
R12102 VSS.n2723 VSS.n2722 0.427593
R12103 VSS.n2731 VSS.n2148 0.417043
R12104 VSS.n2719 VSS.n2718 0.416917
R12105 VSS.n2720 VSS.n2719 0.416191
R12106 VSS.n2718 VSS.n2148 0.416074
R12107 VSS.n2607 VSS.t1185 0.411873
R12108 VSS.n2761 VSS.n2119 0.41014
R12109 VSS.n2028 VSS.t696 0.392129
R12110 VSS.n1372 VSS.t864 0.39181
R12111 VSS.n1357 VSS.t1041 0.39181
R12112 VSS.n755 VSS.t513 0.39181
R12113 VSS.t937 VSS.n1106 0.391779
R12114 VSS.t1026 VSS.n1091 0.391779
R12115 VSS.n724 VSS.t1014 0.391632
R12116 VSS.n1621 VSS.t659 0.391516
R12117 VSS.t1043 VSS.n1516 0.391516
R12118 VSS.t265 VSS.t262 0.388215
R12119 VSS.t2113 VSS.n11 0.11835
R12120 VSS.n10 VSS.t949 0.580161
R12121 VSS.n9 VSS.t1143 0.580161
R12122 VSS.t1452 VSS.n1711 0.380932
R12123 VSS.t476 VSS.n1696 0.380703
R12124 VSS.t816 VSS.n918 0.380674
R12125 VSS.n1821 VSS.t1470 0.380674
R12126 VSS.t515 VSS.n832 0.380529
R12127 VSS.t1762 VSS.n1865 0.380525
R12128 VSS.n2967 VSS.t1627 0.380287
R12129 VSS.n1279 VSS.t143 0.380287
R12130 VSS.n2891 VSS.t798 0.380025
R12131 VSS.n1208 VSS.t58 0.380025
R12132 VSS.n2739 VSS.n2738 0.376066
R12133 VSS.n2705 VSS.n2704 0.376066
R12134 VSS.t31 VSS.n2607 0.372074
R12135 VSS.n2790 VSS.n2789 0.356909
R12136 VSS.n2891 VSS.n2890 0.352462
R12137 VSS.n1208 VSS.n1207 0.352462
R12138 VSS.n1626 VSS.n1621 0.352182
R12139 VSS.n1871 VSS.n1865 0.351924
R12140 VSS.n1107 VSS.n1106 0.351918
R12141 VSS.n1373 VSS.n1372 0.351842
R12142 VSS.n1696 VSS.n1693 0.351726
R12143 VSS.n832 VSS.n827 0.350668
R12144 VSS.n757 VSS.n755 0.350592
R12145 VSS.n1522 VSS.n1516 0.349682
R12146 VSS.n2967 VSS.t1815 0.349629
R12147 VSS.n1279 VSS.t55 0.349629
R12148 VSS.n724 VSS.n726 0.349539
R12149 VSS.n1092 VSS.n1091 0.349418
R12150 VSS.n1358 VSS.n1357 0.349342
R12151 VSS.t698 VSS.n1821 0.349275
R12152 VSS.n918 VSS.t687 0.349275
R12153 VSS.n2028 VSS.n2027 0.349037
R12154 VSS.t393 VSS.t391 0.349031
R12155 VSS.n1711 VSS.t473 0.349016
R12156 VSS.t226 VSS.n4 0.131677
R12157 VSS.t345 VSS.t344 0.348238
R12158 VSS.n2790 VSS.t1559 0.346433
R12159 VSS.n2735 VSS.n2734 0.338265
R12160 VSS.n2709 VSS.n2708 0.338265
R12161 VSS.n2734 VSS.n2733 0.338019
R12162 VSS.n2710 VSS.n2709 0.338019
R12163 VSS.n2122 VSS.n2121 0.33508
R12164 VSS.n3000 VSS.n1074 0.330412
R12165 VSS.n2792 VSS.n575 0.330412
R12166 VSS.n1747 VSS.n1745 0.330412
R12167 VSS.n584 VSS.t345 0.0503834
R12168 VSS.t391 VSS.n586 0.0502676
R12169 VSS.n2753 VSS.n2752 0.312321
R12170 VSS.n2727 VSS.n2726 0.31114
R12171 VSS.t299 VSS.n300 0.320217
R12172 VSS.n348 VSS.t462 0.320217
R12173 VSS.n2738 VSS.n2737 0.306341
R12174 VSS.n2706 VSS.n2705 0.306341
R12175 VSS.t286 VSS.t284 0.305925
R12176 VSS.t274 VSS.t272 0.305925
R12177 VSS.t238 VSS.t236 0.305925
R12178 VSS.t449 VSS.t447 0.305925
R12179 VSS.t437 VSS.t435 0.305925
R12180 VSS.t414 VSS.t412 0.305925
R12181 VSS.t402 VSS.t400 0.305925
R12182 VSS.t589 VSS.t566 0.302314
R12183 VSS.t497 VSS.t2278 0.302153
R12184 VSS.t2032 VSS.t1404 0.302153
R12185 VSS.t1736 VSS.t1119 0.302137
R12186 VSS.t128 VSS.t614 0.302137
R12187 VSS.t1547 VSS.n1683 0.301088
R12188 VSS.n772 VSS.t1617 0.300523
R12189 VSS.n332 VSS.n47 0.256268
R12190 VSS.n1896 VSS.t1368 0.29124
R12191 VSS.t130 VSS.n779 0.291234
R12192 VSS.t1217 VSS.n1686 0.291234
R12193 VSS.n1238 VSS.t2073 0.290734
R12194 VSS.n2926 VSS.t45 0.290734
R12195 VSS.t935 VSS.n687 0.289639
R12196 VSS.t14 VSS.n1341 0.289639
R12197 VSS.t812 VSS.n497 0.380704
R12198 VSS.n2601 VSS.t2221 0.286439
R12199 VSS.n2533 VSS.n2601 0.286439
R12200 VSS.n2144 VSS.n525 0.380365
R12201 VSS.t810 VSS.n2144 0.286439
R12202 VSS.n2142 VSS.t812 0.2861
R12203 VSS.n1986 VSS.n1753 0.28485
R12204 VSS.n687 VSS.n675 0.28352
R12205 VSS.n2724 VSS.n1341 0.28352
R12206 VSS.n87 VSS.n82 0.247534
R12207 VSS.t1877 VSS.n301 0.0285573
R12208 VSS.t1187 VSS.n2126 0.278261
R12209 VSS.t709 VSS.n2804 0.275961
R12210 VSS.t1259 VSS.n1121 0.275961
R12211 VSS.t2196 VSS.n2113 0.275797
R12212 VSS.t1335 VSS.n1780 0.275718
R12213 VSS.n1723 VSS.t1283 0.275718
R12214 VSS.n995 VSS.t667 0.275633
R12215 VSS.n1000 VSS.n695 0.27249
R12216 VSS.n2993 VSS.n1345 0.27249
R12217 VSS.n1001 VSS.n995 0.27241
R12218 VSS.n1780 VSS.n1775 0.272321
R12219 VSS.n1725 VSS.n1425 0.272321
R12220 VSS.n1726 VSS.n1723 0.272321
R12221 VSS.n1305 VSS.n1079 0.272321
R12222 VSS.n2804 VSS.n2805 0.272065
R12223 VSS.n1121 VSS.n1122 0.272065
R12224 VSS.n775 VSS.n769 0.267794
R12225 VSS.n775 VSS.n768 0.267794
R12226 VSS.n775 VSS.n765 0.267794
R12227 VSS.n775 VSS.n763 0.267794
R12228 VSS.n775 VSS.n761 0.267794
R12229 VSS.n775 VSS.n756 0.267794
R12230 VSS.n775 VSS.n754 0.267794
R12231 VSS.n775 VSS.n752 0.267794
R12232 VSS.n775 VSS.n750 0.267794
R12233 VSS.n775 VSS.n749 0.267794
R12234 VSS.n775 VSS.n746 0.267794
R12235 VSS.n775 VSS.n745 0.267794
R12236 VSS.n775 VSS.n742 0.267794
R12237 VSS.n775 VSS.n740 0.267794
R12238 VSS.n775 VSS.n738 0.267794
R12239 VSS.n775 VSS.n735 0.267794
R12240 VSS.n775 VSS.n733 0.267794
R12241 VSS.n775 VSS.n732 0.267794
R12242 VSS.n775 VSS.n730 0.267794
R12243 VSS.n775 VSS.n728 0.267794
R12244 VSS.n775 VSS.n725 0.267794
R12245 VSS.n775 VSS.n721 0.267794
R12246 VSS.n775 VSS.n719 0.267794
R12247 VSS.n775 VSS.n717 0.267794
R12248 VSS.n775 VSS.n716 0.267794
R12249 VSS.n775 VSS.n715 0.267794
R12250 VSS.n775 VSS.n713 0.267794
R12251 VSS.n775 VSS.n711 0.267794
R12252 VSS.n775 VSS.n710 0.267794
R12253 VSS.n775 VSS.n706 0.267794
R12254 VSS.n775 VSS.n704 0.267794
R12255 VSS.n775 VSS.n702 0.267794
R12256 VSS.n775 VSS.n701 0.267794
R12257 VSS.n775 VSS.n700 0.267794
R12258 VSS.n775 VSS.n698 0.267794
R12259 VSS.n775 VSS.n696 0.267794
R12260 VSS.n775 VSS.n1004 0.267794
R12261 VSS.n775 VSS.n997 0.267794
R12262 VSS.n775 VSS.n972 0.267794
R12263 VSS.n775 VSS.n968 0.267794
R12264 VSS.n775 VSS.n966 0.267794
R12265 VSS.n775 VSS.n958 0.267794
R12266 VSS.n775 VSS.n933 0.267794
R12267 VSS.n775 VSS.n929 0.267794
R12268 VSS.n775 VSS.n927 0.267794
R12269 VSS.n775 VSS.n919 0.267794
R12270 VSS.n775 VSS.n900 0.267794
R12271 VSS.n775 VSS.n892 0.267794
R12272 VSS.n775 VSS.n891 0.267794
R12273 VSS.n775 VSS.n885 0.267794
R12274 VSS.n775 VSS.n877 0.267794
R12275 VSS.n775 VSS.n872 0.267794
R12276 VSS.n775 VSS.n864 0.267794
R12277 VSS.n775 VSS.n858 0.267794
R12278 VSS.n775 VSS.n850 0.267794
R12279 VSS.n775 VSS.n837 0.267794
R12280 VSS.n775 VSS.n830 0.267794
R12281 VSS.n775 VSS.n821 0.267794
R12282 VSS.n775 VSS.n820 0.267794
R12283 VSS.n775 VSS.n814 0.267794
R12284 VSS.n775 VSS.n806 0.267794
R12285 VSS.n775 VSS.n801 0.267794
R12286 VSS.n775 VSS.n793 0.267794
R12287 VSS.n775 VSS.n787 0.267794
R12288 VSS.n775 VSS.n776 0.267794
R12289 VSS.n589 VSS.n614 0.267794
R12290 VSS.n589 VSS.n615 0.267794
R12291 VSS.n589 VSS.n673 0.267794
R12292 VSS.n589 VSS.n671 0.267794
R12293 VSS.n589 VSS.n670 0.267794
R12294 VSS.n589 VSS.n669 0.267794
R12295 VSS.n589 VSS.n616 0.267794
R12296 VSS.n589 VSS.n666 0.267794
R12297 VSS.n589 VSS.n617 0.267794
R12298 VSS.n589 VSS.n665 0.267794
R12299 VSS.n589 VSS.n663 0.267794
R12300 VSS.n589 VSS.n662 0.267794
R12301 VSS.n589 VSS.n661 0.267794
R12302 VSS.n589 VSS.n618 0.267794
R12303 VSS.n589 VSS.n658 0.267794
R12304 VSS.n589 VSS.n619 0.267794
R12305 VSS.n589 VSS.n657 0.267794
R12306 VSS.n589 VSS.n655 0.267794
R12307 VSS.n589 VSS.n654 0.267794
R12308 VSS.n589 VSS.n620 0.267794
R12309 VSS.n589 VSS.n652 0.267794
R12310 VSS.n589 VSS.n651 0.267794
R12311 VSS.n589 VSS.n650 0.267794
R12312 VSS.n589 VSS.n621 0.267794
R12313 VSS.n589 VSS.n648 0.267794
R12314 VSS.n589 VSS.n622 0.267794
R12315 VSS.n589 VSS.n647 0.267794
R12316 VSS.n589 VSS.n646 0.267794
R12317 VSS.n589 VSS.n645 0.267794
R12318 VSS.n589 VSS.n644 0.267794
R12319 VSS.n589 VSS.n643 0.267794
R12320 VSS.n589 VSS.n642 0.267794
R12321 VSS.n589 VSS.n624 0.267794
R12322 VSS.n589 VSS.n641 0.267794
R12323 VSS.n589 VSS.n625 0.267794
R12324 VSS.n589 VSS.n639 0.267794
R12325 VSS.n589 VSS.n638 0.267794
R12326 VSS.n589 VSS.n637 0.267794
R12327 VSS.n589 VSS.n626 0.267794
R12328 VSS.n589 VSS.n635 0.267794
R12329 VSS.n589 VSS.n627 0.267794
R12330 VSS.n589 VSS.n634 0.267794
R12331 VSS.n589 VSS.n633 0.267794
R12332 VSS.n589 VSS.n632 0.267794
R12333 VSS.n589 VSS.n631 0.267794
R12334 VSS.n589 VSS.n612 0.267794
R12335 VSS.n589 VSS.n610 0.267794
R12336 VSS.n589 VSS.n609 0.267794
R12337 VSS.n589 VSS.n608 0.267794
R12338 VSS.n589 VSS.n607 0.267794
R12339 VSS.n589 VSS.n605 0.267794
R12340 VSS.n589 VSS.n603 0.267794
R12341 VSS.n589 VSS.n602 0.267794
R12342 VSS.n589 VSS.n601 0.267794
R12343 VSS.n589 VSS.n600 0.267794
R12344 VSS.n589 VSS.n599 0.267794
R12345 VSS.n589 VSS.n598 0.267794
R12346 VSS.n589 VSS.n597 0.267794
R12347 VSS.n589 VSS.n596 0.267794
R12348 VSS.n589 VSS.n595 0.267794
R12349 VSS.n589 VSS.n594 0.267794
R12350 VSS.n589 VSS.n593 0.267794
R12351 VSS.n589 VSS.n592 0.267794
R12352 VSS.n589 VSS.n591 0.267794
R12353 VSS.n439 VSS.n354 0.267794
R12354 VSS.n582 VSS.n571 0.267677
R12355 VSS.n582 VSS.n573 0.267677
R12356 VSS.n1749 VSS.n1418 0.267677
R12357 VSS.n1749 VSS.n1423 0.267677
R12358 VSS.n1749 VSS.n1427 0.267677
R12359 VSS.n1749 VSS.n1431 0.267677
R12360 VSS.n1749 VSS.n1439 0.267677
R12361 VSS.n1749 VSS.n1440 0.267677
R12362 VSS.n1749 VSS.n1443 0.267677
R12363 VSS.n1749 VSS.n1447 0.267677
R12364 VSS.n1749 VSS.n1455 0.267677
R12365 VSS.n1749 VSS.n1456 0.267677
R12366 VSS.n1749 VSS.n1459 0.267677
R12367 VSS.n1749 VSS.n1463 0.267677
R12368 VSS.n1749 VSS.n1471 0.267677
R12369 VSS.n1749 VSS.n1472 0.267677
R12370 VSS.n1749 VSS.n1475 0.267677
R12371 VSS.n1749 VSS.n1479 0.267677
R12372 VSS.n1749 VSS.n1487 0.267677
R12373 VSS.n1749 VSS.n1488 0.267677
R12374 VSS.n1749 VSS.n1491 0.267677
R12375 VSS.n1749 VSS.n1495 0.267677
R12376 VSS.n1749 VSS.n1503 0.267677
R12377 VSS.n1749 VSS.n1504 0.267677
R12378 VSS.n1749 VSS.n1507 0.267677
R12379 VSS.n1749 VSS.n1511 0.267677
R12380 VSS.n1749 VSS.n1519 0.267677
R12381 VSS.n1749 VSS.n1520 0.267677
R12382 VSS.n1749 VSS.n1524 0.267677
R12383 VSS.n1749 VSS.n1528 0.267677
R12384 VSS.n1749 VSS.n1536 0.267677
R12385 VSS.n1749 VSS.n1537 0.267677
R12386 VSS.n1749 VSS.n1540 0.267677
R12387 VSS.n1749 VSS.n1544 0.267677
R12388 VSS.n1749 VSS.n1552 0.267677
R12389 VSS.n1749 VSS.n1553 0.267677
R12390 VSS.n1749 VSS.n1556 0.267677
R12391 VSS.n1749 VSS.n1560 0.267677
R12392 VSS.n1749 VSS.n1568 0.267677
R12393 VSS.n1749 VSS.n1569 0.267677
R12394 VSS.n1749 VSS.n1572 0.267677
R12395 VSS.n1749 VSS.n1576 0.267677
R12396 VSS.n1749 VSS.n1584 0.267677
R12397 VSS.n1749 VSS.n1585 0.267677
R12398 VSS.n1749 VSS.n1588 0.267677
R12399 VSS.n1749 VSS.n1592 0.267677
R12400 VSS.n1749 VSS.n1600 0.267677
R12401 VSS.n1749 VSS.n1601 0.267677
R12402 VSS.n1749 VSS.n1604 0.267677
R12403 VSS.n1749 VSS.n1608 0.267677
R12404 VSS.n1749 VSS.n1616 0.267677
R12405 VSS.n1749 VSS.n1617 0.267677
R12406 VSS.n1749 VSS.n1620 0.267677
R12407 VSS.n1749 VSS.n1624 0.267677
R12408 VSS.n1749 VSS.n1633 0.267677
R12409 VSS.n1749 VSS.n1634 0.267677
R12410 VSS.n1749 VSS.n1637 0.267677
R12411 VSS.n1749 VSS.n1641 0.267677
R12412 VSS.n1749 VSS.n1649 0.267677
R12413 VSS.n1749 VSS.n1650 0.267677
R12414 VSS.n1749 VSS.n1653 0.267677
R12415 VSS.n1749 VSS.n1657 0.267677
R12416 VSS.n1749 VSS.n1665 0.267677
R12417 VSS.n1749 VSS.n1666 0.267677
R12418 VSS.n1749 VSS.n1669 0.267677
R12419 VSS.n1749 VSS.n1673 0.267677
R12420 VSS.n1749 VSS.n1682 0.267677
R12421 VSS.n589 VSS.n629 0.267428
R12422 VSS.n439 VSS.n438 0.267428
R12423 VSS.n439 VSS.n360 0.267428
R12424 VSS.n439 VSS.n436 0.267428
R12425 VSS.n439 VSS.n434 0.267428
R12426 VSS.n439 VSS.n433 0.267428
R12427 VSS.n439 VSS.n432 0.267428
R12428 VSS.n439 VSS.n431 0.267428
R12429 VSS.n439 VSS.n429 0.267428
R12430 VSS.n439 VSS.n361 0.267428
R12431 VSS.n439 VSS.n428 0.267428
R12432 VSS.n439 VSS.n362 0.267428
R12433 VSS.n439 VSS.n427 0.267428
R12434 VSS.n439 VSS.n426 0.267428
R12435 VSS.n439 VSS.n363 0.267428
R12436 VSS.n439 VSS.n425 0.267428
R12437 VSS.n439 VSS.n423 0.267428
R12438 VSS.n439 VSS.n422 0.267428
R12439 VSS.n439 VSS.n421 0.267428
R12440 VSS.n439 VSS.n420 0.267428
R12441 VSS.n439 VSS.n419 0.267428
R12442 VSS.n439 VSS.n365 0.267428
R12443 VSS.n439 VSS.n418 0.267428
R12444 VSS.n439 VSS.n366 0.267428
R12445 VSS.n439 VSS.n417 0.267428
R12446 VSS.n439 VSS.n416 0.267428
R12447 VSS.n439 VSS.n367 0.267428
R12448 VSS.n439 VSS.n415 0.267428
R12449 VSS.n439 VSS.n413 0.267428
R12450 VSS.n439 VSS.n412 0.267428
R12451 VSS.n439 VSS.n411 0.267428
R12452 VSS.n439 VSS.n410 0.267428
R12453 VSS.n439 VSS.n409 0.267428
R12454 VSS.n439 VSS.n408 0.267428
R12455 VSS.n439 VSS.n407 0.267428
R12456 VSS.n439 VSS.n369 0.267428
R12457 VSS.n439 VSS.n370 0.267428
R12458 VSS.n439 VSS.n406 0.267428
R12459 VSS.n439 VSS.n371 0.267428
R12460 VSS.n439 VSS.n405 0.267428
R12461 VSS.n439 VSS.n403 0.267428
R12462 VSS.n439 VSS.n402 0.267428
R12463 VSS.n439 VSS.n401 0.267428
R12464 VSS.n439 VSS.n400 0.267428
R12465 VSS.n439 VSS.n399 0.267428
R12466 VSS.n439 VSS.n398 0.267428
R12467 VSS.n439 VSS.n397 0.267428
R12468 VSS.n439 VSS.n373 0.267428
R12469 VSS.n439 VSS.n374 0.267428
R12470 VSS.n439 VSS.n395 0.267428
R12471 VSS.n439 VSS.n394 0.267428
R12472 VSS.n439 VSS.n393 0.267428
R12473 VSS.n439 VSS.n391 0.267428
R12474 VSS.n439 VSS.n390 0.267428
R12475 VSS.n439 VSS.n389 0.267428
R12476 VSS.n439 VSS.n388 0.267428
R12477 VSS.n439 VSS.n387 0.267428
R12478 VSS.n439 VSS.n386 0.267428
R12479 VSS.n439 VSS.n385 0.267428
R12480 VSS.n439 VSS.n376 0.267428
R12481 VSS.n439 VSS.n377 0.267428
R12482 VSS.n439 VSS.n383 0.267428
R12483 VSS.n439 VSS.n382 0.267428
R12484 VSS.n439 VSS.n381 0.267428
R12485 VSS.n439 VSS.n379 0.267428
R12486 VSS.n2113 VSS.n2116 0.266415
R12487 VSS.n2731 VSS.n2730 0.265797
R12488 VSS.t786 VSS.n1425 0.264468
R12489 VSS.t87 VSS.n1079 0.264468
R12490 VSS.t1871 VSS.n695 0.264294
R12491 VSS.t16 VSS.n1345 0.264294
R12492 VSS.n2730 VSS.n2729 0.263915
R12493 VSS.t731 VSS.n47 0.26243
R12494 VSS.n2127 VSS.n2135 0.260023
R12495 VSS.n294 VSS.t286 0.054987
R12496 VSS.n288 VSS.t274 0.054987
R12497 VSS.t240 VSS.n253 0.196418
R12498 VSS.t452 VSS.n341 0.196418
R12499 VSS.t439 VSS.n335 0.196418
R12500 VSS.t416 VSS.n321 0.196418
R12501 VSS.t404 VSS.n311 0.196418
R12502 VSS.t248 VSS.n258 0.360608
R12503 VSS.t1546 VSS.t497 0.254653
R12504 VSS.t1605 VSS.t1404 0.254653
R12505 VSS.t1591 VSS.t1119 0.254637
R12506 VSS.t1616 VSS.t614 0.254637
R12507 VSS.t589 VSS.t1557 0.254476
R12508 VSS.t1618 VSS.n772 0.254083
R12509 VSS.n3017 VSS.n676 0.25394
R12510 VSS.n3002 VSS.n2999 0.25394
R12511 VSS.n2795 VSS.n2794 0.25394
R12512 VSS.n1683 VSS.t1548 0.25353
R12513 VSS.n2926 VSS.t1812 0.24355
R12514 VSS.n1238 VSS.t52 0.24355
R12515 VSS.n1686 VSS.t470 0.24305
R12516 VSS.n779 VSS.t684 0.24305
R12517 VSS.t2259 VSS.n1896 0.243044
R12518 VSS.n2123 VSS.n2122 0.241289
R12519 VSS.n2126 VSS.n2132 0.240382
R12520 VSS.t67 VSS.n1074 0.239685
R12521 VSS.t76 VSS.n575 0.239685
R12522 VSS.n1745 VSS.n1740 0.239685
R12523 VSS.n2534 VSS.n2533 0.239006
R12524 VSS.n2691 VSS.n2690 0.239006
R12525 VSS.n2714 VSS.n528 0.332933
R12526 VSS.n2713 VSS.n515 0.42443
R12527 VSS.t814 VSS.n494 0.332933
R12528 VSS.n490 VSS.n2686 0.427711
R12529 VSS.n2689 VSS.n478 0.333474
R12530 VSS.n486 VSS.n2689 0.380291
R12531 VSS.n2690 VSS.n483 0.333474
R12532 VSS.t810 VSS.n497 0.380291
R12533 VSS.n492 VSS.t814 0.332521
R12534 VSS.n2715 VSS.n512 0.42443
R12535 VSS.n2711 VSS.n507 1.1658
R12536 VSS.n525 VSS.t808 0.141785
R12537 VSS.n246 VSS.n2560 0.332521
R12538 VSS.n2752 VSS.n2112 0.238218
R12539 VSS.n2686 VSS.n2150 0.237793
R12540 VSS.n2782 VSS.n457 0.325664
R12541 VSS.n1778 VSS.n1753 0.226107
R12542 VSS.n2764 VSS.n2763 0.225674
R12543 VSS.n292 VSS.t279 0.0736713
R12544 VSS.n285 VSS.t267 0.0736713
R12545 VSS.n269 VSS.t254 0.0736713
R12546 VSS.n255 VSS.t243 0.0736713
R12547 VSS.t234 VSS.n251 0.148371
R12548 VSS.t445 VSS.n339 0.148371
R12549 VSS.t433 VSS.n333 0.148371
R12550 VSS.t422 VSS.n326 0.148371
R12551 VSS.t410 VSS.n316 0.148371
R12552 VSS.t398 VSS.n306 0.148371
R12553 VSS.t339 VSS.t342 0.224424
R12554 VSS.t293 VSS.t295 0.224424
R12555 VSS.t224 VSS.t221 0.224424
R12556 VSS.t386 VSS.t388 0.224424
R12557 VSS.t458 VSS.t456 0.224424
R12558 VSS.n2136 VSS.n2135 0.224399
R12559 VSS.t339 VSS.n583 0.0724751
R12560 VSS.t255 VSS.t254 0.220674
R12561 VSS.t292 VSS.n295 0.145945
R12562 VSS.t279 VSS.t280 0.220674
R12563 VSS.t267 VSS.t268 0.220674
R12564 VSS.t243 VSS.t244 0.220674
R12565 VSS.t231 VSS.t232 0.220674
R12566 VSS.t221 VSS.n441 0.0724751
R12567 VSS.t386 VSS.n585 0.0724751
R12568 VSS.n345 VSS.t456 0.0724751
R12569 VSS.t442 VSS.t443 0.220674
R12570 VSS.t431 VSS.t150 0.220674
R12571 VSS.t419 VSS.t420 0.220674
R12572 VSS.t407 VSS.t408 0.220674
R12573 VSS.t396 VSS.t147 0.220674
R12574 VSS.n2763 VSS.n2106 0.219424
R12575 VSS.t715 VSS.n250 1.12475
R12576 VSS.t176 VSS.n302 1.12475
R12577 VSS.t259 VSS.n272 0.30699
R12578 VSS.n331 VSS.t427 0.159942
R12579 VSS.t529 VSS.n463 0.211735
R12580 VSS.n2761 VSS.n2760 0.20686
R12581 VSS.n588 VSS.n1117 0.297117
R12582 VSS.t1689 VSS.n442 0.201909
R12583 VSS.t1187 VSS.n2127 0.201011
R12584 VSS.n2773 VSS.n551 0.195641
R12585 VSS.n2102 VSS.n551 0.195641
R12586 VSS.n2103 VSS.n2102 0.195641
R12587 VSS.n2770 VSS.n446 0.292602
R12588 VSS.n2771 VSS.n2770 0.195641
R12589 VSS.n2701 VSS.n522 0.286815
R12590 VSS.n2687 VSS.n474 0.286042
R12591 VSS.n2688 VSS.n2687 0.191235
R12592 VSS.n483 VSS.n480 0.380849
R12593 VSS.t1569 VSS.n2145 0.191235
R12594 VSS.n2717 VSS.t1563 0.191235
R12595 VSS.n588 VSS.n1235 0.23732
R12596 VSS.t808 VSS.n500 0.468871
R12597 VSS.t805 VSS.n502 0.468871
R12598 VSS.t804 VSS.n2713 0.191235
R12599 VSS.t1569 VSS.t807 0.191235
R12600 VSS.t288 VSS.n2289 0.1883
R12601 VSS.n1018 VSS.t451 0.1883
R12602 VSS.t1586 VSS.t1588 0.1875
R12603 VSS.t1583 VSS.t1580 0.1875
R12604 VSS.t1577 VSS.t1574 0.1875
R12605 VSS.t1552 VSS.t1554 0.1875
R12606 VSS.t1541 VSS.t1543 0.1875
R12607 VSS.t1598 VSS.t1601 0.1875
R12608 VSS.t1611 VSS.t1613 0.1875
R12609 VSS.n278 VSS.n282 0.16313
R12610 VSS.n2777 VSS.n451 0.279772
R12611 VSS.n2778 VSS.n2777 0.187025
R12612 VSS.n2779 VSS.n453 0.279772
R12613 VSS.n2780 VSS.n2779 0.187025
R12614 VSS.n2781 VSS.n2780 0.187025
R12615 VSS.n460 VSS.n2782 0.279772
R12616 VSS.n2783 VSS.n460 0.279772
R12617 VSS.n462 VSS.n2783 0.279772
R12618 VSS.n2138 VSS.n2141 0.181924
R12619 VSS.n2694 VSS.n2693 0.181543
R12620 VSS.n2134 VSS 0.179433
R12621 VSS.t331 VSS.t317 0.325891
R12622 VSS.t122 VSS.t200 0.325891
R12623 VSS.t2 VSS.t364 0.324709
R12624 VSS.n2718 VSS.t1561 0.167615
R12625 VSS.n2104 VSS.n2103 0.167615
R12626 VSS.n2693 VSS.n2696 0.164808
R12627 VSS.n2139 VSS.n2138 0.164424
R12628 VSS.n1749 VSS.n1731 0.16137
R12629 VSS.n1749 VSS.n1739 0.16137
R12630 VSS.n1749 VSS.n1744 0.16137
R12631 VSS.n439 VSS.n358 0.160396
R12632 VSS.n439 VSS.n356 0.160396
R12633 VSS.n439 VSS.n355 0.160396
R12634 VSS.n60 VSS.n508 7.45387
R12635 VSS.n2768 VSS.n2767 0.156138
R12636 VSS.n2727 VSS.n2723 0.150687
R12637 VSS.t1671 VSS.n559 0.149172
R12638 VSS.n2774 VSS.n2773 0.146675
R12639 VSS.n2698 VSS.n2137 0.143368
R12640 VSS.n2921 VSS.n2920 0.142513
R12641 VSS.n2695 VSS.n2702 0.142012
R12642 VSS.t1608 VSS.n1117 0.139294
R12643 VSS.t1595 VSS.n440 0.219067
R12644 VSS.t1685 VSS.n442 0.13875
R12645 VSS.n2696 VSS.n2695 0.138262
R12646 VSS.n3017 VSS.n3016 0.138073
R12647 VSS.n3003 VSS.n3002 0.138073
R12648 VSS.n2726 VSS.n1317 0.138073
R12649 VSS.n2794 VSS.n1751 0.138073
R12650 VSS.t1812 VSS.t1589 0.135868
R12651 VSS.t2259 VSS.t1555 0.135868
R12652 VSS.t470 VSS.t1544 0.135868
R12653 VSS.t52 VSS.t1602 0.135868
R12654 VSS.t684 VSS.t1614 0.135868
R12655 VSS.n2289 VSS.t289 0.133638
R12656 VSS.t452 VSS.n1018 0.133638
R12657 VSS.n2799 VSS.n25 0.124938
R12658 VSS.n2673 VSS.n25 0.124938
R12659 VSS.t1557 VSS.n1905 0.124618
R12660 VSS.t1616 VSS.n771 0.124618
R12661 VSS.t1546 VSS.n1681 0.124618
R12662 VSS.t1591 VSS.n1381 0.124618
R12663 VSS.t1605 VSS.n1115 0.124618
R12664 VSS.n1905 VSS.t1558 0.122118
R12665 VSS.n1904 VSS.t1555 0.122118
R12666 VSS.t1617 VSS.n771 0.122118
R12667 VSS.t1614 VSS.n777 0.122118
R12668 VSS.t1547 VSS.n1681 0.122118
R12669 VSS.t1544 VSS.n1685 0.122118
R12670 VSS.t1592 VSS.n1381 0.122118
R12671 VSS.t1589 VSS.n2918 0.122118
R12672 VSS.t1602 VSS.n1067 0.122118
R12673 VSS.t1604 VSS.n1115 0.122118
R12674 VSS.n2699 VSS.n2698 0.120868
R12675 VSS.n2027 VSS.n1955 0.119618
R12676 VSS.n1823 VSS.t698 0.119618
R12677 VSS.n727 VSS.n726 0.119618
R12678 VSS.t687 VSS.n916 0.119618
R12679 VSS.n1523 VSS.n1522 0.119618
R12680 VSS.t473 VSS.n1709 0.119618
R12681 VSS.n1359 VSS.n1358 0.119618
R12682 VSS.t1815 VSS.n2847 0.119618
R12683 VSS.t55 VSS.n1164 0.119618
R12684 VSS.n1093 VSS.n1092 0.119618
R12685 VSS.t1667 VSS.n559 0.119253
R12686 VSS.n758 VSS.n757 0.118368
R12687 VSS.n827 VSS.t711 0.118368
R12688 VSS.n1627 VSS.n1626 0.117118
R12689 VSS.n1374 VSS.n1373 0.117118
R12690 VSS.n1108 VSS.n1107 0.117118
R12691 VSS.n2890 VSS.t1239 0.117118
R12692 VSS.t2098 VSS.n1871 0.117118
R12693 VSS.n1693 VSS.t657 0.117118
R12694 VSS.n1207 VSS.t939 0.117118
R12695 VSS.n2697 VSS.t1566 0.1171
R12696 VSS.n2145 VSS.n2147 0.112118
R12697 VSS.n2153 VSS.n2717 0.112118
R12698 VSS.t1593 VSS.n2920 0.109642
R12699 VSS.n1235 VSS.t1606 0.109642
R12700 VSS.n2141 VSS.n2140 0.104618
R12701 VSS.n2703 VSS.n2694 0.104618
R12702 VSS.t1695 VSS.n442 0.103851
R12703 VSS.n545 VSS.n544 0.100834
R12704 VSS.t1578 VSS.n2110 0.0971176
R12705 VSS.n2768 VSS.n29 0.586003
R12706 VSS.t1677 VSS.n559 0.0959946
R12707 VSS.n2767 VSS.n2766 0.0958002
R12708 VSS.n2766 VSS.n2765 0.0955
R12709 VSS.n513 VSS.n2697 0.268339
R12710 VSS.n2112 VSS.n2114 0.093
R12711 VSS.t1127 VSS.n1383 0.0928744
R12712 VSS.t1845 VSS.n773 0.0928744
R12713 VSS.n2791 VSS.t1550 0.08925
R12714 VSS.t1609 VSS.n691 0.08925
R12715 VSS.n1748 VSS.t1538 0.08925
R12716 VSS.t1584 VSS.n1342 0.08925
R12717 VSS.t1596 VSS.n1076 0.08925
R12718 VSS.t1232 VSS.n1773 0.08925
R12719 VSS.t1540 VSS.n1729 0.08925
R12720 VSS.t1509 VSS.n1118 0.08925
R12721 VSS.t1759 VSS.n1823 0.0883676
R12722 VSS.n1872 VSS.t2098 0.0883676
R12723 VSS.n916 VSS.t662 0.0883676
R12724 VSS.t711 VSS.n828 0.0883676
R12725 VSS.n1709 VSS.t882 0.0883676
R12726 VSS.t657 VSS.n1694 0.0883676
R12727 VSS.t1057 VSS.n2847 0.0883676
R12728 VSS.t1239 VSS.n2894 0.0883676
R12729 VSS.t2028 VSS.n1164 0.0883676
R12730 VSS.t939 VSS.n1211 0.0883676
R12731 VSS.n1727 VSS.t1541 0.0851154
R12732 VSS.t1543 VSS.n1726 0.0851154
R12733 VSS.n2751 VSS.t1580 0.0851154
R12734 VSS.n2749 VSS.t1583 0.0851154
R12735 VSS.n2755 VSS.t1574 0.0851154
R12736 VSS.n2753 VSS.t1577 0.0851154
R12737 VSS.n2994 VSS.t1586 0.0851154
R12738 VSS.t1588 VSS.n2805 0.0851154
R12739 VSS.n1306 VSS.t1598 0.0851154
R12740 VSS.t1601 VSS.n1122 0.0851154
R12741 VSS.n1002 VSS.t1611 0.0851154
R12742 VSS.t1613 VSS.n1001 0.0851154
R12743 VSS.n1776 VSS.t1552 0.0851154
R12744 VSS.t1554 VSS.n1775 0.0851154
R12745 VSS.n2736 VSS.n2735 0.08425
R12746 VSS.n2708 VSS.n2707 0.08425
R12747 VSS.n2756 VSS.n2755 0.08175
R12748 VSS.n2111 VSS.n2751 0.08175
R12749 VSS.n2117 VSS.n2118 0.08175
R12750 VSS.n2107 VSS.n2108 0.08175
R12751 VSS.n2329 VSS.n1899 0.0805
R12752 VSS.t1618 VSS.n774 0.0805
R12753 VSS.n1684 VSS.t1548 0.0805
R12754 VSS.n2741 VSS.n2740 0.0805
R12755 VSS.n2923 VSS.n2919 0.0805
R12756 VSS.n3005 VSS.n3004 0.0805
R12757 VSS.n2147 VSS.n2146 0.0796176
R12758 VSS.n2153 VSS.n2152 0.0796176
R12759 VSS.t1288 VSS.n1955 0.0771176
R12760 VSS.n1902 VSS.n1901 0.0771176
R12761 VSS.t796 VSS.n727 0.0771176
R12762 VSS.t591 VSS.n758 0.0771176
R12763 VSS.t1406 VSS.n1523 0.0771176
R12764 VSS.t119 VSS.n1627 0.0771176
R12765 VSS.t99 VSS.n1359 0.0771176
R12766 VSS.t1312 VSS.n1374 0.0771176
R12767 VSS.t1595 VSS.n1382 0.0771176
R12768 VSS.t780 VSS.n1093 0.0771176
R12769 VSS.t111 VSS.n1108 0.0771176
R12770 VSS.t1608 VSS.n1116 0.0771176
R12771 VSS.n2742 VSS.n2741 0.07675
R12772 VSS.n2146 VSS.n2731 0.0758676
R12773 VSS.n2720 VSS.n2152 0.0758676
R12774 VSS.n1777 VSS.n1756 0.0746176
R12775 VSS.n1776 VSS.n1774 0.0746176
R12776 VSS.n999 VSS.n692 0.0746176
R12777 VSS.n1003 VSS.n1002 0.0746176
R12778 VSS.n1724 VSS.n1419 0.0746176
R12779 VSS.n1728 VSS.n1727 0.0746176
R12780 VSS.n2992 VSS.n1343 0.0746176
R12781 VSS.n2995 VSS.n2994 0.0746176
R12782 VSS.n1307 VSS.n1306 0.0746176
R12783 VSS.n1304 VSS.n1077 0.0746176
R12784 VSS.n2665 VSS.n541 0.07425
R12785 VSS.n2740 VSS.n2139 0.07425
R12786 VSS.n2120 VSS.t1572 0.0740901
R12787 VSS.t887 VSS.n541 0.07175
R12788 VSS.t1558 VSS.n1902 0.0696176
R12789 VSS.t1592 VSS.n1382 0.0696176
R12790 VSS.n1116 VSS.t1604 0.0696176
R12791 VSS.n1777 VSS.n1754 0.06925
R12792 VSS.t1234 VSS.n1776 0.06925
R12793 VSS.t297 VSS.n297 0.103847
R12794 VSS.n293 VSS.t284 0.0238559
R12795 VSS.n286 VSS.t272 0.0238559
R12796 VSS.n271 VSS.t257 0.0979592
R12797 VSS.n256 VSS.t246 0.0979592
R12798 VSS.n252 VSS.t236 0.0238559
R12799 VSS.n999 VSS.n694 0.06925
R12800 VSS.n1002 VSS.t1847 0.06925
R12801 VSS.t460 VSS.n346 0.103847
R12802 VSS.n340 VSS.t447 0.0238559
R12803 VSS.n334 VSS.t435 0.0238559
R12804 VSS.n327 VSS.t425 0.0238559
R12805 VSS.n317 VSS.t412 0.0238559
R12806 VSS.n307 VSS.t400 0.0238559
R12807 VSS.n1724 VSS.n1422 0.06925
R12808 VSS.n1727 VSS.t2024 0.06925
R12809 VSS.n2737 VSS.n2736 0.06925
R12810 VSS.n2707 VSS.n2706 0.06925
R12811 VSS.t887 VSS.n2742 0.06925
R12812 VSS.n2992 VSS.n1344 0.06925
R12813 VSS.n2994 VSS.t1129 0.06925
R12814 VSS.n1306 VSS.t1867 0.06925
R12815 VSS.n1304 VSS.n1078 0.06925
R12816 VSS.n2754 VSS.n2753 0.0671176
R12817 VSS.n2750 VSS.n2749 0.0671176
R12818 VSS.n2116 VSS.n2115 0.0671176
R12819 VSS.n2106 VSS.n2105 0.0671176
R12820 VSS.n2789 VSS.n1901 0.06675
R12821 VSS.n2755 VSS.n2754 0.0621177
R12822 VSS.n2751 VSS.n2750 0.0621177
R12823 VSS.n2115 VSS.n2117 0.0621177
R12824 VSS.n2105 VSS.n2107 0.0621177
R12825 VSS.n1778 VSS.n1754 0.05925
R12826 VSS.n1000 VSS.n694 0.05925
R12827 VSS.n1725 VSS.n1422 0.05925
R12828 VSS.n2993 VSS.n1344 0.05925
R12829 VSS.n1305 VSS.n1078 0.05925
R12830 VSS.n2805 VSS.t1129 0.05925
R12831 VSS.n1775 VSS.t1234 0.05925
R12832 VSS.n1726 VSS.t2024 0.05925
R12833 VSS.n1122 VSS.t1867 0.05925
R12834 VSS.n1001 VSS.t1847 0.05925
R12835 VSS.t260 VSS.n2562 0.058
R12836 VSS.t425 VSS.n1032 0.058
R12837 VSS.n2110 VSS.t2196 0.0571176
R12838 VSS.t1682 VSS.n2774 0.0567791
R12839 VSS.n1756 VSS.t1550 0.0546176
R12840 VSS.n1774 VSS.t1232 0.0546176
R12841 VSS.t1609 VSS.n692 0.0546176
R12842 VSS.n1003 VSS.t1845 0.0546176
R12843 VSS.t1538 VSS.n1419 0.0546176
R12844 VSS.t1540 VSS.n1728 0.0546176
R12845 VSS.t1584 VSS.n1343 0.0546176
R12846 VSS.n2995 VSS.t1127 0.0546176
R12847 VSS.n1307 VSS.t1509 0.0546176
R12848 VSS.t1596 VSS.n1077 0.0546176
R12849 VSS.t282 VSS.n293 0.0979592
R12850 VSS.t270 VSS.n286 0.0979592
R12851 VSS.t234 VSS.n252 0.0979592
R12852 VSS.t445 VSS.n340 0.0979592
R12853 VSS.t433 VSS.n334 0.0979592
R12854 VSS.t422 VSS.n327 0.0979592
R12855 VSS.t410 VSS.n317 0.0979592
R12856 VSS.t398 VSS.n307 0.0979592
R12857 VSS.n2140 VSS.n2739 0.0496177
R12858 VSS.n2704 VSS.n2703 0.0496177
R12859 VSS.n2757 VSS.n2123 0.04925
R12860 VSS.n2758 VSS.n2757 0.04925
R12861 VSS.n2114 VSS.n2109 0.04925
R12862 VSS.n2700 VSS.n2697 0.04925
R12863 VSS.n2741 VSS.n2137 0.048
R12864 VSS.n2109 VSS.n2111 0.04675
R12865 VSS.n2108 VSS.t1578 0.04675
R12866 VSS.t259 VSS.n2562 0.038
R12867 VSS.n1032 VSS.t424 0.038
R12868 VSS.n448 VSS.n2101 0.123723
R12869 VSS.n2759 VSS.n2756 0.0305
R12870 VSS.n2118 VSS.n2762 0.0305
R12871 VSS.t875 VSS.n1986 0.02925
R12872 VSS.t1559 VSS.n1900 0.02925
R12873 VSS.n2922 VSS.t1593 0.02925
R12874 VSS.t1606 VSS.n630 0.02925
R12875 VSS.n2729 VSS.n2150 0.028
R12876 VSS.n61 VSS.n25 0.0119264
R12877 VSS.n2121 VSS.n2120 0.0253401
R12878 VSS.n1055 VSS.n32 0.023135
R12879 VSS.n1047 VSS.n32 0.023135
R12880 VSS.n1043 VSS.n32 0.023135
R12881 VSS.n63 VSS.n32 0.0134258
R12882 VSS.n1037 VSS.n303 0.023135
R12883 VSS.t403 VSS.n45 413.695
R12884 VSS.t1939 VSS.n46 110.549
R12885 VSS.n1034 VSS.n313 0.023135
R12886 VSS.t415 VSS.n42 413.695
R12887 VSS.t727 VSS.n43 110.549
R12888 VSS.n1030 VSS.n323 0.023135
R12889 VSS.t428 VSS.n49 413.695
R12890 VSS.n48 VSS.n47 0.0058807
R12891 VSS.t438 VSS.n39 413.695
R12892 VSS.t1941 VSS.n40 110.549
R12893 VSS.n1026 VSS.n75 0.023135
R12894 VSS.n1019 VSS.n78 0.023135
R12895 VSS.n87 VSS.n84 0.023135
R12896 VSS.n1023 VSS.n342 0.023135
R12897 VSS.n80 VSS.n78 0.0134258
R12898 VSS.n1904 VSS.n1899 0.02175
R12899 VSS.n777 VSS.n774 0.02175
R12900 VSS.n1685 VSS.n1684 0.02175
R12901 VSS.n2918 VSS.n2919 0.02175
R12902 VSS.n3004 VSS.n1067 0.02175
R12903 VSS.n2769 VSS.n2104 0.0214413
R12904 VSS.t529 VSS.n464 0.0173993
R12905 VSS.n2759 VSS.n2758 0.01675
R12906 VSS.n2762 VSS.t1572 0.01675
R12907 VSS.n1749 VSS.n1730 0.0166972
R12908 VSS.n1749 VSS.n1735 0.0166972
R12909 VSS.n2611 VSS.n15 0.0165968
R12910 VSS.t239 VSS.n71 495.649
R12911 VSS.t331 VSS.t335 57.5432
R12912 VSS.t348 VSS.t331 115.335
R12913 VSS.t122 VSS.t1705 131.587
R12914 VSS.t122 VSS.t6 57.4585
R12915 VSS.t122 VSS.t229 115.335
R12916 VSS.t2 VSS.t1141 57.4585
R12917 VSS.t2 VSS.t394 115.335
R12918 VSS.n439 VSS.n359 0.0165542
R12919 VSS.n439 VSS.n357 0.0165542
R12920 VSS.n2329 VSS.n1900 0.0155
R12921 VSS.n2923 VSS.n2922 0.0155
R12922 VSS.n3005 VSS.n630 0.0155
R12923 VSS.t529 VSS.n467 0.0150892
R12924 VSS.n2765 VSS.n2764 0.013
R12925 VSS.n582 VSS.n572 0.00975656
R12926 VSS.n1749 VSS.n1421 0.0096403
R12927 VSS.n1749 VSS.n1430 0.0096403
R12928 VSS.n1749 VSS.n1446 0.0096403
R12929 VSS.n1749 VSS.n1462 0.0096403
R12930 VSS.n1749 VSS.n1478 0.0096403
R12931 VSS.n1749 VSS.n1494 0.0096403
R12932 VSS.n1749 VSS.n1510 0.0096403
R12933 VSS.n1749 VSS.n1527 0.0096403
R12934 VSS.n1749 VSS.n1543 0.0096403
R12935 VSS.n1749 VSS.n1559 0.0096403
R12936 VSS.n1749 VSS.n1575 0.0096403
R12937 VSS.n1749 VSS.n1591 0.0096403
R12938 VSS.n1749 VSS.n1607 0.0096403
R12939 VSS.n1749 VSS.n1623 0.0096403
R12940 VSS.n1749 VSS.n1640 0.0096403
R12941 VSS.n1749 VSS.n1656 0.0096403
R12942 VSS.n1749 VSS.n1672 0.0096403
R12943 VSS.n1749 VSS.n1680 0.0096403
R12944 VSS.n589 VSS.n623 0.00962826
R12945 VSS.n775 VSS.n992 0.00938635
R12946 VSS.n775 VSS.n980 0.00938635
R12947 VSS.n775 VSS.n953 0.00938635
R12948 VSS.n775 VSS.n941 0.00938635
R12949 VSS.n775 VSS.n913 0.00938635
R12950 VSS.n589 VSS.n628 0.00938635
R12951 VSS.n439 VSS.n437 0.00938635
R12952 VSS.n439 VSS.n435 0.00938635
R12953 VSS.n439 VSS.n424 0.00938635
R12954 VSS.n439 VSS.n414 0.00938635
R12955 VSS.n439 VSS.n404 0.00938635
R12956 VSS.n439 VSS.n396 0.00938635
R12957 VSS.n439 VSS.n392 0.00938635
R12958 VSS.n439 VSS.n384 0.00938635
R12959 VSS.n439 VSS.n380 0.00938635
R12960 VSS.n439 VSS.n352 0.00938635
R12961 VSS.n439 VSS.n351 0.00938635
R12962 VSS.n439 VSS.n350 0.00938635
R12963 VSS.n775 VSS.n778 0.00938222
R12964 VSS.n775 VSS.n766 0.00937856
R12965 VSS.n775 VSS.n743 0.00937856
R12966 VSS.n775 VSS.n723 0.00937856
R12967 VSS.n775 VSS.n708 0.00937856
R12968 VSS.n775 VSS.n693 0.00937856
R12969 VSS.n775 VSS.n901 0.00937856
R12970 VSS.n775 VSS.n859 0.00937856
R12971 VSS.n775 VSS.n845 0.00937856
R12972 VSS.n775 VSS.n831 0.00937856
R12973 VSS.n775 VSS.n788 0.00937856
R12974 VSS.n589 VSS.n668 0.00937856
R12975 VSS.n589 VSS.n660 0.00937856
R12976 VSS.n589 VSS.n613 0.00937856
R12977 VSS.n589 VSS.n606 0.00937856
R12978 VSS.n439 VSS.n364 0.00937856
R12979 VSS.n439 VSS.n368 0.00937856
R12980 VSS.n439 VSS.n372 0.00937856
R12981 VSS.n439 VSS.n375 0.00937856
R12982 VSS.n775 VSS.n886 0.00937856
R12983 VSS.n775 VSS.n815 0.00937856
R12984 VSS.n589 VSS.n674 0.00937856
R12985 VSS.n589 VSS.n672 0.00937856
R12986 VSS.n589 VSS.n667 0.00937856
R12987 VSS.n589 VSS.n664 0.00937856
R12988 VSS.n589 VSS.n659 0.00937856
R12989 VSS.n589 VSS.n656 0.00937856
R12990 VSS.n589 VSS.n653 0.00937856
R12991 VSS.n589 VSS.n649 0.00937856
R12992 VSS.n589 VSS.n640 0.00937856
R12993 VSS.n589 VSS.n636 0.00937856
R12994 VSS.n589 VSS.n611 0.00937856
R12995 VSS.n589 VSS.n604 0.00937856
R12996 VSS.n439 VSS.n430 0.00937856
R12997 VSS.n439 VSS.n353 0.00937856
R12998 VSS.n2792 VSS.n2791 0.00675
R12999 VSS.n1773 VSS.t76 0.00675
R13000 VSS.n691 VSS.n675 0.00675
R13001 VSS.n1748 VSS.n1747 0.00675
R13002 VSS.n1740 VSS.n1729 0.00675
R13003 VSS.n2724 VSS.n1342 0.00675
R13004 VSS.n1118 VSS.t67 0.00675
R13005 VSS.n3000 VSS.n1076 0.00675
R13006 VSS.n550 VSS.n514 0.00495229
R13007 VSS.n513 VSS.n2699 0.164232
R13008 VSS.n773 VSS.t935 0.00412443
R13009 VSS.t14 VSS.n1383 0.00412443
R13010 VSS.n564 VSS.n452 0.00439839
R13011 VSS.n552 VSS.n443 0.00424743
R13012 VSS.n531 VSS.n508 0.00589836
R13013 VSS.n548 VSS.n514 0.00549963
R13014 VSS.n517 VSS.n499 0.00533271
R13015 VSS.n2143 VSS.n529 0.00474925
R13016 VSS.n557 VSS.n445 0.00362425
R13017 VSS.n569 VSS.n459 0.00299994
R13018 VSS.n561 VSS.n449 0.00274942
R13019 VSS.n444 VSS.n442 0.00249997
R13020 VSS.n506 VSS.n2712 0.00474895
R13021 VSS.n511 VSS.n501 0.00449923
R13022 VSS.n529 VSS.n503 0.00437467
R13023 VSS.n549 VSS.n501 0.00437467
R13024 VSS.n499 VSS.n498 0.00437467
R13025 VSS.n2685 VSS.n509 0.00333299
R13026 VSS.n484 VSS.n482 0.00187482
R13027 VSS.n476 VSS.n475 0.00224999
R13028 VSS.n471 VSS.n536 0.00266647
R13029 VSS.n533 VSS.n491 0.00249999
R13030 VSS.n472 VSS.n471 0.00224999
R13031 VSS.n2702 VSS.n2701 0.00224991
R13032 VSS.n2743 VSS.n545 0.00216667
R13033 VSS.n587 VSS.n589 0.00105218
R13034 VSS.n1056 VSS.n32 0.00181696
R13035 VSS.n1051 VSS.n32 0.00181696
R13036 VSS.n305 VSS.n304 0.00181696
R13037 VSS.n310 VSS.n308 0.00181696
R13038 VSS.n310 VSS.n309 0.00181696
R13039 VSS.n315 VSS.n314 0.00181696
R13040 VSS.n320 VSS.n318 0.00181696
R13041 VSS.n320 VSS.n319 0.00181696
R13042 VSS.n325 VSS.n324 0.00181696
R13043 VSS.n330 VSS.n328 0.00181696
R13044 VSS.n330 VSS.n329 0.00181696
R13045 VSS.n38 VSS.t432 148.827
R13046 VSS.n21 VSS.n20 0.0016746
R13047 VSS.n338 VSS.n337 0.00181696
R13048 VSS.n78 VSS.n77 0.00181696
R13049 VSS.n1022 VSS.n86 0.00179957
R13050 VSS.n1021 VSS.n86 0.00179957
R13051 VSS.n344 VSS.n343 0.00179957
R13052 VSS.n2550 VSS.n51 0.00166667
R13053 VSS.n279 VSS.n277 0.00158327
R13054 VSS.n535 VSS.n489 0.00169993
R13055 VSS.n504 VSS.n518 0.00169993
R13056 VSS.n55 VSS.n53 0.00166667
R13057 VSS.n496 VSS.n495 0.00169993
R13058 VSS.n57 VSS.n56 0.00166667
R13059 VSS.n534 VSS.n533 0.00149995
R13060 VSS.n538 VSS.n485 0.00169993
R13061 VSS.n524 VSS.n523 0.00158327
R13062 VSS.n2743 VSS.n530 0.00351501
R13063 VSS.n482 VSS.n481 0.00349999
R13064 VSS.n521 VSS.n520 0.00269993
R13065 VSS.n505 VSS.n504 0.00262501
R13066 VSS.n548 VSS.n547 0.00138884
R13067 VSS.n2712 VSS.n510 0.00166667
R13068 VSS.n569 VSS.n568 0.00149995
R13069 VSS.n545 VSS.n523 0.002
R13070 VSS.n582 VSS.n240 0.00149998
R13071 VSS.n570 VSS.n458 0.00199984
R13072 VSS.n567 VSS.n454 0.00199997
R13073 VSS.n450 VSS.n449 0.0015
R13074 VSS.n559 VSS.n447 0.0015
R13075 VSS.n527 VSS.n516 0.00324982
R13076 VSS.n2668 VSS.n479 0.00291666
R13077 VSS.n487 VSS.n477 0.00321391
R13078 VSS.n489 VSS.n473 0.00421391
R13079 VSS.n532 VSS.n493 0.00269993
R13080 VSS.n2143 VSS.n491 0.00237498
R13081 VSS.n2668 VSS.n485 0.00233332
R13082 VSS.n537 VSS.n487 0.00224999
R13083 VSS.n29 VSS.n8 1.12174
R13084 VSS.n276 VSS.n273 0.00283308
R13085 VSS.n559 VSS.n461 0.002
R13086 VSS.n459 VSS.n458 0.002
R13087 VSS.n444 VSS.n443 0.002
R13088 VSS.n279 VSS.n278 0.002
R13089 VSS.n249 VSS.n248 0.002
R13090 VSS.n260 VSS.n16 0.002
R13091 VSS.n439 VSS.n378 0.00103718
R13092 VSS.n567 VSS.n456 0.00199997
R13093 VSS.n566 VSS.n454 0.00199997
R13094 VSS.n562 VSS.n452 0.00199997
R13095 VSS.n442 VSS.n450 0.00199997
R13096 VSS.n558 VSS.n447 0.00199997
R13097 VSS.n555 VSS.n445 0.00199997
R13098 VSS.n244 VSS.n101 0.00175
R13099 VSS.t2 VSS.t2327 131.593
R13100 VSS.n87 VSS.n85 0.00151876
R13101 VSS.t908 VSS.n24 308.156
R13102 VSS.n78 VSS.n76 0.00150241
R13103 VSS.n1020 VSS.n78 0.00150006
R13104 VSS.n2603 VSS.t529 0.0015
R13105 VSS.n87 VSS.n86 0.0015
R13106 VSS.n342 VSS.n86 0.0015
R13107 VSS.n344 VSS.n342 0.0015
R13108 VSS.n344 VSS.n79 0.00103609
R13109 VSS.n78 VSS.n75 0.0015
R13110 VSS.n338 VSS.n75 0.0015
R13111 VSS.n338 VSS.n67 0.00103609
R13112 VSS.n330 VSS.n323 0.0015
R13113 VSS.n325 VSS.n323 0.0015
R13114 VSS.n325 VSS.n65 0.00103609
R13115 VSS.n320 VSS.n313 0.0015
R13116 VSS.n315 VSS.n313 0.0015
R13117 VSS.n315 VSS.n64 0.00103609
R13118 VSS.n310 VSS.n303 0.0015
R13119 VSS.n305 VSS.n303 0.0015
R13120 VSS.n305 VSS.n62 0.00103609
R13121 VSS.n296 VSS.n299 0.0015
R13122 VSS.n298 VSS.n296 0.0015
R13123 VSS.n298 VSS.n248 0.0015
R13124 VSS.n249 VSS.n247 0.0015
R13125 VSS.n291 VSS.n247 0.0015
R13126 VSS.n291 VSS.n289 0.0015
R13127 VSS.n289 VSS.n287 0.0015
R13128 VSS.n287 VSS.n283 0.0015
R13129 VSS.n284 VSS.n283 0.0015
R13130 VSS.n284 VSS.n278 0.0015
R13131 VSS.n274 VSS.n273 0.0015
R13132 VSS.n274 VSS.n267 0.0015
R13133 VSS.n268 VSS.n267 0.0015
R13134 VSS.n268 VSS.n259 0.0015
R13135 VSS.n260 VSS.n259 0.0015
R13136 VSS.n16 VSS.n15 0.0015
R13137 VSS.n25 VSS.n15 0.0015
R13138 VSS.n17 VSS.t237 140.101
R13139 VSS.t331 VSS.t304 120.838
R13140 VSS.t331 VSS.t306 140.102
R13141 VSS.t331 VSS.t318 120.838
R13142 VSS.t331 VSS.t333 67.8612
R13143 VSS.t122 VSS.t213 125.654
R13144 VSS.t2 VSS.t351 120.838
R13145 VSS.t922 VSS.n59 1.17582
R13146 VSS.n58 VSS.n496 0.00383314
R13147 VSS.n517 VSS.n55 0.00249999
R13148 VSS.n52 VSS.n245 0.00333314
R13149 VSS.t390 VSS.t2 140.102
R13150 VSS.t122 VSS.t227 140.102
R13151 VSS.t346 VSS.t331 140.102
R13152 VSS.n69 VSS.n47 0.00310309
R13153 VSS.n310 VSS.n44 0.00253752
R13154 VSS.n320 VSS.n41 0.00253752
R13155 VSS.n21 VSS.n19 0.00253752
R13156 VSS.n330 VSS.n47 0.00253744
R13157 VSS.t122 VSS.t192 125.654
R13158 VSS.t2 VSS.t360 140.102
R13159 VSS.t145 VSS.n34 177.636
R13160 VSS.n23 VSS.n8 1.79044
R13161 VSS.n6 VSS.t122 1.26774
R13162 VSS.n7 VSS.t331 1.26758
R13163 VSS.t1150 VSS.t2 1.04221
R13164 a_3747_311.n0 a_3747_311.t2 52.0388
R13165 a_3747_311.t1 a_3747_311.n0 35.4491
R13166 a_3747_311.n0 a_3747_311.t3 33.5891
R13167 a_3747_311.t0 a_3747_311.t1 5.61942
R13168 a_3171_311.n0 a_3171_311.t2 51.8377
R13169 a_3171_311.n0 a_3171_311.t3 33.3881
R13170 a_3171_311.t1 a_3171_311.n0 31.8923
R13171 a_3171_311.t0 a_3171_311.t1 5.61777
R13172 a_2595_311.n0 a_2595_311.t2 51.6367
R13173 a_2595_311.n0 a_2595_311.t3 33.187
R13174 a_2595_311.t1 a_2595_311.n0 27.993
R13175 a_2595_311.t0 a_2595_311.t1 5.73018
R13176 a_3747_1047.n0 a_3747_1047.t2 38.0081
R13177 a_3747_1047.n0 a_3747_1047.t3 33.3957
R13178 a_3747_1047.n1 a_3747_1047.t4 33.3957
R13179 a_3747_1047.n2 a_3747_1047.t5 33.3957
R13180 a_3747_1047.n3 a_3747_1047.t6 33.3957
R13181 a_3747_1047.n4 a_3747_1047.t7 33.3957
R13182 a_3747_1047.n5 a_3747_1047.t8 33.3957
R13183 a_3747_1047.n6 a_3747_1047.t9 33.3957
R13184 a_3747_1047.t1 a_3747_1047.n6 23.2419
R13185 a_3747_1047.t0 a_3747_1047.t1 5.61942
R13186 a_3747_1047.n6 a_3747_1047.n5 4.61291
R13187 a_3747_1047.n5 a_3747_1047.n4 4.61291
R13188 a_3747_1047.n4 a_3747_1047.n3 4.61291
R13189 a_3747_1047.n3 a_3747_1047.n2 4.61291
R13190 a_3747_1047.n2 a_3747_1047.n1 4.61291
R13191 a_3747_1047.n1 a_3747_1047.n0 4.61291
R13192 a_3171_1047.n0 a_3171_1047.t2 37.8054
R13193 a_3171_1047.n0 a_3171_1047.t3 33.193
R13194 a_3171_1047.n1 a_3171_1047.t4 33.193
R13195 a_3171_1047.n2 a_3171_1047.t5 33.193
R13196 a_3171_1047.n3 a_3171_1047.t6 33.193
R13197 a_3171_1047.n4 a_3171_1047.t7 33.193
R13198 a_3171_1047.n5 a_3171_1047.t8 33.193
R13199 a_3171_1047.n6 a_3171_1047.t9 33.193
R13200 a_3171_1047.t1 a_3171_1047.n6 23.0313
R13201 a_3171_1047.t0 a_3171_1047.t1 5.61777
R13202 a_3171_1047.n6 a_3171_1047.n5 4.61291
R13203 a_3171_1047.n5 a_3171_1047.n4 4.61291
R13204 a_3171_1047.n4 a_3171_1047.n3 4.61291
R13205 a_3171_1047.n3 a_3171_1047.n2 4.61291
R13206 a_3171_1047.n2 a_3171_1047.n1 4.61291
R13207 a_3171_1047.n1 a_3171_1047.n0 4.61291
R13208 a_2595_1047.n0 a_2595_1047.t2 37.7691
R13209 a_2595_1047.n0 a_2595_1047.t3 33.1567
R13210 a_2595_1047.n1 a_2595_1047.t4 33.1567
R13211 a_2595_1047.n2 a_2595_1047.t5 33.1567
R13212 a_2595_1047.n3 a_2595_1047.t6 33.1567
R13213 a_2595_1047.n4 a_2595_1047.t7 33.1567
R13214 a_2595_1047.n5 a_2595_1047.t8 33.1567
R13215 a_2595_1047.n6 a_2595_1047.t9 33.1567
R13216 a_2595_1047.t1 a_2595_1047.n6 22.7941
R13217 a_2595_1047.t0 a_2595_1047.t1 5.65522
R13218 a_2595_1047.n6 a_2595_1047.n5 4.61291
R13219 a_2595_1047.n5 a_2595_1047.n4 4.61291
R13220 a_2595_1047.n4 a_2595_1047.n3 4.61291
R13221 a_2595_1047.n3 a_2595_1047.n2 4.61291
R13222 a_2595_1047.n2 a_2595_1047.n1 4.61291
R13223 a_2595_1047.n1 a_2595_1047.n0 4.61291
R13224 a_2019_1047.n0 a_2019_1047.t2 37.9701
R13225 a_2019_1047.n0 a_2019_1047.t3 33.3577
R13226 a_2019_1047.n1 a_2019_1047.t4 33.3577
R13227 a_2019_1047.n2 a_2019_1047.t5 33.3577
R13228 a_2019_1047.n3 a_2019_1047.t6 33.3577
R13229 a_2019_1047.n4 a_2019_1047.t7 33.3577
R13230 a_2019_1047.n5 a_2019_1047.t8 33.3577
R13231 a_2019_1047.t1 a_2019_1047.t9 22.5945
R13232 a_2019_1047.t0 a_2019_1047.t1 5.62052
R13233 a_2019_1047.t9 a_2019_1047.n5 4.61291
R13234 a_2019_1047.n5 a_2019_1047.n4 4.61291
R13235 a_2019_1047.n4 a_2019_1047.n3 4.61291
R13236 a_2019_1047.n3 a_2019_1047.n2 4.61291
R13237 a_2019_1047.n2 a_2019_1047.n1 4.61291
R13238 a_2019_1047.n1 a_2019_1047.n0 4.61291
R13239 a_3747_3156.n0 a_3747_3156.t2 52.0388
R13240 a_3747_3156.t1 a_3747_3156.n0 35.4491
R13241 a_3747_3156.n0 a_3747_3156.t3 33.5891
R13242 a_3747_3156.t0 a_3747_3156.t1 5.61942
R13243 a_3171_3156.n0 a_3171_3156.t2 51.8377
R13244 a_3171_3156.n0 a_3171_3156.t3 33.3881
R13245 a_3171_3156.t1 a_3171_3156.n0 31.8923
R13246 a_3171_3156.t0 a_3171_3156.t1 5.61777
R13247 a_2595_3156.n0 a_2595_3156.t2 51.6367
R13248 a_2595_3156.n0 a_2595_3156.t3 33.187
R13249 a_2595_3156.t1 a_2595_3156.n0 27.993
R13250 a_2595_3156.t0 a_2595_3156.t1 5.73018
R13251 a_2019_3156.t3 a_2019_3156.t2 51.6139
R13252 a_2019_3156.t1 a_2019_3156.t3 24.5351
R13253 a_2019_3156.t0 a_2019_3156.t1 5.62052
R13254 a_3747_3892.n0 a_3747_3892.t2 38.0081
R13255 a_3747_3892.n0 a_3747_3892.t3 33.3957
R13256 a_3747_3892.n1 a_3747_3892.t4 33.3957
R13257 a_3747_3892.n2 a_3747_3892.t5 33.3957
R13258 a_3747_3892.n3 a_3747_3892.t6 33.3957
R13259 a_3747_3892.n4 a_3747_3892.t7 33.3957
R13260 a_3747_3892.n5 a_3747_3892.t8 33.3957
R13261 a_3747_3892.n6 a_3747_3892.t9 33.3957
R13262 a_3747_3892.t1 a_3747_3892.n6 23.2419
R13263 a_3747_3892.t0 a_3747_3892.t1 5.61942
R13264 a_3747_3892.n6 a_3747_3892.n5 4.61291
R13265 a_3747_3892.n5 a_3747_3892.n4 4.61291
R13266 a_3747_3892.n4 a_3747_3892.n3 4.61291
R13267 a_3747_3892.n3 a_3747_3892.n2 4.61291
R13268 a_3747_3892.n2 a_3747_3892.n1 4.61291
R13269 a_3747_3892.n1 a_3747_3892.n0 4.61291
R13270 a_3171_3892.n0 a_3171_3892.t2 37.8054
R13271 a_3171_3892.n0 a_3171_3892.t3 33.193
R13272 a_3171_3892.n1 a_3171_3892.t4 33.193
R13273 a_3171_3892.n2 a_3171_3892.t5 33.193
R13274 a_3171_3892.n3 a_3171_3892.t6 33.193
R13275 a_3171_3892.n4 a_3171_3892.t7 33.193
R13276 a_3171_3892.n5 a_3171_3892.t8 33.193
R13277 a_3171_3892.n6 a_3171_3892.t9 33.193
R13278 a_3171_3892.t1 a_3171_3892.n6 23.0313
R13279 a_3171_3892.t0 a_3171_3892.t1 5.61777
R13280 a_3171_3892.n6 a_3171_3892.n5 4.61291
R13281 a_3171_3892.n5 a_3171_3892.n4 4.61291
R13282 a_3171_3892.n4 a_3171_3892.n3 4.61291
R13283 a_3171_3892.n3 a_3171_3892.n2 4.61291
R13284 a_3171_3892.n2 a_3171_3892.n1 4.61291
R13285 a_3171_3892.n1 a_3171_3892.n0 4.61291
R13286 a_2595_3892.n0 a_2595_3892.t2 37.7691
R13287 a_2595_3892.n0 a_2595_3892.t3 33.1567
R13288 a_2595_3892.n1 a_2595_3892.t4 33.1567
R13289 a_2595_3892.n2 a_2595_3892.t5 33.1567
R13290 a_2595_3892.n3 a_2595_3892.t6 33.1567
R13291 a_2595_3892.n4 a_2595_3892.t7 33.1567
R13292 a_2595_3892.n5 a_2595_3892.t8 33.1567
R13293 a_2595_3892.n6 a_2595_3892.t9 33.1567
R13294 a_2595_3892.t1 a_2595_3892.n6 22.7941
R13295 a_2595_3892.t0 a_2595_3892.t1 5.65522
R13296 a_2595_3892.n6 a_2595_3892.n5 4.61291
R13297 a_2595_3892.n5 a_2595_3892.n4 4.61291
R13298 a_2595_3892.n4 a_2595_3892.n3 4.61291
R13299 a_2595_3892.n3 a_2595_3892.n2 4.61291
R13300 a_2595_3892.n2 a_2595_3892.n1 4.61291
R13301 a_2595_3892.n1 a_2595_3892.n0 4.61291
R13302 a_2019_3892.n0 a_2019_3892.t2 37.9701
R13303 a_2019_3892.n0 a_2019_3892.t3 33.3577
R13304 a_2019_3892.n1 a_2019_3892.t4 33.3577
R13305 a_2019_3892.n2 a_2019_3892.t5 33.3577
R13306 a_2019_3892.n3 a_2019_3892.t6 33.3577
R13307 a_2019_3892.n4 a_2019_3892.t7 33.3577
R13308 a_2019_3892.n5 a_2019_3892.t8 33.3577
R13309 a_2019_3892.t1 a_2019_3892.t9 22.5945
R13310 a_2019_3892.t0 a_2019_3892.t1 5.62052
R13311 a_2019_3892.t9 a_2019_3892.n5 4.61291
R13312 a_2019_3892.n5 a_2019_3892.n4 4.61291
R13313 a_2019_3892.n4 a_2019_3892.n3 4.61291
R13314 a_2019_3892.n3 a_2019_3892.n2 4.61291
R13315 a_2019_3892.n2 a_2019_3892.n1 4.61291
R13316 a_2019_3892.n1 a_2019_3892.n0 4.61291
R13317 a_3747_6001.n0 a_3747_6001.t2 52.0388
R13318 a_3747_6001.t1 a_3747_6001.n0 35.4491
R13319 a_3747_6001.n0 a_3747_6001.t3 33.5891
R13320 a_3747_6001.t0 a_3747_6001.t1 5.61942
R13321 a_3171_6001.n0 a_3171_6001.t2 51.8377
R13322 a_3171_6001.n0 a_3171_6001.t3 33.3881
R13323 a_3171_6001.t1 a_3171_6001.n0 31.8923
R13324 a_3171_6001.t0 a_3171_6001.t1 5.61777
R13325 a_2595_6001.n0 a_2595_6001.t2 51.6367
R13326 a_2595_6001.n0 a_2595_6001.t3 33.187
R13327 a_2595_6001.t1 a_2595_6001.n0 27.993
R13328 a_2595_6001.t0 a_2595_6001.t1 5.73018
R13329 a_2019_6001.t3 a_2019_6001.t2 51.6139
R13330 a_2019_6001.t1 a_2019_6001.t3 24.5351
R13331 a_2019_6001.t0 a_2019_6001.t1 5.62052
R13332 a_3747_6737.n0 a_3747_6737.t2 38.0081
R13333 a_3747_6737.n0 a_3747_6737.t3 33.3957
R13334 a_3747_6737.n1 a_3747_6737.t4 33.3957
R13335 a_3747_6737.n2 a_3747_6737.t5 33.3957
R13336 a_3747_6737.n3 a_3747_6737.t6 33.3957
R13337 a_3747_6737.n4 a_3747_6737.t7 33.3957
R13338 a_3747_6737.n5 a_3747_6737.t8 33.3957
R13339 a_3747_6737.n6 a_3747_6737.t9 33.3957
R13340 a_3747_6737.t1 a_3747_6737.n6 23.2419
R13341 a_3747_6737.t0 a_3747_6737.t1 5.61942
R13342 a_3747_6737.n6 a_3747_6737.n5 4.61291
R13343 a_3747_6737.n5 a_3747_6737.n4 4.61291
R13344 a_3747_6737.n4 a_3747_6737.n3 4.61291
R13345 a_3747_6737.n3 a_3747_6737.n2 4.61291
R13346 a_3747_6737.n2 a_3747_6737.n1 4.61291
R13347 a_3747_6737.n1 a_3747_6737.n0 4.61291
R13348 a_3171_6737.n0 a_3171_6737.t2 37.8054
R13349 a_3171_6737.n0 a_3171_6737.t3 33.193
R13350 a_3171_6737.n1 a_3171_6737.t4 33.193
R13351 a_3171_6737.n2 a_3171_6737.t5 33.193
R13352 a_3171_6737.n3 a_3171_6737.t6 33.193
R13353 a_3171_6737.n4 a_3171_6737.t7 33.193
R13354 a_3171_6737.n5 a_3171_6737.t8 33.193
R13355 a_3171_6737.n6 a_3171_6737.t9 33.193
R13356 a_3171_6737.t1 a_3171_6737.n6 23.0313
R13357 a_3171_6737.t0 a_3171_6737.t1 5.61777
R13358 a_3171_6737.n6 a_3171_6737.n5 4.61291
R13359 a_3171_6737.n5 a_3171_6737.n4 4.61291
R13360 a_3171_6737.n4 a_3171_6737.n3 4.61291
R13361 a_3171_6737.n3 a_3171_6737.n2 4.61291
R13362 a_3171_6737.n2 a_3171_6737.n1 4.61291
R13363 a_3171_6737.n1 a_3171_6737.n0 4.61291
R13364 a_2595_6737.n0 a_2595_6737.t2 37.7691
R13365 a_2595_6737.n0 a_2595_6737.t3 33.1567
R13366 a_2595_6737.n1 a_2595_6737.t4 33.1567
R13367 a_2595_6737.n2 a_2595_6737.t5 33.1567
R13368 a_2595_6737.n3 a_2595_6737.t6 33.1567
R13369 a_2595_6737.n4 a_2595_6737.t7 33.1567
R13370 a_2595_6737.n5 a_2595_6737.t8 33.1567
R13371 a_2595_6737.n6 a_2595_6737.t9 33.1567
R13372 a_2595_6737.t1 a_2595_6737.n6 22.7941
R13373 a_2595_6737.t0 a_2595_6737.t1 5.65522
R13374 a_2595_6737.n6 a_2595_6737.n5 4.61291
R13375 a_2595_6737.n5 a_2595_6737.n4 4.61291
R13376 a_2595_6737.n4 a_2595_6737.n3 4.61291
R13377 a_2595_6737.n3 a_2595_6737.n2 4.61291
R13378 a_2595_6737.n2 a_2595_6737.n1 4.61291
R13379 a_2595_6737.n1 a_2595_6737.n0 4.61291
R13380 a_2019_6737.n0 a_2019_6737.t2 37.9701
R13381 a_2019_6737.n0 a_2019_6737.t3 33.3577
R13382 a_2019_6737.n1 a_2019_6737.t4 33.3577
R13383 a_2019_6737.n2 a_2019_6737.t5 33.3577
R13384 a_2019_6737.n3 a_2019_6737.t6 33.3577
R13385 a_2019_6737.n4 a_2019_6737.t7 33.3577
R13386 a_2019_6737.n5 a_2019_6737.t8 33.3577
R13387 a_2019_6737.t1 a_2019_6737.t9 22.5945
R13388 a_2019_6737.t0 a_2019_6737.t1 5.62052
R13389 a_2019_6737.t9 a_2019_6737.n5 4.61291
R13390 a_2019_6737.n5 a_2019_6737.n4 4.61291
R13391 a_2019_6737.n4 a_2019_6737.n3 4.61291
R13392 a_2019_6737.n3 a_2019_6737.n2 4.61291
R13393 a_2019_6737.n2 a_2019_6737.n1 4.61291
R13394 a_2019_6737.n1 a_2019_6737.n0 4.61291
R13395 a_3747_12493.n0 a_3747_12493.t2 52.0388
R13396 a_3747_12493.t1 a_3747_12493.n0 35.4491
R13397 a_3747_12493.n0 a_3747_12493.t3 33.5891
R13398 a_3747_12493.t0 a_3747_12493.t1 5.61942
R13399 a_3171_12493.n0 a_3171_12493.t2 51.8377
R13400 a_3171_12493.n0 a_3171_12493.t3 33.3881
R13401 a_3171_12493.t1 a_3171_12493.n0 31.8923
R13402 a_3171_12493.t0 a_3171_12493.t1 5.61777
R13403 a_2595_12493.n0 a_2595_12493.t2 51.6367
R13404 a_2595_12493.n0 a_2595_12493.t3 33.187
R13405 a_2595_12493.t1 a_2595_12493.n0 27.993
R13406 a_2595_12493.t0 a_2595_12493.t1 5.73018
R13407 a_2019_12493.t3 a_2019_12493.t2 51.6139
R13408 a_2019_12493.t1 a_2019_12493.t3 24.5351
R13409 a_2019_12493.t0 a_2019_12493.t1 5.62052
R13410 a_3747_13229.n0 a_3747_13229.t2 38.0081
R13411 a_3747_13229.n0 a_3747_13229.t3 33.3957
R13412 a_3747_13229.n1 a_3747_13229.t4 33.3957
R13413 a_3747_13229.n2 a_3747_13229.t5 33.3957
R13414 a_3747_13229.n3 a_3747_13229.t6 33.3957
R13415 a_3747_13229.n4 a_3747_13229.t7 33.3957
R13416 a_3747_13229.n5 a_3747_13229.t8 33.3957
R13417 a_3747_13229.n6 a_3747_13229.t9 33.3957
R13418 a_3747_13229.t1 a_3747_13229.n6 23.2419
R13419 a_3747_13229.t0 a_3747_13229.t1 5.61942
R13420 a_3747_13229.n6 a_3747_13229.n5 4.61291
R13421 a_3747_13229.n5 a_3747_13229.n4 4.61291
R13422 a_3747_13229.n4 a_3747_13229.n3 4.61291
R13423 a_3747_13229.n3 a_3747_13229.n2 4.61291
R13424 a_3747_13229.n2 a_3747_13229.n1 4.61291
R13425 a_3747_13229.n1 a_3747_13229.n0 4.61291
R13426 a_3171_13229.n0 a_3171_13229.t2 37.8054
R13427 a_3171_13229.n0 a_3171_13229.t3 33.193
R13428 a_3171_13229.n1 a_3171_13229.t4 33.193
R13429 a_3171_13229.n2 a_3171_13229.t5 33.193
R13430 a_3171_13229.n3 a_3171_13229.t6 33.193
R13431 a_3171_13229.n4 a_3171_13229.t7 33.193
R13432 a_3171_13229.n5 a_3171_13229.t8 33.193
R13433 a_3171_13229.n6 a_3171_13229.t9 33.193
R13434 a_3171_13229.t1 a_3171_13229.n6 23.0313
R13435 a_3171_13229.t0 a_3171_13229.t1 5.61777
R13436 a_3171_13229.n6 a_3171_13229.n5 4.61291
R13437 a_3171_13229.n5 a_3171_13229.n4 4.61291
R13438 a_3171_13229.n4 a_3171_13229.n3 4.61291
R13439 a_3171_13229.n3 a_3171_13229.n2 4.61291
R13440 a_3171_13229.n2 a_3171_13229.n1 4.61291
R13441 a_3171_13229.n1 a_3171_13229.n0 4.61291
R13442 a_2595_13229.n0 a_2595_13229.t2 37.7691
R13443 a_2595_13229.n0 a_2595_13229.t3 33.1567
R13444 a_2595_13229.n1 a_2595_13229.t4 33.1567
R13445 a_2595_13229.n2 a_2595_13229.t5 33.1567
R13446 a_2595_13229.n3 a_2595_13229.t6 33.1567
R13447 a_2595_13229.n4 a_2595_13229.t7 33.1567
R13448 a_2595_13229.n5 a_2595_13229.t8 33.1567
R13449 a_2595_13229.n6 a_2595_13229.t9 33.1567
R13450 a_2595_13229.t1 a_2595_13229.n6 22.7941
R13451 a_2595_13229.t0 a_2595_13229.t1 5.65522
R13452 a_2595_13229.n6 a_2595_13229.n5 4.61291
R13453 a_2595_13229.n5 a_2595_13229.n4 4.61291
R13454 a_2595_13229.n4 a_2595_13229.n3 4.61291
R13455 a_2595_13229.n3 a_2595_13229.n2 4.61291
R13456 a_2595_13229.n2 a_2595_13229.n1 4.61291
R13457 a_2595_13229.n1 a_2595_13229.n0 4.61291
R13458 a_2019_13229.n0 a_2019_13229.t2 37.9701
R13459 a_2019_13229.n0 a_2019_13229.t3 33.3577
R13460 a_2019_13229.n1 a_2019_13229.t4 33.3577
R13461 a_2019_13229.n2 a_2019_13229.t5 33.3577
R13462 a_2019_13229.n3 a_2019_13229.t6 33.3577
R13463 a_2019_13229.n4 a_2019_13229.t7 33.3577
R13464 a_2019_13229.n5 a_2019_13229.t8 33.3577
R13465 a_2019_13229.t1 a_2019_13229.t9 22.5945
R13466 a_2019_13229.t0 a_2019_13229.t1 5.62052
R13467 a_2019_13229.t9 a_2019_13229.n5 4.61291
R13468 a_2019_13229.n5 a_2019_13229.n4 4.61291
R13469 a_2019_13229.n4 a_2019_13229.n3 4.61291
R13470 a_2019_13229.n3 a_2019_13229.n2 4.61291
R13471 a_2019_13229.n2 a_2019_13229.n1 4.61291
R13472 a_2019_13229.n1 a_2019_13229.n0 4.61291
R13473 a_3747_15338.n0 a_3747_15338.t2 52.0388
R13474 a_3747_15338.t1 a_3747_15338.n0 35.4491
R13475 a_3747_15338.n0 a_3747_15338.t3 33.5891
R13476 a_3747_15338.t0 a_3747_15338.t1 5.61942
R13477 a_3171_15338.n0 a_3171_15338.t2 51.8377
R13478 a_3171_15338.n0 a_3171_15338.t3 33.3881
R13479 a_3171_15338.t1 a_3171_15338.n0 31.8923
R13480 a_3171_15338.t0 a_3171_15338.t1 5.61777
R13481 a_2595_15338.n0 a_2595_15338.t2 51.6367
R13482 a_2595_15338.n0 a_2595_15338.t3 33.187
R13483 a_2595_15338.t1 a_2595_15338.n0 27.993
R13484 a_2595_15338.t0 a_2595_15338.t1 5.73018
R13485 a_2019_15338.t3 a_2019_15338.t2 51.6139
R13486 a_2019_15338.t1 a_2019_15338.t3 24.5351
R13487 a_2019_15338.t0 a_2019_15338.t1 5.62052
R13488 a_3747_16074.n0 a_3747_16074.t2 38.0081
R13489 a_3747_16074.n0 a_3747_16074.t3 33.3957
R13490 a_3747_16074.n1 a_3747_16074.t4 33.3957
R13491 a_3747_16074.n2 a_3747_16074.t5 33.3957
R13492 a_3747_16074.n3 a_3747_16074.t6 33.3957
R13493 a_3747_16074.n4 a_3747_16074.t7 33.3957
R13494 a_3747_16074.n5 a_3747_16074.t8 33.3957
R13495 a_3747_16074.n6 a_3747_16074.t9 33.3957
R13496 a_3747_16074.t1 a_3747_16074.n6 23.2419
R13497 a_3747_16074.t0 a_3747_16074.t1 5.61942
R13498 a_3747_16074.n6 a_3747_16074.n5 4.61291
R13499 a_3747_16074.n5 a_3747_16074.n4 4.61291
R13500 a_3747_16074.n4 a_3747_16074.n3 4.61291
R13501 a_3747_16074.n3 a_3747_16074.n2 4.61291
R13502 a_3747_16074.n2 a_3747_16074.n1 4.61291
R13503 a_3747_16074.n1 a_3747_16074.n0 4.61291
R13504 a_3171_16074.n0 a_3171_16074.t2 37.8054
R13505 a_3171_16074.n0 a_3171_16074.t3 33.193
R13506 a_3171_16074.n1 a_3171_16074.t4 33.193
R13507 a_3171_16074.n2 a_3171_16074.t5 33.193
R13508 a_3171_16074.n3 a_3171_16074.t6 33.193
R13509 a_3171_16074.n4 a_3171_16074.t7 33.193
R13510 a_3171_16074.n5 a_3171_16074.t8 33.193
R13511 a_3171_16074.n6 a_3171_16074.t9 33.193
R13512 a_3171_16074.t1 a_3171_16074.n6 23.0313
R13513 a_3171_16074.t0 a_3171_16074.t1 5.61777
R13514 a_3171_16074.n6 a_3171_16074.n5 4.61291
R13515 a_3171_16074.n5 a_3171_16074.n4 4.61291
R13516 a_3171_16074.n4 a_3171_16074.n3 4.61291
R13517 a_3171_16074.n3 a_3171_16074.n2 4.61291
R13518 a_3171_16074.n2 a_3171_16074.n1 4.61291
R13519 a_3171_16074.n1 a_3171_16074.n0 4.61291
R13520 a_2595_16074.n0 a_2595_16074.t2 37.7691
R13521 a_2595_16074.n0 a_2595_16074.t3 33.1567
R13522 a_2595_16074.n1 a_2595_16074.t4 33.1567
R13523 a_2595_16074.n2 a_2595_16074.t5 33.1567
R13524 a_2595_16074.n3 a_2595_16074.t6 33.1567
R13525 a_2595_16074.n4 a_2595_16074.t7 33.1567
R13526 a_2595_16074.n5 a_2595_16074.t8 33.1567
R13527 a_2595_16074.n6 a_2595_16074.t9 33.1567
R13528 a_2595_16074.t1 a_2595_16074.n6 22.7941
R13529 a_2595_16074.t0 a_2595_16074.t1 5.65522
R13530 a_2595_16074.n6 a_2595_16074.n5 4.61291
R13531 a_2595_16074.n5 a_2595_16074.n4 4.61291
R13532 a_2595_16074.n4 a_2595_16074.n3 4.61291
R13533 a_2595_16074.n3 a_2595_16074.n2 4.61291
R13534 a_2595_16074.n2 a_2595_16074.n1 4.61291
R13535 a_2595_16074.n1 a_2595_16074.n0 4.61291
R13536 a_2019_16074.n0 a_2019_16074.t2 37.9701
R13537 a_2019_16074.n0 a_2019_16074.t3 33.3577
R13538 a_2019_16074.n1 a_2019_16074.t4 33.3577
R13539 a_2019_16074.n2 a_2019_16074.t5 33.3577
R13540 a_2019_16074.n3 a_2019_16074.t6 33.3577
R13541 a_2019_16074.n4 a_2019_16074.t7 33.3577
R13542 a_2019_16074.n5 a_2019_16074.t8 33.3577
R13543 a_2019_16074.t1 a_2019_16074.t9 22.5945
R13544 a_2019_16074.t0 a_2019_16074.t1 5.62052
R13545 a_2019_16074.t9 a_2019_16074.n5 4.61291
R13546 a_2019_16074.n5 a_2019_16074.n4 4.61291
R13547 a_2019_16074.n4 a_2019_16074.n3 4.61291
R13548 a_2019_16074.n3 a_2019_16074.n2 4.61291
R13549 a_2019_16074.n2 a_2019_16074.n1 4.61291
R13550 a_2019_16074.n1 a_2019_16074.n0 4.61291
R13551 a_4187_1764.n0 a_4187_1764.t163 34.3755
R13552 a_4187_1764.n31 a_4187_1764.t131 34.3755
R13553 a_4187_1764.n126 a_4187_1764.t97 34.3755
R13554 a_4187_1764.n94 a_4187_1764.t65 34.3755
R13555 a_4187_1764.n63 a_4187_1764.t33 34.3755
R13556 a_4187_1764.n0 a_4187_1764.t162 33.0005
R13557 a_4187_1764.n1 a_4187_1764.t161 33.0005
R13558 a_4187_1764.n2 a_4187_1764.t160 33.0005
R13559 a_4187_1764.n3 a_4187_1764.t159 33.0005
R13560 a_4187_1764.n4 a_4187_1764.t158 33.0005
R13561 a_4187_1764.n5 a_4187_1764.t157 33.0005
R13562 a_4187_1764.n6 a_4187_1764.t156 33.0005
R13563 a_4187_1764.n7 a_4187_1764.t155 33.0005
R13564 a_4187_1764.n8 a_4187_1764.t154 33.0005
R13565 a_4187_1764.n9 a_4187_1764.t153 33.0005
R13566 a_4187_1764.n10 a_4187_1764.t152 33.0005
R13567 a_4187_1764.n11 a_4187_1764.t151 33.0005
R13568 a_4187_1764.n12 a_4187_1764.t150 33.0005
R13569 a_4187_1764.n13 a_4187_1764.t149 33.0005
R13570 a_4187_1764.n14 a_4187_1764.t148 33.0005
R13571 a_4187_1764.n15 a_4187_1764.t147 33.0005
R13572 a_4187_1764.n16 a_4187_1764.t146 33.0005
R13573 a_4187_1764.n17 a_4187_1764.t145 33.0005
R13574 a_4187_1764.n18 a_4187_1764.t144 33.0005
R13575 a_4187_1764.n19 a_4187_1764.t143 33.0005
R13576 a_4187_1764.n20 a_4187_1764.t142 33.0005
R13577 a_4187_1764.n21 a_4187_1764.t141 33.0005
R13578 a_4187_1764.n22 a_4187_1764.t140 33.0005
R13579 a_4187_1764.n23 a_4187_1764.t139 33.0005
R13580 a_4187_1764.n24 a_4187_1764.t138 33.0005
R13581 a_4187_1764.n25 a_4187_1764.t137 33.0005
R13582 a_4187_1764.n26 a_4187_1764.t136 33.0005
R13583 a_4187_1764.n27 a_4187_1764.t135 33.0005
R13584 a_4187_1764.n28 a_4187_1764.t134 33.0005
R13585 a_4187_1764.n29 a_4187_1764.t133 33.0005
R13586 a_4187_1764.n30 a_4187_1764.t132 33.0005
R13587 a_4187_1764.n31 a_4187_1764.t130 33.0005
R13588 a_4187_1764.n32 a_4187_1764.t129 33.0005
R13589 a_4187_1764.n33 a_4187_1764.t128 33.0005
R13590 a_4187_1764.n34 a_4187_1764.t127 33.0005
R13591 a_4187_1764.n35 a_4187_1764.t126 33.0005
R13592 a_4187_1764.n36 a_4187_1764.t125 33.0005
R13593 a_4187_1764.n37 a_4187_1764.t124 33.0005
R13594 a_4187_1764.n38 a_4187_1764.t123 33.0005
R13595 a_4187_1764.n39 a_4187_1764.t122 33.0005
R13596 a_4187_1764.n40 a_4187_1764.t121 33.0005
R13597 a_4187_1764.n41 a_4187_1764.t120 33.0005
R13598 a_4187_1764.n42 a_4187_1764.t119 33.0005
R13599 a_4187_1764.n43 a_4187_1764.t118 33.0005
R13600 a_4187_1764.n44 a_4187_1764.t117 33.0005
R13601 a_4187_1764.n45 a_4187_1764.t116 33.0005
R13602 a_4187_1764.n46 a_4187_1764.t115 33.0005
R13603 a_4187_1764.n47 a_4187_1764.t114 33.0005
R13604 a_4187_1764.n48 a_4187_1764.t113 33.0005
R13605 a_4187_1764.n49 a_4187_1764.t112 33.0005
R13606 a_4187_1764.n50 a_4187_1764.t111 33.0005
R13607 a_4187_1764.n51 a_4187_1764.t110 33.0005
R13608 a_4187_1764.n52 a_4187_1764.t109 33.0005
R13609 a_4187_1764.n53 a_4187_1764.t108 33.0005
R13610 a_4187_1764.n54 a_4187_1764.t107 33.0005
R13611 a_4187_1764.n55 a_4187_1764.t106 33.0005
R13612 a_4187_1764.n56 a_4187_1764.t105 33.0005
R13613 a_4187_1764.n57 a_4187_1764.t104 33.0005
R13614 a_4187_1764.n58 a_4187_1764.t103 33.0005
R13615 a_4187_1764.n59 a_4187_1764.t102 33.0005
R13616 a_4187_1764.n60 a_4187_1764.t101 33.0005
R13617 a_4187_1764.n61 a_4187_1764.t100 33.0005
R13618 a_4187_1764.n126 a_4187_1764.t96 33.0005
R13619 a_4187_1764.n127 a_4187_1764.t95 33.0005
R13620 a_4187_1764.n128 a_4187_1764.t94 33.0005
R13621 a_4187_1764.n129 a_4187_1764.t93 33.0005
R13622 a_4187_1764.n130 a_4187_1764.t92 33.0005
R13623 a_4187_1764.n131 a_4187_1764.t91 33.0005
R13624 a_4187_1764.n132 a_4187_1764.t90 33.0005
R13625 a_4187_1764.n133 a_4187_1764.t89 33.0005
R13626 a_4187_1764.n134 a_4187_1764.t88 33.0005
R13627 a_4187_1764.n135 a_4187_1764.t87 33.0005
R13628 a_4187_1764.n136 a_4187_1764.t86 33.0005
R13629 a_4187_1764.n137 a_4187_1764.t85 33.0005
R13630 a_4187_1764.n138 a_4187_1764.t84 33.0005
R13631 a_4187_1764.n139 a_4187_1764.t83 33.0005
R13632 a_4187_1764.n140 a_4187_1764.t82 33.0005
R13633 a_4187_1764.n141 a_4187_1764.t81 33.0005
R13634 a_4187_1764.n142 a_4187_1764.t80 33.0005
R13635 a_4187_1764.n143 a_4187_1764.t79 33.0005
R13636 a_4187_1764.n144 a_4187_1764.t78 33.0005
R13637 a_4187_1764.n145 a_4187_1764.t77 33.0005
R13638 a_4187_1764.n146 a_4187_1764.t76 33.0005
R13639 a_4187_1764.n147 a_4187_1764.t75 33.0005
R13640 a_4187_1764.n148 a_4187_1764.t74 33.0005
R13641 a_4187_1764.n149 a_4187_1764.t73 33.0005
R13642 a_4187_1764.n150 a_4187_1764.t72 33.0005
R13643 a_4187_1764.n151 a_4187_1764.t71 33.0005
R13644 a_4187_1764.n152 a_4187_1764.t70 33.0005
R13645 a_4187_1764.n153 a_4187_1764.t69 33.0005
R13646 a_4187_1764.n154 a_4187_1764.t68 33.0005
R13647 a_4187_1764.n155 a_4187_1764.t67 33.0005
R13648 a_4187_1764.n156 a_4187_1764.t66 33.0005
R13649 a_4187_1764.n94 a_4187_1764.t64 33.0005
R13650 a_4187_1764.n95 a_4187_1764.t63 33.0005
R13651 a_4187_1764.n96 a_4187_1764.t62 33.0005
R13652 a_4187_1764.n97 a_4187_1764.t61 33.0005
R13653 a_4187_1764.n98 a_4187_1764.t60 33.0005
R13654 a_4187_1764.n99 a_4187_1764.t59 33.0005
R13655 a_4187_1764.n100 a_4187_1764.t58 33.0005
R13656 a_4187_1764.n101 a_4187_1764.t57 33.0005
R13657 a_4187_1764.n102 a_4187_1764.t56 33.0005
R13658 a_4187_1764.n103 a_4187_1764.t55 33.0005
R13659 a_4187_1764.n104 a_4187_1764.t54 33.0005
R13660 a_4187_1764.n105 a_4187_1764.t53 33.0005
R13661 a_4187_1764.n106 a_4187_1764.t52 33.0005
R13662 a_4187_1764.n107 a_4187_1764.t51 33.0005
R13663 a_4187_1764.n108 a_4187_1764.t50 33.0005
R13664 a_4187_1764.n109 a_4187_1764.t49 33.0005
R13665 a_4187_1764.n110 a_4187_1764.t48 33.0005
R13666 a_4187_1764.n111 a_4187_1764.t47 33.0005
R13667 a_4187_1764.n112 a_4187_1764.t46 33.0005
R13668 a_4187_1764.n113 a_4187_1764.t45 33.0005
R13669 a_4187_1764.n114 a_4187_1764.t44 33.0005
R13670 a_4187_1764.n115 a_4187_1764.t43 33.0005
R13671 a_4187_1764.n116 a_4187_1764.t42 33.0005
R13672 a_4187_1764.n117 a_4187_1764.t41 33.0005
R13673 a_4187_1764.n118 a_4187_1764.t40 33.0005
R13674 a_4187_1764.n119 a_4187_1764.t39 33.0005
R13675 a_4187_1764.n120 a_4187_1764.t38 33.0005
R13676 a_4187_1764.n121 a_4187_1764.t37 33.0005
R13677 a_4187_1764.n122 a_4187_1764.t36 33.0005
R13678 a_4187_1764.n123 a_4187_1764.t35 33.0005
R13679 a_4187_1764.n124 a_4187_1764.t34 33.0005
R13680 a_4187_1764.n63 a_4187_1764.t32 33.0005
R13681 a_4187_1764.n64 a_4187_1764.t31 33.0005
R13682 a_4187_1764.n65 a_4187_1764.t30 33.0005
R13683 a_4187_1764.n66 a_4187_1764.t29 33.0005
R13684 a_4187_1764.n67 a_4187_1764.t28 33.0005
R13685 a_4187_1764.n68 a_4187_1764.t27 33.0005
R13686 a_4187_1764.n69 a_4187_1764.t26 33.0005
R13687 a_4187_1764.n70 a_4187_1764.t25 33.0005
R13688 a_4187_1764.n71 a_4187_1764.t24 33.0005
R13689 a_4187_1764.n72 a_4187_1764.t23 33.0005
R13690 a_4187_1764.n73 a_4187_1764.t22 33.0005
R13691 a_4187_1764.n74 a_4187_1764.t21 33.0005
R13692 a_4187_1764.n75 a_4187_1764.t20 33.0005
R13693 a_4187_1764.n76 a_4187_1764.t19 33.0005
R13694 a_4187_1764.n77 a_4187_1764.t18 33.0005
R13695 a_4187_1764.n78 a_4187_1764.t17 33.0005
R13696 a_4187_1764.n79 a_4187_1764.t16 33.0005
R13697 a_4187_1764.n80 a_4187_1764.t15 33.0005
R13698 a_4187_1764.n81 a_4187_1764.t14 33.0005
R13699 a_4187_1764.n82 a_4187_1764.t13 33.0005
R13700 a_4187_1764.n83 a_4187_1764.t12 33.0005
R13701 a_4187_1764.n84 a_4187_1764.t11 33.0005
R13702 a_4187_1764.n85 a_4187_1764.t10 33.0005
R13703 a_4187_1764.n86 a_4187_1764.t9 33.0005
R13704 a_4187_1764.n87 a_4187_1764.t8 33.0005
R13705 a_4187_1764.n88 a_4187_1764.t7 33.0005
R13706 a_4187_1764.n89 a_4187_1764.t6 33.0005
R13707 a_4187_1764.n90 a_4187_1764.t5 33.0005
R13708 a_4187_1764.n91 a_4187_1764.t4 33.0005
R13709 a_4187_1764.n92 a_4187_1764.t3 33.0005
R13710 a_4187_1764.n93 a_4187_1764.t2 33.0005
R13711 a_4187_1764.n159 a_4187_1764.t99 25.0885
R13712 a_4187_1764.n125 a_4187_1764.n93 15.1797
R13713 a_4187_1764.n62 a_4187_1764.n30 15.1797
R13714 a_4187_1764.n158 a_4187_1764.t98 11.19
R13715 a_4187_1764.t0 a_4187_1764.n160 13.9108
R13716 a_4187_1764.n160 a_4187_1764.t1 12.9887
R13717 a_4187_1764.n62 a_4187_1764.n61 10.8632
R13718 a_4187_1764.n157 a_4187_1764.n156 10.8632
R13719 a_4187_1764.n125 a_4187_1764.n124 10.8632
R13720 a_4187_1764.n158 a_4187_1764.n62 5.26657
R13721 a_4187_1764.n158 a_4187_1764.n157 4.58443
R13722 a_4187_1764.n157 a_4187_1764.n125 4.31705
R13723 a_4187_1764.n30 a_4187_1764.n29 1.3755
R13724 a_4187_1764.n29 a_4187_1764.n28 1.3755
R13725 a_4187_1764.n28 a_4187_1764.n27 1.3755
R13726 a_4187_1764.n27 a_4187_1764.n26 1.3755
R13727 a_4187_1764.n26 a_4187_1764.n25 1.3755
R13728 a_4187_1764.n25 a_4187_1764.n24 1.3755
R13729 a_4187_1764.n24 a_4187_1764.n23 1.3755
R13730 a_4187_1764.n23 a_4187_1764.n22 1.3755
R13731 a_4187_1764.n22 a_4187_1764.n21 1.3755
R13732 a_4187_1764.n21 a_4187_1764.n20 1.3755
R13733 a_4187_1764.n20 a_4187_1764.n19 1.3755
R13734 a_4187_1764.n19 a_4187_1764.n18 1.3755
R13735 a_4187_1764.n18 a_4187_1764.n17 1.3755
R13736 a_4187_1764.n17 a_4187_1764.n16 1.3755
R13737 a_4187_1764.n16 a_4187_1764.n15 1.3755
R13738 a_4187_1764.n15 a_4187_1764.n14 1.3755
R13739 a_4187_1764.n14 a_4187_1764.n13 1.3755
R13740 a_4187_1764.n13 a_4187_1764.n12 1.3755
R13741 a_4187_1764.n12 a_4187_1764.n11 1.3755
R13742 a_4187_1764.n11 a_4187_1764.n10 1.3755
R13743 a_4187_1764.n10 a_4187_1764.n9 1.3755
R13744 a_4187_1764.n9 a_4187_1764.n8 1.3755
R13745 a_4187_1764.n8 a_4187_1764.n7 1.3755
R13746 a_4187_1764.n7 a_4187_1764.n6 1.3755
R13747 a_4187_1764.n6 a_4187_1764.n5 1.3755
R13748 a_4187_1764.n5 a_4187_1764.n4 1.3755
R13749 a_4187_1764.n4 a_4187_1764.n3 1.3755
R13750 a_4187_1764.n3 a_4187_1764.n2 1.3755
R13751 a_4187_1764.n2 a_4187_1764.n1 1.3755
R13752 a_4187_1764.n1 a_4187_1764.n0 1.3755
R13753 a_4187_1764.n61 a_4187_1764.n60 1.3755
R13754 a_4187_1764.n60 a_4187_1764.n59 1.3755
R13755 a_4187_1764.n59 a_4187_1764.n58 1.3755
R13756 a_4187_1764.n58 a_4187_1764.n57 1.3755
R13757 a_4187_1764.n57 a_4187_1764.n56 1.3755
R13758 a_4187_1764.n56 a_4187_1764.n55 1.3755
R13759 a_4187_1764.n55 a_4187_1764.n54 1.3755
R13760 a_4187_1764.n54 a_4187_1764.n53 1.3755
R13761 a_4187_1764.n53 a_4187_1764.n52 1.3755
R13762 a_4187_1764.n52 a_4187_1764.n51 1.3755
R13763 a_4187_1764.n51 a_4187_1764.n50 1.3755
R13764 a_4187_1764.n50 a_4187_1764.n49 1.3755
R13765 a_4187_1764.n49 a_4187_1764.n48 1.3755
R13766 a_4187_1764.n48 a_4187_1764.n47 1.3755
R13767 a_4187_1764.n47 a_4187_1764.n46 1.3755
R13768 a_4187_1764.n46 a_4187_1764.n45 1.3755
R13769 a_4187_1764.n45 a_4187_1764.n44 1.3755
R13770 a_4187_1764.n44 a_4187_1764.n43 1.3755
R13771 a_4187_1764.n43 a_4187_1764.n42 1.3755
R13772 a_4187_1764.n42 a_4187_1764.n41 1.3755
R13773 a_4187_1764.n41 a_4187_1764.n40 1.3755
R13774 a_4187_1764.n40 a_4187_1764.n39 1.3755
R13775 a_4187_1764.n39 a_4187_1764.n38 1.3755
R13776 a_4187_1764.n38 a_4187_1764.n37 1.3755
R13777 a_4187_1764.n37 a_4187_1764.n36 1.3755
R13778 a_4187_1764.n36 a_4187_1764.n35 1.3755
R13779 a_4187_1764.n35 a_4187_1764.n34 1.3755
R13780 a_4187_1764.n34 a_4187_1764.n33 1.3755
R13781 a_4187_1764.n33 a_4187_1764.n32 1.3755
R13782 a_4187_1764.n32 a_4187_1764.n31 1.3755
R13783 a_4187_1764.n156 a_4187_1764.n155 1.3755
R13784 a_4187_1764.n155 a_4187_1764.n154 1.3755
R13785 a_4187_1764.n154 a_4187_1764.n153 1.3755
R13786 a_4187_1764.n153 a_4187_1764.n152 1.3755
R13787 a_4187_1764.n152 a_4187_1764.n151 1.3755
R13788 a_4187_1764.n151 a_4187_1764.n150 1.3755
R13789 a_4187_1764.n150 a_4187_1764.n149 1.3755
R13790 a_4187_1764.n149 a_4187_1764.n148 1.3755
R13791 a_4187_1764.n148 a_4187_1764.n147 1.3755
R13792 a_4187_1764.n147 a_4187_1764.n146 1.3755
R13793 a_4187_1764.n146 a_4187_1764.n145 1.3755
R13794 a_4187_1764.n145 a_4187_1764.n144 1.3755
R13795 a_4187_1764.n144 a_4187_1764.n143 1.3755
R13796 a_4187_1764.n143 a_4187_1764.n142 1.3755
R13797 a_4187_1764.n142 a_4187_1764.n141 1.3755
R13798 a_4187_1764.n141 a_4187_1764.n140 1.3755
R13799 a_4187_1764.n140 a_4187_1764.n139 1.3755
R13800 a_4187_1764.n139 a_4187_1764.n138 1.3755
R13801 a_4187_1764.n138 a_4187_1764.n137 1.3755
R13802 a_4187_1764.n137 a_4187_1764.n136 1.3755
R13803 a_4187_1764.n136 a_4187_1764.n135 1.3755
R13804 a_4187_1764.n135 a_4187_1764.n134 1.3755
R13805 a_4187_1764.n134 a_4187_1764.n133 1.3755
R13806 a_4187_1764.n133 a_4187_1764.n132 1.3755
R13807 a_4187_1764.n132 a_4187_1764.n131 1.3755
R13808 a_4187_1764.n131 a_4187_1764.n130 1.3755
R13809 a_4187_1764.n130 a_4187_1764.n129 1.3755
R13810 a_4187_1764.n129 a_4187_1764.n128 1.3755
R13811 a_4187_1764.n128 a_4187_1764.n127 1.3755
R13812 a_4187_1764.n127 a_4187_1764.n126 1.3755
R13813 a_4187_1764.n124 a_4187_1764.n123 1.3755
R13814 a_4187_1764.n123 a_4187_1764.n122 1.3755
R13815 a_4187_1764.n122 a_4187_1764.n121 1.3755
R13816 a_4187_1764.n121 a_4187_1764.n120 1.3755
R13817 a_4187_1764.n120 a_4187_1764.n119 1.3755
R13818 a_4187_1764.n119 a_4187_1764.n118 1.3755
R13819 a_4187_1764.n118 a_4187_1764.n117 1.3755
R13820 a_4187_1764.n117 a_4187_1764.n116 1.3755
R13821 a_4187_1764.n116 a_4187_1764.n115 1.3755
R13822 a_4187_1764.n115 a_4187_1764.n114 1.3755
R13823 a_4187_1764.n114 a_4187_1764.n113 1.3755
R13824 a_4187_1764.n113 a_4187_1764.n112 1.3755
R13825 a_4187_1764.n112 a_4187_1764.n111 1.3755
R13826 a_4187_1764.n111 a_4187_1764.n110 1.3755
R13827 a_4187_1764.n110 a_4187_1764.n109 1.3755
R13828 a_4187_1764.n109 a_4187_1764.n108 1.3755
R13829 a_4187_1764.n108 a_4187_1764.n107 1.3755
R13830 a_4187_1764.n107 a_4187_1764.n106 1.3755
R13831 a_4187_1764.n106 a_4187_1764.n105 1.3755
R13832 a_4187_1764.n105 a_4187_1764.n104 1.3755
R13833 a_4187_1764.n104 a_4187_1764.n103 1.3755
R13834 a_4187_1764.n103 a_4187_1764.n102 1.3755
R13835 a_4187_1764.n102 a_4187_1764.n101 1.3755
R13836 a_4187_1764.n101 a_4187_1764.n100 1.3755
R13837 a_4187_1764.n100 a_4187_1764.n99 1.3755
R13838 a_4187_1764.n99 a_4187_1764.n98 1.3755
R13839 a_4187_1764.n98 a_4187_1764.n97 1.3755
R13840 a_4187_1764.n97 a_4187_1764.n96 1.3755
R13841 a_4187_1764.n96 a_4187_1764.n95 1.3755
R13842 a_4187_1764.n95 a_4187_1764.n94 1.3755
R13843 a_4187_1764.n93 a_4187_1764.n92 1.3755
R13844 a_4187_1764.n92 a_4187_1764.n91 1.3755
R13845 a_4187_1764.n91 a_4187_1764.n90 1.3755
R13846 a_4187_1764.n90 a_4187_1764.n89 1.3755
R13847 a_4187_1764.n89 a_4187_1764.n88 1.3755
R13848 a_4187_1764.n88 a_4187_1764.n87 1.3755
R13849 a_4187_1764.n87 a_4187_1764.n86 1.3755
R13850 a_4187_1764.n86 a_4187_1764.n85 1.3755
R13851 a_4187_1764.n85 a_4187_1764.n84 1.3755
R13852 a_4187_1764.n84 a_4187_1764.n83 1.3755
R13853 a_4187_1764.n83 a_4187_1764.n82 1.3755
R13854 a_4187_1764.n82 a_4187_1764.n81 1.3755
R13855 a_4187_1764.n81 a_4187_1764.n80 1.3755
R13856 a_4187_1764.n80 a_4187_1764.n79 1.3755
R13857 a_4187_1764.n79 a_4187_1764.n78 1.3755
R13858 a_4187_1764.n78 a_4187_1764.n77 1.3755
R13859 a_4187_1764.n77 a_4187_1764.n76 1.3755
R13860 a_4187_1764.n76 a_4187_1764.n75 1.3755
R13861 a_4187_1764.n75 a_4187_1764.n74 1.3755
R13862 a_4187_1764.n74 a_4187_1764.n73 1.3755
R13863 a_4187_1764.n73 a_4187_1764.n72 1.3755
R13864 a_4187_1764.n72 a_4187_1764.n71 1.3755
R13865 a_4187_1764.n71 a_4187_1764.n70 1.3755
R13866 a_4187_1764.n70 a_4187_1764.n69 1.3755
R13867 a_4187_1764.n69 a_4187_1764.n68 1.3755
R13868 a_4187_1764.n68 a_4187_1764.n67 1.3755
R13869 a_4187_1764.n67 a_4187_1764.n66 1.3755
R13870 a_4187_1764.n66 a_4187_1764.n65 1.3755
R13871 a_4187_1764.n65 a_4187_1764.n64 1.3755
R13872 a_4187_1764.n64 a_4187_1764.n63 1.3755
R13873 a_4187_1764.n160 a_4187_1764.n159 0.735818
R13874 a_4187_1764.n159 a_4187_1764.t98 7.58765
C5478 CHAN3_MUX_OUT VSS 3.38545f
C5479 CHAN3_MUX_SEL4 VSS 1.61259f
C5480 CHAN3_MUX_SEL3 VSS 0.90961f
C5481 CHAN3_MUX_SEL2 VSS 2.16639f
C5482 CHAN3_MUX_SEL1 VSS 0.94892f
C5483 CHAN3_MUX_SEL0 VSS 1.91644f
C5484 CHAN3_DELAY_OUT_LAST VSS 0.38565f
C5485 CHAN3_DELAY_IN VSS 1.55907f
C5486 CHAN2_MUX_OUT VSS 1.59734f
C5487 CHAN2_MUX_SEL4 VSS 1.41353f
C5488 CHAN2_MUX_SEL3 VSS 0.89413f
C5489 CHAN2_MUX_SEL2 VSS 1.81186f
C5490 CHAN2_MUX_SEL1 VSS 0.94892f
C5491 CHAN2_MUX_SEL0 VSS 1.91644f
C5492 CHAN2_DELAY_OUT_LAST VSS 0.38565f
C5493 CHAN2_DELAY_IN VSS 1.5514f
C5494 REF_MUX_OUT VSS 1.59734f
C5495 REF_MUX_SEL4 VSS 1.41353f
C5496 REF_MUX_SEL3 VSS 0.89413f
C5497 REF_MUX_SEL2 VSS 1.81186f
C5498 REF_MUX_SEL1 VSS 0.95341f
C5499 REF_MUX_SEL0 VSS 1.93453f
C5500 REF_DELAY_OUT_LAST VSS 2.81565f
C5501 REF_CLK VSS 3.33886f
C5502 DLL_RESETN VSS 4.35023f
C5503 CHAN1_MUX_OUT VSS 2.17637f
C5504 CHAN1_MUX_SEL4 VSS 1.59662f
C5505 CHAN1_MUX_SEL3 VSS 0.90548f
C5506 CHAN1_MUX_SEL2 VSS 2.06125f
C5507 CHAN1_MUX_SEL1 VSS 0.94892f
C5508 CHAN1_MUX_SEL0 VSS 1.91644f
C5509 CHAN1_DELAY_OUT_LAST VSS 0.38565f
C5510 CHAN1_DELAY_IN VSS 1.55908f
C5511 CHAN0_MUX_OUT VSS 1.59734f
C5512 CHAN0_MUX_SEL4 VSS 1.41353f
C5513 CHAN0_MUX_SEL3 VSS 0.89413f
C5514 CHAN0_MUX_SEL2 VSS 1.81186f
C5515 CHAN0_MUX_SEL1 VSS 0.95342f
C5516 CHAN0_MUX_SEL0 VSS 1.93463f
C5517 CHAN0_DELAY_OUT_LAST VSS 0.39284f
C5518 CHAN0_DELAY_IN VSS 1.85909f
C5519 VDD VSS 0.2776p
C5520 a_26985_519# VSS 0.17928f ; **FLOATING
C5521 a_23945_519# VSS 0.17928f ; **FLOATING
C5522 a_20905_519# VSS 0.17928f ; **FLOATING
C5523 a_17865_519# VSS 0.17593f ; **FLOATING
C5524 a_16851_309# VSS 0.38699f ; **FLOATING
C5525 a_16108_289# VSS 3.75745f ; **FLOATING
C5526 a_15964_289# VSS 0.17613f ; **FLOATING
C5527 a_15765_463# VSS 0.36132f ; **FLOATING
C5528 a_14825_519# VSS 0.17928f ; **FLOATING
C5529 a_11785_519# VSS 0.17928f ; **FLOATING
C5530 a_8745_519# VSS 0.17928f ; **FLOATING
C5531 a_5731_289# VSS 3.43538f ; **FLOATING
C5532 a_2019_311# VSS 1.61663f ; **FLOATING
C5533 a_5705_519# VSS 0.17638f ; **FLOATING
C5534 a_3449_331# VSS 0.18478f ; **FLOATING
C5535 a_2873_331# VSS 0.18321f ; **FLOATING
C5536 a_2297_331# VSS 0.18331f ; **FLOATING
C5537 a_1721_331# VSS 0.17178f ; **FLOATING
C5538 a_1544_289# VSS 0.30084f ; **FLOATING
C5539 a_1256_289# VSS 0.87117f ; **FLOATING
C5540 a_27991_1008# VSS 0.18706f ; **FLOATING
C5541 a_27915_1044# VSS 0.10926f ; **FLOATING
C5542 a_27124_1008# VSS 0.17878f ; **FLOATING
C5543 a_27048_1044# VSS 0.12122f ; **FLOATING
C5544 a_26471_1008# VSS 0.18175f ; **FLOATING
C5545 a_26395_1044# VSS 0.11073f ; **FLOATING
C5546 a_25604_1008# VSS 0.18087f ; **FLOATING
C5547 a_25630_1044# VSS 0.37805f ; **FLOATING
C5548 a_25528_1044# VSS 0.12433f ; **FLOATING
C5549 a_24951_1008# VSS 0.18335f ; **FLOATING
C5550 a_24875_1044# VSS 0.11016f ; **FLOATING
C5551 a_24084_1008# VSS 0.17878f ; **FLOATING
C5552 a_24008_1044# VSS 0.12122f ; **FLOATING
C5553 a_23431_1008# VSS 0.1818f ; **FLOATING
C5554 a_23355_1044# VSS 0.11554f ; **FLOATING
C5555 a_22564_1008# VSS 0.18087f ; **FLOATING
C5556 a_22590_1044# VSS 0.34379f ; **FLOATING
C5557 a_22488_1044# VSS 0.12433f ; **FLOATING
C5558 a_21911_1008# VSS 0.18335f ; **FLOATING
C5559 a_21835_1044# VSS 0.11016f ; **FLOATING
C5560 a_21044_1008# VSS 0.17878f ; **FLOATING
C5561 a_20968_1044# VSS 0.12122f ; **FLOATING
C5562 a_20391_1008# VSS 0.18175f ; **FLOATING
C5563 a_20315_1044# VSS 0.11073f ; **FLOATING
C5564 a_19524_1008# VSS 0.18087f ; **FLOATING
C5565 a_19550_1044# VSS 0.33343f ; **FLOATING
C5566 a_19448_1044# VSS 0.12433f ; **FLOATING
C5567 a_18871_1008# VSS 0.18335f ; **FLOATING
C5568 a_18795_1044# VSS 0.11016f ; **FLOATING
C5569 a_18004_1008# VSS 0.17878f ; **FLOATING
C5570 a_17928_1044# VSS 0.12122f ; **FLOATING
C5571 a_17351_1008# VSS 0.18022f ; **FLOATING
C5572 a_17275_1044# VSS 0.10926f ; **FLOATING
C5573 a_16484_1008# VSS 0.18023f ; **FLOATING
C5574 a_16510_1044# VSS 0.28935f ; **FLOATING
C5575 a_16408_1044# VSS 0.1229f ; **FLOATING
C5576 a_15831_1008# VSS 0.17846f ; **FLOATING
C5577 a_15755_1044# VSS 0.10926f ; **FLOATING
C5578 a_14964_1008# VSS 0.17878f ; **FLOATING
C5579 a_14888_1044# VSS 0.12122f ; **FLOATING
C5580 a_14311_1008# VSS 0.18175f ; **FLOATING
C5581 a_14235_1044# VSS 0.11073f ; **FLOATING
C5582 a_13444_1008# VSS 0.18205f ; **FLOATING
C5583 a_13470_1044# VSS 0.30999f ; **FLOATING
C5584 a_13368_1044# VSS 0.13246f ; **FLOATING
C5585 a_12791_1008# VSS 0.18335f ; **FLOATING
C5586 a_12715_1044# VSS 0.11016f ; **FLOATING
C5587 a_11924_1008# VSS 0.17878f ; **FLOATING
C5588 a_11848_1044# VSS 0.12122f ; **FLOATING
C5589 a_11271_1008# VSS 0.18175f ; **FLOATING
C5590 a_11195_1044# VSS 0.11073f ; **FLOATING
C5591 a_10404_1008# VSS 0.18087f ; **FLOATING
C5592 a_10430_1044# VSS 0.30746f ; **FLOATING
C5593 a_10328_1044# VSS 0.12433f ; **FLOATING
C5594 a_9751_1008# VSS 0.18335f ; **FLOATING
C5595 a_9675_1044# VSS 0.11016f ; **FLOATING
C5596 a_8884_1008# VSS 0.17878f ; **FLOATING
C5597 a_8808_1044# VSS 0.12122f ; **FLOATING
C5598 a_8231_1008# VSS 0.18175f ; **FLOATING
C5599 a_8155_1044# VSS 0.11073f ; **FLOATING
C5600 a_7364_1008# VSS 0.18087f ; **FLOATING
C5601 a_7390_1044# VSS 0.31357f ; **FLOATING
C5602 a_7288_1044# VSS 0.12433f ; **FLOATING
C5603 a_6711_1008# VSS 0.18335f ; **FLOATING
C5604 a_6635_1044# VSS 0.11016f ; **FLOATING
C5605 a_5844_1008# VSS 0.17878f ; **FLOATING
C5606 a_5768_1044# VSS 0.12122f ; **FLOATING
C5607 a_5191_1008# VSS 0.18022f ; **FLOATING
C5608 a_5115_1044# VSS 0.10926f ; **FLOATING
C5609 a_4324_1008# VSS 0.18023f ; **FLOATING
C5610 a_4350_1044# VSS 0.26655f ; **FLOATING
C5611 a_4248_1044# VSS 0.12443f ; **FLOATING
C5612 a_27705_1044# VSS 0.25297f ; **FLOATING
C5613 a_26185_1044# VSS 0.23475f ; **FLOATING
C5614 a_24665_1044# VSS 0.25405f ; **FLOATING
C5615 a_23145_1044# VSS 0.24628f ; **FLOATING
C5616 a_21625_1044# VSS 0.25405f ; **FLOATING
C5617 a_20105_1044# VSS 0.23475f ; **FLOATING
C5618 a_18585_1044# VSS 0.25405f ; **FLOATING
C5619 a_17065_1044# VSS 0.23387f ; **FLOATING
C5620 a_15545_1044# VSS 0.25297f ; **FLOATING
C5621 a_14025_1044# VSS 0.23475f ; **FLOATING
C5622 a_12505_1044# VSS 0.25405f ; **FLOATING
C5623 a_10985_1044# VSS 0.23475f ; **FLOATING
C5624 a_9465_1044# VSS 0.25405f ; **FLOATING
C5625 a_7945_1044# VSS 0.23475f ; **FLOATING
C5626 a_6425_1044# VSS 0.25405f ; **FLOATING
C5627 a_4905_1044# VSS 0.2355f ; **FLOATING
C5628 a_4157_1313# VSS 0.32875f ; **FLOATING
C5629 a_3449_1395# VSS 0.18619f ; **FLOATING
C5630 a_2873_1395# VSS 0.18296f ; **FLOATING
C5631 a_2297_1395# VSS 0.18306f ; **FLOATING
C5632 a_1721_1395# VSS 0.172f ; **FLOATING
C5633 a_1544_1044# VSS 0.29854f ; **FLOATING
C5634 a_1256_1044# VSS 0.85418f ; **FLOATING
C5635 a_27671_1842# VSS 0.01336f ; **FLOATING
C5636 a_26911_1842# VSS 0.01336f ; **FLOATING
C5637 a_26151_1842# VSS 0.01336f ; **FLOATING
C5638 a_25391_1842# VSS 0.01336f ; **FLOATING
C5639 a_24631_1842# VSS 0.01336f ; **FLOATING
C5640 a_23871_1842# VSS 0.01336f ; **FLOATING
C5641 a_23111_1842# VSS 0.01733f ; **FLOATING
C5642 a_22351_1842# VSS 0.01336f ; **FLOATING
C5643 a_21591_1842# VSS 0.01336f ; **FLOATING
C5644 a_20831_1842# VSS 0.01336f ; **FLOATING
C5645 a_20071_1842# VSS 0.01336f ; **FLOATING
C5646 a_19311_1842# VSS 0.01336f ; **FLOATING
C5647 a_18551_1842# VSS 0.01336f ; **FLOATING
C5648 a_17791_1842# VSS 0.01336f ; **FLOATING
C5649 a_17031_1842# VSS 0.01336f ; **FLOATING
C5650 a_16271_1842# VSS 0.01336f ; **FLOATING
C5651 a_15511_1842# VSS 0.01336f ; **FLOATING
C5652 a_14751_1842# VSS 0.01336f ; **FLOATING
C5653 a_13991_1842# VSS 0.01336f ; **FLOATING
C5654 a_13231_1842# VSS 0.01733f ; **FLOATING
C5655 a_12471_1842# VSS 0.01336f ; **FLOATING
C5656 a_11711_1842# VSS 0.01336f ; **FLOATING
C5657 a_10951_1842# VSS 0.01336f ; **FLOATING
C5658 a_10191_1842# VSS 0.01336f ; **FLOATING
C5659 a_9431_1842# VSS 0.01336f ; **FLOATING
C5660 a_8671_1842# VSS 0.01336f ; **FLOATING
C5661 a_7911_1842# VSS 0.01336f ; **FLOATING
C5662 a_7151_1842# VSS 0.01336f ; **FLOATING
C5663 a_6391_1842# VSS 0.01336f ; **FLOATING
C5664 a_5631_1842# VSS 0.01336f ; **FLOATING
C5665 a_4871_1842# VSS 0.01336f ; **FLOATING
C5666 a_4111_1842# VSS 0.0139f ; **FLOATING
C5667 a_27563_1842# VSS 0.49473f ; **FLOATING
C5668 a_27997_1842# VSS 0.64441f ; **FLOATING
C5669 a_27433_1842# VSS 0.44435f ; **FLOATING
C5670 a_26803_1842# VSS 0.48676f ; **FLOATING
C5671 a_27237_1842# VSS 0.92458f ; **FLOATING
C5672 a_26673_1842# VSS 0.44348f ; **FLOATING
C5673 a_26043_1842# VSS 0.48774f ; **FLOATING
C5674 a_26477_1842# VSS 0.95131f ; **FLOATING
C5675 a_25913_1842# VSS 0.44619f ; **FLOATING
C5676 a_25283_1842# VSS 0.48565f ; **FLOATING
C5677 a_25717_1842# VSS 0.86118f ; **FLOATING
C5678 a_25153_1842# VSS 0.44417f ; **FLOATING
C5679 a_24523_1842# VSS 0.48747f ; **FLOATING
C5680 a_24957_1842# VSS 0.95519f ; **FLOATING
C5681 a_24393_1842# VSS 0.44145f ; **FLOATING
C5682 a_23763_1842# VSS 0.48687f ; **FLOATING
C5683 a_24197_1842# VSS 0.91985f ; **FLOATING
C5684 a_23633_1842# VSS 0.447f ; **FLOATING
C5685 a_23003_1842# VSS 0.9554f ; **FLOATING
C5686 a_23437_1842# VSS 1.07998f ; **FLOATING
C5687 a_22873_1842# VSS 0.56838f ; **FLOATING
C5688 a_22243_1842# VSS 0.46743f ; **FLOATING
C5689 a_22677_1842# VSS 0.88616f ; **FLOATING
C5690 a_22113_1842# VSS 0.44347f ; **FLOATING
C5691 a_21483_1842# VSS 0.4875f ; **FLOATING
C5692 a_21917_1842# VSS 0.95287f ; **FLOATING
C5693 a_21353_1842# VSS 0.44138f ; **FLOATING
C5694 a_20723_1842# VSS 0.48671f ; **FLOATING
C5695 a_21157_1842# VSS 0.91928f ; **FLOATING
C5696 a_20593_1842# VSS 0.44348f ; **FLOATING
C5697 a_19963_1842# VSS 0.48774f ; **FLOATING
C5698 a_20397_1842# VSS 0.95131f ; **FLOATING
C5699 a_19833_1842# VSS 0.44619f ; **FLOATING
C5700 a_19203_1842# VSS 0.48565f ; **FLOATING
C5701 a_19637_1842# VSS 0.86118f ; **FLOATING
C5702 a_19073_1842# VSS 0.44414f ; **FLOATING
C5703 a_18443_1842# VSS 0.48744f ; **FLOATING
C5704 a_18877_1842# VSS 0.95513f ; **FLOATING
C5705 a_18313_1842# VSS 0.44059f ; **FLOATING
C5706 a_17683_1842# VSS 0.48671f ; **FLOATING
C5707 a_18117_1842# VSS 0.91647f ; **FLOATING
C5708 a_17553_1842# VSS 0.44348f ; **FLOATING
C5709 a_16923_1842# VSS 0.4899f ; **FLOATING
C5710 a_17357_1842# VSS 0.95213f ; **FLOATING
C5711 a_16793_1842# VSS 0.44447f ; **FLOATING
C5712 a_16163_1842# VSS 0.48792f ; **FLOATING
C5713 a_16597_1842# VSS 0.85769f ; **FLOATING
C5714 a_16033_1842# VSS 0.4368f ; **FLOATING
C5715 a_15403_1842# VSS 0.48909f ; **FLOATING
C5716 a_15837_1842# VSS 0.94699f ; **FLOATING
C5717 a_15273_1842# VSS 0.44136f ; **FLOATING
C5718 a_14643_1842# VSS 0.48674f ; **FLOATING
C5719 a_15077_1842# VSS 0.91819f ; **FLOATING
C5720 a_14513_1842# VSS 0.44355f ; **FLOATING
C5721 a_13883_1842# VSS 0.48786f ; **FLOATING
C5722 a_14317_1842# VSS 0.95152f ; **FLOATING
C5723 a_13753_1842# VSS 0.44737f ; **FLOATING
C5724 a_13123_1842# VSS 0.94748f ; **FLOATING
C5725 a_13557_1842# VSS 0.9343f ; **FLOATING
C5726 a_12993_1842# VSS 0.56321f ; **FLOATING
C5727 a_12363_1842# VSS 0.46822f ; **FLOATING
C5728 a_12797_1842# VSS 1.11192f ; **FLOATING
C5729 a_12233_1842# VSS 0.4374f ; **FLOATING
C5730 a_11603_1842# VSS 0.48677f ; **FLOATING
C5731 a_12037_1842# VSS 0.9194f ; **FLOATING
C5732 a_11473_1842# VSS 0.4435f ; **FLOATING
C5733 a_10843_1842# VSS 0.48774f ; **FLOATING
C5734 a_11277_1842# VSS 0.95131f ; **FLOATING
C5735 a_10713_1842# VSS 0.44619f ; **FLOATING
C5736 a_10083_1842# VSS 0.48563f ; **FLOATING
C5737 a_10517_1842# VSS 0.86118f ; **FLOATING
C5738 a_9953_1842# VSS 0.44414f ; **FLOATING
C5739 a_9323_1842# VSS 0.48744f ; **FLOATING
C5740 a_9757_1842# VSS 0.95346f ; **FLOATING
C5741 a_9193_1842# VSS 0.44136f ; **FLOATING
C5742 a_8563_1842# VSS 0.48671f ; **FLOATING
C5743 a_8997_1842# VSS 0.91928f ; **FLOATING
C5744 a_8433_1842# VSS 0.44348f ; **FLOATING
C5745 a_7803_1842# VSS 0.48774f ; **FLOATING
C5746 a_8237_1842# VSS 0.95131f ; **FLOATING
C5747 a_7673_1842# VSS 0.44619f ; **FLOATING
C5748 a_7043_1842# VSS 0.48563f ; **FLOATING
C5749 a_7477_1842# VSS 0.86118f ; **FLOATING
C5750 a_6913_1842# VSS 0.44414f ; **FLOATING
C5751 a_6283_1842# VSS 0.48744f ; **FLOATING
C5752 a_6717_1842# VSS 0.95287f ; **FLOATING
C5753 a_6153_1842# VSS 0.44059f ; **FLOATING
C5754 a_5523_1842# VSS 0.48671f ; **FLOATING
C5755 a_5957_1842# VSS 0.91647f ; **FLOATING
C5756 a_5393_1842# VSS 0.44587f ; **FLOATING
C5757 a_4763_1842# VSS 0.49323f ; **FLOATING
C5758 a_5197_1842# VSS 0.9541f ; **FLOATING
C5759 a_4633_1842# VSS 0.44882f ; **FLOATING
C5760 a_4003_1842# VSS 0.57066f ; **FLOATING
C5761 a_4437_1842# VSS 0.86497f ; **FLOATING
C5762 a_26985_3364# VSS 0.17928f ; **FLOATING
C5763 a_23945_3364# VSS 0.17928f ; **FLOATING
C5764 a_20905_3364# VSS 0.17928f ; **FLOATING
C5765 a_17865_3364# VSS 0.17593f ; **FLOATING
C5766 a_16851_3154# VSS 0.37653f ; **FLOATING
C5767 a_16108_3134# VSS 2.50019f ; **FLOATING
C5768 a_15964_3134# VSS 0.17103f ; **FLOATING
C5769 a_15765_3308# VSS 0.33587f ; **FLOATING
C5770 a_14825_3364# VSS 0.17928f ; **FLOATING
C5771 a_11785_3364# VSS 0.17928f ; **FLOATING
C5772 a_8745_3364# VSS 0.17928f ; **FLOATING
C5773 a_5731_3134# VSS 2.24589f ; **FLOATING
C5774 a_5705_3364# VSS 0.17638f ; **FLOATING
C5775 a_3449_3176# VSS 0.17702f ; **FLOATING
C5776 a_2873_3176# VSS 0.1828f ; **FLOATING
C5777 a_2297_3176# VSS 0.1829f ; **FLOATING
C5778 a_1721_3176# VSS 0.17136f ; **FLOATING
C5779 a_1544_3134# VSS 0.29772f ; **FLOATING
C5780 a_1256_3134# VSS 0.85178f ; **FLOATING
C5781 a_27991_3853# VSS 0.18561f ; **FLOATING
C5782 a_27915_3889# VSS 0.10926f ; **FLOATING
C5783 a_27124_3853# VSS 0.17878f ; **FLOATING
C5784 a_27048_3889# VSS 0.12122f ; **FLOATING
C5785 a_26471_3853# VSS 0.18126f ; **FLOATING
C5786 a_26395_3889# VSS 0.11073f ; **FLOATING
C5787 a_25604_3853# VSS 0.18087f ; **FLOATING
C5788 a_25630_3889# VSS 0.33072f ; **FLOATING
C5789 a_25528_3889# VSS 0.12433f ; **FLOATING
C5790 a_24951_3853# VSS 0.18335f ; **FLOATING
C5791 a_24875_3889# VSS 0.11016f ; **FLOATING
C5792 a_24084_3853# VSS 0.17878f ; **FLOATING
C5793 a_24008_3889# VSS 0.12122f ; **FLOATING
C5794 a_23431_3853# VSS 0.18132f ; **FLOATING
C5795 a_23355_3889# VSS 0.11566f ; **FLOATING
C5796 a_22564_3853# VSS 0.18087f ; **FLOATING
C5797 a_22590_3889# VSS 0.34383f ; **FLOATING
C5798 a_22488_3889# VSS 0.12433f ; **FLOATING
C5799 a_21911_3853# VSS 0.18335f ; **FLOATING
C5800 a_21835_3889# VSS 0.11016f ; **FLOATING
C5801 a_21044_3853# VSS 0.17878f ; **FLOATING
C5802 a_20968_3889# VSS 0.12122f ; **FLOATING
C5803 a_20391_3853# VSS 0.18126f ; **FLOATING
C5804 a_20315_3889# VSS 0.11073f ; **FLOATING
C5805 a_19524_3853# VSS 0.18087f ; **FLOATING
C5806 a_19550_3889# VSS 0.33343f ; **FLOATING
C5807 a_19448_3889# VSS 0.12433f ; **FLOATING
C5808 a_18871_3853# VSS 0.18335f ; **FLOATING
C5809 a_18795_3889# VSS 0.11016f ; **FLOATING
C5810 a_18004_3853# VSS 0.17878f ; **FLOATING
C5811 a_17928_3889# VSS 0.12122f ; **FLOATING
C5812 a_17351_3853# VSS 0.17877f ; **FLOATING
C5813 a_17275_3889# VSS 0.10926f ; **FLOATING
C5814 a_16484_3853# VSS 0.17947f ; **FLOATING
C5815 a_16510_3889# VSS 0.28935f ; **FLOATING
C5816 a_16408_3889# VSS 0.1229f ; **FLOATING
C5817 a_15831_3853# VSS 0.17846f ; **FLOATING
C5818 a_15755_3889# VSS 0.10926f ; **FLOATING
C5819 a_14964_3853# VSS 0.17878f ; **FLOATING
C5820 a_14888_3889# VSS 0.12122f ; **FLOATING
C5821 a_14311_3853# VSS 0.18126f ; **FLOATING
C5822 a_14235_3889# VSS 0.11073f ; **FLOATING
C5823 a_13444_3853# VSS 0.18205f ; **FLOATING
C5824 a_13470_3889# VSS 0.30999f ; **FLOATING
C5825 a_13368_3889# VSS 0.13246f ; **FLOATING
C5826 a_12791_3853# VSS 0.18335f ; **FLOATING
C5827 a_12715_3889# VSS 0.11016f ; **FLOATING
C5828 a_11924_3853# VSS 0.17878f ; **FLOATING
C5829 a_11848_3889# VSS 0.12122f ; **FLOATING
C5830 a_11271_3853# VSS 0.18126f ; **FLOATING
C5831 a_11195_3889# VSS 0.11073f ; **FLOATING
C5832 a_10404_3853# VSS 0.18087f ; **FLOATING
C5833 a_10430_3889# VSS 0.30746f ; **FLOATING
C5834 a_10328_3889# VSS 0.12433f ; **FLOATING
C5835 a_9751_3853# VSS 0.18335f ; **FLOATING
C5836 a_9675_3889# VSS 0.11016f ; **FLOATING
C5837 a_8884_3853# VSS 0.17878f ; **FLOATING
C5838 a_8808_3889# VSS 0.12122f ; **FLOATING
C5839 a_8231_3853# VSS 0.18126f ; **FLOATING
C5840 a_8155_3889# VSS 0.11073f ; **FLOATING
C5841 a_7364_3853# VSS 0.18087f ; **FLOATING
C5842 a_7390_3889# VSS 0.31357f ; **FLOATING
C5843 a_7288_3889# VSS 0.12433f ; **FLOATING
C5844 a_6711_3853# VSS 0.18335f ; **FLOATING
C5845 a_6635_3889# VSS 0.11016f ; **FLOATING
C5846 a_5844_3853# VSS 0.17878f ; **FLOATING
C5847 a_5768_3889# VSS 0.12122f ; **FLOATING
C5848 a_5191_3853# VSS 0.17877f ; **FLOATING
C5849 a_5115_3889# VSS 0.10926f ; **FLOATING
C5850 a_4324_3853# VSS 0.17947f ; **FLOATING
C5851 a_4350_3889# VSS 0.26655f ; **FLOATING
C5852 a_4248_3889# VSS 0.12443f ; **FLOATING
C5853 a_27705_3889# VSS 0.25232f ; **FLOATING
C5854 a_26185_3889# VSS 0.23475f ; **FLOATING
C5855 a_24665_3889# VSS 0.25405f ; **FLOATING
C5856 a_23145_3889# VSS 0.24628f ; **FLOATING
C5857 a_21625_3889# VSS 0.25405f ; **FLOATING
C5858 a_20105_3889# VSS 0.23475f ; **FLOATING
C5859 a_18585_3889# VSS 0.25405f ; **FLOATING
C5860 a_17065_3889# VSS 0.23379f ; **FLOATING
C5861 a_15545_3889# VSS 0.25232f ; **FLOATING
C5862 a_14025_3889# VSS 0.23475f ; **FLOATING
C5863 a_12505_3889# VSS 0.25405f ; **FLOATING
C5864 a_10985_3889# VSS 0.23475f ; **FLOATING
C5865 a_9465_3889# VSS 0.25405f ; **FLOATING
C5866 a_7945_3889# VSS 0.23475f ; **FLOATING
C5867 a_6425_3889# VSS 0.25405f ; **FLOATING
C5868 a_4905_3889# VSS 0.23484f ; **FLOATING
C5869 a_4157_4158# VSS 0.32839f ; **FLOATING
C5870 a_3449_4240# VSS 0.18619f ; **FLOATING
C5871 a_2873_4240# VSS 0.18296f ; **FLOATING
C5872 a_2297_4240# VSS 0.18306f ; **FLOATING
C5873 a_1721_4240# VSS 0.172f ; **FLOATING
C5874 a_1544_3889# VSS 0.29854f ; **FLOATING
C5875 a_1256_3889# VSS 0.85418f ; **FLOATING
C5876 a_27671_4687# VSS 0.01336f ; **FLOATING
C5877 a_26911_4687# VSS 0.01336f ; **FLOATING
C5878 a_26151_4687# VSS 0.01336f ; **FLOATING
C5879 a_25391_4687# VSS 0.01336f ; **FLOATING
C5880 a_24631_4687# VSS 0.01336f ; **FLOATING
C5881 a_23871_4687# VSS 0.01336f ; **FLOATING
C5882 a_23111_4687# VSS 0.01733f ; **FLOATING
C5883 a_22351_4687# VSS 0.01336f ; **FLOATING
C5884 a_21591_4687# VSS 0.01336f ; **FLOATING
C5885 a_20831_4687# VSS 0.01336f ; **FLOATING
C5886 a_20071_4687# VSS 0.01336f ; **FLOATING
C5887 a_19311_4687# VSS 0.01336f ; **FLOATING
C5888 a_18551_4687# VSS 0.01336f ; **FLOATING
C5889 a_17791_4687# VSS 0.01336f ; **FLOATING
C5890 a_17031_4687# VSS 0.01336f ; **FLOATING
C5891 a_16271_4687# VSS 0.01336f ; **FLOATING
C5892 a_15511_4687# VSS 0.01336f ; **FLOATING
C5893 a_14751_4687# VSS 0.01336f ; **FLOATING
C5894 a_13991_4687# VSS 0.01336f ; **FLOATING
C5895 a_13231_4687# VSS 0.01733f ; **FLOATING
C5896 a_12471_4687# VSS 0.01336f ; **FLOATING
C5897 a_11711_4687# VSS 0.01336f ; **FLOATING
C5898 a_10951_4687# VSS 0.01336f ; **FLOATING
C5899 a_10191_4687# VSS 0.01336f ; **FLOATING
C5900 a_9431_4687# VSS 0.01336f ; **FLOATING
C5901 a_8671_4687# VSS 0.01336f ; **FLOATING
C5902 a_7911_4687# VSS 0.01336f ; **FLOATING
C5903 a_7151_4687# VSS 0.01336f ; **FLOATING
C5904 a_6391_4687# VSS 0.01336f ; **FLOATING
C5905 a_5631_4687# VSS 0.01336f ; **FLOATING
C5906 a_4871_4687# VSS 0.01336f ; **FLOATING
C5907 a_4111_4687# VSS 0.0139f ; **FLOATING
C5908 a_27563_4687# VSS 0.49473f ; **FLOATING
C5909 a_27997_4687# VSS 0.64441f ; **FLOATING
C5910 a_27433_4687# VSS 0.44435f ; **FLOATING
C5911 a_26803_4687# VSS 0.48676f ; **FLOATING
C5912 a_27237_4687# VSS 0.92278f ; **FLOATING
C5913 a_26673_4687# VSS 0.44348f ; **FLOATING
C5914 a_26043_4687# VSS 0.48774f ; **FLOATING
C5915 a_26477_4687# VSS 0.95122f ; **FLOATING
C5916 a_25913_4687# VSS 0.44619f ; **FLOATING
C5917 a_25283_4687# VSS 0.48565f ; **FLOATING
C5918 a_25717_4687# VSS 0.86086f ; **FLOATING
C5919 a_25153_4687# VSS 0.44417f ; **FLOATING
C5920 a_24523_4687# VSS 0.48747f ; **FLOATING
C5921 a_24957_4687# VSS 0.95519f ; **FLOATING
C5922 a_24393_4687# VSS 0.44145f ; **FLOATING
C5923 a_23763_4687# VSS 0.48687f ; **FLOATING
C5924 a_24197_4687# VSS 0.91872f ; **FLOATING
C5925 a_23633_4687# VSS 0.44706f ; **FLOATING
C5926 a_23003_4687# VSS 0.95737f ; **FLOATING
C5927 a_23437_4687# VSS 1.08156f ; **FLOATING
C5928 a_22873_4687# VSS 0.56613f ; **FLOATING
C5929 a_22243_4687# VSS 0.46741f ; **FLOATING
C5930 a_22677_4687# VSS 0.88578f ; **FLOATING
C5931 a_22113_4687# VSS 0.4435f ; **FLOATING
C5932 a_21483_4687# VSS 0.4875f ; **FLOATING
C5933 a_21917_4687# VSS 0.95287f ; **FLOATING
C5934 a_21353_4687# VSS 0.44138f ; **FLOATING
C5935 a_20723_4687# VSS 0.48671f ; **FLOATING
C5936 a_21157_4687# VSS 0.91814f ; **FLOATING
C5937 a_20593_4687# VSS 0.44348f ; **FLOATING
C5938 a_19963_4687# VSS 0.48774f ; **FLOATING
C5939 a_20397_4687# VSS 0.95122f ; **FLOATING
C5940 a_19833_4687# VSS 0.44619f ; **FLOATING
C5941 a_19203_4687# VSS 0.48565f ; **FLOATING
C5942 a_19637_4687# VSS 0.86086f ; **FLOATING
C5943 a_19073_4687# VSS 0.44414f ; **FLOATING
C5944 a_18443_4687# VSS 0.48744f ; **FLOATING
C5945 a_18877_4687# VSS 0.95513f ; **FLOATING
C5946 a_18313_4687# VSS 0.44059f ; **FLOATING
C5947 a_17683_4687# VSS 0.48671f ; **FLOATING
C5948 a_18117_4687# VSS 0.91534f ; **FLOATING
C5949 a_17553_4687# VSS 0.44348f ; **FLOATING
C5950 a_16923_4687# VSS 0.4899f ; **FLOATING
C5951 a_17357_4687# VSS 0.95204f ; **FLOATING
C5952 a_16793_4687# VSS 0.44447f ; **FLOATING
C5953 a_16163_4687# VSS 0.48792f ; **FLOATING
C5954 a_16597_4687# VSS 0.85706f ; **FLOATING
C5955 a_16033_4687# VSS 0.4368f ; **FLOATING
C5956 a_15403_4687# VSS 0.48909f ; **FLOATING
C5957 a_15837_4687# VSS 0.94699f ; **FLOATING
C5958 a_15273_4687# VSS 0.44136f ; **FLOATING
C5959 a_14643_4687# VSS 0.48674f ; **FLOATING
C5960 a_15077_4687# VSS 0.91638f ; **FLOATING
C5961 a_14513_4687# VSS 0.44355f ; **FLOATING
C5962 a_13883_4687# VSS 0.48786f ; **FLOATING
C5963 a_14317_4687# VSS 0.95143f ; **FLOATING
C5964 a_13753_4687# VSS 0.44737f ; **FLOATING
C5965 a_13123_4687# VSS 0.94748f ; **FLOATING
C5966 a_13557_4687# VSS 0.93399f ; **FLOATING
C5967 a_12993_4687# VSS 0.56321f ; **FLOATING
C5968 a_12363_4687# VSS 0.46822f ; **FLOATING
C5969 a_12797_4687# VSS 1.11192f ; **FLOATING
C5970 a_12233_4687# VSS 0.4374f ; **FLOATING
C5971 a_11603_4687# VSS 0.48677f ; **FLOATING
C5972 a_12037_4687# VSS 0.91827f ; **FLOATING
C5973 a_11473_4687# VSS 0.4435f ; **FLOATING
C5974 a_10843_4687# VSS 0.48774f ; **FLOATING
C5975 a_11277_4687# VSS 0.95122f ; **FLOATING
C5976 a_10713_4687# VSS 0.44619f ; **FLOATING
C5977 a_10083_4687# VSS 0.48563f ; **FLOATING
C5978 a_10517_4687# VSS 0.86086f ; **FLOATING
C5979 a_9953_4687# VSS 0.44414f ; **FLOATING
C5980 a_9323_4687# VSS 0.48744f ; **FLOATING
C5981 a_9757_4687# VSS 0.95346f ; **FLOATING
C5982 a_9193_4687# VSS 0.44136f ; **FLOATING
C5983 a_8563_4687# VSS 0.48671f ; **FLOATING
C5984 a_8997_4687# VSS 0.91814f ; **FLOATING
C5985 a_8433_4687# VSS 0.44348f ; **FLOATING
C5986 a_7803_4687# VSS 0.48774f ; **FLOATING
C5987 a_8237_4687# VSS 0.95122f ; **FLOATING
C5988 a_7673_4687# VSS 0.44619f ; **FLOATING
C5989 a_7043_4687# VSS 0.48563f ; **FLOATING
C5990 a_7477_4687# VSS 0.86086f ; **FLOATING
C5991 a_6913_4687# VSS 0.44414f ; **FLOATING
C5992 a_6283_4687# VSS 0.48744f ; **FLOATING
C5993 a_6717_4687# VSS 0.95287f ; **FLOATING
C5994 a_6153_4687# VSS 0.44059f ; **FLOATING
C5995 a_5523_4687# VSS 0.48671f ; **FLOATING
C5996 a_5957_4687# VSS 0.91534f ; **FLOATING
C5997 a_5393_4687# VSS 0.44587f ; **FLOATING
C5998 a_4763_4687# VSS 0.49323f ; **FLOATING
C5999 a_5197_4687# VSS 0.95402f ; **FLOATING
C6000 a_4633_4687# VSS 0.44882f ; **FLOATING
C6001 a_4003_4687# VSS 0.57066f ; **FLOATING
C6002 a_4437_4687# VSS 0.86317f ; **FLOATING
C6003 a_26985_6209# VSS 0.17928f ; **FLOATING
C6004 a_23945_6209# VSS 0.17928f ; **FLOATING
C6005 a_20905_6209# VSS 0.17928f ; **FLOATING
C6006 a_17865_6209# VSS 0.17593f ; **FLOATING
C6007 a_16851_5999# VSS 0.37653f ; **FLOATING
C6008 a_16108_5979# VSS 2.50015f ; **FLOATING
C6009 a_15964_5979# VSS 0.17103f ; **FLOATING
C6010 a_15765_6153# VSS 0.33587f ; **FLOATING
C6011 a_14825_6209# VSS 0.17928f ; **FLOATING
C6012 a_11785_6209# VSS 0.17928f ; **FLOATING
C6013 a_8745_6209# VSS 0.17928f ; **FLOATING
C6014 a_5731_5979# VSS 2.24589f ; **FLOATING
C6015 a_5705_6209# VSS 0.17638f ; **FLOATING
C6016 a_3449_6021# VSS 0.17702f ; **FLOATING
C6017 a_2873_6021# VSS 0.1828f ; **FLOATING
C6018 a_2297_6021# VSS 0.1829f ; **FLOATING
C6019 a_1721_6021# VSS 0.17136f ; **FLOATING
C6020 a_1544_5979# VSS 0.29772f ; **FLOATING
C6021 a_1256_5979# VSS 0.85178f ; **FLOATING
C6022 a_27991_6698# VSS 0.18561f ; **FLOATING
C6023 a_27915_6734# VSS 0.10926f ; **FLOATING
C6024 a_27124_6698# VSS 0.17878f ; **FLOATING
C6025 a_27048_6734# VSS 0.12122f ; **FLOATING
C6026 a_26471_6698# VSS 0.18126f ; **FLOATING
C6027 a_26395_6734# VSS 0.11073f ; **FLOATING
C6028 a_25604_6698# VSS 0.18087f ; **FLOATING
C6029 a_25630_6734# VSS 0.33072f ; **FLOATING
C6030 a_25528_6734# VSS 0.12433f ; **FLOATING
C6031 a_24951_6698# VSS 0.18335f ; **FLOATING
C6032 a_24875_6734# VSS 0.11016f ; **FLOATING
C6033 a_24084_6698# VSS 0.17878f ; **FLOATING
C6034 a_24008_6734# VSS 0.12122f ; **FLOATING
C6035 a_23431_6698# VSS 0.18132f ; **FLOATING
C6036 a_23355_6734# VSS 0.11566f ; **FLOATING
C6037 a_22564_6698# VSS 0.18087f ; **FLOATING
C6038 a_22590_6734# VSS 0.34383f ; **FLOATING
C6039 a_22488_6734# VSS 0.12433f ; **FLOATING
C6040 a_21911_6698# VSS 0.18335f ; **FLOATING
C6041 a_21835_6734# VSS 0.11016f ; **FLOATING
C6042 a_21044_6698# VSS 0.17878f ; **FLOATING
C6043 a_20968_6734# VSS 0.12122f ; **FLOATING
C6044 a_20391_6698# VSS 0.18126f ; **FLOATING
C6045 a_20315_6734# VSS 0.11073f ; **FLOATING
C6046 a_19524_6698# VSS 0.18087f ; **FLOATING
C6047 a_19550_6734# VSS 0.33343f ; **FLOATING
C6048 a_19448_6734# VSS 0.12433f ; **FLOATING
C6049 a_18871_6698# VSS 0.18335f ; **FLOATING
C6050 a_18795_6734# VSS 0.11016f ; **FLOATING
C6051 a_18004_6698# VSS 0.17878f ; **FLOATING
C6052 a_17928_6734# VSS 0.12122f ; **FLOATING
C6053 a_17351_6698# VSS 0.17877f ; **FLOATING
C6054 a_17275_6734# VSS 0.10926f ; **FLOATING
C6055 a_16484_6698# VSS 0.17947f ; **FLOATING
C6056 a_16510_6734# VSS 0.28935f ; **FLOATING
C6057 a_16408_6734# VSS 0.1229f ; **FLOATING
C6058 a_15831_6698# VSS 0.17846f ; **FLOATING
C6059 a_15755_6734# VSS 0.10926f ; **FLOATING
C6060 a_14964_6698# VSS 0.17878f ; **FLOATING
C6061 a_14888_6734# VSS 0.12122f ; **FLOATING
C6062 a_14311_6698# VSS 0.18126f ; **FLOATING
C6063 a_14235_6734# VSS 0.11073f ; **FLOATING
C6064 a_13444_6698# VSS 0.18205f ; **FLOATING
C6065 a_13470_6734# VSS 0.30999f ; **FLOATING
C6066 a_13368_6734# VSS 0.13246f ; **FLOATING
C6067 a_12791_6698# VSS 0.18335f ; **FLOATING
C6068 a_12715_6734# VSS 0.11016f ; **FLOATING
C6069 a_11924_6698# VSS 0.17878f ; **FLOATING
C6070 a_11848_6734# VSS 0.12122f ; **FLOATING
C6071 a_11271_6698# VSS 0.18126f ; **FLOATING
C6072 a_11195_6734# VSS 0.11073f ; **FLOATING
C6073 a_10404_6698# VSS 0.18087f ; **FLOATING
C6074 a_10430_6734# VSS 0.30746f ; **FLOATING
C6075 a_10328_6734# VSS 0.12433f ; **FLOATING
C6076 a_9751_6698# VSS 0.18335f ; **FLOATING
C6077 a_9675_6734# VSS 0.11016f ; **FLOATING
C6078 a_8884_6698# VSS 0.17878f ; **FLOATING
C6079 a_8808_6734# VSS 0.12122f ; **FLOATING
C6080 a_8231_6698# VSS 0.18126f ; **FLOATING
C6081 a_8155_6734# VSS 0.11073f ; **FLOATING
C6082 a_7364_6698# VSS 0.18087f ; **FLOATING
C6083 a_7390_6734# VSS 0.31357f ; **FLOATING
C6084 a_7288_6734# VSS 0.12433f ; **FLOATING
C6085 a_6711_6698# VSS 0.18335f ; **FLOATING
C6086 a_6635_6734# VSS 0.11016f ; **FLOATING
C6087 a_5844_6698# VSS 0.17878f ; **FLOATING
C6088 a_5768_6734# VSS 0.12122f ; **FLOATING
C6089 a_5191_6698# VSS 0.17877f ; **FLOATING
C6090 a_5115_6734# VSS 0.10926f ; **FLOATING
C6091 a_4324_6698# VSS 0.17947f ; **FLOATING
C6092 a_4350_6734# VSS 0.26655f ; **FLOATING
C6093 a_4248_6734# VSS 0.12443f ; **FLOATING
C6094 a_27705_6734# VSS 0.25231f ; **FLOATING
C6095 a_26185_6734# VSS 0.23475f ; **FLOATING
C6096 a_24665_6734# VSS 0.25433f ; **FLOATING
C6097 a_23145_6734# VSS 0.24629f ; **FLOATING
C6098 a_21625_6734# VSS 0.25433f ; **FLOATING
C6099 a_20105_6734# VSS 0.23475f ; **FLOATING
C6100 a_18585_6734# VSS 0.25433f ; **FLOATING
C6101 a_17065_6734# VSS 0.23378f ; **FLOATING
C6102 a_15545_6734# VSS 0.25231f ; **FLOATING
C6103 a_14025_6734# VSS 0.23475f ; **FLOATING
C6104 a_12505_6734# VSS 0.25433f ; **FLOATING
C6105 a_10985_6734# VSS 0.23475f ; **FLOATING
C6106 a_9465_6734# VSS 0.25433f ; **FLOATING
C6107 a_7945_6734# VSS 0.23475f ; **FLOATING
C6108 a_6425_6734# VSS 0.25433f ; **FLOATING
C6109 a_4905_6734# VSS 0.23483f ; **FLOATING
C6110 a_4157_7003# VSS 0.32839f ; **FLOATING
C6111 a_3449_7085# VSS 0.18629f ; **FLOATING
C6112 a_2873_7085# VSS 0.18349f ; **FLOATING
C6113 a_2297_7085# VSS 0.18359f ; **FLOATING
C6114 a_1721_7085# VSS 0.17253f ; **FLOATING
C6115 a_1544_6734# VSS 0.29907f ; **FLOATING
C6116 a_1256_6734# VSS 0.86052f ; **FLOATING
C6117 a_27671_7532# VSS 0.01336f ; **FLOATING
C6118 a_26911_7532# VSS 0.01336f ; **FLOATING
C6119 a_26151_7532# VSS 0.01336f ; **FLOATING
C6120 a_25391_7532# VSS 0.01336f ; **FLOATING
C6121 a_24631_7532# VSS 0.01336f ; **FLOATING
C6122 a_23871_7532# VSS 0.01336f ; **FLOATING
C6123 a_23111_7532# VSS 0.01733f ; **FLOATING
C6124 a_22351_7532# VSS 0.01336f ; **FLOATING
C6125 a_21591_7532# VSS 0.01336f ; **FLOATING
C6126 a_20831_7532# VSS 0.01336f ; **FLOATING
C6127 a_20071_7532# VSS 0.01336f ; **FLOATING
C6128 a_19311_7532# VSS 0.01336f ; **FLOATING
C6129 a_18551_7532# VSS 0.01336f ; **FLOATING
C6130 a_17791_7532# VSS 0.01336f ; **FLOATING
C6131 a_17031_7532# VSS 0.01336f ; **FLOATING
C6132 a_16271_7532# VSS 0.01336f ; **FLOATING
C6133 a_15511_7532# VSS 0.01336f ; **FLOATING
C6134 a_14751_7532# VSS 0.01336f ; **FLOATING
C6135 a_13991_7532# VSS 0.01336f ; **FLOATING
C6136 a_13231_7532# VSS 0.01733f ; **FLOATING
C6137 a_12471_7532# VSS 0.01336f ; **FLOATING
C6138 a_11711_7532# VSS 0.01336f ; **FLOATING
C6139 a_10951_7532# VSS 0.01336f ; **FLOATING
C6140 a_10191_7532# VSS 0.01336f ; **FLOATING
C6141 a_9431_7532# VSS 0.01336f ; **FLOATING
C6142 a_8671_7532# VSS 0.01336f ; **FLOATING
C6143 a_7911_7532# VSS 0.01336f ; **FLOATING
C6144 a_7151_7532# VSS 0.01336f ; **FLOATING
C6145 a_6391_7532# VSS 0.01336f ; **FLOATING
C6146 a_5631_7532# VSS 0.01336f ; **FLOATING
C6147 a_4871_7532# VSS 0.01336f ; **FLOATING
C6148 a_4111_7532# VSS 0.0139f ; **FLOATING
C6149 a_27563_7532# VSS 0.50316f ; **FLOATING
C6150 a_27997_7532# VSS 0.6484f ; **FLOATING
C6151 a_27433_7532# VSS 0.4463f ; **FLOATING
C6152 a_26803_7532# VSS 0.49934f ; **FLOATING
C6153 a_27237_7532# VSS 0.92787f ; **FLOATING
C6154 a_26673_7532# VSS 0.4492f ; **FLOATING
C6155 a_26043_7532# VSS 0.50169f ; **FLOATING
C6156 a_26477_7532# VSS 0.9592f ; **FLOATING
C6157 a_25913_7532# VSS 0.4508f ; **FLOATING
C6158 a_25283_7532# VSS 0.49938f ; **FLOATING
C6159 a_25717_7532# VSS 0.86809f ; **FLOATING
C6160 a_25153_7532# VSS 0.45037f ; **FLOATING
C6161 a_24523_7532# VSS 0.50078f ; **FLOATING
C6162 a_24957_7532# VSS 0.96347f ; **FLOATING
C6163 a_24393_7532# VSS 0.44639f ; **FLOATING
C6164 a_23763_7532# VSS 0.49951f ; **FLOATING
C6165 a_24197_7532# VSS 0.92487f ; **FLOATING
C6166 a_23633_7532# VSS 0.45419f ; **FLOATING
C6167 a_23003_7532# VSS 0.96254f ; **FLOATING
C6168 a_23437_7532# VSS 1.07504f ; **FLOATING
C6169 a_22873_7532# VSS 0.57074f ; **FLOATING
C6170 a_22243_7532# VSS 0.47049f ; **FLOATING
C6171 a_22677_7532# VSS 0.88675f ; **FLOATING
C6172 a_22113_7532# VSS 0.45185f ; **FLOATING
C6173 a_21483_7532# VSS 0.50081f ; **FLOATING
C6174 a_21917_7532# VSS 0.96116f ; **FLOATING
C6175 a_21353_7532# VSS 0.44632f ; **FLOATING
C6176 a_20723_7532# VSS 0.49992f ; **FLOATING
C6177 a_21157_7532# VSS 0.92429f ; **FLOATING
C6178 a_20593_7532# VSS 0.45196f ; **FLOATING
C6179 a_19963_7532# VSS 0.50169f ; **FLOATING
C6180 a_20397_7532# VSS 0.95761f ; **FLOATING
C6181 a_19833_7532# VSS 0.4508f ; **FLOATING
C6182 a_19203_7532# VSS 0.5005f ; **FLOATING
C6183 a_19637_7532# VSS 0.86809f ; **FLOATING
C6184 a_19073_7532# VSS 0.44947f ; **FLOATING
C6185 a_18443_7532# VSS 0.50075f ; **FLOATING
C6186 a_18877_7532# VSS 0.96341f ; **FLOATING
C6187 a_18313_7532# VSS 0.4463f ; **FLOATING
C6188 a_17683_7532# VSS 0.50046f ; **FLOATING
C6189 a_18117_7532# VSS 0.92429f ; **FLOATING
C6190 a_17553_7532# VSS 0.44782f ; **FLOATING
C6191 a_16923_7532# VSS 0.50165f ; **FLOATING
C6192 a_17357_7532# VSS 0.95761f ; **FLOATING
C6193 a_16793_7532# VSS 0.45049f ; **FLOATING
C6194 a_16163_7532# VSS 0.4946f ; **FLOATING
C6195 a_16597_7532# VSS 0.86295f ; **FLOATING
C6196 a_16033_7532# VSS 0.44618f ; **FLOATING
C6197 a_15403_7532# VSS 0.49465f ; **FLOATING
C6198 a_15837_7532# VSS 0.95171f ; **FLOATING
C6199 a_15273_7532# VSS 0.44439f ; **FLOATING
C6200 a_14643_7532# VSS 0.49308f ; **FLOATING
C6201 a_15077_7532# VSS 0.9194f ; **FLOATING
C6202 a_14513_7532# VSS 0.44508f ; **FLOATING
C6203 a_13883_7532# VSS 0.50873f ; **FLOATING
C6204 a_14317_7532# VSS 0.96022f ; **FLOATING
C6205 a_13753_7532# VSS 0.46545f ; **FLOATING
C6206 a_13123_7532# VSS 0.94424f ; **FLOATING
C6207 a_13557_7532# VSS 0.94034f ; **FLOATING
C6208 a_12993_7532# VSS 0.57373f ; **FLOATING
C6209 a_12363_7532# VSS 0.47063f ; **FLOATING
C6210 a_12797_7532# VSS 1.11988f ; **FLOATING
C6211 a_12233_7532# VSS 0.44855f ; **FLOATING
C6212 a_11603_7532# VSS 0.50273f ; **FLOATING
C6213 a_12037_7532# VSS 0.92765f ; **FLOATING
C6214 a_11473_7532# VSS 0.45178f ; **FLOATING
C6215 a_10843_7532# VSS 0.50491f ; **FLOATING
C6216 a_11277_7532# VSS 0.96044f ; **FLOATING
C6217 a_10713_7532# VSS 0.44901f ; **FLOATING
C6218 a_10083_7532# VSS 0.50223f ; **FLOATING
C6219 a_10517_7532# VSS 0.87021f ; **FLOATING
C6220 a_9953_7532# VSS 0.44673f ; **FLOATING
C6221 a_9323_7532# VSS 0.5026f ; **FLOATING
C6222 a_9757_7532# VSS 0.96312f ; **FLOATING
C6223 a_9193_7532# VSS 0.44361f ; **FLOATING
C6224 a_8563_7532# VSS 0.49203f ; **FLOATING
C6225 a_8997_7532# VSS 0.92083f ; **FLOATING
C6226 a_8433_7532# VSS 0.44439f ; **FLOATING
C6227 a_7803_7532# VSS 0.49435f ; **FLOATING
C6228 a_8237_7532# VSS 0.95413f ; **FLOATING
C6229 a_7673_7532# VSS 0.44737f ; **FLOATING
C6230 a_7043_7532# VSS 0.49204f ; **FLOATING
C6231 a_7477_7532# VSS 0.86461f ; **FLOATING
C6232 a_6913_7532# VSS 0.44442f ; **FLOATING
C6233 a_6283_7532# VSS 0.49343f ; **FLOATING
C6234 a_6717_7532# VSS 0.95763f ; **FLOATING
C6235 a_6153_7532# VSS 0.44292f ; **FLOATING
C6236 a_5523_7532# VSS 0.50322f ; **FLOATING
C6237 a_5957_7532# VSS 0.92533f ; **FLOATING
C6238 a_5393_7532# VSS 0.4596f ; **FLOATING
C6239 a_4763_7532# VSS 0.51043f ; **FLOATING
C6240 a_5197_7532# VSS 0.96501f ; **FLOATING
C6241 a_4633_7532# VSS 0.46282f ; **FLOATING
C6242 a_4003_7532# VSS 0.58808f ; **FLOATING
C6243 a_4437_7532# VSS 0.87448f ; **FLOATING
C6244 a_9712_9602# VSS 1.28186f ; **FLOATING
C6245 a_9444_9602# VSS 2.12877f ; **FLOATING
C6246 a_5778_9057# VSS 5.22809f ; **FLOATING
C6247 a_15464_9374# VSS 0.75391f ; **FLOATING
C6248 a_14757_10872# VSS 0.09495f ; **FLOATING
C6249 a_13880_10808# VSS 0.06985f ; **FLOATING
C6250 a_15688_11093# VSS 0.26291f ; **FLOATING
C6251 a_15108_11015# VSS 0.24458f ; **FLOATING
C6252 a_14851_10872# VSS 0.38123f ; **FLOATING
C6253 a_9444_10280# VSS 6.03808f ; **FLOATING
C6254 a_14111_10917# VSS 0.19866f ; **FLOATING
C6255 a_14009_10774# VSS 0.44622f ; **FLOATING
C6256 a_13592_11113# VSS 1.58592f ; **FLOATING
C6257 a_13306_10795# VSS 0.30789f ; **FLOATING
C6258 a_13566_11018# VSS 0.16043f ; **FLOATING
C6259 a_13132_11110# VSS 0.14297f ; **FLOATING
C6260 a_12907_11110# VSS 0.14389f ; **FLOATING
C6261 a_12907_10876# VSS 0.14787f ; **FLOATING
C6262 a_13106_11047# VSS 0.07197f ; **FLOATING
C6263 a_15304_10295# VSS 0.32076f ; **FLOATING
C6264 a_14757_11918# VSS 0.09586f ; **FLOATING
C6265 a_15688_11557# VSS 0.26296f ; **FLOATING
C6266 a_14851_11918# VSS 0.39011f ; **FLOATING
C6267 a_15108_11799# VSS 0.24509f ; **FLOATING
C6268 a_14111_11568# VSS 0.21578f ; **FLOATING
C6269 a_13880_11982# VSS 0.07345f ; **FLOATING
C6270 a_14009_11568# VSS 0.46644f ; **FLOATING
C6271 a_13592_11561# VSS 1.58509f ; **FLOATING
C6272 a_13566_11525# VSS 0.15697f ; **FLOATING
C6273 a_13045_11905# VSS 0.01124f ; **FLOATING
C6274 a_13306_11995# VSS 0.32576f ; **FLOATING
C6275 a_12849_11557# VSS 1.39731f ; **FLOATING
C6276 a_13121_11521# VSS 0.77678f ; **FLOATING
C6277 a_13019_11521# VSS 2.13147f ; **FLOATING
C6278 a_12656_11554# VSS 0.28138f ; **FLOATING
C6279 a_12355_11557# VSS 0.54826f ; **FLOATING
C6280 a_11397_11918# VSS 0.09495f ; **FLOATING
C6281 a_12158_11557# VSS 0.25842f ; **FLOATING
C6282 a_11491_11918# VSS 0.29538f ; **FLOATING
C6283 a_11748_11799# VSS 0.16909f ; **FLOATING
C6284 a_10751_11568# VSS 0.1982f ; **FLOATING
C6285 a_10520_11982# VSS 0.03671f ; **FLOATING
C6286 a_10649_11568# VSS 0.46311f ; **FLOATING
C6287 a_10232_11561# VSS 1.51871f ; **FLOATING
C6288 a_10206_11525# VSS 0.08466f ; **FLOATING
C6289 a_9946_11995# VSS 0.18126f ; **FLOATING
C6290 a_9772_11533# VSS 0.12311f ; **FLOATING
C6291 a_9746_11495# VSS 0.06443f ; **FLOATING
C6292 a_9547_11862# VSS 0.15766f ; **FLOATING
C6293 a_9547_11632# VSS 0.11843f ; **FLOATING
C6294 a_6854_11144# VSS 3.39622f ; **FLOATING
C6295 a_6126_9506# VSS 13.5861f ; **FLOATING
C6296 a_6854_11676# VSS 1.6692f ; **FLOATING
C6297 a_5974_11413# VSS 2.38934f ; **FLOATING
C6298 a_6326_10280# VSS 0.86042f ; **FLOATING
C6299 a_26985_12701# VSS 0.17928f ; **FLOATING
C6300 a_23945_12701# VSS 0.17928f ; **FLOATING
C6301 a_20905_12701# VSS 0.17928f ; **FLOATING
C6302 a_17865_12701# VSS 0.17593f ; **FLOATING
C6303 a_16851_12491# VSS 0.3805f ; **FLOATING
C6304 a_16108_12471# VSS 3.17402f ; **FLOATING
C6305 a_15964_12471# VSS 0.17235f ; **FLOATING
C6306 a_15765_12645# VSS 0.34456f ; **FLOATING
C6307 a_14825_12701# VSS 0.17928f ; **FLOATING
C6308 a_11785_12701# VSS 0.17928f ; **FLOATING
C6309 a_8745_12701# VSS 0.17928f ; **FLOATING
C6310 a_5731_12471# VSS 2.6668f ; **FLOATING
C6311 a_5705_12701# VSS 0.17638f ; **FLOATING
C6312 a_3449_12513# VSS 0.18479f ; **FLOATING
C6313 a_2873_12513# VSS 0.18322f ; **FLOATING
C6314 a_2297_12513# VSS 0.18332f ; **FLOATING
C6315 a_1721_12513# VSS 0.17179f ; **FLOATING
C6316 a_1544_12471# VSS 0.29908f ; **FLOATING
C6317 a_1256_12471# VSS 0.86127f ; **FLOATING
C6318 a_27991_13190# VSS 0.18558f ; **FLOATING
C6319 a_27915_13226# VSS 0.10926f ; **FLOATING
C6320 a_27124_13190# VSS 0.17878f ; **FLOATING
C6321 a_27048_13226# VSS 0.12122f ; **FLOATING
C6322 a_26471_13190# VSS 0.18115f ; **FLOATING
C6323 a_26395_13226# VSS 0.11073f ; **FLOATING
C6324 a_25604_13190# VSS 0.18087f ; **FLOATING
C6325 a_25630_13226# VSS 0.3653f ; **FLOATING
C6326 a_25528_13226# VSS 0.12433f ; **FLOATING
C6327 a_24951_13190# VSS 0.18335f ; **FLOATING
C6328 a_24875_13226# VSS 0.11016f ; **FLOATING
C6329 a_24084_13190# VSS 0.17878f ; **FLOATING
C6330 a_24008_13226# VSS 0.12122f ; **FLOATING
C6331 a_23431_13190# VSS 0.18111f ; **FLOATING
C6332 a_23355_13226# VSS 0.11566f ; **FLOATING
C6333 a_22564_13190# VSS 0.18087f ; **FLOATING
C6334 a_22590_13226# VSS 0.34383f ; **FLOATING
C6335 a_22488_13226# VSS 0.12433f ; **FLOATING
C6336 a_21911_13190# VSS 0.18335f ; **FLOATING
C6337 a_21835_13226# VSS 0.11016f ; **FLOATING
C6338 a_21044_13190# VSS 0.17878f ; **FLOATING
C6339 a_20968_13226# VSS 0.12122f ; **FLOATING
C6340 a_20391_13190# VSS 0.18104f ; **FLOATING
C6341 a_20315_13226# VSS 0.11073f ; **FLOATING
C6342 a_19524_13190# VSS 0.18087f ; **FLOATING
C6343 a_19550_13226# VSS 0.33343f ; **FLOATING
C6344 a_19448_13226# VSS 0.12433f ; **FLOATING
C6345 a_18871_13190# VSS 0.18335f ; **FLOATING
C6346 a_18795_13226# VSS 0.11016f ; **FLOATING
C6347 a_18004_13190# VSS 0.17878f ; **FLOATING
C6348 a_17928_13226# VSS 0.12122f ; **FLOATING
C6349 a_17351_13190# VSS 0.17808f ; **FLOATING
C6350 a_17275_13226# VSS 0.10926f ; **FLOATING
C6351 a_16484_13190# VSS 0.17809f ; **FLOATING
C6352 a_16510_13226# VSS 0.28935f ; **FLOATING
C6353 a_16408_13226# VSS 0.1229f ; **FLOATING
C6354 a_15831_13190# VSS 0.17846f ; **FLOATING
C6355 a_15755_13226# VSS 0.10926f ; **FLOATING
C6356 a_14964_13190# VSS 0.17878f ; **FLOATING
C6357 a_14888_13226# VSS 0.12122f ; **FLOATING
C6358 a_14311_13190# VSS 0.18138f ; **FLOATING
C6359 a_14235_13226# VSS 0.11073f ; **FLOATING
C6360 a_13444_13190# VSS 0.18205f ; **FLOATING
C6361 a_13470_13226# VSS 0.30999f ; **FLOATING
C6362 a_13368_13226# VSS 0.13246f ; **FLOATING
C6363 a_12791_13190# VSS 0.18335f ; **FLOATING
C6364 a_12715_13226# VSS 0.11016f ; **FLOATING
C6365 a_11924_13190# VSS 0.17878f ; **FLOATING
C6366 a_11848_13226# VSS 0.12122f ; **FLOATING
C6367 a_11271_13190# VSS 0.18178f ; **FLOATING
C6368 a_11195_13226# VSS 0.11073f ; **FLOATING
C6369 a_10404_13190# VSS 0.18087f ; **FLOATING
C6370 a_10430_13226# VSS 0.30746f ; **FLOATING
C6371 a_10328_13226# VSS 0.12433f ; **FLOATING
C6372 a_9751_13190# VSS 0.18335f ; **FLOATING
C6373 a_9675_13226# VSS 0.11016f ; **FLOATING
C6374 a_8884_13190# VSS 0.17878f ; **FLOATING
C6375 a_8808_13226# VSS 0.12122f ; **FLOATING
C6376 a_8231_13190# VSS 0.1809f ; **FLOATING
C6377 a_8155_13226# VSS 0.11073f ; **FLOATING
C6378 a_7364_13190# VSS 0.18087f ; **FLOATING
C6379 a_7390_13226# VSS 0.31357f ; **FLOATING
C6380 a_7288_13226# VSS 0.12433f ; **FLOATING
C6381 a_6711_13190# VSS 0.18335f ; **FLOATING
C6382 a_6635_13226# VSS 0.11016f ; **FLOATING
C6383 a_5844_13190# VSS 0.17878f ; **FLOATING
C6384 a_5768_13226# VSS 0.12122f ; **FLOATING
C6385 a_5191_13190# VSS 0.18022f ; **FLOATING
C6386 a_5115_13226# VSS 0.10926f ; **FLOATING
C6387 a_4324_13190# VSS 0.18023f ; **FLOATING
C6388 a_4350_13226# VSS 0.26655f ; **FLOATING
C6389 a_4248_13226# VSS 0.12443f ; **FLOATING
C6390 a_27705_13226# VSS 0.25204f ; **FLOATING
C6391 a_26185_13226# VSS 0.23475f ; **FLOATING
C6392 a_24665_13226# VSS 0.25405f ; **FLOATING
C6393 a_23145_13226# VSS 0.24628f ; **FLOATING
C6394 a_21625_13226# VSS 0.25405f ; **FLOATING
C6395 a_20105_13226# VSS 0.23475f ; **FLOATING
C6396 a_18585_13226# VSS 0.25405f ; **FLOATING
C6397 a_17065_13226# VSS 0.23373f ; **FLOATING
C6398 a_15545_13226# VSS 0.25216f ; **FLOATING
C6399 a_14025_13226# VSS 0.23475f ; **FLOATING
C6400 a_12505_13226# VSS 0.25405f ; **FLOATING
C6401 a_10985_13226# VSS 0.23475f ; **FLOATING
C6402 a_9465_13226# VSS 0.25405f ; **FLOATING
C6403 a_7945_13226# VSS 0.23475f ; **FLOATING
C6404 a_6425_13226# VSS 0.25405f ; **FLOATING
C6405 a_4905_13226# VSS 0.2355f ; **FLOATING
C6406 a_4157_13495# VSS 0.32875f ; **FLOATING
C6407 a_3449_13577# VSS 0.18619f ; **FLOATING
C6408 a_2873_13577# VSS 0.18296f ; **FLOATING
C6409 a_2297_13577# VSS 0.18306f ; **FLOATING
C6410 a_1721_13577# VSS 0.172f ; **FLOATING
C6411 a_1544_13226# VSS 0.29854f ; **FLOATING
C6412 a_1256_13226# VSS 0.85418f ; **FLOATING
C6413 a_27671_14024# VSS 0.01336f ; **FLOATING
C6414 a_26911_14024# VSS 0.01336f ; **FLOATING
C6415 a_26151_14024# VSS 0.01336f ; **FLOATING
C6416 a_25391_14024# VSS 0.01336f ; **FLOATING
C6417 a_24631_14024# VSS 0.01336f ; **FLOATING
C6418 a_23871_14024# VSS 0.01336f ; **FLOATING
C6419 a_23111_14024# VSS 0.01733f ; **FLOATING
C6420 a_22351_14024# VSS 0.01336f ; **FLOATING
C6421 a_21591_14024# VSS 0.01336f ; **FLOATING
C6422 a_20831_14024# VSS 0.01336f ; **FLOATING
C6423 a_20071_14024# VSS 0.01336f ; **FLOATING
C6424 a_19311_14024# VSS 0.01336f ; **FLOATING
C6425 a_18551_14024# VSS 0.01336f ; **FLOATING
C6426 a_17791_14024# VSS 0.01336f ; **FLOATING
C6427 a_17031_14024# VSS 0.01336f ; **FLOATING
C6428 a_16271_14024# VSS 0.01336f ; **FLOATING
C6429 a_15511_14024# VSS 0.01336f ; **FLOATING
C6430 a_14751_14024# VSS 0.01336f ; **FLOATING
C6431 a_13991_14024# VSS 0.01336f ; **FLOATING
C6432 a_13231_14024# VSS 0.01733f ; **FLOATING
C6433 a_12471_14024# VSS 0.01336f ; **FLOATING
C6434 a_11711_14024# VSS 0.01336f ; **FLOATING
C6435 a_10951_14024# VSS 0.01336f ; **FLOATING
C6436 a_10191_14024# VSS 0.01336f ; **FLOATING
C6437 a_9431_14024# VSS 0.01336f ; **FLOATING
C6438 a_8671_14024# VSS 0.01336f ; **FLOATING
C6439 a_7911_14024# VSS 0.01336f ; **FLOATING
C6440 a_7151_14024# VSS 0.01336f ; **FLOATING
C6441 a_6391_14024# VSS 0.01336f ; **FLOATING
C6442 a_5631_14024# VSS 0.01336f ; **FLOATING
C6443 a_4871_14024# VSS 0.01336f ; **FLOATING
C6444 a_4111_14024# VSS 0.0139f ; **FLOATING
C6445 a_27563_14024# VSS 0.49473f ; **FLOATING
C6446 a_27997_14024# VSS 0.64441f ; **FLOATING
C6447 a_27433_14024# VSS 0.44435f ; **FLOATING
C6448 a_26803_14024# VSS 0.48676f ; **FLOATING
C6449 a_27237_14024# VSS 0.92245f ; **FLOATING
C6450 a_26673_14024# VSS 0.44348f ; **FLOATING
C6451 a_26043_14024# VSS 0.48774f ; **FLOATING
C6452 a_26477_14024# VSS 0.951f ; **FLOATING
C6453 a_25913_14024# VSS 0.44619f ; **FLOATING
C6454 a_25283_14024# VSS 0.48565f ; **FLOATING
C6455 a_25717_14024# VSS 0.86092f ; **FLOATING
C6456 a_25153_14024# VSS 0.44417f ; **FLOATING
C6457 a_24523_14024# VSS 0.48747f ; **FLOATING
C6458 a_24957_14024# VSS 0.95519f ; **FLOATING
C6459 a_24393_14024# VSS 0.44145f ; **FLOATING
C6460 a_23763_14024# VSS 0.48687f ; **FLOATING
C6461 a_24197_14024# VSS 0.91826f ; **FLOATING
C6462 a_23633_14024# VSS 0.44706f ; **FLOATING
C6463 a_23003_14024# VSS 0.95737f ; **FLOATING
C6464 a_23437_14024# VSS 1.08134f ; **FLOATING
C6465 a_22873_14024# VSS 0.56613f ; **FLOATING
C6466 a_22243_14024# VSS 0.46741f ; **FLOATING
C6467 a_22677_14024# VSS 0.88584f ; **FLOATING
C6468 a_22113_14024# VSS 0.4435f ; **FLOATING
C6469 a_21483_14024# VSS 0.4875f ; **FLOATING
C6470 a_21917_14024# VSS 0.95287f ; **FLOATING
C6471 a_21353_14024# VSS 0.44138f ; **FLOATING
C6472 a_20723_14024# VSS 0.48671f ; **FLOATING
C6473 a_21157_14024# VSS 0.91769f ; **FLOATING
C6474 a_20593_14024# VSS 0.44348f ; **FLOATING
C6475 a_19963_14024# VSS 0.48774f ; **FLOATING
C6476 a_20397_14024# VSS 0.951f ; **FLOATING
C6477 a_19833_14024# VSS 0.44619f ; **FLOATING
C6478 a_19203_14024# VSS 0.48565f ; **FLOATING
C6479 a_19637_14024# VSS 0.86092f ; **FLOATING
C6480 a_19073_14024# VSS 0.44414f ; **FLOATING
C6481 a_18443_14024# VSS 0.48744f ; **FLOATING
C6482 a_18877_14024# VSS 0.95513f ; **FLOATING
C6483 a_18313_14024# VSS 0.44059f ; **FLOATING
C6484 a_17683_14024# VSS 0.48671f ; **FLOATING
C6485 a_18117_14024# VSS 0.91489f ; **FLOATING
C6486 a_17553_14024# VSS 0.44348f ; **FLOATING
C6487 a_16923_14024# VSS 0.4899f ; **FLOATING
C6488 a_17357_14024# VSS 0.95217f ; **FLOATING
C6489 a_16793_14024# VSS 0.44447f ; **FLOATING
C6490 a_16163_14024# VSS 0.48792f ; **FLOATING
C6491 a_16597_14024# VSS 0.85716f ; **FLOATING
C6492 a_16033_14024# VSS 0.4368f ; **FLOATING
C6493 a_15403_14024# VSS 0.48909f ; **FLOATING
C6494 a_15837_14024# VSS 0.94699f ; **FLOATING
C6495 a_15273_14024# VSS 0.44136f ; **FLOATING
C6496 a_14643_14024# VSS 0.48674f ; **FLOATING
C6497 a_15077_14024# VSS 0.91632f ; **FLOATING
C6498 a_14513_14024# VSS 0.44355f ; **FLOATING
C6499 a_13883_14024# VSS 0.48786f ; **FLOATING
C6500 a_14317_14024# VSS 0.95153f ; **FLOATING
C6501 a_13753_14024# VSS 0.44737f ; **FLOATING
C6502 a_13123_14024# VSS 0.94748f ; **FLOATING
C6503 a_13557_14024# VSS 0.93434f ; **FLOATING
C6504 a_12993_14024# VSS 0.56321f ; **FLOATING
C6505 a_12363_14024# VSS 0.46822f ; **FLOATING
C6506 a_12797_14024# VSS 1.11192f ; **FLOATING
C6507 a_12233_14024# VSS 0.4374f ; **FLOATING
C6508 a_11603_14024# VSS 0.48677f ; **FLOATING
C6509 a_12037_14024# VSS 0.91947f ; **FLOATING
C6510 a_11473_14024# VSS 0.4435f ; **FLOATING
C6511 a_10843_14024# VSS 0.48774f ; **FLOATING
C6512 a_11277_14024# VSS 0.95129f ; **FLOATING
C6513 a_10713_14024# VSS 0.44619f ; **FLOATING
C6514 a_10083_14024# VSS 0.48563f ; **FLOATING
C6515 a_10517_14024# VSS 0.86091f ; **FLOATING
C6516 a_9953_14024# VSS 0.44414f ; **FLOATING
C6517 a_9323_14024# VSS 0.48744f ; **FLOATING
C6518 a_9757_14024# VSS 0.95346f ; **FLOATING
C6519 a_9193_14024# VSS 0.44136f ; **FLOATING
C6520 a_8563_14024# VSS 0.48671f ; **FLOATING
C6521 a_8997_14024# VSS 0.91942f ; **FLOATING
C6522 a_8433_14024# VSS 0.44348f ; **FLOATING
C6523 a_7803_14024# VSS 0.48774f ; **FLOATING
C6524 a_8237_14024# VSS 0.95094f ; **FLOATING
C6525 a_7673_14024# VSS 0.44619f ; **FLOATING
C6526 a_7043_14024# VSS 0.48563f ; **FLOATING
C6527 a_7477_14024# VSS 0.86086f ; **FLOATING
C6528 a_6913_14024# VSS 0.44414f ; **FLOATING
C6529 a_6283_14024# VSS 0.48744f ; **FLOATING
C6530 a_6717_14024# VSS 0.95287f ; **FLOATING
C6531 a_6153_14024# VSS 0.44059f ; **FLOATING
C6532 a_5523_14024# VSS 0.48671f ; **FLOATING
C6533 a_5957_14024# VSS 0.91503f ; **FLOATING
C6534 a_5393_14024# VSS 0.44587f ; **FLOATING
C6535 a_4763_14024# VSS 0.49323f ; **FLOATING
C6536 a_5197_14024# VSS 0.9541f ; **FLOATING
C6537 a_4633_14024# VSS 0.44882f ; **FLOATING
C6538 a_4003_14024# VSS 0.57066f ; **FLOATING
C6539 a_4437_14024# VSS 0.86497f ; **FLOATING
C6540 a_26985_15546# VSS 0.17928f ; **FLOATING
C6541 a_23945_15546# VSS 0.17928f ; **FLOATING
C6542 a_20905_15546# VSS 0.17928f ; **FLOATING
C6543 a_17865_15546# VSS 0.17593f ; **FLOATING
C6544 a_16851_15336# VSS 0.37653f ; **FLOATING
C6545 a_16108_15316# VSS 2.50015f ; **FLOATING
C6546 a_15964_15316# VSS 0.17103f ; **FLOATING
C6547 a_15765_15490# VSS 0.33587f ; **FLOATING
C6548 a_14825_15546# VSS 0.17928f ; **FLOATING
C6549 a_11785_15546# VSS 0.17928f ; **FLOATING
C6550 a_8745_15546# VSS 0.17928f ; **FLOATING
C6551 a_5731_15316# VSS 2.24589f ; **FLOATING
C6552 a_5705_15546# VSS 0.17638f ; **FLOATING
C6553 a_3449_15358# VSS 0.17702f ; **FLOATING
C6554 a_2873_15358# VSS 0.1828f ; **FLOATING
C6555 a_2297_15358# VSS 0.1829f ; **FLOATING
C6556 a_1721_15358# VSS 0.17136f ; **FLOATING
C6557 a_1544_15316# VSS 0.29772f ; **FLOATING
C6558 a_1256_15316# VSS 0.85178f ; **FLOATING
C6559 a_27991_16035# VSS 0.18561f ; **FLOATING
C6560 a_27915_16071# VSS 0.10926f ; **FLOATING
C6561 a_27124_16035# VSS 0.17878f ; **FLOATING
C6562 a_27048_16071# VSS 0.12122f ; **FLOATING
C6563 a_26471_16035# VSS 0.18126f ; **FLOATING
C6564 a_26395_16071# VSS 0.11073f ; **FLOATING
C6565 a_25604_16035# VSS 0.18087f ; **FLOATING
C6566 a_25630_16071# VSS 0.33072f ; **FLOATING
C6567 a_25528_16071# VSS 0.12433f ; **FLOATING
C6568 a_24951_16035# VSS 0.18335f ; **FLOATING
C6569 a_24875_16071# VSS 0.11016f ; **FLOATING
C6570 a_24084_16035# VSS 0.17878f ; **FLOATING
C6571 a_24008_16071# VSS 0.12122f ; **FLOATING
C6572 a_23431_16035# VSS 0.18132f ; **FLOATING
C6573 a_23355_16071# VSS 0.11566f ; **FLOATING
C6574 a_22564_16035# VSS 0.18087f ; **FLOATING
C6575 a_22590_16071# VSS 0.34383f ; **FLOATING
C6576 a_22488_16071# VSS 0.12433f ; **FLOATING
C6577 a_21911_16035# VSS 0.18335f ; **FLOATING
C6578 a_21835_16071# VSS 0.11016f ; **FLOATING
C6579 a_21044_16035# VSS 0.17878f ; **FLOATING
C6580 a_20968_16071# VSS 0.12122f ; **FLOATING
C6581 a_20391_16035# VSS 0.18126f ; **FLOATING
C6582 a_20315_16071# VSS 0.11073f ; **FLOATING
C6583 a_19524_16035# VSS 0.18087f ; **FLOATING
C6584 a_19550_16071# VSS 0.33343f ; **FLOATING
C6585 a_19448_16071# VSS 0.12433f ; **FLOATING
C6586 a_18871_16035# VSS 0.18335f ; **FLOATING
C6587 a_18795_16071# VSS 0.11016f ; **FLOATING
C6588 a_18004_16035# VSS 0.17878f ; **FLOATING
C6589 a_17928_16071# VSS 0.12122f ; **FLOATING
C6590 a_17351_16035# VSS 0.17877f ; **FLOATING
C6591 a_17275_16071# VSS 0.10926f ; **FLOATING
C6592 a_16484_16035# VSS 0.17947f ; **FLOATING
C6593 a_16510_16071# VSS 0.28935f ; **FLOATING
C6594 a_16408_16071# VSS 0.1229f ; **FLOATING
C6595 a_15831_16035# VSS 0.17846f ; **FLOATING
C6596 a_15755_16071# VSS 0.10926f ; **FLOATING
C6597 a_14964_16035# VSS 0.17878f ; **FLOATING
C6598 a_14888_16071# VSS 0.12122f ; **FLOATING
C6599 a_14311_16035# VSS 0.18126f ; **FLOATING
C6600 a_14235_16071# VSS 0.11073f ; **FLOATING
C6601 a_13444_16035# VSS 0.18205f ; **FLOATING
C6602 a_13470_16071# VSS 0.30999f ; **FLOATING
C6603 a_13368_16071# VSS 0.13246f ; **FLOATING
C6604 a_12791_16035# VSS 0.18335f ; **FLOATING
C6605 a_12715_16071# VSS 0.11016f ; **FLOATING
C6606 a_11924_16035# VSS 0.17878f ; **FLOATING
C6607 a_11848_16071# VSS 0.12122f ; **FLOATING
C6608 a_11271_16035# VSS 0.18126f ; **FLOATING
C6609 a_11195_16071# VSS 0.11073f ; **FLOATING
C6610 a_10404_16035# VSS 0.18087f ; **FLOATING
C6611 a_10430_16071# VSS 0.30746f ; **FLOATING
C6612 a_10328_16071# VSS 0.12433f ; **FLOATING
C6613 a_9751_16035# VSS 0.18335f ; **FLOATING
C6614 a_9675_16071# VSS 0.11016f ; **FLOATING
C6615 a_8884_16035# VSS 0.17878f ; **FLOATING
C6616 a_8808_16071# VSS 0.12122f ; **FLOATING
C6617 a_8231_16035# VSS 0.18126f ; **FLOATING
C6618 a_8155_16071# VSS 0.11073f ; **FLOATING
C6619 a_7364_16035# VSS 0.18087f ; **FLOATING
C6620 a_7390_16071# VSS 0.31357f ; **FLOATING
C6621 a_7288_16071# VSS 0.12433f ; **FLOATING
C6622 a_6711_16035# VSS 0.18335f ; **FLOATING
C6623 a_6635_16071# VSS 0.11016f ; **FLOATING
C6624 a_5844_16035# VSS 0.17878f ; **FLOATING
C6625 a_5768_16071# VSS 0.12122f ; **FLOATING
C6626 a_5191_16035# VSS 0.17877f ; **FLOATING
C6627 a_5115_16071# VSS 0.10926f ; **FLOATING
C6628 a_4324_16035# VSS 0.17947f ; **FLOATING
C6629 a_4350_16071# VSS 0.26655f ; **FLOATING
C6630 a_4248_16071# VSS 0.12443f ; **FLOATING
C6631 a_27705_16071# VSS 0.25231f ; **FLOATING
C6632 a_26185_16071# VSS 0.23475f ; **FLOATING
C6633 a_24665_16071# VSS 0.25432f ; **FLOATING
C6634 a_23145_16071# VSS 0.24628f ; **FLOATING
C6635 a_21625_16071# VSS 0.25432f ; **FLOATING
C6636 a_20105_16071# VSS 0.23475f ; **FLOATING
C6637 a_18585_16071# VSS 0.25432f ; **FLOATING
C6638 a_17065_16071# VSS 0.23378f ; **FLOATING
C6639 a_15545_16071# VSS 0.25231f ; **FLOATING
C6640 a_14025_16071# VSS 0.23475f ; **FLOATING
C6641 a_12505_16071# VSS 0.25432f ; **FLOATING
C6642 a_10985_16071# VSS 0.23475f ; **FLOATING
C6643 a_9465_16071# VSS 0.25432f ; **FLOATING
C6644 a_7945_16071# VSS 0.23475f ; **FLOATING
C6645 a_6425_16071# VSS 0.25432f ; **FLOATING
C6646 a_4905_16071# VSS 0.23483f ; **FLOATING
C6647 a_4157_16340# VSS 0.32839f ; **FLOATING
C6648 a_3449_16422# VSS 0.18629f ; **FLOATING
C6649 a_2873_16422# VSS 0.18349f ; **FLOATING
C6650 a_2297_16422# VSS 0.18359f ; **FLOATING
C6651 a_1721_16422# VSS 0.17252f ; **FLOATING
C6652 a_1544_16071# VSS 0.29907f ; **FLOATING
C6653 a_1256_16071# VSS 0.86055f ; **FLOATING
C6654 a_27671_16869# VSS 0.01336f ; **FLOATING
C6655 a_26911_16869# VSS 0.01336f ; **FLOATING
C6656 a_26151_16869# VSS 0.01336f ; **FLOATING
C6657 a_25391_16869# VSS 0.01336f ; **FLOATING
C6658 a_24631_16869# VSS 0.01336f ; **FLOATING
C6659 a_23871_16869# VSS 0.01336f ; **FLOATING
C6660 a_23111_16869# VSS 0.01733f ; **FLOATING
C6661 a_22351_16869# VSS 0.01336f ; **FLOATING
C6662 a_21591_16869# VSS 0.01336f ; **FLOATING
C6663 a_20831_16869# VSS 0.01336f ; **FLOATING
C6664 a_20071_16869# VSS 0.01336f ; **FLOATING
C6665 a_19311_16869# VSS 0.01336f ; **FLOATING
C6666 a_18551_16869# VSS 0.01336f ; **FLOATING
C6667 a_17791_16869# VSS 0.01336f ; **FLOATING
C6668 a_17031_16869# VSS 0.01336f ; **FLOATING
C6669 a_16271_16869# VSS 0.01336f ; **FLOATING
C6670 a_15511_16869# VSS 0.01336f ; **FLOATING
C6671 a_14751_16869# VSS 0.01336f ; **FLOATING
C6672 a_13991_16869# VSS 0.01336f ; **FLOATING
C6673 a_13231_16869# VSS 0.01733f ; **FLOATING
C6674 a_12471_16869# VSS 0.01336f ; **FLOATING
C6675 a_11711_16869# VSS 0.01336f ; **FLOATING
C6676 a_10951_16869# VSS 0.01336f ; **FLOATING
C6677 a_10191_16869# VSS 0.01336f ; **FLOATING
C6678 a_9431_16869# VSS 0.01336f ; **FLOATING
C6679 a_8671_16869# VSS 0.01336f ; **FLOATING
C6680 a_7911_16869# VSS 0.01336f ; **FLOATING
C6681 a_7151_16869# VSS 0.01336f ; **FLOATING
C6682 a_6391_16869# VSS 0.01336f ; **FLOATING
C6683 a_5631_16869# VSS 0.01336f ; **FLOATING
C6684 a_4871_16869# VSS 0.01336f ; **FLOATING
C6685 a_4111_16869# VSS 0.0139f ; **FLOATING
C6686 a_27563_16869# VSS 0.51284f ; **FLOATING
C6687 a_27997_16869# VSS 0.6533f ; **FLOATING
C6688 a_27433_16869# VSS 0.45843f ; **FLOATING
C6689 a_26803_16869# VSS 0.50902f ; **FLOATING
C6690 a_27237_16869# VSS 0.93566f ; **FLOATING
C6691 a_26673_16869# VSS 0.45994f ; **FLOATING
C6692 a_26043_16869# VSS 0.51137f ; **FLOATING
C6693 a_26477_16869# VSS 0.9654f ; **FLOATING
C6694 a_25913_16869# VSS 0.46292f ; **FLOATING
C6695 a_25283_16869# VSS 0.50906f ; **FLOATING
C6696 a_25717_16869# VSS 0.87587f ; **FLOATING
C6697 a_25153_16869# VSS 0.45999f ; **FLOATING
C6698 a_24523_16869# VSS 0.51046f ; **FLOATING
C6699 a_24957_16869# VSS 0.97127f ; **FLOATING
C6700 a_24393_16869# VSS 0.45852f ; **FLOATING
C6701 a_23763_16869# VSS 0.50919f ; **FLOATING
C6702 a_24197_16869# VSS 0.93266f ; **FLOATING
C6703 a_23633_16869# VSS 0.46352f ; **FLOATING
C6704 a_23003_16869# VSS 0.96973f ; **FLOATING
C6705 a_23437_16869# VSS 1.07697f ; **FLOATING
C6706 a_22873_16869# VSS 0.58286f ; **FLOATING
C6707 a_22243_16869# VSS 0.47384f ; **FLOATING
C6708 a_22677_16869# VSS 0.88959f ; **FLOATING
C6709 a_22113_16869# VSS 0.45933f ; **FLOATING
C6710 a_21483_16869# VSS 0.51049f ; **FLOATING
C6711 a_21917_16869# VSS 0.96895f ; **FLOATING
C6712 a_21353_16869# VSS 0.45845f ; **FLOATING
C6713 a_20723_16869# VSS 0.50902f ; **FLOATING
C6714 a_21157_16869# VSS 0.93209f ; **FLOATING
C6715 a_20593_16869# VSS 0.45994f ; **FLOATING
C6716 a_19963_16869# VSS 0.51137f ; **FLOATING
C6717 a_20397_16869# VSS 0.9654f ; **FLOATING
C6718 a_19833_16869# VSS 0.46292f ; **FLOATING
C6719 a_19203_16869# VSS 0.50906f ; **FLOATING
C6720 a_19637_16869# VSS 0.87587f ; **FLOATING
C6721 a_19073_16869# VSS 0.45997f ; **FLOATING
C6722 a_18443_16869# VSS 0.51043f ; **FLOATING
C6723 a_18877_16869# VSS 0.97121f ; **FLOATING
C6724 a_18313_16869# VSS 0.45843f ; **FLOATING
C6725 a_17683_16869# VSS 0.50902f ; **FLOATING
C6726 a_18117_16869# VSS 0.93209f ; **FLOATING
C6727 a_17553_16869# VSS 0.45994f ; **FLOATING
C6728 a_16923_16869# VSS 0.51133f ; **FLOATING
C6729 a_17357_16869# VSS 0.9654f ; **FLOATING
C6730 a_16793_16869# VSS 0.46262f ; **FLOATING
C6731 a_16163_16869# VSS 0.50902f ; **FLOATING
C6732 a_16597_16869# VSS 0.87073f ; **FLOATING
C6733 a_16033_16869# VSS 0.45859f ; **FLOATING
C6734 a_15403_16869# VSS 0.51041f ; **FLOATING
C6735 a_15837_16869# VSS 0.9618f ; **FLOATING
C6736 a_15273_16869# VSS 0.45843f ; **FLOATING
C6737 a_14643_16869# VSS 0.50905f ; **FLOATING
C6738 a_15077_16869# VSS 0.93033f ; **FLOATING
C6739 a_14513_16869# VSS 0.46001f ; **FLOATING
C6740 a_13883_16869# VSS 0.51149f ; **FLOATING
C6741 a_14317_16869# VSS 0.96561f ; **FLOATING
C6742 a_13753_16869# VSS 0.4641f ; **FLOATING
C6743 a_13123_16869# VSS 0.95265f ; **FLOATING
C6744 a_13557_16869# VSS 0.94065f ; **FLOATING
C6745 a_12993_16869# VSS 0.57583f ; **FLOATING
C6746 a_12363_16869# VSS 0.47043f ; **FLOATING
C6747 a_12797_16869# VSS 1.128f ; **FLOATING
C6748 a_12233_16869# VSS 0.44863f ; **FLOATING
C6749 a_11603_16869# VSS 0.50908f ; **FLOATING
C6750 a_12037_16869# VSS 0.93221f ; **FLOATING
C6751 a_11473_16869# VSS 0.45996f ; **FLOATING
C6752 a_10843_16869# VSS 0.51137f ; **FLOATING
C6753 a_11277_16869# VSS 0.9654f ; **FLOATING
C6754 a_10713_16869# VSS 0.46292f ; **FLOATING
C6755 a_10083_16869# VSS 0.50904f ; **FLOATING
C6756 a_10517_16869# VSS 0.87587f ; **FLOATING
C6757 a_9953_16869# VSS 0.45997f ; **FLOATING
C6758 a_9323_16869# VSS 0.51043f ; **FLOATING
C6759 a_9757_16869# VSS 0.96954f ; **FLOATING
C6760 a_9193_16869# VSS 0.45843f ; **FLOATING
C6761 a_8563_16869# VSS 0.50902f ; **FLOATING
C6762 a_8997_16869# VSS 0.93209f ; **FLOATING
C6763 a_8433_16869# VSS 0.45994f ; **FLOATING
C6764 a_7803_16869# VSS 0.51137f ; **FLOATING
C6765 a_8237_16869# VSS 0.9654f ; **FLOATING
C6766 a_7673_16869# VSS 0.46292f ; **FLOATING
C6767 a_7043_16869# VSS 0.50904f ; **FLOATING
C6768 a_7477_16869# VSS 0.87587f ; **FLOATING
C6769 a_6913_16869# VSS 0.45997f ; **FLOATING
C6770 a_6283_16869# VSS 0.51043f ; **FLOATING
C6771 a_6717_16869# VSS 0.96895f ; **FLOATING
C6772 a_6153_16869# VSS 0.45843f ; **FLOATING
C6773 a_5523_16869# VSS 0.50902f ; **FLOATING
C6774 a_5957_16869# VSS 0.93209f ; **FLOATING
C6775 a_5393_16869# VSS 0.45994f ; **FLOATING
C6776 a_4763_16869# VSS 0.51133f ; **FLOATING
C6777 a_5197_16869# VSS 0.9654f ; **FLOATING
C6778 a_4633_16869# VSS 0.4629f ; **FLOATING
C6779 a_4003_16869# VSS 0.58899f ; **FLOATING
C6780 a_4437_16869# VSS 0.87486f ; **FLOATING
C6781 a_4187_2434# VSS 18.3371f ; **FLOATING
C6782 a_4187_1764.t98 VSS 69.5843f ; **FLOATING
C6783 a_4187_1764.t163 VSS 0.05831f ; **FLOATING
C6784 a_4187_1764.t162 VSS 0.0566f ; **FLOATING
C6785 a_4187_1764.n0 VSS 0.13395f ; **FLOATING
C6786 a_4187_1764.t161 VSS 0.0566f ; **FLOATING
C6787 a_4187_1764.n1 VSS 0.09291f ; **FLOATING
C6788 a_4187_1764.t160 VSS 0.0566f ; **FLOATING
C6789 a_4187_1764.n2 VSS 0.09291f ; **FLOATING
C6790 a_4187_1764.t159 VSS 0.0566f ; **FLOATING
C6791 a_4187_1764.n3 VSS 0.09291f ; **FLOATING
C6792 a_4187_1764.t158 VSS 0.0566f ; **FLOATING
C6793 a_4187_1764.n4 VSS 0.09291f ; **FLOATING
C6794 a_4187_1764.t157 VSS 0.0566f ; **FLOATING
C6795 a_4187_1764.n5 VSS 0.09291f ; **FLOATING
C6796 a_4187_1764.t156 VSS 0.0566f ; **FLOATING
C6797 a_4187_1764.n6 VSS 0.09291f ; **FLOATING
C6798 a_4187_1764.t155 VSS 0.0566f ; **FLOATING
C6799 a_4187_1764.n7 VSS 0.09291f ; **FLOATING
C6800 a_4187_1764.t154 VSS 0.0566f ; **FLOATING
C6801 a_4187_1764.n8 VSS 0.09291f ; **FLOATING
C6802 a_4187_1764.t153 VSS 0.0566f ; **FLOATING
C6803 a_4187_1764.n9 VSS 0.09291f ; **FLOATING
C6804 a_4187_1764.t152 VSS 0.0566f ; **FLOATING
C6805 a_4187_1764.n10 VSS 0.09291f ; **FLOATING
C6806 a_4187_1764.t151 VSS 0.0566f ; **FLOATING
C6807 a_4187_1764.n11 VSS 0.09291f ; **FLOATING
C6808 a_4187_1764.t150 VSS 0.0566f ; **FLOATING
C6809 a_4187_1764.n12 VSS 0.09291f ; **FLOATING
C6810 a_4187_1764.t149 VSS 0.0566f ; **FLOATING
C6811 a_4187_1764.n13 VSS 0.09291f ; **FLOATING
C6812 a_4187_1764.t148 VSS 0.0566f ; **FLOATING
C6813 a_4187_1764.n14 VSS 0.09291f ; **FLOATING
C6814 a_4187_1764.t147 VSS 0.0566f ; **FLOATING
C6815 a_4187_1764.n15 VSS 0.09291f ; **FLOATING
C6816 a_4187_1764.t146 VSS 0.0566f ; **FLOATING
C6817 a_4187_1764.n16 VSS 0.09291f ; **FLOATING
C6818 a_4187_1764.t145 VSS 0.0566f ; **FLOATING
C6819 a_4187_1764.n17 VSS 0.09291f ; **FLOATING
C6820 a_4187_1764.t144 VSS 0.0566f ; **FLOATING
C6821 a_4187_1764.n18 VSS 0.09291f ; **FLOATING
C6822 a_4187_1764.t143 VSS 0.0566f ; **FLOATING
C6823 a_4187_1764.n19 VSS 0.09291f ; **FLOATING
C6824 a_4187_1764.t142 VSS 0.0566f ; **FLOATING
C6825 a_4187_1764.n20 VSS 0.09291f ; **FLOATING
C6826 a_4187_1764.t141 VSS 0.0566f ; **FLOATING
C6827 a_4187_1764.n21 VSS 0.09291f ; **FLOATING
C6828 a_4187_1764.t140 VSS 0.0566f ; **FLOATING
C6829 a_4187_1764.n22 VSS 0.09291f ; **FLOATING
C6830 a_4187_1764.t139 VSS 0.0566f ; **FLOATING
C6831 a_4187_1764.n23 VSS 0.09291f ; **FLOATING
C6832 a_4187_1764.t138 VSS 0.0566f ; **FLOATING
C6833 a_4187_1764.n24 VSS 0.09291f ; **FLOATING
C6834 a_4187_1764.t137 VSS 0.0566f ; **FLOATING
C6835 a_4187_1764.n25 VSS 0.09291f ; **FLOATING
C6836 a_4187_1764.t136 VSS 0.0566f ; **FLOATING
C6837 a_4187_1764.n26 VSS 0.09291f ; **FLOATING
C6838 a_4187_1764.t135 VSS 0.0566f ; **FLOATING
C6839 a_4187_1764.n27 VSS 0.09291f ; **FLOATING
C6840 a_4187_1764.t134 VSS 0.0566f ; **FLOATING
C6841 a_4187_1764.n28 VSS 0.09291f ; **FLOATING
C6842 a_4187_1764.t133 VSS 0.0566f ; **FLOATING
C6843 a_4187_1764.n29 VSS 0.09291f ; **FLOATING
C6844 a_4187_1764.t132 VSS 0.0566f ; **FLOATING
C6845 a_4187_1764.n30 VSS 0.22761f ; **FLOATING
C6846 a_4187_1764.t131 VSS 0.05831f ; **FLOATING
C6847 a_4187_1764.t130 VSS 0.0566f ; **FLOATING
C6848 a_4187_1764.n31 VSS 0.13395f ; **FLOATING
C6849 a_4187_1764.t129 VSS 0.0566f ; **FLOATING
C6850 a_4187_1764.n32 VSS 0.09291f ; **FLOATING
C6851 a_4187_1764.t128 VSS 0.0566f ; **FLOATING
C6852 a_4187_1764.n33 VSS 0.09291f ; **FLOATING
C6853 a_4187_1764.t127 VSS 0.0566f ; **FLOATING
C6854 a_4187_1764.n34 VSS 0.09291f ; **FLOATING
C6855 a_4187_1764.t126 VSS 0.0566f ; **FLOATING
C6856 a_4187_1764.n35 VSS 0.09291f ; **FLOATING
C6857 a_4187_1764.t125 VSS 0.0566f ; **FLOATING
C6858 a_4187_1764.n36 VSS 0.09291f ; **FLOATING
C6859 a_4187_1764.t124 VSS 0.0566f ; **FLOATING
C6860 a_4187_1764.n37 VSS 0.09291f ; **FLOATING
C6861 a_4187_1764.t123 VSS 0.0566f ; **FLOATING
C6862 a_4187_1764.n38 VSS 0.09291f ; **FLOATING
C6863 a_4187_1764.t122 VSS 0.0566f ; **FLOATING
C6864 a_4187_1764.n39 VSS 0.09291f ; **FLOATING
C6865 a_4187_1764.t121 VSS 0.0566f ; **FLOATING
C6866 a_4187_1764.n40 VSS 0.09291f ; **FLOATING
C6867 a_4187_1764.t120 VSS 0.0566f ; **FLOATING
C6868 a_4187_1764.n41 VSS 0.09291f ; **FLOATING
C6869 a_4187_1764.t119 VSS 0.0566f ; **FLOATING
C6870 a_4187_1764.n42 VSS 0.09291f ; **FLOATING
C6871 a_4187_1764.t118 VSS 0.0566f ; **FLOATING
C6872 a_4187_1764.n43 VSS 0.09291f ; **FLOATING
C6873 a_4187_1764.t117 VSS 0.0566f ; **FLOATING
C6874 a_4187_1764.n44 VSS 0.09291f ; **FLOATING
C6875 a_4187_1764.t116 VSS 0.0566f ; **FLOATING
C6876 a_4187_1764.n45 VSS 0.09291f ; **FLOATING
C6877 a_4187_1764.t115 VSS 0.0566f ; **FLOATING
C6878 a_4187_1764.n46 VSS 0.09291f ; **FLOATING
C6879 a_4187_1764.t114 VSS 0.0566f ; **FLOATING
C6880 a_4187_1764.n47 VSS 0.09291f ; **FLOATING
C6881 a_4187_1764.t113 VSS 0.0566f ; **FLOATING
C6882 a_4187_1764.n48 VSS 0.09291f ; **FLOATING
C6883 a_4187_1764.t112 VSS 0.0566f ; **FLOATING
C6884 a_4187_1764.n49 VSS 0.09291f ; **FLOATING
C6885 a_4187_1764.t111 VSS 0.0566f ; **FLOATING
C6886 a_4187_1764.n50 VSS 0.09291f ; **FLOATING
C6887 a_4187_1764.t110 VSS 0.0566f ; **FLOATING
C6888 a_4187_1764.n51 VSS 0.09291f ; **FLOATING
C6889 a_4187_1764.t109 VSS 0.0566f ; **FLOATING
C6890 a_4187_1764.n52 VSS 0.09291f ; **FLOATING
C6891 a_4187_1764.t108 VSS 0.0566f ; **FLOATING
C6892 a_4187_1764.n53 VSS 0.09291f ; **FLOATING
C6893 a_4187_1764.t107 VSS 0.0566f ; **FLOATING
C6894 a_4187_1764.n54 VSS 0.09291f ; **FLOATING
C6895 a_4187_1764.t106 VSS 0.0566f ; **FLOATING
C6896 a_4187_1764.n55 VSS 0.09291f ; **FLOATING
C6897 a_4187_1764.t105 VSS 0.0566f ; **FLOATING
C6898 a_4187_1764.n56 VSS 0.09291f ; **FLOATING
C6899 a_4187_1764.t104 VSS 0.0566f ; **FLOATING
C6900 a_4187_1764.n57 VSS 0.09291f ; **FLOATING
C6901 a_4187_1764.t103 VSS 0.0566f ; **FLOATING
C6902 a_4187_1764.n58 VSS 0.09291f ; **FLOATING
C6903 a_4187_1764.t102 VSS 0.0566f ; **FLOATING
C6904 a_4187_1764.n59 VSS 0.09291f ; **FLOATING
C6905 a_4187_1764.t101 VSS 0.0566f ; **FLOATING
C6906 a_4187_1764.n60 VSS 0.09291f ; **FLOATING
C6907 a_4187_1764.t100 VSS 0.0566f ; **FLOATING
C6908 a_4187_1764.n61 VSS 0.13955f ; **FLOATING
C6909 a_4187_1764.n62 VSS 0.60639f ; **FLOATING
C6910 a_4187_1764.t33 VSS 0.05831f ; **FLOATING
C6911 a_4187_1764.t32 VSS 0.0566f ; **FLOATING
C6912 a_4187_1764.n63 VSS 0.13395f ; **FLOATING
C6913 a_4187_1764.t31 VSS 0.0566f ; **FLOATING
C6914 a_4187_1764.n64 VSS 0.09291f ; **FLOATING
C6915 a_4187_1764.t30 VSS 0.0566f ; **FLOATING
C6916 a_4187_1764.n65 VSS 0.09291f ; **FLOATING
C6917 a_4187_1764.t29 VSS 0.0566f ; **FLOATING
C6918 a_4187_1764.n66 VSS 0.09291f ; **FLOATING
C6919 a_4187_1764.t28 VSS 0.0566f ; **FLOATING
C6920 a_4187_1764.n67 VSS 0.09291f ; **FLOATING
C6921 a_4187_1764.t27 VSS 0.0566f ; **FLOATING
C6922 a_4187_1764.n68 VSS 0.09291f ; **FLOATING
C6923 a_4187_1764.t26 VSS 0.0566f ; **FLOATING
C6924 a_4187_1764.n69 VSS 0.09291f ; **FLOATING
C6925 a_4187_1764.t25 VSS 0.0566f ; **FLOATING
C6926 a_4187_1764.n70 VSS 0.09291f ; **FLOATING
C6927 a_4187_1764.t24 VSS 0.0566f ; **FLOATING
C6928 a_4187_1764.n71 VSS 0.09291f ; **FLOATING
C6929 a_4187_1764.t23 VSS 0.0566f ; **FLOATING
C6930 a_4187_1764.n72 VSS 0.09291f ; **FLOATING
C6931 a_4187_1764.t22 VSS 0.0566f ; **FLOATING
C6932 a_4187_1764.n73 VSS 0.09291f ; **FLOATING
C6933 a_4187_1764.t21 VSS 0.0566f ; **FLOATING
C6934 a_4187_1764.n74 VSS 0.09291f ; **FLOATING
C6935 a_4187_1764.t20 VSS 0.0566f ; **FLOATING
C6936 a_4187_1764.n75 VSS 0.09291f ; **FLOATING
C6937 a_4187_1764.t19 VSS 0.0566f ; **FLOATING
C6938 a_4187_1764.n76 VSS 0.09291f ; **FLOATING
C6939 a_4187_1764.t18 VSS 0.0566f ; **FLOATING
C6940 a_4187_1764.n77 VSS 0.09291f ; **FLOATING
C6941 a_4187_1764.t17 VSS 0.0566f ; **FLOATING
C6942 a_4187_1764.n78 VSS 0.09291f ; **FLOATING
C6943 a_4187_1764.t16 VSS 0.0566f ; **FLOATING
C6944 a_4187_1764.n79 VSS 0.09291f ; **FLOATING
C6945 a_4187_1764.t15 VSS 0.0566f ; **FLOATING
C6946 a_4187_1764.n80 VSS 0.09291f ; **FLOATING
C6947 a_4187_1764.t14 VSS 0.0566f ; **FLOATING
C6948 a_4187_1764.n81 VSS 0.09291f ; **FLOATING
C6949 a_4187_1764.t13 VSS 0.0566f ; **FLOATING
C6950 a_4187_1764.n82 VSS 0.09291f ; **FLOATING
C6951 a_4187_1764.t12 VSS 0.0566f ; **FLOATING
C6952 a_4187_1764.n83 VSS 0.09291f ; **FLOATING
C6953 a_4187_1764.t11 VSS 0.0566f ; **FLOATING
C6954 a_4187_1764.n84 VSS 0.09291f ; **FLOATING
C6955 a_4187_1764.t10 VSS 0.0566f ; **FLOATING
C6956 a_4187_1764.n85 VSS 0.09291f ; **FLOATING
C6957 a_4187_1764.t9 VSS 0.0566f ; **FLOATING
C6958 a_4187_1764.n86 VSS 0.09291f ; **FLOATING
C6959 a_4187_1764.t8 VSS 0.0566f ; **FLOATING
C6960 a_4187_1764.n87 VSS 0.09291f ; **FLOATING
C6961 a_4187_1764.t7 VSS 0.0566f ; **FLOATING
C6962 a_4187_1764.n88 VSS 0.09291f ; **FLOATING
C6963 a_4187_1764.t6 VSS 0.0566f ; **FLOATING
C6964 a_4187_1764.n89 VSS 0.09291f ; **FLOATING
C6965 a_4187_1764.t5 VSS 0.0566f ; **FLOATING
C6966 a_4187_1764.n90 VSS 0.09291f ; **FLOATING
C6967 a_4187_1764.t4 VSS 0.0566f ; **FLOATING
C6968 a_4187_1764.n91 VSS 0.09291f ; **FLOATING
C6969 a_4187_1764.t3 VSS 0.0566f ; **FLOATING
C6970 a_4187_1764.n92 VSS 0.09291f ; **FLOATING
C6971 a_4187_1764.t2 VSS 0.0566f ; **FLOATING
C6972 a_4187_1764.n93 VSS 0.25093f ; **FLOATING
C6973 a_4187_1764.t65 VSS 0.05831f ; **FLOATING
C6974 a_4187_1764.t64 VSS 0.0566f ; **FLOATING
C6975 a_4187_1764.n94 VSS 0.13395f ; **FLOATING
C6976 a_4187_1764.t63 VSS 0.0566f ; **FLOATING
C6977 a_4187_1764.n95 VSS 0.09291f ; **FLOATING
C6978 a_4187_1764.t62 VSS 0.0566f ; **FLOATING
C6979 a_4187_1764.n96 VSS 0.09291f ; **FLOATING
C6980 a_4187_1764.t61 VSS 0.0566f ; **FLOATING
C6981 a_4187_1764.n97 VSS 0.09291f ; **FLOATING
C6982 a_4187_1764.t60 VSS 0.0566f ; **FLOATING
C6983 a_4187_1764.n98 VSS 0.09291f ; **FLOATING
C6984 a_4187_1764.t59 VSS 0.0566f ; **FLOATING
C6985 a_4187_1764.n99 VSS 0.09291f ; **FLOATING
C6986 a_4187_1764.t58 VSS 0.0566f ; **FLOATING
C6987 a_4187_1764.n100 VSS 0.09291f ; **FLOATING
C6988 a_4187_1764.t57 VSS 0.0566f ; **FLOATING
C6989 a_4187_1764.n101 VSS 0.09291f ; **FLOATING
C6990 a_4187_1764.t56 VSS 0.0566f ; **FLOATING
C6991 a_4187_1764.n102 VSS 0.09291f ; **FLOATING
C6992 a_4187_1764.t55 VSS 0.0566f ; **FLOATING
C6993 a_4187_1764.n103 VSS 0.09291f ; **FLOATING
C6994 a_4187_1764.t54 VSS 0.0566f ; **FLOATING
C6995 a_4187_1764.n104 VSS 0.09291f ; **FLOATING
C6996 a_4187_1764.t53 VSS 0.0566f ; **FLOATING
C6997 a_4187_1764.n105 VSS 0.09291f ; **FLOATING
C6998 a_4187_1764.t52 VSS 0.0566f ; **FLOATING
C6999 a_4187_1764.n106 VSS 0.09291f ; **FLOATING
C7000 a_4187_1764.t51 VSS 0.0566f ; **FLOATING
C7001 a_4187_1764.n107 VSS 0.09291f ; **FLOATING
C7002 a_4187_1764.t50 VSS 0.0566f ; **FLOATING
C7003 a_4187_1764.n108 VSS 0.09291f ; **FLOATING
C7004 a_4187_1764.t49 VSS 0.0566f ; **FLOATING
C7005 a_4187_1764.n109 VSS 0.09291f ; **FLOATING
C7006 a_4187_1764.t48 VSS 0.0566f ; **FLOATING
C7007 a_4187_1764.n110 VSS 0.09291f ; **FLOATING
C7008 a_4187_1764.t47 VSS 0.0566f ; **FLOATING
C7009 a_4187_1764.n111 VSS 0.09291f ; **FLOATING
C7010 a_4187_1764.t46 VSS 0.0566f ; **FLOATING
C7011 a_4187_1764.n112 VSS 0.09291f ; **FLOATING
C7012 a_4187_1764.t45 VSS 0.0566f ; **FLOATING
C7013 a_4187_1764.n113 VSS 0.09291f ; **FLOATING
C7014 a_4187_1764.t44 VSS 0.0566f ; **FLOATING
C7015 a_4187_1764.n114 VSS 0.09291f ; **FLOATING
C7016 a_4187_1764.t43 VSS 0.0566f ; **FLOATING
C7017 a_4187_1764.n115 VSS 0.09291f ; **FLOATING
C7018 a_4187_1764.t42 VSS 0.0566f ; **FLOATING
C7019 a_4187_1764.n116 VSS 0.09291f ; **FLOATING
C7020 a_4187_1764.t41 VSS 0.0566f ; **FLOATING
C7021 a_4187_1764.n117 VSS 0.09291f ; **FLOATING
C7022 a_4187_1764.t40 VSS 0.0566f ; **FLOATING
C7023 a_4187_1764.n118 VSS 0.09291f ; **FLOATING
C7024 a_4187_1764.t39 VSS 0.0566f ; **FLOATING
C7025 a_4187_1764.n119 VSS 0.09291f ; **FLOATING
C7026 a_4187_1764.t38 VSS 0.0566f ; **FLOATING
C7027 a_4187_1764.n120 VSS 0.09291f ; **FLOATING
C7028 a_4187_1764.t37 VSS 0.0566f ; **FLOATING
C7029 a_4187_1764.n121 VSS 0.09291f ; **FLOATING
C7030 a_4187_1764.t36 VSS 0.0566f ; **FLOATING
C7031 a_4187_1764.n122 VSS 0.09291f ; **FLOATING
C7032 a_4187_1764.t35 VSS 0.0566f ; **FLOATING
C7033 a_4187_1764.n123 VSS 0.09291f ; **FLOATING
C7034 a_4187_1764.t34 VSS 0.0566f ; **FLOATING
C7035 a_4187_1764.n124 VSS 0.13955f ; **FLOATING
C7036 a_4187_1764.n125 VSS 0.62764f ; **FLOATING
C7037 a_4187_1764.t97 VSS 0.05831f ; **FLOATING
C7038 a_4187_1764.t96 VSS 0.0566f ; **FLOATING
C7039 a_4187_1764.n126 VSS 0.13395f ; **FLOATING
C7040 a_4187_1764.t95 VSS 0.0566f ; **FLOATING
C7041 a_4187_1764.n127 VSS 0.09291f ; **FLOATING
C7042 a_4187_1764.t94 VSS 0.0566f ; **FLOATING
C7043 a_4187_1764.n128 VSS 0.09291f ; **FLOATING
C7044 a_4187_1764.t93 VSS 0.0566f ; **FLOATING
C7045 a_4187_1764.n129 VSS 0.09291f ; **FLOATING
C7046 a_4187_1764.t92 VSS 0.0566f ; **FLOATING
C7047 a_4187_1764.n130 VSS 0.09291f ; **FLOATING
C7048 a_4187_1764.t91 VSS 0.0566f ; **FLOATING
C7049 a_4187_1764.n131 VSS 0.09291f ; **FLOATING
C7050 a_4187_1764.t90 VSS 0.0566f ; **FLOATING
C7051 a_4187_1764.n132 VSS 0.09291f ; **FLOATING
C7052 a_4187_1764.t89 VSS 0.0566f ; **FLOATING
C7053 a_4187_1764.n133 VSS 0.09291f ; **FLOATING
C7054 a_4187_1764.t88 VSS 0.0566f ; **FLOATING
C7055 a_4187_1764.n134 VSS 0.09291f ; **FLOATING
C7056 a_4187_1764.t87 VSS 0.0566f ; **FLOATING
C7057 a_4187_1764.n135 VSS 0.09291f ; **FLOATING
C7058 a_4187_1764.t86 VSS 0.0566f ; **FLOATING
C7059 a_4187_1764.n136 VSS 0.09291f ; **FLOATING
C7060 a_4187_1764.t85 VSS 0.0566f ; **FLOATING
C7061 a_4187_1764.n137 VSS 0.09291f ; **FLOATING
C7062 a_4187_1764.t84 VSS 0.0566f ; **FLOATING
C7063 a_4187_1764.n138 VSS 0.09291f ; **FLOATING
C7064 a_4187_1764.t83 VSS 0.0566f ; **FLOATING
C7065 a_4187_1764.n139 VSS 0.09291f ; **FLOATING
C7066 a_4187_1764.t82 VSS 0.0566f ; **FLOATING
C7067 a_4187_1764.n140 VSS 0.09291f ; **FLOATING
C7068 a_4187_1764.t81 VSS 0.0566f ; **FLOATING
C7069 a_4187_1764.n141 VSS 0.09291f ; **FLOATING
C7070 a_4187_1764.t80 VSS 0.0566f ; **FLOATING
C7071 a_4187_1764.n142 VSS 0.09291f ; **FLOATING
C7072 a_4187_1764.t79 VSS 0.0566f ; **FLOATING
C7073 a_4187_1764.n143 VSS 0.09291f ; **FLOATING
C7074 a_4187_1764.t78 VSS 0.0566f ; **FLOATING
C7075 a_4187_1764.n144 VSS 0.09291f ; **FLOATING
C7076 a_4187_1764.t77 VSS 0.0566f ; **FLOATING
C7077 a_4187_1764.n145 VSS 0.09291f ; **FLOATING
C7078 a_4187_1764.t76 VSS 0.0566f ; **FLOATING
C7079 a_4187_1764.n146 VSS 0.09291f ; **FLOATING
C7080 a_4187_1764.t75 VSS 0.0566f ; **FLOATING
C7081 a_4187_1764.n147 VSS 0.09291f ; **FLOATING
C7082 a_4187_1764.t74 VSS 0.0566f ; **FLOATING
C7083 a_4187_1764.n148 VSS 0.09291f ; **FLOATING
C7084 a_4187_1764.t73 VSS 0.0566f ; **FLOATING
C7085 a_4187_1764.n149 VSS 0.09291f ; **FLOATING
C7086 a_4187_1764.t72 VSS 0.0566f ; **FLOATING
C7087 a_4187_1764.n150 VSS 0.09291f ; **FLOATING
C7088 a_4187_1764.t71 VSS 0.0566f ; **FLOATING
C7089 a_4187_1764.n151 VSS 0.09291f ; **FLOATING
C7090 a_4187_1764.t70 VSS 0.0566f ; **FLOATING
C7091 a_4187_1764.n152 VSS 0.09291f ; **FLOATING
C7092 a_4187_1764.t69 VSS 0.0566f ; **FLOATING
C7093 a_4187_1764.n153 VSS 0.09291f ; **FLOATING
C7094 a_4187_1764.t68 VSS 0.0566f ; **FLOATING
C7095 a_4187_1764.n154 VSS 0.09291f ; **FLOATING
C7096 a_4187_1764.t67 VSS 0.0566f ; **FLOATING
C7097 a_4187_1764.n155 VSS 0.09291f ; **FLOATING
C7098 a_4187_1764.t66 VSS 0.0566f ; **FLOATING
C7099 a_4187_1764.n156 VSS 0.13955f ; **FLOATING
C7100 a_4187_1764.n157 VSS 0.35793f ; **FLOATING
C7101 a_4187_1764.n158 VSS 0.4796f ; **FLOATING
C7102 a_4187_1764.t99 VSS 0.05228f ; **FLOATING
C7103 a_4187_1764.n159 VSS 0.39749f ; **FLOATING
C7104 a_4187_1764.t1 VSS 0.0132f ; **FLOATING
C7105 a_4187_1764.n160 VSS 0.13499f ; **FLOATING
C7106 a_4187_1764.t0 VSS 0.03578f ; **FLOATING
C7107 a_2019_16074.t2 VSS 0.92496f ; **FLOATING
C7108 a_2019_16074.t3 VSS 0.70221f ; **FLOATING
C7109 a_2019_16074.n0 VSS 4.98028f ; **FLOATING
C7110 a_2019_16074.t4 VSS 0.70221f ; **FLOATING
C7111 a_2019_16074.n1 VSS 3.36929f ; **FLOATING
C7112 a_2019_16074.t5 VSS 0.70221f ; **FLOATING
C7113 a_2019_16074.n2 VSS 3.36929f ; **FLOATING
C7114 a_2019_16074.t6 VSS 0.70221f ; **FLOATING
C7115 a_2019_16074.n3 VSS 3.36929f ; **FLOATING
C7116 a_2019_16074.t7 VSS 0.70221f ; **FLOATING
C7117 a_2019_16074.n4 VSS 3.36929f ; **FLOATING
C7118 a_2019_16074.t8 VSS 0.70221f ; **FLOATING
C7119 a_2019_16074.n5 VSS 3.36929f ; **FLOATING
C7120 a_2019_16074.t9 VSS 5.42375f ; **FLOATING
C7121 a_2019_16074.t1 VSS 1.06646f ; **FLOATING
C7122 a_2019_16074.t0 VSS 0.30312f ; **FLOATING
C7123 a_2595_16074.t2 VSS 1.36713f ; **FLOATING
C7124 a_2595_16074.t3 VSS 1.02102f ; **FLOATING
C7125 a_2595_16074.n0 VSS 7.76181f ; **FLOATING
C7126 a_2595_16074.t4 VSS 1.02102f ; **FLOATING
C7127 a_2595_16074.n1 VSS 5.27379f ; **FLOATING
C7128 a_2595_16074.t5 VSS 1.02102f ; **FLOATING
C7129 a_2595_16074.n2 VSS 5.27379f ; **FLOATING
C7130 a_2595_16074.t6 VSS 1.02102f ; **FLOATING
C7131 a_2595_16074.n3 VSS 5.27379f ; **FLOATING
C7132 a_2595_16074.t7 VSS 1.02102f ; **FLOATING
C7133 a_2595_16074.n4 VSS 5.27379f ; **FLOATING
C7134 a_2595_16074.t8 VSS 1.02102f ; **FLOATING
C7135 a_2595_16074.n5 VSS 5.27379f ; **FLOATING
C7136 a_2595_16074.t9 VSS 1.02102f ; **FLOATING
C7137 a_2595_16074.n6 VSS 7.58603f ; **FLOATING
C7138 a_2595_16074.t1 VSS 1.75132f ; **FLOATING
C7139 a_2595_16074.t0 VSS 0.4823f ; **FLOATING
C7140 a_3171_16074.t2 VSS 1.38467f ; **FLOATING
C7141 a_3171_16074.t3 VSS 1.03752f ; **FLOATING
C7142 a_3171_16074.n0 VSS 7.77995f ; **FLOATING
C7143 a_3171_16074.t4 VSS 1.03752f ; **FLOATING
C7144 a_3171_16074.n1 VSS 5.28177f ; **FLOATING
C7145 a_3171_16074.t5 VSS 1.03752f ; **FLOATING
C7146 a_3171_16074.n2 VSS 5.28177f ; **FLOATING
C7147 a_3171_16074.t6 VSS 1.03752f ; **FLOATING
C7148 a_3171_16074.n3 VSS 5.28177f ; **FLOATING
C7149 a_3171_16074.t7 VSS 1.03752f ; **FLOATING
C7150 a_3171_16074.n4 VSS 5.28177f ; **FLOATING
C7151 a_3171_16074.t8 VSS 1.03752f ; **FLOATING
C7152 a_3171_16074.n5 VSS 5.28177f ; **FLOATING
C7153 a_3171_16074.t9 VSS 1.03752f ; **FLOATING
C7154 a_3171_16074.n6 VSS 7.68484f ; **FLOATING
C7155 a_3171_16074.t1 VSS 1.77058f ; **FLOATING
C7156 a_3171_16074.t0 VSS 0.48093f ; **FLOATING
C7157 a_3747_16074.t2 VSS 0.97174f ; **FLOATING
C7158 a_3747_16074.t3 VSS 0.7398f ; **FLOATING
C7159 a_3747_16074.n0 VSS 5.18288f ; **FLOATING
C7160 a_3747_16074.t4 VSS 0.7398f ; **FLOATING
C7161 a_3747_16074.n1 VSS 3.50356f ; **FLOATING
C7162 a_3747_16074.t5 VSS 0.7398f ; **FLOATING
C7163 a_3747_16074.n2 VSS 3.50356f ; **FLOATING
C7164 a_3747_16074.t6 VSS 0.7398f ; **FLOATING
C7165 a_3747_16074.n3 VSS 3.50356f ; **FLOATING
C7166 a_3747_16074.t7 VSS 0.7398f ; **FLOATING
C7167 a_3747_16074.n4 VSS 3.50356f ; **FLOATING
C7168 a_3747_16074.t8 VSS 0.7398f ; **FLOATING
C7169 a_3747_16074.n5 VSS 3.50356f ; **FLOATING
C7170 a_3747_16074.t9 VSS 0.7398f ; **FLOATING
C7171 a_3747_16074.n6 VSS 5.20237f ; **FLOATING
C7172 a_3747_16074.t1 VSS 1.18889f ; **FLOATING
C7173 a_3747_16074.t0 VSS 0.31431f ; **FLOATING
C7174 a_2019_15338.t2 VSS 4.07073f ; **FLOATING
C7175 a_2019_15338.t3 VSS 21.9073f ; **FLOATING
C7176 a_2019_15338.t1 VSS 1.98996f ; **FLOATING
C7177 a_2019_15338.t0 VSS 0.44681f ; **FLOATING
C7178 a_2595_15338.t1 VSS 3.29754f ; **FLOATING
C7179 a_2595_15338.t2 VSS 5.08334f ; **FLOATING
C7180 a_2595_15338.t3 VSS 1.21634f ; **FLOATING
C7181 a_2595_15338.n0 VSS 27.0901f ; **FLOATING
C7182 a_2595_15338.t0 VSS 0.49984f ; **FLOATING
C7183 a_3171_15338.t2 VSS 5.08045f ; **FLOATING
C7184 a_3171_15338.t3 VSS 1.21878f ; **FLOATING
C7185 a_3171_15338.n0 VSS 30.0294f ; **FLOATING
C7186 a_3171_15338.t1 VSS 4.63926f ; **FLOATING
C7187 a_3171_15338.t0 VSS 0.50029f ; **FLOATING
C7188 a_3747_15338.t2 VSS 3.14577f ; **FLOATING
C7189 a_3747_15338.t3 VSS 0.75716f ; **FLOATING
C7190 a_3747_15338.n0 VSS 20.2342f ; **FLOATING
C7191 a_3747_15338.t1 VSS 3.75304f ; **FLOATING
C7192 a_3747_15338.t0 VSS 0.31068f ; **FLOATING
C7193 a_2019_13229.t2 VSS 0.92505f ; **FLOATING
C7194 a_2019_13229.t3 VSS 0.70227f ; **FLOATING
C7195 a_2019_13229.n0 VSS 4.98075f ; **FLOATING
C7196 a_2019_13229.t4 VSS 0.70227f ; **FLOATING
C7197 a_2019_13229.n1 VSS 3.36962f ; **FLOATING
C7198 a_2019_13229.t5 VSS 0.70227f ; **FLOATING
C7199 a_2019_13229.n2 VSS 3.36962f ; **FLOATING
C7200 a_2019_13229.t6 VSS 0.70227f ; **FLOATING
C7201 a_2019_13229.n3 VSS 3.36962f ; **FLOATING
C7202 a_2019_13229.t7 VSS 0.70227f ; **FLOATING
C7203 a_2019_13229.n4 VSS 3.36962f ; **FLOATING
C7204 a_2019_13229.t8 VSS 0.70227f ; **FLOATING
C7205 a_2019_13229.n5 VSS 3.36962f ; **FLOATING
C7206 a_2019_13229.t9 VSS 5.42427f ; **FLOATING
C7207 a_2019_13229.t1 VSS 1.06656f ; **FLOATING
C7208 a_2019_13229.t0 VSS 0.30315f ; **FLOATING
C7209 a_2595_13229.t2 VSS 1.36714f ; **FLOATING
C7210 a_2595_13229.t3 VSS 1.02102f ; **FLOATING
C7211 a_2595_13229.n0 VSS 7.76187f ; **FLOATING
C7212 a_2595_13229.t4 VSS 1.02102f ; **FLOATING
C7213 a_2595_13229.n1 VSS 5.27383f ; **FLOATING
C7214 a_2595_13229.t5 VSS 1.02102f ; **FLOATING
C7215 a_2595_13229.n2 VSS 5.27383f ; **FLOATING
C7216 a_2595_13229.t6 VSS 1.02102f ; **FLOATING
C7217 a_2595_13229.n3 VSS 5.27383f ; **FLOATING
C7218 a_2595_13229.t7 VSS 1.02102f ; **FLOATING
C7219 a_2595_13229.n4 VSS 5.27383f ; **FLOATING
C7220 a_2595_13229.t8 VSS 1.02102f ; **FLOATING
C7221 a_2595_13229.n5 VSS 5.27383f ; **FLOATING
C7222 a_2595_13229.t9 VSS 1.02102f ; **FLOATING
C7223 a_2595_13229.n6 VSS 7.58609f ; **FLOATING
C7224 a_2595_13229.t1 VSS 1.75133f ; **FLOATING
C7225 a_2595_13229.t0 VSS 0.48231f ; **FLOATING
C7226 a_3171_13229.t2 VSS 1.38481f ; **FLOATING
C7227 a_3171_13229.t3 VSS 1.03763f ; **FLOATING
C7228 a_3171_13229.n0 VSS 7.78073f ; **FLOATING
C7229 a_3171_13229.t4 VSS 1.03763f ; **FLOATING
C7230 a_3171_13229.n1 VSS 5.2823f ; **FLOATING
C7231 a_3171_13229.t5 VSS 1.03763f ; **FLOATING
C7232 a_3171_13229.n2 VSS 5.2823f ; **FLOATING
C7233 a_3171_13229.t6 VSS 1.03763f ; **FLOATING
C7234 a_3171_13229.n3 VSS 5.2823f ; **FLOATING
C7235 a_3171_13229.t7 VSS 1.03763f ; **FLOATING
C7236 a_3171_13229.n4 VSS 5.2823f ; **FLOATING
C7237 a_3171_13229.t8 VSS 1.03763f ; **FLOATING
C7238 a_3171_13229.n5 VSS 5.2823f ; **FLOATING
C7239 a_3171_13229.t9 VSS 1.03763f ; **FLOATING
C7240 a_3171_13229.n6 VSS 7.68561f ; **FLOATING
C7241 a_3171_13229.t1 VSS 1.77076f ; **FLOATING
C7242 a_3171_13229.t0 VSS 0.48098f ; **FLOATING
C7243 a_3747_13229.t2 VSS 0.97097f ; **FLOATING
C7244 a_3747_13229.t3 VSS 0.73922f ; **FLOATING
C7245 a_3747_13229.n0 VSS 5.17878f ; **FLOATING
C7246 a_3747_13229.t4 VSS 0.73922f ; **FLOATING
C7247 a_3747_13229.n1 VSS 3.50079f ; **FLOATING
C7248 a_3747_13229.t5 VSS 0.73922f ; **FLOATING
C7249 a_3747_13229.n2 VSS 3.50079f ; **FLOATING
C7250 a_3747_13229.t6 VSS 0.73922f ; **FLOATING
C7251 a_3747_13229.n3 VSS 3.50079f ; **FLOATING
C7252 a_3747_13229.t7 VSS 0.73922f ; **FLOATING
C7253 a_3747_13229.n4 VSS 3.50079f ; **FLOATING
C7254 a_3747_13229.t8 VSS 0.73922f ; **FLOATING
C7255 a_3747_13229.n5 VSS 3.50079f ; **FLOATING
C7256 a_3747_13229.t9 VSS 0.73922f ; **FLOATING
C7257 a_3747_13229.n6 VSS 5.19826f ; **FLOATING
C7258 a_3747_13229.t1 VSS 1.18795f ; **FLOATING
C7259 a_3747_13229.t0 VSS 0.31406f ; **FLOATING
C7260 a_2019_12493.t2 VSS 4.06273f ; **FLOATING
C7261 a_2019_12493.t3 VSS 21.8643f ; **FLOATING
C7262 a_2019_12493.t1 VSS 1.98604f ; **FLOATING
C7263 a_2019_12493.t0 VSS 0.44594f ; **FLOATING
C7264 a_2595_12493.t1 VSS 3.28559f ; **FLOATING
C7265 a_2595_12493.t2 VSS 5.06492f ; **FLOATING
C7266 a_2595_12493.t3 VSS 1.21193f ; **FLOATING
C7267 a_2595_12493.n0 VSS 26.9919f ; **FLOATING
C7268 a_2595_12493.t0 VSS 0.49803f ; **FLOATING
C7269 a_3171_12493.t2 VSS 5.06481f ; **FLOATING
C7270 a_3171_12493.t3 VSS 1.21502f ; **FLOATING
C7271 a_3171_12493.n0 VSS 29.9369f ; **FLOATING
C7272 a_3171_12493.t1 VSS 4.62497f ; **FLOATING
C7273 a_3171_12493.t0 VSS 0.49875f ; **FLOATING
C7274 a_3747_12493.t2 VSS 3.13063f ; **FLOATING
C7275 a_3747_12493.t3 VSS 0.75351f ; **FLOATING
C7276 a_3747_12493.n0 VSS 20.1368f ; **FLOATING
C7277 a_3747_12493.t1 VSS 3.73498f ; **FLOATING
C7278 a_3747_12493.t0 VSS 0.30918f ; **FLOATING
C7279 a_2019_6737.t2 VSS 0.92506f ; **FLOATING
C7280 a_2019_6737.t3 VSS 0.70228f ; **FLOATING
C7281 a_2019_6737.n0 VSS 4.98081f ; **FLOATING
C7282 a_2019_6737.t4 VSS 0.70228f ; **FLOATING
C7283 a_2019_6737.n1 VSS 3.36966f ; **FLOATING
C7284 a_2019_6737.t5 VSS 0.70228f ; **FLOATING
C7285 a_2019_6737.n2 VSS 3.36966f ; **FLOATING
C7286 a_2019_6737.t6 VSS 0.70228f ; **FLOATING
C7287 a_2019_6737.n3 VSS 3.36966f ; **FLOATING
C7288 a_2019_6737.t7 VSS 0.70228f ; **FLOATING
C7289 a_2019_6737.n4 VSS 3.36966f ; **FLOATING
C7290 a_2019_6737.t8 VSS 0.70228f ; **FLOATING
C7291 a_2019_6737.n5 VSS 3.36966f ; **FLOATING
C7292 a_2019_6737.t9 VSS 5.42433f ; **FLOATING
C7293 a_2019_6737.t1 VSS 1.06657f ; **FLOATING
C7294 a_2019_6737.t0 VSS 0.30315f ; **FLOATING
C7295 a_2595_6737.t2 VSS 1.36713f ; **FLOATING
C7296 a_2595_6737.t3 VSS 1.02102f ; **FLOATING
C7297 a_2595_6737.n0 VSS 7.76184f ; **FLOATING
C7298 a_2595_6737.t4 VSS 1.02102f ; **FLOATING
C7299 a_2595_6737.n1 VSS 5.27381f ; **FLOATING
C7300 a_2595_6737.t5 VSS 1.02102f ; **FLOATING
C7301 a_2595_6737.n2 VSS 5.27381f ; **FLOATING
C7302 a_2595_6737.t6 VSS 1.02102f ; **FLOATING
C7303 a_2595_6737.n3 VSS 5.27381f ; **FLOATING
C7304 a_2595_6737.t7 VSS 1.02102f ; **FLOATING
C7305 a_2595_6737.n4 VSS 5.27381f ; **FLOATING
C7306 a_2595_6737.t8 VSS 1.02102f ; **FLOATING
C7307 a_2595_6737.n5 VSS 5.27381f ; **FLOATING
C7308 a_2595_6737.t9 VSS 1.02102f ; **FLOATING
C7309 a_2595_6737.n6 VSS 7.58606f ; **FLOATING
C7310 a_2595_6737.t1 VSS 1.75133f ; **FLOATING
C7311 a_2595_6737.t0 VSS 0.48231f ; **FLOATING
C7312 a_3171_6737.t2 VSS 1.38468f ; **FLOATING
C7313 a_3171_6737.t3 VSS 1.03753f ; **FLOATING
C7314 a_3171_6737.n0 VSS 7.78001f ; **FLOATING
C7315 a_3171_6737.t4 VSS 1.03753f ; **FLOATING
C7316 a_3171_6737.n1 VSS 5.28181f ; **FLOATING
C7317 a_3171_6737.t5 VSS 1.03753f ; **FLOATING
C7318 a_3171_6737.n2 VSS 5.28181f ; **FLOATING
C7319 a_3171_6737.t6 VSS 1.03753f ; **FLOATING
C7320 a_3171_6737.n3 VSS 5.28181f ; **FLOATING
C7321 a_3171_6737.t7 VSS 1.03753f ; **FLOATING
C7322 a_3171_6737.n4 VSS 5.28181f ; **FLOATING
C7323 a_3171_6737.t8 VSS 1.03753f ; **FLOATING
C7324 a_3171_6737.n5 VSS 5.28181f ; **FLOATING
C7325 a_3171_6737.t9 VSS 1.03753f ; **FLOATING
C7326 a_3171_6737.n6 VSS 7.6849f ; **FLOATING
C7327 a_3171_6737.t1 VSS 1.77059f ; **FLOATING
C7328 a_3171_6737.t0 VSS 0.48093f ; **FLOATING
C7329 a_3747_6737.t2 VSS 0.97175f ; **FLOATING
C7330 a_3747_6737.t3 VSS 0.73981f ; **FLOATING
C7331 a_3747_6737.n0 VSS 5.18292f ; **FLOATING
C7332 a_3747_6737.t4 VSS 0.73981f ; **FLOATING
C7333 a_3747_6737.n1 VSS 3.50359f ; **FLOATING
C7334 a_3747_6737.t5 VSS 0.73981f ; **FLOATING
C7335 a_3747_6737.n2 VSS 3.50359f ; **FLOATING
C7336 a_3747_6737.t6 VSS 0.73981f ; **FLOATING
C7337 a_3747_6737.n3 VSS 3.50359f ; **FLOATING
C7338 a_3747_6737.t7 VSS 0.73981f ; **FLOATING
C7339 a_3747_6737.n4 VSS 3.50359f ; **FLOATING
C7340 a_3747_6737.t8 VSS 0.73981f ; **FLOATING
C7341 a_3747_6737.n5 VSS 3.50359f ; **FLOATING
C7342 a_3747_6737.t9 VSS 0.73981f ; **FLOATING
C7343 a_3747_6737.n6 VSS 5.20242f ; **FLOATING
C7344 a_3747_6737.t1 VSS 1.1889f ; **FLOATING
C7345 a_3747_6737.t0 VSS 0.31431f ; **FLOATING
C7346 a_2019_6001.t2 VSS 4.07073f ; **FLOATING
C7347 a_2019_6001.t3 VSS 21.9073f ; **FLOATING
C7348 a_2019_6001.t1 VSS 1.98996f ; **FLOATING
C7349 a_2019_6001.t0 VSS 0.44681f ; **FLOATING
C7350 a_2595_6001.t1 VSS 3.29754f ; **FLOATING
C7351 a_2595_6001.t2 VSS 5.08334f ; **FLOATING
C7352 a_2595_6001.t3 VSS 1.21634f ; **FLOATING
C7353 a_2595_6001.n0 VSS 27.0901f ; **FLOATING
C7354 a_2595_6001.t0 VSS 0.49984f ; **FLOATING
C7355 a_3171_6001.t2 VSS 5.08045f ; **FLOATING
C7356 a_3171_6001.t3 VSS 1.21878f ; **FLOATING
C7357 a_3171_6001.n0 VSS 30.0294f ; **FLOATING
C7358 a_3171_6001.t1 VSS 4.63926f ; **FLOATING
C7359 a_3171_6001.t0 VSS 0.50029f ; **FLOATING
C7360 a_3747_6001.t2 VSS 3.14577f ; **FLOATING
C7361 a_3747_6001.t3 VSS 0.75716f ; **FLOATING
C7362 a_3747_6001.n0 VSS 20.2342f ; **FLOATING
C7363 a_3747_6001.t1 VSS 3.75304f ; **FLOATING
C7364 a_3747_6001.t0 VSS 0.31068f ; **FLOATING
C7365 a_2019_3892.t2 VSS 0.92508f ; **FLOATING
C7366 a_2019_3892.t3 VSS 0.7023f ; **FLOATING
C7367 a_2019_3892.n0 VSS 4.98093f ; **FLOATING
C7368 a_2019_3892.t4 VSS 0.7023f ; **FLOATING
C7369 a_2019_3892.n1 VSS 3.36973f ; **FLOATING
C7370 a_2019_3892.t5 VSS 0.7023f ; **FLOATING
C7371 a_2019_3892.n2 VSS 3.36973f ; **FLOATING
C7372 a_2019_3892.t6 VSS 0.7023f ; **FLOATING
C7373 a_2019_3892.n3 VSS 3.36973f ; **FLOATING
C7374 a_2019_3892.t7 VSS 0.7023f ; **FLOATING
C7375 a_2019_3892.n4 VSS 3.36973f ; **FLOATING
C7376 a_2019_3892.t8 VSS 0.7023f ; **FLOATING
C7377 a_2019_3892.n5 VSS 3.36973f ; **FLOATING
C7378 a_2019_3892.t9 VSS 5.42446f ; **FLOATING
C7379 a_2019_3892.t1 VSS 1.0666f ; **FLOATING
C7380 a_2019_3892.t0 VSS 0.30316f ; **FLOATING
C7381 a_2595_3892.t2 VSS 1.36716f ; **FLOATING
C7382 a_2595_3892.t3 VSS 1.02104f ; **FLOATING
C7383 a_2595_3892.n0 VSS 7.76201f ; **FLOATING
C7384 a_2595_3892.t4 VSS 1.02104f ; **FLOATING
C7385 a_2595_3892.n1 VSS 5.27393f ; **FLOATING
C7386 a_2595_3892.t5 VSS 1.02104f ; **FLOATING
C7387 a_2595_3892.n2 VSS 5.27393f ; **FLOATING
C7388 a_2595_3892.t6 VSS 1.02104f ; **FLOATING
C7389 a_2595_3892.n3 VSS 5.27393f ; **FLOATING
C7390 a_2595_3892.t7 VSS 1.02104f ; **FLOATING
C7391 a_2595_3892.n4 VSS 5.27393f ; **FLOATING
C7392 a_2595_3892.t8 VSS 1.02104f ; **FLOATING
C7393 a_2595_3892.n5 VSS 5.27393f ; **FLOATING
C7394 a_2595_3892.t9 VSS 1.02104f ; **FLOATING
C7395 a_2595_3892.n6 VSS 7.58623f ; **FLOATING
C7396 a_2595_3892.t1 VSS 1.75137f ; **FLOATING
C7397 a_2595_3892.t0 VSS 0.48232f ; **FLOATING
C7398 a_3171_3892.t2 VSS 1.38486f ; **FLOATING
C7399 a_3171_3892.t3 VSS 1.03766f ; **FLOATING
C7400 a_3171_3892.n0 VSS 7.78102f ; **FLOATING
C7401 a_3171_3892.t4 VSS 1.03766f ; **FLOATING
C7402 a_3171_3892.n1 VSS 5.2825f ; **FLOATING
C7403 a_3171_3892.t5 VSS 1.03766f ; **FLOATING
C7404 a_3171_3892.n2 VSS 5.2825f ; **FLOATING
C7405 a_3171_3892.t6 VSS 1.03766f ; **FLOATING
C7406 a_3171_3892.n3 VSS 5.2825f ; **FLOATING
C7407 a_3171_3892.t7 VSS 1.03766f ; **FLOATING
C7408 a_3171_3892.n4 VSS 5.2825f ; **FLOATING
C7409 a_3171_3892.t8 VSS 1.03766f ; **FLOATING
C7410 a_3171_3892.n5 VSS 5.2825f ; **FLOATING
C7411 a_3171_3892.t9 VSS 1.03766f ; **FLOATING
C7412 a_3171_3892.n6 VSS 7.6859f ; **FLOATING
C7413 a_3171_3892.t1 VSS 1.77082f ; **FLOATING
C7414 a_3171_3892.t0 VSS 0.48099f ; **FLOATING
C7415 a_3747_3892.t2 VSS 0.97185f ; **FLOATING
C7416 a_3747_3892.t3 VSS 0.73989f ; **FLOATING
C7417 a_3747_3892.n0 VSS 5.18349f ; **FLOATING
C7418 a_3747_3892.t4 VSS 0.73989f ; **FLOATING
C7419 a_3747_3892.n1 VSS 3.50397f ; **FLOATING
C7420 a_3747_3892.t5 VSS 0.73989f ; **FLOATING
C7421 a_3747_3892.n2 VSS 3.50397f ; **FLOATING
C7422 a_3747_3892.t6 VSS 0.73989f ; **FLOATING
C7423 a_3747_3892.n3 VSS 3.50397f ; **FLOATING
C7424 a_3747_3892.t7 VSS 0.73989f ; **FLOATING
C7425 a_3747_3892.n4 VSS 3.50397f ; **FLOATING
C7426 a_3747_3892.t8 VSS 0.73989f ; **FLOATING
C7427 a_3747_3892.n5 VSS 3.50397f ; **FLOATING
C7428 a_3747_3892.t9 VSS 0.73989f ; **FLOATING
C7429 a_3747_3892.n6 VSS 5.20298f ; **FLOATING
C7430 a_3747_3892.t1 VSS 1.18903f ; **FLOATING
C7431 a_3747_3892.t0 VSS 0.31435f ; **FLOATING
C7432 a_2019_3156.t2 VSS 4.07073f ; **FLOATING
C7433 a_2019_3156.t3 VSS 21.9073f ; **FLOATING
C7434 a_2019_3156.t1 VSS 1.98996f ; **FLOATING
C7435 a_2019_3156.t0 VSS 0.44681f ; **FLOATING
C7436 a_2595_3156.t1 VSS 3.29754f ; **FLOATING
C7437 a_2595_3156.t2 VSS 5.08334f ; **FLOATING
C7438 a_2595_3156.t3 VSS 1.21634f ; **FLOATING
C7439 a_2595_3156.n0 VSS 27.0901f ; **FLOATING
C7440 a_2595_3156.t0 VSS 0.49984f ; **FLOATING
C7441 a_3171_3156.t2 VSS 5.08045f ; **FLOATING
C7442 a_3171_3156.t3 VSS 1.21878f ; **FLOATING
C7443 a_3171_3156.n0 VSS 30.0294f ; **FLOATING
C7444 a_3171_3156.t1 VSS 4.63926f ; **FLOATING
C7445 a_3171_3156.t0 VSS 0.50029f ; **FLOATING
C7446 a_3747_3156.t2 VSS 3.14577f ; **FLOATING
C7447 a_3747_3156.t3 VSS 0.75716f ; **FLOATING
C7448 a_3747_3156.n0 VSS 20.2342f ; **FLOATING
C7449 a_3747_3156.t1 VSS 3.75304f ; **FLOATING
C7450 a_3747_3156.t0 VSS 0.31068f ; **FLOATING
C7451 a_2019_1047.t2 VSS 0.92494f ; **FLOATING
C7452 a_2019_1047.t3 VSS 0.70219f ; **FLOATING
C7453 a_2019_1047.n0 VSS 4.98016f ; **FLOATING
C7454 a_2019_1047.t4 VSS 0.70219f ; **FLOATING
C7455 a_2019_1047.n1 VSS 3.36921f ; **FLOATING
C7456 a_2019_1047.t5 VSS 0.70219f ; **FLOATING
C7457 a_2019_1047.n2 VSS 3.36921f ; **FLOATING
C7458 a_2019_1047.t6 VSS 0.70219f ; **FLOATING
C7459 a_2019_1047.n3 VSS 3.36921f ; **FLOATING
C7460 a_2019_1047.t7 VSS 0.70219f ; **FLOATING
C7461 a_2019_1047.n4 VSS 3.36921f ; **FLOATING
C7462 a_2019_1047.t8 VSS 0.70219f ; **FLOATING
C7463 a_2019_1047.n5 VSS 3.36921f ; **FLOATING
C7464 a_2019_1047.t9 VSS 5.42362f ; **FLOATING
C7465 a_2019_1047.t1 VSS 1.06643f ; **FLOATING
C7466 a_2019_1047.t0 VSS 0.30311f ; **FLOATING
C7467 a_2595_1047.t2 VSS 1.367f ; **FLOATING
C7468 a_2595_1047.t3 VSS 1.02092f ; **FLOATING
C7469 a_2595_1047.n0 VSS 7.76108f ; **FLOATING
C7470 a_2595_1047.t4 VSS 1.02092f ; **FLOATING
C7471 a_2595_1047.n1 VSS 5.27329f ; **FLOATING
C7472 a_2595_1047.t5 VSS 1.02092f ; **FLOATING
C7473 a_2595_1047.n2 VSS 5.27329f ; **FLOATING
C7474 a_2595_1047.t6 VSS 1.02092f ; **FLOATING
C7475 a_2595_1047.n3 VSS 5.27329f ; **FLOATING
C7476 a_2595_1047.t7 VSS 1.02092f ; **FLOATING
C7477 a_2595_1047.n4 VSS 5.27329f ; **FLOATING
C7478 a_2595_1047.t8 VSS 1.02092f ; **FLOATING
C7479 a_2595_1047.n5 VSS 5.27329f ; **FLOATING
C7480 a_2595_1047.t9 VSS 1.02092f ; **FLOATING
C7481 a_2595_1047.n6 VSS 7.58532f ; **FLOATING
C7482 a_2595_1047.t1 VSS 1.75115f ; **FLOATING
C7483 a_2595_1047.t0 VSS 0.48226f ; **FLOATING
C7484 a_3171_1047.t2 VSS 1.38461f ; **FLOATING
C7485 a_3171_1047.t3 VSS 1.03748f ; **FLOATING
C7486 a_3171_1047.n0 VSS 7.77962f ; **FLOATING
C7487 a_3171_1047.t4 VSS 1.03748f ; **FLOATING
C7488 a_3171_1047.n1 VSS 5.28155f ; **FLOATING
C7489 a_3171_1047.t5 VSS 1.03748f ; **FLOATING
C7490 a_3171_1047.n2 VSS 5.28155f ; **FLOATING
C7491 a_3171_1047.t6 VSS 1.03748f ; **FLOATING
C7492 a_3171_1047.n3 VSS 5.28155f ; **FLOATING
C7493 a_3171_1047.t7 VSS 1.03748f ; **FLOATING
C7494 a_3171_1047.n4 VSS 5.28155f ; **FLOATING
C7495 a_3171_1047.t8 VSS 1.03748f ; **FLOATING
C7496 a_3171_1047.n5 VSS 5.28155f ; **FLOATING
C7497 a_3171_1047.t9 VSS 1.03748f ; **FLOATING
C7498 a_3171_1047.n6 VSS 7.68452f ; **FLOATING
C7499 a_3171_1047.t1 VSS 1.7705f ; **FLOATING
C7500 a_3171_1047.t0 VSS 0.48091f ; **FLOATING
C7501 a_3747_1047.t2 VSS 0.97062f ; **FLOATING
C7502 a_3747_1047.t3 VSS 0.73894f ; **FLOATING
C7503 a_3747_1047.n0 VSS 5.17688f ; **FLOATING
C7504 a_3747_1047.t4 VSS 0.73894f ; **FLOATING
C7505 a_3747_1047.n1 VSS 3.4995f ; **FLOATING
C7506 a_3747_1047.t5 VSS 0.73894f ; **FLOATING
C7507 a_3747_1047.n2 VSS 3.4995f ; **FLOATING
C7508 a_3747_1047.t6 VSS 0.73894f ; **FLOATING
C7509 a_3747_1047.n3 VSS 3.4995f ; **FLOATING
C7510 a_3747_1047.t7 VSS 0.73894f ; **FLOATING
C7511 a_3747_1047.n4 VSS 3.4995f ; **FLOATING
C7512 a_3747_1047.t8 VSS 0.73894f ; **FLOATING
C7513 a_3747_1047.n5 VSS 3.4995f ; **FLOATING
C7514 a_3747_1047.t9 VSS 0.73894f ; **FLOATING
C7515 a_3747_1047.n6 VSS 5.19635f ; **FLOATING
C7516 a_3747_1047.t1 VSS 1.18751f ; **FLOATING
C7517 a_3747_1047.t0 VSS 0.31395f ; **FLOATING
C7518 a_2595_311.t1 VSS 3.27044f ; **FLOATING
C7519 a_2595_311.t2 VSS 5.04156f ; **FLOATING
C7520 a_2595_311.t3 VSS 1.20634f ; **FLOATING
C7521 a_2595_311.n0 VSS 26.8674f ; **FLOATING
C7522 a_2595_311.t0 VSS 0.49573f ; **FLOATING
C7523 a_3171_311.t2 VSS 5.05105f ; **FLOATING
C7524 a_3171_311.t3 VSS 1.21172f ; **FLOATING
C7525 a_3171_311.n0 VSS 29.8556f ; **FLOATING
C7526 a_3171_311.t1 VSS 4.61241f ; **FLOATING
C7527 a_3171_311.t0 VSS 0.4974f ; **FLOATING
C7528 a_3747_311.t2 VSS 3.11824f ; **FLOATING
C7529 a_3747_311.t3 VSS 0.75053f ; **FLOATING
C7530 a_3747_311.n0 VSS 20.0571f ; **FLOATING
C7531 a_3747_311.t1 VSS 3.7202f ; **FLOATING
C7532 a_3747_311.t0 VSS 0.30796f ; **FLOATING
C7533 VSS.t887 VSS 3.22049f ; **FLOATING
C7534 VDD.n0 VSS 0.06157f ; **FLOATING
C7535 VDD.n1 VSS 0.12917f ; **FLOATING
C7536 VDD.n2 VSS 0.15192f ; **FLOATING
C7537 VDD.t378 VSS 48.1045f ; **FLOATING
C7538 VDD.t440 VSS 0.03416f ; **FLOATING
C7539 VDD.t345 VSS 48.1095f ; **FLOATING
C7540 VDD.n3 VSS 0.14445f ; **FLOATING
C7541 VDD.n4 VSS 0.01603f ; **FLOATING
C7542 VDD.n6 VSS 0.60031f ; **FLOATING
C7543 VDD.t476 VSS 0.03464f ; **FLOATING
C7544 VDD.n8 VSS 0.09974f ; **FLOATING
C7545 VDD.n9 VSS 0.02297f ; **FLOATING
C7546 VDD.n10 VSS 0.59465f ; **FLOATING
C7547 VDD.t487 VSS 0.03418f ; **FLOATING
C7548 VDD.n11 VSS 0.02288f ; **FLOATING
C7549 VDD.n12 VSS 0.01706f ; **FLOATING
C7550 VDD.n13 VSS 0.56177f ; **FLOATING
C7551 VDD.n14 VSS 0.01002f ; **FLOATING
C7552 VDD.n15 VSS 0.02509f ; **FLOATING
C7553 VDD.n16 VSS 0.19257f ; **FLOATING
C7554 VDD.n17 VSS 0.01399f ; **FLOATING
C7555 VDD.n18 VSS 0.1892f ; **FLOATING
C7556 VDD.n19 VSS 0.02509f ; **FLOATING
C7557 VDD.n20 VSS 0.19975f ; **FLOATING
C7558 VDD.n22 VSS 0.0389f ; **FLOATING
C7559 VDD.n23 VSS 0.83782f ; **FLOATING
C7560 VDD.t1005 VSS 0.03452f ; **FLOATING
C7561 VDD.n24 VSS 0.08961f ; **FLOATING
C7562 VDD.n25 VSS 0.02509f ; **FLOATING
C7563 VDD.n26 VSS 0.18925f ; **FLOATING
C7564 VDD.n27 VSS 0.01552f ; **FLOATING
C7565 VDD.n28 VSS 0.02509f ; **FLOATING
C7566 VDD.n29 VSS 0.01553f ; **FLOATING
C7567 VDD.n30 VSS 0.10052f ; **FLOATING
C7568 VDD.n31 VSS 0.02509f ; **FLOATING
C7569 VDD.n32 VSS 0.18927f ; **FLOATING
C7570 VDD.n33 VSS 0.0155f ; **FLOATING
C7571 VDD.n34 VSS 0.01905f ; **FLOATING
C7572 VDD.n35 VSS 0.02297f ; **FLOATING
C7573 VDD.n36 VSS 0.55752f ; **FLOATING
C7574 VDD.t474 VSS 0.0199f ; **FLOATING
C7575 VDD.n37 VSS 0.09974f ; **FLOATING
C7576 VDD.n38 VSS 0.02297f ; **FLOATING
C7577 VDD.n39 VSS 0.56289f ; **FLOATING
C7578 VDD.n40 VSS 1.36093f ; **FLOATING
C7579 VDD.t379 VSS 46.5828f ; **FLOATING
C7580 VDD.t347 VSS 46.5806f ; **FLOATING
C7581 VDD.n41 VSS 0.02909f ; **FLOATING
C7582 VDD.n42 VSS 0.12896f ; **FLOATING
C7583 VDD.n43 VSS 0.07849f ; **FLOATING
C7584 VDD.n44 VSS 0.02153f ; **FLOATING
C7585 VDD.n45 VSS 0.06629f ; **FLOATING
C7586 VDD.n46 VSS 0.02017f ; **FLOATING
C7587 VDD.n47 VSS 0.02022f ; **FLOATING
C7588 VDD.n48 VSS 0.11451f ; **FLOATING
C7589 VDD.t34 VSS 53.1538f ; **FLOATING
C7590 VDD.n49 VSS 0.02171f ; **FLOATING
C7591 VDD.n50 VSS 0.11631f ; **FLOATING
C7592 VDD.t2 VSS 53.1538f ; **FLOATING
C7593 VDD.n51 VSS 0.02171f ; **FLOATING
C7594 VDD.n52 VSS 0.11631f ; **FLOATING
C7595 VDD.t9 VSS 53.1538f ; **FLOATING
C7596 VDD.n53 VSS 0.02171f ; **FLOATING
C7597 VDD.n54 VSS 0.11631f ; **FLOATING
C7598 VDD.t0 VSS 53.1538f ; **FLOATING
C7599 VDD.n55 VSS 0.02171f ; **FLOATING
C7600 VDD.n56 VSS 0.11631f ; **FLOATING
C7601 VDD.t67 VSS 53.1538f ; **FLOATING
C7602 VDD.n57 VSS 0.02171f ; **FLOATING
C7603 VDD.n58 VSS 0.11631f ; **FLOATING
C7604 VDD.n59 VSS 0.03371f ; **FLOATING
C7605 VDD.n61 VSS 0.0307f ; **FLOATING
C7606 VDD.n62 VSS 0.03371f ; **FLOATING
C7607 VDD.n64 VSS 0.0307f ; **FLOATING
C7608 VDD.n65 VSS 0.0307f ; **FLOATING
C7609 VDD.n67 VSS 0.03371f ; **FLOATING
C7610 VDD.n69 VSS 0.0307f ; **FLOATING
C7611 VDD.n70 VSS 0.0307f ; **FLOATING
C7612 VDD.n72 VSS 0.52556f ; **FLOATING
C7613 VDD.n73 VSS 0.02509f ; **FLOATING
C7614 VDD.n74 VSS 0.08525f ; **FLOATING
C7615 VDD.n76 VSS 0.02509f ; **FLOATING
C7616 VDD.n77 VSS 0.0991f ; **FLOATING
C7617 VDD.n79 VSS 0.16022f ; **FLOATING
C7618 VDD.n80 VSS 0.02509f ; **FLOATING
C7619 VDD.n81 VSS 0.19649f ; **FLOATING
C7620 VDD.n82 VSS 0.01773f ; **FLOATING
C7621 VDD.n83 VSS 0.14651f ; **FLOATING
C7622 VDD.n84 VSS 0.02509f ; **FLOATING
C7623 VDD.n85 VSS 0.09911f ; **FLOATING
C7624 VDD.n87 VSS 0.02509f ; **FLOATING
C7625 VDD.n88 VSS 0.09909f ; **FLOATING
C7626 VDD.n90 VSS 0.02509f ; **FLOATING
C7627 VDD.n91 VSS 0.09909f ; **FLOATING
C7628 VDD.n93 VSS 0.02509f ; **FLOATING
C7629 VDD.n94 VSS 0.14691f ; **FLOATING
C7630 VDD.n95 VSS 0.19642f ; **FLOATING
C7631 VDD.n96 VSS 0.01723f ; **FLOATING
C7632 VDD.n97 VSS 0.16027f ; **FLOATING
C7633 VDD.n98 VSS 0.02509f ; **FLOATING
C7634 VDD.n99 VSS 0.09906f ; **FLOATING
C7635 VDD.n101 VSS 0.16026f ; **FLOATING
C7636 VDD.n102 VSS 0.02509f ; **FLOATING
C7637 VDD.n103 VSS 0.09909f ; **FLOATING
C7638 VDD.n105 VSS 0.16908f ; **FLOATING
C7639 VDD.n106 VSS 0.02509f ; **FLOATING
C7640 VDD.n107 VSS 0.09906f ; **FLOATING
C7641 VDD.n109 VSS 0.02509f ; **FLOATING
C7642 VDD.n110 VSS 0.0991f ; **FLOATING
C7643 VDD.n112 VSS 0.02509f ; **FLOATING
C7644 VDD.n113 VSS 0.09906f ; **FLOATING
C7645 VDD.n115 VSS 0.02509f ; **FLOATING
C7646 VDD.n116 VSS 0.14657f ; **FLOATING
C7647 VDD.n117 VSS 0.19642f ; **FLOATING
C7648 VDD.n118 VSS 0.01723f ; **FLOATING
C7649 VDD.n119 VSS 0.02509f ; **FLOATING
C7650 VDD.n120 VSS 0.19645f ; **FLOATING
C7651 VDD.n121 VSS 0.02509f ; **FLOATING
C7652 VDD.n122 VSS 0.09909f ; **FLOATING
C7653 VDD.n124 VSS 0.02509f ; **FLOATING
C7654 VDD.n125 VSS 0.14365f ; **FLOATING
C7655 VDD.n126 VSS 0.02509f ; **FLOATING
C7656 VDD.n127 VSS 0.0991f ; **FLOATING
C7657 VDD.n129 VSS 0.02509f ; **FLOATING
C7658 VDD.n130 VSS 0.19643f ; **FLOATING
C7659 VDD.n131 VSS 0.01886f ; **FLOATING
C7660 VDD.n132 VSS 0.02509f ; **FLOATING
C7661 VDD.n133 VSS 0.0991f ; **FLOATING
C7662 VDD.n136 VSS 0.02509f ; **FLOATING
C7663 VDD.n137 VSS 0.09912f ; **FLOATING
C7664 VDD.n139 VSS 0.02509f ; **FLOATING
C7665 VDD.n140 VSS 0.09912f ; **FLOATING
C7666 VDD.n142 VSS 0.16025f ; **FLOATING
C7667 VDD.n143 VSS 0.02509f ; **FLOATING
C7668 VDD.n144 VSS 0.09905f ; **FLOATING
C7669 VDD.n146 VSS 0.02509f ; **FLOATING
C7670 VDD.n147 VSS 0.09905f ; **FLOATING
C7671 VDD.n149 VSS 0.02509f ; **FLOATING
C7672 VDD.n150 VSS 0.08789f ; **FLOATING
C7673 VDD.n151 VSS 0.13566f ; **FLOATING
C7674 VDD.n152 VSS 0.01397f ; **FLOATING
C7675 VDD.n153 VSS 0.02509f ; **FLOATING
C7676 VDD.n154 VSS 0.09905f ; **FLOATING
C7677 VDD.n156 VSS 0.02509f ; **FLOATING
C7678 VDD.n157 VSS 0.09912f ; **FLOATING
C7679 VDD.n159 VSS 0.02509f ; **FLOATING
C7680 VDD.n160 VSS 0.1696f ; **FLOATING
C7681 VDD.n161 VSS 0.17384f ; **FLOATING
C7682 VDD.n162 VSS 0.02509f ; **FLOATING
C7683 VDD.n163 VSS 0.09909f ; **FLOATING
C7684 VDD.n165 VSS 0.02509f ; **FLOATING
C7685 VDD.n166 VSS 0.09912f ; **FLOATING
C7686 VDD.n168 VSS 0.02509f ; **FLOATING
C7687 VDD.n169 VSS 0.0991f ; **FLOATING
C7688 VDD.n171 VSS 0.16907f ; **FLOATING
C7689 VDD.n172 VSS 0.02509f ; **FLOATING
C7690 VDD.n173 VSS 0.19643f ; **FLOATING
C7691 VDD.n174 VSS 0.01773f ; **FLOATING
C7692 VDD.n175 VSS 0.02509f ; **FLOATING
C7693 VDD.n176 VSS 0.09906f ; **FLOATING
C7694 VDD.n178 VSS 0.09411f ; **FLOATING
C7695 VDD.n179 VSS 0.02509f ; **FLOATING
C7696 VDD.n180 VSS 0.09909f ; **FLOATING
C7697 VDD.n182 VSS 0.02509f ; **FLOATING
C7698 VDD.n183 VSS 0.08788f ; **FLOATING
C7699 VDD.n184 VSS 0.12536f ; **FLOATING
C7700 VDD.n185 VSS 0.01834f ; **FLOATING
C7701 VDD.n186 VSS 0.02509f ; **FLOATING
C7702 VDD.n187 VSS 0.09906f ; **FLOATING
C7703 VDD.n189 VSS 0.02509f ; **FLOATING
C7704 VDD.n190 VSS 0.09912f ; **FLOATING
C7705 VDD.n192 VSS 0.181f ; **FLOATING
C7706 VDD.n193 VSS 0.02509f ; **FLOATING
C7707 VDD.n194 VSS 0.1964f ; **FLOATING
C7708 VDD.n195 VSS 0.02509f ; **FLOATING
C7709 VDD.n196 VSS 0.19645f ; **FLOATING
C7710 VDD.n197 VSS 0.0177f ; **FLOATING
C7711 VDD.n198 VSS 0.01706f ; **FLOATING
C7712 VDD.n199 VSS 0.02509f ; **FLOATING
C7713 VDD.n200 VSS 0.24102f ; **FLOATING
C7714 VDD.n201 VSS 0.02247f ; **FLOATING
C7715 VDD.n202 VSS 0.02743f ; **FLOATING
C7716 VDD.n203 VSS 0.02509f ; **FLOATING
C7717 VDD.n204 VSS 0.07371f ; **FLOATING
C7718 VDD.n205 VSS 0.01514f ; **FLOATING
C7719 VDD.n206 VSS 0.16969f ; **FLOATING
C7720 VDD.n207 VSS 0.02648f ; **FLOATING
C7721 VDD.n208 VSS 0.31337f ; **FLOATING
C7722 VDD.n209 VSS 0.02309f ; **FLOATING
C7723 VDD.n210 VSS 0.21701f ; **FLOATING
C7724 VDD.n211 VSS 0.02309f ; **FLOATING
C7725 VDD.n212 VSS 0.21701f ; **FLOATING
C7726 VDD.n213 VSS 0.02309f ; **FLOATING
C7727 VDD.n214 VSS 0.21701f ; **FLOATING
C7728 VDD.n215 VSS 0.02309f ; **FLOATING
C7729 VDD.n216 VSS 0.21701f ; **FLOATING
C7730 VDD.n217 VSS 0.02309f ; **FLOATING
C7731 VDD.n218 VSS 0.21701f ; **FLOATING
C7732 VDD.n219 VSS 0.02509f ; **FLOATING
C7733 VDD.n220 VSS 0.06666f ; **FLOATING
C7734 VDD.n221 VSS 0.02509f ; **FLOATING
C7735 VDD.n222 VSS 0.06887f ; **FLOATING
C7736 VDD.n223 VSS 0.02509f ; **FLOATING
C7737 VDD.n224 VSS 0.07456f ; **FLOATING
C7738 VDD.n225 VSS 0.14218f ; **FLOATING
C7739 VDD.n226 VSS 0.19056f ; **FLOATING
C7740 VDD.n227 VSS 0.2385f ; **FLOATING
C7741 VDD.n229 VSS 0.14218f ; **FLOATING
C7742 VDD.n230 VSS 0.19056f ; **FLOATING
C7743 VDD.n231 VSS 0.2385f ; **FLOATING
C7744 VDD.n233 VSS 0.14218f ; **FLOATING
C7745 VDD.n234 VSS 0.19056f ; **FLOATING
C7746 VDD.n235 VSS 0.2385f ; **FLOATING
C7747 VDD.n237 VSS 0.14218f ; **FLOATING
C7748 VDD.n238 VSS 0.19056f ; **FLOATING
C7749 VDD.n239 VSS 0.2385f ; **FLOATING
C7750 VDD.n241 VSS 0.14218f ; **FLOATING
C7751 VDD.n242 VSS 0.19056f ; **FLOATING
C7752 VDD.n243 VSS 0.2385f ; **FLOATING
C7753 VDD.n245 VSS 0.01806f ; **FLOATING
C7754 VDD.n246 VSS 0.16099f ; **FLOATING
C7755 VDD.n247 VSS 0.01806f ; **FLOATING
C7756 VDD.n248 VSS 0.16099f ; **FLOATING
C7757 VDD.n249 VSS 0.01806f ; **FLOATING
C7758 VDD.n250 VSS 0.16099f ; **FLOATING
C7759 VDD.n251 VSS 0.01806f ; **FLOATING
C7760 VDD.n252 VSS 0.16099f ; **FLOATING
C7761 VDD.n253 VSS 0.01806f ; **FLOATING
C7762 VDD.n254 VSS 0.16099f ; **FLOATING
C7763 VDD.n255 VSS 0.02743f ; **FLOATING
C7764 VDD.n256 VSS 0.02247f ; **FLOATING
C7765 VDD.n257 VSS 0.1282f ; **FLOATING
C7766 VDD.n258 VSS 0.03982f ; **FLOATING
C7767 VDD.n259 VSS 0.1916f ; **FLOATING
C7768 VDD.n260 VSS 0.19157f ; **FLOATING
C7769 VDD.n261 VSS 0.08876f ; **FLOATING
C7770 VDD.n262 VSS 0.19157f ; **FLOATING
C7771 VDD.n263 VSS 0.20215f ; **FLOATING
C7772 VDD.n264 VSS 0.12407f ; **FLOATING
C7773 VDD.n265 VSS 0.19157f ; **FLOATING
C7774 VDD.n266 VSS 0.19157f ; **FLOATING
C7775 VDD.n267 VSS 0.1916f ; **FLOATING
C7776 VDD.n268 VSS 0.19157f ; **FLOATING
C7777 VDD.n269 VSS 0.08876f ; **FLOATING
C7778 VDD.n270 VSS 0.19157f ; **FLOATING
C7779 VDD.n271 VSS 0.20215f ; **FLOATING
C7780 VDD.n272 VSS 0.12407f ; **FLOATING
C7781 VDD.n273 VSS 0.19157f ; **FLOATING
C7782 VDD.n274 VSS 0.19157f ; **FLOATING
C7783 VDD.n275 VSS 0.1916f ; **FLOATING
C7784 VDD.n276 VSS 0.19157f ; **FLOATING
C7785 VDD.n277 VSS 0.08876f ; **FLOATING
C7786 VDD.n278 VSS 0.19157f ; **FLOATING
C7787 VDD.n279 VSS 0.20215f ; **FLOATING
C7788 VDD.n280 VSS 0.12407f ; **FLOATING
C7789 VDD.n281 VSS 0.19157f ; **FLOATING
C7790 VDD.n282 VSS 0.19157f ; **FLOATING
C7791 VDD.n283 VSS 0.1916f ; **FLOATING
C7792 VDD.n284 VSS 0.19157f ; **FLOATING
C7793 VDD.n285 VSS 0.08876f ; **FLOATING
C7794 VDD.n286 VSS 0.19157f ; **FLOATING
C7795 VDD.n287 VSS 0.20215f ; **FLOATING
C7796 VDD.n288 VSS 0.12407f ; **FLOATING
C7797 VDD.n289 VSS 0.19157f ; **FLOATING
C7798 VDD.n290 VSS 0.19157f ; **FLOATING
C7799 VDD.n291 VSS 0.1916f ; **FLOATING
C7800 VDD.n292 VSS 0.19157f ; **FLOATING
C7801 VDD.n293 VSS 0.08876f ; **FLOATING
C7802 VDD.n294 VSS 0.19157f ; **FLOATING
C7803 VDD.n295 VSS 0.20215f ; **FLOATING
C7804 VDD.n296 VSS 0.12407f ; **FLOATING
C7805 VDD.n297 VSS 0.19157f ; **FLOATING
C7806 VDD.n298 VSS 0.19157f ; **FLOATING
C7807 VDD.n300 VSS 0.1547f ; **FLOATING
C7808 VDD.n301 VSS 0.12404f ; **FLOATING
C7809 VDD.n303 VSS 0.1547f ; **FLOATING
C7810 VDD.n305 VSS 0.1547f ; **FLOATING
C7811 VDD.n306 VSS 0.12404f ; **FLOATING
C7812 VDD.n308 VSS 0.1547f ; **FLOATING
C7813 VDD.n310 VSS 0.1547f ; **FLOATING
C7814 VDD.n311 VSS 0.12404f ; **FLOATING
C7815 VDD.n313 VSS 0.1547f ; **FLOATING
C7816 VDD.n315 VSS 0.1547f ; **FLOATING
C7817 VDD.n316 VSS 0.12404f ; **FLOATING
C7818 VDD.n318 VSS 0.1547f ; **FLOATING
C7819 VDD.n320 VSS 0.1547f ; **FLOATING
C7820 VDD.n321 VSS 0.12404f ; **FLOATING
C7821 VDD.n323 VSS 0.1547f ; **FLOATING
C7822 VDD.n325 VSS 0.1547f ; **FLOATING
C7823 VDD.n326 VSS 0.12404f ; **FLOATING
C7824 VDD.n328 VSS 0.1547f ; **FLOATING
C7825 VDD.n330 VSS 0.1547f ; **FLOATING
C7826 VDD.n331 VSS 0.12404f ; **FLOATING
C7827 VDD.n333 VSS 0.1547f ; **FLOATING
C7828 VDD.n335 VSS 0.1547f ; **FLOATING
C7829 VDD.n336 VSS 0.12404f ; **FLOATING
C7830 VDD.n338 VSS 0.1547f ; **FLOATING
C7831 VDD.n340 VSS 0.1547f ; **FLOATING
C7832 VDD.n341 VSS 0.12404f ; **FLOATING
C7833 VDD.n343 VSS 0.1547f ; **FLOATING
C7834 VDD.n345 VSS 0.1547f ; **FLOATING
C7835 VDD.n346 VSS 0.12404f ; **FLOATING
C7836 VDD.n348 VSS 0.1547f ; **FLOATING
C7837 VDD.n350 VSS 0.1547f ; **FLOATING
C7838 VDD.n351 VSS 0.12404f ; **FLOATING
C7839 VDD.n353 VSS 0.1547f ; **FLOATING
C7840 VDD.n355 VSS 0.1547f ; **FLOATING
C7841 VDD.n356 VSS 0.12404f ; **FLOATING
C7842 VDD.n358 VSS 0.1547f ; **FLOATING
C7843 VDD.n360 VSS 0.1547f ; **FLOATING
C7844 VDD.n361 VSS 0.12404f ; **FLOATING
C7845 VDD.n363 VSS 0.1547f ; **FLOATING
C7846 VDD.n365 VSS 0.1547f ; **FLOATING
C7847 VDD.n366 VSS 0.12404f ; **FLOATING
C7848 VDD.n368 VSS 0.1547f ; **FLOATING
C7849 VDD.n370 VSS 0.1547f ; **FLOATING
C7850 VDD.n371 VSS 0.12404f ; **FLOATING
C7851 VDD.n373 VSS 0.1547f ; **FLOATING
C7852 VDD.n374 VSS 0.14218f ; **FLOATING
C7853 VDD.n375 VSS 0.20212f ; **FLOATING
C7854 VDD.n377 VSS 0.14218f ; **FLOATING
C7855 VDD.n378 VSS 0.20212f ; **FLOATING
C7856 VDD.n380 VSS 0.14218f ; **FLOATING
C7857 VDD.n381 VSS 0.20212f ; **FLOATING
C7858 VDD.n383 VSS 0.14218f ; **FLOATING
C7859 VDD.n384 VSS 0.20212f ; **FLOATING
C7860 VDD.n386 VSS 0.14218f ; **FLOATING
C7861 VDD.n387 VSS 0.20212f ; **FLOATING
C7862 VDD.n390 VSS 0.14218f ; **FLOATING
C7863 VDD.n391 VSS 0.20215f ; **FLOATING
C7864 VDD.n393 VSS 0.14218f ; **FLOATING
C7865 VDD.n394 VSS 0.20215f ; **FLOATING
C7866 VDD.n395 VSS 0.14218f ; **FLOATING
C7867 VDD.n398 VSS 0.14218f ; **FLOATING
C7868 VDD.n399 VSS 0.20215f ; **FLOATING
C7869 VDD.n401 VSS 0.14218f ; **FLOATING
C7870 VDD.n402 VSS 0.20215f ; **FLOATING
C7871 VDD.n404 VSS 0.14218f ; **FLOATING
C7872 VDD.n405 VSS 0.20215f ; **FLOATING
C7873 VDD.n406 VSS 0.14218f ; **FLOATING
C7874 VDD.n409 VSS 0.14218f ; **FLOATING
C7875 VDD.n410 VSS 0.20215f ; **FLOATING
C7876 VDD.n412 VSS 0.14218f ; **FLOATING
C7877 VDD.n413 VSS 0.20215f ; **FLOATING
C7878 VDD.n415 VSS 0.14218f ; **FLOATING
C7879 VDD.n416 VSS 0.20215f ; **FLOATING
C7880 VDD.n417 VSS 0.14218f ; **FLOATING
C7881 VDD.n420 VSS 0.14218f ; **FLOATING
C7882 VDD.n421 VSS 0.20215f ; **FLOATING
C7883 VDD.n423 VSS 0.14218f ; **FLOATING
C7884 VDD.n424 VSS 0.20215f ; **FLOATING
C7885 VDD.n426 VSS 0.14218f ; **FLOATING
C7886 VDD.n427 VSS 0.20215f ; **FLOATING
C7887 VDD.n428 VSS 0.14218f ; **FLOATING
C7888 VDD.n431 VSS 0.14218f ; **FLOATING
C7889 VDD.n432 VSS 0.20215f ; **FLOATING
C7890 VDD.n434 VSS 0.14218f ; **FLOATING
C7891 VDD.n435 VSS 0.20215f ; **FLOATING
C7892 VDD.n437 VSS 0.14218f ; **FLOATING
C7893 VDD.n438 VSS 0.20215f ; **FLOATING
C7894 VDD.n439 VSS 0.14218f ; **FLOATING
C7895 VDD.n442 VSS 0.14218f ; **FLOATING
C7896 VDD.n443 VSS 0.20215f ; **FLOATING
C7897 VDD.n444 VSS 0.02509f ; **FLOATING
C7898 VDD.n445 VSS 0.0991f ; **FLOATING
C7899 VDD.n447 VSS 0.02509f ; **FLOATING
C7900 VDD.n448 VSS 0.09909f ; **FLOATING
C7901 VDD.n450 VSS 0.01883f ; **FLOATING
C7902 VDD.n451 VSS 0.02509f ; **FLOATING
C7903 VDD.n452 VSS 0.09909f ; **FLOATING
C7904 VDD.n454 VSS 0.02509f ; **FLOATING
C7905 VDD.n455 VSS 0.0991f ; **FLOATING
C7906 VDD.n457 VSS 1.66868f ; **FLOATING
C7907 VDD.n458 VSS 1.61019f ; **FLOATING
C7908 VDD.n459 VSS 1.9584f ; **FLOATING
C7909 VDD.n460 VSS 0.1602f ; **FLOATING
C7910 VDD.n461 VSS 0.02739f ; **FLOATING
C7911 VDD.n462 VSS 0.02509f ; **FLOATING
C7912 VDD.n463 VSS 0.16905f ; **FLOATING
C7913 VDD.n464 VSS 0.08262f ; **FLOATING
C7914 VDD.n465 VSS 0.03624f ; **FLOATING
C7915 VDD.n466 VSS 0.02509f ; **FLOATING
C7916 VDD.n467 VSS 0.02509f ; **FLOATING
C7917 VDD.n468 VSS 0.17871f ; **FLOATING
C7918 VDD.n469 VSS 0.02509f ; **FLOATING
C7919 VDD.n470 VSS 0.02509f ; **FLOATING
C7920 VDD.n471 VSS 0.17875f ; **FLOATING
C7921 VDD.n472 VSS 0.16022f ; **FLOATING
C7922 VDD.n473 VSS 0.02736f ; **FLOATING
C7923 VDD.n474 VSS 0.02509f ; **FLOATING
C7924 VDD.n475 VSS 0.03627f ; **FLOATING
C7925 VDD.n476 VSS 0.02509f ; **FLOATING
C7926 VDD.n477 VSS 0.02509f ; **FLOATING
C7927 VDD.n478 VSS 0.16905f ; **FLOATING
C7928 VDD.n479 VSS 0.02509f ; **FLOATING
C7929 VDD.n480 VSS 0.16026f ; **FLOATING
C7930 VDD.n481 VSS 0.02509f ; **FLOATING
C7931 VDD.n482 VSS 0.16023f ; **FLOATING
C7932 VDD.n483 VSS 0.02509f ; **FLOATING
C7933 VDD.n484 VSS 0.16278f ; **FLOATING
C7934 VDD.n485 VSS 0.02509f ; **FLOATING
C7935 VDD.n486 VSS 0.02739f ; **FLOATING
C7936 VDD.n487 VSS 0.16028f ; **FLOATING
C7937 VDD.n488 VSS 0.02509f ; **FLOATING
C7938 VDD.n489 VSS 0.18095f ; **FLOATING
C7939 VDD.n490 VSS 0.03621f ; **FLOATING
C7940 VDD.n491 VSS 0.02509f ; **FLOATING
C7941 VDD.n492 VSS 0.16412f ; **FLOATING
C7942 VDD.n493 VSS 0.08262f ; **FLOATING
C7943 VDD.n494 VSS 0.03621f ; **FLOATING
C7944 VDD.n495 VSS 0.02509f ; **FLOATING
C7945 VDD.n496 VSS 0.16029f ; **FLOATING
C7946 VDD.n497 VSS 0.02509f ; **FLOATING
C7947 VDD.n498 VSS 0.02509f ; **FLOATING
C7948 VDD.n499 VSS 0.18096f ; **FLOATING
C7949 VDD.n500 VSS 0.02509f ; **FLOATING
C7950 VDD.n501 VSS 0.02739f ; **FLOATING
C7951 VDD.n502 VSS 0.18245f ; **FLOATING
C7952 VDD.n503 VSS 0.02509f ; **FLOATING
C7953 VDD.n504 VSS 0.18428f ; **FLOATING
C7954 VDD.n505 VSS 0.05438f ; **FLOATING
C7955 VDD.n506 VSS 0.18099f ; **FLOATING
C7956 VDD.n507 VSS 0.08262f ; **FLOATING
C7957 VDD.n508 VSS 0.03621f ; **FLOATING
C7958 VDD.n509 VSS 0.02509f ; **FLOATING
C7959 VDD.n510 VSS 0.16021f ; **FLOATING
C7960 VDD.n511 VSS 0.16021f ; **FLOATING
C7961 VDD.n512 VSS 0.02741f ; **FLOATING
C7962 VDD.n513 VSS 0.02509f ; **FLOATING
C7963 VDD.n514 VSS 0.16901f ; **FLOATING
C7964 VDD.n515 VSS 0.0362f ; **FLOATING
C7965 VDD.n516 VSS 0.02509f ; **FLOATING
C7966 VDD.n517 VSS 0.02509f ; **FLOATING
C7967 VDD.n518 VSS 0.17759f ; **FLOATING
C7968 VDD.n519 VSS 0.03627f ; **FLOATING
C7969 VDD.n520 VSS 0.02509f ; **FLOATING
C7970 VDD.n521 VSS 0.16022f ; **FLOATING
C7971 VDD.n522 VSS 0.08266f ; **FLOATING
C7972 VDD.n523 VSS 0.03619f ; **FLOATING
C7973 VDD.n524 VSS 0.02509f ; **FLOATING
C7974 VDD.n525 VSS 0.15049f ; **FLOATING
C7975 VDD.n526 VSS 0.16905f ; **FLOATING
C7976 VDD.n527 VSS 0.02741f ; **FLOATING
C7977 VDD.n528 VSS 0.02509f ; **FLOATING
C7978 VDD.n529 VSS 0.16024f ; **FLOATING
C7979 VDD.n530 VSS 0.02732f ; **FLOATING
C7980 VDD.n531 VSS 0.02509f ; **FLOATING
C7981 VDD.n532 VSS 0.03627f ; **FLOATING
C7982 VDD.n533 VSS 0.02509f ; **FLOATING
C7983 VDD.n534 VSS 0.02509f ; **FLOATING
C7984 VDD.n535 VSS 0.03623f ; **FLOATING
C7985 VDD.n536 VSS 0.02509f ; **FLOATING
C7986 VDD.n537 VSS 0.03624f ; **FLOATING
C7987 VDD.n538 VSS 0.02509f ; **FLOATING
C7988 VDD.n539 VSS 0.1602f ; **FLOATING
C7989 VDD.n540 VSS 0.08267f ; **FLOATING
C7990 VDD.n541 VSS 0.03615f ; **FLOATING
C7991 VDD.n542 VSS 0.02509f ; **FLOATING
C7992 VDD.n543 VSS 0.16026f ; **FLOATING
C7993 VDD.n544 VSS 0.08262f ; **FLOATING
C7994 VDD.n545 VSS 0.03621f ; **FLOATING
C7995 VDD.n546 VSS 0.02509f ; **FLOATING
C7996 VDD.n547 VSS 0.16025f ; **FLOATING
C7997 VDD.n548 VSS 0.02509f ; **FLOATING
C7998 VDD.n549 VSS 0.17867f ; **FLOATING
C7999 VDD.n550 VSS 0.09335f ; **FLOATING
C8000 VDD.n551 VSS 0.03621f ; **FLOATING
C8001 VDD.n552 VSS 0.02509f ; **FLOATING
C8002 VDD.n553 VSS 0.16024f ; **FLOATING
C8003 VDD.n554 VSS 0.02736f ; **FLOATING
C8004 VDD.n555 VSS 0.02509f ; **FLOATING
C8005 VDD.n556 VSS 0.16909f ; **FLOATING
C8006 VDD.n557 VSS 0.09295f ; **FLOATING
C8007 VDD.n558 VSS 0.03619f ; **FLOATING
C8008 VDD.n559 VSS 0.02509f ; **FLOATING
C8009 VDD.n560 VSS 0.11552f ; **FLOATING
C8010 VDD.n562 VSS 0.11552f ; **FLOATING
C8011 VDD.n564 VSS 0.11552f ; **FLOATING
C8012 VDD.n566 VSS 0.11552f ; **FLOATING
C8013 VDD.n568 VSS 0.11552f ; **FLOATING
C8014 VDD.n570 VSS 0.02743f ; **FLOATING
C8015 VDD.n571 VSS 0.05076f ; **FLOATING
C8016 VDD.n573 VSS 0.05144f ; **FLOATING
C8017 VDD.n574 VSS 0.1486f ; **FLOATING
C8018 VDD.n575 VSS 0.05144f ; **FLOATING
C8019 VDD.n576 VSS 0.14847f ; **FLOATING
C8020 VDD.n577 VSS 0.05144f ; **FLOATING
C8021 VDD.n578 VSS 0.049f ; **FLOATING
C8022 VDD.n579 VSS 0.14896f ; **FLOATING
C8023 VDD.n580 VSS 0.04327f ; **FLOATING
C8024 VDD.n581 VSS 0.77664f ; **FLOATING
C8025 VDD.n582 VSS 0.77664f ; **FLOATING
C8026 VDD.n583 VSS 2.13164f ; **FLOATING
C8027 VDD.n584 VSS 0.77664f ; **FLOATING
C8028 VDD.n585 VSS 1.61019f ; **FLOATING
C8029 VDD.n586 VSS 1.01543f ; **FLOATING
C8030 VDD.n587 VSS 1.65551f ; **FLOATING
C8031 VDD.n588 VSS 0.07922f ; **FLOATING
C8032 VDD.n589 VSS 0.05144f ; **FLOATING
C8033 VDD.n590 VSS 0.14847f ; **FLOATING
C8034 VDD.n591 VSS 0.05138f ; **FLOATING
C8035 VDD.n592 VSS 0.04904f ; **FLOATING
C8036 VDD.n593 VSS 0.14897f ; **FLOATING
C8037 VDD.n594 VSS 0.02739f ; **FLOATING
C8038 VDD.n595 VSS 0.02739f ; **FLOATING
C8039 VDD.n596 VSS 0.02736f ; **FLOATING
C8040 VDD.n597 VSS 0.02741f ; **FLOATING
C8041 VDD.n598 VSS 0.01774f ; **FLOATING
C8042 VDD.n599 VSS 0.02739f ; **FLOATING
C8043 VDD.n600 VSS 0.0274f ; **FLOATING
C8044 VDD.n601 VSS 0.07168f ; **FLOATING
C8045 VDD.n602 VSS 0.02739f ; **FLOATING
C8046 VDD.n603 VSS 0.02741f ; **FLOATING
C8047 VDD.n604 VSS 0.0274f ; **FLOATING
C8048 VDD.n605 VSS 0.02736f ; **FLOATING
C8049 VDD.n606 VSS 0.0274f ; **FLOATING
C8050 VDD.n607 VSS 0.02741f ; **FLOATING
C8051 VDD.n608 VSS 0.06297f ; **FLOATING
C8052 VDD.n609 VSS 0.02509f ; **FLOATING
C8053 VDD.n610 VSS 0.05663f ; **FLOATING
C8054 VDD.n611 VSS 0.02509f ; **FLOATING
C8055 VDD.n612 VSS 0.05335f ; **FLOATING
C8056 VDD.n613 VSS 0.01471f ; **FLOATING
C8057 VDD.n614 VSS 0.03488f ; **FLOATING
C8058 VDD.n615 VSS 0.16142f ; **FLOATING
C8059 VDD.n616 VSS 0.16142f ; **FLOATING
C8060 VDD.n617 VSS 0.03488f ; **FLOATING
C8061 VDD.n618 VSS 0.16142f ; **FLOATING
C8062 VDD.n619 VSS 0.03488f ; **FLOATING
C8063 VDD.n620 VSS 0.16142f ; **FLOATING
C8064 VDD.n621 VSS 0.16142f ; **FLOATING
C8065 VDD.n622 VSS 0.03617f ; **FLOATING
C8066 VDD.n623 VSS 0.03621f ; **FLOATING
C8067 VDD.n624 VSS 0.03619f ; **FLOATING
C8068 VDD.n625 VSS 0.03621f ; **FLOATING
C8069 VDD.n626 VSS 0.02527f ; **FLOATING
C8070 VDD.n627 VSS 0.01471f ; **FLOATING
C8071 VDD.n628 VSS 0.03624f ; **FLOATING
C8072 VDD.n629 VSS 0.01471f ; **FLOATING
C8073 VDD.n630 VSS 0.03627f ; **FLOATING
C8074 VDD.n631 VSS 0.03624f ; **FLOATING
C8075 VDD.n632 VSS 0.01471f ; **FLOATING
C8076 VDD.n633 VSS 0.03621f ; **FLOATING
C8077 VDD.n634 VSS 0.03622f ; **FLOATING
C8078 VDD.n635 VSS 0.01471f ; **FLOATING
C8079 VDD.n636 VSS 0.03615f ; **FLOATING
C8080 VDD.n637 VSS 0.01471f ; **FLOATING
C8081 VDD.n638 VSS 0.03621f ; **FLOATING
C8082 VDD.n639 VSS 0.01471f ; **FLOATING
C8083 VDD.n640 VSS 0.01471f ; **FLOATING
C8084 VDD.n641 VSS 0.03621f ; **FLOATING
C8085 VDD.n642 VSS 0.03624f ; **FLOATING
C8086 VDD.n643 VSS 0.01471f ; **FLOATING
C8087 VDD.n644 VSS 0.03616f ; **FLOATING
C8088 VDD.n645 VSS 0.03622f ; **FLOATING
C8089 VDD.n646 VSS 0.03619f ; **FLOATING
C8090 VDD.n647 VSS 0.03619f ; **FLOATING
C8091 VDD.n648 VSS 0.01471f ; **FLOATING
C8092 VDD.n649 VSS 0.01471f ; **FLOATING
C8093 VDD.n650 VSS 0.01471f ; **FLOATING
C8094 VDD.n651 VSS 0.03628f ; **FLOATING
C8095 VDD.n652 VSS 0.03628f ; **FLOATING
C8096 VDD.n653 VSS 0.1403f ; **FLOATING
C8097 VDD.t364 VSS 8.8051f ; **FLOATING
C8098 VDD.n654 VSS 0.01471f ; **FLOATING
C8099 VDD.n655 VSS 0.01471f ; **FLOATING
C8100 VDD.n656 VSS 0.03621f ; **FLOATING
C8101 VDD.n657 VSS 0.03622f ; **FLOATING
C8102 VDD.n658 VSS 0.01471f ; **FLOATING
C8103 VDD.n659 VSS 0.01471f ; **FLOATING
C8104 VDD.n660 VSS 0.01471f ; **FLOATING
C8105 VDD.n661 VSS 0.03624f ; **FLOATING
C8106 VDD.n662 VSS 0.01471f ; **FLOATING
C8107 VDD.n663 VSS 0.03624f ; **FLOATING
C8108 VDD.n664 VSS 0.01471f ; **FLOATING
C8109 VDD.n665 VSS 0.01471f ; **FLOATING
C8110 VDD.n666 VSS 0.03621f ; **FLOATING
C8111 VDD.n667 VSS 0.01471f ; **FLOATING
C8112 VDD.n668 VSS 0.01471f ; **FLOATING
C8113 VDD.n672 VSS 0.05434f ; **FLOATING
C8114 VDD.n675 VSS 0.05434f ; **FLOATING
C8115 VDD.n677 VSS 0.02568f ; **FLOATING
C8116 VDD.n678 VSS 0.01471f ; **FLOATING
C8117 VDD.n679 VSS 0.01471f ; **FLOATING
C8118 VDD.n681 VSS 0.05434f ; **FLOATING
C8119 VDD.n684 VSS 0.05434f ; **FLOATING
C8120 VDD.n687 VSS 0.05434f ; **FLOATING
C8121 VDD.n692 VSS 0.05434f ; **FLOATING
C8122 VDD.n696 VSS 0.02568f ; **FLOATING
C8123 VDD.n700 VSS 0.05434f ; **FLOATING
C8124 VDD.n703 VSS 0.05434f ; **FLOATING
C8125 VDD.n706 VSS 0.05434f ; **FLOATING
C8126 VDD.n709 VSS 0.05434f ; **FLOATING
C8127 VDD.t548 VSS 0.03925f ; **FLOATING
C8128 VDD.t545 VSS 0.03925f ; **FLOATING
C8129 VDD.n713 VSS 0.13395f ; **FLOATING
C8130 VDD.n714 VSS 0.01692f ; **FLOATING
C8131 VDD.t546 VSS 0.04747f ; **FLOATING
C8132 VDD.t543 VSS 0.04747f ; **FLOATING
C8133 VDD.n715 VSS 0.15112f ; **FLOATING
C8134 VDD.n716 VSS 0.07999f ; **FLOATING
C8135 VDD.n717 VSS 0.04954f ; **FLOATING
C8136 VDD.n718 VSS 0.07674f ; **FLOATING
C8137 VDD.t462 VSS 0.03383f ; **FLOATING
C8138 VDD.n719 VSS 0.02297f ; **FLOATING
C8139 VDD.t461 VSS 0.02443f ; **FLOATING
C8140 VDD.n720 VSS 0.01681f ; **FLOATING
C8141 VDD.t464 VSS 0.0199f ; **FLOATING
C8142 VDD.t463 VSS 0.03782f ; **FLOATING
C8143 VDD.t465 VSS 0.03383f ; **FLOATING
C8144 VDD.t467 VSS 0.03426f ; **FLOATING
C8145 VDD.t466 VSS 0.02458f ; **FLOATING
C8146 VDD.t468 VSS 0.03782f ; **FLOATING
C8147 VDD.t469 VSS 0.01989f ; **FLOATING
C8148 VDD.t470 VSS 0.03416f ; **FLOATING
C8149 VDD.t807 VSS 0.03958f ; **FLOATING
C8150 VDD.t693 VSS 0.02527f ; **FLOATING
C8151 VDD.t360 VSS 3.56387f ; **FLOATING
C8152 VDD.n721 VSS 0.69145f ; **FLOATING
C8153 VDD.n722 VSS 0.12299f ; **FLOATING
C8154 VDD.n723 VSS 0.02906f ; **FLOATING
C8155 VDD.t831 VSS 0.02791f ; **FLOATING
C8156 VDD.t829 VSS 0.02791f ; **FLOATING
C8157 VDD.n724 VSS 0.08283f ; **FLOATING
C8158 VDD.n725 VSS 0.03934f ; **FLOATING
C8159 VDD.t366 VSS 0.01294f ; **FLOATING
C8160 VDD.t827 VSS 0.06439f ; **FLOATING
C8161 VDD.n726 VSS 0.02608f ; **FLOATING
C8162 VDD.t1600 VSS 0.01294f ; **FLOATING
C8163 VDD.t830 VSS 0.06439f ; **FLOATING
C8164 VDD.n727 VSS 0.02608f ; **FLOATING
C8165 VDD.n728 VSS 0.05758f ; **FLOATING
C8166 VDD.n729 VSS 0.01531f ; **FLOATING
C8167 VDD.t359 VSS 0.03793f ; **FLOATING
C8168 VDD.t694 VSS 0.03503f ; **FLOATING
C8169 VDD.t790 VSS 0.03924f ; **FLOATING
C8170 VDD.t1497 VSS 0.01294f ; **FLOATING
C8171 VDD.t572 VSS 0.06439f ; **FLOATING
C8172 VDD.n730 VSS 0.02608f ; **FLOATING
C8173 VDD.t696 VSS 0.02791f ; **FLOATING
C8174 VDD.n731 VSS 0.15706f ; **FLOATING
C8175 VDD.n732 VSS 0.03934f ; **FLOATING
C8176 VDD.n733 VSS 0.01675f ; **FLOATING
C8177 VDD.n734 VSS 0.03809f ; **FLOATING
C8178 VDD.n735 VSS 0.03797f ; **FLOATING
C8179 VDD.n736 VSS 0.03319f ; **FLOATING
C8180 VDD.n737 VSS 0.03807f ; **FLOATING
C8181 VDD.n738 VSS 0.01661f ; **FLOATING
C8182 VDD.n739 VSS 0.03149f ; **FLOATING
C8183 VDD.n740 VSS 0.07603f ; **FLOATING
C8184 VDD.n741 VSS 0.05144f ; **FLOATING
C8185 VDD.n742 VSS 0.05151f ; **FLOATING
C8186 VDD.n743 VSS 0.0515f ; **FLOATING
C8187 VDD.n744 VSS 0.05144f ; **FLOATING
C8188 VDD.n745 VSS 0.05137f ; **FLOATING
C8189 VDD.n746 VSS 0.05144f ; **FLOATING
C8190 VDD.n747 VSS 0.0515f ; **FLOATING
C8191 VDD.n748 VSS 0.05148f ; **FLOATING
C8192 VDD.n749 VSS 0.05139f ; **FLOATING
C8193 VDD.n750 VSS 0.05155f ; **FLOATING
C8194 VDD.n751 VSS 0.04259f ; **FLOATING
C8195 VDD.n752 VSS 0.08366f ; **FLOATING
C8196 VDD.n754 VSS 0.05142f ; **FLOATING
C8197 VDD.n755 VSS 0.0514f ; **FLOATING
C8198 VDD.n756 VSS 0.05146f ; **FLOATING
C8199 VDD.n757 VSS 0.05144f ; **FLOATING
C8200 VDD.n758 VSS 0.05144f ; **FLOATING
C8201 VDD.n759 VSS 0.05139f ; **FLOATING
C8202 VDD.n760 VSS 0.05137f ; **FLOATING
C8203 VDD.n761 VSS 0.05148f ; **FLOATING
C8204 VDD.n762 VSS 0.0515f ; **FLOATING
C8205 VDD.n763 VSS 0.05139f ; **FLOATING
C8206 VDD.n764 VSS 0.0514f ; **FLOATING
C8207 VDD.n765 VSS 0.05141f ; **FLOATING
C8208 VDD.n766 VSS 0.0514f ; **FLOATING
C8209 VDD.n767 VSS 0.05148f ; **FLOATING
C8210 VDD.n768 VSS 0.05148f ; **FLOATING
C8211 VDD.n769 VSS 0.05144f ; **FLOATING
C8212 VDD.n770 VSS 0.05138f ; **FLOATING
C8213 VDD.n771 VSS 0.0514f ; **FLOATING
C8214 VDD.n772 VSS 0.02684f ; **FLOATING
C8215 VDD.t432 VSS 0.07098f ; **FLOATING
C8216 VDD.n774 VSS 0.05404f ; **FLOATING
C8217 VDD.n775 VSS 0.06315f ; **FLOATING
C8218 VDD.t435 VSS 0.0327f ; **FLOATING
C8219 VDD.n776 VSS 0.01667f ; **FLOATING
C8220 VDD.t437 VSS 0.03383f ; **FLOATING
C8221 VDD.n777 VSS 0.02247f ; **FLOATING
C8222 VDD.n778 VSS 0.07433f ; **FLOATING
C8223 VDD.n780 VSS 0.03371f ; **FLOATING
C8224 VDD.t434 VSS 0.03782f ; **FLOATING
C8225 VDD.n781 VSS 0.02743f ; **FLOATING
C8226 VDD.n782 VSS 0.03453f ; **FLOATING
C8227 VDD.n783 VSS 0.01623f ; **FLOATING
C8228 VDD.t433 VSS 0.03383f ; **FLOATING
C8229 VDD.n784 VSS 0.04833f ; **FLOATING
C8230 VDD.n785 VSS 0.02509f ; **FLOATING
C8231 VDD.n786 VSS 0.0382f ; **FLOATING
C8232 VDD.n787 VSS 0.01514f ; **FLOATING
C8233 VDD.t518 VSS 0.03968f ; **FLOATING
C8234 VDD.n788 VSS 0.06298f ; **FLOATING
C8235 VDD.n789 VSS 0.01471f ; **FLOATING
C8236 VDD.t1012 VSS 0.03383f ; **FLOATING
C8237 VDD.n790 VSS 0.09205f ; **FLOATING
C8238 VDD.n791 VSS 0.02509f ; **FLOATING
C8239 VDD.n792 VSS 0.06289f ; **FLOATING
C8240 VDD.n793 VSS 0.03625f ; **FLOATING
C8241 VDD.t845 VSS 0.03968f ; **FLOATING
C8242 VDD.n794 VSS 0.08259f ; **FLOATING
C8243 VDD.n795 VSS 0.01471f ; **FLOATING
C8244 VDD.t1030 VSS 0.03383f ; **FLOATING
C8245 VDD.n796 VSS 0.11118f ; **FLOATING
C8246 VDD.n797 VSS 0.02509f ; **FLOATING
C8247 VDD.n798 VSS 0.06294f ; **FLOATING
C8248 VDD.n799 VSS 0.03617f ; **FLOATING
C8249 VDD.t626 VSS 0.03968f ; **FLOATING
C8250 VDD.n800 VSS 0.08265f ; **FLOATING
C8251 VDD.n801 VSS 0.01469f ; **FLOATING
C8252 VDD.t1028 VSS 0.03383f ; **FLOATING
C8253 VDD.n802 VSS 0.11123f ; **FLOATING
C8254 VDD.n803 VSS 0.02509f ; **FLOATING
C8255 VDD.n804 VSS 0.06285f ; **FLOATING
C8256 VDD.n805 VSS 0.03628f ; **FLOATING
C8257 VDD.t1583 VSS 0.03968f ; **FLOATING
C8258 VDD.n806 VSS 0.0826f ; **FLOATING
C8259 VDD.n807 VSS 0.01471f ; **FLOATING
C8260 VDD.t1029 VSS 0.03383f ; **FLOATING
C8261 VDD.n808 VSS 0.11112f ; **FLOATING
C8262 VDD.n809 VSS 0.02509f ; **FLOATING
C8263 VDD.n810 VSS 0.06294f ; **FLOATING
C8264 VDD.n811 VSS 0.03617f ; **FLOATING
C8265 VDD.t718 VSS 0.03968f ; **FLOATING
C8266 VDD.n812 VSS 0.08262f ; **FLOATING
C8267 VDD.n813 VSS 0.01471f ; **FLOATING
C8268 VDD.t1027 VSS 0.03383f ; **FLOATING
C8269 VDD.n814 VSS 0.11114f ; **FLOATING
C8270 VDD.n815 VSS 0.02509f ; **FLOATING
C8271 VDD.n816 VSS 0.06288f ; **FLOATING
C8272 VDD.n817 VSS 0.03624f ; **FLOATING
C8273 VDD.t755 VSS 0.03968f ; **FLOATING
C8274 VDD.n818 VSS 0.08262f ; **FLOATING
C8275 VDD.n819 VSS 0.01471f ; **FLOATING
C8276 VDD.t1026 VSS 0.03383f ; **FLOATING
C8277 VDD.n820 VSS 0.11115f ; **FLOATING
C8278 VDD.n821 VSS 0.02509f ; **FLOATING
C8279 VDD.n822 VSS 0.0629f ; **FLOATING
C8280 VDD.n823 VSS 0.0362f ; **FLOATING
C8281 VDD.t756 VSS 0.03968f ; **FLOATING
C8282 VDD.n824 VSS 0.08264f ; **FLOATING
C8283 VDD.n825 VSS 0.01471f ; **FLOATING
C8284 VDD.t996 VSS 0.03383f ; **FLOATING
C8285 VDD.n826 VSS 0.11122f ; **FLOATING
C8286 VDD.n827 VSS 0.02509f ; **FLOATING
C8287 VDD.n828 VSS 0.06291f ; **FLOATING
C8288 VDD.n829 VSS 0.03621f ; **FLOATING
C8289 VDD.t585 VSS 0.03968f ; **FLOATING
C8290 VDD.n830 VSS 0.08262f ; **FLOATING
C8291 VDD.n831 VSS 0.01471f ; **FLOATING
C8292 VDD.t988 VSS 0.03383f ; **FLOATING
C8293 VDD.n832 VSS 0.02509f ; **FLOATING
C8294 VDD.n833 VSS 0.0379f ; **FLOATING
C8295 VDD.n834 VSS 0.01152f ; **FLOATING
C8296 VDD.n835 VSS 0.06888f ; **FLOATING
C8297 VDD.n836 VSS 0.02536f ; **FLOATING
C8298 VDD.t1486 VSS 0.03968f ; **FLOATING
C8299 VDD.n837 VSS 0.07288f ; **FLOATING
C8300 VDD.n838 VSS 0.01471f ; **FLOATING
C8301 VDD.t997 VSS 0.03383f ; **FLOATING
C8302 VDD.n839 VSS 0.11116f ; **FLOATING
C8303 VDD.n840 VSS 0.02509f ; **FLOATING
C8304 VDD.n841 VSS 0.06288f ; **FLOATING
C8305 VDD.n842 VSS 0.03624f ; **FLOATING
C8306 VDD.t1487 VSS 0.03968f ; **FLOATING
C8307 VDD.n843 VSS 0.08265f ; **FLOATING
C8308 VDD.n844 VSS 0.01469f ; **FLOATING
C8309 VDD.t1025 VSS 0.03383f ; **FLOATING
C8310 VDD.n845 VSS 0.11121f ; **FLOATING
C8311 VDD.n846 VSS 0.02509f ; **FLOATING
C8312 VDD.n847 VSS 0.06287f ; **FLOATING
C8313 VDD.n848 VSS 0.03622f ; **FLOATING
C8314 VDD.t868 VSS 0.03968f ; **FLOATING
C8315 VDD.n849 VSS 0.08263f ; **FLOATING
C8316 VDD.n850 VSS 0.01471f ; **FLOATING
C8317 VDD.t973 VSS 0.03383f ; **FLOATING
C8318 VDD.n851 VSS 0.11124f ; **FLOATING
C8319 VDD.n852 VSS 0.02509f ; **FLOATING
C8320 VDD.n853 VSS 0.06291f ; **FLOATING
C8321 VDD.n854 VSS 0.03623f ; **FLOATING
C8322 VDD.t1243 VSS 0.03968f ; **FLOATING
C8323 VDD.n855 VSS 0.0826f ; **FLOATING
C8324 VDD.n856 VSS 0.01471f ; **FLOATING
C8325 VDD.t1023 VSS 0.03383f ; **FLOATING
C8326 VDD.n857 VSS 0.11113f ; **FLOATING
C8327 VDD.n858 VSS 0.02509f ; **FLOATING
C8328 VDD.n859 VSS 0.06291f ; **FLOATING
C8329 VDD.n860 VSS 0.03621f ; **FLOATING
C8330 VDD.t1244 VSS 0.03968f ; **FLOATING
C8331 VDD.n861 VSS 0.08265f ; **FLOATING
C8332 VDD.n862 VSS 0.01469f ; **FLOATING
C8333 VDD.t1024 VSS 0.03383f ; **FLOATING
C8334 VDD.n863 VSS 0.11113f ; **FLOATING
C8335 VDD.n864 VSS 0.02509f ; **FLOATING
C8336 VDD.n865 VSS 0.06289f ; **FLOATING
C8337 VDD.n866 VSS 0.03621f ; **FLOATING
C8338 VDD.t717 VSS 0.03968f ; **FLOATING
C8339 VDD.n867 VSS 0.08262f ; **FLOATING
C8340 VDD.n868 VSS 0.01471f ; **FLOATING
C8341 VDD.t962 VSS 0.03383f ; **FLOATING
C8342 VDD.n869 VSS 0.1112f ; **FLOATING
C8343 VDD.n870 VSS 0.02509f ; **FLOATING
C8344 VDD.n871 VSS 0.06289f ; **FLOATING
C8345 VDD.n872 VSS 0.03625f ; **FLOATING
C8346 VDD.t517 VSS 0.03968f ; **FLOATING
C8347 VDD.n873 VSS 0.08259f ; **FLOATING
C8348 VDD.n874 VSS 0.01471f ; **FLOATING
C8349 VDD.t972 VSS 0.03383f ; **FLOATING
C8350 VDD.n875 VSS 0.1112f ; **FLOATING
C8351 VDD.n876 VSS 0.02509f ; **FLOATING
C8352 VDD.n877 VSS 0.06294f ; **FLOATING
C8353 VDD.n878 VSS 0.03617f ; **FLOATING
C8354 VDD.t580 VSS 0.03968f ; **FLOATING
C8355 VDD.n879 VSS 0.08265f ; **FLOATING
C8356 VDD.n880 VSS 0.01469f ; **FLOATING
C8357 VDD.t1000 VSS 0.03383f ; **FLOATING
C8358 VDD.n881 VSS 0.1112f ; **FLOATING
C8359 VDD.n882 VSS 0.02509f ; **FLOATING
C8360 VDD.n883 VSS 0.0629f ; **FLOATING
C8361 VDD.n884 VSS 0.03621f ; **FLOATING
C8362 VDD.t916 VSS 0.03968f ; **FLOATING
C8363 VDD.n885 VSS 0.08262f ; **FLOATING
C8364 VDD.n886 VSS 0.01471f ; **FLOATING
C8365 VDD.t1002 VSS 0.03383f ; **FLOATING
C8366 VDD.n887 VSS 0.11117f ; **FLOATING
C8367 VDD.n888 VSS 0.02509f ; **FLOATING
C8368 VDD.n889 VSS 0.06294f ; **FLOATING
C8369 VDD.n890 VSS 0.03617f ; **FLOATING
C8370 VDD.t919 VSS 0.03968f ; **FLOATING
C8371 VDD.n891 VSS 0.08265f ; **FLOATING
C8372 VDD.n892 VSS 0.01469f ; **FLOATING
C8373 VDD.t1022 VSS 0.03383f ; **FLOATING
C8374 VDD.n893 VSS 0.11113f ; **FLOATING
C8375 VDD.n894 VSS 0.02509f ; **FLOATING
C8376 VDD.n895 VSS 0.06284f ; **FLOATING
C8377 VDD.n896 VSS 0.03627f ; **FLOATING
C8378 VDD.t568 VSS 0.03968f ; **FLOATING
C8379 VDD.n897 VSS 0.08265f ; **FLOATING
C8380 VDD.n898 VSS 0.01469f ; **FLOATING
C8381 VDD.t999 VSS 0.03383f ; **FLOATING
C8382 VDD.n899 VSS 0.11119f ; **FLOATING
C8383 VDD.n900 VSS 0.02509f ; **FLOATING
C8384 VDD.n901 VSS 0.06287f ; **FLOATING
C8385 VDD.n902 VSS 0.03624f ; **FLOATING
C8386 VDD.t1119 VSS 0.03968f ; **FLOATING
C8387 VDD.n903 VSS 0.08262f ; **FLOATING
C8388 VDD.n904 VSS 0.01471f ; **FLOATING
C8389 VDD.t1003 VSS 0.03383f ; **FLOATING
C8390 VDD.n905 VSS 0.1112f ; **FLOATING
C8391 VDD.n906 VSS 0.02509f ; **FLOATING
C8392 VDD.n907 VSS 0.06289f ; **FLOATING
C8393 VDD.n908 VSS 0.03625f ; **FLOATING
C8394 VDD.t867 VSS 0.03968f ; **FLOATING
C8395 VDD.n909 VSS 0.08259f ; **FLOATING
C8396 VDD.n910 VSS 0.01471f ; **FLOATING
C8397 VDD.t1011 VSS 0.03383f ; **FLOATING
C8398 VDD.n911 VSS 0.07186f ; **FLOATING
C8399 VDD.n912 VSS 0.02509f ; **FLOATING
C8400 VDD.n913 VSS 0.0379f ; **FLOATING
C8401 VDD.n914 VSS 0.01129f ; **FLOATING
C8402 VDD.n915 VSS 0.06672f ; **FLOATING
C8403 VDD.n916 VSS 0.0256f ; **FLOATING
C8404 VDD.t915 VSS 0.03968f ; **FLOATING
C8405 VDD.n917 VSS 0.07288f ; **FLOATING
C8406 VDD.n918 VSS 0.01471f ; **FLOATING
C8407 VDD.t1021 VSS 0.03383f ; **FLOATING
C8408 VDD.n919 VSS 0.1016f ; **FLOATING
C8409 VDD.n920 VSS 0.02509f ; **FLOATING
C8410 VDD.n921 VSS 0.06294f ; **FLOATING
C8411 VDD.n922 VSS 0.03617f ; **FLOATING
C8412 VDD.t1148 VSS 0.03968f ; **FLOATING
C8413 VDD.n923 VSS 0.08265f ; **FLOATING
C8414 VDD.n924 VSS 0.01469f ; **FLOATING
C8415 VDD.t961 VSS 0.03383f ; **FLOATING
C8416 VDD.n925 VSS 0.11115f ; **FLOATING
C8417 VDD.n926 VSS 0.02509f ; **FLOATING
C8418 VDD.n927 VSS 0.06287f ; **FLOATING
C8419 VDD.n928 VSS 0.03622f ; **FLOATING
C8420 VDD.t516 VSS 0.03968f ; **FLOATING
C8421 VDD.n929 VSS 0.08266f ; **FLOATING
C8422 VDD.n930 VSS 0.01469f ; **FLOATING
C8423 VDD.t1016 VSS 0.03383f ; **FLOATING
C8424 VDD.n931 VSS 0.11117f ; **FLOATING
C8425 VDD.n932 VSS 0.02509f ; **FLOATING
C8426 VDD.n933 VSS 0.06288f ; **FLOATING
C8427 VDD.n934 VSS 0.03622f ; **FLOATING
C8428 VDD.t514 VSS 0.03968f ; **FLOATING
C8429 VDD.n935 VSS 0.08263f ; **FLOATING
C8430 VDD.n936 VSS 0.01471f ; **FLOATING
C8431 VDD.t1018 VSS 0.03383f ; **FLOATING
C8432 VDD.n937 VSS 0.11113f ; **FLOATING
C8433 VDD.n938 VSS 0.02509f ; **FLOATING
C8434 VDD.n939 VSS 0.06288f ; **FLOATING
C8435 VDD.n940 VSS 0.03624f ; **FLOATING
C8436 VDD.t566 VSS 0.03968f ; **FLOATING
C8437 VDD.n941 VSS 0.08262f ; **FLOATING
C8438 VDD.n942 VSS 0.01471f ; **FLOATING
C8439 VDD.t1019 VSS 0.03383f ; **FLOATING
C8440 VDD.n943 VSS 0.11114f ; **FLOATING
C8441 VDD.n944 VSS 0.02509f ; **FLOATING
C8442 VDD.n945 VSS 0.06294f ; **FLOATING
C8443 VDD.n946 VSS 0.03617f ; **FLOATING
C8444 VDD.t1275 VSS 0.03968f ; **FLOATING
C8445 VDD.n947 VSS 0.08265f ; **FLOATING
C8446 VDD.n948 VSS 0.01469f ; **FLOATING
C8447 VDD.t1020 VSS 0.03383f ; **FLOATING
C8448 VDD.n949 VSS 0.11118f ; **FLOATING
C8449 VDD.n950 VSS 0.02509f ; **FLOATING
C8450 VDD.n951 VSS 0.0629f ; **FLOATING
C8451 VDD.n952 VSS 0.03621f ; **FLOATING
C8452 VDD.t716 VSS 0.03968f ; **FLOATING
C8453 VDD.n953 VSS 0.08262f ; **FLOATING
C8454 VDD.n954 VSS 0.01471f ; **FLOATING
C8455 VDD.t982 VSS 0.03383f ; **FLOATING
C8456 VDD.n955 VSS 0.11123f ; **FLOATING
C8457 VDD.n956 VSS 0.02509f ; **FLOATING
C8458 VDD.n957 VSS 0.06295f ; **FLOATING
C8459 VDD.n958 VSS 0.03616f ; **FLOATING
C8460 VDD.t565 VSS 0.03968f ; **FLOATING
C8461 VDD.n959 VSS 0.08265f ; **FLOATING
C8462 VDD.n960 VSS 0.01469f ; **FLOATING
C8463 VDD.t1017 VSS 0.03383f ; **FLOATING
C8464 VDD.n961 VSS 0.11112f ; **FLOATING
C8465 VDD.n962 VSS 0.02509f ; **FLOATING
C8466 VDD.n963 VSS 0.0629f ; **FLOATING
C8467 VDD.n964 VSS 0.03623f ; **FLOATING
C8468 VDD.t912 VSS 0.03968f ; **FLOATING
C8469 VDD.n965 VSS 0.0826f ; **FLOATING
C8470 VDD.n966 VSS 0.01471f ; **FLOATING
C8471 VDD.t987 VSS 0.03383f ; **FLOATING
C8472 VDD.n967 VSS 0.11111f ; **FLOATING
C8473 VDD.n968 VSS 0.02509f ; **FLOATING
C8474 VDD.n969 VSS 0.06288f ; **FLOATING
C8475 VDD.n970 VSS 0.03624f ; **FLOATING
C8476 VDD.t1205 VSS 0.03968f ; **FLOATING
C8477 VDD.n971 VSS 0.08265f ; **FLOATING
C8478 VDD.n972 VSS 0.01469f ; **FLOATING
C8479 VDD.t998 VSS 0.03383f ; **FLOATING
C8480 VDD.n973 VSS 0.11114f ; **FLOATING
C8481 VDD.n974 VSS 0.02509f ; **FLOATING
C8482 VDD.n975 VSS 0.06287f ; **FLOATING
C8483 VDD.n976 VSS 0.03622f ; **FLOATING
C8484 VDD.t640 VSS 0.03968f ; **FLOATING
C8485 VDD.n977 VSS 0.08263f ; **FLOATING
C8486 VDD.n978 VSS 0.01471f ; **FLOATING
C8487 VDD.t960 VSS 0.03383f ; **FLOATING
C8488 VDD.n979 VSS 0.09974f ; **FLOATING
C8489 VDD.n980 VSS 0.02509f ; **FLOATING
C8490 VDD.n981 VSS 0.06576f ; **FLOATING
C8491 VDD.t431 VSS 0.03383f ; **FLOATING
C8492 VDD.t430 VSS 0.01992f ; **FLOATING
C8493 VDD.t429 VSS 0.03782f ; **FLOATING
C8494 VDD.t428 VSS 0.03383f ; **FLOATING
C8495 VDD.t427 VSS 0.02443f ; **FLOATING
C8496 VDD.t368 VSS 46.5829f ; **FLOATING
C8497 VDD.t635 VSS 0.03503f ; **FLOATING
C8498 VDD.t861 VSS 0.03503f ; **FLOATING
C8499 VDD.t94 VSS 0.03145f ; **FLOATING
C8500 VDD.t385 VSS 0.03503f ; **FLOATING
C8501 VDD.n982 VSS 0.06389f ; **FLOATING
C8502 VDD.n983 VSS 0.01359f ; **FLOATING
C8503 VDD.n984 VSS 0.02892f ; **FLOATING
C8504 VDD.t911 VSS 0.04597f ; **FLOATING
C8505 VDD.n985 VSS 0.08818f ; **FLOATING
C8506 VDD.n986 VSS 0.02579f ; **FLOATING
C8507 VDD.t1613 VSS 0.03503f ; **FLOATING
C8508 VDD.n987 VSS 0.0931f ; **FLOATING
C8509 VDD.n988 VSS 0.01227f ; **FLOATING
C8510 VDD.n989 VSS 0.01279f ; **FLOATING
C8511 VDD.t1263 VSS 0.03904f ; **FLOATING
C8512 VDD.t1456 VSS 0.03904f ; **FLOATING
C8513 VDD.n990 VSS 0.08386f ; **FLOATING
C8514 VDD.n991 VSS 0.01231f ; **FLOATING
C8515 VDD.n992 VSS 0.01296f ; **FLOATING
C8516 VDD.t1306 VSS 0.03904f ; **FLOATING
C8517 VDD.t1426 VSS 0.03904f ; **FLOATING
C8518 VDD.n993 VSS 0.08323f ; **FLOATING
C8519 VDD.n994 VSS 0.01237f ; **FLOATING
C8520 VDD.t1495 VSS 0.03503f ; **FLOATING
C8521 VDD.t353 VSS 0.03503f ; **FLOATING
C8522 VDD.t885 VSS 0.02587f ; **FLOATING
C8523 VDD.t1433 VSS 0.02587f ; **FLOATING
C8524 VDD.n995 VSS 0.08393f ; **FLOATING
C8525 VDD.t1305 VSS 0.03458f ; **FLOATING
C8526 VDD.t1421 VSS 0.03458f ; **FLOATING
C8527 VDD.n996 VSS 0.06951f ; **FLOATING
C8528 VDD.n997 VSS 0.01712f ; **FLOATING
C8529 VDD.t636 VSS 0.02587f ; **FLOATING
C8530 VDD.t863 VSS 0.02587f ; **FLOATING
C8531 VDD.n998 VSS 0.06926f ; **FLOATING
C8532 VDD.t1262 VSS 0.03458f ; **FLOATING
C8533 VDD.t1422 VSS 0.03458f ; **FLOATING
C8534 VDD.n999 VSS 0.07416f ; **FLOATING
C8535 VDD.n1000 VSS 0.01249f ; **FLOATING
C8536 VDD.t1494 VSS 0.02587f ; **FLOATING
C8537 VDD.t355 VSS 0.02587f ; **FLOATING
C8538 VDD.n1001 VSS 0.06903f ; **FLOATING
C8539 VDD.n1002 VSS 0.01204f ; **FLOATING
C8540 VDD.t884 VSS 0.03458f ; **FLOATING
C8541 VDD.t1434 VSS 0.03458f ; **FLOATING
C8542 VDD.n1003 VSS 0.06998f ; **FLOATING
C8543 VDD.n1004 VSS 0.01709f ; **FLOATING
C8544 VDD.t887 VSS 0.03904f ; **FLOATING
C8545 VDD.t1451 VSS 0.03904f ; **FLOATING
C8546 VDD.n1005 VSS 0.07822f ; **FLOATING
C8547 VDD.t637 VSS 0.02587f ; **FLOATING
C8548 VDD.t862 VSS 0.02587f ; **FLOATING
C8549 VDD.n1006 VSS 0.06966f ; **FLOATING
C8550 VDD.n1007 VSS 0.01274f ; **FLOATING
C8551 VDD.t1390 VSS 0.03458f ; **FLOATING
C8552 VDD.t354 VSS 0.03458f ; **FLOATING
C8553 VDD.n1008 VSS 0.07417f ; **FLOATING
C8554 VDD.t1391 VSS 0.03904f ; **FLOATING
C8555 VDD.t1449 VSS 0.03904f ; **FLOATING
C8556 VDD.n1009 VSS 0.0125f ; **FLOATING
C8557 VDD.t888 VSS 0.03503f ; **FLOATING
C8558 VDD.t1504 VSS 0.03515f ; **FLOATING
C8559 VDD.t683 VSS 0.03503f ; **FLOATING
C8560 VDD.n1010 VSS 0.07338f ; **FLOATING
C8561 VDD.n1011 VSS 0.01378f ; **FLOATING
C8562 VDD.t1206 VSS 0.03503f ; **FLOATING
C8563 VDD.n1012 VSS 0.06362f ; **FLOATING
C8564 VDD.t343 VSS 0.03503f ; **FLOATING
C8565 VDD.n1013 VSS 0.05375f ; **FLOATING
C8566 VDD.n1014 VSS 0.01946f ; **FLOATING
C8567 VDD.t504 VSS 0.03503f ; **FLOATING
C8568 VDD.t96 VSS 0.03145f ; **FLOATING
C8569 VDD.t97 VSS 0.03145f ; **FLOATING
C8570 VDD.t1273 VSS 0.03503f ; **FLOATING
C8571 VDD.t95 VSS 0.03376f ; **FLOATING
C8572 VDD.t1707 VSS 0.11617f ; **FLOATING
C8573 VDD.t1282 VSS 0.04597f ; **FLOATING
C8574 VDD.t98 VSS 0.03376f ; **FLOATING
C8575 VDD.t1706 VSS 0.11617f ; **FLOATING
C8576 VDD.n1015 VSS 0.14218f ; **FLOATING
C8577 VDD.n1016 VSS 0.08876f ; **FLOATING
C8578 VDD.t682 VSS 0.03503f ; **FLOATING
C8579 VDD.t100 VSS 0.03145f ; **FLOATING
C8580 VDD.t101 VSS 0.03145f ; **FLOATING
C8581 VDD.t104 VSS 0.03145f ; **FLOATING
C8582 VDD.t1180 VSS 0.03503f ; **FLOATING
C8583 VDD.t1277 VSS 0.03503f ; **FLOATING
C8584 VDD.t757 VSS 0.03503f ; **FLOATING
C8585 VDD.t1518 VSS 0.03503f ; **FLOATING
C8586 VDD.t45 VSS 0.03145f ; **FLOATING
C8587 VDD.t567 VSS 0.04597f ; **FLOATING
C8588 VDD.t1318 VSS 0.03503f ; **FLOATING
C8589 VDD.t48 VSS 0.03145f ; **FLOATING
C8590 VDD.t515 VSS 0.03503f ; **FLOATING
C8591 VDD.t49 VSS 0.03145f ; **FLOATING
C8592 VDD.t681 VSS 0.03503f ; **FLOATING
C8593 VDD.t52 VSS 0.03145f ; **FLOATING
C8594 VDD.t53 VSS 0.03145f ; **FLOATING
C8595 VDD.t811 VSS 0.04614f ; **FLOATING
C8596 VDD.n1017 VSS 0.01946f ; **FLOATING
C8597 VDD.t1149 VSS 0.03503f ; **FLOATING
C8598 VDD.n1018 VSS 0.06362f ; **FLOATING
C8599 VDD.n1019 VSS 0.01378f ; **FLOATING
C8600 VDD.t56 VSS 0.03145f ; **FLOATING
C8601 VDD.t689 VSS 0.03503f ; **FLOATING
C8602 VDD.n1020 VSS 0.0532f ; **FLOATING
C8603 VDD.t1607 VSS 0.03503f ; **FLOATING
C8604 VDD.n1022 VSS 0.05375f ; **FLOATING
C8605 VDD.n1023 VSS 0.01359f ; **FLOATING
C8606 VDD.t1507 VSS 0.03503f ; **FLOATING
C8607 VDD.n1024 VSS 0.06417f ; **FLOATING
C8608 VDD.t289 VSS 0.03145f ; **FLOATING
C8609 VDD.t1147 VSS 0.04597f ; **FLOATING
C8610 VDD.t292 VSS 0.03145f ; **FLOATING
C8611 VDD.t506 VSS 0.03503f ; **FLOATING
C8612 VDD.t293 VSS 0.03145f ; **FLOATING
C8613 VDD.t1509 VSS 0.03503f ; **FLOATING
C8614 VDD.t686 VSS 0.03503f ; **FLOATING
C8615 VDD.t296 VSS 0.03145f ; **FLOATING
C8616 VDD.t297 VSS 0.03145f ; **FLOATING
C8617 VDD.t300 VSS 0.03145f ; **FLOATING
C8618 VDD.t771 VSS 0.03503f ; **FLOATING
C8619 VDD.t844 VSS 0.03503f ; **FLOATING
C8620 VDD.t1221 VSS 0.03503f ; **FLOATING
C8621 VDD.t1515 VSS 0.03503f ; **FLOATING
C8622 VDD.t1125 VSS 0.04597f ; **FLOATING
C8623 VDD.t1538 VSS 0.03503f ; **FLOATING
C8624 VDD.t918 VSS 0.03503f ; **FLOATING
C8625 VDD.t344 VSS 0.03503f ; **FLOATING
C8626 VDD.t759 VSS 0.03503f ; **FLOATING
C8627 VDD.t1452 VSS 0.03719f ; **FLOATING
C8628 VDD.t1123 VSS 0.04597f ; **FLOATING
C8629 VDD.t1453 VSS 0.06567f ; **FLOATING
C8630 VDD.t624 VSS 0.03503f ; **FLOATING
C8631 VDD.t1210 VSS 0.03503f ; **FLOATING
C8632 VDD.t1514 VSS 0.03503f ; **FLOATING
C8633 VDD.t1517 VSS 0.03503f ; **FLOATING
C8634 VDD.t122 VSS 0.03145f ; **FLOATING
C8635 VDD.t813 VSS 0.04597f ; **FLOATING
C8636 VDD.t1319 VSS 0.03503f ; **FLOATING
C8637 VDD.t125 VSS 0.03145f ; **FLOATING
C8638 VDD.t1580 VSS 0.03503f ; **FLOATING
C8639 VDD.t126 VSS 0.03145f ; **FLOATING
C8640 VDD.t752 VSS 0.03503f ; **FLOATING
C8641 VDD.t129 VSS 0.03145f ; **FLOATING
C8642 VDD.t130 VSS 0.03145f ; **FLOATING
C8643 VDD.t1242 VSS 0.04614f ; **FLOATING
C8644 VDD.n1025 VSS 0.01946f ; **FLOATING
C8645 VDD.t1601 VSS 0.03503f ; **FLOATING
C8646 VDD.n1026 VSS 0.06362f ; **FLOATING
C8647 VDD.n1027 VSS 0.01378f ; **FLOATING
C8648 VDD.t133 VSS 0.03145f ; **FLOATING
C8649 VDD.t690 VSS 0.03503f ; **FLOATING
C8650 VDD.n1028 VSS 0.0532f ; **FLOATING
C8651 VDD.t758 VSS 0.03503f ; **FLOATING
C8652 VDD.n1030 VSS 0.05375f ; **FLOATING
C8653 VDD.n1031 VSS 0.01359f ; **FLOATING
C8654 VDD.t1508 VSS 0.03503f ; **FLOATING
C8655 VDD.n1032 VSS 0.06389f ; **FLOATING
C8656 VDD.t35 VSS 0.03145f ; **FLOATING
C8657 VDD.t1356 VSS 0.04597f ; **FLOATING
C8658 VDD.t38 VSS 0.03145f ; **FLOATING
C8659 VDD.t507 VSS 0.03503f ; **FLOATING
C8660 VDD.t39 VSS 0.03145f ; **FLOATING
C8661 VDD.t1489 VSS 0.03503f ; **FLOATING
C8662 VDD.t760 VSS 0.03503f ; **FLOATING
C8663 VDD.t42 VSS 0.03145f ; **FLOATING
C8664 VDD.t43 VSS 0.03145f ; **FLOATING
C8665 VDD.t286 VSS 0.03145f ; **FLOATING
C8666 VDD.t688 VSS 0.03503f ; **FLOATING
C8667 VDD.t1535 VSS 0.03503f ; **FLOATING
C8668 VDD.t623 VSS 0.03503f ; **FLOATING
C8669 VDD.t1516 VSS 0.03503f ; **FLOATING
C8670 VDD.t115 VSS 0.03145f ; **FLOATING
C8671 VDD.t1379 VSS 0.04597f ; **FLOATING
C8672 VDD.t1539 VSS 0.03503f ; **FLOATING
C8673 VDD.t86 VSS 0.03145f ; **FLOATING
C8674 VDD.t870 VSS 0.03503f ; **FLOATING
C8675 VDD.t87 VSS 0.03145f ; **FLOATING
C8676 VDD.t529 VSS 0.03503f ; **FLOATING
C8677 VDD.t62 VSS 0.03145f ; **FLOATING
C8678 VDD.t63 VSS 0.03145f ; **FLOATING
C8679 VDD.t1377 VSS 0.04614f ; **FLOATING
C8680 VDD.n1033 VSS 0.01946f ; **FLOATING
C8681 VDD.t625 VSS 0.03503f ; **FLOATING
C8682 VDD.n1034 VSS 0.06362f ; **FLOATING
C8683 VDD.n1035 VSS 0.01378f ; **FLOATING
C8684 VDD.t66 VSS 0.03145f ; **FLOATING
C8685 VDD.n1036 VSS 0.05434f ; **FLOATING
C8686 VDD.t1181 VSS 0.03503f ; **FLOATING
C8687 VDD.n1037 VSS 0.0532f ; **FLOATING
C8688 VDD.t396 VSS 0.03503f ; **FLOATING
C8689 VDD.n1039 VSS 0.05375f ; **FLOATING
C8690 VDD.n1040 VSS 0.01359f ; **FLOATING
C8691 VDD.t384 VSS 0.03503f ; **FLOATING
C8692 VDD.n1041 VSS 0.06373f ; **FLOATING
C8693 VDD.n1042 VSS 0.02579f ; **FLOATING
C8694 VDD.t846 VSS 0.04597f ; **FLOATING
C8695 VDD.n1043 VSS 0.0935f ; **FLOATING
C8696 VDD.t505 VSS 0.0384f ; **FLOATING
C8697 VDD.n1044 VSS 0.12463f ; **FLOATING
C8698 VDD.t64 VSS 0.03376f ; **FLOATING
C8699 VDD.t1690 VSS 0.11617f ; **FLOATING
C8700 VDD.n1045 VSS 0.14218f ; **FLOATING
C8701 VDD.t61 VSS 0.03376f ; **FLOATING
C8702 VDD.t1691 VSS 0.11617f ; **FLOATING
C8703 VDD.n1046 VSS 0.14218f ; **FLOATING
C8704 VDD.n1047 VSS 0.08876f ; **FLOATING
C8705 VDD.t85 VSS 0.03376f ; **FLOATING
C8706 VDD.t1692 VSS 0.11617f ; **FLOATING
C8707 VDD.n1048 VSS 0.06389f ; **FLOATING
C8708 VDD.n1049 VSS 0.01359f ; **FLOATING
C8709 VDD.n1050 VSS 0.05375f ; **FLOATING
C8710 VDD.n1051 VSS 0.01946f ; **FLOATING
C8711 VDD.n1052 VSS 0.06362f ; **FLOATING
C8712 VDD.n1053 VSS 0.01378f ; **FLOATING
C8713 VDD.n1054 VSS 0.0532f ; **FLOATING
C8714 VDD.n1056 VSS 0.05434f ; **FLOATING
C8715 VDD.t584 VSS 0.04614f ; **FLOATING
C8716 VDD.t44 VSS 0.03376f ; **FLOATING
C8717 VDD.t1693 VSS 0.11617f ; **FLOATING
C8718 VDD.n1057 VSS 0.14218f ; **FLOATING
C8719 VDD.n1058 VSS 0.12404f ; **FLOATING
C8720 VDD.t40 VSS 0.03376f ; **FLOATING
C8721 VDD.t1694 VSS 0.11617f ; **FLOATING
C8722 VDD.n1059 VSS 0.14218f ; **FLOATING
C8723 VDD.t36 VSS 0.03376f ; **FLOATING
C8724 VDD.t1695 VSS 0.11617f ; **FLOATING
C8725 VDD.t131 VSS 0.03376f ; **FLOATING
C8726 VDD.t1696 VSS 0.11617f ; **FLOATING
C8727 VDD.n1060 VSS 0.14218f ; **FLOATING
C8728 VDD.t127 VSS 0.03376f ; **FLOATING
C8729 VDD.t1697 VSS 0.11617f ; **FLOATING
C8730 VDD.n1061 VSS 0.14218f ; **FLOATING
C8731 VDD.n1062 VSS 0.08876f ; **FLOATING
C8732 VDD.t123 VSS 0.03376f ; **FLOATING
C8733 VDD.t1698 VSS 0.11617f ; **FLOATING
C8734 VDD.n1063 VSS 0.06389f ; **FLOATING
C8735 VDD.n1064 VSS 0.01359f ; **FLOATING
C8736 VDD.n1065 VSS 0.05375f ; **FLOATING
C8737 VDD.n1066 VSS 0.01946f ; **FLOATING
C8738 VDD.n1067 VSS 0.06362f ; **FLOATING
C8739 VDD.n1068 VSS 0.01378f ; **FLOATING
C8740 VDD.n1069 VSS 0.07803f ; **FLOATING
C8741 VDD.n1070 VSS 0.01181f ; **FLOATING
C8742 VDD.n1071 VSS 0.07514f ; **FLOATING
C8743 VDD.n1072 VSS 0.07338f ; **FLOATING
C8744 VDD.n1073 VSS 0.02892f ; **FLOATING
C8745 VDD.n1074 VSS 0.08818f ; **FLOATING
C8746 VDD.n1075 VSS 0.02579f ; **FLOATING
C8747 VDD.n1076 VSS 0.06373f ; **FLOATING
C8748 VDD.n1077 VSS 0.01359f ; **FLOATING
C8749 VDD.n1078 VSS 0.05375f ; **FLOATING
C8750 VDD.n1079 VSS 0.01946f ; **FLOATING
C8751 VDD.n1080 VSS 0.06362f ; **FLOATING
C8752 VDD.n1081 VSS 0.01378f ; **FLOATING
C8753 VDD.n1082 VSS 0.0532f ; **FLOATING
C8754 VDD.n1084 VSS 0.05434f ; **FLOATING
C8755 VDD.t1121 VSS 0.04614f ; **FLOATING
C8756 VDD.t298 VSS 0.03376f ; **FLOATING
C8757 VDD.t1699 VSS 0.11617f ; **FLOATING
C8758 VDD.n1085 VSS 0.14218f ; **FLOATING
C8759 VDD.n1086 VSS 0.12404f ; **FLOATING
C8760 VDD.t294 VSS 0.03376f ; **FLOATING
C8761 VDD.t1700 VSS 0.11617f ; **FLOATING
C8762 VDD.n1087 VSS 0.14218f ; **FLOATING
C8763 VDD.t290 VSS 0.03376f ; **FLOATING
C8764 VDD.t1701 VSS 0.11617f ; **FLOATING
C8765 VDD.t54 VSS 0.03376f ; **FLOATING
C8766 VDD.t1702 VSS 0.11617f ; **FLOATING
C8767 VDD.n1088 VSS 0.14218f ; **FLOATING
C8768 VDD.t50 VSS 0.03376f ; **FLOATING
C8769 VDD.t1703 VSS 0.11617f ; **FLOATING
C8770 VDD.n1089 VSS 0.14218f ; **FLOATING
C8771 VDD.n1090 VSS 0.08876f ; **FLOATING
C8772 VDD.t46 VSS 0.03376f ; **FLOATING
C8773 VDD.t1704 VSS 0.11617f ; **FLOATING
C8774 VDD.n1091 VSS 0.06389f ; **FLOATING
C8775 VDD.n1092 VSS 0.01359f ; **FLOATING
C8776 VDD.n1093 VSS 0.05375f ; **FLOATING
C8777 VDD.n1094 VSS 0.01946f ; **FLOATING
C8778 VDD.n1095 VSS 0.06362f ; **FLOATING
C8779 VDD.n1096 VSS 0.01378f ; **FLOATING
C8780 VDD.n1097 VSS 0.0532f ; **FLOATING
C8781 VDD.n1099 VSS 0.05434f ; **FLOATING
C8782 VDD.t1145 VSS 0.04614f ; **FLOATING
C8783 VDD.t102 VSS 0.03376f ; **FLOATING
C8784 VDD.t1705 VSS 0.11617f ; **FLOATING
C8785 VDD.n1100 VSS 0.14218f ; **FLOATING
C8786 VDD.n1101 VSS 0.12404f ; **FLOATING
C8787 VDD.t443 VSS 0.03383f ; **FLOATING
C8788 VDD.t438 VSS 0.02443f ; **FLOATING
C8789 VDD.t1015 VSS 0.03444f ; **FLOATING
C8790 VDD.t1033 VSS 0.03383f ; **FLOATING
C8791 VDD.t995 VSS 0.03383f ; **FLOATING
C8792 VDD.t1034 VSS 0.03383f ; **FLOATING
C8793 VDD.t1035 VSS 0.03383f ; **FLOATING
C8794 VDD.t1036 VSS 0.03383f ; **FLOATING
C8795 VDD.t985 VSS 0.03383f ; **FLOATING
C8796 VDD.t1037 VSS 0.03383f ; **FLOATING
C8797 VDD.t963 VSS 0.03383f ; **FLOATING
C8798 VDD.t1038 VSS 0.03383f ; **FLOATING
C8799 VDD.t983 VSS 0.03383f ; **FLOATING
C8800 VDD.t1040 VSS 0.03383f ; **FLOATING
C8801 VDD.t1039 VSS 0.03383f ; **FLOATING
C8802 VDD.t1041 VSS 0.03383f ; **FLOATING
C8803 VDD.n1102 VSS 0.02509f ; **FLOATING
C8804 VDD.t1043 VSS 0.03383f ; **FLOATING
C8805 VDD.t1042 VSS 0.03383f ; **FLOATING
C8806 VDD.t1001 VSS 0.03383f ; **FLOATING
C8807 VDD.t1044 VSS 0.03383f ; **FLOATING
C8808 VDD.t1032 VSS 0.03383f ; **FLOATING
C8809 VDD.t1009 VSS 0.03383f ; **FLOATING
C8810 VDD.t1013 VSS 0.03383f ; **FLOATING
C8811 VDD.n1103 VSS 0.02509f ; **FLOATING
C8812 VDD.t1045 VSS 0.03383f ; **FLOATING
C8813 VDD.t1031 VSS 0.03383f ; **FLOATING
C8814 VDD.n1104 VSS 0.02509f ; **FLOATING
C8815 VDD.t1008 VSS 0.03383f ; **FLOATING
C8816 VDD.t1014 VSS 0.03383f ; **FLOATING
C8817 VDD.t1004 VSS 0.03383f ; **FLOATING
C8818 VDD.n1105 VSS 0.02509f ; **FLOATING
C8819 VDD.t1010 VSS 0.03383f ; **FLOATING
C8820 VDD.n1106 VSS 0.02509f ; **FLOATING
C8821 VDD.t1046 VSS 0.03383f ; **FLOATING
C8822 VDD.t1048 VSS 0.03383f ; **FLOATING
C8823 VDD.t1047 VSS 0.03383f ; **FLOATING
C8824 VDD.n1107 VSS 0.02509f ; **FLOATING
C8825 VDD.t1049 VSS 0.03383f ; **FLOATING
C8826 VDD.t1006 VSS 0.03383f ; **FLOATING
C8827 VDD.t446 VSS 0.03383f ; **FLOATING
C8828 VDD.t444 VSS 0.07098f ; **FLOATING
C8829 VDD.t445 VSS 0.03782f ; **FLOATING
C8830 VDD.t447 VSS 0.0327f ; **FLOATING
C8831 VDD.n1108 VSS 0.01667f ; **FLOATING
C8832 VDD.t448 VSS 0.03383f ; **FLOATING
C8833 VDD.t561 VSS 0.03968f ; **FLOATING
C8834 VDD.t939 VSS 0.03968f ; **FLOATING
C8835 VDD.t936 VSS 0.03968f ; **FLOATING
C8836 VDD.n1109 VSS 0.0717f ; **FLOATING
C8837 VDD.t524 VSS 0.03968f ; **FLOATING
C8838 VDD.t678 VSS 0.03968f ; **FLOATING
C8839 VDD.t381 VSS 0.03968f ; **FLOATING
C8840 VDD.t931 VSS 0.03968f ; **FLOATING
C8841 VDD.t1512 VSS 0.03968f ; **FLOATING
C8842 VDD.t851 VSS 0.03968f ; **FLOATING
C8843 VDD.t555 VSS 0.03968f ; **FLOATING
C8844 VDD.t822 VSS 0.03968f ; **FLOATING
C8845 VDD.n1110 VSS 0.09335f ; **FLOATING
C8846 VDD.t1133 VSS 0.03968f ; **FLOATING
C8847 VDD.n1111 VSS 0.0717f ; **FLOATING
C8848 VDD.t644 VSS 0.03968f ; **FLOATING
C8849 VDD.t655 VSS 0.03968f ; **FLOATING
C8850 VDD.t642 VSS 0.03968f ; **FLOATING
C8851 VDD.t873 VSS 0.03968f ; **FLOATING
C8852 VDD.t721 VSS 0.03968f ; **FLOATING
C8853 VDD.t722 VSS 0.03968f ; **FLOATING
C8854 VDD.t850 VSS 0.03968f ; **FLOATING
C8855 VDD.t891 VSS 0.03968f ; **FLOATING
C8856 VDD.t599 VSS 0.03968f ; **FLOATING
C8857 VDD.t1155 VSS 0.03968f ; **FLOATING
C8858 VDD.n1112 VSS 0.0909f ; **FLOATING
C8859 VDD.t882 VSS 0.03968f ; **FLOATING
C8860 VDD.t889 VSS 0.03968f ; **FLOATING
C8861 VDD.t1357 VSS 0.03968f ; **FLOATING
C8862 VDD.t922 VSS 0.03968f ; **FLOATING
C8863 VDD.t881 VSS 0.03968f ; **FLOATING
C8864 VDD.t1329 VSS 0.03968f ; **FLOATING
C8865 VDD.t1330 VSS 0.03968f ; **FLOATING
C8866 VDD.t1467 VSS 0.03968f ; **FLOATING
C8867 VDD.t1469 VSS 0.03968f ; **FLOATING
C8868 VDD.t1475 VSS 0.03968f ; **FLOATING
C8869 VDD.n1113 VSS 0.09407f ; **FLOATING
C8870 VDD.n1114 VSS 0.09336f ; **FLOATING
C8871 VDD.n1115 VSS 0.09335f ; **FLOATING
C8872 VDD.n1116 VSS 0.09335f ; **FLOATING
C8873 VDD.n1117 VSS 0.06285f ; **FLOATING
C8874 VDD.n1118 VSS 0.01471f ; **FLOATING
C8875 VDD.n1119 VSS 0.08261f ; **FLOATING
C8876 VDD.n1120 VSS 0.08263f ; **FLOATING
C8877 VDD.n1121 VSS 0.0629f ; **FLOATING
C8878 VDD.n1122 VSS 0.01471f ; **FLOATING
C8879 VDD.n1123 VSS 0.08264f ; **FLOATING
C8880 VDD.n1124 VSS 0.08361f ; **FLOATING
C8881 VDD.n1125 VSS 0.08025f ; **FLOATING
C8882 VDD.n1126 VSS 0.01471f ; **FLOATING
C8883 VDD.n1127 VSS 0.08262f ; **FLOATING
C8884 VDD.n1128 VSS 0.0629f ; **FLOATING
C8885 VDD.n1129 VSS 0.01471f ; **FLOATING
C8886 VDD.n1130 VSS 0.08264f ; **FLOATING
C8887 VDD.n1131 VSS 0.09336f ; **FLOATING
C8888 VDD.n1132 VSS 0.07396f ; **FLOATING
C8889 VDD.n1134 VSS 0.04832f ; **FLOATING
C8890 VDD.n1135 VSS 0.02687f ; **FLOATING
C8891 VDD.n1136 VSS 0.09201f ; **FLOATING
C8892 VDD.n1137 VSS 0.05144f ; **FLOATING
C8893 VDD.n1138 VSS 0.11117f ; **FLOATING
C8894 VDD.n1139 VSS 0.05144f ; **FLOATING
C8895 VDD.n1140 VSS 0.11117f ; **FLOATING
C8896 VDD.n1141 VSS 0.05144f ; **FLOATING
C8897 VDD.n1142 VSS 0.11117f ; **FLOATING
C8898 VDD.n1143 VSS 0.05144f ; **FLOATING
C8899 VDD.n1144 VSS 0.11117f ; **FLOATING
C8900 VDD.n1145 VSS 0.05144f ; **FLOATING
C8901 VDD.n1146 VSS 0.11117f ; **FLOATING
C8902 VDD.n1147 VSS 0.05144f ; **FLOATING
C8903 VDD.n1148 VSS 0.11117f ; **FLOATING
C8904 VDD.n1149 VSS 0.049f ; **FLOATING
C8905 VDD.n1150 VSS 0.11117f ; **FLOATING
C8906 VDD.n1151 VSS 0.05144f ; **FLOATING
C8907 VDD.n1152 VSS 0.11117f ; **FLOATING
C8908 VDD.n1153 VSS 0.05144f ; **FLOATING
C8909 VDD.n1154 VSS 0.11117f ; **FLOATING
C8910 VDD.n1155 VSS 0.05144f ; **FLOATING
C8911 VDD.n1156 VSS 0.11117f ; **FLOATING
C8912 VDD.n1157 VSS 0.05144f ; **FLOATING
C8913 VDD.n1158 VSS 0.11117f ; **FLOATING
C8914 VDD.n1159 VSS 0.05144f ; **FLOATING
C8915 VDD.n1160 VSS 0.11117f ; **FLOATING
C8916 VDD.n1161 VSS 0.05144f ; **FLOATING
C8917 VDD.n1162 VSS 0.11117f ; **FLOATING
C8918 VDD.n1163 VSS 0.05144f ; **FLOATING
C8919 VDD.n1164 VSS 0.11117f ; **FLOATING
C8920 VDD.n1165 VSS 0.05144f ; **FLOATING
C8921 VDD.n1166 VSS 0.11117f ; **FLOATING
C8922 VDD.n1167 VSS 0.05144f ; **FLOATING
C8923 VDD.n1168 VSS 0.11117f ; **FLOATING
C8924 VDD.n1169 VSS 0.05144f ; **FLOATING
C8925 VDD.n1170 VSS 0.11117f ; **FLOATING
C8926 VDD.n1171 VSS 0.05144f ; **FLOATING
C8927 VDD.n1172 VSS 0.11117f ; **FLOATING
C8928 VDD.n1173 VSS 0.05144f ; **FLOATING
C8929 VDD.n1174 VSS 0.07184f ; **FLOATING
C8930 VDD.n1176 VSS 0.08368f ; **FLOATING
C8931 VDD.n1177 VSS 0.04257f ; **FLOATING
C8932 VDD.n1178 VSS 0.10168f ; **FLOATING
C8933 VDD.n1179 VSS 0.05144f ; **FLOATING
C8934 VDD.n1180 VSS 0.11117f ; **FLOATING
C8935 VDD.n1181 VSS 0.05144f ; **FLOATING
C8936 VDD.n1182 VSS 0.11117f ; **FLOATING
C8937 VDD.n1183 VSS 0.05144f ; **FLOATING
C8938 VDD.n1184 VSS 0.11117f ; **FLOATING
C8939 VDD.n1185 VSS 0.05144f ; **FLOATING
C8940 VDD.n1186 VSS 0.11117f ; **FLOATING
C8941 VDD.n1187 VSS 0.05144f ; **FLOATING
C8942 VDD.n1188 VSS 0.11117f ; **FLOATING
C8943 VDD.n1189 VSS 0.05144f ; **FLOATING
C8944 VDD.n1190 VSS 0.11117f ; **FLOATING
C8945 VDD.n1191 VSS 0.05144f ; **FLOATING
C8946 VDD.n1192 VSS 0.11117f ; **FLOATING
C8947 VDD.n1193 VSS 0.05144f ; **FLOATING
C8948 VDD.t441 VSS 0.01992f ; **FLOATING
C8949 VDD.t439 VSS 0.03858f ; **FLOATING
C8950 VDD.t1550 VSS 0.03503f ; **FLOATING
C8951 VDD.t419 VSS 0.03503f ; **FLOATING
C8952 VDD.t342 VSS 0.03145f ; **FLOATING
C8953 VDD.t1397 VSS 0.03503f ; **FLOATING
C8954 VDD.n1194 VSS 0.06389f ; **FLOATING
C8955 VDD.n1195 VSS 0.01359f ; **FLOATING
C8956 VDD.n1196 VSS 0.02892f ; **FLOATING
C8957 VDD.t823 VSS 0.04597f ; **FLOATING
C8958 VDD.n1197 VSS 0.08818f ; **FLOATING
C8959 VDD.n1198 VSS 0.02579f ; **FLOATING
C8960 VDD.t920 VSS 0.03503f ; **FLOATING
C8961 VDD.n1199 VSS 0.0931f ; **FLOATING
C8962 VDD.n1200 VSS 0.01227f ; **FLOATING
C8963 VDD.n1201 VSS 0.01279f ; **FLOATING
C8964 VDD.t1386 VSS 0.03904f ; **FLOATING
C8965 VDD.t634 VSS 0.03904f ; **FLOATING
C8966 VDD.n1202 VSS 0.08386f ; **FLOATING
C8967 VDD.n1203 VSS 0.01231f ; **FLOATING
C8968 VDD.n1204 VSS 0.01296f ; **FLOATING
C8969 VDD.t1338 VSS 0.03904f ; **FLOATING
C8970 VDD.t840 VSS 0.03904f ; **FLOATING
C8971 VDD.n1205 VSS 0.08323f ; **FLOATING
C8972 VDD.n1206 VSS 0.01237f ; **FLOATING
C8973 VDD.t1558 VSS 0.03503f ; **FLOATING
C8974 VDD.t609 VSS 0.03503f ; **FLOATING
C8975 VDD.t952 VSS 0.02587f ; **FLOATING
C8976 VDD.t858 VSS 0.02587f ; **FLOATING
C8977 VDD.n1207 VSS 0.08393f ; **FLOATING
C8978 VDD.t602 VSS 0.03458f ; **FLOATING
C8979 VDD.t801 VSS 0.03458f ; **FLOATING
C8980 VDD.n1208 VSS 0.06951f ; **FLOATING
C8981 VDD.n1209 VSS 0.01712f ; **FLOATING
C8982 VDD.t1551 VSS 0.02587f ; **FLOATING
C8983 VDD.t417 VSS 0.02587f ; **FLOATING
C8984 VDD.n1210 VSS 0.06926f ; **FLOATING
C8985 VDD.t603 VSS 0.03458f ; **FLOATING
C8986 VDD.t633 VSS 0.03458f ; **FLOATING
C8987 VDD.n1211 VSS 0.07416f ; **FLOATING
C8988 VDD.n1212 VSS 0.01249f ; **FLOATING
C8989 VDD.t1559 VSS 0.02587f ; **FLOATING
C8990 VDD.t608 VSS 0.02587f ; **FLOATING
C8991 VDD.n1213 VSS 0.06903f ; **FLOATING
C8992 VDD.n1214 VSS 0.01204f ; **FLOATING
C8993 VDD.t382 VSS 0.03458f ; **FLOATING
C8994 VDD.t740 VSS 0.03458f ; **FLOATING
C8995 VDD.n1215 VSS 0.06998f ; **FLOATING
C8996 VDD.n1216 VSS 0.01709f ; **FLOATING
C8997 VDD.t383 VSS 0.03904f ; **FLOATING
C8998 VDD.t741 VSS 0.03904f ; **FLOATING
C8999 VDD.n1217 VSS 0.07822f ; **FLOATING
C9000 VDD.t1549 VSS 0.02587f ; **FLOATING
C9001 VDD.t418 VSS 0.02587f ; **FLOATING
C9002 VDD.n1218 VSS 0.06966f ; **FLOATING
C9003 VDD.n1219 VSS 0.01274f ; **FLOATING
C9004 VDD.t854 VSS 0.03458f ; **FLOATING
C9005 VDD.t610 VSS 0.03458f ; **FLOATING
C9006 VDD.n1220 VSS 0.07417f ; **FLOATING
C9007 VDD.t855 VSS 0.03904f ; **FLOATING
C9008 VDD.t834 VSS 0.03904f ; **FLOATING
C9009 VDD.n1221 VSS 0.0125f ; **FLOATING
C9010 VDD.t1387 VSS 0.03503f ; **FLOATING
C9011 VDD.t1255 VSS 0.03515f ; **FLOATING
C9012 VDD.t1234 VSS 0.03503f ; **FLOATING
C9013 VDD.n1222 VSS 0.07338f ; **FLOATING
C9014 VDD.n1223 VSS 0.01378f ; **FLOATING
C9015 VDD.t1472 VSS 0.03503f ; **FLOATING
C9016 VDD.n1224 VSS 0.06362f ; **FLOATING
C9017 VDD.t692 VSS 0.03503f ; **FLOATING
C9018 VDD.n1225 VSS 0.05375f ; **FLOATING
C9019 VDD.n1226 VSS 0.01946f ; **FLOATING
C9020 VDD.t1542 VSS 0.03503f ; **FLOATING
C9021 VDD.t92 VSS 0.03145f ; **FLOATING
C9022 VDD.t59 VSS 0.03145f ; **FLOATING
C9023 VDD.t1353 VSS 0.03503f ; **FLOATING
C9024 VDD.t93 VSS 0.03376f ; **FLOATING
C9025 VDD.t1689 VSS 0.11617f ; **FLOATING
C9026 VDD.t728 VSS 0.04597f ; **FLOATING
C9027 VDD.t60 VSS 0.03376f ; **FLOATING
C9028 VDD.t1688 VSS 0.11617f ; **FLOATING
C9029 VDD.n1227 VSS 0.14218f ; **FLOATING
C9030 VDD.n1228 VSS 0.08876f ; **FLOATING
C9031 VDD.t1233 VSS 0.03503f ; **FLOATING
C9032 VDD.t121 VSS 0.03145f ; **FLOATING
C9033 VDD.t157 VSS 0.03145f ; **FLOATING
C9034 VDD.t160 VSS 0.03145f ; **FLOATING
C9035 VDD.t1166 VSS 0.03503f ; **FLOATING
C9036 VDD.t1332 VSS 0.03503f ; **FLOATING
C9037 VDD.t684 VSS 0.03503f ; **FLOATING
C9038 VDD.t1401 VSS 0.03503f ; **FLOATING
C9039 VDD.t3 VSS 0.03145f ; **FLOATING
C9040 VDD.t923 VSS 0.04597f ; **FLOATING
C9041 VDD.t1219 VSS 0.03503f ; **FLOATING
C9042 VDD.t6 VSS 0.03145f ; **FLOATING
C9043 VDD.t1359 VSS 0.03503f ; **FLOATING
C9044 VDD.t134 VSS 0.03145f ; **FLOATING
C9045 VDD.t1223 VSS 0.03503f ; **FLOATING
C9046 VDD.t75 VSS 0.03145f ; **FLOATING
C9047 VDD.t76 VSS 0.03145f ; **FLOATING
C9048 VDD.t890 VSS 0.04614f ; **FLOATING
C9049 VDD.n1229 VSS 0.01946f ; **FLOATING
C9050 VDD.t883 VSS 0.03503f ; **FLOATING
C9051 VDD.n1230 VSS 0.06362f ; **FLOATING
C9052 VDD.n1231 VSS 0.01378f ; **FLOATING
C9053 VDD.t79 VSS 0.03145f ; **FLOATING
C9054 VDD.n1232 VSS 0.05434f ; **FLOATING
C9055 VDD.t1167 VSS 0.03503f ; **FLOATING
C9056 VDD.n1233 VSS 0.0532f ; **FLOATING
C9057 VDD.t691 VSS 0.03503f ; **FLOATING
C9058 VDD.n1235 VSS 0.05375f ; **FLOATING
C9059 VDD.n1236 VSS 0.01359f ; **FLOATING
C9060 VDD.t1402 VSS 0.03503f ; **FLOATING
C9061 VDD.n1237 VSS 0.06417f ; **FLOATING
C9062 VDD.t57 VSS 0.03145f ; **FLOATING
C9063 VDD.t1156 VSS 0.04597f ; **FLOATING
C9064 VDD.t119 VSS 0.03145f ; **FLOATING
C9065 VDD.t1544 VSS 0.03503f ; **FLOATING
C9066 VDD.t70 VSS 0.03145f ; **FLOATING
C9067 VDD.t600 VSS 0.03503f ; **FLOATING
C9068 VDD.t1235 VSS 0.03503f ; **FLOATING
C9069 VDD.t82 VSS 0.03145f ; **FLOATING
C9070 VDD.t83 VSS 0.03145f ; **FLOATING
C9071 VDD.t148 VSS 0.03145f ; **FLOATING
C9072 VDD.t1398 VSS 0.03503f ; **FLOATING
C9073 VDD.t1610 VSS 0.03503f ; **FLOATING
C9074 VDD.t1520 VSS 0.03503f ; **FLOATING
C9075 VDD.t1224 VSS 0.03503f ; **FLOATING
C9076 VDD.t723 VSS 0.04597f ; **FLOATING
C9077 VDD.t1546 VSS 0.03503f ; **FLOATING
C9078 VDD.t817 VSS 0.03503f ; **FLOATING
C9079 VDD.t707 VSS 0.03503f ; **FLOATING
C9080 VDD.t921 VSS 0.03503f ; **FLOATING
C9081 VDD.t651 VSS 0.03719f ; **FLOATING
C9082 VDD.t1412 VSS 0.04597f ; **FLOATING
C9083 VDD.t652 VSS 0.06567f ; **FLOATING
C9084 VDD.t1165 VSS 0.03503f ; **FLOATING
C9085 VDD.t641 VSS 0.03503f ; **FLOATING
C9086 VDD.t627 VSS 0.03503f ; **FLOATING
C9087 VDD.t1400 VSS 0.03503f ; **FLOATING
C9088 VDD.t80 VSS 0.03145f ; **FLOATING
C9089 VDD.t656 VSS 0.04597f ; **FLOATING
C9090 VDD.t1220 VSS 0.03503f ; **FLOATING
C9091 VDD.t73 VSS 0.03145f ; **FLOATING
C9092 VDD.t643 VSS 0.03503f ; **FLOATING
C9093 VDD.t161 VSS 0.03145f ; **FLOATING
C9094 VDD.t1222 VSS 0.03503f ; **FLOATING
C9095 VDD.t117 VSS 0.03145f ; **FLOATING
C9096 VDD.t88 VSS 0.03145f ; **FLOATING
C9097 VDD.t1372 VSS 0.04614f ; **FLOATING
C9098 VDD.n1238 VSS 0.01946f ; **FLOATING
C9099 VDD.t1592 VSS 0.03503f ; **FLOATING
C9100 VDD.n1239 VSS 0.06362f ; **FLOATING
C9101 VDD.n1240 VSS 0.01378f ; **FLOATING
C9102 VDD.t91 VSS 0.03145f ; **FLOATING
C9103 VDD.t1168 VSS 0.03503f ; **FLOATING
C9104 VDD.n1241 VSS 0.0532f ; **FLOATING
C9105 VDD.t685 VSS 0.03503f ; **FLOATING
C9106 VDD.n1243 VSS 0.05375f ; **FLOATING
C9107 VDD.n1244 VSS 0.01359f ; **FLOATING
C9108 VDD.t1403 VSS 0.03503f ; **FLOATING
C9109 VDD.n1245 VSS 0.06389f ; **FLOATING
C9110 VDD.t312 VSS 0.03145f ; **FLOATING
C9111 VDD.t556 VSS 0.04597f ; **FLOATING
C9112 VDD.t309 VSS 0.03145f ; **FLOATING
C9113 VDD.t1545 VSS 0.03503f ; **FLOATING
C9114 VDD.t319 VSS 0.03145f ; **FLOATING
C9115 VDD.t852 VSS 0.03503f ; **FLOATING
C9116 VDD.t1236 VSS 0.03503f ; **FLOATING
C9117 VDD.t311 VSS 0.03145f ; **FLOATING
C9118 VDD.t315 VSS 0.03145f ; **FLOATING
C9119 VDD.t321 VSS 0.03145f ; **FLOATING
C9120 VDD.t1399 VSS 0.03503f ; **FLOATING
C9121 VDD.t930 VSS 0.03503f ; **FLOATING
C9122 VDD.t1548 VSS 0.03503f ; **FLOATING
C9123 VDD.t1225 VSS 0.03503f ; **FLOATING
C9124 VDD.t313 VSS 0.03145f ; **FLOATING
C9125 VDD.t558 VSS 0.04597f ; **FLOATING
C9126 VDD.t1547 VSS 0.03503f ; **FLOATING
C9127 VDD.t318 VSS 0.03145f ; **FLOATING
C9128 VDD.t1597 VSS 0.03503f ; **FLOATING
C9129 VDD.t7 VSS 0.03145f ; **FLOATING
C9130 VDD.t1232 VSS 0.03503f ; **FLOATING
C9131 VDD.t302 VSS 0.03145f ; **FLOATING
C9132 VDD.t303 VSS 0.03145f ; **FLOATING
C9133 VDD.t934 VSS 0.04614f ; **FLOATING
C9134 VDD.n1246 VSS 0.01946f ; **FLOATING
C9135 VDD.t937 VSS 0.03503f ; **FLOATING
C9136 VDD.n1247 VSS 0.06362f ; **FLOATING
C9137 VDD.n1248 VSS 0.01378f ; **FLOATING
C9138 VDD.t306 VSS 0.03145f ; **FLOATING
C9139 VDD.t900 VSS 0.03503f ; **FLOATING
C9140 VDD.n1249 VSS 0.0532f ; **FLOATING
C9141 VDD.t1307 VSS 0.03503f ; **FLOATING
C9142 VDD.n1251 VSS 0.05375f ; **FLOATING
C9143 VDD.n1252 VSS 0.01359f ; **FLOATING
C9144 VDD.t1396 VSS 0.03503f ; **FLOATING
C9145 VDD.n1253 VSS 0.06373f ; **FLOATING
C9146 VDD.n1254 VSS 0.02579f ; **FLOATING
C9147 VDD.t938 VSS 0.04597f ; **FLOATING
C9148 VDD.n1255 VSS 0.0935f ; **FLOATING
C9149 VDD.t1543 VSS 0.0384f ; **FLOATING
C9150 VDD.n1256 VSS 0.12463f ; **FLOATING
C9151 VDD.t304 VSS 0.03376f ; **FLOATING
C9152 VDD.t1672 VSS 0.11617f ; **FLOATING
C9153 VDD.n1257 VSS 0.14218f ; **FLOATING
C9154 VDD.t8 VSS 0.03376f ; **FLOATING
C9155 VDD.t1673 VSS 0.11617f ; **FLOATING
C9156 VDD.n1258 VSS 0.14218f ; **FLOATING
C9157 VDD.n1259 VSS 0.08876f ; **FLOATING
C9158 VDD.t314 VSS 0.03376f ; **FLOATING
C9159 VDD.t1674 VSS 0.11617f ; **FLOATING
C9160 VDD.n1260 VSS 0.06389f ; **FLOATING
C9161 VDD.n1261 VSS 0.01359f ; **FLOATING
C9162 VDD.n1262 VSS 0.05375f ; **FLOATING
C9163 VDD.n1263 VSS 0.01946f ; **FLOATING
C9164 VDD.n1264 VSS 0.06362f ; **FLOATING
C9165 VDD.n1265 VSS 0.01378f ; **FLOATING
C9166 VDD.n1266 VSS 0.0532f ; **FLOATING
C9167 VDD.n1268 VSS 0.05434f ; **FLOATING
C9168 VDD.t1438 VSS 0.04614f ; **FLOATING
C9169 VDD.t316 VSS 0.03376f ; **FLOATING
C9170 VDD.t1675 VSS 0.11617f ; **FLOATING
C9171 VDD.n1269 VSS 0.14218f ; **FLOATING
C9172 VDD.n1270 VSS 0.12404f ; **FLOATING
C9173 VDD.t310 VSS 0.03376f ; **FLOATING
C9174 VDD.t1676 VSS 0.11617f ; **FLOATING
C9175 VDD.n1271 VSS 0.14218f ; **FLOATING
C9176 VDD.t308 VSS 0.03376f ; **FLOATING
C9177 VDD.t1677 VSS 0.11617f ; **FLOATING
C9178 VDD.t89 VSS 0.03376f ; **FLOATING
C9179 VDD.t1678 VSS 0.11617f ; **FLOATING
C9180 VDD.n1272 VSS 0.14218f ; **FLOATING
C9181 VDD.t116 VSS 0.03376f ; **FLOATING
C9182 VDD.t1679 VSS 0.11617f ; **FLOATING
C9183 VDD.n1273 VSS 0.14218f ; **FLOATING
C9184 VDD.n1274 VSS 0.08876f ; **FLOATING
C9185 VDD.t72 VSS 0.03376f ; **FLOATING
C9186 VDD.t1680 VSS 0.11617f ; **FLOATING
C9187 VDD.n1275 VSS 0.06389f ; **FLOATING
C9188 VDD.n1276 VSS 0.01359f ; **FLOATING
C9189 VDD.n1277 VSS 0.05375f ; **FLOATING
C9190 VDD.n1278 VSS 0.01946f ; **FLOATING
C9191 VDD.n1279 VSS 0.06362f ; **FLOATING
C9192 VDD.n1280 VSS 0.01378f ; **FLOATING
C9193 VDD.n1281 VSS 0.07803f ; **FLOATING
C9194 VDD.n1282 VSS 0.01181f ; **FLOATING
C9195 VDD.n1283 VSS 0.07514f ; **FLOATING
C9196 VDD.n1284 VSS 0.07338f ; **FLOATING
C9197 VDD.n1285 VSS 0.02892f ; **FLOATING
C9198 VDD.n1286 VSS 0.08818f ; **FLOATING
C9199 VDD.n1287 VSS 0.02579f ; **FLOATING
C9200 VDD.n1288 VSS 0.06373f ; **FLOATING
C9201 VDD.n1289 VSS 0.01359f ; **FLOATING
C9202 VDD.n1290 VSS 0.05375f ; **FLOATING
C9203 VDD.n1291 VSS 0.01946f ; **FLOATING
C9204 VDD.n1292 VSS 0.06362f ; **FLOATING
C9205 VDD.n1293 VSS 0.01378f ; **FLOATING
C9206 VDD.n1294 VSS 0.0532f ; **FLOATING
C9207 VDD.n1296 VSS 0.05434f ; **FLOATING
C9208 VDD.t1369 VSS 0.04614f ; **FLOATING
C9209 VDD.t84 VSS 0.03376f ; **FLOATING
C9210 VDD.t1681 VSS 0.11617f ; **FLOATING
C9211 VDD.n1297 VSS 0.14218f ; **FLOATING
C9212 VDD.n1298 VSS 0.12404f ; **FLOATING
C9213 VDD.t71 VSS 0.03376f ; **FLOATING
C9214 VDD.t1682 VSS 0.11617f ; **FLOATING
C9215 VDD.n1299 VSS 0.14218f ; **FLOATING
C9216 VDD.t58 VSS 0.03376f ; **FLOATING
C9217 VDD.t1683 VSS 0.11617f ; **FLOATING
C9218 VDD.t77 VSS 0.03376f ; **FLOATING
C9219 VDD.t1684 VSS 0.11617f ; **FLOATING
C9220 VDD.n1300 VSS 0.14218f ; **FLOATING
C9221 VDD.t74 VSS 0.03376f ; **FLOATING
C9222 VDD.t1685 VSS 0.11617f ; **FLOATING
C9223 VDD.n1301 VSS 0.14218f ; **FLOATING
C9224 VDD.n1302 VSS 0.08876f ; **FLOATING
C9225 VDD.t4 VSS 0.03376f ; **FLOATING
C9226 VDD.t1686 VSS 0.11617f ; **FLOATING
C9227 VDD.n1303 VSS 0.06389f ; **FLOATING
C9228 VDD.n1304 VSS 0.01359f ; **FLOATING
C9229 VDD.n1305 VSS 0.05375f ; **FLOATING
C9230 VDD.n1306 VSS 0.01946f ; **FLOATING
C9231 VDD.n1307 VSS 0.06362f ; **FLOATING
C9232 VDD.n1308 VSS 0.01378f ; **FLOATING
C9233 VDD.n1309 VSS 0.0532f ; **FLOATING
C9234 VDD.n1311 VSS 0.05434f ; **FLOATING
C9235 VDD.t1348 VSS 0.04614f ; **FLOATING
C9236 VDD.t158 VSS 0.03376f ; **FLOATING
C9237 VDD.t1687 VSS 0.11617f ; **FLOATING
C9238 VDD.n1312 VSS 0.14218f ; **FLOATING
C9239 VDD.n1313 VSS 0.12404f ; **FLOATING
C9240 VDD.n1314 VSS 0.68722f ; **FLOATING
C9241 VDD.t1431 VSS 0.03503f ; **FLOATING
C9242 VDD.t1213 VSS 0.03503f ; **FLOATING
C9243 VDD.t107 VSS 0.03145f ; **FLOATING
C9244 VDD.t1228 VSS 0.03503f ; **FLOATING
C9245 VDD.n1315 VSS 0.06389f ; **FLOATING
C9246 VDD.n1316 VSS 0.01359f ; **FLOATING
C9247 VDD.n1317 VSS 0.02892f ; **FLOATING
C9248 VDD.t564 VSS 0.04597f ; **FLOATING
C9249 VDD.n1318 VSS 0.08818f ; **FLOATING
C9250 VDD.n1319 VSS 0.02579f ; **FLOATING
C9251 VDD.t588 VSS 0.03503f ; **FLOATING
C9252 VDD.n1320 VSS 0.0931f ; **FLOATING
C9253 VDD.n1321 VSS 0.01227f ; **FLOATING
C9254 VDD.n1322 VSS 0.01279f ; **FLOATING
C9255 VDD.t390 VSS 0.03904f ; **FLOATING
C9256 VDD.t616 VSS 0.03904f ; **FLOATING
C9257 VDD.n1323 VSS 0.08386f ; **FLOATING
C9258 VDD.n1324 VSS 0.01231f ; **FLOATING
C9259 VDD.n1325 VSS 0.01296f ; **FLOATING
C9260 VDD.t1183 VSS 0.03904f ; **FLOATING
C9261 VDD.t1567 VSS 0.03904f ; **FLOATING
C9262 VDD.n1326 VSS 0.08323f ; **FLOATING
C9263 VDD.n1327 VSS 0.01237f ; **FLOATING
C9264 VDD.t1479 VSS 0.03503f ; **FLOATING
C9265 VDD.t1203 VSS 0.03503f ; **FLOATING
C9266 VDD.t703 VSS 0.02587f ; **FLOATING
C9267 VDD.t1577 VSS 0.02587f ; **FLOATING
C9268 VDD.n1328 VSS 0.08393f ; **FLOATING
C9269 VDD.t632 VSS 0.03458f ; **FLOATING
C9270 VDD.t629 VSS 0.03458f ; **FLOATING
C9271 VDD.n1329 VSS 0.06951f ; **FLOATING
C9272 VDD.n1330 VSS 0.01712f ; **FLOATING
C9273 VDD.t1430 VSS 0.02587f ; **FLOATING
C9274 VDD.t1211 VSS 0.02587f ; **FLOATING
C9275 VDD.n1331 VSS 0.06926f ; **FLOATING
C9276 VDD.t389 VSS 0.03458f ; **FLOATING
C9277 VDD.t615 VSS 0.03458f ; **FLOATING
C9278 VDD.n1332 VSS 0.07416f ; **FLOATING
C9279 VDD.n1333 VSS 0.01249f ; **FLOATING
C9280 VDD.t1481 VSS 0.02587f ; **FLOATING
C9281 VDD.t1202 VSS 0.02587f ; **FLOATING
C9282 VDD.n1334 VSS 0.06903f ; **FLOATING
C9283 VDD.n1335 VSS 0.01204f ; **FLOATING
C9284 VDD.t704 VSS 0.03458f ; **FLOATING
C9285 VDD.t351 VSS 0.03458f ; **FLOATING
C9286 VDD.n1336 VSS 0.06998f ; **FLOATING
C9287 VDD.n1337 VSS 0.01709f ; **FLOATING
C9288 VDD.t1503 VSS 0.03904f ; **FLOATING
C9289 VDD.t352 VSS 0.03904f ; **FLOATING
C9290 VDD.n1338 VSS 0.07822f ; **FLOATING
C9291 VDD.t1432 VSS 0.02587f ; **FLOATING
C9292 VDD.t1212 VSS 0.02587f ; **FLOATING
C9293 VDD.n1339 VSS 0.06966f ; **FLOATING
C9294 VDD.n1340 VSS 0.01274f ; **FLOATING
C9295 VDD.t1289 VSS 0.03458f ; **FLOATING
C9296 VDD.t1204 VSS 0.03458f ; **FLOATING
C9297 VDD.n1341 VSS 0.07417f ; **FLOATING
C9298 VDD.t1290 VSS 0.03904f ; **FLOATING
C9299 VDD.t1251 VSS 0.03904f ; **FLOATING
C9300 VDD.n1342 VSS 0.0125f ; **FLOATING
C9301 VDD.t1248 VSS 0.03503f ; **FLOATING
C9302 VDD.t421 VSS 0.03515f ; **FLOATING
C9303 VDD.t592 VSS 0.03503f ; **FLOATING
C9304 VDD.n1343 VSS 0.07338f ; **FLOATING
C9305 VDD.n1344 VSS 0.01378f ; **FLOATING
C9306 VDD.t1445 VSS 0.03503f ; **FLOATING
C9307 VDD.n1345 VSS 0.06362f ; **FLOATING
C9308 VDD.t406 VSS 0.03503f ; **FLOATING
C9309 VDD.n1346 VSS 0.05375f ; **FLOATING
C9310 VDD.n1347 VSS 0.01946f ; **FLOATING
C9311 VDD.t593 VSS 0.03503f ; **FLOATING
C9312 VDD.t205 VSS 0.03145f ; **FLOATING
C9313 VDD.t260 VSS 0.03145f ; **FLOATING
C9314 VDD.t1477 VSS 0.03503f ; **FLOATING
C9315 VDD.t108 VSS 0.03376f ; **FLOATING
C9316 VDD.t1635 VSS 0.11617f ; **FLOATING
C9317 VDD.t422 VSS 0.04597f ; **FLOATING
C9318 VDD.t208 VSS 0.03376f ; **FLOATING
C9319 VDD.t1634 VSS 0.11617f ; **FLOATING
C9320 VDD.n1348 VSS 0.14218f ; **FLOATING
C9321 VDD.n1349 VSS 0.08876f ; **FLOATING
C9322 VDD.t1309 VSS 0.03503f ; **FLOATING
C9323 VDD.t209 VSS 0.03145f ; **FLOATING
C9324 VDD.t279 VSS 0.03145f ; **FLOATING
C9325 VDD.t282 VSS 0.03145f ; **FLOATING
C9326 VDD.t582 VSS 0.03503f ; **FLOATING
C9327 VDD.t1191 VSS 0.03503f ; **FLOATING
C9328 VDD.t1339 VSS 0.03503f ; **FLOATING
C9329 VDD.t575 VSS 0.03503f ; **FLOATING
C9330 VDD.t265 VSS 0.03145f ; **FLOATING
C9331 VDD.t1190 VSS 0.04597f ; **FLOATING
C9332 VDD.t1231 VSS 0.03503f ; **FLOATING
C9333 VDD.t189 VSS 0.03145f ; **FLOATING
C9334 VDD.t522 VSS 0.03503f ; **FLOATING
C9335 VDD.t206 VSS 0.03145f ; **FLOATING
C9336 VDD.t591 VSS 0.03503f ; **FLOATING
C9337 VDD.t264 VSS 0.03145f ; **FLOATING
C9338 VDD.t266 VSS 0.03145f ; **FLOATING
C9339 VDD.t1259 VSS 0.04614f ; **FLOATING
C9340 VDD.n1350 VSS 0.01946f ; **FLOATING
C9341 VDD.t1364 VSS 0.03503f ; **FLOATING
C9342 VDD.n1351 VSS 0.06362f ; **FLOATING
C9343 VDD.n1352 VSS 0.01378f ; **FLOATING
C9344 VDD.t269 VSS 0.03145f ; **FLOATING
C9345 VDD.n1353 VSS 0.05434f ; **FLOATING
C9346 VDD.t583 VSS 0.03503f ; **FLOATING
C9347 VDD.n1354 VSS 0.0532f ; **FLOATING
C9348 VDD.t617 VSS 0.03503f ; **FLOATING
C9349 VDD.n1356 VSS 0.05375f ; **FLOATING
C9350 VDD.n1357 VSS 0.01359f ; **FLOATING
C9351 VDD.t576 VSS 0.03503f ; **FLOATING
C9352 VDD.n1358 VSS 0.06417f ; **FLOATING
C9353 VDD.t183 VSS 0.03145f ; **FLOATING
C9354 VDD.t650 VSS 0.04597f ; **FLOATING
C9355 VDD.t271 VSS 0.03145f ; **FLOATING
C9356 VDD.t595 VSS 0.03503f ; **FLOATING
C9357 VDD.t278 VSS 0.03145f ; **FLOATING
C9358 VDD.t820 VSS 0.03503f ; **FLOATING
C9359 VDD.t586 VSS 0.03503f ; **FLOATING
C9360 VDD.t273 VSS 0.03145f ; **FLOATING
C9361 VDD.t274 VSS 0.03145f ; **FLOATING
C9362 VDD.t277 VSS 0.03145f ; **FLOATING
C9363 VDD.t1229 VSS 0.03503f ; **FLOATING
C9364 VDD.t1375 VSS 0.03503f ; **FLOATING
C9365 VDD.t618 VSS 0.03503f ; **FLOATING
C9366 VDD.t578 VSS 0.03503f ; **FLOATING
C9367 VDD.t925 VSS 0.04597f ; **FLOATING
C9368 VDD.t597 VSS 0.03503f ; **FLOATING
C9369 VDD.t1160 VSS 0.03503f ; **FLOATING
C9370 VDD.t1158 VSS 0.03503f ; **FLOATING
C9371 VDD.t589 VSS 0.03503f ; **FLOATING
C9372 VDD.t630 VSS 0.03719f ; **FLOATING
C9373 VDD.t562 VSS 0.04597f ; **FLOATING
C9374 VDD.t1270 VSS 0.06567f ; **FLOATING
C9375 VDD.t581 VSS 0.03503f ; **FLOATING
C9376 VDD.t724 VSS 0.03503f ; **FLOATING
C9377 VDD.t407 VSS 0.03503f ; **FLOATING
C9378 VDD.t574 VSS 0.03503f ; **FLOATING
C9379 VDD.t307 VSS 0.03145f ; **FLOATING
C9380 VDD.t802 VSS 0.04597f ; **FLOATING
C9381 VDD.t864 VSS 0.03503f ; **FLOATING
C9382 VDD.t156 VSS 0.03145f ; **FLOATING
C9383 VDD.t932 VSS 0.03503f ; **FLOATING
C9384 VDD.t149 VSS 0.03145f ; **FLOATING
C9385 VDD.t590 VSS 0.03503f ; **FLOATING
C9386 VDD.t163 VSS 0.03145f ; **FLOATING
C9387 VDD.t151 VSS 0.03145f ; **FLOATING
C9388 VDD.t620 VSS 0.04614f ; **FLOATING
C9389 VDD.n1359 VSS 0.01946f ; **FLOATING
C9390 VDD.t1296 VSS 0.03503f ; **FLOATING
C9391 VDD.n1360 VSS 0.06362f ; **FLOATING
C9392 VDD.n1361 VSS 0.01378f ; **FLOATING
C9393 VDD.t154 VSS 0.03145f ; **FLOATING
C9394 VDD.t1226 VSS 0.03503f ; **FLOATING
C9395 VDD.n1362 VSS 0.0532f ; **FLOATING
C9396 VDD.t1340 VSS 0.03503f ; **FLOATING
C9397 VDD.n1364 VSS 0.05375f ; **FLOATING
C9398 VDD.n1365 VSS 0.01359f ; **FLOATING
C9399 VDD.t577 VSS 0.03503f ; **FLOATING
C9400 VDD.n1366 VSS 0.06389f ; **FLOATING
C9401 VDD.t170 VSS 0.03145f ; **FLOATING
C9402 VDD.t808 VSS 0.04597f ; **FLOATING
C9403 VDD.t169 VSS 0.03145f ; **FLOATING
C9404 VDD.t596 VSS 0.03503f ; **FLOATING
C9405 VDD.t171 VSS 0.03145f ; **FLOATING
C9406 VDD.t527 VSS 0.03503f ; **FLOATING
C9407 VDD.t587 VSS 0.03503f ; **FLOATING
C9408 VDD.t288 VSS 0.03145f ; **FLOATING
C9409 VDD.t166 VSS 0.03145f ; **FLOATING
C9410 VDD.t204 VSS 0.03145f ; **FLOATING
C9411 VDD.t1230 VSS 0.03503f ; **FLOATING
C9412 VDD.t1540 VSS 0.03503f ; **FLOATING
C9413 VDD.t1341 VSS 0.03503f ; **FLOATING
C9414 VDD.t579 VSS 0.03503f ; **FLOATING
C9415 VDD.t105 VSS 0.03145f ; **FLOATING
C9416 VDD.t942 VSS 0.04597f ; **FLOATING
C9417 VDD.t598 VSS 0.03503f ; **FLOATING
C9418 VDD.t1617 VSS 0.03145f ; **FLOATING
C9419 VDD.t1380 VSS 0.03503f ; **FLOATING
C9420 VDD.t68 VSS 0.03145f ; **FLOATING
C9421 VDD.t1308 VSS 0.03503f ; **FLOATING
C9422 VDD.t110 VSS 0.03145f ; **FLOATING
C9423 VDD.t111 VSS 0.03145f ; **FLOATING
C9424 VDD.t423 VSS 0.04614f ; **FLOATING
C9425 VDD.n1367 VSS 0.01946f ; **FLOATING
C9426 VDD.t1135 VSS 0.03503f ; **FLOATING
C9427 VDD.n1368 VSS 0.06362f ; **FLOATING
C9428 VDD.n1369 VSS 0.01378f ; **FLOATING
C9429 VDD.t114 VSS 0.03145f ; **FLOATING
C9430 VDD.t1327 VSS 0.03503f ; **FLOATING
C9431 VDD.n1370 VSS 0.0532f ; **FLOATING
C9432 VDD.t1157 VSS 0.03503f ; **FLOATING
C9433 VDD.n1372 VSS 0.05375f ; **FLOATING
C9434 VDD.n1373 VSS 0.01359f ; **FLOATING
C9435 VDD.t1227 VSS 0.03503f ; **FLOATING
C9436 VDD.n1374 VSS 0.06373f ; **FLOATING
C9437 VDD.n1375 VSS 0.02579f ; **FLOATING
C9438 VDD.t397 VSS 0.04597f ; **FLOATING
C9439 VDD.n1376 VSS 0.0935f ; **FLOATING
C9440 VDD.t594 VSS 0.0384f ; **FLOATING
C9441 VDD.n1377 VSS 0.12463f ; **FLOATING
C9442 VDD.t112 VSS 0.03376f ; **FLOATING
C9443 VDD.t1618 VSS 0.11617f ; **FLOATING
C9444 VDD.n1378 VSS 0.14218f ; **FLOATING
C9445 VDD.t69 VSS 0.03376f ; **FLOATING
C9446 VDD.t1619 VSS 0.11617f ; **FLOATING
C9447 VDD.n1379 VSS 0.14218f ; **FLOATING
C9448 VDD.n1380 VSS 0.08876f ; **FLOATING
C9449 VDD.t106 VSS 0.03376f ; **FLOATING
C9450 VDD.t1620 VSS 0.11617f ; **FLOATING
C9451 VDD.n1381 VSS 0.06389f ; **FLOATING
C9452 VDD.n1382 VSS 0.01359f ; **FLOATING
C9453 VDD.n1383 VSS 0.05375f ; **FLOATING
C9454 VDD.n1384 VSS 0.01946f ; **FLOATING
C9455 VDD.n1385 VSS 0.06362f ; **FLOATING
C9456 VDD.n1386 VSS 0.01378f ; **FLOATING
C9457 VDD.n1387 VSS 0.0532f ; **FLOATING
C9458 VDD.n1389 VSS 0.05434f ; **FLOATING
C9459 VDD.t607 VSS 0.04614f ; **FLOATING
C9460 VDD.t167 VSS 0.03376f ; **FLOATING
C9461 VDD.t1621 VSS 0.11617f ; **FLOATING
C9462 VDD.n1390 VSS 0.14218f ; **FLOATING
C9463 VDD.n1391 VSS 0.12404f ; **FLOATING
C9464 VDD.t172 VSS 0.03376f ; **FLOATING
C9465 VDD.t1622 VSS 0.11617f ; **FLOATING
C9466 VDD.n1392 VSS 0.14218f ; **FLOATING
C9467 VDD.t168 VSS 0.03376f ; **FLOATING
C9468 VDD.t1623 VSS 0.11617f ; **FLOATING
C9469 VDD.t152 VSS 0.03376f ; **FLOATING
C9470 VDD.t1624 VSS 0.11617f ; **FLOATING
C9471 VDD.n1393 VSS 0.14218f ; **FLOATING
C9472 VDD.t150 VSS 0.03376f ; **FLOATING
C9473 VDD.t1625 VSS 0.11617f ; **FLOATING
C9474 VDD.n1394 VSS 0.14218f ; **FLOATING
C9475 VDD.n1395 VSS 0.08876f ; **FLOATING
C9476 VDD.t155 VSS 0.03376f ; **FLOATING
C9477 VDD.t1626 VSS 0.11617f ; **FLOATING
C9478 VDD.n1396 VSS 0.06389f ; **FLOATING
C9479 VDD.n1397 VSS 0.01359f ; **FLOATING
C9480 VDD.n1398 VSS 0.05375f ; **FLOATING
C9481 VDD.n1399 VSS 0.01946f ; **FLOATING
C9482 VDD.n1400 VSS 0.06362f ; **FLOATING
C9483 VDD.n1401 VSS 0.01378f ; **FLOATING
C9484 VDD.n1402 VSS 0.07803f ; **FLOATING
C9485 VDD.n1403 VSS 0.01181f ; **FLOATING
C9486 VDD.n1404 VSS 0.07514f ; **FLOATING
C9487 VDD.n1405 VSS 0.07338f ; **FLOATING
C9488 VDD.n1406 VSS 0.02892f ; **FLOATING
C9489 VDD.n1407 VSS 0.08818f ; **FLOATING
C9490 VDD.n1408 VSS 0.02579f ; **FLOATING
C9491 VDD.n1409 VSS 0.06373f ; **FLOATING
C9492 VDD.n1410 VSS 0.01359f ; **FLOATING
C9493 VDD.n1411 VSS 0.05375f ; **FLOATING
C9494 VDD.n1412 VSS 0.01946f ; **FLOATING
C9495 VDD.n1413 VSS 0.06362f ; **FLOATING
C9496 VDD.n1414 VSS 0.01378f ; **FLOATING
C9497 VDD.n1415 VSS 0.0532f ; **FLOATING
C9498 VDD.n1417 VSS 0.05434f ; **FLOATING
C9499 VDD.t365 VSS 0.04614f ; **FLOATING
C9500 VDD.t275 VSS 0.03376f ; **FLOATING
C9501 VDD.t1627 VSS 0.11617f ; **FLOATING
C9502 VDD.n1418 VSS 0.14218f ; **FLOATING
C9503 VDD.n1419 VSS 0.12404f ; **FLOATING
C9504 VDD.t272 VSS 0.03376f ; **FLOATING
C9505 VDD.t1628 VSS 0.11617f ; **FLOATING
C9506 VDD.n1420 VSS 0.14218f ; **FLOATING
C9507 VDD.t184 VSS 0.03376f ; **FLOATING
C9508 VDD.t1629 VSS 0.11617f ; **FLOATING
C9509 VDD.t267 VSS 0.03376f ; **FLOATING
C9510 VDD.t1630 VSS 0.11617f ; **FLOATING
C9511 VDD.n1421 VSS 0.14218f ; **FLOATING
C9512 VDD.t207 VSS 0.03376f ; **FLOATING
C9513 VDD.t1631 VSS 0.11617f ; **FLOATING
C9514 VDD.n1422 VSS 0.14218f ; **FLOATING
C9515 VDD.n1423 VSS 0.08876f ; **FLOATING
C9516 VDD.t188 VSS 0.03376f ; **FLOATING
C9517 VDD.t1632 VSS 0.11617f ; **FLOATING
C9518 VDD.n1424 VSS 0.06389f ; **FLOATING
C9519 VDD.n1425 VSS 0.01359f ; **FLOATING
C9520 VDD.n1426 VSS 0.05375f ; **FLOATING
C9521 VDD.n1427 VSS 0.01946f ; **FLOATING
C9522 VDD.n1428 VSS 0.06362f ; **FLOATING
C9523 VDD.n1429 VSS 0.01378f ; **FLOATING
C9524 VDD.n1430 VSS 0.0532f ; **FLOATING
C9525 VDD.n1432 VSS 0.05434f ; **FLOATING
C9526 VDD.t536 VSS 0.04614f ; **FLOATING
C9527 VDD.t280 VSS 0.03376f ; **FLOATING
C9528 VDD.t1633 VSS 0.11617f ; **FLOATING
C9529 VDD.n1433 VSS 0.14218f ; **FLOATING
C9530 VDD.n1434 VSS 0.12404f ; **FLOATING
C9531 VDD.t495 VSS 0.03383f ; **FLOATING
C9532 VDD.t493 VSS 0.02443f ; **FLOATING
C9533 VDD.n1435 VSS 0.01681f ; **FLOATING
C9534 VDD.t498 VSS 0.03383f ; **FLOATING
C9535 VDD.t989 VSS 0.03383f ; **FLOATING
C9536 VDD.t1095 VSS 0.03383f ; **FLOATING
C9537 VDD.t1096 VSS 0.03383f ; **FLOATING
C9538 VDD.t1094 VSS 0.03383f ; **FLOATING
C9539 VDD.n1436 VSS 0.02509f ; **FLOATING
C9540 VDD.t1093 VSS 0.03383f ; **FLOATING
C9541 VDD.t1092 VSS 0.03383f ; **FLOATING
C9542 VDD.t1097 VSS 0.03383f ; **FLOATING
C9543 VDD.t964 VSS 0.03383f ; **FLOATING
C9544 VDD.t974 VSS 0.03383f ; **FLOATING
C9545 VDD.n1437 VSS 0.02509f ; **FLOATING
C9546 VDD.t1101 VSS 0.03383f ; **FLOATING
C9547 VDD.n1438 VSS 0.02509f ; **FLOATING
C9548 VDD.t1100 VSS 0.03383f ; **FLOATING
C9549 VDD.n1439 VSS 0.02509f ; **FLOATING
C9550 VDD.t1102 VSS 0.03383f ; **FLOATING
C9551 VDD.t1099 VSS 0.03383f ; **FLOATING
C9552 VDD.t1103 VSS 0.03383f ; **FLOATING
C9553 VDD.n1440 VSS 0.02509f ; **FLOATING
C9554 VDD.t1104 VSS 0.03383f ; **FLOATING
C9555 VDD.t1098 VSS 0.03383f ; **FLOATING
C9556 VDD.t976 VSS 0.03383f ; **FLOATING
C9557 VDD.n1441 VSS 0.02509f ; **FLOATING
C9558 VDD.t1111 VSS 0.03383f ; **FLOATING
C9559 VDD.t975 VSS 0.03383f ; **FLOATING
C9560 VDD.n1442 VSS 0.02509f ; **FLOATING
C9561 VDD.t1112 VSS 0.03383f ; **FLOATING
C9562 VDD.n1443 VSS 0.02509f ; **FLOATING
C9563 VDD.t1107 VSS 0.03383f ; **FLOATING
C9564 VDD.t1113 VSS 0.03383f ; **FLOATING
C9565 VDD.n1444 VSS 0.02509f ; **FLOATING
C9566 VDD.t1115 VSS 0.03383f ; **FLOATING
C9567 VDD.t1114 VSS 0.03383f ; **FLOATING
C9568 VDD.n1445 VSS 0.02509f ; **FLOATING
C9569 VDD.t1110 VSS 0.03383f ; **FLOATING
C9570 VDD.t1108 VSS 0.03383f ; **FLOATING
C9571 VDD.t1109 VSS 0.03383f ; **FLOATING
C9572 VDD.n1446 VSS 0.02509f ; **FLOATING
C9573 VDD.t1106 VSS 0.03383f ; **FLOATING
C9574 VDD.t1105 VSS 0.03383f ; **FLOATING
C9575 VDD.t1116 VSS 0.03383f ; **FLOATING
C9576 VDD.n1447 VSS 0.02509f ; **FLOATING
C9577 VDD.t1117 VSS 0.03383f ; **FLOATING
C9578 VDD.t1118 VSS 0.03383f ; **FLOATING
C9579 VDD.t501 VSS 0.03383f ; **FLOATING
C9580 VDD.n1448 VSS 0.02509f ; **FLOATING
C9581 VDD.t499 VSS 0.07098f ; **FLOATING
C9582 VDD.t500 VSS 0.03782f ; **FLOATING
C9583 VDD.n1449 VSS 0.02743f ; **FLOATING
C9584 VDD.t502 VSS 0.0327f ; **FLOATING
C9585 VDD.n1450 VSS 0.01667f ; **FLOATING
C9586 VDD.t503 VSS 0.03383f ; **FLOATING
C9587 VDD.n1451 VSS 0.02247f ; **FLOATING
C9588 VDD.t569 VSS 0.03968f ; **FLOATING
C9589 VDD.t1163 VSS 0.03968f ; **FLOATING
C9590 VDD.t853 VSS 0.03968f ; **FLOATING
C9591 VDD.n1452 VSS 0.08267f ; **FLOATING
C9592 VDD.n1453 VSS 0.06288f ; **FLOATING
C9593 VDD.t877 VSS 0.03968f ; **FLOATING
C9594 VDD.t894 VSS 0.03968f ; **FLOATING
C9595 VDD.t941 VSS 0.03968f ; **FLOATING
C9596 VDD.t1336 VSS 0.03968f ; **FLOATING
C9597 VDD.t526 VSS 0.03968f ; **FLOATING
C9598 VDD.t528 VSS 0.03968f ; **FLOATING
C9599 VDD.t876 VSS 0.03968f ; **FLOATING
C9600 VDD.n1454 VSS 0.09336f ; **FLOATING
C9601 VDD.t1297 VSS 0.03968f ; **FLOATING
C9602 VDD.n1455 VSS 0.0717f ; **FLOATING
C9603 VDD.t525 VSS 0.03968f ; **FLOATING
C9604 VDD.t874 VSS 0.03968f ; **FLOATING
C9605 VDD.t560 VSS 0.03968f ; **FLOATING
C9606 VDD.n1456 VSS 0.07173f ; **FLOATING
C9607 VDD.t559 VSS 0.03968f ; **FLOATING
C9608 VDD.t727 VSS 0.03968f ; **FLOATING
C9609 VDD.n1457 VSS 0.06288f ; **FLOATING
C9610 VDD.t677 VSS 0.03968f ; **FLOATING
C9611 VDD.n1458 VSS 0.09413f ; **FLOATING
C9612 VDD.t380 VSS 0.03968f ; **FLOATING
C9613 VDD.t928 VSS 0.03968f ; **FLOATING
C9614 VDD.n1459 VSS 0.06287f ; **FLOATING
C9615 VDD.t645 VSS 0.03968f ; **FLOATING
C9616 VDD.t819 VSS 0.03968f ; **FLOATING
C9617 VDD.t658 VSS 0.03968f ; **FLOATING
C9618 VDD.n1460 VSS 0.06288f ; **FLOATING
C9619 VDD.t848 VSS 0.03968f ; **FLOATING
C9620 VDD.t1334 VSS 0.03968f ; **FLOATING
C9621 VDD.n1461 VSS 0.08266f ; **FLOATING
C9622 VDD.n1462 VSS 0.07172f ; **FLOATING
C9623 VDD.t523 VSS 0.03968f ; **FLOATING
C9624 VDD.t880 VSS 0.03968f ; **FLOATING
C9625 VDD.t1192 VSS 0.03968f ; **FLOATING
C9626 VDD.t1355 VSS 0.03968f ; **FLOATING
C9627 VDD.t1471 VSS 0.03968f ; **FLOATING
C9628 VDD.n1463 VSS 0.07168f ; **FLOATING
C9629 VDD.t878 VSS 0.03968f ; **FLOATING
C9630 VDD.t1446 VSS 0.03968f ; **FLOATING
C9631 VDD.t1457 VSS 0.03968f ; **FLOATING
C9632 VDD.n1464 VSS 0.08263f ; **FLOATING
C9633 VDD.n1465 VSS 0.06291f ; **FLOATING
C9634 VDD.n1466 VSS 0.01471f ; **FLOATING
C9635 VDD.n1467 VSS 0.08263f ; **FLOATING
C9636 VDD.n1468 VSS 0.07287f ; **FLOATING
C9637 VDD.n1469 VSS 0.09432f ; **FLOATING
C9638 VDD.n1470 VSS 0.08262f ; **FLOATING
C9639 VDD.n1471 VSS 0.0629f ; **FLOATING
C9640 VDD.n1472 VSS 0.01471f ; **FLOATING
C9641 VDD.n1473 VSS 0.08262f ; **FLOATING
C9642 VDD.n1474 VSS 0.08264f ; **FLOATING
C9643 VDD.n1475 VSS 0.06288f ; **FLOATING
C9644 VDD.n1476 VSS 0.01471f ; **FLOATING
C9645 VDD.n1477 VSS 0.07287f ; **FLOATING
C9646 VDD.n1478 VSS 0.08184f ; **FLOATING
C9647 VDD.n1479 VSS 0.01471f ; **FLOATING
C9648 VDD.n1480 VSS 0.08261f ; **FLOATING
C9649 VDD.n1481 VSS 0.0941f ; **FLOATING
C9650 VDD.n1482 VSS 0.07444f ; **FLOATING
C9651 VDD.n1483 VSS 0.01514f ; **FLOATING
C9652 VDD.n1484 VSS 0.0382f ; **FLOATING
C9653 VDD.n1485 VSS 0.01623f ; **FLOATING
C9654 VDD.n1486 VSS 0.03453f ; **FLOATING
C9655 VDD.n1488 VSS 0.0743f ; **FLOATING
C9656 VDD.n1489 VSS 0.05417f ; **FLOATING
C9657 VDD.n1490 VSS 0.06306f ; **FLOATING
C9658 VDD.n1492 VSS 0.04832f ; **FLOATING
C9659 VDD.n1493 VSS 0.02687f ; **FLOATING
C9660 VDD.n1494 VSS 0.09201f ; **FLOATING
C9661 VDD.n1495 VSS 0.05144f ; **FLOATING
C9662 VDD.n1496 VSS 0.11117f ; **FLOATING
C9663 VDD.n1497 VSS 0.05144f ; **FLOATING
C9664 VDD.n1498 VSS 0.11117f ; **FLOATING
C9665 VDD.n1499 VSS 0.05144f ; **FLOATING
C9666 VDD.n1500 VSS 0.11117f ; **FLOATING
C9667 VDD.n1501 VSS 0.05144f ; **FLOATING
C9668 VDD.n1502 VSS 0.11117f ; **FLOATING
C9669 VDD.n1503 VSS 0.05144f ; **FLOATING
C9670 VDD.n1504 VSS 0.11117f ; **FLOATING
C9671 VDD.n1505 VSS 0.05144f ; **FLOATING
C9672 VDD.n1506 VSS 0.11117f ; **FLOATING
C9673 VDD.n1507 VSS 0.04886f ; **FLOATING
C9674 VDD.n1508 VSS 0.11117f ; **FLOATING
C9675 VDD.n1509 VSS 0.05144f ; **FLOATING
C9676 VDD.n1510 VSS 0.11117f ; **FLOATING
C9677 VDD.n1511 VSS 0.05144f ; **FLOATING
C9678 VDD.n1512 VSS 0.11117f ; **FLOATING
C9679 VDD.n1513 VSS 0.05144f ; **FLOATING
C9680 VDD.n1514 VSS 0.11117f ; **FLOATING
C9681 VDD.n1515 VSS 0.05144f ; **FLOATING
C9682 VDD.n1516 VSS 0.11117f ; **FLOATING
C9683 VDD.n1517 VSS 0.05144f ; **FLOATING
C9684 VDD.n1518 VSS 0.11117f ; **FLOATING
C9685 VDD.n1519 VSS 0.05144f ; **FLOATING
C9686 VDD.n1520 VSS 0.11117f ; **FLOATING
C9687 VDD.n1521 VSS 0.05144f ; **FLOATING
C9688 VDD.n1522 VSS 0.11117f ; **FLOATING
C9689 VDD.n1523 VSS 0.05144f ; **FLOATING
C9690 VDD.n1524 VSS 0.11117f ; **FLOATING
C9691 VDD.n1525 VSS 0.05144f ; **FLOATING
C9692 VDD.n1526 VSS 0.11117f ; **FLOATING
C9693 VDD.n1527 VSS 0.05144f ; **FLOATING
C9694 VDD.n1528 VSS 0.11117f ; **FLOATING
C9695 VDD.n1529 VSS 0.05144f ; **FLOATING
C9696 VDD.n1530 VSS 0.11117f ; **FLOATING
C9697 VDD.n1531 VSS 0.05144f ; **FLOATING
C9698 VDD.n1532 VSS 0.07184f ; **FLOATING
C9699 VDD.n1534 VSS 0.08368f ; **FLOATING
C9700 VDD.n1535 VSS 0.04257f ; **FLOATING
C9701 VDD.n1536 VSS 0.10168f ; **FLOATING
C9702 VDD.n1537 VSS 0.05144f ; **FLOATING
C9703 VDD.n1538 VSS 0.11117f ; **FLOATING
C9704 VDD.n1539 VSS 0.05144f ; **FLOATING
C9705 VDD.n1540 VSS 0.11117f ; **FLOATING
C9706 VDD.n1541 VSS 0.05144f ; **FLOATING
C9707 VDD.n1542 VSS 0.11117f ; **FLOATING
C9708 VDD.n1543 VSS 0.05144f ; **FLOATING
C9709 VDD.n1544 VSS 0.11117f ; **FLOATING
C9710 VDD.n1545 VSS 0.05144f ; **FLOATING
C9711 VDD.n1546 VSS 0.11117f ; **FLOATING
C9712 VDD.n1547 VSS 0.05144f ; **FLOATING
C9713 VDD.n1548 VSS 0.11117f ; **FLOATING
C9714 VDD.n1549 VSS 0.05144f ; **FLOATING
C9715 VDD.n1550 VSS 0.11117f ; **FLOATING
C9716 VDD.n1551 VSS 0.05144f ; **FLOATING
C9717 VDD.n1552 VSS 0.11117f ; **FLOATING
C9718 VDD.n1553 VSS 0.05144f ; **FLOATING
C9719 VDD.n1554 VSS 0.11117f ; **FLOATING
C9720 VDD.n1555 VSS 0.05144f ; **FLOATING
C9721 VDD.t496 VSS 0.01991f ; **FLOATING
C9722 VDD.t494 VSS 0.03782f ; **FLOATING
C9723 VDD.t709 VSS 0.03503f ; **FLOATING
C9724 VDD.t1482 VSS 0.03503f ; **FLOATING
C9725 VDD.t231 VSS 0.03145f ; **FLOATING
C9726 VDD.t1238 VSS 0.03503f ; **FLOATING
C9727 VDD.n1556 VSS 0.06389f ; **FLOATING
C9728 VDD.n1557 VSS 0.01359f ; **FLOATING
C9729 VDD.n1558 VSS 0.02892f ; **FLOATING
C9730 VDD.t377 VSS 0.04597f ; **FLOATING
C9731 VDD.n1559 VSS 0.08818f ; **FLOATING
C9732 VDD.n1560 VSS 0.02579f ; **FLOATING
C9733 VDD.t1150 VSS 0.03503f ; **FLOATING
C9734 VDD.n1561 VSS 0.0931f ; **FLOATING
C9735 VDD.n1562 VSS 0.01227f ; **FLOATING
C9736 VDD.n1563 VSS 0.01279f ; **FLOATING
C9737 VDD.t1587 VSS 0.03904f ; **FLOATING
C9738 VDD.t1440 VSS 0.03904f ; **FLOATING
C9739 VDD.n1564 VSS 0.08386f ; **FLOATING
C9740 VDD.n1565 VSS 0.01231f ; **FLOATING
C9741 VDD.n1566 VSS 0.01296f ; **FLOATING
C9742 VDD.t520 VSS 0.03904f ; **FLOATING
C9743 VDD.t1436 VSS 0.03904f ; **FLOATING
C9744 VDD.n1567 VSS 0.08323f ; **FLOATING
C9745 VDD.n1568 VSS 0.01237f ; **FLOATING
C9746 VDD.t1173 VSS 0.03503f ; **FLOATING
C9747 VDD.t799 VSS 0.03503f ; **FLOATING
C9748 VDD.t375 VSS 0.02587f ; **FLOATING
C9749 VDD.t1444 VSS 0.02587f ; **FLOATING
C9750 VDD.n1569 VSS 0.08393f ; **FLOATING
C9751 VDD.t519 VSS 0.03458f ; **FLOATING
C9752 VDD.t1435 VSS 0.03458f ; **FLOATING
C9753 VDD.n1570 VSS 0.06951f ; **FLOATING
C9754 VDD.n1571 VSS 0.01712f ; **FLOATING
C9755 VDD.t711 VSS 0.02587f ; **FLOATING
C9756 VDD.t1484 VSS 0.02587f ; **FLOATING
C9757 VDD.n1572 VSS 0.06926f ; **FLOATING
C9758 VDD.t815 VSS 0.03458f ; **FLOATING
C9759 VDD.t1439 VSS 0.03458f ; **FLOATING
C9760 VDD.n1573 VSS 0.07416f ; **FLOATING
C9761 VDD.n1574 VSS 0.01249f ; **FLOATING
C9762 VDD.t1174 VSS 0.02587f ; **FLOATING
C9763 VDD.t797 VSS 0.02587f ; **FLOATING
C9764 VDD.n1575 VSS 0.06903f ; **FLOATING
C9765 VDD.n1576 VSS 0.01204f ; **FLOATING
C9766 VDD.t376 VSS 0.03458f ; **FLOATING
C9767 VDD.t1423 VSS 0.03458f ; **FLOATING
C9768 VDD.n1577 VSS 0.06998f ; **FLOATING
C9769 VDD.n1578 VSS 0.01709f ; **FLOATING
C9770 VDD.t1127 VSS 0.03904f ; **FLOATING
C9771 VDD.t1424 VSS 0.03904f ; **FLOATING
C9772 VDD.n1579 VSS 0.07822f ; **FLOATING
C9773 VDD.t710 VSS 0.02587f ; **FLOATING
C9774 VDD.t1483 VSS 0.02587f ; **FLOATING
C9775 VDD.n1580 VSS 0.06966f ; **FLOATING
C9776 VDD.n1581 VSS 0.01274f ; **FLOATING
C9777 VDD.t1175 VSS 0.03458f ; **FLOATING
C9778 VDD.t798 VSS 0.03458f ; **FLOATING
C9779 VDD.n1582 VSS 0.07417f ; **FLOATING
C9780 VDD.t1302 VSS 0.03904f ; **FLOATING
C9781 VDD.t1429 VSS 0.03904f ; **FLOATING
C9782 VDD.n1583 VSS 0.0125f ; **FLOATING
C9783 VDD.t872 VSS 0.03503f ; **FLOATING
C9784 VDD.t356 VSS 0.03515f ; **FLOATING
C9785 VDD.t1154 VSS 0.03503f ; **FLOATING
C9786 VDD.n1584 VSS 0.07338f ; **FLOATING
C9787 VDD.n1585 VSS 0.01378f ; **FLOATING
C9788 VDD.t787 VSS 0.03503f ; **FLOATING
C9789 VDD.n1586 VSS 0.06362f ; **FLOATING
C9790 VDD.t1581 VSS 0.03503f ; **FLOATING
C9791 VDD.n1587 VSS 0.05375f ; **FLOATING
C9792 VDD.n1588 VSS 0.01946f ; **FLOATING
C9793 VDD.t369 VSS 0.03503f ; **FLOATING
C9794 VDD.t233 VSS 0.03145f ; **FLOATING
C9795 VDD.t234 VSS 0.03145f ; **FLOATING
C9796 VDD.t512 VSS 0.03503f ; **FLOATING
C9797 VDD.t232 VSS 0.03376f ; **FLOATING
C9798 VDD.t1653 VSS 0.11617f ; **FLOATING
C9799 VDD.t521 VSS 0.04597f ; **FLOATING
C9800 VDD.t235 VSS 0.03376f ; **FLOATING
C9801 VDD.t1652 VSS 0.11617f ; **FLOATING
C9802 VDD.n1589 VSS 0.14218f ; **FLOATING
C9803 VDD.n1590 VSS 0.08876f ; **FLOATING
C9804 VDD.t1343 VSS 0.03503f ; **FLOATING
C9805 VDD.t237 VSS 0.03145f ; **FLOATING
C9806 VDD.t238 VSS 0.03145f ; **FLOATING
C9807 VDD.t241 VSS 0.03145f ; **FLOATING
C9808 VDD.t1129 VSS 0.03503f ; **FLOATING
C9809 VDD.t751 VSS 0.03503f ; **FLOATING
C9810 VDD.t552 VSS 0.03503f ; **FLOATING
C9811 VDD.t1208 VSS 0.03503f ; **FLOATING
C9812 VDD.t219 VSS 0.03145f ; **FLOATING
C9813 VDD.t409 VSS 0.04597f ; **FLOATING
C9814 VDD.t1342 VSS 0.03503f ; **FLOATING
C9815 VDD.t222 VSS 0.03145f ; **FLOATING
C9816 VDD.t534 VSS 0.03503f ; **FLOATING
C9817 VDD.t223 VSS 0.03145f ; **FLOATING
C9818 VDD.t1153 VSS 0.03503f ; **FLOATING
C9819 VDD.t226 VSS 0.03145f ; **FLOATING
C9820 VDD.t227 VSS 0.03145f ; **FLOATING
C9821 VDD.t701 VSS 0.04614f ; **FLOATING
C9822 VDD.n1591 VSS 0.01946f ; **FLOATING
C9823 VDD.t782 VSS 0.03503f ; **FLOATING
C9824 VDD.n1592 VSS 0.06362f ; **FLOATING
C9825 VDD.n1593 VSS 0.01378f ; **FLOATING
C9826 VDD.t230 VSS 0.03145f ; **FLOATING
C9827 VDD.t1130 VSS 0.03503f ; **FLOATING
C9828 VDD.n1594 VSS 0.0532f ; **FLOATING
C9829 VDD.t719 VSS 0.03503f ; **FLOATING
C9830 VDD.n1596 VSS 0.05375f ; **FLOATING
C9831 VDD.n1597 VSS 0.01359f ; **FLOATING
C9832 VDD.t1215 VSS 0.03503f ; **FLOATING
C9833 VDD.n1598 VSS 0.06417f ; **FLOATING
C9834 VDD.t248 VSS 0.03145f ; **FLOATING
C9835 VDD.t404 VSS 0.04597f ; **FLOATING
C9836 VDD.t251 VSS 0.03145f ; **FLOATING
C9837 VDD.t371 VSS 0.03503f ; **FLOATING
C9838 VDD.t252 VSS 0.03145f ; **FLOATING
C9839 VDD.t754 VSS 0.03503f ; **FLOATING
C9840 VDD.t1393 VSS 0.03503f ; **FLOATING
C9841 VDD.t255 VSS 0.03145f ; **FLOATING
C9842 VDD.t256 VSS 0.03145f ; **FLOATING
C9843 VDD.t259 VSS 0.03145f ; **FLOATING
C9844 VDD.t1239 VSS 0.03503f ; **FLOATING
C9845 VDD.t826 VSS 0.03503f ; **FLOATING
C9846 VDD.t847 VSS 0.03503f ; **FLOATING
C9847 VDD.t1217 VSS 0.03503f ; **FLOATING
C9848 VDD.t531 VSS 0.04597f ; **FLOATING
C9849 VDD.t373 VSS 0.03503f ; **FLOATING
C9850 VDD.t414 VSS 0.03503f ; **FLOATING
C9851 VDD.t804 VSS 0.03503f ; **FLOATING
C9852 VDD.t1394 VSS 0.03503f ; **FLOATING
C9853 VDD.t1461 VSS 0.03719f ; **FLOATING
C9854 VDD.t510 VSS 0.04597f ; **FLOATING
C9855 VDD.t1462 VSS 0.06567f ; **FLOATING
C9856 VDD.t1128 VSS 0.03503f ; **FLOATING
C9857 VDD.t699 VSS 0.03503f ; **FLOATING
C9858 VDD.t1 VSS 0.03503f ; **FLOATING
C9859 VDD.t1207 VSS 0.03503f ; **FLOATING
C9860 VDD.t190 VSS 0.03145f ; **FLOATING
C9861 VDD.t1313 VSS 0.04597f ; **FLOATING
C9862 VDD.t1395 VSS 0.03503f ; **FLOATING
C9863 VDD.t193 VSS 0.03145f ; **FLOATING
C9864 VDD.t416 VSS 0.03503f ; **FLOATING
C9865 VDD.t194 VSS 0.03145f ; **FLOATING
C9866 VDD.t1152 VSS 0.03503f ; **FLOATING
C9867 VDD.t197 VSS 0.03145f ; **FLOATING
C9868 VDD.t198 VSS 0.03145f ; **FLOATING
C9869 VDD.t773 VSS 0.04614f ; **FLOATING
C9870 VDD.n1599 VSS 0.01946f ; **FLOATING
C9871 VDD.t1141 VSS 0.03503f ; **FLOATING
C9872 VDD.n1600 VSS 0.06362f ; **FLOATING
C9873 VDD.n1601 VSS 0.01378f ; **FLOATING
C9874 VDD.t201 VSS 0.03145f ; **FLOATING
C9875 VDD.t1131 VSS 0.03503f ; **FLOATING
C9876 VDD.n1602 VSS 0.0532f ; **FLOATING
C9877 VDD.t553 VSS 0.03503f ; **FLOATING
C9878 VDD.n1604 VSS 0.05375f ; **FLOATING
C9879 VDD.n1605 VSS 0.01359f ; **FLOATING
C9880 VDD.t1216 VSS 0.03503f ; **FLOATING
C9881 VDD.n1606 VSS 0.06389f ; **FLOATING
C9882 VDD.t322 VSS 0.03145f ; **FLOATING
C9883 VDD.t1241 VSS 0.04597f ; **FLOATING
C9884 VDD.t325 VSS 0.03145f ; **FLOATING
C9885 VDD.t372 VSS 0.03503f ; **FLOATING
C9886 VDD.t326 VSS 0.03145f ; **FLOATING
C9887 VDD.t774 VSS 0.03503f ; **FLOATING
C9888 VDD.t1151 VSS 0.03503f ; **FLOATING
C9889 VDD.t329 VSS 0.03145f ; **FLOATING
C9890 VDD.t330 VSS 0.03145f ; **FLOATING
C9891 VDD.t262 VSS 0.03145f ; **FLOATING
C9892 VDD.t1240 VSS 0.03503f ; **FLOATING
C9893 VDD.t842 VSS 0.03503f ; **FLOATING
C9894 VDD.t554 VSS 0.03503f ; **FLOATING
C9895 VDD.t1218 VSS 0.03503f ; **FLOATING
C9896 VDD.t202 VSS 0.03145f ; **FLOATING
C9897 VDD.t738 VSS 0.04597f ; **FLOATING
C9898 VDD.t374 VSS 0.03503f ; **FLOATING
C9899 VDD.t186 VSS 0.03145f ; **FLOATING
C9900 VDD.t571 VSS 0.03503f ; **FLOATING
C9901 VDD.t187 VSS 0.03145f ; **FLOATING
C9902 VDD.t1345 VSS 0.03503f ; **FLOATING
C9903 VDD.t180 VSS 0.03145f ; **FLOATING
C9904 VDD.t173 VSS 0.03145f ; **FLOATING
C9905 VDD.t1254 VSS 0.04614f ; **FLOATING
C9906 VDD.n1607 VSS 0.01946f ; **FLOATING
C9907 VDD.t866 VSS 0.03503f ; **FLOATING
C9908 VDD.n1608 VSS 0.06362f ; **FLOATING
C9909 VDD.n1609 VSS 0.01378f ; **FLOATING
C9910 VDD.t176 VSS 0.03145f ; **FLOATING
C9911 VDD.t1344 VSS 0.03503f ; **FLOATING
C9912 VDD.n1610 VSS 0.0532f ; **FLOATING
C9913 VDD.t809 VSS 0.03503f ; **FLOATING
C9914 VDD.n1612 VSS 0.05375f ; **FLOATING
C9915 VDD.n1613 VSS 0.01359f ; **FLOATING
C9916 VDD.t1237 VSS 0.03503f ; **FLOATING
C9917 VDD.n1614 VSS 0.06373f ; **FLOATING
C9918 VDD.n1615 VSS 0.02579f ; **FLOATING
C9919 VDD.t1415 VSS 0.04597f ; **FLOATING
C9920 VDD.n1616 VSS 0.0935f ; **FLOATING
C9921 VDD.t370 VSS 0.0384f ; **FLOATING
C9922 VDD.n1617 VSS 0.12463f ; **FLOATING
C9923 VDD.t174 VSS 0.03376f ; **FLOATING
C9924 VDD.t1636 VSS 0.11617f ; **FLOATING
C9925 VDD.n1618 VSS 0.14218f ; **FLOATING
C9926 VDD.t179 VSS 0.03376f ; **FLOATING
C9927 VDD.t1637 VSS 0.11617f ; **FLOATING
C9928 VDD.n1619 VSS 0.14218f ; **FLOATING
C9929 VDD.n1620 VSS 0.08876f ; **FLOATING
C9930 VDD.t185 VSS 0.03376f ; **FLOATING
C9931 VDD.t1638 VSS 0.11617f ; **FLOATING
C9932 VDD.n1621 VSS 0.06389f ; **FLOATING
C9933 VDD.n1622 VSS 0.01359f ; **FLOATING
C9934 VDD.n1623 VSS 0.05375f ; **FLOATING
C9935 VDD.n1624 VSS 0.01946f ; **FLOATING
C9936 VDD.n1625 VSS 0.06362f ; **FLOATING
C9937 VDD.n1626 VSS 0.01378f ; **FLOATING
C9938 VDD.n1627 VSS 0.0532f ; **FLOATING
C9939 VDD.n1629 VSS 0.05434f ; **FLOATING
C9940 VDD.t706 VSS 0.04614f ; **FLOATING
C9941 VDD.t261 VSS 0.03376f ; **FLOATING
C9942 VDD.t1639 VSS 0.11617f ; **FLOATING
C9943 VDD.n1630 VSS 0.14218f ; **FLOATING
C9944 VDD.n1631 VSS 0.12404f ; **FLOATING
C9945 VDD.t327 VSS 0.03376f ; **FLOATING
C9946 VDD.t1640 VSS 0.11617f ; **FLOATING
C9947 VDD.n1632 VSS 0.14218f ; **FLOATING
C9948 VDD.t323 VSS 0.03376f ; **FLOATING
C9949 VDD.t1641 VSS 0.11617f ; **FLOATING
C9950 VDD.t199 VSS 0.03376f ; **FLOATING
C9951 VDD.t1642 VSS 0.11617f ; **FLOATING
C9952 VDD.n1633 VSS 0.14218f ; **FLOATING
C9953 VDD.t195 VSS 0.03376f ; **FLOATING
C9954 VDD.t1643 VSS 0.11617f ; **FLOATING
C9955 VDD.n1634 VSS 0.14218f ; **FLOATING
C9956 VDD.n1635 VSS 0.08876f ; **FLOATING
C9957 VDD.t191 VSS 0.03376f ; **FLOATING
C9958 VDD.t1644 VSS 0.11617f ; **FLOATING
C9959 VDD.n1636 VSS 0.06389f ; **FLOATING
C9960 VDD.n1637 VSS 0.01359f ; **FLOATING
C9961 VDD.n1638 VSS 0.05375f ; **FLOATING
C9962 VDD.n1639 VSS 0.01946f ; **FLOATING
C9963 VDD.n1640 VSS 0.06362f ; **FLOATING
C9964 VDD.n1641 VSS 0.01378f ; **FLOATING
C9965 VDD.n1642 VSS 0.07803f ; **FLOATING
C9966 VDD.n1643 VSS 0.01181f ; **FLOATING
C9967 VDD.n1644 VSS 0.07514f ; **FLOATING
C9968 VDD.n1645 VSS 0.07338f ; **FLOATING
C9969 VDD.n1646 VSS 0.02892f ; **FLOATING
C9970 VDD.n1647 VSS 0.08818f ; **FLOATING
C9971 VDD.n1648 VSS 0.02579f ; **FLOATING
C9972 VDD.n1649 VSS 0.06373f ; **FLOATING
C9973 VDD.n1650 VSS 0.01359f ; **FLOATING
C9974 VDD.n1651 VSS 0.05375f ; **FLOATING
C9975 VDD.n1652 VSS 0.01946f ; **FLOATING
C9976 VDD.n1653 VSS 0.06362f ; **FLOATING
C9977 VDD.n1654 VSS 0.01378f ; **FLOATING
C9978 VDD.n1655 VSS 0.0532f ; **FLOATING
C9979 VDD.n1657 VSS 0.05434f ; **FLOATING
C9980 VDD.t638 VSS 0.04614f ; **FLOATING
C9981 VDD.t257 VSS 0.03376f ; **FLOATING
C9982 VDD.t1645 VSS 0.11617f ; **FLOATING
C9983 VDD.n1658 VSS 0.14218f ; **FLOATING
C9984 VDD.n1659 VSS 0.12404f ; **FLOATING
C9985 VDD.t253 VSS 0.03376f ; **FLOATING
C9986 VDD.t1646 VSS 0.11617f ; **FLOATING
C9987 VDD.n1660 VSS 0.14218f ; **FLOATING
C9988 VDD.t249 VSS 0.03376f ; **FLOATING
C9989 VDD.t1647 VSS 0.11617f ; **FLOATING
C9990 VDD.t228 VSS 0.03376f ; **FLOATING
C9991 VDD.t1648 VSS 0.11617f ; **FLOATING
C9992 VDD.n1661 VSS 0.14218f ; **FLOATING
C9993 VDD.t224 VSS 0.03376f ; **FLOATING
C9994 VDD.t1649 VSS 0.11617f ; **FLOATING
C9995 VDD.n1662 VSS 0.14218f ; **FLOATING
C9996 VDD.n1663 VSS 0.08876f ; **FLOATING
C9997 VDD.t220 VSS 0.03376f ; **FLOATING
C9998 VDD.t1650 VSS 0.11617f ; **FLOATING
C9999 VDD.n1664 VSS 0.06389f ; **FLOATING
C10000 VDD.n1665 VSS 0.01359f ; **FLOATING
C10001 VDD.n1666 VSS 0.05375f ; **FLOATING
C10002 VDD.n1667 VSS 0.01946f ; **FLOATING
C10003 VDD.n1668 VSS 0.06362f ; **FLOATING
C10004 VDD.n1669 VSS 0.01378f ; **FLOATING
C10005 VDD.n1670 VSS 0.0532f ; **FLOATING
C10006 VDD.n1672 VSS 0.05434f ; **FLOATING
C10007 VDD.t1311 VSS 0.04614f ; **FLOATING
C10008 VDD.t239 VSS 0.03376f ; **FLOATING
C10009 VDD.t1651 VSS 0.11617f ; **FLOATING
C10010 VDD.n1673 VSS 0.14218f ; **FLOATING
C10011 VDD.n1674 VSS 0.12404f ; **FLOATING
C10012 VDD.t484 VSS 0.03383f ; **FLOATING
C10013 VDD.t482 VSS 0.02443f ; **FLOATING
C10014 VDD.t1007 VSS 0.03383f ; **FLOATING
C10015 VDD.n1675 VSS 0.02509f ; **FLOATING
C10016 VDD.t1066 VSS 0.03383f ; **FLOATING
C10017 VDD.t984 VSS 0.03383f ; **FLOATING
C10018 VDD.t1075 VSS 0.03383f ; **FLOATING
C10019 VDD.t1074 VSS 0.03383f ; **FLOATING
C10020 VDD.t1070 VSS 0.03383f ; **FLOATING
C10021 VDD.t1079 VSS 0.03383f ; **FLOATING
C10022 VDD.t970 VSS 0.03383f ; **FLOATING
C10023 VDD.n1676 VSS 0.02509f ; **FLOATING
C10024 VDD.t1071 VSS 0.03383f ; **FLOATING
C10025 VDD.n1677 VSS 0.02509f ; **FLOATING
C10026 VDD.t1069 VSS 0.03383f ; **FLOATING
C10027 VDD.n1678 VSS 0.02509f ; **FLOATING
C10028 VDD.t1078 VSS 0.03383f ; **FLOATING
C10029 VDD.t1077 VSS 0.03383f ; **FLOATING
C10030 VDD.t1081 VSS 0.03383f ; **FLOATING
C10031 VDD.t1076 VSS 0.03383f ; **FLOATING
C10032 VDD.n1679 VSS 0.02509f ; **FLOATING
C10033 VDD.t1067 VSS 0.03383f ; **FLOATING
C10034 VDD.n1680 VSS 0.02509f ; **FLOATING
C10035 VDD.t1084 VSS 0.03383f ; **FLOATING
C10036 VDD.t1083 VSS 0.03383f ; **FLOATING
C10037 VDD.n1681 VSS 0.02509f ; **FLOATING
C10038 VDD.t1082 VSS 0.03383f ; **FLOATING
C10039 VDD.t1080 VSS 0.03383f ; **FLOATING
C10040 VDD.t1072 VSS 0.03383f ; **FLOATING
C10041 VDD.t980 VSS 0.03383f ; **FLOATING
C10042 VDD.t1085 VSS 0.03383f ; **FLOATING
C10043 VDD.t1073 VSS 0.03383f ; **FLOATING
C10044 VDD.n1682 VSS 0.02509f ; **FLOATING
C10045 VDD.t959 VSS 0.03383f ; **FLOATING
C10046 VDD.t1087 VSS 0.03383f ; **FLOATING
C10047 VDD.t1086 VSS 0.03383f ; **FLOATING
C10048 VDD.t1068 VSS 0.03383f ; **FLOATING
C10049 VDD.t971 VSS 0.03383f ; **FLOATING
C10050 VDD.t1091 VSS 0.03383f ; **FLOATING
C10051 VDD.n1683 VSS 0.02509f ; **FLOATING
C10052 VDD.t1089 VSS 0.03383f ; **FLOATING
C10053 VDD.t1090 VSS 0.03383f ; **FLOATING
C10054 VDD.t1088 VSS 0.03383f ; **FLOATING
C10055 VDD.n1684 VSS 0.02509f ; **FLOATING
C10056 VDD.t490 VSS 0.03383f ; **FLOATING
C10057 VDD.t488 VSS 0.07098f ; **FLOATING
C10058 VDD.t489 VSS 0.03782f ; **FLOATING
C10059 VDD.t491 VSS 0.0327f ; **FLOATING
C10060 VDD.n1685 VSS 0.01667f ; **FLOATING
C10061 VDD.t492 VSS 0.03383f ; **FLOATING
C10062 VDD.t957 VSS 0.03968f ; **FLOATING
C10063 VDD.n1686 VSS 0.06287f ; **FLOATING
C10064 VDD.t1201 VSS 0.03968f ; **FLOATING
C10065 VDD.t865 VSS 0.03968f ; **FLOATING
C10066 VDD.t1271 VSS 0.03968f ; **FLOATING
C10067 VDD.n1687 VSS 0.06288f ; **FLOATING
C10068 VDD.t570 VSS 0.03968f ; **FLOATING
C10069 VDD.n1688 VSS 0.09412f ; **FLOATING
C10070 VDD.t737 VSS 0.03968f ; **FLOATING
C10071 VDD.t405 VSS 0.03968f ; **FLOATING
C10072 VDD.t705 VSS 0.03968f ; **FLOATING
C10073 VDD.n1689 VSS 0.08987f ; **FLOATING
C10074 VDD.t775 VSS 0.03968f ; **FLOATING
C10075 VDD.t357 VSS 0.03968f ; **FLOATING
C10076 VDD.n1690 VSS 0.0717f ; **FLOATING
C10077 VDD.t1142 VSS 0.03968f ; **FLOATING
C10078 VDD.t735 VSS 0.03968f ; **FLOATING
C10079 VDD.t398 VSS 0.03968f ; **FLOATING
C10080 VDD.t1526 VSS 0.03968f ; **FLOATING
C10081 VDD.t687 VSS 0.03968f ; **FLOATING
C10082 VDD.t509 VSS 0.03968f ; **FLOATING
C10083 VDD.n1691 VSS 0.07168f ; **FLOATING
C10084 VDD.t413 VSS 0.03968f ; **FLOATING
C10085 VDD.t532 VSS 0.03968f ; **FLOATING
C10086 VDD.n1692 VSS 0.06287f ; **FLOATING
C10087 VDD.t614 VSS 0.03968f ; **FLOATING
C10088 VDD.n1693 VSS 0.08184f ; **FLOATING
C10089 VDD.t639 VSS 0.03968f ; **FLOATING
C10090 VDD.t753 VSS 0.03968f ; **FLOATING
C10091 VDD.t403 VSS 0.03968f ; **FLOATING
C10092 VDD.t393 VSS 0.03968f ; **FLOATING
C10093 VDD.n1694 VSS 0.06288f ; **FLOATING
C10094 VDD.t700 VSS 0.03968f ; **FLOATING
C10095 VDD.n1695 VSS 0.08266f ; **FLOATING
C10096 VDD.n1696 VSS 0.06287f ; **FLOATING
C10097 VDD.t533 VSS 0.03968f ; **FLOATING
C10098 VDD.n1697 VSS 0.0629f ; **FLOATING
C10099 VDD.t410 VSS 0.03968f ; **FLOATING
C10100 VDD.t750 VSS 0.03968f ; **FLOATING
C10101 VDD.n1698 VSS 0.0934f ; **FLOATING
C10102 VDD.t649 VSS 0.03968f ; **FLOATING
C10103 VDD.t513 VSS 0.03968f ; **FLOATING
C10104 VDD.t836 VSS 0.03968f ; **FLOATING
C10105 VDD.t408 VSS 0.03968f ; **FLOATING
C10106 VDD.t386 VSS 0.03968f ; **FLOATING
C10107 VDD.n1699 VSS 0.07524f ; **FLOATING
C10108 VDD.n1700 VSS 0.08262f ; **FLOATING
C10109 VDD.n1701 VSS 0.0941f ; **FLOATING
C10110 VDD.n1702 VSS 0.09335f ; **FLOATING
C10111 VDD.n1703 VSS 0.08262f ; **FLOATING
C10112 VDD.n1704 VSS 0.08262f ; **FLOATING
C10113 VDD.n1705 VSS 0.08262f ; **FLOATING
C10114 VDD.n1706 VSS 0.08263f ; **FLOATING
C10115 VDD.n1707 VSS 0.0941f ; **FLOATING
C10116 VDD.n1708 VSS 0.09336f ; **FLOATING
C10117 VDD.n1709 VSS 0.08263f ; **FLOATING
C10118 VDD.n1710 VSS 0.08361f ; **FLOATING
C10119 VDD.n1711 VSS 0.09409f ; **FLOATING
C10120 VDD.n1712 VSS 0.07741f ; **FLOATING
C10121 VDD.n1714 VSS 0.04832f ; **FLOATING
C10122 VDD.n1715 VSS 0.02687f ; **FLOATING
C10123 VDD.n1716 VSS 0.09201f ; **FLOATING
C10124 VDD.n1717 VSS 0.05144f ; **FLOATING
C10125 VDD.n1718 VSS 0.11117f ; **FLOATING
C10126 VDD.n1719 VSS 0.05144f ; **FLOATING
C10127 VDD.n1720 VSS 0.11117f ; **FLOATING
C10128 VDD.n1721 VSS 0.05144f ; **FLOATING
C10129 VDD.n1722 VSS 0.11117f ; **FLOATING
C10130 VDD.n1723 VSS 0.05144f ; **FLOATING
C10131 VDD.n1724 VSS 0.11117f ; **FLOATING
C10132 VDD.n1725 VSS 0.05144f ; **FLOATING
C10133 VDD.n1726 VSS 0.11117f ; **FLOATING
C10134 VDD.n1727 VSS 0.05144f ; **FLOATING
C10135 VDD.n1728 VSS 0.11117f ; **FLOATING
C10136 VDD.n1729 VSS 0.049f ; **FLOATING
C10137 VDD.n1730 VSS 0.11117f ; **FLOATING
C10138 VDD.n1731 VSS 0.05144f ; **FLOATING
C10139 VDD.n1732 VSS 0.11117f ; **FLOATING
C10140 VDD.n1733 VSS 0.05144f ; **FLOATING
C10141 VDD.n1734 VSS 0.11117f ; **FLOATING
C10142 VDD.n1735 VSS 0.05144f ; **FLOATING
C10143 VDD.n1736 VSS 0.11117f ; **FLOATING
C10144 VDD.n1737 VSS 0.05144f ; **FLOATING
C10145 VDD.n1738 VSS 0.11117f ; **FLOATING
C10146 VDD.n1739 VSS 0.05144f ; **FLOATING
C10147 VDD.n1740 VSS 0.11117f ; **FLOATING
C10148 VDD.n1741 VSS 0.05144f ; **FLOATING
C10149 VDD.n1742 VSS 0.11117f ; **FLOATING
C10150 VDD.n1743 VSS 0.05144f ; **FLOATING
C10151 VDD.n1744 VSS 0.11117f ; **FLOATING
C10152 VDD.n1745 VSS 0.05144f ; **FLOATING
C10153 VDD.n1746 VSS 0.11117f ; **FLOATING
C10154 VDD.n1747 VSS 0.05144f ; **FLOATING
C10155 VDD.n1748 VSS 0.11117f ; **FLOATING
C10156 VDD.n1749 VSS 0.05144f ; **FLOATING
C10157 VDD.n1750 VSS 0.11117f ; **FLOATING
C10158 VDD.n1751 VSS 0.05144f ; **FLOATING
C10159 VDD.n1752 VSS 0.11117f ; **FLOATING
C10160 VDD.n1753 VSS 0.05144f ; **FLOATING
C10161 VDD.n1754 VSS 0.07184f ; **FLOATING
C10162 VDD.n1756 VSS 0.08368f ; **FLOATING
C10163 VDD.n1757 VSS 0.04257f ; **FLOATING
C10164 VDD.n1758 VSS 0.10168f ; **FLOATING
C10165 VDD.n1759 VSS 0.05144f ; **FLOATING
C10166 VDD.n1760 VSS 0.11117f ; **FLOATING
C10167 VDD.n1761 VSS 0.05144f ; **FLOATING
C10168 VDD.n1762 VSS 0.11117f ; **FLOATING
C10169 VDD.n1763 VSS 0.05144f ; **FLOATING
C10170 VDD.n1764 VSS 0.11117f ; **FLOATING
C10171 VDD.n1765 VSS 0.05144f ; **FLOATING
C10172 VDD.n1766 VSS 0.11117f ; **FLOATING
C10173 VDD.n1767 VSS 0.05144f ; **FLOATING
C10174 VDD.n1768 VSS 0.11117f ; **FLOATING
C10175 VDD.n1769 VSS 0.05144f ; **FLOATING
C10176 VDD.n1770 VSS 0.11117f ; **FLOATING
C10177 VDD.n1771 VSS 0.05144f ; **FLOATING
C10178 VDD.n1772 VSS 0.11117f ; **FLOATING
C10179 VDD.n1773 VSS 0.05144f ; **FLOATING
C10180 VDD.n1774 VSS 0.11117f ; **FLOATING
C10181 VDD.n1775 VSS 0.05144f ; **FLOATING
C10182 VDD.n1776 VSS 0.11117f ; **FLOATING
C10183 VDD.n1777 VSS 0.05144f ; **FLOATING
C10184 VDD.t485 VSS 0.01991f ; **FLOATING
C10185 VDD.t483 VSS 0.03782f ; **FLOATING
C10186 VDD.t1185 VSS 0.03503f ; **FLOATING
C10187 VDD.t425 VSS 0.03503f ; **FLOATING
C10188 VDD.t331 VSS 0.03145f ; **FLOATING
C10189 VDD.t949 VSS 0.03503f ; **FLOATING
C10190 VDD.n1778 VSS 0.06389f ; **FLOATING
C10191 VDD.n1779 VSS 0.01359f ; **FLOATING
C10192 VDD.n1780 VSS 0.02892f ; **FLOATING
C10193 VDD.t702 VSS 0.04597f ; **FLOATING
C10194 VDD.n1781 VSS 0.08818f ; **FLOATING
C10195 VDD.n1782 VSS 0.02579f ; **FLOATING
C10196 VDD.t765 VSS 0.03503f ; **FLOATING
C10197 VDD.n1783 VSS 0.0931f ; **FLOATING
C10198 VDD.n1784 VSS 0.01227f ; **FLOATING
C10199 VDD.n1785 VSS 0.01279f ; **FLOATING
C10200 VDD.t778 VSS 0.03904f ; **FLOATING
C10201 VDD.t538 VSS 0.03904f ; **FLOATING
C10202 VDD.n1786 VSS 0.08386f ; **FLOATING
C10203 VDD.n1787 VSS 0.01231f ; **FLOATING
C10204 VDD.n1788 VSS 0.01296f ; **FLOATING
C10205 VDD.t1200 VSS 0.03904f ; **FLOATING
C10206 VDD.t550 VSS 0.03904f ; **FLOATING
C10207 VDD.n1789 VSS 0.08323f ; **FLOATING
C10208 VDD.n1790 VSS 0.01237f ; **FLOATING
C10209 VDD.t955 VSS 0.03503f ; **FLOATING
C10210 VDD.t361 VSS 0.03503f ; **FLOATING
C10211 VDD.t349 VSS 0.02587f ; **FLOATING
C10212 VDD.t805 VSS 0.02587f ; **FLOATING
C10213 VDD.n1791 VSS 0.08393f ; **FLOATING
C10214 VDD.t1199 VSS 0.03458f ; **FLOATING
C10215 VDD.t549 VSS 0.03458f ; **FLOATING
C10216 VDD.n1792 VSS 0.06951f ; **FLOATING
C10217 VDD.n1793 VSS 0.01712f ; **FLOATING
C10218 VDD.t1186 VSS 0.02587f ; **FLOATING
C10219 VDD.t424 VSS 0.02587f ; **FLOATING
C10220 VDD.n1794 VSS 0.06926f ; **FLOATING
C10221 VDD.t777 VSS 0.03458f ; **FLOATING
C10222 VDD.t537 VSS 0.03458f ; **FLOATING
C10223 VDD.n1795 VSS 0.07416f ; **FLOATING
C10224 VDD.n1796 VSS 0.01249f ; **FLOATING
C10225 VDD.t954 VSS 0.02587f ; **FLOATING
C10226 VDD.t362 VSS 0.02587f ; **FLOATING
C10227 VDD.n1797 VSS 0.06903f ; **FLOATING
C10228 VDD.n1798 VSS 0.01204f ; **FLOATING
C10229 VDD.t348 VSS 0.03458f ; **FLOATING
C10230 VDD.t729 VSS 0.03458f ; **FLOATING
C10231 VDD.n1799 VSS 0.06998f ; **FLOATING
C10232 VDD.n1800 VSS 0.01709f ; **FLOATING
C10233 VDD.t793 VSS 0.03904f ; **FLOATING
C10234 VDD.t730 VSS 0.03904f ; **FLOATING
C10235 VDD.n1801 VSS 0.07822f ; **FLOATING
C10236 VDD.t1187 VSS 0.02587f ; **FLOATING
C10237 VDD.t426 VSS 0.02587f ; **FLOATING
C10238 VDD.n1802 VSS 0.06966f ; **FLOATING
C10239 VDD.n1803 VSS 0.01274f ; **FLOATING
C10240 VDD.t794 VSS 0.03458f ; **FLOATING
C10241 VDD.t363 VSS 0.03458f ; **FLOATING
C10242 VDD.n1804 VSS 0.07417f ; **FLOATING
C10243 VDD.t795 VSS 0.03904f ; **FLOATING
C10244 VDD.t1279 VSS 0.03904f ; **FLOATING
C10245 VDD.n1805 VSS 0.0125f ; **FLOATING
C10246 VDD.t606 VSS 0.03503f ; **FLOATING
C10247 VDD.t902 VSS 0.03515f ; **FLOATING
C10248 VDD.t762 VSS 0.03503f ; **FLOATING
C10249 VDD.n1806 VSS 0.07338f ; **FLOATING
C10250 VDD.n1807 VSS 0.01378f ; **FLOATING
C10251 VDD.t732 VSS 0.03503f ; **FLOATING
C10252 VDD.n1808 VSS 0.06362f ; **FLOATING
C10253 VDD.t901 VSS 0.03503f ; **FLOATING
C10254 VDD.n1809 VSS 0.05375f ; **FLOATING
C10255 VDD.n1810 VSS 0.01946f ; **FLOATING
C10256 VDD.t1264 VSS 0.03503f ; **FLOATING
C10257 VDD.t333 VSS 0.03145f ; **FLOATING
C10258 VDD.t334 VSS 0.03145f ; **FLOATING
C10259 VDD.t734 VSS 0.03503f ; **FLOATING
C10260 VDD.t332 VSS 0.03376f ; **FLOATING
C10261 VDD.t1671 VSS 0.11617f ; **FLOATING
C10262 VDD.t542 VSS 0.04597f ; **FLOATING
C10263 VDD.t335 VSS 0.03376f ; **FLOATING
C10264 VDD.t1670 VSS 0.11617f ; **FLOATING
C10265 VDD.n1811 VSS 0.14218f ; **FLOATING
C10266 VDD.n1812 VSS 0.08876f ; **FLOATING
C10267 VDD.t769 VSS 0.03503f ; **FLOATING
C10268 VDD.t337 VSS 0.03145f ; **FLOATING
C10269 VDD.t338 VSS 0.03145f ; **FLOATING
C10270 VDD.t341 VSS 0.03145f ; **FLOATING
C10271 VDD.t945 VSS 0.03503f ; **FLOATING
C10272 VDD.t1524 VSS 0.03503f ; **FLOATING
C10273 VDD.t611 VSS 0.03503f ; **FLOATING
C10274 VDD.t1322 VSS 0.03503f ; **FLOATING
C10275 VDD.t22 VSS 0.03145f ; **FLOATING
C10276 VDD.t399 VSS 0.04597f ; **FLOATING
C10277 VDD.t1303 VSS 0.03503f ; **FLOATING
C10278 VDD.t25 VSS 0.03145f ; **FLOATING
C10279 VDD.t746 VSS 0.03503f ; **FLOATING
C10280 VDD.t26 VSS 0.03145f ; **FLOATING
C10281 VDD.t766 VSS 0.03503f ; **FLOATING
C10282 VDD.t29 VSS 0.03145f ; **FLOATING
C10283 VDD.t30 VSS 0.03145f ; **FLOATING
C10284 VDD.t1170 VSS 0.04614f ; **FLOATING
C10285 VDD.n1813 VSS 0.01946f ; **FLOATING
C10286 VDD.t783 VSS 0.03503f ; **FLOATING
C10287 VDD.n1814 VSS 0.06362f ; **FLOATING
C10288 VDD.n1815 VSS 0.01378f ; **FLOATING
C10289 VDD.t33 VSS 0.03145f ; **FLOATING
C10290 VDD.n1816 VSS 0.05434f ; **FLOATING
C10291 VDD.t946 VSS 0.03503f ; **FLOATING
C10292 VDD.n1817 VSS 0.0532f ; **FLOATING
C10293 VDD.t1328 VSS 0.03503f ; **FLOATING
C10294 VDD.n1819 VSS 0.05375f ; **FLOATING
C10295 VDD.n1820 VSS 0.01359f ; **FLOATING
C10296 VDD.t1323 VSS 0.03503f ; **FLOATING
C10297 VDD.n1821 VSS 0.06417f ; **FLOATING
C10298 VDD.t10 VSS 0.03145f ; **FLOATING
C10299 VDD.t1198 VSS 0.04597f ; **FLOATING
C10300 VDD.t13 VSS 0.03145f ; **FLOATING
C10301 VDD.t1266 VSS 0.03503f ; **FLOATING
C10302 VDD.t14 VSS 0.03145f ; **FLOATING
C10303 VDD.t1605 VSS 0.03503f ; **FLOATING
C10304 VDD.t763 VSS 0.03503f ; **FLOATING
C10305 VDD.t17 VSS 0.03145f ; **FLOATING
C10306 VDD.t18 VSS 0.03145f ; **FLOATING
C10307 VDD.t21 VSS 0.03145f ; **FLOATING
C10308 VDD.t913 VSS 0.03503f ; **FLOATING
C10309 VDD.t411 VSS 0.03503f ; **FLOATING
C10310 VDD.t940 VSS 0.03503f ; **FLOATING
C10311 VDD.t1325 VSS 0.03503f ; **FLOATING
C10312 VDD.t743 VSS 0.04597f ; **FLOATING
C10313 VDD.t1252 VSS 0.03503f ; **FLOATING
C10314 VDD.t1530 VSS 0.03503f ; **FLOATING
C10315 VDD.t712 VSS 0.03503f ; **FLOATING
C10316 VDD.t761 VSS 0.03503f ; **FLOATING
C10317 VDD.t713 VSS 0.03719f ; **FLOATING
C10318 VDD.t402 VSS 0.04597f ; **FLOATING
C10319 VDD.t714 VSS 0.06567f ; **FLOATING
C10320 VDD.t944 VSS 0.03503f ; **FLOATING
C10321 VDD.t540 VSS 0.03503f ; **FLOATING
C10322 VDD.t1314 VSS 0.03503f ; **FLOATING
C10323 VDD.t1321 VSS 0.03503f ; **FLOATING
C10324 VDD.t135 VSS 0.03145f ; **FLOATING
C10325 VDD.t605 VSS 0.04597f ; **FLOATING
C10326 VDD.t943 VSS 0.03503f ; **FLOATING
C10327 VDD.t138 VSS 0.03145f ; **FLOATING
C10328 VDD.t388 VSS 0.03503f ; **FLOATING
C10329 VDD.t139 VSS 0.03145f ; **FLOATING
C10330 VDD.t767 VSS 0.03503f ; **FLOATING
C10331 VDD.t142 VSS 0.03145f ; **FLOATING
C10332 VDD.t143 VSS 0.03145f ; **FLOATING
C10333 VDD.t539 VSS 0.04614f ; **FLOATING
C10334 VDD.n1822 VSS 0.01946f ; **FLOATING
C10335 VDD.t1177 VSS 0.03503f ; **FLOATING
C10336 VDD.n1823 VSS 0.06362f ; **FLOATING
C10337 VDD.n1824 VSS 0.01378f ; **FLOATING
C10338 VDD.t146 VSS 0.03145f ; **FLOATING
C10339 VDD.t947 VSS 0.03503f ; **FLOATING
C10340 VDD.n1825 VSS 0.0532f ; **FLOATING
C10341 VDD.t612 VSS 0.03503f ; **FLOATING
C10342 VDD.n1827 VSS 0.05375f ; **FLOATING
C10343 VDD.n1828 VSS 0.01359f ; **FLOATING
C10344 VDD.t1324 VSS 0.03503f ; **FLOATING
C10345 VDD.n1829 VSS 0.06389f ; **FLOATING
C10346 VDD.t210 VSS 0.03145f ; **FLOATING
C10347 VDD.t748 VSS 0.04597f ; **FLOATING
C10348 VDD.t213 VSS 0.03145f ; **FLOATING
C10349 VDD.t1267 VSS 0.03503f ; **FLOATING
C10350 VDD.t214 VSS 0.03145f ; **FLOATING
C10351 VDD.t646 VSS 0.03503f ; **FLOATING
C10352 VDD.t764 VSS 0.03503f ; **FLOATING
C10353 VDD.t217 VSS 0.03145f ; **FLOATING
C10354 VDD.t218 VSS 0.03145f ; **FLOATING
C10355 VDD.t178 VSS 0.03145f ; **FLOATING
C10356 VDD.t914 VSS 0.03503f ; **FLOATING
C10357 VDD.t1614 VSS 0.03503f ; **FLOATING
C10358 VDD.t613 VSS 0.03503f ; **FLOATING
C10359 VDD.t1326 VSS 0.03503f ; **FLOATING
C10360 VDD.t181 VSS 0.03145f ; **FLOATING
C10361 VDD.t395 VSS 0.04597f ; **FLOATING
C10362 VDD.t1253 VSS 0.03503f ; **FLOATING
C10363 VDD.t284 VSS 0.03145f ; **FLOATING
C10364 VDD.t1137 VSS 0.03503f ; **FLOATING
C10365 VDD.t164 VSS 0.03145f ; **FLOATING
C10366 VDD.t768 VSS 0.03503f ; **FLOATING
C10367 VDD.t243 VSS 0.03145f ; **FLOATING
C10368 VDD.t244 VSS 0.03145f ; **FLOATING
C10369 VDD.t715 VSS 0.04614f ; **FLOATING
C10370 VDD.n1830 VSS 0.01946f ; **FLOATING
C10371 VDD.t1257 VSS 0.03503f ; **FLOATING
C10372 VDD.n1831 VSS 0.06362f ; **FLOATING
C10373 VDD.n1832 VSS 0.01378f ; **FLOATING
C10374 VDD.t247 VSS 0.03145f ; **FLOATING
C10375 VDD.n1833 VSS 0.05434f ; **FLOATING
C10376 VDD.t770 VSS 0.03503f ; **FLOATING
C10377 VDD.n1834 VSS 0.0532f ; **FLOATING
C10378 VDD.t1162 VSS 0.03503f ; **FLOATING
C10379 VDD.n1836 VSS 0.05375f ; **FLOATING
C10380 VDD.n1837 VSS 0.01359f ; **FLOATING
C10381 VDD.t948 VSS 0.03503f ; **FLOATING
C10382 VDD.n1838 VSS 0.06373f ; **FLOATING
C10383 VDD.n1839 VSS 0.02579f ; **FLOATING
C10384 VDD.t367 VSS 0.04597f ; **FLOATING
C10385 VDD.n1840 VSS 0.0935f ; **FLOATING
C10386 VDD.t1265 VSS 0.0384f ; **FLOATING
C10387 VDD.n1841 VSS 0.12463f ; **FLOATING
C10388 VDD.t245 VSS 0.03376f ; **FLOATING
C10389 VDD.t1654 VSS 0.11617f ; **FLOATING
C10390 VDD.n1842 VSS 0.14218f ; **FLOATING
C10391 VDD.t165 VSS 0.03376f ; **FLOATING
C10392 VDD.t1655 VSS 0.11617f ; **FLOATING
C10393 VDD.n1843 VSS 0.14218f ; **FLOATING
C10394 VDD.n1844 VSS 0.08876f ; **FLOATING
C10395 VDD.t182 VSS 0.03376f ; **FLOATING
C10396 VDD.t1656 VSS 0.11617f ; **FLOATING
C10397 VDD.n1845 VSS 0.06389f ; **FLOATING
C10398 VDD.n1846 VSS 0.01359f ; **FLOATING
C10399 VDD.n1847 VSS 0.05375f ; **FLOATING
C10400 VDD.n1848 VSS 0.01946f ; **FLOATING
C10401 VDD.n1849 VSS 0.06362f ; **FLOATING
C10402 VDD.n1850 VSS 0.01378f ; **FLOATING
C10403 VDD.n1851 VSS 0.0532f ; **FLOATING
C10404 VDD.n1853 VSS 0.05434f ; **FLOATING
C10405 VDD.t859 VSS 0.04614f ; **FLOATING
C10406 VDD.t177 VSS 0.03376f ; **FLOATING
C10407 VDD.t1657 VSS 0.11617f ; **FLOATING
C10408 VDD.n1854 VSS 0.14218f ; **FLOATING
C10409 VDD.n1855 VSS 0.12404f ; **FLOATING
C10410 VDD.t215 VSS 0.03376f ; **FLOATING
C10411 VDD.t1658 VSS 0.11617f ; **FLOATING
C10412 VDD.n1856 VSS 0.14218f ; **FLOATING
C10413 VDD.t211 VSS 0.03376f ; **FLOATING
C10414 VDD.t1659 VSS 0.11617f ; **FLOATING
C10415 VDD.t144 VSS 0.03376f ; **FLOATING
C10416 VDD.t1660 VSS 0.11617f ; **FLOATING
C10417 VDD.n1857 VSS 0.14218f ; **FLOATING
C10418 VDD.t140 VSS 0.03376f ; **FLOATING
C10419 VDD.t1661 VSS 0.11617f ; **FLOATING
C10420 VDD.n1858 VSS 0.14218f ; **FLOATING
C10421 VDD.n1859 VSS 0.08876f ; **FLOATING
C10422 VDD.t136 VSS 0.03376f ; **FLOATING
C10423 VDD.t1662 VSS 0.11617f ; **FLOATING
C10424 VDD.n1860 VSS 0.06389f ; **FLOATING
C10425 VDD.n1861 VSS 0.01359f ; **FLOATING
C10426 VDD.n1862 VSS 0.05375f ; **FLOATING
C10427 VDD.n1863 VSS 0.01946f ; **FLOATING
C10428 VDD.n1864 VSS 0.06362f ; **FLOATING
C10429 VDD.n1865 VSS 0.01378f ; **FLOATING
C10430 VDD.n1866 VSS 0.07803f ; **FLOATING
C10431 VDD.n1867 VSS 0.01181f ; **FLOATING
C10432 VDD.n1868 VSS 0.07514f ; **FLOATING
C10433 VDD.n1869 VSS 0.07338f ; **FLOATING
C10434 VDD.n1870 VSS 0.02892f ; **FLOATING
C10435 VDD.n1871 VSS 0.08818f ; **FLOATING
C10436 VDD.n1872 VSS 0.02579f ; **FLOATING
C10437 VDD.n1873 VSS 0.06373f ; **FLOATING
C10438 VDD.n1874 VSS 0.01359f ; **FLOATING
C10439 VDD.n1875 VSS 0.05375f ; **FLOATING
C10440 VDD.n1876 VSS 0.01946f ; **FLOATING
C10441 VDD.n1877 VSS 0.06362f ; **FLOATING
C10442 VDD.n1878 VSS 0.01378f ; **FLOATING
C10443 VDD.n1879 VSS 0.0532f ; **FLOATING
C10444 VDD.n1881 VSS 0.05434f ; **FLOATING
C10445 VDD.t391 VSS 0.04614f ; **FLOATING
C10446 VDD.t19 VSS 0.03376f ; **FLOATING
C10447 VDD.t1663 VSS 0.11617f ; **FLOATING
C10448 VDD.n1882 VSS 0.14218f ; **FLOATING
C10449 VDD.n1883 VSS 0.12404f ; **FLOATING
C10450 VDD.t15 VSS 0.03376f ; **FLOATING
C10451 VDD.t1664 VSS 0.11617f ; **FLOATING
C10452 VDD.n1884 VSS 0.14218f ; **FLOATING
C10453 VDD.t11 VSS 0.03376f ; **FLOATING
C10454 VDD.t1665 VSS 0.11617f ; **FLOATING
C10455 VDD.t31 VSS 0.03376f ; **FLOATING
C10456 VDD.t1666 VSS 0.11617f ; **FLOATING
C10457 VDD.n1885 VSS 0.14218f ; **FLOATING
C10458 VDD.t27 VSS 0.03376f ; **FLOATING
C10459 VDD.t1667 VSS 0.11617f ; **FLOATING
C10460 VDD.n1886 VSS 0.14218f ; **FLOATING
C10461 VDD.n1887 VSS 0.08876f ; **FLOATING
C10462 VDD.t23 VSS 0.03376f ; **FLOATING
C10463 VDD.t1668 VSS 0.11617f ; **FLOATING
C10464 VDD.n1888 VSS 0.06389f ; **FLOATING
C10465 VDD.n1889 VSS 0.01359f ; **FLOATING
C10466 VDD.n1890 VSS 0.05375f ; **FLOATING
C10467 VDD.n1891 VSS 0.01946f ; **FLOATING
C10468 VDD.n1892 VSS 0.06362f ; **FLOATING
C10469 VDD.n1893 VSS 0.01378f ; **FLOATING
C10470 VDD.n1894 VSS 0.0532f ; **FLOATING
C10471 VDD.n1896 VSS 0.05434f ; **FLOATING
C10472 VDD.t803 VSS 0.04614f ; **FLOATING
C10473 VDD.t339 VSS 0.03376f ; **FLOATING
C10474 VDD.t1669 VSS 0.11617f ; **FLOATING
C10475 VDD.n1897 VSS 0.14218f ; **FLOATING
C10476 VDD.n1898 VSS 0.12404f ; **FLOATING
C10477 VDD.t477 VSS 0.07098f ; **FLOATING
C10478 VDD.n1900 VSS 0.02687f ; **FLOATING
C10479 VDD.n1901 VSS 0.05144f ; **FLOATING
C10480 VDD.n1902 VSS 0.05144f ; **FLOATING
C10481 VDD.n1903 VSS 0.05144f ; **FLOATING
C10482 VDD.n1904 VSS 0.05144f ; **FLOATING
C10483 VDD.n1905 VSS 0.05144f ; **FLOATING
C10484 VDD.n1906 VSS 0.05144f ; **FLOATING
C10485 VDD.n1907 VSS 0.05144f ; **FLOATING
C10486 VDD.n1908 VSS 0.05144f ; **FLOATING
C10487 VDD.n1909 VSS 0.05144f ; **FLOATING
C10488 VDD.n1910 VSS 0.05144f ; **FLOATING
C10489 VDD.n1911 VSS 0.05144f ; **FLOATING
C10490 VDD.n1912 VSS 0.05144f ; **FLOATING
C10491 VDD.n1913 VSS 0.05144f ; **FLOATING
C10492 VDD.n1914 VSS 0.05144f ; **FLOATING
C10493 VDD.n1915 VSS 0.05144f ; **FLOATING
C10494 VDD.n1916 VSS 0.05144f ; **FLOATING
C10495 VDD.n1917 VSS 0.05144f ; **FLOATING
C10496 VDD.n1918 VSS 0.05144f ; **FLOATING
C10497 VDD.n1920 VSS 0.08368f ; **FLOATING
C10498 VDD.n1921 VSS 0.04257f ; **FLOATING
C10499 VDD.n1922 VSS 0.05144f ; **FLOATING
C10500 VDD.n1923 VSS 0.05144f ; **FLOATING
C10501 VDD.n1924 VSS 0.05144f ; **FLOATING
C10502 VDD.n1925 VSS 0.05144f ; **FLOATING
C10503 VDD.n1926 VSS 0.05144f ; **FLOATING
C10504 VDD.n1927 VSS 0.05144f ; **FLOATING
C10505 VDD.n1928 VSS 0.05144f ; **FLOATING
C10506 VDD.n1929 VSS 0.05144f ; **FLOATING
C10507 VDD.n1930 VSS 0.05417f ; **FLOATING
C10508 VDD.n1931 VSS 0.06306f ; **FLOATING
C10509 VDD.t480 VSS 0.0327f ; **FLOATING
C10510 VDD.n1932 VSS 0.01667f ; **FLOATING
C10511 VDD.t481 VSS 0.03383f ; **FLOATING
C10512 VDD.n1933 VSS 0.02247f ; **FLOATING
C10513 VDD.n1934 VSS 0.07913f ; **FLOATING
C10514 VDD.n1935 VSS 0.03371f ; **FLOATING
C10515 VDD.t478 VSS 0.03782f ; **FLOATING
C10516 VDD.n1936 VSS 0.04832f ; **FLOATING
C10517 VDD.t479 VSS 0.03383f ; **FLOATING
C10518 VDD.t788 VSS 0.03968f ; **FLOATING
C10519 VDD.n1937 VSS 0.09201f ; **FLOATING
C10520 VDD.t978 VSS 0.03383f ; **FLOATING
C10521 VDD.t896 VSS 0.03968f ; **FLOATING
C10522 VDD.n1938 VSS 0.10128f ; **FLOATING
C10523 VDD.n1939 VSS 0.11117f ; **FLOATING
C10524 VDD.t967 VSS 0.03383f ; **FLOATING
C10525 VDD.t1256 VSS 0.03968f ; **FLOATING
C10526 VDD.n1940 VSS 0.11117f ; **FLOATING
C10527 VDD.t1064 VSS 0.03383f ; **FLOATING
C10528 VDD.t907 VSS 0.03968f ; **FLOATING
C10529 VDD.n1941 VSS 0.11117f ; **FLOATING
C10530 VDD.t1065 VSS 0.03383f ; **FLOATING
C10531 VDD.t1138 VSS 0.03968f ; **FLOATING
C10532 VDD.n1942 VSS 0.11117f ; **FLOATING
C10533 VDD.t1062 VSS 0.03383f ; **FLOATING
C10534 VDD.n1943 VSS 0.02509f ; **FLOATING
C10535 VDD.n1944 VSS 0.0717f ; **FLOATING
C10536 VDD.t394 VSS 0.03968f ; **FLOATING
C10537 VDD.n1945 VSS 0.11117f ; **FLOATING
C10538 VDD.t965 VSS 0.03383f ; **FLOATING
C10539 VDD.t908 VSS 0.03968f ; **FLOATING
C10540 VDD.n1946 VSS 0.09335f ; **FLOATING
C10541 VDD.n1947 VSS 0.11117f ; **FLOATING
C10542 VDD.t1063 VSS 0.03383f ; **FLOATING
C10543 VDD.t1499 VSS 0.03968f ; **FLOATING
C10544 VDD.t958 VSS 0.03383f ; **FLOATING
C10545 VDD.t551 VSS 0.03968f ; **FLOATING
C10546 VDD.n1948 VSS 0.11117f ; **FLOATING
C10547 VDD.t966 VSS 0.03383f ; **FLOATING
C10548 VDD.t660 VSS 0.03968f ; **FLOATING
C10549 VDD.n1949 VSS 0.11117f ; **FLOATING
C10550 VDD.t1061 VSS 0.03383f ; **FLOATING
C10551 VDD.t1178 VSS 0.03968f ; **FLOATING
C10552 VDD.n1950 VSS 0.08265f ; **FLOATING
C10553 VDD.n1951 VSS 0.11117f ; **FLOATING
C10554 VDD.t977 VSS 0.03383f ; **FLOATING
C10555 VDD.n1952 VSS 0.02509f ; **FLOATING
C10556 VDD.n1953 VSS 0.06287f ; **FLOATING
C10557 VDD.t780 VSS 0.03968f ; **FLOATING
C10558 VDD.n1954 VSS 0.08262f ; **FLOATING
C10559 VDD.n1955 VSS 0.01471f ; **FLOATING
C10560 VDD.n1956 VSS 0.11117f ; **FLOATING
C10561 VDD.t1060 VSS 0.03383f ; **FLOATING
C10562 VDD.n1957 VSS 0.02509f ; **FLOATING
C10563 VDD.n1958 VSS 0.06286f ; **FLOATING
C10564 VDD.t387 VSS 0.03968f ; **FLOATING
C10565 VDD.n1959 VSS 0.0826f ; **FLOATING
C10566 VDD.n1960 VSS 0.11117f ; **FLOATING
C10567 VDD.t979 VSS 0.03383f ; **FLOATING
C10568 VDD.n1961 VSS 0.02509f ; **FLOATING
C10569 VDD.n1962 VSS 0.0629f ; **FLOATING
C10570 VDD.t604 VSS 0.03968f ; **FLOATING
C10571 VDD.n1963 VSS 0.11117f ; **FLOATING
C10572 VDD.t981 VSS 0.03383f ; **FLOATING
C10573 VDD.n1964 VSS 0.02509f ; **FLOATING
C10574 VDD.t541 VSS 0.03968f ; **FLOATING
C10575 VDD.n1965 VSS 0.11117f ; **FLOATING
C10576 VDD.t1059 VSS 0.03383f ; **FLOATING
C10577 VDD.t346 VSS 0.03968f ; **FLOATING
C10578 VDD.n1966 VSS 0.11117f ; **FLOATING
C10579 VDD.t1058 VSS 0.03383f ; **FLOATING
C10580 VDD.t400 VSS 0.03968f ; **FLOATING
C10581 VDD.n1967 VSS 0.11117f ; **FLOATING
C10582 VDD.t986 VSS 0.03383f ; **FLOATING
C10583 VDD.t744 VSS 0.03968f ; **FLOATING
C10584 VDD.n1968 VSS 0.11117f ; **FLOATING
C10585 VDD.t1057 VSS 0.03383f ; **FLOATING
C10586 VDD.t412 VSS 0.03968f ; **FLOATING
C10587 VDD.n1969 VSS 0.11117f ; **FLOATING
C10588 VDD.t1055 VSS 0.03383f ; **FLOATING
C10589 VDD.t392 VSS 0.03968f ; **FLOATING
C10590 VDD.n1970 VSS 0.11117f ; **FLOATING
C10591 VDD.t1056 VSS 0.03383f ; **FLOATING
C10592 VDD.t796 VSS 0.03968f ; **FLOATING
C10593 VDD.n1971 VSS 0.07184f ; **FLOATING
C10594 VDD.t991 VSS 0.03383f ; **FLOATING
C10595 VDD.n1972 VSS 0.02509f ; **FLOATING
C10596 VDD.n1973 VSS 0.03789f ; **FLOATING
C10597 VDD.n1974 VSS 0.01129f ; **FLOATING
C10598 VDD.n1975 VSS 0.06666f ; **FLOATING
C10599 VDD.t1286 VSS 0.03968f ; **FLOATING
C10600 VDD.n1976 VSS 0.08434f ; **FLOATING
C10601 VDD.n1977 VSS 0.10168f ; **FLOATING
C10602 VDD.t969 VSS 0.03383f ; **FLOATING
C10603 VDD.t784 VSS 0.03968f ; **FLOATING
C10604 VDD.n1978 VSS 0.11117f ; **FLOATING
C10605 VDD.t993 VSS 0.03383f ; **FLOATING
C10606 VDD.t1169 VSS 0.03968f ; **FLOATING
C10607 VDD.n1979 VSS 0.11117f ; **FLOATING
C10608 VDD.t1054 VSS 0.03383f ; **FLOATING
C10609 VDD.n1980 VSS 0.02509f ; **FLOATING
C10610 VDD.t508 VSS 0.03968f ; **FLOATING
C10611 VDD.n1981 VSS 0.11117f ; **FLOATING
C10612 VDD.t994 VSS 0.03383f ; **FLOATING
C10613 VDD.t1288 VSS 0.03968f ; **FLOATING
C10614 VDD.n1982 VSS 0.11117f ; **FLOATING
C10615 VDD.t1053 VSS 0.03383f ; **FLOATING
C10616 VDD.t1525 VSS 0.03968f ; **FLOATING
C10617 VDD.n1983 VSS 0.08981f ; **FLOATING
C10618 VDD.n1984 VSS 0.01471f ; **FLOATING
C10619 VDD.n1985 VSS 0.11117f ; **FLOATING
C10620 VDD.t990 VSS 0.03383f ; **FLOATING
C10621 VDD.n1986 VSS 0.02509f ; **FLOATING
C10622 VDD.t893 VSS 0.03968f ; **FLOATING
C10623 VDD.n1987 VSS 0.11117f ; **FLOATING
C10624 VDD.t992 VSS 0.03383f ; **FLOATING
C10625 VDD.t573 VSS 0.03968f ; **FLOATING
C10626 VDD.n1988 VSS 0.11117f ; **FLOATING
C10627 VDD.t1051 VSS 0.03383f ; **FLOATING
C10628 VDD.t563 VSS 0.03968f ; **FLOATING
C10629 VDD.n1989 VSS 0.13f ; **FLOATING
C10630 VDD.t1052 VSS 0.03383f ; **FLOATING
C10631 VDD.t731 VSS 0.03968f ; **FLOATING
C10632 VDD.t1050 VSS 0.03383f ; **FLOATING
C10633 VDD.t350 VSS 0.03968f ; **FLOATING
C10634 VDD.t968 VSS 0.03498f ; **FLOATING
C10635 VDD.t472 VSS 0.03782f ; **FLOATING
C10636 VDD.t473 VSS 0.03531f ; **FLOATING
C10637 VDD.t471 VSS 0.02443f ; **FLOATING
C10638 VDD.n1990 VSS 0.07168f ; **FLOATING
C10639 VDD.n1991 VSS 0.01471f ; **FLOATING
C10640 VDD.n1992 VSS 0.0826f ; **FLOATING
C10641 VDD.n1993 VSS 0.09409f ; **FLOATING
C10642 VDD.n1994 VSS 0.0717f ; **FLOATING
C10643 VDD.n1995 VSS 0.01471f ; **FLOATING
C10644 VDD.n1996 VSS 0.08262f ; **FLOATING
C10645 VDD.n1997 VSS 0.08262f ; **FLOATING
C10646 VDD.n1998 VSS 0.67331f ; **FLOATING
C10647 VDD.n1999 VSS 0.0157f ; **FLOATING
C10648 VDD.t776 VSS 0.02311f ; **FLOATING
C10649 VDD.n2000 VSS 0.06524f ; **FLOATING
C10650 VDD.n2001 VSS 0.01634f ; **FLOATING
C10651 VDD.n2002 VSS 0.01667f ; **FLOATING
C10652 VDD.n2003 VSS 0.0722f ; **FLOATING
C10653 VDD.t456 VSS 0.06753f ; **FLOATING
C10654 VDD.n2004 VSS 0.02358f ; **FLOATING
C10655 VDD.n2005 VSS 0.05282f ; **FLOATING
C10656 VDD.t451 VSS 0.06042f ; **FLOATING
C10657 VDD.n2006 VSS 0.02355f ; **FLOATING
C10658 VDD.t457 VSS 0.06042f ; **FLOATING
C10659 VDD.n2007 VSS 0.06763f ; **FLOATING
C10660 VDD.n2008 VSS 0.02356f ; **FLOATING
C10661 VDD.n2009 VSS 0.04771f ; **FLOATING
C10662 VDD.t449 VSS 0.38206f ; **FLOATING
C10663 VDD.n2010 VSS 0.01542f ; **FLOATING
C10664 VDD.n2011 VSS 0.04769f ; **FLOATING
C10665 VDD.t450 VSS 0.06753f ; **FLOATING
C10666 VDD.n2012 VSS 0.02358f ; **FLOATING
C10667 VDD.n2013 VSS 0.07216f ; **FLOATING
C10668 VDD.n2014 VSS 0.03804f ; **FLOATING
C10669 VDD.n2015 VSS 0.09184f ; **FLOATING
C10670 VDD.t663 VSS 0.06753f ; **FLOATING
C10671 VDD.n2016 VSS 0.04381f ; **FLOATING
C10672 VDD.t662 VSS 0.06753f ; **FLOATING
C10673 VDD.n2017 VSS 0.04382f ; **FLOATING
C10674 VDD.n2018 VSS 0.09189f ; **FLOATING
C10675 VDD.n2019 VSS 0.03318f ; **FLOATING
C10676 VDD.n2020 VSS 0.09206f ; **FLOATING
C10677 VDD.t664 VSS 0.06753f ; **FLOATING
C10678 VDD.n2021 VSS 0.04381f ; **FLOATING
C10679 VDD.t666 VSS 0.06753f ; **FLOATING
C10680 VDD.n2022 VSS 0.04382f ; **FLOATING
C10681 VDD.n2023 VSS 0.09206f ; **FLOATING
C10682 VDD.n2024 VSS 0.03795f ; **FLOATING
C10683 VDD.n2025 VSS 0.08697f ; **FLOATING
C10684 VDD.t674 VSS 0.06753f ; **FLOATING
C10685 VDD.n2026 VSS 0.04381f ; **FLOATING
C10686 VDD.t668 VSS 0.06753f ; **FLOATING
C10687 VDD.n2027 VSS 0.04382f ; **FLOATING
C10688 VDD.n2028 VSS 0.08698f ; **FLOATING
C10689 VDD.n2029 VSS 0.03811f ; **FLOATING
C10690 VDD.n2030 VSS 0.01668f ; **FLOATING
C10691 VDD.t454 VSS 0.06042f ; **FLOATING
C10692 VDD.t459 VSS 0.06042f ; **FLOATING
C10693 VDD.n2031 VSS 0.07827f ; **FLOATING
C10694 VDD.n2032 VSS 0.02356f ; **FLOATING
C10695 VDD.t453 VSS 0.06753f ; **FLOATING
C10696 VDD.n2033 VSS 0.07218f ; **FLOATING
C10697 VDD.n2034 VSS 0.02358f ; **FLOATING
C10698 VDD.n2035 VSS 0.07217f ; **FLOATING
C10699 VDD.t460 VSS 0.06753f ; **FLOATING
C10700 VDD.n2036 VSS 0.02358f ; **FLOATING
C10701 VDD.n2037 VSS 0.04769f ; **FLOATING
C10702 VDD.t452 VSS 0.38206f ; **FLOATING
C10703 VDD.n2038 VSS 0.01542f ; **FLOATING
C10704 VDD.n2039 VSS 0.05111f ; **FLOATING
C10705 VDD.n2040 VSS 0.02355f ; **FLOATING
C10706 VDD.n2041 VSS 0.086f ; **FLOATING
C10707 VDD.n2042 VSS 0.05023f ; **FLOATING
C10708 VDD.t358 VSS 13.3005f ; **FLOATING
.ends
