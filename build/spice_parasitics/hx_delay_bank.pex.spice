* NGSPICE file created from hx_delay_bank.ext - technology: ihp-sg13g2

.subckt hx_delay_bank VDD CHAN0_DELAY_OUT_LAST CHAN1_DELAY_OUT_LAST CHAN3_DELAY_OUT_LAST
+ CHAN2_DELAY_OUT_LAST REF_DELAY_OUT_LAST DLL_RESETN REF_CLK VSS CHAN0_DELAY_IN CHAN0_MUX_SEL0
+ CHAN0_MUX_SEL1 CHAN0_MUX_OUT CHAN0_MUX_SEL4 CHAN0_MUX_SEL2 CHAN0_MUX_SEL3 CHAN1_DELAY_IN
+ CHAN1_MUX_SEL0 CHAN1_MUX_SEL1 CHAN1_MUX_OUT CHAN1_MUX_SEL4 CHAN1_MUX_SEL2 CHAN1_MUX_SEL3
+ CHAN3_DELAY_IN CHAN2_DELAY_IN CHAN3_MUX_SEL0 CHAN2_MUX_SEL0 CHAN3_MUX_SEL1 CHAN2_MUX_SEL1
+ CHAN3_MUX_OUT CHAN2_MUX_OUT CHAN3_MUX_SEL4 CHAN2_MUX_SEL4 CHAN3_MUX_SEL2 CHAN2_MUX_SEL2
+ CHAN3_MUX_SEL3 CHAN2_MUX_SEL3 REF_MUX_SEL0 REF_MUX_SEL1 REF_MUX_OUT REF_MUX_SEL4
+ REF_MUX_SEL2 REF_MUX_SEL3
X0 VDD.t869 a_4003_1842# a_4437_1842# VDD.t399 sg13_lv_pmos ad=0.2128p pd=1.5u as=0.3808p ps=2.92u w=1.12u l=0.13u
X1 VSS.t84 a_4187_1764.t102 a_26151_14024# VSS.t83 sg13_lv_nmos ad=0.2516p pd=2.16u as=0.1406p ps=1.12u w=0.74u l=0.6u
X2 a_22590_3889# a_22564_3853# a_22488_3889# VDD.t0 sg13_lv_pmos ad=0.3808p pd=2.92u as=0.2128p ps=1.5u w=1.12u l=0.13u
X3 a_15511_8160# a_15273_7532# a_15403_7532# VDD.t275 sg13_lv_pmos ad=0.2128p pd=1.5u as=0.3808p ps=2.92u w=1.12u l=0.2u
X4 a_5974_11413# a_6126_9506# VSS.t24 VSS.t17 sg13_lv_nmos ad=0.38p pd=2.38u as=0.68p ps=4.68u w=2u l=1u
X5 VDD.t1020 a_3171_16074.t4 a_21044_16035# VDD.t4 sg13_lv_pmos ad=0.3808p pd=2.92u as=0.3808p ps=2.92u w=1.12u l=0.13u
X6 a_14751_14652# a_14513_14024# a_14643_14024# VDD.t301 sg13_lv_pmos ad=0.2128p pd=1.5u as=0.3808p ps=2.92u w=1.12u l=0.2u
X7 VSS.t2379 VSS.t2379 VSS.t2378 VSS.t2380 sg13_lv_nmos ad=0.1406p pd=1.12u as=0 ps=0 w=0.74u l=0.2u
X8 a_18551_5315# a_18313_4687# a_18443_4687# VDD.t281 sg13_lv_pmos ad=0.2128p pd=1.5u as=0.3808p ps=2.92u w=1.12u l=0.2u
X9 a_5731_15316# a_14825_15546# a_13470_16071# VDD.t4 sg13_lv_pmos ad=0.3808p pd=2.92u as=0.3808p ps=2.92u w=1.12u l=0.13u
X10 a_19073_14024# a_18877_14024# VDD.t1420 VDD.t301 sg13_lv_pmos ad=0.3808p pd=2.92u as=0.2128p ps=1.5u w=1.12u l=0.13u
X11 VDD.t53 VSS.t815 VDD.t127 VDD.t4 sg13_lv_pmos ad=0.34p pd=2.68u as=0 ps=0 w=1u l=1u
X12 VSS.t1011 VDD.t1640 VSS.t1011 VSS.t1012 sg13_lv_nmos ad=0.1428p pd=1.52u as=0 ps=0 w=0.42u l=1u
X13 a_8808_3889# a_8237_4687# VDD.t827 VDD.t0 sg13_lv_pmos ad=0.2128p pd=1.5u as=0.3808p ps=2.92u w=1.12u l=0.13u
X14 a_25153_4687# a_24957_4687# VSS.t183 VSS.t658 sg13_lv_nmos ad=0.2516p pd=2.16u as=0.1406p ps=1.12u w=0.74u l=0.13u
X15 VDD.t270 a_15108_11799# a_15053_11680# VDD.t268 sg13_lv_pmos ad=1.10612p pd=6.66u as=93.45f ps=0.865u w=0.42u l=0.13u
X16 VSS.t609 a_12037_4687# a_12505_3889# VSS.t608 sg13_lv_nmos ad=0.1665p pd=1.19u as=0.2516p ps=2.16u w=0.74u l=0.13u
X17 a_23871_16869# a_23633_16869# a_23763_16869# VSS.t246 sg13_lv_nmos ad=0.1406p pd=1.12u as=0.2516p ps=2.16u w=0.74u l=0.2u
X18 CHAN0_DELAY_OUT_LAST a_27997_16869# VSS.t1142 VSS.t1298 sg13_lv_nmos ad=0.2516p pd=2.16u as=0.1406p ps=1.12u w=0.74u l=0.13u
X19 VSS.t1327 a_15077_1842# a_15545_1044# VSS.t1694 sg13_lv_nmos ad=0.1665p pd=1.19u as=0.2516p ps=2.16u w=0.74u l=0.13u
X20 a_15108_11015# a_12849_11557# VDD.t270 VDD.t268 sg13_lv_pmos ad=79.8f pd=0.8u as=1.03698p ps=6.245u w=0.42u l=0.13u
X21 a_3449_13577# CHAN1_MUX_SEL0 VDD.t508 VDD.t50 sg13_lv_pmos ad=0.1596p pd=1.22u as=0.2856p ps=2.36u w=0.84u l=0.13u
X22 VDD.t79 VSS.t982 VDD.t231 VDD.t41 sg13_lv_pmos ad=0.34p pd=2.68u as=0 ps=0 w=1u l=1u
X23 VDD.t126 VSS.t970 VDD.t124 VDD.t41 sg13_lv_pmos ad=0.19p pd=1.38u as=0 ps=0 w=1u l=1u
X24 VDD.t732 a_16851_5999# REF_MUX_OUT VDD.t41 sg13_lv_pmos ad=0.7336p pd=3.55u as=0.2128p ps=1.5u w=1.12u l=0.13u
X25 VSS.t600 a_4187_1764.t136 a_24631_16869# VSS.t599 sg13_lv_nmos ad=0.2516p pd=2.16u as=0.1406p ps=1.12u w=0.74u l=0.6u
X26 a_7390_6734# a_8231_6698# a_8155_6734# VDD.t41 sg13_lv_pmos ad=0.3808p pd=2.92u as=0.2128p ps=1.5u w=1.12u l=0.13u
X27 a_27915_1044# a_27705_1044# VDD.t893 VDD.t7 sg13_lv_pmos ad=0.2128p pd=1.5u as=0.252p ps=1.57u w=1.12u l=0.13u
X28 a_10430_6734# a_2019_6737.t7 a_10328_6734# VSS.t739 sg13_lv_nmos ad=0.2516p pd=2.16u as=0.1406p ps=1.12u w=0.74u l=0.13u
X29 VDD.t1459 a_3747_16074.t6 a_15831_16035# VDD.t4 sg13_lv_pmos ad=0.3808p pd=2.92u as=0.3808p ps=2.92u w=1.12u l=0.13u
X30 a_25630_13226# a_3171_13229.t2 a_27048_13226# VSS.t103 sg13_lv_nmos ad=0.2516p pd=2.16u as=0.1406p ps=1.12u w=0.74u l=0.13u
X31 VDD.t73 VSS.t887 VDD.t1584 VDD.t50 sg13_lv_pmos ad=0.34p pd=2.68u as=0 ps=0 w=1u l=1u
X32 VSS.t251 a_1721_16422# a_2019_16074.t1 VSS.t252 sg13_lv_nmos ad=0.2812p pd=2.24u as=0.1406p ps=1.12u w=0.74u l=0.13u
X33 a_2873_16422# CHAN0_MUX_SEL1 VDD.t470 VDD.t4 sg13_lv_pmos ad=0.1596p pd=1.22u as=0.2856p ps=2.36u w=0.84u l=0.13u
X34 a_22351_5315# a_22113_4687# a_22243_4687# VDD.t281 sg13_lv_pmos ad=0.2128p pd=1.5u as=0.3808p ps=2.92u w=1.12u l=0.2u
X35 a_1544_16071# CHAN0_MUX_SEL1 VDD.t471 VDD.t4 sg13_lv_pmos ad=0.3808p pd=2.92u as=0.3808p ps=2.92u w=1.12u l=0.13u
X36 VDD.t824 a_13883_7532# a_14317_7532# VDD.t275 sg13_lv_pmos ad=0.2128p pd=1.5u as=0.3808p ps=2.92u w=1.12u l=0.13u
X37 VSS.t200 a_11748_11799# a_11397_11918# VSS.t1706 sg13_lv_nmos ad=79.8f pd=0.8u as=0.1428p ps=1.52u w=0.42u l=0.13u
X38 VDD.t512 a_16923_4687# a_17357_4687# VDD.t281 sg13_lv_pmos ad=0.2128p pd=1.5u as=0.3808p ps=2.92u w=1.12u l=0.13u
X39 VSS.t948 VDD.t1657 VSS.t948 VSS.t952 sg13_lv_nmos ad=79.8f pd=0.8u as=0 ps=0 w=0.42u l=1u
X40 a_13818_11982# a_12849_11557# VSS.t4 VSS.t7 sg13_lv_nmos ad=37.8f pd=0.6u as=0.1701p ps=1.65u w=0.42u l=0.13u
X41 a_7390_6734# a_3171_6737.t8 a_8808_6734# VSS.t1307 sg13_lv_nmos ad=0.2516p pd=2.16u as=0.1406p ps=1.12u w=0.74u l=0.13u
X42 VSS.t1065 VDD.t1625 VSS.t1063 VSS.t1064 sg13_lv_nmos ad=79.8f pd=0.8u as=0 ps=0 w=0.42u l=1u
X43 a_8433_16869# a_8237_16869# VSS.t660 VSS.t1133 sg13_lv_nmos ad=0.2516p pd=2.16u as=0.1406p ps=1.12u w=0.74u l=0.13u
X44 VSS.t699 a_2019_16074.t2 a_25604_16035# VSS.t698 sg13_lv_nmos ad=0.2516p pd=2.16u as=0.2516p ps=2.16u w=0.74u l=0.13u
X45 a_22873_7532# a_22677_7532# VSS.t175 VSS.t409 sg13_lv_nmos ad=0.2516p pd=2.16u as=0.1406p ps=1.12u w=0.74u l=0.13u
X46 VSS.t1042 VDD.t1632 VSS.t1040 VSS.t1041 sg13_lv_nmos ad=79.8f pd=0.8u as=0 ps=0 w=0.42u l=1u
X47 a_5115_13226# a_4905_13226# VSS.t1913 VSS.t1912 sg13_lv_nmos ad=0.1406p pd=1.12u as=0.1665p ps=1.19u w=0.74u l=0.13u
X48 a_6326_10280# a_6326_10280# VDD.t1130 VDD.t268 sg13_lv_pmos ad=0.38p pd=2.38u as=0.38p ps=2.38u w=2u l=1u
X49 a_13566_11018# a_14009_10774# a_13306_10795# VSS.t1130 sg13_lv_nmos ad=79.8f pd=0.8u as=0.1296p ps=1.52u w=0.42u l=0.13u
X50 VDD.t733 a_27237_4687# a_27705_3889# VDD.t0 sg13_lv_pmos ad=0.252p pd=1.57u as=0.3808p ps=2.92u w=1.12u l=0.13u
X51 VSS.t954 VDD.t1656 VSS.t957 VSS.t956 sg13_lv_nmos ad=79.8f pd=0.8u as=0 ps=0 w=0.42u l=1u
X52 VSS.t381 a_3171_1047.t7 a_11924_1008# VSS.t380 sg13_lv_nmos ad=0.2516p pd=2.16u as=0.2516p ps=2.16u w=0.74u l=0.13u
X53 a_10951_2470# a_10713_1842# a_10843_1842# VDD.t399 sg13_lv_pmos ad=0.2128p pd=1.5u as=0.3808p ps=2.92u w=1.12u l=0.2u
X54 VSS.t1144 a_1544_3134# a_2391_3176# VSS.t255 sg13_lv_nmos ad=0.1331p pd=1.12u as=0.1216p ps=1.02u w=0.64u l=0.13u
X55 VDD.t579 a_12037_7532# a_12505_6734# VDD.t41 sg13_lv_pmos ad=0.252p pd=1.57u as=0.3808p ps=2.92u w=1.12u l=0.13u
X56 VDD.t253 VSS.t1103 VDD.t252 VDD.t7 sg13_lv_pmos ad=0.34p pd=2.68u as=0 ps=0 w=1u l=1u
X57 a_1721_15358# a_1256_15316# VDD.t1273 VDD.t4 sg13_lv_pmos ad=0.1596p pd=1.22u as=0.2856p ps=2.36u w=0.84u l=0.13u
X58 a_6326_10280# a_6126_9506# a_5778_9057# VSS.t14 sg13_lv_nmos ad=0.38p pd=2.38u as=0.68p ps=4.68u w=2u l=1u
X59 VSS.t481 a_4187_1764.t148 a_15511_16869# VSS.t1410 sg13_lv_nmos ad=0.2516p pd=2.16u as=0.1406p ps=1.12u w=0.74u l=0.6u
X60 a_25913_14024# a_25717_14024# VSS.t445 VSS.t1242 sg13_lv_nmos ad=0.2516p pd=2.16u as=0.1406p ps=1.12u w=0.74u l=0.13u
X61 VDD.t863 a_4003_7532# a_4437_7532# VDD.t275 sg13_lv_pmos ad=0.2128p pd=1.5u as=0.3808p ps=2.92u w=1.12u l=0.13u
X62 a_10191_16869# a_9953_16869# a_10083_16869# VSS.t1222 sg13_lv_nmos ad=0.1406p pd=1.12u as=0.2516p ps=2.16u w=0.74u l=0.2u
X63 VDD.t109 VSS.t859 VDD.t107 VDD.t4 sg13_lv_pmos ad=0.19p pd=1.38u as=0 ps=0 w=1u l=1u
X64 VSS.t1065 VDD.t1624 VSS.t1065 VSS.t1066 sg13_lv_nmos ad=0.1428p pd=1.52u as=0 ps=0 w=0.42u l=1u
X65 VDD.t414 a_4187_2434# a_10951_5315# VDD.t281 sg13_lv_pmos ad=0.3808p pd=2.92u as=0.2128p ps=1.5u w=1.12u l=0.6u
X66 VDD.t1404 a_15077_14024# a_15545_13226# VDD.t50 sg13_lv_pmos ad=0.252p pd=1.57u as=0.3808p ps=2.92u w=1.12u l=0.13u
X67 VSS.t494 a_1256_1044# a_2967_1395# VSS.t702 sg13_lv_nmos ad=0.1331p pd=1.12u as=0.1216p ps=1.02u w=0.64u l=0.13u
X68 VSS.t1224 a_4187_1764.t154 a_10951_16869# VSS.t1585 sg13_lv_nmos ad=0.2516p pd=2.16u as=0.1406p ps=1.12u w=0.74u l=0.6u
X69 a_21353_14024# a_21157_14024# VSS.t617 VSS.t1865 sg13_lv_nmos ad=0.2516p pd=2.16u as=0.1406p ps=1.12u w=0.74u l=0.13u
X70 a_9946_11995# a_9772_11533# VDD.t1032 VDD.t268 sg13_lv_pmos ad=79.8f pd=0.8u as=0.1428p ps=1.52u w=0.42u l=0.13u
X71 a_5731_3134# a_3747_3156.t3 a_13470_3889# VSS.t80 sg13_lv_nmos ad=0.2516p pd=2.16u as=0.2516p ps=2.16u w=0.74u l=0.13u
X72 a_16033_16869# a_15837_16869# VDD.t627 VDD.t297 sg13_lv_pmos ad=0.3808p pd=2.92u as=0.2128p ps=1.5u w=1.12u l=0.13u
X73 VDD.t245 VSS.t767 VDD.t244 VDD.t7 sg13_lv_pmos ad=0.34p pd=2.68u as=0 ps=0 w=1u l=1u
X74 VSS.t742 a_14643_14024# a_15077_14024# VSS.t2300 sg13_lv_nmos ad=0.1406p pd=1.12u as=0.2516p ps=2.16u w=0.74u l=0.13u
X75 a_25153_1842# a_24957_1842# VSS.t1606 VSS.t1906 sg13_lv_nmos ad=0.2516p pd=2.16u as=0.1406p ps=1.12u w=0.74u l=0.13u
X76 a_10328_3889# a_9757_4687# VSS.t319 VSS.t318 sg13_lv_nmos ad=0.1406p pd=1.12u as=0.2516p ps=2.16u w=0.74u l=0.13u
X77 VDD.t913 a_20723_4687# a_21157_4687# VDD.t281 sg13_lv_pmos ad=0.2128p pd=1.5u as=0.3808p ps=2.92u w=1.12u l=0.13u
X78 VDD.t1230 a_3171_13229.t3 a_24084_13190# VDD.t50 sg13_lv_pmos ad=0.3808p pd=2.92u as=0.3808p ps=2.92u w=1.12u l=0.13u
X79 a_17791_4687# a_17553_4687# a_17683_4687# VSS.t227 sg13_lv_nmos ad=0.1406p pd=1.12u as=0.2516p ps=2.16u w=0.74u l=0.2u
X80 VSS.t1474 a_15077_7532# a_15545_6734# VSS.t2242 sg13_lv_nmos ad=0.1665p pd=1.19u as=0.2516p ps=2.16u w=0.74u l=0.13u
X81 a_22590_3889# a_2019_3892.t3 a_22488_3889# VSS.t1834 sg13_lv_nmos ad=0.2516p pd=2.16u as=0.1406p ps=1.12u w=0.74u l=0.13u
X82 VDD.t240 VSS.t1042 VDD.t239 VDD.t0 sg13_lv_pmos ad=0.34p pd=2.68u as=0 ps=0 w=1u l=1u
X83 a_25630_1044# a_2019_1047.t2 a_25528_1044# VSS.t1313 sg13_lv_nmos ad=0.2516p pd=2.16u as=0.1406p ps=1.12u w=0.74u l=0.13u
X84 VDD.t171 VSS.t1036 VDD.t169 VDD.t0 sg13_lv_pmos ad=0.19p pd=1.38u as=0 ps=0 w=1u l=1u
X85 VSS.t1467 a_9444_10280# a_9444_9602# VSS.t1466 sg13_lv_nmos ad=0.68p pd=4.68u as=0.38p ps=2.38u w=2u l=1u
X86 VDD.t435 a_4187_2434# a_19311_2470# VDD.t399 sg13_lv_pmos ad=0.3808p pd=2.92u as=0.2128p ps=1.5u w=1.12u l=0.6u
X87 a_8808_3889# a_8237_4687# VSS.t1127 VSS.t1126 sg13_lv_nmos ad=0.1406p pd=1.12u as=0.2516p ps=2.16u w=0.74u l=0.13u
X88 VSS.t1806 a_3747_6001.t2 a_26985_6209# VSS.t1805 sg13_lv_nmos ad=0.2516p pd=2.16u as=0.2516p ps=2.16u w=0.74u l=0.13u
X89 VSS.t1267 a_2019_13229.t6 a_13444_13190# VSS.t1266 sg13_lv_nmos ad=0.2516p pd=2.16u as=0.2516p ps=2.16u w=0.74u l=0.13u
X90 VDD.t191 VSS.t918 VDD.t190 VDD.t50 sg13_lv_pmos ad=0.19p pd=1.38u as=0 ps=0 w=1u l=1u
X91 VSS.t305 a_13123_16869# a_13557_16869# VSS.t1374 sg13_lv_nmos ad=0.1406p pd=1.12u as=0.2516p ps=2.16u w=0.74u l=0.13u
X92 VDD.t420 a_4187_2434# a_23871_5315# VDD.t281 sg13_lv_pmos ad=0.3808p pd=2.92u as=0.2128p ps=1.5u w=1.12u l=0.6u
X93 VSS.t421 a_3171_16074.t7 a_11924_16035# VSS.t1577 sg13_lv_nmos ad=0.2516p pd=2.16u as=0.2516p ps=2.16u w=0.74u l=0.13u
X94 VDD.t1068 a_3747_13229.t5 a_18871_13190# VDD.t50 sg13_lv_pmos ad=0.3808p pd=2.92u as=0.3808p ps=2.92u w=1.12u l=0.13u
X95 VSS.t284 a_14009_10774# a_14111_10917# VSS.t1131 sg13_lv_nmos ad=1.45407p pd=9.445u as=0.2516p ps=2.16u w=0.74u l=0.13u
X96 a_6635_3889# a_6425_3889# VDD.t737 VDD.t0 sg13_lv_pmos ad=0.2128p pd=1.5u as=0.252p ps=1.57u w=1.12u l=0.13u
X97 VDD.t92 VSS.t948 VDD.t90 VDD.t41 sg13_lv_pmos ad=0.19p pd=1.38u as=0 ps=0 w=1u l=1u
X98 VDD.t920 a_4763_16869# a_5197_16869# VDD.t297 sg13_lv_pmos ad=0.2128p pd=1.5u as=0.3808p ps=2.92u w=1.12u l=0.13u
X99 a_16108_289# a_2019_311.t2 a_16510_1044# VSS.t777 sg13_lv_nmos ad=0.2516p pd=2.16u as=0.2516p ps=2.16u w=0.74u l=0.13u
X100 VSS.t1959 a_2019_6001.t3 a_5705_6209# VSS.t1958 sg13_lv_nmos ad=0.2516p pd=2.16u as=0.2516p ps=2.16u w=0.74u l=0.13u
X101 VDD.t1051 a_3747_12493.t2 a_26985_12701# VDD.t50 sg13_lv_pmos ad=0.3808p pd=2.92u as=0.3808p ps=2.92u w=1.12u l=0.13u
X102 VDD.t1232 a_2595_3892.t9 a_5191_3853# VDD.t0 sg13_lv_pmos ad=0.3808p pd=2.92u as=0.3808p ps=2.92u w=1.12u l=0.13u
X103 VSS.t4 a_13121_11521# a_13045_11905# VSS.t802 sg13_lv_nmos ad=0.2516p pd=2.16u as=0.1406p ps=1.12u w=0.74u l=0.13u
X104 VDD.t439 a_4187_2434# a_9431_2470# VDD.t399 sg13_lv_pmos ad=0.3808p pd=2.92u as=0.2128p ps=1.5u w=1.12u l=0.6u
X105 a_21591_4687# a_21353_4687# a_21483_4687# VSS.t2190 sg13_lv_nmos ad=0.1406p pd=1.12u as=0.2516p ps=2.16u w=0.74u l=0.2u
X106 VDD.t283 a_2595_16074.t2 a_26471_16035# VDD.t4 sg13_lv_pmos ad=0.3808p pd=2.92u as=0.3808p ps=2.92u w=1.12u l=0.13u
X107 a_20315_3889# a_20105_3889# VDD.t851 VDD.t0 sg13_lv_pmos ad=0.2128p pd=1.5u as=0.252p ps=1.57u w=1.12u l=0.13u
X108 a_6153_4687# a_5957_4687# VSS.t39 VSS.t805 sg13_lv_nmos ad=0.2516p pd=2.16u as=0.1406p ps=1.12u w=0.74u l=0.13u
X109 VDD.t120 VSS.t957 VDD.t119 VDD.t41 sg13_lv_pmos ad=0.19p pd=1.38u as=0 ps=0 w=1u l=1u
X110 VSS.t937 VDD.t1661 VSS.t937 VSS.t939 sg13_lv_nmos ad=79.8f pd=0.8u as=0 ps=0 w=0.42u l=1u
X111 VSS.t1109 VDD.t1611 VSS.t764 VSS.t1108 sg13_lv_nmos ad=0.1428p pd=1.52u as=0 ps=0 w=0.42u l=1u
X112 a_25528_3889# a_24957_4687# VDD.t683 VDD.t0 sg13_lv_pmos ad=0.2128p pd=1.5u as=0.3808p ps=2.92u w=1.12u l=0.13u
X113 a_26911_14024# a_26673_14024# a_26803_14024# VSS.t76 sg13_lv_nmos ad=0.1406p pd=1.12u as=0.2516p ps=2.16u w=0.74u l=0.2u
X114 a_15108_11799# a_14851_11918# a_15270_11995# VSS.t8 sg13_lv_nmos ad=0.1428p pd=1.52u as=37.8f ps=0.6u w=0.42u l=0.13u
X115 VSS.t50 a_16163_4687# a_16597_4687# VSS.t49 sg13_lv_nmos ad=0.1406p pd=1.12u as=0.2516p ps=2.16u w=0.74u l=0.13u
X116 a_13231_5315# a_12993_4687# a_13123_4687# VDD.t281 sg13_lv_pmos ad=0.2128p pd=1.5u as=0.3808p ps=2.92u w=1.12u l=0.2u
X117 VDD.t1229 a_3171_13229.t6 a_14964_13190# VDD.t50 sg13_lv_pmos ad=0.3808p pd=2.92u as=0.3808p ps=2.92u w=1.12u l=0.13u
X118 CHAN1_MUX_OUT a_16851_12491# VSS.t363 VSS.t643 sg13_lv_nmos ad=0.1406p pd=1.12u as=0.1371p ps=1.12u w=0.74u l=0.13u
X119 a_10951_8160# a_10713_7532# a_10843_7532# VDD.t275 sg13_lv_pmos ad=0.2128p pd=1.5u as=0.3808p ps=2.92u w=1.12u l=0.2u
X120 VSS.t721 a_3171_6737.t7 a_11924_6698# VSS.t1310 sg13_lv_nmos ad=0.2516p pd=2.16u as=0.2516p ps=2.16u w=0.74u l=0.13u
X121 a_10328_6734# a_9757_7532# VDD.t473 VDD.t41 sg13_lv_pmos ad=0.2128p pd=1.5u as=0.3808p ps=2.92u w=1.12u l=0.13u
X122 a_3449_6021# REF_MUX_SEL2 VDD.t727 VDD.t41 sg13_lv_pmos ad=0.1596p pd=1.22u as=0.2856p ps=2.36u w=0.84u l=0.13u
X123 VDD.t454 a_4187_2434# a_23111_2470# VDD.t399 sg13_lv_pmos ad=0.3808p pd=2.92u as=0.2128p ps=1.5u w=1.12u l=0.6u
X124 VSS.t1790 a_4187_1764.t100 a_27671_14024# VSS.t1789 sg13_lv_nmos ad=0.2516p pd=2.16u as=0.1406p ps=1.12u w=0.74u l=0.6u
X125 a_22351_14024# a_22113_14024# a_22243_14024# VSS.t1870 sg13_lv_nmos ad=0.1406p pd=1.12u as=0.2516p ps=2.16u w=0.74u l=0.2u
X126 VSS.t605 a_3747_15338.t3 a_14825_15546# VSS.t604 sg13_lv_nmos ad=0.2516p pd=2.16u as=0.2516p ps=2.16u w=0.74u l=0.13u
X127 a_1721_12513# a_1256_12471# VDD.t1564 VDD.t50 sg13_lv_pmos ad=0.1596p pd=1.22u as=0.2856p ps=2.36u w=0.84u l=0.13u
X128 VDD.t1573 a_2019_16074.t3 a_22564_16035# VDD.t4 sg13_lv_pmos ad=0.3808p pd=2.92u as=0.3808p ps=2.92u w=1.12u l=0.13u
X129 a_22590_6734# a_22564_6698# a_22488_6734# VDD.t41 sg13_lv_pmos ad=0.3808p pd=2.92u as=0.2128p ps=1.5u w=1.12u l=0.13u
X130 a_7390_1044# a_8231_1008# a_8155_1044# VDD.t7 sg13_lv_pmos ad=0.3808p pd=2.92u as=0.2128p ps=1.5u w=1.12u l=0.13u
X131 VSS.t1175 a_1256_6734# a_2967_7085# VSS.t1260 sg13_lv_nmos ad=0.1331p pd=1.12u as=0.1216p ps=1.02u w=0.64u l=0.13u
X132 VSS.t1051 VDD.t1628 VSS.t1051 VSS.t1052 sg13_lv_nmos ad=0.1428p pd=1.52u as=0 ps=0 w=0.42u l=1u
X133 a_10713_16869# a_10517_16869# VSS.t611 VSS.t2199 sg13_lv_nmos ad=0.2516p pd=2.16u as=0.1406p ps=1.12u w=0.74u l=0.13u
X134 VSS.t456 a_4187_1764.t57 a_10191_4687# VSS.t455 sg13_lv_nmos ad=0.2516p pd=2.16u as=0.1406p ps=1.12u w=0.74u l=0.6u
X135 a_12233_4687# a_12037_4687# VDD.t661 VDD.t281 sg13_lv_pmos ad=0.3808p pd=2.92u as=0.2128p ps=1.5u w=1.12u l=0.13u
X136 a_7390_16071# a_7364_16035# a_7288_16071# VDD.t4 sg13_lv_pmos ad=0.3808p pd=2.92u as=0.2128p ps=1.5u w=1.12u l=0.13u
X137 a_16108_15316# CHAN0_MUX_SEL4 a_15964_15316# VSS.t1420 sg13_lv_nmos ad=0.2516p pd=2.16u as=0.2183p ps=1.33u w=0.74u l=0.13u
X138 a_16033_14024# a_15837_14024# VDD.t1396 VDD.t301 sg13_lv_pmos ad=0.3808p pd=2.92u as=0.2128p ps=1.5u w=1.12u l=0.13u
X139 a_8808_6734# a_8237_7532# VDD.t742 VDD.t41 sg13_lv_pmos ad=0.2128p pd=1.5u as=0.3808p ps=2.92u w=1.12u l=0.13u
X140 VSS.t773 a_2595_311.t3 a_8745_519# VSS.t772 sg13_lv_nmos ad=0.2516p pd=2.16u as=0.2516p ps=2.16u w=0.74u l=0.13u
X141 VSS.t794 a_27237_4687# a_27705_3889# VSS.t2173 sg13_lv_nmos ad=0.1665p pd=1.19u as=0.2516p ps=2.16u w=0.74u l=0.13u
X142 a_25153_7532# a_24957_7532# VSS.t229 VSS.t228 sg13_lv_nmos ad=0.2516p pd=2.16u as=0.1406p ps=1.12u w=0.74u l=0.13u
X143 a_2297_15358# CHAN0_MUX_SEL2 VDD.t677 VDD.t4 sg13_lv_pmos ad=0.1596p pd=1.22u as=0.2856p ps=2.36u w=0.84u l=0.13u
X144 a_17791_1842# a_17553_1842# a_17683_1842# VSS.t1934 sg13_lv_nmos ad=0.1406p pd=1.12u as=0.2516p ps=2.16u w=0.74u l=0.2u
X145 VDD.t1512 a_2019_12493.t2 a_17865_12701# VDD.t50 sg13_lv_pmos ad=0.3808p pd=2.92u as=0.3808p ps=2.92u w=1.12u l=0.13u
X146 a_14851_11918# a_14009_11568# a_13592_11561# VDD.t268 sg13_lv_pmos ad=0.2048p pd=1.63u as=0.34p ps=2.68u w=1u l=0.13u
X147 a_25153_16869# a_24957_16869# VSS.t600 VSS.t1226 sg13_lv_nmos ad=0.2516p pd=2.16u as=0.1406p ps=1.12u w=0.74u l=0.13u
X148 VSS.t209 a_19963_4687# a_20397_4687# VSS.t208 sg13_lv_nmos ad=0.1406p pd=1.12u as=0.2516p ps=2.16u w=0.74u l=0.13u
X149 VDD.t1134 a_6326_10280# a_6126_9506# VDD.t268 sg13_lv_pmos ad=0.38p pd=2.38u as=0.38p ps=2.38u w=2u l=1u
X150 VDD.t1557 a_1721_12513# a_2019_12493.t0 VDD.t50 sg13_lv_pmos ad=0.4256p pd=3u as=0.2128p ps=1.5u w=1.12u l=0.13u
X151 a_12656_11554# DLL_RESETN VDD.t875 VDD.t268 sg13_lv_pmos ad=0.3808p pd=2.92u as=0.3808p ps=2.92u w=1.12u l=0.13u
X152 a_25630_6734# a_2019_6737.t2 a_25528_6734# VSS.t106 sg13_lv_nmos ad=0.2516p pd=2.16u as=0.1406p ps=1.12u w=0.74u l=0.13u
X153 VDD.t604 a_2595_16074.t5 a_17351_16035# VDD.t4 sg13_lv_pmos ad=0.3808p pd=2.92u as=0.3808p ps=2.92u w=1.12u l=0.13u
X154 VDD.t376 a_4187_2434# a_19311_8160# VDD.t275 sg13_lv_pmos ad=0.3808p pd=2.92u as=0.2128p ps=1.5u w=1.12u l=0.6u
X155 a_25630_16071# a_3171_16074.t2 a_27048_16071# VSS.t2064 sg13_lv_nmos ad=0.2516p pd=2.16u as=0.1406p ps=1.12u w=0.74u l=0.13u
X156 VDD.t492 a_3747_16074.t7 a_12791_16035# VDD.t4 sg13_lv_pmos ad=0.3808p pd=2.92u as=0.3808p ps=2.92u w=1.12u l=0.13u
X157 a_2595_13229.t1 a_2297_13577# VSS.t259 VSS.t389 sg13_lv_nmos ad=0.1406p pd=1.12u as=0.1331p ps=1.12u w=0.74u l=0.13u
X158 VDD.t1151 a_12037_1842# a_12505_1044# VDD.t7 sg13_lv_pmos ad=0.252p pd=1.57u as=0.3808p ps=2.92u w=1.12u l=0.13u
X159 a_13231_14024# a_12993_14024# a_13123_14024# VSS.t2041 sg13_lv_nmos ad=0.1406p pd=1.12u as=0.2516p ps=2.16u w=0.74u l=0.2u
X160 VDD.t30 VSS.t1016 VDD.t28 VDD.t0 sg13_lv_pmos ad=0.19p pd=1.38u as=0 ps=0 w=1u l=1u
X161 a_16510_1044# a_2019_1047.t5 a_16408_1044# VSS.t139 sg13_lv_nmos ad=0.2516p pd=2.16u as=0.1406p ps=1.12u w=0.74u l=0.13u
X162 VSS.t992 VDD.t1645 VSS.t992 VSS.t996 sg13_lv_nmos ad=79.8f pd=0.8u as=0 ps=0 w=0.42u l=1u
X163 VDD.t1344 a_4763_14024# a_5197_14024# VDD.t301 sg13_lv_pmos ad=0.2128p pd=1.5u as=0.3808p ps=2.92u w=1.12u l=0.13u
X164 VDD.t178 VSS.t937 VDD.t118 VDD.t41 sg13_lv_pmos ad=0.19p pd=1.38u as=0 ps=0 w=1u l=1u
X165 VSS.t744 a_4187_1764.t118 a_13991_14024# VSS.t743 sg13_lv_nmos ad=0.2516p pd=2.16u as=0.1406p ps=1.12u w=0.74u l=0.6u
X166 a_9953_16869# a_9757_16869# VSS.t60 VSS.t1275 sg13_lv_nmos ad=0.2516p pd=2.16u as=0.1406p ps=1.12u w=0.74u l=0.13u
X167 VSS.t909 VDD.t1670 VSS.t907 VSS.t908 sg13_lv_nmos ad=0.1428p pd=1.52u as=0 ps=0 w=0.42u l=1u
X168 VDD.t375 a_4187_2434# a_9431_8160# VDD.t275 sg13_lv_pmos ad=0.3808p pd=2.92u as=0.2128p ps=1.5u w=1.12u l=0.6u
X169 a_21591_1842# a_21353_1842# a_21483_1842# VSS.t1899 sg13_lv_nmos ad=0.1406p pd=1.12u as=0.2516p ps=2.16u w=0.74u l=0.2u
X170 a_2873_3176# CHAN2_MUX_SEL3 VDD.t279 VDD.t0 sg13_lv_pmos ad=0.1596p pd=1.22u as=0.2856p ps=2.36u w=0.84u l=0.13u
X171 VSS.t966 a_2019_6001.t2 a_17865_6209# VSS.t1955 sg13_lv_nmos ad=0.2516p pd=2.16u as=0.2516p ps=2.16u w=0.74u l=0.13u
X172 a_6153_1842# a_5957_1842# VSS.t1652 VSS.t2207 sg13_lv_nmos ad=0.2516p pd=2.16u as=0.1406p ps=1.12u w=0.74u l=0.13u
X173 VDD.t38 VSS.t1021 VDD.t37 VDD.t0 sg13_lv_pmos ad=0.19p pd=1.38u as=0 ps=0 w=1u l=1u
X174 a_5115_16071# a_4905_16071# VSS.t1665 VSS.t1664 sg13_lv_nmos ad=0.1406p pd=1.12u as=0.1665p ps=1.19u w=0.74u l=0.13u
X175 VSS.t569 a_3171_1047.t2 a_27124_1008# VSS.t568 sg13_lv_nmos ad=0.2516p pd=2.16u as=0.2516p ps=2.16u w=0.74u l=0.13u
X176 VSS.t165 a_16163_1842# a_16597_1842# VSS.t1712 sg13_lv_nmos ad=0.1406p pd=1.12u as=0.2516p ps=2.16u w=0.74u l=0.13u
X177 VDD.t1303 a_2595_6001.t2 a_20905_6209# VDD.t41 sg13_lv_pmos ad=0.3808p pd=2.92u as=0.3808p ps=2.92u w=1.12u l=0.13u
X178 VDD.t641 a_27237_7532# a_27705_6734# VDD.t41 sg13_lv_pmos ad=0.252p pd=1.57u as=0.3808p ps=2.92u w=1.12u l=0.13u
X179 VDD.t370 a_4187_2434# a_23111_8160# VDD.t275 sg13_lv_pmos ad=0.3808p pd=2.92u as=0.2128p ps=1.5u w=1.12u l=0.6u
X180 VDD.t1144 a_11603_1842# a_12037_1842# VDD.t399 sg13_lv_pmos ad=0.2128p pd=1.5u as=0.3808p ps=2.92u w=1.12u l=0.13u
X181 a_6635_3889# a_6425_3889# VSS.t804 VSS.t1216 sg13_lv_nmos ad=0.1406p pd=1.12u as=0.1665p ps=1.19u w=0.74u l=0.13u
X182 VSS.t477 a_1544_5979# a_2391_6021# VSS.t476 sg13_lv_nmos ad=0.1331p pd=1.12u as=0.1216p ps=1.02u w=0.64u l=0.13u
X183 a_11711_16869# a_11473_16869# a_11603_16869# VSS.t303 sg13_lv_nmos ad=0.1406p pd=1.12u as=0.2516p ps=2.16u w=0.74u l=0.2u
X184 VDD.t719 a_3171_311.t3 a_11785_519# VDD.t7 sg13_lv_pmos ad=0.3808p pd=2.92u as=0.3808p ps=2.92u w=1.12u l=0.13u
X185 VDD.t427 a_4187_2434# a_26151_5315# VDD.t281 sg13_lv_pmos ad=0.3808p pd=2.92u as=0.2128p ps=1.5u w=1.12u l=0.6u
X186 a_5731_289# a_2595_311.t3 a_7390_1044# VSS.t771 sg13_lv_nmos ad=0.2516p pd=2.16u as=0.2516p ps=2.16u w=0.74u l=0.13u
X187 a_10430_1044# a_2595_1047.t7 a_11195_1044# VSS.t561 sg13_lv_nmos ad=0.2516p pd=2.16u as=0.1406p ps=1.12u w=0.74u l=0.13u
X188 VSS.t119 a_2595_3892.t9 a_5191_3853# VSS.t1831 sg13_lv_nmos ad=0.2516p pd=2.16u as=0.2516p ps=2.16u w=0.74u l=0.13u
X189 a_6854_11676# a_6326_10280# VDD.t767 VDD.t268 sg13_lv_pmos ad=0.38p pd=2.38u as=0.38p ps=2.38u w=2u l=1u
X190 a_15464_9374# a_14851_10872# VSS.t6 VSS.t131 sg13_lv_nmos ad=0.2849p pd=2.25u as=0.2516p ps=2.16u w=0.74u l=0.13u
X191 a_24393_1842# a_24197_1842# VDD.t1291 VDD.t399 sg13_lv_pmos ad=0.3808p pd=2.92u as=0.2128p ps=1.5u w=1.12u l=0.13u
X192 VSS.t664 a_4187_1764.t152 a_12471_16869# VSS.t2231 sg13_lv_nmos ad=0.2516p pd=2.16u as=0.1406p ps=1.12u w=0.74u l=0.6u
X193 a_22873_14024# a_22677_14024# VSS.t1236 VSS.t1816 sg13_lv_nmos ad=0.2516p pd=2.16u as=0.1406p ps=1.12u w=0.74u l=0.13u
X194 a_16408_3889# a_15837_4687# VDD.t610 VDD.t0 sg13_lv_pmos ad=0.2128p pd=1.5u as=0.3808p ps=2.92u w=1.12u l=0.13u
X195 a_20315_3889# a_20105_3889# VSS.t1173 VSS.t2136 sg13_lv_nmos ad=0.1406p pd=1.12u as=0.1665p ps=1.19u w=0.74u l=0.13u
X196 a_17553_16869# a_17357_16869# VDD.t629 VDD.t297 sg13_lv_pmos ad=0.3808p pd=2.92u as=0.2128p ps=1.5u w=1.12u l=0.13u
X197 VDD.t155 VSS.t849 VDD.t153 VDD.t4 sg13_lv_pmos ad=0.19p pd=1.38u as=0 ps=0 w=1u l=1u
X198 a_27048_16071# a_26477_16869# VDD.t932 VDD.t4 sg13_lv_pmos ad=0.2128p pd=1.5u as=0.3808p ps=2.92u w=1.12u l=0.13u
X199 VSS.t1624 a_16163_14024# a_16597_14024# VSS.t2294 sg13_lv_nmos ad=0.1406p pd=1.12u as=0.2516p ps=2.16u w=0.74u l=0.13u
X200 a_23355_1044# a_23145_1044# VSS.t1402 VSS.t1401 sg13_lv_nmos ad=0.1406p pd=1.12u as=0.1665p ps=1.19u w=0.74u l=0.13u
X201 a_25528_3889# a_24957_4687# VSS.t657 VSS.t656 sg13_lv_nmos ad=0.1406p pd=1.12u as=0.2516p ps=2.16u w=0.74u l=0.13u
X202 VSS.t56 a_1256_3889# a_2967_4240# VSS.t128 sg13_lv_nmos ad=0.1331p pd=1.12u as=0.1216p ps=1.02u w=0.64u l=0.13u
X203 VDD.t1457 a_2019_13229.t2 a_25604_13190# VDD.t50 sg13_lv_pmos ad=0.3808p pd=2.92u as=0.3808p ps=2.92u w=1.12u l=0.13u
X204 VDD.t405 a_4187_2434# a_4871_5315# VDD.t281 sg13_lv_pmos ad=0.3808p pd=2.92u as=0.2128p ps=1.5u w=1.12u l=0.6u
X205 VDD.t313 a_4187_2434# a_4111_17497# VDD.t297 sg13_lv_pmos ad=0.3808p pd=2.92u as=0.2128p ps=1.5u w=1.12u l=0.6u
X206 a_26151_16869# a_25913_16869# a_26043_16869# VSS.t1295 sg13_lv_nmos ad=0.1406p pd=1.12u as=0.2516p ps=2.16u w=0.74u l=0.2u
X207 VSS.t291 a_4187_1764.t25 a_10191_1842# VSS.t290 sg13_lv_nmos ad=0.2516p pd=2.16u as=0.1406p ps=1.12u w=0.74u l=0.6u
X208 VSS.t959 VDD.t1654 VSS.t959 VSS.t962 sg13_lv_nmos ad=0.1428p pd=1.52u as=0 ps=0 w=0.42u l=1u
X209 VSS.t927 VDD.t1663 VSS.t927 VSS.t930 sg13_lv_nmos ad=79.8f pd=0.8u as=0 ps=0 w=0.42u l=1u
X210 VDD.t1007 REF_MUX_SEL1 a_3449_7085# VDD.t41 sg13_lv_pmos ad=0.1918p pd=1.5u as=0.1596p ps=1.22u w=0.84u l=0.13u
X211 VSS.t1615 a_3747_1047.t4 a_21911_1008# VSS.t1614 sg13_lv_nmos ad=0.2516p pd=2.16u as=0.2516p ps=2.16u w=0.74u l=0.13u
X212 VSS.t1648 a_11603_14024# a_12037_14024# VSS.t2030 sg13_lv_nmos ad=0.1406p pd=1.12u as=0.2516p ps=2.16u w=0.74u l=0.13u
X213 a_9772_11533# a_9746_11495# VDD.t270 VDD.t268 sg13_lv_pmos ad=0.3927p pd=2.99u as=1.10612p ps=6.66u w=1.155u l=0.13u
X214 a_17791_7532# a_17553_7532# a_17683_7532# VSS.t1217 sg13_lv_nmos ad=0.1406p pd=1.12u as=0.2516p ps=2.16u w=0.74u l=0.2u
X215 VDD.t444 a_4187_2434# a_14751_2470# VDD.t399 sg13_lv_pmos ad=0.3808p pd=2.92u as=0.2128p ps=1.5u w=1.12u l=0.6u
X216 a_2297_12513# CHAN1_MUX_SEL2 VDD.t1544 VDD.t50 sg13_lv_pmos ad=0.1596p pd=1.22u as=0.2856p ps=2.36u w=0.84u l=0.13u
X217 a_10232_11561# a_10206_11525# VDD.t874 VDD.t268 sg13_lv_pmos ad=0.34p pd=2.68u as=0.36237p ps=2.605u w=1u l=0.13u
X218 a_11473_4687# a_11277_4687# VSS.t711 VSS.t2266 sg13_lv_nmos ad=0.2516p pd=2.16u as=0.1406p ps=1.12u w=0.74u l=0.13u
X219 VSS.t1150 a_19963_1842# a_20397_1842# VSS.t1935 sg13_lv_nmos ad=0.1406p pd=1.12u as=0.2516p ps=2.16u w=0.74u l=0.13u
X220 a_2967_15358# CHAN0_MUX_SEL3 a_2873_15358# VSS.t2193 sg13_lv_nmos ad=0.1216p pd=1.02u as=0.2176p ps=1.96u w=0.64u l=0.13u
X221 VSS.t82 VDD.t1636 VSS.t82 VSS.t1026 sg13_lv_nmos ad=79.8f pd=0.8u as=0 ps=0 w=0.42u l=1u
X222 a_7390_3889# a_9751_3853# a_9675_3889# VDD.t0 sg13_lv_pmos ad=0.3808p pd=2.92u as=0.2128p ps=1.5u w=1.12u l=0.13u
X223 VDD.t404 a_4187_2434# a_4111_2470# VDD.t399 sg13_lv_pmos ad=0.3808p pd=2.92u as=0.2128p ps=1.5u w=1.12u l=0.6u
X224 VSS.t135 a_2019_16074.t6 a_13444_16035# VSS.t1634 sg13_lv_nmos ad=0.2516p pd=2.16u as=0.2516p ps=2.16u w=0.74u l=0.13u
X225 a_20968_1044# a_20397_1842# VSS.t566 VSS.t1862 sg13_lv_nmos ad=0.1406p pd=1.12u as=0.2516p ps=2.16u w=0.74u l=0.13u
X226 a_10328_1044# a_9757_1842# VDD.t1153 VDD.t7 sg13_lv_pmos ad=0.2128p pd=1.5u as=0.3808p ps=2.92u w=1.12u l=0.13u
X227 VDD.t47 VSS.t992 VDD.t45 VDD.t41 sg13_lv_pmos ad=0.19p pd=1.38u as=0 ps=0 w=1u l=1u
X228 VSS.t1567 a_2019_13229.t7 a_10404_13190# VSS.t1566 sg13_lv_nmos ad=0.2516p pd=2.16u as=0.2516p ps=2.16u w=0.74u l=0.13u
X229 VDD.t550 a_6283_16869# a_6717_16869# VDD.t297 sg13_lv_pmos ad=0.2128p pd=1.5u as=0.3808p ps=2.92u w=1.12u l=0.13u
X230 a_6635_6734# a_6425_6734# VDD.t276 VDD.t41 sg13_lv_pmos ad=0.2128p pd=1.5u as=0.252p ps=1.57u w=1.12u l=0.13u
X231 a_16510_6734# a_2019_6737.t5 a_16408_6734# VSS.t735 sg13_lv_nmos ad=0.2516p pd=2.16u as=0.1406p ps=1.12u w=0.74u l=0.13u
X232 a_22590_1044# a_22564_1008# a_22488_1044# VDD.t7 sg13_lv_pmos ad=0.3808p pd=2.92u as=0.2128p ps=1.5u w=1.12u l=0.13u
X233 VDD.t916 a_3747_15338.t2 a_26985_15546# VDD.t4 sg13_lv_pmos ad=0.3808p pd=2.92u as=0.3808p ps=2.92u w=1.12u l=0.13u
X234 VDD.t1096 VSS.t1075 VDD.t1014 VDD.t7 sg13_lv_pmos ad=0.19p pd=1.38u as=0 ps=0 w=1u l=1u
X235 a_22590_16071# a_24084_16035# a_24008_16071# VDD.t4 sg13_lv_pmos ad=0.3808p pd=2.92u as=0.2128p ps=1.5u w=1.12u l=0.13u
X236 VDD.t215 VSS.t829 VDD.t213 VDD.t4 sg13_lv_pmos ad=0.19p pd=1.38u as=0 ps=0 w=1u l=1u
X237 VDD.t1506 a_2595_6737.t9 a_5191_6698# VDD.t41 sg13_lv_pmos ad=0.3808p pd=2.92u as=0.3808p ps=2.92u w=1.12u l=0.13u
X238 VDD.t131 VSS.t1003 VDD.t100 VDD.t0 sg13_lv_pmos ad=0.19p pd=1.38u as=0 ps=0 w=1u l=1u
X239 VDD.t595 a_3449_4240# a_3747_3892.t0 VDD.t0 sg13_lv_pmos ad=0.4256p pd=3u as=0.2128p ps=1.5u w=1.12u l=0.13u
X240 a_21591_7532# a_21353_7532# a_21483_7532# VSS.t1732 sg13_lv_nmos ad=0.1406p pd=1.12u as=0.2516p ps=2.16u w=0.74u l=0.2u
X241 a_6153_7532# a_5957_7532# VSS.t226 VSS.t225 sg13_lv_nmos ad=0.2516p pd=2.16u as=0.1406p ps=1.12u w=0.74u l=0.13u
X242 a_20315_6734# a_20105_6734# VDD.t546 VDD.t41 sg13_lv_pmos ad=0.2128p pd=1.5u as=0.252p ps=1.57u w=1.12u l=0.13u
X243 a_8808_1044# a_8237_1842# VDD.t870 VDD.t7 sg13_lv_pmos ad=0.2128p pd=1.5u as=0.3808p ps=2.92u w=1.12u l=0.13u
X244 VDD.t806 VDD.t804 VDD.t805 VDD.t281 sg13_lv_pmos ad=0.3808p pd=2.92u as=0 ps=0 w=1.12u l=0.6u
X245 a_1256_12471# CHAN1_MUX_SEL2 VSS.t121 VSS.t2272 sg13_lv_nmos ad=0.2516p pd=2.16u as=0.2516p ps=2.16u w=0.74u l=0.13u
X246 a_25528_6734# a_24957_7532# VDD.t527 VDD.t41 sg13_lv_pmos ad=0.2128p pd=1.5u as=0.3808p ps=2.92u w=1.12u l=0.13u
X247 a_3171_13229.t1 a_2873_13577# VSS.t259 VSS.t258 sg13_lv_nmos ad=0.1406p pd=1.12u as=0.1331p ps=1.12u w=0.74u l=0.13u
X248 VSS.t602 a_16163_7532# a_16597_7532# VSS.t1234 sg13_lv_nmos ad=0.1406p pd=1.12u as=0.2516p ps=2.16u w=0.74u l=0.13u
X249 VSS.t518 a_3171_6737.t2 a_27124_6698# VSS.t726 sg13_lv_nmos ad=0.2516p pd=2.16u as=0.2516p ps=2.16u w=0.74u l=0.13u
X250 VDD.t206 VSS.t839 VDD.t205 VDD.t4 sg13_lv_pmos ad=0.34p pd=2.68u as=0 ps=0 w=1u l=1u
X251 VDD.t1047 a_2595_3156.t2 a_20905_3364# VDD.t0 sg13_lv_pmos ad=0.3808p pd=2.92u as=0.3808p ps=2.92u w=1.12u l=0.13u
X252 a_23871_14024# a_23633_14024# a_23763_14024# VSS.t1814 sg13_lv_nmos ad=0.1406p pd=1.12u as=0.2516p ps=2.16u w=0.74u l=0.2u
X253 VDD.t1440 a_11603_7532# a_12037_7532# VDD.t275 sg13_lv_pmos ad=0.2128p pd=1.5u as=0.3808p ps=2.92u w=1.12u l=0.13u
X254 a_18551_17497# a_18313_16869# a_18443_16869# VDD.t297 sg13_lv_pmos ad=0.2128p pd=1.5u as=0.3808p ps=2.92u w=1.12u l=0.2u
X255 CHAN1_DELAY_OUT_LAST a_27997_14024# VSS.t1251 VSS.t1894 sg13_lv_nmos ad=0.2516p pd=2.16u as=0.1406p ps=1.12u w=0.74u l=0.13u
X256 VDD.t531 a_3171_13229.t7 a_11924_13190# VDD.t50 sg13_lv_pmos ad=0.3808p pd=2.92u as=0.3808p ps=2.92u w=1.12u l=0.13u
X257 VSS.t820 VDD.t1697 VSS.t819 VSS.t818 sg13_lv_nmos ad=0.1428p pd=1.52u as=0 ps=0 w=0.42u l=1u
X258 a_4350_13226# a_2595_13229.t9 a_5115_13226# VSS.t1952 sg13_lv_nmos ad=0.2516p pd=2.16u as=0.1406p ps=1.12u w=0.74u l=0.13u
X259 a_3449_4240# CHAN2_MUX_SEL0 VDD.t1478 VDD.t0 sg13_lv_pmos ad=0.1596p pd=1.22u as=0.2856p ps=2.36u w=0.84u l=0.13u
X260 a_13880_10808# a_14111_10917# a_13566_11018# VSS.t197 sg13_lv_nmos ad=0.2373p pd=1.97u as=79.8f ps=0.8u w=0.42u l=0.13u
X261 VSS.t447 a_4187_1764.t104 a_24631_14024# VSS.t446 sg13_lv_nmos ad=0.2516p pd=2.16u as=0.1406p ps=1.12u w=0.74u l=0.6u
X262 a_24393_7532# a_24197_7532# VDD.t284 VDD.t275 sg13_lv_pmos ad=0.3808p pd=2.92u as=0.2128p ps=1.5u w=1.12u l=0.13u
X263 a_10430_6734# a_2595_6737.t7 a_11195_6734# VSS.t719 sg13_lv_nmos ad=0.2516p pd=2.16u as=0.1406p ps=1.12u w=0.74u l=0.13u
X264 VSS.t426 a_3171_15338.t3 a_11785_15546# VSS.t425 sg13_lv_nmos ad=0.2516p pd=2.16u as=0.2516p ps=2.16u w=0.74u l=0.13u
X265 a_4157_1313# CHAN3_DELAY_IN VDD.t1479 VDD.t7 sg13_lv_pmos ad=0.3808p pd=2.92u as=0.3808p ps=2.92u w=1.12u l=0.13u
X266 a_27433_4687# a_27237_4687# VDD.t910 VDD.t281 sg13_lv_pmos ad=0.3808p pd=2.92u as=0.2128p ps=1.5u w=1.12u l=0.13u
X267 a_7390_16071# a_8884_16035# a_8808_16071# VDD.t4 sg13_lv_pmos ad=0.3808p pd=2.92u as=0.2128p ps=1.5u w=1.12u l=0.13u
X268 a_17031_2470# a_16793_1842# a_16923_1842# VDD.t399 sg13_lv_pmos ad=0.2128p pd=1.5u as=0.3808p ps=2.92u w=1.12u l=0.2u
X269 VSS.t782 a_4187_1764.t37 a_25391_4687# VSS.t1411 sg13_lv_nmos ad=0.2516p pd=2.16u as=0.1406p ps=1.12u w=0.74u l=0.6u
X270 VDD.t64 VSS.t959 VDD.t63 VDD.t41 sg13_lv_pmos ad=0.34p pd=2.68u as=0 ps=0 w=1u l=1u
X271 VDD.t1267 a_1544_15316# a_1721_15358# VDD.t4 sg13_lv_pmos ad=0.1918p pd=1.5u as=0.1596p ps=1.22u w=0.84u l=0.13u
X272 a_17553_14024# a_17357_14024# VDD.t1389 VDD.t301 sg13_lv_pmos ad=0.3808p pd=2.92u as=0.2128p ps=1.5u w=1.12u l=0.13u
X273 a_23355_6734# a_23145_6734# VSS.t411 VSS.t2127 sg13_lv_nmos ad=0.1406p pd=1.12u as=0.1665p ps=1.19u w=0.74u l=0.13u
X274 VSS.t449 a_4187_1764.t89 a_10191_7532# VSS.t448 sg13_lv_nmos ad=0.2516p pd=2.16u as=0.1406p ps=1.12u w=0.74u l=0.6u
X275 VDD.t316 a_4187_2434# a_4111_14652# VDD.t301 sg13_lv_pmos ad=0.3808p pd=2.92u as=0.2128p ps=1.5u w=1.12u l=0.6u
X276 VDD.t74 VSS.t889 VDD.t73 VDD.t50 sg13_lv_pmos ad=0.19p pd=1.38u as=0 ps=0 w=1u l=1u
X277 a_4350_16071# a_4324_16035# a_4248_16071# VDD.t4 sg13_lv_pmos ad=0.3808p pd=2.92u as=0.2128p ps=1.5u w=1.12u l=0.13u
X278 VSS.t315 a_3747_6737.t4 a_21911_6698# VSS.t1769 sg13_lv_nmos ad=0.2516p pd=2.16u as=0.2516p ps=2.16u w=0.74u l=0.13u
X279 VDD.t965 a_3171_3892.t5 a_18004_3853# VDD.t0 sg13_lv_pmos ad=0.3808p pd=2.92u as=0.3808p ps=2.92u w=1.12u l=0.13u
X280 VDD.t388 a_4187_2434# a_14751_8160# VDD.t275 sg13_lv_pmos ad=0.3808p pd=2.92u as=0.2128p ps=1.5u w=1.12u l=0.6u
X281 a_3171_3156.t0 a_2873_3176# VDD.t707 VDD.t0 sg13_lv_pmos ad=0.2128p pd=1.5u as=0.1918p ps=1.5u w=1.12u l=0.13u
X282 a_26673_16869# a_26477_16869# VSS.t1292 VSS.t1294 sg13_lv_nmos ad=0.2516p pd=2.16u as=0.1406p ps=1.12u w=0.74u l=0.13u
X283 a_11473_1842# a_11277_1842# VSS.t542 VSS.t1672 sg13_lv_nmos ad=0.2516p pd=2.16u as=0.1406p ps=1.12u w=0.74u l=0.13u
X284 VDD.t577 a_2019_15338.t2 a_17865_15546# VDD.t4 sg13_lv_pmos ad=0.3808p pd=2.92u as=0.3808p ps=2.92u w=1.12u l=0.13u
X285 VSS.t280 a_19963_7532# a_20397_7532# VSS.t471 sg13_lv_nmos ad=0.1406p pd=1.12u as=0.2516p ps=2.16u w=0.74u l=0.13u
X286 VDD.t868 a_2297_3176# a_2595_3156.t0 VDD.t0 sg13_lv_pmos ad=0.4256p pd=3u as=0.2128p ps=1.5u w=1.12u l=0.13u
X287 a_2967_12513# CHAN1_MUX_SEL3 a_2873_12513# VSS.t122 sg13_lv_nmos ad=0.1216p pd=1.02u as=0.2176p ps=1.96u w=0.64u l=0.13u
X288 VSS.t1105 VDD.t1613 VSS.t1103 VSS.t1104 sg13_lv_nmos ad=79.8f pd=0.8u as=0 ps=0 w=0.42u l=1u
X289 VDD.t1085 a_3747_12493.t3 a_14825_12701# VDD.t50 sg13_lv_pmos ad=0.3808p pd=2.92u as=0.3808p ps=2.92u w=1.12u l=0.13u
X290 a_16408_3889# a_15837_4687# VSS.t434 VSS.t433 sg13_lv_nmos ad=0.1406p pd=1.12u as=0.2516p ps=2.16u w=0.74u l=0.13u
X291 VDD.t1294 a_1721_15358# a_2019_15338.t0 VDD.t4 sg13_lv_pmos ad=0.4256p pd=3u as=0.2128p ps=1.5u w=1.12u l=0.13u
X292 VSS.t1876 a_1721_15358# a_2019_15338.t1 VSS.t1909 sg13_lv_nmos ad=0.2812p pd=2.24u as=0.1406p ps=1.12u w=0.74u l=0.13u
X293 a_8433_14024# a_8237_14024# VSS.t2019 VSS.t2018 sg13_lv_nmos ad=0.2516p pd=2.16u as=0.1406p ps=1.12u w=0.74u l=0.13u
X294 a_19448_1044# a_18877_1842# VSS.t372 VSS.t1679 sg13_lv_nmos ad=0.1406p pd=1.12u as=0.2516p ps=2.16u w=0.74u l=0.13u
X295 VDD.t1073 a_2595_16074.t6 a_14311_16035# VDD.t4 sg13_lv_pmos ad=0.3808p pd=2.92u as=0.3808p ps=2.92u w=1.12u l=0.13u
X296 VSS.t876 VDD.t1680 VSS.t875 VSS.t874 sg13_lv_nmos ad=0.1428p pd=1.52u as=0 ps=0 w=0.42u l=1u
X297 a_25630_13226# a_2019_13229.t2 a_25528_13226# VSS.t2152 sg13_lv_nmos ad=0.2516p pd=2.16u as=0.1406p ps=1.12u w=0.74u l=0.13u
X298 a_15053_11680# a_14111_11568# a_14851_11918# VDD.t268 sg13_lv_pmos ad=93.45f pd=0.865u as=0.2048p ps=1.63u w=0.42u l=0.13u
X299 VDD.t380 a_4187_2434# a_4111_8160# VDD.t275 sg13_lv_pmos ad=0.3808p pd=2.92u as=0.2128p ps=1.5u w=1.12u l=0.6u
X300 a_10430_1044# a_3171_1047.t7 a_11848_1044# VSS.t379 sg13_lv_nmos ad=0.2516p pd=2.16u as=0.1406p ps=1.12u w=0.74u l=0.13u
X301 a_20968_6734# a_20397_7532# VSS.t724 VSS.t1128 sg13_lv_nmos ad=0.1406p pd=1.12u as=0.2516p ps=2.16u w=0.74u l=0.13u
X302 VDD.t893 a_27237_1842# a_27705_1044# VDD.t7 sg13_lv_pmos ad=0.252p pd=1.57u as=0.3808p ps=2.92u w=1.12u l=0.13u
X303 a_14235_3889# a_14025_3889# VDD.t613 VDD.t0 sg13_lv_pmos ad=0.2128p pd=1.5u as=0.252p ps=1.57u w=1.12u l=0.13u
X304 a_5731_5979# a_14825_6209# a_13470_6734# VDD.t41 sg13_lv_pmos ad=0.3808p pd=2.92u as=0.3808p ps=2.92u w=1.12u l=0.13u
X305 a_19448_13226# a_18877_14024# VSS.t1564 VSS.t2095 sg13_lv_nmos ad=0.1406p pd=1.12u as=0.2516p ps=2.16u w=0.74u l=0.13u
X306 VDD.t408 a_4187_2434# a_7151_5315# VDD.t281 sg13_lv_pmos ad=0.3808p pd=2.92u as=0.2128p ps=1.5u w=1.12u l=0.6u
X307 VSS.t1972 a_16851_15336# CHAN0_MUX_OUT VSS.t1981 sg13_lv_nmos ad=0.2516p pd=2.16u as=0.1406p ps=1.12u w=0.74u l=0.13u
X308 a_16108_12471# a_15765_12645# a_15964_12471# VDD.t50 sg13_lv_pmos ad=0.3808p pd=2.92u as=0.3304p ps=1.71u w=1.12u l=0.13u
X309 VDD.t1132 a_6326_10280# a_6326_10280# VDD.t268 sg13_lv_pmos ad=0.38p pd=2.38u as=0.38p ps=2.38u w=2u l=1u
X310 VSS.t1081 VDD.t1620 VSS.t1079 VSS.t1080 sg13_lv_nmos ad=79.8f pd=0.8u as=0 ps=0 w=0.42u l=1u
X311 VDD.t34 VSS.t1056 VDD.t32 VDD.t0 sg13_lv_pmos ad=0.19p pd=1.38u as=0 ps=0 w=1u l=1u
X312 a_2595_16074.t1 a_2297_16422# VSS.t251 VSS.t1343 sg13_lv_nmos ad=0.1406p pd=1.12u as=0.1331p ps=1.12u w=0.74u l=0.13u
X313 a_20831_2470# a_20593_1842# a_20723_1842# VDD.t399 sg13_lv_pmos ad=0.2128p pd=1.5u as=0.3808p ps=2.92u w=1.12u l=0.2u
X314 VDD.t1353 a_6283_14024# a_6717_14024# VDD.t301 sg13_lv_pmos ad=0.2128p pd=1.5u as=0.3808p ps=2.92u w=1.12u l=0.13u
X315 a_5393_1842# a_5197_1842# VDD.t535 VDD.t399 sg13_lv_pmos ad=0.3808p pd=2.92u as=0.2128p ps=1.5u w=1.12u l=0.13u
X316 VDD.t1058 a_3747_3892.t7 a_12791_3853# VDD.t0 sg13_lv_pmos ad=0.3808p pd=2.92u as=0.3808p ps=2.92u w=1.12u l=0.13u
X317 VSS.t1626 a_4187_1764.t116 a_15511_14024# VSS.t1625 sg13_lv_nmos ad=0.2516p pd=2.16u as=0.1406p ps=1.12u w=0.74u l=0.6u
X318 a_13949_11186# a_13592_11113# VDD.t274 VDD.t268 sg13_lv_pmos ad=63f pd=0.72u as=0.1563p ps=1.22u w=0.42u l=0.13u
X319 VDD.t450 a_4187_2434# a_17031_2470# VDD.t399 sg13_lv_pmos ad=0.3808p pd=2.92u as=0.2128p ps=1.5u w=1.12u l=0.6u
X320 a_10191_14024# a_9953_14024# a_10083_14024# VSS.t2077 sg13_lv_nmos ad=0.1406p pd=1.12u as=0.2516p ps=2.16u w=0.74u l=0.2u
X321 VSS.t1650 a_4187_1764.t122 a_10951_14024# VSS.t1649 sg13_lv_nmos ad=0.2516p pd=2.16u as=0.1406p ps=1.12u w=0.74u l=0.6u
X322 a_7390_3889# a_3747_3892.t8 a_9675_3889# VSS.t1846 sg13_lv_nmos ad=0.2516p pd=2.16u as=0.1406p ps=1.12u w=0.74u l=0.13u
X323 a_25630_13226# a_27124_13190# a_27048_13226# VDD.t50 sg13_lv_pmos ad=0.3808p pd=2.92u as=0.2128p ps=1.5u w=1.12u l=0.13u
X324 VDD.t1254 a_26803_1842# a_27237_1842# VDD.t399 sg13_lv_pmos ad=0.2128p pd=1.5u as=0.3808p ps=2.92u w=1.12u l=0.13u
X325 VDD.t843 CHAN3_MUX_SEL1 a_3449_1395# VDD.t7 sg13_lv_pmos ad=0.1918p pd=1.5u as=0.1596p ps=1.22u w=0.84u l=0.13u
X326 a_17275_16071# a_17065_16071# VDD.t925 VDD.t4 sg13_lv_pmos ad=0.2128p pd=1.5u as=0.252p ps=1.57u w=1.12u l=0.13u
X327 a_11848_3889# a_11277_4687# VDD.t1536 VDD.t0 sg13_lv_pmos ad=0.2128p pd=1.5u as=0.3808p ps=2.92u w=1.12u l=0.13u
X328 a_18551_14652# a_18313_14024# a_18443_14024# VDD.t301 sg13_lv_pmos ad=0.2128p pd=1.5u as=0.3808p ps=2.92u w=1.12u l=0.2u
X329 VSS.t6 a_15108_11015# a_14757_10872# VSS.t90 sg13_lv_nmos ad=79.8f pd=0.8u as=0.1428p ps=1.52u w=0.42u l=0.13u
X330 a_25630_1044# a_2595_1047.t2 a_26395_1044# VSS.t1345 sg13_lv_nmos ad=0.2516p pd=2.16u as=0.1406p ps=1.12u w=0.74u l=0.13u
X331 a_17031_8160# a_16793_7532# a_16923_7532# VDD.t275 sg13_lv_pmos ad=0.2128p pd=1.5u as=0.3808p ps=2.92u w=1.12u l=0.2u
X332 a_16408_6734# a_15837_7532# VDD.t561 VDD.t41 sg13_lv_pmos ad=0.2128p pd=1.5u as=0.3808p ps=2.92u w=1.12u l=0.13u
X333 VSS.t970 VDD.t1651 VSS.t970 VSS.t973 sg13_lv_nmos ad=0.1428p pd=1.52u as=0 ps=0 w=0.42u l=1u
X334 a_27671_16869# a_27433_16869# a_27563_16869# VSS.t1299 sg13_lv_nmos ad=0.1406p pd=1.12u as=0.2516p ps=2.16u w=0.74u l=0.2u
X335 a_16510_13226# a_2019_13229.t5 a_16408_13226# VSS.t1560 sg13_lv_nmos ad=0.2516p pd=2.16u as=0.1406p ps=1.12u w=0.74u l=0.13u
X336 VSS.t489 a_4187_1764.t5 a_25391_1842# VSS.t488 sg13_lv_nmos ad=0.2516p pd=2.16u as=0.1406p ps=1.12u w=0.74u l=0.6u
X337 VDD.t1416 a_1544_12471# a_1721_12513# VDD.t50 sg13_lv_pmos ad=0.1918p pd=1.5u as=0.1596p ps=1.22u w=0.84u l=0.13u
X338 VDD.t249 VSS.t82 VDD.t248 VDD.t0 sg13_lv_pmos ad=0.34p pd=2.68u as=0 ps=0 w=1u l=1u
X339 VSS.t755 a_13123_14024# a_13557_14024# VSS.t2059 sg13_lv_nmos ad=0.1406p pd=1.12u as=0.2516p ps=2.16u w=0.74u l=0.13u
X340 a_5115_13226# a_4905_13226# VDD.t1286 VDD.t50 sg13_lv_pmos ad=0.2128p pd=1.5u as=0.252p ps=1.57u w=1.12u l=0.13u
X341 a_26673_4687# a_26477_4687# VSS.t219 VSS.t400 sg13_lv_nmos ad=0.2516p pd=2.16u as=0.1406p ps=1.12u w=0.74u l=0.13u
X342 a_6635_1044# a_6425_1044# VDD.t688 VDD.t7 sg13_lv_pmos ad=0.2128p pd=1.5u as=0.252p ps=1.57u w=1.12u l=0.13u
X343 a_11473_7532# a_11277_7532# VSS.t596 VSS.t1168 sg13_lv_nmos ad=0.2516p pd=2.16u as=0.1406p ps=1.12u w=0.74u l=0.13u
X344 VSS.t918 VDD.t1666 VSS.t918 VSS.t921 sg13_lv_nmos ad=79.8f pd=0.8u as=0 ps=0 w=0.42u l=1u
X345 a_18313_4687# a_18117_4687# VDD.t1004 VDD.t281 sg13_lv_pmos ad=0.3808p pd=2.92u as=0.2128p ps=1.5u w=1.12u l=0.13u
X346 VDD.t497 a_2595_1047.t9 a_5191_1008# VDD.t7 sg13_lv_pmos ad=0.3808p pd=2.92u as=0.3808p ps=2.92u w=1.12u l=0.13u
X347 a_9431_5315# a_9193_4687# a_9323_4687# VDD.t281 sg13_lv_pmos ad=0.2128p pd=1.5u as=0.3808p ps=2.92u w=1.12u l=0.2u
X348 a_19448_6734# a_18877_7532# VSS.t464 VSS.t696 sg13_lv_nmos ad=0.1406p pd=1.12u as=0.2516p ps=2.16u w=0.74u l=0.13u
X349 a_20315_1044# a_20105_1044# VDD.t1176 VDD.t7 sg13_lv_pmos ad=0.2128p pd=1.5u as=0.252p ps=1.57u w=1.12u l=0.13u
X350 a_13592_11113# a_14111_10917# a_14851_10872# VSS.t198 sg13_lv_nmos ad=0.3473p pd=2.71u as=0.12665p ps=1.145u w=0.74u l=0.13u
X351 a_10430_6734# a_3171_6737.t7 a_11848_6734# VSS.t1309 sg13_lv_nmos ad=0.2516p pd=2.16u as=0.1406p ps=1.12u w=0.74u l=0.13u
X352 a_7390_6734# a_9751_6698# a_9675_6734# VDD.t41 sg13_lv_pmos ad=0.3808p pd=2.92u as=0.2128p ps=1.5u w=1.12u l=0.13u
X353 a_25528_1044# a_24957_1842# VDD.t1281 VDD.t7 sg13_lv_pmos ad=0.2128p pd=1.5u as=0.3808p ps=2.92u w=1.12u l=0.13u
X354 VSS.t256 a_1721_1395# a_2019_1047.t1 VSS.t1145 sg13_lv_nmos ad=0.2812p pd=2.24u as=0.1406p ps=1.12u w=0.74u l=0.13u
X355 a_19311_2470# a_19073_1842# a_19203_1842# VDD.t399 sg13_lv_pmos ad=0.2128p pd=1.5u as=0.3808p ps=2.92u w=1.12u l=0.2u
X356 a_5731_3134# a_14825_3364# a_13470_3889# VDD.t0 sg13_lv_pmos ad=0.3808p pd=2.92u as=0.3808p ps=2.92u w=1.12u l=0.13u
X357 VSS.t669 a_5957_1842# a_6425_1044# VSS.t2208 sg13_lv_nmos ad=0.1665p pd=1.19u as=0.2516p ps=2.16u w=0.74u l=0.13u
X358 VSS.t1350 a_3171_3892.t5 a_18004_3853# VSS.t1349 sg13_lv_nmos ad=0.2516p pd=2.16u as=0.2516p ps=2.16u w=0.74u l=0.13u
X359 VSS.t1277 a_2019_16074.t7 a_10404_16035# VSS.t1479 sg13_lv_nmos ad=0.2516p pd=2.16u as=0.2516p ps=2.16u w=0.74u l=0.13u
X360 a_20831_8160# a_20593_7532# a_20723_7532# VDD.t275 sg13_lv_pmos ad=0.2128p pd=1.5u as=0.3808p ps=2.92u w=1.12u l=0.2u
X361 a_5393_7532# a_5197_7532# VDD.t504 VDD.t275 sg13_lv_pmos ad=0.3808p pd=2.92u as=0.2128p ps=1.5u w=1.12u l=0.13u
X362 a_23871_5315# a_23633_4687# a_23763_4687# VDD.t281 sg13_lv_pmos ad=0.2128p pd=1.5u as=0.3808p ps=2.92u w=1.12u l=0.2u
X363 VDD.t371 a_4187_2434# a_17031_8160# VDD.t275 sg13_lv_pmos ad=0.3808p pd=2.92u as=0.2128p ps=1.5u w=1.12u l=0.6u
X364 VSS.t796 a_4187_1764.t62 a_6391_4687# VSS.t1154 sg13_lv_nmos ad=0.2516p pd=2.16u as=0.1406p ps=1.12u w=0.74u l=0.6u
X365 a_8433_4687# a_8237_4687# VDD.t826 VDD.t281 sg13_lv_pmos ad=0.3808p pd=2.92u as=0.2128p ps=1.5u w=1.12u l=0.13u
X366 VSS.t259 a_2297_13577# a_2595_13229.t1 VSS.t390 sg13_lv_nmos ad=0.2812p pd=2.24u as=0.1406p ps=1.12u w=0.74u l=0.13u
X367 VSS.t510 a_10649_11568# a_10751_11568# VSS.t629 sg13_lv_nmos ad=2.39977p pd=15.495u as=0.2516p ps=2.16u w=0.74u l=0.13u
X368 VDD.t86 VSS.t689 VDD.t85 VDD.t4 sg13_lv_pmos ad=0.34p pd=2.68u as=0 ps=0 w=1u l=1u
X369 VDD.t480 a_18443_4687# a_18877_4687# VDD.t281 sg13_lv_pmos ad=0.2128p pd=1.5u as=0.3808p ps=2.92u w=1.12u l=0.13u
X370 a_19550_16071# a_21044_16035# a_20968_16071# VDD.t4 sg13_lv_pmos ad=0.3808p pd=2.92u as=0.2128p ps=1.5u w=1.12u l=0.13u
X371 a_10713_14024# a_10517_14024# VSS.t524 VSS.t2052 sg13_lv_nmos ad=0.2516p pd=2.16u as=0.1406p ps=1.12u w=0.74u l=0.13u
X372 VDD.t519 a_26803_7532# a_27237_7532# VDD.t275 sg13_lv_pmos ad=0.2128p pd=1.5u as=0.3808p ps=2.92u w=1.12u l=0.13u
X373 a_14235_3889# a_14025_3889# VSS.t440 VSS.t1431 sg13_lv_nmos ad=0.1406p pd=1.12u as=0.1665p ps=1.19u w=0.74u l=0.13u
X374 a_22113_4687# a_21917_4687# VDD.t855 VDD.t281 sg13_lv_pmos ad=0.3808p pd=2.92u as=0.2128p ps=1.5u w=1.12u l=0.13u
X375 VSS.t1725 a_4187_1764.t143 a_19311_16869# VSS.t2120 sg13_lv_nmos ad=0.2516p pd=2.16u as=0.1406p ps=1.12u w=0.74u l=0.6u
X376 a_3171_16074.t1 a_2873_16422# VSS.t251 VSS.t1380 sg13_lv_nmos ad=0.1406p pd=1.12u as=0.1331p ps=1.12u w=0.74u l=0.13u
X377 VDD.t917 a_2019_13229.t6 a_13444_13190# VDD.t50 sg13_lv_pmos ad=0.3808p pd=2.92u as=0.3808p ps=2.92u w=1.12u l=0.13u
X378 VDD.t851 a_19637_4687# a_20105_3889# VDD.t0 sg13_lv_pmos ad=0.252p pd=1.57u as=0.3808p ps=2.92u w=1.12u l=0.13u
X379 VDD.t213 VSS.t829 VDD.t212 VDD.t4 sg13_lv_pmos ad=0.34p pd=2.68u as=0 ps=0 w=1u l=1u
X380 VSS.t153 a_2019_1047.t6 a_13444_1008# VSS.t152 sg13_lv_nmos ad=0.2516p pd=2.16u as=0.2516p ps=2.16u w=0.74u l=0.13u
X381 VSS.t273 a_3747_3892.t7 a_12791_3853# VSS.t1517 sg13_lv_nmos ad=0.2516p pd=2.16u as=0.2516p ps=2.16u w=0.74u l=0.13u
X382 VSS.t502 a_4187_1764.t43 a_20831_4687# VSS.t501 sg13_lv_nmos ad=0.2516p pd=2.16u as=0.1406p ps=1.12u w=0.74u l=0.6u
X383 VDD.t673 a_16851_12491# CHAN1_MUX_OUT VDD.t50 sg13_lv_pmos ad=0.7336p pd=3.55u as=0.2128p ps=1.5u w=1.12u l=0.13u
X384 a_25630_6734# a_2595_6737.t2 a_26395_6734# VSS.t2209 sg13_lv_nmos ad=0.2516p pd=2.16u as=0.1406p ps=1.12u w=0.74u l=0.13u
X385 a_4350_16071# a_2595_16074.t9 a_5115_16071# VSS.t1631 sg13_lv_nmos ad=0.2516p pd=2.16u as=0.1406p ps=1.12u w=0.74u l=0.13u
X386 a_25153_14024# a_24957_14024# VSS.t447 VSS.t1245 sg13_lv_nmos ad=0.2516p pd=2.16u as=0.1406p ps=1.12u w=0.74u l=0.13u
X387 VSS.t1063 VDD.t1625 VSS.t1063 VSS.t1062 sg13_lv_nmos ad=0.1428p pd=1.52u as=0 ps=0 w=0.42u l=1u
X388 a_23111_2470# a_22873_1842# a_23003_1842# VDD.t399 sg13_lv_pmos ad=0.2128p pd=1.5u as=0.3808p ps=2.92u w=1.12u l=0.2u
X389 VSS.t334 a_15964_289# a_16851_309# VSS.t2086 sg13_lv_nmos ad=0.1371p pd=1.12u as=0.2176p ps=1.96u w=0.64u l=0.13u
X390 VDD.t124 VSS.t970 VDD.t123 VDD.t41 sg13_lv_pmos ad=0.34p pd=2.68u as=0 ps=0 w=1u l=1u
X391 a_16108_289# a_17865_519# a_16510_1044# VDD.t7 sg13_lv_pmos ad=0.3808p pd=2.92u as=0.3808p ps=2.92u w=1.12u l=0.13u
X392 VDD.t416 a_4187_2434# a_12471_5315# VDD.t281 sg13_lv_pmos ad=0.3808p pd=2.92u as=0.2128p ps=1.5u w=1.12u l=0.6u
X393 VDD.t1298 a_17683_1842# a_18117_1842# VDD.t399 sg13_lv_pmos ad=0.2128p pd=1.5u as=0.3808p ps=2.92u w=1.12u l=0.13u
X394 VSS.t1121 a_4187_1764.t69 a_25391_7532# VSS.t1602 sg13_lv_nmos ad=0.2516p pd=2.16u as=0.1406p ps=1.12u w=0.74u l=0.6u
X395 a_10713_1842# a_10517_1842# VDD.t1204 VDD.t399 sg13_lv_pmos ad=0.3808p pd=2.92u as=0.2128p ps=1.5u w=1.12u l=0.13u
X396 a_4350_16071# a_5844_16035# a_5768_16071# VDD.t4 sg13_lv_pmos ad=0.3808p pd=2.92u as=0.2128p ps=1.5u w=1.12u l=0.13u
X397 a_11848_3889# a_11277_4687# VSS.t1355 VSS.t2265 sg13_lv_nmos ad=0.1406p pd=1.12u as=0.2516p ps=2.16u w=0.74u l=0.13u
X398 a_10191_4687# a_9953_4687# a_10083_4687# VSS.t443 sg13_lv_nmos ad=0.1406p pd=1.12u as=0.2516p ps=2.16u w=0.74u l=0.2u
X399 VSS.t1552 a_4187_1764.t98 VSS.t1550 VSS.t1535 sg13_lv_nmos ad=1.33p pd=7.38u as=0 ps=0 w=7u l=7u
X400 VDD.t944 a_3171_6737.t5 a_18004_6698# VDD.t41 sg13_lv_pmos ad=0.3808p pd=2.92u as=0.3808p ps=2.92u w=1.12u l=0.13u
X401 a_26673_1842# a_26477_1842# VSS.t268 VSS.t1910 sg13_lv_nmos ad=0.2516p pd=2.16u as=0.1406p ps=1.12u w=0.74u l=0.13u
X402 VDD.t286 a_22243_4687# a_22677_4687# VDD.t281 sg13_lv_pmos ad=0.2128p pd=1.5u as=0.3808p ps=2.92u w=1.12u l=0.13u
X403 VDD.t204 VSS.t839 VDD.t6 VDD.t4 sg13_lv_pmos ad=0.19p pd=1.38u as=0 ps=0 w=1u l=1u
X404 a_23633_16869# a_23437_16869# VSS.t1290 VSS.t2202 sg13_lv_nmos ad=0.2516p pd=2.16u as=0.1406p ps=1.12u w=0.74u l=0.13u
X405 a_13019_11521# a_15688_11093# VSS.t6 VSS.t694 sg13_lv_nmos ad=0.2516p pd=2.16u as=0.1406p ps=1.12u w=0.74u l=0.13u
X406 a_9953_14024# a_9757_14024# VSS.t526 VSS.t2034 sg13_lv_nmos ad=0.2516p pd=2.16u as=0.1406p ps=1.12u w=0.74u l=0.13u
X407 a_20315_13226# a_20105_13226# VSS.t1329 VSS.t1328 sg13_lv_nmos ad=0.1406p pd=1.12u as=0.1665p ps=1.19u w=0.74u l=0.13u
X408 a_16510_3889# a_17351_3853# a_17275_3889# VDD.t0 sg13_lv_pmos ad=0.3808p pd=2.92u as=0.2128p ps=1.5u w=1.12u l=0.13u
X409 VSS.t491 a_16923_16869# a_17357_16869# VSS.t1779 sg13_lv_nmos ad=0.1406p pd=1.12u as=0.2516p ps=2.16u w=0.74u l=0.13u
X410 VDD.t660 a_3747_15338.t3 a_14825_15546# VDD.t4 sg13_lv_pmos ad=0.3808p pd=2.92u as=0.3808p ps=2.92u w=1.12u l=0.13u
X411 VDD.t464 a_7803_1842# a_8237_1842# VDD.t399 sg13_lv_pmos ad=0.2128p pd=1.5u as=0.3808p ps=2.92u w=1.12u l=0.13u
X412 VDD.t1511 a_3171_12493.t3 a_11785_12701# VDD.t50 sg13_lv_pmos ad=0.3808p pd=2.92u as=0.3808p ps=2.92u w=1.12u l=0.13u
X413 VSS.t1040 VDD.t1632 VSS.t1039 VSS.t1038 sg13_lv_nmos ad=0.1428p pd=1.52u as=0 ps=0 w=0.42u l=1u
X414 a_2595_12493.t0 a_2297_12513# VDD.t1415 VDD.t50 sg13_lv_pmos ad=0.2128p pd=1.5u as=0.1918p ps=1.5u w=1.12u l=0.13u
X415 a_25630_16071# a_2019_16074.t2 a_25528_16071# VSS.t697 sg13_lv_nmos ad=0.2516p pd=2.16u as=0.1406p ps=1.12u w=0.74u l=0.13u
X416 a_19311_8160# a_19073_7532# a_19203_7532# VDD.t275 sg13_lv_pmos ad=0.2128p pd=1.5u as=0.3808p ps=2.92u w=1.12u l=0.2u
X417 VSS.t232 a_1721_7085# a_2019_6737.t1 VSS.t233 sg13_lv_nmos ad=0.2812p pd=2.24u as=0.1406p ps=1.12u w=0.74u l=0.13u
X418 a_4248_1044# a_4157_1313# VSS.t1414 VSS.t1818 sg13_lv_nmos ad=0.1406p pd=1.12u as=0.2516p ps=2.16u w=0.74u l=0.13u
X419 VDD.t552 a_8563_16869# a_8997_16869# VDD.t297 sg13_lv_pmos ad=0.2128p pd=1.5u as=0.3808p ps=2.92u w=1.12u l=0.13u
X420 VSS.t955 VDD.t1656 VSS.t954 VSS.t953 sg13_lv_nmos ad=0.1428p pd=1.52u as=0 ps=0 w=0.42u l=1u
X421 a_19448_16071# a_18877_16869# VSS.t454 VSS.t453 sg13_lv_nmos ad=0.1406p pd=1.12u as=0.2516p ps=2.16u w=0.74u l=0.13u
X422 VDD.t605 a_2595_16074.t7 a_11271_16035# VDD.t4 sg13_lv_pmos ad=0.3808p pd=2.92u as=0.3808p ps=2.92u w=1.12u l=0.13u
X423 VSS.t27 a_5957_7532# a_6425_6734# VSS.t224 sg13_lv_nmos ad=0.1665p pd=1.19u as=0.2516p ps=2.16u w=0.74u l=0.13u
X424 a_14235_6734# a_14025_6734# VDD.t999 VDD.t41 sg13_lv_pmos ad=0.2128p pd=1.5u as=0.252p ps=1.57u w=1.12u l=0.13u
X425 VSS.t686 VDD.t1695 VSS.t825 VSS.t824 sg13_lv_nmos ad=0.1428p pd=1.52u as=0 ps=0 w=0.42u l=1u
X426 a_16108_15316# a_15765_15490# a_15964_15316# VDD.t4 sg13_lv_pmos ad=0.3808p pd=2.92u as=0.3304p ps=1.71u w=1.12u l=0.13u
X427 a_16108_289# a_3171_311.t2 a_22590_1044# VSS.t762 sg13_lv_nmos ad=0.2516p pd=2.16u as=0.2516p ps=2.16u w=0.74u l=0.13u
X428 VDD.t1057 a_3747_3892.t2 a_27991_3853# VDD.t0 sg13_lv_pmos ad=0.3808p pd=2.92u as=0.3808p ps=2.92u w=1.12u l=0.13u
X429 a_11711_14024# a_11473_14024# a_11603_14024# VSS.t2020 sg13_lv_nmos ad=0.1406p pd=1.12u as=0.2516p ps=2.16u w=0.74u l=0.2u
X430 a_1721_6021# a_1256_5979# VDD.t488 VDD.t41 sg13_lv_pmos ad=0.1596p pd=1.22u as=0.2856p ps=2.36u w=0.84u l=0.13u
X431 VDD.t1195 a_3747_6737.t7 a_12791_6698# VDD.t41 sg13_lv_pmos ad=0.3808p pd=2.92u as=0.3808p ps=2.92u w=1.12u l=0.13u
X432 VSS.t72 a_4187_1764.t30 a_6391_1842# VSS.t2122 sg13_lv_nmos ad=0.2516p pd=2.16u as=0.1406p ps=1.12u w=0.74u l=0.6u
X433 VSS.t757 a_4187_1764.t120 a_12471_14024# VSS.t756 sg13_lv_nmos ad=0.2516p pd=2.16u as=0.1406p ps=1.12u w=0.74u l=0.6u
X434 a_16408_1044# a_15837_1842# VDD.t1165 VDD.t7 sg13_lv_pmos ad=0.2128p pd=1.5u as=0.3808p ps=2.92u w=1.12u l=0.13u
X435 VDD.t1056 a_3747_3892.t9 a_6711_3853# VDD.t0 sg13_lv_pmos ad=0.3808p pd=2.92u as=0.3808p ps=2.92u w=1.12u l=0.13u
X436 a_26151_14024# a_25913_14024# a_26043_14024# VSS.t1878 sg13_lv_nmos ad=0.1406p pd=1.12u as=0.2516p ps=2.16u w=0.74u l=0.2u
X437 VDD.t139 VSS.t897 VDD.t138 VDD.t50 sg13_lv_pmos ad=0.19p pd=1.38u as=0 ps=0 w=1u l=1u
X438 a_19550_1044# a_3747_1047.t4 a_21835_1044# VSS.t1613 sg13_lv_nmos ad=0.2516p pd=2.16u as=0.1406p ps=1.12u w=0.74u l=0.13u
X439 a_7673_4687# a_7477_4687# VSS.t442 VSS.t1442 sg13_lv_nmos ad=0.2516p pd=2.16u as=0.1406p ps=1.12u w=0.74u l=0.13u
X440 VDD.t230 VSS.t847 VDD.t102 VDD.t4 sg13_lv_pmos ad=0.19p pd=1.38u as=0 ps=0 w=1u l=1u
X441 a_18795_16071# a_18585_16071# VDD.t1186 VDD.t4 sg13_lv_pmos ad=0.2128p pd=1.5u as=0.252p ps=1.57u w=1.12u l=0.13u
X442 VSS.t633 a_2019_6737.t6 a_13444_6698# VSS.t2214 sg13_lv_nmos ad=0.2516p pd=2.16u as=0.2516p ps=2.16u w=0.74u l=0.13u
X443 a_11848_6734# a_11277_7532# VDD.t848 VDD.t41 sg13_lv_pmos ad=0.2128p pd=1.5u as=0.3808p ps=2.92u w=1.12u l=0.13u
X444 a_3171_311.t0 a_2873_331# VDD.t1369 VDD.t7 sg13_lv_pmos ad=0.2128p pd=1.5u as=0.1918p ps=1.5u w=1.12u l=0.13u
X445 VSS.t485 a_4187_1764.t11 a_20831_1842# VSS.t484 sg13_lv_nmos ad=0.2516p pd=2.16u as=0.1406p ps=1.12u w=0.74u l=0.6u
X446 a_14513_16869# a_14317_16869# VSS.t500 VSS.t1371 sg13_lv_nmos ad=0.2516p pd=2.16u as=0.1406p ps=1.12u w=0.74u l=0.13u
X447 a_13880_10808# a_13592_11113# a_13818_10808# VSS.t655 sg13_lv_nmos ad=0.1428p pd=1.52u as=37.8f ps=0.6u w=0.42u l=0.13u
X448 a_23111_8160# a_22873_7532# a_23003_7532# VDD.t275 sg13_lv_pmos ad=0.2128p pd=1.5u as=0.3808p ps=2.92u w=1.12u l=0.2u
X449 a_14235_16071# a_14025_16071# VDD.t554 VDD.t4 sg13_lv_pmos ad=0.2128p pd=1.5u as=0.252p ps=1.57u w=1.12u l=0.13u
X450 VDD.t169 VSS.t1036 VDD.t168 VDD.t0 sg13_lv_pmos ad=0.34p pd=2.68u as=0 ps=0 w=1u l=1u
X451 VDD.t867 a_1544_3134# a_2297_3176# VDD.t0 sg13_lv_pmos ad=0.1918p pd=1.5u as=0.1596p ps=1.22u w=0.84u l=0.13u
X452 a_26151_5315# a_25913_4687# a_26043_4687# VDD.t281 sg13_lv_pmos ad=0.2128p pd=1.5u as=0.3808p ps=2.92u w=1.12u l=0.2u
X453 a_3747_311.t0 a_3449_331# VDD.t1042 VDD.t7 sg13_lv_pmos ad=0.2128p pd=1.5u as=0.1918p ps=1.5u w=1.12u l=0.13u
X454 VDD.t520 a_17683_7532# a_18117_7532# VDD.t275 sg13_lv_pmos ad=0.2128p pd=1.5u as=0.3808p ps=2.92u w=1.12u l=0.13u
X455 a_7390_1044# a_9751_1008# a_9675_1044# VDD.t7 sg13_lv_pmos ad=0.3808p pd=2.92u as=0.2128p ps=1.5u w=1.12u l=0.13u
X456 a_16510_16071# a_2019_16074.t5 a_16408_16071# VSS.t590 sg13_lv_nmos ad=0.2516p pd=2.16u as=0.1406p ps=1.12u w=0.74u l=0.13u
X457 a_25528_16071# a_24957_16869# VDD.t890 VDD.t4 sg13_lv_pmos ad=0.2128p pd=1.5u as=0.3808p ps=2.92u w=1.12u l=0.13u
X458 a_10713_7532# a_10517_7532# VDD.t1468 VDD.t275 sg13_lv_pmos ad=0.3808p pd=2.92u as=0.2128p ps=1.5u w=1.12u l=0.13u
X459 VSS.t1173 a_19637_4687# a_20105_3889# VSS.t1172 sg13_lv_nmos ad=0.1665p pd=1.19u as=0.2516p ps=2.16u w=0.74u l=0.13u
X460 a_13470_13226# a_2019_13229.t6 a_13368_13226# VSS.t1265 sg13_lv_nmos ad=0.2516p pd=2.16u as=0.1406p ps=1.12u w=0.74u l=0.13u
X461 VSS.t1402 a_22677_1842# a_23145_1044# VSS.t1962 sg13_lv_nmos ad=0.1665p pd=1.19u as=0.2516p ps=2.16u w=0.74u l=0.13u
X462 VSS.t295 a_4187_1764.t55 a_11711_4687# VSS.t294 sg13_lv_nmos ad=0.2516p pd=2.16u as=0.1406p ps=1.12u w=0.74u l=0.6u
X463 a_13753_4687# a_13557_4687# VDD.t612 VDD.t281 sg13_lv_pmos ad=0.3808p pd=2.92u as=0.2128p ps=1.5u w=1.12u l=0.13u
X464 VDD.t979 a_19963_16869# a_20397_16869# VDD.t297 sg13_lv_pmos ad=0.2128p pd=1.5u as=0.3808p ps=2.92u w=1.12u l=0.13u
X465 a_4871_5315# a_4633_4687# a_4763_4687# VDD.t281 sg13_lv_pmos ad=0.2128p pd=1.5u as=0.3808p ps=2.92u w=1.12u l=0.2u
X466 a_26673_7532# a_26477_7532# VSS.t395 VSS.t519 sg13_lv_nmos ad=0.2516p pd=2.16u as=0.1406p ps=1.12u w=0.74u l=0.13u
X467 a_10191_1842# a_9953_1842# a_10083_1842# VSS.t1855 sg13_lv_nmos ad=0.1406p pd=1.12u as=0.2516p ps=2.16u w=0.74u l=0.2u
X468 VDD.t1283 a_1721_13577# a_2019_13229.t0 VDD.t50 sg13_lv_pmos ad=0.4256p pd=3u as=0.2128p ps=1.5u w=1.12u l=0.13u
X469 a_16108_12471# a_2019_12493.t2 a_16510_13226# VSS.t2228 sg13_lv_nmos ad=0.2516p pd=2.16u as=0.2516p ps=2.16u w=0.74u l=0.13u
X470 a_14751_2470# a_14513_1842# a_14643_1842# VDD.t399 sg13_lv_pmos ad=0.2128p pd=1.5u as=0.3808p ps=2.92u w=1.12u l=0.2u
X471 VSS.t909 VDD.t1669 VSS.t909 VSS.t912 sg13_lv_nmos ad=79.8f pd=0.8u as=0 ps=0 w=0.42u l=1u
X472 a_5731_289# a_8745_519# a_7390_1044# VDD.t7 sg13_lv_pmos ad=0.3808p pd=2.92u as=0.3808p ps=2.92u w=1.12u l=0.13u
X473 VSS.t1180 a_21483_4687# a_21917_4687# VSS.t2189 sg13_lv_nmos ad=0.1406p pd=1.12u as=0.2516p ps=2.16u w=0.74u l=0.13u
X474 VDD.t743 a_7803_7532# a_8237_7532# VDD.t275 sg13_lv_pmos ad=0.2128p pd=1.5u as=0.3808p ps=2.92u w=1.12u l=0.13u
X475 VDD.t119 VSS.t955 VDD.t156 VDD.t41 sg13_lv_pmos ad=0.34p pd=2.68u as=0 ps=0 w=1u l=1u
X476 VDD.t812 VDD.t813 VDD.t814 VDD.t399 sg13_lv_pmos ad=0.2128p pd=1.5u as=0 ps=0 w=1.12u l=0.13u
X477 VSS.t938 VDD.t1661 VSS.t937 VSS.t936 sg13_lv_nmos ad=0.1428p pd=1.52u as=0 ps=0 w=0.42u l=1u
X478 a_4248_6734# a_4157_7003# VSS.t126 VSS.t125 sg13_lv_nmos ad=0.1406p pd=1.12u as=0.2516p ps=2.16u w=0.74u l=0.13u
X479 VSS.t56 a_1721_4240# a_2019_3892.t1 VSS.t1215 sg13_lv_nmos ad=0.2812p pd=2.24u as=0.1406p ps=1.12u w=0.74u l=0.13u
X480 VDD.t1363 a_8563_14024# a_8997_14024# VDD.t301 sg13_lv_pmos ad=0.2128p pd=1.5u as=0.3808p ps=2.92u w=1.12u l=0.13u
X481 a_4111_2470# CHAN3_DELAY_IN a_4003_1842# VDD.t399 sg13_lv_pmos ad=0.2128p pd=1.5u as=0.3808p ps=2.92u w=1.12u l=0.2u
X482 VDD.t503 a_24523_4687# a_24957_4687# VDD.t281 sg13_lv_pmos ad=0.2128p pd=1.5u as=0.3808p ps=2.92u w=1.12u l=0.13u
X483 a_2019_12493.t1 a_1721_12513# VSS.t2091 VSS.t2296 sg13_lv_nmos ad=0.1406p pd=1.12u as=0.1331p ps=1.12u w=0.74u l=0.13u
X484 VSS.t264 a_4187_1764.t94 a_6391_7532# VSS.t263 sg13_lv_nmos ad=0.2516p pd=2.16u as=0.1406p ps=1.12u w=0.74u l=0.6u
X485 a_16510_3889# a_2595_3892.t5 a_17275_3889# VSS.t1382 sg13_lv_nmos ad=0.2516p pd=2.16u as=0.1406p ps=1.12u w=0.74u l=0.13u
X486 a_22590_16071# a_22564_16035# a_22488_16071# VDD.t4 sg13_lv_pmos ad=0.3808p pd=2.92u as=0.2128p ps=1.5u w=1.12u l=0.13u
X487 VSS.t251 a_2297_16422# a_2595_16074.t1 VSS.t1344 sg13_lv_nmos ad=0.2812p pd=2.24u as=0.1406p ps=1.12u w=0.74u l=0.13u
X488 a_3171_12493.t0 a_2873_12513# VDD.t1427 VDD.t50 sg13_lv_pmos ad=0.2128p pd=1.5u as=0.1918p ps=1.5u w=1.12u l=0.13u
X489 VSS.t1014 VDD.t1640 VSS.t1011 VSS.t1013 sg13_lv_nmos ad=79.8f pd=0.8u as=0 ps=0 w=0.42u l=1u
X490 a_16408_16071# a_15837_16869# VDD.t628 VDD.t4 sg13_lv_pmos ad=0.2128p pd=1.5u as=0.3808p ps=2.92u w=1.12u l=0.13u
X491 a_15511_16869# a_15273_16869# a_15403_16869# VSS.t2201 sg13_lv_nmos ad=0.1406p pd=1.12u as=0.2516p ps=2.16u w=0.74u l=0.2u
X492 a_19550_6734# a_3747_6737.t4 a_21835_6734# VSS.t1768 sg13_lv_nmos ad=0.2516p pd=2.16u as=0.1406p ps=1.12u w=0.74u l=0.13u
X493 a_7673_1842# a_7477_1842# VSS.t627 VSS.t1244 sg13_lv_nmos ad=0.2516p pd=2.16u as=0.1406p ps=1.12u w=0.74u l=0.13u
X494 VDD.t546 a_19637_7532# a_20105_6734# VDD.t41 sg13_lv_pmos ad=0.252p pd=1.57u as=0.3808p ps=2.92u w=1.12u l=0.13u
X495 VDD.t584 a_3171_1047.t5 a_18004_1008# VDD.t7 sg13_lv_pmos ad=0.3808p pd=2.92u as=0.3808p ps=2.92u w=1.12u l=0.13u
X496 VSS.t1515 a_3747_3892.t2 a_27991_3853# VSS.t1514 sg13_lv_nmos ad=0.2516p pd=2.16u as=0.2516p ps=2.16u w=0.74u l=0.13u
X497 VSS.t1820 CHAN1_MUX_SEL1 a_3543_13577# VSS.t2269 sg13_lv_nmos ad=0.1331p pd=1.12u as=0.1216p ps=1.02u w=0.64u l=0.13u
X498 VSS.t1280 a_4187_1764.t147 a_16271_16869# VSS.t1409 sg13_lv_nmos ad=0.2516p pd=2.16u as=0.1406p ps=1.12u w=0.74u l=0.6u
X499 a_26673_14024# a_26477_14024# VSS.t84 VSS.t1890 sg13_lv_nmos ad=0.2516p pd=2.16u as=0.1406p ps=1.12u w=0.74u l=0.13u
X500 VDD.t1065 a_2019_13229.t7 a_10404_13190# VDD.t50 sg13_lv_pmos ad=0.3808p pd=2.92u as=0.3808p ps=2.92u w=1.12u l=0.13u
X501 VDD.t1197 a_13123_1842# a_13557_1842# VDD.t399 sg13_lv_pmos ad=0.2128p pd=1.5u as=0.3808p ps=2.92u w=1.12u l=0.13u
X502 VSS.t163 a_4187_1764.t75 a_20831_7532# VSS.t162 sg13_lv_nmos ad=0.2516p pd=2.16u as=0.1406p ps=1.12u w=0.74u l=0.6u
X503 VDD.t1336 a_16851_15336# CHAN0_MUX_OUT VDD.t4 sg13_lv_pmos ad=0.7336p pd=3.55u as=0.2128p ps=1.5u w=1.12u l=0.13u
X504 VDD.t717 a_3747_311.t2 a_26985_519# VDD.t7 sg13_lv_pmos ad=0.3808p pd=2.92u as=0.3808p ps=2.92u w=1.12u l=0.13u
X505 VDD.t428 a_4187_2434# a_27671_5315# VDD.t281 sg13_lv_pmos ad=0.3808p pd=2.92u as=0.2128p ps=1.5u w=1.12u l=0.6u
X506 VSS.t889 VDD.t1675 VSS.t889 VSS.t892 sg13_lv_nmos ad=79.8f pd=0.8u as=0 ps=0 w=0.42u l=1u
X507 a_7390_3889# a_7364_3853# a_7288_3889# VDD.t0 sg13_lv_pmos ad=0.3808p pd=2.92u as=0.2128p ps=1.5u w=1.12u l=0.13u
X508 a_16510_16071# a_17351_16035# a_17275_16071# VDD.t4 sg13_lv_pmos ad=0.3808p pd=2.92u as=0.2128p ps=1.5u w=1.12u l=0.13u
X509 a_10430_1044# a_3747_1047.t7 a_12715_1044# VSS.t1610 sg13_lv_nmos ad=0.2516p pd=2.16u as=0.1406p ps=1.12u w=0.74u l=0.13u
X510 VSS.t798 a_3747_3892.t9 a_6711_3853# VSS.t1512 sg13_lv_nmos ad=0.2516p pd=2.16u as=0.2516p ps=2.16u w=0.74u l=0.13u
X511 a_25913_1842# a_25717_1842# VDD.t1292 VDD.t399 sg13_lv_pmos ad=0.3808p pd=2.92u as=0.2128p ps=1.5u w=1.12u l=0.13u
X512 VSS.t899 VDD.t1672 VSS.t899 VSS.t901 sg13_lv_nmos ad=0.1428p pd=1.52u as=0 ps=0 w=0.42u l=1u
X513 VSS.t2331 VSS.t2332 VSS.t2331 VSS.t2333 sg13_lv_nmos ad=0.1406p pd=1.12u as=0 ps=0 w=0.74u l=0.2u
X514 a_24875_1044# a_24665_1044# VSS.t671 VSS.t670 sg13_lv_nmos ad=0.1406p pd=1.12u as=0.1665p ps=1.19u w=0.74u l=0.13u
X515 a_14235_1044# a_14025_1044# VDD.t953 VDD.t7 sg13_lv_pmos ad=0.2128p pd=1.5u as=0.252p ps=1.57u w=1.12u l=0.13u
X516 a_25391_4687# a_25153_4687# a_25283_4687# VSS.t1733 sg13_lv_nmos ad=0.1406p pd=1.12u as=0.2516p ps=2.16u w=0.74u l=0.2u
X517 VSS.t411 a_22677_7532# a_23145_6734# VSS.t410 sg13_lv_nmos ad=0.1665p pd=1.19u as=0.2516p ps=2.16u w=0.74u l=0.13u
X518 VDD.t1220 a_19963_14024# a_20397_14024# VDD.t301 sg13_lv_pmos ad=0.2128p pd=1.5u as=0.3808p ps=2.92u w=1.12u l=0.13u
X519 VSS.t1548 a_4187_1764.t98 VSS.t1546 VSS.t1531 sg13_lv_nmos ad=1.33p pd=7.38u as=0 ps=0 w=7u l=7u
X520 VSS.t171 a_4187_1764.t23 a_11711_1842# VSS.t170 sg13_lv_nmos ad=0.2516p pd=2.16u as=0.1406p ps=1.12u w=0.74u l=0.6u
X521 a_10191_7532# a_9953_7532# a_10083_7532# VSS.t2260 sg13_lv_nmos ad=0.1406p pd=1.12u as=0.2516p ps=2.16u w=0.74u l=0.2u
X522 VDD.t852 a_1256_6734# a_2873_7085# VDD.t41 sg13_lv_pmos ad=0.1918p pd=1.5u as=0.1596p ps=1.22u w=0.84u l=0.13u
X523 VSS.t578 a_2595_1047.t3 a_23431_1008# VSS.t577 sg13_lv_nmos ad=0.2516p pd=2.16u as=0.2516p ps=2.16u w=0.74u l=0.13u
X524 VDD.t1075 a_3747_1047.t7 a_12791_1008# VDD.t7 sg13_lv_pmos ad=0.3808p pd=2.92u as=0.3808p ps=2.92u w=1.12u l=0.13u
X525 VDD.t274 a_12849_11557# a_13566_11018# VDD.t268 sg13_lv_pmos ad=0.1563p pd=1.22u as=0.147p ps=1.54u w=0.42u l=0.13u
X526 a_4350_13226# a_5191_13190# a_5115_13226# VDD.t50 sg13_lv_pmos ad=0.3808p pd=2.92u as=0.2128p ps=1.5u w=1.12u l=0.13u
X527 a_14751_8160# a_14513_7532# a_14643_7532# VDD.t275 sg13_lv_pmos ad=0.2128p pd=1.5u as=0.3808p ps=2.92u w=1.12u l=0.2u
X528 a_12993_4687# a_12797_4687# VSS.t271 VSS.t270 sg13_lv_nmos ad=0.2516p pd=2.16u as=0.1406p ps=1.12u w=0.74u l=0.13u
X529 VSS.t452 a_18443_16869# a_18877_16869# VSS.t1286 sg13_lv_nmos ad=0.1406p pd=1.12u as=0.2516p ps=2.16u w=0.74u l=0.13u
X530 a_2595_3892.t0 a_2297_4240# VDD.t289 VDD.t0 sg13_lv_pmos ad=0.2128p pd=1.5u as=0.1918p ps=1.5u w=1.12u l=0.13u
X531 VDD.t118 VSS.t938 VDD.t117 VDD.t41 sg13_lv_pmos ad=0.34p pd=2.68u as=0 ps=0 w=1u l=1u
X532 a_16510_6734# a_17351_6698# a_17275_6734# VDD.t41 sg13_lv_pmos ad=0.3808p pd=2.92u as=0.2128p ps=1.5u w=1.12u l=0.13u
X533 VSS.t546 a_21483_1842# a_21917_1842# VSS.t1956 sg13_lv_nmos ad=0.1406p pd=1.12u as=0.2516p ps=2.16u w=0.74u l=0.13u
X534 a_20315_16071# a_20105_16071# VSS.t1729 VSS.t1807 sg13_lv_nmos ad=0.1406p pd=1.12u as=0.1665p ps=1.19u w=0.74u l=0.13u
X535 VDD.t608 a_3171_15338.t3 a_11785_15546# VDD.t4 sg13_lv_pmos ad=0.3808p pd=2.92u as=0.3808p ps=2.92u w=1.12u l=0.13u
X536 VDD.t790 VDD.t791 VDD.t792 VDD.t275 sg13_lv_pmos ad=0.2128p pd=1.5u as=0 ps=0 w=1.12u l=0.13u
X537 VSS.t1325 a_13557_1842# a_14025_1044# VSS.t1801 sg13_lv_nmos ad=0.1665p pd=1.19u as=0.2516p ps=2.16u w=0.74u l=0.13u
X538 VDD.t37 VSS.t79 VDD.t1586 VDD.t0 sg13_lv_pmos ad=0.34p pd=2.68u as=0 ps=0 w=1u l=1u
X539 a_2595_15338.t0 a_2297_15358# VDD.t1259 VDD.t4 sg13_lv_pmos ad=0.2128p pd=1.5u as=0.1918p ps=1.5u w=1.12u l=0.13u
X540 a_2595_15338.t1 a_2297_15358# VSS.t1876 VSS.t389 sg13_lv_nmos ad=0.1406p pd=1.12u as=0.1331p ps=1.12u w=0.74u l=0.13u
X541 a_17928_13226# a_17357_14024# VSS.t1589 VSS.t2068 sg13_lv_nmos ad=0.1406p pd=1.12u as=0.2516p ps=2.16u w=0.74u l=0.13u
X542 a_4111_8160# REF_CLK a_4003_7532# VDD.t275 sg13_lv_pmos ad=0.2128p pd=1.5u as=0.3808p ps=2.92u w=1.12u l=0.2u
X543 a_11848_1044# a_11277_1842# VDD.t1111 VDD.t7 sg13_lv_pmos ad=0.2128p pd=1.5u as=0.3808p ps=2.92u w=1.12u l=0.13u
X544 VDD.t1123 a_5523_16869# a_5957_16869# VDD.t297 sg13_lv_pmos ad=0.2128p pd=1.5u as=0.3808p ps=2.92u w=1.12u l=0.13u
X545 VSS.t330 a_4187_1764.t52 a_13991_4687# VSS.t428 sg13_lv_nmos ad=0.2516p pd=2.16u as=0.1406p ps=1.12u w=0.74u l=0.6u
X546 a_16033_4687# a_15837_4687# VDD.t611 VDD.t281 sg13_lv_pmos ad=0.3808p pd=2.92u as=0.2128p ps=1.5u w=1.12u l=0.13u
X547 VDD.t1194 a_3747_6737.t2 a_27991_6698# VDD.t41 sg13_lv_pmos ad=0.3808p pd=2.92u as=0.3808p ps=2.92u w=1.12u l=0.13u
X548 a_7151_5315# a_6913_4687# a_7043_4687# VDD.t281 sg13_lv_pmos ad=0.2128p pd=1.5u as=0.3808p ps=2.92u w=1.12u l=0.2u
X549 a_1721_4240# a_1256_3889# VDD.t1515 VDD.t0 sg13_lv_pmos ad=0.1596p pd=1.22u as=0.2856p ps=2.36u w=0.84u l=0.13u
X550 VDD.t937 VSS.t1115 VDD.t936 VDD.t7 sg13_lv_pmos ad=0.19p pd=1.38u as=0 ps=0 w=1u l=1u
X551 a_27671_14024# a_27433_14024# a_27563_14024# VSS.t1895 sg13_lv_nmos ad=0.1406p pd=1.12u as=0.2516p ps=2.16u w=0.74u l=0.2u
X552 VDD.t1193 a_3747_6737.t9 a_6711_6698# VDD.t41 sg13_lv_pmos ad=0.3808p pd=2.92u as=0.3808p ps=2.92u w=1.12u l=0.13u
X553 VSS.t88 a_23763_4687# a_24197_4687# VSS.t1429 sg13_lv_nmos ad=0.1406p pd=1.12u as=0.2516p ps=2.16u w=0.74u l=0.13u
X554 a_7673_7532# a_7477_7532# VSS.t468 VSS.t2250 sg13_lv_nmos ad=0.2516p pd=2.16u as=0.1406p ps=1.12u w=0.74u l=0.13u
X555 a_25630_13226# a_25604_13190# a_25528_13226# VDD.t50 sg13_lv_pmos ad=0.3808p pd=2.92u as=0.2128p ps=1.5u w=1.12u l=0.13u
X556 VSS.t1001 VDD.t1644 VSS.t999 VSS.t1000 sg13_lv_nmos ad=79.8f pd=0.8u as=0 ps=0 w=0.42u l=1u
X557 a_19448_13226# a_18877_14024# VDD.t1419 VDD.t50 sg13_lv_pmos ad=0.2128p pd=1.5u as=0.3808p ps=2.92u w=1.12u l=0.13u
X558 VDD.t226 VSS.t927 VDD.t225 VDD.t50 sg13_lv_pmos ad=0.34p pd=2.68u as=0 ps=0 w=1u l=1u
X559 a_15755_16071# a_15545_16071# VDD.t457 VDD.t4 sg13_lv_pmos ad=0.2128p pd=1.5u as=0.252p ps=1.57u w=1.12u l=0.13u
X560 VDD.t998 a_13123_7532# a_13557_7532# VDD.t275 sg13_lv_pmos ad=0.2128p pd=1.5u as=0.3808p ps=2.92u w=1.12u l=0.13u
X561 a_11473_16869# a_11277_16869# VSS.t1224 VSS.t1223 sg13_lv_nmos ad=0.2516p pd=2.16u as=0.1406p ps=1.12u w=0.74u l=0.13u
X562 a_25913_7532# a_25717_7532# VDD.t823 VDD.t275 sg13_lv_pmos ad=0.3808p pd=2.92u as=0.2128p ps=1.5u w=1.12u l=0.13u
X563 a_10430_6734# a_3747_6737.t7 a_12715_6734# VSS.t1766 sg13_lv_nmos ad=0.2516p pd=2.16u as=0.1406p ps=1.12u w=0.74u l=0.13u
X564 a_13470_13226# a_3171_13229.t6 a_14888_13226# VSS.t1826 sg13_lv_nmos ad=0.2516p pd=2.16u as=0.1406p ps=1.12u w=0.74u l=0.13u
X565 VSS.t348 a_4187_1764.t35 a_26911_4687# VSS.t347 sg13_lv_nmos ad=0.2516p pd=2.16u as=0.1406p ps=1.12u w=0.74u l=0.6u
X566 VDD.t833 a_21483_16869# a_21917_16869# VDD.t297 sg13_lv_pmos ad=0.2128p pd=1.5u as=0.3808p ps=2.92u w=1.12u l=0.13u
X567 VDD.t115 VSS.t880 VDD.t113 VDD.t50 sg13_lv_pmos ad=0.19p pd=1.38u as=0 ps=0 w=1u l=1u
X568 a_24875_6734# a_24665_6734# VSS.t211 VSS.t677 sg13_lv_nmos ad=0.1406p pd=1.12u as=0.1665p ps=1.19u w=0.74u l=0.13u
X569 a_25391_1842# a_25153_1842# a_25283_1842# VSS.t1892 sg13_lv_nmos ad=0.1406p pd=1.12u as=0.2516p ps=2.16u w=0.74u l=0.2u
X570 a_13470_16071# a_2019_16074.t6 a_13368_16071# VSS.t1633 sg13_lv_nmos ad=0.2516p pd=2.16u as=0.1406p ps=1.12u w=0.74u l=0.13u
X571 VSS.t1538 a_4187_1764.t98 VSS.t1540 VSS.t1539 sg13_lv_nmos ad=1.33p pd=7.38u as=0 ps=0 w=7u l=7u
X572 a_6326_10280# a_5974_11413# a_6126_9506# VSS.t17 sg13_lv_nmos ad=0.38p pd=2.38u as=0.68p ps=4.68u w=2u l=1u
X573 VSS.t662 a_4187_1764.t87 a_11711_7532# VSS.t661 sg13_lv_nmos ad=0.2516p pd=2.16u as=0.1406p ps=1.12u w=0.74u l=0.6u
X574 VDD.t282 a_5523_4687# a_5957_4687# VDD.t281 sg13_lv_pmos ad=0.2128p pd=1.5u as=0.3808p ps=2.92u w=1.12u l=0.13u
X575 a_10430_13226# a_2019_13229.t7 a_10328_13226# VSS.t1565 sg13_lv_nmos ad=0.2516p pd=2.16u as=0.1406p ps=1.12u w=0.74u l=0.13u
X576 VSS.t4 a_12849_11557# a_13400_11995# VSS.t3 sg13_lv_nmos ad=0.1626p pd=1.415u as=60.89999f ps=0.71u w=0.42u l=0.13u
X577 VSS.t196 a_2595_6737.t3 a_23431_6698# VSS.t1663 sg13_lv_nmos ad=0.2516p pd=2.16u as=0.2516p ps=2.16u w=0.74u l=0.13u
X578 VDD.t1237 a_2019_3892.t4 a_19524_3853# VDD.t0 sg13_lv_pmos ad=0.3808p pd=2.92u as=0.3808p ps=2.92u w=1.12u l=0.13u
X579 a_12993_1842# a_12797_1842# VSS.t1573 VSS.t1666 sg13_lv_nmos ad=0.2516p pd=2.16u as=0.1406p ps=1.12u w=0.74u l=0.13u
X580 VDD.t100 VSS.t1001 VDD.t99 VDD.t0 sg13_lv_pmos ad=0.34p pd=2.68u as=0 ps=0 w=1u l=1u
X581 a_7390_3889# a_2019_3892.t8 a_7288_3889# VSS.t1850 sg13_lv_nmos ad=0.2516p pd=2.16u as=0.1406p ps=1.12u w=0.74u l=0.13u
X582 VSS.t313 a_21483_7532# a_21917_7532# VSS.t1257 sg13_lv_nmos ad=0.1406p pd=1.12u as=0.2516p ps=2.16u w=0.74u l=0.13u
X583 a_5731_12471# a_3747_12493.t3 a_13470_13226# VSS.t361 sg13_lv_nmos ad=0.2516p pd=2.16u as=0.2516p ps=2.16u w=0.74u l=0.13u
X584 VSS.t1418 a_13557_7532# a_14025_6734# VSS.t1417 sg13_lv_nmos ad=0.1665p pd=1.19u as=0.2516p ps=2.16u w=0.74u l=0.13u
X585 VDD.t939 VSS.t1115 VDD.t938 VDD.t7 sg13_lv_pmos ad=0.34p pd=2.68u as=0 ps=0 w=1u l=1u
X586 a_3543_3176# CHAN2_MUX_SEL2 a_3449_3176# VSS.t2196 sg13_lv_nmos ad=0.1216p pd=1.02u as=0.2176p ps=1.96u w=0.64u l=0.13u
X587 a_16108_5979# a_3171_6001.t2 a_22590_6734# VSS.t1786 sg13_lv_nmos ad=0.2516p pd=2.16u as=0.2516p ps=2.16u w=0.74u l=0.13u
X588 a_2873_15358# CHAN0_MUX_SEL3 VDD.t1488 VDD.t4 sg13_lv_pmos ad=0.1596p pd=1.22u as=0.2856p ps=2.36u w=0.84u l=0.13u
X589 a_16510_13226# a_16484_13190# a_16408_13226# VDD.t50 sg13_lv_pmos ad=0.3808p pd=2.92u as=0.2128p ps=1.5u w=1.12u l=0.13u
X590 CHAN3_DELAY_OUT_LAST a_27997_1842# VDD.t1339 VDD.t399 sg13_lv_pmos ad=0.3808p pd=2.92u as=0.2128p ps=1.5u w=1.12u l=0.13u
X591 VSS.t1644 a_4187_1764.t111 a_19311_14024# VSS.t1643 sg13_lv_nmos ad=0.2516p pd=2.16u as=0.1406p ps=1.12u w=0.74u l=0.6u
X592 VDD.t1176 a_19637_1842# a_20105_1044# VDD.t7 sg13_lv_pmos ad=0.252p pd=1.57u as=0.3808p ps=2.92u w=1.12u l=0.13u
X593 VSS.t860 VDD.t1685 VSS.t859 VSS.t858 sg13_lv_nmos ad=0.1428p pd=1.52u as=0 ps=0 w=0.42u l=1u
X594 a_19550_13226# a_2595_13229.t4 a_20315_13226# VSS.t1641 sg13_lv_nmos ad=0.2516p pd=2.16u as=0.1406p ps=1.12u w=0.74u l=0.13u
X595 VSS.t1502 a_5957_14024# a_6425_13226# VSS.t1987 sg13_lv_nmos ad=0.1665p pd=1.19u as=0.2516p ps=2.16u w=0.74u l=0.13u
X596 a_22590_1044# a_3171_1047.t3 a_24008_1044# VSS.t367 sg13_lv_nmos ad=0.2516p pd=2.16u as=0.1406p ps=1.12u w=0.74u l=0.13u
X597 a_15755_3889# a_15545_3889# VDD.t277 VDD.t0 sg13_lv_pmos ad=0.2128p pd=1.5u as=0.252p ps=1.57u w=1.12u l=0.13u
X598 VSS.t1103 VDD.t1613 VSS.t1103 VSS.t1102 sg13_lv_nmos ad=0.1428p pd=1.52u as=0 ps=0 w=0.42u l=1u
X599 VDD.t296 a_4187_2434# a_8671_5315# VDD.t281 sg13_lv_pmos ad=0.3808p pd=2.92u as=0.2128p ps=1.5u w=1.12u l=0.6u
X600 VDD.t1342 a_5523_14024# a_5957_14024# VDD.t301 sg13_lv_pmos ad=0.2128p pd=1.5u as=0.3808p ps=2.92u w=1.12u l=0.13u
X601 VDD.t1418 a_2297_12513# a_2595_12493.t0 VDD.t50 sg13_lv_pmos ad=0.4256p pd=3u as=0.2128p ps=1.5u w=1.12u l=0.13u
X602 a_12943_11557# a_12656_11554# a_12849_11557# VDD.t268 sg13_lv_pmos ad=0.2128p pd=1.5u as=0.3808p ps=2.92u w=1.12u l=0.13u
X603 VSS.t293 a_4187_1764.t20 a_13991_1842# VSS.t292 sg13_lv_nmos ad=0.2516p pd=2.16u as=0.1406p ps=1.12u w=0.74u l=0.6u
X604 VSS.t801 a_13121_11521# a_6854_11676# VDD.t293 sg13_lv_pmos ad=0.232p pd=2.08u as=0.136p ps=1.14u w=0.4u l=0.2u
X605 VDD.t962 a_1544_16071# a_2297_16422# VDD.t4 sg13_lv_pmos ad=0.1918p pd=1.5u as=0.1596p ps=1.22u w=0.84u l=0.13u
X606 a_6913_1842# a_6717_1842# VDD.t463 VDD.t399 sg13_lv_pmos ad=0.3808p pd=2.92u as=0.2128p ps=1.5u w=1.12u l=0.13u
X607 VDD.t990 a_2595_3892.t6 a_14311_3853# VDD.t0 sg13_lv_pmos ad=0.3808p pd=2.92u as=0.3808p ps=2.92u w=1.12u l=0.13u
X608 VDD.t434 a_4187_2434# a_18551_2470# VDD.t399 sg13_lv_pmos ad=0.3808p pd=2.92u as=0.2128p ps=1.5u w=1.12u l=0.6u
X609 VSS.t1054 VDD.t1628 VSS.t1051 VSS.t1053 sg13_lv_nmos ad=79.8f pd=0.8u as=0 ps=0 w=0.42u l=1u
X610 a_15273_4687# a_15077_4687# VSS.t676 VSS.t675 sg13_lv_nmos ad=0.2516p pd=2.16u as=0.1406p ps=1.12u w=0.74u l=0.13u
X611 a_17031_16869# a_16793_16869# a_16923_16869# VSS.t450 sg13_lv_nmos ad=0.1406p pd=1.12u as=0.2516p ps=2.16u w=0.74u l=0.2u
X612 a_6391_4687# a_6153_4687# a_6283_4687# VSS.t2267 sg13_lv_nmos ad=0.1406p pd=1.12u as=0.2516p ps=2.16u w=0.74u l=0.2u
X613 a_3171_15338.t0 a_2873_15358# VDD.t1257 VDD.t4 sg13_lv_pmos ad=0.2128p pd=1.5u as=0.1918p ps=1.5u w=1.12u l=0.13u
X614 a_3171_15338.t1 a_2873_15358# VSS.t1220 VSS.t258 sg13_lv_nmos ad=0.1406p pd=1.12u as=0.1331p ps=1.12u w=0.74u l=0.13u
X615 VSS.t580 a_23763_1842# a_24197_1842# VSS.t1923 sg13_lv_nmos ad=0.1406p pd=1.12u as=0.2516p ps=2.16u w=0.74u l=0.13u
X616 a_5115_3889# a_4905_3889# VDD.t696 VDD.t0 sg13_lv_pmos ad=0.2128p pd=1.5u as=0.252p ps=1.57u w=1.12u l=0.13u
X617 VDD.t771 VDD.t769 VDD.t770 VDD.t268 sg13_lv_pmos ad=0.38p pd=2.38u as=0 ps=0 w=2u l=1u
X618 VSS.t1079 VDD.t1620 VSS.t767 VSS.t1078 sg13_lv_nmos ad=0.1428p pd=1.52u as=0 ps=0 w=0.42u l=1u
X619 a_13368_16071# a_12797_16869# VDD.t973 VDD.t4 sg13_lv_pmos ad=0.2128p pd=1.5u as=0.3808p ps=2.92u w=1.12u l=0.13u
X620 a_12471_16869# a_12233_16869# a_12363_16869# VSS.t2278 sg13_lv_nmos ad=0.1406p pd=1.12u as=0.2516p ps=2.16u w=0.74u l=0.2u
X621 VSS.t624 a_4187_1764.t145 a_17791_16869# VSS.t623 sg13_lv_nmos ad=0.2516p pd=2.16u as=0.1406p ps=1.12u w=0.74u l=0.6u
X622 VDD.t631 a_1256_1044# a_2873_1395# VDD.t7 sg13_lv_pmos ad=0.1918p pd=1.5u as=0.1596p ps=1.22u w=0.84u l=0.13u
X623 VDD.t545 DLL_RESETN a_10206_11525# VDD.t268 sg13_lv_pmos ad=0.1563p pd=1.22u as=0.147p ps=1.54u w=0.42u l=0.13u
X624 VSS.t95 CHAN0_MUX_SEL1 a_3543_16422# VSS.t94 sg13_lv_nmos ad=0.1331p pd=1.12u as=0.1216p ps=1.02u w=0.64u l=0.13u
X625 VDD.t1370 a_2873_331# a_3171_311.t0 VDD.t7 sg13_lv_pmos ad=0.4256p pd=3u as=0.2128p ps=1.5u w=1.12u l=0.13u
X626 VSS.t791 a_15964_5979# a_16851_5999# VSS.t2307 sg13_lv_nmos ad=0.1371p pd=1.12u as=0.2176p ps=1.96u w=0.64u l=0.13u
X627 a_4111_17497# CHAN0_DELAY_IN a_4003_16869# VDD.t297 sg13_lv_pmos ad=0.2128p pd=1.5u as=0.3808p ps=2.92u w=1.12u l=0.2u
X628 VSS.t305 a_4187_1764.t151 a_13231_16869# VSS.t2230 sg13_lv_nmos ad=0.2516p pd=2.16u as=0.1406p ps=1.12u w=0.74u l=0.6u
X629 a_23633_14024# a_23437_14024# VSS.t1320 VSS.t1319 sg13_lv_nmos ad=0.2516p pd=2.16u as=0.1406p ps=1.12u w=0.74u l=0.13u
X630 VSS.t914 VDD.t1668 VSS.t589 VSS.t913 sg13_lv_nmos ad=0.1428p pd=1.52u as=0 ps=0 w=0.42u l=1u
X631 a_9712_9602# a_6854_11144# a_9444_9602# VSS.t2237 sg13_lv_nmos ad=0.38p pd=2.38u as=0.68p ps=4.68u w=2u l=1u
X632 a_3171_311.t1 a_2873_331# VSS.t2014 VSS.t2028 sg13_lv_nmos ad=0.1406p pd=1.12u as=0.1331p ps=1.12u w=0.74u l=0.13u
X633 a_16510_16071# a_18871_16035# a_18795_16071# VDD.t4 sg13_lv_pmos ad=0.3808p pd=2.92u as=0.2128p ps=1.5u w=1.12u l=0.13u
X634 a_25630_1044# a_3747_1047.t2 a_27915_1044# VSS.t1607 sg13_lv_nmos ad=0.2516p pd=2.16u as=0.1406p ps=1.12u w=0.74u l=0.13u
X635 a_16510_1044# a_17351_1008# a_17275_1044# VDD.t7 sg13_lv_pmos ad=0.3808p pd=2.92u as=0.2128p ps=1.5u w=1.12u l=0.13u
X636 VSS.t346 a_16923_14024# a_17357_14024# VSS.t2050 sg13_lv_nmos ad=0.1406p pd=1.12u as=0.2516p ps=2.16u w=0.74u l=0.13u
X637 a_7390_6734# a_7364_6698# a_7288_6734# VDD.t41 sg13_lv_pmos ad=0.3808p pd=2.92u as=0.2128p ps=1.5u w=1.12u l=0.13u
X638 VDD.t1366 a_3449_331# a_3747_311.t0 VDD.t7 sg13_lv_pmos ad=0.4256p pd=3u as=0.2128p ps=1.5u w=1.12u l=0.13u
X639 a_1256_16071# CHAN0_MUX_SEL0 VDD.t1480 VDD.t4 sg13_lv_pmos ad=0.3808p pd=2.92u as=0.3808p ps=2.92u w=1.12u l=0.13u
X640 VSS.t839 VDD.t1690 VSS.t839 VSS.t843 sg13_lv_nmos ad=79.8f pd=0.8u as=0 ps=0 w=0.42u l=1u
X641 VSS.t436 a_15403_4687# a_15837_4687# VSS.t475 sg13_lv_nmos ad=0.1406p pd=1.12u as=0.2516p ps=2.16u w=0.74u l=0.13u
X642 a_12471_5315# a_12233_4687# a_12363_4687# VDD.t281 sg13_lv_pmos ad=0.2128p pd=1.5u as=0.3808p ps=2.92u w=1.12u l=0.2u
X643 a_13470_16071# a_14311_16035# a_14235_16071# VDD.t4 sg13_lv_pmos ad=0.3808p pd=2.92u as=0.2128p ps=1.5u w=1.12u l=0.13u
X644 VDD.t1218 a_21483_14024# a_21917_14024# VDD.t301 sg13_lv_pmos ad=0.2128p pd=1.5u as=0.3808p ps=2.92u w=1.12u l=0.13u
X645 a_3747_311.t1 a_3449_331# VSS.t1490 VSS.t2024 sg13_lv_nmos ad=0.1406p pd=1.12u as=0.1331p ps=1.12u w=0.74u l=0.13u
X646 VSS.t750 a_4187_1764.t3 a_26911_1842# VSS.t749 sg13_lv_nmos ad=0.2516p pd=2.16u as=0.1406p ps=1.12u w=0.74u l=0.6u
X647 VSS.t2325 VSS.t2325 VSS.t2327 VSS.t2326 sg13_lv_nmos ad=0.1406p pd=1.12u as=0 ps=0 w=0.74u l=0.13u
X648 a_25391_7532# a_25153_7532# a_25283_7532# VSS.t328 sg13_lv_nmos ad=0.1406p pd=1.12u as=0.2516p ps=2.16u w=0.74u l=0.2u
X649 VDD.t1074 a_3747_1047.t2 a_27991_1008# VDD.t7 sg13_lv_pmos ad=0.3808p pd=2.92u as=0.3808p ps=2.92u w=1.12u l=0.13u
X650 VDD.t449 a_4187_2434# a_22351_2470# VDD.t399 sg13_lv_pmos ad=0.3808p pd=2.92u as=0.2128p ps=1.5u w=1.12u l=0.6u
X651 VSS.t889 VDD.t1675 VSS.t889 VSS.t891 sg13_lv_nmos ad=0.1428p pd=1.52u as=0 ps=0 w=0.42u l=1u
X652 VDD.t26 VSS.t1061 VDD.t25 VDD.t7 sg13_lv_pmos ad=0.19p pd=1.38u as=0 ps=0 w=1u l=1u
X653 VSS.t825 VDD.t1695 VSS.t827 VSS.t826 sg13_lv_nmos ad=79.8f pd=0.8u as=0 ps=0 w=0.42u l=1u
X654 VDD.t1066 a_3171_16074.t8 a_8884_16035# VDD.t4 sg13_lv_pmos ad=0.3808p pd=2.92u as=0.3808p ps=2.92u w=1.12u l=0.13u
X655 a_12993_7532# a_12797_7532# VSS.t621 VSS.t631 sg13_lv_nmos ad=0.2516p pd=2.16u as=0.1406p ps=1.12u w=0.74u l=0.13u
X656 VSS.t117 a_4763_4687# a_5197_4687# VSS.t2171 sg13_lv_nmos ad=0.1406p pd=1.12u as=0.2516p ps=2.16u w=0.74u l=0.13u
X657 VDD.t884 a_1721_6021# a_2019_6001.t0 VDD.t41 sg13_lv_pmos ad=0.4256p pd=3u as=0.2128p ps=1.5u w=1.12u l=0.13u
X658 VSS.t481 a_15403_16869# a_15837_16869# VSS.t1339 sg13_lv_nmos ad=0.1406p pd=1.12u as=0.2516p ps=2.16u w=0.74u l=0.13u
X659 VDD.t270 a_11491_11918# a_11748_11799# VDD.t268 sg13_lv_pmos ad=1.10612p pd=6.66u as=79.8f ps=0.8u w=0.42u l=0.13u
X660 VDD.t1072 a_3747_1047.t9 a_6711_1008# VDD.t7 sg13_lv_pmos ad=0.3808p pd=2.92u as=0.3808p ps=2.92u w=1.12u l=0.13u
X661 VDD.t270 a_10649_11568# a_10751_11568# VDD.t268 sg13_lv_pmos ad=1.10612p pd=6.66u as=0.3864p ps=2.93u w=1.12u l=0.13u
X662 a_2873_12513# CHAN1_MUX_SEL3 VDD.t485 VDD.t50 sg13_lv_pmos ad=0.1596p pd=1.22u as=0.2856p ps=2.36u w=0.84u l=0.13u
X663 REF_DELAY_OUT_LAST a_27997_7532# VDD.t1023 VDD.t275 sg13_lv_pmos ad=0.3808p pd=2.92u as=0.2128p ps=1.5u w=1.12u l=0.13u
X664 VDD.t642 a_7043_16869# a_7477_16869# VDD.t297 sg13_lv_pmos ad=0.2128p pd=1.5u as=0.3808p ps=2.92u w=1.12u l=0.13u
X665 a_17928_16071# a_17357_16869# VSS.t418 VSS.t492 sg13_lv_nmos ad=0.1406p pd=1.12u as=0.2516p ps=2.16u w=0.74u l=0.13u
X666 a_22590_6734# a_3171_6737.t3 a_24008_6734# VSS.t1332 sg13_lv_nmos ad=0.2516p pd=2.16u as=0.1406p ps=1.12u w=0.74u l=0.13u
X667 VSS.t113 a_2019_3892.t4 a_19524_3853# VSS.t1841 sg13_lv_nmos ad=0.2516p pd=2.16u as=0.2516p ps=2.16u w=0.74u l=0.13u
X668 VSS.t899 VDD.t1673 VSS.t899 VSS.t900 sg13_lv_nmos ad=79.8f pd=0.8u as=0 ps=0 w=0.42u l=1u
X669 a_12355_11557# a_12158_11557# VSS.t200 VSS.t199 sg13_lv_nmos ad=0.2516p pd=2.16u as=0.1406p ps=1.12u w=0.74u l=0.13u
X670 VSS.t552 a_4187_1764.t84 a_13991_7532# VSS.t551 sg13_lv_nmos ad=0.2516p pd=2.16u as=0.1406p ps=1.12u w=0.74u l=0.6u
X671 a_14513_14024# a_14317_14024# VSS.t744 VSS.t2299 sg13_lv_nmos ad=0.2516p pd=2.16u as=0.1406p ps=1.12u w=0.74u l=0.13u
X672 VSS.t849 VDD.t1688 VSS.t849 VSS.t851 sg13_lv_nmos ad=79.8f pd=0.8u as=0 ps=0 w=0.42u l=1u
X673 a_6913_7532# a_6717_7532# VDD.t638 VDD.t275 sg13_lv_pmos ad=0.3808p pd=2.92u as=0.2128p ps=1.5u w=1.12u l=0.13u
X674 VDD.t377 a_4187_2434# a_18551_8160# VDD.t275 sg13_lv_pmos ad=0.3808p pd=2.92u as=0.2128p ps=1.5u w=1.12u l=0.6u
X675 VSS.t262 a_4187_1764.t60 a_7911_4687# VSS.t261 sg13_lv_nmos ad=0.2516p pd=2.16u as=0.1406p ps=1.12u w=0.74u l=0.6u
X676 VDD.t821 a_10843_4687# a_11277_4687# VDD.t281 sg13_lv_pmos ad=0.2128p pd=1.5u as=0.3808p ps=2.92u w=1.12u l=0.13u
X677 a_9953_4687# a_9757_4687# VDD.t559 VDD.t281 sg13_lv_pmos ad=0.3808p pd=2.92u as=0.2128p ps=1.5u w=1.12u l=0.13u
X678 a_20315_13226# a_20105_13226# VDD.t955 VDD.t50 sg13_lv_pmos ad=0.2128p pd=1.5u as=0.252p ps=1.57u w=1.12u l=0.13u
X679 a_15273_1842# a_15077_1842# VSS.t1571 VSS.t1695 sg13_lv_nmos ad=0.2516p pd=2.16u as=0.1406p ps=1.12u w=0.74u l=0.13u
X680 VSS.t44 a_23763_7532# a_24197_7532# VSS.t43 sg13_lv_nmos ad=0.1406p pd=1.12u as=0.2516p ps=2.16u w=0.74u l=0.13u
X681 a_6391_1842# a_6153_1842# a_6283_1842# VSS.t249 sg13_lv_nmos ad=0.1406p pd=1.12u as=0.2516p ps=2.16u w=0.74u l=0.2u
X682 a_19833_1842# a_19637_1842# VDD.t1268 VDD.t399 sg13_lv_pmos ad=0.3808p pd=2.92u as=0.2128p ps=1.5u w=1.12u l=0.13u
X683 a_15755_3889# a_15545_3889# VSS.t29 VSS.t28 sg13_lv_nmos ad=0.1406p pd=1.12u as=0.1665p ps=1.19u w=0.74u l=0.13u
X684 VDD.t1152 a_21157_4687# a_21625_3889# VDD.t0 sg13_lv_pmos ad=0.252p pd=1.57u as=0.3808p ps=2.92u w=1.12u l=0.13u
X685 VDD.t892 a_1256_16071# a_2873_16422# VDD.t4 sg13_lv_pmos ad=0.1918p pd=1.5u as=0.1596p ps=1.22u w=0.84u l=0.13u
X686 a_12993_16869# a_12797_16869# VSS.t664 VSS.t1370 sg13_lv_nmos ad=0.2516p pd=2.16u as=0.1406p ps=1.12u w=0.74u l=0.13u
X687 a_16108_289# a_23945_519# a_22590_1044# VDD.t7 sg13_lv_pmos ad=0.3808p pd=2.92u as=0.3808p ps=2.92u w=1.12u l=0.13u
X688 VSS.t332 a_2595_3892.t6 a_14311_3853# VSS.t1395 sg13_lv_nmos ad=0.2516p pd=2.16u as=0.2516p ps=2.16u w=0.74u l=0.13u
X689 a_4111_14652# CHAN1_DELAY_IN a_4003_14024# VDD.t301 sg13_lv_pmos ad=0.2128p pd=1.5u as=0.3808p ps=2.92u w=1.12u l=0.2u
X690 a_25630_6734# a_3747_6737.t2 a_27915_6734# VSS.t1763 sg13_lv_nmos ad=0.2516p pd=2.16u as=0.1406p ps=1.12u w=0.74u l=0.13u
X691 a_24631_2470# a_24393_1842# a_24523_1842# VDD.t399 sg13_lv_pmos ad=0.2128p pd=1.5u as=0.3808p ps=2.92u w=1.12u l=0.2u
X692 a_3747_13229.t1 a_3449_13577# VSS.t1820 VSS.t1819 sg13_lv_nmos ad=0.1406p pd=1.12u as=0.1331p ps=1.12u w=0.74u l=0.13u
X693 a_9193_1842# a_8997_1842# VDD.t898 VDD.t399 sg13_lv_pmos ad=0.3808p pd=2.92u as=0.2128p ps=1.5u w=1.12u l=0.13u
X694 a_5115_3889# a_4905_3889# VSS.t681 VSS.t680 sg13_lv_nmos ad=0.1406p pd=1.12u as=0.1665p ps=1.19u w=0.74u l=0.13u
X695 a_13470_16071# a_3171_16074.t6 a_14888_16071# VSS.t2150 sg13_lv_nmos ad=0.2516p pd=2.16u as=0.1406p ps=1.12u w=0.74u l=0.13u
X696 VSS.t907 VDD.t1671 VSS.t905 VSS.t906 sg13_lv_nmos ad=79.8f pd=0.8u as=0 ps=0 w=0.42u l=1u
X697 VSS.t266 a_15403_1842# a_15837_1842# VSS.t1697 sg13_lv_nmos ad=0.1406p pd=1.12u as=0.2516p ps=2.16u w=0.74u l=0.13u
X698 VSS.t215 a_4187_1764.t67 a_26911_7532# VSS.t2011 sg13_lv_nmos ad=0.2516p pd=2.16u as=0.1406p ps=1.12u w=0.74u l=0.6u
X699 a_8155_1044# a_7945_1044# VSS.t461 VSS.t460 sg13_lv_nmos ad=0.1406p pd=1.12u as=0.1665p ps=1.19u w=0.74u l=0.13u
X700 VSS.t1003 VDD.t1642 VSS.t1003 VSS.t1005 sg13_lv_nmos ad=0.1428p pd=1.52u as=0 ps=0 w=0.42u l=1u
X701 a_10430_13226# a_3171_13229.t7 a_11848_13226# VSS.t236 sg13_lv_nmos ad=0.2516p pd=2.16u as=0.1406p ps=1.12u w=0.74u l=0.13u
X702 VDD.t367 a_4187_2434# a_22351_8160# VDD.t275 sg13_lv_pmos ad=0.3808p pd=2.92u as=0.2128p ps=1.5u w=1.12u l=0.6u
X703 a_27433_16869# a_27237_16869# VSS.t66 VSS.t65 sg13_lv_nmos ad=0.2516p pd=2.16u as=0.1406p ps=1.12u w=0.74u l=0.13u
X704 a_10430_16071# a_2019_16074.t7 a_10328_16071# VSS.t1478 sg13_lv_nmos ad=0.2516p pd=2.16u as=0.1406p ps=1.12u w=0.74u l=0.13u
X705 a_11711_4687# a_11473_4687# a_11603_4687# VSS.t799 sg13_lv_nmos ad=0.1406p pd=1.12u as=0.2516p ps=2.16u w=0.74u l=0.2u
X706 VDD.t715 a_2019_6737.t4 a_19524_6698# VDD.t41 sg13_lv_pmos ad=0.3808p pd=2.92u as=0.3808p ps=2.92u w=1.12u l=0.13u
X707 a_23633_1842# a_23437_1842# VDD.t1262 VDD.t399 sg13_lv_pmos ad=0.3808p pd=2.92u as=0.2128p ps=1.5u w=1.12u l=0.13u
X708 VDD.t1235 a_2019_3892.t9 a_4324_3853# VDD.t0 sg13_lv_pmos ad=0.3808p pd=2.92u as=0.3808p ps=2.92u w=1.12u l=0.13u
X709 VSS.t1972 a_15964_15316# a_16851_15336# VSS.t1971 sg13_lv_nmos ad=0.1371p pd=1.12u as=0.2176p ps=1.96u w=0.64u l=0.13u
X710 a_2595_13229.t0 a_2297_13577# VDD.t590 VDD.t50 sg13_lv_pmos ad=0.2128p pd=1.5u as=0.1918p ps=1.5u w=1.12u l=0.13u
X711 a_27048_1044# a_26477_1842# VSS.t1347 VSS.t1911 sg13_lv_nmos ad=0.1406p pd=1.12u as=0.2516p ps=2.16u w=0.74u l=0.13u
X712 VSS.t248 a_4763_1842# a_5197_1842# VSS.t247 sg13_lv_nmos ad=0.1406p pd=1.12u as=0.2516p ps=2.16u w=0.74u l=0.13u
X713 a_16510_3889# a_18871_3853# a_18795_3889# VDD.t0 sg13_lv_pmos ad=0.3808p pd=2.92u as=0.2128p ps=1.5u w=1.12u l=0.13u
X714 VSS.t1144 a_1721_3176# a_2019_3156.t1 VSS.t1145 sg13_lv_nmos ad=0.2812p pd=2.24u as=0.1406p ps=1.12u w=0.74u l=0.13u
X715 a_15511_14024# a_15273_14024# a_15403_14024# VSS.t2292 sg13_lv_nmos ad=0.1406p pd=1.12u as=0.2516p ps=2.16u w=0.74u l=0.2u
X716 VDD.t1121 a_9323_1842# a_9757_1842# VDD.t399 sg13_lv_pmos ad=0.2128p pd=1.5u as=0.3808p ps=2.92u w=1.12u l=0.13u
X717 a_3543_6021# REF_MUX_SEL2 a_3449_6021# VSS.t785 sg13_lv_nmos ad=0.1216p pd=1.02u as=0.2176p ps=1.96u w=0.64u l=0.13u
X718 a_2019_16074.t0 a_1721_16422# VDD.t536 VDD.t4 sg13_lv_pmos ad=0.2128p pd=1.5u as=0.1918p ps=1.5u w=1.12u l=0.13u
X719 VSS.t977 a_2595_6001.t2 a_20905_6209# VSS.t1939 sg13_lv_nmos ad=0.2516p pd=2.16u as=0.2516p ps=2.16u w=0.74u l=0.13u
X720 a_19550_16071# a_2595_16074.t4 a_20315_16071# VSS.t1497 sg13_lv_nmos ad=0.2516p pd=2.16u as=0.1406p ps=1.12u w=0.74u l=0.13u
X721 VDD.t1330 a_7043_14024# a_7477_14024# VDD.t301 sg13_lv_pmos ad=0.2128p pd=1.5u as=0.3808p ps=2.92u w=1.12u l=0.13u
X722 a_13470_13226# a_13444_13190# a_13368_13226# VDD.t50 sg13_lv_pmos ad=0.3808p pd=2.92u as=0.2128p ps=1.5u w=1.12u l=0.13u
X723 a_5768_1044# a_5197_1842# VSS.t150 VSS.t540 sg13_lv_nmos ad=0.1406p pd=1.12u as=0.2516p ps=2.16u w=0.74u l=0.13u
X724 VSS.t254 a_5957_16869# a_6425_16071# VSS.t1689 sg13_lv_nmos ad=0.1665p pd=1.19u as=0.2516p ps=2.16u w=0.74u l=0.13u
X725 VSS.t1624 a_4187_1764.t115 a_16271_14024# VSS.t1623 sg13_lv_nmos ad=0.2516p pd=2.16u as=0.1406p ps=1.12u w=0.74u l=0.6u
X726 a_15755_6734# a_15545_6734# VDD.t1030 VDD.t41 sg13_lv_pmos ad=0.2128p pd=1.5u as=0.252p ps=1.57u w=1.12u l=0.13u
X727 VDD.t1260 a_2297_15358# a_2595_15338.t0 VDD.t4 sg13_lv_pmos ad=0.4256p pd=3u as=0.2128p ps=1.5u w=1.12u l=0.13u
X728 VSS.t1876 a_2297_15358# a_2595_15338.t1 VSS.t390 sg13_lv_nmos ad=0.2812p pd=2.24u as=0.1406p ps=1.12u w=0.74u l=0.13u
X729 VDD.t1105 a_2595_6737.t6 a_14311_6698# VDD.t41 sg13_lv_pmos ad=0.3808p pd=2.92u as=0.3808p ps=2.92u w=1.12u l=0.13u
X730 a_7390_1044# a_7364_1008# a_7288_1044# VDD.t7 sg13_lv_pmos ad=0.3808p pd=2.92u as=0.2128p ps=1.5u w=1.12u l=0.13u
X731 VDD.t925 a_16597_16869# a_17065_16071# VDD.t4 sg13_lv_pmos ad=0.252p pd=1.57u as=0.3808p ps=2.92u w=1.12u l=0.13u
X732 a_15273_7532# a_15077_7532# VSS.t732 VSS.t2241 sg13_lv_nmos ad=0.2516p pd=2.16u as=0.1406p ps=1.12u w=0.74u l=0.13u
X733 VSS.t75 a_4187_1764.t28 a_7911_1842# VSS.t1146 sg13_lv_nmos ad=0.2516p pd=2.16u as=0.1406p ps=1.12u w=0.74u l=0.6u
X734 a_14888_16071# a_14317_16869# VDD.t976 VDD.t4 sg13_lv_pmos ad=0.2128p pd=1.5u as=0.3808p ps=2.92u w=1.12u l=0.13u
X735 a_13306_11995# a_12355_11557# VDD.t1198 VDD.t268 sg13_lv_pmos ad=79.8f pd=0.8u as=0.1428p ps=1.52u w=0.42u l=0.13u
X736 a_6391_7532# a_6153_7532# a_6283_7532# VSS.t2133 sg13_lv_nmos ad=0.1406p pd=1.12u as=0.2516p ps=2.16u w=0.74u l=0.2u
X737 a_5115_6734# a_4905_6734# VDD.t825 VDD.t41 sg13_lv_pmos ad=0.2128p pd=1.5u as=0.252p ps=1.57u w=1.12u l=0.13u
X738 a_13991_16869# a_13753_16869# a_13883_16869# VSS.t1778 sg13_lv_nmos ad=0.1406p pd=1.12u as=0.2516p ps=2.16u w=0.74u l=0.2u
X739 VSS.t2342 VSS.t2344 VSS.t2346 VSS.t2345 sg13_lv_nmos ad=0.1406p pd=1.12u as=0 ps=0 w=0.74u l=0.2u
X740 a_19833_7532# a_19637_7532# VDD.t822 VDD.t275 sg13_lv_pmos ad=0.3808p pd=2.92u as=0.2128p ps=1.5u w=1.12u l=0.13u
X741 a_18313_16869# a_18117_16869# VSS.t624 VSS.t1749 sg13_lv_nmos ad=0.2516p pd=2.16u as=0.1406p ps=1.12u w=0.74u l=0.13u
X742 VSS.t456 a_10083_4687# a_10517_4687# VSS.t1696 sg13_lv_nmos ad=0.1406p pd=1.12u as=0.2516p ps=2.16u w=0.74u l=0.13u
X743 a_10328_16071# a_9757_16869# VDD.t922 VDD.t4 sg13_lv_pmos ad=0.2128p pd=1.5u as=0.3808p ps=2.92u w=1.12u l=0.13u
X744 a_5631_17497# a_5393_16869# a_5523_16869# VDD.t297 sg13_lv_pmos ad=0.2128p pd=1.5u as=0.3808p ps=2.92u w=1.12u l=0.2u
X745 VSS.t64 a_4187_1764.t149 a_14751_16869# VSS.t498 sg13_lv_nmos ad=0.2516p pd=2.16u as=0.1406p ps=1.12u w=0.74u l=0.6u
X746 a_19833_16869# a_19637_16869# VDD.t1167 VDD.t297 sg13_lv_pmos ad=0.3808p pd=2.92u as=0.2128p ps=1.5u w=1.12u l=0.13u
X747 VSS.t1646 a_18443_14024# a_18877_14024# VSS.t2097 sg13_lv_nmos ad=0.1406p pd=1.12u as=0.2516p ps=2.16u w=0.74u l=0.13u
X748 a_24631_8160# a_24393_7532# a_24523_7532# VDD.t275 sg13_lv_pmos ad=0.2128p pd=1.5u as=0.3808p ps=2.92u w=1.12u l=0.2u
X749 VDD.t305 a_4187_2434# a_6391_17497# VDD.t297 sg13_lv_pmos ad=0.3808p pd=2.92u as=0.2128p ps=1.5u w=1.12u l=0.6u
X750 VDD.t564 a_23763_16869# a_24197_16869# VDD.t297 sg13_lv_pmos ad=0.2128p pd=1.5u as=0.3808p ps=2.92u w=1.12u l=0.13u
X751 a_9193_7532# a_8997_7532# VDD.t549 VDD.t275 sg13_lv_pmos ad=0.3808p pd=2.92u as=0.2128p ps=1.5u w=1.12u l=0.13u
X752 a_27671_5315# a_27433_4687# a_27563_4687# VDD.t281 sg13_lv_pmos ad=0.2128p pd=1.5u as=0.3808p ps=2.92u w=1.12u l=0.2u
X753 a_13470_16071# a_15831_16035# a_15755_16071# VDD.t4 sg13_lv_pmos ad=0.3808p pd=2.92u as=0.2128p ps=1.5u w=1.12u l=0.13u
X754 VSS.t474 VDD.t1683 VSS.t865 VSS.t864 sg13_lv_nmos ad=0.1428p pd=1.52u as=0 ps=0 w=0.42u l=1u
X755 VDD.t72 VSS.t907 VDD.t71 VDD.t50 sg13_lv_pmos ad=0.34p pd=2.68u as=0 ps=0 w=1u l=1u
X756 VSS.t221 a_15403_7532# a_15837_7532# VSS.t220 sg13_lv_nmos ad=0.1406p pd=1.12u as=0.2516p ps=2.16u w=0.74u l=0.13u
X757 a_8155_6734# a_7945_6734# VSS.t311 VSS.t310 sg13_lv_nmos ad=0.1406p pd=1.12u as=0.1665p ps=1.19u w=0.74u l=0.13u
X758 VDD.t1041 VSS.t1085 VDD.t1039 VDD.t7 sg13_lv_pmos ad=0.19p pd=1.38u as=0 ps=0 w=1u l=1u
X759 VSS.t1703 a_21157_4687# a_21625_3889# VSS.t2118 sg13_lv_nmos ad=0.1665p pd=1.19u as=0.2516p ps=2.16u w=0.74u l=0.13u
X760 VSS.t949 VDD.t1658 VSS.t948 VSS.t947 sg13_lv_nmos ad=0.1428p pd=1.52u as=0 ps=0 w=0.42u l=1u
X761 VSS.t671 a_24197_1842# a_24665_1044# VSS.t1964 sg13_lv_nmos ad=0.1665p pd=1.19u as=0.2516p ps=2.16u w=0.74u l=0.13u
X762 VSS.t9 a_4187_1764.t98 VSS.t1526 VSS.t1525 sg13_lv_nmos ad=2.38p pd=14.68u as=0 ps=0 w=7u l=7u
X763 a_11711_1842# a_11473_1842# a_11603_1842# VSS.t1723 sg13_lv_nmos ad=0.1406p pd=1.12u as=0.2516p ps=2.16u w=0.74u l=0.2u
X764 a_23633_7532# a_23437_7532# VDD.t509 VDD.t275 sg13_lv_pmos ad=0.3808p pd=2.92u as=0.2128p ps=1.5u w=1.12u l=0.13u
X765 a_16510_1044# a_3171_1047.t5 a_17928_1044# VSS.t373 sg13_lv_nmos ad=0.2516p pd=2.16u as=0.1406p ps=1.12u w=0.74u l=0.13u
X766 VSS.t185 a_4763_7532# a_5197_7532# VSS.t1426 sg13_lv_nmos ad=0.1406p pd=1.12u as=0.2516p ps=2.16u w=0.74u l=0.13u
X767 a_27048_6734# a_26477_7532# VSS.t518 VSS.t517 sg13_lv_nmos ad=0.1406p pd=1.12u as=0.2516p ps=2.16u w=0.74u l=0.13u
X768 VSS.t1075 VDD.t1622 VSS.t1073 VSS.t1074 sg13_lv_nmos ad=79.8f pd=0.8u as=0 ps=0 w=0.42u l=1u
X769 VSS.t183 a_4187_1764.t38 a_24631_4687# VSS.t628 sg13_lv_nmos ad=0.2516p pd=2.16u as=0.1406p ps=1.12u w=0.74u l=0.6u
X770 VSS.t814 VDD.t1698 VSS.t817 VSS.t816 sg13_lv_nmos ad=79.8f pd=0.8u as=0 ps=0 w=0.42u l=1u
X771 VSS.t1034 VDD.t1634 VSS.t1031 VSS.t1033 sg13_lv_nmos ad=79.8f pd=0.8u as=0 ps=0 w=0.42u l=1u
X772 VDD.t474 a_9323_7532# a_9757_7532# VDD.t275 sg13_lv_pmos ad=0.2128p pd=1.5u as=0.3808p ps=2.92u w=1.12u l=0.13u
X773 VSS.t1876 a_1544_15316# a_2391_15358# VSS.t423 sg13_lv_nmos ad=0.1331p pd=1.12u as=0.1216p ps=1.02u w=0.64u l=0.13u
X774 VDD.t419 a_4187_2434# a_16271_5315# VDD.t281 sg13_lv_pmos ad=0.3808p pd=2.92u as=0.2128p ps=1.5u w=1.12u l=0.6u
X775 a_5768_6734# a_5197_7532# VSS.t187 VSS.t186 sg13_lv_nmos ad=0.1406p pd=1.12u as=0.2516p ps=2.16u w=0.74u l=0.13u
X776 a_14513_1842# a_14317_1842# VDD.t1159 VDD.t399 sg13_lv_pmos ad=0.3808p pd=2.92u as=0.2128p ps=1.5u w=1.12u l=0.13u
X777 VDD.t1015 a_4003_16869# a_4437_16869# VDD.t297 sg13_lv_pmos ad=0.2128p pd=1.5u as=0.3808p ps=2.92u w=1.12u l=0.13u
X778 a_6854_11676# a_6326_10280# VDD.t1140 VDD.t268 sg13_lv_pmos ad=0.38p pd=2.38u as=0.38p ps=2.38u w=2u l=1u
X779 a_5631_2470# a_5393_1842# a_5523_1842# VDD.t399 sg13_lv_pmos ad=0.2128p pd=1.5u as=0.3808p ps=2.92u w=1.12u l=0.2u
X780 a_3171_13229.t0 a_2873_13577# VDD.t541 VDD.t50 sg13_lv_pmos ad=0.2128p pd=1.5u as=0.1918p ps=1.5u w=1.12u l=0.13u
X781 VDD.t228 VSS.t927 VDD.t226 VDD.t50 sg13_lv_pmos ad=0.19p pd=1.38u as=0 ps=0 w=1u l=1u
X782 VDD.t529 a_1721_7085# a_2019_6737.t0 VDD.t41 sg13_lv_pmos ad=0.4256p pd=3u as=0.2128p ps=1.5u w=1.12u l=0.13u
X783 VSS.t1450 a_2019_3892.t9 a_4324_3853# VSS.t1837 sg13_lv_nmos ad=0.2516p pd=2.16u as=0.2516p ps=2.16u w=0.74u l=0.13u
X784 a_19311_16869# a_19073_16869# a_19203_16869# VSS.t1496 sg13_lv_nmos ad=0.1406p pd=1.12u as=0.2516p ps=2.16u w=0.74u l=0.2u
X785 VDD.t521 a_26043_4687# a_26477_4687# VDD.t281 sg13_lv_pmos ad=0.2128p pd=1.5u as=0.3808p ps=2.92u w=1.12u l=0.13u
X786 a_11473_14024# a_11277_14024# VSS.t1650 VSS.t2027 sg13_lv_nmos ad=0.2516p pd=2.16u as=0.1406p ps=1.12u w=0.74u l=0.13u
X787 VSS.t1542 a_4187_1764.t98 VSS.t1541 VSS.t1525 sg13_lv_nmos ad=2.38p pd=14.68u as=0 ps=0 w=7u l=7u
X788 VSS.t812 a_4187_1764.t92 a_7911_7532# VSS.t2317 sg13_lv_nmos ad=0.2516p pd=2.16u as=0.1406p ps=1.12u w=0.74u l=0.6u
X789 a_16510_3889# a_3747_3892.t5 a_18795_3889# VSS.t1848 sg13_lv_nmos ad=0.2516p pd=2.16u as=0.1406p ps=1.12u w=0.74u l=0.13u
X790 a_10430_3889# a_10404_3853# a_10328_3889# VDD.t0 sg13_lv_pmos ad=0.3808p pd=2.92u as=0.2128p ps=1.5u w=1.12u l=0.13u
X791 VSS.t976 VDD.t1650 VSS.t979 VSS.t978 sg13_lv_nmos ad=79.8f pd=0.8u as=0 ps=0 w=0.42u l=1u
X792 VSS.t384 a_3171_1047.t4 a_21044_1008# VSS.t383 sg13_lv_nmos ad=0.2516p pd=2.16u as=0.2516p ps=2.16u w=0.74u l=0.13u
X793 VSS.t291 a_10083_1842# a_10517_1842# VSS.t1781 sg13_lv_nmos ad=0.1406p pd=1.12u as=0.2516p ps=2.16u w=0.74u l=0.13u
X794 a_3747_3156.t0 a_3449_3176# VDD.t278 VDD.t0 sg13_lv_pmos ad=0.2128p pd=1.5u as=0.1918p ps=1.5u w=1.12u l=0.13u
X795 a_17928_13226# a_17357_14024# VDD.t1400 VDD.t50 sg13_lv_pmos ad=0.2128p pd=1.5u as=0.3808p ps=2.92u w=1.12u l=0.13u
X796 VDD.t619 a_21157_7532# a_21625_6734# VDD.t41 sg13_lv_pmos ad=0.252p pd=1.57u as=0.3808p ps=2.92u w=1.12u l=0.13u
X797 a_4633_1842# a_4437_1842# VDD.t869 VDD.t399 sg13_lv_pmos ad=0.3808p pd=2.92u as=0.2128p ps=1.5u w=1.12u l=0.13u
X798 VDD.t495 a_2019_1047.t4 a_19524_1008# VDD.t7 sg13_lv_pmos ad=0.3808p pd=2.92u as=0.3808p ps=2.92u w=1.12u l=0.13u
X799 a_5631_14652# a_5393_14024# a_5523_14024# VDD.t301 sg13_lv_pmos ad=0.2128p pd=1.5u as=0.3808p ps=2.92u w=1.12u l=0.2u
X800 VSS.t1505 a_3747_12493.t2 a_26985_12701# VSS.t1504 sg13_lv_nmos ad=0.2516p pd=2.16u as=0.2516p ps=2.16u w=0.74u l=0.13u
X801 a_6854_11676# a_15304_10295# a_4187_1764.t0 VDD.t293 sg13_lv_pmos ad=0.136p pd=1.14u as=0.158p ps=1.245u w=0.4u l=0.2u
X802 a_19833_14024# a_19637_14024# VDD.t1411 VDD.t301 sg13_lv_pmos ad=0.3808p pd=2.92u as=0.2128p ps=1.5u w=1.12u l=0.13u
X803 VDD.t422 a_4187_2434# a_20071_5315# VDD.t281 sg13_lv_pmos ad=0.3808p pd=2.92u as=0.2128p ps=1.5u w=1.12u l=0.6u
X804 VSS.t2014 a_2873_331# a_3171_311.t1 VSS.t2029 sg13_lv_nmos ad=0.2812p pd=2.24u as=0.1406p ps=1.12u w=0.74u l=0.13u
X805 VDD.t302 a_4187_2434# a_6391_14652# VDD.t301 sg13_lv_pmos ad=0.3808p pd=2.92u as=0.2128p ps=1.5u w=1.12u l=0.6u
X806 a_3747_16074.t1 a_3449_16422# VSS.t95 VSS.t1676 sg13_lv_nmos ad=0.1406p pd=1.12u as=0.1331p ps=1.12u w=0.74u l=0.13u
X807 VDD.t992 a_23763_14024# a_24197_14024# VDD.t301 sg13_lv_pmos ad=0.2128p pd=1.5u as=0.3808p ps=2.92u w=1.12u l=0.13u
X808 a_7390_3889# a_8884_3853# a_8808_3889# VDD.t0 sg13_lv_pmos ad=0.3808p pd=2.92u as=0.2128p ps=1.5u w=1.12u l=0.13u
X809 a_13306_10795# a_13132_11110# VDD.t729 VDD.t268 sg13_lv_pmos ad=79.8f pd=0.8u as=0.1428p ps=1.52u w=0.42u l=0.13u
X810 a_16108_3134# a_3171_3156.t2 a_22590_3889# VSS.t0 sg13_lv_nmos ad=0.2516p pd=2.16u as=0.2516p ps=2.16u w=0.74u l=0.13u
X811 VDD.t87 VSS.t949 VDD.t103 VDD.t41 sg13_lv_pmos ad=0.34p pd=2.68u as=0 ps=0 w=1u l=1u
X812 VSS.t1329 a_19637_14024# a_20105_13226# VSS.t2087 sg13_lv_nmos ad=0.1665p pd=1.19u as=0.2516p ps=2.16u w=0.74u l=0.13u
X813 VSS.t1490 a_3449_331# a_3747_311.t1 VSS.t2025 sg13_lv_nmos ad=0.2812p pd=2.24u as=0.1406p ps=1.12u w=0.74u l=0.13u
X814 VSS.t2381 VSS.t2381 VSS.t2383 VSS.t2382 sg13_lv_nmos ad=0.2516p pd=2.16u as=0 ps=0 w=0.74u l=0.13u
X815 a_10430_16071# a_3171_16074.t7 a_11848_16071# VSS.t1576 sg13_lv_nmos ad=0.2516p pd=2.16u as=0.1406p ps=1.12u w=0.74u l=0.13u
X816 a_15755_1044# a_15545_1044# VDD.t954 VDD.t7 sg13_lv_pmos ad=0.2128p pd=1.5u as=0.252p ps=1.57u w=1.12u l=0.13u
X817 a_26911_4687# a_26673_4687# a_26803_4687# VSS.t1237 sg13_lv_nmos ad=0.1406p pd=1.12u as=0.2516p ps=2.16u w=0.74u l=0.2u
X818 VSS.t211 a_24197_7532# a_24665_6734# VSS.t210 sg13_lv_nmos ad=0.1665p pd=1.19u as=0.2516p ps=2.16u w=0.74u l=0.13u
X819 VSS.t1589 a_3171_13229.t5 a_18004_13190# VSS.t1588 sg13_lv_nmos ad=0.2516p pd=2.16u as=0.2516p ps=2.16u w=0.74u l=0.13u
X820 VDD.t1127 a_6326_10280# a_6854_11144# VDD.t268 sg13_lv_pmos ad=0.38p pd=2.38u as=0.38p ps=2.38u w=2u l=1u
X821 a_11711_7532# a_11473_7532# a_11603_7532# VSS.t207 sg13_lv_nmos ad=0.1406p pd=1.12u as=0.2516p ps=2.16u w=0.74u l=0.2u
X822 a_16510_6734# a_3171_6737.t5 a_17928_6734# VSS.t1305 sg13_lv_nmos ad=0.2516p pd=2.16u as=0.1406p ps=1.12u w=0.74u l=0.13u
X823 VDD.t654 a_2595_1047.t6 a_14311_1008# VDD.t7 sg13_lv_pmos ad=0.3808p pd=2.92u as=0.3808p ps=2.92u w=1.12u l=0.13u
X824 VDD.t94 VSS.t820 VDD.t93 VDD.t4 sg13_lv_pmos ad=0.34p pd=2.68u as=0 ps=0 w=1u l=1u
X825 VDD.t713 a_2019_6737.t9 a_4324_6698# VDD.t41 sg13_lv_pmos ad=0.3808p pd=2.92u as=0.3808p ps=2.92u w=1.12u l=0.13u
X826 a_17031_14024# a_16793_14024# a_16923_14024# VSS.t2061 sg13_lv_nmos ad=0.1406p pd=1.12u as=0.2516p ps=2.16u w=0.74u l=0.2u
X827 a_5974_11413# a_6126_9506# VSS.t19 VSS.t17 sg13_lv_nmos ad=0.38p pd=2.38u as=0.68p ps=4.68u w=2u l=1u
X828 VSS.t1606 a_4187_1764.t6 a_24631_1842# VSS.t1605 sg13_lv_nmos ad=0.2516p pd=2.16u as=0.1406p ps=1.12u w=0.74u l=0.6u
X829 a_16510_6734# a_18871_6698# a_18795_6734# VDD.t41 sg13_lv_pmos ad=0.3808p pd=2.92u as=0.2128p ps=1.5u w=1.12u l=0.13u
X830 a_5115_1044# a_4905_1044# VDD.t952 VDD.t7 sg13_lv_pmos ad=0.2128p pd=1.5u as=0.252p ps=1.57u w=1.12u l=0.13u
X831 VSS.t477 a_1721_6021# a_2019_6001.t1 VSS.t1215 sg13_lv_nmos ad=0.2812p pd=2.24u as=0.1406p ps=1.12u w=0.74u l=0.13u
X832 a_13470_13226# a_14964_13190# a_14888_13226# VDD.t50 sg13_lv_pmos ad=0.3808p pd=2.92u as=0.2128p ps=1.5u w=1.12u l=0.13u
X833 a_12471_14024# a_12233_14024# a_12363_14024# VSS.t2067 sg13_lv_nmos ad=0.1406p pd=1.12u as=0.2516p ps=2.16u w=0.74u l=0.2u
X834 VSS.t344 a_4187_1764.t113 a_17791_14024# VSS.t343 sg13_lv_nmos ad=0.2516p pd=2.16u as=0.1406p ps=1.12u w=0.74u l=0.6u
X835 VSS.t2091 a_1544_12471# a_2391_12513# VSS.t2090 sg13_lv_nmos ad=0.1331p pd=1.12u as=0.1216p ps=1.02u w=0.64u l=0.13u
X836 VSS.t1913 a_4437_14024# a_4905_13226# VSS.t1982 sg13_lv_nmos ad=0.1665p pd=1.19u as=0.2516p ps=2.16u w=0.74u l=0.13u
X837 a_14513_7532# a_14317_7532# VDD.t824 VDD.t275 sg13_lv_pmos ad=0.3808p pd=2.92u as=0.2128p ps=1.5u w=1.12u l=0.13u
X838 VDD.t340 a_4187_2434# a_23111_17497# VDD.t297 sg13_lv_pmos ad=0.3808p pd=2.92u as=0.2128p ps=1.5u w=1.12u l=0.6u
X839 VDD.t1338 a_4003_14024# a_4437_14024# VDD.t301 sg13_lv_pmos ad=0.2128p pd=1.5u as=0.3808p ps=2.92u w=1.12u l=0.13u
X840 a_10430_13226# a_10404_13190# a_10328_13226# VDD.t50 sg13_lv_pmos ad=0.3808p pd=2.92u as=0.2128p ps=1.5u w=1.12u l=0.13u
X841 VSS.t904 a_2019_12493.t2 a_17865_12701# VSS.t2229 sg13_lv_nmos ad=0.2516p pd=2.16u as=0.2516p ps=2.16u w=0.74u l=0.13u
X842 a_5631_8160# a_5393_7532# a_5523_7532# VDD.t275 sg13_lv_pmos ad=0.2128p pd=1.5u as=0.3808p ps=2.92u w=1.12u l=0.2u
X843 VSS.t639 a_15964_3134# a_16851_3154# VSS.t1153 sg13_lv_nmos ad=0.1371p pd=1.12u as=0.2176p ps=1.96u w=0.64u l=0.13u
X844 VDD.t277 a_15077_4687# a_15545_3889# VDD.t0 sg13_lv_pmos ad=0.252p pd=1.57u as=0.3808p ps=2.92u w=1.12u l=0.13u
X845 VSS.t436 a_4187_1764.t50 a_15511_4687# VSS.t583 sg13_lv_nmos ad=0.2516p pd=2.16u as=0.1406p ps=1.12u w=0.74u l=0.6u
X846 a_17553_4687# a_17357_4687# VDD.t512 VDD.t281 sg13_lv_pmos ad=0.3808p pd=2.92u as=0.2128p ps=1.5u w=1.12u l=0.13u
X847 VSS.t755 a_4187_1764.t119 a_13231_14024# VSS.t754 sg13_lv_nmos ad=0.2516p pd=2.16u as=0.1406p ps=1.12u w=0.74u l=0.6u
X848 a_8671_5315# a_8433_4687# a_8563_4687# VDD.t281 sg13_lv_pmos ad=0.2128p pd=1.5u as=0.3808p ps=2.92u w=1.12u l=0.2u
X849 VDD.t1186 a_18117_16869# a_18585_16071# VDD.t4 sg13_lv_pmos ad=0.252p pd=1.57u as=0.3808p ps=2.92u w=1.12u l=0.13u
X850 a_13566_11525# a_14009_11568# a_13306_11995# VSS.t192 sg13_lv_nmos ad=79.8f pd=0.8u as=0.1296p ps=1.52u w=0.42u l=0.13u
X851 VDD.t263 VSS.t979 VDD.t49 VDD.t41 sg13_lv_pmos ad=0.19p pd=1.38u as=0 ps=0 w=1u l=1u
X852 VSS.t1220 a_1256_15316# a_2967_15358# VSS.t1897 sg13_lv_nmos ad=0.1331p pd=1.12u as=0.1216p ps=1.02u w=0.64u l=0.13u
X853 a_18551_2470# a_18313_1842# a_18443_1842# VDD.t399 sg13_lv_pmos ad=0.2128p pd=1.5u as=0.3808p ps=2.92u w=1.12u l=0.2u
X854 VSS.t2339 VSS.t2336 VSS.t2336 VSS.t2337 sg13_lv_nmos ad=0.1406p pd=1.12u as=0 ps=0 w=0.74u l=0.13u
X855 VSS.t782 a_25283_4687# a_25717_4687# VSS.t781 sg13_lv_nmos ad=0.1406p pd=1.12u as=0.2516p ps=2.16u w=0.74u l=0.13u
X856 VDD.t1398 a_3171_16074.t2 a_27124_16035# VDD.t4 sg13_lv_pmos ad=0.3808p pd=2.92u as=0.3808p ps=2.92u w=1.12u l=0.13u
X857 a_11848_16071# a_11277_16869# VDD.t888 VDD.t4 sg13_lv_pmos ad=0.2128p pd=1.5u as=0.3808p ps=2.92u w=1.12u l=0.13u
X858 VDD.t174 VSS.t875 VDD.t209 VDD.t50 sg13_lv_pmos ad=0.34p pd=2.68u as=0 ps=0 w=1u l=1u
X859 VSS.t724 a_3171_6737.t4 a_21044_6698# VSS.t1312 sg13_lv_nmos ad=0.2516p pd=2.16u as=0.2516p ps=2.16u w=0.74u l=0.13u
X860 a_10951_16869# a_10713_16869# a_10843_16869# VSS.t1368 sg13_lv_nmos ad=0.1406p pd=1.12u as=0.2516p ps=2.16u w=0.74u l=0.2u
X861 a_19550_13226# a_20391_13190# a_20315_13226# VDD.t50 sg13_lv_pmos ad=0.3808p pd=2.92u as=0.2128p ps=1.5u w=1.12u l=0.13u
X862 VSS.t449 a_10083_7532# a_10517_7532# VSS.t2306 sg13_lv_nmos ad=0.1406p pd=1.12u as=0.2516p ps=2.16u w=0.74u l=0.13u
X863 VDD.t1103 VSS.t1101 VDD.t243 VDD.t7 sg13_lv_pmos ad=0.19p pd=1.38u as=0 ps=0 w=1u l=1u
X864 a_15273_16869# a_15077_16869# VSS.t64 VSS.t63 sg13_lv_nmos ad=0.2516p pd=2.16u as=0.1406p ps=1.12u w=0.74u l=0.13u
X865 a_13592_11561# a_13566_11525# VDD.t269 VDD.t268 sg13_lv_pmos ad=0.34p pd=2.68u as=0.36237p ps=2.605u w=1u l=0.13u
X866 a_4633_7532# a_4437_7532# VDD.t863 VDD.t275 sg13_lv_pmos ad=0.3808p pd=2.92u as=0.2128p ps=1.5u w=1.12u l=0.13u
X867 VDD.t1050 a_5957_14024# a_6425_13226# VDD.t50 sg13_lv_pmos ad=0.252p pd=1.57u as=0.3808p ps=2.92u w=1.12u l=0.13u
X868 VSS.t39 a_4187_1764.t63 a_5631_4687# VSS.t1599 sg13_lv_nmos ad=0.2516p pd=2.16u as=0.1406p ps=1.12u w=0.74u l=0.6u
X869 VDD.t321 a_4187_2434# a_7911_17497# VDD.t297 sg13_lv_pmos ad=0.3808p pd=2.92u as=0.2128p ps=1.5u w=1.12u l=0.6u
X870 VDD.t934 a_25283_16869# a_25717_16869# VDD.t297 sg13_lv_pmos ad=0.2128p pd=1.5u as=0.3808p ps=2.92u w=1.12u l=0.13u
X871 a_3171_1047.t1 a_2873_1395# VSS.t494 VSS.t493 sg13_lv_nmos ad=0.1406p pd=1.12u as=0.1331p ps=1.12u w=0.74u l=0.13u
X872 VSS.t1626 a_15403_14024# a_15837_14024# VSS.t2060 sg13_lv_nmos ad=0.1406p pd=1.12u as=0.2516p ps=2.16u w=0.74u l=0.13u
X873 VSS.t1592 a_2595_13229.t8 a_8231_13190# VSS.t1638 sg13_lv_nmos ad=0.2516p pd=2.16u as=0.2516p ps=2.16u w=0.74u l=0.13u
X874 VSS.t256 a_2297_1395# a_2595_1047.t1 VSS.t1159 sg13_lv_nmos ad=0.2812p pd=2.24u as=0.1406p ps=1.12u w=0.74u l=0.13u
X875 VDD.t17 VSS.t1011 VDD.t16 VDD.t0 sg13_lv_pmos ad=0.34p pd=2.68u as=0 ps=0 w=1u l=1u
X876 a_10430_3889# a_2019_3892.t7 a_10328_3889# VSS.t1842 sg13_lv_nmos ad=0.2516p pd=2.16u as=0.1406p ps=1.12u w=0.74u l=0.13u
X877 a_21353_4687# a_21157_4687# VDD.t913 VDD.t281 sg13_lv_pmos ad=0.3808p pd=2.92u as=0.2128p ps=1.5u w=1.12u l=0.13u
X878 VDD.t533 a_20723_16869# a_21157_16869# VDD.t297 sg13_lv_pmos ad=0.2128p pd=1.5u as=0.3808p ps=2.92u w=1.12u l=0.13u
X879 VSS.t993 VDD.t1646 VSS.t992 VSS.t991 sg13_lv_nmos ad=0.1428p pd=1.52u as=0 ps=0 w=0.42u l=1u
X880 VSS.t2394 VSS.t2394 VSS.t2396 VSS.t2395 sg13_lv_nmos ad=0.2516p pd=2.16u as=0 ps=0 w=0.74u l=0.13u
X881 a_1815_3176# a_1256_3134# a_1721_3176# VSS.t701 sg13_lv_nmos ad=0.1216p pd=1.02u as=0.2176p ps=1.96u w=0.64u l=0.13u
X882 a_26911_1842# a_26673_1842# a_26803_1842# VSS.t1893 sg13_lv_nmos ad=0.1406p pd=1.12u as=0.2516p ps=2.16u w=0.74u l=0.2u
X883 VSS.t767 a_3171_311.t3 a_11785_519# VSS.t766 sg13_lv_nmos ad=0.2516p pd=2.16u as=0.2516p ps=2.16u w=0.74u l=0.13u
X884 VDD.t847 a_7043_4687# a_7477_4687# VDD.t281 sg13_lv_pmos ad=0.2128p pd=1.5u as=0.3808p ps=2.92u w=1.12u l=0.13u
X885 VDD.t1575 a_1721_1395# a_2019_1047.t0 VDD.t7 sg13_lv_pmos ad=0.4256p pd=3u as=0.2128p ps=1.5u w=1.12u l=0.13u
X886 a_22351_2470# a_22113_1842# a_22243_1842# VDD.t399 sg13_lv_pmos ad=0.2128p pd=1.5u as=0.3808p ps=2.92u w=1.12u l=0.2u
X887 VDD.t967 a_3171_3892.t7 a_11924_3853# VDD.t0 sg13_lv_pmos ad=0.3808p pd=2.92u as=0.3808p ps=2.92u w=1.12u l=0.13u
X888 a_2391_1395# CHAN3_MUX_SEL0 a_2297_1395# VSS.t2009 sg13_lv_nmos ad=0.1216p pd=1.02u as=0.2176p ps=1.96u w=0.64u l=0.13u
X889 VDD.t1164 a_16923_1842# a_17357_1842# VDD.t399 sg13_lv_pmos ad=0.2128p pd=1.5u as=0.3808p ps=2.92u w=1.12u l=0.13u
X890 VSS.t229 a_4187_1764.t70 a_24631_7532# VSS.t1438 sg13_lv_nmos ad=0.2516p pd=2.16u as=0.1406p ps=1.12u w=0.74u l=0.6u
X891 a_7390_3889# a_3171_3892.t8 a_8808_3889# VSS.t1351 sg13_lv_nmos ad=0.2516p pd=2.16u as=0.1406p ps=1.12u w=0.74u l=0.13u
X892 a_13368_1044# a_12797_1842# VSS.t1612 VSS.t1667 sg13_lv_nmos ad=0.1406p pd=1.12u as=0.2516p ps=2.16u w=0.74u l=0.13u
X893 VSS.t256 a_1544_1044# a_1815_1395# VSS.t257 sg13_lv_nmos ad=0.1331p pd=1.12u as=0.1216p ps=1.02u w=0.64u l=0.13u
X894 VSS.t999 VDD.t1644 VSS.t998 VSS.t997 sg13_lv_nmos ad=0.1428p pd=1.52u as=0 ps=0 w=0.42u l=1u
X895 VDD.t591 a_2297_13577# a_2595_13229.t0 VDD.t50 sg13_lv_pmos ad=0.4256p pd=3u as=0.2128p ps=1.5u w=1.12u l=0.13u
X896 a_14009_10774# REF_DELAY_OUT_LAST VDD.t270 VDD.t268 sg13_lv_pmos ad=0.4088p pd=2.97u as=1.10612p ps=6.66u w=1.12u l=0.13u
X897 VDD.t643 a_21157_1842# a_21625_1044# VDD.t7 sg13_lv_pmos ad=0.252p pd=1.57u as=0.3808p ps=2.92u w=1.12u l=0.13u
X898 a_5974_11413# a_6126_9506# VSS.t21 VSS.t17 sg13_lv_nmos ad=0.38p pd=2.38u as=0.68p ps=4.68u w=2u l=1u
X899 a_5731_289# a_3171_311.t3 a_10430_1044# VSS.t765 sg13_lv_nmos ad=0.2516p pd=2.16u as=0.2516p ps=2.16u w=0.74u l=0.13u
X900 VDD.t356 a_4187_2434# a_23111_14652# VDD.t301 sg13_lv_pmos ad=0.3808p pd=2.92u as=0.2128p ps=1.5u w=1.12u l=0.6u
X901 a_12993_14024# a_12797_14024# VSS.t757 VSS.t2056 sg13_lv_nmos ad=0.2516p pd=2.16u as=0.1406p ps=1.12u w=0.74u l=0.13u
X902 VSS.t266 a_4187_1764.t18 a_15511_1842# VSS.t265 sg13_lv_nmos ad=0.2516p pd=2.16u as=0.1406p ps=1.12u w=0.74u l=0.6u
X903 VDD.t441 a_4187_2434# a_10951_2470# VDD.t399 sg13_lv_pmos ad=0.3808p pd=2.92u as=0.2128p ps=1.5u w=1.12u l=0.6u
X904 VDD.t195 VSS.t918 VDD.t193 VDD.t50 sg13_lv_pmos ad=0.19p pd=1.38u as=0 ps=0 w=1u l=1u
X905 a_16271_16869# a_16033_16869# a_16163_16869# VSS.t479 sg13_lv_nmos ad=0.1406p pd=1.12u as=0.2516p ps=2.16u w=0.74u l=0.2u
X906 a_25630_3889# a_25604_3853# a_25528_3889# VDD.t0 sg13_lv_pmos ad=0.3808p pd=2.92u as=0.2128p ps=1.5u w=1.12u l=0.13u
X907 VDD.t238 VSS.t1042 VDD.t237 VDD.t0 sg13_lv_pmos ad=0.19p pd=1.38u as=0 ps=0 w=1u l=1u
X908 a_16793_4687# a_16597_4687# VSS.t50 VSS.t691 sg13_lv_nmos ad=0.2516p pd=2.16u as=0.1406p ps=1.12u w=0.74u l=0.13u
X909 VSS.t2103 a_1256_12471# a_2967_12513# VSS.t2304 sg13_lv_nmos ad=0.1331p pd=1.12u as=0.1216p ps=1.02u w=0.64u l=0.13u
X910 a_18551_8160# a_18313_7532# a_18443_7532# VDD.t275 sg13_lv_pmos ad=0.2128p pd=1.5u as=0.3808p ps=2.92u w=1.12u l=0.2u
X911 a_7911_4687# a_7673_4687# a_7803_4687# VSS.t2291 sg13_lv_nmos ad=0.1406p pd=1.12u as=0.2516p ps=2.16u w=0.74u l=0.2u
X912 a_10430_6734# a_10404_6698# a_10328_6734# VDD.t41 sg13_lv_pmos ad=0.3808p pd=2.92u as=0.2128p ps=1.5u w=1.12u l=0.13u
X913 VSS.t426 VDD.t1692 VSS.t835 VSS.t834 sg13_lv_nmos ad=0.1428p pd=1.52u as=0 ps=0 w=0.42u l=1u
X914 a_4350_1044# a_3747_1047.t9 a_6635_1044# VSS.t1596 sg13_lv_nmos ad=0.2516p pd=2.16u as=0.1406p ps=1.12u w=0.74u l=0.13u
X915 VSS.t489 a_25283_1842# a_25717_1842# VSS.t1924 sg13_lv_nmos ad=0.1406p pd=1.12u as=0.2516p ps=2.16u w=0.74u l=0.13u
X916 VDD.t513 REF_MUX_SEL3 a_3449_6021# VDD.t41 sg13_lv_pmos ad=0.1918p pd=1.5u as=0.1596p ps=1.22u w=0.84u l=0.13u
X917 VSS.t491 a_4187_1764.t146 a_17031_16869# VSS.t625 sg13_lv_nmos ad=0.2516p pd=2.16u as=0.1406p ps=1.12u w=0.74u l=0.6u
X918 a_27433_14024# a_27237_14024# VSS.t388 VSS.t387 sg13_lv_nmos ad=0.2516p pd=2.16u as=0.1406p ps=1.12u w=0.74u l=0.13u
X919 VDD.t1327 a_20723_1842# a_21157_1842# VDD.t399 sg13_lv_pmos ad=0.2128p pd=1.5u as=0.3808p ps=2.92u w=1.12u l=0.13u
X920 VDD.t491 a_14851_10872# a_15688_11093# VDD.t268 sg13_lv_pmos ad=0.2128p pd=1.5u as=0.3864p ps=2.93u w=1.12u l=0.13u
X921 VSS.t29 a_15077_4687# a_15545_3889# VSS.t674 sg13_lv_nmos ad=0.1665p pd=1.19u as=0.2516p ps=2.16u w=0.74u l=0.13u
X922 a_3747_12493.t0 a_3449_12513# VDD.t483 VDD.t50 sg13_lv_pmos ad=0.2128p pd=1.5u as=0.1918p ps=1.5u w=1.12u l=0.13u
X923 VDD.t997 a_2019_1047.t9 a_4324_1008# VDD.t7 sg13_lv_pmos ad=0.3808p pd=2.92u as=0.3808p ps=2.92u w=1.12u l=0.13u
X924 VSS.t1652 a_4187_1764.t31 a_5631_1842# VSS.t1651 sg13_lv_nmos ad=0.2516p pd=2.16u as=0.1406p ps=1.12u w=0.74u l=0.6u
X925 a_3449_16422# CHAN0_MUX_SEL0 VDD.t1482 VDD.t4 sg13_lv_pmos ad=0.1596p pd=1.22u as=0.2856p ps=2.36u w=0.84u l=0.13u
X926 VDD.t1328 a_15964_15316# a_16851_15336# VDD.t4 sg13_lv_pmos ad=0.2086p pd=1.5u as=0.34p ps=2.68u w=1u l=0.13u
X927 VDD.t346 a_4187_2434# a_7911_14652# VDD.t301 sg13_lv_pmos ad=0.3808p pd=2.92u as=0.2128p ps=1.5u w=1.12u l=0.6u
X928 VDD.t900 a_25283_14024# a_25717_14024# VDD.t301 sg13_lv_pmos ad=0.2128p pd=1.5u as=0.3808p ps=2.92u w=1.12u l=0.13u
X929 a_19550_1044# a_2595_1047.t4 a_20315_1044# VSS.t564 sg13_lv_nmos ad=0.2516p pd=2.16u as=0.1406p ps=1.12u w=0.74u l=0.13u
X930 a_3171_6737.t1 a_2873_7085# VSS.t1175 VSS.t1174 sg13_lv_nmos ad=0.1406p pd=1.12u as=0.1331p ps=1.12u w=0.74u l=0.13u
X931 VDD.t42 VSS.t993 VDD.t158 VDD.t41 sg13_lv_pmos ad=0.34p pd=2.68u as=0 ps=0 w=1u l=1u
X932 a_16510_1044# a_18871_1008# a_18795_1044# VDD.t7 sg13_lv_pmos ad=0.3808p pd=2.92u as=0.2128p ps=1.5u w=1.12u l=0.13u
X933 a_7390_6734# a_8884_6698# a_8808_6734# VDD.t41 sg13_lv_pmos ad=0.3808p pd=2.92u as=0.2128p ps=1.5u w=1.12u l=0.13u
X934 VSS.t1337 a_21157_14024# a_21625_13226# VSS.t1864 sg13_lv_nmos ad=0.1665p pd=1.19u as=0.2516p ps=2.16u w=0.74u l=0.13u
X935 VSS.t232 a_2297_7085# a_2595_6737.t1 VSS.t1253 sg13_lv_nmos ad=0.2812p pd=2.24u as=0.1406p ps=1.12u w=0.74u l=0.13u
X936 VDD.t1219 a_20723_14024# a_21157_14024# VDD.t301 sg13_lv_pmos ad=0.2128p pd=1.5u as=0.3808p ps=2.92u w=1.12u l=0.13u
X937 a_13991_5315# a_13753_4687# a_13883_4687# VDD.t281 sg13_lv_pmos ad=0.2128p pd=1.5u as=0.3808p ps=2.92u w=1.12u l=0.2u
X938 VSS.t1729 a_19637_16869# a_20105_16071# VSS.t1728 sg13_lv_nmos ad=0.1665p pd=1.19u as=0.2516p ps=2.16u w=0.74u l=0.13u
X939 VSS.t2372 VSS.t2370 VSS.t1433 VSS.t2371 sg13_lv_nmos ad=0.2516p pd=2.16u as=0 ps=0 w=0.74u l=0.13u
X940 VSS.t350 a_27563_4687# a_27997_4687# VSS.t391 sg13_lv_nmos ad=0.1406p pd=1.12u as=0.2516p ps=2.16u w=0.74u l=0.13u
X941 a_26911_7532# a_26673_7532# a_26803_7532# VSS.t470 sg13_lv_nmos ad=0.1406p pd=1.12u as=0.2516p ps=2.16u w=0.74u l=0.2u
X942 VSS.t461 a_7477_1842# a_7945_1044# VSS.t1243 sg13_lv_nmos ad=0.1665p pd=1.19u as=0.2516p ps=2.16u w=0.74u l=0.13u
X943 VDD.t436 a_4187_2434# a_23871_2470# VDD.t399 sg13_lv_pmos ad=0.3808p pd=2.92u as=0.2128p ps=1.5u w=1.12u l=0.6u
X944 VSS.t1564 a_2019_13229.t4 a_19524_13190# VSS.t1563 sg13_lv_nmos ad=0.2516p pd=2.16u as=0.2516p ps=2.16u w=0.74u l=0.13u
X945 a_20593_4687# a_20397_4687# VSS.t209 VSS.t339 sg13_lv_nmos ad=0.2516p pd=2.16u as=0.1406p ps=1.12u w=0.74u l=0.13u
X946 VSS.t1725 a_19203_16869# a_19637_16869# VSS.t1724 sg13_lv_nmos ad=0.1406p pd=1.12u as=0.2516p ps=2.16u w=0.74u l=0.13u
X947 a_22351_8160# a_22113_7532# a_22243_7532# VDD.t275 sg13_lv_pmos ad=0.2128p pd=1.5u as=0.3808p ps=2.92u w=1.12u l=0.2u
X948 VSS.t418 a_3171_16074.t5 a_18004_16035# VSS.t2058 sg13_lv_nmos ad=0.2516p pd=2.16u as=0.2516p ps=2.16u w=0.74u l=0.13u
X949 VSS.t1044 VDD.t1630 VSS.t1044 VSS.t1047 sg13_lv_nmos ad=79.8f pd=0.8u as=0 ps=0 w=0.42u l=1u
X950 VDD.t861 a_16923_7532# a_17357_7532# VDD.t275 sg13_lv_pmos ad=0.2128p pd=1.5u as=0.3808p ps=2.92u w=1.12u l=0.13u
X951 a_2391_7085# REF_MUX_SEL0 a_2297_7085# VSS.t337 sg13_lv_nmos ad=0.1216p pd=1.02u as=0.2176p ps=1.96u w=0.64u l=0.13u
X952 VSS.t796 a_6283_4687# a_6717_4687# VSS.t1419 sg13_lv_nmos ad=0.1406p pd=1.12u as=0.2516p ps=2.16u w=0.74u l=0.13u
X953 VSS.t959 VDD.t1654 VSS.t959 VSS.t963 sg13_lv_nmos ad=79.8f pd=0.8u as=0 ps=0 w=0.42u l=1u
X954 a_13368_6734# a_12797_7532# VSS.t633 VSS.t632 sg13_lv_nmos ad=0.1406p pd=1.12u as=0.2516p ps=2.16u w=0.74u l=0.13u
X955 VSS.t82 a_3747_3156.t3 a_14825_3364# VSS.t81 sg13_lv_nmos ad=0.2516p pd=2.16u as=0.2516p ps=2.16u w=0.74u l=0.13u
X956 a_13991_14024# a_13753_14024# a_13883_14024# VSS.t2054 sg13_lv_nmos ad=0.1406p pd=1.12u as=0.2516p ps=2.16u w=0.74u l=0.2u
X957 a_18313_14024# a_18117_14024# VSS.t344 VSS.t2049 sg13_lv_nmos ad=0.2516p pd=2.16u as=0.1406p ps=1.12u w=0.74u l=0.13u
X958 VSS.t232 a_1544_6734# a_1815_7085# VSS.t641 sg13_lv_nmos ad=0.1331p pd=1.12u as=0.1216p ps=1.02u w=0.64u l=0.13u
X959 VDD.t25 VSS.t770 VDD.t247 VDD.t7 sg13_lv_pmos ad=0.34p pd=2.68u as=0 ps=0 w=1u l=1u
X960 a_13231_2470# a_12993_1842# a_13123_1842# VDD.t399 sg13_lv_pmos ad=0.2128p pd=1.5u as=0.3808p ps=2.92u w=1.12u l=0.2u
X961 a_10430_13226# a_11924_13190# a_11848_13226# VDD.t50 sg13_lv_pmos ad=0.3808p pd=2.92u as=0.2128p ps=1.5u w=1.12u l=0.13u
X962 VSS.t742 a_4187_1764.t117 a_14751_14024# VSS.t741 sg13_lv_nmos ad=0.2516p pd=2.16u as=0.1406p ps=1.12u w=0.74u l=0.6u
X963 a_3449_3176# CHAN2_MUX_SEL2 VDD.t1492 VDD.t0 sg13_lv_pmos ad=0.1596p pd=1.22u as=0.2856p ps=2.36u w=0.84u l=0.13u
X964 VSS.t1355 a_3171_3892.t7 a_11924_3853# VSS.t1354 sg13_lv_nmos ad=0.2516p pd=2.16u as=0.2516p ps=2.16u w=0.74u l=0.13u
X965 VSS.t1665 a_4437_16869# a_4905_16071# VSS.t2198 sg13_lv_nmos ad=0.1665p pd=1.19u as=0.2516p ps=2.16u w=0.74u l=0.13u
X966 VSS.t508 a_3747_13229.t3 a_24951_13190# VSS.t507 sg13_lv_nmos ad=0.2516p pd=2.16u as=0.2516p ps=2.16u w=0.74u l=0.13u
X967 a_13880_11982# a_13592_11561# a_13818_11982# VSS.t809 sg13_lv_nmos ad=0.1428p pd=1.52u as=37.8f ps=0.6u w=0.42u l=0.13u
X968 VDD.t333 a_4187_2434# a_20071_17497# VDD.t297 sg13_lv_pmos ad=0.3808p pd=2.92u as=0.2128p ps=1.5u w=1.12u l=0.6u
X969 VSS.t221 a_4187_1764.t82 a_15511_7532# VSS.t1361 sg13_lv_nmos ad=0.2516p pd=2.16u as=0.1406p ps=1.12u w=0.74u l=0.6u
X970 VDD.t1030 a_15077_7532# a_15545_6734# VDD.t41 sg13_lv_pmos ad=0.252p pd=1.57u as=0.3808p ps=2.92u w=1.12u l=0.13u
X971 VSS.t899 a_3747_12493.t3 a_14825_12701# VSS.t361 sg13_lv_nmos ad=0.2516p pd=2.16u as=0.2516p ps=2.16u w=0.74u l=0.13u
X972 VDD.t385 a_4187_2434# a_10951_8160# VDD.t275 sg13_lv_pmos ad=0.3808p pd=2.92u as=0.2128p ps=1.5u w=1.12u l=0.6u
X973 VSS.t1544 a_4187_1764.t98 VSS.t1542 VSS.t1527 sg13_lv_nmos ad=1.33p pd=7.38u as=0 ps=0 w=7u l=7u
X974 VDD.t457 a_15077_16869# a_15545_16071# VDD.t4 sg13_lv_pmos ad=0.252p pd=1.57u as=0.3808p ps=2.92u w=1.12u l=0.13u
X975 VDD.t543 a_12363_4687# a_12797_4687# VDD.t281 sg13_lv_pmos ad=0.2128p pd=1.5u as=0.3808p ps=2.92u w=1.12u l=0.13u
X976 a_16793_1842# a_16597_1842# VSS.t165 VSS.t1673 sg13_lv_nmos ad=0.2516p pd=2.16u as=0.1406p ps=1.12u w=0.74u l=0.13u
X977 VSS.t1121 a_25283_7532# a_25717_7532# VSS.t1120 sg13_lv_nmos ad=0.1406p pd=1.12u as=0.2516p ps=2.16u w=0.74u l=0.13u
X978 a_7911_1842# a_7673_1842# a_7803_1842# VSS.t1200 sg13_lv_nmos ad=0.1406p pd=1.12u as=0.2516p ps=2.16u w=0.74u l=0.2u
X979 a_12233_1842# a_12037_1842# VDD.t1144 VDD.t399 sg13_lv_pmos ad=0.3808p pd=2.92u as=0.2128p ps=1.5u w=1.12u l=0.13u
X980 a_16793_16869# a_16597_16869# VSS.t1280 VSS.t1279 sg13_lv_nmos ad=0.2516p pd=2.16u as=0.1406p ps=1.12u w=0.74u l=0.13u
X981 a_4350_6734# a_3747_6737.t9 a_6635_6734# VSS.t1761 sg13_lv_nmos ad=0.2516p pd=2.16u as=0.1406p ps=1.12u w=0.74u l=0.13u
X982 VSS.t865 VDD.t1683 VSS.t867 VSS.t866 sg13_lv_nmos ad=79.8f pd=0.8u as=0 ps=0 w=0.42u l=1u
X983 a_16108_12471# CHAN1_MUX_SEL4 a_15964_12471# VSS.t361 sg13_lv_nmos ad=0.2516p pd=2.16u as=0.2183p ps=1.33u w=0.74u l=0.13u
X984 VDD.t1120 a_20723_7532# a_21157_7532# VDD.t275 sg13_lv_pmos ad=0.2128p pd=1.5u as=0.3808p ps=2.92u w=1.12u l=0.13u
X985 VDD.t1069 a_3171_16074.t3 a_24084_16035# VDD.t4 sg13_lv_pmos ad=0.3808p pd=2.92u as=0.3808p ps=2.92u w=1.12u l=0.13u
X986 VSS.t1016 VDD.t1639 VSS.t1016 VSS.t1015 sg13_lv_nmos ad=0.1428p pd=1.52u as=0 ps=0 w=0.42u l=1u
X987 a_12233_16869# a_12037_16869# VSS.t415 VSS.t414 sg13_lv_nmos ad=0.2516p pd=2.16u as=0.1406p ps=1.12u w=0.74u l=0.13u
X988 VDD.t58 VSS.t686 VDD.t57 VDD.t4 sg13_lv_pmos ad=0.34p pd=2.68u as=0 ps=0 w=1u l=1u
X989 VSS.t226 a_4187_1764.t95 a_5631_7532# VSS.t582 sg13_lv_nmos ad=0.2516p pd=2.16u as=0.1406p ps=1.12u w=0.74u l=0.6u
X990 a_19550_6734# a_2595_6737.t4 a_20315_6734# VSS.t722 sg13_lv_nmos ad=0.2516p pd=2.16u as=0.1406p ps=1.12u w=0.74u l=0.13u
X991 VDD.t1462 a_3747_311.t3 a_14825_519# VDD.t7 sg13_lv_pmos ad=0.3808p pd=2.92u as=0.3808p ps=2.92u w=1.12u l=0.13u
X992 a_16510_3889# a_16484_3853# a_16408_3889# VDD.t0 sg13_lv_pmos ad=0.3808p pd=2.92u as=0.2128p ps=1.5u w=1.12u l=0.13u
X993 VSS.t1567 a_3747_13229.t8 a_9751_13190# VSS.t2161 sg13_lv_nmos ad=0.2516p pd=2.16u as=0.2516p ps=2.16u w=0.74u l=0.13u
X994 VDD.t298 a_4187_2434# a_4871_17497# VDD.t297 sg13_lv_pmos ad=0.3808p pd=2.92u as=0.2128p ps=1.5u w=1.12u l=0.6u
X995 a_25630_3889# a_2019_3892.t2 a_25528_3889# VSS.t1852 sg13_lv_nmos ad=0.2516p pd=2.16u as=0.1406p ps=1.12u w=0.74u l=0.13u
X996 a_3171_3892.t1 a_2873_4240# VSS.t56 VSS.t678 sg13_lv_nmos ad=0.1406p pd=1.12u as=0.1331p ps=1.12u w=0.74u l=0.13u
X997 VDD.t687 a_22243_16869# a_22677_16869# VDD.t297 sg13_lv_pmos ad=0.2128p pd=1.5u as=0.3808p ps=2.92u w=1.12u l=0.13u
X998 VDD.t24 VSS.t1051 VDD.t23 VDD.t0 sg13_lv_pmos ad=0.34p pd=2.68u as=0 ps=0 w=1u l=1u
X999 VSS.t1135 a_2595_16074.t8 a_8231_16035# VSS.t1735 sg13_lv_nmos ad=0.2516p pd=2.16u as=0.2516p ps=2.16u w=0.74u l=0.13u
X1000 VSS.t102 a_2595_13229.t9 a_5191_13190# VSS.t1953 sg13_lv_nmos ad=0.2516p pd=2.16u as=0.2516p ps=2.16u w=0.74u l=0.13u
X1001 VSS.t56 a_2297_4240# a_2595_3892.t1 VSS.t57 sg13_lv_nmos ad=0.2812p pd=2.24u as=0.1406p ps=1.12u w=0.74u l=0.13u
X1002 a_19073_4687# a_18877_4687# VSS.t115 VSS.t114 sg13_lv_nmos ad=0.2516p pd=2.16u as=0.1406p ps=1.12u w=0.74u l=0.13u
X1003 a_9675_1044# a_9465_1044# VSS.t459 VSS.t458 sg13_lv_nmos ad=0.1406p pd=1.12u as=0.1665p ps=1.19u w=0.74u l=0.13u
X1004 VDD.t989 a_3171_3892.t2 a_27124_3853# VDD.t0 sg13_lv_pmos ad=0.3808p pd=2.92u as=0.3808p ps=2.92u w=1.12u l=0.13u
X1005 a_1815_6021# a_1256_5979# a_1721_6021# VSS.t127 sg13_lv_nmos ad=0.1216p pd=1.02u as=0.2176p ps=1.96u w=0.64u l=0.13u
X1006 VDD.t394 a_4187_2434# a_23871_8160# VDD.t275 sg13_lv_pmos ad=0.3808p pd=2.92u as=0.2128p ps=1.5u w=1.12u l=0.6u
X1007 VSS.t311 a_7477_7532# a_7945_6734# VSS.t2251 sg13_lv_nmos ad=0.1665p pd=1.19u as=0.2516p ps=2.16u w=0.74u l=0.13u
X1008 VSS.t1985 a_27563_1842# a_27997_1842# VSS.t2002 sg13_lv_nmos ad=0.1406p pd=1.12u as=0.2516p ps=2.16u w=0.74u l=0.13u
X1009 VDD.t1086 a_3747_16074.t5 a_18871_16035# VDD.t4 sg13_lv_pmos ad=0.3808p pd=2.92u as=0.3808p ps=2.92u w=1.12u l=0.13u
X1010 VDD.t946 a_3171_6737.t7 a_11924_6698# VDD.t41 sg13_lv_pmos ad=0.3808p pd=2.92u as=0.3808p ps=2.92u w=1.12u l=0.13u
X1011 a_20593_1842# a_20397_1842# VSS.t1150 VSS.t1863 sg13_lv_nmos ad=0.2516p pd=2.16u as=0.1406p ps=1.12u w=0.74u l=0.13u
X1012 VDD.t731 a_15964_5979# a_16851_5999# VDD.t41 sg13_lv_pmos ad=0.2086p pd=1.5u as=0.34p ps=2.68u w=1u l=0.13u
X1013 VSS.t560 a_2595_1047.t8 a_8231_1008# VSS.t559 sg13_lv_nmos ad=0.2516p pd=2.16u as=0.2516p ps=2.16u w=0.74u l=0.13u
X1014 a_19311_14024# a_19073_14024# a_19203_14024# VSS.t2089 sg13_lv_nmos ad=0.1406p pd=1.12u as=0.2516p ps=2.16u w=0.74u l=0.2u
X1015 VDD.t66 VSS.t959 VDD.t64 VDD.t41 sg13_lv_pmos ad=0.19p pd=1.38u as=0 ps=0 w=1u l=1u
X1016 VSS.t72 a_6283_1842# a_6717_1842# VSS.t71 sg13_lv_nmos ad=0.1406p pd=1.12u as=0.2516p ps=2.16u w=0.74u l=0.13u
X1017 a_10430_3889# a_11271_3853# a_11195_3889# VDD.t0 sg13_lv_pmos ad=0.3808p pd=2.92u as=0.2128p ps=1.5u w=1.12u l=0.13u
X1018 a_2391_4240# CHAN2_MUX_SEL0 a_2297_4240# VSS.t784 sg13_lv_nmos ad=0.1216p pd=1.02u as=0.2176p ps=1.96u w=0.64u l=0.13u
X1019 a_10430_1044# a_10404_1008# a_10328_1044# VDD.t7 sg13_lv_pmos ad=0.3808p pd=2.92u as=0.2128p ps=1.5u w=1.12u l=0.13u
X1020 a_23355_3889# a_23145_3889# VDD.t285 VDD.t0 sg13_lv_pmos ad=0.2128p pd=1.5u as=0.252p ps=1.57u w=1.12u l=0.13u
X1021 VSS.t56 a_1544_3889# a_1815_4240# VSS.t478 sg13_lv_nmos ad=0.1331p pd=1.12u as=0.1216p ps=1.02u w=0.64u l=0.13u
X1022 a_16108_5979# a_23945_6209# a_22590_6734# VDD.t41 sg13_lv_pmos ad=0.3808p pd=2.92u as=0.3808p ps=2.92u w=1.12u l=0.13u
X1023 a_13231_8160# a_12993_7532# a_13123_7532# VDD.t275 sg13_lv_pmos ad=0.2128p pd=1.5u as=0.3808p ps=2.92u w=1.12u l=0.2u
X1024 VDD.t1456 a_3171_16074.t6 a_14964_16035# VDD.t4 sg13_lv_pmos ad=0.3808p pd=2.92u as=0.3808p ps=2.92u w=1.12u l=0.13u
X1025 VSS.t497 a_19203_4687# a_19637_4687# VSS.t1190 sg13_lv_nmos ad=0.1406p pd=1.12u as=0.2516p ps=2.16u w=0.74u l=0.13u
X1026 a_16271_5315# a_16033_4687# a_16163_4687# VDD.t281 sg13_lv_pmos ad=0.2128p pd=1.5u as=0.3808p ps=2.92u w=1.12u l=0.2u
X1027 a_15108_11799# a_12849_11557# VDD.t270 VDD.t268 sg13_lv_pmos ad=79.8f pd=0.8u as=1.03698p ps=6.245u w=0.42u l=0.13u
X1028 VDD.t1059 a_3747_3892.t4 a_21911_3853# VDD.t0 sg13_lv_pmos ad=0.3808p pd=2.92u as=0.3808p ps=2.92u w=1.12u l=0.13u
X1029 a_8155_13226# a_7945_13226# VSS.t1256 VSS.t1255 sg13_lv_nmos ad=0.1406p pd=1.12u as=0.1665p ps=1.19u w=0.74u l=0.13u
X1030 a_5778_9057# a_6126_9506# a_6326_10280# VSS.t14 sg13_lv_nmos ad=0.68p pd=4.68u as=0.38p ps=2.38u w=2u l=1u
X1031 VDD.t455 a_4187_2434# a_26151_2470# VDD.t399 sg13_lv_pmos ad=0.3808p pd=2.92u as=0.2128p ps=1.5u w=1.12u l=0.6u
X1032 VDD.t489 a_14851_10872# a_15108_11015# VDD.t268 sg13_lv_pmos ad=0.2639p pd=1.81u as=79.8f ps=0.8u w=0.42u l=0.13u
X1033 a_17791_16869# a_17553_16869# a_17683_16869# VSS.t1342 sg13_lv_nmos ad=0.1406p pd=1.12u as=0.2516p ps=2.16u w=0.74u l=0.2u
X1034 VDD.t358 a_4187_2434# a_20071_14652# VDD.t301 sg13_lv_pmos ad=0.3808p pd=2.92u as=0.2128p ps=1.5u w=1.12u l=0.6u
X1035 VDD.t1225 CHAN1_MUX_SEL1 a_3449_13577# VDD.t50 sg13_lv_pmos ad=0.1918p pd=1.5u as=0.1596p ps=1.22u w=0.84u l=0.13u
X1036 a_7390_1044# a_8884_1008# a_8808_1044# VDD.t7 sg13_lv_pmos ad=0.3808p pd=2.92u as=0.2128p ps=1.5u w=1.12u l=0.13u
X1037 VDD.t1592 VSS.t909 VDD.t1590 VDD.t50 sg13_lv_pmos ad=0.19p pd=1.38u as=0 ps=0 w=1u l=1u
X1038 a_25630_6734# a_25604_6698# a_25528_6734# VDD.t41 sg13_lv_pmos ad=0.3808p pd=2.92u as=0.2128p ps=1.5u w=1.12u l=0.13u
X1039 a_9431_17497# a_9193_16869# a_9323_16869# VDD.t297 sg13_lv_pmos ad=0.2128p pd=1.5u as=0.3808p ps=2.92u w=1.12u l=0.2u
X1040 VSS.t452 a_4187_1764.t144 a_18551_16869# VSS.t2121 sg13_lv_nmos ad=0.2516p pd=2.16u as=0.1406p ps=1.12u w=0.74u l=0.6u
X1041 a_16793_7532# a_16597_7532# VSS.t602 VSS.t2261 sg13_lv_nmos ad=0.2516p pd=2.16u as=0.1406p ps=1.12u w=0.74u l=0.13u
X1042 VSS.t653 a_8563_4687# a_8997_4687# VSS.t652 sg13_lv_nmos ad=0.1406p pd=1.12u as=0.2516p ps=2.16u w=0.74u l=0.13u
X1043 a_12233_7532# a_12037_7532# VDD.t1440 VDD.t275 sg13_lv_pmos ad=0.3808p pd=2.92u as=0.2128p ps=1.5u w=1.12u l=0.13u
X1044 a_7911_7532# a_7673_7532# a_7803_7532# VSS.t37 sg13_lv_nmos ad=0.1406p pd=1.12u as=0.2516p ps=2.16u w=0.74u l=0.2u
X1045 VDD.t430 a_4187_2434# a_4871_2470# VDD.t399 sg13_lv_pmos ad=0.3808p pd=2.92u as=0.2128p ps=1.5u w=1.12u l=0.6u
X1046 VSS.t438 a_4187_1764.t53 a_13231_4687# VSS.t751 sg13_lv_nmos ad=0.2516p pd=2.16u as=0.1406p ps=1.12u w=0.74u l=0.6u
X1047 a_20968_3889# a_20397_4687# VDD.t574 VDD.t0 sg13_lv_pmos ad=0.2128p pd=1.5u as=0.3808p ps=2.92u w=1.12u l=0.13u
X1048 VDD.t594 CHAN2_MUX_SEL1 a_3449_4240# VDD.t0 sg13_lv_pmos ad=0.1918p pd=1.5u as=0.1596p ps=1.22u w=0.84u l=0.13u
X1049 VDD.t835 a_27563_16869# a_27997_16869# VDD.t297 sg13_lv_pmos ad=0.2128p pd=1.5u as=0.3808p ps=2.92u w=1.12u l=0.13u
X1050 a_13880_11982# a_14111_11568# a_13566_11525# VSS.t192 sg13_lv_nmos ad=0.2373p pd=1.97u as=79.8f ps=0.8u w=0.42u l=0.13u
X1051 a_13949_11604# a_13592_11561# VDD.t272 VDD.t268 sg13_lv_pmos ad=63f pd=0.72u as=0.1563p ps=1.22u w=0.42u l=0.13u
X1052 a_3747_15338.t0 a_3449_15358# VDD.t1306 VDD.t4 sg13_lv_pmos ad=0.2128p pd=1.5u as=0.1918p ps=1.5u w=1.12u l=0.13u
X1053 a_3449_331# CHAN3_MUX_SEL2 VDD.t1053 VDD.t7 sg13_lv_pmos ad=0.1596p pd=1.22u as=0.2856p ps=2.36u w=0.84u l=0.13u
X1054 a_3747_15338.t1 a_3449_15358# VSS.t1220 VSS.t1944 sg13_lv_nmos ad=0.1406p pd=1.12u as=0.1331p ps=1.12u w=0.74u l=0.13u
X1055 VSS.t614 a_23003_4687# a_23437_4687# VSS.t1424 sg13_lv_nmos ad=0.1406p pd=1.12u as=0.2516p ps=2.16u w=0.74u l=0.13u
X1056 a_20071_5315# a_19833_4687# a_19963_4687# VDD.t281 sg13_lv_pmos ad=0.2128p pd=1.5u as=0.3808p ps=2.92u w=1.12u l=0.2u
X1057 VDD.t343 a_4187_2434# a_4871_14652# VDD.t301 sg13_lv_pmos ad=0.3808p pd=2.92u as=0.2128p ps=1.5u w=1.12u l=0.6u
X1058 a_11910_11995# DLL_RESETN VSS.t200 VSS.t1205 sg13_lv_nmos ad=37.8f pd=0.6u as=79.8f ps=0.8u w=0.42u l=0.13u
X1059 VDD.t896 a_22243_14024# a_22677_14024# VDD.t301 sg13_lv_pmos ad=0.2128p pd=1.5u as=0.3808p ps=2.92u w=1.12u l=0.13u
X1060 VDD.t1029 a_14851_11918# a_15688_11557# VDD.t268 sg13_lv_pmos ad=0.2128p pd=1.5u as=0.3864p ps=2.93u w=1.12u l=0.13u
X1061 VSS.t245 a_21157_16869# a_21625_16071# VSS.t244 sg13_lv_nmos ad=0.1665p pd=1.19u as=0.2516p ps=2.16u w=0.74u l=0.13u
X1062 VDD.t1316 VSS.t1095 VDD.t1314 VDD.t7 sg13_lv_pmos ad=0.19p pd=1.38u as=0 ps=0 w=1u l=1u
X1063 a_19073_1842# a_18877_1842# VSS.t748 VSS.t1680 sg13_lv_nmos ad=0.2516p pd=2.16u as=0.1406p ps=1.12u w=0.74u l=0.13u
X1064 VDD.t866 a_2873_3176# a_3171_3156.t0 VDD.t0 sg13_lv_pmos ad=0.4256p pd=3u as=0.2128p ps=1.5u w=1.12u l=0.13u
X1065 VDD.t692 a_14643_4687# a_15077_4687# VDD.t281 sg13_lv_pmos ad=0.2128p pd=1.5u as=0.3808p ps=2.92u w=1.12u l=0.13u
X1066 a_9675_6734# a_9465_6734# VSS.t286 VSS.t285 sg13_lv_nmos ad=0.1406p pd=1.12u as=0.1665p ps=1.19u w=0.74u l=0.13u
X1067 VSS.t1455 a_27563_7532# a_27997_7532# VSS.t2135 sg13_lv_nmos ad=0.1406p pd=1.12u as=0.2516p ps=2.16u w=0.74u l=0.13u
X1068 VSS.t454 a_2019_16074.t4 a_19524_16035# VSS.t1482 sg13_lv_nmos ad=0.2516p pd=2.16u as=0.2516p ps=2.16u w=0.74u l=0.13u
X1069 a_20593_7532# a_20397_7532# VSS.t280 VSS.t1129 sg13_lv_nmos ad=0.2516p pd=2.16u as=0.1406p ps=1.12u w=0.74u l=0.13u
X1070 VDD.t954 a_15077_1842# a_15545_1044# VDD.t7 sg13_lv_pmos ad=0.252p pd=1.57u as=0.3808p ps=2.92u w=1.12u l=0.13u
X1071 VDD.t838 a_15964_3134# a_16851_3154# VDD.t0 sg13_lv_pmos ad=0.2086p pd=1.5u as=0.34p ps=2.68u w=1u l=0.13u
X1072 VSS.t505 a_2019_13229.t5 a_16484_13190# VSS.t1561 sg13_lv_nmos ad=0.2516p pd=2.16u as=0.2516p ps=2.16u w=0.74u l=0.13u
X1073 VSS.t718 a_2595_6737.t8 a_8231_6698# VSS.t717 sg13_lv_nmos ad=0.2516p pd=2.16u as=0.2516p ps=2.16u w=0.74u l=0.13u
X1074 a_16510_3889# a_2019_3892.t5 a_16408_3889# VSS.t1838 sg13_lv_nmos ad=0.2516p pd=2.16u as=0.1406p ps=1.12u w=0.74u l=0.13u
X1075 VDD.t251 VSS.t82 VDD.t249 VDD.t0 sg13_lv_pmos ad=0.19p pd=1.38u as=0 ps=0 w=1u l=1u
X1076 a_19550_1044# a_2019_1047.t4 a_19448_1044# VSS.t142 sg13_lv_nmos ad=0.2516p pd=2.16u as=0.1406p ps=1.12u w=0.74u l=0.13u
X1077 VDD.t78 VSS.t889 VDD.t76 VDD.t50 sg13_lv_pmos ad=0.19p pd=1.38u as=0 ps=0 w=1u l=1u
X1078 VSS.t264 a_6283_7532# a_6717_7532# VSS.t2240 sg13_lv_nmos ad=0.1406p pd=1.12u as=0.2516p ps=2.16u w=0.74u l=0.13u
X1079 VSS.t1115 VDD.t1610 VSS.t1113 VSS.t1114 sg13_lv_nmos ad=79.8f pd=0.8u as=0 ps=0 w=0.42u l=1u
X1080 VDD.t685 a_7803_16869# a_8237_16869# VDD.t297 sg13_lv_pmos ad=0.2128p pd=1.5u as=0.3808p ps=2.92u w=1.12u l=0.13u
X1081 VDD.t817 VDD.t815 VDD.t816 VDD.t399 sg13_lv_pmos ad=0.3808p pd=2.92u as=0 ps=0 w=1.12u l=0.6u
X1082 a_20831_17497# a_20593_16869# a_20723_16869# VDD.t297 sg13_lv_pmos ad=0.2128p pd=1.5u as=0.3808p ps=2.92u w=1.12u l=0.2u
X1083 VDD.t874 DLL_RESETN a_9946_11995# VDD.t268 sg13_lv_pmos ad=0.36237p pd=2.605u as=79.8f ps=0.8u w=0.42u l=0.13u
X1084 VDD.t1312 VSS.t1095 VDD.t20 VDD.t7 sg13_lv_pmos ad=0.19p pd=1.38u as=0 ps=0 w=1u l=1u
X1085 a_5731_5979# a_2595_6001.t3 a_7390_6734# VSS.t1936 sg13_lv_nmos ad=0.2516p pd=2.16u as=0.2516p ps=2.16u w=0.74u l=0.13u
X1086 a_16108_3134# a_23945_3364# a_22590_3889# VDD.t0 sg13_lv_pmos ad=0.3808p pd=2.92u as=0.3808p ps=2.92u w=1.12u l=0.13u
X1087 VSS.t402 a_3171_3892.t2 a_27124_3853# VSS.t1393 sg13_lv_nmos ad=0.2516p pd=2.16u as=0.2516p ps=2.16u w=0.74u l=0.13u
X1088 a_10951_14024# a_10713_14024# a_10843_14024# VSS.t1998 sg13_lv_nmos ad=0.1406p pd=1.12u as=0.2516p ps=2.16u w=0.74u l=0.2u
X1089 VDD.t955 a_19637_14024# a_20105_13226# VDD.t50 sg13_lv_pmos ad=0.252p pd=1.57u as=0.3808p ps=2.92u w=1.12u l=0.13u
X1090 VDD.t187 VSS.t899 VDD.t186 VDD.t50 sg13_lv_pmos ad=0.34p pd=2.68u as=0 ps=0 w=1u l=1u
X1091 VDD.t407 a_4187_2434# a_17791_5315# VDD.t281 sg13_lv_pmos ad=0.3808p pd=2.92u as=0.2128p ps=1.5u w=1.12u l=0.6u
X1092 a_15273_14024# a_15077_14024# VSS.t742 VSS.t2074 sg13_lv_nmos ad=0.2516p pd=2.16u as=0.1406p ps=1.12u w=0.74u l=0.13u
X1093 VSS.t1569 a_19203_1842# a_19637_1842# VSS.t1889 sg13_lv_nmos ad=0.1406p pd=1.12u as=0.2516p ps=2.16u w=0.74u l=0.13u
X1094 VSS.t1008 a_2595_3156.t3 a_8745_3364# VSS.t1493 sg13_lv_nmos ad=0.2516p pd=2.16u as=0.2516p ps=2.16u w=0.74u l=0.13u
X1095 VDD.t335 a_4187_2434# a_21591_17497# VDD.t297 sg13_lv_pmos ad=0.3808p pd=2.92u as=0.2128p ps=1.5u w=1.12u l=0.6u
X1096 a_2019_3156.t0 a_1721_3176# VDD.t836 VDD.t0 sg13_lv_pmos ad=0.2128p pd=1.5u as=0.1918p ps=1.5u w=1.12u l=0.13u
X1097 VDD.t396 a_4187_2434# a_26151_8160# VDD.t275 sg13_lv_pmos ad=0.3808p pd=2.92u as=0.2128p ps=1.5u w=1.12u l=0.6u
X1098 VDD.t1098 VSS.t1075 VDD.t1097 VDD.t7 sg13_lv_pmos ad=0.34p pd=2.68u as=0 ps=0 w=1u l=1u
X1099 VSS.t699 a_3747_16074.t3 a_24951_16035# VSS.t2159 sg13_lv_nmos ad=0.2516p pd=2.16u as=0.2516p ps=2.16u w=0.74u l=0.13u
X1100 VDD.t1070 a_3171_13229.t5 a_18004_13190# VDD.t50 sg13_lv_pmos ad=0.3808p pd=2.92u as=0.3808p ps=2.92u w=1.12u l=0.13u
X1101 VSS.t880 VDD.t1679 VSS.t878 VSS.t879 sg13_lv_nmos ad=0.1428p pd=1.52u as=0 ps=0 w=0.42u l=1u
X1102 VSS.t1270 a_3747_13229.t4 a_21911_13190# VSS.t1408 sg13_lv_nmos ad=0.2516p pd=2.16u as=0.2516p ps=2.16u w=0.74u l=0.13u
X1103 a_10430_3889# a_2595_3892.t7 a_11195_3889# VSS.t1386 sg13_lv_nmos ad=0.2516p pd=2.16u as=0.1406p ps=1.12u w=0.74u l=0.13u
X1104 a_15511_4687# a_15273_4687# a_15403_4687# VSS.t351 sg13_lv_nmos ad=0.1406p pd=1.12u as=0.2516p ps=2.16u w=0.74u l=0.2u
X1105 VSS.t894 a_3171_12493.t3 a_11785_12701# VSS.t2227 sg13_lv_nmos ad=0.2516p pd=2.16u as=0.2516p ps=2.16u w=0.74u l=0.13u
X1106 a_13470_1044# a_2595_1047.t6 a_14235_1044# VSS.t573 sg13_lv_nmos ad=0.2516p pd=2.16u as=0.1406p ps=1.12u w=0.74u l=0.13u
X1107 VDD.t1369 a_1256_289# a_2873_331# VDD.t7 sg13_lv_pmos ad=0.1918p pd=1.5u as=0.1596p ps=1.22u w=0.84u l=0.13u
X1108 a_27433_1842# a_27237_1842# VDD.t1254 VDD.t399 sg13_lv_pmos ad=0.3808p pd=2.92u as=0.2128p ps=1.5u w=1.12u l=0.13u
X1109 a_9431_14652# a_9193_14024# a_9323_14024# VDD.t301 sg13_lv_pmos ad=0.2128p pd=1.5u as=0.3808p ps=2.92u w=1.12u l=0.2u
X1110 VSS.t169 a_8563_1842# a_8997_1842# VSS.t1300 sg13_lv_nmos ad=0.1406p pd=1.12u as=0.2516p ps=2.16u w=0.74u l=0.13u
X1111 a_19448_3889# a_18877_4687# VDD.t479 VDD.t0 sg13_lv_pmos ad=0.2128p pd=1.5u as=0.3808p ps=2.92u w=1.12u l=0.13u
X1112 a_23355_3889# a_23145_3889# VSS.t46 VSS.t654 sg13_lv_nmos ad=0.1406p pd=1.12u as=0.1665p ps=1.19u w=0.74u l=0.13u
X1113 VDD.t381 a_4187_2434# a_4871_8160# VDD.t275 sg13_lv_pmos ad=0.3808p pd=2.92u as=0.2128p ps=1.5u w=1.12u l=0.6u
X1114 VDD.t705 a_2019_16074.t2 a_25604_16035# VDD.t4 sg13_lv_pmos ad=0.3808p pd=2.92u as=0.3808p ps=2.92u w=1.12u l=0.13u
X1115 a_3543_15358# CHAN0_MUX_SEL2 a_3449_15358# VSS.t651 sg13_lv_nmos ad=0.1216p pd=1.02u as=0.2176p ps=1.96u w=0.64u l=0.13u
X1116 VDD.t270 a_14009_10774# a_14111_10917# VDD.t268 sg13_lv_pmos ad=1.10612p pd=6.66u as=0.3864p ps=2.93u w=1.12u l=0.13u
X1117 a_10430_3889# a_11924_3853# a_11848_3889# VDD.t0 sg13_lv_pmos ad=0.3808p pd=2.92u as=0.2128p ps=1.5u w=1.12u l=0.13u
X1118 VSS.t1148 a_4187_1764.t21 a_13231_1842# VSS.t1147 sg13_lv_nmos ad=0.2516p pd=2.16u as=0.1406p ps=1.12u w=0.74u l=0.6u
X1119 VSS.t1182 a_3747_3892.t4 a_21911_3853# VSS.t1519 sg13_lv_nmos ad=0.2516p pd=2.16u as=0.2516p ps=2.16u w=0.74u l=0.13u
X1120 a_13753_16869# a_13557_16869# VSS.t305 VSS.t304 sg13_lv_nmos ad=0.2516p pd=2.16u as=0.1406p ps=1.12u w=0.74u l=0.13u
X1121 VSS.t855 VDD.t1686 VSS.t857 VSS.t856 sg13_lv_nmos ad=79.8f pd=0.8u as=0 ps=0 w=0.42u l=1u
X1122 VDD.t1286 a_4437_14024# a_4905_13226# VDD.t50 sg13_lv_pmos ad=0.252p pd=1.57u as=0.3808p ps=2.92u w=1.12u l=0.13u
X1123 VSS.t156 a_2019_1047.t3 a_22564_1008# VSS.t155 sg13_lv_nmos ad=0.2516p pd=2.16u as=0.2516p ps=2.16u w=0.74u l=0.13u
X1124 VDD.t586 a_3171_1047.t7 a_11924_1008# VDD.t7 sg13_lv_pmos ad=0.3808p pd=2.92u as=0.3808p ps=2.92u w=1.12u l=0.13u
X1125 VDD.t907 a_27563_14024# a_27997_14024# VDD.t301 sg13_lv_pmos ad=0.2128p pd=1.5u as=0.3808p ps=2.92u w=1.12u l=0.13u
X1126 a_16510_6734# a_16484_6698# a_16408_6734# VDD.t41 sg13_lv_pmos ad=0.3808p pd=2.92u as=0.2128p ps=1.5u w=1.12u l=0.13u
X1127 a_5393_16869# a_5197_16869# VDD.t920 VDD.t297 sg13_lv_pmos ad=0.3808p pd=2.92u as=0.2128p ps=1.5u w=1.12u l=0.13u
X1128 VDD.t424 a_4187_2434# a_21591_5315# VDD.t281 sg13_lv_pmos ad=0.3808p pd=2.92u as=0.2128p ps=1.5u w=1.12u l=0.6u
X1129 VSS.t1277 a_3747_16074.t8 a_9751_16035# VSS.t1500 sg13_lv_nmos ad=0.2516p pd=2.16u as=0.2516p ps=2.16u w=0.74u l=0.13u
X1130 VSS.t487 a_23003_1842# a_23437_1842# VSS.t1881 sg13_lv_nmos ad=0.1406p pd=1.12u as=0.2516p ps=2.16u w=0.74u l=0.13u
X1131 VSS.t1031 VDD.t1634 VSS.t1031 VSS.t1032 sg13_lv_nmos ad=0.1428p pd=1.52u as=0 ps=0 w=0.42u l=1u
X1132 VSS.t1948 a_3747_13229.t9 a_6711_13190# VSS.t1947 sg13_lv_nmos ad=0.2516p pd=2.16u as=0.2516p ps=2.16u w=0.74u l=0.13u
X1133 VSS.t2091 a_1721_12513# a_2019_12493.t1 VSS.t2297 sg13_lv_nmos ad=0.2812p pd=2.24u as=0.1406p ps=1.12u w=0.74u l=0.13u
X1134 VSS.t1115 VDD.t1609 VSS.t1115 VSS.t1116 sg13_lv_nmos ad=0.1428p pd=1.52u as=0 ps=0 w=0.42u l=1u
X1135 VSS.t1272 a_2595_16074.t9 a_5191_16035# VSS.t1632 sg13_lv_nmos ad=0.2516p pd=2.16u as=0.2516p ps=2.16u w=0.74u l=0.13u
X1136 a_19073_7532# a_18877_7532# VSS.t223 VSS.t695 sg13_lv_nmos ad=0.2516p pd=2.16u as=0.1406p ps=1.12u w=0.74u l=0.13u
X1137 VDD.t402 a_4187_2434# a_7151_2470# VDD.t399 sg13_lv_pmos ad=0.3808p pd=2.92u as=0.2128p ps=1.5u w=1.12u l=0.6u
X1138 a_20968_3889# a_20397_4687# VSS.t341 VSS.t340 sg13_lv_nmos ad=0.1406p pd=1.12u as=0.2516p ps=2.16u w=0.74u l=0.13u
X1139 VDD.t712 a_3171_6737.t2 a_27124_6698# VDD.t41 sg13_lv_pmos ad=0.3808p pd=2.92u as=0.3808p ps=2.92u w=1.12u l=0.13u
X1140 VSS.t363 a_16851_12491# CHAN1_MUX_OUT VSS.t644 sg13_lv_nmos ad=0.2516p pd=2.16u as=0.1406p ps=1.12u w=0.74u l=0.13u
X1141 VSS.t330 a_13883_4687# a_14317_4687# VSS.t615 sg13_lv_nmos ad=0.1406p pd=1.12u as=0.2516p ps=2.16u w=0.74u l=0.13u
X1142 a_11491_11918# a_10649_11568# a_11397_11918# VSS.t630 sg13_lv_nmos ad=0.12665p pd=1.145u as=0.1428p ps=1.52u w=0.42u l=0.13u
X1143 a_25630_3889# a_26471_3853# a_26395_3889# VDD.t0 sg13_lv_pmos ad=0.3808p pd=2.92u as=0.2128p ps=1.5u w=1.12u l=0.13u
X1144 a_19550_6734# a_2019_6737.t4 a_19448_6734# VSS.t737 sg13_lv_nmos ad=0.2516p pd=2.16u as=0.1406p ps=1.12u w=0.74u l=0.13u
X1145 a_16271_14024# a_16033_14024# a_16163_14024# VSS.t2042 sg13_lv_nmos ad=0.1406p pd=1.12u as=0.2516p ps=2.16u w=0.74u l=0.2u
X1146 a_25630_1044# a_25604_1008# a_25528_1044# VDD.t7 sg13_lv_pmos ad=0.3808p pd=2.92u as=0.2128p ps=1.5u w=1.12u l=0.13u
X1147 a_10430_6734# a_11271_6698# a_11195_6734# VDD.t41 sg13_lv_pmos ad=0.3808p pd=2.92u as=0.2128p ps=1.5u w=1.12u l=0.13u
X1148 VDD.t1090 a_2595_13229.t8 a_8231_13190# VDD.t50 sg13_lv_pmos ad=0.3808p pd=2.92u as=0.3808p ps=2.92u w=1.12u l=0.13u
X1149 VDD.t809 VDD.t807 VDD.t806 VDD.t281 sg13_lv_pmos ad=0.2128p pd=1.5u as=0 ps=0 w=1.12u l=0.2u
X1150 VDD.t1362 a_7803_14024# a_8237_14024# VDD.t301 sg13_lv_pmos ad=0.2128p pd=1.5u as=0.3808p ps=2.92u w=1.12u l=0.13u
X1151 VDD.t795 VDD.t793 VDD.t794 VDD.t275 sg13_lv_pmos ad=0.3808p pd=2.92u as=0 ps=0 w=1.12u l=0.6u
X1152 a_20831_14652# a_20593_14024# a_20723_14024# VDD.t301 sg13_lv_pmos ad=0.2128p pd=1.5u as=0.3808p ps=2.92u w=1.12u l=0.2u
X1153 VSS.t977 VDD.t1650 VSS.t976 VSS.t975 sg13_lv_nmos ad=0.1428p pd=1.52u as=0 ps=0 w=0.42u l=1u
X1154 VSS.t346 a_4187_1764.t114 a_17031_14024# VSS.t345 sg13_lv_nmos ad=0.2516p pd=2.16u as=0.1406p ps=1.12u w=0.74u l=0.6u
X1155 a_23355_6734# a_23145_6734# VDD.t601 VDD.t41 sg13_lv_pmos ad=0.2128p pd=1.5u as=0.252p ps=1.57u w=1.12u l=0.13u
X1156 a_9675_13226# a_9465_13226# VSS.t1404 VSS.t1403 sg13_lv_nmos ad=0.1406p pd=1.12u as=0.1665p ps=1.19u w=0.74u l=0.13u
X1157 VSS.t709 a_19203_7532# a_19637_7532# VSS.t1119 sg13_lv_nmos ad=0.1406p pd=1.12u as=0.2516p ps=2.16u w=0.74u l=0.13u
X1158 VDD.t1067 a_3171_16074.t7 a_11924_16035# VDD.t4 sg13_lv_pmos ad=0.3808p pd=2.92u as=0.3808p ps=2.92u w=1.12u l=0.13u
X1159 VDD.t1259 a_1544_15316# a_2297_15358# VDD.t4 sg13_lv_pmos ad=0.1918p pd=1.5u as=0.1596p ps=1.22u w=0.84u l=0.13u
X1160 VDD.t359 a_4187_2434# a_21591_14652# VDD.t301 sg13_lv_pmos ad=0.3808p pd=2.92u as=0.2128p ps=1.5u w=1.12u l=0.6u
X1161 VDD.t1196 a_3747_6737.t4 a_21911_6698# VDD.t41 sg13_lv_pmos ad=0.3808p pd=2.92u as=0.3808p ps=2.92u w=1.12u l=0.13u
X1162 a_8155_16071# a_7945_16071# VSS.t1156 VSS.t1155 sg13_lv_nmos ad=0.1406p pd=1.12u as=0.1665p ps=1.19u w=0.74u l=0.13u
X1163 VSS.t538 a_4003_4687# a_4437_4687# VSS.t2170 sg13_lv_nmos ad=0.1406p pd=1.12u as=0.2516p ps=2.16u w=0.74u l=0.13u
X1164 a_14851_10872# a_14009_10774# a_14757_10872# VSS.t1132 sg13_lv_nmos ad=0.12665p pd=1.145u as=0.1428p ps=1.52u w=0.42u l=0.13u
X1165 a_15511_1842# a_15273_1842# a_15403_1842# VSS.t1686 sg13_lv_nmos ad=0.1406p pd=1.12u as=0.2516p ps=2.16u w=0.74u l=0.2u
X1166 a_14751_16869# a_14513_16869# a_14643_16869# VSS.t1136 sg13_lv_nmos ad=0.1406p pd=1.12u as=0.2516p ps=2.16u w=0.74u l=0.2u
X1167 a_27433_7532# a_27237_7532# VDD.t519 VDD.t275 sg13_lv_pmos ad=0.3808p pd=2.92u as=0.2128p ps=1.5u w=1.12u l=0.13u
X1168 a_13470_6734# a_2595_6737.t6 a_14235_6734# VSS.t1660 sg13_lv_nmos ad=0.2516p pd=2.16u as=0.1406p ps=1.12u w=0.74u l=0.13u
X1169 VDD.t1496 a_10083_16869# a_10517_16869# VDD.t297 sg13_lv_pmos ad=0.2128p pd=1.5u as=0.3808p ps=2.92u w=1.12u l=0.13u
X1170 a_19073_16869# a_18877_16869# VSS.t452 VSS.t451 sg13_lv_nmos ad=0.2516p pd=2.16u as=0.1406p ps=1.12u w=0.74u l=0.13u
X1171 VSS.t289 a_8563_7532# a_8997_7532# VSS.t780 sg13_lv_nmos ad=0.1406p pd=1.12u as=0.2516p ps=2.16u w=0.74u l=0.13u
X1172 VDD.t1211 a_3747_6001.t3 a_14825_6209# VDD.t41 sg13_lv_pmos ad=0.3808p pd=2.92u as=0.3808p ps=2.92u w=1.12u l=0.13u
X1173 a_6391_17497# a_6153_16869# a_6283_16869# VDD.t297 sg13_lv_pmos ad=0.2128p pd=1.5u as=0.3808p ps=2.92u w=1.12u l=0.2u
X1174 VSS.t1470 a_9444_10280# a_9444_10280# VSS.t1466 sg13_lv_nmos ad=0.68p pd=4.68u as=0.38p ps=2.38u w=2u l=1u
X1175 a_3543_12513# CHAN1_MUX_SEL2 a_3449_12513# VSS.t2274 sg13_lv_nmos ad=0.1216p pd=1.02u as=0.2176p ps=1.96u w=0.64u l=0.13u
X1176 VSS.t1416 a_4187_1764.t85 a_13231_7532# VSS.t2321 sg13_lv_nmos ad=0.2516p pd=2.16u as=0.1406p ps=1.12u w=0.74u l=0.6u
X1177 VSS.t315 a_2019_6737.t3 a_22564_6698# VSS.t2216 sg13_lv_nmos ad=0.2516p pd=2.16u as=0.2516p ps=2.16u w=0.74u l=0.13u
X1178 a_20968_6734# a_20397_7532# VDD.t828 VDD.t41 sg13_lv_pmos ad=0.2128p pd=1.5u as=0.3808p ps=2.92u w=1.12u l=0.13u
X1179 VDD.t737 a_5957_4687# a_6425_3889# VDD.t0 sg13_lv_pmos ad=0.252p pd=1.57u as=0.3808p ps=2.92u w=1.12u l=0.13u
X1180 VDD.t104 VSS.t860 VDD.t200 VDD.t4 sg13_lv_pmos ad=0.34p pd=2.68u as=0 ps=0 w=1u l=1u
X1181 VSS.t1644 a_19203_14024# a_19637_14024# VSS.t2085 sg13_lv_nmos ad=0.1406p pd=1.12u as=0.2516p ps=2.16u w=0.74u l=0.13u
X1182 a_3171_6001.t0 a_2873_6021# VDD.t487 VDD.t41 sg13_lv_pmos ad=0.2128p pd=1.5u as=0.1918p ps=1.5u w=1.12u l=0.13u
X1183 VSS.t2364 VSS.t2364 VSS.t2366 VSS.t2365 sg13_lv_nmos ad=0.2516p pd=2.16u as=0 ps=0 w=0.74u l=0.13u
X1184 VSS.t1061 VDD.t1626 VSS.t1059 VSS.t1060 sg13_lv_nmos ad=79.8f pd=0.8u as=0 ps=0 w=0.42u l=1u
X1185 VDD.t325 a_4187_2434# a_7151_17497# VDD.t297 sg13_lv_pmos ad=0.3808p pd=2.92u as=0.2128p ps=1.5u w=1.12u l=0.6u
X1186 a_16510_13226# a_3171_13229.t5 a_17928_13226# VSS.t1587 sg13_lv_nmos ad=0.2516p pd=2.16u as=0.1406p ps=1.12u w=0.74u l=0.13u
X1187 a_5731_289# a_11785_519# a_10430_1044# VDD.t7 sg13_lv_pmos ad=0.3808p pd=2.92u as=0.3808p ps=2.92u w=1.12u l=0.13u
X1188 VDD.t889 a_24523_16869# a_24957_16869# VDD.t297 sg13_lv_pmos ad=0.2128p pd=1.5u as=0.3808p ps=2.92u w=1.12u l=0.13u
X1189 VSS.t2363 VSS.t2359 VSS.t2359 VSS.t2361 sg13_lv_nmos ad=0.1406p pd=1.12u as=0 ps=0 w=0.74u l=0.13u
X1190 a_18313_1842# a_18117_1842# VDD.t1298 VDD.t399 sg13_lv_pmos ad=0.3808p pd=2.92u as=0.2128p ps=1.5u w=1.12u l=0.13u
X1191 a_5393_14024# a_5197_14024# VDD.t1344 VDD.t301 sg13_lv_pmos ad=0.3808p pd=2.92u as=0.2128p ps=1.5u w=1.12u l=0.13u
X1192 VDD.t860 a_2297_6021# a_2595_6001.t0 VDD.t41 sg13_lv_pmos ad=0.4256p pd=3u as=0.2128p ps=1.5u w=1.12u l=0.13u
X1193 VDD.t270 a_12907_10876# a_12907_11110# VDD.t268 sg13_lv_pmos ad=1.10612p pd=6.66u as=0.2442p ps=2.06u w=0.66u l=0.13u
X1194 VSS.t194 a_23003_7532# a_23437_7532# VSS.t213 sg13_lv_nmos ad=0.1406p pd=1.12u as=0.2516p ps=2.16u w=0.74u l=0.13u
X1195 a_9431_2470# a_9193_1842# a_9323_1842# VDD.t399 sg13_lv_pmos ad=0.2128p pd=1.5u as=0.3808p ps=2.92u w=1.12u l=0.2u
X1196 a_17275_1044# a_17065_1044# VSS.t1675 VSS.t2149 sg13_lv_nmos ad=0.1406p pd=1.12u as=0.1665p ps=1.19u w=0.74u l=0.13u
X1197 a_19448_3889# a_18877_4687# VSS.t113 VSS.t112 sg13_lv_nmos ad=0.1406p pd=1.12u as=0.2516p ps=2.16u w=0.74u l=0.13u
X1198 VDD.t243 VSS.t776 VDD.t242 VDD.t7 sg13_lv_pmos ad=0.34p pd=2.68u as=0 ps=0 w=1u l=1u
X1199 a_10430_3889# a_3171_3892.t7 a_11848_3889# VSS.t1353 sg13_lv_nmos ad=0.2516p pd=2.16u as=0.1406p ps=1.12u w=0.74u l=0.13u
X1200 a_22873_4687# a_22677_4687# VDD.t286 VDD.t281 sg13_lv_pmos ad=0.3808p pd=2.92u as=0.2128p ps=1.5u w=1.12u l=0.13u
X1201 VDD.t378 a_4187_2434# a_7151_8160# VDD.t275 sg13_lv_pmos ad=0.3808p pd=2.92u as=0.2128p ps=1.5u w=1.12u l=0.6u
X1202 VSS.t1618 a_3747_1047.t6 a_15831_1008# VSS.t1617 sg13_lv_nmos ad=0.2516p pd=2.16u as=0.2516p ps=2.16u w=0.74u l=0.13u
X1203 VSS.t761 a_3747_311.t2 a_26985_519# VSS.t760 sg13_lv_nmos ad=0.2516p pd=2.16u as=0.2516p ps=2.16u w=0.74u l=0.13u
X1204 VSS.t483 a_2019_16074.t5 a_16484_16035# VSS.t591 sg13_lv_nmos ad=0.2516p pd=2.16u as=0.2516p ps=2.16u w=0.74u l=0.13u
X1205 a_5778_9057# VSS.t2253 VSS.t2252 rppd l=32u w=1u
X1206 VSS.t293 a_13883_1842# a_14317_1842# VSS.t1726 sg13_lv_nmos ad=0.1406p pd=1.12u as=0.2516p ps=2.16u w=0.74u l=0.13u
X1207 a_23871_2470# a_23633_1842# a_23763_1842# VDD.t399 sg13_lv_pmos ad=0.2128p pd=1.5u as=0.3808p ps=2.92u w=1.12u l=0.2u
X1208 VDD.t1233 a_2019_3892.t6 a_13444_3853# VDD.t0 sg13_lv_pmos ad=0.3808p pd=2.92u as=0.3808p ps=2.92u w=1.12u l=0.13u
X1209 a_8433_1842# a_8237_1842# VDD.t464 VDD.t399 sg13_lv_pmos ad=0.3808p pd=2.92u as=0.2128p ps=1.5u w=1.12u l=0.13u
X1210 VDD.t456 a_9323_16869# a_9757_16869# VDD.t297 sg13_lv_pmos ad=0.2128p pd=1.5u as=0.3808p ps=2.92u w=1.12u l=0.13u
X1211 VDD.t52 VSS.t589 VDD.t51 VDD.t50 sg13_lv_pmos ad=0.34p pd=2.68u as=0 ps=0 w=1u l=1u
X1212 VDD.t49 VSS.t977 VDD.t48 VDD.t41 sg13_lv_pmos ad=0.34p pd=2.68u as=0 ps=0 w=1u l=1u
X1213 VDD.t1118 a_18443_1842# a_18877_1842# VDD.t399 sg13_lv_pmos ad=0.2128p pd=1.5u as=0.3808p ps=2.92u w=1.12u l=0.13u
X1214 a_4350_1044# a_2019_1047.t9 a_4248_1044# VSS.t1412 sg13_lv_nmos ad=0.2516p pd=2.16u as=0.1406p ps=1.12u w=0.74u l=0.13u
X1215 a_7288_13226# a_6717_14024# VSS.t1948 VSS.t2005 sg13_lv_nmos ad=0.1406p pd=1.12u as=0.2516p ps=2.16u w=0.74u l=0.13u
X1216 a_25630_16071# a_27124_16035# a_27048_16071# VDD.t4 sg13_lv_pmos ad=0.3808p pd=2.92u as=0.2128p ps=1.5u w=1.12u l=0.13u
X1217 a_16793_14024# a_16597_14024# VSS.t1624 VSS.t2302 sg13_lv_nmos ad=0.2516p pd=2.16u as=0.1406p ps=1.12u w=0.74u l=0.13u
X1218 VDD.t959 a_21157_14024# a_21625_13226# VDD.t50 sg13_lv_pmos ad=0.252p pd=1.57u as=0.3808p ps=2.92u w=1.12u l=0.13u
X1219 a_14888_1044# a_14317_1842# VSS.t575 VSS.t1709 sg13_lv_nmos ad=0.1406p pd=1.12u as=0.2516p ps=2.16u w=0.74u l=0.13u
X1220 VDD.t208 VSS.t839 VDD.t206 VDD.t4 sg13_lv_pmos ad=0.19p pd=1.38u as=0 ps=0 w=1u l=1u
X1221 a_22113_1842# a_21917_1842# VDD.t1252 VDD.t399 sg13_lv_pmos ad=0.3808p pd=2.92u as=0.2128p ps=1.5u w=1.12u l=0.13u
X1222 a_10951_4687# a_10713_4687# a_10843_4687# VSS.t393 sg13_lv_nmos ad=0.1406p pd=1.12u as=0.2516p ps=2.16u w=0.74u l=0.2u
X1223 a_22113_16869# a_21917_16869# VDD.t833 VDD.t297 sg13_lv_pmos ad=0.3808p pd=2.92u as=0.2128p ps=1.5u w=1.12u l=0.13u
X1224 VDD.t1064 a_2019_13229.t4 a_19524_13190# VDD.t50 sg13_lv_pmos ad=0.3808p pd=2.92u as=0.3808p ps=2.92u w=1.12u l=0.13u
X1225 a_12233_14024# a_12037_14024# VSS.t1648 VSS.t1995 sg13_lv_nmos ad=0.2516p pd=2.16u as=0.1406p ps=1.12u w=0.74u l=0.13u
X1226 VDD.t76 VSS.t889 VDD.t75 VDD.t50 sg13_lv_pmos ad=0.34p pd=2.68u as=0 ps=0 w=1u l=1u
X1227 a_16108_289# a_3747_311.t2 a_25630_1044# VSS.t759 sg13_lv_nmos ad=0.2516p pd=2.16u as=0.2516p ps=2.16u w=0.74u l=0.13u
X1228 VSS.t181 a_2595_13229.t3 a_23431_13190# VSS.t180 sg13_lv_nmos ad=0.2516p pd=2.16u as=0.2516p ps=2.16u w=0.74u l=0.13u
X1229 VDD.t1415 a_1544_12471# a_2297_12513# VDD.t50 sg13_lv_pmos ad=0.1918p pd=1.5u as=0.1596p ps=1.22u w=0.84u l=0.13u
X1230 a_16510_1044# a_16484_1008# a_16408_1044# VDD.t7 sg13_lv_pmos ad=0.3808p pd=2.92u as=0.2128p ps=1.5u w=1.12u l=0.13u
X1231 VSS.t746 a_4003_1842# a_4437_1842# VSS.t1197 sg13_lv_nmos ad=0.1406p pd=1.12u as=0.2516p ps=2.16u w=0.74u l=0.13u
X1232 a_25630_3889# a_2595_3892.t2 a_26395_3889# VSS.t1844 sg13_lv_nmos ad=0.2516p pd=2.16u as=0.1406p ps=1.12u w=0.74u l=0.13u
X1233 VDD.t202 VSS.t827 VDD.t58 VDD.t4 sg13_lv_pmos ad=0.19p pd=1.38u as=0 ps=0 w=1u l=1u
X1234 VSS.t138 a_3747_16074.t4 a_21911_16035# VSS.t137 sg13_lv_nmos ad=0.2516p pd=2.16u as=0.2516p ps=2.16u w=0.74u l=0.13u
X1235 a_15511_7532# a_15273_7532# a_15403_7532# VSS.t13 sg13_lv_nmos ad=0.1406p pd=1.12u as=0.2516p ps=2.16u w=0.74u l=0.2u
X1236 VDD.t401 a_4187_2434# a_12471_2470# VDD.t399 sg13_lv_pmos ad=0.3808p pd=2.92u as=0.2128p ps=1.5u w=1.12u l=0.6u
X1237 a_7390_13226# a_2595_13229.t8 a_8155_13226# VSS.t1637 sg13_lv_nmos ad=0.2516p pd=2.16u as=0.1406p ps=1.12u w=0.74u l=0.13u
X1238 VSS.t948 VDD.t1658 VSS.t948 VSS.t950 sg13_lv_nmos ad=79.8f pd=0.8u as=0 ps=0 w=0.42u l=1u
X1239 VDD.t1364 a_10083_14024# a_10517_14024# VDD.t301 sg13_lv_pmos ad=0.2128p pd=1.5u as=0.3808p ps=2.92u w=1.12u l=0.13u
X1240 a_19448_6734# a_18877_7532# VDD.t704 VDD.t41 sg13_lv_pmos ad=0.2128p pd=1.5u as=0.3808p ps=2.92u w=1.12u l=0.13u
X1241 VDD.t466 a_3747_3156.t3 a_14825_3364# VDD.t0 sg13_lv_pmos ad=0.3808p pd=2.92u as=0.3808p ps=2.92u w=1.12u l=0.13u
X1242 a_5115_16071# a_4905_16071# VDD.t1107 VDD.t4 sg13_lv_pmos ad=0.2128p pd=1.5u as=0.252p ps=1.57u w=1.12u l=0.13u
X1243 a_3747_13229.t0 a_3449_13577# VDD.t1225 VDD.t50 sg13_lv_pmos ad=0.2128p pd=1.5u as=0.1918p ps=1.5u w=1.12u l=0.13u
X1244 a_10430_6734# a_11924_6698# a_11848_6734# VDD.t41 sg13_lv_pmos ad=0.3808p pd=2.92u as=0.2128p ps=1.5u w=1.12u l=0.13u
X1245 VDD.t652 a_3171_1047.t2 a_27124_1008# VDD.t7 sg13_lv_pmos ad=0.3808p pd=2.92u as=0.3808p ps=2.92u w=1.12u l=0.13u
X1246 VDD.t487 a_1256_5979# a_2873_6021# VDD.t41 sg13_lv_pmos ad=0.1918p pd=1.5u as=0.1596p ps=1.22u w=0.84u l=0.13u
X1247 a_6391_14652# a_6153_14024# a_6283_14024# VDD.t301 sg13_lv_pmos ad=0.2128p pd=1.5u as=0.3808p ps=2.92u w=1.12u l=0.2u
X1248 a_4248_3889# a_4157_4158# VDD.t1019 VDD.t0 sg13_lv_pmos ad=0.2128p pd=1.5u as=0.3808p ps=2.92u w=1.12u l=0.13u
X1249 VDD.t1257 a_1256_15316# a_2873_15358# VDD.t4 sg13_lv_pmos ad=0.1918p pd=1.5u as=0.1596p ps=1.22u w=0.84u l=0.13u
X1250 VDD.t1290 a_22243_1842# a_22677_1842# VDD.t399 sg13_lv_pmos ad=0.2128p pd=1.5u as=0.3808p ps=2.92u w=1.12u l=0.13u
X1251 a_6913_16869# a_6717_16869# VDD.t550 VDD.t297 sg13_lv_pmos ad=0.3808p pd=2.92u as=0.2128p ps=1.5u w=1.12u l=0.13u
X1252 VDD.t634 a_3747_13229.t3 a_24951_13190# VDD.t50 sg13_lv_pmos ad=0.3808p pd=2.92u as=0.3808p ps=2.92u w=1.12u l=0.13u
X1253 a_3171_3156.t1 a_2873_3176# VSS.t34 VSS.t493 sg13_lv_nmos ad=0.1406p pd=1.12u as=0.1331p ps=1.12u w=0.74u l=0.13u
X1254 VDD.t342 a_4187_2434# a_7151_14652# VDD.t301 sg13_lv_pmos ad=0.3808p pd=2.92u as=0.2128p ps=1.5u w=1.12u l=0.6u
X1255 VDD.t903 a_24523_14024# a_24957_14024# VDD.t301 sg13_lv_pmos ad=0.2128p pd=1.5u as=0.3808p ps=2.92u w=1.12u l=0.13u
X1256 VDD.t185 VSS.t899 VDD.t141 VDD.t50 sg13_lv_pmos ad=0.19p pd=1.38u as=0 ps=0 w=1u l=1u
X1257 a_10206_11525# a_10649_11568# a_10589_11604# VDD.t268 sg13_lv_pmos ad=79.8f pd=0.8u as=63f ps=0.72u w=0.42u l=0.13u
X1258 a_18313_7532# a_18117_7532# VDD.t520 VDD.t275 sg13_lv_pmos ad=0.3808p pd=2.92u as=0.2128p ps=1.5u w=1.12u l=0.13u
X1259 a_2595_311.t0 a_2297_331# VDD.t1359 VDD.t7 sg13_lv_pmos ad=0.2128p pd=1.5u as=0.1918p ps=1.5u w=1.12u l=0.13u
X1260 VDD.t1042 CHAN3_MUX_SEL3 a_3449_331# VDD.t7 sg13_lv_pmos ad=0.1918p pd=1.5u as=0.1596p ps=1.22u w=0.84u l=0.13u
X1261 VDD.t736 a_13019_11521# a_12943_11557# VDD.t268 sg13_lv_pmos ad=0.2128p pd=1.5u as=0.2128p ps=1.5u w=1.12u l=0.13u
X1262 a_9431_8160# a_9193_7532# a_9323_7532# VDD.t275 sg13_lv_pmos ad=0.2128p pd=1.5u as=0.3808p ps=2.92u w=1.12u l=0.2u
X1263 a_10430_1044# a_11271_1008# a_11195_1044# VDD.t7 sg13_lv_pmos ad=0.3808p pd=2.92u as=0.2128p ps=1.5u w=1.12u l=0.13u
X1264 VDD.t151 VSS.t849 VDD.t150 VDD.t4 sg13_lv_pmos ad=0.19p pd=1.38u as=0 ps=0 w=1u l=1u
X1265 VSS.t1144 a_2297_3176# a_2595_3156.t1 VSS.t1159 sg13_lv_nmos ad=0.2812p pd=2.24u as=0.1406p ps=1.12u w=0.74u l=0.13u
X1266 VSS.t497 a_4187_1764.t45 a_19311_4687# VSS.t496 sg13_lv_nmos ad=0.2516p pd=2.16u as=0.1406p ps=1.12u w=0.74u l=0.6u
X1267 VSS.t405 a_3747_16074.t9 a_6711_16035# VSS.t404 sg13_lv_nmos ad=0.2516p pd=2.16u as=0.2516p ps=2.16u w=0.74u l=0.13u
X1268 a_26395_13226# a_26185_13226# VSS.t673 VSS.t672 sg13_lv_nmos ad=0.1406p pd=1.12u as=0.1665p ps=1.19u w=0.74u l=0.13u
X1269 a_17275_6734# a_17065_6734# VSS.t536 VSS.t535 sg13_lv_nmos ad=0.1406p pd=1.12u as=0.1665p ps=1.19u w=0.74u l=0.13u
X1270 VSS.t1463 a_9444_10280# a_9444_10280# VSS.t1462 sg13_lv_nmos ad=0.68p pd=4.68u as=0.38p ps=2.38u w=2u l=1u
X1271 a_23355_1044# a_23145_1044# VDD.t993 VDD.t7 sg13_lv_pmos ad=0.2128p pd=1.5u as=0.252p ps=1.57u w=1.12u l=0.13u
X1272 a_19550_3889# a_21911_3853# a_21835_3889# VDD.t0 sg13_lv_pmos ad=0.3808p pd=2.92u as=0.2128p ps=1.5u w=1.12u l=0.13u
X1273 VSS.t259 a_2873_13577# a_3171_13229.t1 VSS.t260 sg13_lv_nmos ad=0.2812p pd=2.24u as=0.1406p ps=1.12u w=0.74u l=0.13u
X1274 VSS.t321 a_3747_6737.t6 a_15831_6698# VSS.t1773 sg13_lv_nmos ad=0.2516p pd=2.16u as=0.2516p ps=2.16u w=0.74u l=0.13u
X1275 VSS.t804 a_5957_4687# a_6425_3889# VSS.t803 sg13_lv_nmos ad=0.1665p pd=1.19u as=0.2516p ps=2.16u w=0.74u l=0.13u
X1276 VSS.t885 VDD.t1677 VSS.t586 VSS.t884 sg13_lv_nmos ad=0.1428p pd=1.52u as=0 ps=0 w=0.42u l=1u
X1277 a_10649_11568# REF_CLK VSS.t510 VSS.t2131 sg13_lv_nmos ad=0.2516p pd=2.16u as=1.9998p ps=12.915u w=0.74u l=0.13u
X1278 VDD.t1076 a_3747_1047.t4 a_21911_1008# VDD.t7 sg13_lv_pmos ad=0.3808p pd=2.92u as=0.3808p ps=2.92u w=1.12u l=0.13u
X1279 VSS.t459 a_8997_1842# a_9465_1044# VSS.t1238 sg13_lv_nmos ad=0.1665p pd=1.19u as=0.2516p ps=2.16u w=0.74u l=0.13u
X1280 a_17791_14024# a_17553_14024# a_17683_14024# VSS.t2078 sg13_lv_nmos ad=0.1406p pd=1.12u as=0.2516p ps=2.16u w=0.74u l=0.2u
X1281 a_23871_8160# a_23633_7532# a_23763_7532# VDD.t275 sg13_lv_pmos ad=0.2128p pd=1.5u as=0.3808p ps=2.92u w=1.12u l=0.2u
X1282 VSS.t552 a_13883_7532# a_14317_7532# VSS.t1122 sg13_lv_nmos ad=0.1406p pd=1.12u as=0.2516p ps=2.16u w=0.74u l=0.13u
X1283 a_1721_3176# a_1256_3134# VDD.t706 VDD.t0 sg13_lv_pmos ad=0.1596p pd=1.22u as=0.2856p ps=2.36u w=0.84u l=0.13u
X1284 a_8433_7532# a_8237_7532# VDD.t743 VDD.t275 sg13_lv_pmos ad=0.3808p pd=2.92u as=0.2128p ps=1.5u w=1.12u l=0.13u
X1285 a_25630_6734# a_26471_6698# a_26395_6734# VDD.t41 sg13_lv_pmos ad=0.3808p pd=2.92u as=0.2128p ps=1.5u w=1.12u l=0.13u
X1286 a_23111_17497# a_22873_16869# a_23003_16869# VDD.t297 sg13_lv_pmos ad=0.2128p pd=1.5u as=0.3808p ps=2.92u w=1.12u l=0.2u
X1287 VDD.t1349 a_9323_14024# a_9757_14024# VDD.t301 sg13_lv_pmos ad=0.2128p pd=1.5u as=0.3808p ps=2.92u w=1.12u l=0.13u
X1288 VDD.t1461 a_3747_13229.t8 a_9751_13190# VDD.t50 sg13_lv_pmos ad=0.3808p pd=2.92u as=0.3808p ps=2.92u w=1.12u l=0.13u
X1289 VSS.t317 a_4187_1764.t58 a_9431_4687# VSS.t2223 sg13_lv_nmos ad=0.2516p pd=2.16u as=0.1406p ps=1.12u w=0.74u l=0.6u
X1290 VDD.t523 a_18443_7532# a_18877_7532# VDD.t275 sg13_lv_pmos ad=0.2128p pd=1.5u as=0.3808p ps=2.92u w=1.12u l=0.13u
X1291 VDD.t237 VSS.t1039 VDD.t266 VDD.t0 sg13_lv_pmos ad=0.34p pd=2.68u as=0 ps=0 w=1u l=1u
X1292 VSS.t1646 a_4187_1764.t112 a_18551_14024# VSS.t1645 sg13_lv_nmos ad=0.2516p pd=2.16u as=0.1406p ps=1.12u w=0.74u l=0.6u
X1293 a_4350_6734# a_2019_6737.t9 a_4248_6734# VSS.t733 sg13_lv_nmos ad=0.2516p pd=2.16u as=0.1406p ps=1.12u w=0.74u l=0.13u
X1294 a_22113_7532# a_21917_7532# VDD.t557 VDD.t275 sg13_lv_pmos ad=0.3808p pd=2.92u as=0.2128p ps=1.5u w=1.12u l=0.13u
X1295 a_14888_6734# a_14317_7532# VSS.t1248 VSS.t1247 sg13_lv_nmos ad=0.1406p pd=1.12u as=0.2516p ps=2.16u w=0.74u l=0.13u
X1296 VDD.t1310 a_2595_13229.t9 a_5191_13190# VDD.t50 sg13_lv_pmos ad=0.3808p pd=2.92u as=0.3808p ps=2.92u w=1.12u l=0.13u
X1297 VDD.t70 VSS.t907 VDD.t69 VDD.t50 sg13_lv_pmos ad=0.19p pd=1.38u as=0 ps=0 w=1u l=1u
X1298 VDD.t1088 a_2019_16074.t6 a_13444_16035# VDD.t4 sg13_lv_pmos ad=0.3808p pd=2.92u as=0.3808p ps=2.92u w=1.12u l=0.13u
X1299 a_20968_1044# a_20397_1842# VDD.t1248 VDD.t7 sg13_lv_pmos ad=0.2128p pd=1.5u as=0.3808p ps=2.92u w=1.12u l=0.13u
X1300 a_25153_4687# a_24957_4687# VDD.t503 VDD.t281 sg13_lv_pmos ad=0.3808p pd=2.92u as=0.2128p ps=1.5u w=1.12u l=0.13u
X1301 a_9675_16071# a_9465_16071# VSS.t300 VSS.t1780 sg13_lv_nmos ad=0.1406p pd=1.12u as=0.1665p ps=1.19u w=0.74u l=0.13u
X1302 VDD.t272 a_12849_11557# a_13566_11525# VDD.t268 sg13_lv_pmos ad=0.1563p pd=1.22u as=0.147p ps=1.54u w=0.42u l=0.13u
X1303 a_10951_1842# a_10713_1842# a_10843_1842# VSS.t1757 sg13_lv_nmos ad=0.1406p pd=1.12u as=0.2516p ps=2.16u w=0.74u l=0.2u
X1304 VDD.t285 a_22677_4687# a_23145_3889# VDD.t0 sg13_lv_pmos ad=0.252p pd=1.57u as=0.3808p ps=2.92u w=1.12u l=0.13u
X1305 VSS.t614 a_4187_1764.t40 a_23111_4687# VSS.t613 sg13_lv_nmos ad=0.2516p pd=2.16u as=0.1406p ps=1.12u w=0.74u l=0.6u
X1306 a_22113_14024# a_21917_14024# VDD.t1218 VDD.t301 sg13_lv_pmos ad=0.3808p pd=2.92u as=0.2128p ps=1.5u w=1.12u l=0.13u
X1307 a_6635_13226# a_6425_13226# VSS.t1502 VSS.t1501 sg13_lv_nmos ad=0.1406p pd=1.12u as=0.1665p ps=1.19u w=0.74u l=0.13u
X1308 VSS.t273 a_2019_3892.t6 a_13444_3853# VSS.t1833 sg13_lv_nmos ad=0.2516p pd=2.16u as=0.2516p ps=2.16u w=0.74u l=0.13u
X1309 VSS.t1152 a_4003_7532# a_4437_7532# VSS.t1191 sg13_lv_nmos ad=0.1406p pd=1.12u as=0.2516p ps=2.16u w=0.74u l=0.13u
X1310 VSS.t141 a_2019_1047.t5 a_16484_1008# VSS.t140 sg13_lv_nmos ad=0.2516p pd=2.16u as=0.2516p ps=2.16u w=0.74u l=0.13u
X1311 VDD.t88 VSS.t948 VDD.t87 VDD.t41 sg13_lv_pmos ad=0.19p pd=1.38u as=0 ps=0 w=1u l=1u
X1312 a_26151_2470# a_25913_1842# a_26043_1842# VDD.t399 sg13_lv_pmos ad=0.2128p pd=1.5u as=0.3808p ps=2.92u w=1.12u l=0.2u
X1313 VDD.t373 a_4187_2434# a_12471_8160# VDD.t275 sg13_lv_pmos ad=0.3808p pd=2.92u as=0.2128p ps=1.5u w=1.12u l=0.6u
X1314 VDD.t1383 a_1721_331# a_2019_311.t0 VDD.t7 sg13_lv_pmos ad=0.4256p pd=3u as=0.2128p ps=1.5u w=1.12u l=0.13u
X1315 a_7911_17497# a_7673_16869# a_7803_16869# VDD.t297 sg13_lv_pmos ad=0.2128p pd=1.5u as=0.3808p ps=2.92u w=1.12u l=0.2u
X1316 a_16033_16869# a_15837_16869# VSS.t481 VSS.t480 sg13_lv_nmos ad=0.2516p pd=2.16u as=0.1406p ps=1.12u w=0.74u l=0.13u
X1317 a_13753_1842# a_13557_1842# VDD.t1197 VDD.t399 sg13_lv_pmos ad=0.3808p pd=2.92u as=0.2128p ps=1.5u w=1.12u l=0.13u
X1318 VSS.t932 VDD.t1662 VSS.t935 VSS.t934 sg13_lv_nmos ad=79.8f pd=0.8u as=0 ps=0 w=0.42u l=1u
X1319 VSS.t1085 VDD.t1618 VSS.t1085 VSS.t1087 sg13_lv_nmos ad=79.8f pd=0.8u as=0 ps=0 w=0.42u l=1u
X1320 VSS.t572 a_3171_1047.t9 a_5844_1008# VSS.t571 sg13_lv_nmos ad=0.2516p pd=2.16u as=0.2516p ps=2.16u w=0.74u l=0.13u
X1321 a_4871_2470# a_4633_1842# a_4763_1842# VDD.t399 sg13_lv_pmos ad=0.2128p pd=1.5u as=0.3808p ps=2.92u w=1.12u l=0.2u
X1322 VDD.t320 a_4187_2434# a_8671_17497# VDD.t297 sg13_lv_pmos ad=0.3808p pd=2.92u as=0.2128p ps=1.5u w=1.12u l=0.6u
X1323 a_19550_13226# a_2019_13229.t4 a_19448_13226# VSS.t1562 sg13_lv_nmos ad=0.2516p pd=2.16u as=0.1406p ps=1.12u w=0.74u l=0.13u
X1324 VDD.t1427 a_1256_12471# a_2873_12513# VDD.t50 sg13_lv_pmos ad=0.1918p pd=1.5u as=0.1596p ps=1.22u w=0.84u l=0.13u
X1325 VDD.t600 a_22243_7532# a_22677_7532# VDD.t275 sg13_lv_pmos ad=0.2128p pd=1.5u as=0.3808p ps=2.92u w=1.12u l=0.13u
X1326 VDD.t722 a_2595_311.t2 a_20905_519# VDD.t7 sg13_lv_pmos ad=0.3808p pd=2.92u as=0.3808p ps=2.92u w=1.12u l=0.13u
X1327 VDD.t931 a_26043_16869# a_26477_16869# VDD.t297 sg13_lv_pmos ad=0.2128p pd=1.5u as=0.3808p ps=2.92u w=1.12u l=0.13u
X1328 VDD.t276 a_5957_7532# a_6425_6734# VDD.t41 sg13_lv_pmos ad=0.252p pd=1.57u as=0.3808p ps=2.92u w=1.12u l=0.13u
X1329 VDD.t1360 a_2297_331# a_2595_311.t0 VDD.t7 sg13_lv_pmos ad=0.4256p pd=3u as=0.2128p ps=1.5u w=1.12u l=0.13u
X1330 VDD.t1302 a_2595_6001.t3 a_8745_6209# VDD.t41 sg13_lv_pmos ad=0.3808p pd=2.92u as=0.3808p ps=2.92u w=1.12u l=0.13u
X1331 a_16510_16071# a_3171_16074.t5 a_17928_16071# VSS.t2057 sg13_lv_nmos ad=0.2516p pd=2.16u as=0.1406p ps=1.12u w=0.74u l=0.13u
X1332 a_6913_14024# a_6717_14024# VDD.t1353 VDD.t301 sg13_lv_pmos ad=0.3808p pd=2.92u as=0.2128p ps=1.5u w=1.12u l=0.13u
X1333 a_8155_13226# a_7945_13226# VDD.t911 VDD.t50 sg13_lv_pmos ad=0.2128p pd=1.5u as=0.252p ps=1.57u w=1.12u l=0.13u
X1334 VSS.t1044 VDD.t1630 VSS.t1044 VSS.t1046 sg13_lv_nmos ad=0.1428p pd=1.52u as=0 ps=0 w=0.42u l=1u
X1335 VSS.t2352 VSS.t2350 VSS.t2350 VSS.t2351 sg13_lv_nmos ad=0.68p pd=4.68u as=0 ps=0 w=2u l=1u
X1336 VSS.t563 a_2595_1047.t7 a_11271_1008# VSS.t562 sg13_lv_nmos ad=0.2516p pd=2.16u as=0.2516p ps=2.16u w=0.74u l=0.13u
X1337 VSS.t1569 a_4187_1764.t13 a_19311_1842# VSS.t1568 sg13_lv_nmos ad=0.2516p pd=2.16u as=0.1406p ps=1.12u w=0.74u l=0.6u
X1338 a_5731_3134# a_2595_3156.t3 a_7390_3889# VSS.t1492 sg13_lv_nmos ad=0.2516p pd=2.16u as=0.2516p ps=2.16u w=0.74u l=0.13u
X1339 VSS.t1049 VDD.t1629 VSS.t2 VSS.t1048 sg13_lv_nmos ad=0.1428p pd=1.52u as=0 ps=0 w=0.42u l=1u
X1340 a_3171_6737.t0 a_2873_7085# VDD.t852 VDD.t41 sg13_lv_pmos ad=0.2128p pd=1.5u as=0.1918p ps=1.5u w=1.12u l=0.13u
X1341 a_4248_3889# a_4157_4158# VSS.t1450 VSS.t1449 sg13_lv_nmos ad=0.1406p pd=1.12u as=0.2516p ps=2.16u w=0.74u l=0.13u
X1342 a_1815_13577# a_1256_13226# a_1721_13577# VSS.t1896 sg13_lv_nmos ad=0.1216p pd=1.02u as=0.2176p ps=1.96u w=0.64u l=0.13u
X1343 VSS.t286 a_8997_7532# a_9465_6734# VSS.t287 sg13_lv_nmos ad=0.1665p pd=1.19u as=0.2516p ps=2.16u w=0.74u l=0.13u
X1344 VDD.t909 a_2297_7085# a_2595_6737.t0 VDD.t41 sg13_lv_pmos ad=0.4256p pd=3u as=0.2128p ps=1.5u w=1.12u l=0.13u
X1345 VDD.t1275 a_24523_1842# a_24957_1842# VDD.t399 sg13_lv_pmos ad=0.2128p pd=1.5u as=0.3808p ps=2.92u w=1.12u l=0.13u
X1346 VSS.t278 a_4763_16869# a_5197_16869# VSS.t1736 sg13_lv_nmos ad=0.1406p pd=1.12u as=0.2516p ps=2.16u w=0.74u l=0.13u
X1347 VDD.t1507 a_2019_6737.t6 a_13444_6698# VDD.t41 sg13_lv_pmos ad=0.3808p pd=2.92u as=0.3808p ps=2.92u w=1.12u l=0.13u
X1348 a_15270_10795# a_12849_11557# VSS.t6 VSS.t5 sg13_lv_nmos ad=37.8f pd=0.6u as=79.8f ps=0.8u w=0.42u l=0.13u
X1349 VSS.t159 a_3747_1047.t8 a_9751_1008# VSS.t158 sg13_lv_nmos ad=0.2516p pd=2.16u as=0.2516p ps=2.16u w=0.74u l=0.13u
X1350 VSS.t284 a_12907_10876# a_12907_10876# VSS.t2066 sg13_lv_nmos ad=1.45407p pd=9.445u as=0.111p ps=1.34u w=0.3u l=0.13u
X1351 a_8808_13226# a_8237_14024# VSS.t1592 VSS.t2017 sg13_lv_nmos ad=0.1406p pd=1.12u as=0.2516p ps=2.16u w=0.74u l=0.13u
X1352 a_23111_14652# a_22873_14024# a_23003_14024# VDD.t301 sg13_lv_pmos ad=0.2128p pd=1.5u as=0.3808p ps=2.92u w=1.12u l=0.2u
X1353 a_6126_9506# a_5974_11413# a_6326_10280# VSS.t17 sg13_lv_nmos ad=0.68p pd=4.68u as=0.38p ps=2.38u w=2u l=1u
X1354 VSS.t173 a_4187_1764.t26 a_9431_1842# VSS.t172 sg13_lv_nmos ad=0.2516p pd=2.16u as=0.1406p ps=1.12u w=0.74u l=0.6u
X1355 a_19448_1044# a_18877_1842# VDD.t1117 VDD.t7 sg13_lv_pmos ad=0.2128p pd=1.5u as=0.3808p ps=2.92u w=1.12u l=0.13u
X1356 a_10430_3889# a_12791_3853# a_12715_3889# VDD.t0 sg13_lv_pmos ad=0.3808p pd=2.92u as=0.2128p ps=1.5u w=1.12u l=0.13u
X1357 a_7288_16071# a_6717_16869# VSS.t405 VSS.t1738 sg13_lv_nmos ad=0.1406p pd=1.12u as=0.2516p ps=2.16u w=0.74u l=0.13u
X1358 a_10430_1044# a_11924_1008# a_11848_1044# VDD.t7 sg13_lv_pmos ad=0.3808p pd=2.92u as=0.2128p ps=1.5u w=1.12u l=0.13u
X1359 a_19550_3889# a_3747_3892.t4 a_21835_3889# VSS.t1518 sg13_lv_nmos ad=0.2516p pd=2.16u as=0.1406p ps=1.12u w=0.74u l=0.13u
X1360 VDD.t234 VSS.t474 VDD.t233 VDD.t4 sg13_lv_pmos ad=0.34p pd=2.68u as=0 ps=0 w=1u l=1u
X1361 a_4248_13226# a_4157_13495# VSS.t1559 VSS.t1914 sg13_lv_nmos ad=0.1406p pd=1.12u as=0.2516p ps=2.16u w=0.74u l=0.13u
X1362 a_2297_7085# REF_MUX_SEL0 VDD.t570 VDD.t41 sg13_lv_pmos ad=0.1596p pd=1.22u as=0.2856p ps=2.36u w=0.84u l=0.13u
X1363 a_24875_3889# a_24665_3889# VDD.t467 VDD.t0 sg13_lv_pmos ad=0.2128p pd=1.5u as=0.252p ps=1.57u w=1.12u l=0.13u
X1364 a_13753_14024# a_13557_14024# VSS.t755 VSS.t2038 sg13_lv_nmos ad=0.2516p pd=2.16u as=0.1406p ps=1.12u w=0.74u l=0.13u
X1365 VSS.t295 a_11603_4687# a_12037_4687# VSS.t807 sg13_lv_nmos ad=0.1406p pd=1.12u as=0.2516p ps=2.16u w=0.74u l=0.13u
X1366 a_10951_7532# a_10713_7532# a_10843_7532# VSS.t2275 sg13_lv_nmos ad=0.1406p pd=1.12u as=0.2516p ps=2.16u w=0.74u l=0.2u
X1367 VSS.t487 a_4187_1764.t8 a_23111_1842# VSS.t486 sg13_lv_nmos ad=0.2516p pd=2.16u as=0.1406p ps=1.12u w=0.74u l=0.6u
X1368 a_17791_5315# a_17553_4687# a_17683_4687# VDD.t281 sg13_lv_pmos ad=0.2128p pd=1.5u as=0.3808p ps=2.92u w=1.12u l=0.2u
X1369 VDD.t528 a_1544_6734# a_1721_7085# VDD.t41 sg13_lv_pmos ad=0.1918p pd=1.5u as=0.1596p ps=1.22u w=0.84u l=0.13u
X1370 VDD.t991 a_2595_3892.t3 a_23431_3853# VDD.t0 sg13_lv_pmos ad=0.3808p pd=2.92u as=0.3808p ps=2.92u w=1.12u l=0.13u
X1371 VSS.t1583 a_2595_16074.t3 a_23431_16035# VSS.t2083 sg13_lv_nmos ad=0.2516p pd=2.16u as=0.2516p ps=2.16u w=0.74u l=0.13u
X1372 VDD.t1063 a_2019_13229.t5 a_16484_13190# VDD.t50 sg13_lv_pmos ad=0.3808p pd=2.92u as=0.3808p ps=2.92u w=1.12u l=0.13u
X1373 VSS.t321 a_2019_6737.t5 a_16484_6698# VSS.t736 sg13_lv_nmos ad=0.2516p pd=2.16u as=0.2516p ps=2.16u w=0.74u l=0.13u
X1374 VDD.t445 a_4187_2434# a_27671_2470# VDD.t399 sg13_lv_pmos ad=0.3808p pd=2.92u as=0.2128p ps=1.5u w=1.12u l=0.6u
X1375 a_24393_4687# a_24197_4687# VSS.t88 VSS.t87 sg13_lv_nmos ad=0.2516p pd=2.16u as=0.1406p ps=1.12u w=0.74u l=0.13u
X1376 a_7390_13226# a_3747_13229.t8 a_9675_13226# VSS.t2160 sg13_lv_nmos ad=0.2516p pd=2.16u as=0.1406p ps=1.12u w=0.74u l=0.13u
X1377 VSS.t241 a_2595_13229.t4 a_20391_13190# VSS.t1642 sg13_lv_nmos ad=0.2516p pd=2.16u as=0.2516p ps=2.16u w=0.74u l=0.13u
X1378 a_26151_8160# a_25913_7532# a_26043_7532# VDD.t275 sg13_lv_pmos ad=0.2128p pd=1.5u as=0.3808p ps=2.92u w=1.12u l=0.2u
X1379 VDD.t36 VSS.t1014 VDD.t17 VDD.t0 sg13_lv_pmos ad=0.19p pd=1.38u as=0 ps=0 w=1u l=1u
X1380 VSS.t992 VDD.t1646 VSS.t992 VSS.t994 sg13_lv_nmos ad=79.8f pd=0.8u as=0 ps=0 w=0.42u l=1u
X1381 a_7390_16071# a_2595_16074.t8 a_8155_16071# VSS.t1734 sg13_lv_nmos ad=0.2516p pd=2.16u as=0.1406p ps=1.12u w=0.74u l=0.13u
X1382 VDD.t54 VSS.t817 VDD.t53 VDD.t4 sg13_lv_pmos ad=0.19p pd=1.38u as=0 ps=0 w=1u l=1u
X1383 a_9444_10280# a_6854_11144# a_6854_11144# VSS.t2238 sg13_lv_nmos ad=0.68p pd=4.68u as=0.38p ps=2.38u w=2u l=1u
X1384 VDD.t147 VSS.t935 VDD.t68 VDD.t41 sg13_lv_pmos ad=0.19p pd=1.38u as=0 ps=0 w=1u l=1u
X1385 a_7911_14652# a_7673_14024# a_7803_14024# VDD.t301 sg13_lv_pmos ad=0.2128p pd=1.5u as=0.3808p ps=2.92u w=1.12u l=0.2u
X1386 VDD.t613 a_13557_4687# a_14025_3889# VDD.t0 sg13_lv_pmos ad=0.252p pd=1.57u as=0.3808p ps=2.92u w=1.12u l=0.13u
X1387 a_13753_7532# a_13557_7532# VDD.t998 VDD.t275 sg13_lv_pmos ad=0.3808p pd=2.92u as=0.2128p ps=1.5u w=1.12u l=0.13u
X1388 VSS.t1530 a_4187_1764.t98 VSS.t1532 VSS.t1531 sg13_lv_nmos ad=1.33p pd=7.38u as=0 ps=0 w=7u l=7u
X1389 a_4871_8160# a_4633_7532# a_4763_7532# VDD.t275 sg13_lv_pmos ad=0.2128p pd=1.5u as=0.3808p ps=2.92u w=1.12u l=0.2u
X1390 VSS.t187 a_3171_6737.t9 a_5844_6698# VSS.t1659 sg13_lv_nmos ad=0.2516p pd=2.16u as=0.2516p ps=2.16u w=0.74u l=0.13u
X1391 a_4248_6734# a_4157_7003# VDD.t486 VDD.t41 sg13_lv_pmos ad=0.2128p pd=1.5u as=0.3808p ps=2.92u w=1.12u l=0.13u
X1392 VSS.t46 a_22677_4687# a_23145_3889# VSS.t45 sg13_lv_nmos ad=0.1665p pd=1.19u as=0.2516p ps=2.16u w=0.74u l=0.13u
X1393 VSS.t676 a_4187_1764.t51 a_14751_4687# VSS.t1580 sg13_lv_nmos ad=0.2516p pd=2.16u as=0.1406p ps=1.12u w=0.74u l=0.6u
X1394 VDD.t537 a_1721_16422# a_2019_16074.t0 VDD.t4 sg13_lv_pmos ad=0.4256p pd=3u as=0.2128p ps=1.5u w=1.12u l=0.13u
X1395 VDD.t349 a_4187_2434# a_8671_14652# VDD.t301 sg13_lv_pmos ad=0.3808p pd=2.92u as=0.2128p ps=1.5u w=1.12u l=0.6u
X1396 VDD.t694 a_1256_3889# a_2873_4240# VDD.t0 sg13_lv_pmos ad=0.1918p pd=1.5u as=0.1596p ps=1.22u w=0.84u l=0.13u
X1397 VDD.t1269 a_26043_14024# a_26477_14024# VDD.t301 sg13_lv_pmos ad=0.2128p pd=1.5u as=0.3808p ps=2.92u w=1.12u l=0.13u
X1398 VDD.t1046 a_2595_3156.t3 a_8745_3364# VDD.t0 sg13_lv_pmos ad=0.3808p pd=2.92u as=0.3808p ps=2.92u w=1.12u l=0.13u
X1399 a_25630_1044# a_26471_1008# a_26395_1044# VDD.t7 sg13_lv_pmos ad=0.3808p pd=2.92u as=0.2128p ps=1.5u w=1.12u l=0.13u
X1400 a_3171_6001.t1 a_2873_6021# VSS.t129 VSS.t678 sg13_lv_nmos ad=0.1406p pd=1.12u as=0.1331p ps=1.12u w=0.74u l=0.13u
X1401 a_27915_13226# a_27705_13226# VSS.t386 VSS.t1825 sg13_lv_nmos ad=0.1406p pd=1.12u as=0.1665p ps=1.19u w=0.74u l=0.13u
X1402 VDD.t996 a_3747_13229.t4 a_21911_13190# VDD.t50 sg13_lv_pmos ad=0.3808p pd=2.92u as=0.3808p ps=2.92u w=1.12u l=0.13u
X1403 VSS.t721 a_2595_6737.t7 a_11271_6698# VSS.t720 sg13_lv_nmos ad=0.2516p pd=2.16u as=0.2516p ps=2.16u w=0.74u l=0.13u
X1404 VSS.t709 a_4187_1764.t77 a_19311_7532# VSS.t708 sg13_lv_nmos ad=0.2516p pd=2.16u as=0.1406p ps=1.12u w=0.74u l=0.6u
X1405 a_21591_5315# a_21353_4687# a_21483_4687# VDD.t281 sg13_lv_pmos ad=0.2128p pd=1.5u as=0.3808p ps=2.92u w=1.12u l=0.2u
X1406 VSS.t477 a_2297_6021# a_2595_6001.t1 VSS.t57 sg13_lv_nmos ad=0.2812p pd=2.24u as=0.1406p ps=1.12u w=0.74u l=0.13u
X1407 a_26395_16071# a_26185_16071# VSS.t1754 VSS.t1759 sg13_lv_nmos ad=0.1406p pd=1.12u as=0.1665p ps=1.19u w=0.74u l=0.13u
X1408 VSS.t2347 VSS.t2347 VSS.t2349 VSS.t2348 sg13_lv_nmos ad=0.68p pd=4.68u as=0 ps=0 w=2u l=1u
X1409 VSS.t1532 a_4187_1764.t98 VSS.t1534 VSS.t1533 sg13_lv_nmos ad=1.33p pd=7.38u as=0 ps=0 w=7u l=7u
X1410 VSS.t538 a_4187_1764.t65 a_4111_4687# VSS.t537 sg13_lv_nmos ad=0.2516p pd=2.16u as=0.1406p ps=1.12u w=0.74u l=0.6u
X1411 a_6153_4687# a_5957_4687# VDD.t282 VDD.t281 sg13_lv_pmos ad=0.3808p pd=2.92u as=0.2128p ps=1.5u w=1.12u l=0.13u
X1412 a_23355_13226# a_23145_13226# VSS.t1335 VSS.t1334 sg13_lv_nmos ad=0.1406p pd=1.12u as=0.1665p ps=1.19u w=0.74u l=0.13u
X1413 a_2595_12493.t1 a_2297_12513# VSS.t2091 VSS.t2093 sg13_lv_nmos ad=0.1406p pd=1.12u as=0.1331p ps=1.12u w=0.74u l=0.13u
X1414 a_19550_6734# a_21911_6698# a_21835_6734# VDD.t41 sg13_lv_pmos ad=0.3808p pd=2.92u as=0.2128p ps=1.5u w=1.12u l=0.13u
X1415 VSS.t251 a_2873_16422# a_3171_16074.t1 VSS.t1381 sg13_lv_nmos ad=0.2812p pd=2.24u as=0.1406p ps=1.12u w=0.74u l=0.13u
X1416 VDD.t287 a_16163_4687# a_16597_4687# VDD.t281 sg13_lv_pmos ad=0.2128p pd=1.5u as=0.3808p ps=2.92u w=1.12u l=0.13u
X1417 a_16033_1842# a_15837_1842# VDD.t1148 VDD.t399 sg13_lv_pmos ad=0.3808p pd=2.92u as=0.2128p ps=1.5u w=1.12u l=0.13u
X1418 VDD.t526 a_24523_7532# a_24957_7532# VDD.t275 sg13_lv_pmos ad=0.2128p pd=1.5u as=0.3808p ps=2.92u w=1.12u l=0.13u
X1419 a_7151_2470# a_6913_1842# a_7043_1842# VDD.t399 sg13_lv_pmos ad=0.2128p pd=1.5u as=0.3808p ps=2.92u w=1.12u l=0.2u
X1420 VDD.t568 a_15964_289# a_16851_309# VDD.t7 sg13_lv_pmos ad=0.2086p pd=1.5u as=0.34p ps=2.68u w=1u l=0.13u
X1421 a_24631_17497# a_24393_16869# a_24523_16869# VDD.t297 sg13_lv_pmos ad=0.2128p pd=1.5u as=0.3808p ps=2.92u w=1.12u l=0.2u
X1422 VSS.t97 a_3747_6737.t8 a_9751_6698# VSS.t1285 sg13_lv_nmos ad=0.2516p pd=2.16u as=0.2516p ps=2.16u w=0.74u l=0.13u
X1423 VDD.t1314 VSS.t1095 VDD.t1313 VDD.t7 sg13_lv_pmos ad=0.34p pd=2.68u as=0 ps=0 w=1u l=1u
X1424 VSS.t34 CHAN2_MUX_SEL3 a_3543_3176# VSS.t33 sg13_lv_nmos ad=0.1331p pd=1.12u as=0.1216p ps=1.02u w=0.64u l=0.13u
X1425 a_14751_14024# a_14513_14024# a_14643_14024# VSS.t2293 sg13_lv_nmos ad=0.1406p pd=1.12u as=0.2516p ps=2.16u w=0.74u l=0.2u
X1426 a_19073_14024# a_18877_14024# VSS.t1646 VSS.t2096 sg13_lv_nmos ad=0.2516p pd=2.16u as=0.1406p ps=1.12u w=0.74u l=0.13u
X1427 VSS.t99 a_4187_1764.t90 a_9431_7532# VSS.t457 sg13_lv_nmos ad=0.2516p pd=2.16u as=0.1406p ps=1.12u w=0.74u l=0.6u
X1428 VDD.t337 a_4187_2434# a_25391_17497# VDD.t297 sg13_lv_pmos ad=0.3808p pd=2.92u as=0.2128p ps=1.5u w=1.12u l=0.6u
X1429 VDD.t1308 a_3747_13229.t9 a_6711_13190# VDD.t50 sg13_lv_pmos ad=0.3808p pd=2.92u as=0.3808p ps=2.92u w=1.12u l=0.13u
X1430 VSS.t1024 VDD.t1637 VSS.t1021 VSS.t1023 sg13_lv_nmos ad=79.8f pd=0.8u as=0 ps=0 w=0.42u l=1u
X1431 a_20071_17497# a_19833_16869# a_19963_16869# VDD.t297 sg13_lv_pmos ad=0.2128p pd=1.5u as=0.3808p ps=2.92u w=1.12u l=0.2u
X1432 a_2391_13577# CHAN1_MUX_SEL0 a_2297_13577# VSS.t190 sg13_lv_nmos ad=0.1216p pd=1.02u as=0.2176p ps=1.96u w=0.64u l=0.13u
X1433 VDD.t412 a_4187_2434# a_10191_5315# VDD.t281 sg13_lv_pmos ad=0.3808p pd=2.92u as=0.2128p ps=1.5u w=1.12u l=0.6u
X1434 VDD.t688 a_5957_1842# a_6425_1044# VDD.t7 sg13_lv_pmos ad=0.252p pd=1.57u as=0.3808p ps=2.92u w=1.12u l=0.13u
X1435 VSS.t1101 VDD.t1614 VSS.t1099 VSS.t1100 sg13_lv_nmos ad=79.8f pd=0.8u as=0 ps=0 w=0.42u l=1u
X1436 VSS.t171 a_11603_1842# a_12037_1842# VSS.t1693 sg13_lv_nmos ad=0.1406p pd=1.12u as=0.2516p ps=2.16u w=0.74u l=0.13u
X1437 VSS.t194 a_4187_1764.t72 a_23111_7532# VSS.t554 sg13_lv_nmos ad=0.2516p pd=2.16u as=0.1406p ps=1.12u w=0.74u l=0.6u
X1438 VDD.t601 a_22677_7532# a_23145_6734# VDD.t41 sg13_lv_pmos ad=0.252p pd=1.57u as=0.3808p ps=2.92u w=1.12u l=0.13u
X1439 VDD.t1033 a_2019_16074.t7 a_10404_16035# VDD.t4 sg13_lv_pmos ad=0.3808p pd=2.92u as=0.3808p ps=2.92u w=1.12u l=0.13u
X1440 VDD.t1014 VSS.t1073 VDD.t1013 VDD.t7 sg13_lv_pmos ad=0.34p pd=2.68u as=0 ps=0 w=1u l=1u
X1441 VDD.t43 VSS.t992 VDD.t42 VDD.t41 sg13_lv_pmos ad=0.19p pd=1.38u as=0 ps=0 w=1u l=1u
X1442 a_6635_16071# a_6425_16071# VSS.t254 VSS.t253 sg13_lv_nmos ad=0.1406p pd=1.12u as=0.1665p ps=1.19u w=0.74u l=0.13u
X1443 VDD.t397 a_4187_2434# a_27671_8160# VDD.t275 sg13_lv_pmos ad=0.3808p pd=2.92u as=0.2128p ps=1.5u w=1.12u l=0.6u
X1444 a_3747_1047.t1 a_3449_1395# VSS.t1161 VSS.t1160 sg13_lv_nmos ad=0.1406p pd=1.12u as=0.1331p ps=1.12u w=0.74u l=0.13u
X1445 a_24393_1842# a_24197_1842# VSS.t580 VSS.t1965 sg13_lv_nmos ad=0.2516p pd=2.16u as=0.1406p ps=1.12u w=0.74u l=0.13u
X1446 VDD.t515 a_19963_4687# a_20397_4687# VDD.t281 sg13_lv_pmos ad=0.2128p pd=1.5u as=0.3808p ps=2.92u w=1.12u l=0.13u
X1447 VSS.t859 VDD.t1684 VSS.t859 VSS.t862 sg13_lv_nmos ad=0.1428p pd=1.52u as=0 ps=0 w=0.42u l=1u
X1448 VDD.t20 VSS.t1093 VDD.t19 VDD.t7 sg13_lv_pmos ad=0.34p pd=2.68u as=0 ps=0 w=1u l=1u
X1449 a_1544_1044# CHAN3_MUX_SEL1 VSS.t256 VSS.t30 sg13_lv_nmos ad=0.2516p pd=2.16u as=0.2516p ps=2.16u w=0.74u l=0.13u
X1450 a_10430_3889# a_3747_3892.t7 a_12715_3889# VSS.t1516 sg13_lv_nmos ad=0.2516p pd=2.16u as=0.1406p ps=1.12u w=0.74u l=0.13u
X1451 a_17031_4687# a_16793_4687# a_16923_4687# VSS.t2183 sg13_lv_nmos ad=0.1406p pd=1.12u as=0.2516p ps=2.16u w=0.74u l=0.2u
X1452 a_17553_16869# a_17357_16869# VSS.t491 VSS.t490 sg13_lv_nmos ad=0.2516p pd=2.16u as=0.1406p ps=1.12u w=0.74u l=0.13u
X1453 VDD.t774 VDD.t766 VDD.t773 VDD.t268 sg13_lv_pmos ad=0.68p pd=4.68u as=0 ps=0 w=2u l=1u
X1454 a_13470_1044# a_3747_1047.t6 a_15755_1044# VSS.t1616 sg13_lv_nmos ad=0.2516p pd=2.16u as=0.1406p ps=1.12u w=0.74u l=0.13u
X1455 VDD.t98 VSS.t1001 VDD.t96 VDD.t0 sg13_lv_pmos ad=0.19p pd=1.38u as=0 ps=0 w=1u l=1u
X1456 a_3171_1047.t0 a_2873_1395# VDD.t631 VDD.t7 sg13_lv_pmos ad=0.2128p pd=1.5u as=0.1918p ps=1.5u w=1.12u l=0.13u
X1457 a_24875_3889# a_24665_3889# VSS.t86 VSS.t2134 sg13_lv_nmos ad=0.1406p pd=1.12u as=0.1665p ps=1.19u w=0.74u l=0.13u
X1458 a_4871_17497# a_4633_16869# a_4763_16869# VDD.t297 sg13_lv_pmos ad=0.2128p pd=1.5u as=0.3808p ps=2.92u w=1.12u l=0.2u
X1459 VSS.t161 a_4187_1764.t163 a_4111_16869# VSS.t160 sg13_lv_nmos ad=0.2516p pd=2.16u as=0.1406p ps=1.12u w=0.74u l=0.6u
X1460 a_9193_16869# a_8997_16869# VDD.t552 VDD.t297 sg13_lv_pmos ad=0.3808p pd=2.92u as=0.2128p ps=1.5u w=1.12u l=0.13u
X1461 VDD.t1503 a_5523_1842# a_5957_1842# VDD.t399 sg13_lv_pmos ad=0.2128p pd=1.5u as=0.3808p ps=2.92u w=1.12u l=0.13u
X1462 a_9675_13226# a_9465_13226# VDD.t994 VDD.t50 sg13_lv_pmos ad=0.2128p pd=1.5u as=0.252p ps=1.57u w=1.12u l=0.13u
X1463 VSS.t2225 a_4187_1764.t99 a_4187_2434# VSS.t2224 sg13_lv_nmos ad=0.2516p pd=2.16u as=0.6808p ps=3.32u w=0.74u l=0.6u
X1464 VDD.t842 a_2297_1395# a_2595_1047.t0 VDD.t7 sg13_lv_pmos ad=0.4256p pd=3u as=0.2128p ps=1.5u w=1.12u l=0.13u
X1465 a_22590_3889# a_24084_3853# a_24008_3889# VDD.t0 sg13_lv_pmos ad=0.3808p pd=2.92u as=0.2128p ps=1.5u w=1.12u l=0.13u
X1466 a_19550_16071# a_2019_16074.t4 a_19448_16071# VSS.t1481 sg13_lv_nmos ad=0.2516p pd=2.16u as=0.1406p ps=1.12u w=0.74u l=0.13u
X1467 VDD.t498 a_2019_1047.t6 a_13444_1008# VDD.t7 sg13_lv_pmos ad=0.3808p pd=2.92u as=0.3808p ps=2.92u w=1.12u l=0.13u
X1468 VSS.t1571 a_4187_1764.t19 a_14751_1842# VSS.t1570 sg13_lv_nmos ad=0.2516p pd=2.16u as=0.1406p ps=1.12u w=0.74u l=0.6u
X1469 VSS.t1398 a_2595_3892.t3 a_23431_3853# VSS.t1397 sg13_lv_nmos ad=0.2516p pd=2.16u as=0.2516p ps=2.16u w=0.74u l=0.13u
X1470 VDD.t319 a_4187_2434# a_5631_17497# VDD.t297 sg13_lv_pmos ad=0.3808p pd=2.92u as=0.2128p ps=1.5u w=1.12u l=0.6u
X1471 VDD.t930 a_23003_16869# a_23437_16869# VDD.t297 sg13_lv_pmos ad=0.2128p pd=1.5u as=0.3808p ps=2.92u w=1.12u l=0.13u
X1472 a_4350_16071# a_5191_16035# a_5115_16071# VDD.t4 sg13_lv_pmos ad=0.3808p pd=2.92u as=0.2128p ps=1.5u w=1.12u l=0.13u
X1473 VSS.t1347 a_2595_1047.t2 a_26471_1008# VSS.t1346 sg13_lv_nmos ad=0.2516p pd=2.16u as=0.2516p ps=2.16u w=0.74u l=0.13u
X1474 a_4350_1044# a_2595_1047.t9 a_5115_1044# VSS.t148 sg13_lv_nmos ad=0.2516p pd=2.16u as=0.1406p ps=1.12u w=0.74u l=0.13u
X1475 a_2967_1395# CHAN3_MUX_SEL1 a_2873_1395# VSS.t32 sg13_lv_nmos ad=0.1216p pd=1.02u as=0.2176p ps=1.96u w=0.64u l=0.13u
X1476 VSS.t639 CHAN2_MUX_SEL4 a_15765_3308# VSS.t638 sg13_lv_nmos ad=0.2516p pd=2.16u as=0.2516p ps=2.16u w=0.74u l=0.13u
X1477 a_2595_311.t1 a_2297_331# VSS.t2014 VSS.t2013 sg13_lv_nmos ad=0.1406p pd=1.12u as=0.1331p ps=1.12u w=0.74u l=0.13u
X1478 VSS.t819 VDD.t1696 VSS.t819 VSS.t822 sg13_lv_nmos ad=0.1428p pd=1.52u as=0 ps=0 w=0.42u l=1u
X1479 VSS.t440 a_13557_4687# a_14025_3889# VSS.t439 sg13_lv_nmos ad=0.1665p pd=1.19u as=0.2516p ps=2.16u w=0.74u l=0.13u
X1480 a_9946_11995# a_10751_11568# a_10206_11525# VDD.t268 sg13_lv_pmos ad=0.1428p pd=1.52u as=79.8f ps=0.8u w=0.42u l=0.13u
X1481 VSS.t1675 a_16597_1842# a_17065_1044# VSS.t1674 sg13_lv_nmos ad=0.1665p pd=1.19u as=0.2516p ps=2.16u w=0.74u l=0.13u
X1482 a_2297_1395# CHAN3_MUX_SEL0 VDD.t1356 VDD.t7 sg13_lv_pmos ad=0.1596p pd=1.22u as=0.2856p ps=2.36u w=0.84u l=0.13u
X1483 VSS.t746 a_4187_1764.t33 a_4111_1842# VSS.t745 sg13_lv_nmos ad=0.2516p pd=2.16u as=0.1406p ps=1.12u w=0.74u l=0.6u
X1484 VSS.t918 VDD.t1667 VSS.t916 VSS.t917 sg13_lv_nmos ad=0.1428p pd=1.52u as=0 ps=0 w=0.42u l=1u
X1485 a_12943_11557# a_13121_11521# VDD.t736 VDD.t268 sg13_lv_pmos ad=0.3808p pd=2.92u as=0.2128p ps=1.5u w=1.12u l=0.13u
X1486 VSS.t937 VDD.t1660 VSS.t937 VSS.t940 sg13_lv_nmos ad=0.1428p pd=1.52u as=0 ps=0 w=0.42u l=1u
X1487 VSS.t298 a_6283_16869# a_6717_16869# VSS.t297 sg13_lv_nmos ad=0.1406p pd=1.12u as=0.2516p ps=2.16u w=0.74u l=0.13u
X1488 a_25630_13226# a_2595_13229.t2 a_26395_13226# VSS.t1301 sg13_lv_nmos ad=0.2516p pd=2.16u as=0.1406p ps=1.12u w=0.74u l=0.13u
X1489 a_16033_7532# a_15837_7532# VDD.t522 VDD.t275 sg13_lv_pmos ad=0.3808p pd=2.92u as=0.2128p ps=1.5u w=1.12u l=0.13u
X1490 VDD.t540 a_1544_1044# a_1721_1395# VDD.t7 sg13_lv_pmos ad=0.1918p pd=1.5u as=0.1596p ps=1.22u w=0.84u l=0.13u
X1491 VDD.t432 a_4187_2434# a_8671_2470# VDD.t399 sg13_lv_pmos ad=0.3808p pd=2.92u as=0.2128p ps=1.5u w=1.12u l=0.6u
X1492 a_20831_4687# a_20593_4687# a_20723_4687# VSS.t786 sg13_lv_nmos ad=0.1406p pd=1.12u as=0.2516p ps=2.16u w=0.74u l=0.2u
X1493 a_1815_16422# a_1256_16071# a_1721_16422# VSS.t1228 sg13_lv_nmos ad=0.1216p pd=1.02u as=0.2176p ps=1.96u w=0.64u l=0.13u
X1494 VSS.t9 a_15108_11799# a_14757_11918# VSS.t8 sg13_lv_nmos ad=79.8f pd=0.8u as=0.1428p ps=1.52u w=0.42u l=0.13u
X1495 a_7151_8160# a_6913_7532# a_7043_7532# VDD.t275 sg13_lv_pmos ad=0.2128p pd=1.5u as=0.3808p ps=2.92u w=1.12u l=0.2u
X1496 a_5393_4687# a_5197_4687# VSS.t117 VSS.t116 sg13_lv_nmos ad=0.2516p pd=2.16u as=0.1406p ps=1.12u w=0.74u l=0.13u
X1497 VSS.t203 a_4187_1764.t48 a_17031_4687# VSS.t1797 sg13_lv_nmos ad=0.2516p pd=2.16u as=0.1406p ps=1.12u w=0.74u l=0.6u
X1498 a_16510_13226# a_18004_13190# a_17928_13226# VDD.t50 sg13_lv_pmos ad=0.3808p pd=2.92u as=0.2128p ps=1.5u w=1.12u l=0.13u
X1499 VDD.t236 VSS.t1071 VDD.t235 VDD.t7 sg13_lv_pmos ad=0.19p pd=1.38u as=0 ps=0 w=1u l=1u
X1500 a_24631_14652# a_24393_14024# a_24523_14024# VDD.t301 sg13_lv_pmos ad=0.2128p pd=1.5u as=0.3808p ps=2.92u w=1.12u l=0.2u
X1501 VSS.t1003 VDD.t1642 VSS.t1003 VSS.t1006 sg13_lv_nmos ad=79.8f pd=0.8u as=0 ps=0 w=0.42u l=1u
X1502 a_25630_3889# a_27991_3853# a_27915_3889# VDD.t0 sg13_lv_pmos ad=0.3808p pd=2.92u as=0.2128p ps=1.5u w=1.12u l=0.13u
X1503 a_8808_16071# a_8237_16869# VSS.t1135 VSS.t1134 sg13_lv_nmos ad=0.1406p pd=1.12u as=0.2516p ps=2.16u w=0.74u l=0.13u
X1504 VSS.t1256 a_7477_14024# a_7945_13226# VSS.t1973 sg13_lv_nmos ad=0.1665p pd=1.19u as=0.2516p ps=2.16u w=0.74u l=0.13u
X1505 a_3171_12493.t1 a_2873_12513# VSS.t2103 VSS.t2102 sg13_lv_nmos ad=0.1406p pd=1.12u as=0.1331p ps=1.12u w=0.74u l=0.13u
X1506 a_10430_6734# a_12791_6698# a_12715_6734# VDD.t41 sg13_lv_pmos ad=0.3808p pd=2.92u as=0.2128p ps=1.5u w=1.12u l=0.13u
X1507 a_20071_14652# a_19833_14024# a_19963_14024# VDD.t301 sg13_lv_pmos ad=0.2128p pd=1.5u as=0.3808p ps=2.92u w=1.12u l=0.2u
X1508 VDD.t363 a_4187_2434# a_25391_14652# VDD.t301 sg13_lv_pmos ad=0.3808p pd=2.92u as=0.2128p ps=1.5u w=1.12u l=0.6u
X1509 a_5768_13226# a_5197_14024# VSS.t102 VSS.t1996 sg13_lv_nmos ad=0.1406p pd=1.12u as=0.2516p ps=2.16u w=0.74u l=0.13u
X1510 VSS.t348 a_26803_4687# a_27237_4687# VSS.t1254 sg13_lv_nmos ad=0.1406p pd=1.12u as=0.2516p ps=2.16u w=0.74u l=0.13u
X1511 a_25630_16071# a_25604_16035# a_25528_16071# VDD.t4 sg13_lv_pmos ad=0.3808p pd=2.92u as=0.2128p ps=1.5u w=1.12u l=0.13u
X1512 a_4248_1044# a_4157_1313# VDD.t1224 VDD.t7 sg13_lv_pmos ad=0.2128p pd=1.5u as=0.3808p ps=2.92u w=1.12u l=0.13u
X1513 a_4248_16071# a_4157_16340# VSS.t594 VSS.t1669 sg13_lv_nmos ad=0.1406p pd=1.12u as=0.2516p ps=2.16u w=0.74u l=0.13u
X1514 a_19448_16071# a_18877_16869# VDD.t615 VDD.t4 sg13_lv_pmos ad=0.2128p pd=1.5u as=0.3808p ps=2.92u w=1.12u l=0.13u
X1515 VSS.t662 a_11603_7532# a_12037_7532# VSS.t2126 sg13_lv_nmos ad=0.1406p pd=1.12u as=0.2516p ps=2.16u w=0.74u l=0.13u
X1516 a_24875_6734# a_24665_6734# VDD.t516 VDD.t41 sg13_lv_pmos ad=0.2128p pd=1.5u as=0.252p ps=1.57u w=1.12u l=0.13u
X1517 a_20593_16869# a_20397_16869# VDD.t979 VDD.t297 sg13_lv_pmos ad=0.3808p pd=2.92u as=0.2128p ps=1.5u w=1.12u l=0.13u
X1518 a_18551_16869# a_18313_16869# a_18443_16869# VSS.t1340 sg13_lv_nmos ad=0.1406p pd=1.12u as=0.2516p ps=2.16u w=0.74u l=0.2u
X1519 VDD.t975 a_13883_16869# a_14317_16869# VDD.t297 sg13_lv_pmos ad=0.2128p pd=1.5u as=0.3808p ps=2.92u w=1.12u l=0.13u
X1520 VDD.t265 VSS.t1054 VDD.t24 VDD.t0 sg13_lv_pmos ad=0.19p pd=1.38u as=0 ps=0 w=1u l=1u
X1521 a_3747_6737.t1 a_3449_7085# VSS.t1433 VSS.t1432 sg13_lv_nmos ad=0.1406p pd=1.12u as=0.1331p ps=1.12u w=0.74u l=0.13u
X1522 a_11473_4687# a_11277_4687# VDD.t821 VDD.t281 sg13_lv_pmos ad=0.3808p pd=2.92u as=0.2128p ps=1.5u w=1.12u l=0.13u
X1523 VDD.t1106 a_2595_6737.t3 a_23431_6698# VDD.t41 sg13_lv_pmos ad=0.3808p pd=2.92u as=0.3808p ps=2.92u w=1.12u l=0.13u
X1524 a_7390_16071# a_3747_16074.t8 a_9675_16071# VSS.t1499 sg13_lv_nmos ad=0.2516p pd=2.16u as=0.1406p ps=1.12u w=0.74u l=0.13u
X1525 a_24393_7532# a_24197_7532# VSS.t44 VSS.t212 sg13_lv_nmos ad=0.2516p pd=2.16u as=0.1406p ps=1.12u w=0.74u l=0.13u
X1526 VSS.t1376 a_2595_16074.t4 a_20391_16035# VSS.t1498 sg13_lv_nmos ad=0.2516p pd=2.16u as=0.2516p ps=2.16u w=0.74u l=0.13u
X1527 a_1544_6734# REF_MUX_SEL1 VSS.t232 VSS.t2123 sg13_lv_nmos ad=0.2516p pd=2.16u as=0.2516p ps=2.16u w=0.74u l=0.13u
X1528 a_4350_13226# a_3747_13229.t9 a_6635_13226# VSS.t1946 sg13_lv_nmos ad=0.2516p pd=2.16u as=0.1406p ps=1.12u w=0.74u l=0.13u
X1529 a_17031_1842# a_16793_1842# a_16923_1842# VSS.t1730 sg13_lv_nmos ad=0.1406p pd=1.12u as=0.2516p ps=2.16u w=0.74u l=0.2u
X1530 a_13470_6734# a_3747_6737.t6 a_15755_6734# VSS.t1772 sg13_lv_nmos ad=0.2516p pd=2.16u as=0.1406p ps=1.12u w=0.74u l=0.13u
X1531 a_7288_13226# a_6717_14024# VDD.t1354 VDD.t50 sg13_lv_pmos ad=0.2128p pd=1.5u as=0.3808p ps=2.92u w=1.12u l=0.13u
X1532 VSS.t899 VDD.t1672 VSS.t899 VSS.t902 sg13_lv_nmos ad=79.8f pd=0.8u as=0 ps=0 w=0.42u l=1u
X1533 a_12471_2470# a_12233_1842# a_12363_1842# VDD.t399 sg13_lv_pmos ad=0.2128p pd=1.5u as=0.3808p ps=2.92u w=1.12u l=0.2u
X1534 a_13592_11561# a_14111_11568# a_14851_11918# VSS.t8 sg13_lv_nmos ad=0.3473p pd=2.71u as=0.12665p ps=1.145u w=0.74u l=0.13u
X1535 VDD.t999 a_13557_7532# a_14025_6734# VDD.t41 sg13_lv_pmos ad=0.252p pd=1.57u as=0.3808p ps=2.92u w=1.12u l=0.13u
X1536 a_19550_1044# a_21911_1008# a_21835_1044# VDD.t7 sg13_lv_pmos ad=0.3808p pd=2.92u as=0.2128p ps=1.5u w=1.12u l=0.13u
X1537 VSS.t2014 a_1721_331# a_2019_311.t1 VSS.t2044 sg13_lv_nmos ad=0.2812p pd=2.24u as=0.1406p ps=1.12u w=0.74u l=0.13u
X1538 a_4871_14652# a_4633_14024# a_4763_14024# VDD.t301 sg13_lv_pmos ad=0.2128p pd=1.5u as=0.3808p ps=2.92u w=1.12u l=0.2u
X1539 VDD.t697 a_15464_9374# a_9712_9602# VSS.t683 sg13_lv_nmos ad=0.232p pd=2.08u as=0.136p ps=1.14u w=0.4u l=0.2u
X1540 a_9193_14024# a_8997_14024# VDD.t1363 VDD.t301 sg13_lv_pmos ad=0.3808p pd=2.92u as=0.2128p ps=1.5u w=1.12u l=0.13u
X1541 VDD.t525 a_5523_7532# a_5957_7532# VDD.t275 sg13_lv_pmos ad=0.2128p pd=1.5u as=0.3808p ps=2.92u w=1.12u l=0.13u
X1542 a_14851_10872# a_14009_10774# a_13592_11113# VDD.t268 sg13_lv_pmos ad=0.2048p pd=1.63u as=0.34p ps=2.68u w=1u l=0.13u
X1543 VSS.t732 a_4187_1764.t83 a_14751_7532# VSS.t731 sg13_lv_nmos ad=0.2516p pd=2.16u as=0.1406p ps=1.12u w=0.74u l=0.6u
X1544 a_3449_15358# CHAN0_MUX_SEL2 VDD.t679 VDD.t4 sg13_lv_pmos ad=0.1596p pd=1.22u as=0.2856p ps=2.36u w=0.84u l=0.13u
X1545 a_6854_11144# a_6326_10280# VDD.t1134 VDD.t268 sg13_lv_pmos ad=0.38p pd=2.38u as=0.38p ps=2.38u w=2u l=1u
X1546 VDD.t345 a_4187_2434# a_5631_14652# VDD.t301 sg13_lv_pmos ad=0.3808p pd=2.92u as=0.2128p ps=1.5u w=1.12u l=0.6u
X1547 VDD.t502 a_2595_13229.t3 a_23431_13190# VDD.t50 sg13_lv_pmos ad=0.3808p pd=2.92u as=0.3808p ps=2.92u w=1.12u l=0.13u
X1548 VSS.t887 VDD.t1677 VSS.t885 VSS.t886 sg13_lv_nmos ad=79.8f pd=0.8u as=0 ps=0 w=0.42u l=1u
X1549 VSS.t518 a_2595_6737.t2 a_26471_6698# VSS.t2210 sg13_lv_nmos ad=0.2516p pd=2.16u as=0.2516p ps=2.16u w=0.74u l=0.13u
X1550 VSS.t2014 a_2297_331# a_2595_311.t1 VSS.t2015 sg13_lv_nmos ad=0.2812p pd=2.24u as=0.1406p ps=1.12u w=0.74u l=0.13u
X1551 VDD.t950 a_23003_14024# a_23437_14024# VDD.t301 sg13_lv_pmos ad=0.2128p pd=1.5u as=0.3808p ps=2.92u w=1.12u l=0.13u
X1552 a_2967_7085# REF_MUX_SEL1 a_2873_7085# VSS.t2124 sg13_lv_nmos ad=0.1216p pd=1.02u as=0.2176p ps=1.96u w=0.64u l=0.13u
X1553 a_4350_6734# a_2595_6737.t9 a_5115_6734# VSS.t2211 sg13_lv_nmos ad=0.2516p pd=2.16u as=0.1406p ps=1.12u w=0.74u l=0.13u
X1554 a_16108_289# a_26985_519# a_25630_1044# VDD.t7 sg13_lv_pmos ad=0.3808p pd=2.92u as=0.3808p ps=2.92u w=1.12u l=0.13u
X1555 a_27915_16071# a_27705_16071# VSS.t68 VSS.t1782 sg13_lv_nmos ad=0.1406p pd=1.12u as=0.1665p ps=1.19u w=0.74u l=0.13u
X1556 VDD.t180 VSS.t937 VDD.t179 VDD.t41 sg13_lv_pmos ad=0.34p pd=2.68u as=0 ps=0 w=1u l=1u
X1557 a_24875_13226# a_24665_13226# VSS.t1365 VSS.t1364 sg13_lv_nmos ad=0.1406p pd=1.12u as=0.1665p ps=1.19u w=0.74u l=0.13u
X1558 a_7390_13226# a_8231_13190# a_8155_13226# VDD.t50 sg13_lv_pmos ad=0.3808p pd=2.92u as=0.2128p ps=1.5u w=1.12u l=0.13u
X1559 VDD.t1428 a_2873_12513# a_3171_12493.t0 VDD.t50 sg13_lv_pmos ad=0.4256p pd=3u as=0.2128p ps=1.5u w=1.12u l=0.13u
X1560 a_16510_16071# a_16484_16035# a_16408_16071# VDD.t4 sg13_lv_pmos ad=0.3808p pd=2.92u as=0.2128p ps=1.5u w=1.12u l=0.13u
X1561 VSS.t1152 a_4187_1764.t97 a_4111_7532# VSS.t1151 sg13_lv_nmos ad=0.2516p pd=2.16u as=0.1406p ps=1.12u w=0.74u l=0.6u
X1562 a_18795_1044# a_18585_1044# VSS.t309 VSS.t308 sg13_lv_nmos ad=0.1406p pd=1.12u as=0.1665p ps=1.19u w=0.74u l=0.13u
X1563 a_19311_4687# a_19073_4687# a_19203_4687# VSS.t2107 sg13_lv_nmos ad=0.1406p pd=1.12u as=0.2516p ps=2.16u w=0.74u l=0.2u
X1564 VSS.t536 a_16597_7532# a_17065_6734# VSS.t2262 sg13_lv_nmos ad=0.1665p pd=1.19u as=0.2516p ps=2.16u w=0.74u l=0.13u
X1565 a_23355_16071# a_23145_16071# VSS.t1685 VSS.t1684 sg13_lv_nmos ad=0.1406p pd=1.12u as=0.1665p ps=1.19u w=0.74u l=0.13u
X1566 VSS.t1059 VDD.t1626 VSS.t770 VSS.t1058 sg13_lv_nmos ad=0.1428p pd=1.52u as=0 ps=0 w=0.42u l=1u
X1567 VDD.t198 VSS.t426 VDD.t267 VDD.t4 sg13_lv_pmos ad=0.34p pd=2.68u as=0 ps=0 w=1u l=1u
X1568 VDD.t993 a_22677_1842# a_23145_1044# VDD.t7 sg13_lv_pmos ad=0.252p pd=1.57u as=0.3808p ps=2.92u w=1.12u l=0.13u
X1569 a_22590_3889# a_3171_3892.t3 a_24008_3889# VSS.t1656 sg13_lv_nmos ad=0.2516p pd=2.16u as=0.1406p ps=1.12u w=0.74u l=0.13u
X1570 VDD.t383 a_4187_2434# a_8671_8160# VDD.t275 sg13_lv_pmos ad=0.3808p pd=2.92u as=0.2128p ps=1.5u w=1.12u l=0.6u
X1571 VSS.t557 a_2595_1047.t5 a_17351_1008# VSS.t556 sg13_lv_nmos ad=0.2516p pd=2.16u as=0.2516p ps=2.16u w=0.74u l=0.13u
X1572 a_20831_1842# a_20593_1842# a_20723_1842# VSS.t2001 sg13_lv_nmos ad=0.1406p pd=1.12u as=0.2516p ps=2.16u w=0.74u l=0.2u
X1573 a_25630_1044# a_3171_1047.t2 a_27048_1044# VSS.t567 sg13_lv_nmos ad=0.2516p pd=2.16u as=0.1406p ps=1.12u w=0.74u l=0.13u
X1574 a_5393_1842# a_5197_1842# VSS.t248 VSS.t539 sg13_lv_nmos ad=0.2516p pd=2.16u as=0.1406p ps=1.12u w=0.74u l=0.13u
X1575 VSS.t909 VDD.t1670 VSS.t909 VSS.t910 sg13_lv_nmos ad=79.8f pd=0.8u as=0 ps=0 w=0.42u l=1u
X1576 VSS.t167 a_4187_1764.t16 a_17031_1842# VSS.t166 sg13_lv_nmos ad=0.2516p pd=2.16u as=0.1406p ps=1.12u w=0.74u l=0.6u
X1577 a_5731_15316# a_2595_15338.t3 a_7390_16071# VSS.t684 sg13_lv_nmos ad=0.2516p pd=2.16u as=0.2516p ps=2.16u w=0.74u l=0.13u
X1578 VSS.t259 a_1544_13226# a_1815_13577# VSS.t422 sg13_lv_nmos ad=0.1331p pd=1.12u as=0.1216p ps=1.02u w=0.64u l=0.13u
X1579 a_9953_1842# a_9757_1842# VDD.t1121 VDD.t399 sg13_lv_pmos ad=0.3808p pd=2.92u as=0.2128p ps=1.5u w=1.12u l=0.13u
X1580 VSS.t205 REF_MUX_SEL3 a_3543_6021# VSS.t649 sg13_lv_nmos ad=0.1331p pd=1.12u as=0.1216p ps=1.02u w=0.64u l=0.13u
X1581 a_21591_17497# a_21353_16869# a_21483_16869# VDD.t297 sg13_lv_pmos ad=0.2128p pd=1.5u as=0.3808p ps=2.92u w=1.12u l=0.2u
X1582 VDD.t330 a_4187_2434# a_26911_17497# VDD.t297 sg13_lv_pmos ad=0.3808p pd=2.92u as=0.2128p ps=1.5u w=1.12u l=0.6u
X1583 VDD.t1112 a_10843_1842# a_11277_1842# VDD.t399 sg13_lv_pmos ad=0.2128p pd=1.5u as=0.3808p ps=2.92u w=1.12u l=0.13u
X1584 a_26395_13226# a_26185_13226# VDD.t690 VDD.t50 sg13_lv_pmos ad=0.2128p pd=1.5u as=0.252p ps=1.57u w=1.12u l=0.13u
X1585 VDD.t291 a_4187_2434# a_25391_5315# VDD.t281 sg13_lv_pmos ad=0.3808p pd=2.92u as=0.2128p ps=1.5u w=1.12u l=0.6u
X1586 VSS.t970 VDD.t1652 VSS.t970 VSS.t972 sg13_lv_nmos ad=79.8f pd=0.8u as=0 ps=0 w=0.42u l=1u
X1587 a_16033_14024# a_15837_14024# VSS.t1626 VSS.t2071 sg13_lv_nmos ad=0.2516p pd=2.16u as=0.1406p ps=1.12u w=0.74u l=0.13u
X1588 a_4350_1044# a_3171_1047.t9 a_5768_1044# VSS.t570 sg13_lv_nmos ad=0.2516p pd=2.16u as=0.1406p ps=1.12u w=0.74u l=0.13u
X1589 a_9444_10280# a_9444_10280# VSS.t1469 VSS.t1464 sg13_lv_nmos ad=0.38p pd=2.38u as=0.68p ps=4.68u w=2u l=1u
X1590 VSS.t750 a_26803_1842# a_27237_1842# VSS.t1869 sg13_lv_nmos ad=0.1406p pd=1.12u as=0.2516p ps=2.16u w=0.74u l=0.13u
X1591 a_8155_3889# a_7945_3889# VDD.t894 VDD.t0 sg13_lv_pmos ad=0.2128p pd=1.5u as=0.252p ps=1.57u w=1.12u l=0.13u
X1592 a_5731_5979# a_8745_6209# a_7390_6734# VDD.t41 sg13_lv_pmos ad=0.3808p pd=2.92u as=0.3808p ps=2.92u w=1.12u l=0.13u
X1593 VDD.t341 a_4187_2434# a_22351_17497# VDD.t297 sg13_lv_pmos ad=0.3808p pd=2.92u as=0.2128p ps=1.5u w=1.12u l=0.6u
X1594 a_2391_16422# CHAN0_MUX_SEL0 a_2297_16422# VSS.t2181 sg13_lv_nmos ad=0.1216p pd=1.02u as=0.2176p ps=1.96u w=0.64u l=0.13u
X1595 a_20593_14024# a_20397_14024# VDD.t1220 VDD.t301 sg13_lv_pmos ad=0.3808p pd=2.92u as=0.2128p ps=1.5u w=1.12u l=0.13u
X1596 a_23111_4687# a_22873_4687# a_23003_4687# VSS.t2186 sg13_lv_nmos ad=0.1406p pd=1.12u as=0.2516p ps=2.16u w=0.74u l=0.2u
X1597 VDD.t1381 a_13883_14024# a_14317_14024# VDD.t301 sg13_lv_pmos ad=0.2128p pd=1.5u as=0.3808p ps=2.92u w=1.12u l=0.13u
X1598 VDD.t1130 a_6326_10280# a_6854_11676# VDD.t268 sg13_lv_pmos ad=0.38p pd=2.38u as=0.38p ps=2.38u w=2u l=1u
X1599 a_25630_3889# a_3747_3892.t2 a_27915_3889# VSS.t1513 sg13_lv_nmos ad=0.2516p pd=2.16u as=0.1406p ps=1.12u w=0.74u l=0.13u
X1600 a_3747_3892.t1 a_3449_4240# VSS.t397 VSS.t396 sg13_lv_nmos ad=0.1406p pd=1.12u as=0.1331p ps=1.12u w=0.74u l=0.13u
X1601 a_27048_3889# a_26477_4687# VDD.t597 VDD.t0 sg13_lv_pmos ad=0.2128p pd=1.5u as=0.3808p ps=2.92u w=1.12u l=0.13u
X1602 VSS.t1428 a_17683_4687# a_18117_4687# VSS.t1427 sg13_lv_nmos ad=0.1406p pd=1.12u as=0.2516p ps=2.16u w=0.74u l=0.13u
X1603 a_17031_7532# a_16793_7532# a_16923_7532# VSS.t53 sg13_lv_nmos ad=0.1406p pd=1.12u as=0.2516p ps=2.16u w=0.74u l=0.2u
X1604 VSS.t849 VDD.t1687 VSS.t849 VSS.t852 sg13_lv_nmos ad=0.1428p pd=1.52u as=0 ps=0 w=0.42u l=1u
X1605 a_12471_8160# a_12233_7532# a_12363_7532# VDD.t275 sg13_lv_pmos ad=0.2128p pd=1.5u as=0.3808p ps=2.92u w=1.12u l=0.2u
X1606 a_10713_4687# a_10517_4687# VSS.t456 VSS.t2256 sg13_lv_nmos ad=0.2516p pd=2.16u as=0.1406p ps=1.12u w=0.74u l=0.13u
X1607 a_11195_13226# a_10985_13226# VSS.t1824 VSS.t1823 sg13_lv_nmos ad=0.1406p pd=1.12u as=0.1665p ps=1.19u w=0.74u l=0.13u
X1608 a_5768_3889# a_5197_4687# VDD.t482 VDD.t0 sg13_lv_pmos ad=0.2128p pd=1.5u as=0.3808p ps=2.92u w=1.12u l=0.13u
X1609 a_6153_16869# a_5957_16869# VDD.t1123 VDD.t297 sg13_lv_pmos ad=0.3808p pd=2.92u as=0.2128p ps=1.5u w=1.12u l=0.13u
X1610 a_22590_6734# a_24084_6698# a_24008_6734# VDD.t41 sg13_lv_pmos ad=0.3808p pd=2.92u as=0.2128p ps=1.5u w=1.12u l=0.13u
X1611 VSS.t550 a_4763_14024# a_5197_14024# VSS.t1993 sg13_lv_nmos ad=0.1406p pd=1.12u as=0.2516p ps=2.16u w=0.74u l=0.13u
X1612 a_6635_13226# a_6425_13226# VDD.t1050 VDD.t50 sg13_lv_pmos ad=0.2128p pd=1.5u as=0.252p ps=1.57u w=1.12u l=0.13u
X1613 a_3449_12513# CHAN1_MUX_SEL2 VDD.t1543 VDD.t50 sg13_lv_pmos ad=0.1596p pd=1.22u as=0.2856p ps=2.36u w=0.84u l=0.13u
X1614 a_10649_11568# REF_CLK VDD.t270 VDD.t268 sg13_lv_pmos ad=0.4088p pd=2.97u as=1.03698p ps=6.245u w=1.12u l=0.13u
X1615 a_22488_13226# a_21917_14024# VSS.t1270 VSS.t1860 sg13_lv_nmos ad=0.1406p pd=1.12u as=0.2516p ps=2.16u w=0.74u l=0.13u
X1616 VSS.t363 a_15964_12471# a_16851_12491# VSS.t2234 sg13_lv_nmos ad=0.1371p pd=1.12u as=0.2176p ps=1.96u w=0.64u l=0.13u
X1617 a_2967_4240# CHAN2_MUX_SEL1 a_2873_4240# VSS.t648 sg13_lv_nmos ad=0.1216p pd=1.02u as=0.2176p ps=1.96u w=0.64u l=0.13u
X1618 a_10430_1044# a_12791_1008# a_12715_1044# VDD.t7 sg13_lv_pmos ad=0.3808p pd=2.92u as=0.2128p ps=1.5u w=1.12u l=0.13u
X1619 VSS.t262 a_7803_4687# a_8237_4687# VSS.t2263 sg13_lv_nmos ad=0.1406p pd=1.12u as=0.2516p ps=2.16u w=0.74u l=0.13u
X1620 VDD.t133 VSS.t1003 VDD.t132 VDD.t0 sg13_lv_pmos ad=0.34p pd=2.68u as=0 ps=0 w=1u l=1u
X1621 a_18795_6734# a_18585_6734# VSS.t2222 VSS.t2221 sg13_lv_nmos ad=0.1406p pd=1.12u as=0.1665p ps=1.19u w=0.74u l=0.13u
X1622 a_19311_1842# a_19073_1842# a_19203_1842# VSS.t1713 sg13_lv_nmos ad=0.1406p pd=1.12u as=0.2516p ps=2.16u w=0.74u l=0.2u
X1623 a_25630_13226# a_3747_13229.t2 a_27915_13226# VSS.t1949 sg13_lv_nmos ad=0.2516p pd=2.16u as=0.1406p ps=1.12u w=0.74u l=0.13u
X1624 a_24875_1044# a_24665_1044# VDD.t689 VDD.t7 sg13_lv_pmos ad=0.2128p pd=1.5u as=0.252p ps=1.57u w=1.12u l=0.13u
X1625 a_25630_16071# a_2595_16074.t2 a_26395_16071# VSS.t40 sg13_lv_nmos ad=0.2516p pd=2.16u as=0.1406p ps=1.12u w=0.74u l=0.13u
X1626 VDD.t1600 VSS.t867 VDD.t234 VDD.t4 sg13_lv_pmos ad=0.19p pd=1.38u as=0 ps=0 w=1u l=1u
X1627 a_19550_13226# a_19524_13190# a_19448_13226# VDD.t50 sg13_lv_pmos ad=0.3808p pd=2.92u as=0.2128p ps=1.5u w=1.12u l=0.13u
X1628 a_20831_7532# a_20593_7532# a_20723_7532# VSS.t2084 sg13_lv_nmos ad=0.1406p pd=1.12u as=0.2516p ps=2.16u w=0.74u l=0.2u
X1629 VSS.t715 a_2595_6737.t5 a_17351_6698# VSS.t714 sg13_lv_nmos ad=0.2516p pd=2.16u as=0.2516p ps=2.16u w=0.74u l=0.13u
X1630 a_5393_7532# a_5197_7532# VSS.t185 VSS.t184 sg13_lv_nmos ad=0.2516p pd=2.16u as=0.1406p ps=1.12u w=0.74u l=0.13u
X1631 a_25630_6734# a_3171_6737.t2 a_27048_6734# VSS.t725 sg13_lv_nmos ad=0.2516p pd=2.16u as=0.1406p ps=1.12u w=0.74u l=0.13u
X1632 VDD.t655 a_2595_1047.t3 a_23431_1008# VDD.t7 sg13_lv_pmos ad=0.3808p pd=2.92u as=0.3808p ps=2.92u w=1.12u l=0.13u
X1633 a_22590_13226# a_2595_13229.t3 a_23355_13226# VSS.t179 sg13_lv_nmos ad=0.2516p pd=2.16u as=0.1406p ps=1.12u w=0.74u l=0.13u
X1634 VSS.t870 VDD.t1682 VSS.t869 VSS.t868 sg13_lv_nmos ad=0.1428p pd=1.52u as=0 ps=0 w=0.42u l=1u
X1635 VSS.t2091 a_2297_12513# a_2595_12493.t1 VSS.t2094 sg13_lv_nmos ad=0.2812p pd=2.24u as=0.1406p ps=1.12u w=0.74u l=0.13u
X1636 VSS.t1189 a_4187_1764.t80 a_17031_7532# VSS.t1483 sg13_lv_nmos ad=0.2516p pd=2.16u as=0.1406p ps=1.12u w=0.74u l=0.6u
X1637 VSS.t1404 a_8997_14024# a_9465_13226# VSS.t2035 sg13_lv_nmos ad=0.1665p pd=1.19u as=0.2516p ps=2.16u w=0.74u l=0.13u
X1638 VDD.t122 VSS.t970 VDD.t121 VDD.t41 sg13_lv_pmos ad=0.19p pd=1.38u as=0 ps=0 w=1u l=1u
X1639 a_9953_7532# a_9757_7532# VDD.t474 VDD.t275 sg13_lv_pmos ad=0.3808p pd=2.92u as=0.2128p ps=1.5u w=1.12u l=0.13u
X1640 a_25630_6734# a_27991_6698# a_27915_6734# VDD.t41 sg13_lv_pmos ad=0.3808p pd=2.92u as=0.2128p ps=1.5u w=1.12u l=0.13u
X1641 a_20315_16071# a_20105_16071# VDD.t1170 VDD.t4 sg13_lv_pmos ad=0.2128p pd=1.5u as=0.252p ps=1.57u w=1.12u l=0.13u
X1642 VDD.t318 a_4187_2434# a_26911_14652# VDD.t301 sg13_lv_pmos ad=0.3808p pd=2.92u as=0.2128p ps=1.5u w=1.12u l=0.6u
X1643 VDD.t849 a_10843_7532# a_11277_7532# VDD.t275 sg13_lv_pmos ad=0.2128p pd=1.5u as=0.3808p ps=2.92u w=1.12u l=0.13u
X1644 VSS.t1156 a_7477_16869# a_7945_16071# VSS.t2140 sg13_lv_nmos ad=0.1665p pd=1.19u as=0.2516p ps=2.16u w=0.74u l=0.13u
X1645 a_21591_14652# a_21353_14024# a_21483_14024# VDD.t301 sg13_lv_pmos ad=0.2128p pd=1.5u as=0.3808p ps=2.92u w=1.12u l=0.2u
X1646 a_16108_5979# a_2019_6001.t2 a_16510_6734# VSS.t1954 sg13_lv_nmos ad=0.2516p pd=2.16u as=0.2516p ps=2.16u w=0.74u l=0.13u
X1647 a_4350_6734# a_3171_6737.t9 a_5768_6734# VSS.t1658 sg13_lv_nmos ad=0.2516p pd=2.16u as=0.1406p ps=1.12u w=0.74u l=0.13u
X1648 VDD.t953 a_13557_1842# a_14025_1044# VDD.t7 sg13_lv_pmos ad=0.252p pd=1.57u as=0.3808p ps=2.92u w=1.12u l=0.13u
X1649 CHAN2_MUX_OUT a_16851_3154# VDD.t838 VDD.t0 sg13_lv_pmos ad=0.2128p pd=1.5u as=0.2086p ps=1.5u w=1.12u l=0.13u
X1650 a_5768_16071# a_5197_16869# VSS.t1272 VSS.t1271 sg13_lv_nmos ad=0.1406p pd=1.12u as=0.2516p ps=2.16u w=0.74u l=0.13u
X1651 VSS.t215 a_26803_7532# a_27237_7532# VSS.t214 sg13_lv_nmos ad=0.1406p pd=1.12u as=0.2516p ps=2.16u w=0.74u l=0.13u
X1652 a_5731_3134# a_8745_3364# a_7390_3889# VDD.t0 sg13_lv_pmos ad=0.3808p pd=2.92u as=0.3808p ps=2.92u w=1.12u l=0.13u
X1653 VDD.t365 a_4187_2434# a_22351_14652# VDD.t301 sg13_lv_pmos ad=0.3808p pd=2.92u as=0.2128p ps=1.5u w=1.12u l=0.6u
X1654 VSS.t819 VDD.t1697 VSS.t819 VSS.t821 sg13_lv_nmos ad=79.8f pd=0.8u as=0 ps=0 w=0.42u l=1u
X1655 a_26673_4687# a_26477_4687# VDD.t521 VDD.t281 sg13_lv_pmos ad=0.3808p pd=2.92u as=0.2128p ps=1.5u w=1.12u l=0.13u
X1656 VDD.t467 a_24197_4687# a_24665_3889# VDD.t0 sg13_lv_pmos ad=0.252p pd=1.57u as=0.3808p ps=2.92u w=1.12u l=0.13u
X1657 VDD.t270 a_9547_11862# a_9547_11632# VDD.t268 sg13_lv_pmos ad=1.10612p pd=6.66u as=0.2442p ps=2.06u w=0.66u l=0.13u
X1658 a_23111_1842# a_22873_1842# a_23003_1842# VSS.t1915 sg13_lv_nmos ad=0.1406p pd=1.12u as=0.2516p ps=2.16u w=0.74u l=0.2u
X1659 a_16510_3889# a_18004_3853# a_17928_3889# VDD.t0 sg13_lv_pmos ad=0.3808p pd=2.92u as=0.2128p ps=1.5u w=1.12u l=0.13u
X1660 VDD.t887 a_10843_16869# a_11277_16869# VDD.t297 sg13_lv_pmos ad=0.2128p pd=1.5u as=0.3808p ps=2.92u w=1.12u l=0.13u
X1661 a_8808_13226# a_8237_14024# VDD.t1361 VDD.t50 sg13_lv_pmos ad=0.2128p pd=1.5u as=0.3808p ps=2.92u w=1.12u l=0.13u
X1662 VSS.t1931 a_17683_1842# a_18117_1842# VSS.t1930 sg13_lv_nmos ad=0.1406p pd=1.12u as=0.2516p ps=2.16u w=0.74u l=0.13u
X1663 a_27671_2470# a_27433_1842# a_27563_1842# VDD.t399 sg13_lv_pmos ad=0.2128p pd=1.5u as=0.3808p ps=2.92u w=1.12u l=0.2u
X1664 a_7151_17497# a_6913_16869# a_7043_16869# VDD.t297 sg13_lv_pmos ad=0.2128p pd=1.5u as=0.3808p ps=2.92u w=1.12u l=0.2u
X1665 a_4350_16071# a_3747_16074.t9 a_6635_16071# VSS.t403 sg13_lv_nmos ad=0.2516p pd=2.16u as=0.1406p ps=1.12u w=0.74u l=0.13u
X1666 VSS.t923 VDD.t1665 VSS.t431 VSS.t922 sg13_lv_nmos ad=0.1428p pd=1.52u as=0 ps=0 w=0.42u l=1u
X1667 VSS.t1095 VDD.t1615 VSS.t1095 VSS.t1097 sg13_lv_nmos ad=79.8f pd=0.8u as=0 ps=0 w=0.42u l=1u
X1668 a_10713_1842# a_10517_1842# VSS.t291 VSS.t1927 sg13_lv_nmos ad=0.2516p pd=2.16u as=0.1406p ps=1.12u w=0.74u l=0.13u
X1669 VDD.t462 a_3449_3176# a_3747_3156.t0 VDD.t0 sg13_lv_pmos ad=0.4256p pd=3u as=0.2128p ps=1.5u w=1.12u l=0.13u
X1670 a_8155_3889# a_7945_3889# VSS.t1233 VSS.t1232 sg13_lv_nmos ad=0.1406p pd=1.12u as=0.1665p ps=1.19u w=0.74u l=0.13u
X1671 a_4248_13226# a_4157_13495# VDD.t1287 VDD.t50 sg13_lv_pmos ad=0.2128p pd=1.5u as=0.3808p ps=2.92u w=1.12u l=0.13u
X1672 VSS.t1318 a_2019_1047.t8 a_7364_1008# VSS.t1317 sg13_lv_nmos ad=0.2516p pd=2.16u as=0.2516p ps=2.16u w=0.74u l=0.13u
X1673 a_6153_14024# a_5957_14024# VDD.t1342 VDD.t301 sg13_lv_pmos ad=0.3808p pd=2.92u as=0.2128p ps=1.5u w=1.12u l=0.13u
X1674 a_14751_4687# a_14513_4687# a_14643_4687# VSS.t1170 sg13_lv_nmos ad=0.1406p pd=1.12u as=0.2516p ps=2.16u w=0.74u l=0.2u
X1675 a_2595_16074.t0 a_2297_16422# VDD.t962 VDD.t4 sg13_lv_pmos ad=0.2128p pd=1.5u as=0.1918p ps=1.5u w=1.12u l=0.13u
X1676 a_27048_3889# a_26477_4687# VSS.t402 VSS.t401 sg13_lv_nmos ad=0.1406p pd=1.12u as=0.2516p ps=2.16u w=0.74u l=0.13u
X1677 a_7390_13226# a_9751_13190# a_9675_13226# VDD.t50 sg13_lv_pmos ad=0.3808p pd=2.92u as=0.2128p ps=1.5u w=1.12u l=0.13u
X1678 VDD.t1092 a_2595_13229.t4 a_20391_13190# VDD.t50 sg13_lv_pmos ad=0.3808p pd=2.92u as=0.3808p ps=2.92u w=1.12u l=0.13u
X1679 VSS.t878 VDD.t1680 VSS.t876 VSS.t877 sg13_lv_nmos ad=79.8f pd=0.8u as=0 ps=0 w=0.42u l=1u
X1680 VDD.t411 a_4187_2434# a_6391_5315# VDD.t281 sg13_lv_pmos ad=0.3808p pd=2.92u as=0.2128p ps=1.5u w=1.12u l=0.6u
X1681 VSS.t75 a_7803_1842# a_8237_1842# VSS.t74 sg13_lv_nmos ad=0.1406p pd=1.12u as=0.2516p ps=2.16u w=0.74u l=0.13u
X1682 VSS.t2386 VSS.t2383 VSS.t2383 VSS.t2384 sg13_lv_nmos ad=0.1406p pd=1.12u as=0 ps=0 w=0.74u l=0.13u
X1683 a_24875_16071# a_24665_16071# VSS.t326 VSS.t1783 sg13_lv_nmos ad=0.1406p pd=1.12u as=0.1665p ps=1.19u w=0.74u l=0.13u
X1684 VDD.t1258 a_2873_15358# a_3171_15338.t0 VDD.t4 sg13_lv_pmos ad=0.4256p pd=3u as=0.2128p ps=1.5u w=1.12u l=0.13u
X1685 VSS.t1095 VDD.t1616 VSS.t1093 VSS.t1094 sg13_lv_nmos ad=79.8f pd=0.8u as=0 ps=0 w=0.42u l=1u
X1686 VSS.t1220 a_2873_15358# a_3171_15338.t1 VSS.t260 sg13_lv_nmos ad=0.2812p pd=2.24u as=0.1406p ps=1.12u w=0.74u l=0.13u
X1687 a_19311_7532# a_19073_7532# a_19203_7532# VSS.t58 sg13_lv_nmos ad=0.1406p pd=1.12u as=0.2516p ps=2.16u w=0.74u l=0.2u
X1688 VDD.t437 a_4187_2434# a_16271_2470# VDD.t399 sg13_lv_pmos ad=0.3808p pd=2.92u as=0.2128p ps=1.5u w=1.12u l=0.6u
X1689 VSS.t302 a_8563_16869# a_8997_16869# VSS.t1278 sg13_lv_nmos ad=0.1406p pd=1.12u as=0.2516p ps=2.16u w=0.74u l=0.13u
X1690 a_21835_13226# a_21625_13226# VSS.t1337 VSS.t1336 sg13_lv_nmos ad=0.1406p pd=1.12u as=0.1665p ps=1.19u w=0.74u l=0.13u
X1691 a_13470_16071# a_13444_16035# a_13368_16071# VDD.t4 sg13_lv_pmos ad=0.3808p pd=2.92u as=0.2128p ps=1.5u w=1.12u l=0.13u
X1692 a_5768_3889# a_5197_4687# VSS.t119 VSS.t118 sg13_lv_nmos ad=0.1406p pd=1.12u as=0.2516p ps=2.16u w=0.74u l=0.13u
X1693 a_4111_4687# CHAN2_DELAY_IN a_4003_4687# VSS.t1776 sg13_lv_nmos ad=0.1406p pd=1.12u as=0.2516p ps=2.16u w=0.74u l=0.2u
X1694 VDD.t968 a_3171_3892.t4 a_21044_3853# VDD.t0 sg13_lv_pmos ad=0.3808p pd=2.92u as=0.3808p ps=2.92u w=1.12u l=0.13u
X1695 VSS.t1075 VDD.t1621 VSS.t1075 VSS.t1076 sg13_lv_nmos ad=0.1428p pd=1.52u as=0 ps=0 w=0.42u l=1u
X1696 VDD.t1531 a_1721_4240# a_2019_3892.t0 VDD.t0 sg13_lv_pmos ad=0.4256p pd=3u as=0.2128p ps=1.5u w=1.12u l=0.13u
X1697 VDD.t292 a_4187_2434# a_20831_5315# VDD.t281 sg13_lv_pmos ad=0.3808p pd=2.92u as=0.2128p ps=1.5u w=1.12u l=0.6u
X1698 VDD.t1277 a_26043_1842# a_26477_1842# VDD.t399 sg13_lv_pmos ad=0.2128p pd=1.5u as=0.3808p ps=2.92u w=1.12u l=0.13u
X1699 a_27915_13226# a_27705_13226# VDD.t588 VDD.t50 sg13_lv_pmos ad=0.2128p pd=1.5u as=0.252p ps=1.57u w=1.12u l=0.13u
X1700 VDD.t3 VSS.t1034 VDD.t2 VDD.t0 sg13_lv_pmos ad=0.19p pd=1.38u as=0 ps=0 w=1u l=1u
X1701 VSS.t251 a_1544_16071# a_1815_16422# VSS.t1755 sg13_lv_nmos ad=0.1331p pd=1.12u as=0.1216p ps=1.02u w=0.64u l=0.13u
X1702 a_17553_14024# a_17357_14024# VSS.t346 VSS.t2069 sg13_lv_nmos ad=0.2516p pd=2.16u as=0.1406p ps=1.12u w=0.74u l=0.13u
X1703 a_5731_15316# a_2019_15338.t3 a_4350_16071# VSS.t2115 sg13_lv_nmos ad=0.2516p pd=2.16u as=0.2516p ps=2.16u w=0.74u l=0.13u
X1704 a_22488_1044# a_21917_1842# VSS.t1615 VSS.t1867 sg13_lv_nmos ad=0.1406p pd=1.12u as=0.2516p ps=2.16u w=0.74u l=0.13u
X1705 VDD.t578 REF_MUX_SEL4 a_15765_6153# VDD.t41 sg13_lv_pmos ad=0.3808p pd=2.92u as=0.3808p ps=2.92u w=1.12u l=0.13u
X1706 VDD.t306 a_4187_2434# a_23871_17497# VDD.t297 sg13_lv_pmos ad=0.3808p pd=2.92u as=0.2128p ps=1.5u w=1.12u l=0.6u
X1707 VSS.t728 a_4187_1764.t131 a_4111_14024# VSS.t727 sg13_lv_nmos ad=0.2516p pd=2.16u as=0.1406p ps=1.12u w=0.74u l=0.6u
X1708 a_3543_331# CHAN3_MUX_SEL2 a_3449_331# VSS.t1508 sg13_lv_nmos ad=0.1216p pd=1.02u as=0.2176p ps=1.96u w=0.64u l=0.13u
X1709 VSS.t933 VDD.t1662 VSS.t932 VSS.t931 sg13_lv_nmos ad=0.1428p pd=1.52u as=0 ps=0 w=0.42u l=1u
X1710 a_23355_13226# a_23145_13226# VDD.t958 VDD.t50 sg13_lv_pmos ad=0.2128p pd=1.5u as=0.252p ps=1.57u w=1.12u l=0.13u
X1711 a_8155_6734# a_7945_6734# VDD.t556 VDD.t41 sg13_lv_pmos ad=0.2128p pd=1.5u as=0.252p ps=1.57u w=1.12u l=0.13u
X1712 a_22590_1044# a_24084_1008# a_24008_1044# VDD.t7 sg13_lv_pmos ad=0.3808p pd=2.92u as=0.2128p ps=1.5u w=1.12u l=0.13u
X1713 VDD.t13 VSS.t1065 VDD.t11 VDD.t7 sg13_lv_pmos ad=0.19p pd=1.38u as=0 ps=0 w=1u l=1u
X1714 VSS.t438 a_13123_4687# a_13557_4687# VSS.t2255 sg13_lv_nmos ad=0.1406p pd=1.12u as=0.2516p ps=2.16u w=0.74u l=0.13u
X1715 a_10191_5315# a_9953_4687# a_10083_4687# VDD.t281 sg13_lv_pmos ad=0.2128p pd=1.5u as=0.3808p ps=2.92u w=1.12u l=0.2u
X1716 a_23111_7532# a_22873_7532# a_23003_7532# VSS.t201 sg13_lv_nmos ad=0.1406p pd=1.12u as=0.2516p ps=2.16u w=0.74u l=0.2u
X1717 a_13106_11047# a_12907_11110# VSS.t284 VSS.t283 sg13_lv_nmos ad=0.27427p pd=2.28u as=1.45407p ps=9.445u w=0.795u l=0.13u
X1718 VDD.t451 a_4187_2434# a_20071_2470# VDD.t399 sg13_lv_pmos ad=0.3808p pd=2.92u as=0.2128p ps=1.5u w=1.12u l=0.6u
X1719 VDD.t1350 a_10843_14024# a_11277_14024# VDD.t301 sg13_lv_pmos ad=0.2128p pd=1.5u as=0.3808p ps=2.92u w=1.12u l=0.13u
X1720 a_25913_4687# a_25717_4687# VSS.t782 VSS.t1457 sg13_lv_nmos ad=0.2516p pd=2.16u as=0.1406p ps=1.12u w=0.74u l=0.13u
X1721 a_27048_6734# a_26477_7532# VDD.t639 VDD.t41 sg13_lv_pmos ad=0.2128p pd=1.5u as=0.3808p ps=2.92u w=1.12u l=0.13u
X1722 a_5731_12471# a_8745_12701# a_7390_13226# VDD.t50 sg13_lv_pmos ad=0.3808p pd=2.92u as=0.3808p ps=2.92u w=1.12u l=0.13u
X1723 a_27671_8160# a_27433_7532# a_27563_7532# VDD.t275 sg13_lv_pmos ad=0.2128p pd=1.5u as=0.3808p ps=2.92u w=1.12u l=0.2u
X1724 VSS.t217 a_17683_7532# a_18117_7532# VSS.t216 sg13_lv_nmos ad=0.1406p pd=1.12u as=0.2516p ps=2.16u w=0.74u l=0.13u
X1725 a_7151_14652# a_6913_14024# a_7043_14024# VDD.t301 sg13_lv_pmos ad=0.2128p pd=1.5u as=0.3808p ps=2.92u w=1.12u l=0.2u
X1726 a_10713_7532# a_10517_7532# VSS.t449 VSS.t2167 sg13_lv_nmos ad=0.2516p pd=2.16u as=0.1406p ps=1.12u w=0.74u l=0.13u
X1727 VDD.t746 VDD.t744 VDD.t745 VDD.t297 sg13_lv_pmos ad=0.3808p pd=2.92u as=0 ps=0 w=1.12u l=0.13u
X1728 a_12715_13226# a_12505_13226# VSS.t1920 VSS.t1919 sg13_lv_nmos ad=0.1406p pd=1.12u as=0.1665p ps=1.19u w=0.74u l=0.13u
X1729 VSS.t1378 a_19963_16869# a_20397_16869# VSS.t1491 sg13_lv_nmos ad=0.1406p pd=1.12u as=0.2516p ps=2.16u w=0.74u l=0.13u
X1730 a_7673_16869# a_7477_16869# VDD.t642 VDD.t297 sg13_lv_pmos ad=0.3808p pd=2.92u as=0.2128p ps=1.5u w=1.12u l=0.13u
X1731 a_11195_16071# a_10985_16071# VSS.t1715 VSS.t1714 sg13_lv_nmos ad=0.1406p pd=1.12u as=0.1665p ps=1.19u w=0.74u l=0.13u
X1732 VSS.t707 a_6283_14024# a_6717_14024# VSS.t2004 sg13_lv_nmos ad=0.1406p pd=1.12u as=0.2516p ps=2.16u w=0.74u l=0.13u
X1733 VSS.t673 a_25717_14024# a_26185_13226# VSS.t1241 sg13_lv_nmos ad=0.1665p pd=1.19u as=0.2516p ps=2.16u w=0.74u l=0.13u
X1734 VSS.t111 a_2019_6737.t8 a_7364_6698# VSS.t110 sg13_lv_nmos ad=0.2516p pd=2.16u as=0.2516p ps=2.16u w=0.74u l=0.13u
X1735 a_5768_6734# a_5197_7532# VDD.t505 VDD.t41 sg13_lv_pmos ad=0.2128p pd=1.5u as=0.3808p ps=2.92u w=1.12u l=0.13u
X1736 VSS.t86 a_24197_4687# a_24665_3889# VSS.t85 sg13_lv_nmos ad=0.1665p pd=1.19u as=0.2516p ps=2.16u w=0.74u l=0.13u
X1737 a_24008_13226# a_23437_14024# VSS.t181 VSS.t1321 sg13_lv_nmos ad=0.1406p pd=1.12u as=0.2516p ps=2.16u w=0.74u l=0.13u
X1738 VDD.t197 VSS.t1111 VDD.t196 VDD.t7 sg13_lv_pmos ad=0.19p pd=1.38u as=0 ps=0 w=1u l=1u
X1739 VSS.t494 a_2873_1395# a_3171_1047.t1 VSS.t495 sg13_lv_nmos ad=0.2812p pd=2.24u as=0.1406p ps=1.12u w=0.74u l=0.13u
X1740 a_16510_3889# a_3171_3892.t5 a_17928_3889# VSS.t1348 sg13_lv_nmos ad=0.2516p pd=2.16u as=0.1406p ps=1.12u w=0.74u l=0.13u
X1741 a_14751_1842# a_14513_1842# a_14643_1842# VSS.t1717 sg13_lv_nmos ad=0.1406p pd=1.12u as=0.2516p ps=2.16u w=0.74u l=0.2u
X1742 a_22488_16071# a_21917_16869# VSS.t138 VSS.t1139 sg13_lv_nmos ad=0.1406p pd=1.12u as=0.2516p ps=2.16u w=0.74u l=0.13u
X1743 a_25630_1044# a_27991_1008# a_27915_1044# VDD.t7 sg13_lv_pmos ad=0.3808p pd=2.92u as=0.2128p ps=1.5u w=1.12u l=0.13u
X1744 VDD.t110 VSS.t878 VDD.t176 VDD.t50 sg13_lv_pmos ad=0.34p pd=2.68u as=0 ps=0 w=1u l=1u
X1745 VSS.t1554 a_4187_1764.t98 VSS.t1552 VSS.t1537 sg13_lv_nmos ad=1.33p pd=7.38u as=0 ps=0 w=7u l=7u
X1746 VSS.t812 a_7803_7532# a_8237_7532# VSS.t2172 sg13_lv_nmos ad=0.1406p pd=1.12u as=0.2516p ps=2.16u w=0.74u l=0.13u
X1747 a_13132_11110# a_13106_11047# VDD.t270 VDD.t268 sg13_lv_pmos ad=0.3927p pd=2.99u as=1.10612p ps=6.66u w=1.155u l=0.13u
X1748 VSS.t2399 VSS.t2396 VSS.t2396 VSS.t2397 sg13_lv_nmos ad=0.1406p pd=1.12u as=0 ps=0 w=0.74u l=0.13u
X1749 VDD.t387 a_4187_2434# a_16271_8160# VDD.t275 sg13_lv_pmos ad=0.3808p pd=2.92u as=0.2128p ps=1.5u w=1.12u l=0.6u
X1750 a_7673_4687# a_7477_4687# VDD.t847 VDD.t281 sg13_lv_pmos ad=0.3808p pd=2.92u as=0.2128p ps=1.5u w=1.12u l=0.13u
X1751 VDD.t751 VDD.t749 VDD.t750 VDD.t297 sg13_lv_pmos ad=0.3808p pd=2.92u as=0 ps=0 w=1.12u l=0.6u
X1752 a_25630_16071# a_3747_16074.t2 a_27915_16071# VSS.t406 sg13_lv_nmos ad=0.2516p pd=2.16u as=0.1406p ps=1.12u w=0.74u l=0.13u
X1753 VDD.t323 a_4187_2434# a_10191_17497# VDD.t297 sg13_lv_pmos ad=0.3808p pd=2.92u as=0.2128p ps=1.5u w=1.12u l=0.6u
X1754 a_4111_1842# CHAN3_DELAY_IN a_4003_1842# VSS.t2177 sg13_lv_nmos ad=0.1406p pd=1.12u as=0.2516p ps=2.16u w=0.74u l=0.2u
X1755 a_18551_14024# a_18313_14024# a_18443_14024# VSS.t2295 sg13_lv_nmos ad=0.1406p pd=1.12u as=0.2516p ps=2.16u w=0.74u l=0.2u
X1756 a_22590_13226# a_3747_13229.t3 a_24875_13226# VSS.t506 sg13_lv_nmos ad=0.2516p pd=2.16u as=0.1406p ps=1.12u w=0.74u l=0.13u
X1757 a_3171_16074.t0 a_2873_16422# VDD.t892 VDD.t4 sg13_lv_pmos ad=0.2128p pd=1.5u as=0.1918p ps=1.5u w=1.12u l=0.13u
X1758 VSS.t1085 a_3747_311.t3 a_14825_519# VSS.t2163 sg13_lv_nmos ad=0.2516p pd=2.16u as=0.2516p ps=2.16u w=0.74u l=0.13u
X1759 a_17553_1842# a_17357_1842# VDD.t1164 VDD.t399 sg13_lv_pmos ad=0.3808p pd=2.92u as=0.2128p ps=1.5u w=1.12u l=0.13u
X1760 VDD.t1464 VSS.t857 VDD.t86 VDD.t4 sg13_lv_pmos ad=0.19p pd=1.38u as=0 ps=0 w=1u l=1u
X1761 VSS.t2014 a_1256_289# a_2967_331# VSS.t2046 sg13_lv_nmos ad=0.1331p pd=1.12u as=0.1216p ps=1.02u w=0.64u l=0.13u
X1762 VSS.t256 a_1544_1044# a_2391_1395# VSS.t255 sg13_lv_nmos ad=0.1331p pd=1.12u as=0.1216p ps=1.02u w=0.64u l=0.13u
X1763 a_22590_16071# a_2595_16074.t3 a_23355_16071# VSS.t2082 sg13_lv_nmos ad=0.2516p pd=2.16u as=0.1406p ps=1.12u w=0.74u l=0.13u
X1764 VDD.t593 a_26043_7532# a_26477_7532# VDD.t275 sg13_lv_pmos ad=0.2128p pd=1.5u as=0.3808p ps=2.92u w=1.12u l=0.13u
X1765 a_8671_2470# a_8433_1842# a_8563_1842# VDD.t399 sg13_lv_pmos ad=0.2128p pd=1.5u as=0.3808p ps=2.92u w=1.12u l=0.2u
X1766 VSS.t300 a_8997_16869# a_9465_16071# VSS.t299 sg13_lv_nmos ad=0.1665p pd=1.19u as=0.2516p ps=2.16u w=0.74u l=0.13u
X1767 a_13470_1044# a_2019_1047.t6 a_13368_1044# VSS.t151 sg13_lv_nmos ad=0.2516p pd=2.16u as=0.1406p ps=1.12u w=0.74u l=0.13u
X1768 a_2019_1047.t1 a_1721_1395# VSS.t256 VSS.t1143 sg13_lv_nmos ad=0.1406p pd=1.12u as=0.1331p ps=1.12u w=0.74u l=0.13u
X1769 VSS.t981 VDD.t1648 VSS.t981 VSS.t985 sg13_lv_nmos ad=79.8f pd=0.8u as=0 ps=0 w=0.42u l=1u
X1770 a_6854_11144# a_6854_11144# a_9444_10280# VSS.t2237 sg13_lv_nmos ad=0.38p pd=2.38u as=0.68p ps=4.68u w=2u l=1u
X1771 a_22488_6734# a_21917_7532# VSS.t315 VSS.t314 sg13_lv_nmos ad=0.1406p pd=1.12u as=0.2516p ps=2.16u w=0.74u l=0.13u
X1772 VSS.t2 a_3171_3156.t2 a_23945_3364# VSS.t1 sg13_lv_nmos ad=0.2516p pd=2.16u as=0.2516p ps=2.16u w=0.74u l=0.13u
X1773 VSS.t34 a_1256_3134# a_2967_3176# VSS.t702 sg13_lv_nmos ad=0.1331p pd=1.12u as=0.1216p ps=1.02u w=0.64u l=0.13u
X1774 VDD.t68 VSS.t933 VDD.t67 VDD.t41 sg13_lv_pmos ad=0.34p pd=2.68u as=0 ps=0 w=1u l=1u
X1775 VSS.t1822 a_3449_13577# a_3747_13229.t1 VSS.t1821 sg13_lv_nmos ad=0.2812p pd=2.24u as=0.1406p ps=1.12u w=0.74u l=0.13u
X1776 a_15964_289# a_15765_463# a_5731_289# VSS.t2305 sg13_lv_nmos ad=0.2183p pd=1.33u as=0.2516p ps=2.16u w=0.74u l=0.13u
X1777 VDD.t669 CHAN2_MUX_SEL4 a_15765_3308# VDD.t0 sg13_lv_pmos ad=0.3808p pd=2.92u as=0.3808p ps=2.92u w=1.12u l=0.13u
X1778 VSS.t1800 a_3747_6001.t3 a_14825_6209# VSS.t1799 sg13_lv_nmos ad=0.2516p pd=2.16u as=0.2516p ps=2.16u w=0.74u l=0.13u
X1779 VDD.t364 a_4187_2434# a_23871_14652# VDD.t301 sg13_lv_pmos ad=0.3808p pd=2.92u as=0.2128p ps=1.5u w=1.12u l=0.6u
X1780 VSS.t341 a_3171_3892.t4 a_21044_3853# VSS.t1357 sg13_lv_nmos ad=0.2516p pd=2.16u as=0.2516p ps=2.16u w=0.74u l=0.13u
X1781 a_17928_16071# a_17357_16869# VDD.t630 VDD.t4 sg13_lv_pmos ad=0.2128p pd=1.5u as=0.3808p ps=2.92u w=1.12u l=0.13u
X1782 VDD.t410 a_4187_2434# a_11711_5315# VDD.t281 sg13_lv_pmos ad=0.3808p pd=2.92u as=0.2128p ps=1.5u w=1.12u l=0.6u
X1783 a_3747_6001.t0 a_3449_6021# VDD.t513 VDD.t41 sg13_lv_pmos ad=0.2128p pd=1.5u as=0.1918p ps=1.5u w=1.12u l=0.13u
X1784 a_25630_13226# a_26471_13190# a_26395_13226# VDD.t50 sg13_lv_pmos ad=0.3808p pd=2.92u as=0.2128p ps=1.5u w=1.12u l=0.13u
X1785 VSS.t369 a_3171_1047.t3 a_24084_1008# VSS.t368 sg13_lv_nmos ad=0.2516p pd=2.16u as=0.2516p ps=2.16u w=0.74u l=0.13u
X1786 VSS.t1148 a_13123_1842# a_13557_1842# VSS.t1770 sg13_lv_nmos ad=0.1406p pd=1.12u as=0.2516p ps=2.16u w=0.74u l=0.13u
X1787 VDD.t516 a_24197_7532# a_24665_6734# VDD.t41 sg13_lv_pmos ad=0.252p pd=1.57u as=0.3808p ps=2.92u w=1.12u l=0.13u
X1788 VDD.t686 a_12363_16869# a_12797_16869# VDD.t297 sg13_lv_pmos ad=0.2128p pd=1.5u as=0.3808p ps=2.92u w=1.12u l=0.13u
X1789 VDD.t391 a_4187_2434# a_20071_8160# VDD.t275 sg13_lv_pmos ad=0.3808p pd=2.92u as=0.2128p ps=1.5u w=1.12u l=0.6u
X1790 VDD.t936 VSS.t1113 VDD.t1231 VDD.t7 sg13_lv_pmos ad=0.34p pd=2.68u as=0 ps=0 w=1u l=1u
X1791 a_16510_6734# a_18004_6698# a_17928_6734# VDD.t41 sg13_lv_pmos ad=0.3808p pd=2.92u as=0.2128p ps=1.5u w=1.12u l=0.13u
X1792 a_8671_17497# a_8433_16869# a_8563_16869# VDD.t297 sg13_lv_pmos ad=0.2128p pd=1.5u as=0.3808p ps=2.92u w=1.12u l=0.2u
X1793 a_25913_1842# a_25717_1842# VSS.t489 VSS.t1977 sg13_lv_nmos ad=0.2516p pd=2.16u as=0.1406p ps=1.12u w=0.74u l=0.13u
X1794 VDD.t855 a_21483_4687# a_21917_4687# VDD.t281 sg13_lv_pmos ad=0.2128p pd=1.5u as=0.3808p ps=2.92u w=1.12u l=0.13u
X1795 VDD.t911 a_7477_14024# a_7945_13226# VDD.t50 sg13_lv_pmos ad=0.252p pd=1.57u as=0.3808p ps=2.92u w=1.12u l=0.13u
X1796 a_2297_331# CHAN3_MUX_SEL2 VDD.t1052 VDD.t7 sg13_lv_pmos ad=0.1596p pd=1.22u as=0.2856p ps=2.36u w=0.84u l=0.13u
X1797 a_4187_1764.t0 DLL_RESETN VDD.t877 VDD.t293 sg13_lv_pmos ad=0.158p pd=1.245u as=0.272p ps=2.28u w=0.8u l=0.2u
X1798 VSS.t1099 VDD.t1614 VSS.t776 VSS.t1098 sg13_lv_nmos ad=0.1428p pd=1.52u as=0 ps=0 w=0.42u l=1u
X1799 a_21353_1842# a_21157_1842# VDD.t1327 VDD.t399 sg13_lv_pmos ad=0.3808p pd=2.92u as=0.2128p ps=1.5u w=1.12u l=0.13u
X1800 VDD.t757 VDD.t755 VDD.t756 VDD.t301 sg13_lv_pmos ad=0.3808p pd=2.92u as=0 ps=0 w=1.12u l=0.13u
X1801 a_5768_13226# a_5197_14024# VDD.t1347 VDD.t50 sg13_lv_pmos ad=0.2128p pd=1.5u as=0.3808p ps=2.92u w=1.12u l=0.13u
X1802 a_13368_3889# a_12797_4687# VDD.t544 VDD.t0 sg13_lv_pmos ad=0.2128p pd=1.5u as=0.3808p ps=2.92u w=1.12u l=0.13u
X1803 VDD.t324 a_4187_2434# a_9431_17497# VDD.t297 sg13_lv_pmos ad=0.3808p pd=2.92u as=0.2128p ps=1.5u w=1.12u l=0.6u
X1804 VDD.t459 a_26803_16869# a_27237_16869# VDD.t297 sg13_lv_pmos ad=0.2128p pd=1.5u as=0.3808p ps=2.92u w=1.12u l=0.13u
X1805 a_16108_15316# a_3747_15338.t2 a_25630_16071# VSS.t1261 sg13_lv_nmos ad=0.2516p pd=2.16u as=0.2516p ps=2.16u w=0.74u l=0.13u
X1806 a_7673_14024# a_7477_14024# VDD.t1330 VDD.t301 sg13_lv_pmos ad=0.3808p pd=2.92u as=0.2128p ps=1.5u w=1.12u l=0.13u
X1807 a_2873_331# CHAN3_MUX_SEL3 VDD.t1043 VDD.t7 sg13_lv_pmos ad=0.1596p pd=1.22u as=0.2856p ps=2.36u w=0.84u l=0.13u
X1808 VDD.t840 a_7043_1842# a_7477_1842# VDD.t399 sg13_lv_pmos ad=0.2128p pd=1.5u as=0.3808p ps=2.92u w=1.12u l=0.13u
X1809 a_15464_9374# a_14851_10872# VDD.t489 VDD.t268 sg13_lv_pmos ad=0.4312p pd=3.01u as=0.2639p ps=1.81u w=1.12u l=0.13u
X1810 VSS.t1175 a_2873_7085# a_3171_6737.t1 VSS.t1176 sg13_lv_nmos ad=0.2812p pd=2.24u as=0.1406p ps=1.12u w=0.74u l=0.13u
X1811 VSS.t948 VDD.t1657 VSS.t948 VSS.t951 sg13_lv_nmos ad=0.1428p pd=1.52u as=0 ps=0 w=0.42u l=1u
X1812 a_10430_13226# a_2595_13229.t7 a_11195_13226# VSS.t1639 sg13_lv_nmos ad=0.2516p pd=2.16u as=0.1406p ps=1.12u w=0.74u l=0.13u
X1813 a_14751_7532# a_14513_7532# a_14643_7532# VSS.t1221 sg13_lv_nmos ad=0.1406p pd=1.12u as=0.2516p ps=2.16u w=0.74u l=0.2u
X1814 VSS.t840 VDD.t1691 VSS.t839 VSS.t838 sg13_lv_nmos ad=0.1428p pd=1.52u as=0 ps=0 w=0.42u l=1u
X1815 a_6326_10280# a_6326_10280# VDD.t1128 VDD.t268 sg13_lv_pmos ad=0.38p pd=2.38u as=0.38p ps=2.38u w=2u l=1u
X1816 a_5778_9057# a_6126_9506# a_6326_10280# VSS.t14 sg13_lv_nmos ad=0.68p pd=4.68u as=0.42p ps=2.42u w=2u l=1u
X1817 VSS.t2372 VSS.t2372 VSS.t2374 VSS.t2373 sg13_lv_nmos ad=0.1406p pd=1.12u as=0 ps=0 w=0.74u l=0.13u
X1818 VSS.t1021 VDD.t1637 VSS.t1021 VSS.t1022 sg13_lv_nmos ad=0.1428p pd=1.52u as=0 ps=0 w=0.42u l=1u
X1819 a_4350_13226# a_6711_13190# a_6635_13226# VDD.t50 sg13_lv_pmos ad=0.3808p pd=2.92u as=0.2128p ps=1.5u w=1.12u l=0.13u
X1820 VDD.t269 a_12849_11557# a_13306_11995# VDD.t268 sg13_lv_pmos ad=0.36237p pd=2.605u as=79.8f ps=0.8u w=0.42u l=0.13u
X1821 CHAN2_DELAY_OUT_LAST a_27997_4687# VSS.t350 VSS.t349 sg13_lv_nmos ad=0.2516p pd=2.16u as=0.1406p ps=1.12u w=0.74u l=0.13u
X1822 a_13470_16071# a_14964_16035# a_14888_16071# VDD.t4 sg13_lv_pmos ad=0.3808p pd=2.92u as=0.2128p ps=1.5u w=1.12u l=0.13u
X1823 a_8155_1044# a_7945_1044# VDD.t617 VDD.t7 sg13_lv_pmos ad=0.2128p pd=1.5u as=0.252p ps=1.57u w=1.12u l=0.13u
X1824 a_21835_16071# a_21625_16071# VSS.t245 VSS.t1698 sg13_lv_nmos ad=0.1406p pd=1.12u as=0.1665p ps=1.19u w=0.74u l=0.13u
X1825 a_4350_3889# a_6711_3853# a_6635_3889# VDD.t0 sg13_lv_pmos ad=0.3808p pd=2.92u as=0.2128p ps=1.5u w=1.12u l=0.13u
X1826 VDD.t762 VDD.t760 VDD.t761 VDD.t301 sg13_lv_pmos ad=0.3808p pd=2.92u as=0 ps=0 w=1.12u l=0.6u
X1827 VSS.t102 a_3171_13229.t9 a_5844_13190# VSS.t101 sg13_lv_nmos ad=0.2516p pd=2.16u as=0.2516p ps=2.16u w=0.74u l=0.13u
X1828 VSS.t309 a_18117_1842# a_18585_1044# VSS.t1932 sg13_lv_nmos ad=0.1665p pd=1.19u as=0.2516p ps=2.16u w=0.74u l=0.13u
X1829 VSS.t276 a_5523_16869# a_5957_16869# VSS.t1687 sg13_lv_nmos ad=0.1406p pd=1.12u as=0.2516p ps=2.16u w=0.74u l=0.13u
X1830 VDD.t348 a_4187_2434# a_10191_14652# VDD.t301 sg13_lv_pmos ad=0.3808p pd=2.92u as=0.2128p ps=1.5u w=1.12u l=0.6u
X1831 a_4111_7532# REF_CLK a_4003_7532# VSS.t2132 sg13_lv_nmos ad=0.1406p pd=1.12u as=0.2516p ps=2.16u w=0.74u l=0.2u
X1832 VDD.t947 a_3171_6737.t4 a_21044_6698# VDD.t41 sg13_lv_pmos ad=0.3808p pd=2.92u as=0.3808p ps=2.92u w=1.12u l=0.13u
X1833 a_10430_16071# a_10404_16035# a_10328_16071# VDD.t4 sg13_lv_pmos ad=0.3808p pd=2.92u as=0.2128p ps=1.5u w=1.12u l=0.13u
X1834 a_17553_7532# a_17357_7532# VDD.t861 VDD.t275 sg13_lv_pmos ad=0.3808p pd=2.92u as=0.2128p ps=1.5u w=1.12u l=0.13u
X1835 VSS.t232 a_1544_6734# a_2391_7085# VSS.t642 sg13_lv_nmos ad=0.1331p pd=1.12u as=0.1216p ps=1.02u w=0.64u l=0.13u
X1836 VDD.t84 VSS.t981 VDD.t82 VDD.t41 sg13_lv_pmos ad=0.19p pd=1.38u as=0 ps=0 w=1u l=1u
X1837 a_8671_8160# a_8433_7532# a_8563_7532# VDD.t275 sg13_lv_pmos ad=0.2128p pd=1.5u as=0.3808p ps=2.92u w=1.12u l=0.2u
X1838 a_6913_4687# a_6717_4687# VSS.t796 VSS.t795 sg13_lv_nmos ad=0.2516p pd=2.16u as=0.1406p ps=1.12u w=0.74u l=0.13u
X1839 VSS.t115 a_4187_1764.t46 a_18551_4687# VSS.t2322 sg13_lv_nmos ad=0.2516p pd=2.16u as=0.1406p ps=1.12u w=0.74u l=0.6u
X1840 a_27048_1044# a_26477_1842# VDD.t1285 VDD.t7 sg13_lv_pmos ad=0.2128p pd=1.5u as=0.3808p ps=2.92u w=1.12u l=0.13u
X1841 a_19550_3889# a_20391_3853# a_20315_3889# VDD.t0 sg13_lv_pmos ad=0.3808p pd=2.92u as=0.2128p ps=1.5u w=1.12u l=0.13u
X1842 a_2019_6737.t1 a_1721_7085# VSS.t232 VSS.t231 sg13_lv_nmos ad=0.1406p pd=1.12u as=0.1331p ps=1.12u w=0.74u l=0.13u
X1843 a_13470_6734# a_2019_6737.t6 a_13368_6734# VSS.t2213 sg13_lv_nmos ad=0.2516p pd=2.16u as=0.1406p ps=1.12u w=0.74u l=0.13u
X1844 a_24393_16869# a_24197_16869# VDD.t564 VDD.t297 sg13_lv_pmos ad=0.3808p pd=2.92u as=0.2128p ps=1.5u w=1.12u l=0.13u
X1845 VDD.t96 VSS.t998 VDD.t95 VDD.t0 sg13_lv_pmos ad=0.34p pd=2.68u as=0 ps=0 w=1u l=1u
X1846 a_24875_13226# a_24665_13226# VDD.t971 VDD.t50 sg13_lv_pmos ad=0.2128p pd=1.5u as=0.252p ps=1.57u w=1.12u l=0.13u
X1847 VDD.t961 a_17683_16869# a_18117_16869# VDD.t297 sg13_lv_pmos ad=0.2128p pd=1.5u as=0.3808p ps=2.92u w=1.12u l=0.13u
X1848 VSS.t895 VDD.t1674 VSS.t894 VSS.t893 sg13_lv_nmos ad=0.1428p pd=1.52u as=0 ps=0 w=0.42u l=1u
X1849 VDD.t278 CHAN2_MUX_SEL3 a_3449_3176# VDD.t0 sg13_lv_pmos ad=0.1918p pd=1.5u as=0.1596p ps=1.22u w=0.84u l=0.13u
X1850 VDD.t332 a_4187_2434# a_20831_17497# VDD.t297 sg13_lv_pmos ad=0.3808p pd=2.92u as=0.2128p ps=1.5u w=1.12u l=0.6u
X1851 a_6326_10280# a_6126_9506# a_5778_9057# VSS.t14 sg13_lv_nmos ad=0.38p pd=2.38u as=0.68p ps=4.68u w=2u l=1u
X1852 a_25391_5315# a_25153_4687# a_25283_4687# VDD.t281 sg13_lv_pmos ad=0.2128p pd=1.5u as=0.3808p ps=2.92u w=1.12u l=0.2u
X1853 a_19550_16071# a_20391_16035# a_20315_16071# VDD.t4 sg13_lv_pmos ad=0.3808p pd=2.92u as=0.2128p ps=1.5u w=1.12u l=0.13u
X1854 VSS.t354 VDD.t1689 VSS.t845 VSS.t844 sg13_lv_nmos ad=0.1428p pd=1.52u as=0 ps=0 w=0.42u l=1u
X1855 a_5768_1044# a_5197_1842# VDD.t647 VDD.t7 sg13_lv_pmos ad=0.2128p pd=1.5u as=0.3808p ps=2.92u w=1.12u l=0.13u
X1856 VSS.t196 a_3171_6737.t3 a_24084_6698# VSS.t1333 sg13_lv_nmos ad=0.2516p pd=2.16u as=0.2516p ps=2.16u w=0.74u l=0.13u
X1857 VDD.t894 a_7477_4687# a_7945_3889# VDD.t0 sg13_lv_pmos ad=0.252p pd=1.57u as=0.3808p ps=2.92u w=1.12u l=0.13u
X1858 VDD.t538 a_5957_16869# a_6425_16071# VDD.t4 sg13_lv_pmos ad=0.252p pd=1.57u as=0.3808p ps=2.92u w=1.12u l=0.13u
X1859 VSS.t1416 a_13123_7532# a_13557_7532# VSS.t2113 sg13_lv_nmos ad=0.1406p pd=1.12u as=0.2516p ps=2.16u w=0.74u l=0.13u
X1860 a_3747_3156.t1 a_3449_3176# VSS.t34 VSS.t69 sg13_lv_nmos ad=0.1406p pd=1.12u as=0.1331p ps=1.12u w=0.74u l=0.13u
X1861 VDD.t1386 a_12363_14024# a_12797_14024# VDD.t301 sg13_lv_pmos ad=0.2128p pd=1.5u as=0.3808p ps=2.92u w=1.12u l=0.13u
X1862 VDD.t672 a_15964_12471# a_16851_12491# VDD.t50 sg13_lv_pmos ad=0.2086p pd=1.5u as=0.34p ps=2.68u w=1u l=0.13u
X1863 a_12993_4687# a_12797_4687# VDD.t543 VDD.t281 sg13_lv_pmos ad=0.3808p pd=2.92u as=0.2128p ps=1.5u w=1.12u l=0.13u
X1864 a_8671_14652# a_8433_14024# a_8563_14024# VDD.t301 sg13_lv_pmos ad=0.2128p pd=1.5u as=0.3808p ps=2.92u w=1.12u l=0.2u
X1865 a_25913_7532# a_25717_7532# VSS.t1121 VSS.t1210 sg13_lv_nmos ad=0.2516p pd=2.16u as=0.1406p ps=1.12u w=0.74u l=0.13u
X1866 VSS.t1051 VDD.t1629 VSS.t1049 VSS.t1050 sg13_lv_nmos ad=79.8f pd=0.8u as=0 ps=0 w=0.42u l=1u
X1867 a_5731_15316# a_8745_15546# a_7390_16071# VDD.t4 sg13_lv_pmos ad=0.3808p pd=2.92u as=0.3808p ps=2.92u w=1.12u l=0.13u
X1868 a_21353_7532# a_21157_7532# VDD.t1120 VDD.t275 sg13_lv_pmos ad=0.3808p pd=2.92u as=0.2128p ps=1.5u w=1.12u l=0.13u
X1869 VSS.t1138 a_21483_16869# a_21917_16869# VSS.t1192 sg13_lv_nmos ad=0.1406p pd=1.12u as=0.2516p ps=2.16u w=0.74u l=0.13u
X1870 a_12715_16071# a_12505_16071# VSS.t413 VSS.t1692 sg13_lv_nmos ad=0.1406p pd=1.12u as=0.1665p ps=1.19u w=0.74u l=0.13u
X1871 a_5731_12471# a_5705_12701# a_4350_13226# VDD.t50 sg13_lv_pmos ad=0.3808p pd=2.92u as=0.3808p ps=2.92u w=1.12u l=0.13u
X1872 VSS.t366 a_3171_1047.t6 a_14964_1008# VSS.t365 sg13_lv_nmos ad=0.2516p pd=2.16u as=0.2516p ps=2.16u w=0.74u l=0.13u
X1873 VSS.t48 a_4187_1764.t41 a_22351_4687# VSS.t1586 sg13_lv_nmos ad=0.2516p pd=2.16u as=0.1406p ps=1.12u w=0.74u l=0.6u
X1874 VDD.t344 a_4187_2434# a_9431_14652# VDD.t301 sg13_lv_pmos ad=0.3808p pd=2.92u as=0.2128p ps=1.5u w=1.12u l=0.6u
X1875 VSS.t386 a_27237_14024# a_27705_13226# VSS.t385 sg13_lv_nmos ad=0.1665p pd=1.19u as=0.2516p ps=2.16u w=0.74u l=0.13u
X1876 a_13991_2470# a_13753_1842# a_13883_1842# VDD.t399 sg13_lv_pmos ad=0.2128p pd=1.5u as=0.3808p ps=2.92u w=1.12u l=0.2u
X1877 VDD.t90 VSS.t948 VDD.t89 VDD.t41 sg13_lv_pmos ad=0.34p pd=2.68u as=0 ps=0 w=1u l=1u
X1878 VDD.t589 a_26803_14024# a_27237_14024# VDD.t301 sg13_lv_pmos ad=0.2128p pd=1.5u as=0.3808p ps=2.92u w=1.12u l=0.13u
X1879 a_10232_11561# a_10206_11525# VSS.t1207 VSS.t2254 sg13_lv_nmos ad=0.2516p pd=2.16u as=0.1626p ps=1.415u w=0.74u l=0.13u
X1880 VSS.t1754 a_25717_16869# a_26185_16071# VSS.t1753 sg13_lv_nmos ad=0.1665p pd=1.19u as=0.2516p ps=2.16u w=0.74u l=0.13u
X1881 VDD.t620 a_7043_7532# a_7477_7532# VDD.t275 sg13_lv_pmos ad=0.2128p pd=1.5u as=0.3808p ps=2.92u w=1.12u l=0.13u
X1882 a_4633_16869# a_4437_16869# VDD.t1015 VDD.t297 sg13_lv_pmos ad=0.3808p pd=2.92u as=0.2128p ps=1.5u w=1.12u l=0.13u
X1883 a_24008_16071# a_23437_16869# VSS.t1583 VSS.t2203 sg13_lv_nmos ad=0.1406p pd=1.12u as=0.2516p ps=2.16u w=0.74u l=0.13u
X1884 VSS.t56 a_2873_4240# a_3171_3892.t1 VSS.t679 sg13_lv_nmos ad=0.2812p pd=2.24u as=0.1406p ps=1.12u w=0.74u l=0.13u
X1885 VDD.t409 a_4187_2434# a_13991_5315# VDD.t281 sg13_lv_pmos ad=0.3808p pd=2.92u as=0.2128p ps=1.5u w=1.12u l=0.6u
X1886 VSS.t1335 a_22677_14024# a_23145_13226# VSS.t1815 sg13_lv_nmos ad=0.1665p pd=1.19u as=0.2516p ps=2.16u w=0.74u l=0.13u
X1887 VDD.t542 a_2873_13577# a_3171_13229.t0 VDD.t50 sg13_lv_pmos ad=0.4256p pd=3u as=0.2128p ps=1.5u w=1.12u l=0.13u
X1888 a_6854_11144# a_6854_11144# a_9444_10280# VSS.t2235 sg13_lv_nmos ad=0.38p pd=2.38u as=0.68p ps=4.68u w=2u l=1u
X1889 a_20968_13226# a_20397_14024# VSS.t241 VSS.t2099 sg13_lv_nmos ad=0.1406p pd=1.12u as=0.2516p ps=2.16u w=0.74u l=0.13u
X1890 VDD.t723 a_2019_311.t2 a_17865_519# VDD.t7 sg13_lv_pmos ad=0.3808p pd=2.92u as=0.3808p ps=2.92u w=1.12u l=0.13u
X1891 VSS.t869 VDD.t1682 VSS.t869 VSS.t871 sg13_lv_nmos ad=79.8f pd=0.8u as=0 ps=0 w=0.42u l=1u
X1892 a_15964_5979# a_15765_6153# a_5731_5979# VSS.t35 sg13_lv_nmos ad=0.2183p pd=1.33u as=0.2516p ps=2.16u w=0.74u l=0.13u
X1893 a_16108_3134# a_2019_3156.t2 a_16510_3889# VSS.t1523 sg13_lv_nmos ad=0.2516p pd=2.16u as=0.2516p ps=2.16u w=0.74u l=0.13u
X1894 a_11195_1044# a_10985_1044# VSS.t1902 VSS.t1901 sg13_lv_nmos ad=0.1406p pd=1.12u as=0.1665p ps=1.19u w=0.74u l=0.13u
X1895 CHAN3_DELAY_OUT_LAST a_27997_1842# VSS.t1985 VSS.t1984 sg13_lv_nmos ad=0.2516p pd=2.16u as=0.1406p ps=1.12u w=0.74u l=0.13u
X1896 a_13368_3889# a_12797_4687# VSS.t273 VSS.t272 sg13_lv_nmos ad=0.1406p pd=1.12u as=0.2516p ps=2.16u w=0.74u l=0.13u
X1897 VDD.t468 a_23763_4687# a_24197_4687# VDD.t281 sg13_lv_pmos ad=0.2128p pd=1.5u as=0.3808p ps=2.92u w=1.12u l=0.13u
X1898 VDD.t299 a_4187_2434# a_11711_17497# VDD.t297 sg13_lv_pmos ad=0.3808p pd=2.92u as=0.2128p ps=1.5u w=1.12u l=0.6u
X1899 VDD.t963 a_2297_16422# a_2595_16074.t0 VDD.t4 sg13_lv_pmos ad=0.4256p pd=3u as=0.2128p ps=1.5u w=1.12u l=0.13u
X1900 VSS.t1009 VDD.t1641 VSS.t1008 VSS.t1007 sg13_lv_nmos ad=0.1428p pd=1.52u as=0 ps=0 w=0.42u l=1u
X1901 VSS.t2222 a_18117_7532# a_18585_6734# VSS.t2271 sg13_lv_nmos ad=0.1665p pd=1.19u as=0.2516p ps=2.16u w=0.74u l=0.13u
X1902 a_11195_13226# a_10985_13226# VDD.t1227 VDD.t50 sg13_lv_pmos ad=0.2128p pd=1.5u as=0.252p ps=1.57u w=1.12u l=0.13u
X1903 a_25391_17497# a_25153_16869# a_25283_16869# VDD.t297 sg13_lv_pmos ad=0.2128p pd=1.5u as=0.3808p ps=2.92u w=1.12u l=0.2u
X1904 a_22590_16071# a_3747_16074.t3 a_24875_16071# VSS.t2158 sg13_lv_nmos ad=0.2516p pd=2.16u as=0.1406p ps=1.12u w=0.74u l=0.13u
X1905 VDD.t689 a_24197_1842# a_24665_1044# VDD.t7 sg13_lv_pmos ad=0.252p pd=1.57u as=0.3808p ps=2.92u w=1.12u l=0.13u
X1906 a_19550_13226# a_3747_13229.t4 a_21835_13226# VSS.t1407 sg13_lv_nmos ad=0.2516p pd=2.16u as=0.1406p ps=1.12u w=0.74u l=0.13u
X1907 a_16510_1044# a_18004_1008# a_17928_1044# VDD.t7 sg13_lv_pmos ad=0.3808p pd=2.92u as=0.2128p ps=1.5u w=1.12u l=0.13u
X1908 VDD.t1084 VSS.t1044 VDD.t1082 VDD.t0 sg13_lv_pmos ad=0.19p pd=1.38u as=0 ps=0 w=1u l=1u
X1909 VSS.t56 a_1544_3889# a_2391_4240# VSS.t476 sg13_lv_nmos ad=0.1331p pd=1.12u as=0.1216p ps=1.02u w=0.64u l=0.13u
X1910 a_6913_1842# a_6717_1842# VSS.t72 VSS.t2287 sg13_lv_nmos ad=0.2516p pd=2.16u as=0.1406p ps=1.12u w=0.74u l=0.13u
X1911 a_22488_13226# a_21917_14024# VDD.t1247 VDD.t50 sg13_lv_pmos ad=0.2128p pd=1.5u as=0.3808p ps=2.92u w=1.12u l=0.13u
X1912 VSS.t748 a_4187_1764.t14 a_18551_1842# VSS.t747 sg13_lv_nmos ad=0.2516p pd=2.16u as=0.1406p ps=1.12u w=0.74u l=0.6u
X1913 VDD.t338 a_4187_2434# a_26151_17497# VDD.t297 sg13_lv_pmos ad=0.3808p pd=2.92u as=0.2128p ps=1.5u w=1.12u l=0.6u
X1914 a_2019_3892.t1 a_1721_4240# VSS.t56 VSS.t1214 sg13_lv_nmos ad=0.1406p pd=1.12u as=0.1331p ps=1.12u w=0.74u l=0.13u
X1915 VSS.t129 a_1256_5979# a_2967_6021# VSS.t128 sg13_lv_nmos ad=0.1331p pd=1.12u as=0.1216p ps=1.02u w=0.64u l=0.13u
X1916 VSS.t1678 a_3449_16422# a_3747_16074.t1 VSS.t1677 sg13_lv_nmos ad=0.2812p pd=2.24u as=0.1406p ps=1.12u w=0.74u l=0.13u
X1917 a_24393_14024# a_24197_14024# VDD.t992 VDD.t301 sg13_lv_pmos ad=0.3808p pd=2.92u as=0.2128p ps=1.5u w=1.12u l=0.13u
X1918 VDD.t1108 a_12363_1842# a_12797_1842# VDD.t399 sg13_lv_pmos ad=0.2128p pd=1.5u as=0.3808p ps=2.92u w=1.12u l=0.13u
X1919 VDD.t271 a_12849_11557# a_13306_10795# VDD.t268 sg13_lv_pmos ad=0.36237p pd=2.605u as=79.8f ps=0.8u w=0.42u l=0.13u
X1920 a_19833_4687# a_19637_4687# VSS.t497 VSS.t1171 sg13_lv_nmos ad=0.2516p pd=2.16u as=0.1406p ps=1.12u w=0.74u l=0.13u
X1921 a_4350_3889# a_3747_3892.t9 a_6635_3889# VSS.t1511 sg13_lv_nmos ad=0.2516p pd=2.16u as=0.1406p ps=1.12u w=0.74u l=0.13u
X1922 VDD.t295 a_4187_2434# a_26911_5315# VDD.t281 sg13_lv_pmos ad=0.3808p pd=2.92u as=0.2128p ps=1.5u w=1.12u l=0.6u
X1923 VDD.t1388 a_17683_14024# a_18117_14024# VDD.t301 sg13_lv_pmos ad=0.2128p pd=1.5u as=0.3808p ps=2.92u w=1.12u l=0.13u
X1924 VDD.t360 a_4187_2434# a_20831_14652# VDD.t301 sg13_lv_pmos ad=0.3808p pd=2.92u as=0.2128p ps=1.5u w=1.12u l=0.6u
X1925 a_25630_13226# a_27991_13190# a_27915_13226# VDD.t50 sg13_lv_pmos ad=0.3808p pd=2.92u as=0.2128p ps=1.5u w=1.12u l=0.13u
X1926 VSS.t925 VDD.t1665 VSS.t923 VSS.t924 sg13_lv_nmos ad=79.8f pd=0.8u as=0 ps=0 w=0.42u l=1u
X1927 VDD.t777 a_6326_10280# a_6854_11676# VDD.t268 sg13_lv_pmos ad=0.38p pd=2.38u as=0.38p ps=2.38u w=2u l=1u
X1928 VSS.t1490 CHAN3_MUX_SEL3 a_3543_331# VSS.t1489 sg13_lv_nmos ad=0.1331p pd=1.12u as=0.1216p ps=1.02u w=0.64u l=0.13u
X1929 a_9675_3889# a_9465_3889# VDD.t636 VDD.t0 sg13_lv_pmos ad=0.2128p pd=1.5u as=0.252p ps=1.57u w=1.12u l=0.13u
X1930 VSS.t1917 a_13557_14024# a_14025_13226# VSS.t2037 sg13_lv_nmos ad=0.1665p pd=1.19u as=0.2516p ps=2.16u w=0.74u l=0.13u
X1931 VSS.t944 a_2595_6001.t3 a_8745_6209# VSS.t1937 sg13_lv_nmos ad=0.2516p pd=2.16u as=0.2516p ps=2.16u w=0.74u l=0.13u
X1932 VDD.t143 VSS.t586 VDD.t142 VDD.t50 sg13_lv_pmos ad=0.34p pd=2.68u as=0 ps=0 w=1u l=1u
X1933 a_4111_16869# CHAN0_DELAY_IN a_4003_16869# VSS.t1218 sg13_lv_nmos ad=0.1406p pd=1.12u as=0.2516p ps=2.16u w=0.74u l=0.2u
X1934 VDD.t985 a_2595_3892.t8 a_8231_3853# VDD.t0 sg13_lv_pmos ad=0.3808p pd=2.92u as=0.3808p ps=2.92u w=1.12u l=0.13u
X1935 a_22590_13226# a_23431_13190# a_23355_13226# VDD.t50 sg13_lv_pmos ad=0.3808p pd=2.92u as=0.2128p ps=1.5u w=1.12u l=0.13u
X1936 a_19550_3889# a_2595_3892.t4 a_20315_3889# VSS.t1388 sg13_lv_nmos ad=0.2516p pd=2.16u as=0.1406p ps=1.12u w=0.74u l=0.13u
X1937 a_24631_4687# a_24393_4687# a_24523_4687# VSS.t2187 sg13_lv_nmos ad=0.1406p pd=1.12u as=0.2516p ps=2.16u w=0.74u l=0.2u
X1938 a_9193_4687# a_8997_4687# VSS.t653 VSS.t1795 sg13_lv_nmos ad=0.2516p pd=2.16u as=0.1406p ps=1.12u w=0.74u l=0.13u
X1939 VDD.t994 a_8997_14024# a_9465_13226# VDD.t50 sg13_lv_pmos ad=0.252p pd=1.57u as=0.3808p ps=2.92u w=1.12u l=0.13u
X1940 a_22590_1044# a_2595_1047.t3 a_23355_1044# VSS.t576 sg13_lv_nmos ad=0.2516p pd=2.16u as=0.1406p ps=1.12u w=0.74u l=0.13u
X1941 a_2967_13577# CHAN1_MUX_SEL1 a_2873_13577# VSS.t2193 sg13_lv_nmos ad=0.1216p pd=1.02u as=0.2176p ps=1.96u w=0.64u l=0.13u
X1942 a_3747_6737.t0 a_3449_7085# VDD.t1007 VDD.t41 sg13_lv_pmos ad=0.2128p pd=1.5u as=0.1918p ps=1.5u w=1.12u l=0.13u
X1943 VSS.t2022 a_8563_14024# a_8997_14024# VSS.t2021 sg13_lv_nmos ad=0.1406p pd=1.12u as=0.2516p ps=2.16u w=0.74u l=0.13u
X1944 a_13991_8160# a_13753_7532# a_13883_7532# VDD.t275 sg13_lv_pmos ad=0.2128p pd=1.5u as=0.3808p ps=2.92u w=1.12u l=0.2u
X1945 VSS.t1248 a_3171_6737.t6 a_14964_6698# VSS.t1331 sg13_lv_nmos ad=0.2516p pd=2.16u as=0.2516p ps=2.16u w=0.74u l=0.13u
X1946 a_13368_6734# a_12797_7532# VDD.t666 VDD.t41 sg13_lv_pmos ad=0.2128p pd=1.5u as=0.3808p ps=2.92u w=1.12u l=0.13u
X1947 VSS.t544 a_4187_1764.t9 a_22351_1842# VSS.t543 sg13_lv_nmos ad=0.2516p pd=2.16u as=0.1406p ps=1.12u w=0.74u l=0.6u
X1948 VDD.t587 a_3171_1047.t4 a_21044_1008# VDD.t7 sg13_lv_pmos ad=0.3808p pd=2.92u as=0.3808p ps=2.92u w=1.12u l=0.13u
X1949 VDD.t28 VSS.t1016 VDD.t27 VDD.t0 sg13_lv_pmos ad=0.34p pd=2.68u as=0 ps=0 w=1u l=1u
X1950 VSS.t1233 a_7477_4687# a_7945_3889# VSS.t1441 sg13_lv_nmos ad=0.1665p pd=1.19u as=0.2516p ps=2.16u w=0.74u l=0.13u
X1951 a_16108_15316# a_3171_15338.t2 a_22590_16071# VSS.t472 sg13_lv_nmos ad=0.2516p pd=2.16u as=0.2516p ps=2.16u w=0.74u l=0.13u
X1952 a_4633_14024# a_4437_14024# VDD.t1338 VDD.t301 sg13_lv_pmos ad=0.3808p pd=2.92u as=0.2128p ps=1.5u w=1.12u l=0.13u
X1953 a_10430_13226# a_3747_13229.t7 a_12715_13226# VSS.t1405 sg13_lv_nmos ad=0.2516p pd=2.16u as=0.1406p ps=1.12u w=0.74u l=0.13u
X1954 a_23633_4687# a_23437_4687# VSS.t614 VSS.t2415 sg13_lv_nmos ad=0.2516p pd=2.16u as=0.1406p ps=1.12u w=0.74u l=0.13u
X1955 a_10430_16071# a_2595_16074.t7 a_11195_16071# VSS.t419 sg13_lv_nmos ad=0.2516p pd=2.16u as=0.1406p ps=1.12u w=0.74u l=0.13u
X1956 a_1721_13577# a_1256_13226# VDD.t1553 VDD.t50 sg13_lv_pmos ad=0.1596p pd=1.22u as=0.2856p ps=2.36u w=0.84u l=0.13u
X1957 VSS.t510 a_9547_11862# a_9547_11862# VSS.t1164 sg13_lv_nmos ad=2.39977p pd=15.495u as=0.111p ps=1.34u w=0.3u l=0.13u
X1958 VSS.t830 VDD.t1694 VSS.t829 VSS.t828 sg13_lv_nmos ad=0.1428p pd=1.52u as=0 ps=0 w=0.42u l=1u
X1959 a_15273_4687# a_15077_4687# VDD.t692 VDD.t281 sg13_lv_pmos ad=0.3808p pd=2.92u as=0.2128p ps=1.5u w=1.12u l=0.13u
X1960 VSS.t317 a_9323_4687# a_9757_4687# VSS.t806 sg13_lv_nmos ad=0.1406p pd=1.12u as=0.2516p ps=2.16u w=0.74u l=0.13u
X1961 a_6391_5315# a_6153_4687# a_6283_4687# VDD.t281 sg13_lv_pmos ad=0.2128p pd=1.5u as=0.3808p ps=2.92u w=1.12u l=0.2u
X1962 VSS.t971 VDD.t1652 VSS.t970 VSS.t969 sg13_lv_nmos ad=0.1428p pd=1.52u as=0 ps=0 w=0.42u l=1u
X1963 VSS.t1948 a_2019_13229.t8 a_7364_13190# VSS.t2155 sg13_lv_nmos ad=0.2516p pd=2.16u as=0.2516p ps=2.16u w=0.74u l=0.13u
X1964 REF_DELAY_OUT_LAST a_27997_7532# VSS.t1455 VSS.t1454 sg13_lv_nmos ad=0.2516p pd=2.16u as=0.1406p ps=1.12u w=0.74u l=0.13u
X1965 a_11195_6734# a_10985_6734# VSS.t534 VSS.t533 sg13_lv_nmos ad=0.1406p pd=1.12u as=0.1665p ps=1.19u w=0.74u l=0.13u
X1966 a_2873_7085# REF_MUX_SEL1 VDD.t1438 VDD.t41 sg13_lv_pmos ad=0.1596p pd=1.22u as=0.2856p ps=2.36u w=0.84u l=0.13u
X1967 VSS.t529 a_7043_16869# a_7477_16869# VSS.t528 sg13_lv_nmos ad=0.1406p pd=1.12u as=0.2516p ps=2.16u w=0.74u l=0.13u
X1968 VDD.t347 a_4187_2434# a_11711_14652# VDD.t301 sg13_lv_pmos ad=0.3808p pd=2.92u as=0.2128p ps=1.5u w=1.12u l=0.6u
X1969 VDD.t261 VSS.t1105 VDD.t259 VDD.t7 sg13_lv_pmos ad=0.19p pd=1.38u as=0 ps=0 w=1u l=1u
X1970 VSS.t1272 a_3171_16074.t9 a_5844_16035# VSS.t2063 sg13_lv_nmos ad=0.2516p pd=2.16u as=0.2516p ps=2.16u w=0.74u l=0.13u
X1971 a_10430_16071# a_11924_16035# a_11848_16071# VDD.t4 sg13_lv_pmos ad=0.3808p pd=2.92u as=0.2128p ps=1.5u w=1.12u l=0.13u
X1972 a_15304_10295# a_14851_11918# VDD.t1027 VDD.t268 sg13_lv_pmos ad=0.4312p pd=3.01u as=0.2639p ps=1.81u w=1.12u l=0.13u
X1973 a_4350_6734# a_6711_6698# a_6635_6734# VDD.t41 sg13_lv_pmos ad=0.3808p pd=2.92u as=0.2128p ps=1.5u w=1.12u l=0.13u
X1974 a_16108_12471# a_26985_12701# a_25630_13226# VDD.t50 sg13_lv_pmos ad=0.3808p pd=2.92u as=0.3808p ps=2.92u w=1.12u l=0.13u
X1975 a_16271_2470# a_16033_1842# a_16163_1842# VDD.t399 sg13_lv_pmos ad=0.2128p pd=1.5u as=0.3808p ps=2.92u w=1.12u l=0.2u
X1976 a_25391_14652# a_25153_14024# a_25283_14024# VDD.t301 sg13_lv_pmos ad=0.2128p pd=1.5u as=0.3808p ps=2.92u w=1.12u l=0.2u
X1977 a_13566_11018# a_14009_10774# a_13949_11186# VDD.t268 sg13_lv_pmos ad=79.8f pd=0.8u as=63f ps=0.72u w=0.42u l=0.13u
X1978 a_6913_7532# a_6717_7532# VSS.t264 VSS.t514 sg13_lv_nmos ad=0.2516p pd=2.16u as=0.1406p ps=1.12u w=0.74u l=0.13u
X1979 VDD.t270 a_11748_11799# a_11693_11680# VDD.t268 sg13_lv_pmos ad=1.10612p pd=6.66u as=93.45f ps=0.865u w=0.42u l=0.13u
X1980 a_25913_16869# a_25717_16869# VDD.t934 VDD.t297 sg13_lv_pmos ad=0.3808p pd=2.92u as=0.2128p ps=1.5u w=1.12u l=0.13u
X1981 VDD.t511 a_11491_11918# a_12158_11557# VDD.t268 sg13_lv_pmos ad=0.2128p pd=1.5u as=0.3864p ps=2.93u w=1.12u l=0.13u
X1982 VSS.t223 a_4187_1764.t78 a_18551_7532# VSS.t2412 sg13_lv_nmos ad=0.2516p pd=2.16u as=0.1406p ps=1.12u w=0.74u l=0.6u
X1983 a_19550_6734# a_20391_6698# a_20315_6734# VDD.t41 sg13_lv_pmos ad=0.3808p pd=2.92u as=0.2128p ps=1.5u w=1.12u l=0.13u
X1984 VDD.t355 a_4187_2434# a_26151_14652# VDD.t301 sg13_lv_pmos ad=0.3808p pd=2.92u as=0.2128p ps=1.5u w=1.12u l=0.6u
X1985 VDD.t1037 VSS.t1085 VDD.t1036 VDD.t7 sg13_lv_pmos ad=0.19p pd=1.38u as=0 ps=0 w=1u l=1u
X1986 VDD.t665 a_12363_7532# a_12797_7532# VDD.t275 sg13_lv_pmos ad=0.2128p pd=1.5u as=0.3808p ps=2.92u w=1.12u l=0.13u
X1987 a_2595_3156.t0 a_2297_3176# VDD.t867 VDD.t0 sg13_lv_pmos ad=0.2128p pd=1.5u as=0.1918p ps=1.5u w=1.12u l=0.13u
X1988 VDD.t611 a_15403_4687# a_15837_4687# VDD.t281 sg13_lv_pmos ad=0.2128p pd=1.5u as=0.3808p ps=2.92u w=1.12u l=0.13u
X1989 a_21353_16869# a_21157_16869# VDD.t533 VDD.t297 sg13_lv_pmos ad=0.3808p pd=2.92u as=0.2128p ps=1.5u w=1.12u l=0.13u
X1990 a_19833_1842# a_19637_1842# VSS.t1569 VSS.t1961 sg13_lv_nmos ad=0.2516p pd=2.16u as=0.1406p ps=1.12u w=0.74u l=0.13u
X1991 VSS.t619 a_19963_14024# a_20397_14024# VSS.t1813 sg13_lv_nmos ad=0.1406p pd=1.12u as=0.2516p ps=2.16u w=0.74u l=0.13u
X1992 a_21835_13226# a_21625_13226# VDD.t959 VDD.t50 sg13_lv_pmos ad=0.2128p pd=1.5u as=0.252p ps=1.57u w=1.12u l=0.13u
X1993 VDD.t720 a_2019_311.t3 a_5705_519# VDD.t7 sg13_lv_pmos ad=0.3808p pd=2.92u as=0.3808p ps=2.92u w=1.12u l=0.13u
X1994 VDD.t458 a_14643_16869# a_15077_16869# VDD.t297 sg13_lv_pmos ad=0.2128p pd=1.5u as=0.3808p ps=2.92u w=1.12u l=0.13u
X1995 VDD.t556 a_7477_7532# a_7945_6734# VDD.t41 sg13_lv_pmos ad=0.252p pd=1.57u as=0.3808p ps=2.92u w=1.12u l=0.13u
X1996 a_3747_6001.t1 a_3449_6021# VSS.t205 VSS.t204 sg13_lv_nmos ad=0.1406p pd=1.12u as=0.1331p ps=1.12u w=0.74u l=0.13u
X1997 a_3747_12493.t1 a_3449_12513# VSS.t124 VSS.t2075 sg13_lv_nmos ad=0.1406p pd=1.12u as=0.1331p ps=1.12u w=0.74u l=0.13u
X1998 VSS.t147 a_2019_1047.t7 a_10404_1008# VSS.t146 sg13_lv_nmos ad=0.2516p pd=2.16u as=0.2516p ps=2.16u w=0.74u l=0.13u
X1999 VDD.t1039 VSS.t1085 VDD.t1038 VDD.t7 sg13_lv_pmos ad=0.34p pd=2.68u as=0 ps=0 w=1u l=1u
X2000 a_24631_1842# a_24393_1842# a_24523_1842# VSS.t1918 sg13_lv_nmos ad=0.1406p pd=1.12u as=0.2516p ps=2.16u w=0.74u l=0.2u
X2001 a_22590_6734# a_2595_6737.t3 a_23355_6734# VSS.t1662 sg13_lv_nmos ad=0.2516p pd=2.16u as=0.1406p ps=1.12u w=0.74u l=0.13u
X2002 a_19550_3889# a_19524_3853# a_19448_3889# VDD.t0 sg13_lv_pmos ad=0.3808p pd=2.92u as=0.2128p ps=1.5u w=1.12u l=0.13u
X2003 VDD.t481 a_4763_4687# a_5197_4687# VDD.t281 sg13_lv_pmos ad=0.2128p pd=1.5u as=0.3808p ps=2.92u w=1.12u l=0.13u
X2004 a_9193_1842# a_8997_1842# VSS.t169 VSS.t1239 sg13_lv_nmos ad=0.2516p pd=2.16u as=0.1406p ps=1.12u w=0.74u l=0.13u
X2005 a_20071_2470# a_19833_1842# a_19963_1842# VDD.t399 sg13_lv_pmos ad=0.2128p pd=1.5u as=0.3808p ps=2.92u w=1.12u l=0.2u
X2006 VDD.t1208 a_3171_6001.t2 a_23945_6209# VDD.t41 sg13_lv_pmos ad=0.3808p pd=2.92u as=0.3808p ps=2.92u w=1.12u l=0.13u
X2007 a_1544_5979# REF_MUX_SEL3 VSS.t647 VSS.t646 sg13_lv_nmos ad=0.2516p pd=2.16u as=0.2516p ps=2.16u w=0.74u l=0.13u
X2008 VDD.t1359 a_1544_289# a_2297_331# VDD.t7 sg13_lv_pmos ad=0.1918p pd=1.5u as=0.1596p ps=1.22u w=0.84u l=0.13u
X2009 a_5731_15316# a_5705_15546# a_4350_16071# VDD.t4 sg13_lv_pmos ad=0.3808p pd=2.92u as=0.3808p ps=2.92u w=1.12u l=0.13u
X2010 VDD.t1146 a_14643_1842# a_15077_1842# VDD.t399 sg13_lv_pmos ad=0.2128p pd=1.5u as=0.3808p ps=2.92u w=1.12u l=0.13u
X2011 VSS.t68 a_27237_16869# a_27705_16071# VSS.t67 sg13_lv_nmos ad=0.1665p pd=1.19u as=0.2516p ps=2.16u w=0.74u l=0.13u
X2012 VSS.t175 a_4187_1764.t73 a_22351_7532# VSS.t174 sg13_lv_nmos ad=0.2516p pd=2.16u as=0.1406p ps=1.12u w=0.74u l=0.6u
X2013 a_9675_3889# a_9465_3889# VSS.t512 VSS.t511 sg13_lv_nmos ad=0.1406p pd=1.12u as=0.1665p ps=1.19u w=0.74u l=0.13u
X2014 a_14009_11568# REF_CLK VSS.t510 VSS.t2130 sg13_lv_nmos ad=0.2516p pd=2.16u as=1.9998p ps=12.915u w=0.74u l=0.13u
X2015 VSS.t1365 a_24197_14024# a_24665_13226# VSS.t1871 sg13_lv_nmos ad=0.1665p pd=1.19u as=0.2516p ps=2.16u w=0.74u l=0.13u
X2016 a_2019_311.t0 a_1721_331# VDD.t1373 VDD.t7 sg13_lv_pmos ad=0.2128p pd=1.5u as=0.1918p ps=1.5u w=1.12u l=0.13u
X2017 VSS.t1127 a_2595_3892.t8 a_8231_3853# VSS.t1385 sg13_lv_nmos ad=0.2516p pd=2.16u as=0.2516p ps=2.16u w=0.74u l=0.13u
X2018 VSS.t1685 a_22677_16869# a_23145_16071# VSS.t1708 sg13_lv_nmos ad=0.1665p pd=1.19u as=0.2516p ps=2.16u w=0.74u l=0.13u
X2019 a_23633_1842# a_23437_1842# VSS.t487 VSS.t1905 sg13_lv_nmos ad=0.2516p pd=2.16u as=0.1406p ps=1.12u w=0.74u l=0.13u
X2020 VDD.t121 VSS.t971 VDD.t183 VDD.t41 sg13_lv_pmos ad=0.34p pd=2.68u as=0 ps=0 w=1u l=1u
X2021 a_20968_16071# a_20397_16869# VSS.t1376 VSS.t1375 sg13_lv_nmos ad=0.1406p pd=1.12u as=0.2516p ps=2.16u w=0.74u l=0.13u
X2022 VSS.t1095 VDD.t1615 VSS.t1095 VSS.t1096 sg13_lv_nmos ad=0.1428p pd=1.52u as=0 ps=0 w=0.42u l=1u
X2023 a_26395_1044# a_26185_1044# VSS.t1979 VSS.t2148 sg13_lv_nmos ad=0.1406p pd=1.12u as=0.1665p ps=1.19u w=0.74u l=0.13u
X2024 VDD.t307 a_4187_2434# a_7911_5315# VDD.t281 sg13_lv_pmos ad=0.3808p pd=2.92u as=0.2128p ps=1.5u w=1.12u l=0.6u
X2025 VSS.t859 VDD.t1685 VSS.t859 VSS.t861 sg13_lv_nmos ad=79.8f pd=0.8u as=0 ps=0 w=0.42u l=1u
X2026 VSS.t173 a_9323_1842# a_9757_1842# VSS.t1683 sg13_lv_nmos ad=0.1406p pd=1.12u as=0.2516p ps=2.16u w=0.74u l=0.13u
X2027 a_13470_3889# a_14311_3853# a_14235_3889# VDD.t0 sg13_lv_pmos ad=0.3808p pd=2.92u as=0.2128p ps=1.5u w=1.12u l=0.13u
X2028 a_12715_13226# a_12505_13226# VDD.t1289 VDD.t50 sg13_lv_pmos ad=0.2128p pd=1.5u as=0.252p ps=1.57u w=1.12u l=0.13u
X2029 VSS.t1621 a_3747_1047.t3 a_24951_1008# VSS.t1620 sg13_lv_nmos ad=0.2516p pd=2.16u as=0.2516p ps=2.16u w=0.74u l=0.13u
X2030 a_26911_17497# a_26673_16869# a_26803_16869# VDD.t297 sg13_lv_pmos ad=0.2128p pd=1.5u as=0.3808p ps=2.92u w=1.12u l=0.2u
X2031 VDD.t447 a_4187_2434# a_17791_2470# VDD.t399 sg13_lv_pmos ad=0.3808p pd=2.92u as=0.2128p ps=1.5u w=1.12u l=0.6u
X2032 a_14513_4687# a_14317_4687# VSS.t330 VSS.t329 sg13_lv_nmos ad=0.2516p pd=2.16u as=0.1406p ps=1.12u w=0.74u l=0.13u
X2033 a_13019_11521# a_15688_11093# VDD.t491 VDD.t268 sg13_lv_pmos ad=0.3808p pd=2.92u as=0.2128p ps=1.5u w=1.12u l=0.13u
X2034 a_16271_8160# a_16033_7532# a_16163_7532# VDD.t275 sg13_lv_pmos ad=0.2128p pd=1.5u as=0.3808p ps=2.92u w=1.12u l=0.2u
X2035 a_5631_4687# a_5393_4687# a_5523_4687# VSS.t36 sg13_lv_nmos ad=0.1406p pd=1.12u as=0.2516p ps=2.16u w=0.74u l=0.2u
X2036 VDD.t690 a_25717_14024# a_26185_13226# VDD.t50 sg13_lv_pmos ad=0.252p pd=1.57u as=0.3808p ps=2.92u w=1.12u l=0.13u
X2037 VSS.t1073 VDD.t1622 VSS.t1073 VSS.t1072 sg13_lv_nmos ad=0.1428p pd=1.52u as=0 ps=0 w=0.42u l=1u
X2038 VDD.t1234 a_2019_3892.t3 a_22564_3853# VDD.t0 sg13_lv_pmos ad=0.3808p pd=2.92u as=0.3808p ps=2.92u w=1.12u l=0.13u
X2039 a_2297_13577# CHAN1_MUX_SEL0 VDD.t506 VDD.t50 sg13_lv_pmos ad=0.1596p pd=1.22u as=0.2856p ps=2.36u w=0.84u l=0.13u
X2040 a_24008_13226# a_23437_14024# VDD.t951 VDD.t50 sg13_lv_pmos ad=0.2128p pd=1.5u as=0.3808p ps=2.92u w=1.12u l=0.13u
X2041 a_22351_17497# a_22113_16869# a_22243_16869# VDD.t297 sg13_lv_pmos ad=0.2128p pd=1.5u as=0.3808p ps=2.92u w=1.12u l=0.2u
X2042 VDD.t327 a_4187_2434# a_27671_17497# VDD.t297 sg13_lv_pmos ad=0.3808p pd=2.92u as=0.2128p ps=1.5u w=1.12u l=0.6u
X2043 a_19550_16071# a_3747_16074.t4 a_21835_16071# VSS.t136 sg13_lv_nmos ad=0.2516p pd=2.16u as=0.1406p ps=1.12u w=0.74u l=0.13u
X2044 VDD.t1407 a_3449_12513# a_3747_12493.t0 VDD.t50 sg13_lv_pmos ad=0.4256p pd=3u as=0.2128p ps=1.5u w=1.12u l=0.13u
X2045 VDD.t472 CHAN0_MUX_SEL1 a_3449_16422# VDD.t4 sg13_lv_pmos ad=0.1918p pd=1.5u as=0.1596p ps=1.22u w=0.84u l=0.13u
X2046 VSS.t1093 VDD.t1616 VSS.t1093 VSS.t1092 sg13_lv_nmos ad=0.1428p pd=1.52u as=0 ps=0 w=0.42u l=1u
X2047 a_25913_14024# a_25717_14024# VDD.t900 VDD.t301 sg13_lv_pmos ad=0.3808p pd=2.92u as=0.2128p ps=1.5u w=1.12u l=0.13u
X2048 VSS.t1951 a_3747_13229.t2 a_27991_13190# VSS.t1950 sg13_lv_nmos ad=0.2516p pd=2.16u as=0.2516p ps=2.16u w=0.74u l=0.13u
X2049 VDD.t294 a_4187_2434# a_4187_2434# VDD.t293 sg13_lv_pmos ad=0.3808p pd=2.92u as=1.0304p ps=4.08u w=1.12u l=0.6u
X2050 a_3747_1047.t0 a_3449_1395# VDD.t843 VDD.t7 sg13_lv_pmos ad=0.2128p pd=1.5u as=0.1918p ps=1.5u w=1.12u l=0.13u
X2051 a_24008_1044# a_23437_1842# VSS.t578 VSS.t1904 sg13_lv_nmos ad=0.1406p pd=1.12u as=0.2516p ps=2.16u w=0.74u l=0.13u
X2052 a_13368_1044# a_12797_1842# VDD.t1109 VDD.t7 sg13_lv_pmos ad=0.2128p pd=1.5u as=0.3808p ps=2.92u w=1.12u l=0.13u
X2053 a_19833_7532# a_19637_7532# VSS.t709 VSS.t2249 sg13_lv_nmos ad=0.2516p pd=2.16u as=0.1406p ps=1.12u w=0.74u l=0.13u
X2054 VSS.t1031 VDD.t1635 VSS.t1029 VSS.t1030 sg13_lv_nmos ad=79.8f pd=0.8u as=0 ps=0 w=0.42u l=1u
X2055 a_21353_14024# a_21157_14024# VDD.t1219 VDD.t301 sg13_lv_pmos ad=0.3808p pd=2.92u as=0.2128p ps=1.5u w=1.12u l=0.13u
X2056 a_9675_6734# a_9465_6734# VDD.t547 VDD.t41 sg13_lv_pmos ad=0.2128p pd=1.5u as=0.252p ps=1.57u w=1.12u l=0.13u
X2057 a_4633_4687# a_4437_4687# VSS.t538 VSS.t1745 sg13_lv_nmos ad=0.2516p pd=2.16u as=0.1406p ps=1.12u w=0.74u l=0.13u
X2058 a_5631_16869# a_5393_16869# a_5523_16869# VSS.t1691 sg13_lv_nmos ad=0.1406p pd=1.12u as=0.2516p ps=2.16u w=0.74u l=0.2u
X2059 VDD.t1405 a_14643_14024# a_15077_14024# VDD.t301 sg13_lv_pmos ad=0.2128p pd=1.5u as=0.3808p ps=2.92u w=1.12u l=0.13u
X2060 a_9444_9602# a_6854_11144# a_9712_9602# VSS.t2238 sg13_lv_nmos ad=0.68p pd=4.68u as=0.38p ps=2.38u w=2u l=1u
X2061 a_22590_13226# a_24951_13190# a_24875_13226# VDD.t50 sg13_lv_pmos ad=0.3808p pd=2.92u as=0.2128p ps=1.5u w=1.12u l=0.13u
X2062 VSS.t916 VDD.t1668 VSS.t914 VSS.t915 sg13_lv_nmos ad=79.8f pd=0.8u as=0 ps=0 w=0.42u l=1u
X2063 a_19833_16869# a_19637_16869# VSS.t1725 VSS.t1727 sg13_lv_nmos ad=0.2516p pd=2.16u as=0.1406p ps=1.12u w=0.74u l=0.13u
X2064 VSS.t307 a_13557_16869# a_14025_16071# VSS.t306 sg13_lv_nmos ad=0.1665p pd=1.19u as=0.2516p ps=2.16u w=0.74u l=0.13u
X2065 a_11711_5315# a_11473_4687# a_11603_4687# VDD.t281 sg13_lv_pmos ad=0.2128p pd=1.5u as=0.3808p ps=2.92u w=1.12u l=0.2u
X2066 VDD.t709 a_2595_6737.t8 a_8231_6698# VDD.t41 sg13_lv_pmos ad=0.3808p pd=2.92u as=0.3808p ps=2.92u w=1.12u l=0.13u
X2067 VSS.t1824 a_10517_14024# a_10985_13226# VSS.t2051 sg13_lv_nmos ad=0.1665p pd=1.19u as=0.2516p ps=2.16u w=0.74u l=0.13u
X2068 a_24631_7532# a_24393_7532# a_24523_7532# VSS.t2314 sg13_lv_nmos ad=0.1406p pd=1.12u as=0.2516p ps=2.16u w=0.74u l=0.2u
X2069 VSS.t97 a_2019_6737.t7 a_10404_6698# VSS.t740 sg13_lv_nmos ad=0.2516p pd=2.16u as=0.2516p ps=2.16u w=0.74u l=0.13u
X2070 VSS.t298 a_4187_1764.t160 a_6391_16869# VSS.t1601 sg13_lv_nmos ad=0.2516p pd=2.16u as=0.1406p ps=1.12u w=0.74u l=0.6u
X2071 VDD.t453 a_4187_2434# a_21591_2470# VDD.t399 sg13_lv_pmos ad=0.3808p pd=2.92u as=0.2128p ps=1.5u w=1.12u l=0.6u
X2072 VSS.t324 a_23763_16869# a_24197_16869# VSS.t1288 sg13_lv_nmos ad=0.1406p pd=1.12u as=0.2516p ps=2.16u w=0.74u l=0.13u
X2073 a_20071_8160# a_19833_7532# a_19963_7532# VDD.t275 sg13_lv_pmos ad=0.2128p pd=1.5u as=0.3808p ps=2.92u w=1.12u l=0.2u
X2074 a_9193_7532# a_8997_7532# VSS.t289 VSS.t288 sg13_lv_nmos ad=0.2516p pd=2.16u as=0.1406p ps=1.12u w=0.74u l=0.13u
X2075 a_2967_16422# CHAN0_MUX_SEL1 a_2873_16422# VSS.t93 sg13_lv_nmos ad=0.1216p pd=1.02u as=0.2176p ps=1.96u w=0.64u l=0.13u
X2076 VDD.t563 a_5974_11413# a_5974_11413# VDD.t268 sg13_lv_pmos ad=0.2448p pd=2.08u as=0.2826p ps=2.29u w=0.36u l=2u
X2077 a_2873_1395# CHAN3_MUX_SEL1 VDD.t1425 VDD.t7 sg13_lv_pmos ad=0.1596p pd=1.22u as=0.2856p ps=2.36u w=0.84u l=0.13u
X2078 VDD.t1 a_3171_3156.t2 a_23945_3364# VDD.t0 sg13_lv_pmos ad=0.3808p pd=2.92u as=0.3808p ps=2.92u w=1.12u l=0.13u
X2079 VDD.t1430 a_14643_7532# a_15077_7532# VDD.t275 sg13_lv_pmos ad=0.2128p pd=1.5u as=0.3808p ps=2.92u w=1.12u l=0.13u
X2080 a_4350_1044# a_6711_1008# a_6635_1044# VDD.t7 sg13_lv_pmos ad=0.3808p pd=2.92u as=0.2128p ps=1.5u w=1.12u l=0.13u
X2081 a_15964_289# CHAN3_MUX_SEL4 a_5731_289# VDD.t7 sg13_lv_pmos ad=0.3304p pd=1.71u as=0.3808p ps=2.92u w=1.12u l=0.13u
X2082 VDD.t858 a_2873_6021# a_3171_6001.t0 VDD.t41 sg13_lv_pmos ad=0.4256p pd=3u as=0.2128p ps=1.5u w=1.12u l=0.13u
X2083 VSS.t548 a_5523_14024# a_5957_14024# VSS.t1989 sg13_lv_nmos ad=0.1406p pd=1.12u as=0.2516p ps=2.16u w=0.74u l=0.13u
X2084 a_13231_17497# a_12993_16869# a_13123_16869# VDD.t297 sg13_lv_pmos ad=0.2128p pd=1.5u as=0.3808p ps=2.92u w=1.12u l=0.2u
X2085 a_10430_16071# a_3747_16074.t7 a_12715_16071# VSS.t133 sg13_lv_nmos ad=0.2516p pd=2.16u as=0.1406p ps=1.12u w=0.74u l=0.13u
X2086 a_11748_11799# a_11491_11918# a_11910_11995# VSS.t635 sg13_lv_nmos ad=0.1428p pd=1.52u as=37.8f ps=0.6u w=0.42u l=0.13u
X2087 a_16108_15316# a_2595_15338.t2 a_19550_16071# VSS.t687 sg13_lv_nmos ad=0.2516p pd=2.16u as=0.2516p ps=2.16u w=0.74u l=0.13u
X2088 a_23633_7532# a_23437_7532# VSS.t194 VSS.t193 sg13_lv_nmos ad=0.2516p pd=2.16u as=0.1406p ps=1.12u w=0.74u l=0.13u
X2089 VSS.t1071 VDD.t1623 VSS.t1069 VSS.t1070 sg13_lv_nmos ad=79.8f pd=0.8u as=0 ps=0 w=0.42u l=1u
X2090 a_19550_1044# a_20391_1008# a_20315_1044# VDD.t7 sg13_lv_pmos ad=0.3808p pd=2.92u as=0.2128p ps=1.5u w=1.12u l=0.13u
X2091 VDD.t2 VSS.t1031 VDD.t1598 VDD.t0 sg13_lv_pmos ad=0.34p pd=2.68u as=0 ps=0 w=1u l=1u
X2092 a_19550_3889# a_2019_3892.t4 a_19448_3889# VSS.t1840 sg13_lv_nmos ad=0.2516p pd=2.16u as=0.1406p ps=1.12u w=0.74u l=0.13u
X2093 a_26395_6734# a_26185_6734# VSS.t1178 VSS.t1177 sg13_lv_nmos ad=0.1406p pd=1.12u as=0.1665p ps=1.19u w=0.74u l=0.13u
X2094 a_1256_1044# CHAN3_MUX_SEL0 VSS.t256 VSS.t2008 sg13_lv_nmos ad=0.2516p pd=2.16u as=0.2516p ps=2.16u w=0.74u l=0.13u
X2095 VDD.t326 a_4187_2434# a_13991_17497# VDD.t297 sg13_lv_pmos ad=0.3808p pd=2.92u as=0.2128p ps=1.5u w=1.12u l=0.6u
X2096 VDD.t107 VSS.t859 VDD.t106 VDD.t4 sg13_lv_pmos ad=0.34p pd=2.68u as=0 ps=0 w=1u l=1u
X2097 VSS.t99 a_9323_7532# a_9757_7532# VSS.t1165 sg13_lv_nmos ad=0.1406p pd=1.12u as=0.2516p ps=2.16u w=0.74u l=0.13u
X2098 VDD.t820 VDD.t818 VDD.t817 VDD.t399 sg13_lv_pmos ad=0.2128p pd=1.5u as=0 ps=0 w=1.12u l=0.2u
X2099 VSS.t405 a_2019_16074.t8 a_7364_16035# VSS.t2112 sg13_lv_nmos ad=0.2516p pd=2.16u as=0.2516p ps=2.16u w=0.74u l=0.13u
X2100 VSS.t108 a_3747_6737.t3 a_24951_6698# VSS.t1775 sg13_lv_nmos ad=0.2516p pd=2.16u as=0.2516p ps=2.16u w=0.74u l=0.13u
X2101 VDD.t1170 a_19637_16869# a_20105_16071# VDD.t4 sg13_lv_pmos ad=0.252p pd=1.57u as=0.3808p ps=2.92u w=1.12u l=0.13u
X2102 VDD.t390 a_4187_2434# a_17791_8160# VDD.t275 sg13_lv_pmos ad=0.3808p pd=2.92u as=0.2128p ps=1.5u w=1.12u l=0.6u
X2103 VSS.t776 a_2595_311.t2 a_20905_519# VSS.t775 sg13_lv_nmos ad=0.2516p pd=2.16u as=0.2516p ps=2.16u w=0.74u l=0.13u
X2104 a_26911_14652# a_26673_14024# a_26803_14024# VDD.t301 sg13_lv_pmos ad=0.2128p pd=1.5u as=0.3808p ps=2.92u w=1.12u l=0.2u
X2105 VSS.t1559 a_2019_13229.t9 a_4324_13190# VSS.t1558 sg13_lv_nmos ad=0.2516p pd=2.16u as=0.2516p ps=2.16u w=0.74u l=0.13u
X2106 VDD.t617 a_7477_1842# a_7945_1044# VDD.t7 sg13_lv_pmos ad=0.252p pd=1.57u as=0.3808p ps=2.92u w=1.12u l=0.13u
X2107 VDD.t1147 a_10083_4687# a_10517_4687# VDD.t281 sg13_lv_pmos ad=0.2128p pd=1.5u as=0.3808p ps=2.92u w=1.12u l=0.13u
X2108 VSS.t161 a_4003_16869# a_4437_16869# VSS.t1443 sg13_lv_nmos ad=0.1406p pd=1.12u as=0.2516p ps=2.16u w=0.74u l=0.13u
X2109 VSS.t1422 CHAN0_MUX_SEL4 a_15765_15490# VSS.t1421 sg13_lv_nmos ad=0.2516p pd=2.16u as=0.2516p ps=2.16u w=0.74u l=0.13u
X2110 a_16108_15316# a_26985_15546# a_25630_16071# VDD.t4 sg13_lv_pmos ad=0.3808p pd=2.92u as=0.3808p ps=2.92u w=1.12u l=0.13u
X2111 a_14513_1842# a_14317_1842# VSS.t293 VSS.t1710 sg13_lv_nmos ad=0.2516p pd=2.16u as=0.1406p ps=1.12u w=0.74u l=0.13u
X2112 a_5631_1842# a_5393_1842# a_5523_1842# VSS.t73 sg13_lv_nmos ad=0.1406p pd=1.12u as=0.2516p ps=2.16u w=0.74u l=0.2u
X2113 a_16108_12471# a_23945_12701# a_22590_13226# VDD.t50 sg13_lv_pmos ad=0.3808p pd=2.92u as=0.3808p ps=2.92u w=1.12u l=0.13u
X2114 a_2019_6001.t0 a_1721_6021# VDD.t626 VDD.t41 sg13_lv_pmos ad=0.2128p pd=1.5u as=0.1918p ps=1.5u w=1.12u l=0.13u
X2115 VDD.t1394 a_3171_16074.t5 a_18004_16035# VDD.t4 sg13_lv_pmos ad=0.3808p pd=2.92u as=0.3808p ps=2.92u w=1.12u l=0.13u
X2116 a_22351_14652# a_22113_14024# a_22243_14024# VDD.t301 sg13_lv_pmos ad=0.2128p pd=1.5u as=0.3808p ps=2.92u w=1.12u l=0.2u
X2117 VDD.t366 a_4187_2434# a_27671_14652# VDD.t301 sg13_lv_pmos ad=0.3808p pd=2.92u as=0.2128p ps=1.5u w=1.12u l=0.6u
X2118 a_10430_13226# a_11271_13190# a_11195_13226# VDD.t50 sg13_lv_pmos ad=0.3808p pd=2.92u as=0.2128p ps=1.5u w=1.12u l=0.13u
X2119 a_22873_16869# a_22677_16869# VDD.t687 VDD.t297 sg13_lv_pmos ad=0.3808p pd=2.92u as=0.2128p ps=1.5u w=1.12u l=0.13u
X2120 a_13470_1044# a_3171_1047.t6 a_14888_1044# VSS.t364 sg13_lv_nmos ad=0.2516p pd=2.16u as=0.1406p ps=1.12u w=0.74u l=0.13u
X2121 a_13470_3889# a_2595_3892.t6 a_14235_3889# VSS.t1394 sg13_lv_nmos ad=0.2516p pd=2.16u as=0.1406p ps=1.12u w=0.74u l=0.13u
X2122 a_18551_4687# a_18313_4687# a_18443_4687# VSS.t1447 sg13_lv_nmos ad=0.1406p pd=1.12u as=0.2516p ps=2.16u w=0.74u l=0.2u
X2123 VSS.t1811 a_21483_14024# a_21917_14024# VSS.t1810 sg13_lv_nmos ad=0.1406p pd=1.12u as=0.2516p ps=2.16u w=0.74u l=0.13u
X2124 a_24008_6734# a_23437_7532# VSS.t196 VSS.t195 sg13_lv_nmos ad=0.1406p pd=1.12u as=0.2516p ps=2.16u w=0.74u l=0.13u
X2125 a_17275_3889# a_17065_3889# VDD.t288 VDD.t0 sg13_lv_pmos ad=0.2128p pd=1.5u as=0.252p ps=1.57u w=1.12u l=0.13u
X2126 a_16108_5979# a_17865_6209# a_16510_6734# VDD.t41 sg13_lv_pmos ad=0.3808p pd=2.92u as=0.3808p ps=2.92u w=1.12u l=0.13u
X2127 a_9444_9602# a_9444_10280# VSS.t1465 VSS.t1464 sg13_lv_nmos ad=0.38p pd=2.38u as=0.68p ps=4.68u w=2u l=1u
X2128 VDD.t924 a_16163_16869# a_16597_16869# VDD.t297 sg13_lv_pmos ad=0.2128p pd=1.5u as=0.3808p ps=2.92u w=1.12u l=0.13u
X2129 VDD.t219 VSS.t819 VDD.t218 VDD.t4 sg13_lv_pmos ad=0.34p pd=2.68u as=0 ps=0 w=1u l=1u
X2130 a_1256_289# CHAN3_MUX_SEL2 VSS.t1487 VSS.t1506 sg13_lv_nmos ad=0.2516p pd=2.16u as=0.2516p ps=2.16u w=0.74u l=0.13u
X2131 VDD.t475 a_3171_13229.t9 a_5844_13190# VDD.t50 sg13_lv_pmos ad=0.3808p pd=2.92u as=0.3808p ps=2.92u w=1.12u l=0.13u
X2132 VDD.t1304 a_3747_3892.t6 a_15831_3853# VDD.t0 sg13_lv_pmos ad=0.3808p pd=2.92u as=0.3808p ps=2.92u w=1.12u l=0.13u
X2133 VDD.t190 VSS.t916 VDD.t1595 VDD.t50 sg13_lv_pmos ad=0.34p pd=2.68u as=0 ps=0 w=1u l=1u
X2134 a_4633_1842# a_4437_1842# VSS.t746 VSS.t2206 sg13_lv_nmos ad=0.2516p pd=2.16u as=0.1406p ps=1.12u w=0.74u l=0.13u
X2135 VSS.t1182 a_2019_3892.t3 a_22564_3853# VSS.t1835 sg13_lv_nmos ad=0.2516p pd=2.16u as=0.2516p ps=2.16u w=0.74u l=0.13u
X2136 VDD.t1107 a_4437_16869# a_4905_16071# VDD.t4 sg13_lv_pmos ad=0.252p pd=1.57u as=0.3808p ps=2.92u w=1.12u l=0.13u
X2137 a_5731_15316# a_3171_15338.t3 a_10430_16071# VSS.t424 sg13_lv_nmos ad=0.2516p pd=2.16u as=0.2516p ps=2.16u w=0.74u l=0.13u
X2138 VDD.t603 a_11603_16869# a_12037_16869# VDD.t297 sg13_lv_pmos ad=0.2128p pd=1.5u as=0.3808p ps=2.92u w=1.12u l=0.13u
X2139 VSS.t1315 a_2019_1047.t2 a_25604_1008# VSS.t1314 sg13_lv_nmos ad=0.2516p pd=2.16u as=0.2516p ps=2.16u w=0.74u l=0.13u
X2140 VDD.t393 a_4187_2434# a_21591_8160# VDD.t275 sg13_lv_pmos ad=0.3808p pd=2.92u as=0.2128p ps=1.5u w=1.12u l=0.6u
X2141 a_16108_289# CHAN3_MUX_SEL4 a_15964_289# VSS.t2407 sg13_lv_nmos ad=0.2516p pd=2.16u as=0.2183p ps=1.33u w=0.74u l=0.13u
X2142 a_15964_3134# a_15765_3308# a_5731_3134# VSS.t2284 sg13_lv_nmos ad=0.2183p pd=1.33u as=0.2516p ps=2.16u w=0.74u l=0.13u
X2143 a_19550_6734# a_19524_6698# a_19448_6734# VDD.t41 sg13_lv_pmos ad=0.3808p pd=2.92u as=0.2128p ps=1.5u w=1.12u l=0.13u
X2144 VDD.t426 a_4187_2434# a_24631_5315# VDD.t281 sg13_lv_pmos ad=0.3808p pd=2.92u as=0.2128p ps=1.5u w=1.12u l=0.6u
X2145 a_4350_3889# a_4324_3853# a_4248_3889# VDD.t0 sg13_lv_pmos ad=0.3808p pd=2.92u as=0.2128p ps=1.5u w=1.12u l=0.13u
X2146 a_22873_1842# a_22677_1842# VDD.t1290 VDD.t399 sg13_lv_pmos ad=0.3808p pd=2.92u as=0.2128p ps=1.5u w=1.12u l=0.13u
X2147 a_14888_3889# a_14317_4687# VDD.t567 VDD.t0 sg13_lv_pmos ad=0.2128p pd=1.5u as=0.3808p ps=2.92u w=1.12u l=0.13u
X2148 VSS.t34 a_2873_3176# a_3171_3156.t1 VSS.t495 sg13_lv_nmos ad=0.2812p pd=2.24u as=0.1406p ps=1.12u w=0.74u l=0.13u
X2149 VSS.t326 a_24197_16869# a_24665_16071# VSS.t325 sg13_lv_nmos ad=0.1665p pd=1.19u as=0.2516p ps=2.16u w=0.74u l=0.13u
X2150 a_21835_1044# a_21625_1044# VSS.t532 VSS.t531 sg13_lv_nmos ad=0.1406p pd=1.12u as=0.1665p ps=1.19u w=0.74u l=0.13u
X2151 a_22351_4687# a_22113_4687# a_22243_4687# VSS.t1187 sg13_lv_nmos ad=0.1406p pd=1.12u as=0.2516p ps=2.16u w=0.74u l=0.2u
X2152 VDD.t1027 a_14851_11918# a_15108_11799# VDD.t268 sg13_lv_pmos ad=0.2639p pd=1.81u as=79.8f ps=0.8u w=0.42u l=0.13u
X2153 VSS.t1534 a_4187_1764.t98 VSS.t1536 VSS.t1535 sg13_lv_nmos ad=1.33p pd=7.38u as=0 ps=0 w=7u l=7u
X2154 a_13231_14652# a_12993_14024# a_13123_14024# VDD.t301 sg13_lv_pmos ad=0.2128p pd=1.5u as=0.3808p ps=2.92u w=1.12u l=0.2u
X2155 VSS.t566 a_2595_1047.t4 a_20391_1008# VSS.t565 sg13_lv_nmos ad=0.2516p pd=2.16u as=0.2516p ps=2.16u w=0.74u l=0.13u
X2156 VSS.t203 a_16923_4687# a_17357_4687# VSS.t202 sg13_lv_nmos ad=0.1406p pd=1.12u as=0.2516p ps=2.16u w=0.74u l=0.13u
X2157 VSS.t981 VDD.t1648 VSS.t981 VSS.t984 sg13_lv_nmos ad=0.1428p pd=1.52u as=0 ps=0 w=0.42u l=1u
X2158 a_1256_6734# REF_MUX_SEL0 VSS.t232 VSS.t336 sg13_lv_nmos ad=0.2516p pd=2.16u as=0.2516p ps=2.16u w=0.74u l=0.13u
X2159 VDD.t352 a_4187_2434# a_13991_14652# VDD.t301 sg13_lv_pmos ad=0.3808p pd=2.92u as=0.2128p ps=1.5u w=1.12u l=0.6u
X2160 VDD.t798 VDD.t796 VDD.t795 VDD.t275 sg13_lv_pmos ad=0.2128p pd=1.5u as=0 ps=0 w=1.12u l=0.2u
X2161 VDD.t1172 a_2595_16074.t8 a_8231_16035# VDD.t4 sg13_lv_pmos ad=0.3808p pd=2.92u as=0.3808p ps=2.92u w=1.12u l=0.13u
X2162 a_13470_6734# a_14311_6698# a_14235_6734# VDD.t41 sg13_lv_pmos ad=0.3808p pd=2.92u as=0.2128p ps=1.5u w=1.12u l=0.13u
X2163 a_2297_6021# REF_MUX_SEL2 VDD.t728 VDD.t41 sg13_lv_pmos ad=0.1596p pd=1.22u as=0.2856p ps=2.36u w=0.84u l=0.13u
X2164 VDD.t607 a_1544_13226# a_1721_13577# VDD.t50 sg13_lv_pmos ad=0.1918p pd=1.5u as=0.1596p ps=1.22u w=0.84u l=0.13u
X2165 a_13400_10795# a_13132_11110# a_13306_10795# VSS.t788 sg13_lv_nmos ad=60.89999f pd=0.71u as=0.1428p ps=1.52u w=0.42u l=0.13u
X2166 VDD.t588 a_27237_14024# a_27705_13226# VDD.t50 sg13_lv_pmos ad=0.252p pd=1.57u as=0.3808p ps=2.92u w=1.12u l=0.13u
X2167 VDD.t189 VSS.t899 VDD.t187 VDD.t50 sg13_lv_pmos ad=0.19p pd=1.38u as=0 ps=0 w=1u l=1u
X2168 VSS.t1902 a_10517_1842# a_10985_1044# VSS.t1928 sg13_lv_nmos ad=0.1665p pd=1.19u as=0.2516p ps=2.16u w=0.74u l=0.13u
X2169 a_9675_1044# a_9465_1044# VDD.t616 VDD.t7 sg13_lv_pmos ad=0.2128p pd=1.5u as=0.252p ps=1.57u w=1.12u l=0.13u
X2170 VSS.t988 VDD.t1647 VSS.t987 VSS.t986 sg13_lv_nmos ad=0.1428p pd=1.52u as=0 ps=0 w=0.42u l=1u
X2171 VDD.t626 a_1544_5979# a_1721_6021# VDD.t41 sg13_lv_pmos ad=0.1918p pd=1.5u as=0.1596p ps=1.22u w=0.84u l=0.13u
X2172 VSS.t1290 a_4187_1764.t138 a_23111_16869# VSS.t1480 sg13_lv_nmos ad=0.2516p pd=2.16u as=0.1406p ps=1.12u w=0.74u l=0.6u
X2173 a_14513_7532# a_14317_7532# VSS.t552 VSS.t1249 sg13_lv_nmos ad=0.2516p pd=2.16u as=0.1406p ps=1.12u w=0.74u l=0.13u
X2174 a_23871_17497# a_23633_16869# a_23763_16869# VDD.t297 sg13_lv_pmos ad=0.2128p pd=1.5u as=0.3808p ps=2.92u w=1.12u l=0.2u
X2175 a_5631_7532# a_5393_7532# a_5523_7532# VSS.t358 sg13_lv_nmos ad=0.1406p pd=1.12u as=0.2516p ps=2.16u w=0.74u l=0.2u
X2176 VDD.t1508 a_2019_6737.t3 a_22564_6698# VDD.t41 sg13_lv_pmos ad=0.3808p pd=2.92u as=0.3808p ps=2.92u w=1.12u l=0.13u
X2177 CHAN0_DELAY_OUT_LAST a_27997_16869# VDD.t835 VDD.t297 sg13_lv_pmos ad=0.3808p pd=2.92u as=0.2128p ps=1.5u w=1.12u l=0.13u
X2178 a_4111_14024# CHAN1_DELAY_IN a_4003_14024# VSS.t2105 sg13_lv_nmos ad=0.1406p pd=1.12u as=0.2516p ps=2.16u w=0.74u l=0.2u
X2179 VDD.t649 a_2595_1047.t8 a_8231_1008# VDD.t7 sg13_lv_pmos ad=0.3808p pd=2.92u as=0.3808p ps=2.92u w=1.12u l=0.13u
X2180 VDD.t1307 a_3449_15358# a_3747_15338.t0 VDD.t4 sg13_lv_pmos ad=0.4256p pd=3u as=0.2128p ps=1.5u w=1.12u l=0.13u
X2181 a_1544_15316# CHAN0_MUX_SEL3 VSS.t650 VSS.t2192 sg13_lv_nmos ad=0.2516p pd=2.16u as=0.2516p ps=2.16u w=0.74u l=0.13u
X2182 VDD.t958 a_22677_14024# a_23145_13226# VDD.t50 sg13_lv_pmos ad=0.252p pd=1.57u as=0.3808p ps=2.92u w=1.12u l=0.13u
X2183 a_2019_3156.t1 a_1721_3176# VSS.t1144 VSS.t1143 sg13_lv_nmos ad=0.1406p pd=1.12u as=0.1331p ps=1.12u w=0.74u l=0.13u
X2184 VSS.t711 a_4187_1764.t56 a_10951_4687# VSS.t710 sg13_lv_nmos ad=0.2516p pd=2.16u as=0.1406p ps=1.12u w=0.74u l=0.6u
X2185 VDD.t339 a_4187_2434# a_24631_17497# VDD.t297 sg13_lv_pmos ad=0.3808p pd=2.92u as=0.2128p ps=1.5u w=1.12u l=0.6u
X2186 VSS.t1220 a_3449_15358# a_3747_15338.t1 VSS.t1945 sg13_lv_nmos ad=0.2812p pd=2.24u as=0.1406p ps=1.12u w=0.74u l=0.13u
X2187 a_20968_13226# a_20397_14024# VDD.t1423 VDD.t50 sg13_lv_pmos ad=0.2128p pd=1.5u as=0.3808p ps=2.92u w=1.12u l=0.13u
X2188 VDD.t1583 VSS.t887 VDD.t143 VDD.t50 sg13_lv_pmos ad=0.19p pd=1.38u as=0 ps=0 w=1u l=1u
X2189 VSS.t408 a_3747_16074.t2 a_27991_16035# VSS.t407 sg13_lv_nmos ad=0.2516p pd=2.16u as=0.2516p ps=2.16u w=0.74u l=0.13u
X2190 VSS.t1207 DLL_RESETN a_10040_11995# VSS.t1206 sg13_lv_nmos ad=0.1626p pd=1.415u as=60.89999f ps=0.71u w=0.42u l=0.13u
X2191 a_13306_10795# a_14111_10917# a_13566_11018# VDD.t268 sg13_lv_pmos ad=0.1428p pd=1.52u as=79.8f ps=0.8u w=0.42u l=0.13u
X2192 a_13470_6734# a_3171_6737.t6 a_14888_6734# VSS.t1330 sg13_lv_nmos ad=0.2516p pd=2.16u as=0.1406p ps=1.12u w=0.74u l=0.13u
X2193 a_18551_1842# a_18313_1842# a_18443_1842# VSS.t1788 sg13_lv_nmos ad=0.1406p pd=1.12u as=0.2516p ps=2.16u w=0.74u l=0.2u
X2194 a_22873_14024# a_22677_14024# VDD.t896 VDD.t301 sg13_lv_pmos ad=0.3808p pd=2.92u as=0.2128p ps=1.5u w=1.12u l=0.13u
X2195 a_16108_3134# a_17865_3364# a_16510_3889# VDD.t0 sg13_lv_pmos ad=0.3808p pd=2.92u as=0.3808p ps=2.92u w=1.12u l=0.13u
X2196 VDD.t1555 a_16163_14024# a_16597_14024# VDD.t301 sg13_lv_pmos ad=0.2128p pd=1.5u as=0.3808p ps=2.92u w=1.12u l=0.13u
X2197 a_13121_11521# a_15688_11557# VDD.t1029 VDD.t268 sg13_lv_pmos ad=0.3808p pd=2.92u as=0.2128p ps=1.5u w=1.12u l=0.13u
X2198 VDD.t707 a_1256_3134# a_2873_3176# VDD.t0 sg13_lv_pmos ad=0.1918p pd=1.5u as=0.1596p ps=1.22u w=0.84u l=0.13u
X2199 VSS.t502 a_20723_4687# a_21157_4687# VSS.t1258 sg13_lv_nmos ad=0.1406p pd=1.12u as=0.2516p ps=2.16u w=0.74u l=0.13u
X2200 VDD.t801 VDD.t799 VDD.t800 VDD.t281 sg13_lv_pmos ad=0.3808p pd=2.92u as=0 ps=0 w=1.12u l=0.13u
X2201 a_4633_7532# a_4437_7532# VSS.t1152 VSS.t2312 sg13_lv_nmos ad=0.2516p pd=2.16u as=0.1406p ps=1.12u w=0.74u l=0.13u
X2202 a_26911_5315# a_26673_4687# a_26803_4687# VDD.t281 sg13_lv_pmos ad=0.2128p pd=1.5u as=0.3808p ps=2.92u w=1.12u l=0.2u
X2203 VSS.t1920 a_12037_14024# a_12505_13226# VSS.t1994 sg13_lv_nmos ad=0.1665p pd=1.19u as=0.2516p ps=2.16u w=0.74u l=0.13u
X2204 VSS.t108 a_2019_6737.t2 a_25604_6698# VSS.t107 sg13_lv_nmos ad=0.2516p pd=2.16u as=0.2516p ps=2.16u w=0.74u l=0.13u
X2205 VDD.t636 a_8997_4687# a_9465_3889# VDD.t0 sg13_lv_pmos ad=0.252p pd=1.57u as=0.3808p ps=2.92u w=1.12u l=0.13u
X2206 VSS.t660 a_4187_1764.t158 a_7911_16869# VSS.t1437 sg13_lv_nmos ad=0.2516p pd=2.16u as=0.1406p ps=1.12u w=0.74u l=0.6u
X2207 VDD.t1346 a_11603_14024# a_12037_14024# VDD.t301 sg13_lv_pmos ad=0.2128p pd=1.5u as=0.3808p ps=2.92u w=1.12u l=0.13u
X2208 VSS.t598 a_25283_16869# a_25717_16869# VSS.t1296 sg13_lv_nmos ad=0.1406p pd=1.12u as=0.2516p ps=2.16u w=0.74u l=0.13u
X2209 a_19550_13226# a_21911_13190# a_21835_13226# VDD.t50 sg13_lv_pmos ad=0.3808p pd=2.92u as=0.2128p ps=1.5u w=1.12u l=0.13u
X2210 VSS.t1715 a_10517_16869# a_10985_16071# VSS.t2200 sg13_lv_nmos ad=0.1665p pd=1.19u as=0.2516p ps=2.16u w=0.74u l=0.13u
X2211 VDD.t1588 VSS.t909 VDD.t72 VDD.t50 sg13_lv_pmos ad=0.19p pd=1.38u as=0 ps=0 w=1u l=1u
X2212 VSS.t9 a_14851_11918# a_15688_11557# VSS.t8 sg13_lv_nmos ad=0.1406p pd=1.12u as=0.2516p ps=2.16u w=0.74u l=0.13u
X2213 VSS.t241 a_3171_13229.t4 a_21044_13190# VSS.t240 sg13_lv_nmos ad=0.2516p pd=2.16u as=0.2516p ps=2.16u w=0.74u l=0.13u
X2214 a_17275_3889# a_17065_3889# VSS.t52 VSS.t51 sg13_lv_nmos ad=0.1406p pd=1.12u as=0.1665p ps=1.19u w=0.74u l=0.13u
X2215 VSS.t243 a_20723_16869# a_21157_16869# VSS.t2144 sg13_lv_nmos ad=0.1406p pd=1.12u as=0.2516p ps=2.16u w=0.74u l=0.13u
X2216 a_8433_16869# a_8237_16869# VDD.t685 VDD.t297 sg13_lv_pmos ad=0.3808p pd=2.92u as=0.2128p ps=1.5u w=1.12u l=0.13u
X2217 VSS.t829 VDD.t1694 VSS.t829 VSS.t831 sg13_lv_nmos ad=79.8f pd=0.8u as=0 ps=0 w=0.42u l=1u
X2218 a_22873_7532# a_22677_7532# VDD.t600 VDD.t275 sg13_lv_pmos ad=0.3808p pd=2.92u as=0.2128p ps=1.5u w=1.12u l=0.13u
X2219 VSS.t705 a_7043_14024# a_7477_14024# VSS.t2003 sg13_lv_nmos ad=0.1406p pd=1.12u as=0.2516p ps=2.16u w=0.74u l=0.13u
X2220 VSS.t434 a_3747_3892.t6 a_15831_3853# VSS.t1941 sg13_lv_nmos ad=0.2516p pd=2.16u as=0.2516p ps=2.16u w=0.74u l=0.13u
X2221 VSS.t88 a_4187_1764.t39 a_23871_4687# VSS.t2413 sg13_lv_nmos ad=0.2516p pd=2.16u as=0.1406p ps=1.12u w=0.74u l=0.6u
X2222 a_21835_6734# a_21625_6734# VSS.t466 VSS.t465 sg13_lv_nmos ad=0.1406p pd=1.12u as=0.1665p ps=1.19u w=0.74u l=0.13u
X2223 VSS.t372 a_3747_1047.t5 a_18871_1008# VSS.t371 sg13_lv_nmos ad=0.2516p pd=2.16u as=0.2516p ps=2.16u w=0.74u l=0.13u
X2224 a_22351_1842# a_22113_1842# a_22243_1842# VSS.t1856 sg13_lv_nmos ad=0.1406p pd=1.12u as=0.2516p ps=2.16u w=0.74u l=0.2u
X2225 VDD.t718 a_3171_311.t2 a_23945_519# VDD.t7 sg13_lv_pmos ad=0.3808p pd=2.92u as=0.3808p ps=2.92u w=1.12u l=0.13u
X2226 VDD.t82 VSS.t981 VDD.t81 VDD.t41 sg13_lv_pmos ad=0.34p pd=2.68u as=0 ps=0 w=1u l=1u
X2227 VDD.t1288 a_13557_14024# a_14025_13226# VDD.t50 sg13_lv_pmos ad=0.252p pd=1.57u as=0.3808p ps=2.92u w=1.12u l=0.13u
X2228 VDD.t418 a_4187_2434# a_15511_5315# VDD.t281 sg13_lv_pmos ad=0.3808p pd=2.92u as=0.2128p ps=1.5u w=1.12u l=0.6u
X2229 a_10191_17497# a_9953_16869# a_10083_16869# VDD.t297 sg13_lv_pmos ad=0.2128p pd=1.5u as=0.3808p ps=2.92u w=1.12u l=0.2u
X2230 VDD.t315 a_4187_2434# a_15511_17497# VDD.t297 sg13_lv_pmos ad=0.3808p pd=2.92u as=0.2128p ps=1.5u w=1.12u l=0.6u
X2231 VSS.t16 a_6126_9506# a_6126_9506# VSS.t14 sg13_lv_nmos ad=0.68p pd=4.68u as=0.38p ps=2.38u w=2u l=1u
X2232 VSS.t724 a_2595_6737.t4 a_20391_6698# VSS.t723 sg13_lv_nmos ad=0.2516p pd=2.16u as=0.2516p ps=2.16u w=0.74u l=0.13u
X2233 a_2019_311.t1 a_1721_331# VSS.t2014 VSS.t2043 sg13_lv_nmos ad=0.1406p pd=1.12u as=0.1331p ps=1.12u w=0.74u l=0.13u
X2234 VSS.t167 a_16923_1842# a_17357_1842# VSS.t1731 sg13_lv_nmos ad=0.1406p pd=1.12u as=0.2516p ps=2.16u w=0.74u l=0.13u
X2235 VDD.t1236 a_2019_3892.t5 a_16484_3853# VDD.t0 sg13_lv_pmos ad=0.3808p pd=2.92u as=0.3808p ps=2.92u w=1.12u l=0.13u
X2236 REF_MUX_OUT a_16851_5999# VSS.t791 VSS.t790 sg13_lv_nmos ad=0.1406p pd=1.12u as=0.1371p ps=1.12u w=0.74u l=0.13u
X2237 VDD.t853 a_2873_7085# a_3171_6737.t0 VDD.t41 sg13_lv_pmos ad=0.4256p pd=3u as=0.2128p ps=1.5u w=1.12u l=0.13u
X2238 a_4350_3889# a_2019_3892.t9 a_4248_3889# VSS.t1836 sg13_lv_nmos ad=0.2516p pd=2.16u as=0.1406p ps=1.12u w=0.74u l=0.13u
X2239 VDD.t56 VSS.t988 VDD.t55 VDD.t41 sg13_lv_pmos ad=0.34p pd=2.68u as=0 ps=0 w=1u l=1u
X2240 VSS.t505 a_3747_13229.t6 a_15831_13190# VSS.t504 sg13_lv_nmos ad=0.2516p pd=2.16u as=0.2516p ps=2.16u w=0.74u l=0.13u
X2241 VDD.t322 a_4187_2434# a_10951_17497# VDD.t297 sg13_lv_pmos ad=0.3808p pd=2.92u as=0.2128p ps=1.5u w=1.12u l=0.6u
X2242 VDD.t534 a_21157_16869# a_21625_16071# VDD.t4 sg13_lv_pmos ad=0.252p pd=1.57u as=0.3808p ps=2.92u w=1.12u l=0.13u
X2243 VDD.t768 VDD.t766 VDD.t767 VDD.t268 sg13_lv_pmos ad=0.68p pd=4.68u as=0 ps=0 w=2u l=1u
X2244 VDD.t153 VSS.t849 VDD.t152 VDD.t4 sg13_lv_pmos ad=0.34p pd=2.68u as=0 ps=0 w=1u l=1u
X2245 VSS.t510 a_14009_11568# a_14111_11568# VSS.t509 sg13_lv_nmos ad=2.39977p pd=15.495u as=0.2516p ps=2.16u w=0.74u l=0.13u
X2246 a_12715_1044# a_12505_1044# VSS.t1701 VSS.t1898 sg13_lv_nmos ad=0.1406p pd=1.12u as=0.1665p ps=1.19u w=0.74u l=0.13u
X2247 a_14888_3889# a_14317_4687# VSS.t332 VSS.t331 sg13_lv_nmos ad=0.1406p pd=1.12u as=0.2516p ps=2.16u w=0.74u l=0.13u
X2248 a_13231_4687# a_12993_4687# a_13123_4687# VSS.t1202 sg13_lv_nmos ad=0.1406p pd=1.12u as=0.2516p ps=2.16u w=0.74u l=0.2u
X2249 VDD.t725 a_25283_4687# a_25717_4687# VDD.t281 sg13_lv_pmos ad=0.2128p pd=1.5u as=0.3808p ps=2.92u w=1.12u l=0.13u
X2250 VSS.t534 a_10517_7532# a_10985_6734# VSS.t2166 sg13_lv_nmos ad=0.1665p pd=1.19u as=0.2516p ps=2.16u w=0.74u l=0.13u
X2251 a_17928_1044# a_17357_1842# VSS.t557 VSS.t1718 sg13_lv_nmos ad=0.1406p pd=1.12u as=0.2516p ps=2.16u w=0.74u l=0.13u
X2252 a_16108_5979# a_2595_6001.t2 a_19550_6734# VSS.t1938 sg13_lv_nmos ad=0.2516p pd=2.16u as=0.2516p ps=2.16u w=0.74u l=0.13u
X2253 VSS.t594 a_2019_16074.t9 a_4324_16035# VSS.t593 sg13_lv_nmos ad=0.2516p pd=2.16u as=0.2516p ps=2.16u w=0.74u l=0.13u
X2254 VSS.t1220 CHAN0_MUX_SEL3 a_3543_15358# VSS.t2194 sg13_lv_nmos ad=0.1331p pd=1.12u as=0.1216p ps=1.02u w=0.64u l=0.13u
X2255 a_25153_1842# a_24957_1842# VDD.t1275 VDD.t399 sg13_lv_pmos ad=0.3808p pd=2.92u as=0.2128p ps=1.5u w=1.12u l=0.13u
X2256 VDD.t1034 a_2019_16074.t4 a_19524_16035# VDD.t4 sg13_lv_pmos ad=0.3808p pd=2.92u as=0.3808p ps=2.92u w=1.12u l=0.13u
X2257 VDD.t988 a_3171_3892.t9 a_5844_3853# VDD.t0 sg13_lv_pmos ad=0.3808p pd=2.92u as=0.3808p ps=2.92u w=1.12u l=0.13u
X2258 a_23871_14652# a_23633_14024# a_23763_14024# VDD.t301 sg13_lv_pmos ad=0.2128p pd=1.5u as=0.3808p ps=2.92u w=1.12u l=0.2u
X2259 a_1544_13226# CHAN1_MUX_SEL1 VSS.t189 VSS.t2192 sg13_lv_nmos ad=0.2516p pd=2.16u as=0.2516p ps=2.16u w=0.74u l=0.13u
X2260 a_16108_15316# a_23945_15546# a_22590_16071# VDD.t4 sg13_lv_pmos ad=0.3808p pd=2.92u as=0.3808p ps=2.92u w=1.12u l=0.13u
X2261 CHAN1_DELAY_OUT_LAST a_27997_14024# VDD.t907 VDD.t301 sg13_lv_pmos ad=0.3808p pd=2.92u as=0.2128p ps=1.5u w=1.12u l=0.13u
X2262 a_10430_13226# a_12791_13190# a_12715_13226# VDD.t50 sg13_lv_pmos ad=0.3808p pd=2.92u as=0.2128p ps=1.5u w=1.12u l=0.13u
X2263 a_19550_1044# a_3171_1047.t4 a_20968_1044# VSS.t382 sg13_lv_nmos ad=0.2516p pd=2.16u as=0.1406p ps=1.12u w=0.74u l=0.13u
X2264 VDD.t1579 CHAN3_MUX_SEL4 a_15765_463# VDD.t7 sg13_lv_pmos ad=0.3808p pd=2.92u as=0.3808p ps=2.92u w=1.12u l=0.13u
X2265 VDD.t308 a_4187_2434# a_5631_5315# VDD.t281 sg13_lv_pmos ad=0.3808p pd=2.92u as=0.2128p ps=1.5u w=1.12u l=0.6u
X2266 a_16108_12471# a_20905_12701# a_19550_13226# VDD.t50 sg13_lv_pmos ad=0.3808p pd=2.92u as=0.3808p ps=2.92u w=1.12u l=0.13u
X2267 a_19550_1044# a_19524_1008# a_19448_1044# VDD.t7 sg13_lv_pmos ad=0.3808p pd=2.92u as=0.2128p ps=1.5u w=1.12u l=0.13u
X2268 VSS.t542 a_4187_1764.t24 a_10951_1842# VSS.t541 sg13_lv_nmos ad=0.2516p pd=2.16u as=0.1406p ps=1.12u w=0.74u l=0.6u
X2269 VDD.t304 a_4187_2434# a_24631_14652# VDD.t301 sg13_lv_pmos ad=0.3808p pd=2.92u as=0.2128p ps=1.5u w=1.12u l=0.6u
X2270 VSS.t1044 VDD.t1631 VSS.t1044 VSS.t1045 sg13_lv_nmos ad=79.8f pd=0.8u as=0 ps=0 w=0.42u l=1u
X2271 VDD.t986 a_2595_3892.t7 a_11271_3853# VDD.t0 sg13_lv_pmos ad=0.3808p pd=2.92u as=0.3808p ps=2.92u w=1.12u l=0.13u
X2272 a_18551_7532# a_18313_7532# a_18443_7532# VSS.t693 sg13_lv_nmos ad=0.1406p pd=1.12u as=0.2516p ps=2.16u w=0.74u l=0.2u
X2273 VDD.t671 a_1544_6734# a_2297_7085# VDD.t41 sg13_lv_pmos ad=0.1918p pd=1.5u as=0.1596p ps=1.22u w=0.84u l=0.13u
X2274 a_7288_1044# a_6717_1842# VSS.t1598 VSS.t2286 sg13_lv_nmos ad=0.1406p pd=1.12u as=0.2516p ps=2.16u w=0.74u l=0.13u
X2275 a_1544_3134# CHAN2_MUX_SEL3 VSS.t31 VSS.t30 sg13_lv_nmos ad=0.2516p pd=2.16u as=0.2516p ps=2.16u w=0.74u l=0.13u
X2276 a_12233_4687# a_12037_4687# VSS.t295 VSS.t607 sg13_lv_nmos ad=0.2516p pd=2.16u as=0.1406p ps=1.12u w=0.74u l=0.13u
X2277 a_17275_6734# a_17065_6734# VDD.t645 VDD.t41 sg13_lv_pmos ad=0.2128p pd=1.5u as=0.252p ps=1.57u w=1.12u l=0.13u
X2278 VSS.t959 VDD.t1655 VSS.t959 VSS.t961 sg13_lv_nmos ad=79.8f pd=0.8u as=0 ps=0 w=0.42u l=1u
X2279 a_3747_16074.t0 a_3449_16422# VDD.t472 VDD.t4 sg13_lv_pmos ad=0.2128p pd=1.5u as=0.1918p ps=1.5u w=1.12u l=0.13u
X2280 VDD.t1458 a_2019_13229.t8 a_7364_13190# VDD.t50 sg13_lv_pmos ad=0.3808p pd=2.92u as=0.3808p ps=2.92u w=1.12u l=0.13u
X2281 VSS.t485 a_20723_1842# a_21157_1842# VSS.t1976 sg13_lv_nmos ad=0.1406p pd=1.12u as=0.2516p ps=2.16u w=0.74u l=0.13u
X2282 a_2019_6737.t0 a_1721_7085# VDD.t528 VDD.t41 sg13_lv_pmos ad=0.2128p pd=1.5u as=0.1918p ps=1.5u w=1.12u l=0.13u
X2283 VDD.t553 a_13123_16869# a_13557_16869# VDD.t297 sg13_lv_pmos ad=0.2128p pd=1.5u as=0.3808p ps=2.92u w=1.12u l=0.13u
X2284 VDD.t1199 a_3747_6737.t6 a_15831_6698# VDD.t41 sg13_lv_pmos ad=0.3808p pd=2.92u as=0.3808p ps=2.92u w=1.12u l=0.13u
X2285 a_11693_11680# a_10751_11568# a_11491_11918# VDD.t268 sg13_lv_pmos ad=93.45f pd=0.865u as=0.2048p ps=1.63u w=0.42u l=0.13u
X2286 VDD.t580 CHAN1_MUX_SEL4 a_15765_12645# VDD.t50 sg13_lv_pmos ad=0.3808p pd=2.92u as=0.3808p ps=2.92u w=1.12u l=0.13u
X2287 VDD.t1460 a_3747_16074.t3 a_24951_16035# VDD.t4 sg13_lv_pmos ad=0.3808p pd=2.92u as=0.3808p ps=2.92u w=1.12u l=0.13u
X2288 a_1544_289# CHAN3_MUX_SEL3 VSS.t1487 VSS.t1486 sg13_lv_nmos ad=0.2516p pd=2.16u as=0.2516p ps=2.16u w=0.74u l=0.13u
X2289 VDD.t1240 a_3747_3892.t8 a_9751_3853# VDD.t0 sg13_lv_pmos ad=0.3808p pd=2.92u as=0.3808p ps=2.92u w=1.12u l=0.13u
X2290 VDD.t129 VSS.t870 VDD.t128 VDD.t4 sg13_lv_pmos ad=0.34p pd=2.68u as=0 ps=0 w=1u l=1u
X2291 a_22590_1044# a_3747_1047.t3 a_24875_1044# VSS.t1619 sg13_lv_nmos ad=0.2516p pd=2.16u as=0.1406p ps=1.12u w=0.74u l=0.13u
X2292 a_13470_1044# a_14311_1008# a_14235_1044# VDD.t7 sg13_lv_pmos ad=0.3808p pd=2.92u as=0.2128p ps=1.5u w=1.12u l=0.13u
X2293 a_4350_6734# a_4324_6698# a_4248_6734# VDD.t41 sg13_lv_pmos ad=0.3808p pd=2.92u as=0.2128p ps=1.5u w=1.12u l=0.13u
X2294 a_8433_14024# a_8237_14024# VDD.t1362 VDD.t301 sg13_lv_pmos ad=0.3808p pd=2.92u as=0.2128p ps=1.5u w=1.12u l=0.13u
X2295 a_3171_3892.t0 a_2873_4240# VDD.t694 VDD.t0 sg13_lv_pmos ad=0.2128p pd=1.5u as=0.1918p ps=1.5u w=1.12u l=0.13u
X2296 a_14888_6734# a_14317_7532# VDD.t905 VDD.t41 sg13_lv_pmos ad=0.2128p pd=1.5u as=0.3808p ps=2.92u w=1.12u l=0.13u
X2297 VSS.t580 a_4187_1764.t7 a_23871_1842# VSS.t579 sg13_lv_nmos ad=0.2516p pd=2.16u as=0.1406p ps=1.12u w=0.74u l=0.6u
X2298 a_22351_7532# a_22113_7532# a_22243_7532# VSS.t1430 sg13_lv_nmos ad=0.1406p pd=1.12u as=0.2516p ps=2.16u w=0.74u l=0.2u
X2299 VSS.t464 a_3747_6737.t5 a_18871_6698# VSS.t463 sg13_lv_nmos ad=0.2516p pd=2.16u as=0.2516p ps=2.16u w=0.74u l=0.13u
X2300 VDD.t499 a_2019_1047.t3 a_22564_1008# VDD.t7 sg13_lv_pmos ad=0.3808p pd=2.92u as=0.3808p ps=2.92u w=1.12u l=0.13u
X2301 VSS.t512 a_8997_4687# a_9465_3889# VSS.t1794 sg13_lv_nmos ad=0.1665p pd=1.19u as=0.2516p ps=2.16u w=0.74u l=0.13u
X2302 VSS.t129 a_2873_6021# a_3171_6001.t1 VSS.t679 sg13_lv_nmos ad=0.2812p pd=2.24u as=0.1406p ps=1.12u w=0.74u l=0.13u
X2303 VDD.t1082 VSS.t1044 VDD.t1081 VDD.t0 sg13_lv_pmos ad=0.34p pd=2.68u as=0 ps=0 w=1u l=1u
X2304 VDD.t290 a_2297_4240# a_2595_3892.t0 VDD.t0 sg13_lv_pmos ad=0.4256p pd=3u as=0.2128p ps=1.5u w=1.12u l=0.13u
X2305 VDD.t217 VSS.t819 VDD.t94 VDD.t4 sg13_lv_pmos ad=0.19p pd=1.38u as=0 ps=0 w=1u l=1u
X2306 a_5731_12471# a_11785_12701# a_10430_13226# VDD.t50 sg13_lv_pmos ad=0.3808p pd=2.92u as=0.3808p ps=2.92u w=1.12u l=0.13u
X2307 a_15964_15316# a_15765_15490# a_5731_15316# VSS.t1990 sg13_lv_nmos ad=0.2183p pd=1.33u as=0.2516p ps=2.16u w=0.74u l=0.13u
X2308 VSS.t1189 a_16923_7532# a_17357_7532# VSS.t1188 sg13_lv_nmos ad=0.1406p pd=1.12u as=0.2516p ps=2.16u w=0.74u l=0.13u
X2309 VDD.t1049 a_3747_16074.t8 a_9751_16035# VDD.t4 sg13_lv_pmos ad=0.3808p pd=2.92u as=0.3808p ps=2.92u w=1.12u l=0.13u
X2310 a_10191_14652# a_9953_14024# a_10083_14024# VDD.t301 sg13_lv_pmos ad=0.2128p pd=1.5u as=0.3808p ps=2.92u w=1.12u l=0.2u
X2311 VDD.t310 a_4187_2434# a_15511_14652# VDD.t301 sg13_lv_pmos ad=0.3808p pd=2.92u as=0.2128p ps=1.5u w=1.12u l=0.6u
X2312 VSS.t357 REF_MUX_SEL4 a_15765_6153# VSS.t356 sg13_lv_nmos ad=0.2516p pd=2.16u as=0.2516p ps=2.16u w=0.74u l=0.13u
X2313 a_10713_16869# a_10517_16869# VDD.t1496 VDD.t297 sg13_lv_pmos ad=0.3808p pd=2.92u as=0.2128p ps=1.5u w=1.12u l=0.13u
X2314 VDD.t21 VSS.t2 VDD.t241 VDD.t0 sg13_lv_pmos ad=0.34p pd=2.68u as=0 ps=0 w=1u l=1u
X2315 a_16793_4687# a_16597_4687# VDD.t287 VDD.t281 sg13_lv_pmos ad=0.3808p pd=2.92u as=0.2128p ps=1.5u w=1.12u l=0.13u
X2316 VSS.t1979 a_25717_1842# a_26185_1044# VSS.t1978 sg13_lv_nmos ad=0.1665p pd=1.19u as=0.2516p ps=2.16u w=0.74u l=0.13u
X2317 a_7911_5315# a_7673_4687# a_7803_4687# VDD.t281 sg13_lv_pmos ad=0.2128p pd=1.5u as=0.3808p ps=2.92u w=1.12u l=0.2u
X2318 VDD.t1087 a_2595_16074.t9 a_5191_16035# VDD.t4 sg13_lv_pmos ad=0.3808p pd=2.92u as=0.3808p ps=2.92u w=1.12u l=0.13u
X2319 VDD.t350 a_4187_2434# a_10951_14652# VDD.t301 sg13_lv_pmos ad=0.3808p pd=2.92u as=0.2128p ps=1.5u w=1.12u l=0.6u
X2320 VDD.t161 VSS.t431 VDD.t165 VDD.t50 sg13_lv_pmos ad=0.34p pd=2.68u as=0 ps=0 w=1u l=1u
X2321 a_12715_6734# a_12505_6734# VSS.t360 VSS.t359 sg13_lv_nmos ad=0.1406p pd=1.12u as=0.1665p ps=1.19u w=0.74u l=0.13u
X2322 a_13231_1842# a_12993_1842# a_13123_1842# VSS.t1304 sg13_lv_nmos ad=0.1406p pd=1.12u as=0.2516p ps=2.16u w=0.74u l=0.2u
X2323 a_2297_4240# CHAN2_MUX_SEL0 VDD.t1476 VDD.t0 sg13_lv_pmos ad=0.1596p pd=1.22u as=0.2856p ps=2.36u w=0.84u l=0.13u
X2324 a_25153_7532# a_24957_7532# VDD.t526 VDD.t275 sg13_lv_pmos ad=0.3808p pd=2.92u as=0.2128p ps=1.5u w=1.12u l=0.13u
X2325 a_17928_6734# a_17357_7532# VSS.t715 VSS.t1439 sg13_lv_nmos ad=0.1406p pd=1.12u as=0.2516p ps=2.16u w=0.74u l=0.13u
X2326 a_5631_14024# a_5393_14024# a_5523_14024# VSS.t1992 sg13_lv_nmos ad=0.1406p pd=1.12u as=0.2516p ps=2.16u w=0.74u l=0.2u
X2327 VSS.t124 CHAN1_MUX_SEL3 a_3543_12513# VSS.t123 sg13_lv_nmos ad=0.1331p pd=1.12u as=0.1216p ps=1.02u w=0.64u l=0.13u
X2328 VSS.t1065 VDD.t1624 VSS.t1065 VSS.t1067 sg13_lv_nmos ad=79.8f pd=0.8u as=0 ps=0 w=0.42u l=1u
X2329 VDD.t971 a_24197_14024# a_24665_13226# VDD.t50 sg13_lv_pmos ad=0.252p pd=1.57u as=0.3808p ps=2.92u w=1.12u l=0.13u
X2330 a_19833_14024# a_19637_14024# VSS.t1644 VSS.t2088 sg13_lv_nmos ad=0.2516p pd=2.16u as=0.1406p ps=1.12u w=0.74u l=0.13u
X2331 a_17791_2470# a_17553_1842# a_17683_1842# VDD.t399 sg13_lv_pmos ad=0.2128p pd=1.5u as=0.3808p ps=2.92u w=1.12u l=0.2u
X2332 VDD.t1470 a_1544_3889# a_1721_4240# VDD.t0 sg13_lv_pmos ad=0.1918p pd=1.5u as=0.1596p ps=1.22u w=0.84u l=0.13u
X2333 VSS.t219 a_4187_1764.t36 a_26151_4687# VSS.t527 sg13_lv_nmos ad=0.2516p pd=2.16u as=0.1406p ps=1.12u w=0.74u l=0.6u
X2334 a_19550_6734# a_3171_6737.t4 a_20968_6734# VSS.t1311 sg13_lv_nmos ad=0.2516p pd=2.16u as=0.1406p ps=1.12u w=0.74u l=0.13u
X2335 VSS.t1378 a_4187_1764.t142 a_20071_16869# VSS.t1792 sg13_lv_nmos ad=0.2516p pd=2.16u as=0.1406p ps=1.12u w=0.74u l=0.6u
X2336 VSS.t1323 a_4437_1842# a_4905_1044# VSS.t2205 sg13_lv_nmos ad=0.1665p pd=1.19u as=0.2516p ps=2.16u w=0.74u l=0.13u
X2337 VSS.t434 a_2019_3892.t5 a_16484_3853# VSS.t1839 sg13_lv_nmos ad=0.2516p pd=2.16u as=0.2516p ps=2.16u w=0.74u l=0.13u
X2338 a_25153_16869# a_24957_16869# VDD.t889 VDD.t297 sg13_lv_pmos ad=0.3808p pd=2.92u as=0.2128p ps=1.5u w=1.12u l=0.13u
X2339 VSS.t707 a_4187_1764.t128 a_6391_14024# VSS.t706 sg13_lv_nmos ad=0.2516p pd=2.16u as=0.1406p ps=1.12u w=0.74u l=0.6u
X2340 VSS.t596 a_4187_1764.t88 a_10951_7532# VSS.t595 sg13_lv_nmos ad=0.2516p pd=2.16u as=0.1406p ps=1.12u w=0.74u l=0.6u
X2341 a_2019_6001.t1 a_1721_6021# VSS.t477 VSS.t1214 sg13_lv_nmos ad=0.1406p pd=1.12u as=0.1331p ps=1.12u w=0.74u l=0.13u
X2342 VSS.t1400 a_23763_14024# a_24197_14024# VSS.t1399 sg13_lv_nmos ad=0.1406p pd=1.12u as=0.2516p ps=2.16u w=0.74u l=0.13u
X2343 VDD.t62 VSS.t959 VDD.t61 VDD.t41 sg13_lv_pmos ad=0.19p pd=1.38u as=0 ps=0 w=1u l=1u
X2344 VSS.t937 VDD.t1660 VSS.t937 VSS.t941 sg13_lv_nmos ad=79.8f pd=0.8u as=0 ps=0 w=0.42u l=1u
X2345 VSS.t105 a_2595_13229.t2 a_26471_13190# VSS.t1302 sg13_lv_nmos ad=0.2516p pd=2.16u as=0.2516p ps=2.16u w=0.74u l=0.13u
X2346 VDD.t175 VSS.t878 VDD.t174 VDD.t50 sg13_lv_pmos ad=0.19p pd=1.38u as=0 ps=0 w=1u l=1u
X2347 a_7288_6734# a_6717_7532# VSS.t111 VSS.t513 sg13_lv_nmos ad=0.1406p pd=1.12u as=0.2516p ps=2.16u w=0.74u l=0.13u
X2348 VDD.t259 VSS.t1105 VDD.t258 VDD.t7 sg13_lv_pmos ad=0.34p pd=2.68u as=0 ps=0 w=1u l=1u
X2349 VSS.t117 a_4187_1764.t64 a_4871_4687# VSS.t700 sg13_lv_nmos ad=0.2516p pd=2.16u as=0.1406p ps=1.12u w=0.74u l=0.6u
X2350 a_5731_5979# a_3171_6001.t3 a_10430_6734# VSS.t1784 sg13_lv_nmos ad=0.2516p pd=2.16u as=0.2516p ps=2.16u w=0.74u l=0.13u
X2351 a_12233_1842# a_12037_1842# VSS.t171 VSS.t1699 sg13_lv_nmos ad=0.2516p pd=2.16u as=0.1406p ps=1.12u w=0.74u l=0.13u
X2352 VSS.t163 a_20723_7532# a_21157_7532# VSS.t2311 sg13_lv_nmos ad=0.1406p pd=1.12u as=0.2516p ps=2.16u w=0.74u l=0.13u
X2353 VSS.t119 a_3171_3892.t9 a_5844_3853# VSS.t1391 sg13_lv_nmos ad=0.2516p pd=2.16u as=0.2516p ps=2.16u w=0.74u l=0.13u
X2354 VDD.t576 a_27563_4687# a_27997_4687# VDD.t281 sg13_lv_pmos ad=0.2128p pd=1.5u as=0.3808p ps=2.92u w=1.12u l=0.13u
X2355 VDD.t1379 a_13123_14024# a_13557_14024# VDD.t301 sg13_lv_pmos ad=0.2128p pd=1.5u as=0.3808p ps=2.92u w=1.12u l=0.13u
X2356 VSS.t378 a_3171_1047.t8 a_8884_1008# VSS.t377 sg13_lv_nmos ad=0.2516p pd=2.16u as=0.2516p ps=2.16u w=0.74u l=0.13u
X2357 VSS.t1111 VDD.t1611 VSS.t1109 VSS.t1110 sg13_lv_nmos ad=79.8f pd=0.8u as=0 ps=0 w=0.42u l=1u
X2358 VSS.t1163 a_3449_1395# a_3747_1047.t1 VSS.t1162 sg13_lv_nmos ad=0.2812p pd=2.24u as=0.1406p ps=1.12u w=0.74u l=0.13u
X2359 VSS.t413 a_12037_16869# a_12505_16071# VSS.t412 sg13_lv_nmos ad=0.1665p pd=1.19u as=0.2516p ps=2.16u w=0.74u l=0.13u
X2360 a_20593_4687# a_20397_4687# VDD.t515 VDD.t281 sg13_lv_pmos ad=0.3808p pd=2.92u as=0.2128p ps=1.5u w=1.12u l=0.13u
X2361 a_8155_16071# a_7945_16071# VDD.t839 VDD.t4 sg13_lv_pmos ad=0.2128p pd=1.5u as=0.252p ps=1.57u w=1.12u l=0.13u
X2362 a_14009_11568# REF_CLK VDD.t270 VDD.t268 sg13_lv_pmos ad=0.4088p pd=2.97u as=1.03698p ps=6.245u w=1.12u l=0.13u
X2363 VDD.t547 a_8997_7532# a_9465_6734# VDD.t41 sg13_lv_pmos ad=0.252p pd=1.57u as=0.3808p ps=2.92u w=1.12u l=0.13u
X2364 VDD.t1036 VSS.t1083 VDD.t1101 VDD.t7 sg13_lv_pmos ad=0.34p pd=2.68u as=0 ps=0 w=1u l=1u
X2365 VDD.t255 VSS.t1091 VDD.t254 VDD.t7 sg13_lv_pmos ad=0.19p pd=1.38u as=0 ps=0 w=1u l=1u
X2366 VSS.t1270 a_2019_13229.t3 a_22564_13190# VSS.t1269 sg13_lv_nmos ad=0.2516p pd=2.16u as=0.2516p ps=2.16u w=0.74u l=0.13u
X2367 VSS.t278 a_4187_1764.t162 a_4871_16869# VSS.t277 sg13_lv_nmos ad=0.2516p pd=2.16u as=0.1406p ps=1.12u w=0.74u l=0.6u
X2368 a_1544_12471# CHAN1_MUX_SEL3 VDD.t484 VDD.t50 sg13_lv_pmos ad=0.3808p pd=2.92u as=0.3808p ps=2.92u w=1.12u l=0.13u
X2369 VDD.t632 a_2873_1395# a_3171_1047.t0 VDD.t7 sg13_lv_pmos ad=0.4256p pd=3u as=0.2128p ps=1.5u w=1.12u l=0.13u
X2370 VSS.t1056 VDD.t1627 VSS.t1056 VSS.t1055 sg13_lv_nmos ad=0.1428p pd=1.52u as=0 ps=0 w=0.42u l=1u
X2371 VSS.t1355 a_2595_3892.t7 a_11271_3853# VSS.t1387 sg13_lv_nmos ad=0.2516p pd=2.16u as=0.2516p ps=2.16u w=0.74u l=0.13u
X2372 a_9953_16869# a_9757_16869# VDD.t456 VDD.t297 sg13_lv_pmos ad=0.3808p pd=2.92u as=0.2128p ps=1.5u w=1.12u l=0.13u
X2373 VSS.t666 a_22243_16869# a_22677_16869# VSS.t665 sg13_lv_nmos ad=0.1406p pd=1.12u as=0.2516p ps=2.16u w=0.74u l=0.13u
X2374 a_22590_6734# a_3747_6737.t3 a_24875_6734# VSS.t1774 sg13_lv_nmos ad=0.2516p pd=2.16u as=0.1406p ps=1.12u w=0.74u l=0.13u
X2375 VDD.t734 a_6283_4687# a_6717_4687# VDD.t281 sg13_lv_pmos ad=0.2128p pd=1.5u as=0.3808p ps=2.92u w=1.12u l=0.13u
X2376 VSS.t1376 a_3171_16074.t4 a_21044_16035# VSS.t1452 sg13_lv_nmos ad=0.2516p pd=2.16u as=0.2516p ps=2.16u w=0.74u l=0.13u
X2377 VDD.t1309 a_3747_13229.t2 a_27991_13190# VDD.t50 sg13_lv_pmos ad=0.3808p pd=2.92u as=0.3808p ps=2.92u w=1.12u l=0.13u
X2378 a_21591_2470# a_21353_1842# a_21483_1842# VDD.t399 sg13_lv_pmos ad=0.2128p pd=1.5u as=0.3808p ps=2.92u w=1.12u l=0.2u
X2379 a_6153_1842# a_5957_1842# VDD.t1503 VDD.t399 sg13_lv_pmos ad=0.3808p pd=2.92u as=0.2128p ps=1.5u w=1.12u l=0.13u
X2380 a_7390_13226# a_2019_13229.t8 a_7288_13226# VSS.t2154 sg13_lv_nmos ad=0.2516p pd=2.16u as=0.1406p ps=1.12u w=0.74u l=0.13u
X2381 a_3543_1395# CHAN3_MUX_SEL0 a_3449_1395# VSS.t2010 sg13_lv_nmos ad=0.1216p pd=1.02u as=0.2176p ps=1.96u w=0.64u l=0.13u
X2382 VDD.t1113 a_16163_1842# a_16597_1842# VDD.t399 sg13_lv_pmos ad=0.2128p pd=1.5u as=0.3808p ps=2.92u w=1.12u l=0.13u
X2383 VSS.t728 a_4003_14024# a_4437_14024# VSS.t1986 sg13_lv_nmos ad=0.1406p pd=1.12u as=0.2516p ps=2.16u w=0.74u l=0.13u
X2384 VSS.t44 a_4187_1764.t71 a_23871_7532# VSS.t622 sg13_lv_nmos ad=0.2516p pd=2.16u as=0.1406p ps=1.12u w=0.74u l=0.6u
X2385 a_11711_17497# a_11473_16869# a_11603_16869# VDD.t297 sg13_lv_pmos ad=0.2128p pd=1.5u as=0.3808p ps=2.92u w=1.12u l=0.2u
X2386 VSS.t319 a_3747_3892.t8 a_9751_3853# VSS.t1847 sg13_lv_nmos ad=0.2516p pd=2.16u as=0.2516p ps=2.16u w=0.74u l=0.13u
X2387 VDD.t1227 a_10517_14024# a_10985_13226# VDD.t50 sg13_lv_pmos ad=0.252p pd=1.57u as=0.3808p ps=2.92u w=1.12u l=0.13u
X2388 VDD.t714 a_2019_6737.t5 a_16484_6698# VDD.t41 sg13_lv_pmos ad=0.3808p pd=2.92u as=0.3808p ps=2.92u w=1.12u l=0.13u
X2389 VSS.t1589 a_2595_13229.t5 a_17351_13190# VSS.t1636 sg13_lv_nmos ad=0.2516p pd=2.16u as=0.2516p ps=2.16u w=0.74u l=0.13u
X2390 VDD.t328 a_4187_2434# a_12471_17497# VDD.t297 sg13_lv_pmos ad=0.3808p pd=2.92u as=0.2128p ps=1.5u w=1.12u l=0.6u
X2391 VDD.t539 a_1544_1044# a_2297_1395# VDD.t7 sg13_lv_pmos ad=0.1918p pd=1.5u as=0.1596p ps=1.22u w=0.84u l=0.13u
X2392 a_1544_3889# CHAN2_MUX_SEL1 VDD.t1179 VDD.t0 sg13_lv_pmos ad=0.3808p pd=2.92u as=0.3808p ps=2.92u w=1.12u l=0.13u
X2393 a_15964_5979# REF_MUX_SEL4 a_5731_5979# VDD.t41 sg13_lv_pmos ad=0.3304p pd=1.71u as=0.3808p ps=2.92u w=1.12u l=0.13u
X2394 a_27915_1044# a_27705_1044# VSS.t1231 VSS.t1230 sg13_lv_nmos ad=0.1406p pd=1.12u as=0.1665p ps=1.19u w=0.74u l=0.13u
X2395 a_17275_1044# a_17065_1044# VDD.t1114 VDD.t7 sg13_lv_pmos ad=0.2128p pd=1.5u as=0.252p ps=1.57u w=1.12u l=0.13u
X2396 VSS.t2390 VSS.t2387 VSS.t2389 VSS.t2388 sg13_lv_nmos ad=0.2516p pd=2.16u as=0 ps=0 w=0.74u l=0.6u
X2397 VSS.t483 a_3747_16074.t6 a_15831_16035# VSS.t2157 sg13_lv_nmos ad=0.2516p pd=2.16u as=0.2516p ps=2.16u w=0.74u l=0.13u
X2398 VSS.t1178 a_25717_7532# a_26185_6734# VSS.t1209 sg13_lv_nmos ad=0.1665p pd=1.19u as=0.2516p ps=2.16u w=0.74u l=0.13u
X2399 a_10713_14024# a_10517_14024# VDD.t1364 VDD.t301 sg13_lv_pmos ad=0.3808p pd=2.92u as=0.2128p ps=1.5u w=1.12u l=0.13u
X2400 a_13470_3889# a_15831_3853# a_15755_3889# VDD.t0 sg13_lv_pmos ad=0.3808p pd=2.92u as=0.2128p ps=1.5u w=1.12u l=0.13u
X2401 a_26151_17497# a_25913_16869# a_26043_16869# VDD.t297 sg13_lv_pmos ad=0.2128p pd=1.5u as=0.3808p ps=2.92u w=1.12u l=0.2u
X2402 VSS.t474 a_3171_15338.t2 a_23945_15546# VSS.t473 sg13_lv_nmos ad=0.2516p pd=2.16u as=0.2516p ps=2.16u w=0.74u l=0.13u
X2403 VSS.t1267 a_3747_13229.t7 a_12791_13190# VSS.t1406 sg13_lv_nmos ad=0.2516p pd=2.16u as=0.2516p ps=2.16u w=0.74u l=0.13u
X2404 VDD.t785 VDD.t783 VDD.t784 VDD.t293 sg13_lv_pmos ad=0.3808p pd=2.92u as=0 ps=0 w=1.12u l=0.13u
X2405 a_13231_7532# a_12993_7532# a_13123_7532# VSS.t269 sg13_lv_nmos ad=0.1406p pd=1.12u as=0.2516p ps=2.16u w=0.74u l=0.2u
X2406 a_2019_1047.t0 a_1721_1395# VDD.t540 VDD.t7 sg13_lv_pmos ad=0.2128p pd=1.5u as=0.1918p ps=1.5u w=1.12u l=0.13u
X2407 VDD.t431 a_4187_2434# a_10191_2470# VDD.t399 sg13_lv_pmos ad=0.3808p pd=2.92u as=0.2128p ps=1.5u w=1.12u l=0.6u
X2408 a_16108_5979# REF_MUX_SEL4 a_15964_5979# VSS.t355 sg13_lv_nmos ad=0.2516p pd=2.16u as=0.2183p ps=1.33u w=0.74u l=0.13u
X2409 VDD.t1226 a_3449_13577# a_3747_13229.t0 VDD.t50 sg13_lv_pmos ad=0.4256p pd=3u as=0.2128p ps=1.5u w=1.12u l=0.13u
X2410 VDD.t1077 a_3747_1047.t6 a_15831_1008# VDD.t7 sg13_lv_pmos ad=0.3808p pd=2.92u as=0.3808p ps=2.92u w=1.12u l=0.13u
X2411 a_15108_11015# a_14851_10872# a_15270_10795# VSS.t130 sg13_lv_nmos ad=0.1428p pd=1.52u as=37.8f ps=0.6u w=0.42u l=0.13u
X2412 a_17791_8160# a_17553_7532# a_17683_7532# VDD.t275 sg13_lv_pmos ad=0.2128p pd=1.5u as=0.3808p ps=2.92u w=1.12u l=0.2u
X2413 VDD.t1104 a_3171_6737.t9 a_5844_6698# VDD.t41 sg13_lv_pmos ad=0.3808p pd=2.92u as=0.3808p ps=2.92u w=1.12u l=0.13u
X2414 VSS.t268 a_4187_1764.t4 a_26151_1842# VSS.t267 sg13_lv_nmos ad=0.2516p pd=2.16u as=0.1406p ps=1.12u w=0.74u l=0.6u
X2415 a_1544_16071# CHAN0_MUX_SEL1 VSS.t92 VSS.t91 sg13_lv_nmos ad=0.2516p pd=2.16u as=0.2516p ps=2.16u w=0.74u l=0.13u
X2416 VDD.t658 a_2019_16074.t5 a_16484_16035# VDD.t4 sg13_lv_pmos ad=0.3808p pd=2.92u as=0.3808p ps=2.92u w=1.12u l=0.13u
X2417 VSS.t1526 a_4187_1764.t98 VSS.t1528 VSS.t1527 sg13_lv_nmos ad=1.33p pd=7.38u as=0 ps=0 w=7u l=7u
X2418 VSS.t1113 VDD.t1610 VSS.t1113 VSS.t1112 sg13_lv_nmos ad=0.1428p pd=1.52u as=0 ps=0 w=0.42u l=1u
X2419 VDD.t182 VSS.t937 VDD.t180 VDD.t41 sg13_lv_pmos ad=0.19p pd=1.38u as=0 ps=0 w=1u l=1u
X2420 VSS.t1124 a_4437_7532# a_4905_6734# VSS.t2313 sg13_lv_nmos ad=0.1665p pd=1.19u as=0.2516p ps=2.16u w=0.74u l=0.13u
X2421 VDD.t1239 a_2595_3892.t2 a_26471_3853# VDD.t0 sg13_lv_pmos ad=0.3808p pd=2.92u as=0.3808p ps=2.92u w=1.12u l=0.13u
X2422 a_25153_14024# a_24957_14024# VDD.t903 VDD.t301 sg13_lv_pmos ad=0.3808p pd=2.92u as=0.2128p ps=1.5u w=1.12u l=0.13u
X2423 VDD.t1249 a_19963_1842# a_20397_1842# VDD.t399 sg13_lv_pmos ad=0.2128p pd=1.5u as=0.3808p ps=2.92u w=1.12u l=0.13u
X2424 a_16108_15316# a_20905_15546# a_19550_16071# VDD.t4 sg13_lv_pmos ad=0.3808p pd=2.92u as=0.3808p ps=2.92u w=1.12u l=0.13u
X2425 VSS.t918 VDD.t1666 VSS.t918 VSS.t920 sg13_lv_nmos ad=0.1428p pd=1.52u as=0 ps=0 w=0.42u l=1u
X2426 a_4350_3889# a_5191_3853# a_5115_3889# VDD.t0 sg13_lv_pmos ad=0.3808p pd=2.92u as=0.2128p ps=1.5u w=1.12u l=0.13u
X2427 a_27433_4687# a_27237_4687# VSS.t348 VSS.t2174 sg13_lv_nmos ad=0.2516p pd=2.16u as=0.1406p ps=1.12u w=0.74u l=0.13u
X2428 VSS.t835 VDD.t1692 VSS.t837 VSS.t836 sg13_lv_nmos ad=79.8f pd=0.8u as=0 ps=0 w=0.42u l=1u
X2429 VDD.t710 a_2595_6737.t7 a_11271_6698# VDD.t41 sg13_lv_pmos ad=0.3808p pd=2.92u as=0.3808p ps=2.92u w=1.12u l=0.13u
X2430 VDD.t167 VSS.t1024 VDD.t40 VDD.t0 sg13_lv_pmos ad=0.19p pd=1.38u as=0 ps=0 w=1u l=1u
X2431 a_9431_16869# a_9193_16869# a_9323_16869# VSS.t2276 sg13_lv_nmos ad=0.1406p pd=1.12u as=0.2516p ps=2.16u w=0.74u l=0.2u
X2432 a_4350_1044# a_4324_1008# a_4248_1044# VDD.t7 sg13_lv_pmos ad=0.3808p pd=2.92u as=0.2128p ps=1.5u w=1.12u l=0.13u
X2433 a_12233_7532# a_12037_7532# VSS.t662 VSS.t2185 sg13_lv_nmos ad=0.2516p pd=2.16u as=0.1406p ps=1.12u w=0.74u l=0.13u
X2434 a_14888_1044# a_14317_1842# VDD.t1158 VDD.t7 sg13_lv_pmos ad=0.2128p pd=1.5u as=0.3808p ps=2.92u w=1.12u l=0.13u
X2435 VSS.t248 a_4187_1764.t32 a_4871_1842# VSS.t758 sg13_lv_nmos ad=0.2516p pd=2.16u as=0.1406p ps=1.12u w=0.74u l=0.6u
X2436 a_19073_4687# a_18877_4687# VDD.t480 VDD.t281 sg13_lv_pmos ad=0.3808p pd=2.92u as=0.2128p ps=1.5u w=1.12u l=0.13u
X2437 VDD.t288 a_16597_4687# a_17065_3889# VDD.t0 sg13_lv_pmos ad=0.252p pd=1.57u as=0.3808p ps=2.92u w=1.12u l=0.13u
X2438 VSS.t686 a_2595_15338.t3 a_8745_15546# VSS.t685 sg13_lv_nmos ad=0.2516p pd=2.16u as=0.2516p ps=2.16u w=0.74u l=0.13u
X2439 VDD.t1062 a_2019_13229.t9 a_4324_13190# VDD.t50 sg13_lv_pmos ad=0.3808p pd=2.92u as=0.3808p ps=2.92u w=1.12u l=0.13u
X2440 VSS.t1435 a_3449_7085# a_3747_6737.t1 VSS.t1434 sg13_lv_nmos ad=0.2812p pd=2.24u as=0.1406p ps=1.12u w=0.74u l=0.13u
X2441 VSS.t1142 a_27563_16869# a_27997_16869# VSS.t1141 sg13_lv_nmos ad=0.1406p pd=1.12u as=0.2516p ps=2.16u w=0.74u l=0.13u
X2442 VDD.t270 a_15108_11015# a_15053_11110# VDD.t268 sg13_lv_pmos ad=1.10612p pd=6.66u as=93.45f ps=0.865u w=0.42u l=0.13u
X2443 VSS.t718 a_3171_6737.t8 a_8884_6698# VSS.t1308 sg13_lv_nmos ad=0.2516p pd=2.16u as=0.2516p ps=2.16u w=0.74u l=0.13u
X2444 VDD.t1001 CHAN0_MUX_SEL4 a_15765_15490# VDD.t4 sg13_lv_pmos ad=0.3808p pd=2.92u as=0.3808p ps=2.92u w=1.12u l=0.13u
X2445 VDD.t927 a_3747_6737.t8 a_9751_6698# VDD.t41 sg13_lv_pmos ad=0.3808p pd=2.92u as=0.3808p ps=2.92u w=1.12u l=0.13u
X2446 VDD.t493 a_3747_16074.t4 a_21911_16035# VDD.t4 sg13_lv_pmos ad=0.3808p pd=2.92u as=0.3808p ps=2.92u w=1.12u l=0.13u
X2447 a_9953_14024# a_9757_14024# VDD.t1349 VDD.t301 sg13_lv_pmos ad=0.3808p pd=2.92u as=0.2128p ps=1.5u w=1.12u l=0.13u
X2448 a_21591_8160# a_21353_7532# a_21483_7532# VDD.t275 sg13_lv_pmos ad=0.2128p pd=1.5u as=0.3808p ps=2.92u w=1.12u l=0.2u
X2449 VSS.t1011 VDD.t1641 VSS.t1009 VSS.t1010 sg13_lv_nmos ad=79.8f pd=0.8u as=0 ps=0 w=0.42u l=1u
X2450 a_27048_13226# a_26477_14024# VSS.t105 VSS.t1891 sg13_lv_nmos ad=0.1406p pd=1.12u as=0.2516p ps=2.16u w=0.74u l=0.13u
X2451 VSS.t880 VDD.t1678 VSS.t880 VSS.t882 sg13_lv_nmos ad=0.1428p pd=1.52u as=0 ps=0 w=0.42u l=1u
X2452 a_6153_7532# a_5957_7532# VDD.t525 VDD.t275 sg13_lv_pmos ad=0.3808p pd=2.92u as=0.2128p ps=1.5u w=1.12u l=0.13u
X2453 a_3543_7085# REF_MUX_SEL0 a_3449_7085# VSS.t338 sg13_lv_nmos ad=0.1216p pd=1.02u as=0.2176p ps=1.96u w=0.64u l=0.13u
X2454 VSS.t442 a_4187_1764.t61 a_7151_4687# VSS.t441 sg13_lv_nmos ad=0.2516p pd=2.16u as=0.1406p ps=1.12u w=0.74u l=0.6u
X2455 VDD.t895 a_16163_7532# a_16597_7532# VDD.t275 sg13_lv_pmos ad=0.2128p pd=1.5u as=0.3808p ps=2.92u w=1.12u l=0.13u
X2456 VSS.t1320 a_4187_1764.t106 a_23111_14024# VSS.t2110 sg13_lv_nmos ad=0.2516p pd=2.16u as=0.1406p ps=1.12u w=0.74u l=0.6u
X2457 a_1256_289# CHAN3_MUX_SEL2 VDD.t1054 VDD.t7 sg13_lv_pmos ad=0.3808p pd=2.92u as=0.3808p ps=2.92u w=1.12u l=0.13u
X2458 VDD.t850 a_19203_4687# a_19637_4687# VDD.t281 sg13_lv_pmos ad=0.2128p pd=1.5u as=0.3808p ps=2.92u w=1.12u l=0.13u
X2459 a_11711_14652# a_11473_14024# a_11603_14024# VDD.t301 sg13_lv_pmos ad=0.2128p pd=1.5u as=0.3808p ps=2.92u w=1.12u l=0.2u
X2460 a_5731_15316# a_11785_15546# a_10430_16071# VDD.t4 sg13_lv_pmos ad=0.3808p pd=2.92u as=0.3808p ps=2.92u w=1.12u l=0.13u
X2461 VSS.t660 a_7803_16869# a_8237_16869# VSS.t659 sg13_lv_nmos ad=0.1406p pd=1.12u as=0.2516p ps=2.16u w=0.74u l=0.13u
X2462 VDD.t598 a_3747_16074.t9 a_6711_16035# VDD.t4 sg13_lv_pmos ad=0.3808p pd=2.92u as=0.3808p ps=2.92u w=1.12u l=0.13u
X2463 VDD.t351 a_4187_2434# a_12471_14652# VDD.t301 sg13_lv_pmos ad=0.3808p pd=2.92u as=0.2128p ps=1.5u w=1.12u l=0.6u
X2464 a_27915_6734# a_27705_6734# VSS.t521 VSS.t520 sg13_lv_nmos ad=0.1406p pd=1.12u as=0.1665p ps=1.19u w=0.74u l=0.13u
X2465 a_16108_289# a_15765_463# a_15964_289# VDD.t7 sg13_lv_pmos ad=0.3808p pd=2.92u as=0.3304p ps=1.71u w=1.12u l=0.13u
X2466 VSS.t2403 VSS.t2400 VSS.t2402 VSS.t2401 sg13_lv_nmos ad=0.2516p pd=2.16u as=0 ps=0 w=0.74u l=0.6u
X2467 a_15964_3134# CHAN2_MUX_SEL4 a_5731_3134# VDD.t0 sg13_lv_pmos ad=0.3304p pd=1.71u as=0.3808p ps=2.92u w=1.12u l=0.13u
X2468 a_20831_16869# a_20593_16869# a_20723_16869# VSS.t2280 sg13_lv_nmos ad=0.1406p pd=1.12u as=0.2516p ps=2.16u w=0.74u l=0.2u
X2469 VSS.t1029 VDD.t1635 VSS.t1028 VSS.t1027 sg13_lv_nmos ad=0.1428p pd=1.52u as=0 ps=0 w=0.42u l=1u
X2470 VDD.t680 a_8563_4687# a_8997_4687# VDD.t281 sg13_lv_pmos ad=0.2128p pd=1.5u as=0.3808p ps=2.92u w=1.12u l=0.13u
X2471 VDD.t384 a_4187_2434# a_10191_8160# VDD.t275 sg13_lv_pmos ad=0.3808p pd=2.92u as=0.2128p ps=1.5u w=1.12u l=0.6u
X2472 a_26151_14652# a_25913_14024# a_26043_14024# VDD.t301 sg13_lv_pmos ad=0.2128p pd=1.5u as=0.3808p ps=2.92u w=1.12u l=0.2u
X2473 VDD.t415 a_4187_2434# a_13231_5315# VDD.t281 sg13_lv_pmos ad=0.3808p pd=2.92u as=0.2128p ps=1.5u w=1.12u l=0.6u
X2474 VSS.t1138 a_4187_1764.t140 a_21591_16869# VSS.t1594 sg13_lv_nmos ad=0.2516p pd=2.16u as=0.1406p ps=1.12u w=0.74u l=0.6u
X2475 VDD.t616 a_8997_1842# a_9465_1044# VDD.t7 sg13_lv_pmos ad=0.252p pd=1.57u as=0.3808p ps=2.92u w=1.12u l=0.13u
X2476 a_26673_16869# a_26477_16869# VDD.t931 VDD.t297 sg13_lv_pmos ad=0.3808p pd=2.92u as=0.2128p ps=1.5u w=1.12u l=0.13u
X2477 VSS.t2019 a_4187_1764.t126 a_7911_14024# VSS.t2411 sg13_lv_nmos ad=0.2516p pd=2.16u as=0.1406p ps=1.12u w=0.74u l=0.6u
X2478 VSS.t395 a_4187_1764.t68 a_26151_7532# VSS.t553 sg13_lv_nmos ad=0.2516p pd=2.16u as=0.1406p ps=1.12u w=0.74u l=0.6u
X2479 VSS.t445 a_25283_14024# a_25717_14024# VSS.t1880 sg13_lv_nmos ad=0.1406p pd=1.12u as=0.2516p ps=2.16u w=0.74u l=0.13u
X2480 a_11473_1842# a_11277_1842# VDD.t1112 VDD.t399 sg13_lv_pmos ad=0.3808p pd=2.92u as=0.2128p ps=1.5u w=1.12u l=0.13u
X2481 VDD.t135 VSS.t1003 VDD.t133 VDD.t0 sg13_lv_pmos ad=0.19p pd=1.38u as=0 ps=0 w=1u l=1u
X2482 a_2391_331# CHAN3_MUX_SEL2 a_2297_331# VSS.t1507 sg13_lv_nmos ad=0.1216p pd=1.02u as=0.2176p ps=1.96u w=0.64u l=0.13u
X2483 a_22590_13226# a_3171_13229.t3 a_24008_13226# VSS.t1828 sg13_lv_nmos ad=0.2516p pd=2.16u as=0.1406p ps=1.12u w=0.74u l=0.13u
X2484 VDD.t622 a_19963_7532# a_20397_7532# VDD.t275 sg13_lv_pmos ad=0.2128p pd=1.5u as=0.3808p ps=2.92u w=1.12u l=0.13u
X2485 a_1544_3889# CHAN2_MUX_SEL1 VSS.t1741 VSS.t646 sg13_lv_nmos ad=0.2516p pd=2.16u as=0.2516p ps=2.16u w=0.74u l=0.13u
X2486 a_16108_5979# a_3747_6001.t2 a_25630_6734# VSS.t1804 sg13_lv_nmos ad=0.2516p pd=2.16u as=0.2516p ps=2.16u w=0.74u l=0.13u
X2487 VDD.t6 VSS.t840 VDD.t5 VDD.t4 sg13_lv_pmos ad=0.34p pd=2.68u as=0 ps=0 w=1u l=1u
X2488 a_15964_12471# CHAN1_MUX_SEL4 a_5731_12471# VDD.t50 sg13_lv_pmos ad=0.3304p pd=1.71u as=0.3808p ps=2.92u w=1.12u l=0.13u
X2489 a_27433_1842# a_27237_1842# VSS.t750 VSS.t1882 sg13_lv_nmos ad=0.2516p pd=2.16u as=0.1406p ps=1.12u w=0.74u l=0.13u
X2490 VDD.t1002 a_23003_4687# a_23437_4687# VDD.t281 sg13_lv_pmos ad=0.2128p pd=1.5u as=0.3808p ps=2.92u w=1.12u l=0.13u
X2491 VSS.t42 a_2595_16074.t2 a_26471_16035# VSS.t41 sg13_lv_nmos ad=0.2516p pd=2.16u as=0.2516p ps=2.16u w=0.74u l=0.13u
X2492 VSS.t617 a_20723_14024# a_21157_14024# VSS.t1812 sg13_lv_nmos ad=0.1406p pd=1.12u as=0.2516p ps=2.16u w=0.74u l=0.13u
X2493 VSS.t185 a_4187_1764.t96 a_4871_7532# VSS.t581 sg13_lv_nmos ad=0.2516p pd=2.16u as=0.1406p ps=1.12u w=0.74u l=0.6u
X2494 a_4157_4158# CHAN2_DELAY_IN VDD.t1201 VDD.t0 sg13_lv_pmos ad=0.3808p pd=2.92u as=0.3808p ps=2.92u w=1.12u l=0.13u
X2495 a_13470_3889# a_3747_3892.t6 a_15755_3889# VSS.t1940 sg13_lv_nmos ad=0.2516p pd=2.16u as=0.1406p ps=1.12u w=0.74u l=0.13u
X2496 a_13592_11113# a_13566_11018# VDD.t271 VDD.t268 sg13_lv_pmos ad=0.34p pd=2.68u as=0.36237p ps=2.605u w=1u l=0.13u
X2497 a_2967_331# CHAN3_MUX_SEL3 a_2873_331# VSS.t1488 sg13_lv_nmos ad=0.1216p pd=1.02u as=0.2176p ps=1.96u w=0.64u l=0.13u
X2498 a_18795_3889# a_18585_3889# VDD.t530 VDD.t0 sg13_lv_pmos ad=0.2128p pd=1.5u as=0.252p ps=1.57u w=1.12u l=0.13u
X2499 a_9675_16071# a_9465_16071# VDD.t551 VDD.t4 sg13_lv_pmos ad=0.2128p pd=1.5u as=0.252p ps=1.57u w=1.12u l=0.13u
X2500 VDD.t984 a_2595_3892.t5 a_17351_3853# VDD.t0 sg13_lv_pmos ad=0.3808p pd=2.92u as=0.3808p ps=2.92u w=1.12u l=0.13u
X2501 VSS.t399 a_3449_4240# a_3747_3892.t1 VSS.t398 sg13_lv_nmos ad=0.2812p pd=2.24u as=0.1406p ps=1.12u w=0.74u l=0.13u
X2502 a_25630_3889# a_27124_3853# a_27048_3889# VDD.t0 sg13_lv_pmos ad=0.3808p pd=2.92u as=0.2128p ps=1.5u w=1.12u l=0.13u
X2503 VSS.t402 a_2595_3892.t2 a_26471_3853# VSS.t1845 sg13_lv_nmos ad=0.2516p pd=2.16u as=0.2516p ps=2.16u w=0.74u l=0.13u
X2504 a_18313_4687# a_18117_4687# VSS.t1428 VSS.t2246 sg13_lv_nmos ad=0.2516p pd=2.16u as=0.1406p ps=1.12u w=0.74u l=0.13u
X2505 a_5393_16869# a_5197_16869# VSS.t278 VSS.t1273 sg13_lv_nmos ad=0.2516p pd=2.16u as=0.1406p ps=1.12u w=0.74u l=0.13u
X2506 VDD.t494 a_2019_1047.t5 a_16484_1008# VDD.t7 sg13_lv_pmos ad=0.3808p pd=2.92u as=0.3808p ps=2.92u w=1.12u l=0.13u
X2507 a_9431_4687# a_9193_4687# a_9323_4687# VSS.t800 sg13_lv_nmos ad=0.1406p pd=1.12u as=0.2516p ps=2.16u w=0.74u l=0.2u
X2508 a_4350_3889# a_2595_3892.t9 a_5115_3889# VSS.t1830 sg13_lv_nmos ad=0.2516p pd=2.16u as=0.1406p ps=1.12u w=0.74u l=0.13u
X2509 VSS.t138 a_2019_16074.t3 a_22564_16035# VSS.t2316 sg13_lv_nmos ad=0.2516p pd=2.16u as=0.2516p ps=2.16u w=0.74u l=0.13u
X2510 a_1544_15316# CHAN0_MUX_SEL3 VDD.t1489 VDD.t4 sg13_lv_pmos ad=0.3808p pd=2.92u as=0.3808p ps=2.92u w=1.12u l=0.13u
X2511 a_7390_1044# a_2595_1047.t8 a_8155_1044# VSS.t558 sg13_lv_nmos ad=0.2516p pd=2.16u as=0.1406p ps=1.12u w=0.74u l=0.13u
X2512 CHAN2_MUX_OUT a_16851_3154# VSS.t639 VSS.t2146 sg13_lv_nmos ad=0.1406p pd=1.12u as=0.1371p ps=1.12u w=0.74u l=0.13u
X2513 a_7390_13226# a_3171_13229.t8 a_8808_13226# VSS.t1590 sg13_lv_nmos ad=0.2516p pd=2.16u as=0.1406p ps=1.12u w=0.74u l=0.13u
X2514 a_1544_5979# REF_MUX_SEL3 VDD.t675 VDD.t41 sg13_lv_pmos ad=0.3808p pd=2.92u as=0.3808p ps=2.92u w=1.12u l=0.13u
X2515 a_7390_16071# a_2019_16074.t8 a_7288_16071# VSS.t2111 sg13_lv_nmos ad=0.2516p pd=2.16u as=0.1406p ps=1.12u w=0.74u l=0.13u
X2516 a_4350_3889# a_5844_3853# a_5768_3889# VDD.t0 sg13_lv_pmos ad=0.3808p pd=2.92u as=0.2128p ps=1.5u w=1.12u l=0.13u
X2517 a_16108_3134# a_2595_3156.t2 a_19550_3889# VSS.t1494 sg13_lv_nmos ad=0.2516p pd=2.16u as=0.2516p ps=2.16u w=0.74u l=0.13u
X2518 VSS.t52 a_16597_4687# a_17065_3889# VSS.t690 sg13_lv_nmos ad=0.1665p pd=1.19u as=0.2516p ps=2.16u w=0.74u l=0.13u
X2519 a_3543_4240# CHAN2_MUX_SEL0 a_3449_4240# VSS.t2176 sg13_lv_nmos ad=0.1216p pd=1.02u as=0.2176p ps=1.96u w=0.64u l=0.13u
X2520 a_4350_13226# a_2019_13229.t9 a_4248_13226# VSS.t1557 sg13_lv_nmos ad=0.2516p pd=2.16u as=0.1406p ps=1.12u w=0.74u l=0.13u
X2521 VDD.t138 VSS.t894 VDD.t173 VDD.t50 sg13_lv_pmos ad=0.34p pd=2.68u as=0 ps=0 w=1u l=1u
X2522 VDD.t653 a_3171_1047.t9 a_5844_1008# VDD.t7 sg13_lv_pmos ad=0.3808p pd=2.92u as=0.3808p ps=2.92u w=1.12u l=0.13u
X2523 VSS.t627 a_4187_1764.t29 a_7151_1842# VSS.t626 sg13_lv_nmos ad=0.2516p pd=2.16u as=0.1406p ps=1.12u w=0.74u l=0.6u
X2524 VDD.t102 VSS.t354 VDD.t101 VDD.t4 sg13_lv_pmos ad=0.34p pd=2.68u as=0 ps=0 w=1u l=1u
X2525 VDD.t1289 a_12037_14024# a_12505_13226# VDD.t50 sg13_lv_pmos ad=0.252p pd=1.57u as=0.3808p ps=2.92u w=1.12u l=0.13u
X2526 a_23871_4687# a_23633_4687# a_23763_4687# VSS.t2053 sg13_lv_nmos ad=0.1406p pd=1.12u as=0.2516p ps=2.16u w=0.74u l=0.2u
X2527 a_16510_16071# a_18004_16035# a_17928_16071# VDD.t4 sg13_lv_pmos ad=0.3808p pd=2.92u as=0.2128p ps=1.5u w=1.12u l=0.13u
X2528 a_8433_4687# a_8237_4687# VSS.t262 VSS.t1125 sg13_lv_nmos ad=0.2516p pd=2.16u as=0.1406p ps=1.12u w=0.74u l=0.13u
X2529 a_5731_12471# a_2595_12493.t3 a_7390_13226# VSS.t584 sg13_lv_nmos ad=0.2516p pd=2.16u as=0.2516p ps=2.16u w=0.74u l=0.13u
X2530 a_12656_11554# DLL_RESETN VSS.t1204 VSS.t1203 sg13_lv_nmos ad=0.2516p pd=2.16u as=0.2516p ps=2.16u w=0.74u l=0.13u
X2531 VDD.t650 a_2595_1047.t7 a_11271_1008# VDD.t7 sg13_lv_pmos ad=0.3808p pd=2.92u as=0.3808p ps=2.92u w=1.12u l=0.13u
X2532 VSS.t115 a_18443_4687# a_18877_4687# VSS.t2079 sg13_lv_nmos ad=0.1406p pd=1.12u as=0.2516p ps=2.16u w=0.74u l=0.13u
X2533 a_15511_5315# a_15273_4687# a_15403_4687# VDD.t281 sg13_lv_pmos ad=0.2128p pd=1.5u as=0.3808p ps=2.92u w=1.12u l=0.2u
X2534 VSS.t418 a_2595_16074.t5 a_17351_16035# VSS.t417 sg13_lv_nmos ad=0.2516p pd=2.16u as=0.2516p ps=2.16u w=0.74u l=0.13u
X2535 VDD.t532 a_3171_13229.t4 a_21044_13190# VDD.t50 sg13_lv_pmos ad=0.3808p pd=2.92u as=0.3808p ps=2.92u w=1.12u l=0.13u
X2536 VSS.t2378 VSS.t2375 VSS.t2377 VSS.t2376 sg13_lv_nmos ad=0.2516p pd=2.16u as=0 ps=0 w=0.74u l=0.6u
X2537 a_1544_6734# REF_MUX_SEL1 VDD.t1437 VDD.t41 sg13_lv_pmos ad=0.3808p pd=2.92u as=0.3808p ps=2.92u w=1.12u l=0.13u
X2538 a_27671_17497# a_27433_16869# a_27563_16869# VDD.t297 sg13_lv_pmos ad=0.2128p pd=1.5u as=0.3808p ps=2.92u w=1.12u l=0.2u
X2539 VSS.t178 a_2595_13229.t6 a_14311_13190# VSS.t177 sg13_lv_nmos ad=0.2516p pd=2.16u as=0.2516p ps=2.16u w=0.74u l=0.13u
X2540 VDD.t448 a_4187_2434# a_25391_2470# VDD.t399 sg13_lv_pmos ad=0.3808p pd=2.92u as=0.2128p ps=1.5u w=1.12u l=0.6u
X2541 a_22113_4687# a_21917_4687# VSS.t1180 VSS.t1179 sg13_lv_nmos ad=0.2516p pd=2.16u as=0.1406p ps=1.12u w=0.74u l=0.13u
X2542 a_13470_6734# a_15831_6698# a_15755_6734# VDD.t41 sg13_lv_pmos ad=0.3808p pd=2.92u as=0.2128p ps=1.5u w=1.12u l=0.13u
X2543 VDD.t1100 VSS.t1075 VDD.t1098 VDD.t7 sg13_lv_pmos ad=0.19p pd=1.38u as=0 ps=0 w=1u l=1u
X2544 VSS.t135 a_3747_16074.t7 a_12791_16035# VSS.t134 sg13_lv_nmos ad=0.2516p pd=2.16u as=0.2516p ps=2.16u w=0.74u l=0.13u
X2545 VSS.t1701 a_12037_1842# a_12505_1044# VSS.t1700 sg13_lv_nmos ad=0.1665p pd=1.19u as=0.2516p ps=2.16u w=0.74u l=0.13u
X2546 VSS.t689 a_2595_15338.t2 a_20905_15546# VSS.t688 sg13_lv_nmos ad=0.2516p pd=2.16u as=0.2516p ps=2.16u w=0.74u l=0.13u
X2547 a_26673_14024# a_26477_14024# VDD.t1269 VDD.t301 sg13_lv_pmos ad=0.3808p pd=2.92u as=0.2128p ps=1.5u w=1.12u l=0.13u
X2548 a_11473_7532# a_11277_7532# VDD.t849 VDD.t275 sg13_lv_pmos ad=0.3808p pd=2.92u as=0.2128p ps=1.5u w=1.12u l=0.13u
X2549 VDD.t500 a_3747_1047.t8 a_9751_1008# VDD.t7 sg13_lv_pmos ad=0.3808p pd=2.92u as=0.3808p ps=2.92u w=1.12u l=0.13u
X2550 VDD.t1453 a_16851_3154# CHAN2_MUX_OUT VDD.t0 sg13_lv_pmos ad=0.7336p pd=3.55u as=0.2128p ps=1.5u w=1.12u l=0.13u
X2551 VSS.t271 a_4187_1764.t54 a_12471_4687# VSS.t703 sg13_lv_nmos ad=0.2516p pd=2.16u as=0.1406p ps=1.12u w=0.74u l=0.6u
X2552 VDD.t1505 a_2595_6737.t2 a_26471_6698# VDD.t41 sg13_lv_pmos ad=0.3808p pd=2.92u as=0.3808p ps=2.92u w=1.12u l=0.13u
X2553 a_4350_6734# a_5191_6698# a_5115_6734# VDD.t41 sg13_lv_pmos ad=0.3808p pd=2.92u as=0.2128p ps=1.5u w=1.12u l=0.13u
X2554 a_27433_7532# a_27237_7532# VSS.t215 VSS.t2165 sg13_lv_nmos ad=0.2516p pd=2.16u as=0.1406p ps=1.12u w=0.74u l=0.13u
X2555 VSS.t611 a_10083_16869# a_10517_16869# VSS.t2277 sg13_lv_nmos ad=0.1406p pd=1.12u as=0.2516p ps=2.16u w=0.74u l=0.13u
X2556 VDD.t1602 VSS.t869 VDD.t129 VDD.t4 sg13_lv_pmos ad=0.19p pd=1.38u as=0 ps=0 w=1u l=1u
X2557 a_7288_16071# a_6717_16869# VDD.t1175 VDD.t4 sg13_lv_pmos ad=0.2128p pd=1.5u as=0.3808p ps=2.92u w=1.12u l=0.13u
X2558 VDD.t633 a_3747_13229.t6 a_15831_13190# VDD.t50 sg13_lv_pmos ad=0.3808p pd=2.92u as=0.3808p ps=2.92u w=1.12u l=0.13u
X2559 VSS.t909 VDD.t1669 VSS.t909 VSS.t911 sg13_lv_nmos ad=0.1428p pd=1.52u as=0 ps=0 w=0.42u l=1u
X2560 a_6391_16869# a_6153_16869# a_6283_16869# VSS.t1338 sg13_lv_nmos ad=0.1406p pd=1.12u as=0.2516p ps=2.16u w=0.74u l=0.2u
X2561 VSS.t869 VDD.t1681 VSS.t869 VSS.t872 sg13_lv_nmos ad=0.1428p pd=1.52u as=0 ps=0 w=0.42u l=1u
X2562 a_2873_13577# CHAN1_MUX_SEL1 VDD.t1539 VDD.t50 sg13_lv_pmos ad=0.1596p pd=1.22u as=0.2856p ps=2.36u w=0.84u l=0.13u
X2563 VDD.t645 a_16597_7532# a_17065_6734# VDD.t41 sg13_lv_pmos ad=0.252p pd=1.57u as=0.3808p ps=2.92u w=1.12u l=0.13u
X2564 VSS.t48 a_22243_4687# a_22677_4687# VSS.t789 sg13_lv_nmos ad=0.1406p pd=1.12u as=0.2516p ps=2.16u w=0.74u l=0.13u
X2565 VDD.t609 a_3171_12493.t2 a_23945_12701# VDD.t50 sg13_lv_pmos ad=0.3808p pd=2.92u as=0.3808p ps=2.92u w=1.12u l=0.13u
X2566 a_17275_13226# a_17065_13226# VSS.t1363 VSS.t1362 sg13_lv_nmos ad=0.1406p pd=1.12u as=0.1665p ps=1.19u w=0.74u l=0.13u
X2567 VSS.t529 a_4187_1764.t159 a_7151_16869# VSS.t1600 sg13_lv_nmos ad=0.2516p pd=2.16u as=0.1406p ps=1.12u w=0.74u l=0.6u
X2568 a_1544_13226# CHAN1_MUX_SEL1 VDD.t1538 VDD.t50 sg13_lv_pmos ad=0.3808p pd=2.92u as=0.3808p ps=2.92u w=1.12u l=0.13u
X2569 VSS.t600 a_24523_16869# a_24957_16869# VSS.t1379 sg13_lv_nmos ad=0.1406p pd=1.12u as=0.2516p ps=2.16u w=0.74u l=0.13u
X2570 VDD.t1410 a_2595_16074.t3 a_23431_16035# VDD.t4 sg13_lv_pmos ad=0.3808p pd=2.92u as=0.3808p ps=2.92u w=1.12u l=0.13u
X2571 VSS.t2117 a_2019_15338.t3 a_5705_15546# VSS.t2116 sg13_lv_nmos ad=0.2516p pd=2.16u as=0.2516p ps=2.16u w=0.74u l=0.13u
X2572 a_18313_1842# a_18117_1842# VSS.t1931 VSS.t1933 sg13_lv_nmos ad=0.2516p pd=2.16u as=0.1406p ps=1.12u w=0.74u l=0.13u
X2573 VDD.t566 a_13883_4687# a_14317_4687# VDD.t281 sg13_lv_pmos ad=0.2128p pd=1.5u as=0.3808p ps=2.92u w=1.12u l=0.13u
X2574 CHAN3_MUX_OUT a_16851_309# VSS.t334 VSS.t333 sg13_lv_nmos ad=0.1406p pd=1.12u as=0.1371p ps=1.12u w=0.74u l=0.13u
X2575 a_9431_1842# a_9193_1842# a_9323_1842# VSS.t1668 sg13_lv_nmos ad=0.1406p pd=1.12u as=0.2516p ps=2.16u w=0.74u l=0.2u
X2576 a_7390_6734# a_2595_6737.t8 a_8155_6734# VSS.t716 sg13_lv_nmos ad=0.2516p pd=2.16u as=0.1406p ps=1.12u w=0.74u l=0.13u
X2577 a_7390_16071# a_8231_16035# a_8155_16071# VDD.t4 sg13_lv_pmos ad=0.3808p pd=2.92u as=0.2128p ps=1.5u w=1.12u l=0.13u
X2578 VSS.t819 VDD.t1696 VSS.t819 VSS.t823 sg13_lv_nmos ad=79.8f pd=0.8u as=0 ps=0 w=0.42u l=1u
X2579 a_27048_16071# a_26477_16869# VSS.t42 VSS.t1293 sg13_lv_nmos ad=0.1406p pd=1.12u as=0.2516p ps=2.16u w=0.74u l=0.13u
X2580 a_18795_3889# a_18585_3889# VSS.t235 VSS.t234 sg13_lv_nmos ad=0.1406p pd=1.12u as=0.1665p ps=1.19u w=0.74u l=0.13u
X2581 VSS.t21 a_6126_9506# a_5974_11413# VSS.t17 sg13_lv_nmos ad=0.68p pd=4.68u as=0.38p ps=2.38u w=2u l=1u
X2582 VSS.t1105 VDD.t1612 VSS.t1105 VSS.t1107 sg13_lv_nmos ad=79.8f pd=0.8u as=0 ps=0 w=0.42u l=1u
X2583 a_1544_3134# CHAN2_MUX_SEL3 VDD.t280 VDD.t0 sg13_lv_pmos ad=0.3808p pd=2.92u as=0.3808p ps=2.92u w=1.12u l=0.13u
X2584 VDD.t334 a_4187_2434# a_19311_17497# VDD.t297 sg13_lv_pmos ad=0.3808p pd=2.92u as=0.2128p ps=1.5u w=1.12u l=0.6u
X2585 VSS.t259 a_1544_13226# a_2391_13577# VSS.t423 sg13_lv_nmos ad=0.1331p pd=1.12u as=0.1216p ps=1.02u w=0.64u l=0.13u
X2586 VSS.t468 a_4187_1764.t93 a_7151_7532# VSS.t1808 sg13_lv_nmos ad=0.2516p pd=2.16u as=0.1406p ps=1.12u w=0.74u l=0.6u
X2587 VDD.t162 VSS.t925 VDD.t161 VDD.t50 sg13_lv_pmos ad=0.19p pd=1.38u as=0 ps=0 w=1u l=1u
X2588 VSS.t1350 a_2595_3892.t5 a_17351_3853# VSS.t1383 sg13_lv_nmos ad=0.2516p pd=2.16u as=0.2516p ps=2.16u w=0.74u l=0.13u
X2589 a_25630_3889# a_3171_3892.t2 a_27048_3889# VSS.t1392 sg13_lv_nmos ad=0.2516p pd=2.16u as=0.1406p ps=1.12u w=0.74u l=0.13u
X2590 VSS.t619 a_4187_1764.t110 a_20071_14024# VSS.t618 sg13_lv_nmos ad=0.2516p pd=2.16u as=0.1406p ps=1.12u w=0.74u l=0.6u
X2591 VDD.t656 a_2595_12493.t3 a_8745_12701# VDD.t50 sg13_lv_pmos ad=0.3808p pd=2.92u as=0.3808p ps=2.92u w=1.12u l=0.13u
X2592 VDD.t270 a_14009_11568# a_14111_11568# VDD.t268 sg13_lv_pmos ad=1.10612p pd=6.66u as=0.3864p ps=2.93u w=1.12u l=0.13u
X2593 a_23871_1842# a_23633_1842# a_23763_1842# VSS.t1858 sg13_lv_nmos ad=0.1406p pd=1.12u as=0.2516p ps=2.16u w=0.74u l=0.2u
X2594 VSS.t927 VDD.t1664 VSS.t925 VSS.t926 sg13_lv_nmos ad=0.1428p pd=1.52u as=0 ps=0 w=0.42u l=1u
X2595 VDD.t1181 a_4003_4687# a_4437_4687# VDD.t281 sg13_lv_pmos ad=0.2128p pd=1.5u as=0.3808p ps=2.92u w=1.12u l=0.13u
X2596 a_8433_1842# a_8237_1842# VSS.t75 VSS.t1199 sg13_lv_nmos ad=0.2516p pd=2.16u as=0.1406p ps=1.12u w=0.74u l=0.13u
X2597 VSS.t60 a_9323_16869# a_9757_16869# VSS.t59 sg13_lv_nmos ad=0.1406p pd=1.12u as=0.2516p ps=2.16u w=0.74u l=0.13u
X2598 VSS.t1085 VDD.t1619 VSS.t1083 VSS.t1084 sg13_lv_nmos ad=79.8f pd=0.8u as=0 ps=0 w=0.42u l=1u
X2599 VSS.t748 a_18443_1842# a_18877_1842# VSS.t1929 sg13_lv_nmos ad=0.1406p pd=1.12u as=0.2516p ps=2.16u w=0.74u l=0.13u
X2600 a_1544_289# CHAN3_MUX_SEL3 VDD.t1044 VDD.t7 sg13_lv_pmos ad=0.3808p pd=2.92u as=0.3808p ps=2.92u w=1.12u l=0.13u
X2601 a_5731_3134# a_3171_3156.t3 a_10430_3889# VSS.t77 sg13_lv_nmos ad=0.2516p pd=2.16u as=0.2516p ps=2.16u w=0.74u l=0.13u
X2602 a_26395_16071# a_26185_16071# VDD.t1188 VDD.t4 sg13_lv_pmos ad=0.2128p pd=1.5u as=0.252p ps=1.57u w=1.12u l=0.13u
X2603 VDD.t398 a_4187_2434# a_25391_8160# VDD.t275 sg13_lv_pmos ad=0.3808p pd=2.92u as=0.2128p ps=1.5u w=1.12u l=0.6u
X2604 a_27671_14652# a_27433_14024# a_27563_14024# VDD.t301 sg13_lv_pmos ad=0.2128p pd=1.5u as=0.3808p ps=2.92u w=1.12u l=0.2u
X2605 a_4350_3889# a_3171_3892.t9 a_5768_3889# VSS.t1390 sg13_lv_nmos ad=0.2516p pd=2.16u as=0.1406p ps=1.12u w=0.74u l=0.13u
X2606 a_22113_1842# a_21917_1842# VSS.t546 VSS.t1866 sg13_lv_nmos ad=0.2516p pd=2.16u as=0.1406p ps=1.12u w=0.74u l=0.13u
X2607 a_10328_1044# a_9757_1842# VSS.t159 VSS.t1704 sg13_lv_nmos ad=0.1406p pd=1.12u as=0.2516p ps=2.16u w=0.74u l=0.13u
X2608 a_22113_16869# a_21917_16869# VSS.t1138 VSS.t1137 sg13_lv_nmos ad=0.2516p pd=2.16u as=0.1406p ps=1.12u w=0.74u l=0.13u
X2609 VSS.t880 VDD.t1679 VSS.t880 VSS.t881 sg13_lv_nmos ad=79.8f pd=0.8u as=0 ps=0 w=0.42u l=1u
X2610 VSS.t360 a_12037_7532# a_12505_6734# VSS.t2184 sg13_lv_nmos ad=0.1665p pd=1.19u as=0.2516p ps=2.16u w=0.74u l=0.13u
X2611 a_26673_1842# a_26477_1842# VDD.t1277 VDD.t399 sg13_lv_pmos ad=0.3808p pd=2.92u as=0.2128p ps=1.5u w=1.12u l=0.13u
X2612 VDD.t1242 a_2019_3892.t8 a_7364_3853# VDD.t0 sg13_lv_pmos ad=0.3808p pd=2.92u as=0.3808p ps=2.92u w=1.12u l=0.13u
X2613 VDD.t785 VDD.t786 VDD.t787 VDD.t293 sg13_lv_pmos ad=0.2128p pd=1.5u as=0 ps=0 w=1.12u l=0.13u
X2614 VSS.t1085 VDD.t1618 VSS.t1085 VSS.t1086 sg13_lv_nmos ad=0.1428p pd=1.52u as=0 ps=0 w=0.42u l=1u
X2615 a_22590_1044# a_2019_1047.t3 a_22488_1044# VSS.t154 sg13_lv_nmos ad=0.2516p pd=2.16u as=0.1406p ps=1.12u w=0.74u l=0.13u
X2616 a_26151_4687# a_25913_4687# a_26043_4687# VSS.t1423 sg13_lv_nmos ad=0.1406p pd=1.12u as=0.2516p ps=2.16u w=0.74u l=0.2u
X2617 a_23633_16869# a_23437_16869# VDD.t930 VDD.t297 sg13_lv_pmos ad=0.3808p pd=2.92u as=0.2128p ps=1.5u w=1.12u l=0.13u
X2618 a_22590_16071# a_3171_16074.t3 a_24008_16071# VSS.t1581 sg13_lv_nmos ad=0.2516p pd=2.16u as=0.1406p ps=1.12u w=0.74u l=0.13u
X2619 VSS.t550 a_4187_1764.t130 a_4871_14024# VSS.t549 sg13_lv_nmos ad=0.2516p pd=2.16u as=0.1406p ps=1.12u w=0.74u l=0.6u
X2620 VSS.t1236 a_22243_14024# a_22677_14024# VSS.t1235 sg13_lv_nmos ad=0.1406p pd=1.12u as=0.2516p ps=2.16u w=0.74u l=0.13u
X2621 a_6126_9506# a_6326_10280# VDD.t1132 VDD.t268 sg13_lv_pmos ad=0.38p pd=2.38u as=0.38p ps=2.38u w=2u l=1u
X2622 VSS.t1573 a_4187_1764.t22 a_12471_1842# VSS.t1572 sg13_lv_nmos ad=0.2516p pd=2.16u as=0.1406p ps=1.12u w=0.74u l=0.6u
X2623 VDD.t629 a_16923_16869# a_17357_16869# VDD.t297 sg13_lv_pmos ad=0.2128p pd=1.5u as=0.3808p ps=2.92u w=1.12u l=0.13u
X2624 a_15964_15316# CHAN0_MUX_SEL4 a_5731_15316# VDD.t4 sg13_lv_pmos ad=0.3304p pd=1.71u as=0.3808p ps=2.92u w=1.12u l=0.13u
X2625 a_19550_13226# a_3171_13229.t4 a_20968_13226# VSS.t239 sg13_lv_nmos ad=0.2516p pd=2.16u as=0.1406p ps=1.12u w=0.74u l=0.13u
X2626 VSS.t988 a_3171_6001.t2 a_23945_6209# VSS.t1787 sg13_lv_nmos ad=0.2516p pd=2.16u as=0.2516p ps=2.16u w=0.74u l=0.13u
X2627 VDD.t149 VSS.t830 VDD.t148 VDD.t4 sg13_lv_pmos ad=0.34p pd=2.68u as=0 ps=0 w=1u l=1u
X2628 a_8808_1044# a_8237_1842# VSS.t560 VSS.t1198 sg13_lv_nmos ad=0.1406p pd=1.12u as=0.2516p ps=2.16u w=0.74u l=0.13u
X2629 a_13753_4687# a_13557_4687# VSS.t438 VSS.t437 sg13_lv_nmos ad=0.2516p pd=2.16u as=0.1406p ps=1.12u w=0.74u l=0.13u
X2630 a_13592_11561# a_13566_11525# VSS.t4 VSS.t342 sg13_lv_nmos ad=0.2516p pd=2.16u as=0.1626p ps=1.415u w=0.74u l=0.13u
X2631 a_5778_9057# a_6126_9506# a_6326_10280# VSS.t14 sg13_lv_nmos ad=0.68p pd=4.68u as=0.38p ps=2.38u w=2u l=1u
X2632 a_18795_6734# a_18585_6734# VDD.t1510 VDD.t41 sg13_lv_pmos ad=0.2128p pd=1.5u as=0.252p ps=1.57u w=1.12u l=0.13u
X2633 a_4871_4687# a_4633_4687# a_4763_4687# VSS.t392 sg13_lv_nmos ad=0.1406p pd=1.12u as=0.2516p ps=2.16u w=0.74u l=0.2u
X2634 VSS.t544 a_22243_1842# a_22677_1842# VSS.t1922 sg13_lv_nmos ad=0.1406p pd=1.12u as=0.2516p ps=2.16u w=0.74u l=0.13u
X2635 a_6913_16869# a_6717_16869# VSS.t298 VSS.t1737 sg13_lv_nmos ad=0.2516p pd=2.16u as=0.1406p ps=1.12u w=0.74u l=0.13u
X2636 a_15270_11995# a_12849_11557# VSS.t9 VSS.t8 sg13_lv_nmos ad=37.8f pd=0.6u as=79.8f ps=0.8u w=0.42u l=0.13u
X2637 VDD.t708 a_2595_6737.t5 a_17351_6698# VDD.t41 sg13_lv_pmos ad=0.3808p pd=2.92u as=0.3808p ps=2.92u w=1.12u l=0.13u
X2638 a_6635_16071# a_6425_16071# VDD.t538 VDD.t4 sg13_lv_pmos ad=0.2128p pd=1.5u as=0.252p ps=1.57u w=1.12u l=0.13u
X2639 a_25630_6734# a_27124_6698# a_27048_6734# VDD.t41 sg13_lv_pmos ad=0.3808p pd=2.92u as=0.2128p ps=1.5u w=1.12u l=0.13u
X2640 a_18313_7532# a_18117_7532# VSS.t217 VSS.t2270 sg13_lv_nmos ad=0.2516p pd=2.16u as=0.1406p ps=1.12u w=0.74u l=0.13u
X2641 a_9431_7532# a_9193_7532# a_9323_7532# VSS.t1425 sg13_lv_nmos ad=0.1406p pd=1.12u as=0.2516p ps=2.16u w=0.74u l=0.2u
X2642 VDD.t400 a_4187_2434# a_6391_2470# VDD.t399 sg13_lv_pmos ad=0.3808p pd=2.92u as=0.2128p ps=1.5u w=1.12u l=0.6u
X2643 a_1544_1044# CHAN3_MUX_SEL1 VDD.t1424 VDD.t7 sg13_lv_pmos ad=0.3808p pd=2.92u as=0.3808p ps=2.92u w=1.12u l=0.13u
X2644 a_7390_16071# a_3171_16074.t8 a_8808_16071# VSS.t1574 sg13_lv_nmos ad=0.2516p pd=2.16u as=0.1406p ps=1.12u w=0.74u l=0.13u
X2645 VDD.t943 a_2595_13229.t2 a_26471_13190# VDD.t50 sg13_lv_pmos ad=0.3808p pd=2.92u as=0.3808p ps=2.92u w=1.12u l=0.13u
X2646 a_13470_1044# a_15831_1008# a_15755_1044# VDD.t7 sg13_lv_pmos ad=0.3808p pd=2.92u as=0.2128p ps=1.5u w=1.12u l=0.13u
X2647 a_22488_3889# a_21917_4687# VDD.t856 VDD.t0 sg13_lv_pmos ad=0.2128p pd=1.5u as=0.3808p ps=2.92u w=1.12u l=0.13u
X2648 a_10520_11982# a_10232_11561# a_10458_11982# VSS.t274 sg13_lv_nmos ad=0.1428p pd=1.52u as=37.8f ps=0.6u w=0.42u l=0.13u
X2649 a_16108_3134# CHAN2_MUX_SEL4 a_15964_3134# VSS.t637 sg13_lv_nmos ad=0.2516p pd=2.16u as=0.2183p ps=1.33u w=0.74u l=0.13u
X2650 a_4350_13226# a_3171_13229.t9 a_5768_13226# VSS.t100 sg13_lv_nmos ad=0.2516p pd=2.16u as=0.1406p ps=1.12u w=0.74u l=0.13u
X2651 VSS.t2103 a_2873_12513# a_3171_12493.t1 VSS.t2104 sg13_lv_nmos ad=0.2812p pd=2.24u as=0.1406p ps=1.12u w=0.74u l=0.13u
X2652 a_4350_6734# a_5844_6698# a_5768_6734# VDD.t41 sg13_lv_pmos ad=0.3808p pd=2.92u as=0.2128p ps=1.5u w=1.12u l=0.13u
X2653 a_4350_16071# a_2019_16074.t9 a_4248_16071# VSS.t592 sg13_lv_nmos ad=0.2516p pd=2.16u as=0.1406p ps=1.12u w=0.74u l=0.13u
X2654 VDD.t362 a_4187_2434# a_19311_14652# VDD.t301 sg13_lv_pmos ad=0.3808p pd=2.92u as=0.2128p ps=1.5u w=1.12u l=0.6u
X2655 a_10951_5315# a_10713_4687# a_10843_4687# VDD.t281 sg13_lv_pmos ad=0.2128p pd=1.5u as=0.3808p ps=2.92u w=1.12u l=0.2u
X2656 a_19550_16071# a_19524_16035# a_19448_16071# VDD.t4 sg13_lv_pmos ad=0.3808p pd=2.92u as=0.2128p ps=1.5u w=1.12u l=0.13u
X2657 VSS.t183 a_24523_4687# a_24957_4687# VSS.t182 sg13_lv_nmos ad=0.1406p pd=1.12u as=0.2516p ps=2.16u w=0.74u l=0.13u
X2658 a_23871_7532# a_23633_7532# a_23763_7532# VSS.t432 sg13_lv_nmos ad=0.1406p pd=1.12u as=0.2516p ps=2.16u w=0.74u l=0.2u
X2659 VDD.t452 a_4187_2434# a_20831_2470# VDD.t399 sg13_lv_pmos ad=0.3808p pd=2.92u as=0.2128p ps=1.5u w=1.12u l=0.6u
X2660 a_14513_16869# a_14317_16869# VDD.t975 VDD.t297 sg13_lv_pmos ad=0.3808p pd=2.92u as=0.2128p ps=1.5u w=1.12u l=0.13u
X2661 a_8433_7532# a_8237_7532# VSS.t812 VSS.t811 sg13_lv_nmos ad=0.2516p pd=2.16u as=0.1406p ps=1.12u w=0.74u l=0.13u
X2662 VDD.t964 a_2595_1047.t2 a_26471_1008# VDD.t7 sg13_lv_pmos ad=0.3808p pd=2.92u as=0.3808p ps=2.92u w=1.12u l=0.13u
X2663 a_4350_1044# a_5191_1008# a_5115_1044# VDD.t7 sg13_lv_pmos ad=0.3808p pd=2.92u as=0.2128p ps=1.5u w=1.12u l=0.13u
X2664 VDD.t918 a_2019_13229.t3 a_22564_13190# VDD.t50 sg13_lv_pmos ad=0.3808p pd=2.92u as=0.3808p ps=2.92u w=1.12u l=0.13u
X2665 a_23111_16869# a_22873_16869# a_23003_16869# VSS.t327 sg13_lv_nmos ad=0.1406p pd=1.12u as=0.2516p ps=2.16u w=0.74u l=0.2u
X2666 VSS.t223 a_18443_7532# a_18877_7532# VSS.t222 sg13_lv_nmos ad=0.1406p pd=1.12u as=0.2516p ps=2.16u w=0.74u l=0.13u
X2667 VSS.t1044 VDD.t1631 VSS.t1042 VSS.t1043 sg13_lv_nmos ad=0.1428p pd=1.52u as=0 ps=0 w=0.42u l=1u
X2668 a_9431_14024# a_9193_14024# a_9323_14024# VSS.t2016 sg13_lv_nmos ad=0.1406p pd=1.12u as=0.2516p ps=2.16u w=0.74u l=0.2u
X2669 a_5731_12471# a_2019_12493.t3 a_4350_13226# VSS.t2217 sg13_lv_nmos ad=0.2516p pd=2.16u as=0.2516p ps=2.16u w=0.74u l=0.13u
X2670 VSS.t19 a_6126_9506# a_5974_11413# VSS.t17 sg13_lv_nmos ad=0.68p pd=4.68u as=0.38p ps=2.38u w=2u l=1u
X2671 VSS.t1036 VDD.t1633 VSS.t1036 VSS.t1037 sg13_lv_nmos ad=79.8f pd=0.8u as=0 ps=0 w=0.42u l=1u
X2672 REF_MUX_OUT a_16851_5999# VDD.t731 VDD.t41 sg13_lv_pmos ad=0.2128p pd=1.5u as=0.2086p ps=1.5u w=1.12u l=0.13u
X2673 a_1256_5979# REF_MUX_SEL2 VSS.t647 VSS.t783 sg13_lv_nmos ad=0.2516p pd=2.16u as=0.2516p ps=2.16u w=0.74u l=0.13u
X2674 VSS.t1373 a_2595_16074.t6 a_14311_16035# VSS.t1604 sg13_lv_nmos ad=0.2516p pd=2.16u as=0.2516p ps=2.16u w=0.74u l=0.13u
X2675 VSS.t960 VDD.t1655 VSS.t959 VSS.t958 sg13_lv_nmos ad=0.1428p pd=1.52u as=0 ps=0 w=0.42u l=1u
X2676 VSS.t259 a_1256_13226# a_2967_13577# VSS.t1897 sg13_lv_nmos ad=0.1331p pd=1.12u as=0.1216p ps=1.02u w=0.64u l=0.13u
X2677 a_7390_13226# a_7364_13190# a_7288_13226# VDD.t50 sg13_lv_pmos ad=0.3808p pd=2.92u as=0.2128p ps=1.5u w=1.12u l=0.13u
X2678 a_22113_7532# a_21917_7532# VSS.t313 VSS.t312 sg13_lv_nmos ad=0.2516p pd=2.16u as=0.1406p ps=1.12u w=0.74u l=0.13u
X2679 VSS.t1231 a_27237_1842# a_27705_1044# VSS.t1883 sg13_lv_nmos ad=0.1665p pd=1.19u as=0.2516p ps=2.16u w=0.74u l=0.13u
X2680 VDD.t1114 a_16597_1842# a_17065_1044# VDD.t7 sg13_lv_pmos ad=0.252p pd=1.57u as=0.3808p ps=2.92u w=1.12u l=0.13u
X2681 VSS.t238 a_2595_13229.t7 a_11271_13190# VSS.t1640 sg13_lv_nmos ad=0.2516p pd=2.16u as=0.2516p ps=2.16u w=0.74u l=0.13u
X2682 a_10328_6734# a_9757_7532# VSS.t97 VSS.t96 sg13_lv_nmos ad=0.1406p pd=1.12u as=0.2516p ps=2.16u w=0.74u l=0.13u
X2683 VSS.t79 a_3171_3156.t3 a_11785_3364# VSS.t78 sg13_lv_nmos ad=0.2516p pd=2.16u as=0.2516p ps=2.16u w=0.74u l=0.13u
X2684 a_2595_1047.t1 a_2297_1395# VSS.t256 VSS.t1158 sg13_lv_nmos ad=0.1406p pd=1.12u as=0.1331p ps=1.12u w=0.74u l=0.13u
X2685 VSS.t1251 a_27563_14024# a_27997_14024# VSS.t1250 sg13_lv_nmos ad=0.1406p pd=1.12u as=0.2516p ps=2.16u w=0.74u l=0.13u
X2686 a_26673_7532# a_26477_7532# VDD.t593 VDD.t275 sg13_lv_pmos ad=0.3808p pd=2.92u as=0.2128p ps=1.5u w=1.12u l=0.13u
X2687 a_10191_2470# a_9953_1842# a_10083_1842# VDD.t399 sg13_lv_pmos ad=0.2128p pd=1.5u as=0.3808p ps=2.92u w=1.12u l=0.2u
X2688 VSS.t1628 a_4187_1764.t34 a_27671_4687# VSS.t1627 sg13_lv_nmos ad=0.2516p pd=2.16u as=0.1406p ps=1.12u w=0.74u l=0.6u
X2689 VDD.t1306 CHAN0_MUX_SEL3 a_3449_15358# VDD.t4 sg13_lv_pmos ad=0.1918p pd=1.5u as=0.1596p ps=1.22u w=0.84u l=0.13u
X2690 VSS.t779 a_2019_311.t2 a_17865_519# VSS.t778 sg13_lv_nmos ad=0.2516p pd=2.16u as=0.2516p ps=2.16u w=0.74u l=0.13u
X2691 a_22590_6734# a_2019_6737.t3 a_22488_6734# VSS.t2215 sg13_lv_nmos ad=0.2516p pd=2.16u as=0.1406p ps=1.12u w=0.74u l=0.13u
X2692 a_26151_1842# a_25913_1842# a_26043_1842# VSS.t1921 sg13_lv_nmos ad=0.1406p pd=1.12u as=0.2516p ps=2.16u w=0.74u l=0.2u
X2693 a_23633_14024# a_23437_14024# VDD.t950 VDD.t301 sg13_lv_pmos ad=0.3808p pd=2.92u as=0.2128p ps=1.5u w=1.12u l=0.13u
X2694 VSS.t2014 a_1544_289# a_2391_331# VSS.t2032 sg13_lv_nmos ad=0.1331p pd=1.12u as=0.1216p ps=1.02u w=0.64u l=0.13u
X2695 VSS.t621 a_4187_1764.t86 a_12471_7532# VSS.t620 sg13_lv_nmos ad=0.2516p pd=2.16u as=0.1406p ps=1.12u w=0.74u l=0.6u
X2696 a_8808_16071# a_8237_16869# VDD.t832 VDD.t4 sg13_lv_pmos ad=0.2128p pd=1.5u as=0.3808p ps=2.92u w=1.12u l=0.13u
X2697 VDD.t1389 a_16923_14024# a_17357_14024# VDD.t301 sg13_lv_pmos ad=0.2128p pd=1.5u as=0.3808p ps=2.92u w=1.12u l=0.13u
X2698 VDD.t1089 a_2595_13229.t5 a_17351_13190# VDD.t50 sg13_lv_pmos ad=0.3808p pd=2.92u as=0.3808p ps=2.92u w=1.12u l=0.13u
X2699 a_6326_10280# a_6126_9506# a_5778_9057# VSS.t14 sg13_lv_nmos ad=0.42p pd=2.42u as=0.68p ps=4.68u w=2u l=1u
X2700 VDD.t421 a_4187_2434# a_19311_5315# VDD.t281 sg13_lv_pmos ad=0.3808p pd=2.92u as=0.2128p ps=1.5u w=1.12u l=0.6u
X2701 a_7911_16869# a_7673_16869# a_7803_16869# VSS.t1274 sg13_lv_nmos ad=0.1406p pd=1.12u as=0.2516p ps=2.16u w=0.74u l=0.2u
X2702 a_8808_6734# a_8237_7532# VSS.t718 VSS.t810 sg13_lv_nmos ad=0.1406p pd=1.12u as=0.2516p ps=2.16u w=0.74u l=0.13u
X2703 VDD.t514 a_3449_6021# a_3747_6001.t0 VDD.t41 sg13_lv_pmos ad=0.4256p pd=3u as=0.2128p ps=1.5u w=1.12u l=0.13u
X2704 VDD.t105 VSS.t859 VDD.t104 VDD.t4 sg13_lv_pmos ad=0.19p pd=1.38u as=0 ps=0 w=1u l=1u
X2705 a_18795_13226# a_18585_13226# VSS.t1510 VSS.t1509 sg13_lv_nmos ad=0.1406p pd=1.12u as=0.1665p ps=1.19u w=0.74u l=0.13u
X2706 a_13753_1842# a_13557_1842# VSS.t1148 VSS.t1802 sg13_lv_nmos ad=0.2516p pd=2.16u as=0.1406p ps=1.12u w=0.74u l=0.13u
X2707 a_4248_16071# a_4157_16340# VDD.t1110 VDD.t4 sg13_lv_pmos ad=0.2128p pd=1.5u as=0.3808p ps=2.92u w=1.12u l=0.13u
X2708 VDD.t995 a_3747_13229.t7 a_12791_13190# VDD.t50 sg13_lv_pmos ad=0.3808p pd=2.92u as=0.3808p ps=2.92u w=1.12u l=0.13u
X2709 VSS.t175 a_22243_7532# a_22677_7532# VSS.t2264 sg13_lv_nmos ad=0.1406p pd=1.12u as=0.2516p ps=2.16u w=0.74u l=0.13u
X2710 a_1815_1395# a_1256_1044# a_1721_1395# VSS.t701 sg13_lv_nmos ad=0.1216p pd=1.02u as=0.2176p ps=1.96u w=0.64u l=0.13u
X2711 a_4871_1842# a_4633_1842# a_4763_1842# VSS.t2285 sg13_lv_nmos ad=0.1406p pd=1.12u as=0.2516p ps=2.16u w=0.74u l=0.2u
X2712 VSS.t302 a_4187_1764.t157 a_8671_16869# VSS.t1436 sg13_lv_nmos ad=0.2516p pd=2.16u as=0.1406p ps=1.12u w=0.74u l=0.6u
X2713 VSS.t1292 a_26043_16869# a_26477_16869# VSS.t1291 sg13_lv_nmos ad=0.1406p pd=1.12u as=0.2516p ps=2.16u w=0.74u l=0.13u
X2714 VDD.t623 a_3171_15338.t2 a_23945_15546# VDD.t4 sg13_lv_pmos ad=0.3808p pd=2.92u as=0.3808p ps=2.92u w=1.12u l=0.13u
X2715 a_17275_16071# a_17065_16071# VSS.t1282 VSS.t1854 sg13_lv_nmos ad=0.1406p pd=1.12u as=0.1665p ps=1.19u w=0.74u l=0.13u
X2716 VSS.t798 a_2019_3892.t8 a_7364_3853# VSS.t1851 sg13_lv_nmos ad=0.2516p pd=2.16u as=0.2516p ps=2.16u w=0.74u l=0.13u
X2717 VDD.t657 a_2595_12493.t2 a_20905_12701# VDD.t50 sg13_lv_pmos ad=0.3808p pd=2.92u as=0.3808p ps=2.92u w=1.12u l=0.13u
X2718 a_14235_13226# a_14025_13226# VSS.t1917 VSS.t1916 sg13_lv_nmos ad=0.1406p pd=1.12u as=0.1665p ps=1.19u w=0.74u l=0.13u
X2719 a_2391_3176# CHAN2_MUX_SEL2 a_2297_3176# VSS.t2009 sg13_lv_nmos ad=0.1216p pd=1.02u as=0.2176p ps=1.96u w=0.64u l=0.13u
X2720 a_7390_16071# a_9751_16035# a_9675_16071# VDD.t4 sg13_lv_pmos ad=0.3808p pd=2.92u as=0.2128p ps=1.5u w=1.12u l=0.13u
X2721 VDD.t382 a_4187_2434# a_6391_8160# VDD.t275 sg13_lv_pmos ad=0.3808p pd=2.92u as=0.2128p ps=1.5u w=1.12u l=0.6u
X2722 VDD.t1048 a_2595_16074.t4 a_20391_16035# VDD.t4 sg13_lv_pmos ad=0.3808p pd=2.92u as=0.3808p ps=2.92u w=1.12u l=0.13u
X2723 a_13470_3889# a_13444_3853# a_13368_3889# VDD.t0 sg13_lv_pmos ad=0.3808p pd=2.92u as=0.2128p ps=1.5u w=1.12u l=0.13u
X2724 VSS.t2019 a_7803_14024# a_8237_14024# VSS.t2039 sg13_lv_nmos ad=0.1406p pd=1.12u as=0.2516p ps=2.16u w=0.74u l=0.13u
X2725 a_2019_13229.t1 a_1721_13577# VSS.t259 VSS.t1908 sg13_lv_nmos ad=0.1406p pd=1.12u as=0.1331p ps=1.12u w=0.74u l=0.13u
X2726 VSS.t1144 a_1544_3134# a_1815_3176# VSS.t257 sg13_lv_nmos ad=0.1331p pd=1.12u as=0.1216p ps=1.02u w=0.64u l=0.13u
X2727 VDD.t413 a_4187_2434# a_9431_5315# VDD.t281 sg13_lv_pmos ad=0.3808p pd=2.92u as=0.2128p ps=1.5u w=1.12u l=0.6u
X2728 a_20831_14024# a_20593_14024# a_20723_14024# VSS.t1868 sg13_lv_nmos ad=0.1406p pd=1.12u as=0.2516p ps=2.16u w=0.74u l=0.2u
X2729 a_25528_13226# a_24957_14024# VSS.t508 VSS.t1246 sg13_lv_nmos ad=0.1406p pd=1.12u as=0.2516p ps=2.16u w=0.74u l=0.13u
X2730 VSS.t987 VDD.t1647 VSS.t990 VSS.t989 sg13_lv_nmos ad=79.8f pd=0.8u as=0 ps=0 w=0.42u l=1u
X2731 a_15511_17497# a_15273_16869# a_15403_16869# VDD.t297 sg13_lv_pmos ad=0.2128p pd=1.5u as=0.3808p ps=2.92u w=1.12u l=0.2u
X2732 a_10040_11995# a_9772_11533# a_9946_11995# VSS.t1476 sg13_lv_nmos ad=60.89999f pd=0.71u as=0.1428p ps=1.52u w=0.42u l=0.13u
X2733 a_1721_331# a_1256_289# VDD.t1385 VDD.t7 sg13_lv_pmos ad=0.1596p pd=1.22u as=0.2856p ps=2.36u w=0.84u l=0.13u
X2734 a_7673_1842# a_7477_1842# VDD.t840 VDD.t399 sg13_lv_pmos ad=0.3808p pd=2.92u as=0.2128p ps=1.5u w=1.12u l=0.13u
X2735 a_12849_11557# a_12656_11554# VSS.t4 VSS.t682 sg13_lv_nmos ad=0.1406p pd=1.12u as=0.2516p ps=2.16u w=0.74u l=0.13u
X2736 a_15053_11110# a_14111_10917# a_14851_10872# VDD.t268 sg13_lv_pmos ad=93.45f pd=0.865u as=0.2048p ps=1.63u w=0.42u l=0.13u
X2737 VSS.t251 a_1544_16071# a_2391_16422# VSS.t1756 sg13_lv_nmos ad=0.1331p pd=1.12u as=0.1216p ps=1.02u w=0.64u l=0.13u
X2738 CHAN0_MUX_OUT a_16851_15336# VSS.t1972 VSS.t1980 sg13_lv_nmos ad=0.1406p pd=1.12u as=0.1371p ps=1.12u w=0.74u l=0.13u
X2739 a_16033_4687# a_15837_4687# VSS.t436 VSS.t435 sg13_lv_nmos ad=0.2516p pd=2.16u as=0.1406p ps=1.12u w=0.74u l=0.13u
X2740 VSS.t1811 a_4187_1764.t108 a_21591_14024# VSS.t2220 sg13_lv_nmos ad=0.2516p pd=2.16u as=0.1406p ps=1.12u w=0.74u l=0.6u
X2741 VDD.t770 a_6326_10280# a_6854_11144# VDD.t268 sg13_lv_pmos ad=0.38p pd=2.38u as=0.38p ps=2.38u w=2u l=1u
X2742 VDD.t254 VSS.t779 VDD.t981 VDD.t7 sg13_lv_pmos ad=0.34p pd=2.68u as=0 ps=0 w=1u l=1u
X2743 a_7151_4687# a_6913_4687# a_7043_4687# VSS.t89 sg13_lv_nmos ad=0.1406p pd=1.12u as=0.2516p ps=2.16u w=0.74u l=0.2u
X2744 VDD.t423 a_4187_2434# a_23111_5315# VDD.t281 sg13_lv_pmos ad=0.3808p pd=2.92u as=0.2128p ps=1.5u w=1.12u l=0.6u
X2745 VDD.t329 a_4187_2434# a_16271_17497# VDD.t297 sg13_lv_pmos ad=0.3808p pd=2.92u as=0.2128p ps=1.5u w=1.12u l=0.6u
X2746 a_6635_1044# a_6425_1044# VSS.t669 VSS.t668 sg13_lv_nmos ad=0.1406p pd=1.12u as=0.1665p ps=1.19u w=0.74u l=0.13u
X2747 VDD.t1094 a_3171_3892.t3 a_24084_3853# VDD.t0 sg13_lv_pmos ad=0.3808p pd=2.92u as=0.3808p ps=2.92u w=1.12u l=0.13u
X2748 VDD.t698 a_2595_15338.t3 a_8745_15546# VDD.t4 sg13_lv_pmos ad=0.3808p pd=2.92u as=0.3808p ps=2.92u w=1.12u l=0.13u
X2749 VDD.t392 a_4187_2434# a_20831_8160# VDD.t275 sg13_lv_pmos ad=0.3808p pd=2.92u as=0.2128p ps=1.5u w=1.12u l=0.6u
X2750 VSS.t1606 a_24523_1842# a_24957_1842# VSS.t1900 sg13_lv_nmos ad=0.1406p pd=1.12u as=0.2516p ps=2.16u w=0.74u l=0.13u
X2751 VDD.t1594 VSS.t916 VDD.t52 VDD.t50 sg13_lv_pmos ad=0.19p pd=1.38u as=0 ps=0 w=1u l=1u
X2752 a_14513_14024# a_14317_14024# VDD.t1381 VDD.t301 sg13_lv_pmos ad=0.3808p pd=2.92u as=0.2128p ps=1.5u w=1.12u l=0.13u
X2753 VDD.t1509 a_2019_12493.t3 a_5705_12701# VDD.t50 sg13_lv_pmos ad=0.3808p pd=2.92u as=0.3808p ps=2.92u w=1.12u l=0.13u
X2754 VSS.t150 a_2595_1047.t9 a_5191_1008# VSS.t149 sg13_lv_nmos ad=0.2516p pd=2.16u as=0.2516p ps=2.16u w=0.74u l=0.13u
X2755 a_16108_3134# a_3747_3156.t2 a_25630_3889# VSS.t2281 sg13_lv_nmos ad=0.2516p pd=2.16u as=0.2516p ps=2.16u w=0.74u l=0.13u
X2756 VDD.t61 VSS.t960 VDD.t1585 VDD.t41 sg13_lv_pmos ad=0.34p pd=2.68u as=0 ps=0 w=1u l=1u
X2757 a_27915_16071# a_27705_16071# VDD.t460 VDD.t4 sg13_lv_pmos ad=0.2128p pd=1.5u as=0.252p ps=1.57u w=1.12u l=0.13u
X2758 a_10589_11604# a_10232_11561# VDD.t545 VDD.t268 sg13_lv_pmos ad=63f pd=0.72u as=0.1563p ps=1.22u w=0.42u l=0.13u
X2759 a_20315_1044# a_20105_1044# VSS.t1740 VSS.t1739 sg13_lv_nmos ad=0.1406p pd=1.12u as=0.1665p ps=1.19u w=0.74u l=0.13u
X2760 a_22488_3889# a_21917_4687# VSS.t1182 VSS.t1181 sg13_lv_nmos ad=0.1406p pd=1.12u as=0.2516p ps=2.16u w=0.74u l=0.13u
X2761 a_27048_13226# a_26477_14024# VDD.t1270 VDD.t50 sg13_lv_pmos ad=0.2128p pd=1.5u as=0.3808p ps=2.92u w=1.12u l=0.13u
X2762 a_25528_1044# a_24957_1842# VSS.t1621 VSS.t1907 sg13_lv_nmos ad=0.1406p pd=1.12u as=0.2516p ps=2.16u w=0.74u l=0.13u
X2763 a_18795_1044# a_18585_1044# VDD.t555 VDD.t7 sg13_lv_pmos ad=0.2128p pd=1.5u as=0.252p ps=1.57u w=1.12u l=0.13u
X2764 VDD.t780 VDD.t778 VDD.t779 VDD.t293 sg13_lv_pmos ad=0.3808p pd=2.92u as=0 ps=0 w=1.12u l=0.13u
X2765 VSS.t521 a_27237_7532# a_27705_6734# VSS.t2164 sg13_lv_nmos ad=0.1665p pd=1.19u as=0.2516p ps=2.16u w=0.74u l=0.13u
X2766 VDD.t754 VDD.t752 VDD.t751 VDD.t297 sg13_lv_pmos ad=0.2128p pd=1.5u as=0 ps=0 w=1.12u l=0.2u
X2767 a_23355_16071# a_23145_16071# VDD.t1122 VDD.t4 sg13_lv_pmos ad=0.2128p pd=1.5u as=0.252p ps=1.57u w=1.12u l=0.13u
X2768 VSS.t1528 a_4187_1764.t98 VSS.t1530 VSS.t1529 sg13_lv_nmos ad=1.33p pd=7.38u as=0 ps=0 w=7u l=7u
X2769 a_2595_6737.t1 a_2297_7085# VSS.t232 VSS.t1252 sg13_lv_nmos ad=0.1406p pd=1.12u as=0.1331p ps=1.12u w=0.74u l=0.13u
X2770 VDD.t440 a_4187_2434# a_11711_2470# VDD.t399 sg13_lv_pmos ad=0.3808p pd=2.92u as=0.2128p ps=1.5u w=1.12u l=0.6u
X2771 a_16108_5979# a_20905_6209# a_19550_6734# VDD.t41 sg13_lv_pmos ad=0.3808p pd=2.92u as=0.3808p ps=2.92u w=1.12u l=0.13u
X2772 VSS.t944 VDD.t1659 VSS.t943 VSS.t942 sg13_lv_nmos ad=0.1428p pd=1.52u as=0 ps=0 w=0.42u l=1u
X2773 a_10191_8160# a_9953_7532# a_10083_7532# VDD.t275 sg13_lv_pmos ad=0.2128p pd=1.5u as=0.3808p ps=2.92u w=1.12u l=0.2u
X2774 VDD.t648 a_2595_1047.t5 a_17351_1008# VDD.t7 sg13_lv_pmos ad=0.3808p pd=2.92u as=0.3808p ps=2.92u w=1.12u l=0.13u
X2775 a_25630_1044# a_27124_1008# a_27048_1044# VDD.t7 sg13_lv_pmos ad=0.3808p pd=2.92u as=0.2128p ps=1.5u w=1.12u l=0.13u
X2776 VDD.t478 a_2019_6737.t8 a_7364_6698# VDD.t41 sg13_lv_pmos ad=0.3808p pd=2.92u as=0.3808p ps=2.92u w=1.12u l=0.13u
X2777 a_5731_289# a_3747_311.t3 a_13470_1044# VSS.t2162 sg13_lv_nmos ad=0.2516p pd=2.16u as=0.2516p ps=2.16u w=0.74u l=0.13u
X2778 a_5393_14024# a_5197_14024# VSS.t550 VSS.t1997 sg13_lv_nmos ad=0.2516p pd=2.16u as=0.1406p ps=1.12u w=0.74u l=0.13u
X2779 VSS.t2139 a_4187_1764.t2 a_27671_1842# VSS.t2138 sg13_lv_nmos ad=0.2516p pd=2.16u as=0.1406p ps=1.12u w=0.74u l=0.6u
X2780 VDD.t614 a_18443_16869# a_18877_16869# VDD.t297 sg13_lv_pmos ad=0.2128p pd=1.5u as=0.3808p ps=2.92u w=1.12u l=0.13u
X2781 VDD.t483 CHAN1_MUX_SEL3 a_3449_12513# VDD.t50 sg13_lv_pmos ad=0.1918p pd=1.5u as=0.1596p ps=1.22u w=0.84u l=0.13u
X2782 a_26151_7532# a_25913_7532# a_26043_7532# VSS.t2128 sg13_lv_nmos ad=0.1406p pd=1.12u as=0.2516p ps=2.16u w=0.74u l=0.2u
X2783 VSS.t1016 VDD.t1639 VSS.t1016 VSS.t1017 sg13_lv_nmos ad=79.8f pd=0.8u as=0 ps=0 w=0.42u l=1u
X2784 a_22590_13226# a_2019_13229.t3 a_22488_13226# VSS.t1268 sg13_lv_nmos ad=0.2516p pd=2.16u as=0.1406p ps=1.12u w=0.74u l=0.13u
X2785 VDD.t1252 a_21483_1842# a_21917_1842# VDD.t399 sg13_lv_pmos ad=0.2128p pd=1.5u as=0.3808p ps=2.92u w=1.12u l=0.13u
X2786 a_16408_13226# a_15837_14024# VSS.t505 VSS.t2070 sg13_lv_nmos ad=0.1406p pd=1.12u as=0.2516p ps=2.16u w=0.74u l=0.13u
X2787 a_19550_16071# a_3171_16074.t4 a_20968_16071# VSS.t1451 sg13_lv_nmos ad=0.2516p pd=2.16u as=0.1406p ps=1.12u w=0.74u l=0.13u
X2788 a_4350_1044# a_5844_1008# a_5768_1044# VDD.t7 sg13_lv_pmos ad=0.3808p pd=2.92u as=0.2128p ps=1.5u w=1.12u l=0.13u
X2789 a_16108_12471# a_3747_12493.t2 a_25630_13226# VSS.t1503 sg13_lv_nmos ad=0.2516p pd=2.16u as=0.2516p ps=2.16u w=0.74u l=0.13u
X2790 a_13753_7532# a_13557_7532# VSS.t1416 VSS.t1415 sg13_lv_nmos ad=0.2516p pd=2.16u as=0.1406p ps=1.12u w=0.74u l=0.13u
X2791 VSS.t1021 VDD.t1638 VSS.t1019 VSS.t1020 sg13_lv_nmos ad=79.8f pd=0.8u as=0 ps=0 w=0.42u l=1u
X2792 VSS.t34 a_3449_3176# a_3747_3156.t1 VSS.t70 sg13_lv_nmos ad=0.2812p pd=2.24u as=0.1406p ps=1.12u w=0.74u l=0.13u
X2793 VSS.t39 a_5523_4687# a_5957_4687# VSS.t38 sg13_lv_nmos ad=0.1406p pd=1.12u as=0.2516p ps=2.16u w=0.74u l=0.13u
X2794 a_4871_7532# a_4633_7532# a_4763_7532# VSS.t640 sg13_lv_nmos ad=0.1406p pd=1.12u as=0.2516p ps=2.16u w=0.74u l=0.2u
X2795 a_1815_7085# a_1256_6734# a_1721_7085# VSS.t1259 sg13_lv_nmos ad=0.1216p pd=1.02u as=0.2176p ps=1.96u w=0.64u l=0.13u
X2796 VDD.t530 a_18117_4687# a_18585_3889# VDD.t0 sg13_lv_pmos ad=0.252p pd=1.57u as=0.3808p ps=2.92u w=1.12u l=0.13u
X2797 VSS.t899 VDD.t1673 VSS.t897 VSS.t898 sg13_lv_nmos ad=0.1428p pd=1.52u as=0 ps=0 w=0.42u l=1u
X2798 VDD.t160 VSS.t990 VDD.t56 VDD.t41 sg13_lv_pmos ad=0.19p pd=1.38u as=0 ps=0 w=1u l=1u
X2799 a_22590_13226# a_24084_13190# a_24008_13226# VDD.t50 sg13_lv_pmos ad=0.3808p pd=2.92u as=0.2128p ps=1.5u w=1.12u l=0.13u
X2800 VSS.t850 VDD.t1688 VSS.t849 VSS.t848 sg13_lv_nmos ad=0.1428p pd=1.52u as=0 ps=0 w=0.42u l=1u
X2801 a_16510_13226# a_2595_13229.t5 a_17275_13226# VSS.t1635 sg13_lv_nmos ad=0.2516p pd=2.16u as=0.1406p ps=1.12u w=0.74u l=0.13u
X2802 a_6326_10280# a_6126_9506# a_5778_9057# VSS.t14 sg13_lv_nmos ad=0.38p pd=2.38u as=0.68p ps=4.68u w=2u l=1u
X2803 VSS.t334 a_16851_309# CHAN3_MUX_OUT VSS.t335 sg13_lv_nmos ad=0.2516p pd=2.16u as=0.1406p ps=1.12u w=0.74u l=0.13u
X2804 a_2873_6021# REF_MUX_SEL3 VDD.t676 VDD.t41 sg13_lv_pmos ad=0.1596p pd=1.22u as=0.2856p ps=2.36u w=0.84u l=0.13u
X2805 a_22488_6734# a_21917_7532# VDD.t558 VDD.t41 sg13_lv_pmos ad=0.2128p pd=1.5u as=0.3808p ps=2.92u w=1.12u l=0.13u
X2806 VDD.t1373 a_1544_289# a_1721_331# VDD.t7 sg13_lv_pmos ad=0.1918p pd=1.5u as=0.1596p ps=1.22u w=0.84u l=0.13u
X2807 VSS.t770 a_2019_311.t3 a_5705_519# VSS.t769 sg13_lv_nmos ad=0.2516p pd=2.16u as=0.2516p ps=2.16u w=0.74u l=0.13u
X2808 a_4350_16071# a_3171_16074.t9 a_5768_16071# VSS.t2062 sg13_lv_nmos ad=0.2516p pd=2.16u as=0.1406p ps=1.12u w=0.74u l=0.13u
X2809 a_15511_14652# a_15273_14024# a_15403_14024# VDD.t301 sg13_lv_pmos ad=0.2128p pd=1.5u as=0.3808p ps=2.92u w=1.12u l=0.2u
X2810 a_7673_7532# a_7477_7532# VDD.t620 VDD.t275 sg13_lv_pmos ad=0.3808p pd=2.92u as=0.2128p ps=1.5u w=1.12u l=0.13u
X2811 VSS.t653 a_4187_1764.t59 a_8671_4687# VSS.t1264 sg13_lv_nmos ad=0.2516p pd=2.16u as=0.1406p ps=1.12u w=0.74u l=0.6u
X2812 a_16033_1842# a_15837_1842# VSS.t266 VSS.t1721 sg13_lv_nmos ad=0.2516p pd=2.16u as=0.1406p ps=1.12u w=0.74u l=0.13u
X2813 VDD.t661 a_11603_4687# a_12037_4687# VDD.t281 sg13_lv_pmos ad=0.2128p pd=1.5u as=0.3808p ps=2.92u w=1.12u l=0.13u
X2814 VSS.t229 a_24523_7532# a_24957_7532# VSS.t2114 sg13_lv_nmos ad=0.1406p pd=1.12u as=0.2516p ps=2.16u w=0.74u l=0.13u
X2815 a_6635_6734# a_6425_6734# VSS.t27 VSS.t26 sg13_lv_nmos ad=0.1406p pd=1.12u as=0.1665p ps=1.19u w=0.74u l=0.13u
X2816 a_7151_1842# a_6913_1842# a_7043_1842# VSS.t667 sg13_lv_nmos ad=0.1406p pd=1.12u as=0.2516p ps=2.16u w=0.74u l=0.2u
X2817 VDD.t357 a_4187_2434# a_16271_14652# VDD.t301 sg13_lv_pmos ad=0.3808p pd=2.92u as=0.2128p ps=1.5u w=1.12u l=0.6u
X2818 a_9746_11495# a_9547_11632# VSS.t510 VSS.t692 sg13_lv_nmos ad=0.27427p pd=2.28u as=2.39977p ps=15.495u w=0.795u l=0.13u
X2819 a_24631_16869# a_24393_16869# a_24523_16869# VSS.t1140 sg13_lv_nmos ad=0.1406p pd=1.12u as=0.2516p ps=2.16u w=0.74u l=0.2u
X2820 VSS.t187 a_2595_6737.t9 a_5191_6698# VSS.t2212 sg13_lv_nmos ad=0.2516p pd=2.16u as=0.2516p ps=2.16u w=0.74u l=0.13u
X2821 VDD.t40 VSS.t1021 VDD.t39 VDD.t0 sg13_lv_pmos ad=0.34p pd=2.68u as=0 ps=0 w=1u l=1u
X2822 a_13470_3889# a_2019_3892.t6 a_13368_3889# VSS.t1832 sg13_lv_nmos ad=0.2516p pd=2.16u as=0.1406p ps=1.12u w=0.74u l=0.13u
X2823 a_24393_4687# a_24197_4687# VDD.t468 VDD.t281 sg13_lv_pmos ad=0.3808p pd=2.92u as=0.2128p ps=1.5u w=1.12u l=0.13u
X2824 a_11473_16869# a_11277_16869# VDD.t887 VDD.t297 sg13_lv_pmos ad=0.3808p pd=2.92u as=0.2128p ps=1.5u w=1.12u l=0.13u
X2825 VSS.t524 a_10083_14024# a_10517_14024# VSS.t2023 sg13_lv_nmos ad=0.1406p pd=1.12u as=0.2516p ps=2.16u w=0.74u l=0.13u
X2826 a_20315_6734# a_20105_6734# VSS.t282 VSS.t281 sg13_lv_nmos ad=0.1406p pd=1.12u as=0.1665p ps=1.19u w=0.74u l=0.13u
X2827 a_20071_16869# a_19833_16869# a_19963_16869# VSS.t1722 sg13_lv_nmos ad=0.1406p pd=1.12u as=0.2516p ps=2.16u w=0.74u l=0.2u
X2828 VSS.t598 a_4187_1764.t135 a_25391_16869# VSS.t597 sg13_lv_nmos ad=0.2516p pd=2.16u as=0.1406p ps=1.12u w=0.74u l=0.6u
X2829 a_7390_13226# a_8884_13190# a_8808_13226# VDD.t50 sg13_lv_pmos ad=0.3808p pd=2.92u as=0.2128p ps=1.5u w=1.12u l=0.13u
X2830 a_25528_6734# a_24957_7532# VSS.t108 VSS.t230 sg13_lv_nmos ad=0.1406p pd=1.12u as=0.2516p ps=2.16u w=0.74u l=0.13u
X2831 CHAN3_MUX_OUT a_16851_309# VDD.t568 VDD.t7 sg13_lv_pmos ad=0.2128p pd=1.5u as=0.2086p ps=1.5u w=1.12u l=0.13u
X2832 VSS.t2283 a_3747_3156.t2 a_26985_3364# VSS.t2282 sg13_lv_nmos ad=0.2516p pd=2.16u as=0.2516p ps=2.16u w=0.74u l=0.13u
X2833 VDD.t59 VSS.t944 VDD.t157 VDD.t41 sg13_lv_pmos ad=0.34p pd=2.68u as=0 ps=0 w=1u l=1u
X2834 a_6126_9506# a_6326_10280# VDD.t1127 VDD.t268 sg13_lv_pmos ad=0.38p pd=2.38u as=0.38p ps=2.38u w=2u l=1u
X2835 VSS.t251 a_1256_16071# a_2967_16422# VSS.t1229 sg13_lv_nmos ad=0.1331p pd=1.12u as=0.1216p ps=1.02u w=0.64u l=0.13u
X2836 a_6391_14024# a_6153_14024# a_6283_14024# VSS.t2007 sg13_lv_nmos ad=0.1406p pd=1.12u as=0.2516p ps=2.16u w=0.74u l=0.2u
X2837 VSS.t421 a_2595_16074.t7 a_11271_16035# VSS.t420 sg13_lv_nmos ad=0.2516p pd=2.16u as=0.2516p ps=2.16u w=0.74u l=0.13u
X2838 a_25391_2470# a_25153_1842# a_25283_1842# VDD.t399 sg13_lv_pmos ad=0.2128p pd=1.5u as=0.3808p ps=2.92u w=1.12u l=0.2u
X2839 VDD.t1093 a_3171_3892.t6 a_14964_3853# VDD.t0 sg13_lv_pmos ad=0.3808p pd=2.92u as=0.3808p ps=2.92u w=1.12u l=0.13u
X2840 a_5731_5979# a_2019_6001.t3 a_4350_6734# VSS.t1957 sg13_lv_nmos ad=0.2516p pd=2.16u as=0.2516p ps=2.16u w=0.74u l=0.13u
X2841 VDD.t765 VDD.t763 VDD.t762 VDD.t301 sg13_lv_pmos ad=0.2128p pd=1.5u as=0 ps=0 w=1.12u l=0.2u
X2842 VSS.t905 VDD.t1671 VSS.t904 VSS.t903 sg13_lv_nmos ad=0.1428p pd=1.52u as=0 ps=0 w=0.42u l=1u
X2843 VDD.t374 a_4187_2434# a_11711_8160# VDD.t275 sg13_lv_pmos ad=0.3808p pd=2.92u as=0.2128p ps=1.5u w=1.12u l=0.6u
X2844 VDD.t235 VSS.t773 VDD.t246 VDD.t7 sg13_lv_pmos ad=0.34p pd=2.68u as=0 ps=0 w=1u l=1u
X2845 a_16108_3134# a_20905_3364# a_19550_3889# VDD.t0 sg13_lv_pmos ad=0.3808p pd=2.92u as=0.3808p ps=2.92u w=1.12u l=0.13u
X2846 a_2595_3892.t1 a_2297_4240# VSS.t56 VSS.t55 sg13_lv_nmos ad=0.1406p pd=1.12u as=0.1331p ps=1.12u w=0.74u l=0.13u
X2847 VSS.t869 VDD.t1681 VSS.t869 VSS.t873 sg13_lv_nmos ad=79.8f pd=0.8u as=0 ps=0 w=0.42u l=1u
X2848 a_4350_13226# a_4324_13190# a_4248_13226# VDD.t50 sg13_lv_pmos ad=0.3808p pd=2.92u as=0.2128p ps=1.5u w=1.12u l=0.13u
X2849 VSS.t1398 a_3171_3892.t3 a_24084_3853# VSS.t1657 sg13_lv_nmos ad=0.2516p pd=2.16u as=0.2516p ps=2.16u w=0.74u l=0.13u
X2850 a_25630_16071# a_26471_16035# a_26395_16071# VDD.t4 sg13_lv_pmos ad=0.3808p pd=2.92u as=0.2128p ps=1.5u w=1.12u l=0.13u
X2851 VSS.t705 a_4187_1764.t127 a_7151_14024# VSS.t704 sg13_lv_nmos ad=0.2516p pd=2.16u as=0.1406p ps=1.12u w=0.74u l=0.6u
X2852 CHAN1_MUX_OUT a_16851_12491# VDD.t672 VDD.t50 sg13_lv_pmos ad=0.2128p pd=1.5u as=0.2086p ps=1.5u w=1.12u l=0.13u
X2853 VSS.t1550 a_4187_1764.t98 VSS.t1548 VSS.t1533 sg13_lv_nmos ad=1.33p pd=7.38u as=0 ps=0 w=7u l=7u
X2854 VDD.t406 a_4187_2434# a_14751_5315# VDD.t281 sg13_lv_pmos ad=0.3808p pd=2.92u as=0.2128p ps=1.5u w=1.12u l=0.6u
X2855 VSS.t447 a_24523_14024# a_24957_14024# VSS.t1885 sg13_lv_nmos ad=0.1406p pd=1.12u as=0.2516p ps=2.16u w=0.74u l=0.13u
X2856 VSS.t1522 a_2019_3156.t3 a_5705_3364# VSS.t1521 sg13_lv_nmos ad=0.2516p pd=2.16u as=0.2516p ps=2.16u w=0.74u l=0.13u
X2857 VSS.t753 a_4187_1764.t66 a_27671_7532# VSS.t752 sg13_lv_nmos ad=0.2516p pd=2.16u as=0.1406p ps=1.12u w=0.74u l=0.6u
X2858 a_12993_1842# a_12797_1842# VDD.t1108 VDD.t399 sg13_lv_pmos ad=0.3808p pd=2.92u as=0.2128p ps=1.5u w=1.12u l=0.13u
X2859 VDD.t1420 a_18443_14024# a_18877_14024# VDD.t301 sg13_lv_pmos ad=0.2128p pd=1.5u as=0.3808p ps=2.92u w=1.12u l=0.13u
X2860 a_16408_1044# a_15837_1842# VSS.t1618 VSS.t1720 sg13_lv_nmos ad=0.1406p pd=1.12u as=0.2516p ps=2.16u w=0.74u l=0.13u
X2861 VDD.t557 a_21483_7532# a_21917_7532# VDD.t275 sg13_lv_pmos ad=0.2128p pd=1.5u as=0.3808p ps=2.92u w=1.12u l=0.13u
X2862 VDD.t839 a_7477_16869# a_7945_16071# VDD.t4 sg13_lv_pmos ad=0.252p pd=1.57u as=0.3808p ps=2.92u w=1.12u l=0.13u
X2863 VSS.t1003 VDD.t1643 VSS.t1003 VSS.t1004 sg13_lv_nmos ad=79.8f pd=0.8u as=0 ps=0 w=0.42u l=1u
X2864 a_12471_4687# a_12233_4687# a_12363_4687# VSS.t2233 sg13_lv_nmos ad=0.1406p pd=1.12u as=0.2516p ps=2.16u w=0.74u l=0.2u
X2865 a_5768_16071# a_5197_16869# VDD.t919 VDD.t4 sg13_lv_pmos ad=0.2128p pd=1.5u as=0.3808p ps=2.92u w=1.12u l=0.13u
X2866 VDD.t501 a_2595_13229.t6 a_14311_13190# VDD.t50 sg13_lv_pmos ad=0.3808p pd=2.92u as=0.3808p ps=2.92u w=1.12u l=0.13u
X2867 a_11195_3889# a_10985_3889# VDD.t1035 VDD.t0 sg13_lv_pmos ad=0.2128p pd=1.5u as=0.252p ps=1.57u w=1.12u l=0.13u
X2868 a_5731_5979# a_11785_6209# a_10430_6734# VDD.t41 sg13_lv_pmos ad=0.3808p pd=2.92u as=0.3808p ps=2.92u w=1.12u l=0.13u
X2869 a_4871_16869# a_4633_16869# a_4763_16869# VSS.t296 sg13_lv_nmos ad=0.1406p pd=1.12u as=0.2516p ps=2.16u w=0.74u l=0.2u
X2870 VDD.t312 a_4187_2434# a_4111_5315# VDD.t281 sg13_lv_pmos ad=0.3808p pd=2.92u as=0.2128p ps=1.5u w=1.12u l=0.6u
X2871 a_9193_16869# a_8997_16869# VSS.t302 VSS.t301 sg13_lv_nmos ad=0.2516p pd=2.16u as=0.1406p ps=1.12u w=0.74u l=0.13u
X2872 a_18795_16071# a_18585_16071# VSS.t1751 VSS.t1809 sg13_lv_nmos ad=0.1406p pd=1.12u as=0.1665p ps=1.19u w=0.74u l=0.13u
X2873 VSS.t1652 a_5523_1842# a_5957_1842# VSS.t2288 sg13_lv_nmos ad=0.1406p pd=1.12u as=0.2516p ps=2.16u w=0.74u l=0.13u
X2874 a_13566_11525# a_14009_11568# a_13949_11604# VDD.t268 sg13_lv_pmos ad=79.8f pd=0.8u as=63f ps=0.72u w=0.42u l=0.13u
X2875 a_15755_13226# a_15545_13226# VSS.t2073 VSS.t2290 sg13_lv_nmos ad=0.1406p pd=1.12u as=0.1665p ps=1.19u w=0.74u l=0.13u
X2876 a_1815_4240# a_1256_3889# a_1721_4240# VSS.t127 sg13_lv_nmos ad=0.1216p pd=1.02u as=0.2176p ps=1.96u w=0.64u l=0.13u
X2877 a_5731_289# a_2019_311.t3 a_4350_1044# VSS.t768 sg13_lv_nmos ad=0.2516p pd=2.16u as=0.2516p ps=2.16u w=0.74u l=0.13u
X2878 VDD.t442 a_4187_2434# a_13991_2470# VDD.t399 sg13_lv_pmos ad=0.3808p pd=2.92u as=0.2128p ps=1.5u w=1.12u l=0.6u
X2879 VSS.t276 a_4187_1764.t161 a_5631_16869# VSS.t275 sg13_lv_nmos ad=0.2516p pd=2.16u as=0.1406p ps=1.12u w=0.74u l=0.6u
X2880 VDD.t699 a_2595_15338.t2 a_20905_15546# VDD.t4 sg13_lv_pmos ad=0.3808p pd=2.92u as=0.3808p ps=2.92u w=1.12u l=0.13u
X2881 VSS.t6 a_14851_10872# a_15688_11093# VSS.t132 sg13_lv_nmos ad=0.1406p pd=1.12u as=0.2516p ps=2.16u w=0.74u l=0.13u
X2882 VSS.t1290 a_23003_16869# a_23437_16869# VSS.t1289 sg13_lv_nmos ad=0.1406p pd=1.12u as=0.2516p ps=2.16u w=0.74u l=0.13u
X2883 a_14235_16071# a_14025_16071# VSS.t307 VSS.t1975 sg13_lv_nmos ad=0.1406p pd=1.12u as=0.1665p ps=1.19u w=0.74u l=0.13u
X2884 VSS.t526 a_9323_14024# a_9757_14024# VSS.t1999 sg13_lv_nmos ad=0.1406p pd=1.12u as=0.2516p ps=2.16u w=0.74u l=0.13u
X2885 VDD.t22 VSS.t1051 VDD.t21 VDD.t0 sg13_lv_pmos ad=0.19p pd=1.38u as=0 ps=0 w=1u l=1u
X2886 a_2391_6021# REF_MUX_SEL2 a_2297_6021# VSS.t784 sg13_lv_nmos ad=0.1216p pd=1.02u as=0.2176p ps=1.96u w=0.64u l=0.13u
X2887 VSS.t927 VDD.t1664 VSS.t927 VSS.t928 sg13_lv_nmos ad=79.8f pd=0.8u as=0 ps=0 w=0.42u l=1u
X2888 VDD.t1008 a_3449_7085# a_3747_6737.t0 VDD.t41 sg13_lv_pmos ad=0.4256p pd=3u as=0.2128p ps=1.5u w=1.12u l=0.13u
X2889 a_13470_6734# a_13444_6698# a_13368_6734# VDD.t41 sg13_lv_pmos ad=0.3808p pd=2.92u as=0.2128p ps=1.5u w=1.12u l=0.13u
X2890 a_17031_17497# a_16793_16869# a_16923_16869# VDD.t297 sg13_lv_pmos ad=0.2128p pd=1.5u as=0.3808p ps=2.92u w=1.12u l=0.2u
X2891 a_2019_16074.t1 a_1721_16422# VSS.t251 VSS.t250 sg13_lv_nmos ad=0.1406p pd=1.12u as=0.1331p ps=1.12u w=0.74u l=0.13u
X2892 a_10458_11982# DLL_RESETN VSS.t1207 VSS.t1208 sg13_lv_nmos ad=37.8f pd=0.6u as=0.1701p ps=1.65u w=0.42u l=0.13u
X2893 a_7390_1044# a_3747_1047.t8 a_9675_1044# VSS.t157 sg13_lv_nmos ad=0.2516p pd=2.16u as=0.1406p ps=1.12u w=0.74u l=0.13u
X2894 VSS.t477 a_1544_5979# a_1815_6021# VSS.t478 sg13_lv_nmos ad=0.1331p pd=1.12u as=0.1216p ps=1.02u w=0.64u l=0.13u
X2895 a_4350_16071# a_6711_16035# a_6635_16071# VDD.t4 sg13_lv_pmos ad=0.3808p pd=2.92u as=0.2128p ps=1.5u w=1.12u l=0.13u
X2896 VDD.t1291 a_23763_1842# a_24197_1842# VDD.t399 sg13_lv_pmos ad=0.2128p pd=1.5u as=0.3808p ps=2.92u w=1.12u l=0.13u
X2897 a_25528_16071# a_24957_16869# VSS.t699 VSS.t1227 sg13_lv_nmos ad=0.1406p pd=1.12u as=0.2516p ps=2.16u w=0.74u l=0.13u
X2898 a_1256_15316# CHAN0_MUX_SEL2 VSS.t650 VSS.t188 sg13_lv_nmos ad=0.2516p pd=2.16u as=0.2516p ps=2.16u w=0.74u l=0.13u
X2899 a_22113_14024# a_21917_14024# VSS.t1811 VSS.t1859 sg13_lv_nmos ad=0.2516p pd=2.16u as=0.1406p ps=1.12u w=0.74u l=0.13u
X2900 VSS.t235 a_18117_4687# a_18585_3889# VSS.t2245 sg13_lv_nmos ad=0.1665p pd=1.19u as=0.2516p ps=2.16u w=0.74u l=0.13u
X2901 a_12471_17497# a_12233_16869# a_12363_16869# VDD.t297 sg13_lv_pmos ad=0.2128p pd=1.5u as=0.3808p ps=2.92u w=1.12u l=0.2u
X2902 VDD.t331 a_4187_2434# a_17791_17497# VDD.t297 sg13_lv_pmos ad=0.3808p pd=2.92u as=0.2128p ps=1.5u w=1.12u l=0.6u
X2903 a_16033_7532# a_15837_7532# VSS.t221 VSS.t322 sg13_lv_nmos ad=0.2516p pd=2.16u as=0.1406p ps=1.12u w=0.74u l=0.13u
X2904 VDD.t949 a_2019_1047.t8 a_7364_1008# VDD.t7 sg13_lv_pmos ad=0.3808p pd=2.92u as=0.3808p ps=2.92u w=1.12u l=0.13u
X2905 VSS.t169 a_4187_1764.t27 a_8671_1842# VSS.t168 sg13_lv_nmos ad=0.2516p pd=2.16u as=0.1406p ps=1.12u w=0.74u l=0.6u
X2906 a_17275_13226# a_17065_13226# VDD.t970 VDD.t50 sg13_lv_pmos ad=0.2128p pd=1.5u as=0.252p ps=1.57u w=1.12u l=0.13u
X2907 a_7151_7532# a_6913_7532# a_7043_7532# VSS.t808 sg13_lv_nmos ad=0.1406p pd=1.12u as=0.2516p ps=2.16u w=0.74u l=0.2u
X2908 VDD.t957 a_3171_6737.t3 a_24084_6698# VDD.t41 sg13_lv_pmos ad=0.3808p pd=2.92u as=0.3808p ps=2.92u w=1.12u l=0.13u
X2909 a_3449_7085# REF_MUX_SEL0 VDD.t572 VDD.t41 sg13_lv_pmos ad=0.1596p pd=1.22u as=0.2856p ps=2.36u w=0.84u l=0.13u
X2910 VDD.t317 a_4187_2434# a_13231_17497# VDD.t297 sg13_lv_pmos ad=0.3808p pd=2.92u as=0.2128p ps=1.5u w=1.12u l=0.6u
X2911 a_9953_4687# a_9757_4687# VSS.t317 VSS.t316 sg13_lv_nmos ad=0.2516p pd=2.16u as=0.1406p ps=1.12u w=0.74u l=0.13u
X2912 VDD.t1434 a_2019_15338.t3 a_5705_15546# VDD.t4 sg13_lv_pmos ad=0.3808p pd=2.92u as=0.3808p ps=2.92u w=1.12u l=0.13u
X2913 VSS.t711 a_10843_4687# a_11277_4687# VSS.t1118 sg13_lv_nmos ad=0.1406p pd=1.12u as=0.2516p ps=2.16u w=0.74u l=0.13u
X2914 a_11473_14024# a_11277_14024# VDD.t1350 VDD.t301 sg13_lv_pmos ad=0.3808p pd=2.92u as=0.2128p ps=1.5u w=1.12u l=0.13u
X2915 a_22590_3889# a_23431_3853# a_23355_3889# VDD.t0 sg13_lv_pmos ad=0.3808p pd=2.92u as=0.2128p ps=1.5u w=1.12u l=0.13u
X2916 a_17031_5315# a_16793_4687# a_16923_4687# VDD.t281 sg13_lv_pmos ad=0.2128p pd=1.5u as=0.3808p ps=2.92u w=1.12u l=0.2u
X2917 a_24875_16071# a_24665_16071# VDD.t565 VDD.t4 sg13_lv_pmos ad=0.2128p pd=1.5u as=0.252p ps=1.57u w=1.12u l=0.13u
X2918 VDD.t14 VSS.t1008 VDD.t222 VDD.t0 sg13_lv_pmos ad=0.34p pd=2.68u as=0 ps=0 w=1u l=1u
X2919 VDD.t746 VDD.t747 VDD.t748 VDD.t297 sg13_lv_pmos ad=0.2128p pd=1.5u as=0 ps=0 w=1.12u l=0.13u
X2920 a_4157_13495# CHAN1_DELAY_IN VSS.t124 VSS.t2106 sg13_lv_nmos ad=0.2516p pd=2.16u as=0.2553p ps=2.17u w=0.74u l=0.13u
X2921 VDD.t446 a_4187_2434# a_26911_2470# VDD.t399 sg13_lv_pmos ad=0.3808p pd=2.92u as=0.2128p ps=1.5u w=1.12u l=0.6u
X2922 VDD.t211 VSS.t829 VDD.t149 VDD.t4 sg13_lv_pmos ad=0.19p pd=1.38u as=0 ps=0 w=1u l=1u
X2923 a_25391_8160# a_25153_7532# a_25283_7532# VDD.t275 sg13_lv_pmos ad=0.2128p pd=1.5u as=0.3808p ps=2.92u w=1.12u l=0.2u
X2924 a_16108_5979# a_15765_6153# a_15964_5979# VDD.t41 sg13_lv_pmos ad=0.3808p pd=2.92u as=0.3304p ps=1.71u w=1.12u l=0.13u
X2925 a_20593_16869# a_20397_16869# VSS.t1378 VSS.t1377 sg13_lv_nmos ad=0.2516p pd=2.16u as=0.1406p ps=1.12u w=0.74u l=0.13u
X2926 VDD.t941 VSS.t1115 VDD.t939 VDD.t7 sg13_lv_pmos ad=0.19p pd=1.38u as=0 ps=0 w=1u l=1u
X2927 VSS.t500 a_13883_16869# a_14317_16869# VSS.t1748 sg13_lv_nmos ad=0.1406p pd=1.12u as=0.2516p ps=2.16u w=0.74u l=0.13u
X2928 a_6913_14024# a_6717_14024# VSS.t707 VSS.t2006 sg13_lv_nmos ad=0.2516p pd=2.16u as=0.1406p ps=1.12u w=0.74u l=0.13u
X2929 VSS.t1056 VDD.t1627 VSS.t1056 VSS.t1057 sg13_lv_nmos ad=79.8f pd=0.8u as=0 ps=0 w=0.42u l=1u
X2930 a_12993_7532# a_12797_7532# VDD.t665 VDD.t275 sg13_lv_pmos ad=0.3808p pd=2.92u as=0.2128p ps=1.5u w=1.12u l=0.13u
X2931 a_22590_16071# a_2019_16074.t3 a_22488_16071# VSS.t2315 sg13_lv_nmos ad=0.2516p pd=2.16u as=0.1406p ps=1.12u w=0.74u l=0.13u
X2932 a_16408_6734# a_15837_7532# VSS.t321 VSS.t320 sg13_lv_nmos ad=0.1406p pd=1.12u as=0.2516p ps=2.16u w=0.74u l=0.13u
X2933 VSS.t1028 a_2019_3156.t2 a_17865_3364# VSS.t1524 sg13_lv_nmos ad=0.2516p pd=2.16u as=0.2516p ps=2.16u w=0.74u l=0.13u
X2934 VDD.t627 a_15403_16869# a_15837_16869# VDD.t297 sg13_lv_pmos ad=0.2128p pd=1.5u as=0.3808p ps=2.92u w=1.12u l=0.13u
X2935 a_22488_1044# a_21917_1842# VDD.t1253 VDD.t7 sg13_lv_pmos ad=0.2128p pd=1.5u as=0.3808p ps=2.92u w=1.12u l=0.13u
X2936 a_16408_16071# a_15837_16869# VSS.t483 VSS.t482 sg13_lv_nmos ad=0.1406p pd=1.12u as=0.2516p ps=2.16u w=0.74u l=0.13u
X2937 VSS.t815 VDD.t1698 VSS.t814 VSS.t813 sg13_lv_nmos ad=0.1428p pd=1.52u as=0 ps=0 w=0.42u l=1u
X2938 a_12471_1842# a_12233_1842# a_12363_1842# VSS.t1760 sg13_lv_nmos ad=0.1406p pd=1.12u as=0.2516p ps=2.16u w=0.74u l=0.2u
X2939 a_3747_3892.t0 a_3449_4240# VDD.t594 VDD.t0 sg13_lv_pmos ad=0.2128p pd=1.5u as=0.1918p ps=1.5u w=1.12u l=0.13u
X2940 a_5731_3134# a_11785_3364# a_10430_3889# VDD.t0 sg13_lv_pmos ad=0.3808p pd=2.92u as=0.3808p ps=2.92u w=1.12u l=0.13u
X2941 a_13368_13226# a_12797_14024# VSS.t1267 VSS.t2055 sg13_lv_nmos ad=0.1406p pd=1.12u as=0.2516p ps=2.16u w=0.74u l=0.13u
X2942 VSS.t332 a_3171_3892.t6 a_14964_3853# VSS.t1655 sg13_lv_nmos ad=0.2516p pd=2.16u as=0.2516p ps=2.16u w=0.74u l=0.13u
X2943 VSS.t226 a_5523_7532# a_5957_7532# VSS.t1211 sg13_lv_nmos ad=0.1406p pd=1.12u as=0.2516p ps=2.16u w=0.74u l=0.13u
X2944 VSS.t965 VDD.t1653 VSS.t968 VSS.t967 sg13_lv_nmos ad=79.8f pd=0.8u as=0 ps=0 w=0.42u l=1u
X2945 VSS.t205 a_3449_6021# a_3747_6001.t1 VSS.t206 sg13_lv_nmos ad=0.2812p pd=2.24u as=0.1406p ps=1.12u w=0.74u l=0.13u
X2946 VSS.t375 a_3171_1047.t5 a_18004_1008# VSS.t374 sg13_lv_nmos ad=0.2516p pd=2.16u as=0.2516p ps=2.16u w=0.74u l=0.13u
X2947 VDD.t721 a_2595_311.t3 a_8745_519# VDD.t7 sg13_lv_pmos ad=0.3808p pd=2.92u as=0.3808p ps=2.92u w=1.12u l=0.13u
X2948 VDD.t1207 a_3171_6001.t3 a_11785_6209# VDD.t41 sg13_lv_pmos ad=0.3808p pd=2.92u as=0.3808p ps=2.92u w=1.12u l=0.13u
X2949 a_16108_12471# a_3171_12493.t2 a_22590_13226# VSS.t429 sg13_lv_nmos ad=0.2516p pd=2.16u as=0.2516p ps=2.16u w=0.74u l=0.13u
X2950 VDD.t1510 a_18117_7532# a_18585_6734# VDD.t41 sg13_lv_pmos ad=0.252p pd=1.57u as=0.3808p ps=2.92u w=1.12u l=0.13u
X2951 a_20831_5315# a_20593_4687# a_20723_4687# VDD.t281 sg13_lv_pmos ad=0.2128p pd=1.5u as=0.3808p ps=2.92u w=1.12u l=0.2u
X2952 VSS.t11 a_12849_11557# a_13400_10795# VSS.t10 sg13_lv_nmos ad=0.1626p pd=1.415u as=60.89999f ps=0.71u w=0.42u l=0.13u
X2953 VDD.t369 a_4187_2434# a_13991_8160# VDD.t275 sg13_lv_pmos ad=0.3808p pd=2.92u as=0.2128p ps=1.5u w=1.12u l=0.6u
X2954 a_5393_4687# a_5197_4687# VDD.t481 VDD.t281 sg13_lv_pmos ad=0.3808p pd=2.92u as=0.2128p ps=1.5u w=1.12u l=0.13u
X2955 VDD.t983 a_2873_16422# a_3171_16074.t0 VDD.t4 sg13_lv_pmos ad=0.4256p pd=3u as=0.2128p ps=1.5u w=1.12u l=0.13u
X2956 a_16510_13226# a_3747_13229.t5 a_18795_13226# VSS.t1578 sg13_lv_nmos ad=0.2516p pd=2.16u as=0.1406p ps=1.12u w=0.74u l=0.13u
X2957 VDD.t1140 a_6326_10280# a_6326_10280# VDD.t268 sg13_lv_pmos ad=0.38p pd=2.38u as=0.38p ps=2.38u w=2u l=1u
X2958 VDD.t417 a_4187_2434# a_17031_5315# VDD.t281 sg13_lv_pmos ad=0.3808p pd=2.92u as=0.2128p ps=1.5u w=1.12u l=0.6u
X2959 a_23111_14024# a_22873_14024# a_23003_14024# VSS.t1875 sg13_lv_nmos ad=0.1406p pd=1.12u as=0.2516p ps=2.16u w=0.74u l=0.2u
X2960 VSS.t1556 a_4187_1764.t98 VSS.t1554 VSS.t1539 sg13_lv_nmos ad=1.33p pd=7.38u as=0 ps=0 w=7u l=7u
X2961 a_16510_16071# a_2595_16074.t5 a_17275_16071# VSS.t416 sg13_lv_nmos ad=0.2516p pd=2.16u as=0.1406p ps=1.12u w=0.74u l=0.13u
X2962 a_15273_1842# a_15077_1842# VDD.t1146 VDD.t399 sg13_lv_pmos ad=0.3808p pd=2.92u as=0.2128p ps=1.5u w=1.12u l=0.13u
X2963 a_17031_14652# a_16793_14024# a_16923_14024# VDD.t301 sg13_lv_pmos ad=0.2128p pd=1.5u as=0.3808p ps=2.92u w=1.12u l=0.2u
X2964 VSS.t889 VDD.t1676 VSS.t887 VSS.t888 sg13_lv_nmos ad=0.1428p pd=1.52u as=0 ps=0 w=0.42u l=1u
X2965 a_9444_9602# a_6854_11144# a_9712_9602# VSS.t2236 sg13_lv_nmos ad=0.68p pd=4.68u as=0.38p ps=2.38u w=2u l=1u
X2966 a_7390_6734# a_3747_6737.t8 a_9675_6734# VSS.t1284 sg13_lv_nmos ad=0.2516p pd=2.16u as=0.1406p ps=1.12u w=0.74u l=0.13u
X2967 a_1256_3134# CHAN2_MUX_SEL2 VSS.t31 VSS.t2008 sg13_lv_nmos ad=0.2516p pd=2.16u as=0.2516p ps=2.16u w=0.74u l=0.13u
X2968 a_1256_13226# CHAN1_MUX_SEL0 VSS.t189 VSS.t188 sg13_lv_nmos ad=0.2516p pd=2.16u as=0.2516p ps=2.16u w=0.74u l=0.13u
X2969 a_13470_13226# a_2595_13229.t6 a_14235_13226# VSS.t176 sg13_lv_nmos ad=0.2516p pd=2.16u as=0.1406p ps=1.12u w=0.74u l=0.13u
X2970 a_19550_13226# a_21044_13190# a_20968_13226# VDD.t50 sg13_lv_pmos ad=0.3808p pd=2.92u as=0.2128p ps=1.5u w=1.12u l=0.13u
X2971 VDD.t284 a_23763_7532# a_24197_7532# VDD.t275 sg13_lv_pmos ad=0.2128p pd=1.5u as=0.3808p ps=2.92u w=1.12u l=0.13u
X2972 a_6391_2470# a_6153_1842# a_6283_1842# VDD.t399 sg13_lv_pmos ad=0.2128p pd=1.5u as=0.3808p ps=2.92u w=1.12u l=0.2u
X2973 a_11195_3889# a_10985_3889# VSS.t1485 VSS.t1484 sg13_lv_nmos ad=0.1406p pd=1.12u as=0.1665p ps=1.19u w=0.74u l=0.13u
X2974 a_2873_4240# CHAN2_MUX_SEL1 VDD.t1178 VDD.t0 sg13_lv_pmos ad=0.1596p pd=1.22u as=0.2856p ps=2.36u w=0.84u l=0.13u
X2975 a_14235_1044# a_14025_1044# VSS.t1325 VSS.t1324 sg13_lv_nmos ad=0.1406p pd=1.12u as=0.1665p ps=1.19u w=0.74u l=0.13u
X2976 VSS.t82 VDD.t1636 VSS.t82 VSS.t1025 sg13_lv_nmos ad=0.1428p pd=1.52u as=0 ps=0 w=0.42u l=1u
X2977 VDD.t910 a_26803_4687# a_27237_4687# VDD.t281 sg13_lv_pmos ad=0.2128p pd=1.5u as=0.3808p ps=2.92u w=1.12u l=0.13u
X2978 a_11195_16071# a_10985_16071# VDD.t1161 VDD.t4 sg13_lv_pmos ad=0.2128p pd=1.5u as=0.252p ps=1.57u w=1.12u l=0.13u
X2979 a_12471_14652# a_12233_14024# a_12363_14024# VDD.t301 sg13_lv_pmos ad=0.2128p pd=1.5u as=0.3808p ps=2.92u w=1.12u l=0.2u
X2980 VDD.t353 a_4187_2434# a_17791_14652# VDD.t301 sg13_lv_pmos ad=0.3808p pd=2.92u as=0.2128p ps=1.5u w=1.12u l=0.6u
X2981 a_10206_11525# a_10649_11568# a_9946_11995# VSS.t515 sg13_lv_nmos ad=79.8f pd=0.8u as=0.1296p ps=1.52u w=0.42u l=0.13u
X2982 VSS.t289 a_4187_1764.t91 a_8671_7532# VSS.t427 sg13_lv_nmos ad=0.2516p pd=2.16u as=0.1406p ps=1.12u w=0.74u l=0.6u
X2983 a_9444_10280# a_9444_10280# VSS.t1461 VSS.t1459 sg13_lv_nmos ad=0.38p pd=2.38u as=0.68p ps=4.68u w=2u l=1u
X2984 VSS.t1612 a_3747_1047.t7 a_12791_1008# VSS.t1611 sg13_lv_nmos ad=0.2516p pd=2.16u as=0.2516p ps=2.16u w=0.74u l=0.13u
X2985 a_12993_16869# a_12797_16869# VDD.t686 VDD.t297 sg13_lv_pmos ad=0.3808p pd=2.92u as=0.2128p ps=1.5u w=1.12u l=0.13u
X2986 VSS.t1592 a_3171_13229.t8 a_8884_13190# VSS.t1591 sg13_lv_nmos ad=0.2516p pd=2.16u as=0.2516p ps=2.16u w=0.74u l=0.13u
X2987 a_22488_16071# a_21917_16869# VDD.t834 VDD.t4 sg13_lv_pmos ad=0.2128p pd=1.5u as=0.3808p ps=2.92u w=1.12u l=0.13u
X2988 VDD.t309 a_4187_2434# a_13231_14652# VDD.t301 sg13_lv_pmos ad=0.3808p pd=2.92u as=0.2128p ps=1.5u w=1.12u l=0.6u
X2989 VDD.t1238 a_2019_3892.t7 a_10404_3853# VDD.t0 sg13_lv_pmos ad=0.3808p pd=2.92u as=0.3808p ps=2.92u w=1.12u l=0.13u
X2990 a_21591_16869# a_21353_16869# a_21483_16869# VSS.t1287 sg13_lv_nmos ad=0.1406p pd=1.12u as=0.2516p ps=2.16u w=0.74u l=0.2u
X2991 VSS.t66 a_4187_1764.t133 a_26911_16869# VSS.t1359 sg13_lv_nmos ad=0.2516p pd=2.16u as=0.1406p ps=1.12u w=0.74u l=0.6u
X2992 VSS.t542 a_10843_1842# a_11277_1842# VSS.t1688 sg13_lv_nmos ad=0.1406p pd=1.12u as=0.2516p ps=2.16u w=0.74u l=0.13u
X2993 a_9953_1842# a_9757_1842# VSS.t173 VSS.t1705 sg13_lv_nmos ad=0.2516p pd=2.16u as=0.1406p ps=1.12u w=0.74u l=0.13u
X2994 VSS.t1105 VDD.t1612 VSS.t1105 VSS.t1106 sg13_lv_nmos ad=0.1428p pd=1.52u as=0 ps=0 w=0.42u l=1u
X2995 a_7911_14024# a_7673_14024# a_7803_14024# VSS.t1970 sg13_lv_nmos ad=0.1406p pd=1.12u as=0.2516p ps=2.16u w=0.74u l=0.2u
X2996 VDD.t395 a_4187_2434# a_26911_8160# VDD.t275 sg13_lv_pmos ad=0.3808p pd=2.92u as=0.2128p ps=1.5u w=1.12u l=0.6u
X2997 VDD.t1148 a_15403_1842# a_15837_1842# VDD.t399 sg13_lv_pmos ad=0.2128p pd=1.5u as=0.3808p ps=2.92u w=1.12u l=0.13u
X2998 VSS.t666 a_4187_1764.t139 a_22351_16869# VSS.t1593 sg13_lv_nmos ad=0.2516p pd=2.16u as=0.1406p ps=1.12u w=0.74u l=0.6u
X2999 a_4350_13226# a_5844_13190# a_5768_13226# VDD.t50 sg13_lv_pmos ad=0.3808p pd=2.92u as=0.2128p ps=1.5u w=1.12u l=0.13u
X3000 a_27433_16869# a_27237_16869# VDD.t459 VDD.t297 sg13_lv_pmos ad=0.3808p pd=2.92u as=0.2128p ps=1.5u w=1.12u l=0.13u
X3001 a_25630_16071# a_27991_16035# a_27915_16071# VDD.t4 sg13_lv_pmos ad=0.3808p pd=2.92u as=0.2128p ps=1.5u w=1.12u l=0.13u
X3002 VDD.t757 VDD.t758 VDD.t759 VDD.t301 sg13_lv_pmos ad=0.2128p pd=1.5u as=0 ps=0 w=1.12u l=0.13u
X3003 VDD.t956 a_3171_6737.t6 a_14964_6698# VDD.t41 sg13_lv_pmos ad=0.3808p pd=2.92u as=0.3808p ps=2.92u w=1.12u l=0.13u
X3004 a_16108_3134# a_15765_3308# a_15964_3134# VDD.t0 sg13_lv_pmos ad=0.3808p pd=2.92u as=0.3304p ps=1.71u w=1.12u l=0.13u
X3005 VSS.t2022 a_4187_1764.t125 a_8671_14024# VSS.t2410 sg13_lv_nmos ad=0.2516p pd=2.16u as=0.1406p ps=1.12u w=0.74u l=0.6u
X3006 VSS.t84 a_26043_14024# a_26477_14024# VSS.t2320 sg13_lv_nmos ad=0.1406p pd=1.12u as=0.2516p ps=2.16u w=0.74u l=0.13u
X3007 a_3543_13577# CHAN1_MUX_SEL0 a_3449_13577# VSS.t191 sg13_lv_nmos ad=0.1216p pd=1.02u as=0.2176p ps=1.96u w=0.64u l=0.13u
X3008 a_11848_1044# a_11277_1842# VSS.t563 VSS.t1671 sg13_lv_nmos ad=0.1406p pd=1.12u as=0.2516p ps=2.16u w=0.74u l=0.13u
X3009 CHAN0_MUX_OUT a_16851_15336# VDD.t1328 VDD.t4 sg13_lv_pmos ad=0.2128p pd=1.5u as=0.2086p ps=1.5u w=1.12u l=0.13u
X3010 VSS.t859 VDD.t1684 VSS.t859 VSS.t863 sg13_lv_nmos ad=79.8f pd=0.8u as=0 ps=0 w=0.42u l=1u
X3011 VDD.t780 VDD.t781 VDD.t782 VDD.t293 sg13_lv_pmos ad=0.2128p pd=1.5u as=0 ps=0 w=1.12u l=0.13u
X3012 VSS.t1083 VDD.t1619 VSS.t1083 VSS.t1082 sg13_lv_nmos ad=0.1428p pd=1.52u as=0 ps=0 w=0.42u l=1u
X3013 a_22590_16071# a_23431_16035# a_23355_16071# VDD.t4 sg13_lv_pmos ad=0.3808p pd=2.92u as=0.2128p ps=1.5u w=1.12u l=0.13u
X3014 a_11491_11918# a_10649_11568# a_10232_11561# VDD.t268 sg13_lv_pmos ad=0.2048p pd=1.63u as=0.34p ps=2.68u w=1u l=0.13u
X3015 VSS.t1091 VDD.t1617 VSS.t1089 VSS.t1090 sg13_lv_nmos ad=79.8f pd=0.8u as=0 ps=0 w=0.42u l=1u
X3016 a_6854_11144# a_6326_10280# VDD.t773 VDD.t268 sg13_lv_pmos ad=0.38p pd=2.38u as=0.38p ps=2.38u w=2u l=1u
X3017 VDD.t844 a_3449_1395# a_3747_1047.t0 VDD.t7 sg13_lv_pmos ad=0.4256p pd=3u as=0.2128p ps=1.5u w=1.12u l=0.13u
X3018 VDD.t551 a_8997_16869# a_9465_16071# VDD.t4 sg13_lv_pmos ad=0.252p pd=1.57u as=0.3808p ps=2.92u w=1.12u l=0.13u
X3019 a_13470_1044# a_13444_1008# a_13368_1044# VDD.t7 sg13_lv_pmos ad=0.3808p pd=2.92u as=0.2128p ps=1.5u w=1.12u l=0.13u
X3020 VDD.t535 a_4763_1842# a_5197_1842# VDD.t399 sg13_lv_pmos ad=0.2128p pd=1.5u as=0.3808p ps=2.92u w=1.12u l=0.13u
X3021 a_22590_3889# a_2595_3892.t3 a_23355_3889# VSS.t1396 sg13_lv_nmos ad=0.2516p pd=2.16u as=0.1406p ps=1.12u w=0.74u l=0.13u
X3022 a_27671_4687# a_27433_4687# a_27563_4687# VSS.t2247 sg13_lv_nmos ad=0.1406p pd=1.12u as=0.2516p ps=2.16u w=0.74u l=0.2u
X3023 a_16108_5979# a_26985_6209# a_25630_6734# VDD.t41 sg13_lv_pmos ad=0.3808p pd=2.92u as=0.3808p ps=2.92u w=1.12u l=0.13u
X3024 VDD.t1396 a_15403_14024# a_15837_14024# VDD.t301 sg13_lv_pmos ad=0.2128p pd=1.5u as=0.3808p ps=2.92u w=1.12u l=0.13u
X3025 a_26395_3889# a_26185_3889# VDD.t882 VDD.t0 sg13_lv_pmos ad=0.2128p pd=1.5u as=0.252p ps=1.57u w=1.12u l=0.13u
X3026 VDD.t1608 VSS.t968 VDD.t137 VDD.t41 sg13_lv_pmos ad=0.19p pd=1.38u as=0 ps=0 w=1u l=1u
X3027 a_12471_7532# a_12233_7532# a_12363_7532# VSS.t2243 sg13_lv_nmos ad=0.1406p pd=1.12u as=0.2516p ps=2.16u w=0.74u l=0.2u
X3028 a_19311_5315# a_19073_4687# a_19203_4687# VDD.t281 sg13_lv_pmos ad=0.2128p pd=1.5u as=0.3808p ps=2.92u w=1.12u l=0.2u
X3029 a_11195_6734# a_10985_6734# VDD.t644 VDD.t41 sg13_lv_pmos ad=0.2128p pd=1.5u as=0.252p ps=1.57u w=1.12u l=0.13u
X3030 VDD.t1305 a_3747_3892.t3 a_24951_3853# VDD.t0 sg13_lv_pmos ad=0.3808p pd=2.92u as=0.3808p ps=2.92u w=1.12u l=0.13u
X3031 VDD.t1091 a_2595_13229.t7 a_11271_13190# VDD.t50 sg13_lv_pmos ad=0.3808p pd=2.92u as=0.3808p ps=2.92u w=1.12u l=0.13u
X3032 VSS.t715 a_3171_6737.t5 a_18004_6698# VSS.t1306 sg13_lv_nmos ad=0.2516p pd=2.16u as=0.2516p ps=2.16u w=0.74u l=0.13u
X3033 VDD.t465 a_3171_3156.t3 a_11785_3364# VDD.t0 sg13_lv_pmos ad=0.3808p pd=2.92u as=0.3808p ps=2.92u w=1.12u l=0.13u
X3034 VDD.t582 a_3171_1047.t3 a_24084_1008# VDD.t7 sg13_lv_pmos ad=0.3808p pd=2.92u as=0.3808p ps=2.92u w=1.12u l=0.13u
X3035 a_6153_16869# a_5957_16869# VSS.t276 VSS.t1690 sg13_lv_nmos ad=0.2516p pd=2.16u as=0.1406p ps=1.12u w=0.74u l=0.13u
X3036 a_15755_16071# a_15545_16071# VSS.t62 VSS.t1857 sg13_lv_nmos ad=0.1406p pd=1.12u as=0.1665p ps=1.19u w=0.74u l=0.13u
X3037 a_3449_1395# CHAN3_MUX_SEL0 VDD.t1357 VDD.t7 sg13_lv_pmos ad=0.1596p pd=1.22u as=0.2856p ps=2.36u w=0.84u l=0.13u
X3038 a_2019_12493.t0 a_1721_12513# VDD.t1416 VDD.t50 sg13_lv_pmos ad=0.2128p pd=1.5u as=0.1918p ps=1.5u w=1.12u l=0.13u
X3039 a_1721_16422# a_1256_16071# VDD.t891 VDD.t4 sg13_lv_pmos ad=0.1596p pd=1.22u as=0.2856p ps=2.36u w=0.84u l=0.13u
X3040 a_15273_7532# a_15077_7532# VDD.t1430 VDD.t275 sg13_lv_pmos ad=0.3808p pd=2.92u as=0.2128p ps=1.5u w=1.12u l=0.13u
X3041 VDD.t438 a_4187_2434# a_7911_2470# VDD.t399 sg13_lv_pmos ad=0.3808p pd=2.92u as=0.2128p ps=1.5u w=1.12u l=0.6u
X3042 a_13818_10808# a_12849_11557# VSS.t11 VSS.t12 sg13_lv_nmos ad=37.8f pd=0.6u as=0.1701p ps=1.65u w=0.42u l=0.13u
X3043 a_6391_8160# a_6153_7532# a_6283_7532# VDD.t275 sg13_lv_pmos ad=0.2128p pd=1.5u as=0.3808p ps=2.92u w=1.12u l=0.2u
X3044 VDD.t9 VSS.t1065 VDD.t8 VDD.t7 sg13_lv_pmos ad=0.19p pd=1.38u as=0 ps=0 w=1u l=1u
X3045 VSS.t918 VDD.t1667 VSS.t918 VSS.t919 sg13_lv_nmos ad=79.8f pd=0.8u as=0 ps=0 w=0.42u l=1u
X3046 VSS.t50 a_4187_1764.t49 a_16271_4687# VSS.t2409 sg13_lv_nmos ad=0.2516p pd=2.16u as=0.1406p ps=1.12u w=0.74u l=0.6u
X3047 a_13991_17497# a_13753_16869# a_13883_16869# VDD.t297 sg13_lv_pmos ad=0.2128p pd=1.5u as=0.3808p ps=2.92u w=1.12u l=0.2u
X3048 a_24008_3889# a_23437_4687# VDD.t1580 VDD.t0 sg13_lv_pmos ad=0.2128p pd=1.5u as=0.3808p ps=2.92u w=1.12u l=0.13u
X3049 a_18313_16869# a_18117_16869# VDD.t961 VDD.t297 sg13_lv_pmos ad=0.3808p pd=2.92u as=0.2128p ps=1.5u w=1.12u l=0.13u
X3050 a_14235_6734# a_14025_6734# VSS.t1418 VSS.t1716 sg13_lv_nmos ad=0.1406p pd=1.12u as=0.1665p ps=1.19u w=0.74u l=0.13u
X3051 a_18795_13226# a_18585_13226# VDD.t1055 VDD.t50 sg13_lv_pmos ad=0.2128p pd=1.5u as=0.252p ps=1.57u w=1.12u l=0.13u
X3052 VDD.t300 a_4187_2434# a_14751_17497# VDD.t297 sg13_lv_pmos ad=0.3808p pd=2.92u as=0.2128p ps=1.5u w=1.12u l=0.6u
X3053 VSS.t633 a_3747_6737.t7 a_12791_6698# VSS.t1767 sg13_lv_nmos ad=0.2516p pd=2.16u as=0.2516p ps=2.16u w=0.74u l=0.13u
X3054 VSS.t219 a_26043_4687# a_26477_4687# VSS.t218 sg13_lv_nmos ad=0.1406p pd=1.12u as=0.2516p ps=2.16u w=0.74u l=0.13u
X3055 a_12993_14024# a_12797_14024# VDD.t1386 VDD.t301 sg13_lv_pmos ad=0.3808p pd=2.92u as=0.2128p ps=1.5u w=1.12u l=0.13u
X3056 a_14235_13226# a_14025_13226# VDD.t1288 VDD.t50 sg13_lv_pmos ad=0.2128p pd=1.5u as=0.252p ps=1.57u w=1.12u l=0.13u
X3057 a_23111_5315# a_22873_4687# a_23003_4687# VDD.t281 sg13_lv_pmos ad=0.2128p pd=1.5u as=0.3808p ps=2.92u w=1.12u l=0.2u
X3058 a_9953_7532# a_9757_7532# VSS.t99 VSS.t98 sg13_lv_nmos ad=0.2516p pd=2.16u as=0.1406p ps=1.12u w=0.74u l=0.13u
X3059 VDD.t11 VSS.t1065 VDD.t10 VDD.t7 sg13_lv_pmos ad=0.34p pd=2.68u as=0 ps=0 w=1u l=1u
X3060 VSS.t596 a_10843_7532# a_11277_7532# VSS.t1475 sg13_lv_nmos ad=0.1406p pd=1.12u as=0.2516p ps=2.16u w=0.74u l=0.13u
X3061 VSS.t2360 VSS.t2357 VSS.t2359 VSS.t2358 sg13_lv_nmos ad=0.2516p pd=2.16u as=0 ps=0 w=0.74u l=0.13u
X3062 a_22590_6734# a_23431_6698# a_23355_6734# VDD.t41 sg13_lv_pmos ad=0.3808p pd=2.92u as=0.2128p ps=1.5u w=1.12u l=0.13u
X3063 VDD.t1004 a_17683_4687# a_18117_4687# VDD.t281 sg13_lv_pmos ad=0.2128p pd=1.5u as=0.3808p ps=2.92u w=1.12u l=0.13u
X3064 a_4157_7003# REF_CLK VSS.t205 VSS.t2129 sg13_lv_nmos ad=0.2516p pd=2.16u as=0.2553p ps=2.17u w=0.74u l=0.13u
X3065 a_2595_6001.t0 a_2297_6021# VDD.t625 VDD.t41 sg13_lv_pmos ad=0.2128p pd=1.5u as=0.1918p ps=1.5u w=1.12u l=0.13u
X3066 a_25528_13226# a_24957_14024# VDD.t904 VDD.t50 sg13_lv_pmos ad=0.2128p pd=1.5u as=0.3808p ps=2.92u w=1.12u l=0.13u
X3067 VDD.t522 a_15403_7532# a_15837_7532# VDD.t275 sg13_lv_pmos ad=0.2128p pd=1.5u as=0.3808p ps=2.92u w=1.12u l=0.13u
X3068 VSS.t1740 a_19637_1842# a_20105_1044# VSS.t1960 sg13_lv_nmos ad=0.1665p pd=1.19u as=0.2516p ps=2.16u w=0.74u l=0.13u
X3069 VDD.t569 a_16851_309# CHAN3_MUX_OUT VDD.t7 sg13_lv_pmos ad=0.7336p pd=3.55u as=0.2128p ps=1.5u w=1.12u l=0.13u
X3070 a_10713_4687# a_10517_4687# VDD.t1147 VDD.t281 sg13_lv_pmos ad=0.3808p pd=2.92u as=0.2128p ps=1.5u w=1.12u l=0.13u
X3071 a_21835_16071# a_21625_16071# VDD.t534 VDD.t4 sg13_lv_pmos ad=0.2128p pd=1.5u as=0.252p ps=1.57u w=1.12u l=0.13u
X3072 a_4157_16340# CHAN0_DELAY_IN VSS.t1220 VSS.t1219 sg13_lv_nmos ad=0.2516p pd=2.16u as=0.2553p ps=2.17u w=0.74u l=0.13u
X3073 a_1256_12471# CHAN1_MUX_SEL2 VDD.t1545 VDD.t50 sg13_lv_pmos ad=0.3808p pd=2.92u as=0.3808p ps=2.92u w=1.12u l=0.13u
X3074 VDD.t555 a_18117_1842# a_18585_1044# VDD.t7 sg13_lv_pmos ad=0.252p pd=1.57u as=0.3808p ps=2.92u w=1.12u l=0.13u
X3075 a_27433_14024# a_27237_14024# VDD.t589 VDD.t301 sg13_lv_pmos ad=0.3808p pd=2.92u as=0.2128p ps=1.5u w=1.12u l=0.13u
X3076 a_11848_6734# a_11277_7532# VSS.t721 VSS.t1167 sg13_lv_nmos ad=0.1406p pd=1.12u as=0.2516p ps=2.16u w=0.74u l=0.13u
X3077 VSS.t764 a_3171_311.t2 a_23945_519# VSS.t763 sg13_lv_nmos ad=0.2516p pd=2.16u as=0.2516p ps=2.16u w=0.74u l=0.13u
X3078 VSS.t209 a_4187_1764.t44 a_20071_4687# VSS.t1793 sg13_lv_nmos ad=0.2516p pd=2.16u as=0.1406p ps=1.12u w=0.74u l=0.6u
X3079 a_11711_2470# a_11473_1842# a_11603_1842# VDD.t399 sg13_lv_pmos ad=0.2128p pd=1.5u as=0.3808p ps=2.92u w=1.12u l=0.2u
X3080 VSS.t319 a_2019_3892.t7 a_10404_3853# VSS.t1843 sg13_lv_nmos ad=0.2516p pd=2.16u as=0.2516p ps=2.16u w=0.74u l=0.13u
X3081 VSS.t1224 a_10843_16869# a_11277_16869# VSS.t2142 sg13_lv_nmos ad=0.1406p pd=1.12u as=0.2516p ps=2.16u w=0.74u l=0.13u
X3082 VSS.t1363 a_16597_14024# a_17065_13226# VSS.t2301 sg13_lv_nmos ad=0.1665p pd=1.19u as=0.2516p ps=2.16u w=0.74u l=0.13u
X3083 VDD.t504 a_4763_7532# a_5197_7532# VDD.t275 sg13_lv_pmos ad=0.2128p pd=1.5u as=0.3808p ps=2.92u w=1.12u l=0.13u
X3084 a_27671_1842# a_27433_1842# a_27563_1842# VSS.t1966 sg13_lv_nmos ad=0.1406p pd=1.12u as=0.2516p ps=2.16u w=0.74u l=0.2u
X3085 VDD.t826 a_7803_4687# a_8237_4687# VDD.t281 sg13_lv_pmos ad=0.2128p pd=1.5u as=0.3808p ps=2.92u w=1.12u l=0.13u
X3086 a_7151_16869# a_6913_16869# a_7043_16869# VSS.t1366 sg13_lv_nmos ad=0.1406p pd=1.12u as=0.2516p ps=2.16u w=0.74u l=0.2u
X3087 a_14888_13226# a_14317_14024# VSS.t178 VSS.t2298 sg13_lv_nmos ad=0.1406p pd=1.12u as=0.2516p ps=2.16u w=0.74u l=0.13u
X3088 a_16108_3134# a_26985_3364# a_25630_3889# VDD.t0 sg13_lv_pmos ad=0.3808p pd=2.92u as=0.3808p ps=2.92u w=1.12u l=0.13u
X3089 VDD.t1597 VSS.t1031 VDD.t145 VDD.t0 sg13_lv_pmos ad=0.19p pd=1.38u as=0 ps=0 w=1u l=1u
X3090 a_1256_3889# CHAN2_MUX_SEL0 VDD.t1477 VDD.t0 sg13_lv_pmos ad=0.3808p pd=2.92u as=0.3808p ps=2.92u w=1.12u l=0.13u
X3091 VDD.t1215 a_3747_6001.t2 a_26985_6209# VDD.t41 sg13_lv_pmos ad=0.3808p pd=2.92u as=0.3808p ps=2.92u w=1.12u l=0.13u
X3092 a_13368_16071# a_12797_16869# VSS.t135 VSS.t1369 sg13_lv_nmos ad=0.1406p pd=1.12u as=0.2516p ps=2.16u w=0.74u l=0.13u
X3093 VSS.t2369 VSS.t2366 VSS.t2366 VSS.t2367 sg13_lv_nmos ad=0.1406p pd=1.12u as=0 ps=0 w=0.74u l=0.13u
X3094 a_10328_13226# a_9757_14024# VSS.t1567 VSS.t2033 sg13_lv_nmos ad=0.1406p pd=1.12u as=0.2516p ps=2.16u w=0.74u l=0.13u
X3095 VSS.t334 CHAN3_MUX_SEL4 a_15765_463# VSS.t2408 sg13_lv_nmos ad=0.2516p pd=2.16u as=0.2516p ps=2.16u w=0.74u l=0.13u
X3096 a_24631_14024# a_24393_14024# a_24523_14024# VSS.t1888 sg13_lv_nmos ad=0.1406p pd=1.12u as=0.2516p ps=2.16u w=0.74u l=0.2u
X3097 a_16108_12471# a_2595_12493.t2 a_19550_13226# VSS.t587 sg13_lv_nmos ad=0.2516p pd=2.16u as=0.2516p ps=2.16u w=0.74u l=0.13u
X3098 a_19311_17497# a_19073_16869# a_19203_16869# VDD.t297 sg13_lv_pmos ad=0.2128p pd=1.5u as=0.3808p ps=2.92u w=1.12u l=0.2u
X3099 a_16510_1044# a_2595_1047.t5 a_17275_1044# VSS.t555 sg13_lv_nmos ad=0.2516p pd=2.16u as=0.1406p ps=1.12u w=0.74u l=0.13u
X3100 a_5731_289# a_14825_519# a_13470_1044# VDD.t7 sg13_lv_pmos ad=0.3808p pd=2.92u as=0.3808p ps=2.92u w=1.12u l=0.13u
X3101 a_16510_16071# a_3747_16074.t5 a_18795_16071# VSS.t1629 sg13_lv_nmos ad=0.2516p pd=2.16u as=0.1406p ps=1.12u w=0.74u l=0.13u
X3102 a_13306_11995# a_14111_11568# a_13566_11525# VDD.t268 sg13_lv_pmos ad=0.1428p pd=1.52u as=79.8f ps=0.8u w=0.42u l=0.13u
X3103 VDD.t1319 a_2019_6001.t3 a_5705_6209# VDD.t41 sg13_lv_pmos ad=0.3808p pd=2.92u as=0.3808p ps=2.92u w=1.12u l=0.13u
X3104 a_22590_13226# a_22564_13190# a_22488_13226# VDD.t50 sg13_lv_pmos ad=0.3808p pd=2.92u as=0.2128p ps=1.5u w=1.12u l=0.13u
X3105 a_13470_13226# a_3747_13229.t6 a_15755_13226# VSS.t503 sg13_lv_nmos ad=0.2516p pd=2.16u as=0.1406p ps=1.12u w=0.74u l=0.13u
X3106 a_5974_11413# a_6126_9506# VSS.t18 VSS.t17 sg13_lv_nmos ad=0.38p pd=2.38u as=0.68p ps=4.68u w=2u l=1u
X3107 VDD.t372 a_4187_2434# a_7911_8160# VDD.t275 sg13_lv_pmos ad=0.3808p pd=2.92u as=0.2128p ps=1.5u w=1.12u l=0.6u
X3108 VSS.t1036 VDD.t1633 VSS.t1036 VSS.t1035 sg13_lv_nmos ad=0.1428p pd=1.52u as=0 ps=0 w=0.42u l=1u
X3109 a_26395_3889# a_26185_3889# VSS.t1213 VSS.t1212 sg13_lv_nmos ad=0.1406p pd=1.12u as=0.1665p ps=1.19u w=0.74u l=0.13u
X3110 a_20071_14024# a_19833_14024# a_19963_14024# VSS.t2081 sg13_lv_nmos ad=0.1406p pd=1.12u as=0.2516p ps=2.16u w=0.74u l=0.2u
X3111 VSS.t445 a_4187_1764.t103 a_25391_14024# VSS.t444 sg13_lv_nmos ad=0.2516p pd=2.16u as=0.1406p ps=1.12u w=0.74u l=0.6u
X3112 a_16408_13226# a_15837_14024# VDD.t1402 VDD.t50 sg13_lv_pmos ad=0.2128p pd=1.5u as=0.3808p ps=2.92u w=1.12u l=0.13u
X3113 VDD.t193 VSS.t918 VDD.t192 VDD.t50 sg13_lv_pmos ad=0.34p pd=2.68u as=0 ps=0 w=1u l=1u
X3114 a_13470_3889# a_14964_3853# a_14888_3889# VDD.t0 sg13_lv_pmos ad=0.3808p pd=2.92u as=0.2128p ps=1.5u w=1.12u l=0.13u
X3115 a_1256_16071# CHAN0_MUX_SEL0 VSS.t92 VSS.t2180 sg13_lv_nmos ad=0.2516p pd=2.16u as=0.2516p ps=2.16u w=0.74u l=0.13u
X3116 VDD.t199 VSS.t837 VDD.t198 VDD.t4 sg13_lv_pmos ad=0.19p pd=1.38u as=0 ps=0 w=1u l=1u
X3117 a_13470_16071# a_2595_16074.t6 a_14235_16071# VSS.t1603 sg13_lv_nmos ad=0.2516p pd=2.16u as=0.1406p ps=1.12u w=0.74u l=0.13u
X3118 a_12715_16071# a_12505_16071# VDD.t602 VDD.t4 sg13_lv_pmos ad=0.2128p pd=1.5u as=0.252p ps=1.57u w=1.12u l=0.13u
X3119 VDD.t196 VSS.t764 VDD.t232 VDD.t7 sg13_lv_pmos ad=0.34p pd=2.68u as=0 ps=0 w=1u l=1u
X3120 VSS.t165 a_4187_1764.t17 a_16271_1842# VSS.t164 sg13_lv_nmos ad=0.2516p pd=2.16u as=0.1406p ps=1.12u w=0.74u l=0.6u
X3121 VSS.t657 a_3747_3892.t3 a_24951_3853# VSS.t1943 sg13_lv_nmos ad=0.2516p pd=2.16u as=0.2516p ps=2.16u w=0.74u l=0.13u
X3122 a_13991_14652# a_13753_14024# a_13883_14024# VDD.t301 sg13_lv_pmos ad=0.2128p pd=1.5u as=0.3808p ps=2.92u w=1.12u l=0.2u
X3123 VDD.t581 a_3171_1047.t6 a_14964_1008# VDD.t7 sg13_lv_pmos ad=0.3808p pd=2.92u as=0.3808p ps=2.92u w=1.12u l=0.13u
X3124 a_5731_3134# a_2019_3156.t3 a_4350_3889# VSS.t1520 sg13_lv_nmos ad=0.2516p pd=2.16u as=0.2516p ps=2.16u w=0.74u l=0.13u
X3125 a_18313_14024# a_18117_14024# VDD.t1388 VDD.t301 sg13_lv_pmos ad=0.3808p pd=2.92u as=0.2128p ps=1.5u w=1.12u l=0.13u
X3126 VDD.t1128 a_6326_10280# a_6126_9506# VDD.t268 sg13_lv_pmos ad=0.38p pd=2.38u as=0.38p ps=2.38u w=2u l=1u
X3127 VSS.t1609 a_3747_1047.t2 a_27991_1008# VSS.t1608 sg13_lv_nmos ad=0.2516p pd=2.16u as=0.2516p ps=2.16u w=0.74u l=0.13u
X3128 VDD.t1204 a_10083_1842# a_10517_1842# VDD.t399 sg13_lv_pmos ad=0.2128p pd=1.5u as=0.3808p ps=2.92u w=1.12u l=0.13u
X3129 VDD.t1188 a_25717_16869# a_26185_16071# VDD.t4 sg13_lv_pmos ad=0.252p pd=1.57u as=0.3808p ps=2.92u w=1.12u l=0.13u
X3130 VSS.t363 CHAN1_MUX_SEL4 a_15765_12645# VSS.t362 sg13_lv_nmos ad=0.2516p pd=2.16u as=0.2516p ps=2.16u w=0.74u l=0.13u
X3131 a_9444_10280# a_6854_11144# a_6854_11144# VSS.t2236 sg13_lv_nmos ad=0.68p pd=4.68u as=0.38p ps=2.38u w=2u l=1u
X3132 a_17553_4687# a_17357_4687# VSS.t203 VSS.t2309 sg13_lv_nmos ad=0.2516p pd=2.16u as=0.1406p ps=1.12u w=0.74u l=0.13u
X3133 a_2297_16422# CHAN0_MUX_SEL0 VDD.t1481 VDD.t4 sg13_lv_pmos ad=0.1596p pd=1.22u as=0.2856p ps=2.36u w=0.84u l=0.13u
X3134 a_24008_16071# a_23437_16869# VDD.t1499 VDD.t4 sg13_lv_pmos ad=0.2128p pd=1.5u as=0.3808p ps=2.92u w=1.12u l=0.13u
X3135 a_8671_4687# a_8433_4687# a_8563_4687# VSS.t645 sg13_lv_nmos ad=0.1406p pd=1.12u as=0.2516p ps=2.16u w=0.74u l=0.2u
X3136 VDD.t311 a_4187_2434# a_14751_14652# VDD.t301 sg13_lv_pmos ad=0.3808p pd=2.92u as=0.2128p ps=1.5u w=1.12u l=0.6u
X3137 VDD.t1243 a_2019_3892.t2 a_25604_3853# VDD.t0 sg13_lv_pmos ad=0.3808p pd=2.92u as=0.3808p ps=2.92u w=1.12u l=0.13u
X3138 VSS.t1135 a_3171_16074.t8 a_8884_16035# VSS.t1575 sg13_lv_nmos ad=0.2516p pd=2.16u as=0.2516p ps=2.16u w=0.74u l=0.13u
X3139 VSS.t268 a_26043_1842# a_26477_1842# VSS.t1903 sg13_lv_nmos ad=0.1406p pd=1.12u as=0.2516p ps=2.16u w=0.74u l=0.13u
X3140 VDD.t625 a_1544_5979# a_2297_6021# VDD.t41 sg13_lv_pmos ad=0.1918p pd=1.5u as=0.1596p ps=1.22u w=0.84u l=0.13u
X3141 VDD.t716 a_2019_6737.t7 a_10404_6698# VDD.t41 sg13_lv_pmos ad=0.3808p pd=2.92u as=0.3808p ps=2.92u w=1.12u l=0.13u
X3142 a_16510_13226# a_17351_13190# a_17275_13226# VDD.t50 sg13_lv_pmos ad=0.3808p pd=2.92u as=0.2128p ps=1.5u w=1.12u l=0.13u
X3143 VSS.t1598 a_3747_1047.t9 a_6711_1008# VSS.t1597 sg13_lv_nmos ad=0.2516p pd=2.16u as=0.2516p ps=2.16u w=0.74u l=0.13u
X3144 VSS.t324 a_4187_1764.t137 a_23871_16869# VSS.t1477 sg13_lv_nmos ad=0.2516p pd=2.16u as=0.1406p ps=1.12u w=0.74u l=0.6u
X3145 a_11195_1044# a_10985_1044# VDD.t1276 VDD.t7 sg13_lv_pmos ad=0.2128p pd=1.5u as=0.252p ps=1.57u w=1.12u l=0.13u
X3146 a_24008_3889# a_23437_4687# VSS.t1398 VSS.t2414 sg13_lv_nmos ad=0.1406p pd=1.12u as=0.2516p ps=2.16u w=0.74u l=0.13u
X3147 a_4871_14024# a_4633_14024# a_4763_14024# VSS.t1969 sg13_lv_nmos ad=0.1406p pd=1.12u as=0.2516p ps=2.16u w=0.74u l=0.2u
X3148 VDD.t113 VSS.t880 VDD.t112 VDD.t50 sg13_lv_pmos ad=0.34p pd=2.68u as=0 ps=0 w=1u l=1u
X3149 VSS.t282 a_19637_7532# a_20105_6734# VSS.t2248 sg13_lv_nmos ad=0.1665p pd=1.19u as=0.2516p ps=2.16u w=0.74u l=0.13u
X3150 a_2595_3156.t1 a_2297_3176# VSS.t1144 VSS.t1158 sg13_lv_nmos ad=0.1406p pd=1.12u as=0.1331p ps=1.12u w=0.74u l=0.13u
X3151 a_9193_14024# a_8997_14024# VSS.t2022 VSS.t2036 sg13_lv_nmos ad=0.2516p pd=2.16u as=0.1406p ps=1.12u w=0.74u l=0.13u
X3152 a_16108_289# a_2595_311.t2 a_19550_1044# VSS.t774 sg13_lv_nmos ad=0.2516p pd=2.16u as=0.2516p ps=2.16u w=0.74u l=0.13u
X3153 a_3543_16422# CHAN0_MUX_SEL0 a_3449_16422# VSS.t2182 sg13_lv_nmos ad=0.1216p pd=1.02u as=0.2176p ps=1.96u w=0.64u l=0.13u
X3154 a_22590_16071# a_24951_16035# a_24875_16071# VDD.t4 sg13_lv_pmos ad=0.3808p pd=2.92u as=0.2128p ps=1.5u w=1.12u l=0.13u
X3155 a_21835_3889# a_21625_3889# VDD.t1152 VDD.t0 sg13_lv_pmos ad=0.2128p pd=1.5u as=0.252p ps=1.57u w=1.12u l=0.13u
X3156 VSS.t548 a_4187_1764.t129 a_5631_14024# VSS.t547 sg13_lv_nmos ad=0.2516p pd=2.16u as=0.1406p ps=1.12u w=0.74u l=0.6u
X3157 a_5731_12471# a_3171_12493.t3 a_10430_13226# VSS.t2226 sg13_lv_nmos ad=0.2516p pd=2.16u as=0.2516p ps=2.16u w=0.74u l=0.13u
X3158 a_11711_8160# a_11473_7532# a_11603_7532# VDD.t275 sg13_lv_pmos ad=0.2128p pd=1.5u as=0.3808p ps=2.92u w=1.12u l=0.2u
X3159 VSS.t1320 a_23003_14024# a_23437_14024# VSS.t1358 sg13_lv_nmos ad=0.1406p pd=1.12u as=0.2516p ps=2.16u w=0.74u l=0.13u
X3160 VSS.t1150 a_4187_1764.t12 a_20071_1842# VSS.t1149 sg13_lv_nmos ad=0.2516p pd=2.16u as=0.1406p ps=1.12u w=0.74u l=0.6u
X3161 a_16108_15316# a_2019_15338.t2 a_16510_16071# VSS.t352 sg13_lv_nmos ad=0.2516p pd=2.16u as=0.2516p ps=2.16u w=0.74u l=0.13u
X3162 a_14751_5315# a_14513_4687# a_14643_4687# VDD.t281 sg13_lv_pmos ad=0.2128p pd=1.5u as=0.3808p ps=2.92u w=1.12u l=0.2u
X3163 VDD.t987 a_2595_3892.t4 a_20391_3853# VDD.t0 sg13_lv_pmos ad=0.3808p pd=2.92u as=0.3808p ps=2.92u w=1.12u l=0.13u
X3164 VSS.t849 VDD.t1687 VSS.t849 VSS.t853 sg13_lv_nmos ad=79.8f pd=0.8u as=0 ps=0 w=0.42u l=1u
X3165 a_27671_7532# a_27433_7532# a_27563_7532# VSS.t1446 sg13_lv_nmos ad=0.1406p pd=1.12u as=0.2516p ps=2.16u w=0.74u l=0.2u
X3166 VDD.t433 a_4187_2434# a_24631_2470# VDD.t399 sg13_lv_pmos ad=0.3808p pd=2.92u as=0.2128p ps=1.5u w=1.12u l=0.6u
X3167 a_21353_4687# a_21157_4687# VSS.t502 VSS.t2119 sg13_lv_nmos ad=0.2516p pd=2.16u as=0.1406p ps=1.12u w=0.74u l=0.13u
X3168 VSS.t981 VDD.t1649 VSS.t981 VSS.t983 sg13_lv_nmos ad=79.8f pd=0.8u as=0 ps=0 w=0.42u l=1u
X3169 a_26395_6734# a_26185_6734# VDD.t854 VDD.t41 sg13_lv_pmos ad=0.2128p pd=1.5u as=0.252p ps=1.57u w=1.12u l=0.13u
X3170 VSS.t2325 VSS.t2323 VSS.t95 VSS.t2324 sg13_lv_nmos ad=0.2516p pd=2.16u as=0 ps=0 w=0.74u l=0.13u
X3171 VDD.t801 VDD.t802 VDD.t803 VDD.t281 sg13_lv_pmos ad=0.2128p pd=1.5u as=0 ps=0 w=1.12u l=0.13u
X3172 VDD.t1548 a_3747_3156.t2 a_26985_3364# VDD.t0 sg13_lv_pmos ad=0.3808p pd=2.92u as=0.3808p ps=2.92u w=1.12u l=0.13u
X3173 a_7673_16869# a_7477_16869# VSS.t529 VSS.t2141 sg13_lv_nmos ad=0.2516p pd=2.16u as=0.1406p ps=1.12u w=0.74u l=0.13u
X3174 VDD.t1035 a_10517_4687# a_10985_3889# VDD.t0 sg13_lv_pmos ad=0.252p pd=1.57u as=0.3808p ps=2.92u w=1.12u l=0.13u
X3175 VDD.t1200 a_3747_6737.t3 a_24951_6698# VDD.t41 sg13_lv_pmos ad=0.3808p pd=2.92u as=0.3808p ps=2.92u w=1.12u l=0.13u
X3176 VSS.t442 a_7043_4687# a_7477_4687# VSS.t1166 sg13_lv_nmos ad=0.1406p pd=1.12u as=0.2516p ps=2.16u w=0.74u l=0.13u
X3177 a_4111_5315# CHAN2_DELAY_IN a_4003_4687# VDD.t281 sg13_lv_pmos ad=0.2128p pd=1.5u as=0.3808p ps=2.92u w=1.12u l=0.2u
X3178 a_2019_15338.t0 a_1721_15358# VDD.t1267 VDD.t4 sg13_lv_pmos ad=0.2128p pd=1.5u as=0.1918p ps=1.5u w=1.12u l=0.13u
X3179 a_16510_6734# a_2595_6737.t5 a_17275_6734# VSS.t713 sg13_lv_nmos ad=0.2516p pd=2.16u as=0.1406p ps=1.12u w=0.74u l=0.13u
X3180 a_2019_15338.t1 a_1721_15358# VSS.t1876 VSS.t1908 sg13_lv_nmos ad=0.1406p pd=1.12u as=0.1331p ps=1.12u w=0.74u l=0.13u
X3181 a_19311_14652# a_19073_14024# a_19203_14024# VDD.t301 sg13_lv_pmos ad=0.2128p pd=1.5u as=0.3808p ps=2.92u w=1.12u l=0.2u
X3182 a_11748_11799# DLL_RESETN VDD.t270 VDD.t268 sg13_lv_pmos ad=79.8f pd=0.8u as=1.10612p ps=6.66u w=0.42u l=0.13u
X3183 VDD.t1060 a_2019_3156.t3 a_5705_3364# VDD.t0 sg13_lv_pmos ad=0.3808p pd=2.92u as=0.3808p ps=2.92u w=1.12u l=0.13u
X3184 a_12355_11557# a_12158_11557# VDD.t511 VDD.t268 sg13_lv_pmos ad=0.3808p pd=2.92u as=0.2128p ps=1.5u w=1.12u l=0.13u
X3185 a_22590_1044# a_23431_1008# a_23355_1044# VDD.t7 sg13_lv_pmos ad=0.3808p pd=2.92u as=0.2128p ps=1.5u w=1.12u l=0.13u
X3186 a_1256_3889# CHAN2_MUX_SEL0 VSS.t1741 VSS.t783 sg13_lv_nmos ad=0.2516p pd=2.16u as=0.2516p ps=2.16u w=0.74u l=0.13u
X3187 VDD.t1317 a_2019_6001.t2 a_17865_6209# VDD.t41 sg13_lv_pmos ad=0.3808p pd=2.92u as=0.3808p ps=2.92u w=1.12u l=0.13u
X3188 a_15304_10295# a_14851_11918# VSS.t9 VSS.t8 sg13_lv_nmos ad=0.2849p pd=2.25u as=0.2516p ps=2.16u w=0.74u l=0.13u
X3189 a_2297_3176# CHAN2_MUX_SEL2 VDD.t1493 VDD.t0 sg13_lv_pmos ad=0.1596p pd=1.22u as=0.2856p ps=2.36u w=0.84u l=0.13u
X3190 a_14851_11918# a_14009_11568# a_14757_11918# VSS.t8 sg13_lv_nmos ad=0.12665p pd=1.145u as=0.1428p ps=1.52u w=0.42u l=0.13u
X3191 VSS.t602 a_4187_1764.t81 a_16271_7532# VSS.t601 sg13_lv_nmos ad=0.2516p pd=2.16u as=0.1406p ps=1.12u w=0.74u l=0.6u
X3192 a_24008_6734# a_23437_7532# VDD.t510 VDD.t41 sg13_lv_pmos ad=0.2128p pd=1.5u as=0.3808p ps=2.92u w=1.12u l=0.13u
X3193 VSS.t2331 VSS.t2328 VSS.t2330 VSS.t2329 sg13_lv_nmos ad=0.2516p pd=2.16u as=0 ps=0 w=0.74u l=0.6u
X3194 VSS.t1075 VDD.t1621 VSS.t1075 VSS.t1077 sg13_lv_nmos ad=79.8f pd=0.8u as=0 ps=0 w=0.42u l=1u
X3195 VSS.t611 a_4187_1764.t155 a_10191_16869# VSS.t610 sg13_lv_nmos ad=0.2516p pd=2.16u as=0.1406p ps=1.12u w=0.74u l=0.6u
X3196 a_20593_14024# a_20397_14024# VSS.t619 VSS.t2098 sg13_lv_nmos ad=0.2516p pd=2.16u as=0.1406p ps=1.12u w=0.74u l=0.13u
X3197 VSS.t1765 a_3747_6737.t2 a_27991_6698# VSS.t1764 sg13_lv_nmos ad=0.2516p pd=2.16u as=0.2516p ps=2.16u w=0.74u l=0.13u
X3198 VDD.t836 a_1544_3134# a_1721_3176# VDD.t0 sg13_lv_pmos ad=0.1918p pd=1.5u as=0.1596p ps=1.22u w=0.84u l=0.13u
X3199 a_10951_17497# a_10713_16869# a_10843_16869# VDD.t297 sg13_lv_pmos ad=0.2128p pd=1.5u as=0.3808p ps=2.92u w=1.12u l=0.2u
X3200 VDD.t1468 a_10083_7532# a_10517_7532# VDD.t275 sg13_lv_pmos ad=0.2128p pd=1.5u as=0.3808p ps=2.92u w=1.12u l=0.13u
X3201 a_15273_16869# a_15077_16869# VDD.t458 VDD.t297 sg13_lv_pmos ad=0.3808p pd=2.92u as=0.2128p ps=1.5u w=1.12u l=0.13u
X3202 VSS.t744 a_13883_14024# a_14317_14024# VSS.t2040 sg13_lv_nmos ad=0.1406p pd=1.12u as=0.2516p ps=2.16u w=0.74u l=0.13u
X3203 VSS.t200 a_11491_11918# a_12158_11557# VSS.t636 sg13_lv_nmos ad=0.1406p pd=1.12u as=0.2516p ps=2.16u w=0.74u l=0.13u
X3204 VDD.t612 a_13123_4687# a_13557_4687# VDD.t281 sg13_lv_pmos ad=0.2128p pd=1.5u as=0.3808p ps=2.92u w=1.12u l=0.13u
X3205 a_15755_13226# a_15545_13226# VDD.t1404 VDD.t50 sg13_lv_pmos ad=0.2128p pd=1.5u as=0.252p ps=1.57u w=1.12u l=0.13u
X3206 a_17553_1842# a_17357_1842# VSS.t167 VSS.t1719 sg13_lv_nmos ad=0.2516p pd=2.16u as=0.1406p ps=1.12u w=0.74u l=0.13u
X3207 VSS.t395 a_26043_7532# a_26477_7532# VSS.t394 sg13_lv_nmos ad=0.1406p pd=1.12u as=0.2516p ps=2.16u w=0.74u l=0.13u
X3208 a_8671_1842# a_8433_1842# a_8563_1842# VSS.t1303 sg13_lv_nmos ad=0.1406p pd=1.12u as=0.2516p ps=2.16u w=0.74u l=0.2u
X3209 VSS.t791 a_16851_5999# REF_MUX_OUT VSS.t792 sg13_lv_nmos ad=0.2516p pd=2.16u as=0.1406p ps=1.12u w=0.74u l=0.13u
X3210 VSS.t829 VDD.t1693 VSS.t829 VSS.t833 sg13_lv_nmos ad=79.8f pd=0.8u as=0 ps=0 w=0.42u l=1u
X3211 a_1544_12471# CHAN1_MUX_SEL3 VSS.t121 VSS.t120 sg13_lv_nmos ad=0.2516p pd=2.16u as=0.2516p ps=2.16u w=0.74u l=0.13u
X3212 a_5731_289# a_5705_519# a_4350_1044# VDD.t7 sg13_lv_pmos ad=0.3808p pd=2.92u as=0.3808p ps=2.92u w=1.12u l=0.13u
X3213 a_10430_16071# a_11271_16035# a_11195_16071# VDD.t4 sg13_lv_pmos ad=0.3808p pd=2.92u as=0.2128p ps=1.5u w=1.12u l=0.13u
X3214 VSS.t124 a_3449_12513# a_3747_12493.t1 VSS.t2076 sg13_lv_nmos ad=0.2812p pd=2.24u as=0.1406p ps=1.12u w=0.74u l=0.13u
X3215 a_10520_11982# a_10751_11568# a_10206_11525# VSS.t515 sg13_lv_nmos ad=0.2373p pd=1.97u as=79.8f ps=0.8u w=0.42u l=0.13u
X3216 a_9712_9602# a_13019_11521# a_4187_1764.t1 VSS.t1744 sg13_lv_nmos ad=0.136p pd=1.14u as=0.232p ps=2.08u w=0.4u l=0.2u
X3217 VSS.t111 a_3747_6737.t9 a_6711_6698# VSS.t1762 sg13_lv_nmos ad=0.2516p pd=2.16u as=0.2516p ps=2.16u w=0.74u l=0.13u
X3218 a_13470_3889# a_3171_3892.t6 a_14888_3889# VSS.t1654 sg13_lv_nmos ad=0.2516p pd=2.16u as=0.1406p ps=1.12u w=0.74u l=0.13u
X3219 a_25913_4687# a_25717_4687# VDD.t725 VDD.t281 sg13_lv_pmos ad=0.3808p pd=2.92u as=0.2128p ps=1.5u w=1.12u l=0.13u
X3220 VSS.t25 a_6126_9506# a_5974_11413# VSS.t17 sg13_lv_nmos ad=0.68p pd=4.68u as=0.38p ps=2.38u w=2u l=1u
X3221 VSS.t839 VDD.t1690 VSS.t839 VSS.t842 sg13_lv_nmos ad=0.1428p pd=1.52u as=0 ps=0 w=0.42u l=1u
X3222 VSS.t1019 VDD.t1638 VSS.t79 VSS.t1018 sg13_lv_nmos ad=0.1428p pd=1.52u as=0 ps=0 w=0.42u l=1u
X3223 a_1256_5979# REF_MUX_SEL2 VDD.t726 VDD.t41 sg13_lv_pmos ad=0.3808p pd=2.92u as=0.3808p ps=2.92u w=1.12u l=0.13u
X3224 VDD.t812 VDD.t810 VDD.t811 VDD.t399 sg13_lv_pmos ad=0.3808p pd=2.92u as=0 ps=0 w=1.12u l=0.13u
X3225 VDD.t1397 a_3171_16074.t9 a_5844_16035# VDD.t4 sg13_lv_pmos ad=0.3808p pd=2.92u as=0.3808p ps=2.92u w=1.12u l=0.13u
X3226 a_1256_15316# CHAN0_MUX_SEL2 VDD.t678 VDD.t4 sg13_lv_pmos ad=0.3808p pd=2.92u as=0.3808p ps=2.92u w=1.12u l=0.13u
X3227 a_26911_2470# a_26673_1842# a_26803_1842# VDD.t399 sg13_lv_pmos ad=0.2128p pd=1.5u as=0.3808p ps=2.92u w=1.12u l=0.2u
X3228 VDD.t1241 a_3747_3892.t5 a_18871_3853# VDD.t0 sg13_lv_pmos ad=0.3808p pd=2.92u as=0.3808p ps=2.92u w=1.12u l=0.13u
X3229 VSS.t664 a_12363_16869# a_12797_16869# VSS.t663 sg13_lv_nmos ad=0.1406p pd=1.12u as=0.2516p ps=2.16u w=0.74u l=0.13u
X3230 VSS.t657 a_2019_3892.t2 a_25604_3853# VSS.t1853 sg13_lv_nmos ad=0.2516p pd=2.16u as=0.2516p ps=2.16u w=0.74u l=0.13u
X3231 VSS.t280 a_4187_1764.t76 a_20071_7532# VSS.t279 sg13_lv_nmos ad=0.2516p pd=2.16u as=0.1406p ps=1.12u w=0.74u l=0.6u
X3232 VSS.t1510 a_18117_14024# a_18585_13226# VSS.t2048 sg13_lv_nmos ad=0.1665p pd=1.19u as=0.2516p ps=2.16u w=0.74u l=0.13u
X3233 VDD.t80 VSS.t981 VDD.t79 VDD.t41 sg13_lv_pmos ad=0.19p pd=1.38u as=0 ps=0 w=1u l=1u
X3234 a_8671_16869# a_8433_16869# a_8563_16869# VSS.t530 sg13_lv_nmos ad=0.1406p pd=1.12u as=0.2516p ps=2.16u w=0.74u l=0.2u
X3235 a_2595_6737.t0 a_2297_7085# VDD.t671 VDD.t41 sg13_lv_pmos ad=0.2128p pd=1.5u as=0.1918p ps=1.5u w=1.12u l=0.13u
X3236 a_7390_1044# a_2019_1047.t8 a_7288_1044# VSS.t1316 sg13_lv_nmos ad=0.2516p pd=2.16u as=0.1406p ps=1.12u w=0.74u l=0.13u
X3237 VDD.t368 a_4187_2434# a_24631_8160# VDD.t275 sg13_lv_pmos ad=0.3808p pd=2.92u as=0.2128p ps=1.5u w=1.12u l=0.6u
X3238 VSS.t1282 a_16597_16869# a_17065_16071# VSS.t1281 sg13_lv_nmos ad=0.1665p pd=1.19u as=0.2516p ps=2.16u w=0.74u l=0.13u
X3239 a_14888_16071# a_14317_16869# VSS.t1373 VSS.t1372 sg13_lv_nmos ad=0.1406p pd=1.12u as=0.2516p ps=2.16u w=0.74u l=0.13u
X3240 a_1256_6734# REF_MUX_SEL0 VDD.t571 VDD.t41 sg13_lv_pmos ad=0.3808p pd=2.92u as=0.3808p ps=2.92u w=1.12u l=0.13u
X3241 a_21353_1842# a_21157_1842# VSS.t485 VSS.t1968 sg13_lv_nmos ad=0.2516p pd=2.16u as=0.1406p ps=1.12u w=0.74u l=0.13u
X3242 VSS.t105 a_3171_13229.t2 a_27124_13190# VSS.t104 sg13_lv_nmos ad=0.2516p pd=2.16u as=0.2516p ps=2.16u w=0.74u l=0.13u
X3243 a_13991_4687# a_13753_4687# a_13883_4687# VSS.t522 sg13_lv_nmos ad=0.1406p pd=1.12u as=0.2516p ps=2.16u w=0.74u l=0.2u
X3244 VSS.t60 a_4187_1764.t156 a_9431_16869# VSS.t612 sg13_lv_nmos ad=0.2516p pd=2.16u as=0.1406p ps=1.12u w=0.74u l=0.6u
X3245 a_11848_13226# a_11277_14024# VSS.t238 VSS.t2026 sg13_lv_nmos ad=0.1406p pd=1.12u as=0.2516p ps=2.16u w=0.74u l=0.13u
X3246 VSS.t889 VDD.t1676 VSS.t889 VSS.t890 sg13_lv_nmos ad=79.8f pd=0.8u as=0 ps=0 w=0.42u l=1u
X3247 VSS.t66 a_26803_16869# a_27237_16869# VSS.t2204 sg13_lv_nmos ad=0.1406p pd=1.12u as=0.2516p ps=2.16u w=0.74u l=0.13u
X3248 a_12715_3889# a_12505_3889# VDD.t662 VDD.t0 sg13_lv_pmos ad=0.2128p pd=1.5u as=0.252p ps=1.57u w=1.12u l=0.13u
X3249 a_1815_15358# a_1256_15316# a_1721_15358# VSS.t1896 sg13_lv_nmos ad=0.1216p pd=1.02u as=0.2176p ps=1.96u w=0.64u l=0.13u
X3250 a_10328_16071# a_9757_16869# VSS.t1277 VSS.t1276 sg13_lv_nmos ad=0.1406p pd=1.12u as=0.2516p ps=2.16u w=0.74u l=0.13u
X3251 a_4157_13495# CHAN1_DELAY_IN VDD.t1429 VDD.t50 sg13_lv_pmos ad=0.3808p pd=2.92u as=0.3808p ps=2.92u w=1.12u l=0.13u
X3252 VSS.t627 a_7043_1842# a_7477_1842# VSS.t1157 sg13_lv_nmos ad=0.1406p pd=1.12u as=0.2516p ps=2.16u w=0.74u l=0.13u
X3253 a_17928_3889# a_17357_4687# VDD.t1569 VDD.t0 sg13_lv_pmos ad=0.2128p pd=1.5u as=0.3808p ps=2.92u w=1.12u l=0.13u
X3254 a_21835_3889# a_21625_3889# VSS.t1703 VSS.t1702 sg13_lv_nmos ad=0.1406p pd=1.12u as=0.1665p ps=1.19u w=0.74u l=0.13u
X3255 VDD.t590 a_1544_13226# a_2297_13577# VDD.t50 sg13_lv_pmos ad=0.1918p pd=1.5u as=0.1596p ps=1.22u w=0.84u l=0.13u
X3256 VDD.t443 a_4187_2434# a_15511_2470# VDD.t399 sg13_lv_pmos ad=0.3808p pd=2.92u as=0.2128p ps=1.5u w=1.12u l=0.6u
X3257 a_19550_3889# a_21044_3853# a_20968_3889# VDD.t0 sg13_lv_pmos ad=0.3808p pd=2.92u as=0.2128p ps=1.5u w=1.12u l=0.13u
X3258 VDD.t496 a_2019_1047.t7 a_10404_1008# VDD.t7 sg13_lv_pmos ad=0.3808p pd=2.92u as=0.3808p ps=2.92u w=1.12u l=0.13u
X3259 VSS.t341 a_2595_3892.t4 a_20391_3853# VSS.t1389 sg13_lv_nmos ad=0.2516p pd=2.16u as=0.2516p ps=2.16u w=0.74u l=0.13u
X3260 a_21591_14024# a_21353_14024# a_21483_14024# VSS.t1861 sg13_lv_nmos ad=0.1406p pd=1.12u as=0.2516p ps=2.16u w=0.74u l=0.2u
X3261 VSS.t388 a_4187_1764.t101 a_26911_14024# VSS.t712 sg13_lv_nmos ad=0.2516p pd=2.16u as=0.1406p ps=1.12u w=0.74u l=0.6u
X3262 a_1721_7085# a_1256_6734# VDD.t914 VDD.t41 sg13_lv_pmos ad=0.1596p pd=1.22u as=0.2856p ps=2.36u w=0.84u l=0.13u
X3263 a_16271_17497# a_16033_16869# a_16163_16869# VDD.t297 sg13_lv_pmos ad=0.2128p pd=1.5u as=0.3808p ps=2.92u w=1.12u l=0.2u
X3264 a_13470_16071# a_3747_16074.t6 a_15755_16071# VSS.t2156 sg13_lv_nmos ad=0.2516p pd=2.16u as=0.1406p ps=1.12u w=0.74u l=0.13u
X3265 VDD.t695 a_2873_4240# a_3171_3892.t0 VDD.t0 sg13_lv_pmos ad=0.4256p pd=3u as=0.2128p ps=1.5u w=1.12u l=0.13u
X3266 VSS.t992 VDD.t1645 VSS.t992 VSS.t995 sg13_lv_nmos ad=0.1428p pd=1.52u as=0 ps=0 w=0.42u l=1u
X3267 a_13470_6734# a_14964_6698# a_14888_6734# VDD.t41 sg13_lv_pmos ad=0.3808p pd=2.92u as=0.2128p ps=1.5u w=1.12u l=0.13u
X3268 VDD.t1061 a_2019_3156.t2 a_17865_3364# VDD.t0 sg13_lv_pmos ad=0.3808p pd=2.92u as=0.3808p ps=2.92u w=1.12u l=0.13u
X3269 a_7288_3889# a_6717_4687# VDD.t735 VDD.t0 sg13_lv_pmos ad=0.2128p pd=1.5u as=0.3808p ps=2.92u w=1.12u l=0.13u
X3270 VDD.t536 a_1544_16071# a_1721_16422# VDD.t4 sg13_lv_pmos ad=0.1918p pd=1.5u as=0.1596p ps=1.22u w=0.84u l=0.13u
X3271 VSS.t1236 a_4187_1764.t107 a_22351_14024# VSS.t2219 sg13_lv_nmos ad=0.2516p pd=2.16u as=0.1406p ps=1.12u w=0.74u l=0.6u
X3272 VDD.t1292 a_25283_1842# a_25717_1842# VDD.t399 sg13_lv_pmos ad=0.2128p pd=1.5u as=0.3808p ps=2.92u w=1.12u l=0.13u
X3273 VDD.t460 a_27237_16869# a_27705_16071# VDD.t4 sg13_lv_pmos ad=0.252p pd=1.57u as=0.3808p ps=2.92u w=1.12u l=0.13u
X3274 a_13368_13226# a_12797_14024# VDD.t1392 VDD.t50 sg13_lv_pmos ad=0.2128p pd=1.5u as=0.3808p ps=2.92u w=1.12u l=0.13u
X3275 VDD.t1590 VSS.t909 VDD.t1589 VDD.t50 sg13_lv_pmos ad=0.34p pd=2.68u as=0 ps=0 w=1u l=1u
X3276 VSS.t1485 a_10517_4687# a_10985_3889# VSS.t2257 sg13_lv_nmos ad=0.1665p pd=1.19u as=0.2516p ps=2.16u w=0.74u l=0.13u
X3277 VDD.t314 a_4187_2434# a_17031_17497# VDD.t297 sg13_lv_pmos ad=0.3808p pd=2.92u as=0.2128p ps=1.5u w=1.12u l=0.6u
X3278 VDD.t1604 VSS.t869 VDD.t1603 VDD.t4 sg13_lv_pmos ad=0.34p pd=2.68u as=0 ps=0 w=1u l=1u
X3279 a_10951_14652# a_10713_14024# a_10843_14024# VDD.t301 sg13_lv_pmos ad=0.2128p pd=1.5u as=0.3808p ps=2.92u w=1.12u l=0.2u
X3280 a_15273_14024# a_15077_14024# VDD.t1405 VDD.t301 sg13_lv_pmos ad=0.3808p pd=2.92u as=0.2128p ps=1.5u w=1.12u l=0.13u
X3281 VSS.t23 a_6126_9506# a_5974_11413# VSS.t17 sg13_lv_nmos ad=0.76p pd=4.76u as=0.38p ps=2.38u w=2u l=1u
X3282 a_17553_7532# a_17357_7532# VSS.t1189 VSS.t1440 sg13_lv_nmos ad=0.2516p pd=2.16u as=0.1406p ps=1.12u w=0.74u l=0.13u
X3283 VDD.t1122 a_22677_16869# a_23145_16071# VDD.t4 sg13_lv_pmos ad=0.252p pd=1.57u as=0.3808p ps=2.92u w=1.12u l=0.13u
X3284 a_8671_7532# a_8433_7532# a_8563_7532# VSS.t606 sg13_lv_nmos ad=0.1406p pd=1.12u as=0.2516p ps=2.16u w=0.74u l=0.2u
X3285 VDD.t429 a_4187_2434# a_5631_2470# VDD.t399 sg13_lv_pmos ad=0.3808p pd=2.92u as=0.2128p ps=1.5u w=1.12u l=0.6u
X3286 VDD.t477 a_2019_6737.t2 a_25604_6698# VDD.t41 sg13_lv_pmos ad=0.3808p pd=2.92u as=0.3808p ps=2.92u w=1.12u l=0.13u
X3287 a_20968_16071# a_20397_16869# VDD.t978 VDD.t4 sg13_lv_pmos ad=0.2128p pd=1.5u as=0.3808p ps=2.92u w=1.12u l=0.13u
X3288 a_16510_13226# a_18871_13190# a_18795_13226# VDD.t50 sg13_lv_pmos ad=0.3808p pd=2.92u as=0.2128p ps=1.5u w=1.12u l=0.13u
X3289 a_10232_11561# a_10751_11568# a_11491_11918# VSS.t516 sg13_lv_nmos ad=0.3473p pd=2.71u as=0.12665p ps=1.145u w=0.74u l=0.13u
X3290 a_26395_1044# a_26185_1044# VDD.t1334 VDD.t7 sg13_lv_pmos ad=0.2128p pd=1.5u as=0.252p ps=1.57u w=1.12u l=0.13u
X3291 a_24393_16869# a_24197_16869# VSS.t324 VSS.t323 sg13_lv_nmos ad=0.2516p pd=2.16u as=0.1406p ps=1.12u w=0.74u l=0.13u
X3292 VSS.t1003 VDD.t1643 VSS.t1001 VSS.t1002 sg13_lv_nmos ad=0.1428p pd=1.52u as=0 ps=0 w=0.42u l=1u
X3293 VSS.t271 a_12363_4687# a_12797_4687# VSS.t469 sg13_lv_nmos ad=0.1406p pd=1.12u as=0.2516p ps=2.16u w=0.74u l=0.13u
X3294 a_22590_3889# a_24951_3853# a_24875_3889# VDD.t0 sg13_lv_pmos ad=0.3808p pd=2.92u as=0.2128p ps=1.5u w=1.12u l=0.13u
X3295 VDD.t289 a_1544_3889# a_2297_4240# VDD.t0 sg13_lv_pmos ad=0.1918p pd=1.5u as=0.1596p ps=1.22u w=0.84u l=0.13u
X3296 VSS.t624 a_17683_16869# a_18117_16869# VSS.t1341 sg13_lv_nmos ad=0.1406p pd=1.12u as=0.2516p ps=2.16u w=0.74u l=0.13u
X3297 a_1256_13226# CHAN1_MUX_SEL0 VDD.t507 VDD.t50 sg13_lv_pmos ad=0.3808p pd=2.92u as=0.3808p ps=2.92u w=1.12u l=0.13u
X3298 VDD.t221 VSS.t819 VDD.t219 VDD.t4 sg13_lv_pmos ad=0.19p pd=1.38u as=0 ps=0 w=1u l=1u
X3299 a_13470_13226# a_14311_13190# a_14235_13226# VDD.t50 sg13_lv_pmos ad=0.3808p pd=2.92u as=0.2128p ps=1.5u w=1.12u l=0.13u
X3300 VDD.t1078 a_3747_1047.t3 a_24951_1008# VDD.t7 sg13_lv_pmos ad=0.3808p pd=2.92u as=0.3808p ps=2.92u w=1.12u l=0.13u
X3301 a_1256_3134# CHAN2_MUX_SEL2 VDD.t1491 VDD.t0 sg13_lv_pmos ad=0.3808p pd=2.92u as=0.3808p ps=2.92u w=1.12u l=0.13u
X3302 a_2595_6001.t1 a_2297_6021# VSS.t477 VSS.t55 sg13_lv_nmos ad=0.1406p pd=1.12u as=0.1331p ps=1.12u w=0.74u l=0.13u
X3303 VSS.t243 a_4187_1764.t141 a_20831_16869# VSS.t1791 sg13_lv_nmos ad=0.2516p pd=2.16u as=0.1406p ps=1.12u w=0.74u l=0.6u
X3304 a_2019_3892.t0 a_1721_4240# VDD.t1470 VDD.t0 sg13_lv_pmos ad=0.2128p pd=1.5u as=0.1918p ps=1.5u w=1.12u l=0.13u
X3305 VDD.t790 VDD.t788 VDD.t789 VDD.t275 sg13_lv_pmos ad=0.3808p pd=2.92u as=0 ps=0 w=1.12u l=0.13u
X3306 a_6153_14024# a_5957_14024# VSS.t548 VSS.t1988 sg13_lv_nmos ad=0.2516p pd=2.16u as=0.1406p ps=1.12u w=0.74u l=0.13u
X3307 a_26911_8160# a_26673_7532# a_26803_7532# VDD.t275 sg13_lv_pmos ad=0.2128p pd=1.5u as=0.3808p ps=2.92u w=1.12u l=0.2u
X3308 VDD.t1167 a_19203_16869# a_19637_16869# VDD.t297 sg13_lv_pmos ad=0.2128p pd=1.5u as=0.3808p ps=2.92u w=1.12u l=0.13u
X3309 a_21835_6734# a_21625_6734# VDD.t619 VDD.t41 sg13_lv_pmos ad=0.2128p pd=1.5u as=0.252p ps=1.57u w=1.12u l=0.13u
X3310 a_19550_16071# a_21911_16035# a_21835_16071# VDD.t4 sg13_lv_pmos ad=0.3808p pd=2.92u as=0.2128p ps=1.5u w=1.12u l=0.13u
X3311 VDD.t1071 a_3171_13229.t8 a_8884_13190# VDD.t50 sg13_lv_pmos ad=0.3808p pd=2.92u as=0.3808p ps=2.92u w=1.12u l=0.13u
X3312 VDD.t164 VSS.t925 VDD.t163 VDD.t50 sg13_lv_pmos ad=0.34p pd=2.68u as=0 ps=0 w=1u l=1u
X3313 a_7390_6734# a_2019_6737.t8 a_7288_6734# VSS.t109 sg13_lv_nmos ad=0.2516p pd=2.16u as=0.1406p ps=1.12u w=0.74u l=0.13u
X3314 VDD.t257 VSS.t1105 VDD.t253 VDD.t7 sg13_lv_pmos ad=0.19p pd=1.38u as=0 ps=0 w=1u l=1u
X3315 VDD.t1080 VSS.t1044 VDD.t240 VDD.t0 sg13_lv_pmos ad=0.19p pd=1.38u as=0 ps=0 w=1u l=1u
X3316 a_5731_15316# a_3747_15338.t3 a_13470_16071# VSS.t603 sg13_lv_nmos ad=0.2516p pd=2.16u as=0.2516p ps=2.16u w=0.74u l=0.13u
X3317 VDD.t711 a_2595_6737.t4 a_20391_6698# VDD.t41 sg13_lv_pmos ad=0.3808p pd=2.92u as=0.3808p ps=2.92u w=1.12u l=0.13u
X3318 VDD.t837 a_1721_3176# a_2019_3156.t0 VDD.t0 sg13_lv_pmos ad=0.4256p pd=3u as=0.2128p ps=1.5u w=1.12u l=0.13u
X3319 a_21353_7532# a_21157_7532# VSS.t163 VSS.t1682 sg13_lv_nmos ad=0.2516p pd=2.16u as=0.1406p ps=1.12u w=0.74u l=0.13u
X3320 a_24008_1044# a_23437_1842# VDD.t1278 VDD.t7 sg13_lv_pmos ad=0.2128p pd=1.5u as=0.3808p ps=2.92u w=1.12u l=0.13u
X3321 CHAN2_DELAY_OUT_LAST a_27997_4687# VDD.t576 VDD.t281 sg13_lv_pmos ad=0.3808p pd=2.92u as=0.2128p ps=1.5u w=1.12u l=0.13u
X3322 a_13991_1842# a_13753_1842# a_13883_1842# VSS.t1670 sg13_lv_nmos ad=0.1406p pd=1.12u as=0.2516p ps=2.16u w=0.74u l=0.2u
X3323 VDD.t882 a_25717_4687# a_26185_3889# VDD.t0 sg13_lv_pmos ad=0.252p pd=1.57u as=0.3808p ps=2.92u w=1.12u l=0.13u
X3324 a_1815_12513# a_1256_12471# a_1721_12513# VSS.t2303 sg13_lv_nmos ad=0.1216p pd=1.02u as=0.2176p ps=1.96u w=0.64u l=0.13u
X3325 VSS.t468 a_7043_7532# a_7477_7532# VSS.t467 sg13_lv_nmos ad=0.1406p pd=1.12u as=0.2516p ps=2.16u w=0.74u l=0.13u
X3326 VDD.t644 a_10517_7532# a_10985_6734# VDD.t41 sg13_lv_pmos ad=0.252p pd=1.57u as=0.3808p ps=2.92u w=1.12u l=0.13u
X3327 VSS.t144 a_2019_1047.t4 a_19524_1008# VSS.t143 sg13_lv_nmos ad=0.2516p pd=2.16u as=0.2516p ps=2.16u w=0.74u l=0.13u
X3328 VSS.t113 a_3747_3892.t5 a_18871_3853# VSS.t1849 sg13_lv_nmos ad=0.2516p pd=2.16u as=0.2516p ps=2.16u w=0.74u l=0.13u
X3329 a_4633_16869# a_4437_16869# VSS.t161 VSS.t2197 sg13_lv_nmos ad=0.2516p pd=2.16u as=0.1406p ps=1.12u w=0.74u l=0.13u
X3330 VDD.t1578 VSS.t1081 VDD.t245 VDD.t7 sg13_lv_pmos ad=0.19p pd=1.38u as=0 ps=0 w=1u l=1u
X3331 VDD.t554 a_13557_16869# a_14025_16071# VDD.t4 sg13_lv_pmos ad=0.252p pd=1.57u as=0.3808p ps=2.92u w=1.12u l=0.13u
X3332 VDD.t111 VSS.t880 VDD.t110 VDD.t50 sg13_lv_pmos ad=0.19p pd=1.38u as=0 ps=0 w=1u l=1u
X3333 VDD.t389 a_4187_2434# a_15511_8160# VDD.t275 sg13_lv_pmos ad=0.3808p pd=2.92u as=0.2128p ps=1.5u w=1.12u l=0.6u
X3334 VDD.t45 VSS.t992 VDD.t44 VDD.t41 sg13_lv_pmos ad=0.34p pd=2.68u as=0 ps=0 w=1u l=1u
X3335 VDD.t696 a_4437_4687# a_4905_3889# VDD.t0 sg13_lv_pmos ad=0.252p pd=1.57u as=0.3808p ps=2.92u w=1.12u l=0.13u
X3336 a_6913_4687# a_6717_4687# VDD.t734 VDD.t281 sg13_lv_pmos ad=0.3808p pd=2.92u as=0.2128p ps=1.5u w=1.12u l=0.13u
X3337 a_16108_12471# a_17865_12701# a_16510_13226# VDD.t50 sg13_lv_pmos ad=0.3808p pd=2.92u as=0.3808p ps=2.92u w=1.12u l=0.13u
X3338 a_15964_12471# a_15765_12645# a_5731_12471# VSS.t361 sg13_lv_nmos ad=0.2183p pd=1.33u as=0.2516p ps=2.16u w=0.74u l=0.13u
X3339 VDD.t303 a_4187_2434# a_18551_5315# VDD.t281 sg13_lv_pmos ad=0.3808p pd=2.92u as=0.2128p ps=1.5u w=1.12u l=0.6u
X3340 a_16271_14652# a_16033_14024# a_16163_14024# VDD.t301 sg13_lv_pmos ad=0.2128p pd=1.5u as=0.3808p ps=2.92u w=1.12u l=0.2u
X3341 VSS.t1468 a_9444_10280# a_9444_9602# VSS.t1462 sg13_lv_nmos ad=0.68p pd=4.68u as=0.38p ps=2.38u w=2u l=1u
X3342 VSS.t1161 CHAN3_MUX_SEL1 a_3543_1395# VSS.t2101 sg13_lv_nmos ad=0.1331p pd=1.12u as=0.1216p ps=1.02u w=0.64u l=0.13u
X3343 a_4157_4158# CHAN2_DELAY_IN VSS.t34 VSS.t1777 sg13_lv_nmos ad=0.2516p pd=2.16u as=0.2553p ps=2.17u w=0.74u l=0.13u
X3344 a_16793_1842# a_16597_1842# VDD.t1113 VDD.t399 sg13_lv_pmos ad=0.3808p pd=2.92u as=0.2128p ps=1.5u w=1.12u l=0.13u
X3345 a_2391_15358# CHAN0_MUX_SEL2 a_2297_15358# VSS.t190 sg13_lv_nmos ad=0.1216p pd=1.02u as=0.2176p ps=1.96u w=0.64u l=0.13u
X3346 a_7911_2470# a_7673_1842# a_7803_1842# VDD.t399 sg13_lv_pmos ad=0.2128p pd=1.5u as=0.3808p ps=2.92u w=1.12u l=0.2u
X3347 VSS.t943 VDD.t1659 VSS.t946 VSS.t945 sg13_lv_nmos ad=79.8f pd=0.8u as=0 ps=0 w=0.42u l=1u
X3348 VSS.t415 a_4187_1764.t153 a_11711_16869# VSS.t1584 sg13_lv_nmos ad=0.2516p pd=2.16u as=0.1406p ps=1.12u w=0.74u l=0.6u
X3349 VDD.t823 a_25283_7532# a_25717_7532# VDD.t275 sg13_lv_pmos ad=0.2128p pd=1.5u as=0.3808p ps=2.92u w=1.12u l=0.13u
X3350 a_12715_3889# a_12505_3889# VSS.t609 VSS.t2308 sg13_lv_nmos ad=0.1406p pd=1.12u as=0.1665p ps=1.19u w=0.74u l=0.13u
X3351 a_16793_16869# a_16597_16869# VDD.t924 VDD.t297 sg13_lv_pmos ad=0.3808p pd=2.92u as=0.2128p ps=1.5u w=1.12u l=0.13u
X3352 VDD.t354 a_4187_2434# a_17031_14652# VDD.t301 sg13_lv_pmos ad=0.3808p pd=2.92u as=0.2128p ps=1.5u w=1.12u l=0.6u
X3353 a_15755_1044# a_15545_1044# VSS.t1327 VSS.t1326 sg13_lv_nmos ad=0.1406p pd=1.12u as=0.1665p ps=1.19u w=0.74u l=0.13u
X3354 a_17928_3889# a_17357_4687# VSS.t1350 VSS.t2310 sg13_lv_nmos ad=0.1406p pd=1.12u as=0.2516p ps=2.16u w=0.74u l=0.13u
X3355 a_16271_4687# a_16033_4687# a_16163_4687# VSS.t1169 sg13_lv_nmos ad=0.1406p pd=1.12u as=0.2516p ps=2.16u w=0.74u l=0.2u
X3356 a_25391_16869# a_25153_16869# a_25283_16869# VSS.t1297 sg13_lv_nmos ad=0.1406p pd=1.12u as=0.2516p ps=2.16u w=0.74u l=0.2u
X3357 VDD.t541 a_1256_13226# a_2873_13577# VDD.t50 sg13_lv_pmos ad=0.1918p pd=1.5u as=0.1596p ps=1.22u w=0.84u l=0.13u
X3358 a_10430_16071# a_12791_16035# a_12715_16071# VDD.t4 sg13_lv_pmos ad=0.3808p pd=2.92u as=0.2128p ps=1.5u w=1.12u l=0.13u
X3359 VDD.t966 a_3171_3892.t8 a_8884_3853# VDD.t0 sg13_lv_pmos ad=0.3808p pd=2.92u as=0.3808p ps=2.92u w=1.12u l=0.13u
X3360 a_19550_3889# a_3171_3892.t4 a_20968_3889# VSS.t1356 sg13_lv_nmos ad=0.2516p pd=2.16u as=0.1406p ps=1.12u w=0.74u l=0.13u
X3361 a_12233_16869# a_12037_16869# VDD.t603 VDD.t297 sg13_lv_pmos ad=0.3808p pd=2.92u as=0.2128p ps=1.5u w=1.12u l=0.13u
X3362 VDD.t379 a_4187_2434# a_5631_8160# VDD.t275 sg13_lv_pmos ad=0.3808p pd=2.92u as=0.2128p ps=1.5u w=1.12u l=0.6u
X3363 VSS.t575 a_2595_1047.t6 a_14311_1008# VSS.t574 sg13_lv_nmos ad=0.2516p pd=2.16u as=0.2516p ps=2.16u w=0.74u l=0.13u
X3364 a_2595_1047.t0 a_2297_1395# VDD.t539 VDD.t7 sg13_lv_pmos ad=0.2128p pd=1.5u as=0.1918p ps=1.5u w=1.12u l=0.13u
X3365 VSS.t689 VDD.t1686 VSS.t855 VSS.t854 sg13_lv_nmos ad=0.1428p pd=1.52u as=0 ps=0 w=0.42u l=1u
X3366 VSS.t1650 a_10843_14024# a_11277_14024# VSS.t2000 sg13_lv_nmos ad=0.1406p pd=1.12u as=0.2516p ps=2.16u w=0.74u l=0.13u
X3367 VSS.t1292 a_4187_1764.t134 a_26151_16869# VSS.t1360 sg13_lv_nmos ad=0.2516p pd=2.16u as=0.1406p ps=1.12u w=0.74u l=0.6u
X3368 a_1256_1044# CHAN3_MUX_SEL0 VDD.t1358 VDD.t7 sg13_lv_pmos ad=0.3808p pd=2.92u as=0.3808p ps=2.92u w=1.12u l=0.13u
X3369 a_7151_14024# a_6913_14024# a_7043_14024# VSS.t1991 sg13_lv_nmos ad=0.1406p pd=1.12u as=0.2516p ps=2.16u w=0.74u l=0.2u
X3370 VSS.t1573 a_12363_1842# a_12797_1842# VSS.t1758 sg13_lv_nmos ad=0.1406p pd=1.12u as=0.2516p ps=2.16u w=0.74u l=0.13u
X3371 a_5115_1044# a_4905_1044# VSS.t1323 VSS.t1322 sg13_lv_nmos ad=0.1406p pd=1.12u as=0.1665p ps=1.19u w=0.74u l=0.13u
X3372 a_7288_3889# a_6717_4687# VSS.t798 VSS.t797 sg13_lv_nmos ad=0.1406p pd=1.12u as=0.2516p ps=2.16u w=0.74u l=0.13u
X3373 VDD.t1431 a_2019_16074.t8 a_7364_16035# VDD.t4 sg13_lv_pmos ad=0.3808p pd=2.92u as=0.3808p ps=2.92u w=1.12u l=0.13u
X3374 VSS.t966 VDD.t1653 VSS.t965 VSS.t964 sg13_lv_nmos ad=0.1428p pd=1.52u as=0 ps=0 w=0.42u l=1u
X3375 VDD.t425 a_4187_2434# a_22351_5315# VDD.t281 sg13_lv_pmos ad=0.3808p pd=2.92u as=0.2128p ps=1.5u w=1.12u l=0.6u
X3376 VSS.t829 VDD.t1693 VSS.t829 VSS.t832 sg13_lv_nmos ad=0.1428p pd=1.52u as=0 ps=0 w=0.42u l=1u
X3377 VDD.t1339 a_27563_1842# a_27997_1842# VDD.t399 sg13_lv_pmos ad=0.2128p pd=1.5u as=0.3808p ps=2.92u w=1.12u l=0.13u
X3378 a_5731_5979# a_5705_6209# a_4350_6734# VDD.t41 sg13_lv_pmos ad=0.3808p pd=2.92u as=0.3808p ps=2.92u w=1.12u l=0.13u
X3379 a_20593_1842# a_20397_1842# VDD.t1249 VDD.t399 sg13_lv_pmos ad=0.3808p pd=2.92u as=0.2128p ps=1.5u w=1.12u l=0.13u
X3380 VDD.t1411 a_19203_14024# a_19637_14024# VDD.t301 sg13_lv_pmos ad=0.2128p pd=1.5u as=0.3808p ps=2.92u w=1.12u l=0.13u
X3381 VDD.t618 a_3747_6737.t5 a_18871_6698# VDD.t41 sg13_lv_pmos ad=0.3808p pd=2.92u as=0.3808p ps=2.92u w=1.12u l=0.13u
X3382 a_2967_3176# CHAN2_MUX_SEL3 a_2873_3176# VSS.t32 sg13_lv_nmos ad=0.1216p pd=1.02u as=0.2176p ps=1.96u w=0.64u l=0.13u
X3383 VSS.t1751 a_18117_16869# a_18585_16071# VSS.t1750 sg13_lv_nmos ad=0.1665p pd=1.19u as=0.2516p ps=2.16u w=0.74u l=0.13u
X3384 a_1721_1395# a_1256_1044# VDD.t873 VDD.t7 sg13_lv_pmos ad=0.1596p pd=1.22u as=0.2856p ps=2.36u w=0.84u l=0.13u
X3385 a_20071_4687# a_19833_4687# a_19963_4687# VSS.t634 sg13_lv_nmos ad=0.1406p pd=1.12u as=0.2516p ps=2.16u w=0.74u l=0.2u
X3386 VSS.t2073 a_15077_14024# a_15545_13226# VSS.t2072 sg13_lv_nmos ad=0.1665p pd=1.19u as=0.2516p ps=2.16u w=0.74u l=0.13u
X3387 a_13470_1044# a_14964_1008# a_14888_1044# VDD.t7 sg13_lv_pmos ad=0.3808p pd=2.92u as=0.2128p ps=1.5u w=1.12u l=0.13u
X3388 VDD.t463 a_6283_1842# a_6717_1842# VDD.t399 sg13_lv_pmos ad=0.2128p pd=1.5u as=0.3808p ps=2.92u w=1.12u l=0.13u
X3389 a_22590_3889# a_3747_3892.t3 a_24875_3889# VSS.t1942 sg13_lv_nmos ad=0.2516p pd=2.16u as=0.1406p ps=1.12u w=0.74u l=0.13u
X3390 a_27915_3889# a_27705_3889# VDD.t733 VDD.t0 sg13_lv_pmos ad=0.2128p pd=1.5u as=0.252p ps=1.57u w=1.12u l=0.13u
X3391 VSS.t676 a_14643_4687# a_15077_4687# VSS.t2191 sg13_lv_nmos ad=0.1406p pd=1.12u as=0.2516p ps=2.16u w=0.74u l=0.13u
X3392 VSS.t42 a_3171_16074.t2 a_27124_16035# VSS.t2065 sg13_lv_nmos ad=0.2516p pd=2.16u as=0.2516p ps=2.16u w=0.74u l=0.13u
X3393 a_13991_7532# a_13753_7532# a_13883_7532# VSS.t54 sg13_lv_nmos ad=0.1406p pd=1.12u as=0.2516p ps=2.16u w=0.74u l=0.2u
X3394 a_11848_16071# a_11277_16869# VSS.t421 VSS.t1225 sg13_lv_nmos ad=0.1406p pd=1.12u as=0.2516p ps=2.16u w=0.74u l=0.13u
X3395 a_2019_13229.t0 a_1721_13577# VDD.t607 VDD.t50 sg13_lv_pmos ad=0.2128p pd=1.5u as=0.1918p ps=1.5u w=1.12u l=0.13u
X3396 a_12715_6734# a_12505_6734# VDD.t579 VDD.t41 sg13_lv_pmos ad=0.2128p pd=1.5u as=0.252p ps=1.57u w=1.12u l=0.13u
X3397 VSS.t181 a_3171_13229.t3 a_24084_13190# VSS.t1829 sg13_lv_nmos ad=0.2516p pd=2.16u as=0.2516p ps=2.16u w=0.74u l=0.13u
X3398 VSS.t1089 VDD.t1617 VSS.t779 VSS.t1088 sg13_lv_nmos ad=0.1428p pd=1.52u as=0 ps=0 w=0.42u l=1u
X3399 a_4157_16340# CHAN0_DELAY_IN VDD.t886 VDD.t4 sg13_lv_pmos ad=0.3808p pd=2.92u as=0.3808p ps=2.92u w=1.12u l=0.13u
X3400 VSS.t464 a_2019_6737.t4 a_19524_6698# VSS.t738 sg13_lv_nmos ad=0.2516p pd=2.16u as=0.2516p ps=2.16u w=0.74u l=0.13u
X3401 a_17928_6734# a_17357_7532# VDD.t1009 VDD.t41 sg13_lv_pmos ad=0.2128p pd=1.5u as=0.3808p ps=2.92u w=1.12u l=0.13u
X3402 VSS.t839 VDD.t1691 VSS.t839 VSS.t841 sg13_lv_nmos ad=79.8f pd=0.8u as=0 ps=0 w=0.42u l=1u
X3403 VDD.t948 a_2019_1047.t2 a_25604_1008# VDD.t7 sg13_lv_pmos ad=0.3808p pd=2.92u as=0.3808p ps=2.92u w=1.12u l=0.13u
X3404 VDD.t32 VSS.t1056 VDD.t31 VDD.t0 sg13_lv_pmos ad=0.34p pd=2.68u as=0 ps=0 w=1u l=1u
X3405 a_17791_17497# a_17553_16869# a_17683_16869# VDD.t297 sg13_lv_pmos ad=0.2128p pd=1.5u as=0.3808p ps=2.92u w=1.12u l=0.2u
X3406 a_19550_6734# a_21044_6698# a_20968_6734# VDD.t41 sg13_lv_pmos ad=0.3808p pd=2.92u as=0.2128p ps=1.5u w=1.12u l=0.13u
X3407 VDD.t60 VSS.t946 VDD.t59 VDD.t41 sg13_lv_pmos ad=0.19p pd=1.38u as=0 ps=0 w=1u l=1u
X3408 VSS.t1400 a_4187_1764.t105 a_23871_14024# VSS.t2109 sg13_lv_nmos ad=0.2516p pd=2.16u as=0.1406p ps=1.12u w=0.74u l=0.6u
X3409 VDD.t970 a_16597_14024# a_17065_13226# VDD.t50 sg13_lv_pmos ad=0.252p pd=1.57u as=0.3808p ps=2.92u w=1.12u l=0.13u
X3410 VSS.t1433 REF_MUX_SEL1 a_3543_7085# VSS.t2125 sg13_lv_nmos ad=0.1331p pd=1.12u as=0.1216p ps=1.02u w=0.64u l=0.13u
X3411 a_14888_13226# a_14317_14024# VDD.t1558 VDD.t50 sg13_lv_pmos ad=0.2128p pd=1.5u as=0.3808p ps=2.92u w=1.12u l=0.13u
X3412 a_16793_7532# a_16597_7532# VDD.t895 VDD.t275 sg13_lv_pmos ad=0.3808p pd=2.92u as=0.2128p ps=1.5u w=1.12u l=0.13u
X3413 VDD.t336 a_4187_2434# a_18551_17497# VDD.t297 sg13_lv_pmos ad=0.3808p pd=2.92u as=0.2128p ps=1.5u w=1.12u l=0.6u
X3414 a_7911_8160# a_7673_7532# a_7803_7532# VDD.t275 sg13_lv_pmos ad=0.2128p pd=1.5u as=0.3808p ps=2.92u w=1.12u l=0.2u
X3415 a_7288_6734# a_6717_7532# VDD.t637 VDD.t41 sg13_lv_pmos ad=0.2128p pd=1.5u as=0.3808p ps=2.92u w=1.12u l=0.13u
X3416 VSS.t1213 a_25717_4687# a_26185_3889# VSS.t1456 sg13_lv_nmos ad=0.1665p pd=1.19u as=0.2516p ps=2.16u w=0.74u l=0.13u
X3417 a_2391_12513# CHAN1_MUX_SEL2 a_2297_12513# VSS.t2273 sg13_lv_nmos ad=0.1216p pd=1.02u as=0.2176p ps=1.96u w=0.64u l=0.13u
X3418 a_9712_9602# a_6854_11144# a_9444_9602# VSS.t2235 sg13_lv_nmos ad=0.38p pd=2.38u as=0.68p ps=4.68u w=2u l=1u
X3419 VSS.t1428 a_4187_1764.t47 a_17791_4687# VSS.t1796 sg13_lv_nmos ad=0.2516p pd=2.16u as=0.1406p ps=1.12u w=0.74u l=0.6u
X3420 a_19833_4687# a_19637_4687# VDD.t850 VDD.t281 sg13_lv_pmos ad=0.3808p pd=2.92u as=0.2128p ps=1.5u w=1.12u l=0.13u
X3421 a_16793_14024# a_16597_14024# VDD.t1555 VDD.t301 sg13_lv_pmos ad=0.3808p pd=2.92u as=0.2128p ps=1.5u w=1.12u l=0.13u
X3422 VSS.t431 a_3171_12493.t2 a_23945_12701# VSS.t430 sg13_lv_nmos ad=0.2516p pd=2.16u as=0.2516p ps=2.16u w=0.74u l=0.13u
X3423 a_15755_6734# a_15545_6734# VSS.t1474 VSS.t1473 sg13_lv_nmos ad=0.1406p pd=1.12u as=0.1665p ps=1.19u w=0.74u l=0.13u
X3424 a_16271_1842# a_16033_1842# a_16163_1842# VSS.t1240 sg13_lv_nmos ad=0.1406p pd=1.12u as=0.2516p ps=2.16u w=0.74u l=0.2u
X3425 VSS.t1564 a_3747_13229.t5 a_18871_13190# VSS.t1579 sg13_lv_nmos ad=0.2516p pd=2.16u as=0.2516p ps=2.16u w=0.74u l=0.13u
X3426 a_10328_13226# a_9757_14024# VDD.t1374 VDD.t50 sg13_lv_pmos ad=0.2128p pd=1.5u as=0.3808p ps=2.92u w=1.12u l=0.13u
X3427 a_21835_1044# a_21625_1044# VDD.t643 VDD.t7 sg13_lv_pmos ad=0.2128p pd=1.5u as=0.252p ps=1.57u w=1.12u l=0.13u
X3428 VDD.t565 a_24197_16869# a_24665_16071# VDD.t4 sg13_lv_pmos ad=0.252p pd=1.57u as=0.3808p ps=2.92u w=1.12u l=0.13u
X3429 a_12233_14024# a_12037_14024# VDD.t1346 VDD.t301 sg13_lv_pmos ad=0.3808p pd=2.92u as=0.2128p ps=1.5u w=1.12u l=0.13u
X3430 VSS.t1248 a_2595_6737.t6 a_14311_6698# VSS.t1661 sg13_lv_nmos ad=0.2516p pd=2.16u as=0.2516p ps=2.16u w=0.74u l=0.13u
X3431 VSS.t681 a_4437_4687# a_4905_3889# VSS.t1746 sg13_lv_nmos ad=0.1665p pd=1.19u as=0.2516p ps=2.16u w=0.74u l=0.13u
X3432 a_25913_16869# a_25717_16869# VSS.t598 VSS.t1752 sg13_lv_nmos ad=0.2516p pd=2.16u as=0.1406p ps=1.12u w=0.74u l=0.13u
X3433 VDD.t651 a_2595_1047.t4 a_20391_1008# VDD.t7 sg13_lv_pmos ad=0.3808p pd=2.92u as=0.3808p ps=2.92u w=1.12u l=0.13u
X3434 VDD.t8 VSS.t1063 VDD.t18 VDD.t7 sg13_lv_pmos ad=0.34p pd=2.68u as=0 ps=0 w=1u l=1u
X3435 a_24631_5315# a_24393_4687# a_24523_4687# VDD.t281 sg13_lv_pmos ad=0.2128p pd=1.5u as=0.3808p ps=2.92u w=1.12u l=0.2u
X3436 a_13121_11521# a_15688_11557# VSS.t9 VSS.t8 sg13_lv_nmos ad=0.2516p pd=2.16u as=0.1406p ps=1.12u w=0.74u l=0.13u
X3437 a_9193_4687# a_8997_4687# VDD.t680 VDD.t281 sg13_lv_pmos ad=0.3808p pd=2.92u as=0.2128p ps=1.5u w=1.12u l=0.13u
X3438 VDD.t137 VSS.t966 VDD.t136 VDD.t41 sg13_lv_pmos ad=0.34p pd=2.68u as=0 ps=0 w=1u l=1u
X3439 a_13470_13226# a_15831_13190# a_15755_13226# VDD.t50 sg13_lv_pmos ad=0.3808p pd=2.92u as=0.2128p ps=1.5u w=1.12u l=0.13u
X3440 VSS.t897 VDD.t1674 VSS.t895 VSS.t896 sg13_lv_nmos ad=79.8f pd=0.8u as=0 ps=0 w=0.42u l=1u
X3441 a_5778_9057# a_6126_9506# a_6326_10280# VSS.t14 sg13_lv_nmos ad=0.68p pd=4.68u as=0.38p ps=2.38u w=2u l=1u
X3442 VSS.t621 a_12363_7532# a_12797_7532# VSS.t1448 sg13_lv_nmos ad=0.1406p pd=1.12u as=0.2516p ps=2.16u w=0.74u l=0.13u
X3443 VSS.t2334 VSS.t2334 VSS.t2336 VSS.t2335 sg13_lv_nmos ad=0.2516p pd=2.16u as=0 ps=0 w=0.74u l=0.13u
X3444 a_5115_6734# a_4905_6734# VSS.t1124 VSS.t1123 sg13_lv_nmos ad=0.1406p pd=1.12u as=0.1665p ps=1.19u w=0.74u l=0.13u
X3445 a_22590_6734# a_24951_6698# a_24875_6734# VDD.t41 sg13_lv_pmos ad=0.3808p pd=2.92u as=0.2128p ps=1.5u w=1.12u l=0.13u
X3446 a_21353_16869# a_21157_16869# VSS.t243 VSS.t242 sg13_lv_nmos ad=0.2516p pd=2.16u as=0.1406p ps=1.12u w=0.74u l=0.13u
X3447 VSS.t845 VDD.t1689 VSS.t847 VSS.t846 sg13_lv_nmos ad=79.8f pd=0.8u as=0 ps=0 w=0.42u l=1u
X3448 VSS.t178 a_3171_13229.t6 a_14964_13190# VSS.t1827 sg13_lv_nmos ad=0.2516p pd=2.16u as=0.2516p ps=2.16u w=0.74u l=0.13u
X3449 a_5731_5979# a_3747_6001.t3 a_13470_6734# VSS.t1798 sg13_lv_nmos ad=0.2516p pd=2.16u as=0.2516p ps=2.16u w=0.74u l=0.13u
X3450 a_7673_14024# a_7477_14024# VSS.t705 VSS.t1974 sg13_lv_nmos ad=0.2516p pd=2.16u as=0.1406p ps=1.12u w=0.74u l=0.13u
X3451 a_9444_9602# a_9444_10280# VSS.t1460 VSS.t1459 sg13_lv_nmos ad=0.38p pd=2.38u as=0.68p ps=4.68u w=2u l=1u
X3452 VSS.t1546 a_4187_1764.t98 VSS.t1544 VSS.t1529 sg13_lv_nmos ad=1.33p pd=7.38u as=0 ps=0 w=7u l=7u
X3453 VSS.t532 a_21157_1842# a_21625_1044# VSS.t1967 sg13_lv_nmos ad=0.1665p pd=1.19u as=0.2516p ps=2.16u w=0.74u l=0.13u
X3454 VDD.t1276 a_10517_1842# a_10985_1044# VDD.t7 sg13_lv_pmos ad=0.252p pd=1.57u as=0.3808p ps=2.92u w=1.12u l=0.13u
X3455 a_19073_1842# a_18877_1842# VDD.t1118 VDD.t399 sg13_lv_pmos ad=0.3808p pd=2.92u as=0.2128p ps=1.5u w=1.12u l=0.13u
X3456 VSS.t64 a_14643_16869# a_15077_16869# VSS.t2279 sg13_lv_nmos ad=0.1406p pd=1.12u as=0.2516p ps=2.16u w=0.74u l=0.13u
X3457 VDD.t1023 a_27563_7532# a_27997_7532# VDD.t275 sg13_lv_pmos ad=0.2128p pd=1.5u as=0.3808p ps=2.92u w=1.12u l=0.13u
X3458 VSS.t586 a_2595_12493.t3 a_8745_12701# VSS.t585 sg13_lv_nmos ad=0.2516p pd=2.16u as=0.2516p ps=2.16u w=0.74u l=0.13u
X3459 a_5731_3134# a_5705_3364# a_4350_3889# VDD.t0 sg13_lv_pmos ad=0.3808p pd=2.92u as=0.3808p ps=2.92u w=1.12u l=0.13u
X3460 a_20593_7532# a_20397_7532# VDD.t622 VDD.t275 sg13_lv_pmos ad=0.3808p pd=2.92u as=0.2128p ps=1.5u w=1.12u l=0.13u
X3461 VSS.t1127 a_3171_3892.t8 a_8884_3853# VSS.t1352 sg13_lv_nmos ad=0.2516p pd=2.16u as=0.2516p ps=2.16u w=0.74u l=0.13u
X3462 VSS.t1180 a_4187_1764.t42 a_21591_4687# VSS.t2232 sg13_lv_nmos ad=0.2516p pd=2.16u as=0.1406p ps=1.12u w=0.74u l=0.6u
X3463 a_23633_4687# a_23437_4687# VDD.t1002 VDD.t281 sg13_lv_pmos ad=0.3808p pd=2.92u as=0.2128p ps=1.5u w=1.12u l=0.13u
X3464 a_20071_1842# a_19833_1842# a_19963_1842# VSS.t1879 sg13_lv_nmos ad=0.1406p pd=1.12u as=0.2516p ps=2.16u w=0.74u l=0.2u
X3465 a_1815_331# a_1256_289# a_1721_331# VSS.t2045 sg13_lv_nmos ad=0.1216p pd=1.02u as=0.2176p ps=1.96u w=0.64u l=0.13u
X3466 VDD.t599 a_3747_16074.t2 a_27991_16035# VDD.t4 sg13_lv_pmos ad=0.3808p pd=2.92u as=0.3808p ps=2.92u w=1.12u l=0.13u
X3467 VDD.t638 a_6283_7532# a_6717_7532# VDD.t275 sg13_lv_pmos ad=0.2128p pd=1.5u as=0.3808p ps=2.92u w=1.12u l=0.13u
X3468 VDD.t559 a_9323_4687# a_9757_4687# VDD.t281 sg13_lv_pmos ad=0.2128p pd=1.5u as=0.3808p ps=2.92u w=1.12u l=0.13u
X3469 VSS.t1571 a_14643_1842# a_15077_1842# VSS.t1803 sg13_lv_nmos ad=0.1406p pd=1.12u as=0.2516p ps=2.16u w=0.74u l=0.13u
X3470 VSS.t2343 VSS.t2340 VSS.t2342 VSS.t2341 sg13_lv_nmos ad=0.2516p pd=2.16u as=0 ps=0 w=0.74u l=0.6u
X3471 VDD.t854 a_25717_7532# a_26185_6734# VDD.t41 sg13_lv_pmos ad=0.252p pd=1.57u as=0.3808p ps=2.92u w=1.12u l=0.13u
X3472 VSS.t524 a_4187_1764.t123 a_10191_14024# VSS.t523 sg13_lv_nmos ad=0.2516p pd=2.16u as=0.1406p ps=1.12u w=0.74u l=0.6u
X3473 VDD.t1268 a_19203_1842# a_19637_1842# VDD.t399 sg13_lv_pmos ad=0.2128p pd=1.5u as=0.3808p ps=2.92u w=1.12u l=0.13u
X3474 a_16108_289# a_20905_519# a_19550_1044# VDD.t7 sg13_lv_pmos ad=0.3808p pd=2.92u as=0.3808p ps=2.92u w=1.12u l=0.13u
X3475 VSS.t639 a_16851_3154# CHAN2_MUX_OUT VSS.t2147 sg13_lv_nmos ad=0.2516p pd=2.16u as=0.1406p ps=1.12u w=0.74u l=0.13u
X3476 VSS.t1414 a_2019_1047.t9 a_4324_1008# VSS.t1413 sg13_lv_nmos ad=0.2516p pd=2.16u as=0.2516p ps=2.16u w=0.74u l=0.13u
X3477 VDD.t1161 a_10517_16869# a_10985_16071# VDD.t4 sg13_lv_pmos ad=0.252p pd=1.57u as=0.3808p ps=2.92u w=1.12u l=0.13u
X3478 VSS.t1876 a_1544_15316# a_1815_15358# VSS.t422 sg13_lv_nmos ad=0.1331p pd=1.12u as=0.1216p ps=1.02u w=0.64u l=0.13u
X3479 a_17791_14652# a_17553_14024# a_17683_14024# VDD.t301 sg13_lv_pmos ad=0.2128p pd=1.5u as=0.3808p ps=2.92u w=1.12u l=0.2u
X3480 VDD.t825 a_4437_7532# a_4905_6734# VDD.t41 sg13_lv_pmos ad=0.252p pd=1.57u as=0.3808p ps=2.92u w=1.12u l=0.13u
X3481 a_16510_1044# a_3747_1047.t5 a_18795_1044# VSS.t370 sg13_lv_nmos ad=0.2516p pd=2.16u as=0.1406p ps=1.12u w=0.74u l=0.13u
X3482 VDD.t15 VSS.t1011 VDD.t14 VDD.t0 sg13_lv_pmos ad=0.19p pd=1.38u as=0 ps=0 w=1u l=1u
X3483 a_16108_15316# a_17865_15546# a_16510_16071# VDD.t4 sg13_lv_pmos ad=0.3808p pd=2.92u as=0.3808p ps=2.92u w=1.12u l=0.13u
X3484 VSS.t2389 VSS.t2391 VSS.t2393 VSS.t2392 sg13_lv_nmos ad=0.1406p pd=1.12u as=0 ps=0 w=0.74u l=0.2u
X3485 a_27915_3889# a_27705_3889# VSS.t794 VSS.t793 sg13_lv_nmos ad=0.1406p pd=1.12u as=0.1665p ps=1.19u w=0.74u l=0.13u
X3486 VSS.t397 CHAN2_MUX_SEL1 a_3543_4240# VSS.t1742 sg13_lv_nmos ad=0.1331p pd=1.12u as=0.1216p ps=1.02u w=0.64u l=0.13u
X3487 a_5731_12471# a_14825_12701# a_13470_13226# VDD.t50 sg13_lv_pmos ad=0.3808p pd=2.92u as=0.3808p ps=2.92u w=1.12u l=0.13u
X3488 VDD.t361 a_4187_2434# a_18551_14652# VDD.t301 sg13_lv_pmos ad=0.3808p pd=2.92u as=0.2128p ps=1.5u w=1.12u l=0.6u
X3489 VDD.t898 a_8563_1842# a_8997_1842# VDD.t399 sg13_lv_pmos ad=0.2128p pd=1.5u as=0.3808p ps=2.92u w=1.12u l=0.13u
X3490 a_26911_16869# a_26673_16869# a_26803_16869# VSS.t2145 sg13_lv_nmos ad=0.1406p pd=1.12u as=0.2516p ps=2.16u w=0.74u l=0.2u
X3491 VDD.t1116 a_3449_16422# a_3747_16074.t0 VDD.t4 sg13_lv_pmos ad=0.4256p pd=3u as=0.2128p ps=1.5u w=1.12u l=0.13u
X3492 VSS.t1931 a_4187_1764.t15 a_17791_1842# VSS.t2137 sg13_lv_nmos ad=0.2516p pd=2.16u as=0.1406p ps=1.12u w=0.74u l=0.6u
X3493 a_16271_7532# a_16033_7532# a_16163_7532# VSS.t1458 sg13_lv_nmos ad=0.1406p pd=1.12u as=0.2516p ps=2.16u w=0.74u l=0.2u
X3494 VSS.t1069 VDD.t1623 VSS.t773 VSS.t1068 sg13_lv_nmos ad=0.1428p pd=1.52u as=0 ps=0 w=0.42u l=1u
X3495 VDD.t403 a_4187_2434# a_13231_2470# VDD.t399 sg13_lv_pmos ad=0.3808p pd=2.92u as=0.2128p ps=1.5u w=1.12u l=0.6u
X3496 a_13753_16869# a_13557_16869# VDD.t553 VDD.t297 sg13_lv_pmos ad=0.3808p pd=2.92u as=0.2128p ps=1.5u w=1.12u l=0.13u
X3497 VDD.t583 a_3747_1047.t5 a_18871_1008# VDD.t7 sg13_lv_pmos ad=0.3808p pd=2.92u as=0.3808p ps=2.92u w=1.12u l=0.13u
X3498 VSS.t757 a_12363_14024# a_12797_14024# VSS.t2047 sg13_lv_nmos ad=0.1406p pd=1.12u as=0.2516p ps=2.16u w=0.74u l=0.13u
X3499 VSS.t730 a_4187_1764.t132 a_27671_16869# VSS.t729 sg13_lv_nmos ad=0.2516p pd=2.16u as=0.1406p ps=1.12u w=0.74u l=0.6u
X3500 a_14009_10774# REF_DELAY_OUT_LAST VSS.t284 VSS.t1453 sg13_lv_nmos ad=0.2516p pd=2.16u as=1.45407p ps=9.445u w=0.74u l=0.13u
X3501 VDD.t945 a_3171_6737.t8 a_8884_6698# VDD.t41 sg13_lv_pmos ad=0.3808p pd=2.92u as=0.3808p ps=2.92u w=1.12u l=0.13u
X3502 a_22351_16869# a_22113_16869# a_22243_16869# VSS.t1711 sg13_lv_nmos ad=0.1406p pd=1.12u as=0.2516p ps=2.16u w=0.74u l=0.2u
X3503 a_8671_14024# a_8433_14024# a_8563_14024# VSS.t2012 sg13_lv_nmos ad=0.1406p pd=1.12u as=0.2516p ps=2.16u w=0.74u l=0.2u
X3504 VSS.t1536 a_4187_1764.t98 VSS.t1538 VSS.t1537 sg13_lv_nmos ad=1.33p pd=7.38u as=0 ps=0 w=7u l=7u
X3505 VDD.t141 VSS.t897 VDD.t140 VDD.t50 sg13_lv_pmos ad=0.34p pd=2.68u as=0 ps=0 w=1u l=1u
X3506 VDD.t1262 a_23003_1842# a_23437_1842# VDD.t399 sg13_lv_pmos ad=0.2128p pd=1.5u as=0.3808p ps=2.92u w=1.12u l=0.13u
X3507 VDD.t145 VSS.t1028 VDD.t144 VDD.t0 sg13_lv_pmos ad=0.34p pd=2.68u as=0 ps=0 w=1u l=1u
X3508 a_7390_3889# a_8231_3853# a_8155_3889# VDD.t0 sg13_lv_pmos ad=0.3808p pd=2.92u as=0.2128p ps=1.5u w=1.12u l=0.13u
X3509 VDD.t150 VSS.t850 VDD.t172 VDD.t4 sg13_lv_pmos ad=0.34p pd=2.68u as=0 ps=0 w=1u l=1u
X3510 VSS.t526 a_4187_1764.t124 a_9431_14024# VSS.t525 sg13_lv_nmos ad=0.2516p pd=2.16u as=0.1406p ps=1.12u w=0.74u l=0.6u
X3511 VDD.t777 VDD.t769 VDD.t776 VDD.t268 sg13_lv_pmos ad=0.38p pd=2.38u as=0 ps=0 w=2u l=1u
X3512 VSS.t388 a_26803_14024# a_27237_14024# VSS.t1817 sg13_lv_nmos ad=0.1406p pd=1.12u as=0.2516p ps=2.16u w=0.74u l=0.13u
X3513 VSS.t259 a_1721_13577# a_2019_13229.t1 VSS.t1909 sg13_lv_nmos ad=0.2812p pd=2.24u as=0.1406p ps=1.12u w=0.74u l=0.13u
X3514 a_19073_7532# a_18877_7532# VDD.t523 VDD.t275 sg13_lv_pmos ad=0.3808p pd=2.92u as=0.2128p ps=1.5u w=1.12u l=0.13u
X3515 a_12715_1044# a_12505_1044# VDD.t1151 VDD.t7 sg13_lv_pmos ad=0.2128p pd=1.5u as=0.252p ps=1.57u w=1.12u l=0.13u
X3516 VSS.t466 a_21157_7532# a_21625_6734# VSS.t1681 sg13_lv_nmos ad=0.1665p pd=1.19u as=0.2516p ps=2.16u w=0.74u l=0.13u
X3517 VDD.t659 a_2019_16074.t9 a_4324_16035# VDD.t4 sg13_lv_pmos ad=0.3808p pd=2.92u as=0.3808p ps=2.92u w=1.12u l=0.13u
X3518 a_17928_1044# a_17357_1842# VDD.t1163 VDD.t7 sg13_lv_pmos ad=0.2128p pd=1.5u as=0.3808p ps=2.92u w=1.12u l=0.13u
X3519 a_13045_11905# a_13019_11521# a_12849_11557# VSS.t1743 sg13_lv_nmos ad=0.1406p pd=1.12u as=0.1406p ps=1.12u w=0.74u l=0.13u
X3520 a_19550_1044# a_21044_1008# a_20968_1044# VDD.t7 sg13_lv_pmos ad=0.3808p pd=2.92u as=0.2128p ps=1.5u w=1.12u l=0.13u
X3521 a_2967_6021# REF_MUX_SEL3 a_2873_6021# VSS.t648 sg13_lv_nmos ad=0.1216p pd=1.02u as=0.2176p ps=1.96u w=0.64u l=0.13u
X3522 VSS.t2014 a_1544_289# a_1815_331# VSS.t2031 sg13_lv_nmos ad=0.1331p pd=1.12u as=0.1216p ps=1.02u w=0.64u l=0.13u
X3523 VSS.t546 a_4187_1764.t10 a_21591_1842# VSS.t545 sg13_lv_nmos ad=0.2516p pd=2.16u as=0.1406p ps=1.12u w=0.74u l=0.6u
X3524 a_20071_7532# a_19833_7532# a_19963_7532# VSS.t787 sg13_lv_nmos ad=0.1406p pd=1.12u as=0.2516p ps=2.16u w=0.74u l=0.2u
X3525 VSS.t62 a_15077_16869# a_15545_16071# VSS.t61 sg13_lv_nmos ad=0.1665p pd=1.19u as=0.2516p ps=2.16u w=0.74u l=0.13u
X3526 a_13592_11113# a_13566_11018# VSS.t11 VSS.t2188 sg13_lv_nmos ad=0.2516p pd=2.16u as=0.1626p ps=1.415u w=0.74u l=0.13u
X3527 a_7288_1044# a_6717_1842# VDD.t1549 VDD.t7 sg13_lv_pmos ad=0.2128p pd=1.5u as=0.3808p ps=2.92u w=1.12u l=0.13u
X3528 a_22873_4687# a_22677_4687# VSS.t48 VSS.t47 sg13_lv_nmos ad=0.2516p pd=2.16u as=0.1406p ps=1.12u w=0.74u l=0.13u
X3529 VSS.t508 a_2019_13229.t2 a_25604_13190# VSS.t2153 sg13_lv_nmos ad=0.2516p pd=2.16u as=0.2516p ps=2.16u w=0.74u l=0.13u
X3530 a_13400_11995# a_12355_11557# a_13306_11995# VSS.t1771 sg13_lv_nmos ad=60.89999f pd=0.71u as=0.1428p ps=1.52u w=0.42u l=0.13u
X3531 VSS.t2352 VSS.t2350 VSS.t2350 VSS.t2351 sg13_lv_nmos ad=0.68p pd=4.68u as=0 ps=0 w=2u l=1u
X3532 VSS.t732 a_14643_7532# a_15077_7532# VSS.t2108 sg13_lv_nmos ad=0.1406p pd=1.12u as=0.2516p ps=2.16u w=0.74u l=0.13u
X3533 a_27915_6734# a_27705_6734# VDD.t641 VDD.t41 sg13_lv_pmos ad=0.2128p pd=1.5u as=0.252p ps=1.57u w=1.12u l=0.13u
X3534 VSS.t1583 a_3171_16074.t3 a_24084_16035# VSS.t1582 sg13_lv_nmos ad=0.2516p pd=2.16u as=0.2516p ps=2.16u w=0.74u l=0.13u
X3535 VDD.t822 a_19203_7532# a_19637_7532# VDD.t275 sg13_lv_pmos ad=0.2128p pd=1.5u as=0.3808p ps=2.92u w=1.12u l=0.13u
X3536 VDD.t662 a_12037_4687# a_12505_3889# VDD.t0 sg13_lv_pmos ad=0.252p pd=1.57u as=0.3808p ps=2.92u w=1.12u l=0.13u
X3537 a_14513_4687# a_14317_4687# VDD.t566 VDD.t281 sg13_lv_pmos ad=0.3808p pd=2.92u as=0.2128p ps=1.5u w=1.12u l=0.13u
X3538 a_13231_16869# a_12993_16869# a_13123_16869# VSS.t2143 sg13_lv_nmos ad=0.1406p pd=1.12u as=0.2516p ps=2.16u w=0.74u l=0.2u
X3539 VDD.t69 VSS.t904 VDD.t116 VDD.t50 sg13_lv_pmos ad=0.34p pd=2.68u as=0 ps=0 w=1u l=1u
X3540 a_5631_5315# a_5393_4687# a_5523_4687# VDD.t281 sg13_lv_pmos ad=0.2128p pd=1.5u as=0.3808p ps=2.92u w=1.12u l=0.2u
X3541 VDD.t1606 VSS.t869 VDD.t1604 VDD.t4 sg13_lv_pmos ad=0.19p pd=1.38u as=0 ps=0 w=1u l=1u
X3542 VSS.t126 a_2019_6737.t9 a_4324_6698# VSS.t734 sg13_lv_nmos ad=0.2516p pd=2.16u as=0.2516p ps=2.16u w=0.74u l=0.13u
X3543 VDD.t1055 a_18117_14024# a_18585_13226# VDD.t50 sg13_lv_pmos ad=0.252p pd=1.57u as=0.3808p ps=2.92u w=1.12u l=0.13u
X3544 VSS.t2091 a_1544_12471# a_1815_12513# VSS.t2092 sg13_lv_nmos ad=0.1331p pd=1.12u as=0.1216p ps=1.02u w=0.64u l=0.13u
X3545 a_16510_6734# a_3747_6737.t5 a_18795_6734# VSS.t462 sg13_lv_nmos ad=0.2516p pd=2.16u as=0.1406p ps=1.12u w=0.74u l=0.13u
X3546 VSS.t500 a_4187_1764.t150 a_13991_16869# VSS.t499 sg13_lv_nmos ad=0.2516p pd=2.16u as=0.1406p ps=1.12u w=0.74u l=0.6u
X3547 a_24393_14024# a_24197_14024# VSS.t1400 VSS.t1872 sg13_lv_nmos ad=0.2516p pd=2.16u as=0.1406p ps=1.12u w=0.74u l=0.13u
X3548 a_15511_2470# a_15273_1842# a_15403_1842# VDD.t399 sg13_lv_pmos ad=0.2128p pd=1.5u as=0.3808p ps=2.92u w=1.12u l=0.2u
X3549 a_14751_17497# a_14513_16869# a_14643_16869# VDD.t297 sg13_lv_pmos ad=0.2128p pd=1.5u as=0.3808p ps=2.92u w=1.12u l=0.2u
X3550 a_19073_16869# a_18877_16869# VDD.t614 VDD.t297 sg13_lv_pmos ad=0.3808p pd=2.92u as=0.2128p ps=1.5u w=1.12u l=0.13u
X3551 a_22590_1044# a_24951_1008# a_24875_1044# VDD.t7 sg13_lv_pmos ad=0.3808p pd=2.92u as=0.2128p ps=1.5u w=1.12u l=0.13u
X3552 VSS.t2402 VSS.t2404 VSS.t2406 VSS.t2405 sg13_lv_nmos ad=0.1406p pd=1.12u as=0 ps=0 w=0.74u l=0.2u
X3553 VSS.t344 a_17683_14024# a_18117_14024# VSS.t2080 sg13_lv_nmos ad=0.1406p pd=1.12u as=0.2516p ps=2.16u w=0.74u l=0.13u
X3554 VDD.t549 a_8563_7532# a_8997_7532# VDD.t275 sg13_lv_pmos ad=0.2128p pd=1.5u as=0.3808p ps=2.92u w=1.12u l=0.13u
X3555 VSS.t617 a_4187_1764.t109 a_20831_14024# VSS.t616 sg13_lv_nmos ad=0.2516p pd=2.16u as=0.1406p ps=1.12u w=0.74u l=0.6u
X3556 a_11848_13226# a_11277_14024# VDD.t1367 VDD.t50 sg13_lv_pmos ad=0.2128p pd=1.5u as=0.3808p ps=2.92u w=1.12u l=0.13u
X3557 VDD.t476 a_3171_13229.t2 a_27124_13190# VDD.t50 sg13_lv_pmos ad=0.3808p pd=2.92u as=0.3808p ps=2.92u w=1.12u l=0.13u
X3558 a_6126_9506# a_6126_9506# VSS.t15 VSS.t14 sg13_lv_nmos ad=0.38p pd=2.38u as=0.68p ps=4.68u w=2u l=1u
X3559 VSS.t217 a_4187_1764.t79 a_17791_7532# VSS.t1595 sg13_lv_nmos ad=0.2516p pd=2.16u as=0.1406p ps=1.12u w=0.74u l=0.6u
X3560 VSS.t1115 VDD.t1609 VSS.t1115 VSS.t1117 sg13_lv_nmos ad=79.8f pd=0.8u as=0 ps=0 w=0.42u l=1u
X3561 VDD.t386 a_4187_2434# a_13231_8160# VDD.t275 sg13_lv_pmos ad=0.3808p pd=2.92u as=0.2128p ps=1.5u w=1.12u l=0.6u
X3562 VSS.t454 a_3747_16074.t5 a_18871_16035# VSS.t1630 sg13_lv_nmos ad=0.2516p pd=2.16u as=0.2516p ps=2.16u w=0.74u l=0.13u
X3563 VSS.t589 a_2595_12493.t2 a_20905_12701# VSS.t588 sg13_lv_nmos ad=0.2516p pd=2.16u as=0.2516p ps=2.16u w=0.74u l=0.13u
X3564 a_4633_4687# a_4437_4687# VDD.t1181 VDD.t281 sg13_lv_pmos ad=0.3808p pd=2.92u as=0.2128p ps=1.5u w=1.12u l=0.13u
X3565 a_13753_14024# a_13557_14024# VDD.t1379 VDD.t301 sg13_lv_pmos ad=0.3808p pd=2.92u as=0.2128p ps=1.5u w=1.12u l=0.13u
X3566 VSS.t1263 a_3747_15338.t2 a_26985_15546# VSS.t1262 sg13_lv_nmos ad=0.2516p pd=2.16u as=0.2516p ps=2.16u w=0.74u l=0.13u
X3567 VDD.t509 a_23003_7532# a_23437_7532# VDD.t275 sg13_lv_pmos ad=0.2128p pd=1.5u as=0.3808p ps=2.92u w=1.12u l=0.13u
X3568 a_22873_16869# a_22677_16869# VSS.t666 VSS.t1707 sg13_lv_nmos ad=0.2516p pd=2.16u as=0.1406p ps=1.12u w=0.74u l=0.13u
X3569 VDD.t224 VSS.t927 VDD.t164 VDD.t50 sg13_lv_pmos ad=0.19p pd=1.38u as=0 ps=0 w=1u l=1u
X3570 VSS.t982 VDD.t1649 VSS.t981 VSS.t980 sg13_lv_nmos ad=0.1428p pd=1.52u as=0 ps=0 w=0.42u l=1u
X3571 VSS.t18 VSS.t2347 VSS.t2347 VSS.t2348 sg13_lv_nmos ad=0.68p pd=4.68u as=0 ps=0 w=2u l=1u
X3572 a_10430_1044# a_2019_1047.t7 a_10328_1044# VSS.t145 sg13_lv_nmos ad=0.2516p pd=2.16u as=0.1406p ps=1.12u w=0.74u l=0.13u
X3573 VSS.t970 VDD.t1651 VSS.t970 VSS.t974 sg13_lv_nmos ad=79.8f pd=0.8u as=0 ps=0 w=0.42u l=1u
X3574 a_4157_7003# REF_CLK VDD.t1442 VDD.t41 sg13_lv_pmos ad=0.3808p pd=2.92u as=0.3808p ps=2.92u w=1.12u l=0.13u
X3575 VSS.t1280 a_16163_16869# a_16597_16869# VSS.t1283 sg13_lv_nmos ad=0.1406p pd=1.12u as=0.2516p ps=2.16u w=0.74u l=0.13u
X3576 VDD.t1334 a_25717_1842# a_26185_1044# VDD.t7 sg13_lv_pmos ad=0.252p pd=1.57u as=0.3808p ps=2.92u w=1.12u l=0.13u
X3577 VSS.t1039 a_2595_3156.t2 a_20905_3364# VSS.t1495 sg13_lv_nmos ad=0.2516p pd=2.16u as=0.2516p ps=2.16u w=0.74u l=0.13u
X3578 VSS.t927 VDD.t1663 VSS.t927 VSS.t929 sg13_lv_nmos ad=0.1428p pd=1.52u as=0 ps=0 w=0.42u l=1u
X3579 VSS.t1373 a_3171_16074.t6 a_14964_16035# VSS.t2151 sg13_lv_nmos ad=0.2516p pd=2.16u as=0.2516p ps=2.16u w=0.74u l=0.13u
X3580 VSS.t955 a_3171_6001.t3 a_11785_6209# VSS.t1785 sg13_lv_nmos ad=0.2516p pd=2.16u as=0.2516p ps=2.16u w=0.74u l=0.13u
X3581 a_4633_14024# a_4437_14024# VSS.t728 VSS.t1983 sg13_lv_nmos ad=0.2516p pd=2.16u as=0.1406p ps=1.12u w=0.74u l=0.13u
X3582 VSS.t238 a_3171_13229.t7 a_11924_13190# VSS.t237 sg13_lv_nmos ad=0.2516p pd=2.16u as=0.2516p ps=2.16u w=0.74u l=0.13u
X3583 VSS.t415 a_11603_16869# a_12037_16869# VSS.t1367 sg13_lv_nmos ad=0.1406p pd=1.12u as=0.2516p ps=2.16u w=0.74u l=0.13u
X3584 VSS.t875 a_2019_12493.t3 a_5705_12701# VSS.t2218 sg13_lv_nmos ad=0.2516p pd=2.16u as=0.2516p ps=2.16u w=0.74u l=0.13u
X3585 VDD.t952 a_4437_1842# a_4905_1044# VDD.t7 sg13_lv_pmos ad=0.252p pd=1.57u as=0.3808p ps=2.92u w=1.12u l=0.13u
X3586 VDD.t1159 a_13883_1842# a_14317_1842# VDD.t399 sg13_lv_pmos ad=0.2128p pd=1.5u as=0.3808p ps=2.92u w=1.12u l=0.13u
X3587 VSS.t313 a_4187_1764.t74 a_21591_7532# VSS.t1653 sg13_lv_nmos ad=0.2516p pd=2.16u as=0.1406p ps=1.12u w=0.74u l=0.6u
X3588 a_4157_1313# CHAN3_DELAY_IN VSS.t2179 VSS.t2178 sg13_lv_nmos ad=0.2516p pd=2.16u as=0.2553p ps=2.17u w=0.74u l=0.13u
X3589 a_7390_1044# a_3171_1047.t8 a_8808_1044# VSS.t376 sg13_lv_nmos ad=0.2516p pd=2.16u as=0.1406p ps=1.12u w=0.74u l=0.13u
X3590 a_7390_3889# a_2595_3892.t8 a_8155_3889# VSS.t1384 sg13_lv_nmos ad=0.2516p pd=2.16u as=0.1406p ps=1.12u w=0.74u l=0.13u
X3591 VSS.t880 VDD.t1678 VSS.t880 VSS.t883 sg13_lv_nmos ad=79.8f pd=0.8u as=0 ps=0 w=0.42u l=1u
X3592 VSS.t1648 a_4187_1764.t121 a_11711_14024# VSS.t1647 sg13_lv_nmos ad=0.2516p pd=2.16u as=0.1406p ps=1.12u w=0.74u l=0.6u
X3593 a_22873_1842# a_22677_1842# VSS.t544 VSS.t1963 sg13_lv_nmos ad=0.2516p pd=2.16u as=0.1406p ps=1.12u w=0.74u l=0.13u
X3594 a_25391_14024# a_25153_14024# a_25283_14024# VSS.t1884 sg13_lv_nmos ad=0.1406p pd=1.12u as=0.2516p ps=2.16u w=0.74u l=0.2u
X3595 a_10328_3889# a_9757_4687# VDD.t560 VDD.t0 sg13_lv_pmos ad=0.2128p pd=1.5u as=0.3808p ps=2.92u w=1.12u l=0.13u
X3596 VSS.t354 a_2019_15338.t2 a_17865_15546# VSS.t353 sg13_lv_nmos ad=0.2516p pd=2.16u as=0.2516p ps=2.16u w=0.74u l=0.13u
X3597 VDD.t585 a_3171_1047.t8 a_8884_1008# VDD.t7 sg13_lv_pmos ad=0.3808p pd=2.92u as=0.3808p ps=2.92u w=1.12u l=0.13u
X3598 VDD.t602 a_12037_16869# a_12505_16071# VDD.t4 sg13_lv_pmos ad=0.252p pd=1.57u as=0.3808p ps=2.92u w=1.12u l=0.13u
C0 a_18004_3853# a_18117_4687# 0.02055f
C1 VDD a_24875_13226# 0.15407f
C2 VDD a_15403_14024# 0.4973f
C3 VDD a_6913_4687# 0.49655f
C4 VDD a_4111_8160# 0.01866f
C5 a_4187_2434# a_20723_16869# 0.06627f
C6 a_12233_16869# a_12363_16869# 0.70845f
C7 a_7390_16071# a_8745_15546# 0.01756f
C8 a_19550_16071# a_20315_16071# 0.39037f
C9 a_15837_16869# a_15831_16035# 0.02354f
C10 a_16793_14024# a_17357_14024# 0.0114f
C11 a_4187_2434# a_11603_7532# 0.06627f
C12 a_21483_14024# a_19550_13226# 0.01012f
C13 a_25630_13226# a_26471_13190# 0.28268f
C14 a_16510_13226# a_16851_12491# 0.02131f
C15 a_5197_7532# a_5844_6698# 0.02312f
C16 a_7390_6734# a_8808_6734# 0.38994f
C17 a_15545_6734# a_15755_6734# 0.09424f
C18 a_11277_4687# a_10430_3889# 0.08038f
C19 a_24523_4687# a_24631_4687# 0.01163f
C20 a_18117_4687# a_18585_3889# 0.2079f
C21 a_8237_4687# a_7803_4687# 0.6972f
C22 a_16597_1842# a_16163_1842# 0.69698f
C23 a_21157_1842# a_19550_1044# 0.05231f
C24 a_20397_1842# a_20391_1008# 0.02349f
C25 a_25528_1044# a_25630_1044# 0.37183f
C26 a_16271_2470# VDD 0.01806f
C27 a_16033_1842# a_4187_2434# 0.11222f
C28 a_19550_3889# a_21625_3889# 0.03208f
C29 VDD a_1721_15358# 0.45365f
C30 VDD a_19637_16869# 0.86712f
C31 VDD a_15545_13226# 0.29918f
C32 VDD a_10517_7532# 0.86712f
C33 VDD a_17275_6734# 0.15389f
C34 CHAN1_MUX_OUT a_1544_12471# 0.69943f
C35 CHAN1_MUX_SEL3 a_2297_12513# 0.01595f
C36 CHAN1_MUX_SEL2 a_2873_12513# 0.01422f
C37 CHAN1_MUX_SEL4 a_1721_12513# 0.05813f
C38 a_23763_16869# a_23871_17497# 0.01697f
C39 a_7390_16071# a_8231_16035# 0.28268f
C40 a_5197_16869# a_5844_16035# 0.02312f
C41 a_5731_15316# a_15403_14024# 0.01563f
C42 a_7673_14024# a_7803_14024# 0.70845f
C43 a_4187_2434# a_24957_4687# 0.0414f
C44 a_13470_13226# a_14888_13226# 0.38994f
C45 a_4003_7532# a_4111_7532# 0.01163f
C46 a_10083_7532# a_10191_8160# 0.01697f
C47 a_20397_7532# a_20593_7532# 0.76914f
C48 a_12849_11557# a_14851_11918# 0.13392f
C49 a_13121_11521# a_15688_11557# 0.17255f
C50 a_24957_7532# a_24951_6698# 0.02354f
C51 a_24957_4687# a_25717_4687# 0.06198f
C52 a_6425_3889# a_6635_3889# 0.09424f
C53 a_7477_1842# a_7673_1842# 0.73897f
C54 a_5731_3134# a_15077_1842# 0.01319f
C55 a_9757_1842# a_10404_1008# 0.02011f
C56 a_13368_1044# a_13444_1008# 0.01176f
C57 a_13883_1842# VDD 0.50058f
C58 a_22590_1044# VDD 1.09432f
C59 a_4003_1842# CHAN2_MUX_SEL4 0.01225f
C60 a_27124_3853# a_27237_4687# 0.02055f
C61 VDD a_5115_16071# 0.15389f
C62 VDD a_14751_14652# 0.01806f
C63 VDD a_13019_11521# 0.42215f
C64 VDD a_22873_4687# 0.49553f
C65 CHAN0_MUX_OUT a_16851_15336# 0.45865f
C66 a_20397_16869# a_21157_16869# 0.03319f
C67 a_4003_16869# a_4111_16869# 0.01163f
C68 a_24957_16869# a_24951_16035# 0.02354f
C69 a_4187_2434# a_15837_14024# 0.0414f
C70 a_25630_16071# a_16108_15316# 0.55833f
C71 a_16923_14024# a_17031_14652# 0.01697f
C72 a_24957_14024# a_25153_14024# 0.76914f
C73 a_4187_2434# a_27563_7532# 0.06663f
C74 a_10843_14024# a_10951_14024# 0.01163f
C75 a_4187_2434# a_6283_4687# 0.06627f
C76 a_14317_7532# a_14964_6698# 0.02312f
C77 a_11277_7532# a_12037_7532# 0.03319f
C78 a_18795_6734# a_18871_6698# 0.01194f
C79 a_15837_4687# a_16163_4687# 0.01427f
C80 a_16163_1842# a_16271_2470# 0.01697f
C81 a_4905_1044# a_5115_1044# 0.09424f
C82 a_10083_1842# a_10191_1842# 0.01163f
C83 a_16108_289# a_23945_519# 0.2906f
C84 a_27048_3889# VDD 0.17499f
C85 a_16510_3889# a_17357_4687# 0.08038f
C86 VDD a_13753_14024# 0.49553f
C87 VDD a_25391_17497# 0.01806f
C88 VDD a_26477_7532# 0.86919f
C89 VDD a_21911_13190# 0.2822f
C90 VDD a_5197_4687# 0.87057f
C91 VDD a_10328_3889# 0.17274f
C92 REF_CLK a_4187_2434# 2.13625f
C93 REF_MUX_SEL2 a_1544_5979# 0.07405f
C94 REF_MUX_SEL3 a_1256_5979# 1.41161f
C95 a_11277_16869# a_11603_16869# 0.01427f
C96 a_4187_2434# a_19073_16869# 0.11222f
C97 a_14317_16869# a_14964_16035# 0.02312f
C98 a_15837_14024# a_16597_14024# 0.06198f
C99 a_4187_2434# a_9953_7532# 0.11222f
C100 a_24875_13226# a_24951_13190# 0.01194f
C101 a_4437_7532# a_4350_6734# 0.1088f
C102 a_5731_5979# a_14317_4687# 0.01319f
C103 a_6913_4687# a_7477_4687# 0.0114f
C104 a_23003_4687# a_23111_4687# 0.01163f
C105 a_9757_4687# a_9751_3853# 0.02354f
C106 a_15273_1842# a_15837_1842# 0.0114f
C107 a_24008_1044# a_24084_1008# 0.01176f
C108 a_18877_1842# a_19524_1008# 0.02011f
C109 a_10191_2470# VDD 0.01806f
C110 VDD CHAN1_MUX_SEL0 0.56365f
C111 a_1544_289# CHAN3_MUX_SEL2 0.07405f
C112 a_3449_331# CHAN3_DELAY_IN 0.01017f
C113 a_1256_289# CHAN3_MUX_SEL3 1.41161f
C114 a_14317_1842# a_4187_2434# 0.0414f
C115 VDD a_16923_16869# 0.4973f
C116 VDD a_26395_16071# 0.15389f
C117 VDD a_7803_7532# 0.4973f
C118 VDD a_4905_13226# 0.3013f
C119 VDD a_14311_6698# 0.28357f
C120 a_22243_16869# a_22351_17497# 0.01697f
C121 a_4437_16869# a_4350_16071# 0.1088f
C122 a_6717_14024# a_7043_14024# 0.01427f
C123 a_6635_16071# a_6711_16035# 0.01194f
C124 a_5731_15316# a_13753_14024# 0.01865f
C125 a_13121_11521# a_14009_11568# 0.01604f
C126 a_4187_2434# a_22243_4687# 0.06627f
C127 a_6854_11676# a_9444_10280# 0.02502f
C128 a_12849_11557# a_13592_11561# 0.38817f
C129 a_23145_13226# a_23355_13226# 0.09424f
C130 a_13306_11995# a_13566_11525# 0.75507f
C131 a_19073_7532# a_19203_7532# 0.70845f
C132 a_8563_7532# a_8671_8160# 0.01697f
C133 a_23437_7532# a_24084_6698# 0.02312f
C134 a_24197_4687# a_23763_4687# 0.6972f
C135 a_4157_4158# a_4350_3889# 0.04624f
C136 a_5731_3134# a_12363_1842# 0.01542f
C137 a_6153_1842# a_6283_1842# 0.70845f
C138 a_8997_1842# a_8884_1008# 0.02055f
C139 a_12233_1842# VDD 0.4946f
C140 a_19524_1008# VDD 0.28758f
C141 a_15964_3134# CHAN2_MUX_SEL4 0.5544f
C142 VDD CHAN3_MUX_SEL3 0.40589f
C143 a_25630_3889# a_26477_4687# 0.08038f
C144 VDD a_23145_16071# 0.30409f
C145 VDD a_8671_14652# 0.01806f
C146 VDD a_11748_11799# 0.1686f
C147 VDD a_21157_4687# 0.85996f
C148 a_19637_16869# a_19203_16869# 0.69698f
C149 a_23437_16869# a_24084_16035# 0.02312f
C150 a_4187_2434# a_13123_14024# 0.06627f
C151 a_1544_16071# a_2297_16422# 0.28651f
C152 a_23633_14024# a_23763_14024# 0.70845f
C153 a_9323_14024# a_9431_14024# 0.01163f
C154 a_4187_2434# a_4633_4687# 0.11222f
C155 a_15403_14024# a_15511_14652# 0.01697f
C156 a_4187_2434# a_25913_7532# 0.11284f
C157 a_4157_13495# a_4248_13226# 0.11672f
C158 a_15964_12471# a_16851_12491# 0.16757f
C159 a_5731_12471# a_6854_11144# 0.05419f
C160 a_10517_7532# a_10083_7532# 0.69698f
C161 a_13557_7532# a_13470_6734# 0.1088f
C162 a_16108_5979# a_27433_4687# 0.01872f
C163 a_17275_6734# a_17351_6698# 0.01194f
C164 a_4350_6734# a_5705_6209# 0.02005f
C165 a_16510_6734# a_18004_6698# 0.28279f
C166 a_15077_4687# a_15273_4687# 0.77122f
C167 a_1256_3134# a_1544_3134# 1.25711f
C168 a_23437_1842# a_23633_1842# 0.76914f
C169 a_8563_1842# a_8671_1842# 0.01163f
C170 a_14643_1842# a_14751_2470# 0.01697f
C171 a_24084_3853# VDD 0.28225f
C172 a_15831_3853# a_15837_4687# 0.02354f
C173 VDD a_19311_17497# 0.01806f
C174 VDD a_12037_14024# 0.85955f
C175 VDD a_23763_7532# 0.49671f
C176 VDD a_19448_13226# 0.17274f
C177 VDD a_7390_3889# 0.8686f
C178 VDD a_16851_5999# 0.52304f
C179 CHAN1_DELAY_OUT_LAST a_4187_2434# 0.21225f
C180 REF_CLK a_12849_11557# 0.26382f
C181 CHAN2_MUX_OUT a_1544_3889# 0.04258f
C182 CHAN2_MUX_SEL1 a_2297_4240# 0.01995f
C183 a_4187_2434# a_17357_16869# 0.04141f
C184 a_10517_16869# a_10713_16869# 0.73897f
C185 a_13557_16869# a_13470_16071# 0.1088f
C186 a_16510_16071# a_17928_16071# 0.38994f
C187 a_16108_15316# a_26803_14024# 0.01544f
C188 a_15077_14024# a_14643_14024# 0.6972f
C189 a_4187_2434# a_8237_7532# 0.04141f
C190 a_23355_13226# a_23431_13190# 0.01194f
C191 a_22590_13226# a_24084_13190# 0.28279f
C192 a_5731_5979# a_11603_4687# 0.01544f
C193 a_5957_4687# a_6717_4687# 0.02912f
C194 a_4350_6734# a_6635_6734# 0.39036f
C195 a_10985_6734# a_11195_6734# 0.09424f
C196 a_21483_4687# a_21591_4687# 0.01163f
C197 a_8237_4687# a_8884_3853# 0.02312f
C198 a_27563_4687# a_27671_5315# 0.01697f
C199 a_16408_3889# a_16484_3853# 0.01176f
C200 a_14317_1842# a_15077_1842# 0.03319f
C201 a_16108_3134# a_26477_1842# 0.01319f
C202 a_22590_1044# a_22564_1008# 0.277f
C203 a_18117_1842# a_18004_1008# 0.02055f
C204 a_13470_1044# a_5731_289# 0.41365f
C205 a_4111_2470# VDD 0.01866f
C206 VDD CHAN0_MUX_SEL0 0.56365f
C207 a_11603_1842# a_4187_2434# 0.06627f
C208 a_15755_3889# a_15545_3889# 0.09424f
C209 VDD a_15273_16869# 0.49285f
C210 VDD a_23431_16035# 0.28357f
C211 VDD a_2297_13577# 0.46536f
C212 VDD a_6153_7532# 0.49285f
C213 VDD a_11848_6734# 0.17499f
C214 REF_DELAY_OUT_LAST a_14009_10774# 0.25594f
C215 a_20723_16869# a_20831_17497# 0.01697f
C216 a_5957_14024# a_6153_14024# 0.77122f
C217 a_12505_16071# a_10430_16071# 0.03208f
C218 a_4350_16071# a_5844_16035# 0.28279f
C219 a_5731_15316# a_12037_14024# 0.01319f
C220 a_5115_16071# a_5191_16035# 0.01194f
C221 a_10430_13226# a_12715_13226# 0.39036f
C222 a_4187_2434# a_20593_4687# 0.11222f
C223 a_8237_14024# a_8808_13226# 0.10863f
C224 a_12656_11554# a_12849_11557# 0.33075f
C225 a_13019_11521# a_13121_11521# 0.56469f
C226 a_12355_11557# a_13306_11995# 0.26489f
C227 a_7043_7532# a_7151_8160# 0.01697f
C228 a_22677_7532# a_22590_6734# 0.1088f
C229 a_22873_4687# a_23437_4687# 0.0114f
C230 a_19550_6734# a_20905_6209# 0.02165f
C231 a_5731_3134# a_10713_1842# 0.01865f
C232 a_5197_1842# a_5523_1842# 0.01427f
C233 a_13557_1842# a_14025_1044# 0.19203f
C234 a_8237_1842# a_7390_1044# 0.08038f
C235 a_21625_1044# a_19550_1044# 0.03208f
C236 a_10430_1044# a_11195_1044# 0.39037f
C237 a_17275_1044# VDD 0.15464f
C238 a_10517_1842# VDD 0.87128f
C239 a_5731_3134# CHAN2_MUX_OUT 1.04829f
C240 a_8745_3364# CHAN2_MUX_SEL4 0.04472f
C241 VDD CHAN2_MUX_SEL3 0.41814f
C242 CHAN1_MUX_SEL4 CHAN1_MUX_OUT 0.91933f
C243 a_24951_3853# a_24957_4687# 0.02354f
C244 VDD a_10985_16071# 0.30409f
C245 VDD a_27997_14024# 0.76528f
C246 VDD a_9946_11995# 0.77235f
C247 VDD a_18443_4687# 0.50001f
C248 a_18313_16869# a_18877_16869# 0.0114f
C249 a_4187_2434# a_11473_14024# 0.11222f
C250 a_22677_16869# a_22590_16071# 0.1088f
C251 a_27915_16071# a_27991_16035# 0.01194f
C252 a_4187_2434# a_16108_5979# 0.24917f
C253 a_13883_14024# a_13991_14652# 0.01697f
C254 a_7803_14024# a_7911_14024# 0.01163f
C255 a_4187_2434# a_24197_7532# 0.04188f
C256 a_9193_7532# a_9757_7532# 0.0114f
C257 a_16108_5979# a_25717_4687# 0.01314f
C258 a_13753_4687# a_13883_4687# 0.70845f
C259 a_27048_3889# a_27124_3853# 0.01176f
C260 a_22113_1842# a_22243_1842# 0.70845f
C261 a_7043_1842# a_7151_1842# 0.01163f
C262 a_13123_1842# a_13231_2470# 0.01697f
C263 a_5731_289# a_15765_463# 0.23301f
C264 a_27237_1842# a_27124_1008# 0.02055f
C265 a_21835_3889# VDD 0.15407f
C266 a_27563_1842# a_4187_2434# 0.06629f
C267 a_14964_3853# a_14317_4687# 0.02312f
C268 VDD a_13231_17497# 0.01806f
C269 VDD a_9323_14024# 0.50001f
C270 VDD a_16510_13226# 0.8795f
C271 VDD a_22113_7532# 0.49426f
C272 VDD a_4324_3853# 0.28687f
C273 CHAN0_DELAY_IN a_4437_16869# 0.05007f
C274 CHAN0_DELAY_OUT_LAST a_4187_2434# 0.21225f
C275 REF_CLK a_12158_11557# 0.01309f
C276 a_4187_2434# a_14643_16869# 0.06627f
C277 a_9193_16869# a_9323_16869# 0.70845f
C278 a_4187_2434# a_5523_7532# 0.06627f
C279 a_13753_14024# a_14317_14024# 0.0114f
C280 a_16108_15316# a_25153_14024# 0.01872f
C281 a_17357_14024# a_17928_13226# 0.10863f
C282 a_14111_10917# a_14851_10872# 0.26905f
C283 a_26477_7532# a_26043_7532# 0.6972f
C284 a_5731_5979# a_9953_4687# 0.01872f
C285 a_5197_4687# a_4763_4687# 0.6972f
C286 a_19963_4687# a_20071_4687# 0.01163f
C287 a_7477_4687# a_7390_3889# 0.1088f
C288 a_26043_4687# a_26151_5315# 0.01697f
C289 a_10328_3889# a_10430_3889# 0.37183f
C290 a_27237_1842# a_27705_1044# 0.2079f
C291 a_17357_1842# a_16510_1044# 0.08038f
C292 a_16108_3134# a_23763_1842# 0.01544f
C293 a_13557_1842# a_13123_1842# 0.69698f
C294 a_26477_1842# VDD 0.87208f
C295 a_9953_1842# a_4187_2434# 0.11222f
C296 VDD a_20968_16071# 0.17499f
C297 VDD a_13557_16869# 0.86712f
C298 VDD a_8884_6698# 0.28225f
C299 VDD a_4437_7532# 0.87051f
C300 VDD a_23871_5315# 0.01806f
C301 a_19203_16869# a_19311_17497# 0.01697f
C302 a_26477_16869# a_26673_16869# 0.76914f
C303 a_4187_2434# a_27433_14024# 0.11222f
C304 a_4633_14024# a_4763_14024# 0.70845f
C305 a_5731_15316# a_9323_14024# 0.01542f
C306 a_18585_13226# a_18871_13190# 0.01885f
C307 a_4187_2434# a_18877_4687# 0.0414f
C308 a_5523_7532# a_5631_8160# 0.01697f
C309 a_17357_7532# a_17553_7532# 0.76914f
C310 a_21917_4687# a_22677_4687# 0.06198f
C311 a_25630_6734# a_27915_6734# 0.39036f
C312 a_4437_1842# a_4633_1842# 0.73897f
C313 a_5731_3134# a_8997_1842# 0.01319f
C314 a_6717_1842# a_6711_1008# 0.02354f
C315 a_7803_1842# VDD 0.50058f
C316 a_14311_1008# VDD 0.28439f
C317 a_2873_3176# CHAN2_MUX_SEL4 0.04916f
C318 a_3449_3176# CHAN2_MUX_SEL3 0.28429f
C319 a_2297_3176# CHAN2_MUX_OUT 0.01179f
C320 CHAN1_MUX_SEL0 CHAN1_MUX_SEL1 3.14917f
C321 VDD REF_MUX_SEL3 0.41814f
C322 a_24084_3853# a_23437_4687# 0.02312f
C323 VDD a_5974_11413# 0.91632f
C324 VDD a_25283_14024# 0.50004f
C325 VDD a_16793_4687# 0.49408f
C326 CHAN0_MUX_SEL2 a_1544_15316# 0.07405f
C327 CHAN0_MUX_SEL3 a_1256_15316# 1.41161f
C328 CHAN0_DELAY_IN a_3449_15358# 0.01017f
C329 a_17357_16869# a_18117_16869# 0.03319f
C330 a_4187_2434# a_9757_14024# 0.0414f
C331 a_25630_16071# a_27124_16035# 0.28279f
C332 a_21917_14024# a_22113_14024# 0.76914f
C333 a_12363_14024# a_12471_14652# 0.01697f
C334 a_4187_2434# a_21483_7532# 0.06661f
C335 a_26395_16071# a_26471_16035# 0.01194f
C336 a_6283_14024# a_6391_14024# 0.01163f
C337 a_26477_14024# a_27048_13226# 0.10863f
C338 a_8237_7532# a_8997_7532# 0.03319f
C339 a_13470_6734# a_15831_6698# 0.26208f
C340 a_26185_6734# a_26395_6734# 0.09424f
C341 a_16108_5979# a_23003_4687# 0.01539f
C342 a_12797_4687# a_13123_4687# 0.01427f
C343 a_25630_3889# a_25604_3853# 0.277f
C344 a_16510_3889# a_15964_3134# 0.05416f
C345 a_11603_1842# a_11711_2470# 0.01697f
C346 a_5523_1842# a_5631_1842# 0.01163f
C347 a_26477_1842# a_25630_1044# 0.08038f
C348 a_18871_3853# VDD 0.2822f
C349 a_25913_1842# a_4187_2434# 0.11222f
C350 a_13470_3889# a_13557_4687# 0.1088f
C351 a_5705_3364# a_4350_3889# 0.02005f
C352 VDD a_7673_14024# 0.49553f
C353 VDD a_7151_17497# 0.01806f
C354 VDD a_13444_13190# 0.28633f
C355 VDD a_20397_7532# 0.86919f
C356 VDD a_5705_6209# 0.29556f
C357 VDD a_21625_3889# 0.29742f
C358 DLL_RESETN a_10232_11561# 0.39088f
C359 a_8237_16869# a_8563_16869# 0.01427f
C360 a_4187_2434# a_12993_16869# 0.11222f
C361 a_13470_16071# a_15755_16071# 0.39036f
C362 a_27705_16071# a_25630_16071# 0.03208f
C363 a_12797_14024# a_13557_14024# 0.06198f
C364 a_16108_15316# a_23437_14024# 0.01319f
C365 a_4187_2434# a_5864_9057# 0.03252f
C366 a_19550_13226# a_21911_13190# 0.26208f
C367 a_13306_10795# a_14009_10774# 0.02454f
C368 a_25153_7532# a_25717_7532# 0.0114f
C369 a_18443_4687# a_18551_4687# 0.01163f
C370 a_24523_4687# a_24631_5315# 0.01697f
C371 a_5731_5979# a_8237_4687# 0.01319f
C372 a_8808_3889# a_8884_3853# 0.01176f
C373 a_16108_3134# a_22113_1842# 0.01872f
C374 a_12233_1842# a_12797_1842# 0.0114f
C375 a_13470_3889# a_14235_3889# 0.39037f
C376 a_15837_1842# a_15831_1008# 0.02354f
C377 a_19550_1044# a_20391_1008# 0.28268f
C378 a_23763_1842# VDD 0.49684f
C379 a_16851_309# VDD 0.51566f
C380 CHAN3_MUX_SEL2 CHAN3_MUX_OUT 0.08497f
C381 CHAN3_MUX_SEL3 CHAN3_MUX_SEL4 0.75489f
C382 a_8237_1842# a_4187_2434# 0.0414f
C383 VDD a_18004_16035# 0.28225f
C384 VDD a_10843_16869# 0.4973f
C385 VDD a_6635_6734# 0.15406f
C386 VDD a_17791_5315# 0.01806f
C387 REF_MUX_SEL0 a_3449_7085# 0.10753f
C388 a_25153_16869# a_25283_16869# 0.70845f
C389 a_17683_16869# a_17791_17497# 0.01697f
C390 a_6425_16071# a_6711_16035# 0.01885f
C391 a_4187_2434# a_25717_14024# 0.0414f
C392 a_5731_15316# a_7673_14024# 0.01865f
C393 a_17065_13226# a_16510_13226# 0.03209f
C394 a_4187_2434# a_16163_4687# 0.06627f
C395 a_16033_7532# a_16163_7532# 0.70845f
C396 a_4003_7532# a_4111_8160# 0.01697f
C397 a_11748_11799# a_11491_11918# 0.34468f
C398 a_21157_4687# a_20723_4687# 0.6972f
C399 a_5731_3134# a_6283_1842# 0.01542f
C400 a_5197_1842# a_5844_1008# 0.02312f
C401 a_15545_1044# a_15755_1044# 0.09424f
C402 a_7390_1044# a_8808_1044# 0.38994f
C403 a_6153_1842# VDD 0.4946f
C404 a_11848_1044# VDD 0.17575f
C405 a_3449_1395# CHAN3_MUX_SEL0 0.10753f
C406 CHAN0_MUX_SEL4 CHAN0_MUX_OUT 0.91933f
C407 a_22590_3889# a_22677_4687# 0.1088f
C408 VDD a_1721_16422# 0.4533f
C409 VDD a_15964_12471# 0.31312f
C410 VDD a_23633_14024# 0.49593f
C411 VDD a_15077_4687# 0.86122f
C412 VDD a_27671_8160# 0.01806f
C413 CHAN1_MUX_SEL1 a_2297_13577# 0.01995f
C414 CHAN1_MUX_OUT a_1544_13226# 0.04258f
C415 a_16597_16869# a_16163_16869# 0.69698f
C416 a_4187_2434# a_7043_14024# 0.06627f
C417 a_10843_14024# a_10951_14652# 0.01697f
C418 a_4763_14024# a_4871_14024# 0.01163f
C419 a_20593_14024# a_20723_14024# 0.70845f
C420 a_4187_2434# a_19833_7532# 0.11284f
C421 a_25630_13226# a_26985_12701# 0.02165f
C422 a_7477_7532# a_7043_7532# 0.69698f
C423 a_13368_6734# a_13470_6734# 0.37183f
C424 a_16108_5979# a_21353_4687# 0.01872f
C425 a_12037_4687# a_12233_4687# 0.77122f
C426 a_10083_1842# a_10191_2470# 0.01697f
C427 a_20397_1842# a_20593_1842# 0.76914f
C428 a_4003_1842# a_4111_1842# 0.01163f
C429 a_24957_1842# a_24951_1008# 0.02354f
C430 a_16408_3889# VDD 0.17274f
C431 a_24197_1842# a_4187_2434# 0.04141f
C432 VDD a_5957_14024# 0.86079f
C433 VDD a_26803_16869# 0.49671f
C434 VDD a_17683_7532# 0.49671f
C435 VDD a_11195_13226# 0.1539f
C436 VDD a_27915_6734# 0.15389f
C437 VDD a_9465_3889# 0.29742f
C438 DLL_RESETN a_6854_11144# 0.03626f
C439 a_4187_2434# a_11277_16869# 0.04141f
C440 a_7477_16869# a_7673_16869# 0.73897f
C441 a_12037_14024# a_11603_14024# 0.6972f
C442 a_16108_15316# a_20723_14024# 0.01544f
C443 a_19448_13226# a_19550_13226# 0.37183f
C444 a_24197_7532# a_24957_7532# 0.02912f
C445 a_15304_10295# a_13592_11113# 0.01817f
C446 a_6425_6734# a_4350_6734# 0.03208f
C447 a_5731_5979# a_5523_4687# 0.01562f
C448 a_16108_5979# a_20905_6209# 0.2906f
C449 a_24957_7532# a_16108_5979# 0.0157f
C450 a_23003_4687# a_23111_5315# 0.01697f
C451 a_16923_4687# a_17031_4687# 0.01163f
C452 a_7390_3889# a_7364_3853# 0.277f
C453 a_16108_3134# a_20397_1842# 0.01319f
C454 a_11277_1842# a_12037_1842# 0.03319f
C455 a_14317_1842# a_14964_1008# 0.02312f
C456 a_18795_1044# a_18871_1008# 0.01194f
C457 a_22113_1842# VDD 0.49655f
C458 CHAN3_DELAY_IN CHAN3_MUX_SEL1 0.01822f
C459 a_5523_1842# a_4187_2434# 0.06627f
C460 VDD a_9193_16869# 0.49285f
C461 VDD a_15755_16071# 0.15389f
C462 VDD a_11711_5315# 0.01806f
C463 a_16163_16869# a_16271_17497# 0.01697f
C464 a_4157_16340# a_4324_16035# 0.02463f
C465 a_24957_16869# a_16108_15316# 0.0157f
C466 a_4187_2434# a_23003_14024# 0.06627f
C467 a_16108_15316# a_17865_15546# 0.29564f
C468 a_4905_16071# a_4350_16071# 0.03209f
C469 a_5731_15316# a_5957_14024# 0.01644f
C470 a_4763_14024# a_4350_13226# 0.01012f
C471 a_14025_13226# a_14311_13190# 0.01885f
C472 a_10232_11561# a_10520_11982# 0.43707f
C473 a_4187_2434# a_14513_4687# 0.11222f
C474 a_7288_13226# a_7364_13190# 0.01176f
C475 a_13470_6734# a_14825_6209# 0.02058f
C476 a_19833_4687# a_20397_4687# 0.0114f
C477 a_15765_3308# a_16108_3134# 0.42004f
C478 a_4437_1842# a_4350_1044# 0.1088f
C479 a_4437_1842# VDD 0.87179f
C480 a_8884_1008# VDD 0.28328f
C481 CHAN0_MUX_SEL0 CHAN0_MUX_SEL1 3.14917f
C482 VDD a_21917_14024# 0.88247f
C483 VDD a_8745_12701# 0.29292f
C484 VDD a_21591_8160# 0.01806f
C485 VDD a_12363_4687# 0.50001f
C486 CHAN2_DELAY_IN a_4003_4687# 0.54998f
C487 CHAN2_MUX_SEL4 a_7390_3889# 0.34655f
C488 a_15273_16869# a_15837_16869# 0.0114f
C489 a_4187_2434# a_27237_16869# 0.06254f
C490 a_22590_16071# a_24951_16035# 0.26208f
C491 a_4187_2434# a_5393_14024# 0.11222f
C492 a_9323_14024# a_9431_14652# 0.01697f
C493 a_4187_2434# a_18117_7532# 0.04188f
C494 a_15077_7532# a_15545_6734# 0.2079f
C495 a_6153_7532# a_6717_7532# 0.0114f
C496 a_9323_7532# a_7390_6734# 0.01012f
C497 a_10713_4687# a_10843_4687# 0.70845f
C498 a_11848_6734# a_11924_6698# 0.01176f
C499 a_16108_5979# a_19637_4687# 0.01314f
C500 a_21625_6734# a_21911_6698# 0.01885f
C501 a_8563_1842# a_8671_2470# 0.01697f
C502 a_19073_1842# a_19203_1842# 0.70845f
C503 a_22590_3889# a_23431_3853# 0.28268f
C504 a_23437_1842# a_24084_1008# 0.02312f
C505 a_13470_3889# VDD 0.87936f
C506 CHAN1_MUX_OUT REF_DELAY_OUT_LAST 0.02664f
C507 a_21483_1842# a_4187_2434# 0.06627f
C508 a_26395_3889# a_26185_3889# 0.09424f
C509 VDD a_25153_16869# 0.49426f
C510 VDD a_23945_15546# 0.29292f
C511 VDD a_8231_13190# 0.28349f
C512 VDD a_16033_7532# 0.49413f
C513 VDD a_24951_6698# 0.2822f
C514 a_4187_2434# a_8563_16869# 0.06627f
C515 a_15077_16869# a_15545_16071# 0.2079f
C516 a_9323_16869# a_7390_16071# 0.01012f
C517 a_6153_16869# a_6283_16869# 0.70845f
C518 a_21625_16071# a_21835_16071# 0.09424f
C519 a_16108_15316# a_19073_14024# 0.01872f
C520 a_10713_14024# a_11277_14024# 0.0114f
C521 a_13883_14024# a_13470_13226# 0.01012f
C522 a_17928_13226# a_18004_13190# 0.01176f
C523 a_23437_7532# a_23003_7532# 0.6972f
C524 a_15403_4687# a_15511_4687# 0.01163f
C525 a_21483_4687# a_21591_5315# 0.01697f
C526 a_16108_3134# a_17683_1842# 0.01562f
C527 a_10517_1842# a_10083_1842# 0.69698f
C528 a_16510_1044# a_18004_1008# 0.28279f
C529 a_13557_1842# a_13470_1044# 0.1088f
C530 a_17275_1044# a_17351_1008# 0.01194f
C531 a_4350_1044# a_5705_519# 0.02005f
C532 a_20397_1842# VDD 0.87208f
C533 a_5705_519# VDD 0.29579f
C534 CHAN2_MUX_SEL3 CHAN2_MUX_SEL4 0.75489f
C535 CHAN2_MUX_SEL2 CHAN2_MUX_OUT 0.08497f
C536 VDD a_7477_16869# 0.86712f
C537 VDD a_12791_16035# 0.2822f
C538 VDD a_12907_10876# 0.0638f
C539 VDD a_17065_6734# 0.3023f
C540 VDD a_5631_5315# 0.01806f
C541 a_23437_16869# a_23633_16869# 0.76914f
C542 a_14643_16869# a_14751_17497# 0.01697f
C543 a_4187_2434# a_21353_14024# 0.11222f
C544 a_27997_14024# a_27563_14024# 0.69646f
C545 a_4187_2434# a_12797_4687# 0.0414f
C546 a_7477_14024# a_7945_13226# 0.19203f
C547 a_14317_7532# a_14513_7532# 0.76914f
C548 a_18443_7532# a_16510_6734# 0.01012f
C549 a_22488_6734# a_22564_6698# 0.01176f
C550 a_18877_4687# a_19637_4687# 0.06198f
C551 a_5731_3134# a_16108_3134# 0.01334f
C552 a_4350_1044# a_6635_1044# 0.39036f
C553 a_10985_1044# a_11195_1044# 0.09424f
C554 a_15765_3308# VDD 0.36528f
C555 a_6635_1044# VDD 0.15482f
C556 VDD a_19203_14024# 0.50004f
C557 VDD a_2873_12513# 0.46585f
C558 VDD a_15511_8160# 0.01806f
C559 VDD a_10713_4687# 0.49553f
C560 CHAN0_MUX_SEL4 a_12797_16869# 0.01829f
C561 REF_MUX_OUT a_16108_5979# 0.24265f
C562 a_18443_16869# a_16510_16071# 0.01012f
C563 a_4187_2434# a_24523_16869# 0.06627f
C564 a_14317_16869# a_15077_16869# 0.03319f
C565 a_22488_16071# a_22590_16071# 0.37183f
C566 a_23003_14024# a_22590_13226# 0.01012f
C567 a_18877_14024# a_19073_14024# 0.76914f
C568 a_1544_13226# a_1721_13577# 0.38063f
C569 a_4187_2434# a_15403_7532# 0.06668f
C570 a_7803_14024# a_7911_14652# 0.01697f
C571 a_1256_12471# a_1721_12513# 0.13421f
C572 a_5197_7532# a_5957_7532# 0.03319f
C573 a_9757_4687# a_10083_4687# 0.01427f
C574 a_20105_6734# a_19550_6734# 0.03209f
C575 a_16108_5979# a_16923_4687# 0.01073f
C576 a_10430_6734# a_10404_6698# 0.277f
C577 a_21835_3889# a_21911_3853# 0.01194f
C578 a_7043_1842# a_7151_2470# 0.01697f
C579 a_19550_1044# a_20905_519# 0.02165f
C580 a_22677_1842# a_22590_1044# 0.1088f
C581 a_27671_2470# VDD 0.01806f
C582 a_16108_289# CHAN3_MUX_OUT 0.24265f
C583 a_19833_1842# a_4187_2434# 0.11222f
C584 VDD a_23437_16869# 0.86919f
C585 VDD a_5768_13226# 0.17499f
C586 VDD a_11785_15546# 0.29292f
C587 VDD a_14317_7532# 0.87239f
C588 VDD a_22488_6734# 0.17274f
C589 VDD a_1544_3889# 0.45079f
C590 CHAN0_MUX_SEL0 a_3449_16422# 0.10753f
C591 CHAN1_MUX_SEL4 a_11785_12701# 0.03255f
C592 a_4187_2434# a_6913_16869# 0.11222f
C593 a_5197_16869# a_5523_16869# 0.01427f
C594 a_16108_15316# a_17357_14024# 0.01319f
C595 a_10328_16071# a_10404_16035# 0.01176f
C596 a_9757_14024# a_10517_14024# 0.06198f
C597 a_12797_14024# a_13368_13226# 0.10864f
C598 a_21157_14024# a_21625_13226# 0.2079f
C599 a_16510_13226# a_16484_13190# 0.277f
C600 a_12849_11557# a_14111_10917# 0.42064f
C601 a_14851_11918# a_14757_11918# 0.28931f
C602 a_22113_7532# a_22677_7532# 0.0114f
C603 a_27563_7532# a_25630_6734# 0.01024f
C604 a_5731_5979# a_14825_6209# 0.28056f
C605 a_19963_4687# a_20071_5315# 0.01697f
C606 a_26673_4687# a_26803_4687# 0.70845f
C607 a_13883_4687# a_13991_4687# 0.01163f
C608 a_4350_3889# a_5191_3853# 0.28268f
C609 a_9193_1842# a_9757_1842# 0.0114f
C610 a_16108_3134# a_16033_1842# 0.01197f
C611 a_17683_1842# VDD 0.49684f
C612 a_27915_1044# VDD 0.15464f
C613 CHAN2_DELAY_IN CHAN2_MUX_SEL1 0.01858f
C614 a_16108_3134# a_24957_4687# 0.0157f
C615 VDD a_4763_16869# 0.4973f
C616 VDD a_10328_16071# 0.17274f
C617 VDD a_26151_14652# 0.01806f
C618 VDD a_6425_6734# 0.29722f
C619 VDD a_14851_11918# 0.25841f
C620 VDD a_26673_4687# 0.49593f
C621 a_13123_16869# a_13231_17497# 0.01697f
C622 a_27563_16869# a_25630_16071# 0.01024f
C623 a_4187_2434# a_19637_14024# 0.0414f
C624 a_22113_16869# a_22243_16869# 0.70845f
C625 a_5731_15316# a_11785_15546# 0.28056f
C626 a_4187_2434# a_10083_4687# 0.06627f
C627 a_26673_14024# a_27237_14024# 0.0114f
C628 a_5957_14024# a_6425_13226# 0.2079f
C629 a_4350_13226# a_5115_13226# 0.39037f
C630 a_12993_7532# a_13123_7532# 0.70845f
C631 a_5731_12471# a_12849_11557# 0.01934f
C632 a_9547_11632# a_9547_11862# 0.1117f
C633 a_18117_4687# a_17683_4687# 0.6972f
C634 a_10430_6734# a_5731_5979# 0.41176f
C635 a_26477_1842# a_26043_1842# 0.6972f
C636 a_5731_3134# VDD 0.95083f
C637 VDD a_17553_14024# 0.49593f
C638 VDD a_27048_13226# 0.17499f
C639 VDD a_9431_8160# 0.01806f
C640 VDD a_8997_4687# 0.85996f
C641 REF_CLK a_13132_11110# 0.02025f
C642 a_4187_2434# a_22873_16869# 0.11222f
C643 a_13557_16869# a_13123_16869# 0.69698f
C644 a_20968_16071# a_21044_16035# 0.01176f
C645 a_6283_14024# a_6391_14652# 0.01697f
C646 a_4187_2434# a_13753_7532# 0.11222f
C647 a_17553_14024# a_17683_14024# 0.70845f
C648 a_21917_14024# a_22488_13226# 0.10864f
C649 a_4437_7532# a_4003_7532# 0.69698f
C650 a_17065_6734# a_17351_6698# 0.01885f
C651 a_8997_4687# a_9193_4687# 0.77122f
C652 a_19637_4687# a_20105_3889# 0.19203f
C653 a_12363_4687# a_10430_3889# 0.01012f
C654 a_19550_3889# a_21044_3853# 0.28279f
C655 a_20315_3889# a_20391_3853# 0.01194f
C656 a_17357_1842# a_17553_1842# 0.76914f
C657 a_5523_1842# a_5631_2470# 0.01697f
C658 a_25630_1044# a_27915_1044# 0.39036f
C659 a_21591_2470# VDD 0.01806f
C660 a_18117_1842# a_4187_2434# 0.04141f
C661 a_21911_3853# a_21625_3889# 0.01885f
C662 a_11924_3853# a_11848_3889# 0.01176f
C663 VDD a_20723_16869# 0.49671f
C664 VDD a_26185_13226# 0.30411f
C665 VDD a_19550_6734# 0.89766f
C666 VDD a_11603_7532# 0.49671f
C667 a_4187_2434# a_5197_16869# 0.04141f
C668 a_4437_16869# a_4633_16869# 0.73897f
C669 a_17065_16071# a_17275_16071# 0.09424f
C670 a_8997_14024# a_8563_14024# 0.6972f
C671 a_12797_14024# a_10430_13226# 0.02479f
C672 a_4187_2434# a_26043_4687# 0.06627f
C673 a_21157_7532# a_21917_7532# 0.02912f
C674 a_6854_11144# a_9712_9602# 0.6789f
C675 a_13592_11561# a_14757_11918# 0.43239f
C676 a_6126_9506# a_5864_9057# 0.23738f
C677 a_18877_7532# a_16108_5979# 0.0157f
C678 a_4437_4687# a_4905_3889# 0.19203f
C679 a_12363_4687# a_12471_4687# 0.01163f
C680 a_18443_4687# a_18551_5315# 0.01697f
C681 a_7945_3889# a_8155_3889# 0.09424f
C682 a_8237_1842# a_8997_1842# 0.03319f
C683 a_26185_1044# a_26395_1044# 0.09424f
C684 a_13470_1044# a_15831_1008# 0.26208f
C685 a_16033_1842# VDD 0.49413f
C686 a_24951_1008# VDD 0.2841f
C687 REF_MUX_SEL2 REF_MUX_OUT 0.08497f
C688 REF_MUX_SEL3 REF_MUX_SEL4 0.75489f
C689 VDD a_7390_16071# 0.8686f
C690 VDD a_20071_14652# 0.01806f
C691 VDD a_13592_11561# 0.07382f
C692 VDD a_24957_4687# 0.88247f
C693 CHAN1_DELAY_IN a_4003_14024# 0.54998f
C694 CHAN0_DELAY_OUT_LAST a_27997_16869# 0.70955f
C695 CHAN1_MUX_SEL4 a_7390_13226# 0.34655f
C696 a_11603_16869# a_11711_17497# 0.01697f
C697 a_4187_2434# a_16923_14024# 0.06627f
C698 a_18877_16869# a_16108_15316# 0.0157f
C699 a_4437_14024# a_4157_13495# 0.01771f
C700 a_25717_14024# a_26477_14024# 0.01669f
C701 a_4187_2434# a_8433_4687# 0.11222f
C702 a_9465_13226# a_7390_13226# 0.03208f
C703 a_5974_11413# a_6854_11676# 0.029f
C704 a_6326_10280# a_6126_9506# 2.84014f
C705 a_19550_6734# a_20315_6734# 0.39037f
C706 a_7390_6734# a_8745_6209# 0.01756f
C707 a_16793_4687# a_17357_4687# 0.0114f
C708 a_25153_1842# a_25717_1842# 0.0114f
C709 a_2297_3176# VDD 0.46603f
C710 a_17065_1044# VDD 0.30321f
C711 a_16510_3889# a_18443_4687# 0.01012f
C712 VDD a_15837_14024# 0.87964f
C713 VDD a_24084_13190# 0.28225f
C714 VDD a_27563_7532# 0.49811f
C715 VDD a_6283_4687# 0.50001f
C716 REF_MUX_SEL4 a_5705_6209# 0.03556f
C717 a_12233_16869# a_12797_16869# 0.0114f
C718 a_4187_2434# a_21157_16869# 0.04152f
C719 a_19550_16071# a_19524_16035# 0.277f
C720 a_7390_16071# a_5731_15316# 0.41331f
C721 a_4187_2434# a_12037_7532# 0.04152f
C722 a_4763_14024# a_4871_14652# 0.01697f
C723 a_25630_13226# a_26395_13226# 0.39037f
C724 a_21917_14024# a_19550_13226# 0.02479f
C725 a_16510_13226# a_16108_12471# 0.56108f
C726 a_5197_7532# a_5768_6734# 0.10863f
C727 a_7390_6734# a_8231_6698# 0.28268f
C728 a_5731_5979# a_15403_4687# 0.01563f
C729 a_7673_4687# a_7803_4687# 0.70845f
C730 a_4003_1842# a_4111_2470# 0.01697f
C731 a_16033_1842# a_16163_1842# 0.70845f
C732 a_15511_2470# VDD 0.01806f
C733 a_5705_519# CHAN3_MUX_SEL4 0.03556f
C734 VDD REF_CLK 2.08938f
C735 a_15403_1842# a_4187_2434# 0.06627f
C736 a_19550_3889# a_20105_3889# 0.03209f
C737 VDD a_1544_15316# 0.39372f
C738 VDD a_19073_16869# 0.49426f
C739 VDD a_14025_13226# 0.30411f
C740 VDD a_9953_7532# 0.49426f
C741 VDD a_16484_6698# 0.28687f
C742 CHAN1_MUX_SEL4 a_1544_12471# 0.47529f
C743 CHAN1_MUX_OUT a_1256_12471# 0.1134f
C744 CHAN1_MUX_SEL2 a_2297_12513# 0.10655f
C745 a_5197_16869# a_5768_16071# 0.10863f
C746 a_7390_16071# a_8155_16071# 0.39037f
C747 a_10517_14024# a_10404_13190# 0.05157f
C748 a_7673_14024# a_8237_14024# 0.0114f
C749 a_4187_2434# a_24393_4687# 0.11222f
C750 a_13470_13226# a_14311_13190# 0.28268f
C751 a_13019_11521# a_15688_11557# 0.0195f
C752 a_13306_11995# a_14111_11568# 0.097f
C753 a_12849_11557# a_15108_11799# 0.10225f
C754 a_13121_11521# a_14851_11918# 0.03404f
C755 a_20397_7532# a_19963_7532# 0.6972f
C756 a_25630_6734# a_16108_5979# 0.55833f
C757 a_16923_4687# a_17031_5315# 0.01697f
C758 a_10843_4687# a_10951_4687# 0.01163f
C759 a_24957_4687# a_25153_4687# 0.76914f
C760 a_5731_3134# a_14513_1842# 0.01872f
C761 a_7477_1842# a_7043_1842# 0.69698f
C762 a_13368_1044# a_13470_1044# 0.37183f
C763 a_14317_1842# VDD 0.87208f
C764 a_22488_1044# VDD 0.17444f
C765 a_25630_3889# a_27563_4687# 0.01024f
C766 VDD a_4324_16035# 0.28687f
C767 VDD a_12656_11554# 0.26377f
C768 VDD a_13991_14652# 0.01806f
C769 VDD a_22243_4687# 0.50004f
C770 CHAN0_MUX_OUT a_16108_15316# 0.24265f
C771 a_10083_16869# a_10191_17497# 0.01697f
C772 a_20397_16869# a_20593_16869# 0.76914f
C773 a_4187_2434# a_15273_14024# 0.11222f
C774 a_4187_2434# a_27997_7532# 0.04038f
C775 a_24957_14024# a_24523_14024# 0.6972f
C776 a_4187_2434# a_6717_4687# 0.0414f
C777 a_11277_7532# a_11473_7532# 0.76914f
C778 a_14317_7532# a_14888_6734# 0.10863f
C779 a_15837_4687# a_16597_4687# 0.06198f
C780 a_22590_3889# a_23945_3364# 0.02165f
C781 a_24957_1842# a_16108_289# 0.0157f
C782 a_24197_1842# a_24957_1842# 0.02912f
C783 a_6425_1044# a_4350_1044# 0.03208f
C784 a_16108_289# a_20905_519# 0.2906f
C785 a_26471_3853# VDD 0.28357f
C786 a_6425_1044# VDD 0.29845f
C787 a_13470_3889# CHAN2_MUX_SEL4 0.256f
C788 a_5731_3134# a_10430_3889# 0.41176f
C789 VDD a_13123_14024# 0.49994f
C790 VDD a_24631_17497# 0.01806f
C791 VDD a_21835_13226# 0.15407f
C792 VDD a_25913_7532# 0.49294f
C793 VDD a_4633_4687# 0.49523f
C794 DLL_RESETN a_4187_2434# 0.07017f
C795 CHAN0_MUX_SEL4 a_6717_16869# 0.0195f
C796 VDD a_9751_3853# 0.2822f
C797 DLL_RESETN a_12943_11557# 0.03616f
C798 REF_MUX_SEL2 a_1256_5979# 0.33134f
C799 a_11277_16869# a_12037_16869# 0.03319f
C800 a_4187_2434# a_18443_16869# 0.06627f
C801 a_14317_16869# a_14888_16071# 0.10863f
C802 a_15837_14024# a_16033_14024# 0.76914f
C803 a_4187_2434# a_9323_7532# 0.06627f
C804 a_19637_14024# a_19524_13190# 0.05157f
C805 a_6635_6734# a_6711_6698# 0.01194f
C806 a_5731_5979# a_13753_4687# 0.01865f
C807 a_6717_4687# a_7043_4687# 0.01427f
C808 a_16510_3889# a_18871_3853# 0.26208f
C809 a_13470_1044# a_14825_519# 0.02058f
C810 a_9431_2470# VDD 0.01806f
C811 VDD CHAN1_DELAY_OUT_LAST 0.46919f
C812 a_1256_289# CHAN3_MUX_SEL2 0.33134f
C813 a_13753_1842# a_4187_2434# 0.11222f
C814 a_17351_3853# a_17065_3889# 0.01885f
C815 VDD a_17357_16869# 0.86919f
C816 VDD a_25604_16035# 0.28633f
C817 VDD a_8237_7532# 0.86919f
C818 VDD a_4157_13495# 0.48936f
C819 VDD a_14235_6734# 0.15389f
C820 REF_DELAY_OUT_LAST a_15688_11093# 0.01699f
C821 a_5731_15316# a_13123_14024# 0.01539f
C822 a_12505_16071# a_12791_16035# 0.01885f
C823 a_6717_14024# a_7477_14024# 0.06198f
C824 a_13121_11521# a_13592_11561# 0.01445f
C825 a_24665_13226# a_22590_13226# 0.03208f
C826 a_12849_11557# a_13566_11525# 0.27346f
C827 a_4187_2434# a_22677_4687# 0.0414f
C828 a_12715_13226# a_12791_13190# 0.01194f
C829 a_19073_7532# a_19637_7532# 0.0114f
C830 a_23437_7532# a_24008_6734# 0.10863f
C831 a_1544_6734# a_2297_7085# 0.28651f
C832 a_23633_4687# a_23763_4687# 0.70845f
C833 a_15403_4687# a_15511_5315# 0.01697f
C834 a_4157_4158# a_4248_3889# 0.11672f
C835 a_9323_4687# a_9431_4687# 0.01163f
C836 a_6153_1842# a_6717_1842# 0.0114f
C837 a_5731_3134# a_12797_1842# 0.01307f
C838 a_15077_1842# a_15545_1044# 0.2079f
C839 a_21625_1044# a_21911_1008# 0.01885f
C840 a_9323_1842# a_7390_1044# 0.01012f
C841 a_11848_1044# a_11924_1008# 0.01176f
C842 a_11603_1842# VDD 0.49684f
C843 a_19550_1044# VDD 1.09641f
C844 a_15765_3308# CHAN2_MUX_SEL4 0.65508f
C845 VDD CHAN3_MUX_SEL2 0.51007f
C846 a_16108_3134# a_18877_4687# 0.0157f
C847 VDD a_21625_16071# 0.29722f
C848 VDD a_7911_14652# 0.01806f
C849 VDD a_10751_11568# 0.20524f
C850 VDD a_20593_4687# 0.49593f
C851 a_8563_16869# a_8671_17497# 0.01697f
C852 a_19073_16869# a_19203_16869# 0.70845f
C853 a_1256_15316# a_2873_15358# 0.27926f
C854 a_1256_16071# a_2297_16422# 0.04619f
C855 a_1544_15316# a_2297_15358# 0.27303f
C856 a_23437_16869# a_24008_16071# 0.10863f
C857 a_4187_2434# a_13557_14024# 0.0414f
C858 a_22590_16071# a_16108_15316# 0.58202f
C859 a_23633_14024# a_24197_14024# 0.0114f
C860 a_4187_2434# a_25283_7532# 0.06661f
C861 a_4187_2434# a_4003_4687# 0.05992f
C862 a_15964_12471# a_16108_12471# 0.42202f
C863 a_5731_12471# a_6126_9506# 0.02557f
C864 a_9953_7532# a_10083_7532# 0.70845f
C865 a_16108_5979# a_26803_4687# 0.01544f
C866 a_16510_6734# a_17928_6734# 0.38994f
C867 a_15077_4687# a_14643_4687# 0.6972f
C868 a_23437_1842# a_23003_1842# 0.6972f
C869 a_24008_3889# VDD 0.17499f
C870 a_8745_3364# a_7390_3889# 0.01756f
C871 VDD a_18551_17497# 0.01806f
C872 VDD a_11473_14024# 0.49593f
C873 VDD a_18871_13190# 0.2822f
C874 VDD a_24197_7532# 0.85889f
C875 VDD a_7288_3889# 0.17274f
C876 VDD a_16108_5979# 1.62848f
C877 CHAN1_DELAY_IN a_4187_2434# 0.07719f
C878 DLL_RESETN a_12849_11557# 0.3501f
C879 REF_CLK a_13121_11521# 1.40135f
C880 CHAN2_MUX_OUT a_1256_3889# 0.02466f
C881 CHAN2_MUX_SEL0 a_2297_4240# 0.10655f
C882 CHAN2_MUX_SEL4 a_1544_3889# 0.03407f
C883 a_4187_2434# a_25630_16071# 0.02227f
C884 a_10517_16869# a_10083_16869# 0.69698f
C885 a_4187_2434# a_16793_16869# 0.11222f
C886 a_4187_2434# a_7673_7532# 0.11222f
C887 a_16108_15316# a_27237_14024# 0.01319f
C888 a_16510_16071# a_17351_16035# 0.28268f
C889 a_14513_14024# a_14643_14024# 0.70845f
C890 a_22590_13226# a_24008_13226# 0.38994f
C891 a_27237_7532# a_27433_7532# 0.77122f
C892 a_5731_5979# a_12037_4687# 0.01319f
C893 a_4350_6734# a_5844_6698# 0.28279f
C894 a_5115_6734# a_5191_6698# 0.01194f
C895 a_12505_6734# a_10430_6734# 0.03208f
C896 a_5957_4687# a_6153_4687# 0.77122f
C897 a_8237_4687# a_8808_3889# 0.10863f
C898 a_16408_3889# a_16510_3889# 0.37183f
C899 a_16108_3134# a_25913_1842# 0.01865f
C900 a_14317_1842# a_14513_1842# 0.76914f
C901 a_18443_1842# a_16510_1044# 0.01012f
C902 a_22488_1044# a_22564_1008# 0.01176f
C903 a_27563_1842# VDD 0.50198f
C904 VDD CHAN0_DELAY_OUT_LAST 0.46312f
C905 a_12037_1842# a_4187_2434# 0.04141f
C906 VDD a_14643_16869# 0.49671f
C907 VDD a_23355_16071# 0.15389f
C908 VDD a_11271_6698# 0.28357f
C909 VDD a_5523_7532# 0.49671f
C910 REF_DELAY_OUT_LAST a_13592_11113# 0.08062f
C911 a_10985_16071# a_10430_16071# 0.03209f
C912 a_5957_14024# a_5523_14024# 0.6972f
C913 a_4350_16071# a_5768_16071# 0.38994f
C914 a_5731_15316# a_11473_14024# 0.01872f
C915 a_10430_13226# a_11924_13190# 0.28279f
C916 a_11195_13226# a_11271_13190# 0.01194f
C917 a_8997_14024# a_7390_13226# 0.05231f
C918 a_8237_14024# a_8231_13190# 0.02349f
C919 a_4187_2434# a_19963_4687# 0.06627f
C920 a_12355_11557# a_12849_11557# 0.07687f
C921 a_18117_7532# a_18877_7532# 0.02912f
C922 a_7803_4687# a_7911_4687# 0.01163f
C923 a_13883_4687# a_13991_5315# 0.01697f
C924 a_27915_6734# a_27991_6698# 0.01194f
C925 a_5197_1842# a_5957_1842# 0.03319f
C926 a_5731_3134# a_10083_1842# 0.01539f
C927 a_10430_1044# a_10404_1008# 0.277f
C928 a_20105_1044# a_19550_1044# 0.03209f
C929 a_9953_1842# VDD 0.49655f
C930 a_16484_1008# VDD 0.28723f
C931 a_5731_3134# CHAN2_MUX_SEL4 4.60702f
C932 VDD CHAN2_MUX_SEL2 0.59889f
C933 CHAN1_MUX_SEL3 CHAN1_MUX_OUT 0.79533f
C934 VDD a_9465_16071# 0.29722f
C935 VDD a_27433_14024# 0.4946f
C936 VDD a_9772_11533# 0.24887f
C937 VDD a_18877_4687# 0.88247f
C938 CHAN0_MUX_SEL4 a_5705_15546# 0.03556f
C939 a_7043_16869# a_7151_17497# 0.01697f
C940 a_4187_2434# a_10843_14024# 0.06627f
C941 a_21917_14024# a_16108_12471# 0.0157f
C942 a_4187_2434# a_23633_7532# 0.11286f
C943 a_22677_14024# a_23437_14024# 0.01669f
C944 a_13753_4687# a_14317_4687# 0.0114f
C945 a_16108_5979# a_25153_4687# 0.01872f
C946 a_22113_1842# a_22677_1842# 0.0114f
C947 a_27563_1842# a_25630_1044# 0.01024f
C948 a_5731_289# a_14825_519# 0.28056f
C949 a_21044_3853# VDD 0.28225f
C950 a_27997_1842# a_4187_2434# 0.04001f
C951 a_14888_3889# a_14317_4687# 0.10863f
C952 VDD a_12471_17497# 0.01806f
C953 VDD a_16408_13226# 0.17274f
C954 VDD a_9757_14024# 0.88193f
C955 VDD a_21483_7532# 0.4973f
C956 VDD a_4350_3889# 0.87635f
C957 CHAN0_DELAY_IN a_4187_2434# 0.07974f
C958 REF_CLK a_11491_11918# 0.01827f
C959 DLL_RESETN a_12158_11557# 0.02442f
C960 a_4187_2434# a_15077_16869# 0.04194f
C961 a_9193_16869# a_9757_16869# 0.0114f
C962 a_4187_2434# a_5957_7532# 0.04152f
C963 a_15755_16071# a_15831_16035# 0.01194f
C964 a_27705_16071# a_27991_16035# 0.01885f
C965 a_16108_15316# a_24523_14024# 0.01542f
C966 a_18117_14024# a_16510_13226# 0.05231f
C967 a_17357_14024# a_17351_13190# 0.02349f
C968 a_25913_7532# a_26043_7532# 0.70845f
C969 a_4633_4687# a_4763_4687# 0.70845f
C970 a_5731_5979# a_9323_4687# 0.01542f
C971 a_14888_3889# a_14964_3853# 0.01176f
C972 a_16108_3134# a_24197_1842# 0.01319f
C973 a_12993_1842# a_13123_1842# 0.70845f
C974 a_10430_1044# a_5731_289# 0.41176f
C975 a_25913_1842# VDD 0.49553f
C976 a_9323_1842# a_4187_2434# 0.06627f
C977 VDD a_20391_16035# 0.28357f
C978 VDD a_12993_16869# 0.49426f
C979 VDD a_8808_6734# 0.17499f
C980 VDD a_5864_9057# 0.13532f
C981 VDD a_23111_5315# 0.01806f
C982 REF_DELAY_OUT_LAST a_15304_10295# 0.05582f
C983 a_26477_16869# a_26043_16869# 0.6972f
C984 a_7945_16071# a_8231_16035# 0.01885f
C985 a_4187_2434# a_26803_14024# 0.06627f
C986 a_4633_14024# a_5197_14024# 0.0114f
C987 a_5731_15316# a_9757_14024# 0.01307f
C988 a_18585_13226# a_18795_13226# 0.09424f
C989 a_4187_2434# a_18313_4687# 0.11222f
C990 a_6717_14024# a_7364_13190# 0.02011f
C991 a_12158_11557# a_12355_11557# 0.12454f
C992 a_17357_7532# a_16923_7532# 0.6972f
C993 a_12363_4687# a_12471_5315# 0.01697f
C994 a_25630_6734# a_27124_6698# 0.28279f
C995 a_6283_4687# a_6391_4687# 0.01163f
C996 a_21917_4687# a_22113_4687# 0.76914f
C997 a_26395_6734# a_26471_6698# 0.01194f
C998 a_4437_1842# a_4003_1842# 0.69698f
C999 a_5731_3134# a_8433_1842# 0.01872f
C1000 a_17065_1044# a_17351_1008# 0.01885f
C1001 a_8237_1842# VDD 0.87208f
C1002 a_14235_1044# VDD 0.15465f
C1003 a_2297_3176# CHAN2_MUX_SEL4 0.04338f
C1004 a_3449_3176# CHAN2_MUX_SEL2 0.10741f
C1005 a_2873_3176# CHAN2_MUX_SEL3 0.12606f
C1006 VDD REF_MUX_SEL2 0.59889f
C1007 a_24008_3889# a_23437_4687# 0.10863f
C1008 VDD a_25717_14024# 0.87095f
C1009 VDD a_6326_10280# 7.58054f
C1010 VDD a_16163_4687# 0.49822f
C1011 CHAN0_MUX_SEL2 a_1256_15316# 0.33134f
C1012 a_17357_16869# a_17553_16869# 0.76914f
C1013 a_5523_16869# a_5631_17497# 0.01697f
C1014 a_4187_2434# a_9193_14024# 0.11222f
C1015 a_4187_2434# a_21917_7532# 0.04176f
C1016 a_21917_14024# a_21483_14024# 0.6972f
C1017 a_25630_16071# a_27048_16071# 0.38994f
C1018 a_16510_16071# a_17865_15546# 0.02165f
C1019 a_26477_14024# a_26471_13190# 0.02349f
C1020 a_27237_14024# a_25630_13226# 0.05253f
C1021 a_8237_7532# a_8433_7532# 0.76914f
C1022 a_27705_6734# a_25630_6734# 0.03208f
C1023 a_10843_7532# a_10430_6734# 0.01012f
C1024 a_13470_6734# a_15755_6734# 0.39036f
C1025 a_16108_5979# a_23437_4687# 0.01319f
C1026 a_12797_4687# a_13557_4687# 0.06198f
C1027 a_25528_3889# a_25604_3853# 0.01176f
C1028 a_18877_1842# a_16108_289# 0.0157f
C1029 a_21157_1842# a_21917_1842# 0.02912f
C1030 a_18795_3889# VDD 0.15407f
C1031 a_25283_1842# a_4187_2434# 0.06627f
C1032 VDD a_6391_17497# 0.01806f
C1033 VDD a_7043_14024# 0.4999f
C1034 VDD a_13470_13226# 0.87936f
C1035 VDD a_19833_7532# 0.49294f
C1036 VDD a_3449_6021# 0.47499f
C1037 VDD a_20105_3889# 0.30411f
C1038 DLL_RESETN a_10206_11525# 0.27343f
C1039 CHAN1_MUX_OUT a_10232_11561# 0.01279f
C1040 a_8237_16869# a_8997_16869# 0.03319f
C1041 a_4187_2434# a_12363_16869# 0.06627f
C1042 a_13470_16071# a_14964_16035# 0.28279f
C1043 a_26185_16071# a_25630_16071# 0.03209f
C1044 a_14235_16071# a_14311_16035# 0.01194f
C1045 a_10843_16869# a_10430_16071# 0.01012f
C1046 a_12797_14024# a_12993_14024# 0.76914f
C1047 a_4187_2434# a_9712_9602# 0.14197f
C1048 a_16108_15316# a_22873_14024# 0.01865f
C1049 a_19550_13226# a_21835_13226# 0.39036f
C1050 a_15837_14024# a_16484_13190# 0.02011f
C1051 a_24957_7532# a_25283_7532# 0.01427f
C1052 a_13566_11018# a_14009_10774# 0.02242f
C1053 a_13306_10795# a_13592_11113# 0.41329f
C1054 a_15304_10295# a_15108_11015# 0.01986f
C1055 a_6425_6734# a_6711_6698# 0.01885f
C1056 a_5731_5979# a_7673_4687# 0.01865f
C1057 a_16108_3134# a_21483_1842# 0.01542f
C1058 a_13470_3889# a_13444_3853# 0.277f
C1059 a_19550_1044# a_20315_1044# 0.39037f
C1060 a_7390_1044# a_8745_519# 0.01756f
C1061 a_24197_1842# VDD 0.85988f
C1062 a_16108_289# VDD 1.29784f
C1063 CHAN3_MUX_SEL2 CHAN3_MUX_SEL4 0.01978f
C1064 a_7673_1842# a_4187_2434# 0.11222f
C1065 VDD a_17928_16071# 0.17499f
C1066 VDD a_11277_16869# 0.86919f
C1067 VDD a_13880_10808# 0.02994f
C1068 VDD a_5844_6698# 0.28225f
C1069 VDD a_17031_5315# 0.01806f
C1070 a_25153_16869# a_25717_16869# 0.0114f
C1071 a_6425_16071# a_6635_16071# 0.09424f
C1072 a_4187_2434# a_25153_14024# 0.11222f
C1073 a_5731_15316# a_7043_14024# 0.01539f
C1074 a_5957_14024# a_5844_13190# 0.02055f
C1075 a_7390_13226# a_9751_13190# 0.26208f
C1076 a_4187_2434# a_16597_4687# 0.0414f
C1077 a_10751_11568# a_11491_11918# 0.26905f
C1078 a_16033_7532# a_16597_7532# 0.0114f
C1079 a_19963_7532# a_19550_6734# 0.01012f
C1080 a_10843_4687# a_10951_5315# 0.01697f
C1081 a_4763_4687# a_4871_4687# 0.01163f
C1082 a_20593_4687# a_20723_4687# 0.70845f
C1083 a_5731_3134# a_6717_1842# 0.01307f
C1084 a_16108_3134# a_26985_3364# 0.2906f
C1085 a_7390_1044# a_8231_1008# 0.28268f
C1086 a_5197_1842# a_5768_1044# 0.10863f
C1087 a_5523_1842# VDD 0.49684f
C1088 a_11271_1008# VDD 0.28439f
C1089 a_4157_1313# CHAN3_DELAY_IN 0.50642f
C1090 CHAN0_MUX_SEL2 CHAN1_DELAY_IN 0.25306f
C1091 CHAN0_MUX_SEL3 CHAN0_MUX_OUT 0.79533f
C1092 VDD a_23003_14024# 0.50058f
C1093 VDD a_1544_16071# 0.45079f
C1094 VDD a_15765_12645# 0.35715f
C1095 VDD a_14513_4687# 0.49593f
C1096 VDD a_26911_8160# 0.01806f
C1097 CHAN1_MUX_OUT a_1256_13226# 0.02466f
C1098 REF_CLK a_4003_7532# 0.55467f
C1099 CHAN1_MUX_SEL0 a_2297_13577# 0.10655f
C1100 CHAN1_MUX_SEL4 a_1544_13226# 0.03407f
C1101 a_4003_16869# a_4111_17497# 0.01697f
C1102 a_16033_16869# a_16163_16869# 0.70845f
C1103 a_4187_2434# a_7477_14024# 0.0414f
C1104 a_19963_16869# a_19550_16071# 0.01012f
C1105 a_4187_2434# a_19203_7532# 0.06661f
C1106 a_20593_14024# a_21157_14024# 0.0114f
C1107 a_5705_12701# a_5731_12471# 0.28954f
C1108 a_24957_14024# a_25604_13190# 0.02011f
C1109 a_9757_7532# a_10328_6734# 0.10864f
C1110 a_16597_7532# a_17065_6734# 0.19203f
C1111 a_6913_7532# a_7043_7532# 0.70845f
C1112 a_16108_5979# a_20723_4687# 0.01544f
C1113 a_12037_4687# a_11603_4687# 0.6972f
C1114 a_20397_1842# a_19963_1842# 0.6972f
C1115 a_25630_1044# a_16108_289# 0.55833f
C1116 a_15831_3853# VDD 0.2816f
C1117 REF_CLK REF_MUX_SEL4 0.0663f
C1118 a_23633_1842# a_4187_2434# 0.11222f
C1119 VDD a_5393_14024# 0.49643f
C1120 VDD a_27237_16869# 0.86022f
C1121 VDD a_10404_13190# 0.28633f
C1122 VDD a_18117_7532# 0.85889f
C1123 VDD a_27124_6698# 0.28225f
C1124 VDD a_7945_3889# 0.30411f
C1125 REF_CLK a_6854_11676# 0.05061f
C1126 CHAN1_MUX_OUT a_6854_11144# 0.16652f
C1127 DLL_RESETN a_6126_9506# 0.06398f
C1128 a_7477_16869# a_7043_16869# 0.69698f
C1129 a_16597_16869# a_17065_16071# 0.19203f
C1130 a_4187_2434# a_10713_16869# 0.11222f
C1131 a_9757_16869# a_10328_16071# 0.10864f
C1132 a_23145_16071# a_23431_16035# 0.01885f
C1133 a_15077_14024# a_14964_13190# 0.02055f
C1134 a_11473_14024# a_11603_14024# 0.70845f
C1135 a_16108_15316# a_21157_14024# 0.01319f
C1136 a_24197_7532# a_24393_7532# 0.77122f
C1137 a_13106_11047# a_13132_11110# 0.1657f
C1138 a_12907_10876# a_12907_11110# 0.1117f
C1139 a_4157_7003# a_4324_6698# 0.02463f
C1140 a_16108_5979# a_17865_6209# 0.29564f
C1141 a_5731_5979# a_5957_4687# 0.01644f
C1142 a_4905_6734# a_4350_6734# 0.03209f
C1143 a_4763_4687# a_4350_3889# 0.01012f
C1144 a_7288_3889# a_7364_3853# 0.01176f
C1145 a_16108_3134# a_19833_1842# 0.01865f
C1146 a_11277_1842# a_11473_1842# 0.76914f
C1147 a_14317_1842# a_14888_1044# 0.10863f
C1148 a_21483_1842# VDD 0.50001f
C1149 a_5957_1842# a_4187_2434# 0.04141f
C1150 VDD a_8563_16869# 0.49671f
C1151 VDD a_14964_16035# 0.28225f
C1152 VDD a_14111_10917# 0.33926f
C1153 VDD a_27705_6734# 0.29962f
C1154 VDD a_10951_5315# 0.01806f
C1155 REF_MUX_SEL1 a_1544_6734# 0.1672f
C1156 REF_MUX_SEL0 a_1721_7085# 0.01315f
C1157 a_24197_16869# a_24957_16869# 0.02912f
C1158 a_4187_2434# a_23437_14024# 0.0414f
C1159 a_16108_15316# a_16851_15336# 0.06181f
C1160 a_4157_16340# a_4350_16071# 0.04624f
C1161 a_8997_14024# a_9465_13226# 0.2079f
C1162 a_5197_14024# a_4350_13226# 0.08038f
C1163 a_4187_2434# a_13883_4687# 0.06627f
C1164 a_14025_13226# a_14235_13226# 0.09424f
C1165 a_7288_13226# a_7390_13226# 0.37183f
C1166 a_15077_7532# a_15837_7532# 0.02912f
C1167 a_18877_7532# a_19448_6734# 0.10864f
C1168 a_22590_6734# a_24951_6698# 0.26208f
C1169 a_9323_4687# a_9431_5315# 0.01697f
C1170 a_15765_3308# a_15964_3134# 0.061f
C1171 a_6635_1044# a_6711_1008# 0.01194f
C1172 a_26985_3364# VDD 0.29292f
C1173 a_8808_1044# VDD 0.17575f
C1174 a_1721_1395# CHAN3_MUX_SEL0 0.01315f
C1175 a_1544_1044# CHAN3_MUX_SEL1 0.1672f
C1176 VDD a_21353_14024# 0.4946f
C1177 VDD a_5731_12471# 0.84177f
C1178 VDD a_20831_8160# 0.01806f
C1179 VDD a_12797_4687# 0.88193f
C1180 CHAN2_DELAY_IN a_4437_4687# 0.05007f
C1181 REF_MUX_SEL4 a_4633_4687# 0.01287f
C1182 a_4187_2434# a_26673_16869# 0.11222f
C1183 a_4187_2434# a_4763_14024# 0.06627f
C1184 a_18877_16869# a_19448_16071# 0.10864f
C1185 a_22590_16071# a_24875_16071# 0.39036f
C1186 a_4187_2434# a_17553_7532# 0.11284f
C1187 a_24197_14024# a_24084_13190# 0.02055f
C1188 a_19637_14024# a_20397_14024# 0.01669f
C1189 a_9757_7532# a_7390_6734# 0.02479f
C1190 a_16108_5979# a_19073_4687# 0.01872f
C1191 a_21625_6734# a_21835_6734# 0.09424f
C1192 a_10713_4687# a_11277_4687# 0.0114f
C1193 a_22590_3889# a_23355_3889# 0.39037f
C1194 a_19073_1842# a_19637_1842# 0.0114f
C1195 a_23437_1842# a_24008_1044# 0.10863f
C1196 a_1544_1044# a_2297_1395# 0.28651f
C1197 a_13368_3889# VDD 0.17274f
C1198 a_21917_1842# a_4187_2434# 0.0414f
C1199 a_25630_3889# a_27705_3889# 0.03208f
C1200 VDD a_24523_16869# 0.4973f
C1201 VDD a_20905_15546# 0.29292f
C1202 VDD a_8155_13226# 0.1539f
C1203 VDD a_15403_7532# 0.4973f
C1204 VDD a_24875_6734# 0.15406f
C1205 VDD a_2873_4240# 0.46517f
C1206 a_9757_16869# a_7390_16071# 0.02479f
C1207 a_6153_16869# a_6717_16869# 0.0114f
C1208 a_4187_2434# a_8997_16869# 0.04152f
C1209 a_10430_16071# a_12791_16035# 0.26208f
C1210 a_16108_15316# a_18443_14024# 0.01542f
C1211 a_22677_14024# a_23145_13226# 0.19203f
C1212 a_14317_14024# a_13470_13226# 0.08038f
C1213 a_22873_7532# a_23003_7532# 0.70845f
C1214 a_7477_4687# a_7945_3889# 0.19203f
C1215 a_27997_4687# a_27563_4687# 0.69646f
C1216 a_9953_1842# a_10083_1842# 0.70845f
C1217 a_16108_3134# a_18117_1842# 0.01644f
C1218 a_16510_1044# a_17928_1044# 0.38994f
C1219 a_19833_1842# VDD 0.49553f
C1220 a_3449_331# VDD 0.46666f
C1221 CHAN2_MUX_SEL2 CHAN2_MUX_SEL4 0.01978f
C1222 CHAN2_MUX_SEL1 CHAN2_MUX_OUT 0.09357f
C1223 VDD a_6913_16869# 0.49426f
C1224 VDD a_12715_16071# 0.15406f
C1225 VDD a_15545_6734# 0.29962f
C1226 VDD a_13106_11047# 0.09231f
C1227 VDD a_4871_5315# 0.01806f
C1228 a_23437_16869# a_23003_16869# 0.6972f
C1229 a_4187_2434# a_20723_14024# 0.06627f
C1230 a_27433_14024# a_27563_14024# 0.70845f
C1231 a_5768_13226# a_5844_13190# 0.01176f
C1232 a_4187_2434# a_12233_4687# 0.11222f
C1233 a_14317_7532# a_13883_7532# 0.6972f
C1234 a_18877_7532# a_16510_6734# 0.02479f
C1235 a_7803_4687# a_7911_5315# 0.01697f
C1236 a_22488_6734# a_22590_6734# 0.37183f
C1237 a_18877_4687# a_19073_4687# 0.76914f
C1238 a_1544_3889# a_1721_4240# 0.38063f
C1239 a_5731_3134# a_15964_3134# 0.2778f
C1240 a_27237_1842# a_27433_1842# 0.77122f
C1241 a_12505_1044# a_10430_1044# 0.03208f
C1242 a_5115_1044# a_5191_1008# 0.01194f
C1243 a_4350_1044# a_5844_1008# 0.28279f
C1244 a_14825_3364# VDD 0.29292f
C1245 a_5844_1008# VDD 0.28328f
C1246 a_19550_3889# a_19963_4687# 0.01012f
C1247 VDD a_19637_14024# 0.87095f
C1248 VDD a_2297_12513# 0.4659f
C1249 VDD a_14751_8160# 0.01806f
C1250 VDD a_10083_4687# 0.49994f
C1251 REF_MUX_OUT a_15964_5979# 0.01307f
C1252 REF_MUX_SEL4 a_16108_5979# 0.1283f
C1253 CHAN2_MUX_SEL4 a_4350_3889# 0.31434f
C1254 a_4187_2434# a_24957_16869# 0.0414f
C1255 a_14317_16869# a_14513_16869# 0.76914f
C1256 a_18877_16869# a_16510_16071# 0.02479f
C1257 a_18877_14024# a_18443_14024# 0.6972f
C1258 a_4187_2434# a_15837_7532# 0.04182f
C1259 a_10430_16071# a_11785_15546# 0.02058f
C1260 a_1256_13226# a_1721_13577# 0.13421f
C1261 a_23437_14024# a_22590_13226# 0.08038f
C1262 a_5197_7532# a_5393_7532# 0.76914f
C1263 a_1256_12471# a_1544_12471# 1.25711f
C1264 a_7477_7532# a_7364_6698# 0.05157f
C1265 a_10328_6734# a_10404_6698# 0.01176f
C1266 a_16108_5979# a_17357_4687# 0.01319f
C1267 a_9757_4687# a_10517_4687# 0.06198f
C1268 a_21157_4687# a_21625_3889# 0.2079f
C1269 a_18117_1842# a_18877_1842# 0.02912f
C1270 a_27915_1044# a_27991_1008# 0.01194f
C1271 a_26911_2470# VDD 0.01806f
C1272 a_15964_289# CHAN3_MUX_OUT 0.01307f
C1273 a_16108_289# CHAN3_MUX_SEL4 0.1283f
C1274 a_19203_1842# a_4187_2434# 0.06627f
C1275 VDD a_22873_16869# 0.49294f
C1276 VDD a_5191_13190# 0.28575f
C1277 VDD a_21911_6698# 0.2822f
C1278 VDD a_13753_7532# 0.49349f
C1279 VDD a_1256_3889# 0.475f
C1280 CHAN0_DELAY_IN a_4157_16340# 0.50642f
C1281 a_4187_2434# a_6283_16869# 0.06627f
C1282 a_5197_16869# a_5957_16869# 0.03319f
C1283 a_7477_16869# a_7364_16035# 0.05157f
C1284 a_16108_15316# a_16793_14024# 0.01843f
C1285 a_10328_16071# a_10430_16071# 0.37183f
C1286 a_9757_14024# a_9953_14024# 0.76914f
C1287 a_16408_13226# a_16484_13190# 0.01176f
C1288 a_12797_14024# a_12791_13190# 0.02354f
C1289 a_12849_11557# a_14009_10774# 0.03463f
C1290 a_14851_11918# a_15688_11557# 0.08776f
C1291 a_21917_7532# a_22243_7532# 0.01427f
C1292 a_26673_4687# a_27237_4687# 0.0114f
C1293 a_5957_4687# a_6425_3889# 0.2079f
C1294 a_5731_5979# a_11785_6209# 0.28056f
C1295 a_4350_3889# a_5115_3889# 0.39037f
C1296 a_27124_1008# VDD 0.28328f
C1297 a_18117_1842# VDD 0.85988f
C1298 CHAN2_DELAY_IN CHAN2_MUX_SEL0 0.14089f
C1299 VDD a_5197_16869# 0.86919f
C1300 VDD a_9751_16035# 0.2822f
C1301 VDD a_25391_14652# 0.01806f
C1302 VDD a_15108_11799# 0.135f
C1303 VDD a_4905_6734# 0.3017f
C1304 VDD a_26043_4687# 0.50058f
C1305 a_22113_16869# a_22677_16869# 0.0114f
C1306 a_4187_2434# a_19073_14024# 0.11222f
C1307 a_26477_14024# a_26803_14024# 0.01427f
C1308 a_4187_2434# a_10517_4687# 0.0414f
C1309 a_9465_13226# a_9751_13190# 0.01885f
C1310 a_4350_13226# a_4324_13190# 0.277f
C1311 a_5731_12471# a_13121_11521# 0.02518f
C1312 a_12993_7532# a_13557_7532# 0.0114f
C1313 a_16597_7532# a_16484_6698# 0.05157f
C1314 a_20968_6734# a_21044_6698# 0.01176f
C1315 a_17553_4687# a_17683_4687# 0.70845f
C1316 a_6283_4687# a_6391_5315# 0.01697f
C1317 a_5731_3134# a_8745_3364# 0.28635f
C1318 a_25913_1842# a_26043_1842# 0.70845f
C1319 a_27705_1044# VDD 0.30021f
C1320 a_19448_3889# a_18877_4687# 0.10864f
C1321 VDD a_26471_13190# 0.28336f
C1322 VDD a_16923_14024# 0.4982f
C1323 VDD a_8671_8160# 0.01806f
C1324 VDD a_8433_4687# 0.49593f
C1325 DLL_RESETN a_13132_11110# 0.01689f
C1326 a_4187_2434# a_22243_16869# 0.06627f
C1327 a_12993_16869# a_13123_16869# 0.70845f
C1328 a_16597_16869# a_16484_16035# 0.05157f
C1329 a_4187_2434# a_13123_7532# 0.06627f
C1330 a_17553_14024# a_18117_14024# 0.0114f
C1331 a_27048_13226# a_27124_13190# 0.01176f
C1332 a_21917_14024# a_21911_13190# 0.02354f
C1333 a_17065_6734# a_17275_6734# 0.09424f
C1334 a_12797_4687# a_10430_3889# 0.02479f
C1335 a_8997_4687# a_8563_4687# 0.6972f
C1336 a_19550_3889# a_20968_3889# 0.38994f
C1337 a_17357_1842# a_16923_1842# 0.6972f
C1338 a_25630_1044# a_27124_1008# 0.28279f
C1339 a_26395_1044# a_26471_1008# 0.01194f
C1340 a_20831_2470# VDD 0.01806f
C1341 a_17553_1842# a_4187_2434# 0.11222f
C1342 a_21835_3889# a_21625_3889# 0.09424f
C1343 VDD a_21157_16869# 0.85889f
C1344 VDD a_24665_13226# 0.29742f
C1345 VDD a_19448_6734# 0.17274f
C1346 VDD a_12037_7532# 0.85889f
C1347 CHAN0_MUX_SEL0 a_1721_16422# 0.01315f
C1348 CHAN0_MUX_SEL1 a_1544_16071# 0.1672f
C1349 a_4437_16869# a_4003_16869# 0.69698f
C1350 a_4187_2434# a_4633_16869# 0.11222f
C1351 a_18585_16071# a_16510_16071# 0.03208f
C1352 a_8808_16071# a_8884_16035# 0.01176f
C1353 a_8433_14024# a_8563_14024# 0.70845f
C1354 a_4187_2434# a_26477_4687# 0.04145f
C1355 a_11277_14024# a_11924_13190# 0.02312f
C1356 a_21157_7532# a_21353_7532# 0.77122f
C1357 a_6854_11144# a_9444_9602# 0.8486f
C1358 a_25717_7532# a_25604_6698# 0.05157f
C1359 a_25717_4687# a_26477_4687# 0.01669f
C1360 a_4437_4687# a_4157_4158# 0.01771f
C1361 a_9465_3889# a_7390_3889# 0.03208f
C1362 a_8237_1842# a_8433_1842# 0.76914f
C1363 a_10843_1842# a_10430_1044# 0.01012f
C1364 a_13470_1044# a_15755_1044# 0.39036f
C1365 a_27705_1044# a_25630_1044# 0.03208f
C1366 a_15403_1842# VDD 0.4973f
C1367 a_24875_1044# VDD 0.15482f
C1368 REF_MUX_SEL1 REF_MUX_OUT 0.09357f
C1369 REF_MUX_SEL2 REF_MUX_SEL4 0.01978f
C1370 VDD a_7288_16071# 0.17274f
C1371 VDD a_13566_11525# 0.09469f
C1372 VDD a_19311_14652# 0.01806f
C1373 VDD a_2297_7085# 0.46536f
C1374 VDD a_24393_4687# 0.4946f
C1375 CHAN0_MUX_SEL4 a_4633_14024# 0.01287f
C1376 CHAN1_DELAY_IN a_4437_14024# 0.05007f
C1377 a_21157_16869# a_21917_16869# 0.02912f
C1378 a_25717_16869# a_25604_16035# 0.05157f
C1379 a_4187_2434# a_17357_14024# 0.0414f
C1380 a_25717_14024# a_25913_14024# 0.73897f
C1381 a_4187_2434# a_7803_4687# 0.06627f
C1382 a_6326_10280# a_6854_11676# 1.31745f
C1383 a_7945_13226# a_7390_13226# 0.03209f
C1384 a_12037_7532# a_12797_7532# 0.02912f
C1385 a_7390_6734# a_5731_5979# 0.41331f
C1386 a_19550_6734# a_19524_6698# 0.277f
C1387 a_4763_4687# a_4871_5315# 0.01697f
C1388 a_24957_1842# a_25283_1842# 0.01427f
C1389 a_6425_1044# a_6711_1008# 0.01885f
C1390 a_1721_3176# VDD 0.45365f
C1391 a_15545_1044# VDD 0.30021f
C1392 a_16510_3889# a_18877_4687# 0.02479f
C1393 VDD a_15273_14024# 0.4946f
C1394 VDD a_24008_13226# 0.17499f
C1395 VDD a_6717_4687# 0.88148f
C1396 VDD a_27997_7532# 0.76025f
C1397 REF_MUX_SEL4 a_3449_6021# 0.05166f
C1398 a_4187_2434# a_20593_16869# 0.11222f
C1399 a_19448_16071# a_19524_16035# 0.01176f
C1400 a_16597_14024# a_17357_14024# 0.01669f
C1401 a_4187_2434# a_11473_7532# 0.11222f
C1402 a_20397_14024# a_21044_13190# 0.02312f
C1403 a_16510_13226# a_15964_12471# 0.05416f
C1404 a_25630_13226# a_25604_13190# 0.277f
C1405 a_15464_9374# a_9712_9602# 0.01237f
C1406 a_5197_7532# a_5191_6698# 0.02349f
C1407 a_5957_7532# a_4350_6734# 0.05231f
C1408 a_7390_6734# a_8155_6734# 0.39037f
C1409 a_10517_4687# a_10404_3853# 0.05157f
C1410 a_7673_4687# a_8237_4687# 0.0114f
C1411 a_16033_1842# a_16597_1842# 0.0114f
C1412 a_19963_1842# a_19550_1044# 0.01012f
C1413 a_14751_2470# VDD 0.01806f
C1414 a_3449_331# CHAN3_MUX_SEL4 0.05166f
C1415 VDD DLL_RESETN 2.48732f
C1416 a_15837_1842# a_4187_2434# 0.0414f
C1417 VDD a_1256_15316# 0.41949f
C1418 VDD a_18443_16869# 0.4973f
C1419 VDD a_9323_7532# 0.4973f
C1420 VDD a_12505_13226# 0.29742f
C1421 VDD a_16510_6734# 0.8795f
C1422 CHAN1_MUX_SEL4 a_1256_12471# 0.65005f
C1423 CHAN1_MUX_SEL2 a_1721_12513# 0.01315f
C1424 CHAN1_MUX_SEL3 a_1544_12471# 0.15976f
C1425 a_5197_16869# a_5191_16035# 0.02349f
C1426 a_5957_16869# a_4350_16071# 0.05231f
C1427 a_7390_16071# a_7364_16035# 0.277f
C1428 a_10517_14024# a_10430_13226# 0.1088f
C1429 a_5731_15316# a_15273_14024# 0.01872f
C1430 a_13470_13226# a_14235_13226# 0.39037f
C1431 a_13121_11521# a_15108_11799# 0.03701f
C1432 a_24665_13226# a_24951_13190# 0.01885f
C1433 a_4187_2434# a_23763_4687# 0.06627f
C1434 a_13592_11561# a_14009_11568# 0.37583f
C1435 a_13019_11521# a_14851_11918# 0.01651f
C1436 a_13306_11995# a_13880_11982# 0.31978f
C1437 a_12849_11557# a_14111_11568# 0.42174f
C1438 a_19833_7532# a_19963_7532# 0.70845f
C1439 a_24957_4687# a_24523_4687# 0.6972f
C1440 a_6913_1842# a_7043_1842# 0.70845f
C1441 a_5731_3134# a_13883_1842# 0.01539f
C1442 a_9757_1842# a_10328_1044# 0.10864f
C1443 a_16597_1842# a_17065_1044# 0.19203f
C1444 a_13753_1842# VDD 0.49553f
C1445 a_21911_1008# VDD 0.2841f
C1446 VDD a_4350_16071# 0.87635f
C1447 VDD a_13231_14652# 0.01806f
C1448 VDD a_12355_11557# 0.38057f
C1449 VDD a_22677_4687# 0.871f
C1450 CHAN0_MUX_OUT a_15964_15316# 0.01307f
C1451 CHAN0_MUX_SEL4 a_16108_15316# 0.1283f
C1452 DLL_RESETN a_12797_7532# 0.0106f
C1453 CHAN1_MUX_SEL4 a_4350_13226# 0.31434f
C1454 CHAN2_MUX_SEL4 a_12797_4687# 0.01829f
C1455 a_20397_16869# a_19963_16869# 0.6972f
C1456 a_4187_2434# a_14643_14024# 0.06627f
C1457 a_4187_2434# a_27433_7532# 0.11284f
C1458 a_24393_14024# a_24523_14024# 0.70845f
C1459 a_4187_2434# a_6153_4687# 0.11222f
C1460 a_14317_7532# a_14311_6698# 0.02349f
C1461 a_11277_7532# a_10843_7532# 0.6972f
C1462 a_15077_7532# a_13470_6734# 0.05231f
C1463 a_15837_4687# a_16033_4687# 0.76914f
C1464 a_24197_1842# a_24393_1842# 0.77122f
C1465 a_4157_1313# a_4324_1008# 0.02463f
C1466 a_4905_1044# a_4350_1044# 0.03209f
C1467 a_16108_289# a_17865_519# 0.29564f
C1468 a_4905_1044# VDD 0.30229f
C1469 a_26395_3889# VDD 0.1539f
C1470 a_16484_3853# a_16597_4687# 0.05157f
C1471 VDD a_23871_17497# 0.01806f
C1472 VDD a_13557_14024# 0.87095f
C1473 VDD a_21044_13190# 0.28225f
C1474 VDD a_25283_7532# 0.49737f
C1475 VDD a_4003_4687# 0.61691f
C1476 VDD a_9675_3889# 0.15407f
C1477 REF_CLK a_14009_11568# 0.25847f
C1478 CHAN2_MUX_SEL1 a_3449_4240# 0.29404f
C1479 a_15077_16869# a_13470_16071# 0.05231f
C1480 a_11277_16869# a_11473_16869# 0.76914f
C1481 a_14317_16869# a_14311_16035# 0.02349f
C1482 a_4187_2434# a_18877_16869# 0.0414f
C1483 a_4350_16071# a_5731_15316# 0.41099f
C1484 a_4187_2434# a_9757_7532# 0.0414f
C1485 a_15837_14024# a_15403_14024# 0.6972f
C1486 a_19637_14024# a_19550_13226# 0.1088f
C1487 a_9444_10280# a_5864_9057# 0.06832f
C1488 a_5731_5979# a_13123_4687# 0.01539f
C1489 a_6717_4687# a_7477_4687# 0.06198f
C1490 a_12505_6734# a_12791_6698# 0.01885f
C1491 a_16510_3889# a_18795_3889# 0.39036f
C1492 a_15077_1842# a_15837_1842# 0.02912f
C1493 a_18877_1842# a_19448_1044# 0.10864f
C1494 a_22590_1044# a_24951_1008# 0.26208f
C1495 a_8671_2470# VDD 0.01806f
C1496 VDD CHAN1_DELAY_IN 1.34195f
C1497 a_13123_1842# a_4187_2434# 0.06627f
C1498 a_17275_3889# a_17065_3889# 0.09424f
C1499 VDD a_16793_16869# 0.49277f
C1500 VDD a_25630_16071# 0.89819f
C1501 VDD a_3449_13577# 0.46731f
C1502 VDD a_7673_7532# 0.49294f
C1503 VDD a_13444_6698# 0.28633f
C1504 REF_DELAY_OUT_LAST a_15108_11015# 0.01399f
C1505 a_5731_15316# a_13557_14024# 0.01314f
C1506 a_6717_14024# a_6913_14024# 0.76914f
C1507 a_12505_16071# a_12715_16071# 0.09424f
C1508 a_4187_2434# a_22113_4687# 0.11222f
C1509 a_13121_11521# a_13566_11525# 0.01158f
C1510 a_13019_11521# a_13592_11561# 0.04178f
C1511 a_23145_13226# a_22590_13226# 0.03209f
C1512 a_6326_10280# a_9444_10280# 0.01269f
C1513 a_24197_7532# a_22590_6734# 0.05231f
C1514 a_18877_7532# a_19203_7532# 0.01427f
C1515 a_23437_7532# a_23431_6698# 0.02349f
C1516 a_1256_6734# a_2297_7085# 0.04619f
C1517 a_22590_6734# a_16108_5979# 0.58202f
C1518 a_1544_5979# a_2297_6021# 0.27303f
C1519 a_1256_5979# a_2873_6021# 0.27926f
C1520 a_23633_4687# a_24197_4687# 0.0114f
C1521 a_5731_3134# a_12233_1842# 0.01872f
C1522 a_21625_1044# a_21835_1044# 0.09424f
C1523 a_9757_1842# a_7390_1044# 0.02479f
C1524 a_19448_1044# VDD 0.17444f
C1525 a_12037_1842# VDD 0.85988f
C1526 a_14825_3364# CHAN2_MUX_SEL4 0.03307f
C1527 VDD CHAN3_MUX_SEL1 0.62956f
C1528 a_25604_3853# a_25717_4687# 0.05157f
C1529 VDD a_20105_16071# 0.30409f
C1530 VDD a_7151_14652# 0.01806f
C1531 VDD a_19963_4687# 0.50058f
C1532 a_19073_16869# a_19637_16869# 0.0114f
C1533 a_1256_15316# a_2297_15358# 0.04261f
C1534 a_4187_2434# a_12993_14024# 0.11222f
C1535 a_1544_15316# a_1721_15358# 0.36963f
C1536 a_23437_16869# a_23431_16035# 0.02349f
C1537 a_24197_16869# a_22590_16071# 0.05231f
C1538 a_23437_14024# a_23763_14024# 0.01427f
C1539 a_4187_2434# a_4437_4687# 0.04193f
C1540 a_4187_2434# a_25717_7532# 0.04176f
C1541 a_15765_12645# a_16108_12471# 0.42004f
C1542 a_5731_12471# a_6854_11676# 0.02323f
C1543 a_27563_7532# a_27671_7532# 0.01163f
C1544 a_9953_7532# a_10517_7532# 0.0114f
C1545 a_12797_7532# a_13444_6698# 0.02011f
C1546 a_16510_6734# a_17351_6698# 0.28268f
C1547 a_16108_5979# a_27237_4687# 0.01319f
C1548 a_14513_4687# a_14643_4687# 0.70845f
C1549 a_22873_1842# a_23003_1842# 0.70845f
C1550 a_23431_3853# VDD 0.28357f
C1551 a_2297_1395# VDD 0.46645f
C1552 a_5731_3134# a_7390_3889# 0.41331f
C1553 VDD a_17791_17497# 0.01806f
C1554 VDD a_10843_14024# 0.50058f
C1555 VDD a_18795_13226# 0.15407f
C1556 VDD a_23633_7532# 0.49417f
C1557 VDD a_6711_3853# 0.2822f
C1558 VDD a_15964_5979# 0.31771f
C1559 CHAN0_MUX_OUT a_4187_2434# 1.38214f
C1560 DLL_RESETN a_13121_11521# 0.04337f
C1561 REF_CLK a_13019_11521# 0.35409f
C1562 CHAN2_MUX_SEL4 a_1256_3889# 0.04908f
C1563 a_27563_16869# a_27671_16869# 0.01163f
C1564 a_12797_16869# a_13444_16035# 0.02011f
C1565 a_9953_16869# a_10083_16869# 0.70845f
C1566 a_4187_2434# a_16163_16869# 0.06627f
C1567 a_16108_15316# a_26673_14024# 0.01872f
C1568 a_16510_16071# a_17275_16071# 0.39037f
C1569 a_4187_2434# a_7043_7532# 0.06627f
C1570 a_14513_14024# a_15077_14024# 0.0114f
C1571 a_14851_10872# a_15688_11093# 0.08776f
C1572 a_22590_13226# a_23431_13190# 0.28268f
C1573 a_10985_6734# a_10430_6734# 0.03209f
C1574 a_4350_6734# a_5768_6734# 0.38994f
C1575 a_27237_7532# a_26803_7532# 0.6972f
C1576 a_5731_5979# a_11473_4687# 0.01872f
C1577 a_5957_4687# a_5523_4687# 0.6972f
C1578 a_8997_4687# a_7390_3889# 0.05231f
C1579 a_8237_4687# a_8231_3853# 0.02349f
C1580 a_11195_3889# a_11271_3853# 0.01194f
C1581 a_14317_1842# a_13883_1842# 0.6972f
C1582 a_16108_3134# a_25283_1842# 0.01539f
C1583 a_22488_1044# a_22590_1044# 0.37183f
C1584 a_18877_1842# a_16510_1044# 0.02479f
C1585 a_27997_1842# VDD 0.76534f
C1586 VDD CHAN0_DELAY_IN 1.33865f
C1587 a_11473_1842# a_4187_2434# 0.11222f
C1588 VDD a_15077_16869# 0.86016f
C1589 VDD a_22564_16035# 0.28633f
C1590 VDD a_11195_6734# 0.15389f
C1591 VDD a_5957_7532# 0.85889f
C1592 CHAN2_DELAY_OUT_LAST a_27997_4687# 0.70955f
C1593 a_27237_16869# a_27433_16869# 0.77122f
C1594 a_5731_15316# a_10843_14024# 0.01539f
C1595 a_5393_14024# a_5523_14024# 0.70845f
C1596 a_4350_16071# a_5191_16035# 0.28268f
C1597 a_20105_13226# a_20391_13190# 0.01885f
C1598 a_10430_13226# a_11848_13226# 0.38994f
C1599 a_4187_2434# a_20397_4687# 0.04141f
C1600 a_12355_11557# a_13121_11521# 0.05795f
C1601 a_12656_11554# a_13019_11521# 0.04193f
C1602 a_21917_7532# a_22564_6698# 0.02011f
C1603 a_18117_7532# a_18313_7532# 0.77122f
C1604 a_22677_4687# a_23437_4687# 0.01669f
C1605 a_5731_3134# a_10517_1842# 0.01314f
C1606 a_5197_1842# a_5393_1842# 0.76914f
C1607 a_7477_1842# a_7364_1008# 0.05157f
C1608 a_10328_1044# a_10404_1008# 0.01176f
C1609 a_9323_1842# VDD 0.50001f
C1610 a_16510_1044# VDD 1.07824f
C1611 CHAN1_MUX_SEL2 CHAN1_MUX_OUT 0.08497f
C1612 VDD CHAN2_MUX_SEL1 0.50267f
C1613 CHAN1_MUX_SEL3 CHAN1_MUX_SEL4 0.75489f
C1614 VDD a_7945_16071# 0.30409f
C1615 VDD a_26803_14024# 0.49684f
C1616 VDD a_9746_11495# 0.0935f
C1617 VDD a_18313_4687# 0.4946f
C1618 CHAN0_MUX_SEL4 a_3449_15358# 0.05166f
C1619 a_4187_2434# a_11277_14024# 0.0414f
C1620 a_21917_16869# a_22564_16035# 0.02011f
C1621 a_18117_16869# a_18877_16869# 0.02912f
C1622 a_4187_2434# a_23003_7532# 0.06661f
C1623 a_19550_16071# a_16108_15316# 0.58202f
C1624 a_22677_14024# a_22873_14024# 0.73897f
C1625 a_5731_12471# a_16108_12471# 0.01334f
C1626 a_8997_7532# a_9757_7532# 0.02912f
C1627 a_12037_7532# a_11924_6698# 0.02055f
C1628 a_26043_7532# a_26151_7532# 0.01163f
C1629 a_27705_6734# a_27991_6698# 0.01885f
C1630 a_16108_5979# a_24523_4687# 0.01542f
C1631 a_15755_6734# a_15831_6698# 0.01194f
C1632 a_25630_3889# a_27991_3853# 0.26208f
C1633 a_21917_1842# a_22243_1842# 0.01427f
C1634 a_5731_289# a_11785_519# 0.28056f
C1635 a_20968_3889# VDD 0.17499f
C1636 a_27433_1842# a_4187_2434# 0.11222f
C1637 a_14311_3853# a_14317_4687# 0.02349f
C1638 a_13470_3889# a_15077_4687# 0.05231f
C1639 VDD a_11711_17497# 0.01806f
C1640 VDD a_15831_13190# 0.2816f
C1641 VDD a_9193_14024# 0.4946f
C1642 VDD a_21917_7532# 0.87825f
C1643 VDD a_8745_6209# 0.29292f
C1644 VDD a_4248_3889# 0.17587f
C1645 DLL_RESETN a_11491_11918# 0.14622f
C1646 REF_CLK a_11748_11799# 0.0148f
C1647 a_4187_2434# a_14513_16869# 0.11222f
C1648 a_26043_16869# a_26151_16869# 0.01163f
C1649 a_12037_16869# a_11924_16035# 0.02055f
C1650 a_27705_16071# a_27915_16071# 0.09424f
C1651 a_4187_2434# a_5393_7532# 0.11222f
C1652 a_16108_15316# a_24957_14024# 0.01307f
C1653 a_13557_14024# a_14317_14024# 0.01669f
C1654 a_21835_13226# a_21911_13190# 0.01194f
C1655 a_13592_11113# a_14851_10872# 0.01529f
C1656 a_25913_7532# a_26477_7532# 0.0114f
C1657 a_7945_6734# a_8231_6698# 0.01885f
C1658 a_6717_4687# a_7364_3853# 0.02011f
C1659 a_5731_5979# a_9757_4687# 0.01307f
C1660 a_4633_4687# a_5197_4687# 0.0114f
C1661 a_12993_1842# a_13557_1842# 0.0114f
C1662 a_16597_1842# a_16484_1008# 0.05157f
C1663 a_16108_3134# a_23633_1842# 0.01872f
C1664 a_20968_1044# a_21044_1008# 0.01176f
C1665 a_25283_1842# VDD 0.50009f
C1666 a_9757_1842# a_4187_2434# 0.0414f
C1667 a_12791_3853# a_12505_3889# 0.01885f
C1668 VDD a_12363_16869# 0.4973f
C1669 VDD a_20315_16071# 0.15389f
C1670 VDD a_9712_9602# 0.23255f
C1671 VDD a_8231_6698# 0.28357f
C1672 VDD a_22351_5315# 0.01806f
C1673 CHAN1_MUX_SEL4 a_12797_14024# 0.01829f
C1674 a_4187_2434# a_27237_14024# 0.06189f
C1675 a_25913_16869# a_26043_16869# 0.70845f
C1676 a_7945_16071# a_8155_16071# 0.09424f
C1677 a_5731_15316# a_9193_14024# 0.01872f
C1678 a_4187_2434# a_17683_4687# 0.06627f
C1679 a_16793_7532# a_16923_7532# 0.70845f
C1680 a_21157_7532# a_21044_6698# 0.02055f
C1681 a_21917_4687# a_21483_4687# 0.6972f
C1682 a_16510_6734# a_17865_6209# 0.02165f
C1683 a_25630_6734# a_27048_6734# 0.38994f
C1684 a_5731_3134# a_7803_1842# 0.01539f
C1685 a_17065_1044# a_17275_1044# 0.09424f
C1686 a_7673_1842# VDD 0.49553f
C1687 a_13444_1008# VDD 0.28758f
C1688 a_1544_3134# CHAN2_MUX_OUT 0.69943f
C1689 a_1721_3176# CHAN2_MUX_SEL4 0.05813f
C1690 a_2297_3176# CHAN2_MUX_SEL3 0.01595f
C1691 a_2873_3176# CHAN2_MUX_SEL2 0.01422f
C1692 VDD REF_MUX_SEL1 0.50267f
C1693 CHAN1_DELAY_IN CHAN1_MUX_SEL1 0.01858f
C1694 a_23431_3853# a_23437_4687# 0.02349f
C1695 a_22590_3889# a_24197_4687# 0.05231f
C1696 VDD a_2873_16422# 0.46517f
C1697 VDD a_26985_12701# 0.29292f
C1698 VDD a_25153_14024# 0.49655f
C1699 VDD a_16597_4687# 0.86971f
C1700 CHAN1_MUX_SEL1 a_3449_13577# 0.29404f
C1701 CHAN2_MUX_SEL4 a_6717_4687# 0.0195f
C1702 a_17357_16869# a_16923_16869# 0.6972f
C1703 a_4187_2434# a_8563_14024# 0.06627f
C1704 a_21157_16869# a_21044_16035# 0.02055f
C1705 a_21353_14024# a_21483_14024# 0.70845f
C1706 a_25630_16071# a_26471_16035# 0.28268f
C1707 a_4187_2434# a_21353_7532# 0.11284f
C1708 a_16510_16071# a_16851_15336# 0.02131f
C1709 a_4187_2434# a_5731_5979# 0.17047f
C1710 a_8237_7532# a_7803_7532# 0.6972f
C1711 a_14235_6734# a_14311_6698# 0.01194f
C1712 a_24523_7532# a_24631_7532# 0.01163f
C1713 a_13470_6734# a_14964_6698# 0.28279f
C1714 a_11277_7532# a_10430_6734# 0.08038f
C1715 a_26185_6734# a_25630_6734# 0.03209f
C1716 a_18117_7532# a_18585_6734# 0.2079f
C1717 a_12797_4687# a_12993_4687# 0.76914f
C1718 a_16108_5979# a_22873_4687# 0.01865f
C1719 a_25528_3889# a_25630_3889# 0.37183f
C1720 a_25717_1842# a_25604_1008# 0.05157f
C1721 a_21157_1842# a_21353_1842# 0.77122f
C1722 a_18004_3853# VDD 0.28225f
C1723 a_25717_1842# a_4187_2434# 0.0414f
C1724 a_13444_3853# a_12797_4687# 0.02011f
C1725 VDD a_7477_14024# 0.871f
C1726 VDD a_5631_17497# 0.01806f
C1727 VDD a_13368_13226# 0.17274f
C1728 VDD a_19203_7532# 0.49737f
C1729 VDD a_2873_6021# 0.46598f
C1730 VDD a_18585_3889# 0.29742f
C1731 a_4187_2434# a_12797_16869# 0.0414f
C1732 a_8237_16869# a_8433_16869# 0.76914f
C1733 a_13470_16071# a_14888_16071# 0.38994f
C1734 a_11277_16869# a_10430_16071# 0.08038f
C1735 a_18117_16869# a_18585_16071# 0.2079f
C1736 a_24523_16869# a_24631_16869# 0.01163f
C1737 a_12797_14024# a_12363_14024# 0.6972f
C1738 a_16108_15316# a_22243_14024# 0.01539f
C1739 a_19550_13226# a_21044_13190# 0.28279f
C1740 a_20315_13226# a_20391_13190# 0.01194f
C1741 a_15304_10295# a_14851_10872# 0.05156f
C1742 a_13566_11018# a_13592_11113# 0.36952f
C1743 a_24957_7532# a_25717_7532# 0.06198f
C1744 a_6425_6734# a_6635_6734# 0.09424f
C1745 a_5731_5979# a_7043_4687# 0.01539f
C1746 a_5957_4687# a_5844_3853# 0.02055f
C1747 a_7390_3889# a_9751_3853# 0.26208f
C1748 a_12037_1842# a_12797_1842# 0.02912f
C1749 a_16108_3134# a_21917_1842# 0.01307f
C1750 a_13368_3889# a_13444_3853# 0.01176f
C1751 a_19550_1044# a_19524_1008# 0.277f
C1752 a_7390_1044# a_5731_289# 0.41331f
C1753 a_23633_1842# VDD 0.49593f
C1754 a_15964_289# VDD 0.3291f
C1755 CHAN3_MUX_SEL1 CHAN3_MUX_SEL4 0.03574f
C1756 CHAN3_MUX_SEL2 CHAN3_MUX_SEL3 3.21891f
C1757 a_7043_1842# a_4187_2434# 0.06627f
C1758 VDD a_17351_16035# 0.28637f
C1759 VDD a_10713_16869# 0.49294f
C1760 VDD a_5768_6734# 0.17499f
C1761 VDD a_16271_5315# 0.01806f
C1762 REF_MUX_SEL1 a_2873_7085# 0.13092f
C1763 a_24957_16869# a_25283_16869# 0.01427f
C1764 a_4187_2434# a_24523_14024# 0.06627f
C1765 a_10517_14024# a_10985_13226# 0.19203f
C1766 a_5731_15316# a_7477_14024# 0.01314f
C1767 a_6283_14024# a_4350_13226# 0.01012f
C1768 a_7390_13226# a_9675_13226# 0.39036f
C1769 a_10751_11568# a_11748_11799# 0.03061f
C1770 a_4187_2434# a_16033_4687# 0.11222f
C1771 a_10649_11568# a_11397_11918# 0.01058f
C1772 a_15837_7532# a_16163_7532# 0.01427f
C1773 a_20397_7532# a_19550_6734# 0.08038f
C1774 a_20593_4687# a_21157_4687# 0.0114f
C1775 a_5731_3134# a_6153_1842# 0.02026f
C1776 a_16108_3134# a_23945_3364# 0.2906f
C1777 a_5197_1842# a_5191_1008# 0.02349f
C1778 a_5957_1842# a_4350_1044# 0.05231f
C1779 a_7390_1044# a_8155_1044# 0.39037f
C1780 a_5957_1842# VDD 0.85988f
C1781 a_11195_1044# VDD 0.15465f
C1782 a_3449_1395# CHAN3_DELAY_IN 0.01045f
C1783 a_2873_1395# CHAN3_MUX_SEL1 0.13092f
C1784 CHAN0_MUX_SEL3 CHAN0_MUX_SEL4 0.75489f
C1785 CHAN0_MUX_SEL2 CHAN0_MUX_OUT 0.08497f
C1786 a_22564_3853# a_21917_4687# 0.02011f
C1787 VDD a_23437_14024# 0.87175f
C1788 VDD a_1256_16071# 0.475f
C1789 VDD a_14825_12701# 0.29292f
C1790 VDD a_13883_4687# 0.50058f
C1791 VDD a_26151_8160# 0.01806f
C1792 CHAN1_MUX_SEL4 a_1256_13226# 0.04908f
C1793 REF_CLK a_4437_7532# 0.05209f
C1794 a_16033_16869# a_16597_16869# 0.0114f
C1795 a_20397_16869# a_19550_16071# 0.08038f
C1796 a_4187_2434# a_6913_14024# 0.11222f
C1797 a_24875_16071# a_24951_16035# 0.01194f
C1798 a_20397_14024# a_20723_14024# 0.01427f
C1799 a_4187_2434# a_19637_7532# 0.04176f
C1800 a_23003_7532# a_23111_7532# 0.01163f
C1801 a_6913_7532# a_7477_7532# 0.0114f
C1802 a_9757_7532# a_9751_6698# 0.02354f
C1803 a_23145_6734# a_23431_6698# 0.01885f
C1804 a_11473_4687# a_11603_4687# 0.70845f
C1805 a_16108_5979# a_21157_4687# 0.01319f
C1806 a_24008_3889# a_24084_3853# 0.01176f
C1807 a_19833_1842# a_19963_1842# 0.70845f
C1808 a_15755_3889# VDD 0.15389f
C1809 a_23003_1842# a_4187_2434# 0.06627f
C1810 a_11924_3853# a_12037_4687# 0.02055f
C1811 a_27991_3853# a_27705_3889# 0.01885f
C1812 VDD a_26673_16869# 0.49417f
C1813 VDD a_4763_14024# 0.49875f
C1814 VDD a_17553_7532# 0.49417f
C1815 VDD a_10430_13226# 0.88416f
C1816 VDD a_27048_6734# 0.17499f
C1817 CHAN1_DELAY_OUT_LAST a_27997_14024# 0.70955f
C1818 DLL_RESETN a_6854_11676# 0.50331f
C1819 a_6913_16869# a_7043_16869# 0.70845f
C1820 a_9757_16869# a_9751_16035# 0.02354f
C1821 a_4187_2434# a_10083_16869# 0.06627f
C1822 a_23003_16869# a_23111_16869# 0.01163f
C1823 a_23145_16071# a_23355_16071# 0.09424f
C1824 a_16108_15316# a_20593_14024# 0.01872f
C1825 a_15403_14024# a_13470_13226# 0.01012f
C1826 a_11473_14024# a_12037_14024# 0.0114f
C1827 a_24197_14024# a_24665_13226# 0.2079f
C1828 a_13106_11047# a_12907_11110# 0.14994f
C1829 a_24197_7532# a_23763_7532# 0.6972f
C1830 a_16108_5979# a_16851_5999# 0.06181f
C1831 a_4157_7003# a_4350_6734# 0.04624f
C1832 a_8997_4687# a_9465_3889# 0.2079f
C1833 a_5197_4687# a_4350_3889# 0.08038f
C1834 a_7288_3889# a_7390_3889# 0.37183f
C1835 a_16108_3134# a_19203_1842# 0.01539f
C1836 a_11277_1842# a_10843_1842# 0.6972f
C1837 a_14317_1842# a_14311_1008# 0.02349f
C1838 a_15077_1842# a_13470_1044# 0.05231f
C1839 a_21917_1842# VDD 0.88424f
C1840 a_8745_519# VDD 0.29315f
C1841 a_5393_1842# a_4187_2434# 0.11222f
C1842 VDD a_8997_16869# 0.85889f
C1843 VDD a_14888_16071# 0.17499f
C1844 VDD a_14009_10774# 0.31815f
C1845 VDD a_26185_6734# 0.30409f
C1846 VDD a_10191_5315# 0.01806f
C1847 REF_MUX_SEL0 a_1544_6734# 0.07603f
C1848 REF_MUX_SEL1 a_1256_6734# 1.44243f
C1849 a_24197_16869# a_24393_16869# 0.77122f
C1850 a_15964_15316# a_16851_15336# 0.16757f
C1851 a_4187_2434# a_22873_14024# 0.11222f
C1852 a_4157_16340# a_4248_16071# 0.11672f
C1853 a_15545_13226# a_13470_13226# 0.03208f
C1854 a_9946_11995# a_10751_11568# 0.097f
C1855 a_10232_11561# a_10649_11568# 0.37583f
C1856 a_4187_2434# a_14317_4687# 0.04141f
C1857 a_18877_7532# a_18871_6698# 0.02354f
C1858 a_15077_7532# a_15273_7532# 0.77122f
C1859 a_22590_6734# a_24875_6734# 0.39036f
C1860 a_19637_4687# a_20397_4687# 0.01669f
C1861 a_12505_1044# a_12791_1008# 0.01885f
C1862 a_23945_3364# VDD 0.29292f
C1863 a_8231_1008# VDD 0.28439f
C1864 a_1256_1044# CHAN3_MUX_SEL1 1.44243f
C1865 a_1544_1044# CHAN3_MUX_SEL0 0.07603f
C1866 CHAN0_DELAY_IN CHAN0_MUX_SEL1 0.01858f
C1867 a_21044_3853# a_21157_4687# 0.02055f
C1868 VDD a_20723_14024# 0.49684f
C1869 VDD a_20071_8160# 0.01806f
C1870 VDD a_12233_4687# 0.4946f
C1871 REF_MUX_SEL4 a_4003_4687# 0.01225f
C1872 a_18877_16869# a_18871_16035# 0.02354f
C1873 a_4187_2434# a_5197_14024# 0.0414f
C1874 a_15077_16869# a_15837_16869# 0.02912f
C1875 a_4187_2434# a_26043_16869# 0.06627f
C1876 a_23355_16071# a_23431_16035# 0.01194f
C1877 a_22590_16071# a_24084_16035# 0.28279f
C1878 a_15837_14024# a_15964_12471# 0.02f
C1879 a_19637_14024# a_19833_14024# 0.73897f
C1880 a_24523_14024# a_22590_13226# 0.01012f
C1881 a_4187_2434# a_16923_7532# 0.06661f
C1882 a_22590_13226# a_23945_12701# 0.02165f
C1883 a_27563_7532# a_27671_8160# 0.01697f
C1884 a_21483_7532# a_21591_7532# 0.01163f
C1885 a_8237_7532# a_8884_6698# 0.02312f
C1886 a_5957_7532# a_6717_7532# 0.02912f
C1887 a_16108_5979# a_18443_4687# 0.01542f
C1888 a_10430_6734# a_12791_6698# 0.26208f
C1889 a_22677_4687# a_23145_3889# 0.19203f
C1890 a_13470_3889# a_5731_3134# 0.41365f
C1891 a_18877_1842# a_19203_1842# 0.01427f
C1892 a_22590_3889# a_22564_3853# 0.277f
C1893 a_1256_289# a_2873_331# 0.27926f
C1894 a_1256_1044# a_2297_1395# 0.04619f
C1895 a_23437_1842# a_23431_1008# 0.02349f
C1896 a_1544_289# a_2297_331# 0.27303f
C1897 a_22590_1044# a_16108_289# 0.58202f
C1898 a_24197_1842# a_22590_1044# 0.05231f
C1899 a_12791_3853# VDD 0.2822f
C1900 a_21353_1842# a_4187_2434# 0.11222f
C1901 a_25630_3889# a_26185_3889# 0.03209f
C1902 VDD a_24957_16869# 0.87825f
C1903 VDD a_7364_13190# 0.28633f
C1904 VDD a_17865_15546# 0.29444f
C1905 VDD a_15837_7532# 0.87963f
C1906 VDD a_24084_6698# 0.28225f
C1907 CHAN1_MUX_OUT a_16851_12491# 0.45865f
C1908 a_4187_2434# a_8433_16869# 0.11222f
C1909 a_21483_16869# a_21591_16869# 0.01163f
C1910 a_8237_16869# a_8884_16035# 0.02312f
C1911 a_10517_14024# a_11277_14024# 0.01669f
C1912 a_10430_16071# a_12715_16071# 0.39036f
C1913 a_16108_15316# a_18877_14024# 0.01307f
C1914 a_16510_13226# a_18871_13190# 0.26208f
C1915 a_22873_7532# a_23437_7532# 0.0114f
C1916 a_27433_4687# a_27563_4687# 0.70845f
C1917 a_5768_3889# a_5844_3853# 0.01176f
C1918 a_16108_3134# a_17553_1842# 0.01872f
C1919 a_9953_1842# a_10517_1842# 0.0114f
C1920 a_16510_1044# a_17351_1008# 0.28268f
C1921 a_27563_1842# a_27671_1842# 0.01163f
C1922 a_12797_1842# a_13444_1008# 0.02011f
C1923 a_19203_1842# VDD 0.50009f
C1924 a_2873_331# VDD 0.46642f
C1925 CHAN2_MUX_SEL1 CHAN2_MUX_SEL4 0.03574f
C1926 CHAN2_MUX_SEL2 CHAN2_MUX_SEL3 3.21891f
C1927 VDD a_6283_16869# 0.4973f
C1928 VDD a_11924_16035# 0.28225f
C1929 VDD a_14025_6734# 0.30409f
C1930 VDD a_4111_5315# 0.01866f
C1931 CHAN1_MUX_SEL4 a_6717_14024# 0.0195f
C1932 a_22873_16869# a_23003_16869# 0.70845f
C1933 a_4187_2434# a_21157_14024# 0.04141f
C1934 a_27433_14024# a_27997_14024# 0.0114f
C1935 a_4187_2434# a_11603_4687# 0.06627f
C1936 a_9772_11533# a_9946_11995# 0.27179f
C1937 a_17357_7532# a_18004_6698# 0.02312f
C1938 a_13753_7532# a_13883_7532# 0.70845f
C1939 a_18877_4687# a_18443_4687# 0.6972f
C1940 a_10430_6734# a_11785_6209# 0.02058f
C1941 a_1256_3889# a_1721_4240# 0.13421f
C1942 a_5731_3134# a_15765_3308# 0.23301f
C1943 a_27237_1842# a_26803_1842# 0.6972f
C1944 a_10985_1044# a_10430_1044# 0.03209f
C1945 a_4350_1044# a_5768_1044# 0.38994f
C1946 a_11785_3364# VDD 0.29292f
C1947 a_5768_1044# VDD 0.17575f
C1948 a_19550_3889# a_20397_4687# 0.08038f
C1949 VDD a_19073_14024# 0.49655f
C1950 VDD a_1721_12513# 0.45352f
C1951 VDD a_13991_8160# 0.01806f
C1952 VDD a_10517_4687# 0.871f
C1953 DLL_RESETN a_9444_10280# 0.10275f
C1954 REF_MUX_SEL4 a_15964_5979# 0.5544f
C1955 a_17357_16869# a_18004_16035# 0.02312f
C1956 a_14317_16869# a_13883_16869# 0.6972f
C1957 a_4187_2434# a_24393_16869# 0.11222f
C1958 a_18313_14024# a_18443_14024# 0.70845f
C1959 a_4187_2434# a_15273_7532# 0.11297f
C1960 a_1256_13226# a_1544_13226# 1.26509f
C1961 a_5197_7532# a_4763_7532# 0.6972f
C1962 a_7477_7532# a_7390_6734# 0.1088f
C1963 a_19963_7532# a_20071_7532# 0.01163f
C1964 a_26043_7532# a_26151_8160# 0.01697f
C1965 a_10328_6734# a_10430_6734# 0.37183f
C1966 a_16108_5979# a_16793_4687# 0.01843f
C1967 a_9757_4687# a_9953_4687# 0.76914f
C1968 a_18117_1842# a_18313_1842# 0.77122f
C1969 a_21917_1842# a_22564_1008# 0.02011f
C1970 a_26151_2470# VDD 0.01806f
C1971 a_15964_289# CHAN3_MUX_SEL4 0.5544f
C1972 a_19637_1842# a_4187_2434# 0.0414f
C1973 a_23431_3853# a_23145_3889# 0.01885f
C1974 VDD a_22243_16869# 0.49737f
C1975 VDD a_5115_13226# 0.15389f
C1976 VDD a_21835_6734# 0.15406f
C1977 VDD a_13123_7532# 0.49727f
C1978 CHAN0_DELAY_IN a_3449_16422# 0.01058f
C1979 CHAN0_MUX_SEL1 a_2873_16422# 0.13092f
C1980 a_4187_2434# a_6717_16869# 0.0414f
C1981 a_5197_16869# a_5393_16869# 0.76914f
C1982 a_7477_16869# a_7390_16071# 0.1088f
C1983 a_19963_16869# a_20071_16869# 0.01163f
C1984 a_16108_15316# a_16163_14024# 0.0155f
C1985 a_9757_14024# a_9323_14024# 0.6972f
C1986 a_18585_16071# a_18871_16035# 0.01885f
C1987 a_16408_13226# a_16510_13226# 0.37183f
C1988 a_26803_14024# a_26911_14024# 0.01163f
C1989 a_4187_2434# a_27563_4687# 0.06629f
C1990 a_12849_11557# a_13592_11113# 0.38497f
C1991 a_21917_7532# a_22677_7532# 0.06198f
C1992 a_26477_7532# a_27124_6698# 0.02312f
C1993 a_26477_4687# a_26803_4687# 0.01427f
C1994 a_9465_3889# a_9751_3853# 0.01885f
C1995 a_4350_3889# a_4324_3853# 0.277f
C1996 a_8997_1842# a_9757_1842# 0.02912f
C1997 a_26043_1842# a_26151_1842# 0.01163f
C1998 a_12037_1842# a_11924_1008# 0.02055f
C1999 a_15755_1044# a_15831_1008# 0.01194f
C2000 a_27705_1044# a_27991_1008# 0.01885f
C2001 a_17553_1842# VDD 0.49593f
C2002 a_27048_1044# VDD 0.17575f
C2003 VDD a_9675_16071# 0.15406f
C2004 VDD a_4633_16869# 0.49285f
C2005 VDD a_24631_14652# 0.01806f
C2006 VDD a_4157_7003# 0.48942f
C2007 VDD a_14111_11568# 0.21331f
C2008 VDD a_26477_4687# 0.87185f
C2009 a_21917_16869# a_22243_16869# 0.01427f
C2010 a_4187_2434# a_18443_14024# 0.06627f
C2011 a_26477_16869# a_27124_16035# 0.02312f
C2012 a_26477_14024# a_27237_14024# 0.03319f
C2013 a_4248_13226# a_4324_13190# 0.01176f
C2014 a_9465_13226# a_9675_13226# 0.09424f
C2015 a_4187_2434# a_9953_4687# 0.11222f
C2016 a_5731_12471# a_13019_11521# 0.01694f
C2017 a_12797_7532# a_13123_7532# 0.01427f
C2018 a_16597_7532# a_16510_6734# 0.1088f
C2019 a_17553_4687# a_18117_4687# 0.0114f
C2020 a_25913_1842# a_26477_1842# 0.0114f
C2021 a_7945_1044# a_8231_1008# 0.01885f
C2022 a_26185_1044# VDD 0.30514f
C2023 a_18871_3853# a_18877_4687# 0.02354f
C2024 VDD a_26395_13226# 0.1539f
C2025 VDD a_17357_14024# 0.87006f
C2026 VDD a_7803_4687# 0.50058f
C2027 VDD a_7911_8160# 0.01806f
C2028 DLL_RESETN a_12907_11110# 0.04234f
C2029 REF_MUX_OUT a_5731_5979# 1.04829f
C2030 REF_MUX_SEL4 a_8745_6209# 0.04472f
C2031 a_4187_2434# a_22677_16869# 0.0414f
C2032 a_12993_16869# a_13557_16869# 0.0114f
C2033 a_16597_16869# a_16510_16071# 0.1088f
C2034 a_4187_2434# a_13557_7532# 0.0414f
C2035 a_19550_16071# a_21911_16035# 0.26208f
C2036 a_17357_14024# a_17683_14024# 0.01427f
C2037 a_18585_6734# a_16510_6734# 0.03208f
C2038 a_24523_7532# a_24631_8160# 0.01697f
C2039 a_8808_6734# a_8884_6698# 0.01176f
C2040 a_18443_7532# a_18551_7532# 0.01163f
C2041 a_8433_4687# a_8563_4687# 0.70845f
C2042 a_19550_3889# a_20391_3853# 0.28268f
C2043 a_21157_1842# a_21044_1008# 0.02055f
C2044 a_16793_1842# a_16923_1842# 0.70845f
C2045 a_16510_1044# a_17865_519# 0.02165f
C2046 a_25630_1044# a_27048_1044# 0.38994f
C2047 a_20071_2470# VDD 0.01806f
C2048 a_5731_289# CHAN3_MUX_OUT 1.04829f
C2049 a_8745_519# CHAN3_MUX_SEL4 0.04472f
C2050 a_16923_1842# a_4187_2434# 0.06627f
C2051 a_12791_3853# a_10430_3889# 0.26208f
C2052 VDD a_20593_16869# 0.49417f
C2053 VDD a_23145_13226# 0.30411f
C2054 VDD a_18871_6698# 0.2822f
C2055 VDD a_11473_7532# 0.49417f
C2056 CHAN0_MUX_SEL1 a_1256_16071# 1.44243f
C2057 CHAN0_MUX_SEL0 a_1544_16071# 0.07603f
C2058 a_4187_2434# a_4003_16869# 0.05992f
C2059 a_18443_16869# a_18551_16869# 0.01163f
C2060 a_17065_16071# a_16510_16071# 0.03209f
C2061 a_8433_14024# a_8997_14024# 0.0114f
C2062 a_14888_13226# a_14964_13190# 0.01176f
C2063 a_11277_14024# a_11848_13226# 0.10863f
C2064 a_25283_14024# a_25391_14024# 0.01163f
C2065 a_4187_2434# a_25913_4687# 0.11222f
C2066 a_12849_11557# a_15304_10295# 0.0606f
C2067 a_6854_11676# a_9712_9602# 0.83268f
C2068 a_13592_11561# a_14851_11918# 0.01529f
C2069 a_21157_7532# a_20723_7532# 0.6972f
C2070 a_6854_11144# a_5778_9057# 0.02695f
C2071 a_5974_11413# a_5864_9057# 0.01697f
C2072 a_6126_9506# a_9444_9602# 0.25721f
C2073 a_25717_7532# a_25630_6734# 0.1088f
C2074 a_25717_4687# a_25913_4687# 0.73897f
C2075 a_7945_3889# a_7390_3889# 0.03209f
C2076 a_8237_1842# a_7803_1842# 0.6972f
C2077 a_24523_1842# a_24631_1842# 0.01163f
C2078 a_11277_1842# a_10430_1044# 0.08038f
C2079 a_18117_1842# a_18585_1044# 0.2079f
C2080 a_14235_1044# a_14311_1008# 0.01194f
C2081 a_13470_1044# a_14964_1008# 0.28279f
C2082 a_26185_1044# a_25630_1044# 0.03209f
C2083 a_15837_1842# VDD 0.88141f
C2084 a_24084_1008# VDD 0.28328f
C2085 REF_MUX_SEL1 REF_MUX_SEL4 0.03574f
C2086 REF_MUX_SEL2 REF_MUX_SEL3 3.21891f
C2087 VDD a_6711_16035# 0.2822f
C2088 VDD a_18551_14652# 0.01806f
C2089 VDD a_23763_4687# 0.49684f
C2090 CHAN0_MUX_SEL4 a_4003_14024# 0.01225f
C2091 a_21157_16869# a_21353_16869# 0.77122f
C2092 a_25717_16869# a_25630_16071# 0.1088f
C2093 a_4187_2434# a_16793_14024# 0.11222f
C2094 a_25630_16071# a_26985_15546# 0.02165f
C2095 a_25717_14024# a_25283_14024# 0.69698f
C2096 a_4187_2434# a_8237_4687# 0.04141f
C2097 a_6326_10280# a_5974_11413# 0.33136f
C2098 a_12037_7532# a_12233_7532# 0.77122f
C2099 a_19448_6734# a_19524_6698# 0.01176f
C2100 a_16597_4687# a_17357_4687# 0.01669f
C2101 a_24957_1842# a_25717_1842# 0.06198f
C2102 a_6425_1044# a_6635_1044# 0.09424f
C2103 a_1544_3134# VDD 0.39372f
C2104 a_14025_1044# VDD 0.30514f
C2105 a_18004_3853# a_17357_4687# 0.02312f
C2106 a_11785_3364# a_10430_3889# 0.02058f
C2107 VDD a_14643_14024# 0.49684f
C2108 VDD a_23431_13190# 0.28336f
C2109 VDD a_27433_7532# 0.49285f
C2110 VDD a_6153_4687# 0.4946f
C2111 VDD a_11848_3889# 0.17499f
C2112 REF_MUX_SEL4 a_2873_6021# 0.04916f
C2113 REF_MUX_OUT a_2297_6021# 0.01179f
C2114 REF_MUX_SEL3 a_3449_6021# 0.28429f
C2115 a_4187_2434# a_19963_16869# 0.06627f
C2116 a_12037_16869# a_12797_16869# 0.02912f
C2117 a_19448_16071# a_19550_16071# 0.37183f
C2118 a_16597_14024# a_16793_14024# 0.73897f
C2119 a_4187_2434# a_10843_7532# 0.06627f
C2120 a_20397_14024# a_20968_13226# 0.10863f
C2121 a_25528_13226# a_25604_13190# 0.01176f
C2122 a_16923_7532# a_17031_7532# 0.01163f
C2123 a_23003_7532# a_23111_8160# 0.01697f
C2124 a_7390_6734# a_7364_6698# 0.277f
C2125 a_10517_4687# a_10430_3889# 0.1088f
C2126 a_5731_5979# a_15273_4687# 0.01872f
C2127 a_18795_3889# a_18871_3853# 0.01194f
C2128 a_15837_1842# a_16163_1842# 0.01427f
C2129 a_20397_1842# a_19550_1044# 0.08038f
C2130 a_13991_2470# VDD 0.01806f
C2131 a_2297_331# CHAN3_MUX_OUT 0.01179f
C2132 VDD CHAN1_MUX_OUT 0.57958f
C2133 a_3449_331# CHAN3_MUX_SEL3 0.28429f
C2134 a_2873_331# CHAN3_MUX_SEL4 0.04916f
C2135 a_15273_1842# a_4187_2434# 0.11222f
C2136 VDD a_27991_16035# 0.28273f
C2137 VDD a_18877_16869# 0.87825f
C2138 VDD a_10985_13226# 0.30411f
C2139 VDD a_9757_7532# 0.87771f
C2140 VDD a_16408_6734# 0.17274f
C2141 CHAN1_MUX_SEL3 a_1256_12471# 1.41161f
C2142 CHAN1_MUX_SEL2 a_1544_12471# 0.07405f
C2143 CHAN1_DELAY_IN a_3449_12513# 0.01017f
C2144 a_16923_16869# a_17031_16869# 0.01163f
C2145 a_7288_16071# a_7364_16035# 0.01176f
C2146 a_14025_16071# a_14311_16035# 0.01885f
C2147 a_23763_14024# a_23871_14024# 0.01163f
C2148 a_7477_14024# a_8237_14024# 0.01669f
C2149 a_5731_15316# a_14643_14024# 0.01544f
C2150 a_13470_13226# a_13444_13190# 0.277f
C2151 a_13121_11521# a_14111_11568# 0.0235f
C2152 a_13566_11525# a_14009_11568# 0.02242f
C2153 a_4187_2434# a_24197_4687# 0.04152f
C2154 a_24665_13226# a_24875_13226# 0.09424f
C2155 a_19833_7532# a_20397_7532# 0.0114f
C2156 a_24393_4687# a_24523_4687# 0.70845f
C2157 a_6913_1842# a_7477_1842# 0.0114f
C2158 a_5731_3134# a_14317_1842# 0.01319f
C2159 a_9757_1842# a_9751_1008# 0.02354f
C2160 a_23145_1044# a_23431_1008# 0.01885f
C2161 a_23003_1842# a_23111_1842# 0.01163f
C2162 a_13123_1842# VDD 0.49999f
C2163 a_21835_1044# VDD 0.15482f
C2164 a_27124_3853# a_26477_4687# 0.02312f
C2165 VDD a_4248_16071# 0.17587f
C2166 VDD a_12471_14652# 0.01806f
C2167 VDD a_22113_4687# 0.49655f
C2168 CHAN0_MUX_SEL4 a_15964_15316# 0.5544f
C2169 a_19833_16869# a_19963_16869# 0.70845f
C2170 a_4187_2434# a_15077_14024# 0.04141f
C2171 a_24393_14024# a_24957_14024# 0.0114f
C2172 a_4187_2434# a_26803_7532# 0.06661f
C2173 a_4187_2434# a_5523_4687# 0.06627f
C2174 a_4905_13226# a_5191_13190# 0.01885f
C2175 a_16108_12471# a_26985_12701# 0.2906f
C2176 a_10713_7532# a_10843_7532# 0.70845f
C2177 a_4350_6734# a_5731_5979# 0.41099f
C2178 a_15837_4687# a_15403_4687# 0.6972f
C2179 a_24197_1842# a_23763_1842# 0.6972f
C2180 a_4157_1313# a_4350_1044# 0.04624f
C2181 a_16108_289# a_16851_309# 0.06181f
C2182 a_4157_1313# VDD 0.52404f
C2183 a_25604_3853# VDD 0.28633f
C2184 a_16510_3889# a_16597_4687# 0.1088f
C2185 VDD a_12993_14024# 0.49655f
C2186 VDD a_23111_17497# 0.01806f
C2187 VDD a_25717_7532# 0.86712f
C2188 VDD a_20968_13226# 0.17499f
C2189 VDD a_4437_4687# 0.872f
C2190 VDD a_8884_3853# 0.28225f
C2191 REF_CLK a_13592_11561# 0.11539f
C2192 CHAN2_MUX_SEL0 a_3449_4240# 0.10753f
C2193 a_4187_2434# a_18313_16869# 0.11222f
C2194 a_11277_16869# a_10843_16869# 0.6972f
C2195 a_17928_16071# a_18004_16035# 0.01176f
C2196 a_15273_14024# a_15403_14024# 0.70845f
C2197 a_4187_2434# a_9193_7532# 0.11222f
C2198 a_15688_11093# a_15464_9374# 0.1999f
C2199 a_9444_10280# a_9712_9602# 0.39071f
C2200 a_15403_7532# a_15511_7532# 0.01163f
C2201 a_21483_7532# a_21591_8160# 0.01697f
C2202 a_5731_5979# a_13557_4687# 0.01314f
C2203 a_6717_4687# a_6913_4687# 0.76914f
C2204 a_12505_6734# a_12715_6734# 0.09424f
C2205 a_15077_1842# a_15273_1842# 0.77122f
C2206 a_16510_3889# a_18004_3853# 0.28279f
C2207 a_17275_3889# a_17351_3853# 0.01194f
C2208 a_16108_3134# a_27433_1842# 0.01872f
C2209 a_18877_1842# a_18871_1008# 0.02354f
C2210 a_22590_1044# a_24875_1044# 0.39036f
C2211 a_7911_2470# VDD 0.01806f
C2212 VDD CHAN0_MUX_OUT 0.72212f
C2213 a_13557_1842# a_4187_2434# 0.0414f
C2214 a_16510_3889# a_18585_3889# 0.03208f
C2215 VDD a_16163_16869# 0.4973f
C2216 VDD a_25528_16071# 0.17274f
C2217 VDD a_7043_7532# 0.49723f
C2218 VDD a_13470_6734# 0.87936f
C2219 REF_DELAY_OUT_LAST a_14851_10872# 0.02109f
C2220 a_15403_16869# a_15511_16869# 0.01163f
C2221 a_5731_15316# a_12993_14024# 0.01872f
C2222 a_6717_14024# a_6283_14024# 0.6972f
C2223 a_22243_14024# a_22351_14024# 0.01163f
C2224 a_4187_2434# a_21483_4687# 0.06627f
C2225 a_18877_7532# a_19637_7532# 0.06198f
C2226 a_1544_5979# a_1721_6021# 0.36963f
C2227 a_1256_5979# a_2297_6021# 0.04261f
C2228 a_23437_4687# a_23763_4687# 0.01427f
C2229 a_8237_1842# a_8884_1008# 0.02312f
C2230 a_27563_1842# a_27671_2470# 0.01697f
C2231 a_5731_3134# a_11603_1842# 0.01544f
C2232 a_21483_1842# a_21591_1842# 0.01163f
C2233 a_5957_1842# a_6717_1842# 0.02912f
C2234 a_10430_1044# a_12791_1008# 0.26208f
C2235 a_18871_1008# VDD 0.2841f
C2236 a_11473_1842# VDD 0.49593f
C2237 a_11785_3364# CHAN2_MUX_SEL4 0.03255f
C2238 VDD CHAN3_MUX_SEL0 0.50264f
C2239 a_25630_3889# a_4187_2434# 0.02227f
C2240 a_25630_3889# a_25717_4687# 0.1088f
C2241 VDD a_18585_16071# 0.29722f
C2242 VDD a_6391_14652# 0.01806f
C2243 VDD a_20397_4687# 0.87185f
C2244 CHAN0_MUX_SEL4 a_8745_15546# 0.04472f
C2245 CHAN0_MUX_OUT a_5731_15316# 1.04829f
C2246 a_18877_16869# a_19203_16869# 0.01427f
C2247 a_1544_16071# a_1721_16422# 0.38063f
C2248 a_4187_2434# a_12363_14024# 0.06627f
C2249 a_1256_15316# a_1721_15358# 0.13421f
C2250 a_23437_14024# a_24197_14024# 0.03319f
C2251 a_4187_2434# a_25153_7532# 0.11284f
C2252 a_15765_12645# a_15964_12471# 0.061f
C2253 a_5731_12471# a_5974_11413# 0.01167f
C2254 a_9757_7532# a_10083_7532# 0.01427f
C2255 a_16108_5979# a_26673_4687# 0.01872f
C2256 a_14513_4687# a_15077_4687# 0.0114f
C2257 a_16510_6734# a_17275_6734# 0.39037f
C2258 a_19550_3889# a_20905_3364# 0.02165f
C2259 a_22873_1842# a_23437_1842# 0.0114f
C2260 a_23355_3889# VDD 0.1539f
C2261 VDD a_17031_17497# 0.01806f
C2262 VDD a_11277_14024# 0.87175f
C2263 VDD a_18004_13190# 0.28225f
C2264 VDD a_23003_7532# 0.4973f
C2265 VDD a_15765_6153# 0.36528f
C2266 VDD a_6635_3889# 0.15407f
C2267 CHAN0_MUX_SEL4 a_4187_2434# 0.01921f
C2268 DLL_RESETN a_13019_11521# 0.01429f
C2269 REF_CLK a_12656_11554# 0.01215f
C2270 a_9953_16869# a_10517_16869# 0.0114f
C2271 a_4187_2434# a_16597_16869# 0.0414f
C2272 a_16510_16071# a_16484_16035# 0.277f
C2273 a_16108_15316# a_26043_14024# 0.01539f
C2274 a_14317_14024# a_14643_14024# 0.01427f
C2275 a_4187_2434# a_7477_7532# 0.0414f
C2276 a_14851_10872# a_15108_11015# 0.29858f
C2277 a_14009_10774# a_14757_10872# 0.01058f
C2278 a_22590_13226# a_23355_13226# 0.39037f
C2279 a_13883_7532# a_13991_7532# 0.01163f
C2280 a_26673_7532# a_26803_7532# 0.70845f
C2281 a_19963_7532# a_20071_8160# 0.01697f
C2282 a_4350_6734# a_5191_6698# 0.28268f
C2283 a_5393_4687# a_5523_4687# 0.70845f
C2284 a_5731_5979# a_10843_4687# 0.01539f
C2285 a_10430_3889# a_11848_3889# 0.38994f
C2286 a_17357_1842# a_18004_1008# 0.02312f
C2287 a_13753_1842# a_13883_1842# 0.70845f
C2288 a_16108_3134# a_25717_1842# 0.01314f
C2289 a_10430_1044# a_11785_519# 0.02058f
C2290 a_27433_1842# VDD 0.4946f
C2291 a_10843_1842# a_4187_2434# 0.06627f
C2292 VDD a_14513_16869# 0.49417f
C2293 VDD a_1721_13577# 0.4533f
C2294 VDD a_22590_16071# 0.89557f
C2295 VDD a_10404_6698# 0.28633f
C2296 VDD a_5393_7532# 0.49417f
C2297 VDD a_27671_5315# 0.01806f
C2298 CHAN3_DELAY_OUT_LAST a_4187_2434# 0.21225f
C2299 a_13883_16869# a_13991_16869# 0.01163f
C2300 a_27237_16869# a_26803_16869# 0.6972f
C2301 a_5731_15316# a_11277_14024# 0.01319f
C2302 a_5393_14024# a_5957_14024# 0.0114f
C2303 a_4350_16071# a_5115_16071# 0.39037f
C2304 a_7803_14024# a_7390_13226# 0.01012f
C2305 a_26803_14024# a_26911_14652# 0.01697f
C2306 a_20723_14024# a_20831_14024# 0.01163f
C2307 a_4187_2434# a_19833_4687# 0.11222f
C2308 a_10430_13226# a_11271_13190# 0.28268f
C2309 a_20105_13226# a_20315_13226# 0.09424f
C2310 a_12355_11557# a_13019_11521# 0.3846f
C2311 a_18117_7532# a_17683_7532# 0.6972f
C2312 a_22677_4687# a_22873_4687# 0.73897f
C2313 a_19550_6734# a_16108_5979# 0.58202f
C2314 a_5731_3134# a_9953_1842# 0.01872f
C2315 a_7477_1842# a_7390_1044# 0.1088f
C2316 a_5197_1842# a_4763_1842# 0.6972f
C2317 a_19963_1842# a_20071_1842# 0.01163f
C2318 a_26043_1842# a_26151_2470# 0.01697f
C2319 a_10328_1044# a_10430_1044# 0.37183f
C2320 a_16408_1044# VDD 0.17444f
C2321 a_9757_1842# VDD 0.8837f
C2322 CHAN1_MUX_SEL2 CHAN1_MUX_SEL4 0.01978f
C2323 VDD CHAN2_MUX_SEL0 0.56365f
C2324 CHAN1_MUX_SEL1 CHAN1_MUX_OUT 0.09357f
C2325 VDD a_27237_14024# 0.86075f
C2326 VDD a_9547_11862# 0.08951f
C2327 VDD a_17683_4687# 0.49684f
C2328 CHAN0_MUX_SEL3 a_3449_15358# 0.28429f
C2329 CHAN0_MUX_OUT a_2297_15358# 0.01179f
C2330 CHAN0_MUX_SEL4 a_2873_15358# 0.04916f
C2331 a_4187_2434# a_10713_14024# 0.11222f
C2332 a_18117_16869# a_18313_16869# 0.77122f
C2333 a_4187_2434# a_23437_7532# 0.04176f
C2334 a_22677_14024# a_22243_14024# 0.69698f
C2335 a_8997_7532# a_9193_7532# 0.77122f
C2336 a_5731_12471# a_15964_12471# 0.2778f
C2337 a_12363_7532# a_10430_6734# 0.01012f
C2338 a_27705_6734# a_27915_6734# 0.09424f
C2339 a_19637_7532# a_20105_6734# 0.19203f
C2340 a_16108_5979# a_24957_4687# 0.01307f
C2341 a_13557_4687# a_14317_4687# 0.01669f
C2342 a_25630_3889# a_27915_3889# 0.39036f
C2343 a_21917_1842# a_22677_1842# 0.06198f
C2344 a_26477_1842# a_27124_1008# 0.02312f
C2345 a_20391_3853# VDD 0.28357f
C2346 a_26803_1842# a_4187_2434# 0.06627f
C2347 a_5731_3134# a_4350_3889# 0.41099f
C2348 VDD a_10951_17497# 0.01806f
C2349 VDD a_8563_14024# 0.49684f
C2350 VDD a_15755_13226# 0.15389f
C2351 VDD a_5731_5979# 0.95083f
C2352 VDD a_21353_7532# 0.49285f
C2353 DLL_RESETN a_11748_11799# 0.11133f
C2354 REF_CLK a_10751_11568# 0.01931f
C2355 a_4187_2434# a_13883_16869# 0.06627f
C2356 a_8997_16869# a_9757_16869# 0.02912f
C2357 a_12363_16869# a_10430_16071# 0.01012f
C2358 a_19637_16869# a_20105_16071# 0.19203f
C2359 a_4187_2434# a_4763_7532# 0.06627f
C2360 a_13557_14024# a_13753_14024# 0.73897f
C2361 a_16108_15316# a_24393_14024# 0.01872f
C2362 a_16923_14024# a_16510_13226# 0.01012f
C2363 a_12363_7532# a_12471_7532# 0.01163f
C2364 a_7945_6734# a_8155_6734# 0.09424f
C2365 a_18443_7532# a_18551_8160# 0.01697f
C2366 a_4437_7532# a_4905_6734# 0.19203f
C2367 a_5731_5979# a_9193_4687# 0.01872f
C2368 a_13470_3889# a_15831_3853# 0.26208f
C2369 a_16108_3134# a_23003_1842# 0.01539f
C2370 a_16597_1842# a_16510_1044# 0.1088f
C2371 a_12797_1842# a_13123_1842# 0.01427f
C2372 a_25717_1842# VDD 0.87128f
C2373 a_9193_1842# a_4187_2434# 0.11222f
C2374 a_12715_3889# a_12505_3889# 0.09424f
C2375 VDD a_19524_16035# 0.28633f
C2376 VDD a_12797_16869# 0.87771f
C2377 VDD a_9444_9602# 0.0107f
C2378 VDD a_8155_6734# 0.15389f
C2379 VDD a_21591_5315# 0.01806f
C2380 CHAN2_DELAY_OUT_LAST a_4187_2434# 0.21225f
C2381 REF_MUX_SEL4 a_4157_7003# 0.08229f
C2382 a_9465_16071# a_7390_16071# 0.03208f
C2383 a_4187_2434# a_26673_14024# 0.11222f
C2384 a_4437_16869# a_4905_16071# 0.19203f
C2385 a_12363_16869# a_12471_16869# 0.01163f
C2386 a_25913_16869# a_26477_16869# 0.0114f
C2387 a_19203_14024# a_19311_14024# 0.01163f
C2388 a_12037_14024# a_12505_13226# 0.2079f
C2389 a_25283_14024# a_25391_14652# 0.01697f
C2390 a_5731_15316# a_8563_14024# 0.01544f
C2391 a_6717_14024# a_7288_13226# 0.10864f
C2392 a_4437_14024# a_5197_14024# 0.01669f
C2393 a_4187_2434# a_18117_4687# 0.04152f
C2394 a_9675_13226# a_9751_13190# 0.01194f
C2395 a_16793_7532# a_17357_7532# 0.0114f
C2396 a_21483_7532# a_19550_6734# 0.01012f
C2397 a_25630_6734# a_26471_6698# 0.28268f
C2398 a_16510_6734# a_16851_5999# 0.02131f
C2399 a_21353_4687# a_21483_4687# 0.70845f
C2400 a_5731_3134# a_8237_1842# 0.01319f
C2401 a_24523_1842# a_24631_2470# 0.01697f
C2402 a_18443_1842# a_18551_1842# 0.01163f
C2403 a_8808_1044# a_8884_1008# 0.01176f
C2404 a_18585_1044# a_16510_1044# 0.03208f
C2405 a_7043_1842# VDD 0.49996f
C2406 a_13470_1044# VDD 1.07811f
C2407 a_2297_3176# CHAN2_MUX_SEL2 0.10655f
C2408 a_1544_3134# CHAN2_MUX_SEL4 0.47529f
C2409 a_1256_3134# CHAN2_MUX_OUT 0.1134f
C2410 a_4157_1313# CHAN3_MUX_SEL4 0.08229f
C2411 CHAN1_DELAY_IN CHAN1_MUX_SEL0 0.14089f
C2412 VDD REF_MUX_SEL0 0.56365f
C2413 VDD a_23945_12701# 0.29292f
C2414 VDD a_24523_14024# 0.50001f
C2415 VDD a_16033_4687# 0.49413f
C2416 CHAN1_MUX_SEL0 a_3449_13577# 0.10753f
C2417 a_16793_16869# a_16923_16869# 0.70845f
C2418 a_21483_16869# a_19550_16071# 0.01012f
C2419 a_4187_2434# a_8997_14024# 0.04141f
C2420 a_16510_16071# a_16108_15316# 0.56108f
C2421 a_21353_14024# a_21917_14024# 0.0114f
C2422 a_4187_2434# a_20723_7532# 0.06661f
C2423 a_25630_16071# a_26395_16071# 0.39037f
C2424 a_5731_12471# a_8745_12701# 0.28635f
C2425 a_26043_14024# a_25630_13226# 0.01012f
C2426 a_7673_7532# a_7803_7532# 0.70845f
C2427 a_13470_6734# a_14888_6734# 0.38994f
C2428 a_12797_4687# a_12363_4687# 0.6972f
C2429 a_16108_5979# a_22243_4687# 0.01539f
C2430 a_25717_1842# a_25630_1044# 0.1088f
C2431 a_21157_1842# a_20723_1842# 0.6972f
C2432 a_17928_3889# VDD 0.17499f
C2433 a_25153_1842# a_4187_2434# 0.11222f
C2434 VDD a_6913_14024# 0.49655f
C2435 VDD a_4871_17497# 0.01806f
C2436 VDD a_12791_13190# 0.2822f
C2437 VDD a_19637_7532# 0.86712f
C2438 VDD a_2297_6021# 0.46603f
C2439 VDD a_17065_3889# 0.3023f
C2440 DLL_RESETN a_9946_11995# 0.09997f
C2441 a_8237_16869# a_7803_16869# 0.6972f
C2442 a_4187_2434# a_12233_16869# 0.11222f
C2443 a_13470_16071# a_14311_16035# 0.28268f
C2444 a_16108_15316# a_22677_14024# 0.01314f
C2445 a_12233_14024# a_12363_14024# 0.70845f
C2446 a_15837_14024# a_16408_13226# 0.10864f
C2447 a_19550_13226# a_20968_13226# 0.38994f
C2448 a_25717_14024# a_26185_13226# 0.19203f
C2449 a_10843_7532# a_10951_7532# 0.01163f
C2450 a_24957_7532# a_25153_7532# 0.76914f
C2451 a_13566_11018# a_13306_10795# 0.75507f
C2452 a_16923_7532# a_17031_8160# 0.01697f
C2453 a_6283_4687# a_4350_3889# 0.01012f
C2454 a_5731_5979# a_7477_4687# 0.01314f
C2455 a_10517_4687# a_10985_3889# 0.19203f
C2456 a_7390_3889# a_9675_3889# 0.39036f
C2457 a_12037_1842# a_12233_1842# 0.77122f
C2458 a_13368_3889# a_13470_3889# 0.37183f
C2459 a_16108_3134# a_21353_1842# 0.01872f
C2460 a_19448_1044# a_19524_1008# 0.01176f
C2461 a_23003_1842# VDD 0.50058f
C2462 a_15765_463# VDD 0.35391f
C2463 a_7477_1842# a_4187_2434# 0.0414f
C2464 VDD a_10083_16869# 0.49727f
C2465 VDD a_17275_16071# 0.15389f
C2466 VDD a_15688_11093# 0.30345f
C2467 VDD a_5191_6698# 0.28637f
C2468 VDD a_15511_5315# 0.01806f
C2469 REF_DELAY_OUT_LAST a_4187_2434# 1.08837f
C2470 REF_MUX_SEL0 a_2873_7085# 0.01504f
C2471 a_10843_16869# a_10951_16869# 0.01163f
C2472 a_24957_16869# a_25717_16869# 0.06198f
C2473 a_4187_2434# a_24957_14024# 0.0414f
C2474 a_5731_15316# a_6913_14024# 0.01872f
C2475 a_17683_14024# a_17791_14024# 0.01163f
C2476 a_6717_14024# a_4350_13226# 0.02479f
C2477 a_23763_14024# a_23871_14652# 0.01697f
C2478 a_15545_13226# a_15831_13190# 0.01885f
C2479 a_8155_13226# a_8231_13190# 0.01194f
C2480 a_10232_11561# a_11397_11918# 0.43239f
C2481 a_7390_13226# a_8884_13190# 0.28279f
C2482 a_4187_2434# a_15403_4687# 0.06627f
C2483 a_15837_7532# a_16597_7532# 0.06198f
C2484 a_24875_6734# a_24951_6698# 0.01194f
C2485 a_20397_4687# a_20723_4687# 0.01427f
C2486 a_16108_3134# a_20905_3364# 0.2906f
C2487 a_5731_3134# a_5523_1842# 0.01562f
C2488 a_7390_1044# a_7364_1008# 0.277f
C2489 a_23003_1842# a_23111_2470# 0.01697f
C2490 a_16923_1842# a_17031_1842# 0.01163f
C2491 a_5393_1842# VDD 0.49643f
C2492 a_10404_1008# VDD 0.28758f
C2493 a_2873_1395# CHAN3_MUX_SEL0 0.01504f
C2494 CHAN0_MUX_SEL2 CHAN0_MUX_SEL4 0.01978f
C2495 CHAN0_MUX_SEL1 CHAN0_MUX_OUT 0.09357f
C2496 VDD a_22873_14024# 0.49553f
C2497 VDD a_11785_12701# 0.29292f
C2498 VDD a_14317_4687# 0.87185f
C2499 VDD a_25391_8160# 0.01806f
C2500 a_15837_16869# a_16163_16869# 0.01427f
C2501 a_4187_2434# a_6283_14024# 0.06627f
C2502 a_20397_14024# a_21157_14024# 0.03319f
C2503 a_4187_2434# a_19073_7532# 0.11286f
C2504 a_24957_14024# a_25528_13226# 0.10864f
C2505 a_6717_7532# a_7043_7532# 0.01427f
C2506 a_23145_6734# a_23355_6734# 0.09424f
C2507 a_11473_4687# a_12037_4687# 0.0114f
C2508 a_24197_4687# a_24665_3889# 0.2079f
C2509 a_16108_5979# a_20593_4687# 0.01872f
C2510 a_19833_1842# a_20397_1842# 0.0114f
C2511 a_13470_3889# a_14825_3364# 0.02058f
C2512 a_14964_3853# VDD 0.28225f
C2513 a_23437_1842# a_4187_2434# 0.0414f
C2514 a_27915_3889# a_27705_3889# 0.09424f
C2515 VDD a_5197_14024# 0.87049f
C2516 VDD a_26043_16869# 0.4973f
C2517 VDD a_10328_13226# 0.17274f
C2518 VDD a_16923_7532# 0.4973f
C2519 VDD a_26471_6698# 0.28357f
C2520 VDD a_6425_3889# 0.29742f
C2521 CHAN1_MUX_OUT a_6854_11676# 0.04362f
C2522 DLL_RESETN a_5974_11413# 0.02002f
C2523 REF_MUX_SEL4 a_9757_7532# 0.01829f
C2524 a_4187_2434# a_10517_16869# 0.0414f
C2525 a_6913_16869# a_7477_16869# 0.0114f
C2526 a_12715_16071# a_12791_16035# 0.01194f
C2527 a_24665_16071# a_22590_16071# 0.03208f
C2528 a_16108_15316# a_19963_14024# 0.01539f
C2529 a_15837_14024# a_13470_13226# 0.02479f
C2530 a_11277_14024# a_11603_14024# 0.01427f
C2531 a_13106_11047# a_12907_10876# 0.02437f
C2532 a_13019_11521# a_9712_9602# 0.03275f
C2533 a_9323_7532# a_9431_7532# 0.01163f
C2534 a_15403_7532# a_15511_8160# 0.01697f
C2535 a_23633_7532# a_23763_7532# 0.70845f
C2536 a_4157_7003# a_4248_6734# 0.11672f
C2537 a_15964_5979# a_16851_5999# 0.16757f
C2538 a_16108_3134# a_19637_1842# 0.01314f
C2539 a_10713_1842# a_10843_1842# 0.70845f
C2540 a_4350_1044# a_5731_289# 0.41099f
C2541 a_21353_1842# VDD 0.4946f
C2542 a_5731_289# VDD 0.61464f
C2543 a_9757_1842# CHAN3_MUX_SEL4 0.01829f
C2544 a_4763_1842# a_4187_2434# 0.06627f
C2545 VDD a_8433_16869# 0.49417f
C2546 VDD a_14311_16035# 0.28357f
C2547 VDD a_13592_11113# 0.11685f
C2548 VDD a_9431_5315# 0.01806f
C2549 VDD a_24665_6734# 0.29722f
C2550 REF_CLK a_3449_6021# 0.01017f
C2551 REF_DELAY_OUT_LAST a_12849_11557# 0.01791f
C2552 REF_MUX_SEL0 a_1256_6734# 0.3314f
C2553 a_9323_16869# a_9431_16869# 0.01163f
C2554 a_24197_16869# a_23763_16869# 0.6972f
C2555 a_15964_15316# a_16108_15316# 0.42202f
C2556 a_4187_2434# a_22243_14024# 0.06627f
C2557 a_16163_14024# a_16271_14024# 0.01163f
C2558 a_22243_14024# a_22351_14652# 0.01697f
C2559 a_4437_14024# a_4324_13190# 0.05157f
C2560 a_4187_2434# a_13753_4687# 0.11222f
C2561 a_14025_13226# a_13470_13226# 0.03209f
C2562 a_10206_11525# a_10649_11568# 0.02242f
C2563 a_9946_11995# a_10520_11982# 0.31978f
C2564 a_15077_7532# a_14643_7532# 0.6972f
C2565 a_22590_6734# a_24084_6698# 0.28279f
C2566 a_23355_6734# a_23431_6698# 0.01194f
C2567 a_19637_4687# a_19833_4687# 0.73897f
C2568 a_21483_1842# a_21591_2470# 0.01697f
C2569 a_15403_1842# a_15511_1842# 0.01163f
C2570 a_12505_1044# a_12715_1044# 0.09424f
C2571 a_20905_3364# VDD 0.29292f
C2572 a_8155_1044# VDD 0.15465f
C2573 a_1256_1044# CHAN3_MUX_SEL0 0.3314f
C2574 CHAN0_DELAY_IN CHAN0_MUX_SEL0 0.14089f
C2575 a_19550_3889# a_21483_4687# 0.01012f
C2576 VDD a_21157_14024# 0.85955f
C2577 VDD a_19311_8160# 0.01806f
C2578 VDD a_11603_4687# 0.49684f
C2579 a_4187_2434# a_26477_16869# 0.04145f
C2580 a_4187_2434# a_4633_14024# 0.11222f
C2581 a_15077_16869# a_15273_16869# 0.77122f
C2582 a_22590_16071# a_24008_16071# 0.38994f
C2583 a_4187_2434# a_17357_7532# 0.04176f
C2584 a_1256_13226# a_2873_13577# 0.28892f
C2585 a_19637_14024# a_19203_14024# 0.69698f
C2586 a_24957_14024# a_22590_13226# 0.02479f
C2587 a_5957_7532# a_6153_7532# 0.77122f
C2588 a_8237_7532# a_8808_6734# 0.10863f
C2589 a_16108_5979# a_18877_4687# 0.01307f
C2590 a_10430_6734# a_12715_6734# 0.39036f
C2591 a_10517_4687# a_11277_4687# 0.01669f
C2592 a_18877_1842# a_19637_1842# 0.06198f
C2593 a_22488_3889# a_22564_3853# 0.01176f
C2594 a_1256_289# a_2297_331# 0.04261f
C2595 a_1544_289# a_1721_331# 0.36963f
C2596 a_12715_3889# VDD 0.15407f
C2597 a_20723_1842# a_4187_2434# 0.06627f
C2598 VDD a_24393_16869# 0.49285f
C2599 VDD a_7390_13226# 0.8686f
C2600 VDD a_16851_15336# 0.52304f
C2601 VDD a_15273_7532# 0.49298f
C2602 VDD a_24008_6734# 0.17499f
C2603 CHAN0_MUX_SEL4 a_4157_16340# 0.08229f
C2604 CHAN1_MUX_OUT a_16108_12471# 0.24265f
C2605 REF_MUX_SEL4 a_13470_6734# 0.256f
C2606 a_8237_16869# a_8808_16071# 0.10863f
C2607 a_4187_2434# a_7803_16869# 0.06627f
C2608 a_27563_16869# a_27671_17497# 0.01697f
C2609 a_5957_16869# a_6717_16869# 0.02912f
C2610 a_10430_16071# a_11924_16035# 0.28279f
C2611 a_10517_14024# a_10713_14024# 0.73897f
C2612 a_16108_15316# a_18313_14024# 0.02026f
C2613 a_11195_16071# a_11271_16035# 0.01194f
C2614 a_13557_14024# a_13444_13190# 0.05157f
C2615 a_12849_11557# a_15108_11015# 0.10521f
C2616 a_16510_13226# a_18795_13226# 0.39036f
C2617 a_13121_11521# a_15688_11093# 0.01441f
C2618 a_7803_7532# a_7911_7532# 0.01163f
C2619 a_13883_7532# a_13991_8160# 0.01697f
C2620 a_27433_4687# a_27997_4687# 0.0114f
C2621 a_16108_3134# a_16923_1842# 0.01073f
C2622 a_9757_1842# a_10083_1842# 0.01427f
C2623 a_16510_1044# a_17275_1044# 0.39037f
C2624 a_19637_1842# VDD 0.87128f
C2625 a_2297_331# VDD 0.46608f
C2626 a_13470_1044# CHAN3_MUX_SEL4 0.256f
C2627 VDD a_6717_16869# 0.87726f
C2628 VDD a_11848_16071# 0.17499f
C2629 VDD a_12505_6734# 0.29722f
C2630 VDD a_15304_10295# 0.72158f
C2631 VDD a_27563_4687# 0.50198f
C2632 a_4187_2434# a_20593_14024# 0.11222f
C2633 a_22873_16869# a_23437_16869# 0.0114f
C2634 a_7803_16869# a_7911_16869# 0.01163f
C2635 a_10985_13226# a_11271_13190# 0.01885f
C2636 a_20723_14024# a_20831_14652# 0.01697f
C2637 a_4350_13226# a_6711_13190# 0.26208f
C2638 a_14643_14024# a_14751_14024# 0.01163f
C2639 a_4187_2434# a_12037_4687# 0.04152f
C2640 a_17357_7532# a_17928_6734# 0.10863f
C2641 a_13753_7532# a_14317_7532# 0.0114f
C2642 a_18313_4687# a_18443_4687# 0.70845f
C2643 a_1256_3889# a_1544_3889# 1.26509f
C2644 a_26673_1842# a_26803_1842# 0.70845f
C2645 a_5731_3134# a_14825_3364# 0.28056f
C2646 a_19963_1842# a_20071_2470# 0.01697f
C2647 a_13883_1842# a_13991_1842# 0.01163f
C2648 a_4350_1044# a_5191_1008# 0.28268f
C2649 a_5191_1008# VDD 0.28668f
C2650 VDD a_1544_12471# 0.39332f
C2651 VDD a_18443_14024# 0.50001f
C2652 VDD a_13231_8160# 0.01806f
C2653 VDD a_9953_4687# 0.49655f
C2654 REF_MUX_SEL4 a_15765_6153# 0.65508f
C2655 a_4187_2434# a_23763_16869# 0.06627f
C2656 a_13753_16869# a_13883_16869# 0.70845f
C2657 a_4187_2434# a_16108_15316# 0.24917f
C2658 a_17357_16869# a_17928_16071# 0.10863f
C2659 a_4187_2434# a_14643_7532# 0.06668f
C2660 a_18313_14024# a_18877_14024# 0.0114f
C2661 a_22677_14024# a_22564_13190# 0.05157f
C2662 a_4633_7532# a_4763_7532# 0.70845f
C2663 a_18585_6734# a_18871_6698# 0.01885f
C2664 a_9757_4687# a_9323_4687# 0.6972f
C2665 a_16108_5979# a_16163_4687# 0.0155f
C2666 a_26803_4687# a_26911_4687# 0.01163f
C2667 a_18117_1842# a_17683_1842# 0.6972f
C2668 a_19550_1044# a_16108_289# 0.58202f
C2669 a_25391_2470# VDD 0.01806f
C2670 a_15765_463# CHAN3_MUX_SEL4 0.65508f
C2671 a_19073_1842# a_4187_2434# 0.11222f
C2672 a_23355_3889# a_23145_3889# 0.09424f
C2673 VDD a_22677_16869# 0.86712f
C2674 VDD a_4324_13190# 0.28607f
C2675 VDD a_13557_7532# 0.86712f
C2676 VDD a_21044_6698# 0.28225f
C2677 CHAN0_MUX_SEL0 a_2873_16422# 0.01504f
C2678 REF_CLK a_5731_12471# 0.02937f
C2679 a_5197_16869# a_4763_16869# 0.6972f
C2680 a_4187_2434# a_6153_16869# 0.11222f
C2681 a_26043_16869# a_26151_17497# 0.01697f
C2682 a_18585_16071# a_18795_16071# 0.09424f
C2683 a_9193_14024# a_9323_14024# 0.70845f
C2684 a_16108_15316# a_16597_14024# 0.01319f
C2685 a_4187_2434# a_27997_4687# 0.04001f
C2686 a_15108_11799# a_14851_11918# 0.29858f
C2687 a_12849_11557# a_13306_10795# 0.10976f
C2688 a_26477_7532# a_27048_6734# 0.10863f
C2689 a_12363_7532# a_12471_8160# 0.01697f
C2690 a_6283_7532# a_6391_7532# 0.01163f
C2691 a_21917_7532# a_22113_7532# 0.76914f
C2692 a_26477_4687# a_27237_4687# 0.03319f
C2693 a_4248_3889# a_4324_3853# 0.01176f
C2694 a_9465_3889# a_9675_3889# 0.09424f
C2695 a_12363_1842# a_10430_1044# 0.01012f
C2696 a_19637_1842# a_20105_1044# 0.19203f
C2697 a_8997_1842# a_9193_1842# 0.77122f
C2698 a_27705_1044# a_27915_1044# 0.09424f
C2699 a_16923_1842# VDD 0.4982f
C2700 a_26471_1008# VDD 0.28439f
C2701 VDD a_4003_16869# 0.61559f
C2702 VDD a_8884_16035# 0.28225f
C2703 VDD a_23871_14652# 0.01806f
C2704 VDD a_3449_7085# 0.46731f
C2705 VDD a_25913_4687# 0.49553f
C2706 a_26477_16869# a_27048_16071# 0.10863f
C2707 a_21917_16869# a_22677_16869# 0.06198f
C2708 a_6283_16869# a_6391_16869# 0.01163f
C2709 a_4187_2434# a_18877_14024# 0.0414f
C2710 a_26477_14024# a_26673_14024# 0.76914f
C2711 a_13123_14024# a_13231_14024# 0.01163f
C2712 a_19203_14024# a_19311_14652# 0.01697f
C2713 a_4187_2434# a_9323_4687# 0.06627f
C2714 a_4248_13226# a_4350_13226# 0.37183f
C2715 a_12797_7532# a_13557_7532# 0.06198f
C2716 a_19550_6734# a_21911_6698# 0.26208f
C2717 a_17357_4687# a_17683_4687# 0.01427f
C2718 a_12363_1842# a_12471_1842# 0.01163f
C2719 a_4437_1842# a_4905_1044# 0.19203f
C2720 a_18443_1842# a_18551_2470# 0.01697f
C2721 a_7945_1044# a_8155_1044# 0.09424f
C2722 a_24665_1044# VDD 0.29845f
C2723 VDD a_16793_14024# 0.49408f
C2724 VDD a_25604_13190# 0.28633f
C2725 VDD a_8237_4687# 0.87185f
C2726 VDD a_7151_8160# 0.01806f
C2727 DLL_RESETN a_12907_10876# 0.02177f
C2728 REF_MUX_SEL4 a_5731_5979# 4.60702f
C2729 a_4187_2434# a_22113_16869# 0.11222f
C2730 a_12797_16869# a_13123_16869# 0.01427f
C2731 a_4187_2434# a_12993_7532# 0.11222f
C2732 a_19550_16071# a_21835_16071# 0.39036f
C2733 a_17357_14024# a_18117_14024# 0.03319f
C2734 a_25630_13226# a_27991_13190# 0.26208f
C2735 a_17065_6734# a_16510_6734# 0.03209f
C2736 a_8433_4687# a_8997_4687# 0.0114f
C2737 a_25283_4687# a_25391_4687# 0.01163f
C2738 a_11277_4687# a_11848_3889# 0.10863f
C2739 a_19550_3889# a_20315_3889# 0.39037f
C2740 a_21483_1842# a_19550_1044# 0.01012f
C2741 a_16793_1842# a_17357_1842# 0.0114f
C2742 a_16510_1044# a_16851_309# 0.02131f
C2743 a_25630_1044# a_26471_1008# 0.28268f
C2744 a_19311_2470# VDD 0.01806f
C2745 a_5731_289# CHAN3_MUX_SEL4 4.60702f
C2746 a_17357_1842# a_4187_2434# 0.0414f
C2747 a_12715_3889# a_10430_3889# 0.39036f
C2748 VDD a_5705_15546# 0.29556f
C2749 VDD a_19963_16869# 0.4973f
C2750 VDD a_21625_13226# 0.29742f
C2751 VDD a_18795_6734# 0.15406f
C2752 VDD a_10843_7532# 0.4973f
C2753 CHAN0_MUX_SEL0 a_1256_16071# 0.3314f
C2754 CHAN1_MUX_SEL4 a_5705_12701# 0.03556f
C2755 a_4187_2434# a_4437_16869# 0.04193f
C2756 a_7390_16071# a_9751_16035# 0.26208f
C2757 a_24523_16869# a_24631_17497# 0.01697f
C2758 a_12037_14024# a_10430_13226# 0.05231f
C2759 a_8237_14024# a_8563_14024# 0.01427f
C2760 a_11277_14024# a_11271_13190# 0.02349f
C2761 a_4187_2434# a_25283_4687# 0.06627f
C2762 a_26185_13226# a_26471_13190# 0.01885f
C2763 a_6126_9506# a_5778_9057# 1.6143f
C2764 a_5974_11413# a_9712_9602# 0.01152f
C2765 a_14009_11568# a_14111_11568# 0.47795f
C2766 a_6326_10280# a_5864_9057# 0.01889f
C2767 a_10843_7532# a_10951_8160# 0.01697f
C2768 a_4763_7532# a_4871_7532# 0.01163f
C2769 a_20593_7532# a_20723_7532# 0.70845f
C2770 a_13121_11521# a_15304_10295# 0.40921f
C2771 a_25630_6734# a_26985_6209# 0.02165f
C2772 a_25717_4687# a_25283_4687# 0.69698f
C2773 a_7673_1842# a_7803_1842# 0.70845f
C2774 a_5731_3134# a_15403_1842# 0.01563f
C2775 a_13470_1044# a_14888_1044# 0.38994f
C2776 a_15273_1842# VDD 0.4946f
C2777 a_24008_1044# VDD 0.17575f
C2778 VDD a_6635_16071# 0.15406f
C2779 VDD a_17791_14652# 0.01806f
C2780 VDD a_24197_4687# 0.85996f
C2781 a_4763_16869# a_4871_16869# 0.01163f
C2782 a_21157_16869# a_20723_16869# 0.6972f
C2783 a_4187_2434# a_16163_14024# 0.06627f
C2784 a_25153_14024# a_25283_14024# 0.70845f
C2785 a_17683_14024# a_17791_14652# 0.01697f
C2786 a_5705_15546# a_5731_15316# 0.28954f
C2787 a_4187_2434# a_25630_13226# 0.01522f
C2788 a_11603_14024# a_11711_14024# 0.01163f
C2789 a_4187_2434# a_7673_4687# 0.11222f
C2790 a_12037_7532# a_11603_7532# 0.6972f
C2791 a_19448_6734# a_19550_6734# 0.37183f
C2792 a_16597_4687# a_16793_4687# 0.73897f
C2793 a_25630_3889# a_16108_3134# 0.55833f
C2794 a_10843_1842# a_10951_1842# 0.01163f
C2795 a_24957_1842# a_25153_1842# 0.76914f
C2796 a_16923_1842# a_17031_2470# 0.01697f
C2797 a_1256_3134# VDD 0.41949f
C2798 a_12505_1044# VDD 0.29845f
C2799 a_17928_3889# a_17357_4687# 0.10863f
C2800 VDD a_15077_14024# 0.86069f
C2801 VDD a_23355_13226# 0.1539f
C2802 VDD a_5523_4687# 0.49684f
C2803 VDD a_26803_7532# 0.49671f
C2804 VDD a_11271_3853# 0.28357f
C2805 CHAN0_MUX_SEL4 a_13470_16071# 0.256f
C2806 REF_MUX_SEL2 a_3449_6021# 0.10741f
C2807 REF_MUX_SEL4 a_2297_6021# 0.04338f
C2808 REF_MUX_SEL3 a_2873_6021# 0.12606f
C2809 a_12037_16869# a_12233_16869# 0.77122f
C2810 a_4187_2434# a_20397_16869# 0.04141f
C2811 a_16597_14024# a_16163_14024# 0.69698f
C2812 a_4187_2434# a_11277_7532# 0.04141f
C2813 a_20397_14024# a_20391_13190# 0.02349f
C2814 a_21157_14024# a_19550_13226# 0.05231f
C2815 a_25528_13226# a_25630_13226# 0.37183f
C2816 a_4763_7532# a_4350_6734# 0.01012f
C2817 a_7288_6734# a_7364_6698# 0.01176f
C2818 a_14025_6734# a_14311_6698# 0.01885f
C2819 a_5731_5979# a_14643_4687# 0.01544f
C2820 a_23763_4687# a_23871_4687# 0.01163f
C2821 a_7477_4687# a_8237_4687# 0.01669f
C2822 a_15837_1842# a_16597_1842# 0.06198f
C2823 a_24875_1044# a_24951_1008# 0.01194f
C2824 a_13231_2470# VDD 0.01806f
C2825 VDD CHAN1_MUX_SEL4 2.64786f
C2826 a_2297_331# CHAN3_MUX_SEL4 0.04338f
C2827 a_2873_331# CHAN3_MUX_SEL3 0.12606f
C2828 a_3449_331# CHAN3_MUX_SEL2 0.10741f
C2829 a_14643_1842# a_4187_2434# 0.06627f
C2830 a_18871_3853# a_18585_3889# 0.01885f
C2831 VDD a_18313_16869# 0.49285f
C2832 VDD a_27915_16071# 0.15389f
C2833 VDD a_9193_7532# 0.49285f
C2834 VDD a_9465_13226# 0.29742f
C2835 VDD a_15831_6698# 0.2816f
C2836 CHAN1_MUX_SEL2 a_1256_12471# 0.33134f
C2837 REF_DELAY_OUT_LAST a_15464_9374# 0.02565f
C2838 a_23003_16869# a_23111_17497# 0.01697f
C2839 a_4763_16869# a_4350_16071# 0.01012f
C2840 a_14025_16071# a_14235_16071# 0.09424f
C2841 a_7288_16071# a_7390_16071# 0.37183f
C2842 a_5731_15316# a_15077_14024# 0.01319f
C2843 a_9757_14024# a_10404_13190# 0.02011f
C2844 a_7477_14024# a_7673_14024# 0.73897f
C2845 a_13368_13226# a_13444_13190# 0.01176f
C2846 a_13566_11525# a_13592_11561# 0.36952f
C2847 a_4187_2434# a_23633_4687# 0.11222f
C2848 a_9323_7532# a_9431_8160# 0.01697f
C2849 a_24393_4687# a_24957_4687# 0.0114f
C2850 a_4905_3889# a_5191_3853# 0.01885f
C2851 a_6717_1842# a_7043_1842# 0.01427f
C2852 a_5731_3134# a_13753_1842# 0.01865f
C2853 a_23145_1044# a_23355_1044# 0.09424f
C2854 a_13557_1842# VDD 0.87128f
C2855 a_21044_1008# VDD 0.28328f
C2856 a_27048_3889# a_26477_4687# 0.10863f
C2857 VDD a_11711_14652# 0.01806f
C2858 VDD a_21483_4687# 0.50001f
C2859 CHAN0_MUX_SEL4 a_15765_15490# 0.65508f
C2860 a_19833_16869# a_20397_16869# 0.0114f
C2861 a_4187_2434# a_14513_14024# 0.11222f
C2862 a_4187_2434# a_27237_7532# 0.0629f
C2863 a_16163_14024# a_16271_14652# 0.01697f
C2864 a_10083_14024# a_10191_14024# 0.01163f
C2865 a_4187_2434# a_5957_4687# 0.04152f
C2866 a_4905_13226# a_5115_13226# 0.09424f
C2867 a_16108_12471# a_23945_12701# 0.2906f
C2868 a_10713_7532# a_11277_7532# 0.0114f
C2869 a_13883_7532# a_13470_6734# 0.01012f
C2870 a_17928_6734# a_18004_6698# 0.01176f
C2871 a_15273_4687# a_15403_4687# 0.70845f
C2872 a_9323_1842# a_9431_1842# 0.01163f
C2873 a_23633_1842# a_23763_1842# 0.70845f
C2874 a_15403_1842# a_15511_2470# 0.01697f
C2875 a_4157_1313# a_4248_1044# 0.11672f
C2876 a_15964_289# a_16851_309# 0.16757f
C2877 a_3449_1395# VDD 0.46876f
C2878 a_25630_3889# VDD 0.89819f
C2879 VDD a_12363_14024# 0.50001f
C2880 VDD a_22351_17497# 0.01806f
C2881 VDD a_20391_13190# 0.28336f
C2882 VDD a_25153_7532# 0.49426f
C2883 VDD a_26985_6209# 0.29292f
C2884 VDD a_8808_3889# 0.17499f
C2885 REF_CLK a_13566_11525# 0.01538f
C2886 CHAN2_DELAY_IN a_4157_4158# 0.50642f
C2887 a_13883_16869# a_13470_16071# 0.01012f
C2888 a_4187_2434# a_17683_16869# 0.06627f
C2889 a_10713_16869# a_10843_16869# 0.70845f
C2890 a_18877_14024# a_19524_13190# 0.02011f
C2891 a_15273_14024# a_15837_14024# 0.0114f
C2892 a_4187_2434# a_8563_7532# 0.06627f
C2893 a_9444_10280# a_9444_9602# 2.20289f
C2894 a_24008_13226# a_24084_13190# 0.01176f
C2895 a_15108_11015# a_15464_9374# 0.12158f
C2896 a_7477_7532# a_7945_6734# 0.19203f
C2897 a_27997_7532# a_27563_7532# 0.69646f
C2898 a_6717_4687# a_6283_4687# 0.6972f
C2899 a_5731_5979# a_12993_4687# 0.01872f
C2900 a_22243_4687# a_22351_4687# 0.01163f
C2901 a_16108_3134# a_26803_1842# 0.01544f
C2902 a_16510_3889# a_17928_3889# 0.38994f
C2903 a_15077_1842# a_14643_1842# 0.6972f
C2904 a_23355_1044# a_23431_1008# 0.01194f
C2905 a_22590_1044# a_24084_1008# 0.28279f
C2906 a_7151_2470# VDD 0.01806f
C2907 VDD CHAN0_MUX_SEL4 2.69627f
C2908 a_12993_1842# a_4187_2434# 0.11222f
C2909 a_16510_3889# a_17065_3889# 0.03209f
C2910 VDD a_16597_16869# 0.86886f
C2911 VDD a_24951_16035# 0.2822f
C2912 VDD a_7477_7532# 0.86712f
C2913 VDD a_13368_6734# 0.17274f
C2914 a_21483_16869# a_21591_17497# 0.01697f
C2915 a_7477_16869# a_7945_16071# 0.19203f
C2916 a_6153_14024# a_6283_14024# 0.70845f
C2917 a_5731_15316# a_12363_14024# 0.01542f
C2918 a_5768_16071# a_5844_16035# 0.01176f
C2919 a_8997_14024# a_8884_13190# 0.02055f
C2920 a_6854_11676# a_13592_11113# 0.01958f
C2921 a_4187_2434# a_21917_4687# 0.0414f
C2922 a_12849_11557# a_13306_11995# 0.12097f
C2923 a_1544_6734# a_1721_7085# 0.38063f
C2924 a_23003_7532# a_22590_6734# 0.01012f
C2925 a_7803_7532# a_7911_8160# 0.01697f
C2926 a_18877_7532# a_19073_7532# 0.76914f
C2927 a_1256_5979# a_1721_6021# 0.13421f
C2928 a_23437_4687# a_24197_4687# 0.03319f
C2929 a_5957_1842# a_6153_1842# 0.77122f
C2930 a_5731_3134# a_12037_1842# 0.01319f
C2931 a_8237_1842# a_8808_1044# 0.10863f
C2932 a_10430_1044# a_12715_1044# 0.39036f
C2933 a_10843_1842# VDD 0.50058f
C2934 a_18795_1044# VDD 0.15482f
C2935 VDD CHAN3_DELAY_OUT_LAST 0.4694f
C2936 DLL_RESETN REF_CLK 10.7961f
C2937 VDD a_17065_16071# 0.3023f
C2938 VDD a_5631_14652# 0.01806f
C2939 VDD a_10649_11568# 0.24892f
C2940 VDD a_19833_4687# 0.49553f
C2941 CHAN0_MUX_SEL4 a_5731_15316# 4.60702f
C2942 a_1256_16071# a_1721_16422# 0.13421f
C2943 a_18877_16869# a_19637_16869# 0.06198f
C2944 a_23003_16869# a_22590_16071# 0.01012f
C2945 a_4187_2434# a_12797_14024# 0.0414f
C2946 a_1256_15316# a_1544_15316# 1.25711f
C2947 a_8563_14024# a_8671_14024# 0.01163f
C2948 a_23437_14024# a_23633_14024# 0.76914f
C2949 a_4187_2434# a_24523_7532# 0.06661f
C2950 a_14643_14024# a_14751_14652# 0.01697f
C2951 a_5731_12471# a_6326_10280# 0.11352f
C2952 a_9757_7532# a_10517_7532# 0.06198f
C2953 a_12797_7532# a_13368_6734# 0.10864f
C2954 a_21157_7532# a_21625_6734# 0.2079f
C2955 a_16510_6734# a_16484_6698# 0.277f
C2956 a_14317_4687# a_14643_4687# 0.01427f
C2957 a_16108_5979# a_26043_4687# 0.01539f
C2958 a_27915_3889# a_27991_3853# 0.01194f
C2959 a_13883_1842# a_13991_2470# 0.01697f
C2960 a_7803_1842# a_7911_1842# 0.01163f
C2961 a_22564_3853# VDD 0.28633f
C2962 VDD a_16271_17497# 0.01806f
C2963 VDD a_17928_13226# 0.17499f
C2964 VDD a_10713_14024# 0.49553f
C2965 VDD a_23437_7532# 0.86919f
C2966 VDD a_5844_3853# 0.28225f
C2967 VDD a_14825_6209# 0.29292f
C2968 CHAN1_MUX_OUT a_13019_11521# 0.31842f
C2969 REF_CLK a_12355_11557# 1.0042f
C2970 DLL_RESETN a_12656_11554# 0.11782f
C2971 CHAN2_MUX_SEL0 a_1721_4240# 0.01315f
C2972 CHAN2_MUX_SEL1 a_1544_3889# 0.1672f
C2973 a_21157_16869# a_21625_16071# 0.2079f
C2974 a_9757_16869# a_10083_16869# 0.01427f
C2975 a_4187_2434# a_16033_16869# 0.11222f
C2976 a_12797_16869# a_13368_16071# 0.10864f
C2977 a_4187_2434# a_6913_7532# 0.11222f
C2978 a_16108_15316# a_26477_14024# 0.01319f
C2979 a_16408_16071# a_16484_16035# 0.01176f
C2980 a_14317_14024# a_15077_14024# 0.03319f
C2981 a_18117_14024# a_18004_13190# 0.02055f
C2982 a_14111_10917# a_13880_10808# 0.12701f
C2983 a_13470_13226# a_5731_12471# 0.41365f
C2984 a_13592_11113# a_14757_10872# 0.43239f
C2985 a_22590_13226# a_22564_13190# 0.277f
C2986 a_5957_7532# a_6425_6734# 0.2079f
C2987 a_4350_6734# a_5115_6734# 0.39037f
C2988 a_26673_7532# a_27237_7532# 0.0114f
C2989 a_5393_4687# a_5957_4687# 0.0114f
C2990 a_5731_5979# a_11277_4687# 0.01319f
C2991 a_10430_3889# a_11271_3853# 0.28268f
C2992 a_26803_4687# a_26911_5315# 0.01697f
C2993 a_20723_4687# a_20831_4687# 0.01163f
C2994 a_7803_4687# a_7390_3889# 0.01012f
C2995 a_17357_1842# a_17928_1044# 0.10863f
C2996 a_16108_3134# a_25153_1842# 0.01872f
C2997 a_13753_1842# a_14317_1842# 0.0114f
C2998 a_26803_1842# VDD 0.49684f
C2999 a_11277_1842# a_4187_2434# 0.0414f
C3000 a_14311_3853# a_14025_3889# 0.01885f
C3001 VDD a_13883_16869# 0.4973f
C3002 VDD a_1544_13226# 0.45079f
C3003 VDD a_22488_16071# 0.17274f
C3004 VDD a_4763_7532# 0.4973f
C3005 VDD a_10430_6734# 0.88416f
C3006 VDD a_26911_5315# 0.01806f
C3007 CHAN3_DELAY_IN a_4187_2434# 0.07719f
C3008 a_9465_16071# a_9751_16035# 0.01885f
C3009 a_4350_16071# a_4324_16035# 0.277f
C3010 a_19963_16869# a_20071_17497# 0.01697f
C3011 a_26673_16869# a_26803_16869# 0.70845f
C3012 a_5957_16869# a_6425_16071# 0.2079f
C3013 a_5197_14024# a_5523_14024# 0.01427f
C3014 a_5731_15316# a_10713_14024# 0.01865f
C3015 a_21625_13226# a_19550_13226# 0.03208f
C3016 a_13557_14024# a_14025_13226# 0.19203f
C3017 a_4187_2434# a_19203_4687# 0.06627f
C3018 a_8237_14024# a_7390_13226# 0.08038f
C3019 a_10430_13226# a_11195_13226# 0.39037f
C3020 a_6854_11676# a_15304_10295# 0.08165f
C3021 a_12355_11557# a_12656_11554# 0.03277f
C3022 a_6283_7532# a_6391_8160# 0.01697f
C3023 a_17553_7532# a_17683_7532# 0.70845f
C3024 a_21917_7532# a_22488_6734# 0.10864f
C3025 a_22677_4687# a_22243_4687# 0.69698f
C3026 a_5731_3134# a_9323_1842# 0.01542f
C3027 a_4633_1842# a_4763_1842# 0.70845f
C3028 a_18585_1044# a_18871_1008# 0.01885f
C3029 a_9193_1842# VDD 0.4946f
C3030 a_15831_1008# VDD 0.2835f
C3031 CHAN1_MUX_SEL2 CHAN1_MUX_SEL3 3.21891f
C3032 VDD CHAN2_DELAY_OUT_LAST 0.46919f
C3033 CHAN1_MUX_SEL1 CHAN1_MUX_SEL4 0.03574f
C3034 VDD a_6425_16071# 0.29722f
C3035 VDD a_26673_14024# 0.49593f
C3036 VDD a_9547_11632# 0.15246f
C3037 VDD a_18117_4687# 0.85996f
C3038 CHAN0_MUX_SEL2 a_3449_15358# 0.10741f
C3039 CHAN0_MUX_SEL4 a_2297_15358# 0.04338f
C3040 CHAN0_MUX_SEL3 a_2873_15358# 0.12606f
C3041 a_18117_16869# a_17683_16869# 0.6972f
C3042 a_4187_2434# a_10083_14024# 0.06627f
C3043 a_21917_16869# a_22488_16071# 0.10864f
C3044 a_7043_14024# a_7151_14024# 0.01163f
C3045 a_4187_2434# a_22873_7532# 0.11284f
C3046 a_13123_14024# a_13231_14652# 0.01697f
C3047 a_27048_16071# a_27124_16035# 0.01176f
C3048 a_22113_14024# a_22243_14024# 0.70845f
C3049 a_27237_14024# a_27124_13190# 0.02055f
C3050 a_5731_12471# a_15765_12645# 0.23301f
C3051 a_8997_7532# a_8563_7532# 0.6972f
C3052 a_12797_7532# a_10430_6734# 0.02479f
C3053 a_13557_4687# a_13753_4687# 0.73897f
C3054 a_16108_5979# a_24393_4687# 0.01872f
C3055 a_25630_3889# a_27124_3853# 0.28279f
C3056 a_26395_3889# a_26471_3853# 0.01194f
C3057 a_21917_1842# a_22113_1842# 0.76914f
C3058 a_12363_1842# a_12471_2470# 0.01697f
C3059 a_6283_1842# a_6391_1842# 0.01163f
C3060 a_26477_1842# a_27048_1044# 0.10863f
C3061 a_20315_3889# VDD 0.1539f
C3062 a_27237_1842# a_4187_2434# 0.06189f
C3063 a_13470_3889# a_13883_4687# 0.01012f
C3064 VDD a_10191_17497# 0.01806f
C3065 VDD a_14964_13190# 0.28225f
C3066 VDD a_8997_14024# 0.85955f
C3067 VDD a_20723_7532# 0.49671f
C3068 VDD a_27705_3889# 0.29962f
C3069 DLL_RESETN a_10751_11568# 0.45018f
C3070 a_4187_2434# a_14317_16869# 0.04141f
C3071 a_8997_16869# a_9193_16869# 0.77122f
C3072 a_12797_16869# a_10430_16071# 0.02479f
C3073 a_16108_15316# a_23763_14024# 0.01544f
C3074 a_4187_2434# a_5197_7532# 0.04141f
C3075 a_13557_14024# a_13123_14024# 0.69698f
C3076 a_27237_14024# a_27705_13226# 0.2079f
C3077 a_17357_14024# a_16510_13226# 0.08038f
C3078 a_15304_10295# a_14757_10872# 0.02225f
C3079 a_9465_6734# a_7390_6734# 0.03208f
C3080 a_25717_7532# a_26477_7532# 0.01669f
C3081 a_4437_7532# a_4157_7003# 0.01771f
C3082 a_4437_4687# a_5197_4687# 0.01669f
C3083 a_5731_5979# a_8563_4687# 0.01544f
C3084 a_19203_4687# a_19311_4687# 0.01163f
C3085 a_12037_4687# a_12505_3889# 0.2079f
C3086 a_25283_4687# a_25391_5315# 0.01697f
C3087 a_6717_4687# a_7288_3889# 0.10864f
C3088 a_9675_3889# a_9751_3853# 0.01194f
C3089 a_13470_3889# a_15755_3889# 0.39036f
C3090 a_12797_1842# a_13557_1842# 0.06198f
C3091 a_16108_3134# a_23437_1842# 0.01319f
C3092 a_19550_1044# a_21911_1008# 0.26208f
C3093 a_25153_1842# VDD 0.49655f
C3094 a_26985_519# VDD 0.29315f
C3095 a_8563_1842# a_4187_2434# 0.06627f
C3096 VDD a_19550_16071# 0.89766f
C3097 VDD a_12233_16869# 0.49285f
C3098 VDD a_7364_6698# 0.28633f
C3099 VDD a_20831_5315# 0.01806f
C3100 CHAN2_DELAY_IN a_4187_2434# 0.07974f
C3101 a_18443_16869# a_18551_17497# 0.01697f
C3102 a_4187_2434# a_26043_14024# 0.06627f
C3103 a_4437_16869# a_4157_16340# 0.01771f
C3104 a_7945_16071# a_7390_16071# 0.03209f
C3105 a_6717_14024# a_6711_13190# 0.02354f
C3106 a_4437_14024# a_4633_14024# 0.73897f
C3107 a_5731_15316# a_8997_14024# 0.01319f
C3108 a_4187_2434# a_17553_4687# 0.11222f
C3109 a_4763_7532# a_4871_8160# 0.01697f
C3110 a_16510_6734# a_16108_5979# 0.56108f
C3111 a_21917_7532# a_19550_6734# 0.02479f
C3112 a_25630_6734# a_26395_6734# 0.39037f
C3113 a_21353_4687# a_21917_4687# 0.0114f
C3114 a_5731_3134# a_7673_1842# 0.01865f
C3115 a_17065_1044# a_16510_1044# 0.03209f
C3116 a_7477_1842# VDD 0.87128f
C3117 a_13368_1044# VDD 0.17444f
C3118 a_1721_3176# CHAN2_MUX_SEL2 0.01315f
C3119 a_1544_3134# CHAN2_MUX_SEL3 0.15976f
C3120 a_1256_3134# CHAN2_MUX_SEL4 0.65005f
C3121 VDD REF_DELAY_OUT_LAST 0.71424f
C3122 a_22590_3889# a_23003_4687# 0.01012f
C3123 VDD a_24957_14024# 0.88247f
C3124 VDD a_20905_12701# 0.29292f
C3125 VDD a_15403_4687# 0.4973f
C3126 CHAN1_DELAY_IN a_4157_13495# 0.50642f
C3127 a_16793_16869# a_17357_16869# 0.0114f
C3128 a_4187_2434# a_8433_14024# 0.11222f
C3129 a_21917_16869# a_19550_16071# 0.02479f
C3130 a_25630_16071# a_25604_16035# 0.277f
C3131 a_16510_16071# a_15964_15316# 0.05416f
C3132 a_4187_2434# a_21157_7532# 0.04188f
C3133 a_5523_14024# a_5631_14024# 0.01163f
C3134 a_11603_14024# a_11711_14652# 0.01697f
C3135 a_26477_14024# a_25630_13226# 0.08038f
C3136 a_7673_7532# a_8237_7532# 0.0114f
C3137 a_13470_6734# a_14311_6698# 0.28268f
C3138 a_10517_7532# a_10404_6698# 0.05157f
C3139 a_12233_4687# a_12363_4687# 0.70845f
C3140 a_16108_5979# a_22677_4687# 0.01314f
C3141 a_25717_4687# a_26185_3889# 0.19203f
C3142 a_20593_1842# a_20723_1842# 0.70845f
C3143 a_10843_1842# a_10951_2470# 0.01697f
C3144 a_4763_1842# a_4871_1842# 0.01163f
C3145 a_25630_1044# a_26985_519# 0.02165f
C3146 a_17351_3853# VDD 0.28637f
C3147 a_24523_1842# a_4187_2434# 0.06627f
C3148 a_13368_3889# a_12797_4687# 0.10864f
C3149 VDD a_4111_17497# 0.01866f
C3150 VDD a_6283_14024# 0.50001f
C3151 VDD a_12715_13226# 0.15407f
C3152 VDD a_1721_6021# 0.45365f
C3153 VDD a_19073_7532# 0.49426f
C3154 VDD a_15545_3889# 0.29962f
C3155 DLL_RESETN a_9772_11533# 0.06592f
C3156 a_4187_2434# a_11603_16869# 0.06627f
C3157 a_7673_16869# a_7803_16869# 0.70845f
C3158 a_24665_16071# a_24951_16035# 0.01885f
C3159 a_13470_16071# a_14235_16071# 0.39037f
C3160 a_10517_16869# a_10404_16035# 0.05157f
C3161 a_15837_14024# a_15831_13190# 0.02354f
C3162 a_16108_15316# a_22113_14024# 0.01872f
C3163 a_12233_14024# a_12797_14024# 0.0114f
C3164 a_19550_13226# a_20391_13190# 0.28268f
C3165 a_24957_7532# a_24523_7532# 0.6972f
C3166 a_13132_11110# a_13306_10795# 0.27179f
C3167 a_17683_4687# a_17791_4687# 0.01163f
C3168 a_23763_4687# a_23871_5315# 0.01697f
C3169 a_5731_5979# a_6913_4687# 0.01872f
C3170 a_6717_4687# a_4350_3889# 0.02479f
C3171 a_8155_3889# a_8231_3853# 0.01194f
C3172 a_7390_3889# a_8884_3853# 0.28279f
C3173 a_12037_1842# a_11603_1842# 0.6972f
C3174 a_16108_3134# a_20723_1842# 0.01544f
C3175 a_19448_1044# a_19550_1044# 0.37183f
C3176 a_23437_1842# VDD 0.87208f
C3177 a_14825_519# VDD 0.29315f
C3178 a_6913_1842# a_4187_2434# 0.11222f
C3179 VDD a_10517_16869# 0.86712f
C3180 VDD a_16484_16035# 0.28687f
C3181 VDD a_15108_11015# 0.13728f
C3182 VDD a_14751_5315# 0.01806f
C3183 VDD a_5115_6734# 0.15389f
C3184 a_24957_16869# a_25153_16869# 0.76914f
C3185 a_16923_16869# a_17031_17497# 0.01697f
C3186 a_4187_2434# a_24393_14024# 0.11222f
C3187 a_5197_14024# a_5844_13190# 0.02312f
C3188 a_5731_15316# a_6283_14024# 0.01542f
C3189 a_15545_13226# a_15755_13226# 0.09424f
C3190 a_4187_2434# a_15837_4687# 0.0414f
C3191 a_7390_13226# a_8808_13226# 0.38994f
C3192 a_10520_11982# a_10751_11568# 0.12701f
C3193 a_15837_7532# a_16033_7532# 0.76914f
C3194 a_19637_7532# a_19524_6698# 0.05157f
C3195 a_20397_4687# a_21157_4687# 0.03319f
C3196 a_16108_3134# a_17865_3364# 0.29564f
C3197 a_5731_3134# a_5957_1842# 0.01644f
C3198 a_14025_1044# a_14311_1008# 0.01885f
C3199 a_7288_1044# a_7364_1008# 0.01176f
C3200 a_4763_1842# a_4350_1044# 0.01012f
C3201 a_4763_1842# VDD 0.49875f
C3202 a_10430_1044# VDD 1.08291f
C3203 CHAN0_MUX_SEL1 CHAN0_MUX_SEL4 0.03574f
C3204 CHAN0_MUX_SEL2 CHAN0_MUX_SEL3 3.21891f
C3205 a_22488_3889# a_21917_4687# 0.10864f
C3206 VDD a_22243_14024# 0.50004f
C3207 VDD a_13753_4687# 0.49553f
C3208 VDD a_24631_8160# 0.01806f
C3209 DLL_RESETN a_5864_9057# 0.1727f
C3210 REF_CLK a_9712_9602# 0.06562f
C3211 CHAN1_MUX_SEL1 a_1544_13226# 0.1672f
C3212 CHAN1_MUX_SEL0 a_1721_13577# 0.01315f
C3213 a_15837_16869# a_16597_16869# 0.06198f
C3214 a_4187_2434# a_27563_16869# 0.06629f
C3215 a_4187_2434# a_6717_14024# 0.0414f
C3216 a_19637_16869# a_19524_16035# 0.05157f
C3217 a_10083_14024# a_10191_14652# 0.01697f
C3218 a_20397_14024# a_20593_14024# 0.76914f
C3219 a_4187_2434# a_18443_7532# 0.06661f
C3220 a_4003_14024# a_4111_14024# 0.01163f
C3221 a_24957_14024# a_24951_13190# 0.02354f
C3222 a_6717_7532# a_7477_7532# 0.06198f
C3223 a_12715_6734# a_12791_6698# 0.01194f
C3224 a_24665_6734# a_22590_6734# 0.03208f
C3225 a_11277_4687# a_11603_4687# 0.01427f
C3226 a_16108_5979# a_19963_4687# 0.01539f
C3227 a_9323_1842# a_9431_2470# 0.01697f
C3228 a_22590_3889# a_24951_3853# 0.26208f
C3229 a_14888_3889# VDD 0.17499f
C3230 REF_CLK REF_MUX_SEL1 0.01858f
C3231 a_22873_1842# a_4187_2434# 0.11222f
C3232 VDD a_26477_16869# 0.86919f
C3233 VDD a_4633_14024# 0.49523f
C3234 VDD a_17357_7532# 0.86919f
C3235 VDD a_9751_13190# 0.2822f
C3236 VDD a_26395_6734# 0.15389f
C3237 VDD a_4905_3889# 0.3017f
C3238 a_4187_2434# a_9953_16869# 0.11222f
C3239 a_6717_16869# a_7043_16869# 0.01427f
C3240 a_23145_16071# a_22590_16071# 0.03209f
C3241 a_16108_15316# a_20397_14024# 0.01319f
C3242 a_11277_14024# a_12037_14024# 0.03319f
C3243 a_14317_14024# a_14964_13190# 0.02312f
C3244 a_18795_13226# a_18871_13190# 0.01194f
C3245 a_23633_7532# a_24197_7532# 0.0114f
C3246 a_15964_5979# a_16108_5979# 0.42202f
C3247 a_22243_4687# a_22351_5315# 0.01697f
C3248 a_16163_4687# a_16271_4687# 0.01163f
C3249 a_4437_4687# a_4324_3853# 0.05157f
C3250 a_16108_3134# a_19073_1842# 0.01872f
C3251 a_10713_1842# a_11277_1842# 0.0114f
C3252 a_13883_1842# a_13470_1044# 0.01012f
C3253 a_17928_1044# a_18004_1008# 0.01176f
C3254 a_20723_1842# VDD 0.49684f
C3255 a_5197_1842# a_4187_2434# 0.0414f
C3256 CHAN2_MUX_OUT CHAN3_DELAY_IN 0.0515f
C3257 VDD a_7803_16869# 0.4973f
C3258 VDD a_14235_16071# 0.15389f
C3259 VDD a_13306_10795# 0.79687f
C3260 VDD a_23145_6734# 0.30409f
C3261 VDD a_8671_5315# 0.01806f
C3262 REF_DELAY_OUT_LAST a_13121_11521# 0.13178f
C3263 a_15403_16869# a_15511_17497# 0.01697f
C3264 a_23633_16869# a_23763_16869# 0.70845f
C3265 a_15765_15490# a_16108_15316# 0.42004f
C3266 a_4187_2434# a_22677_14024# 0.0414f
C3267 a_4437_14024# a_4350_13226# 0.1088f
C3268 a_10206_11525# a_10232_11561# 0.36952f
C3269 a_4187_2434# a_13123_4687# 0.06627f
C3270 a_14513_7532# a_14643_7532# 0.70845f
C3271 a_22590_6734# a_24008_6734# 0.38994f
C3272 a_1256_3889# a_2873_4240# 0.28892f
C3273 a_19637_4687# a_19203_4687# 0.69698f
C3274 a_7477_1842# a_7945_1044# 0.19203f
C3275 a_27997_1842# a_27563_1842# 0.69646f
C3276 a_17865_3364# VDD 0.29444f
C3277 a_7364_1008# VDD 0.28758f
C3278 a_19550_3889# a_21917_4687# 0.02479f
C3279 VDD a_20593_14024# 0.49593f
C3280 VDD a_18551_8160# 0.01806f
C3281 VDD a_12037_4687# 0.85996f
C3282 a_4187_2434# a_25913_16869# 0.11222f
C3283 a_4187_2434# a_4003_14024# 0.05992f
C3284 a_15077_16869# a_14643_16869# 0.6972f
C3285 a_22590_16071# a_23431_16035# 0.28268f
C3286 a_8563_14024# a_8671_14652# 0.01697f
C3287 a_4187_2434# a_16793_7532# 0.11284f
C3288 a_23437_14024# a_24084_13190# 0.02312f
C3289 a_19073_14024# a_19203_14024# 0.70845f
C3290 a_5957_7532# a_5523_7532# 0.6972f
C3291 a_8237_7532# a_8231_6698# 0.02349f
C3292 a_8997_7532# a_7390_6734# 0.05231f
C3293 a_10430_6734# a_11924_6698# 0.28279f
C3294 a_10517_4687# a_10713_4687# 0.73897f
C3295 a_16108_5979# a_18313_4687# 0.02026f
C3296 a_11195_6734# a_11271_6698# 0.01194f
C3297 a_22488_3889# a_22590_3889# 0.37183f
C3298 a_7803_1842# a_7911_2470# 0.01697f
C3299 a_18877_1842# a_19073_1842# 0.76914f
C3300 a_23003_1842# a_22590_1044# 0.01012f
C3301 a_1256_289# a_1721_331# 0.13421f
C3302 a_1544_1044# a_1721_1395# 0.38063f
C3303 a_11924_3853# VDD 0.28225f
C3304 a_21157_1842# a_4187_2434# 0.04141f
C3305 VDD a_23763_16869# 0.49671f
C3306 VDD a_7288_13226# 0.17274f
C3307 VDD a_16108_15316# 1.62848f
C3308 VDD a_14643_7532# 0.49675f
C3309 VDD a_2297_4240# 0.46536f
C3310 VDD a_23431_6698# 0.28357f
C3311 CHAN1_MUX_SEL4 a_16108_12471# 0.1283f
C3312 CHAN1_MUX_OUT a_15964_12471# 0.01307f
C3313 a_8997_16869# a_7390_16071# 0.05231f
C3314 a_5957_16869# a_6153_16869# 0.77122f
C3315 a_4187_2434# a_8237_16869# 0.04141f
C3316 a_8237_16869# a_8231_16035# 0.02349f
C3317 a_10517_14024# a_10083_14024# 0.69698f
C3318 a_10430_16071# a_11848_16071# 0.38994f
C3319 a_20105_16071# a_20391_16035# 0.01885f
C3320 a_16108_15316# a_17683_14024# 0.01562f
C3321 a_13557_14024# a_13470_13226# 0.1088f
C3322 a_4350_13226# a_5705_12701# 0.02005f
C3323 a_15688_11557# a_15304_10295# 0.19136f
C3324 a_12849_11557# a_14851_10872# 0.13376f
C3325 a_13019_11521# a_15688_11093# 0.1287f
C3326 a_16510_13226# a_18004_13190# 0.28279f
C3327 a_17275_13226# a_17351_13190# 0.01194f
C3328 a_13121_11521# a_15108_11015# 0.05903f
C3329 a_22677_7532# a_23437_7532# 0.01669f
C3330 a_21917_7532# a_16108_5979# 0.0157f
C3331 a_14643_4687# a_14751_4687# 0.01163f
C3332 a_20723_4687# a_20831_5315# 0.01697f
C3333 a_4350_3889# a_6711_3853# 0.26208f
C3334 a_10985_3889# a_11271_3853# 0.01885f
C3335 a_21157_1842# a_21625_1044# 0.2079f
C3336 a_9757_1842# a_10517_1842# 0.06198f
C3337 a_12797_1842# a_13368_1044# 0.10864f
C3338 a_16108_3134# a_17357_1842# 0.01319f
C3339 a_16510_1044# a_16484_1008# 0.277f
C3340 a_1721_331# VDD 0.45373f
C3341 a_19073_1842# VDD 0.49655f
C3342 VDD a_6153_16869# 0.49285f
C3343 VDD a_11271_16035# 0.28357f
C3344 VDD a_10985_6734# 0.30409f
C3345 VDD a_27997_4687# 0.76528f
C3346 a_4187_2434# a_19963_14024# 0.06627f
C3347 a_13883_16869# a_13991_17497# 0.01697f
C3348 a_21917_16869# a_16108_15316# 0.0157f
C3349 a_5731_15316# a_16108_15316# 0.01334f
C3350 a_10985_13226# a_11195_13226# 0.09424f
C3351 a_4350_13226# a_6635_13226# 0.39036f
C3352 a_4187_2434# a_11473_4687# 0.11222f
C3353 a_9746_11495# a_9772_11533# 0.1657f
C3354 a_18117_7532# a_16510_6734# 0.05231f
C3355 a_17357_7532# a_17351_6698# 0.02349f
C3356 a_18313_4687# a_18877_4687# 0.0114f
C3357 a_26673_1842# a_27237_1842# 0.0114f
C3358 a_5731_3134# a_11785_3364# 0.28056f
C3359 a_5957_1842# a_6425_1044# 0.2079f
C3360 a_4350_1044# a_5115_1044# 0.39037f
C3361 a_5115_1044# VDD 0.15464f
C3362 a_19524_3853# a_19637_4687# 0.05157f
C3363 VDD a_18877_14024# 0.88247f
C3364 VDD a_1256_12471# 0.41762f
C3365 VDD a_12471_8160# 0.01806f
C3366 VDD a_9323_4687# 0.50001f
C3367 REF_MUX_SEL4 a_14825_6209# 0.03307f
C3368 a_13753_16869# a_14317_16869# 0.0114f
C3369 a_17357_16869# a_17351_16035# 0.02349f
C3370 a_4187_2434# a_24197_16869# 0.04152f
C3371 a_18117_16869# a_16510_16071# 0.05231f
C3372 a_4187_2434# a_15077_7532# 0.04237f
C3373 a_21835_16071# a_21911_16035# 0.01194f
C3374 a_7043_14024# a_7151_14652# 0.01697f
C3375 a_22677_14024# a_22590_13226# 0.1088f
C3376 a_4633_7532# a_5197_7532# 0.0114f
C3377 a_19550_13226# a_20905_12701# 0.02165f
C3378 a_6717_7532# a_7364_6698# 0.02011f
C3379 a_18585_6734# a_18795_6734# 0.09424f
C3380 a_16108_5979# a_16597_4687# 0.01319f
C3381 a_9193_4687# a_9323_4687# 0.70845f
C3382 a_20968_3889# a_21044_3853# 0.01176f
C3383 a_21917_1842# a_22488_1044# 0.10864f
C3384 a_17553_1842# a_17683_1842# 0.70845f
C3385 a_6283_1842# a_6391_2470# 0.01697f
C3386 a_24631_2470# VDD 0.01806f
C3387 a_14825_519# CHAN3_MUX_SEL4 0.03307f
C3388 a_18443_1842# a_4187_2434# 0.06627f
C3389 a_22590_3889# a_24665_3889# 0.03208f
C3390 VDD a_22113_16869# 0.49426f
C3391 VDD a_4350_13226# 0.87638f
C3392 VDD a_12993_7532# 0.49426f
C3393 VDD a_20968_6734# 0.17499f
C3394 DLL_RESETN a_5731_12471# 0.02461f
C3395 REF_MUX_SEL4 a_10430_6734# 0.24983f
C3396 a_4633_16869# a_4763_16869# 0.70845f
C3397 a_4187_2434# a_5523_16869# 0.06627f
C3398 a_6717_16869# a_7364_16035# 0.02011f
C3399 a_16108_15316# a_16033_14024# 0.01197f
C3400 a_9193_14024# a_9757_14024# 0.0114f
C3401 a_4187_2434# a_27433_4687# 0.11222f
C3402 a_12849_11557# a_13566_11018# 0.26617f
C3403 a_14111_11568# a_14851_11918# 0.26905f
C3404 a_21917_7532# a_21483_7532# 0.6972f
C3405 a_26477_7532# a_26471_6698# 0.02349f
C3406 a_27237_7532# a_25630_6734# 0.05253f
C3407 a_13123_4687# a_13231_4687# 0.01163f
C3408 a_26477_4687# a_26673_4687# 0.76914f
C3409 a_19203_4687# a_19311_5315# 0.01697f
C3410 a_4248_3889# a_4350_3889# 0.37183f
C3411 a_8997_1842# a_8563_1842# 0.6972f
C3412 a_12797_1842# a_10430_1044# 0.02479f
C3413 a_17357_1842# VDD 0.87038f
C3414 a_26395_1044# VDD 0.15465f
C3415 a_10430_1044# CHAN3_MUX_SEL4 0.24983f
C3416 REF_MUX_OUT CHAN2_DELAY_IN 0.05155f
C3417 VDD a_8808_16071# 0.17499f
C3418 VDD a_4437_16869# 0.87051f
C3419 VDD a_23111_14652# 0.01806f
C3420 VDD a_25283_4687# 0.50004f
C3421 a_27237_16869# a_25630_16071# 0.05253f
C3422 a_26477_16869# a_26471_16035# 0.02349f
C3423 a_12363_16869# a_12471_17497# 0.01697f
C3424 a_4187_2434# a_18313_14024# 0.11222f
C3425 a_21917_16869# a_22113_16869# 0.76914f
C3426 a_26477_14024# a_26043_14024# 0.6972f
C3427 a_4187_2434# a_9757_4687# 0.0414f
C3428 a_6126_9506# a_6854_11144# 0.22705f
C3429 a_12797_7532# a_12993_7532# 0.76914f
C3430 a_5731_12471# a_12355_11557# 0.01498f
C3431 a_15837_7532# a_16484_6698# 0.02011f
C3432 a_19550_6734# a_21835_6734# 0.39036f
C3433 a_17357_4687# a_18117_4687# 0.03319f
C3434 a_9465_1044# a_7390_1044# 0.03208f
C3435 a_4437_1842# a_4157_1313# 0.01771f
C3436 a_25717_1842# a_26477_1842# 0.01669f
C3437 a_23145_1044# VDD 0.30514f
C3438 VDD a_16163_14024# 0.49822f
C3439 VDD a_25630_13226# 0.89531f
C3440 VDD a_6391_8160# 0.01806f
C3441 VDD a_7673_4687# 0.49553f
C3442 CHAN0_MUX_SEL4 a_9757_16869# 0.01829f
C3443 DLL_RESETN a_13106_11047# 0.01263f
C3444 a_12797_16869# a_13557_16869# 0.06198f
C3445 a_4187_2434# a_21483_16869# 0.06627f
C3446 a_15837_16869# a_16484_16035# 0.02011f
C3447 a_19550_16071# a_21044_16035# 0.28279f
C3448 a_17357_14024# a_17553_14024# 0.76914f
C3449 a_20315_16071# a_20391_16035# 0.01194f
C3450 a_4187_2434# a_12363_7532# 0.06627f
C3451 a_5523_14024# a_5631_14652# 0.01697f
C3452 a_25630_13226# a_27915_13226# 0.39036f
C3453 a_5957_7532# a_5844_6698# 0.02055f
C3454 a_7390_6734# a_9751_6698# 0.26208f
C3455 a_8237_4687# a_8563_4687# 0.01427f
C3456 a_12037_4687# a_10430_3889# 0.05231f
C3457 a_11277_4687# a_11271_3853# 0.02349f
C3458 a_19550_3889# a_19524_3853# 0.277f
C3459 a_21917_1842# a_19550_1044# 0.02479f
C3460 a_4763_1842# a_4871_2470# 0.01697f
C3461 a_16510_1044# a_16108_289# 0.56108f
C3462 a_25630_1044# a_26395_1044# 0.39037f
C3463 a_18551_2470# VDD 0.01806f
C3464 a_16793_1842# a_4187_2434# 0.11222f
C3465 a_11924_3853# a_10430_3889# 0.28279f
C3466 VDD a_20397_16869# 0.86919f
C3467 VDD a_3449_15358# 0.47499f
C3468 VDD a_20105_13226# 0.30411f
C3469 VDD a_18004_6698# 0.28225f
C3470 VDD a_11277_7532# 0.86919f
C3471 CHAN1_MUX_SEL4 a_3449_12513# 0.05166f
C3472 a_7390_16071# a_9675_16071# 0.39036f
C3473 a_5957_16869# a_5844_16035# 0.02055f
C3474 a_8237_14024# a_8997_14024# 0.03319f
C3475 a_13470_13226# a_15831_13190# 0.26208f
C3476 a_4187_2434# a_25717_4687# 0.0414f
C3477 a_26185_13226# a_26395_13226# 0.09424f
C3478 a_13592_11561# a_14111_11568# 0.34102f
C3479 a_13019_11521# a_15304_10295# 0.07025f
C3480 a_14009_11568# a_13880_11982# 0.01562f
C3481 a_6326_10280# a_9712_9602# 0.04741f
C3482 a_20593_7532# a_21157_7532# 0.0114f
C3483 a_24957_7532# a_25604_6698# 0.02011f
C3484 a_5705_6209# a_5731_5979# 0.28954f
C3485 a_25153_4687# a_25283_4687# 0.70845f
C3486 a_11603_4687# a_11711_4687# 0.01163f
C3487 a_17683_4687# a_17791_5315# 0.01697f
C3488 a_7673_1842# a_8237_1842# 0.0114f
C3489 a_10517_1842# a_10404_1008# 0.05157f
C3490 a_13470_1044# a_14311_1008# 0.28268f
C3491 a_14643_1842# VDD 0.49684f
C3492 a_23431_1008# VDD 0.28439f
C3493 a_4763_1842# CHAN2_MUX_SEL4 0.01225f
C3494 a_16108_3134# a_21917_4687# 0.0157f
C3495 VDD a_5844_16035# 0.28225f
C3496 VDD a_13306_11995# 0.77663f
C3497 VDD a_17031_14652# 0.01806f
C3498 VDD a_1721_7085# 0.4533f
C3499 VDD a_23633_4687# 0.49593f
C3500 REF_DELAY_OUT_LAST a_6854_11676# 0.08491f
C3501 a_10843_16869# a_10951_17497# 0.01697f
C3502 a_20593_16869# a_20723_16869# 0.70845f
C3503 a_24957_16869# a_25604_16035# 0.02011f
C3504 a_4187_2434# a_16597_14024# 0.0414f
C3505 a_25153_14024# a_25717_14024# 0.0114f
C3506 a_4187_2434# a_7043_4687# 0.06627f
C3507 a_11473_7532# a_11603_7532# 0.70845f
C3508 a_15077_7532# a_14964_6698# 0.02055f
C3509 a_16597_4687# a_16163_4687# 0.69698f
C3510 a_24957_1842# a_24523_1842# 0.6972f
C3511 a_27991_3853# VDD 0.28273f
C3512 a_10985_1044# VDD 0.30514f
C3513 a_17351_3853# a_17357_4687# 0.02349f
C3514 a_16510_3889# a_18117_4687# 0.05231f
C3515 VDD a_27671_17497# 0.01806f
C3516 VDD a_14513_14024# 0.49593f
C3517 VDD a_22564_13190# 0.28633f
C3518 VDD a_27237_7532# 0.86022f
C3519 VDD a_5957_4687# 0.85996f
C3520 VDD a_11195_3889# 0.1539f
C3521 REF_CLK a_14111_11568# 0.02263f
C3522 REF_CLK a_4157_7003# 0.50643f
C3523 REF_MUX_SEL3 a_2297_6021# 0.01595f
C3524 REF_MUX_SEL2 a_2873_6021# 0.01422f
C3525 REF_MUX_SEL4 a_1721_6021# 0.05813f
C3526 REF_MUX_OUT a_1544_5979# 0.69943f
C3527 a_12037_16869# a_11603_16869# 0.6972f
C3528 a_4187_2434# a_19833_16869# 0.11222f
C3529 a_15077_16869# a_14964_16035# 0.02055f
C3530 a_16033_14024# a_16163_14024# 0.70845f
C3531 a_4003_14024# a_4111_14652# 0.01697f
C3532 a_4187_2434# a_10713_7532# 0.11222f
C3533 a_8997_7532# a_9465_6734# 0.2079f
C3534 a_5197_7532# a_4350_6734# 0.08038f
C3535 a_7288_6734# a_7390_6734# 0.37183f
C3536 a_14025_6734# a_14235_6734# 0.09424f
C3537 a_7477_4687# a_7673_4687# 0.73897f
C3538 a_9757_4687# a_10404_3853# 0.02011f
C3539 a_5731_5979# a_15077_4687# 0.01319f
C3540 a_15837_1842# a_16033_1842# 0.76914f
C3541 a_19637_1842# a_19524_1008# 0.05157f
C3542 a_12471_2470# VDD 0.01806f
C3543 a_2297_331# CHAN3_MUX_SEL3 0.01595f
C3544 a_1544_289# CHAN3_MUX_OUT 0.69943f
C3545 VDD CHAN1_MUX_SEL3 0.41251f
C3546 a_1721_331# CHAN3_MUX_SEL4 0.05813f
C3547 a_2873_331# CHAN3_MUX_SEL2 0.01422f
C3548 a_15077_1842# a_4187_2434# 0.04141f
C3549 a_18795_3889# a_18585_3889# 0.09424f
C3550 VDD a_17683_16869# 0.49671f
C3551 VDD a_27124_16035# 0.28225f
C3552 VDD a_7945_13226# 0.30411f
C3553 VDD a_8563_7532# 0.49671f
C3554 VDD a_15755_6734# 0.15389f
C3555 a_8997_16869# a_9465_16071# 0.2079f
C3556 a_5197_16869# a_4350_16071# 0.08038f
C3557 a_15545_16071# a_13470_16071# 0.03208f
C3558 a_7477_14024# a_7043_14024# 0.69698f
C3559 a_5731_15316# a_14513_14024# 0.01872f
C3560 a_12849_11557# a_12943_11557# 0.16706f
C3561 a_4187_2434# a_23003_4687# 0.06627f
C3562 a_13368_13226# a_13470_13226# 0.37183f
C3563 a_19637_7532# a_20397_7532# 0.01669f
C3564 a_24197_7532# a_24084_6698# 0.02055f
C3565 a_10083_4687# a_10191_4687# 0.01163f
C3566 a_16163_4687# a_16271_5315# 0.01697f
C3567 a_4905_3889# a_5115_3889# 0.09424f
C3568 a_6717_1842# a_7477_1842# 0.06198f
C3569 a_5731_3134# a_13123_1842# 0.01539f
C3570 a_24665_1044# a_22590_1044# 0.03208f
C3571 a_12715_1044# a_12791_1008# 0.01194f
C3572 a_12993_1842# VDD 0.49655f
C3573 a_20968_1044# VDD 0.17575f
C3574 a_16851_3154# CHAN2_MUX_OUT 0.45865f
C3575 a_25630_3889# a_27237_4687# 0.05253f
C3576 a_26471_3853# a_26477_4687# 0.02349f
C3577 VDD a_10951_14652# 0.01806f
C3578 VDD a_27705_16071# 0.29962f
C3579 VDD a_21917_4687# 0.88247f
C3580 CHAN0_MUX_SEL4 a_14825_15546# 0.03307f
C3581 REF_DELAY_OUT_LAST a_16108_12471# 0.01181f
C3582 a_9323_16869# a_9431_17497# 0.01697f
C3583 a_24197_16869# a_24084_16035# 0.02055f
C3584 a_4187_2434# a_13883_14024# 0.06627f
C3585 a_22590_16071# a_23945_15546# 0.02165f
C3586 a_4187_2434# a_26673_7532# 0.11284f
C3587 a_24197_14024# a_24957_14024# 0.02912f
C3588 a_24957_14024# a_16108_12471# 0.0157f
C3589 a_4187_2434# a_5393_4687# 0.11222f
C3590 a_16108_12471# a_20905_12701# 0.2906f
C3591 a_6425_13226# a_4350_13226# 0.03208f
C3592 a_22677_7532# a_23145_6734# 0.19203f
C3593 a_14317_7532# a_13470_6734# 0.08038f
C3594 a_15273_4687# a_15837_4687# 0.0114f
C3595 a_23633_1842# a_24197_1842# 0.0114f
C3596 a_22590_3889# a_16108_3134# 0.58202f
C3597 a_1256_3134# a_2873_3176# 0.27926f
C3598 a_1544_3134# a_2297_3176# 0.27303f
C3599 a_15964_289# a_16108_289# 0.42202f
C3600 a_25528_3889# VDD 0.17274f
C3601 a_16484_3853# a_15837_4687# 0.02011f
C3602 VDD a_21591_17497# 0.01806f
C3603 VDD a_12797_14024# 0.88193f
C3604 VDD a_20315_13226# 0.1539f
C3605 VDD a_24523_7532# 0.4973f
C3606 VDD a_23945_6209# 0.29292f
C3607 VDD a_8231_3853# 0.28357f
C3608 CHAN0_MUX_SEL4 a_10430_16071# 0.24983f
C3609 CHAN2_DELAY_IN a_3449_4240# 0.01058f
C3610 CHAN2_MUX_SEL1 a_2873_4240# 0.13092f
C3611 a_22677_16869# a_23145_16071# 0.19203f
C3612 a_4187_2434# a_18117_16869# 0.04152f
C3613 a_14317_16869# a_13470_16071# 0.08038f
C3614 a_10713_16869# a_11277_16869# 0.0114f
C3615 a_16510_16071# a_18871_16035# 0.26208f
C3616 a_4187_2434# a_8997_7532# 0.04152f
C3617 a_13470_13226# a_14825_12701# 0.02058f
C3618 a_9444_10280# a_5778_9057# 0.19787f
C3619 a_14851_10872# a_15464_9374# 0.04797f
C3620 a_27433_7532# a_27563_7532# 0.70845f
C3621 a_5731_5979# a_12363_4687# 0.01542f
C3622 a_5768_6734# a_5844_6698# 0.01176f
C3623 a_6153_4687# a_6283_4687# 0.70845f
C3624 a_8997_4687# a_8884_3853# 0.02055f
C3625 a_16510_3889# a_17351_3853# 0.28268f
C3626 a_16108_3134# a_27237_1842# 0.01319f
C3627 a_14513_1842# a_14643_1842# 0.70845f
C3628 a_22590_1044# a_24008_1044# 0.38994f
C3629 a_6391_2470# VDD 0.01806f
C3630 VDD CHAN0_MUX_SEL3 0.41814f
C3631 a_12363_1842# a_4187_2434# 0.06627f
C3632 VDD a_16033_16869# 0.49413f
C3633 VDD a_24875_16071# 0.15406f
C3634 VDD a_2873_13577# 0.46517f
C3635 VDD a_6913_7532# 0.49426f
C3636 VDD a_12791_6698# 0.2822f
C3637 a_27997_16869# a_27563_16869# 0.69646f
C3638 a_5731_15316# a_12797_14024# 0.01307f
C3639 a_6153_14024# a_6717_14024# 0.0114f
C3640 a_9323_14024# a_7390_13226# 0.01012f
C3641 a_15077_14024# a_15545_13226# 0.2079f
C3642 a_4187_2434# a_21353_4687# 0.11222f
C3643 a_13121_11521# a_13306_11995# 0.01008f
C3644 a_13019_11521# a_13045_11905# 0.01249f
C3645 a_11848_13226# a_11924_13190# 0.01176f
C3646 a_21625_13226# a_21911_13190# 0.01885f
C3647 a_1256_6734# a_1721_7085# 0.13421f
C3648 a_23437_7532# a_22590_6734# 0.08038f
C3649 a_18877_7532# a_18443_7532# 0.6972f
C3650 a_1256_5979# a_1544_5979# 1.25711f
C3651 a_14643_4687# a_14751_5315# 0.01697f
C3652 a_23437_4687# a_23633_4687# 0.76914f
C3653 a_8563_4687# a_8671_4687# 0.01163f
C3654 a_8237_1842# a_8231_1008# 0.02349f
C3655 a_5731_3134# a_11473_1842# 0.01872f
C3656 a_8997_1842# a_7390_1044# 0.05231f
C3657 a_5957_1842# a_5523_1842# 0.6972f
C3658 a_10430_1044# a_11924_1008# 0.28279f
C3659 a_11195_1044# a_11271_1008# 0.01194f
C3660 a_11277_1842# VDD 0.87208f
C3661 a_18004_1008# VDD 0.28328f
C3662 CHAN1_MUX_OUT REF_CLK 0.07706f
C3663 VDD CHAN3_DELAY_IN 1.36805f
C3664 a_25604_3853# a_24957_4687# 0.02011f
C3665 VDD a_4871_14652# 0.01806f
C3666 VDD a_15545_16071# 0.29962f
C3667 VDD a_10232_11561# 0.07564f
C3668 VDD a_19203_4687# 0.50004f
C3669 a_23437_16869# a_22590_16071# 0.08038f
C3670 a_1256_16071# a_1544_16071# 1.26509f
C3671 a_4187_2434# a_12233_14024# 0.11222f
C3672 a_18877_16869# a_19073_16869# 0.76914f
C3673 a_7803_16869# a_7911_17497# 0.01697f
C3674 a_23437_14024# a_23003_14024# 0.6972f
C3675 a_4187_2434# a_24957_7532# 0.04176f
C3676 a_9757_7532# a_9953_7532# 0.76914f
C3677 a_12797_7532# a_12791_6698# 0.02354f
C3678 a_16408_6734# a_16484_6698# 0.01176f
C3679 a_16108_5979# a_26477_4687# 0.01319f
C3680 a_14317_4687# a_15077_4687# 0.03319f
C3681 a_22677_1842# a_23437_1842# 0.01669f
C3682 a_21917_1842# a_16108_289# 0.0157f
C3683 a_22590_3889# VDD 0.89557f
C3684 a_1721_1395# VDD 0.45726f
C3685 a_14964_3853# a_15077_4687# 0.02055f
C3686 VDD a_15511_17497# 0.01806f
C3687 VDD a_17351_13190# 0.28565f
C3688 VDD a_10083_14024# 0.49994f
C3689 VDD a_22873_7532# 0.49294f
C3690 VDD a_11785_6209# 0.29292f
C3691 VDD a_5768_3889# 0.17499f
C3692 DLL_RESETN a_12355_11557# 0.04879f
C3693 CHAN2_MUX_SEL1 a_1256_3889# 1.44243f
C3694 CHAN2_MUX_SEL0 a_1544_3889# 0.07603f
C3695 a_4187_2434# a_15403_16869# 0.06627f
C3696 a_12797_16869# a_12791_16035# 0.02354f
C3697 a_9757_16869# a_10517_16869# 0.06198f
C3698 a_14317_14024# a_14513_14024# 0.76914f
C3699 a_16108_15316# a_25913_14024# 0.01865f
C3700 a_4187_2434# a_6283_7532# 0.06627f
C3701 a_16408_16071# a_16510_16071# 0.37183f
C3702 a_18443_14024# a_16510_13226# 0.01012f
C3703 a_14009_10774# a_13880_10808# 0.01562f
C3704 a_22488_13226# a_22564_13190# 0.01176f
C3705 a_26477_7532# a_26803_7532# 0.01427f
C3706 a_9465_6734# a_9751_6698# 0.01885f
C3707 a_4350_6734# a_4324_6698# 0.277f
C3708 a_5197_4687# a_5523_4687# 0.01427f
C3709 a_5731_5979# a_10713_4687# 0.01865f
C3710 a_10430_3889# a_11195_3889# 0.39037f
C3711 a_8237_4687# a_7390_3889# 0.08038f
C3712 a_13557_4687# a_14025_3889# 0.19203f
C3713 a_15755_3889# a_15831_3853# 0.01194f
C3714 a_16108_3134# a_24523_1842# 0.01542f
C3715 a_17357_1842# a_17351_1008# 0.02349f
C3716 a_18117_1842# a_16510_1044# 0.05231f
C3717 a_27237_1842# VDD 0.86108f
C3718 a_10713_1842# a_4187_2434# 0.11222f
C3719 a_14235_3889# a_14025_3889# 0.09424f
C3720 VDD a_14317_16869# 0.86919f
C3721 VDD a_21911_16035# 0.2822f
C3722 VDD a_1256_13226# 0.475f
C3723 VDD a_10328_6734# 0.17274f
C3724 VDD a_5197_7532# 0.86919f
C3725 VDD a_26151_5315# 0.01806f
C3726 CHAN2_MUX_OUT a_4187_2434# 1.38214f
C3727 a_26673_16869# a_27237_16869# 0.0114f
C3728 a_9465_16071# a_9675_16071# 0.09424f
C3729 a_4248_16071# a_4324_16035# 0.01176f
C3730 a_5731_15316# a_10083_14024# 0.01539f
C3731 a_5197_14024# a_5957_14024# 0.03319f
C3732 a_4187_2434# a_19637_4687# 0.0414f
C3733 a_10430_13226# a_10404_13190# 0.277f
C3734 a_20105_13226# a_19550_13226# 0.03209f
C3735 a_17553_7532# a_18117_7532# 0.0114f
C3736 a_21917_7532# a_21911_6698# 0.02354f
C3737 a_27048_6734# a_27124_6698# 0.01176f
C3738 a_22113_4687# a_22243_4687# 0.70845f
C3739 a_7043_4687# a_7151_4687# 0.01163f
C3740 a_13123_4687# a_13231_5315# 0.01697f
C3741 a_6717_1842# a_7364_1008# 0.02011f
C3742 a_4633_1842# a_5197_1842# 0.0114f
C3743 a_5731_3134# a_9757_1842# 0.01307f
C3744 a_18585_1044# a_18795_1044# 0.09424f
C3745 a_8563_1842# VDD 0.49684f
C3746 a_15755_1044# VDD 0.15464f
C3747 VDD CHAN2_DELAY_IN 1.34596f
C3748 a_24084_3853# a_24197_4687# 0.02055f
C3749 VDD a_4905_16071# 0.3017f
C3750 VDD a_6854_11144# 1.0388f
C3751 VDD a_26043_14024# 0.50058f
C3752 VDD a_17553_4687# 0.49593f
C3753 CHAN0_MUX_OUT a_1544_15316# 0.69943f
C3754 CHAN0_MUX_SEL3 a_2297_15358# 0.01595f
C3755 CHAN0_MUX_SEL4 a_1721_15358# 0.05813f
C3756 CHAN0_MUX_SEL2 a_2873_15358# 0.01422f
C3757 a_21917_16869# a_21911_16035# 0.02354f
C3758 a_17553_16869# a_17683_16869# 0.70845f
C3759 a_4187_2434# a_10517_14024# 0.0414f
C3760 a_6283_16869# a_6391_17497# 0.01697f
C3761 a_4187_2434# a_22243_7532# 0.06661f
C3762 a_22113_14024# a_22677_14024# 0.0114f
C3763 a_27563_14024# a_25630_13226# 0.01024f
C3764 a_5731_12471# a_14825_12701# 0.28056f
C3765 a_8433_7532# a_8563_7532# 0.70845f
C3766 a_11277_7532# a_11924_6698# 0.02312f
C3767 a_13557_4687# a_13123_4687# 0.69698f
C3768 a_16108_5979# a_23763_4687# 0.01544f
C3769 a_27237_4687# a_27705_3889# 0.2079f
C3770 a_16510_3889# a_17865_3364# 0.02165f
C3771 a_25630_3889# a_27048_3889# 0.38994f
C3772 a_26477_1842# a_26471_1008# 0.02349f
C3773 a_21917_1842# a_21483_1842# 0.6972f
C3774 a_27237_1842# a_25630_1044# 0.05253f
C3775 a_19524_3853# VDD 0.28633f
C3776 a_26673_1842# a_4187_2434# 0.11222f
C3777 a_13470_3889# a_14317_4687# 0.08038f
C3778 VDD a_9431_17497# 0.01806f
C3779 VDD a_8433_14024# 0.49593f
C3780 VDD a_14888_13226# 0.17499f
C3781 VDD a_21157_7532# 0.85889f
C3782 VDD a_26185_3889# 0.30411f
C3783 a_8997_16869# a_8563_16869# 0.6972f
C3784 a_4187_2434# a_13753_16869# 0.11222f
C3785 a_14888_16071# a_14964_16035# 0.01176f
C3786 a_11277_16869# a_11924_16035# 0.02312f
C3787 a_16108_15316# a_24197_14024# 0.01319f
C3788 a_4187_2434# a_4633_7532# 0.11222f
C3789 a_12993_14024# a_13123_14024# 0.70845f
C3790 a_10430_13226# a_5731_12471# 0.41176f
C3791 a_14009_10774# a_14111_10917# 0.47622f
C3792 a_25717_7532# a_25913_7532# 0.73897f
C3793 a_7945_6734# a_7390_6734# 0.03209f
C3794 a_5731_5979# a_8997_4687# 0.01319f
C3795 a_6717_4687# a_6711_3853# 0.02354f
C3796 a_4437_4687# a_4633_4687# 0.73897f
C3797 a_14235_3889# a_14311_3853# 0.01194f
C3798 a_13470_3889# a_14964_3853# 0.28279f
C3799 a_12797_1842# a_12993_1842# 0.76914f
C3800 a_16108_3134# a_22873_1842# 0.01865f
C3801 a_15837_1842# a_16484_1008# 0.02011f
C3802 a_19550_1044# a_21835_1044# 0.39036f
C3803 a_24523_1842# VDD 0.50001f
C3804 a_23945_519# VDD 0.29315f
C3805 a_8997_1842# a_4187_2434# 0.04141f
C3806 VDD a_11603_16869# 0.49671f
C3807 VDD a_19448_16071# 0.17274f
C3808 VDD a_7390_6734# 0.8686f
C3809 VDD a_20071_5315# 0.01806f
C3810 REF_MUX_OUT a_4187_2434# 1.38214f
C3811 a_25717_16869# a_26477_16869# 0.01669f
C3812 a_4187_2434# a_26477_14024# 0.04144f
C3813 a_4187_2434# a_6126_9506# 0.01821f
C3814 a_5731_15316# a_8433_14024# 0.01872f
C3815 a_4437_14024# a_4003_14024# 0.69698f
C3816 a_4187_2434# a_16923_4687# 0.06627f
C3817 a_17065_13226# a_17351_13190# 0.01885f
C3818 a_16597_7532# a_17357_7532# 0.01669f
C3819 a_11491_11918# a_11397_11918# 0.28931f
C3820 a_20397_7532# a_21044_6698# 0.02312f
C3821 a_25630_6734# a_25604_6698# 0.277f
C3822 a_16510_6734# a_15964_5979# 0.05416f
C3823 a_5523_4687# a_5631_4687# 0.01163f
C3824 a_11603_4687# a_11711_5315# 0.01697f
C3825 a_5731_3134# a_7043_1842# 0.01539f
C3826 a_5957_1842# a_5844_1008# 0.02055f
C3827 a_7390_1044# a_9751_1008# 0.26208f
C3828 a_6913_1842# VDD 0.49655f
C3829 a_12791_1008# VDD 0.2841f
C3830 a_3449_3176# CHAN2_DELAY_IN 0.01017f
C3831 a_1256_3134# CHAN2_MUX_SEL3 1.41161f
C3832 a_1544_3134# CHAN2_MUX_SEL2 0.07405f
C3833 a_22590_3889# a_23437_4687# 0.08038f
C3834 VDD a_2297_16422# 0.46536f
C3835 VDD a_24393_14024# 0.4946f
C3836 VDD a_17865_12701# 0.29444f
C3837 VDD a_15837_4687# 0.87964f
C3838 CHAN1_DELAY_IN a_3449_13577# 0.01058f
C3839 CHAN1_MUX_SEL1 a_2873_13577# 0.13092f
C3840 a_4763_16869# a_4871_17497# 0.01697f
C3841 a_20397_16869# a_21044_16035# 0.02312f
C3842 a_4187_2434# a_7803_14024# 0.06627f
C3843 a_4187_2434# a_20593_7532# 0.11287f
C3844 a_21157_14024# a_21917_14024# 0.02912f
C3845 a_25528_16071# a_25604_16035# 0.01176f
C3846 a_18877_14024# a_16108_12471# 0.0157f
C3847 a_24665_6734# a_24951_6698# 0.01885f
C3848 a_13470_6734# a_14235_6734# 0.39037f
C3849 a_10517_7532# a_10430_6734# 0.1088f
C3850 a_16108_5979# a_22113_4687# 0.01872f
C3851 a_12233_4687# a_12797_4687# 0.0114f
C3852 a_20593_1842# a_21157_1842# 0.0114f
C3853 a_24957_1842# a_25604_1008# 0.02011f
C3854 a_5705_519# a_5731_289# 0.28954f
C3855 a_17275_3889# VDD 0.15389f
C3856 a_24957_1842# a_4187_2434# 0.0414f
C3857 a_12791_3853# a_12797_4687# 0.02354f
C3858 VDD a_6717_14024# 0.88148f
C3859 VDD a_27563_16869# 0.49811f
C3860 VDD a_11924_13190# 0.28225f
C3861 VDD a_18443_7532# 0.4973f
C3862 VDD a_1544_5979# 0.39372f
C3863 VDD a_14025_3889# 0.30411f
C3864 a_7673_16869# a_8237_16869# 0.0114f
C3865 a_4187_2434# a_12037_16869# 0.04152f
C3866 a_24665_16071# a_24875_16071# 0.09424f
C3867 a_10517_16869# a_10430_16071# 0.1088f
C3868 a_13470_16071# a_13444_16035# 0.277f
C3869 a_16108_15316# a_21483_14024# 0.01542f
C3870 a_19550_13226# a_20315_13226# 0.39037f
C3871 a_7390_13226# a_8745_12701# 0.01756f
C3872 a_24393_7532# a_24523_7532# 0.70845f
C3873 a_5731_5979# a_6283_4687# 0.01542f
C3874 a_5197_4687# a_5844_3853# 0.02312f
C3875 a_7390_3889# a_8808_3889# 0.38994f
C3876 a_11473_1842# a_11603_1842# 0.70845f
C3877 a_16108_3134# a_21157_1842# 0.01319f
C3878 a_15077_1842# a_14964_1008# 0.02055f
C3879 a_22873_1842# VDD 0.49553f
C3880 a_11785_519# VDD 0.29315f
C3881 CHAN3_MUX_SEL0 CHAN3_MUX_SEL2 0.01204f
C3882 CHAN3_DELAY_IN CHAN3_MUX_SEL4 0.0663f
C3883 a_6283_1842# a_4187_2434# 0.06627f
C3884 VDD a_9953_16869# 0.49426f
C3885 VDD a_16510_16071# 0.8795f
C3886 VDD a_14851_10872# 0.26676f
C3887 VDD a_4324_6698# 0.28687f
C3888 VDD a_13991_5315# 0.01806f
C3889 REF_MUX_SEL1 a_2297_7085# 0.01995f
C3890 REF_MUX_OUT a_1544_6734# 0.04258f
C3891 a_24957_16869# a_24523_16869# 0.6972f
C3892 a_4187_2434# a_23763_14024# 0.06627f
C3893 a_4905_16071# a_5191_16035# 0.01885f
C3894 a_5197_14024# a_5768_13226# 0.10863f
C3895 a_5731_15316# a_6717_14024# 0.01307f
C3896 a_16108_15316# a_26985_15546# 0.2906f
C3897 a_4187_2434# a_15273_4687# 0.11222f
C3898 a_10232_11561# a_11491_11918# 0.01529f
C3899 a_7390_13226# a_8231_13190# 0.28268f
C3900 a_15837_7532# a_15403_7532# 0.6972f
C3901 a_19637_7532# a_19550_6734# 0.1088f
C3902 a_20397_4687# a_20593_4687# 0.76914f
C3903 a_10083_4687# a_10191_5315# 0.01697f
C3904 a_4003_4687# a_4111_4687# 0.01163f
C3905 a_16108_3134# a_16851_3154# 0.06181f
C3906 a_5197_1842# a_4350_1044# 0.08038f
C3907 a_7288_1044# a_7390_1044# 0.37183f
C3908 a_14025_1044# a_14235_1044# 0.09424f
C3909 a_8997_1842# a_9465_1044# 0.2079f
C3910 a_5197_1842# VDD 0.8708f
C3911 a_10328_1044# VDD 0.17444f
C3912 a_2297_1395# CHAN3_MUX_SEL1 0.01995f
C3913 a_21911_3853# a_21917_4687# 0.02354f
C3914 VDD a_22677_14024# 0.87095f
C3915 VDD a_23871_8160# 0.01806f
C3916 VDD a_13123_4687# 0.49994f
C3917 CHAN1_MUX_SEL1 a_1256_13226# 1.44243f
C3918 DLL_RESETN a_9712_9602# 0.4243f
C3919 CHAN1_MUX_SEL0 a_1544_13226# 0.07603f
C3920 a_4187_2434# a_27997_16869# 0.04001f
C3921 a_15837_16869# a_16033_16869# 0.76914f
C3922 a_19637_16869# a_19550_16071# 0.1088f
C3923 a_4187_2434# a_6153_14024# 0.11222f
C3924 a_20397_14024# a_19963_14024# 0.6972f
C3925 a_4187_2434# a_18877_7532# 0.04176f
C3926 a_25630_13226# a_16108_12471# 0.55833f
C3927 a_6717_7532# a_6913_7532# 0.76914f
C3928 a_23145_6734# a_22590_6734# 0.03209f
C3929 a_16108_5979# a_20397_4687# 0.01319f
C3930 a_11277_4687# a_12037_4687# 0.03319f
C3931 a_19637_1842# a_20397_1842# 0.01669f
C3932 a_22590_3889# a_24875_3889# 0.39036f
C3933 a_24197_1842# a_24084_1008# 0.02055f
C3934 a_14311_3853# VDD 0.28357f
C3935 REF_CLK REF_MUX_SEL0 0.14089f
C3936 a_22243_1842# a_4187_2434# 0.06627f
C3937 a_11924_3853# a_11277_4687# 0.02312f
C3938 VDD a_25913_16869# 0.49294f
C3939 VDD a_4003_14024# 0.61691f
C3940 VDD a_16793_7532# 0.49277f
C3941 VDD a_9675_13226# 0.15407f
C3942 VDD a_4157_4158# 0.48942f
C3943 VDD a_25604_6698# 0.28633f
C3944 CHAN1_MUX_OUT a_6326_10280# 0.06947f
C3945 a_6717_16869# a_7477_16869# 0.06198f
C3946 a_4187_2434# a_9323_16869# 0.06627f
C3947 a_16108_15316# a_19833_14024# 0.01865f
C3948 a_11277_14024# a_11473_14024# 0.76914f
C3949 a_14317_14024# a_14888_13226# 0.10863f
C3950 a_23437_7532# a_23763_7532# 0.01427f
C3951 a_15765_6153# a_16108_5979# 0.42004f
C3952 a_4437_4687# a_4350_3889# 0.1088f
C3953 a_16108_3134# a_18443_1842# 0.01542f
C3954 a_22677_1842# a_23145_1044# 0.19203f
C3955 a_14317_1842# a_13470_1044# 0.08038f
C3956 a_21157_1842# VDD 0.85988f
C3957 CHAN2_MUX_SEL2 CHAN3_MUX_SEL0 0.01667f
C3958 CHAN2_MUX_SEL4 CHAN3_DELAY_IN 0.01332f
C3959 a_4633_1842# a_4187_2434# 0.11222f
C3960 VDD a_8237_16869# 0.86919f
C3961 VDD a_13444_16035# 0.28633f
C3962 VDD a_13566_11018# 0.0947f
C3963 VDD a_21625_6734# 0.29722f
C3964 VDD a_7911_5315# 0.01806f
C3965 REF_DELAY_OUT_LAST a_13019_11521# 0.08017f
C3966 a_23633_16869# a_24197_16869# 0.0114f
C3967 a_15765_15490# a_15964_15316# 0.061f
C3968 a_4187_2434# a_22113_14024# 0.11222f
C3969 a_9946_11995# a_10649_11568# 0.02432f
C3970 a_6635_13226# a_6711_13190# 0.01194f
C3971 a_4187_2434# a_13557_4687# 0.0414f
C3972 a_14513_7532# a_15077_7532# 0.0114f
C3973 a_22590_6734# a_23431_6698# 0.28268f
C3974 a_8563_4687# a_8671_5315# 0.01697f
C3975 a_19073_4687# a_19203_4687# 0.70845f
C3976 a_27433_1842# a_27563_1842# 0.70845f
C3977 a_5768_1044# a_5844_1008# 0.01176f
C3978 a_7390_1044# VDD 1.06734f
C3979 a_16851_3154# VDD 0.52304f
C3980 a_21044_3853# a_20397_4687# 0.02312f
C3981 VDD a_19963_14024# 0.50058f
C3982 VDD a_17791_8160# 0.01806f
C3983 VDD a_11473_4687# 0.49593f
C3984 a_4187_2434# a_25283_16869# 0.06627f
C3985 a_14513_16869# a_14643_16869# 0.70845f
C3986 a_4187_2434# a_4437_14024# 0.0414f
C3987 a_22590_16071# a_23355_16071# 0.39037f
C3988 a_1544_13226# a_2297_13577# 0.28651f
C3989 a_23437_14024# a_24008_13226# 0.10863f
C3990 a_4187_2434# a_16163_7532# 0.06661f
C3991 a_19073_14024# a_19637_14024# 0.0114f
C3992 a_4187_2434# a_25630_6734# 0.02227f
C3993 a_5393_7532# a_5523_7532# 0.70845f
C3994 a_10517_4687# a_10083_4687# 0.69698f
C3995 a_20105_6734# a_20391_6698# 0.01885f
C3996 a_10430_6734# a_11848_6734# 0.38994f
C3997 a_16108_5979# a_17683_4687# 0.01562f
C3998 a_18877_1842# a_18443_1842# 0.6972f
C3999 a_1256_1044# a_1721_1395# 0.13421f
C4000 a_1256_289# a_1544_289# 1.25711f
C4001 a_23437_1842# a_22590_1044# 0.08038f
C4002 a_20593_1842# a_4187_2434# 0.11222f
C4003 a_24951_3853# a_24665_3889# 0.01885f
C4004 VDD a_24197_16869# 0.85889f
C4005 VDD a_15964_15316# 0.31771f
C4006 VDD a_6711_13190# 0.2822f
C4007 VDD a_15077_7532# 0.86018f
C4008 VDD a_23355_6734# 0.15389f
C4009 CHAN1_MUX_SEL4 a_15964_12471# 0.5544f
C4010 a_4187_2434# a_7673_16869# 0.11222f
C4011 a_5957_16869# a_5523_16869# 0.6972f
C4012 a_9953_14024# a_10083_14024# 0.70845f
C4013 a_10430_16071# a_11271_16035# 0.28268f
C4014 a_20105_16071# a_20315_16071# 0.09424f
C4015 a_16108_15316# a_18117_14024# 0.01644f
C4016 a_16510_13226# a_17928_13226# 0.38994f
C4017 a_14851_11918# a_15304_10295# 0.12139f
C4018 a_13121_11521# a_14851_10872# 0.03337f
C4019 a_22677_7532# a_22873_7532# 0.73897f
C4020 a_5731_5979# a_16108_5979# 0.01334f
C4021 a_10985_3889# a_11195_3889# 0.09424f
C4022 a_4350_3889# a_6635_3889# 0.39036f
C4023 a_9757_1842# a_9953_1842# 0.76914f
C4024 a_16108_3134# a_16793_1842# 0.01843f
C4025 a_12797_1842# a_12791_1008# 0.02354f
C4026 a_16408_1044# a_16484_1008# 0.01176f
C4027 a_1544_289# VDD 0.39181f
C4028 a_18443_1842# VDD 0.50001f
C4029 CHAN2_DELAY_IN CHAN2_MUX_SEL4 0.0663f
C4030 CHAN2_MUX_SEL0 CHAN2_MUX_SEL2 0.01204f
C4031 a_16108_3134# a_4187_2434# 0.24917f
C4032 VDD a_5523_16869# 0.49671f
C4033 VDD a_11195_16071# 0.15389f
C4034 VDD a_9465_6734# 0.29722f
C4035 VDD a_27433_4687# 0.4946f
C4036 a_22677_16869# a_23437_16869# 0.01669f
C4037 a_4187_2434# a_20397_14024# 0.0414f
C4038 a_5731_15316# a_15964_15316# 0.2778f
C4039 a_27237_14024# a_27433_14024# 0.77122f
C4040 a_4350_13226# a_5844_13190# 0.28279f
C4041 a_4187_2434# a_10843_4687# 0.06627f
C4042 a_5115_13226# a_5191_13190# 0.01194f
C4043 a_12505_13226# a_10430_13226# 0.03208f
C4044 a_13557_7532# a_14317_7532# 0.01669f
C4045 a_7043_4687# a_7151_5315# 0.01697f
C4046 a_21835_6734# a_21911_6698# 0.01194f
C4047 a_26477_1842# a_26803_1842# 0.01427f
C4048 a_4350_1044# a_4324_1008# 0.277f
C4049 a_9465_1044# a_9751_1008# 0.01885f
C4050 a_4324_1008# VDD 0.28723f
C4051 a_19550_3889# a_19637_4687# 0.1088f
C4052 VDD a_27991_13190# 0.28201f
C4053 VDD a_18313_14024# 0.4946f
C4054 VDD a_11711_8160# 0.01806f
C4055 VDD a_9757_4687# 0.88193f
C4056 REF_CLK a_13592_11113# 0.03445f
C4057 REF_MUX_SEL4 a_11785_6209# 0.03255f
C4058 a_4187_2434# a_23633_16869# 0.11222f
C4059 a_4187_2434# a_14513_7532# 0.12091f
C4060 a_18117_14024# a_18877_14024# 0.02912f
C4061 a_27915_13226# a_27991_13190# 0.01194f
C4062 a_9193_4687# a_9757_4687# 0.0114f
C4063 a_16108_5979# a_16033_4687# 0.01197f
C4064 a_21917_1842# a_21911_1008# 0.02354f
C4065 a_17553_1842# a_18117_1842# 0.0114f
C4066 a_27048_1044# a_27124_1008# 0.01176f
C4067 a_23871_2470# VDD 0.01806f
C4068 a_11785_519# CHAN3_MUX_SEL4 0.03255f
C4069 a_18877_1842# a_4187_2434# 0.0414f
C4070 a_22590_3889# a_23145_3889# 0.03209f
C4071 VDD a_21483_16869# 0.4973f
C4072 VDD a_4248_13226# 0.17587f
C4073 VDD a_8745_15546# 0.29292f
C4074 VDD a_12363_7532# 0.4973f
C4075 VDD a_20391_6698# 0.28357f
C4076 CHAN0_MUX_OUT a_1544_16071# 0.04258f
C4077 CHAN0_MUX_SEL1 a_2297_16422# 0.01995f
C4078 CHAN1_MUX_OUT a_5731_12471# 1.04829f
C4079 CHAN1_MUX_SEL4 a_8745_12701# 0.04472f
C4080 a_4187_2434# a_5957_16869# 0.04152f
C4081 a_4633_16869# a_5197_16869# 0.0114f
C4082 a_9675_16071# a_9751_16035# 0.01194f
C4083 a_4187_2434# a_26803_4687# 0.06627f
C4084 a_12849_11557# a_13132_11110# 0.06758f
C4085 a_14111_11568# a_15108_11799# 0.03093f
C4086 a_21353_7532# a_21483_7532# 0.70845f
C4087 a_26477_4687# a_26043_4687# 0.6972f
C4088 a_11277_1842# a_11924_1008# 0.02312f
C4089 a_8433_1842# a_8563_1842# 0.70845f
C4090 a_16793_1842# VDD 0.49408f
C4091 a_25604_1008# VDD 0.28758f
C4092 REF_MUX_SEL2 CHAN2_MUX_SEL0 0.01667f
C4093 REF_MUX_SEL4 CHAN2_DELAY_IN 0.01332f
C4094 VDD a_4187_2434# 68.8381f
C4095 VDD a_8231_16035# 0.28357f
C4096 VDD a_12943_11557# 0.29488f
C4097 VDD a_22351_14652# 0.01806f
C4098 VDD a_25717_4687# 0.871f
C4099 a_4187_2434# a_17683_14024# 0.06627f
C4100 a_21917_16869# a_21483_16869# 0.6972f
C4101 a_5731_15316# a_8745_15546# 0.28635f
C4102 a_25913_14024# a_26043_14024# 0.70845f
C4103 a_4187_2434# a_9193_4687# 0.11222f
C4104 a_6854_11676# a_6854_11144# 0.30378f
C4105 a_12797_7532# a_12363_7532# 0.6972f
C4106 a_19550_6734# a_21044_6698# 0.28279f
C4107 a_20315_6734# a_20391_6698# 0.01194f
C4108 a_17357_4687# a_17553_4687# 0.76914f
C4109 a_5523_4687# a_5631_5315# 0.01697f
C4110 a_25717_1842# a_25913_1842# 0.73897f
C4111 a_7945_1044# a_7390_1044# 0.03209f
C4112 a_5705_3364# VDD 0.29556f
C4113 a_21625_1044# VDD 0.29845f
C4114 VDD a_16597_14024# 0.86961f
C4115 VDD a_25528_13226# 0.17274f
C4116 VDD a_7043_4687# 0.4999f
C4117 VDD a_5631_8160# 0.01806f
C4118 REF_CLK a_15304_10295# 0.01066f
C4119 a_4187_2434# a_21917_16869# 0.0414f
C4120 a_12797_16869# a_12993_16869# 0.76914f
C4121 a_4187_2434# a_5731_15316# 0.17047f
C4122 a_19550_16071# a_20968_16071# 0.38994f
C4123 a_4187_2434# a_12797_7532# 0.0414f
C4124 a_17357_14024# a_16923_14024# 0.6972f
C4125 a_26395_13226# a_26471_13190# 0.01194f
C4126 a_25630_13226# a_27124_13190# 0.28279f
C4127 a_9444_9602# a_5864_9057# 0.02483f
C4128 a_10517_7532# a_10985_6734# 0.19203f
C4129 a_6283_7532# a_4350_6734# 0.01012f
C4130 a_7390_6734# a_9675_6734# 0.39036f
C4131 a_8237_4687# a_8997_4687# 0.03319f
C4132 a_19448_3889# a_19524_3853# 0.01176f
C4133 a_20397_1842# a_21044_1008# 0.02312f
C4134 a_16597_1842# a_17357_1842# 0.01669f
C4135 a_16510_1044# a_15964_289# 0.05416f
C4136 a_25630_1044# a_25604_1008# 0.277f
C4137 a_17791_2470# VDD 0.01806f
C4138 a_25630_1044# a_4187_2434# 0.01522f
C4139 a_16163_1842# a_4187_2434# 0.06627f
C4140 a_20391_3853# a_20105_3889# 0.01885f
C4141 VDD a_2873_15358# 0.46598f
C4142 VDD a_19833_16869# 0.49294f
C4143 VDD a_18585_13226# 0.29742f
C4144 VDD a_10713_7532# 0.49294f
C4145 VDD a_17928_6734# 0.17499f
C4146 CHAN1_MUX_SEL3 a_3449_12513# 0.28429f
C4147 CHAN1_MUX_OUT a_2297_12513# 0.01179f
C4148 CHAN1_MUX_SEL4 a_2873_12513# 0.04916f
C4149 REF_MUX_SEL4 a_7390_6734# 0.34655f
C4150 a_6283_16869# a_4350_16071# 0.01012f
C4151 a_10517_16869# a_10985_16071# 0.19203f
C4152 a_8155_16071# a_8231_16035# 0.01194f
C4153 a_15545_16071# a_15831_16035# 0.01885f
C4154 a_7390_16071# a_8884_16035# 0.28279f
C4155 a_8237_14024# a_8433_14024# 0.76914f
C4156 a_10843_14024# a_10430_13226# 0.01012f
C4157 a_4187_2434# a_25153_4687# 0.11222f
C4158 a_13470_13226# a_15755_13226# 0.39036f
C4159 a_27705_13226# a_25630_13226# 0.03208f
C4160 a_20397_7532# a_20723_7532# 0.01427f
C4161 a_5974_11413# a_5778_9057# 2.88221f
C4162 a_13592_11561# a_13880_11982# 0.43707f
C4163 a_25153_4687# a_25717_4687# 0.0114f
C4164 a_5731_3134# a_15273_1842# 0.01872f
C4165 a_10517_1842# a_10430_1044# 0.1088f
C4166 a_24665_1044# a_24951_1008# 0.01885f
C4167 a_13470_1044# a_14235_1044# 0.39037f
C4168 a_15077_1842# VDD 0.86102f
C4169 a_23355_1044# VDD 0.15465f
C4170 a_4003_1842# CHAN3_DELAY_IN 0.54998f
C4171 a_7390_1044# CHAN3_MUX_SEL4 0.34655f
C4172 REF_MUX_SEL0 REF_MUX_SEL2 0.01204f
C4173 VDD a_5768_16071# 0.17499f
C4174 VDD a_16271_14652# 0.01806f
C4175 VDD a_12849_11557# 2.58319f
C4176 VDD a_1544_6734# 0.45079f
C4177 VDD a_23003_4687# 0.50058f
C4178 a_20593_16869# a_21157_16869# 0.0114f
C4179 a_4187_2434# a_16033_14024# 0.11222f
C4180 a_24957_14024# a_25283_14024# 0.01427f
C4181 a_4187_2434# a_7477_4687# 0.0414f
C4182 a_6425_13226# a_6711_13190# 0.01885f
C4183 a_11473_7532# a_12037_7532# 0.0114f
C4184 a_24197_7532# a_24665_6734# 0.2079f
C4185 a_15403_7532# a_13470_6734# 0.01012f
C4186 a_16033_4687# a_16163_4687# 0.70845f
C4187 a_4003_4687# a_4111_5315# 0.01697f
C4188 a_24393_1842# a_24523_1842# 0.70845f
C4189 a_27915_3889# VDD 0.15389f
C4190 a_9465_1044# VDD 0.29845f
C4191 VDD a_13883_14024# 0.50058f
C4192 VDD a_26911_17497# 0.01806f
C4193 VDD a_22590_13226# 0.89557f
C4194 VDD a_26673_7532# 0.49417f
C4195 VDD a_5393_4687# 0.49643f
C4196 VDD a_10404_3853# 0.28633f
C4197 REF_CLK a_3449_7085# 0.01058f
C4198 REF_MUX_OUT a_1256_5979# 0.1134f
C4199 REF_MUX_SEL4 a_1544_5979# 0.47529f
C4200 REF_MUX_SEL2 a_2297_6021# 0.10655f
C4201 CHAN2_MUX_SEL4 a_4157_4158# 0.08229f
C4202 a_11473_16869# a_11603_16869# 0.70845f
C4203 a_4187_2434# a_19203_16869# 0.06627f
C4204 a_24197_16869# a_24665_16071# 0.2079f
C4205 a_15403_16869# a_13470_16071# 0.01012f
C4206 a_4187_2434# a_10083_7532# 0.06627f
C4207 a_16033_14024# a_16597_14024# 0.0114f
C4208 a_19963_14024# a_19550_13226# 0.01012f
C4209 a_5731_5979# a_14513_4687# 0.01872f
C4210 a_15545_6734# a_13470_6734# 0.03208f
C4211 a_7477_4687# a_7043_4687# 0.69698f
C4212 a_15837_1842# a_15403_1842# 0.6972f
C4213 a_19637_1842# a_19550_1044# 0.1088f
C4214 a_11711_2470# VDD 0.01806f
C4215 a_1544_289# CHAN3_MUX_SEL4 0.47529f
C4216 a_2297_331# CHAN3_MUX_SEL2 0.10655f
C4217 VDD CHAN1_MUX_SEL2 0.60238f
C4218 a_1256_289# CHAN3_MUX_OUT 0.1134f
C4219 a_14513_1842# a_4187_2434# 0.11222f
C4220 VDD a_18117_16869# 0.85889f
C4221 VDD a_27048_16071# 0.17499f
C4222 VDD a_8997_7532# 0.85889f
C4223 VDD a_14964_6698# 0.28225f
C4224 a_14025_16071# a_13470_16071# 0.03209f
C4225 a_16597_14024# a_17065_13226# 0.19203f
C4226 a_9757_14024# a_10328_13226# 0.10864f
C4227 a_6913_14024# a_7043_14024# 0.70845f
C4228 a_5731_15316# a_13883_14024# 0.01539f
C4229 a_6854_11144# a_9444_10280# 1.25013f
C4230 a_13121_11521# a_12943_11557# 0.09118f
C4231 a_4187_2434# a_23437_4687# 0.04141f
C4232 a_13306_11995# a_14009_11568# 0.02432f
C4233 a_19637_7532# a_19833_7532# 0.73897f
C4234 a_22590_6734# a_23945_6209# 0.02165f
C4235 a_24523_7532# a_22590_6734# 0.01012f
C4236 a_15837_7532# a_15964_5979# 0.02f
C4237 a_24197_4687# a_24957_4687# 0.02912f
C4238 a_6425_3889# a_4350_3889# 0.03208f
C4239 a_6717_1842# a_6913_1842# 0.76914f
C4240 a_5731_3134# a_13557_1842# 0.01314f
C4241 a_23145_1044# a_22590_1044# 0.03209f
C4242 a_12363_1842# VDD 0.50001f
C4243 a_20391_1008# VDD 0.28439f
C4244 a_16108_3134# CHAN2_MUX_OUT 0.24265f
C4245 VDD CHAN3_MUX_OUT 1.12112f
C4246 VDD a_10191_14652# 0.01806f
C4247 VDD a_26185_16071# 0.30409f
C4248 VDD a_12158_11557# 0.37941f
C4249 VDD a_21353_4687# 0.4946f
C4250 CHAN0_MUX_SEL4 a_11785_15546# 0.03255f
C4251 a_19637_16869# a_20397_16869# 0.01669f
C4252 a_1256_16071# a_2873_16422# 0.28892f
C4253 a_24523_16869# a_22590_16071# 0.01012f
C4254 a_4187_2434# a_14317_14024# 0.0414f
C4255 a_15837_16869# a_15964_15316# 0.02f
C4256 a_4905_13226# a_4350_13226# 0.03209f
C4257 a_4187_2434# a_4763_4687# 0.06627f
C4258 a_4187_2434# a_26043_7532# 0.06661f
C4259 a_24197_14024# a_24393_14024# 0.77122f
C4260 a_4157_13495# a_4324_13190# 0.02463f
C4261 a_16108_12471# a_17865_12701# 0.29564f
C4262 a_10517_7532# a_11277_7532# 0.01669f
C4263 a_16510_6734# a_18871_6698# 0.26208f
C4264 a_1544_3134# a_1721_3176# 0.36963f
C4265 a_23437_1842# a_23763_1842# 0.01427f
C4266 a_1256_3134# a_2297_3176# 0.04261f
C4267 a_15765_463# a_16108_289# 0.42004f
C4268 a_24951_3853# VDD 0.2822f
C4269 VDD a_20831_17497# 0.01806f
C4270 VDD a_12233_14024# 0.4946f
C4271 VDD a_24957_7532# 0.87825f
C4272 VDD a_19524_13190# 0.28633f
C4273 VDD a_20905_6209# 0.29292f
C4274 VDD a_8155_3889# 0.1539f
C4275 CHAN2_MUX_SEL0 a_2873_4240# 0.01504f
C4276 a_4187_2434# a_17553_16869# 0.11222f
C4277 a_16510_16071# a_18795_16071# 0.39036f
C4278 a_4187_2434# a_8433_7532# 0.11222f
C4279 a_15077_14024# a_15837_14024# 0.02912f
C4280 a_18877_14024# a_19448_13226# 0.10864f
C4281 a_14851_10872# a_14757_10872# 0.28931f
C4282 a_22590_13226# a_24951_13190# 0.26208f
C4283 a_27433_7532# a_27997_7532# 0.0114f
C4284 a_5731_5979# a_12797_4687# 0.01307f
C4285 a_6153_4687# a_6717_4687# 0.0114f
C4286 a_15077_4687# a_15545_3889# 0.2079f
C4287 a_9323_4687# a_7390_3889# 0.01012f
C4288 a_16510_3889# a_17275_3889# 0.39037f
C4289 a_16108_3134# a_26673_1842# 0.01872f
C4290 a_14513_1842# a_15077_1842# 0.0114f
C4291 a_22590_1044# a_23431_1008# 0.28268f
C4292 a_5631_2470# VDD 0.01806f
C4293 VDD CHAN0_MUX_SEL2 0.59889f
C4294 a_12797_1842# a_4187_2434# 0.0414f
C4295 VDD a_15403_16869# 0.4973f
C4296 VDD a_24084_16035# 0.28225f
C4297 VDD a_6283_7532# 0.4973f
C4298 VDD a_12715_6734# 0.15406f
C4299 a_27433_16869# a_27563_16869# 0.70845f
C4300 a_5731_15316# a_12233_14024# 0.01872f
C4301 a_4350_16071# a_6711_16035# 0.26208f
C4302 a_10985_16071# a_11271_16035# 0.01885f
C4303 a_9757_14024# a_7390_13226# 0.02479f
C4304 a_4187_2434# a_20723_4687# 0.06627f
C4305 a_21625_13226# a_21835_13226# 0.09424f
C4306 a_13121_11521# a_12849_11557# 0.55272f
C4307 a_18313_7532# a_18443_7532# 0.70845f
C4308 a_1256_6734# a_1544_6734# 1.26509f
C4309 a_23437_4687# a_23003_4687# 0.6972f
C4310 a_5731_3134# a_10843_1842# 0.01539f
C4311 a_5393_1842# a_5523_1842# 0.70845f
C4312 a_10430_1044# a_11848_1044# 0.38994f
C4313 a_20105_1044# a_20391_1008# 0.01885f
C4314 a_17928_1044# VDD 0.17575f
C4315 a_10713_1842# VDD 0.49553f
C4316 VDD CHAN2_MUX_OUT 0.72212f
C4317 CHAN1_MUX_OUT DLL_RESETN 0.0503f
C4318 VDD a_14025_16071# 0.30409f
C4319 VDD a_4111_14652# 0.01866f
C4320 VDD a_10206_11525# 0.09398f
C4321 VDD a_19637_4687# 0.871f
C4322 CHAN2_MUX_SEL4 a_9757_4687# 0.01829f
C4323 a_4187_2434# a_11603_14024# 0.06627f
C4324 a_18877_16869# a_18443_16869# 0.6972f
C4325 a_4187_2434# a_24393_7532# 0.11284f
C4326 a_22873_14024# a_23003_14024# 0.70845f
C4327 a_9757_7532# a_9323_7532# 0.6972f
C4328 a_26803_7532# a_26911_7532# 0.01163f
C4329 a_16408_6734# a_16510_6734# 0.37183f
C4330 a_16108_5979# a_25913_4687# 0.01865f
C4331 a_14317_4687# a_14513_4687# 0.76914f
C4332 a_19550_3889# a_16108_3134# 0.58202f
C4333 a_22677_1842# a_22873_1842# 0.73897f
C4334 a_5731_289# a_16108_289# 0.01334f
C4335 a_22488_3889# VDD 0.17274f
C4336 a_1544_1044# VDD 0.51173f
C4337 a_13470_3889# a_15403_4687# 0.01012f
C4338 VDD a_14751_17497# 0.01806f
C4339 VDD a_17275_13226# 0.15389f
C4340 VDD a_10517_14024# 0.87095f
C4341 VDD a_22243_7532# 0.49737f
C4342 VDD a_5191_3853# 0.28637f
C4343 CHAN0_MUX_SEL4 a_7390_16071# 0.34655f
C4344 CHAN1_MUX_OUT a_12355_11557# 0.05729f
C4345 CHAN2_MUX_SEL0 a_1256_3889# 0.3314f
C4346 a_9757_16869# a_9953_16869# 0.76914f
C4347 a_26803_16869# a_26911_16869# 0.01163f
C4348 a_4187_2434# a_15837_16869# 0.0414f
C4349 a_4187_2434# a_6717_7532# 0.0414f
C4350 a_14317_14024# a_13883_14024# 0.6972f
C4351 a_16108_15316# a_25283_14024# 0.01539f
C4352 a_18877_14024# a_16510_13226# 0.02479f
C4353 a_22488_13226# a_22590_13226# 0.37183f
C4354 a_13592_11113# a_13880_10808# 0.43707f
C4355 a_4248_6734# a_4324_6698# 0.01176f
C4356 a_9465_6734# a_9675_6734# 0.09424f
C4357 a_26477_7532# a_27237_7532# 0.03319f
C4358 a_5197_4687# a_5957_4687# 0.03319f
C4359 a_5731_5979# a_10083_4687# 0.01539f
C4360 a_10430_3889# a_10404_3853# 0.277f
C4361 a_16108_3134# a_24957_1842# 0.01307f
C4362 a_13557_1842# a_14317_1842# 0.01669f
C4363 a_21835_1044# a_21911_1008# 0.01194f
C4364 a_26673_1842# VDD 0.49593f
C4365 a_10083_1842# a_4187_2434# 0.06627f
C4366 a_13470_3889# a_15545_3889# 0.03208f
C4367 VDD a_13753_16869# 0.49294f
C4368 VDD a_21835_16071# 0.15406f
C4369 VDD a_4633_7532# 0.49285f
C4370 VDD a_9751_6698# 0.2822f
C4371 VDD a_25391_5315# 0.01806f
C4372 CHAN2_MUX_SEL4 a_4187_2434# 0.01921f
C4373 a_4187_2434# a_27563_14024# 0.06629f
C4374 a_4248_16071# a_4350_16071# 0.37183f
C4375 a_26477_16869# a_26803_16869# 0.01427f
C4376 a_5731_15316# a_10517_14024# 0.01314f
C4377 a_5197_14024# a_5393_14024# 0.76914f
C4378 a_10328_13226# a_10404_13190# 0.01176f
C4379 a_7477_14024# a_7364_13190# 0.05157f
C4380 a_4187_2434# a_19073_4687# 0.11222f
C4381 a_17357_7532# a_17683_7532# 0.01427f
C4382 a_22113_4687# a_22677_4687# 0.0114f
C4383 a_5731_3134# a_9193_1842# 0.01872f
C4384 a_8997_1842# VDD 0.85988f
C4385 a_14964_1008# VDD 0.28328f
C4386 a_5705_3364# CHAN2_MUX_SEL4 0.03556f
C4387 VDD REF_MUX_OUT 0.72212f
C4388 a_22590_3889# a_24523_4687# 0.01012f
C4389 a_15964_3134# a_15837_4687# 0.02f
C4390 VDD a_4157_16340# 0.48942f
C4391 VDD a_6126_9506# 0.84321f
C4392 VDD a_26477_14024# 0.87175f
C4393 VDD a_16923_4687# 0.4982f
C4394 CHAN0_MUX_OUT a_1256_15316# 0.1134f
C4395 CHAN0_MUX_SEL4 a_1544_15316# 0.47529f
C4396 CHAN1_MUX_SEL4 a_4157_13495# 0.08229f
C4397 CHAN0_MUX_SEL2 a_2297_15358# 0.10655f
C4398 a_4187_2434# a_9953_14024# 0.11222f
C4399 a_17553_16869# a_18117_16869# 0.0114f
C4400 a_21917_14024# a_22243_14024# 0.01427f
C4401 a_25630_16071# a_27991_16035# 0.26208f
C4402 a_4187_2434# a_22677_7532# 0.04176f
C4403 a_8433_7532# a_8997_7532# 0.0114f
C4404 a_5731_12471# a_11785_12701# 0.28056f
C4405 a_14888_6734# a_14964_6698# 0.01176f
C4406 a_25283_7532# a_25391_7532# 0.01163f
C4407 a_11277_7532# a_11848_6734# 0.10863f
C4408 a_16108_5979# a_24197_4687# 0.01319f
C4409 a_12993_4687# a_13123_4687# 0.70845f
C4410 a_25630_3889# a_26471_3853# 0.28268f
C4411 a_16510_3889# a_16851_3154# 0.02131f
C4412 a_21353_1842# a_21483_1842# 0.70845f
C4413 a_19550_3889# VDD 0.89766f
C4414 a_26043_1842# a_4187_2434# 0.06627f
C4415 VDD a_8671_17497# 0.01806f
C4416 VDD a_7803_14024# 0.50058f
C4417 VDD a_14311_13190# 0.28336f
C4418 VDD a_20593_7532# 0.49417f
C4419 VDD a_24665_3889# 0.29742f
C4420 REF_CLK a_10649_11568# 0.25484f
C4421 a_8433_16869# a_8563_16869# 0.70845f
C4422 a_4187_2434# a_13123_16869# 0.06627f
C4423 a_26185_16071# a_26471_16035# 0.01885f
C4424 a_11277_16869# a_11848_16071# 0.10863f
C4425 a_25283_16869# a_25391_16869# 0.01163f
C4426 a_16108_15316# a_23633_14024# 0.01872f
C4427 a_4187_2434# a_4003_7532# 0.05992f
C4428 a_12993_14024# a_13557_14024# 0.0114f
C4429 a_16597_14024# a_16484_13190# 0.05157f
C4430 a_20968_13226# a_21044_13190# 0.01176f
C4431 a_13592_11113# a_14111_10917# 0.34114f
C4432 a_25717_7532# a_25283_7532# 0.69698f
C4433 a_4437_4687# a_4003_4687# 0.69698f
C4434 a_5731_5979# a_8433_4687# 0.01872f
C4435 a_13470_3889# a_14888_3889# 0.38994f
C4436 a_12797_1842# a_12363_1842# 0.6972f
C4437 a_16108_3134# a_22243_1842# 0.01539f
C4438 a_20315_1044# a_20391_1008# 0.01194f
C4439 a_19550_1044# a_21044_1008# 0.28279f
C4440 a_24957_1842# VDD 0.88424f
C4441 a_20905_519# VDD 0.29315f
C4442 CHAN3_MUX_SEL4 CHAN3_MUX_OUT 0.91933f
C4443 a_8433_1842# a_4187_2434# 0.11222f
C4444 VDD a_12037_16869# 0.85889f
C4445 VDD a_18871_16035# 0.2822f
C4446 VDD a_15464_9374# 0.52511f
C4447 VDD a_7288_6734# 0.17274f
C4448 VDD a_19311_5315# 0.01806f
C4449 REF_MUX_SEL4 a_4187_2434# 0.01921f
C4450 a_25717_16869# a_25913_16869# 0.73897f
C4451 a_4187_2434# a_25913_14024# 0.11222f
C4452 a_4187_2434# a_6854_11676# 0.01478f
C4453 a_5731_15316# a_7803_14024# 0.01539f
C4454 a_4187_2434# a_17357_4687# 0.04141f
C4455 a_17065_13226# a_17275_13226# 0.09424f
C4456 a_16597_7532# a_16793_7532# 0.73897f
C4457 a_11491_11918# a_12158_11557# 0.0894f
C4458 a_20397_7532# a_20968_6734# 0.10863f
C4459 a_25528_6734# a_25604_6698# 0.01176f
C4460 a_21157_4687# a_21917_4687# 0.02912f
C4461 a_5731_3134# a_7477_1842# 0.01314f
C4462 a_10517_1842# a_10985_1044# 0.19203f
C4463 a_7390_1044# a_9675_1044# 0.39036f
C4464 a_6283_1842# a_4350_1044# 0.01012f
C4465 a_6283_1842# VDD 0.50001f
C4466 a_12715_1044# VDD 0.15482f
C4467 a_1256_3134# CHAN2_MUX_SEL2 0.33134f
C4468 CHAN0_MUX_OUT CHAN1_DELAY_IN 0.05155f
C4469 VDD a_23763_14024# 0.49684f
C4470 VDD a_16851_12491# 0.51536f
C4471 VDD a_15273_4687# 0.4946f
C4472 CHAN1_MUX_SEL0 a_2873_13577# 0.01504f
C4473 a_16597_16869# a_17357_16869# 0.01669f
C4474 a_4187_2434# a_8237_14024# 0.0414f
C4475 a_20397_16869# a_20968_16071# 0.10863f
C4476 a_25528_16071# a_25630_16071# 0.37183f
C4477 a_21157_14024# a_21353_14024# 0.77122f
C4478 a_4187_2434# a_19963_7532# 0.06661f
C4479 a_25717_14024# a_25604_13190# 0.05157f
C4480 a_7477_7532# a_8237_7532# 0.01669f
C4481 a_23763_7532# a_23871_7532# 0.01163f
C4482 a_13470_6734# a_13444_6698# 0.277f
C4483 a_24665_6734# a_24875_6734# 0.09424f
C4484 a_16108_5979# a_21483_4687# 0.01542f
C4485 a_24875_3889# a_24951_3853# 0.01194f
C4486 a_20397_1842# a_20723_1842# 0.01427f
C4487 a_16484_3853# VDD 0.28687f
C4488 a_24393_1842# a_4187_2434# 0.11222f
C4489 VDD a_6153_14024# 0.4946f
C4490 VDD a_27997_16869# 0.76025f
C4491 VDD a_11848_13226# 0.17499f
C4492 VDD a_18877_7532# 0.87825f
C4493 VDD a_1256_5979# 0.41949f
C4494 VDD a_12505_3889# 0.29742f
C4495 a_4187_2434# a_11473_16869# 0.11222f
C4496 a_13368_16071# a_13444_16035# 0.01176f
C4497 a_23763_16869# a_23871_16869# 0.01163f
C4498 a_12037_14024# a_12797_14024# 0.02912f
C4499 a_16108_15316# a_21917_14024# 0.01307f
C4500 a_19550_13226# a_19524_13190# 0.277f
C4501 a_7390_13226# a_5731_12471# 0.41331f
C4502 a_24393_7532# a_24957_7532# 0.0114f
C4503 a_15304_10295# a_14111_10917# 0.01761f
C4504 a_16108_5979# a_26985_6209# 0.2906f
C4505 a_4905_6734# a_5191_6698# 0.01885f
C4506 a_5731_5979# a_6717_4687# 0.01307f
C4507 a_5197_4687# a_5768_3889# 0.10863f
C4508 a_7390_3889# a_8231_3853# 0.28268f
C4509 a_11473_1842# a_12037_1842# 0.0114f
C4510 a_16108_3134# a_20593_1842# 0.01872f
C4511 a_24197_1842# a_24665_1044# 0.2079f
C4512 a_15403_1842# a_13470_1044# 0.01012f
C4513 a_22243_1842# VDD 0.50009f
C4514 a_6717_1842# a_4187_2434# 0.0414f
C4515 CHAN3_MUX_SEL0 CHAN3_MUX_SEL1 3.14917f
C4516 VDD a_9323_16869# 0.4973f
C4517 VDD a_16408_16071# 0.17274f
C4518 VDD a_4350_6734# 0.87635f
C4519 VDD a_13231_5315# 0.01806f
C4520 CHAN1_MUX_SEL4 a_9757_14024# 0.01829f
C4521 REF_MUX_SEL0 a_2297_7085# 0.10655f
C4522 REF_MUX_SEL4 a_1544_6734# 0.03407f
C4523 REF_MUX_OUT a_1256_6734# 0.02466f
C4524 a_24393_16869# a_24523_16869# 0.70845f
C4525 a_4187_2434# a_24197_14024# 0.04141f
C4526 a_4905_16071# a_5115_16071# 0.09424f
C4527 a_5197_14024# a_5191_13190# 0.02349f
C4528 a_16108_15316# a_23945_15546# 0.2906f
C4529 a_5731_15316# a_6153_14024# 0.02026f
C4530 a_5957_14024# a_4350_13226# 0.05231f
C4531 a_7390_13226# a_8155_13226# 0.39037f
C4532 a_10649_11568# a_10751_11568# 0.47795f
C4533 a_5731_12471# a_15304_10295# 0.04235f
C4534 a_6854_11676# a_12849_11557# 0.06216f
C4535 a_4187_2434# a_14643_4687# 0.06627f
C4536 a_15273_7532# a_15403_7532# 0.70845f
C4537 a_20397_4687# a_19963_4687# 0.6972f
C4538 a_15964_3134# a_16851_3154# 0.16757f
C4539 a_15545_1044# a_13470_1044# 0.03208f
C4540 a_4633_1842# VDD 0.49523f
C4541 a_9751_1008# VDD 0.2841f
C4542 a_1544_1044# CHAN3_MUX_SEL4 0.03386f
C4543 a_2297_1395# CHAN3_MUX_SEL0 0.10655f
C4544 VDD a_22113_14024# 0.49655f
C4545 VDD a_23111_8160# 0.01806f
C4546 VDD a_13557_4687# 0.871f
C4547 CHAN1_MUX_SEL0 a_1256_13226# 0.3314f
C4548 DLL_RESETN a_9444_9602# 0.03031f
C4549 a_4187_2434# a_27433_16869# 0.11222f
C4550 a_15837_16869# a_15403_16869# 0.6972f
C4551 a_4187_2434# a_5523_14024# 0.06627f
C4552 a_24008_16071# a_24084_16035# 0.01176f
C4553 a_19833_14024# a_19963_14024# 0.70845f
C4554 a_4187_2434# a_18313_7532# 0.11284f
C4555 a_22243_7532# a_22351_7532# 0.01163f
C4556 a_6717_7532# a_6283_7532# 0.6972f
C4557 a_11277_4687# a_11473_4687# 0.76914f
C4558 a_16108_5979# a_19833_4687# 0.01865f
C4559 a_22590_3889# a_24084_3853# 0.28279f
C4560 a_23355_3889# a_23431_3853# 0.01194f
C4561 a_19637_1842# a_19833_1842# 0.73897f
C4562 a_24523_1842# a_22590_1044# 0.01012f
C4563 a_15837_1842# a_15964_289# 0.02f
C4564 a_22590_1044# a_23945_519# 0.02165f
C4565 a_14235_3889# VDD 0.1539f
C4566 a_22677_1842# a_4187_2434# 0.0414f
C4567 VDD a_25283_16869# 0.49737f
C4568 VDD a_4437_14024# 0.87156f
C4569 VDD a_8884_13190# 0.28225f
C4570 VDD a_16163_7532# 0.4973f
C4571 VDD a_25630_6734# 0.89819f
C4572 VDD a_3449_4240# 0.46731f
C4573 a_22243_16869# a_22351_16869# 0.01163f
C4574 a_4187_2434# a_9757_16869# 0.0414f
C4575 a_6717_16869# a_6913_16869# 0.76914f
C4576 a_16108_15316# a_19203_14024# 0.01539f
C4577 a_15077_14024# a_13470_13226# 0.05231f
C4578 a_14317_14024# a_14311_13190# 0.02349f
C4579 a_11277_14024# a_10843_14024# 0.6972f
C4580 a_13121_11521# a_15464_9374# 0.33256f
C4581 a_23437_7532# a_24197_7532# 0.03319f
C4582 a_15765_6153# a_15964_5979# 0.061f
C4583 a_6635_3889# a_6711_3853# 0.01194f
C4584 a_16108_3134# a_18877_1842# 0.01307f
C4585 a_10517_1842# a_11277_1842# 0.01669f
C4586 a_16510_1044# a_18871_1008# 0.26208f
C4587 a_20593_1842# VDD 0.49593f
C4588 CHAN2_MUX_SEL4 CHAN2_MUX_OUT 0.91933f
C4589 a_4003_1842# a_4187_2434# 0.05992f
C4590 VDD a_7673_16869# 0.49294f
C4591 VDD a_13470_16071# 0.87936f
C4592 VDD a_13132_11110# 0.23866f
C4593 VDD a_20105_6734# 0.30409f
C4594 VDD a_7151_5315# 0.01806f
C4595 CHAN1_MUX_SEL4 a_13470_13226# 0.256f
C4596 a_23437_16869# a_23763_16869# 0.01427f
C4597 a_4187_2434# a_21483_14024# 0.06627f
C4598 a_4187_2434# a_12993_4687# 0.11222f
C4599 a_12505_13226# a_12791_13190# 0.01885f
C4600 a_9946_11995# a_10232_11561# 0.41329f
C4601 a_14317_7532# a_14643_7532# 0.01427f
C4602 a_22590_6734# a_23355_6734# 0.39037f
C4603 a_1544_3889# a_2297_4240# 0.28651f
C4604 a_19073_4687# a_19637_4687# 0.0114f
C4605 a_27433_1842# a_27997_1842# 0.0114f
C4606 a_16108_3134# VDD 1.62848f
C4607 a_7288_1044# VDD 0.17444f
C4608 a_20968_3889# a_20397_4687# 0.10863f
C4609 VDD a_20397_14024# 0.87175f
C4610 VDD a_5705_12701# 0.29556f
C4611 VDD a_17031_8160# 0.01806f
C4612 VDD a_10843_4687# 0.50058f
C4613 a_14513_16869# a_15077_16869# 0.0114f
C4614 a_4187_2434# a_25717_16869# 0.0414f
C4615 a_13470_16071# a_5731_15316# 0.41365f
C4616 a_22590_16071# a_22564_16035# 0.277f
C4617 a_24197_14024# a_22590_13226# 0.05231f
C4618 a_4187_2434# a_16597_7532# 0.04176f
C4619 a_1256_13226# a_2297_13577# 0.04619f
C4620 a_18877_14024# a_19203_14024# 0.01427f
C4621 a_23437_14024# a_23431_13190# 0.02349f
C4622 a_1256_12471# a_2873_12513# 0.27926f
C4623 a_5393_7532# a_5957_7532# 0.0114f
C4624 a_1544_12471# a_2297_12513# 0.27303f
C4625 a_22590_13226# a_16108_12471# 0.58202f
C4626 a_20723_7532# a_20831_7532# 0.01163f
C4627 a_7803_7532# a_7390_6734# 0.01012f
C4628 a_26803_7532# a_26911_8160# 0.01697f
C4629 a_10430_6734# a_11271_6698# 0.28268f
C4630 a_9953_4687# a_10083_4687# 0.70845f
C4631 a_20105_6734# a_20315_6734# 0.09424f
C4632 a_16108_5979# a_18117_4687# 0.01644f
C4633 a_18313_1842# a_18443_1842# 0.70845f
C4634 a_1256_1044# a_1544_1044# 1.26509f
C4635 a_19963_1842# a_4187_2434# 0.06627f
C4636 a_24875_3889# a_24665_3889# 0.09424f
C4637 VDD a_23633_16869# 0.49417f
C4638 VDD a_15765_15490# 0.36528f
C4639 VDD a_6635_13226# 0.15407f
C4640 VDD a_14513_7532# 0.49436f
C4641 VDD a_22564_6698# 0.28633f
C4642 CHAN1_MUX_SEL4 a_15765_12645# 0.65508f
C4643 a_5393_16869# a_5523_16869# 0.70845f
C4644 a_4187_2434# a_7043_16869# 0.06627f
C4645 a_20723_16869# a_20831_16869# 0.01163f
C4646 a_7803_16869# a_7390_16071# 0.01012f
C4647 a_10430_16071# a_11195_16071# 0.39037f
C4648 a_16108_15316# a_17553_14024# 0.01872f
C4649 a_9953_14024# a_10517_14024# 0.0114f
C4650 a_21625_16071# a_19550_16071# 0.03208f
C4651 a_12797_14024# a_13444_13190# 0.02011f
C4652 a_27563_14024# a_27671_14024# 0.01163f
C4653 a_15108_11799# a_15304_10295# 0.17528f
C4654 a_16510_13226# a_17351_13190# 0.28268f
C4655 a_22677_7532# a_22243_7532# 0.69698f
C4656 a_5731_5979# a_15964_5979# 0.2778f
C4657 a_27237_4687# a_27433_4687# 0.77122f
C4658 a_5115_3889# a_5191_3853# 0.01194f
C4659 a_12505_3889# a_10430_3889# 0.03208f
C4660 a_4350_3889# a_5844_3853# 0.28279f
C4661 a_26803_1842# a_26911_1842# 0.01163f
C4662 a_16108_3134# a_16163_1842# 0.0155f
C4663 a_9757_1842# a_9323_1842# 0.6972f
C4664 a_16408_1044# a_16510_1044# 0.37183f
C4665 a_18877_1842# VDD 0.88424f
C4666 a_1256_289# VDD 0.40359f
C4667 CHAN2_MUX_SEL0 CHAN2_MUX_SEL1 3.14917f
C4668 VDD a_5957_16869# 0.85889f
C4669 VDD a_10404_16035# 0.28633f
C4670 VDD a_27671_14652# 0.01806f
C4671 VDD a_7945_6734# 0.30409f
C4672 VDD a_26803_4687# 0.49684f
C4673 a_4187_2434# a_19833_14024# 0.11222f
C4674 a_22677_16869# a_22873_16869# 0.73897f
C4675 a_5731_15316# a_15765_15490# 0.23301f
C4676 a_10985_13226# a_10430_13226# 0.03209f
C4677 a_4350_13226# a_5768_13226# 0.38994f
C4678 a_4187_2434# a_11277_4687# 0.04141f
C4679 a_27237_14024# a_26803_14024# 0.6972f
C4680 a_9547_11632# a_9772_11533# 0.02416f
C4681 a_9547_11862# a_9746_11495# 0.02437f
C4682 a_13557_7532# a_13753_7532# 0.73897f
C4683 a_16923_7532# a_16510_6734# 0.01012f
C4684 a_18117_4687# a_18877_4687# 0.02912f
C4685 a_26477_1842# a_27237_1842# 0.03319f
C4686 a_9465_1044# a_9675_1044# 0.09424f
C4687 a_4248_1044# a_4324_1008# 0.01176f
C4688 a_4350_1044# VDD 1.07502f
C4689 VDD a_17683_14024# 0.49684f
C4690 VDD a_27915_13226# 0.15389f
C4691 VDD a_10951_8160# 0.01806f
C4692 VDD a_9193_4687# 0.4946f
C4693 REF_CLK a_13306_10795# 0.06166f
C4694 a_16923_16869# a_16510_16071# 0.01012f
C4695 a_4187_2434# a_23003_16869# 0.06627f
C4696 a_13557_16869# a_14317_16869# 0.01669f
C4697 a_18117_14024# a_18313_14024# 0.77122f
C4698 a_4187_2434# a_13883_7532# 0.06627f
C4699 a_21917_14024# a_22564_13190# 0.02011f
C4700 a_4437_7532# a_5197_7532# 0.01669f
C4701 a_6717_7532# a_7288_6734# 0.10864f
C4702 a_19203_7532# a_19311_7532# 0.01163f
C4703 a_12037_7532# a_12505_6734# 0.2079f
C4704 a_25283_7532# a_25391_8160# 0.01697f
C4705 a_9675_6734# a_9751_6698# 0.01194f
C4706 a_19550_3889# a_21911_3853# 0.26208f
C4707 a_17357_1842# a_17683_1842# 0.01427f
C4708 a_23111_2470# VDD 0.01806f
C4709 a_18313_1842# a_4187_2434# 0.11222f
C4710 VDD a_21917_16869# 0.87825f
C4711 VDD a_5731_15316# 0.95083f
C4712 VDD a_12797_7532# 0.87771f
C4713 VDD a_20315_6734# 0.15389f
C4714 CHAN0_MUX_OUT a_1256_16071# 0.02466f
C4715 CHAN0_MUX_SEL4 a_1544_16071# 0.03407f
C4716 CHAN0_MUX_SEL0 a_2297_16422# 0.10655f
C4717 CHAN1_MUX_SEL4 a_5731_12471# 4.60702f
C4718 a_4187_2434# a_5393_16869# 0.11222f
C4719 a_19203_16869# a_19311_16869# 0.01163f
C4720 a_12037_16869# a_12505_16071# 0.2079f
C4721 a_6717_16869# a_7288_16071# 0.10864f
C4722 a_8997_14024# a_9757_14024# 0.02912f
C4723 a_26043_14024# a_26151_14024# 0.01163f
C4724 a_4187_2434# a_27237_4687# 0.06254f
C4725 a_15755_13226# a_15831_13190# 0.01194f
C4726 a_27705_13226# a_27991_13190# 0.01885f
C4727 a_12037_14024# a_11924_13190# 0.02055f
C4728 a_21353_7532# a_21917_7532# 0.0114f
C4729 a_26043_7532# a_25630_6734# 0.01012f
C4730 a_5731_5979# a_8745_6209# 0.28635f
C4731 a_25913_4687# a_26043_4687# 0.70845f
C4732 a_8433_1842# a_8997_1842# 0.0114f
C4733 a_11277_1842# a_11848_1044# 0.10863f
C4734 a_25283_1842# a_25391_1842# 0.01163f
C4735 a_14888_1044# a_14964_1008# 0.01176f
C4736 a_16163_1842# VDD 0.49828f
C4737 a_25630_1044# VDD 1.09405f
C4738 REF_MUX_SEL4 REF_MUX_OUT 0.91933f
C4739 VDD a_8155_16071# 0.15389f
C4740 VDD a_21591_14652# 0.01806f
C4741 VDD a_2873_7085# 0.46517f
C4742 VDD a_25153_4687# 0.49655f
C4743 a_4187_2434# a_18117_14024# 0.04141f
C4744 a_26043_16869# a_25630_16071# 0.01012f
C4745 a_21353_16869# a_21483_16869# 0.70845f
C4746 a_25913_14024# a_26477_14024# 0.0114f
C4747 a_4187_2434# a_8563_4687# 0.06627f
C4748 a_7945_13226# a_8231_13190# 0.01885f
C4749 a_6854_11676# a_6126_9506# 0.18536f
C4750 a_5974_11413# a_6854_11144# 0.01757f
C4751 a_12233_7532# a_12363_7532# 0.70845f
C4752 a_19550_6734# a_20968_6734# 0.38994f
C4753 a_25717_7532# a_26185_6734# 0.19203f
C4754 a_15837_7532# a_16408_6734# 0.10864f
C4755 a_17357_4687# a_16923_4687# 0.6972f
C4756 a_25630_3889# a_26985_3364# 0.02165f
C4757 a_25717_1842# a_25283_1842# 0.69698f
C4758 a_3449_3176# VDD 0.47499f
C4759 a_20105_1044# VDD 0.30514f
C4760 VDD a_16033_14024# 0.49413f
C4761 VDD a_24951_13190# 0.2822f
C4762 VDD a_7477_4687# 0.871f
C4763 VDD a_4871_8160# 0.01806f
C4764 DLL_RESETN a_15304_10295# 0.03137f
C4765 a_4187_2434# a_21353_16869# 0.11222f
C4766 a_12797_16869# a_12363_16869# 0.6972f
C4767 a_15837_16869# a_16408_16071# 0.10864f
C4768 a_19550_16071# a_20391_16035# 0.28268f
C4769 a_25717_16869# a_26185_16071# 0.19203f
C4770 a_16793_14024# a_16923_14024# 0.70845f
C4771 a_4187_2434# a_12233_7532# 0.11222f
C4772 a_16510_13226# a_17865_12701# 0.02165f
C4773 a_21157_14024# a_21044_13190# 0.02055f
C4774 a_25630_13226# a_27048_13226# 0.38994f
C4775 a_23763_7532# a_23871_8160# 0.01697f
C4776 a_17683_7532# a_17791_7532# 0.01163f
C4777 a_5778_9057# a_5864_9057# 0.07306f
C4778 a_6717_7532# a_4350_6734# 0.02479f
C4779 a_9444_9602# a_9712_9602# 0.72189f
C4780 a_8155_6734# a_8231_6698# 0.01194f
C4781 a_7390_6734# a_8884_6698# 0.28279f
C4782 a_15545_6734# a_15831_6698# 0.01885f
C4783 a_10843_4687# a_10430_3889# 0.01012f
C4784 a_8237_4687# a_8433_4687# 0.76914f
C4785 a_19448_3889# a_19550_3889# 0.37183f
C4786 a_16597_1842# a_16793_1842# 0.73897f
C4787 a_20397_1842# a_20968_1044# 0.10863f
C4788 a_25528_1044# a_25604_1008# 0.01176f
C4789 a_17031_2470# VDD 0.01806f
C4790 a_16597_1842# a_4187_2434# 0.0414f
C4791 a_20315_3889# a_20105_3889# 0.09424f
C4792 VDD a_2297_15358# 0.46603f
C4793 VDD a_19203_16869# 0.49737f
C4794 VDD a_10083_7532# 0.49727f
C4795 VDD a_17065_13226# 0.30218f
C4796 VDD a_17351_6698# 0.28637f
C4797 CHAN1_MUX_SEL4 a_2297_12513# 0.04338f
C4798 CHAN1_MUX_SEL2 a_3449_12513# 0.10741f
C4799 CHAN1_MUX_SEL3 a_2873_12513# 0.12606f
C4800 a_17683_16869# a_17791_16869# 0.01163f
C4801 a_7390_16071# a_8808_16071# 0.38994f
C4802 a_15545_16071# a_15755_16071# 0.09424f
C4803 a_6717_16869# a_4350_16071# 0.02479f
C4804 a_11277_14024# a_10430_13226# 0.08038f
C4805 a_24523_14024# a_24631_14024# 0.01163f
C4806 a_18117_14024# a_18585_13226# 0.2079f
C4807 a_8237_14024# a_7803_14024# 0.6972f
C4808 a_14235_13226# a_14311_13190# 0.01194f
C4809 a_13470_13226# a_14964_13190# 0.28279f
C4810 a_4187_2434# a_24523_4687# 0.06627f
C4811 a_26185_13226# a_25630_13226# 0.03209f
C4812 a_20397_7532# a_21157_7532# 0.03319f
C4813 a_6326_10280# a_5778_9057# 0.8779f
C4814 a_24957_7532# a_25528_6734# 0.10864f
C4815 a_24957_4687# a_25283_4687# 0.01427f
C4816 a_6425_3889# a_6711_3853# 0.01885f
C4817 a_5731_3134# a_14643_1842# 0.01544f
C4818 a_7477_1842# a_8237_1842# 0.01669f
C4819 a_23763_1842# a_23871_1842# 0.01163f
C4820 a_24665_1044# a_24875_1044# 0.09424f
C4821 a_13470_1044# a_13444_1008# 0.277f
C4822 a_14513_1842# VDD 0.49593f
C4823 a_22564_1008# VDD 0.28758f
C4824 a_4437_1842# CHAN3_DELAY_IN 0.05007f
C4825 a_4633_1842# CHAN2_MUX_SEL4 0.01287f
C4826 REF_MUX_SEL0 REF_MUX_SEL1 3.14917f
C4827 VDD a_5191_16035# 0.28637f
C4828 VDD a_15511_14652# 0.01806f
C4829 VDD a_13121_11521# 0.99842f
C4830 VDD a_1256_6734# 0.475f
C4831 VDD a_23437_4687# 0.87185f
C4832 a_20397_16869# a_20723_16869# 0.01427f
C4833 a_24957_16869# a_25528_16071# 0.10864f
C4834 a_4187_2434# a_15403_14024# 0.06627f
C4835 a_24957_14024# a_25717_14024# 0.06198f
C4836 a_4187_2434# a_6913_4687# 0.11222f
C4837 a_6425_13226# a_6635_13226# 0.09424f
C4838 a_11277_7532# a_11603_7532# 0.01427f
C4839 a_15837_7532# a_13470_6734# 0.02479f
C4840 a_16033_4687# a_16597_4687# 0.0114f
C4841 a_4905_1044# a_5191_1008# 0.01885f
C4842 a_24393_1842# a_24957_1842# 0.0114f
C4843 a_16108_289# a_26985_519# 0.2906f
C4844 a_27124_3853# VDD 0.28225f
C4845 a_7945_1044# VDD 0.30514f
C4846 a_16510_3889# a_16923_4687# 0.01012f
C4847 VDD a_26151_17497# 0.01806f
C4848 VDD a_14317_14024# 0.87175f
C4849 VDD a_22488_13226# 0.17274f
C4850 VDD a_26043_7532# 0.4973f
C4851 VDD a_4763_4687# 0.49875f
C4852 VDD a_10430_3889# 0.88416f
C4853 REF_MUX_SEL2 a_1721_6021# 0.01315f
C4854 REF_MUX_SEL4 a_1256_5979# 0.65005f
C4855 REF_MUX_SEL3 a_1544_5979# 0.15976f
C4856 a_4187_2434# a_19637_16869# 0.0414f
C4857 a_11473_16869# a_12037_16869# 0.0114f
C4858 a_18795_16071# a_18871_16035# 0.01194f
C4859 a_15837_16869# a_13470_16071# 0.02479f
C4860 a_15837_14024# a_16163_14024# 0.01427f
C4861 a_4187_2434# a_10517_7532# 0.0414f
C4862 a_20397_14024# a_19550_13226# 0.08038f
C4863 a_22243_7532# a_22351_8160# 0.01697f
C4864 a_16163_7532# a_16271_7532# 0.01163f
C4865 a_4437_7532# a_4324_6698# 0.05157f
C4866 a_14025_6734# a_13470_6734# 0.03209f
C4867 a_5731_5979# a_13883_4687# 0.01539f
C4868 a_6913_4687# a_7043_4687# 0.70845f
C4869 a_16597_4687# a_17065_3889# 0.19203f
C4870 a_9757_4687# a_10328_3889# 0.10864f
C4871 a_17928_3889# a_18004_3853# 0.01176f
C4872 a_15273_1842# a_15403_1842# 0.70845f
C4873 a_10951_2470# VDD 0.01806f
C4874 VDD CHAN1_MUX_SEL1 0.50267f
C4875 a_1544_289# CHAN3_MUX_SEL3 0.15976f
C4876 a_1721_331# CHAN3_MUX_SEL2 0.01315f
C4877 a_1256_289# CHAN3_MUX_SEL4 0.65005f
C4878 a_13883_1842# a_4187_2434# 0.06627f
C4879 VDD a_17553_16869# 0.49417f
C4880 VDD a_26471_16035# 0.28357f
C4881 VDD a_6425_13226# 0.2975f
C4882 VDD a_8433_7532# 0.49417f
C4883 VDD a_14888_6734# 0.17499f
C4884 REF_MUX_SEL4 a_4350_6734# 0.31434f
C4885 a_16163_16869# a_16271_16869# 0.01163f
C4886 a_4437_16869# a_4324_16035# 0.05157f
C4887 a_6913_14024# a_7477_14024# 0.0114f
C4888 a_5731_15316# a_14317_14024# 0.01319f
C4889 a_9757_14024# a_9751_13190# 0.02354f
C4890 a_4187_2434# a_13019_11521# 0.02377f
C4891 a_23003_14024# a_23111_14024# 0.01163f
C4892 a_6126_9506# a_9444_10280# 0.03029f
C4893 a_4187_2434# a_22873_4687# 0.11222f
C4894 a_12849_11557# a_14009_11568# 0.03525f
C4895 a_13019_11521# a_12943_11557# 0.03346f
C4896 a_13306_11995# a_13592_11561# 0.41329f
C4897 a_23145_13226# a_23431_13190# 0.01885f
C4898 a_19637_7532# a_19203_7532# 0.69698f
C4899 a_1256_6734# a_2873_7085# 0.28892f
C4900 a_24957_7532# a_22590_6734# 0.02479f
C4901 a_24197_4687# a_24393_4687# 0.77122f
C4902 a_4905_3889# a_4350_3889# 0.03209f
C4903 a_4157_4158# a_4324_3853# 0.02463f
C4904 a_5731_3134# a_12993_1842# 0.01872f
C4905 a_6717_1842# a_6283_1842# 0.6972f
C4906 a_22243_1842# a_22351_1842# 0.01163f
C4907 a_12797_1842# VDD 0.8837f
C4908 a_20315_1044# VDD 0.15465f
C4909 a_16108_3134# CHAN2_MUX_SEL4 0.1283f
C4910 a_4350_1044# CHAN3_MUX_SEL4 0.31434f
C4911 a_15964_3134# CHAN2_MUX_OUT 0.01307f
C4912 VDD CHAN3_MUX_SEL4 2.75206f
C4913 a_25630_3889# a_26043_4687# 0.01012f
C4914 VDD a_24665_16071# 0.29722f
C4915 VDD a_9431_14652# 0.01806f
C4916 VDD a_11491_11918# 0.16908f
C4917 VDD a_20723_4687# 0.49684f
C4918 a_19637_16869# a_19833_16869# 0.73897f
C4919 a_4187_2434# a_13753_14024# 0.11222f
C4920 a_24957_16869# a_22590_16071# 0.02479f
C4921 a_4187_2434# a_5197_4687# 0.04141f
C4922 a_4187_2434# a_26477_7532# 0.04182f
C4923 a_4157_13495# a_4350_13226# 0.04624f
C4924 a_24197_14024# a_23763_14024# 0.6972f
C4925 a_16108_12471# a_16851_12491# 0.06181f
C4926 a_13557_7532# a_13444_6698# 0.05157f
C4927 a_10517_7532# a_10713_7532# 0.73897f
C4928 a_15077_4687# a_15837_4687# 0.02912f
C4929 a_16510_6734# a_18795_6734# 0.39036f
C4930 a_23437_1842# a_24197_1842# 0.03319f
C4931 a_1256_3134# a_1721_3176# 0.13421f
C4932 a_15765_463# a_15964_289# 0.061f
C4933 a_2873_1395# VDD 0.46667f
C4934 a_24875_3889# VDD 0.15407f
C4935 a_16408_3889# a_15837_4687# 0.10864f
C4936 VDD a_20071_17497# 0.01806f
C4937 VDD a_11603_14024# 0.49684f
C4938 VDD a_19550_13226# 0.89766f
C4939 VDD a_24393_7532# 0.49285f
C4940 VDD a_7364_3853# 0.28633f
C4941 VDD a_17865_6209# 0.29444f
C4942 REF_CLK a_13306_11995# 0.05059f
C4943 a_4187_2434# a_16923_16869# 0.06627f
C4944 a_10517_16869# a_11277_16869# 0.01669f
C4945 a_13557_16869# a_13444_16035# 0.05157f
C4946 a_17275_16071# a_17351_16035# 0.01194f
C4947 a_4350_16071# a_5705_15546# 0.02005f
C4948 a_16510_16071# a_18004_16035# 0.28279f
C4949 a_16108_15316# a_27433_14024# 0.01872f
C4950 a_4187_2434# a_7803_7532# 0.06627f
C4951 a_18877_14024# a_18871_13190# 0.02354f
C4952 a_15077_14024# a_15273_14024# 0.77122f
C4953 a_22590_13226# a_24875_13226# 0.39036f
C4954 a_14643_7532# a_14751_7532# 0.01163f
C4955 a_20723_7532# a_20831_8160# 0.01697f
C4956 a_5731_5979# a_12233_4687# 0.01872f
C4957 a_4350_6734# a_6711_6698# 0.26208f
C4958 a_10985_6734# a_11271_6698# 0.01885f
C4959 a_9757_4687# a_7390_3889# 0.02479f
C4960 a_16510_3889# a_16484_3853# 0.277f
C4961 a_14317_1842# a_14643_1842# 0.01427f
C4962 a_16108_3134# a_26043_1842# 0.01539f
C4963 a_22590_1044# a_23355_1044# 0.39037f
C4964 a_4871_2470# VDD 0.01806f
C4965 VDD CHAN0_MUX_SEL1 0.50267f
C4966 a_12233_1842# a_4187_2434# 0.11222f
C4967 a_15831_3853# a_15545_3889# 0.01885f
C4968 VDD a_15837_16869# 0.87963f
C4969 VDD a_24008_16071# 0.17499f
C4970 VDD a_6717_7532# 0.87726f
C4971 VDD a_11924_6698# 0.28225f
C4972 REF_DELAY_OUT_LAST a_14111_10917# 0.02024f
C4973 a_14643_16869# a_14751_16869# 0.01163f
C4974 a_27433_16869# a_27997_16869# 0.0114f
C4975 a_10985_16071# a_11195_16071# 0.09424f
C4976 a_5957_14024# a_6717_14024# 0.02912f
C4977 a_5731_15316# a_11603_14024# 0.01544f
C4978 a_4350_16071# a_6635_16071# 0.39036f
C4979 a_4187_2434# a_21157_4687# 0.04152f
C4980 a_27563_14024# a_27671_14652# 0.01697f
C4981 a_8237_14024# a_8884_13190# 0.02312f
C4982 a_10430_13226# a_12791_13190# 0.26208f
C4983 a_21483_14024# a_21591_14024# 0.01163f
C4984 a_13019_11521# a_12849_11557# 0.12838f
C4985 a_6854_11676# a_13132_11110# 0.01367f
C4986 a_22677_7532# a_22564_6698# 0.05157f
C4987 a_18313_7532# a_18877_7532# 0.0114f
C4988 a_22873_4687# a_23003_4687# 0.70845f
C4989 a_5393_1842# a_5957_1842# 0.0114f
C4990 a_5731_3134# a_11277_1842# 0.01319f
C4991 a_26803_1842# a_26911_2470# 0.01697f
C4992 a_7803_1842# a_7390_1044# 0.01012f
C4993 a_20723_1842# a_20831_1842# 0.01163f
C4994 a_10430_1044# a_11271_1008# 0.28268f
C4995 a_20105_1044# a_20315_1044# 0.09424f
C4996 a_17351_1008# VDD 0.28668f
C4997 a_10083_1842# VDD 0.49999f
C4998 VDD CHAN2_MUX_SEL4 2.69627f
C4999 a_25528_3889# a_24957_4687# 0.10864f
C5000 VDD a_12505_16071# 0.29722f
C5001 VDD a_27563_14024# 0.50198f
C5002 VDD a_19073_4687# 0.49655f
C5003 a_4187_2434# a_12037_14024# 0.04141f
C5004 a_18313_16869# a_18443_16869# 0.70845f
C5005 a_22677_16869# a_22564_16035# 0.05157f
C5006 a_19550_16071# a_20905_15546# 0.02165f
C5007 a_4187_2434# a_23763_7532# 0.06661f
C5008 a_22873_14024# a_23437_14024# 0.0114f
C5009 a_9193_7532# a_9323_7532# 0.70845f
C5010 a_16108_5979# a_25283_4687# 0.01539f
C5011 a_14317_4687# a_13883_4687# 0.6972f
C5012 a_22677_1842# a_22243_1842# 0.69698f
C5013 a_5731_289# a_15964_289# 0.2778f
C5014 a_21911_3853# VDD 0.2822f
C5015 a_1256_1044# VDD 0.5077f
C5016 a_13470_3889# a_15837_4687# 0.02479f
C5017 VDD a_13991_17497# 0.01806f
C5018 VDD a_16484_13190# 0.28597f
C5019 VDD a_9953_14024# 0.49655f
C5020 VDD a_22677_7532# 0.86712f
C5021 VDD a_5115_3889# 0.15389f
C5022 CHAN0_DELAY_IN a_4003_16869# 0.54998f
C5023 a_4187_2434# a_15273_16869# 0.11222f
C5024 a_9757_16869# a_9323_16869# 0.6972f
C5025 a_16108_15316# a_25717_14024# 0.01314f
C5026 a_4187_2434# a_6153_7532# 0.11222f
C5027 a_13753_14024# a_13883_14024# 0.70845f
C5028 a_17357_14024# a_18004_13190# 0.02312f
C5029 a_10430_13226# a_11785_12701# 0.02058f
C5030 a_14111_10917# a_15108_11015# 0.03012f
C5031 a_13306_10795# a_13880_10808# 0.31978f
C5032 a_26477_7532# a_26673_7532# 0.76914f
C5033 a_13123_7532# a_13231_7532# 0.01163f
C5034 a_19203_7532# a_19311_8160# 0.01697f
C5035 a_4248_6734# a_4350_6734# 0.37183f
C5036 a_5197_4687# a_5393_4687# 0.76914f
C5037 a_5731_5979# a_10517_4687# 0.01314f
C5038 a_7477_4687# a_7364_3853# 0.05157f
C5039 a_10328_3889# a_10404_3853# 0.01176f
C5040 a_13557_1842# a_13753_1842# 0.73897f
C5041 a_16108_3134# a_24393_1842# 0.01872f
C5042 a_16923_1842# a_16510_1044# 0.01012f
C5043 a_26043_1842# VDD 0.50058f
C5044 a_10517_1842# a_4187_2434# 0.0414f
C5045 a_13470_3889# a_14025_3889# 0.03209f
C5046 VDD a_13123_16869# 0.49727f
C5047 VDD a_21044_16035# 0.28225f
C5048 VDD a_4003_7532# 0.61559f
C5049 VDD a_9675_6734# 0.15406f
C5050 VDD a_24631_5315# 0.01806f
C5051 a_26477_16869# a_27237_16869# 0.03319f
C5052 a_4187_2434# a_27997_14024# 0.04001f
C5053 a_13123_16869# a_13231_16869# 0.01163f
C5054 a_5197_14024# a_4763_14024# 0.6972f
C5055 a_5731_15316# a_9953_14024# 0.01872f
C5056 a_19963_14024# a_20071_14024# 0.01163f
C5057 a_26043_14024# a_26151_14652# 0.01697f
C5058 a_7477_14024# a_7390_13226# 0.1088f
C5059 a_10328_13226# a_10430_13226# 0.37183f
C5060 a_4187_2434# a_18443_4687# 0.06627f
C5061 a_17357_7532# a_18117_7532# 0.03319f
C5062 a_25630_6734# a_27991_6698# 0.26208f
C5063 a_21917_4687# a_22243_4687# 0.01427f
C5064 a_5731_3134# a_8563_1842# 0.01544f
C5065 a_4437_1842# a_5197_1842# 0.01669f
C5066 a_6717_1842# a_7288_1044# 0.10864f
C5067 a_19203_1842# a_19311_1842# 0.01163f
C5068 a_25283_1842# a_25391_2470# 0.01697f
C5069 a_12037_1842# a_12505_1044# 0.2079f
C5070 a_9675_1044# a_9751_1008# 0.01194f
C5071 a_8433_1842# VDD 0.49593f
C5072 a_14888_1044# VDD 0.17575f
C5073 a_3449_3176# CHAN2_MUX_SEL4 0.05166f
C5074 CHAN1_MUX_SEL0 CHAN1_MUX_SEL2 0.01204f
C5075 CHAN1_DELAY_IN CHAN1_MUX_SEL4 0.0663f
C5076 VDD REF_MUX_SEL4 2.69627f
C5077 a_22590_3889# a_24957_4687# 0.02479f
C5078 VDD a_3449_16422# 0.46731f
C5079 VDD a_6854_11676# 1.21128f
C5080 VDD a_25913_14024# 0.49553f
C5081 VDD a_17357_4687# 0.87016f
C5082 CHAN0_MUX_SEL2 a_1721_15358# 0.01315f
C5083 CHAN0_MUX_SEL4 a_1256_15316# 0.65005f
C5084 CHAN0_MUX_SEL3 a_1544_15316# 0.15976f
C5085 a_17357_16869# a_17683_16869# 0.01427f
C5086 a_4187_2434# a_9323_14024# 0.06627f
C5087 a_4187_2434# a_22113_7532# 0.11286f
C5088 a_21917_14024# a_22677_14024# 0.06198f
C5089 a_25630_16071# a_27915_16071# 0.39036f
C5090 a_26477_14024# a_27124_13190# 0.02312f
C5091 a_8237_7532# a_8563_7532# 0.01427f
C5092 a_12037_7532# a_10430_6734# 0.05231f
C5093 a_11277_7532# a_11271_6698# 0.02349f
C5094 a_26185_6734# a_26471_6698# 0.01885f
C5095 a_12993_4687# a_13557_4687# 0.0114f
C5096 a_16108_5979# a_23633_4687# 0.01872f
C5097 a_16510_3889# a_16108_3134# 0.56108f
C5098 a_25630_3889# a_26395_3889# 0.39037f
C5099 a_26043_1842# a_25630_1044# 0.01012f
C5100 a_21353_1842# a_21917_1842# 0.0114f
C5101 a_5731_289# a_8745_519# 0.28635f
C5102 a_19448_3889# VDD 0.17274f
C5103 a_26477_1842# a_4187_2434# 0.04144f
C5104 a_13444_3853# a_13557_4687# 0.05157f
C5105 VDD a_7911_17497# 0.01806f
C5106 VDD a_8237_14024# 0.87181f
C5107 VDD a_14235_13226# 0.1539f
C5108 VDD a_19963_7532# 0.4973f
C5109 VDD a_23145_3889# 0.30411f
C5110 CHAN0_MUX_SEL4 a_4350_16071# 0.31434f
C5111 DLL_RESETN a_10649_11568# 0.05713f
C5112 REF_CLK a_10232_11561# 0.08086f
C5113 REF_MUX_SEL4 a_12797_7532# 0.01829f
C5114 a_8433_16869# a_8997_16869# 0.0114f
C5115 a_4187_2434# a_13557_16869# 0.0414f
C5116 a_12037_16869# a_10430_16071# 0.05231f
C5117 a_26185_16071# a_26395_16071# 0.09424f
C5118 a_13470_16071# a_15831_16035# 0.26208f
C5119 a_11277_16869# a_11271_16035# 0.02349f
C5120 a_16108_15316# a_23003_14024# 0.01539f
C5121 a_12797_14024# a_13123_14024# 0.01427f
C5122 a_4187_2434# a_4437_7532# 0.04193f
C5123 a_16597_14024# a_16510_13226# 0.1088f
C5124 a_13306_10795# a_14111_10917# 0.097f
C5125 a_11603_7532# a_11711_7532# 0.01163f
C5126 a_25153_7532# a_25283_7532# 0.70845f
C5127 a_13592_11113# a_14009_10774# 0.3749f
C5128 a_17683_7532# a_17791_8160# 0.01697f
C5129 a_5731_5979# a_7803_4687# 0.01539f
C5130 a_13470_3889# a_14311_3853# 0.28268f
C5131 a_25717_1842# a_26185_1044# 0.19203f
C5132 a_15837_1842# a_16408_1044# 0.10864f
C5133 a_12233_1842# a_12363_1842# 0.70845f
C5134 a_16108_3134# a_22677_1842# 0.01314f
C5135 a_19550_1044# a_20968_1044# 0.38994f
C5136 a_24393_1842# VDD 0.4946f
C5137 a_17865_519# VDD 0.29467f
C5138 a_12797_1842# CHAN3_MUX_SEL4 0.01829f
C5139 CHAN3_MUX_SEL3 CHAN3_MUX_OUT 0.79533f
C5140 a_7803_1842# a_4187_2434# 0.06627f
C5141 VDD a_11473_16869# 0.49417f
C5142 VDD a_18795_16071# 0.15406f
C5143 VDD a_6711_6698# 0.2822f
C5144 VDD a_18551_5315# 0.01806f
C5145 REF_MUX_SEL1 a_3449_7085# 0.29404f
C5146 a_11603_16869# a_11711_16869# 0.01163f
C5147 a_25717_16869# a_25283_16869# 0.69698f
C5148 a_4187_2434# a_25283_14024# 0.06627f
C5149 a_24523_14024# a_24631_14652# 0.01697f
C5150 a_5731_15316# a_8237_14024# 0.01319f
C5151 a_18443_14024# a_18551_14024# 0.01163f
C5152 a_18585_13226# a_16510_13226# 0.03208f
C5153 a_8808_13226# a_8884_13190# 0.01176f
C5154 a_4187_2434# a_16793_4687# 0.11222f
C5155 a_16597_7532# a_16163_7532# 0.69698f
C5156 a_11748_11799# a_12158_11557# 0.10373f
C5157 a_21157_7532# a_19550_6734# 0.05231f
C5158 a_20397_7532# a_20391_6698# 0.02349f
C5159 a_25528_6734# a_25630_6734# 0.37183f
C5160 a_21157_4687# a_21353_4687# 0.77122f
C5161 a_5731_3134# a_6913_1842# 0.01872f
C5162 a_7390_1044# a_8884_1008# 0.28279f
C5163 a_23763_1842# a_23871_2470# 0.01697f
C5164 a_15545_1044# a_15831_1008# 0.01885f
C5165 a_17683_1842# a_17791_1842# 0.01163f
C5166 a_6717_1842# a_4350_1044# 0.02479f
C5167 a_8155_1044# a_8231_1008# 0.01194f
C5168 a_6717_1842# VDD 0.88325f
C5169 a_11924_1008# VDD 0.28328f
C5170 a_3449_1395# CHAN3_MUX_SEL1 0.29404f
C5171 CHAN0_MUX_SEL2 CHAN1_MUX_SEL0 0.01667f
C5172 CHAN0_MUX_SEL4 CHAN1_DELAY_IN 0.01332f
C5173 a_22564_3853# a_22677_4687# 0.05157f
C5174 VDD a_24197_14024# 0.85955f
C5175 VDD a_16108_12471# 1.25759f
C5176 VDD a_14643_4687# 0.49684f
C5177 CHAN2_MUX_SEL4 a_10430_3889# 0.24983f
C5178 a_16597_16869# a_16793_16869# 0.73897f
C5179 a_4187_2434# a_7673_14024# 0.11222f
C5180 a_21157_16869# a_19550_16071# 0.05231f
C5181 a_20397_16869# a_20391_16035# 0.02349f
C5182 a_4187_2434# a_20397_7532# 0.04176f
C5183 a_21157_14024# a_20723_14024# 0.6972f
C5184 a_25717_14024# a_25630_13226# 0.1088f
C5185 a_7477_7532# a_7673_7532# 0.73897f
C5186 a_9757_7532# a_10404_6698# 0.02011f
C5187 a_13368_6734# a_13444_6698# 0.01176f
C5188 a_16108_5979# a_21917_4687# 0.01307f
C5189 a_12037_4687# a_12797_4687# 0.02912f
C5190 a_24957_1842# a_25528_1044# 0.10864f
C5191 a_20397_1842# a_21157_1842# 0.03319f
C5192 a_16510_3889# VDD 0.8795f
C5193 a_23763_1842# a_4187_2434# 0.06627f
C5194 VDD a_5523_14024# 0.49684f
C5195 VDD a_27433_16869# 0.49285f
C5196 VDD a_11271_13190# 0.28336f
C5197 VDD a_18313_7532# 0.49285f
C5198 VDD a_27991_6698# 0.28273f
C5199 VDD a_10985_3889# 0.30411f
C5200 a_7477_16869# a_8237_16869# 0.01669f
C5201 a_4187_2434# a_10843_16869# 0.06627f
C5202 a_9757_16869# a_10404_16035# 0.02011f
C5203 a_13368_16071# a_13470_16071# 0.37183f
C5204 a_12037_14024# a_12233_14024# 0.77122f
C5205 a_16108_15316# a_21353_14024# 0.01872f
C5206 a_19448_13226# a_19524_13190# 0.01176f
C5207 a_16163_7532# a_16271_8160# 0.01697f
C5208 a_12907_11110# a_13132_11110# 0.02416f
C5209 a_10083_7532# a_10191_7532# 0.01163f
C5210 a_5731_5979# a_6153_4687# 0.02026f
C5211 a_16108_5979# a_23945_6209# 0.2906f
C5212 a_4905_6734# a_5115_6734# 0.09424f
C5213 a_5957_4687# a_4350_3889# 0.05231f
C5214 a_5197_4687# a_5191_3853# 0.02349f
C5215 a_7390_3889# a_8155_3889# 0.39037f
C5216 a_16108_3134# a_19963_1842# 0.01539f
C5217 a_12715_3889# a_12791_3853# 0.01194f
C5218 a_11277_1842# a_11603_1842# 0.01427f
C5219 a_15837_1842# a_13470_1044# 0.02479f
C5220 a_22677_1842# VDD 0.87128f
C5221 a_6153_1842# a_4187_2434# 0.11222f
C5222 VDD a_9757_16869# 0.87771f
C5223 VDD a_15831_16035# 0.2816f
C5224 VDD a_9444_10280# 0.01557f
C5225 VDD a_4248_6734# 0.17587f
C5226 VDD a_12471_5315# 0.01806f
C5227 REF_MUX_SEL4 a_1256_6734# 0.04908f
C5228 a_10083_16869# a_10191_16869# 0.01163f
C5229 a_24393_16869# a_24957_16869# 0.0114f
C5230 a_16108_15316# a_20905_15546# 0.2906f
C5231 a_4187_2434# a_23633_14024# 0.11222f
C5232 a_6425_16071# a_4350_16071# 0.03208f
C5233 a_5731_15316# a_5523_14024# 0.01562f
C5234 a_23003_14024# a_23111_14652# 0.01697f
C5235 a_16923_14024# a_17031_14024# 0.01163f
C5236 a_10649_11568# a_10520_11982# 0.01562f
C5237 a_4187_2434# a_15077_4687# 0.04194f
C5238 a_6854_11676# a_13121_11521# 0.10056f
C5239 a_7390_13226# a_7364_13190# 0.277f
C5240 a_10232_11561# a_10751_11568# 0.34102f
C5241 a_15273_7532# a_15837_7532# 0.0114f
C5242 a_18877_7532# a_19524_6698# 0.02011f
C5243 a_24008_6734# a_24084_6698# 0.01176f
C5244 a_19833_4687# a_19963_4687# 0.70845f
C5245 a_15964_3134# a_16108_3134# 0.42202f
C5246 a_16163_1842# a_16271_1842# 0.01163f
C5247 a_22243_1842# a_22351_2470# 0.01697f
C5248 a_14025_1044# a_13470_1044# 0.03209f
C5249 a_4437_1842# a_4324_1008# 0.05157f
C5250 a_9675_1044# VDD 0.15482f
C5251 a_4003_1842# VDD 0.61702f
C5252 a_1256_1044# CHAN3_MUX_SEL4 0.04908f
C5253 CHAN0_DELAY_IN CHAN0_MUX_SEL4 0.0663f
C5254 CHAN0_MUX_SEL0 CHAN0_MUX_SEL2 0.01204f
C5255 VDD a_21483_14024# 0.50001f
C5256 VDD a_22351_8160# 0.01806f
C5257 VDD a_12993_4687# 0.49655f
C5258 DLL_RESETN a_5778_9057# 0.01215f
C5259 REF_DELAY_OUT_LAST a_27997_7532# 0.70957f
C5260 REF_MUX_SEL4 a_4763_4687# 0.01225f
C5261 a_4187_2434# a_26803_16869# 0.06627f
C5262 a_15273_16869# a_15403_16869# 0.70845f
C5263 a_13470_16071# a_14825_15546# 0.02058f
C5264 a_18877_16869# a_19524_16035# 0.02011f
C5265 a_4187_2434# a_5957_14024# 0.04141f
C5266 a_4187_2434# a_17683_7532# 0.06661f
C5267 a_19833_14024# a_20397_14024# 0.0114f
C5268 a_6153_7532# a_6283_7532# 0.70845f
C5269 a_8997_7532# a_8884_6698# 0.02055f
C5270 a_16108_5979# a_19203_4687# 0.01539f
C5271 a_11277_4687# a_10843_4687# 0.6972f
C5272 a_22590_3889# a_24008_3889# 0.38994f
C5273 a_19637_1842# a_19203_1842# 0.69698f
C5274 a_24957_1842# a_22590_1044# 0.02479f
C5275 a_1256_1044# a_2873_1395# 0.28892f
C5276 a_13444_3853# VDD 0.28633f
C5277 a_27997_1842# CHAN3_DELAY_OUT_LAST 0.70955f
C5278 a_22113_1842# a_4187_2434# 0.11222f
C5279 a_26471_3853# a_26185_3889# 0.01885f
C5280 VDD a_25717_16869# 0.86712f
C5281 VDD a_26985_15546# 0.29292f
C5282 VDD a_8808_13226# 0.17499f
C5283 VDD a_16597_7532# 0.86886f
C5284 VDD a_25528_6734# 0.17274f
C5285 a_6717_16869# a_6283_16869# 0.6972f
C5286 a_8997_16869# a_8884_16035# 0.02055f
C5287 a_4187_2434# a_9193_16869# 0.11222f
C5288 a_11848_16071# a_11924_16035# 0.01176f
C5289 a_21625_16071# a_21911_16035# 0.01885f
C5290 a_10713_14024# a_10843_14024# 0.70845f
C5291 a_16108_15316# a_19637_14024# 0.01314f
C5292 a_4350_13226# a_5731_12471# 0.41099f
C5293 a_13019_11521# a_15464_9374# 0.59875f
C5294 a_14643_7532# a_14751_8160# 0.01697f
C5295 a_23437_7532# a_23633_7532# 0.76914f
C5296 a_8563_7532# a_8671_7532# 0.01163f
C5297 a_16108_3134# a_18313_1842# 0.02026f
C5298 a_10517_1842# a_10713_1842# 0.73897f
C5299 a_16510_1044# a_18795_1044# 0.39036f
C5300 a_13557_1842# a_13444_1008# 0.05157f
C5301 a_19963_1842# VDD 0.50058f
C5302 CHAN2_MUX_SEL3 CHAN2_MUX_OUT 0.79533f
C5303 a_4437_1842# a_4187_2434# 0.0414f
C5304 CHAN2_MUX_SEL2 CHAN3_DELAY_IN 0.25306f
C5305 VDD a_7043_16869# 0.49723f
C5306 VDD a_13368_16071# 0.17274f
C5307 VDD a_12907_11110# 0.07753f
C5308 VDD a_6391_5315# 0.01806f
C5309 VDD a_18585_6734# 0.29722f
C5310 a_8563_16869# a_8671_16869# 0.01163f
C5311 a_23437_16869# a_24197_16869# 0.03319f
C5312 a_4187_2434# a_21917_14024# 0.0414f
C5313 a_21483_14024# a_21591_14652# 0.01697f
C5314 a_12505_13226# a_12715_13226# 0.09424f
C5315 a_15403_14024# a_15511_14024# 0.01163f
C5316 a_4187_2434# a_12363_4687# 0.06627f
C5317 a_9946_11995# a_10206_11525# 0.75507f
C5318 a_18117_7532# a_18004_6698# 0.02055f
C5319 a_14317_7532# a_15077_7532# 0.03319f
C5320 a_13470_6734# a_5731_5979# 0.41365f
C5321 a_22590_6734# a_22564_6698# 0.277f
C5322 a_18877_4687# a_19203_4687# 0.01427f
C5323 a_1256_3889# a_2297_4240# 0.04619f
C5324 a_14643_1842# a_14751_1842# 0.01163f
C5325 a_20723_1842# a_20831_2470# 0.01697f
C5326 a_4350_1044# a_6711_1008# 0.26208f
C5327 a_10985_1044# a_11271_1008# 0.01885f
C5328 a_6711_1008# VDD 0.2841f
C5329 a_15964_3134# VDD 0.31771f
C5330 a_19550_3889# a_21157_4687# 0.05231f
C5331 a_20391_3853# a_20397_4687# 0.02349f
C5332 VDD a_19833_14024# 0.49553f
C5333 VDD a_3449_12513# 0.46689f
C5334 VDD a_16271_8160# 0.01806f
C5335 VDD a_11277_4687# 0.87185f
C5336 REF_MUX_OUT a_16851_5999# 0.45865f
C5337 a_18117_16869# a_18004_16035# 0.02055f
C5338 a_14317_16869# a_14643_16869# 0.01427f
C5339 a_4187_2434# a_25153_16869# 0.11222f
C5340 a_22488_16071# a_22564_16035# 0.01176f
C5341 a_4187_2434# a_16033_7532# 0.11287f
C5342 a_18877_14024# a_19637_14024# 0.06198f
C5343 a_1544_12471# a_1721_12513# 0.36963f
C5344 a_1256_12471# a_2297_12513# 0.04261f
C5345 a_5197_7532# a_5523_7532# 0.01427f
C5346 a_13557_7532# a_14025_6734# 0.19203f
C5347 a_8237_7532# a_7390_6734# 0.08038f
C5348 a_16108_5979# a_17553_4687# 0.01872f
C5349 a_9953_4687# a_10517_4687# 0.0114f
C5350 a_21625_6734# a_19550_6734# 0.03208f
C5351 a_10430_6734# a_11195_6734# 0.39037f
C5352 a_27563_4687# a_27671_4687# 0.01163f
C5353 a_18313_1842# a_18877_1842# 0.0114f
C5354 a_22677_1842# a_22564_1008# 0.05157f
C5355 a_16851_309# CHAN3_MUX_OUT 0.45865f
C5356 a_20397_1842# a_4187_2434# 0.0414f
C5357 VDD a_23003_16869# 0.4973f
C5358 VDD a_14825_15546# 0.29292f
C5359 VDD a_5844_13190# 0.28225f
C5360 VDD a_13883_7532# 0.49742f
C5361 VDD a_22590_6734# 0.89557f
C5362 VDD a_1721_4240# 0.4533f
C5363 CHAN0_MUX_SEL1 a_3449_16422# 0.29404f
C5364 CHAN1_MUX_SEL4 a_14825_12701# 0.03307f
C5365 REF_MUX_SEL4 a_6717_7532# 0.0195f
C5366 a_4187_2434# a_7477_16869# 0.0414f
C5367 a_5393_16869# a_5957_16869# 0.0114f
C5368 a_8237_16869# a_7390_16071# 0.08038f
C5369 a_13557_16869# a_14025_16071# 0.19203f
C5370 a_26803_16869# a_26911_17497# 0.01697f
C5371 a_20105_16071# a_19550_16071# 0.03209f
C5372 a_16108_15316# a_16923_14024# 0.01073f
C5373 a_10430_16071# a_10404_16035# 0.277f
C5374 a_9757_14024# a_10083_14024# 0.01427f
C5375 a_16510_13226# a_17275_13226# 0.39037f
C5376 a_14111_11568# a_15304_10295# 0.01811f
C5377 a_7043_7532# a_7151_7532# 0.01163f
C5378 a_13123_7532# a_13231_8160# 0.01697f
C5379 a_22113_7532# a_22243_7532# 0.70845f
C5380 a_27237_7532# a_27124_6698# 0.02055f
C5381 a_5731_5979# a_15765_6153# 0.23301f
C5382 a_27237_4687# a_26803_4687# 0.6972f
C5383 a_10985_3889# a_10430_3889# 0.03209f
C5384 a_4350_3889# a_5768_3889# 0.38994f
C5385 a_9193_1842# a_9323_1842# 0.70845f
C5386 a_16108_3134# a_16597_1842# 0.01319f
C5387 a_18313_1842# VDD 0.4946f
C5388 a_27991_1008# VDD 0.28391f
C5389 a_6717_1842# CHAN3_MUX_SEL4 0.0195f
C5390 VDD a_5393_16869# 0.49417f
C5391 VDD a_10430_16071# 0.88416f
C5392 VDD a_26911_14652# 0.01806f
C5393 VDD a_15688_11557# 0.30345f
C5394 VDD a_27237_4687# 0.86128f
C5395 CHAN1_MUX_SEL4 a_10430_13226# 0.24983f
C5396 a_22677_16869# a_22243_16869# 0.69698f
C5397 a_7043_16869# a_7151_16869# 0.01163f
C5398 a_4187_2434# a_19203_14024# 0.06627f
C5399 a_27237_16869# a_27124_16035# 0.02055f
C5400 a_5731_15316# a_14825_15546# 0.28056f
C5401 a_26673_14024# a_26803_14024# 0.70845f
C5402 a_4187_2434# a_10713_4687# 0.11222f
C5403 a_4350_13226# a_5191_13190# 0.28268f
C5404 a_13883_14024# a_13991_14024# 0.01163f
C5405 a_19963_14024# a_20071_14652# 0.01697f
C5406 a_13557_7532# a_13123_7532# 0.69698f
C5407 a_9547_11632# a_9746_11495# 0.14994f
C5408 a_27237_7532# a_27705_6734# 0.2079f
C5409 a_17357_7532# a_16510_6734# 0.08038f
C5410 a_18117_4687# a_18313_4687# 0.77122f
C5411 a_19203_1842# a_19311_2470# 0.01697f
C5412 a_13123_1842# a_13231_1842# 0.01163f
C5413 a_26477_1842# a_26673_1842# 0.76914f
C5414 a_4248_1044# a_4350_1044# 0.37183f
C5415 a_8745_3364# VDD 0.29292f
C5416 a_4248_1044# VDD 0.17756f
C5417 a_19524_3853# a_18877_4687# 0.02011f
C5418 VDD a_18117_14024# 0.85955f
C5419 VDD a_27124_13190# 0.28225f
C5420 VDD a_10191_8160# 0.01806f
C5421 VDD a_8563_4687# 0.49684f
C5422 REF_CLK a_13566_11018# 0.01093f
C5423 a_13557_16869# a_13753_16869# 0.73897f
C5424 a_4187_2434# a_23437_16869# 0.04141f
C5425 a_27237_16869# a_27705_16071# 0.2079f
C5426 a_17357_16869# a_16510_16071# 0.08038f
C5427 a_10430_16071# a_5731_15316# 0.41176f
C5428 a_18117_14024# a_17683_14024# 0.6972f
C5429 a_4187_2434# a_14317_7532# 0.04317f
C5430 a_19550_13226# a_16108_12471# 0.58202f
C5431 a_4437_7532# a_4633_7532# 0.73897f
C5432 a_6717_7532# a_6711_6698# 0.02354f
C5433 a_8997_4687# a_9757_4687# 0.02912f
C5434 a_26043_4687# a_26151_4687# 0.01163f
C5435 a_19550_3889# a_21835_3889# 0.39036f
C5436 a_17357_1842# a_18117_1842# 0.03319f
C5437 a_25630_1044# a_27991_1008# 0.26208f
C5438 a_22351_2470# VDD 0.01806f
C5439 a_17683_1842# a_4187_2434# 0.06627f
C5440 VDD a_21353_16869# 0.49285f
C5441 VDD a_27705_13226# 0.29918f
C5442 VDD a_19524_6698# 0.28633f
C5443 VDD a_12233_7532# 0.49285f
C5444 CHAN0_MUX_SEL4 a_1256_16071# 0.04908f
C5445 a_4187_2434# a_4763_16869# 0.06627f
C5446 a_4437_16869# a_5197_16869# 0.01669f
C5447 a_17065_16071# a_17351_16035# 0.01885f
C5448 a_6717_16869# a_6711_16035# 0.02354f
C5449 a_25283_16869# a_25391_17497# 0.01697f
C5450 a_8997_14024# a_9193_14024# 0.77122f
C5451 a_19637_14024# a_20105_13226# 0.19203f
C5452 a_4187_2434# a_26673_4687# 0.11222f
C5453 a_27705_13226# a_27915_13226# 0.09424f
C5454 a_12363_14024# a_10430_13226# 0.01012f
C5455 a_13880_11982# a_14111_11568# 0.12701f
C5456 a_5523_7532# a_5631_7532# 0.01163f
C5457 a_14009_11568# a_14757_11918# 0.01058f
C5458 a_6854_11144# a_5864_9057# 0.03661f
C5459 a_11603_7532# a_11711_8160# 0.01697f
C5460 a_26477_7532# a_25630_6734# 0.08038f
C5461 a_25913_4687# a_26477_4687# 0.0114f
C5462 a_7945_3889# a_8231_3853# 0.01885f
C5463 a_8237_1842# a_8563_1842# 0.01427f
C5464 a_12037_1842# a_10430_1044# 0.05231f
C5465 a_11277_1842# a_11271_1008# 0.02349f
C5466 a_26185_1044# a_26471_1008# 0.01885f
C5467 a_16597_1842# VDD 0.86994f
C5468 a_25528_1044# VDD 0.17444f
C5469 REF_MUX_SEL2 CHAN2_DELAY_IN 0.25306f
C5470 REF_MUX_SEL3 REF_MUX_OUT 0.79533f
C5471 a_5731_3134# a_4187_2434# 0.17047f
C5472 VDD a_7364_16035# 0.28633f
C5473 VDD a_14009_11568# 0.25384f
C5474 VDD a_20831_14652# 0.01806f
C5475 VDD a_24523_4687# 0.50001f
C5476 CHAN0_MUX_SEL4 a_4763_14024# 0.01225f
C5477 a_5523_16869# a_5631_16869# 0.01163f
C5478 a_21353_16869# a_21917_16869# 0.0114f
C5479 a_4187_2434# a_17553_14024# 0.11222f
C5480 a_26477_16869# a_25630_16071# 0.08038f
C5481 a_18443_14024# a_18551_14652# 0.01697f
C5482 a_12363_14024# a_12471_14024# 0.01163f
C5483 a_4437_14024# a_4905_13226# 0.19203f
C5484 a_7945_13226# a_8155_13226# 0.09424f
C5485 a_4187_2434# a_8997_4687# 0.04152f
C5486 a_5974_11413# a_6126_9506# 1.74589f
C5487 a_12233_7532# a_12797_7532# 0.0114f
C5488 a_6326_10280# a_6854_11144# 1.25249f
C5489 a_15837_7532# a_15831_6698# 0.02354f
C5490 a_19550_6734# a_20391_6698# 0.28268f
C5491 a_16793_4687# a_16923_4687# 0.70845f
C5492 a_5705_3364# a_5731_3134# 0.28954f
C5493 a_25153_1842# a_25283_1842# 0.70845f
C5494 a_11603_1842# a_11711_1842# 0.01163f
C5495 a_17683_1842# a_17791_2470# 0.01697f
C5496 a_2873_3176# VDD 0.46598f
C5497 a_18585_1044# VDD 0.29845f
R0 VDD.n476 VDD.t545 17.3693
R1 VDD.n465 VDD.t274 17.3693
R2 VDD.n465 VDD.t272 17.3693
R3 VDD.n477 VDD.t1032 17.3517
R4 VDD.n468 VDD.t729 17.3517
R5 VDD.n467 VDD.t1198 17.3517
R6 VDD.n299 VDD.t568 17.2438
R7 VDD.n297 VDD.t838 17.2438
R8 VDD.n295 VDD.t731 17.2438
R9 VDD.n293 VDD.t672 17.2438
R10 VDD.n291 VDD.t1328 17.2438
R11 VDD.n471 VDD.t736 17.2247
R12 VDD.n477 VDD.t874 17.0005
R13 VDD.n468 VDD.t271 17.0005
R14 VDD.n467 VDD.t269 17.0005
R15 VDD.t7 VDD.n430 4.19382
R16 VDD.n184 VDD.n185 0.189847
R17 VDD.n414 VDD.n321 0.149987
R18 VDD.t7 VDD.n321 2.39616
R19 VDD.n318 VDD.n203 0.149987
R20 VDD.n318 VDD.t7 2.39616
R21 VDD.n415 VDD.n315 0.149987
R22 VDD.t7 VDD.n315 2.39616
R23 VDD.n310 VDD.n200 0.149987
R24 VDD.n310 VDD.t7 2.39616
R25 VDD.n416 VDD.n307 0.149987
R26 VDD.t7 VDD.n307 2.39616
R27 VDD.n303 VDD.n197 0.149987
R28 VDD.t7 VDD.n303 2.39616
R29 VDD.t0 VDD.n427 4.19382
R30 VDD.n186 VDD.n187 0.189847
R31 VDD.n411 VDD.n341 0.149987
R32 VDD.t0 VDD.n341 2.39616
R33 VDD.n338 VDD.n215 0.149987
R34 VDD.n338 VDD.t0 2.39616
R35 VDD.n412 VDD.n335 0.149987
R36 VDD.t0 VDD.n335 2.39616
R37 VDD.n330 VDD.n212 0.149987
R38 VDD.n330 VDD.t0 2.39616
R39 VDD.n413 VDD.n327 0.149987
R40 VDD.t0 VDD.n327 2.39616
R41 VDD.n323 VDD.n209 0.149987
R42 VDD.t0 VDD.n323 2.39616
R43 VDD.t41 VDD.n424 4.19382
R44 VDD.n188 VDD.n189 0.189847
R45 VDD.n408 VDD.n361 0.149987
R46 VDD.t41 VDD.n361 2.39616
R47 VDD.n358 VDD.n227 0.149987
R48 VDD.n358 VDD.t41 2.39616
R49 VDD.n409 VDD.n355 0.149987
R50 VDD.t41 VDD.n355 2.39616
R51 VDD.n350 VDD.n224 0.149987
R52 VDD.n350 VDD.t41 2.39616
R53 VDD.n410 VDD.n347 0.149987
R54 VDD.t41 VDD.n347 2.39616
R55 VDD.n343 VDD.n221 0.149987
R56 VDD.t41 VDD.n343 2.39616
R57 VDD.t50 VDD.n421 4.19382
R58 VDD.n190 VDD.n191 0.189847
R59 VDD.n405 VDD.n381 0.149987
R60 VDD.t50 VDD.n381 2.39616
R61 VDD.n378 VDD.n239 0.149987
R62 VDD.n378 VDD.t50 2.39616
R63 VDD.n406 VDD.n375 0.149987
R64 VDD.t50 VDD.n375 2.39616
R65 VDD.n370 VDD.n236 0.149987
R66 VDD.n370 VDD.t50 2.39616
R67 VDD.n407 VDD.n367 0.149987
R68 VDD.t50 VDD.n367 2.39616
R69 VDD.n363 VDD.n233 0.149987
R70 VDD.t50 VDD.n363 2.39616
R71 VDD.t4 VDD.n418 4.19382
R72 VDD.n192 VDD.n193 0.189847
R73 VDD.n402 VDD.n401 0.149987
R74 VDD.t4 VDD.n401 2.39616
R75 VDD.n398 VDD.n251 0.149987
R76 VDD.n398 VDD.t4 2.39616
R77 VDD.n403 VDD.n395 0.149987
R78 VDD.t4 VDD.n395 2.39616
R79 VDD.n390 VDD.n248 0.149987
R80 VDD.n390 VDD.t4 2.39616
R81 VDD.n404 VDD.n387 0.149987
R82 VDD.t4 VDD.n387 2.39616
R83 VDD.n383 VDD.n245 0.149987
R84 VDD.t4 VDD.n383 2.39616
R85 VDD.t297 VDD.n66 1.5967
R86 VDD.t293 VDD.n175 2.05485
R87 VDD.n164 VDD.n283 0.448571
R88 VDD.n166 VDD.t815 15.1333
R89 VDD.n168 VDD.t804 15.1333
R90 VDD.n170 VDD.t793 15.1333
R91 VDD.n172 VDD.t760 15.1333
R92 VDD.n174 VDD.t749 15.1333
R93 VDD.n1237 VDD.t818 15.0005
R94 VDD.n7 VDD.t813 15.0005
R95 VDD.n1488 VDD.t807 15.0005
R96 VDD.n1 VDD.t802 15.0005
R97 VDD.n1739 VDD.t796 15.0005
R98 VDD.n4 VDD.t791 15.0005
R99 VDD.n964 VDD.t763 15.0005
R100 VDD.n9 VDD.t758 15.0005
R101 VDD.n520 VDD.t752 15.0005
R102 VDD.n67 VDD.t744 15.0005
R103 VDD.n148 VDD.t747 15.0005
R104 VDD.n282 VDD.t778 15.0005
R105 VDD.n177 VDD.t783 15.0005
R106 VDD.n285 VDD.t697 17.9449
R107 VDD.n1745 VDD.n1744 9.17219
R108 VDD.n1743 VDD.n1742 9.17119
R109 VDD.n286 VDD.n285 0.341666
R110 VDD.n1747 VDD.t563 9.02285
R111 VDD.n300 VDD.n301 0.0615821
R112 VDD.n462 VDD.n138 4.47071
R113 VDD.n461 VDD.t877 8.95516
R114 VDD.n996 VDD.t1385 8.76154
R115 VDD.n64 VDD.t1373 8.76154
R116 VDD.n64 VDD.t1052 8.76154
R117 VDD.n64 VDD.t1359 8.76154
R118 VDD.n63 VDD.t1043 8.76154
R119 VDD.n997 VDD.t1369 8.76154
R120 VDD.n194 VDD.t1053 8.76154
R121 VDD.n998 VDD.t1042 8.76154
R122 VDD.n299 VDD.t569 8.76154
R123 VDD.n1247 VDD.t706 8.76154
R124 VDD.n61 VDD.t836 8.76154
R125 VDD.n61 VDD.t1493 8.76154
R126 VDD.n61 VDD.t867 8.76154
R127 VDD.n60 VDD.t279 8.76154
R128 VDD.n1248 VDD.t707 8.76154
R129 VDD.n206 VDD.t1492 8.76154
R130 VDD.n1249 VDD.t278 8.76154
R131 VDD.n297 VDD.t1453 8.76154
R132 VDD.n1498 VDD.t488 8.76154
R133 VDD.n58 VDD.t626 8.76154
R134 VDD.n58 VDD.t728 8.76154
R135 VDD.n58 VDD.t625 8.76154
R136 VDD.n57 VDD.t676 8.76154
R137 VDD.n1499 VDD.t487 8.76154
R138 VDD.n218 VDD.t727 8.76154
R139 VDD.n1500 VDD.t513 8.76154
R140 VDD.n295 VDD.t732 8.76154
R141 VDD.n974 VDD.t1564 8.76154
R142 VDD.n55 VDD.t1416 8.76154
R143 VDD.n55 VDD.t1544 8.76154
R144 VDD.n55 VDD.t1415 8.76154
R145 VDD.n54 VDD.t485 8.76154
R146 VDD.n975 VDD.t1427 8.76154
R147 VDD.n230 VDD.t1543 8.76154
R148 VDD.n976 VDD.t483 8.76154
R149 VDD.n293 VDD.t673 8.76154
R150 VDD.n723 VDD.t1273 8.76154
R151 VDD.n52 VDD.t1267 8.76154
R152 VDD.n52 VDD.t677 8.76154
R153 VDD.n52 VDD.t1259 8.76154
R154 VDD.n51 VDD.t1488 8.76154
R155 VDD.n724 VDD.t1257 8.76154
R156 VDD.n242 VDD.t679 8.76154
R157 VDD.n725 VDD.t1306 8.76154
R158 VDD.n291 VDD.t1336 8.76154
R159 VDD.n455 VDD.t489 8.76054
R160 VDD.n455 VDD.t1027 8.76054
R161 VDD.n996 VDD.t873 8.76054
R162 VDD.n64 VDD.t540 8.76054
R163 VDD.n64 VDD.t1356 8.76054
R164 VDD.n64 VDD.t539 8.76054
R165 VDD.n63 VDD.t1425 8.76054
R166 VDD.n997 VDD.t631 8.76054
R167 VDD.n194 VDD.t1357 8.76054
R168 VDD.n998 VDD.t843 8.76054
R169 VDD.n1247 VDD.t1515 8.76054
R170 VDD.n61 VDD.t1470 8.76054
R171 VDD.n61 VDD.t1476 8.76054
R172 VDD.n61 VDD.t289 8.76054
R173 VDD.n60 VDD.t1178 8.76054
R174 VDD.n1248 VDD.t694 8.76054
R175 VDD.n206 VDD.t1478 8.76054
R176 VDD.n1249 VDD.t594 8.76054
R177 VDD.n1498 VDD.t914 8.76054
R178 VDD.n58 VDD.t528 8.76054
R179 VDD.n58 VDD.t570 8.76054
R180 VDD.n58 VDD.t671 8.76054
R181 VDD.n57 VDD.t1438 8.76054
R182 VDD.n1499 VDD.t852 8.76054
R183 VDD.n218 VDD.t572 8.76054
R184 VDD.n1500 VDD.t1007 8.76054
R185 VDD.n974 VDD.t1553 8.76054
R186 VDD.n55 VDD.t607 8.76054
R187 VDD.n55 VDD.t506 8.76054
R188 VDD.n55 VDD.t590 8.76054
R189 VDD.n54 VDD.t1539 8.76054
R190 VDD.n975 VDD.t541 8.76054
R191 VDD.n230 VDD.t508 8.76054
R192 VDD.n976 VDD.t1225 8.76054
R193 VDD.n723 VDD.t891 8.76054
R194 VDD.n52 VDD.t536 8.76054
R195 VDD.n52 VDD.t1481 8.76054
R196 VDD.n52 VDD.t962 8.76054
R197 VDD.n51 VDD.t470 8.76054
R198 VDD.n724 VDD.t892 8.76054
R199 VDD.n242 VDD.t1482 8.76054
R200 VDD.n725 VDD.t472 8.76054
R201 VDD.n321 VDD.n320 0.0442395
R202 VDD.n317 VDD.n318 0.0442395
R203 VDD.n315 VDD.n314 0.0442395
R204 VDD.n309 VDD.n310 0.0442395
R205 VDD.n307 VDD.n306 0.0442395
R206 VDD.n304 VDD.n303 0.0442395
R207 VDD.n341 VDD.n340 0.0442395
R208 VDD.n337 VDD.n338 0.0442395
R209 VDD.n335 VDD.n334 0.0442395
R210 VDD.n329 VDD.n330 0.0442395
R211 VDD.n327 VDD.n326 0.0442395
R212 VDD.n324 VDD.n323 0.0442395
R213 VDD.n361 VDD.n360 0.0442395
R214 VDD.n357 VDD.n358 0.0442395
R215 VDD.n355 VDD.n354 0.0442395
R216 VDD.n349 VDD.n350 0.0442395
R217 VDD.n347 VDD.n346 0.0442395
R218 VDD.n344 VDD.n343 0.0442395
R219 VDD.n381 VDD.n380 0.0442395
R220 VDD.n377 VDD.n378 0.0442395
R221 VDD.n375 VDD.n374 0.0442395
R222 VDD.n369 VDD.n370 0.0442395
R223 VDD.n367 VDD.n366 0.0442395
R224 VDD.n364 VDD.n363 0.0442395
R225 VDD.n401 VDD.n400 0.0442395
R226 VDD.n397 VDD.n398 0.0442395
R227 VDD.n395 VDD.n394 0.0442395
R228 VDD.n389 VDD.n390 0.0442395
R229 VDD.n387 VDD.n386 0.0442395
R230 VDD.n384 VDD.n383 0.0442395
R231 VDD VDD.t268 8.47732
R232 VDD.n196 VDD.n195 0.0953067
R233 VDD.t7 VDD.n196 4.19225
R234 VDD.t7 VDD.n179 3.34459
R235 VDD.t7 VDD.n65 1.07426
R236 VDD.n75 VDD.t7 0.282276
R237 VDD.t7 VDD.n17 0.793108
R238 VDD.t7 VDD.n124 1.13836
R239 VDD.n16 VDD.t7 0.793108
R240 VDD.n126 VDD.t7 1.13836
R241 VDD.t7 VDD.n14 0.793108
R242 VDD.t7 VDD.n127 0.315451
R243 VDD.n13 VDD.t7 0.793108
R244 VDD.n130 VDD.t7 1.13836
R245 VDD.t7 VDD.n11 0.793108
R246 VDD.t7 VDD.n132 1.13836
R247 VDD.t7 VDD.n46 0.793077
R248 VDD.t399 VDD.n254 4.20922
R249 VDD.t399 VDD.n262 4.20922
R250 VDD.n208 VDD.n207 0.0953067
R251 VDD.t0 VDD.n208 4.19225
R252 VDD.t0 VDD.n180 3.34459
R253 VDD.t0 VDD.n62 1.07426
R254 VDD.n71 VDD.t0 0.282273
R255 VDD.t0 VDD.n24 0.793108
R256 VDD.t0 VDD.n113 1.13836
R257 VDD.n23 VDD.t0 0.793108
R258 VDD.n115 VDD.t0 1.13836
R259 VDD.t0 VDD.n21 0.793108
R260 VDD.t0 VDD.n116 0.315451
R261 VDD.n20 VDD.t0 0.793108
R262 VDD.n119 VDD.t0 1.13836
R263 VDD.t0 VDD.n18 0.793108
R264 VDD.t0 VDD.n121 1.13836
R265 VDD.t0 VDD.n47 0.793077
R266 VDD.t281 VDD.n255 4.20922
R267 VDD.t281 VDD.n266 4.20922
R268 VDD.n220 VDD.n219 0.0953067
R269 VDD.t41 VDD.n220 4.19225
R270 VDD.t41 VDD.n181 3.34459
R271 VDD.t41 VDD.n59 1.07426
R272 VDD.n69 VDD.t41 0.282264
R273 VDD.t41 VDD.n31 0.793108
R274 VDD.t41 VDD.n102 1.13836
R275 VDD.n30 VDD.t41 0.793108
R276 VDD.n104 VDD.t41 1.13836
R277 VDD.t41 VDD.n28 0.793108
R278 VDD.t41 VDD.n105 0.315451
R279 VDD.n27 VDD.t41 0.793108
R280 VDD.n108 VDD.t41 1.13836
R281 VDD.t41 VDD.n25 0.793108
R282 VDD.t41 VDD.n110 1.13836
R283 VDD.t41 VDD.n48 0.793077
R284 VDD.t275 VDD.n256 4.20922
R285 VDD.t275 VDD.n270 4.20922
R286 VDD.n232 VDD.n231 0.0953067
R287 VDD.t50 VDD.n232 4.19225
R288 VDD.t50 VDD.n182 3.34459
R289 VDD.n77 VDD.t50 0.28229
R290 VDD.t50 VDD.n38 0.793108
R291 VDD.t50 VDD.n91 1.13836
R292 VDD.n37 VDD.t50 0.793108
R293 VDD.n93 VDD.t50 1.13836
R294 VDD.t50 VDD.n35 0.793108
R295 VDD.t50 VDD.n94 0.315451
R296 VDD.n34 VDD.t50 0.793108
R297 VDD.n97 VDD.t50 1.13836
R298 VDD.t50 VDD.n32 0.793108
R299 VDD.t50 VDD.n99 1.13836
R300 VDD.t50 VDD.n49 0.793077
R301 VDD.t301 VDD.n257 4.20922
R302 VDD.t301 VDD.n274 4.20922
R303 VDD.n244 VDD.n243 0.0953067
R304 VDD.t4 VDD.n244 4.19225
R305 VDD.t4 VDD.n183 3.34459
R306 VDD.n73 VDD.t4 0.282275
R307 VDD.t4 VDD.n45 0.793108
R308 VDD.t4 VDD.n80 1.13836
R309 VDD.n44 VDD.t4 0.793108
R310 VDD.n82 VDD.t4 1.13836
R311 VDD.t4 VDD.n42 0.793108
R312 VDD.t4 VDD.n83 0.315451
R313 VDD.n41 VDD.t4 0.793108
R314 VDD.n86 VDD.t4 1.13836
R315 VDD.t4 VDD.n39 0.793108
R316 VDD.t4 VDD.n88 1.13836
R317 VDD.t4 VDD.n50 0.793077
R318 VDD.t297 VDD.n258 4.20922
R319 VDD.t297 VDD.n280 4.20922
R320 VDD.t293 VDD.n259 1.61947
R321 VDD.t293 VDD.n164 0.894484
R322 VDD.t293 VDD.n300 8.47732
R323 VDD.n46 VDD.t1626 7.62628
R324 VDD.n302 VDD.t1625 7.62628
R325 VDD.n132 VDD.t1624 7.62628
R326 VDD.n11 VDD.t1623 7.62628
R327 VDD.n305 VDD.t1622 7.62628
R328 VDD.n130 VDD.t1621 7.62628
R329 VDD.n13 VDD.t1620 7.62628
R330 VDD.n308 VDD.t1619 7.62628
R331 VDD.n128 VDD.t1618 7.62628
R332 VDD.n14 VDD.t1617 7.62628
R333 VDD.n313 VDD.t1616 7.62628
R334 VDD.n126 VDD.t1615 7.62628
R335 VDD.n16 VDD.t1614 7.62628
R336 VDD.n316 VDD.t1613 7.62628
R337 VDD.n124 VDD.t1612 7.62628
R338 VDD.n17 VDD.t1611 7.62628
R339 VDD.n319 VDD.t1610 7.62628
R340 VDD.n122 VDD.t1609 7.62628
R341 VDD.n47 VDD.t1644 7.62628
R342 VDD.n322 VDD.t1643 7.62628
R343 VDD.n121 VDD.t1642 7.62628
R344 VDD.n18 VDD.t1641 7.62628
R345 VDD.n325 VDD.t1640 7.62628
R346 VDD.n119 VDD.t1639 7.62628
R347 VDD.n20 VDD.t1638 7.62628
R348 VDD.n328 VDD.t1637 7.62628
R349 VDD.n117 VDD.t1636 7.62628
R350 VDD.n21 VDD.t1635 7.62628
R351 VDD.n333 VDD.t1634 7.62628
R352 VDD.n115 VDD.t1633 7.62628
R353 VDD.n23 VDD.t1632 7.62628
R354 VDD.n336 VDD.t1631 7.62628
R355 VDD.n113 VDD.t1630 7.62628
R356 VDD.n24 VDD.t1629 7.62628
R357 VDD.n339 VDD.t1628 7.62628
R358 VDD.n111 VDD.t1627 7.62628
R359 VDD.n48 VDD.t1662 7.62628
R360 VDD.n342 VDD.t1661 7.62628
R361 VDD.n110 VDD.t1660 7.62628
R362 VDD.n25 VDD.t1659 7.62628
R363 VDD.n345 VDD.t1658 7.62628
R364 VDD.n108 VDD.t1657 7.62628
R365 VDD.n27 VDD.t1656 7.62628
R366 VDD.n348 VDD.t1655 7.62628
R367 VDD.n106 VDD.t1654 7.62628
R368 VDD.n28 VDD.t1653 7.62628
R369 VDD.n353 VDD.t1652 7.62628
R370 VDD.n104 VDD.t1651 7.62628
R371 VDD.n30 VDD.t1650 7.62628
R372 VDD.n356 VDD.t1649 7.62628
R373 VDD.n102 VDD.t1648 7.62628
R374 VDD.n31 VDD.t1647 7.62628
R375 VDD.n359 VDD.t1646 7.62628
R376 VDD.n100 VDD.t1645 7.62628
R377 VDD.n49 VDD.t1680 7.62628
R378 VDD.n362 VDD.t1679 7.62628
R379 VDD.n99 VDD.t1678 7.62628
R380 VDD.n32 VDD.t1677 7.62628
R381 VDD.n365 VDD.t1676 7.62628
R382 VDD.n97 VDD.t1675 7.62628
R383 VDD.n34 VDD.t1674 7.62628
R384 VDD.n368 VDD.t1673 7.62628
R385 VDD.n95 VDD.t1672 7.62628
R386 VDD.n35 VDD.t1671 7.62628
R387 VDD.n373 VDD.t1670 7.62628
R388 VDD.n93 VDD.t1669 7.62628
R389 VDD.n37 VDD.t1668 7.62628
R390 VDD.n376 VDD.t1667 7.62628
R391 VDD.n91 VDD.t1666 7.62628
R392 VDD.n38 VDD.t1665 7.62628
R393 VDD.n379 VDD.t1664 7.62628
R394 VDD.n89 VDD.t1663 7.62628
R395 VDD.n50 VDD.t1698 7.62628
R396 VDD.n382 VDD.t1697 7.62628
R397 VDD.n88 VDD.t1696 7.62628
R398 VDD.n39 VDD.t1695 7.62628
R399 VDD.n385 VDD.t1694 7.62628
R400 VDD.n86 VDD.t1693 7.62628
R401 VDD.n41 VDD.t1692 7.62628
R402 VDD.n388 VDD.t1691 7.62628
R403 VDD.n84 VDD.t1690 7.62628
R404 VDD.n42 VDD.t1689 7.62628
R405 VDD.n393 VDD.t1688 7.62628
R406 VDD.n82 VDD.t1687 7.62628
R407 VDD.n44 VDD.t1686 7.62628
R408 VDD.n396 VDD.t1685 7.62628
R409 VDD.n80 VDD.t1684 7.62628
R410 VDD.n45 VDD.t1683 7.62628
R411 VDD.n399 VDD.t1682 7.62628
R412 VDD.n78 VDD.t1681 7.62628
R413 VDD.n145 VDD.n148 0.143882
R414 VDD.n7 VDD.n140 3.11859
R415 VDD.n1 VDD.n141 3.11859
R416 VDD.n4 VDD.n142 3.11859
R417 VDD.n143 VDD.n9 3.11859
R418 VDD.n1046 VDD.t869 6.09923
R419 VDD.n1052 VDD.t535 6.09923
R420 VDD.n1058 VDD.t1503 6.09923
R421 VDD.n1064 VDD.t463 6.09923
R422 VDD.n1070 VDD.t840 6.09923
R423 VDD.n1076 VDD.t464 6.09923
R424 VDD.n1082 VDD.t898 6.09923
R425 VDD.n1088 VDD.t1121 6.09923
R426 VDD.n1094 VDD.t1204 6.09923
R427 VDD.n1100 VDD.t1112 6.09923
R428 VDD.n1106 VDD.t1144 6.09923
R429 VDD.n1112 VDD.t1108 6.09923
R430 VDD.n1118 VDD.t1197 6.09923
R431 VDD.n1124 VDD.t1159 6.09923
R432 VDD.n1130 VDD.t1146 6.09923
R433 VDD.n1136 VDD.t1148 6.09923
R434 VDD.n1142 VDD.t1113 6.09923
R435 VDD.n1148 VDD.t1164 6.09923
R436 VDD.n1154 VDD.t1298 6.09923
R437 VDD.n1160 VDD.t1118 6.09923
R438 VDD.n1166 VDD.t1268 6.09923
R439 VDD.n1172 VDD.t1249 6.09923
R440 VDD.n1178 VDD.t1327 6.09923
R441 VDD.n1184 VDD.t1252 6.09923
R442 VDD.n1190 VDD.t1290 6.09923
R443 VDD.n1196 VDD.t1262 6.09923
R444 VDD.n1202 VDD.t1291 6.09923
R445 VDD.n1208 VDD.t1275 6.09923
R446 VDD.n1214 VDD.t1292 6.09923
R447 VDD.n1220 VDD.t1277 6.09923
R448 VDD.n1226 VDD.t1254 6.09923
R449 VDD.n1232 VDD.t1339 6.09923
R450 VDD.n1297 VDD.t1181 6.09923
R451 VDD.n1303 VDD.t481 6.09923
R452 VDD.n1309 VDD.t282 6.09923
R453 VDD.n1315 VDD.t734 6.09923
R454 VDD.n1321 VDD.t847 6.09923
R455 VDD.n1327 VDD.t826 6.09923
R456 VDD.n1333 VDD.t680 6.09923
R457 VDD.n1339 VDD.t559 6.09923
R458 VDD.n1345 VDD.t1147 6.09923
R459 VDD.n1351 VDD.t821 6.09923
R460 VDD.n1357 VDD.t661 6.09923
R461 VDD.n1363 VDD.t543 6.09923
R462 VDD.n1369 VDD.t612 6.09923
R463 VDD.n1375 VDD.t566 6.09923
R464 VDD.n1381 VDD.t692 6.09923
R465 VDD.n1387 VDD.t611 6.09923
R466 VDD.n1393 VDD.t287 6.09923
R467 VDD.n1399 VDD.t512 6.09923
R468 VDD.n1405 VDD.t1004 6.09923
R469 VDD.n1411 VDD.t480 6.09923
R470 VDD.n1417 VDD.t850 6.09923
R471 VDD.n1423 VDD.t515 6.09923
R472 VDD.n1429 VDD.t913 6.09923
R473 VDD.n1435 VDD.t855 6.09923
R474 VDD.n1441 VDD.t286 6.09923
R475 VDD.n1447 VDD.t1002 6.09923
R476 VDD.n1453 VDD.t468 6.09923
R477 VDD.n1459 VDD.t503 6.09923
R478 VDD.n1465 VDD.t725 6.09923
R479 VDD.n1471 VDD.t521 6.09923
R480 VDD.n1477 VDD.t910 6.09923
R481 VDD.n1483 VDD.t576 6.09923
R482 VDD.n1548 VDD.t863 6.09923
R483 VDD.n1554 VDD.t504 6.09923
R484 VDD.n1560 VDD.t525 6.09923
R485 VDD.n1566 VDD.t638 6.09923
R486 VDD.n1572 VDD.t620 6.09923
R487 VDD.n1578 VDD.t743 6.09923
R488 VDD.n1584 VDD.t549 6.09923
R489 VDD.n1590 VDD.t474 6.09923
R490 VDD.n1596 VDD.t1468 6.09923
R491 VDD.n1602 VDD.t849 6.09923
R492 VDD.n1608 VDD.t1440 6.09923
R493 VDD.n1614 VDD.t665 6.09923
R494 VDD.n1620 VDD.t998 6.09923
R495 VDD.n1626 VDD.t824 6.09923
R496 VDD.n1632 VDD.t1430 6.09923
R497 VDD.n1638 VDD.t522 6.09923
R498 VDD.n1644 VDD.t895 6.09923
R499 VDD.n1650 VDD.t861 6.09923
R500 VDD.n1656 VDD.t520 6.09923
R501 VDD.n1662 VDD.t523 6.09923
R502 VDD.n1668 VDD.t822 6.09923
R503 VDD.n1674 VDD.t622 6.09923
R504 VDD.n1680 VDD.t1120 6.09923
R505 VDD.n1686 VDD.t557 6.09923
R506 VDD.n1692 VDD.t600 6.09923
R507 VDD.n1698 VDD.t509 6.09923
R508 VDD.n1704 VDD.t284 6.09923
R509 VDD.n1710 VDD.t526 6.09923
R510 VDD.n1716 VDD.t823 6.09923
R511 VDD.n1722 VDD.t593 6.09923
R512 VDD.n1728 VDD.t519 6.09923
R513 VDD.n1734 VDD.t1023 6.09923
R514 VDD.n773 VDD.t1338 6.09923
R515 VDD.n779 VDD.t1344 6.09923
R516 VDD.n785 VDD.t1342 6.09923
R517 VDD.n791 VDD.t1353 6.09923
R518 VDD.n797 VDD.t1330 6.09923
R519 VDD.n803 VDD.t1362 6.09923
R520 VDD.n809 VDD.t1363 6.09923
R521 VDD.n815 VDD.t1349 6.09923
R522 VDD.n821 VDD.t1364 6.09923
R523 VDD.n827 VDD.t1350 6.09923
R524 VDD.n833 VDD.t1346 6.09923
R525 VDD.n839 VDD.t1386 6.09923
R526 VDD.n845 VDD.t1379 6.09923
R527 VDD.n851 VDD.t1381 6.09923
R528 VDD.n857 VDD.t1405 6.09923
R529 VDD.n863 VDD.t1396 6.09923
R530 VDD.n869 VDD.t1555 6.09923
R531 VDD.n875 VDD.t1389 6.09923
R532 VDD.n881 VDD.t1388 6.09923
R533 VDD.n887 VDD.t1420 6.09923
R534 VDD.n893 VDD.t1411 6.09923
R535 VDD.n899 VDD.t1220 6.09923
R536 VDD.n905 VDD.t1219 6.09923
R537 VDD.n911 VDD.t1218 6.09923
R538 VDD.n917 VDD.t896 6.09923
R539 VDD.n923 VDD.t950 6.09923
R540 VDD.n929 VDD.t992 6.09923
R541 VDD.n935 VDD.t903 6.09923
R542 VDD.n941 VDD.t900 6.09923
R543 VDD.n947 VDD.t1269 6.09923
R544 VDD.n953 VDD.t589 6.09923
R545 VDD.n959 VDD.t907 6.09923
R546 VDD.n711 VDD.t1015 6.09923
R547 VDD.n705 VDD.t920 6.09923
R548 VDD.n699 VDD.t1123 6.09923
R549 VDD.n693 VDD.t550 6.09923
R550 VDD.n687 VDD.t642 6.09923
R551 VDD.n681 VDD.t685 6.09923
R552 VDD.n675 VDD.t552 6.09923
R553 VDD.n669 VDD.t456 6.09923
R554 VDD.n663 VDD.t1496 6.09923
R555 VDD.n657 VDD.t887 6.09923
R556 VDD.n651 VDD.t603 6.09923
R557 VDD.n645 VDD.t686 6.09923
R558 VDD.n639 VDD.t553 6.09923
R559 VDD.n633 VDD.t975 6.09923
R560 VDD.n627 VDD.t458 6.09923
R561 VDD.n621 VDD.t627 6.09923
R562 VDD.n615 VDD.t924 6.09923
R563 VDD.n609 VDD.t629 6.09923
R564 VDD.n603 VDD.t961 6.09923
R565 VDD.n597 VDD.t614 6.09923
R566 VDD.n591 VDD.t1167 6.09923
R567 VDD.n585 VDD.t979 6.09923
R568 VDD.n579 VDD.t533 6.09923
R569 VDD.n573 VDD.t833 6.09923
R570 VDD.n567 VDD.t687 6.09923
R571 VDD.n561 VDD.t930 6.09923
R572 VDD.n555 VDD.t564 6.09923
R573 VDD.n549 VDD.t889 6.09923
R574 VDD.n543 VDD.t934 6.09923
R575 VDD.n537 VDD.t931 6.09923
R576 VDD.n531 VDD.t459 6.09923
R577 VDD.n525 VDD.t835 6.09923
R578 VDD.n132 VDD.t617 5.99122
R579 VDD.n130 VDD.t1276 5.99122
R580 VDD.n128 VDD.t953 5.99122
R581 VDD.n126 VDD.t1176 5.99122
R582 VDD.n124 VDD.t993 5.99122
R583 VDD.n122 VDD.t1334 5.99122
R584 VDD.n121 VDD.t894 5.99122
R585 VDD.n119 VDD.t1035 5.99122
R586 VDD.n117 VDD.t613 5.99122
R587 VDD.n115 VDD.t851 5.99122
R588 VDD.n113 VDD.t285 5.99122
R589 VDD.n111 VDD.t882 5.99122
R590 VDD.n110 VDD.t556 5.99122
R591 VDD.n108 VDD.t644 5.99122
R592 VDD.n106 VDD.t999 5.99122
R593 VDD.n104 VDD.t546 5.99122
R594 VDD.n102 VDD.t601 5.99122
R595 VDD.n100 VDD.t854 5.99122
R596 VDD.n99 VDD.t911 5.99122
R597 VDD.n97 VDD.t1227 5.99122
R598 VDD.n95 VDD.t1288 5.99122
R599 VDD.n93 VDD.t955 5.99122
R600 VDD.n91 VDD.t958 5.99122
R601 VDD.n89 VDD.t690 5.99122
R602 VDD.n88 VDD.t839 5.99122
R603 VDD.n86 VDD.t1161 5.99122
R604 VDD.n84 VDD.t554 5.99122
R605 VDD.n82 VDD.t1170 5.99122
R606 VDD.n80 VDD.t1122 5.99122
R607 VDD.n78 VDD.t1188 5.99122
R608 VDD.n431 VDD.t1479 5.98905
R609 VDD.n428 VDD.t1201 5.98905
R610 VDD.n425 VDD.t1442 5.98905
R611 VDD.n422 VDD.t1429 5.98905
R612 VDD.n419 VDD.t886 5.98905
R613 VDD.n475 VDD.t511 5.9886
R614 VDD.n453 VDD.t491 5.97675
R615 VDD.n453 VDD.t1029 5.97675
R616 VDD.n64 VDD.t1383 5.97212
R617 VDD.n64 VDD.t1360 5.97212
R618 VDD.n195 VDD.t1370 5.97212
R619 VDD.n999 VDD.t1366 5.97212
R620 VDD.n61 VDD.t837 5.97212
R621 VDD.n61 VDD.t868 5.97212
R622 VDD.n207 VDD.t866 5.97212
R623 VDD.n1250 VDD.t462 5.97212
R624 VDD.n58 VDD.t884 5.97212
R625 VDD.n58 VDD.t860 5.97212
R626 VDD.n219 VDD.t858 5.97212
R627 VDD.n1501 VDD.t514 5.97212
R628 VDD.n55 VDD.t1557 5.97212
R629 VDD.n55 VDD.t1418 5.97212
R630 VDD.n231 VDD.t1428 5.97212
R631 VDD.n977 VDD.t1407 5.97212
R632 VDD.n52 VDD.t1294 5.97212
R633 VDD.n52 VDD.t1260 5.97212
R634 VDD.n243 VDD.t1258 5.97212
R635 VDD.n726 VDD.t1307 5.97212
R636 VDD.n64 VDD.t1575 5.97169
R637 VDD.n64 VDD.t842 5.97169
R638 VDD.n195 VDD.t632 5.97169
R639 VDD.n999 VDD.t844 5.97169
R640 VDD.n61 VDD.t1531 5.97169
R641 VDD.n61 VDD.t290 5.97169
R642 VDD.n207 VDD.t695 5.97169
R643 VDD.n1250 VDD.t595 5.97169
R644 VDD.n58 VDD.t529 5.97169
R645 VDD.n58 VDD.t909 5.97169
R646 VDD.n219 VDD.t853 5.97169
R647 VDD.n1501 VDD.t1008 5.97169
R648 VDD.n55 VDD.t1283 5.97169
R649 VDD.n55 VDD.t591 5.97169
R650 VDD.n231 VDD.t542 5.97169
R651 VDD.n977 VDD.t1226 5.97169
R652 VDD.n52 VDD.t537 5.97169
R653 VDD.n52 VDD.t963 5.97169
R654 VDD.n243 VDD.t983 5.97169
R655 VDD.n726 VDD.t1116 5.97169
R656 VDD.n46 VDD.t247 5.97001
R657 VDD.n46 VDD.t18 5.97001
R658 VDD.n46 VDD.t26 5.97001
R659 VDD.n198 VDD.t10 5.97001
R660 VDD.n197 VDD.t9 5.97001
R661 VDD.n11 VDD.t246 5.97001
R662 VDD.n132 VDD.t13 5.97001
R663 VDD.n11 VDD.t1013 5.97001
R664 VDD.n11 VDD.t236 5.97001
R665 VDD.n199 VDD.t1097 5.97001
R666 VDD.n416 VDD.t1096 5.97001
R667 VDD.n13 VDD.t244 5.97001
R668 VDD.n130 VDD.t1100 5.97001
R669 VDD.n13 VDD.t1101 5.97001
R670 VDD.n13 VDD.t1578 5.97001
R671 VDD.n201 VDD.t1038 5.97001
R672 VDD.n200 VDD.t1037 5.97001
R673 VDD.n14 VDD.t981 5.97001
R674 VDD.n128 VDD.t1041 5.97001
R675 VDD.n14 VDD.t19 5.97001
R676 VDD.n14 VDD.t255 5.97001
R677 VDD.n202 VDD.t1313 5.97001
R678 VDD.n415 VDD.t1312 5.97001
R679 VDD.n16 VDD.t242 5.97001
R680 VDD.n126 VDD.t1316 5.97001
R681 VDD.n16 VDD.t252 5.97001
R682 VDD.n16 VDD.t1103 5.97001
R683 VDD.n204 VDD.t258 5.97001
R684 VDD.n203 VDD.t257 5.97001
R685 VDD.n17 VDD.t232 5.97001
R686 VDD.n124 VDD.t261 5.97001
R687 VDD.n17 VDD.t1231 5.97001
R688 VDD.n17 VDD.t197 5.97001
R689 VDD.n205 VDD.t938 5.97001
R690 VDD.n414 VDD.t937 5.97001
R691 VDD.n122 VDD.t941 5.97001
R692 VDD.n47 VDD.t95 5.97001
R693 VDD.n47 VDD.t99 5.97001
R694 VDD.n47 VDD.t98 5.97001
R695 VDD.n210 VDD.t132 5.97001
R696 VDD.n209 VDD.t131 5.97001
R697 VDD.n18 VDD.t222 5.97001
R698 VDD.n121 VDD.t135 5.97001
R699 VDD.n18 VDD.t16 5.97001
R700 VDD.n18 VDD.t15 5.97001
R701 VDD.n211 VDD.t27 5.97001
R702 VDD.n413 VDD.t36 5.97001
R703 VDD.n20 VDD.t1586 5.97001
R704 VDD.n119 VDD.t30 5.97001
R705 VDD.n20 VDD.t39 5.97001
R706 VDD.n20 VDD.t38 5.97001
R707 VDD.n213 VDD.t248 5.97001
R708 VDD.n212 VDD.t167 5.97001
R709 VDD.n21 VDD.t144 5.97001
R710 VDD.n117 VDD.t251 5.97001
R711 VDD.n21 VDD.t1598 5.97001
R712 VDD.n21 VDD.t1597 5.97001
R713 VDD.n214 VDD.t168 5.97001
R714 VDD.n412 VDD.t3 5.97001
R715 VDD.n23 VDD.t266 5.97001
R716 VDD.n115 VDD.t171 5.97001
R717 VDD.n23 VDD.t239 5.97001
R718 VDD.n23 VDD.t238 5.97001
R719 VDD.n216 VDD.t1081 5.97001
R720 VDD.n215 VDD.t1080 5.97001
R721 VDD.n24 VDD.t241 5.97001
R722 VDD.n113 VDD.t1084 5.97001
R723 VDD.n24 VDD.t23 5.97001
R724 VDD.n24 VDD.t22 5.97001
R725 VDD.n217 VDD.t31 5.97001
R726 VDD.n411 VDD.t265 5.97001
R727 VDD.n111 VDD.t34 5.97001
R728 VDD.n48 VDD.t67 5.97001
R729 VDD.n48 VDD.t117 5.97001
R730 VDD.n48 VDD.t147 5.97001
R731 VDD.n222 VDD.t179 5.97001
R732 VDD.n221 VDD.t178 5.97001
R733 VDD.n25 VDD.t157 5.97001
R734 VDD.n110 VDD.t182 5.97001
R735 VDD.n25 VDD.t103 5.97001
R736 VDD.n25 VDD.t60 5.97001
R737 VDD.n223 VDD.t89 5.97001
R738 VDD.n410 VDD.t88 5.97001
R739 VDD.n27 VDD.t156 5.97001
R740 VDD.n108 VDD.t92 5.97001
R741 VDD.n27 VDD.t1585 5.97001
R742 VDD.n27 VDD.t120 5.97001
R743 VDD.n225 VDD.t63 5.97001
R744 VDD.n224 VDD.t62 5.97001
R745 VDD.n28 VDD.t136 5.97001
R746 VDD.n106 VDD.t66 5.97001
R747 VDD.n28 VDD.t183 5.97001
R748 VDD.n28 VDD.t1608 5.97001
R749 VDD.n226 VDD.t123 5.97001
R750 VDD.n409 VDD.t122 5.97001
R751 VDD.n30 VDD.t48 5.97001
R752 VDD.n104 VDD.t126 5.97001
R753 VDD.n30 VDD.t231 5.97001
R754 VDD.n30 VDD.t263 5.97001
R755 VDD.n228 VDD.t81 5.97001
R756 VDD.n227 VDD.t80 5.97001
R757 VDD.n31 VDD.t55 5.97001
R758 VDD.n102 VDD.t84 5.97001
R759 VDD.n31 VDD.t158 5.97001
R760 VDD.n31 VDD.t160 5.97001
R761 VDD.n229 VDD.t44 5.97001
R762 VDD.n408 VDD.t43 5.97001
R763 VDD.n100 VDD.t47 5.97001
R764 VDD.n49 VDD.t209 5.97001
R765 VDD.n49 VDD.t176 5.97001
R766 VDD.n49 VDD.t175 5.97001
R767 VDD.n234 VDD.t112 5.97001
R768 VDD.n233 VDD.t111 5.97001
R769 VDD.n32 VDD.t142 5.97001
R770 VDD.n99 VDD.t115 5.97001
R771 VDD.n32 VDD.t1584 5.97001
R772 VDD.n32 VDD.t1583 5.97001
R773 VDD.n235 VDD.t75 5.97001
R774 VDD.n407 VDD.t74 5.97001
R775 VDD.n34 VDD.t173 5.97001
R776 VDD.n97 VDD.t78 5.97001
R777 VDD.n34 VDD.t140 5.97001
R778 VDD.n34 VDD.t139 5.97001
R779 VDD.n237 VDD.t186 5.97001
R780 VDD.n236 VDD.t185 5.97001
R781 VDD.n35 VDD.t116 5.97001
R782 VDD.n95 VDD.t189 5.97001
R783 VDD.n35 VDD.t71 5.97001
R784 VDD.n35 VDD.t70 5.97001
R785 VDD.n238 VDD.t1589 5.97001
R786 VDD.n406 VDD.t1588 5.97001
R787 VDD.n37 VDD.t51 5.97001
R788 VDD.n93 VDD.t1592 5.97001
R789 VDD.n37 VDD.t1595 5.97001
R790 VDD.n37 VDD.t1594 5.97001
R791 VDD.n240 VDD.t192 5.97001
R792 VDD.n239 VDD.t191 5.97001
R793 VDD.n38 VDD.t165 5.97001
R794 VDD.n91 VDD.t195 5.97001
R795 VDD.n38 VDD.t163 5.97001
R796 VDD.n38 VDD.t162 5.97001
R797 VDD.n241 VDD.t225 5.97001
R798 VDD.n405 VDD.t224 5.97001
R799 VDD.n89 VDD.t228 5.97001
R800 VDD.n50 VDD.t127 5.97001
R801 VDD.n50 VDD.t93 5.97001
R802 VDD.n50 VDD.t54 5.97001
R803 VDD.n246 VDD.t218 5.97001
R804 VDD.n245 VDD.t217 5.97001
R805 VDD.n39 VDD.t57 5.97001
R806 VDD.n88 VDD.t221 5.97001
R807 VDD.n39 VDD.t148 5.97001
R808 VDD.n39 VDD.t202 5.97001
R809 VDD.n247 VDD.t212 5.97001
R810 VDD.n404 VDD.t211 5.97001
R811 VDD.n41 VDD.t267 5.97001
R812 VDD.n86 VDD.t215 5.97001
R813 VDD.n41 VDD.t5 5.97001
R814 VDD.n41 VDD.t199 5.97001
R815 VDD.n249 VDD.t205 5.97001
R816 VDD.n248 VDD.t204 5.97001
R817 VDD.n42 VDD.t101 5.97001
R818 VDD.n84 VDD.t208 5.97001
R819 VDD.n42 VDD.t172 5.97001
R820 VDD.n42 VDD.t230 5.97001
R821 VDD.n250 VDD.t152 5.97001
R822 VDD.n403 VDD.t151 5.97001
R823 VDD.n44 VDD.t85 5.97001
R824 VDD.n82 VDD.t155 5.97001
R825 VDD.n44 VDD.t200 5.97001
R826 VDD.n44 VDD.t1464 5.97001
R827 VDD.n252 VDD.t106 5.97001
R828 VDD.n251 VDD.t105 5.97001
R829 VDD.n45 VDD.t233 5.97001
R830 VDD.n80 VDD.t109 5.97001
R831 VDD.n45 VDD.t128 5.97001
R832 VDD.n45 VDD.t1600 5.97001
R833 VDD.n253 VDD.t1603 5.97001
R834 VDD.n402 VDD.t1602 5.97001
R835 VDD.n78 VDD.t1606 5.97001
R836 VDD.n150 VDD.t720 5.96578
R837 VDD.n184 VDD.t1054 5.96578
R838 VDD.n994 VDD.t1044 5.96578
R839 VDD.n131 VDD.t721 5.96578
R840 VDD.n129 VDD.t719 5.96578
R841 VDD.n151 VDD.t723 5.96578
R842 VDD.n312 VDD.t1579 5.96578
R843 VDD.n133 VDD.t1462 5.96578
R844 VDD.n125 VDD.t722 5.96578
R845 VDD.n123 VDD.t718 5.96578
R846 VDD.n74 VDD.t717 5.96578
R847 VDD.n153 VDD.t1060 5.96578
R848 VDD.n186 VDD.t1491 5.96578
R849 VDD.n1245 VDD.t280 5.96578
R850 VDD.n120 VDD.t1046 5.96578
R851 VDD.n118 VDD.t465 5.96578
R852 VDD.n154 VDD.t1061 5.96578
R853 VDD.n332 VDD.t669 5.96578
R854 VDD.n134 VDD.t466 5.96578
R855 VDD.n114 VDD.t1047 5.96578
R856 VDD.n112 VDD.t1 5.96578
R857 VDD.n70 VDD.t1548 5.96578
R858 VDD.n156 VDD.t1319 5.96578
R859 VDD.n188 VDD.t726 5.96578
R860 VDD.n1496 VDD.t675 5.96578
R861 VDD.n109 VDD.t1302 5.96578
R862 VDD.n107 VDD.t1207 5.96578
R863 VDD.n157 VDD.t1317 5.96578
R864 VDD.n352 VDD.t578 5.96578
R865 VDD.n135 VDD.t1211 5.96578
R866 VDD.n103 VDD.t1303 5.96578
R867 VDD.n101 VDD.t1208 5.96578
R868 VDD.n68 VDD.t1215 5.96578
R869 VDD.n159 VDD.t1509 5.96578
R870 VDD.n190 VDD.t1545 5.96578
R871 VDD.n972 VDD.t484 5.96578
R872 VDD.n98 VDD.t656 5.96578
R873 VDD.n96 VDD.t1511 5.96578
R874 VDD.n160 VDD.t1512 5.96578
R875 VDD.n372 VDD.t580 5.96578
R876 VDD.n136 VDD.t1085 5.96578
R877 VDD.n92 VDD.t657 5.96578
R878 VDD.n90 VDD.t609 5.96578
R879 VDD.n76 VDD.t1051 5.96578
R880 VDD.n162 VDD.t1434 5.96578
R881 VDD.n192 VDD.t678 5.96578
R882 VDD.n721 VDD.t1489 5.96578
R883 VDD.n87 VDD.t698 5.96578
R884 VDD.n85 VDD.t608 5.96578
R885 VDD.n163 VDD.t577 5.96578
R886 VDD.n392 VDD.t1001 5.96578
R887 VDD.n137 VDD.t660 5.96578
R888 VDD.n81 VDD.t699 5.96578
R889 VDD.n79 VDD.t623 5.96578
R890 VDD.n72 VDD.t916 5.96578
R891 VDD.n184 VDD.t1358 5.96534
R892 VDD.n994 VDD.t1424 5.96534
R893 VDD.n431 VDD.t1224 5.96534
R894 VDD.n992 VDD.t997 5.96534
R895 VDD.n990 VDD.t952 5.96534
R896 VDD.n1001 VDD.t497 5.96534
R897 VDD.n149 VDD.t647 5.96534
R898 VDD.n150 VDD.t653 5.96534
R899 VDD.n46 VDD.t688 5.96534
R900 VDD.n46 VDD.t1072 5.96534
R901 VDD.n432 VDD.t1549 5.96534
R902 VDD.n197 VDD.t949 5.96534
R903 VDD.n132 VDD.t649 5.96534
R904 VDD.n132 VDD.t870 5.96534
R905 VDD.n131 VDD.t585 5.96534
R906 VDD.n11 VDD.t616 5.96534
R907 VDD.n11 VDD.t500 5.96534
R908 VDD.n433 VDD.t1153 5.96534
R909 VDD.n416 VDD.t496 5.96534
R910 VDD.n130 VDD.t650 5.96534
R911 VDD.n130 VDD.t1111 5.96534
R912 VDD.n129 VDD.t586 5.96534
R913 VDD.n13 VDD.t1151 5.96534
R914 VDD.n13 VDD.t1075 5.96534
R915 VDD.n12 VDD.t1109 5.96534
R916 VDD.n200 VDD.t498 5.96534
R917 VDD.n128 VDD.t654 5.96534
R918 VDD.n128 VDD.t1158 5.96534
R919 VDD.n133 VDD.t581 5.96534
R920 VDD.n133 VDD.t954 5.96534
R921 VDD.n1009 VDD.t1077 5.96534
R922 VDD.n312 VDD.t1165 5.96534
R923 VDD.n1007 VDD.t494 5.96534
R924 VDD.n299 VDD.t1114 5.96534
R925 VDD.n1005 VDD.t648 5.96534
R926 VDD.n1003 VDD.t1163 5.96534
R927 VDD.n151 VDD.t584 5.96534
R928 VDD.n14 VDD.t555 5.96534
R929 VDD.n14 VDD.t583 5.96534
R930 VDD.n434 VDD.t1117 5.96534
R931 VDD.n415 VDD.t495 5.96534
R932 VDD.n126 VDD.t651 5.96534
R933 VDD.n126 VDD.t1248 5.96534
R934 VDD.n125 VDD.t587 5.96534
R935 VDD.n16 VDD.t643 5.96534
R936 VDD.n16 VDD.t1076 5.96534
R937 VDD.n15 VDD.t1253 5.96534
R938 VDD.n203 VDD.t499 5.96534
R939 VDD.n124 VDD.t655 5.96534
R940 VDD.n124 VDD.t1278 5.96534
R941 VDD.n123 VDD.t582 5.96534
R942 VDD.n17 VDD.t689 5.96534
R943 VDD.n17 VDD.t1078 5.96534
R944 VDD.n435 VDD.t1281 5.96534
R945 VDD.n414 VDD.t948 5.96534
R946 VDD.n122 VDD.t964 5.96534
R947 VDD.n122 VDD.t1285 5.96534
R948 VDD.n74 VDD.t652 5.96534
R949 VDD.n74 VDD.t893 5.96534
R950 VDD.n186 VDD.t1477 5.96534
R951 VDD.n1245 VDD.t1179 5.96534
R952 VDD.n428 VDD.t1019 5.96534
R953 VDD.n1243 VDD.t1235 5.96534
R954 VDD.n1241 VDD.t696 5.96534
R955 VDD.n1252 VDD.t1232 5.96534
R956 VDD.n152 VDD.t482 5.96534
R957 VDD.n153 VDD.t988 5.96534
R958 VDD.n47 VDD.t737 5.96534
R959 VDD.n47 VDD.t1056 5.96534
R960 VDD.n436 VDD.t735 5.96534
R961 VDD.n209 VDD.t1242 5.96534
R962 VDD.n121 VDD.t985 5.96534
R963 VDD.n121 VDD.t827 5.96534
R964 VDD.n120 VDD.t966 5.96534
R965 VDD.n18 VDD.t636 5.96534
R966 VDD.n18 VDD.t1240 5.96534
R967 VDD.n437 VDD.t560 5.96534
R968 VDD.n413 VDD.t1238 5.96534
R969 VDD.n119 VDD.t986 5.96534
R970 VDD.n119 VDD.t1536 5.96534
R971 VDD.n118 VDD.t967 5.96534
R972 VDD.n20 VDD.t662 5.96534
R973 VDD.n20 VDD.t1058 5.96534
R974 VDD.n19 VDD.t544 5.96534
R975 VDD.n212 VDD.t1233 5.96534
R976 VDD.n117 VDD.t990 5.96534
R977 VDD.n117 VDD.t567 5.96534
R978 VDD.n134 VDD.t1093 5.96534
R979 VDD.n134 VDD.t277 5.96534
R980 VDD.n1260 VDD.t1304 5.96534
R981 VDD.n332 VDD.t610 5.96534
R982 VDD.n1258 VDD.t1236 5.96534
R983 VDD.n297 VDD.t288 5.96534
R984 VDD.n1256 VDD.t984 5.96534
R985 VDD.n1254 VDD.t1569 5.96534
R986 VDD.n154 VDD.t965 5.96534
R987 VDD.n21 VDD.t530 5.96534
R988 VDD.n21 VDD.t1241 5.96534
R989 VDD.n438 VDD.t479 5.96534
R990 VDD.n412 VDD.t1237 5.96534
R991 VDD.n115 VDD.t987 5.96534
R992 VDD.n115 VDD.t574 5.96534
R993 VDD.n114 VDD.t968 5.96534
R994 VDD.n23 VDD.t1152 5.96534
R995 VDD.n23 VDD.t1059 5.96534
R996 VDD.n22 VDD.t856 5.96534
R997 VDD.n215 VDD.t1234 5.96534
R998 VDD.n113 VDD.t991 5.96534
R999 VDD.n113 VDD.t1580 5.96534
R1000 VDD.n112 VDD.t1094 5.96534
R1001 VDD.n24 VDD.t467 5.96534
R1002 VDD.n24 VDD.t1305 5.96534
R1003 VDD.n439 VDD.t683 5.96534
R1004 VDD.n411 VDD.t1243 5.96534
R1005 VDD.n111 VDD.t1239 5.96534
R1006 VDD.n111 VDD.t597 5.96534
R1007 VDD.n70 VDD.t989 5.96534
R1008 VDD.n70 VDD.t733 5.96534
R1009 VDD.n188 VDD.t571 5.96534
R1010 VDD.n1496 VDD.t1437 5.96534
R1011 VDD.n425 VDD.t486 5.96534
R1012 VDD.n1494 VDD.t713 5.96534
R1013 VDD.n1492 VDD.t825 5.96534
R1014 VDD.n1503 VDD.t1506 5.96534
R1015 VDD.n155 VDD.t505 5.96534
R1016 VDD.n156 VDD.t1104 5.96534
R1017 VDD.n48 VDD.t276 5.96534
R1018 VDD.n48 VDD.t1193 5.96534
R1019 VDD.n440 VDD.t637 5.96534
R1020 VDD.n221 VDD.t478 5.96534
R1021 VDD.n110 VDD.t709 5.96534
R1022 VDD.n110 VDD.t742 5.96534
R1023 VDD.n109 VDD.t945 5.96534
R1024 VDD.n25 VDD.t547 5.96534
R1025 VDD.n25 VDD.t927 5.96534
R1026 VDD.n441 VDD.t473 5.96534
R1027 VDD.n410 VDD.t716 5.96534
R1028 VDD.n108 VDD.t710 5.96534
R1029 VDD.n108 VDD.t848 5.96534
R1030 VDD.n107 VDD.t946 5.96534
R1031 VDD.n27 VDD.t579 5.96534
R1032 VDD.n27 VDD.t1195 5.96534
R1033 VDD.n26 VDD.t666 5.96534
R1034 VDD.n224 VDD.t1507 5.96534
R1035 VDD.n106 VDD.t1105 5.96534
R1036 VDD.n106 VDD.t905 5.96534
R1037 VDD.n135 VDD.t956 5.96534
R1038 VDD.n135 VDD.t1030 5.96534
R1039 VDD.n1511 VDD.t1199 5.96534
R1040 VDD.n352 VDD.t561 5.96534
R1041 VDD.n1509 VDD.t714 5.96534
R1042 VDD.n295 VDD.t645 5.96534
R1043 VDD.n1507 VDD.t708 5.96534
R1044 VDD.n1505 VDD.t1009 5.96534
R1045 VDD.n157 VDD.t944 5.96534
R1046 VDD.n28 VDD.t1510 5.96534
R1047 VDD.n28 VDD.t618 5.96534
R1048 VDD.n442 VDD.t704 5.96534
R1049 VDD.n409 VDD.t715 5.96534
R1050 VDD.n104 VDD.t711 5.96534
R1051 VDD.n104 VDD.t828 5.96534
R1052 VDD.n103 VDD.t947 5.96534
R1053 VDD.n30 VDD.t619 5.96534
R1054 VDD.n30 VDD.t1196 5.96534
R1055 VDD.n29 VDD.t558 5.96534
R1056 VDD.n227 VDD.t1508 5.96534
R1057 VDD.n102 VDD.t1106 5.96534
R1058 VDD.n102 VDD.t510 5.96534
R1059 VDD.n101 VDD.t957 5.96534
R1060 VDD.n31 VDD.t516 5.96534
R1061 VDD.n31 VDD.t1200 5.96534
R1062 VDD.n443 VDD.t527 5.96534
R1063 VDD.n408 VDD.t477 5.96534
R1064 VDD.n100 VDD.t1505 5.96534
R1065 VDD.n100 VDD.t639 5.96534
R1066 VDD.n68 VDD.t712 5.96534
R1067 VDD.n68 VDD.t641 5.96534
R1068 VDD.n190 VDD.t507 5.96534
R1069 VDD.n972 VDD.t1538 5.96534
R1070 VDD.n422 VDD.t1287 5.96534
R1071 VDD.n970 VDD.t1062 5.96534
R1072 VDD.n968 VDD.t1286 5.96534
R1073 VDD.n979 VDD.t1310 5.96534
R1074 VDD.n158 VDD.t1347 5.96534
R1075 VDD.n159 VDD.t475 5.96534
R1076 VDD.n49 VDD.t1050 5.96534
R1077 VDD.n49 VDD.t1308 5.96534
R1078 VDD.n444 VDD.t1354 5.96534
R1079 VDD.n233 VDD.t1458 5.96534
R1080 VDD.n99 VDD.t1090 5.96534
R1081 VDD.n99 VDD.t1361 5.96534
R1082 VDD.n98 VDD.t1071 5.96534
R1083 VDD.n32 VDD.t994 5.96534
R1084 VDD.n32 VDD.t1461 5.96534
R1085 VDD.n445 VDD.t1374 5.96534
R1086 VDD.n407 VDD.t1065 5.96534
R1087 VDD.n97 VDD.t1091 5.96534
R1088 VDD.n97 VDD.t1367 5.96534
R1089 VDD.n96 VDD.t531 5.96534
R1090 VDD.n34 VDD.t1289 5.96534
R1091 VDD.n34 VDD.t995 5.96534
R1092 VDD.n33 VDD.t1392 5.96534
R1093 VDD.n236 VDD.t917 5.96534
R1094 VDD.n95 VDD.t501 5.96534
R1095 VDD.n95 VDD.t1558 5.96534
R1096 VDD.n136 VDD.t1229 5.96534
R1097 VDD.n136 VDD.t1404 5.96534
R1098 VDD.n987 VDD.t633 5.96534
R1099 VDD.n372 VDD.t1402 5.96534
R1100 VDD.n985 VDD.t1063 5.96534
R1101 VDD.n293 VDD.t970 5.96534
R1102 VDD.n983 VDD.t1089 5.96534
R1103 VDD.n981 VDD.t1400 5.96534
R1104 VDD.n160 VDD.t1070 5.96534
R1105 VDD.n35 VDD.t1055 5.96534
R1106 VDD.n35 VDD.t1068 5.96534
R1107 VDD.n446 VDD.t1419 5.96534
R1108 VDD.n406 VDD.t1064 5.96534
R1109 VDD.n93 VDD.t1092 5.96534
R1110 VDD.n93 VDD.t1423 5.96534
R1111 VDD.n92 VDD.t532 5.96534
R1112 VDD.n37 VDD.t959 5.96534
R1113 VDD.n37 VDD.t996 5.96534
R1114 VDD.n36 VDD.t1247 5.96534
R1115 VDD.n239 VDD.t918 5.96534
R1116 VDD.n91 VDD.t502 5.96534
R1117 VDD.n91 VDD.t951 5.96534
R1118 VDD.n90 VDD.t1230 5.96534
R1119 VDD.n38 VDD.t971 5.96534
R1120 VDD.n38 VDD.t634 5.96534
R1121 VDD.n447 VDD.t904 5.96534
R1122 VDD.n405 VDD.t1457 5.96534
R1123 VDD.n89 VDD.t943 5.96534
R1124 VDD.n89 VDD.t1270 5.96534
R1125 VDD.n76 VDD.t476 5.96534
R1126 VDD.n76 VDD.t588 5.96534
R1127 VDD.n192 VDD.t1480 5.96534
R1128 VDD.n721 VDD.t471 5.96534
R1129 VDD.n419 VDD.t1110 5.96534
R1130 VDD.n719 VDD.t659 5.96534
R1131 VDD.n717 VDD.t1107 5.96534
R1132 VDD.n728 VDD.t1087 5.96534
R1133 VDD.n161 VDD.t919 5.96534
R1134 VDD.n162 VDD.t1397 5.96534
R1135 VDD.n50 VDD.t538 5.96534
R1136 VDD.n50 VDD.t598 5.96534
R1137 VDD.n448 VDD.t1175 5.96534
R1138 VDD.n245 VDD.t1431 5.96534
R1139 VDD.n88 VDD.t1172 5.96534
R1140 VDD.n88 VDD.t832 5.96534
R1141 VDD.n87 VDD.t1066 5.96534
R1142 VDD.n39 VDD.t551 5.96534
R1143 VDD.n39 VDD.t1049 5.96534
R1144 VDD.n449 VDD.t922 5.96534
R1145 VDD.n404 VDD.t1033 5.96534
R1146 VDD.n86 VDD.t605 5.96534
R1147 VDD.n86 VDD.t888 5.96534
R1148 VDD.n85 VDD.t1067 5.96534
R1149 VDD.n41 VDD.t602 5.96534
R1150 VDD.n41 VDD.t492 5.96534
R1151 VDD.n40 VDD.t973 5.96534
R1152 VDD.n248 VDD.t1088 5.96534
R1153 VDD.n84 VDD.t1073 5.96534
R1154 VDD.n84 VDD.t976 5.96534
R1155 VDD.n137 VDD.t1456 5.96534
R1156 VDD.n137 VDD.t457 5.96534
R1157 VDD.n736 VDD.t1459 5.96534
R1158 VDD.n392 VDD.t628 5.96534
R1159 VDD.n734 VDD.t658 5.96534
R1160 VDD.n291 VDD.t925 5.96534
R1161 VDD.n732 VDD.t604 5.96534
R1162 VDD.n730 VDD.t630 5.96534
R1163 VDD.n163 VDD.t1394 5.96534
R1164 VDD.n42 VDD.t1186 5.96534
R1165 VDD.n42 VDD.t1086 5.96534
R1166 VDD.n450 VDD.t615 5.96534
R1167 VDD.n403 VDD.t1034 5.96534
R1168 VDD.n82 VDD.t1048 5.96534
R1169 VDD.n82 VDD.t978 5.96534
R1170 VDD.n81 VDD.t1020 5.96534
R1171 VDD.n44 VDD.t534 5.96534
R1172 VDD.n44 VDD.t493 5.96534
R1173 VDD.n43 VDD.t834 5.96534
R1174 VDD.n251 VDD.t1573 5.96534
R1175 VDD.n80 VDD.t1410 5.96534
R1176 VDD.n80 VDD.t1499 5.96534
R1177 VDD.n79 VDD.t1069 5.96534
R1178 VDD.n45 VDD.t565 5.96534
R1179 VDD.n45 VDD.t1460 5.96534
R1180 VDD.n451 VDD.t890 5.96534
R1181 VDD.n402 VDD.t705 5.96534
R1182 VDD.n78 VDD.t283 5.96534
R1183 VDD.n78 VDD.t932 5.96534
R1184 VDD.n72 VDD.t1398 5.96534
R1185 VDD.n72 VDD.t460 5.96534
R1186 VDD.n473 VDD.t875 5.96478
R1187 VDD.n46 VDD.t25 5.65005
R1188 VDD.n302 VDD.t8 5.65005
R1189 VDD.n132 VDD.t11 5.65005
R1190 VDD.n11 VDD.t235 5.65005
R1191 VDD.n305 VDD.t1014 5.65005
R1192 VDD.n130 VDD.t1098 5.65005
R1193 VDD.n13 VDD.t245 5.65005
R1194 VDD.n308 VDD.t1036 5.65005
R1195 VDD.n128 VDD.t1039 5.65005
R1196 VDD.n14 VDD.t254 5.65005
R1197 VDD.n313 VDD.t20 5.65005
R1198 VDD.n126 VDD.t1314 5.65005
R1199 VDD.n16 VDD.t243 5.65005
R1200 VDD.n316 VDD.t253 5.65005
R1201 VDD.n124 VDD.t259 5.65005
R1202 VDD.n17 VDD.t196 5.65005
R1203 VDD.n319 VDD.t936 5.65005
R1204 VDD.n122 VDD.t939 5.65005
R1205 VDD.n47 VDD.t96 5.65005
R1206 VDD.n322 VDD.t100 5.65005
R1207 VDD.n121 VDD.t133 5.65005
R1208 VDD.n18 VDD.t14 5.65005
R1209 VDD.n325 VDD.t17 5.65005
R1210 VDD.n119 VDD.t28 5.65005
R1211 VDD.n20 VDD.t37 5.65005
R1212 VDD.n328 VDD.t40 5.65005
R1213 VDD.n117 VDD.t249 5.65005
R1214 VDD.n21 VDD.t145 5.65005
R1215 VDD.n333 VDD.t2 5.65005
R1216 VDD.n115 VDD.t169 5.65005
R1217 VDD.n23 VDD.t237 5.65005
R1218 VDD.n336 VDD.t240 5.65005
R1219 VDD.n113 VDD.t1082 5.65005
R1220 VDD.n24 VDD.t21 5.65005
R1221 VDD.n339 VDD.t24 5.65005
R1222 VDD.n111 VDD.t32 5.65005
R1223 VDD.n48 VDD.t68 5.65005
R1224 VDD.n342 VDD.t118 5.65005
R1225 VDD.n110 VDD.t180 5.65005
R1226 VDD.n25 VDD.t59 5.65005
R1227 VDD.n345 VDD.t87 5.65005
R1228 VDD.n108 VDD.t90 5.65005
R1229 VDD.n27 VDD.t119 5.65005
R1230 VDD.n348 VDD.t61 5.65005
R1231 VDD.n106 VDD.t64 5.65005
R1232 VDD.n28 VDD.t137 5.65005
R1233 VDD.n353 VDD.t121 5.65005
R1234 VDD.n104 VDD.t124 5.65005
R1235 VDD.n30 VDD.t49 5.65005
R1236 VDD.n356 VDD.t79 5.65005
R1237 VDD.n102 VDD.t82 5.65005
R1238 VDD.n31 VDD.t56 5.65005
R1239 VDD.n359 VDD.t42 5.65005
R1240 VDD.n100 VDD.t45 5.65005
R1241 VDD.n49 VDD.t174 5.65005
R1242 VDD.n362 VDD.t110 5.65005
R1243 VDD.n99 VDD.t113 5.65005
R1244 VDD.n32 VDD.t143 5.65005
R1245 VDD.n365 VDD.t73 5.65005
R1246 VDD.n97 VDD.t76 5.65005
R1247 VDD.n34 VDD.t138 5.65005
R1248 VDD.n368 VDD.t141 5.65005
R1249 VDD.n95 VDD.t187 5.65005
R1250 VDD.n35 VDD.t69 5.65005
R1251 VDD.n373 VDD.t72 5.65005
R1252 VDD.n93 VDD.t1590 5.65005
R1253 VDD.n37 VDD.t52 5.65005
R1254 VDD.n376 VDD.t190 5.65005
R1255 VDD.n91 VDD.t193 5.65005
R1256 VDD.n38 VDD.t161 5.65005
R1257 VDD.n379 VDD.t164 5.65005
R1258 VDD.n89 VDD.t226 5.65005
R1259 VDD.n50 VDD.t53 5.65005
R1260 VDD.n382 VDD.t94 5.65005
R1261 VDD.n88 VDD.t219 5.65005
R1262 VDD.n39 VDD.t58 5.65005
R1263 VDD.n385 VDD.t149 5.65005
R1264 VDD.n86 VDD.t213 5.65005
R1265 VDD.n41 VDD.t198 5.65005
R1266 VDD.n388 VDD.t6 5.65005
R1267 VDD.n84 VDD.t206 5.65005
R1268 VDD.n42 VDD.t102 5.65005
R1269 VDD.n393 VDD.t150 5.65005
R1270 VDD.n82 VDD.t153 5.65005
R1271 VDD.n44 VDD.t86 5.65005
R1272 VDD.n396 VDD.t104 5.65005
R1273 VDD.n80 VDD.t107 5.65005
R1274 VDD.n45 VDD.t234 5.65005
R1275 VDD.n399 VDD.t129 5.65005
R1276 VDD.n78 VDD.t1604 5.65005
R1277 VDD.t268 VDD.n1748 5.62581
R1278 VDD.t268 VDD.n1746 5.62581
R1279 VDD.t7 VDD.n1002 5.62581
R1280 VDD.t7 VDD.n1000 5.62581
R1281 VDD.t7 VDD.n993 5.62581
R1282 VDD.n179 VDD.n997 0.160419
R1283 VDD.n65 VDD.n64 0.134613
R1284 VDD.n1004 VDD.t7 5.62581
R1285 VDD.n298 VDD.t7 1.79705
R1286 VDD.n1006 VDD.t7 5.62581
R1287 VDD.n1008 VDD.t7 5.62581
R1288 VDD.t399 VDD.n1045 5.62581
R1289 VDD.t399 VDD.n1051 5.62581
R1290 VDD.t399 VDD.n1057 5.62581
R1291 VDD.t399 VDD.n1063 5.62581
R1292 VDD.t399 VDD.n1069 5.62581
R1293 VDD.t399 VDD.n1075 5.62581
R1294 VDD.t399 VDD.n1081 5.62581
R1295 VDD.t399 VDD.n1087 5.62581
R1296 VDD.t399 VDD.n1093 5.62581
R1297 VDD.t399 VDD.n1099 5.62581
R1298 VDD.t399 VDD.n1105 5.62581
R1299 VDD.t399 VDD.n1111 5.62581
R1300 VDD.t399 VDD.n1117 5.62581
R1301 VDD.t399 VDD.n1123 5.62581
R1302 VDD.t399 VDD.n1129 5.62581
R1303 VDD.t399 VDD.n1135 5.62581
R1304 VDD.t399 VDD.n1141 5.62581
R1305 VDD.t399 VDD.n1147 5.62581
R1306 VDD.t399 VDD.n1153 5.62581
R1307 VDD.t399 VDD.n1159 5.62581
R1308 VDD.t399 VDD.n1165 5.62581
R1309 VDD.t399 VDD.n1171 5.62581
R1310 VDD.t399 VDD.n1177 5.62581
R1311 VDD.t399 VDD.n1183 5.62581
R1312 VDD.t399 VDD.n1189 5.62581
R1313 VDD.t399 VDD.n1195 5.62581
R1314 VDD.t399 VDD.n1201 5.62581
R1315 VDD.t399 VDD.n1207 5.62581
R1316 VDD.t399 VDD.n1213 5.62581
R1317 VDD.t399 VDD.n1219 5.62581
R1318 VDD.t399 VDD.n1225 5.62581
R1319 VDD.t399 VDD.n1231 5.62581
R1320 VDD.t399 VDD.n1233 5.62581
R1321 VDD.t0 VDD.n1253 5.62581
R1322 VDD.t0 VDD.n1251 5.62581
R1323 VDD.t0 VDD.n1244 5.62581
R1324 VDD.n180 VDD.n1248 0.160419
R1325 VDD.n62 VDD.n61 0.134613
R1326 VDD.n1255 VDD.t0 5.62581
R1327 VDD.n296 VDD.t0 1.79705
R1328 VDD.n1257 VDD.t0 5.62581
R1329 VDD.n1259 VDD.t0 5.62581
R1330 VDD.t281 VDD.n1296 5.62581
R1331 VDD.t281 VDD.n1302 5.62581
R1332 VDD.t281 VDD.n1308 5.62581
R1333 VDD.t281 VDD.n1314 5.62581
R1334 VDD.t281 VDD.n1320 5.62581
R1335 VDD.t281 VDD.n1326 5.62581
R1336 VDD.t281 VDD.n1332 5.62581
R1337 VDD.t281 VDD.n1338 5.62581
R1338 VDD.t281 VDD.n1344 5.62581
R1339 VDD.t281 VDD.n1350 5.62581
R1340 VDD.t281 VDD.n1356 5.62581
R1341 VDD.t281 VDD.n1362 5.62581
R1342 VDD.t281 VDD.n1368 5.62581
R1343 VDD.t281 VDD.n1374 5.62581
R1344 VDD.t281 VDD.n1380 5.62581
R1345 VDD.t281 VDD.n1386 5.62581
R1346 VDD.t281 VDD.n1392 5.62581
R1347 VDD.t281 VDD.n1398 5.62581
R1348 VDD.t281 VDD.n1404 5.62581
R1349 VDD.t281 VDD.n1410 5.62581
R1350 VDD.t281 VDD.n1416 5.62581
R1351 VDD.t281 VDD.n1422 5.62581
R1352 VDD.t281 VDD.n1428 5.62581
R1353 VDD.t281 VDD.n1434 5.62581
R1354 VDD.t281 VDD.n1440 5.62581
R1355 VDD.t281 VDD.n1446 5.62581
R1356 VDD.t281 VDD.n1452 5.62581
R1357 VDD.t281 VDD.n1458 5.62581
R1358 VDD.t281 VDD.n1464 5.62581
R1359 VDD.t281 VDD.n1470 5.62581
R1360 VDD.t281 VDD.n1476 5.62581
R1361 VDD.t281 VDD.n1482 5.62581
R1362 VDD.t281 VDD.n1484 5.62581
R1363 VDD.t41 VDD.n1504 5.62581
R1364 VDD.t41 VDD.n1502 5.62581
R1365 VDD.t41 VDD.n1495 5.62581
R1366 VDD.n181 VDD.n1499 0.160419
R1367 VDD.n59 VDD.n58 0.134613
R1368 VDD.n1506 VDD.t41 5.62581
R1369 VDD.n294 VDD.t41 1.79705
R1370 VDD.n1508 VDD.t41 5.62581
R1371 VDD.n1510 VDD.t41 5.62581
R1372 VDD.t275 VDD.n1547 5.62581
R1373 VDD.t275 VDD.n1553 5.62581
R1374 VDD.t275 VDD.n1559 5.62581
R1375 VDD.t275 VDD.n1565 5.62581
R1376 VDD.t275 VDD.n1571 5.62581
R1377 VDD.t275 VDD.n1577 5.62581
R1378 VDD.t275 VDD.n1583 5.62581
R1379 VDD.t275 VDD.n1589 5.62581
R1380 VDD.t275 VDD.n1595 5.62581
R1381 VDD.t275 VDD.n1601 5.62581
R1382 VDD.t275 VDD.n1607 5.62581
R1383 VDD.t275 VDD.n1613 5.62581
R1384 VDD.t275 VDD.n1619 5.62581
R1385 VDD.t275 VDD.n1625 5.62581
R1386 VDD.t275 VDD.n1631 5.62581
R1387 VDD.t275 VDD.n1637 5.62581
R1388 VDD.t275 VDD.n1643 5.62581
R1389 VDD.t275 VDD.n1649 5.62581
R1390 VDD.t275 VDD.n1655 5.62581
R1391 VDD.t275 VDD.n1661 5.62581
R1392 VDD.t275 VDD.n1667 5.62581
R1393 VDD.t275 VDD.n1673 5.62581
R1394 VDD.t275 VDD.n1679 5.62581
R1395 VDD.t275 VDD.n1685 5.62581
R1396 VDD.t275 VDD.n1691 5.62581
R1397 VDD.t275 VDD.n1697 5.62581
R1398 VDD.t275 VDD.n1703 5.62581
R1399 VDD.t275 VDD.n1709 5.62581
R1400 VDD.t275 VDD.n1715 5.62581
R1401 VDD.t275 VDD.n1721 5.62581
R1402 VDD.t275 VDD.n1727 5.62581
R1403 VDD.t275 VDD.n1733 5.62581
R1404 VDD.t275 VDD.n1735 5.62581
R1405 VDD.t50 VDD.n980 5.62581
R1406 VDD.t50 VDD.n978 5.62581
R1407 VDD.t50 VDD.n971 5.62581
R1408 VDD.n182 VDD.n975 0.160419
R1409 VDD.t50 VDD.n56 1.07426
R1410 VDD.n982 VDD.t50 5.62581
R1411 VDD.n292 VDD.t50 1.79705
R1412 VDD.n984 VDD.t50 5.62581
R1413 VDD.n986 VDD.t50 5.62581
R1414 VDD.t301 VDD.n772 5.62581
R1415 VDD.t301 VDD.n778 5.62581
R1416 VDD.t301 VDD.n784 5.62581
R1417 VDD.t301 VDD.n790 5.62581
R1418 VDD.t301 VDD.n796 5.62581
R1419 VDD.t301 VDD.n802 5.62581
R1420 VDD.t301 VDD.n808 5.62581
R1421 VDD.t301 VDD.n814 5.62581
R1422 VDD.t301 VDD.n820 5.62581
R1423 VDD.t301 VDD.n826 5.62581
R1424 VDD.t301 VDD.n832 5.62581
R1425 VDD.t301 VDD.n838 5.62581
R1426 VDD.t301 VDD.n844 5.62581
R1427 VDD.t301 VDD.n850 5.62581
R1428 VDD.t301 VDD.n856 5.62581
R1429 VDD.t301 VDD.n862 5.62581
R1430 VDD.t301 VDD.n868 5.62581
R1431 VDD.t301 VDD.n874 5.62581
R1432 VDD.t301 VDD.n880 5.62581
R1433 VDD.t301 VDD.n886 5.62581
R1434 VDD.t301 VDD.n892 5.62581
R1435 VDD.t301 VDD.n898 5.62581
R1436 VDD.t301 VDD.n904 5.62581
R1437 VDD.t301 VDD.n910 5.62581
R1438 VDD.t301 VDD.n916 5.62581
R1439 VDD.t301 VDD.n922 5.62581
R1440 VDD.t301 VDD.n928 5.62581
R1441 VDD.t301 VDD.n934 5.62581
R1442 VDD.t301 VDD.n940 5.62581
R1443 VDD.t301 VDD.n946 5.62581
R1444 VDD.t301 VDD.n952 5.62581
R1445 VDD.t301 VDD.n958 5.62581
R1446 VDD.t301 VDD.n960 5.62581
R1447 VDD.t4 VDD.n729 5.62581
R1448 VDD.t4 VDD.n727 5.62581
R1449 VDD.t4 VDD.n720 5.62581
R1450 VDD.n183 VDD.n724 0.160419
R1451 VDD.t4 VDD.n53 1.07426
R1452 VDD.n731 VDD.t4 5.62581
R1453 VDD.n290 VDD.t4 1.79705
R1454 VDD.n733 VDD.t4 5.62581
R1455 VDD.n735 VDD.t4 5.62581
R1456 VDD.t297 VDD.n712 5.62581
R1457 VDD.t297 VDD.n706 5.62581
R1458 VDD.t297 VDD.n700 5.62581
R1459 VDD.t297 VDD.n694 5.62581
R1460 VDD.t297 VDD.n688 5.62581
R1461 VDD.t297 VDD.n682 5.62581
R1462 VDD.t297 VDD.n676 5.62581
R1463 VDD.t297 VDD.n670 5.62581
R1464 VDD.t297 VDD.n664 5.62581
R1465 VDD.t297 VDD.n658 5.62581
R1466 VDD.t297 VDD.n652 5.62581
R1467 VDD.t297 VDD.n646 5.62581
R1468 VDD.t297 VDD.n640 5.62581
R1469 VDD.t297 VDD.n634 5.62581
R1470 VDD.t297 VDD.n628 5.62581
R1471 VDD.t297 VDD.n622 5.62581
R1472 VDD.t297 VDD.n616 5.62581
R1473 VDD.t297 VDD.n610 5.62581
R1474 VDD.t297 VDD.n604 5.62581
R1475 VDD.t297 VDD.n598 5.62581
R1476 VDD.t297 VDD.n592 5.62581
R1477 VDD.t297 VDD.n586 5.62581
R1478 VDD.t297 VDD.n580 5.62581
R1479 VDD.t297 VDD.n574 5.62581
R1480 VDD.t297 VDD.n568 5.62581
R1481 VDD.t297 VDD.n562 5.62581
R1482 VDD.t297 VDD.n556 5.62581
R1483 VDD.t297 VDD.n550 5.62581
R1484 VDD.t297 VDD.n544 5.62581
R1485 VDD.t297 VDD.n538 5.62581
R1486 VDD.t297 VDD.n532 5.62581
R1487 VDD.t297 VDD.n526 5.62581
R1488 VDD.t297 VDD.n524 5.62581
R1489 VDD.t270 VDD.n470 5.61485
R1490 VDD.t270 VDD.n474 5.61485
R1491 VDD.n6 VDD.t811 5.7457
R1492 VDD.n0 VDD.t800 5.7457
R1493 VDD.n3 VDD.t789 5.7457
R1494 VDD.n144 VDD.t756 5.7457
R1495 VDD.n145 VDD.t745 5.72944
R1496 VDD.n457 VDD.t779 5.60969
R1497 VDD.n458 VDD.t784 5.60969
R1498 VDD.n7 VDD.t814 5.71623
R1499 VDD.n1 VDD.t803 5.71623
R1500 VDD.n4 VDD.t792 5.71623
R1501 VDD.n9 VDD.t759 5.71623
R1502 VDD.n146 VDD.t748 5.60347
R1503 VDD.n1236 VDD.t820 5.60347
R1504 VDD.n263 VDD.t817 5.60347
R1505 VDD.n1487 VDD.t809 5.60347
R1506 VDD.n267 VDD.t806 5.60347
R1507 VDD.n1738 VDD.t798 5.60347
R1508 VDD.n271 VDD.t795 5.60347
R1509 VDD.n963 VDD.t765 5.60347
R1510 VDD.n275 VDD.t762 5.60347
R1511 VDD.n521 VDD.t754 5.60347
R1512 VDD.n277 VDD.t751 5.60347
R1513 VDD.n138 VDD.t782 5.60347
R1514 VDD.n460 VDD.t787 5.60347
R1515 VDD.n1043 VDD.t404 5.59675
R1516 VDD.n1049 VDD.t430 5.59675
R1517 VDD.n1055 VDD.t429 5.59675
R1518 VDD.n1061 VDD.t400 5.59675
R1519 VDD.n1067 VDD.t402 5.59675
R1520 VDD.n1073 VDD.t438 5.59675
R1521 VDD.n1079 VDD.t432 5.59675
R1522 VDD.n1085 VDD.t439 5.59675
R1523 VDD.n1091 VDD.t431 5.59675
R1524 VDD.n1097 VDD.t441 5.59675
R1525 VDD.n1103 VDD.t440 5.59675
R1526 VDD.n1109 VDD.t401 5.59675
R1527 VDD.n1115 VDD.t403 5.59675
R1528 VDD.n1121 VDD.t442 5.59675
R1529 VDD.n1127 VDD.t444 5.59675
R1530 VDD.n1133 VDD.t443 5.59675
R1531 VDD.n1139 VDD.t437 5.59675
R1532 VDD.n1145 VDD.t450 5.59675
R1533 VDD.n1151 VDD.t447 5.59675
R1534 VDD.n1157 VDD.t434 5.59675
R1535 VDD.n1163 VDD.t435 5.59675
R1536 VDD.n1169 VDD.t451 5.59675
R1537 VDD.n1175 VDD.t452 5.59675
R1538 VDD.n1181 VDD.t453 5.59675
R1539 VDD.n1187 VDD.t449 5.59675
R1540 VDD.n1193 VDD.t454 5.59675
R1541 VDD.n1199 VDD.t436 5.59675
R1542 VDD.n1205 VDD.t433 5.59675
R1543 VDD.n1211 VDD.t448 5.59675
R1544 VDD.n1217 VDD.t455 5.59675
R1545 VDD.n1223 VDD.t446 5.59675
R1546 VDD.n1229 VDD.t445 5.59675
R1547 VDD.n1234 VDD.t816 5.59675
R1548 VDD.n1294 VDD.t312 5.59675
R1549 VDD.n1300 VDD.t405 5.59675
R1550 VDD.n1306 VDD.t308 5.59675
R1551 VDD.n1312 VDD.t411 5.59675
R1552 VDD.n1318 VDD.t408 5.59675
R1553 VDD.n1324 VDD.t307 5.59675
R1554 VDD.n1330 VDD.t296 5.59675
R1555 VDD.n1336 VDD.t413 5.59675
R1556 VDD.n1342 VDD.t412 5.59675
R1557 VDD.n1348 VDD.t414 5.59675
R1558 VDD.n1354 VDD.t410 5.59675
R1559 VDD.n1360 VDD.t416 5.59675
R1560 VDD.n1366 VDD.t415 5.59675
R1561 VDD.n1372 VDD.t409 5.59675
R1562 VDD.n1378 VDD.t406 5.59675
R1563 VDD.n1384 VDD.t418 5.59675
R1564 VDD.n1390 VDD.t419 5.59675
R1565 VDD.n1396 VDD.t417 5.59675
R1566 VDD.n1402 VDD.t407 5.59675
R1567 VDD.n1408 VDD.t303 5.59675
R1568 VDD.n1414 VDD.t421 5.59675
R1569 VDD.n1420 VDD.t422 5.59675
R1570 VDD.n1426 VDD.t292 5.59675
R1571 VDD.n1432 VDD.t424 5.59675
R1572 VDD.n1438 VDD.t425 5.59675
R1573 VDD.n1444 VDD.t423 5.59675
R1574 VDD.n1450 VDD.t420 5.59675
R1575 VDD.n1456 VDD.t426 5.59675
R1576 VDD.n1462 VDD.t291 5.59675
R1577 VDD.n1468 VDD.t427 5.59675
R1578 VDD.n1474 VDD.t295 5.59675
R1579 VDD.n1480 VDD.t428 5.59675
R1580 VDD.n1485 VDD.t805 5.59675
R1581 VDD.n1545 VDD.t380 5.59675
R1582 VDD.n1551 VDD.t381 5.59675
R1583 VDD.n1557 VDD.t379 5.59675
R1584 VDD.n1563 VDD.t382 5.59675
R1585 VDD.n1569 VDD.t378 5.59675
R1586 VDD.n1575 VDD.t372 5.59675
R1587 VDD.n1581 VDD.t383 5.59675
R1588 VDD.n1587 VDD.t375 5.59675
R1589 VDD.n1593 VDD.t384 5.59675
R1590 VDD.n1599 VDD.t385 5.59675
R1591 VDD.n1605 VDD.t374 5.59675
R1592 VDD.n1611 VDD.t373 5.59675
R1593 VDD.n1617 VDD.t386 5.59675
R1594 VDD.n1623 VDD.t369 5.59675
R1595 VDD.n1629 VDD.t388 5.59675
R1596 VDD.n1635 VDD.t389 5.59675
R1597 VDD.n1641 VDD.t387 5.59675
R1598 VDD.n1647 VDD.t371 5.59675
R1599 VDD.n1653 VDD.t390 5.59675
R1600 VDD.n1659 VDD.t377 5.59675
R1601 VDD.n1665 VDD.t376 5.59675
R1602 VDD.n1671 VDD.t391 5.59675
R1603 VDD.n1677 VDD.t392 5.59675
R1604 VDD.n1683 VDD.t393 5.59675
R1605 VDD.n1689 VDD.t367 5.59675
R1606 VDD.n1695 VDD.t370 5.59675
R1607 VDD.n1701 VDD.t394 5.59675
R1608 VDD.n1707 VDD.t368 5.59675
R1609 VDD.n1713 VDD.t398 5.59675
R1610 VDD.n1719 VDD.t396 5.59675
R1611 VDD.n1725 VDD.t395 5.59675
R1612 VDD.n1731 VDD.t397 5.59675
R1613 VDD.n1736 VDD.t794 5.59675
R1614 VDD.n770 VDD.t316 5.59675
R1615 VDD.n776 VDD.t343 5.59675
R1616 VDD.n782 VDD.t345 5.59675
R1617 VDD.n788 VDD.t302 5.59675
R1618 VDD.n794 VDD.t342 5.59675
R1619 VDD.n800 VDD.t346 5.59675
R1620 VDD.n806 VDD.t349 5.59675
R1621 VDD.n812 VDD.t344 5.59675
R1622 VDD.n818 VDD.t348 5.59675
R1623 VDD.n824 VDD.t350 5.59675
R1624 VDD.n830 VDD.t347 5.59675
R1625 VDD.n836 VDD.t351 5.59675
R1626 VDD.n842 VDD.t309 5.59675
R1627 VDD.n848 VDD.t352 5.59675
R1628 VDD.n854 VDD.t311 5.59675
R1629 VDD.n860 VDD.t310 5.59675
R1630 VDD.n866 VDD.t357 5.59675
R1631 VDD.n872 VDD.t354 5.59675
R1632 VDD.n878 VDD.t353 5.59675
R1633 VDD.n884 VDD.t361 5.59675
R1634 VDD.n890 VDD.t362 5.59675
R1635 VDD.n896 VDD.t358 5.59675
R1636 VDD.n902 VDD.t360 5.59675
R1637 VDD.n908 VDD.t359 5.59675
R1638 VDD.n914 VDD.t365 5.59675
R1639 VDD.n920 VDD.t356 5.59675
R1640 VDD.n926 VDD.t364 5.59675
R1641 VDD.n932 VDD.t304 5.59675
R1642 VDD.n938 VDD.t363 5.59675
R1643 VDD.n944 VDD.t355 5.59675
R1644 VDD.n950 VDD.t318 5.59675
R1645 VDD.n956 VDD.t366 5.59675
R1646 VDD.n961 VDD.t761 5.59675
R1647 VDD.n714 VDD.t313 5.59675
R1648 VDD.n708 VDD.t298 5.59675
R1649 VDD.n702 VDD.t319 5.59675
R1650 VDD.n696 VDD.t305 5.59675
R1651 VDD.n690 VDD.t325 5.59675
R1652 VDD.n684 VDD.t321 5.59675
R1653 VDD.n678 VDD.t320 5.59675
R1654 VDD.n672 VDD.t324 5.59675
R1655 VDD.n666 VDD.t323 5.59675
R1656 VDD.n660 VDD.t322 5.59675
R1657 VDD.n654 VDD.t299 5.59675
R1658 VDD.n648 VDD.t328 5.59675
R1659 VDD.n642 VDD.t317 5.59675
R1660 VDD.n636 VDD.t326 5.59675
R1661 VDD.n630 VDD.t300 5.59675
R1662 VDD.n624 VDD.t315 5.59675
R1663 VDD.n618 VDD.t329 5.59675
R1664 VDD.n612 VDD.t314 5.59675
R1665 VDD.n606 VDD.t331 5.59675
R1666 VDD.n600 VDD.t336 5.59675
R1667 VDD.n594 VDD.t334 5.59675
R1668 VDD.n588 VDD.t333 5.59675
R1669 VDD.n582 VDD.t332 5.59675
R1670 VDD.n576 VDD.t335 5.59675
R1671 VDD.n570 VDD.t341 5.59675
R1672 VDD.n564 VDD.t340 5.59675
R1673 VDD.n558 VDD.t306 5.59675
R1674 VDD.n552 VDD.t339 5.59675
R1675 VDD.n546 VDD.t337 5.59675
R1676 VDD.n540 VDD.t338 5.59675
R1677 VDD.n534 VDD.t330 5.59675
R1678 VDD.n528 VDD.t327 5.59675
R1679 VDD.n522 VDD.t750 5.59675
R1680 VDD.n176 VDD.t294 5.59675
R1681 VDD.n138 VDD.t780 5.59179
R1682 VDD.n459 VDD.t785 5.59179
R1683 VDD.n7 VDD.t812 5.59179
R1684 VDD.n1 VDD.t801 5.59179
R1685 VDD.n4 VDD.t790 5.59179
R1686 VDD.n9 VDD.t757 5.59179
R1687 VDD.n148 VDD.t746 5.59179
R1688 VDD.n1785 VDD.t769 4.9462
R1689 VDD.n1757 VDD.t766 4.9462
R1690 VDD.n463 VDD.n462 4.90372
R1691 VDD.n1010 VDD 4.28517
R1692 VDD.t7 VDD.n995 4.19244
R1693 VDD.t7 VDD.n185 3.32638
R1694 VDD.t0 VDD.n1246 4.19244
R1695 VDD.t0 VDD.n187 3.32638
R1696 VDD.t41 VDD.n1497 4.19244
R1697 VDD.t41 VDD.n189 3.32638
R1698 VDD.t50 VDD.n973 4.19244
R1699 VDD.t50 VDD.n191 3.32638
R1700 VDD.t4 VDD.n722 4.19244
R1701 VDD.t4 VDD.n193 3.32638
R1702 VDD.t268 VDD.n484 4.19238
R1703 VDD.t268 VDD.n1777 4.19238
R1704 VDD.n259 VDD.n138 0.406014
R1705 VDD.n175 VDD.n301 0.379679
R1706 VDD.t268 VDD.n479 4.19225
R1707 VDD.t268 VDD.n1749 4.19225
R1708 VDD.t7 VDD.n429 3.3265
R1709 VDD.n1005 VDD.n298 0.341
R1710 VDD.n311 VDD.t7 3.3265
R1711 VDD.t0 VDD.n426 3.3265
R1712 VDD.n1256 VDD.n296 0.341
R1713 VDD.n331 VDD.t0 3.3265
R1714 VDD.t41 VDD.n423 3.3265
R1715 VDD.n1507 VDD.n294 0.341
R1716 VDD.n351 VDD.t41 3.3265
R1717 VDD.t50 VDD.n420 3.3265
R1718 VDD.n983 VDD.n292 0.341
R1719 VDD.n371 VDD.t50 3.3265
R1720 VDD.t4 VDD.n417 3.3265
R1721 VDD.n732 VDD.n290 0.341
R1722 VDD.n391 VDD.t4 3.3265
R1723 VDD.t270 VDD.n472 3.31226
R1724 VDD.t270 VDD.n464 3.30706
R1725 VDD.t270 VDD.n466 3.30706
R1726 VDD.t270 VDD.n478 3.30688
R1727 VDD.n1010 VDD.n184 3.24041
R1728 VDD.n1261 VDD.n186 3.24041
R1729 VDD.n1512 VDD.n188 3.24041
R1730 VDD.n988 VDD.n190 3.24041
R1731 VDD.n737 VDD.n192 3.24041
R1732 VDD.t270 VDD.n454 2.7751
R1733 VDD.t7 VDD.n989 2.74446
R1734 VDD.t7 VDD.n991 2.74446
R1735 VDD.n75 VDD.n74 0.286687
R1736 VDD.n1009 VDD.n133 0.44578
R1737 VDD.n133 VDD.n127 0.309939
R1738 VDD.t0 VDD.n1240 2.74446
R1739 VDD.t0 VDD.n1242 2.74446
R1740 VDD.n71 VDD.n70 0.286684
R1741 VDD.n1260 VDD.n134 0.44578
R1742 VDD.n134 VDD.n116 0.309939
R1743 VDD.t41 VDD.n1491 2.74446
R1744 VDD.t41 VDD.n1493 2.74446
R1745 VDD.n69 VDD.n68 0.286677
R1746 VDD.n1511 VDD.n135 0.44578
R1747 VDD.n135 VDD.n105 0.309939
R1748 VDD.t50 VDD.n967 2.74446
R1749 VDD.t50 VDD.n969 2.74446
R1750 VDD.n77 VDD.n76 0.2867
R1751 VDD.n987 VDD.n136 0.44578
R1752 VDD.n136 VDD.n94 0.309939
R1753 VDD.t4 VDD.n716 2.74446
R1754 VDD.t4 VDD.n718 2.74446
R1755 VDD.n73 VDD.n72 0.286687
R1756 VDD.n736 VDD.n137 0.44578
R1757 VDD.n137 VDD.n83 0.309939
R1758 VDD.n147 VDD.n713 0.435393
R1759 VDD.t399 VDD.n165 2.74414
R1760 VDD.t281 VDD.n167 2.74414
R1761 VDD.n66 VDD.n715 0.36833
R1762 VDD.n8 VDD.n1044 0.528092
R1763 VDD.n2 VDD.n1295 0.527966
R1764 VDD.n5 VDD.n1546 0.527966
R1765 VDD.n10 VDD.n771 0.528092
R1766 VDD.t297 VDD.n173 2.74397
R1767 VDD.t268 VDD.n485 2.74386
R1768 VDD.n7 VDD.n1042 0.435597
R1769 VDD.t275 VDD.n169 2.74386
R1770 VDD.t301 VDD.n171 2.74386
R1771 VDD.n9 VDD.n769 0.435597
R1772 VDD.t270 VDD 1.47683
R1773 VDD.n1755 VDD.t774 2.69937
R1774 VDD.n1753 VDD.t768 2.69937
R1775 VDD.n1779 VDD.t776 2.69937
R1776 VDD.n1787 VDD.t771 2.69937
R1777 VDD.n1783 VDD.t777 2.6992
R1778 VDD.n1781 VDD.t770 2.6992
R1779 VDD.n1751 VDD.t773 2.6992
R1780 VDD.n1759 VDD.t767 2.6992
R1781 VDD.n1764 VDD.t1130 2.6992
R1782 VDD.n1763 VDD.t1127 2.6992
R1783 VDD.n1769 VDD.t1132 2.6992
R1784 VDD.n1768 VDD.t1128 2.6992
R1785 VDD.n1774 VDD.t1134 2.6992
R1786 VDD.n1773 VDD.t1140 2.6992
R1787 VDD.t268 VDD.n288 2.33382
R1788 VDD.t399 VDD.n1083 2.32446
R1789 VDD.t399 VDD.n1191 2.32446
R1790 VDD.t275 VDD.n1585 2.32446
R1791 VDD.t301 VDD.n858 2.32446
R1792 VDD.t301 VDD.n870 2.32446
R1793 VDD.t301 VDD.n894 2.32446
R1794 VDD.t297 VDD.n620 2.32446
R1795 VDD.t399 VDD.n1047 2.32439
R1796 VDD.t399 VDD.n1113 2.32439
R1797 VDD.t281 VDD.n1298 2.32439
R1798 VDD.t281 VDD.n1328 2.32439
R1799 VDD.t281 VDD.n1418 2.32439
R1800 VDD.t281 VDD.n1424 2.32439
R1801 VDD.t281 VDD.n1478 2.32439
R1802 VDD.t275 VDD.n1645 2.32439
R1803 VDD.t275 VDD.n1651 2.32439
R1804 VDD.t301 VDD.n828 2.32439
R1805 VDD.t301 VDD.n882 2.32439
R1806 VDD.t301 VDD.n906 2.32439
R1807 VDD.t297 VDD.n566 2.32439
R1808 VDD.t399 VDD.n1143 2.32432
R1809 VDD.t399 VDD.n1167 2.32432
R1810 VDD.t281 VDD.n1358 2.32432
R1811 VDD.t275 VDD.n1603 2.32432
R1812 VDD.t275 VDD.n1639 2.32432
R1813 VDD.t275 VDD.n1705 2.32432
R1814 VDD.t275 VDD.n1717 2.32432
R1815 VDD.t301 VDD.n792 2.32432
R1816 VDD.t301 VDD.n822 2.32432
R1817 VDD.t301 VDD.n918 2.32432
R1818 VDD.t301 VDD.n954 2.32432
R1819 VDD.t297 VDD.n614 2.32432
R1820 VDD.t297 VDD.n530 2.32432
R1821 VDD.t399 VDD.n1071 2.32425
R1822 VDD.t399 VDD.n1077 2.32425
R1823 VDD.t399 VDD.n1089 2.32425
R1824 VDD.t399 VDD.n1101 2.32425
R1825 VDD.t399 VDD.n1107 2.32425
R1826 VDD.t399 VDD.n1125 2.32425
R1827 VDD.t399 VDD.n1137 2.32425
R1828 VDD.t399 VDD.n1221 2.32425
R1829 VDD.t281 VDD.n1316 2.32425
R1830 VDD.t281 VDD.n1364 2.32425
R1831 VDD.t281 VDD.n1406 2.32425
R1832 VDD.t275 VDD.n1621 2.32425
R1833 VDD.t275 VDD.n1663 2.32425
R1834 VDD.t301 VDD.n852 2.32425
R1835 VDD.t301 VDD.n900 2.32425
R1836 VDD.t297 VDD.n638 2.32425
R1837 VDD.t301 VDD.n774 2.3242
R1838 VDD.t297 VDD.n650 2.3242
R1839 VDD.t399 VDD.n1059 2.32417
R1840 VDD.t399 VDD.n1149 2.32417
R1841 VDD.t399 VDD.n1185 2.32417
R1842 VDD.t281 VDD.n1304 2.32417
R1843 VDD.t281 VDD.n1340 2.32417
R1844 VDD.t281 VDD.n1346 2.32417
R1845 VDD.t281 VDD.n1376 2.32417
R1846 VDD.t281 VDD.n1412 2.32417
R1847 VDD.t281 VDD.n1442 2.32417
R1848 VDD.t275 VDD.n1579 2.32417
R1849 VDD.t275 VDD.n1591 2.32417
R1850 VDD.t275 VDD.n1615 2.32417
R1851 VDD.t275 VDD.n1627 2.32417
R1852 VDD.t275 VDD.n1681 2.32417
R1853 VDD.t275 VDD.n1699 2.32417
R1854 VDD.t275 VDD.n1723 2.32417
R1855 VDD.t275 VDD.n1729 2.32417
R1856 VDD.t301 VDD.n780 2.32417
R1857 VDD.t301 VDD.n798 2.32417
R1858 VDD.t301 VDD.n810 2.32417
R1859 VDD.t301 VDD.n840 2.32417
R1860 VDD.t301 VDD.n888 2.32417
R1861 VDD.t301 VDD.n912 2.32417
R1862 VDD.t301 VDD.n942 2.32417
R1863 VDD.t297 VDD.n686 2.32417
R1864 VDD.t297 VDD.n680 2.32417
R1865 VDD.t297 VDD.n662 2.32417
R1866 VDD.t297 VDD.n644 2.32417
R1867 VDD.t297 VDD.n632 2.32417
R1868 VDD.t297 VDD.n584 2.32417
R1869 VDD.t297 VDD.n572 2.32417
R1870 VDD.t297 VDD.n560 2.32417
R1871 VDD.t297 VDD.n554 2.32417
R1872 VDD.t297 VDD.n548 2.32417
R1873 VDD.t268 VDD.n480 2.32417
R1874 VDD.t268 VDD.n483 2.32417
R1875 VDD.t268 VDD.n1771 2.32417
R1876 VDD.t293 VDD.n286 0.570319
R1877 VDD.t399 VDD.n1119 2.32417
R1878 VDD.t399 VDD.n1179 2.32417
R1879 VDD.t399 VDD.n1197 2.32417
R1880 VDD.t399 VDD.n1215 2.32417
R1881 VDD.t399 VDD.n1227 2.32417
R1882 VDD.t281 VDD.n1322 2.32417
R1883 VDD.t281 VDD.n1400 2.32417
R1884 VDD.t281 VDD.n1430 2.32417
R1885 VDD.t281 VDD.n1448 2.32417
R1886 VDD.t281 VDD.n1454 2.32417
R1887 VDD.t275 VDD.n1549 2.32417
R1888 VDD.t275 VDD.n1633 2.32417
R1889 VDD.t275 VDD.n1669 2.32417
R1890 VDD.t275 VDD.n1687 2.32417
R1891 VDD.t275 VDD.n1693 2.32417
R1892 VDD.t301 VDD.n834 2.32417
R1893 VDD.t301 VDD.n846 2.32417
R1894 VDD.t301 VDD.n876 2.32417
R1895 VDD.t301 VDD.n948 2.32417
R1896 VDD.t297 VDD.n692 2.32417
R1897 VDD.t297 VDD.n668 2.32417
R1898 VDD.t297 VDD.n590 2.32417
R1899 VDD.t399 VDD.n1095 2.32414
R1900 VDD.t399 VDD.n1203 2.32414
R1901 VDD.t281 VDD.n1310 2.32414
R1902 VDD.t281 VDD.n1370 2.32414
R1903 VDD.t281 VDD.n1394 2.32414
R1904 VDD.t275 VDD.n1567 2.32414
R1905 VDD.t275 VDD.n1657 2.32414
R1906 VDD.t275 VDD.n1675 2.32414
R1907 VDD.t301 VDD.n804 2.32414
R1908 VDD.t301 VDD.n864 2.32414
R1909 VDD.t301 VDD.n930 2.32414
R1910 VDD.t297 VDD.n674 2.32414
R1911 VDD.t297 VDD.n602 2.32414
R1912 VDD.t297 VDD.n536 2.32414
R1913 VDD.t399 VDD.n1053 2.32407
R1914 VDD.t399 VDD.n1131 2.32407
R1915 VDD.t281 VDD.n1388 2.32407
R1916 VDD.t301 VDD.n816 2.32407
R1917 VDD.t297 VDD.n656 2.32407
R1918 VDD.t268 VDD.n481 2.32406
R1919 VDD.t268 VDD.n1776 2.32406
R1920 VDD.t268 VDD.n1761 2.32406
R1921 VDD.t399 VDD.n1065 2.32406
R1922 VDD.t399 VDD.n1155 2.32406
R1923 VDD.t399 VDD.n1161 2.32406
R1924 VDD.t399 VDD.n1173 2.32406
R1925 VDD.t399 VDD.n1209 2.32406
R1926 VDD.t281 VDD.n1334 2.32406
R1927 VDD.t281 VDD.n1352 2.32406
R1928 VDD.t281 VDD.n1382 2.32406
R1929 VDD.t281 VDD.n1436 2.32406
R1930 VDD.t281 VDD.n1460 2.32406
R1931 VDD.t281 VDD.n1466 2.32406
R1932 VDD.t281 VDD.n1472 2.32406
R1933 VDD.t275 VDD.n1555 2.32406
R1934 VDD.t275 VDD.n1561 2.32406
R1935 VDD.t275 VDD.n1573 2.32406
R1936 VDD.t275 VDD.n1597 2.32406
R1937 VDD.t275 VDD.n1609 2.32406
R1938 VDD.t275 VDD.n1711 2.32406
R1939 VDD.t301 VDD.n786 2.32406
R1940 VDD.t301 VDD.n924 2.32406
R1941 VDD.t301 VDD.n936 2.32406
R1942 VDD.t297 VDD.n710 2.32406
R1943 VDD.t297 VDD.n704 2.32406
R1944 VDD.t297 VDD.n698 2.32406
R1945 VDD.t297 VDD.n626 2.32406
R1946 VDD.t297 VDD.n608 2.32406
R1947 VDD.t297 VDD.n596 2.32406
R1948 VDD.t297 VDD.n578 2.32406
R1949 VDD.t297 VDD.n542 2.32406
R1950 VDD.n76 VDD.t1309 6.35403
R1951 VDD.n74 VDD.t1074 6.35401
R1952 VDD.n72 VDD.t599 6.35401
R1953 VDD.n70 VDD.t1057 6.35401
R1954 VDD.n68 VDD.t1194 6.354
R1955 VDD.t268 VDD.n482 2.0061
R1956 VDD.t268 VDD.n1766 2.00592
R1957 VDD.t268 VDD.n1789 1.75847
R1958 VDD.t399 VDD.n1239 1.56886
R1959 VDD.t281 VDD.n1490 1.56886
R1960 VDD.t275 VDD.n1741 1.56886
R1961 VDD.t301 VDD.n966 1.56886
R1962 VDD.t297 VDD.n518 1.56865
R1963 VDD.t297 VDD.n516 1.55402
R1964 VDD.t297 VDD.n517 1.55387
R1965 VDD.t399 VDD.n1011 1.55381
R1966 VDD.t399 VDD.n1012 1.55381
R1967 VDD.t399 VDD.n1013 1.55381
R1968 VDD.t399 VDD.n1015 1.55381
R1969 VDD.t399 VDD.n1016 1.55381
R1970 VDD.t399 VDD.n1017 1.55381
R1971 VDD.t399 VDD.n1018 1.55381
R1972 VDD.t399 VDD.n1019 1.55381
R1973 VDD.t399 VDD.n1022 1.55381
R1974 VDD.t399 VDD.n1023 1.55381
R1975 VDD.t399 VDD.n1024 1.55381
R1976 VDD.t399 VDD.n1025 1.55381
R1977 VDD.t399 VDD.n1027 1.55381
R1978 VDD.t399 VDD.n1028 1.55381
R1979 VDD.t399 VDD.n1029 1.55381
R1980 VDD.t399 VDD.n1030 1.55381
R1981 VDD.t399 VDD.n1033 1.55381
R1982 VDD.t399 VDD.n1034 1.55381
R1983 VDD.t399 VDD.n1040 1.55381
R1984 VDD.t399 VDD.n1041 1.55381
R1985 VDD.t281 VDD.n1262 1.55381
R1986 VDD.t281 VDD.n1263 1.55381
R1987 VDD.t281 VDD.n1264 1.55381
R1988 VDD.t281 VDD.n1266 1.55381
R1989 VDD.t281 VDD.n1267 1.55381
R1990 VDD.t281 VDD.n1270 1.55381
R1991 VDD.t281 VDD.n1271 1.55381
R1992 VDD.t281 VDD.n1273 1.55381
R1993 VDD.t281 VDD.n1275 1.55381
R1994 VDD.t281 VDD.n1276 1.55381
R1995 VDD.t281 VDD.n1277 1.55381
R1996 VDD.t281 VDD.n1278 1.55381
R1997 VDD.t281 VDD.n1279 1.55381
R1998 VDD.t281 VDD.n1281 1.55381
R1999 VDD.t281 VDD.n1282 1.55381
R2000 VDD.t281 VDD.n1284 1.55381
R2001 VDD.t281 VDD.n1285 1.55381
R2002 VDD.t281 VDD.n1286 1.55381
R2003 VDD.t281 VDD.n1287 1.55381
R2004 VDD.t281 VDD.n1288 1.55381
R2005 VDD.t281 VDD.n1289 1.55381
R2006 VDD.t281 VDD.n1291 1.55381
R2007 VDD.t281 VDD.n1292 1.55381
R2008 VDD.t275 VDD.n1513 1.55381
R2009 VDD.t275 VDD.n1514 1.55381
R2010 VDD.t275 VDD.n1516 1.55381
R2011 VDD.t275 VDD.n1517 1.55381
R2012 VDD.t275 VDD.n1519 1.55381
R2013 VDD.t275 VDD.n1520 1.55381
R2014 VDD.t275 VDD.n1521 1.55381
R2015 VDD.t275 VDD.n1524 1.55381
R2016 VDD.t275 VDD.n1525 1.55381
R2017 VDD.t275 VDD.n1526 1.55381
R2018 VDD.t275 VDD.n1529 1.55381
R2019 VDD.t275 VDD.n1530 1.55381
R2020 VDD.t275 VDD.n1531 1.55381
R2021 VDD.t275 VDD.n1532 1.55381
R2022 VDD.t275 VDD.n1533 1.55381
R2023 VDD.t275 VDD.n1534 1.55381
R2024 VDD.t275 VDD.n1535 1.55381
R2025 VDD.t275 VDD.n1538 1.55381
R2026 VDD.t275 VDD.n1540 1.55381
R2027 VDD.t275 VDD.n1541 1.55381
R2028 VDD.t275 VDD.n1542 1.55381
R2029 VDD.t301 VDD.n738 1.55381
R2030 VDD.t301 VDD.n739 1.55381
R2031 VDD.t301 VDD.n740 1.55381
R2032 VDD.t301 VDD.n741 1.55381
R2033 VDD.t301 VDD.n745 1.55381
R2034 VDD.t301 VDD.n748 1.55381
R2035 VDD.t301 VDD.n749 1.55381
R2036 VDD.t301 VDD.n750 1.55381
R2037 VDD.t301 VDD.n752 1.55381
R2038 VDD.t301 VDD.n756 1.55381
R2039 VDD.t301 VDD.n757 1.55381
R2040 VDD.t301 VDD.n758 1.55381
R2041 VDD.t301 VDD.n759 1.55381
R2042 VDD.t301 VDD.n761 1.55381
R2043 VDD.t301 VDD.n762 1.55381
R2044 VDD.t301 VDD.n763 1.55381
R2045 VDD.t301 VDD.n764 1.55381
R2046 VDD.t301 VDD.n765 1.55381
R2047 VDD.t301 VDD.n767 1.55381
R2048 VDD.t301 VDD.n768 1.55381
R2049 VDD.t297 VDD.n504 1.55371
R2050 VDD.t297 VDD.n508 1.55361
R2051 VDD.t297 VDD.n509 1.55359
R2052 VDD.t297 VDD.n502 1.55354
R2053 VDD.t297 VDD.n503 1.55354
R2054 VDD.t297 VDD.n487 1.55353
R2055 VDD.t297 VDD.n500 1.55352
R2056 VDD.t297 VDD.n498 1.5535
R2057 VDD.t297 VDD.n493 1.5535
R2058 VDD.t297 VDD.n488 1.55345
R2059 VDD.t297 VDD.n512 1.55344
R2060 VDD.t399 VDD.n1014 1.55341
R2061 VDD.t399 VDD.n1020 1.55341
R2062 VDD.t399 VDD.n1021 1.55341
R2063 VDD.t399 VDD.n1026 1.55341
R2064 VDD.t399 VDD.n1031 1.55341
R2065 VDD.t399 VDD.n1032 1.55341
R2066 VDD.t399 VDD.n1035 1.55341
R2067 VDD.t399 VDD.n1036 1.55341
R2068 VDD.t399 VDD.n1037 1.55341
R2069 VDD.t399 VDD.n1038 1.55341
R2070 VDD.t399 VDD.n1039 1.55341
R2071 VDD.t281 VDD.n1265 1.55341
R2072 VDD.t281 VDD.n1268 1.55341
R2073 VDD.t281 VDD.n1269 1.55341
R2074 VDD.t281 VDD.n1272 1.55341
R2075 VDD.t281 VDD.n1274 1.55341
R2076 VDD.t281 VDD.n1280 1.55341
R2077 VDD.t281 VDD.n1283 1.55341
R2078 VDD.t281 VDD.n1290 1.55341
R2079 VDD.t275 VDD.n1515 1.55341
R2080 VDD.t275 VDD.n1518 1.55341
R2081 VDD.t275 VDD.n1522 1.55341
R2082 VDD.t275 VDD.n1523 1.55341
R2083 VDD.t275 VDD.n1527 1.55341
R2084 VDD.t275 VDD.n1528 1.55341
R2085 VDD.t275 VDD.n1536 1.55341
R2086 VDD.t275 VDD.n1537 1.55341
R2087 VDD.t275 VDD.n1539 1.55341
R2088 VDD.t275 VDD.n1543 1.55341
R2089 VDD.t301 VDD.n742 1.55341
R2090 VDD.t301 VDD.n743 1.55341
R2091 VDD.t301 VDD.n744 1.55341
R2092 VDD.t301 VDD.n746 1.55341
R2093 VDD.t301 VDD.n747 1.55341
R2094 VDD.t301 VDD.n751 1.55341
R2095 VDD.t301 VDD.n753 1.55341
R2096 VDD.t301 VDD.n754 1.55341
R2097 VDD.t301 VDD.n755 1.55341
R2098 VDD.t301 VDD.n760 1.55341
R2099 VDD.t301 VDD.n766 1.55341
R2100 VDD.t297 VDD.n489 1.55341
R2101 VDD.t297 VDD.n515 1.55341
R2102 VDD.t297 VDD.n505 1.55335
R2103 VDD.t297 VDD.n490 1.55334
R2104 VDD.t297 VDD.n499 1.55334
R2105 VDD.t297 VDD.n511 1.55334
R2106 VDD.t297 VDD.n496 1.55334
R2107 VDD.t297 VDD.n501 1.55334
R2108 VDD.t297 VDD.n506 1.55334
R2109 VDD.t297 VDD.n514 1.55334
R2110 VDD.t297 VDD.n513 1.55334
R2111 VDD.t297 VDD.n497 1.55333
R2112 VDD.t297 VDD.n495 1.55333
R2113 VDD.t297 VDD.n491 1.55333
R2114 VDD.t297 VDD.n492 1.55331
R2115 VDD.t297 VDD.n507 1.55327
R2116 VDD.t297 VDD.n510 1.55327
R2117 VDD.t297 VDD.n494 1.55325
R2118 VDD.t270 VDD.n456 1.20461
R2119 VDD.n286 VDD.n461 0.779651
R2120 VDD.n1764 VDD.n1763 1.11007
R2121 VDD.n1769 VDD.n1768 1.11007
R2122 VDD.n1774 VDD.n1773 1.11007
R2123 VDD.t268 VDD.n486 1.01993
R2124 VDD.n476 VDD.n452 0.975304
R2125 VDD.n452 VDD.n475 0.817678
R2126 VDD.n1743 VDD.n142 0.808112
R2127 VDD.n463 VDD.n456 0.671512
R2128 VDD.n456 VDD.n455 0.6645
R2129 VDD.n1745 VDD.n486 0.632886
R2130 VDD.n1742 VDD.n486 0.618267
R2131 VDD.n1753 VDD.n1752 0.570444
R2132 VDD.n1788 VDD.n1787 0.570444
R2133 VDD.n1781 VDD.n1780 0.570274
R2134 VDD.n1760 VDD.n1759 0.570274
R2135 VDD.n1765 VDD.n1764 0.570274
R2136 VDD.n1770 VDD.n1769 0.570274
R2137 VDD.n1775 VDD.n1774 0.570274
R2138 VDD.n1783 VDD.n1782 0.569912
R2139 VDD.n1751 VDD.n1750 0.569912
R2140 VDD.n1763 VDD.n1762 0.569912
R2141 VDD.n1768 VDD.n1767 0.569912
R2142 VDD.n1773 VDD.n1772 0.569912
R2143 VDD.n1755 VDD.n1754 0.569733
R2144 VDD.n1779 VDD.n1778 0.569733
R2145 VDD.n139 VDD.n138 0.183807
R2146 VDD.n459 VDD.n178 0.508375
R2147 VDD.t270 VDD.n452 0.49685
R2148 VDD.n1043 VDD.n1042 0.495398
R2149 VDD.n1049 VDD.n1048 0.495398
R2150 VDD.n1055 VDD.n1054 0.495398
R2151 VDD.n1061 VDD.n1060 0.495398
R2152 VDD.n1067 VDD.n1066 0.495398
R2153 VDD.n1073 VDD.n1072 0.495398
R2154 VDD.n1079 VDD.n1078 0.495398
R2155 VDD.n1085 VDD.n1084 0.495398
R2156 VDD.n1091 VDD.n1090 0.495398
R2157 VDD.n1097 VDD.n1096 0.495398
R2158 VDD.n1103 VDD.n1102 0.495398
R2159 VDD.n1109 VDD.n1108 0.495398
R2160 VDD.n1115 VDD.n1114 0.495398
R2161 VDD.n1121 VDD.n1120 0.495398
R2162 VDD.n1127 VDD.n1126 0.495398
R2163 VDD.n1133 VDD.n1132 0.495398
R2164 VDD.n1139 VDD.n1138 0.495398
R2165 VDD.n1145 VDD.n1144 0.495398
R2166 VDD.n1151 VDD.n1150 0.495398
R2167 VDD.n1157 VDD.n1156 0.495398
R2168 VDD.n1163 VDD.n1162 0.495398
R2169 VDD.n1169 VDD.n1168 0.495398
R2170 VDD.n1175 VDD.n1174 0.495398
R2171 VDD.n1181 VDD.n1180 0.495398
R2172 VDD.n1187 VDD.n1186 0.495398
R2173 VDD.n1193 VDD.n1192 0.495398
R2174 VDD.n1199 VDD.n1198 0.495398
R2175 VDD.n1205 VDD.n1204 0.495398
R2176 VDD.n1211 VDD.n1210 0.495398
R2177 VDD.n1217 VDD.n1216 0.495398
R2178 VDD.n1223 VDD.n1222 0.495398
R2179 VDD.n1229 VDD.n1228 0.495398
R2180 VDD.n1234 VDD.n166 0.495398
R2181 VDD.n1294 VDD.n1293 0.495398
R2182 VDD.n1300 VDD.n1299 0.495398
R2183 VDD.n1306 VDD.n1305 0.495398
R2184 VDD.n1312 VDD.n1311 0.495398
R2185 VDD.n1318 VDD.n1317 0.495398
R2186 VDD.n1324 VDD.n1323 0.495398
R2187 VDD.n1330 VDD.n1329 0.495398
R2188 VDD.n1336 VDD.n1335 0.495398
R2189 VDD.n1342 VDD.n1341 0.495398
R2190 VDD.n1348 VDD.n1347 0.495398
R2191 VDD.n1354 VDD.n1353 0.495398
R2192 VDD.n1360 VDD.n1359 0.495398
R2193 VDD.n1366 VDD.n1365 0.495398
R2194 VDD.n1372 VDD.n1371 0.495398
R2195 VDD.n1378 VDD.n1377 0.495398
R2196 VDD.n1384 VDD.n1383 0.495398
R2197 VDD.n1390 VDD.n1389 0.495398
R2198 VDD.n1396 VDD.n1395 0.495398
R2199 VDD.n1402 VDD.n1401 0.495398
R2200 VDD.n1408 VDD.n1407 0.495398
R2201 VDD.n1414 VDD.n1413 0.495398
R2202 VDD.n1420 VDD.n1419 0.495398
R2203 VDD.n1426 VDD.n1425 0.495398
R2204 VDD.n1432 VDD.n1431 0.495398
R2205 VDD.n1438 VDD.n1437 0.495398
R2206 VDD.n1444 VDD.n1443 0.495398
R2207 VDD.n1450 VDD.n1449 0.495398
R2208 VDD.n1456 VDD.n1455 0.495398
R2209 VDD.n1462 VDD.n1461 0.495398
R2210 VDD.n1468 VDD.n1467 0.495398
R2211 VDD.n1474 VDD.n1473 0.495398
R2212 VDD.n1480 VDD.n1479 0.495398
R2213 VDD.n1485 VDD.n168 0.495398
R2214 VDD.n1545 VDD.n1544 0.495398
R2215 VDD.n1551 VDD.n1550 0.495398
R2216 VDD.n1557 VDD.n1556 0.495398
R2217 VDD.n1563 VDD.n1562 0.495398
R2218 VDD.n1569 VDD.n1568 0.495398
R2219 VDD.n1575 VDD.n1574 0.495398
R2220 VDD.n1581 VDD.n1580 0.495398
R2221 VDD.n1587 VDD.n1586 0.495398
R2222 VDD.n1593 VDD.n1592 0.495398
R2223 VDD.n1599 VDD.n1598 0.495398
R2224 VDD.n1605 VDD.n1604 0.495398
R2225 VDD.n1611 VDD.n1610 0.495398
R2226 VDD.n1617 VDD.n1616 0.495398
R2227 VDD.n1623 VDD.n1622 0.495398
R2228 VDD.n1629 VDD.n1628 0.495398
R2229 VDD.n1635 VDD.n1634 0.495398
R2230 VDD.n1641 VDD.n1640 0.495398
R2231 VDD.n1647 VDD.n1646 0.495398
R2232 VDD.n1653 VDD.n1652 0.495398
R2233 VDD.n1659 VDD.n1658 0.495398
R2234 VDD.n1665 VDD.n1664 0.495398
R2235 VDD.n1671 VDD.n1670 0.495398
R2236 VDD.n1677 VDD.n1676 0.495398
R2237 VDD.n1683 VDD.n1682 0.495398
R2238 VDD.n1689 VDD.n1688 0.495398
R2239 VDD.n1695 VDD.n1694 0.495398
R2240 VDD.n1701 VDD.n1700 0.495398
R2241 VDD.n1707 VDD.n1706 0.495398
R2242 VDD.n1713 VDD.n1712 0.495398
R2243 VDD.n1719 VDD.n1718 0.495398
R2244 VDD.n1725 VDD.n1724 0.495398
R2245 VDD.n1731 VDD.n1730 0.495398
R2246 VDD.n1736 VDD.n170 0.495398
R2247 VDD.n770 VDD.n769 0.495398
R2248 VDD.n776 VDD.n775 0.495398
R2249 VDD.n782 VDD.n781 0.495398
R2250 VDD.n788 VDD.n787 0.495398
R2251 VDD.n794 VDD.n793 0.495398
R2252 VDD.n800 VDD.n799 0.495398
R2253 VDD.n806 VDD.n805 0.495398
R2254 VDD.n812 VDD.n811 0.495398
R2255 VDD.n818 VDD.n817 0.495398
R2256 VDD.n824 VDD.n823 0.495398
R2257 VDD.n830 VDD.n829 0.495398
R2258 VDD.n836 VDD.n835 0.495398
R2259 VDD.n842 VDD.n841 0.495398
R2260 VDD.n848 VDD.n847 0.495398
R2261 VDD.n854 VDD.n853 0.495398
R2262 VDD.n860 VDD.n859 0.495398
R2263 VDD.n866 VDD.n865 0.495398
R2264 VDD.n872 VDD.n871 0.495398
R2265 VDD.n878 VDD.n877 0.495398
R2266 VDD.n884 VDD.n883 0.495398
R2267 VDD.n890 VDD.n889 0.495398
R2268 VDD.n896 VDD.n895 0.495398
R2269 VDD.n902 VDD.n901 0.495398
R2270 VDD.n908 VDD.n907 0.495398
R2271 VDD.n914 VDD.n913 0.495398
R2272 VDD.n920 VDD.n919 0.495398
R2273 VDD.n926 VDD.n925 0.495398
R2274 VDD.n932 VDD.n931 0.495398
R2275 VDD.n938 VDD.n937 0.495398
R2276 VDD.n944 VDD.n943 0.495398
R2277 VDD.n950 VDD.n949 0.495398
R2278 VDD.n956 VDD.n955 0.495398
R2279 VDD.n961 VDD.n172 0.495398
R2280 VDD.n714 VDD.n713 0.495398
R2281 VDD.n708 VDD.n707 0.495398
R2282 VDD.n702 VDD.n701 0.495398
R2283 VDD.n696 VDD.n695 0.495398
R2284 VDD.n690 VDD.n689 0.495398
R2285 VDD.n684 VDD.n683 0.495398
R2286 VDD.n678 VDD.n677 0.495398
R2287 VDD.n672 VDD.n671 0.495398
R2288 VDD.n666 VDD.n665 0.495398
R2289 VDD.n660 VDD.n659 0.495398
R2290 VDD.n654 VDD.n653 0.495398
R2291 VDD.n648 VDD.n647 0.495398
R2292 VDD.n642 VDD.n641 0.495398
R2293 VDD.n636 VDD.n635 0.495398
R2294 VDD.n630 VDD.n629 0.495398
R2295 VDD.n624 VDD.n623 0.495398
R2296 VDD.n618 VDD.n617 0.495398
R2297 VDD.n612 VDD.n611 0.495398
R2298 VDD.n606 VDD.n605 0.495398
R2299 VDD.n600 VDD.n599 0.495398
R2300 VDD.n594 VDD.n593 0.495398
R2301 VDD.n588 VDD.n587 0.495398
R2302 VDD.n582 VDD.n581 0.495398
R2303 VDD.n576 VDD.n575 0.495398
R2304 VDD.n570 VDD.n569 0.495398
R2305 VDD.n564 VDD.n563 0.495398
R2306 VDD.n558 VDD.n557 0.495398
R2307 VDD.n552 VDD.n551 0.495398
R2308 VDD.n546 VDD.n545 0.495398
R2309 VDD.n540 VDD.n539 0.495398
R2310 VDD.n534 VDD.n533 0.495398
R2311 VDD.n528 VDD.n527 0.495398
R2312 VDD.n522 VDD.n174 0.495398
R2313 VDD.n176 VDD.n260 0.495398
R2314 VDD.n1756 VDD.n1755 0.492175
R2315 VDD.n1786 VDD.n1779 0.492175
R2316 VDD.n1784 VDD.n1783 0.492005
R2317 VDD.n1758 VDD.n1751 0.492005
R2318 VDD.n1784 VDD.n1781 0.491643
R2319 VDD.n1759 VDD.n1758 0.491643
R2320 VDD.n1756 VDD.n1753 0.491464
R2321 VDD.n1787 VDD.n1786 0.491464
R2322 VDD.n1044 VDD.n1043 0.478641
R2323 VDD.n1050 VDD.n1049 0.478641
R2324 VDD.n1056 VDD.n1055 0.478641
R2325 VDD.n1062 VDD.n1061 0.478641
R2326 VDD.n1068 VDD.n1067 0.478641
R2327 VDD.n1074 VDD.n1073 0.478641
R2328 VDD.n1080 VDD.n1079 0.478641
R2329 VDD.n1086 VDD.n1085 0.478641
R2330 VDD.n1092 VDD.n1091 0.478641
R2331 VDD.n1098 VDD.n1097 0.478641
R2332 VDD.n1104 VDD.n1103 0.478641
R2333 VDD.n1110 VDD.n1109 0.478641
R2334 VDD.n1116 VDD.n1115 0.478641
R2335 VDD.n1122 VDD.n1121 0.478641
R2336 VDD.n1128 VDD.n1127 0.478641
R2337 VDD.n1134 VDD.n1133 0.478641
R2338 VDD.n1140 VDD.n1139 0.478641
R2339 VDD.n1146 VDD.n1145 0.478641
R2340 VDD.n1152 VDD.n1151 0.478641
R2341 VDD.n1158 VDD.n1157 0.478641
R2342 VDD.n1164 VDD.n1163 0.478641
R2343 VDD.n1170 VDD.n1169 0.478641
R2344 VDD.n1176 VDD.n1175 0.478641
R2345 VDD.n1182 VDD.n1181 0.478641
R2346 VDD.n1188 VDD.n1187 0.478641
R2347 VDD.n1194 VDD.n1193 0.478641
R2348 VDD.n1200 VDD.n1199 0.478641
R2349 VDD.n1206 VDD.n1205 0.478641
R2350 VDD.n1212 VDD.n1211 0.478641
R2351 VDD.n1218 VDD.n1217 0.478641
R2352 VDD.n1224 VDD.n1223 0.478641
R2353 VDD.n1230 VDD.n1229 0.478641
R2354 VDD.n261 VDD.n1234 0.478641
R2355 VDD.n1295 VDD.n1294 0.478641
R2356 VDD.n1301 VDD.n1300 0.478641
R2357 VDD.n1307 VDD.n1306 0.478641
R2358 VDD.n1313 VDD.n1312 0.478641
R2359 VDD.n1319 VDD.n1318 0.478641
R2360 VDD.n1325 VDD.n1324 0.478641
R2361 VDD.n1331 VDD.n1330 0.478641
R2362 VDD.n1337 VDD.n1336 0.478641
R2363 VDD.n1343 VDD.n1342 0.478641
R2364 VDD.n1349 VDD.n1348 0.478641
R2365 VDD.n1355 VDD.n1354 0.478641
R2366 VDD.n1361 VDD.n1360 0.478641
R2367 VDD.n1367 VDD.n1366 0.478641
R2368 VDD.n1373 VDD.n1372 0.478641
R2369 VDD.n1379 VDD.n1378 0.478641
R2370 VDD.n1385 VDD.n1384 0.478641
R2371 VDD.n1391 VDD.n1390 0.478641
R2372 VDD.n1397 VDD.n1396 0.478641
R2373 VDD.n1403 VDD.n1402 0.478641
R2374 VDD.n1409 VDD.n1408 0.478641
R2375 VDD.n1415 VDD.n1414 0.478641
R2376 VDD.n1421 VDD.n1420 0.478641
R2377 VDD.n1427 VDD.n1426 0.478641
R2378 VDD.n1433 VDD.n1432 0.478641
R2379 VDD.n1439 VDD.n1438 0.478641
R2380 VDD.n1445 VDD.n1444 0.478641
R2381 VDD.n1451 VDD.n1450 0.478641
R2382 VDD.n1457 VDD.n1456 0.478641
R2383 VDD.n1463 VDD.n1462 0.478641
R2384 VDD.n1469 VDD.n1468 0.478641
R2385 VDD.n1475 VDD.n1474 0.478641
R2386 VDD.n1481 VDD.n1480 0.478641
R2387 VDD.n265 VDD.n1485 0.478641
R2388 VDD.n1546 VDD.n1545 0.478641
R2389 VDD.n1552 VDD.n1551 0.478641
R2390 VDD.n1558 VDD.n1557 0.478641
R2391 VDD.n1564 VDD.n1563 0.478641
R2392 VDD.n1570 VDD.n1569 0.478641
R2393 VDD.n1576 VDD.n1575 0.478641
R2394 VDD.n1582 VDD.n1581 0.478641
R2395 VDD.n1588 VDD.n1587 0.478641
R2396 VDD.n1594 VDD.n1593 0.478641
R2397 VDD.n1600 VDD.n1599 0.478641
R2398 VDD.n1606 VDD.n1605 0.478641
R2399 VDD.n1612 VDD.n1611 0.478641
R2400 VDD.n1618 VDD.n1617 0.478641
R2401 VDD.n1624 VDD.n1623 0.478641
R2402 VDD.n1630 VDD.n1629 0.478641
R2403 VDD.n1636 VDD.n1635 0.478641
R2404 VDD.n1642 VDD.n1641 0.478641
R2405 VDD.n1648 VDD.n1647 0.478641
R2406 VDD.n1654 VDD.n1653 0.478641
R2407 VDD.n1660 VDD.n1659 0.478641
R2408 VDD.n1666 VDD.n1665 0.478641
R2409 VDD.n1672 VDD.n1671 0.478641
R2410 VDD.n1678 VDD.n1677 0.478641
R2411 VDD.n1684 VDD.n1683 0.478641
R2412 VDD.n1690 VDD.n1689 0.478641
R2413 VDD.n1696 VDD.n1695 0.478641
R2414 VDD.n1702 VDD.n1701 0.478641
R2415 VDD.n1708 VDD.n1707 0.478641
R2416 VDD.n1714 VDD.n1713 0.478641
R2417 VDD.n1720 VDD.n1719 0.478641
R2418 VDD.n1726 VDD.n1725 0.478641
R2419 VDD.n1732 VDD.n1731 0.478641
R2420 VDD.n269 VDD.n1736 0.478641
R2421 VDD.n771 VDD.n770 0.478641
R2422 VDD.n777 VDD.n776 0.478641
R2423 VDD.n783 VDD.n782 0.478641
R2424 VDD.n789 VDD.n788 0.478641
R2425 VDD.n795 VDD.n794 0.478641
R2426 VDD.n801 VDD.n800 0.478641
R2427 VDD.n807 VDD.n806 0.478641
R2428 VDD.n813 VDD.n812 0.478641
R2429 VDD.n819 VDD.n818 0.478641
R2430 VDD.n825 VDD.n824 0.478641
R2431 VDD.n831 VDD.n830 0.478641
R2432 VDD.n837 VDD.n836 0.478641
R2433 VDD.n843 VDD.n842 0.478641
R2434 VDD.n849 VDD.n848 0.478641
R2435 VDD.n855 VDD.n854 0.478641
R2436 VDD.n861 VDD.n860 0.478641
R2437 VDD.n867 VDD.n866 0.478641
R2438 VDD.n873 VDD.n872 0.478641
R2439 VDD.n879 VDD.n878 0.478641
R2440 VDD.n885 VDD.n884 0.478641
R2441 VDD.n891 VDD.n890 0.478641
R2442 VDD.n897 VDD.n896 0.478641
R2443 VDD.n903 VDD.n902 0.478641
R2444 VDD.n909 VDD.n908 0.478641
R2445 VDD.n915 VDD.n914 0.478641
R2446 VDD.n921 VDD.n920 0.478641
R2447 VDD.n927 VDD.n926 0.478641
R2448 VDD.n933 VDD.n932 0.478641
R2449 VDD.n939 VDD.n938 0.478641
R2450 VDD.n945 VDD.n944 0.478641
R2451 VDD.n951 VDD.n950 0.478641
R2452 VDD.n957 VDD.n956 0.478641
R2453 VDD.n273 VDD.n961 0.478641
R2454 VDD.n715 VDD.n714 0.478641
R2455 VDD.n709 VDD.n708 0.478641
R2456 VDD.n703 VDD.n702 0.478641
R2457 VDD.n697 VDD.n696 0.478641
R2458 VDD.n691 VDD.n690 0.478641
R2459 VDD.n685 VDD.n684 0.478641
R2460 VDD.n679 VDD.n678 0.478641
R2461 VDD.n673 VDD.n672 0.478641
R2462 VDD.n667 VDD.n666 0.478641
R2463 VDD.n661 VDD.n660 0.478641
R2464 VDD.n655 VDD.n654 0.478641
R2465 VDD.n649 VDD.n648 0.478641
R2466 VDD.n643 VDD.n642 0.478641
R2467 VDD.n637 VDD.n636 0.478641
R2468 VDD.n631 VDD.n630 0.478641
R2469 VDD.n625 VDD.n624 0.478641
R2470 VDD.n619 VDD.n618 0.478641
R2471 VDD.n613 VDD.n612 0.478641
R2472 VDD.n607 VDD.n606 0.478641
R2473 VDD.n601 VDD.n600 0.478641
R2474 VDD.n595 VDD.n594 0.478641
R2475 VDD.n589 VDD.n588 0.478641
R2476 VDD.n583 VDD.n582 0.478641
R2477 VDD.n577 VDD.n576 0.478641
R2478 VDD.n571 VDD.n570 0.478641
R2479 VDD.n565 VDD.n564 0.478641
R2480 VDD.n559 VDD.n558 0.478641
R2481 VDD.n553 VDD.n552 0.478641
R2482 VDD.n547 VDD.n546 0.478641
R2483 VDD.n541 VDD.n540 0.478641
R2484 VDD.n535 VDD.n534 0.478641
R2485 VDD.n529 VDD.n528 0.478641
R2486 VDD.n523 VDD.n522 0.478641
R2487 VDD.n178 VDD.n176 0.478641
R2488 VDD.n539 VDD.n516 0.467635
R2489 VDD.n533 VDD.n517 0.467485
R2490 VDD.n1042 VDD.n1041 0.467341
R2491 VDD.n1048 VDD.n1040 0.467341
R2492 VDD.n1084 VDD.n1034 0.467341
R2493 VDD.n1090 VDD.n1033 0.467341
R2494 VDD.n1108 VDD.n1030 0.467341
R2495 VDD.n1114 VDD.n1029 0.467341
R2496 VDD.n1120 VDD.n1028 0.467341
R2497 VDD.n1126 VDD.n1027 0.467341
R2498 VDD.n1138 VDD.n1025 0.467341
R2499 VDD.n1144 VDD.n1024 0.467341
R2500 VDD.n1150 VDD.n1023 0.467341
R2501 VDD.n1156 VDD.n1022 0.467341
R2502 VDD.n1174 VDD.n1019 0.467341
R2503 VDD.n1180 VDD.n1018 0.467341
R2504 VDD.n1186 VDD.n1017 0.467341
R2505 VDD.n1192 VDD.n1016 0.467341
R2506 VDD.n1198 VDD.n1015 0.467341
R2507 VDD.n1210 VDD.n1013 0.467341
R2508 VDD.n1216 VDD.n1012 0.467341
R2509 VDD.n1222 VDD.n1011 0.467341
R2510 VDD.n1293 VDD.n1292 0.467341
R2511 VDD.n1299 VDD.n1291 0.467341
R2512 VDD.n1311 VDD.n1289 0.467341
R2513 VDD.n1317 VDD.n1288 0.467341
R2514 VDD.n1323 VDD.n1287 0.467341
R2515 VDD.n1329 VDD.n1286 0.467341
R2516 VDD.n1335 VDD.n1285 0.467341
R2517 VDD.n1341 VDD.n1284 0.467341
R2518 VDD.n1353 VDD.n1282 0.467341
R2519 VDD.n1359 VDD.n1281 0.467341
R2520 VDD.n1371 VDD.n1279 0.467341
R2521 VDD.n1377 VDD.n1278 0.467341
R2522 VDD.n1383 VDD.n1277 0.467341
R2523 VDD.n1389 VDD.n1276 0.467341
R2524 VDD.n1395 VDD.n1275 0.467341
R2525 VDD.n1407 VDD.n1273 0.467341
R2526 VDD.n1419 VDD.n1271 0.467341
R2527 VDD.n1425 VDD.n1270 0.467341
R2528 VDD.n1443 VDD.n1267 0.467341
R2529 VDD.n1449 VDD.n1266 0.467341
R2530 VDD.n1461 VDD.n1264 0.467341
R2531 VDD.n1467 VDD.n1263 0.467341
R2532 VDD.n1473 VDD.n1262 0.467341
R2533 VDD.n1550 VDD.n1542 0.467341
R2534 VDD.n1556 VDD.n1541 0.467341
R2535 VDD.n1562 VDD.n1540 0.467341
R2536 VDD.n1574 VDD.n1538 0.467341
R2537 VDD.n1592 VDD.n1535 0.467341
R2538 VDD.n1598 VDD.n1534 0.467341
R2539 VDD.n1604 VDD.n1533 0.467341
R2540 VDD.n1610 VDD.n1532 0.467341
R2541 VDD.n1616 VDD.n1531 0.467341
R2542 VDD.n1622 VDD.n1530 0.467341
R2543 VDD.n1628 VDD.n1529 0.467341
R2544 VDD.n1646 VDD.n1526 0.467341
R2545 VDD.n1652 VDD.n1525 0.467341
R2546 VDD.n1658 VDD.n1524 0.467341
R2547 VDD.n1676 VDD.n1521 0.467341
R2548 VDD.n1682 VDD.n1520 0.467341
R2549 VDD.n1688 VDD.n1519 0.467341
R2550 VDD.n1700 VDD.n1517 0.467341
R2551 VDD.n1706 VDD.n1516 0.467341
R2552 VDD.n1718 VDD.n1514 0.467341
R2553 VDD.n1724 VDD.n1513 0.467341
R2554 VDD.n769 VDD.n768 0.467341
R2555 VDD.n775 VDD.n767 0.467341
R2556 VDD.n787 VDD.n765 0.467341
R2557 VDD.n793 VDD.n764 0.467341
R2558 VDD.n799 VDD.n763 0.467341
R2559 VDD.n805 VDD.n762 0.467341
R2560 VDD.n811 VDD.n761 0.467341
R2561 VDD.n823 VDD.n759 0.467341
R2562 VDD.n829 VDD.n758 0.467341
R2563 VDD.n835 VDD.n757 0.467341
R2564 VDD.n841 VDD.n756 0.467341
R2565 VDD.n865 VDD.n752 0.467341
R2566 VDD.n877 VDD.n750 0.467341
R2567 VDD.n883 VDD.n749 0.467341
R2568 VDD.n889 VDD.n748 0.467341
R2569 VDD.n907 VDD.n745 0.467341
R2570 VDD.n931 VDD.n741 0.467341
R2571 VDD.n937 VDD.n740 0.467341
R2572 VDD.n943 VDD.n739 0.467341
R2573 VDD.n949 VDD.n738 0.467341
R2574 VDD.n611 VDD.n504 0.467258
R2575 VDD.n587 VDD.n508 0.467143
R2576 VDD.n635 VDD.n500 0.467091
R2577 VDD.n617 VDD.n503 0.467079
R2578 VDD.n713 VDD.n487 0.466945
R2579 VDD.n623 VDD.n502 0.466912
R2580 VDD.n1054 VDD.n1039 0.466909
R2581 VDD.n1060 VDD.n1038 0.466909
R2582 VDD.n1066 VDD.n1037 0.466909
R2583 VDD.n1072 VDD.n1036 0.466909
R2584 VDD.n1078 VDD.n1035 0.466909
R2585 VDD.n1096 VDD.n1032 0.466909
R2586 VDD.n1102 VDD.n1031 0.466909
R2587 VDD.n1132 VDD.n1026 0.466909
R2588 VDD.n1162 VDD.n1021 0.466909
R2589 VDD.n1168 VDD.n1020 0.466909
R2590 VDD.n1204 VDD.n1014 0.466909
R2591 VDD.n1305 VDD.n1290 0.466909
R2592 VDD.n1347 VDD.n1283 0.466909
R2593 VDD.n1365 VDD.n1280 0.466909
R2594 VDD.n1401 VDD.n1274 0.466909
R2595 VDD.n1413 VDD.n1272 0.466909
R2596 VDD.n1431 VDD.n1269 0.466909
R2597 VDD.n1437 VDD.n1268 0.466909
R2598 VDD.n1455 VDD.n1265 0.466909
R2599 VDD.n1544 VDD.n1543 0.466909
R2600 VDD.n1568 VDD.n1539 0.466909
R2601 VDD.n1580 VDD.n1537 0.466909
R2602 VDD.n1586 VDD.n1536 0.466909
R2603 VDD.n1634 VDD.n1528 0.466909
R2604 VDD.n1640 VDD.n1527 0.466909
R2605 VDD.n1664 VDD.n1523 0.466909
R2606 VDD.n1670 VDD.n1522 0.466909
R2607 VDD.n1694 VDD.n1518 0.466909
R2608 VDD.n1712 VDD.n1515 0.466909
R2609 VDD.n781 VDD.n766 0.466909
R2610 VDD.n817 VDD.n760 0.466909
R2611 VDD.n847 VDD.n755 0.466909
R2612 VDD.n853 VDD.n754 0.466909
R2613 VDD.n859 VDD.n753 0.466909
R2614 VDD.n871 VDD.n751 0.466909
R2615 VDD.n895 VDD.n747 0.466909
R2616 VDD.n901 VDD.n746 0.466909
R2617 VDD.n913 VDD.n744 0.466909
R2618 VDD.n919 VDD.n743 0.466909
R2619 VDD.n925 VDD.n742 0.466909
R2620 VDD.n701 VDD.n489 0.466909
R2621 VDD.n545 VDD.n515 0.466909
R2622 VDD.n563 VDD.n512 0.466798
R2623 VDD.n557 VDD.n513 0.466741
R2624 VDD.n641 VDD.n499 0.466699
R2625 VDD.n695 VDD.n490 0.466699
R2626 VDD.n647 VDD.n498 0.466677
R2627 VDD.n683 VDD.n492 0.466677
R2628 VDD.n671 VDD.n494 0.466592
R2629 VDD.n689 VDD.n491 0.466589
R2630 VDD.n581 VDD.n509 0.466559
R2631 VDD.n605 VDD.n505 0.466454
R2632 VDD.n593 VDD.n507 0.466439
R2633 VDD.n575 VDD.n510 0.466439
R2634 VDD.n677 VDD.n493 0.466426
R2635 VDD.n653 VDD.n497 0.466372
R2636 VDD.n665 VDD.n495 0.466257
R2637 VDD.n569 VDD.n511 0.466253
R2638 VDD.n707 VDD.n488 0.466103
R2639 VDD.n659 VDD.n496 0.466076
R2640 VDD.n629 VDD.n501 0.466076
R2641 VDD.n599 VDD.n506 0.466076
R2642 VDD.n551 VDD.n514 0.466076
R2643 VDD.n593 VDD.n506 0.45184
R2644 VDD.n653 VDD.n496 0.45184
R2645 VDD.n623 VDD.n501 0.45184
R2646 VDD.n545 VDD.n514 0.45184
R2647 VDD.n701 VDD.n488 0.451788
R2648 VDD.n563 VDD.n511 0.451699
R2649 VDD.n659 VDD.n495 0.451693
R2650 VDD.n647 VDD.n497 0.451585
R2651 VDD.n671 VDD.n493 0.451477
R2652 VDD.n569 VDD.n510 0.451469
R2653 VDD.n587 VDD.n507 0.451469
R2654 VDD.n599 VDD.n505 0.451423
R2655 VDD.n683 VDD.n491 0.451368
R2656 VDD.n575 VDD.n509 0.45132
R2657 VDD.n665 VDD.n494 0.451294
R2658 VDD.n677 VDD.n492 0.451265
R2659 VDD.n689 VDD.n490 0.451252
R2660 VDD.n635 VDD.n499 0.451252
R2661 VDD.n641 VDD.n498 0.451226
R2662 VDD.n551 VDD.n513 0.451193
R2663 VDD.n557 VDD.n512 0.451129
R2664 VDD.n707 VDD.n487 0.451058
R2665 VDD.n1060 VDD.n1039 0.451022
R2666 VDD.n1066 VDD.n1038 0.451022
R2667 VDD.n1072 VDD.n1037 0.451022
R2668 VDD.n1078 VDD.n1036 0.451022
R2669 VDD.n1084 VDD.n1035 0.451022
R2670 VDD.n1102 VDD.n1032 0.451022
R2671 VDD.n1108 VDD.n1031 0.451022
R2672 VDD.n1138 VDD.n1026 0.451022
R2673 VDD.n1168 VDD.n1021 0.451022
R2674 VDD.n1174 VDD.n1020 0.451022
R2675 VDD.n1210 VDD.n1014 0.451022
R2676 VDD.n1311 VDD.n1290 0.451022
R2677 VDD.n1353 VDD.n1283 0.451022
R2678 VDD.n1371 VDD.n1280 0.451022
R2679 VDD.n1407 VDD.n1274 0.451022
R2680 VDD.n1419 VDD.n1272 0.451022
R2681 VDD.n1437 VDD.n1269 0.451022
R2682 VDD.n1443 VDD.n1268 0.451022
R2683 VDD.n1461 VDD.n1265 0.451022
R2684 VDD.n1550 VDD.n1543 0.451022
R2685 VDD.n1574 VDD.n1539 0.451022
R2686 VDD.n1586 VDD.n1537 0.451022
R2687 VDD.n1592 VDD.n1536 0.451022
R2688 VDD.n1640 VDD.n1528 0.451022
R2689 VDD.n1646 VDD.n1527 0.451022
R2690 VDD.n1670 VDD.n1523 0.451022
R2691 VDD.n1676 VDD.n1522 0.451022
R2692 VDD.n1700 VDD.n1518 0.451022
R2693 VDD.n1718 VDD.n1515 0.451022
R2694 VDD.n787 VDD.n766 0.451022
R2695 VDD.n823 VDD.n760 0.451022
R2696 VDD.n853 VDD.n755 0.451022
R2697 VDD.n859 VDD.n754 0.451022
R2698 VDD.n865 VDD.n753 0.451022
R2699 VDD.n877 VDD.n751 0.451022
R2700 VDD.n901 VDD.n747 0.451022
R2701 VDD.n907 VDD.n746 0.451022
R2702 VDD.n919 VDD.n744 0.451022
R2703 VDD.n925 VDD.n743 0.451022
R2704 VDD.n931 VDD.n742 0.451022
R2705 VDD.n695 VDD.n489 0.451022
R2706 VDD.n539 VDD.n515 0.451022
R2707 VDD.n617 VDD.n502 0.451015
R2708 VDD.n629 VDD.n500 0.450884
R2709 VDD.n611 VDD.n503 0.450883
R2710 VDD.n581 VDD.n508 0.450828
R2711 VDD.n605 VDD.n504 0.450729
R2712 VDD.n1048 VDD.n1041 0.450618
R2713 VDD.n1054 VDD.n1040 0.450618
R2714 VDD.n1090 VDD.n1034 0.450618
R2715 VDD.n1096 VDD.n1033 0.450618
R2716 VDD.n1114 VDD.n1030 0.450618
R2717 VDD.n1120 VDD.n1029 0.450618
R2718 VDD.n1126 VDD.n1028 0.450618
R2719 VDD.n1132 VDD.n1027 0.450618
R2720 VDD.n1144 VDD.n1025 0.450618
R2721 VDD.n1150 VDD.n1024 0.450618
R2722 VDD.n1156 VDD.n1023 0.450618
R2723 VDD.n1162 VDD.n1022 0.450618
R2724 VDD.n1180 VDD.n1019 0.450618
R2725 VDD.n1186 VDD.n1018 0.450618
R2726 VDD.n1192 VDD.n1017 0.450618
R2727 VDD.n1198 VDD.n1016 0.450618
R2728 VDD.n1204 VDD.n1015 0.450618
R2729 VDD.n1216 VDD.n1013 0.450618
R2730 VDD.n1222 VDD.n1012 0.450618
R2731 VDD.n1228 VDD.n1011 0.450618
R2732 VDD.n1299 VDD.n1292 0.450618
R2733 VDD.n1305 VDD.n1291 0.450618
R2734 VDD.n1317 VDD.n1289 0.450618
R2735 VDD.n1323 VDD.n1288 0.450618
R2736 VDD.n1329 VDD.n1287 0.450618
R2737 VDD.n1335 VDD.n1286 0.450618
R2738 VDD.n1341 VDD.n1285 0.450618
R2739 VDD.n1347 VDD.n1284 0.450618
R2740 VDD.n1359 VDD.n1282 0.450618
R2741 VDD.n1365 VDD.n1281 0.450618
R2742 VDD.n1377 VDD.n1279 0.450618
R2743 VDD.n1383 VDD.n1278 0.450618
R2744 VDD.n1389 VDD.n1277 0.450618
R2745 VDD.n1395 VDD.n1276 0.450618
R2746 VDD.n1401 VDD.n1275 0.450618
R2747 VDD.n1413 VDD.n1273 0.450618
R2748 VDD.n1425 VDD.n1271 0.450618
R2749 VDD.n1431 VDD.n1270 0.450618
R2750 VDD.n1449 VDD.n1267 0.450618
R2751 VDD.n1455 VDD.n1266 0.450618
R2752 VDD.n1467 VDD.n1264 0.450618
R2753 VDD.n1473 VDD.n1263 0.450618
R2754 VDD.n1479 VDD.n1262 0.450618
R2755 VDD.n1556 VDD.n1542 0.450618
R2756 VDD.n1562 VDD.n1541 0.450618
R2757 VDD.n1568 VDD.n1540 0.450618
R2758 VDD.n1580 VDD.n1538 0.450618
R2759 VDD.n1598 VDD.n1535 0.450618
R2760 VDD.n1604 VDD.n1534 0.450618
R2761 VDD.n1610 VDD.n1533 0.450618
R2762 VDD.n1616 VDD.n1532 0.450618
R2763 VDD.n1622 VDD.n1531 0.450618
R2764 VDD.n1628 VDD.n1530 0.450618
R2765 VDD.n1634 VDD.n1529 0.450618
R2766 VDD.n1652 VDD.n1526 0.450618
R2767 VDD.n1658 VDD.n1525 0.450618
R2768 VDD.n1664 VDD.n1524 0.450618
R2769 VDD.n1682 VDD.n1521 0.450618
R2770 VDD.n1688 VDD.n1520 0.450618
R2771 VDD.n1694 VDD.n1519 0.450618
R2772 VDD.n1706 VDD.n1517 0.450618
R2773 VDD.n1712 VDD.n1516 0.450618
R2774 VDD.n1724 VDD.n1514 0.450618
R2775 VDD.n1730 VDD.n1513 0.450618
R2776 VDD.n775 VDD.n768 0.450618
R2777 VDD.n781 VDD.n767 0.450618
R2778 VDD.n793 VDD.n765 0.450618
R2779 VDD.n799 VDD.n764 0.450618
R2780 VDD.n805 VDD.n763 0.450618
R2781 VDD.n811 VDD.n762 0.450618
R2782 VDD.n817 VDD.n761 0.450618
R2783 VDD.n829 VDD.n759 0.450618
R2784 VDD.n835 VDD.n758 0.450618
R2785 VDD.n841 VDD.n757 0.450618
R2786 VDD.n847 VDD.n756 0.450618
R2787 VDD.n871 VDD.n752 0.450618
R2788 VDD.n883 VDD.n750 0.450618
R2789 VDD.n889 VDD.n749 0.450618
R2790 VDD.n895 VDD.n748 0.450618
R2791 VDD.n913 VDD.n745 0.450618
R2792 VDD.n937 VDD.n741 0.450618
R2793 VDD.n943 VDD.n740 0.450618
R2794 VDD.n949 VDD.n739 0.450618
R2795 VDD.n955 VDD.n738 0.450618
R2796 VDD.n527 VDD.n517 0.450539
R2797 VDD.n533 VDD.n516 0.450381
R2798 VDD.n263 VDD.n254 0.445771
R2799 VDD.n267 VDD.n255 0.445771
R2800 VDD.n271 VDD.n256 0.445771
R2801 VDD.n275 VDD.n257 0.445771
R2802 VDD.n277 VDD.n258 0.445771
R2803 VDD.n1789 VDD.n1788 0.432417
R2804 VDD.n146 VDD.n67 0.43027
R2805 VDD.n300 VDD.n139 0.0930507
R2806 VDD.n284 VDD.n460 0.429929
R2807 VDD.n1239 VDD.n1238 0.429766
R2808 VDD.n1490 VDD.n1489 0.429766
R2809 VDD.n1741 VDD.n1740 0.429766
R2810 VDD.n966 VDD.n965 0.429766
R2811 VDD.n519 VDD.n518 0.428915
R2812 VDD.n1236 VDD.n1235 0.427147
R2813 VDD.n264 VDD.n263 0.427147
R2814 VDD.n1487 VDD.n1486 0.427147
R2815 VDD.n268 VDD.n267 0.427147
R2816 VDD.n1738 VDD.n1737 0.427147
R2817 VDD.n272 VDD.n271 0.427147
R2818 VDD.n963 VDD.n962 0.427147
R2819 VDD.n276 VDD.n275 0.427147
R2820 VDD.n278 VDD.n521 0.427147
R2821 VDD.n279 VDD.n277 0.427147
R2822 VDD.n278 VDD.n518 0.426918
R2823 VDD.n1239 VDD.n1235 0.426171
R2824 VDD.n1490 VDD.n1486 0.426171
R2825 VDD.n1741 VDD.n1737 0.426171
R2826 VDD.n966 VDD.n962 0.426171
R2827 VDD.n457 VDD.n138 0.413465
R2828 VDD.n458 VDD.n260 0.413465
R2829 VDD.n737 VDD.n67 3.40985
R2830 VDD.n1789 VDD.n287 0.404427
R2831 VDD.t268 VDD.t270 0.383639
R2832 VDD.n1771 VDD.n1770 0.372655
R2833 VDD.n1767 VDD.n481 0.372571
R2834 VDD.n1083 VDD.n1082 0.35553
R2835 VDD.n1191 VDD.n1190 0.35553
R2836 VDD.n1585 VDD.n1584 0.35553
R2837 VDD.n858 VDD.n857 0.35553
R2838 VDD.n870 VDD.n869 0.35553
R2839 VDD.n894 VDD.n893 0.35553
R2840 VDD.n621 VDD.n620 0.35553
R2841 VDD.n1113 VDD.n1112 0.355452
R2842 VDD.n1047 VDD.n1046 0.355452
R2843 VDD.n1328 VDD.n1327 0.355452
R2844 VDD.n1424 VDD.n1423 0.355452
R2845 VDD.n1298 VDD.n1297 0.355452
R2846 VDD.n1418 VDD.n1417 0.355452
R2847 VDD.n1478 VDD.n1477 0.355452
R2848 VDD.n1645 VDD.n1644 0.355452
R2849 VDD.n1651 VDD.n1650 0.355452
R2850 VDD.n906 VDD.n905 0.355452
R2851 VDD.n828 VDD.n827 0.355452
R2852 VDD.n882 VDD.n881 0.355452
R2853 VDD.n567 VDD.n566 0.355452
R2854 VDD.n1143 VDD.n1142 0.355386
R2855 VDD.n1167 VDD.n1166 0.355386
R2856 VDD.n1358 VDD.n1357 0.355386
R2857 VDD.n1603 VDD.n1602 0.355386
R2858 VDD.n1639 VDD.n1638 0.355386
R2859 VDD.n1705 VDD.n1704 0.355386
R2860 VDD.n1717 VDD.n1716 0.355386
R2861 VDD.n792 VDD.n791 0.355386
R2862 VDD.n822 VDD.n821 0.355386
R2863 VDD.n918 VDD.n917 0.355386
R2864 VDD.n954 VDD.n953 0.355386
R2865 VDD.n615 VDD.n614 0.355386
R2866 VDD.n531 VDD.n530 0.355386
R2867 VDD.n1071 VDD.n1070 0.355312
R2868 VDD.n1077 VDD.n1076 0.355312
R2869 VDD.n1089 VDD.n1088 0.355312
R2870 VDD.n1101 VDD.n1100 0.355312
R2871 VDD.n1107 VDD.n1106 0.355312
R2872 VDD.n1125 VDD.n1124 0.355312
R2873 VDD.n1137 VDD.n1136 0.355312
R2874 VDD.n1221 VDD.n1220 0.355312
R2875 VDD.n1316 VDD.n1315 0.355312
R2876 VDD.n1364 VDD.n1363 0.355312
R2877 VDD.n1406 VDD.n1405 0.355312
R2878 VDD.n1621 VDD.n1620 0.355312
R2879 VDD.n1663 VDD.n1662 0.355312
R2880 VDD.n852 VDD.n851 0.355312
R2881 VDD.n900 VDD.n899 0.355312
R2882 VDD.n639 VDD.n638 0.355312
R2883 VDD.n1059 VDD.n1058 0.355155
R2884 VDD.n1149 VDD.n1148 0.355155
R2885 VDD.n1304 VDD.n1303 0.355155
R2886 VDD.n1340 VDD.n1339 0.355155
R2887 VDD.n1346 VDD.n1345 0.355155
R2888 VDD.n1376 VDD.n1375 0.355155
R2889 VDD.n1412 VDD.n1411 0.355155
R2890 VDD.n1442 VDD.n1441 0.355155
R2891 VDD.n1579 VDD.n1578 0.355155
R2892 VDD.n1681 VDD.n1680 0.355155
R2893 VDD.n1723 VDD.n1722 0.355155
R2894 VDD.n1591 VDD.n1590 0.355155
R2895 VDD.n1615 VDD.n1614 0.355155
R2896 VDD.n1627 VDD.n1626 0.355155
R2897 VDD.n1699 VDD.n1698 0.355155
R2898 VDD.n1729 VDD.n1728 0.355155
R2899 VDD.n912 VDD.n911 0.355155
R2900 VDD.n780 VDD.n779 0.355155
R2901 VDD.n798 VDD.n797 0.355155
R2902 VDD.n810 VDD.n809 0.355155
R2903 VDD.n840 VDD.n839 0.355155
R2904 VDD.n888 VDD.n887 0.355155
R2905 VDD.n942 VDD.n941 0.355155
R2906 VDD.n681 VDD.n680 0.355155
R2907 VDD.n561 VDD.n560 0.355155
R2908 VDD.n549 VDD.n548 0.355155
R2909 VDD.n687 VDD.n686 0.355155
R2910 VDD.n663 VDD.n662 0.355155
R2911 VDD.n645 VDD.n644 0.355155
R2912 VDD.n633 VDD.n632 0.355155
R2913 VDD.n585 VDD.n584 0.355155
R2914 VDD.n573 VDD.n572 0.355155
R2915 VDD.n834 VDD.n833 0.35515
R2916 VDD.n846 VDD.n845 0.35515
R2917 VDD.n1161 VDD.n1160 0.355071
R2918 VDD.n1466 VDD.n1465 0.355071
R2919 VDD.n1561 VDD.n1560 0.355071
R2920 VDD.n699 VDD.n698 0.355071
R2921 VDD.n627 VDD.n626 0.355071
R2922 VDD.n609 VDD.n608 0.355071
R2923 VDD.n543 VDD.n542 0.355071
R2924 VDD.n1179 VDD.n1178 0.35501
R2925 VDD.n1215 VDD.n1214 0.35501
R2926 VDD.n1448 VDD.n1447 0.35501
R2927 VDD.n1454 VDD.n1453 0.35501
R2928 VDD.n1693 VDD.n1692 0.35501
R2929 VDD.n1669 VDD.n1668 0.35501
R2930 VDD.n876 VDD.n875 0.35501
R2931 VDD.n1095 VDD.n1094 0.354936
R2932 VDD.n1203 VDD.n1202 0.354936
R2933 VDD.n1310 VDD.n1309 0.354936
R2934 VDD.n1370 VDD.n1369 0.354936
R2935 VDD.n1394 VDD.n1393 0.354936
R2936 VDD.n1567 VDD.n1566 0.354936
R2937 VDD.n1657 VDD.n1656 0.354936
R2938 VDD.n1675 VDD.n1674 0.354936
R2939 VDD.n804 VDD.n803 0.354936
R2940 VDD.n864 VDD.n863 0.354936
R2941 VDD.n930 VDD.n929 0.354936
R2942 VDD.n675 VDD.n674 0.354936
R2943 VDD.n603 VDD.n602 0.354936
R2944 VDD.n537 VDD.n536 0.354936
R2945 VDD.n774 VDD.n773 0.354903
R2946 VDD.n651 VDD.n650 0.354903
R2947 VDD.n1053 VDD.n1052 0.354838
R2948 VDD.n1131 VDD.n1130 0.354838
R2949 VDD.n1388 VDD.n1387 0.354838
R2950 VDD.n816 VDD.n815 0.354838
R2951 VDD.n657 VDD.n656 0.354838
R2952 VDD.n1197 VDD.n1196 0.354837
R2953 VDD.n1227 VDD.n1226 0.354837
R2954 VDD.n1322 VDD.n1321 0.354837
R2955 VDD.n1765 VDD.n1761 0.354771
R2956 VDD.n1065 VDD.n1064 0.354771
R2957 VDD.n1155 VDD.n1154 0.354771
R2958 VDD.n1173 VDD.n1172 0.354771
R2959 VDD.n1209 VDD.n1208 0.354771
R2960 VDD.n1334 VDD.n1333 0.354771
R2961 VDD.n1352 VDD.n1351 0.354771
R2962 VDD.n1382 VDD.n1381 0.354771
R2963 VDD.n1436 VDD.n1435 0.354771
R2964 VDD.n1460 VDD.n1459 0.354771
R2965 VDD.n1472 VDD.n1471 0.354771
R2966 VDD.n1555 VDD.n1554 0.354771
R2967 VDD.n1573 VDD.n1572 0.354771
R2968 VDD.n1597 VDD.n1596 0.354771
R2969 VDD.n1609 VDD.n1608 0.354771
R2970 VDD.n1711 VDD.n1710 0.354771
R2971 VDD.n786 VDD.n785 0.354771
R2972 VDD.n924 VDD.n923 0.354771
R2973 VDD.n936 VDD.n935 0.354771
R2974 VDD.n711 VDD.n710 0.354771
R2975 VDD.n705 VDD.n704 0.354771
R2976 VDD.n597 VDD.n596 0.354771
R2977 VDD.n579 VDD.n578 0.354771
R2978 VDD.n1119 VDD.n1118 0.354697
R2979 VDD.n1400 VDD.n1399 0.354697
R2980 VDD.n1430 VDD.n1429 0.354697
R2981 VDD.n1549 VDD.n1548 0.354697
R2982 VDD.n1633 VDD.n1632 0.354697
R2983 VDD.n1687 VDD.n1686 0.354697
R2984 VDD.n948 VDD.n947 0.354697
R2985 VDD.n693 VDD.n692 0.354697
R2986 VDD.n669 VDD.n668 0.354697
R2987 VDD.n591 VDD.n590 0.354697
R2988 VDD.n1762 VDD.n483 0.354692
R2989 VDD.n1185 VDD.n1184 0.354692
R2990 VDD.n555 VDD.n554 0.354692
R2991 VDD.n1772 VDD.n480 0.347655
R2992 VDD.n1776 VDD.n1775 0.347571
R2993 VDD.n1762 VDD.n482 0.347254
R2994 VDD.n1766 VDD.n1765 0.347039
R2995 VDD.n1744 VDD.n1743 0.342527
R2996 VDD.n478 VDD.n476 0.335799
R2997 VDD.n466 VDD.n465 0.335496
R2998 VDD.n1780 VDD.n1776 0.334771
R2999 VDD.n1782 VDD.n480 0.334692
R3000 VDD.n469 VDD.n466 0.332368
R3001 VDD.n478 VDD.n289 0.332058
R3002 VDD.n1778 VDD.n288 0.33018
R3003 VDD.n1770 VDD.n1766 0.329132
R3004 VDD.n1767 VDD.n482 0.328947
R3005 VDD.n1750 VDD.n483 0.327655
R3006 VDD.n1761 VDD.n1760 0.327571
R3007 VDD.t810 VDD.n6 15.0851
R3008 VDD.t799 VDD.n0 15.0851
R3009 VDD.t788 VDD.n3 15.0851
R3010 VDD.n144 VDD.t755 15.0851
R3011 VDD.n282 VDD.n457 0.327154
R3012 VDD.n177 VDD.n458 0.327154
R3013 VDD.n473 VDD.n472 0.32704
R3014 VDD.n1754 VDD.n485 0.319637
R3015 VDD.n1237 VDD.n1236 0.313013
R3016 VDD.n1488 VDD.n1487 0.313013
R3017 VDD.n1739 VDD.n1738 0.313013
R3018 VDD.n964 VDD.n963 0.313013
R3019 VDD.n521 VDD.n520 0.313013
R3020 VDD.n1188 VDD.n1185 0.310155
R3021 VDD.n554 VDD.n553 0.310155
R3022 VDD.n1122 VDD.n1119 0.31015
R3023 VDD.n1403 VDD.n1400 0.31015
R3024 VDD.n1433 VDD.n1430 0.31015
R3025 VDD.n1552 VDD.n1549 0.31015
R3026 VDD.n1636 VDD.n1633 0.31015
R3027 VDD.n1690 VDD.n1687 0.31015
R3028 VDD.n951 VDD.n948 0.31015
R3029 VDD.n692 VDD.n691 0.31015
R3030 VDD.n668 VDD.n667 0.31015
R3031 VDD.n590 VDD.n589 0.31015
R3032 VDD.n1068 VDD.n1065 0.310071
R3033 VDD.n1158 VDD.n1155 0.310071
R3034 VDD.n1176 VDD.n1173 0.310071
R3035 VDD.n1212 VDD.n1209 0.310071
R3036 VDD.n1337 VDD.n1334 0.310071
R3037 VDD.n1355 VDD.n1352 0.310071
R3038 VDD.n1385 VDD.n1382 0.310071
R3039 VDD.n1439 VDD.n1436 0.310071
R3040 VDD.n1463 VDD.n1460 0.310071
R3041 VDD.n1475 VDD.n1472 0.310071
R3042 VDD.n1558 VDD.n1555 0.310071
R3043 VDD.n1576 VDD.n1573 0.310071
R3044 VDD.n1600 VDD.n1597 0.310071
R3045 VDD.n1612 VDD.n1609 0.310071
R3046 VDD.n1714 VDD.n1711 0.310071
R3047 VDD.n789 VDD.n786 0.310071
R3048 VDD.n927 VDD.n924 0.310071
R3049 VDD.n939 VDD.n936 0.310071
R3050 VDD.n710 VDD.n709 0.310071
R3051 VDD.n704 VDD.n703 0.310071
R3052 VDD.n596 VDD.n595 0.310071
R3053 VDD.n578 VDD.n577 0.310071
R3054 VDD.n1230 VDD.n1227 0.31001
R3055 VDD.n1200 VDD.n1197 0.31001
R3056 VDD.n1325 VDD.n1322 0.31001
R3057 VDD.n1056 VDD.n1053 0.309994
R3058 VDD.n1134 VDD.n1131 0.309994
R3059 VDD.n1391 VDD.n1388 0.309994
R3060 VDD.n819 VDD.n816 0.309994
R3061 VDD.n656 VDD.n655 0.309994
R3062 VDD.n777 VDD.n774 0.309933
R3063 VDD.n650 VDD.n649 0.309933
R3064 VDD.n1098 VDD.n1095 0.309928
R3065 VDD.n1206 VDD.n1203 0.309928
R3066 VDD.n1313 VDD.n1310 0.309928
R3067 VDD.n1373 VDD.n1370 0.309928
R3068 VDD.n1397 VDD.n1394 0.309928
R3069 VDD.n1570 VDD.n1567 0.309928
R3070 VDD.n1660 VDD.n1657 0.309928
R3071 VDD.n1678 VDD.n1675 0.309928
R3072 VDD.n807 VDD.n804 0.309928
R3073 VDD.n867 VDD.n864 0.309928
R3074 VDD.n933 VDD.n930 0.309928
R3075 VDD.n674 VDD.n673 0.309928
R3076 VDD.n602 VDD.n601 0.309928
R3077 VDD.n536 VDD.n535 0.309928
R3078 VDD.n1218 VDD.n1215 0.309837
R3079 VDD.n1451 VDD.n1448 0.309837
R3080 VDD.n1696 VDD.n1693 0.309837
R3081 VDD.n879 VDD.n876 0.309837
R3082 VDD.n1182 VDD.n1179 0.309837
R3083 VDD.n1457 VDD.n1454 0.309837
R3084 VDD.n1672 VDD.n1669 0.309837
R3085 VDD.n1772 VDD.n481 0.309771
R3086 VDD.n1164 VDD.n1161 0.309771
R3087 VDD.n1469 VDD.n1466 0.309771
R3088 VDD.n1564 VDD.n1561 0.309771
R3089 VDD.n698 VDD.n697 0.309771
R3090 VDD.n626 VDD.n625 0.309771
R3091 VDD.n608 VDD.n607 0.309771
R3092 VDD.n542 VDD.n541 0.309771
R3093 VDD.n837 VDD.n834 0.309697
R3094 VDD.n849 VDD.n846 0.309697
R3095 VDD.n1307 VDD.n1304 0.309692
R3096 VDD.n1379 VDD.n1376 0.309692
R3097 VDD.n1630 VDD.n1627 0.309692
R3098 VDD.n1684 VDD.n1681 0.309692
R3099 VDD.n1726 VDD.n1723 0.309692
R3100 VDD.n843 VDD.n840 0.309692
R3101 VDD.n945 VDD.n942 0.309692
R3102 VDD.n662 VDD.n661 0.309692
R3103 VDD.n644 VDD.n643 0.309692
R3104 VDD.n560 VDD.n559 0.309692
R3105 VDD.n1775 VDD.n1771 0.309692
R3106 VDD.n1062 VDD.n1059 0.309692
R3107 VDD.n1152 VDD.n1149 0.309692
R3108 VDD.n1343 VDD.n1340 0.309692
R3109 VDD.n1349 VDD.n1346 0.309692
R3110 VDD.n1415 VDD.n1412 0.309692
R3111 VDD.n1445 VDD.n1442 0.309692
R3112 VDD.n1582 VDD.n1579 0.309692
R3113 VDD.n1594 VDD.n1591 0.309692
R3114 VDD.n1618 VDD.n1615 0.309692
R3115 VDD.n1702 VDD.n1699 0.309692
R3116 VDD.n1732 VDD.n1729 0.309692
R3117 VDD.n783 VDD.n780 0.309692
R3118 VDD.n801 VDD.n798 0.309692
R3119 VDD.n813 VDD.n810 0.309692
R3120 VDD.n891 VDD.n888 0.309692
R3121 VDD.n915 VDD.n912 0.309692
R3122 VDD.n686 VDD.n685 0.309692
R3123 VDD.n680 VDD.n679 0.309692
R3124 VDD.n632 VDD.n631 0.309692
R3125 VDD.n584 VDD.n583 0.309692
R3126 VDD.n572 VDD.n571 0.309692
R3127 VDD.n548 VDD.n547 0.309692
R3128 VDD.n1074 VDD.n1071 0.309557
R3129 VDD.n1080 VDD.n1077 0.309557
R3130 VDD.n1092 VDD.n1089 0.309557
R3131 VDD.n1104 VDD.n1101 0.309557
R3132 VDD.n1110 VDD.n1107 0.309557
R3133 VDD.n1128 VDD.n1125 0.309557
R3134 VDD.n1140 VDD.n1137 0.309557
R3135 VDD.n1224 VDD.n1221 0.309557
R3136 VDD.n1319 VDD.n1316 0.309557
R3137 VDD.n1367 VDD.n1364 0.309557
R3138 VDD.n1409 VDD.n1406 0.309557
R3139 VDD.n1624 VDD.n1621 0.309557
R3140 VDD.n1666 VDD.n1663 0.309557
R3141 VDD.n855 VDD.n852 0.309557
R3142 VDD.n903 VDD.n900 0.309557
R3143 VDD.n638 VDD.n637 0.309557
R3144 VDD.n1146 VDD.n1143 0.309483
R3145 VDD.n1170 VDD.n1167 0.309483
R3146 VDD.n1361 VDD.n1358 0.309483
R3147 VDD.n1606 VDD.n1603 0.309483
R3148 VDD.n1642 VDD.n1639 0.309483
R3149 VDD.n1708 VDD.n1705 0.309483
R3150 VDD.n1720 VDD.n1717 0.309483
R3151 VDD.n795 VDD.n792 0.309483
R3152 VDD.n825 VDD.n822 0.309483
R3153 VDD.n921 VDD.n918 0.309483
R3154 VDD.n957 VDD.n954 0.309483
R3155 VDD.n614 VDD.n613 0.309483
R3156 VDD.n530 VDD.n529 0.309483
R3157 VDD.n1050 VDD.n1047 0.309405
R3158 VDD.n1116 VDD.n1113 0.309405
R3159 VDD.n1301 VDD.n1298 0.309405
R3160 VDD.n1331 VDD.n1328 0.309405
R3161 VDD.n1421 VDD.n1418 0.309405
R3162 VDD.n1427 VDD.n1424 0.309405
R3163 VDD.n1481 VDD.n1478 0.309405
R3164 VDD.n1648 VDD.n1645 0.309405
R3165 VDD.n1654 VDD.n1651 0.309405
R3166 VDD.n831 VDD.n828 0.309405
R3167 VDD.n885 VDD.n882 0.309405
R3168 VDD.n909 VDD.n906 0.309405
R3169 VDD.n566 VDD.n565 0.309405
R3170 VDD.n1086 VDD.n1083 0.309333
R3171 VDD.n1194 VDD.n1191 0.309333
R3172 VDD.n1588 VDD.n1585 0.309333
R3173 VDD.n861 VDD.n858 0.309333
R3174 VDD.n873 VDD.n870 0.309333
R3175 VDD.n897 VDD.n894 0.309333
R3176 VDD.n620 VDD.n619 0.309333
R3177 VDD.n455 VDD.n454 0.306614
R3178 VDD.n464 VDD.n463 0.298721
R3179 VDD.n1228 VDD.n165 0.29124
R3180 VDD.n1479 VDD.n167 0.29124
R3181 VDD.n527 VDD.n173 0.291071
R3182 VDD.n1730 VDD.n169 0.290887
R3183 VDD.n955 VDD.n171 0.290887
R3184 VDD VDD.n289 0.423614
R3185 VDD.n8 VDD.t399 0.549263
R3186 VDD.n2 VDD.t281 0.549201
R3187 VDD.n5 VDD.t275 0.549201
R3188 VDD.n10 VDD.t301 0.549263
R3189 VDD.n147 VDD.t297 0.984813
R3190 VDD.n990 VDD.n989 0.284268
R3191 VDD.n1241 VDD.n1240 0.284268
R3192 VDD.n1492 VDD.n1491 0.284268
R3193 VDD.n968 VDD.n967 0.284268
R3194 VDD.n717 VDD.n716 0.284268
R3195 VDD.n472 VDD.n471 0.282613
R3196 VDD.n991 VDD.n990 0.282549
R3197 VDD.n1242 VDD.n1241 0.282549
R3198 VDD.n1493 VDD.n1492 0.282549
R3199 VDD.n969 VDD.n968 0.282549
R3200 VDD.n718 VDD.n717 0.282549
R3201 VDD.n429 VDD.n992 0.279247
R3202 VDD.n311 VDD.n1007 0.279247
R3203 VDD.n426 VDD.n1243 0.279247
R3204 VDD.n331 VDD.n1258 0.279247
R3205 VDD.n423 VDD.n1494 0.279247
R3206 VDD.n351 VDD.n1509 0.279247
R3207 VDD.n420 VDD.n970 0.279247
R3208 VDD.n371 VDD.n985 0.279247
R3209 VDD.n417 VDD.n719 0.279247
R3210 VDD.n391 VDD.n734 0.279247
R3211 VDD.n1293 VDD.n1 0.435454
R3212 VDD.n1544 VDD.n4 0.435454
R3213 VDD.n148 VDD.n147 0.0988687
R3214 VDD.n67 VDD.n66 0.15919
R3215 VDD.n2 VDD.n1 0.0990691
R3216 VDD.n5 VDD.n4 0.0990691
R3217 VDD.n8 VDD.n7 0.0990076
R3218 VDD.n10 VDD.n9 0.0990076
R3219 VDD.n1261 VDD.n140 0.349045
R3220 VDD.n1512 VDD.n141 0.349045
R3221 VDD.n1744 VDD.n988 0.269193
R3222 VDD.n143 VDD.n737 0.349045
R3223 VDD.n1001 VDD.n989 0.268799
R3224 VDD.n1252 VDD.n1240 0.268799
R3225 VDD.n1503 VDD.n1491 0.268799
R3226 VDD.n979 VDD.n967 0.268799
R3227 VDD.n728 VDD.n716 0.268799
R3228 VDD.n431 VDD.n429 0.267977
R3229 VDD.n428 VDD.n426 0.267977
R3230 VDD.n425 VDD.n423 0.267977
R3231 VDD.n422 VDD.n420 0.267977
R3232 VDD.n419 VDD.n417 0.267977
R3233 VDD.n465 VDD.n464 0.260496
R3234 VDD.n1742 VDD.n485 0.259637
R3235 VDD.n1785 VDD.n1784 0.253639
R3236 VDD.n1757 VDD.n1756 0.253639
R3237 VDD.n460 VDD.n260 0.25333
R3238 VDD.n1786 VDD.n1785 0.253298
R3239 VDD.n1758 VDD.n1757 0.253298
R3240 VDD.n148 VDD.n146 0.252989
R3241 VDD VDD.n288 0.250961
R3242 VDD.n170 VDD.n169 0.243387
R3243 VDD.n172 VDD.n171 0.243387
R3244 VDD.n174 VDD.n173 0.243218
R3245 VDD.n166 VDD.n165 0.243044
R3246 VDD.n168 VDD.n167 0.243044
R3247 VDD.n992 VDD.n991 0.241768
R3248 VDD.n1243 VDD.n1242 0.241768
R3249 VDD.n1494 VDD.n1493 0.241768
R3250 VDD.n970 VDD.n969 0.241768
R3251 VDD.n719 VDD.n718 0.241768
R3252 VDD.n462 VDD.n301 4.71183
R3253 VDD.n285 VDD.n284 0.706063
R3254 VDD VDD.n287 0.521582
R3255 VDD.n299 VDD.n298 0.484477
R3256 VDD.n297 VDD.n296 0.484477
R3257 VDD.n295 VDD.n294 0.484477
R3258 VDD.n293 VDD.n292 0.484477
R3259 VDD.n291 VDD.n290 0.484477
R3260 VDD.n281 VDD.t786 15.0439
R3261 VDD.n281 VDD.n260 0.130762
R3262 VDD.n284 VDD.n178 0.291774
R3263 VDD.n312 VDD.n311 0.222977
R3264 VDD.n332 VDD.n331 0.222977
R3265 VDD.n352 VDD.n351 0.222977
R3266 VDD.n372 VDD.n371 0.222977
R3267 VDD.n392 VDD.n391 0.222977
R3268 VDD.n150 VDD.n149 0.251712
R3269 VDD.n132 VDD.n131 0.251712
R3270 VDD.n130 VDD.n129 0.251712
R3271 VDD.n1003 VDD.n151 0.251712
R3272 VDD.n126 VDD.n125 0.251712
R3273 VDD.n124 VDD.n123 0.251712
R3274 VDD.n153 VDD.n152 0.251712
R3275 VDD.n121 VDD.n120 0.251712
R3276 VDD.n119 VDD.n118 0.251712
R3277 VDD.n1254 VDD.n154 0.251712
R3278 VDD.n115 VDD.n114 0.251712
R3279 VDD.n113 VDD.n112 0.251712
R3280 VDD.n156 VDD.n155 0.251712
R3281 VDD.n110 VDD.n109 0.251712
R3282 VDD.n108 VDD.n107 0.251712
R3283 VDD.n1505 VDD.n157 0.251712
R3284 VDD.n104 VDD.n103 0.251712
R3285 VDD.n102 VDD.n101 0.251712
R3286 VDD.n159 VDD.n158 0.251712
R3287 VDD.n99 VDD.n98 0.251712
R3288 VDD.n97 VDD.n96 0.251712
R3289 VDD.n981 VDD.n160 0.251712
R3290 VDD.n93 VDD.n92 0.251712
R3291 VDD.n91 VDD.n90 0.251712
R3292 VDD.n162 VDD.n161 0.251712
R3293 VDD.n88 VDD.n87 0.251712
R3294 VDD.n86 VDD.n85 0.251712
R3295 VDD.n730 VDD.n163 0.251712
R3296 VDD.n82 VDD.n81 0.251712
R3297 VDD.n80 VDD.n79 0.251712
R3298 VDD.n451 VDD.n45 0.272485
R3299 VDD.n44 VDD.n43 0.272485
R3300 VDD.n450 VDD.n42 0.272485
R3301 VDD.n41 VDD.n40 0.272485
R3302 VDD.n449 VDD.n39 0.272485
R3303 VDD.n448 VDD.n50 0.272485
R3304 VDD.n447 VDD.n38 0.272485
R3305 VDD.n37 VDD.n36 0.272485
R3306 VDD.n446 VDD.n35 0.272485
R3307 VDD.n34 VDD.n33 0.272485
R3308 VDD.n445 VDD.n32 0.272485
R3309 VDD.n444 VDD.n49 0.272485
R3310 VDD.n443 VDD.n31 0.272485
R3311 VDD.n30 VDD.n29 0.272485
R3312 VDD.n442 VDD.n28 0.272485
R3313 VDD.n27 VDD.n26 0.272485
R3314 VDD.n441 VDD.n25 0.272485
R3315 VDD.n440 VDD.n48 0.272485
R3316 VDD.n439 VDD.n24 0.272485
R3317 VDD.n23 VDD.n22 0.272485
R3318 VDD.n438 VDD.n21 0.272485
R3319 VDD.n20 VDD.n19 0.272485
R3320 VDD.n437 VDD.n18 0.272485
R3321 VDD.n436 VDD.n47 0.272485
R3322 VDD.n435 VDD.n17 0.272485
R3323 VDD.n16 VDD.n15 0.272485
R3324 VDD.n434 VDD.n14 0.272485
R3325 VDD.n13 VDD.n12 0.272485
R3326 VDD.n433 VDD.n11 0.272485
R3327 VDD.n432 VDD.n46 0.272485
R3328 VDD.n139 VDD.n283 0.109866
R3329 VDD.n260 VDD.n259 0.0835447
R3330 VDD.n178 VDD.n175 0.100238
R3331 VDD.n475 VDD.n474 0.202075
R3332 VDD.n1760 VDD.n1749 0.191924
R3333 VDD.n1750 VDD.n484 0.191793
R3334 VDD.n1786 VDD.n287 0.189333
R3335 VDD.n1780 VDD.n1777 0.184552
R3336 VDD.n1782 VDD.n479 0.184424
R3337 VDD.n995 VDD.n994 0.181058
R3338 VDD.n1246 VDD.n1245 0.181058
R3339 VDD.n1497 VDD.n1496 0.181058
R3340 VDD.n973 VDD.n972 0.181058
R3341 VDD.n722 VDD.n721 0.181058
R3342 VDD.n1752 VDD.n1748 0.179888
R3343 VDD.n474 VDD.n473 0.175486
R3344 VDD.n471 VDD.n470 0.171736
R3345 VDD.n1735 VDD.n1734 0.169888
R3346 VDD.n525 VDD.n524 0.169888
R3347 VDD.n1747 VDD.n1746 0.16955
R3348 VDD.n1233 VDD.n1232 0.16955
R3349 VDD.n1484 VDD.n1483 0.16955
R3350 VDD.n960 VDD.n959 0.16955
R3351 VDD.n999 VDD.n430 0.210474
R3352 VDD.n1250 VDD.n427 0.210474
R3353 VDD.n1501 VDD.n424 0.210474
R3354 VDD.n977 VDD.n421 0.210474
R3355 VDD.n726 VDD.n418 0.210474
R3356 VDD.n1045 VDD.n1044 0.162388
R3357 VDD.n1051 VDD.n1050 0.162388
R3358 VDD.n1075 VDD.n1074 0.162388
R3359 VDD.n1087 VDD.n1086 0.162388
R3360 VDD.n1099 VDD.n1098 0.162388
R3361 VDD.n1111 VDD.n1110 0.162388
R3362 VDD.n1117 VDD.n1116 0.162388
R3363 VDD.n1123 VDD.n1122 0.162388
R3364 VDD.n1183 VDD.n1182 0.162388
R3365 VDD.n1189 VDD.n1188 0.162388
R3366 VDD.n1195 VDD.n1194 0.162388
R3367 VDD.n1201 VDD.n1200 0.162388
R3368 VDD.n1207 VDD.n1206 0.162388
R3369 VDD.n1219 VDD.n1218 0.162388
R3370 VDD.n1225 VDD.n1224 0.162388
R3371 VDD.n1332 VDD.n1331 0.162388
R3372 VDD.n1344 VDD.n1343 0.162388
R3373 VDD.n1356 VDD.n1355 0.162388
R3374 VDD.n1374 VDD.n1373 0.162388
R3375 VDD.n1380 VDD.n1379 0.162388
R3376 VDD.n1386 VDD.n1385 0.162388
R3377 VDD.n1398 VDD.n1397 0.162388
R3378 VDD.n1404 VDD.n1403 0.162388
R3379 VDD.n1410 VDD.n1409 0.162388
R3380 VDD.n1416 VDD.n1415 0.162388
R3381 VDD.n1428 VDD.n1427 0.162388
R3382 VDD.n1446 VDD.n1445 0.162388
R3383 VDD.n1452 VDD.n1451 0.162388
R3384 VDD.n1458 VDD.n1457 0.162388
R3385 VDD.n1464 VDD.n1463 0.162388
R3386 VDD.n1470 VDD.n1469 0.162388
R3387 VDD.n1559 VDD.n1558 0.162388
R3388 VDD.n1565 VDD.n1564 0.162388
R3389 VDD.n1583 VDD.n1582 0.162388
R3390 VDD.n1601 VDD.n1600 0.162388
R3391 VDD.n1631 VDD.n1630 0.162388
R3392 VDD.n1679 VDD.n1678 0.162388
R3393 VDD.n784 VDD.n783 0.162388
R3394 VDD.n802 VDD.n801 0.162388
R3395 VDD.n820 VDD.n819 0.162388
R3396 VDD.n844 VDD.n843 0.162388
R3397 VDD.n850 VDD.n849 0.162388
R3398 VDD.n856 VDD.n855 0.162388
R3399 VDD.n862 VDD.n861 0.162388
R3400 VDD.n886 VDD.n885 0.162388
R3401 VDD.n892 VDD.n891 0.162388
R3402 VDD.n934 VDD.n933 0.162388
R3403 VDD.n715 VDD.n712 0.162388
R3404 VDD.n697 VDD.n694 0.162388
R3405 VDD.n625 VDD.n622 0.162388
R3406 VDD.n607 VDD.n604 0.162388
R3407 VDD.n595 VDD.n592 0.162388
R3408 VDD.n589 VDD.n586 0.162388
R3409 VDD.n535 VDD.n532 0.162388
R3410 VDD.n1057 VDD.n1056 0.16205
R3411 VDD.n1063 VDD.n1062 0.16205
R3412 VDD.n1069 VDD.n1068 0.16205
R3413 VDD.n1081 VDD.n1080 0.16205
R3414 VDD.n1093 VDD.n1092 0.16205
R3415 VDD.n1105 VDD.n1104 0.16205
R3416 VDD.n1129 VDD.n1128 0.16205
R3417 VDD.n1135 VDD.n1134 0.16205
R3418 VDD.n1141 VDD.n1140 0.16205
R3419 VDD.n1147 VDD.n1146 0.16205
R3420 VDD.n1153 VDD.n1152 0.16205
R3421 VDD.n1159 VDD.n1158 0.16205
R3422 VDD.n1165 VDD.n1164 0.16205
R3423 VDD.n1171 VDD.n1170 0.16205
R3424 VDD.n1177 VDD.n1176 0.16205
R3425 VDD.n1213 VDD.n1212 0.16205
R3426 VDD.n1231 VDD.n1230 0.16205
R3427 VDD.n1296 VDD.n1295 0.16205
R3428 VDD.n1302 VDD.n1301 0.16205
R3429 VDD.n1308 VDD.n1307 0.16205
R3430 VDD.n1314 VDD.n1313 0.16205
R3431 VDD.n1320 VDD.n1319 0.16205
R3432 VDD.n1326 VDD.n1325 0.16205
R3433 VDD.n1338 VDD.n1337 0.16205
R3434 VDD.n1350 VDD.n1349 0.16205
R3435 VDD.n1362 VDD.n1361 0.16205
R3436 VDD.n1368 VDD.n1367 0.16205
R3437 VDD.n1392 VDD.n1391 0.16205
R3438 VDD.n1422 VDD.n1421 0.16205
R3439 VDD.n1434 VDD.n1433 0.16205
R3440 VDD.n1440 VDD.n1439 0.16205
R3441 VDD.n1476 VDD.n1475 0.16205
R3442 VDD.n1482 VDD.n1481 0.16205
R3443 VDD.n1547 VDD.n1546 0.16205
R3444 VDD.n1553 VDD.n1552 0.16205
R3445 VDD.n1571 VDD.n1570 0.16205
R3446 VDD.n1577 VDD.n1576 0.16205
R3447 VDD.n1589 VDD.n1588 0.16205
R3448 VDD.n1595 VDD.n1594 0.16205
R3449 VDD.n1607 VDD.n1606 0.16205
R3450 VDD.n1613 VDD.n1612 0.16205
R3451 VDD.n1619 VDD.n1618 0.16205
R3452 VDD.n1625 VDD.n1624 0.16205
R3453 VDD.n1637 VDD.n1636 0.16205
R3454 VDD.n1643 VDD.n1642 0.16205
R3455 VDD.n1649 VDD.n1648 0.16205
R3456 VDD.n1655 VDD.n1654 0.16205
R3457 VDD.n1661 VDD.n1660 0.16205
R3458 VDD.n1667 VDD.n1666 0.16205
R3459 VDD.n1673 VDD.n1672 0.16205
R3460 VDD.n1685 VDD.n1684 0.16205
R3461 VDD.n1691 VDD.n1690 0.16205
R3462 VDD.n1697 VDD.n1696 0.16205
R3463 VDD.n1703 VDD.n1702 0.16205
R3464 VDD.n1709 VDD.n1708 0.16205
R3465 VDD.n1715 VDD.n1714 0.16205
R3466 VDD.n1721 VDD.n1720 0.16205
R3467 VDD.n1727 VDD.n1726 0.16205
R3468 VDD.n1733 VDD.n1732 0.16205
R3469 VDD.n772 VDD.n771 0.16205
R3470 VDD.n778 VDD.n777 0.16205
R3471 VDD.n790 VDD.n789 0.16205
R3472 VDD.n796 VDD.n795 0.16205
R3473 VDD.n808 VDD.n807 0.16205
R3474 VDD.n814 VDD.n813 0.16205
R3475 VDD.n826 VDD.n825 0.16205
R3476 VDD.n832 VDD.n831 0.16205
R3477 VDD.n838 VDD.n837 0.16205
R3478 VDD.n868 VDD.n867 0.16205
R3479 VDD.n874 VDD.n873 0.16205
R3480 VDD.n880 VDD.n879 0.16205
R3481 VDD.n898 VDD.n897 0.16205
R3482 VDD.n904 VDD.n903 0.16205
R3483 VDD.n910 VDD.n909 0.16205
R3484 VDD.n916 VDD.n915 0.16205
R3485 VDD.n922 VDD.n921 0.16205
R3486 VDD.n928 VDD.n927 0.16205
R3487 VDD.n940 VDD.n939 0.16205
R3488 VDD.n946 VDD.n945 0.16205
R3489 VDD.n952 VDD.n951 0.16205
R3490 VDD.n958 VDD.n957 0.16205
R3491 VDD.n709 VDD.n706 0.16205
R3492 VDD.n703 VDD.n700 0.16205
R3493 VDD.n691 VDD.n688 0.16205
R3494 VDD.n685 VDD.n682 0.16205
R3495 VDD.n679 VDD.n676 0.16205
R3496 VDD.n673 VDD.n670 0.16205
R3497 VDD.n667 VDD.n664 0.16205
R3498 VDD.n661 VDD.n658 0.16205
R3499 VDD.n655 VDD.n652 0.16205
R3500 VDD.n649 VDD.n646 0.16205
R3501 VDD.n643 VDD.n640 0.16205
R3502 VDD.n637 VDD.n634 0.16205
R3503 VDD.n631 VDD.n628 0.16205
R3504 VDD.n619 VDD.n616 0.16205
R3505 VDD.n613 VDD.n610 0.16205
R3506 VDD.n601 VDD.n598 0.16205
R3507 VDD.n583 VDD.n580 0.16205
R3508 VDD.n577 VDD.n574 0.16205
R3509 VDD.n571 VDD.n568 0.16205
R3510 VDD.n565 VDD.n562 0.16205
R3511 VDD.n559 VDD.n556 0.16205
R3512 VDD.n553 VDD.n550 0.16205
R3513 VDD.n547 VDD.n544 0.16205
R3514 VDD.n541 VDD.n538 0.16205
R3515 VDD.n529 VDD.n526 0.16205
R3516 VDD.n1778 VDD.n479 0.161924
R3517 VDD.n1788 VDD.n1777 0.161793
R3518 VDD.n140 VDD.n1010 0.485468
R3519 VDD.n141 VDD.n1261 0.485468
R3520 VDD.n142 VDD.n1512 0.485468
R3521 VDD.n988 VDD.n143 0.485468
R3522 VDD.n179 VDD.n63 0.0957379
R3523 VDD.n180 VDD.n60 0.0957379
R3524 VDD.n181 VDD.n57 0.0957379
R3525 VDD.n182 VDD.n54 0.0957379
R3526 VDD.n183 VDD.n51 0.0957379
R3527 VDD.n996 VDD.n995 0.159043
R3528 VDD.n1247 VDD.n1246 0.159043
R3529 VDD.n1498 VDD.n1497 0.159043
R3530 VDD.n974 VDD.n973 0.159043
R3531 VDD.n723 VDD.n722 0.159043
R3532 VDD.n1002 VDD.n1001 0.157388
R3533 VDD.n1009 VDD.n1008 0.157388
R3534 VDD.n1005 VDD.n1004 0.157388
R3535 VDD.n1253 VDD.n1252 0.157388
R3536 VDD.n1260 VDD.n1259 0.157388
R3537 VDD.n1256 VDD.n1255 0.157388
R3538 VDD.n1504 VDD.n1503 0.157388
R3539 VDD.n1511 VDD.n1510 0.157388
R3540 VDD.n1507 VDD.n1506 0.157388
R3541 VDD.n980 VDD.n979 0.157388
R3542 VDD.n987 VDD.n986 0.157388
R3543 VDD.n983 VDD.n982 0.157388
R3544 VDD.n729 VDD.n728 0.157388
R3545 VDD.n736 VDD.n735 0.157388
R3546 VDD.n732 VDD.n731 0.157388
R3547 VDD.n1754 VDD.n484 0.154552
R3548 VDD.n1752 VDD.n1749 0.154424
R3549 VDD.n289 VDD.n477 0.152808
R3550 VDD.n469 VDD.n468 0.152808
R3551 VDD.n469 VDD.n467 0.152808
R3552 VDD.n998 VDD.n993 0.15205
R3553 VDD.n1006 VDD.n299 0.15205
R3554 VDD.n1249 VDD.n1244 0.15205
R3555 VDD.n1257 VDD.n297 0.15205
R3556 VDD.n1500 VDD.n1495 0.15205
R3557 VDD.n1508 VDD.n295 0.15205
R3558 VDD.n976 VDD.n971 0.15205
R3559 VDD.n984 VDD.n293 0.15205
R3560 VDD.n725 VDD.n720 0.15205
R3561 VDD.n733 VDD.n291 0.15205
R3562 VDD.n470 VDD.n469 0.147075
R3563 VDD.n196 VDD.n997 0.236924
R3564 VDD.n208 VDD.n1248 0.236924
R3565 VDD.n220 VDD.n1499 0.236924
R3566 VDD.n232 VDD.n975 0.236924
R3567 VDD.n244 VDD.n724 0.236924
R3568 VDD.n1000 VDD.n998 0.134888
R3569 VDD.n1251 VDD.n1249 0.134888
R3570 VDD.n1502 VDD.n1500 0.134888
R3571 VDD.n978 VDD.n976 0.134888
R3572 VDD.n727 VDD.n725 0.134888
R3573 VDD.n195 VDD.n194 0.134618
R3574 VDD.n207 VDD.n206 0.134618
R3575 VDD.n219 VDD.n218 0.134618
R3576 VDD.n231 VDD.n230 0.134618
R3577 VDD.n243 VDD.n242 0.134618
R3578 VDD.n1238 VDD.n1237 0.133259
R3579 VDD.n1489 VDD.n1488 0.133259
R3580 VDD.n1740 VDD.n1739 0.133259
R3581 VDD.n965 VDD.n964 0.133259
R3582 VDD.n520 VDD.n519 0.133259
R3583 VDD.n283 VDD.n282 0.133259
R3584 VDD.n431 VDD.n430 0.16225
R3585 VDD.n428 VDD.n427 0.16225
R3586 VDD.n425 VDD.n424 0.16225
R3587 VDD.n422 VDD.n421 0.16225
R3588 VDD.n419 VDD.n418 0.16225
R3589 VDD.n304 VDD.n302 0.128884
R3590 VDD.n306 VDD.n305 0.128884
R3591 VDD.n309 VDD.n308 0.128884
R3592 VDD.n314 VDD.n313 0.128884
R3593 VDD.n317 VDD.n316 0.128884
R3594 VDD.n320 VDD.n319 0.128884
R3595 VDD.n324 VDD.n322 0.128884
R3596 VDD.n326 VDD.n325 0.128884
R3597 VDD.n329 VDD.n328 0.128884
R3598 VDD.n334 VDD.n333 0.128884
R3599 VDD.n337 VDD.n336 0.128884
R3600 VDD.n340 VDD.n339 0.128884
R3601 VDD.n344 VDD.n342 0.128884
R3602 VDD.n346 VDD.n345 0.128884
R3603 VDD.n349 VDD.n348 0.128884
R3604 VDD.n354 VDD.n353 0.128884
R3605 VDD.n357 VDD.n356 0.128884
R3606 VDD.n360 VDD.n359 0.128884
R3607 VDD.n364 VDD.n362 0.128884
R3608 VDD.n366 VDD.n365 0.128884
R3609 VDD.n369 VDD.n368 0.128884
R3610 VDD.n374 VDD.n373 0.128884
R3611 VDD.n377 VDD.n376 0.128884
R3612 VDD.n380 VDD.n379 0.128884
R3613 VDD.n384 VDD.n382 0.128884
R3614 VDD.n386 VDD.n385 0.128884
R3615 VDD.n389 VDD.n388 0.128884
R3616 VDD.n394 VDD.n393 0.128884
R3617 VDD.n397 VDD.n396 0.128884
R3618 VDD.n400 VDD.n399 0.128884
R3619 VDD.n454 VDD.n453 0.127628
R3620 VDD.n65 VDD.n996 0.947265
R3621 VDD.n62 VDD.n1247 0.947265
R3622 VDD.n59 VDD.n1498 0.947265
R3623 VDD.n56 VDD.n974 0.947265
R3624 VDD.n53 VDD.n723 0.947265
R3625 VDD.n262 VDD.n261 0.185493
R3626 VDD.n266 VDD.n265 0.185493
R3627 VDD.n270 VDD.n269 0.185493
R3628 VDD.n274 VDD.n273 0.185493
R3629 VDD.n523 VDD.n280 0.185493
R3630 VDD.n735 VDD.n392 0.1583
R3631 VDD.n986 VDD.n372 0.1583
R3632 VDD.n1510 VDD.n352 0.1583
R3633 VDD.n1259 VDD.n332 0.1583
R3634 VDD.n1008 VDD.n312 0.1583
R3635 VDD.n400 VDD.n451 0.141235
R3636 VDD.n43 VDD.n397 0.141235
R3637 VDD.n394 VDD.n450 0.141235
R3638 VDD.n40 VDD.n389 0.141235
R3639 VDD.n386 VDD.n449 0.141235
R3640 VDD.n384 VDD.n448 0.141235
R3641 VDD.n380 VDD.n447 0.141235
R3642 VDD.n36 VDD.n377 0.141235
R3643 VDD.n374 VDD.n446 0.141235
R3644 VDD.n33 VDD.n369 0.141235
R3645 VDD.n366 VDD.n445 0.141235
R3646 VDD.n364 VDD.n444 0.141235
R3647 VDD.n360 VDD.n443 0.141235
R3648 VDD.n29 VDD.n357 0.141235
R3649 VDD.n354 VDD.n442 0.141235
R3650 VDD.n26 VDD.n349 0.141235
R3651 VDD.n346 VDD.n441 0.141235
R3652 VDD.n344 VDD.n440 0.141235
R3653 VDD.n340 VDD.n439 0.141235
R3654 VDD.n22 VDD.n337 0.141235
R3655 VDD.n334 VDD.n438 0.141235
R3656 VDD.n19 VDD.n329 0.141235
R3657 VDD.n326 VDD.n437 0.141235
R3658 VDD.n324 VDD.n436 0.141235
R3659 VDD.n320 VDD.n435 0.141235
R3660 VDD.n15 VDD.n317 0.141235
R3661 VDD.n314 VDD.n434 0.141235
R3662 VDD.n12 VDD.n309 0.141235
R3663 VDD.n306 VDD.n433 0.141235
R3664 VDD.n304 VDD.n432 0.141235
R3665 VDD.n264 VDD.n262 0.0613757
R3666 VDD.n268 VDD.n266 0.0613757
R3667 VDD.n272 VDD.n270 0.0613757
R3668 VDD.n276 VDD.n274 0.0613757
R3669 VDD.n280 VDD.n279 0.0613757
R3670 VDD.n1000 VDD.n999 0.12205
R3671 VDD.n1251 VDD.n1250 0.12205
R3672 VDD.n1502 VDD.n1501 0.12205
R3673 VDD.n978 VDD.n977 0.12205
R3674 VDD.n727 VDD.n726 0.12205
R3675 VDD.n1746 VDD.n1745 0.119888
R3676 VDD.n1058 VDD.n1057 0.117388
R3677 VDD.n1064 VDD.n1063 0.117388
R3678 VDD.n1070 VDD.n1069 0.117388
R3679 VDD.n1082 VDD.n1081 0.117388
R3680 VDD.n1094 VDD.n1093 0.117388
R3681 VDD.n1106 VDD.n1105 0.117388
R3682 VDD.n1130 VDD.n1129 0.117388
R3683 VDD.n1136 VDD.n1135 0.117388
R3684 VDD.n1142 VDD.n1141 0.117388
R3685 VDD.n1148 VDD.n1147 0.117388
R3686 VDD.n1154 VDD.n1153 0.117388
R3687 VDD.n1160 VDD.n1159 0.117388
R3688 VDD.n1166 VDD.n1165 0.117388
R3689 VDD.n1172 VDD.n1171 0.117388
R3690 VDD.n1178 VDD.n1177 0.117388
R3691 VDD.n1214 VDD.n1213 0.117388
R3692 VDD.n1232 VDD.n1231 0.117388
R3693 VDD.n1297 VDD.n1296 0.117388
R3694 VDD.n1303 VDD.n1302 0.117388
R3695 VDD.n1309 VDD.n1308 0.117388
R3696 VDD.n1315 VDD.n1314 0.117388
R3697 VDD.n1321 VDD.n1320 0.117388
R3698 VDD.n1327 VDD.n1326 0.117388
R3699 VDD.n1339 VDD.n1338 0.117388
R3700 VDD.n1351 VDD.n1350 0.117388
R3701 VDD.n1363 VDD.n1362 0.117388
R3702 VDD.n1369 VDD.n1368 0.117388
R3703 VDD.n1393 VDD.n1392 0.117388
R3704 VDD.n1423 VDD.n1422 0.117388
R3705 VDD.n1435 VDD.n1434 0.117388
R3706 VDD.n1441 VDD.n1440 0.117388
R3707 VDD.n1477 VDD.n1476 0.117388
R3708 VDD.n1483 VDD.n1482 0.117388
R3709 VDD.n1548 VDD.n1547 0.117388
R3710 VDD.n1554 VDD.n1553 0.117388
R3711 VDD.n1572 VDD.n1571 0.117388
R3712 VDD.n1578 VDD.n1577 0.117388
R3713 VDD.n1590 VDD.n1589 0.117388
R3714 VDD.n1596 VDD.n1595 0.117388
R3715 VDD.n1608 VDD.n1607 0.117388
R3716 VDD.n1614 VDD.n1613 0.117388
R3717 VDD.n1620 VDD.n1619 0.117388
R3718 VDD.n1626 VDD.n1625 0.117388
R3719 VDD.n1638 VDD.n1637 0.117388
R3720 VDD.n1644 VDD.n1643 0.117388
R3721 VDD.n1650 VDD.n1649 0.117388
R3722 VDD.n1656 VDD.n1655 0.117388
R3723 VDD.n1662 VDD.n1661 0.117388
R3724 VDD.n1668 VDD.n1667 0.117388
R3725 VDD.n1674 VDD.n1673 0.117388
R3726 VDD.n1686 VDD.n1685 0.117388
R3727 VDD.n1692 VDD.n1691 0.117388
R3728 VDD.n1698 VDD.n1697 0.117388
R3729 VDD.n1704 VDD.n1703 0.117388
R3730 VDD.n1710 VDD.n1709 0.117388
R3731 VDD.n1716 VDD.n1715 0.117388
R3732 VDD.n1722 VDD.n1721 0.117388
R3733 VDD.n1728 VDD.n1727 0.117388
R3734 VDD.n1734 VDD.n1733 0.117388
R3735 VDD.n773 VDD.n772 0.117388
R3736 VDD.n779 VDD.n778 0.117388
R3737 VDD.n791 VDD.n790 0.117388
R3738 VDD.n797 VDD.n796 0.117388
R3739 VDD.n809 VDD.n808 0.117388
R3740 VDD.n815 VDD.n814 0.117388
R3741 VDD.n827 VDD.n826 0.117388
R3742 VDD.n833 VDD.n832 0.117388
R3743 VDD.n839 VDD.n838 0.117388
R3744 VDD.n869 VDD.n868 0.117388
R3745 VDD.n875 VDD.n874 0.117388
R3746 VDD.n881 VDD.n880 0.117388
R3747 VDD.n899 VDD.n898 0.117388
R3748 VDD.n905 VDD.n904 0.117388
R3749 VDD.n911 VDD.n910 0.117388
R3750 VDD.n917 VDD.n916 0.117388
R3751 VDD.n923 VDD.n922 0.117388
R3752 VDD.n929 VDD.n928 0.117388
R3753 VDD.n941 VDD.n940 0.117388
R3754 VDD.n947 VDD.n946 0.117388
R3755 VDD.n953 VDD.n952 0.117388
R3756 VDD.n959 VDD.n958 0.117388
R3757 VDD.n706 VDD.n705 0.117388
R3758 VDD.n700 VDD.n699 0.117388
R3759 VDD.n688 VDD.n687 0.117388
R3760 VDD.n682 VDD.n681 0.117388
R3761 VDD.n676 VDD.n675 0.117388
R3762 VDD.n670 VDD.n669 0.117388
R3763 VDD.n664 VDD.n663 0.117388
R3764 VDD.n658 VDD.n657 0.117388
R3765 VDD.n652 VDD.n651 0.117388
R3766 VDD.n646 VDD.n645 0.117388
R3767 VDD.n640 VDD.n639 0.117388
R3768 VDD.n634 VDD.n633 0.117388
R3769 VDD.n628 VDD.n627 0.117388
R3770 VDD.n616 VDD.n615 0.117388
R3771 VDD.n610 VDD.n609 0.117388
R3772 VDD.n598 VDD.n597 0.117388
R3773 VDD.n580 VDD.n579 0.117388
R3774 VDD.n574 VDD.n573 0.117388
R3775 VDD.n568 VDD.n567 0.117388
R3776 VDD.n562 VDD.n561 0.117388
R3777 VDD.n556 VDD.n555 0.117388
R3778 VDD.n550 VDD.n549 0.117388
R3779 VDD.n544 VDD.n543 0.117388
R3780 VDD.n538 VDD.n537 0.117388
R3781 VDD.n526 VDD.n525 0.117388
R3782 VDD.n1748 VDD.n1747 0.11705
R3783 VDD.n1046 VDD.n1045 0.11705
R3784 VDD.n1052 VDD.n1051 0.11705
R3785 VDD.n1076 VDD.n1075 0.11705
R3786 VDD.n1088 VDD.n1087 0.11705
R3787 VDD.n1100 VDD.n1099 0.11705
R3788 VDD.n1112 VDD.n1111 0.11705
R3789 VDD.n1118 VDD.n1117 0.11705
R3790 VDD.n1124 VDD.n1123 0.11705
R3791 VDD.n1184 VDD.n1183 0.11705
R3792 VDD.n1190 VDD.n1189 0.11705
R3793 VDD.n1196 VDD.n1195 0.11705
R3794 VDD.n1202 VDD.n1201 0.11705
R3795 VDD.n1208 VDD.n1207 0.11705
R3796 VDD.n1220 VDD.n1219 0.11705
R3797 VDD.n1226 VDD.n1225 0.11705
R3798 VDD.n1333 VDD.n1332 0.11705
R3799 VDD.n1345 VDD.n1344 0.11705
R3800 VDD.n1357 VDD.n1356 0.11705
R3801 VDD.n1375 VDD.n1374 0.11705
R3802 VDD.n1381 VDD.n1380 0.11705
R3803 VDD.n1387 VDD.n1386 0.11705
R3804 VDD.n1399 VDD.n1398 0.11705
R3805 VDD.n1405 VDD.n1404 0.11705
R3806 VDD.n1411 VDD.n1410 0.11705
R3807 VDD.n1417 VDD.n1416 0.11705
R3808 VDD.n1429 VDD.n1428 0.11705
R3809 VDD.n1447 VDD.n1446 0.11705
R3810 VDD.n1453 VDD.n1452 0.11705
R3811 VDD.n1459 VDD.n1458 0.11705
R3812 VDD.n1465 VDD.n1464 0.11705
R3813 VDD.n1471 VDD.n1470 0.11705
R3814 VDD.n1560 VDD.n1559 0.11705
R3815 VDD.n1566 VDD.n1565 0.11705
R3816 VDD.n1584 VDD.n1583 0.11705
R3817 VDD.n1602 VDD.n1601 0.11705
R3818 VDD.n1632 VDD.n1631 0.11705
R3819 VDD.n1680 VDD.n1679 0.11705
R3820 VDD.n785 VDD.n784 0.11705
R3821 VDD.n803 VDD.n802 0.11705
R3822 VDD.n821 VDD.n820 0.11705
R3823 VDD.n845 VDD.n844 0.11705
R3824 VDD.n851 VDD.n850 0.11705
R3825 VDD.n857 VDD.n856 0.11705
R3826 VDD.n863 VDD.n862 0.11705
R3827 VDD.n887 VDD.n886 0.11705
R3828 VDD.n893 VDD.n892 0.11705
R3829 VDD.n935 VDD.n934 0.11705
R3830 VDD.n712 VDD.n711 0.11705
R3831 VDD.n694 VDD.n693 0.11705
R3832 VDD.n622 VDD.n621 0.11705
R3833 VDD.n604 VDD.n603 0.11705
R3834 VDD.n592 VDD.n591 0.11705
R3835 VDD.n586 VDD.n585 0.11705
R3836 VDD.n532 VDD.n531 0.11705
R3837 VDD.n261 VDD.n1233 0.114888
R3838 VDD.n265 VDD.n1484 0.114888
R3839 VDD.n273 VDD.n960 0.114888
R3840 VDD.n269 VDD.n1735 0.11455
R3841 VDD.n524 VDD.n523 0.11455
R3842 VDD.n149 VDD.n1002 0.1133
R3843 VDD.n1004 VDD.n1003 0.1133
R3844 VDD.n152 VDD.n1253 0.1133
R3845 VDD.n1255 VDD.n1254 0.1133
R3846 VDD.n155 VDD.n1504 0.1133
R3847 VDD.n1506 VDD.n1505 0.1133
R3848 VDD.n158 VDD.n980 0.1133
R3849 VDD.n982 VDD.n981 0.1133
R3850 VDD.n161 VDD.n729 0.1133
R3851 VDD.n731 VDD.n730 0.1133
R3852 VDD.n194 VDD.n993 0.104888
R3853 VDD.n206 VDD.n1244 0.104888
R3854 VDD.n218 VDD.n1495 0.104888
R3855 VDD.n230 VDD.n971 0.104888
R3856 VDD.n242 VDD.n720 0.104888
R3857 VDD.n1007 VDD.n1006 0.101138
R3858 VDD.n1258 VDD.n1257 0.101138
R3859 VDD.n1509 VDD.n1508 0.101138
R3860 VDD.n985 VDD.n984 0.101138
R3861 VDD.n734 VDD.n733 0.101138
R3862 VDD.n281 VDD.n459 0.340529
R3863 VDD.n258 VDD.n174 0.257619
R3864 VDD.n257 VDD.n172 0.257619
R3865 VDD.n256 VDD.n170 0.257619
R3866 VDD.n255 VDD.n168 0.257619
R3867 VDD.n254 VDD.n166 0.257619
R3868 VDD.n178 VDD.n177 0.251665
R3869 VDD.n721 VDD.n193 0.24736
R3870 VDD.n972 VDD.n191 0.24736
R3871 VDD.n1496 VDD.n189 0.24736
R3872 VDD.n1245 VDD.n187 0.24736
R3873 VDD.n994 VDD.n185 0.24736
R3874 VDD.n461 VDD.n260 0.205524
R3875 VDD.n279 VDD.n278 0.146235
R3876 VDD.n519 VDD.n258 0.146235
R3877 VDD.n962 VDD.n276 0.146235
R3878 VDD.n965 VDD.n257 0.146235
R3879 VDD.n1737 VDD.n272 0.146235
R3880 VDD.n1740 VDD.n256 0.146235
R3881 VDD.n1486 VDD.n268 0.146235
R3882 VDD.n1489 VDD.n255 0.146235
R3883 VDD.n1235 VDD.n264 0.146235
R3884 VDD.n1238 VDD.n254 0.146235
R3885 VDD.n402 VDD.n253 0.224985
R3886 VDD.n252 VDD.n251 0.224985
R3887 VDD.n403 VDD.n250 0.224985
R3888 VDD.n249 VDD.n248 0.224985
R3889 VDD.n404 VDD.n247 0.224985
R3890 VDD.n246 VDD.n245 0.224985
R3891 VDD.n405 VDD.n241 0.224985
R3892 VDD.n240 VDD.n239 0.224985
R3893 VDD.n406 VDD.n238 0.224985
R3894 VDD.n237 VDD.n236 0.224985
R3895 VDD.n407 VDD.n235 0.224985
R3896 VDD.n234 VDD.n233 0.224985
R3897 VDD.n408 VDD.n229 0.224985
R3898 VDD.n228 VDD.n227 0.224985
R3899 VDD.n409 VDD.n226 0.224985
R3900 VDD.n225 VDD.n224 0.224985
R3901 VDD.n410 VDD.n223 0.224985
R3902 VDD.n222 VDD.n221 0.224985
R3903 VDD.n411 VDD.n217 0.224985
R3904 VDD.n216 VDD.n215 0.224985
R3905 VDD.n412 VDD.n214 0.224985
R3906 VDD.n213 VDD.n212 0.224985
R3907 VDD.n413 VDD.n211 0.224985
R3908 VDD.n210 VDD.n209 0.224985
R3909 VDD.n414 VDD.n205 0.224985
R3910 VDD.n204 VDD.n203 0.224985
R3911 VDD.n415 VDD.n202 0.224985
R3912 VDD.n201 VDD.n200 0.224985
R3913 VDD.n416 VDD.n199 0.224985
R3914 VDD.n198 VDD.n197 0.224985
R3915 VDD.n52 VDD.n51 0.211235
R3916 VDD.n55 VDD.n54 0.211235
R3917 VDD.n58 VDD.n57 0.211235
R3918 VDD.n61 VDD.n60 0.211235
R3919 VDD.n64 VDD.n63 0.211235
R3920 VDD.n138 VDD.t781 15.0336
R3921 VDD.n79 VDD.n45 1.20647
R3922 VDD.n44 VDD.n81 1.20647
R3923 VDD.n163 VDD.n42 1.20647
R3924 VDD.n41 VDD.n85 1.20647
R3925 VDD.n87 VDD.n39 1.20647
R3926 VDD.n90 VDD.n38 1.20647
R3927 VDD.n37 VDD.n92 1.20647
R3928 VDD.n160 VDD.n35 1.20647
R3929 VDD.n34 VDD.n96 1.20647
R3930 VDD.n98 VDD.n32 1.20647
R3931 VDD.n101 VDD.n31 1.20647
R3932 VDD.n30 VDD.n103 1.20647
R3933 VDD.n157 VDD.n28 1.20647
R3934 VDD.n27 VDD.n107 1.20647
R3935 VDD.n109 VDD.n25 1.20647
R3936 VDD.n112 VDD.n24 1.20647
R3937 VDD.n23 VDD.n114 1.20647
R3938 VDD.n154 VDD.n21 1.20647
R3939 VDD.n20 VDD.n118 1.20647
R3940 VDD.n120 VDD.n18 1.20647
R3941 VDD.n123 VDD.n17 1.20647
R3942 VDD.n16 VDD.n125 1.20647
R3943 VDD.n151 VDD.n14 1.20647
R3944 VDD.n13 VDD.n129 1.20647
R3945 VDD.n131 VDD.n11 1.20647
R3946 VDD.n50 VDD.n162 1.20646
R3947 VDD.n49 VDD.n159 1.20646
R3948 VDD.n48 VDD.n156 1.20646
R3949 VDD.n47 VDD.n153 1.20646
R3950 VDD.n46 VDD.n150 1.20646
R3951 VDD.n164 VDD.n138 1.17026
R3952 VDD.n4 VDD.n3 1.10286
R3953 VDD.n1 VDD.n0 1.10286
R3954 VDD.n144 VDD.n9 1.10275
R3955 VDD.n7 VDD.n6 1.10275
R3956 VDD.n53 VDD.n52 0.134613
R3957 VDD.n56 VDD.n55 0.134613
R3958 VDD.n145 VDD.n67 1.03683
R3959 VDD.n100 VDD.n69 0.432633
R3960 VDD.n111 VDD.n71 0.432627
R3961 VDD.n78 VDD.n73 0.432625
R3962 VDD.n122 VDD.n75 0.432625
R3963 VDD.n89 VDD.n77 0.432616
R3964 VDD.n84 VDD.n83 0.409065
R3965 VDD.n95 VDD.n94 0.409065
R3966 VDD.n106 VDD.n105 0.409065
R3967 VDD.n117 VDD.n116 0.409065
R3968 VDD.n128 VDD.n127 0.409065
R3969 VDD.n198 VDD.n132 1.01698
R3970 VDD.n199 VDD.n130 1.01698
R3971 VDD.n201 VDD.n128 1.01698
R3972 VDD.n202 VDD.n126 1.01698
R3973 VDD.n204 VDD.n124 1.01698
R3974 VDD.n205 VDD.n122 1.01698
R3975 VDD.n210 VDD.n121 1.01698
R3976 VDD.n211 VDD.n119 1.01698
R3977 VDD.n213 VDD.n117 1.01698
R3978 VDD.n214 VDD.n115 1.01698
R3979 VDD.n216 VDD.n113 1.01698
R3980 VDD.n217 VDD.n111 1.01698
R3981 VDD.n222 VDD.n110 1.01698
R3982 VDD.n223 VDD.n108 1.01698
R3983 VDD.n225 VDD.n106 1.01698
R3984 VDD.n226 VDD.n104 1.01698
R3985 VDD.n228 VDD.n102 1.01698
R3986 VDD.n229 VDD.n100 1.01698
R3987 VDD.n234 VDD.n99 1.01698
R3988 VDD.n235 VDD.n97 1.01698
R3989 VDD.n237 VDD.n95 1.01698
R3990 VDD.n238 VDD.n93 1.01698
R3991 VDD.n240 VDD.n91 1.01698
R3992 VDD.n241 VDD.n89 1.01698
R3993 VDD.n246 VDD.n88 1.01698
R3994 VDD.n247 VDD.n86 1.01698
R3995 VDD.n249 VDD.n84 1.01698
R3996 VDD.n250 VDD.n82 1.01698
R3997 VDD.n252 VDD.n80 1.01698
R3998 VDD.n253 VDD.n78 1.01698
R3999 VSS.n1618 VSS.n1617 22369.4
R4000 VSS.n2778 VSS.n2777 8296.08
R4001 VSS.n1524 VSS.n1523 8239.28
R4002 VSS.n1039 VSS.n289 8239.28
R4003 VSS.n385 VSS.n590 7907.02
R4004 VSS.n2291 VSS.n1623 6494.85
R4005 VSS.n1531 VSS.n488 3524.8
R4006 VSS.n1533 VSS.n1532 3461.11
R4007 VSS.n2835 VSS.n2834 3456.87
R4008 VSS.n2834 VSS.n1547 2770.39
R4009 VSS.n1532 VSS.n1531 2315.59
R4010 VSS.n1531 VSS.n810 891.294
R4011 VSS.n1532 VSS.n1120 891.294
R4012 VSS.n2834 VSS.n2386 891.294
R4013 VSS.t131 VSS.n1610 849.322
R4014 VSS.t14 VSS.t17 571.348
R4015 VSS.n1456 VSS.n1455 560.236
R4016 VSS.n1467 VSS.n1466 560.236
R4017 VSS.n1478 VSS.n1477 560.236
R4018 VSS.n1497 VSS.n1496 560.236
R4019 VSS.n1508 VSS.n1507 560.236
R4020 VSS.n1519 VSS.n1518 560.236
R4021 VSS.n2710 VSS.n2709 560.236
R4022 VSS.n2721 VSS.n2720 560.236
R4023 VSS.n2732 VSS.n2731 560.236
R4024 VSS.n2751 VSS.n2750 560.236
R4025 VSS.n2762 VSS.n2761 560.236
R4026 VSS.n2773 VSS.n2772 560.236
R4027 VSS.n1724 VSS.n1723 560.236
R4028 VSS.n855 VSS.n228 560.236
R4029 VSS.n3115 VSS.n3114 560.236
R4030 VSS.n3109 VSS.n3108 560.236
R4031 VSS.n3103 VSS.n3102 560.236
R4032 VSS.n867 VSS.n276 560.236
R4033 VSS.n3098 VSS.n3097 560.236
R4034 VSS.n1450 VSS.n1140 544.265
R4035 VSS.n2704 VSS.n2397 544.265
R4036 VSS.n1728 VSS.n1561 544.265
R4037 VSS.n852 VSS.n851 544.265
R4038 VSS.n1453 VSS.n1452 544.264
R4039 VSS.n1464 VSS.n1463 544.264
R4040 VSS.n1475 VSS.n1474 544.264
R4041 VSS.n1494 VSS.n1493 544.264
R4042 VSS.n1505 VSS.n1504 544.264
R4043 VSS.n1516 VSS.n1515 544.264
R4044 VSS.n2707 VSS.n2706 544.264
R4045 VSS.n2718 VSS.n2717 544.264
R4046 VSS.n2729 VSS.n2728 544.264
R4047 VSS.n2748 VSS.n2747 544.264
R4048 VSS.n2759 VSS.n2758 544.264
R4049 VSS.n2770 VSS.n2769 544.264
R4050 VSS.n1730 VSS.n1726 544.264
R4051 VSS.n226 VSS.n854 544.264
R4052 VSS.n3118 VSS.n3117 544.264
R4053 VSS.n3112 VSS.n3111 544.264
R4054 VSS.n3106 VSS.n3105 544.264
R4055 VSS.n274 VSS.n866 544.264
R4056 VSS.n3101 VSS.n3100 544.264
R4057 VSS.n1461 VSS.n1460 544.264
R4058 VSS.n1472 VSS.n1471 544.264
R4059 VSS.n1491 VSS.n1490 544.264
R4060 VSS.n1502 VSS.n1501 544.264
R4061 VSS.n1513 VSS.n1512 544.264
R4062 VSS.n2715 VSS.n2714 544.264
R4063 VSS.n2726 VSS.n2725 544.264
R4064 VSS.n2745 VSS.n2744 544.264
R4065 VSS.n2756 VSS.n2755 544.264
R4066 VSS.n2767 VSS.n2766 544.264
R4067 VSS.n860 VSS.n859 544.264
R4068 VSS.n237 VSS.n3113 544.264
R4069 VSS.n248 VSS.n3107 544.264
R4070 VSS.n864 VSS.n266 544.264
R4071 VSS.n872 VSS.n871 544.264
R4072 VSS.n2884 VSS.t198 539.653
R4073 VSS.t356 VSS.n1484 537.303
R4074 VSS.t1421 VSS.n2738 537.303
R4075 VSS.t638 VSS.n256 537.303
R4076 VSS.n2887 VSS.t1131 522.508
R4077 VSS.n1483 VSS.t35 520.833
R4078 VSS.n2737 VSS.t1990 520.833
R4079 VSS.n862 VSS.t2284 520.833
R4080 VSS.t2307 VSS.n1485 502.599
R4081 VSS.t1971 VSS.n2739 502.599
R4082 VSS.t1153 VSS.n251 502.599
R4083 VSS.n1520 VSS.t995 495.639
R4084 VSS.n1509 VSS.t984 495.639
R4085 VSS.n1498 VSS.t973 495.639
R4086 VSS.n1479 VSS.t962 495.639
R4087 VSS.n1468 VSS.t951 495.639
R4088 VSS.n1457 VSS.t940 495.639
R4089 VSS.n2774 VSS.t872 495.639
R4090 VSS.n2763 VSS.t862 495.639
R4091 VSS.n2752 VSS.t852 495.639
R4092 VSS.n2733 VSS.t842 495.639
R4093 VSS.n2722 VSS.t832 495.639
R4094 VSS.n2711 VSS.t822 495.639
R4095 VSS.t882 VSS.n1722 495.639
R4096 VSS.n287 VSS.t1055 495.639
R4097 VSS.n868 VSS.t1046 495.639
R4098 VSS.n268 VSS.t1035 495.639
R4099 VSS.n254 VSS.t1025 495.639
R4100 VSS.n240 VSS.t1015 495.639
R4101 VSS.n856 VSS.t1005 495.639
R4102 VSS.n2885 VSS.t1132 491.87
R4103 VSS.n3089 VSS.t649 486.111
R4104 VSS.n2848 VSS.t2194 486.111
R4105 VSS.n3127 VSS.t33 486.111
R4106 VSS.t936 VSS.n1453 481.764
R4107 VSS.t947 VSS.n1464 481.764
R4108 VSS.t958 VSS.n1475 481.764
R4109 VSS.t969 VSS.n1494 481.764
R4110 VSS.t980 VSS.n1505 481.764
R4111 VSS.t991 VSS.n1516 481.764
R4112 VSS.t818 VSS.n2707 481.764
R4113 VSS.t828 VSS.n2718 481.764
R4114 VSS.t838 VSS.n2729 481.764
R4115 VSS.t848 VSS.n2748 481.764
R4116 VSS.t858 VSS.n2759 481.764
R4117 VSS.t868 VSS.n2770 481.764
R4118 VSS.n1726 VSS.t879 481.764
R4119 VSS.n226 VSS.t1002 481.764
R4120 VSS.n3117 VSS.t1012 481.764
R4121 VSS.n3111 VSS.t1022 481.764
R4122 VSS.n3105 VSS.t1032 481.764
R4123 VSS.n274 VSS.t1043 481.764
R4124 VSS.n3100 VSS.t1052 481.764
R4125 VSS.t355 VSS.n1483 479.168
R4126 VSS.t1420 VSS.n2737 479.168
R4127 VSS.n862 VSS.t637 479.168
R4128 VSS.t90 VSS.n1621 470.019
R4129 VSS.n510 VSS.n509 469.783
R4130 VSS.n523 VSS.n522 469.783
R4131 VSS.n545 VSS.n544 469.783
R4132 VSS.n563 VSS.n562 469.783
R4133 VSS.n581 VSS.n580 469.783
R4134 VSS.n595 VSS.n594 469.783
R4135 VSS.n3180 VSS.n3179 454.007
R4136 VSS.n3171 VSS.n3170 454.007
R4137 VSS.n528 VSS.n525 454.007
R4138 VSS.n3156 VSS.n3155 454.007
R4139 VSS.n568 VSS.n565 454.007
R4140 VSS.n3141 VSS.n3140 454.007
R4141 VSS.n3177 VSS.n3176 453.986
R4142 VSS.n3168 VSS.n3167 453.986
R4143 VSS.n531 VSS.n530 453.986
R4144 VSS.n3153 VSS.n3152 453.986
R4145 VSS.n571 VSS.n570 453.986
R4146 VSS.n3138 VSS.n3137 453.986
R4147 VSS.n3176 VSS.n500 453.986
R4148 VSS.n3167 VSS.n514 453.986
R4149 VSS.n542 VSS.n531 453.986
R4150 VSS.n3152 VSS.n554 453.986
R4151 VSS.n578 VSS.n571 453.986
R4152 VSS.n3137 VSS.n585 453.986
R4153 VSS.t2408 VSS.n539 448.228
R4154 VSS.t2348 VSS.n1563 446.527
R4155 VSS.t2029 VSS.n480 442.469
R4156 VSS.t1488 VSS.n482 437.62
R4157 VSS.n548 VSS.t2305 431.863
R4158 VSS.t2086 VSS.n549 419.459
R4159 VSS.t1116 VSS.n592 413.68
R4160 VSS.t1106 VSS.n577 413.68
R4161 VSS.t1096 VSS.n560 413.68
R4162 VSS.t1086 VSS.n541 413.68
R4163 VSS.t1076 VSS.n520 413.68
R4164 VSS.t1066 VSS.n507 413.68
R4165 VSS.n3032 VSS.n3031 412.522
R4166 VSS.n495 VSS.t1489 403.072
R4167 VSS.t1453 VSS.n2885 401.591
R4168 VSS.t941 VSS.n1457 398.414
R4169 VSS.t952 VSS.n1468 398.414
R4170 VSS.t963 VSS.n1479 398.414
R4171 VSS.t974 VSS.n1498 398.414
R4172 VSS.t985 VSS.n1509 398.414
R4173 VSS.t996 VSS.n1520 398.414
R4174 VSS.t823 VSS.n2711 398.414
R4175 VSS.t833 VSS.n2722 398.414
R4176 VSS.t843 VSS.n2733 398.414
R4177 VSS.t853 VSS.n2752 398.414
R4178 VSS.t863 VSS.n2763 398.414
R4179 VSS.t873 VSS.n2774 398.414
R4180 VSS.n1722 VSS.t883 398.414
R4181 VSS.t1006 VSS.n856 398.414
R4182 VSS.t1017 VSS.n240 398.414
R4183 VSS.t1026 VSS.n254 398.414
R4184 VSS.t1037 VSS.n268 398.414
R4185 VSS.t1047 VSS.n868 398.414
R4186 VSS.n287 VSS.t1057 398.414
R4187 VSS.n548 VSS.t2407 397.313
R4188 VSS.n493 VSS.t2013 391.555
R4189 VSS.t204 VSS.n3086 388.889
R4190 VSS.n1487 VSS.t790 388.889
R4191 VSS.t1944 VSS.n2846 388.889
R4192 VSS.n2741 VSS.t1980 388.889
R4193 VSS.t69 VSS.n3124 388.889
R4194 VSS.n863 VSS.t2146 388.889
R4195 VSS.t131 VSS.n3033 388.781
R4196 VSS.t1062 VSS.n500 385.798
R4197 VSS.t1072 VSS.n514 385.798
R4198 VSS.t1082 VSS.n542 385.798
R4199 VSS.t1092 VSS.n554 385.798
R4200 VSS.t1102 VSS.n578 385.798
R4201 VSS.t1112 VSS.n585 385.798
R4202 VSS.n490 VSS.t2045 384.887
R4203 VSS.n491 VSS.t2044 380.038
R4204 VSS.n1452 VSS.t934 368.057
R4205 VSS.n1463 VSS.t945 368.057
R4206 VSS.n1474 VSS.t956 368.057
R4207 VSS.n1493 VSS.t967 368.057
R4208 VSS.n1504 VSS.t978 368.057
R4209 VSS.n1515 VSS.t989 368.057
R4210 VSS.n2706 VSS.t816 368.057
R4211 VSS.n2717 VSS.t826 368.057
R4212 VSS.n2728 VSS.t836 368.057
R4213 VSS.n2747 VSS.t846 368.057
R4214 VSS.n2758 VSS.t856 368.057
R4215 VSS.n2769 VSS.t866 368.057
R4216 VSS.n1730 VSS.t877 368.057
R4217 VSS.n854 VSS.t1000 368.057
R4218 VSS.n3118 VSS.t1010 368.057
R4219 VSS.n3112 VSS.t1020 368.057
R4220 VSS.n3106 VSS.t1030 368.057
R4221 VSS.n866 VSS.t1041 368.057
R4222 VSS.n3101 VSS.t1050 368.057
R4223 VSS.t5 VSS.t130 359.769
R4224 VSS.t2031 VSS.n486 357.007
R4225 VSS.t931 VSS.n1450 354.168
R4226 VSS.t942 VSS.n1461 354.168
R4227 VSS.t953 VSS.n1472 354.168
R4228 VSS.t964 VSS.n1491 354.168
R4229 VSS.t975 VSS.n1502 354.168
R4230 VSS.t986 VSS.n1513 354.168
R4231 VSS.t813 VSS.n2704 354.168
R4232 VSS.t824 VSS.n2715 354.168
R4233 VSS.t834 VSS.n2726 354.168
R4234 VSS.t844 VSS.n2745 354.168
R4235 VSS.t854 VSS.n2756 354.168
R4236 VSS.t864 VSS.n2767 354.168
R4237 VSS.t874 VSS.n1728 354.168
R4238 VSS.t997 VSS.n852 354.168
R4239 VSS.t1007 VSS.n860 354.168
R4240 VSS.n3113 VSS.t1018 354.168
R4241 VSS.n3107 VSS.t1027 354.168
R4242 VSS.t1038 VSS.n864 354.168
R4243 VSS.t1048 VSS.n872 354.168
R4244 VSS.n1522 VSS.t1804 349.805
R4245 VSS.n1511 VSS.t1786 349.805
R4246 VSS.n1500 VSS.t1938 349.805
R4247 VSS.n1489 VSS.t1954 349.805
R4248 VSS.n1481 VSS.t1798 349.805
R4249 VSS.n1470 VSS.t1784 349.805
R4250 VSS.n1459 VSS.t1936 349.805
R4251 VSS.n2776 VSS.t1261 349.805
R4252 VSS.n2765 VSS.t472 349.805
R4253 VSS.n2754 VSS.t687 349.805
R4254 VSS.n2743 VSS.t352 349.805
R4255 VSS.n2735 VSS.t603 349.805
R4256 VSS.n2724 VSS.t424 349.805
R4257 VSS.n2713 VSS.t684 349.805
R4258 VSS.t584 VSS.n1720 349.805
R4259 VSS.n286 VSS.t2281 349.805
R4260 VSS.n870 VSS.t0 349.805
R4261 VSS.t1494 VSS.n269 349.805
R4262 VSS.t1523 VSS.n258 349.805
R4263 VSS.t80 VSS.n255 349.805
R4264 VSS.t77 VSS.n241 349.805
R4265 VSS.n858 VSS.t1492 349.805
R4266 VSS.t1957 VSS.n3083 349.803
R4267 VSS.t2115 VSS.n2843 349.803
R4268 VSS.t1520 VSS.n3120 349.803
R4269 VSS.t2032 VSS.n484 333.974
R4270 VSS.n490 VSS.t1486 333.065
R4271 VSS.t1067 VSS.n507 333.063
R4272 VSS.t1077 VSS.n520 333.063
R4273 VSS.t1087 VSS.n541 333.063
R4274 VSS.t1097 VSS.n560 333.063
R4275 VSS.t1107 VSS.n577 333.063
R4276 VSS.n592 VSS.t1117 333.063
R4277 VSS.n3085 VSS.t2129 328.988
R4278 VSS.n3122 VSS.t1777 328.988
R4279 VSS.n2845 VSS.t1219 328.986
R4280 VSS.n55 VSS.t14 327.81
R4281 VSS.t2024 VSS.n478 322.457
R4282 VSS.n551 VSS.t333 322.457
R4283 VSS.n3086 VSS.t206 319.445
R4284 VSS.t792 VSS.n1487 319.445
R4285 VSS.n2846 VSS.t1945 319.445
R4286 VSS.t1981 VSS.n2741 319.445
R4287 VSS.n3124 VSS.t70 319.445
R4288 VSS.n863 VSS.t2147 319.445
R4289 VSS.n3027 VSS.t2348 314.327
R4290 VSS.n2888 VSS.t1130 313.659
R4291 VSS.n1523 VSS.t1805 308.159
R4292 VSS.n2777 VSS.t1262 308.159
R4293 VSS.t2282 VSS.n289 308.159
R4294 VSS.n1482 VSS.t1799 308.158
R4295 VSS.n2736 VSS.t604 308.158
R4296 VSS.n252 VSS.t81 308.158
R4297 VSS.n1512 VSS.t1787 308.156
R4298 VSS.n1501 VSS.t1939 308.156
R4299 VSS.n1490 VSS.t1955 308.156
R4300 VSS.n1471 VSS.t1785 308.156
R4301 VSS.n1460 VSS.t1937 308.156
R4302 VSS.n2766 VSS.t473 308.156
R4303 VSS.n2755 VSS.t688 308.156
R4304 VSS.n2744 VSS.t353 308.156
R4305 VSS.n2725 VSS.t425 308.156
R4306 VSS.n2714 VSS.t685 308.156
R4307 VSS.n248 VSS.t1524 308.156
R4308 VSS.n237 VSS.t78 308.156
R4309 VSS.n859 VSS.t1493 308.156
R4310 VSS.n266 VSS.t1495 308.156
R4311 VSS.n871 VSS.t1 308.156
R4312 VSS.t585 VSS.n1719 308.154
R4313 VSS.t1958 VSS.n1140 308.154
R4314 VSS.t2116 VSS.n2397 308.154
R4315 VSS.t2218 VSS.n1561 308.154
R4316 VSS.t1521 VSS.n851 308.154
R4317 VSS.n3177 VSS.t1060 305.183
R4318 VSS.n3168 VSS.t1070 305.183
R4319 VSS.n530 VSS.t1080 305.183
R4320 VSS.n3153 VSS.t1090 305.183
R4321 VSS.n570 VSS.t1100 305.183
R4322 VSS.n3138 VSS.t1110 305.183
R4323 VSS.t197 VSS.n2887 299.735
R4324 VSS.n494 VSS.t2028 299.425
R4325 VSS.n3179 VSS.t1058 293.666
R4326 VSS.n3170 VSS.t1068 293.666
R4327 VSS.t1078 VSS.n528 293.666
R4328 VSS.n3155 VSS.t1088 293.666
R4329 VSS.t1098 VSS.n568 293.666
R4330 VSS.n3140 VSS.t1108 293.666
R4331 VSS.n596 VSS.t759 292.757
R4332 VSS.t762 VSS.n576 292.757
R4333 VSS.t774 VSS.n559 292.757
R4334 VSS.t777 VSS.n537 292.757
R4335 VSS.t2162 VSS.n540 292.757
R4336 VSS.t765 VSS.n519 292.757
R4337 VSS.t771 VSS.n506 292.757
R4338 VSS.t768 VSS.n476 292.757
R4339 VSS.n494 VSS.t2046 287.909
R4340 VSS.t939 VSS.n1454 287.32
R4341 VSS.t950 VSS.n1465 287.32
R4342 VSS.t961 VSS.n1476 287.32
R4343 VSS.t972 VSS.n1495 287.32
R4344 VSS.t983 VSS.n1506 287.32
R4345 VSS.t994 VSS.n1517 287.32
R4346 VSS.t821 VSS.n2708 287.32
R4347 VSS.t831 VSS.n2719 287.32
R4348 VSS.t841 VSS.n2730 287.32
R4349 VSS.t851 VSS.n2749 287.32
R4350 VSS.t861 VSS.n2760 287.32
R4351 VSS.t871 VSS.n2771 287.32
R4352 VSS.n1725 VSS.t881 287.32
R4353 VSS.n227 VSS.t1004 287.32
R4354 VSS.n3116 VSS.t1013 287.32
R4355 VSS.n3110 VSS.t1023 287.32
R4356 VSS.n3104 VSS.t1033 287.32
R4357 VSS.n275 VSS.t1045 287.32
R4358 VSS.n3099 VSS.t1053 287.32
R4359 VSS.n3090 VSS.t785 277.779
R4360 VSS.n2849 VSS.t651 277.779
R4361 VSS.t2196 VSS.n3126 277.779
R4362 VSS.n497 VSS.t2178 275.505
R4363 VSS.n1455 VSS.t939 273.432
R4364 VSS.n1466 VSS.t950 273.432
R4365 VSS.n1477 VSS.t961 273.432
R4366 VSS.n1496 VSS.t972 273.432
R4367 VSS.n1507 VSS.t983 273.432
R4368 VSS.n1518 VSS.t994 273.432
R4369 VSS.n2709 VSS.t821 273.432
R4370 VSS.n2720 VSS.t831 273.432
R4371 VSS.n2731 VSS.t841 273.432
R4372 VSS.n2750 VSS.t851 273.432
R4373 VSS.n2761 VSS.t861 273.432
R4374 VSS.n2772 VSS.t871 273.432
R4375 VSS.t881 VSS.n1724 273.432
R4376 VSS.t1004 VSS.n228 273.432
R4377 VSS.t1013 VSS.n3115 273.432
R4378 VSS.t1023 VSS.n3109 273.432
R4379 VSS.t1033 VSS.n3103 273.432
R4380 VSS.t1045 VSS.n276 273.432
R4381 VSS.t1053 VSS.n3098 273.432
R4382 VSS.t1508 VSS.n480 269.724
R4383 VSS.n1909 VSS.n1907 265.116
R4384 VSS.n1715 VSS.n1711 265.116
R4385 VSS.t2025 VSS.n478 264.875
R4386 VSS.n551 VSS.t335 264.875
R4387 VSS.n1786 VSS.n1785 258.741
R4388 VSS.t760 VSS.n590 258.238
R4389 VSS.n547 VSS.t2163 258.236
R4390 VSS.n3141 VSS.t763 258.233
R4391 VSS.n3156 VSS.t778 258.233
R4392 VSS.n3171 VSS.t772 258.233
R4393 VSS.n3180 VSS.t769 258.233
R4394 VSS.n525 VSS.t766 258.233
R4395 VSS.n565 VSS.t775 258.233
R4396 VSS.t2015 VSS.n483 258.231
R4397 VSS.n1757 VSS.n1756 258.14
R4398 VSS.n1694 VSS.n1693 258.14
R4399 VSS.n1901 VSS.n1900 258.14
R4400 VSS.t1507 VSS.n484 253.359
R4401 VSS.n3083 VSS.t1958 252.583
R4402 VSS.n2843 VSS.t2116 252.583
R4403 VSS.n3120 VSS.t1521 252.583
R4404 VSS.t1937 VSS.n1459 252.582
R4405 VSS.t1785 VSS.n1470 252.582
R4406 VSS.t1799 VSS.n1481 252.582
R4407 VSS.t1955 VSS.n1489 252.582
R4408 VSS.t1939 VSS.n1500 252.582
R4409 VSS.t1787 VSS.n1511 252.582
R4410 VSS.t1805 VSS.n1522 252.582
R4411 VSS.t685 VSS.n2713 252.582
R4412 VSS.t425 VSS.n2724 252.582
R4413 VSS.t604 VSS.n2735 252.582
R4414 VSS.t353 VSS.n2743 252.582
R4415 VSS.t688 VSS.n2754 252.582
R4416 VSS.t473 VSS.n2765 252.582
R4417 VSS.t1262 VSS.n2776 252.582
R4418 VSS.n1720 VSS.t585 252.582
R4419 VSS.t1493 VSS.n858 252.582
R4420 VSS.t78 VSS.n241 252.582
R4421 VSS.t81 VSS.n255 252.582
R4422 VSS.t1524 VSS.n258 252.582
R4423 VSS.t1495 VSS.n269 252.582
R4424 VSS.t1 VSS.n870 252.582
R4425 VSS.n286 VSS.t2282 252.582
R4426 VSS.t1218 VSS.n2444 252.375
R4427 VSS.t296 VSS.n2453 252.375
R4428 VSS.t1338 VSS.n2469 252.375
R4429 VSS.t1274 VSS.n2485 252.375
R4430 VSS.t2276 VSS.n2501 252.375
R4431 VSS.t1368 VSS.n2517 252.375
R4432 VSS.t2278 VSS.n2533 252.375
R4433 VSS.t1778 VSS.n2549 252.375
R4434 VSS.t2201 VSS.n2565 252.375
R4435 VSS.t450 VSS.n2581 252.375
R4436 VSS.t1340 VSS.n2597 252.375
R4437 VSS.t1722 VSS.n2613 252.375
R4438 VSS.t1287 VSS.n2629 252.375
R4439 VSS.t327 VSS.n2645 252.375
R4440 VSS.t1140 VSS.n2661 252.375
R4441 VSS.t1295 VSS.n2677 252.375
R4442 VSS.t1299 VSS.n2693 252.375
R4443 VSS.t1918 VSS.n392 252.375
R4444 VSS.t1730 VSS.n398 252.375
R4445 VSS.t1668 VSS.n404 252.375
R4446 VSS.t2285 VSS.n410 252.375
R4447 VSS.t249 VSS.n414 252.375
R4448 VSS.t1200 VSS.n406 252.375
R4449 VSS.t1760 VSS.n424 252.375
R4450 VSS.t1670 VSS.n428 252.375
R4451 VSS.t1686 VSS.n400 252.375
R4452 VSS.t1879 VSS.n438 252.375
R4453 VSS.t1899 VSS.n442 252.375
R4454 VSS.t1915 VSS.n394 252.375
R4455 VSS.t1921 VSS.n449 252.375
R4456 VSS.n388 VSS.t1966 252.375
R4457 VSS.n376 VSS.t1776 252.375
R4458 VSS.n373 VSS.t392 252.375
R4459 VSS.n372 VSS.t2267 252.375
R4460 VSS.n369 VSS.t2291 252.375
R4461 VSS.n366 VSS.t800 252.375
R4462 VSS.n365 VSS.t393 252.375
R4463 VSS.n362 VSS.t2233 252.375
R4464 VSS.n358 VSS.t522 252.375
R4465 VSS.n357 VSS.t351 252.375
R4466 VSS.n354 VSS.t2183 252.375
R4467 VSS.n350 VSS.t1447 252.375
R4468 VSS.n349 VSS.t634 252.375
R4469 VSS.n346 VSS.t2190 252.375
R4470 VSS.n342 VSS.t2186 252.375
R4471 VSS.n341 VSS.t2187 252.375
R4472 VSS.n338 VSS.t1423 252.375
R4473 VSS.n295 VSS.t2247 252.375
R4474 VSS.n181 VSS.t2105 252.375
R4475 VSS.n179 VSS.t2007 252.375
R4476 VSS.n175 VSS.t1970 252.375
R4477 VSS.n171 VSS.t1998 252.375
R4478 VSS.n167 VSS.t2067 252.375
R4479 VSS.n163 VSS.t2292 252.375
R4480 VSS.n159 VSS.t2061 252.375
R4481 VSS.n156 VSS.t2081 252.375
R4482 VSS.n152 VSS.t1861 252.375
R4483 VSS.n151 VSS.t1875 252.375
R4484 VSS.n148 VSS.t1888 252.375
R4485 VSS.n145 VSS.t1878 252.375
R4486 VSS.n144 VSS.t1895 252.375
R4487 VSS.t2133 VSS.n1217 252.375
R4488 VSS.t2275 VSS.n1155 252.375
R4489 VSS.t13 VSS.n1162 252.375
R4490 VSS.t787 VSS.n1169 252.375
R4491 VSS.t2314 VSS.n1176 252.375
R4492 VSS.n470 VSS.t2177 252.374
R4493 VSS.n466 VSS.t1757 252.374
R4494 VSS.n461 VSS.t1788 252.374
R4495 VSS.n127 VSS.t1969 252.374
R4496 VSS.n130 VSS.t2016 252.374
R4497 VSS.n132 VSS.t2054 252.374
R4498 VSS.n135 VSS.t2295 252.374
R4499 VSS.t2132 VSS.n1189 252.374
R4500 VSS.t640 VSS.n1201 252.374
R4501 VSS.t37 VSS.n1233 252.374
R4502 VSS.t1425 VSS.n1249 252.374
R4503 VSS.t2243 VSS.n1280 252.374
R4504 VSS.t54 VSS.n1296 252.374
R4505 VSS.t53 VSS.n1327 252.374
R4506 VSS.t693 VSS.n1343 252.374
R4507 VSS.t1732 VSS.n1374 252.374
R4508 VSS.t201 VSS.n1390 252.374
R4509 VSS.t2128 VSS.n1421 252.374
R4510 VSS.t1446 VSS.n1437 252.374
R4511 VSS.t73 VSS.n412 252.117
R4512 VSS.t667 VSS.n415 252.117
R4513 VSS.t1303 VSS.n418 252.117
R4514 VSS.t1855 VSS.n403 252.117
R4515 VSS.t1304 VSS.n426 252.117
R4516 VSS.t1717 VSS.n429 252.117
R4517 VSS.t1240 VSS.n432 252.117
R4518 VSS.t1934 VSS.n397 252.117
R4519 VSS.t2001 VSS.n440 252.117
R4520 VSS.t1856 VSS.n443 252.117
R4521 VSS.t1858 VSS.n446 252.117
R4522 VSS.n391 VSS.t1892 252.117
R4523 VSS.n371 VSS.t89 252.117
R4524 VSS.n368 VSS.t645 252.117
R4525 VSS.n364 VSS.t799 252.117
R4526 VSS.n360 VSS.t1202 252.117
R4527 VSS.n356 VSS.t1169 252.117
R4528 VSS.n352 VSS.t227 252.117
R4529 VSS.n348 VSS.t786 252.117
R4530 VSS.n344 VSS.t1187 252.117
R4531 VSS.n340 VSS.t1733 252.117
R4532 VSS.n336 VSS.t1237 252.117
R4533 VSS.n180 VSS.t1992 252.117
R4534 VSS.n178 VSS.t1991 252.117
R4535 VSS.n174 VSS.t2012 252.117
R4536 VSS.n173 VSS.t2077 252.117
R4537 VSS.n170 VSS.t2020 252.117
R4538 VSS.n166 VSS.t2041 252.117
R4539 VSS.n165 VSS.t2293 252.117
R4540 VSS.n162 VSS.t2042 252.117
R4541 VSS.n158 VSS.t2089 252.117
R4542 VSS.n155 VSS.t1868 252.117
R4543 VSS.n150 VSS.t1814 252.117
R4544 VSS.n147 VSS.t1884 252.117
R4545 VSS.t1691 VSS.n2462 252.117
R4546 VSS.t1366 VSS.n2478 252.117
R4547 VSS.t530 VSS.n2494 252.117
R4548 VSS.t1222 VSS.n2510 252.117
R4549 VSS.t303 VSS.n2526 252.117
R4550 VSS.t2143 VSS.n2542 252.117
R4551 VSS.t1136 VSS.n2558 252.117
R4552 VSS.t479 VSS.n2574 252.117
R4553 VSS.t1342 VSS.n2590 252.117
R4554 VSS.t1496 VSS.n2606 252.117
R4555 VSS.t2280 VSS.n2622 252.117
R4556 VSS.t1711 VSS.n2638 252.117
R4557 VSS.t246 VSS.n2654 252.117
R4558 VSS.t1297 VSS.n2670 252.117
R4559 VSS.t2145 VSS.n2686 252.117
R4560 VSS.n465 VSS.t1723 252.115
R4561 VSS.n460 VSS.t1713 252.115
R4562 VSS.n454 VSS.t1893 252.115
R4563 VSS.n321 VSS.t36 252.115
R4564 VSS.n323 VSS.t443 252.115
R4565 VSS.n325 VSS.t1170 252.115
R4566 VSS.n327 VSS.t2107 252.115
R4567 VSS.n329 VSS.t2053 252.115
R4568 VSS.n134 VSS.t2078 252.115
R4569 VSS.n137 VSS.t1870 252.115
R4570 VSS.n140 VSS.t76 252.115
R4571 VSS.t358 VSS.n1210 252.115
R4572 VSS.t808 VSS.n1226 252.115
R4573 VSS.t606 VSS.n1242 252.115
R4574 VSS.t2260 VSS.n1258 252.115
R4575 VSS.t207 VSS.n1273 252.115
R4576 VSS.t269 VSS.n1289 252.115
R4577 VSS.t1221 VSS.n1305 252.115
R4578 VSS.t1458 VSS.n1320 252.115
R4579 VSS.t1217 VSS.n1336 252.115
R4580 VSS.t58 VSS.n1352 252.115
R4581 VSS.t2084 VSS.n1367 252.115
R4582 VSS.t1430 VSS.n1383 252.115
R4583 VSS.t432 VSS.n1399 252.115
R4584 VSS.t328 VSS.n1414 252.115
R4585 VSS.t470 VSS.n1430 252.115
R4586 VSS.n1563 VSS.t2218 252.083
R4587 VSS.t745 VSS.n639 250.837
R4588 VSS.t758 VSS.n640 250.837
R4589 VSS.t1651 VSS.n644 250.837
R4590 VSS.t2122 VSS.n645 250.837
R4591 VSS.t626 VSS.n649 250.837
R4592 VSS.t1146 VSS.n650 250.837
R4593 VSS.t168 VSS.n654 250.837
R4594 VSS.t172 VSS.n655 250.837
R4595 VSS.t290 VSS.n659 250.837
R4596 VSS.t541 VSS.n660 250.837
R4597 VSS.t170 VSS.n664 250.837
R4598 VSS.t1572 VSS.n665 250.837
R4599 VSS.t1147 VSS.n669 250.837
R4600 VSS.t292 VSS.n670 250.837
R4601 VSS.t1570 VSS.n674 250.837
R4602 VSS.t265 VSS.n675 250.837
R4603 VSS.t164 VSS.n679 250.837
R4604 VSS.t166 VSS.n680 250.837
R4605 VSS.t2137 VSS.n684 250.837
R4606 VSS.t747 VSS.n685 250.837
R4607 VSS.t1568 VSS.n689 250.837
R4608 VSS.t1149 VSS.n690 250.837
R4609 VSS.t484 VSS.n694 250.837
R4610 VSS.t545 VSS.n695 250.837
R4611 VSS.t543 VSS.n699 250.837
R4612 VSS.t486 VSS.n700 250.837
R4613 VSS.t579 VSS.n704 250.837
R4614 VSS.t1605 VSS.n705 250.837
R4615 VSS.t488 VSS.n709 250.837
R4616 VSS.t267 VSS.n710 250.837
R4617 VSS.t749 VSS.n714 250.837
R4618 VSS.t2138 VSS.n715 250.837
R4619 VSS.n1105 VSS.t537 250.837
R4620 VSS.n1104 VSS.t700 250.837
R4621 VSS.n1101 VSS.t1599 250.837
R4622 VSS.n1100 VSS.t1154 250.837
R4623 VSS.n1097 VSS.t441 250.837
R4624 VSS.n1096 VSS.t261 250.837
R4625 VSS.n1093 VSS.t1264 250.837
R4626 VSS.n1092 VSS.t2223 250.837
R4627 VSS.n1089 VSS.t455 250.837
R4628 VSS.n1088 VSS.t710 250.837
R4629 VSS.n1085 VSS.t294 250.837
R4630 VSS.n1084 VSS.t703 250.837
R4631 VSS.n1081 VSS.t751 250.837
R4632 VSS.n1080 VSS.t428 250.837
R4633 VSS.n1077 VSS.t1580 250.837
R4634 VSS.n1076 VSS.t583 250.837
R4635 VSS.n1073 VSS.t2409 250.837
R4636 VSS.n1072 VSS.t1797 250.837
R4637 VSS.n1069 VSS.t1796 250.837
R4638 VSS.n1068 VSS.t2322 250.837
R4639 VSS.n1065 VSS.t496 250.837
R4640 VSS.n1064 VSS.t1793 250.837
R4641 VSS.n1061 VSS.t501 250.837
R4642 VSS.n1060 VSS.t2232 250.837
R4643 VSS.n1057 VSS.t1586 250.837
R4644 VSS.n1056 VSS.t613 250.837
R4645 VSS.n1053 VSS.t2413 250.837
R4646 VSS.n1052 VSS.t628 250.837
R4647 VSS.n1049 VSS.t1411 250.837
R4648 VSS.n1048 VSS.t527 250.837
R4649 VSS.n1045 VSS.t347 250.837
R4650 VSS.n1044 VSS.t1627 250.837
R4651 VSS.n1197 VSS.t1151 250.837
R4652 VSS.n1204 VSS.t581 250.837
R4653 VSS.n1213 VSS.t582 250.837
R4654 VSS.n1220 VSS.t263 250.837
R4655 VSS.n1229 VSS.t1808 250.837
R4656 VSS.n1236 VSS.t2317 250.837
R4657 VSS.n1245 VSS.t427 250.837
R4658 VSS.n1252 VSS.t457 250.837
R4659 VSS.n1261 VSS.t448 250.837
R4660 VSS.n1267 VSS.t595 250.837
R4661 VSS.n1276 VSS.t661 250.837
R4662 VSS.n1283 VSS.t620 250.837
R4663 VSS.n1292 VSS.t2321 250.837
R4664 VSS.n1299 VSS.t551 250.837
R4665 VSS.n1308 VSS.t731 250.837
R4666 VSS.n1314 VSS.t1361 250.837
R4667 VSS.n1323 VSS.t601 250.837
R4668 VSS.n1330 VSS.t1483 250.837
R4669 VSS.n1339 VSS.t1595 250.837
R4670 VSS.n1346 VSS.t2412 250.837
R4671 VSS.n1355 VSS.t708 250.837
R4672 VSS.n1361 VSS.t279 250.837
R4673 VSS.n1370 VSS.t162 250.837
R4674 VSS.n1377 VSS.t1653 250.837
R4675 VSS.n1386 VSS.t174 250.837
R4676 VSS.n1393 VSS.t554 250.837
R4677 VSS.n1402 VSS.t622 250.837
R4678 VSS.n1408 VSS.t1438 250.837
R4679 VSS.n1417 VSS.t1602 250.837
R4680 VSS.n1424 VSS.t553 250.837
R4681 VSS.n1433 VSS.t2011 250.837
R4682 VSS.n1440 VSS.t752 250.837
R4683 VSS.n2357 VSS.t727 250.837
R4684 VSS.n2356 VSS.t549 250.837
R4685 VSS.n2353 VSS.t547 250.837
R4686 VSS.n2352 VSS.t706 250.837
R4687 VSS.n2349 VSS.t704 250.837
R4688 VSS.n2348 VSS.t2411 250.837
R4689 VSS.n2345 VSS.t2410 250.837
R4690 VSS.n2344 VSS.t525 250.837
R4691 VSS.n2341 VSS.t523 250.837
R4692 VSS.n2340 VSS.t1649 250.837
R4693 VSS.n2337 VSS.t1647 250.837
R4694 VSS.n2336 VSS.t756 250.837
R4695 VSS.n2333 VSS.t754 250.837
R4696 VSS.n2332 VSS.t743 250.837
R4697 VSS.n2329 VSS.t741 250.837
R4698 VSS.n2328 VSS.t1625 250.837
R4699 VSS.n2325 VSS.t1623 250.837
R4700 VSS.n2324 VSS.t345 250.837
R4701 VSS.n2321 VSS.t343 250.837
R4702 VSS.n2320 VSS.t1645 250.837
R4703 VSS.n2317 VSS.t1643 250.837
R4704 VSS.n2316 VSS.t618 250.837
R4705 VSS.n2313 VSS.t616 250.837
R4706 VSS.n2312 VSS.t2220 250.837
R4707 VSS.n2309 VSS.t2219 250.837
R4708 VSS.n2308 VSS.t2110 250.837
R4709 VSS.n2305 VSS.t2109 250.837
R4710 VSS.n2304 VSS.t446 250.837
R4711 VSS.n2301 VSS.t444 250.837
R4712 VSS.n2300 VSS.t83 250.837
R4713 VSS.n2297 VSS.t712 250.837
R4714 VSS.n2296 VSS.t1789 250.837
R4715 VSS.n2448 VSS.t160 250.837
R4716 VSS.n2456 VSS.t277 250.837
R4717 VSS.n2465 VSS.t275 250.837
R4718 VSS.n2472 VSS.t1601 250.837
R4719 VSS.n2481 VSS.t1600 250.837
R4720 VSS.n2488 VSS.t1437 250.837
R4721 VSS.n2497 VSS.t1436 250.837
R4722 VSS.n2504 VSS.t612 250.837
R4723 VSS.n2513 VSS.t610 250.837
R4724 VSS.n2520 VSS.t1585 250.837
R4725 VSS.n2529 VSS.t1584 250.837
R4726 VSS.n2536 VSS.t2231 250.837
R4727 VSS.n2545 VSS.t2230 250.837
R4728 VSS.n2552 VSS.t499 250.837
R4729 VSS.n2561 VSS.t498 250.837
R4730 VSS.n2568 VSS.t1410 250.837
R4731 VSS.n2577 VSS.t1409 250.837
R4732 VSS.n2584 VSS.t625 250.837
R4733 VSS.n2593 VSS.t623 250.837
R4734 VSS.n2600 VSS.t2121 250.837
R4735 VSS.n2609 VSS.t2120 250.837
R4736 VSS.n2616 VSS.t1792 250.837
R4737 VSS.n2625 VSS.t1791 250.837
R4738 VSS.n2632 VSS.t1594 250.837
R4739 VSS.n2641 VSS.t1593 250.837
R4740 VSS.n2648 VSS.t1480 250.837
R4741 VSS.n2657 VSS.t1477 250.837
R4742 VSS.n2664 VSS.t599 250.837
R4743 VSS.n2673 VSS.t597 250.837
R4744 VSS.n2680 VSS.t1360 250.837
R4745 VSS.n2689 VSS.t1359 250.837
R4746 VSS.n2696 VSS.t729 250.837
R4747 VSS.n1890 VSS.n1889 248.252
R4748 VSS.n1778 VSS.n1777 244.186
R4749 VSS.n1805 VSS.n1804 244.186
R4750 VSS.n489 VSS.t1506 240.956
R4751 VSS.t1064 VSS.n508 240.956
R4752 VSS.t1074 VSS.n521 240.956
R4753 VSS.t1084 VSS.n543 240.956
R4754 VSS.t1094 VSS.n561 240.956
R4755 VSS.t1104 VSS.n579 240.956
R4756 VSS.t1114 VSS.n593 240.956
R4757 VSS.t342 VSS.n1688 240.698
R4758 VSS.n798 VSS.t539 234.114
R4759 VSS.n793 VSS.t2287 234.114
R4760 VSS.n788 VSS.t1199 234.114
R4761 VSS.n783 VSS.t1705 234.114
R4762 VSS.n778 VSS.t1672 234.114
R4763 VSS.n773 VSS.t1666 234.114
R4764 VSS.n768 VSS.t1710 234.114
R4765 VSS.n763 VSS.t1721 234.114
R4766 VSS.n758 VSS.t1719 234.114
R4767 VSS.n753 VSS.t1680 234.114
R4768 VSS.n748 VSS.t1863 234.114
R4769 VSS.n743 VSS.t1866 234.114
R4770 VSS.n738 VSS.t1905 234.114
R4771 VSS.n733 VSS.t1906 234.114
R4772 VSS.n728 VSS.t1910 234.114
R4773 VSS.n723 VSS.t1984 234.114
R4774 VSS.t116 VSS.n932 234.114
R4775 VSS.t795 VSS.n939 234.114
R4776 VSS.t1125 VSS.n946 234.114
R4777 VSS.t316 VSS.n953 234.114
R4778 VSS.t2266 VSS.n960 234.114
R4779 VSS.t270 VSS.n967 234.114
R4780 VSS.t329 VSS.n974 234.114
R4781 VSS.t435 VSS.n981 234.114
R4782 VSS.t2309 VSS.n988 234.114
R4783 VSS.t114 VSS.n995 234.114
R4784 VSS.t339 VSS.n1002 234.114
R4785 VSS.t1179 VSS.n1009 234.114
R4786 VSS.t2415 VSS.n1016 234.114
R4787 VSS.t658 VSS.n1023 234.114
R4788 VSS.t400 VSS.n1030 234.114
R4789 VSS.t349 VSS.n1037 234.114
R4790 VSS.t184 VSS.n1208 234.114
R4791 VSS.t514 VSS.n1224 234.114
R4792 VSS.t811 VSS.n1240 234.114
R4793 VSS.t98 VSS.n1256 234.114
R4794 VSS.t1168 VSS.n1271 234.114
R4795 VSS.t631 VSS.n1287 234.114
R4796 VSS.t1249 VSS.n1303 234.114
R4797 VSS.t322 VSS.n1318 234.114
R4798 VSS.t1440 VSS.n1334 234.114
R4799 VSS.t695 VSS.n1350 234.114
R4800 VSS.t1129 VSS.n1365 234.114
R4801 VSS.t312 VSS.n1381 234.114
R4802 VSS.t193 VSS.n1397 234.114
R4803 VSS.t228 VSS.n1412 234.114
R4804 VSS.t519 VSS.n1428 234.114
R4805 VSS.t1454 VSS.n1443 234.114
R4806 VSS.t1997 VSS.n2184 234.114
R4807 VSS.t2006 VSS.n2191 234.114
R4808 VSS.t2018 VSS.n2198 234.114
R4809 VSS.t2034 VSS.n2205 234.114
R4810 VSS.t2027 VSS.n2212 234.114
R4811 VSS.t2056 VSS.n2219 234.114
R4812 VSS.t2299 VSS.n2226 234.114
R4813 VSS.t2071 VSS.n2233 234.114
R4814 VSS.t2069 VSS.n2240 234.114
R4815 VSS.t2096 VSS.n2247 234.114
R4816 VSS.t2098 VSS.n2254 234.114
R4817 VSS.t1859 VSS.n2261 234.114
R4818 VSS.t1319 VSS.n2268 234.114
R4819 VSS.t1245 VSS.n2275 234.114
R4820 VSS.t1890 VSS.n2282 234.114
R4821 VSS.t1894 VSS.n2289 234.114
R4822 VSS.t1273 VSS.n2460 234.114
R4823 VSS.t1737 VSS.n2476 234.114
R4824 VSS.t1133 VSS.n2491 234.114
R4825 VSS.t1275 VSS.n2507 234.114
R4826 VSS.t1223 VSS.n2523 234.114
R4827 VSS.t1370 VSS.n2540 234.114
R4828 VSS.t1371 VSS.n2555 234.114
R4829 VSS.t480 VSS.n2571 234.114
R4830 VSS.t490 VSS.n2588 234.114
R4831 VSS.t451 VSS.n2603 234.114
R4832 VSS.t1377 VSS.n2619 234.114
R4833 VSS.t1137 VSS.n2636 234.114
R4834 VSS.t2202 VSS.n2651 234.114
R4835 VSS.t1226 VSS.n2668 234.114
R4836 VSS.t1294 VSS.n2684 234.114
R4837 VSS.t1298 VSS.n2699 234.114
R4838 VSS.n1747 VSS.t888 233.721
R4839 VSS.t1777 VSS.n3121 231.767
R4840 VSS.t2129 VSS.n3084 231.766
R4841 VSS.t1219 VSS.n2844 231.764
R4842 VSS.t2043 VSS.n486 230.327
R4843 VSS.n1773 VSS.n1772 230.233
R4844 VSS.n1739 VSS.n1737 230.233
R4845 VSS.n1740 VSS.n1706 230.233
R4846 VSS.n509 VSS.t1064 229.44
R4847 VSS.n522 VSS.t1074 229.44
R4848 VSS.n544 VSS.t1084 229.44
R4849 VSS.n562 VSS.t1094 229.44
R4850 VSS.n580 VSS.t1104 229.44
R4851 VSS.n594 VSS.t1114 229.44
R4852 VSS.t1506 VSS.n488 228.827
R4853 VSS.t1818 VSS.n409 225.361
R4854 VSS.t540 VSS.n413 225.361
R4855 VSS.t1198 VSS.n419 225.361
R4856 VSS.t1704 VSS.n421 225.361
R4857 VSS.t1671 VSS.n423 225.361
R4858 VSS.t1667 VSS.n427 225.361
R4859 VSS.t1720 VSS.n433 225.361
R4860 VSS.t1718 VSS.n435 225.361
R4861 VSS.t1679 VSS.n437 225.361
R4862 VSS.t1862 VSS.n441 225.361
R4863 VSS.t1904 VSS.n447 225.361
R4864 VSS.t1907 VSS.n390 225.361
R4865 VSS.t1911 VSS.n389 225.361
R4866 VSS.n375 VSS.t1449 225.361
R4867 VSS.t118 VSS.n319 225.361
R4868 VSS.t797 VSS.n316 225.361
R4869 VSS.t1126 VSS.n315 225.361
R4870 VSS.t318 VSS.n313 225.361
R4871 VSS.t272 VSS.n310 225.361
R4872 VSS.t331 VSS.n308 225.361
R4873 VSS.t2310 VSS.n305 225.361
R4874 VSS.t112 VSS.n303 225.361
R4875 VSS.t1181 VSS.n300 225.361
R4876 VSS.t2414 VSS.n298 225.361
R4877 VSS.t401 VSS.n296 225.361
R4878 VSS.t1914 VSS.n126 225.361
R4879 VSS.t1996 VSS.n123 225.361
R4880 VSS.n177 VSS.t2005 225.361
R4881 VSS.t2017 VSS.n121 225.361
R4882 VSS.t2033 VSS.n118 225.361
R4883 VSS.n169 VSS.t2026 225.361
R4884 VSS.t2055 VSS.n116 225.361
R4885 VSS.t2298 VSS.n113 225.361
R4886 VSS.n161 VSS.t2070 225.361
R4887 VSS.t2068 VSS.n111 225.361
R4888 VSS.t2095 VSS.n108 225.361
R4889 VSS.n154 VSS.t2099 225.361
R4890 VSS.t1860 VSS.n106 225.361
R4891 VSS.t1246 VSS.n103 225.361
R4892 VSS.t1891 VSS.n101 225.361
R4893 VSS.t1669 VSS.n2446 225.361
R4894 VSS.t1271 VSS.n2463 225.361
R4895 VSS.t1738 VSS.n2479 225.361
R4896 VSS.t1134 VSS.n2495 225.361
R4897 VSS.t1276 VSS.n2511 225.361
R4898 VSS.t1225 VSS.n2527 225.361
R4899 VSS.t1369 VSS.n2543 225.361
R4900 VSS.t1372 VSS.n2559 225.361
R4901 VSS.t482 VSS.n2575 225.361
R4902 VSS.t492 VSS.n2591 225.361
R4903 VSS.t453 VSS.n2607 225.361
R4904 VSS.t1375 VSS.n2623 225.361
R4905 VSS.t1139 VSS.n2639 225.361
R4906 VSS.t2203 VSS.n2655 225.361
R4907 VSS.t1227 VSS.n2671 225.361
R4908 VSS.t1293 VSS.n2687 225.361
R4909 VSS.n467 VSS.t2286 225.359
R4910 VSS.n462 VSS.t1709 225.359
R4911 VSS.n457 VSS.t1867 225.359
R4912 VSS.t2265 VSS.n324 225.359
R4913 VSS.t433 VSS.n326 225.359
R4914 VSS.t340 VSS.n328 225.359
R4915 VSS.t656 VSS.n331 225.359
R4916 VSS.t1321 VSS.n138 225.359
R4917 VSS.t125 VSS.n1195 225.359
R4918 VSS.t186 VSS.n1211 225.359
R4919 VSS.t513 VSS.n1227 225.359
R4920 VSS.t810 VSS.n1243 225.359
R4921 VSS.t96 VSS.n1259 225.359
R4922 VSS.t1167 VSS.n1274 225.359
R4923 VSS.t632 VSS.n1290 225.359
R4924 VSS.t1247 VSS.n1306 225.359
R4925 VSS.t320 VSS.n1321 225.359
R4926 VSS.t1439 VSS.n1337 225.359
R4927 VSS.t696 VSS.n1353 225.359
R4928 VSS.t1128 VSS.n1368 225.359
R4929 VSS.t314 VSS.n1384 225.359
R4930 VSS.t195 VSS.n1400 225.359
R4931 VSS.t230 VSS.n1415 225.359
R4932 VSS.t517 VSS.n1431 225.359
R4933 VSS.n1488 VSS.t792 224.823
R4934 VSS.n2742 VSS.t1981 224.823
R4935 VSS.t2147 VSS.n257 224.823
R4936 VSS.t1945 VSS.n2845 224.821
R4937 VSS.t206 VSS.n3085 224.821
R4938 VSS.t70 VSS.n3122 224.821
R4939 VSS.t785 VSS.n3089 222.222
R4940 VSS.t651 VSS.n2848 222.222
R4941 VSS.n3127 VSS.t2196 222.222
R4942 VSS.t2130 VSS.n1891 216.784
R4943 VSS.n1762 VSS.n1761 216.28
R4944 VSS.n1801 VSS.n1690 216.28
R4945 VSS.n1906 VSS.n1905 216.28
R4946 VSS.n1750 VSS.n1749 216.28
R4947 VSS.t2252 VSS.n47 216.094
R4948 VSS.n3027 VSS.t2252 215.731
R4949 VSS.t769 VSS.n476 212.143
R4950 VSS.t772 VSS.n506 212.143
R4951 VSS.t766 VSS.n519 212.143
R4952 VSS.t2163 VSS.n540 212.143
R4953 VSS.t778 VSS.n537 212.143
R4954 VSS.t775 VSS.n559 212.143
R4955 VSS.t763 VSS.n576 212.143
R4956 VSS.n596 VSS.t760 212.143
R4957 VSS.n469 VSS.t570 211.982
R4958 VSS.n464 VSS.t151 211.982
R4959 VSS.n459 VSS.t382 211.982
R4960 VSS.n456 VSS.t1313 211.982
R4961 VSS.n453 VSS.t567 211.982
R4962 VSS.t1656 VSS.n330 211.982
R4963 VSS.t100 VSS.n128 211.982
R4964 VSS.t1412 VSS.n407 211.982
R4965 VSS.n416 VSS.t1316 211.982
R4966 VSS.t376 VSS.n405 211.982
R4967 VSS.t145 VSS.n402 211.982
R4968 VSS.t379 VSS.n401 211.982
R4969 VSS.n430 VSS.t364 211.982
R4970 VSS.t139 VSS.n399 211.982
R4971 VSS.t373 VSS.n396 211.982
R4972 VSS.t142 VSS.n395 211.982
R4973 VSS.n444 VSS.t154 211.982
R4974 VSS.t367 VSS.n393 211.982
R4975 VSS.t1836 VSS.n374 211.982
R4976 VSS.t1390 VSS.n318 211.982
R4977 VSS.t1850 VSS.n370 211.982
R4978 VSS.t1351 VSS.n367 211.982
R4979 VSS.t1842 VSS.n312 211.982
R4980 VSS.t1353 VSS.n363 211.982
R4981 VSS.t1832 VSS.n359 211.982
R4982 VSS.t1654 VSS.n307 211.982
R4983 VSS.t1838 VSS.n355 211.982
R4984 VSS.t1348 VSS.n351 211.982
R4985 VSS.t1840 VSS.n302 211.982
R4986 VSS.t1356 VSS.n347 211.982
R4987 VSS.t1834 VSS.n343 211.982
R4988 VSS.t1852 VSS.n339 211.982
R4989 VSS.t1392 VSS.n335 211.982
R4990 VSS.t1557 VSS.n125 211.982
R4991 VSS.t2154 VSS.n176 211.982
R4992 VSS.t1590 VSS.n120 211.982
R4993 VSS.t1565 VSS.n172 211.982
R4994 VSS.t236 VSS.n168 211.982
R4995 VSS.t1265 VSS.n115 211.982
R4996 VSS.t1826 VSS.n164 211.982
R4997 VSS.t1560 VSS.n160 211.982
R4998 VSS.t1587 VSS.n110 211.982
R4999 VSS.t1562 VSS.n157 211.982
R5000 VSS.t239 VSS.n153 211.982
R5001 VSS.t1268 VSS.n105 211.982
R5002 VSS.t1828 VSS.n149 211.982
R5003 VSS.t2152 VSS.n146 211.982
R5004 VSS.t103 VSS.n100 211.982
R5005 VSS.n2450 VSS.t592 211.982
R5006 VSS.n2466 VSS.t2062 211.982
R5007 VSS.n2482 VSS.t2111 211.982
R5008 VSS.n2498 VSS.t1574 211.982
R5009 VSS.n2514 VSS.t1478 211.982
R5010 VSS.n2530 VSS.t1576 211.982
R5011 VSS.n2546 VSS.t1633 211.982
R5012 VSS.n2562 VSS.t2150 211.982
R5013 VSS.n2578 VSS.t590 211.982
R5014 VSS.n2594 VSS.t2057 211.982
R5015 VSS.n2610 VSS.t1481 211.982
R5016 VSS.n2626 VSS.t1451 211.982
R5017 VSS.n2642 VSS.t2315 211.982
R5018 VSS.n2658 VSS.t1581 211.982
R5019 VSS.n2674 VSS.t697 211.982
R5020 VSS.n2690 VSS.t2064 211.982
R5021 VSS.n1199 VSS.t733 211.982
R5022 VSS.n1215 VSS.t1658 211.982
R5023 VSS.n1231 VSS.t109 211.982
R5024 VSS.n1247 VSS.t1307 211.982
R5025 VSS.n1263 VSS.t739 211.982
R5026 VSS.n1278 VSS.t1309 211.982
R5027 VSS.n1294 VSS.t2213 211.982
R5028 VSS.n1310 VSS.t1330 211.982
R5029 VSS.n1325 VSS.t735 211.982
R5030 VSS.n1341 VSS.t1305 211.982
R5031 VSS.n1357 VSS.t737 211.982
R5032 VSS.n1372 VSS.t1311 211.982
R5033 VSS.n1388 VSS.t2215 211.982
R5034 VSS.n1404 VSS.t1332 211.982
R5035 VSS.n1419 VSS.t106 211.982
R5036 VSS.n1435 VSS.t725 211.982
R5037 VSS.n3084 VSS.t1957 210.933
R5038 VSS.t1954 VSS.n1488 210.931
R5039 VSS.n2844 VSS.t2115 210.931
R5040 VSS.t352 VSS.n2742 210.931
R5041 VSS.n3121 VSS.t1520 210.931
R5042 VSS.n257 VSS.t1523 210.931
R5043 VSS.t1936 VSS.n1458 210.93
R5044 VSS.t1784 VSS.n1469 210.93
R5045 VSS.t1798 VSS.n1480 210.93
R5046 VSS.t1938 VSS.n1499 210.93
R5047 VSS.t1786 VSS.n1510 210.93
R5048 VSS.t1804 VSS.n1521 210.93
R5049 VSS.t684 VSS.n2712 210.93
R5050 VSS.t424 VSS.n2723 210.93
R5051 VSS.t603 VSS.n2734 210.93
R5052 VSS.t687 VSS.n2753 210.93
R5053 VSS.t472 VSS.n2764 210.93
R5054 VSS.t1261 VSS.n2775 210.93
R5055 VSS.n1721 VSS.t584 210.93
R5056 VSS.t1492 VSS.n857 210.93
R5057 VSS.n239 VSS.t77 210.93
R5058 VSS.n253 VSS.t80 210.93
R5059 VSS.n267 VSS.t1494 210.93
R5060 VSS.t0 VSS.n869 210.93
R5061 VSS.t2281 VSS.n288 210.93
R5062 VSS.n2886 VSS.t1453 208.828
R5063 VSS.n491 VSS.t2043 207.294
R5064 VSS.n1897 VSS.n1896 202.798
R5065 VSS.n1894 VSS.n1893 202.798
R5066 VSS.t891 VSS.n1787 202.798
R5067 VSS.n2888 VSS.t197 202.362
R5068 VSS.n1754 VSS.n1696 202.327
R5069 VSS.n1796 VSS.n1794 202.327
R5070 VSS.n1701 VSS.n1700 202.327
R5071 VSS.n1791 VSS.n1789 202.327
R5072 VSS.n485 VSS.t1507 200.649
R5073 VSS.n1618 VSS.n0 197.518
R5074 VSS.n493 VSS.t2015 195.778
R5075 VSS.t2205 VSS.n411 195.26
R5076 VSS.t1243 VSS.n417 195.26
R5077 VSS.t1238 VSS.n420 195.26
R5078 VSS.t1928 VSS.n422 195.26
R5079 VSS.t1700 VSS.n425 195.26
R5080 VSS.t1694 VSS.n431 195.26
R5081 VSS.t1674 VSS.n434 195.26
R5082 VSS.t1932 VSS.n436 195.26
R5083 VSS.t1960 VSS.n439 195.26
R5084 VSS.t1962 VSS.n445 195.26
R5085 VSS.t1964 VSS.n448 195.26
R5086 VSS.t1883 VSS.n387 195.26
R5087 VSS.t1746 VSS.n320 195.26
R5088 VSS.t803 VSS.n317 195.26
R5089 VSS.t1794 VSS.n314 195.26
R5090 VSS.t2257 VSS.n311 195.26
R5091 VSS.n361 VSS.t608 195.26
R5092 VSS.t439 VSS.n309 195.26
R5093 VSS.t674 VSS.n306 195.26
R5094 VSS.n353 VSS.t690 195.26
R5095 VSS.t2245 VSS.n304 195.26
R5096 VSS.t1172 VSS.n301 195.26
R5097 VSS.n345 VSS.t2118 195.26
R5098 VSS.t45 VSS.n299 195.26
R5099 VSS.t85 VSS.n297 195.26
R5100 VSS.n337 VSS.t1456 195.26
R5101 VSS.t2173 VSS.n294 195.26
R5102 VSS.t1982 VSS.n124 195.26
R5103 VSS.t1973 VSS.n122 195.26
R5104 VSS.t2035 VSS.n119 195.26
R5105 VSS.t1994 VSS.n117 195.26
R5106 VSS.t2037 VSS.n114 195.26
R5107 VSS.t2301 VSS.n112 195.26
R5108 VSS.t2048 VSS.n109 195.26
R5109 VSS.t1864 VSS.n107 195.26
R5110 VSS.t1815 VSS.n104 195.26
R5111 VSS.t1241 VSS.n102 195.26
R5112 VSS.t385 VSS.n99 195.26
R5113 VSS.t2198 VSS.n2454 195.26
R5114 VSS.t1689 VSS.n2470 195.26
R5115 VSS.t2140 VSS.n2486 195.26
R5116 VSS.t299 VSS.n2502 195.26
R5117 VSS.t2200 VSS.n2518 195.26
R5118 VSS.t412 VSS.n2534 195.26
R5119 VSS.t306 VSS.n2550 195.26
R5120 VSS.t61 VSS.n2566 195.26
R5121 VSS.t1281 VSS.n2582 195.26
R5122 VSS.t1750 VSS.n2598 195.26
R5123 VSS.t1728 VSS.n2614 195.26
R5124 VSS.t244 VSS.n2630 195.26
R5125 VSS.t1708 VSS.n2646 195.26
R5126 VSS.t325 VSS.n2662 195.26
R5127 VSS.t1753 VSS.n2678 195.26
R5128 VSS.t67 VSS.n2694 195.26
R5129 VSS.n468 VSS.t2208 195.26
R5130 VSS.n463 VSS.t1801 195.26
R5131 VSS.n458 VSS.t1967 195.26
R5132 VSS.n455 VSS.t1978 195.26
R5133 VSS.t1441 VSS.n322 195.26
R5134 VSS.t1987 VSS.n129 195.26
R5135 VSS.t2051 VSS.n131 195.26
R5136 VSS.t2072 VSS.n133 195.26
R5137 VSS.t2087 VSS.n136 195.26
R5138 VSS.t1871 VSS.n139 195.26
R5139 VSS.t2313 VSS.n1202 195.26
R5140 VSS.t224 VSS.n1218 195.26
R5141 VSS.t2251 VSS.n1234 195.26
R5142 VSS.t287 VSS.n1250 195.26
R5143 VSS.t2166 VSS.n1265 195.26
R5144 VSS.t2184 VSS.n1281 195.26
R5145 VSS.t1417 VSS.n1297 195.26
R5146 VSS.t2242 VSS.n1312 195.26
R5147 VSS.t2262 VSS.n1328 195.26
R5148 VSS.t2271 VSS.n1344 195.26
R5149 VSS.t2248 VSS.n1359 195.26
R5150 VSS.t1681 VSS.n1375 195.26
R5151 VSS.t410 VSS.n1391 195.26
R5152 VSS.t210 VSS.n1406 195.26
R5153 VSS.t1209 VSS.n1422 195.26
R5154 VSS.t2164 VSS.n1438 195.26
R5155 VSS.t2178 VSS.n477 194.899
R5156 VSS.n3034 VSS.t131 194.514
R5157 VSS.n1781 VSS.t892 192.309
R5158 VSS.n1451 VSS.t931 190.097
R5159 VSS.n1462 VSS.t942 190.097
R5160 VSS.n1473 VSS.t953 190.097
R5161 VSS.n1492 VSS.t964 190.097
R5162 VSS.n1503 VSS.t975 190.097
R5163 VSS.n1514 VSS.t986 190.097
R5164 VSS.n2705 VSS.t813 190.097
R5165 VSS.n2716 VSS.t824 190.097
R5166 VSS.n2727 VSS.t834 190.097
R5167 VSS.n2746 VSS.t844 190.097
R5168 VSS.n2757 VSS.t854 190.097
R5169 VSS.n2768 VSS.t864 190.097
R5170 VSS.n1729 VSS.t874 190.097
R5171 VSS.n853 VSS.t997 190.097
R5172 VSS.n233 VSS.t1007 190.097
R5173 VSS.n245 VSS.t1018 190.097
R5174 VSS.n262 VSS.t1027 190.097
R5175 VSS.n865 VSS.t1038 190.097
R5176 VSS.n281 VSS.t1048 190.097
R5177 VSS.t335 VSS.n538 189.137
R5178 VSS.n497 VSS.t2025 189.135
R5179 VSS.n1784 VSS.n1783 188.811
R5180 VSS.n1903 VSS.n1902 188.373
R5181 VSS.t1130 VSS.n1619 187.895
R5182 VSS.n799 VSS.t1322 187.292
R5183 VSS.n794 VSS.t668 187.292
R5184 VSS.n789 VSS.t460 187.292
R5185 VSS.n784 VSS.t458 187.292
R5186 VSS.n779 VSS.t1901 187.292
R5187 VSS.n774 VSS.t1898 187.292
R5188 VSS.n769 VSS.t1324 187.292
R5189 VSS.n764 VSS.t1326 187.292
R5190 VSS.n759 VSS.t2149 187.292
R5191 VSS.n754 VSS.t308 187.292
R5192 VSS.n749 VSS.t1739 187.292
R5193 VSS.n744 VSS.t531 187.292
R5194 VSS.n739 VSS.t1401 187.292
R5195 VSS.n734 VSS.t670 187.292
R5196 VSS.n729 VSS.t2148 187.292
R5197 VSS.n724 VSS.t1230 187.292
R5198 VSS.t680 VSS.n931 187.292
R5199 VSS.t1216 VSS.n938 187.292
R5200 VSS.t1232 VSS.n945 187.292
R5201 VSS.t511 VSS.n952 187.292
R5202 VSS.t1484 VSS.n959 187.292
R5203 VSS.t2308 VSS.n966 187.292
R5204 VSS.t1431 VSS.n973 187.292
R5205 VSS.t28 VSS.n980 187.292
R5206 VSS.t51 VSS.n987 187.292
R5207 VSS.t234 VSS.n994 187.292
R5208 VSS.t2136 VSS.n1001 187.292
R5209 VSS.t1702 VSS.n1008 187.292
R5210 VSS.t654 VSS.n1015 187.292
R5211 VSS.t2134 VSS.n1022 187.292
R5212 VSS.t1212 VSS.n1029 187.292
R5213 VSS.t793 VSS.n1036 187.292
R5214 VSS.n1205 VSS.t1123 187.292
R5215 VSS.n1222 VSS.t26 187.292
R5216 VSS.n1238 VSS.t310 187.292
R5217 VSS.n1253 VSS.t285 187.292
R5218 VSS.n1269 VSS.t533 187.292
R5219 VSS.n1285 VSS.t359 187.292
R5220 VSS.n1300 VSS.t1716 187.292
R5221 VSS.n1316 VSS.t1473 187.292
R5222 VSS.n1332 VSS.t535 187.292
R5223 VSS.n1347 VSS.t2221 187.292
R5224 VSS.n1363 VSS.t281 187.292
R5225 VSS.n1379 VSS.t465 187.292
R5226 VSS.n1394 VSS.t2127 187.292
R5227 VSS.n1410 VSS.t677 187.292
R5228 VSS.n1426 VSS.t1177 187.292
R5229 VSS.n1441 VSS.t520 187.292
R5230 VSS.t1912 VSS.n2183 187.292
R5231 VSS.t1501 VSS.n2190 187.292
R5232 VSS.t1255 VSS.n2197 187.292
R5233 VSS.t1403 VSS.n2204 187.292
R5234 VSS.t1823 VSS.n2211 187.292
R5235 VSS.t1919 VSS.n2218 187.292
R5236 VSS.t1916 VSS.n2225 187.292
R5237 VSS.t2290 VSS.n2232 187.292
R5238 VSS.t1362 VSS.n2239 187.292
R5239 VSS.t1509 VSS.n2246 187.292
R5240 VSS.t1328 VSS.n2253 187.292
R5241 VSS.t1336 VSS.n2260 187.292
R5242 VSS.t1334 VSS.n2267 187.292
R5243 VSS.t1364 VSS.n2274 187.292
R5244 VSS.t672 VSS.n2281 187.292
R5245 VSS.t1825 VSS.n2288 187.292
R5246 VSS.n2457 VSS.t1664 187.292
R5247 VSS.n2473 VSS.t253 187.292
R5248 VSS.n2489 VSS.t1155 187.292
R5249 VSS.n2505 VSS.t1780 187.292
R5250 VSS.n2521 VSS.t1714 187.292
R5251 VSS.n2537 VSS.t1692 187.292
R5252 VSS.n2553 VSS.t1975 187.292
R5253 VSS.n2569 VSS.t1857 187.292
R5254 VSS.n2585 VSS.t1854 187.292
R5255 VSS.n2601 VSS.t1809 187.292
R5256 VSS.n2617 VSS.t1807 187.292
R5257 VSS.n2633 VSS.t1698 187.292
R5258 VSS.n2649 VSS.t1684 187.292
R5259 VSS.n2665 VSS.t1783 187.292
R5260 VSS.n2681 VSS.t1759 187.292
R5261 VSS.n2697 VSS.t1782 187.292
R5262 VSS.n1799 VSS.t896 184.885
R5263 VSS.n1741 VSS.t886 184.885
R5264 VSS.t2254 VSS.n1705 184.885
R5265 VSS.n495 VSS.t1508 184.262
R5266 VSS.n6 VSS.t683 177.713
R5267 VSS.n477 VSS.t768 177.617
R5268 VSS.n538 VSS.t777 177.617
R5269 VSS.n511 VSS.t771 177.615
R5270 VSS.n524 VSS.t765 177.615
R5271 VSS.n546 VSS.t2162 177.615
R5272 VSS.n564 VSS.t774 177.615
R5273 VSS.n582 VSS.t762 177.615
R5274 VSS.t759 VSS.n591 177.615
R5275 VSS.t934 VSS.n1451 176.208
R5276 VSS.t945 VSS.n1462 176.208
R5277 VSS.t956 VSS.n1473 176.208
R5278 VSS.t967 VSS.n1492 176.208
R5279 VSS.t978 VSS.n1503 176.208
R5280 VSS.t989 VSS.n1514 176.208
R5281 VSS.t816 VSS.n2705 176.208
R5282 VSS.t826 VSS.n2716 176.208
R5283 VSS.t836 VSS.n2727 176.208
R5284 VSS.t846 VSS.n2746 176.208
R5285 VSS.t856 VSS.n2757 176.208
R5286 VSS.t866 VSS.n2768 176.208
R5287 VSS.t877 VSS.n1729 176.208
R5288 VSS.t1000 VSS.n853 176.208
R5289 VSS.t1010 VSS.n233 176.208
R5290 VSS.t1020 VSS.n245 176.208
R5291 VSS.t1030 VSS.n262 176.208
R5292 VSS.t1041 VSS.n865 176.208
R5293 VSS.t1050 VSS.n281 176.208
R5294 VSS.n1888 VSS.t8 175.31
R5295 VSS.n1776 VSS.n1775 174.419
R5296 VSS.n1813 VSS.n1811 174.419
R5297 VSS.n1734 VSS.n1710 174.419
R5298 VSS.t149 VSS.n643 173.913
R5299 VSS.t1597 VSS.n648 173.913
R5300 VSS.t559 VSS.n653 173.913
R5301 VSS.n658 VSS.t158 173.913
R5302 VSS.t562 VSS.n663 173.913
R5303 VSS.t1611 VSS.n668 173.913
R5304 VSS.t574 VSS.n673 173.913
R5305 VSS.t1617 VSS.n678 173.913
R5306 VSS.n683 VSS.t556 173.913
R5307 VSS.t371 VSS.n688 173.913
R5308 VSS.t565 VSS.n693 173.913
R5309 VSS.t1614 VSS.n698 173.913
R5310 VSS.t577 VSS.n703 173.913
R5311 VSS.n708 VSS.t1620 173.913
R5312 VSS.t1346 VSS.n713 173.913
R5313 VSS.t1608 VSS.n718 173.913
R5314 VSS.n720 VSS.n385 173.913
R5315 VSS.n1102 VSS.t1831 173.913
R5316 VSS.n1098 VSS.t1512 173.913
R5317 VSS.n1094 VSS.t1385 173.913
R5318 VSS.n1090 VSS.t1847 173.913
R5319 VSS.n1086 VSS.t1387 173.913
R5320 VSS.n1082 VSS.t1517 173.913
R5321 VSS.n1078 VSS.t1395 173.913
R5322 VSS.n1074 VSS.t1941 173.913
R5323 VSS.n1070 VSS.t1383 173.913
R5324 VSS.n1066 VSS.t1849 173.913
R5325 VSS.n1062 VSS.t1389 173.913
R5326 VSS.n1058 VSS.t1519 173.913
R5327 VSS.n1054 VSS.t1397 173.913
R5328 VSS.n1050 VSS.t1943 173.913
R5329 VSS.n1046 VSS.t1845 173.913
R5330 VSS.n1042 VSS.t1514 173.913
R5331 VSS.n1040 VSS.n1039 173.913
R5332 VSS.t2212 VSS.n1209 173.913
R5333 VSS.t1762 VSS.n1225 173.913
R5334 VSS.t717 VSS.n1241 173.913
R5335 VSS.t1285 VSS.n1257 173.913
R5336 VSS.t720 VSS.n1272 173.913
R5337 VSS.t1767 VSS.n1288 173.913
R5338 VSS.t1661 VSS.n1304 173.913
R5339 VSS.t1773 VSS.n1319 173.913
R5340 VSS.t714 VSS.n1335 173.913
R5341 VSS.t463 VSS.n1351 173.913
R5342 VSS.t723 VSS.n1366 173.913
R5343 VSS.t1769 VSS.n1382 173.913
R5344 VSS.t1663 VSS.n1398 173.913
R5345 VSS.t1775 VSS.n1413 173.913
R5346 VSS.t2210 VSS.n1429 173.913
R5347 VSS.t1764 VSS.n1444 173.913
R5348 VSS.n1524 VSS.n1448 173.913
R5349 VSS.n2354 VSS.t1953 173.913
R5350 VSS.n2350 VSS.t1947 173.913
R5351 VSS.n2346 VSS.t1638 173.913
R5352 VSS.n2342 VSS.t2161 173.913
R5353 VSS.n2338 VSS.t1640 173.913
R5354 VSS.n2334 VSS.t1406 173.913
R5355 VSS.n2330 VSS.t177 173.913
R5356 VSS.n2326 VSS.t504 173.913
R5357 VSS.n2322 VSS.t1636 173.913
R5358 VSS.n2318 VSS.t1579 173.913
R5359 VSS.n2314 VSS.t1642 173.913
R5360 VSS.n2310 VSS.t1408 173.913
R5361 VSS.n2306 VSS.t180 173.913
R5362 VSS.n2302 VSS.t507 173.913
R5363 VSS.n2298 VSS.t1302 173.913
R5364 VSS.n2294 VSS.t1950 173.913
R5365 VSS.n2292 VSS.n2291 173.913
R5366 VSS.t1632 VSS.n2461 173.913
R5367 VSS.t404 VSS.n2477 173.913
R5368 VSS.t1735 VSS.n2493 173.913
R5369 VSS.t1500 VSS.n2509 173.913
R5370 VSS.t420 VSS.n2525 173.913
R5371 VSS.t134 VSS.n2541 173.913
R5372 VSS.t1604 VSS.n2557 173.913
R5373 VSS.t2157 VSS.n2573 173.913
R5374 VSS.t417 VSS.n2589 173.913
R5375 VSS.t1630 VSS.n2605 173.913
R5376 VSS.t1498 VSS.n2621 173.913
R5377 VSS.t137 VSS.n2637 173.913
R5378 VSS.t2083 VSS.n2653 173.913
R5379 VSS.t2159 VSS.n2669 173.913
R5380 VSS.t41 VSS.n2685 173.913
R5381 VSS.t407 VSS.n2700 173.913
R5382 VSS.n1889 VSS.t361 173.119
R5383 VSS.t2226 VSS.n1769 167.442
R5384 VSS.t1413 VSS.t2206 163.881
R5385 VSS.t571 VSS.t2207 163.881
R5386 VSS.t1317 VSS.t1244 163.881
R5387 VSS.t377 VSS.t1239 163.881
R5388 VSS.t146 VSS.t1927 163.881
R5389 VSS.t380 VSS.t1699 163.881
R5390 VSS.t152 VSS.t1802 163.881
R5391 VSS.t365 VSS.t1695 163.881
R5392 VSS.t140 VSS.t1673 163.881
R5393 VSS.t374 VSS.t1933 163.881
R5394 VSS.t143 VSS.t1961 163.881
R5395 VSS.t383 VSS.t1968 163.881
R5396 VSS.t155 VSS.t1963 163.881
R5397 VSS.t368 VSS.t1965 163.881
R5398 VSS.t1314 VSS.t1977 163.881
R5399 VSS.t568 VSS.t1882 163.881
R5400 VSS.t1745 VSS.t1837 163.881
R5401 VSS.t805 VSS.t1391 163.881
R5402 VSS.t1442 VSS.t1851 163.881
R5403 VSS.t1795 VSS.t1352 163.881
R5404 VSS.t2256 VSS.t1843 163.881
R5405 VSS.t607 VSS.t1354 163.881
R5406 VSS.t437 VSS.t1833 163.881
R5407 VSS.t675 VSS.t1655 163.881
R5408 VSS.t691 VSS.t1839 163.881
R5409 VSS.t2246 VSS.t1349 163.881
R5410 VSS.t1171 VSS.t1841 163.881
R5411 VSS.t2119 VSS.t1357 163.881
R5412 VSS.t47 VSS.t1835 163.881
R5413 VSS.t87 VSS.t1657 163.881
R5414 VSS.t1457 VSS.t1853 163.881
R5415 VSS.t1393 VSS.t2174 163.881
R5416 VSS.t2312 VSS.t734 163.881
R5417 VSS.t225 VSS.t1659 163.881
R5418 VSS.t2250 VSS.t110 163.881
R5419 VSS.t288 VSS.t1308 163.881
R5420 VSS.t740 VSS.t2167 163.881
R5421 VSS.t2185 VSS.t1310 163.881
R5422 VSS.t1415 VSS.t2214 163.881
R5423 VSS.t1331 VSS.t2241 163.881
R5424 VSS.t2261 VSS.t736 163.881
R5425 VSS.t2270 VSS.t1306 163.881
R5426 VSS.t738 VSS.t2249 163.881
R5427 VSS.t1682 VSS.t1312 163.881
R5428 VSS.t409 VSS.t2216 163.881
R5429 VSS.t1333 VSS.t212 163.881
R5430 VSS.t1210 VSS.t107 163.881
R5431 VSS.t2165 VSS.t726 163.881
R5432 VSS.t1983 VSS.t1558 163.881
R5433 VSS.t1988 VSS.t101 163.881
R5434 VSS.t1974 VSS.t2155 163.881
R5435 VSS.t2036 VSS.t1591 163.881
R5436 VSS.t2052 VSS.t1566 163.881
R5437 VSS.t1995 VSS.t237 163.881
R5438 VSS.t2038 VSS.t1266 163.881
R5439 VSS.t2074 VSS.t1827 163.881
R5440 VSS.t2302 VSS.t1561 163.881
R5441 VSS.t2049 VSS.t1588 163.881
R5442 VSS.t2088 VSS.t1563 163.881
R5443 VSS.t1865 VSS.t240 163.881
R5444 VSS.t1816 VSS.t1269 163.881
R5445 VSS.t1872 VSS.t1829 163.881
R5446 VSS.t1242 VSS.t2153 163.881
R5447 VSS.t387 VSS.t104 163.881
R5448 VSS.t2197 VSS.t593 163.881
R5449 VSS.t1690 VSS.t2063 163.881
R5450 VSS.t2141 VSS.t2112 163.881
R5451 VSS.t301 VSS.t1575 163.881
R5452 VSS.t2199 VSS.t1479 163.881
R5453 VSS.t414 VSS.t1577 163.881
R5454 VSS.t304 VSS.t1634 163.881
R5455 VSS.t63 VSS.t2151 163.881
R5456 VSS.t1279 VSS.t591 163.881
R5457 VSS.t1749 VSS.t2058 163.881
R5458 VSS.t1727 VSS.t1482 163.881
R5459 VSS.t242 VSS.t1452 163.881
R5460 VSS.t1707 VSS.t2316 163.881
R5461 VSS.t323 VSS.t1582 163.881
R5462 VSS.t1752 VSS.t698 163.881
R5463 VSS.t65 VSS.t2065 163.881
R5464 VSS.n1521 VSS.t996 162.322
R5465 VSS.n1510 VSS.t985 162.322
R5466 VSS.n1499 VSS.t974 162.322
R5467 VSS.n1480 VSS.t963 162.322
R5468 VSS.n1469 VSS.t952 162.322
R5469 VSS.n1458 VSS.t941 162.322
R5470 VSS.n2775 VSS.t873 162.322
R5471 VSS.n2764 VSS.t863 162.322
R5472 VSS.n2753 VSS.t853 162.322
R5473 VSS.n2734 VSS.t843 162.322
R5474 VSS.n2723 VSS.t833 162.322
R5475 VSS.n2712 VSS.t823 162.322
R5476 VSS.t883 VSS.n1721 162.322
R5477 VSS.t1057 VSS.n288 162.322
R5478 VSS.n869 VSS.t1047 162.322
R5479 VSS.n267 VSS.t1037 162.322
R5480 VSS.n253 VSS.t1026 162.322
R5481 VSS.n239 VSS.t1017 162.322
R5482 VSS.n857 VSS.t1006 162.322
R5483 VSS.n1813 VSS.n1812 160.465
R5484 VSS.n1745 VSS.n1744 160.465
R5485 VSS.n498 VSS.t1058 160.341
R5486 VSS.n512 VSS.t1068 160.341
R5487 VSS.n529 VSS.t1078 160.341
R5488 VSS.n552 VSS.t1088 160.341
R5489 VSS.n569 VSS.t1098 160.341
R5490 VSS.n583 VSS.t1108 160.341
R5491 VSS.t2124 VSS.n3074 157.601
R5492 VSS.n2824 VSS.t93 157.062
R5493 VSS.t809 VSS.n1686 156.977
R5494 VSS.t884 VSS.n1735 156.977
R5495 VSS.n3078 VSS.t338 156.464
R5496 VSS.t2182 VSS.n2819 156.429
R5497 VSS.t1197 VSS.n407 155.126
R5498 VSS.t1157 VSS.n416 155.126
R5499 VSS.t1300 VSS.n405 155.126
R5500 VSS.t1781 VSS.n402 155.126
R5501 VSS.t1693 VSS.n401 155.126
R5502 VSS.t1803 VSS.n430 155.126
R5503 VSS.t1712 VSS.n399 155.126
R5504 VSS.t1930 VSS.n396 155.126
R5505 VSS.t1889 VSS.n395 155.126
R5506 VSS.t1922 VSS.n444 155.126
R5507 VSS.t1923 VSS.n393 155.126
R5508 VSS.n374 VSS.t2170 155.126
R5509 VSS.t38 VSS.n318 155.126
R5510 VSS.n370 VSS.t1166 155.126
R5511 VSS.n367 VSS.t652 155.126
R5512 VSS.t1696 VSS.n312 155.126
R5513 VSS.n363 VSS.t807 155.126
R5514 VSS.n359 VSS.t2255 155.126
R5515 VSS.t2191 VSS.n307 155.126
R5516 VSS.n355 VSS.t49 155.126
R5517 VSS.n351 VSS.t1427 155.126
R5518 VSS.t1190 VSS.n302 155.126
R5519 VSS.n347 VSS.t1258 155.126
R5520 VSS.n343 VSS.t789 155.126
R5521 VSS.n339 VSS.t781 155.126
R5522 VSS.n335 VSS.t1254 155.126
R5523 VSS.t1986 VSS.n125 155.126
R5524 VSS.n176 VSS.t2003 155.126
R5525 VSS.t2021 VSS.n120 155.126
R5526 VSS.n172 VSS.t2023 155.126
R5527 VSS.n168 VSS.t2030 155.126
R5528 VSS.t2059 VSS.n115 155.126
R5529 VSS.n164 VSS.t2300 155.126
R5530 VSS.n160 VSS.t2294 155.126
R5531 VSS.t2080 VSS.n110 155.126
R5532 VSS.n157 VSS.t2085 155.126
R5533 VSS.n153 VSS.t1812 155.126
R5534 VSS.t1235 VSS.n105 155.126
R5535 VSS.n149 VSS.t1399 155.126
R5536 VSS.n146 VSS.t1880 155.126
R5537 VSS.t1817 VSS.n100 155.126
R5538 VSS.t1443 VSS.n2450 155.126
R5539 VSS.t1687 VSS.n2466 155.126
R5540 VSS.t528 VSS.n2482 155.126
R5541 VSS.t1278 VSS.n2498 155.126
R5542 VSS.t2277 VSS.n2514 155.126
R5543 VSS.t1367 VSS.n2530 155.126
R5544 VSS.t1374 VSS.n2546 155.126
R5545 VSS.t2279 VSS.n2562 155.126
R5546 VSS.t1283 VSS.n2578 155.126
R5547 VSS.t1341 VSS.n2594 155.126
R5548 VSS.t1724 VSS.n2610 155.126
R5549 VSS.t2144 VSS.n2626 155.126
R5550 VSS.t665 VSS.n2642 155.126
R5551 VSS.t1288 VSS.n2658 155.126
R5552 VSS.t1296 VSS.n2674 155.126
R5553 VSS.t2204 VSS.n2690 155.126
R5554 VSS.n469 VSS.t2288 155.125
R5555 VSS.n464 VSS.t1770 155.125
R5556 VSS.n459 VSS.t1976 155.125
R5557 VSS.n456 VSS.t1924 155.125
R5558 VSS.n453 VSS.t1869 155.125
R5559 VSS.t1429 VSS.n330 155.125
R5560 VSS.t1989 VSS.n128 155.125
R5561 VSS.t1191 VSS.n1199 155.125
R5562 VSS.t1211 VSS.n1215 155.125
R5563 VSS.t467 VSS.n1231 155.125
R5564 VSS.t780 VSS.n1247 155.125
R5565 VSS.t2306 VSS.n1263 155.125
R5566 VSS.t2126 VSS.n1278 155.125
R5567 VSS.t2113 VSS.n1294 155.125
R5568 VSS.t2108 VSS.n1310 155.125
R5569 VSS.t1234 VSS.n1325 155.125
R5570 VSS.t216 VSS.n1341 155.125
R5571 VSS.t1119 VSS.n1357 155.125
R5572 VSS.t2311 VSS.n1372 155.125
R5573 VSS.t2264 VSS.n1388 155.125
R5574 VSS.t43 VSS.n1404 155.125
R5575 VSS.t1120 VSS.n1419 155.125
R5576 VSS.t214 VSS.n1435 155.125
R5577 VSS.n3088 VSS.t204 154.862
R5578 VSS.t790 VSS.n1486 154.862
R5579 VSS.n2847 VSS.t1944 154.862
R5580 VSS.t1980 VSS.n2740 154.862
R5581 VSS.n3125 VSS.t69 154.862
R5582 VSS.t2146 VSS.n250 154.862
R5583 VSS.n1591 VSS.t2358 154.613
R5584 VSS.n1602 VSS.t2365 154.613
R5585 VSS.t2028 VSS.n481 153.971
R5586 VSS.n3078 VSS.t1176 153.851
R5587 VSS.n808 VSS.t1162 153.846
R5588 VSS.n799 VSS.t148 153.846
R5589 VSS.n794 VSS.t1596 153.846
R5590 VSS.n789 VSS.t558 153.846
R5591 VSS.n784 VSS.t157 153.846
R5592 VSS.n779 VSS.t561 153.846
R5593 VSS.n774 VSS.t1610 153.846
R5594 VSS.n769 VSS.t573 153.846
R5595 VSS.n764 VSS.t1616 153.846
R5596 VSS.n759 VSS.t555 153.846
R5597 VSS.n754 VSS.t370 153.846
R5598 VSS.n749 VSS.t564 153.846
R5599 VSS.n744 VSS.t1613 153.846
R5600 VSS.n739 VSS.t576 153.846
R5601 VSS.n734 VSS.t1619 153.846
R5602 VSS.n729 VSS.t1345 153.846
R5603 VSS.n724 VSS.t1607 153.846
R5604 VSS.t398 VSS.n924 153.846
R5605 VSS.t1830 VSS.n931 153.846
R5606 VSS.t1511 VSS.n938 153.846
R5607 VSS.t1384 VSS.n945 153.846
R5608 VSS.t1846 VSS.n952 153.846
R5609 VSS.t1386 VSS.n959 153.846
R5610 VSS.t1516 VSS.n966 153.846
R5611 VSS.t1394 VSS.n973 153.846
R5612 VSS.t1940 VSS.n980 153.846
R5613 VSS.t1382 VSS.n987 153.846
R5614 VSS.t1848 VSS.n994 153.846
R5615 VSS.t1388 VSS.n1001 153.846
R5616 VSS.t1518 VSS.n1008 153.846
R5617 VSS.t1396 VSS.n1015 153.846
R5618 VSS.t1942 VSS.n1022 153.846
R5619 VSS.t1844 VSS.n1029 153.846
R5620 VSS.t1513 VSS.n1036 153.846
R5621 VSS.t1434 VSS.n1188 153.846
R5622 VSS.t2211 VSS.n1205 153.846
R5623 VSS.t1761 VSS.n1222 153.846
R5624 VSS.t716 VSS.n1238 153.846
R5625 VSS.t1284 VSS.n1253 153.846
R5626 VSS.t719 VSS.n1269 153.846
R5627 VSS.t1766 VSS.n1285 153.846
R5628 VSS.t1660 VSS.n1300 153.846
R5629 VSS.t1772 VSS.n1316 153.846
R5630 VSS.t713 VSS.n1332 153.846
R5631 VSS.t462 VSS.n1347 153.846
R5632 VSS.t722 VSS.n1363 153.846
R5633 VSS.t1768 VSS.n1379 153.846
R5634 VSS.t1662 VSS.n1394 153.846
R5635 VSS.t1774 VSS.n1410 153.846
R5636 VSS.t2209 VSS.n1426 153.846
R5637 VSS.t1763 VSS.n1441 153.846
R5638 VSS.t1821 VSS.n2176 153.846
R5639 VSS.t1952 VSS.n2183 153.846
R5640 VSS.t1946 VSS.n2190 153.846
R5641 VSS.t1637 VSS.n2197 153.846
R5642 VSS.t2160 VSS.n2204 153.846
R5643 VSS.t1639 VSS.n2211 153.846
R5644 VSS.t1405 VSS.n2218 153.846
R5645 VSS.t176 VSS.n2225 153.846
R5646 VSS.t503 VSS.n2232 153.846
R5647 VSS.t1635 VSS.n2239 153.846
R5648 VSS.t1578 VSS.n2246 153.846
R5649 VSS.t1641 VSS.n2253 153.846
R5650 VSS.t1407 VSS.n2260 153.846
R5651 VSS.t179 VSS.n2267 153.846
R5652 VSS.t506 VSS.n2274 153.846
R5653 VSS.t1301 VSS.n2281 153.846
R5654 VSS.t1949 VSS.n2288 153.846
R5655 VSS.t1677 VSS.n2443 153.846
R5656 VSS.t1631 VSS.n2457 153.846
R5657 VSS.t403 VSS.n2473 153.846
R5658 VSS.t1734 VSS.n2489 153.846
R5659 VSS.t1499 VSS.n2505 153.846
R5660 VSS.t419 VSS.n2521 153.846
R5661 VSS.t133 VSS.n2537 153.846
R5662 VSS.t1603 VSS.n2553 153.846
R5663 VSS.t2156 VSS.n2569 153.846
R5664 VSS.t416 VSS.n2585 153.846
R5665 VSS.t1629 VSS.n2601 153.846
R5666 VSS.t1497 VSS.n2617 153.846
R5667 VSS.t136 VSS.n2633 153.846
R5668 VSS.t2082 VSS.n2649 153.846
R5669 VSS.t2158 VSS.n2665 153.846
R5670 VSS.t40 VSS.n2681 153.846
R5671 VSS.t406 VSS.n2697 153.846
R5672 VSS.t1381 VSS.n2819 153.327
R5673 VSS.t2101 VSS.n384 153.236
R5674 VSS.n378 VSS.t1742 153.236
R5675 VSS.t2125 VSS.n1184 153.236
R5676 VSS.n183 VSS.t2269 153.236
R5677 VSS.n2838 VSS.t94 153.236
R5678 VSS.n1719 VSS.n1718 152.102
R5679 VSS.n1775 VSS.t516 150
R5680 VSS.t2046 VSS.n482 149.713
R5681 VSS.t1060 VSS.n498 148.826
R5682 VSS.t1070 VSS.n512 148.826
R5683 VSS.t1080 VSS.n529 148.826
R5684 VSS.t1090 VSS.n552 148.826
R5685 VSS.t1100 VSS.n569 148.826
R5686 VSS.t1110 VSS.n583 148.826
R5687 VSS.t1744 VSS.n3 147.452
R5688 VSS.t247 VSS.n642 147.157
R5689 VSS.t71 VSS.n647 147.157
R5690 VSS.t74 VSS.n652 147.157
R5691 VSS.t1683 VSS.n657 147.157
R5692 VSS.t1688 VSS.n662 147.157
R5693 VSS.t1758 VSS.n667 147.157
R5694 VSS.t1726 VSS.n672 147.157
R5695 VSS.t1697 VSS.n677 147.157
R5696 VSS.t1731 VSS.n682 147.157
R5697 VSS.t1929 VSS.n687 147.157
R5698 VSS.t1935 VSS.n692 147.157
R5699 VSS.t1956 VSS.n697 147.157
R5700 VSS.t1881 VSS.n702 147.157
R5701 VSS.t1900 VSS.n707 147.157
R5702 VSS.t1903 VSS.n712 147.157
R5703 VSS.t2002 VSS.n717 147.157
R5704 VSS.n1103 VSS.t2171 147.157
R5705 VSS.n1099 VSS.t1419 147.157
R5706 VSS.n1095 VSS.t2263 147.157
R5707 VSS.n1091 VSS.t806 147.157
R5708 VSS.n1087 VSS.t1118 147.157
R5709 VSS.n1083 VSS.t469 147.157
R5710 VSS.n1079 VSS.t615 147.157
R5711 VSS.n1075 VSS.t475 147.157
R5712 VSS.n1071 VSS.t202 147.157
R5713 VSS.n1067 VSS.t2079 147.157
R5714 VSS.n1063 VSS.t208 147.157
R5715 VSS.n1059 VSS.t2189 147.157
R5716 VSS.n1055 VSS.t1424 147.157
R5717 VSS.n1051 VSS.t182 147.157
R5718 VSS.n1047 VSS.t218 147.157
R5719 VSS.n1043 VSS.t391 147.157
R5720 VSS.t1426 VSS.n1206 147.157
R5721 VSS.t2240 VSS.n1223 147.157
R5722 VSS.t2172 VSS.n1239 147.157
R5723 VSS.t1165 VSS.n1254 147.157
R5724 VSS.t1475 VSS.n1270 147.157
R5725 VSS.t1448 VSS.n1286 147.157
R5726 VSS.t1122 VSS.n1301 147.157
R5727 VSS.t220 VSS.n1317 147.157
R5728 VSS.t1188 VSS.n1333 147.157
R5729 VSS.t222 VSS.n1348 147.157
R5730 VSS.t471 VSS.n1364 147.157
R5731 VSS.t1257 VSS.n1380 147.157
R5732 VSS.t213 VSS.n1395 147.157
R5733 VSS.t2114 VSS.n1411 147.157
R5734 VSS.t394 VSS.n1427 147.157
R5735 VSS.t2135 VSS.n1442 147.157
R5736 VSS.n2355 VSS.t1993 147.157
R5737 VSS.n2351 VSS.t2004 147.157
R5738 VSS.n2347 VSS.t2039 147.157
R5739 VSS.n2343 VSS.t1999 147.157
R5740 VSS.n2339 VSS.t2000 147.157
R5741 VSS.n2335 VSS.t2047 147.157
R5742 VSS.n2331 VSS.t2040 147.157
R5743 VSS.n2327 VSS.t2060 147.157
R5744 VSS.n2323 VSS.t2050 147.157
R5745 VSS.n2319 VSS.t2097 147.157
R5746 VSS.n2315 VSS.t1813 147.157
R5747 VSS.n2311 VSS.t1810 147.157
R5748 VSS.n2307 VSS.t1358 147.157
R5749 VSS.n2303 VSS.t1885 147.157
R5750 VSS.n2299 VSS.t2320 147.157
R5751 VSS.n2295 VSS.t1250 147.157
R5752 VSS.t1736 VSS.n2458 147.157
R5753 VSS.t297 VSS.n2475 147.157
R5754 VSS.t659 VSS.n2490 147.157
R5755 VSS.t59 VSS.n2506 147.157
R5756 VSS.t2142 VSS.n2522 147.157
R5757 VSS.t663 VSS.n2538 147.157
R5758 VSS.t1748 VSS.n2554 147.157
R5759 VSS.t1339 VSS.n2570 147.157
R5760 VSS.t1779 VSS.n2587 147.157
R5761 VSS.t1286 VSS.n2602 147.157
R5762 VSS.t1491 VSS.n2618 147.157
R5763 VSS.t1192 VSS.n2635 147.157
R5764 VSS.t1289 VSS.n2650 147.157
R5765 VSS.t1379 VSS.n2666 147.157
R5766 VSS.t1291 VSS.n2683 147.157
R5767 VSS.t1141 VSS.n2698 147.157
R5768 VSS.t902 VSS.n1898 146.853
R5769 VSS.n1783 VSS.n1782 146.853
R5770 VSS.n1760 VSS.n1759 146.512
R5771 VSS.n1799 VSS.n1797 146.512
R5772 VSS.n1904 VSS.n1903 146.512
R5773 VSS.t2380 VSS.n1446 145.093
R5774 VSS.t2333 VSS.n2703 145.093
R5775 VSS.t2405 VSS.n451 145.091
R5776 VSS.t2392 VSS.n333 145.091
R5777 VSS.t2345 VSS.n142 145.091
R5778 VSS.n1803 VSS.t898 143.024
R5779 VSS.n1759 VSS.t199 139.536
R5780 VSS.t692 VSS.n1710 139.536
R5781 VSS.n1446 VSS.t2376 138.404
R5782 VSS.n2703 VSS.t2329 138.403
R5783 VSS.n451 VSS.t2401 138.403
R5784 VSS.n333 VSS.t2388 138.403
R5785 VSS.n142 VSS.t2341 138.403
R5786 VSS.t1117 VSS.n591 137.311
R5787 VSS.n582 VSS.t1107 137.311
R5788 VSS.n564 VSS.t1097 137.311
R5789 VSS.n546 VSS.t1087 137.311
R5790 VSS.n524 VSS.t1077 137.311
R5791 VSS.n511 VSS.t1067 137.311
R5792 VSS.t1486 VSS.n489 137.309
R5793 VSS.n1753 VSS.t890 136.048
R5794 VSS.n2832 VSS.t1228 134.661
R5795 VSS.n3126 VSS.t2010 133.78
R5796 VSS.n3090 VSS.t2176 133.78
R5797 VSS.n2849 VSS.t191 133.78
R5798 VSS.n1888 VSS.n1821 132.891
R5799 VSS.n1895 VSS.n1894 132.868
R5800 VSS.n1790 VSS.n1700 132.559
R5801 VSS.n1791 VSS.n1790 132.559
R5802 VSS.t2329 VSS.n2701 131.975
R5803 VSS.t2376 VSS.n1445 131.974
R5804 VSS.t2401 VSS.n450 131.972
R5805 VSS.t2388 VSS.n332 131.972
R5806 VSS.t2341 VSS.n141 131.972
R5807 VSS.n479 VSS.t2024 130.939
R5808 VSS.t333 VSS.n550 130.939
R5809 VSS.n1767 VSS.t635 129.071
R5810 VSS.t1203 VSS.n1696 129.071
R5811 VSS.t3 VSS.n1806 129.071
R5812 VSS.t900 VSS.n1687 129.071
R5813 VSS.n1718 VSS.n1715 129.071
R5814 VSS.t1206 VSS.n1743 129.071
R5815 VSS.n3073 VSS.t1252 127.421
R5816 VSS.t1343 VSS.n2825 126.945
R5817 VSS.t2227 VSS.n1764 125.582
R5818 VSS.t2224 VSS.n1 125.359
R5819 VSS.t233 VSS.n3068 123.674
R5820 VSS.n2829 VSS.t252 123.212
R5821 VSS.n2778 VSS.t2333 122.516
R5822 VSS.n1619 VSS.n1618 122.129
R5823 VSS.t890 VSS.n1751 122.094
R5824 VSS.n1621 VSS.t5 121.858
R5825 VSS.t2010 VSS.n384 120.691
R5826 VSS.t2176 VSS.n378 120.691
R5827 VSS.t338 VSS.n1184 120.691
R5828 VSS.t191 VSS.n183 120.691
R5829 VSS.n2838 VSS.t2182 120.691
R5830 VSS.n492 VSS.t2032 119.422
R5831 VSS.n1765 VSS.t2227 118.606
R5832 VSS.n1899 VSS.t902 118.606
R5833 VSS.n1750 VSS.n1748 118.606
R5834 VSS.n1537 VSS.t2123 118.249
R5835 VSS.t91 VSS.n2832 117.858
R5836 VSS.n720 VSS.t2405 117.058
R5837 VSS.n1040 VSS.t2392 117.058
R5838 VSS.n1448 VSS.t2380 117.058
R5839 VSS.n2292 VSS.t2345 117.058
R5840 VSS.n3067 VSS.t641 116.177
R5841 VSS.t1755 VSS.n2830 115.745
R5842 VSS.t1208 VSS.n1703 115.117
R5843 VSS.t283 VSS.n1611 112.174
R5844 VSS.t648 VSS.n883 112.15
R5845 VSS.n1782 VSS.t2131 111.888
R5846 VSS.n836 VSS.t495 109.198
R5847 VSS.t679 VSS.n884 109.198
R5848 VSS.t260 VSS.n2137 109.198
R5849 VSS.t642 VSS.n3071 108.683
R5850 VSS.n2827 VSS.t1756 108.276
R5851 VSS.n801 VSS.t1197 107.023
R5852 VSS.n798 VSS.t247 107.023
R5853 VSS.t2288 VSS.n796 107.023
R5854 VSS.n793 VSS.t71 107.023
R5855 VSS.n791 VSS.t1157 107.023
R5856 VSS.n788 VSS.t74 107.023
R5857 VSS.n786 VSS.t1300 107.023
R5858 VSS.n783 VSS.t1683 107.023
R5859 VSS.n781 VSS.t1781 107.023
R5860 VSS.n778 VSS.t1688 107.023
R5861 VSS.n776 VSS.t1693 107.023
R5862 VSS.n773 VSS.t1758 107.023
R5863 VSS.t1770 VSS.n771 107.023
R5864 VSS.n768 VSS.t1726 107.023
R5865 VSS.n766 VSS.t1803 107.023
R5866 VSS.n763 VSS.t1697 107.023
R5867 VSS.n761 VSS.t1712 107.023
R5868 VSS.n758 VSS.t1731 107.023
R5869 VSS.n756 VSS.t1930 107.023
R5870 VSS.n753 VSS.t1929 107.023
R5871 VSS.n751 VSS.t1889 107.023
R5872 VSS.n748 VSS.t1935 107.023
R5873 VSS.t1976 VSS.n746 107.023
R5874 VSS.n743 VSS.t1956 107.023
R5875 VSS.n741 VSS.t1922 107.023
R5876 VSS.n738 VSS.t1881 107.023
R5877 VSS.n736 VSS.t1923 107.023
R5878 VSS.n733 VSS.t1900 107.023
R5879 VSS.t1924 VSS.n731 107.023
R5880 VSS.n728 VSS.t1903 107.023
R5881 VSS.t1869 VSS.n726 107.023
R5882 VSS.n723 VSS.t2002 107.023
R5883 VSS.t2170 VSS.n929 107.023
R5884 VSS.t2171 VSS.n932 107.023
R5885 VSS.n936 VSS.t38 107.023
R5886 VSS.t1419 VSS.n939 107.023
R5887 VSS.t1166 VSS.n943 107.023
R5888 VSS.t2263 VSS.n946 107.023
R5889 VSS.t652 VSS.n950 107.023
R5890 VSS.t806 VSS.n953 107.023
R5891 VSS.n957 VSS.t1696 107.023
R5892 VSS.t1118 VSS.n960 107.023
R5893 VSS.t807 VSS.n964 107.023
R5894 VSS.t469 VSS.n967 107.023
R5895 VSS.t2255 VSS.n971 107.023
R5896 VSS.t615 VSS.n974 107.023
R5897 VSS.n978 VSS.t2191 107.023
R5898 VSS.t475 VSS.n981 107.023
R5899 VSS.t49 VSS.n985 107.023
R5900 VSS.t202 VSS.n988 107.023
R5901 VSS.t1427 VSS.n992 107.023
R5902 VSS.t2079 VSS.n995 107.023
R5903 VSS.n999 VSS.t1190 107.023
R5904 VSS.t208 VSS.n1002 107.023
R5905 VSS.t1258 VSS.n1006 107.023
R5906 VSS.t2189 VSS.n1009 107.023
R5907 VSS.t789 VSS.n1013 107.023
R5908 VSS.t1424 VSS.n1016 107.023
R5909 VSS.n1020 VSS.t1429 107.023
R5910 VSS.t182 VSS.n1023 107.023
R5911 VSS.t781 VSS.n1027 107.023
R5912 VSS.t218 VSS.n1030 107.023
R5913 VSS.t1254 VSS.n1034 107.023
R5914 VSS.t391 VSS.n1037 107.023
R5915 VSS.n1200 VSS.t1191 107.023
R5916 VSS.n1208 VSS.t1426 107.023
R5917 VSS.n1216 VSS.t1211 107.023
R5918 VSS.n1224 VSS.t2240 107.023
R5919 VSS.n1232 VSS.t467 107.023
R5920 VSS.n1240 VSS.t2172 107.023
R5921 VSS.n1248 VSS.t780 107.023
R5922 VSS.n1256 VSS.t1165 107.023
R5923 VSS.n1264 VSS.t2306 107.023
R5924 VSS.n1271 VSS.t1475 107.023
R5925 VSS.n1279 VSS.t2126 107.023
R5926 VSS.n1287 VSS.t1448 107.023
R5927 VSS.n1295 VSS.t2113 107.023
R5928 VSS.n1303 VSS.t1122 107.023
R5929 VSS.n1311 VSS.t2108 107.023
R5930 VSS.n1318 VSS.t220 107.023
R5931 VSS.n1326 VSS.t1234 107.023
R5932 VSS.n1334 VSS.t1188 107.023
R5933 VSS.n1342 VSS.t216 107.023
R5934 VSS.n1350 VSS.t222 107.023
R5935 VSS.n1358 VSS.t1119 107.023
R5936 VSS.n1365 VSS.t471 107.023
R5937 VSS.n1373 VSS.t2311 107.023
R5938 VSS.n1381 VSS.t1257 107.023
R5939 VSS.n1389 VSS.t2264 107.023
R5940 VSS.n1397 VSS.t213 107.023
R5941 VSS.n1405 VSS.t43 107.023
R5942 VSS.n1412 VSS.t2114 107.023
R5943 VSS.n1420 VSS.t1120 107.023
R5944 VSS.n1428 VSS.t394 107.023
R5945 VSS.n1436 VSS.t214 107.023
R5946 VSS.n1443 VSS.t2135 107.023
R5947 VSS.n2181 VSS.t1986 107.023
R5948 VSS.t1993 VSS.n2184 107.023
R5949 VSS.n2188 VSS.t1989 107.023
R5950 VSS.t2004 VSS.n2191 107.023
R5951 VSS.t2003 VSS.n2195 107.023
R5952 VSS.t2039 VSS.n2198 107.023
R5953 VSS.n2202 VSS.t2021 107.023
R5954 VSS.t1999 VSS.n2205 107.023
R5955 VSS.t2023 VSS.n2209 107.023
R5956 VSS.t2000 VSS.n2212 107.023
R5957 VSS.t2030 VSS.n2216 107.023
R5958 VSS.t2047 VSS.n2219 107.023
R5959 VSS.n2223 VSS.t2059 107.023
R5960 VSS.t2040 VSS.n2226 107.023
R5961 VSS.t2300 VSS.n2230 107.023
R5962 VSS.t2060 VSS.n2233 107.023
R5963 VSS.t2294 VSS.n2237 107.023
R5964 VSS.t2050 VSS.n2240 107.023
R5965 VSS.n2244 VSS.t2080 107.023
R5966 VSS.t2097 VSS.n2247 107.023
R5967 VSS.t2085 VSS.n2251 107.023
R5968 VSS.t1813 VSS.n2254 107.023
R5969 VSS.t1812 VSS.n2258 107.023
R5970 VSS.t1810 VSS.n2261 107.023
R5971 VSS.n2265 VSS.t1235 107.023
R5972 VSS.t1358 VSS.n2268 107.023
R5973 VSS.t1399 VSS.n2272 107.023
R5974 VSS.t1885 VSS.n2275 107.023
R5975 VSS.t1880 VSS.n2279 107.023
R5976 VSS.t2320 VSS.n2282 107.023
R5977 VSS.n2286 VSS.t1817 107.023
R5978 VSS.t1250 VSS.n2289 107.023
R5979 VSS.n2451 VSS.t1443 107.023
R5980 VSS.n2460 VSS.t1736 107.023
R5981 VSS.n2468 VSS.t1687 107.023
R5982 VSS.n2476 VSS.t297 107.023
R5983 VSS.n2484 VSS.t528 107.023
R5984 VSS.n2491 VSS.t659 107.023
R5985 VSS.n2499 VSS.t1278 107.023
R5986 VSS.n2507 VSS.t59 107.023
R5987 VSS.n2515 VSS.t2277 107.023
R5988 VSS.n2523 VSS.t2142 107.023
R5989 VSS.n2531 VSS.t1367 107.023
R5990 VSS.n2540 VSS.t663 107.023
R5991 VSS.n2548 VSS.t1374 107.023
R5992 VSS.n2555 VSS.t1748 107.023
R5993 VSS.n2563 VSS.t2279 107.023
R5994 VSS.n2571 VSS.t1339 107.023
R5995 VSS.n2580 VSS.t1283 107.023
R5996 VSS.n2588 VSS.t1779 107.023
R5997 VSS.n2595 VSS.t1341 107.023
R5998 VSS.n2603 VSS.t1286 107.023
R5999 VSS.n2611 VSS.t1724 107.023
R6000 VSS.n2619 VSS.t1491 107.023
R6001 VSS.n2628 VSS.t2144 107.023
R6002 VSS.n2636 VSS.t1192 107.023
R6003 VSS.n2643 VSS.t665 107.023
R6004 VSS.n2651 VSS.t1289 107.023
R6005 VSS.n2659 VSS.t1288 107.023
R6006 VSS.n2668 VSS.t1379 107.023
R6007 VSS.n2676 VSS.t1296 107.023
R6008 VSS.n2684 VSS.t1291 107.023
R6009 VSS.n2691 VSS.t2204 107.023
R6010 VSS.n2699 VSS.t1141 107.023
R6011 VSS.t1259 VSS.n3065 106.808
R6012 VSS.n1774 VSS.n1773 104.651
R6013 VSS.n1769 VSS.n1768 104.651
R6014 VSS.t1743 VSS.n1690 104.651
R6015 VSS.n1808 VSS.n1807 104.651
R6016 VSS.n1812 VSS.n1687 104.651
R6017 VSS.n1739 VSS.n1738 104.651
R6018 VSS.n2883 VSS.t90 103.538
R6019 VSS.n2890 VSS.t788 103.379
R6020 VSS.n1808 VSS.t3 101.163
R6021 VSS.n1809 VSS.t900 101.163
R6022 VSS.t274 VSS.n1703 101.163
R6023 VSS.n829 VSS.t1158 100.344
R6024 VSS.t55 VSS.n1114 100.344
R6025 VSS.t389 VSS.n2367 100.344
R6026 VSS.n808 VSS.t2395 100.335
R6027 VSS.t148 VSS.n642 100.335
R6028 VSS.t1596 VSS.n647 100.335
R6029 VSS.t558 VSS.n652 100.335
R6030 VSS.t157 VSS.n657 100.335
R6031 VSS.t561 VSS.n662 100.335
R6032 VSS.t1610 VSS.n667 100.335
R6033 VSS.t573 VSS.n672 100.335
R6034 VSS.t1616 VSS.n677 100.335
R6035 VSS.t555 VSS.n682 100.335
R6036 VSS.t370 VSS.n687 100.335
R6037 VSS.t564 VSS.n692 100.335
R6038 VSS.t1613 VSS.n697 100.335
R6039 VSS.t576 VSS.n702 100.335
R6040 VSS.t1619 VSS.n707 100.335
R6041 VSS.t1345 VSS.n712 100.335
R6042 VSS.t1607 VSS.n717 100.335
R6043 VSS.t2382 VSS.n924 100.335
R6044 VSS.n1103 VSS.t1830 100.335
R6045 VSS.n1099 VSS.t1511 100.335
R6046 VSS.n1095 VSS.t1384 100.335
R6047 VSS.n1091 VSS.t1846 100.335
R6048 VSS.n1087 VSS.t1386 100.335
R6049 VSS.n1083 VSS.t1516 100.335
R6050 VSS.n1079 VSS.t1394 100.335
R6051 VSS.n1075 VSS.t1940 100.335
R6052 VSS.n1071 VSS.t1382 100.335
R6053 VSS.n1067 VSS.t1848 100.335
R6054 VSS.n1063 VSS.t1388 100.335
R6055 VSS.n1059 VSS.t1518 100.335
R6056 VSS.n1055 VSS.t1396 100.335
R6057 VSS.n1051 VSS.t1942 100.335
R6058 VSS.n1047 VSS.t1844 100.335
R6059 VSS.n1043 VSS.t1513 100.335
R6060 VSS.n1188 VSS.t2371 100.335
R6061 VSS.n1206 VSS.t2211 100.335
R6062 VSS.n1223 VSS.t1761 100.335
R6063 VSS.n1239 VSS.t716 100.335
R6064 VSS.n1254 VSS.t1284 100.335
R6065 VSS.n1270 VSS.t719 100.335
R6066 VSS.n1286 VSS.t1766 100.335
R6067 VSS.n1301 VSS.t1660 100.335
R6068 VSS.n1317 VSS.t1772 100.335
R6069 VSS.n1333 VSS.t713 100.335
R6070 VSS.n1348 VSS.t462 100.335
R6071 VSS.n1364 VSS.t722 100.335
R6072 VSS.n1380 VSS.t1768 100.335
R6073 VSS.n1395 VSS.t1662 100.335
R6074 VSS.n1411 VSS.t1774 100.335
R6075 VSS.n1427 VSS.t2209 100.335
R6076 VSS.n1442 VSS.t1763 100.335
R6077 VSS.t2335 VSS.n2176 100.335
R6078 VSS.n2355 VSS.t1952 100.335
R6079 VSS.n2351 VSS.t1946 100.335
R6080 VSS.n2347 VSS.t1637 100.335
R6081 VSS.n2343 VSS.t2160 100.335
R6082 VSS.n2339 VSS.t1639 100.335
R6083 VSS.n2335 VSS.t1405 100.335
R6084 VSS.n2331 VSS.t176 100.335
R6085 VSS.n2327 VSS.t503 100.335
R6086 VSS.n2323 VSS.t1635 100.335
R6087 VSS.n2319 VSS.t1578 100.335
R6088 VSS.n2315 VSS.t1641 100.335
R6089 VSS.n2311 VSS.t1407 100.335
R6090 VSS.n2307 VSS.t179 100.335
R6091 VSS.n2303 VSS.t506 100.335
R6092 VSS.n2299 VSS.t1301 100.335
R6093 VSS.n2295 VSS.t1949 100.335
R6094 VSS.n2443 VSS.t2324 100.335
R6095 VSS.n2458 VSS.t1631 100.335
R6096 VSS.n2475 VSS.t403 100.335
R6097 VSS.n2490 VSS.t1734 100.335
R6098 VSS.n2506 VSS.t1499 100.335
R6099 VSS.n2522 VSS.t419 100.335
R6100 VSS.n2538 VSS.t133 100.335
R6101 VSS.n2554 VSS.t1603 100.335
R6102 VSS.n2570 VSS.t2156 100.335
R6103 VSS.n2587 VSS.t416 100.335
R6104 VSS.n2602 VSS.t1629 100.335
R6105 VSS.n2618 VSS.t1497 100.335
R6106 VSS.n2635 VSS.t136 100.335
R6107 VSS.n2650 VSS.t2082 100.335
R6108 VSS.n2666 VSS.t2158 100.335
R6109 VSS.n2683 VSS.t40 100.335
R6110 VSS.n2698 VSS.t406 100.335
R6111 VSS.n1591 VSS.t2361 99.7511
R6112 VSS.t2367 VSS.n1602 99.7511
R6113 VSS.n2889 VSS.t2188 98.4633
R6114 VSS.t2361 VSS.n1 97.9291
R6115 VSS.n5 VSS.t2367 97.9273
R6116 VSS.t1174 VSS.n3076 97.4396
R6117 VSS.t1145 VSS.n821 97.3935
R6118 VSS.t1215 VSS.n1115 97.3935
R6119 VSS.t1909 VSS.n2369 97.3935
R6120 VSS.n2822 VSS.t1380 97.0758
R6121 VSS.n487 VSS.t2031 96.3896
R6122 VSS.n839 VSS.t701 94.4422
R6123 VSS.t127 VSS.n1116 94.4422
R6124 VSS.t1896 VSS.n2383 94.4422
R6125 VSS.t901 VSS.n1904 94.1866
R6126 VSS.n3074 VSS.t1253 93.8889
R6127 VSS.n3076 VSS.t1260 93.6919
R6128 VSS.t1344 VSS.n2824 93.5889
R6129 VSS.t1229 VSS.n2822 93.3421
R6130 VSS.n820 VSS.t257 91.4909
R6131 VSS.t478 VSS.n875 91.4909
R6132 VSS.t422 VSS.n2129 91.4909
R6133 VSS.n1896 VSS.t509 90.9096
R6134 VSS.n1766 VSS.n1765 90.6982
R6135 VSS.n1805 VSS.n1803 90.6982
R6136 VSS.n1736 VSS.n1734 90.6982
R6137 VSS.n1743 VSS.n1705 90.6982
R6138 VSS.n450 VSS.t1608 88.4947
R6139 VSS.t1514 VSS.n332 88.4947
R6140 VSS.t1950 VSS.n141 88.4947
R6141 VSS.n1445 VSS.t1764 88.4945
R6142 VSS.n2701 VSS.t407 88.4935
R6143 VSS.n1535 VSS.t336 88.4111
R6144 VSS.t1131 VSS.n2886 88.3462
R6145 VSS.n465 VSS.t562 88.2366
R6146 VSS.n460 VSS.t371 88.2366
R6147 VSS.n454 VSS.t1346 88.2366
R6148 VSS.t1831 VSS.n321 88.2366
R6149 VSS.t1847 VSS.n323 88.2366
R6150 VSS.t1395 VSS.n325 88.2366
R6151 VSS.t1849 VSS.n327 88.2366
R6152 VSS.t1397 VSS.n329 88.2366
R6153 VSS.t1636 VSS.n134 88.2366
R6154 VSS.t1408 VSS.n137 88.2366
R6155 VSS.t1302 VSS.n140 88.2366
R6156 VSS.n412 VSS.t149 88.2359
R6157 VSS.n415 VSS.t1597 88.2359
R6158 VSS.n418 VSS.t559 88.2359
R6159 VSS.t158 VSS.n403 88.2359
R6160 VSS.n426 VSS.t1611 88.2359
R6161 VSS.n429 VSS.t574 88.2359
R6162 VSS.n432 VSS.t1617 88.2359
R6163 VSS.t556 VSS.n397 88.2359
R6164 VSS.n440 VSS.t565 88.2359
R6165 VSS.n443 VSS.t1614 88.2359
R6166 VSS.n446 VSS.t577 88.2359
R6167 VSS.t1620 VSS.n391 88.2359
R6168 VSS.t1512 VSS.n371 88.2359
R6169 VSS.t1385 VSS.n368 88.2359
R6170 VSS.t1387 VSS.n364 88.2359
R6171 VSS.t1517 VSS.n360 88.2359
R6172 VSS.t1941 VSS.n356 88.2359
R6173 VSS.t1383 VSS.n352 88.2359
R6174 VSS.t1389 VSS.n348 88.2359
R6175 VSS.t1519 VSS.n344 88.2359
R6176 VSS.t1943 VSS.n340 88.2359
R6177 VSS.t1845 VSS.n336 88.2359
R6178 VSS.t1953 VSS.n180 88.2359
R6179 VSS.t1947 VSS.n178 88.2359
R6180 VSS.t1638 VSS.n174 88.2359
R6181 VSS.t2161 VSS.n173 88.2359
R6182 VSS.t1640 VSS.n170 88.2359
R6183 VSS.t1406 VSS.n166 88.2359
R6184 VSS.t177 VSS.n165 88.2359
R6185 VSS.t504 VSS.n162 88.2359
R6186 VSS.t1579 VSS.n158 88.2359
R6187 VSS.t1642 VSS.n155 88.2359
R6188 VSS.t180 VSS.n150 88.2359
R6189 VSS.t507 VSS.n147 88.2359
R6190 VSS.n2462 VSS.t1632 88.2357
R6191 VSS.n2478 VSS.t404 88.2357
R6192 VSS.n2494 VSS.t1735 88.2357
R6193 VSS.n2510 VSS.t1500 88.2357
R6194 VSS.n2526 VSS.t420 88.2357
R6195 VSS.n2542 VSS.t134 88.2357
R6196 VSS.n2558 VSS.t1604 88.2357
R6197 VSS.n2574 VSS.t2157 88.2357
R6198 VSS.n2590 VSS.t417 88.2357
R6199 VSS.n2606 VSS.t1630 88.2357
R6200 VSS.n2622 VSS.t1498 88.2357
R6201 VSS.n2638 VSS.t137 88.2357
R6202 VSS.n2654 VSS.t2083 88.2357
R6203 VSS.n2670 VSS.t2159 88.2357
R6204 VSS.n2686 VSS.t41 88.2357
R6205 VSS.n1210 VSS.t2212 88.2357
R6206 VSS.n1226 VSS.t1762 88.2357
R6207 VSS.n1242 VSS.t717 88.2357
R6208 VSS.n1258 VSS.t1285 88.2357
R6209 VSS.n1273 VSS.t720 88.2357
R6210 VSS.n1289 VSS.t1767 88.2357
R6211 VSS.n1305 VSS.t1661 88.2357
R6212 VSS.n1320 VSS.t1773 88.2357
R6213 VSS.n1336 VSS.t714 88.2357
R6214 VSS.n1352 VSS.t463 88.2357
R6215 VSS.n1367 VSS.t723 88.2357
R6216 VSS.n1383 VSS.t1769 88.2357
R6217 VSS.n1399 VSS.t1663 88.2357
R6218 VSS.n1414 VSS.t1775 88.2357
R6219 VSS.n1430 VSS.t2210 88.2357
R6220 VSS.t2180 VSS.n2833 88.133
R6221 VSS.n1039 VSS.n291 88.4708
R6222 VSS.n2291 VSS.n96 88.4708
R6223 VSS.t1205 VSS.n1767 87.2098
R6224 VSS.n1796 VSS.t893 87.2098
R6225 VSS.n1807 VSS.t1771 87.2098
R6226 VSS.n1744 VSS.t1476 87.2098
R6227 VSS.t2395 VSS.t1160 86.957
R6228 VSS.t1162 VSS.t2397 86.957
R6229 VSS.t396 VSS.t2382 86.957
R6230 VSS.t2384 VSS.t398 86.957
R6231 VSS.t2371 VSS.t1432 86.957
R6232 VSS.t2373 VSS.t1434 86.957
R6233 VSS.t1819 VSS.t2335 86.957
R6234 VSS.t2337 VSS.t1821 86.957
R6235 VSS.t2324 VSS.t1676 86.957
R6236 VSS.t2326 VSS.t1677 86.957
R6237 VSS.t255 VSS.n826 85.5883
R6238 VSS.t476 VSS.n880 85.5883
R6239 VSS.t423 VSS.n2133 85.5883
R6240 VSS.t2045 VSS.n487 84.8733
R6241 VSS.t336 VSS.n1533 83.0562
R6242 VSS.n2835 VSS.t2180 82.7875
R6243 VSS.n3071 VSS.t337 82.449
R6244 VSS.t2181 VSS.n2827 82.1411
R6245 VSS.t1132 VSS.n2884 81.2384
R6246 VSS.n816 VSS.t30 81.1613
R6247 VSS.t646 VSS.n1128 81.1613
R6248 VSS.t2192 VSS.n2372 81.1613
R6249 VSS.n2 VSS.t2224 80.4704
R6250 VSS.n1525 VSS.n1524 80.2681
R6251 VSS.t886 VSS.n1709 80.2331
R6252 VSS.n1454 VSS.t936 78.9866
R6253 VSS.n1465 VSS.t947 78.9866
R6254 VSS.n1476 VSS.t958 78.9866
R6255 VSS.n1495 VSS.t969 78.9866
R6256 VSS.n1506 VSS.t980 78.9866
R6257 VSS.n1517 VSS.t991 78.9866
R6258 VSS.n2708 VSS.t818 78.9866
R6259 VSS.n2719 VSS.t828 78.9866
R6260 VSS.n2730 VSS.t838 78.9866
R6261 VSS.n2749 VSS.t848 78.9866
R6262 VSS.n2760 VSS.t858 78.9866
R6263 VSS.n2771 VSS.t868 78.9866
R6264 VSS.t879 VSS.n1725 78.9866
R6265 VSS.t1002 VSS.n227 78.9866
R6266 VSS.t1012 VSS.n3116 78.9866
R6267 VSS.t1022 VSS.n3110 78.9866
R6268 VSS.t1032 VSS.n3104 78.9866
R6269 VSS.t1043 VSS.n275 78.9866
R6270 VSS.t1052 VSS.n3099 78.9866
R6271 VSS.n2926 VSS.t2235 77.8798
R6272 VSS.n1755 VSS.n1754 77.8593
R6273 VSS.n1794 VSS.n1695 77.8593
R6274 VSS.n1702 VSS.n1701 77.8593
R6275 VSS.n3032 VSS.t2066 77.2751
R6276 VSS.t655 VSS.t12 77.2751
R6277 VSS.n1758 VSS.n1757 76.7447
R6278 VSS.n1902 VSS.n1901 76.7447
R6279 VSS.n1753 VSS.n1752 76.7447
R6280 VSS.t493 VSS.n833 76.7344
R6281 VSS.t678 VSS.n1112 76.7344
R6282 VSS.t258 VSS.n2365 76.7344
R6283 VSS.n3033 VSS.t130 75.4357
R6284 VSS.t337 VSS.n3069 75.2962
R6285 VSS.n2828 VSS.t2181 75.0671
R6286 VSS.t231 VSS.n3067 74.9537
R6287 VSS.t1160 VSS.n408 74.8587
R6288 VSS.n377 VSS.t396 74.8587
R6289 VSS.n182 VSS.t1819 74.8587
R6290 VSS.t1676 VSS.n2441 74.8585
R6291 VSS.t1432 VSS.n1186 74.8578
R6292 VSS.t694 VSS.n1820 74.7824
R6293 VSS.n2830 VSS.t250 74.6738
R6294 VSS.t2044 VSS.n485 73.9692
R6295 VSS.t702 VSS.n833 73.7831
R6296 VSS.t128 VSS.n1112 73.7831
R6297 VSS.n2365 VSS.t1897 73.7831
R6298 VSS.t10 VSS.n1612 73.536
R6299 VSS.n1617 VSS.n1613 73.536
R6300 VSS.n1768 VSS.t1205 73.2563
R6301 VSS.t1771 VSS.n1689 73.2563
R6302 VSS.n801 VSS.t1413 70.2346
R6303 VSS.n796 VSS.t571 70.2346
R6304 VSS.n791 VSS.t1317 70.2346
R6305 VSS.n786 VSS.t377 70.2346
R6306 VSS.n781 VSS.t146 70.2346
R6307 VSS.n776 VSS.t380 70.2346
R6308 VSS.n771 VSS.t152 70.2346
R6309 VSS.n766 VSS.t365 70.2346
R6310 VSS.n761 VSS.t140 70.2346
R6311 VSS.n756 VSS.t374 70.2346
R6312 VSS.n751 VSS.t143 70.2346
R6313 VSS.n746 VSS.t383 70.2346
R6314 VSS.n741 VSS.t155 70.2346
R6315 VSS.n736 VSS.t368 70.2346
R6316 VSS.n731 VSS.t1314 70.2346
R6317 VSS.n726 VSS.t568 70.2346
R6318 VSS.t1837 VSS.n929 70.2346
R6319 VSS.t1391 VSS.n936 70.2346
R6320 VSS.t1851 VSS.n943 70.2346
R6321 VSS.t1352 VSS.n950 70.2346
R6322 VSS.t1843 VSS.n957 70.2346
R6323 VSS.t1354 VSS.n964 70.2346
R6324 VSS.t1833 VSS.n971 70.2346
R6325 VSS.t1655 VSS.n978 70.2346
R6326 VSS.t1839 VSS.n985 70.2346
R6327 VSS.t1349 VSS.n992 70.2346
R6328 VSS.t1841 VSS.n999 70.2346
R6329 VSS.t1357 VSS.n1006 70.2346
R6330 VSS.t1835 VSS.n1013 70.2346
R6331 VSS.t1657 VSS.n1020 70.2346
R6332 VSS.t1853 VSS.n1027 70.2346
R6333 VSS.n1034 VSS.t1393 70.2346
R6334 VSS.t734 VSS.n1200 70.2346
R6335 VSS.t1659 VSS.n1216 70.2346
R6336 VSS.t110 VSS.n1232 70.2346
R6337 VSS.t1308 VSS.n1248 70.2346
R6338 VSS.n1264 VSS.t740 70.2346
R6339 VSS.t1310 VSS.n1279 70.2346
R6340 VSS.t2214 VSS.n1295 70.2346
R6341 VSS.n1311 VSS.t1331 70.2346
R6342 VSS.t736 VSS.n1326 70.2346
R6343 VSS.t1306 VSS.n1342 70.2346
R6344 VSS.n1358 VSS.t738 70.2346
R6345 VSS.t1312 VSS.n1373 70.2346
R6346 VSS.t2216 VSS.n1389 70.2346
R6347 VSS.n1405 VSS.t1333 70.2346
R6348 VSS.t107 VSS.n1420 70.2346
R6349 VSS.t726 VSS.n1436 70.2346
R6350 VSS.t1558 VSS.n2181 70.2346
R6351 VSS.t101 VSS.n2188 70.2346
R6352 VSS.t2155 VSS.n2195 70.2346
R6353 VSS.t1591 VSS.n2202 70.2346
R6354 VSS.t1566 VSS.n2209 70.2346
R6355 VSS.t237 VSS.n2216 70.2346
R6356 VSS.t1266 VSS.n2223 70.2346
R6357 VSS.t1827 VSS.n2230 70.2346
R6358 VSS.t1561 VSS.n2237 70.2346
R6359 VSS.t1588 VSS.n2244 70.2346
R6360 VSS.t1563 VSS.n2251 70.2346
R6361 VSS.t240 VSS.n2258 70.2346
R6362 VSS.t1269 VSS.n2265 70.2346
R6363 VSS.t1829 VSS.n2272 70.2346
R6364 VSS.t2153 VSS.n2279 70.2346
R6365 VSS.t104 VSS.n2286 70.2346
R6366 VSS.t593 VSS.n2451 70.2346
R6367 VSS.t2063 VSS.n2468 70.2346
R6368 VSS.t2112 VSS.n2484 70.2346
R6369 VSS.t1575 VSS.n2499 70.2346
R6370 VSS.t1479 VSS.n2515 70.2346
R6371 VSS.t1577 VSS.n2531 70.2346
R6372 VSS.t1634 VSS.n2548 70.2346
R6373 VSS.t2151 VSS.n2563 70.2346
R6374 VSS.t591 VSS.n2580 70.2346
R6375 VSS.t2058 VSS.n2595 70.2346
R6376 VSS.t1482 VSS.n2611 70.2346
R6377 VSS.t1452 VSS.n2628 70.2346
R6378 VSS.t2316 VSS.n2643 70.2346
R6379 VSS.t1582 VSS.n2659 70.2346
R6380 VSS.t698 VSS.n2676 70.2346
R6381 VSS.t2065 VSS.n2691 70.2346
R6382 VSS.n48 VSS.n26 12.4712
R6383 VSS.t636 VSS.n1760 69.7679
R6384 VSS.t682 VSS.n1693 69.7679
R6385 VSS.n2913 VSS.t1466 69.1047
R6386 VSS.n508 VSS.t1062 68.211
R6387 VSS.n521 VSS.t1072 68.211
R6388 VSS.n543 VSS.t1082 68.211
R6389 VSS.n561 VSS.t1092 68.211
R6390 VSS.n579 VSS.t1102 68.211
R6391 VSS.n593 VSS.t1112 68.211
R6392 VSS.n1555 VSS.t2104 67.4624
R6393 VSS.n3068 VSS.t231 67.4583
R6394 VSS.t250 VSS.n2829 67.2065
R6395 VSS.t2237 VSS.n2896 66.9109
R6396 VSS.n800 VSS.t2205 66.8901
R6397 VSS.t1322 VSS.n640 66.8901
R6398 VSS.t2208 VSS.n795 66.8901
R6399 VSS.t668 VSS.n645 66.8901
R6400 VSS.n790 VSS.t1243 66.8901
R6401 VSS.t460 VSS.n650 66.8901
R6402 VSS.n785 VSS.t1238 66.8901
R6403 VSS.t458 VSS.n655 66.8901
R6404 VSS.n780 VSS.t1928 66.8901
R6405 VSS.t1901 VSS.n660 66.8901
R6406 VSS.n775 VSS.t1700 66.8901
R6407 VSS.t1898 VSS.n665 66.8901
R6408 VSS.t1801 VSS.n770 66.8901
R6409 VSS.t1324 VSS.n670 66.8901
R6410 VSS.n765 VSS.t1694 66.8901
R6411 VSS.t1326 VSS.n675 66.8901
R6412 VSS.n760 VSS.t1674 66.8901
R6413 VSS.t2149 VSS.n680 66.8901
R6414 VSS.n755 VSS.t1932 66.8901
R6415 VSS.t308 VSS.n685 66.8901
R6416 VSS.n750 VSS.t1960 66.8901
R6417 VSS.t1739 VSS.n690 66.8901
R6418 VSS.t1967 VSS.n745 66.8901
R6419 VSS.t531 VSS.n695 66.8901
R6420 VSS.n740 VSS.t1962 66.8901
R6421 VSS.t1401 VSS.n700 66.8901
R6422 VSS.n735 VSS.t1964 66.8901
R6423 VSS.t670 VSS.n705 66.8901
R6424 VSS.t1978 VSS.n730 66.8901
R6425 VSS.t2148 VSS.n710 66.8901
R6426 VSS.n725 VSS.t1883 66.8901
R6427 VSS.t1230 VSS.n715 66.8901
R6428 VSS.n930 VSS.t1746 66.8901
R6429 VSS.n1104 VSS.t680 66.8901
R6430 VSS.n937 VSS.t803 66.8901
R6431 VSS.n1100 VSS.t1216 66.8901
R6432 VSS.n944 VSS.t1441 66.8901
R6433 VSS.n1096 VSS.t1232 66.8901
R6434 VSS.n951 VSS.t1794 66.8901
R6435 VSS.n1092 VSS.t511 66.8901
R6436 VSS.n958 VSS.t2257 66.8901
R6437 VSS.n1088 VSS.t1484 66.8901
R6438 VSS.t608 VSS.n965 66.8901
R6439 VSS.n1084 VSS.t2308 66.8901
R6440 VSS.n972 VSS.t439 66.8901
R6441 VSS.n1080 VSS.t1431 66.8901
R6442 VSS.n979 VSS.t674 66.8901
R6443 VSS.n1076 VSS.t28 66.8901
R6444 VSS.t690 VSS.n986 66.8901
R6445 VSS.n1072 VSS.t51 66.8901
R6446 VSS.n993 VSS.t2245 66.8901
R6447 VSS.n1068 VSS.t234 66.8901
R6448 VSS.n1000 VSS.t1172 66.8901
R6449 VSS.n1064 VSS.t2136 66.8901
R6450 VSS.t2118 VSS.n1007 66.8901
R6451 VSS.n1060 VSS.t1702 66.8901
R6452 VSS.n1014 VSS.t45 66.8901
R6453 VSS.n1056 VSS.t654 66.8901
R6454 VSS.n1021 VSS.t85 66.8901
R6455 VSS.n1052 VSS.t2134 66.8901
R6456 VSS.t1456 VSS.n1028 66.8901
R6457 VSS.n1048 VSS.t1212 66.8901
R6458 VSS.n1035 VSS.t2173 66.8901
R6459 VSS.n1044 VSS.t793 66.8901
R6460 VSS.n1203 VSS.t2313 66.8901
R6461 VSS.t1123 VSS.n1204 66.8901
R6462 VSS.n1219 VSS.t224 66.8901
R6463 VSS.t26 VSS.n1220 66.8901
R6464 VSS.n1235 VSS.t2251 66.8901
R6465 VSS.t310 VSS.n1236 66.8901
R6466 VSS.n1251 VSS.t287 66.8901
R6467 VSS.t285 VSS.n1252 66.8901
R6468 VSS.n1266 VSS.t2166 66.8901
R6469 VSS.t533 VSS.n1267 66.8901
R6470 VSS.n1282 VSS.t2184 66.8901
R6471 VSS.t359 VSS.n1283 66.8901
R6472 VSS.n1298 VSS.t1417 66.8901
R6473 VSS.t1716 VSS.n1299 66.8901
R6474 VSS.n1313 VSS.t2242 66.8901
R6475 VSS.t1473 VSS.n1314 66.8901
R6476 VSS.n1329 VSS.t2262 66.8901
R6477 VSS.t535 VSS.n1330 66.8901
R6478 VSS.n1345 VSS.t2271 66.8901
R6479 VSS.t2221 VSS.n1346 66.8901
R6480 VSS.n1360 VSS.t2248 66.8901
R6481 VSS.t281 VSS.n1361 66.8901
R6482 VSS.n1376 VSS.t1681 66.8901
R6483 VSS.t465 VSS.n1377 66.8901
R6484 VSS.n1392 VSS.t410 66.8901
R6485 VSS.t2127 VSS.n1393 66.8901
R6486 VSS.n1407 VSS.t210 66.8901
R6487 VSS.t677 VSS.n1408 66.8901
R6488 VSS.n1423 VSS.t1209 66.8901
R6489 VSS.t1177 VSS.n1424 66.8901
R6490 VSS.n1439 VSS.t2164 66.8901
R6491 VSS.t520 VSS.n1440 66.8901
R6492 VSS.n2182 VSS.t1982 66.8901
R6493 VSS.n2356 VSS.t1912 66.8901
R6494 VSS.n2189 VSS.t1987 66.8901
R6495 VSS.n2352 VSS.t1501 66.8901
R6496 VSS.n2196 VSS.t1973 66.8901
R6497 VSS.n2348 VSS.t1255 66.8901
R6498 VSS.n2203 VSS.t2035 66.8901
R6499 VSS.n2344 VSS.t1403 66.8901
R6500 VSS.n2210 VSS.t2051 66.8901
R6501 VSS.n2340 VSS.t1823 66.8901
R6502 VSS.n2217 VSS.t1994 66.8901
R6503 VSS.n2336 VSS.t1919 66.8901
R6504 VSS.n2224 VSS.t2037 66.8901
R6505 VSS.n2332 VSS.t1916 66.8901
R6506 VSS.n2231 VSS.t2072 66.8901
R6507 VSS.n2328 VSS.t2290 66.8901
R6508 VSS.n2238 VSS.t2301 66.8901
R6509 VSS.n2324 VSS.t1362 66.8901
R6510 VSS.n2245 VSS.t2048 66.8901
R6511 VSS.n2320 VSS.t1509 66.8901
R6512 VSS.n2252 VSS.t2087 66.8901
R6513 VSS.n2316 VSS.t1328 66.8901
R6514 VSS.n2259 VSS.t1864 66.8901
R6515 VSS.n2312 VSS.t1336 66.8901
R6516 VSS.n2266 VSS.t1815 66.8901
R6517 VSS.n2308 VSS.t1334 66.8901
R6518 VSS.n2273 VSS.t1871 66.8901
R6519 VSS.n2304 VSS.t1364 66.8901
R6520 VSS.n2280 VSS.t1241 66.8901
R6521 VSS.n2300 VSS.t672 66.8901
R6522 VSS.n2287 VSS.t385 66.8901
R6523 VSS.n2296 VSS.t1825 66.8901
R6524 VSS.n2455 VSS.t2198 66.8901
R6525 VSS.t1664 VSS.n2456 66.8901
R6526 VSS.n2471 VSS.t1689 66.8901
R6527 VSS.t253 VSS.n2472 66.8901
R6528 VSS.n2487 VSS.t2140 66.8901
R6529 VSS.t1155 VSS.n2488 66.8901
R6530 VSS.n2503 VSS.t299 66.8901
R6531 VSS.t1780 VSS.n2504 66.8901
R6532 VSS.n2519 VSS.t2200 66.8901
R6533 VSS.t1714 VSS.n2520 66.8901
R6534 VSS.n2535 VSS.t412 66.8901
R6535 VSS.t1692 VSS.n2536 66.8901
R6536 VSS.n2551 VSS.t306 66.8901
R6537 VSS.t1975 VSS.n2552 66.8901
R6538 VSS.n2567 VSS.t61 66.8901
R6539 VSS.t1857 VSS.n2568 66.8901
R6540 VSS.n2583 VSS.t1281 66.8901
R6541 VSS.t1854 VSS.n2584 66.8901
R6542 VSS.n2599 VSS.t1750 66.8901
R6543 VSS.t1809 VSS.n2600 66.8901
R6544 VSS.n2615 VSS.t1728 66.8901
R6545 VSS.t1807 VSS.n2616 66.8901
R6546 VSS.n2631 VSS.t244 66.8901
R6547 VSS.t1698 VSS.n2632 66.8901
R6548 VSS.n2647 VSS.t1708 66.8901
R6549 VSS.t1684 VSS.n2648 66.8901
R6550 VSS.n2663 VSS.t325 66.8901
R6551 VSS.t1783 VSS.n2664 66.8901
R6552 VSS.n2679 VSS.t1753 66.8901
R6553 VSS.t1759 VSS.n2680 66.8901
R6554 VSS.n2695 VSS.t67 66.8901
R6555 VSS.t1782 VSS.n2696 66.8901
R6556 VSS.n1484 VSS.t355 65.0826
R6557 VSS.n2738 VSS.t1420 65.0826
R6558 VSS.t637 VSS.n256 65.0826
R6559 VSS.n826 VSS.t2009 64.9292
R6560 VSS.t784 VSS.n880 64.9292
R6561 VSS.t190 VSS.n2133 64.9292
R6562 VSS.t940 VSS.n1456 64.5832
R6563 VSS.t951 VSS.n1467 64.5832
R6564 VSS.t962 VSS.n1478 64.5832
R6565 VSS.t973 VSS.n1497 64.5832
R6566 VSS.t984 VSS.n1508 64.5832
R6567 VSS.t995 VSS.n1519 64.5832
R6568 VSS.t822 VSS.n2710 64.5832
R6569 VSS.t832 VSS.n2721 64.5832
R6570 VSS.t842 VSS.n2732 64.5832
R6571 VSS.t852 VSS.n2751 64.5832
R6572 VSS.t862 VSS.n2762 64.5832
R6573 VSS.t872 VSS.n2773 64.5832
R6574 VSS.n1723 VSS.t882 64.5832
R6575 VSS.t1005 VSS.n855 64.5832
R6576 VSS.n3114 VSS.t1015 64.5832
R6577 VSS.n3108 VSS.t1025 64.5832
R6578 VSS.n3102 VSS.t1035 64.5832
R6579 VSS.t1046 VSS.n867 64.5832
R6580 VSS.n3097 VSS.t1055 64.5832
R6581 VSS.n1780 VSS.n1779 64.0227
R6582 VSS.n1763 VSS.n1762 63.9058
R6583 VSS.t1253 VSS.n3073 63.7107
R6584 VSS.n2825 VSS.t1344 63.4728
R6585 VSS.n1898 VSS.n1897 62.9376
R6586 VSS.n1893 VSS.n1892 62.9376
R6587 VSS.n1789 VSS.n1788 62.7912
R6588 VSS.n1788 VSS.t891 62.7912
R6589 VSS.t1260 VSS.n3075 62.4441
R6590 VSS.n2823 VSS.t1229 62.2523
R6591 VSS.n830 VSS.t1159 61.9779
R6592 VSS.n1136 VSS.t57 61.9779
R6593 VSS.n2393 VSS.t390 61.9779
R6594 VSS.t2013 VSS.n492 61.8407
R6595 VSS.n1617 VSS.n1616 59.3547
R6596 VSS.t7 VSS.n1686 59.3028
R6597 VSS.t1164 VSS.t884 59.3028
R6598 VSS.n1746 VSS.t2254 59.3028
R6599 VSS.t1143 VSS.n820 59.0266
R6600 VSS.t1214 VSS.n875 59.0266
R6601 VSS.t1908 VSS.n2129 59.0266
R6602 VSS.n3077 VSS.t1174 58.6964
R6603 VSS.t1380 VSS.n2821 58.5186
R6604 VSS.n2938 VSS.t1462 58.1358
R6605 VSS.n1821 VSS.t694 58.1084
R6606 VSS.n5 VSS.t1744 58.0284
R6607 VSS.t649 VSS.n3088 57.6388
R6608 VSS.n1486 VSS.t2307 57.6388
R6609 VSS.t2194 VSS.n2847 57.6388
R6610 VSS.n2740 VSS.t1971 57.6388
R6611 VSS.t33 VSS.n3125 57.6388
R6612 VSS.n250 VSS.t1153 57.6388
R6613 VSS.n812 VSS.t2008 57.5509
R6614 VSS.n1129 VSS.t783 57.5509
R6615 VSS.t188 VSS.n2385 57.5509
R6616 VSS.t2407 VSS.n539 56.6734
R6617 VSS.n510 VSS.t1066 56.0825
R6618 VSS.n523 VSS.t1076 56.0825
R6619 VSS.n545 VSS.t1086 56.0825
R6620 VSS.n563 VSS.t1096 56.0825
R6621 VSS.n581 VSS.t1106 56.0825
R6622 VSS.n595 VSS.t1116 56.0825
R6623 VSS.n2920 VSS.t1459 55.942
R6624 VSS.n1553 VSS.t122 55.8966
R6625 VSS.t192 VSS.t809 55.8145
R6626 VSS.t515 VSS.t274 55.8145
R6627 VSS.t2123 VSS.n1535 54.6841
R6628 VSS.t2008 VSS.n811 54.5996
R6629 VSS.n3093 VSS.t783 54.5996
R6630 VSS.n2387 VSS.t188 54.5996
R6631 VSS.n2833 VSS.t91 54.532
R6632 VSS.n2999 VSS.t2348 53.7482
R6633 VSS.n3064 VSS.t120 53.4884
R6634 VSS.n821 VSS.t1143 53.124
R6635 VSS.n1115 VSS.t1214 53.124
R6636 VSS.n2369 VSS.t1908 53.124
R6637 VSS.n1820 VSS.t132 52.3478
R6638 VSS.n1770 VSS.t1706 52.3261
R6639 VSS.t123 VSS.n1541 51.4837
R6640 VSS.n1887 VSS.n1886 51.0224
R6641 VSS.n2862 VSS.n1623 51.0224
R6642 VSS.n1882 VSS.n1881 50.7482
R6643 VSS.n1880 VSS.n1879 50.7482
R6644 VSS.n1878 VSS.n1877 50.7482
R6645 VSS.n1876 VSS.n1875 50.7482
R6646 VSS.n1874 VSS.n1873 50.7482
R6647 VSS.n1872 VSS.n1871 50.7482
R6648 VSS.n1870 VSS.n1869 50.7482
R6649 VSS.n1866 VSS.n1865 50.7482
R6650 VSS.n1860 VSS.n1859 50.7482
R6651 VSS.n1858 VSS.n1857 50.7482
R6652 VSS.n1856 VSS.n1855 50.7482
R6653 VSS.n1854 VSS.n1853 50.7482
R6654 VSS.n1852 VSS.n1851 50.7482
R6655 VSS.n1850 VSS.n1849 50.7482
R6656 VSS.n1848 VSS.n1847 50.7482
R6657 VSS.n1846 VSS.n1845 50.7482
R6658 VSS.n1844 VSS.n1843 50.7482
R6659 VSS.n1840 VSS.n1839 50.7482
R6660 VSS.n1838 VSS.n1837 50.7482
R6661 VSS.n1834 VSS.n1833 50.7482
R6662 VSS.n1832 VSS.n1831 50.7482
R6663 VSS.n1830 VSS.n1829 50.7482
R6664 VSS.n1828 VSS.n1827 50.7482
R6665 VSS.n1826 VSS.n1825 50.7482
R6666 VSS.n1822 VSS.n1682 50.7482
R6667 VSS.n1913 VSS.n1681 50.7482
R6668 VSS.n1918 VSS.n1917 50.7482
R6669 VSS.n1916 VSS.n1680 50.7482
R6670 VSS.n1919 VSS.n1677 50.7482
R6671 VSS.n1925 VSS.n1924 50.7482
R6672 VSS.n1923 VSS.n1676 50.7482
R6673 VSS.n1928 VSS.n1927 50.7482
R6674 VSS.n1931 VSS.n1930 50.7482
R6675 VSS.n1929 VSS.n1674 50.7482
R6676 VSS.n1934 VSS.n1933 50.7482
R6677 VSS.n1937 VSS.n1936 50.7482
R6678 VSS.n1935 VSS.n1672 50.7482
R6679 VSS.n1983 VSS.n1982 50.7482
R6680 VSS.n1979 VSS.n1978 50.7482
R6681 VSS.t911 VSS.n1977 50.7482
R6682 VSS.n1976 VSS.n1975 50.7482
R6683 VSS.n1974 VSS.n1973 50.7482
R6684 VSS.n1970 VSS.n1969 50.7482
R6685 VSS.n1968 VSS.n1967 50.7482
R6686 VSS.n1966 VSS.n1965 50.7482
R6687 VSS.n1964 VSS.n1963 50.7482
R6688 VSS.n1962 VSS.n1961 50.7482
R6689 VSS.n1960 VSS.n1959 50.7482
R6690 VSS.n1956 VSS.n1955 50.7482
R6691 VSS.n1954 VSS.n1953 50.7482
R6692 VSS.n1950 VSS.n1949 50.7482
R6693 VSS.n1948 VSS.n1947 50.7482
R6694 VSS.n1946 VSS.n1945 50.7482
R6695 VSS.n1944 VSS.n1943 50.7482
R6696 VSS.n1940 VSS.n1939 50.7482
R6697 VSS.n1938 VSS.n1668 50.7482
R6698 VSS.n1986 VSS.n1667 50.7482
R6699 VSS.n1991 VSS.n1990 50.7482
R6700 VSS.n1989 VSS.n1666 50.7482
R6701 VSS.n1992 VSS.n1663 50.7482
R6702 VSS.n1998 VSS.n1997 50.7482
R6703 VSS.n1996 VSS.n1662 50.7482
R6704 VSS.n2001 VSS.n2000 50.7482
R6705 VSS.n2004 VSS.n2003 50.7482
R6706 VSS.n2002 VSS.n1660 50.7482
R6707 VSS.n2007 VSS.n2006 50.7482
R6708 VSS.n2010 VSS.n2009 50.7482
R6709 VSS.n2008 VSS.n1658 50.7482
R6710 VSS.n2054 VSS.n2053 50.7482
R6711 VSS.n2052 VSS.n2051 50.7482
R6712 VSS.t920 VSS.n2050 50.7482
R6713 VSS.n2049 VSS.n2048 50.7482
R6714 VSS.n2047 VSS.n2046 50.7482
R6715 VSS.n2043 VSS.n2042 50.7482
R6716 VSS.n2041 VSS.n2040 50.7482
R6717 VSS.n2039 VSS.n2038 50.7482
R6718 VSS.n2037 VSS.n2036 50.7482
R6719 VSS.n2035 VSS.n2034 50.7482
R6720 VSS.n2033 VSS.n2032 50.7482
R6721 VSS.n2029 VSS.n2028 50.7482
R6722 VSS.n2027 VSS.n2026 50.7482
R6723 VSS.n2023 VSS.n2022 50.7482
R6724 VSS.n2021 VSS.n2020 50.7482
R6725 VSS.n2019 VSS.n2018 50.7482
R6726 VSS.n2015 VSS.n2014 50.7482
R6727 VSS.n2013 VSS.n2012 50.7482
R6728 VSS.n2011 VSS.n1654 50.7482
R6729 VSS.n2059 VSS.n1653 50.7482
R6730 VSS.n2064 VSS.n2063 50.7482
R6731 VSS.n2062 VSS.n1652 50.7482
R6732 VSS.n2065 VSS.n1649 50.7482
R6733 VSS.n2071 VSS.n2070 50.7482
R6734 VSS.n2069 VSS.n1648 50.7482
R6735 VSS.n2074 VSS.n2073 50.7482
R6736 VSS.n2077 VSS.n2076 50.7482
R6737 VSS.n2075 VSS.n1646 50.7482
R6738 VSS.n2080 VSS.n2079 50.7482
R6739 VSS.n2083 VSS.n2082 50.7482
R6740 VSS.n2086 VSS.n2085 50.7482
R6741 VSS.n2084 VSS.n1643 50.7482
R6742 VSS.n1642 VSS.n1641 50.7482
R6743 VSS.n2089 VSS.t929 50.7482
R6744 VSS.n2088 VSS.n1640 50.7482
R6745 VSS.n2092 VSS.n2091 50.7482
R6746 VSS.n2095 VSS.n2094 50.7482
R6747 VSS.n2093 VSS.n1638 50.7482
R6748 VSS.n2098 VSS.n2097 50.7482
R6749 VSS.n2096 VSS.n1637 50.7482
R6750 VSS.n2101 VSS.n2100 50.7482
R6751 VSS.n2099 VSS.n1636 50.7482
R6752 VSS.n2102 VSS.n1635 50.7482
R6753 VSS.n2107 VSS.n2106 50.7482
R6754 VSS.n2110 VSS.n2109 50.7482
R6755 VSS.n2113 VSS.n2112 50.7482
R6756 VSS.n2111 VSS.n1629 50.7482
R6757 VSS.n2116 VSS.n2115 50.7482
R6758 VSS.n2114 VSS.n1628 50.7482
R6759 VSS.n2119 VSS.n2118 50.7482
R6760 VSS.n2117 VSS.n1627 50.7482
R6761 VSS.n2122 VSS.n2121 50.7482
R6762 VSS.n2120 VSS.n1626 50.7482
R6763 VSS.n2125 VSS.n2124 50.7482
R6764 VSS.n2123 VSS.n1625 50.7482
R6765 VSS.n2860 VSS.n1624 50.7482
R6766 VSS.t1489 VSS.n479 50.3244
R6767 VSS.n550 VSS.t2086 50.3244
R6768 VSS.t1159 VSS.n829 50.1727
R6769 VSS.t57 VSS.n1114 50.1727
R6770 VSS.t390 VSS.n2367 50.1727
R6771 VSS.n639 VSS.t1412 50.1677
R6772 VSS.t570 VSS.n644 50.1677
R6773 VSS.t1316 VSS.n649 50.1677
R6774 VSS.n654 VSS.t376 50.1677
R6775 VSS.n659 VSS.t145 50.1677
R6776 VSS.n664 VSS.t379 50.1677
R6777 VSS.t151 VSS.n669 50.1677
R6778 VSS.t364 VSS.n674 50.1677
R6779 VSS.n679 VSS.t139 50.1677
R6780 VSS.n684 VSS.t373 50.1677
R6781 VSS.n689 VSS.t142 50.1677
R6782 VSS.t382 VSS.n694 50.1677
R6783 VSS.t154 VSS.n699 50.1677
R6784 VSS.n704 VSS.t367 50.1677
R6785 VSS.t1313 VSS.n709 50.1677
R6786 VSS.t567 VSS.n714 50.1677
R6787 VSS.n1105 VSS.t1836 50.1677
R6788 VSS.n1101 VSS.t1390 50.1677
R6789 VSS.n1097 VSS.t1850 50.1677
R6790 VSS.n1093 VSS.t1351 50.1677
R6791 VSS.n1089 VSS.t1842 50.1677
R6792 VSS.n1085 VSS.t1353 50.1677
R6793 VSS.n1081 VSS.t1832 50.1677
R6794 VSS.n1077 VSS.t1654 50.1677
R6795 VSS.n1073 VSS.t1838 50.1677
R6796 VSS.n1069 VSS.t1348 50.1677
R6797 VSS.n1065 VSS.t1840 50.1677
R6798 VSS.n1061 VSS.t1356 50.1677
R6799 VSS.n1057 VSS.t1834 50.1677
R6800 VSS.n1053 VSS.t1656 50.1677
R6801 VSS.n1049 VSS.t1852 50.1677
R6802 VSS.n1045 VSS.t1392 50.1677
R6803 VSS.t733 VSS.n1197 50.1677
R6804 VSS.t1658 VSS.n1213 50.1677
R6805 VSS.t109 VSS.n1229 50.1677
R6806 VSS.t1307 VSS.n1245 50.1677
R6807 VSS.t739 VSS.n1261 50.1677
R6808 VSS.t1309 VSS.n1276 50.1677
R6809 VSS.t2213 VSS.n1292 50.1677
R6810 VSS.t1330 VSS.n1308 50.1677
R6811 VSS.t735 VSS.n1323 50.1677
R6812 VSS.t1305 VSS.n1339 50.1677
R6813 VSS.t737 VSS.n1355 50.1677
R6814 VSS.t1311 VSS.n1370 50.1677
R6815 VSS.t2215 VSS.n1386 50.1677
R6816 VSS.t1332 VSS.n1402 50.1677
R6817 VSS.t106 VSS.n1417 50.1677
R6818 VSS.t725 VSS.n1433 50.1677
R6819 VSS.n2357 VSS.t1557 50.1677
R6820 VSS.n2353 VSS.t100 50.1677
R6821 VSS.n2349 VSS.t2154 50.1677
R6822 VSS.n2345 VSS.t1590 50.1677
R6823 VSS.n2341 VSS.t1565 50.1677
R6824 VSS.n2337 VSS.t236 50.1677
R6825 VSS.n2333 VSS.t1265 50.1677
R6826 VSS.n2329 VSS.t1826 50.1677
R6827 VSS.n2325 VSS.t1560 50.1677
R6828 VSS.n2321 VSS.t1587 50.1677
R6829 VSS.n2317 VSS.t1562 50.1677
R6830 VSS.n2313 VSS.t239 50.1677
R6831 VSS.n2309 VSS.t1268 50.1677
R6832 VSS.n2305 VSS.t1828 50.1677
R6833 VSS.n2301 VSS.t2152 50.1677
R6834 VSS.n2297 VSS.t103 50.1677
R6835 VSS.t592 VSS.n2448 50.1677
R6836 VSS.t2062 VSS.n2465 50.1677
R6837 VSS.t2111 VSS.n2481 50.1677
R6838 VSS.t1574 VSS.n2497 50.1677
R6839 VSS.t1478 VSS.n2513 50.1677
R6840 VSS.t1576 VSS.n2529 50.1677
R6841 VSS.t1633 VSS.n2545 50.1677
R6842 VSS.t2150 VSS.n2561 50.1677
R6843 VSS.t590 VSS.n2577 50.1677
R6844 VSS.t2057 VSS.n2593 50.1677
R6845 VSS.t1481 VSS.n2609 50.1677
R6846 VSS.t1451 VSS.n2625 50.1677
R6847 VSS.t2315 VSS.n2641 50.1677
R6848 VSS.t1581 VSS.n2657 50.1677
R6849 VSS.t697 VSS.n2673 50.1677
R6850 VSS.t2064 VSS.n2689 50.1677
R6851 VSS.t2093 VSS.n1543 50.0128
R6852 VSS.n1884 VSS.t362 50.0128
R6853 VSS.n2108 VSS.t1539 50.0128
R6854 VSS.n1772 VSS.n1771 49.9524
R6855 VSS.n1771 VSS.n1770 49.9524
R6856 VSS.t2351 VSS.n2910 49.3606
R6857 VSS.n1892 VSS.t2130 48.9515
R6858 VSS.t630 VSS.n1776 48.8377
R6859 VSS.n1761 VSS.t636 48.8377
R6860 VSS.t199 VSS.n1758 48.8377
R6861 VSS.n1907 VSS.n1906 48.8377
R6862 VSS.n1749 VSS.n1704 48.8377
R6863 VSS.t2297 VSS.n1545 48.5418
R6864 VSS.t1535 VSS.n2016 47.8063
R6865 VSS.n3072 VSS.t642 47.4535
R6866 VSS.t1756 VSS.n2826 47.3176
R6867 VSS.t2009 VSS.n825 47.2214
R6868 VSS.n1125 VSS.t784 47.2214
R6869 VSS.n2380 VSS.t190 47.2214
R6870 VSS.t2236 VSS.n2924 47.1669
R6871 VSS.n2992 VSS.t2238 47.1669
R6872 VSS.t2106 VSS.n1539 46.7342
R6873 VSS.n1868 VSS.t2234 46.3354
R6874 VSS.n2889 VSS.t10 46.116
R6875 VSS.n1549 VSS.t2092 45.5999
R6876 VSS.n1555 VSS.t2274 45.3973
R6877 VSS.t635 VSS.n1766 45.3493
R6878 VSS.t893 VSS.n1795 45.3493
R6879 VSS.n1745 VSS.t1206 45.3493
R6880 VSS.t1464 VSS.n2902 44.9731
R6881 VSS.n1552 VSS.t2094 44.4294
R6882 VSS.n1926 VSS.t908 44.129
R6883 VSS.n1981 VSS.t1529 44.129
R6884 VSS.n1999 VSS.t917 44.129
R6885 VSS.n2072 VSS.t926 44.129
R6886 VSS.t2365 VSS.n2 43.0642
R6887 VSS.t2358 VSS.n0 43.0619
R6888 VSS.n1551 VSS.t2090 42.658
R6889 VSS.t2066 VSS.n1611 42.3769
R6890 VSS.t2272 VSS.n1546 42.223
R6891 VSS.t509 VSS.n1895 41.9585
R6892 VSS.t629 VSS.n1784 41.9585
R6893 VSS.n3065 VSS.t2303 41.9225
R6894 VSS.n1777 VSS.t630 41.861
R6895 VSS.n1557 VSS.t2075 41.1871
R6896 VSS.t643 VSS.n1863 41.1871
R6897 VSS.t641 VSS.n3066 39.9582
R6898 VSS.n2831 VSS.t1755 39.8503
R6899 VSS.n1921 VSS.t906 38.9806
R6900 VSS.t1531 VSS.n1941 38.9806
R6901 VSS.n1994 VSS.t915 38.9806
R6902 VSS.n2067 VSS.t924 38.9806
R6903 VSS.n2914 VSS.t1464 38.3917
R6904 VSS.n849 VSS.t702 38.3674
R6905 VSS.n1137 VSS.t128 38.3674
R6906 VSS.t1897 VSS.n2136 38.3674
R6907 VSS.t2102 VSS.n1542 38.2452
R6908 VSS.n1547 VSS.t2272 37.7839
R6909 VSS.n3059 VSS.n1560 37.5097
R6910 VSS.t2273 VSS.n1550 37.0746
R6911 VSS.n803 VSS.t1818 36.7898
R6912 VSS.n797 VSS.t540 36.7898
R6913 VSS.t2286 VSS.n792 36.7898
R6914 VSS.n787 VSS.t1198 36.7898
R6915 VSS.n782 VSS.t1704 36.7898
R6916 VSS.n777 VSS.t1671 36.7898
R6917 VSS.n772 VSS.t1667 36.7898
R6918 VSS.t1709 VSS.n767 36.7898
R6919 VSS.n762 VSS.t1720 36.7898
R6920 VSS.n757 VSS.t1718 36.7898
R6921 VSS.n752 VSS.t1679 36.7898
R6922 VSS.n747 VSS.t1862 36.7898
R6923 VSS.t1867 VSS.n742 36.7898
R6924 VSS.n737 VSS.t1904 36.7898
R6925 VSS.n732 VSS.t1907 36.7898
R6926 VSS.n727 VSS.t1911 36.7898
R6927 VSS.t1449 VSS.n925 36.7898
R6928 VSS.n933 VSS.t118 36.7898
R6929 VSS.n940 VSS.t797 36.7898
R6930 VSS.n947 VSS.t1126 36.7898
R6931 VSS.n954 VSS.t318 36.7898
R6932 VSS.n961 VSS.t2265 36.7898
R6933 VSS.n968 VSS.t272 36.7898
R6934 VSS.n975 VSS.t331 36.7898
R6935 VSS.n982 VSS.t433 36.7898
R6936 VSS.n989 VSS.t2310 36.7898
R6937 VSS.n996 VSS.t112 36.7898
R6938 VSS.n1003 VSS.t340 36.7898
R6939 VSS.n1010 VSS.t1181 36.7898
R6940 VSS.n1017 VSS.t2414 36.7898
R6941 VSS.n1024 VSS.t656 36.7898
R6942 VSS.n1031 VSS.t401 36.7898
R6943 VSS.n1196 VSS.t125 36.7898
R6944 VSS.n1212 VSS.t186 36.7898
R6945 VSS.n1228 VSS.t513 36.7898
R6946 VSS.n1244 VSS.t810 36.7898
R6947 VSS.n1260 VSS.t96 36.7898
R6948 VSS.n1275 VSS.t1167 36.7898
R6949 VSS.n1291 VSS.t632 36.7898
R6950 VSS.n1307 VSS.t1247 36.7898
R6951 VSS.n1322 VSS.t320 36.7898
R6952 VSS.n1338 VSS.t1439 36.7898
R6953 VSS.n1354 VSS.t696 36.7898
R6954 VSS.n1369 VSS.t1128 36.7898
R6955 VSS.n1385 VSS.t314 36.7898
R6956 VSS.n1401 VSS.t195 36.7898
R6957 VSS.n1416 VSS.t230 36.7898
R6958 VSS.n1432 VSS.t517 36.7898
R6959 VSS.n2177 VSS.t1914 36.7898
R6960 VSS.n2185 VSS.t1996 36.7898
R6961 VSS.t2005 VSS.n2192 36.7898
R6962 VSS.n2199 VSS.t2017 36.7898
R6963 VSS.n2206 VSS.t2033 36.7898
R6964 VSS.t2026 VSS.n2213 36.7898
R6965 VSS.n2220 VSS.t2055 36.7898
R6966 VSS.n2227 VSS.t2298 36.7898
R6967 VSS.t2070 VSS.n2234 36.7898
R6968 VSS.n2241 VSS.t2068 36.7898
R6969 VSS.n2248 VSS.t2095 36.7898
R6970 VSS.t2099 VSS.n2255 36.7898
R6971 VSS.n2262 VSS.t1860 36.7898
R6972 VSS.n2269 VSS.t1321 36.7898
R6973 VSS.n2276 VSS.t1246 36.7898
R6974 VSS.n2283 VSS.t1891 36.7898
R6975 VSS.n2447 VSS.t1669 36.7898
R6976 VSS.n2464 VSS.t1271 36.7898
R6977 VSS.n2480 VSS.t1738 36.7898
R6978 VSS.n2496 VSS.t1134 36.7898
R6979 VSS.n2512 VSS.t1276 36.7898
R6980 VSS.n2528 VSS.t1225 36.7898
R6981 VSS.n2544 VSS.t1369 36.7898
R6982 VSS.n2560 VSS.t1372 36.7898
R6983 VSS.n2576 VSS.t482 36.7898
R6984 VSS.n2592 VSS.t492 36.7898
R6985 VSS.n2608 VSS.t453 36.7898
R6986 VSS.n2624 VSS.t1375 36.7898
R6987 VSS.n2640 VSS.t1139 36.7898
R6988 VSS.n2656 VSS.t2203 36.7898
R6989 VSS.n2672 VSS.t1227 36.7898
R6990 VSS.n2688 VSS.t1293 36.7898
R6991 VSS.t2304 VSS.n1542 36.7742
R6992 VSS.n1559 VSS.t2106 36.4698
R6993 VSS.n3066 VSS.t1259 36.2105
R6994 VSS.n2928 VSS.t2236 36.1979
R6995 VSS.t2238 VSS.n2898 36.1979
R6996 VSS.t1228 VSS.n2831 36.1166
R6997 VSS.n1779 VSS.n1778 36.0019
R6998 VSS.n1764 VSS.n1763 35.9989
R6999 VSS.n1804 VSS.n1802 35.9989
R7000 VSS.t2076 VSS.n1539 35.7039
R7001 VSS.n834 VSS.t493 35.4161
R7002 VSS.n1138 VSS.t678 35.4161
R7003 VSS.n2395 VSS.t258 35.4161
R7004 VSS.t2228 VSS.n1841 35.3033
R7005 VSS.n1972 VSS.t912 35.3033
R7006 VSS.t587 VSS.n1957 35.3033
R7007 VSS.t1533 VSS.n2055 35.3033
R7008 VSS.n2045 VSS.t921 35.3033
R7009 VSS.t429 VSS.n2030 35.3033
R7010 VSS.n2090 VSS.t930 35.3033
R7011 VSS.n2104 VSS.t1503 35.3033
R7012 VSS.n46 VSS.n1559 35.2066
R7013 VSS.n1785 VSS.t629 34.9655
R7014 VSS.t802 VSS.n1801 34.8842
R7015 VSS.n1806 VSS.n1688 34.8842
R7016 VSS.n1810 VSS.n1809 34.8842
R7017 VSS.n1737 VSS.n1709 34.8842
R7018 VSS.n1741 VSS.n1740 34.8842
R7019 VSS.n3069 VSS.t233 34.07
R7020 VSS.n2977 VSS.t2351 34.0042
R7021 VSS.t252 VSS.n2828 33.9948
R7022 VSS.t198 VSS.n2883 33.9067
R7023 VSS.n1557 VSS.t2076 33.8323
R7024 VSS.n1551 VSS.t2273 32.3614
R7025 VSS.t903 VSS.n1914 32.3614
R7026 VSS.t913 VSS.n1987 32.3614
R7027 VSS.t922 VSS.n2060 32.3614
R7028 VSS.t898 VSS.n1689 31.3958
R7029 VSS.n1811 VSS.t7 31.3958
R7030 VSS.n1908 VSS.t192 31.3958
R7031 VSS.t888 VSS.n1704 31.3958
R7032 VSS.n1748 VSS.t1208 31.3958
R7033 VSS.n1752 VSS.t515 31.3958
R7034 VSS.t788 VSS.n1612 31.1596
R7035 VSS.t30 VSS.n815 30.9892
R7036 VSS.n1131 VSS.t646 30.9892
R7037 VSS.n2389 VSS.t2192 30.9892
R7038 VSS.t2229 VSS.n1835 30.8904
R7039 VSS.t588 VSS.n1951 30.8904
R7040 VSS.t430 VSS.n2024 30.8904
R7041 VSS.t1504 VSS.n1631 30.8904
R7042 VSS.t1527 VSS.n1823 30.1549
R7043 VSS.n1549 VSS.t2296 29.4195
R7044 VSS.n1802 VSS.t802 29.0221
R7045 VSS.n1546 VSS.t120 28.9844
R7046 VSS.t1252 VSS.n3072 28.7152
R7047 VSS.n1862 VSS.t644 28.684
R7048 VSS.n2826 VSS.t1343 28.6493
R7049 VSS.n3065 VSS.n1537 28.3058
R7050 VSS.n1201 VSS.t2312 28.2943
R7051 VSS.n1233 VSS.t2250 28.2943
R7052 VSS.n1249 VSS.t288 28.2943
R7053 VSS.n1280 VSS.t2185 28.2943
R7054 VSS.n1296 VSS.t1415 28.2943
R7055 VSS.n1327 VSS.t2261 28.2943
R7056 VSS.n1343 VSS.t2270 28.2943
R7057 VSS.n1374 VSS.t1682 28.2943
R7058 VSS.n1390 VSS.t409 28.2943
R7059 VSS.n1421 VSS.t1210 28.2943
R7060 VSS.n1437 VSS.t2165 28.2943
R7061 VSS.n1217 VSS.t225 28.2941
R7062 VSS.t2167 VSS.n1155 28.2941
R7063 VSS.t2241 VSS.n1162 28.2941
R7064 VSS.t2249 VSS.n1169 28.2941
R7065 VSS.t212 VSS.n1176 28.2941
R7066 VSS.t2206 VSS.n410 28.2938
R7067 VSS.t2207 VSS.n414 28.2938
R7068 VSS.t1244 VSS.n406 28.2938
R7069 VSS.t1699 VSS.n424 28.2938
R7070 VSS.t1802 VSS.n428 28.2938
R7071 VSS.t1695 VSS.n400 28.2938
R7072 VSS.t1961 VSS.n438 28.2938
R7073 VSS.t1968 VSS.n442 28.2938
R7074 VSS.t1963 VSS.n394 28.2938
R7075 VSS.t1239 VSS.n404 28.2938
R7076 VSS.t1673 VSS.n398 28.2938
R7077 VSS.t1965 VSS.n392 28.2938
R7078 VSS.t1977 VSS.n449 28.2938
R7079 VSS.t1882 VSS.n388 28.2938
R7080 VSS.n372 VSS.t805 28.2938
R7081 VSS.n369 VSS.t1442 28.2938
R7082 VSS.n365 VSS.t2256 28.2938
R7083 VSS.n362 VSS.t607 28.2938
R7084 VSS.n357 VSS.t675 28.2938
R7085 VSS.n354 VSS.t691 28.2938
R7086 VSS.n349 VSS.t1171 28.2938
R7087 VSS.n346 VSS.t2119 28.2938
R7088 VSS.n341 VSS.t87 28.2938
R7089 VSS.n338 VSS.t1457 28.2938
R7090 VSS.n373 VSS.t1745 28.2938
R7091 VSS.n366 VSS.t1795 28.2938
R7092 VSS.n358 VSS.t437 28.2938
R7093 VSS.n350 VSS.t2246 28.2938
R7094 VSS.n342 VSS.t47 28.2938
R7095 VSS.t2174 VSS.n295 28.2938
R7096 VSS.n179 VSS.t1988 28.2938
R7097 VSS.n175 VSS.t1974 28.2938
R7098 VSS.n171 VSS.t2052 28.2938
R7099 VSS.n167 VSS.t1995 28.2938
R7100 VSS.n163 VSS.t2074 28.2938
R7101 VSS.n156 VSS.t2088 28.2938
R7102 VSS.n151 VSS.t1816 28.2938
R7103 VSS.n148 VSS.t1872 28.2938
R7104 VSS.n144 VSS.t387 28.2938
R7105 VSS.n159 VSS.t2302 28.2938
R7106 VSS.n152 VSS.t1865 28.2938
R7107 VSS.n145 VSS.t1242 28.2938
R7108 VSS.t1927 VSS.n466 28.2936
R7109 VSS.t1933 VSS.n461 28.2936
R7110 VSS.n127 VSS.t1983 28.2936
R7111 VSS.n130 VSS.t2036 28.2936
R7112 VSS.n132 VSS.t2038 28.2936
R7113 VSS.n135 VSS.t2049 28.2936
R7114 VSS.n2453 VSS.t2197 28.2928
R7115 VSS.n2469 VSS.t1690 28.2928
R7116 VSS.n2485 VSS.t2141 28.2928
R7117 VSS.n2501 VSS.t301 28.2928
R7118 VSS.n2517 VSS.t2199 28.2928
R7119 VSS.n2533 VSS.t414 28.2928
R7120 VSS.n2549 VSS.t304 28.2928
R7121 VSS.n2565 VSS.t63 28.2928
R7122 VSS.n2581 VSS.t1279 28.2928
R7123 VSS.n2597 VSS.t1749 28.2928
R7124 VSS.n2613 VSS.t1727 28.2928
R7125 VSS.n2629 VSS.t242 28.2928
R7126 VSS.n2645 VSS.t1707 28.2928
R7127 VSS.n2661 VSS.t323 28.2928
R7128 VSS.n2677 VSS.t1752 28.2928
R7129 VSS.n2693 VSS.t65 28.2928
R7130 VSS.n1554 VSS.t2102 28.2227
R7131 VSS.n408 VSS.t2101 28.0352
R7132 VSS.t1742 VSS.n377 28.0352
R7133 VSS.t2269 VSS.n182 28.0352
R7134 VSS.t94 VSS.n2441 28.035
R7135 VSS.n1186 VSS.t2125 28.035
R7136 VSS.n1736 VSS.t1164 27.9075
R7137 VSS.t683 VSS.n3 27.7523
R7138 VSS.t1459 VSS.n2900 27.4228
R7139 VSS.n481 VSS.t2029 27.2918
R7140 VSS.t910 VSS.n1673 27.2131
R7141 VSS.t919 VSS.n1659 27.2131
R7142 VSS.t928 VSS.n1645 27.2131
R7143 VSS.n827 VSS.t255 26.5622
R7144 VSS.n1124 VSS.t476 26.5622
R7145 VSS.n2379 VSS.t423 26.5622
R7146 VSS.t2296 VSS.n1545 26.4776
R7147 VSS.n2081 VSS.t1537 26.4776
R7148 VSS.n840 VSS.n817 26.0918
R7149 VSS.n3130 VSS.n3129 26.0918
R7150 VSS.n842 VSS.n813 26.0918
R7151 VSS.n841 VSS.n813 26.0918
R7152 VSS.n845 VSS.n824 26.0918
R7153 VSS.n846 VSS.n824 26.0918
R7154 VSS.n847 VSS.n831 26.0918
R7155 VSS.n848 VSS.n831 26.0918
R7156 VSS.n1139 VSS.n885 26.0918
R7157 VSS.n1130 VSS.n1119 26.0918
R7158 VSS.n1130 VSS.n1118 26.0918
R7159 VSS.n1132 VSS.n1117 26.0918
R7160 VSS.n1126 VSS.n878 26.0918
R7161 VSS.n1126 VSS.n879 26.0918
R7162 VSS.n1123 VSS.n882 26.0918
R7163 VSS.n2384 VSS.n2371 26.0918
R7164 VSS.n2388 VSS.n2128 26.0918
R7165 VSS.n2388 VSS.n2373 26.0918
R7166 VSS.n2381 VSS.n2368 26.0918
R7167 VSS.n2381 VSS.n2132 26.0918
R7168 VSS.n2378 VSS.n2366 26.0918
R7169 VSS.n2378 VSS.n2135 26.0918
R7170 VSS.n2396 VSS.n2363 26.0918
R7171 VSS.t2075 VSS.n1556 25.2808
R7172 VSS.t1462 VSS.n2918 25.229
R7173 VSS.t2094 VSS.n1543 25.0066
R7174 VSS.t892 VSS.n1780 24.476
R7175 VSS.t12 VSS.n1616 24.4565
R7176 VSS.n1810 VSS.t342 24.4191
R7177 VSS.n1905 VSS.t901 24.4191
R7178 VSS.t1537 VSS.n1644 24.2712
R7179 VSS.t2090 VSS.n1544 23.8099
R7180 VSS.t2274 VSS.n1541 23.5357
R7181 VSS.n1932 VSS.t910 23.5357
R7182 VSS.n2005 VSS.t919 23.5357
R7183 VSS.n2078 VSS.t928 23.5357
R7184 VSS.n1485 VSS.t356 23.4335
R7185 VSS.n2739 VSS.t1421 23.4335
R7186 VSS.n251 VSS.t638 23.4335
R7187 VSS.t35 VSS.n1482 23.4315
R7188 VSS.t1990 VSS.n2736 23.4315
R7189 VSS.t2284 VSS.n252 23.4315
R7190 VSS.n46 VSS.n1560 22.4774
R7191 VSS.n2890 VSS.t283 22.3643
R7192 VSS.n549 VSS.t2408 22.1486
R7193 VSS.t2305 VSS.n547 22.1466
R7194 VSS.t644 VSS.n1861 22.0647
R7195 VSS.n1756 VSS.n1755 22.0454
R7196 VSS.n1695 VSS.n1694 22.0454
R7197 VSS.n1751 VSS.n1702 22.0454
R7198 VSS.n1189 VSS.t2373 21.6054
R7199 VSS.n376 VSS.t2384 21.6048
R7200 VSS.n181 VSS.t2337 21.6048
R7201 VSS.t2397 VSS.n470 21.6046
R7202 VSS.n2444 VSS.t2326 21.6039
R7203 VSS.t2188 VSS.n1613 21.1887
R7204 VSS.n1909 VSS.n1908 20.9307
R7205 VSS.n1735 VSS.n1711 20.9307
R7206 VSS.n1738 VSS.t692 20.9307
R7207 VSS.n1747 VSS.n1746 20.9307
R7208 VSS.n1550 VSS.t2297 20.8942
R7209 VSS.t2092 VSS.n1548 20.868
R7210 VSS.t257 VSS.n819 20.6596
R7211 VSS.n1127 VSS.t478 20.6596
R7212 VSS.n2382 VSS.t422 20.6596
R7213 VSS.t2217 VSS.n1538 20.5938
R7214 VSS.n1824 VSS.t1527 20.5938
R7215 VSS.t539 VSS.n643 20.0674
R7216 VSS.t2287 VSS.n648 20.0674
R7217 VSS.t1199 VSS.n653 20.0674
R7218 VSS.t1705 VSS.n658 20.0674
R7219 VSS.t1672 VSS.n663 20.0674
R7220 VSS.t1666 VSS.n668 20.0674
R7221 VSS.t1710 VSS.n673 20.0674
R7222 VSS.t1721 VSS.n678 20.0674
R7223 VSS.t1719 VSS.n683 20.0674
R7224 VSS.t1680 VSS.n688 20.0674
R7225 VSS.t1863 VSS.n693 20.0674
R7226 VSS.t1866 VSS.n698 20.0674
R7227 VSS.t1905 VSS.n703 20.0674
R7228 VSS.t1906 VSS.n708 20.0674
R7229 VSS.t1910 VSS.n713 20.0674
R7230 VSS.t1984 VSS.n718 20.0674
R7231 VSS.n1102 VSS.t116 20.0674
R7232 VSS.n1098 VSS.t795 20.0674
R7233 VSS.n1094 VSS.t1125 20.0674
R7234 VSS.n1090 VSS.t316 20.0674
R7235 VSS.n1086 VSS.t2266 20.0674
R7236 VSS.n1082 VSS.t270 20.0674
R7237 VSS.n1078 VSS.t329 20.0674
R7238 VSS.n1074 VSS.t435 20.0674
R7239 VSS.n1070 VSS.t2309 20.0674
R7240 VSS.n1066 VSS.t114 20.0674
R7241 VSS.n1062 VSS.t339 20.0674
R7242 VSS.n1058 VSS.t1179 20.0674
R7243 VSS.n1054 VSS.t2415 20.0674
R7244 VSS.n1050 VSS.t658 20.0674
R7245 VSS.n1046 VSS.t400 20.0674
R7246 VSS.n1042 VSS.t349 20.0674
R7247 VSS.n1209 VSS.t184 20.0674
R7248 VSS.n1225 VSS.t514 20.0674
R7249 VSS.n1241 VSS.t811 20.0674
R7250 VSS.n1257 VSS.t98 20.0674
R7251 VSS.n1272 VSS.t1168 20.0674
R7252 VSS.n1288 VSS.t631 20.0674
R7253 VSS.n1304 VSS.t1249 20.0674
R7254 VSS.n1319 VSS.t322 20.0674
R7255 VSS.n1335 VSS.t1440 20.0674
R7256 VSS.n1351 VSS.t695 20.0674
R7257 VSS.n1366 VSS.t1129 20.0674
R7258 VSS.n1382 VSS.t312 20.0674
R7259 VSS.n1398 VSS.t193 20.0674
R7260 VSS.n1413 VSS.t228 20.0674
R7261 VSS.n1429 VSS.t519 20.0674
R7262 VSS.n1444 VSS.t1454 20.0674
R7263 VSS.n2354 VSS.t1997 20.0674
R7264 VSS.n2350 VSS.t2006 20.0674
R7265 VSS.n2346 VSS.t2018 20.0674
R7266 VSS.n2342 VSS.t2034 20.0674
R7267 VSS.n2338 VSS.t2027 20.0674
R7268 VSS.n2334 VSS.t2056 20.0674
R7269 VSS.n2330 VSS.t2299 20.0674
R7270 VSS.n2326 VSS.t2071 20.0674
R7271 VSS.n2322 VSS.t2069 20.0674
R7272 VSS.n2318 VSS.t2096 20.0674
R7273 VSS.n2314 VSS.t2098 20.0674
R7274 VSS.n2310 VSS.t1859 20.0674
R7275 VSS.n2306 VSS.t1319 20.0674
R7276 VSS.n2302 VSS.t1245 20.0674
R7277 VSS.n2298 VSS.t1890 20.0674
R7278 VSS.n2294 VSS.t1894 20.0674
R7279 VSS.n2461 VSS.t1273 20.0674
R7280 VSS.n2477 VSS.t1737 20.0674
R7281 VSS.n2493 VSS.t1133 20.0674
R7282 VSS.n2509 VSS.t1275 20.0674
R7283 VSS.n2525 VSS.t1223 20.0674
R7284 VSS.n2541 VSS.t1370 20.0674
R7285 VSS.n2557 VSS.t1371 20.0674
R7286 VSS.n2573 VSS.t480 20.0674
R7287 VSS.n2589 VSS.t490 20.0674
R7288 VSS.n2605 VSS.t451 20.0674
R7289 VSS.n2621 VSS.t1377 20.0674
R7290 VSS.n2637 VSS.t1137 20.0674
R7291 VSS.n2653 VSS.t2202 20.0674
R7292 VSS.n2669 VSS.t1226 20.0674
R7293 VSS.n2685 VSS.t1294 20.0674
R7294 VSS.n2700 VSS.t1298 20.0674
R7295 VSS.t131 VSS.t132 19.9423
R7296 VSS.n1836 VSS.t2229 19.8583
R7297 VSS.n1952 VSS.t588 19.8583
R7298 VSS.n2025 VSS.t430 19.8583
R7299 VSS.n2105 VSS.t1504 19.8583
R7300 VSS.n1548 VSS.t2303 19.397
R7301 VSS.n1553 VSS.t2304 19.1228
R7302 VSS.n3059 VSS.n1538 18.3874
R7303 VSS.n3062 VSS.n3061 18.3874
R7304 VSS.n1915 VSS.t903 18.3874
R7305 VSS.n1988 VSS.t913 18.3874
R7306 VSS.n2061 VSS.t922 18.3874
R7307 VSS.n3065 VSS.n3064 18.1847
R7308 VSS.n468 VSS.t249 18.0025
R7309 VSS.n467 VSS.t667 18.0025
R7310 VSS.n463 VSS.t1670 18.0025
R7311 VSS.n462 VSS.t1717 18.0025
R7312 VSS.n458 VSS.t1899 18.0025
R7313 VSS.n457 VSS.t1856 18.0025
R7314 VSS.n455 VSS.t1921 18.0025
R7315 VSS.t2291 VSS.n322 18.0025
R7316 VSS.t799 VSS.n324 18.0025
R7317 VSS.t1169 VSS.n326 18.0025
R7318 VSS.t786 VSS.n328 18.0025
R7319 VSS.t1733 VSS.n331 18.0025
R7320 VSS.t2007 VSS.n129 18.0025
R7321 VSS.t1998 VSS.n131 18.0025
R7322 VSS.t2292 VSS.n133 18.0025
R7323 VSS.t2081 VSS.n136 18.0025
R7324 VSS.t1814 VSS.n138 18.0025
R7325 VSS.t1888 VSS.n139 18.0025
R7326 VSS.t2177 VSS.n409 18.0017
R7327 VSS.n411 VSS.t2285 18.0017
R7328 VSS.n413 VSS.t73 18.0017
R7329 VSS.n417 VSS.t1200 18.0017
R7330 VSS.n419 VSS.t1303 18.0017
R7331 VSS.n420 VSS.t1668 18.0017
R7332 VSS.n421 VSS.t1855 18.0017
R7333 VSS.t1757 VSS.n422 18.0017
R7334 VSS.t1723 VSS.n423 18.0017
R7335 VSS.n425 VSS.t1760 18.0017
R7336 VSS.n427 VSS.t1304 18.0017
R7337 VSS.n431 VSS.t1686 18.0017
R7338 VSS.n433 VSS.t1240 18.0017
R7339 VSS.n434 VSS.t1730 18.0017
R7340 VSS.n435 VSS.t1934 18.0017
R7341 VSS.t1788 VSS.n436 18.0017
R7342 VSS.t1713 VSS.n437 18.0017
R7343 VSS.n439 VSS.t1879 18.0017
R7344 VSS.n441 VSS.t2001 18.0017
R7345 VSS.n445 VSS.t1915 18.0017
R7346 VSS.n447 VSS.t1858 18.0017
R7347 VSS.n448 VSS.t1918 18.0017
R7348 VSS.t1892 VSS.n390 18.0017
R7349 VSS.t1893 VSS.n389 18.0017
R7350 VSS.t1966 VSS.n387 18.0017
R7351 VSS.t1776 VSS.n375 18.0017
R7352 VSS.t392 VSS.n320 18.0017
R7353 VSS.t36 VSS.n319 18.0017
R7354 VSS.t2267 VSS.n317 18.0017
R7355 VSS.t89 VSS.n316 18.0017
R7356 VSS.t645 VSS.n315 18.0017
R7357 VSS.t800 VSS.n314 18.0017
R7358 VSS.t443 VSS.n313 18.0017
R7359 VSS.t393 VSS.n311 18.0017
R7360 VSS.t2233 VSS.n361 18.0017
R7361 VSS.t1202 VSS.n310 18.0017
R7362 VSS.t522 VSS.n309 18.0017
R7363 VSS.t1170 VSS.n308 18.0017
R7364 VSS.t351 VSS.n306 18.0017
R7365 VSS.t2183 VSS.n353 18.0017
R7366 VSS.t227 VSS.n305 18.0017
R7367 VSS.t1447 VSS.n304 18.0017
R7368 VSS.t2107 VSS.n303 18.0017
R7369 VSS.t634 VSS.n301 18.0017
R7370 VSS.t2190 VSS.n345 18.0017
R7371 VSS.t1187 VSS.n300 18.0017
R7372 VSS.t2186 VSS.n299 18.0017
R7373 VSS.t2053 VSS.n298 18.0017
R7374 VSS.t2187 VSS.n297 18.0017
R7375 VSS.t1423 VSS.n337 18.0017
R7376 VSS.t1237 VSS.n296 18.0017
R7377 VSS.t2247 VSS.n294 18.0017
R7378 VSS.t2105 VSS.n126 18.0017
R7379 VSS.t1969 VSS.n124 18.0017
R7380 VSS.t1992 VSS.n123 18.0017
R7381 VSS.t1991 VSS.n177 18.0017
R7382 VSS.t1970 VSS.n122 18.0017
R7383 VSS.t2012 VSS.n121 18.0017
R7384 VSS.t2016 VSS.n119 18.0017
R7385 VSS.t2077 VSS.n118 18.0017
R7386 VSS.t2020 VSS.n169 18.0017
R7387 VSS.t2067 VSS.n117 18.0017
R7388 VSS.t2041 VSS.n116 18.0017
R7389 VSS.t2054 VSS.n114 18.0017
R7390 VSS.t2293 VSS.n113 18.0017
R7391 VSS.t2042 VSS.n161 18.0017
R7392 VSS.t2061 VSS.n112 18.0017
R7393 VSS.t2078 VSS.n111 18.0017
R7394 VSS.t2295 VSS.n109 18.0017
R7395 VSS.t2089 VSS.n108 18.0017
R7396 VSS.t1868 VSS.n154 18.0017
R7397 VSS.t1861 VSS.n107 18.0017
R7398 VSS.t1870 VSS.n106 18.0017
R7399 VSS.t1875 VSS.n104 18.0017
R7400 VSS.t1884 VSS.n103 18.0017
R7401 VSS.t1878 VSS.n102 18.0017
R7402 VSS.t76 VSS.n101 18.0017
R7403 VSS.t1895 VSS.n99 18.0017
R7404 VSS.n2446 VSS.t1218 18.0016
R7405 VSS.n2454 VSS.t296 18.0016
R7406 VSS.n2463 VSS.t1691 18.0016
R7407 VSS.n2470 VSS.t1338 18.0016
R7408 VSS.n2479 VSS.t1366 18.0016
R7409 VSS.n2486 VSS.t1274 18.0016
R7410 VSS.n2495 VSS.t530 18.0016
R7411 VSS.n2502 VSS.t2276 18.0016
R7412 VSS.n2511 VSS.t1222 18.0016
R7413 VSS.n2518 VSS.t1368 18.0016
R7414 VSS.n2527 VSS.t303 18.0016
R7415 VSS.n2534 VSS.t2278 18.0016
R7416 VSS.n2543 VSS.t2143 18.0016
R7417 VSS.n2550 VSS.t1778 18.0016
R7418 VSS.n2559 VSS.t1136 18.0016
R7419 VSS.n2566 VSS.t2201 18.0016
R7420 VSS.n2575 VSS.t479 18.0016
R7421 VSS.n2582 VSS.t450 18.0016
R7422 VSS.n2591 VSS.t1342 18.0016
R7423 VSS.n2598 VSS.t1340 18.0016
R7424 VSS.n2607 VSS.t1496 18.0016
R7425 VSS.n2614 VSS.t1722 18.0016
R7426 VSS.n2623 VSS.t2280 18.0016
R7427 VSS.n2630 VSS.t1287 18.0016
R7428 VSS.n2639 VSS.t1711 18.0016
R7429 VSS.n2646 VSS.t327 18.0016
R7430 VSS.n2655 VSS.t246 18.0016
R7431 VSS.n2662 VSS.t1140 18.0016
R7432 VSS.n2671 VSS.t1297 18.0016
R7433 VSS.n2678 VSS.t1295 18.0016
R7434 VSS.n2687 VSS.t2145 18.0016
R7435 VSS.n2694 VSS.t1299 18.0016
R7436 VSS.n1195 VSS.t2132 18.0016
R7437 VSS.n1202 VSS.t640 18.0016
R7438 VSS.n1211 VSS.t358 18.0016
R7439 VSS.n1218 VSS.t2133 18.0016
R7440 VSS.n1227 VSS.t808 18.0016
R7441 VSS.n1234 VSS.t37 18.0016
R7442 VSS.n1243 VSS.t606 18.0016
R7443 VSS.n1250 VSS.t1425 18.0016
R7444 VSS.n1259 VSS.t2260 18.0016
R7445 VSS.n1265 VSS.t2275 18.0016
R7446 VSS.n1274 VSS.t207 18.0016
R7447 VSS.n1281 VSS.t2243 18.0016
R7448 VSS.n1290 VSS.t269 18.0016
R7449 VSS.n1297 VSS.t54 18.0016
R7450 VSS.n1306 VSS.t1221 18.0016
R7451 VSS.n1312 VSS.t13 18.0016
R7452 VSS.n1321 VSS.t1458 18.0016
R7453 VSS.n1328 VSS.t53 18.0016
R7454 VSS.n1337 VSS.t1217 18.0016
R7455 VSS.n1344 VSS.t693 18.0016
R7456 VSS.n1353 VSS.t58 18.0016
R7457 VSS.n1359 VSS.t787 18.0016
R7458 VSS.n1368 VSS.t2084 18.0016
R7459 VSS.n1375 VSS.t1732 18.0016
R7460 VSS.n1384 VSS.t1430 18.0016
R7461 VSS.n1391 VSS.t201 18.0016
R7462 VSS.n1400 VSS.t432 18.0016
R7463 VSS.n1406 VSS.t2314 18.0016
R7464 VSS.n1415 VSS.t328 18.0016
R7465 VSS.n1422 VSS.t2128 18.0016
R7466 VSS.n1431 VSS.t470 18.0016
R7467 VSS.n1438 VSS.t1446 18.0016
R7468 VSS.t701 VSS.n818 17.7083
R7469 VSS.n1133 VSS.t127 17.7083
R7470 VSS.n2390 VSS.t1896 17.7083
R7471 VSS.t1176 VSS.n3077 17.4722
R7472 VSS.n2821 VSS.t1381 17.4483
R7473 VSS.t1476 VSS.n1706 17.4424
R7474 VSS.n382 VSS.n810 17.0005
R7475 VSS.n382 VSS.n471 17.0005
R7476 VSS.n382 VSS.n811 17.0005
R7477 VSS.n382 VSS.n812 17.0005
R7478 VSS.n382 VSS.n815 17.0005
R7479 VSS.n382 VSS.n816 17.0005
R7480 VSS.n382 VSS.n818 17.0005
R7481 VSS.n382 VSS.n819 17.0005
R7482 VSS.n382 VSS.n820 17.0005
R7483 VSS.n382 VSS.n821 17.0005
R7484 VSS.n382 VSS.n823 17.0005
R7485 VSS.n382 VSS.n825 17.0005
R7486 VSS.n382 VSS.n826 17.0005
R7487 VSS.n382 VSS.n827 17.0005
R7488 VSS.n382 VSS.n828 17.0005
R7489 VSS.n382 VSS.n829 17.0005
R7490 VSS.n382 VSS.n830 17.0005
R7491 VSS.n382 VSS.n833 17.0005
R7492 VSS.n382 VSS.n834 17.0005
R7493 VSS.n382 VSS.n835 17.0005
R7494 VSS.n382 VSS.n836 17.0005
R7495 VSS.n382 VSS.n809 17.0005
R7496 VSS.n382 VSS.t1163 17.0005
R7497 VSS.n3131 VSS.n382 17.0005
R7498 VSS.n382 VSS.n452 17.0005
R7499 VSS.n587 VSS.n585 17.0005
R7500 VSS.n3136 VSS.n586 17.0005
R7501 VSS.n3139 VSS.n3138 17.0005
R7502 VSS.n3140 VSS.n3139 17.0005
R7503 VSS.n578 VSS.n572 17.0005
R7504 VSS.n3145 VSS.n567 17.0005
R7505 VSS.n570 VSS.n566 17.0005
R7506 VSS.n568 VSS.n566 17.0005
R7507 VSS.n556 VSS.n554 17.0005
R7508 VSS.n3151 VSS.n555 17.0005
R7509 VSS.n3154 VSS.n3153 17.0005
R7510 VSS.n3155 VSS.n3154 17.0005
R7511 VSS.n3157 VSS.n551 17.0005
R7512 VSS.n3157 VSS.n548 17.0005
R7513 VSS.n542 VSS.n532 17.0005
R7514 VSS.n3160 VSS.n527 17.0005
R7515 VSS.n530 VSS.n526 17.0005
R7516 VSS.n528 VSS.n526 17.0005
R7517 VSS.n516 VSS.n514 17.0005
R7518 VSS.n3166 VSS.n515 17.0005
R7519 VSS.n3169 VSS.n3168 17.0005
R7520 VSS.n3170 VSS.n3169 17.0005
R7521 VSS.n502 VSS.n500 17.0005
R7522 VSS.n3175 VSS.n501 17.0005
R7523 VSS.n3178 VSS.n3177 17.0005
R7524 VSS.n3179 VSS.n3178 17.0005
R7525 VSS.n3181 VSS.n478 17.0005
R7526 VSS.n3181 VSS.n495 17.0005
R7527 VSS.n3181 VSS.n494 17.0005
R7528 VSS.n3181 VSS.n482 17.0005
R7529 VSS.n3181 VSS.n493 17.0005
R7530 VSS.n3181 VSS.n484 17.0005
R7531 VSS.n3181 VSS.n491 17.0005
R7532 VSS.n3181 VSS.n486 17.0005
R7533 VSS.n382 VSS.n634 17.0005
R7534 VSS.n382 VSS.n637 17.0005
R7535 VSS.n3128 VSS.n837 17.0005
R7536 VSS.n3128 VSS.n833 17.0005
R7537 VSS.n3128 VSS.n849 17.0005
R7538 VSS.n3128 VSS.n829 17.0005
R7539 VSS.n3128 VSS.n826 17.0005
R7540 VSS.n3128 VSS.n821 17.0005
R7541 VSS.n3128 VSS.n820 17.0005
R7542 VSS.n3128 VSS.n839 17.0005
R7543 VSS.n3092 VSS.n3091 17.0005
R7544 VSS.n3092 VSS.n1122 17.0005
R7545 VSS.n3092 VSS.n1138 17.0005
R7546 VSS.n3092 VSS.n1112 17.0005
R7547 VSS.n3092 VSS.n1137 17.0005
R7548 VSS.n3092 VSS.t648 17.0005
R7549 VSS.n3092 VSS.n1136 17.0005
R7550 VSS.n3092 VSS.n1114 17.0005
R7551 VSS.n3092 VSS.n1135 17.0005
R7552 VSS.n3092 VSS.n1124 17.0005
R7553 VSS.n3092 VSS.n880 17.0005
R7554 VSS.n3092 VSS.n1125 17.0005
R7555 VSS.n3092 VSS.n1134 17.0005
R7556 VSS.n3092 VSS.n1115 17.0005
R7557 VSS.n3092 VSS.n875 17.0005
R7558 VSS.n3092 VSS.n1127 17.0005
R7559 VSS.n3092 VSS.n1133 17.0005
R7560 VSS.n3092 VSS.n1128 17.0005
R7561 VSS.n3092 VSS.n1131 17.0005
R7562 VSS.n3092 VSS.n1129 17.0005
R7563 VSS.n3093 VSS.n3092 17.0005
R7564 VSS.n3092 VSS.n1120 17.0005
R7565 VSS.n293 VSS.n1116 17.0005
R7566 VSS.n293 VSS.n875 17.0005
R7567 VSS.n293 VSS.n1115 17.0005
R7568 VSS.n293 VSS.n880 17.0005
R7569 VSS.n293 VSS.n1114 17.0005
R7570 VSS.n293 VSS.n883 17.0005
R7571 VSS.n293 VSS.n1112 17.0005
R7572 VSS.n293 VSS.n884 17.0005
R7573 VSS.n293 VSS.n876 17.0005
R7574 VSS.n293 VSS.t399 17.0005
R7575 VSS.n3095 VSS.n293 17.0005
R7576 VSS.n293 VSS.n334 17.0005
R7577 VSS.n293 VSS.n921 17.0005
R7578 VSS.n293 VSS.n923 17.0005
R7579 VSS.n1515 VSS.n217 17.0005
R7580 VSS.n1513 VSS.n217 17.0005
R7581 VSS.n1504 VSS.n211 17.0005
R7582 VSS.n1502 VSS.n211 17.0005
R7583 VSS.n1493 VSS.n205 17.0005
R7584 VSS.n1491 VSS.n205 17.0005
R7585 VSS.n1487 VSS.n203 17.0005
R7586 VSS.n1483 VSS.n203 17.0005
R7587 VSS.n1474 VSS.n199 17.0005
R7588 VSS.n1472 VSS.n199 17.0005
R7589 VSS.n1463 VSS.n193 17.0005
R7590 VSS.n1461 VSS.n193 17.0005
R7591 VSS.n1452 VSS.n187 17.0005
R7592 VSS.n1450 VSS.n187 17.0005
R7593 VSS.n3092 VSS.n3086 17.0005
R7594 VSS.n3092 VSS.n3089 17.0005
R7595 VSS.n3079 VSS.n1143 17.0005
R7596 VSS.n3079 VSS.t1435 17.0005
R7597 VSS.n3080 VSS.n3079 17.0005
R7598 VSS.n3079 VSS.n1141 17.0005
R7599 VSS.n3079 VSS.n1190 17.0005
R7600 VSS.n3079 VSS.n1185 17.0005
R7601 VSS.n3079 VSS.n1534 17.0005
R7602 VSS.n3079 VSS.n3067 17.0005
R7603 VSS.n3079 VSS.n3068 17.0005
R7604 VSS.n3079 VSS.n3071 17.0005
R7605 VSS.n3079 VSS.n3073 17.0005
R7606 VSS.n3079 VSS.n3076 17.0005
R7607 VSS.n3063 VSS.n3062 17.0005
R7608 VSS.n3063 VSS.n1538 17.0005
R7609 VSS.n3063 VSS.n1560 17.0005
R7610 VSS.n3063 VSS.n1557 17.0005
R7611 VSS.n3063 VSS.n1541 17.0005
R7612 VSS.n3063 VSS.n1542 17.0005
R7613 VSS.n3063 VSS.n1553 17.0005
R7614 VSS.n3063 VSS.n1543 17.0005
R7615 VSS.n3063 VSS.n1551 17.0005
R7616 VSS.n3063 VSS.n1545 17.0005
R7617 VSS.n3063 VSS.n1549 17.0005
R7618 VSS.n3057 VSS.n47 17.0005
R7619 VSS.n52 VSS.n3059 5.66744
R7620 VSS.n3060 VSS.n3058 17.0005
R7621 VSS.n2851 VSS.n2850 17.0005
R7622 VSS.n2851 VSS.n2376 17.0005
R7623 VSS.n2851 VSS.n2395 17.0005
R7624 VSS.n2851 VSS.n2365 17.0005
R7625 VSS.n2851 VSS.n2393 17.0005
R7626 VSS.n2851 VSS.n2367 17.0005
R7627 VSS.n2851 VSS.n2392 17.0005
R7628 VSS.n2851 VSS.n2379 17.0005
R7629 VSS.n2851 VSS.n2133 17.0005
R7630 VSS.n2851 VSS.n2380 17.0005
R7631 VSS.n2851 VSS.n2391 17.0005
R7632 VSS.n2851 VSS.n2369 17.0005
R7633 VSS.n2851 VSS.n2129 17.0005
R7634 VSS.n2851 VSS.n2382 17.0005
R7635 VSS.n2851 VSS.n2390 17.0005
R7636 VSS.n2851 VSS.n2383 17.0005
R7637 VSS.n2851 VSS.n2389 17.0005
R7638 VSS.n2851 VSS.n2385 17.0005
R7639 VSS.n2851 VSS.n2387 17.0005
R7640 VSS.n2851 VSS.n2386 17.0005
R7641 VSS.n98 VSS.n2372 17.0005
R7642 VSS.n98 VSS.n2129 17.0005
R7643 VSS.n98 VSS.n2369 17.0005
R7644 VSS.n98 VSS.n2133 17.0005
R7645 VSS.n98 VSS.n2367 17.0005
R7646 VSS.n98 VSS.n2136 17.0005
R7647 VSS.n98 VSS.n2365 17.0005
R7648 VSS.n98 VSS.n2137 17.0005
R7649 VSS.n98 VSS.n2130 17.0005
R7650 VSS.n98 VSS.t1822 17.0005
R7651 VSS.n2857 VSS.n98 17.0005
R7652 VSS.n98 VSS.n143 17.0005
R7653 VSS.n98 VSS.n2173 17.0005
R7654 VSS.n98 VSS.n2175 17.0005
R7655 VSS.n2769 VSS.n2433 17.0005
R7656 VSS.n2767 VSS.n2433 17.0005
R7657 VSS.n2758 VSS.n2426 17.0005
R7658 VSS.n2756 VSS.n2426 17.0005
R7659 VSS.n2747 VSS.n2419 17.0005
R7660 VSS.n2745 VSS.n2419 17.0005
R7661 VSS.n2741 VSS.n2417 17.0005
R7662 VSS.n2737 VSS.n2417 17.0005
R7663 VSS.n2728 VSS.n2413 17.0005
R7664 VSS.n2726 VSS.n2413 17.0005
R7665 VSS.n2717 VSS.n2406 17.0005
R7666 VSS.n2715 VSS.n2406 17.0005
R7667 VSS.n2706 VSS.n2399 17.0005
R7668 VSS.n2704 VSS.n2399 17.0005
R7669 VSS.n2851 VSS.n2846 17.0005
R7670 VSS.n2851 VSS.n2848 17.0005
R7671 VSS.n2841 VSS.n2840 17.0005
R7672 VSS.n2841 VSS.n2445 17.0005
R7673 VSS.n2841 VSS.n2817 17.0005
R7674 VSS.n2841 VSS.t1678 17.0005
R7675 VSS.n2439 VSS.n2841 17.0005
R7676 VSS.n2841 VSS.n2830 17.0005
R7677 VSS.n2841 VSS.n2829 17.0005
R7678 VSS.n2841 VSS.n2827 17.0005
R7679 VSS.n2841 VSS.n2825 17.0005
R7680 VSS.n2841 VSS.n2822 17.0005
R7681 VSS.n2860 VSS.n2859 17.0005
R7682 VSS.n2859 VSS.n1625 17.0005
R7683 VSS.n2859 VSS.n2125 17.0005
R7684 VSS.n2859 VSS.n1626 17.0005
R7685 VSS.n2859 VSS.n2122 17.0005
R7686 VSS.n2859 VSS.n1627 17.0005
R7687 VSS.n2859 VSS.n2119 17.0005
R7688 VSS.n2859 VSS.n1628 17.0005
R7689 VSS.n2859 VSS.n2116 17.0005
R7690 VSS.n2859 VSS.n1629 17.0005
R7691 VSS.n2859 VSS.n2113 17.0005
R7692 VSS.n2859 VSS.n1630 17.0005
R7693 VSS.n2859 VSS.n2110 17.0005
R7694 VSS.n2859 VSS.n1631 17.0005
R7695 VSS.n2859 VSS.n2107 17.0005
R7696 VSS.n2859 VSS.n1635 17.0005
R7697 VSS.n2859 VSS.n2104 17.0005
R7698 VSS.n2859 VSS.n1636 17.0005
R7699 VSS.n2859 VSS.n2101 17.0005
R7700 VSS.n2859 VSS.n1637 17.0005
R7701 VSS.n2859 VSS.n2098 17.0005
R7702 VSS.n2859 VSS.n1638 17.0005
R7703 VSS.n2859 VSS.n2095 17.0005
R7704 VSS.n2859 VSS.n1639 17.0005
R7705 VSS.n2859 VSS.n2092 17.0005
R7706 VSS.n2859 VSS.n1640 17.0005
R7707 VSS.n2859 VSS.n2089 17.0005
R7708 VSS.n2859 VSS.n1641 17.0005
R7709 VSS.n2859 VSS.n1643 17.0005
R7710 VSS.n2087 VSS.n2086 17.0005
R7711 VSS.n2087 VSS.n1644 17.0005
R7712 VSS.n2087 VSS.n2083 17.0005
R7713 VSS.n2087 VSS.n1645 17.0005
R7714 VSS.n2087 VSS.n2080 17.0005
R7715 VSS.n2087 VSS.n1646 17.0005
R7716 VSS.n2087 VSS.n2077 17.0005
R7717 VSS.n2087 VSS.n1647 17.0005
R7718 VSS.n2087 VSS.n2074 17.0005
R7719 VSS.n2087 VSS.n1648 17.0005
R7720 VSS.n2087 VSS.n2071 17.0005
R7721 VSS.n2087 VSS.n1649 17.0005
R7722 VSS.n2068 VSS.n2067 17.0005
R7723 VSS.n2068 VSS.n1652 17.0005
R7724 VSS.n2068 VSS.n2064 17.0005
R7725 VSS.n2068 VSS.n1653 17.0005
R7726 VSS.n2068 VSS.n2061 17.0005
R7727 VSS.n2068 VSS.n1654 17.0005
R7728 VSS.n2012 VSS.n1655 17.0005
R7729 VSS.n2014 VSS.n1655 17.0005
R7730 VSS.n2016 VSS.n1655 17.0005
R7731 VSS.n2018 VSS.n1655 17.0005
R7732 VSS.n2020 VSS.n1655 17.0005
R7733 VSS.n2022 VSS.n1655 17.0005
R7734 VSS.n2024 VSS.n1655 17.0005
R7735 VSS.n2026 VSS.n1655 17.0005
R7736 VSS.n2028 VSS.n1655 17.0005
R7737 VSS.n2030 VSS.n1655 17.0005
R7738 VSS.n2032 VSS.n1655 17.0005
R7739 VSS.n2034 VSS.n1655 17.0005
R7740 VSS.n2036 VSS.n1655 17.0005
R7741 VSS.n2038 VSS.n1655 17.0005
R7742 VSS.n2040 VSS.n1655 17.0005
R7743 VSS.n2042 VSS.n1655 17.0005
R7744 VSS.n2044 VSS.n1655 17.0005
R7745 VSS.n2046 VSS.n1655 17.0005
R7746 VSS.n2048 VSS.n1655 17.0005
R7747 VSS.n2050 VSS.n1655 17.0005
R7748 VSS.n2051 VSS.n1655 17.0005
R7749 VSS.n2053 VSS.n1655 17.0005
R7750 VSS.n2057 VSS.n2056 17.0005
R7751 VSS.n2057 VSS.n1658 17.0005
R7752 VSS.n2057 VSS.n2010 17.0005
R7753 VSS.n2057 VSS.n1659 17.0005
R7754 VSS.n2057 VSS.n2007 17.0005
R7755 VSS.n2057 VSS.n1660 17.0005
R7756 VSS.n2057 VSS.n2004 17.0005
R7757 VSS.n2057 VSS.n1661 17.0005
R7758 VSS.n2057 VSS.n2001 17.0005
R7759 VSS.n2057 VSS.n1662 17.0005
R7760 VSS.n2057 VSS.n1998 17.0005
R7761 VSS.n2057 VSS.n1663 17.0005
R7762 VSS.n1995 VSS.n1994 17.0005
R7763 VSS.n1995 VSS.n1666 17.0005
R7764 VSS.n1995 VSS.n1991 17.0005
R7765 VSS.n1995 VSS.n1667 17.0005
R7766 VSS.n1995 VSS.n1988 17.0005
R7767 VSS.n1995 VSS.n1668 17.0005
R7768 VSS.n1939 VSS.n1669 17.0005
R7769 VSS.n1941 VSS.n1669 17.0005
R7770 VSS.n1943 VSS.n1669 17.0005
R7771 VSS.n1945 VSS.n1669 17.0005
R7772 VSS.n1947 VSS.n1669 17.0005
R7773 VSS.n1949 VSS.n1669 17.0005
R7774 VSS.n1951 VSS.n1669 17.0005
R7775 VSS.n1953 VSS.n1669 17.0005
R7776 VSS.n1955 VSS.n1669 17.0005
R7777 VSS.n1957 VSS.n1669 17.0005
R7778 VSS.n1959 VSS.n1669 17.0005
R7779 VSS.n1961 VSS.n1669 17.0005
R7780 VSS.n1963 VSS.n1669 17.0005
R7781 VSS.n1965 VSS.n1669 17.0005
R7782 VSS.n1967 VSS.n1669 17.0005
R7783 VSS.n1969 VSS.n1669 17.0005
R7784 VSS.n1971 VSS.n1669 17.0005
R7785 VSS.n1973 VSS.n1669 17.0005
R7786 VSS.n1975 VSS.n1669 17.0005
R7787 VSS.n1977 VSS.n1669 17.0005
R7788 VSS.n1978 VSS.n1669 17.0005
R7789 VSS.n1980 VSS.n1669 17.0005
R7790 VSS.n1984 VSS.n1983 17.0005
R7791 VSS.n1984 VSS.n1672 17.0005
R7792 VSS.n1984 VSS.n1937 17.0005
R7793 VSS.n1984 VSS.n1673 17.0005
R7794 VSS.n1984 VSS.n1934 17.0005
R7795 VSS.n1984 VSS.n1674 17.0005
R7796 VSS.n1984 VSS.n1931 17.0005
R7797 VSS.n1984 VSS.n1675 17.0005
R7798 VSS.n1984 VSS.n1928 17.0005
R7799 VSS.n1984 VSS.n1676 17.0005
R7800 VSS.n1984 VSS.n1925 17.0005
R7801 VSS.n1984 VSS.n1677 17.0005
R7802 VSS.n1922 VSS.n1921 17.0005
R7803 VSS.n1922 VSS.n1680 17.0005
R7804 VSS.n1922 VSS.n1918 17.0005
R7805 VSS.n1922 VSS.n1681 17.0005
R7806 VSS.n1922 VSS.n1915 17.0005
R7807 VSS.n1922 VSS.n1682 17.0005
R7808 VSS.n1823 VSS.n1683 17.0005
R7809 VSS.n1825 VSS.n1683 17.0005
R7810 VSS.n1827 VSS.n1683 17.0005
R7811 VSS.n1829 VSS.n1683 17.0005
R7812 VSS.n1831 VSS.n1683 17.0005
R7813 VSS.n1833 VSS.n1683 17.0005
R7814 VSS.n1835 VSS.n1683 17.0005
R7815 VSS.n1837 VSS.n1683 17.0005
R7816 VSS.n1839 VSS.n1683 17.0005
R7817 VSS.n1841 VSS.n1683 17.0005
R7818 VSS.n1843 VSS.n1683 17.0005
R7819 VSS.n1845 VSS.n1683 17.0005
R7820 VSS.n1847 VSS.n1683 17.0005
R7821 VSS.n1849 VSS.n1683 17.0005
R7822 VSS.n1851 VSS.n1683 17.0005
R7823 VSS.n1853 VSS.n1683 17.0005
R7824 VSS.n1855 VSS.n1683 17.0005
R7825 VSS.n1857 VSS.n1683 17.0005
R7826 VSS.n1859 VSS.n1683 17.0005
R7827 VSS.n1861 VSS.n1683 17.0005
R7828 VSS.n1863 VSS.n1683 17.0005
R7829 VSS.n1865 VSS.n1683 17.0005
R7830 VSS.n1867 VSS.n1683 17.0005
R7831 VSS.n1869 VSS.n1683 17.0005
R7832 VSS.n1871 VSS.n1683 17.0005
R7833 VSS.n1873 VSS.n1683 17.0005
R7834 VSS.n1875 VSS.n1683 17.0005
R7835 VSS.n1877 VSS.n1683 17.0005
R7836 VSS.n1879 VSS.n1683 17.0005
R7837 VSS.n1881 VSS.n1683 17.0005
R7838 VSS.n1883 VSS.n1683 17.0005
R7839 VSS.n1885 VSS.n1683 17.0005
R7840 VSS.n1820 VSS.n1819 17.0005
R7841 VSS.n1891 VSS.n1683 17.0005
R7842 VSS.n1892 VSS.n1683 17.0005
R7843 VSS.n1894 VSS.n1683 17.0005
R7844 VSS.n1896 VSS.n1683 17.0005
R7845 VSS.n1898 VSS.n1683 17.0005
R7846 VSS.n1890 VSS.t510 17.0005
R7847 VSS.n1893 VSS.t510 17.0005
R7848 VSS.n1895 VSS.t510 17.0005
R7849 VSS.n1897 VSS.t510 17.0005
R7850 VSS.n1899 VSS.n1683 17.0005
R7851 VSS.n1901 VSS.n1683 17.0005
R7852 VSS.n1903 VSS.n1683 17.0005
R7853 VSS.n1905 VSS.n1683 17.0005
R7854 VSS.n1907 VSS.n1683 17.0005
R7855 VSS.n1910 VSS.n1909 17.0005
R7856 VSS.n1910 VSS.n1686 17.0005
R7857 VSS.n1910 VSS.n1813 17.0005
R7858 VSS.n1910 VSS.n1687 17.0005
R7859 VSS.n1910 VSS.n1810 17.0005
R7860 VSS.n1910 VSS.n1688 17.0005
R7861 VSS.n1910 VSS.n1808 17.0005
R7862 VSS.n1910 VSS.n1689 17.0005
R7863 VSS.n1910 VSS.n1805 17.0005
R7864 VSS.n1910 VSS.n1690 17.0005
R7865 VSS.n1800 VSS.n1799 17.0005
R7866 VSS.n1800 VSS.n1693 17.0005
R7867 VSS.n1800 VSS.n1796 17.0005
R7868 VSS.n1800 VSS.n1696 17.0005
R7869 VSS.n1757 VSS.n1697 17.0005
R7870 VSS.n1759 VSS.n1697 17.0005
R7871 VSS.n1761 VSS.n1697 17.0005
R7872 VSS.n1765 VSS.n1697 17.0005
R7873 VSS.n1767 VSS.n1697 17.0005
R7874 VSS.n1769 VSS.n1697 17.0005
R7875 VSS.n1773 VSS.n1697 17.0005
R7876 VSS.n1775 VSS.n1697 17.0005
R7877 VSS.n1777 VSS.n1697 17.0005
R7878 VSS.n1900 VSS.t510 17.0005
R7879 VSS.n1902 VSS.t510 17.0005
R7880 VSS.n1904 VSS.t510 17.0005
R7881 VSS.n1906 VSS.t510 17.0005
R7882 VSS.n1908 VSS.t510 17.0005
R7883 VSS.n1811 VSS.t510 17.0005
R7884 VSS.n1812 VSS.t510 17.0005
R7885 VSS.n1809 VSS.t510 17.0005
R7886 VSS.n1806 VSS.t510 17.0005
R7887 VSS.n1807 VSS.t510 17.0005
R7888 VSS.n1803 VSS.t510 17.0005
R7889 VSS.n1804 VSS.t510 17.0005
R7890 VSS.n1801 VSS.t510 17.0005
R7891 VSS.n1797 VSS.t510 17.0005
R7892 VSS.n1798 VSS.t510 17.0005
R7893 VSS.n1694 VSS.t510 17.0005
R7894 VSS.n1794 VSS.t510 17.0005
R7895 VSS.n1795 VSS.t510 17.0005
R7896 VSS.n1754 VSS.t510 17.0005
R7897 VSS.n1756 VSS.t510 17.0005
R7898 VSS.n1758 VSS.t510 17.0005
R7899 VSS.n1760 VSS.t510 17.0005
R7900 VSS.n1762 VSS.t510 17.0005
R7901 VSS.n1764 VSS.t510 17.0005
R7902 VSS.n1766 VSS.t510 17.0005
R7903 VSS.n1768 VSS.t510 17.0005
R7904 VSS.n1770 VSS.t510 17.0005
R7905 VSS.n1772 VSS.t510 17.0005
R7906 VSS.n1774 VSS.t510 17.0005
R7907 VSS.n1776 VSS.t510 17.0005
R7908 VSS.n1778 VSS.t510 17.0005
R7909 VSS.n1781 VSS.n1697 17.0005
R7910 VSS.n1783 VSS.n1697 17.0005
R7911 VSS.n1785 VSS.n1697 17.0005
R7912 VSS.n1787 VSS.n1697 17.0005
R7913 VSS.n1780 VSS.t510 17.0005
R7914 VSS.n1782 VSS.t510 17.0005
R7915 VSS.n1784 VSS.t510 17.0005
R7916 VSS.n1786 VSS.t510 17.0005
R7917 VSS.n1788 VSS.n1697 17.0005
R7918 VSS.n1792 VSS.n1791 17.0005
R7919 VSS.n1792 VSS.n1700 17.0005
R7920 VSS.n1792 VSS.n1753 17.0005
R7921 VSS.n1792 VSS.n1703 17.0005
R7922 VSS.n1792 VSS.n1750 17.0005
R7923 VSS.n1792 VSS.n1704 17.0005
R7924 VSS.n1792 VSS.n1747 17.0005
R7925 VSS.n1792 VSS.n1705 17.0005
R7926 VSS.n1792 VSS.n1745 17.0005
R7927 VSS.n1792 VSS.n1706 17.0005
R7928 VSS.n1742 VSS.n1741 17.0005
R7929 VSS.n1742 VSS.n1709 17.0005
R7930 VSS.n1742 VSS.n1739 17.0005
R7931 VSS.n1742 VSS.n1710 17.0005
R7932 VSS.n1742 VSS.n1736 17.0005
R7933 VSS.n1742 VSS.n1711 17.0005
R7934 VSS.n1715 VSS.n1712 17.0005
R7935 VSS.n1789 VSS.t510 17.0005
R7936 VSS.n1790 VSS.t510 17.0005
R7937 VSS.n1701 VSS.t510 17.0005
R7938 VSS.n1751 VSS.t510 17.0005
R7939 VSS.n1752 VSS.t510 17.0005
R7940 VSS.n1748 VSS.t510 17.0005
R7941 VSS.n1749 VSS.t510 17.0005
R7942 VSS.n1746 VSS.t510 17.0005
R7943 VSS.n1743 VSS.t510 17.0005
R7944 VSS.n1744 VSS.t510 17.0005
R7945 VSS.n1740 VSS.t510 17.0005
R7946 VSS.n1737 VSS.t510 17.0005
R7947 VSS.n1738 VSS.t510 17.0005
R7948 VSS.n1734 VSS.t510 17.0005
R7949 VSS.n1735 VSS.t510 17.0005
R7950 VSS.n1731 VSS.n1730 17.0005
R7951 VSS.n1731 VSS.n1728 17.0005
R7952 VSS.t284 VSS.n3032 17.0005
R7953 VSS.t284 VSS.n1611 17.0005
R7954 VSS.t284 VSS.n1612 17.0005
R7955 VSS.t284 VSS.n2889 17.0005
R7956 VSS.t284 VSS.n1613 17.0005
R7957 VSS.t284 VSS.n2888 17.0005
R7958 VSS.n3033 VSS.t284 17.0005
R7959 VSS.t284 VSS.n1621 17.0005
R7960 VSS.t284 VSS.n2884 17.0005
R7961 VSS.n8 VSS.n1579 17.0005
R7962 VSS.n8 VSS.n1583 17.0005
R7963 VSS.n8 VSS.n1586 17.0005
R7964 VSS.n8 VSS.n1601 17.0005
R7965 VSS.n8 VSS.n1599 17.0005
R7966 VSS.n8 VSS.n4 17.0005
R7967 VSS.n48 VSS.n45 1.51099
R7968 VSS.n2975 VSS.n45 17.0005
R7969 VSS.n2910 VSS.n45 17.0005
R7970 VSS.n2977 VSS.n45 17.0005
R7971 VSS.n2955 VSS.n45 17.0005
R7972 VSS.n2954 VSS.n45 17.0005
R7973 VSS.n2951 VSS.n45 17.0005
R7974 VSS.n2913 VSS.n45 17.0005
R7975 VSS.n2904 VSS.n45 17.0005
R7976 VSS.n2949 VSS.n45 17.0005
R7977 VSS.n2947 VSS.n45 17.0005
R7978 VSS.n2914 VSS.n45 17.0005
R7979 VSS.n2902 VSS.n45 17.0005
R7980 VSS.n2945 VSS.n45 17.0005
R7981 VSS.n2940 VSS.n45 17.0005
R7982 VSS.n2939 VSS.n45 17.0005
R7983 VSS.n2938 VSS.n45 17.0005
R7984 VSS.n2918 VSS.n45 17.0005
R7985 VSS.n2983 VSS.n45 17.0005
R7986 VSS.n2985 VSS.n45 17.0005
R7987 VSS.n2900 VSS.n45 17.0005
R7988 VSS.n2920 VSS.n45 17.0005
R7989 VSS.n2987 VSS.n45 17.0005
R7990 VSS.n2990 VSS.n45 17.0005
R7991 VSS.n2989 VSS.n45 17.0005
R7992 VSS.n2992 VSS.n45 17.0005
R7993 VSS.n2898 VSS.n45 17.0005
R7994 VSS.n2936 VSS.n45 17.0005
R7995 VSS.n2934 VSS.n45 17.0005
R7996 VSS.n2923 VSS.n45 17.0005
R7997 VSS.n2896 VSS.n45 17.0005
R7998 VSS.n2932 VSS.n45 17.0005
R7999 VSS.n2930 VSS.n45 17.0005
R8000 VSS.n2929 VSS.n45 17.0005
R8001 VSS.n2928 VSS.n45 17.0005
R8002 VSS.n2924 VSS.n45 17.0005
R8003 VSS.n2993 VSS.n45 17.0005
R8004 VSS.n2995 VSS.n45 17.0005
R8005 VSS.n2893 VSS.n45 17.0005
R8006 VSS.n2926 VSS.n45 17.0005
R8007 VSS.n2997 VSS.n45 17.0005
R8008 VSS.n2999 VSS.n45 17.0005
R8009 VSS.n51 VSS.n2926 17.0005
R8010 VSS.n51 VSS.n2893 17.0005
R8011 VSS.n51 VSS.n2924 17.0005
R8012 VSS.n51 VSS.n2896 17.0005
R8013 VSS.n51 VSS.n2923 17.0005
R8014 VSS.n51 VSS.n2898 17.0005
R8015 VSS.n51 VSS.n2920 17.0005
R8016 VSS.n51 VSS.n2900 17.0005
R8017 VSS.n51 VSS.n2918 17.0005
R8018 VSS.n51 VSS.n2901 17.0005
R8019 VSS.n51 VSS.n2902 17.0005
R8020 VSS.n51 VSS.n2914 17.0005
R8021 VSS.n51 VSS.n2904 17.0005
R8022 VSS.n51 VSS.n2913 17.0005
R8023 VSS.n28 VSS.n2999 17.0005
R8024 VSS.n28 VSS.n2928 17.0005
R8025 VSS.n28 VSS.n2992 17.0005
R8026 VSS.n28 VSS.n2938 17.0005
R8027 VSS.n28 VSS.n2944 17.0005
R8028 VSS.n28 VSS.n2977 17.0005
R8029 VSS.n28 VSS.n26 17.0005
R8030 VSS.n51 VSS.n2910 17.0005
R8031 VSS.n51 VSS.n2908 17.0005
R8032 VSS.n1571 VSS.n45 17.0005
R8033 VSS.n282 VSS.n3101 17.0005
R8034 VSS.n282 VSS.n872 17.0005
R8035 VSS.n866 VSS.n265 17.0005
R8036 VSS.n864 VSS.n265 17.0005
R8037 VSS.n249 VSS.n3106 17.0005
R8038 VSS.n3107 VSS.n249 17.0005
R8039 VSS.n259 VSS.n863 17.0005
R8040 VSS.n259 VSS.n862 17.0005
R8041 VSS.n238 VSS.n3112 17.0005
R8042 VSS.n3113 VSS.n238 17.0005
R8043 VSS.n234 VSS.n3118 17.0005
R8044 VSS.n234 VSS.n860 17.0005
R8045 VSS.n854 VSS.n223 17.0005
R8046 VSS.n852 VSS.n223 17.0005
R8047 VSS.n3128 VSS.n3124 17.0005
R8048 VSS.n3128 VSS.n3127 17.0005
R8049 VSS.n3061 VSS.t2217 16.9164
R8050 VSS.n1544 VSS.t2093 16.4551
R8051 VSS.n2923 VSS.t2237 16.4539
R8052 VSS.n483 VSS.t1488 16.3876
R8053 VSS.n1886 VSS.n1885 15.4455
R8054 VSS.n1842 VSS.t2228 15.4455
R8055 VSS.t912 VSS.n1971 15.4455
R8056 VSS.n1958 VSS.t587 15.4455
R8057 VSS.n2056 VSS.t1533 15.4455
R8058 VSS.t921 VSS.n2044 15.4455
R8059 VSS.n2031 VSS.t429 15.4455
R8060 VSS.t930 VSS.n1639 15.4455
R8061 VSS.t1503 VSS.n2103 15.4455
R8062 VSS.n386 VSS.n385 88.2779
R8063 VSS.n1556 VSS.t123 14.9842
R8064 VSS.n823 VSS.t1145 14.757
R8065 VSS.n1134 VSS.t1215 14.757
R8066 VSS.n2391 VSS.t1909 14.757
R8067 VSS.t1466 VSS.n2904 14.2601
R8068 VSS.n1797 VSS.t1743 13.954
R8069 VSS.n3075 VSS.t2124 13.7246
R8070 VSS.t93 VSS.n2823 13.7147
R8071 VSS.t122 VSS.n1552 13.5395
R8072 VSS.t17 VSS.t2348 13.4836
R8073 VSS.n849 VSS.n832 13.0461
R8074 VSS.n850 VSS.n835 13.0461
R8075 VSS.n848 VSS.t32 13.0461
R8076 VSS.n838 VSS.n828 13.0461
R8077 VSS.n846 VSS.n825 13.0461
R8078 VSS.n844 VSS.n819 13.0461
R8079 VSS.n841 VSS.n815 13.0461
R8080 VSS.n843 VSS.n811 13.0461
R8081 VSS.n843 VSS.n810 13.0461
R8082 VSS.n842 VSS.n812 13.0461
R8083 VSS.n840 VSS.n816 13.0461
R8084 VSS.n839 VSS.n817 13.0461
R8085 VSS.n844 VSS.n818 13.0461
R8086 VSS.n845 VSS.n823 13.0461
R8087 VSS.n838 VSS.n827 13.0461
R8088 VSS.n847 VSS.n830 13.0461
R8089 VSS.t32 VSS.n832 13.0461
R8090 VSS.n850 VSS.n834 13.0461
R8091 VSS.n3129 VSS.n836 13.0461
R8092 VSS.n3130 VSS.n837 13.0461
R8093 VSS.n1123 VSS.n883 13.0461
R8094 VSS.n1132 VSS.n1116 13.0461
R8095 VSS.n3094 VSS.n3093 13.0461
R8096 VSS.n1131 VSS.n1118 13.0461
R8097 VSS.n1127 VSS.n874 13.0461
R8098 VSS.n1125 VSS.n879 13.0461
R8099 VSS.n1124 VSS.n881 13.0461
R8100 VSS.n1137 VSS.n1113 13.0461
R8101 VSS.n1138 VSS.n1111 13.0461
R8102 VSS.n3094 VSS.n1120 13.0461
R8103 VSS.n1129 VSS.n1119 13.0461
R8104 VSS.n1128 VSS.n1117 13.0461
R8105 VSS.n1133 VSS.n874 13.0461
R8106 VSS.n1134 VSS.n878 13.0461
R8107 VSS.n1135 VSS.n881 13.0461
R8108 VSS.n1136 VSS.n882 13.0461
R8109 VSS.t648 VSS.n1113 13.0461
R8110 VSS.n1122 VSS.n1111 13.0461
R8111 VSS.n1139 VSS.n884 13.0461
R8112 VSS.n3091 VSS.n885 13.0461
R8113 VSS.n2394 VSS.t2193 13.0461
R8114 VSS.n2386 VSS.n2127 13.0461
R8115 VSS.n2385 VSS.n2128 13.0461
R8116 VSS.n2389 VSS.n2373 13.0461
R8117 VSS.n2390 VSS.n2370 13.0461
R8118 VSS.n2391 VSS.n2368 13.0461
R8119 VSS.n2380 VSS.n2132 13.0461
R8120 VSS.n2379 VSS.n2134 13.0461
R8121 VSS.n2393 VSS.n2366 13.0461
R8122 VSS.t2193 VSS.n2135 13.0461
R8123 VSS.n2395 VSS.n2364 13.0461
R8124 VSS.n2850 VSS.n2363 13.0461
R8125 VSS.n2387 VSS.n2127 13.0461
R8126 VSS.n2384 VSS.n2372 13.0461
R8127 VSS.n2383 VSS.n2371 13.0461
R8128 VSS.n2382 VSS.n2370 13.0461
R8129 VSS.n2392 VSS.n2134 13.0461
R8130 VSS.n2394 VSS.n2136 13.0461
R8131 VSS.n2376 VSS.n2364 13.0461
R8132 VSS.n2396 VSS.n2137 13.0461
R8133 VSS.n2997 VSS.n2927 12.0761
R8134 VSS.n2993 VSS.n2925 12.0761
R8135 VSS.n2929 VSS.n2894 12.0761
R8136 VSS.n2932 VSS.n2895 12.0761
R8137 VSS.n2936 VSS.n2897 12.0761
R8138 VSS.n2989 VSS.n2922 12.0761
R8139 VSS.n2987 VSS.n2921 12.0761
R8140 VSS.n2983 VSS.n2919 12.0761
R8141 VSS.n2938 VSS.n2917 12.0761
R8142 VSS.n2940 VSS.n2916 12.0761
R8143 VSS.n2949 VSS.n2903 12.0761
R8144 VSS.n2954 VSS.n2905 12.0761
R8145 VSS.n2998 VSS.n2997 12.0761
R8146 VSS.n2996 VSS.n2893 12.0761
R8147 VSS.n2994 VSS.n2993 12.0761
R8148 VSS.n2931 VSS.n2929 12.0761
R8149 VSS.n2933 VSS.n2932 12.0761
R8150 VSS.n2935 VSS.n2923 12.0761
R8151 VSS.n2937 VSS.n2936 12.0761
R8152 VSS.n2991 VSS.n2989 12.0761
R8153 VSS.n2988 VSS.n2987 12.0761
R8154 VSS.n2986 VSS.n2900 12.0761
R8155 VSS.n2984 VSS.n2983 12.0761
R8156 VSS.n2941 VSS.n2939 12.0761
R8157 VSS.n2946 VSS.n2945 12.0761
R8158 VSS.n2948 VSS.n2914 12.0761
R8159 VSS.n2950 VSS.n2949 12.0761
R8160 VSS.n2952 VSS.n2913 12.0761
R8161 VSS.n2956 VSS.n2954 12.0761
R8162 VSS.n2976 VSS.n2910 12.0761
R8163 VSS.n2977 VSS.n2912 12.0761
R8164 VSS.n2909 VSS.n26 12.0761
R8165 VSS.n2999 VSS.n2927 12.0761
R8166 VSS.n2998 VSS.n2926 12.0761
R8167 VSS.n2996 VSS.n2995 12.0761
R8168 VSS.n2995 VSS.n2925 12.0761
R8169 VSS.n2994 VSS.n2924 12.0761
R8170 VSS.n2928 VSS.n2894 12.0761
R8171 VSS.n2931 VSS.n2930 12.0761
R8172 VSS.n2930 VSS.n2895 12.0761
R8173 VSS.n2933 VSS.n2896 12.0761
R8174 VSS.n2935 VSS.n2934 12.0761
R8175 VSS.n2934 VSS.n2897 12.0761
R8176 VSS.n2937 VSS.n2898 12.0761
R8177 VSS.n2992 VSS.n2922 12.0761
R8178 VSS.n2991 VSS.n2990 12.0761
R8179 VSS.n2990 VSS.n2921 12.0761
R8180 VSS.n2988 VSS.n2920 12.0761
R8181 VSS.n2986 VSS.n2985 12.0761
R8182 VSS.n2985 VSS.n2919 12.0761
R8183 VSS.n2984 VSS.n2918 12.0761
R8184 VSS.n2939 VSS.n2917 12.0761
R8185 VSS.n2941 VSS.n2940 12.0761
R8186 VSS.n2945 VSS.n2916 12.0761
R8187 VSS.n2946 VSS.n2902 12.0761
R8188 VSS.n2948 VSS.n2947 12.0761
R8189 VSS.n2947 VSS.n2903 12.0761
R8190 VSS.n2950 VSS.n2904 12.0761
R8191 VSS.n2952 VSS.n2951 12.0761
R8192 VSS.n2951 VSS.n2905 12.0761
R8193 VSS.n2956 VSS.n2955 12.0761
R8194 VSS.n2955 VSS.n2912 12.0761
R8195 VSS.n2976 VSS.n2975 12.0761
R8196 VSS.n2975 VSS.n2909 12.0761
R8197 VSS.t2104 VSS.n1554 12.0423
R8198 VSS.n1888 VSS.n1887 12.0423
R8199 VSS.t1158 VSS.n828 11.8057
R8200 VSS.n1135 VSS.t55 11.8057
R8201 VSS.n2392 VSS.t389 11.8057
R8202 VSS.t906 VSS.n1920 11.7681
R8203 VSS.n1942 VSS.t1531 11.7681
R8204 VSS.t915 VSS.n1993 11.7681
R8205 VSS.t924 VSS.n2066 11.7681
R8206 VSS.t516 VSS.n1774 10.4656
R8207 VSS.t1706 VSS.t2226 10.4656
R8208 VSS.n3062 VSS.t2348 10.2971
R8209 VSS.n1864 VSS.t643 9.56167
R8210 VSS.n3052 VSS.n1570 9.39094
R8211 VSS.n3056 VSS.n1566 9.39094
R8212 VSS.n3050 VSS.n3049 9.38916
R8213 VSS.n1588 VSS.t801 9.08698
R8214 VSS.t801 VSS.n1587 9.0445
R8215 VSS.n3036 VSS.n3035 9.0005
R8216 VSS.n3036 VSS.n1574 9.0005
R8217 VSS.n1578 VSS.n1573 9.0005
R8218 VSS.n2969 VSS.n1573 9.0005
R8219 VSS.t1115 VSS.n3134 8.501
R8220 VSS.n3135 VSS.t1113 8.501
R8221 VSS.t1111 VSS.n584 8.501
R8222 VSS.t764 VSS.n575 8.501
R8223 VSS.t1105 VSS.n3143 8.501
R8224 VSS.n3144 VSS.t1103 8.501
R8225 VSS.t1101 VSS.n3146 8.501
R8226 VSS.n3147 VSS.t776 8.501
R8227 VSS.t1095 VSS.n3149 8.501
R8228 VSS.n3150 VSS.t1093 8.501
R8229 VSS.t1091 VSS.n553 8.501
R8230 VSS.t779 VSS.n536 8.501
R8231 VSS.t1085 VSS.n3158 8.501
R8232 VSS.n3159 VSS.t1083 8.501
R8233 VSS.t1081 VSS.n3161 8.501
R8234 VSS.n3162 VSS.t767 8.501
R8235 VSS.t1075 VSS.n3164 8.501
R8236 VSS.n3165 VSS.t1073 8.501
R8237 VSS.t1071 VSS.n513 8.501
R8238 VSS.t773 VSS.n505 8.501
R8239 VSS.t1065 VSS.n3173 8.501
R8240 VSS.n3174 VSS.t1063 8.501
R8241 VSS.t1061 VSS.n499 8.501
R8242 VSS.t770 VSS.n475 8.501
R8243 VSS.n380 VSS.n379 0.00174993
R8244 VSS.n380 VSS.n386 9.59049
R8245 VSS.t992 VSS.n222 0.831559
R8246 VSS.t990 VSS.n220 0.264361
R8247 VSS.t988 VSS.n218 0.145945
R8248 VSS.t981 VSS.n216 0.627105
R8249 VSS.t979 VSS.n214 0.264361
R8250 VSS.t977 VSS.n212 0.145945
R8251 VSS.t970 VSS.n210 0.627105
R8252 VSS.t968 VSS.n208 0.264361
R8253 VSS.t966 VSS.n206 0.145945
R8254 VSS.n204 VSS.n203 0.229424
R8255 VSS.t957 VSS.n202 0.264361
R8256 VSS.t955 VSS.n200 0.145945
R8257 VSS.t948 VSS.n198 0.627105
R8258 VSS.t946 VSS.n196 0.264361
R8259 VSS.t944 VSS.n194 0.145945
R8260 VSS.t937 VSS.n192 0.627105
R8261 VSS.t935 VSS.n190 0.264361
R8262 VSS.t933 VSS.n188 0.145945
R8263 VSS.n1525 VSS.n184 233.198
R8264 VSS.n186 VSS.n184 0.00235708
R8265 VSS.t869 VSS.n2436 8.501
R8266 VSS.t867 VSS.n2434 8.501
R8267 VSS.t474 VSS.n2432 8.501
R8268 VSS.t859 VSS.n2429 8.501
R8269 VSS.t857 VSS.n2427 8.501
R8270 VSS.t689 VSS.n2425 8.501
R8271 VSS.t849 VSS.n2422 8.501
R8272 VSS.t847 VSS.n2420 8.501
R8273 VSS.t354 VSS.n2418 8.501
R8274 VSS.t839 VSS.n2416 8.501
R8275 VSS.t837 VSS.n2414 8.501
R8276 VSS.t426 VSS.n2412 8.501
R8277 VSS.t829 VSS.n2409 8.501
R8278 VSS.t827 VSS.n2407 8.501
R8279 VSS.t686 VSS.n2405 8.501
R8280 VSS.t819 VSS.n2402 8.501
R8281 VSS.t817 VSS.n2400 8.501
R8282 VSS.t815 VSS.n2398 8.501
R8283 VSS.t927 VSS.n1633 8.501
R8284 VSS.t925 VSS.n1650 8.501
R8285 VSS.n2058 VSS.t431 8.501
R8286 VSS.t918 VSS.n1656 8.501
R8287 VSS.t916 VSS.n1664 8.501
R8288 VSS.n1985 VSS.t589 8.501
R8289 VSS.t909 VSS.n1670 8.501
R8290 VSS.t907 VSS.n1678 8.501
R8291 VSS.n1912 VSS.t904 8.501
R8292 VSS.n75 VSS.n2862 1.57848
R8293 VSS.n74 VSS.n72 0.00149997
R8294 VSS.n2862 VSS.n78 1.54642
R8295 VSS.n79 VSS.n81 0.00158329
R8296 VSS.n2862 VSS.n83 0.944682
R8297 VSS.n83 VSS.n85 0.00291023
R8298 VSS.n85 VSS.n86 0.00172539
R8299 VSS.n86 VSS.n87 0.00171613
R8300 VSS.n87 VSS.n88 0.00169968
R8301 VSS.n88 VSS.n89 0.00166651
R8302 VSS.n89 VSS.n91 0.00158329
R8303 VSS.n2862 VSS.n95 3.40102
R8304 VSS.t899 VSS.n1684 8.501
R8305 VSS.t897 VSS.n1691 8.501
R8306 VSS.n1793 VSS.t894 8.501
R8307 VSS.t889 VSS.n1698 8.501
R8308 VSS.t887 VSS.n1707 8.501
R8309 VSS.n1733 VSS.t586 8.501
R8310 VSS.t880 VSS.n1713 8.501
R8311 VSS.t878 VSS.n1727 8.501
R8312 VSS.t875 VSS.n1562 8.501
R8313 VSS.n3034 VSS.n6 5.41263
R8314 VSS.n3027 VSS.n29 4.251
R8315 VSS.n3027 VSS.n30 3.40102
R8316 VSS.n3027 VSS.n32 3.40102
R8317 VSS.n3027 VSS.n34 2.42956
R8318 VSS.n3027 VSS.n36 3.40102
R8319 VSS.n3027 VSS.n39 1.54642
R8320 VSS.n13 VSS.n40 0.00158329
R8321 VSS.n3027 VSS.n42 1.701
R8322 VSS.n53 VSS.n54 0.00214867
R8323 VSS.n56 VSS.n53 0.00173104
R8324 VSS.n57 VSS.n56 0.00172539
R8325 VSS.n58 VSS.n57 0.00171613
R8326 VSS.n59 VSS.n58 0.00169968
R8327 VSS.n60 VSS.n59 0.00166651
R8328 VSS.n15 VSS.n60 0.00158329
R8329 VSS.n55 VSS.n61 3.40102
R8330 VSS.n55 VSS.n66 3.40102
R8331 VSS.n55 VSS.n69 3.40102
R8332 VSS.n55 VSS.n71 1.88989
R8333 VSS.n3031 VSS.n28 8.501
R8334 VSS.n23 VSS.n51 0.00174987
R8335 VSS.n3031 VSS.n23 1.70092
R8336 VSS.n25 VSS.n21 0.00149997
R8337 VSS.n3031 VSS.n48 6.23647
R8338 VSS.t2253 VSS.n49 8.501
R8339 VSS.t1056 VSS.n285 0.831118
R8340 VSS.t1051 VSS.n284 0.263721
R8341 VSS.t2 VSS.n283 0.145945
R8342 VSS.n279 VSS.t1044 0.627105
R8343 VSS.t1042 VSS.n278 0.264111
R8344 VSS.n272 VSS.t1039 0.145945
R8345 VSS.n271 VSS.t1036 0.626394
R8346 VSS.t1031 VSS.n264 0.263721
R8347 VSS.t1028 VSS.n263 0.145945
R8348 VSS.n259 VSS.n260 0.126674
R8349 VSS.t1021 VSS.n247 0.263721
R8350 VSS.t79 VSS.n246 0.145945
R8351 VSS.n243 VSS.t1016 0.626394
R8352 VSS.t1011 VSS.n236 0.263721
R8353 VSS.t1008 VSS.n235 0.145945
R8354 VSS.n231 VSS.t1003 0.627105
R8355 VSS.t1001 VSS.n230 0.264111
R8356 VSS.t998 VSS.n224 0.145945
R8357 VSS.n382 VSS.n808 8.5005
R8358 VSS.n382 VSS.n803 8.5005
R8359 VSS.n382 VSS.n639 8.5005
R8360 VSS.n382 VSS.n801 8.5005
R8361 VSS.n382 VSS.n800 8.5005
R8362 VSS.n382 VSS.n640 8.5005
R8363 VSS.n382 VSS.n799 8.5005
R8364 VSS.n382 VSS.n642 8.5005
R8365 VSS.n382 VSS.n798 8.5005
R8366 VSS.n382 VSS.n643 8.5005
R8367 VSS.n382 VSS.n797 8.5005
R8368 VSS.n382 VSS.n644 8.5005
R8369 VSS.n382 VSS.n796 8.5005
R8370 VSS.n382 VSS.n795 8.5005
R8371 VSS.n382 VSS.n645 8.5005
R8372 VSS.n382 VSS.n794 8.5005
R8373 VSS.n382 VSS.n647 8.5005
R8374 VSS.n382 VSS.n793 8.5005
R8375 VSS.n382 VSS.n648 8.5005
R8376 VSS.n382 VSS.n792 8.5005
R8377 VSS.n382 VSS.n649 8.5005
R8378 VSS.n382 VSS.n791 8.5005
R8379 VSS.n382 VSS.n790 8.5005
R8380 VSS.n382 VSS.n650 8.5005
R8381 VSS.n382 VSS.n789 8.5005
R8382 VSS.n382 VSS.n652 8.5005
R8383 VSS.n382 VSS.n788 8.5005
R8384 VSS.n382 VSS.n653 8.5005
R8385 VSS.n382 VSS.n787 8.5005
R8386 VSS.n382 VSS.n654 8.5005
R8387 VSS.n382 VSS.n786 8.5005
R8388 VSS.n382 VSS.n785 8.5005
R8389 VSS.n382 VSS.n655 8.5005
R8390 VSS.n382 VSS.n784 8.5005
R8391 VSS.n382 VSS.n657 8.5005
R8392 VSS.n382 VSS.n783 8.5005
R8393 VSS.n382 VSS.n658 8.5005
R8394 VSS.n382 VSS.n782 8.5005
R8395 VSS.n382 VSS.n659 8.5005
R8396 VSS.n382 VSS.n781 8.5005
R8397 VSS.n382 VSS.n780 8.5005
R8398 VSS.n382 VSS.n660 8.5005
R8399 VSS.n382 VSS.n779 8.5005
R8400 VSS.n382 VSS.n662 8.5005
R8401 VSS.n382 VSS.n778 8.5005
R8402 VSS.n382 VSS.n663 8.5005
R8403 VSS.n382 VSS.n777 8.5005
R8404 VSS.n382 VSS.n664 8.5005
R8405 VSS.n382 VSS.n776 8.5005
R8406 VSS.n382 VSS.n775 8.5005
R8407 VSS.n382 VSS.n665 8.5005
R8408 VSS.n382 VSS.n774 8.5005
R8409 VSS.n382 VSS.n667 8.5005
R8410 VSS.n382 VSS.n773 8.5005
R8411 VSS.n382 VSS.n668 8.5005
R8412 VSS.n382 VSS.n772 8.5005
R8413 VSS.n382 VSS.n669 8.5005
R8414 VSS.n382 VSS.n771 8.5005
R8415 VSS.n382 VSS.n770 8.5005
R8416 VSS.n382 VSS.n670 8.5005
R8417 VSS.n382 VSS.n769 8.5005
R8418 VSS.n382 VSS.n672 8.5005
R8419 VSS.n382 VSS.n768 8.5005
R8420 VSS.n382 VSS.n673 8.5005
R8421 VSS.n382 VSS.n767 8.5005
R8422 VSS.n382 VSS.n674 8.5005
R8423 VSS.n382 VSS.n766 8.5005
R8424 VSS.n382 VSS.n765 8.5005
R8425 VSS.n382 VSS.n675 8.5005
R8426 VSS.n382 VSS.n764 8.5005
R8427 VSS.n382 VSS.n677 8.5005
R8428 VSS.n382 VSS.n763 8.5005
R8429 VSS.n382 VSS.n678 8.5005
R8430 VSS.n382 VSS.n762 8.5005
R8431 VSS.n382 VSS.n679 8.5005
R8432 VSS.n382 VSS.n761 8.5005
R8433 VSS.n382 VSS.n760 8.5005
R8434 VSS.n382 VSS.n680 8.5005
R8435 VSS.n382 VSS.n759 8.5005
R8436 VSS.n382 VSS.n682 8.5005
R8437 VSS.n382 VSS.n758 8.5005
R8438 VSS.n382 VSS.n683 8.5005
R8439 VSS.n382 VSS.n757 8.5005
R8440 VSS.n382 VSS.n684 8.5005
R8441 VSS.n382 VSS.n756 8.5005
R8442 VSS.n382 VSS.n755 8.5005
R8443 VSS.n382 VSS.n685 8.5005
R8444 VSS.n382 VSS.n754 8.5005
R8445 VSS.n382 VSS.n687 8.5005
R8446 VSS.n382 VSS.n753 8.5005
R8447 VSS.n382 VSS.n688 8.5005
R8448 VSS.n382 VSS.n752 8.5005
R8449 VSS.n382 VSS.n689 8.5005
R8450 VSS.n382 VSS.n751 8.5005
R8451 VSS.n382 VSS.n750 8.5005
R8452 VSS.n382 VSS.n690 8.5005
R8453 VSS.n382 VSS.n749 8.5005
R8454 VSS.n382 VSS.n692 8.5005
R8455 VSS.n382 VSS.n748 8.5005
R8456 VSS.n382 VSS.n693 8.5005
R8457 VSS.n382 VSS.n747 8.5005
R8458 VSS.n382 VSS.n694 8.5005
R8459 VSS.n382 VSS.n746 8.5005
R8460 VSS.n382 VSS.n745 8.5005
R8461 VSS.n382 VSS.n695 8.5005
R8462 VSS.n382 VSS.n744 8.5005
R8463 VSS.n382 VSS.n697 8.5005
R8464 VSS.n382 VSS.n743 8.5005
R8465 VSS.n382 VSS.n698 8.5005
R8466 VSS.n382 VSS.n742 8.5005
R8467 VSS.n382 VSS.n699 8.5005
R8468 VSS.n382 VSS.n741 8.5005
R8469 VSS.n382 VSS.n740 8.5005
R8470 VSS.n382 VSS.n700 8.5005
R8471 VSS.n382 VSS.n739 8.5005
R8472 VSS.n382 VSS.n702 8.5005
R8473 VSS.n382 VSS.n738 8.5005
R8474 VSS.n382 VSS.n703 8.5005
R8475 VSS.n382 VSS.n737 8.5005
R8476 VSS.n382 VSS.n704 8.5005
R8477 VSS.n382 VSS.n736 8.5005
R8478 VSS.n382 VSS.n735 8.5005
R8479 VSS.n382 VSS.n705 8.5005
R8480 VSS.n382 VSS.n734 8.5005
R8481 VSS.n382 VSS.n707 8.5005
R8482 VSS.n382 VSS.n733 8.5005
R8483 VSS.n382 VSS.n708 8.5005
R8484 VSS.n382 VSS.n732 8.5005
R8485 VSS.n382 VSS.n709 8.5005
R8486 VSS.n382 VSS.n731 8.5005
R8487 VSS.n382 VSS.n730 8.5005
R8488 VSS.n382 VSS.n710 8.5005
R8489 VSS.n382 VSS.n729 8.5005
R8490 VSS.n382 VSS.n712 8.5005
R8491 VSS.n382 VSS.n728 8.5005
R8492 VSS.n382 VSS.n713 8.5005
R8493 VSS.n382 VSS.n727 8.5005
R8494 VSS.n382 VSS.n714 8.5005
R8495 VSS.n382 VSS.n726 8.5005
R8496 VSS.n382 VSS.n725 8.5005
R8497 VSS.n382 VSS.n715 8.5005
R8498 VSS.n382 VSS.n724 8.5005
R8499 VSS.n382 VSS.n717 8.5005
R8500 VSS.n382 VSS.n723 8.5005
R8501 VSS.n382 VSS.n718 8.5005
R8502 VSS.n382 VSS.n720 8.5005
R8503 VSS.n293 VSS.n924 8.5005
R8504 VSS.n293 VSS.n925 8.5005
R8505 VSS.n293 VSS.n1105 8.5005
R8506 VSS.n293 VSS.n929 8.5005
R8507 VSS.n293 VSS.n930 8.5005
R8508 VSS.n293 VSS.n1104 8.5005
R8509 VSS.n293 VSS.n931 8.5005
R8510 VSS.n293 VSS.n1103 8.5005
R8511 VSS.n293 VSS.n932 8.5005
R8512 VSS.n293 VSS.n1102 8.5005
R8513 VSS.n293 VSS.n933 8.5005
R8514 VSS.n293 VSS.n1101 8.5005
R8515 VSS.n293 VSS.n936 8.5005
R8516 VSS.n293 VSS.n937 8.5005
R8517 VSS.n293 VSS.n1100 8.5005
R8518 VSS.n293 VSS.n938 8.5005
R8519 VSS.n293 VSS.n1099 8.5005
R8520 VSS.n293 VSS.n939 8.5005
R8521 VSS.n293 VSS.n1098 8.5005
R8522 VSS.n293 VSS.n940 8.5005
R8523 VSS.n293 VSS.n1097 8.5005
R8524 VSS.n293 VSS.n943 8.5005
R8525 VSS.n293 VSS.n944 8.5005
R8526 VSS.n293 VSS.n1096 8.5005
R8527 VSS.n293 VSS.n945 8.5005
R8528 VSS.n293 VSS.n1095 8.5005
R8529 VSS.n293 VSS.n946 8.5005
R8530 VSS.n293 VSS.n1094 8.5005
R8531 VSS.n293 VSS.n947 8.5005
R8532 VSS.n293 VSS.n1093 8.5005
R8533 VSS.n293 VSS.n950 8.5005
R8534 VSS.n293 VSS.n951 8.5005
R8535 VSS.n293 VSS.n1092 8.5005
R8536 VSS.n293 VSS.n952 8.5005
R8537 VSS.n293 VSS.n1091 8.5005
R8538 VSS.n293 VSS.n953 8.5005
R8539 VSS.n293 VSS.n1090 8.5005
R8540 VSS.n293 VSS.n954 8.5005
R8541 VSS.n293 VSS.n1089 8.5005
R8542 VSS.n293 VSS.n957 8.5005
R8543 VSS.n293 VSS.n958 8.5005
R8544 VSS.n293 VSS.n1088 8.5005
R8545 VSS.n293 VSS.n959 8.5005
R8546 VSS.n293 VSS.n1087 8.5005
R8547 VSS.n293 VSS.n960 8.5005
R8548 VSS.n293 VSS.n1086 8.5005
R8549 VSS.n293 VSS.n961 8.5005
R8550 VSS.n293 VSS.n1085 8.5005
R8551 VSS.n293 VSS.n964 8.5005
R8552 VSS.n293 VSS.n965 8.5005
R8553 VSS.n293 VSS.n1084 8.5005
R8554 VSS.n293 VSS.n966 8.5005
R8555 VSS.n293 VSS.n1083 8.5005
R8556 VSS.n293 VSS.n967 8.5005
R8557 VSS.n293 VSS.n1082 8.5005
R8558 VSS.n293 VSS.n968 8.5005
R8559 VSS.n293 VSS.n1081 8.5005
R8560 VSS.n293 VSS.n971 8.5005
R8561 VSS.n293 VSS.n972 8.5005
R8562 VSS.n293 VSS.n1080 8.5005
R8563 VSS.n293 VSS.n973 8.5005
R8564 VSS.n293 VSS.n1079 8.5005
R8565 VSS.n293 VSS.n974 8.5005
R8566 VSS.n293 VSS.n1078 8.5005
R8567 VSS.n293 VSS.n975 8.5005
R8568 VSS.n293 VSS.n1077 8.5005
R8569 VSS.n293 VSS.n978 8.5005
R8570 VSS.n293 VSS.n979 8.5005
R8571 VSS.n293 VSS.n1076 8.5005
R8572 VSS.n293 VSS.n980 8.5005
R8573 VSS.n293 VSS.n1075 8.5005
R8574 VSS.n293 VSS.n981 8.5005
R8575 VSS.n293 VSS.n1074 8.5005
R8576 VSS.n293 VSS.n982 8.5005
R8577 VSS.n293 VSS.n1073 8.5005
R8578 VSS.n293 VSS.n985 8.5005
R8579 VSS.n293 VSS.n986 8.5005
R8580 VSS.n293 VSS.n1072 8.5005
R8581 VSS.n293 VSS.n987 8.5005
R8582 VSS.n293 VSS.n1071 8.5005
R8583 VSS.n293 VSS.n988 8.5005
R8584 VSS.n293 VSS.n1070 8.5005
R8585 VSS.n293 VSS.n989 8.5005
R8586 VSS.n293 VSS.n1069 8.5005
R8587 VSS.n293 VSS.n992 8.5005
R8588 VSS.n293 VSS.n993 8.5005
R8589 VSS.n293 VSS.n1068 8.5005
R8590 VSS.n293 VSS.n994 8.5005
R8591 VSS.n293 VSS.n1067 8.5005
R8592 VSS.n293 VSS.n995 8.5005
R8593 VSS.n293 VSS.n1066 8.5005
R8594 VSS.n293 VSS.n996 8.5005
R8595 VSS.n293 VSS.n1065 8.5005
R8596 VSS.n293 VSS.n999 8.5005
R8597 VSS.n293 VSS.n1000 8.5005
R8598 VSS.n293 VSS.n1064 8.5005
R8599 VSS.n293 VSS.n1001 8.5005
R8600 VSS.n293 VSS.n1063 8.5005
R8601 VSS.n293 VSS.n1002 8.5005
R8602 VSS.n293 VSS.n1062 8.5005
R8603 VSS.n293 VSS.n1003 8.5005
R8604 VSS.n293 VSS.n1061 8.5005
R8605 VSS.n293 VSS.n1006 8.5005
R8606 VSS.n293 VSS.n1007 8.5005
R8607 VSS.n293 VSS.n1060 8.5005
R8608 VSS.n293 VSS.n1008 8.5005
R8609 VSS.n293 VSS.n1059 8.5005
R8610 VSS.n293 VSS.n1009 8.5005
R8611 VSS.n293 VSS.n1058 8.5005
R8612 VSS.n293 VSS.n1010 8.5005
R8613 VSS.n293 VSS.n1057 8.5005
R8614 VSS.n293 VSS.n1013 8.5005
R8615 VSS.n293 VSS.n1014 8.5005
R8616 VSS.n293 VSS.n1056 8.5005
R8617 VSS.n293 VSS.n1015 8.5005
R8618 VSS.n293 VSS.n1055 8.5005
R8619 VSS.n293 VSS.n1016 8.5005
R8620 VSS.n293 VSS.n1054 8.5005
R8621 VSS.n293 VSS.n1017 8.5005
R8622 VSS.n293 VSS.n1053 8.5005
R8623 VSS.n293 VSS.n1020 8.5005
R8624 VSS.n293 VSS.n1021 8.5005
R8625 VSS.n293 VSS.n1052 8.5005
R8626 VSS.n293 VSS.n1022 8.5005
R8627 VSS.n293 VSS.n1051 8.5005
R8628 VSS.n293 VSS.n1023 8.5005
R8629 VSS.n293 VSS.n1050 8.5005
R8630 VSS.n293 VSS.n1024 8.5005
R8631 VSS.n293 VSS.n1049 8.5005
R8632 VSS.n293 VSS.n1027 8.5005
R8633 VSS.n293 VSS.n1028 8.5005
R8634 VSS.n293 VSS.n1048 8.5005
R8635 VSS.n293 VSS.n1029 8.5005
R8636 VSS.n293 VSS.n1047 8.5005
R8637 VSS.n293 VSS.n1030 8.5005
R8638 VSS.n293 VSS.n1046 8.5005
R8639 VSS.n293 VSS.n1031 8.5005
R8640 VSS.n293 VSS.n1045 8.5005
R8641 VSS.n293 VSS.n1034 8.5005
R8642 VSS.n293 VSS.n1035 8.5005
R8643 VSS.n293 VSS.n1044 8.5005
R8644 VSS.n293 VSS.n1036 8.5005
R8645 VSS.n293 VSS.n1043 8.5005
R8646 VSS.n293 VSS.n1037 8.5005
R8647 VSS.n293 VSS.n1042 8.5005
R8648 VSS.n293 VSS.n1040 8.5005
R8649 VSS.n3079 VSS.n1525 8.5005
R8650 VSS.n3079 VSS.n1448 8.5005
R8651 VSS.n3079 VSS.n1444 8.5005
R8652 VSS.n3079 VSS.n1443 8.5005
R8653 VSS.n3079 VSS.n1442 8.5005
R8654 VSS.n3079 VSS.n1441 8.5005
R8655 VSS.n3079 VSS.n1440 8.5005
R8656 VSS.n3079 VSS.n1439 8.5005
R8657 VSS.n3079 VSS.n1436 8.5005
R8658 VSS.n3079 VSS.n1433 8.5005
R8659 VSS.n3079 VSS.n1432 8.5005
R8660 VSS.n3079 VSS.n1429 8.5005
R8661 VSS.n3079 VSS.n1428 8.5005
R8662 VSS.n3079 VSS.n1427 8.5005
R8663 VSS.n3079 VSS.n1426 8.5005
R8664 VSS.n3079 VSS.n1424 8.5005
R8665 VSS.n3079 VSS.n1423 8.5005
R8666 VSS.n3079 VSS.n1420 8.5005
R8667 VSS.n3079 VSS.n1417 8.5005
R8668 VSS.n3079 VSS.n1416 8.5005
R8669 VSS.n3079 VSS.n1413 8.5005
R8670 VSS.n3079 VSS.n1412 8.5005
R8671 VSS.n3079 VSS.n1411 8.5005
R8672 VSS.n3079 VSS.n1410 8.5005
R8673 VSS.n3079 VSS.n1408 8.5005
R8674 VSS.n3079 VSS.n1407 8.5005
R8675 VSS.n3079 VSS.n1405 8.5005
R8676 VSS.n3079 VSS.n1402 8.5005
R8677 VSS.n3079 VSS.n1401 8.5005
R8678 VSS.n3079 VSS.n1398 8.5005
R8679 VSS.n3079 VSS.n1397 8.5005
R8680 VSS.n3079 VSS.n1395 8.5005
R8681 VSS.n3079 VSS.n1394 8.5005
R8682 VSS.n3079 VSS.n1393 8.5005
R8683 VSS.n3079 VSS.n1392 8.5005
R8684 VSS.n3079 VSS.n1389 8.5005
R8685 VSS.n3079 VSS.n1386 8.5005
R8686 VSS.n3079 VSS.n1385 8.5005
R8687 VSS.n3079 VSS.n1382 8.5005
R8688 VSS.n3079 VSS.n1381 8.5005
R8689 VSS.n3079 VSS.n1380 8.5005
R8690 VSS.n3079 VSS.n1379 8.5005
R8691 VSS.n3079 VSS.n1377 8.5005
R8692 VSS.n3079 VSS.n1376 8.5005
R8693 VSS.n3079 VSS.n1373 8.5005
R8694 VSS.n3079 VSS.n1370 8.5005
R8695 VSS.n3079 VSS.n1369 8.5005
R8696 VSS.n3079 VSS.n1366 8.5005
R8697 VSS.n3079 VSS.n1365 8.5005
R8698 VSS.n3079 VSS.n1364 8.5005
R8699 VSS.n3079 VSS.n1363 8.5005
R8700 VSS.n3079 VSS.n1361 8.5005
R8701 VSS.n3079 VSS.n1360 8.5005
R8702 VSS.n3079 VSS.n1358 8.5005
R8703 VSS.n3079 VSS.n1355 8.5005
R8704 VSS.n3079 VSS.n1354 8.5005
R8705 VSS.n3079 VSS.n1351 8.5005
R8706 VSS.n3079 VSS.n1350 8.5005
R8707 VSS.n3079 VSS.n1348 8.5005
R8708 VSS.n3079 VSS.n1347 8.5005
R8709 VSS.n3079 VSS.n1346 8.5005
R8710 VSS.n3079 VSS.n1345 8.5005
R8711 VSS.n3079 VSS.n1342 8.5005
R8712 VSS.n3079 VSS.n1339 8.5005
R8713 VSS.n3079 VSS.n1338 8.5005
R8714 VSS.n3079 VSS.n1335 8.5005
R8715 VSS.n3079 VSS.n1334 8.5005
R8716 VSS.n3079 VSS.n1333 8.5005
R8717 VSS.n3079 VSS.n1332 8.5005
R8718 VSS.n3079 VSS.n1330 8.5005
R8719 VSS.n3079 VSS.n1329 8.5005
R8720 VSS.n3079 VSS.n1326 8.5005
R8721 VSS.n3079 VSS.n1323 8.5005
R8722 VSS.n3079 VSS.n1322 8.5005
R8723 VSS.n3079 VSS.n1319 8.5005
R8724 VSS.n3079 VSS.n1318 8.5005
R8725 VSS.n3079 VSS.n1317 8.5005
R8726 VSS.n3079 VSS.n1316 8.5005
R8727 VSS.n3079 VSS.n1314 8.5005
R8728 VSS.n3079 VSS.n1313 8.5005
R8729 VSS.n3079 VSS.n1311 8.5005
R8730 VSS.n3079 VSS.n1308 8.5005
R8731 VSS.n3079 VSS.n1307 8.5005
R8732 VSS.n3079 VSS.n1304 8.5005
R8733 VSS.n3079 VSS.n1303 8.5005
R8734 VSS.n3079 VSS.n1301 8.5005
R8735 VSS.n3079 VSS.n1300 8.5005
R8736 VSS.n3079 VSS.n1299 8.5005
R8737 VSS.n3079 VSS.n1298 8.5005
R8738 VSS.n3079 VSS.n1295 8.5005
R8739 VSS.n3079 VSS.n1292 8.5005
R8740 VSS.n3079 VSS.n1291 8.5005
R8741 VSS.n3079 VSS.n1288 8.5005
R8742 VSS.n3079 VSS.n1287 8.5005
R8743 VSS.n3079 VSS.n1286 8.5005
R8744 VSS.n3079 VSS.n1285 8.5005
R8745 VSS.n3079 VSS.n1283 8.5005
R8746 VSS.n3079 VSS.n1282 8.5005
R8747 VSS.n3079 VSS.n1279 8.5005
R8748 VSS.n3079 VSS.n1276 8.5005
R8749 VSS.n3079 VSS.n1275 8.5005
R8750 VSS.n3079 VSS.n1272 8.5005
R8751 VSS.n3079 VSS.n1271 8.5005
R8752 VSS.n3079 VSS.n1270 8.5005
R8753 VSS.n3079 VSS.n1269 8.5005
R8754 VSS.n3079 VSS.n1267 8.5005
R8755 VSS.n3079 VSS.n1266 8.5005
R8756 VSS.n3079 VSS.n1264 8.5005
R8757 VSS.n3079 VSS.n1261 8.5005
R8758 VSS.n3079 VSS.n1260 8.5005
R8759 VSS.n3079 VSS.n1257 8.5005
R8760 VSS.n3079 VSS.n1256 8.5005
R8761 VSS.n3079 VSS.n1254 8.5005
R8762 VSS.n3079 VSS.n1253 8.5005
R8763 VSS.n3079 VSS.n1252 8.5005
R8764 VSS.n3079 VSS.n1251 8.5005
R8765 VSS.n3079 VSS.n1248 8.5005
R8766 VSS.n3079 VSS.n1245 8.5005
R8767 VSS.n3079 VSS.n1244 8.5005
R8768 VSS.n3079 VSS.n1241 8.5005
R8769 VSS.n3079 VSS.n1240 8.5005
R8770 VSS.n3079 VSS.n1239 8.5005
R8771 VSS.n3079 VSS.n1238 8.5005
R8772 VSS.n3079 VSS.n1236 8.5005
R8773 VSS.n3079 VSS.n1235 8.5005
R8774 VSS.n3079 VSS.n1232 8.5005
R8775 VSS.n3079 VSS.n1229 8.5005
R8776 VSS.n3079 VSS.n1228 8.5005
R8777 VSS.n3079 VSS.n1225 8.5005
R8778 VSS.n3079 VSS.n1224 8.5005
R8779 VSS.n3079 VSS.n1223 8.5005
R8780 VSS.n3079 VSS.n1222 8.5005
R8781 VSS.n3079 VSS.n1220 8.5005
R8782 VSS.n3079 VSS.n1219 8.5005
R8783 VSS.n3079 VSS.n1216 8.5005
R8784 VSS.n3079 VSS.n1213 8.5005
R8785 VSS.n3079 VSS.n1212 8.5005
R8786 VSS.n3079 VSS.n1209 8.5005
R8787 VSS.n3079 VSS.n1208 8.5005
R8788 VSS.n3079 VSS.n1206 8.5005
R8789 VSS.n3079 VSS.n1205 8.5005
R8790 VSS.n3079 VSS.n1204 8.5005
R8791 VSS.n3079 VSS.n1203 8.5005
R8792 VSS.n3079 VSS.n1200 8.5005
R8793 VSS.n3079 VSS.n1197 8.5005
R8794 VSS.n3079 VSS.n1196 8.5005
R8795 VSS.n3079 VSS.n1188 8.5005
R8796 VSS.n52 VSS.n47 0.00133332
R8797 VSS.n98 VSS.n2176 8.5005
R8798 VSS.n98 VSS.n2177 8.5005
R8799 VSS.n98 VSS.n2357 8.5005
R8800 VSS.n98 VSS.n2181 8.5005
R8801 VSS.n98 VSS.n2182 8.5005
R8802 VSS.n98 VSS.n2356 8.5005
R8803 VSS.n98 VSS.n2183 8.5005
R8804 VSS.n98 VSS.n2355 8.5005
R8805 VSS.n98 VSS.n2184 8.5005
R8806 VSS.n98 VSS.n2354 8.5005
R8807 VSS.n98 VSS.n2185 8.5005
R8808 VSS.n98 VSS.n2353 8.5005
R8809 VSS.n98 VSS.n2188 8.5005
R8810 VSS.n98 VSS.n2189 8.5005
R8811 VSS.n98 VSS.n2352 8.5005
R8812 VSS.n98 VSS.n2190 8.5005
R8813 VSS.n98 VSS.n2351 8.5005
R8814 VSS.n98 VSS.n2191 8.5005
R8815 VSS.n98 VSS.n2350 8.5005
R8816 VSS.n98 VSS.n2192 8.5005
R8817 VSS.n98 VSS.n2349 8.5005
R8818 VSS.n98 VSS.n2195 8.5005
R8819 VSS.n98 VSS.n2196 8.5005
R8820 VSS.n98 VSS.n2348 8.5005
R8821 VSS.n98 VSS.n2197 8.5005
R8822 VSS.n98 VSS.n2347 8.5005
R8823 VSS.n98 VSS.n2198 8.5005
R8824 VSS.n98 VSS.n2346 8.5005
R8825 VSS.n98 VSS.n2199 8.5005
R8826 VSS.n98 VSS.n2345 8.5005
R8827 VSS.n98 VSS.n2202 8.5005
R8828 VSS.n98 VSS.n2203 8.5005
R8829 VSS.n98 VSS.n2344 8.5005
R8830 VSS.n98 VSS.n2204 8.5005
R8831 VSS.n98 VSS.n2343 8.5005
R8832 VSS.n98 VSS.n2205 8.5005
R8833 VSS.n98 VSS.n2342 8.5005
R8834 VSS.n98 VSS.n2206 8.5005
R8835 VSS.n98 VSS.n2341 8.5005
R8836 VSS.n98 VSS.n2209 8.5005
R8837 VSS.n98 VSS.n2210 8.5005
R8838 VSS.n98 VSS.n2340 8.5005
R8839 VSS.n98 VSS.n2211 8.5005
R8840 VSS.n98 VSS.n2339 8.5005
R8841 VSS.n98 VSS.n2212 8.5005
R8842 VSS.n98 VSS.n2338 8.5005
R8843 VSS.n98 VSS.n2213 8.5005
R8844 VSS.n98 VSS.n2337 8.5005
R8845 VSS.n98 VSS.n2216 8.5005
R8846 VSS.n98 VSS.n2217 8.5005
R8847 VSS.n98 VSS.n2336 8.5005
R8848 VSS.n98 VSS.n2218 8.5005
R8849 VSS.n98 VSS.n2335 8.5005
R8850 VSS.n98 VSS.n2219 8.5005
R8851 VSS.n98 VSS.n2334 8.5005
R8852 VSS.n98 VSS.n2220 8.5005
R8853 VSS.n98 VSS.n2333 8.5005
R8854 VSS.n98 VSS.n2223 8.5005
R8855 VSS.n98 VSS.n2224 8.5005
R8856 VSS.n98 VSS.n2332 8.5005
R8857 VSS.n98 VSS.n2225 8.5005
R8858 VSS.n98 VSS.n2331 8.5005
R8859 VSS.n98 VSS.n2226 8.5005
R8860 VSS.n98 VSS.n2330 8.5005
R8861 VSS.n98 VSS.n2227 8.5005
R8862 VSS.n98 VSS.n2329 8.5005
R8863 VSS.n98 VSS.n2230 8.5005
R8864 VSS.n98 VSS.n2231 8.5005
R8865 VSS.n98 VSS.n2328 8.5005
R8866 VSS.n98 VSS.n2232 8.5005
R8867 VSS.n98 VSS.n2327 8.5005
R8868 VSS.n98 VSS.n2233 8.5005
R8869 VSS.n98 VSS.n2326 8.5005
R8870 VSS.n98 VSS.n2234 8.5005
R8871 VSS.n98 VSS.n2325 8.5005
R8872 VSS.n98 VSS.n2237 8.5005
R8873 VSS.n98 VSS.n2238 8.5005
R8874 VSS.n98 VSS.n2324 8.5005
R8875 VSS.n98 VSS.n2239 8.5005
R8876 VSS.n98 VSS.n2323 8.5005
R8877 VSS.n98 VSS.n2240 8.5005
R8878 VSS.n98 VSS.n2322 8.5005
R8879 VSS.n98 VSS.n2241 8.5005
R8880 VSS.n98 VSS.n2321 8.5005
R8881 VSS.n98 VSS.n2244 8.5005
R8882 VSS.n98 VSS.n2245 8.5005
R8883 VSS.n98 VSS.n2320 8.5005
R8884 VSS.n98 VSS.n2246 8.5005
R8885 VSS.n98 VSS.n2319 8.5005
R8886 VSS.n98 VSS.n2247 8.5005
R8887 VSS.n98 VSS.n2318 8.5005
R8888 VSS.n98 VSS.n2248 8.5005
R8889 VSS.n98 VSS.n2317 8.5005
R8890 VSS.n98 VSS.n2251 8.5005
R8891 VSS.n98 VSS.n2252 8.5005
R8892 VSS.n98 VSS.n2316 8.5005
R8893 VSS.n98 VSS.n2253 8.5005
R8894 VSS.n98 VSS.n2315 8.5005
R8895 VSS.n98 VSS.n2254 8.5005
R8896 VSS.n98 VSS.n2314 8.5005
R8897 VSS.n98 VSS.n2255 8.5005
R8898 VSS.n98 VSS.n2313 8.5005
R8899 VSS.n98 VSS.n2258 8.5005
R8900 VSS.n98 VSS.n2259 8.5005
R8901 VSS.n98 VSS.n2312 8.5005
R8902 VSS.n98 VSS.n2260 8.5005
R8903 VSS.n98 VSS.n2311 8.5005
R8904 VSS.n98 VSS.n2261 8.5005
R8905 VSS.n98 VSS.n2310 8.5005
R8906 VSS.n98 VSS.n2262 8.5005
R8907 VSS.n98 VSS.n2309 8.5005
R8908 VSS.n98 VSS.n2265 8.5005
R8909 VSS.n98 VSS.n2266 8.5005
R8910 VSS.n98 VSS.n2308 8.5005
R8911 VSS.n98 VSS.n2267 8.5005
R8912 VSS.n98 VSS.n2307 8.5005
R8913 VSS.n98 VSS.n2268 8.5005
R8914 VSS.n98 VSS.n2306 8.5005
R8915 VSS.n98 VSS.n2269 8.5005
R8916 VSS.n98 VSS.n2305 8.5005
R8917 VSS.n98 VSS.n2272 8.5005
R8918 VSS.n98 VSS.n2273 8.5005
R8919 VSS.n98 VSS.n2304 8.5005
R8920 VSS.n98 VSS.n2274 8.5005
R8921 VSS.n98 VSS.n2303 8.5005
R8922 VSS.n98 VSS.n2275 8.5005
R8923 VSS.n98 VSS.n2302 8.5005
R8924 VSS.n98 VSS.n2276 8.5005
R8925 VSS.n98 VSS.n2301 8.5005
R8926 VSS.n98 VSS.n2279 8.5005
R8927 VSS.n98 VSS.n2280 8.5005
R8928 VSS.n98 VSS.n2300 8.5005
R8929 VSS.n98 VSS.n2281 8.5005
R8930 VSS.n98 VSS.n2299 8.5005
R8931 VSS.n98 VSS.n2282 8.5005
R8932 VSS.n98 VSS.n2298 8.5005
R8933 VSS.n98 VSS.n2283 8.5005
R8934 VSS.n98 VSS.n2297 8.5005
R8935 VSS.n98 VSS.n2286 8.5005
R8936 VSS.n98 VSS.n2287 8.5005
R8937 VSS.n98 VSS.n2296 8.5005
R8938 VSS.n98 VSS.n2288 8.5005
R8939 VSS.n98 VSS.n2295 8.5005
R8940 VSS.n98 VSS.n2289 8.5005
R8941 VSS.n98 VSS.n2294 8.5005
R8942 VSS.n98 VSS.n2292 8.5005
R8943 VSS.n2841 VSS.n2443 8.5005
R8944 VSS.n2841 VSS.n2447 8.5005
R8945 VSS.n2841 VSS.n2448 8.5005
R8946 VSS.n2841 VSS.n2451 8.5005
R8947 VSS.n2841 VSS.n2455 8.5005
R8948 VSS.n2841 VSS.n2456 8.5005
R8949 VSS.n2841 VSS.n2457 8.5005
R8950 VSS.n2841 VSS.n2458 8.5005
R8951 VSS.n2841 VSS.n2460 8.5005
R8952 VSS.n2841 VSS.n2461 8.5005
R8953 VSS.n2841 VSS.n2464 8.5005
R8954 VSS.n2841 VSS.n2465 8.5005
R8955 VSS.n2841 VSS.n2468 8.5005
R8956 VSS.n2841 VSS.n2471 8.5005
R8957 VSS.n2841 VSS.n2472 8.5005
R8958 VSS.n2841 VSS.n2473 8.5005
R8959 VSS.n2841 VSS.n2475 8.5005
R8960 VSS.n2841 VSS.n2476 8.5005
R8961 VSS.n2841 VSS.n2477 8.5005
R8962 VSS.n2841 VSS.n2480 8.5005
R8963 VSS.n2841 VSS.n2481 8.5005
R8964 VSS.n2841 VSS.n2484 8.5005
R8965 VSS.n2841 VSS.n2487 8.5005
R8966 VSS.n2841 VSS.n2488 8.5005
R8967 VSS.n2841 VSS.n2489 8.5005
R8968 VSS.n2841 VSS.n2490 8.5005
R8969 VSS.n2841 VSS.n2491 8.5005
R8970 VSS.n2841 VSS.n2493 8.5005
R8971 VSS.n2841 VSS.n2496 8.5005
R8972 VSS.n2841 VSS.n2497 8.5005
R8973 VSS.n2841 VSS.n2499 8.5005
R8974 VSS.n2841 VSS.n2503 8.5005
R8975 VSS.n2841 VSS.n2504 8.5005
R8976 VSS.n2841 VSS.n2505 8.5005
R8977 VSS.n2841 VSS.n2506 8.5005
R8978 VSS.n2841 VSS.n2507 8.5005
R8979 VSS.n2841 VSS.n2509 8.5005
R8980 VSS.n2841 VSS.n2512 8.5005
R8981 VSS.n2841 VSS.n2513 8.5005
R8982 VSS.n2841 VSS.n2515 8.5005
R8983 VSS.n2841 VSS.n2519 8.5005
R8984 VSS.n2841 VSS.n2520 8.5005
R8985 VSS.n2841 VSS.n2521 8.5005
R8986 VSS.n2841 VSS.n2522 8.5005
R8987 VSS.n2841 VSS.n2523 8.5005
R8988 VSS.n2841 VSS.n2525 8.5005
R8989 VSS.n2841 VSS.n2528 8.5005
R8990 VSS.n2841 VSS.n2529 8.5005
R8991 VSS.n2841 VSS.n2531 8.5005
R8992 VSS.n2841 VSS.n2535 8.5005
R8993 VSS.n2841 VSS.n2536 8.5005
R8994 VSS.n2841 VSS.n2537 8.5005
R8995 VSS.n2841 VSS.n2538 8.5005
R8996 VSS.n2841 VSS.n2540 8.5005
R8997 VSS.n2841 VSS.n2541 8.5005
R8998 VSS.n2841 VSS.n2544 8.5005
R8999 VSS.n2841 VSS.n2545 8.5005
R9000 VSS.n2841 VSS.n2548 8.5005
R9001 VSS.n2841 VSS.n2551 8.5005
R9002 VSS.n2841 VSS.n2552 8.5005
R9003 VSS.n2841 VSS.n2553 8.5005
R9004 VSS.n2841 VSS.n2554 8.5005
R9005 VSS.n2841 VSS.n2555 8.5005
R9006 VSS.n2841 VSS.n2557 8.5005
R9007 VSS.n2841 VSS.n2560 8.5005
R9008 VSS.n2841 VSS.n2561 8.5005
R9009 VSS.n2841 VSS.n2563 8.5005
R9010 VSS.n2841 VSS.n2567 8.5005
R9011 VSS.n2841 VSS.n2568 8.5005
R9012 VSS.n2841 VSS.n2569 8.5005
R9013 VSS.n2841 VSS.n2570 8.5005
R9014 VSS.n2841 VSS.n2571 8.5005
R9015 VSS.n2841 VSS.n2573 8.5005
R9016 VSS.n2841 VSS.n2576 8.5005
R9017 VSS.n2841 VSS.n2577 8.5005
R9018 VSS.n2841 VSS.n2580 8.5005
R9019 VSS.n2841 VSS.n2583 8.5005
R9020 VSS.n2841 VSS.n2584 8.5005
R9021 VSS.n2841 VSS.n2585 8.5005
R9022 VSS.n2841 VSS.n2587 8.5005
R9023 VSS.n2841 VSS.n2588 8.5005
R9024 VSS.n2841 VSS.n2589 8.5005
R9025 VSS.n2841 VSS.n2592 8.5005
R9026 VSS.n2841 VSS.n2593 8.5005
R9027 VSS.n2841 VSS.n2595 8.5005
R9028 VSS.n2841 VSS.n2599 8.5005
R9029 VSS.n2841 VSS.n2600 8.5005
R9030 VSS.n2841 VSS.n2601 8.5005
R9031 VSS.n2841 VSS.n2602 8.5005
R9032 VSS.n2841 VSS.n2603 8.5005
R9033 VSS.n2841 VSS.n2605 8.5005
R9034 VSS.n2841 VSS.n2608 8.5005
R9035 VSS.n2841 VSS.n2609 8.5005
R9036 VSS.n2841 VSS.n2611 8.5005
R9037 VSS.n2841 VSS.n2615 8.5005
R9038 VSS.n2841 VSS.n2616 8.5005
R9039 VSS.n2841 VSS.n2617 8.5005
R9040 VSS.n2841 VSS.n2618 8.5005
R9041 VSS.n2841 VSS.n2619 8.5005
R9042 VSS.n2841 VSS.n2621 8.5005
R9043 VSS.n2841 VSS.n2624 8.5005
R9044 VSS.n2841 VSS.n2625 8.5005
R9045 VSS.n2841 VSS.n2628 8.5005
R9046 VSS.n2841 VSS.n2631 8.5005
R9047 VSS.n2841 VSS.n2632 8.5005
R9048 VSS.n2841 VSS.n2633 8.5005
R9049 VSS.n2841 VSS.n2635 8.5005
R9050 VSS.n2841 VSS.n2636 8.5005
R9051 VSS.n2841 VSS.n2637 8.5005
R9052 VSS.n2841 VSS.n2640 8.5005
R9053 VSS.n2841 VSS.n2641 8.5005
R9054 VSS.n2841 VSS.n2643 8.5005
R9055 VSS.n2841 VSS.n2647 8.5005
R9056 VSS.n2841 VSS.n2648 8.5005
R9057 VSS.n2841 VSS.n2649 8.5005
R9058 VSS.n2841 VSS.n2650 8.5005
R9059 VSS.n2841 VSS.n2651 8.5005
R9060 VSS.n2841 VSS.n2653 8.5005
R9061 VSS.n2841 VSS.n2656 8.5005
R9062 VSS.n2841 VSS.n2657 8.5005
R9063 VSS.n2841 VSS.n2659 8.5005
R9064 VSS.n2841 VSS.n2663 8.5005
R9065 VSS.n2841 VSS.n2664 8.5005
R9066 VSS.n2841 VSS.n2665 8.5005
R9067 VSS.n2841 VSS.n2666 8.5005
R9068 VSS.n2841 VSS.n2668 8.5005
R9069 VSS.n2841 VSS.n2669 8.5005
R9070 VSS.n2841 VSS.n2672 8.5005
R9071 VSS.n2841 VSS.n2673 8.5005
R9072 VSS.n2841 VSS.n2676 8.5005
R9073 VSS.n2841 VSS.n2679 8.5005
R9074 VSS.n2841 VSS.n2680 8.5005
R9075 VSS.n2841 VSS.n2681 8.5005
R9076 VSS.n2841 VSS.n2683 8.5005
R9077 VSS.n2841 VSS.n2684 8.5005
R9078 VSS.n2841 VSS.n2685 8.5005
R9079 VSS.n2841 VSS.n2688 8.5005
R9080 VSS.n2841 VSS.n2689 8.5005
R9081 VSS.n2841 VSS.n2691 8.5005
R9082 VSS.n2841 VSS.n2695 8.5005
R9083 VSS.n2841 VSS.n2696 8.5005
R9084 VSS.n2841 VSS.n2697 8.5005
R9085 VSS.n2841 VSS.n2698 8.5005
R9086 VSS.n2841 VSS.n2699 8.5005
R9087 VSS.n2841 VSS.n2700 8.5005
R9088 VSS.n1624 VSS.n74 8.5005
R9089 VSS.n2123 VSS.n74 8.5005
R9090 VSS.n2124 VSS.n74 8.5005
R9091 VSS.n2120 VSS.n74 8.5005
R9092 VSS.n2121 VSS.n74 8.5005
R9093 VSS.n2117 VSS.n74 8.5005
R9094 VSS.n2118 VSS.n74 8.5005
R9095 VSS.n2114 VSS.n74 8.5005
R9096 VSS.n2115 VSS.n74 8.5005
R9097 VSS.n2111 VSS.n74 8.5005
R9098 VSS.n2112 VSS.n74 8.5005
R9099 VSS.n2108 VSS.n74 8.5005
R9100 VSS.n2109 VSS.n74 8.5005
R9101 VSS.n2105 VSS.n74 8.5005
R9102 VSS.n2106 VSS.n74 8.5005
R9103 VSS.n2102 VSS.n74 8.5005
R9104 VSS.n2103 VSS.n74 8.5005
R9105 VSS.n2099 VSS.n74 8.5005
R9106 VSS.n2100 VSS.n74 8.5005
R9107 VSS.n2096 VSS.n74 8.5005
R9108 VSS.n2097 VSS.n74 8.5005
R9109 VSS.n2093 VSS.n74 8.5005
R9110 VSS.n2094 VSS.n74 8.5005
R9111 VSS.n2090 VSS.n74 8.5005
R9112 VSS.n2091 VSS.n74 8.5005
R9113 VSS.n2088 VSS.n74 8.5005
R9114 VSS.t929 VSS.n74 8.5005
R9115 VSS.n1642 VSS.n74 8.5005
R9116 VSS.n2084 VSS.n74 8.5005
R9117 VSS.n2085 VSS.n74 8.5005
R9118 VSS.n2081 VSS.n74 8.5005
R9119 VSS.n2082 VSS.n74 8.5005
R9120 VSS.n2078 VSS.n74 8.5005
R9121 VSS.n2079 VSS.n74 8.5005
R9122 VSS.n2075 VSS.n74 8.5005
R9123 VSS.n2076 VSS.n74 8.5005
R9124 VSS.n2072 VSS.n74 8.5005
R9125 VSS.n2073 VSS.n74 8.5005
R9126 VSS.n2069 VSS.n74 8.5005
R9127 VSS.n2070 VSS.n74 8.5005
R9128 VSS.n2065 VSS.n74 8.5005
R9129 VSS.n2066 VSS.n74 8.5005
R9130 VSS.n2062 VSS.n74 8.5005
R9131 VSS.n2063 VSS.n74 8.5005
R9132 VSS.n2059 VSS.n74 8.5005
R9133 VSS.n2060 VSS.n74 8.5005
R9134 VSS.n2011 VSS.n74 8.5005
R9135 VSS.n2013 VSS.n74 8.5005
R9136 VSS.n2015 VSS.n74 8.5005
R9137 VSS.n2017 VSS.n74 8.5005
R9138 VSS.n2019 VSS.n74 8.5005
R9139 VSS.n2021 VSS.n74 8.5005
R9140 VSS.n2023 VSS.n74 8.5005
R9141 VSS.n2025 VSS.n74 8.5005
R9142 VSS.n2027 VSS.n74 8.5005
R9143 VSS.n2029 VSS.n74 8.5005
R9144 VSS.n2031 VSS.n74 8.5005
R9145 VSS.n2033 VSS.n74 8.5005
R9146 VSS.n2035 VSS.n74 8.5005
R9147 VSS.n2037 VSS.n74 8.5005
R9148 VSS.n2039 VSS.n74 8.5005
R9149 VSS.n2041 VSS.n74 8.5005
R9150 VSS.n2043 VSS.n74 8.5005
R9151 VSS.n2045 VSS.n74 8.5005
R9152 VSS.n2047 VSS.n74 8.5005
R9153 VSS.n2049 VSS.n74 8.5005
R9154 VSS.t920 VSS.n74 8.5005
R9155 VSS.n2052 VSS.n74 8.5005
R9156 VSS.n2054 VSS.n74 8.5005
R9157 VSS.n2055 VSS.n74 8.5005
R9158 VSS.n2008 VSS.n74 8.5005
R9159 VSS.n2009 VSS.n74 8.5005
R9160 VSS.n2005 VSS.n74 8.5005
R9161 VSS.n2006 VSS.n74 8.5005
R9162 VSS.n2002 VSS.n74 8.5005
R9163 VSS.n2003 VSS.n74 8.5005
R9164 VSS.n1999 VSS.n74 8.5005
R9165 VSS.n2000 VSS.n74 8.5005
R9166 VSS.n1996 VSS.n74 8.5005
R9167 VSS.n1997 VSS.n74 8.5005
R9168 VSS.n1992 VSS.n74 8.5005
R9169 VSS.n1993 VSS.n74 8.5005
R9170 VSS.n1989 VSS.n74 8.5005
R9171 VSS.n1990 VSS.n74 8.5005
R9172 VSS.n1986 VSS.n74 8.5005
R9173 VSS.n1987 VSS.n74 8.5005
R9174 VSS.n1938 VSS.n74 8.5005
R9175 VSS.n1940 VSS.n74 8.5005
R9176 VSS.n1942 VSS.n74 8.5005
R9177 VSS.n1944 VSS.n74 8.5005
R9178 VSS.n1946 VSS.n74 8.5005
R9179 VSS.n1948 VSS.n74 8.5005
R9180 VSS.n1950 VSS.n74 8.5005
R9181 VSS.n1952 VSS.n74 8.5005
R9182 VSS.n1954 VSS.n74 8.5005
R9183 VSS.n1956 VSS.n74 8.5005
R9184 VSS.n1958 VSS.n74 8.5005
R9185 VSS.n1960 VSS.n74 8.5005
R9186 VSS.n1962 VSS.n74 8.5005
R9187 VSS.n1964 VSS.n74 8.5005
R9188 VSS.n1966 VSS.n74 8.5005
R9189 VSS.n1968 VSS.n74 8.5005
R9190 VSS.n1970 VSS.n74 8.5005
R9191 VSS.n1972 VSS.n74 8.5005
R9192 VSS.n1974 VSS.n74 8.5005
R9193 VSS.n1976 VSS.n74 8.5005
R9194 VSS.t911 VSS.n74 8.5005
R9195 VSS.n1979 VSS.n74 8.5005
R9196 VSS.n1981 VSS.n74 8.5005
R9197 VSS.n1982 VSS.n74 8.5005
R9198 VSS.n1935 VSS.n74 8.5005
R9199 VSS.n1936 VSS.n74 8.5005
R9200 VSS.n1932 VSS.n74 8.5005
R9201 VSS.n1933 VSS.n74 8.5005
R9202 VSS.n1929 VSS.n74 8.5005
R9203 VSS.n1930 VSS.n74 8.5005
R9204 VSS.n1926 VSS.n74 8.5005
R9205 VSS.n1927 VSS.n74 8.5005
R9206 VSS.n1923 VSS.n74 8.5005
R9207 VSS.n1924 VSS.n74 8.5005
R9208 VSS.n1919 VSS.n74 8.5005
R9209 VSS.n1920 VSS.n74 8.5005
R9210 VSS.n1916 VSS.n74 8.5005
R9211 VSS.n1917 VSS.n74 8.5005
R9212 VSS.n1913 VSS.n74 8.5005
R9213 VSS.n1914 VSS.n74 8.5005
R9214 VSS.n1822 VSS.n74 8.5005
R9215 VSS.n1824 VSS.n74 8.5005
R9216 VSS.n1826 VSS.n74 8.5005
R9217 VSS.n1828 VSS.n74 8.5005
R9218 VSS.n1830 VSS.n74 8.5005
R9219 VSS.n1832 VSS.n74 8.5005
R9220 VSS.n1834 VSS.n74 8.5005
R9221 VSS.n1836 VSS.n74 8.5005
R9222 VSS.n1838 VSS.n74 8.5005
R9223 VSS.n1840 VSS.n74 8.5005
R9224 VSS.n1842 VSS.n74 8.5005
R9225 VSS.n1844 VSS.n74 8.5005
R9226 VSS.n1846 VSS.n74 8.5005
R9227 VSS.n1848 VSS.n74 8.5005
R9228 VSS.n1850 VSS.n74 8.5005
R9229 VSS.n1852 VSS.n74 8.5005
R9230 VSS.n1854 VSS.n74 8.5005
R9231 VSS.n1856 VSS.n74 8.5005
R9232 VSS.n1858 VSS.n74 8.5005
R9233 VSS.n1860 VSS.n74 8.5005
R9234 VSS.n1862 VSS.n74 8.5005
R9235 VSS.n1864 VSS.n74 8.5005
R9236 VSS.n1866 VSS.n74 8.5005
R9237 VSS.n1868 VSS.n74 8.5005
R9238 VSS.n1870 VSS.n74 8.5005
R9239 VSS.n1872 VSS.n74 8.5005
R9240 VSS.n1874 VSS.n74 8.5005
R9241 VSS.n1876 VSS.n74 8.5005
R9242 VSS.n1878 VSS.n74 8.5005
R9243 VSS.n1880 VSS.n74 8.5005
R9244 VSS.n1882 VSS.n74 8.5005
R9245 VSS.n1884 VSS.n74 8.5005
R9246 VSS.n8 VSS.n1602 8.5005
R9247 VSS.n8 VSS.n1591 8.5005
R9248 VSS.n8 VSS.n1575 8.48883
R9249 VSS.n1576 VSS.n8 8.48883
R9250 VSS.n51 VSS.n2907 8.48385
R9251 VSS.n2972 VSS.n25 8.48291
R9252 VSS.n382 VSS.n722 8.48012
R9253 VSS.n293 VSS.n1038 8.48012
R9254 VSS.n3079 VSS.n1182 8.48012
R9255 VSS.n98 VSS.n2290 8.48012
R9256 VSS.t1556 VSS.n72 8.47784
R9257 VSS.n2865 VSS.n77 8.47784
R9258 VSS.n2866 VSS.n79 8.47784
R9259 VSS.n2867 VSS.n81 8.47784
R9260 VSS.n2868 VSS.n80 8.47784
R9261 VSS.n2869 VSS.n82 8.47784
R9262 VSS.n2870 VSS.n84 8.47784
R9263 VSS.n2871 VSS.n85 8.47784
R9264 VSS.n2872 VSS.n86 8.47784
R9265 VSS.n2873 VSS.n87 8.47784
R9266 VSS.n2874 VSS.n88 8.47784
R9267 VSS.n2875 VSS.n89 8.47784
R9268 VSS.n2876 VSS.n91 8.47784
R9269 VSS.n2877 VSS.n90 8.47784
R9270 VSS.n2879 VSS.n94 8.47784
R9271 VSS.n2880 VSS.n93 8.47784
R9272 VSS.n382 VSS.n638 8.47732
R9273 VSS.n382 VSS.t2400 8.47732
R9274 VSS.n721 VSS.n379 8.47732
R9275 VSS.n383 VSS.n381 8.47732
R9276 VSS.n382 VSS.n600 8.47732
R9277 VSS.n382 VSS.n601 8.47732
R9278 VSS.n382 VSS.n635 8.47732
R9279 VSS.n293 VSS.n1109 8.47732
R9280 VSS.n293 VSS.t2387 8.47732
R9281 VSS.n292 VSS.n291 4.19564
R9282 VSS.n293 VSS.n887 8.47732
R9283 VSS.n293 VSS.n888 8.47732
R9284 VSS.n293 VSS.n922 8.47732
R9285 VSS.n3079 VSS.n1183 8.47732
R9286 VSS.n3079 VSS.t2375 8.47732
R9287 VSS.n1527 VSS.n185 8.47732
R9288 VSS.n1528 VSS.n186 8.47732
R9289 VSS.n3079 VSS.n1449 8.47732
R9290 VSS.n3079 VSS.n1447 8.47732
R9291 VSS.n3079 VSS.n1187 8.47732
R9292 VSS.n3053 VSS.n47 8.47732
R9293 VSS.n1569 VSS.n47 8.47732
R9294 VSS.n98 VSS.n2361 8.47732
R9295 VSS.n98 VSS.t2340 8.47732
R9296 VSS.n97 VSS.n96 4.19564
R9297 VSS.n98 VSS.n2139 8.47732
R9298 VSS.n98 VSS.n2140 8.47732
R9299 VSS.n98 VSS.n2174 8.47732
R9300 VSS.n2841 VSS.n2442 8.47732
R9301 VSS.n2841 VSS.n2702 8.47732
R9302 VSS.n2841 VSS.n2816 8.47732
R9303 VSS.n2841 VSS.t2328 8.47732
R9304 VSS.n2863 VSS.n74 8.47732
R9305 VSS.n8 VSS.n1580 8.47732
R9306 VSS.n8 VSS.n1582 8.47732
R9307 VSS.n8 VSS.n1584 8.47732
R9308 VSS.n8 VSS.n1590 8.47732
R9309 VSS.n8 VSS.n1603 8.47732
R9310 VSS.n8 VSS.n1592 8.47732
R9311 VSS.t18 VSS.n10 0.141785
R9312 VSS.n3024 VSS.n31 8.47732
R9313 VSS.t19 VSS.n33 8.47732
R9314 VSS.n3019 VSS.n35 8.47732
R9315 VSS.n12 VSS.n11 3.32615
R9316 VSS.n3018 VSS.n37 8.47732
R9317 VSS.t23 VSS.n38 8.47732
R9318 VSS.n40 VSS.t24 8.47732
R9319 VSS.n14 VSS.n13 4.19225
R9320 VSS.n3017 VSS.n41 8.47732
R9321 VSS.n3029 VSS.n44 8.47732
R9322 VSS.n3030 VSS.n43 8.47732
R9323 VSS.n51 VSS.n2906 8.47732
R9324 VSS.n53 VSS.t2349 8.47732
R9325 VSS.n56 VSS.n3007 8.47732
R9326 VSS.n57 VSS.n3006 8.47732
R9327 VSS.n58 VSS.n3005 8.47732
R9328 VSS.n59 VSS.n3004 8.47732
R9329 VSS.n60 VSS.n3003 8.47732
R9330 VSS.n15 VSS.n16 4.19225
R9331 VSS.t15 VSS.n63 8.47732
R9332 VSS.n3000 VSS.n65 8.47732
R9333 VSS.n3010 VSS.n68 8.47732
R9334 VSS.n3012 VSS.n70 8.47732
R9335 VSS.n19 VSS.n18 4.19225
R9336 VSS.n28 VSS.n2953 8.47732
R9337 VSS.n2971 VSS.n24 8.47732
R9338 VSS.n22 VSS.n21 3.32623
R9339 VSS.n2966 VSS.n2965 8.47732
R9340 VSS.n28 VSS.n2974 8.46924
R9341 VSS.n2839 VSS.n2374 6.99673
R9342 VSS.n1891 VSS.n1890 6.99351
R9343 VSS.n1787 VSS.n1786 6.99351
R9344 VSS.t2131 VSS.n1781 6.99351
R9345 VSS.n1798 VSS.t682 6.97724
R9346 VSS.n1900 VSS.n1899 6.97724
R9347 VSS.n636 VSS.n472 6.85916
R9348 VSS.n2854 VSS.n2853 6.85916
R9349 VSS.n3048 VSS.n3047 6.85916
R9350 VSS.n3044 VSS.n3043 6.85916
R9351 VSS.t908 VSS.n1675 6.61977
R9352 VSS.t1529 VSS.n1980 6.61977
R9353 VSS.t917 VSS.n1661 6.61977
R9354 VSS.t926 VSS.n1647 6.61977
R9355 VSS.n3126 VSS.n837 5.90311
R9356 VSS.n3091 VSS.n3090 5.90311
R9357 VSS.n2850 VSS.n2849 5.90311
R9358 VSS.n78 VSS.n76 0.00268168
R9359 VSS.n95 VSS.n92 0.00229996
R9360 VSS.n2862 VSS.n2861 5.66778
R9361 VSS.n30 VSS.n9 0.00229996
R9362 VSS.n32 VSS.n3023 0.00229996
R9363 VSS.n34 VSS.n3020 0.00249991
R9364 VSS.n39 VSS.n3026 0.00268168
R9365 VSS.n42 VSS.n3028 0.00264986
R9366 VSS.n55 VSS.n54 0.894636
R9367 VSS.n3008 VSS.n61 0.00229996
R9368 VSS.n66 VSS.n62 0.00229996
R9369 VSS.n69 VSS.n64 0.00229996
R9370 VSS.n71 VSS.n67 0.00261098
R9371 VSS.n3031 VSS.n20 5.66778
R9372 VSS.n3031 VSS.n2892 5.66778
R9373 VSS.n3031 VSS.n2891 5.66778
R9374 VSS.n3061 VSS.n47 5.66767
R9375 VSS.n44 VSS.n43 0.00139998
R9376 VSS.n2964 VSS.n2963 5.64619
R9377 VSS.n3079 VSS.n1529 5.63915
R9378 VSS.n382 VSS.n599 5.63915
R9379 VSS.n293 VSS.n886 5.63915
R9380 VSS.n98 VSS.n2138 5.63915
R9381 VSS.n2864 VSS.n76 5.62674
R9382 VSS.n2878 VSS.n92 5.62674
R9383 VSS.n3060 VSS.n1564 5.62581
R9384 VSS.n2841 VSS.n2818 5.62581
R9385 VSS.n8 VSS.n1589 5.62581
R9386 VSS.n10 VSS.n9 3.32623
R9387 VSS.n3022 VSS.n3023 5.62581
R9388 VSS.n3021 VSS.n3020 5.62581
R9389 VSS.t21 VSS.n12 0.0945573
R9390 VSS.n3026 VSS.n3025 5.62581
R9391 VSS.t25 VSS.n3028 5.62581
R9392 VSS.n3008 VSS.n3001 5.62581
R9393 VSS.n3009 VSS.n62 5.62581
R9394 VSS.t16 VSS.n64 5.62581
R9395 VSS.n3011 VSS.n67 5.62581
R9396 VSS.n3013 VSS.n17 5.62581
R9397 VSS.n2968 VSS.n2967 5.62581
R9398 VSS.t2235 VSS.n2893 5.48496
R9399 VSS.n1885 VSS.n1884 5.14882
R9400 VSS.n1883 VSS.n1882 5.14882
R9401 VSS.n1881 VSS.n1880 5.14882
R9402 VSS.n1879 VSS.n1878 5.14882
R9403 VSS.n1877 VSS.n1876 5.14882
R9404 VSS.n1875 VSS.n1874 5.14882
R9405 VSS.n1873 VSS.n1872 5.14882
R9406 VSS.n1871 VSS.n1870 5.14882
R9407 VSS.n1869 VSS.n1868 5.14882
R9408 VSS.n1867 VSS.n1866 5.14882
R9409 VSS.n1865 VSS.n1864 5.14882
R9410 VSS.n1861 VSS.n1860 5.14882
R9411 VSS.n1859 VSS.n1858 5.14882
R9412 VSS.n1857 VSS.n1856 5.14882
R9413 VSS.n1855 VSS.n1854 5.14882
R9414 VSS.n1853 VSS.n1852 5.14882
R9415 VSS.n1851 VSS.n1850 5.14882
R9416 VSS.n1849 VSS.n1848 5.14882
R9417 VSS.n1847 VSS.n1846 5.14882
R9418 VSS.n1845 VSS.n1844 5.14882
R9419 VSS.n1843 VSS.n1842 5.14882
R9420 VSS.n1841 VSS.n1840 5.14882
R9421 VSS.n1839 VSS.n1838 5.14882
R9422 VSS.n1837 VSS.n1836 5.14882
R9423 VSS.n1835 VSS.n1834 5.14882
R9424 VSS.n1833 VSS.n1832 5.14882
R9425 VSS.n1831 VSS.n1830 5.14882
R9426 VSS.n1829 VSS.n1828 5.14882
R9427 VSS.n1827 VSS.n1826 5.14882
R9428 VSS.n1825 VSS.n1824 5.14882
R9429 VSS.n1823 VSS.n1822 5.14882
R9430 VSS.n1914 VSS.n1682 5.14882
R9431 VSS.n1915 VSS.n1913 5.14882
R9432 VSS.n1917 VSS.n1681 5.14882
R9433 VSS.n1918 VSS.n1916 5.14882
R9434 VSS.n1920 VSS.n1680 5.14882
R9435 VSS.n1921 VSS.n1919 5.14882
R9436 VSS.n1924 VSS.n1677 5.14882
R9437 VSS.n1925 VSS.n1923 5.14882
R9438 VSS.n1927 VSS.n1676 5.14882
R9439 VSS.n1928 VSS.n1926 5.14882
R9440 VSS.n1930 VSS.n1675 5.14882
R9441 VSS.n1931 VSS.n1929 5.14882
R9442 VSS.n1933 VSS.n1674 5.14882
R9443 VSS.n1934 VSS.n1932 5.14882
R9444 VSS.n1936 VSS.n1673 5.14882
R9445 VSS.n1937 VSS.n1935 5.14882
R9446 VSS.n1982 VSS.n1672 5.14882
R9447 VSS.n1983 VSS.n1981 5.14882
R9448 VSS.n1980 VSS.n1979 5.14882
R9449 VSS.n1978 VSS.t911 5.14882
R9450 VSS.n1977 VSS.n1976 5.14882
R9451 VSS.n1975 VSS.n1974 5.14882
R9452 VSS.n1973 VSS.n1972 5.14882
R9453 VSS.n1971 VSS.n1970 5.14882
R9454 VSS.n1969 VSS.n1968 5.14882
R9455 VSS.n1967 VSS.n1966 5.14882
R9456 VSS.n1965 VSS.n1964 5.14882
R9457 VSS.n1963 VSS.n1962 5.14882
R9458 VSS.n1961 VSS.n1960 5.14882
R9459 VSS.n1959 VSS.n1958 5.14882
R9460 VSS.n1957 VSS.n1956 5.14882
R9461 VSS.n1955 VSS.n1954 5.14882
R9462 VSS.n1953 VSS.n1952 5.14882
R9463 VSS.n1951 VSS.n1950 5.14882
R9464 VSS.n1949 VSS.n1948 5.14882
R9465 VSS.n1947 VSS.n1946 5.14882
R9466 VSS.n1945 VSS.n1944 5.14882
R9467 VSS.n1943 VSS.n1942 5.14882
R9468 VSS.n1941 VSS.n1940 5.14882
R9469 VSS.n1939 VSS.n1938 5.14882
R9470 VSS.n1987 VSS.n1668 5.14882
R9471 VSS.n1988 VSS.n1986 5.14882
R9472 VSS.n1990 VSS.n1667 5.14882
R9473 VSS.n1991 VSS.n1989 5.14882
R9474 VSS.n1993 VSS.n1666 5.14882
R9475 VSS.n1994 VSS.n1992 5.14882
R9476 VSS.n1997 VSS.n1663 5.14882
R9477 VSS.n1998 VSS.n1996 5.14882
R9478 VSS.n2000 VSS.n1662 5.14882
R9479 VSS.n2001 VSS.n1999 5.14882
R9480 VSS.n2003 VSS.n1661 5.14882
R9481 VSS.n2004 VSS.n2002 5.14882
R9482 VSS.n2006 VSS.n1660 5.14882
R9483 VSS.n2007 VSS.n2005 5.14882
R9484 VSS.n2009 VSS.n1659 5.14882
R9485 VSS.n2010 VSS.n2008 5.14882
R9486 VSS.n2055 VSS.n1658 5.14882
R9487 VSS.n2056 VSS.n2054 5.14882
R9488 VSS.n2053 VSS.n2052 5.14882
R9489 VSS.n2051 VSS.t920 5.14882
R9490 VSS.n2050 VSS.n2049 5.14882
R9491 VSS.n2048 VSS.n2047 5.14882
R9492 VSS.n2046 VSS.n2045 5.14882
R9493 VSS.n2044 VSS.n2043 5.14882
R9494 VSS.n2042 VSS.n2041 5.14882
R9495 VSS.n2040 VSS.n2039 5.14882
R9496 VSS.n2038 VSS.n2037 5.14882
R9497 VSS.n2036 VSS.n2035 5.14882
R9498 VSS.n2034 VSS.n2033 5.14882
R9499 VSS.n2032 VSS.n2031 5.14882
R9500 VSS.n2030 VSS.n2029 5.14882
R9501 VSS.n2028 VSS.n2027 5.14882
R9502 VSS.n2026 VSS.n2025 5.14882
R9503 VSS.n2024 VSS.n2023 5.14882
R9504 VSS.n2022 VSS.n2021 5.14882
R9505 VSS.n2020 VSS.n2019 5.14882
R9506 VSS.n2018 VSS.n2017 5.14882
R9507 VSS.n2016 VSS.n2015 5.14882
R9508 VSS.n2014 VSS.n2013 5.14882
R9509 VSS.n2012 VSS.n2011 5.14882
R9510 VSS.n2060 VSS.n1654 5.14882
R9511 VSS.n2061 VSS.n2059 5.14882
R9512 VSS.n2063 VSS.n1653 5.14882
R9513 VSS.n2064 VSS.n2062 5.14882
R9514 VSS.n2066 VSS.n1652 5.14882
R9515 VSS.n2067 VSS.n2065 5.14882
R9516 VSS.n2070 VSS.n1649 5.14882
R9517 VSS.n2071 VSS.n2069 5.14882
R9518 VSS.n2073 VSS.n1648 5.14882
R9519 VSS.n2074 VSS.n2072 5.14882
R9520 VSS.n2076 VSS.n1647 5.14882
R9521 VSS.n2077 VSS.n2075 5.14882
R9522 VSS.n2079 VSS.n1646 5.14882
R9523 VSS.n2080 VSS.n2078 5.14882
R9524 VSS.n2082 VSS.n1645 5.14882
R9525 VSS.n2083 VSS.n2081 5.14882
R9526 VSS.n2085 VSS.n1644 5.14882
R9527 VSS.n2086 VSS.n2084 5.14882
R9528 VSS.n1643 VSS.n1642 5.14882
R9529 VSS.t929 VSS.n1641 5.14882
R9530 VSS.n2089 VSS.n2088 5.14882
R9531 VSS.n2091 VSS.n1640 5.14882
R9532 VSS.n2092 VSS.n2090 5.14882
R9533 VSS.n2094 VSS.n1639 5.14882
R9534 VSS.n2095 VSS.n2093 5.14882
R9535 VSS.n2097 VSS.n1638 5.14882
R9536 VSS.n2098 VSS.n2096 5.14882
R9537 VSS.n2100 VSS.n1637 5.14882
R9538 VSS.n2101 VSS.n2099 5.14882
R9539 VSS.n2103 VSS.n1636 5.14882
R9540 VSS.n2104 VSS.n2102 5.14882
R9541 VSS.n2106 VSS.n1635 5.14882
R9542 VSS.n2107 VSS.n2105 5.14882
R9543 VSS.n2109 VSS.n1631 5.14882
R9544 VSS.n2110 VSS.n2108 5.14882
R9545 VSS.n2112 VSS.n1630 5.14882
R9546 VSS.n2113 VSS.n2111 5.14882
R9547 VSS.n2115 VSS.n1629 5.14882
R9548 VSS.n2116 VSS.n2114 5.14882
R9549 VSS.n2118 VSS.n1628 5.14882
R9550 VSS.n2119 VSS.n2117 5.14882
R9551 VSS.n2121 VSS.n1627 5.14882
R9552 VSS.n2122 VSS.n2120 5.14882
R9553 VSS.n2124 VSS.n1626 5.14882
R9554 VSS.n2125 VSS.n2123 5.14882
R9555 VSS.n1625 VSS.n1624 5.14882
R9556 VSS.n2882 VSS.t4 5.13648
R9557 VSS.n1618 VSS.t655 4.98596
R9558 VSS.n75 VSS.n2860 9.09338
R9559 VSS.n3037 VSS.n3036 4.63796
R9560 VSS.t11 VSS.n2882 4.4712
R9561 VSS.t2234 VSS.n1867 4.41335
R9562 VSS.n3182 VSS.t1487 4.28393
R9563 VSS.n1718 VSS.n1717 4.25123
R9564 VSS.n55 VSS.n3002 4.25119
R9565 VSS.n2881 VSS.n74 4.19647
R9566 VSS.n28 VSS.n2957 4.19244
R9567 VSS.n3139 VSS.t1109 4.19225
R9568 VSS.t1099 VSS.n566 4.19225
R9569 VSS.n3154 VSS.t1089 4.19225
R9570 VSS.t1079 VSS.n526 4.19225
R9571 VSS.n3169 VSS.t1069 4.19225
R9572 VSS.n3178 VSS.t1059 4.19225
R9573 VSS.n218 VSS.n217 2.76051
R9574 VSS.n212 VSS.n211 2.76051
R9575 VSS.n206 VSS.n205 2.76051
R9576 VSS.n200 VSS.n199 2.76051
R9577 VSS.n194 VSS.n193 2.76051
R9578 VSS.n188 VSS.n187 2.76051
R9579 VSS.t865 VSS.n2433 4.19225
R9580 VSS.t855 VSS.n2426 4.19225
R9581 VSS.t845 VSS.n2419 4.19225
R9582 VSS.t835 VSS.n2413 4.19225
R9583 VSS.t825 VSS.n2406 4.19225
R9584 VSS.t814 VSS.n2399 4.19225
R9585 VSS.t923 VSS.n2068 4.19225
R9586 VSS.t914 VSS.n1995 4.19225
R9587 VSS.t905 VSS.n1922 4.19225
R9588 VSS.t895 VSS.n1800 4.19225
R9589 VSS.t885 VSS.n1742 4.19225
R9590 VSS.t876 VSS.n1731 4.19225
R9591 VSS.n8 VSS.n1585 4.19225
R9592 VSS.n51 VSS.n2911 4.19225
R9593 VSS.n282 VSS.n283 2.76051
R9594 VSS.n272 VSS.n265 2.76051
R9595 VSS.n249 VSS.n263 2.76051
R9596 VSS.n238 VSS.n246 2.76051
R9597 VSS.n234 VSS.n235 2.76051
R9598 VSS.n224 VSS.n223 2.76051
R9599 VSS.n1819 VSS.t6 4.177
R9600 VSS.n75 VSS.n74 1.30314
R9601 VSS.t92 VSS.n2374 3.84219
R9602 VSS.t189 VSS.n2856 3.84219
R9603 VSS.n3046 VSS.n1534 3.84219
R9604 VSS.n3042 VSS.t1741 3.84219
R9605 VSS.n3182 VSS.n471 3.84119
R9606 VSS.n2852 VSS.t650 3.84041
R9607 VSS.n2855 VSS.t121 3.84041
R9608 VSS.n3045 VSS.t647 3.84041
R9609 VSS.n3041 VSS.t31 3.84041
R9610 VSS VSS.n3182 3.55647
R9611 VSS.n1795 VSS.t1203 3.48887
R9612 VSS.t896 VSS.n1798 3.48887
R9613 VSS.t1806 VSS.n3081 3.3922
R9614 VSS.t1263 VSS.t2332 3.3922
R9615 VSS.n803 VSS.t745 3.34498
R9616 VSS.n800 VSS.t758 3.34498
R9617 VSS.n797 VSS.t1651 3.34498
R9618 VSS.n795 VSS.t2122 3.34498
R9619 VSS.n792 VSS.t626 3.34498
R9620 VSS.n790 VSS.t1146 3.34498
R9621 VSS.n787 VSS.t168 3.34498
R9622 VSS.n785 VSS.t172 3.34498
R9623 VSS.n782 VSS.t290 3.34498
R9624 VSS.n780 VSS.t541 3.34498
R9625 VSS.n777 VSS.t170 3.34498
R9626 VSS.n775 VSS.t1572 3.34498
R9627 VSS.n772 VSS.t1147 3.34498
R9628 VSS.n770 VSS.t292 3.34498
R9629 VSS.n767 VSS.t1570 3.34498
R9630 VSS.n765 VSS.t265 3.34498
R9631 VSS.n762 VSS.t164 3.34498
R9632 VSS.n760 VSS.t166 3.34498
R9633 VSS.n757 VSS.t2137 3.34498
R9634 VSS.n755 VSS.t747 3.34498
R9635 VSS.n752 VSS.t1568 3.34498
R9636 VSS.n750 VSS.t1149 3.34498
R9637 VSS.n747 VSS.t484 3.34498
R9638 VSS.n745 VSS.t545 3.34498
R9639 VSS.n742 VSS.t543 3.34498
R9640 VSS.n740 VSS.t486 3.34498
R9641 VSS.n737 VSS.t579 3.34498
R9642 VSS.n735 VSS.t1605 3.34498
R9643 VSS.n732 VSS.t488 3.34498
R9644 VSS.n730 VSS.t267 3.34498
R9645 VSS.n727 VSS.t749 3.34498
R9646 VSS.n725 VSS.t2138 3.34498
R9647 VSS.t537 VSS.n925 3.34498
R9648 VSS.t700 VSS.n930 3.34498
R9649 VSS.t1599 VSS.n933 3.34498
R9650 VSS.t1154 VSS.n937 3.34498
R9651 VSS.t441 VSS.n940 3.34498
R9652 VSS.t261 VSS.n944 3.34498
R9653 VSS.t1264 VSS.n947 3.34498
R9654 VSS.t2223 VSS.n951 3.34498
R9655 VSS.t455 VSS.n954 3.34498
R9656 VSS.t710 VSS.n958 3.34498
R9657 VSS.t294 VSS.n961 3.34498
R9658 VSS.t703 VSS.n965 3.34498
R9659 VSS.t751 VSS.n968 3.34498
R9660 VSS.t428 VSS.n972 3.34498
R9661 VSS.t1580 VSS.n975 3.34498
R9662 VSS.t583 VSS.n979 3.34498
R9663 VSS.t2409 VSS.n982 3.34498
R9664 VSS.t1797 VSS.n986 3.34498
R9665 VSS.t1796 VSS.n989 3.34498
R9666 VSS.t2322 VSS.n993 3.34498
R9667 VSS.t496 VSS.n996 3.34498
R9668 VSS.t1793 VSS.n1000 3.34498
R9669 VSS.t501 VSS.n1003 3.34498
R9670 VSS.t2232 VSS.n1007 3.34498
R9671 VSS.t1586 VSS.n1010 3.34498
R9672 VSS.t613 VSS.n1014 3.34498
R9673 VSS.t2413 VSS.n1017 3.34498
R9674 VSS.t628 VSS.n1021 3.34498
R9675 VSS.t1411 VSS.n1024 3.34498
R9676 VSS.t527 VSS.n1028 3.34498
R9677 VSS.t347 VSS.n1031 3.34498
R9678 VSS.t1627 VSS.n1035 3.34498
R9679 VSS.t1151 VSS.n1196 3.34498
R9680 VSS.t581 VSS.n1203 3.34498
R9681 VSS.t582 VSS.n1212 3.34498
R9682 VSS.t263 VSS.n1219 3.34498
R9683 VSS.t1808 VSS.n1228 3.34498
R9684 VSS.t2317 VSS.n1235 3.34498
R9685 VSS.t427 VSS.n1244 3.34498
R9686 VSS.t457 VSS.n1251 3.34498
R9687 VSS.t448 VSS.n1260 3.34498
R9688 VSS.t595 VSS.n1266 3.34498
R9689 VSS.t661 VSS.n1275 3.34498
R9690 VSS.t620 VSS.n1282 3.34498
R9691 VSS.t2321 VSS.n1291 3.34498
R9692 VSS.t551 VSS.n1298 3.34498
R9693 VSS.t731 VSS.n1307 3.34498
R9694 VSS.t1361 VSS.n1313 3.34498
R9695 VSS.t601 VSS.n1322 3.34498
R9696 VSS.t1483 VSS.n1329 3.34498
R9697 VSS.t1595 VSS.n1338 3.34498
R9698 VSS.t2412 VSS.n1345 3.34498
R9699 VSS.t708 VSS.n1354 3.34498
R9700 VSS.t279 VSS.n1360 3.34498
R9701 VSS.t162 VSS.n1369 3.34498
R9702 VSS.t1653 VSS.n1376 3.34498
R9703 VSS.t174 VSS.n1385 3.34498
R9704 VSS.t554 VSS.n1392 3.34498
R9705 VSS.t622 VSS.n1401 3.34498
R9706 VSS.t1438 VSS.n1407 3.34498
R9707 VSS.t1602 VSS.n1416 3.34498
R9708 VSS.t553 VSS.n1423 3.34498
R9709 VSS.t2011 VSS.n1432 3.34498
R9710 VSS.t752 VSS.n1439 3.34498
R9711 VSS.t727 VSS.n2177 3.34498
R9712 VSS.t549 VSS.n2182 3.34498
R9713 VSS.t547 VSS.n2185 3.34498
R9714 VSS.t706 VSS.n2189 3.34498
R9715 VSS.t704 VSS.n2192 3.34498
R9716 VSS.t2411 VSS.n2196 3.34498
R9717 VSS.t2410 VSS.n2199 3.34498
R9718 VSS.t525 VSS.n2203 3.34498
R9719 VSS.t523 VSS.n2206 3.34498
R9720 VSS.t1649 VSS.n2210 3.34498
R9721 VSS.t1647 VSS.n2213 3.34498
R9722 VSS.t756 VSS.n2217 3.34498
R9723 VSS.t754 VSS.n2220 3.34498
R9724 VSS.t743 VSS.n2224 3.34498
R9725 VSS.t741 VSS.n2227 3.34498
R9726 VSS.t1625 VSS.n2231 3.34498
R9727 VSS.t1623 VSS.n2234 3.34498
R9728 VSS.t345 VSS.n2238 3.34498
R9729 VSS.t343 VSS.n2241 3.34498
R9730 VSS.t1645 VSS.n2245 3.34498
R9731 VSS.t1643 VSS.n2248 3.34498
R9732 VSS.t618 VSS.n2252 3.34498
R9733 VSS.t616 VSS.n2255 3.34498
R9734 VSS.t2220 VSS.n2259 3.34498
R9735 VSS.t2219 VSS.n2262 3.34498
R9736 VSS.t2110 VSS.n2266 3.34498
R9737 VSS.t2109 VSS.n2269 3.34498
R9738 VSS.t446 VSS.n2273 3.34498
R9739 VSS.t444 VSS.n2276 3.34498
R9740 VSS.t83 VSS.n2280 3.34498
R9741 VSS.t712 VSS.n2283 3.34498
R9742 VSS.t1789 VSS.n2287 3.34498
R9743 VSS.t160 VSS.n2447 3.34498
R9744 VSS.t277 VSS.n2455 3.34498
R9745 VSS.t275 VSS.n2464 3.34498
R9746 VSS.t1601 VSS.n2471 3.34498
R9747 VSS.t1600 VSS.n2480 3.34498
R9748 VSS.t1437 VSS.n2487 3.34498
R9749 VSS.t1436 VSS.n2496 3.34498
R9750 VSS.t612 VSS.n2503 3.34498
R9751 VSS.t610 VSS.n2512 3.34498
R9752 VSS.t1585 VSS.n2519 3.34498
R9753 VSS.t1584 VSS.n2528 3.34498
R9754 VSS.t2231 VSS.n2535 3.34498
R9755 VSS.t2230 VSS.n2544 3.34498
R9756 VSS.t499 VSS.n2551 3.34498
R9757 VSS.t498 VSS.n2560 3.34498
R9758 VSS.t1410 VSS.n2567 3.34498
R9759 VSS.t1409 VSS.n2576 3.34498
R9760 VSS.t625 VSS.n2583 3.34498
R9761 VSS.t623 VSS.n2592 3.34498
R9762 VSS.t2121 VSS.n2599 3.34498
R9763 VSS.t2120 VSS.n2608 3.34498
R9764 VSS.t1792 VSS.n2615 3.34498
R9765 VSS.t1791 VSS.n2624 3.34498
R9766 VSS.t1594 VSS.n2631 3.34498
R9767 VSS.t1593 VSS.n2640 3.34498
R9768 VSS.t1480 VSS.n2647 3.34498
R9769 VSS.t1477 VSS.n2656 3.34498
R9770 VSS.t599 VSS.n2663 3.34498
R9771 VSS.t597 VSS.n2672 3.34498
R9772 VSS.t1360 VSS.n2679 3.34498
R9773 VSS.t1359 VSS.n2688 3.34498
R9774 VSS.t729 VSS.n2695 3.34498
R9775 VSS.n8 VSS.n1577 3.32697
R9776 VSS.n3051 VSS.n47 3.3265
R9777 VSS.n3092 VSS.n1121 3.32623
R9778 VSS.n3092 VSS.n3082 3.32615
R9779 VSS.n2851 VSS.n2842 3.32615
R9780 VSS.n8 VSS.n1581 3.32615
R9781 VSS.n3128 VSS.n3119 3.32615
R9782 VSS.n2858 VSS.t1505 3.30447
R9783 VSS.n3096 VSS.t2283 3.30447
R9784 VSS.n3132 VSS.t761 3.28366
R9785 VSS.n3063 VSS.n1556 3.21582
R9786 VSS.n3063 VSS.n1554 3.21582
R9787 VSS.n3063 VSS.n1544 3.21582
R9788 VSS.n3063 VSS.n1548 3.21582
R9789 VSS.n3063 VSS.n1547 3.21582
R9790 VSS.n2859 VSS.n1623 3.21582
R9791 VSS.n1887 VSS.n1683 3.21582
R9792 VSS.t495 VSS.n835 2.9518
R9793 VSS.n1122 VSS.t679 2.9518
R9794 VSS.n2376 VSS.t260 2.9518
R9795 VSS.t1525 VSS.n1862 2.9424
R9796 VSS.n2017 VSS.t1535 2.9424
R9797 VSS.n2841 VSS.n2778 2.77723
R9798 VSS.n3037 VSS.n1572 2.7456
R9799 VSS.n293 VSS.n1110 2.74463
R9800 VSS.n98 VSS.n2362 2.74463
R9801 VSS.n3079 VSS.n1530 2.74446
R9802 VSS.n2841 VSS.n2837 2.74446
R9803 VSS.n382 VSS.n598 2.74436
R9804 VSS.n382 VSS.n719 2.7443
R9805 VSS.n293 VSS.n1041 2.7443
R9806 VSS.n3079 VSS.n1181 2.7443
R9807 VSS.n98 VSS.n2293 2.7443
R9808 VSS.n3079 VSS.n1194 2.74414
R9809 VSS.n2841 VSS.n2779 2.74413
R9810 VSS.n382 VSS.t1985 2.74402
R9811 VSS.n293 VSS.t350 2.74402
R9812 VSS.n98 VSS.t1251 2.74402
R9813 VSS.n2841 VSS.t1142 2.74402
R9814 VSS.n382 VSS.n802 2.74397
R9815 VSS.n293 VSS.n926 2.74397
R9816 VSS.n3079 VSS.n1144 2.74397
R9817 VSS.n98 VSS.n2178 2.74397
R9818 VSS.n382 VSS.n633 2.74397
R9819 VSS.n293 VSS.n920 2.74397
R9820 VSS.n98 VSS.n2172 2.74397
R9821 VSS.n2841 VSS.n2811 2.74397
R9822 VSS.n8 VSS.n1597 2.74397
R9823 VSS.n3079 VSS.t1455 2.74386
R9824 VSS.n2841 VSS.n2449 2.74386
R9825 VSS.n51 VSS.n2927 2.46343
R9826 VSS.n51 VSS.n2925 2.46343
R9827 VSS.n51 VSS.n2894 2.46343
R9828 VSS.n51 VSS.n2895 2.46343
R9829 VSS.n51 VSS.n2897 2.46343
R9830 VSS.n51 VSS.n2922 2.46343
R9831 VSS.n51 VSS.n2921 2.46343
R9832 VSS.n51 VSS.n2919 2.46343
R9833 VSS.n51 VSS.n2917 2.46343
R9834 VSS.n51 VSS.n2916 2.46343
R9835 VSS.n51 VSS.n2903 2.46343
R9836 VSS.n51 VSS.n2905 2.46343
R9837 VSS.n28 VSS.n2998 2.46343
R9838 VSS.n28 VSS.n2996 2.46343
R9839 VSS.n28 VSS.n2994 2.46343
R9840 VSS.n28 VSS.n2931 2.46343
R9841 VSS.n28 VSS.n2933 2.46343
R9842 VSS.n28 VSS.n2935 2.46343
R9843 VSS.n28 VSS.n2937 2.46343
R9844 VSS.n28 VSS.n2991 2.46343
R9845 VSS.n28 VSS.n2988 2.46343
R9846 VSS.n28 VSS.n2986 2.46343
R9847 VSS.n28 VSS.n2984 2.46343
R9848 VSS.n28 VSS.n2941 2.46343
R9849 VSS.n28 VSS.n2946 2.46343
R9850 VSS.n28 VSS.n2948 2.46343
R9851 VSS.n28 VSS.n2950 2.46343
R9852 VSS.n28 VSS.n2952 2.46343
R9853 VSS.n28 VSS.n2956 2.46343
R9854 VSS.n28 VSS.n2976 2.46343
R9855 VSS.n51 VSS.n2912 2.46343
R9856 VSS.n51 VSS.n2909 2.46343
R9857 VSS.n3040 VSS.n3039 2.41928
R9858 VSS.n588 VSS.n587 2.34876
R9859 VSS.n573 VSS.n572 2.34876
R9860 VSS.n557 VSS.n556 2.34876
R9861 VSS.n533 VSS.n532 2.34876
R9862 VSS.n517 VSS.n516 2.34876
R9863 VSS.n503 VSS.n502 2.34876
R9864 VSS.n51 VSS.n2915 2.32483
R9865 VSS.n28 VSS.n2982 2.32483
R9866 VSS.n1863 VSS.t1525 2.20692
R9867 VSS.n1889 VSS.n1888 2.19188
R9868 VSS.n51 VSS.n2899 2.00687
R9869 VSS.n28 VSS.n27 2.00687
R9870 VSS.n382 VSS.n813 1.97843
R9871 VSS.n382 VSS.n817 1.97843
R9872 VSS.n382 VSS.n824 1.97843
R9873 VSS.n382 VSS.n831 1.97843
R9874 VSS.n382 VSS.n832 1.97843
R9875 VSS.n382 VSS.n3130 1.97843
R9876 VSS.n3129 VSS.n3128 1.97843
R9877 VSS.n3128 VSS.n850 1.97843
R9878 VSS.n3128 VSS.n848 1.97843
R9879 VSS.n3128 VSS.n847 1.97843
R9880 VSS.n3128 VSS.n838 1.97843
R9881 VSS.n3128 VSS.n846 1.97843
R9882 VSS.n3128 VSS.n845 1.97843
R9883 VSS.n3128 VSS.n844 1.97843
R9884 VSS.n3128 VSS.n840 1.97843
R9885 VSS.n3128 VSS.n841 1.97843
R9886 VSS.n3128 VSS.n842 1.97843
R9887 VSS.n3128 VSS.n843 1.97843
R9888 VSS.n3092 VSS.n1139 1.97843
R9889 VSS.n3092 VSS.n1123 1.97843
R9890 VSS.n3092 VSS.n1126 1.97843
R9891 VSS.n3092 VSS.n1132 1.97843
R9892 VSS.n3092 VSS.n1130 1.97843
R9893 VSS.n293 VSS.n3094 1.97843
R9894 VSS.n293 VSS.n1119 1.97843
R9895 VSS.n293 VSS.n1118 1.97843
R9896 VSS.n293 VSS.n1117 1.97843
R9897 VSS.n293 VSS.n874 1.97843
R9898 VSS.n293 VSS.n878 1.97843
R9899 VSS.n293 VSS.n879 1.97843
R9900 VSS.n293 VSS.n881 1.97843
R9901 VSS.n293 VSS.n882 1.97843
R9902 VSS.n293 VSS.n1113 1.97843
R9903 VSS.n293 VSS.n1111 1.97843
R9904 VSS.n293 VSS.n885 1.97843
R9905 VSS.n2851 VSS.n2396 1.97843
R9906 VSS.n2851 VSS.n2394 1.97843
R9907 VSS.n2851 VSS.n2378 1.97843
R9908 VSS.n2851 VSS.n2381 1.97843
R9909 VSS.n2851 VSS.n2384 1.97843
R9910 VSS.n2851 VSS.n2388 1.97843
R9911 VSS.n98 VSS.n2127 1.97843
R9912 VSS.n98 VSS.n2128 1.97843
R9913 VSS.n98 VSS.n2373 1.97843
R9914 VSS.n98 VSS.n2371 1.97843
R9915 VSS.n98 VSS.n2370 1.97843
R9916 VSS.n98 VSS.n2368 1.97843
R9917 VSS.n98 VSS.n2132 1.97843
R9918 VSS.n98 VSS.n2134 1.97843
R9919 VSS.n98 VSS.n2366 1.97843
R9920 VSS.n98 VSS.n2135 1.97843
R9921 VSS.n98 VSS.n2364 1.97843
R9922 VSS.n98 VSS.n2363 1.97843
R9923 VSS.n1821 VSS.n1819 1.88189
R9924 VSS.t284 VSS.n1616 1.88189
R9925 VSS.n3038 VSS.n3037 1.83435
R9926 VSS.n1717 VSS.t1207 1.80531
R9927 VSS.n3055 VSS.n47 1.75689
R9928 VSS.n1567 VSS.n47 1.75689
R9929 VSS.n8 VSS.n1608 1.75507
R9930 VSS.n2973 VSS.n2969 1.66925
R9931 VSS.n2841 VSS.n2835 1.64417
R9932 VSS.n2841 VSS.n2831 1.64417
R9933 VSS.n2841 VSS.n2826 1.64417
R9934 VSS.n2841 VSS.n2823 1.64417
R9935 VSS.n2841 VSS.n2821 1.64417
R9936 VSS.n3079 VSS.n1533 1.63922
R9937 VSS.n3079 VSS.n3066 1.63922
R9938 VSS.n3079 VSS.n3072 1.63922
R9939 VSS.n3079 VSS.n3075 1.63922
R9940 VSS.n3079 VSS.n3077 1.63922
R9941 VSS.n284 VSS.n280 1.30186
R9942 VSS.n264 VSS.n261 1.30186
R9943 VSS.n247 VSS.n244 1.30186
R9944 VSS.n236 VSS.n232 1.30186
R9945 VSS.n1632 VSS.n2087 1.59458
R9946 VSS.n1657 VSS.n2057 1.59458
R9947 VSS.n1671 VSS.n1984 1.59458
R9948 VSS.n1685 VSS.n1910 1.59458
R9949 VSS.n1699 VSS.n1792 1.59458
R9950 VSS.n1714 VSS.n1732 1.59458
R9951 VSS.n277 VSS.n278 1.3018
R9952 VSS.n229 VSS.n230 1.3018
R9953 VSS.n220 VSS.n219 1.30167
R9954 VSS.n214 VSS.n213 1.30167
R9955 VSS.n208 VSS.n207 1.30167
R9956 VSS.n202 VSS.n201 1.30167
R9957 VSS.n196 VSS.n195 1.30167
R9958 VSS.n190 VSS.n189 1.30167
R9959 VSS.t870 VSS.n2435 1.59445
R9960 VSS.t860 VSS.n2428 1.59445
R9961 VSS.t850 VSS.n2421 1.59445
R9962 VSS.t840 VSS.n2415 1.59445
R9963 VSS.t830 VSS.n2408 1.59445
R9964 VSS.t820 VSS.n2401 1.59445
R9965 VSS.n382 VSS.n641 1.55386
R9966 VSS.n382 VSS.n646 1.55386
R9967 VSS.n382 VSS.n651 1.55386
R9968 VSS.n382 VSS.n656 1.55386
R9969 VSS.n382 VSS.n661 1.55386
R9970 VSS.n382 VSS.n666 1.55386
R9971 VSS.n382 VSS.n671 1.55386
R9972 VSS.n382 VSS.n676 1.55386
R9973 VSS.n382 VSS.n681 1.55386
R9974 VSS.n382 VSS.n686 1.55386
R9975 VSS.n382 VSS.n691 1.55386
R9976 VSS.n382 VSS.n696 1.55386
R9977 VSS.n382 VSS.n701 1.55386
R9978 VSS.n382 VSS.n706 1.55386
R9979 VSS.n382 VSS.n711 1.55386
R9980 VSS.n382 VSS.n716 1.55386
R9981 VSS.n293 VSS.n928 1.55386
R9982 VSS.n293 VSS.n935 1.55386
R9983 VSS.n293 VSS.n942 1.55386
R9984 VSS.n293 VSS.n949 1.55386
R9985 VSS.n293 VSS.n956 1.55386
R9986 VSS.n293 VSS.n963 1.55386
R9987 VSS.n293 VSS.n970 1.55386
R9988 VSS.n293 VSS.n977 1.55386
R9989 VSS.n293 VSS.n984 1.55386
R9990 VSS.n293 VSS.n991 1.55386
R9991 VSS.n293 VSS.n998 1.55386
R9992 VSS.n293 VSS.n1005 1.55386
R9993 VSS.n293 VSS.n1012 1.55386
R9994 VSS.n293 VSS.n1019 1.55386
R9995 VSS.n293 VSS.n1026 1.55386
R9996 VSS.n293 VSS.n1033 1.55386
R9997 VSS.n3079 VSS.n1146 1.55386
R9998 VSS.n3079 VSS.n1148 1.55386
R9999 VSS.n3079 VSS.n1150 1.55386
R10000 VSS.n3079 VSS.n1152 1.55386
R10001 VSS.n3079 VSS.n1154 1.55386
R10002 VSS.n3079 VSS.n1157 1.55386
R10003 VSS.n3079 VSS.n1159 1.55386
R10004 VSS.n3079 VSS.n1161 1.55386
R10005 VSS.n3079 VSS.n1164 1.55386
R10006 VSS.n3079 VSS.n1166 1.55386
R10007 VSS.n3079 VSS.n1168 1.55386
R10008 VSS.n3079 VSS.n1171 1.55386
R10009 VSS.n3079 VSS.n1173 1.55386
R10010 VSS.n3079 VSS.n1175 1.55386
R10011 VSS.n3079 VSS.n1178 1.55386
R10012 VSS.n3079 VSS.n1180 1.55386
R10013 VSS.n98 VSS.n2180 1.55386
R10014 VSS.n98 VSS.n2187 1.55386
R10015 VSS.n98 VSS.n2194 1.55386
R10016 VSS.n98 VSS.n2201 1.55386
R10017 VSS.n98 VSS.n2208 1.55386
R10018 VSS.n98 VSS.n2215 1.55386
R10019 VSS.n98 VSS.n2222 1.55386
R10020 VSS.n98 VSS.n2229 1.55386
R10021 VSS.n98 VSS.n2236 1.55386
R10022 VSS.n98 VSS.n2243 1.55386
R10023 VSS.n98 VSS.n2250 1.55386
R10024 VSS.n98 VSS.n2257 1.55386
R10025 VSS.n98 VSS.n2264 1.55386
R10026 VSS.n98 VSS.n2271 1.55386
R10027 VSS.n98 VSS.n2278 1.55386
R10028 VSS.n98 VSS.n2285 1.55386
R10029 VSS.n2841 VSS.n2784 1.5537
R10030 VSS.n2841 VSS.n2810 1.55368
R10031 VSS.n2841 VSS.n2804 1.55368
R10032 VSS.n2841 VSS.n2798 1.55368
R10033 VSS.n2841 VSS.n2808 1.55365
R10034 VSS.n2841 VSS.n2802 1.55365
R10035 VSS.n2841 VSS.n2796 1.55365
R10036 VSS.n2841 VSS.n2790 1.55365
R10037 VSS.n2841 VSS.n2792 1.55363
R10038 VSS.n2841 VSS.n2786 1.55363
R10039 VSS.n2841 VSS.n2780 1.55363
R10040 VSS.n2841 VSS.n2806 1.55358
R10041 VSS.n2841 VSS.n2805 1.55358
R10042 VSS.n2841 VSS.n2800 1.55358
R10043 VSS.n2841 VSS.n2794 1.55358
R10044 VSS.n2841 VSS.n2788 1.55358
R10045 VSS.n2841 VSS.n2782 1.55358
R10046 VSS.n2841 VSS.n2809 1.55354
R10047 VSS.n2841 VSS.n2803 1.55354
R10048 VSS.n2841 VSS.n2799 1.55354
R10049 VSS.n2841 VSS.n2797 1.55354
R10050 VSS.n2841 VSS.n2793 1.55354
R10051 VSS.n2841 VSS.n2787 1.55354
R10052 VSS.n2841 VSS.n2781 1.55354
R10053 VSS.n3063 VSS.n1540 1.55353
R10054 VSS.n2841 VSS.n2807 1.5535
R10055 VSS.n2841 VSS.n2801 1.5535
R10056 VSS.n2841 VSS.n2795 1.5535
R10057 VSS.n2841 VSS.n2789 1.5535
R10058 VSS.n2841 VSS.n2783 1.5535
R10059 VSS.n2841 VSS.n2791 1.55347
R10060 VSS.n2841 VSS.n2785 1.55347
R10061 VSS.n382 VSS.t150 1.55345
R10062 VSS.n382 VSS.t1598 1.55345
R10063 VSS.n382 VSS.t560 1.55345
R10064 VSS.n382 VSS.t159 1.55345
R10065 VSS.n382 VSS.t563 1.55345
R10066 VSS.n382 VSS.t1612 1.55345
R10067 VSS.n382 VSS.t575 1.55345
R10068 VSS.n382 VSS.t1618 1.55345
R10069 VSS.n382 VSS.t557 1.55345
R10070 VSS.n382 VSS.t372 1.55345
R10071 VSS.n382 VSS.t566 1.55345
R10072 VSS.n382 VSS.t1615 1.55345
R10073 VSS.n382 VSS.t578 1.55345
R10074 VSS.n382 VSS.t1621 1.55345
R10075 VSS.n382 VSS.t1347 1.55345
R10076 VSS.n293 VSS.n934 1.55345
R10077 VSS.n293 VSS.n941 1.55345
R10078 VSS.n293 VSS.n948 1.55345
R10079 VSS.n293 VSS.n955 1.55345
R10080 VSS.n293 VSS.n962 1.55345
R10081 VSS.n293 VSS.n969 1.55345
R10082 VSS.n293 VSS.n976 1.55345
R10083 VSS.n293 VSS.n983 1.55345
R10084 VSS.n293 VSS.n990 1.55345
R10085 VSS.n293 VSS.n997 1.55345
R10086 VSS.n293 VSS.n1004 1.55345
R10087 VSS.n293 VSS.n1011 1.55345
R10088 VSS.n293 VSS.n1018 1.55345
R10089 VSS.n293 VSS.n1025 1.55345
R10090 VSS.n293 VSS.n1032 1.55345
R10091 VSS.n3079 VSS.n1147 1.55345
R10092 VSS.n3079 VSS.n1149 1.55345
R10093 VSS.n3079 VSS.n1151 1.55345
R10094 VSS.n3079 VSS.n1153 1.55345
R10095 VSS.n3079 VSS.n1156 1.55345
R10096 VSS.n3079 VSS.n1158 1.55345
R10097 VSS.n3079 VSS.n1160 1.55345
R10098 VSS.n3079 VSS.n1163 1.55345
R10099 VSS.n3079 VSS.n1165 1.55345
R10100 VSS.n3079 VSS.n1167 1.55345
R10101 VSS.n3079 VSS.n1170 1.55345
R10102 VSS.n3079 VSS.n1172 1.55345
R10103 VSS.n3079 VSS.n1174 1.55345
R10104 VSS.n3079 VSS.n1177 1.55345
R10105 VSS.n3079 VSS.n1179 1.55345
R10106 VSS.n98 VSS.n2186 1.55345
R10107 VSS.n98 VSS.n2193 1.55345
R10108 VSS.n98 VSS.n2200 1.55345
R10109 VSS.n98 VSS.n2207 1.55345
R10110 VSS.n98 VSS.n2214 1.55345
R10111 VSS.n98 VSS.n2221 1.55345
R10112 VSS.n98 VSS.n2228 1.55345
R10113 VSS.n98 VSS.n2235 1.55345
R10114 VSS.n98 VSS.n2242 1.55345
R10115 VSS.n98 VSS.n2249 1.55345
R10116 VSS.n98 VSS.n2256 1.55345
R10117 VSS.n98 VSS.n2263 1.55345
R10118 VSS.n98 VSS.n2270 1.55345
R10119 VSS.n98 VSS.n2277 1.55345
R10120 VSS.n98 VSS.n2284 1.55345
R10121 VSS.n2841 VSS.n2500 1.55344
R10122 VSS.n2841 VSS.n2596 1.55344
R10123 VSS.n2841 VSS.n2644 1.55344
R10124 VSS.n2841 VSS.n2692 1.55344
R10125 VSS.n2841 VSS.n2516 1.5534
R10126 VSS.n2841 VSS.n2604 1.5534
R10127 VSS.n2841 VSS.n2652 1.5534
R10128 VSS.n2841 VSS.n2572 1.55339
R10129 VSS.n2841 VSS.n2620 1.55339
R10130 VSS.n2841 VSS.n2492 1.55338
R10131 VSS.n382 VSS.n602 1.55338
R10132 VSS.n382 VSS.n603 1.55338
R10133 VSS.n382 VSS.n604 1.55338
R10134 VSS.n382 VSS.n605 1.55338
R10135 VSS.n382 VSS.n606 1.55338
R10136 VSS.n382 VSS.n607 1.55338
R10137 VSS.n382 VSS.n608 1.55338
R10138 VSS.n382 VSS.n609 1.55338
R10139 VSS.n382 VSS.n610 1.55338
R10140 VSS.n382 VSS.n611 1.55338
R10141 VSS.n382 VSS.n612 1.55338
R10142 VSS.n382 VSS.n613 1.55338
R10143 VSS.n382 VSS.n614 1.55338
R10144 VSS.n382 VSS.n615 1.55338
R10145 VSS.n382 VSS.n616 1.55338
R10146 VSS.n382 VSS.n617 1.55338
R10147 VSS.n382 VSS.n618 1.55338
R10148 VSS.n382 VSS.n619 1.55338
R10149 VSS.n382 VSS.n620 1.55338
R10150 VSS.n382 VSS.n621 1.55338
R10151 VSS.n382 VSS.n622 1.55338
R10152 VSS.n382 VSS.n623 1.55338
R10153 VSS.n382 VSS.n624 1.55338
R10154 VSS.n382 VSS.n625 1.55338
R10155 VSS.n382 VSS.n626 1.55338
R10156 VSS.n382 VSS.n627 1.55338
R10157 VSS.n382 VSS.n628 1.55338
R10158 VSS.n382 VSS.n629 1.55338
R10159 VSS.n382 VSS.n630 1.55338
R10160 VSS.n382 VSS.n631 1.55338
R10161 VSS.n382 VSS.n632 1.55338
R10162 VSS.n293 VSS.n889 1.55338
R10163 VSS.n293 VSS.n890 1.55338
R10164 VSS.n293 VSS.n891 1.55338
R10165 VSS.n293 VSS.n892 1.55338
R10166 VSS.n293 VSS.n893 1.55338
R10167 VSS.n293 VSS.n894 1.55338
R10168 VSS.n293 VSS.n895 1.55338
R10169 VSS.n293 VSS.n896 1.55338
R10170 VSS.n293 VSS.n897 1.55338
R10171 VSS.n293 VSS.n898 1.55338
R10172 VSS.n293 VSS.n899 1.55338
R10173 VSS.n293 VSS.n900 1.55338
R10174 VSS.n293 VSS.n901 1.55338
R10175 VSS.n293 VSS.n902 1.55338
R10176 VSS.n293 VSS.n903 1.55338
R10177 VSS.n293 VSS.n904 1.55338
R10178 VSS.n293 VSS.n905 1.55338
R10179 VSS.n293 VSS.n906 1.55338
R10180 VSS.n293 VSS.n907 1.55338
R10181 VSS.n293 VSS.n908 1.55338
R10182 VSS.n293 VSS.n909 1.55338
R10183 VSS.n293 VSS.n910 1.55338
R10184 VSS.n293 VSS.n911 1.55338
R10185 VSS.n293 VSS.n912 1.55338
R10186 VSS.n293 VSS.n913 1.55338
R10187 VSS.n293 VSS.n914 1.55338
R10188 VSS.n293 VSS.n915 1.55338
R10189 VSS.n293 VSS.n916 1.55338
R10190 VSS.n293 VSS.n917 1.55338
R10191 VSS.n293 VSS.n918 1.55338
R10192 VSS.n293 VSS.n919 1.55338
R10193 VSS.n98 VSS.n2141 1.55338
R10194 VSS.n98 VSS.n2142 1.55338
R10195 VSS.n98 VSS.n2143 1.55338
R10196 VSS.n98 VSS.n2144 1.55338
R10197 VSS.n98 VSS.n2145 1.55338
R10198 VSS.n98 VSS.n2146 1.55338
R10199 VSS.n98 VSS.n2147 1.55338
R10200 VSS.n98 VSS.n2148 1.55338
R10201 VSS.n98 VSS.n2149 1.55338
R10202 VSS.n98 VSS.n2150 1.55338
R10203 VSS.n98 VSS.n2151 1.55338
R10204 VSS.n98 VSS.n2152 1.55338
R10205 VSS.n98 VSS.n2153 1.55338
R10206 VSS.n98 VSS.n2154 1.55338
R10207 VSS.n98 VSS.n2155 1.55338
R10208 VSS.n98 VSS.n2156 1.55338
R10209 VSS.n98 VSS.n2157 1.55338
R10210 VSS.n98 VSS.n2158 1.55338
R10211 VSS.n98 VSS.n2159 1.55338
R10212 VSS.n98 VSS.n2160 1.55338
R10213 VSS.n98 VSS.n2161 1.55338
R10214 VSS.n98 VSS.n2162 1.55338
R10215 VSS.n98 VSS.n2163 1.55338
R10216 VSS.n98 VSS.n2164 1.55338
R10217 VSS.n98 VSS.n2165 1.55338
R10218 VSS.n98 VSS.n2166 1.55338
R10219 VSS.n98 VSS.n2167 1.55338
R10220 VSS.n98 VSS.n2168 1.55338
R10221 VSS.n98 VSS.n2169 1.55338
R10222 VSS.n98 VSS.n2170 1.55338
R10223 VSS.n98 VSS.n2171 1.55338
R10224 VSS.n2841 VSS.n2508 1.55338
R10225 VSS.n2841 VSS.n2556 1.55338
R10226 VSS.n3079 VSS.n1425 1.55337
R10227 VSS.n3079 VSS.n1418 1.55337
R10228 VSS.n3079 VSS.n1409 1.55337
R10229 VSS.n3079 VSS.n1403 1.55337
R10230 VSS.n3079 VSS.n1378 1.55337
R10231 VSS.n3079 VSS.n1371 1.55337
R10232 VSS.n3079 VSS.n1362 1.55337
R10233 VSS.n3079 VSS.n1356 1.55337
R10234 VSS.n3079 VSS.n1331 1.55337
R10235 VSS.n3079 VSS.n1324 1.55337
R10236 VSS.n3079 VSS.n1315 1.55337
R10237 VSS.n3079 VSS.n1284 1.55337
R10238 VSS.n3079 VSS.n1277 1.55337
R10239 VSS.n3079 VSS.n1268 1.55337
R10240 VSS.n3079 VSS.n1237 1.55337
R10241 VSS.n3079 VSS.n1230 1.55337
R10242 VSS.n3079 VSS.n1221 1.55337
R10243 VSS.n2841 VSS.n2474 1.55337
R10244 VSS.n2841 VSS.n2483 1.55337
R10245 VSS.n2841 VSS.n2579 1.55337
R10246 VSS.n2841 VSS.n2627 1.55337
R10247 VSS.n2841 VSS.n2675 1.55337
R10248 VSS.n2841 VSS.n2452 1.55335
R10249 VSS.n2841 VSS.n2524 1.55335
R10250 VSS.n2841 VSS.n2532 1.55335
R10251 VSS.n2841 VSS.n2564 1.55335
R10252 VSS.n2841 VSS.n2612 1.55335
R10253 VSS.n2841 VSS.n2660 1.55335
R10254 VSS.n2841 VSS.n2459 1.55333
R10255 VSS.n2841 VSS.n2467 1.55333
R10256 VSS.n2841 VSS.n2539 1.55333
R10257 VSS.n2841 VSS.n2667 1.55333
R10258 VSS.n2841 VSS.n2547 1.55332
R10259 VSS.n2841 VSS.n2586 1.55332
R10260 VSS.n2841 VSS.n2634 1.55332
R10261 VSS.n2841 VSS.n2682 1.55332
R10262 VSS.n3079 VSS.n1434 1.55328
R10263 VSS.n3079 VSS.n1396 1.55328
R10264 VSS.n3079 VSS.n1387 1.55328
R10265 VSS.n3079 VSS.n1349 1.55328
R10266 VSS.n3079 VSS.n1340 1.55328
R10267 VSS.n3079 VSS.n1309 1.55328
R10268 VSS.n3079 VSS.n1302 1.55328
R10269 VSS.n3079 VSS.n1293 1.55328
R10270 VSS.n3079 VSS.n1262 1.55328
R10271 VSS.n3079 VSS.n1255 1.55328
R10272 VSS.n3079 VSS.n1246 1.55328
R10273 VSS.n3079 VSS.n1214 1.55328
R10274 VSS.n3079 VSS.n1207 1.55328
R10275 VSS.n3079 VSS.n1198 1.55328
R10276 VSS.n1814 VSS.n74 1.55041
R10277 VSS.n2958 VSS.t2352 1.43372
R10278 VSS.t2350 VSS.n2959 1.43372
R10279 VSS.t2352 VSS.n2961 1.42949
R10280 VSS.t2350 VSS.n2960 1.42949
R10281 VSS.t1467 VSS.t1470 1.41892
R10282 VSS.t1465 VSS.t1469 1.41892
R10283 VSS.t1463 VSS.t1468 1.41892
R10284 VSS.t1460 VSS.t1461 1.41892
R10285 VSS.n3181 VSS.n496 1.38589
R10286 VSS.t2347 VSS.n1568 1.37661
R10287 VSS.t2347 VSS.n1565 1.37661
R10288 VSS.n2841 VSS.n2438 1.35622
R10289 VSS.t334 VSS.n534 1.28795
R10290 VSS.t1556 VSS.t1554 1.25706
R10291 VSS.n1817 VSS.n74 1.24506
R10292 VSS.n1622 VSS.t9 1.24155
R10293 VSS.t2014 VSS.t1490 1.23805
R10294 VSS.t8 VSS.t510 1.21479
R10295 VSS.n3039 VSS.n3038 1.20825
R10296 VSS.n3050 VSS.n3040 1.2045
R10297 VSS.t1544 VSS.t1546 1.18357
R10298 VSS.t1528 VSS.t1530 1.1832
R10299 VSS.t1548 VSS.t1546 1.17915
R10300 VSS.t1530 VSS.t1532 1.17908
R10301 VSS.t1542 VSS.t1541 1.1778
R10302 VSS.t1534 VSS.t1536 1.17371
R10303 VSS.t1552 VSS.t1550 1.17364
R10304 VSS.t1554 VSS.t1552 1.15983
R10305 VSS.t1538 VSS.t1540 1.15883
R10306 VSS.t9 VSS.t1526 1.15771
R10307 VSS.t1536 VSS.t1538 1.12817
R10308 VSS.t1526 VSS.t1528 1.12612
R10309 VSS.n1620 VSS.t6 1.12123
R10310 VSS.t1532 VSS.t1534 1.11346
R10311 VSS.t1550 VSS.t1548 1.11316
R10312 VSS.t1544 VSS.t1542 1.10881
R10313 VSS.n1558 VSS.t124 1.10823
R10314 VSS.t1220 VSS.n2377 1.10092
R10315 VSS.n3123 VSS.t34 1.10092
R10316 VSS.t284 VSS.n1614 1.09664
R10317 VSS.t1207 VSS.n1716 1.09156
R10318 VSS.t259 VSS.n2131 1.09154
R10319 VSS.t56 VSS.n877 1.09154
R10320 VSS.n2377 VSS.t2117 1.08176
R10321 VSS.n3123 VSS.t1522 1.08176
R10322 VSS.t875 VSS.n1558 1.08057
R10323 VSS.t2091 VSS.t2103 1.07709
R10324 VSS.t82 VSS.n260 0.934731
R10325 VSS.t1085 VSS.n534 1.06717
R10326 VSS.t363 VSS.n1911 1.05697
R10327 VSS.t605 VSS.t1422 1.05581
R10328 VSS.t1800 VSS.t357 1.05581
R10329 VSS.t205 VSS.n3087 1.04464
R10330 VSS.t477 VSS.t129 1.03782
R10331 VSS.t1144 VSS.t34 1.03782
R10332 VSS.n2820 VSS.t251 1.03651
R10333 VSS.n474 VSS.t770 1.03359
R10334 VSS.n1716 VSS.t200 1.02487
R10335 VSS.n1614 VSS.n1615 1.02454
R10336 VSS.n1622 VSS.t4 1.02273
R10337 VSS.n814 VSS.t256 1.02121
R10338 VSS.n1536 VSS.t232 1.02115
R10339 VSS.t904 VSS.n1679 1.01993
R10340 VSS.t259 VSS.t189 1.01968
R10341 VSS.t56 VSS.t1741 1.01968
R10342 VSS.t1876 VSS.t1220 1.01968
R10343 VSS.t791 VSS.t966 1.01873
R10344 VSS.t1972 VSS.t354 1.01873
R10345 VSS.n3087 VSS.t1959 1.01479
R10346 VSS.n3070 VSS.t1175 1.00721
R10347 VSS.n822 VSS.t494 1.00718
R10348 VSS.t357 VSS.t791 1.00659
R10349 VSS.t1422 VSS.t1972 1.00659
R10350 VSS.n474 VSS.t2179 1.0064
R10351 VSS.n1679 VSS.t363 1.00536
R10352 VSS.n3014 VSS.n3013 0.980375
R10353 VSS.n2820 VSS.t92 0.973762
R10354 VSS.n473 VSS.t1487 0.971887
R10355 VSS.t647 VSS.t477 0.971846
R10356 VSS.t31 VSS.t1144 0.971846
R10357 VSS.t650 VSS.n2375 0.971526
R10358 VSS.t959 VSS.n204 0.846293
R10359 VSS.t839 VSS.t605 0.968
R10360 VSS.n1910 VSS.n1802 0.967179
R10361 VSS.n1800 VSS.n1695 0.967179
R10362 VSS.n1755 VSS.n1697 0.967179
R10363 VSS.n1763 VSS.n1697 0.967179
R10364 VSS.n1771 VSS.n1697 0.967179
R10365 VSS.n1792 VSS.n1702 0.967179
R10366 VSS.n1911 VSS.t899 0.966998
R10367 VSS.n1779 VSS.n1697 0.965685
R10368 VSS.n222 VSS.t1806 0.0285658
R10369 VSS.t869 VSS.t1263 0.951549
R10370 VSS.n1634 VSS.t927 0.951015
R10371 VSS.t2283 VSS.n285 0.116908
R10372 VSS.t1115 VSS.n589 0.950816
R10373 VSS.t361 VSS.n1683 0.944944
R10374 VSS.t200 VSS.t1204 0.942592
R10375 VSS.t121 VSS.t2091 0.934564
R10376 VSS.n50 VSS.n3030 0.932604
R10377 VSS.t1204 VSS.t4 0.91887
R10378 VSS.n1620 VSS.t11 0.885254
R10379 VSS.n50 VSS.n3016 0.881792
R10380 VSS.n3015 VSS.n3014 0.881792
R10381 VSS.t1028 VSS.n861 0.841394
R10382 VSS.t779 VSS.n535 0.841394
R10383 VSS.t9 VSS.n73 0.832423
R10384 VSS.t2323 VSS.t95 0.806856
R10385 VSS.t2357 VSS.t2360 0.806856
R10386 VSS.t2370 VSS.t1433 0.806856
R10387 VSS.t1820 VSS.t2334 0.806855
R10388 VSS.n1600 VSS.t2364 0.806855
R10389 VSS.t397 VSS.t2381 0.806855
R10390 VSS.t1161 VSS.t2394 0.806855
R10391 VSS.t594 VSS.t161 0.802775
R10392 VSS.t1665 VSS.t278 0.802775
R10393 VSS.t1272 VSS.t276 0.802775
R10394 VSS.t254 VSS.t298 0.802775
R10395 VSS.t405 VSS.t529 0.802775
R10396 VSS.t1156 VSS.t660 0.802775
R10397 VSS.t1135 VSS.t302 0.802775
R10398 VSS.t300 VSS.t60 0.802775
R10399 VSS.t1277 VSS.t611 0.802775
R10400 VSS.t1715 VSS.t1224 0.802775
R10401 VSS.t421 VSS.t415 0.802775
R10402 VSS.t413 VSS.t664 0.802775
R10403 VSS.t135 VSS.t305 0.802775
R10404 VSS.t307 VSS.t500 0.802775
R10405 VSS.t1373 VSS.t64 0.802775
R10406 VSS.t62 VSS.t481 0.802775
R10407 VSS.t483 VSS.t1280 0.802775
R10408 VSS.t1282 VSS.t491 0.802775
R10409 VSS.t418 VSS.t624 0.802775
R10410 VSS.t1751 VSS.t452 0.802775
R10411 VSS.t454 VSS.t1725 0.802775
R10412 VSS.t1729 VSS.t1378 0.802775
R10413 VSS.t1376 VSS.t243 0.802775
R10414 VSS.t245 VSS.t1138 0.802775
R10415 VSS.t138 VSS.t666 0.802775
R10416 VSS.t1685 VSS.t1290 0.802775
R10417 VSS.t1583 VSS.t324 0.802775
R10418 VSS.t326 VSS.t600 0.802775
R10419 VSS.t699 VSS.t598 0.802775
R10420 VSS.t1754 VSS.t1292 0.802775
R10421 VSS.t42 VSS.t66 0.802775
R10422 VSS.t68 VSS.t730 0.802775
R10423 VSS.t408 VSS.t2330 0.802775
R10424 VSS.t1913 VSS.t550 0.802775
R10425 VSS.t1502 VSS.t707 0.802775
R10426 VSS.t1256 VSS.t2019 0.802775
R10427 VSS.t1404 VSS.t526 0.802775
R10428 VSS.t1824 VSS.t1650 0.802775
R10429 VSS.t1920 VSS.t757 0.802775
R10430 VSS.t1917 VSS.t744 0.802775
R10431 VSS.t2073 VSS.t1626 0.802775
R10432 VSS.t1363 VSS.t346 0.802775
R10433 VSS.t1510 VSS.t1646 0.802775
R10434 VSS.t1329 VSS.t619 0.802775
R10435 VSS.t1337 VSS.t1811 0.802775
R10436 VSS.t1335 VSS.t1320 0.802775
R10437 VSS.t1365 VSS.t447 0.802775
R10438 VSS.t673 VSS.t84 0.802775
R10439 VSS.t386 VSS.t1790 0.802775
R10440 VSS.t1951 VSS.t2343 0.802775
R10441 VSS.t105 VSS.t388 0.802775
R10442 VSS.t508 VSS.t445 0.802775
R10443 VSS.t181 VSS.t1400 0.802775
R10444 VSS.t1270 VSS.t1236 0.802775
R10445 VSS.t241 VSS.t617 0.802775
R10446 VSS.t1564 VSS.t1644 0.802775
R10447 VSS.t1589 VSS.t344 0.802775
R10448 VSS.t505 VSS.t1624 0.802775
R10449 VSS.t178 VSS.t742 0.802775
R10450 VSS.t1267 VSS.t755 0.802775
R10451 VSS.t238 VSS.t1648 0.802775
R10452 VSS.t1567 VSS.t524 0.802775
R10453 VSS.t1592 VSS.t2022 0.802775
R10454 VSS.t1948 VSS.t705 0.802775
R10455 VSS.t102 VSS.t548 0.802775
R10456 VSS.t1559 VSS.t728 0.802775
R10457 VSS.n1598 VSS.t2225 0.802775
R10458 VSS.t2377 VSS.t1765 0.802775
R10459 VSS.t753 VSS.t521 0.802775
R10460 VSS.t215 VSS.t518 0.802775
R10461 VSS.t395 VSS.t1178 0.802775
R10462 VSS.t1121 VSS.t108 0.802775
R10463 VSS.t229 VSS.t211 0.802775
R10464 VSS.t44 VSS.t196 0.802775
R10465 VSS.t194 VSS.t411 0.802775
R10466 VSS.t175 VSS.t315 0.802775
R10467 VSS.t313 VSS.t466 0.802775
R10468 VSS.t163 VSS.t724 0.802775
R10469 VSS.t280 VSS.t282 0.802775
R10470 VSS.t709 VSS.t464 0.802775
R10471 VSS.t223 VSS.t2222 0.802775
R10472 VSS.t217 VSS.t715 0.802775
R10473 VSS.t1189 VSS.t536 0.802775
R10474 VSS.t602 VSS.t321 0.802775
R10475 VSS.t221 VSS.t1474 0.802775
R10476 VSS.t732 VSS.t1248 0.802775
R10477 VSS.t552 VSS.t1418 0.802775
R10478 VSS.t1416 VSS.t633 0.802775
R10479 VSS.t621 VSS.t360 0.802775
R10480 VSS.t662 VSS.t721 0.802775
R10481 VSS.t596 VSS.t534 0.802775
R10482 VSS.t449 VSS.t97 0.802775
R10483 VSS.t99 VSS.t286 0.802775
R10484 VSS.t289 VSS.t718 0.802775
R10485 VSS.t812 VSS.t311 0.802775
R10486 VSS.t468 VSS.t111 0.802775
R10487 VSS.t264 VSS.t27 0.802775
R10488 VSS.t226 VSS.t187 0.802775
R10489 VSS.t185 VSS.t1124 0.802775
R10490 VSS.t1152 VSS.t126 0.802775
R10491 VSS.t681 VSS.t117 0.802775
R10492 VSS.t804 VSS.t796 0.802775
R10493 VSS.t1233 VSS.t262 0.802775
R10494 VSS.t512 VSS.t317 0.802775
R10495 VSS.t1485 VSS.t711 0.802775
R10496 VSS.t609 VSS.t271 0.802775
R10497 VSS.t440 VSS.t330 0.802775
R10498 VSS.t29 VSS.t436 0.802775
R10499 VSS.t52 VSS.t203 0.802775
R10500 VSS.t235 VSS.t115 0.802775
R10501 VSS.t1173 VSS.t209 0.802775
R10502 VSS.t1703 VSS.t1180 0.802775
R10503 VSS.t46 VSS.t614 0.802775
R10504 VSS.t86 VSS.t183 0.802775
R10505 VSS.t1213 VSS.t219 0.802775
R10506 VSS.t794 VSS.t1628 0.802775
R10507 VSS.t1515 VSS.t2390 0.802775
R10508 VSS.t402 VSS.t348 0.802775
R10509 VSS.t657 VSS.t782 0.802775
R10510 VSS.t1398 VSS.t88 0.802775
R10511 VSS.t1182 VSS.t48 0.802775
R10512 VSS.t341 VSS.t502 0.802775
R10513 VSS.t113 VSS.t497 0.802775
R10514 VSS.t1350 VSS.t1428 0.802775
R10515 VSS.t434 VSS.t50 0.802775
R10516 VSS.t332 VSS.t676 0.802775
R10517 VSS.t273 VSS.t438 0.802775
R10518 VSS.t1355 VSS.t295 0.802775
R10519 VSS.t319 VSS.t456 0.802775
R10520 VSS.t1127 VSS.t653 0.802775
R10521 VSS.t798 VSS.t442 0.802775
R10522 VSS.t119 VSS.t39 0.802775
R10523 VSS.t1450 VSS.t538 0.802775
R10524 VSS.t1414 VSS.t746 0.802775
R10525 VSS.t1323 VSS.t248 0.802775
R10526 VSS.t572 VSS.t1652 0.802775
R10527 VSS.t669 VSS.t72 0.802775
R10528 VSS.t1318 VSS.t627 0.802775
R10529 VSS.t461 VSS.t75 0.802775
R10530 VSS.t378 VSS.t169 0.802775
R10531 VSS.t459 VSS.t173 0.802775
R10532 VSS.t147 VSS.t291 0.802775
R10533 VSS.t1902 VSS.t542 0.802775
R10534 VSS.t381 VSS.t171 0.802775
R10535 VSS.t1701 VSS.t1573 0.802775
R10536 VSS.t153 VSS.t1148 0.802775
R10537 VSS.t1325 VSS.t293 0.802775
R10538 VSS.t366 VSS.t1571 0.802775
R10539 VSS.t1327 VSS.t266 0.802775
R10540 VSS.t141 VSS.t165 0.802775
R10541 VSS.t1675 VSS.t167 0.802775
R10542 VSS.t375 VSS.t1931 0.802775
R10543 VSS.t309 VSS.t748 0.802775
R10544 VSS.t144 VSS.t1569 0.802775
R10545 VSS.t1740 VSS.t1150 0.802775
R10546 VSS.t384 VSS.t485 0.802775
R10547 VSS.t532 VSS.t546 0.802775
R10548 VSS.t156 VSS.t544 0.802775
R10549 VSS.t1402 VSS.t487 0.802775
R10550 VSS.t369 VSS.t580 0.802775
R10551 VSS.t671 VSS.t1606 0.802775
R10552 VSS.t1315 VSS.t489 0.802775
R10553 VSS.t1979 VSS.t268 0.802775
R10554 VSS.t569 VSS.t750 0.802775
R10555 VSS.t1231 VSS.t2139 0.802775
R10556 VSS.t1609 VSS.t2403 0.802775
R10557 VSS.t431 VSS.n1651 0.78864
R10558 VSS.t589 VSS.n1665 0.78864
R10559 VSS.t894 VSS.n1692 0.78864
R10560 VSS.t586 VSS.n1708 0.78864
R10561 VSS.t764 VSS.n574 0.78864
R10562 VSS.t776 VSS.n558 0.78864
R10563 VSS.t767 VSS.n518 0.78864
R10564 VSS.t773 VSS.n504 0.78864
R10565 VSS.n2404 VSS.t686 0.787714
R10566 VSS.n2411 VSS.t426 0.787714
R10567 VSS.n2424 VSS.t689 0.787714
R10568 VSS.n2431 VSS.t474 0.787714
R10569 VSS.t362 VSS.n1883 0.735974
R10570 VSS.t1539 VSS.n1630 0.735974
R10571 VSS.t284 VSS.n1620 0.728354
R10572 VSS.n231 VSS.t1008 0.83385
R10573 VSS.n279 VSS.t2 0.83385
R10574 VSS.n192 VSS.t944 0.83385
R10575 VSS.n198 VSS.t955 0.83385
R10576 VSS.n210 VSS.t977 0.83385
R10577 VSS.n216 VSS.t988 0.83385
R10578 VSS.t819 VSS.n2404 0.725653
R10579 VSS.t829 VSS.n2411 0.725653
R10580 VSS.t849 VSS.n2424 0.725653
R10581 VSS.t859 VSS.n2431 0.725653
R10582 VSS.n1651 VSS.t918 0.724795
R10583 VSS.n1665 VSS.t909 0.724795
R10584 VSS.n1692 VSS.t889 0.724795
R10585 VSS.n1708 VSS.t880 0.724795
R10586 VSS.n271 VSS.t1039 0.834754
R10587 VSS.n243 VSS.t79 0.834754
R10588 VSS.t1105 VSS.n574 0.724795
R10589 VSS.t1095 VSS.n558 0.724795
R10590 VSS.t1075 VSS.n518 0.724795
R10591 VSS.t1065 VSS.n504 0.724795
R10592 VSS.t2331 VSS.n2440 0.723599
R10593 VSS.t2344 VSS.t2346 0.723599
R10594 VSS.t2342 VSS.n2126 0.723599
R10595 VSS.n1526 VSS.t2379 0.723599
R10596 VSS.t2378 VSS.n1142 0.723599
R10597 VSS.t2391 VSS.t2393 0.723599
R10598 VSS.t2389 VSS.n873 0.723599
R10599 VSS.t2404 VSS.t2406 0.723599
R10600 VSS.t2402 VSS.n597 0.723599
R10601 VSS.n2979 VSS.t1467 0.722582
R10602 VSS.n2981 VSS.t1465 0.722582
R10603 VSS.n2943 VSS.t1463 0.722582
R10604 VSS.t1461 VSS.n3015 0.722582
R10605 VSS.t1470 VSS.n2978 0.72222
R10606 VSS.t1469 VSS.n2980 0.72222
R10607 VSS.t1468 VSS.n2942 0.72222
R10608 VSS.n3016 VSS.t1460 0.72222
R10609 VSS.n1818 VSS.n73 0.711165
R10610 VSS.t11 VSS.n1614 0.699997
R10611 VSS.n535 VSS.t334 0.699882
R10612 VSS.n861 VSS.t639 0.699882
R10613 VSS.n1816 VSS.n1815 0.6955
R10614 VSS.t1204 VSS.t510 0.663064
R10615 VSS.n3063 VSS.n1555 0.631585
R10616 VSS.n3064 VSS.n3063 0.631585
R10617 VSS.n3142 VSS.n574 0.62049
R10618 VSS.n3148 VSS.n558 0.62049
R10619 VSS.n3163 VSS.n518 0.62049
R10620 VSS.n3172 VSS.n504 0.62049
R10621 VSS.n1651 VSS.n1655 0.62049
R10622 VSS.n1665 VSS.n1669 0.62049
R10623 VSS.n1692 VSS.n1697 0.62049
R10624 VSS.n1708 VSS.n1712 0.62049
R10625 VSS.n270 VSS.n271 0.536332
R10626 VSS.n242 VSS.n243 0.536332
R10627 VSS.n216 VSS.n215 0.535962
R10628 VSS.n210 VSS.n209 0.535962
R10629 VSS.n198 VSS.n197 0.535962
R10630 VSS.n192 VSS.n191 0.535962
R10631 VSS.n2431 VSS.n2430 0.620091
R10632 VSS.n2424 VSS.n2423 0.620091
R10633 VSS.n2411 VSS.n2410 0.620091
R10634 VSS.n2404 VSS.n2403 0.620091
R10635 VSS.n279 VSS.n273 0.535962
R10636 VSS.n231 VSS.n225 0.535962
R10637 VSS.n3133 VSS.n595 0.613782
R10638 VSS.n3142 VSS.n581 0.613782
R10639 VSS.n3148 VSS.n563 0.613782
R10640 VSS.n3157 VSS.n550 0.613782
R10641 VSS.n3157 VSS.n545 0.613782
R10642 VSS.n3163 VSS.n523 0.613782
R10643 VSS.n3172 VSS.n510 0.613782
R10644 VSS.n3181 VSS.n479 0.613782
R10645 VSS.n3181 VSS.n481 0.613782
R10646 VSS.n3181 VSS.n492 0.613782
R10647 VSS.n3181 VSS.n487 0.613782
R10648 VSS.n3181 VSS.n488 0.613782
R10649 VSS.n74 VSS.n73 0.599773
R10650 VSS.t2327 VSS.n2813 0.595317
R10651 VSS.t2325 VSS.n2812 0.595317
R10652 VSS.t2339 VSS.n2359 0.595317
R10653 VSS.t2336 VSS.n2358 0.595317
R10654 VSS.t2369 VSS.n1604 0.595317
R10655 VSS.t2366 VSS.n1605 0.595317
R10656 VSS.t2363 VSS.n1593 0.595317
R10657 VSS.t2359 VSS.n1594 0.595317
R10658 VSS.n1193 VSS.t2374 0.595317
R10659 VSS.t2372 VSS.n1191 0.595317
R10660 VSS.t2386 VSS.n1107 0.595317
R10661 VSS.t2383 VSS.n1106 0.595317
R10662 VSS.t2399 VSS.n804 0.595317
R10663 VSS.t2396 VSS.n805 0.595317
R10664 VSS.n382 VSS.n386 0.1979
R10665 VSS.n98 VSS.n96 0.00105218
R10666 VSS.n1818 VSS.n1817 0.56503
R10667 VSS.t284 VSS.n1619 0.557126
R10668 VSS.n382 VSS.n384 0.556705
R10669 VSS.n293 VSS.n378 0.556705
R10670 VSS.n3079 VSS.n1184 0.556705
R10671 VSS.n98 VSS.n183 0.556705
R10672 VSS.n2841 VSS.n2838 0.556705
R10673 VSS.n51 VSS.n50 0.556483
R10674 VSS.n3014 VSS.n28 0.556483
R10675 VSS.n3157 VSS.n535 0.554008
R10676 VSS.n259 VSS.n861 0.554008
R10677 VSS.t2179 VSS.n496 0.539958
R10678 VSS.n1609 VSS.n1608 0.52186
R10679 VSS.n1519 VSS.n221 0.515438
R10680 VSS.n1508 VSS.n215 0.515438
R10681 VSS.n1497 VSS.n209 0.515438
R10682 VSS.n1486 VSS.n203 0.515438
R10683 VSS.n1478 VSS.n203 0.515438
R10684 VSS.n1467 VSS.n197 0.515438
R10685 VSS.n1456 VSS.n191 0.515438
R10686 VSS.n3092 VSS.n3088 0.515438
R10687 VSS.n2773 VSS.n2437 0.515438
R10688 VSS.n2762 VSS.n2430 0.515438
R10689 VSS.n2751 VSS.n2423 0.515438
R10690 VSS.n2740 VSS.n2417 0.515438
R10691 VSS.n2732 VSS.n2417 0.515438
R10692 VSS.n2721 VSS.n2410 0.515438
R10693 VSS.n2710 VSS.n2403 0.515438
R10694 VSS.n2851 VSS.n2847 0.515438
R10695 VSS.n1723 VSS.n1712 0.515438
R10696 VSS.n3063 VSS.n1563 0.515438
R10697 VSS.n3097 VSS.n290 0.515438
R10698 VSS.n867 VSS.n273 0.515438
R10699 VSS.n3102 VSS.n270 0.515438
R10700 VSS.n259 VSS.n250 0.515438
R10701 VSS.n3108 VSS.n259 0.515438
R10702 VSS.n3114 VSS.n242 0.515438
R10703 VSS.n855 VSS.n225 0.515438
R10704 VSS.n3128 VSS.n3125 0.515438
R10705 VSS.n1622 VSS.t510 0.506033
R10706 VSS.t2352 VSS.t2350 0.492336
R10707 VSS.t1378 VSS.n2620 0.477785
R10708 VSS.t481 VSS.n2572 0.477785
R10709 VSS.n2675 VSS.t598 0.477743
R10710 VSS.t243 VSS.n2627 0.477743
R10711 VSS.t1280 VSS.n2579 0.477743
R10712 VSS.n2483 VSS.t529 0.477743
R10713 VSS.n2474 VSS.t298 0.477743
R10714 VSS.n1425 VSS.t395 0.477743
R10715 VSS.n1418 VSS.t1121 0.477743
R10716 VSS.n1409 VSS.t229 0.477743
R10717 VSS.n1403 VSS.t44 0.477743
R10718 VSS.n1378 VSS.t313 0.477743
R10719 VSS.n1371 VSS.t163 0.477743
R10720 VSS.n1362 VSS.t280 0.477743
R10721 VSS.n1356 VSS.t709 0.477743
R10722 VSS.n1331 VSS.t1189 0.477743
R10723 VSS.n1324 VSS.t602 0.477743
R10724 VSS.n1315 VSS.t221 0.477743
R10725 VSS.n1284 VSS.t621 0.477743
R10726 VSS.n1277 VSS.t662 0.477743
R10727 VSS.n1268 VSS.t596 0.477743
R10728 VSS.n1237 VSS.t812 0.477743
R10729 VSS.n1230 VSS.t468 0.477743
R10730 VSS.n1221 VSS.t264 0.477743
R10731 VSS.n2556 VSS.t500 0.477689
R10732 VSS.n2508 VSS.t60 0.477689
R10733 VSS.t728 VSS.n2171 0.477689
R10734 VSS.t550 VSS.n2170 0.477689
R10735 VSS.t548 VSS.n2169 0.477689
R10736 VSS.t707 VSS.n2168 0.477689
R10737 VSS.t705 VSS.n2167 0.477689
R10738 VSS.t2019 VSS.n2166 0.477689
R10739 VSS.t2022 VSS.n2165 0.477689
R10740 VSS.t526 VSS.n2164 0.477689
R10741 VSS.t524 VSS.n2163 0.477689
R10742 VSS.t1650 VSS.n2162 0.477689
R10743 VSS.t1648 VSS.n2161 0.477689
R10744 VSS.t757 VSS.n2160 0.477689
R10745 VSS.t755 VSS.n2159 0.477689
R10746 VSS.t744 VSS.n2158 0.477689
R10747 VSS.t742 VSS.n2157 0.477689
R10748 VSS.t1626 VSS.n2156 0.477689
R10749 VSS.t1624 VSS.n2155 0.477689
R10750 VSS.t346 VSS.n2154 0.477689
R10751 VSS.t344 VSS.n2153 0.477689
R10752 VSS.t1646 VSS.n2152 0.477689
R10753 VSS.t1644 VSS.n2151 0.477689
R10754 VSS.t619 VSS.n2150 0.477689
R10755 VSS.t617 VSS.n2149 0.477689
R10756 VSS.t1811 VSS.n2148 0.477689
R10757 VSS.t1236 VSS.n2147 0.477689
R10758 VSS.t1320 VSS.n2146 0.477689
R10759 VSS.t1400 VSS.n2145 0.477689
R10760 VSS.t447 VSS.n2144 0.477689
R10761 VSS.t445 VSS.n2143 0.477689
R10762 VSS.t84 VSS.n2142 0.477689
R10763 VSS.t388 VSS.n2141 0.477689
R10764 VSS.t538 VSS.n919 0.477689
R10765 VSS.t117 VSS.n918 0.477689
R10766 VSS.t39 VSS.n917 0.477689
R10767 VSS.t796 VSS.n916 0.477689
R10768 VSS.t442 VSS.n915 0.477689
R10769 VSS.t262 VSS.n914 0.477689
R10770 VSS.t653 VSS.n913 0.477689
R10771 VSS.t317 VSS.n912 0.477689
R10772 VSS.t456 VSS.n911 0.477689
R10773 VSS.t711 VSS.n910 0.477689
R10774 VSS.t295 VSS.n909 0.477689
R10775 VSS.t271 VSS.n908 0.477689
R10776 VSS.t438 VSS.n907 0.477689
R10777 VSS.t330 VSS.n906 0.477689
R10778 VSS.t676 VSS.n905 0.477689
R10779 VSS.t436 VSS.n904 0.477689
R10780 VSS.t50 VSS.n903 0.477689
R10781 VSS.t203 VSS.n902 0.477689
R10782 VSS.t1428 VSS.n901 0.477689
R10783 VSS.t115 VSS.n900 0.477689
R10784 VSS.t497 VSS.n899 0.477689
R10785 VSS.t209 VSS.n898 0.477689
R10786 VSS.t502 VSS.n897 0.477689
R10787 VSS.t1180 VSS.n896 0.477689
R10788 VSS.t48 VSS.n895 0.477689
R10789 VSS.t614 VSS.n894 0.477689
R10790 VSS.t88 VSS.n893 0.477689
R10791 VSS.t183 VSS.n892 0.477689
R10792 VSS.t782 VSS.n891 0.477689
R10793 VSS.t219 VSS.n890 0.477689
R10794 VSS.t348 VSS.n889 0.477689
R10795 VSS.t746 VSS.n632 0.477689
R10796 VSS.t248 VSS.n631 0.477689
R10797 VSS.t1652 VSS.n630 0.477689
R10798 VSS.t72 VSS.n629 0.477689
R10799 VSS.t627 VSS.n628 0.477689
R10800 VSS.t75 VSS.n627 0.477689
R10801 VSS.t169 VSS.n626 0.477689
R10802 VSS.t173 VSS.n625 0.477689
R10803 VSS.t291 VSS.n624 0.477689
R10804 VSS.t542 VSS.n623 0.477689
R10805 VSS.t171 VSS.n622 0.477689
R10806 VSS.t1573 VSS.n621 0.477689
R10807 VSS.t1148 VSS.n620 0.477689
R10808 VSS.t293 VSS.n619 0.477689
R10809 VSS.t1571 VSS.n618 0.477689
R10810 VSS.t266 VSS.n617 0.477689
R10811 VSS.t165 VSS.n616 0.477689
R10812 VSS.t167 VSS.n615 0.477689
R10813 VSS.t1931 VSS.n614 0.477689
R10814 VSS.t748 VSS.n613 0.477689
R10815 VSS.t1569 VSS.n612 0.477689
R10816 VSS.t1150 VSS.n611 0.477689
R10817 VSS.t485 VSS.n610 0.477689
R10818 VSS.t546 VSS.n609 0.477689
R10819 VSS.t544 VSS.n608 0.477689
R10820 VSS.t487 VSS.n607 0.477689
R10821 VSS.t580 VSS.n606 0.477689
R10822 VSS.t1606 VSS.n605 0.477689
R10823 VSS.t489 VSS.n604 0.477689
R10824 VSS.t268 VSS.n603 0.477689
R10825 VSS.t750 VSS.n602 0.477689
R10826 VSS.t660 VSS.n2492 0.477685
R10827 VSS.t600 VSS.n2667 0.47766
R10828 VSS.t664 VSS.n2539 0.47766
R10829 VSS.t276 VSS.n2467 0.47766
R10830 VSS.t278 VSS.n2459 0.47766
R10831 VSS.t324 VSS.n2660 0.47764
R10832 VSS.t1725 VSS.n2612 0.47764
R10833 VSS.t64 VSS.n2564 0.47764
R10834 VSS.t415 VSS.n2532 0.47764
R10835 VSS.t1224 VSS.n2524 0.47764
R10836 VSS.t161 VSS.n2452 0.47764
R10837 VSS.n2682 VSS.t1292 0.47756
R10838 VSS.n2634 VSS.t1138 0.47756
R10839 VSS.n2586 VSS.t491 0.47756
R10840 VSS.t305 VSS.n2547 0.47756
R10841 VSS.n1434 VSS.t215 0.477515
R10842 VSS.n1396 VSS.t194 0.477515
R10843 VSS.n1387 VSS.t175 0.477515
R10844 VSS.n1349 VSS.t223 0.477515
R10845 VSS.n1340 VSS.t217 0.477515
R10846 VSS.n1309 VSS.t732 0.477515
R10847 VSS.n1302 VSS.t552 0.477515
R10848 VSS.n1293 VSS.t1416 0.477515
R10849 VSS.n1262 VSS.t449 0.477515
R10850 VSS.n1255 VSS.t99 0.477515
R10851 VSS.n1246 VSS.t289 0.477515
R10852 VSS.n1214 VSS.t226 0.477515
R10853 VSS.n1207 VSS.t185 0.477515
R10854 VSS.n1198 VSS.t1152 0.477515
R10855 VSS.n2692 VSS.t66 0.477488
R10856 VSS.n2644 VSS.t666 0.477488
R10857 VSS.n2596 VSS.t624 0.477488
R10858 VSS.n2500 VSS.t302 0.477488
R10859 VSS.t1290 VSS.n2652 0.477451
R10860 VSS.t452 VSS.n2604 0.477451
R10861 VSS.t611 VSS.n2516 0.477451
R10862 VSS.n1814 VSS.n1572 0.47741
R10863 VSS.t284 VSS.n2885 0.477286
R10864 VSS.t284 VSS.n2886 0.472981
R10865 VSS.t1156 VSS.n2805 0.467137
R10866 VSS.n2809 VSS.t1665 0.467079
R10867 VSS.n2803 VSS.t300 0.467079
R10868 VSS.n2797 VSS.t307 0.467079
R10869 VSS.t413 VSS.n2799 0.467079
R10870 VSS.t1282 VSS.n2793 0.467079
R10871 VSS.t245 VSS.n2787 0.467079
R10872 VSS.t1754 VSS.n2781 0.467079
R10873 VSS.t1583 VSS.n2784 0.467061
R10874 VSS.t1751 VSS.n2791 0.46695
R10875 VSS.t1685 VSS.n2785 0.46695
R10876 VSS.t1272 VSS.n2808 0.466877
R10877 VSS.t1277 VSS.n2802 0.466877
R10878 VSS.t1373 VSS.n2796 0.466877
R10879 VSS.t454 VSS.n2790 0.466877
R10880 VSS.n2783 VSS.t326 0.466867
R10881 VSS.t254 VSS.n2807 0.466867
R10882 VSS.t1715 VSS.n2801 0.466867
R10883 VSS.t62 VSS.n2795 0.466867
R10884 VSS.t1729 VSS.n2789 0.466867
R10885 VSS.t418 VSS.n2792 0.466777
R10886 VSS.t138 VSS.n2786 0.466777
R10887 VSS.t42 VSS.n2780 0.466777
R10888 VSS.t405 VSS.n2806 0.466752
R10889 VSS.n2800 VSS.t421 0.466752
R10890 VSS.n2794 VSS.t483 0.466752
R10891 VSS.n2788 VSS.t1376 0.466752
R10892 VSS.n2782 VSS.t699 0.466752
R10893 VSS.t594 VSS.n2810 0.466686
R10894 VSS.t1135 VSS.n2804 0.466686
R10895 VSS.t135 VSS.n2798 0.466686
R10896 VSS.t1178 VSS.n1179 0.466542
R10897 VSS.t211 VSS.n1177 0.466542
R10898 VSS.t411 VSS.n1174 0.466542
R10899 VSS.t466 VSS.n1172 0.466542
R10900 VSS.t282 VSS.n1170 0.466542
R10901 VSS.t2222 VSS.n1167 0.466542
R10902 VSS.t536 VSS.n1165 0.466542
R10903 VSS.t1474 VSS.n1163 0.466542
R10904 VSS.t1418 VSS.n1160 0.466542
R10905 VSS.t360 VSS.n1158 0.466542
R10906 VSS.t534 VSS.n1156 0.466542
R10907 VSS.t286 VSS.n1153 0.466542
R10908 VSS.t311 VSS.n1151 0.466542
R10909 VSS.t27 VSS.n1149 0.466542
R10910 VSS.t1124 VSS.n1147 0.466542
R10911 VSS.t673 VSS.n2284 0.466542
R10912 VSS.t1365 VSS.n2277 0.466542
R10913 VSS.t1335 VSS.n2270 0.466542
R10914 VSS.t1337 VSS.n2263 0.466542
R10915 VSS.t1329 VSS.n2256 0.466542
R10916 VSS.t1510 VSS.n2249 0.466542
R10917 VSS.t1363 VSS.n2242 0.466542
R10918 VSS.t2073 VSS.n2235 0.466542
R10919 VSS.t1917 VSS.n2228 0.466542
R10920 VSS.t1920 VSS.n2221 0.466542
R10921 VSS.t1824 VSS.n2214 0.466542
R10922 VSS.t1404 VSS.n2207 0.466542
R10923 VSS.t1256 VSS.n2200 0.466542
R10924 VSS.t1502 VSS.n2193 0.466542
R10925 VSS.t1913 VSS.n2186 0.466542
R10926 VSS.t1213 VSS.n1032 0.466542
R10927 VSS.t86 VSS.n1025 0.466542
R10928 VSS.t46 VSS.n1018 0.466542
R10929 VSS.t1703 VSS.n1011 0.466542
R10930 VSS.t1173 VSS.n1004 0.466542
R10931 VSS.t235 VSS.n997 0.466542
R10932 VSS.t52 VSS.n990 0.466542
R10933 VSS.t29 VSS.n983 0.466542
R10934 VSS.t440 VSS.n976 0.466542
R10935 VSS.t609 VSS.n969 0.466542
R10936 VSS.t1485 VSS.n962 0.466542
R10937 VSS.t512 VSS.n955 0.466542
R10938 VSS.t1233 VSS.n948 0.466542
R10939 VSS.t804 VSS.n941 0.466542
R10940 VSS.t681 VSS.n934 0.466542
R10941 VSS.t1347 VSS.t1979 0.466542
R10942 VSS.t1621 VSS.t671 0.466542
R10943 VSS.t578 VSS.t1402 0.466542
R10944 VSS.t1615 VSS.t532 0.466542
R10945 VSS.t566 VSS.t1740 0.466542
R10946 VSS.t372 VSS.t309 0.466542
R10947 VSS.t557 VSS.t1675 0.466542
R10948 VSS.t1618 VSS.t1327 0.466542
R10949 VSS.t575 VSS.t1325 0.466542
R10950 VSS.t1612 VSS.t1701 0.466542
R10951 VSS.t563 VSS.t1902 0.466542
R10952 VSS.t159 VSS.t459 0.466542
R10953 VSS.t560 VSS.t461 0.466542
R10954 VSS.t1598 VSS.t669 0.466542
R10955 VSS.t150 VSS.t1323 0.466542
R10956 VSS.n641 VSS.t1414 0.466192
R10957 VSS.n646 VSS.t572 0.466192
R10958 VSS.n651 VSS.t1318 0.466192
R10959 VSS.n656 VSS.t378 0.466192
R10960 VSS.n661 VSS.t147 0.466192
R10961 VSS.n666 VSS.t381 0.466192
R10962 VSS.n671 VSS.t153 0.466192
R10963 VSS.n676 VSS.t366 0.466192
R10964 VSS.n681 VSS.t141 0.466192
R10965 VSS.n686 VSS.t375 0.466192
R10966 VSS.n691 VSS.t144 0.466192
R10967 VSS.n696 VSS.t384 0.466192
R10968 VSS.n701 VSS.t156 0.466192
R10969 VSS.n706 VSS.t369 0.466192
R10970 VSS.n711 VSS.t1315 0.466192
R10971 VSS.n716 VSS.t569 0.466192
R10972 VSS.n2285 VSS.t105 0.466192
R10973 VSS.n2278 VSS.t508 0.466192
R10974 VSS.n2271 VSS.t181 0.466192
R10975 VSS.n2264 VSS.t1270 0.466192
R10976 VSS.n2257 VSS.t241 0.466192
R10977 VSS.n2250 VSS.t1564 0.466192
R10978 VSS.n2243 VSS.t1589 0.466192
R10979 VSS.n2236 VSS.t505 0.466192
R10980 VSS.n2229 VSS.t178 0.466192
R10981 VSS.n2222 VSS.t1267 0.466192
R10982 VSS.n2215 VSS.t238 0.466192
R10983 VSS.n2208 VSS.t1567 0.466192
R10984 VSS.n2201 VSS.t1592 0.466192
R10985 VSS.n2194 VSS.t1948 0.466192
R10986 VSS.n2187 VSS.t102 0.466192
R10987 VSS.n2180 VSS.t1559 0.466192
R10988 VSS.n1180 VSS.t518 0.466192
R10989 VSS.n1178 VSS.t108 0.466192
R10990 VSS.n1175 VSS.t196 0.466192
R10991 VSS.n1173 VSS.t315 0.466192
R10992 VSS.n1171 VSS.t724 0.466192
R10993 VSS.n1168 VSS.t464 0.466192
R10994 VSS.n1166 VSS.t715 0.466192
R10995 VSS.n1164 VSS.t321 0.466192
R10996 VSS.n1161 VSS.t1248 0.466192
R10997 VSS.n1159 VSS.t633 0.466192
R10998 VSS.n1157 VSS.t721 0.466192
R10999 VSS.n1154 VSS.t97 0.466192
R11000 VSS.n1152 VSS.t718 0.466192
R11001 VSS.n1150 VSS.t111 0.466192
R11002 VSS.n1148 VSS.t187 0.466192
R11003 VSS.n1146 VSS.t126 0.466192
R11004 VSS.n1033 VSS.t402 0.466192
R11005 VSS.n1026 VSS.t657 0.466192
R11006 VSS.n1019 VSS.t1398 0.466192
R11007 VSS.n1012 VSS.t1182 0.466192
R11008 VSS.n1005 VSS.t341 0.466192
R11009 VSS.n998 VSS.t113 0.466192
R11010 VSS.n991 VSS.t1350 0.466192
R11011 VSS.n984 VSS.t434 0.466192
R11012 VSS.n977 VSS.t332 0.466192
R11013 VSS.n970 VSS.t273 0.466192
R11014 VSS.n963 VSS.t1355 0.466192
R11015 VSS.n956 VSS.t319 0.466192
R11016 VSS.n949 VSS.t1127 0.466192
R11017 VSS.n942 VSS.t798 0.466192
R11018 VSS.n935 VSS.t119 0.466192
R11019 VSS.n928 VSS.t1450 0.466192
R11020 VSS.n1818 VSS.t6 0.464894
R11021 VSS.n1716 VSS.t510 0.462947
R11022 VSS.n1816 VSS.n1814 0.460744
R11023 VSS.n1817 VSS.n1816 0.455207
R11024 VSS.n2180 VSS.t1913 0.451785
R11025 VSS.n2187 VSS.t1502 0.451785
R11026 VSS.n2194 VSS.t1256 0.451785
R11027 VSS.n2201 VSS.t1404 0.451785
R11028 VSS.n2208 VSS.t1824 0.451785
R11029 VSS.n2215 VSS.t1920 0.451785
R11030 VSS.n2222 VSS.t1917 0.451785
R11031 VSS.n2229 VSS.t2073 0.451785
R11032 VSS.n2236 VSS.t1363 0.451785
R11033 VSS.n2243 VSS.t1510 0.451785
R11034 VSS.n2250 VSS.t1329 0.451785
R11035 VSS.n2257 VSS.t1337 0.451785
R11036 VSS.n2264 VSS.t1335 0.451785
R11037 VSS.n2271 VSS.t1365 0.451785
R11038 VSS.n2278 VSS.t673 0.451785
R11039 VSS.n2285 VSS.t386 0.451785
R11040 VSS.t1124 VSS.n1146 0.451785
R11041 VSS.t27 VSS.n1148 0.451785
R11042 VSS.t311 VSS.n1150 0.451785
R11043 VSS.t286 VSS.n1152 0.451785
R11044 VSS.t534 VSS.n1154 0.451785
R11045 VSS.t360 VSS.n1157 0.451785
R11046 VSS.t1418 VSS.n1159 0.451785
R11047 VSS.t1474 VSS.n1161 0.451785
R11048 VSS.t536 VSS.n1164 0.451785
R11049 VSS.t2222 VSS.n1166 0.451785
R11050 VSS.t282 VSS.n1168 0.451785
R11051 VSS.t466 VSS.n1171 0.451785
R11052 VSS.t411 VSS.n1173 0.451785
R11053 VSS.t211 VSS.n1175 0.451785
R11054 VSS.t1178 VSS.n1178 0.451785
R11055 VSS.t521 VSS.n1180 0.451785
R11056 VSS.n928 VSS.t681 0.451785
R11057 VSS.n935 VSS.t804 0.451785
R11058 VSS.n942 VSS.t1233 0.451785
R11059 VSS.n949 VSS.t512 0.451785
R11060 VSS.n956 VSS.t1485 0.451785
R11061 VSS.n963 VSS.t609 0.451785
R11062 VSS.n970 VSS.t440 0.451785
R11063 VSS.n977 VSS.t29 0.451785
R11064 VSS.n984 VSS.t52 0.451785
R11065 VSS.n991 VSS.t235 0.451785
R11066 VSS.n998 VSS.t1173 0.451785
R11067 VSS.n1005 VSS.t1703 0.451785
R11068 VSS.n1012 VSS.t46 0.451785
R11069 VSS.n1019 VSS.t86 0.451785
R11070 VSS.n1026 VSS.t1213 0.451785
R11071 VSS.n1033 VSS.t794 0.451785
R11072 VSS.t1231 VSS.n716 0.451785
R11073 VSS.t1979 VSS.n711 0.451785
R11074 VSS.t671 VSS.n706 0.451785
R11075 VSS.t1402 VSS.n701 0.451785
R11076 VSS.t532 VSS.n696 0.451785
R11077 VSS.t1740 VSS.n691 0.451785
R11078 VSS.t309 VSS.n686 0.451785
R11079 VSS.t1675 VSS.n681 0.451785
R11080 VSS.t1327 VSS.n676 0.451785
R11081 VSS.t1325 VSS.n671 0.451785
R11082 VSS.t1701 VSS.n666 0.451785
R11083 VSS.t1902 VSS.n661 0.451785
R11084 VSS.t459 VSS.n656 0.451785
R11085 VSS.t461 VSS.n651 0.451785
R11086 VSS.t669 VSS.n646 0.451785
R11087 VSS.t1323 VSS.n641 0.451785
R11088 VSS.t105 VSS.n2284 0.451337
R11089 VSS.t508 VSS.n2277 0.451337
R11090 VSS.t181 VSS.n2270 0.451337
R11091 VSS.t1270 VSS.n2263 0.451337
R11092 VSS.t241 VSS.n2256 0.451337
R11093 VSS.t1564 VSS.n2249 0.451337
R11094 VSS.t1589 VSS.n2242 0.451337
R11095 VSS.t505 VSS.n2235 0.451337
R11096 VSS.t178 VSS.n2228 0.451337
R11097 VSS.t1267 VSS.n2221 0.451337
R11098 VSS.t238 VSS.n2214 0.451337
R11099 VSS.t1567 VSS.n2207 0.451337
R11100 VSS.t1592 VSS.n2200 0.451337
R11101 VSS.t1948 VSS.n2193 0.451337
R11102 VSS.t102 VSS.n2186 0.451337
R11103 VSS.t518 VSS.n1179 0.451337
R11104 VSS.t108 VSS.n1177 0.451337
R11105 VSS.t196 VSS.n1174 0.451337
R11106 VSS.t315 VSS.n1172 0.451337
R11107 VSS.t724 VSS.n1170 0.451337
R11108 VSS.t464 VSS.n1167 0.451337
R11109 VSS.t715 VSS.n1165 0.451337
R11110 VSS.t321 VSS.n1163 0.451337
R11111 VSS.t1248 VSS.n1160 0.451337
R11112 VSS.t633 VSS.n1158 0.451337
R11113 VSS.t721 VSS.n1156 0.451337
R11114 VSS.t97 VSS.n1153 0.451337
R11115 VSS.t718 VSS.n1151 0.451337
R11116 VSS.t111 VSS.n1149 0.451337
R11117 VSS.t187 VSS.n1147 0.451337
R11118 VSS.t402 VSS.n1032 0.451337
R11119 VSS.t657 VSS.n1025 0.451337
R11120 VSS.t1398 VSS.n1018 0.451337
R11121 VSS.t1182 VSS.n1011 0.451337
R11122 VSS.t341 VSS.n1004 0.451337
R11123 VSS.t113 VSS.n997 0.451337
R11124 VSS.t1350 VSS.n990 0.451337
R11125 VSS.t434 VSS.n983 0.451337
R11126 VSS.t332 VSS.n976 0.451337
R11127 VSS.t273 VSS.n969 0.451337
R11128 VSS.t1355 VSS.n962 0.451337
R11129 VSS.t319 VSS.n955 0.451337
R11130 VSS.t1127 VSS.n948 0.451337
R11131 VSS.t798 VSS.n941 0.451337
R11132 VSS.t119 VSS.n934 0.451337
R11133 VSS.t150 VSS.t572 0.451337
R11134 VSS.t1598 VSS.t1318 0.451337
R11135 VSS.t560 VSS.t378 0.451337
R11136 VSS.t159 VSS.t147 0.451337
R11137 VSS.t563 VSS.t381 0.451337
R11138 VSS.t1612 VSS.t153 0.451337
R11139 VSS.t575 VSS.t366 0.451337
R11140 VSS.t1618 VSS.t141 0.451337
R11141 VSS.t557 VSS.t375 0.451337
R11142 VSS.t372 VSS.t144 0.451337
R11143 VSS.t566 VSS.t384 0.451337
R11144 VSS.t1615 VSS.t156 0.451337
R11145 VSS.t578 VSS.t369 0.451337
R11146 VSS.t1621 VSS.t1315 0.451337
R11147 VSS.t1347 VSS.t569 0.451337
R11148 VSS.n2810 VSS.t1665 0.451261
R11149 VSS.n2804 VSS.t300 0.451261
R11150 VSS.n2798 VSS.t307 0.451261
R11151 VSS.n2792 VSS.t1751 0.451143
R11152 VSS.n2786 VSS.t1685 0.451143
R11153 VSS.n2780 VSS.t68 0.451143
R11154 VSS.n2806 VSS.t1156 0.451136
R11155 VSS.n2800 VSS.t413 0.451136
R11156 VSS.n2794 VSS.t1282 0.451136
R11157 VSS.n2788 VSS.t245 0.451136
R11158 VSS.n2782 VSS.t1754 0.451136
R11159 VSS.n2807 VSS.t405 0.451074
R11160 VSS.n2801 VSS.t421 0.451074
R11161 VSS.n2795 VSS.t483 0.451074
R11162 VSS.n2789 VSS.t1376 0.451074
R11163 VSS.n2783 VSS.t699 0.451074
R11164 VSS.n2808 VSS.t254 0.451048
R11165 VSS.n2802 VSS.t1715 0.451048
R11166 VSS.n2796 VSS.t62 0.451048
R11167 VSS.n2790 VSS.t1729 0.451048
R11168 VSS.n2791 VSS.t454 0.450975
R11169 VSS.n2785 VSS.t1583 0.450975
R11170 VSS.n2809 VSS.t1272 0.450883
R11171 VSS.n2803 VSS.t1277 0.450883
R11172 VSS.n2799 VSS.t135 0.450883
R11173 VSS.n2797 VSS.t1373 0.450883
R11174 VSS.n2793 VSS.t418 0.450883
R11175 VSS.n2787 VSS.t138 0.450883
R11176 VSS.n2781 VSS.t42 0.450883
R11177 VSS.n2784 VSS.t326 0.450853
R11178 VSS.n2805 VSS.t1135 0.450834
R11179 VSS.n1608 VSS.n1607 0.447348
R11180 VSS.n3042 VSS.n3041 0.44402
R11181 VSS.n3046 VSS.n3045 0.44402
R11182 VSS.n2856 VSS.n2855 0.44402
R11183 VSS.n2852 VSS.n2374 0.44402
R11184 VSS.t1224 VSS.n2516 0.440502
R11185 VSS.t1725 VSS.n2604 0.440502
R11186 VSS.t324 VSS.n2652 0.440502
R11187 VSS.n2500 VSS.t60 0.440463
R11188 VSS.n2596 VSS.t452 0.440463
R11189 VSS.n2644 VSS.t1290 0.440463
R11190 VSS.n2692 VSS.t730 0.440463
R11191 VSS.n1434 VSS.t753 0.440369
R11192 VSS.n1396 VSS.t44 0.440369
R11193 VSS.n1387 VSS.t194 0.440369
R11194 VSS.n1349 VSS.t709 0.440369
R11195 VSS.n1340 VSS.t223 0.440369
R11196 VSS.n1309 VSS.t221 0.440369
R11197 VSS.n1302 VSS.t732 0.440369
R11198 VSS.n1293 VSS.t552 0.440369
R11199 VSS.n1262 VSS.t596 0.440369
R11200 VSS.n1255 VSS.t449 0.440369
R11201 VSS.n1246 VSS.t99 0.440369
R11202 VSS.n1214 VSS.t264 0.440369
R11203 VSS.n1207 VSS.t226 0.440369
R11204 VSS.n1198 VSS.t185 0.440369
R11205 VSS.t500 VSS.n2547 0.440319
R11206 VSS.t624 VSS.n2586 0.440319
R11207 VSS.t666 VSS.n2634 0.440319
R11208 VSS.t66 VSS.n2682 0.440319
R11209 VSS.t278 VSS.n2452 0.44028
R11210 VSS.t415 VSS.n2524 0.44028
R11211 VSS.t664 VSS.n2532 0.44028
R11212 VSS.t481 VSS.n2564 0.44028
R11213 VSS.t1378 VSS.n2612 0.44028
R11214 VSS.t600 VSS.n2660 0.44028
R11215 VSS.t302 VSS.n2492 0.440231
R11216 VSS.t707 VSS.n2169 0.440228
R11217 VSS.t1650 VSS.n2163 0.440228
R11218 VSS.t744 VSS.n2159 0.440228
R11219 VSS.t1626 VSS.n2157 0.440228
R11220 VSS.t1646 VSS.n2153 0.440228
R11221 VSS.t619 VSS.n2151 0.440228
R11222 VSS.t1320 VSS.n2147 0.440228
R11223 VSS.t447 VSS.n2145 0.440228
R11224 VSS.t1790 VSS.n2141 0.440228
R11225 VSS.t796 VSS.n917 0.440228
R11226 VSS.t262 VSS.n915 0.440228
R11227 VSS.t711 VSS.n911 0.440228
R11228 VSS.t271 VSS.n909 0.440228
R11229 VSS.t436 VSS.n905 0.440228
R11230 VSS.t203 VSS.n903 0.440228
R11231 VSS.t209 VSS.n899 0.440228
R11232 VSS.t502 VSS.n898 0.440228
R11233 VSS.t1180 VSS.n897 0.440228
R11234 VSS.t183 VSS.n893 0.440228
R11235 VSS.t782 VSS.n892 0.440228
R11236 VSS.t248 VSS.n632 0.440228
R11237 VSS.t173 VSS.n626 0.440228
R11238 VSS.t542 VSS.n624 0.440228
R11239 VSS.t171 VSS.n623 0.440228
R11240 VSS.t1573 VSS.n622 0.440228
R11241 VSS.t167 VSS.n616 0.440228
R11242 VSS.t748 VSS.n614 0.440228
R11243 VSS.t1569 VSS.n613 0.440228
R11244 VSS.t1150 VSS.n612 0.440228
R11245 VSS.t1606 VSS.n606 0.440228
R11246 VSS.t268 VSS.n604 0.440228
R11247 VSS.t750 VSS.n603 0.440228
R11248 VSS.t2139 VSS.n602 0.440228
R11249 VSS.n2142 VSS.t388 0.440228
R11250 VSS.n2143 VSS.t84 0.440228
R11251 VSS.n2144 VSS.t445 0.440228
R11252 VSS.n2146 VSS.t1400 0.440228
R11253 VSS.n2148 VSS.t1236 0.440228
R11254 VSS.n2149 VSS.t1811 0.440228
R11255 VSS.n2150 VSS.t617 0.440228
R11256 VSS.n2152 VSS.t1644 0.440228
R11257 VSS.n2154 VSS.t344 0.440228
R11258 VSS.n2155 VSS.t346 0.440228
R11259 VSS.n2156 VSS.t1624 0.440228
R11260 VSS.n2158 VSS.t742 0.440228
R11261 VSS.n2160 VSS.t755 0.440228
R11262 VSS.n2161 VSS.t757 0.440228
R11263 VSS.n2162 VSS.t1648 0.440228
R11264 VSS.n2164 VSS.t524 0.440228
R11265 VSS.n2165 VSS.t526 0.440228
R11266 VSS.n2166 VSS.t2022 0.440228
R11267 VSS.n2167 VSS.t2019 0.440228
R11268 VSS.n2168 VSS.t705 0.440228
R11269 VSS.n2170 VSS.t548 0.440228
R11270 VSS.n2171 VSS.t550 0.440228
R11271 VSS.n605 VSS.t489 0.440228
R11272 VSS.n607 VSS.t580 0.440228
R11273 VSS.n608 VSS.t487 0.440228
R11274 VSS.n609 VSS.t544 0.440228
R11275 VSS.n610 VSS.t546 0.440228
R11276 VSS.n611 VSS.t485 0.440228
R11277 VSS.n615 VSS.t1931 0.440228
R11278 VSS.n617 VSS.t165 0.440228
R11279 VSS.n618 VSS.t266 0.440228
R11280 VSS.n619 VSS.t1571 0.440228
R11281 VSS.n620 VSS.t293 0.440228
R11282 VSS.n621 VSS.t1148 0.440228
R11283 VSS.n625 VSS.t291 0.440228
R11284 VSS.n627 VSS.t169 0.440228
R11285 VSS.n628 VSS.t75 0.440228
R11286 VSS.n629 VSS.t627 0.440228
R11287 VSS.n630 VSS.t72 0.440228
R11288 VSS.n631 VSS.t1652 0.440228
R11289 VSS.n889 VSS.t1628 0.440228
R11290 VSS.n890 VSS.t348 0.440228
R11291 VSS.n891 VSS.t219 0.440228
R11292 VSS.n894 VSS.t88 0.440228
R11293 VSS.n895 VSS.t614 0.440228
R11294 VSS.n896 VSS.t48 0.440228
R11295 VSS.n900 VSS.t497 0.440228
R11296 VSS.n901 VSS.t115 0.440228
R11297 VSS.n902 VSS.t1428 0.440228
R11298 VSS.n904 VSS.t50 0.440228
R11299 VSS.n906 VSS.t676 0.440228
R11300 VSS.n907 VSS.t330 0.440228
R11301 VSS.n908 VSS.t438 0.440228
R11302 VSS.n910 VSS.t295 0.440228
R11303 VSS.n912 VSS.t456 0.440228
R11304 VSS.n913 VSS.t317 0.440228
R11305 VSS.n914 VSS.t653 0.440228
R11306 VSS.n916 VSS.t442 0.440228
R11307 VSS.n918 VSS.t39 0.440228
R11308 VSS.n919 VSS.t117 0.440228
R11309 VSS.n2508 VSS.t611 0.440228
R11310 VSS.n2556 VSS.t64 0.440228
R11311 VSS.t276 VSS.n2459 0.440225
R11312 VSS.t298 VSS.n2467 0.440225
R11313 VSS.t305 VSS.n2539 0.440225
R11314 VSS.t598 VSS.n2667 0.440225
R11315 VSS.t1280 VSS.n2572 0.440136
R11316 VSS.t243 VSS.n2620 0.440136
R11317 VSS.t529 VSS.n2474 0.440116
R11318 VSS.t660 VSS.n2483 0.440116
R11319 VSS.t491 VSS.n2579 0.440116
R11320 VSS.t1138 VSS.n2627 0.440116
R11321 VSS.t1292 VSS.n2675 0.440116
R11322 VSS.t468 VSS.n1221 0.440116
R11323 VSS.t812 VSS.n1230 0.440116
R11324 VSS.t289 VSS.n1237 0.440116
R11325 VSS.t662 VSS.n1268 0.440116
R11326 VSS.t621 VSS.n1277 0.440116
R11327 VSS.t1416 VSS.n1284 0.440116
R11328 VSS.t602 VSS.n1315 0.440116
R11329 VSS.t1189 VSS.n1324 0.440116
R11330 VSS.t217 VSS.n1331 0.440116
R11331 VSS.t280 VSS.n1356 0.440116
R11332 VSS.t163 VSS.n1362 0.440116
R11333 VSS.t313 VSS.n1371 0.440116
R11334 VSS.t175 VSS.n1378 0.440116
R11335 VSS.t229 VSS.n1403 0.440116
R11336 VSS.t1121 VSS.n1409 0.440116
R11337 VSS.t395 VSS.n1418 0.440116
R11338 VSS.t215 VSS.n1425 0.440116
R11339 VSS.t124 VSS.n1540 0.437595
R11340 VSS.n2855 VSS.n1566 0.435807
R11341 VSS.n1570 VSS.n1566 0.427593
R11342 VSS.n3052 VSS.n1567 0.418268
R11343 VSS.n3055 VSS.n3054 0.418268
R11344 VSS.n3054 VSS.n1567 0.414988
R11345 VSS.n3056 VSS.n3055 0.414988
R11346 VSS.n2882 VSS.n1573 0.41014
R11347 VSS.n1886 VSS.n74 0.405262
R11348 VSS.n2978 VSS.n2915 0.376066
R11349 VSS.n2982 VSS.n2979 0.376066
R11350 VSS.n1540 VSS.t2103 0.363709
R11351 VSS.n8 VSS.n3 0.351198
R11352 VSS.t1056 VSS.t1054 0.349031
R11353 VSS.t1036 VSS.t1034 0.349031
R11354 VSS.t82 VSS.t1024 0.349031
R11355 VSS.t1016 VSS.t1014 0.349031
R11356 VSS.t880 VSS.n1714 0.348532
R11357 VSS.t889 VSS.n1699 0.348532
R11358 VSS.t899 VSS.n1685 0.348532
R11359 VSS.t909 VSS.n1671 0.348532
R11360 VSS.t918 VSS.n1657 0.348532
R11361 VSS.t927 VSS.n1632 0.348532
R11362 VSS.t938 VSS.t937 0.348238
R11363 VSS.t949 VSS.t948 0.348238
R11364 VSS.t960 VSS.t959 0.348238
R11365 VSS.t971 VSS.t970 0.348238
R11366 VSS.t982 VSS.t981 0.348238
R11367 VSS.t993 VSS.t992 0.348238
R11368 VSS.t820 VSS.t819 0.348238
R11369 VSS.t830 VSS.t829 0.348238
R11370 VSS.t840 VSS.t839 0.348238
R11371 VSS.t850 VSS.t849 0.348238
R11372 VSS.t860 VSS.t859 0.348238
R11373 VSS.t870 VSS.t869 0.348238
R11374 VSS.n3063 VSS.t2091 0.343959
R11375 VSS.n2942 VSS.n2899 0.338265
R11376 VSS.n2943 VSS.n27 0.338265
R11377 VSS.n3016 VSS.n2899 0.338019
R11378 VSS.n3015 VSS.n27 0.338019
R11379 VSS.n636 VSS.n598 0.330337
R11380 VSS.n3047 VSS.n1530 0.330169
R11381 VSS.n2839 VSS.n2837 0.330169
R11382 VSS.n2853 VSS.n2362 0.329994
R11383 VSS.n3043 VSS.n1110 0.329994
R11384 VSS.t867 VSS.t870 0.323243
R11385 VSS.t857 VSS.t860 0.323243
R11386 VSS.t847 VSS.t850 0.323243
R11387 VSS.t837 VSS.t840 0.323243
R11388 VSS.t827 VSS.t830 0.323243
R11389 VSS.t817 VSS.t820 0.323243
R11390 VSS.n220 VSS.t993 0.0503834
R11391 VSS.n214 VSS.t982 0.0503834
R11392 VSS.n208 VSS.t971 0.0503834
R11393 VSS.n202 VSS.t960 0.0503834
R11394 VSS.n196 VSS.t949 0.0503834
R11395 VSS.n190 VSS.t938 0.0503834
R11396 VSS.n1632 VSS.t925 0.322931
R11397 VSS.n1657 VSS.t916 0.322931
R11398 VSS.n1671 VSS.t907 0.322931
R11399 VSS.n1685 VSS.t897 0.322931
R11400 VSS.n1699 VSS.t887 0.322931
R11401 VSS.n1714 VSS.t878 0.322931
R11402 VSS.n278 VSS.t1044 0.398372
R11403 VSS.n230 VSS.t1003 0.398372
R11404 VSS.t1054 VSS.n284 0.0502676
R11405 VSS.t1034 VSS.n264 0.0502676
R11406 VSS.t1024 VSS.n247 0.0502676
R11407 VSS.t1014 VSS.n236 0.0502676
R11408 VSS.n1597 VSS.n1596 0.312321
R11409 VSS.n3049 VSS.n3048 0.31114
R11410 VSS.t1063 VSS.n503 0.306378
R11411 VSS.t1073 VSS.n517 0.306378
R11412 VSS.t1083 VSS.n533 0.306378
R11413 VSS.t1093 VSS.n557 0.306378
R11414 VSS.t1103 VSS.n573 0.306378
R11415 VSS.t1113 VSS.n588 0.306378
R11416 VSS.n2980 VSS.n2915 0.306341
R11417 VSS.n2982 VSS.n2981 0.306341
R11418 VSS.t730 VSS.t1142 0.302153
R11419 VSS.t1790 VSS.t1251 0.302153
R11420 VSS.t1628 VSS.t350 0.302153
R11421 VSS.t2139 VSS.t1985 0.302153
R11422 VSS.t1455 VSS.t753 0.302137
R11423 VSS.n2438 VSS.t2331 0.300927
R11424 VSS.n2841 VSS.n2820 0.295515
R11425 VSS.n1679 VSS.n1683 0.295287
R11426 VSS.t791 VSS.n203 0.295277
R11427 VSS.t1972 VSS.n2417 0.295277
R11428 VSS.n473 VSS.n3181 0.295237
R11429 VSS.n2851 VSS.n2375 0.29523
R11430 VSS.n3128 VSS.t1144 0.294836
R11431 VSS.n3092 VSS.t477 0.294836
R11432 VSS.n1577 VSS.n1574 0.291601
R11433 VSS.t68 VSS.n2779 0.291234
R11434 VSS.n719 VSS.t1231 0.290734
R11435 VSS.n1041 VSS.t794 0.290734
R11436 VSS.n1181 VSS.t521 0.290734
R11437 VSS.n2293 VSS.t386 0.290734
R11438 VSS.n2969 VSS.n1577 0.287886
R11439 VSS.n2859 VSS.n1634 0.282859
R11440 VSS.n290 VSS.n285 0.247594
R11441 VSS.n3133 VSS.n589 0.282782
R11442 VSS.n222 VSS.n221 0.247384
R11443 VSS.t1263 VSS.n2437 0.282627
R11444 VSS.n2881 VSS.n2880 0.278282
R11445 VSS.t2225 VSS.n1581 0.2761
R11446 VSS.t1559 VSS.n2178 0.275961
R11447 VSS.t126 VSS.n1144 0.275961
R11448 VSS.t1450 VSS.n926 0.275961
R11449 VSS.n802 VSS.t1414 0.275961
R11450 VSS.n3181 VSS.n474 0.275933
R11451 VSS.n2811 VSS.t594 0.275718
R11452 VSS.t2117 VSS.n2842 0.273607
R11453 VSS.t1959 VSS.n3082 0.273607
R11454 VSS.t1522 VSS.n3119 0.273607
R11455 VSS.n1194 VSS.n1193 0.27249
R11456 VSS.n2814 VSS.n2811 0.272321
R11457 VSS.n2359 VSS.n2172 0.272321
R11458 VSS.n1107 VSS.n920 0.272321
R11459 VSS.n804 VSS.n633 0.272321
R11460 VSS.n2813 VSS.n2449 0.272137
R11461 VSS.n2178 VSS.n2179 0.272065
R11462 VSS.n807 VSS.n802 0.272065
R11463 VSS.n926 VSS.n927 0.272065
R11464 VSS.n1144 VSS.n1145 0.272065
R11465 VSS.n382 VSS.n409 0.267794
R11466 VSS.n382 VSS.n411 0.267794
R11467 VSS.n382 VSS.n412 0.267794
R11468 VSS.n382 VSS.n413 0.267794
R11469 VSS.n382 VSS.n469 0.267794
R11470 VSS.n382 VSS.n468 0.267794
R11471 VSS.n382 VSS.n415 0.267794
R11472 VSS.n382 VSS.n467 0.267794
R11473 VSS.n382 VSS.n416 0.267794
R11474 VSS.n382 VSS.n417 0.267794
R11475 VSS.n382 VSS.n418 0.267794
R11476 VSS.n382 VSS.n419 0.267794
R11477 VSS.n382 VSS.n420 0.267794
R11478 VSS.n382 VSS.n421 0.267794
R11479 VSS.n382 VSS.n422 0.267794
R11480 VSS.n382 VSS.n465 0.267794
R11481 VSS.n382 VSS.n423 0.267794
R11482 VSS.n382 VSS.n425 0.267794
R11483 VSS.n382 VSS.n426 0.267794
R11484 VSS.n382 VSS.n427 0.267794
R11485 VSS.n382 VSS.n464 0.267794
R11486 VSS.n382 VSS.n463 0.267794
R11487 VSS.n382 VSS.n429 0.267794
R11488 VSS.n382 VSS.n462 0.267794
R11489 VSS.n382 VSS.n430 0.267794
R11490 VSS.n382 VSS.n431 0.267794
R11491 VSS.n382 VSS.n432 0.267794
R11492 VSS.n382 VSS.n433 0.267794
R11493 VSS.n382 VSS.n434 0.267794
R11494 VSS.n382 VSS.n435 0.267794
R11495 VSS.n382 VSS.n436 0.267794
R11496 VSS.n382 VSS.n460 0.267794
R11497 VSS.n382 VSS.n437 0.267794
R11498 VSS.n382 VSS.n439 0.267794
R11499 VSS.n382 VSS.n440 0.267794
R11500 VSS.n382 VSS.n441 0.267794
R11501 VSS.n382 VSS.n459 0.267794
R11502 VSS.n382 VSS.n458 0.267794
R11503 VSS.n382 VSS.n443 0.267794
R11504 VSS.n382 VSS.n457 0.267794
R11505 VSS.n382 VSS.n444 0.267794
R11506 VSS.n382 VSS.n445 0.267794
R11507 VSS.n382 VSS.n446 0.267794
R11508 VSS.n382 VSS.n447 0.267794
R11509 VSS.n382 VSS.n448 0.267794
R11510 VSS.n382 VSS.n456 0.267794
R11511 VSS.n382 VSS.n455 0.267794
R11512 VSS.n382 VSS.n454 0.267794
R11513 VSS.n382 VSS.n453 0.267794
R11514 VSS.n382 VSS.n387 0.267794
R11515 VSS.n382 VSS.n389 0.267794
R11516 VSS.n382 VSS.n390 0.267794
R11517 VSS.n382 VSS.n391 0.267794
R11518 VSS.n382 VSS.n393 0.267794
R11519 VSS.n382 VSS.n395 0.267794
R11520 VSS.n382 VSS.n396 0.267794
R11521 VSS.n382 VSS.n397 0.267794
R11522 VSS.n382 VSS.n399 0.267794
R11523 VSS.n382 VSS.n401 0.267794
R11524 VSS.n382 VSS.n402 0.267794
R11525 VSS.n382 VSS.n403 0.267794
R11526 VSS.n382 VSS.n405 0.267794
R11527 VSS.n382 VSS.n407 0.267794
R11528 VSS.n382 VSS.n408 0.267794
R11529 VSS.n293 VSS.n377 0.267794
R11530 VSS.n293 VSS.n375 0.267794
R11531 VSS.n293 VSS.n374 0.267794
R11532 VSS.n293 VSS.n321 0.267794
R11533 VSS.n293 VSS.n371 0.267794
R11534 VSS.n293 VSS.n370 0.267794
R11535 VSS.n293 VSS.n322 0.267794
R11536 VSS.n293 VSS.n368 0.267794
R11537 VSS.n293 VSS.n367 0.267794
R11538 VSS.n293 VSS.n323 0.267794
R11539 VSS.n293 VSS.n364 0.267794
R11540 VSS.n293 VSS.n324 0.267794
R11541 VSS.n293 VSS.n363 0.267794
R11542 VSS.n293 VSS.n361 0.267794
R11543 VSS.n293 VSS.n360 0.267794
R11544 VSS.n293 VSS.n359 0.267794
R11545 VSS.n293 VSS.n325 0.267794
R11546 VSS.n293 VSS.n356 0.267794
R11547 VSS.n293 VSS.n326 0.267794
R11548 VSS.n293 VSS.n355 0.267794
R11549 VSS.n293 VSS.n353 0.267794
R11550 VSS.n293 VSS.n352 0.267794
R11551 VSS.n293 VSS.n351 0.267794
R11552 VSS.n293 VSS.n327 0.267794
R11553 VSS.n293 VSS.n348 0.267794
R11554 VSS.n293 VSS.n328 0.267794
R11555 VSS.n293 VSS.n347 0.267794
R11556 VSS.n293 VSS.n345 0.267794
R11557 VSS.n293 VSS.n344 0.267794
R11558 VSS.n293 VSS.n343 0.267794
R11559 VSS.n293 VSS.n329 0.267794
R11560 VSS.n293 VSS.n330 0.267794
R11561 VSS.n293 VSS.n340 0.267794
R11562 VSS.n293 VSS.n331 0.267794
R11563 VSS.n293 VSS.n339 0.267794
R11564 VSS.n293 VSS.n337 0.267794
R11565 VSS.n293 VSS.n336 0.267794
R11566 VSS.n293 VSS.n335 0.267794
R11567 VSS.n293 VSS.n294 0.267794
R11568 VSS.n293 VSS.n296 0.267794
R11569 VSS.n293 VSS.n297 0.267794
R11570 VSS.n293 VSS.n298 0.267794
R11571 VSS.n293 VSS.n299 0.267794
R11572 VSS.n293 VSS.n300 0.267794
R11573 VSS.n293 VSS.n301 0.267794
R11574 VSS.n293 VSS.n302 0.267794
R11575 VSS.n293 VSS.n303 0.267794
R11576 VSS.n293 VSS.n304 0.267794
R11577 VSS.n293 VSS.n305 0.267794
R11578 VSS.n293 VSS.n306 0.267794
R11579 VSS.n293 VSS.n307 0.267794
R11580 VSS.n293 VSS.n308 0.267794
R11581 VSS.n293 VSS.n309 0.267794
R11582 VSS.n293 VSS.n310 0.267794
R11583 VSS.n293 VSS.n311 0.267794
R11584 VSS.n293 VSS.n312 0.267794
R11585 VSS.n293 VSS.n313 0.267794
R11586 VSS.n293 VSS.n314 0.267794
R11587 VSS.n293 VSS.n315 0.267794
R11588 VSS.n293 VSS.n316 0.267794
R11589 VSS.n293 VSS.n317 0.267794
R11590 VSS.n293 VSS.n318 0.267794
R11591 VSS.n293 VSS.n319 0.267794
R11592 VSS.n293 VSS.n320 0.267794
R11593 VSS.n3079 VSS.n1446 0.267794
R11594 VSS.n98 VSS.n182 0.267794
R11595 VSS.n98 VSS.n180 0.267794
R11596 VSS.n98 VSS.n128 0.267794
R11597 VSS.n98 VSS.n129 0.267794
R11598 VSS.n98 VSS.n178 0.267794
R11599 VSS.n98 VSS.n177 0.267794
R11600 VSS.n98 VSS.n176 0.267794
R11601 VSS.n98 VSS.n174 0.267794
R11602 VSS.n98 VSS.n173 0.267794
R11603 VSS.n98 VSS.n172 0.267794
R11604 VSS.n98 VSS.n131 0.267794
R11605 VSS.n98 VSS.n170 0.267794
R11606 VSS.n98 VSS.n169 0.267794
R11607 VSS.n98 VSS.n168 0.267794
R11608 VSS.n98 VSS.n166 0.267794
R11609 VSS.n98 VSS.n165 0.267794
R11610 VSS.n98 VSS.n164 0.267794
R11611 VSS.n98 VSS.n133 0.267794
R11612 VSS.n98 VSS.n162 0.267794
R11613 VSS.n98 VSS.n161 0.267794
R11614 VSS.n98 VSS.n160 0.267794
R11615 VSS.n98 VSS.n134 0.267794
R11616 VSS.n98 VSS.n158 0.267794
R11617 VSS.n98 VSS.n157 0.267794
R11618 VSS.n98 VSS.n136 0.267794
R11619 VSS.n98 VSS.n155 0.267794
R11620 VSS.n98 VSS.n154 0.267794
R11621 VSS.n98 VSS.n153 0.267794
R11622 VSS.n98 VSS.n137 0.267794
R11623 VSS.n98 VSS.n150 0.267794
R11624 VSS.n98 VSS.n138 0.267794
R11625 VSS.n98 VSS.n149 0.267794
R11626 VSS.n98 VSS.n139 0.267794
R11627 VSS.n98 VSS.n147 0.267794
R11628 VSS.n98 VSS.n146 0.267794
R11629 VSS.n98 VSS.n140 0.267794
R11630 VSS.n98 VSS.n99 0.267794
R11631 VSS.n98 VSS.n100 0.267794
R11632 VSS.n98 VSS.n101 0.267794
R11633 VSS.n98 VSS.n102 0.267794
R11634 VSS.n98 VSS.n103 0.267794
R11635 VSS.n98 VSS.n104 0.267794
R11636 VSS.n98 VSS.n105 0.267794
R11637 VSS.n98 VSS.n106 0.267794
R11638 VSS.n98 VSS.n107 0.267794
R11639 VSS.n98 VSS.n108 0.267794
R11640 VSS.n98 VSS.n109 0.267794
R11641 VSS.n98 VSS.n110 0.267794
R11642 VSS.n98 VSS.n111 0.267794
R11643 VSS.n98 VSS.n112 0.267794
R11644 VSS.n98 VSS.n113 0.267794
R11645 VSS.n98 VSS.n114 0.267794
R11646 VSS.n98 VSS.n115 0.267794
R11647 VSS.n98 VSS.n116 0.267794
R11648 VSS.n98 VSS.n117 0.267794
R11649 VSS.n98 VSS.n118 0.267794
R11650 VSS.n98 VSS.n119 0.267794
R11651 VSS.n98 VSS.n120 0.267794
R11652 VSS.n98 VSS.n121 0.267794
R11653 VSS.n98 VSS.n122 0.267794
R11654 VSS.n98 VSS.n123 0.267794
R11655 VSS.n98 VSS.n124 0.267794
R11656 VSS.n98 VSS.n125 0.267794
R11657 VSS.n98 VSS.n126 0.267794
R11658 VSS.n2841 VSS.n2441 0.267677
R11659 VSS.n2841 VSS.n2446 0.267677
R11660 VSS.n2841 VSS.n2450 0.267677
R11661 VSS.n2841 VSS.n2454 0.267677
R11662 VSS.n2841 VSS.n2462 0.267677
R11663 VSS.n2841 VSS.n2463 0.267677
R11664 VSS.n2841 VSS.n2466 0.267677
R11665 VSS.n2841 VSS.n2470 0.267677
R11666 VSS.n2841 VSS.n2478 0.267677
R11667 VSS.n2841 VSS.n2479 0.267677
R11668 VSS.n2841 VSS.n2482 0.267677
R11669 VSS.n2841 VSS.n2486 0.267677
R11670 VSS.n2841 VSS.n2494 0.267677
R11671 VSS.n2841 VSS.n2495 0.267677
R11672 VSS.n2841 VSS.n2498 0.267677
R11673 VSS.n2841 VSS.n2502 0.267677
R11674 VSS.n2841 VSS.n2510 0.267677
R11675 VSS.n2841 VSS.n2511 0.267677
R11676 VSS.n2841 VSS.n2514 0.267677
R11677 VSS.n2841 VSS.n2518 0.267677
R11678 VSS.n2841 VSS.n2526 0.267677
R11679 VSS.n2841 VSS.n2527 0.267677
R11680 VSS.n2841 VSS.n2530 0.267677
R11681 VSS.n2841 VSS.n2534 0.267677
R11682 VSS.n2841 VSS.n2542 0.267677
R11683 VSS.n2841 VSS.n2543 0.267677
R11684 VSS.n2841 VSS.n2546 0.267677
R11685 VSS.n2841 VSS.n2550 0.267677
R11686 VSS.n2841 VSS.n2558 0.267677
R11687 VSS.n2841 VSS.n2559 0.267677
R11688 VSS.n2841 VSS.n2562 0.267677
R11689 VSS.n2841 VSS.n2566 0.267677
R11690 VSS.n2841 VSS.n2574 0.267677
R11691 VSS.n2841 VSS.n2575 0.267677
R11692 VSS.n2841 VSS.n2578 0.267677
R11693 VSS.n2841 VSS.n2582 0.267677
R11694 VSS.n2841 VSS.n2590 0.267677
R11695 VSS.n2841 VSS.n2591 0.267677
R11696 VSS.n2841 VSS.n2594 0.267677
R11697 VSS.n2841 VSS.n2598 0.267677
R11698 VSS.n2841 VSS.n2606 0.267677
R11699 VSS.n2841 VSS.n2607 0.267677
R11700 VSS.n2841 VSS.n2610 0.267677
R11701 VSS.n2841 VSS.n2614 0.267677
R11702 VSS.n2841 VSS.n2622 0.267677
R11703 VSS.n2841 VSS.n2623 0.267677
R11704 VSS.n2841 VSS.n2626 0.267677
R11705 VSS.n2841 VSS.n2630 0.267677
R11706 VSS.n2841 VSS.n2638 0.267677
R11707 VSS.n2841 VSS.n2639 0.267677
R11708 VSS.n2841 VSS.n2642 0.267677
R11709 VSS.n2841 VSS.n2646 0.267677
R11710 VSS.n2841 VSS.n2654 0.267677
R11711 VSS.n2841 VSS.n2655 0.267677
R11712 VSS.n2841 VSS.n2658 0.267677
R11713 VSS.n2841 VSS.n2662 0.267677
R11714 VSS.n2841 VSS.n2670 0.267677
R11715 VSS.n2841 VSS.n2671 0.267677
R11716 VSS.n2841 VSS.n2674 0.267677
R11717 VSS.n2841 VSS.n2678 0.267677
R11718 VSS.n2841 VSS.n2686 0.267677
R11719 VSS.n2841 VSS.n2687 0.267677
R11720 VSS.n2841 VSS.n2690 0.267677
R11721 VSS.n2841 VSS.n2694 0.267677
R11722 VSS.n2841 VSS.n2703 0.267677
R11723 VSS.n382 VSS.n451 0.267428
R11724 VSS.n293 VSS.n333 0.267428
R11725 VSS.n3079 VSS.n1438 0.267428
R11726 VSS.n3079 VSS.n1435 0.267428
R11727 VSS.n3079 VSS.n1431 0.267428
R11728 VSS.n3079 VSS.n1430 0.267428
R11729 VSS.n3079 VSS.n1422 0.267428
R11730 VSS.n3079 VSS.n1419 0.267428
R11731 VSS.n3079 VSS.n1415 0.267428
R11732 VSS.n3079 VSS.n1414 0.267428
R11733 VSS.n3079 VSS.n1406 0.267428
R11734 VSS.n3079 VSS.n1404 0.267428
R11735 VSS.n3079 VSS.n1400 0.267428
R11736 VSS.n3079 VSS.n1399 0.267428
R11737 VSS.n3079 VSS.n1391 0.267428
R11738 VSS.n3079 VSS.n1388 0.267428
R11739 VSS.n3079 VSS.n1384 0.267428
R11740 VSS.n3079 VSS.n1383 0.267428
R11741 VSS.n3079 VSS.n1375 0.267428
R11742 VSS.n3079 VSS.n1372 0.267428
R11743 VSS.n3079 VSS.n1368 0.267428
R11744 VSS.n3079 VSS.n1367 0.267428
R11745 VSS.n3079 VSS.n1359 0.267428
R11746 VSS.n3079 VSS.n1357 0.267428
R11747 VSS.n3079 VSS.n1353 0.267428
R11748 VSS.n3079 VSS.n1352 0.267428
R11749 VSS.n3079 VSS.n1344 0.267428
R11750 VSS.n3079 VSS.n1341 0.267428
R11751 VSS.n3079 VSS.n1337 0.267428
R11752 VSS.n3079 VSS.n1336 0.267428
R11753 VSS.n3079 VSS.n1328 0.267428
R11754 VSS.n3079 VSS.n1325 0.267428
R11755 VSS.n3079 VSS.n1321 0.267428
R11756 VSS.n3079 VSS.n1320 0.267428
R11757 VSS.n3079 VSS.n1312 0.267428
R11758 VSS.n3079 VSS.n1310 0.267428
R11759 VSS.n3079 VSS.n1306 0.267428
R11760 VSS.n3079 VSS.n1305 0.267428
R11761 VSS.n3079 VSS.n1297 0.267428
R11762 VSS.n3079 VSS.n1294 0.267428
R11763 VSS.n3079 VSS.n1290 0.267428
R11764 VSS.n3079 VSS.n1289 0.267428
R11765 VSS.n3079 VSS.n1281 0.267428
R11766 VSS.n3079 VSS.n1278 0.267428
R11767 VSS.n3079 VSS.n1274 0.267428
R11768 VSS.n3079 VSS.n1273 0.267428
R11769 VSS.n3079 VSS.n1265 0.267428
R11770 VSS.n3079 VSS.n1263 0.267428
R11771 VSS.n3079 VSS.n1259 0.267428
R11772 VSS.n3079 VSS.n1258 0.267428
R11773 VSS.n3079 VSS.n1250 0.267428
R11774 VSS.n3079 VSS.n1247 0.267428
R11775 VSS.n3079 VSS.n1243 0.267428
R11776 VSS.n3079 VSS.n1242 0.267428
R11777 VSS.n3079 VSS.n1234 0.267428
R11778 VSS.n3079 VSS.n1231 0.267428
R11779 VSS.n3079 VSS.n1227 0.267428
R11780 VSS.n3079 VSS.n1226 0.267428
R11781 VSS.n3079 VSS.n1218 0.267428
R11782 VSS.n3079 VSS.n1215 0.267428
R11783 VSS.n3079 VSS.n1211 0.267428
R11784 VSS.n3079 VSS.n1210 0.267428
R11785 VSS.n3079 VSS.n1202 0.267428
R11786 VSS.n3079 VSS.n1199 0.267428
R11787 VSS.n3079 VSS.n1195 0.267428
R11788 VSS.n3079 VSS.n1186 0.267428
R11789 VSS.n98 VSS.n142 0.267428
R11790 VSS.n1593 VSS.n1581 0.266107
R11791 VSS.n3052 VSS.n3051 0.265497
R11792 VSS.t161 VSS.n2449 0.264637
R11793 VSS.t538 VSS.n920 0.264468
R11794 VSS.t728 VSS.n2172 0.264468
R11795 VSS.t746 VSS.n633 0.264468
R11796 VSS.t1152 VSS.n1194 0.264294
R11797 VSS.n3051 VSS.n3050 0.264227
R11798 VSS.n496 VSS.t1490 0.263148
R11799 VSS.n1911 VSS.n1683 0.262612
R11800 VSS.t1800 VSS.n204 0.0269985
R11801 VSS.t605 VSS.n2417 0.261948
R11802 VSS.n503 VSS.t1065 0.255324
R11803 VSS.n517 VSS.t1075 0.255324
R11804 VSS.n533 VSS.t1085 0.255324
R11805 VSS.n557 VSS.t1095 0.255324
R11806 VSS.n573 VSS.t1105 0.255324
R11807 VSS.n588 VSS.t1115 0.255324
R11808 VSS.t1251 VSS.t2343 0.254653
R11809 VSS.t2330 VSS.t1142 0.254653
R11810 VSS.t1985 VSS.t2403 0.254653
R11811 VSS.t350 VSS.t2390 0.254653
R11812 VSS.t2377 VSS.t1455 0.254637
R11813 VSS.n3041 VSS.n472 0.25394
R11814 VSS.n3045 VSS.n3044 0.25394
R11815 VSS.n2854 VSS.n2852 0.25394
R11816 VSS.n3092 VSS.n3087 0.253932
R11817 VSS.n2438 VSS.t2332 0.253679
R11818 VSS.n382 VSS.n814 0.253554
R11819 VSS.n3079 VSS.n1536 0.253548
R11820 VSS.t205 VSS.n1121 0.246315
R11821 VSS.n2293 VSS.t1951 0.24355
R11822 VSS.t1765 VSS.n1181 0.24355
R11823 VSS.n1041 VSS.t1515 0.24355
R11824 VSS.t1609 VSS.n719 0.24355
R11825 VSS.n2779 VSS.t408 0.24305
R11826 VSS.n1110 VSS.n877 0.24011
R11827 VSS.n2362 VSS.n2131 0.24011
R11828 VSS.n3070 VSS.n1530 0.239942
R11829 VSS.n2837 VSS.n2836 0.239942
R11830 VSS.n822 VSS.n598 0.239757
R11831 VSS.t25 VSS.n14 0.333813
R11832 VSS.n3019 VSS.n3021 0.239006
R11833 VSS.n3025 VSS.t23 0.239006
R11834 VSS.n3000 VSS.n3009 0.239006
R11835 VSS.n3010 VSS.t16 0.239006
R11836 VSS.n3012 VSS.n3011 0.239006
R11837 VSS.n2968 VSS.n2966 0.239006
R11838 VSS.t19 VSS.n3022 0.239006
R11839 VSS.n12 VSS.n3019 0.332717
R11840 VSS.t2349 VSS.n1564 0.239006
R11841 VSS.n3001 VSS.t15 0.239006
R11842 VSS.n3022 VSS.n3024 0.238668
R11843 VSS.n3025 VSS.n3018 0.238668
R11844 VSS.n16 VSS.n3001 0.333474
R11845 VSS.n3009 VSS.t15 0.238668
R11846 VSS.n3011 VSS.n3010 0.238668
R11847 VSS.n3013 VSS.n19 0.333474
R11848 VSS.n22 VSS.n2973 0.197153
R11849 VSS.n3021 VSS.t19 0.238668
R11850 VSS.n3024 VSS.n10 0.332933
R11851 VSS.n3018 VSS.t21 0.238668
R11852 VSS.n3017 VSS.t25 0.238668
R11853 VSS.t16 VSS.n3000 0.238668
R11854 VSS.n3082 VSS.t933 0.2386
R11855 VSS.n2842 VSS.t815 0.2386
R11856 VSS.n3119 VSS.t998 0.2386
R11857 VSS.n1598 VSS.n1597 0.238218
R11858 VSS.n293 VSS.t56 0.234477
R11859 VSS.n98 VSS.t259 0.234477
R11860 VSS.n2865 VSS.n2864 0.233757
R11861 VSS.n2879 VSS.n2878 0.233757
R11862 VSS.n2864 VSS.t1556 0.233419
R11863 VSS.n2878 VSS.n2877 0.233419
R11864 VSS.n1587 VSS.n1585 0.225674
R11865 VSS.t1079 VSS.t1081 0.224424
R11866 VSS.t1099 VSS.t1101 0.224424
R11867 VSS.t999 VSS.t1001 0.224424
R11868 VSS.t1040 VSS.t1042 0.224424
R11869 VSS.t932 VSS.t935 0.224424
R11870 VSS.t943 VSS.t946 0.224424
R11871 VSS.t954 VSS.t957 0.224424
R11872 VSS.t965 VSS.t968 0.224424
R11873 VSS.t976 VSS.t979 0.224424
R11874 VSS.t987 VSS.t990 0.224424
R11875 VSS.t814 VSS.t817 0.224424
R11876 VSS.t825 VSS.t827 0.224424
R11877 VSS.t835 VSS.t837 0.224424
R11878 VSS.t845 VSS.t847 0.224424
R11879 VSS.t855 VSS.t857 0.224424
R11880 VSS.t865 VSS.t867 0.224424
R11881 VSS.t878 VSS.t876 0.224424
R11882 VSS.t887 VSS.t885 0.224424
R11883 VSS.t897 VSS.t895 0.224424
R11884 VSS.t907 VSS.t905 0.224424
R11885 VSS.t916 VSS.t914 0.224424
R11886 VSS.t925 VSS.t923 0.224424
R11887 VSS.t1051 VSS.t1049 0.224424
R11888 VSS.t1029 VSS.t1031 0.224424
R11889 VSS.t1019 VSS.t1021 0.224424
R11890 VSS.t1011 VSS.t1009 0.224424
R11891 VSS.t1109 VSS.t1111 0.224424
R11892 VSS.t1089 VSS.t1091 0.224424
R11893 VSS.t1069 VSS.t1071 0.224424
R11894 VSS.t1059 VSS.t1061 0.224424
R11895 VSS.t767 VSS.t1079 0.220674
R11896 VSS.t776 VSS.t1099 0.220674
R11897 VSS.n224 VSS.t999 0.0724751
R11898 VSS.n272 VSS.t1040 0.0724751
R11899 VSS.n188 VSS.t932 0.0724751
R11900 VSS.n194 VSS.t943 0.0724751
R11901 VSS.n200 VSS.t954 0.0724751
R11902 VSS.n206 VSS.t965 0.0724751
R11903 VSS.n212 VSS.t976 0.0724751
R11904 VSS.n218 VSS.t987 0.0724751
R11905 VSS.t815 VSS.t814 0.220674
R11906 VSS.t686 VSS.t825 0.220674
R11907 VSS.t426 VSS.t835 0.220674
R11908 VSS.t354 VSS.t845 0.220674
R11909 VSS.t689 VSS.t855 0.220674
R11910 VSS.t474 VSS.t865 0.220674
R11911 VSS.t876 VSS.t875 0.220674
R11912 VSS.t586 VSS.t885 0.220674
R11913 VSS.t894 VSS.t895 0.220674
R11914 VSS.t904 VSS.t905 0.220674
R11915 VSS.t589 VSS.t914 0.220674
R11916 VSS.t431 VSS.t923 0.220674
R11917 VSS.n283 VSS.t1049 0.0724751
R11918 VSS.t1029 VSS.n263 0.0724751
R11919 VSS.t1019 VSS.n246 0.0724751
R11920 VSS.n235 VSS.t1009 0.0724751
R11921 VSS.t1109 VSS.t764 0.220674
R11922 VSS.t1089 VSS.t779 0.220674
R11923 VSS.t1069 VSS.t773 0.220674
R11924 VSS.t1059 VSS.t770 0.220674
R11925 VSS.n1604 VSS.n1585 0.219424
R11926 VSS.n3063 VSS.n1558 0.21912
R11927 VSS.t129 VSS.n1121 0.218403
R11928 VSS.t284 VSS.n2890 0.211735
R11929 VSS.n2966 VSS.n2964 0.208461
R11930 VSS.n3036 VSS.n1573 0.20686
R11931 VSS.n1529 VSS.n1528 0.202646
R11932 VSS.n97 VSS.n2138 0.297117
R11933 VSS.n292 VSS.n886 0.297117
R11934 VSS.n381 VSS.n599 0.20231
R11935 VSS.n97 VSS.n2290 0.23732
R11936 VSS.n1609 VSS.n1590 0.191235
R11937 VSS.t18 VSS.n1569 0.191235
R11938 VSS.t24 VSS.n14 0.286042
R11939 VSS.n3029 VSS.n3017 0.191235
R11940 VSS.n3030 VSS.n3029 0.191235
R11941 VSS.t2349 VSS.n3007 0.191235
R11942 VSS.n3007 VSS.n3006 0.191235
R11943 VSS.n3006 VSS.n3005 0.191235
R11944 VSS.n3005 VSS.n3004 0.191235
R11945 VSS.n3004 VSS.n3003 0.191235
R11946 VSS.n3003 VSS.n16 0.286042
R11947 VSS.n19 VSS.n3012 0.286042
R11948 VSS.n1528 VSS.n1527 0.191235
R11949 VSS.n292 VSS.n1038 0.23732
R11950 VSS.n721 VSS.n381 0.191235
R11951 VSS.t23 VSS.t24 0.191235
R11952 VSS.t2325 VSS.t2327 0.1875
R11953 VSS.t2336 VSS.t2339 0.1875
R11954 VSS.t2369 VSS.t2366 0.1875
R11955 VSS.t2363 VSS.t2359 0.1875
R11956 VSS.t2374 VSS.t2372 0.1875
R11957 VSS.t2383 VSS.t2386 0.1875
R11958 VSS.t2399 VSS.t2396 0.1875
R11959 VSS.n2866 VSS.n2865 0.187025
R11960 VSS.n2867 VSS.n2866 0.187025
R11961 VSS.n2868 VSS.n2867 0.187025
R11962 VSS.n2869 VSS.n2868 0.187025
R11963 VSS.n2870 VSS.n2869 0.187025
R11964 VSS.n2871 VSS.n2870 0.187025
R11965 VSS.n2872 VSS.n2871 0.187025
R11966 VSS.n2873 VSS.n2872 0.187025
R11967 VSS.n2874 VSS.n2873 0.187025
R11968 VSS.n2875 VSS.n2874 0.187025
R11969 VSS.n2876 VSS.n2875 0.187025
R11970 VSS.n2877 VSS.n2876 0.187025
R11971 VSS.n2880 VSS.n2879 0.187025
R11972 VSS.n2960 VSS.n2911 0.181924
R11973 VSS.n2959 VSS.n2957 0.181543
R11974 VSS.n2972 VSS.n2971 0.180041
R11975 VSS.n2851 VSS.n2377 0.173835
R11976 VSS.n3128 VSS.n3123 0.173835
R11977 VSS.n3054 VSS.t2347 0.167615
R11978 VSS.n2836 VSS.n2818 0.16705
R11979 VSS.n2958 VSS.n2957 0.164808
R11980 VSS.n2961 VSS.n2911 0.164424
R11981 VSS.n2841 VSS.n2832 0.16137
R11982 VSS.n2841 VSS.n2824 0.16137
R11983 VSS.n2841 VSS.n2819 0.16137
R11984 VSS.n3079 VSS.n1537 0.160396
R11985 VSS.n3079 VSS.n3074 0.160396
R11986 VSS.n3079 VSS.n3078 0.160396
R11987 VSS.n47 VSS.n46 0.159968
R11988 VSS.n1565 VSS.n1564 0.15955
R11989 VSS.t1540 VSS.n2881 0.158553
R11990 VSS.n1815 VSS.n1589 0.156138
R11991 VSS.n3049 VSS.n1570 0.150687
R11992 VSS.t1546 VSS.n74 0.14953
R11993 VSS.t1530 VSS.n74 0.149502
R11994 VSS.n2962 VSS.n2968 0.14455
R11995 VSS.n3157 VSS.n534 0.144066
R11996 VSS.n260 VSS.t639 1.30422
R11997 VSS.n1527 VSS.n1182 0.142513
R11998 VSS.n722 VSS.n721 0.142513
R11999 VSS.n2962 VSS.n22 0.236315
R12000 VSS.n2974 VSS.n1615 0.142012
R12001 VSS.t2406 VSS.n599 0.139294
R12002 VSS.t2393 VSS.n886 0.139294
R12003 VSS.t2346 VSS.n2138 0.139294
R12004 VSS.n1529 VSS.n1526 0.138956
R12005 VSS.t1534 VSS.n74 0.138776
R12006 VSS.t1550 VSS.n74 0.13875
R12007 VSS.t1542 VSS.n74 0.138705
R12008 VSS.t1538 VSS.n74 0.1387
R12009 VSS.n2974 VSS.n2958 0.138262
R12010 VSS.n3182 VSS.n472 0.138073
R12011 VSS.n3044 VSS.n3042 0.138073
R12012 VSS.n3048 VSS.n3046 0.138073
R12013 VSS.n2856 VSS.n2854 0.138073
R12014 VSS.t408 VSS.t2328 0.135868
R12015 VSS.t1951 VSS.t2340 0.135868
R12016 VSS.t1765 VSS.t2375 0.135868
R12017 VSS.t1515 VSS.t2387 0.135868
R12018 VSS.t2400 VSS.t1609 0.135868
R12019 VSS.t251 VSS.n2818 0.124888
R12020 VSS.n3063 VSS.n1552 0.124859
R12021 VSS.n3063 VSS.n1550 0.124859
R12022 VSS.n3063 VSS.n1546 0.124859
R12023 VSS.t2330 VSS.n2702 0.124618
R12024 VSS.t2343 VSS.n2140 0.124618
R12025 VSS.n1447 VSS.t2377 0.124618
R12026 VSS.t2390 VSS.n888 0.124618
R12027 VSS.t2403 VSS.n601 0.124618
R12028 VSS.t2400 VSS.n597 0.122118
R12029 VSS.t2331 VSS.n2702 0.122118
R12030 VSS.t2328 VSS.n2440 0.122118
R12031 VSS.t2340 VSS.n2126 0.122118
R12032 VSS.n2140 VSS.t2342 0.122118
R12033 VSS.t2378 VSS.n1447 0.122118
R12034 VSS.t2375 VSS.n1142 0.122118
R12035 VSS.t2387 VSS.n873 0.122118
R12036 VSS.n888 VSS.t2389 0.122118
R12037 VSS.n601 VSS.t2402 0.122118
R12038 VSS.t1526 VSS.n74 0.119425
R12039 VSS.t2352 VSS.n2962 0.1171
R12040 VSS.n1568 VSS.n1569 0.112118
R12041 VSS.n2970 VSS.n2907 0.111556
R12042 VSS.t761 VSS.n589 0.109701
R12043 VSS.n722 VSS.t2404 0.109642
R12044 VSS.n2290 VSS.t2344 0.109642
R12045 VSS.t2379 VSS.n1182 0.109642
R12046 VSS.n1038 VSS.t2391 0.109642
R12047 VSS.n3039 VSS.n45 0.108147
R12048 VSS.n2960 VSS.n2906 0.104618
R12049 VSS.n2959 VSS.n2953 0.104618
R12050 VSS.t1554 VSS.n74 0.103331
R12051 VSS.t2364 VSS.n1582 0.0971176
R12052 VSS.n1815 VSS.n1590 0.0971176
R12053 VSS.n2971 VSS.n2970 0.0958676
R12054 VSS.n1589 VSS.n1588 0.0958002
R12055 VSS.n1588 VSS.n1586 0.0955
R12056 VSS.n3058 VSS.n3057 0.0955
R12057 VSS.n1599 VSS.n1598 0.093
R12058 VSS.n2840 VSS.t2323 0.08925
R12059 VSS.t2334 VSS.n2175 0.08925
R12060 VSS.t2370 VSS.n1185 0.08925
R12061 VSS.t2381 VSS.n923 0.08925
R12062 VSS.t2394 VSS.n637 0.08925
R12063 VSS.t95 VSS.n2817 0.08925
R12064 VSS.t1820 VSS.n2130 0.08925
R12065 VSS.t1433 VSS.n1143 0.08925
R12066 VSS.t397 VSS.n876 0.08925
R12067 VSS.n809 VSS.t1161 0.08925
R12068 VSS.n1634 VSS.t1505 0.0888345
R12069 VSS.n2815 VSS.t2325 0.0851154
R12070 VSS.t2327 VSS.n2814 0.0851154
R12071 VSS.n2360 VSS.t2336 0.0851154
R12072 VSS.t2339 VSS.n2179 0.0851154
R12073 VSS.t2366 VSS.n1606 0.0851154
R12074 VSS.n1607 VSS.t2369 0.0851154
R12075 VSS.t2359 VSS.n1595 0.0851154
R12076 VSS.n1596 VSS.t2363 0.0851154
R12077 VSS.t2372 VSS.n1192 0.0851154
R12078 VSS.t2374 VSS.n1145 0.0851154
R12079 VSS.n1108 VSS.t2383 0.0851154
R12080 VSS.t2386 VSS.n927 0.0851154
R12081 VSS.t2396 VSS.n806 0.0851154
R12082 VSS.n807 VSS.t2399 0.0851154
R12083 VSS.n2863 VSS.n1572 0.0846176
R12084 VSS.n2942 VSS.n2901 0.08425
R12085 VSS.n2944 VSS.n2943 0.08425
R12086 VSS.n1595 VSS.n4 0.08175
R12087 VSS.n1606 VSS.n1601 0.08175
R12088 VSS.n1594 VSS.n1579 0.08175
R12089 VSS.n1605 VSS.n1583 0.08175
R12090 VSS.n3132 VSS.n3131 0.0805
R12091 VSS.t2332 VSS.n2439 0.0805
R12092 VSS.n2858 VSS.n2857 0.0805
R12093 VSS.n2970 VSS.n2908 0.0805
R12094 VSS.n3081 VSS.n3080 0.0805
R12095 VSS.n3096 VSS.n3095 0.0805
R12096 VSS.n1568 VSS.n3053 0.0796176
R12097 VSS.t232 VSS.n1534 0.078
R12098 VSS.t256 VSS.n471 0.078
R12099 VSS.t2346 VSS.n2139 0.0771176
R12100 VSS.n1526 VSS.n1449 0.0771176
R12101 VSS.t2393 VSS.n887 0.0771176
R12102 VSS.t2406 VSS.n600 0.0771176
R12103 VSS.n3053 VSS.n3052 0.0758676
R12104 VSS.n806 VSS.n638 0.0746176
R12105 VSS.n2812 VSS.n2442 0.0746176
R12106 VSS.n2816 VSS.n2815 0.0746176
R12107 VSS.n2361 VSS.n2360 0.0746176
R12108 VSS.n2358 VSS.n2174 0.0746176
R12109 VSS.n1191 VSS.n1187 0.0746176
R12110 VSS.n1192 VSS.n1183 0.0746176
R12111 VSS.n1109 VSS.n1108 0.0746176
R12112 VSS.n1106 VSS.n922 0.0746176
R12113 VSS.n805 VSS.n635 0.0746176
R12114 VSS.n3038 VSS.n1571 0.07425
R12115 VSS.n2961 VSS.n2908 0.07425
R12116 VSS.t2360 VSS.n1576 0.0740901
R12117 VSS.t2357 VSS.n1575 0.0740901
R12118 VSS.t2253 VSS.n1571 0.07175
R12119 VSS.t494 VSS.n814 0.0715402
R12120 VSS.t1175 VSS.n1536 0.0715165
R12121 VSS.t1541 VSS.n2863 0.0708676
R12122 VSS.t2342 VSS.n2139 0.0696176
R12123 VSS.n1449 VSS.t2378 0.0696176
R12124 VSS.t2389 VSS.n887 0.0696176
R12125 VSS.t2402 VSS.n600 0.0696176
R12126 VSS.n806 VSS.t1163 0.06925
R12127 VSS.t1063 VSS.n501 0.06925
R12128 VSS.t1073 VSS.n515 0.06925
R12129 VSS.t1083 VSS.n527 0.06925
R12130 VSS.t1093 VSS.n555 0.06925
R12131 VSS.t1103 VSS.n567 0.06925
R12132 VSS.t1113 VSS.n586 0.06925
R12133 VSS.n2812 VSS.n2445 0.06925
R12134 VSS.n2815 VSS.t1678 0.06925
R12135 VSS.n2360 VSS.t1822 0.06925
R12136 VSS.n2358 VSS.n2173 0.06925
R12137 VSS.n2980 VSS.n2901 0.06925
R12138 VSS.n2981 VSS.n2944 0.06925
R12139 VSS.n1191 VSS.n1190 0.06925
R12140 VSS.n1192 VSS.t1435 0.06925
R12141 VSS.n1108 VSS.t399 0.06925
R12142 VSS.n1106 VSS.n921 0.06925
R12143 VSS.n805 VSS.n634 0.06925
R12144 VSS.n3040 VSS.n47 0.0687326
R12145 VSS.n1596 VSS.n1592 0.0671176
R12146 VSS.n1607 VSS.n1603 0.0671176
R12147 VSS.n1593 VSS.n1580 0.0671176
R12148 VSS.n1604 VSS.n1584 0.0671176
R12149 VSS.n1595 VSS.n1592 0.0621177
R12150 VSS.n1606 VSS.n1603 0.0621177
R12151 VSS.n1594 VSS.n1580 0.0621177
R12152 VSS.n1605 VSS.n1584 0.0621177
R12153 VSS.n2813 VSS.n2445 0.05925
R12154 VSS.n2359 VSS.n2173 0.05925
R12155 VSS.n1193 VSS.n1190 0.05925
R12156 VSS.n1107 VSS.n921 0.05925
R12157 VSS.n804 VSS.n634 0.05925
R12158 VSS.n2814 VSS.t1678 0.05925
R12159 VSS.n2179 VSS.t1822 0.05925
R12160 VSS.n1145 VSS.t1435 0.05925
R12161 VSS.n927 VSS.t399 0.05925
R12162 VSS.n807 VSS.t1163 0.05925
R12163 VSS.t2225 VSS.n1582 0.0571176
R12164 VSS.t1161 VSS.n638 0.0546176
R12165 VSS.t2323 VSS.n2442 0.0546176
R12166 VSS.t95 VSS.n2816 0.0546176
R12167 VSS.n2361 VSS.t1820 0.0546176
R12168 VSS.t2334 VSS.n2174 0.0546176
R12169 VSS.n1187 VSS.t2370 0.0546176
R12170 VSS.t1433 VSS.n1183 0.0546176
R12171 VSS.n1109 VSS.t397 0.0546176
R12172 VSS.t2381 VSS.n922 0.0546176
R12173 VSS.t2394 VSS.n635 0.0546176
R12174 VSS.n501 VSS.t1061 0.05175
R12175 VSS.n515 VSS.t1071 0.05175
R12176 VSS.t1081 VSS.n527 0.05175
R12177 VSS.n555 VSS.t1091 0.05175
R12178 VSS.t1101 VSS.n567 0.05175
R12179 VSS.n586 VSS.t1111 0.05175
R12180 VSS.n2978 VSS.n2906 0.0496177
R12181 VSS.n2979 VSS.n2953 0.0496177
R12182 VSS.n1600 VSS.n1599 0.04925
R12183 VSS.n1601 VSS.n1600 0.04675
R12184 VSS.t2364 VSS.n1583 0.04675
R12185 VSS.n8 VSS.n6 0.0161289
R12186 VSS.n2973 VSS.n2972 0.0371729
R12187 VSS.n2907 VSS.t2253 0.0353056
R12188 VSS.n2964 VSS.n1615 0.0345427
R12189 VSS.n3058 VSS.n1565 0.03175
R12190 VSS.n3035 VSS.n4 0.0305
R12191 VSS.n1579 VSS.n1578 0.0305
R12192 VSS.t2404 VSS.n452 0.02925
R12193 VSS.t2344 VSS.n143 0.02925
R12194 VSS.t2379 VSS.n1141 0.02925
R12195 VSS.t2391 VSS.n334 0.02925
R12196 VSS.n3057 VSS.n3056 0.028
R12197 VSS.n3063 VSS.n1539 0.0254237
R12198 VSS.n1576 VSS.n1574 0.0253401
R12199 VSS.n2969 VSS.n1575 0.0253401
R12200 VSS.n3133 VSS.n596 0.023135
R12201 VSS.n3133 VSS.n592 0.023135
R12202 VSS.n3137 VSS.n3136 0.023135
R12203 VSS.n3142 VSS.n576 0.023135
R12204 VSS.n3142 VSS.n577 0.023135
R12205 VSS.n3145 VSS.n571 0.023135
R12206 VSS.n3148 VSS.n559 0.023135
R12207 VSS.n3148 VSS.n560 0.023135
R12208 VSS.n3152 VSS.n3151 0.023135
R12209 VSS.n3157 VSS.n537 0.023135
R12210 VSS.n3157 VSS.n539 0.023135
R12211 VSS.n3157 VSS.n540 0.023135
R12212 VSS.n3157 VSS.n541 0.023135
R12213 VSS.n3160 VSS.n531 0.023135
R12214 VSS.n3163 VSS.n519 0.023135
R12215 VSS.n3163 VSS.n520 0.023135
R12216 VSS.n3167 VSS.n3166 0.023135
R12217 VSS.n3172 VSS.n506 0.023135
R12218 VSS.n3172 VSS.n507 0.023135
R12219 VSS.n3176 VSS.n3175 0.023135
R12220 VSS.n3181 VSS.n476 0.023135
R12221 VSS.n3181 VSS.n480 0.023135
R12222 VSS.n3181 VSS.n490 0.023135
R12223 VSS.n3131 VSS.n597 0.02175
R12224 VSS.n2439 VSS.n2440 0.02175
R12225 VSS.n2857 VSS.n2126 0.02175
R12226 VSS.n3080 VSS.n1142 0.02175
R12227 VSS.n3095 VSS.n873 0.02175
R12228 VSS.n473 VSS.t2014 0.0191553
R12229 VSS.t1876 VSS.n2375 0.0191477
R12230 VSS.t284 VSS.n2887 0.0173993
R12231 VSS.n3035 VSS.t2360 0.01675
R12232 VSS.n1578 VSS.t2357 0.01675
R12233 VSS.n2841 VSS.n2833 0.0166972
R12234 VSS.n2841 VSS.n2828 0.0166972
R12235 VSS.n1522 VSS.n221 0.0165968
R12236 VSS.n1520 VSS.n221 0.0165968
R12237 VSS.n1511 VSS.n215 0.0165968
R12238 VSS.n1509 VSS.n215 0.0165968
R12239 VSS.n1500 VSS.n209 0.0165968
R12240 VSS.n1498 VSS.n209 0.0165968
R12241 VSS.n1489 VSS.n203 0.0165968
R12242 VSS.n1484 VSS.n203 0.0165968
R12243 VSS.n1481 VSS.n203 0.0165968
R12244 VSS.n1479 VSS.n203 0.0165968
R12245 VSS.n1470 VSS.n197 0.0165968
R12246 VSS.n1468 VSS.n197 0.0165968
R12247 VSS.n1459 VSS.n191 0.0165968
R12248 VSS.n1457 VSS.n191 0.0165968
R12249 VSS.n3092 VSS.n3083 0.0165968
R12250 VSS.n2776 VSS.n2437 0.0165968
R12251 VSS.n2774 VSS.n2437 0.0165968
R12252 VSS.n2765 VSS.n2430 0.0165968
R12253 VSS.n2763 VSS.n2430 0.0165968
R12254 VSS.n2754 VSS.n2423 0.0165968
R12255 VSS.n2752 VSS.n2423 0.0165968
R12256 VSS.n2743 VSS.n2417 0.0165968
R12257 VSS.n2738 VSS.n2417 0.0165968
R12258 VSS.n2735 VSS.n2417 0.0165968
R12259 VSS.n2733 VSS.n2417 0.0165968
R12260 VSS.n2724 VSS.n2410 0.0165968
R12261 VSS.n2722 VSS.n2410 0.0165968
R12262 VSS.n2713 VSS.n2403 0.0165968
R12263 VSS.n2711 VSS.n2403 0.0165968
R12264 VSS.n2851 VSS.n2843 0.0165968
R12265 VSS.n1720 VSS.n1712 0.0165968
R12266 VSS.n1722 VSS.n1712 0.0165968
R12267 VSS.n290 VSS.n286 0.0165968
R12268 VSS.n290 VSS.n287 0.0165968
R12269 VSS.n870 VSS.n273 0.0165968
R12270 VSS.n868 VSS.n273 0.0165968
R12271 VSS.n270 VSS.n269 0.0165968
R12272 VSS.n270 VSS.n268 0.0165968
R12273 VSS.n259 VSS.n258 0.0165968
R12274 VSS.n259 VSS.n256 0.0165968
R12275 VSS.n259 VSS.n255 0.0165968
R12276 VSS.n259 VSS.n254 0.0165968
R12277 VSS.n242 VSS.n241 0.0165968
R12278 VSS.n242 VSS.n240 0.0165968
R12279 VSS.n858 VSS.n225 0.0165968
R12280 VSS.n856 VSS.n225 0.0165968
R12281 VSS.n3128 VSS.n3120 0.0165968
R12282 VSS.n3079 VSS.n1535 0.0165542
R12283 VSS.n3079 VSS.n3069 0.0165542
R12284 VSS.n3132 VSS.n452 0.0155
R12285 VSS.n2858 VSS.n143 0.0155
R12286 VSS.n3081 VSS.n1141 0.0155
R12287 VSS.n3096 VSS.n334 0.0155
R12288 VSS.t284 VSS.n2883 0.0150892
R12289 VSS.n1587 VSS.n1586 0.013
R12290 VSS.n2841 VSS.n2444 0.0096403
R12291 VSS.n2841 VSS.n2453 0.0096403
R12292 VSS.n2841 VSS.n2469 0.0096403
R12293 VSS.n2841 VSS.n2485 0.0096403
R12294 VSS.n2841 VSS.n2501 0.0096403
R12295 VSS.n2841 VSS.n2517 0.0096403
R12296 VSS.n2841 VSS.n2533 0.0096403
R12297 VSS.n2841 VSS.n2549 0.0096403
R12298 VSS.n2841 VSS.n2565 0.0096403
R12299 VSS.n2841 VSS.n2581 0.0096403
R12300 VSS.n2841 VSS.n2597 0.0096403
R12301 VSS.n2841 VSS.n2613 0.0096403
R12302 VSS.n2841 VSS.n2629 0.0096403
R12303 VSS.n2841 VSS.n2645 0.0096403
R12304 VSS.n2841 VSS.n2661 0.0096403
R12305 VSS.n2841 VSS.n2677 0.0096403
R12306 VSS.n2841 VSS.n2693 0.0096403
R12307 VSS.n2841 VSS.n2701 0.0096403
R12308 VSS.n382 VSS.n470 0.00962826
R12309 VSS.n382 VSS.n466 0.00962826
R12310 VSS.n382 VSS.n461 0.00962826
R12311 VSS.n98 VSS.n127 0.00962826
R12312 VSS.n98 VSS.n130 0.00962826
R12313 VSS.n98 VSS.n132 0.00962826
R12314 VSS.n98 VSS.n135 0.00962826
R12315 VSS.n3079 VSS.n1437 0.00938635
R12316 VSS.n3079 VSS.n1421 0.00938635
R12317 VSS.n3079 VSS.n1390 0.00938635
R12318 VSS.n3079 VSS.n1374 0.00938635
R12319 VSS.n3079 VSS.n1343 0.00938635
R12320 VSS.n3079 VSS.n1327 0.00938635
R12321 VSS.n3079 VSS.n1296 0.00938635
R12322 VSS.n3079 VSS.n1280 0.00938635
R12323 VSS.n3079 VSS.n1249 0.00938635
R12324 VSS.n3079 VSS.n1233 0.00938635
R12325 VSS.n3079 VSS.n1201 0.00938635
R12326 VSS.n3079 VSS.n1189 0.00938635
R12327 VSS.n382 VSS.n450 0.00937856
R12328 VSS.n382 VSS.n392 0.00937856
R12329 VSS.n382 VSS.n398 0.00937856
R12330 VSS.n382 VSS.n404 0.00937856
R12331 VSS.n293 VSS.n373 0.00937856
R12332 VSS.n293 VSS.n366 0.00937856
R12333 VSS.n293 VSS.n358 0.00937856
R12334 VSS.n293 VSS.n350 0.00937856
R12335 VSS.n293 VSS.n342 0.00937856
R12336 VSS.n3079 VSS.n1155 0.00937856
R12337 VSS.n3079 VSS.n1162 0.00937856
R12338 VSS.n3079 VSS.n1169 0.00937856
R12339 VSS.n3079 VSS.n1176 0.00937856
R12340 VSS.n98 VSS.n181 0.00937856
R12341 VSS.n98 VSS.n159 0.00937856
R12342 VSS.n98 VSS.n152 0.00937856
R12343 VSS.n98 VSS.n145 0.00937856
R12344 VSS.n98 VSS.n141 0.00937856
R12345 VSS.n382 VSS.n410 0.00937856
R12346 VSS.n382 VSS.n414 0.00937856
R12347 VSS.n382 VSS.n424 0.00937856
R12348 VSS.n382 VSS.n428 0.00937856
R12349 VSS.n382 VSS.n438 0.00937856
R12350 VSS.n382 VSS.n442 0.00937856
R12351 VSS.n382 VSS.n449 0.00937856
R12352 VSS.n382 VSS.n388 0.00937856
R12353 VSS.n382 VSS.n394 0.00937856
R12354 VSS.n382 VSS.n400 0.00937856
R12355 VSS.n382 VSS.n406 0.00937856
R12356 VSS.n293 VSS.n376 0.00937856
R12357 VSS.n293 VSS.n372 0.00937856
R12358 VSS.n293 VSS.n369 0.00937856
R12359 VSS.n293 VSS.n365 0.00937856
R12360 VSS.n293 VSS.n362 0.00937856
R12361 VSS.n293 VSS.n357 0.00937856
R12362 VSS.n293 VSS.n354 0.00937856
R12363 VSS.n293 VSS.n349 0.00937856
R12364 VSS.n293 VSS.n346 0.00937856
R12365 VSS.n293 VSS.n341 0.00937856
R12366 VSS.n293 VSS.n338 0.00937856
R12367 VSS.n293 VSS.n332 0.00937856
R12368 VSS.n293 VSS.n295 0.00937856
R12369 VSS.n3079 VSS.n1445 0.00937856
R12370 VSS.n3079 VSS.n1217 0.00937856
R12371 VSS.n98 VSS.n179 0.00937856
R12372 VSS.n98 VSS.n175 0.00937856
R12373 VSS.n98 VSS.n171 0.00937856
R12374 VSS.n98 VSS.n167 0.00937856
R12375 VSS.n98 VSS.n163 0.00937856
R12376 VSS.n98 VSS.n156 0.00937856
R12377 VSS.n98 VSS.n151 0.00937856
R12378 VSS.n98 VSS.n148 0.00937856
R12379 VSS.n98 VSS.n144 0.00937856
R12380 VSS.n54 VSS.n3060 0.00796144
R12381 VSS.n822 VSS.n809 0.00675
R12382 VSS.n2840 VSS.n2839 0.00675
R12383 VSS.n2836 VSS.n2817 0.00675
R12384 VSS.n2131 VSS.n2130 0.00675
R12385 VSS.n2853 VSS.n2175 0.00675
R12386 VSS.n3047 VSS.n1185 0.00675
R12387 VSS.n3070 VSS.n1143 0.00675
R12388 VSS.n877 VSS.n876 0.00675
R12389 VSS.n3043 VSS.n923 0.00675
R12390 VSS.n637 VSS.n636 0.00675
R12391 VSS.n84 VSS.n83 0.0064349
R12392 VSS.n77 VSS.n79 0.00466584
R12393 VSS.n38 VSS.n40 0.00466584
R12394 VSS.n41 VSS.n44 0.00409958
R12395 VSS.n24 VSS.n25 0.00399966
R12396 VSS.n70 VSS.n18 0.00374975
R12397 VSS.n35 VSS.n11 0.00299994
R12398 VSS.n8 VSS.n0 0.00296307
R12399 VSS.n2861 VSS.n74 0.00283329
R12400 VSS.n36 VSS.n11 0.00279996
R12401 VSS.n291 VSS.n293 0.00105218
R12402 VSS.n380 VSS.n383 0.00174993
R12403 VSS.n594 VSS.n587 0.00179957
R12404 VSS.n593 VSS.n587 0.00179957
R12405 VSS.n3139 VSS.n583 0.00179957
R12406 VSS.n580 VSS.n572 0.00179957
R12407 VSS.n579 VSS.n572 0.00179957
R12408 VSS.n569 VSS.n566 0.00179957
R12409 VSS.n562 VSS.n556 0.00179957
R12410 VSS.n561 VSS.n556 0.00179957
R12411 VSS.n3154 VSS.n552 0.00179957
R12412 VSS.n544 VSS.n532 0.00179957
R12413 VSS.n543 VSS.n532 0.00179957
R12414 VSS.n529 VSS.n526 0.00179957
R12415 VSS.n522 VSS.n516 0.00179957
R12416 VSS.n521 VSS.n516 0.00179957
R12417 VSS.n3169 VSS.n512 0.00179957
R12418 VSS.n509 VSS.n502 0.00179957
R12419 VSS.n508 VSS.n502 0.00179957
R12420 VSS.n3178 VSS.n498 0.00179957
R12421 VSS.n3181 VSS.n483 0.00179957
R12422 VSS.n3181 VSS.n485 0.00179957
R12423 VSS.n3181 VSS.n489 0.00179957
R12424 VSS.n2967 VSS.n20 0.00166667
R12425 VSS.n2965 VSS.n2892 0.00166667
R12426 VSS.n2965 VSS.n2891 0.00166667
R12427 VSS.n31 VSS.n30 0.00169993
R12428 VSS.n33 VSS.n32 0.00169993
R12429 VSS.n35 VSS.n34 0.00149995
R12430 VSS.n37 VSS.n36 0.00169993
R12431 VSS.n39 VSS.n38 0.00131814
R12432 VSS.n42 VSS.n41 0.00134996
R12433 VSS.n63 VSS.n61 0.00169993
R12434 VSS.n66 VSS.n65 0.00169993
R12435 VSS.n69 VSS.n68 0.00169993
R12436 VSS.n71 VSS.n70 0.00138885
R12437 VSS.n78 VSS.n77 0.00131814
R12438 VSS.n95 VSS.n94 0.00169993
R12439 VSS.n2861 VSS.n93 0.00166667
R12440 VSS.n3002 VSS.n28 0.00162501
R12441 VSS.n8 VSS.n2 0.00161188
R12442 VSS.n49 VSS.n45 0.0015
R12443 VSS.n51 VSS.n49 0.00224999
R12444 VSS.n382 VSS.n379 0.0015
R12445 VSS.n290 VSS.n280 0.0015
R12446 VSS.n282 VSS.n280 0.0015
R12447 VSS.n282 VSS.n273 0.0015
R12448 VSS.n277 VSS.n273 0.0015
R12449 VSS.n277 VSS.n265 0.0015
R12450 VSS.n270 VSS.n265 0.0015
R12451 VSS.n270 VSS.n261 0.0015
R12452 VSS.n249 VSS.n261 0.0015
R12453 VSS.n259 VSS.n249 0.0015
R12454 VSS.n259 VSS.n244 0.0015
R12455 VSS.n238 VSS.n244 0.0015
R12456 VSS.n242 VSS.n238 0.0015
R12457 VSS.n242 VSS.n232 0.0015
R12458 VSS.n234 VSS.n232 0.0015
R12459 VSS.n234 VSS.n225 0.0015
R12460 VSS.n229 VSS.n225 0.0015
R12461 VSS.n229 VSS.n223 0.0015
R12462 VSS.n3128 VSS.n223 0.0015
R12463 VSS.n221 VSS.n219 0.0015
R12464 VSS.n219 VSS.n217 0.0015
R12465 VSS.n217 VSS.n215 0.0015
R12466 VSS.n215 VSS.n213 0.0015
R12467 VSS.n213 VSS.n211 0.0015
R12468 VSS.n211 VSS.n209 0.0015
R12469 VSS.n209 VSS.n207 0.0015
R12470 VSS.n207 VSS.n205 0.0015
R12471 VSS.n205 VSS.n203 0.0015
R12472 VSS.n203 VSS.n201 0.0015
R12473 VSS.n201 VSS.n199 0.0015
R12474 VSS.n199 VSS.n197 0.0015
R12475 VSS.n197 VSS.n195 0.0015
R12476 VSS.n195 VSS.n193 0.0015
R12477 VSS.n193 VSS.n191 0.0015
R12478 VSS.n191 VSS.n189 0.0015
R12479 VSS.n189 VSS.n187 0.0015
R12480 VSS.n3092 VSS.n187 0.0015
R12481 VSS.n185 VSS.n184 0.00214264
R12482 VSS.n24 VSS.n23 0.0014999
R12483 VSS.n3079 VSS.n185 0.0015
R12484 VSS.n94 VSS.n93 0.0015
R12485 VSS.n90 VSS.n92 0.0015
R12486 VSS.n84 VSS.n82 0.0015
R12487 VSS.n80 VSS.n82 0.0015
R12488 VSS.n68 VSS.n67 0.0015
R12489 VSS.n65 VSS.n64 0.0015
R12490 VSS.n63 VSS.n62 0.0015
R12491 VSS.n52 VSS.n3060 0.00166664
R12492 VSS.n51 VSS.n43 0.0015
R12493 VSS.n47 VSS.n45 0.0015
R12494 VSS.n29 VSS.n47 0.00249997
R12495 VSS.n18 VSS.n17 0.00224999
R12496 VSS.n3008 VSS.n15 0.00224999
R12497 VSS.n3028 VSS.n13 0.00224999
R12498 VSS.n29 VSS.n9 0.00199997
R12499 VSS.n21 VSS.n20 0.00183332
R12500 VSS.n3026 VSS.n37 0.0015
R12501 VSS.n3020 VSS.n33 0.0015
R12502 VSS.n3023 VSS.n31 0.0015
R12503 VSS.n2963 VSS.n28 0.0015
R12504 VSS.n8 VSS.n7 0.00125
R12505 VSS.n1518 VSS.n219 0.00147287
R12506 VSS.n1517 VSS.n219 0.00147287
R12507 VSS.n1516 VSS.n219 0.00147287
R12508 VSS.n1514 VSS.n217 0.00147287
R12509 VSS.n1507 VSS.n213 0.00147287
R12510 VSS.n1506 VSS.n213 0.00147287
R12511 VSS.n1505 VSS.n213 0.00147287
R12512 VSS.n1503 VSS.n211 0.00147287
R12513 VSS.n1496 VSS.n207 0.00147287
R12514 VSS.n1495 VSS.n207 0.00147287
R12515 VSS.n1494 VSS.n207 0.00147287
R12516 VSS.n1492 VSS.n205 0.00147287
R12517 VSS.n1477 VSS.n201 0.00147287
R12518 VSS.n1476 VSS.n201 0.00147287
R12519 VSS.n1475 VSS.n201 0.00147287
R12520 VSS.n1473 VSS.n199 0.00147287
R12521 VSS.n1466 VSS.n195 0.00147287
R12522 VSS.n1465 VSS.n195 0.00147287
R12523 VSS.n1464 VSS.n195 0.00147287
R12524 VSS.n1462 VSS.n193 0.00147287
R12525 VSS.n1455 VSS.n189 0.00147287
R12526 VSS.n1454 VSS.n189 0.00147287
R12527 VSS.n1453 VSS.n189 0.00147287
R12528 VSS.n1451 VSS.n187 0.00147287
R12529 VSS.n2772 VSS.n2435 0.00147287
R12530 VSS.n2771 VSS.n2435 0.00147287
R12531 VSS.n2770 VSS.n2435 0.00147287
R12532 VSS.n2768 VSS.n2433 0.00147287
R12533 VSS.n2761 VSS.n2428 0.00147287
R12534 VSS.n2760 VSS.n2428 0.00147287
R12535 VSS.n2759 VSS.n2428 0.00147287
R12536 VSS.n2757 VSS.n2426 0.00147287
R12537 VSS.n2750 VSS.n2421 0.00147287
R12538 VSS.n2749 VSS.n2421 0.00147287
R12539 VSS.n2748 VSS.n2421 0.00147287
R12540 VSS.n2746 VSS.n2419 0.00147287
R12541 VSS.n2731 VSS.n2415 0.00147287
R12542 VSS.n2730 VSS.n2415 0.00147287
R12543 VSS.n2729 VSS.n2415 0.00147287
R12544 VSS.n2727 VSS.n2413 0.00147287
R12545 VSS.n2720 VSS.n2408 0.00147287
R12546 VSS.n2719 VSS.n2408 0.00147287
R12547 VSS.n2718 VSS.n2408 0.00147287
R12548 VSS.n2716 VSS.n2406 0.00147287
R12549 VSS.n2709 VSS.n2401 0.00147287
R12550 VSS.n2708 VSS.n2401 0.00147287
R12551 VSS.n2707 VSS.n2401 0.00147287
R12552 VSS.n2705 VSS.n2399 0.00147287
R12553 VSS.n1732 VSS.n1724 0.00147287
R12554 VSS.n1732 VSS.n1725 0.00147287
R12555 VSS.n1732 VSS.n1726 0.00147287
R12556 VSS.n1731 VSS.n1729 0.00147287
R12557 VSS.n3098 VSS.n280 0.00147287
R12558 VSS.n3099 VSS.n280 0.00147287
R12559 VSS.n3100 VSS.n280 0.00147287
R12560 VSS.n282 VSS.n281 0.00147287
R12561 VSS.n277 VSS.n276 0.00147287
R12562 VSS.n277 VSS.n275 0.00147287
R12563 VSS.n277 VSS.n274 0.00147287
R12564 VSS.n865 VSS.n265 0.00147287
R12565 VSS.n3103 VSS.n261 0.00147287
R12566 VSS.n3104 VSS.n261 0.00147287
R12567 VSS.n3105 VSS.n261 0.00147287
R12568 VSS.n249 VSS.n262 0.00147287
R12569 VSS.n3109 VSS.n244 0.00147287
R12570 VSS.n3110 VSS.n244 0.00147287
R12571 VSS.n3111 VSS.n244 0.00147287
R12572 VSS.n238 VSS.n245 0.00147287
R12573 VSS.n3115 VSS.n232 0.00147287
R12574 VSS.n3116 VSS.n232 0.00147287
R12575 VSS.n3117 VSS.n232 0.00147287
R12576 VSS.n234 VSS.n233 0.00147287
R12577 VSS.n229 VSS.n228 0.00147287
R12578 VSS.n229 VSS.n227 0.00147287
R12579 VSS.n229 VSS.n226 0.00147287
R12580 VSS.n853 VSS.n223 0.00147287
R12581 VSS.n3002 VSS.n17 0.00137498
R12582 VSS.n2967 VSS.n2892 0.00133332
R12583 VSS.n2963 VSS.n2891 0.00133332
R12584 VSS.n8 VSS.n1 0.00128552
R12585 VSS.n1717 VSS.t510 0.00126823
R12586 VSS.n3181 VSS.n497 0.00104691
R12587 VSS.n8 VSS.n5 0.00103597
R12588 VSS.n2851 VSS.n2845 0.00102947
R12589 VSS.n3063 VSS.n1559 0.00102006
R12590 VSS.n3133 VSS.n591 0.00101811
R12591 VSS.n3142 VSS.n3141 0.00101811
R12592 VSS.n3142 VSS.n582 0.00101811
R12593 VSS.n3148 VSS.n565 0.00101811
R12594 VSS.n3148 VSS.n564 0.00101811
R12595 VSS.n3157 VSS.n3156 0.00101811
R12596 VSS.n3157 VSS.n546 0.00101811
R12597 VSS.n3163 VSS.n525 0.00101811
R12598 VSS.n3163 VSS.n524 0.00101811
R12599 VSS.n3172 VSS.n3171 0.00101811
R12600 VSS.n3172 VSS.n511 0.00101811
R12601 VSS.n3181 VSS.n3180 0.00101811
R12602 VSS.n1521 VSS.n221 0.00101517
R12603 VSS.n1512 VSS.n215 0.00101517
R12604 VSS.n1510 VSS.n215 0.00101517
R12605 VSS.n1501 VSS.n209 0.00101517
R12606 VSS.n1499 VSS.n209 0.00101517
R12607 VSS.n1490 VSS.n203 0.00101517
R12608 VSS.n1480 VSS.n203 0.00101517
R12609 VSS.n1471 VSS.n197 0.00101517
R12610 VSS.n1469 VSS.n197 0.00101517
R12611 VSS.n1460 VSS.n191 0.00101517
R12612 VSS.n1458 VSS.n191 0.00101517
R12613 VSS.n2775 VSS.n2437 0.00101517
R12614 VSS.n2766 VSS.n2430 0.00101517
R12615 VSS.n2764 VSS.n2430 0.00101517
R12616 VSS.n2755 VSS.n2423 0.00101517
R12617 VSS.n2753 VSS.n2423 0.00101517
R12618 VSS.n2744 VSS.n2417 0.00101517
R12619 VSS.n2734 VSS.n2417 0.00101517
R12620 VSS.n2725 VSS.n2410 0.00101517
R12621 VSS.n2723 VSS.n2410 0.00101517
R12622 VSS.n2714 VSS.n2403 0.00101517
R12623 VSS.n2712 VSS.n2403 0.00101517
R12624 VSS.n1721 VSS.n1712 0.00101517
R12625 VSS.n290 VSS.n288 0.00101517
R12626 VSS.n871 VSS.n273 0.00101517
R12627 VSS.n869 VSS.n273 0.00101517
R12628 VSS.n270 VSS.n266 0.00101517
R12629 VSS.n270 VSS.n267 0.00101517
R12630 VSS.n259 VSS.n248 0.00101517
R12631 VSS.n259 VSS.n253 0.00101517
R12632 VSS.n242 VSS.n237 0.00101517
R12633 VSS.n242 VSS.n239 0.00101517
R12634 VSS.n859 VSS.n225 0.00101517
R12635 VSS.n857 VSS.n225 0.00101517
R12636 VSS.n3092 VSS.n3085 0.00101478
R12637 VSS.n3128 VSS.n3122 0.00101478
R12638 VSS.n1719 VSS.n1712 0.00100164
R12639 VSS.n3157 VSS.n549 0.00100065
R12640 VSS.n3133 VSS.n590 0.00100065
R12641 VSS.n3157 VSS.n538 0.00100065
R12642 VSS.n3157 VSS.n547 0.00100065
R12643 VSS.n3181 VSS.n477 0.00100065
R12644 VSS.n3092 VSS.n1140 0.00100047
R12645 VSS.n2851 VSS.n2397 0.00100047
R12646 VSS.n3063 VSS.n1561 0.00100047
R12647 VSS.n3128 VSS.n851 0.00100047
R12648 VSS.n1485 VSS.n203 0.00100046
R12649 VSS.n2739 VSS.n2417 0.00100046
R12650 VSS.n259 VSS.n251 0.00100046
R12651 VSS.n1523 VSS.n221 0.00100046
R12652 VSS.n1488 VSS.n203 0.00100046
R12653 VSS.n1482 VSS.n203 0.00100046
R12654 VSS.n2777 VSS.n2437 0.00100046
R12655 VSS.n2742 VSS.n2417 0.00100046
R12656 VSS.n2736 VSS.n2417 0.00100046
R12657 VSS.n290 VSS.n289 0.00100046
R12658 VSS.n259 VSS.n257 0.00100046
R12659 VSS.n259 VSS.n252 0.00100046
R12660 VSS.n2851 VSS.n2844 0.001
R12661 VSS.n3128 VSS.n3121 0.001
R12662 VSS.n3092 VSS.n3084 0.001
R12663 VSS.n3134 VSS.n587 0.001
R12664 VSS.n3136 VSS.n3135 0.001
R12665 VSS.n3139 VSS.n584 0.001
R12666 VSS.n3142 VSS.n575 0.001
R12667 VSS.n3143 VSS.n572 0.001
R12668 VSS.n3145 VSS.n3144 0.001
R12669 VSS.n3146 VSS.n566 0.001
R12670 VSS.n3148 VSS.n3147 0.001
R12671 VSS.n3149 VSS.n556 0.001
R12672 VSS.n3151 VSS.n3150 0.001
R12673 VSS.n3154 VSS.n553 0.001
R12674 VSS.n3157 VSS.n536 0.001
R12675 VSS.n3158 VSS.n532 0.001
R12676 VSS.n3160 VSS.n3159 0.001
R12677 VSS.n3161 VSS.n526 0.001
R12678 VSS.n3163 VSS.n3162 0.001
R12679 VSS.n3164 VSS.n516 0.001
R12680 VSS.n3166 VSS.n3165 0.001
R12681 VSS.n3169 VSS.n513 0.001
R12682 VSS.n3172 VSS.n505 0.001
R12683 VSS.n3173 VSS.n502 0.001
R12684 VSS.n3175 VSS.n3174 0.001
R12685 VSS.n3178 VSS.n499 0.001
R12686 VSS.n3181 VSS.n475 0.001
R12687 VSS.n3178 VSS.n475 0.001
R12688 VSS.n3175 VSS.n499 0.001
R12689 VSS.n3174 VSS.n502 0.001
R12690 VSS.n3173 VSS.n3172 0.001
R12691 VSS.n3169 VSS.n505 0.001
R12692 VSS.n3166 VSS.n513 0.001
R12693 VSS.n3165 VSS.n516 0.001
R12694 VSS.n3164 VSS.n3163 0.001
R12695 VSS.n3162 VSS.n526 0.001
R12696 VSS.n3161 VSS.n3160 0.001
R12697 VSS.n3159 VSS.n532 0.001
R12698 VSS.n3158 VSS.n3157 0.001
R12699 VSS.n3154 VSS.n536 0.001
R12700 VSS.n3151 VSS.n553 0.001
R12701 VSS.n3150 VSS.n556 0.001
R12702 VSS.n3149 VSS.n3148 0.001
R12703 VSS.n3147 VSS.n566 0.001
R12704 VSS.n3146 VSS.n3145 0.001
R12705 VSS.n3144 VSS.n572 0.001
R12706 VSS.n3143 VSS.n3142 0.001
R12707 VSS.n3139 VSS.n575 0.001
R12708 VSS.n3136 VSS.n584 0.001
R12709 VSS.n3135 VSS.n587 0.001
R12710 VSS.n3134 VSS.n3133 0.001
R12711 VSS.n383 VSS.n382 0.001
R12712 VSS.n3079 VSS.n186 0.001
R12713 VSS.n2436 VSS.n2435 0.001
R12714 VSS.n2434 VSS.n2433 0.001
R12715 VSS.n2432 VSS.n2430 0.001
R12716 VSS.n2429 VSS.n2428 0.001
R12717 VSS.n2427 VSS.n2426 0.001
R12718 VSS.n2425 VSS.n2423 0.001
R12719 VSS.n2422 VSS.n2421 0.001
R12720 VSS.n2420 VSS.n2419 0.001
R12721 VSS.n2418 VSS.n2417 0.001
R12722 VSS.n2416 VSS.n2415 0.001
R12723 VSS.n2414 VSS.n2413 0.001
R12724 VSS.n2412 VSS.n2410 0.001
R12725 VSS.n2409 VSS.n2408 0.001
R12726 VSS.n2407 VSS.n2406 0.001
R12727 VSS.n2405 VSS.n2403 0.001
R12728 VSS.n2402 VSS.n2401 0.001
R12729 VSS.n2400 VSS.n2399 0.001
R12730 VSS.n2851 VSS.n2398 0.001
R12731 VSS.n2399 VSS.n2398 0.001
R12732 VSS.n2401 VSS.n2400 0.001
R12733 VSS.n2403 VSS.n2402 0.001
R12734 VSS.n2406 VSS.n2405 0.001
R12735 VSS.n2408 VSS.n2407 0.001
R12736 VSS.n2410 VSS.n2409 0.001
R12737 VSS.n2413 VSS.n2412 0.001
R12738 VSS.n2415 VSS.n2414 0.001
R12739 VSS.n2417 VSS.n2416 0.001
R12740 VSS.n2419 VSS.n2418 0.001
R12741 VSS.n2421 VSS.n2420 0.001
R12742 VSS.n2423 VSS.n2422 0.001
R12743 VSS.n2426 VSS.n2425 0.001
R12744 VSS.n2428 VSS.n2427 0.001
R12745 VSS.n2430 VSS.n2429 0.001
R12746 VSS.n2433 VSS.n2432 0.001
R12747 VSS.n2435 VSS.n2434 0.001
R12748 VSS.n2437 VSS.n2436 0.001
R12749 VSS.n2087 VSS.n1633 0.001
R12750 VSS.n2068 VSS.n1650 0.001
R12751 VSS.n2058 VSS.n1655 0.001
R12752 VSS.n2057 VSS.n1656 0.001
R12753 VSS.n1995 VSS.n1664 0.001
R12754 VSS.n1985 VSS.n1669 0.001
R12755 VSS.n1984 VSS.n1670 0.001
R12756 VSS.n1922 VSS.n1678 0.001
R12757 VSS.n1912 VSS.n1683 0.001
R12758 VSS.n72 VSS.n76 0.001
R12759 VSS.n81 VSS.n80 0.00124999
R12760 VSS.n91 VSS.n90 0.00124999
R12761 VSS.n1910 VSS.n1684 0.001
R12762 VSS.n1800 VSS.n1691 0.001
R12763 VSS.n1793 VSS.n1697 0.001
R12764 VSS.n1792 VSS.n1698 0.001
R12765 VSS.n1742 VSS.n1707 0.001
R12766 VSS.n1733 VSS.n1712 0.001
R12767 VSS.n1732 VSS.n1713 0.001
R12768 VSS.n1731 VSS.n1727 0.001
R12769 VSS.n3063 VSS.n1562 0.001
R12770 VSS.n1731 VSS.n1562 0.001
R12771 VSS.n1732 VSS.n1727 0.001
R12772 VSS.n1713 VSS.n1712 0.001
R12773 VSS.n1742 VSS.n1733 0.001
R12774 VSS.n1792 VSS.n1707 0.001
R12775 VSS.n1698 VSS.n1697 0.001
R12776 VSS.n1800 VSS.n1793 0.001
R12777 VSS.n1910 VSS.n1691 0.001
R12778 VSS.n1684 VSS.n1683 0.001
R12779 VSS.n1922 VSS.n1912 0.001
R12780 VSS.n1984 VSS.n1678 0.001
R12781 VSS.n1670 VSS.n1669 0.001
R12782 VSS.n1995 VSS.n1985 0.001
R12783 VSS.n2057 VSS.n1664 0.001
R12784 VSS.n1656 VSS.n1655 0.001
R12785 VSS.n2068 VSS.n2058 0.001
R12786 VSS.n2087 VSS.n1650 0.001
R12787 VSS.n2859 VSS.n1633 0.001
R12788 VSS.n1819 VSS.n1610 0.001
R12789 VSS.t284 VSS.n1610 0.001
R12790 VSS.n1609 VSS.n7 8.47794
R12791 VSS.n3034 VSS.n7 8.50175
R12792 a_3747_311.n0 a_3747_311.t2 52.0388
R12793 a_3747_311.t1 a_3747_311.n0 35.4491
R12794 a_3747_311.n0 a_3747_311.t3 33.5891
R12795 a_3747_311.t0 a_3747_311.t1 5.61942
R12796 a_3171_311.n0 a_3171_311.t2 51.8377
R12797 a_3171_311.n0 a_3171_311.t3 33.3881
R12798 a_3171_311.t1 a_3171_311.n0 31.8923
R12799 a_3171_311.t0 a_3171_311.t1 5.61777
R12800 a_2595_311.n0 a_2595_311.t2 51.6367
R12801 a_2595_311.n0 a_2595_311.t3 33.187
R12802 a_2595_311.t1 a_2595_311.n0 27.993
R12803 a_2595_311.t0 a_2595_311.t1 5.73018
R12804 a_2019_311.t3 a_2019_311.t2 51.6139
R12805 a_2019_311.t1 a_2019_311.t3 24.5351
R12806 a_2019_311.t0 a_2019_311.t1 5.62052
R12807 a_3747_1047.n0 a_3747_1047.t2 38.0081
R12808 a_3747_1047.n0 a_3747_1047.t3 33.3957
R12809 a_3747_1047.n1 a_3747_1047.t4 33.3957
R12810 a_3747_1047.n2 a_3747_1047.t5 33.3957
R12811 a_3747_1047.n3 a_3747_1047.t6 33.3957
R12812 a_3747_1047.n4 a_3747_1047.t7 33.3957
R12813 a_3747_1047.n5 a_3747_1047.t8 33.3957
R12814 a_3747_1047.n6 a_3747_1047.t9 33.3957
R12815 a_3747_1047.t1 a_3747_1047.n6 23.2419
R12816 a_3747_1047.t0 a_3747_1047.t1 5.61942
R12817 a_3747_1047.n6 a_3747_1047.n5 4.61291
R12818 a_3747_1047.n5 a_3747_1047.n4 4.61291
R12819 a_3747_1047.n4 a_3747_1047.n3 4.61291
R12820 a_3747_1047.n3 a_3747_1047.n2 4.61291
R12821 a_3747_1047.n2 a_3747_1047.n1 4.61291
R12822 a_3747_1047.n1 a_3747_1047.n0 4.61291
R12823 a_3171_1047.n0 a_3171_1047.t2 37.8054
R12824 a_3171_1047.n0 a_3171_1047.t3 33.193
R12825 a_3171_1047.n1 a_3171_1047.t4 33.193
R12826 a_3171_1047.n2 a_3171_1047.t5 33.193
R12827 a_3171_1047.n3 a_3171_1047.t6 33.193
R12828 a_3171_1047.n4 a_3171_1047.t7 33.193
R12829 a_3171_1047.n5 a_3171_1047.t8 33.193
R12830 a_3171_1047.n6 a_3171_1047.t9 33.193
R12831 a_3171_1047.t1 a_3171_1047.n6 23.0313
R12832 a_3171_1047.t0 a_3171_1047.t1 5.61777
R12833 a_3171_1047.n6 a_3171_1047.n5 4.61291
R12834 a_3171_1047.n5 a_3171_1047.n4 4.61291
R12835 a_3171_1047.n4 a_3171_1047.n3 4.61291
R12836 a_3171_1047.n3 a_3171_1047.n2 4.61291
R12837 a_3171_1047.n2 a_3171_1047.n1 4.61291
R12838 a_3171_1047.n1 a_3171_1047.n0 4.61291
R12839 a_2595_1047.n0 a_2595_1047.t2 37.7691
R12840 a_2595_1047.n0 a_2595_1047.t3 33.1567
R12841 a_2595_1047.n1 a_2595_1047.t4 33.1567
R12842 a_2595_1047.n2 a_2595_1047.t5 33.1567
R12843 a_2595_1047.n3 a_2595_1047.t6 33.1567
R12844 a_2595_1047.n4 a_2595_1047.t7 33.1567
R12845 a_2595_1047.n5 a_2595_1047.t8 33.1567
R12846 a_2595_1047.n6 a_2595_1047.t9 33.1567
R12847 a_2595_1047.t1 a_2595_1047.n6 22.7941
R12848 a_2595_1047.t0 a_2595_1047.t1 5.65522
R12849 a_2595_1047.n6 a_2595_1047.n5 4.61291
R12850 a_2595_1047.n5 a_2595_1047.n4 4.61291
R12851 a_2595_1047.n4 a_2595_1047.n3 4.61291
R12852 a_2595_1047.n3 a_2595_1047.n2 4.61291
R12853 a_2595_1047.n2 a_2595_1047.n1 4.61291
R12854 a_2595_1047.n1 a_2595_1047.n0 4.61291
R12855 a_2019_1047.n0 a_2019_1047.t2 37.9701
R12856 a_2019_1047.n0 a_2019_1047.t3 33.3577
R12857 a_2019_1047.n1 a_2019_1047.t4 33.3577
R12858 a_2019_1047.n2 a_2019_1047.t5 33.3577
R12859 a_2019_1047.n3 a_2019_1047.t6 33.3577
R12860 a_2019_1047.n4 a_2019_1047.t7 33.3577
R12861 a_2019_1047.t1 a_2019_1047.t9 22.5945
R12862 a_2019_1047.t0 a_2019_1047.t1 5.62052
R12863 a_2019_1047.t9 a_2019_1047.t8 4.61291
R12864 a_2019_1047.t8 a_2019_1047.n4 4.61291
R12865 a_2019_1047.n4 a_2019_1047.n3 4.61291
R12866 a_2019_1047.n3 a_2019_1047.n2 4.61291
R12867 a_2019_1047.n2 a_2019_1047.n1 4.61291
R12868 a_2019_1047.n1 a_2019_1047.n0 4.61291
R12869 a_3747_3156.n0 a_3747_3156.t2 52.0388
R12870 a_3747_3156.t1 a_3747_3156.n0 35.4491
R12871 a_3747_3156.n0 a_3747_3156.t3 33.5891
R12872 a_3747_3156.t0 a_3747_3156.t1 5.61942
R12873 a_3171_3156.n0 a_3171_3156.t2 51.8377
R12874 a_3171_3156.n0 a_3171_3156.t3 33.3881
R12875 a_3171_3156.t1 a_3171_3156.n0 31.8923
R12876 a_3171_3156.t0 a_3171_3156.t1 5.61777
R12877 a_2595_3156.n0 a_2595_3156.t2 51.6367
R12878 a_2595_3156.n0 a_2595_3156.t3 33.187
R12879 a_2595_3156.t1 a_2595_3156.n0 27.993
R12880 a_2595_3156.t0 a_2595_3156.t1 5.73018
R12881 a_2019_3156.t3 a_2019_3156.t2 51.6139
R12882 a_2019_3156.t1 a_2019_3156.t3 24.5351
R12883 a_2019_3156.t0 a_2019_3156.t1 5.62052
R12884 a_3747_3892.n0 a_3747_3892.t2 38.0081
R12885 a_3747_3892.n0 a_3747_3892.t3 33.3957
R12886 a_3747_3892.n1 a_3747_3892.t4 33.3957
R12887 a_3747_3892.n2 a_3747_3892.t5 33.3957
R12888 a_3747_3892.n3 a_3747_3892.t6 33.3957
R12889 a_3747_3892.n4 a_3747_3892.t7 33.3957
R12890 a_3747_3892.n5 a_3747_3892.t8 33.3957
R12891 a_3747_3892.n6 a_3747_3892.t9 33.3957
R12892 a_3747_3892.t1 a_3747_3892.n6 23.2419
R12893 a_3747_3892.t0 a_3747_3892.t1 5.61942
R12894 a_3747_3892.n6 a_3747_3892.n5 4.61291
R12895 a_3747_3892.n5 a_3747_3892.n4 4.61291
R12896 a_3747_3892.n4 a_3747_3892.n3 4.61291
R12897 a_3747_3892.n3 a_3747_3892.n2 4.61291
R12898 a_3747_3892.n2 a_3747_3892.n1 4.61291
R12899 a_3747_3892.n1 a_3747_3892.n0 4.61291
R12900 a_3171_3892.n0 a_3171_3892.t2 37.8054
R12901 a_3171_3892.n0 a_3171_3892.t3 33.193
R12902 a_3171_3892.n1 a_3171_3892.t4 33.193
R12903 a_3171_3892.n2 a_3171_3892.t5 33.193
R12904 a_3171_3892.n3 a_3171_3892.t6 33.193
R12905 a_3171_3892.n4 a_3171_3892.t7 33.193
R12906 a_3171_3892.n5 a_3171_3892.t8 33.193
R12907 a_3171_3892.n6 a_3171_3892.t9 33.193
R12908 a_3171_3892.t1 a_3171_3892.n6 23.0313
R12909 a_3171_3892.t0 a_3171_3892.t1 5.61777
R12910 a_3171_3892.n6 a_3171_3892.n5 4.61291
R12911 a_3171_3892.n5 a_3171_3892.n4 4.61291
R12912 a_3171_3892.n4 a_3171_3892.n3 4.61291
R12913 a_3171_3892.n3 a_3171_3892.n2 4.61291
R12914 a_3171_3892.n2 a_3171_3892.n1 4.61291
R12915 a_3171_3892.n1 a_3171_3892.n0 4.61291
R12916 a_2595_3892.n0 a_2595_3892.t2 37.7691
R12917 a_2595_3892.n0 a_2595_3892.t3 33.1567
R12918 a_2595_3892.n1 a_2595_3892.t4 33.1567
R12919 a_2595_3892.n2 a_2595_3892.t5 33.1567
R12920 a_2595_3892.n3 a_2595_3892.t6 33.1567
R12921 a_2595_3892.n4 a_2595_3892.t7 33.1567
R12922 a_2595_3892.n5 a_2595_3892.t8 33.1567
R12923 a_2595_3892.n6 a_2595_3892.t9 33.1567
R12924 a_2595_3892.t1 a_2595_3892.n6 22.7941
R12925 a_2595_3892.t0 a_2595_3892.t1 5.65522
R12926 a_2595_3892.n6 a_2595_3892.n5 4.61291
R12927 a_2595_3892.n5 a_2595_3892.n4 4.61291
R12928 a_2595_3892.n4 a_2595_3892.n3 4.61291
R12929 a_2595_3892.n3 a_2595_3892.n2 4.61291
R12930 a_2595_3892.n2 a_2595_3892.n1 4.61291
R12931 a_2595_3892.n1 a_2595_3892.n0 4.61291
R12932 a_2019_3892.n0 a_2019_3892.t2 37.9701
R12933 a_2019_3892.n0 a_2019_3892.t3 33.3577
R12934 a_2019_3892.n1 a_2019_3892.t4 33.3577
R12935 a_2019_3892.n2 a_2019_3892.t5 33.3577
R12936 a_2019_3892.n3 a_2019_3892.t6 33.3577
R12937 a_2019_3892.n4 a_2019_3892.t7 33.3577
R12938 a_2019_3892.n5 a_2019_3892.t8 33.3577
R12939 a_2019_3892.t1 a_2019_3892.t9 22.5945
R12940 a_2019_3892.t0 a_2019_3892.t1 5.62052
R12941 a_2019_3892.t9 a_2019_3892.n5 4.61291
R12942 a_2019_3892.n5 a_2019_3892.n4 4.61291
R12943 a_2019_3892.n4 a_2019_3892.n3 4.61291
R12944 a_2019_3892.n3 a_2019_3892.n2 4.61291
R12945 a_2019_3892.n2 a_2019_3892.n1 4.61291
R12946 a_2019_3892.n1 a_2019_3892.n0 4.61291
R12947 a_3747_6001.n0 a_3747_6001.t2 52.0388
R12948 a_3747_6001.t1 a_3747_6001.n0 35.4491
R12949 a_3747_6001.n0 a_3747_6001.t3 33.5891
R12950 a_3747_6001.t0 a_3747_6001.t1 5.61942
R12951 a_3171_6001.n0 a_3171_6001.t2 51.8377
R12952 a_3171_6001.n0 a_3171_6001.t3 33.3881
R12953 a_3171_6001.t1 a_3171_6001.n0 31.8923
R12954 a_3171_6001.t0 a_3171_6001.t1 5.61777
R12955 a_2595_6001.n0 a_2595_6001.t2 51.6367
R12956 a_2595_6001.n0 a_2595_6001.t3 33.187
R12957 a_2595_6001.t1 a_2595_6001.n0 27.993
R12958 a_2595_6001.t0 a_2595_6001.t1 5.73018
R12959 a_2019_6001.t3 a_2019_6001.t2 51.6139
R12960 a_2019_6001.t1 a_2019_6001.t3 24.5351
R12961 a_2019_6001.t0 a_2019_6001.t1 5.62052
R12962 a_3747_6737.n0 a_3747_6737.t2 38.0081
R12963 a_3747_6737.n0 a_3747_6737.t3 33.3957
R12964 a_3747_6737.n1 a_3747_6737.t4 33.3957
R12965 a_3747_6737.n2 a_3747_6737.t5 33.3957
R12966 a_3747_6737.n3 a_3747_6737.t6 33.3957
R12967 a_3747_6737.n4 a_3747_6737.t7 33.3957
R12968 a_3747_6737.n5 a_3747_6737.t8 33.3957
R12969 a_3747_6737.n6 a_3747_6737.t9 33.3957
R12970 a_3747_6737.t1 a_3747_6737.n6 23.2419
R12971 a_3747_6737.t0 a_3747_6737.t1 5.61942
R12972 a_3747_6737.n6 a_3747_6737.n5 4.61291
R12973 a_3747_6737.n5 a_3747_6737.n4 4.61291
R12974 a_3747_6737.n4 a_3747_6737.n3 4.61291
R12975 a_3747_6737.n3 a_3747_6737.n2 4.61291
R12976 a_3747_6737.n2 a_3747_6737.n1 4.61291
R12977 a_3747_6737.n1 a_3747_6737.n0 4.61291
R12978 a_3171_6737.n0 a_3171_6737.t2 37.8054
R12979 a_3171_6737.n0 a_3171_6737.t3 33.193
R12980 a_3171_6737.n1 a_3171_6737.t4 33.193
R12981 a_3171_6737.n2 a_3171_6737.t5 33.193
R12982 a_3171_6737.n3 a_3171_6737.t6 33.193
R12983 a_3171_6737.n4 a_3171_6737.t7 33.193
R12984 a_3171_6737.n5 a_3171_6737.t8 33.193
R12985 a_3171_6737.n6 a_3171_6737.t9 33.193
R12986 a_3171_6737.t1 a_3171_6737.n6 23.0313
R12987 a_3171_6737.t0 a_3171_6737.t1 5.61777
R12988 a_3171_6737.n6 a_3171_6737.n5 4.61291
R12989 a_3171_6737.n5 a_3171_6737.n4 4.61291
R12990 a_3171_6737.n4 a_3171_6737.n3 4.61291
R12991 a_3171_6737.n3 a_3171_6737.n2 4.61291
R12992 a_3171_6737.n2 a_3171_6737.n1 4.61291
R12993 a_3171_6737.n1 a_3171_6737.n0 4.61291
R12994 a_2595_6737.n0 a_2595_6737.t2 37.7691
R12995 a_2595_6737.n0 a_2595_6737.t3 33.1567
R12996 a_2595_6737.n1 a_2595_6737.t4 33.1567
R12997 a_2595_6737.n2 a_2595_6737.t5 33.1567
R12998 a_2595_6737.n3 a_2595_6737.t6 33.1567
R12999 a_2595_6737.n4 a_2595_6737.t7 33.1567
R13000 a_2595_6737.n5 a_2595_6737.t8 33.1567
R13001 a_2595_6737.n6 a_2595_6737.t9 33.1567
R13002 a_2595_6737.t1 a_2595_6737.n6 22.7941
R13003 a_2595_6737.t0 a_2595_6737.t1 5.65522
R13004 a_2595_6737.n6 a_2595_6737.n5 4.61291
R13005 a_2595_6737.n5 a_2595_6737.n4 4.61291
R13006 a_2595_6737.n4 a_2595_6737.n3 4.61291
R13007 a_2595_6737.n3 a_2595_6737.n2 4.61291
R13008 a_2595_6737.n2 a_2595_6737.n1 4.61291
R13009 a_2595_6737.n1 a_2595_6737.n0 4.61291
R13010 a_2019_6737.n0 a_2019_6737.t2 37.9701
R13011 a_2019_6737.n0 a_2019_6737.t3 33.3577
R13012 a_2019_6737.n1 a_2019_6737.t4 33.3577
R13013 a_2019_6737.n2 a_2019_6737.t5 33.3577
R13014 a_2019_6737.n3 a_2019_6737.t6 33.3577
R13015 a_2019_6737.n4 a_2019_6737.t7 33.3577
R13016 a_2019_6737.n5 a_2019_6737.t8 33.3577
R13017 a_2019_6737.t1 a_2019_6737.t9 22.5945
R13018 a_2019_6737.t0 a_2019_6737.t1 5.62052
R13019 a_2019_6737.t9 a_2019_6737.n5 4.61291
R13020 a_2019_6737.n5 a_2019_6737.n4 4.61291
R13021 a_2019_6737.n4 a_2019_6737.n3 4.61291
R13022 a_2019_6737.n3 a_2019_6737.n2 4.61291
R13023 a_2019_6737.n2 a_2019_6737.n1 4.61291
R13024 a_2019_6737.n1 a_2019_6737.n0 4.61291
R13025 a_3747_12493.n0 a_3747_12493.t2 52.0388
R13026 a_3747_12493.t1 a_3747_12493.n0 35.4491
R13027 a_3747_12493.n0 a_3747_12493.t3 33.5891
R13028 a_3747_12493.t0 a_3747_12493.t1 5.61942
R13029 a_3171_12493.n0 a_3171_12493.t2 51.8377
R13030 a_3171_12493.n0 a_3171_12493.t3 33.3881
R13031 a_3171_12493.t1 a_3171_12493.n0 31.8923
R13032 a_3171_12493.t0 a_3171_12493.t1 5.61777
R13033 a_2595_12493.n0 a_2595_12493.t2 51.6367
R13034 a_2595_12493.n0 a_2595_12493.t3 33.187
R13035 a_2595_12493.t1 a_2595_12493.n0 27.993
R13036 a_2595_12493.t0 a_2595_12493.t1 5.73018
R13037 a_2019_12493.t3 a_2019_12493.t2 51.6139
R13038 a_2019_12493.t1 a_2019_12493.t3 24.5351
R13039 a_2019_12493.t0 a_2019_12493.t1 5.62052
R13040 a_3747_13229.n0 a_3747_13229.t2 38.0081
R13041 a_3747_13229.n0 a_3747_13229.t3 33.3957
R13042 a_3747_13229.n1 a_3747_13229.t4 33.3957
R13043 a_3747_13229.n2 a_3747_13229.t5 33.3957
R13044 a_3747_13229.n3 a_3747_13229.t6 33.3957
R13045 a_3747_13229.n4 a_3747_13229.t7 33.3957
R13046 a_3747_13229.n5 a_3747_13229.t8 33.3957
R13047 a_3747_13229.n6 a_3747_13229.t9 33.3957
R13048 a_3747_13229.t1 a_3747_13229.n6 23.2419
R13049 a_3747_13229.t0 a_3747_13229.t1 5.61942
R13050 a_3747_13229.n6 a_3747_13229.n5 4.61291
R13051 a_3747_13229.n5 a_3747_13229.n4 4.61291
R13052 a_3747_13229.n4 a_3747_13229.n3 4.61291
R13053 a_3747_13229.n3 a_3747_13229.n2 4.61291
R13054 a_3747_13229.n2 a_3747_13229.n1 4.61291
R13055 a_3747_13229.n1 a_3747_13229.n0 4.61291
R13056 a_3171_13229.n0 a_3171_13229.t2 37.8054
R13057 a_3171_13229.n0 a_3171_13229.t3 33.193
R13058 a_3171_13229.n1 a_3171_13229.t4 33.193
R13059 a_3171_13229.n2 a_3171_13229.t5 33.193
R13060 a_3171_13229.n3 a_3171_13229.t6 33.193
R13061 a_3171_13229.n4 a_3171_13229.t7 33.193
R13062 a_3171_13229.n5 a_3171_13229.t8 33.193
R13063 a_3171_13229.n6 a_3171_13229.t9 33.193
R13064 a_3171_13229.t1 a_3171_13229.n6 23.0313
R13065 a_3171_13229.t0 a_3171_13229.t1 5.61777
R13066 a_3171_13229.n6 a_3171_13229.n5 4.61291
R13067 a_3171_13229.n5 a_3171_13229.n4 4.61291
R13068 a_3171_13229.n4 a_3171_13229.n3 4.61291
R13069 a_3171_13229.n3 a_3171_13229.n2 4.61291
R13070 a_3171_13229.n2 a_3171_13229.n1 4.61291
R13071 a_3171_13229.n1 a_3171_13229.n0 4.61291
R13072 a_2595_13229.n0 a_2595_13229.t2 37.7691
R13073 a_2595_13229.n0 a_2595_13229.t3 33.1567
R13074 a_2595_13229.n1 a_2595_13229.t4 33.1567
R13075 a_2595_13229.n2 a_2595_13229.t5 33.1567
R13076 a_2595_13229.n3 a_2595_13229.t6 33.1567
R13077 a_2595_13229.n4 a_2595_13229.t7 33.1567
R13078 a_2595_13229.n5 a_2595_13229.t8 33.1567
R13079 a_2595_13229.n6 a_2595_13229.t9 33.1567
R13080 a_2595_13229.t1 a_2595_13229.n6 22.7941
R13081 a_2595_13229.t0 a_2595_13229.t1 5.65522
R13082 a_2595_13229.n6 a_2595_13229.n5 4.61291
R13083 a_2595_13229.n5 a_2595_13229.n4 4.61291
R13084 a_2595_13229.n4 a_2595_13229.n3 4.61291
R13085 a_2595_13229.n3 a_2595_13229.n2 4.61291
R13086 a_2595_13229.n2 a_2595_13229.n1 4.61291
R13087 a_2595_13229.n1 a_2595_13229.n0 4.61291
R13088 a_2019_13229.n0 a_2019_13229.t2 37.9701
R13089 a_2019_13229.n0 a_2019_13229.t3 33.3577
R13090 a_2019_13229.n1 a_2019_13229.t4 33.3577
R13091 a_2019_13229.n2 a_2019_13229.t5 33.3577
R13092 a_2019_13229.n3 a_2019_13229.t6 33.3577
R13093 a_2019_13229.n4 a_2019_13229.t7 33.3577
R13094 a_2019_13229.n5 a_2019_13229.t8 33.3577
R13095 a_2019_13229.t1 a_2019_13229.t9 22.5945
R13096 a_2019_13229.t0 a_2019_13229.t1 5.62052
R13097 a_2019_13229.t9 a_2019_13229.n5 4.61291
R13098 a_2019_13229.n5 a_2019_13229.n4 4.61291
R13099 a_2019_13229.n4 a_2019_13229.n3 4.61291
R13100 a_2019_13229.n3 a_2019_13229.n2 4.61291
R13101 a_2019_13229.n2 a_2019_13229.n1 4.61291
R13102 a_2019_13229.n1 a_2019_13229.n0 4.61291
R13103 a_3747_15338.n0 a_3747_15338.t2 52.0388
R13104 a_3747_15338.t1 a_3747_15338.n0 35.4491
R13105 a_3747_15338.n0 a_3747_15338.t3 33.5891
R13106 a_3747_15338.t0 a_3747_15338.t1 5.61942
R13107 a_3171_15338.n0 a_3171_15338.t2 51.8377
R13108 a_3171_15338.n0 a_3171_15338.t3 33.3881
R13109 a_3171_15338.t1 a_3171_15338.n0 31.8923
R13110 a_3171_15338.t0 a_3171_15338.t1 5.61777
R13111 a_2595_15338.n0 a_2595_15338.t2 51.6367
R13112 a_2595_15338.n0 a_2595_15338.t3 33.187
R13113 a_2595_15338.t1 a_2595_15338.n0 27.993
R13114 a_2595_15338.t0 a_2595_15338.t1 5.73018
R13115 a_2019_15338.t3 a_2019_15338.t2 51.6139
R13116 a_2019_15338.t1 a_2019_15338.t3 24.5351
R13117 a_2019_15338.t0 a_2019_15338.t1 5.62052
R13118 a_3747_16074.n0 a_3747_16074.t2 38.0081
R13119 a_3747_16074.n0 a_3747_16074.t3 33.3957
R13120 a_3747_16074.n1 a_3747_16074.t4 33.3957
R13121 a_3747_16074.n2 a_3747_16074.t5 33.3957
R13122 a_3747_16074.n3 a_3747_16074.t6 33.3957
R13123 a_3747_16074.n4 a_3747_16074.t7 33.3957
R13124 a_3747_16074.n5 a_3747_16074.t8 33.3957
R13125 a_3747_16074.n6 a_3747_16074.t9 33.3957
R13126 a_3747_16074.t1 a_3747_16074.n6 23.2419
R13127 a_3747_16074.t0 a_3747_16074.t1 5.61942
R13128 a_3747_16074.n6 a_3747_16074.n5 4.61291
R13129 a_3747_16074.n5 a_3747_16074.n4 4.61291
R13130 a_3747_16074.n4 a_3747_16074.n3 4.61291
R13131 a_3747_16074.n3 a_3747_16074.n2 4.61291
R13132 a_3747_16074.n2 a_3747_16074.n1 4.61291
R13133 a_3747_16074.n1 a_3747_16074.n0 4.61291
R13134 a_3171_16074.n0 a_3171_16074.t2 37.8054
R13135 a_3171_16074.n0 a_3171_16074.t3 33.193
R13136 a_3171_16074.n1 a_3171_16074.t4 33.193
R13137 a_3171_16074.n2 a_3171_16074.t5 33.193
R13138 a_3171_16074.n3 a_3171_16074.t6 33.193
R13139 a_3171_16074.n4 a_3171_16074.t7 33.193
R13140 a_3171_16074.n5 a_3171_16074.t8 33.193
R13141 a_3171_16074.n6 a_3171_16074.t9 33.193
R13142 a_3171_16074.t1 a_3171_16074.n6 23.0313
R13143 a_3171_16074.t0 a_3171_16074.t1 5.61777
R13144 a_3171_16074.n6 a_3171_16074.n5 4.61291
R13145 a_3171_16074.n5 a_3171_16074.n4 4.61291
R13146 a_3171_16074.n4 a_3171_16074.n3 4.61291
R13147 a_3171_16074.n3 a_3171_16074.n2 4.61291
R13148 a_3171_16074.n2 a_3171_16074.n1 4.61291
R13149 a_3171_16074.n1 a_3171_16074.n0 4.61291
R13150 a_2595_16074.n0 a_2595_16074.t2 37.7691
R13151 a_2595_16074.n0 a_2595_16074.t3 33.1567
R13152 a_2595_16074.n1 a_2595_16074.t4 33.1567
R13153 a_2595_16074.n2 a_2595_16074.t5 33.1567
R13154 a_2595_16074.n3 a_2595_16074.t6 33.1567
R13155 a_2595_16074.n4 a_2595_16074.t7 33.1567
R13156 a_2595_16074.n5 a_2595_16074.t8 33.1567
R13157 a_2595_16074.n6 a_2595_16074.t9 33.1567
R13158 a_2595_16074.t1 a_2595_16074.n6 22.7941
R13159 a_2595_16074.t0 a_2595_16074.t1 5.65522
R13160 a_2595_16074.n6 a_2595_16074.n5 4.61291
R13161 a_2595_16074.n5 a_2595_16074.n4 4.61291
R13162 a_2595_16074.n4 a_2595_16074.n3 4.61291
R13163 a_2595_16074.n3 a_2595_16074.n2 4.61291
R13164 a_2595_16074.n2 a_2595_16074.n1 4.61291
R13165 a_2595_16074.n1 a_2595_16074.n0 4.61291
R13166 a_2019_16074.n0 a_2019_16074.t2 37.9701
R13167 a_2019_16074.n0 a_2019_16074.t3 33.3577
R13168 a_2019_16074.n1 a_2019_16074.t4 33.3577
R13169 a_2019_16074.n2 a_2019_16074.t5 33.3577
R13170 a_2019_16074.n3 a_2019_16074.t6 33.3577
R13171 a_2019_16074.n4 a_2019_16074.t7 33.3577
R13172 a_2019_16074.n5 a_2019_16074.t8 33.3577
R13173 a_2019_16074.t1 a_2019_16074.t9 22.5945
R13174 a_2019_16074.t0 a_2019_16074.t1 5.62052
R13175 a_2019_16074.t9 a_2019_16074.n5 4.61291
R13176 a_2019_16074.n5 a_2019_16074.n4 4.61291
R13177 a_2019_16074.n4 a_2019_16074.n3 4.61291
R13178 a_2019_16074.n3 a_2019_16074.n2 4.61291
R13179 a_2019_16074.n2 a_2019_16074.n1 4.61291
R13180 a_2019_16074.n1 a_2019_16074.n0 4.61291
R13181 a_4187_1764.n0 a_4187_1764.t163 34.3755
R13182 a_4187_1764.n31 a_4187_1764.t131 34.3755
R13183 a_4187_1764.n126 a_4187_1764.t97 34.3755
R13184 a_4187_1764.n94 a_4187_1764.t65 34.3755
R13185 a_4187_1764.n63 a_4187_1764.t33 34.3755
R13186 a_4187_1764.n0 a_4187_1764.t162 33.0005
R13187 a_4187_1764.n1 a_4187_1764.t161 33.0005
R13188 a_4187_1764.n2 a_4187_1764.t160 33.0005
R13189 a_4187_1764.n3 a_4187_1764.t159 33.0005
R13190 a_4187_1764.n4 a_4187_1764.t158 33.0005
R13191 a_4187_1764.n5 a_4187_1764.t157 33.0005
R13192 a_4187_1764.n6 a_4187_1764.t156 33.0005
R13193 a_4187_1764.n7 a_4187_1764.t155 33.0005
R13194 a_4187_1764.n8 a_4187_1764.t154 33.0005
R13195 a_4187_1764.n9 a_4187_1764.t153 33.0005
R13196 a_4187_1764.n10 a_4187_1764.t152 33.0005
R13197 a_4187_1764.n11 a_4187_1764.t151 33.0005
R13198 a_4187_1764.n12 a_4187_1764.t150 33.0005
R13199 a_4187_1764.n13 a_4187_1764.t149 33.0005
R13200 a_4187_1764.n14 a_4187_1764.t148 33.0005
R13201 a_4187_1764.n15 a_4187_1764.t147 33.0005
R13202 a_4187_1764.n16 a_4187_1764.t146 33.0005
R13203 a_4187_1764.n17 a_4187_1764.t145 33.0005
R13204 a_4187_1764.n18 a_4187_1764.t144 33.0005
R13205 a_4187_1764.n19 a_4187_1764.t143 33.0005
R13206 a_4187_1764.n20 a_4187_1764.t142 33.0005
R13207 a_4187_1764.n21 a_4187_1764.t141 33.0005
R13208 a_4187_1764.n22 a_4187_1764.t140 33.0005
R13209 a_4187_1764.n23 a_4187_1764.t139 33.0005
R13210 a_4187_1764.n24 a_4187_1764.t138 33.0005
R13211 a_4187_1764.n25 a_4187_1764.t137 33.0005
R13212 a_4187_1764.n26 a_4187_1764.t136 33.0005
R13213 a_4187_1764.n27 a_4187_1764.t135 33.0005
R13214 a_4187_1764.n28 a_4187_1764.t134 33.0005
R13215 a_4187_1764.n29 a_4187_1764.t133 33.0005
R13216 a_4187_1764.n30 a_4187_1764.t132 33.0005
R13217 a_4187_1764.n31 a_4187_1764.t130 33.0005
R13218 a_4187_1764.n32 a_4187_1764.t129 33.0005
R13219 a_4187_1764.n33 a_4187_1764.t128 33.0005
R13220 a_4187_1764.n34 a_4187_1764.t127 33.0005
R13221 a_4187_1764.n35 a_4187_1764.t126 33.0005
R13222 a_4187_1764.n36 a_4187_1764.t125 33.0005
R13223 a_4187_1764.n37 a_4187_1764.t124 33.0005
R13224 a_4187_1764.n38 a_4187_1764.t123 33.0005
R13225 a_4187_1764.n39 a_4187_1764.t122 33.0005
R13226 a_4187_1764.n40 a_4187_1764.t121 33.0005
R13227 a_4187_1764.n41 a_4187_1764.t120 33.0005
R13228 a_4187_1764.n42 a_4187_1764.t119 33.0005
R13229 a_4187_1764.n43 a_4187_1764.t118 33.0005
R13230 a_4187_1764.n44 a_4187_1764.t117 33.0005
R13231 a_4187_1764.n45 a_4187_1764.t116 33.0005
R13232 a_4187_1764.n46 a_4187_1764.t115 33.0005
R13233 a_4187_1764.n47 a_4187_1764.t114 33.0005
R13234 a_4187_1764.n48 a_4187_1764.t113 33.0005
R13235 a_4187_1764.n49 a_4187_1764.t112 33.0005
R13236 a_4187_1764.n50 a_4187_1764.t111 33.0005
R13237 a_4187_1764.n51 a_4187_1764.t110 33.0005
R13238 a_4187_1764.n52 a_4187_1764.t109 33.0005
R13239 a_4187_1764.n53 a_4187_1764.t108 33.0005
R13240 a_4187_1764.n54 a_4187_1764.t107 33.0005
R13241 a_4187_1764.n55 a_4187_1764.t106 33.0005
R13242 a_4187_1764.n56 a_4187_1764.t105 33.0005
R13243 a_4187_1764.n57 a_4187_1764.t104 33.0005
R13244 a_4187_1764.n58 a_4187_1764.t103 33.0005
R13245 a_4187_1764.n59 a_4187_1764.t102 33.0005
R13246 a_4187_1764.n60 a_4187_1764.t101 33.0005
R13247 a_4187_1764.n61 a_4187_1764.t100 33.0005
R13248 a_4187_1764.n126 a_4187_1764.t96 33.0005
R13249 a_4187_1764.n127 a_4187_1764.t95 33.0005
R13250 a_4187_1764.n128 a_4187_1764.t94 33.0005
R13251 a_4187_1764.n129 a_4187_1764.t93 33.0005
R13252 a_4187_1764.n130 a_4187_1764.t92 33.0005
R13253 a_4187_1764.n131 a_4187_1764.t91 33.0005
R13254 a_4187_1764.n132 a_4187_1764.t90 33.0005
R13255 a_4187_1764.n133 a_4187_1764.t89 33.0005
R13256 a_4187_1764.n134 a_4187_1764.t88 33.0005
R13257 a_4187_1764.n135 a_4187_1764.t87 33.0005
R13258 a_4187_1764.n136 a_4187_1764.t86 33.0005
R13259 a_4187_1764.n137 a_4187_1764.t85 33.0005
R13260 a_4187_1764.n138 a_4187_1764.t84 33.0005
R13261 a_4187_1764.n139 a_4187_1764.t83 33.0005
R13262 a_4187_1764.n140 a_4187_1764.t82 33.0005
R13263 a_4187_1764.n141 a_4187_1764.t81 33.0005
R13264 a_4187_1764.n142 a_4187_1764.t80 33.0005
R13265 a_4187_1764.n143 a_4187_1764.t79 33.0005
R13266 a_4187_1764.n144 a_4187_1764.t78 33.0005
R13267 a_4187_1764.n145 a_4187_1764.t77 33.0005
R13268 a_4187_1764.n146 a_4187_1764.t76 33.0005
R13269 a_4187_1764.n147 a_4187_1764.t75 33.0005
R13270 a_4187_1764.n148 a_4187_1764.t74 33.0005
R13271 a_4187_1764.n149 a_4187_1764.t73 33.0005
R13272 a_4187_1764.n150 a_4187_1764.t72 33.0005
R13273 a_4187_1764.n151 a_4187_1764.t71 33.0005
R13274 a_4187_1764.n152 a_4187_1764.t70 33.0005
R13275 a_4187_1764.n153 a_4187_1764.t69 33.0005
R13276 a_4187_1764.n154 a_4187_1764.t68 33.0005
R13277 a_4187_1764.n155 a_4187_1764.t67 33.0005
R13278 a_4187_1764.n156 a_4187_1764.t66 33.0005
R13279 a_4187_1764.n94 a_4187_1764.t64 33.0005
R13280 a_4187_1764.n95 a_4187_1764.t63 33.0005
R13281 a_4187_1764.n96 a_4187_1764.t62 33.0005
R13282 a_4187_1764.n97 a_4187_1764.t61 33.0005
R13283 a_4187_1764.n98 a_4187_1764.t60 33.0005
R13284 a_4187_1764.n99 a_4187_1764.t59 33.0005
R13285 a_4187_1764.n100 a_4187_1764.t58 33.0005
R13286 a_4187_1764.n101 a_4187_1764.t57 33.0005
R13287 a_4187_1764.n102 a_4187_1764.t56 33.0005
R13288 a_4187_1764.n103 a_4187_1764.t55 33.0005
R13289 a_4187_1764.n104 a_4187_1764.t54 33.0005
R13290 a_4187_1764.n105 a_4187_1764.t53 33.0005
R13291 a_4187_1764.n106 a_4187_1764.t52 33.0005
R13292 a_4187_1764.n107 a_4187_1764.t51 33.0005
R13293 a_4187_1764.n108 a_4187_1764.t50 33.0005
R13294 a_4187_1764.n109 a_4187_1764.t49 33.0005
R13295 a_4187_1764.n110 a_4187_1764.t48 33.0005
R13296 a_4187_1764.n111 a_4187_1764.t47 33.0005
R13297 a_4187_1764.n112 a_4187_1764.t46 33.0005
R13298 a_4187_1764.n113 a_4187_1764.t45 33.0005
R13299 a_4187_1764.n114 a_4187_1764.t44 33.0005
R13300 a_4187_1764.n115 a_4187_1764.t43 33.0005
R13301 a_4187_1764.n116 a_4187_1764.t42 33.0005
R13302 a_4187_1764.n117 a_4187_1764.t41 33.0005
R13303 a_4187_1764.n118 a_4187_1764.t40 33.0005
R13304 a_4187_1764.n119 a_4187_1764.t39 33.0005
R13305 a_4187_1764.n120 a_4187_1764.t38 33.0005
R13306 a_4187_1764.n121 a_4187_1764.t37 33.0005
R13307 a_4187_1764.n122 a_4187_1764.t36 33.0005
R13308 a_4187_1764.n123 a_4187_1764.t35 33.0005
R13309 a_4187_1764.n124 a_4187_1764.t34 33.0005
R13310 a_4187_1764.n63 a_4187_1764.t32 33.0005
R13311 a_4187_1764.n64 a_4187_1764.t31 33.0005
R13312 a_4187_1764.n65 a_4187_1764.t30 33.0005
R13313 a_4187_1764.n66 a_4187_1764.t29 33.0005
R13314 a_4187_1764.n67 a_4187_1764.t28 33.0005
R13315 a_4187_1764.n68 a_4187_1764.t27 33.0005
R13316 a_4187_1764.n69 a_4187_1764.t26 33.0005
R13317 a_4187_1764.n70 a_4187_1764.t25 33.0005
R13318 a_4187_1764.n71 a_4187_1764.t24 33.0005
R13319 a_4187_1764.n72 a_4187_1764.t23 33.0005
R13320 a_4187_1764.n73 a_4187_1764.t22 33.0005
R13321 a_4187_1764.n74 a_4187_1764.t21 33.0005
R13322 a_4187_1764.n75 a_4187_1764.t20 33.0005
R13323 a_4187_1764.n76 a_4187_1764.t19 33.0005
R13324 a_4187_1764.n77 a_4187_1764.t18 33.0005
R13325 a_4187_1764.n78 a_4187_1764.t17 33.0005
R13326 a_4187_1764.n79 a_4187_1764.t16 33.0005
R13327 a_4187_1764.n80 a_4187_1764.t15 33.0005
R13328 a_4187_1764.n81 a_4187_1764.t14 33.0005
R13329 a_4187_1764.n82 a_4187_1764.t13 33.0005
R13330 a_4187_1764.n83 a_4187_1764.t12 33.0005
R13331 a_4187_1764.n84 a_4187_1764.t11 33.0005
R13332 a_4187_1764.n85 a_4187_1764.t10 33.0005
R13333 a_4187_1764.n86 a_4187_1764.t9 33.0005
R13334 a_4187_1764.n87 a_4187_1764.t8 33.0005
R13335 a_4187_1764.n88 a_4187_1764.t7 33.0005
R13336 a_4187_1764.n89 a_4187_1764.t6 33.0005
R13337 a_4187_1764.n90 a_4187_1764.t5 33.0005
R13338 a_4187_1764.n91 a_4187_1764.t4 33.0005
R13339 a_4187_1764.n92 a_4187_1764.t3 33.0005
R13340 a_4187_1764.n93 a_4187_1764.t2 33.0005
R13341 a_4187_1764.n159 a_4187_1764.t99 25.0885
R13342 a_4187_1764.n125 a_4187_1764.n93 15.1797
R13343 a_4187_1764.n62 a_4187_1764.n30 15.1797
R13344 a_4187_1764.n158 a_4187_1764.t98 11.19
R13345 a_4187_1764.t0 a_4187_1764.n160 13.9108
R13346 a_4187_1764.n160 a_4187_1764.t1 12.9887
R13347 a_4187_1764.n62 a_4187_1764.n61 10.8632
R13348 a_4187_1764.n157 a_4187_1764.n156 10.8632
R13349 a_4187_1764.n125 a_4187_1764.n124 10.8632
R13350 a_4187_1764.n158 a_4187_1764.n62 5.26657
R13351 a_4187_1764.n158 a_4187_1764.n157 4.58443
R13352 a_4187_1764.n157 a_4187_1764.n125 4.31705
R13353 a_4187_1764.n30 a_4187_1764.n29 1.3755
R13354 a_4187_1764.n29 a_4187_1764.n28 1.3755
R13355 a_4187_1764.n28 a_4187_1764.n27 1.3755
R13356 a_4187_1764.n27 a_4187_1764.n26 1.3755
R13357 a_4187_1764.n26 a_4187_1764.n25 1.3755
R13358 a_4187_1764.n25 a_4187_1764.n24 1.3755
R13359 a_4187_1764.n24 a_4187_1764.n23 1.3755
R13360 a_4187_1764.n23 a_4187_1764.n22 1.3755
R13361 a_4187_1764.n22 a_4187_1764.n21 1.3755
R13362 a_4187_1764.n21 a_4187_1764.n20 1.3755
R13363 a_4187_1764.n20 a_4187_1764.n19 1.3755
R13364 a_4187_1764.n19 a_4187_1764.n18 1.3755
R13365 a_4187_1764.n18 a_4187_1764.n17 1.3755
R13366 a_4187_1764.n17 a_4187_1764.n16 1.3755
R13367 a_4187_1764.n16 a_4187_1764.n15 1.3755
R13368 a_4187_1764.n15 a_4187_1764.n14 1.3755
R13369 a_4187_1764.n14 a_4187_1764.n13 1.3755
R13370 a_4187_1764.n13 a_4187_1764.n12 1.3755
R13371 a_4187_1764.n12 a_4187_1764.n11 1.3755
R13372 a_4187_1764.n11 a_4187_1764.n10 1.3755
R13373 a_4187_1764.n10 a_4187_1764.n9 1.3755
R13374 a_4187_1764.n9 a_4187_1764.n8 1.3755
R13375 a_4187_1764.n8 a_4187_1764.n7 1.3755
R13376 a_4187_1764.n7 a_4187_1764.n6 1.3755
R13377 a_4187_1764.n6 a_4187_1764.n5 1.3755
R13378 a_4187_1764.n5 a_4187_1764.n4 1.3755
R13379 a_4187_1764.n4 a_4187_1764.n3 1.3755
R13380 a_4187_1764.n3 a_4187_1764.n2 1.3755
R13381 a_4187_1764.n2 a_4187_1764.n1 1.3755
R13382 a_4187_1764.n1 a_4187_1764.n0 1.3755
R13383 a_4187_1764.n61 a_4187_1764.n60 1.3755
R13384 a_4187_1764.n60 a_4187_1764.n59 1.3755
R13385 a_4187_1764.n59 a_4187_1764.n58 1.3755
R13386 a_4187_1764.n58 a_4187_1764.n57 1.3755
R13387 a_4187_1764.n57 a_4187_1764.n56 1.3755
R13388 a_4187_1764.n56 a_4187_1764.n55 1.3755
R13389 a_4187_1764.n55 a_4187_1764.n54 1.3755
R13390 a_4187_1764.n54 a_4187_1764.n53 1.3755
R13391 a_4187_1764.n53 a_4187_1764.n52 1.3755
R13392 a_4187_1764.n52 a_4187_1764.n51 1.3755
R13393 a_4187_1764.n51 a_4187_1764.n50 1.3755
R13394 a_4187_1764.n50 a_4187_1764.n49 1.3755
R13395 a_4187_1764.n49 a_4187_1764.n48 1.3755
R13396 a_4187_1764.n48 a_4187_1764.n47 1.3755
R13397 a_4187_1764.n47 a_4187_1764.n46 1.3755
R13398 a_4187_1764.n46 a_4187_1764.n45 1.3755
R13399 a_4187_1764.n45 a_4187_1764.n44 1.3755
R13400 a_4187_1764.n44 a_4187_1764.n43 1.3755
R13401 a_4187_1764.n43 a_4187_1764.n42 1.3755
R13402 a_4187_1764.n42 a_4187_1764.n41 1.3755
R13403 a_4187_1764.n41 a_4187_1764.n40 1.3755
R13404 a_4187_1764.n40 a_4187_1764.n39 1.3755
R13405 a_4187_1764.n39 a_4187_1764.n38 1.3755
R13406 a_4187_1764.n38 a_4187_1764.n37 1.3755
R13407 a_4187_1764.n37 a_4187_1764.n36 1.3755
R13408 a_4187_1764.n36 a_4187_1764.n35 1.3755
R13409 a_4187_1764.n35 a_4187_1764.n34 1.3755
R13410 a_4187_1764.n34 a_4187_1764.n33 1.3755
R13411 a_4187_1764.n33 a_4187_1764.n32 1.3755
R13412 a_4187_1764.n32 a_4187_1764.n31 1.3755
R13413 a_4187_1764.n156 a_4187_1764.n155 1.3755
R13414 a_4187_1764.n155 a_4187_1764.n154 1.3755
R13415 a_4187_1764.n154 a_4187_1764.n153 1.3755
R13416 a_4187_1764.n153 a_4187_1764.n152 1.3755
R13417 a_4187_1764.n152 a_4187_1764.n151 1.3755
R13418 a_4187_1764.n151 a_4187_1764.n150 1.3755
R13419 a_4187_1764.n150 a_4187_1764.n149 1.3755
R13420 a_4187_1764.n149 a_4187_1764.n148 1.3755
R13421 a_4187_1764.n148 a_4187_1764.n147 1.3755
R13422 a_4187_1764.n147 a_4187_1764.n146 1.3755
R13423 a_4187_1764.n146 a_4187_1764.n145 1.3755
R13424 a_4187_1764.n145 a_4187_1764.n144 1.3755
R13425 a_4187_1764.n144 a_4187_1764.n143 1.3755
R13426 a_4187_1764.n143 a_4187_1764.n142 1.3755
R13427 a_4187_1764.n142 a_4187_1764.n141 1.3755
R13428 a_4187_1764.n141 a_4187_1764.n140 1.3755
R13429 a_4187_1764.n140 a_4187_1764.n139 1.3755
R13430 a_4187_1764.n139 a_4187_1764.n138 1.3755
R13431 a_4187_1764.n138 a_4187_1764.n137 1.3755
R13432 a_4187_1764.n137 a_4187_1764.n136 1.3755
R13433 a_4187_1764.n136 a_4187_1764.n135 1.3755
R13434 a_4187_1764.n135 a_4187_1764.n134 1.3755
R13435 a_4187_1764.n134 a_4187_1764.n133 1.3755
R13436 a_4187_1764.n133 a_4187_1764.n132 1.3755
R13437 a_4187_1764.n132 a_4187_1764.n131 1.3755
R13438 a_4187_1764.n131 a_4187_1764.n130 1.3755
R13439 a_4187_1764.n130 a_4187_1764.n129 1.3755
R13440 a_4187_1764.n129 a_4187_1764.n128 1.3755
R13441 a_4187_1764.n128 a_4187_1764.n127 1.3755
R13442 a_4187_1764.n127 a_4187_1764.n126 1.3755
R13443 a_4187_1764.n124 a_4187_1764.n123 1.3755
R13444 a_4187_1764.n123 a_4187_1764.n122 1.3755
R13445 a_4187_1764.n122 a_4187_1764.n121 1.3755
R13446 a_4187_1764.n121 a_4187_1764.n120 1.3755
R13447 a_4187_1764.n120 a_4187_1764.n119 1.3755
R13448 a_4187_1764.n119 a_4187_1764.n118 1.3755
R13449 a_4187_1764.n118 a_4187_1764.n117 1.3755
R13450 a_4187_1764.n117 a_4187_1764.n116 1.3755
R13451 a_4187_1764.n116 a_4187_1764.n115 1.3755
R13452 a_4187_1764.n115 a_4187_1764.n114 1.3755
R13453 a_4187_1764.n114 a_4187_1764.n113 1.3755
R13454 a_4187_1764.n113 a_4187_1764.n112 1.3755
R13455 a_4187_1764.n112 a_4187_1764.n111 1.3755
R13456 a_4187_1764.n111 a_4187_1764.n110 1.3755
R13457 a_4187_1764.n110 a_4187_1764.n109 1.3755
R13458 a_4187_1764.n109 a_4187_1764.n108 1.3755
R13459 a_4187_1764.n108 a_4187_1764.n107 1.3755
R13460 a_4187_1764.n107 a_4187_1764.n106 1.3755
R13461 a_4187_1764.n106 a_4187_1764.n105 1.3755
R13462 a_4187_1764.n105 a_4187_1764.n104 1.3755
R13463 a_4187_1764.n104 a_4187_1764.n103 1.3755
R13464 a_4187_1764.n103 a_4187_1764.n102 1.3755
R13465 a_4187_1764.n102 a_4187_1764.n101 1.3755
R13466 a_4187_1764.n101 a_4187_1764.n100 1.3755
R13467 a_4187_1764.n100 a_4187_1764.n99 1.3755
R13468 a_4187_1764.n99 a_4187_1764.n98 1.3755
R13469 a_4187_1764.n98 a_4187_1764.n97 1.3755
R13470 a_4187_1764.n97 a_4187_1764.n96 1.3755
R13471 a_4187_1764.n96 a_4187_1764.n95 1.3755
R13472 a_4187_1764.n95 a_4187_1764.n94 1.3755
R13473 a_4187_1764.n93 a_4187_1764.n92 1.3755
R13474 a_4187_1764.n92 a_4187_1764.n91 1.3755
R13475 a_4187_1764.n91 a_4187_1764.n90 1.3755
R13476 a_4187_1764.n90 a_4187_1764.n89 1.3755
R13477 a_4187_1764.n89 a_4187_1764.n88 1.3755
R13478 a_4187_1764.n88 a_4187_1764.n87 1.3755
R13479 a_4187_1764.n87 a_4187_1764.n86 1.3755
R13480 a_4187_1764.n86 a_4187_1764.n85 1.3755
R13481 a_4187_1764.n85 a_4187_1764.n84 1.3755
R13482 a_4187_1764.n84 a_4187_1764.n83 1.3755
R13483 a_4187_1764.n83 a_4187_1764.n82 1.3755
R13484 a_4187_1764.n82 a_4187_1764.n81 1.3755
R13485 a_4187_1764.n81 a_4187_1764.n80 1.3755
R13486 a_4187_1764.n80 a_4187_1764.n79 1.3755
R13487 a_4187_1764.n79 a_4187_1764.n78 1.3755
R13488 a_4187_1764.n78 a_4187_1764.n77 1.3755
R13489 a_4187_1764.n77 a_4187_1764.n76 1.3755
R13490 a_4187_1764.n76 a_4187_1764.n75 1.3755
R13491 a_4187_1764.n75 a_4187_1764.n74 1.3755
R13492 a_4187_1764.n74 a_4187_1764.n73 1.3755
R13493 a_4187_1764.n73 a_4187_1764.n72 1.3755
R13494 a_4187_1764.n72 a_4187_1764.n71 1.3755
R13495 a_4187_1764.n71 a_4187_1764.n70 1.3755
R13496 a_4187_1764.n70 a_4187_1764.n69 1.3755
R13497 a_4187_1764.n69 a_4187_1764.n68 1.3755
R13498 a_4187_1764.n68 a_4187_1764.n67 1.3755
R13499 a_4187_1764.n67 a_4187_1764.n66 1.3755
R13500 a_4187_1764.n66 a_4187_1764.n65 1.3755
R13501 a_4187_1764.n65 a_4187_1764.n64 1.3755
R13502 a_4187_1764.n64 a_4187_1764.n63 1.3755
R13503 a_4187_1764.n160 a_4187_1764.n159 0.735818
R13504 a_4187_1764.n159 a_4187_1764.t98 7.58765
C5498 CHAN3_MUX_OUT VSS 3.18604f
C5499 CHAN3_MUX_SEL4 VSS 1.60879f
C5500 CHAN3_MUX_SEL3 VSS 0.90686f
C5501 CHAN3_MUX_SEL2 VSS 1.81137f
C5502 CHAN3_MUX_SEL1 VSS 0.94645f
C5503 CHAN3_MUX_SEL0 VSS 3.79169f
C5504 CHAN3_DELAY_OUT_LAST VSS 0.39276f
C5505 CHAN3_DELAY_IN VSS 1.72958f
C5506 CHAN2_MUX_OUT VSS 1.39088f
C5507 CHAN2_MUX_SEL4 VSS 1.40825f
C5508 CHAN2_MUX_SEL3 VSS 0.89148f
C5509 CHAN2_MUX_SEL2 VSS 1.41111f
C5510 CHAN2_MUX_SEL1 VSS 0.94625f
C5511 CHAN2_MUX_SEL0 VSS 1.52748f
C5512 CHAN2_DELAY_OUT_LAST VSS 0.38565f
C5513 CHAN2_DELAY_IN VSS 1.50373f
C5514 REF_MUX_OUT VSS 1.39387f
C5515 REF_MUX_SEL4 VSS 1.40825f
C5516 REF_MUX_SEL3 VSS 0.89138f
C5517 REF_MUX_SEL2 VSS 1.41085f
C5518 REF_MUX_SEL1 VSS 0.95075f
C5519 REF_MUX_SEL0 VSS 1.5515f
C5520 REF_DELAY_OUT_LAST VSS 2.82546f
C5521 REF_CLK VSS 3.04322f
C5522 DLL_RESETN VSS 4.11477f
C5523 CHAN1_MUX_OUT VSS 1.9842f
C5524 CHAN1_MUX_SEL4 VSS 1.59151f
C5525 CHAN1_MUX_SEL3 VSS 0.90273f
C5526 CHAN1_MUX_SEL2 VSS 1.7502f
C5527 CHAN1_MUX_SEL1 VSS 0.94625f
C5528 CHAN1_MUX_SEL0 VSS 1.52748f
C5529 CHAN1_DELAY_OUT_LAST VSS 0.38565f
C5530 CHAN1_DELAY_IN VSS 1.51141f
C5531 CHAN0_MUX_OUT VSS 1.39387f
C5532 CHAN0_MUX_SEL4 VSS 1.40825f
C5533 CHAN0_MUX_SEL3 VSS 0.89138f
C5534 CHAN0_MUX_SEL2 VSS 1.41085f
C5535 CHAN0_MUX_SEL1 VSS 0.95076f
C5536 CHAN0_MUX_SEL0 VSS 1.55166f
C5537 CHAN0_DELAY_OUT_LAST VSS 0.39284f
C5538 CHAN0_DELAY_IN VSS 1.91187f
C5539 VDD VSS 0.27453p
C5540 a_26985_519# VSS 0.17928f ; **FLOATING
C5541 a_23945_519# VSS 0.17928f ; **FLOATING
C5542 a_20905_519# VSS 0.17928f ; **FLOATING
C5543 a_17865_519# VSS 0.17593f ; **FLOATING
C5544 a_16851_309# VSS 0.38699f ; **FLOATING
C5545 a_16108_289# VSS 3.85111f ; **FLOATING
C5546 a_15964_289# VSS 0.17629f ; **FLOATING
C5547 a_15765_463# VSS 0.36132f ; **FLOATING
C5548 a_14825_519# VSS 0.17928f ; **FLOATING
C5549 a_11785_519# VSS 0.17928f ; **FLOATING
C5550 a_8745_519# VSS 0.17928f ; **FLOATING
C5551 a_5731_289# VSS 3.39133f ; **FLOATING
C5552 a_5705_519# VSS 0.17638f ; **FLOATING
C5553 a_3449_331# VSS 0.18478f ; **FLOATING
C5554 a_2873_331# VSS 0.18321f ; **FLOATING
C5555 a_2297_331# VSS 0.18321f ; **FLOATING
C5556 a_1721_331# VSS 0.17001f ; **FLOATING
C5557 a_1544_289# VSS 0.30014f ; **FLOATING
C5558 a_1256_289# VSS 0.84266f ; **FLOATING
C5559 a_27991_1008# VSS 0.19199f ; **FLOATING
C5560 a_27915_1044# VSS 0.11348f ; **FLOATING
C5561 a_27124_1008# VSS 0.18203f ; **FLOATING
C5562 a_27048_1044# VSS 0.12436f ; **FLOATING
C5563 a_26471_1008# VSS 0.18345f ; **FLOATING
C5564 a_26395_1044# VSS 0.1129f ; **FLOATING
C5565 a_25604_1008# VSS 0.18141f ; **FLOATING
C5566 a_25630_1044# VSS 0.3539f ; **FLOATING
C5567 a_25528_1044# VSS 0.12489f ; **FLOATING
C5568 a_24951_1008# VSS 0.18359f ; **FLOATING
C5569 a_24875_1044# VSS 0.11072f ; **FLOATING
C5570 a_24084_1008# VSS 0.17902f ; **FLOATING
C5571 a_24008_1044# VSS 0.12178f ; **FLOATING
C5572 a_23431_1008# VSS 0.18198f ; **FLOATING
C5573 a_23355_1044# VSS 0.11129f ; **FLOATING
C5574 a_22564_1008# VSS 0.18141f ; **FLOATING
C5575 a_22590_1044# VSS 0.33743f ; **FLOATING
C5576 a_22488_1044# VSS 0.12489f ; **FLOATING
C5577 a_21911_1008# VSS 0.18359f ; **FLOATING
C5578 a_21835_1044# VSS 0.11072f ; **FLOATING
C5579 a_21044_1008# VSS 0.17902f ; **FLOATING
C5580 a_20968_1044# VSS 0.12178f ; **FLOATING
C5581 a_20391_1008# VSS 0.18198f ; **FLOATING
C5582 a_20315_1044# VSS 0.11129f ; **FLOATING
C5583 a_19524_1008# VSS 0.18141f ; **FLOATING
C5584 a_19550_1044# VSS 0.33992f ; **FLOATING
C5585 a_19448_1044# VSS 0.12489f ; **FLOATING
C5586 a_18871_1008# VSS 0.18359f ; **FLOATING
C5587 a_18795_1044# VSS 0.11072f ; **FLOATING
C5588 a_18004_1008# VSS 0.17902f ; **FLOATING
C5589 a_17928_1044# VSS 0.12178f ; **FLOATING
C5590 a_17351_1008# VSS 0.18046f ; **FLOATING
C5591 a_17275_1044# VSS 0.10982f ; **FLOATING
C5592 a_16484_1008# VSS 0.18077f ; **FLOATING
C5593 a_16510_1044# VSS 0.29364f ; **FLOATING
C5594 a_16408_1044# VSS 0.12346f ; **FLOATING
C5595 a_15831_1008# VSS 0.1787f ; **FLOATING
C5596 a_15755_1044# VSS 0.10982f ; **FLOATING
C5597 a_14964_1008# VSS 0.17902f ; **FLOATING
C5598 a_14888_1044# VSS 0.12178f ; **FLOATING
C5599 a_14311_1008# VSS 0.18198f ; **FLOATING
C5600 a_14235_1044# VSS 0.11129f ; **FLOATING
C5601 a_13444_1008# VSS 0.18141f ; **FLOATING
C5602 a_13470_1044# VSS 0.30762f ; **FLOATING
C5603 a_13368_1044# VSS 0.12489f ; **FLOATING
C5604 a_12791_1008# VSS 0.18359f ; **FLOATING
C5605 a_12715_1044# VSS 0.11072f ; **FLOATING
C5606 a_11924_1008# VSS 0.17902f ; **FLOATING
C5607 a_11848_1044# VSS 0.12178f ; **FLOATING
C5608 a_11271_1008# VSS 0.18198f ; **FLOATING
C5609 a_11195_1044# VSS 0.11129f ; **FLOATING
C5610 a_10404_1008# VSS 0.18141f ; **FLOATING
C5611 a_10430_1044# VSS 0.32095f ; **FLOATING
C5612 a_10328_1044# VSS 0.12489f ; **FLOATING
C5613 a_9751_1008# VSS 0.18359f ; **FLOATING
C5614 a_9675_1044# VSS 0.11072f ; **FLOATING
C5615 a_8884_1008# VSS 0.17902f ; **FLOATING
C5616 a_8808_1044# VSS 0.12178f ; **FLOATING
C5617 a_8231_1008# VSS 0.18198f ; **FLOATING
C5618 a_8155_1044# VSS 0.11129f ; **FLOATING
C5619 a_7364_1008# VSS 0.18141f ; **FLOATING
C5620 a_7390_1044# VSS 0.31786f ; **FLOATING
C5621 a_7288_1044# VSS 0.12489f ; **FLOATING
C5622 a_6711_1008# VSS 0.18359f ; **FLOATING
C5623 a_6635_1044# VSS 0.11072f ; **FLOATING
C5624 a_5844_1008# VSS 0.17902f ; **FLOATING
C5625 a_5768_1044# VSS 0.12178f ; **FLOATING
C5626 a_5191_1008# VSS 0.18046f ; **FLOATING
C5627 a_5115_1044# VSS 0.10982f ; **FLOATING
C5628 a_4324_1008# VSS 0.18077f ; **FLOATING
C5629 a_4350_1044# VSS 0.27085f ; **FLOATING
C5630 a_4248_1044# VSS 0.12499f ; **FLOATING
C5631 a_27705_1044# VSS 0.25948f ; **FLOATING
C5632 a_26185_1044# VSS 0.23746f ; **FLOATING
C5633 a_24665_1044# VSS 0.25486f ; **FLOATING
C5634 a_23145_1044# VSS 0.23556f ; **FLOATING
C5635 a_21625_1044# VSS 0.25486f ; **FLOATING
C5636 a_20105_1044# VSS 0.23556f ; **FLOATING
C5637 a_18585_1044# VSS 0.25486f ; **FLOATING
C5638 a_17065_1044# VSS 0.23467f ; **FLOATING
C5639 a_15545_1044# VSS 0.25378f ; **FLOATING
C5640 a_14025_1044# VSS 0.23556f ; **FLOATING
C5641 a_12505_1044# VSS 0.25486f ; **FLOATING
C5642 a_10985_1044# VSS 0.23556f ; **FLOATING
C5643 a_9465_1044# VSS 0.25486f ; **FLOATING
C5644 a_7945_1044# VSS 0.23556f ; **FLOATING
C5645 a_6425_1044# VSS 0.25486f ; **FLOATING
C5646 a_4905_1044# VSS 0.2363f ; **FLOATING
C5647 a_4157_1313# VSS 0.32969f ; **FLOATING
C5648 a_3449_1395# VSS 0.1866f ; **FLOATING
C5649 a_2873_1395# VSS 0.18345f ; **FLOATING
C5650 a_2297_1395# VSS 0.18296f ; **FLOATING
C5651 a_1721_1395# VSS 0.16976f ; **FLOATING
C5652 a_1544_1044# VSS 0.29918f ; **FLOATING
C5653 a_1256_1044# VSS 0.83793f ; **FLOATING
C5654 a_27671_1842# VSS 0.01336f ; **FLOATING
C5655 a_26911_1842# VSS 0.01336f ; **FLOATING
C5656 a_26151_1842# VSS 0.01336f ; **FLOATING
C5657 a_25391_1842# VSS 0.01336f ; **FLOATING
C5658 a_24631_1842# VSS 0.01336f ; **FLOATING
C5659 a_23871_1842# VSS 0.01336f ; **FLOATING
C5660 a_23111_1842# VSS 0.01336f ; **FLOATING
C5661 a_22351_1842# VSS 0.01336f ; **FLOATING
C5662 a_21591_1842# VSS 0.01336f ; **FLOATING
C5663 a_20831_1842# VSS 0.01336f ; **FLOATING
C5664 a_20071_1842# VSS 0.01336f ; **FLOATING
C5665 a_19311_1842# VSS 0.01336f ; **FLOATING
C5666 a_18551_1842# VSS 0.01336f ; **FLOATING
C5667 a_17791_1842# VSS 0.01336f ; **FLOATING
C5668 a_17031_1842# VSS 0.01336f ; **FLOATING
C5669 a_16271_1842# VSS 0.01336f ; **FLOATING
C5670 a_15511_1842# VSS 0.01336f ; **FLOATING
C5671 a_14751_1842# VSS 0.01336f ; **FLOATING
C5672 a_13991_1842# VSS 0.01336f ; **FLOATING
C5673 a_13231_1842# VSS 0.01336f ; **FLOATING
C5674 a_12471_1842# VSS 0.01336f ; **FLOATING
C5675 a_11711_1842# VSS 0.01336f ; **FLOATING
C5676 a_10951_1842# VSS 0.01336f ; **FLOATING
C5677 a_10191_1842# VSS 0.01336f ; **FLOATING
C5678 a_9431_1842# VSS 0.01336f ; **FLOATING
C5679 a_8671_1842# VSS 0.01336f ; **FLOATING
C5680 a_7911_1842# VSS 0.01336f ; **FLOATING
C5681 a_7151_1842# VSS 0.01336f ; **FLOATING
C5682 a_6391_1842# VSS 0.01336f ; **FLOATING
C5683 a_5631_1842# VSS 0.01336f ; **FLOATING
C5684 a_4871_1842# VSS 0.01336f ; **FLOATING
C5685 a_4111_1842# VSS 0.0139f ; **FLOATING
C5686 a_27563_1842# VSS 0.49584f ; **FLOATING
C5687 a_27997_1842# VSS 0.647f ; **FLOATING
C5688 a_27433_1842# VSS 0.44853f ; **FLOATING
C5689 a_26803_1842# VSS 0.48882f ; **FLOATING
C5690 a_27237_1842# VSS 0.9864f ; **FLOATING
C5691 a_26673_1842# VSS 0.45065f ; **FLOATING
C5692 a_26043_1842# VSS 0.48986f ; **FLOATING
C5693 a_26477_1842# VSS 1.01987f ; **FLOATING
C5694 a_25913_1842# VSS 0.45336f ; **FLOATING
C5695 a_25283_1842# VSS 0.48776f ; **FLOATING
C5696 a_25717_1842# VSS 0.89652f ; **FLOATING
C5697 a_25153_1842# VSS 0.45131f ; **FLOATING
C5698 a_24523_1842# VSS 0.48956f ; **FLOATING
C5699 a_24957_1842# VSS 1.01947f ; **FLOATING
C5700 a_24393_1842# VSS 0.44853f ; **FLOATING
C5701 a_23763_1842# VSS 0.48882f ; **FLOATING
C5702 a_24197_1842# VSS 0.97668f ; **FLOATING
C5703 a_23633_1842# VSS 0.45065f ; **FLOATING
C5704 a_23003_1842# VSS 0.48986f ; **FLOATING
C5705 a_23437_1842# VSS 1.01565f ; **FLOATING
C5706 a_22873_1842# VSS 0.45336f ; **FLOATING
C5707 a_22243_1842# VSS 0.48776f ; **FLOATING
C5708 a_22677_1842# VSS 0.89612f ; **FLOATING
C5709 a_22113_1842# VSS 0.45131f ; **FLOATING
C5710 a_21483_1842# VSS 0.48956f ; **FLOATING
C5711 a_21917_1842# VSS 1.01947f ; **FLOATING
C5712 a_21353_1842# VSS 0.44853f ; **FLOATING
C5713 a_20723_1842# VSS 0.48882f ; **FLOATING
C5714 a_21157_1842# VSS 0.97668f ; **FLOATING
C5715 a_20593_1842# VSS 0.45065f ; **FLOATING
C5716 a_19963_1842# VSS 0.48986f ; **FLOATING
C5717 a_20397_1842# VSS 1.01565f ; **FLOATING
C5718 a_19833_1842# VSS 0.45336f ; **FLOATING
C5719 a_19203_1842# VSS 0.48776f ; **FLOATING
C5720 a_19637_1842# VSS 0.89612f ; **FLOATING
C5721 a_19073_1842# VSS 0.45131f ; **FLOATING
C5722 a_18443_1842# VSS 0.48956f ; **FLOATING
C5723 a_18877_1842# VSS 1.01947f ; **FLOATING
C5724 a_18313_1842# VSS 0.44776f ; **FLOATING
C5725 a_17683_1842# VSS 0.48882f ; **FLOATING
C5726 a_18117_1842# VSS 0.97388f ; **FLOATING
C5727 a_17553_1842# VSS 0.45065f ; **FLOATING
C5728 a_16923_1842# VSS 0.49202f ; **FLOATING
C5729 a_17357_1842# VSS 1.01647f ; **FLOATING
C5730 a_16793_1842# VSS 0.45164f ; **FLOATING
C5731 a_16163_1842# VSS 0.49004f ; **FLOATING
C5732 a_16597_1842# VSS 0.89263f ; **FLOATING
C5733 a_16033_1842# VSS 0.44397f ; **FLOATING
C5734 a_15403_1842# VSS 0.49121f ; **FLOATING
C5735 a_15837_1842# VSS 1.01134f ; **FLOATING
C5736 a_15273_1842# VSS 0.44853f ; **FLOATING
C5737 a_14643_1842# VSS 0.48882f ; **FLOATING
C5738 a_15077_1842# VSS 0.97555f ; **FLOATING
C5739 a_14513_1842# VSS 0.45065f ; **FLOATING
C5740 a_13883_1842# VSS 0.48986f ; **FLOATING
C5741 a_14317_1842# VSS 1.01565f ; **FLOATING
C5742 a_13753_1842# VSS 0.45336f ; **FLOATING
C5743 a_13123_1842# VSS 0.48775f ; **FLOATING
C5744 a_13557_1842# VSS 0.89612f ; **FLOATING
C5745 a_12993_1842# VSS 0.45131f ; **FLOATING
C5746 a_12363_1842# VSS 0.48956f ; **FLOATING
C5747 a_12797_1842# VSS 1.0178f ; **FLOATING
C5748 a_12233_1842# VSS 0.44853f ; **FLOATING
C5749 a_11603_1842# VSS 0.48882f ; **FLOATING
C5750 a_12037_1842# VSS 0.97668f ; **FLOATING
C5751 a_11473_1842# VSS 0.45065f ; **FLOATING
C5752 a_10843_1842# VSS 0.48986f ; **FLOATING
C5753 a_11277_1842# VSS 1.01565f ; **FLOATING
C5754 a_10713_1842# VSS 0.45336f ; **FLOATING
C5755 a_10083_1842# VSS 0.48775f ; **FLOATING
C5756 a_10517_1842# VSS 0.89612f ; **FLOATING
C5757 a_9953_1842# VSS 0.45131f ; **FLOATING
C5758 a_9323_1842# VSS 0.48956f ; **FLOATING
C5759 a_9757_1842# VSS 1.0178f ; **FLOATING
C5760 a_9193_1842# VSS 0.44853f ; **FLOATING
C5761 a_8563_1842# VSS 0.48882f ; **FLOATING
C5762 a_8997_1842# VSS 0.97668f ; **FLOATING
C5763 a_8433_1842# VSS 0.45065f ; **FLOATING
C5764 a_7803_1842# VSS 0.48986f ; **FLOATING
C5765 a_8237_1842# VSS 1.01565f ; **FLOATING
C5766 a_7673_1842# VSS 0.45336f ; **FLOATING
C5767 a_7043_1842# VSS 0.48775f ; **FLOATING
C5768 a_7477_1842# VSS 0.89612f ; **FLOATING
C5769 a_6913_1842# VSS 0.45131f ; **FLOATING
C5770 a_6283_1842# VSS 0.48956f ; **FLOATING
C5771 a_6717_1842# VSS 1.01722f ; **FLOATING
C5772 a_6153_1842# VSS 0.44776f ; **FLOATING
C5773 a_5523_1842# VSS 0.48882f ; **FLOATING
C5774 a_5957_1842# VSS 0.97388f ; **FLOATING
C5775 a_5393_1842# VSS 0.45304f ; **FLOATING
C5776 a_4763_1842# VSS 0.49534f ; **FLOATING
C5777 a_5197_1842# VSS 1.01845f ; **FLOATING
C5778 a_4633_1842# VSS 0.45599f ; **FLOATING
C5779 a_4003_1842# VSS 0.57702f ; **FLOATING
C5780 a_4437_1842# VSS 0.89938f ; **FLOATING
C5781 a_26985_3364# VSS 0.17928f ; **FLOATING
C5782 a_23945_3364# VSS 0.17928f ; **FLOATING
C5783 a_20905_3364# VSS 0.17928f ; **FLOATING
C5784 a_17865_3364# VSS 0.17593f ; **FLOATING
C5785 a_16851_3154# VSS 0.37653f ; **FLOATING
C5786 a_16108_3134# VSS 2.47661f ; **FLOATING
C5787 a_15964_3134# VSS 0.17103f ; **FLOATING
C5788 a_15765_3308# VSS 0.33587f ; **FLOATING
C5789 a_14825_3364# VSS 0.17928f ; **FLOATING
C5790 a_11785_3364# VSS 0.17928f ; **FLOATING
C5791 a_8745_3364# VSS 0.17928f ; **FLOATING
C5792 a_5731_3134# VSS 2.14831f ; **FLOATING
C5793 a_5705_3364# VSS 0.17638f ; **FLOATING
C5794 a_3449_3176# VSS 0.17702f ; **FLOATING
C5795 a_2873_3176# VSS 0.1828f ; **FLOATING
C5796 a_2297_3176# VSS 0.1828f ; **FLOATING
C5797 a_1721_3176# VSS 0.1696f ; **FLOATING
C5798 a_1544_3134# VSS 0.29702f ; **FLOATING
C5799 a_1256_3134# VSS 0.81882f ; **FLOATING
C5800 a_27991_3853# VSS 0.18561f ; **FLOATING
C5801 a_27915_3889# VSS 0.10926f ; **FLOATING
C5802 a_27124_3853# VSS 0.17878f ; **FLOATING
C5803 a_27048_3889# VSS 0.12122f ; **FLOATING
C5804 a_26471_3853# VSS 0.18126f ; **FLOATING
C5805 a_26395_3889# VSS 0.11073f ; **FLOATING
C5806 a_25604_3853# VSS 0.18087f ; **FLOATING
C5807 a_25630_3889# VSS 0.32104f ; **FLOATING
C5808 a_25528_3889# VSS 0.12433f ; **FLOATING
C5809 a_24951_3853# VSS 0.18335f ; **FLOATING
C5810 a_24875_3889# VSS 0.11016f ; **FLOATING
C5811 a_24084_3853# VSS 0.17878f ; **FLOATING
C5812 a_24008_3889# VSS 0.12122f ; **FLOATING
C5813 a_23431_3853# VSS 0.18126f ; **FLOATING
C5814 a_23355_3889# VSS 0.11073f ; **FLOATING
C5815 a_22564_3853# VSS 0.18087f ; **FLOATING
C5816 a_22590_3889# VSS 0.33314f ; **FLOATING
C5817 a_22488_3889# VSS 0.12433f ; **FLOATING
C5818 a_21911_3853# VSS 0.18335f ; **FLOATING
C5819 a_21835_3889# VSS 0.11016f ; **FLOATING
C5820 a_21044_3853# VSS 0.17878f ; **FLOATING
C5821 a_20968_3889# VSS 0.12122f ; **FLOATING
C5822 a_20391_3853# VSS 0.18126f ; **FLOATING
C5823 a_20315_3889# VSS 0.11073f ; **FLOATING
C5824 a_19524_3853# VSS 0.18087f ; **FLOATING
C5825 a_19550_3889# VSS 0.33563f ; **FLOATING
C5826 a_19448_3889# VSS 0.12433f ; **FLOATING
C5827 a_18871_3853# VSS 0.18335f ; **FLOATING
C5828 a_18795_3889# VSS 0.11016f ; **FLOATING
C5829 a_18004_3853# VSS 0.17878f ; **FLOATING
C5830 a_17928_3889# VSS 0.12122f ; **FLOATING
C5831 a_17351_3853# VSS 0.17877f ; **FLOATING
C5832 a_17275_3889# VSS 0.10926f ; **FLOATING
C5833 a_16484_3853# VSS 0.17947f ; **FLOATING
C5834 a_16510_3889# VSS 0.28935f ; **FLOATING
C5835 a_16408_3889# VSS 0.1229f ; **FLOATING
C5836 a_15831_3853# VSS 0.17846f ; **FLOATING
C5837 a_15755_3889# VSS 0.10926f ; **FLOATING
C5838 a_14964_3853# VSS 0.17878f ; **FLOATING
C5839 a_14888_3889# VSS 0.12122f ; **FLOATING
C5840 a_14311_3853# VSS 0.18126f ; **FLOATING
C5841 a_14235_3889# VSS 0.11073f ; **FLOATING
C5842 a_13444_3853# VSS 0.18087f ; **FLOATING
C5843 a_13470_3889# VSS 0.30333f ; **FLOATING
C5844 a_13368_3889# VSS 0.12433f ; **FLOATING
C5845 a_12791_3853# VSS 0.18335f ; **FLOATING
C5846 a_12715_3889# VSS 0.11016f ; **FLOATING
C5847 a_11924_3853# VSS 0.17878f ; **FLOATING
C5848 a_11848_3889# VSS 0.12122f ; **FLOATING
C5849 a_11271_3853# VSS 0.18126f ; **FLOATING
C5850 a_11195_3889# VSS 0.11073f ; **FLOATING
C5851 a_10404_3853# VSS 0.18087f ; **FLOATING
C5852 a_10430_3889# VSS 0.31665f ; **FLOATING
C5853 a_10328_3889# VSS 0.12433f ; **FLOATING
C5854 a_9751_3853# VSS 0.18335f ; **FLOATING
C5855 a_9675_3889# VSS 0.11016f ; **FLOATING
C5856 a_8884_3853# VSS 0.17878f ; **FLOATING
C5857 a_8808_3889# VSS 0.12122f ; **FLOATING
C5858 a_8231_3853# VSS 0.18126f ; **FLOATING
C5859 a_8155_3889# VSS 0.11073f ; **FLOATING
C5860 a_7364_3853# VSS 0.18087f ; **FLOATING
C5861 a_7390_3889# VSS 0.31357f ; **FLOATING
C5862 a_7288_3889# VSS 0.12433f ; **FLOATING
C5863 a_6711_3853# VSS 0.18335f ; **FLOATING
C5864 a_6635_3889# VSS 0.11016f ; **FLOATING
C5865 a_5844_3853# VSS 0.17878f ; **FLOATING
C5866 a_5768_3889# VSS 0.12122f ; **FLOATING
C5867 a_5191_3853# VSS 0.17877f ; **FLOATING
C5868 a_5115_3889# VSS 0.10926f ; **FLOATING
C5869 a_4324_3853# VSS 0.17947f ; **FLOATING
C5870 a_4350_3889# VSS 0.26655f ; **FLOATING
C5871 a_4248_3889# VSS 0.12443f ; **FLOATING
C5872 a_27705_3889# VSS 0.25232f ; **FLOATING
C5873 a_26185_3889# VSS 0.23475f ; **FLOATING
C5874 a_24665_3889# VSS 0.25405f ; **FLOATING
C5875 a_23145_3889# VSS 0.23475f ; **FLOATING
C5876 a_21625_3889# VSS 0.25405f ; **FLOATING
C5877 a_20105_3889# VSS 0.23475f ; **FLOATING
C5878 a_18585_3889# VSS 0.25405f ; **FLOATING
C5879 a_17065_3889# VSS 0.23379f ; **FLOATING
C5880 a_15545_3889# VSS 0.25232f ; **FLOATING
C5881 a_14025_3889# VSS 0.23475f ; **FLOATING
C5882 a_12505_3889# VSS 0.25405f ; **FLOATING
C5883 a_10985_3889# VSS 0.23475f ; **FLOATING
C5884 a_9465_3889# VSS 0.25405f ; **FLOATING
C5885 a_7945_3889# VSS 0.23475f ; **FLOATING
C5886 a_6425_3889# VSS 0.25405f ; **FLOATING
C5887 a_4905_3889# VSS 0.23484f ; **FLOATING
C5888 a_4157_4158# VSS 0.32839f ; **FLOATING
C5889 a_3449_4240# VSS 0.18619f ; **FLOATING
C5890 a_2873_4240# VSS 0.18296f ; **FLOATING
C5891 a_2297_4240# VSS 0.18296f ; **FLOATING
C5892 a_1721_4240# VSS 0.16976f ; **FLOATING
C5893 a_1544_3889# VSS 0.29775f ; **FLOATING
C5894 a_1256_3889# VSS 0.82301f ; **FLOATING
C5895 a_27671_4687# VSS 0.01336f ; **FLOATING
C5896 a_26911_4687# VSS 0.01336f ; **FLOATING
C5897 a_26151_4687# VSS 0.01336f ; **FLOATING
C5898 a_25391_4687# VSS 0.01336f ; **FLOATING
C5899 a_24631_4687# VSS 0.01336f ; **FLOATING
C5900 a_23871_4687# VSS 0.01336f ; **FLOATING
C5901 a_23111_4687# VSS 0.01336f ; **FLOATING
C5902 a_22351_4687# VSS 0.01336f ; **FLOATING
C5903 a_21591_4687# VSS 0.01336f ; **FLOATING
C5904 a_20831_4687# VSS 0.01336f ; **FLOATING
C5905 a_20071_4687# VSS 0.01336f ; **FLOATING
C5906 a_19311_4687# VSS 0.01336f ; **FLOATING
C5907 a_18551_4687# VSS 0.01336f ; **FLOATING
C5908 a_17791_4687# VSS 0.01336f ; **FLOATING
C5909 a_17031_4687# VSS 0.01336f ; **FLOATING
C5910 a_16271_4687# VSS 0.01336f ; **FLOATING
C5911 a_15511_4687# VSS 0.01336f ; **FLOATING
C5912 a_14751_4687# VSS 0.01336f ; **FLOATING
C5913 a_13991_4687# VSS 0.01336f ; **FLOATING
C5914 a_13231_4687# VSS 0.01336f ; **FLOATING
C5915 a_12471_4687# VSS 0.01336f ; **FLOATING
C5916 a_11711_4687# VSS 0.01336f ; **FLOATING
C5917 a_10951_4687# VSS 0.01336f ; **FLOATING
C5918 a_10191_4687# VSS 0.01336f ; **FLOATING
C5919 a_9431_4687# VSS 0.01336f ; **FLOATING
C5920 a_8671_4687# VSS 0.01336f ; **FLOATING
C5921 a_7911_4687# VSS 0.01336f ; **FLOATING
C5922 a_7151_4687# VSS 0.01336f ; **FLOATING
C5923 a_6391_4687# VSS 0.01336f ; **FLOATING
C5924 a_5631_4687# VSS 0.01336f ; **FLOATING
C5925 a_4871_4687# VSS 0.01336f ; **FLOATING
C5926 a_4111_4687# VSS 0.0139f ; **FLOATING
C5927 a_27563_4687# VSS 0.49372f ; **FLOATING
C5928 a_27997_4687# VSS 0.64441f ; **FLOATING
C5929 a_27433_4687# VSS 0.44136f ; **FLOATING
C5930 a_26803_4687# VSS 0.48671f ; **FLOATING
C5931 a_27237_4687# VSS 0.92172f ; **FLOATING
C5932 a_26673_4687# VSS 0.44348f ; **FLOATING
C5933 a_26043_4687# VSS 0.48774f ; **FLOATING
C5934 a_26477_4687# VSS 0.95122f ; **FLOATING
C5935 a_25913_4687# VSS 0.44619f ; **FLOATING
C5936 a_25283_4687# VSS 0.48565f ; **FLOATING
C5937 a_25717_4687# VSS 0.86086f ; **FLOATING
C5938 a_25153_4687# VSS 0.44414f ; **FLOATING
C5939 a_24523_4687# VSS 0.48744f ; **FLOATING
C5940 a_24957_4687# VSS 0.95513f ; **FLOATING
C5941 a_24393_4687# VSS 0.44136f ; **FLOATING
C5942 a_23763_4687# VSS 0.48671f ; **FLOATING
C5943 a_24197_4687# VSS 0.91814f ; **FLOATING
C5944 a_23633_4687# VSS 0.44348f ; **FLOATING
C5945 a_23003_4687# VSS 0.48774f ; **FLOATING
C5946 a_23437_4687# VSS 0.95122f ; **FLOATING
C5947 a_22873_4687# VSS 0.44619f ; **FLOATING
C5948 a_22243_4687# VSS 0.48565f ; **FLOATING
C5949 a_22677_4687# VSS 0.86086f ; **FLOATING
C5950 a_22113_4687# VSS 0.44414f ; **FLOATING
C5951 a_21483_4687# VSS 0.48744f ; **FLOATING
C5952 a_21917_4687# VSS 0.95513f ; **FLOATING
C5953 a_21353_4687# VSS 0.44136f ; **FLOATING
C5954 a_20723_4687# VSS 0.48671f ; **FLOATING
C5955 a_21157_4687# VSS 0.91814f ; **FLOATING
C5956 a_20593_4687# VSS 0.44348f ; **FLOATING
C5957 a_19963_4687# VSS 0.48774f ; **FLOATING
C5958 a_20397_4687# VSS 0.95122f ; **FLOATING
C5959 a_19833_4687# VSS 0.44619f ; **FLOATING
C5960 a_19203_4687# VSS 0.48565f ; **FLOATING
C5961 a_19637_4687# VSS 0.86086f ; **FLOATING
C5962 a_19073_4687# VSS 0.44414f ; **FLOATING
C5963 a_18443_4687# VSS 0.48744f ; **FLOATING
C5964 a_18877_4687# VSS 0.95513f ; **FLOATING
C5965 a_18313_4687# VSS 0.44059f ; **FLOATING
C5966 a_17683_4687# VSS 0.48671f ; **FLOATING
C5967 a_18117_4687# VSS 0.91534f ; **FLOATING
C5968 a_17553_4687# VSS 0.44348f ; **FLOATING
C5969 a_16923_4687# VSS 0.4899f ; **FLOATING
C5970 a_17357_4687# VSS 0.95204f ; **FLOATING
C5971 a_16793_4687# VSS 0.44447f ; **FLOATING
C5972 a_16163_4687# VSS 0.48792f ; **FLOATING
C5973 a_16597_4687# VSS 0.85706f ; **FLOATING
C5974 a_16033_4687# VSS 0.4368f ; **FLOATING
C5975 a_15403_4687# VSS 0.48909f ; **FLOATING
C5976 a_15837_4687# VSS 0.94699f ; **FLOATING
C5977 a_15273_4687# VSS 0.44136f ; **FLOATING
C5978 a_14643_4687# VSS 0.48671f ; **FLOATING
C5979 a_15077_4687# VSS 0.91634f ; **FLOATING
C5980 a_14513_4687# VSS 0.44348f ; **FLOATING
C5981 a_13883_4687# VSS 0.48774f ; **FLOATING
C5982 a_14317_4687# VSS 0.95122f ; **FLOATING
C5983 a_13753_4687# VSS 0.44619f ; **FLOATING
C5984 a_13123_4687# VSS 0.48563f ; **FLOATING
C5985 a_13557_4687# VSS 0.86086f ; **FLOATING
C5986 a_12993_4687# VSS 0.44414f ; **FLOATING
C5987 a_12363_4687# VSS 0.48744f ; **FLOATING
C5988 a_12797_4687# VSS 0.95346f ; **FLOATING
C5989 a_12233_4687# VSS 0.44136f ; **FLOATING
C5990 a_11603_4687# VSS 0.48671f ; **FLOATING
C5991 a_12037_4687# VSS 0.91814f ; **FLOATING
C5992 a_11473_4687# VSS 0.44348f ; **FLOATING
C5993 a_10843_4687# VSS 0.48774f ; **FLOATING
C5994 a_11277_4687# VSS 0.95122f ; **FLOATING
C5995 a_10713_4687# VSS 0.44619f ; **FLOATING
C5996 a_10083_4687# VSS 0.48563f ; **FLOATING
C5997 a_10517_4687# VSS 0.86086f ; **FLOATING
C5998 a_9953_4687# VSS 0.44414f ; **FLOATING
C5999 a_9323_4687# VSS 0.48744f ; **FLOATING
C6000 a_9757_4687# VSS 0.95346f ; **FLOATING
C6001 a_9193_4687# VSS 0.44136f ; **FLOATING
C6002 a_8563_4687# VSS 0.48671f ; **FLOATING
C6003 a_8997_4687# VSS 0.91814f ; **FLOATING
C6004 a_8433_4687# VSS 0.44348f ; **FLOATING
C6005 a_7803_4687# VSS 0.48774f ; **FLOATING
C6006 a_8237_4687# VSS 0.95122f ; **FLOATING
C6007 a_7673_4687# VSS 0.44619f ; **FLOATING
C6008 a_7043_4687# VSS 0.48563f ; **FLOATING
C6009 a_7477_4687# VSS 0.86086f ; **FLOATING
C6010 a_6913_4687# VSS 0.44414f ; **FLOATING
C6011 a_6283_4687# VSS 0.48744f ; **FLOATING
C6012 a_6717_4687# VSS 0.95287f ; **FLOATING
C6013 a_6153_4687# VSS 0.44059f ; **FLOATING
C6014 a_5523_4687# VSS 0.48671f ; **FLOATING
C6015 a_5957_4687# VSS 0.91534f ; **FLOATING
C6016 a_5393_4687# VSS 0.44587f ; **FLOATING
C6017 a_4763_4687# VSS 0.49323f ; **FLOATING
C6018 a_5197_4687# VSS 0.95402f ; **FLOATING
C6019 a_4633_4687# VSS 0.44882f ; **FLOATING
C6020 a_4003_4687# VSS 0.57066f ; **FLOATING
C6021 a_4437_4687# VSS 0.86317f ; **FLOATING
C6022 a_26985_6209# VSS 0.17928f ; **FLOATING
C6023 a_23945_6209# VSS 0.17928f ; **FLOATING
C6024 a_20905_6209# VSS 0.17928f ; **FLOATING
C6025 a_17865_6209# VSS 0.17593f ; **FLOATING
C6026 a_16851_5999# VSS 0.37653f ; **FLOATING
C6027 a_16108_5979# VSS 2.47628f ; **FLOATING
C6028 a_15964_5979# VSS 0.17103f ; **FLOATING
C6029 a_15765_6153# VSS 0.33587f ; **FLOATING
C6030 a_14825_6209# VSS 0.17928f ; **FLOATING
C6031 a_11785_6209# VSS 0.17928f ; **FLOATING
C6032 a_8745_6209# VSS 0.17928f ; **FLOATING
C6033 a_5731_5979# VSS 2.14802f ; **FLOATING
C6034 a_5705_6209# VSS 0.17638f ; **FLOATING
C6035 a_3449_6021# VSS 0.17702f ; **FLOATING
C6036 a_2873_6021# VSS 0.1828f ; **FLOATING
C6037 a_2297_6021# VSS 0.1828f ; **FLOATING
C6038 a_1721_6021# VSS 0.1696f ; **FLOATING
C6039 a_1544_5979# VSS 0.29702f ; **FLOATING
C6040 a_1256_5979# VSS 0.8186f ; **FLOATING
C6041 a_27991_6698# VSS 0.18561f ; **FLOATING
C6042 a_27915_6734# VSS 0.10926f ; **FLOATING
C6043 a_27124_6698# VSS 0.17878f ; **FLOATING
C6044 a_27048_6734# VSS 0.12122f ; **FLOATING
C6045 a_26471_6698# VSS 0.18126f ; **FLOATING
C6046 a_26395_6734# VSS 0.11073f ; **FLOATING
C6047 a_25604_6698# VSS 0.18087f ; **FLOATING
C6048 a_25630_6734# VSS 0.32104f ; **FLOATING
C6049 a_25528_6734# VSS 0.12433f ; **FLOATING
C6050 a_24951_6698# VSS 0.18335f ; **FLOATING
C6051 a_24875_6734# VSS 0.11016f ; **FLOATING
C6052 a_24084_6698# VSS 0.17878f ; **FLOATING
C6053 a_24008_6734# VSS 0.12122f ; **FLOATING
C6054 a_23431_6698# VSS 0.18126f ; **FLOATING
C6055 a_23355_6734# VSS 0.11073f ; **FLOATING
C6056 a_22564_6698# VSS 0.18087f ; **FLOATING
C6057 a_22590_6734# VSS 0.33314f ; **FLOATING
C6058 a_22488_6734# VSS 0.12433f ; **FLOATING
C6059 a_21911_6698# VSS 0.18335f ; **FLOATING
C6060 a_21835_6734# VSS 0.11016f ; **FLOATING
C6061 a_21044_6698# VSS 0.17878f ; **FLOATING
C6062 a_20968_6734# VSS 0.12122f ; **FLOATING
C6063 a_20391_6698# VSS 0.18126f ; **FLOATING
C6064 a_20315_6734# VSS 0.11073f ; **FLOATING
C6065 a_19524_6698# VSS 0.18087f ; **FLOATING
C6066 a_19550_6734# VSS 0.33563f ; **FLOATING
C6067 a_19448_6734# VSS 0.12433f ; **FLOATING
C6068 a_18871_6698# VSS 0.18335f ; **FLOATING
C6069 a_18795_6734# VSS 0.11016f ; **FLOATING
C6070 a_18004_6698# VSS 0.17878f ; **FLOATING
C6071 a_17928_6734# VSS 0.12122f ; **FLOATING
C6072 a_17351_6698# VSS 0.17877f ; **FLOATING
C6073 a_17275_6734# VSS 0.10926f ; **FLOATING
C6074 a_16484_6698# VSS 0.17947f ; **FLOATING
C6075 a_16510_6734# VSS 0.28935f ; **FLOATING
C6076 a_16408_6734# VSS 0.1229f ; **FLOATING
C6077 a_15831_6698# VSS 0.17846f ; **FLOATING
C6078 a_15755_6734# VSS 0.10926f ; **FLOATING
C6079 a_14964_6698# VSS 0.17878f ; **FLOATING
C6080 a_14888_6734# VSS 0.12122f ; **FLOATING
C6081 a_14311_6698# VSS 0.18126f ; **FLOATING
C6082 a_14235_6734# VSS 0.11073f ; **FLOATING
C6083 a_13444_6698# VSS 0.18087f ; **FLOATING
C6084 a_13470_6734# VSS 0.30333f ; **FLOATING
C6085 a_13368_6734# VSS 0.12433f ; **FLOATING
C6086 a_12791_6698# VSS 0.18335f ; **FLOATING
C6087 a_12715_6734# VSS 0.11016f ; **FLOATING
C6088 a_11924_6698# VSS 0.17878f ; **FLOATING
C6089 a_11848_6734# VSS 0.12122f ; **FLOATING
C6090 a_11271_6698# VSS 0.18126f ; **FLOATING
C6091 a_11195_6734# VSS 0.11073f ; **FLOATING
C6092 a_10404_6698# VSS 0.18087f ; **FLOATING
C6093 a_10430_6734# VSS 0.31665f ; **FLOATING
C6094 a_10328_6734# VSS 0.12433f ; **FLOATING
C6095 a_9751_6698# VSS 0.18335f ; **FLOATING
C6096 a_9675_6734# VSS 0.11016f ; **FLOATING
C6097 a_8884_6698# VSS 0.17878f ; **FLOATING
C6098 a_8808_6734# VSS 0.12122f ; **FLOATING
C6099 a_8231_6698# VSS 0.18126f ; **FLOATING
C6100 a_8155_6734# VSS 0.11073f ; **FLOATING
C6101 a_7364_6698# VSS 0.18087f ; **FLOATING
C6102 a_7390_6734# VSS 0.31357f ; **FLOATING
C6103 a_7288_6734# VSS 0.12433f ; **FLOATING
C6104 a_6711_6698# VSS 0.18335f ; **FLOATING
C6105 a_6635_6734# VSS 0.11016f ; **FLOATING
C6106 a_5844_6698# VSS 0.17878f ; **FLOATING
C6107 a_5768_6734# VSS 0.12122f ; **FLOATING
C6108 a_5191_6698# VSS 0.17877f ; **FLOATING
C6109 a_5115_6734# VSS 0.10926f ; **FLOATING
C6110 a_4324_6698# VSS 0.17947f ; **FLOATING
C6111 a_4350_6734# VSS 0.26655f ; **FLOATING
C6112 a_4248_6734# VSS 0.12443f ; **FLOATING
C6113 a_27705_6734# VSS 0.25231f ; **FLOATING
C6114 a_26185_6734# VSS 0.23475f ; **FLOATING
C6115 a_24665_6734# VSS 0.25433f ; **FLOATING
C6116 a_23145_6734# VSS 0.23475f ; **FLOATING
C6117 a_21625_6734# VSS 0.25433f ; **FLOATING
C6118 a_20105_6734# VSS 0.23475f ; **FLOATING
C6119 a_18585_6734# VSS 0.25433f ; **FLOATING
C6120 a_17065_6734# VSS 0.23378f ; **FLOATING
C6121 a_15545_6734# VSS 0.25231f ; **FLOATING
C6122 a_14025_6734# VSS 0.23475f ; **FLOATING
C6123 a_12505_6734# VSS 0.25433f ; **FLOATING
C6124 a_10985_6734# VSS 0.23475f ; **FLOATING
C6125 a_9465_6734# VSS 0.25433f ; **FLOATING
C6126 a_7945_6734# VSS 0.23475f ; **FLOATING
C6127 a_6425_6734# VSS 0.25433f ; **FLOATING
C6128 a_4905_6734# VSS 0.23483f ; **FLOATING
C6129 a_4157_7003# VSS 0.32839f ; **FLOATING
C6130 a_3449_7085# VSS 0.18629f ; **FLOATING
C6131 a_2873_7085# VSS 0.18349f ; **FLOATING
C6132 a_2297_7085# VSS 0.18349f ; **FLOATING
C6133 a_1721_7085# VSS 0.17029f ; **FLOATING
C6134 a_1544_6734# VSS 0.29829f ; **FLOATING
C6135 a_1256_6734# VSS 0.82974f ; **FLOATING
C6136 a_27671_7532# VSS 0.01336f ; **FLOATING
C6137 a_26911_7532# VSS 0.01336f ; **FLOATING
C6138 a_26151_7532# VSS 0.01336f ; **FLOATING
C6139 a_25391_7532# VSS 0.01336f ; **FLOATING
C6140 a_24631_7532# VSS 0.01336f ; **FLOATING
C6141 a_23871_7532# VSS 0.01336f ; **FLOATING
C6142 a_23111_7532# VSS 0.01336f ; **FLOATING
C6143 a_22351_7532# VSS 0.01336f ; **FLOATING
C6144 a_21591_7532# VSS 0.01336f ; **FLOATING
C6145 a_20831_7532# VSS 0.01336f ; **FLOATING
C6146 a_20071_7532# VSS 0.01336f ; **FLOATING
C6147 a_19311_7532# VSS 0.01336f ; **FLOATING
C6148 a_18551_7532# VSS 0.01336f ; **FLOATING
C6149 a_17791_7532# VSS 0.01336f ; **FLOATING
C6150 a_17031_7532# VSS 0.01336f ; **FLOATING
C6151 a_16271_7532# VSS 0.01336f ; **FLOATING
C6152 a_15511_7532# VSS 0.01336f ; **FLOATING
C6153 a_14751_7532# VSS 0.01336f ; **FLOATING
C6154 a_13991_7532# VSS 0.01336f ; **FLOATING
C6155 a_13231_7532# VSS 0.01336f ; **FLOATING
C6156 a_12471_7532# VSS 0.01336f ; **FLOATING
C6157 a_11711_7532# VSS 0.01336f ; **FLOATING
C6158 a_10951_7532# VSS 0.01336f ; **FLOATING
C6159 a_10191_7532# VSS 0.01336f ; **FLOATING
C6160 a_9431_7532# VSS 0.01336f ; **FLOATING
C6161 a_8671_7532# VSS 0.01336f ; **FLOATING
C6162 a_7911_7532# VSS 0.01336f ; **FLOATING
C6163 a_7151_7532# VSS 0.01336f ; **FLOATING
C6164 a_6391_7532# VSS 0.01336f ; **FLOATING
C6165 a_5631_7532# VSS 0.01336f ; **FLOATING
C6166 a_4871_7532# VSS 0.01336f ; **FLOATING
C6167 a_4111_7532# VSS 0.0139f ; **FLOATING
C6168 a_27563_7532# VSS 0.50316f ; **FLOATING
C6169 a_27997_7532# VSS 0.6484f ; **FLOATING
C6170 a_27433_7532# VSS 0.4463f ; **FLOATING
C6171 a_26803_7532# VSS 0.49934f ; **FLOATING
C6172 a_27237_7532# VSS 0.92787f ; **FLOATING
C6173 a_26673_7532# VSS 0.4492f ; **FLOATING
C6174 a_26043_7532# VSS 0.50169f ; **FLOATING
C6175 a_26477_7532# VSS 0.9592f ; **FLOATING
C6176 a_25913_7532# VSS 0.4508f ; **FLOATING
C6177 a_25283_7532# VSS 0.49938f ; **FLOATING
C6178 a_25717_7532# VSS 0.86809f ; **FLOATING
C6179 a_25153_7532# VSS 0.45035f ; **FLOATING
C6180 a_24523_7532# VSS 0.50075f ; **FLOATING
C6181 a_24957_7532# VSS 0.96341f ; **FLOATING
C6182 a_24393_7532# VSS 0.4463f ; **FLOATING
C6183 a_23763_7532# VSS 0.49934f ; **FLOATING
C6184 a_24197_7532# VSS 0.92429f ; **FLOATING
C6185 a_23633_7532# VSS 0.45062f ; **FLOATING
C6186 a_23003_7532# VSS 0.50169f ; **FLOATING
C6187 a_23437_7532# VSS 0.95761f ; **FLOATING
C6188 a_22873_7532# VSS 0.4508f ; **FLOATING
C6189 a_22243_7532# VSS 0.49938f ; **FLOATING
C6190 a_22677_7532# VSS 0.86809f ; **FLOATING
C6191 a_22113_7532# VSS 0.45249f ; **FLOATING
C6192 a_21483_7532# VSS 0.50075f ; **FLOATING
C6193 a_21917_7532# VSS 0.96341f ; **FLOATING
C6194 a_21353_7532# VSS 0.4463f ; **FLOATING
C6195 a_20723_7532# VSS 0.49992f ; **FLOATING
C6196 a_21157_7532# VSS 0.92429f ; **FLOATING
C6197 a_20593_7532# VSS 0.45196f ; **FLOATING
C6198 a_19963_7532# VSS 0.50169f ; **FLOATING
C6199 a_20397_7532# VSS 0.95761f ; **FLOATING
C6200 a_19833_7532# VSS 0.4508f ; **FLOATING
C6201 a_19203_7532# VSS 0.5005f ; **FLOATING
C6202 a_19637_7532# VSS 0.86809f ; **FLOATING
C6203 a_19073_7532# VSS 0.44947f ; **FLOATING
C6204 a_18443_7532# VSS 0.50075f ; **FLOATING
C6205 a_18877_7532# VSS 0.96341f ; **FLOATING
C6206 a_18313_7532# VSS 0.4463f ; **FLOATING
C6207 a_17683_7532# VSS 0.50046f ; **FLOATING
C6208 a_18117_7532# VSS 0.92429f ; **FLOATING
C6209 a_17553_7532# VSS 0.44782f ; **FLOATING
C6210 a_16923_7532# VSS 0.50165f ; **FLOATING
C6211 a_17357_7532# VSS 0.95761f ; **FLOATING
C6212 a_16793_7532# VSS 0.45049f ; **FLOATING
C6213 a_16163_7532# VSS 0.4946f ; **FLOATING
C6214 a_16597_7532# VSS 0.86295f ; **FLOATING
C6215 a_16033_7532# VSS 0.44618f ; **FLOATING
C6216 a_15403_7532# VSS 0.49465f ; **FLOATING
C6217 a_15837_7532# VSS 0.95171f ; **FLOATING
C6218 a_15273_7532# VSS 0.44439f ; **FLOATING
C6219 a_14643_7532# VSS 0.49305f ; **FLOATING
C6220 a_15077_7532# VSS 0.91936f ; **FLOATING
C6221 a_14513_7532# VSS 0.44501f ; **FLOATING
C6222 a_13883_7532# VSS 0.50862f ; **FLOATING
C6223 a_14317_7532# VSS 0.96f ; **FLOATING
C6224 a_13753_7532# VSS 0.46427f ; **FLOATING
C6225 a_13123_7532# VSS 0.50173f ; **FLOATING
C6226 a_13557_7532# VSS 0.87556f ; **FLOATING
C6227 a_12993_7532# VSS 0.45643f ; **FLOATING
C6228 a_12363_7532# VSS 0.50854f ; **FLOATING
C6229 a_12797_7532# VSS 0.96142f ; **FLOATING
C6230 a_12233_7532# VSS 0.45757f ; **FLOATING
C6231 a_11603_7532# VSS 0.50267f ; **FLOATING
C6232 a_12037_7532# VSS 0.92753f ; **FLOATING
C6233 a_11473_7532# VSS 0.45177f ; **FLOATING
C6234 a_10843_7532# VSS 0.50491f ; **FLOATING
C6235 a_11277_7532# VSS 0.96044f ; **FLOATING
C6236 a_10713_7532# VSS 0.44901f ; **FLOATING
C6237 a_10083_7532# VSS 0.50223f ; **FLOATING
C6238 a_10517_7532# VSS 0.87021f ; **FLOATING
C6239 a_9953_7532# VSS 0.44673f ; **FLOATING
C6240 a_9323_7532# VSS 0.5026f ; **FLOATING
C6241 a_9757_7532# VSS 0.96312f ; **FLOATING
C6242 a_9193_7532# VSS 0.44361f ; **FLOATING
C6243 a_8563_7532# VSS 0.49203f ; **FLOATING
C6244 a_8997_7532# VSS 0.92083f ; **FLOATING
C6245 a_8433_7532# VSS 0.44439f ; **FLOATING
C6246 a_7803_7532# VSS 0.49435f ; **FLOATING
C6247 a_8237_7532# VSS 0.95413f ; **FLOATING
C6248 a_7673_7532# VSS 0.44737f ; **FLOATING
C6249 a_7043_7532# VSS 0.49204f ; **FLOATING
C6250 a_7477_7532# VSS 0.86461f ; **FLOATING
C6251 a_6913_7532# VSS 0.44442f ; **FLOATING
C6252 a_6283_7532# VSS 0.49343f ; **FLOATING
C6253 a_6717_7532# VSS 0.95763f ; **FLOATING
C6254 a_6153_7532# VSS 0.44292f ; **FLOATING
C6255 a_5523_7532# VSS 0.50322f ; **FLOATING
C6256 a_5957_7532# VSS 0.92533f ; **FLOATING
C6257 a_5393_7532# VSS 0.4596f ; **FLOATING
C6258 a_4763_7532# VSS 0.51043f ; **FLOATING
C6259 a_5197_7532# VSS 0.96501f ; **FLOATING
C6260 a_4633_7532# VSS 0.46282f ; **FLOATING
C6261 a_4003_7532# VSS 0.58808f ; **FLOATING
C6262 a_4437_7532# VSS 0.87448f ; **FLOATING
C6263 a_9712_9602# VSS 1.52086f ; **FLOATING
C6264 a_9444_9602# VSS 2.12877f ; **FLOATING
C6265 a_5778_9057# VSS 5.22809f ; **FLOATING
C6266 a_15464_9374# VSS 0.75391f ; **FLOATING
C6267 a_14757_10872# VSS 0.09495f ; **FLOATING
C6268 a_13880_10808# VSS 0.06985f ; **FLOATING
C6269 a_15688_11093# VSS 0.26291f ; **FLOATING
C6270 a_15108_11015# VSS 0.24458f ; **FLOATING
C6271 a_14851_10872# VSS 0.38123f ; **FLOATING
C6272 a_9444_10280# VSS 6.08223f ; **FLOATING
C6273 a_14111_10917# VSS 0.19866f ; **FLOATING
C6274 a_14009_10774# VSS 0.44622f ; **FLOATING
C6275 a_13592_11113# VSS 1.57456f ; **FLOATING
C6276 a_13306_10795# VSS 0.30095f ; **FLOATING
C6277 a_13566_11018# VSS 0.15441f ; **FLOATING
C6278 a_13132_11110# VSS 0.13036f ; **FLOATING
C6279 a_12907_11110# VSS 0.14379f ; **FLOATING
C6280 a_12907_10876# VSS 0.14787f ; **FLOATING
C6281 a_13106_11047# VSS 0.06341f ; **FLOATING
C6282 a_15304_10295# VSS 0.32071f ; **FLOATING
C6283 a_14757_11918# VSS 0.09586f ; **FLOATING
C6284 a_15688_11557# VSS 0.26296f ; **FLOATING
C6285 a_14851_11918# VSS 0.39011f ; **FLOATING
C6286 a_15108_11799# VSS 0.24509f ; **FLOATING
C6287 a_14111_11568# VSS 0.21578f ; **FLOATING
C6288 a_13880_11982# VSS 0.07345f ; **FLOATING
C6289 a_14009_11568# VSS 0.46644f ; **FLOATING
C6290 a_13592_11561# VSS 1.58178f ; **FLOATING
C6291 a_13566_11525# VSS 0.15442f ; **FLOATING
C6292 a_13045_11905# VSS 0.01124f ; **FLOATING
C6293 a_13306_11995# VSS 0.31701f ; **FLOATING
C6294 a_12849_11557# VSS 1.37418f ; **FLOATING
C6295 a_13121_11521# VSS 0.77226f ; **FLOATING
C6296 a_13019_11521# VSS 1.84445f ; **FLOATING
C6297 a_12656_11554# VSS 0.28138f ; **FLOATING
C6298 a_12355_11557# VSS 0.53943f ; **FLOATING
C6299 a_11397_11918# VSS 0.09495f ; **FLOATING
C6300 a_12158_11557# VSS 0.25842f ; **FLOATING
C6301 a_11491_11918# VSS 0.29538f ; **FLOATING
C6302 a_11748_11799# VSS 0.16909f ; **FLOATING
C6303 a_10751_11568# VSS 0.1982f ; **FLOATING
C6304 a_10520_11982# VSS 0.03671f ; **FLOATING
C6305 a_10649_11568# VSS 0.46311f ; **FLOATING
C6306 a_10232_11561# VSS 1.51871f ; **FLOATING
C6307 a_10206_11525# VSS 0.08466f ; **FLOATING
C6308 a_9946_11995# VSS 0.18126f ; **FLOATING
C6309 a_9772_11533# VSS 0.12311f ; **FLOATING
C6310 a_9746_11495# VSS 0.06443f ; **FLOATING
C6311 a_9547_11862# VSS 0.15766f ; **FLOATING
C6312 a_9547_11632# VSS 0.11843f ; **FLOATING
C6313 a_6854_11144# VSS 3.39622f ; **FLOATING
C6314 a_6126_9506# VSS 13.5861f ; **FLOATING
C6315 a_6854_11676# VSS 1.11097f ; **FLOATING
C6316 a_5974_11413# VSS 2.38934f ; **FLOATING
C6317 a_6326_10280# VSS 0.86042f ; **FLOATING
C6318 a_26985_12701# VSS 0.17928f ; **FLOATING
C6319 a_23945_12701# VSS 0.17928f ; **FLOATING
C6320 a_20905_12701# VSS 0.17928f ; **FLOATING
C6321 a_17865_12701# VSS 0.17593f ; **FLOATING
C6322 a_16851_12491# VSS 0.3805f ; **FLOATING
C6323 a_16108_12471# VSS 3.20934f ; **FLOATING
C6324 a_15964_12471# VSS 0.17235f ; **FLOATING
C6325 a_15765_12645# VSS 0.34456f ; **FLOATING
C6326 a_14825_12701# VSS 0.17928f ; **FLOATING
C6327 a_11785_12701# VSS 0.17928f ; **FLOATING
C6328 a_8745_12701# VSS 0.17928f ; **FLOATING
C6329 a_5731_12471# VSS 2.60625f ; **FLOATING
C6330 a_5705_12701# VSS 0.17638f ; **FLOATING
C6331 a_3449_12513# VSS 0.18479f ; **FLOATING
C6332 a_2873_12513# VSS 0.18322f ; **FLOATING
C6333 a_2297_12513# VSS 0.18322f ; **FLOATING
C6334 a_1721_12513# VSS 0.17002f ; **FLOATING
C6335 a_1544_12471# VSS 0.29837f ; **FLOATING
C6336 a_1256_12471# VSS 0.8301f ; **FLOATING
C6337 a_27991_13190# VSS 0.18558f ; **FLOATING
C6338 a_27915_13226# VSS 0.10926f ; **FLOATING
C6339 a_27124_13190# VSS 0.17878f ; **FLOATING
C6340 a_27048_13226# VSS 0.12122f ; **FLOATING
C6341 a_26471_13190# VSS 0.18115f ; **FLOATING
C6342 a_26395_13226# VSS 0.11073f ; **FLOATING
C6343 a_25604_13190# VSS 0.18087f ; **FLOATING
C6344 a_25630_13226# VSS 0.33618f ; **FLOATING
C6345 a_25528_13226# VSS 0.12433f ; **FLOATING
C6346 a_24951_13190# VSS 0.18335f ; **FLOATING
C6347 a_24875_13226# VSS 0.11016f ; **FLOATING
C6348 a_24084_13190# VSS 0.17878f ; **FLOATING
C6349 a_24008_13226# VSS 0.12122f ; **FLOATING
C6350 a_23431_13190# VSS 0.18104f ; **FLOATING
C6351 a_23355_13226# VSS 0.11073f ; **FLOATING
C6352 a_22564_13190# VSS 0.18087f ; **FLOATING
C6353 a_22590_13226# VSS 0.33314f ; **FLOATING
C6354 a_22488_13226# VSS 0.12433f ; **FLOATING
C6355 a_21911_13190# VSS 0.18335f ; **FLOATING
C6356 a_21835_13226# VSS 0.11016f ; **FLOATING
C6357 a_21044_13190# VSS 0.17878f ; **FLOATING
C6358 a_20968_13226# VSS 0.12122f ; **FLOATING
C6359 a_20391_13190# VSS 0.18104f ; **FLOATING
C6360 a_20315_13226# VSS 0.11073f ; **FLOATING
C6361 a_19524_13190# VSS 0.18087f ; **FLOATING
C6362 a_19550_13226# VSS 0.33563f ; **FLOATING
C6363 a_19448_13226# VSS 0.12433f ; **FLOATING
C6364 a_18871_13190# VSS 0.18335f ; **FLOATING
C6365 a_18795_13226# VSS 0.11016f ; **FLOATING
C6366 a_18004_13190# VSS 0.17878f ; **FLOATING
C6367 a_17928_13226# VSS 0.12122f ; **FLOATING
C6368 a_17351_13190# VSS 0.17808f ; **FLOATING
C6369 a_17275_13226# VSS 0.10926f ; **FLOATING
C6370 a_16484_13190# VSS 0.17809f ; **FLOATING
C6371 a_16510_13226# VSS 0.28935f ; **FLOATING
C6372 a_16408_13226# VSS 0.1229f ; **FLOATING
C6373 a_15831_13190# VSS 0.17846f ; **FLOATING
C6374 a_15755_13226# VSS 0.10926f ; **FLOATING
C6375 a_14964_13190# VSS 0.17878f ; **FLOATING
C6376 a_14888_13226# VSS 0.12122f ; **FLOATING
C6377 a_14311_13190# VSS 0.18138f ; **FLOATING
C6378 a_14235_13226# VSS 0.11073f ; **FLOATING
C6379 a_13444_13190# VSS 0.18087f ; **FLOATING
C6380 a_13470_13226# VSS 0.30333f ; **FLOATING
C6381 a_13368_13226# VSS 0.12433f ; **FLOATING
C6382 a_12791_13190# VSS 0.18335f ; **FLOATING
C6383 a_12715_13226# VSS 0.11016f ; **FLOATING
C6384 a_11924_13190# VSS 0.17878f ; **FLOATING
C6385 a_11848_13226# VSS 0.12122f ; **FLOATING
C6386 a_11271_13190# VSS 0.18178f ; **FLOATING
C6387 a_11195_13226# VSS 0.11073f ; **FLOATING
C6388 a_10404_13190# VSS 0.18087f ; **FLOATING
C6389 a_10430_13226# VSS 0.31665f ; **FLOATING
C6390 a_10328_13226# VSS 0.12433f ; **FLOATING
C6391 a_9751_13190# VSS 0.18335f ; **FLOATING
C6392 a_9675_13226# VSS 0.11016f ; **FLOATING
C6393 a_8884_13190# VSS 0.17878f ; **FLOATING
C6394 a_8808_13226# VSS 0.12122f ; **FLOATING
C6395 a_8231_13190# VSS 0.1809f ; **FLOATING
C6396 a_8155_13226# VSS 0.11073f ; **FLOATING
C6397 a_7364_13190# VSS 0.18087f ; **FLOATING
C6398 a_7390_13226# VSS 0.31357f ; **FLOATING
C6399 a_7288_13226# VSS 0.12433f ; **FLOATING
C6400 a_6711_13190# VSS 0.18335f ; **FLOATING
C6401 a_6635_13226# VSS 0.11016f ; **FLOATING
C6402 a_5844_13190# VSS 0.17878f ; **FLOATING
C6403 a_5768_13226# VSS 0.12122f ; **FLOATING
C6404 a_5191_13190# VSS 0.18022f ; **FLOATING
C6405 a_5115_13226# VSS 0.10926f ; **FLOATING
C6406 a_4324_13190# VSS 0.18023f ; **FLOATING
C6407 a_4350_13226# VSS 0.26655f ; **FLOATING
C6408 a_4248_13226# VSS 0.12443f ; **FLOATING
C6409 a_27705_13226# VSS 0.25204f ; **FLOATING
C6410 a_26185_13226# VSS 0.23475f ; **FLOATING
C6411 a_24665_13226# VSS 0.25405f ; **FLOATING
C6412 a_23145_13226# VSS 0.23475f ; **FLOATING
C6413 a_21625_13226# VSS 0.25405f ; **FLOATING
C6414 a_20105_13226# VSS 0.23475f ; **FLOATING
C6415 a_18585_13226# VSS 0.25405f ; **FLOATING
C6416 a_17065_13226# VSS 0.23373f ; **FLOATING
C6417 a_15545_13226# VSS 0.25216f ; **FLOATING
C6418 a_14025_13226# VSS 0.23475f ; **FLOATING
C6419 a_12505_13226# VSS 0.25405f ; **FLOATING
C6420 a_10985_13226# VSS 0.23475f ; **FLOATING
C6421 a_9465_13226# VSS 0.25405f ; **FLOATING
C6422 a_7945_13226# VSS 0.23475f ; **FLOATING
C6423 a_6425_13226# VSS 0.25405f ; **FLOATING
C6424 a_4905_13226# VSS 0.2355f ; **FLOATING
C6425 a_4157_13495# VSS 0.32875f ; **FLOATING
C6426 a_3449_13577# VSS 0.18619f ; **FLOATING
C6427 a_2873_13577# VSS 0.18296f ; **FLOATING
C6428 a_2297_13577# VSS 0.18296f ; **FLOATING
C6429 a_1721_13577# VSS 0.16976f ; **FLOATING
C6430 a_1544_13226# VSS 0.29775f ; **FLOATING
C6431 a_1256_13226# VSS 0.82301f ; **FLOATING
C6432 a_27671_14024# VSS 0.01336f ; **FLOATING
C6433 a_26911_14024# VSS 0.01336f ; **FLOATING
C6434 a_26151_14024# VSS 0.01336f ; **FLOATING
C6435 a_25391_14024# VSS 0.01336f ; **FLOATING
C6436 a_24631_14024# VSS 0.01336f ; **FLOATING
C6437 a_23871_14024# VSS 0.01336f ; **FLOATING
C6438 a_23111_14024# VSS 0.01336f ; **FLOATING
C6439 a_22351_14024# VSS 0.01336f ; **FLOATING
C6440 a_21591_14024# VSS 0.01336f ; **FLOATING
C6441 a_20831_14024# VSS 0.01336f ; **FLOATING
C6442 a_20071_14024# VSS 0.01336f ; **FLOATING
C6443 a_19311_14024# VSS 0.01336f ; **FLOATING
C6444 a_18551_14024# VSS 0.01336f ; **FLOATING
C6445 a_17791_14024# VSS 0.01336f ; **FLOATING
C6446 a_17031_14024# VSS 0.01336f ; **FLOATING
C6447 a_16271_14024# VSS 0.01336f ; **FLOATING
C6448 a_15511_14024# VSS 0.01336f ; **FLOATING
C6449 a_14751_14024# VSS 0.01336f ; **FLOATING
C6450 a_13991_14024# VSS 0.01336f ; **FLOATING
C6451 a_13231_14024# VSS 0.01336f ; **FLOATING
C6452 a_12471_14024# VSS 0.01336f ; **FLOATING
C6453 a_11711_14024# VSS 0.01336f ; **FLOATING
C6454 a_10951_14024# VSS 0.01336f ; **FLOATING
C6455 a_10191_14024# VSS 0.01336f ; **FLOATING
C6456 a_9431_14024# VSS 0.01336f ; **FLOATING
C6457 a_8671_14024# VSS 0.01336f ; **FLOATING
C6458 a_7911_14024# VSS 0.01336f ; **FLOATING
C6459 a_7151_14024# VSS 0.01336f ; **FLOATING
C6460 a_6391_14024# VSS 0.01336f ; **FLOATING
C6461 a_5631_14024# VSS 0.01336f ; **FLOATING
C6462 a_4871_14024# VSS 0.01336f ; **FLOATING
C6463 a_4111_14024# VSS 0.0139f ; **FLOATING
C6464 a_27563_14024# VSS 0.49372f ; **FLOATING
C6465 a_27997_14024# VSS 0.64441f ; **FLOATING
C6466 a_27433_14024# VSS 0.44136f ; **FLOATING
C6467 a_26803_14024# VSS 0.48671f ; **FLOATING
C6468 a_27237_14024# VSS 0.92139f ; **FLOATING
C6469 a_26673_14024# VSS 0.44348f ; **FLOATING
C6470 a_26043_14024# VSS 0.48774f ; **FLOATING
C6471 a_26477_14024# VSS 0.951f ; **FLOATING
C6472 a_25913_14024# VSS 0.44619f ; **FLOATING
C6473 a_25283_14024# VSS 0.48565f ; **FLOATING
C6474 a_25717_14024# VSS 0.86092f ; **FLOATING
C6475 a_25153_14024# VSS 0.44414f ; **FLOATING
C6476 a_24523_14024# VSS 0.48744f ; **FLOATING
C6477 a_24957_14024# VSS 0.95513f ; **FLOATING
C6478 a_24393_14024# VSS 0.44136f ; **FLOATING
C6479 a_23763_14024# VSS 0.48671f ; **FLOATING
C6480 a_24197_14024# VSS 0.91769f ; **FLOATING
C6481 a_23633_14024# VSS 0.44348f ; **FLOATING
C6482 a_23003_14024# VSS 0.48774f ; **FLOATING
C6483 a_23437_14024# VSS 0.951f ; **FLOATING
C6484 a_22873_14024# VSS 0.44619f ; **FLOATING
C6485 a_22243_14024# VSS 0.48565f ; **FLOATING
C6486 a_22677_14024# VSS 0.86092f ; **FLOATING
C6487 a_22113_14024# VSS 0.44414f ; **FLOATING
C6488 a_21483_14024# VSS 0.48744f ; **FLOATING
C6489 a_21917_14024# VSS 0.95513f ; **FLOATING
C6490 a_21353_14024# VSS 0.44136f ; **FLOATING
C6491 a_20723_14024# VSS 0.48671f ; **FLOATING
C6492 a_21157_14024# VSS 0.91769f ; **FLOATING
C6493 a_20593_14024# VSS 0.44348f ; **FLOATING
C6494 a_19963_14024# VSS 0.48774f ; **FLOATING
C6495 a_20397_14024# VSS 0.951f ; **FLOATING
C6496 a_19833_14024# VSS 0.44619f ; **FLOATING
C6497 a_19203_14024# VSS 0.48565f ; **FLOATING
C6498 a_19637_14024# VSS 0.86092f ; **FLOATING
C6499 a_19073_14024# VSS 0.44414f ; **FLOATING
C6500 a_18443_14024# VSS 0.48744f ; **FLOATING
C6501 a_18877_14024# VSS 0.95513f ; **FLOATING
C6502 a_18313_14024# VSS 0.44059f ; **FLOATING
C6503 a_17683_14024# VSS 0.48671f ; **FLOATING
C6504 a_18117_14024# VSS 0.91489f ; **FLOATING
C6505 a_17553_14024# VSS 0.44348f ; **FLOATING
C6506 a_16923_14024# VSS 0.4899f ; **FLOATING
C6507 a_17357_14024# VSS 0.95217f ; **FLOATING
C6508 a_16793_14024# VSS 0.44447f ; **FLOATING
C6509 a_16163_14024# VSS 0.48792f ; **FLOATING
C6510 a_16597_14024# VSS 0.85716f ; **FLOATING
C6511 a_16033_14024# VSS 0.4368f ; **FLOATING
C6512 a_15403_14024# VSS 0.48909f ; **FLOATING
C6513 a_15837_14024# VSS 0.94699f ; **FLOATING
C6514 a_15273_14024# VSS 0.44136f ; **FLOATING
C6515 a_14643_14024# VSS 0.48671f ; **FLOATING
C6516 a_15077_14024# VSS 0.91627f ; **FLOATING
C6517 a_14513_14024# VSS 0.44348f ; **FLOATING
C6518 a_13883_14024# VSS 0.48774f ; **FLOATING
C6519 a_14317_14024# VSS 0.95132f ; **FLOATING
C6520 a_13753_14024# VSS 0.44619f ; **FLOATING
C6521 a_13123_14024# VSS 0.48563f ; **FLOATING
C6522 a_13557_14024# VSS 0.86121f ; **FLOATING
C6523 a_12993_14024# VSS 0.44414f ; **FLOATING
C6524 a_12363_14024# VSS 0.48744f ; **FLOATING
C6525 a_12797_14024# VSS 0.95346f ; **FLOATING
C6526 a_12233_14024# VSS 0.44136f ; **FLOATING
C6527 a_11603_14024# VSS 0.48671f ; **FLOATING
C6528 a_12037_14024# VSS 0.91935f ; **FLOATING
C6529 a_11473_14024# VSS 0.44348f ; **FLOATING
C6530 a_10843_14024# VSS 0.48774f ; **FLOATING
C6531 a_11277_14024# VSS 0.95129f ; **FLOATING
C6532 a_10713_14024# VSS 0.44619f ; **FLOATING
C6533 a_10083_14024# VSS 0.48563f ; **FLOATING
C6534 a_10517_14024# VSS 0.86091f ; **FLOATING
C6535 a_9953_14024# VSS 0.44414f ; **FLOATING
C6536 a_9323_14024# VSS 0.48744f ; **FLOATING
C6537 a_9757_14024# VSS 0.95346f ; **FLOATING
C6538 a_9193_14024# VSS 0.44136f ; **FLOATING
C6539 a_8563_14024# VSS 0.48671f ; **FLOATING
C6540 a_8997_14024# VSS 0.91942f ; **FLOATING
C6541 a_8433_14024# VSS 0.44348f ; **FLOATING
C6542 a_7803_14024# VSS 0.48774f ; **FLOATING
C6543 a_8237_14024# VSS 0.95094f ; **FLOATING
C6544 a_7673_14024# VSS 0.44619f ; **FLOATING
C6545 a_7043_14024# VSS 0.48563f ; **FLOATING
C6546 a_7477_14024# VSS 0.86086f ; **FLOATING
C6547 a_6913_14024# VSS 0.44414f ; **FLOATING
C6548 a_6283_14024# VSS 0.48744f ; **FLOATING
C6549 a_6717_14024# VSS 0.95287f ; **FLOATING
C6550 a_6153_14024# VSS 0.44059f ; **FLOATING
C6551 a_5523_14024# VSS 0.48671f ; **FLOATING
C6552 a_5957_14024# VSS 0.91503f ; **FLOATING
C6553 a_5393_14024# VSS 0.44587f ; **FLOATING
C6554 a_4763_14024# VSS 0.49323f ; **FLOATING
C6555 a_5197_14024# VSS 0.9541f ; **FLOATING
C6556 a_4633_14024# VSS 0.44882f ; **FLOATING
C6557 a_4003_14024# VSS 0.57066f ; **FLOATING
C6558 a_4437_14024# VSS 0.86497f ; **FLOATING
C6559 a_26985_15546# VSS 0.17928f ; **FLOATING
C6560 a_23945_15546# VSS 0.17928f ; **FLOATING
C6561 a_20905_15546# VSS 0.17928f ; **FLOATING
C6562 a_17865_15546# VSS 0.17593f ; **FLOATING
C6563 a_16851_15336# VSS 0.37653f ; **FLOATING
C6564 a_16108_15316# VSS 2.47628f ; **FLOATING
C6565 a_15964_15316# VSS 0.17103f ; **FLOATING
C6566 a_15765_15490# VSS 0.33587f ; **FLOATING
C6567 a_14825_15546# VSS 0.17928f ; **FLOATING
C6568 a_11785_15546# VSS 0.17928f ; **FLOATING
C6569 a_8745_15546# VSS 0.17928f ; **FLOATING
C6570 a_5731_15316# VSS 2.14802f ; **FLOATING
C6571 a_5705_15546# VSS 0.17638f ; **FLOATING
C6572 a_3449_15358# VSS 0.17702f ; **FLOATING
C6573 a_2873_15358# VSS 0.1828f ; **FLOATING
C6574 a_2297_15358# VSS 0.1828f ; **FLOATING
C6575 a_1721_15358# VSS 0.1696f ; **FLOATING
C6576 a_1544_15316# VSS 0.29702f ; **FLOATING
C6577 a_1256_15316# VSS 0.8186f ; **FLOATING
C6578 a_27991_16035# VSS 0.18561f ; **FLOATING
C6579 a_27915_16071# VSS 0.10926f ; **FLOATING
C6580 a_27124_16035# VSS 0.17878f ; **FLOATING
C6581 a_27048_16071# VSS 0.12122f ; **FLOATING
C6582 a_26471_16035# VSS 0.18126f ; **FLOATING
C6583 a_26395_16071# VSS 0.11073f ; **FLOATING
C6584 a_25604_16035# VSS 0.18087f ; **FLOATING
C6585 a_25630_16071# VSS 0.32104f ; **FLOATING
C6586 a_25528_16071# VSS 0.12433f ; **FLOATING
C6587 a_24951_16035# VSS 0.18335f ; **FLOATING
C6588 a_24875_16071# VSS 0.11016f ; **FLOATING
C6589 a_24084_16035# VSS 0.17878f ; **FLOATING
C6590 a_24008_16071# VSS 0.12122f ; **FLOATING
C6591 a_23431_16035# VSS 0.18126f ; **FLOATING
C6592 a_23355_16071# VSS 0.11073f ; **FLOATING
C6593 a_22564_16035# VSS 0.18087f ; **FLOATING
C6594 a_22590_16071# VSS 0.33314f ; **FLOATING
C6595 a_22488_16071# VSS 0.12433f ; **FLOATING
C6596 a_21911_16035# VSS 0.18335f ; **FLOATING
C6597 a_21835_16071# VSS 0.11016f ; **FLOATING
C6598 a_21044_16035# VSS 0.17878f ; **FLOATING
C6599 a_20968_16071# VSS 0.12122f ; **FLOATING
C6600 a_20391_16035# VSS 0.18126f ; **FLOATING
C6601 a_20315_16071# VSS 0.11073f ; **FLOATING
C6602 a_19524_16035# VSS 0.18087f ; **FLOATING
C6603 a_19550_16071# VSS 0.33563f ; **FLOATING
C6604 a_19448_16071# VSS 0.12433f ; **FLOATING
C6605 a_18871_16035# VSS 0.18335f ; **FLOATING
C6606 a_18795_16071# VSS 0.11016f ; **FLOATING
C6607 a_18004_16035# VSS 0.17878f ; **FLOATING
C6608 a_17928_16071# VSS 0.12122f ; **FLOATING
C6609 a_17351_16035# VSS 0.17877f ; **FLOATING
C6610 a_17275_16071# VSS 0.10926f ; **FLOATING
C6611 a_16484_16035# VSS 0.17947f ; **FLOATING
C6612 a_16510_16071# VSS 0.28935f ; **FLOATING
C6613 a_16408_16071# VSS 0.1229f ; **FLOATING
C6614 a_15831_16035# VSS 0.17846f ; **FLOATING
C6615 a_15755_16071# VSS 0.10926f ; **FLOATING
C6616 a_14964_16035# VSS 0.17878f ; **FLOATING
C6617 a_14888_16071# VSS 0.12122f ; **FLOATING
C6618 a_14311_16035# VSS 0.18126f ; **FLOATING
C6619 a_14235_16071# VSS 0.11073f ; **FLOATING
C6620 a_13444_16035# VSS 0.18087f ; **FLOATING
C6621 a_13470_16071# VSS 0.30333f ; **FLOATING
C6622 a_13368_16071# VSS 0.12433f ; **FLOATING
C6623 a_12791_16035# VSS 0.18335f ; **FLOATING
C6624 a_12715_16071# VSS 0.11016f ; **FLOATING
C6625 a_11924_16035# VSS 0.17878f ; **FLOATING
C6626 a_11848_16071# VSS 0.12122f ; **FLOATING
C6627 a_11271_16035# VSS 0.18126f ; **FLOATING
C6628 a_11195_16071# VSS 0.11073f ; **FLOATING
C6629 a_10404_16035# VSS 0.18087f ; **FLOATING
C6630 a_10430_16071# VSS 0.31665f ; **FLOATING
C6631 a_10328_16071# VSS 0.12433f ; **FLOATING
C6632 a_9751_16035# VSS 0.18335f ; **FLOATING
C6633 a_9675_16071# VSS 0.11016f ; **FLOATING
C6634 a_8884_16035# VSS 0.17878f ; **FLOATING
C6635 a_8808_16071# VSS 0.12122f ; **FLOATING
C6636 a_8231_16035# VSS 0.18126f ; **FLOATING
C6637 a_8155_16071# VSS 0.11073f ; **FLOATING
C6638 a_7364_16035# VSS 0.18087f ; **FLOATING
C6639 a_7390_16071# VSS 0.31357f ; **FLOATING
C6640 a_7288_16071# VSS 0.12433f ; **FLOATING
C6641 a_6711_16035# VSS 0.18335f ; **FLOATING
C6642 a_6635_16071# VSS 0.11016f ; **FLOATING
C6643 a_5844_16035# VSS 0.17878f ; **FLOATING
C6644 a_5768_16071# VSS 0.12122f ; **FLOATING
C6645 a_5191_16035# VSS 0.17877f ; **FLOATING
C6646 a_5115_16071# VSS 0.10926f ; **FLOATING
C6647 a_4324_16035# VSS 0.17947f ; **FLOATING
C6648 a_4350_16071# VSS 0.26655f ; **FLOATING
C6649 a_4248_16071# VSS 0.12443f ; **FLOATING
C6650 a_27705_16071# VSS 0.25231f ; **FLOATING
C6651 a_26185_16071# VSS 0.23475f ; **FLOATING
C6652 a_24665_16071# VSS 0.25432f ; **FLOATING
C6653 a_23145_16071# VSS 0.23475f ; **FLOATING
C6654 a_21625_16071# VSS 0.25432f ; **FLOATING
C6655 a_20105_16071# VSS 0.23475f ; **FLOATING
C6656 a_18585_16071# VSS 0.25432f ; **FLOATING
C6657 a_17065_16071# VSS 0.23378f ; **FLOATING
C6658 a_15545_16071# VSS 0.25231f ; **FLOATING
C6659 a_14025_16071# VSS 0.23475f ; **FLOATING
C6660 a_12505_16071# VSS 0.25432f ; **FLOATING
C6661 a_10985_16071# VSS 0.23475f ; **FLOATING
C6662 a_9465_16071# VSS 0.25432f ; **FLOATING
C6663 a_7945_16071# VSS 0.23475f ; **FLOATING
C6664 a_6425_16071# VSS 0.25432f ; **FLOATING
C6665 a_4905_16071# VSS 0.23483f ; **FLOATING
C6666 a_4157_16340# VSS 0.32839f ; **FLOATING
C6667 a_3449_16422# VSS 0.18629f ; **FLOATING
C6668 a_2873_16422# VSS 0.18349f ; **FLOATING
C6669 a_2297_16422# VSS 0.18349f ; **FLOATING
C6670 a_1721_16422# VSS 0.17029f ; **FLOATING
C6671 a_1544_16071# VSS 0.29829f ; **FLOATING
C6672 a_1256_16071# VSS 0.82978f ; **FLOATING
C6673 a_27671_16869# VSS 0.01336f ; **FLOATING
C6674 a_26911_16869# VSS 0.01336f ; **FLOATING
C6675 a_26151_16869# VSS 0.01336f ; **FLOATING
C6676 a_25391_16869# VSS 0.01336f ; **FLOATING
C6677 a_24631_16869# VSS 0.01336f ; **FLOATING
C6678 a_23871_16869# VSS 0.01336f ; **FLOATING
C6679 a_23111_16869# VSS 0.01336f ; **FLOATING
C6680 a_22351_16869# VSS 0.01336f ; **FLOATING
C6681 a_21591_16869# VSS 0.01336f ; **FLOATING
C6682 a_20831_16869# VSS 0.01336f ; **FLOATING
C6683 a_20071_16869# VSS 0.01336f ; **FLOATING
C6684 a_19311_16869# VSS 0.01336f ; **FLOATING
C6685 a_18551_16869# VSS 0.01336f ; **FLOATING
C6686 a_17791_16869# VSS 0.01336f ; **FLOATING
C6687 a_17031_16869# VSS 0.01336f ; **FLOATING
C6688 a_16271_16869# VSS 0.01336f ; **FLOATING
C6689 a_15511_16869# VSS 0.01336f ; **FLOATING
C6690 a_14751_16869# VSS 0.01336f ; **FLOATING
C6691 a_13991_16869# VSS 0.01336f ; **FLOATING
C6692 a_13231_16869# VSS 0.01336f ; **FLOATING
C6693 a_12471_16869# VSS 0.01336f ; **FLOATING
C6694 a_11711_16869# VSS 0.01336f ; **FLOATING
C6695 a_10951_16869# VSS 0.01336f ; **FLOATING
C6696 a_10191_16869# VSS 0.01336f ; **FLOATING
C6697 a_9431_16869# VSS 0.01336f ; **FLOATING
C6698 a_8671_16869# VSS 0.01336f ; **FLOATING
C6699 a_7911_16869# VSS 0.01336f ; **FLOATING
C6700 a_7151_16869# VSS 0.01336f ; **FLOATING
C6701 a_6391_16869# VSS 0.01336f ; **FLOATING
C6702 a_5631_16869# VSS 0.01336f ; **FLOATING
C6703 a_4871_16869# VSS 0.01336f ; **FLOATING
C6704 a_4111_16869# VSS 0.0139f ; **FLOATING
C6705 a_27563_16869# VSS 0.51284f ; **FLOATING
C6706 a_27997_16869# VSS 0.6533f ; **FLOATING
C6707 a_27433_16869# VSS 0.45843f ; **FLOATING
C6708 a_26803_16869# VSS 0.50902f ; **FLOATING
C6709 a_27237_16869# VSS 0.93566f ; **FLOATING
C6710 a_26673_16869# VSS 0.45994f ; **FLOATING
C6711 a_26043_16869# VSS 0.51137f ; **FLOATING
C6712 a_26477_16869# VSS 0.9654f ; **FLOATING
C6713 a_25913_16869# VSS 0.46292f ; **FLOATING
C6714 a_25283_16869# VSS 0.50906f ; **FLOATING
C6715 a_25717_16869# VSS 0.87587f ; **FLOATING
C6716 a_25153_16869# VSS 0.45997f ; **FLOATING
C6717 a_24523_16869# VSS 0.51043f ; **FLOATING
C6718 a_24957_16869# VSS 0.97121f ; **FLOATING
C6719 a_24393_16869# VSS 0.45843f ; **FLOATING
C6720 a_23763_16869# VSS 0.50902f ; **FLOATING
C6721 a_24197_16869# VSS 0.93209f ; **FLOATING
C6722 a_23633_16869# VSS 0.45994f ; **FLOATING
C6723 a_23003_16869# VSS 0.51137f ; **FLOATING
C6724 a_23437_16869# VSS 0.9654f ; **FLOATING
C6725 a_22873_16869# VSS 0.46292f ; **FLOATING
C6726 a_22243_16869# VSS 0.50906f ; **FLOATING
C6727 a_22677_16869# VSS 0.87587f ; **FLOATING
C6728 a_22113_16869# VSS 0.45997f ; **FLOATING
C6729 a_21483_16869# VSS 0.51043f ; **FLOATING
C6730 a_21917_16869# VSS 0.97121f ; **FLOATING
C6731 a_21353_16869# VSS 0.45843f ; **FLOATING
C6732 a_20723_16869# VSS 0.50902f ; **FLOATING
C6733 a_21157_16869# VSS 0.93209f ; **FLOATING
C6734 a_20593_16869# VSS 0.45994f ; **FLOATING
C6735 a_19963_16869# VSS 0.51137f ; **FLOATING
C6736 a_20397_16869# VSS 0.9654f ; **FLOATING
C6737 a_19833_16869# VSS 0.46292f ; **FLOATING
C6738 a_19203_16869# VSS 0.50906f ; **FLOATING
C6739 a_19637_16869# VSS 0.87587f ; **FLOATING
C6740 a_19073_16869# VSS 0.45997f ; **FLOATING
C6741 a_18443_16869# VSS 0.51043f ; **FLOATING
C6742 a_18877_16869# VSS 0.97121f ; **FLOATING
C6743 a_18313_16869# VSS 0.45843f ; **FLOATING
C6744 a_17683_16869# VSS 0.50902f ; **FLOATING
C6745 a_18117_16869# VSS 0.93209f ; **FLOATING
C6746 a_17553_16869# VSS 0.45994f ; **FLOATING
C6747 a_16923_16869# VSS 0.51133f ; **FLOATING
C6748 a_17357_16869# VSS 0.9654f ; **FLOATING
C6749 a_16793_16869# VSS 0.46262f ; **FLOATING
C6750 a_16163_16869# VSS 0.50902f ; **FLOATING
C6751 a_16597_16869# VSS 0.87073f ; **FLOATING
C6752 a_16033_16869# VSS 0.45859f ; **FLOATING
C6753 a_15403_16869# VSS 0.51041f ; **FLOATING
C6754 a_15837_16869# VSS 0.9618f ; **FLOATING
C6755 a_15273_16869# VSS 0.45843f ; **FLOATING
C6756 a_14643_16869# VSS 0.50902f ; **FLOATING
C6757 a_15077_16869# VSS 0.93029f ; **FLOATING
C6758 a_14513_16869# VSS 0.45994f ; **FLOATING
C6759 a_13883_16869# VSS 0.51137f ; **FLOATING
C6760 a_14317_16869# VSS 0.9654f ; **FLOATING
C6761 a_13753_16869# VSS 0.46292f ; **FLOATING
C6762 a_13123_16869# VSS 0.50904f ; **FLOATING
C6763 a_13557_16869# VSS 0.87587f ; **FLOATING
C6764 a_12993_16869# VSS 0.45997f ; **FLOATING
C6765 a_12363_16869# VSS 0.51043f ; **FLOATING
C6766 a_12797_16869# VSS 0.96954f ; **FLOATING
C6767 a_12233_16869# VSS 0.45843f ; **FLOATING
C6768 a_11603_16869# VSS 0.50902f ; **FLOATING
C6769 a_12037_16869# VSS 0.93209f ; **FLOATING
C6770 a_11473_16869# VSS 0.45994f ; **FLOATING
C6771 a_10843_16869# VSS 0.51137f ; **FLOATING
C6772 a_11277_16869# VSS 0.9654f ; **FLOATING
C6773 a_10713_16869# VSS 0.46292f ; **FLOATING
C6774 a_10083_16869# VSS 0.50904f ; **FLOATING
C6775 a_10517_16869# VSS 0.87587f ; **FLOATING
C6776 a_9953_16869# VSS 0.45997f ; **FLOATING
C6777 a_9323_16869# VSS 0.51043f ; **FLOATING
C6778 a_9757_16869# VSS 0.96954f ; **FLOATING
C6779 a_9193_16869# VSS 0.45843f ; **FLOATING
C6780 a_8563_16869# VSS 0.50902f ; **FLOATING
C6781 a_8997_16869# VSS 0.93209f ; **FLOATING
C6782 a_8433_16869# VSS 0.45994f ; **FLOATING
C6783 a_7803_16869# VSS 0.51137f ; **FLOATING
C6784 a_8237_16869# VSS 0.9654f ; **FLOATING
C6785 a_7673_16869# VSS 0.46292f ; **FLOATING
C6786 a_7043_16869# VSS 0.50904f ; **FLOATING
C6787 a_7477_16869# VSS 0.87587f ; **FLOATING
C6788 a_6913_16869# VSS 0.45997f ; **FLOATING
C6789 a_6283_16869# VSS 0.51043f ; **FLOATING
C6790 a_6717_16869# VSS 0.96895f ; **FLOATING
C6791 a_6153_16869# VSS 0.45843f ; **FLOATING
C6792 a_5523_16869# VSS 0.50902f ; **FLOATING
C6793 a_5957_16869# VSS 0.93209f ; **FLOATING
C6794 a_5393_16869# VSS 0.45994f ; **FLOATING
C6795 a_4763_16869# VSS 0.51133f ; **FLOATING
C6796 a_5197_16869# VSS 0.9654f ; **FLOATING
C6797 a_4633_16869# VSS 0.4629f ; **FLOATING
C6798 a_4003_16869# VSS 0.58899f ; **FLOATING
C6799 a_4437_16869# VSS 0.87486f ; **FLOATING
C6800 a_4187_2434# VSS 17.5895f ; **FLOATING
C6801 a_4187_1764.t98 VSS 67.7834f ; **FLOATING
C6802 a_4187_1764.t163 VSS 0.0568f ; **FLOATING
C6803 a_4187_1764.t162 VSS 0.05514f ; **FLOATING
C6804 a_4187_1764.n0 VSS 0.13048f ; **FLOATING
C6805 a_4187_1764.t161 VSS 0.05514f ; **FLOATING
C6806 a_4187_1764.n1 VSS 0.09051f ; **FLOATING
C6807 a_4187_1764.t160 VSS 0.05514f ; **FLOATING
C6808 a_4187_1764.n2 VSS 0.09051f ; **FLOATING
C6809 a_4187_1764.t159 VSS 0.05514f ; **FLOATING
C6810 a_4187_1764.n3 VSS 0.09051f ; **FLOATING
C6811 a_4187_1764.t158 VSS 0.05514f ; **FLOATING
C6812 a_4187_1764.n4 VSS 0.09051f ; **FLOATING
C6813 a_4187_1764.t157 VSS 0.05514f ; **FLOATING
C6814 a_4187_1764.n5 VSS 0.09051f ; **FLOATING
C6815 a_4187_1764.t156 VSS 0.05514f ; **FLOATING
C6816 a_4187_1764.n6 VSS 0.09051f ; **FLOATING
C6817 a_4187_1764.t155 VSS 0.05514f ; **FLOATING
C6818 a_4187_1764.n7 VSS 0.09051f ; **FLOATING
C6819 a_4187_1764.t154 VSS 0.05514f ; **FLOATING
C6820 a_4187_1764.n8 VSS 0.09051f ; **FLOATING
C6821 a_4187_1764.t153 VSS 0.05514f ; **FLOATING
C6822 a_4187_1764.n9 VSS 0.09051f ; **FLOATING
C6823 a_4187_1764.t152 VSS 0.05514f ; **FLOATING
C6824 a_4187_1764.n10 VSS 0.09051f ; **FLOATING
C6825 a_4187_1764.t151 VSS 0.05514f ; **FLOATING
C6826 a_4187_1764.n11 VSS 0.09051f ; **FLOATING
C6827 a_4187_1764.t150 VSS 0.05514f ; **FLOATING
C6828 a_4187_1764.n12 VSS 0.09051f ; **FLOATING
C6829 a_4187_1764.t149 VSS 0.05514f ; **FLOATING
C6830 a_4187_1764.n13 VSS 0.09051f ; **FLOATING
C6831 a_4187_1764.t148 VSS 0.05514f ; **FLOATING
C6832 a_4187_1764.n14 VSS 0.09051f ; **FLOATING
C6833 a_4187_1764.t147 VSS 0.05514f ; **FLOATING
C6834 a_4187_1764.n15 VSS 0.09051f ; **FLOATING
C6835 a_4187_1764.t146 VSS 0.05514f ; **FLOATING
C6836 a_4187_1764.n16 VSS 0.09051f ; **FLOATING
C6837 a_4187_1764.t145 VSS 0.05514f ; **FLOATING
C6838 a_4187_1764.n17 VSS 0.09051f ; **FLOATING
C6839 a_4187_1764.t144 VSS 0.05514f ; **FLOATING
C6840 a_4187_1764.n18 VSS 0.09051f ; **FLOATING
C6841 a_4187_1764.t143 VSS 0.05514f ; **FLOATING
C6842 a_4187_1764.n19 VSS 0.09051f ; **FLOATING
C6843 a_4187_1764.t142 VSS 0.05514f ; **FLOATING
C6844 a_4187_1764.n20 VSS 0.09051f ; **FLOATING
C6845 a_4187_1764.t141 VSS 0.05514f ; **FLOATING
C6846 a_4187_1764.n21 VSS 0.09051f ; **FLOATING
C6847 a_4187_1764.t140 VSS 0.05514f ; **FLOATING
C6848 a_4187_1764.n22 VSS 0.09051f ; **FLOATING
C6849 a_4187_1764.t139 VSS 0.05514f ; **FLOATING
C6850 a_4187_1764.n23 VSS 0.09051f ; **FLOATING
C6851 a_4187_1764.t138 VSS 0.05514f ; **FLOATING
C6852 a_4187_1764.n24 VSS 0.09051f ; **FLOATING
C6853 a_4187_1764.t137 VSS 0.05514f ; **FLOATING
C6854 a_4187_1764.n25 VSS 0.09051f ; **FLOATING
C6855 a_4187_1764.t136 VSS 0.05514f ; **FLOATING
C6856 a_4187_1764.n26 VSS 0.09051f ; **FLOATING
C6857 a_4187_1764.t135 VSS 0.05514f ; **FLOATING
C6858 a_4187_1764.n27 VSS 0.09051f ; **FLOATING
C6859 a_4187_1764.t134 VSS 0.05514f ; **FLOATING
C6860 a_4187_1764.n28 VSS 0.09051f ; **FLOATING
C6861 a_4187_1764.t133 VSS 0.05514f ; **FLOATING
C6862 a_4187_1764.n29 VSS 0.09051f ; **FLOATING
C6863 a_4187_1764.t132 VSS 0.05514f ; **FLOATING
C6864 a_4187_1764.n30 VSS 0.22172f ; **FLOATING
C6865 a_4187_1764.t131 VSS 0.0568f ; **FLOATING
C6866 a_4187_1764.t130 VSS 0.05514f ; **FLOATING
C6867 a_4187_1764.n31 VSS 0.13048f ; **FLOATING
C6868 a_4187_1764.t129 VSS 0.05514f ; **FLOATING
C6869 a_4187_1764.n32 VSS 0.09051f ; **FLOATING
C6870 a_4187_1764.t128 VSS 0.05514f ; **FLOATING
C6871 a_4187_1764.n33 VSS 0.09051f ; **FLOATING
C6872 a_4187_1764.t127 VSS 0.05514f ; **FLOATING
C6873 a_4187_1764.n34 VSS 0.09051f ; **FLOATING
C6874 a_4187_1764.t126 VSS 0.05514f ; **FLOATING
C6875 a_4187_1764.n35 VSS 0.09051f ; **FLOATING
C6876 a_4187_1764.t125 VSS 0.05514f ; **FLOATING
C6877 a_4187_1764.n36 VSS 0.09051f ; **FLOATING
C6878 a_4187_1764.t124 VSS 0.05514f ; **FLOATING
C6879 a_4187_1764.n37 VSS 0.09051f ; **FLOATING
C6880 a_4187_1764.t123 VSS 0.05514f ; **FLOATING
C6881 a_4187_1764.n38 VSS 0.09051f ; **FLOATING
C6882 a_4187_1764.t122 VSS 0.05514f ; **FLOATING
C6883 a_4187_1764.n39 VSS 0.09051f ; **FLOATING
C6884 a_4187_1764.t121 VSS 0.05514f ; **FLOATING
C6885 a_4187_1764.n40 VSS 0.09051f ; **FLOATING
C6886 a_4187_1764.t120 VSS 0.05514f ; **FLOATING
C6887 a_4187_1764.n41 VSS 0.09051f ; **FLOATING
C6888 a_4187_1764.t119 VSS 0.05514f ; **FLOATING
C6889 a_4187_1764.n42 VSS 0.09051f ; **FLOATING
C6890 a_4187_1764.t118 VSS 0.05514f ; **FLOATING
C6891 a_4187_1764.n43 VSS 0.09051f ; **FLOATING
C6892 a_4187_1764.t117 VSS 0.05514f ; **FLOATING
C6893 a_4187_1764.n44 VSS 0.09051f ; **FLOATING
C6894 a_4187_1764.t116 VSS 0.05514f ; **FLOATING
C6895 a_4187_1764.n45 VSS 0.09051f ; **FLOATING
C6896 a_4187_1764.t115 VSS 0.05514f ; **FLOATING
C6897 a_4187_1764.n46 VSS 0.09051f ; **FLOATING
C6898 a_4187_1764.t114 VSS 0.05514f ; **FLOATING
C6899 a_4187_1764.n47 VSS 0.09051f ; **FLOATING
C6900 a_4187_1764.t113 VSS 0.05514f ; **FLOATING
C6901 a_4187_1764.n48 VSS 0.09051f ; **FLOATING
C6902 a_4187_1764.t112 VSS 0.05514f ; **FLOATING
C6903 a_4187_1764.n49 VSS 0.09051f ; **FLOATING
C6904 a_4187_1764.t111 VSS 0.05514f ; **FLOATING
C6905 a_4187_1764.n50 VSS 0.09051f ; **FLOATING
C6906 a_4187_1764.t110 VSS 0.05514f ; **FLOATING
C6907 a_4187_1764.n51 VSS 0.09051f ; **FLOATING
C6908 a_4187_1764.t109 VSS 0.05514f ; **FLOATING
C6909 a_4187_1764.n52 VSS 0.09051f ; **FLOATING
C6910 a_4187_1764.t108 VSS 0.05514f ; **FLOATING
C6911 a_4187_1764.n53 VSS 0.09051f ; **FLOATING
C6912 a_4187_1764.t107 VSS 0.05514f ; **FLOATING
C6913 a_4187_1764.n54 VSS 0.09051f ; **FLOATING
C6914 a_4187_1764.t106 VSS 0.05514f ; **FLOATING
C6915 a_4187_1764.n55 VSS 0.09051f ; **FLOATING
C6916 a_4187_1764.t105 VSS 0.05514f ; **FLOATING
C6917 a_4187_1764.n56 VSS 0.09051f ; **FLOATING
C6918 a_4187_1764.t104 VSS 0.05514f ; **FLOATING
C6919 a_4187_1764.n57 VSS 0.09051f ; **FLOATING
C6920 a_4187_1764.t103 VSS 0.05514f ; **FLOATING
C6921 a_4187_1764.n58 VSS 0.09051f ; **FLOATING
C6922 a_4187_1764.t102 VSS 0.05514f ; **FLOATING
C6923 a_4187_1764.n59 VSS 0.09051f ; **FLOATING
C6924 a_4187_1764.t101 VSS 0.05514f ; **FLOATING
C6925 a_4187_1764.n60 VSS 0.09051f ; **FLOATING
C6926 a_4187_1764.t100 VSS 0.05514f ; **FLOATING
C6927 a_4187_1764.n61 VSS 0.13594f ; **FLOATING
C6928 a_4187_1764.n62 VSS 0.5907f ; **FLOATING
C6929 a_4187_1764.t33 VSS 0.0568f ; **FLOATING
C6930 a_4187_1764.t32 VSS 0.05514f ; **FLOATING
C6931 a_4187_1764.n63 VSS 0.13048f ; **FLOATING
C6932 a_4187_1764.t31 VSS 0.05514f ; **FLOATING
C6933 a_4187_1764.n64 VSS 0.09051f ; **FLOATING
C6934 a_4187_1764.t30 VSS 0.05514f ; **FLOATING
C6935 a_4187_1764.n65 VSS 0.09051f ; **FLOATING
C6936 a_4187_1764.t29 VSS 0.05514f ; **FLOATING
C6937 a_4187_1764.n66 VSS 0.09051f ; **FLOATING
C6938 a_4187_1764.t28 VSS 0.05514f ; **FLOATING
C6939 a_4187_1764.n67 VSS 0.09051f ; **FLOATING
C6940 a_4187_1764.t27 VSS 0.05514f ; **FLOATING
C6941 a_4187_1764.n68 VSS 0.09051f ; **FLOATING
C6942 a_4187_1764.t26 VSS 0.05514f ; **FLOATING
C6943 a_4187_1764.n69 VSS 0.09051f ; **FLOATING
C6944 a_4187_1764.t25 VSS 0.05514f ; **FLOATING
C6945 a_4187_1764.n70 VSS 0.09051f ; **FLOATING
C6946 a_4187_1764.t24 VSS 0.05514f ; **FLOATING
C6947 a_4187_1764.n71 VSS 0.09051f ; **FLOATING
C6948 a_4187_1764.t23 VSS 0.05514f ; **FLOATING
C6949 a_4187_1764.n72 VSS 0.09051f ; **FLOATING
C6950 a_4187_1764.t22 VSS 0.05514f ; **FLOATING
C6951 a_4187_1764.n73 VSS 0.09051f ; **FLOATING
C6952 a_4187_1764.t21 VSS 0.05514f ; **FLOATING
C6953 a_4187_1764.n74 VSS 0.09051f ; **FLOATING
C6954 a_4187_1764.t20 VSS 0.05514f ; **FLOATING
C6955 a_4187_1764.n75 VSS 0.09051f ; **FLOATING
C6956 a_4187_1764.t19 VSS 0.05514f ; **FLOATING
C6957 a_4187_1764.n76 VSS 0.09051f ; **FLOATING
C6958 a_4187_1764.t18 VSS 0.05514f ; **FLOATING
C6959 a_4187_1764.n77 VSS 0.09051f ; **FLOATING
C6960 a_4187_1764.t17 VSS 0.05514f ; **FLOATING
C6961 a_4187_1764.n78 VSS 0.09051f ; **FLOATING
C6962 a_4187_1764.t16 VSS 0.05514f ; **FLOATING
C6963 a_4187_1764.n79 VSS 0.09051f ; **FLOATING
C6964 a_4187_1764.t15 VSS 0.05514f ; **FLOATING
C6965 a_4187_1764.n80 VSS 0.09051f ; **FLOATING
C6966 a_4187_1764.t14 VSS 0.05514f ; **FLOATING
C6967 a_4187_1764.n81 VSS 0.09051f ; **FLOATING
C6968 a_4187_1764.t13 VSS 0.05514f ; **FLOATING
C6969 a_4187_1764.n82 VSS 0.09051f ; **FLOATING
C6970 a_4187_1764.t12 VSS 0.05514f ; **FLOATING
C6971 a_4187_1764.n83 VSS 0.09051f ; **FLOATING
C6972 a_4187_1764.t11 VSS 0.05514f ; **FLOATING
C6973 a_4187_1764.n84 VSS 0.09051f ; **FLOATING
C6974 a_4187_1764.t10 VSS 0.05514f ; **FLOATING
C6975 a_4187_1764.n85 VSS 0.09051f ; **FLOATING
C6976 a_4187_1764.t9 VSS 0.05514f ; **FLOATING
C6977 a_4187_1764.n86 VSS 0.09051f ; **FLOATING
C6978 a_4187_1764.t8 VSS 0.05514f ; **FLOATING
C6979 a_4187_1764.n87 VSS 0.09051f ; **FLOATING
C6980 a_4187_1764.t7 VSS 0.05514f ; **FLOATING
C6981 a_4187_1764.n88 VSS 0.09051f ; **FLOATING
C6982 a_4187_1764.t6 VSS 0.05514f ; **FLOATING
C6983 a_4187_1764.n89 VSS 0.09051f ; **FLOATING
C6984 a_4187_1764.t5 VSS 0.05514f ; **FLOATING
C6985 a_4187_1764.n90 VSS 0.09051f ; **FLOATING
C6986 a_4187_1764.t4 VSS 0.05514f ; **FLOATING
C6987 a_4187_1764.n91 VSS 0.09051f ; **FLOATING
C6988 a_4187_1764.t3 VSS 0.05514f ; **FLOATING
C6989 a_4187_1764.n92 VSS 0.09051f ; **FLOATING
C6990 a_4187_1764.t2 VSS 0.05514f ; **FLOATING
C6991 a_4187_1764.n93 VSS 0.24444f ; **FLOATING
C6992 a_4187_1764.t65 VSS 0.0568f ; **FLOATING
C6993 a_4187_1764.t64 VSS 0.05514f ; **FLOATING
C6994 a_4187_1764.n94 VSS 0.13048f ; **FLOATING
C6995 a_4187_1764.t63 VSS 0.05514f ; **FLOATING
C6996 a_4187_1764.n95 VSS 0.09051f ; **FLOATING
C6997 a_4187_1764.t62 VSS 0.05514f ; **FLOATING
C6998 a_4187_1764.n96 VSS 0.09051f ; **FLOATING
C6999 a_4187_1764.t61 VSS 0.05514f ; **FLOATING
C7000 a_4187_1764.n97 VSS 0.09051f ; **FLOATING
C7001 a_4187_1764.t60 VSS 0.05514f ; **FLOATING
C7002 a_4187_1764.n98 VSS 0.09051f ; **FLOATING
C7003 a_4187_1764.t59 VSS 0.05514f ; **FLOATING
C7004 a_4187_1764.n99 VSS 0.09051f ; **FLOATING
C7005 a_4187_1764.t58 VSS 0.05514f ; **FLOATING
C7006 a_4187_1764.n100 VSS 0.09051f ; **FLOATING
C7007 a_4187_1764.t57 VSS 0.05514f ; **FLOATING
C7008 a_4187_1764.n101 VSS 0.09051f ; **FLOATING
C7009 a_4187_1764.t56 VSS 0.05514f ; **FLOATING
C7010 a_4187_1764.n102 VSS 0.09051f ; **FLOATING
C7011 a_4187_1764.t55 VSS 0.05514f ; **FLOATING
C7012 a_4187_1764.n103 VSS 0.09051f ; **FLOATING
C7013 a_4187_1764.t54 VSS 0.05514f ; **FLOATING
C7014 a_4187_1764.n104 VSS 0.09051f ; **FLOATING
C7015 a_4187_1764.t53 VSS 0.05514f ; **FLOATING
C7016 a_4187_1764.n105 VSS 0.09051f ; **FLOATING
C7017 a_4187_1764.t52 VSS 0.05514f ; **FLOATING
C7018 a_4187_1764.n106 VSS 0.09051f ; **FLOATING
C7019 a_4187_1764.t51 VSS 0.05514f ; **FLOATING
C7020 a_4187_1764.n107 VSS 0.09051f ; **FLOATING
C7021 a_4187_1764.t50 VSS 0.05514f ; **FLOATING
C7022 a_4187_1764.n108 VSS 0.09051f ; **FLOATING
C7023 a_4187_1764.t49 VSS 0.05514f ; **FLOATING
C7024 a_4187_1764.n109 VSS 0.09051f ; **FLOATING
C7025 a_4187_1764.t48 VSS 0.05514f ; **FLOATING
C7026 a_4187_1764.n110 VSS 0.09051f ; **FLOATING
C7027 a_4187_1764.t47 VSS 0.05514f ; **FLOATING
C7028 a_4187_1764.n111 VSS 0.09051f ; **FLOATING
C7029 a_4187_1764.t46 VSS 0.05514f ; **FLOATING
C7030 a_4187_1764.n112 VSS 0.09051f ; **FLOATING
C7031 a_4187_1764.t45 VSS 0.05514f ; **FLOATING
C7032 a_4187_1764.n113 VSS 0.09051f ; **FLOATING
C7033 a_4187_1764.t44 VSS 0.05514f ; **FLOATING
C7034 a_4187_1764.n114 VSS 0.09051f ; **FLOATING
C7035 a_4187_1764.t43 VSS 0.05514f ; **FLOATING
C7036 a_4187_1764.n115 VSS 0.09051f ; **FLOATING
C7037 a_4187_1764.t42 VSS 0.05514f ; **FLOATING
C7038 a_4187_1764.n116 VSS 0.09051f ; **FLOATING
C7039 a_4187_1764.t41 VSS 0.05514f ; **FLOATING
C7040 a_4187_1764.n117 VSS 0.09051f ; **FLOATING
C7041 a_4187_1764.t40 VSS 0.05514f ; **FLOATING
C7042 a_4187_1764.n118 VSS 0.09051f ; **FLOATING
C7043 a_4187_1764.t39 VSS 0.05514f ; **FLOATING
C7044 a_4187_1764.n119 VSS 0.09051f ; **FLOATING
C7045 a_4187_1764.t38 VSS 0.05514f ; **FLOATING
C7046 a_4187_1764.n120 VSS 0.09051f ; **FLOATING
C7047 a_4187_1764.t37 VSS 0.05514f ; **FLOATING
C7048 a_4187_1764.n121 VSS 0.09051f ; **FLOATING
C7049 a_4187_1764.t36 VSS 0.05514f ; **FLOATING
C7050 a_4187_1764.n122 VSS 0.09051f ; **FLOATING
C7051 a_4187_1764.t35 VSS 0.05514f ; **FLOATING
C7052 a_4187_1764.n123 VSS 0.09051f ; **FLOATING
C7053 a_4187_1764.t34 VSS 0.05514f ; **FLOATING
C7054 a_4187_1764.n124 VSS 0.13594f ; **FLOATING
C7055 a_4187_1764.n125 VSS 0.6114f ; **FLOATING
C7056 a_4187_1764.t97 VSS 0.0568f ; **FLOATING
C7057 a_4187_1764.t96 VSS 0.05514f ; **FLOATING
C7058 a_4187_1764.n126 VSS 0.13048f ; **FLOATING
C7059 a_4187_1764.t95 VSS 0.05514f ; **FLOATING
C7060 a_4187_1764.n127 VSS 0.09051f ; **FLOATING
C7061 a_4187_1764.t94 VSS 0.05514f ; **FLOATING
C7062 a_4187_1764.n128 VSS 0.09051f ; **FLOATING
C7063 a_4187_1764.t93 VSS 0.05514f ; **FLOATING
C7064 a_4187_1764.n129 VSS 0.09051f ; **FLOATING
C7065 a_4187_1764.t92 VSS 0.05514f ; **FLOATING
C7066 a_4187_1764.n130 VSS 0.09051f ; **FLOATING
C7067 a_4187_1764.t91 VSS 0.05514f ; **FLOATING
C7068 a_4187_1764.n131 VSS 0.09051f ; **FLOATING
C7069 a_4187_1764.t90 VSS 0.05514f ; **FLOATING
C7070 a_4187_1764.n132 VSS 0.09051f ; **FLOATING
C7071 a_4187_1764.t89 VSS 0.05514f ; **FLOATING
C7072 a_4187_1764.n133 VSS 0.09051f ; **FLOATING
C7073 a_4187_1764.t88 VSS 0.05514f ; **FLOATING
C7074 a_4187_1764.n134 VSS 0.09051f ; **FLOATING
C7075 a_4187_1764.t87 VSS 0.05514f ; **FLOATING
C7076 a_4187_1764.n135 VSS 0.09051f ; **FLOATING
C7077 a_4187_1764.t86 VSS 0.05514f ; **FLOATING
C7078 a_4187_1764.n136 VSS 0.09051f ; **FLOATING
C7079 a_4187_1764.t85 VSS 0.05514f ; **FLOATING
C7080 a_4187_1764.n137 VSS 0.09051f ; **FLOATING
C7081 a_4187_1764.t84 VSS 0.05514f ; **FLOATING
C7082 a_4187_1764.n138 VSS 0.09051f ; **FLOATING
C7083 a_4187_1764.t83 VSS 0.05514f ; **FLOATING
C7084 a_4187_1764.n139 VSS 0.09051f ; **FLOATING
C7085 a_4187_1764.t82 VSS 0.05514f ; **FLOATING
C7086 a_4187_1764.n140 VSS 0.09051f ; **FLOATING
C7087 a_4187_1764.t81 VSS 0.05514f ; **FLOATING
C7088 a_4187_1764.n141 VSS 0.09051f ; **FLOATING
C7089 a_4187_1764.t80 VSS 0.05514f ; **FLOATING
C7090 a_4187_1764.n142 VSS 0.09051f ; **FLOATING
C7091 a_4187_1764.t79 VSS 0.05514f ; **FLOATING
C7092 a_4187_1764.n143 VSS 0.09051f ; **FLOATING
C7093 a_4187_1764.t78 VSS 0.05514f ; **FLOATING
C7094 a_4187_1764.n144 VSS 0.09051f ; **FLOATING
C7095 a_4187_1764.t77 VSS 0.05514f ; **FLOATING
C7096 a_4187_1764.n145 VSS 0.09051f ; **FLOATING
C7097 a_4187_1764.t76 VSS 0.05514f ; **FLOATING
C7098 a_4187_1764.n146 VSS 0.09051f ; **FLOATING
C7099 a_4187_1764.t75 VSS 0.05514f ; **FLOATING
C7100 a_4187_1764.n147 VSS 0.09051f ; **FLOATING
C7101 a_4187_1764.t74 VSS 0.05514f ; **FLOATING
C7102 a_4187_1764.n148 VSS 0.09051f ; **FLOATING
C7103 a_4187_1764.t73 VSS 0.05514f ; **FLOATING
C7104 a_4187_1764.n149 VSS 0.09051f ; **FLOATING
C7105 a_4187_1764.t72 VSS 0.05514f ; **FLOATING
C7106 a_4187_1764.n150 VSS 0.09051f ; **FLOATING
C7107 a_4187_1764.t71 VSS 0.05514f ; **FLOATING
C7108 a_4187_1764.n151 VSS 0.09051f ; **FLOATING
C7109 a_4187_1764.t70 VSS 0.05514f ; **FLOATING
C7110 a_4187_1764.n152 VSS 0.09051f ; **FLOATING
C7111 a_4187_1764.t69 VSS 0.05514f ; **FLOATING
C7112 a_4187_1764.n153 VSS 0.09051f ; **FLOATING
C7113 a_4187_1764.t68 VSS 0.05514f ; **FLOATING
C7114 a_4187_1764.n154 VSS 0.09051f ; **FLOATING
C7115 a_4187_1764.t67 VSS 0.05514f ; **FLOATING
C7116 a_4187_1764.n155 VSS 0.09051f ; **FLOATING
C7117 a_4187_1764.t66 VSS 0.05514f ; **FLOATING
C7118 a_4187_1764.n156 VSS 0.13594f ; **FLOATING
C7119 a_4187_1764.n157 VSS 0.34867f ; **FLOATING
C7120 a_4187_1764.n158 VSS 0.46719f ; **FLOATING
C7121 a_4187_1764.t99 VSS 0.05092f ; **FLOATING
C7122 a_4187_1764.n159 VSS 0.38721f ; **FLOATING
C7123 a_4187_1764.t1 VSS 0.01286f ; **FLOATING
C7124 a_4187_1764.n160 VSS 0.1315f ; **FLOATING
C7125 a_4187_1764.t0 VSS 0.03485f ; **FLOATING
C7126 a_2019_16074.t2 VSS 0.9303f ; **FLOATING
C7127 a_2019_16074.t3 VSS 0.70626f ; **FLOATING
C7128 a_2019_16074.n0 VSS 5.00904f ; **FLOATING
C7129 a_2019_16074.t4 VSS 0.70626f ; **FLOATING
C7130 a_2019_16074.n1 VSS 3.38875f ; **FLOATING
C7131 a_2019_16074.t5 VSS 0.70626f ; **FLOATING
C7132 a_2019_16074.n2 VSS 3.38875f ; **FLOATING
C7133 a_2019_16074.t6 VSS 0.70626f ; **FLOATING
C7134 a_2019_16074.n3 VSS 3.38875f ; **FLOATING
C7135 a_2019_16074.t7 VSS 0.70626f ; **FLOATING
C7136 a_2019_16074.n4 VSS 3.38875f ; **FLOATING
C7137 a_2019_16074.t8 VSS 0.70626f ; **FLOATING
C7138 a_2019_16074.n5 VSS 3.38875f ; **FLOATING
C7139 a_2019_16074.t9 VSS 5.45507f ; **FLOATING
C7140 a_2019_16074.t1 VSS 1.07262f ; **FLOATING
C7141 a_2019_16074.t0 VSS 0.30487f ; **FLOATING
C7142 a_2595_16074.t2 VSS 1.36719f ; **FLOATING
C7143 a_2595_16074.t3 VSS 1.02106f ; **FLOATING
C7144 a_2595_16074.n0 VSS 7.76213f ; **FLOATING
C7145 a_2595_16074.t4 VSS 1.02106f ; **FLOATING
C7146 a_2595_16074.n1 VSS 5.27401f ; **FLOATING
C7147 a_2595_16074.t5 VSS 1.02106f ; **FLOATING
C7148 a_2595_16074.n2 VSS 5.27401f ; **FLOATING
C7149 a_2595_16074.t6 VSS 1.02106f ; **FLOATING
C7150 a_2595_16074.n3 VSS 5.27401f ; **FLOATING
C7151 a_2595_16074.t7 VSS 1.02106f ; **FLOATING
C7152 a_2595_16074.n4 VSS 5.27401f ; **FLOATING
C7153 a_2595_16074.t8 VSS 1.02106f ; **FLOATING
C7154 a_2595_16074.n5 VSS 5.27401f ; **FLOATING
C7155 a_2595_16074.t9 VSS 1.02106f ; **FLOATING
C7156 a_2595_16074.n6 VSS 7.58635f ; **FLOATING
C7157 a_2595_16074.t1 VSS 1.75139f ; **FLOATING
C7158 a_2595_16074.t0 VSS 0.48232f ; **FLOATING
C7159 a_3171_16074.t2 VSS 1.38467f ; **FLOATING
C7160 a_3171_16074.t3 VSS 1.03752f ; **FLOATING
C7161 a_3171_16074.n0 VSS 7.77994f ; **FLOATING
C7162 a_3171_16074.t4 VSS 1.03752f ; **FLOATING
C7163 a_3171_16074.n1 VSS 5.28177f ; **FLOATING
C7164 a_3171_16074.t5 VSS 1.03752f ; **FLOATING
C7165 a_3171_16074.n2 VSS 5.28177f ; **FLOATING
C7166 a_3171_16074.t6 VSS 1.03752f ; **FLOATING
C7167 a_3171_16074.n3 VSS 5.28177f ; **FLOATING
C7168 a_3171_16074.t7 VSS 1.03752f ; **FLOATING
C7169 a_3171_16074.n4 VSS 5.28177f ; **FLOATING
C7170 a_3171_16074.t8 VSS 1.03752f ; **FLOATING
C7171 a_3171_16074.n5 VSS 5.28177f ; **FLOATING
C7172 a_3171_16074.t9 VSS 1.03752f ; **FLOATING
C7173 a_3171_16074.n6 VSS 7.68483f ; **FLOATING
C7174 a_3171_16074.t1 VSS 1.77058f ; **FLOATING
C7175 a_3171_16074.t0 VSS 0.48093f ; **FLOATING
C7176 a_3747_16074.t2 VSS 0.9701f ; **FLOATING
C7177 a_3747_16074.t3 VSS 0.73855f ; **FLOATING
C7178 a_3747_16074.n0 VSS 5.17414f ; **FLOATING
C7179 a_3747_16074.t4 VSS 0.73855f ; **FLOATING
C7180 a_3747_16074.n1 VSS 3.49765f ; **FLOATING
C7181 a_3747_16074.t5 VSS 0.73855f ; **FLOATING
C7182 a_3747_16074.n2 VSS 3.49765f ; **FLOATING
C7183 a_3747_16074.t6 VSS 0.73855f ; **FLOATING
C7184 a_3747_16074.n3 VSS 3.49765f ; **FLOATING
C7185 a_3747_16074.t7 VSS 0.73855f ; **FLOATING
C7186 a_3747_16074.n4 VSS 3.49765f ; **FLOATING
C7187 a_3747_16074.t8 VSS 0.73855f ; **FLOATING
C7188 a_3747_16074.n5 VSS 3.49765f ; **FLOATING
C7189 a_3747_16074.t9 VSS 0.73855f ; **FLOATING
C7190 a_3747_16074.n6 VSS 5.1936f ; **FLOATING
C7191 a_3747_16074.t1 VSS 1.18688f ; **FLOATING
C7192 a_3747_16074.t0 VSS 0.31378f ; **FLOATING
C7193 a_2019_15338.t2 VSS 4.07073f ; **FLOATING
C7194 a_2019_15338.t3 VSS 21.9073f ; **FLOATING
C7195 a_2019_15338.t1 VSS 1.98996f ; **FLOATING
C7196 a_2019_15338.t0 VSS 0.44681f ; **FLOATING
C7197 a_2595_15338.t1 VSS 3.29747f ; **FLOATING
C7198 a_2595_15338.t2 VSS 5.08323f ; **FLOATING
C7199 a_2595_15338.t3 VSS 1.21631f ; **FLOATING
C7200 a_2595_15338.n0 VSS 27.0895f ; **FLOATING
C7201 a_2595_15338.t0 VSS 0.49983f ; **FLOATING
C7202 a_3171_15338.t2 VSS 5.08303f ; **FLOATING
C7203 a_3171_15338.t3 VSS 1.21939f ; **FLOATING
C7204 a_3171_15338.n0 VSS 30.0446f ; **FLOATING
C7205 a_3171_15338.t1 VSS 4.64161f ; **FLOATING
C7206 a_3171_15338.t0 VSS 0.50055f ; **FLOATING
C7207 a_3747_15338.t2 VSS 3.11899f ; **FLOATING
C7208 a_3747_15338.t3 VSS 0.75071f ; **FLOATING
C7209 a_3747_15338.n0 VSS 20.062f ; **FLOATING
C7210 a_3747_15338.t1 VSS 3.72109f ; **FLOATING
C7211 a_3747_15338.t0 VSS 0.30803f ; **FLOATING
C7212 a_2019_13229.t2 VSS 0.93039f ; **FLOATING
C7213 a_2019_13229.t3 VSS 0.70633f ; **FLOATING
C7214 a_2019_13229.n0 VSS 5.00952f ; **FLOATING
C7215 a_2019_13229.t4 VSS 0.70633f ; **FLOATING
C7216 a_2019_13229.n1 VSS 3.38908f ; **FLOATING
C7217 a_2019_13229.t5 VSS 0.70633f ; **FLOATING
C7218 a_2019_13229.n2 VSS 3.38908f ; **FLOATING
C7219 a_2019_13229.t6 VSS 0.70633f ; **FLOATING
C7220 a_2019_13229.n3 VSS 3.38908f ; **FLOATING
C7221 a_2019_13229.t7 VSS 0.70633f ; **FLOATING
C7222 a_2019_13229.n4 VSS 3.38908f ; **FLOATING
C7223 a_2019_13229.t8 VSS 0.70633f ; **FLOATING
C7224 a_2019_13229.n5 VSS 3.38908f ; **FLOATING
C7225 a_2019_13229.t9 VSS 5.45559f ; **FLOATING
C7226 a_2019_13229.t1 VSS 1.07272f ; **FLOATING
C7227 a_2019_13229.t0 VSS 0.3049f ; **FLOATING
C7228 a_2595_13229.t2 VSS 1.36719f ; **FLOATING
C7229 a_2595_13229.t3 VSS 1.02107f ; **FLOATING
C7230 a_2595_13229.n0 VSS 7.76219f ; **FLOATING
C7231 a_2595_13229.t4 VSS 1.02107f ; **FLOATING
C7232 a_2595_13229.n1 VSS 5.27405f ; **FLOATING
C7233 a_2595_13229.t5 VSS 1.02107f ; **FLOATING
C7234 a_2595_13229.n2 VSS 5.27405f ; **FLOATING
C7235 a_2595_13229.t6 VSS 1.02107f ; **FLOATING
C7236 a_2595_13229.n3 VSS 5.27405f ; **FLOATING
C7237 a_2595_13229.t7 VSS 1.02107f ; **FLOATING
C7238 a_2595_13229.n4 VSS 5.27405f ; **FLOATING
C7239 a_2595_13229.t8 VSS 1.02107f ; **FLOATING
C7240 a_2595_13229.n5 VSS 5.27405f ; **FLOATING
C7241 a_2595_13229.t9 VSS 1.02107f ; **FLOATING
C7242 a_2595_13229.n6 VSS 7.5864f ; **FLOATING
C7243 a_2595_13229.t1 VSS 1.75141f ; **FLOATING
C7244 a_2595_13229.t0 VSS 0.48233f ; **FLOATING
C7245 a_3171_13229.t2 VSS 1.38481f ; **FLOATING
C7246 a_3171_13229.t3 VSS 1.03763f ; **FLOATING
C7247 a_3171_13229.n0 VSS 7.78073f ; **FLOATING
C7248 a_3171_13229.t4 VSS 1.03763f ; **FLOATING
C7249 a_3171_13229.n1 VSS 5.2823f ; **FLOATING
C7250 a_3171_13229.t5 VSS 1.03763f ; **FLOATING
C7251 a_3171_13229.n2 VSS 5.2823f ; **FLOATING
C7252 a_3171_13229.t6 VSS 1.03763f ; **FLOATING
C7253 a_3171_13229.n3 VSS 5.2823f ; **FLOATING
C7254 a_3171_13229.t7 VSS 1.03763f ; **FLOATING
C7255 a_3171_13229.n4 VSS 5.2823f ; **FLOATING
C7256 a_3171_13229.t8 VSS 1.03763f ; **FLOATING
C7257 a_3171_13229.n5 VSS 5.2823f ; **FLOATING
C7258 a_3171_13229.t9 VSS 1.03763f ; **FLOATING
C7259 a_3171_13229.n6 VSS 7.68561f ; **FLOATING
C7260 a_3171_13229.t1 VSS 1.77076f ; **FLOATING
C7261 a_3171_13229.t0 VSS 0.48098f ; **FLOATING
C7262 a_3747_13229.t2 VSS 0.96933f ; **FLOATING
C7263 a_3747_13229.t3 VSS 0.73797f ; **FLOATING
C7264 a_3747_13229.n0 VSS 5.17004f ; **FLOATING
C7265 a_3747_13229.t4 VSS 0.73797f ; **FLOATING
C7266 a_3747_13229.n1 VSS 3.49488f ; **FLOATING
C7267 a_3747_13229.t5 VSS 0.73797f ; **FLOATING
C7268 a_3747_13229.n2 VSS 3.49488f ; **FLOATING
C7269 a_3747_13229.t6 VSS 0.73797f ; **FLOATING
C7270 a_3747_13229.n3 VSS 3.49488f ; **FLOATING
C7271 a_3747_13229.t7 VSS 0.73797f ; **FLOATING
C7272 a_3747_13229.n4 VSS 3.49488f ; **FLOATING
C7273 a_3747_13229.t8 VSS 0.73797f ; **FLOATING
C7274 a_3747_13229.n5 VSS 3.49488f ; **FLOATING
C7275 a_3747_13229.t9 VSS 0.73797f ; **FLOATING
C7276 a_3747_13229.n6 VSS 5.18949f ; **FLOATING
C7277 a_3747_13229.t1 VSS 1.18594f ; **FLOATING
C7278 a_3747_13229.t0 VSS 0.31353f ; **FLOATING
C7279 a_2019_12493.t2 VSS 4.06273f ; **FLOATING
C7280 a_2019_12493.t3 VSS 21.8643f ; **FLOATING
C7281 a_2019_12493.t1 VSS 1.98604f ; **FLOATING
C7282 a_2019_12493.t0 VSS 0.44594f ; **FLOATING
C7283 a_2595_12493.t1 VSS 3.28552f ; **FLOATING
C7284 a_2595_12493.t2 VSS 5.06481f ; **FLOATING
C7285 a_2595_12493.t3 VSS 1.21191f ; **FLOATING
C7286 a_2595_12493.n0 VSS 26.9913f ; **FLOATING
C7287 a_2595_12493.t0 VSS 0.49802f ; **FLOATING
C7288 a_3171_12493.t2 VSS 5.06579f ; **FLOATING
C7289 a_3171_12493.t3 VSS 1.21526f ; **FLOATING
C7290 a_3171_12493.n0 VSS 29.9427f ; **FLOATING
C7291 a_3171_12493.t1 VSS 4.62587f ; **FLOATING
C7292 a_3171_12493.t0 VSS 0.49885f ; **FLOATING
C7293 a_3747_12493.t2 VSS 3.10423f ; **FLOATING
C7294 a_3747_12493.t3 VSS 0.74716f ; **FLOATING
C7295 a_3747_12493.n0 VSS 19.967f ; **FLOATING
C7296 a_3747_12493.t1 VSS 3.70349f ; **FLOATING
C7297 a_3747_12493.t0 VSS 0.30657f ; **FLOATING
C7298 a_2019_6737.t2 VSS 0.93041f ; **FLOATING
C7299 a_2019_6737.t3 VSS 0.70634f ; **FLOATING
C7300 a_2019_6737.n0 VSS 5.00958f ; **FLOATING
C7301 a_2019_6737.t4 VSS 0.70634f ; **FLOATING
C7302 a_2019_6737.n1 VSS 3.38912f ; **FLOATING
C7303 a_2019_6737.t5 VSS 0.70634f ; **FLOATING
C7304 a_2019_6737.n2 VSS 3.38912f ; **FLOATING
C7305 a_2019_6737.t6 VSS 0.70634f ; **FLOATING
C7306 a_2019_6737.n3 VSS 3.38912f ; **FLOATING
C7307 a_2019_6737.t7 VSS 0.70634f ; **FLOATING
C7308 a_2019_6737.n4 VSS 3.38912f ; **FLOATING
C7309 a_2019_6737.t8 VSS 0.70634f ; **FLOATING
C7310 a_2019_6737.n5 VSS 3.38912f ; **FLOATING
C7311 a_2019_6737.t9 VSS 5.45566f ; **FLOATING
C7312 a_2019_6737.t1 VSS 1.07273f ; **FLOATING
C7313 a_2019_6737.t0 VSS 0.3049f ; **FLOATING
C7314 a_2595_6737.t2 VSS 1.36719f ; **FLOATING
C7315 a_2595_6737.t3 VSS 1.02106f ; **FLOATING
C7316 a_2595_6737.n0 VSS 7.76216f ; **FLOATING
C7317 a_2595_6737.t4 VSS 1.02106f ; **FLOATING
C7318 a_2595_6737.n1 VSS 5.27403f ; **FLOATING
C7319 a_2595_6737.t5 VSS 1.02106f ; **FLOATING
C7320 a_2595_6737.n2 VSS 5.27403f ; **FLOATING
C7321 a_2595_6737.t6 VSS 1.02106f ; **FLOATING
C7322 a_2595_6737.n3 VSS 5.27403f ; **FLOATING
C7323 a_2595_6737.t7 VSS 1.02106f ; **FLOATING
C7324 a_2595_6737.n4 VSS 5.27403f ; **FLOATING
C7325 a_2595_6737.t8 VSS 1.02106f ; **FLOATING
C7326 a_2595_6737.n5 VSS 5.27403f ; **FLOATING
C7327 a_2595_6737.t9 VSS 1.02106f ; **FLOATING
C7328 a_2595_6737.n6 VSS 7.58638f ; **FLOATING
C7329 a_2595_6737.t1 VSS 1.7514f ; **FLOATING
C7330 a_2595_6737.t0 VSS 0.48233f ; **FLOATING
C7331 a_3171_6737.t2 VSS 1.38468f ; **FLOATING
C7332 a_3171_6737.t3 VSS 1.03753f ; **FLOATING
C7333 a_3171_6737.n0 VSS 7.78f ; **FLOATING
C7334 a_3171_6737.t4 VSS 1.03753f ; **FLOATING
C7335 a_3171_6737.n1 VSS 5.2818f ; **FLOATING
C7336 a_3171_6737.t5 VSS 1.03753f ; **FLOATING
C7337 a_3171_6737.n2 VSS 5.2818f ; **FLOATING
C7338 a_3171_6737.t6 VSS 1.03753f ; **FLOATING
C7339 a_3171_6737.n3 VSS 5.2818f ; **FLOATING
C7340 a_3171_6737.t7 VSS 1.03753f ; **FLOATING
C7341 a_3171_6737.n4 VSS 5.2818f ; **FLOATING
C7342 a_3171_6737.t8 VSS 1.03753f ; **FLOATING
C7343 a_3171_6737.n5 VSS 5.2818f ; **FLOATING
C7344 a_3171_6737.t9 VSS 1.03753f ; **FLOATING
C7345 a_3171_6737.n6 VSS 7.68489f ; **FLOATING
C7346 a_3171_6737.t1 VSS 1.77059f ; **FLOATING
C7347 a_3171_6737.t0 VSS 0.48093f ; **FLOATING
C7348 a_3747_6737.t2 VSS 0.97011f ; **FLOATING
C7349 a_3747_6737.t3 VSS 0.73856f ; **FLOATING
C7350 a_3747_6737.n0 VSS 5.17418f ; **FLOATING
C7351 a_3747_6737.t4 VSS 0.73856f ; **FLOATING
C7352 a_3747_6737.n1 VSS 3.49768f ; **FLOATING
C7353 a_3747_6737.t5 VSS 0.73856f ; **FLOATING
C7354 a_3747_6737.n2 VSS 3.49768f ; **FLOATING
C7355 a_3747_6737.t6 VSS 0.73856f ; **FLOATING
C7356 a_3747_6737.n3 VSS 3.49768f ; **FLOATING
C7357 a_3747_6737.t7 VSS 0.73856f ; **FLOATING
C7358 a_3747_6737.n4 VSS 3.49768f ; **FLOATING
C7359 a_3747_6737.t8 VSS 0.73856f ; **FLOATING
C7360 a_3747_6737.n5 VSS 3.49768f ; **FLOATING
C7361 a_3747_6737.t9 VSS 0.73856f ; **FLOATING
C7362 a_3747_6737.n6 VSS 5.19364f ; **FLOATING
C7363 a_3747_6737.t1 VSS 1.18689f ; **FLOATING
C7364 a_3747_6737.t0 VSS 0.31378f ; **FLOATING
C7365 a_2019_6001.t2 VSS 4.07073f ; **FLOATING
C7366 a_2019_6001.t3 VSS 21.9073f ; **FLOATING
C7367 a_2019_6001.t1 VSS 1.98996f ; **FLOATING
C7368 a_2019_6001.t0 VSS 0.44681f ; **FLOATING
C7369 a_2595_6001.t1 VSS 3.29747f ; **FLOATING
C7370 a_2595_6001.t2 VSS 5.08323f ; **FLOATING
C7371 a_2595_6001.t3 VSS 1.21631f ; **FLOATING
C7372 a_2595_6001.n0 VSS 27.0895f ; **FLOATING
C7373 a_2595_6001.t0 VSS 0.49983f ; **FLOATING
C7374 a_3171_6001.t2 VSS 5.08303f ; **FLOATING
C7375 a_3171_6001.t3 VSS 1.21939f ; **FLOATING
C7376 a_3171_6001.n0 VSS 30.0446f ; **FLOATING
C7377 a_3171_6001.t1 VSS 4.64161f ; **FLOATING
C7378 a_3171_6001.t0 VSS 0.50055f ; **FLOATING
C7379 a_3747_6001.t2 VSS 3.11899f ; **FLOATING
C7380 a_3747_6001.t3 VSS 0.75071f ; **FLOATING
C7381 a_3747_6001.n0 VSS 20.062f ; **FLOATING
C7382 a_3747_6001.t1 VSS 3.72109f ; **FLOATING
C7383 a_3747_6001.t0 VSS 0.30803f ; **FLOATING
C7384 a_2019_3892.t2 VSS 0.93043f ; **FLOATING
C7385 a_2019_3892.t3 VSS 0.70635f ; **FLOATING
C7386 a_2019_3892.n0 VSS 5.00969f ; **FLOATING
C7387 a_2019_3892.t4 VSS 0.70635f ; **FLOATING
C7388 a_2019_3892.n1 VSS 3.38919f ; **FLOATING
C7389 a_2019_3892.t5 VSS 0.70635f ; **FLOATING
C7390 a_2019_3892.n2 VSS 3.38919f ; **FLOATING
C7391 a_2019_3892.t6 VSS 0.70635f ; **FLOATING
C7392 a_2019_3892.n3 VSS 3.38919f ; **FLOATING
C7393 a_2019_3892.t7 VSS 0.70635f ; **FLOATING
C7394 a_2019_3892.n4 VSS 3.38919f ; **FLOATING
C7395 a_2019_3892.t8 VSS 0.70635f ; **FLOATING
C7396 a_2019_3892.n5 VSS 3.38919f ; **FLOATING
C7397 a_2019_3892.t9 VSS 5.45578f ; **FLOATING
C7398 a_2019_3892.t1 VSS 1.07276f ; **FLOATING
C7399 a_2019_3892.t0 VSS 0.30491f ; **FLOATING
C7400 a_2595_3892.t2 VSS 1.36722f ; **FLOATING
C7401 a_2595_3892.t3 VSS 1.02108f ; **FLOATING
C7402 a_2595_3892.n0 VSS 7.76233f ; **FLOATING
C7403 a_2595_3892.t4 VSS 1.02108f ; **FLOATING
C7404 a_2595_3892.n1 VSS 5.27415f ; **FLOATING
C7405 a_2595_3892.t5 VSS 1.02108f ; **FLOATING
C7406 a_2595_3892.n2 VSS 5.27415f ; **FLOATING
C7407 a_2595_3892.t6 VSS 1.02108f ; **FLOATING
C7408 a_2595_3892.n3 VSS 5.27415f ; **FLOATING
C7409 a_2595_3892.t7 VSS 1.02108f ; **FLOATING
C7410 a_2595_3892.n4 VSS 5.27415f ; **FLOATING
C7411 a_2595_3892.t8 VSS 1.02108f ; **FLOATING
C7412 a_2595_3892.n5 VSS 5.27415f ; **FLOATING
C7413 a_2595_3892.t9 VSS 1.02108f ; **FLOATING
C7414 a_2595_3892.n6 VSS 7.58654f ; **FLOATING
C7415 a_2595_3892.t1 VSS 1.75144f ; **FLOATING
C7416 a_2595_3892.t0 VSS 0.48234f ; **FLOATING
C7417 a_3171_3892.t2 VSS 1.38485f ; **FLOATING
C7418 a_3171_3892.t3 VSS 1.03766f ; **FLOATING
C7419 a_3171_3892.n0 VSS 7.781f ; **FLOATING
C7420 a_3171_3892.t4 VSS 1.03766f ; **FLOATING
C7421 a_3171_3892.n1 VSS 5.28249f ; **FLOATING
C7422 a_3171_3892.t5 VSS 1.03766f ; **FLOATING
C7423 a_3171_3892.n2 VSS 5.28249f ; **FLOATING
C7424 a_3171_3892.t6 VSS 1.03766f ; **FLOATING
C7425 a_3171_3892.n3 VSS 5.28249f ; **FLOATING
C7426 a_3171_3892.t7 VSS 1.03766f ; **FLOATING
C7427 a_3171_3892.n4 VSS 5.28249f ; **FLOATING
C7428 a_3171_3892.t8 VSS 1.03766f ; **FLOATING
C7429 a_3171_3892.n5 VSS 5.28249f ; **FLOATING
C7430 a_3171_3892.t9 VSS 1.03766f ; **FLOATING
C7431 a_3171_3892.n6 VSS 7.68588f ; **FLOATING
C7432 a_3171_3892.t1 VSS 1.77082f ; **FLOATING
C7433 a_3171_3892.t0 VSS 0.48099f ; **FLOATING
C7434 a_3747_3892.t2 VSS 0.97022f ; **FLOATING
C7435 a_3747_3892.t3 VSS 0.73864f ; **FLOATING
C7436 a_3747_3892.n0 VSS 5.17474f ; **FLOATING
C7437 a_3747_3892.t4 VSS 0.73864f ; **FLOATING
C7438 a_3747_3892.n1 VSS 3.49805f ; **FLOATING
C7439 a_3747_3892.t5 VSS 0.73864f ; **FLOATING
C7440 a_3747_3892.n2 VSS 3.49805f ; **FLOATING
C7441 a_3747_3892.t6 VSS 0.73864f ; **FLOATING
C7442 a_3747_3892.n3 VSS 3.49805f ; **FLOATING
C7443 a_3747_3892.t7 VSS 0.73864f ; **FLOATING
C7444 a_3747_3892.n4 VSS 3.49805f ; **FLOATING
C7445 a_3747_3892.t8 VSS 0.73864f ; **FLOATING
C7446 a_3747_3892.n5 VSS 3.49805f ; **FLOATING
C7447 a_3747_3892.t9 VSS 0.73864f ; **FLOATING
C7448 a_3747_3892.n6 VSS 5.1942f ; **FLOATING
C7449 a_3747_3892.t1 VSS 1.18702f ; **FLOATING
C7450 a_3747_3892.t0 VSS 0.31382f ; **FLOATING
C7451 a_2019_3156.t2 VSS 4.07073f ; **FLOATING
C7452 a_2019_3156.t3 VSS 21.9073f ; **FLOATING
C7453 a_2019_3156.t1 VSS 1.98996f ; **FLOATING
C7454 a_2019_3156.t0 VSS 0.44681f ; **FLOATING
C7455 a_2595_3156.t1 VSS 3.29747f ; **FLOATING
C7456 a_2595_3156.t2 VSS 5.08323f ; **FLOATING
C7457 a_2595_3156.t3 VSS 1.21631f ; **FLOATING
C7458 a_2595_3156.n0 VSS 27.0895f ; **FLOATING
C7459 a_2595_3156.t0 VSS 0.49983f ; **FLOATING
C7460 a_3171_3156.t2 VSS 5.08303f ; **FLOATING
C7461 a_3171_3156.t3 VSS 1.21939f ; **FLOATING
C7462 a_3171_3156.n0 VSS 30.0446f ; **FLOATING
C7463 a_3171_3156.t1 VSS 4.64161f ; **FLOATING
C7464 a_3171_3156.t0 VSS 0.50055f ; **FLOATING
C7465 a_3747_3156.t2 VSS 3.11899f ; **FLOATING
C7466 a_3747_3156.t3 VSS 0.75071f ; **FLOATING
C7467 a_3747_3156.n0 VSS 20.062f ; **FLOATING
C7468 a_3747_3156.t1 VSS 3.72109f ; **FLOATING
C7469 a_3747_3156.t0 VSS 0.30803f ; **FLOATING
C7470 a_2019_1047.t2 VSS 0.83355f ; **FLOATING
C7471 a_2019_1047.t3 VSS 0.63281f ; **FLOATING
C7472 a_2019_1047.n0 VSS 4.48811f ; **FLOATING
C7473 a_2019_1047.t4 VSS 0.63281f ; **FLOATING
C7474 a_2019_1047.n1 VSS 3.03633f ; **FLOATING
C7475 a_2019_1047.t5 VSS 0.63281f ; **FLOATING
C7476 a_2019_1047.n2 VSS 3.03633f ; **FLOATING
C7477 a_2019_1047.t6 VSS 0.63281f ; **FLOATING
C7478 a_2019_1047.n3 VSS 3.03633f ; **FLOATING
C7479 a_2019_1047.t7 VSS 0.63281f ; **FLOATING
C7480 a_2019_1047.n4 VSS 3.03633f ; **FLOATING
C7481 a_2019_1047.t8 VSS 3.66914f ; **FLOATING
C7482 a_2019_1047.t9 VSS 4.88776f ; **FLOATING
C7483 a_2019_1047.t1 VSS 0.96107f ; **FLOATING
C7484 a_2019_1047.t0 VSS 0.27316f ; **FLOATING
C7485 a_2595_1047.t2 VSS 1.36608f ; **FLOATING
C7486 a_2595_1047.t3 VSS 1.02023f ; **FLOATING
C7487 a_2595_1047.n0 VSS 7.75584f ; **FLOATING
C7488 a_2595_1047.t4 VSS 1.02023f ; **FLOATING
C7489 a_2595_1047.n1 VSS 5.26973f ; **FLOATING
C7490 a_2595_1047.t5 VSS 1.02023f ; **FLOATING
C7491 a_2595_1047.n2 VSS 5.26973f ; **FLOATING
C7492 a_2595_1047.t6 VSS 1.02023f ; **FLOATING
C7493 a_2595_1047.n3 VSS 5.26973f ; **FLOATING
C7494 a_2595_1047.t7 VSS 1.02023f ; **FLOATING
C7495 a_2595_1047.n4 VSS 5.26973f ; **FLOATING
C7496 a_2595_1047.t8 VSS 1.02023f ; **FLOATING
C7497 a_2595_1047.n5 VSS 5.26973f ; **FLOATING
C7498 a_2595_1047.t9 VSS 1.02023f ; **FLOATING
C7499 a_2595_1047.n6 VSS 7.5802f ; **FLOATING
C7500 a_2595_1047.t1 VSS 1.74997f ; **FLOATING
C7501 a_2595_1047.t0 VSS 0.48193f ; **FLOATING
C7502 a_3171_1047.t2 VSS 1.39011f ; **FLOATING
C7503 a_3171_1047.t3 VSS 1.0416f ; **FLOATING
C7504 a_3171_1047.n0 VSS 7.81054f ; **FLOATING
C7505 a_3171_1047.t4 VSS 1.0416f ; **FLOATING
C7506 a_3171_1047.n1 VSS 5.30254f ; **FLOATING
C7507 a_3171_1047.t5 VSS 1.0416f ; **FLOATING
C7508 a_3171_1047.n2 VSS 5.30254f ; **FLOATING
C7509 a_3171_1047.t6 VSS 1.0416f ; **FLOATING
C7510 a_3171_1047.n3 VSS 5.30254f ; **FLOATING
C7511 a_3171_1047.t7 VSS 1.0416f ; **FLOATING
C7512 a_3171_1047.n4 VSS 5.30254f ; **FLOATING
C7513 a_3171_1047.t8 VSS 1.0416f ; **FLOATING
C7514 a_3171_1047.n5 VSS 5.30254f ; **FLOATING
C7515 a_3171_1047.t9 VSS 1.0416f ; **FLOATING
C7516 a_3171_1047.n6 VSS 7.71506f ; **FLOATING
C7517 a_3171_1047.t1 VSS 1.77754f ; **FLOATING
C7518 a_3171_1047.t0 VSS 0.48282f ; **FLOATING
C7519 a_3747_1047.t2 VSS 1.01419f ; **FLOATING
C7520 a_3747_1047.t3 VSS 0.77211f ; **FLOATING
C7521 a_3747_1047.n0 VSS 5.40927f ; **FLOATING
C7522 a_3747_1047.t4 VSS 0.77211f ; **FLOATING
C7523 a_3747_1047.n1 VSS 3.6566f ; **FLOATING
C7524 a_3747_1047.t5 VSS 0.77211f ; **FLOATING
C7525 a_3747_1047.n2 VSS 3.6566f ; **FLOATING
C7526 a_3747_1047.t6 VSS 0.77211f ; **FLOATING
C7527 a_3747_1047.n3 VSS 3.6566f ; **FLOATING
C7528 a_3747_1047.t7 VSS 0.77211f ; **FLOATING
C7529 a_3747_1047.n4 VSS 3.6566f ; **FLOATING
C7530 a_3747_1047.t8 VSS 0.77211f ; **FLOATING
C7531 a_3747_1047.n5 VSS 3.6566f ; **FLOATING
C7532 a_3747_1047.t9 VSS 0.77211f ; **FLOATING
C7533 a_3747_1047.n6 VSS 5.42962f ; **FLOATING
C7534 a_3747_1047.t1 VSS 1.24082f ; **FLOATING
C7535 a_3747_1047.t0 VSS 0.32804f ; **FLOATING
C7536 a_2019_311.t2 VSS 4.06407f ; **FLOATING
C7537 a_2019_311.t3 VSS 21.8715f ; **FLOATING
C7538 a_2019_311.t1 VSS 1.9867f ; **FLOATING
C7539 a_2019_311.t0 VSS 0.44608f ; **FLOATING
C7540 a_2595_311.t1 VSS 3.27636f ; **FLOATING
C7541 a_2595_311.t2 VSS 5.05069f ; **FLOATING
C7542 a_2595_311.t3 VSS 1.20853f ; **FLOATING
C7543 a_2595_311.n0 VSS 26.916f ; **FLOATING
C7544 a_2595_311.t0 VSS 0.49663f ; **FLOATING
C7545 a_3171_311.t2 VSS 5.08446f ; **FLOATING
C7546 a_3171_311.t3 VSS 1.21974f ; **FLOATING
C7547 a_3171_311.n0 VSS 30.0531f ; **FLOATING
C7548 a_3171_311.t1 VSS 4.64292f ; **FLOATING
C7549 a_3171_311.t0 VSS 0.50069f ; **FLOATING
C7550 a_3747_311.t2 VSS 3.83974f ; **FLOATING
C7551 a_3747_311.t3 VSS 0.92419f ; **FLOATING
C7552 a_3747_311.n0 VSS 24.698f ; **FLOATING
C7553 a_3747_311.t1 VSS 4.58098f ; **FLOATING
C7554 a_3747_311.t0 VSS 0.37921f ; **FLOATING
C7555 VSS.t2253 VSS 3.22049f ; **FLOATING
C7556 VDD.n0 VSS 0.03924f ; **FLOATING
C7557 VDD.n1 VSS 1.20416f ; **FLOATING
C7558 VDD.n2 VSS 0.03209f ; **FLOATING
C7559 VDD.n3 VSS 0.03924f ; **FLOATING
C7560 VDD.n4 VSS 1.20416f ; **FLOATING
C7561 VDD.n5 VSS 0.03209f ; **FLOATING
C7562 VDD.n6 VSS 0.03924f ; **FLOATING
C7563 VDD.n7 VSS 1.20419f ; **FLOATING
C7564 VDD.n8 VSS 0.03213f ; **FLOATING
C7565 VDD.n9 VSS 1.20419f ; **FLOATING
C7566 VDD.n10 VSS 0.03213f ; **FLOATING
C7567 VDD.n11 VSS 0.50039f ; **FLOATING
C7568 VDD.n12 VSS 0.04506f ; **FLOATING
C7569 VDD.t7 VSS 53.279f ; **FLOATING
C7570 VDD.n13 VSS 0.50039f ; **FLOATING
C7571 VDD.n14 VSS 0.50039f ; **FLOATING
C7572 VDD.n15 VSS 0.04506f ; **FLOATING
C7573 VDD.n16 VSS 0.50039f ; **FLOATING
C7574 VDD.n17 VSS 0.50039f ; **FLOATING
C7575 VDD.n18 VSS 0.50039f ; **FLOATING
C7576 VDD.n19 VSS 0.04506f ; **FLOATING
C7577 VDD.t0 VSS 53.279f ; **FLOATING
C7578 VDD.n20 VSS 0.50039f ; **FLOATING
C7579 VDD.n21 VSS 0.50039f ; **FLOATING
C7580 VDD.n22 VSS 0.04506f ; **FLOATING
C7581 VDD.n23 VSS 0.50039f ; **FLOATING
C7582 VDD.n24 VSS 0.50039f ; **FLOATING
C7583 VDD.n25 VSS 0.50039f ; **FLOATING
C7584 VDD.n26 VSS 0.04506f ; **FLOATING
C7585 VDD.t41 VSS 53.279f ; **FLOATING
C7586 VDD.n27 VSS 0.50039f ; **FLOATING
C7587 VDD.n28 VSS 0.50039f ; **FLOATING
C7588 VDD.n29 VSS 0.04506f ; **FLOATING
C7589 VDD.n30 VSS 0.50039f ; **FLOATING
C7590 VDD.n31 VSS 0.50039f ; **FLOATING
C7591 VDD.n32 VSS 0.50039f ; **FLOATING
C7592 VDD.n33 VSS 0.04506f ; **FLOATING
C7593 VDD.t50 VSS 53.279f ; **FLOATING
C7594 VDD.n34 VSS 0.50039f ; **FLOATING
C7595 VDD.n35 VSS 0.50039f ; **FLOATING
C7596 VDD.n36 VSS 0.04506f ; **FLOATING
C7597 VDD.n37 VSS 0.50039f ; **FLOATING
C7598 VDD.n38 VSS 0.50039f ; **FLOATING
C7599 VDD.n39 VSS 0.50039f ; **FLOATING
C7600 VDD.n40 VSS 0.04506f ; **FLOATING
C7601 VDD.t4 VSS 53.279f ; **FLOATING
C7602 VDD.n41 VSS 0.50039f ; **FLOATING
C7603 VDD.n42 VSS 0.50039f ; **FLOATING
C7604 VDD.n43 VSS 0.04506f ; **FLOATING
C7605 VDD.n44 VSS 0.50039f ; **FLOATING
C7606 VDD.n45 VSS 0.50039f ; **FLOATING
C7607 VDD.n46 VSS 0.50039f ; **FLOATING
C7608 VDD.n47 VSS 0.50039f ; **FLOATING
C7609 VDD.n48 VSS 0.50039f ; **FLOATING
C7610 VDD.n49 VSS 0.50039f ; **FLOATING
C7611 VDD.n50 VSS 0.50039f ; **FLOATING
C7612 VDD.n51 VSS 0.08201f ; **FLOATING
C7613 VDD.n52 VSS 0.43116f ; **FLOATING
C7614 VDD.n54 VSS 0.08201f ; **FLOATING
C7615 VDD.n55 VSS 0.43116f ; **FLOATING
C7616 VDD.n57 VSS 0.08201f ; **FLOATING
C7617 VDD.n58 VSS 0.43116f ; **FLOATING
C7618 VDD.n60 VSS 0.08201f ; **FLOATING
C7619 VDD.n61 VSS 0.43116f ; **FLOATING
C7620 VDD.n63 VSS 0.08201f ; **FLOATING
C7621 VDD.n64 VSS 0.43116f ; **FLOATING
C7622 VDD.n66 VSS 0.01954f ; **FLOATING
C7623 VDD.n67 VSS 0.71497f ; **FLOATING
C7624 VDD.n68 VSS 0.38927f ; **FLOATING
C7625 VDD.n70 VSS 0.38927f ; **FLOATING
C7626 VDD.n72 VSS 0.38926f ; **FLOATING
C7627 VDD.n74 VSS 0.38926f ; **FLOATING
C7628 VDD.n76 VSS 0.38926f ; **FLOATING
C7629 VDD.n78 VSS 0.47737f ; **FLOATING
C7630 VDD.n79 VSS 0.14514f ; **FLOATING
C7631 VDD.n80 VSS 0.47737f ; **FLOATING
C7632 VDD.n81 VSS 0.14514f ; **FLOATING
C7633 VDD.n82 VSS 0.47737f ; **FLOATING
C7634 VDD.n84 VSS 0.47737f ; **FLOATING
C7635 VDD.n85 VSS 0.14514f ; **FLOATING
C7636 VDD.n86 VSS 0.47737f ; **FLOATING
C7637 VDD.n87 VSS 0.14514f ; **FLOATING
C7638 VDD.n88 VSS 0.47737f ; **FLOATING
C7639 VDD.n89 VSS 0.47737f ; **FLOATING
C7640 VDD.n90 VSS 0.14514f ; **FLOATING
C7641 VDD.n91 VSS 0.47737f ; **FLOATING
C7642 VDD.n92 VSS 0.14514f ; **FLOATING
C7643 VDD.n93 VSS 0.47737f ; **FLOATING
C7644 VDD.n95 VSS 0.47737f ; **FLOATING
C7645 VDD.n96 VSS 0.14514f ; **FLOATING
C7646 VDD.n97 VSS 0.47737f ; **FLOATING
C7647 VDD.n98 VSS 0.14514f ; **FLOATING
C7648 VDD.n99 VSS 0.47737f ; **FLOATING
C7649 VDD.n100 VSS 0.47737f ; **FLOATING
C7650 VDD.n101 VSS 0.14514f ; **FLOATING
C7651 VDD.n102 VSS 0.47737f ; **FLOATING
C7652 VDD.n103 VSS 0.14514f ; **FLOATING
C7653 VDD.n104 VSS 0.47737f ; **FLOATING
C7654 VDD.n106 VSS 0.47737f ; **FLOATING
C7655 VDD.n107 VSS 0.14514f ; **FLOATING
C7656 VDD.n108 VSS 0.47737f ; **FLOATING
C7657 VDD.n109 VSS 0.14514f ; **FLOATING
C7658 VDD.n110 VSS 0.47737f ; **FLOATING
C7659 VDD.n111 VSS 0.47737f ; **FLOATING
C7660 VDD.n112 VSS 0.14514f ; **FLOATING
C7661 VDD.n113 VSS 0.47737f ; **FLOATING
C7662 VDD.n114 VSS 0.14514f ; **FLOATING
C7663 VDD.n115 VSS 0.47737f ; **FLOATING
C7664 VDD.n117 VSS 0.47737f ; **FLOATING
C7665 VDD.n118 VSS 0.14514f ; **FLOATING
C7666 VDD.n119 VSS 0.47737f ; **FLOATING
C7667 VDD.n120 VSS 0.14514f ; **FLOATING
C7668 VDD.n121 VSS 0.47737f ; **FLOATING
C7669 VDD.n122 VSS 0.47737f ; **FLOATING
C7670 VDD.n123 VSS 0.14514f ; **FLOATING
C7671 VDD.n124 VSS 0.47737f ; **FLOATING
C7672 VDD.n125 VSS 0.14514f ; **FLOATING
C7673 VDD.n126 VSS 0.47737f ; **FLOATING
C7674 VDD.n128 VSS 0.47737f ; **FLOATING
C7675 VDD.n129 VSS 0.14514f ; **FLOATING
C7676 VDD.n130 VSS 0.47737f ; **FLOATING
C7677 VDD.n131 VSS 0.14514f ; **FLOATING
C7678 VDD.n132 VSS 0.47737f ; **FLOATING
C7679 VDD.n133 VSS 0.28021f ; **FLOATING
C7680 VDD.n134 VSS 0.28021f ; **FLOATING
C7681 VDD.n135 VSS 0.28021f ; **FLOATING
C7682 VDD.n136 VSS 0.28021f ; **FLOATING
C7683 VDD.n137 VSS 0.28021f ; **FLOATING
C7684 VDD.n138 VSS 0.24517f ; **FLOATING
C7685 VDD.n140 VSS 1.16662f ; **FLOATING
C7686 VDD.n141 VSS 1.16662f ; **FLOATING
C7687 VDD.n142 VSS 1.72169f ; **FLOATING
C7688 VDD.n143 VSS 1.16662f ; **FLOATING
C7689 VDD.n144 VSS 0.03924f ; **FLOATING
C7690 VDD.n145 VSS 0.02254f ; **FLOATING
C7691 VDD.n146 VSS 0.02021f ; **FLOATING
C7692 VDD.t297 VSS 46.6912f ; **FLOATING
C7693 VDD.n147 VSS 0.01801f ; **FLOATING
C7694 VDD.n148 VSS 0.64548f ; **FLOATING
C7695 VDD.t301 VSS 46.6912f ; **FLOATING
C7696 VDD.t275 VSS 46.6912f ; **FLOATING
C7697 VDD.t281 VSS 46.6912f ; **FLOATING
C7698 VDD.t399 VSS 46.6912f ; **FLOATING
C7699 VDD.n149 VSS 0.06615f ; **FLOATING
C7700 VDD.n150 VSS 0.14514f ; **FLOATING
C7701 VDD.n151 VSS 0.14514f ; **FLOATING
C7702 VDD.n152 VSS 0.06615f ; **FLOATING
C7703 VDD.n153 VSS 0.14514f ; **FLOATING
C7704 VDD.n154 VSS 0.14514f ; **FLOATING
C7705 VDD.n155 VSS 0.06615f ; **FLOATING
C7706 VDD.n156 VSS 0.14514f ; **FLOATING
C7707 VDD.n157 VSS 0.14514f ; **FLOATING
C7708 VDD.n158 VSS 0.06615f ; **FLOATING
C7709 VDD.n159 VSS 0.14514f ; **FLOATING
C7710 VDD.n160 VSS 0.14514f ; **FLOATING
C7711 VDD.n161 VSS 0.06615f ; **FLOATING
C7712 VDD.n162 VSS 0.14514f ; **FLOATING
C7713 VDD.n163 VSS 0.14514f ; **FLOATING
C7714 VDD.n164 VSS 0.03317f ; **FLOATING
C7715 VDD.t781 VSS 0.01996f ; **FLOATING
C7716 VDD.n165 VSS 0.02684f ; **FLOATING
C7717 VDD.n166 VSS 0.08252f ; **FLOATING
C7718 VDD.n167 VSS 0.02684f ; **FLOATING
C7719 VDD.n168 VSS 0.08252f ; **FLOATING
C7720 VDD.n169 VSS 0.0269f ; **FLOATING
C7721 VDD.n170 VSS 0.08247f ; **FLOATING
C7722 VDD.n171 VSS 0.0269f ; **FLOATING
C7723 VDD.n172 VSS 0.08247f ; **FLOATING
C7724 VDD.n173 VSS 0.02693f ; **FLOATING
C7725 VDD.n174 VSS 0.08246f ; **FLOATING
C7726 VDD.n175 VSS 0.02284f ; **FLOATING
C7727 VDD.n176 VSS 0.02515f ; **FLOATING
C7728 VDD.n177 VSS 0.01685f ; **FLOATING
C7729 VDD.n178 VSS 0.10917f ; **FLOATING
C7730 VDD.n184 VSS 0.16097f ; **FLOATING
C7731 VDD.n185 VSS 0.0148f ; **FLOATING
C7732 VDD.n186 VSS 0.16097f ; **FLOATING
C7733 VDD.n187 VSS 0.0148f ; **FLOATING
C7734 VDD.n188 VSS 0.16097f ; **FLOATING
C7735 VDD.n189 VSS 0.0148f ; **FLOATING
C7736 VDD.n190 VSS 0.16097f ; **FLOATING
C7737 VDD.n191 VSS 0.0148f ; **FLOATING
C7738 VDD.n192 VSS 0.16097f ; **FLOATING
C7739 VDD.n193 VSS 0.0148f ; **FLOATING
C7740 VDD.n194 VSS 0.06982f ; **FLOATING
C7741 VDD.n195 VSS 0.09118f ; **FLOATING
C7742 VDD.n196 VSS 0.01026f ; **FLOATING
C7743 VDD.n197 VSS 0.09003f ; **FLOATING
C7744 VDD.n198 VSS 0.06308f ; **FLOATING
C7745 VDD.n199 VSS 0.06308f ; **FLOATING
C7746 VDD.n200 VSS 0.09003f ; **FLOATING
C7747 VDD.n201 VSS 0.06308f ; **FLOATING
C7748 VDD.n202 VSS 0.06308f ; **FLOATING
C7749 VDD.n203 VSS 0.09003f ; **FLOATING
C7750 VDD.n204 VSS 0.06308f ; **FLOATING
C7751 VDD.n205 VSS 0.06308f ; **FLOATING
C7752 VDD.n206 VSS 0.06982f ; **FLOATING
C7753 VDD.n207 VSS 0.09118f ; **FLOATING
C7754 VDD.n208 VSS 0.01026f ; **FLOATING
C7755 VDD.n209 VSS 0.09003f ; **FLOATING
C7756 VDD.n210 VSS 0.06308f ; **FLOATING
C7757 VDD.n211 VSS 0.06308f ; **FLOATING
C7758 VDD.n212 VSS 0.09003f ; **FLOATING
C7759 VDD.n213 VSS 0.06308f ; **FLOATING
C7760 VDD.n214 VSS 0.06308f ; **FLOATING
C7761 VDD.n215 VSS 0.09003f ; **FLOATING
C7762 VDD.n216 VSS 0.06308f ; **FLOATING
C7763 VDD.n217 VSS 0.06308f ; **FLOATING
C7764 VDD.n218 VSS 0.06982f ; **FLOATING
C7765 VDD.n219 VSS 0.09118f ; **FLOATING
C7766 VDD.n220 VSS 0.01026f ; **FLOATING
C7767 VDD.n221 VSS 0.09003f ; **FLOATING
C7768 VDD.n222 VSS 0.06308f ; **FLOATING
C7769 VDD.n223 VSS 0.06308f ; **FLOATING
C7770 VDD.n224 VSS 0.09003f ; **FLOATING
C7771 VDD.n225 VSS 0.06308f ; **FLOATING
C7772 VDD.n226 VSS 0.06308f ; **FLOATING
C7773 VDD.n227 VSS 0.09003f ; **FLOATING
C7774 VDD.n228 VSS 0.06308f ; **FLOATING
C7775 VDD.n229 VSS 0.06308f ; **FLOATING
C7776 VDD.n230 VSS 0.06982f ; **FLOATING
C7777 VDD.n231 VSS 0.09118f ; **FLOATING
C7778 VDD.n232 VSS 0.01026f ; **FLOATING
C7779 VDD.n233 VSS 0.09003f ; **FLOATING
C7780 VDD.n234 VSS 0.06308f ; **FLOATING
C7781 VDD.n235 VSS 0.06308f ; **FLOATING
C7782 VDD.n236 VSS 0.09003f ; **FLOATING
C7783 VDD.n237 VSS 0.06308f ; **FLOATING
C7784 VDD.n238 VSS 0.06308f ; **FLOATING
C7785 VDD.n239 VSS 0.09003f ; **FLOATING
C7786 VDD.n240 VSS 0.06308f ; **FLOATING
C7787 VDD.n241 VSS 0.06308f ; **FLOATING
C7788 VDD.n242 VSS 0.06982f ; **FLOATING
C7789 VDD.n243 VSS 0.09118f ; **FLOATING
C7790 VDD.n244 VSS 0.01026f ; **FLOATING
C7791 VDD.n245 VSS 0.09003f ; **FLOATING
C7792 VDD.n246 VSS 0.06308f ; **FLOATING
C7793 VDD.n247 VSS 0.06308f ; **FLOATING
C7794 VDD.n248 VSS 0.09003f ; **FLOATING
C7795 VDD.n249 VSS 0.06308f ; **FLOATING
C7796 VDD.n250 VSS 0.06308f ; **FLOATING
C7797 VDD.n251 VSS 0.09003f ; **FLOATING
C7798 VDD.n252 VSS 0.06308f ; **FLOATING
C7799 VDD.n253 VSS 0.06308f ; **FLOATING
C7800 VDD.n254 VSS 0.04279f ; **FLOATING
C7801 VDD.n255 VSS 0.04279f ; **FLOATING
C7802 VDD.n256 VSS 0.04279f ; **FLOATING
C7803 VDD.n257 VSS 0.04279f ; **FLOATING
C7804 VDD.n258 VSS 0.04279f ; **FLOATING
C7805 VDD.n259 VSS 0.02213f ; **FLOATING
C7806 VDD.n260 VSS 0.15168f ; **FLOATING
C7807 VDD.n261 VSS 0.04364f ; **FLOATING
C7808 VDD.n262 VSS 0.01091f ; **FLOATING
C7809 VDD.n263 VSS 0.0275f ; **FLOATING
C7810 VDD.n264 VSS 0.04106f ; **FLOATING
C7811 VDD.n265 VSS 0.04364f ; **FLOATING
C7812 VDD.n266 VSS 0.01091f ; **FLOATING
C7813 VDD.n267 VSS 0.0275f ; **FLOATING
C7814 VDD.n268 VSS 0.04106f ; **FLOATING
C7815 VDD.n269 VSS 0.04367f ; **FLOATING
C7816 VDD.n270 VSS 0.01091f ; **FLOATING
C7817 VDD.n271 VSS 0.0275f ; **FLOATING
C7818 VDD.n272 VSS 0.04106f ; **FLOATING
C7819 VDD.n273 VSS 0.04364f ; **FLOATING
C7820 VDD.n274 VSS 0.01091f ; **FLOATING
C7821 VDD.n275 VSS 0.0275f ; **FLOATING
C7822 VDD.n276 VSS 0.04106f ; **FLOATING
C7823 VDD.n277 VSS 0.0275f ; **FLOATING
C7824 VDD.n278 VSS 0.07451f ; **FLOATING
C7825 VDD.n279 VSS 0.04106f ; **FLOATING
C7826 VDD.n280 VSS 0.01091f ; **FLOATING
C7827 VDD.n281 VSS 0.02257f ; **FLOATING
C7828 VDD.n282 VSS 0.01685f ; **FLOATING
C7829 VDD.n283 VSS 0.11372f ; **FLOATING
C7830 VDD.n284 VSS 0.05498f ; **FLOATING
C7831 VDD.n285 VSS 0.21783f ; **FLOATING
C7832 VDD.n286 VSS 0.06308f ; **FLOATING
C7833 VDD.n287 VSS 0.05986f ; **FLOATING
C7834 VDD.n288 VSS 0.03387f ; **FLOATING
C7835 VDD.n289 VSS 0.07867f ; **FLOATING
C7836 VDD.n290 VSS 0.0181f ; **FLOATING
C7837 VDD.n291 VSS 0.16137f ; **FLOATING
C7838 VDD.n292 VSS 0.0181f ; **FLOATING
C7839 VDD.n293 VSS 0.16137f ; **FLOATING
C7840 VDD.n294 VSS 0.0181f ; **FLOATING
C7841 VDD.n295 VSS 0.16137f ; **FLOATING
C7842 VDD.n296 VSS 0.0181f ; **FLOATING
C7843 VDD.n297 VSS 0.16137f ; **FLOATING
C7844 VDD.n298 VSS 0.0181f ; **FLOATING
C7845 VDD.n299 VSS 0.16137f ; **FLOATING
C7846 VDD.n300 VSS 0.03374f ; **FLOATING
C7847 VDD.n301 VSS 0.03806f ; **FLOATING
C7848 VDD.n302 VSS 0.14254f ; **FLOATING
C7849 VDD.n304 VSS 0.09208f ; **FLOATING
C7850 VDD.n305 VSS 0.14254f ; **FLOATING
C7851 VDD.n306 VSS 0.09208f ; **FLOATING
C7852 VDD.n308 VSS 0.14254f ; **FLOATING
C7853 VDD.n309 VSS 0.09208f ; **FLOATING
C7854 VDD.n311 VSS 0.02809f ; **FLOATING
C7855 VDD.n312 VSS 0.10277f ; **FLOATING
C7856 VDD.n313 VSS 0.14254f ; **FLOATING
C7857 VDD.n314 VSS 0.09208f ; **FLOATING
C7858 VDD.n316 VSS 0.14254f ; **FLOATING
C7859 VDD.n317 VSS 0.09208f ; **FLOATING
C7860 VDD.n319 VSS 0.14254f ; **FLOATING
C7861 VDD.n320 VSS 0.09208f ; **FLOATING
C7862 VDD.n322 VSS 0.14254f ; **FLOATING
C7863 VDD.n324 VSS 0.09208f ; **FLOATING
C7864 VDD.n325 VSS 0.14254f ; **FLOATING
C7865 VDD.n326 VSS 0.09208f ; **FLOATING
C7866 VDD.n328 VSS 0.14254f ; **FLOATING
C7867 VDD.n329 VSS 0.09208f ; **FLOATING
C7868 VDD.n331 VSS 0.02809f ; **FLOATING
C7869 VDD.n332 VSS 0.10277f ; **FLOATING
C7870 VDD.n333 VSS 0.14254f ; **FLOATING
C7871 VDD.n334 VSS 0.09208f ; **FLOATING
C7872 VDD.n336 VSS 0.14254f ; **FLOATING
C7873 VDD.n337 VSS 0.09208f ; **FLOATING
C7874 VDD.n339 VSS 0.14254f ; **FLOATING
C7875 VDD.n340 VSS 0.09208f ; **FLOATING
C7876 VDD.n342 VSS 0.14254f ; **FLOATING
C7877 VDD.n344 VSS 0.09208f ; **FLOATING
C7878 VDD.n345 VSS 0.14254f ; **FLOATING
C7879 VDD.n346 VSS 0.09208f ; **FLOATING
C7880 VDD.n348 VSS 0.14254f ; **FLOATING
C7881 VDD.n349 VSS 0.09208f ; **FLOATING
C7882 VDD.n351 VSS 0.02809f ; **FLOATING
C7883 VDD.n352 VSS 0.10277f ; **FLOATING
C7884 VDD.n353 VSS 0.14254f ; **FLOATING
C7885 VDD.n354 VSS 0.09208f ; **FLOATING
C7886 VDD.n356 VSS 0.14254f ; **FLOATING
C7887 VDD.n357 VSS 0.09208f ; **FLOATING
C7888 VDD.n359 VSS 0.14254f ; **FLOATING
C7889 VDD.n360 VSS 0.09208f ; **FLOATING
C7890 VDD.n362 VSS 0.14254f ; **FLOATING
C7891 VDD.n364 VSS 0.09208f ; **FLOATING
C7892 VDD.n365 VSS 0.14254f ; **FLOATING
C7893 VDD.n366 VSS 0.09208f ; **FLOATING
C7894 VDD.n368 VSS 0.14254f ; **FLOATING
C7895 VDD.n369 VSS 0.09208f ; **FLOATING
C7896 VDD.n371 VSS 0.02809f ; **FLOATING
C7897 VDD.n372 VSS 0.10277f ; **FLOATING
C7898 VDD.n373 VSS 0.14254f ; **FLOATING
C7899 VDD.n374 VSS 0.09208f ; **FLOATING
C7900 VDD.n376 VSS 0.14254f ; **FLOATING
C7901 VDD.n377 VSS 0.09208f ; **FLOATING
C7902 VDD.n379 VSS 0.14254f ; **FLOATING
C7903 VDD.n380 VSS 0.09208f ; **FLOATING
C7904 VDD.n382 VSS 0.14254f ; **FLOATING
C7905 VDD.n384 VSS 0.09208f ; **FLOATING
C7906 VDD.n385 VSS 0.14254f ; **FLOATING
C7907 VDD.n386 VSS 0.09208f ; **FLOATING
C7908 VDD.n388 VSS 0.14254f ; **FLOATING
C7909 VDD.n389 VSS 0.09208f ; **FLOATING
C7910 VDD.n391 VSS 0.02809f ; **FLOATING
C7911 VDD.n392 VSS 0.10277f ; **FLOATING
C7912 VDD.n393 VSS 0.14254f ; **FLOATING
C7913 VDD.n394 VSS 0.09208f ; **FLOATING
C7914 VDD.n396 VSS 0.14254f ; **FLOATING
C7915 VDD.n397 VSS 0.09208f ; **FLOATING
C7916 VDD.n399 VSS 0.14254f ; **FLOATING
C7917 VDD.n400 VSS 0.09208f ; **FLOATING
C7918 VDD.n402 VSS 0.09003f ; **FLOATING
C7919 VDD.n403 VSS 0.09003f ; **FLOATING
C7920 VDD.n404 VSS 0.09003f ; **FLOATING
C7921 VDD.n405 VSS 0.09003f ; **FLOATING
C7922 VDD.n406 VSS 0.09003f ; **FLOATING
C7923 VDD.n407 VSS 0.09003f ; **FLOATING
C7924 VDD.n408 VSS 0.09003f ; **FLOATING
C7925 VDD.n409 VSS 0.09003f ; **FLOATING
C7926 VDD.n410 VSS 0.09003f ; **FLOATING
C7927 VDD.n411 VSS 0.09003f ; **FLOATING
C7928 VDD.n412 VSS 0.09003f ; **FLOATING
C7929 VDD.n413 VSS 0.09003f ; **FLOATING
C7930 VDD.n414 VSS 0.09003f ; **FLOATING
C7931 VDD.n415 VSS 0.09003f ; **FLOATING
C7932 VDD.n416 VSS 0.09003f ; **FLOATING
C7933 VDD.n417 VSS 0.03268f ; **FLOATING
C7934 VDD.n418 VSS 0.01693f ; **FLOATING
C7935 VDD.n419 VSS 0.10714f ; **FLOATING
C7936 VDD.n420 VSS 0.03268f ; **FLOATING
C7937 VDD.n421 VSS 0.01693f ; **FLOATING
C7938 VDD.n422 VSS 0.10714f ; **FLOATING
C7939 VDD.n423 VSS 0.03268f ; **FLOATING
C7940 VDD.n424 VSS 0.01693f ; **FLOATING
C7941 VDD.n425 VSS 0.10714f ; **FLOATING
C7942 VDD.n426 VSS 0.03268f ; **FLOATING
C7943 VDD.n427 VSS 0.01693f ; **FLOATING
C7944 VDD.n428 VSS 0.10714f ; **FLOATING
C7945 VDD.n429 VSS 0.03268f ; **FLOATING
C7946 VDD.n430 VSS 0.01693f ; **FLOATING
C7947 VDD.n431 VSS 0.10714f ; **FLOATING
C7948 VDD.n432 VSS 0.04506f ; **FLOATING
C7949 VDD.n433 VSS 0.04506f ; **FLOATING
C7950 VDD.n434 VSS 0.04506f ; **FLOATING
C7951 VDD.n435 VSS 0.04506f ; **FLOATING
C7952 VDD.n436 VSS 0.04506f ; **FLOATING
C7953 VDD.n437 VSS 0.04506f ; **FLOATING
C7954 VDD.n438 VSS 0.04506f ; **FLOATING
C7955 VDD.n439 VSS 0.04506f ; **FLOATING
C7956 VDD.n440 VSS 0.04506f ; **FLOATING
C7957 VDD.n441 VSS 0.04506f ; **FLOATING
C7958 VDD.n442 VSS 0.04506f ; **FLOATING
C7959 VDD.n443 VSS 0.04506f ; **FLOATING
C7960 VDD.n444 VSS 0.04506f ; **FLOATING
C7961 VDD.n445 VSS 0.04506f ; **FLOATING
C7962 VDD.n446 VSS 0.04506f ; **FLOATING
C7963 VDD.n447 VSS 0.04506f ; **FLOATING
C7964 VDD.n448 VSS 0.04506f ; **FLOATING
C7965 VDD.n449 VSS 0.04506f ; **FLOATING
C7966 VDD.n450 VSS 0.04506f ; **FLOATING
C7967 VDD.n451 VSS 0.04506f ; **FLOATING
C7968 VDD.n452 VSS 0.14063f ; **FLOATING
C7969 VDD.t270 VSS 8.82584f ; **FLOATING
C7970 VDD.t1029 VSS 0.03934f ; **FLOATING
C7971 VDD.t491 VSS 0.03934f ; **FLOATING
C7972 VDD.n453 VSS 0.13433f ; **FLOATING
C7973 VDD.n454 VSS 0.0169f ; **FLOATING
C7974 VDD.t1027 VSS 0.04758f ; **FLOATING
C7975 VDD.t489 VSS 0.04758f ; **FLOATING
C7976 VDD.n455 VSS 0.15148f ; **FLOATING
C7977 VDD.n456 VSS 0.08017f ; **FLOATING
C7978 VDD.t779 VSS 0.03391f ; **FLOATING
C7979 VDD.n457 VSS 0.02302f ; **FLOATING
C7980 VDD.t778 VSS 0.02448f ; **FLOATING
C7981 VDD.t780 VSS 0.0379f ; **FLOATING
C7982 VDD.t782 VSS 0.03391f ; **FLOATING
C7983 VDD.t294 VSS 0.03391f ; **FLOATING
C7984 VDD.t784 VSS 0.03391f ; **FLOATING
C7985 VDD.n458 VSS 0.02302f ; **FLOATING
C7986 VDD.t783 VSS 0.02448f ; **FLOATING
C7987 VDD.t785 VSS 0.0379f ; **FLOATING
C7988 VDD.n459 VSS 0.01926f ; **FLOATING
C7989 VDD.t786 VSS 0.01996f ; **FLOATING
C7990 VDD.t787 VSS 0.03391f ; **FLOATING
C7991 VDD.n460 VSS 0.02022f ; **FLOATING
C7992 VDD.t697 VSS 0.03723f ; **FLOATING
C7993 VDD.t877 VSS 0.02533f ; **FLOATING
C7994 VDD.n461 VSS 0.12741f ; **FLOATING
C7995 VDD.t293 VSS 3.55941f ; **FLOATING
C7996 VDD.n462 VSS 0.69308f ; **FLOATING
C7997 VDD.n463 VSS 0.12328f ; **FLOATING
C7998 VDD.n464 VSS 0.02912f ; **FLOATING
C7999 VDD.t272 VSS 0.02797f ; **FLOATING
C8000 VDD.t274 VSS 0.02797f ; **FLOATING
C8001 VDD.n465 VSS 0.08305f ; **FLOATING
C8002 VDD.n466 VSS 0.03941f ; **FLOATING
C8003 VDD.t1198 VSS 0.01297f ; **FLOATING
C8004 VDD.t269 VSS 0.06454f ; **FLOATING
C8005 VDD.n467 VSS 0.02614f ; **FLOATING
C8006 VDD.t729 VSS 0.01297f ; **FLOATING
C8007 VDD.t271 VSS 0.06454f ; **FLOATING
C8008 VDD.n468 VSS 0.02614f ; **FLOATING
C8009 VDD.n469 VSS 0.05772f ; **FLOATING
C8010 VDD.n470 VSS 0.01534f ; **FLOATING
C8011 VDD.t736 VSS 0.03802f ; **FLOATING
C8012 VDD.n471 VSS 0.06837f ; **FLOATING
C8013 VDD.n472 VSS 0.03758f ; **FLOATING
C8014 VDD.t875 VSS 0.03511f ; **FLOATING
C8015 VDD.n473 VSS 0.08148f ; **FLOATING
C8016 VDD.n474 VSS 0.02144f ; **FLOATING
C8017 VDD.t511 VSS 0.03934f ; **FLOATING
C8018 VDD.n475 VSS 0.17576f ; **FLOATING
C8019 VDD.t545 VSS 0.02797f ; **FLOATING
C8020 VDD.n476 VSS 0.15743f ; **FLOATING
C8021 VDD.t1032 VSS 0.01297f ; **FLOATING
C8022 VDD.t874 VSS 0.06454f ; **FLOATING
C8023 VDD.n477 VSS 0.02614f ; **FLOATING
C8024 VDD.n478 VSS 0.03943f ; **FLOATING
C8025 VDD.n479 VSS 0.01679f ; **FLOATING
C8026 VDD.n480 VSS 0.03818f ; **FLOATING
C8027 VDD.n481 VSS 0.03806f ; **FLOATING
C8028 VDD.n482 VSS 0.03327f ; **FLOATING
C8029 VDD.n483 VSS 0.03816f ; **FLOATING
C8030 VDD.n484 VSS 0.01664f ; **FLOATING
C8031 VDD.n485 VSS 0.0316f ; **FLOATING
C8032 VDD.n486 VSS 0.07621f ; **FLOATING
C8033 VDD.n487 VSS 0.05164f ; **FLOATING
C8034 VDD.n488 VSS 0.0515f ; **FLOATING
C8035 VDD.n489 VSS 0.05156f ; **FLOATING
C8036 VDD.n490 VSS 0.05162f ; **FLOATING
C8037 VDD.n491 VSS 0.05163f ; **FLOATING
C8038 VDD.n492 VSS 0.05162f ; **FLOATING
C8039 VDD.n493 VSS 0.0515f ; **FLOATING
C8040 VDD.n494 VSS 0.05155f ; **FLOATING
C8041 VDD.n495 VSS 0.05163f ; **FLOATING
C8042 VDD.n496 VSS 0.05157f ; **FLOATING
C8043 VDD.n497 VSS 0.05163f ; **FLOATING
C8044 VDD.n498 VSS 0.0515f ; **FLOATING
C8045 VDD.n499 VSS 0.05162f ; **FLOATING
C8046 VDD.n500 VSS 0.0516f ; **FLOATING
C8047 VDD.n501 VSS 0.05157f ; **FLOATING
C8048 VDD.n502 VSS 0.05152f ; **FLOATING
C8049 VDD.n503 VSS 0.05157f ; **FLOATING
C8050 VDD.n504 VSS 0.05155f ; **FLOATING
C8051 VDD.n505 VSS 0.0515f ; **FLOATING
C8052 VDD.n506 VSS 0.05157f ; **FLOATING
C8053 VDD.n507 VSS 0.05158f ; **FLOATING
C8054 VDD.n508 VSS 0.05156f ; **FLOATING
C8055 VDD.n509 VSS 0.05143f ; **FLOATING
C8056 VDD.n510 VSS 0.05158f ; **FLOATING
C8057 VDD.n511 VSS 0.05162f ; **FLOATING
C8058 VDD.n512 VSS 0.05155f ; **FLOATING
C8059 VDD.n513 VSS 0.05159f ; **FLOATING
C8060 VDD.n514 VSS 0.05157f ; **FLOATING
C8061 VDD.n515 VSS 0.05156f ; **FLOATING
C8062 VDD.n516 VSS 0.05149f ; **FLOATING
C8063 VDD.n517 VSS 0.05155f ; **FLOATING
C8064 VDD.t749 VSS 0.07114f ; **FLOATING
C8065 VDD.n518 VSS 0.05417f ; **FLOATING
C8066 VDD.t754 VSS 0.03391f ; **FLOATING
C8067 VDD.n519 VSS 0.0633f ; **FLOATING
C8068 VDD.t752 VSS 0.03277f ; **FLOATING
C8069 VDD.n520 VSS 0.01671f ; **FLOATING
C8070 VDD.n521 VSS 0.02251f ; **FLOATING
C8071 VDD.t751 VSS 0.0379f ; **FLOATING
C8072 VDD.t750 VSS 0.03391f ; **FLOATING
C8073 VDD.n522 VSS 0.02515f ; **FLOATING
C8074 VDD.n523 VSS 0.04367f ; **FLOATING
C8075 VDD.n524 VSS 0.01515f ; **FLOATING
C8076 VDD.t835 VSS 0.03978f ; **FLOATING
C8077 VDD.n525 VSS 0.06312f ; **FLOATING
C8078 VDD.n526 VSS 0.01474f ; **FLOATING
C8079 VDD.t327 VSS 0.03391f ; **FLOATING
C8080 VDD.n527 VSS 0.09224f ; **FLOATING
C8081 VDD.n528 VSS 0.02515f ; **FLOATING
C8082 VDD.n529 VSS 0.06306f ; **FLOATING
C8083 VDD.n530 VSS 0.03631f ; **FLOATING
C8084 VDD.t459 VSS 0.03978f ; **FLOATING
C8085 VDD.n531 VSS 0.08282f ; **FLOATING
C8086 VDD.n532 VSS 0.01472f ; **FLOATING
C8087 VDD.t330 VSS 0.03391f ; **FLOATING
C8088 VDD.n533 VSS 0.11147f ; **FLOATING
C8089 VDD.n534 VSS 0.02515f ; **FLOATING
C8090 VDD.n535 VSS 0.063f ; **FLOATING
C8091 VDD.n536 VSS 0.03636f ; **FLOATING
C8092 VDD.t931 VSS 0.03978f ; **FLOATING
C8093 VDD.n537 VSS 0.08279f ; **FLOATING
C8094 VDD.n538 VSS 0.01474f ; **FLOATING
C8095 VDD.t338 VSS 0.03391f ; **FLOATING
C8096 VDD.n539 VSS 0.11143f ; **FLOATING
C8097 VDD.n540 VSS 0.02515f ; **FLOATING
C8098 VDD.n541 VSS 0.06304f ; **FLOATING
C8099 VDD.n542 VSS 0.03632f ; **FLOATING
C8100 VDD.t934 VSS 0.03978f ; **FLOATING
C8101 VDD.n543 VSS 0.08281f ; **FLOATING
C8102 VDD.n544 VSS 0.01474f ; **FLOATING
C8103 VDD.t337 VSS 0.03391f ; **FLOATING
C8104 VDD.n545 VSS 0.11139f ; **FLOATING
C8105 VDD.n546 VSS 0.02515f ; **FLOATING
C8106 VDD.n547 VSS 0.06305f ; **FLOATING
C8107 VDD.n548 VSS 0.0363f ; **FLOATING
C8108 VDD.t889 VSS 0.03978f ; **FLOATING
C8109 VDD.n549 VSS 0.08281f ; **FLOATING
C8110 VDD.n550 VSS 0.01474f ; **FLOATING
C8111 VDD.t339 VSS 0.03391f ; **FLOATING
C8112 VDD.n551 VSS 0.11143f ; **FLOATING
C8113 VDD.n552 VSS 0.02515f ; **FLOATING
C8114 VDD.n553 VSS 0.06303f ; **FLOATING
C8115 VDD.n554 VSS 0.03631f ; **FLOATING
C8116 VDD.t564 VSS 0.03978f ; **FLOATING
C8117 VDD.n555 VSS 0.08283f ; **FLOATING
C8118 VDD.n556 VSS 0.01474f ; **FLOATING
C8119 VDD.t306 VSS 0.03391f ; **FLOATING
C8120 VDD.n557 VSS 0.11142f ; **FLOATING
C8121 VDD.n558 VSS 0.02515f ; **FLOATING
C8122 VDD.n559 VSS 0.06305f ; **FLOATING
C8123 VDD.n560 VSS 0.0363f ; **FLOATING
C8124 VDD.t930 VSS 0.03978f ; **FLOATING
C8125 VDD.n561 VSS 0.08281f ; **FLOATING
C8126 VDD.n562 VSS 0.01474f ; **FLOATING
C8127 VDD.t340 VSS 0.03391f ; **FLOATING
C8128 VDD.n563 VSS 0.11138f ; **FLOATING
C8129 VDD.n564 VSS 0.02515f ; **FLOATING
C8130 VDD.n565 VSS 0.06309f ; **FLOATING
C8131 VDD.n566 VSS 0.03625f ; **FLOATING
C8132 VDD.t687 VSS 0.03978f ; **FLOATING
C8133 VDD.n567 VSS 0.08282f ; **FLOATING
C8134 VDD.n568 VSS 0.01474f ; **FLOATING
C8135 VDD.t341 VSS 0.03391f ; **FLOATING
C8136 VDD.n569 VSS 0.1114f ; **FLOATING
C8137 VDD.n570 VSS 0.02515f ; **FLOATING
C8138 VDD.n571 VSS 0.06305f ; **FLOATING
C8139 VDD.n572 VSS 0.0363f ; **FLOATING
C8140 VDD.t833 VSS 0.03978f ; **FLOATING
C8141 VDD.n573 VSS 0.08281f ; **FLOATING
C8142 VDD.n574 VSS 0.01474f ; **FLOATING
C8143 VDD.t335 VSS 0.03391f ; **FLOATING
C8144 VDD.n575 VSS 0.11149f ; **FLOATING
C8145 VDD.n576 VSS 0.02515f ; **FLOATING
C8146 VDD.n577 VSS 0.06303f ; **FLOATING
C8147 VDD.n578 VSS 0.03632f ; **FLOATING
C8148 VDD.t533 VSS 0.03978f ; **FLOATING
C8149 VDD.n579 VSS 0.08282f ; **FLOATING
C8150 VDD.n580 VSS 0.01474f ; **FLOATING
C8151 VDD.t332 VSS 0.03391f ; **FLOATING
C8152 VDD.n581 VSS 0.11151f ; **FLOATING
C8153 VDD.n582 VSS 0.02515f ; **FLOATING
C8154 VDD.n583 VSS 0.06305f ; **FLOATING
C8155 VDD.n584 VSS 0.0363f ; **FLOATING
C8156 VDD.t979 VSS 0.03978f ; **FLOATING
C8157 VDD.n585 VSS 0.08284f ; **FLOATING
C8158 VDD.n586 VSS 0.01472f ; **FLOATING
C8159 VDD.t333 VSS 0.03391f ; **FLOATING
C8160 VDD.n587 VSS 0.1114f ; **FLOATING
C8161 VDD.n588 VSS 0.02515f ; **FLOATING
C8162 VDD.n589 VSS 0.06302f ; **FLOATING
C8163 VDD.n590 VSS 0.03631f ; **FLOATING
C8164 VDD.t1167 VSS 0.03978f ; **FLOATING
C8165 VDD.n591 VSS 0.08285f ; **FLOATING
C8166 VDD.n592 VSS 0.01472f ; **FLOATING
C8167 VDD.t334 VSS 0.03391f ; **FLOATING
C8168 VDD.n593 VSS 0.1114f ; **FLOATING
C8169 VDD.n594 VSS 0.02515f ; **FLOATING
C8170 VDD.n595 VSS 0.06301f ; **FLOATING
C8171 VDD.n596 VSS 0.03632f ; **FLOATING
C8172 VDD.t614 VSS 0.03978f ; **FLOATING
C8173 VDD.n597 VSS 0.08282f ; **FLOATING
C8174 VDD.n598 VSS 0.01474f ; **FLOATING
C8175 VDD.t336 VSS 0.03391f ; **FLOATING
C8176 VDD.n599 VSS 0.11147f ; **FLOATING
C8177 VDD.n600 VSS 0.02515f ; **FLOATING
C8178 VDD.n601 VSS 0.06301f ; **FLOATING
C8179 VDD.n602 VSS 0.03636f ; **FLOATING
C8180 VDD.t961 VSS 0.03978f ; **FLOATING
C8181 VDD.n603 VSS 0.08282f ; **FLOATING
C8182 VDD.n604 VSS 0.01472f ; **FLOATING
C8183 VDD.t331 VSS 0.03391f ; **FLOATING
C8184 VDD.n605 VSS 0.11148f ; **FLOATING
C8185 VDD.n606 VSS 0.02515f ; **FLOATING
C8186 VDD.n607 VSS 0.06303f ; **FLOATING
C8187 VDD.n608 VSS 0.03632f ; **FLOATING
C8188 VDD.t629 VSS 0.03978f ; **FLOATING
C8189 VDD.n609 VSS 0.08281f ; **FLOATING
C8190 VDD.n610 VSS 0.01474f ; **FLOATING
C8191 VDD.t314 VSS 0.03391f ; **FLOATING
C8192 VDD.n611 VSS 0.11142f ; **FLOATING
C8193 VDD.n612 VSS 0.02515f ; **FLOATING
C8194 VDD.n613 VSS 0.06306f ; **FLOATING
C8195 VDD.n614 VSS 0.03631f ; **FLOATING
C8196 VDD.t924 VSS 0.03978f ; **FLOATING
C8197 VDD.n615 VSS 0.0828f ; **FLOATING
C8198 VDD.n616 VSS 0.01474f ; **FLOATING
C8199 VDD.t329 VSS 0.03391f ; **FLOATING
C8200 VDD.n617 VSS 0.11143f ; **FLOATING
C8201 VDD.n618 VSS 0.02515f ; **FLOATING
C8202 VDD.n619 VSS 0.0631f ; **FLOATING
C8203 VDD.n620 VSS 0.03625f ; **FLOATING
C8204 VDD.t627 VSS 0.03978f ; **FLOATING
C8205 VDD.n621 VSS 0.08285f ; **FLOATING
C8206 VDD.n622 VSS 0.01472f ; **FLOATING
C8207 VDD.t315 VSS 0.03391f ; **FLOATING
C8208 VDD.n623 VSS 0.11141f ; **FLOATING
C8209 VDD.n624 VSS 0.02515f ; **FLOATING
C8210 VDD.n625 VSS 0.06303f ; **FLOATING
C8211 VDD.n626 VSS 0.03632f ; **FLOATING
C8212 VDD.t458 VSS 0.03978f ; **FLOATING
C8213 VDD.n627 VSS 0.08281f ; **FLOATING
C8214 VDD.n628 VSS 0.01474f ; **FLOATING
C8215 VDD.t300 VSS 0.03391f ; **FLOATING
C8216 VDD.n629 VSS 0.11144f ; **FLOATING
C8217 VDD.n630 VSS 0.02515f ; **FLOATING
C8218 VDD.n631 VSS 0.06305f ; **FLOATING
C8219 VDD.n632 VSS 0.0363f ; **FLOATING
C8220 VDD.t975 VSS 0.03978f ; **FLOATING
C8221 VDD.n633 VSS 0.08281f ; **FLOATING
C8222 VDD.n634 VSS 0.01474f ; **FLOATING
C8223 VDD.t326 VSS 0.03391f ; **FLOATING
C8224 VDD.n635 VSS 0.11136f ; **FLOATING
C8225 VDD.n636 VSS 0.02515f ; **FLOATING
C8226 VDD.n637 VSS 0.06304f ; **FLOATING
C8227 VDD.n638 VSS 0.03634f ; **FLOATING
C8228 VDD.t553 VSS 0.03978f ; **FLOATING
C8229 VDD.n639 VSS 0.08279f ; **FLOATING
C8230 VDD.n640 VSS 0.01474f ; **FLOATING
C8231 VDD.t317 VSS 0.03391f ; **FLOATING
C8232 VDD.n641 VSS 0.11143f ; **FLOATING
C8233 VDD.n642 VSS 0.02515f ; **FLOATING
C8234 VDD.n643 VSS 0.06305f ; **FLOATING
C8235 VDD.n644 VSS 0.0363f ; **FLOATING
C8236 VDD.t686 VSS 0.03978f ; **FLOATING
C8237 VDD.n645 VSS 0.08281f ; **FLOATING
C8238 VDD.n646 VSS 0.01474f ; **FLOATING
C8239 VDD.t328 VSS 0.03391f ; **FLOATING
C8240 VDD.n647 VSS 0.11141f ; **FLOATING
C8241 VDD.n648 VSS 0.02515f ; **FLOATING
C8242 VDD.n649 VSS 0.06307f ; **FLOATING
C8243 VDD.n650 VSS 0.03626f ; **FLOATING
C8244 VDD.t603 VSS 0.03978f ; **FLOATING
C8245 VDD.n651 VSS 0.08284f ; **FLOATING
C8246 VDD.n652 VSS 0.01474f ; **FLOATING
C8247 VDD.t299 VSS 0.03391f ; **FLOATING
C8248 VDD.n653 VSS 0.11138f ; **FLOATING
C8249 VDD.n654 VSS 0.02515f ; **FLOATING
C8250 VDD.n655 VSS 0.06305f ; **FLOATING
C8251 VDD.n656 VSS 0.03628f ; **FLOATING
C8252 VDD.t887 VSS 0.03978f ; **FLOATING
C8253 VDD.n657 VSS 0.08283f ; **FLOATING
C8254 VDD.n658 VSS 0.01474f ; **FLOATING
C8255 VDD.t322 VSS 0.03391f ; **FLOATING
C8256 VDD.n659 VSS 0.1114f ; **FLOATING
C8257 VDD.n660 VSS 0.02515f ; **FLOATING
C8258 VDD.n661 VSS 0.06305f ; **FLOATING
C8259 VDD.n662 VSS 0.0363f ; **FLOATING
C8260 VDD.t1496 VSS 0.03978f ; **FLOATING
C8261 VDD.n663 VSS 0.08281f ; **FLOATING
C8262 VDD.n664 VSS 0.01474f ; **FLOATING
C8263 VDD.t323 VSS 0.03391f ; **FLOATING
C8264 VDD.n665 VSS 0.11142f ; **FLOATING
C8265 VDD.n666 VSS 0.02515f ; **FLOATING
C8266 VDD.n667 VSS 0.06303f ; **FLOATING
C8267 VDD.n668 VSS 0.03631f ; **FLOATING
C8268 VDD.t456 VSS 0.03978f ; **FLOATING
C8269 VDD.n669 VSS 0.08283f ; **FLOATING
C8270 VDD.n670 VSS 0.01474f ; **FLOATING
C8271 VDD.t324 VSS 0.03391f ; **FLOATING
C8272 VDD.n671 VSS 0.11146f ; **FLOATING
C8273 VDD.n672 VSS 0.02515f ; **FLOATING
C8274 VDD.n673 VSS 0.06301f ; **FLOATING
C8275 VDD.n674 VSS 0.03636f ; **FLOATING
C8276 VDD.t552 VSS 0.03978f ; **FLOATING
C8277 VDD.n675 VSS 0.08279f ; **FLOATING
C8278 VDD.n676 VSS 0.01474f ; **FLOATING
C8279 VDD.t320 VSS 0.03391f ; **FLOATING
C8280 VDD.n677 VSS 0.11144f ; **FLOATING
C8281 VDD.n678 VSS 0.02515f ; **FLOATING
C8282 VDD.n679 VSS 0.06305f ; **FLOATING
C8283 VDD.n680 VSS 0.0363f ; **FLOATING
C8284 VDD.t685 VSS 0.03978f ; **FLOATING
C8285 VDD.n681 VSS 0.08281f ; **FLOATING
C8286 VDD.n682 VSS 0.01474f ; **FLOATING
C8287 VDD.t321 VSS 0.03391f ; **FLOATING
C8288 VDD.n683 VSS 0.11136f ; **FLOATING
C8289 VDD.n684 VSS 0.02515f ; **FLOATING
C8290 VDD.n685 VSS 0.06305f ; **FLOATING
C8291 VDD.n686 VSS 0.0363f ; **FLOATING
C8292 VDD.t642 VSS 0.03978f ; **FLOATING
C8293 VDD.n687 VSS 0.08281f ; **FLOATING
C8294 VDD.n688 VSS 0.01474f ; **FLOATING
C8295 VDD.t325 VSS 0.03391f ; **FLOATING
C8296 VDD.n689 VSS 0.11136f ; **FLOATING
C8297 VDD.n690 VSS 0.02515f ; **FLOATING
C8298 VDD.n691 VSS 0.06303f ; **FLOATING
C8299 VDD.n692 VSS 0.03631f ; **FLOATING
C8300 VDD.t550 VSS 0.03978f ; **FLOATING
C8301 VDD.n693 VSS 0.08285f ; **FLOATING
C8302 VDD.n694 VSS 0.01472f ; **FLOATING
C8303 VDD.t305 VSS 0.03391f ; **FLOATING
C8304 VDD.n695 VSS 0.11141f ; **FLOATING
C8305 VDD.n696 VSS 0.02515f ; **FLOATING
C8306 VDD.n697 VSS 0.06303f ; **FLOATING
C8307 VDD.n698 VSS 0.03632f ; **FLOATING
C8308 VDD.t1123 VSS 0.03978f ; **FLOATING
C8309 VDD.n699 VSS 0.08281f ; **FLOATING
C8310 VDD.n700 VSS 0.01474f ; **FLOATING
C8311 VDD.t319 VSS 0.03391f ; **FLOATING
C8312 VDD.n701 VSS 0.11143f ; **FLOATING
C8313 VDD.n702 VSS 0.02515f ; **FLOATING
C8314 VDD.n703 VSS 0.06303f ; **FLOATING
C8315 VDD.n704 VSS 0.03632f ; **FLOATING
C8316 VDD.t920 VSS 0.03978f ; **FLOATING
C8317 VDD.n705 VSS 0.08282f ; **FLOATING
C8318 VDD.n706 VSS 0.01474f ; **FLOATING
C8319 VDD.t298 VSS 0.03391f ; **FLOATING
C8320 VDD.n707 VSS 0.11145f ; **FLOATING
C8321 VDD.n708 VSS 0.02515f ; **FLOATING
C8322 VDD.n709 VSS 0.06303f ; **FLOATING
C8323 VDD.n710 VSS 0.03632f ; **FLOATING
C8324 VDD.t1015 VSS 0.03978f ; **FLOATING
C8325 VDD.n711 VSS 0.08284f ; **FLOATING
C8326 VDD.n712 VSS 0.01472f ; **FLOATING
C8327 VDD.t313 VSS 0.03391f ; **FLOATING
C8328 VDD.n713 VSS 0.10264f ; **FLOATING
C8329 VDD.n714 VSS 0.02515f ; **FLOATING
C8330 VDD.n715 VSS 0.0659f ; **FLOATING
C8331 VDD.t746 VSS 0.0379f ; **FLOATING
C8332 VDD.t748 VSS 0.03391f ; **FLOATING
C8333 VDD.t747 VSS 0.01994f ; **FLOATING
C8334 VDD.t744 VSS 0.02448f ; **FLOATING
C8335 VDD.t745 VSS 0.0344f ; **FLOATING
C8336 VDD.t1480 VSS 0.03511f ; **FLOATING
C8337 VDD.t678 VSS 0.03511f ; **FLOATING
C8338 VDD.t127 VSS 0.03153f ; **FLOATING
C8339 VDD.t1397 VSS 0.03511f ; **FLOATING
C8340 VDD.n716 VSS 0.02899f ; **FLOATING
C8341 VDD.t1107 VSS 0.04608f ; **FLOATING
C8342 VDD.n717 VSS 0.08838f ; **FLOATING
C8343 VDD.n718 VSS 0.02585f ; **FLOATING
C8344 VDD.t659 VSS 0.03511f ; **FLOATING
C8345 VDD.n719 VSS 0.08379f ; **FLOATING
C8346 VDD.n720 VSS 0.0123f ; **FLOATING
C8347 VDD.t963 VSS 0.03913f ; **FLOATING
C8348 VDD.t1260 VSS 0.03913f ; **FLOATING
C8349 VDD.t537 VSS 0.03913f ; **FLOATING
C8350 VDD.t1294 VSS 0.03913f ; **FLOATING
C8351 VDD.t471 VSS 0.03511f ; **FLOATING
C8352 VDD.t1489 VSS 0.03511f ; **FLOATING
C8353 VDD.n721 VSS 0.10156f ; **FLOATING
C8354 VDD.n722 VSS 0.01607f ; **FLOATING
C8355 VDD.t891 VSS 0.02593f ; **FLOATING
C8356 VDD.t1273 VSS 0.02593f ; **FLOATING
C8357 VDD.n723 VSS 0.08955f ; **FLOATING
C8358 VDD.t536 VSS 0.03466f ; **FLOATING
C8359 VDD.t1267 VSS 0.03466f ; **FLOATING
C8360 VDD.t1481 VSS 0.02593f ; **FLOATING
C8361 VDD.t677 VSS 0.02593f ; **FLOATING
C8362 VDD.t962 VSS 0.03466f ; **FLOATING
C8363 VDD.t1259 VSS 0.03466f ; **FLOATING
C8364 VDD.t470 VSS 0.02593f ; **FLOATING
C8365 VDD.t1488 VSS 0.02593f ; **FLOATING
C8366 VDD.t892 VSS 0.03466f ; **FLOATING
C8367 VDD.t1257 VSS 0.03466f ; **FLOATING
C8368 VDD.n724 VSS 0.0818f ; **FLOATING
C8369 VDD.t983 VSS 0.03913f ; **FLOATING
C8370 VDD.t1258 VSS 0.03913f ; **FLOATING
C8371 VDD.t1482 VSS 0.02593f ; **FLOATING
C8372 VDD.t679 VSS 0.02593f ; **FLOATING
C8373 VDD.t472 VSS 0.03466f ; **FLOATING
C8374 VDD.t1306 VSS 0.03466f ; **FLOATING
C8375 VDD.n725 VSS 0.07434f ; **FLOATING
C8376 VDD.t1116 VSS 0.03913f ; **FLOATING
C8377 VDD.t1307 VSS 0.03913f ; **FLOATING
C8378 VDD.n726 VSS 0.09345f ; **FLOATING
C8379 VDD.n727 VSS 0.01253f ; **FLOATING
C8380 VDD.t1110 VSS 0.03511f ; **FLOATING
C8381 VDD.t886 VSS 0.03523f ; **FLOATING
C8382 VDD.t1087 VSS 0.03511f ; **FLOATING
C8383 VDD.n728 VSS 0.07356f ; **FLOATING
C8384 VDD.n729 VSS 0.01381f ; **FLOATING
C8385 VDD.t919 VSS 0.03511f ; **FLOATING
C8386 VDD.t1434 VSS 0.03511f ; **FLOATING
C8387 VDD.t598 VSS 0.03511f ; **FLOATING
C8388 VDD.t54 VSS 0.03152f ; **FLOATING
C8389 VDD.t93 VSS 0.03153f ; **FLOATING
C8390 VDD.t1175 VSS 0.03511f ; **FLOATING
C8391 VDD.t1698 VSS 0.11644f ; **FLOATING
C8392 VDD.t53 VSS 0.03384f ; **FLOATING
C8393 VDD.t538 VSS 0.04608f ; **FLOATING
C8394 VDD.t1697 VSS 0.11644f ; **FLOATING
C8395 VDD.t94 VSS 0.03384f ; **FLOATING
C8396 VDD.t1431 VSS 0.03511f ; **FLOATING
C8397 VDD.t217 VSS 0.03152f ; **FLOATING
C8398 VDD.t218 VSS 0.03153f ; **FLOATING
C8399 VDD.t221 VSS 0.03152f ; **FLOATING
C8400 VDD.t1172 VSS 0.03511f ; **FLOATING
C8401 VDD.t832 VSS 0.03511f ; **FLOATING
C8402 VDD.t698 VSS 0.03511f ; **FLOATING
C8403 VDD.t1066 VSS 0.03511f ; **FLOATING
C8404 VDD.t57 VSS 0.03153f ; **FLOATING
C8405 VDD.t551 VSS 0.04608f ; **FLOATING
C8406 VDD.t1049 VSS 0.03511f ; **FLOATING
C8407 VDD.t202 VSS 0.03152f ; **FLOATING
C8408 VDD.t922 VSS 0.03511f ; **FLOATING
C8409 VDD.t148 VSS 0.03153f ; **FLOATING
C8410 VDD.t1033 VSS 0.03511f ; **FLOATING
C8411 VDD.t211 VSS 0.03152f ; **FLOATING
C8412 VDD.t212 VSS 0.03153f ; **FLOATING
C8413 VDD.t1161 VSS 0.04625f ; **FLOATING
C8414 VDD.t888 VSS 0.03511f ; **FLOATING
C8415 VDD.t215 VSS 0.03152f ; **FLOATING
C8416 VDD.t605 VSS 0.03511f ; **FLOATING
C8417 VDD.t608 VSS 0.03511f ; **FLOATING
C8418 VDD.t1067 VSS 0.03511f ; **FLOATING
C8419 VDD.t267 VSS 0.03153f ; **FLOATING
C8420 VDD.t602 VSS 0.04608f ; **FLOATING
C8421 VDD.t199 VSS 0.03152f ; **FLOATING
C8422 VDD.t492 VSS 0.03511f ; **FLOATING
C8423 VDD.t5 VSS 0.03153f ; **FLOATING
C8424 VDD.t973 VSS 0.03511f ; **FLOATING
C8425 VDD.t1088 VSS 0.03511f ; **FLOATING
C8426 VDD.t204 VSS 0.03152f ; **FLOATING
C8427 VDD.t205 VSS 0.03153f ; **FLOATING
C8428 VDD.t208 VSS 0.03152f ; **FLOATING
C8429 VDD.t1073 VSS 0.03511f ; **FLOATING
C8430 VDD.t976 VSS 0.03511f ; **FLOATING
C8431 VDD.t660 VSS 0.03511f ; **FLOATING
C8432 VDD.t1456 VSS 0.03511f ; **FLOATING
C8433 VDD.t457 VSS 0.04608f ; **FLOATING
C8434 VDD.t1459 VSS 0.03511f ; **FLOATING
C8435 VDD.t628 VSS 0.03511f ; **FLOATING
C8436 VDD.t1001 VSS 0.03511f ; **FLOATING
C8437 VDD.t658 VSS 0.03511f ; **FLOATING
C8438 VDD.t1328 VSS 0.03728f ; **FLOATING
C8439 VDD.t925 VSS 0.04608f ; **FLOATING
C8440 VDD.t1336 VSS 0.06583f ; **FLOATING
C8441 VDD.t604 VSS 0.03511f ; **FLOATING
C8442 VDD.t630 VSS 0.03511f ; **FLOATING
C8443 VDD.t577 VSS 0.03511f ; **FLOATING
C8444 VDD.t1394 VSS 0.03511f ; **FLOATING
C8445 VDD.t101 VSS 0.03153f ; **FLOATING
C8446 VDD.t1186 VSS 0.04608f ; **FLOATING
C8447 VDD.t1086 VSS 0.03511f ; **FLOATING
C8448 VDD.t230 VSS 0.03152f ; **FLOATING
C8449 VDD.t615 VSS 0.03511f ; **FLOATING
C8450 VDD.t172 VSS 0.03153f ; **FLOATING
C8451 VDD.t1034 VSS 0.03511f ; **FLOATING
C8452 VDD.t151 VSS 0.03152f ; **FLOATING
C8453 VDD.t152 VSS 0.03153f ; **FLOATING
C8454 VDD.t1170 VSS 0.04625f ; **FLOATING
C8455 VDD.t978 VSS 0.03511f ; **FLOATING
C8456 VDD.t155 VSS 0.03152f ; **FLOATING
C8457 VDD.t1048 VSS 0.03511f ; **FLOATING
C8458 VDD.t699 VSS 0.03511f ; **FLOATING
C8459 VDD.t1020 VSS 0.03511f ; **FLOATING
C8460 VDD.t85 VSS 0.03153f ; **FLOATING
C8461 VDD.t534 VSS 0.04608f ; **FLOATING
C8462 VDD.t1464 VSS 0.03152f ; **FLOATING
C8463 VDD.t493 VSS 0.03511f ; **FLOATING
C8464 VDD.t200 VSS 0.03153f ; **FLOATING
C8465 VDD.t834 VSS 0.03511f ; **FLOATING
C8466 VDD.t1573 VSS 0.03511f ; **FLOATING
C8467 VDD.t105 VSS 0.03152f ; **FLOATING
C8468 VDD.t106 VSS 0.03153f ; **FLOATING
C8469 VDD.t109 VSS 0.03152f ; **FLOATING
C8470 VDD.t1410 VSS 0.03511f ; **FLOATING
C8471 VDD.t1499 VSS 0.03511f ; **FLOATING
C8472 VDD.t623 VSS 0.03511f ; **FLOATING
C8473 VDD.t1069 VSS 0.03511f ; **FLOATING
C8474 VDD.t233 VSS 0.03153f ; **FLOATING
C8475 VDD.t565 VSS 0.04608f ; **FLOATING
C8476 VDD.t1460 VSS 0.03511f ; **FLOATING
C8477 VDD.t1600 VSS 0.03152f ; **FLOATING
C8478 VDD.t890 VSS 0.03511f ; **FLOATING
C8479 VDD.t128 VSS 0.03153f ; **FLOATING
C8480 VDD.t705 VSS 0.03511f ; **FLOATING
C8481 VDD.t1602 VSS 0.03152f ; **FLOATING
C8482 VDD.t1603 VSS 0.03153f ; **FLOATING
C8483 VDD.t1188 VSS 0.04625f ; **FLOATING
C8484 VDD.t932 VSS 0.03511f ; **FLOATING
C8485 VDD.t1606 VSS 0.03152f ; **FLOATING
C8486 VDD.t283 VSS 0.03511f ; **FLOATING
C8487 VDD.t916 VSS 0.03511f ; **FLOATING
C8488 VDD.t1398 VSS 0.03511f ; **FLOATING
C8489 VDD.t460 VSS 0.04608f ; **FLOATING
C8490 VDD.t599 VSS 0.04222f ; **FLOATING
C8491 VDD.t1681 VSS 0.11644f ; **FLOATING
C8492 VDD.t1604 VSS 0.03384f ; **FLOATING
C8493 VDD.t1682 VSS 0.11644f ; **FLOATING
C8494 VDD.t129 VSS 0.03384f ; **FLOATING
C8495 VDD.t1683 VSS 0.11644f ; **FLOATING
C8496 VDD.t234 VSS 0.03384f ; **FLOATING
C8497 VDD.t1122 VSS 0.04625f ; **FLOATING
C8498 VDD.t1684 VSS 0.11644f ; **FLOATING
C8499 VDD.t107 VSS 0.03384f ; **FLOATING
C8500 VDD.t1685 VSS 0.11644f ; **FLOATING
C8501 VDD.t104 VSS 0.03384f ; **FLOATING
C8502 VDD.t1686 VSS 0.11644f ; **FLOATING
C8503 VDD.t86 VSS 0.03384f ; **FLOATING
C8504 VDD.t1687 VSS 0.11644f ; **FLOATING
C8505 VDD.t153 VSS 0.03384f ; **FLOATING
C8506 VDD.t1688 VSS 0.11644f ; **FLOATING
C8507 VDD.t150 VSS 0.03384f ; **FLOATING
C8508 VDD.t1689 VSS 0.11644f ; **FLOATING
C8509 VDD.t102 VSS 0.03384f ; **FLOATING
C8510 VDD.n730 VSS 0.06615f ; **FLOATING
C8511 VDD.n731 VSS 0.01381f ; **FLOATING
C8512 VDD.n732 VSS 0.07821f ; **FLOATING
C8513 VDD.n733 VSS 0.01184f ; **FLOATING
C8514 VDD.n734 VSS 0.06899f ; **FLOATING
C8515 VDD.n735 VSS 0.01381f ; **FLOATING
C8516 VDD.n736 VSS 0.08508f ; **FLOATING
C8517 VDD.t554 VSS 0.04625f ; **FLOATING
C8518 VDD.t1690 VSS 0.11644f ; **FLOATING
C8519 VDD.t206 VSS 0.03384f ; **FLOATING
C8520 VDD.t1691 VSS 0.11644f ; **FLOATING
C8521 VDD.t6 VSS 0.03384f ; **FLOATING
C8522 VDD.t1692 VSS 0.11644f ; **FLOATING
C8523 VDD.t198 VSS 0.03384f ; **FLOATING
C8524 VDD.t1693 VSS 0.11644f ; **FLOATING
C8525 VDD.t213 VSS 0.03384f ; **FLOATING
C8526 VDD.t1694 VSS 0.11644f ; **FLOATING
C8527 VDD.t149 VSS 0.03384f ; **FLOATING
C8528 VDD.t1695 VSS 0.11644f ; **FLOATING
C8529 VDD.t58 VSS 0.03384f ; **FLOATING
C8530 VDD.t839 VSS 0.04625f ; **FLOATING
C8531 VDD.t1696 VSS 0.11644f ; **FLOATING
C8532 VDD.t219 VSS 0.03384f ; **FLOATING
C8533 VDD.n737 VSS 1.96542f ; **FLOATING
C8534 VDD.t760 VSS 0.07114f ; **FLOATING
C8535 VDD.n738 VSS 0.05148f ; **FLOATING
C8536 VDD.n739 VSS 0.05148f ; **FLOATING
C8537 VDD.n740 VSS 0.05148f ; **FLOATING
C8538 VDD.n741 VSS 0.05148f ; **FLOATING
C8539 VDD.n742 VSS 0.05156f ; **FLOATING
C8540 VDD.n743 VSS 0.05156f ; **FLOATING
C8541 VDD.n744 VSS 0.05156f ; **FLOATING
C8542 VDD.n745 VSS 0.05148f ; **FLOATING
C8543 VDD.n746 VSS 0.05156f ; **FLOATING
C8544 VDD.n747 VSS 0.05156f ; **FLOATING
C8545 VDD.n748 VSS 0.05148f ; **FLOATING
C8546 VDD.n749 VSS 0.05148f ; **FLOATING
C8547 VDD.n750 VSS 0.05148f ; **FLOATING
C8548 VDD.n751 VSS 0.05156f ; **FLOATING
C8549 VDD.n752 VSS 0.05148f ; **FLOATING
C8550 VDD.n753 VSS 0.05156f ; **FLOATING
C8551 VDD.n754 VSS 0.05156f ; **FLOATING
C8552 VDD.n755 VSS 0.05156f ; **FLOATING
C8553 VDD.n756 VSS 0.05148f ; **FLOATING
C8554 VDD.n757 VSS 0.05148f ; **FLOATING
C8555 VDD.n758 VSS 0.05148f ; **FLOATING
C8556 VDD.n759 VSS 0.05148f ; **FLOATING
C8557 VDD.n760 VSS 0.05156f ; **FLOATING
C8558 VDD.n761 VSS 0.05148f ; **FLOATING
C8559 VDD.n762 VSS 0.05148f ; **FLOATING
C8560 VDD.n763 VSS 0.05148f ; **FLOATING
C8561 VDD.n764 VSS 0.05148f ; **FLOATING
C8562 VDD.n765 VSS 0.05148f ; **FLOATING
C8563 VDD.n766 VSS 0.05156f ; **FLOATING
C8564 VDD.n767 VSS 0.05148f ; **FLOATING
C8565 VDD.n768 VSS 0.05148f ; **FLOATING
C8566 VDD.t755 VSS 0.02458f ; **FLOATING
C8567 VDD.t756 VSS 0.03446f ; **FLOATING
C8568 VDD.t759 VSS 0.03431f ; **FLOATING
C8569 VDD.t757 VSS 0.0379f ; **FLOATING
C8570 VDD.t758 VSS 0.01994f ; **FLOATING
C8571 VDD.t316 VSS 0.03391f ; **FLOATING
C8572 VDD.n769 VSS 0.10265f ; **FLOATING
C8573 VDD.n770 VSS 0.02515f ; **FLOATING
C8574 VDD.n771 VSS 0.07976f ; **FLOATING
C8575 VDD.n772 VSS 0.01474f ; **FLOATING
C8576 VDD.t1338 VSS 0.03978f ; **FLOATING
C8577 VDD.n773 VSS 0.08284f ; **FLOATING
C8578 VDD.n774 VSS 0.03626f ; **FLOATING
C8579 VDD.t343 VSS 0.03391f ; **FLOATING
C8580 VDD.n775 VSS 0.11151f ; **FLOATING
C8581 VDD.n776 VSS 0.02515f ; **FLOATING
C8582 VDD.n777 VSS 0.06307f ; **FLOATING
C8583 VDD.n778 VSS 0.01474f ; **FLOATING
C8584 VDD.t1344 VSS 0.03978f ; **FLOATING
C8585 VDD.n779 VSS 0.08281f ; **FLOATING
C8586 VDD.n780 VSS 0.0363f ; **FLOATING
C8587 VDD.t345 VSS 0.03391f ; **FLOATING
C8588 VDD.n781 VSS 0.11149f ; **FLOATING
C8589 VDD.n782 VSS 0.02515f ; **FLOATING
C8590 VDD.n783 VSS 0.06304f ; **FLOATING
C8591 VDD.n784 VSS 0.01472f ; **FLOATING
C8592 VDD.t1342 VSS 0.03978f ; **FLOATING
C8593 VDD.n785 VSS 0.08284f ; **FLOATING
C8594 VDD.n786 VSS 0.03632f ; **FLOATING
C8595 VDD.t302 VSS 0.03391f ; **FLOATING
C8596 VDD.n787 VSS 0.11145f ; **FLOATING
C8597 VDD.n788 VSS 0.02515f ; **FLOATING
C8598 VDD.n789 VSS 0.06303f ; **FLOATING
C8599 VDD.n790 VSS 0.01474f ; **FLOATING
C8600 VDD.t1353 VSS 0.03978f ; **FLOATING
C8601 VDD.n791 VSS 0.0828f ; **FLOATING
C8602 VDD.n792 VSS 0.03631f ; **FLOATING
C8603 VDD.t342 VSS 0.03391f ; **FLOATING
C8604 VDD.n793 VSS 0.11151f ; **FLOATING
C8605 VDD.n794 VSS 0.02515f ; **FLOATING
C8606 VDD.n795 VSS 0.06306f ; **FLOATING
C8607 VDD.n796 VSS 0.01474f ; **FLOATING
C8608 VDD.t1330 VSS 0.03978f ; **FLOATING
C8609 VDD.n797 VSS 0.08281f ; **FLOATING
C8610 VDD.n798 VSS 0.0363f ; **FLOATING
C8611 VDD.t346 VSS 0.03391f ; **FLOATING
C8612 VDD.n799 VSS 0.11151f ; **FLOATING
C8613 VDD.n800 VSS 0.02515f ; **FLOATING
C8614 VDD.n801 VSS 0.06304f ; **FLOATING
C8615 VDD.n802 VSS 0.01472f ; **FLOATING
C8616 VDD.t1362 VSS 0.03978f ; **FLOATING
C8617 VDD.n803 VSS 0.08282f ; **FLOATING
C8618 VDD.n804 VSS 0.03636f ; **FLOATING
C8619 VDD.t349 VSS 0.03391f ; **FLOATING
C8620 VDD.n805 VSS 0.11151f ; **FLOATING
C8621 VDD.n806 VSS 0.02515f ; **FLOATING
C8622 VDD.n807 VSS 0.06301f ; **FLOATING
C8623 VDD.n808 VSS 0.01474f ; **FLOATING
C8624 VDD.t1363 VSS 0.03978f ; **FLOATING
C8625 VDD.n809 VSS 0.08281f ; **FLOATING
C8626 VDD.n810 VSS 0.0363f ; **FLOATING
C8627 VDD.t344 VSS 0.03391f ; **FLOATING
C8628 VDD.n811 VSS 0.11151f ; **FLOATING
C8629 VDD.n812 VSS 0.02515f ; **FLOATING
C8630 VDD.n813 VSS 0.06305f ; **FLOATING
C8631 VDD.n814 VSS 0.01474f ; **FLOATING
C8632 VDD.t1349 VSS 0.03978f ; **FLOATING
C8633 VDD.n815 VSS 0.08283f ; **FLOATING
C8634 VDD.n816 VSS 0.03628f ; **FLOATING
C8635 VDD.t348 VSS 0.03391f ; **FLOATING
C8636 VDD.n817 VSS 0.11149f ; **FLOATING
C8637 VDD.n818 VSS 0.02515f ; **FLOATING
C8638 VDD.n819 VSS 0.06304f ; **FLOATING
C8639 VDD.n820 VSS 0.01472f ; **FLOATING
C8640 VDD.t1364 VSS 0.03978f ; **FLOATING
C8641 VDD.n821 VSS 0.08282f ; **FLOATING
C8642 VDD.n822 VSS 0.03631f ; **FLOATING
C8643 VDD.t350 VSS 0.03391f ; **FLOATING
C8644 VDD.n823 VSS 0.11145f ; **FLOATING
C8645 VDD.n824 VSS 0.02515f ; **FLOATING
C8646 VDD.n825 VSS 0.06306f ; **FLOATING
C8647 VDD.n826 VSS 0.01474f ; **FLOATING
C8648 VDD.t1350 VSS 0.03978f ; **FLOATING
C8649 VDD.n827 VSS 0.08282f ; **FLOATING
C8650 VDD.n828 VSS 0.03625f ; **FLOATING
C8651 VDD.t347 VSS 0.03391f ; **FLOATING
C8652 VDD.n829 VSS 0.11151f ; **FLOATING
C8653 VDD.n830 VSS 0.02515f ; **FLOATING
C8654 VDD.n831 VSS 0.06309f ; **FLOATING
C8655 VDD.n832 VSS 0.01474f ; **FLOATING
C8656 VDD.t1346 VSS 0.03978f ; **FLOATING
C8657 VDD.n833 VSS 0.08281f ; **FLOATING
C8658 VDD.n834 VSS 0.0363f ; **FLOATING
C8659 VDD.t351 VSS 0.03391f ; **FLOATING
C8660 VDD.n835 VSS 0.11151f ; **FLOATING
C8661 VDD.n836 VSS 0.02515f ; **FLOATING
C8662 VDD.n837 VSS 0.06306f ; **FLOATING
C8663 VDD.n838 VSS 0.01474f ; **FLOATING
C8664 VDD.t1386 VSS 0.03978f ; **FLOATING
C8665 VDD.n839 VSS 0.08281f ; **FLOATING
C8666 VDD.n840 VSS 0.0363f ; **FLOATING
C8667 VDD.t309 VSS 0.03391f ; **FLOATING
C8668 VDD.n841 VSS 0.11151f ; **FLOATING
C8669 VDD.n842 VSS 0.02515f ; **FLOATING
C8670 VDD.n843 VSS 0.06304f ; **FLOATING
C8671 VDD.n844 VSS 0.01472f ; **FLOATING
C8672 VDD.t1379 VSS 0.03978f ; **FLOATING
C8673 VDD.n845 VSS 0.08284f ; **FLOATING
C8674 VDD.n846 VSS 0.0363f ; **FLOATING
C8675 VDD.t352 VSS 0.03391f ; **FLOATING
C8676 VDD.n847 VSS 0.11149f ; **FLOATING
C8677 VDD.n848 VSS 0.02515f ; **FLOATING
C8678 VDD.n849 VSS 0.06305f ; **FLOATING
C8679 VDD.n850 VSS 0.01472f ; **FLOATING
C8680 VDD.t1381 VSS 0.03978f ; **FLOATING
C8681 VDD.n851 VSS 0.08282f ; **FLOATING
C8682 VDD.n852 VSS 0.03634f ; **FLOATING
C8683 VDD.t311 VSS 0.03391f ; **FLOATING
C8684 VDD.n853 VSS 0.11142f ; **FLOATING
C8685 VDD.n854 VSS 0.02515f ; **FLOATING
C8686 VDD.n855 VSS 0.06303f ; **FLOATING
C8687 VDD.n856 VSS 0.01472f ; **FLOATING
C8688 VDD.t1405 VSS 0.03978f ; **FLOATING
C8689 VDD.n857 VSS 0.08285f ; **FLOATING
C8690 VDD.n858 VSS 0.03625f ; **FLOATING
C8691 VDD.t310 VSS 0.03391f ; **FLOATING
C8692 VDD.n859 VSS 0.11142f ; **FLOATING
C8693 VDD.n860 VSS 0.02515f ; **FLOATING
C8694 VDD.n861 VSS 0.06309f ; **FLOATING
C8695 VDD.n862 VSS 0.01472f ; **FLOATING
C8696 VDD.t1396 VSS 0.03978f ; **FLOATING
C8697 VDD.n863 VSS 0.08282f ; **FLOATING
C8698 VDD.n864 VSS 0.03636f ; **FLOATING
C8699 VDD.t357 VSS 0.03391f ; **FLOATING
C8700 VDD.n865 VSS 0.11145f ; **FLOATING
C8701 VDD.n866 VSS 0.02515f ; **FLOATING
C8702 VDD.n867 VSS 0.06301f ; **FLOATING
C8703 VDD.n868 VSS 0.01474f ; **FLOATING
C8704 VDD.t1555 VSS 0.03978f ; **FLOATING
C8705 VDD.n869 VSS 0.08282f ; **FLOATING
C8706 VDD.n870 VSS 0.03625f ; **FLOATING
C8707 VDD.t354 VSS 0.03391f ; **FLOATING
C8708 VDD.n871 VSS 0.11149f ; **FLOATING
C8709 VDD.n872 VSS 0.02515f ; **FLOATING
C8710 VDD.n873 VSS 0.0631f ; **FLOATING
C8711 VDD.n874 VSS 0.01474f ; **FLOATING
C8712 VDD.t1389 VSS 0.03978f ; **FLOATING
C8713 VDD.n875 VSS 0.08282f ; **FLOATING
C8714 VDD.n876 VSS 0.0363f ; **FLOATING
C8715 VDD.t353 VSS 0.03391f ; **FLOATING
C8716 VDD.n877 VSS 0.11145f ; **FLOATING
C8717 VDD.n878 VSS 0.02515f ; **FLOATING
C8718 VDD.n879 VSS 0.06305f ; **FLOATING
C8719 VDD.n880 VSS 0.01474f ; **FLOATING
C8720 VDD.t1388 VSS 0.03978f ; **FLOATING
C8721 VDD.n881 VSS 0.08282f ; **FLOATING
C8722 VDD.n882 VSS 0.03625f ; **FLOATING
C8723 VDD.t361 VSS 0.03391f ; **FLOATING
C8724 VDD.n883 VSS 0.11151f ; **FLOATING
C8725 VDD.n884 VSS 0.02515f ; **FLOATING
C8726 VDD.n885 VSS 0.06308f ; **FLOATING
C8727 VDD.n886 VSS 0.01472f ; **FLOATING
C8728 VDD.t1420 VSS 0.03978f ; **FLOATING
C8729 VDD.n887 VSS 0.08284f ; **FLOATING
C8730 VDD.n888 VSS 0.0363f ; **FLOATING
C8731 VDD.t362 VSS 0.03391f ; **FLOATING
C8732 VDD.n889 VSS 0.11151f ; **FLOATING
C8733 VDD.n890 VSS 0.02515f ; **FLOATING
C8734 VDD.n891 VSS 0.06304f ; **FLOATING
C8735 VDD.n892 VSS 0.01472f ; **FLOATING
C8736 VDD.t1411 VSS 0.03978f ; **FLOATING
C8737 VDD.n893 VSS 0.08285f ; **FLOATING
C8738 VDD.n894 VSS 0.03625f ; **FLOATING
C8739 VDD.t358 VSS 0.03391f ; **FLOATING
C8740 VDD.n895 VSS 0.11149f ; **FLOATING
C8741 VDD.n896 VSS 0.02515f ; **FLOATING
C8742 VDD.n897 VSS 0.0631f ; **FLOATING
C8743 VDD.n898 VSS 0.01474f ; **FLOATING
C8744 VDD.t1220 VSS 0.03978f ; **FLOATING
C8745 VDD.n899 VSS 0.08279f ; **FLOATING
C8746 VDD.n900 VSS 0.03634f ; **FLOATING
C8747 VDD.t360 VSS 0.03391f ; **FLOATING
C8748 VDD.n901 VSS 0.11142f ; **FLOATING
C8749 VDD.n902 VSS 0.02515f ; **FLOATING
C8750 VDD.n903 VSS 0.06304f ; **FLOATING
C8751 VDD.n904 VSS 0.01474f ; **FLOATING
C8752 VDD.t1219 VSS 0.03978f ; **FLOATING
C8753 VDD.n905 VSS 0.08282f ; **FLOATING
C8754 VDD.n906 VSS 0.03625f ; **FLOATING
C8755 VDD.t359 VSS 0.03391f ; **FLOATING
C8756 VDD.n907 VSS 0.11145f ; **FLOATING
C8757 VDD.n908 VSS 0.02515f ; **FLOATING
C8758 VDD.n909 VSS 0.06309f ; **FLOATING
C8759 VDD.n910 VSS 0.01474f ; **FLOATING
C8760 VDD.t1218 VSS 0.03978f ; **FLOATING
C8761 VDD.n911 VSS 0.08281f ; **FLOATING
C8762 VDD.n912 VSS 0.0363f ; **FLOATING
C8763 VDD.t365 VSS 0.03391f ; **FLOATING
C8764 VDD.n913 VSS 0.11149f ; **FLOATING
C8765 VDD.n914 VSS 0.02515f ; **FLOATING
C8766 VDD.n915 VSS 0.06305f ; **FLOATING
C8767 VDD.n916 VSS 0.01474f ; **FLOATING
C8768 VDD.t896 VSS 0.03978f ; **FLOATING
C8769 VDD.n917 VSS 0.0828f ; **FLOATING
C8770 VDD.n918 VSS 0.03631f ; **FLOATING
C8771 VDD.t356 VSS 0.03391f ; **FLOATING
C8772 VDD.n919 VSS 0.11142f ; **FLOATING
C8773 VDD.n920 VSS 0.02515f ; **FLOATING
C8774 VDD.n921 VSS 0.06306f ; **FLOATING
C8775 VDD.n922 VSS 0.01474f ; **FLOATING
C8776 VDD.t950 VSS 0.03978f ; **FLOATING
C8777 VDD.n923 VSS 0.08282f ; **FLOATING
C8778 VDD.n924 VSS 0.03632f ; **FLOATING
C8779 VDD.t364 VSS 0.03391f ; **FLOATING
C8780 VDD.n925 VSS 0.11142f ; **FLOATING
C8781 VDD.n926 VSS 0.02515f ; **FLOATING
C8782 VDD.n927 VSS 0.06303f ; **FLOATING
C8783 VDD.n928 VSS 0.01474f ; **FLOATING
C8784 VDD.t992 VSS 0.03978f ; **FLOATING
C8785 VDD.n929 VSS 0.08279f ; **FLOATING
C8786 VDD.n930 VSS 0.03636f ; **FLOATING
C8787 VDD.t304 VSS 0.03391f ; **FLOATING
C8788 VDD.n931 VSS 0.11145f ; **FLOATING
C8789 VDD.n932 VSS 0.02515f ; **FLOATING
C8790 VDD.n933 VSS 0.063f ; **FLOATING
C8791 VDD.n934 VSS 0.01472f ; **FLOATING
C8792 VDD.t903 VSS 0.03978f ; **FLOATING
C8793 VDD.n935 VSS 0.08284f ; **FLOATING
C8794 VDD.n936 VSS 0.03632f ; **FLOATING
C8795 VDD.t363 VSS 0.03391f ; **FLOATING
C8796 VDD.n937 VSS 0.11151f ; **FLOATING
C8797 VDD.n938 VSS 0.02515f ; **FLOATING
C8798 VDD.n939 VSS 0.06303f ; **FLOATING
C8799 VDD.n940 VSS 0.01474f ; **FLOATING
C8800 VDD.t900 VSS 0.03978f ; **FLOATING
C8801 VDD.n941 VSS 0.08281f ; **FLOATING
C8802 VDD.n942 VSS 0.0363f ; **FLOATING
C8803 VDD.t355 VSS 0.03391f ; **FLOATING
C8804 VDD.n943 VSS 0.11151f ; **FLOATING
C8805 VDD.n944 VSS 0.02515f ; **FLOATING
C8806 VDD.n945 VSS 0.06305f ; **FLOATING
C8807 VDD.n946 VSS 0.01474f ; **FLOATING
C8808 VDD.t1269 VSS 0.03978f ; **FLOATING
C8809 VDD.n947 VSS 0.08283f ; **FLOATING
C8810 VDD.n948 VSS 0.03631f ; **FLOATING
C8811 VDD.t318 VSS 0.03391f ; **FLOATING
C8812 VDD.n949 VSS 0.11151f ; **FLOATING
C8813 VDD.n950 VSS 0.02515f ; **FLOATING
C8814 VDD.n951 VSS 0.06303f ; **FLOATING
C8815 VDD.n952 VSS 0.01474f ; **FLOATING
C8816 VDD.t589 VSS 0.03978f ; **FLOATING
C8817 VDD.n953 VSS 0.0828f ; **FLOATING
C8818 VDD.n954 VSS 0.03631f ; **FLOATING
C8819 VDD.t366 VSS 0.03391f ; **FLOATING
C8820 VDD.n955 VSS 0.0923f ; **FLOATING
C8821 VDD.n956 VSS 0.02515f ; **FLOATING
C8822 VDD.n957 VSS 0.06306f ; **FLOATING
C8823 VDD.n958 VSS 0.01474f ; **FLOATING
C8824 VDD.t907 VSS 0.03978f ; **FLOATING
C8825 VDD.n959 VSS 0.06313f ; **FLOATING
C8826 VDD.n960 VSS 0.01517f ; **FLOATING
C8827 VDD.t761 VSS 0.03391f ; **FLOATING
C8828 VDD.n961 VSS 0.02515f ; **FLOATING
C8829 VDD.t762 VSS 0.0379f ; **FLOATING
C8830 VDD.n962 VSS 0.07448f ; **FLOATING
C8831 VDD.t765 VSS 0.03391f ; **FLOATING
C8832 VDD.n963 VSS 0.02251f ; **FLOATING
C8833 VDD.t763 VSS 0.03277f ; **FLOATING
C8834 VDD.n964 VSS 0.01671f ; **FLOATING
C8835 VDD.n965 VSS 0.06321f ; **FLOATING
C8836 VDD.n966 VSS 0.05429f ; **FLOATING
C8837 VDD.t507 VSS 0.03511f ; **FLOATING
C8838 VDD.t1545 VSS 0.03511f ; **FLOATING
C8839 VDD.t209 VSS 0.03153f ; **FLOATING
C8840 VDD.t475 VSS 0.03511f ; **FLOATING
C8841 VDD.n967 VSS 0.02899f ; **FLOATING
C8842 VDD.t1286 VSS 0.04608f ; **FLOATING
C8843 VDD.n968 VSS 0.08838f ; **FLOATING
C8844 VDD.n969 VSS 0.02585f ; **FLOATING
C8845 VDD.t1062 VSS 0.03511f ; **FLOATING
C8846 VDD.n970 VSS 0.08379f ; **FLOATING
C8847 VDD.n971 VSS 0.0123f ; **FLOATING
C8848 VDD.t591 VSS 0.03913f ; **FLOATING
C8849 VDD.t1418 VSS 0.03913f ; **FLOATING
C8850 VDD.t1283 VSS 0.03913f ; **FLOATING
C8851 VDD.t1557 VSS 0.03913f ; **FLOATING
C8852 VDD.t1538 VSS 0.03511f ; **FLOATING
C8853 VDD.t484 VSS 0.03511f ; **FLOATING
C8854 VDD.n972 VSS 0.10156f ; **FLOATING
C8855 VDD.n973 VSS 0.01607f ; **FLOATING
C8856 VDD.t1553 VSS 0.02593f ; **FLOATING
C8857 VDD.t1564 VSS 0.02593f ; **FLOATING
C8858 VDD.n974 VSS 0.08955f ; **FLOATING
C8859 VDD.t607 VSS 0.03466f ; **FLOATING
C8860 VDD.t1416 VSS 0.03466f ; **FLOATING
C8861 VDD.t506 VSS 0.02593f ; **FLOATING
C8862 VDD.t1544 VSS 0.02593f ; **FLOATING
C8863 VDD.t590 VSS 0.03466f ; **FLOATING
C8864 VDD.t1415 VSS 0.03466f ; **FLOATING
C8865 VDD.t1539 VSS 0.02593f ; **FLOATING
C8866 VDD.t485 VSS 0.02593f ; **FLOATING
C8867 VDD.t541 VSS 0.03466f ; **FLOATING
C8868 VDD.t1427 VSS 0.03466f ; **FLOATING
C8869 VDD.n975 VSS 0.0818f ; **FLOATING
C8870 VDD.t542 VSS 0.03913f ; **FLOATING
C8871 VDD.t1428 VSS 0.03913f ; **FLOATING
C8872 VDD.t508 VSS 0.02593f ; **FLOATING
C8873 VDD.t1543 VSS 0.02593f ; **FLOATING
C8874 VDD.t1225 VSS 0.03466f ; **FLOATING
C8875 VDD.t483 VSS 0.03466f ; **FLOATING
C8876 VDD.n976 VSS 0.07434f ; **FLOATING
C8877 VDD.t1226 VSS 0.03913f ; **FLOATING
C8878 VDD.t1407 VSS 0.03913f ; **FLOATING
C8879 VDD.n977 VSS 0.09345f ; **FLOATING
C8880 VDD.n978 VSS 0.01253f ; **FLOATING
C8881 VDD.t1287 VSS 0.03511f ; **FLOATING
C8882 VDD.t1429 VSS 0.03523f ; **FLOATING
C8883 VDD.t1310 VSS 0.03511f ; **FLOATING
C8884 VDD.n979 VSS 0.07356f ; **FLOATING
C8885 VDD.n980 VSS 0.01381f ; **FLOATING
C8886 VDD.t1347 VSS 0.03511f ; **FLOATING
C8887 VDD.t1509 VSS 0.03511f ; **FLOATING
C8888 VDD.t1308 VSS 0.03511f ; **FLOATING
C8889 VDD.t175 VSS 0.03152f ; **FLOATING
C8890 VDD.t176 VSS 0.03153f ; **FLOATING
C8891 VDD.t1354 VSS 0.03511f ; **FLOATING
C8892 VDD.t1680 VSS 0.11644f ; **FLOATING
C8893 VDD.t174 VSS 0.03384f ; **FLOATING
C8894 VDD.t1050 VSS 0.04608f ; **FLOATING
C8895 VDD.t1679 VSS 0.11644f ; **FLOATING
C8896 VDD.t110 VSS 0.03384f ; **FLOATING
C8897 VDD.t1458 VSS 0.03511f ; **FLOATING
C8898 VDD.t111 VSS 0.03152f ; **FLOATING
C8899 VDD.t112 VSS 0.03153f ; **FLOATING
C8900 VDD.t115 VSS 0.03152f ; **FLOATING
C8901 VDD.t1090 VSS 0.03511f ; **FLOATING
C8902 VDD.t1361 VSS 0.03511f ; **FLOATING
C8903 VDD.t656 VSS 0.03511f ; **FLOATING
C8904 VDD.t1071 VSS 0.03511f ; **FLOATING
C8905 VDD.t142 VSS 0.03153f ; **FLOATING
C8906 VDD.t994 VSS 0.04608f ; **FLOATING
C8907 VDD.t1461 VSS 0.03511f ; **FLOATING
C8908 VDD.t1583 VSS 0.03152f ; **FLOATING
C8909 VDD.t1374 VSS 0.03511f ; **FLOATING
C8910 VDD.t1584 VSS 0.03153f ; **FLOATING
C8911 VDD.t1065 VSS 0.03511f ; **FLOATING
C8912 VDD.t74 VSS 0.03152f ; **FLOATING
C8913 VDD.t75 VSS 0.03153f ; **FLOATING
C8914 VDD.t1227 VSS 0.04625f ; **FLOATING
C8915 VDD.t1367 VSS 0.03511f ; **FLOATING
C8916 VDD.t78 VSS 0.03152f ; **FLOATING
C8917 VDD.t1091 VSS 0.03511f ; **FLOATING
C8918 VDD.t1511 VSS 0.03511f ; **FLOATING
C8919 VDD.t531 VSS 0.03511f ; **FLOATING
C8920 VDD.t173 VSS 0.03153f ; **FLOATING
C8921 VDD.t1289 VSS 0.04608f ; **FLOATING
C8922 VDD.t139 VSS 0.03152f ; **FLOATING
C8923 VDD.t995 VSS 0.03511f ; **FLOATING
C8924 VDD.t140 VSS 0.03153f ; **FLOATING
C8925 VDD.t1392 VSS 0.03511f ; **FLOATING
C8926 VDD.t917 VSS 0.03511f ; **FLOATING
C8927 VDD.t185 VSS 0.03152f ; **FLOATING
C8928 VDD.t186 VSS 0.03153f ; **FLOATING
C8929 VDD.t189 VSS 0.03152f ; **FLOATING
C8930 VDD.t501 VSS 0.03511f ; **FLOATING
C8931 VDD.t1558 VSS 0.03511f ; **FLOATING
C8932 VDD.t1085 VSS 0.03511f ; **FLOATING
C8933 VDD.t1229 VSS 0.03511f ; **FLOATING
C8934 VDD.t1404 VSS 0.04608f ; **FLOATING
C8935 VDD.t633 VSS 0.03511f ; **FLOATING
C8936 VDD.t1402 VSS 0.03511f ; **FLOATING
C8937 VDD.t580 VSS 0.03511f ; **FLOATING
C8938 VDD.t1063 VSS 0.03511f ; **FLOATING
C8939 VDD.t672 VSS 0.03728f ; **FLOATING
C8940 VDD.t970 VSS 0.04608f ; **FLOATING
C8941 VDD.t673 VSS 0.06583f ; **FLOATING
C8942 VDD.t1089 VSS 0.03511f ; **FLOATING
C8943 VDD.t1400 VSS 0.03511f ; **FLOATING
C8944 VDD.t1512 VSS 0.03511f ; **FLOATING
C8945 VDD.t1070 VSS 0.03511f ; **FLOATING
C8946 VDD.t116 VSS 0.03153f ; **FLOATING
C8947 VDD.t1055 VSS 0.04608f ; **FLOATING
C8948 VDD.t1068 VSS 0.03511f ; **FLOATING
C8949 VDD.t70 VSS 0.03152f ; **FLOATING
C8950 VDD.t1419 VSS 0.03511f ; **FLOATING
C8951 VDD.t71 VSS 0.03153f ; **FLOATING
C8952 VDD.t1064 VSS 0.03511f ; **FLOATING
C8953 VDD.t1588 VSS 0.03152f ; **FLOATING
C8954 VDD.t1589 VSS 0.03153f ; **FLOATING
C8955 VDD.t955 VSS 0.04625f ; **FLOATING
C8956 VDD.t1423 VSS 0.03511f ; **FLOATING
C8957 VDD.t1592 VSS 0.03152f ; **FLOATING
C8958 VDD.t1092 VSS 0.03511f ; **FLOATING
C8959 VDD.t657 VSS 0.03511f ; **FLOATING
C8960 VDD.t532 VSS 0.03511f ; **FLOATING
C8961 VDD.t51 VSS 0.03153f ; **FLOATING
C8962 VDD.t959 VSS 0.04608f ; **FLOATING
C8963 VDD.t1594 VSS 0.03152f ; **FLOATING
C8964 VDD.t996 VSS 0.03511f ; **FLOATING
C8965 VDD.t1595 VSS 0.03153f ; **FLOATING
C8966 VDD.t1247 VSS 0.03511f ; **FLOATING
C8967 VDD.t918 VSS 0.03511f ; **FLOATING
C8968 VDD.t191 VSS 0.03152f ; **FLOATING
C8969 VDD.t192 VSS 0.03153f ; **FLOATING
C8970 VDD.t195 VSS 0.03152f ; **FLOATING
C8971 VDD.t502 VSS 0.03511f ; **FLOATING
C8972 VDD.t951 VSS 0.03511f ; **FLOATING
C8973 VDD.t609 VSS 0.03511f ; **FLOATING
C8974 VDD.t1230 VSS 0.03511f ; **FLOATING
C8975 VDD.t165 VSS 0.03153f ; **FLOATING
C8976 VDD.t971 VSS 0.04608f ; **FLOATING
C8977 VDD.t634 VSS 0.03511f ; **FLOATING
C8978 VDD.t162 VSS 0.03152f ; **FLOATING
C8979 VDD.t904 VSS 0.03511f ; **FLOATING
C8980 VDD.t163 VSS 0.03153f ; **FLOATING
C8981 VDD.t1457 VSS 0.03511f ; **FLOATING
C8982 VDD.t224 VSS 0.03152f ; **FLOATING
C8983 VDD.t225 VSS 0.03153f ; **FLOATING
C8984 VDD.t690 VSS 0.04625f ; **FLOATING
C8985 VDD.t1270 VSS 0.03511f ; **FLOATING
C8986 VDD.t228 VSS 0.03152f ; **FLOATING
C8987 VDD.t943 VSS 0.03511f ; **FLOATING
C8988 VDD.t1051 VSS 0.03511f ; **FLOATING
C8989 VDD.t476 VSS 0.03511f ; **FLOATING
C8990 VDD.t588 VSS 0.04608f ; **FLOATING
C8991 VDD.t1309 VSS 0.04222f ; **FLOATING
C8992 VDD.t1663 VSS 0.11644f ; **FLOATING
C8993 VDD.t226 VSS 0.03384f ; **FLOATING
C8994 VDD.t1664 VSS 0.11644f ; **FLOATING
C8995 VDD.t164 VSS 0.03384f ; **FLOATING
C8996 VDD.t1665 VSS 0.11644f ; **FLOATING
C8997 VDD.t161 VSS 0.03384f ; **FLOATING
C8998 VDD.t958 VSS 0.04625f ; **FLOATING
C8999 VDD.t1666 VSS 0.11644f ; **FLOATING
C9000 VDD.t193 VSS 0.03384f ; **FLOATING
C9001 VDD.t1667 VSS 0.11644f ; **FLOATING
C9002 VDD.t190 VSS 0.03384f ; **FLOATING
C9003 VDD.t1668 VSS 0.11644f ; **FLOATING
C9004 VDD.t52 VSS 0.03384f ; **FLOATING
C9005 VDD.t1669 VSS 0.11644f ; **FLOATING
C9006 VDD.t1590 VSS 0.03384f ; **FLOATING
C9007 VDD.t1670 VSS 0.11644f ; **FLOATING
C9008 VDD.t72 VSS 0.03384f ; **FLOATING
C9009 VDD.t1671 VSS 0.11644f ; **FLOATING
C9010 VDD.t69 VSS 0.03384f ; **FLOATING
C9011 VDD.n981 VSS 0.06615f ; **FLOATING
C9012 VDD.n982 VSS 0.01381f ; **FLOATING
C9013 VDD.n983 VSS 0.07821f ; **FLOATING
C9014 VDD.n984 VSS 0.01184f ; **FLOATING
C9015 VDD.n985 VSS 0.06899f ; **FLOATING
C9016 VDD.n986 VSS 0.01381f ; **FLOATING
C9017 VDD.n987 VSS 0.08508f ; **FLOATING
C9018 VDD.t1288 VSS 0.04625f ; **FLOATING
C9019 VDD.t1672 VSS 0.11644f ; **FLOATING
C9020 VDD.t187 VSS 0.03384f ; **FLOATING
C9021 VDD.t1673 VSS 0.11644f ; **FLOATING
C9022 VDD.t141 VSS 0.03384f ; **FLOATING
C9023 VDD.t1674 VSS 0.11644f ; **FLOATING
C9024 VDD.t138 VSS 0.03384f ; **FLOATING
C9025 VDD.t1675 VSS 0.11644f ; **FLOATING
C9026 VDD.t76 VSS 0.03384f ; **FLOATING
C9027 VDD.t1676 VSS 0.11644f ; **FLOATING
C9028 VDD.t73 VSS 0.03384f ; **FLOATING
C9029 VDD.t1677 VSS 0.11644f ; **FLOATING
C9030 VDD.t143 VSS 0.03384f ; **FLOATING
C9031 VDD.t911 VSS 0.04625f ; **FLOATING
C9032 VDD.t1678 VSS 0.11644f ; **FLOATING
C9033 VDD.t113 VSS 0.03384f ; **FLOATING
C9034 VDD.n988 VSS 0.90365f ; **FLOATING
C9035 VDD.t1358 VSS 0.03511f ; **FLOATING
C9036 VDD.t1054 VSS 0.03511f ; **FLOATING
C9037 VDD.t247 VSS 0.03153f ; **FLOATING
C9038 VDD.t653 VSS 0.03511f ; **FLOATING
C9039 VDD.n989 VSS 0.02899f ; **FLOATING
C9040 VDD.t952 VSS 0.04608f ; **FLOATING
C9041 VDD.n990 VSS 0.08838f ; **FLOATING
C9042 VDD.n991 VSS 0.02585f ; **FLOATING
C9043 VDD.t997 VSS 0.03511f ; **FLOATING
C9044 VDD.n992 VSS 0.08379f ; **FLOATING
C9045 VDD.n993 VSS 0.0123f ; **FLOATING
C9046 VDD.t842 VSS 0.03913f ; **FLOATING
C9047 VDD.t1360 VSS 0.03913f ; **FLOATING
C9048 VDD.t1575 VSS 0.03913f ; **FLOATING
C9049 VDD.t1383 VSS 0.03913f ; **FLOATING
C9050 VDD.t1424 VSS 0.03511f ; **FLOATING
C9051 VDD.t1044 VSS 0.03511f ; **FLOATING
C9052 VDD.n994 VSS 0.10156f ; **FLOATING
C9053 VDD.n995 VSS 0.01607f ; **FLOATING
C9054 VDD.t873 VSS 0.02593f ; **FLOATING
C9055 VDD.t1385 VSS 0.02593f ; **FLOATING
C9056 VDD.n996 VSS 0.08955f ; **FLOATING
C9057 VDD.t540 VSS 0.03466f ; **FLOATING
C9058 VDD.t1373 VSS 0.03466f ; **FLOATING
C9059 VDD.t1356 VSS 0.02593f ; **FLOATING
C9060 VDD.t1052 VSS 0.02593f ; **FLOATING
C9061 VDD.t539 VSS 0.03466f ; **FLOATING
C9062 VDD.t1359 VSS 0.03466f ; **FLOATING
C9063 VDD.t1425 VSS 0.02593f ; **FLOATING
C9064 VDD.t1043 VSS 0.02593f ; **FLOATING
C9065 VDD.t631 VSS 0.03466f ; **FLOATING
C9066 VDD.t1369 VSS 0.03466f ; **FLOATING
C9067 VDD.n997 VSS 0.0818f ; **FLOATING
C9068 VDD.t632 VSS 0.03913f ; **FLOATING
C9069 VDD.t1370 VSS 0.03913f ; **FLOATING
C9070 VDD.t1357 VSS 0.02593f ; **FLOATING
C9071 VDD.t1053 VSS 0.02593f ; **FLOATING
C9072 VDD.t843 VSS 0.03466f ; **FLOATING
C9073 VDD.t1042 VSS 0.03466f ; **FLOATING
C9074 VDD.n998 VSS 0.07434f ; **FLOATING
C9075 VDD.t844 VSS 0.03913f ; **FLOATING
C9076 VDD.t1366 VSS 0.03913f ; **FLOATING
C9077 VDD.n999 VSS 0.09345f ; **FLOATING
C9078 VDD.n1000 VSS 0.01253f ; **FLOATING
C9079 VDD.t1224 VSS 0.03511f ; **FLOATING
C9080 VDD.t1479 VSS 0.03523f ; **FLOATING
C9081 VDD.t497 VSS 0.03511f ; **FLOATING
C9082 VDD.n1001 VSS 0.07356f ; **FLOATING
C9083 VDD.n1002 VSS 0.01381f ; **FLOATING
C9084 VDD.t647 VSS 0.03511f ; **FLOATING
C9085 VDD.t720 VSS 0.03511f ; **FLOATING
C9086 VDD.t1072 VSS 0.03511f ; **FLOATING
C9087 VDD.t26 VSS 0.03152f ; **FLOATING
C9088 VDD.t18 VSS 0.03153f ; **FLOATING
C9089 VDD.t1549 VSS 0.03511f ; **FLOATING
C9090 VDD.t1626 VSS 0.11644f ; **FLOATING
C9091 VDD.t25 VSS 0.03384f ; **FLOATING
C9092 VDD.t688 VSS 0.04608f ; **FLOATING
C9093 VDD.t1625 VSS 0.11644f ; **FLOATING
C9094 VDD.t8 VSS 0.03384f ; **FLOATING
C9095 VDD.t949 VSS 0.03511f ; **FLOATING
C9096 VDD.t9 VSS 0.03152f ; **FLOATING
C9097 VDD.t10 VSS 0.03153f ; **FLOATING
C9098 VDD.t13 VSS 0.03152f ; **FLOATING
C9099 VDD.t649 VSS 0.03511f ; **FLOATING
C9100 VDD.t870 VSS 0.03511f ; **FLOATING
C9101 VDD.t721 VSS 0.03511f ; **FLOATING
C9102 VDD.t585 VSS 0.03511f ; **FLOATING
C9103 VDD.t246 VSS 0.03153f ; **FLOATING
C9104 VDD.t616 VSS 0.04608f ; **FLOATING
C9105 VDD.t500 VSS 0.03511f ; **FLOATING
C9106 VDD.t236 VSS 0.03152f ; **FLOATING
C9107 VDD.t1153 VSS 0.03511f ; **FLOATING
C9108 VDD.t1013 VSS 0.03153f ; **FLOATING
C9109 VDD.t496 VSS 0.03511f ; **FLOATING
C9110 VDD.t1096 VSS 0.03152f ; **FLOATING
C9111 VDD.t1097 VSS 0.03153f ; **FLOATING
C9112 VDD.t1276 VSS 0.04625f ; **FLOATING
C9113 VDD.t1111 VSS 0.03511f ; **FLOATING
C9114 VDD.t1100 VSS 0.03152f ; **FLOATING
C9115 VDD.t650 VSS 0.03511f ; **FLOATING
C9116 VDD.t719 VSS 0.03511f ; **FLOATING
C9117 VDD.t586 VSS 0.03511f ; **FLOATING
C9118 VDD.t244 VSS 0.03153f ; **FLOATING
C9119 VDD.t1151 VSS 0.04608f ; **FLOATING
C9120 VDD.t1578 VSS 0.03152f ; **FLOATING
C9121 VDD.t1075 VSS 0.03511f ; **FLOATING
C9122 VDD.t1101 VSS 0.03153f ; **FLOATING
C9123 VDD.t1109 VSS 0.03511f ; **FLOATING
C9124 VDD.t498 VSS 0.03511f ; **FLOATING
C9125 VDD.t1037 VSS 0.03152f ; **FLOATING
C9126 VDD.t1038 VSS 0.03153f ; **FLOATING
C9127 VDD.t1041 VSS 0.03152f ; **FLOATING
C9128 VDD.t654 VSS 0.03511f ; **FLOATING
C9129 VDD.t1158 VSS 0.03511f ; **FLOATING
C9130 VDD.t1462 VSS 0.03511f ; **FLOATING
C9131 VDD.t581 VSS 0.03511f ; **FLOATING
C9132 VDD.t954 VSS 0.04608f ; **FLOATING
C9133 VDD.t1077 VSS 0.03511f ; **FLOATING
C9134 VDD.t1165 VSS 0.03511f ; **FLOATING
C9135 VDD.t1579 VSS 0.03511f ; **FLOATING
C9136 VDD.t494 VSS 0.03511f ; **FLOATING
C9137 VDD.t568 VSS 0.03728f ; **FLOATING
C9138 VDD.t1114 VSS 0.04608f ; **FLOATING
C9139 VDD.t569 VSS 0.06583f ; **FLOATING
C9140 VDD.t648 VSS 0.03511f ; **FLOATING
C9141 VDD.t1163 VSS 0.03511f ; **FLOATING
C9142 VDD.t723 VSS 0.03511f ; **FLOATING
C9143 VDD.t584 VSS 0.03511f ; **FLOATING
C9144 VDD.t981 VSS 0.03153f ; **FLOATING
C9145 VDD.t555 VSS 0.04608f ; **FLOATING
C9146 VDD.t583 VSS 0.03511f ; **FLOATING
C9147 VDD.t255 VSS 0.03152f ; **FLOATING
C9148 VDD.t1117 VSS 0.03511f ; **FLOATING
C9149 VDD.t19 VSS 0.03153f ; **FLOATING
C9150 VDD.t495 VSS 0.03511f ; **FLOATING
C9151 VDD.t1312 VSS 0.03152f ; **FLOATING
C9152 VDD.t1313 VSS 0.03153f ; **FLOATING
C9153 VDD.t1176 VSS 0.04625f ; **FLOATING
C9154 VDD.t1248 VSS 0.03511f ; **FLOATING
C9155 VDD.t1316 VSS 0.03152f ; **FLOATING
C9156 VDD.t651 VSS 0.03511f ; **FLOATING
C9157 VDD.t722 VSS 0.03511f ; **FLOATING
C9158 VDD.t587 VSS 0.03511f ; **FLOATING
C9159 VDD.t242 VSS 0.03153f ; **FLOATING
C9160 VDD.t643 VSS 0.04608f ; **FLOATING
C9161 VDD.t1103 VSS 0.03152f ; **FLOATING
C9162 VDD.t1076 VSS 0.03511f ; **FLOATING
C9163 VDD.t252 VSS 0.03153f ; **FLOATING
C9164 VDD.t1253 VSS 0.03511f ; **FLOATING
C9165 VDD.t499 VSS 0.03511f ; **FLOATING
C9166 VDD.t257 VSS 0.03152f ; **FLOATING
C9167 VDD.t258 VSS 0.03153f ; **FLOATING
C9168 VDD.t261 VSS 0.03152f ; **FLOATING
C9169 VDD.t655 VSS 0.03511f ; **FLOATING
C9170 VDD.t1278 VSS 0.03511f ; **FLOATING
C9171 VDD.t718 VSS 0.03511f ; **FLOATING
C9172 VDD.t582 VSS 0.03511f ; **FLOATING
C9173 VDD.t232 VSS 0.03153f ; **FLOATING
C9174 VDD.t689 VSS 0.04608f ; **FLOATING
C9175 VDD.t1078 VSS 0.03511f ; **FLOATING
C9176 VDD.t197 VSS 0.03152f ; **FLOATING
C9177 VDD.t1281 VSS 0.03511f ; **FLOATING
C9178 VDD.t1231 VSS 0.03153f ; **FLOATING
C9179 VDD.t948 VSS 0.03511f ; **FLOATING
C9180 VDD.t937 VSS 0.03152f ; **FLOATING
C9181 VDD.t938 VSS 0.03153f ; **FLOATING
C9182 VDD.t1334 VSS 0.04625f ; **FLOATING
C9183 VDD.t1285 VSS 0.03511f ; **FLOATING
C9184 VDD.t941 VSS 0.03152f ; **FLOATING
C9185 VDD.t964 VSS 0.03511f ; **FLOATING
C9186 VDD.t717 VSS 0.03511f ; **FLOATING
C9187 VDD.t652 VSS 0.03511f ; **FLOATING
C9188 VDD.t893 VSS 0.04608f ; **FLOATING
C9189 VDD.t1074 VSS 0.04222f ; **FLOATING
C9190 VDD.t1609 VSS 0.11644f ; **FLOATING
C9191 VDD.t939 VSS 0.03384f ; **FLOATING
C9192 VDD.t1610 VSS 0.11644f ; **FLOATING
C9193 VDD.t936 VSS 0.03384f ; **FLOATING
C9194 VDD.t1611 VSS 0.11644f ; **FLOATING
C9195 VDD.t196 VSS 0.03384f ; **FLOATING
C9196 VDD.t993 VSS 0.04625f ; **FLOATING
C9197 VDD.t1612 VSS 0.11644f ; **FLOATING
C9198 VDD.t259 VSS 0.03384f ; **FLOATING
C9199 VDD.t1613 VSS 0.11644f ; **FLOATING
C9200 VDD.t253 VSS 0.03384f ; **FLOATING
C9201 VDD.t1614 VSS 0.11644f ; **FLOATING
C9202 VDD.t243 VSS 0.03384f ; **FLOATING
C9203 VDD.t1615 VSS 0.11644f ; **FLOATING
C9204 VDD.t1314 VSS 0.03384f ; **FLOATING
C9205 VDD.t1616 VSS 0.11644f ; **FLOATING
C9206 VDD.t20 VSS 0.03384f ; **FLOATING
C9207 VDD.t1617 VSS 0.11644f ; **FLOATING
C9208 VDD.t254 VSS 0.03384f ; **FLOATING
C9209 VDD.n1003 VSS 0.06615f ; **FLOATING
C9210 VDD.n1004 VSS 0.01381f ; **FLOATING
C9211 VDD.n1005 VSS 0.07821f ; **FLOATING
C9212 VDD.n1006 VSS 0.01184f ; **FLOATING
C9213 VDD.n1007 VSS 0.06899f ; **FLOATING
C9214 VDD.n1008 VSS 0.01381f ; **FLOATING
C9215 VDD.n1009 VSS 0.08508f ; **FLOATING
C9216 VDD.t953 VSS 0.04625f ; **FLOATING
C9217 VDD.t1618 VSS 0.11644f ; **FLOATING
C9218 VDD.t1039 VSS 0.03384f ; **FLOATING
C9219 VDD.t1619 VSS 0.11644f ; **FLOATING
C9220 VDD.t1036 VSS 0.03384f ; **FLOATING
C9221 VDD.t1620 VSS 0.11644f ; **FLOATING
C9222 VDD.t245 VSS 0.03384f ; **FLOATING
C9223 VDD.t1621 VSS 0.11644f ; **FLOATING
C9224 VDD.t1098 VSS 0.03384f ; **FLOATING
C9225 VDD.t1622 VSS 0.11644f ; **FLOATING
C9226 VDD.t1014 VSS 0.03384f ; **FLOATING
C9227 VDD.t1623 VSS 0.11644f ; **FLOATING
C9228 VDD.t235 VSS 0.03384f ; **FLOATING
C9229 VDD.t617 VSS 0.04625f ; **FLOATING
C9230 VDD.t1624 VSS 0.11644f ; **FLOATING
C9231 VDD.t11 VSS 0.03384f ; **FLOATING
C9232 VDD.n1010 VSS 2.30959f ; **FLOATING
C9233 VDD.t815 VSS 0.07114f ; **FLOATING
C9234 VDD.n1011 VSS 0.05148f ; **FLOATING
C9235 VDD.n1012 VSS 0.05148f ; **FLOATING
C9236 VDD.n1013 VSS 0.05148f ; **FLOATING
C9237 VDD.n1014 VSS 0.05156f ; **FLOATING
C9238 VDD.n1015 VSS 0.05148f ; **FLOATING
C9239 VDD.n1016 VSS 0.05148f ; **FLOATING
C9240 VDD.n1017 VSS 0.05148f ; **FLOATING
C9241 VDD.n1018 VSS 0.05148f ; **FLOATING
C9242 VDD.n1019 VSS 0.05148f ; **FLOATING
C9243 VDD.n1020 VSS 0.05156f ; **FLOATING
C9244 VDD.n1021 VSS 0.05156f ; **FLOATING
C9245 VDD.n1022 VSS 0.05148f ; **FLOATING
C9246 VDD.n1023 VSS 0.05148f ; **FLOATING
C9247 VDD.n1024 VSS 0.05148f ; **FLOATING
C9248 VDD.n1025 VSS 0.05148f ; **FLOATING
C9249 VDD.n1026 VSS 0.05156f ; **FLOATING
C9250 VDD.n1027 VSS 0.05148f ; **FLOATING
C9251 VDD.n1028 VSS 0.05148f ; **FLOATING
C9252 VDD.n1029 VSS 0.05148f ; **FLOATING
C9253 VDD.n1030 VSS 0.05148f ; **FLOATING
C9254 VDD.n1031 VSS 0.05156f ; **FLOATING
C9255 VDD.n1032 VSS 0.05156f ; **FLOATING
C9256 VDD.n1033 VSS 0.05148f ; **FLOATING
C9257 VDD.n1034 VSS 0.05148f ; **FLOATING
C9258 VDD.n1035 VSS 0.05156f ; **FLOATING
C9259 VDD.n1036 VSS 0.05156f ; **FLOATING
C9260 VDD.n1037 VSS 0.05156f ; **FLOATING
C9261 VDD.n1038 VSS 0.05156f ; **FLOATING
C9262 VDD.n1039 VSS 0.05156f ; **FLOATING
C9263 VDD.n1040 VSS 0.05148f ; **FLOATING
C9264 VDD.n1041 VSS 0.05148f ; **FLOATING
C9265 VDD.t811 VSS 0.03446f ; **FLOATING
C9266 VDD.t810 VSS 0.02458f ; **FLOATING
C9267 VDD.t814 VSS 0.03431f ; **FLOATING
C9268 VDD.t812 VSS 0.0379f ; **FLOATING
C9269 VDD.t813 VSS 0.01994f ; **FLOATING
C9270 VDD.t404 VSS 0.03391f ; **FLOATING
C9271 VDD.n1042 VSS 0.10265f ; **FLOATING
C9272 VDD.n1043 VSS 0.02515f ; **FLOATING
C9273 VDD.n1044 VSS 0.07975f ; **FLOATING
C9274 VDD.n1045 VSS 0.01472f ; **FLOATING
C9275 VDD.t869 VSS 0.03978f ; **FLOATING
C9276 VDD.n1046 VSS 0.08285f ; **FLOATING
C9277 VDD.n1047 VSS 0.03625f ; **FLOATING
C9278 VDD.t430 VSS 0.03391f ; **FLOATING
C9279 VDD.n1048 VSS 0.11151f ; **FLOATING
C9280 VDD.n1049 VSS 0.02515f ; **FLOATING
C9281 VDD.n1050 VSS 0.06308f ; **FLOATING
C9282 VDD.n1051 VSS 0.01472f ; **FLOATING
C9283 VDD.t535 VSS 0.03978f ; **FLOATING
C9284 VDD.n1052 VSS 0.08286f ; **FLOATING
C9285 VDD.n1053 VSS 0.03628f ; **FLOATING
C9286 VDD.t429 VSS 0.03391f ; **FLOATING
C9287 VDD.n1054 VSS 0.11149f ; **FLOATING
C9288 VDD.n1055 VSS 0.02515f ; **FLOATING
C9289 VDD.n1056 VSS 0.06305f ; **FLOATING
C9290 VDD.n1057 VSS 0.01474f ; **FLOATING
C9291 VDD.t1503 VSS 0.03978f ; **FLOATING
C9292 VDD.n1058 VSS 0.08281f ; **FLOATING
C9293 VDD.n1059 VSS 0.0363f ; **FLOATING
C9294 VDD.t400 VSS 0.03391f ; **FLOATING
C9295 VDD.n1060 VSS 0.11142f ; **FLOATING
C9296 VDD.n1061 VSS 0.02515f ; **FLOATING
C9297 VDD.n1062 VSS 0.06305f ; **FLOATING
C9298 VDD.n1063 VSS 0.01474f ; **FLOATING
C9299 VDD.t463 VSS 0.03978f ; **FLOATING
C9300 VDD.n1064 VSS 0.08282f ; **FLOATING
C9301 VDD.n1065 VSS 0.03632f ; **FLOATING
C9302 VDD.t402 VSS 0.03391f ; **FLOATING
C9303 VDD.n1066 VSS 0.11142f ; **FLOATING
C9304 VDD.n1067 VSS 0.02515f ; **FLOATING
C9305 VDD.n1068 VSS 0.06303f ; **FLOATING
C9306 VDD.n1069 VSS 0.01474f ; **FLOATING
C9307 VDD.t840 VSS 0.03978f ; **FLOATING
C9308 VDD.n1070 VSS 0.08279f ; **FLOATING
C9309 VDD.n1071 VSS 0.03634f ; **FLOATING
C9310 VDD.t438 VSS 0.03391f ; **FLOATING
C9311 VDD.n1072 VSS 0.11142f ; **FLOATING
C9312 VDD.n1073 VSS 0.02515f ; **FLOATING
C9313 VDD.n1074 VSS 0.06303f ; **FLOATING
C9314 VDD.n1075 VSS 0.01472f ; **FLOATING
C9315 VDD.t464 VSS 0.03978f ; **FLOATING
C9316 VDD.n1076 VSS 0.08282f ; **FLOATING
C9317 VDD.n1077 VSS 0.03634f ; **FLOATING
C9318 VDD.t432 VSS 0.03391f ; **FLOATING
C9319 VDD.n1078 VSS 0.11142f ; **FLOATING
C9320 VDD.n1079 VSS 0.02515f ; **FLOATING
C9321 VDD.n1080 VSS 0.06304f ; **FLOATING
C9322 VDD.n1081 VSS 0.01474f ; **FLOATING
C9323 VDD.t898 VSS 0.03978f ; **FLOATING
C9324 VDD.n1082 VSS 0.08282f ; **FLOATING
C9325 VDD.n1083 VSS 0.03625f ; **FLOATING
C9326 VDD.t439 VSS 0.03391f ; **FLOATING
C9327 VDD.n1084 VSS 0.11145f ; **FLOATING
C9328 VDD.n1085 VSS 0.02515f ; **FLOATING
C9329 VDD.n1086 VSS 0.06309f ; **FLOATING
C9330 VDD.n1087 VSS 0.01472f ; **FLOATING
C9331 VDD.t1121 VSS 0.03978f ; **FLOATING
C9332 VDD.n1088 VSS 0.08282f ; **FLOATING
C9333 VDD.n1089 VSS 0.03634f ; **FLOATING
C9334 VDD.t431 VSS 0.03391f ; **FLOATING
C9335 VDD.n1090 VSS 0.11151f ; **FLOATING
C9336 VDD.n1091 VSS 0.02515f ; **FLOATING
C9337 VDD.n1092 VSS 0.06304f ; **FLOATING
C9338 VDD.n1093 VSS 0.01474f ; **FLOATING
C9339 VDD.t1204 VSS 0.03978f ; **FLOATING
C9340 VDD.n1094 VSS 0.08279f ; **FLOATING
C9341 VDD.n1095 VSS 0.03636f ; **FLOATING
C9342 VDD.t441 VSS 0.03391f ; **FLOATING
C9343 VDD.n1096 VSS 0.11149f ; **FLOATING
C9344 VDD.n1097 VSS 0.02515f ; **FLOATING
C9345 VDD.n1098 VSS 0.063f ; **FLOATING
C9346 VDD.n1099 VSS 0.01472f ; **FLOATING
C9347 VDD.t1112 VSS 0.03978f ; **FLOATING
C9348 VDD.n1100 VSS 0.08282f ; **FLOATING
C9349 VDD.n1101 VSS 0.03634f ; **FLOATING
C9350 VDD.t440 VSS 0.03391f ; **FLOATING
C9351 VDD.n1102 VSS 0.11142f ; **FLOATING
C9352 VDD.n1103 VSS 0.02515f ; **FLOATING
C9353 VDD.n1104 VSS 0.06304f ; **FLOATING
C9354 VDD.n1105 VSS 0.01474f ; **FLOATING
C9355 VDD.t1144 VSS 0.03978f ; **FLOATING
C9356 VDD.n1106 VSS 0.08279f ; **FLOATING
C9357 VDD.n1107 VSS 0.03634f ; **FLOATING
C9358 VDD.t401 VSS 0.03391f ; **FLOATING
C9359 VDD.n1108 VSS 0.11145f ; **FLOATING
C9360 VDD.n1109 VSS 0.02515f ; **FLOATING
C9361 VDD.n1110 VSS 0.06303f ; **FLOATING
C9362 VDD.n1111 VSS 0.01472f ; **FLOATING
C9363 VDD.t1108 VSS 0.03978f ; **FLOATING
C9364 VDD.n1112 VSS 0.08285f ; **FLOATING
C9365 VDD.n1113 VSS 0.03625f ; **FLOATING
C9366 VDD.t403 VSS 0.03391f ; **FLOATING
C9367 VDD.n1114 VSS 0.11151f ; **FLOATING
C9368 VDD.n1115 VSS 0.02515f ; **FLOATING
C9369 VDD.n1116 VSS 0.06308f ; **FLOATING
C9370 VDD.n1117 VSS 0.01472f ; **FLOATING
C9371 VDD.t1197 VSS 0.03978f ; **FLOATING
C9372 VDD.n1118 VSS 0.08285f ; **FLOATING
C9373 VDD.n1119 VSS 0.03631f ; **FLOATING
C9374 VDD.t442 VSS 0.03391f ; **FLOATING
C9375 VDD.n1120 VSS 0.11151f ; **FLOATING
C9376 VDD.n1121 VSS 0.02515f ; **FLOATING
C9377 VDD.n1122 VSS 0.06302f ; **FLOATING
C9378 VDD.n1123 VSS 0.01472f ; **FLOATING
C9379 VDD.t1159 VSS 0.03978f ; **FLOATING
C9380 VDD.n1124 VSS 0.08282f ; **FLOATING
C9381 VDD.n1125 VSS 0.03634f ; **FLOATING
C9382 VDD.t444 VSS 0.03391f ; **FLOATING
C9383 VDD.n1126 VSS 0.11151f ; **FLOATING
C9384 VDD.n1127 VSS 0.02515f ; **FLOATING
C9385 VDD.n1128 VSS 0.06304f ; **FLOATING
C9386 VDD.n1129 VSS 0.01474f ; **FLOATING
C9387 VDD.t1146 VSS 0.03978f ; **FLOATING
C9388 VDD.n1130 VSS 0.08283f ; **FLOATING
C9389 VDD.n1131 VSS 0.03628f ; **FLOATING
C9390 VDD.t443 VSS 0.03391f ; **FLOATING
C9391 VDD.n1132 VSS 0.11149f ; **FLOATING
C9392 VDD.n1133 VSS 0.02515f ; **FLOATING
C9393 VDD.n1134 VSS 0.06305f ; **FLOATING
C9394 VDD.n1135 VSS 0.01474f ; **FLOATING
C9395 VDD.t1148 VSS 0.03978f ; **FLOATING
C9396 VDD.n1136 VSS 0.08279f ; **FLOATING
C9397 VDD.n1137 VSS 0.03634f ; **FLOATING
C9398 VDD.t437 VSS 0.03391f ; **FLOATING
C9399 VDD.n1138 VSS 0.11145f ; **FLOATING
C9400 VDD.n1139 VSS 0.02515f ; **FLOATING
C9401 VDD.n1140 VSS 0.06304f ; **FLOATING
C9402 VDD.n1141 VSS 0.01474f ; **FLOATING
C9403 VDD.t1113 VSS 0.03978f ; **FLOATING
C9404 VDD.n1142 VSS 0.0828f ; **FLOATING
C9405 VDD.n1143 VSS 0.03631f ; **FLOATING
C9406 VDD.t450 VSS 0.03391f ; **FLOATING
C9407 VDD.n1144 VSS 0.11151f ; **FLOATING
C9408 VDD.n1145 VSS 0.02515f ; **FLOATING
C9409 VDD.n1146 VSS 0.06306f ; **FLOATING
C9410 VDD.n1147 VSS 0.01474f ; **FLOATING
C9411 VDD.t1164 VSS 0.03978f ; **FLOATING
C9412 VDD.n1148 VSS 0.08281f ; **FLOATING
C9413 VDD.n1149 VSS 0.0363f ; **FLOATING
C9414 VDD.t447 VSS 0.03391f ; **FLOATING
C9415 VDD.n1150 VSS 0.11151f ; **FLOATING
C9416 VDD.n1151 VSS 0.02515f ; **FLOATING
C9417 VDD.n1152 VSS 0.06305f ; **FLOATING
C9418 VDD.n1153 VSS 0.01474f ; **FLOATING
C9419 VDD.t1298 VSS 0.03978f ; **FLOATING
C9420 VDD.n1154 VSS 0.08282f ; **FLOATING
C9421 VDD.n1155 VSS 0.03632f ; **FLOATING
C9422 VDD.t434 VSS 0.03391f ; **FLOATING
C9423 VDD.n1156 VSS 0.11151f ; **FLOATING
C9424 VDD.n1157 VSS 0.02515f ; **FLOATING
C9425 VDD.n1158 VSS 0.06303f ; **FLOATING
C9426 VDD.n1159 VSS 0.01474f ; **FLOATING
C9427 VDD.t1118 VSS 0.03978f ; **FLOATING
C9428 VDD.n1160 VSS 0.08281f ; **FLOATING
C9429 VDD.n1161 VSS 0.03632f ; **FLOATING
C9430 VDD.t435 VSS 0.03391f ; **FLOATING
C9431 VDD.n1162 VSS 0.11149f ; **FLOATING
C9432 VDD.n1163 VSS 0.02515f ; **FLOATING
C9433 VDD.n1164 VSS 0.06304f ; **FLOATING
C9434 VDD.n1165 VSS 0.01474f ; **FLOATING
C9435 VDD.t1268 VSS 0.03978f ; **FLOATING
C9436 VDD.n1166 VSS 0.0828f ; **FLOATING
C9437 VDD.n1167 VSS 0.03631f ; **FLOATING
C9438 VDD.t451 VSS 0.03391f ; **FLOATING
C9439 VDD.n1168 VSS 0.11142f ; **FLOATING
C9440 VDD.n1169 VSS 0.02515f ; **FLOATING
C9441 VDD.n1170 VSS 0.06306f ; **FLOATING
C9442 VDD.n1171 VSS 0.01474f ; **FLOATING
C9443 VDD.t1249 VSS 0.03978f ; **FLOATING
C9444 VDD.n1172 VSS 0.08282f ; **FLOATING
C9445 VDD.n1173 VSS 0.03632f ; **FLOATING
C9446 VDD.t452 VSS 0.03391f ; **FLOATING
C9447 VDD.n1174 VSS 0.11145f ; **FLOATING
C9448 VDD.n1175 VSS 0.02515f ; **FLOATING
C9449 VDD.n1176 VSS 0.06303f ; **FLOATING
C9450 VDD.n1177 VSS 0.01474f ; **FLOATING
C9451 VDD.t1327 VSS 0.03978f ; **FLOATING
C9452 VDD.n1178 VSS 0.08282f ; **FLOATING
C9453 VDD.n1179 VSS 0.0363f ; **FLOATING
C9454 VDD.t453 VSS 0.03391f ; **FLOATING
C9455 VDD.n1180 VSS 0.11151f ; **FLOATING
C9456 VDD.n1181 VSS 0.02515f ; **FLOATING
C9457 VDD.n1182 VSS 0.06304f ; **FLOATING
C9458 VDD.n1183 VSS 0.01472f ; **FLOATING
C9459 VDD.t1252 VSS 0.03978f ; **FLOATING
C9460 VDD.n1184 VSS 0.08285f ; **FLOATING
C9461 VDD.n1185 VSS 0.03631f ; **FLOATING
C9462 VDD.t449 VSS 0.03391f ; **FLOATING
C9463 VDD.n1186 VSS 0.11151f ; **FLOATING
C9464 VDD.n1187 VSS 0.02515f ; **FLOATING
C9465 VDD.n1188 VSS 0.06302f ; **FLOATING
C9466 VDD.n1189 VSS 0.01472f ; **FLOATING
C9467 VDD.t1290 VSS 0.03978f ; **FLOATING
C9468 VDD.n1190 VSS 0.08285f ; **FLOATING
C9469 VDD.n1191 VSS 0.03625f ; **FLOATING
C9470 VDD.t454 VSS 0.03391f ; **FLOATING
C9471 VDD.n1192 VSS 0.11151f ; **FLOATING
C9472 VDD.n1193 VSS 0.02515f ; **FLOATING
C9473 VDD.n1194 VSS 0.06309f ; **FLOATING
C9474 VDD.n1195 VSS 0.01472f ; **FLOATING
C9475 VDD.t1262 VSS 0.03978f ; **FLOATING
C9476 VDD.n1196 VSS 0.08285f ; **FLOATING
C9477 VDD.n1197 VSS 0.0363f ; **FLOATING
C9478 VDD.t436 VSS 0.03391f ; **FLOATING
C9479 VDD.n1198 VSS 0.11151f ; **FLOATING
C9480 VDD.n1199 VSS 0.02515f ; **FLOATING
C9481 VDD.n1200 VSS 0.06303f ; **FLOATING
C9482 VDD.n1201 VSS 0.01472f ; **FLOATING
C9483 VDD.t1291 VSS 0.03978f ; **FLOATING
C9484 VDD.n1202 VSS 0.08282f ; **FLOATING
C9485 VDD.n1203 VSS 0.03636f ; **FLOATING
C9486 VDD.t433 VSS 0.03391f ; **FLOATING
C9487 VDD.n1204 VSS 0.11149f ; **FLOATING
C9488 VDD.n1205 VSS 0.02515f ; **FLOATING
C9489 VDD.n1206 VSS 0.063f ; **FLOATING
C9490 VDD.n1207 VSS 0.01472f ; **FLOATING
C9491 VDD.t1275 VSS 0.03978f ; **FLOATING
C9492 VDD.n1208 VSS 0.08284f ; **FLOATING
C9493 VDD.n1209 VSS 0.03632f ; **FLOATING
C9494 VDD.t448 VSS 0.03391f ; **FLOATING
C9495 VDD.n1210 VSS 0.11145f ; **FLOATING
C9496 VDD.n1211 VSS 0.02515f ; **FLOATING
C9497 VDD.n1212 VSS 0.06303f ; **FLOATING
C9498 VDD.n1213 VSS 0.01474f ; **FLOATING
C9499 VDD.t1292 VSS 0.03978f ; **FLOATING
C9500 VDD.n1214 VSS 0.08282f ; **FLOATING
C9501 VDD.n1215 VSS 0.0363f ; **FLOATING
C9502 VDD.t455 VSS 0.03391f ; **FLOATING
C9503 VDD.n1216 VSS 0.11151f ; **FLOATING
C9504 VDD.n1217 VSS 0.02515f ; **FLOATING
C9505 VDD.n1218 VSS 0.06304f ; **FLOATING
C9506 VDD.n1219 VSS 0.01472f ; **FLOATING
C9507 VDD.t1277 VSS 0.03978f ; **FLOATING
C9508 VDD.n1220 VSS 0.08282f ; **FLOATING
C9509 VDD.n1221 VSS 0.03634f ; **FLOATING
C9510 VDD.t446 VSS 0.03391f ; **FLOATING
C9511 VDD.n1222 VSS 0.11151f ; **FLOATING
C9512 VDD.n1223 VSS 0.02515f ; **FLOATING
C9513 VDD.n1224 VSS 0.06303f ; **FLOATING
C9514 VDD.n1225 VSS 0.01472f ; **FLOATING
C9515 VDD.t1254 VSS 0.03978f ; **FLOATING
C9516 VDD.n1226 VSS 0.08285f ; **FLOATING
C9517 VDD.n1227 VSS 0.0363f ; **FLOATING
C9518 VDD.t445 VSS 0.03391f ; **FLOATING
C9519 VDD.n1228 VSS 0.0923f ; **FLOATING
C9520 VDD.n1229 VSS 0.02515f ; **FLOATING
C9521 VDD.n1230 VSS 0.06304f ; **FLOATING
C9522 VDD.n1231 VSS 0.01474f ; **FLOATING
C9523 VDD.t1339 VSS 0.03978f ; **FLOATING
C9524 VDD.n1232 VSS 0.06313f ; **FLOATING
C9525 VDD.n1233 VSS 0.01517f ; **FLOATING
C9526 VDD.t816 VSS 0.03391f ; **FLOATING
C9527 VDD.n1234 VSS 0.02515f ; **FLOATING
C9528 VDD.t817 VSS 0.0379f ; **FLOATING
C9529 VDD.n1235 VSS 0.07448f ; **FLOATING
C9530 VDD.t820 VSS 0.03391f ; **FLOATING
C9531 VDD.n1236 VSS 0.02251f ; **FLOATING
C9532 VDD.t818 VSS 0.03277f ; **FLOATING
C9533 VDD.n1237 VSS 0.01671f ; **FLOATING
C9534 VDD.n1238 VSS 0.06321f ; **FLOATING
C9535 VDD.n1239 VSS 0.05429f ; **FLOATING
C9536 VDD.t1477 VSS 0.03511f ; **FLOATING
C9537 VDD.t1491 VSS 0.03511f ; **FLOATING
C9538 VDD.t95 VSS 0.03153f ; **FLOATING
C9539 VDD.t988 VSS 0.03511f ; **FLOATING
C9540 VDD.n1240 VSS 0.02899f ; **FLOATING
C9541 VDD.t696 VSS 0.04608f ; **FLOATING
C9542 VDD.n1241 VSS 0.08838f ; **FLOATING
C9543 VDD.n1242 VSS 0.02585f ; **FLOATING
C9544 VDD.t1235 VSS 0.03511f ; **FLOATING
C9545 VDD.n1243 VSS 0.08379f ; **FLOATING
C9546 VDD.n1244 VSS 0.0123f ; **FLOATING
C9547 VDD.t290 VSS 0.03913f ; **FLOATING
C9548 VDD.t868 VSS 0.03913f ; **FLOATING
C9549 VDD.t1531 VSS 0.03913f ; **FLOATING
C9550 VDD.t837 VSS 0.03913f ; **FLOATING
C9551 VDD.t1179 VSS 0.03511f ; **FLOATING
C9552 VDD.t280 VSS 0.03511f ; **FLOATING
C9553 VDD.n1245 VSS 0.10156f ; **FLOATING
C9554 VDD.n1246 VSS 0.01607f ; **FLOATING
C9555 VDD.t1515 VSS 0.02593f ; **FLOATING
C9556 VDD.t706 VSS 0.02593f ; **FLOATING
C9557 VDD.n1247 VSS 0.08955f ; **FLOATING
C9558 VDD.t1470 VSS 0.03466f ; **FLOATING
C9559 VDD.t836 VSS 0.03466f ; **FLOATING
C9560 VDD.t1476 VSS 0.02593f ; **FLOATING
C9561 VDD.t1493 VSS 0.02593f ; **FLOATING
C9562 VDD.t289 VSS 0.03466f ; **FLOATING
C9563 VDD.t867 VSS 0.03466f ; **FLOATING
C9564 VDD.t1178 VSS 0.02593f ; **FLOATING
C9565 VDD.t279 VSS 0.02593f ; **FLOATING
C9566 VDD.t694 VSS 0.03466f ; **FLOATING
C9567 VDD.t707 VSS 0.03466f ; **FLOATING
C9568 VDD.n1248 VSS 0.0818f ; **FLOATING
C9569 VDD.t695 VSS 0.03913f ; **FLOATING
C9570 VDD.t866 VSS 0.03913f ; **FLOATING
C9571 VDD.t1478 VSS 0.02593f ; **FLOATING
C9572 VDD.t1492 VSS 0.02593f ; **FLOATING
C9573 VDD.t594 VSS 0.03466f ; **FLOATING
C9574 VDD.t278 VSS 0.03466f ; **FLOATING
C9575 VDD.n1249 VSS 0.07434f ; **FLOATING
C9576 VDD.t595 VSS 0.03913f ; **FLOATING
C9577 VDD.t462 VSS 0.03913f ; **FLOATING
C9578 VDD.n1250 VSS 0.09345f ; **FLOATING
C9579 VDD.n1251 VSS 0.01253f ; **FLOATING
C9580 VDD.t1019 VSS 0.03511f ; **FLOATING
C9581 VDD.t1201 VSS 0.03523f ; **FLOATING
C9582 VDD.t1232 VSS 0.03511f ; **FLOATING
C9583 VDD.n1252 VSS 0.07356f ; **FLOATING
C9584 VDD.n1253 VSS 0.01381f ; **FLOATING
C9585 VDD.t482 VSS 0.03511f ; **FLOATING
C9586 VDD.t1060 VSS 0.03511f ; **FLOATING
C9587 VDD.t1056 VSS 0.03511f ; **FLOATING
C9588 VDD.t98 VSS 0.03152f ; **FLOATING
C9589 VDD.t99 VSS 0.03153f ; **FLOATING
C9590 VDD.t735 VSS 0.03511f ; **FLOATING
C9591 VDD.t1644 VSS 0.11644f ; **FLOATING
C9592 VDD.t96 VSS 0.03384f ; **FLOATING
C9593 VDD.t737 VSS 0.04608f ; **FLOATING
C9594 VDD.t1643 VSS 0.11644f ; **FLOATING
C9595 VDD.t100 VSS 0.03384f ; **FLOATING
C9596 VDD.t1242 VSS 0.03511f ; **FLOATING
C9597 VDD.t131 VSS 0.03152f ; **FLOATING
C9598 VDD.t132 VSS 0.03153f ; **FLOATING
C9599 VDD.t135 VSS 0.03152f ; **FLOATING
C9600 VDD.t985 VSS 0.03511f ; **FLOATING
C9601 VDD.t827 VSS 0.03511f ; **FLOATING
C9602 VDD.t1046 VSS 0.03511f ; **FLOATING
C9603 VDD.t966 VSS 0.03511f ; **FLOATING
C9604 VDD.t222 VSS 0.03153f ; **FLOATING
C9605 VDD.t636 VSS 0.04608f ; **FLOATING
C9606 VDD.t1240 VSS 0.03511f ; **FLOATING
C9607 VDD.t15 VSS 0.03152f ; **FLOATING
C9608 VDD.t560 VSS 0.03511f ; **FLOATING
C9609 VDD.t16 VSS 0.03153f ; **FLOATING
C9610 VDD.t1238 VSS 0.03511f ; **FLOATING
C9611 VDD.t36 VSS 0.03152f ; **FLOATING
C9612 VDD.t27 VSS 0.03153f ; **FLOATING
C9613 VDD.t1035 VSS 0.04625f ; **FLOATING
C9614 VDD.t1536 VSS 0.03511f ; **FLOATING
C9615 VDD.t30 VSS 0.03152f ; **FLOATING
C9616 VDD.t986 VSS 0.03511f ; **FLOATING
C9617 VDD.t465 VSS 0.03511f ; **FLOATING
C9618 VDD.t967 VSS 0.03511f ; **FLOATING
C9619 VDD.t1586 VSS 0.03153f ; **FLOATING
C9620 VDD.t662 VSS 0.04608f ; **FLOATING
C9621 VDD.t38 VSS 0.03152f ; **FLOATING
C9622 VDD.t1058 VSS 0.03511f ; **FLOATING
C9623 VDD.t39 VSS 0.03153f ; **FLOATING
C9624 VDD.t544 VSS 0.03511f ; **FLOATING
C9625 VDD.t1233 VSS 0.03511f ; **FLOATING
C9626 VDD.t167 VSS 0.03152f ; **FLOATING
C9627 VDD.t248 VSS 0.03153f ; **FLOATING
C9628 VDD.t251 VSS 0.03152f ; **FLOATING
C9629 VDD.t990 VSS 0.03511f ; **FLOATING
C9630 VDD.t567 VSS 0.03511f ; **FLOATING
C9631 VDD.t466 VSS 0.03511f ; **FLOATING
C9632 VDD.t1093 VSS 0.03511f ; **FLOATING
C9633 VDD.t277 VSS 0.04608f ; **FLOATING
C9634 VDD.t1304 VSS 0.03511f ; **FLOATING
C9635 VDD.t610 VSS 0.03511f ; **FLOATING
C9636 VDD.t669 VSS 0.03511f ; **FLOATING
C9637 VDD.t1236 VSS 0.03511f ; **FLOATING
C9638 VDD.t838 VSS 0.03728f ; **FLOATING
C9639 VDD.t288 VSS 0.04608f ; **FLOATING
C9640 VDD.t1453 VSS 0.06583f ; **FLOATING
C9641 VDD.t984 VSS 0.03511f ; **FLOATING
C9642 VDD.t1569 VSS 0.03511f ; **FLOATING
C9643 VDD.t1061 VSS 0.03511f ; **FLOATING
C9644 VDD.t965 VSS 0.03511f ; **FLOATING
C9645 VDD.t144 VSS 0.03153f ; **FLOATING
C9646 VDD.t530 VSS 0.04608f ; **FLOATING
C9647 VDD.t1241 VSS 0.03511f ; **FLOATING
C9648 VDD.t1597 VSS 0.03152f ; **FLOATING
C9649 VDD.t479 VSS 0.03511f ; **FLOATING
C9650 VDD.t1598 VSS 0.03153f ; **FLOATING
C9651 VDD.t1237 VSS 0.03511f ; **FLOATING
C9652 VDD.t3 VSS 0.03152f ; **FLOATING
C9653 VDD.t168 VSS 0.03153f ; **FLOATING
C9654 VDD.t851 VSS 0.04625f ; **FLOATING
C9655 VDD.t574 VSS 0.03511f ; **FLOATING
C9656 VDD.t171 VSS 0.03152f ; **FLOATING
C9657 VDD.t987 VSS 0.03511f ; **FLOATING
C9658 VDD.t1047 VSS 0.03511f ; **FLOATING
C9659 VDD.t968 VSS 0.03511f ; **FLOATING
C9660 VDD.t266 VSS 0.03153f ; **FLOATING
C9661 VDD.t1152 VSS 0.04608f ; **FLOATING
C9662 VDD.t238 VSS 0.03152f ; **FLOATING
C9663 VDD.t1059 VSS 0.03511f ; **FLOATING
C9664 VDD.t239 VSS 0.03153f ; **FLOATING
C9665 VDD.t856 VSS 0.03511f ; **FLOATING
C9666 VDD.t1234 VSS 0.03511f ; **FLOATING
C9667 VDD.t1080 VSS 0.03152f ; **FLOATING
C9668 VDD.t1081 VSS 0.03153f ; **FLOATING
C9669 VDD.t1084 VSS 0.03152f ; **FLOATING
C9670 VDD.t991 VSS 0.03511f ; **FLOATING
C9671 VDD.t1580 VSS 0.03511f ; **FLOATING
C9672 VDD.t1 VSS 0.03511f ; **FLOATING
C9673 VDD.t1094 VSS 0.03511f ; **FLOATING
C9674 VDD.t241 VSS 0.03153f ; **FLOATING
C9675 VDD.t467 VSS 0.04608f ; **FLOATING
C9676 VDD.t1305 VSS 0.03511f ; **FLOATING
C9677 VDD.t22 VSS 0.03152f ; **FLOATING
C9678 VDD.t683 VSS 0.03511f ; **FLOATING
C9679 VDD.t23 VSS 0.03153f ; **FLOATING
C9680 VDD.t1243 VSS 0.03511f ; **FLOATING
C9681 VDD.t265 VSS 0.03152f ; **FLOATING
C9682 VDD.t31 VSS 0.03153f ; **FLOATING
C9683 VDD.t882 VSS 0.04625f ; **FLOATING
C9684 VDD.t597 VSS 0.03511f ; **FLOATING
C9685 VDD.t34 VSS 0.03152f ; **FLOATING
C9686 VDD.t1239 VSS 0.03511f ; **FLOATING
C9687 VDD.t1548 VSS 0.03511f ; **FLOATING
C9688 VDD.t989 VSS 0.03511f ; **FLOATING
C9689 VDD.t733 VSS 0.04608f ; **FLOATING
C9690 VDD.t1057 VSS 0.04222f ; **FLOATING
C9691 VDD.t1627 VSS 0.11644f ; **FLOATING
C9692 VDD.t32 VSS 0.03384f ; **FLOATING
C9693 VDD.t1628 VSS 0.11644f ; **FLOATING
C9694 VDD.t24 VSS 0.03384f ; **FLOATING
C9695 VDD.t1629 VSS 0.11644f ; **FLOATING
C9696 VDD.t21 VSS 0.03384f ; **FLOATING
C9697 VDD.t285 VSS 0.04625f ; **FLOATING
C9698 VDD.t1630 VSS 0.11644f ; **FLOATING
C9699 VDD.t1082 VSS 0.03384f ; **FLOATING
C9700 VDD.t1631 VSS 0.11644f ; **FLOATING
C9701 VDD.t240 VSS 0.03384f ; **FLOATING
C9702 VDD.t1632 VSS 0.11644f ; **FLOATING
C9703 VDD.t237 VSS 0.03384f ; **FLOATING
C9704 VDD.t1633 VSS 0.11644f ; **FLOATING
C9705 VDD.t169 VSS 0.03384f ; **FLOATING
C9706 VDD.t1634 VSS 0.11644f ; **FLOATING
C9707 VDD.t2 VSS 0.03384f ; **FLOATING
C9708 VDD.t1635 VSS 0.11644f ; **FLOATING
C9709 VDD.t145 VSS 0.03384f ; **FLOATING
C9710 VDD.n1254 VSS 0.06615f ; **FLOATING
C9711 VDD.n1255 VSS 0.01381f ; **FLOATING
C9712 VDD.n1256 VSS 0.07821f ; **FLOATING
C9713 VDD.n1257 VSS 0.01184f ; **FLOATING
C9714 VDD.n1258 VSS 0.06899f ; **FLOATING
C9715 VDD.n1259 VSS 0.01381f ; **FLOATING
C9716 VDD.n1260 VSS 0.08508f ; **FLOATING
C9717 VDD.t613 VSS 0.04625f ; **FLOATING
C9718 VDD.t1636 VSS 0.11644f ; **FLOATING
C9719 VDD.t249 VSS 0.03384f ; **FLOATING
C9720 VDD.t1637 VSS 0.11644f ; **FLOATING
C9721 VDD.t40 VSS 0.03384f ; **FLOATING
C9722 VDD.t1638 VSS 0.11644f ; **FLOATING
C9723 VDD.t37 VSS 0.03384f ; **FLOATING
C9724 VDD.t1639 VSS 0.11644f ; **FLOATING
C9725 VDD.t28 VSS 0.03384f ; **FLOATING
C9726 VDD.t1640 VSS 0.11644f ; **FLOATING
C9727 VDD.t17 VSS 0.03384f ; **FLOATING
C9728 VDD.t1641 VSS 0.11644f ; **FLOATING
C9729 VDD.t14 VSS 0.03384f ; **FLOATING
C9730 VDD.t894 VSS 0.04625f ; **FLOATING
C9731 VDD.t1642 VSS 0.11644f ; **FLOATING
C9732 VDD.t133 VSS 0.03384f ; **FLOATING
C9733 VDD.n1261 VSS 1.05155f ; **FLOATING
C9734 VDD.t804 VSS 0.07114f ; **FLOATING
C9735 VDD.n1262 VSS 0.05148f ; **FLOATING
C9736 VDD.n1263 VSS 0.05148f ; **FLOATING
C9737 VDD.n1264 VSS 0.05148f ; **FLOATING
C9738 VDD.n1265 VSS 0.05156f ; **FLOATING
C9739 VDD.n1266 VSS 0.05148f ; **FLOATING
C9740 VDD.n1267 VSS 0.05148f ; **FLOATING
C9741 VDD.n1268 VSS 0.05156f ; **FLOATING
C9742 VDD.n1269 VSS 0.05156f ; **FLOATING
C9743 VDD.n1270 VSS 0.05148f ; **FLOATING
C9744 VDD.n1271 VSS 0.05148f ; **FLOATING
C9745 VDD.n1272 VSS 0.05156f ; **FLOATING
C9746 VDD.n1273 VSS 0.05148f ; **FLOATING
C9747 VDD.n1274 VSS 0.05156f ; **FLOATING
C9748 VDD.n1275 VSS 0.05148f ; **FLOATING
C9749 VDD.n1276 VSS 0.05148f ; **FLOATING
C9750 VDD.n1277 VSS 0.05148f ; **FLOATING
C9751 VDD.n1278 VSS 0.05148f ; **FLOATING
C9752 VDD.n1279 VSS 0.05148f ; **FLOATING
C9753 VDD.n1280 VSS 0.05156f ; **FLOATING
C9754 VDD.n1281 VSS 0.05148f ; **FLOATING
C9755 VDD.n1282 VSS 0.05148f ; **FLOATING
C9756 VDD.n1283 VSS 0.05156f ; **FLOATING
C9757 VDD.n1284 VSS 0.05148f ; **FLOATING
C9758 VDD.n1285 VSS 0.05148f ; **FLOATING
C9759 VDD.n1286 VSS 0.05148f ; **FLOATING
C9760 VDD.n1287 VSS 0.05148f ; **FLOATING
C9761 VDD.n1288 VSS 0.05148f ; **FLOATING
C9762 VDD.n1289 VSS 0.05148f ; **FLOATING
C9763 VDD.n1290 VSS 0.05156f ; **FLOATING
C9764 VDD.n1291 VSS 0.05148f ; **FLOATING
C9765 VDD.n1292 VSS 0.05148f ; **FLOATING
C9766 VDD.t800 VSS 0.03446f ; **FLOATING
C9767 VDD.t799 VSS 0.02458f ; **FLOATING
C9768 VDD.t803 VSS 0.03431f ; **FLOATING
C9769 VDD.t801 VSS 0.0379f ; **FLOATING
C9770 VDD.t802 VSS 0.01994f ; **FLOATING
C9771 VDD.t312 VSS 0.03391f ; **FLOATING
C9772 VDD.n1293 VSS 0.10269f ; **FLOATING
C9773 VDD.n1294 VSS 0.02515f ; **FLOATING
C9774 VDD.n1295 VSS 0.07979f ; **FLOATING
C9775 VDD.n1296 VSS 0.01474f ; **FLOATING
C9776 VDD.t1181 VSS 0.03978f ; **FLOATING
C9777 VDD.n1297 VSS 0.08282f ; **FLOATING
C9778 VDD.n1298 VSS 0.03625f ; **FLOATING
C9779 VDD.t405 VSS 0.03391f ; **FLOATING
C9780 VDD.n1299 VSS 0.11151f ; **FLOATING
C9781 VDD.n1300 VSS 0.02515f ; **FLOATING
C9782 VDD.n1301 VSS 0.06309f ; **FLOATING
C9783 VDD.n1302 VSS 0.01474f ; **FLOATING
C9784 VDD.t481 VSS 0.03978f ; **FLOATING
C9785 VDD.n1303 VSS 0.08281f ; **FLOATING
C9786 VDD.n1304 VSS 0.0363f ; **FLOATING
C9787 VDD.t308 VSS 0.03391f ; **FLOATING
C9788 VDD.n1305 VSS 0.11149f ; **FLOATING
C9789 VDD.n1306 VSS 0.02515f ; **FLOATING
C9790 VDD.n1307 VSS 0.06305f ; **FLOATING
C9791 VDD.n1308 VSS 0.01474f ; **FLOATING
C9792 VDD.t282 VSS 0.03978f ; **FLOATING
C9793 VDD.n1309 VSS 0.08279f ; **FLOATING
C9794 VDD.n1310 VSS 0.03636f ; **FLOATING
C9795 VDD.t411 VSS 0.03391f ; **FLOATING
C9796 VDD.n1311 VSS 0.11145f ; **FLOATING
C9797 VDD.n1312 VSS 0.02515f ; **FLOATING
C9798 VDD.n1313 VSS 0.06301f ; **FLOATING
C9799 VDD.n1314 VSS 0.01474f ; **FLOATING
C9800 VDD.t734 VSS 0.03978f ; **FLOATING
C9801 VDD.n1315 VSS 0.08279f ; **FLOATING
C9802 VDD.n1316 VSS 0.03634f ; **FLOATING
C9803 VDD.t408 VSS 0.03391f ; **FLOATING
C9804 VDD.n1317 VSS 0.11151f ; **FLOATING
C9805 VDD.n1318 VSS 0.02515f ; **FLOATING
C9806 VDD.n1319 VSS 0.06304f ; **FLOATING
C9807 VDD.n1320 VSS 0.01474f ; **FLOATING
C9808 VDD.t847 VSS 0.03978f ; **FLOATING
C9809 VDD.n1321 VSS 0.08282f ; **FLOATING
C9810 VDD.n1322 VSS 0.0363f ; **FLOATING
C9811 VDD.t307 VSS 0.03391f ; **FLOATING
C9812 VDD.n1323 VSS 0.11151f ; **FLOATING
C9813 VDD.n1324 VSS 0.02515f ; **FLOATING
C9814 VDD.n1325 VSS 0.06304f ; **FLOATING
C9815 VDD.n1326 VSS 0.01474f ; **FLOATING
C9816 VDD.t826 VSS 0.03978f ; **FLOATING
C9817 VDD.n1327 VSS 0.08282f ; **FLOATING
C9818 VDD.n1328 VSS 0.03625f ; **FLOATING
C9819 VDD.t296 VSS 0.03391f ; **FLOATING
C9820 VDD.n1329 VSS 0.11151f ; **FLOATING
C9821 VDD.n1330 VSS 0.02515f ; **FLOATING
C9822 VDD.n1331 VSS 0.06308f ; **FLOATING
C9823 VDD.n1332 VSS 0.01472f ; **FLOATING
C9824 VDD.t680 VSS 0.03978f ; **FLOATING
C9825 VDD.n1333 VSS 0.08284f ; **FLOATING
C9826 VDD.n1334 VSS 0.03632f ; **FLOATING
C9827 VDD.t413 VSS 0.03391f ; **FLOATING
C9828 VDD.n1335 VSS 0.11151f ; **FLOATING
C9829 VDD.n1336 VSS 0.02515f ; **FLOATING
C9830 VDD.n1337 VSS 0.06303f ; **FLOATING
C9831 VDD.n1338 VSS 0.01474f ; **FLOATING
C9832 VDD.t559 VSS 0.03978f ; **FLOATING
C9833 VDD.n1339 VSS 0.08281f ; **FLOATING
C9834 VDD.n1340 VSS 0.0363f ; **FLOATING
C9835 VDD.t412 VSS 0.03391f ; **FLOATING
C9836 VDD.n1341 VSS 0.11151f ; **FLOATING
C9837 VDD.n1342 VSS 0.02515f ; **FLOATING
C9838 VDD.n1343 VSS 0.06304f ; **FLOATING
C9839 VDD.n1344 VSS 0.01472f ; **FLOATING
C9840 VDD.t1147 VSS 0.03978f ; **FLOATING
C9841 VDD.n1345 VSS 0.08284f ; **FLOATING
C9842 VDD.n1346 VSS 0.0363f ; **FLOATING
C9843 VDD.t414 VSS 0.03391f ; **FLOATING
C9844 VDD.n1347 VSS 0.11149f ; **FLOATING
C9845 VDD.n1348 VSS 0.02515f ; **FLOATING
C9846 VDD.n1349 VSS 0.06305f ; **FLOATING
C9847 VDD.n1350 VSS 0.01474f ; **FLOATING
C9848 VDD.t821 VSS 0.03978f ; **FLOATING
C9849 VDD.n1351 VSS 0.08282f ; **FLOATING
C9850 VDD.n1352 VSS 0.03632f ; **FLOATING
C9851 VDD.t410 VSS 0.03391f ; **FLOATING
C9852 VDD.n1353 VSS 0.11145f ; **FLOATING
C9853 VDD.n1354 VSS 0.02515f ; **FLOATING
C9854 VDD.n1355 VSS 0.06301f ; **FLOATING
C9855 VDD.n1356 VSS 0.01472f ; **FLOATING
C9856 VDD.t661 VSS 0.03978f ; **FLOATING
C9857 VDD.n1357 VSS 0.08282f ; **FLOATING
C9858 VDD.n1358 VSS 0.03631f ; **FLOATING
C9859 VDD.t416 VSS 0.03391f ; **FLOATING
C9860 VDD.n1359 VSS 0.11151f ; **FLOATING
C9861 VDD.n1360 VSS 0.02515f ; **FLOATING
C9862 VDD.n1361 VSS 0.06306f ; **FLOATING
C9863 VDD.n1362 VSS 0.01474f ; **FLOATING
C9864 VDD.t543 VSS 0.03978f ; **FLOATING
C9865 VDD.n1363 VSS 0.08279f ; **FLOATING
C9866 VDD.n1364 VSS 0.03634f ; **FLOATING
C9867 VDD.t415 VSS 0.03391f ; **FLOATING
C9868 VDD.n1365 VSS 0.11149f ; **FLOATING
C9869 VDD.n1366 VSS 0.02515f ; **FLOATING
C9870 VDD.n1367 VSS 0.06304f ; **FLOATING
C9871 VDD.n1368 VSS 0.01474f ; **FLOATING
C9872 VDD.t612 VSS 0.03978f ; **FLOATING
C9873 VDD.n1369 VSS 0.08279f ; **FLOATING
C9874 VDD.n1370 VSS 0.03636f ; **FLOATING
C9875 VDD.t409 VSS 0.03391f ; **FLOATING
C9876 VDD.n1371 VSS 0.11145f ; **FLOATING
C9877 VDD.n1372 VSS 0.02515f ; **FLOATING
C9878 VDD.n1373 VSS 0.063f ; **FLOATING
C9879 VDD.n1374 VSS 0.01472f ; **FLOATING
C9880 VDD.t566 VSS 0.03978f ; **FLOATING
C9881 VDD.n1375 VSS 0.08284f ; **FLOATING
C9882 VDD.n1376 VSS 0.0363f ; **FLOATING
C9883 VDD.t406 VSS 0.03391f ; **FLOATING
C9884 VDD.n1377 VSS 0.11151f ; **FLOATING
C9885 VDD.n1378 VSS 0.02515f ; **FLOATING
C9886 VDD.n1379 VSS 0.06304f ; **FLOATING
C9887 VDD.n1380 VSS 0.01472f ; **FLOATING
C9888 VDD.t692 VSS 0.03978f ; **FLOATING
C9889 VDD.n1381 VSS 0.08284f ; **FLOATING
C9890 VDD.n1382 VSS 0.03632f ; **FLOATING
C9891 VDD.t418 VSS 0.03391f ; **FLOATING
C9892 VDD.n1383 VSS 0.11151f ; **FLOATING
C9893 VDD.n1384 VSS 0.02515f ; **FLOATING
C9894 VDD.n1385 VSS 0.06301f ; **FLOATING
C9895 VDD.n1386 VSS 0.01472f ; **FLOATING
C9896 VDD.t611 VSS 0.03978f ; **FLOATING
C9897 VDD.n1387 VSS 0.08286f ; **FLOATING
C9898 VDD.n1388 VSS 0.03628f ; **FLOATING
C9899 VDD.t419 VSS 0.03391f ; **FLOATING
C9900 VDD.n1389 VSS 0.11151f ; **FLOATING
C9901 VDD.n1390 VSS 0.02515f ; **FLOATING
C9902 VDD.n1391 VSS 0.06305f ; **FLOATING
C9903 VDD.n1392 VSS 0.01474f ; **FLOATING
C9904 VDD.t287 VSS 0.03978f ; **FLOATING
C9905 VDD.n1393 VSS 0.08279f ; **FLOATING
C9906 VDD.n1394 VSS 0.03636f ; **FLOATING
C9907 VDD.t417 VSS 0.03391f ; **FLOATING
C9908 VDD.n1395 VSS 0.11151f ; **FLOATING
C9909 VDD.n1396 VSS 0.02515f ; **FLOATING
C9910 VDD.n1397 VSS 0.063f ; **FLOATING
C9911 VDD.n1398 VSS 0.01472f ; **FLOATING
C9912 VDD.t512 VSS 0.03978f ; **FLOATING
C9913 VDD.n1399 VSS 0.08285f ; **FLOATING
C9914 VDD.n1400 VSS 0.03631f ; **FLOATING
C9915 VDD.t407 VSS 0.03391f ; **FLOATING
C9916 VDD.n1401 VSS 0.11149f ; **FLOATING
C9917 VDD.n1402 VSS 0.02515f ; **FLOATING
C9918 VDD.n1403 VSS 0.06302f ; **FLOATING
C9919 VDD.n1404 VSS 0.01472f ; **FLOATING
C9920 VDD.t1004 VSS 0.03978f ; **FLOATING
C9921 VDD.n1405 VSS 0.08282f ; **FLOATING
C9922 VDD.n1406 VSS 0.03634f ; **FLOATING
C9923 VDD.t303 VSS 0.03391f ; **FLOATING
C9924 VDD.n1407 VSS 0.11145f ; **FLOATING
C9925 VDD.n1408 VSS 0.02515f ; **FLOATING
C9926 VDD.n1409 VSS 0.06303f ; **FLOATING
C9927 VDD.n1410 VSS 0.01472f ; **FLOATING
C9928 VDD.t480 VSS 0.03978f ; **FLOATING
C9929 VDD.n1411 VSS 0.08284f ; **FLOATING
C9930 VDD.n1412 VSS 0.0363f ; **FLOATING
C9931 VDD.t421 VSS 0.03391f ; **FLOATING
C9932 VDD.n1413 VSS 0.11149f ; **FLOATING
C9933 VDD.n1414 VSS 0.02515f ; **FLOATING
C9934 VDD.n1415 VSS 0.06304f ; **FLOATING
C9935 VDD.n1416 VSS 0.01472f ; **FLOATING
C9936 VDD.t850 VSS 0.03978f ; **FLOATING
C9937 VDD.n1417 VSS 0.08285f ; **FLOATING
C9938 VDD.n1418 VSS 0.03625f ; **FLOATING
C9939 VDD.t422 VSS 0.03391f ; **FLOATING
C9940 VDD.n1419 VSS 0.11145f ; **FLOATING
C9941 VDD.n1420 VSS 0.02515f ; **FLOATING
C9942 VDD.n1421 VSS 0.06309f ; **FLOATING
C9943 VDD.n1422 VSS 0.01474f ; **FLOATING
C9944 VDD.t515 VSS 0.03978f ; **FLOATING
C9945 VDD.n1423 VSS 0.08282f ; **FLOATING
C9946 VDD.n1424 VSS 0.03625f ; **FLOATING
C9947 VDD.t292 VSS 0.03391f ; **FLOATING
C9948 VDD.n1425 VSS 0.11151f ; **FLOATING
C9949 VDD.n1426 VSS 0.02515f ; **FLOATING
C9950 VDD.n1427 VSS 0.06308f ; **FLOATING
C9951 VDD.n1428 VSS 0.01472f ; **FLOATING
C9952 VDD.t913 VSS 0.03978f ; **FLOATING
C9953 VDD.n1429 VSS 0.08285f ; **FLOATING
C9954 VDD.n1430 VSS 0.03631f ; **FLOATING
C9955 VDD.t424 VSS 0.03391f ; **FLOATING
C9956 VDD.n1431 VSS 0.11149f ; **FLOATING
C9957 VDD.n1432 VSS 0.02515f ; **FLOATING
C9958 VDD.n1433 VSS 0.06303f ; **FLOATING
C9959 VDD.n1434 VSS 0.01474f ; **FLOATING
C9960 VDD.t855 VSS 0.03978f ; **FLOATING
C9961 VDD.n1435 VSS 0.08282f ; **FLOATING
C9962 VDD.n1436 VSS 0.03632f ; **FLOATING
C9963 VDD.t425 VSS 0.03391f ; **FLOATING
C9964 VDD.n1437 VSS 0.11142f ; **FLOATING
C9965 VDD.n1438 VSS 0.02515f ; **FLOATING
C9966 VDD.n1439 VSS 0.06303f ; **FLOATING
C9967 VDD.n1440 VSS 0.01474f ; **FLOATING
C9968 VDD.t286 VSS 0.03978f ; **FLOATING
C9969 VDD.n1441 VSS 0.08281f ; **FLOATING
C9970 VDD.n1442 VSS 0.0363f ; **FLOATING
C9971 VDD.t423 VSS 0.03391f ; **FLOATING
C9972 VDD.n1443 VSS 0.11145f ; **FLOATING
C9973 VDD.n1444 VSS 0.02515f ; **FLOATING
C9974 VDD.n1445 VSS 0.06304f ; **FLOATING
C9975 VDD.n1446 VSS 0.01472f ; **FLOATING
C9976 VDD.t1002 VSS 0.03978f ; **FLOATING
C9977 VDD.n1447 VSS 0.08285f ; **FLOATING
C9978 VDD.n1448 VSS 0.0363f ; **FLOATING
C9979 VDD.t420 VSS 0.03391f ; **FLOATING
C9980 VDD.n1449 VSS 0.11151f ; **FLOATING
C9981 VDD.n1450 VSS 0.02515f ; **FLOATING
C9982 VDD.n1451 VSS 0.06304f ; **FLOATING
C9983 VDD.n1452 VSS 0.01472f ; **FLOATING
C9984 VDD.t468 VSS 0.03978f ; **FLOATING
C9985 VDD.n1453 VSS 0.08285f ; **FLOATING
C9986 VDD.n1454 VSS 0.0363f ; **FLOATING
C9987 VDD.t426 VSS 0.03391f ; **FLOATING
C9988 VDD.n1455 VSS 0.11149f ; **FLOATING
C9989 VDD.n1456 VSS 0.02515f ; **FLOATING
C9990 VDD.n1457 VSS 0.06304f ; **FLOATING
C9991 VDD.n1458 VSS 0.01472f ; **FLOATING
C9992 VDD.t503 VSS 0.03978f ; **FLOATING
C9993 VDD.n1459 VSS 0.08284f ; **FLOATING
C9994 VDD.n1460 VSS 0.03632f ; **FLOATING
C9995 VDD.t291 VSS 0.03391f ; **FLOATING
C9996 VDD.n1461 VSS 0.11145f ; **FLOATING
C9997 VDD.n1462 VSS 0.02515f ; **FLOATING
C9998 VDD.n1463 VSS 0.06301f ; **FLOATING
C9999 VDD.n1464 VSS 0.01472f ; **FLOATING
C10000 VDD.t725 VSS 0.03978f ; **FLOATING
C10001 VDD.n1465 VSS 0.08283f ; **FLOATING
C10002 VDD.n1466 VSS 0.03632f ; **FLOATING
C10003 VDD.t427 VSS 0.03391f ; **FLOATING
C10004 VDD.n1467 VSS 0.11151f ; **FLOATING
C10005 VDD.n1468 VSS 0.02515f ; **FLOATING
C10006 VDD.n1469 VSS 0.06303f ; **FLOATING
C10007 VDD.n1470 VSS 0.01472f ; **FLOATING
C10008 VDD.t521 VSS 0.03978f ; **FLOATING
C10009 VDD.n1471 VSS 0.08284f ; **FLOATING
C10010 VDD.n1472 VSS 0.03632f ; **FLOATING
C10011 VDD.t295 VSS 0.03391f ; **FLOATING
C10012 VDD.n1473 VSS 0.11151f ; **FLOATING
C10013 VDD.n1474 VSS 0.02515f ; **FLOATING
C10014 VDD.n1475 VSS 0.06303f ; **FLOATING
C10015 VDD.n1476 VSS 0.01474f ; **FLOATING
C10016 VDD.t910 VSS 0.03978f ; **FLOATING
C10017 VDD.n1477 VSS 0.08282f ; **FLOATING
C10018 VDD.n1478 VSS 0.03625f ; **FLOATING
C10019 VDD.t428 VSS 0.03391f ; **FLOATING
C10020 VDD.n1479 VSS 0.0923f ; **FLOATING
C10021 VDD.n1480 VSS 0.02515f ; **FLOATING
C10022 VDD.n1481 VSS 0.06309f ; **FLOATING
C10023 VDD.n1482 VSS 0.01474f ; **FLOATING
C10024 VDD.t576 VSS 0.03978f ; **FLOATING
C10025 VDD.n1483 VSS 0.06313f ; **FLOATING
C10026 VDD.n1484 VSS 0.01517f ; **FLOATING
C10027 VDD.t805 VSS 0.03391f ; **FLOATING
C10028 VDD.n1485 VSS 0.02515f ; **FLOATING
C10029 VDD.t806 VSS 0.0379f ; **FLOATING
C10030 VDD.n1486 VSS 0.07448f ; **FLOATING
C10031 VDD.t809 VSS 0.03391f ; **FLOATING
C10032 VDD.n1487 VSS 0.02251f ; **FLOATING
C10033 VDD.t807 VSS 0.03277f ; **FLOATING
C10034 VDD.n1488 VSS 0.01671f ; **FLOATING
C10035 VDD.n1489 VSS 0.06321f ; **FLOATING
C10036 VDD.n1490 VSS 0.05429f ; **FLOATING
C10037 VDD.t571 VSS 0.03511f ; **FLOATING
C10038 VDD.t726 VSS 0.03511f ; **FLOATING
C10039 VDD.t67 VSS 0.03153f ; **FLOATING
C10040 VDD.t1104 VSS 0.03511f ; **FLOATING
C10041 VDD.n1491 VSS 0.02899f ; **FLOATING
C10042 VDD.t825 VSS 0.04608f ; **FLOATING
C10043 VDD.n1492 VSS 0.08838f ; **FLOATING
C10044 VDD.n1493 VSS 0.02585f ; **FLOATING
C10045 VDD.t713 VSS 0.03511f ; **FLOATING
C10046 VDD.n1494 VSS 0.08379f ; **FLOATING
C10047 VDD.n1495 VSS 0.0123f ; **FLOATING
C10048 VDD.t909 VSS 0.03913f ; **FLOATING
C10049 VDD.t860 VSS 0.03913f ; **FLOATING
C10050 VDD.t529 VSS 0.03913f ; **FLOATING
C10051 VDD.t884 VSS 0.03913f ; **FLOATING
C10052 VDD.t1437 VSS 0.03511f ; **FLOATING
C10053 VDD.t675 VSS 0.03511f ; **FLOATING
C10054 VDD.n1496 VSS 0.10156f ; **FLOATING
C10055 VDD.n1497 VSS 0.01607f ; **FLOATING
C10056 VDD.t914 VSS 0.02593f ; **FLOATING
C10057 VDD.t488 VSS 0.02593f ; **FLOATING
C10058 VDD.n1498 VSS 0.08955f ; **FLOATING
C10059 VDD.t528 VSS 0.03466f ; **FLOATING
C10060 VDD.t626 VSS 0.03466f ; **FLOATING
C10061 VDD.t570 VSS 0.02593f ; **FLOATING
C10062 VDD.t728 VSS 0.02593f ; **FLOATING
C10063 VDD.t671 VSS 0.03466f ; **FLOATING
C10064 VDD.t625 VSS 0.03466f ; **FLOATING
C10065 VDD.t1438 VSS 0.02593f ; **FLOATING
C10066 VDD.t676 VSS 0.02593f ; **FLOATING
C10067 VDD.t852 VSS 0.03466f ; **FLOATING
C10068 VDD.t487 VSS 0.03466f ; **FLOATING
C10069 VDD.n1499 VSS 0.0818f ; **FLOATING
C10070 VDD.t853 VSS 0.03913f ; **FLOATING
C10071 VDD.t858 VSS 0.03913f ; **FLOATING
C10072 VDD.t572 VSS 0.02593f ; **FLOATING
C10073 VDD.t727 VSS 0.02593f ; **FLOATING
C10074 VDD.t1007 VSS 0.03466f ; **FLOATING
C10075 VDD.t513 VSS 0.03466f ; **FLOATING
C10076 VDD.n1500 VSS 0.07434f ; **FLOATING
C10077 VDD.t1008 VSS 0.03913f ; **FLOATING
C10078 VDD.t514 VSS 0.03913f ; **FLOATING
C10079 VDD.n1501 VSS 0.09345f ; **FLOATING
C10080 VDD.n1502 VSS 0.01253f ; **FLOATING
C10081 VDD.t486 VSS 0.03511f ; **FLOATING
C10082 VDD.t1442 VSS 0.03523f ; **FLOATING
C10083 VDD.t1506 VSS 0.03511f ; **FLOATING
C10084 VDD.n1503 VSS 0.07356f ; **FLOATING
C10085 VDD.n1504 VSS 0.01381f ; **FLOATING
C10086 VDD.t505 VSS 0.03511f ; **FLOATING
C10087 VDD.t1319 VSS 0.03511f ; **FLOATING
C10088 VDD.t1193 VSS 0.03511f ; **FLOATING
C10089 VDD.t147 VSS 0.03152f ; **FLOATING
C10090 VDD.t117 VSS 0.03153f ; **FLOATING
C10091 VDD.t637 VSS 0.03511f ; **FLOATING
C10092 VDD.t1662 VSS 0.11644f ; **FLOATING
C10093 VDD.t68 VSS 0.03384f ; **FLOATING
C10094 VDD.t276 VSS 0.04608f ; **FLOATING
C10095 VDD.t1661 VSS 0.11644f ; **FLOATING
C10096 VDD.t118 VSS 0.03384f ; **FLOATING
C10097 VDD.t478 VSS 0.03511f ; **FLOATING
C10098 VDD.t178 VSS 0.03152f ; **FLOATING
C10099 VDD.t179 VSS 0.03153f ; **FLOATING
C10100 VDD.t182 VSS 0.03152f ; **FLOATING
C10101 VDD.t709 VSS 0.03511f ; **FLOATING
C10102 VDD.t742 VSS 0.03511f ; **FLOATING
C10103 VDD.t1302 VSS 0.03511f ; **FLOATING
C10104 VDD.t945 VSS 0.03511f ; **FLOATING
C10105 VDD.t157 VSS 0.03153f ; **FLOATING
C10106 VDD.t547 VSS 0.04608f ; **FLOATING
C10107 VDD.t927 VSS 0.03511f ; **FLOATING
C10108 VDD.t60 VSS 0.03152f ; **FLOATING
C10109 VDD.t473 VSS 0.03511f ; **FLOATING
C10110 VDD.t103 VSS 0.03153f ; **FLOATING
C10111 VDD.t716 VSS 0.03511f ; **FLOATING
C10112 VDD.t88 VSS 0.03152f ; **FLOATING
C10113 VDD.t89 VSS 0.03153f ; **FLOATING
C10114 VDD.t644 VSS 0.04625f ; **FLOATING
C10115 VDD.t848 VSS 0.03511f ; **FLOATING
C10116 VDD.t92 VSS 0.03152f ; **FLOATING
C10117 VDD.t710 VSS 0.03511f ; **FLOATING
C10118 VDD.t1207 VSS 0.03511f ; **FLOATING
C10119 VDD.t946 VSS 0.03511f ; **FLOATING
C10120 VDD.t156 VSS 0.03153f ; **FLOATING
C10121 VDD.t579 VSS 0.04608f ; **FLOATING
C10122 VDD.t120 VSS 0.03152f ; **FLOATING
C10123 VDD.t1195 VSS 0.03511f ; **FLOATING
C10124 VDD.t1585 VSS 0.03153f ; **FLOATING
C10125 VDD.t666 VSS 0.03511f ; **FLOATING
C10126 VDD.t1507 VSS 0.03511f ; **FLOATING
C10127 VDD.t62 VSS 0.03152f ; **FLOATING
C10128 VDD.t63 VSS 0.03153f ; **FLOATING
C10129 VDD.t66 VSS 0.03152f ; **FLOATING
C10130 VDD.t1105 VSS 0.03511f ; **FLOATING
C10131 VDD.t905 VSS 0.03511f ; **FLOATING
C10132 VDD.t1211 VSS 0.03511f ; **FLOATING
C10133 VDD.t956 VSS 0.03511f ; **FLOATING
C10134 VDD.t1030 VSS 0.04608f ; **FLOATING
C10135 VDD.t1199 VSS 0.03511f ; **FLOATING
C10136 VDD.t561 VSS 0.03511f ; **FLOATING
C10137 VDD.t578 VSS 0.03511f ; **FLOATING
C10138 VDD.t714 VSS 0.03511f ; **FLOATING
C10139 VDD.t731 VSS 0.03728f ; **FLOATING
C10140 VDD.t645 VSS 0.04608f ; **FLOATING
C10141 VDD.t732 VSS 0.06583f ; **FLOATING
C10142 VDD.t708 VSS 0.03511f ; **FLOATING
C10143 VDD.t1009 VSS 0.03511f ; **FLOATING
C10144 VDD.t1317 VSS 0.03511f ; **FLOATING
C10145 VDD.t944 VSS 0.03511f ; **FLOATING
C10146 VDD.t136 VSS 0.03153f ; **FLOATING
C10147 VDD.t1510 VSS 0.04608f ; **FLOATING
C10148 VDD.t618 VSS 0.03511f ; **FLOATING
C10149 VDD.t1608 VSS 0.03152f ; **FLOATING
C10150 VDD.t704 VSS 0.03511f ; **FLOATING
C10151 VDD.t183 VSS 0.03153f ; **FLOATING
C10152 VDD.t715 VSS 0.03511f ; **FLOATING
C10153 VDD.t122 VSS 0.03152f ; **FLOATING
C10154 VDD.t123 VSS 0.03153f ; **FLOATING
C10155 VDD.t546 VSS 0.04625f ; **FLOATING
C10156 VDD.t828 VSS 0.03511f ; **FLOATING
C10157 VDD.t126 VSS 0.03152f ; **FLOATING
C10158 VDD.t711 VSS 0.03511f ; **FLOATING
C10159 VDD.t1303 VSS 0.03511f ; **FLOATING
C10160 VDD.t947 VSS 0.03511f ; **FLOATING
C10161 VDD.t48 VSS 0.03153f ; **FLOATING
C10162 VDD.t619 VSS 0.04608f ; **FLOATING
C10163 VDD.t263 VSS 0.03152f ; **FLOATING
C10164 VDD.t1196 VSS 0.03511f ; **FLOATING
C10165 VDD.t231 VSS 0.03153f ; **FLOATING
C10166 VDD.t558 VSS 0.03511f ; **FLOATING
C10167 VDD.t1508 VSS 0.03511f ; **FLOATING
C10168 VDD.t80 VSS 0.03152f ; **FLOATING
C10169 VDD.t81 VSS 0.03153f ; **FLOATING
C10170 VDD.t84 VSS 0.03152f ; **FLOATING
C10171 VDD.t1106 VSS 0.03511f ; **FLOATING
C10172 VDD.t510 VSS 0.03511f ; **FLOATING
C10173 VDD.t1208 VSS 0.03511f ; **FLOATING
C10174 VDD.t957 VSS 0.03511f ; **FLOATING
C10175 VDD.t55 VSS 0.03153f ; **FLOATING
C10176 VDD.t516 VSS 0.04608f ; **FLOATING
C10177 VDD.t1200 VSS 0.03511f ; **FLOATING
C10178 VDD.t160 VSS 0.03152f ; **FLOATING
C10179 VDD.t527 VSS 0.03511f ; **FLOATING
C10180 VDD.t158 VSS 0.03153f ; **FLOATING
C10181 VDD.t477 VSS 0.03511f ; **FLOATING
C10182 VDD.t43 VSS 0.03152f ; **FLOATING
C10183 VDD.t44 VSS 0.03153f ; **FLOATING
C10184 VDD.t854 VSS 0.04625f ; **FLOATING
C10185 VDD.t639 VSS 0.03511f ; **FLOATING
C10186 VDD.t47 VSS 0.03152f ; **FLOATING
C10187 VDD.t1505 VSS 0.03511f ; **FLOATING
C10188 VDD.t1215 VSS 0.03511f ; **FLOATING
C10189 VDD.t712 VSS 0.03511f ; **FLOATING
C10190 VDD.t641 VSS 0.04608f ; **FLOATING
C10191 VDD.t1194 VSS 0.04222f ; **FLOATING
C10192 VDD.t1645 VSS 0.11644f ; **FLOATING
C10193 VDD.t45 VSS 0.03384f ; **FLOATING
C10194 VDD.t1646 VSS 0.11644f ; **FLOATING
C10195 VDD.t42 VSS 0.03384f ; **FLOATING
C10196 VDD.t1647 VSS 0.11644f ; **FLOATING
C10197 VDD.t56 VSS 0.03384f ; **FLOATING
C10198 VDD.t601 VSS 0.04625f ; **FLOATING
C10199 VDD.t1648 VSS 0.11644f ; **FLOATING
C10200 VDD.t82 VSS 0.03384f ; **FLOATING
C10201 VDD.t1649 VSS 0.11644f ; **FLOATING
C10202 VDD.t79 VSS 0.03384f ; **FLOATING
C10203 VDD.t1650 VSS 0.11644f ; **FLOATING
C10204 VDD.t49 VSS 0.03384f ; **FLOATING
C10205 VDD.t1651 VSS 0.11644f ; **FLOATING
C10206 VDD.t124 VSS 0.03384f ; **FLOATING
C10207 VDD.t1652 VSS 0.11644f ; **FLOATING
C10208 VDD.t121 VSS 0.03384f ; **FLOATING
C10209 VDD.t1653 VSS 0.11644f ; **FLOATING
C10210 VDD.t137 VSS 0.03384f ; **FLOATING
C10211 VDD.n1505 VSS 0.06615f ; **FLOATING
C10212 VDD.n1506 VSS 0.01381f ; **FLOATING
C10213 VDD.n1507 VSS 0.07821f ; **FLOATING
C10214 VDD.n1508 VSS 0.01184f ; **FLOATING
C10215 VDD.n1509 VSS 0.06899f ; **FLOATING
C10216 VDD.n1510 VSS 0.01381f ; **FLOATING
C10217 VDD.n1511 VSS 0.08508f ; **FLOATING
C10218 VDD.t999 VSS 0.04625f ; **FLOATING
C10219 VDD.t1654 VSS 0.11644f ; **FLOATING
C10220 VDD.t64 VSS 0.03384f ; **FLOATING
C10221 VDD.t1655 VSS 0.11644f ; **FLOATING
C10222 VDD.t61 VSS 0.03384f ; **FLOATING
C10223 VDD.t1656 VSS 0.11644f ; **FLOATING
C10224 VDD.t119 VSS 0.03384f ; **FLOATING
C10225 VDD.t1657 VSS 0.11644f ; **FLOATING
C10226 VDD.t90 VSS 0.03384f ; **FLOATING
C10227 VDD.t1658 VSS 0.11644f ; **FLOATING
C10228 VDD.t87 VSS 0.03384f ; **FLOATING
C10229 VDD.t1659 VSS 0.11644f ; **FLOATING
C10230 VDD.t59 VSS 0.03384f ; **FLOATING
C10231 VDD.t556 VSS 0.04625f ; **FLOATING
C10232 VDD.t1660 VSS 0.11644f ; **FLOATING
C10233 VDD.t180 VSS 0.03384f ; **FLOATING
C10234 VDD.n1512 VSS 1.05155f ; **FLOATING
C10235 VDD.t793 VSS 0.07114f ; **FLOATING
C10236 VDD.n1513 VSS 0.05148f ; **FLOATING
C10237 VDD.n1514 VSS 0.05148f ; **FLOATING
C10238 VDD.n1515 VSS 0.05156f ; **FLOATING
C10239 VDD.n1516 VSS 0.05148f ; **FLOATING
C10240 VDD.n1517 VSS 0.05148f ; **FLOATING
C10241 VDD.n1518 VSS 0.05156f ; **FLOATING
C10242 VDD.n1519 VSS 0.05148f ; **FLOATING
C10243 VDD.n1520 VSS 0.05148f ; **FLOATING
C10244 VDD.n1521 VSS 0.05148f ; **FLOATING
C10245 VDD.n1522 VSS 0.05156f ; **FLOATING
C10246 VDD.n1523 VSS 0.05156f ; **FLOATING
C10247 VDD.n1524 VSS 0.05148f ; **FLOATING
C10248 VDD.n1525 VSS 0.05148f ; **FLOATING
C10249 VDD.n1526 VSS 0.05148f ; **FLOATING
C10250 VDD.n1527 VSS 0.05156f ; **FLOATING
C10251 VDD.n1528 VSS 0.05156f ; **FLOATING
C10252 VDD.n1529 VSS 0.05148f ; **FLOATING
C10253 VDD.n1530 VSS 0.05148f ; **FLOATING
C10254 VDD.n1531 VSS 0.05148f ; **FLOATING
C10255 VDD.n1532 VSS 0.05148f ; **FLOATING
C10256 VDD.n1533 VSS 0.05148f ; **FLOATING
C10257 VDD.n1534 VSS 0.05148f ; **FLOATING
C10258 VDD.n1535 VSS 0.05148f ; **FLOATING
C10259 VDD.n1536 VSS 0.05156f ; **FLOATING
C10260 VDD.n1537 VSS 0.05156f ; **FLOATING
C10261 VDD.n1538 VSS 0.05148f ; **FLOATING
C10262 VDD.n1539 VSS 0.05156f ; **FLOATING
C10263 VDD.n1540 VSS 0.05148f ; **FLOATING
C10264 VDD.n1541 VSS 0.05148f ; **FLOATING
C10265 VDD.n1542 VSS 0.05148f ; **FLOATING
C10266 VDD.n1543 VSS 0.05156f ; **FLOATING
C10267 VDD.t789 VSS 0.03446f ; **FLOATING
C10268 VDD.t788 VSS 0.02458f ; **FLOATING
C10269 VDD.t792 VSS 0.03431f ; **FLOATING
C10270 VDD.t790 VSS 0.0379f ; **FLOATING
C10271 VDD.t791 VSS 0.01994f ; **FLOATING
C10272 VDD.t380 VSS 0.03391f ; **FLOATING
C10273 VDD.n1544 VSS 0.10267f ; **FLOATING
C10274 VDD.n1545 VSS 0.02515f ; **FLOATING
C10275 VDD.n1546 VSS 0.07979f ; **FLOATING
C10276 VDD.n1547 VSS 0.01474f ; **FLOATING
C10277 VDD.t863 VSS 0.03978f ; **FLOATING
C10278 VDD.n1548 VSS 0.08283f ; **FLOATING
C10279 VDD.n1549 VSS 0.03631f ; **FLOATING
C10280 VDD.t381 VSS 0.03391f ; **FLOATING
C10281 VDD.n1550 VSS 0.11145f ; **FLOATING
C10282 VDD.n1551 VSS 0.02515f ; **FLOATING
C10283 VDD.n1552 VSS 0.06303f ; **FLOATING
C10284 VDD.n1553 VSS 0.01474f ; **FLOATING
C10285 VDD.t504 VSS 0.03978f ; **FLOATING
C10286 VDD.n1554 VSS 0.08282f ; **FLOATING
C10287 VDD.n1555 VSS 0.03632f ; **FLOATING
C10288 VDD.t379 VSS 0.03391f ; **FLOATING
C10289 VDD.n1556 VSS 0.11151f ; **FLOATING
C10290 VDD.n1557 VSS 0.02515f ; **FLOATING
C10291 VDD.n1558 VSS 0.06301f ; **FLOATING
C10292 VDD.n1559 VSS 0.01472f ; **FLOATING
C10293 VDD.t525 VSS 0.03978f ; **FLOATING
C10294 VDD.n1560 VSS 0.08283f ; **FLOATING
C10295 VDD.n1561 VSS 0.03632f ; **FLOATING
C10296 VDD.t382 VSS 0.03391f ; **FLOATING
C10297 VDD.n1562 VSS 0.11151f ; **FLOATING
C10298 VDD.n1563 VSS 0.02515f ; **FLOATING
C10299 VDD.n1564 VSS 0.06303f ; **FLOATING
C10300 VDD.n1565 VSS 0.01472f ; **FLOATING
C10301 VDD.t638 VSS 0.03978f ; **FLOATING
C10302 VDD.n1566 VSS 0.08282f ; **FLOATING
C10303 VDD.n1567 VSS 0.03636f ; **FLOATING
C10304 VDD.t378 VSS 0.03391f ; **FLOATING
C10305 VDD.n1568 VSS 0.11149f ; **FLOATING
C10306 VDD.n1569 VSS 0.02515f ; **FLOATING
C10307 VDD.n1570 VSS 0.06301f ; **FLOATING
C10308 VDD.n1571 VSS 0.01474f ; **FLOATING
C10309 VDD.t620 VSS 0.03978f ; **FLOATING
C10310 VDD.n1572 VSS 0.08282f ; **FLOATING
C10311 VDD.n1573 VSS 0.03632f ; **FLOATING
C10312 VDD.t372 VSS 0.03391f ; **FLOATING
C10313 VDD.n1574 VSS 0.11145f ; **FLOATING
C10314 VDD.n1575 VSS 0.02515f ; **FLOATING
C10315 VDD.n1576 VSS 0.06303f ; **FLOATING
C10316 VDD.n1577 VSS 0.01474f ; **FLOATING
C10317 VDD.t743 VSS 0.03978f ; **FLOATING
C10318 VDD.n1578 VSS 0.08281f ; **FLOATING
C10319 VDD.n1579 VSS 0.0363f ; **FLOATING
C10320 VDD.t383 VSS 0.03391f ; **FLOATING
C10321 VDD.n1580 VSS 0.11149f ; **FLOATING
C10322 VDD.n1581 VSS 0.02515f ; **FLOATING
C10323 VDD.n1582 VSS 0.06304f ; **FLOATING
C10324 VDD.n1583 VSS 0.01472f ; **FLOATING
C10325 VDD.t549 VSS 0.03978f ; **FLOATING
C10326 VDD.n1584 VSS 0.08285f ; **FLOATING
C10327 VDD.n1585 VSS 0.03625f ; **FLOATING
C10328 VDD.t375 VSS 0.03391f ; **FLOATING
C10329 VDD.n1586 VSS 0.11142f ; **FLOATING
C10330 VDD.n1587 VSS 0.02515f ; **FLOATING
C10331 VDD.n1588 VSS 0.0631f ; **FLOATING
C10332 VDD.n1589 VSS 0.01474f ; **FLOATING
C10333 VDD.t474 VSS 0.03978f ; **FLOATING
C10334 VDD.n1590 VSS 0.08281f ; **FLOATING
C10335 VDD.n1591 VSS 0.0363f ; **FLOATING
C10336 VDD.t384 VSS 0.03391f ; **FLOATING
C10337 VDD.n1592 VSS 0.11145f ; **FLOATING
C10338 VDD.n1593 VSS 0.02515f ; **FLOATING
C10339 VDD.n1594 VSS 0.06305f ; **FLOATING
C10340 VDD.n1595 VSS 0.01474f ; **FLOATING
C10341 VDD.t1468 VSS 0.03978f ; **FLOATING
C10342 VDD.n1596 VSS 0.08282f ; **FLOATING
C10343 VDD.n1597 VSS 0.03632f ; **FLOATING
C10344 VDD.t385 VSS 0.03391f ; **FLOATING
C10345 VDD.n1598 VSS 0.11151f ; **FLOATING
C10346 VDD.n1599 VSS 0.02515f ; **FLOATING
C10347 VDD.n1600 VSS 0.06301f ; **FLOATING
C10348 VDD.n1601 VSS 0.01472f ; **FLOATING
C10349 VDD.t849 VSS 0.03978f ; **FLOATING
C10350 VDD.n1602 VSS 0.08282f ; **FLOATING
C10351 VDD.n1603 VSS 0.03631f ; **FLOATING
C10352 VDD.t374 VSS 0.03391f ; **FLOATING
C10353 VDD.n1604 VSS 0.11151f ; **FLOATING
C10354 VDD.n1605 VSS 0.02515f ; **FLOATING
C10355 VDD.n1606 VSS 0.06306f ; **FLOATING
C10356 VDD.n1607 VSS 0.01474f ; **FLOATING
C10357 VDD.t1440 VSS 0.03978f ; **FLOATING
C10358 VDD.n1608 VSS 0.08282f ; **FLOATING
C10359 VDD.n1609 VSS 0.03632f ; **FLOATING
C10360 VDD.t373 VSS 0.03391f ; **FLOATING
C10361 VDD.n1610 VSS 0.11151f ; **FLOATING
C10362 VDD.n1611 VSS 0.02515f ; **FLOATING
C10363 VDD.n1612 VSS 0.06303f ; **FLOATING
C10364 VDD.n1613 VSS 0.01474f ; **FLOATING
C10365 VDD.t665 VSS 0.03978f ; **FLOATING
C10366 VDD.n1614 VSS 0.08281f ; **FLOATING
C10367 VDD.n1615 VSS 0.0363f ; **FLOATING
C10368 VDD.t386 VSS 0.03391f ; **FLOATING
C10369 VDD.n1616 VSS 0.11151f ; **FLOATING
C10370 VDD.n1617 VSS 0.02515f ; **FLOATING
C10371 VDD.n1618 VSS 0.06305f ; **FLOATING
C10372 VDD.n1619 VSS 0.01474f ; **FLOATING
C10373 VDD.t998 VSS 0.03978f ; **FLOATING
C10374 VDD.n1620 VSS 0.08279f ; **FLOATING
C10375 VDD.n1621 VSS 0.03634f ; **FLOATING
C10376 VDD.t369 VSS 0.03391f ; **FLOATING
C10377 VDD.n1622 VSS 0.11151f ; **FLOATING
C10378 VDD.n1623 VSS 0.02515f ; **FLOATING
C10379 VDD.n1624 VSS 0.06304f ; **FLOATING
C10380 VDD.n1625 VSS 0.01474f ; **FLOATING
C10381 VDD.t824 VSS 0.03978f ; **FLOATING
C10382 VDD.n1626 VSS 0.08281f ; **FLOATING
C10383 VDD.n1627 VSS 0.0363f ; **FLOATING
C10384 VDD.t388 VSS 0.03391f ; **FLOATING
C10385 VDD.n1628 VSS 0.11151f ; **FLOATING
C10386 VDD.n1629 VSS 0.02515f ; **FLOATING
C10387 VDD.n1630 VSS 0.06304f ; **FLOATING
C10388 VDD.n1631 VSS 0.01472f ; **FLOATING
C10389 VDD.t1430 VSS 0.03978f ; **FLOATING
C10390 VDD.n1632 VSS 0.08285f ; **FLOATING
C10391 VDD.n1633 VSS 0.03631f ; **FLOATING
C10392 VDD.t389 VSS 0.03391f ; **FLOATING
C10393 VDD.n1634 VSS 0.11149f ; **FLOATING
C10394 VDD.n1635 VSS 0.02515f ; **FLOATING
C10395 VDD.n1636 VSS 0.06303f ; **FLOATING
C10396 VDD.n1637 VSS 0.01474f ; **FLOATING
C10397 VDD.t522 VSS 0.03978f ; **FLOATING
C10398 VDD.n1638 VSS 0.0828f ; **FLOATING
C10399 VDD.n1639 VSS 0.03631f ; **FLOATING
C10400 VDD.t387 VSS 0.03391f ; **FLOATING
C10401 VDD.n1640 VSS 0.11142f ; **FLOATING
C10402 VDD.n1641 VSS 0.02515f ; **FLOATING
C10403 VDD.n1642 VSS 0.06306f ; **FLOATING
C10404 VDD.n1643 VSS 0.01474f ; **FLOATING
C10405 VDD.t895 VSS 0.03978f ; **FLOATING
C10406 VDD.n1644 VSS 0.08282f ; **FLOATING
C10407 VDD.n1645 VSS 0.03625f ; **FLOATING
C10408 VDD.t371 VSS 0.03391f ; **FLOATING
C10409 VDD.n1646 VSS 0.11145f ; **FLOATING
C10410 VDD.n1647 VSS 0.02515f ; **FLOATING
C10411 VDD.n1648 VSS 0.06309f ; **FLOATING
C10412 VDD.n1649 VSS 0.01474f ; **FLOATING
C10413 VDD.t861 VSS 0.03978f ; **FLOATING
C10414 VDD.n1650 VSS 0.08282f ; **FLOATING
C10415 VDD.n1651 VSS 0.03625f ; **FLOATING
C10416 VDD.t390 VSS 0.03391f ; **FLOATING
C10417 VDD.n1652 VSS 0.11151f ; **FLOATING
C10418 VDD.n1653 VSS 0.02515f ; **FLOATING
C10419 VDD.n1654 VSS 0.06309f ; **FLOATING
C10420 VDD.n1655 VSS 0.01474f ; **FLOATING
C10421 VDD.t520 VSS 0.03978f ; **FLOATING
C10422 VDD.n1656 VSS 0.08279f ; **FLOATING
C10423 VDD.n1657 VSS 0.03636f ; **FLOATING
C10424 VDD.t377 VSS 0.03391f ; **FLOATING
C10425 VDD.n1658 VSS 0.11151f ; **FLOATING
C10426 VDD.n1659 VSS 0.02515f ; **FLOATING
C10427 VDD.n1660 VSS 0.06301f ; **FLOATING
C10428 VDD.n1661 VSS 0.01474f ; **FLOATING
C10429 VDD.t523 VSS 0.03978f ; **FLOATING
C10430 VDD.n1662 VSS 0.08279f ; **FLOATING
C10431 VDD.n1663 VSS 0.03634f ; **FLOATING
C10432 VDD.t376 VSS 0.03391f ; **FLOATING
C10433 VDD.n1664 VSS 0.11149f ; **FLOATING
C10434 VDD.n1665 VSS 0.02515f ; **FLOATING
C10435 VDD.n1666 VSS 0.06304f ; **FLOATING
C10436 VDD.n1667 VSS 0.01474f ; **FLOATING
C10437 VDD.t822 VSS 0.03978f ; **FLOATING
C10438 VDD.n1668 VSS 0.08282f ; **FLOATING
C10439 VDD.n1669 VSS 0.0363f ; **FLOATING
C10440 VDD.t391 VSS 0.03391f ; **FLOATING
C10441 VDD.n1670 VSS 0.11142f ; **FLOATING
C10442 VDD.n1671 VSS 0.02515f ; **FLOATING
C10443 VDD.n1672 VSS 0.06305f ; **FLOATING
C10444 VDD.n1673 VSS 0.01474f ; **FLOATING
C10445 VDD.t622 VSS 0.03978f ; **FLOATING
C10446 VDD.n1674 VSS 0.08279f ; **FLOATING
C10447 VDD.n1675 VSS 0.03636f ; **FLOATING
C10448 VDD.t392 VSS 0.03391f ; **FLOATING
C10449 VDD.n1676 VSS 0.11145f ; **FLOATING
C10450 VDD.n1677 VSS 0.02515f ; **FLOATING
C10451 VDD.n1678 VSS 0.063f ; **FLOATING
C10452 VDD.n1679 VSS 0.01472f ; **FLOATING
C10453 VDD.t1120 VSS 0.03978f ; **FLOATING
C10454 VDD.n1680 VSS 0.08284f ; **FLOATING
C10455 VDD.n1681 VSS 0.0363f ; **FLOATING
C10456 VDD.t393 VSS 0.03391f ; **FLOATING
C10457 VDD.n1682 VSS 0.11151f ; **FLOATING
C10458 VDD.n1683 VSS 0.02515f ; **FLOATING
C10459 VDD.n1684 VSS 0.06305f ; **FLOATING
C10460 VDD.n1685 VSS 0.01474f ; **FLOATING
C10461 VDD.t557 VSS 0.03978f ; **FLOATING
C10462 VDD.n1686 VSS 0.08283f ; **FLOATING
C10463 VDD.n1687 VSS 0.03631f ; **FLOATING
C10464 VDD.t367 VSS 0.03391f ; **FLOATING
C10465 VDD.n1688 VSS 0.11151f ; **FLOATING
C10466 VDD.n1689 VSS 0.02515f ; **FLOATING
C10467 VDD.n1690 VSS 0.06303f ; **FLOATING
C10468 VDD.n1691 VSS 0.01474f ; **FLOATING
C10469 VDD.t600 VSS 0.03978f ; **FLOATING
C10470 VDD.n1692 VSS 0.08282f ; **FLOATING
C10471 VDD.n1693 VSS 0.0363f ; **FLOATING
C10472 VDD.t370 VSS 0.03391f ; **FLOATING
C10473 VDD.n1694 VSS 0.11149f ; **FLOATING
C10474 VDD.n1695 VSS 0.02515f ; **FLOATING
C10475 VDD.n1696 VSS 0.06305f ; **FLOATING
C10476 VDD.n1697 VSS 0.01474f ; **FLOATING
C10477 VDD.t509 VSS 0.03978f ; **FLOATING
C10478 VDD.n1698 VSS 0.08281f ; **FLOATING
C10479 VDD.n1699 VSS 0.0363f ; **FLOATING
C10480 VDD.t394 VSS 0.03391f ; **FLOATING
C10481 VDD.n1700 VSS 0.11145f ; **FLOATING
C10482 VDD.n1701 VSS 0.02515f ; **FLOATING
C10483 VDD.n1702 VSS 0.06305f ; **FLOATING
C10484 VDD.n1703 VSS 0.01474f ; **FLOATING
C10485 VDD.t284 VSS 0.03978f ; **FLOATING
C10486 VDD.n1704 VSS 0.0828f ; **FLOATING
C10487 VDD.n1705 VSS 0.03631f ; **FLOATING
C10488 VDD.t368 VSS 0.03391f ; **FLOATING
C10489 VDD.n1706 VSS 0.11151f ; **FLOATING
C10490 VDD.n1707 VSS 0.02515f ; **FLOATING
C10491 VDD.n1708 VSS 0.06306f ; **FLOATING
C10492 VDD.n1709 VSS 0.01474f ; **FLOATING
C10493 VDD.t526 VSS 0.03978f ; **FLOATING
C10494 VDD.n1710 VSS 0.08282f ; **FLOATING
C10495 VDD.n1711 VSS 0.03632f ; **FLOATING
C10496 VDD.t398 VSS 0.03391f ; **FLOATING
C10497 VDD.n1712 VSS 0.11149f ; **FLOATING
C10498 VDD.n1713 VSS 0.02515f ; **FLOATING
C10499 VDD.n1714 VSS 0.06303f ; **FLOATING
C10500 VDD.n1715 VSS 0.01474f ; **FLOATING
C10501 VDD.t823 VSS 0.03978f ; **FLOATING
C10502 VDD.n1716 VSS 0.0828f ; **FLOATING
C10503 VDD.n1717 VSS 0.03631f ; **FLOATING
C10504 VDD.t396 VSS 0.03391f ; **FLOATING
C10505 VDD.n1718 VSS 0.11145f ; **FLOATING
C10506 VDD.n1719 VSS 0.02515f ; **FLOATING
C10507 VDD.n1720 VSS 0.06306f ; **FLOATING
C10508 VDD.n1721 VSS 0.01474f ; **FLOATING
C10509 VDD.t593 VSS 0.03978f ; **FLOATING
C10510 VDD.n1722 VSS 0.08281f ; **FLOATING
C10511 VDD.n1723 VSS 0.0363f ; **FLOATING
C10512 VDD.t395 VSS 0.03391f ; **FLOATING
C10513 VDD.n1724 VSS 0.11151f ; **FLOATING
C10514 VDD.n1725 VSS 0.02515f ; **FLOATING
C10515 VDD.n1726 VSS 0.06305f ; **FLOATING
C10516 VDD.n1727 VSS 0.01474f ; **FLOATING
C10517 VDD.t519 VSS 0.03978f ; **FLOATING
C10518 VDD.n1728 VSS 0.08281f ; **FLOATING
C10519 VDD.n1729 VSS 0.0363f ; **FLOATING
C10520 VDD.t397 VSS 0.03391f ; **FLOATING
C10521 VDD.n1730 VSS 0.0923f ; **FLOATING
C10522 VDD.n1731 VSS 0.02515f ; **FLOATING
C10523 VDD.n1732 VSS 0.06305f ; **FLOATING
C10524 VDD.n1733 VSS 0.01474f ; **FLOATING
C10525 VDD.t1023 VSS 0.03978f ; **FLOATING
C10526 VDD.n1734 VSS 0.06312f ; **FLOATING
C10527 VDD.n1735 VSS 0.01515f ; **FLOATING
C10528 VDD.t794 VSS 0.03391f ; **FLOATING
C10529 VDD.n1736 VSS 0.02515f ; **FLOATING
C10530 VDD.t795 VSS 0.0379f ; **FLOATING
C10531 VDD.n1737 VSS 0.07448f ; **FLOATING
C10532 VDD.t798 VSS 0.03391f ; **FLOATING
C10533 VDD.n1738 VSS 0.02251f ; **FLOATING
C10534 VDD.t796 VSS 0.03277f ; **FLOATING
C10535 VDD.n1739 VSS 0.01671f ; **FLOATING
C10536 VDD.n1740 VSS 0.06321f ; **FLOATING
C10537 VDD.n1741 VSS 0.05429f ; **FLOATING
C10538 VDD.n1742 VSS 0.74965f ; **FLOATING
C10539 VDD.n1743 VSS 1.6851f ; **FLOATING
C10540 VDD.n1744 VSS 1.04687f ; **FLOATING
C10541 VDD.n1745 VSS 0.73566f ; **FLOATING
C10542 VDD.n1746 VSS 0.01574f ; **FLOATING
C10543 VDD.t563 VSS 0.02316f ; **FLOATING
C10544 VDD.n1747 VSS 0.0654f ; **FLOATING
C10545 VDD.n1748 VSS 0.01638f ; **FLOATING
C10546 VDD.n1749 VSS 0.01671f ; **FLOATING
C10547 VDD.n1750 VSS 0.07237f ; **FLOATING
C10548 VDD.t773 VSS 0.06769f ; **FLOATING
C10549 VDD.n1751 VSS 0.02363f ; **FLOATING
C10550 VDD.n1752 VSS 0.05294f ; **FLOATING
C10551 VDD.t768 VSS 0.06056f ; **FLOATING
C10552 VDD.n1753 VSS 0.02361f ; **FLOATING
C10553 VDD.t774 VSS 0.06056f ; **FLOATING
C10554 VDD.n1754 VSS 0.06776f ; **FLOATING
C10555 VDD.n1755 VSS 0.02361f ; **FLOATING
C10556 VDD.n1756 VSS 0.04782f ; **FLOATING
C10557 VDD.t766 VSS 0.38296f ; **FLOATING
C10558 VDD.n1757 VSS 0.01546f ; **FLOATING
C10559 VDD.n1758 VSS 0.0478f ; **FLOATING
C10560 VDD.t767 VSS 0.06769f ; **FLOATING
C10561 VDD.n1759 VSS 0.02363f ; **FLOATING
C10562 VDD.n1760 VSS 0.07232f ; **FLOATING
C10563 VDD.n1761 VSS 0.03818f ; **FLOATING
C10564 VDD.n1762 VSS 0.09206f ; **FLOATING
C10565 VDD.t1127 VSS 0.06769f ; **FLOATING
C10566 VDD.n1763 VSS 0.04391f ; **FLOATING
C10567 VDD.t1130 VSS 0.06769f ; **FLOATING
C10568 VDD.n1764 VSS 0.04392f ; **FLOATING
C10569 VDD.n1765 VSS 0.09206f ; **FLOATING
C10570 VDD.n1766 VSS 0.03326f ; **FLOATING
C10571 VDD.n1767 VSS 0.09228f ; **FLOATING
C10572 VDD.t1128 VSS 0.06769f ; **FLOATING
C10573 VDD.n1768 VSS 0.04391f ; **FLOATING
C10574 VDD.t1132 VSS 0.06769f ; **FLOATING
C10575 VDD.n1769 VSS 0.04392f ; **FLOATING
C10576 VDD.n1770 VSS 0.09228f ; **FLOATING
C10577 VDD.n1771 VSS 0.03804f ; **FLOATING
C10578 VDD.n1772 VSS 0.08718f ; **FLOATING
C10579 VDD.t1140 VSS 0.06769f ; **FLOATING
C10580 VDD.n1773 VSS 0.04391f ; **FLOATING
C10581 VDD.t1134 VSS 0.06769f ; **FLOATING
C10582 VDD.n1774 VSS 0.04392f ; **FLOATING
C10583 VDD.n1775 VSS 0.08718f ; **FLOATING
C10584 VDD.n1776 VSS 0.0382f ; **FLOATING
C10585 VDD.n1777 VSS 0.01672f ; **FLOATING
C10586 VDD.t771 VSS 0.06056f ; **FLOATING
C10587 VDD.t776 VSS 0.06056f ; **FLOATING
C10588 VDD.n1778 VSS 0.07374f ; **FLOATING
C10589 VDD.n1779 VSS 0.02361f ; **FLOATING
C10590 VDD.t770 VSS 0.06769f ; **FLOATING
C10591 VDD.n1780 VSS 0.07235f ; **FLOATING
C10592 VDD.n1781 VSS 0.02363f ; **FLOATING
C10593 VDD.n1782 VSS 0.07234f ; **FLOATING
C10594 VDD.t777 VSS 0.06769f ; **FLOATING
C10595 VDD.n1783 VSS 0.02363f ; **FLOATING
C10596 VDD.n1784 VSS 0.0478f ; **FLOATING
C10597 VDD.t769 VSS 0.38296f ; **FLOATING
C10598 VDD.n1785 VSS 0.01546f ; **FLOATING
C10599 VDD.n1786 VSS 0.05123f ; **FLOATING
C10600 VDD.n1787 VSS 0.02361f ; **FLOATING
C10601 VDD.n1788 VSS 0.08617f ; **FLOATING
C10602 VDD.n1789 VSS 0.05039f ; **FLOATING
C10603 VDD.t268 VSS 13.3319f ; **FLOATING
.ends
