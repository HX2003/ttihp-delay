* NGSPICE file created from hx_delay_bank.ext - technology: ihp-sg13g2

.subckt hx_delay_bank VDD CHAN0_DELAY_OUT_LAST CHAN1_DELAY_OUT_LAST CHAN3_DELAY_OUT_LAST
+ CHAN2_DELAY_OUT_LAST REF_DELAY_OUT_LAST DLL_RESETN REF_CLK VSS CHAN0_DELAY_IN CHAN0_MUX_SEL0
+ CHAN0_MUX_SEL1 CHAN0_MUX_OUT CHAN0_MUX_SEL4 CHAN0_MUX_SEL2 CHAN0_MUX_SEL3 CHAN1_DELAY_IN
+ CHAN1_MUX_SEL0 CHAN1_MUX_SEL1 CHAN1_MUX_OUT CHAN1_MUX_SEL4 CHAN1_MUX_SEL2 CHAN1_MUX_SEL3
+ CHAN3_DELAY_IN CHAN2_DELAY_IN CHAN3_MUX_SEL0 CHAN2_MUX_SEL0 CHAN3_MUX_SEL1 CHAN2_MUX_SEL1
+ CHAN3_MUX_OUT CHAN2_MUX_OUT CHAN3_MUX_SEL4 CHAN2_MUX_SEL4 CHAN3_MUX_SEL2 CHAN2_MUX_SEL2
+ CHAN3_MUX_SEL3 CHAN2_MUX_SEL3 REF_MUX_SEL0 REF_MUX_SEL1 REF_MUX_OUT REF_MUX_SEL4
+ REF_MUX_SEL2 REF_MUX_SEL3
X0 VDD.t575 a_4003_1842# a_4437_1842# VDD.t353 sg13_lv_pmos ad=0.2128p pd=1.5u as=0.3808p ps=2.92u w=1.12u l=0.13u
X1 VSS.t429 a_4187_1764.t102 a_26151_14024# VSS.t1562 sg13_lv_nmos ad=0.2516p pd=2.16u as=0.1406p ps=1.12u w=0.74u l=0.6u
X2 a_22590_3889# a_22564_3853# a_22488_3889# VDD.t9 sg13_lv_pmos ad=0.3808p pd=2.92u as=0.2128p ps=1.5u w=1.12u l=0.13u
X3 a_15511_8160# a_15273_7532# a_15403_7532# VDD.t341 sg13_lv_pmos ad=0.2128p pd=1.5u as=0.3808p ps=2.92u w=1.12u l=0.2u
X4 a_5974_11413# a_6126_9506# VSS.t965 VSS.t959 sg13_lv_nmos ad=0.38p pd=2.38u as=0.68p ps=4.68u w=2u l=1u
X5 VDD.t1499 a_3171_16074.t4 a_21044_16035# VDD.t20 sg13_lv_pmos ad=0.3808p pd=2.92u as=0.3808p ps=2.92u w=1.12u l=0.13u
X6 a_14751_14652# a_14513_14024# a_14643_14024# VDD.t381 sg13_lv_pmos ad=0.2128p pd=1.5u as=0.3808p ps=2.92u w=1.12u l=0.2u
X7 VSS.t932 VSS.t930 VSS.t929 VSS.t931 sg13_lv_nmos ad=0.1406p pd=1.12u as=0 ps=0 w=0.74u l=0.2u
X8 a_18551_5315# a_18313_4687# a_18443_4687# VDD.t339 sg13_lv_pmos ad=0.2128p pd=1.5u as=0.3808p ps=2.92u w=1.12u l=0.2u
X9 a_5731_15316# a_14825_15546# a_13470_16071# VDD.t20 sg13_lv_pmos ad=0.3808p pd=2.92u as=0.3808p ps=2.92u w=1.12u l=0.13u
X10 a_19073_14024# a_18877_14024# VDD.t382 VDD.t381 sg13_lv_pmos ad=0.3808p pd=2.92u as=0.2128p ps=1.5u w=1.12u l=0.13u
X11 VDD.t136 VSS.t252 VDD.t313 VDD.t20 sg13_lv_pmos ad=0.34p pd=2.68u as=0 ps=0 w=1u l=1u
X12 VSS.t739 VDD.t1651 VSS.t739 VSS.t740 sg13_lv_nmos ad=0.1428p pd=1.52u as=0 ps=0 w=0.42u l=1u
X13 a_8808_3889# a_8237_4687# VDD.t1109 VDD.t9 sg13_lv_pmos ad=0.2128p pd=1.5u as=0.3808p ps=2.92u w=1.12u l=0.13u
X14 a_25153_4687# a_24957_4687# VSS.t220 VSS.t1192 sg13_lv_nmos ad=0.2516p pd=2.16u as=0.1406p ps=1.12u w=0.74u l=0.13u
X15 VDD.t352 a_15108_11799# a_15053_11680# VDD.t351 sg13_lv_pmos ad=1.10612p pd=6.66u as=93.45f ps=0.865u w=0.42u l=0.13u
X16 VSS.t1638 a_12037_4687# a_12505_3889# VSS.t1637 sg13_lv_nmos ad=0.1665p pd=1.19u as=0.2516p ps=2.16u w=0.74u l=0.13u
X17 a_23871_16869# a_23633_16869# a_23763_16869# VSS.t1266 sg13_lv_nmos ad=0.1406p pd=1.12u as=0.2516p ps=2.16u w=0.74u l=0.2u
X18 CHAN0_DELAY_OUT_LAST a_27997_16869# VSS.t1408 VSS.t1407 sg13_lv_nmos ad=0.2516p pd=2.16u as=0.1406p ps=1.12u w=0.74u l=0.13u
X19 VSS.t262 a_15077_1842# a_15545_1044# VSS.t1502 sg13_lv_nmos ad=0.1665p pd=1.19u as=0.2516p ps=2.16u w=0.74u l=0.13u
X20 a_15108_11015# a_12849_11557# VDD.t352 VDD.t351 sg13_lv_pmos ad=79.8f pd=0.8u as=1.03698p ps=6.245u w=0.42u l=0.13u
X21 a_3449_13577# CHAN1_MUX_SEL0 VDD.t557 VDD.t36 sg13_lv_pmos ad=0.1596p pd=1.22u as=0.2856p ps=2.36u w=0.84u l=0.13u
X22 VDD.t106 VSS.t396 VDD.t105 VDD.t29 sg13_lv_pmos ad=0.34p pd=2.68u as=0 ps=0 w=1u l=1u
X23 VDD.t171 VSS.t709 VDD.t169 VDD.t29 sg13_lv_pmos ad=0.19p pd=1.38u as=0 ps=0 w=1u l=1u
X24 VDD.t391 a_16851_5999# REF_MUX_OUT VDD.t29 sg13_lv_pmos ad=0.7336p pd=3.55u as=0.2128p ps=1.5u w=1.12u l=0.13u
X25 VSS.t1144 a_4187_1764.t136 a_24631_16869# VSS.t1143 sg13_lv_nmos ad=0.2516p pd=2.16u as=0.1406p ps=1.12u w=0.74u l=0.6u
X26 a_7390_6734# a_8231_6698# a_8155_6734# VDD.t29 sg13_lv_pmos ad=0.3808p pd=2.92u as=0.2128p ps=1.5u w=1.12u l=0.13u
X27 a_27915_1044# a_27705_1044# VDD.t747 VDD.t0 sg13_lv_pmos ad=0.2128p pd=1.5u as=0.252p ps=1.57u w=1.12u l=0.13u
X28 a_10430_6734# a_2019_6737.t7 a_10328_6734# VSS.t1077 sg13_lv_nmos ad=0.2516p pd=2.16u as=0.1406p ps=1.12u w=0.74u l=0.13u
X29 VDD.t531 a_3747_16074.t6 a_15831_16035# VDD.t20 sg13_lv_pmos ad=0.3808p pd=2.92u as=0.3808p ps=2.92u w=1.12u l=0.13u
X30 a_25630_13226# a_3171_13229.t2 a_27048_13226# VSS.t1891 sg13_lv_nmos ad=0.2516p pd=2.16u as=0.1406p ps=1.12u w=0.74u l=0.13u
X31 VDD.t221 VSS.t652 VDD.t220 VDD.t36 sg13_lv_pmos ad=0.34p pd=2.68u as=0 ps=0 w=1u l=1u
X32 VSS.t1918 a_1721_16422# a_2019_16074.t1 VSS.t1919 sg13_lv_nmos ad=0.2812p pd=2.24u as=0.1406p ps=1.12u w=0.74u l=0.13u
X33 a_2873_16422# CHAN0_MUX_SEL1 VDD.t503 VDD.t20 sg13_lv_pmos ad=0.1596p pd=1.22u as=0.2856p ps=2.36u w=0.84u l=0.13u
X34 a_22351_5315# a_22113_4687# a_22243_4687# VDD.t339 sg13_lv_pmos ad=0.2128p pd=1.5u as=0.3808p ps=2.92u w=1.12u l=0.2u
X35 a_1544_16071# CHAN0_MUX_SEL1 VDD.t504 VDD.t20 sg13_lv_pmos ad=0.3808p pd=2.92u as=0.3808p ps=2.92u w=1.12u l=0.13u
X36 VDD.t562 a_13883_7532# a_14317_7532# VDD.t341 sg13_lv_pmos ad=0.2128p pd=1.5u as=0.3808p ps=2.92u w=1.12u l=0.13u
X37 VSS.t45 a_11748_11799# a_11397_11918# VSS.t1172 sg13_lv_nmos ad=79.8f pd=0.8u as=0.1428p ps=1.52u w=0.42u l=0.13u
X38 VDD.t1241 a_16923_4687# a_17357_4687# VDD.t339 sg13_lv_pmos ad=0.2128p pd=1.5u as=0.3808p ps=2.92u w=1.12u l=0.13u
X39 VSS.t696 VDD.t1668 VSS.t696 VSS.t700 sg13_lv_nmos ad=79.8f pd=0.8u as=0 ps=0 w=0.42u l=1u
X40 a_13818_11982# a_12849_11557# VSS.t872 VSS.t1184 sg13_lv_nmos ad=37.8f pd=0.6u as=0.1701p ps=1.65u w=0.42u l=0.13u
X41 a_7390_6734# a_3171_6737.t8 a_8808_6734# VSS.t2110 sg13_lv_nmos ad=0.2516p pd=2.16u as=0.1406p ps=1.12u w=0.74u l=0.13u
X42 VSS.t779 VDD.t1636 VSS.t781 VSS.t780 sg13_lv_nmos ad=79.8f pd=0.8u as=0 ps=0 w=0.42u l=1u
X43 a_8433_16869# a_8237_16869# VSS.t1209 VSS.t1388 sg13_lv_nmos ad=0.2516p pd=2.16u as=0.1406p ps=1.12u w=0.74u l=0.13u
X44 VSS.t1072 a_2019_16074.t2 a_25604_16035# VSS.t1071 sg13_lv_nmos ad=0.2516p pd=2.16u as=0.2516p ps=2.16u w=0.74u l=0.13u
X45 a_22873_7532# a_22677_7532# VSS.t1251 VSS.t1250 sg13_lv_nmos ad=0.2516p pd=2.16u as=0.1406p ps=1.12u w=0.74u l=0.13u
X46 VSS.t758 VDD.t1643 VSS.t760 VSS.t759 sg13_lv_nmos ad=79.8f pd=0.8u as=0 ps=0 w=0.42u l=1u
X47 a_5115_13226# a_4905_13226# VSS.t1928 VSS.t2081 sg13_lv_nmos ad=0.1406p pd=1.12u as=0.1665p ps=1.19u w=0.74u l=0.13u
X48 a_6326_10280# a_6326_10280# VDD.t442 VDD.t351 sg13_lv_pmos ad=0.38p pd=2.38u as=0.38p ps=2.38u w=2u l=1u
X49 a_13566_11018# a_14009_10774# a_13306_10795# VSS.t35 sg13_lv_nmos ad=79.8f pd=0.8u as=0.1296p ps=1.52u w=0.42u l=0.13u
X50 VDD.t1221 a_27237_4687# a_27705_3889# VDD.t9 sg13_lv_pmos ad=0.252p pd=1.57u as=0.3808p ps=2.92u w=1.12u l=0.13u
X51 VSS.t702 VDD.t1667 VSS.t702 VSS.t703 sg13_lv_nmos ad=79.8f pd=0.8u as=0 ps=0 w=0.42u l=1u
X52 VSS.t339 a_3171_1047.t7 a_11924_1008# VSS.t338 sg13_lv_nmos ad=0.2516p pd=2.16u as=0.2516p ps=2.16u w=0.74u l=0.13u
X53 a_10951_2470# a_10713_1842# a_10843_1842# VDD.t353 sg13_lv_pmos ad=0.2128p pd=1.5u as=0.3808p ps=2.92u w=1.12u l=0.2u
X54 VSS.t93 a_1544_3134# a_2391_3176# VSS.t1801 sg13_lv_nmos ad=0.1331p pd=1.12u as=0.1216p ps=1.02u w=0.64u l=0.13u
X55 VDD.t435 a_12037_7532# a_12505_6734# VDD.t29 sg13_lv_pmos ad=0.252p pd=1.57u as=0.3808p ps=2.92u w=1.12u l=0.13u
X56 VDD.t17 VSS.t825 VDD.t16 VDD.t0 sg13_lv_pmos ad=0.34p pd=2.68u as=0 ps=0 w=1u l=1u
X57 a_1721_15358# a_1256_15316# VDD.t1596 VDD.t20 sg13_lv_pmos ad=0.1596p pd=1.22u as=0.2856p ps=2.36u w=0.84u l=0.13u
X58 a_6326_10280# a_6126_9506# a_5778_9057# VSS.t956 sg13_lv_nmos ad=0.38p pd=2.38u as=0.68p ps=4.68u w=2u l=1u
X59 VSS.t1758 a_4187_1764.t148 a_15511_16869# VSS.t2069 sg13_lv_nmos ad=0.2516p pd=2.16u as=0.1406p ps=1.12u w=0.74u l=0.6u
X60 a_25913_14024# a_25717_14024# VSS.t570 VSS.t1067 sg13_lv_nmos ad=0.2516p pd=2.16u as=0.1406p ps=1.12u w=0.74u l=0.13u
X61 VDD.t422 a_4003_7532# a_4437_7532# VDD.t341 sg13_lv_pmos ad=0.2128p pd=1.5u as=0.3808p ps=2.92u w=1.12u l=0.13u
X62 a_10191_16869# a_9953_16869# a_10083_16869# VSS.t1392 sg13_lv_nmos ad=0.1406p pd=1.12u as=0.2516p ps=2.16u w=0.74u l=0.2u
X63 VDD.t199 VSS.t628 VDD.t197 VDD.t20 sg13_lv_pmos ad=0.19p pd=1.38u as=0 ps=0 w=1u l=1u
X64 VSS.t783 VDD.t1635 VSS.t783 VSS.t782 sg13_lv_nmos ad=0.1428p pd=1.52u as=0 ps=0 w=0.42u l=1u
X65 VDD.t892 a_4187_2434# a_10951_5315# VDD.t339 sg13_lv_pmos ad=0.3808p pd=2.92u as=0.2128p ps=1.5u w=1.12u l=0.6u
X66 VDD.t1429 a_15077_14024# a_15545_13226# VDD.t36 sg13_lv_pmos ad=0.252p pd=1.57u as=0.3808p ps=2.92u w=1.12u l=0.13u
X67 VSS.t1166 a_1256_1044# a_2967_1395# VSS.t1012 sg13_lv_nmos ad=0.1331p pd=1.12u as=0.1216p ps=1.02u w=0.64u l=0.13u
X68 VSS.t59 a_4187_1764.t154 a_10951_16869# VSS.t140 sg13_lv_nmos ad=0.2516p pd=2.16u as=0.1406p ps=1.12u w=0.74u l=0.6u
X69 a_21353_14024# a_21157_14024# VSS.t448 VSS.t1430 sg13_lv_nmos ad=0.2516p pd=2.16u as=0.1406p ps=1.12u w=0.74u l=0.13u
X70 a_9946_11995# a_9772_11533# VDD.t591 VDD.t351 sg13_lv_pmos ad=79.8f pd=0.8u as=0.1428p ps=1.52u w=0.42u l=0.13u
X71 a_5731_3134# a_3747_3156.t3 a_13470_3889# VSS.t973 sg13_lv_nmos ad=0.2516p pd=2.16u as=0.2516p ps=2.16u w=0.74u l=0.13u
X72 a_16033_16869# a_15837_16869# VDD.t1223 VDD.t365 sg13_lv_pmos ad=0.3808p pd=2.92u as=0.2128p ps=1.5u w=1.12u l=0.13u
X73 VDD.t58 VSS.t798 VDD.t57 VDD.t0 sg13_lv_pmos ad=0.34p pd=2.68u as=0 ps=0 w=1u l=1u
X74 VSS.t510 a_14643_14024# a_15077_14024# VSS.t509 sg13_lv_nmos ad=0.1406p pd=1.12u as=0.2516p ps=2.16u w=0.74u l=0.13u
X75 a_25153_1842# a_24957_1842# VSS.t483 VSS.t2339 sg13_lv_nmos ad=0.2516p pd=2.16u as=0.1406p ps=1.12u w=0.74u l=0.13u
X76 a_10328_3889# a_9757_4687# VSS.t1627 VSS.t1626 sg13_lv_nmos ad=0.1406p pd=1.12u as=0.2516p ps=2.16u w=0.74u l=0.13u
X77 VDD.t364 a_20723_4687# a_21157_4687# VDD.t339 sg13_lv_pmos ad=0.2128p pd=1.5u as=0.3808p ps=2.92u w=1.12u l=0.13u
X78 VDD.t1382 a_3171_13229.t3 a_24084_13190# VDD.t36 sg13_lv_pmos ad=0.3808p pd=2.92u as=0.3808p ps=2.92u w=1.12u l=0.13u
X79 a_17791_4687# a_17553_4687# a_17683_4687# VSS.t1802 sg13_lv_nmos ad=0.1406p pd=1.12u as=0.2516p ps=2.16u w=0.74u l=0.2u
X80 VSS.t270 a_15077_7532# a_15545_6734# VSS.t269 sg13_lv_nmos ad=0.1665p pd=1.19u as=0.2516p ps=2.16u w=0.74u l=0.13u
X81 a_22590_3889# a_2019_3892.t3 a_22488_3889# VSS.t1998 sg13_lv_nmos ad=0.2516p pd=2.16u as=0.1406p ps=1.12u w=0.74u l=0.13u
X82 VDD.t264 VSS.t760 VDD.t263 VDD.t9 sg13_lv_pmos ad=0.34p pd=2.68u as=0 ps=0 w=1u l=1u
X83 a_25630_1044# a_2019_1047.t2 a_25528_1044# VSS.t1875 sg13_lv_nmos ad=0.2516p pd=2.16u as=0.1406p ps=1.12u w=0.74u l=0.13u
X84 VDD.t134 VSS.t100 VDD.t132 VDD.t9 sg13_lv_pmos ad=0.19p pd=1.38u as=0 ps=0 w=1u l=1u
X85 VSS.t865 a_9444_10280# a_9444_9602# VSS.t864 sg13_lv_nmos ad=0.68p pd=4.68u as=0.38p ps=2.38u w=2u l=1u
X86 VDD.t911 a_4187_2434# a_19311_2470# VDD.t353 sg13_lv_pmos ad=0.3808p pd=2.92u as=0.2128p ps=1.5u w=1.12u l=0.6u
X87 a_8808_3889# a_8237_4687# VSS.t1483 VSS.t1511 sg13_lv_nmos ad=0.1406p pd=1.12u as=0.2516p ps=2.16u w=0.74u l=0.13u
X88 VSS.t725 a_3747_6001.t2 a_26985_6209# VSS.t1434 sg13_lv_nmos ad=0.2516p pd=2.16u as=0.2516p ps=2.16u w=0.74u l=0.13u
X89 VSS.t149 a_2019_13229.t6 a_13444_13190# VSS.t148 sg13_lv_nmos ad=0.2516p pd=2.16u as=0.2516p ps=2.16u w=0.74u l=0.13u
X90 VDD.t142 VSS.t674 VDD.t140 VDD.t36 sg13_lv_pmos ad=0.19p pd=1.38u as=0 ps=0 w=1u l=1u
X91 VSS.t1042 a_13123_16869# a_13557_16869# VSS.t1620 sg13_lv_nmos ad=0.1406p pd=1.12u as=0.2516p ps=2.16u w=0.74u l=0.13u
X92 VDD.t789 a_4187_2434# a_23871_5315# VDD.t339 sg13_lv_pmos ad=0.3808p pd=2.92u as=0.2128p ps=1.5u w=1.12u l=0.6u
X93 VSS.t2188 a_3171_16074.t7 a_11924_16035# VSS.t2187 sg13_lv_nmos ad=0.2516p pd=2.16u as=0.2516p ps=2.16u w=0.74u l=0.13u
X94 VDD.t1212 a_3747_13229.t5 a_18871_13190# VDD.t36 sg13_lv_pmos ad=0.3808p pd=2.92u as=0.3808p ps=2.92u w=1.12u l=0.13u
X95 VSS.t37 a_14009_10774# a_14111_10917# VSS.t36 sg13_lv_nmos ad=1.45407p pd=9.445u as=0.2516p ps=2.16u w=0.74u l=0.13u
X96 a_6635_3889# a_6425_3889# VDD.t1336 VDD.t9 sg13_lv_pmos ad=0.2128p pd=1.5u as=0.252p ps=1.57u w=1.12u l=0.13u
X97 VDD.t244 VSS.t696 VDD.t242 VDD.t29 sg13_lv_pmos ad=0.19p pd=1.38u as=0 ps=0 w=1u l=1u
X98 VDD.t494 a_4763_16869# a_5197_16869# VDD.t365 sg13_lv_pmos ad=0.2128p pd=1.5u as=0.3808p ps=2.92u w=1.12u l=0.13u
X99 a_16108_289# a_2019_311# a_16510_1044# VSS.t1245 sg13_lv_nmos ad=0.2516p pd=2.16u as=0.2516p ps=2.16u w=0.74u l=0.13u
X100 VSS.t687 a_2019_6001.t3 a_5705_6209# VSS.t1361 sg13_lv_nmos ad=0.2516p pd=2.16u as=0.2516p ps=2.16u w=0.74u l=0.13u
X101 VDD.t550 a_3747_12493.t2 a_26985_12701# VDD.t36 sg13_lv_pmos ad=0.3808p pd=2.92u as=0.3808p ps=2.92u w=1.12u l=0.13u
X102 VDD.t1125 a_2595_3892.t9 a_5191_3853# VDD.t9 sg13_lv_pmos ad=0.3808p pd=2.92u as=0.3808p ps=2.92u w=1.12u l=0.13u
X103 VSS.t872 a_13121_11521# a_13045_11905# VSS.t2161 sg13_lv_nmos ad=0.2516p pd=2.16u as=0.1406p ps=1.12u w=0.74u l=0.13u
X104 VDD.t915 a_4187_2434# a_9431_2470# VDD.t353 sg13_lv_pmos ad=0.3808p pd=2.92u as=0.2128p ps=1.5u w=1.12u l=0.6u
X105 a_21591_4687# a_21353_4687# a_21483_4687# VSS.t2171 sg13_lv_nmos ad=0.1406p pd=1.12u as=0.2516p ps=2.16u w=0.74u l=0.2u
X106 VDD.t491 a_2595_16074.t2 a_26471_16035# VDD.t20 sg13_lv_pmos ad=0.3808p pd=2.92u as=0.3808p ps=2.92u w=1.12u l=0.13u
X107 a_20315_3889# a_20105_3889# VDD.t1257 VDD.t9 sg13_lv_pmos ad=0.2128p pd=1.5u as=0.252p ps=1.57u w=1.12u l=0.13u
X108 a_6153_4687# a_5957_4687# VSS.t459 VSS.t2213 sg13_lv_nmos ad=0.2516p pd=2.16u as=0.1406p ps=1.12u w=0.74u l=0.13u
X109 VDD.t44 VSS.t702 VDD.t42 VDD.t29 sg13_lv_pmos ad=0.19p pd=1.38u as=0 ps=0 w=1u l=1u
X110 VSS.t687 VDD.t1672 VSS.t687 VSS.t690 sg13_lv_nmos ad=79.8f pd=0.8u as=0 ps=0 w=0.42u l=1u
X111 VSS.t424 VDD.t1622 VSS.t832 VSS.t831 sg13_lv_nmos ad=0.1428p pd=1.52u as=0 ps=0 w=0.42u l=1u
X112 a_25528_3889# a_24957_4687# VDD.t932 VDD.t9 sg13_lv_pmos ad=0.2128p pd=1.5u as=0.3808p ps=2.92u w=1.12u l=0.13u
X113 a_26911_14024# a_26673_14024# a_26803_14024# VSS.t1887 sg13_lv_nmos ad=0.1406p pd=1.12u as=0.2516p ps=2.16u w=0.74u l=0.2u
X114 a_15108_11799# a_14851_11918# a_15270_11995# VSS.t266 sg13_lv_nmos ad=0.1428p pd=1.52u as=37.8f ps=0.6u w=0.42u l=0.13u
X115 VSS.t491 a_16163_4687# a_16597_4687# VSS.t1176 sg13_lv_nmos ad=0.1406p pd=1.12u as=0.2516p ps=2.16u w=0.74u l=0.13u
X116 a_13231_5315# a_12993_4687# a_13123_4687# VDD.t339 sg13_lv_pmos ad=0.2128p pd=1.5u as=0.3808p ps=2.92u w=1.12u l=0.2u
X117 VDD.t1381 a_3171_13229.t6 a_14964_13190# VDD.t36 sg13_lv_pmos ad=0.3808p pd=2.92u as=0.3808p ps=2.92u w=1.12u l=0.13u
X118 CHAN1_MUX_OUT a_16851_12491# VSS.t196 VSS.t1611 sg13_lv_nmos ad=0.1406p pd=1.12u as=0.1371p ps=1.12u w=0.74u l=0.13u
X119 a_10951_8160# a_10713_7532# a_10843_7532# VDD.t341 sg13_lv_pmos ad=0.2128p pd=1.5u as=0.3808p ps=2.92u w=1.12u l=0.2u
X120 VSS.t185 a_3171_6737.t7 a_11924_6698# VSS.t2113 sg13_lv_nmos ad=0.2516p pd=2.16u as=0.2516p ps=2.16u w=0.74u l=0.13u
X121 a_10328_6734# a_9757_7532# VDD.t728 VDD.t29 sg13_lv_pmos ad=0.2128p pd=1.5u as=0.3808p ps=2.92u w=1.12u l=0.13u
X122 a_3449_6021# REF_MUX_SEL2 VDD.t417 VDD.t29 sg13_lv_pmos ad=0.1596p pd=1.22u as=0.2856p ps=2.36u w=0.84u l=0.13u
X123 VDD.t925 a_4187_2434# a_23111_2470# VDD.t353 sg13_lv_pmos ad=0.3808p pd=2.92u as=0.2128p ps=1.5u w=1.12u l=0.6u
X124 VSS.t1040 a_4187_1764.t100 a_27671_14024# VSS.t1039 sg13_lv_nmos ad=0.2516p pd=2.16u as=0.1406p ps=1.12u w=0.74u l=0.6u
X125 a_22351_14024# a_22113_14024# a_22243_14024# VSS.t2231 sg13_lv_nmos ad=0.1406p pd=1.12u as=0.2516p ps=2.16u w=0.74u l=0.2u
X126 VSS.t273 a_3747_15338.t3 a_14825_15546# VSS.t272 sg13_lv_nmos ad=0.2516p pd=2.16u as=0.2516p ps=2.16u w=0.74u l=0.13u
X127 a_1721_12513# a_1256_12471# VDD.t1510 VDD.t36 sg13_lv_pmos ad=0.1596p pd=1.22u as=0.2856p ps=2.36u w=0.84u l=0.13u
X128 VDD.t726 a_2019_16074.t3 a_22564_16035# VDD.t20 sg13_lv_pmos ad=0.3808p pd=2.92u as=0.3808p ps=2.92u w=1.12u l=0.13u
X129 a_22590_6734# a_22564_6698# a_22488_6734# VDD.t29 sg13_lv_pmos ad=0.3808p pd=2.92u as=0.2128p ps=1.5u w=1.12u l=0.13u
X130 a_7390_1044# a_8231_1008# a_8155_1044# VDD.t0 sg13_lv_pmos ad=0.3808p pd=2.92u as=0.2128p ps=1.5u w=1.12u l=0.13u
X131 VSS.t134 a_1256_6734# a_2967_7085# VSS.t133 sg13_lv_nmos ad=0.1331p pd=1.12u as=0.1216p ps=1.02u w=0.64u l=0.13u
X132 VSS.t766 VDD.t1639 VSS.t769 VSS.t768 sg13_lv_nmos ad=0.1428p pd=1.52u as=0 ps=0 w=0.42u l=1u
X133 a_10713_16869# a_10517_16869# VSS.t142 VSS.t1189 sg13_lv_nmos ad=0.2516p pd=2.16u as=0.1406p ps=1.12u w=0.74u l=0.13u
X134 VSS.t20 a_4187_1764.t57 a_10191_4687# VSS.t137 sg13_lv_nmos ad=0.2516p pd=2.16u as=0.1406p ps=1.12u w=0.74u l=0.6u
X135 a_12233_4687# a_12037_4687# VDD.t564 VDD.t339 sg13_lv_pmos ad=0.3808p pd=2.92u as=0.2128p ps=1.5u w=1.12u l=0.13u
X136 a_7390_16071# a_7364_16035# a_7288_16071# VDD.t20 sg13_lv_pmos ad=0.3808p pd=2.92u as=0.2128p ps=1.5u w=1.12u l=0.13u
X137 a_16108_15316# CHAN0_MUX_SEL4 a_15964_15316# VSS.t2207 sg13_lv_nmos ad=0.2516p pd=2.16u as=0.2183p ps=1.33u w=0.74u l=0.13u
X138 a_16033_14024# a_15837_14024# VDD.t1100 VDD.t381 sg13_lv_pmos ad=0.3808p pd=2.92u as=0.2128p ps=1.5u w=1.12u l=0.13u
X139 a_8808_6734# a_8237_7532# VDD.t1565 VDD.t29 sg13_lv_pmos ad=0.2128p pd=1.5u as=0.3808p ps=2.92u w=1.12u l=0.13u
X140 VSS.t418 a_2595_311.t3 a_8745_519# VSS.t417 sg13_lv_nmos ad=0.2516p pd=2.16u as=0.2516p ps=2.16u w=0.74u l=0.13u
X141 VSS.t1754 a_27237_4687# a_27705_3889# VSS.t1753 sg13_lv_nmos ad=0.1665p pd=1.19u as=0.2516p ps=2.16u w=0.74u l=0.13u
X142 a_25153_7532# a_24957_7532# VSS.t163 VSS.t844 sg13_lv_nmos ad=0.2516p pd=2.16u as=0.1406p ps=1.12u w=0.74u l=0.13u
X143 a_2297_15358# CHAN0_MUX_SEL2 VDD.t1163 VDD.t20 sg13_lv_pmos ad=0.1596p pd=1.22u as=0.2856p ps=2.36u w=0.84u l=0.13u
X144 a_17791_1842# a_17553_1842# a_17683_1842# VSS.t2185 sg13_lv_nmos ad=0.1406p pd=1.12u as=0.2516p ps=2.16u w=0.74u l=0.2u
X145 VDD.t1433 a_2019_12493.t2 a_17865_12701# VDD.t36 sg13_lv_pmos ad=0.3808p pd=2.92u as=0.3808p ps=2.92u w=1.12u l=0.13u
X146 a_14851_11918# a_14009_11568# a_13592_11561# VDD.t351 sg13_lv_pmos ad=0.2048p pd=1.63u as=0.34p ps=2.68u w=1u l=0.13u
X147 a_25153_16869# a_24957_16869# VSS.t1144 VSS.t2310 sg13_lv_nmos ad=0.2516p pd=2.16u as=0.1406p ps=1.12u w=0.74u l=0.13u
X148 VSS.t1523 a_19963_4687# a_20397_4687# VSS.t1522 sg13_lv_nmos ad=0.1406p pd=1.12u as=0.2516p ps=2.16u w=0.74u l=0.13u
X149 VDD.t446 a_6326_10280# a_6126_9506# VDD.t351 sg13_lv_pmos ad=0.38p pd=2.38u as=0.38p ps=2.38u w=2u l=1u
X150 VDD.t1251 a_1721_12513# a_2019_12493.t0 VDD.t36 sg13_lv_pmos ad=0.4256p pd=3u as=0.2128p ps=1.5u w=1.12u l=0.13u
X151 a_12656_11554# DLL_RESETN VDD.t358 VDD.t351 sg13_lv_pmos ad=0.3808p pd=2.92u as=0.3808p ps=2.92u w=1.12u l=0.13u
X152 a_25630_6734# a_2019_6737.t2 a_25528_6734# VSS.t2241 sg13_lv_nmos ad=0.2516p pd=2.16u as=0.1406p ps=1.12u w=0.74u l=0.13u
X153 VDD.t1286 a_2595_16074.t5 a_17351_16035# VDD.t20 sg13_lv_pmos ad=0.3808p pd=2.92u as=0.3808p ps=2.92u w=1.12u l=0.13u
X154 VDD.t871 a_4187_2434# a_19311_8160# VDD.t341 sg13_lv_pmos ad=0.3808p pd=2.92u as=0.2128p ps=1.5u w=1.12u l=0.6u
X155 a_25630_16071# a_3171_16074.t2 a_27048_16071# VSS.t2255 sg13_lv_nmos ad=0.2516p pd=2.16u as=0.1406p ps=1.12u w=0.74u l=0.13u
X156 VDD.t348 a_3747_16074.t7 a_12791_16035# VDD.t20 sg13_lv_pmos ad=0.3808p pd=2.92u as=0.3808p ps=2.92u w=1.12u l=0.13u
X157 a_2595_13229.t1 a_2297_13577# VSS.t2024 VSS.t2023 sg13_lv_nmos ad=0.1406p pd=1.12u as=0.1331p ps=1.12u w=0.74u l=0.13u
X158 VDD.t1187 a_12037_1842# a_12505_1044# VDD.t0 sg13_lv_pmos ad=0.252p pd=1.57u as=0.3808p ps=2.92u w=1.12u l=0.13u
X159 a_13231_14024# a_12993_14024# a_13123_14024# VSS.t2317 sg13_lv_nmos ad=0.1406p pd=1.12u as=0.2516p ps=2.16u w=0.74u l=0.2u
X160 VDD.t181 VSS.t739 VDD.t179 VDD.t9 sg13_lv_pmos ad=0.19p pd=1.38u as=0 ps=0 w=1u l=1u
X161 a_16510_1044# a_2019_1047.t5 a_16408_1044# VSS.t347 sg13_lv_nmos ad=0.2516p pd=2.16u as=0.1406p ps=1.12u w=0.74u l=0.13u
X162 VSS.t725 VDD.t1656 VSS.t725 VSS.t728 sg13_lv_nmos ad=79.8f pd=0.8u as=0 ps=0 w=0.42u l=1u
X163 VDD.t1152 a_4763_14024# a_5197_14024# VDD.t381 sg13_lv_pmos ad=0.2128p pd=1.5u as=0.3808p ps=2.92u w=1.12u l=0.13u
X164 VDD.t251 VSS.t687 VDD.t249 VDD.t29 sg13_lv_pmos ad=0.19p pd=1.38u as=0 ps=0 w=1u l=1u
X165 VSS.t1279 a_4187_1764.t118 a_13991_14024# VSS.t2049 sg13_lv_nmos ad=0.2516p pd=2.16u as=0.1406p ps=1.12u w=0.74u l=0.6u
X166 a_9953_16869# a_9757_16869# VSS.t1394 VSS.t2224 sg13_lv_nmos ad=0.2516p pd=2.16u as=0.1406p ps=1.12u w=0.74u l=0.13u
X167 VSS.t665 VDD.t1681 VSS.t665 VSS.t667 sg13_lv_nmos ad=0.1428p pd=1.52u as=0 ps=0 w=0.42u l=1u
X168 VDD.t875 a_4187_2434# a_9431_8160# VDD.t341 sg13_lv_pmos ad=0.3808p pd=2.92u as=0.2128p ps=1.5u w=1.12u l=0.6u
X169 a_21591_1842# a_21353_1842# a_21483_1842# VSS.t2041 sg13_lv_nmos ad=0.1406p pd=1.12u as=0.2516p ps=2.16u w=0.74u l=0.2u
X170 a_2873_3176# CHAN2_MUX_SEL3 VDD.t1148 VDD.t9 sg13_lv_pmos ad=0.1596p pd=1.22u as=0.2856p ps=2.36u w=0.84u l=0.13u
X171 VSS.t709 a_2019_6001.t2 a_17865_6209# VSS.t1845 sg13_lv_nmos ad=0.2516p pd=2.16u as=0.2516p ps=2.16u w=0.74u l=0.13u
X172 a_6153_1842# a_5957_1842# VSS.t368 VSS.t2181 sg13_lv_nmos ad=0.2516p pd=2.16u as=0.1406p ps=1.12u w=0.74u l=0.13u
X173 VDD.t295 VSS.t745 VDD.t293 VDD.t9 sg13_lv_pmos ad=0.19p pd=1.38u as=0 ps=0 w=1u l=1u
X174 a_5115_16071# a_4905_16071# VSS.t1260 VSS.t1963 sg13_lv_nmos ad=0.1406p pd=1.12u as=0.1665p ps=1.19u w=0.74u l=0.13u
X175 VSS.t1710 a_3171_1047.t2 a_27124_1008# VSS.t1709 sg13_lv_nmos ad=0.2516p pd=2.16u as=0.2516p ps=2.16u w=0.74u l=0.13u
X176 VSS.t1105 a_16163_1842# a_16597_1842# VSS.t1225 sg13_lv_nmos ad=0.1406p pd=1.12u as=0.2516p ps=2.16u w=0.74u l=0.13u
X177 VDD.t1107 a_2595_6001.t2 a_20905_6209# VDD.t29 sg13_lv_pmos ad=0.3808p pd=2.92u as=0.3808p ps=2.92u w=1.12u l=0.13u
X178 VDD.t1159 a_27237_7532# a_27705_6734# VDD.t29 sg13_lv_pmos ad=0.252p pd=1.57u as=0.3808p ps=2.92u w=1.12u l=0.13u
X179 VDD.t886 a_4187_2434# a_23111_8160# VDD.t341 sg13_lv_pmos ad=0.3808p pd=2.92u as=0.2128p ps=1.5u w=1.12u l=0.6u
X180 VDD.t1186 a_11603_1842# a_12037_1842# VDD.t353 sg13_lv_pmos ad=0.2128p pd=1.5u as=0.3808p ps=2.92u w=1.12u l=0.13u
X181 a_6635_3889# a_6425_3889# VSS.t1947 VSS.t1946 sg13_lv_nmos ad=0.1406p pd=1.12u as=0.1665p ps=1.19u w=0.74u l=0.13u
X182 VSS.t191 a_1544_5979# a_2391_6021# VSS.t1134 sg13_lv_nmos ad=0.1331p pd=1.12u as=0.1216p ps=1.02u w=0.64u l=0.13u
X183 a_11711_16869# a_11473_16869# a_11603_16869# VSS.t1843 sg13_lv_nmos ad=0.1406p pd=1.12u as=0.2516p ps=2.16u w=0.74u l=0.2u
X184 VDD.t1126 a_3171_311.t3 a_11785_519# VDD.t0 sg13_lv_pmos ad=0.3808p pd=2.92u as=0.3808p ps=2.92u w=1.12u l=0.13u
X185 VDD.t902 a_4187_2434# a_26151_5315# VDD.t339 sg13_lv_pmos ad=0.3808p pd=2.92u as=0.2128p ps=1.5u w=1.12u l=0.6u
X186 a_5731_289# a_2595_311.t3 a_7390_1044# VSS.t416 sg13_lv_nmos ad=0.2516p pd=2.16u as=0.2516p ps=2.16u w=0.74u l=0.13u
X187 a_10430_1044# a_2595_1047.t7 a_11195_1044# VSS.t1704 sg13_lv_nmos ad=0.2516p pd=2.16u as=0.1406p ps=1.12u w=0.74u l=0.13u
X188 VSS.t1542 a_2595_3892.t9 a_5191_3853# VSS.t1541 sg13_lv_nmos ad=0.2516p pd=2.16u as=0.2516p ps=2.16u w=0.74u l=0.13u
X189 a_6854_11676# a_6326_10280# VDD.t441 VDD.t351 sg13_lv_pmos ad=0.38p pd=2.38u as=0.38p ps=2.38u w=2u l=1u
X190 a_15464_9374# a_14851_10872# VSS.t1186 VSS.t1807 sg13_lv_nmos ad=0.2849p pd=2.25u as=0.2516p ps=2.16u w=0.74u l=0.13u
X191 a_24393_1842# a_24197_1842# VDD.t1423 VDD.t353 sg13_lv_pmos ad=0.3808p pd=2.92u as=0.2128p ps=1.5u w=1.12u l=0.13u
X192 VSS.t980 a_4187_1764.t152 a_12471_16869# VSS.t2360 sg13_lv_nmos ad=0.2516p pd=2.16u as=0.1406p ps=1.12u w=0.74u l=0.6u
X193 a_22873_14024# a_22677_14024# VSS.t283 VSS.t530 sg13_lv_nmos ad=0.2516p pd=2.16u as=0.1406p ps=1.12u w=0.74u l=0.13u
X194 a_16408_3889# a_15837_4687# VDD.t1467 VDD.t9 sg13_lv_pmos ad=0.2128p pd=1.5u as=0.3808p ps=2.92u w=1.12u l=0.13u
X195 a_20315_3889# a_20105_3889# VSS.t1805 VSS.t2034 sg13_lv_nmos ad=0.1406p pd=1.12u as=0.1665p ps=1.19u w=0.74u l=0.13u
X196 a_17553_16869# a_17357_16869# VDD.t1469 VDD.t365 sg13_lv_pmos ad=0.3808p pd=2.92u as=0.2128p ps=1.5u w=1.12u l=0.13u
X197 VDD.t205 VSS.t616 VDD.t203 VDD.t20 sg13_lv_pmos ad=0.19p pd=1.38u as=0 ps=0 w=1u l=1u
X198 a_27048_16071# a_26477_16869# VDD.t1581 VDD.t20 sg13_lv_pmos ad=0.2128p pd=1.5u as=0.3808p ps=2.92u w=1.12u l=0.13u
X199 VSS.t1422 a_16163_14024# a_16597_14024# VSS.t1421 sg13_lv_nmos ad=0.1406p pd=1.12u as=0.2516p ps=2.16u w=0.74u l=0.13u
X200 a_23355_1044# a_23145_1044# VSS.t1029 VSS.t1028 sg13_lv_nmos ad=0.1406p pd=1.12u as=0.1665p ps=1.19u w=0.74u l=0.13u
X201 a_25528_3889# a_24957_4687# VSS.t79 VSS.t1193 sg13_lv_nmos ad=0.1406p pd=1.12u as=0.2516p ps=2.16u w=0.74u l=0.13u
X202 VSS.t1923 a_1256_3889# a_2967_4240# VSS.t1995 sg13_lv_nmos ad=0.1331p pd=1.12u as=0.1216p ps=1.02u w=0.64u l=0.13u
X203 VDD.t1376 a_2019_13229.t2 a_25604_13190# VDD.t36 sg13_lv_pmos ad=0.3808p pd=2.92u as=0.3808p ps=2.92u w=1.12u l=0.13u
X204 VDD.t850 a_4187_2434# a_4871_5315# VDD.t339 sg13_lv_pmos ad=0.3808p pd=2.92u as=0.2128p ps=1.5u w=1.12u l=0.6u
X205 VDD.t820 a_4187_2434# a_4111_17497# VDD.t365 sg13_lv_pmos ad=0.3808p pd=2.92u as=0.2128p ps=1.5u w=1.12u l=0.6u
X206 a_26151_16869# a_25913_16869# a_26043_16869# VSS.t2315 sg13_lv_nmos ad=0.1406p pd=1.12u as=0.2516p ps=2.16u w=0.74u l=0.2u
X207 VSS.t1331 a_4187_1764.t25 a_10191_1842# VSS.t1330 sg13_lv_nmos ad=0.2516p pd=2.16u as=0.1406p ps=1.12u w=0.74u l=0.6u
X208 VSS.t702 VDD.t1665 VSS.t702 VSS.t706 sg13_lv_nmos ad=0.1428p pd=1.52u as=0 ps=0 w=0.42u l=1u
X209 VSS.t462 VDD.t1674 VSS.t462 VSS.t685 sg13_lv_nmos ad=79.8f pd=0.8u as=0 ps=0 w=0.42u l=1u
X210 VDD.t436 REF_MUX_SEL1 a_3449_7085# VDD.t29 sg13_lv_pmos ad=0.1918p pd=1.5u as=0.1596p ps=1.22u w=0.84u l=0.13u
X211 VSS.t366 a_3747_1047.t4 a_21911_1008# VSS.t1001 sg13_lv_nmos ad=0.2516p pd=2.16u as=0.2516p ps=2.16u w=0.74u l=0.13u
X212 VSS.t1066 a_11603_14024# a_12037_14024# VSS.t1414 sg13_lv_nmos ad=0.1406p pd=1.12u as=0.2516p ps=2.16u w=0.74u l=0.13u
X213 a_9772_11533# a_9746_11495# VDD.t352 VDD.t351 sg13_lv_pmos ad=0.3927p pd=2.99u as=1.10612p ps=6.66u w=1.155u l=0.13u
X214 a_17791_7532# a_17553_7532# a_17683_7532# VSS.t1828 sg13_lv_nmos ad=0.1406p pd=1.12u as=0.2516p ps=2.16u w=0.74u l=0.2u
X215 VDD.t769 a_4187_2434# a_14751_2470# VDD.t353 sg13_lv_pmos ad=0.3808p pd=2.92u as=0.2128p ps=1.5u w=1.12u l=0.6u
X216 a_2297_12513# CHAN1_MUX_SEL2 VDD.t403 VDD.t36 sg13_lv_pmos ad=0.1596p pd=1.22u as=0.2856p ps=2.36u w=0.84u l=0.13u
X217 a_10232_11561# a_10206_11525# VDD.t356 VDD.t351 sg13_lv_pmos ad=0.34p pd=2.68u as=0.36237p ps=2.605u w=1u l=0.13u
X218 a_11473_4687# a_11277_4687# VSS.t291 VSS.t1027 sg13_lv_nmos ad=0.2516p pd=2.16u as=0.1406p ps=1.12u w=0.74u l=0.13u
X219 VSS.t464 a_19963_1842# a_20397_1842# VSS.t1988 sg13_lv_nmos ad=0.1406p pd=1.12u as=0.2516p ps=2.16u w=0.74u l=0.13u
X220 a_2967_15358# CHAN0_MUX_SEL3 a_2873_15358# VSS.t201 sg13_lv_nmos ad=0.1216p pd=1.02u as=0.2176p ps=1.96u w=0.64u l=0.13u
X221 VSS.t745 VDD.t1647 VSS.t745 VSS.t750 sg13_lv_nmos ad=79.8f pd=0.8u as=0 ps=0 w=0.42u l=1u
X222 a_7390_3889# a_9751_3853# a_9675_3889# VDD.t9 sg13_lv_pmos ad=0.3808p pd=2.92u as=0.2128p ps=1.5u w=1.12u l=0.13u
X223 VDD.t802 a_4187_2434# a_4111_2470# VDD.t353 sg13_lv_pmos ad=0.3808p pd=2.92u as=0.2128p ps=1.5u w=1.12u l=0.6u
X224 VSS.t107 a_2019_16074.t6 a_13444_16035# VSS.t106 sg13_lv_nmos ad=0.2516p pd=2.16u as=0.2516p ps=2.16u w=0.74u l=0.13u
X225 a_20968_1044# a_20397_1842# VSS.t357 VSS.t1285 sg13_lv_nmos ad=0.1406p pd=1.12u as=0.2516p ps=2.16u w=0.74u l=0.13u
X226 a_10328_1044# a_9757_1842# VDD.t1350 VDD.t0 sg13_lv_pmos ad=0.2128p pd=1.5u as=0.3808p ps=2.92u w=1.12u l=0.13u
X227 VDD.t193 VSS.t725 VDD.t191 VDD.t29 sg13_lv_pmos ad=0.19p pd=1.38u as=0 ps=0 w=1u l=1u
X228 VSS.t550 a_2019_13229.t7 a_10404_13190# VSS.t549 sg13_lv_nmos ad=0.2516p pd=2.16u as=0.2516p ps=2.16u w=0.74u l=0.13u
X229 VDD.t457 a_6283_16869# a_6717_16869# VDD.t365 sg13_lv_pmos ad=0.2128p pd=1.5u as=0.3808p ps=2.92u w=1.12u l=0.13u
X230 a_6635_6734# a_6425_6734# VDD.t472 VDD.t29 sg13_lv_pmos ad=0.2128p pd=1.5u as=0.252p ps=1.57u w=1.12u l=0.13u
X231 a_16510_6734# a_2019_6737.t5 a_16408_6734# VSS.t1742 sg13_lv_nmos ad=0.2516p pd=2.16u as=0.1406p ps=1.12u w=0.74u l=0.13u
X232 a_22590_1044# a_22564_1008# a_22488_1044# VDD.t0 sg13_lv_pmos ad=0.3808p pd=2.92u as=0.2128p ps=1.5u w=1.12u l=0.13u
X233 VDD.t1619 a_3747_15338.t2 a_26985_15546# VDD.t20 sg13_lv_pmos ad=0.3808p pd=2.92u as=0.3808p ps=2.92u w=1.12u l=0.13u
X234 VDD.t64 VSS.t792 VDD.t63 VDD.t0 sg13_lv_pmos ad=0.19p pd=1.38u as=0 ps=0 w=1u l=1u
X235 a_22590_16071# a_24084_16035# a_24008_16071# VDD.t20 sg13_lv_pmos ad=0.3808p pd=2.92u as=0.2128p ps=1.5u w=1.12u l=0.13u
X236 VDD.t1201 VSS.t593 VDD.t1199 VDD.t20 sg13_lv_pmos ad=0.19p pd=1.38u as=0 ps=0 w=1u l=1u
X237 VDD.t1218 a_2595_6737.t9 a_5191_6698# VDD.t29 sg13_lv_pmos ad=0.3808p pd=2.92u as=0.3808p ps=2.92u w=1.12u l=0.13u
X238 VDD.t88 VSS.t730 VDD.t86 VDD.t9 sg13_lv_pmos ad=0.19p pd=1.38u as=0 ps=0 w=1u l=1u
X239 VDD.t1418 a_3449_4240# a_3747_3892.t0 VDD.t9 sg13_lv_pmos ad=0.4256p pd=3u as=0.2128p ps=1.5u w=1.12u l=0.13u
X240 a_21591_7532# a_21353_7532# a_21483_7532# VSS.t499 sg13_lv_nmos ad=0.1406p pd=1.12u as=0.2516p ps=2.16u w=0.74u l=0.2u
X241 a_6153_7532# a_5957_7532# VSS.t377 VSS.t2352 sg13_lv_nmos ad=0.2516p pd=2.16u as=0.1406p ps=1.12u w=0.74u l=0.13u
X242 a_20315_6734# a_20105_6734# VDD.t393 VDD.t29 sg13_lv_pmos ad=0.2128p pd=1.5u as=0.252p ps=1.57u w=1.12u l=0.13u
X243 a_8808_1044# a_8237_1842# VDD.t1174 VDD.t0 sg13_lv_pmos ad=0.2128p pd=1.5u as=0.3808p ps=2.92u w=1.12u l=0.13u
X244 VDD.t654 VDD.t652 VDD.t653 VDD.t339 sg13_lv_pmos ad=0.3808p pd=2.92u as=0 ps=0 w=1.12u l=0.6u
X245 a_1256_12471# CHAN1_MUX_SEL2 VSS.t129 VSS.t128 sg13_lv_nmos ad=0.2516p pd=2.16u as=0.2516p ps=2.16u w=0.74u l=0.13u
X246 a_25528_6734# a_24957_7532# VDD.t670 VDD.t29 sg13_lv_pmos ad=0.2128p pd=1.5u as=0.3808p ps=2.92u w=1.12u l=0.13u
X247 a_3171_13229.t1 a_2873_13577# VSS.t2046 VSS.t2059 sg13_lv_nmos ad=0.1406p pd=1.12u as=0.1331p ps=1.12u w=0.74u l=0.13u
X248 VSS.t113 a_16163_7532# a_16597_7532# VSS.t112 sg13_lv_nmos ad=0.1406p pd=1.12u as=0.2516p ps=2.16u w=0.74u l=0.13u
X249 VSS.t1448 a_3171_6737.t2 a_27124_6698# VSS.t1447 sg13_lv_nmos ad=0.2516p pd=2.16u as=0.2516p ps=2.16u w=0.74u l=0.13u
X250 VDD.t22 VSS.t604 VDD.t21 VDD.t20 sg13_lv_pmos ad=0.34p pd=2.68u as=0 ps=0 w=1u l=1u
X251 VDD.t972 a_2595_3156.t2 a_20905_3364# VDD.t9 sg13_lv_pmos ad=0.3808p pd=2.92u as=0.3808p ps=2.92u w=1.12u l=0.13u
X252 a_23871_14024# a_23633_14024# a_23763_14024# VSS.t1431 sg13_lv_nmos ad=0.1406p pd=1.12u as=0.2516p ps=2.16u w=0.74u l=0.2u
X253 VDD.t734 a_11603_7532# a_12037_7532# VDD.t341 sg13_lv_pmos ad=0.2128p pd=1.5u as=0.3808p ps=2.92u w=1.12u l=0.13u
X254 a_18551_17497# a_18313_16869# a_18443_16869# VDD.t365 sg13_lv_pmos ad=0.2128p pd=1.5u as=0.3808p ps=2.92u w=1.12u l=0.2u
X255 CHAN1_DELAY_OUT_LAST a_27997_14024# VSS.t1959 VSS.t1958 sg13_lv_nmos ad=0.2516p pd=2.16u as=0.1406p ps=1.12u w=0.74u l=0.13u
X256 VDD.t1379 a_3171_13229.t7 a_11924_13190# VDD.t36 sg13_lv_pmos ad=0.3808p pd=2.92u as=0.3808p ps=2.92u w=1.12u l=0.13u
X257 VSS.t577 VDD.t1708 VSS.t577 VSS.t576 sg13_lv_nmos ad=0.1428p pd=1.52u as=0 ps=0 w=0.42u l=1u
X258 a_4350_13226# a_2595_13229.t9 a_5115_13226# VSS.t551 sg13_lv_nmos ad=0.2516p pd=2.16u as=0.1406p ps=1.12u w=0.74u l=0.13u
X259 a_3449_4240# CHAN2_MUX_SEL0 VDD.t961 VDD.t9 sg13_lv_pmos ad=0.1596p pd=1.22u as=0.2856p ps=2.36u w=0.84u l=0.13u
X260 a_13880_10808# a_14111_10917# a_13566_11018# VSS.t854 sg13_lv_nmos ad=0.2373p pd=1.97u as=79.8f ps=0.8u w=0.42u l=0.13u
X261 VSS.t97 a_4187_1764.t104 a_24631_14024# VSS.t322 sg13_lv_nmos ad=0.2516p pd=2.16u as=0.1406p ps=1.12u w=0.74u l=0.6u
X262 a_24393_7532# a_24197_7532# VDD.t739 VDD.t341 sg13_lv_pmos ad=0.3808p pd=2.92u as=0.2128p ps=1.5u w=1.12u l=0.13u
X263 a_10430_6734# a_2595_6737.t7 a_11195_6734# VSS.t1442 sg13_lv_nmos ad=0.2516p pd=2.16u as=0.1406p ps=1.12u w=0.74u l=0.13u
X264 VSS.t556 a_3171_15338.t3 a_11785_15546# VSS.t555 sg13_lv_nmos ad=0.2516p pd=2.16u as=0.2516p ps=2.16u w=0.74u l=0.13u
X265 a_4157_1313# CHAN3_DELAY_IN VDD.t354 VDD.t0 sg13_lv_pmos ad=0.3808p pd=2.92u as=0.3808p ps=2.92u w=1.12u l=0.13u
X266 a_27433_4687# a_27237_4687# VDD.t1222 VDD.t339 sg13_lv_pmos ad=0.3808p pd=2.92u as=0.2128p ps=1.5u w=1.12u l=0.13u
X267 a_7390_16071# a_8884_16035# a_8808_16071# VDD.t20 sg13_lv_pmos ad=0.3808p pd=2.92u as=0.2128p ps=1.5u w=1.12u l=0.13u
X268 a_17031_2470# a_16793_1842# a_16923_1842# VDD.t353 sg13_lv_pmos ad=0.2128p pd=1.5u as=0.3808p ps=2.92u w=1.12u l=0.2u
X269 VSS.t1309 a_4187_1764.t37 a_25391_4687# VSS.t1635 sg13_lv_nmos ad=0.2516p pd=2.16u as=0.1406p ps=1.12u w=0.74u l=0.6u
X270 VDD.t50 VSS.t702 VDD.t49 VDD.t29 sg13_lv_pmos ad=0.34p pd=2.68u as=0 ps=0 w=1u l=1u
X271 VDD.t1446 a_1544_15316# a_1721_15358# VDD.t20 sg13_lv_pmos ad=0.1918p pd=1.5u as=0.1596p ps=1.22u w=0.84u l=0.13u
X272 a_17553_14024# a_17357_14024# VDD.t697 VDD.t381 sg13_lv_pmos ad=0.3808p pd=2.92u as=0.2128p ps=1.5u w=1.12u l=0.13u
X273 a_23355_6734# a_23145_6734# VSS.t1253 VSS.t2217 sg13_lv_nmos ad=0.1406p pd=1.12u as=0.1665p ps=1.19u w=0.74u l=0.13u
X274 VSS.t392 a_4187_1764.t89 a_10191_7532# VSS.t1123 sg13_lv_nmos ad=0.2516p pd=2.16u as=0.1406p ps=1.12u w=0.74u l=0.6u
X275 VDD.t832 a_4187_2434# a_4111_14652# VDD.t381 sg13_lv_pmos ad=0.3808p pd=2.92u as=0.2128p ps=1.5u w=1.12u l=0.6u
X276 VDD.t223 VSS.t652 VDD.t221 VDD.t36 sg13_lv_pmos ad=0.19p pd=1.38u as=0 ps=0 w=1u l=1u
X277 a_4350_16071# a_4324_16035# a_4248_16071# VDD.t20 sg13_lv_pmos ad=0.3808p pd=2.92u as=0.2128p ps=1.5u w=1.12u l=0.13u
X278 VSS.t12 a_3747_6737.t4 a_21911_6698# VSS.t1770 sg13_lv_nmos ad=0.2516p pd=2.16u as=0.2516p ps=2.16u w=0.74u l=0.13u
X279 VDD.t1171 a_3171_3892.t5 a_18004_3853# VDD.t9 sg13_lv_pmos ad=0.3808p pd=2.92u as=0.3808p ps=2.92u w=1.12u l=0.13u
X280 VDD.t879 a_4187_2434# a_14751_8160# VDD.t341 sg13_lv_pmos ad=0.3808p pd=2.92u as=0.2128p ps=1.5u w=1.12u l=0.6u
X281 a_3171_3156.t0 a_2873_3176# VDD.t379 VDD.t9 sg13_lv_pmos ad=0.2128p pd=1.5u as=0.1918p ps=1.5u w=1.12u l=0.13u
X282 a_26673_16869# a_26477_16869# VSS.t1725 VSS.t2313 sg13_lv_nmos ad=0.2516p pd=2.16u as=0.1406p ps=1.12u w=0.74u l=0.13u
X283 a_11473_1842# a_11277_1842# VSS.t379 VSS.t378 sg13_lv_nmos ad=0.2516p pd=2.16u as=0.1406p ps=1.12u w=0.74u l=0.13u
X284 VDD.t546 a_2019_15338.t2 a_17865_15546# VDD.t20 sg13_lv_pmos ad=0.3808p pd=2.92u as=0.3808p ps=2.92u w=1.12u l=0.13u
X285 VSS.t1024 a_19963_7532# a_20397_7532# VSS.t2222 sg13_lv_nmos ad=0.1406p pd=1.12u as=0.2516p ps=2.16u w=0.74u l=0.13u
X286 VDD.t976 a_2297_3176# a_2595_3156.t0 VDD.t9 sg13_lv_pmos ad=0.4256p pd=3u as=0.2128p ps=1.5u w=1.12u l=0.13u
X287 a_2967_12513# CHAN1_MUX_SEL3 a_2873_12513# VSS.t1786 sg13_lv_nmos ad=0.1216p pd=1.02u as=0.2176p ps=1.96u w=0.64u l=0.13u
X288 VSS.t825 VDD.t1624 VSS.t827 VSS.t826 sg13_lv_nmos ad=79.8f pd=0.8u as=0 ps=0 w=0.42u l=1u
X289 VDD.t569 a_3747_12493.t3 a_14825_12701# VDD.t36 sg13_lv_pmos ad=0.3808p pd=2.92u as=0.3808p ps=2.92u w=1.12u l=0.13u
X290 a_16408_3889# a_15837_4687# VSS.t76 VSS.t2139 sg13_lv_nmos ad=0.1406p pd=1.12u as=0.2516p ps=2.16u w=0.74u l=0.13u
X291 VDD.t1447 a_1721_15358# a_2019_15338.t0 VDD.t20 sg13_lv_pmos ad=0.4256p pd=3u as=0.2128p ps=1.5u w=1.12u l=0.13u
X292 VSS.t2114 a_1721_15358# a_2019_15338.t1 VSS.t2066 sg13_lv_nmos ad=0.2812p pd=2.24u as=0.1406p ps=1.12u w=0.74u l=0.13u
X293 a_8433_14024# a_8237_14024# VSS.t1094 VSS.t1939 sg13_lv_nmos ad=0.2516p pd=2.16u as=0.1406p ps=1.12u w=0.74u l=0.13u
X294 a_19448_1044# a_18877_1842# VSS.t102 VSS.t101 sg13_lv_nmos ad=0.1406p pd=1.12u as=0.2516p ps=2.16u w=0.74u l=0.13u
X295 VDD.t501 a_2595_16074.t6 a_14311_16035# VDD.t20 sg13_lv_pmos ad=0.3808p pd=2.92u as=0.3808p ps=2.92u w=1.12u l=0.13u
X296 VSS.t643 VDD.t1691 VSS.t643 VSS.t642 sg13_lv_nmos ad=0.1428p pd=1.52u as=0 ps=0 w=0.42u l=1u
X297 a_25630_13226# a_2019_13229.t2 a_25528_13226# VSS.t2002 sg13_lv_nmos ad=0.2516p pd=2.16u as=0.1406p ps=1.12u w=0.74u l=0.13u
X298 a_15053_11680# a_14111_11568# a_14851_11918# VDD.t351 sg13_lv_pmos ad=93.45f pd=0.865u as=0.2048p ps=1.63u w=0.42u l=0.13u
X299 VDD.t785 a_4187_2434# a_4111_8160# VDD.t341 sg13_lv_pmos ad=0.3808p pd=2.92u as=0.2128p ps=1.5u w=1.12u l=0.6u
X300 a_10430_1044# a_3171_1047.t7 a_11848_1044# VSS.t337 sg13_lv_nmos ad=0.2516p pd=2.16u as=0.1406p ps=1.12u w=0.74u l=0.13u
X301 a_20968_6734# a_20397_7532# VSS.t1022 VSS.t1021 sg13_lv_nmos ad=0.1406p pd=1.12u as=0.2516p ps=2.16u w=0.74u l=0.13u
X302 VDD.t747 a_27237_1842# a_27705_1044# VDD.t0 sg13_lv_pmos ad=0.252p pd=1.57u as=0.3808p ps=2.92u w=1.12u l=0.13u
X303 a_14235_3889# a_14025_3889# VDD.t1253 VDD.t9 sg13_lv_pmos ad=0.2128p pd=1.5u as=0.252p ps=1.57u w=1.12u l=0.13u
X304 a_5731_5979# a_14825_6209# a_13470_6734# VDD.t29 sg13_lv_pmos ad=0.3808p pd=2.92u as=0.3808p ps=2.92u w=1.12u l=0.13u
X305 a_19448_13226# a_18877_14024# VSS.t1732 VSS.t2321 sg13_lv_nmos ad=0.1406p pd=1.12u as=0.2516p ps=2.16u w=0.74u l=0.13u
X306 VDD.t891 a_4187_2434# a_7151_5315# VDD.t339 sg13_lv_pmos ad=0.3808p pd=2.92u as=0.2128p ps=1.5u w=1.12u l=0.6u
X307 VSS.t1341 a_16851_15336# CHAN0_MUX_OUT VSS.t1342 sg13_lv_nmos ad=0.2516p pd=2.16u as=0.1406p ps=1.12u w=0.74u l=0.13u
X308 a_16108_12471# a_15765_12645# a_15964_12471# VDD.t36 sg13_lv_pmos ad=0.3808p pd=2.92u as=0.3304p ps=1.71u w=1.12u l=0.13u
X309 VDD.t444 a_6326_10280# a_6326_10280# VDD.t351 sg13_lv_pmos ad=0.38p pd=2.38u as=0.38p ps=2.38u w=2u l=1u
X310 VSS.t797 VDD.t1631 VSS.t800 VSS.t799 sg13_lv_nmos ad=79.8f pd=0.8u as=0 ps=0 w=0.42u l=1u
X311 VDD.t277 VSS.t769 VDD.t275 VDD.t9 sg13_lv_pmos ad=0.19p pd=1.38u as=0 ps=0 w=1u l=1u
X312 a_2595_16074.t1 a_2297_16422# VSS.t2027 VSS.t2026 sg13_lv_nmos ad=0.1406p pd=1.12u as=0.1331p ps=1.12u w=0.74u l=0.13u
X313 a_20831_2470# a_20593_1842# a_20723_1842# VDD.t353 sg13_lv_pmos ad=0.2128p pd=1.5u as=0.3808p ps=2.92u w=1.12u l=0.2u
X314 VDD.t1017 a_6283_14024# a_6717_14024# VDD.t381 sg13_lv_pmos ad=0.2128p pd=1.5u as=0.3808p ps=2.92u w=1.12u l=0.13u
X315 a_5393_1842# a_5197_1842# VDD.t980 VDD.t353 sg13_lv_pmos ad=0.3808p pd=2.92u as=0.2128p ps=1.5u w=1.12u l=0.13u
X316 VDD.t370 a_3747_3892.t7 a_12791_3853# VDD.t9 sg13_lv_pmos ad=0.3808p pd=2.92u as=0.3808p ps=2.92u w=1.12u l=0.13u
X317 VSS.t1037 a_4187_1764.t116 a_15511_14024# VSS.t1036 sg13_lv_nmos ad=0.2516p pd=2.16u as=0.1406p ps=1.12u w=0.74u l=0.6u
X318 a_13949_11186# a_13592_11113# VDD.t699 VDD.t351 sg13_lv_pmos ad=63f pd=0.72u as=0.1563p ps=1.22u w=0.42u l=0.13u
X319 VDD.t788 a_4187_2434# a_17031_2470# VDD.t353 sg13_lv_pmos ad=0.3808p pd=2.92u as=0.2128p ps=1.5u w=1.12u l=0.6u
X320 a_10191_14024# a_9953_14024# a_10083_14024# VSS.t1276 sg13_lv_nmos ad=0.1406p pd=1.12u as=0.2516p ps=2.16u w=0.74u l=0.2u
X321 VSS.t1086 a_4187_1764.t122 a_10951_14024# VSS.t1085 sg13_lv_nmos ad=0.2516p pd=2.16u as=0.1406p ps=1.12u w=0.74u l=0.6u
X322 a_7390_3889# a_3747_3892.t8 a_9675_3889# VSS.t1901 sg13_lv_nmos ad=0.2516p pd=2.16u as=0.1406p ps=1.12u w=0.74u l=0.13u
X323 a_25630_13226# a_27124_13190# a_27048_13226# VDD.t36 sg13_lv_pmos ad=0.3808p pd=2.92u as=0.2128p ps=1.5u w=1.12u l=0.13u
X324 VDD.t1441 a_26803_1842# a_27237_1842# VDD.t353 sg13_lv_pmos ad=0.2128p pd=1.5u as=0.3808p ps=2.92u w=1.12u l=0.13u
X325 VDD.t1464 CHAN3_MUX_SEL1 a_3449_1395# VDD.t0 sg13_lv_pmos ad=0.1918p pd=1.5u as=0.1596p ps=1.22u w=0.84u l=0.13u
X326 a_17275_16071# a_17065_16071# VDD.t1391 VDD.t20 sg13_lv_pmos ad=0.2128p pd=1.5u as=0.252p ps=1.57u w=1.12u l=0.13u
X327 a_11848_3889# a_11277_4687# VDD.t702 VDD.t9 sg13_lv_pmos ad=0.2128p pd=1.5u as=0.3808p ps=2.92u w=1.12u l=0.13u
X328 a_18551_14652# a_18313_14024# a_18443_14024# VDD.t381 sg13_lv_pmos ad=0.2128p pd=1.5u as=0.3808p ps=2.92u w=1.12u l=0.2u
X329 VSS.t1186 a_15108_11015# a_14757_10872# VSS.t2137 sg13_lv_nmos ad=79.8f pd=0.8u as=0.1428p ps=1.52u w=0.42u l=0.13u
X330 a_25630_1044# a_2595_1047.t2 a_26395_1044# VSS.t1880 sg13_lv_nmos ad=0.2516p pd=2.16u as=0.1406p ps=1.12u w=0.74u l=0.13u
X331 a_17031_8160# a_16793_7532# a_16923_7532# VDD.t341 sg13_lv_pmos ad=0.2128p pd=1.5u as=0.3808p ps=2.92u w=1.12u l=0.2u
X332 a_16408_6734# a_15837_7532# VDD.t1230 VDD.t29 sg13_lv_pmos ad=0.2128p pd=1.5u as=0.3808p ps=2.92u w=1.12u l=0.13u
X333 VSS.t709 VDD.t1662 VSS.t709 VSS.t713 sg13_lv_nmos ad=0.1428p pd=1.52u as=0 ps=0 w=0.42u l=1u
X334 a_27671_16869# a_27433_16869# a_27563_16869# VSS.t91 sg13_lv_nmos ad=0.1406p pd=1.12u as=0.2516p ps=2.16u w=0.74u l=0.2u
X335 a_16510_13226# a_2019_13229.t5 a_16408_13226# VSS.t1682 sg13_lv_nmos ad=0.2516p pd=2.16u as=0.1406p ps=1.12u w=0.74u l=0.13u
X336 VSS.t2126 a_4187_1764.t5 a_25391_1842# VSS.t2388 sg13_lv_nmos ad=0.2516p pd=2.16u as=0.1406p ps=1.12u w=0.74u l=0.6u
X337 VDD.t950 a_1544_12471# a_1721_12513# VDD.t36 sg13_lv_pmos ad=0.1918p pd=1.5u as=0.1596p ps=1.22u w=0.84u l=0.13u
X338 VDD.t301 VSS.t745 VDD.t300 VDD.t9 sg13_lv_pmos ad=0.34p pd=2.68u as=0 ps=0 w=1u l=1u
X339 VSS.t1319 a_13123_14024# a_13557_14024# VSS.t2316 sg13_lv_nmos ad=0.1406p pd=1.12u as=0.2516p ps=2.16u w=0.74u l=0.13u
X340 a_5115_13226# a_4905_13226# VDD.t1322 VDD.t36 sg13_lv_pmos ad=0.2128p pd=1.5u as=0.252p ps=1.57u w=1.12u l=0.13u
X341 a_26673_4687# a_26477_4687# VSS.t1338 VSS.t2196 sg13_lv_nmos ad=0.2516p pd=2.16u as=0.1406p ps=1.12u w=0.74u l=0.13u
X342 a_6635_1044# a_6425_1044# VDD.t350 VDD.t0 sg13_lv_pmos ad=0.2128p pd=1.5u as=0.252p ps=1.57u w=1.12u l=0.13u
X343 a_11473_7532# a_11277_7532# VSS.t187 VSS.t186 sg13_lv_nmos ad=0.2516p pd=2.16u as=0.1406p ps=1.12u w=0.74u l=0.13u
X344 VSS.t674 VDD.t1677 VSS.t674 VSS.t678 sg13_lv_nmos ad=79.8f pd=0.8u as=0 ps=0 w=0.42u l=1u
X345 a_18313_4687# a_18117_4687# VDD.t1114 VDD.t339 sg13_lv_pmos ad=0.3808p pd=2.92u as=0.2128p ps=1.5u w=1.12u l=0.13u
X346 VDD.t515 a_2595_1047.t9 a_5191_1008# VDD.t0 sg13_lv_pmos ad=0.3808p pd=2.92u as=0.3808p ps=2.92u w=1.12u l=0.13u
X347 a_9431_5315# a_9193_4687# a_9323_4687# VDD.t339 sg13_lv_pmos ad=0.2128p pd=1.5u as=0.3808p ps=2.92u w=1.12u l=0.2u
X348 a_19448_6734# a_18877_7532# VSS.t488 VSS.t1809 sg13_lv_nmos ad=0.1406p pd=1.12u as=0.2516p ps=2.16u w=0.74u l=0.13u
X349 a_20315_1044# a_20105_1044# VDD.t421 VDD.t0 sg13_lv_pmos ad=0.2128p pd=1.5u as=0.252p ps=1.57u w=1.12u l=0.13u
X350 a_13592_11113# a_14111_10917# a_14851_10872# VSS.t855 sg13_lv_nmos ad=0.3473p pd=2.71u as=0.12665p ps=1.145u w=0.74u l=0.13u
X351 a_10430_6734# a_3171_6737.t7 a_11848_6734# VSS.t2112 sg13_lv_nmos ad=0.2516p pd=2.16u as=0.1406p ps=1.12u w=0.74u l=0.13u
X352 a_7390_6734# a_9751_6698# a_9675_6734# VDD.t29 sg13_lv_pmos ad=0.3808p pd=2.92u as=0.2128p ps=1.5u w=1.12u l=0.13u
X353 a_25528_1044# a_24957_1842# VDD.t1601 VDD.t0 sg13_lv_pmos ad=0.2128p pd=1.5u as=0.3808p ps=2.92u w=1.12u l=0.13u
X354 VSS.t254 a_1721_1395# a_2019_1047.t1 VSS.t255 sg13_lv_nmos ad=0.2812p pd=2.24u as=0.1406p ps=1.12u w=0.74u l=0.13u
X355 a_19311_2470# a_19073_1842# a_19203_1842# VDD.t353 sg13_lv_pmos ad=0.2128p pd=1.5u as=0.3808p ps=2.92u w=1.12u l=0.2u
X356 a_5731_3134# a_14825_3364# a_13470_3889# VDD.t9 sg13_lv_pmos ad=0.3808p pd=2.92u as=0.3808p ps=2.92u w=1.12u l=0.13u
X357 VSS.t34 a_5957_1842# a_6425_1044# VSS.t2180 sg13_lv_nmos ad=0.1665p pd=1.19u as=0.2516p ps=2.16u w=0.74u l=0.13u
X358 VSS.t1653 a_3171_3892.t5 a_18004_3853# VSS.t1652 sg13_lv_nmos ad=0.2516p pd=2.16u as=0.2516p ps=2.16u w=0.74u l=0.13u
X359 VSS.t539 a_2019_16074.t7 a_10404_16035# VSS.t538 sg13_lv_nmos ad=0.2516p pd=2.16u as=0.2516p ps=2.16u w=0.74u l=0.13u
X360 a_20831_8160# a_20593_7532# a_20723_7532# VDD.t341 sg13_lv_pmos ad=0.2128p pd=1.5u as=0.3808p ps=2.92u w=1.12u l=0.2u
X361 a_5393_7532# a_5197_7532# VDD.t427 VDD.t341 sg13_lv_pmos ad=0.3808p pd=2.92u as=0.2128p ps=1.5u w=1.12u l=0.13u
X362 a_23871_5315# a_23633_4687# a_23763_4687# VDD.t339 sg13_lv_pmos ad=0.2128p pd=1.5u as=0.3808p ps=2.92u w=1.12u l=0.2u
X363 VDD.t881 a_4187_2434# a_17031_8160# VDD.t341 sg13_lv_pmos ad=0.3808p pd=2.92u as=0.2128p ps=1.5u w=1.12u l=0.6u
X364 VSS.t213 a_4187_1764.t62 a_6391_4687# VSS.t1860 sg13_lv_nmos ad=0.2516p pd=2.16u as=0.1406p ps=1.12u w=0.74u l=0.6u
X365 a_8433_4687# a_8237_4687# VDD.t1108 VDD.t339 sg13_lv_pmos ad=0.3808p pd=2.92u as=0.2128p ps=1.5u w=1.12u l=0.13u
X366 VSS.t2024 a_2297_13577# a_2595_13229.t1 VSS.t2025 sg13_lv_nmos ad=0.2812p pd=2.24u as=0.1406p ps=1.12u w=0.74u l=0.13u
X367 VSS.t136 a_10649_11568# a_10751_11568# VSS.t1369 sg13_lv_nmos ad=2.39977p pd=15.495u as=0.2516p ps=2.16u w=0.74u l=0.13u
X368 VDD.t100 VSS.t620 VDD.t99 VDD.t20 sg13_lv_pmos ad=0.34p pd=2.68u as=0 ps=0 w=1u l=1u
X369 VDD.t492 a_18443_4687# a_18877_4687# VDD.t339 sg13_lv_pmos ad=0.2128p pd=1.5u as=0.3808p ps=2.92u w=1.12u l=0.13u
X370 a_19550_16071# a_21044_16035# a_20968_16071# VDD.t20 sg13_lv_pmos ad=0.3808p pd=2.92u as=0.2128p ps=1.5u w=1.12u l=0.13u
X371 a_10713_14024# a_10517_14024# VSS.t506 VSS.t1490 sg13_lv_nmos ad=0.2516p pd=2.16u as=0.1406p ps=1.12u w=0.74u l=0.13u
X372 VDD.t698 a_26803_7532# a_27237_7532# VDD.t341 sg13_lv_pmos ad=0.2128p pd=1.5u as=0.3808p ps=2.92u w=1.12u l=0.13u
X373 a_14235_3889# a_14025_3889# VSS.t1799 VSS.t1971 sg13_lv_nmos ad=0.1406p pd=1.12u as=0.1665p ps=1.19u w=0.74u l=0.13u
X374 a_22113_4687# a_21917_4687# VDD.t495 VDD.t339 sg13_lv_pmos ad=0.3808p pd=2.92u as=0.2128p ps=1.5u w=1.12u l=0.13u
X375 VSS.t1102 a_4187_1764.t143 a_19311_16869# VSS.t1101 sg13_lv_nmos ad=0.2516p pd=2.16u as=0.1406p ps=1.12u w=0.74u l=0.6u
X376 a_3171_16074.t1 a_2873_16422# VSS.t1834 VSS.t2021 sg13_lv_nmos ad=0.1406p pd=1.12u as=0.1331p ps=1.12u w=0.74u l=0.13u
X377 VDD.t408 a_2019_13229.t6 a_13444_13190# VDD.t36 sg13_lv_pmos ad=0.3808p pd=2.92u as=0.3808p ps=2.92u w=1.12u l=0.13u
X378 VDD.t1257 a_19637_4687# a_20105_3889# VDD.t9 sg13_lv_pmos ad=0.252p pd=1.57u as=0.3808p ps=2.92u w=1.12u l=0.13u
X379 VDD.t1199 VSS.t593 VDD.t1198 VDD.t20 sg13_lv_pmos ad=0.34p pd=2.68u as=0 ps=0 w=1u l=1u
X380 VSS.t363 a_2019_1047.t6 a_13444_1008# VSS.t362 sg13_lv_nmos ad=0.2516p pd=2.16u as=0.2516p ps=2.16u w=0.74u l=0.13u
X381 VSS.t70 a_3747_3892.t7 a_12791_3853# VSS.t69 sg13_lv_nmos ad=0.2516p pd=2.16u as=0.2516p ps=2.16u w=0.74u l=0.13u
X382 VSS.t56 a_4187_1764.t43 a_20831_4687# VSS.t1114 sg13_lv_nmos ad=0.2516p pd=2.16u as=0.1406p ps=1.12u w=0.74u l=0.6u
X383 VDD.t1145 a_16851_12491# CHAN1_MUX_OUT VDD.t36 sg13_lv_pmos ad=0.7336p pd=3.55u as=0.2128p ps=1.5u w=1.12u l=0.13u
X384 a_25630_6734# a_2595_6737.t2 a_26395_6734# VSS.t2246 sg13_lv_nmos ad=0.2516p pd=2.16u as=0.1406p ps=1.12u w=0.74u l=0.13u
X385 a_4350_16071# a_2595_16074.t9 a_5115_16071# VSS.t153 sg13_lv_nmos ad=0.2516p pd=2.16u as=0.1406p ps=1.12u w=0.74u l=0.13u
X386 a_25153_14024# a_24957_14024# VSS.t97 VSS.t2329 sg13_lv_nmos ad=0.2516p pd=2.16u as=0.1406p ps=1.12u w=0.74u l=0.13u
X387 VSS.t779 VDD.t1636 VSS.t779 VSS.t778 sg13_lv_nmos ad=0.1428p pd=1.52u as=0 ps=0 w=0.42u l=1u
X388 a_23111_2470# a_22873_1842# a_23003_1842# VDD.t353 sg13_lv_pmos ad=0.2128p pd=1.5u as=0.3808p ps=2.92u w=1.12u l=0.2u
X389 VSS.t321 a_15964_289# a_16851_309# VSS.t320 sg13_lv_nmos ad=0.1371p pd=1.12u as=0.2176p ps=1.96u w=0.64u l=0.13u
X390 VDD.t169 VSS.t709 VDD.t168 VDD.t29 sg13_lv_pmos ad=0.34p pd=2.68u as=0 ps=0 w=1u l=1u
X391 a_16108_289# a_17865_519# a_16510_1044# VDD.t0 sg13_lv_pmos ad=0.3808p pd=2.92u as=0.3808p ps=2.92u w=1.12u l=0.13u
X392 VDD.t778 a_4187_2434# a_12471_5315# VDD.t339 sg13_lv_pmos ad=0.3808p pd=2.92u as=0.2128p ps=1.5u w=1.12u l=0.6u
X393 VDD.t1081 a_17683_1842# a_18117_1842# VDD.t353 sg13_lv_pmos ad=0.2128p pd=1.5u as=0.3808p ps=2.92u w=1.12u l=0.13u
X394 VSS.t2072 a_4187_1764.t69 a_25391_7532# VSS.t2071 sg13_lv_nmos ad=0.2516p pd=2.16u as=0.1406p ps=1.12u w=0.74u l=0.6u
X395 a_10713_1842# a_10517_1842# VDD.t1346 VDD.t353 sg13_lv_pmos ad=0.3808p pd=2.92u as=0.2128p ps=1.5u w=1.12u l=0.13u
X396 a_4350_16071# a_5844_16035# a_5768_16071# VDD.t20 sg13_lv_pmos ad=0.3808p pd=2.92u as=0.2128p ps=1.5u w=1.12u l=0.13u
X397 a_11848_3889# a_11277_4687# VSS.t1026 VSS.t1025 sg13_lv_nmos ad=0.1406p pd=1.12u as=0.2516p ps=2.16u w=0.74u l=0.13u
X398 a_10191_4687# a_9953_4687# a_10083_4687# VSS.t1643 sg13_lv_nmos ad=0.1406p pd=1.12u as=0.2516p ps=2.16u w=0.74u l=0.2u
X399 VSS.t1590 a_4187_1764.t98 VSS.t1588 VSS.t1573 sg13_lv_nmos ad=1.33p pd=7.38u as=0 ps=0 w=7u l=7u
X400 VDD.t1443 a_3171_6737.t5 a_18004_6698# VDD.t29 sg13_lv_pmos ad=0.3808p pd=2.92u as=0.3808p ps=2.92u w=1.12u l=0.13u
X401 a_26673_1842# a_26477_1842# VSS.t546 VSS.t2099 sg13_lv_nmos ad=0.2516p pd=2.16u as=0.1406p ps=1.12u w=0.74u l=0.13u
X402 VDD.t998 a_22243_4687# a_22677_4687# VDD.t339 sg13_lv_pmos ad=0.2128p pd=1.5u as=0.3808p ps=2.92u w=1.12u l=0.13u
X403 VDD.t234 VSS.t602 VDD.t24 VDD.t20 sg13_lv_pmos ad=0.19p pd=1.38u as=0 ps=0 w=1u l=1u
X404 a_23633_16869# a_23437_16869# VSS.t85 VSS.t84 sg13_lv_nmos ad=0.2516p pd=2.16u as=0.1406p ps=1.12u w=0.74u l=0.13u
X405 a_13019_11521# a_15688_11093# VSS.t1186 VSS.t1293 sg13_lv_nmos ad=0.2516p pd=2.16u as=0.1406p ps=1.12u w=0.74u l=0.13u
X406 a_9953_14024# a_9757_14024# VSS.t370 VSS.t369 sg13_lv_nmos ad=0.2516p pd=2.16u as=0.1406p ps=1.12u w=0.74u l=0.13u
X407 a_20315_13226# a_20105_13226# VSS.t2098 VSS.t2097 sg13_lv_nmos ad=0.1406p pd=1.12u as=0.1665p ps=1.19u w=0.74u l=0.13u
X408 a_16510_3889# a_17351_3853# a_17275_3889# VDD.t9 sg13_lv_pmos ad=0.3808p pd=2.92u as=0.2128p ps=1.5u w=1.12u l=0.13u
X409 VSS.t454 a_16923_16869# a_17357_16869# VSS.t2142 sg13_lv_nmos ad=0.1406p pd=1.12u as=0.2516p ps=2.16u w=0.74u l=0.13u
X410 VDD.t480 a_3747_15338.t3 a_14825_15546# VDD.t20 sg13_lv_pmos ad=0.3808p pd=2.92u as=0.3808p ps=2.92u w=1.12u l=0.13u
X411 VDD.t460 a_7803_1842# a_8237_1842# VDD.t353 sg13_lv_pmos ad=0.2128p pd=1.5u as=0.3808p ps=2.92u w=1.12u l=0.13u
X412 VDD.t1176 a_3171_12493.t3 a_11785_12701# VDD.t36 sg13_lv_pmos ad=0.3808p pd=2.92u as=0.3808p ps=2.92u w=1.12u l=0.13u
X413 VSS.t758 VDD.t1643 VSS.t758 VSS.t757 sg13_lv_nmos ad=0.1428p pd=1.52u as=0 ps=0 w=0.42u l=1u
X414 a_2595_12493.t0 a_2297_12513# VDD.t757 VDD.t36 sg13_lv_pmos ad=0.2128p pd=1.5u as=0.1918p ps=1.5u w=1.12u l=0.13u
X415 a_25630_16071# a_2019_16074.t2 a_25528_16071# VSS.t1070 sg13_lv_nmos ad=0.2516p pd=2.16u as=0.1406p ps=1.12u w=0.74u l=0.13u
X416 a_19311_8160# a_19073_7532# a_19203_7532# VDD.t341 sg13_lv_pmos ad=0.2128p pd=1.5u as=0.3808p ps=2.92u w=1.12u l=0.2u
X417 VSS.t264 a_1721_7085# a_2019_6737.t1 VSS.t265 sg13_lv_nmos ad=0.2812p pd=2.24u as=0.1406p ps=1.12u w=0.74u l=0.13u
X418 a_4248_1044# a_4157_1313# VSS.t111 VSS.t110 sg13_lv_nmos ad=0.1406p pd=1.12u as=0.2516p ps=2.16u w=0.74u l=0.13u
X419 VDD.t1046 a_8563_16869# a_8997_16869# VDD.t365 sg13_lv_pmos ad=0.2128p pd=1.5u as=0.3808p ps=2.92u w=1.12u l=0.13u
X420 VSS.t702 VDD.t1667 VSS.t702 VSS.t701 sg13_lv_nmos ad=0.1428p pd=1.52u as=0 ps=0 w=0.42u l=1u
X421 a_19448_16071# a_18877_16869# VSS.t1061 VSS.t1060 sg13_lv_nmos ad=0.1406p pd=1.12u as=0.2516p ps=2.16u w=0.74u l=0.13u
X422 VDD.t1288 a_2595_16074.t7 a_11271_16035# VDD.t20 sg13_lv_pmos ad=0.3808p pd=2.92u as=0.3808p ps=2.92u w=1.12u l=0.13u
X423 VSS.t257 a_5957_7532# a_6425_6734# VSS.t2351 sg13_lv_nmos ad=0.1665p pd=1.19u as=0.2516p ps=2.16u w=0.74u l=0.13u
X424 a_14235_6734# a_14025_6734# VDD.t723 VDD.t29 sg13_lv_pmos ad=0.2128p pd=1.5u as=0.252p ps=1.57u w=1.12u l=0.13u
X425 VSS.t585 VDD.t1706 VSS.t584 VSS.t583 sg13_lv_nmos ad=0.1428p pd=1.52u as=0 ps=0 w=0.42u l=1u
X426 a_16108_15316# a_15765_15490# a_15964_15316# VDD.t20 sg13_lv_pmos ad=0.3808p pd=2.92u as=0.3304p ps=1.71u w=1.12u l=0.13u
X427 a_16108_289# a_3171_311.t2 a_22590_1044# VSS.t422 sg13_lv_nmos ad=0.2516p pd=2.16u as=0.2516p ps=2.16u w=0.74u l=0.13u
X428 VDD.t369 a_3747_3892.t2 a_27991_3853# VDD.t9 sg13_lv_pmos ad=0.3808p pd=2.92u as=0.3808p ps=2.92u w=1.12u l=0.13u
X429 a_11711_14024# a_11473_14024# a_11603_14024# VSS.t225 sg13_lv_nmos ad=0.1406p pd=1.12u as=0.2516p ps=2.16u w=0.74u l=0.2u
X430 a_1721_6021# a_1256_5979# VDD.t1481 VDD.t29 sg13_lv_pmos ad=0.1596p pd=1.22u as=0.2856p ps=2.36u w=0.84u l=0.13u
X431 VDD.t1228 a_3747_6737.t7 a_12791_6698# VDD.t29 sg13_lv_pmos ad=0.3808p pd=2.92u as=0.3808p ps=2.92u w=1.12u l=0.13u
X432 VSS.t287 a_4187_1764.t30 a_6391_1842# VSS.t2162 sg13_lv_nmos ad=0.2516p pd=2.16u as=0.1406p ps=1.12u w=0.74u l=0.6u
X433 VSS.t1064 a_4187_1764.t120 a_12471_14024# VSS.t1063 sg13_lv_nmos ad=0.2516p pd=2.16u as=0.1406p ps=1.12u w=0.74u l=0.6u
X434 a_16408_1044# a_15837_1842# VDD.t1079 VDD.t0 sg13_lv_pmos ad=0.2128p pd=1.5u as=0.3808p ps=2.92u w=1.12u l=0.13u
X435 VDD.t368 a_3747_3892.t9 a_6711_3853# VDD.t9 sg13_lv_pmos ad=0.3808p pd=2.92u as=0.3808p ps=2.92u w=1.12u l=0.13u
X436 a_26151_14024# a_25913_14024# a_26043_14024# VSS.t1886 sg13_lv_nmos ad=0.1406p pd=1.12u as=0.2516p ps=2.16u w=0.74u l=0.2u
X437 VDD.t283 VSS.t656 VDD.t281 VDD.t36 sg13_lv_pmos ad=0.19p pd=1.38u as=0 ps=0 w=1u l=1u
X438 a_19550_1044# a_3747_1047.t4 a_21835_1044# VSS.t1000 sg13_lv_nmos ad=0.2516p pd=2.16u as=0.1406p ps=1.12u w=0.74u l=0.13u
X439 a_7673_4687# a_7477_4687# VSS.t127 VSS.t2095 sg13_lv_nmos ad=0.2516p pd=2.16u as=0.1406p ps=1.12u w=0.74u l=0.13u
X440 VDD.t54 VSS.t610 VDD.t53 VDD.t20 sg13_lv_pmos ad=0.19p pd=1.38u as=0 ps=0 w=1u l=1u
X441 a_18795_16071# a_18585_16071# VDD.t709 VDD.t20 sg13_lv_pmos ad=0.2128p pd=1.5u as=0.252p ps=1.57u w=1.12u l=0.13u
X442 VSS.t1749 a_2019_6737.t6 a_13444_6698# VSS.t1748 sg13_lv_nmos ad=0.2516p pd=2.16u as=0.2516p ps=2.16u w=0.74u l=0.13u
X443 a_11848_6734# a_11277_7532# VDD.t425 VDD.t29 sg13_lv_pmos ad=0.2128p pd=1.5u as=0.3808p ps=2.92u w=1.12u l=0.13u
X444 a_3171_311.t0 a_2873_331# VDD.t545 VDD.t0 sg13_lv_pmos ad=0.2128p pd=1.5u as=0.1918p ps=1.5u w=1.12u l=0.13u
X445 VSS.t383 a_4187_1764.t11 a_20831_1842# VSS.t465 sg13_lv_nmos ad=0.2516p pd=2.16u as=0.1406p ps=1.12u w=0.74u l=0.6u
X446 a_14513_16869# a_14317_16869# VSS.t1196 VSS.t1195 sg13_lv_nmos ad=0.2516p pd=2.16u as=0.1406p ps=1.12u w=0.74u l=0.13u
X447 a_13880_10808# a_13592_11113# a_13818_10808# VSS.t1018 sg13_lv_nmos ad=0.1428p pd=1.52u as=37.8f ps=0.6u w=0.42u l=0.13u
X448 a_23111_8160# a_22873_7532# a_23003_7532# VDD.t341 sg13_lv_pmos ad=0.2128p pd=1.5u as=0.3808p ps=2.92u w=1.12u l=0.2u
X449 a_14235_16071# a_14025_16071# VDD.t708 VDD.t20 sg13_lv_pmos ad=0.2128p pd=1.5u as=0.252p ps=1.57u w=1.12u l=0.13u
X450 VDD.t132 VSS.t100 VDD.t131 VDD.t9 sg13_lv_pmos ad=0.34p pd=2.68u as=0 ps=0 w=1u l=1u
X451 VDD.t975 a_1544_3134# a_2297_3176# VDD.t9 sg13_lv_pmos ad=0.1918p pd=1.5u as=0.1596p ps=1.22u w=0.84u l=0.13u
X452 a_26151_5315# a_25913_4687# a_26043_4687# VDD.t339 sg13_lv_pmos ad=0.2128p pd=1.5u as=0.3808p ps=2.92u w=1.12u l=0.2u
X453 a_3747_311.t0 a_3449_331# VDD.t1168 VDD.t0 sg13_lv_pmos ad=0.2128p pd=1.5u as=0.1918p ps=1.5u w=1.12u l=0.13u
X454 VDD.t414 a_17683_7532# a_18117_7532# VDD.t341 sg13_lv_pmos ad=0.2128p pd=1.5u as=0.3808p ps=2.92u w=1.12u l=0.13u
X455 a_7390_1044# a_9751_1008# a_9675_1044# VDD.t0 sg13_lv_pmos ad=0.3808p pd=2.92u as=0.2128p ps=1.5u w=1.12u l=0.13u
X456 a_16510_16071# a_2019_16074.t5 a_16408_16071# VSS.t1848 sg13_lv_nmos ad=0.2516p pd=2.16u as=0.1406p ps=1.12u w=0.74u l=0.13u
X457 a_25528_16071# a_24957_16869# VDD.t1578 VDD.t20 sg13_lv_pmos ad=0.2128p pd=1.5u as=0.3808p ps=2.92u w=1.12u l=0.13u
X458 a_10713_7532# a_10517_7532# VDD.t525 VDD.t341 sg13_lv_pmos ad=0.3808p pd=2.92u as=0.2128p ps=1.5u w=1.12u l=0.13u
X459 VSS.t1805 a_19637_4687# a_20105_3889# VSS.t1804 sg13_lv_nmos ad=0.1665p pd=1.19u as=0.2516p ps=2.16u w=0.74u l=0.13u
X460 a_13470_13226# a_2019_13229.t6 a_13368_13226# VSS.t147 sg13_lv_nmos ad=0.2516p pd=2.16u as=0.1406p ps=1.12u w=0.74u l=0.13u
X461 VSS.t1029 a_22677_1842# a_23145_1044# VSS.t2055 sg13_lv_nmos ad=0.1665p pd=1.19u as=0.2516p ps=2.16u w=0.74u l=0.13u
X462 VSS.t501 a_4187_1764.t55 a_11711_4687# VSS.t1642 sg13_lv_nmos ad=0.2516p pd=2.16u as=0.1406p ps=1.12u w=0.74u l=0.6u
X463 a_13753_4687# a_13557_4687# VDD.t1252 VDD.t339 sg13_lv_pmos ad=0.3808p pd=2.92u as=0.2128p ps=1.5u w=1.12u l=0.13u
X464 VDD.t938 a_19963_16869# a_20397_16869# VDD.t365 sg13_lv_pmos ad=0.2128p pd=1.5u as=0.3808p ps=2.92u w=1.12u l=0.13u
X465 a_4871_5315# a_4633_4687# a_4763_4687# VDD.t339 sg13_lv_pmos ad=0.2128p pd=1.5u as=0.3808p ps=2.92u w=1.12u l=0.2u
X466 a_26673_7532# a_26477_7532# VSS.t1816 VSS.t1815 sg13_lv_nmos ad=0.2516p pd=2.16u as=0.1406p ps=1.12u w=0.74u l=0.13u
X467 a_10191_1842# a_9953_1842# a_10083_1842# VSS.t1352 sg13_lv_nmos ad=0.1406p pd=1.12u as=0.2516p ps=2.16u w=0.74u l=0.2u
X468 VDD.t1414 a_1721_13577# a_2019_13229.t0 VDD.t36 sg13_lv_pmos ad=0.4256p pd=3u as=0.2128p ps=1.5u w=1.12u l=0.13u
X469 a_16108_12471# a_2019_12493.t2 a_16510_13226# VSS.t2092 sg13_lv_nmos ad=0.2516p pd=2.16u as=0.2516p ps=2.16u w=0.74u l=0.13u
X470 a_14751_2470# a_14513_1842# a_14643_1842# VDD.t353 sg13_lv_pmos ad=0.2128p pd=1.5u as=0.3808p ps=2.92u w=1.12u l=0.2u
X471 VSS.t665 VDD.t1680 VSS.t665 VSS.t670 sg13_lv_nmos ad=79.8f pd=0.8u as=0 ps=0 w=0.42u l=1u
X472 a_5731_289# a_8745_519# a_7390_1044# VDD.t0 sg13_lv_pmos ad=0.3808p pd=2.92u as=0.3808p ps=2.92u w=1.12u l=0.13u
X473 VSS.t139 a_21483_4687# a_21917_4687# VSS.t1401 sg13_lv_nmos ad=0.1406p pd=1.12u as=0.2516p ps=2.16u w=0.74u l=0.13u
X474 VDD.t1247 a_7803_7532# a_8237_7532# VDD.t341 sg13_lv_pmos ad=0.2128p pd=1.5u as=0.3808p ps=2.92u w=1.12u l=0.13u
X475 VDD.t42 VSS.t702 VDD.t41 VDD.t29 sg13_lv_pmos ad=0.34p pd=2.68u as=0 ps=0 w=1u l=1u
X476 VDD.t662 VDD.t660 VDD.t658 VDD.t353 sg13_lv_pmos ad=0.2128p pd=1.5u as=0 ps=0 w=1.12u l=0.13u
X477 VSS.t687 VDD.t1672 VSS.t687 VSS.t689 sg13_lv_nmos ad=0.1428p pd=1.52u as=0 ps=0 w=0.42u l=1u
X478 a_4248_6734# a_4157_7003# VSS.t1032 VSS.t1031 sg13_lv_nmos ad=0.1406p pd=1.12u as=0.2516p ps=2.16u w=0.74u l=0.13u
X479 VSS.t1409 a_1721_4240# a_2019_3892.t1 VSS.t1516 sg13_lv_nmos ad=0.2812p pd=2.24u as=0.1406p ps=1.12u w=0.74u l=0.13u
X480 VDD.t692 a_8563_14024# a_8997_14024# VDD.t381 sg13_lv_pmos ad=0.2128p pd=1.5u as=0.3808p ps=2.92u w=1.12u l=0.13u
X481 a_4111_2470# CHAN3_DELAY_IN a_4003_1842# VDD.t353 sg13_lv_pmos ad=0.2128p pd=1.5u as=0.3808p ps=2.92u w=1.12u l=0.2u
X482 VDD.t458 a_24523_4687# a_24957_4687# VDD.t339 sg13_lv_pmos ad=0.2128p pd=1.5u as=0.3808p ps=2.92u w=1.12u l=0.13u
X483 a_2019_12493.t1 a_1721_12513# VSS.t1229 VSS.t1795 sg13_lv_nmos ad=0.1406p pd=1.12u as=0.1331p ps=1.12u w=0.74u l=0.13u
X484 VSS.t18 a_4187_1764.t94 a_6391_7532# VSS.t542 sg13_lv_nmos ad=0.2516p pd=2.16u as=0.1406p ps=1.12u w=0.74u l=0.6u
X485 a_16510_3889# a_2595_3892.t5 a_17275_3889# VSS.t1478 sg13_lv_nmos ad=0.2516p pd=2.16u as=0.1406p ps=1.12u w=0.74u l=0.13u
X486 a_22590_16071# a_22564_16035# a_22488_16071# VDD.t20 sg13_lv_pmos ad=0.3808p pd=2.92u as=0.2128p ps=1.5u w=1.12u l=0.13u
X487 VSS.t2027 a_2297_16422# a_2595_16074.t1 VSS.t2028 sg13_lv_nmos ad=0.2812p pd=2.24u as=0.1406p ps=1.12u w=0.74u l=0.13u
X488 a_3171_12493.t0 a_2873_12513# VDD.t988 VDD.t36 sg13_lv_pmos ad=0.2128p pd=1.5u as=0.1918p ps=1.5u w=1.12u l=0.13u
X489 VSS.t739 VDD.t1651 VSS.t739 VSS.t741 sg13_lv_nmos ad=79.8f pd=0.8u as=0 ps=0 w=0.42u l=1u
X490 a_16408_16071# a_15837_16869# VDD.t1225 VDD.t20 sg13_lv_pmos ad=0.2128p pd=1.5u as=0.3808p ps=2.92u w=1.12u l=0.13u
X491 a_15511_16869# a_15273_16869# a_15403_16869# VSS.t1991 sg13_lv_nmos ad=0.1406p pd=1.12u as=0.2516p ps=2.16u w=0.74u l=0.2u
X492 a_19550_6734# a_3747_6737.t4 a_21835_6734# VSS.t1769 sg13_lv_nmos ad=0.2516p pd=2.16u as=0.1406p ps=1.12u w=0.74u l=0.13u
X493 a_7673_1842# a_7477_1842# VSS.t1324 VSS.t1560 sg13_lv_nmos ad=0.2516p pd=2.16u as=0.1406p ps=1.12u w=0.74u l=0.13u
X494 VDD.t393 a_19637_7532# a_20105_6734# VDD.t29 sg13_lv_pmos ad=0.252p pd=1.57u as=0.3808p ps=2.92u w=1.12u l=0.13u
X495 VDD.t505 a_3171_1047.t5 a_18004_1008# VDD.t0 sg13_lv_pmos ad=0.3808p pd=2.92u as=0.3808p ps=2.92u w=1.12u l=0.13u
X496 VSS.t67 a_3747_3892.t2 a_27991_3853# VSS.t66 sg13_lv_nmos ad=0.2516p pd=2.16u as=0.2516p ps=2.16u w=0.74u l=0.13u
X497 VSS.t203 CHAN1_MUX_SEL1 a_3543_13577# VSS.t202 sg13_lv_nmos ad=0.1331p pd=1.12u as=0.1216p ps=1.02u w=0.64u l=0.13u
X498 VSS.t456 a_4187_1764.t147 a_16271_16869# VSS.t455 sg13_lv_nmos ad=0.2516p pd=2.16u as=0.1406p ps=1.12u w=0.74u l=0.6u
X499 a_26673_14024# a_26477_14024# VSS.t429 VSS.t428 sg13_lv_nmos ad=0.2516p pd=2.16u as=0.1406p ps=1.12u w=0.74u l=0.13u
X500 VDD.t585 a_2019_13229.t7 a_10404_13190# VDD.t36 sg13_lv_pmos ad=0.3808p pd=2.92u as=0.3808p ps=2.92u w=1.12u l=0.13u
X501 VDD.t1078 a_13123_1842# a_13557_1842# VDD.t353 sg13_lv_pmos ad=0.2128p pd=1.5u as=0.3808p ps=2.92u w=1.12u l=0.13u
X502 VSS.t1609 a_4187_1764.t75 a_20831_7532# VSS.t2370 sg13_lv_nmos ad=0.2516p pd=2.16u as=0.1406p ps=1.12u w=0.74u l=0.6u
X503 VDD.t1011 a_16851_15336# CHAN0_MUX_OUT VDD.t20 sg13_lv_pmos ad=0.7336p pd=3.55u as=0.2128p ps=1.5u w=1.12u l=0.13u
X504 VDD.t533 a_3747_311.t2 a_26985_519# VDD.t0 sg13_lv_pmos ad=0.3808p pd=2.92u as=0.3808p ps=2.92u w=1.12u l=0.13u
X505 VDD.t905 a_4187_2434# a_27671_5315# VDD.t339 sg13_lv_pmos ad=0.3808p pd=2.92u as=0.2128p ps=1.5u w=1.12u l=0.6u
X506 VSS.t656 VDD.t1686 VSS.t656 VSS.t657 sg13_lv_nmos ad=79.8f pd=0.8u as=0 ps=0 w=0.42u l=1u
X507 a_7390_3889# a_7364_3853# a_7288_3889# VDD.t9 sg13_lv_pmos ad=0.3808p pd=2.92u as=0.2128p ps=1.5u w=1.12u l=0.13u
X508 a_16510_16071# a_17351_16035# a_17275_16071# VDD.t20 sg13_lv_pmos ad=0.3808p pd=2.92u as=0.2128p ps=1.5u w=1.12u l=0.13u
X509 a_10430_1044# a_3747_1047.t7 a_12715_1044# VSS.t998 sg13_lv_nmos ad=0.2516p pd=2.16u as=0.1406p ps=1.12u w=0.74u l=0.13u
X510 VSS.t64 a_3747_3892.t9 a_6711_3853# VSS.t63 sg13_lv_nmos ad=0.2516p pd=2.16u as=0.2516p ps=2.16u w=0.74u l=0.13u
X511 a_25913_1842# a_25717_1842# VDD.t1456 VDD.t353 sg13_lv_pmos ad=0.3808p pd=2.92u as=0.2128p ps=1.5u w=1.12u l=0.13u
X512 VSS.t656 VDD.t1683 VSS.t656 VSS.t662 sg13_lv_nmos ad=0.1428p pd=1.52u as=0 ps=0 w=0.42u l=1u
X513 VSS.t881 VSS.t883 VSS.t883 VSS.t884 sg13_lv_nmos ad=0.1406p pd=1.12u as=0 ps=0 w=0.74u l=0.2u
X514 a_24875_1044# a_24665_1044# VSS.t1629 VSS.t1628 sg13_lv_nmos ad=0.1406p pd=1.12u as=0.1665p ps=1.19u w=0.74u l=0.13u
X515 a_14235_1044# a_14025_1044# VDD.t672 VDD.t0 sg13_lv_pmos ad=0.2128p pd=1.5u as=0.252p ps=1.57u w=1.12u l=0.13u
X516 a_25391_4687# a_25153_4687# a_25283_4687# VSS.t340 sg13_lv_nmos ad=0.1406p pd=1.12u as=0.2516p ps=2.16u w=0.74u l=0.2u
X517 VSS.t1253 a_22677_7532# a_23145_6734# VSS.t1252 sg13_lv_nmos ad=0.1665p pd=1.19u as=0.2516p ps=2.16u w=0.74u l=0.13u
X518 VDD.t579 a_19963_14024# a_20397_14024# VDD.t381 sg13_lv_pmos ad=0.2128p pd=1.5u as=0.3808p ps=2.92u w=1.12u l=0.13u
X519 VSS.t1586 a_4187_1764.t98 VSS.t1584 VSS.t1569 sg13_lv_nmos ad=1.33p pd=7.38u as=0 ps=0 w=7u l=7u
X520 VSS.t1110 a_4187_1764.t23 a_11711_1842# VSS.t1109 sg13_lv_nmos ad=0.2516p pd=2.16u as=0.1406p ps=1.12u w=0.74u l=0.6u
X521 a_10191_7532# a_9953_7532# a_10083_7532# VSS.t292 sg13_lv_nmos ad=0.1406p pd=1.12u as=0.2516p ps=2.16u w=0.74u l=0.2u
X522 VDD.t407 a_1256_6734# a_2873_7085# VDD.t29 sg13_lv_pmos ad=0.1918p pd=1.5u as=0.1596p ps=1.22u w=0.84u l=0.13u
X523 VSS.t1304 a_2595_1047.t3 a_23431_1008# VSS.t1722 sg13_lv_nmos ad=0.2516p pd=2.16u as=0.2516p ps=2.16u w=0.74u l=0.13u
X524 VDD.t688 a_3747_1047.t7 a_12791_1008# VDD.t0 sg13_lv_pmos ad=0.3808p pd=2.92u as=0.3808p ps=2.92u w=1.12u l=0.13u
X525 VDD.t699 a_12849_11557# a_13566_11018# VDD.t351 sg13_lv_pmos ad=0.1563p pd=1.22u as=0.147p ps=1.54u w=0.42u l=0.13u
X526 a_4350_13226# a_5191_13190# a_5115_13226# VDD.t36 sg13_lv_pmos ad=0.3808p pd=2.92u as=0.2128p ps=1.5u w=1.12u l=0.13u
X527 a_14751_8160# a_14513_7532# a_14643_7532# VDD.t341 sg13_lv_pmos ad=0.2128p pd=1.5u as=0.3808p ps=2.92u w=1.12u l=0.2u
X528 a_12993_4687# a_12797_4687# VSS.t23 VSS.t1780 sg13_lv_nmos ad=0.2516p pd=2.16u as=0.1406p ps=1.12u w=0.74u l=0.13u
X529 VSS.t451 a_18443_16869# a_18877_16869# VSS.t450 sg13_lv_nmos ad=0.1406p pd=1.12u as=0.2516p ps=2.16u w=0.74u l=0.13u
X530 a_2595_3892.t0 a_2297_4240# VDD.t1052 VDD.t9 sg13_lv_pmos ad=0.2128p pd=1.5u as=0.1918p ps=1.5u w=1.12u l=0.13u
X531 VDD.t249 VSS.t687 VDD.t248 VDD.t29 sg13_lv_pmos ad=0.34p pd=2.68u as=0 ps=0 w=1u l=1u
X532 a_16510_6734# a_17351_6698# a_17275_6734# VDD.t29 sg13_lv_pmos ad=0.3808p pd=2.92u as=0.2128p ps=1.5u w=1.12u l=0.13u
X533 VSS.t2058 a_21483_1842# a_21917_1842# VSS.t2057 sg13_lv_nmos ad=0.1406p pd=1.12u as=0.2516p ps=2.16u w=0.74u l=0.13u
X534 a_20315_16071# a_20105_16071# VSS.t2036 VSS.t2035 sg13_lv_nmos ad=0.1406p pd=1.12u as=0.1665p ps=1.19u w=0.74u l=0.13u
X535 VDD.t587 a_3171_15338.t3 a_11785_15546# VDD.t20 sg13_lv_pmos ad=0.3808p pd=2.92u as=0.3808p ps=2.92u w=1.12u l=0.13u
X536 VDD.t640 VDD.t638 VDD.t636 VDD.t341 sg13_lv_pmos ad=0.2128p pd=1.5u as=0 ps=0 w=1.12u l=0.13u
X537 VSS.t851 a_13557_1842# a_14025_1044# VSS.t1677 sg13_lv_nmos ad=0.1665p pd=1.19u as=0.2516p ps=2.16u w=0.74u l=0.13u
X538 VDD.t293 VSS.t745 VDD.t292 VDD.t9 sg13_lv_pmos ad=0.34p pd=2.68u as=0 ps=0 w=1u l=1u
X539 a_2595_15338.t0 a_2297_15358# VDD.t1452 VDD.t20 sg13_lv_pmos ad=0.2128p pd=1.5u as=0.1918p ps=1.5u w=1.12u l=0.13u
X540 a_2595_15338.t1 a_2297_15358# VSS.t2118 VSS.t2023 sg13_lv_nmos ad=0.1406p pd=1.12u as=0.1331p ps=1.12u w=0.74u l=0.13u
X541 a_17928_13226# a_17357_14024# VSS.t241 VSS.t1013 sg13_lv_nmos ad=0.1406p pd=1.12u as=0.2516p ps=2.16u w=0.74u l=0.13u
X542 a_4111_8160# REF_CLK a_4003_7532# VDD.t341 sg13_lv_pmos ad=0.2128p pd=1.5u as=0.3808p ps=2.92u w=1.12u l=0.2u
X543 a_11848_1044# a_11277_1842# VDD.t521 VDD.t0 sg13_lv_pmos ad=0.2128p pd=1.5u as=0.3808p ps=2.92u w=1.12u l=0.13u
X544 VDD.t455 a_5523_16869# a_5957_16869# VDD.t365 sg13_lv_pmos ad=0.2128p pd=1.5u as=0.3808p ps=2.92u w=1.12u l=0.13u
X545 VSS.t52 a_4187_1764.t52 a_13991_4687# VSS.t1723 sg13_lv_nmos ad=0.2516p pd=2.16u as=0.1406p ps=1.12u w=0.74u l=0.6u
X546 a_16033_4687# a_15837_4687# VDD.t1033 VDD.t339 sg13_lv_pmos ad=0.3808p pd=2.92u as=0.2128p ps=1.5u w=1.12u l=0.13u
X547 VDD.t1227 a_3747_6737.t2 a_27991_6698# VDD.t29 sg13_lv_pmos ad=0.3808p pd=2.92u as=0.3808p ps=2.92u w=1.12u l=0.13u
X548 a_7151_5315# a_6913_4687# a_7043_4687# VDD.t339 sg13_lv_pmos ad=0.2128p pd=1.5u as=0.3808p ps=2.92u w=1.12u l=0.2u
X549 a_1721_4240# a_1256_3889# VDD.t1371 VDD.t9 sg13_lv_pmos ad=0.1596p pd=1.22u as=0.2856p ps=2.36u w=0.84u l=0.13u
X550 VDD.t19 VSS.t839 VDD.t18 VDD.t0 sg13_lv_pmos ad=0.19p pd=1.38u as=0 ps=0 w=1u l=1u
X551 a_27671_14024# a_27433_14024# a_27563_14024# VSS.t381 sg13_lv_nmos ad=0.1406p pd=1.12u as=0.2516p ps=2.16u w=0.74u l=0.2u
X552 VDD.t1226 a_3747_6737.t9 a_6711_6698# VDD.t29 sg13_lv_pmos ad=0.3808p pd=2.92u as=0.3808p ps=2.92u w=1.12u l=0.13u
X553 VSS.t1198 a_23763_4687# a_24197_4687# VSS.t1654 sg13_lv_nmos ad=0.1406p pd=1.12u as=0.2516p ps=2.16u w=0.74u l=0.13u
X554 a_7673_7532# a_7477_7532# VSS.t296 VSS.t295 sg13_lv_nmos ad=0.2516p pd=2.16u as=0.1406p ps=1.12u w=0.74u l=0.13u
X555 a_25630_13226# a_25604_13190# a_25528_13226# VDD.t36 sg13_lv_pmos ad=0.3808p pd=2.92u as=0.2128p ps=1.5u w=1.12u l=0.13u
X556 VSS.t730 VDD.t1655 VSS.t730 VSS.t731 sg13_lv_nmos ad=79.8f pd=0.8u as=0 ps=0 w=0.42u l=1u
X557 a_19448_13226# a_18877_14024# VDD.t1585 VDD.t36 sg13_lv_pmos ad=0.2128p pd=1.5u as=0.3808p ps=2.92u w=1.12u l=0.13u
X558 VDD.t185 VSS.t462 VDD.t184 VDD.t36 sg13_lv_pmos ad=0.34p pd=2.68u as=0 ps=0 w=1u l=1u
X559 a_15755_16071# a_15545_16071# VDD.t508 VDD.t20 sg13_lv_pmos ad=0.2128p pd=1.5u as=0.252p ps=1.57u w=1.12u l=0.13u
X560 VDD.t722 a_13123_7532# a_13557_7532# VDD.t341 sg13_lv_pmos ad=0.2128p pd=1.5u as=0.3808p ps=2.92u w=1.12u l=0.13u
X561 a_11473_16869# a_11277_16869# VSS.t59 VSS.t58 sg13_lv_nmos ad=0.2516p pd=2.16u as=0.1406p ps=1.12u w=0.74u l=0.13u
X562 a_25913_7532# a_25717_7532# VDD.t1449 VDD.t341 sg13_lv_pmos ad=0.3808p pd=2.92u as=0.2128p ps=1.5u w=1.12u l=0.13u
X563 a_10430_6734# a_3747_6737.t7 a_12715_6734# VSS.t1767 sg13_lv_nmos ad=0.2516p pd=2.16u as=0.1406p ps=1.12u w=0.74u l=0.13u
X564 a_13470_13226# a_3171_13229.t6 a_14888_13226# VSS.t2014 sg13_lv_nmos ad=0.2516p pd=2.16u as=0.1406p ps=1.12u w=0.74u l=0.13u
X565 VSS.t1756 a_4187_1764.t35 a_26911_4687# VSS.t1859 sg13_lv_nmos ad=0.2516p pd=2.16u as=0.1406p ps=1.12u w=0.74u l=0.6u
X566 VDD.t681 a_21483_16869# a_21917_16869# VDD.t365 sg13_lv_pmos ad=0.2128p pd=1.5u as=0.3808p ps=2.92u w=1.12u l=0.13u
X567 VDD.t159 VSS.t643 VDD.t157 VDD.t36 sg13_lv_pmos ad=0.19p pd=1.38u as=0 ps=0 w=1u l=1u
X568 a_24875_6734# a_24665_6734# VSS.t972 VSS.t971 sg13_lv_nmos ad=0.1406p pd=1.12u as=0.1665p ps=1.19u w=0.74u l=0.13u
X569 a_25391_1842# a_25153_1842# a_25283_1842# VSS.t2084 sg13_lv_nmos ad=0.1406p pd=1.12u as=0.2516p ps=2.16u w=0.74u l=0.2u
X570 a_13470_16071# a_2019_16074.t6 a_13368_16071# VSS.t105 sg13_lv_nmos ad=0.2516p pd=2.16u as=0.1406p ps=1.12u w=0.74u l=0.13u
X571 VSS.t1576 a_4187_1764.t98 VSS.t1578 VSS.t1577 sg13_lv_nmos ad=1.33p pd=7.38u as=0 ps=0 w=7u l=7u
X572 a_6326_10280# a_5974_11413# a_6126_9506# VSS.t959 sg13_lv_nmos ad=0.38p pd=2.38u as=0.68p ps=4.68u w=2u l=1u
X573 VSS.t1140 a_4187_1764.t87 a_11711_7532# VSS.t2380 sg13_lv_nmos ad=0.2516p pd=2.16u as=0.1406p ps=1.12u w=0.74u l=0.6u
X574 VDD.t964 a_5523_4687# a_5957_4687# VDD.t339 sg13_lv_pmos ad=0.2128p pd=1.5u as=0.3808p ps=2.92u w=1.12u l=0.13u
X575 a_10430_13226# a_2019_13229.t7 a_10328_13226# VSS.t548 sg13_lv_nmos ad=0.2516p pd=2.16u as=0.1406p ps=1.12u w=0.74u l=0.13u
X576 VSS.t872 a_12849_11557# a_13400_11995# VSS.t1183 sg13_lv_nmos ad=0.1626p pd=1.415u as=60.89999f ps=0.71u w=0.42u l=0.13u
X577 VSS.t1365 a_2595_6737.t3 a_23431_6698# VSS.t1377 sg13_lv_nmos ad=0.2516p pd=2.16u as=0.2516p ps=2.16u w=0.74u l=0.13u
X578 VDD.t1123 a_2019_3892.t4 a_19524_3853# VDD.t9 sg13_lv_pmos ad=0.3808p pd=2.92u as=0.3808p ps=2.92u w=1.12u l=0.13u
X579 a_12993_1842# a_12797_1842# VSS.t1501 VSS.t1500 sg13_lv_nmos ad=0.2516p pd=2.16u as=0.1406p ps=1.12u w=0.74u l=0.13u
X580 VDD.t86 VSS.t730 VDD.t85 VDD.t9 sg13_lv_pmos ad=0.34p pd=2.68u as=0 ps=0 w=1u l=1u
X581 a_7390_3889# a_2019_3892.t8 a_7288_3889# VSS.t1904 sg13_lv_nmos ad=0.2516p pd=2.16u as=0.1406p ps=1.12u w=0.74u l=0.13u
X582 VSS.t14 a_21483_7532# a_21917_7532# VSS.t2280 sg13_lv_nmos ad=0.1406p pd=1.12u as=0.2516p ps=2.16u w=0.74u l=0.13u
X583 a_5731_12471# a_3747_12493.t3 a_13470_13226# VSS.t194 sg13_lv_nmos ad=0.2516p pd=2.16u as=0.2516p ps=2.16u w=0.74u l=0.13u
X584 VSS.t1118 a_13557_7532# a_14025_6734# VSS.t1117 sg13_lv_nmos ad=0.1665p pd=1.19u as=0.2516p ps=2.16u w=0.74u l=0.13u
X585 VDD.t6 VSS.t841 VDD.t5 VDD.t0 sg13_lv_pmos ad=0.34p pd=2.68u as=0 ps=0 w=1u l=1u
X586 a_3543_3176# CHAN2_MUX_SEL2 a_3449_3176# VSS.t1598 sg13_lv_nmos ad=0.1216p pd=1.02u as=0.2176p ps=1.96u w=0.64u l=0.13u
X587 a_16108_5979# a_3171_6001.t2 a_22590_6734# VSS.t394 sg13_lv_nmos ad=0.2516p pd=2.16u as=0.2516p ps=2.16u w=0.74u l=0.13u
X588 a_2873_15358# CHAN0_MUX_SEL3 VDD.t483 VDD.t20 sg13_lv_pmos ad=0.1596p pd=1.22u as=0.2856p ps=2.36u w=0.84u l=0.13u
X589 a_16510_13226# a_16484_13190# a_16408_13226# VDD.t36 sg13_lv_pmos ad=0.3808p pd=2.92u as=0.2128p ps=1.5u w=1.12u l=0.13u
X590 CHAN3_DELAY_OUT_LAST a_27997_1842# VDD.t530 VDD.t353 sg13_lv_pmos ad=0.3808p pd=2.92u as=0.2128p ps=1.5u w=1.12u l=0.13u
X591 VSS.t525 a_4187_1764.t111 a_19311_14024# VSS.t2148 sg13_lv_nmos ad=0.2516p pd=2.16u as=0.1406p ps=1.12u w=0.74u l=0.6u
X592 VDD.t421 a_19637_1842# a_20105_1044# VDD.t0 sg13_lv_pmos ad=0.252p pd=1.57u as=0.3808p ps=2.92u w=1.12u l=0.13u
X593 VSS.t624 VDD.t1696 VSS.t624 VSS.t623 sg13_lv_nmos ad=0.1428p pd=1.52u as=0 ps=0 w=0.42u l=1u
X594 a_19550_13226# a_2595_13229.t4 a_20315_13226# VSS.t1686 sg13_lv_nmos ad=0.2516p pd=2.16u as=0.1406p ps=1.12u w=0.74u l=0.13u
X595 VSS.t1413 a_5957_14024# a_6425_13226# VSS.t1412 sg13_lv_nmos ad=0.1665p pd=1.19u as=0.2516p ps=2.16u w=0.74u l=0.13u
X596 a_22590_1044# a_3171_1047.t3 a_24008_1044# VSS.t1302 sg13_lv_nmos ad=0.2516p pd=2.16u as=0.1406p ps=1.12u w=0.74u l=0.13u
X597 a_15755_3889# a_15545_3889# VDD.t1343 VDD.t9 sg13_lv_pmos ad=0.2128p pd=1.5u as=0.252p ps=1.57u w=1.12u l=0.13u
X598 VSS.t825 VDD.t1624 VSS.t825 VSS.t824 sg13_lv_nmos ad=0.1428p pd=1.52u as=0 ps=0 w=0.42u l=1u
X599 VDD.t771 a_4187_2434# a_8671_5315# VDD.t339 sg13_lv_pmos ad=0.3808p pd=2.92u as=0.2128p ps=1.5u w=1.12u l=0.6u
X600 VDD.t1013 a_5523_14024# a_5957_14024# VDD.t381 sg13_lv_pmos ad=0.2128p pd=1.5u as=0.3808p ps=2.92u w=1.12u l=0.13u
X601 VDD.t758 a_2297_12513# a_2595_12493.t0 VDD.t36 sg13_lv_pmos ad=0.4256p pd=3u as=0.2128p ps=1.5u w=1.12u l=0.13u
X602 a_12943_11557# a_12656_11554# a_12849_11557# VDD.t351 sg13_lv_pmos ad=0.2128p pd=1.5u as=0.3808p ps=2.92u w=1.12u l=0.13u
X603 VSS.t1326 a_4187_1764.t20 a_13991_1842# VSS.t1355 sg13_lv_nmos ad=0.2516p pd=2.16u as=0.1406p ps=1.12u w=0.74u l=0.6u
X604 VSS.t2160 a_13121_11521# a_6854_11676# VDD.t360 sg13_lv_pmos ad=0.232p pd=2.08u as=0.136p ps=1.14u w=0.4u l=0.2u
X605 VDD.t1389 a_1544_16071# a_2297_16422# VDD.t20 sg13_lv_pmos ad=0.1918p pd=1.5u as=0.1596p ps=1.22u w=0.84u l=0.13u
X606 a_6913_1842# a_6717_1842# VDD.t486 VDD.t353 sg13_lv_pmos ad=0.3808p pd=2.92u as=0.2128p ps=1.5u w=1.12u l=0.13u
X607 VDD.t1215 a_2595_3892.t6 a_14311_3853# VDD.t9 sg13_lv_pmos ad=0.3808p pd=2.92u as=0.3808p ps=2.92u w=1.12u l=0.13u
X608 VDD.t907 a_4187_2434# a_18551_2470# VDD.t353 sg13_lv_pmos ad=0.3808p pd=2.92u as=0.2128p ps=1.5u w=1.12u l=0.6u
X609 VSS.t769 VDD.t1639 VSS.t769 VSS.t770 sg13_lv_nmos ad=79.8f pd=0.8u as=0 ps=0 w=0.42u l=1u
X610 a_15273_4687# a_15077_4687# VSS.t183 VSS.t2272 sg13_lv_nmos ad=0.2516p pd=2.16u as=0.1406p ps=1.12u w=0.74u l=0.13u
X611 a_17031_16869# a_16793_16869# a_16923_16869# VSS.t1207 sg13_lv_nmos ad=0.1406p pd=1.12u as=0.2516p ps=2.16u w=0.74u l=0.2u
X612 a_6391_4687# a_6153_4687# a_6283_4687# VSS.t1160 sg13_lv_nmos ad=0.1406p pd=1.12u as=0.2516p ps=2.16u w=0.74u l=0.2u
X613 a_3171_15338.t0 a_2873_15358# VDD.t1450 VDD.t20 sg13_lv_pmos ad=0.2128p pd=1.5u as=0.1918p ps=1.5u w=1.12u l=0.13u
X614 a_3171_15338.t1 a_2873_15358# VSS.t2118 VSS.t2059 sg13_lv_nmos ad=0.1406p pd=1.12u as=0.1331p ps=1.12u w=0.74u l=0.13u
X615 VSS.t374 a_23763_1842# a_24197_1842# VSS.t2079 sg13_lv_nmos ad=0.1406p pd=1.12u as=0.2516p ps=2.16u w=0.74u l=0.13u
X616 a_5115_3889# a_4905_3889# VDD.t1147 VDD.t9 sg13_lv_pmos ad=0.2128p pd=1.5u as=0.252p ps=1.57u w=1.12u l=0.13u
X617 VDD.t619 VDD.t617 VDD.t448 VDD.t351 sg13_lv_pmos ad=0.38p pd=2.38u as=0 ps=0 w=2u l=1u
X618 VSS.t798 VDD.t1631 VSS.t797 VSS.t796 sg13_lv_nmos ad=0.1428p pd=1.52u as=0 ps=0 w=0.42u l=1u
X619 a_13368_16071# a_12797_16869# VDD.t678 VDD.t20 sg13_lv_pmos ad=0.2128p pd=1.5u as=0.3808p ps=2.92u w=1.12u l=0.13u
X620 a_12471_16869# a_12233_16869# a_12363_16869# VSS.t1472 sg13_lv_nmos ad=0.1406p pd=1.12u as=0.2516p ps=2.16u w=0.74u l=0.2u
X621 VSS.t1054 a_4187_1764.t145 a_17791_16869# VSS.t1336 sg13_lv_nmos ad=0.2516p pd=2.16u as=0.1406p ps=1.12u w=0.74u l=0.6u
X622 VDD.t752 a_1256_1044# a_2873_1395# VDD.t0 sg13_lv_pmos ad=0.1918p pd=1.5u as=0.1596p ps=1.22u w=0.84u l=0.13u
X623 VDD.t357 DLL_RESETN a_10206_11525# VDD.t351 sg13_lv_pmos ad=0.1563p pd=1.22u as=0.147p ps=1.54u w=0.42u l=0.13u
X624 VSS.t330 CHAN0_MUX_SEL1 a_3543_16422# VSS.t329 sg13_lv_nmos ad=0.1331p pd=1.12u as=0.1216p ps=1.02u w=0.64u l=0.13u
X625 VDD.t1027 a_2873_331# a_3171_311.t0 VDD.t0 sg13_lv_pmos ad=0.4256p pd=3u as=0.2128p ps=1.5u w=1.12u l=0.13u
X626 VSS.t43 a_15964_5979# a_16851_5999# VSS.t42 sg13_lv_nmos ad=0.1371p pd=1.12u as=0.2176p ps=1.96u w=0.64u l=0.13u
X627 a_4111_17497# CHAN0_DELAY_IN a_4003_16869# VDD.t365 sg13_lv_pmos ad=0.2128p pd=1.5u as=0.3808p ps=2.92u w=1.12u l=0.2u
X628 VSS.t1042 a_4187_1764.t151 a_13231_16869# VSS.t2369 sg13_lv_nmos ad=0.2516p pd=2.16u as=0.1406p ps=1.12u w=0.74u l=0.6u
X629 a_23633_14024# a_23437_14024# VSS.t281 VSS.t1953 sg13_lv_nmos ad=0.2516p pd=2.16u as=0.1406p ps=1.12u w=0.74u l=0.13u
X630 VSS.t672 VDD.t1679 VSS.t672 VSS.t671 sg13_lv_nmos ad=0.1428p pd=1.52u as=0 ps=0 w=0.42u l=1u
X631 a_9712_9602# a_6854_11144# a_9444_9602# VSS.t1241 sg13_lv_nmos ad=0.38p pd=2.38u as=0.68p ps=4.68u w=2u l=1u
X632 a_3171_311.t1 a_2873_331# VSS.t435 VSS.t1366 sg13_lv_nmos ad=0.1406p pd=1.12u as=0.1331p ps=1.12u w=0.74u l=0.13u
X633 a_16510_16071# a_18871_16035# a_18795_16071# VDD.t20 sg13_lv_pmos ad=0.3808p pd=2.92u as=0.2128p ps=1.5u w=1.12u l=0.13u
X634 a_25630_1044# a_3747_1047.t2 a_27915_1044# VSS.t995 sg13_lv_nmos ad=0.2516p pd=2.16u as=0.1406p ps=1.12u w=0.74u l=0.13u
X635 a_16510_1044# a_17351_1008# a_17275_1044# VDD.t0 sg13_lv_pmos ad=0.3808p pd=2.92u as=0.2128p ps=1.5u w=1.12u l=0.13u
X636 VSS.t1015 a_16923_14024# a_17357_14024# VSS.t1821 sg13_lv_nmos ad=0.1406p pd=1.12u as=0.2516p ps=2.16u w=0.74u l=0.13u
X637 a_7390_6734# a_7364_6698# a_7288_6734# VDD.t29 sg13_lv_pmos ad=0.3808p pd=2.92u as=0.2128p ps=1.5u w=1.12u l=0.13u
X638 VDD.t1564 a_3449_331# a_3747_311.t0 VDD.t0 sg13_lv_pmos ad=0.4256p pd=3u as=0.2128p ps=1.5u w=1.12u l=0.13u
X639 a_1256_16071# CHAN0_MUX_SEL0 VDD.t1570 VDD.t20 sg13_lv_pmos ad=0.3808p pd=2.92u as=0.3808p ps=2.92u w=1.12u l=0.13u
X640 VSS.t604 VDD.t1701 VSS.t273 VSS.t605 sg13_lv_nmos ad=79.8f pd=0.8u as=0 ps=0 w=0.42u l=1u
X641 VSS.t1089 a_15403_4687# a_15837_4687# VSS.t1378 sg13_lv_nmos ad=0.1406p pd=1.12u as=0.2516p ps=2.16u w=0.74u l=0.13u
X642 a_12471_5315# a_12233_4687# a_12363_4687# VDD.t339 sg13_lv_pmos ad=0.2128p pd=1.5u as=0.3808p ps=2.92u w=1.12u l=0.2u
X643 a_13470_16071# a_14311_16035# a_14235_16071# VDD.t20 sg13_lv_pmos ad=0.3808p pd=2.92u as=0.2128p ps=1.5u w=1.12u l=0.13u
X644 VDD.t578 a_21483_14024# a_21917_14024# VDD.t381 sg13_lv_pmos ad=0.2128p pd=1.5u as=0.3808p ps=2.92u w=1.12u l=0.13u
X645 a_3747_311.t1 a_3449_331# VSS.t41 VSS.t2291 sg13_lv_nmos ad=0.1406p pd=1.12u as=0.1331p ps=1.12u w=0.74u l=0.13u
X646 VSS.t385 a_4187_1764.t3 a_26911_1842# VSS.t384 sg13_lv_nmos ad=0.2516p pd=2.16u as=0.1406p ps=1.12u w=0.74u l=0.6u
X647 VSS.t878 VSS.t875 VSS.t875 VSS.t876 sg13_lv_nmos ad=0.1406p pd=1.12u as=0 ps=0 w=0.74u l=0.13u
X648 a_25391_7532# a_25153_7532# a_25283_7532# VSS.t2156 sg13_lv_nmos ad=0.1406p pd=1.12u as=0.2516p ps=2.16u w=0.74u l=0.2u
X649 VDD.t687 a_3747_1047.t2 a_27991_1008# VDD.t0 sg13_lv_pmos ad=0.3808p pd=2.92u as=0.3808p ps=2.92u w=1.12u l=0.13u
X650 VDD.t796 a_4187_2434# a_22351_2470# VDD.t353 sg13_lv_pmos ad=0.3808p pd=2.92u as=0.2128p ps=1.5u w=1.12u l=0.6u
X651 VSS.t656 VDD.t1686 VSS.t652 VSS.t655 sg13_lv_nmos ad=0.1428p pd=1.52u as=0 ps=0 w=0.42u l=1u
X652 VDD.t40 VSS.t777 VDD.t396 VDD.t0 sg13_lv_pmos ad=0.19p pd=1.38u as=0 ps=0 w=1u l=1u
X653 VSS.t584 VDD.t1706 VSS.t587 VSS.t586 sg13_lv_nmos ad=79.8f pd=0.8u as=0 ps=0 w=0.42u l=1u
X654 VDD.t529 a_3171_16074.t8 a_8884_16035# VDD.t20 sg13_lv_pmos ad=0.3808p pd=2.92u as=0.3808p ps=2.92u w=1.12u l=0.13u
X655 a_12993_7532# a_12797_7532# VSS.t109 VSS.t1813 sg13_lv_nmos ad=0.2516p pd=2.16u as=0.1406p ps=1.12u w=0.74u l=0.13u
X656 VSS.t503 a_4763_4687# a_5197_4687# VSS.t2274 sg13_lv_nmos ad=0.1406p pd=1.12u as=0.2516p ps=2.16u w=0.74u l=0.13u
X657 VDD.t1112 a_1721_6021# a_2019_6001.t0 VDD.t29 sg13_lv_pmos ad=0.4256p pd=3u as=0.2128p ps=1.5u w=1.12u l=0.13u
X658 VSS.t1758 a_15403_16869# a_15837_16869# VSS.t1757 sg13_lv_nmos ad=0.1406p pd=1.12u as=0.2516p ps=2.16u w=0.74u l=0.13u
X659 VDD.t352 a_11491_11918# a_11748_11799# VDD.t351 sg13_lv_pmos ad=1.10612p pd=6.66u as=79.8f ps=0.8u w=0.42u l=0.13u
X660 VDD.t686 a_3747_1047.t9 a_6711_1008# VDD.t0 sg13_lv_pmos ad=0.3808p pd=2.92u as=0.3808p ps=2.92u w=1.12u l=0.13u
X661 VDD.t352 a_10649_11568# a_10751_11568# VDD.t351 sg13_lv_pmos ad=1.10612p pd=6.66u as=0.3864p ps=2.93u w=1.12u l=0.13u
X662 a_2873_12513# CHAN1_MUX_SEL3 VDD.t1243 VDD.t36 sg13_lv_pmos ad=0.1596p pd=1.22u as=0.2856p ps=2.36u w=0.84u l=0.13u
X663 REF_DELAY_OUT_LAST a_27997_7532# VDD.t993 VDD.t341 sg13_lv_pmos ad=0.3808p pd=2.92u as=0.2128p ps=1.5u w=1.12u l=0.13u
X664 VDD.t1042 a_7043_16869# a_7477_16869# VDD.t365 sg13_lv_pmos ad=0.2128p pd=1.5u as=0.3808p ps=2.92u w=1.12u l=0.13u
X665 a_17928_16071# a_17357_16869# VSS.t1854 VSS.t2150 sg13_lv_nmos ad=0.1406p pd=1.12u as=0.2516p ps=2.16u w=0.74u l=0.13u
X666 a_22590_6734# a_3171_6737.t3 a_24008_6734# VSS.t1870 sg13_lv_nmos ad=0.2516p pd=2.16u as=0.1406p ps=1.12u w=0.74u l=0.13u
X667 VSS.t305 a_2019_3892.t4 a_19524_3853# VSS.t1536 sg13_lv_nmos ad=0.2516p pd=2.16u as=0.2516p ps=2.16u w=0.74u l=0.13u
X668 VSS.t656 VDD.t1684 VSS.t656 VSS.t661 sg13_lv_nmos ad=79.8f pd=0.8u as=0 ps=0 w=0.42u l=1u
X669 a_12355_11557# a_12158_11557# VSS.t45 VSS.t489 sg13_lv_nmos ad=0.2516p pd=2.16u as=0.1406p ps=1.12u w=0.74u l=0.13u
X670 VSS.t157 a_4187_1764.t84 a_13991_7532# VSS.t156 sg13_lv_nmos ad=0.2516p pd=2.16u as=0.1406p ps=1.12u w=0.74u l=0.6u
X671 a_14513_14024# a_14317_14024# VSS.t1279 VSS.t1945 sg13_lv_nmos ad=0.2516p pd=2.16u as=0.1406p ps=1.12u w=0.74u l=0.13u
X672 VSS.t612 VDD.t1699 VSS.t614 VSS.t613 sg13_lv_nmos ad=79.8f pd=0.8u as=0 ps=0 w=0.42u l=1u
X673 a_6913_7532# a_6717_7532# VDD.t344 VDD.t341 sg13_lv_pmos ad=0.3808p pd=2.92u as=0.2128p ps=1.5u w=1.12u l=0.13u
X674 VDD.t876 a_4187_2434# a_18551_8160# VDD.t341 sg13_lv_pmos ad=0.3808p pd=2.92u as=0.2128p ps=1.5u w=1.12u l=0.6u
X675 VSS.t1510 a_4187_1764.t60 a_7911_4687# VSS.t1851 sg13_lv_nmos ad=0.2516p pd=2.16u as=0.1406p ps=1.12u w=0.74u l=0.6u
X676 VDD.t487 a_10843_4687# a_11277_4687# VDD.t339 sg13_lv_pmos ad=0.2128p pd=1.5u as=0.3808p ps=2.92u w=1.12u l=0.13u
X677 a_9953_4687# a_9757_4687# VDD.t956 VDD.t339 sg13_lv_pmos ad=0.3808p pd=2.92u as=0.2128p ps=1.5u w=1.12u l=0.13u
X678 a_20315_13226# a_20105_13226# VDD.t1436 VDD.t36 sg13_lv_pmos ad=0.2128p pd=1.5u as=0.252p ps=1.57u w=1.12u l=0.13u
X679 a_15273_1842# a_15077_1842# VSS.t1283 VSS.t1503 sg13_lv_nmos ad=0.2516p pd=2.16u as=0.1406p ps=1.12u w=0.74u l=0.13u
X680 VSS.t144 a_23763_7532# a_24197_7532# VSS.t2199 sg13_lv_nmos ad=0.1406p pd=1.12u as=0.2516p ps=2.16u w=0.74u l=0.13u
X681 a_6391_1842# a_6153_1842# a_6283_1842# VSS.t1555 sg13_lv_nmos ad=0.1406p pd=1.12u as=0.2516p ps=2.16u w=0.74u l=0.2u
X682 a_19833_1842# a_19637_1842# VDD.t1300 VDD.t353 sg13_lv_pmos ad=0.3808p pd=2.92u as=0.2128p ps=1.5u w=1.12u l=0.13u
X683 a_15755_3889# a_15545_3889# VSS.t1957 VSS.t1956 sg13_lv_nmos ad=0.1406p pd=1.12u as=0.1665p ps=1.19u w=0.74u l=0.13u
X684 VDD.t363 a_21157_4687# a_21625_3889# VDD.t9 sg13_lv_pmos ad=0.252p pd=1.57u as=0.3808p ps=2.92u w=1.12u l=0.13u
X685 VDD.t1278 a_1256_16071# a_2873_16422# VDD.t20 sg13_lv_pmos ad=0.1918p pd=1.5u as=0.1596p ps=1.22u w=0.84u l=0.13u
X686 a_12993_16869# a_12797_16869# VSS.t980 VSS.t979 sg13_lv_nmos ad=0.2516p pd=2.16u as=0.1406p ps=1.12u w=0.74u l=0.13u
X687 a_16108_289# a_23945_519# a_22590_1044# VDD.t0 sg13_lv_pmos ad=0.3808p pd=2.92u as=0.3808p ps=2.92u w=1.12u l=0.13u
X688 VSS.t1233 a_2595_3892.t6 a_14311_3853# VSS.t1739 sg13_lv_nmos ad=0.2516p pd=2.16u as=0.2516p ps=2.16u w=0.74u l=0.13u
X689 a_4111_14652# CHAN1_DELAY_IN a_4003_14024# VDD.t381 sg13_lv_pmos ad=0.2128p pd=1.5u as=0.3808p ps=2.92u w=1.12u l=0.2u
X690 a_25630_6734# a_3747_6737.t2 a_27915_6734# VSS.t1764 sg13_lv_nmos ad=0.2516p pd=2.16u as=0.1406p ps=1.12u w=0.74u l=0.13u
X691 a_24631_2470# a_24393_1842# a_24523_1842# VDD.t353 sg13_lv_pmos ad=0.2128p pd=1.5u as=0.3808p ps=2.92u w=1.12u l=0.2u
X692 a_3747_13229.t1 a_3449_13577# VSS.t203 VSS.t2344 sg13_lv_nmos ad=0.1406p pd=1.12u as=0.1331p ps=1.12u w=0.74u l=0.13u
X693 a_9193_1842# a_8997_1842# VDD.t1273 VDD.t353 sg13_lv_pmos ad=0.3808p pd=2.92u as=0.2128p ps=1.5u w=1.12u l=0.13u
X694 a_5115_3889# a_4905_3889# VSS.t1615 VSS.t2048 sg13_lv_nmos ad=0.1406p pd=1.12u as=0.1665p ps=1.19u w=0.74u l=0.13u
X695 a_13470_16071# a_3171_16074.t6 a_14888_16071# VSS.t311 sg13_lv_nmos ad=0.2516p pd=2.16u as=0.1406p ps=1.12u w=0.74u l=0.13u
X696 VSS.t665 VDD.t1682 VSS.t665 VSS.t666 sg13_lv_nmos ad=79.8f pd=0.8u as=0 ps=0 w=0.42u l=1u
X697 VSS.t544 a_15403_1842# a_15837_1842# VSS.t1226 sg13_lv_nmos ad=0.1406p pd=1.12u as=0.2516p ps=2.16u w=0.74u l=0.13u
X698 VSS.t474 a_4187_1764.t67 a_26911_7532# VSS.t473 sg13_lv_nmos ad=0.2516p pd=2.16u as=0.1406p ps=1.12u w=0.74u l=0.6u
X699 a_8155_1044# a_7945_1044# VSS.t389 VSS.t388 sg13_lv_nmos ad=0.1406p pd=1.12u as=0.1665p ps=1.19u w=0.74u l=0.13u
X700 VSS.t730 VDD.t1653 VSS.t730 VSS.t734 sg13_lv_nmos ad=0.1428p pd=1.52u as=0 ps=0 w=0.42u l=1u
X701 a_10430_13226# a_3171_13229.t7 a_11848_13226# VSS.t2010 sg13_lv_nmos ad=0.2516p pd=2.16u as=0.1406p ps=1.12u w=0.74u l=0.13u
X702 VDD.t884 a_4187_2434# a_22351_8160# VDD.t341 sg13_lv_pmos ad=0.3808p pd=2.92u as=0.2128p ps=1.5u w=1.12u l=0.6u
X703 a_27433_16869# a_27237_16869# VSS.t989 VSS.t988 sg13_lv_nmos ad=0.2516p pd=2.16u as=0.1406p ps=1.12u w=0.74u l=0.13u
X704 a_10430_16071# a_2019_16074.t7 a_10328_16071# VSS.t537 sg13_lv_nmos ad=0.2516p pd=2.16u as=0.1406p ps=1.12u w=0.74u l=0.13u
X705 a_11711_4687# a_11473_4687# a_11603_4687# VSS.t2282 sg13_lv_nmos ad=0.1406p pd=1.12u as=0.2516p ps=2.16u w=0.74u l=0.2u
X706 VDD.t720 a_2019_6737.t4 a_19524_6698# VDD.t29 sg13_lv_pmos ad=0.3808p pd=2.92u as=0.3808p ps=2.92u w=1.12u l=0.13u
X707 a_23633_1842# a_23437_1842# VDD.t1400 VDD.t353 sg13_lv_pmos ad=0.3808p pd=2.92u as=0.2128p ps=1.5u w=1.12u l=0.13u
X708 VDD.t1121 a_2019_3892.t9 a_4324_3853# VDD.t9 sg13_lv_pmos ad=0.3808p pd=2.92u as=0.3808p ps=2.92u w=1.12u l=0.13u
X709 VSS.t1341 a_15964_15316# a_16851_15336# VSS.t1915 sg13_lv_nmos ad=0.1371p pd=1.12u as=0.2176p ps=1.96u w=0.64u l=0.13u
X710 a_2595_13229.t0 a_2297_13577# VDD.t1387 VDD.t36 sg13_lv_pmos ad=0.2128p pd=1.5u as=0.1918p ps=1.5u w=1.12u l=0.13u
X711 a_27048_1044# a_26477_1842# VSS.t1710 VSS.t2100 sg13_lv_nmos ad=0.1406p pd=1.12u as=0.2516p ps=2.16u w=0.74u l=0.13u
X712 VSS.t568 a_4763_1842# a_5197_1842# VSS.t1424 sg13_lv_nmos ad=0.1406p pd=1.12u as=0.2516p ps=2.16u w=0.74u l=0.13u
X713 a_16510_3889# a_18871_3853# a_18795_3889# VDD.t9 sg13_lv_pmos ad=0.3808p pd=2.92u as=0.2128p ps=1.5u w=1.12u l=0.13u
X714 VSS.t1215 a_1721_3176# a_2019_3156.t1 VSS.t255 sg13_lv_nmos ad=0.2812p pd=2.24u as=0.1406p ps=1.12u w=0.74u l=0.13u
X715 a_15511_14024# a_15273_14024# a_15403_14024# VSS.t484 sg13_lv_nmos ad=0.1406p pd=1.12u as=0.2516p ps=2.16u w=0.74u l=0.2u
X716 VDD.t1347 a_9323_1842# a_9757_1842# VDD.t353 sg13_lv_pmos ad=0.2128p pd=1.5u as=0.3808p ps=2.92u w=1.12u l=0.13u
X717 a_3543_6021# REF_MUX_SEL2 a_3449_6021# VSS.t172 sg13_lv_nmos ad=0.1216p pd=1.02u as=0.2176p ps=1.96u w=0.64u l=0.13u
X718 a_2019_16074.t0 a_1721_16422# VDD.t1313 VDD.t20 sg13_lv_pmos ad=0.2128p pd=1.5u as=0.1918p ps=1.5u w=1.12u l=0.13u
X719 VSS.t396 a_2595_6001.t2 a_20905_6209# VSS.t1508 sg13_lv_nmos ad=0.2516p pd=2.16u as=0.2516p ps=2.16u w=0.74u l=0.13u
X720 a_19550_16071# a_2595_16074.t4 a_20315_16071# VSS.t1082 sg13_lv_nmos ad=0.2516p pd=2.16u as=0.1406p ps=1.12u w=0.74u l=0.13u
X721 VDD.t1015 a_7043_14024# a_7477_14024# VDD.t381 sg13_lv_pmos ad=0.2128p pd=1.5u as=0.3808p ps=2.92u w=1.12u l=0.13u
X722 a_13470_13226# a_13444_13190# a_13368_13226# VDD.t36 sg13_lv_pmos ad=0.3808p pd=2.92u as=0.2128p ps=1.5u w=1.12u l=0.13u
X723 a_5768_1044# a_5197_1842# VSS.t360 VSS.t1280 sg13_lv_nmos ad=0.1406p pd=1.12u as=0.2516p ps=2.16u w=0.74u l=0.13u
X724 VSS.t1382 a_5957_16869# a_6425_16071# VSS.t1381 sg13_lv_nmos ad=0.1665p pd=1.19u as=0.2516p ps=2.16u w=0.74u l=0.13u
X725 VSS.t1422 a_4187_1764.t115 a_16271_14024# VSS.t1729 sg13_lv_nmos ad=0.2516p pd=2.16u as=0.1406p ps=1.12u w=0.74u l=0.6u
X726 a_15755_6734# a_15545_6734# VDD.t479 VDD.t29 sg13_lv_pmos ad=0.2128p pd=1.5u as=0.252p ps=1.57u w=1.12u l=0.13u
X727 VDD.t1453 a_2297_15358# a_2595_15338.t0 VDD.t20 sg13_lv_pmos ad=0.4256p pd=3u as=0.2128p ps=1.5u w=1.12u l=0.13u
X728 VSS.t2118 a_2297_15358# a_2595_15338.t1 VSS.t2025 sg13_lv_nmos ad=0.2812p pd=2.24u as=0.1406p ps=1.12u w=0.74u l=0.13u
X729 VDD.t1031 a_2595_6737.t6 a_14311_6698# VDD.t29 sg13_lv_pmos ad=0.3808p pd=2.92u as=0.3808p ps=2.92u w=1.12u l=0.13u
X730 a_7390_1044# a_7364_1008# a_7288_1044# VDD.t0 sg13_lv_pmos ad=0.3808p pd=2.92u as=0.2128p ps=1.5u w=1.12u l=0.13u
X731 VDD.t1391 a_16597_16869# a_17065_16071# VDD.t20 sg13_lv_pmos ad=0.252p pd=1.57u as=0.3808p ps=2.92u w=1.12u l=0.13u
X732 a_15273_7532# a_15077_7532# VSS.t198 VSS.t268 sg13_lv_nmos ad=0.2516p pd=2.16u as=0.1406p ps=1.12u w=0.74u l=0.13u
X733 VSS.t228 a_4187_1764.t28 a_7911_1842# VSS.t2375 sg13_lv_nmos ad=0.2516p pd=2.16u as=0.1406p ps=1.12u w=0.74u l=0.6u
X734 a_14888_16071# a_14317_16869# VDD.t933 VDD.t20 sg13_lv_pmos ad=0.2128p pd=1.5u as=0.3808p ps=2.92u w=1.12u l=0.13u
X735 a_13306_11995# a_12355_11557# VDD.t1012 VDD.t351 sg13_lv_pmos ad=79.8f pd=0.8u as=0.1428p ps=1.52u w=0.42u l=0.13u
X736 a_6391_7532# a_6153_7532# a_6283_7532# VSS.t1616 sg13_lv_nmos ad=0.1406p pd=1.12u as=0.2516p ps=2.16u w=0.74u l=0.2u
X737 a_5115_6734# a_4905_6734# VDD.t423 VDD.t29 sg13_lv_pmos ad=0.2128p pd=1.5u as=0.252p ps=1.57u w=1.12u l=0.13u
X738 a_13991_16869# a_13753_16869# a_13883_16869# VSS.t221 sg13_lv_nmos ad=0.1406p pd=1.12u as=0.2516p ps=2.16u w=0.74u l=0.2u
X739 VSS.t893 VSS.t895 VSS.t897 VSS.t896 sg13_lv_nmos ad=0.1406p pd=1.12u as=0 ps=0 w=0.74u l=0.2u
X740 a_19833_7532# a_19637_7532# VDD.t571 VDD.t341 sg13_lv_pmos ad=0.3808p pd=2.92u as=0.2128p ps=1.5u w=1.12u l=0.13u
X741 a_18313_16869# a_18117_16869# VSS.t1054 VSS.t1053 sg13_lv_nmos ad=0.2516p pd=2.16u as=0.1406p ps=1.12u w=0.74u l=0.13u
X742 VSS.t20 a_10083_4687# a_10517_4687# VSS.t19 sg13_lv_nmos ad=0.1406p pd=1.12u as=0.2516p ps=2.16u w=0.74u l=0.13u
X743 a_10328_16071# a_9757_16869# VDD.t1525 VDD.t20 sg13_lv_pmos ad=0.2128p pd=1.5u as=0.3808p ps=2.92u w=1.12u l=0.13u
X744 a_5631_17497# a_5393_16869# a_5523_16869# VDD.t365 sg13_lv_pmos ad=0.2128p pd=1.5u as=0.3808p ps=2.92u w=1.12u l=0.2u
X745 VSS.t344 a_4187_1764.t149 a_14751_16869# VSS.t2070 sg13_lv_nmos ad=0.2516p pd=2.16u as=0.1406p ps=1.12u w=0.74u l=0.6u
X746 a_19833_16869# a_19637_16869# VDD.t1526 VDD.t365 sg13_lv_pmos ad=0.3808p pd=2.92u as=0.2128p ps=1.5u w=1.12u l=0.13u
X747 VSS.t1 a_18443_14024# a_18877_14024# VSS.t95 sg13_lv_nmos ad=0.1406p pd=1.12u as=0.2516p ps=2.16u w=0.74u l=0.13u
X748 a_24631_8160# a_24393_7532# a_24523_7532# VDD.t341 sg13_lv_pmos ad=0.2128p pd=1.5u as=0.3808p ps=2.92u w=1.12u l=0.2u
X749 VDD.t822 a_4187_2434# a_6391_17497# VDD.t365 sg13_lv_pmos ad=0.3808p pd=2.92u as=0.2128p ps=1.5u w=1.12u l=0.6u
X750 VDD.t539 a_23763_16869# a_24197_16869# VDD.t365 sg13_lv_pmos ad=0.2128p pd=1.5u as=0.3808p ps=2.92u w=1.12u l=0.13u
X751 a_9193_7532# a_8997_7532# VDD.t1245 VDD.t341 sg13_lv_pmos ad=0.3808p pd=2.92u as=0.2128p ps=1.5u w=1.12u l=0.13u
X752 a_27671_5315# a_27433_4687# a_27563_4687# VDD.t339 sg13_lv_pmos ad=0.2128p pd=1.5u as=0.3808p ps=2.92u w=1.12u l=0.2u
X753 a_13470_16071# a_15831_16035# a_15755_16071# VDD.t20 sg13_lv_pmos ad=0.3808p pd=2.92u as=0.2128p ps=1.5u w=1.12u l=0.13u
X754 VSS.t120 VDD.t1694 VSS.t631 VSS.t630 sg13_lv_nmos ad=0.1428p pd=1.52u as=0 ps=0 w=0.42u l=1u
X755 VDD.t211 VSS.t665 VDD.t210 VDD.t36 sg13_lv_pmos ad=0.34p pd=2.68u as=0 ps=0 w=1u l=1u
X756 VSS.t260 a_15403_7532# a_15837_7532# VSS.t259 sg13_lv_nmos ad=0.1406p pd=1.12u as=0.2516p ps=2.16u w=0.74u l=0.13u
X757 a_8155_6734# a_7945_6734# VSS.t298 VSS.t1639 sg13_lv_nmos ad=0.1406p pd=1.12u as=0.1665p ps=1.19u w=0.74u l=0.13u
X758 VDD.t317 VSS.t806 VDD.t315 VDD.t0 sg13_lv_pmos ad=0.19p pd=1.38u as=0 ps=0 w=1u l=1u
X759 VSS.t54 a_21157_4687# a_21625_3889# VSS.t53 sg13_lv_nmos ad=0.1665p pd=1.19u as=0.2516p ps=2.16u w=0.74u l=0.13u
X760 VSS.t696 VDD.t1669 VSS.t696 VSS.t697 sg13_lv_nmos ad=0.1428p pd=1.52u as=0 ps=0 w=0.42u l=1u
X761 VSS.t1629 a_24197_1842# a_24665_1044# VSS.t2089 sg13_lv_nmos ad=0.1665p pd=1.19u as=0.2516p ps=2.16u w=0.74u l=0.13u
X762 VSS.t267 a_4187_1764.t98 VSS.t1564 VSS.t1563 sg13_lv_nmos ad=2.38p pd=14.68u as=0 ps=0 w=7u l=7u
X763 a_11711_1842# a_11473_1842# a_11603_1842# VSS.t1435 sg13_lv_nmos ad=0.1406p pd=1.12u as=0.2516p ps=2.16u w=0.74u l=0.2u
X764 a_23633_7532# a_23437_7532# VDD.t551 VDD.t341 sg13_lv_pmos ad=0.3808p pd=2.92u as=0.2128p ps=1.5u w=1.12u l=0.13u
X765 a_16510_1044# a_3171_1047.t5 a_17928_1044# VSS.t331 sg13_lv_nmos ad=0.2516p pd=2.16u as=0.1406p ps=1.12u w=0.74u l=0.13u
X766 VSS.t189 a_4763_7532# a_5197_7532# VSS.t188 sg13_lv_nmos ad=0.1406p pd=1.12u as=0.2516p ps=2.16u w=0.74u l=0.13u
X767 a_27048_6734# a_26477_7532# VSS.t1448 VSS.t1814 sg13_lv_nmos ad=0.1406p pd=1.12u as=0.2516p ps=2.16u w=0.74u l=0.13u
X768 VSS.t790 VDD.t1633 VSS.t792 VSS.t791 sg13_lv_nmos ad=79.8f pd=0.8u as=0 ps=0 w=0.42u l=1u
X769 VSS.t220 a_4187_1764.t38 a_24631_4687# VSS.t1092 sg13_lv_nmos ad=0.2516p pd=2.16u as=0.1406p ps=1.12u w=0.74u l=0.6u
X770 VSS.t573 VDD.t1709 VSS.t575 VSS.t574 sg13_lv_nmos ad=79.8f pd=0.8u as=0 ps=0 w=0.42u l=1u
X771 VSS.t100 VDD.t1645 VSS.t100 VSS.t754 sg13_lv_nmos ad=79.8f pd=0.8u as=0 ps=0 w=0.42u l=1u
X772 VDD.t727 a_9323_7532# a_9757_7532# VDD.t341 sg13_lv_pmos ad=0.2128p pd=1.5u as=0.3808p ps=2.92u w=1.12u l=0.13u
X773 VSS.t2118 a_1544_15316# a_2391_15358# VSS.t2067 sg13_lv_nmos ad=0.1331p pd=1.12u as=0.1216p ps=1.02u w=0.64u l=0.13u
X774 VDD.t790 a_4187_2434# a_16271_5315# VDD.t339 sg13_lv_pmos ad=0.3808p pd=2.92u as=0.2128p ps=1.5u w=1.12u l=0.6u
X775 a_5768_6734# a_5197_7532# VSS.t1170 VSS.t1169 sg13_lv_nmos ad=0.1406p pd=1.12u as=0.2516p ps=2.16u w=0.74u l=0.13u
X776 a_14513_1842# a_14317_1842# VDD.t1008 VDD.t353 sg13_lv_pmos ad=0.3808p pd=2.92u as=0.2128p ps=1.5u w=1.12u l=0.13u
X777 VDD.t966 a_4003_16869# a_4437_16869# VDD.t365 sg13_lv_pmos ad=0.2128p pd=1.5u as=0.3808p ps=2.92u w=1.12u l=0.13u
X778 a_6854_11676# a_6326_10280# VDD.t451 VDD.t351 sg13_lv_pmos ad=0.38p pd=2.38u as=0.38p ps=2.38u w=2u l=1u
X779 a_5631_2470# a_5393_1842# a_5523_1842# VDD.t353 sg13_lv_pmos ad=0.2128p pd=1.5u as=0.3808p ps=2.92u w=1.12u l=0.2u
X780 a_3171_13229.t0 a_2873_13577# VDD.t1401 VDD.t36 sg13_lv_pmos ad=0.2128p pd=1.5u as=0.1918p ps=1.5u w=1.12u l=0.13u
X781 VDD.t187 VSS.t462 VDD.t185 VDD.t36 sg13_lv_pmos ad=0.19p pd=1.38u as=0 ps=0 w=1u l=1u
X782 VDD.t476 a_1721_7085# a_2019_6737.t0 VDD.t29 sg13_lv_pmos ad=0.4256p pd=3u as=0.2128p ps=1.5u w=1.12u l=0.13u
X783 VSS.t1532 a_2019_3892.t9 a_4324_3853# VSS.t1531 sg13_lv_nmos ad=0.2516p pd=2.16u as=0.2516p ps=2.16u w=0.74u l=0.13u
X784 a_19311_16869# a_19073_16869# a_19203_16869# VSS.t1310 sg13_lv_nmos ad=0.1406p pd=1.12u as=0.2516p ps=2.16u w=0.74u l=0.2u
X785 VDD.t1470 a_26043_4687# a_26477_4687# VDD.t339 sg13_lv_pmos ad=0.2128p pd=1.5u as=0.3808p ps=2.92u w=1.12u l=0.13u
X786 a_11473_14024# a_11277_14024# VSS.t1086 VSS.t1220 sg13_lv_nmos ad=0.2516p pd=2.16u as=0.1406p ps=1.12u w=0.74u l=0.13u
X787 VSS.t1580 a_4187_1764.t98 VSS.t1579 VSS.t1563 sg13_lv_nmos ad=2.38p pd=14.68u as=0 ps=0 w=7u l=7u
X788 VSS.t1202 a_4187_1764.t92 a_7911_7532# VSS.t1201 sg13_lv_nmos ad=0.2516p pd=2.16u as=0.1406p ps=1.12u w=0.74u l=0.6u
X789 a_16510_3889# a_3747_3892.t5 a_18795_3889# VSS.t2000 sg13_lv_nmos ad=0.2516p pd=2.16u as=0.1406p ps=1.12u w=0.74u l=0.13u
X790 a_10430_3889# a_10404_3853# a_10328_3889# VDD.t9 sg13_lv_pmos ad=0.3808p pd=2.92u as=0.2128p ps=1.5u w=1.12u l=0.13u
X791 VSS.t396 VDD.t1661 VSS.t396 VSS.t716 sg13_lv_nmos ad=79.8f pd=0.8u as=0 ps=0 w=0.42u l=1u
X792 VSS.t357 a_3171_1047.t4 a_21044_1008# VSS.t356 sg13_lv_nmos ad=0.2516p pd=2.16u as=0.2516p ps=2.16u w=0.74u l=0.13u
X793 VSS.t1331 a_10083_1842# a_10517_1842# VSS.t1961 sg13_lv_nmos ad=0.1406p pd=1.12u as=0.2516p ps=2.16u w=0.74u l=0.13u
X794 a_3747_3156.t0 a_3449_3176# VDD.t1150 VDD.t9 sg13_lv_pmos ad=0.2128p pd=1.5u as=0.1918p ps=1.5u w=1.12u l=0.13u
X795 a_17928_13226# a_17357_14024# VDD.t696 VDD.t36 sg13_lv_pmos ad=0.2128p pd=1.5u as=0.3808p ps=2.92u w=1.12u l=0.13u
X796 VDD.t986 a_21157_7532# a_21625_6734# VDD.t29 sg13_lv_pmos ad=0.252p pd=1.57u as=0.3808p ps=2.92u w=1.12u l=0.13u
X797 a_4633_1842# a_4437_1842# VDD.t575 VDD.t353 sg13_lv_pmos ad=0.3808p pd=2.92u as=0.2128p ps=1.5u w=1.12u l=0.13u
X798 VDD.t512 a_2019_1047.t4 a_19524_1008# VDD.t0 sg13_lv_pmos ad=0.3808p pd=2.92u as=0.3808p ps=2.92u w=1.12u l=0.13u
X799 a_5631_14652# a_5393_14024# a_5523_14024# VDD.t381 sg13_lv_pmos ad=0.2128p pd=1.5u as=0.3808p ps=2.92u w=1.12u l=0.2u
X800 VSS.t462 a_3747_12493.t2 a_26985_12701# VSS.t461 sg13_lv_nmos ad=0.2516p pd=2.16u as=0.2516p ps=2.16u w=0.74u l=0.13u
X801 a_6854_11676# a_15304_10295# a_4187_1764.t0 VDD.t360 sg13_lv_pmos ad=0.136p pd=1.14u as=0.158p ps=1.245u w=0.4u l=0.2u
X802 a_19833_14024# a_19637_14024# VDD.t576 VDD.t381 sg13_lv_pmos ad=0.3808p pd=2.92u as=0.2128p ps=1.5u w=1.12u l=0.13u
X803 VDD.t779 a_4187_2434# a_20071_5315# VDD.t339 sg13_lv_pmos ad=0.3808p pd=2.92u as=0.2128p ps=1.5u w=1.12u l=0.6u
X804 VSS.t435 a_2873_331# a_3171_311.t1 VSS.t1367 sg13_lv_nmos ad=0.2812p pd=2.24u as=0.1406p ps=1.12u w=0.74u l=0.13u
X805 VDD.t805 a_4187_2434# a_6391_14652# VDD.t381 sg13_lv_pmos ad=0.3808p pd=2.92u as=0.2128p ps=1.5u w=1.12u l=0.6u
X806 a_3747_16074.t1 a_3449_16422# VSS.t330 VSS.t1974 sg13_lv_nmos ad=0.1406p pd=1.12u as=0.1331p ps=1.12u w=0.74u l=0.13u
X807 VDD.t1132 a_23763_14024# a_24197_14024# VDD.t381 sg13_lv_pmos ad=0.2128p pd=1.5u as=0.3808p ps=2.92u w=1.12u l=0.13u
X808 a_7390_3889# a_8884_3853# a_8808_3889# VDD.t9 sg13_lv_pmos ad=0.3808p pd=2.92u as=0.2128p ps=1.5u w=1.12u l=0.13u
X809 a_13306_10795# a_13132_11110# VDD.t416 VDD.t351 sg13_lv_pmos ad=79.8f pd=0.8u as=0.1428p ps=1.52u w=0.42u l=0.13u
X810 a_16108_3134# a_3171_3156.t2 a_22590_3889# VSS.t1271 sg13_lv_nmos ad=0.2516p pd=2.16u as=0.2516p ps=2.16u w=0.74u l=0.13u
X811 VDD.t238 VSS.t696 VDD.t237 VDD.t29 sg13_lv_pmos ad=0.34p pd=2.68u as=0 ps=0 w=1u l=1u
X812 VSS.t2098 a_19637_14024# a_20105_13226# VSS.t2179 sg13_lv_nmos ad=0.1665p pd=1.19u as=0.2516p ps=2.16u w=0.74u l=0.13u
X813 VSS.t41 a_3449_331# a_3747_311.t1 VSS.t2292 sg13_lv_nmos ad=0.2812p pd=2.24u as=0.1406p ps=1.12u w=0.74u l=0.13u
X814 VSS.t125 VSS.t933 VSS.t935 VSS.t934 sg13_lv_nmos ad=0.2516p pd=2.16u as=0 ps=0 w=0.74u l=0.13u
X815 a_10430_16071# a_3171_16074.t7 a_11848_16071# VSS.t2186 sg13_lv_nmos ad=0.2516p pd=2.16u as=0.1406p ps=1.12u w=0.74u l=0.13u
X816 a_15755_1044# a_15545_1044# VDD.t474 VDD.t0 sg13_lv_pmos ad=0.2128p pd=1.5u as=0.252p ps=1.57u w=1.12u l=0.13u
X817 a_26911_4687# a_26673_4687# a_26803_4687# VSS.t1761 sg13_lv_nmos ad=0.1406p pd=1.12u as=0.2516p ps=2.16u w=0.74u l=0.2u
X818 VSS.t972 a_24197_7532# a_24665_6734# VSS.t1149 sg13_lv_nmos ad=0.1665p pd=1.19u as=0.2516p ps=2.16u w=0.74u l=0.13u
X819 VSS.t2007 a_3171_13229.t5 a_18004_13190# VSS.t2006 sg13_lv_nmos ad=0.2516p pd=2.16u as=0.2516p ps=2.16u w=0.74u l=0.13u
X820 VDD.t438 a_6326_10280# a_6854_11144# VDD.t351 sg13_lv_pmos ad=0.38p pd=2.38u as=0.38p ps=2.38u w=2u l=1u
X821 a_11711_7532# a_11473_7532# a_11603_7532# VSS.t2216 sg13_lv_nmos ad=0.1406p pd=1.12u as=0.2516p ps=2.16u w=0.74u l=0.2u
X822 a_16510_6734# a_3171_6737.t5 a_17928_6734# VSS.t2107 sg13_lv_nmos ad=0.2516p pd=2.16u as=0.1406p ps=1.12u w=0.74u l=0.13u
X823 VDD.t1210 a_2595_1047.t6 a_14311_1008# VDD.t0 sg13_lv_pmos ad=0.3808p pd=2.92u as=0.3808p ps=2.92u w=1.12u l=0.13u
X824 VDD.t114 VSS.t577 VDD.t113 VDD.t20 sg13_lv_pmos ad=0.34p pd=2.68u as=0 ps=0 w=1u l=1u
X825 VDD.t718 a_2019_6737.t9 a_4324_6698# VDD.t29 sg13_lv_pmos ad=0.3808p pd=2.92u as=0.3808p ps=2.92u w=1.12u l=0.13u
X826 a_17031_14024# a_16793_14024# a_16923_14024# VSS.t1224 sg13_lv_nmos ad=0.1406p pd=1.12u as=0.2516p ps=2.16u w=0.74u l=0.2u
X827 a_5974_11413# a_6126_9506# VSS.t962 VSS.t959 sg13_lv_nmos ad=0.38p pd=2.38u as=0.68p ps=4.68u w=2u l=1u
X828 VSS.t483 a_4187_1764.t6 a_24631_1842# VSS.t482 sg13_lv_nmos ad=0.2516p pd=2.16u as=0.1406p ps=1.12u w=0.74u l=0.6u
X829 a_16510_6734# a_18871_6698# a_18795_6734# VDD.t29 sg13_lv_pmos ad=0.3808p pd=2.92u as=0.2128p ps=1.5u w=1.12u l=0.13u
X830 a_5115_1044# a_4905_1044# VDD.t760 VDD.t0 sg13_lv_pmos ad=0.2128p pd=1.5u as=0.252p ps=1.57u w=1.12u l=0.13u
X831 VSS.t1136 a_1721_6021# a_2019_6001.t1 VSS.t1516 sg13_lv_nmos ad=0.2812p pd=2.24u as=0.1406p ps=1.12u w=0.74u l=0.13u
X832 a_13470_13226# a_14964_13190# a_14888_13226# VDD.t36 sg13_lv_pmos ad=0.3808p pd=2.92u as=0.2128p ps=1.5u w=1.12u l=0.13u
X833 a_12471_14024# a_12233_14024# a_12363_14024# VSS.t1495 sg13_lv_nmos ad=0.1406p pd=1.12u as=0.2516p ps=2.16u w=0.74u l=0.2u
X834 VSS.t3 a_4187_1764.t113 a_17791_14024# VSS.t2 sg13_lv_nmos ad=0.2516p pd=2.16u as=0.1406p ps=1.12u w=0.74u l=0.6u
X835 VSS.t1174 a_1544_12471# a_2391_12513# VSS.t1230 sg13_lv_nmos ad=0.1331p pd=1.12u as=0.1216p ps=1.02u w=0.64u l=0.13u
X836 VSS.t1928 a_4437_14024# a_4905_13226# VSS.t1927 sg13_lv_nmos ad=0.1665p pd=1.19u as=0.2516p ps=2.16u w=0.74u l=0.13u
X837 a_14513_7532# a_14317_7532# VDD.t562 VDD.t341 sg13_lv_pmos ad=0.3808p pd=2.92u as=0.2128p ps=1.5u w=1.12u l=0.13u
X838 VDD.t838 a_4187_2434# a_23111_17497# VDD.t365 sg13_lv_pmos ad=0.3808p pd=2.92u as=0.2128p ps=1.5u w=1.12u l=0.6u
X839 VDD.t1317 a_4003_14024# a_4437_14024# VDD.t381 sg13_lv_pmos ad=0.2128p pd=1.5u as=0.3808p ps=2.92u w=1.12u l=0.13u
X840 a_10430_13226# a_10404_13190# a_10328_13226# VDD.t36 sg13_lv_pmos ad=0.3808p pd=2.92u as=0.2128p ps=1.5u w=1.12u l=0.13u
X841 VSS.t665 a_2019_12493.t2 a_17865_12701# VSS.t2093 sg13_lv_nmos ad=0.2516p pd=2.16u as=0.2516p ps=2.16u w=0.74u l=0.13u
X842 a_5631_8160# a_5393_7532# a_5523_7532# VDD.t341 sg13_lv_pmos ad=0.2128p pd=1.5u as=0.3808p ps=2.92u w=1.12u l=0.2u
X843 VSS.t508 a_15964_3134# a_16851_3154# VSS.t507 sg13_lv_nmos ad=0.1371p pd=1.12u as=0.2176p ps=1.96u w=0.64u l=0.13u
X844 VDD.t1343 a_15077_4687# a_15545_3889# VDD.t9 sg13_lv_pmos ad=0.252p pd=1.57u as=0.3808p ps=2.92u w=1.12u l=0.13u
X845 VSS.t1089 a_4187_1764.t50 a_15511_4687# VSS.t1088 sg13_lv_nmos ad=0.2516p pd=2.16u as=0.1406p ps=1.12u w=0.74u l=0.6u
X846 a_17553_4687# a_17357_4687# VDD.t1241 VDD.t339 sg13_lv_pmos ad=0.3808p pd=2.92u as=0.2128p ps=1.5u w=1.12u l=0.13u
X847 VSS.t1319 a_4187_1764.t119 a_13231_14024# VSS.t2050 sg13_lv_nmos ad=0.2516p pd=2.16u as=0.1406p ps=1.12u w=0.74u l=0.6u
X848 a_8671_5315# a_8433_4687# a_8563_4687# VDD.t339 sg13_lv_pmos ad=0.2128p pd=1.5u as=0.3808p ps=2.92u w=1.12u l=0.2u
X849 VDD.t709 a_18117_16869# a_18585_16071# VDD.t20 sg13_lv_pmos ad=0.252p pd=1.57u as=0.3808p ps=2.92u w=1.12u l=0.13u
X850 a_13566_11525# a_14009_11568# a_13306_11995# VSS.t1351 sg13_lv_nmos ad=79.8f pd=0.8u as=0.1296p ps=1.52u w=0.42u l=0.13u
X851 VDD.t104 VSS.t396 VDD.t102 VDD.t29 sg13_lv_pmos ad=0.19p pd=1.38u as=0 ps=0 w=1u l=1u
X852 VSS.t2118 a_1256_15316# a_2967_15358# VSS.t2045 sg13_lv_nmos ad=0.1331p pd=1.12u as=0.1216p ps=1.02u w=0.64u l=0.13u
X853 a_18551_2470# a_18313_1842# a_18443_1842# VDD.t353 sg13_lv_pmos ad=0.2128p pd=1.5u as=0.3808p ps=2.92u w=1.12u l=0.2u
X854 VSS.t890 VSS.t887 VSS.t887 VSS.t888 sg13_lv_nmos ad=0.1406p pd=1.12u as=0 ps=0 w=0.74u l=0.13u
X855 VSS.t1309 a_25283_4687# a_25717_4687# VSS.t1308 sg13_lv_nmos ad=0.1406p pd=1.12u as=0.2516p ps=2.16u w=0.74u l=0.13u
X856 VDD.t1537 a_3171_16074.t2 a_27124_16035# VDD.t20 sg13_lv_pmos ad=0.3808p pd=2.92u as=0.3808p ps=2.92u w=1.12u l=0.13u
X857 a_11848_16071# a_11277_16869# VDD.t367 VDD.t20 sg13_lv_pmos ad=0.2128p pd=1.5u as=0.3808p ps=2.92u w=1.12u l=0.13u
X858 VDD.t150 VSS.t643 VDD.t149 VDD.t36 sg13_lv_pmos ad=0.34p pd=2.68u as=0 ps=0 w=1u l=1u
X859 VSS.t1022 a_3171_6737.t4 a_21044_6698# VSS.t1867 sg13_lv_nmos ad=0.2516p pd=2.16u as=0.2516p ps=2.16u w=0.74u l=0.13u
X860 a_10951_16869# a_10713_16869# a_10843_16869# VSS.t1263 sg13_lv_nmos ad=0.1406p pd=1.12u as=0.2516p ps=2.16u w=0.74u l=0.2u
X861 a_19550_13226# a_20391_13190# a_20315_13226# VDD.t36 sg13_lv_pmos ad=0.3808p pd=2.92u as=0.2128p ps=1.5u w=1.12u l=0.13u
X862 VSS.t392 a_10083_7532# a_10517_7532# VSS.t2270 sg13_lv_nmos ad=0.1406p pd=1.12u as=0.2516p ps=2.16u w=0.74u l=0.13u
X863 VDD.t2 VSS.t823 VDD.t1 VDD.t0 sg13_lv_pmos ad=0.19p pd=1.38u as=0 ps=0 w=1u l=1u
X864 a_15273_16869# a_15077_16869# VSS.t344 VSS.t343 sg13_lv_nmos ad=0.2516p pd=2.16u as=0.1406p ps=1.12u w=0.74u l=0.13u
X865 a_13592_11561# a_13566_11525# VDD.t761 VDD.t351 sg13_lv_pmos ad=0.34p pd=2.68u as=0.36237p ps=2.605u w=1u l=0.13u
X866 a_4633_7532# a_4437_7532# VDD.t422 VDD.t341 sg13_lv_pmos ad=0.3808p pd=2.92u as=0.2128p ps=1.5u w=1.12u l=0.13u
X867 VDD.t1055 a_5957_14024# a_6425_13226# VDD.t36 sg13_lv_pmos ad=0.252p pd=1.57u as=0.3808p ps=2.92u w=1.12u l=0.13u
X868 VSS.t459 a_4187_1764.t63 a_5631_4687# VSS.t458 sg13_lv_nmos ad=0.2516p pd=2.16u as=0.1406p ps=1.12u w=0.74u l=0.6u
X869 VDD.t817 a_4187_2434# a_7911_17497# VDD.t365 sg13_lv_pmos ad=0.3808p pd=2.92u as=0.2128p ps=1.5u w=1.12u l=0.6u
X870 VDD.t378 a_25283_16869# a_25717_16869# VDD.t365 sg13_lv_pmos ad=0.2128p pd=1.5u as=0.3808p ps=2.92u w=1.12u l=0.13u
X871 a_3171_1047.t1 a_2873_1395# VSS.t1166 VSS.t92 sg13_lv_nmos ad=0.1406p pd=1.12u as=0.1331p ps=1.12u w=0.74u l=0.13u
X872 VSS.t1037 a_15403_14024# a_15837_14024# VSS.t1948 sg13_lv_nmos ad=0.1406p pd=1.12u as=0.2516p ps=2.16u w=0.74u l=0.13u
X873 VSS.t244 a_2595_13229.t8 a_8231_13190# VSS.t243 sg13_lv_nmos ad=0.2516p pd=2.16u as=0.2516p ps=2.16u w=0.74u l=0.13u
X874 VSS.t1782 a_2297_1395# a_2595_1047.t1 VSS.t1275 sg13_lv_nmos ad=0.2812p pd=2.24u as=0.1406p ps=1.12u w=0.74u l=0.13u
X875 VDD.t175 VSS.t739 VDD.t174 VDD.t9 sg13_lv_pmos ad=0.34p pd=2.68u as=0 ps=0 w=1u l=1u
X876 a_10430_3889# a_2019_3892.t7 a_10328_3889# VSS.t1537 sg13_lv_nmos ad=0.2516p pd=2.16u as=0.1406p ps=1.12u w=0.74u l=0.13u
X877 a_21353_4687# a_21157_4687# VDD.t364 VDD.t339 sg13_lv_pmos ad=0.3808p pd=2.92u as=0.2128p ps=1.5u w=1.12u l=0.13u
X878 VDD.t375 a_20723_16869# a_21157_16869# VDD.t365 sg13_lv_pmos ad=0.2128p pd=1.5u as=0.3808p ps=2.92u w=1.12u l=0.13u
X879 VSS.t722 VDD.t1657 VSS.t725 VSS.t724 sg13_lv_nmos ad=0.1428p pd=1.52u as=0 ps=0 w=0.42u l=1u
X880 VSS.t947 VSS.t945 VSS.t945 VSS.t946 sg13_lv_nmos ad=0.2516p pd=2.16u as=0 ps=0 w=0.74u l=0.13u
X881 a_1815_3176# a_1256_3134# a_1721_3176# VSS.t1011 sg13_lv_nmos ad=0.1216p pd=1.02u as=0.2176p ps=1.96u w=0.64u l=0.13u
X882 a_26911_1842# a_26673_1842# a_26803_1842# VSS.t2124 sg13_lv_nmos ad=0.1406p pd=1.12u as=0.2516p ps=2.16u w=0.74u l=0.2u
X883 VSS.t798 a_3171_311.t3 a_11785_519# VSS.t1545 sg13_lv_nmos ad=0.2516p pd=2.16u as=0.2516p ps=2.16u w=0.74u l=0.13u
X884 VDD.t402 a_7043_4687# a_7477_4687# VDD.t339 sg13_lv_pmos ad=0.2128p pd=1.5u as=0.3808p ps=2.92u w=1.12u l=0.13u
X885 VDD.t471 a_1721_1395# a_2019_1047.t0 VDD.t0 sg13_lv_pmos ad=0.4256p pd=3u as=0.2128p ps=1.5u w=1.12u l=0.13u
X886 a_22351_2470# a_22113_1842# a_22243_1842# VDD.t353 sg13_lv_pmos ad=0.2128p pd=1.5u as=0.3808p ps=2.92u w=1.12u l=0.2u
X887 VDD.t1182 a_3171_3892.t7 a_11924_3853# VDD.t9 sg13_lv_pmos ad=0.3808p pd=2.92u as=0.3808p ps=2.92u w=1.12u l=0.13u
X888 a_2391_1395# CHAN3_MUX_SEL0 a_2297_1395# VSS.t1597 sg13_lv_nmos ad=0.1216p pd=1.02u as=0.2176p ps=1.96u w=0.64u l=0.13u
X889 VDD.t463 a_16923_1842# a_17357_1842# VDD.t353 sg13_lv_pmos ad=0.2128p pd=1.5u as=0.3808p ps=2.92u w=1.12u l=0.13u
X890 VSS.t163 a_4187_1764.t70 a_24631_7532# VSS.t1865 sg13_lv_nmos ad=0.2516p pd=2.16u as=0.1406p ps=1.12u w=0.74u l=0.6u
X891 a_7390_3889# a_3171_3892.t8 a_8808_3889# VSS.t1664 sg13_lv_nmos ad=0.2516p pd=2.16u as=0.1406p ps=1.12u w=0.74u l=0.13u
X892 a_13368_1044# a_12797_1842# VSS.t363 VSS.t1499 sg13_lv_nmos ad=0.1406p pd=1.12u as=0.2516p ps=2.16u w=0.74u l=0.13u
X893 VSS.t254 a_1544_1044# a_1815_1395# VSS.t1800 sg13_lv_nmos ad=0.1331p pd=1.12u as=0.1216p ps=1.02u w=0.64u l=0.13u
X894 VSS.t730 VDD.t1655 VSS.t730 VSS.t729 sg13_lv_nmos ad=0.1428p pd=1.52u as=0 ps=0 w=0.42u l=1u
X895 VDD.t1388 a_2297_13577# a_2595_13229.t0 VDD.t36 sg13_lv_pmos ad=0.4256p pd=3u as=0.2128p ps=1.5u w=1.12u l=0.13u
X896 a_14009_10774# REF_DELAY_OUT_LAST VDD.t352 VDD.t351 sg13_lv_pmos ad=0.4088p pd=2.97u as=1.10612p ps=6.66u w=1.12u l=0.13u
X897 VDD.t1476 a_21157_1842# a_21625_1044# VDD.t0 sg13_lv_pmos ad=0.252p pd=1.57u as=0.3808p ps=2.92u w=1.12u l=0.13u
X898 a_5974_11413# a_6126_9506# VSS.t963 VSS.t959 sg13_lv_nmos ad=0.38p pd=2.38u as=0.68p ps=4.68u w=2u l=1u
X899 a_5731_289# a_3171_311.t3 a_10430_1044# VSS.t1544 sg13_lv_nmos ad=0.2516p pd=2.16u as=0.2516p ps=2.16u w=0.74u l=0.13u
X900 VDD.t862 a_4187_2434# a_23111_14652# VDD.t381 sg13_lv_pmos ad=0.3808p pd=2.92u as=0.2128p ps=1.5u w=1.12u l=0.6u
X901 a_12993_14024# a_12797_14024# VSS.t1064 VSS.t1494 sg13_lv_nmos ad=0.2516p pd=2.16u as=0.1406p ps=1.12u w=0.74u l=0.13u
X902 VSS.t544 a_4187_1764.t18 a_15511_1842# VSS.t543 sg13_lv_nmos ad=0.2516p pd=2.16u as=0.1406p ps=1.12u w=0.74u l=0.6u
X903 VDD.t917 a_4187_2434# a_10951_2470# VDD.t353 sg13_lv_pmos ad=0.3808p pd=2.92u as=0.2128p ps=1.5u w=1.12u l=0.6u
X904 VDD.t146 VSS.t674 VDD.t144 VDD.t36 sg13_lv_pmos ad=0.19p pd=1.38u as=0 ps=0 w=1u l=1u
X905 a_16271_16869# a_16033_16869# a_16163_16869# VSS.t1752 sg13_lv_nmos ad=0.1406p pd=1.12u as=0.2516p ps=2.16u w=0.74u l=0.2u
X906 a_25630_3889# a_25604_3853# a_25528_3889# VDD.t9 sg13_lv_pmos ad=0.3808p pd=2.92u as=0.2128p ps=1.5u w=1.12u l=0.13u
X907 VDD.t262 VSS.t760 VDD.t261 VDD.t9 sg13_lv_pmos ad=0.19p pd=1.38u as=0 ps=0 w=1u l=1u
X908 a_16793_4687# a_16597_4687# VSS.t491 VSS.t490 sg13_lv_nmos ad=0.2516p pd=2.16u as=0.1406p ps=1.12u w=0.74u l=0.13u
X909 VSS.t1174 a_1256_12471# a_2967_12513# VSS.t2204 sg13_lv_nmos ad=0.1331p pd=1.12u as=0.1216p ps=1.02u w=0.64u l=0.13u
X910 a_18551_8160# a_18313_7532# a_18443_7532# VDD.t341 sg13_lv_pmos ad=0.2128p pd=1.5u as=0.3808p ps=2.92u w=1.12u l=0.2u
X911 a_7911_4687# a_7673_4687# a_7803_4687# VSS.t317 sg13_lv_nmos ad=0.1406p pd=1.12u as=0.2516p ps=2.16u w=0.74u l=0.2u
X912 a_10430_6734# a_10404_6698# a_10328_6734# VDD.t29 sg13_lv_pmos ad=0.3808p pd=2.92u as=0.2128p ps=1.5u w=1.12u l=0.13u
X913 VSS.t556 VDD.t1703 VSS.t596 VSS.t595 sg13_lv_nmos ad=0.1428p pd=1.52u as=0 ps=0 w=0.42u l=1u
X914 a_4350_1044# a_3747_1047.t9 a_6635_1044# VSS.t992 sg13_lv_nmos ad=0.2516p pd=2.16u as=0.1406p ps=1.12u w=0.74u l=0.13u
X915 VSS.t2126 a_25283_1842# a_25717_1842# VSS.t2335 sg13_lv_nmos ad=0.1406p pd=1.12u as=0.2516p ps=2.16u w=0.74u l=0.13u
X916 VDD.t428 REF_MUX_SEL3 a_3449_6021# VDD.t29 sg13_lv_pmos ad=0.1918p pd=1.5u as=0.1596p ps=1.22u w=0.84u l=0.13u
X917 VSS.t454 a_4187_1764.t146 a_17031_16869# VSS.t453 sg13_lv_nmos ad=0.2516p pd=2.16u as=0.1406p ps=1.12u w=0.74u l=0.6u
X918 a_27433_14024# a_27237_14024# VSS.t231 VSS.t230 sg13_lv_nmos ad=0.2516p pd=2.16u as=0.1406p ps=1.12u w=0.74u l=0.13u
X919 VDD.t522 a_20723_1842# a_21157_1842# VDD.t353 sg13_lv_pmos ad=0.2128p pd=1.5u as=0.3808p ps=2.92u w=1.12u l=0.13u
X920 VDD.t990 a_14851_10872# a_15688_11093# VDD.t351 sg13_lv_pmos ad=0.2128p pd=1.5u as=0.3864p ps=2.93u w=1.12u l=0.13u
X921 VSS.t1957 a_15077_4687# a_15545_3889# VSS.t2273 sg13_lv_nmos ad=0.1665p pd=1.19u as=0.2516p ps=2.16u w=0.74u l=0.13u
X922 a_3747_12493.t0 a_3449_12513# VDD.t991 VDD.t36 sg13_lv_pmos ad=0.2128p pd=1.5u as=0.1918p ps=1.5u w=1.12u l=0.13u
X923 VDD.t510 a_2019_1047.t9 a_4324_1008# VDD.t0 sg13_lv_pmos ad=0.3808p pd=2.92u as=0.3808p ps=2.92u w=1.12u l=0.13u
X924 VSS.t368 a_4187_1764.t31 a_5631_1842# VSS.t367 sg13_lv_nmos ad=0.2516p pd=2.16u as=0.1406p ps=1.12u w=0.74u l=0.6u
X925 a_3449_16422# CHAN0_MUX_SEL0 VDD.t1571 VDD.t20 sg13_lv_pmos ad=0.1596p pd=1.22u as=0.2856p ps=2.36u w=0.84u l=0.13u
X926 VDD.t1010 a_15964_15316# a_16851_15336# VDD.t20 sg13_lv_pmos ad=0.2086p pd=1.5u as=0.34p ps=2.68u w=1u l=0.13u
X927 VDD.t843 a_4187_2434# a_7911_14652# VDD.t381 sg13_lv_pmos ad=0.3808p pd=2.92u as=0.2128p ps=1.5u w=1.12u l=0.6u
X928 VDD.t715 a_25283_14024# a_25717_14024# VDD.t381 sg13_lv_pmos ad=0.2128p pd=1.5u as=0.3808p ps=2.92u w=1.12u l=0.13u
X929 a_19550_1044# a_2595_1047.t4 a_20315_1044# VSS.t1706 sg13_lv_nmos ad=0.2516p pd=2.16u as=0.1406p ps=1.12u w=0.74u l=0.13u
X930 a_3171_6737.t1 a_2873_7085# VSS.t134 VSS.t476 sg13_lv_nmos ad=0.1406p pd=1.12u as=0.1331p ps=1.12u w=0.74u l=0.13u
X931 VDD.t35 VSS.t722 VDD.t34 VDD.t29 sg13_lv_pmos ad=0.34p pd=2.68u as=0 ps=0 w=1u l=1u
X932 a_16510_1044# a_18871_1008# a_18795_1044# VDD.t0 sg13_lv_pmos ad=0.3808p pd=2.92u as=0.2128p ps=1.5u w=1.12u l=0.13u
X933 a_7390_6734# a_8884_6698# a_8808_6734# VDD.t29 sg13_lv_pmos ad=0.3808p pd=2.92u as=0.2128p ps=1.5u w=1.12u l=0.13u
X934 VSS.t1429 a_21157_14024# a_21625_13226# VSS.t1428 sg13_lv_nmos ad=0.1665p pd=1.19u as=0.2516p ps=2.16u w=0.74u l=0.13u
X935 VSS.t275 a_2297_7085# a_2595_6737.t1 VSS.t276 sg13_lv_nmos ad=0.2812p pd=2.24u as=0.1406p ps=1.12u w=0.74u l=0.13u
X936 VDD.t1067 a_20723_14024# a_21157_14024# VDD.t381 sg13_lv_pmos ad=0.2128p pd=1.5u as=0.3808p ps=2.92u w=1.12u l=0.13u
X937 a_13991_5315# a_13753_4687# a_13883_4687# VDD.t339 sg13_lv_pmos ad=0.2128p pd=1.5u as=0.3808p ps=2.92u w=1.12u l=0.2u
X938 VSS.t2036 a_19637_16869# a_20105_16071# VSS.t2228 sg13_lv_nmos ad=0.1665p pd=1.19u as=0.2516p ps=2.16u w=0.74u l=0.13u
X939 VSS.t923 VSS.t921 VSS.t921 VSS.t922 sg13_lv_nmos ad=0.2516p pd=2.16u as=0 ps=0 w=0.74u l=0.13u
X940 VSS.t1204 a_27563_4687# a_27997_4687# VSS.t2198 sg13_lv_nmos ad=0.1406p pd=1.12u as=0.2516p ps=2.16u w=0.74u l=0.13u
X941 a_26911_7532# a_26673_7532# a_26803_7532# VSS.t1168 sg13_lv_nmos ad=0.1406p pd=1.12u as=0.2516p ps=2.16u w=0.74u l=0.2u
X942 VSS.t389 a_7477_1842# a_7945_1044# VSS.t1559 sg13_lv_nmos ad=0.1665p pd=1.19u as=0.2516p ps=2.16u w=0.74u l=0.13u
X943 VDD.t924 a_4187_2434# a_23871_2470# VDD.t353 sg13_lv_pmos ad=0.3808p pd=2.92u as=0.2128p ps=1.5u w=1.12u l=0.6u
X944 VSS.t1732 a_2019_13229.t4 a_19524_13190# VSS.t2195 sg13_lv_nmos ad=0.2516p pd=2.16u as=0.2516p ps=2.16u w=0.74u l=0.13u
X945 a_20593_4687# a_20397_4687# VSS.t1523 VSS.t1524 sg13_lv_nmos ad=0.2516p pd=2.16u as=0.1406p ps=1.12u w=0.74u l=0.13u
X946 VSS.t1102 a_19203_16869# a_19637_16869# VSS.t2305 sg13_lv_nmos ad=0.1406p pd=1.12u as=0.2516p ps=2.16u w=0.74u l=0.13u
X947 a_22351_8160# a_22113_7532# a_22243_7532# VDD.t341 sg13_lv_pmos ad=0.2128p pd=1.5u as=0.3808p ps=2.92u w=1.12u l=0.2u
X948 VSS.t399 a_3171_16074.t5 a_18004_16035# VSS.t398 sg13_lv_nmos ad=0.2516p pd=2.16u as=0.2516p ps=2.16u w=0.74u l=0.13u
X949 VSS.t760 VDD.t1641 VSS.t760 VSS.t764 sg13_lv_nmos ad=79.8f pd=0.8u as=0 ps=0 w=0.42u l=1u
X950 VDD.t1268 a_16923_7532# a_17357_7532# VDD.t341 sg13_lv_pmos ad=0.2128p pd=1.5u as=0.3808p ps=2.92u w=1.12u l=0.13u
X951 a_2391_7085# REF_MUX_SEL0 a_2297_7085# VSS.t1151 sg13_lv_nmos ad=0.1216p pd=1.02u as=0.2176p ps=1.96u w=0.64u l=0.13u
X952 VSS.t213 a_6283_4687# a_6717_4687# VSS.t212 sg13_lv_nmos ad=0.1406p pd=1.12u as=0.2516p ps=2.16u w=0.74u l=0.13u
X953 VSS.t702 VDD.t1665 VSS.t702 VSS.t707 sg13_lv_nmos ad=79.8f pd=0.8u as=0 ps=0 w=0.42u l=1u
X954 a_13368_6734# a_12797_7532# VSS.t1749 VSS.t1812 sg13_lv_nmos ad=0.1406p pd=1.12u as=0.2516p ps=2.16u w=0.74u l=0.13u
X955 VSS.t975 a_3747_3156.t3 a_14825_3364# VSS.t974 sg13_lv_nmos ad=0.2516p pd=2.16u as=0.2516p ps=2.16u w=0.74u l=0.13u
X956 a_13991_14024# a_13753_14024# a_13883_14024# VSS.t481 sg13_lv_nmos ad=0.1406p pd=1.12u as=0.2516p ps=2.16u w=0.74u l=0.2u
X957 a_18313_14024# a_18117_14024# VSS.t3 VSS.t1418 sg13_lv_nmos ad=0.2516p pd=2.16u as=0.1406p ps=1.12u w=0.74u l=0.13u
X958 VSS.t264 a_1544_6734# a_1815_7085# VSS.t1165 sg13_lv_nmos ad=0.1331p pd=1.12u as=0.1216p ps=1.02u w=0.64u l=0.13u
X959 VDD.t40 VSS.t775 VDD.t39 VDD.t0 sg13_lv_pmos ad=0.34p pd=2.68u as=0 ps=0 w=1u l=1u
X960 a_13231_2470# a_12993_1842# a_13123_1842# VDD.t353 sg13_lv_pmos ad=0.2128p pd=1.5u as=0.3808p ps=2.92u w=1.12u l=0.2u
X961 a_10430_13226# a_11924_13190# a_11848_13226# VDD.t36 sg13_lv_pmos ad=0.3808p pd=2.92u as=0.2128p ps=1.5u w=1.12u l=0.13u
X962 VSS.t510 a_4187_1764.t117 a_14751_14024# VSS.t1038 sg13_lv_nmos ad=0.2516p pd=2.16u as=0.1406p ps=1.12u w=0.74u l=0.6u
X963 a_3449_3176# CHAN2_MUX_SEL2 VDD.t1138 VDD.t9 sg13_lv_pmos ad=0.1596p pd=1.22u as=0.2856p ps=2.36u w=0.84u l=0.13u
X964 VSS.t1026 a_3171_3892.t7 a_11924_3853# VSS.t1667 sg13_lv_nmos ad=0.2516p pd=2.16u as=0.2516p ps=2.16u w=0.74u l=0.13u
X965 VSS.t1260 a_4437_16869# a_4905_16071# VSS.t1259 sg13_lv_nmos ad=0.1665p pd=1.19u as=0.2516p ps=2.16u w=0.74u l=0.13u
X966 VSS.t1839 a_3747_13229.t3 a_24951_13190# VSS.t1838 sg13_lv_nmos ad=0.2516p pd=2.16u as=0.2516p ps=2.16u w=0.74u l=0.13u
X967 a_13880_11982# a_13592_11561# a_13818_11982# VSS.t1162 sg13_lv_nmos ad=0.1428p pd=1.52u as=37.8f ps=0.6u w=0.42u l=0.13u
X968 VDD.t835 a_4187_2434# a_20071_17497# VDD.t365 sg13_lv_pmos ad=0.3808p pd=2.92u as=0.2128p ps=1.5u w=1.12u l=0.6u
X969 VSS.t260 a_4187_1764.t82 a_15511_7532# VSS.t284 sg13_lv_nmos ad=0.2516p pd=2.16u as=0.1406p ps=1.12u w=0.74u l=0.6u
X970 VDD.t479 a_15077_7532# a_15545_6734# VDD.t29 sg13_lv_pmos ad=0.252p pd=1.57u as=0.3808p ps=2.92u w=1.12u l=0.13u
X971 VSS.t513 a_3747_12493.t3 a_14825_12701# VSS.t194 sg13_lv_nmos ad=0.2516p pd=2.16u as=0.2516p ps=2.16u w=0.74u l=0.13u
X972 VDD.t783 a_4187_2434# a_10951_8160# VDD.t341 sg13_lv_pmos ad=0.3808p pd=2.92u as=0.2128p ps=1.5u w=1.12u l=0.6u
X973 VSS.t1582 a_4187_1764.t98 VSS.t1580 VSS.t1565 sg13_lv_nmos ad=1.33p pd=7.38u as=0 ps=0 w=7u l=7u
X974 VDD.t508 a_15077_16869# a_15545_16071# VDD.t20 sg13_lv_pmos ad=0.252p pd=1.57u as=0.3808p ps=2.92u w=1.12u l=0.13u
X975 VDD.t346 a_12363_4687# a_12797_4687# VDD.t339 sg13_lv_pmos ad=0.2128p pd=1.5u as=0.3808p ps=2.92u w=1.12u l=0.13u
X976 a_16793_1842# a_16597_1842# VSS.t1105 VSS.t2183 sg13_lv_nmos ad=0.2516p pd=2.16u as=0.1406p ps=1.12u w=0.74u l=0.13u
X977 VSS.t2072 a_25283_7532# a_25717_7532# VSS.t2117 sg13_lv_nmos ad=0.1406p pd=1.12u as=0.2516p ps=2.16u w=0.74u l=0.13u
X978 a_7911_1842# a_7673_1842# a_7803_1842# VSS.t2232 sg13_lv_nmos ad=0.1406p pd=1.12u as=0.2516p ps=2.16u w=0.74u l=0.2u
X979 a_12233_1842# a_12037_1842# VDD.t1186 VDD.t353 sg13_lv_pmos ad=0.3808p pd=2.92u as=0.2128p ps=1.5u w=1.12u l=0.13u
X980 a_16793_16869# a_16597_16869# VSS.t456 VSS.t2353 sg13_lv_nmos ad=0.2516p pd=2.16u as=0.1406p ps=1.12u w=0.74u l=0.13u
X981 a_4350_6734# a_3747_6737.t9 a_6635_6734# VSS.t1762 sg13_lv_nmos ad=0.2516p pd=2.16u as=0.1406p ps=1.12u w=0.74u l=0.13u
X982 VSS.t631 VDD.t1694 VSS.t633 VSS.t632 sg13_lv_nmos ad=79.8f pd=0.8u as=0 ps=0 w=0.42u l=1u
X983 a_16108_12471# CHAN1_MUX_SEL4 a_15964_12471# VSS.t194 sg13_lv_nmos ad=0.2516p pd=2.16u as=0.2183p ps=1.33u w=0.74u l=0.13u
X984 VDD.t1142 a_20723_7532# a_21157_7532# VDD.t341 sg13_lv_pmos ad=0.2128p pd=1.5u as=0.3808p ps=2.92u w=1.12u l=0.13u
X985 VDD.t498 a_3171_16074.t3 a_24084_16035# VDD.t20 sg13_lv_pmos ad=0.3808p pd=2.92u as=0.3808p ps=2.92u w=1.12u l=0.13u
X986 VSS.t739 VDD.t1650 VSS.t739 VSS.t742 sg13_lv_nmos ad=0.1428p pd=1.52u as=0 ps=0 w=0.42u l=1u
X987 a_12233_16869# a_12037_16869# VSS.t1403 VSS.t1473 sg13_lv_nmos ad=0.2516p pd=2.16u as=0.1406p ps=1.12u w=0.74u l=0.13u
X988 VDD.t310 VSS.t585 VDD.t312 VDD.t20 sg13_lv_pmos ad=0.34p pd=2.68u as=0 ps=0 w=1u l=1u
X989 VSS.t377 a_4187_1764.t95 a_5631_7532# VSS.t376 sg13_lv_nmos ad=0.2516p pd=2.16u as=0.1406p ps=1.12u w=0.74u l=0.6u
X990 a_19550_6734# a_2595_6737.t4 a_20315_6734# VSS.t1444 sg13_lv_nmos ad=0.2516p pd=2.16u as=0.1406p ps=1.12u w=0.74u l=0.13u
X991 VDD.t1127 a_3747_311.t3 a_14825_519# VDD.t0 sg13_lv_pmos ad=0.3808p pd=2.92u as=0.3808p ps=2.92u w=1.12u l=0.13u
X992 a_16510_3889# a_16484_3853# a_16408_3889# VDD.t9 sg13_lv_pmos ad=0.3808p pd=2.92u as=0.2128p ps=1.5u w=1.12u l=0.13u
X993 VSS.t2251 a_3747_13229.t8 a_9751_13190# VSS.t2250 sg13_lv_nmos ad=0.2516p pd=2.16u as=0.2516p ps=2.16u w=0.74u l=0.13u
X994 VDD.t808 a_4187_2434# a_4871_17497# VDD.t365 sg13_lv_pmos ad=0.3808p pd=2.92u as=0.2128p ps=1.5u w=1.12u l=0.6u
X995 a_25630_3889# a_2019_3892.t2 a_25528_3889# VSS.t1906 sg13_lv_nmos ad=0.2516p pd=2.16u as=0.1406p ps=1.12u w=0.74u l=0.13u
X996 a_3171_3892.t1 a_2873_4240# VSS.t1923 VSS.t535 sg13_lv_nmos ad=0.1406p pd=1.12u as=0.1331p ps=1.12u w=0.74u l=0.13u
X997 VDD.t459 a_22243_16869# a_22677_16869# VDD.t365 sg13_lv_pmos ad=0.2128p pd=1.5u as=0.3808p ps=2.92u w=1.12u l=0.13u
X998 VDD.t15 VSS.t766 VDD.t14 VDD.t9 sg13_lv_pmos ad=0.34p pd=2.68u as=0 ps=0 w=1u l=1u
X999 VSS.t1390 a_2595_16074.t8 a_8231_16035# VSS.t1856 sg13_lv_nmos ad=0.2516p pd=2.16u as=0.2516p ps=2.16u w=0.74u l=0.13u
X1000 VSS.t553 a_2595_13229.t9 a_5191_13190# VSS.t552 sg13_lv_nmos ad=0.2516p pd=2.16u as=0.2516p ps=2.16u w=0.74u l=0.13u
X1001 VSS.t1409 a_2297_4240# a_2595_3892.t1 VSS.t1125 sg13_lv_nmos ad=0.2812p pd=2.24u as=0.1406p ps=1.12u w=0.74u l=0.13u
X1002 a_19073_4687# a_18877_4687# VSS.t303 VSS.t302 sg13_lv_nmos ad=0.2516p pd=2.16u as=0.1406p ps=1.12u w=0.74u l=0.13u
X1003 a_9675_1044# a_9465_1044# VSS.t857 VSS.t856 sg13_lv_nmos ad=0.1406p pd=1.12u as=0.1665p ps=1.19u w=0.74u l=0.13u
X1004 VDD.t1214 a_3171_3892.t2 a_27124_3853# VDD.t9 sg13_lv_pmos ad=0.3808p pd=2.92u as=0.3808p ps=2.92u w=1.12u l=0.13u
X1005 a_1815_6021# a_1256_5979# a_1721_6021# VSS.t1994 sg13_lv_nmos ad=0.1216p pd=1.02u as=0.2176p ps=1.96u w=0.64u l=0.13u
X1006 VDD.t885 a_4187_2434# a_23871_8160# VDD.t341 sg13_lv_pmos ad=0.3808p pd=2.92u as=0.2128p ps=1.5u w=1.12u l=0.6u
X1007 VSS.t298 a_7477_7532# a_7945_6734# VSS.t297 sg13_lv_nmos ad=0.1665p pd=1.19u as=0.2516p ps=2.16u w=0.74u l=0.13u
X1008 VSS.t404 a_27563_1842# a_27997_1842# VSS.t403 sg13_lv_nmos ad=0.1406p pd=1.12u as=0.2516p ps=2.16u w=0.74u l=0.13u
X1009 VDD.t1500 a_3747_16074.t5 a_18871_16035# VDD.t20 sg13_lv_pmos ad=0.3808p pd=2.92u as=0.3808p ps=2.92u w=1.12u l=0.13u
X1010 VDD.t1445 a_3171_6737.t7 a_11924_6698# VDD.t29 sg13_lv_pmos ad=0.3808p pd=2.92u as=0.3808p ps=2.92u w=1.12u l=0.13u
X1011 a_20593_1842# a_20397_1842# VSS.t464 VSS.t1286 sg13_lv_nmos ad=0.2516p pd=2.16u as=0.1406p ps=1.12u w=0.74u l=0.13u
X1012 VDD.t355 a_15964_5979# a_16851_5999# VDD.t29 sg13_lv_pmos ad=0.2086p pd=1.5u as=0.34p ps=2.68u w=1u l=0.13u
X1013 VSS.t336 a_2595_1047.t8 a_8231_1008# VSS.t1703 sg13_lv_nmos ad=0.2516p pd=2.16u as=0.2516p ps=2.16u w=0.74u l=0.13u
X1014 a_19311_14024# a_19073_14024# a_19203_14024# VSS.t2320 sg13_lv_nmos ad=0.1406p pd=1.12u as=0.2516p ps=2.16u w=0.74u l=0.2u
X1015 VDD.t52 VSS.t702 VDD.t50 VDD.t29 sg13_lv_pmos ad=0.19p pd=1.38u as=0 ps=0 w=1u l=1u
X1016 VSS.t287 a_6283_1842# a_6717_1842# VSS.t286 sg13_lv_nmos ad=0.1406p pd=1.12u as=0.2516p ps=2.16u w=0.74u l=0.13u
X1017 a_10430_3889# a_11271_3853# a_11195_3889# VDD.t9 sg13_lv_pmos ad=0.3808p pd=2.92u as=0.2128p ps=1.5u w=1.12u l=0.13u
X1018 a_2391_4240# CHAN2_MUX_SEL0 a_2297_4240# VSS.t171 sg13_lv_nmos ad=0.1216p pd=1.02u as=0.2176p ps=1.96u w=0.64u l=0.13u
X1019 a_10430_1044# a_10404_1008# a_10328_1044# VDD.t0 sg13_lv_pmos ad=0.3808p pd=2.92u as=0.2128p ps=1.5u w=1.12u l=0.13u
X1020 a_23355_3889# a_23145_3889# VDD.t1045 VDD.t9 sg13_lv_pmos ad=0.2128p pd=1.5u as=0.252p ps=1.57u w=1.12u l=0.13u
X1021 VSS.t1409 a_1544_3889# a_1815_4240# VSS.t1135 sg13_lv_nmos ad=0.1331p pd=1.12u as=0.1216p ps=1.02u w=0.64u l=0.13u
X1022 a_16108_5979# a_23945_6209# a_22590_6734# VDD.t29 sg13_lv_pmos ad=0.3808p pd=2.92u as=0.3808p ps=2.92u w=1.12u l=0.13u
X1023 a_13231_8160# a_12993_7532# a_13123_7532# VDD.t341 sg13_lv_pmos ad=0.2128p pd=1.5u as=0.3808p ps=2.92u w=1.12u l=0.2u
X1024 VDD.t497 a_3171_16074.t6 a_14964_16035# VDD.t20 sg13_lv_pmos ad=0.3808p pd=2.92u as=0.3808p ps=2.92u w=1.12u l=0.13u
X1025 VSS.t1091 a_19203_4687# a_19637_4687# VSS.t1520 sg13_lv_nmos ad=0.1406p pd=1.12u as=0.2516p ps=2.16u w=0.74u l=0.13u
X1026 a_16271_5315# a_16033_4687# a_16163_4687# VDD.t339 sg13_lv_pmos ad=0.2128p pd=1.5u as=0.3808p ps=2.92u w=1.12u l=0.2u
X1027 a_15108_11799# a_12849_11557# VDD.t352 VDD.t351 sg13_lv_pmos ad=79.8f pd=0.8u as=1.03698p ps=6.245u w=0.42u l=0.13u
X1028 VDD.t371 a_3747_3892.t4 a_21911_3853# VDD.t9 sg13_lv_pmos ad=0.3808p pd=2.92u as=0.3808p ps=2.92u w=1.12u l=0.13u
X1029 a_8155_13226# a_7945_13226# VSS.t1348 VSS.t2082 sg13_lv_nmos ad=0.1406p pd=1.12u as=0.1665p ps=1.19u w=0.74u l=0.13u
X1030 a_5778_9057# a_6126_9506# a_6326_10280# VSS.t956 sg13_lv_nmos ad=0.68p pd=4.68u as=0.38p ps=2.38u w=2u l=1u
X1031 VDD.t926 a_4187_2434# a_26151_2470# VDD.t353 sg13_lv_pmos ad=0.3808p pd=2.92u as=0.2128p ps=1.5u w=1.12u l=0.6u
X1032 VDD.t1258 a_14851_10872# a_15108_11015# VDD.t351 sg13_lv_pmos ad=0.2639p pd=1.81u as=79.8f ps=0.8u w=0.42u l=0.13u
X1033 a_17791_16869# a_17553_16869# a_17683_16869# VSS.t2174 sg13_lv_nmos ad=0.1406p pd=1.12u as=0.2516p ps=2.16u w=0.74u l=0.2u
X1034 VDD.t856 a_4187_2434# a_20071_14652# VDD.t381 sg13_lv_pmos ad=0.3808p pd=2.92u as=0.2128p ps=1.5u w=1.12u l=0.6u
X1035 VDD.t434 CHAN1_MUX_SEL1 a_3449_13577# VDD.t36 sg13_lv_pmos ad=0.1918p pd=1.5u as=0.1596p ps=1.22u w=0.84u l=0.13u
X1036 a_7390_1044# a_8884_1008# a_8808_1044# VDD.t0 sg13_lv_pmos ad=0.3808p pd=2.92u as=0.2128p ps=1.5u w=1.12u l=0.13u
X1037 VDD.t217 VSS.t665 VDD.t215 VDD.t36 sg13_lv_pmos ad=0.19p pd=1.38u as=0 ps=0 w=1u l=1u
X1038 a_25630_6734# a_25604_6698# a_25528_6734# VDD.t29 sg13_lv_pmos ad=0.3808p pd=2.92u as=0.2128p ps=1.5u w=1.12u l=0.13u
X1039 a_9431_17497# a_9193_16869# a_9323_16869# VDD.t365 sg13_lv_pmos ad=0.2128p pd=1.5u as=0.3808p ps=2.92u w=1.12u l=0.2u
X1040 VSS.t451 a_4187_1764.t144 a_18551_16869# VSS.t1335 sg13_lv_nmos ad=0.2516p pd=2.16u as=0.1406p ps=1.12u w=0.74u l=0.6u
X1041 a_16793_7532# a_16597_7532# VSS.t113 VSS.t2285 sg13_lv_nmos ad=0.2516p pd=2.16u as=0.1406p ps=1.12u w=0.74u l=0.13u
X1042 VSS.t1333 a_8563_4687# a_8997_4687# VSS.t2168 sg13_lv_nmos ad=0.1406p pd=1.12u as=0.2516p ps=2.16u w=0.74u l=0.13u
X1043 a_12233_7532# a_12037_7532# VDD.t734 VDD.t341 sg13_lv_pmos ad=0.3808p pd=2.92u as=0.2128p ps=1.5u w=1.12u l=0.13u
X1044 a_7911_7532# a_7673_7532# a_7803_7532# VSS.t210 sg13_lv_nmos ad=0.1406p pd=1.12u as=0.2516p ps=2.16u w=0.74u l=0.2u
X1045 VDD.t906 a_4187_2434# a_4871_2470# VDD.t353 sg13_lv_pmos ad=0.3808p pd=2.92u as=0.2128p ps=1.5u w=1.12u l=0.6u
X1046 VSS.t498 a_4187_1764.t53 a_13231_4687# VSS.t497 sg13_lv_nmos ad=0.2516p pd=2.16u as=0.1406p ps=1.12u w=0.74u l=0.6u
X1047 a_20968_3889# a_20397_4687# VDD.t1118 VDD.t9 sg13_lv_pmos ad=0.2128p pd=1.5u as=0.3808p ps=2.92u w=1.12u l=0.13u
X1048 VDD.t401 CHAN2_MUX_SEL1 a_3449_4240# VDD.t9 sg13_lv_pmos ad=0.1918p pd=1.5u as=0.1596p ps=1.22u w=0.84u l=0.13u
X1049 VDD.t1051 a_27563_16869# a_27997_16869# VDD.t365 sg13_lv_pmos ad=0.2128p pd=1.5u as=0.3808p ps=2.92u w=1.12u l=0.13u
X1050 a_13880_11982# a_14111_11568# a_13566_11525# VSS.t1351 sg13_lv_nmos ad=0.2373p pd=1.97u as=79.8f ps=0.8u w=0.42u l=0.13u
X1051 a_13949_11604# a_13592_11561# VDD.t749 VDD.t351 sg13_lv_pmos ad=63f pd=0.72u as=0.1563p ps=1.22u w=0.42u l=0.13u
X1052 a_3747_15338.t0 a_3449_15358# VDD.t485 VDD.t20 sg13_lv_pmos ad=0.2128p pd=1.5u as=0.1918p ps=1.5u w=1.12u l=0.13u
X1053 a_3449_331# CHAN3_MUX_SEL2 VDD.t1179 VDD.t0 sg13_lv_pmos ad=0.1596p pd=1.22u as=0.2856p ps=2.36u w=0.84u l=0.13u
X1054 a_3747_15338.t1 a_3449_15358# VSS.t279 VSS.t2337 sg13_lv_nmos ad=0.1406p pd=1.12u as=0.1331p ps=1.12u w=0.74u l=0.13u
X1055 VSS.t564 a_23003_4687# a_23437_4687# VSS.t1262 sg13_lv_nmos ad=0.1406p pd=1.12u as=0.2516p ps=2.16u w=0.74u l=0.13u
X1056 a_20071_5315# a_19833_4687# a_19963_4687# VDD.t339 sg13_lv_pmos ad=0.2128p pd=1.5u as=0.3808p ps=2.92u w=1.12u l=0.2u
X1057 VDD.t810 a_4187_2434# a_4871_14652# VDD.t381 sg13_lv_pmos ad=0.3808p pd=2.92u as=0.2128p ps=1.5u w=1.12u l=0.6u
X1058 a_11910_11995# DLL_RESETN VSS.t45 VSS.t50 sg13_lv_nmos ad=37.8f pd=0.6u as=79.8f ps=0.8u w=0.42u l=0.13u
X1059 VDD.t580 a_22243_14024# a_22677_14024# VDD.t381 sg13_lv_pmos ad=0.2128p pd=1.5u as=0.3808p ps=2.92u w=1.12u l=0.13u
X1060 VDD.t477 a_14851_11918# a_15688_11557# VDD.t351 sg13_lv_pmos ad=0.2128p pd=1.5u as=0.3864p ps=2.93u w=1.12u l=0.13u
X1061 VSS.t81 a_21157_16869# a_21625_16071# VSS.t80 sg13_lv_nmos ad=0.1665p pd=1.19u as=0.2516p ps=2.16u w=0.74u l=0.13u
X1062 VDD.t78 VSS.t818 VDD.t76 VDD.t0 sg13_lv_pmos ad=0.19p pd=1.38u as=0 ps=0 w=1u l=1u
X1063 a_19073_1842# a_18877_1842# VSS.t104 VSS.t103 sg13_lv_nmos ad=0.2516p pd=2.16u as=0.1406p ps=1.12u w=0.74u l=0.13u
X1064 VDD.t380 a_2873_3176# a_3171_3156.t0 VDD.t9 sg13_lv_pmos ad=0.4256p pd=3u as=0.2128p ps=1.5u w=1.12u l=0.13u
X1065 VDD.t424 a_14643_4687# a_15077_4687# VDD.t339 sg13_lv_pmos ad=0.2128p pd=1.5u as=0.3808p ps=2.92u w=1.12u l=0.13u
X1066 a_9675_6734# a_9465_6734# VSS.t1237 VSS.t1236 sg13_lv_nmos ad=0.1406p pd=1.12u as=0.1665p ps=1.19u w=0.74u l=0.13u
X1067 VSS.t1298 a_27563_7532# a_27997_7532# VSS.t2212 sg13_lv_nmos ad=0.1406p pd=1.12u as=0.2516p ps=2.16u w=0.74u l=0.13u
X1068 VSS.t2239 a_2019_16074.t4 a_19524_16035# VSS.t2238 sg13_lv_nmos ad=0.2516p pd=2.16u as=0.2516p ps=2.16u w=0.74u l=0.13u
X1069 a_20593_7532# a_20397_7532# VSS.t1024 VSS.t1023 sg13_lv_nmos ad=0.2516p pd=2.16u as=0.1406p ps=1.12u w=0.74u l=0.13u
X1070 VDD.t474 a_15077_1842# a_15545_1044# VDD.t0 sg13_lv_pmos ad=0.252p pd=1.57u as=0.3808p ps=2.92u w=1.12u l=0.13u
X1071 VDD.t567 a_15964_3134# a_16851_3154# VDD.t9 sg13_lv_pmos ad=0.2086p pd=1.5u as=0.34p ps=2.68u w=1u l=0.13u
X1072 VSS.t1498 a_2019_13229.t5 a_16484_13190# VSS.t1683 sg13_lv_nmos ad=0.2516p pd=2.16u as=0.2516p ps=2.16u w=0.74u l=0.13u
X1073 VSS.t1441 a_2595_6737.t8 a_8231_6698# VSS.t1440 sg13_lv_nmos ad=0.2516p pd=2.16u as=0.2516p ps=2.16u w=0.74u l=0.13u
X1074 a_16510_3889# a_2019_3892.t5 a_16408_3889# VSS.t1533 sg13_lv_nmos ad=0.2516p pd=2.16u as=0.1406p ps=1.12u w=0.74u l=0.13u
X1075 VDD.t303 VSS.t745 VDD.t301 VDD.t9 sg13_lv_pmos ad=0.19p pd=1.38u as=0 ps=0 w=1u l=1u
X1076 a_19550_1044# a_2019_1047.t4 a_19448_1044# VSS.t350 sg13_lv_nmos ad=0.2516p pd=2.16u as=0.1406p ps=1.12u w=0.74u l=0.13u
X1077 VDD.t279 VSS.t656 VDD.t225 VDD.t36 sg13_lv_pmos ad=0.19p pd=1.38u as=0 ps=0 w=1u l=1u
X1078 VSS.t18 a_6283_7532# a_6717_7532# VSS.t1599 sg13_lv_nmos ad=0.1406p pd=1.12u as=0.2516p ps=2.16u w=0.74u l=0.13u
X1079 VSS.t839 VDD.t1621 VSS.t836 VSS.t838 sg13_lv_nmos ad=79.8f pd=0.8u as=0 ps=0 w=0.42u l=1u
X1080 VDD.t1039 a_7803_16869# a_8237_16869# VDD.t365 sg13_lv_pmos ad=0.2128p pd=1.5u as=0.3808p ps=2.92u w=1.12u l=0.13u
X1081 VDD.t665 VDD.t663 VDD.t664 VDD.t353 sg13_lv_pmos ad=0.3808p pd=2.92u as=0 ps=0 w=1.12u l=0.6u
X1082 a_20831_17497# a_20593_16869# a_20723_16869# VDD.t365 sg13_lv_pmos ad=0.2128p pd=1.5u as=0.3808p ps=2.92u w=1.12u l=0.2u
X1083 VDD.t356 DLL_RESETN a_9946_11995# VDD.t351 sg13_lv_pmos ad=0.36237p pd=2.605u as=79.8f ps=0.8u w=0.42u l=0.13u
X1084 VDD.t321 VSS.t816 VDD.t305 VDD.t0 sg13_lv_pmos ad=0.19p pd=1.38u as=0 ps=0 w=1u l=1u
X1085 a_5731_5979# a_2595_6001.t3 a_7390_6734# VSS.t1505 sg13_lv_nmos ad=0.2516p pd=2.16u as=0.2516p ps=2.16u w=0.74u l=0.13u
X1086 a_16108_3134# a_23945_3364# a_22590_3889# VDD.t9 sg13_lv_pmos ad=0.3808p pd=2.92u as=0.3808p ps=2.92u w=1.12u l=0.13u
X1087 VSS.t1737 a_3171_3892.t2 a_27124_3853# VSS.t1736 sg13_lv_nmos ad=0.2516p pd=2.16u as=0.2516p ps=2.16u w=0.74u l=0.13u
X1088 a_10951_14024# a_10713_14024# a_10843_14024# VSS.t1489 sg13_lv_nmos ad=0.1406p pd=1.12u as=0.2516p ps=2.16u w=0.74u l=0.2u
X1089 VDD.t1436 a_19637_14024# a_20105_13226# VDD.t36 sg13_lv_pmos ad=0.252p pd=1.57u as=0.3808p ps=2.92u w=1.12u l=0.13u
X1090 VDD.t289 VSS.t656 VDD.t288 VDD.t36 sg13_lv_pmos ad=0.34p pd=2.68u as=0 ps=0 w=1u l=1u
X1091 VDD.t804 a_4187_2434# a_17791_5315# VDD.t339 sg13_lv_pmos ad=0.3808p pd=2.92u as=0.2128p ps=1.5u w=1.12u l=0.6u
X1092 a_15273_14024# a_15077_14024# VSS.t510 VSS.t2318 sg13_lv_nmos ad=0.2516p pd=2.16u as=0.1406p ps=1.12u w=0.74u l=0.13u
X1093 VSS.t1357 a_19203_1842# a_19637_1842# VSS.t2031 sg13_lv_nmos ad=0.1406p pd=1.12u as=0.2516p ps=2.16u w=0.74u l=0.13u
X1094 VSS.t730 a_2595_3156.t3 a_8745_3364# VSS.t1268 sg13_lv_nmos ad=0.2516p pd=2.16u as=0.2516p ps=2.16u w=0.74u l=0.13u
X1095 VDD.t814 a_4187_2434# a_21591_17497# VDD.t365 sg13_lv_pmos ad=0.3808p pd=2.92u as=0.2128p ps=1.5u w=1.12u l=0.6u
X1096 a_2019_3156.t0 a_1721_3176# VDD.t940 VDD.t9 sg13_lv_pmos ad=0.2128p pd=1.5u as=0.1918p ps=1.5u w=1.12u l=0.13u
X1097 VDD.t888 a_4187_2434# a_26151_8160# VDD.t341 sg13_lv_pmos ad=0.3808p pd=2.92u as=0.2128p ps=1.5u w=1.12u l=0.6u
X1098 VDD.t72 VSS.t794 VDD.t71 VDD.t0 sg13_lv_pmos ad=0.34p pd=2.68u as=0 ps=0 w=1u l=1u
X1099 VSS.t410 a_3747_16074.t3 a_24951_16035# VSS.t409 sg13_lv_nmos ad=0.2516p pd=2.16u as=0.2516p ps=2.16u w=0.74u l=0.13u
X1100 VDD.t1377 a_3171_13229.t5 a_18004_13190# VDD.t36 sg13_lv_pmos ad=0.3808p pd=2.92u as=0.3808p ps=2.92u w=1.12u l=0.13u
X1101 VSS.t643 VDD.t1690 VSS.t643 VSS.t645 sg13_lv_nmos ad=0.1428p pd=1.52u as=0 ps=0 w=0.42u l=1u
X1102 VSS.t152 a_3747_13229.t4 a_21911_13190# VSS.t1693 sg13_lv_nmos ad=0.2516p pd=2.16u as=0.2516p ps=2.16u w=0.74u l=0.13u
X1103 a_10430_3889# a_2595_3892.t7 a_11195_3889# VSS.t1484 sg13_lv_nmos ad=0.2516p pd=2.16u as=0.1406p ps=1.12u w=0.74u l=0.13u
X1104 a_15511_4687# a_15273_4687# a_15403_4687# VSS.t1030 sg13_lv_nmos ad=0.1406p pd=1.12u as=0.2516p ps=2.16u w=0.74u l=0.2u
X1105 VSS.t656 a_3171_12493.t3 a_11785_12701# VSS.t1659 sg13_lv_nmos ad=0.2516p pd=2.16u as=0.2516p ps=2.16u w=0.74u l=0.13u
X1106 a_13470_1044# a_2595_1047.t6 a_14235_1044# VSS.t1719 sg13_lv_nmos ad=0.2516p pd=2.16u as=0.1406p ps=1.12u w=0.74u l=0.13u
X1107 VDD.t545 a_1256_289# a_2873_331# VDD.t0 sg13_lv_pmos ad=0.1918p pd=1.5u as=0.1596p ps=1.22u w=0.84u l=0.13u
X1108 a_27433_1842# a_27237_1842# VDD.t1441 VDD.t353 sg13_lv_pmos ad=0.3808p pd=2.92u as=0.2128p ps=1.5u w=1.12u l=0.13u
X1109 a_9431_14652# a_9193_14024# a_9323_14024# VDD.t381 sg13_lv_pmos ad=0.2128p pd=1.5u as=0.3808p ps=2.92u w=1.12u l=0.2u
X1110 VSS.t1108 a_8563_1842# a_8997_1842# VSS.t1950 sg13_lv_nmos ad=0.1406p pd=1.12u as=0.2516p ps=2.16u w=0.74u l=0.13u
X1111 a_19448_3889# a_18877_4687# VDD.t493 VDD.t9 sg13_lv_pmos ad=0.2128p pd=1.5u as=0.3808p ps=2.92u w=1.12u l=0.13u
X1112 a_23355_3889# a_23145_3889# VSS.t1397 VSS.t1972 sg13_lv_nmos ad=0.1406p pd=1.12u as=0.1665p ps=1.19u w=0.74u l=0.13u
X1113 VDD.t868 a_4187_2434# a_4871_8160# VDD.t341 sg13_lv_pmos ad=0.3808p pd=2.92u as=0.2128p ps=1.5u w=1.12u l=0.6u
X1114 VDD.t717 a_2019_16074.t2 a_25604_16035# VDD.t20 sg13_lv_pmos ad=0.3808p pd=2.92u as=0.3808p ps=2.92u w=1.12u l=0.13u
X1115 a_3543_15358# CHAN0_MUX_SEL2 a_3449_15358# VSS.t1641 sg13_lv_nmos ad=0.1216p pd=1.02u as=0.2176p ps=1.96u w=0.64u l=0.13u
X1116 VDD.t352 a_14009_10774# a_14111_10917# VDD.t351 sg13_lv_pmos ad=1.10612p pd=6.66u as=0.3864p ps=2.93u w=1.12u l=0.13u
X1117 a_10430_3889# a_11924_3853# a_11848_3889# VDD.t9 sg13_lv_pmos ad=0.3808p pd=2.92u as=0.2128p ps=1.5u w=1.12u l=0.13u
X1118 VSS.t1455 a_4187_1764.t21 a_13231_1842# VSS.t2376 sg13_lv_nmos ad=0.2516p pd=2.16u as=0.1406p ps=1.12u w=0.74u l=0.6u
X1119 VSS.t73 a_3747_3892.t4 a_21911_3853# VSS.t72 sg13_lv_nmos ad=0.2516p pd=2.16u as=0.2516p ps=2.16u w=0.74u l=0.13u
X1120 a_13753_16869# a_13557_16869# VSS.t1042 VSS.t1041 sg13_lv_nmos ad=0.2516p pd=2.16u as=0.1406p ps=1.12u w=0.74u l=0.13u
X1121 VSS.t619 VDD.t1697 VSS.t622 VSS.t621 sg13_lv_nmos ad=79.8f pd=0.8u as=0 ps=0 w=0.42u l=1u
X1122 VDD.t1322 a_4437_14024# a_4905_13226# VDD.t36 sg13_lv_pmos ad=0.252p pd=1.57u as=0.3808p ps=2.92u w=1.12u l=0.13u
X1123 VSS.t366 a_2019_1047.t3 a_22564_1008# VSS.t365 sg13_lv_nmos ad=0.2516p pd=2.16u as=0.2516p ps=2.16u w=0.74u l=0.13u
X1124 VDD.t507 a_3171_1047.t7 a_11924_1008# VDD.t0 sg13_lv_pmos ad=0.3808p pd=2.92u as=0.3808p ps=2.92u w=1.12u l=0.13u
X1125 VDD.t1344 a_27563_14024# a_27997_14024# VDD.t381 sg13_lv_pmos ad=0.2128p pd=1.5u as=0.3808p ps=2.92u w=1.12u l=0.13u
X1126 a_16510_6734# a_16484_6698# a_16408_6734# VDD.t29 sg13_lv_pmos ad=0.3808p pd=2.92u as=0.2128p ps=1.5u w=1.12u l=0.13u
X1127 a_5393_16869# a_5197_16869# VDD.t494 VDD.t365 sg13_lv_pmos ad=0.3808p pd=2.92u as=0.2128p ps=1.5u w=1.12u l=0.13u
X1128 VDD.t899 a_4187_2434# a_21591_5315# VDD.t339 sg13_lv_pmos ad=0.3808p pd=2.92u as=0.2128p ps=1.5u w=1.12u l=0.6u
X1129 VSS.t1035 a_3747_16074.t8 a_9751_16035# VSS.t1034 sg13_lv_nmos ad=0.2516p pd=2.16u as=0.2516p ps=2.16u w=0.74u l=0.13u
X1130 VSS.t467 a_23003_1842# a_23437_1842# VSS.t2080 sg13_lv_nmos ad=0.1406p pd=1.12u as=0.2516p ps=2.16u w=0.74u l=0.13u
X1131 VSS.t100 VDD.t1645 VSS.t100 VSS.t753 sg13_lv_nmos ad=0.1428p pd=1.52u as=0 ps=0 w=0.42u l=1u
X1132 VSS.t6 a_3747_13229.t9 a_6711_13190# VSS.t5 sg13_lv_nmos ad=0.2516p pd=2.16u as=0.2516p ps=2.16u w=0.74u l=0.13u
X1133 VSS.t1229 a_1721_12513# a_2019_12493.t1 VSS.t1796 sg13_lv_nmos ad=0.2812p pd=2.24u as=0.1406p ps=1.12u w=0.74u l=0.13u
X1134 VSS.t841 VDD.t1620 VSS.t841 VSS.t840 sg13_lv_nmos ad=0.1428p pd=1.52u as=0 ps=0 w=0.42u l=1u
X1135 VSS.t155 a_2595_16074.t9 a_5191_16035# VSS.t154 sg13_lv_nmos ad=0.2516p pd=2.16u as=0.2516p ps=2.16u w=0.74u l=0.13u
X1136 a_19073_7532# a_18877_7532# VSS.t1142 VSS.t1810 sg13_lv_nmos ad=0.2516p pd=2.16u as=0.1406p ps=1.12u w=0.74u l=0.13u
X1137 VDD.t909 a_4187_2434# a_7151_2470# VDD.t353 sg13_lv_pmos ad=0.3808p pd=2.92u as=0.2128p ps=1.5u w=1.12u l=0.6u
X1138 a_20968_3889# a_20397_4687# VSS.t1488 VSS.t1525 sg13_lv_nmos ad=0.1406p pd=1.12u as=0.2516p ps=2.16u w=0.74u l=0.13u
X1139 VDD.t1074 a_3171_6737.t2 a_27124_6698# VDD.t29 sg13_lv_pmos ad=0.3808p pd=2.92u as=0.3808p ps=2.92u w=1.12u l=0.13u
X1140 VSS.t196 a_16851_12491# CHAN1_MUX_OUT VSS.t1612 sg13_lv_nmos ad=0.2516p pd=2.16u as=0.1406p ps=1.12u w=0.74u l=0.13u
X1141 VSS.t52 a_13883_4687# a_14317_4687# VSS.t51 sg13_lv_nmos ad=0.1406p pd=1.12u as=0.2516p ps=2.16u w=0.74u l=0.13u
X1142 a_11491_11918# a_10649_11568# a_11397_11918# VSS.t1370 sg13_lv_nmos ad=0.12665p pd=1.145u as=0.1428p ps=1.52u w=0.42u l=0.13u
X1143 a_25630_3889# a_26471_3853# a_26395_3889# VDD.t9 sg13_lv_pmos ad=0.3808p pd=2.92u as=0.2128p ps=1.5u w=1.12u l=0.13u
X1144 a_19550_6734# a_2019_6737.t4 a_19448_6734# VSS.t1080 sg13_lv_nmos ad=0.2516p pd=2.16u as=0.1406p ps=1.12u w=0.74u l=0.13u
X1145 a_16271_14024# a_16033_14024# a_16163_14024# VSS.t1223 sg13_lv_nmos ad=0.1406p pd=1.12u as=0.2516p ps=2.16u w=0.74u l=0.2u
X1146 a_25630_1044# a_25604_1008# a_25528_1044# VDD.t0 sg13_lv_pmos ad=0.3808p pd=2.92u as=0.2128p ps=1.5u w=1.12u l=0.13u
X1147 a_10430_6734# a_11271_6698# a_11195_6734# VDD.t29 sg13_lv_pmos ad=0.3808p pd=2.92u as=0.2128p ps=1.5u w=1.12u l=0.13u
X1148 VDD.t466 a_2595_13229.t8 a_8231_13190# VDD.t36 sg13_lv_pmos ad=0.3808p pd=2.92u as=0.3808p ps=2.92u w=1.12u l=0.13u
X1149 VDD.t653 VDD.t655 VDD.t656 VDD.t339 sg13_lv_pmos ad=0.2128p pd=1.5u as=0 ps=0 w=1.12u l=0.2u
X1150 VDD.t1330 a_7803_14024# a_8237_14024# VDD.t381 sg13_lv_pmos ad=0.2128p pd=1.5u as=0.3808p ps=2.92u w=1.12u l=0.13u
X1151 VDD.t643 VDD.t641 VDD.t642 VDD.t341 sg13_lv_pmos ad=0.3808p pd=2.92u as=0 ps=0 w=1.12u l=0.6u
X1152 a_20831_14652# a_20593_14024# a_20723_14024# VDD.t381 sg13_lv_pmos ad=0.2128p pd=1.5u as=0.3808p ps=2.92u w=1.12u l=0.2u
X1153 VSS.t396 VDD.t1661 VSS.t396 VSS.t715 sg13_lv_nmos ad=0.1428p pd=1.52u as=0 ps=0 w=0.42u l=1u
X1154 VSS.t1015 a_4187_1764.t114 a_17031_14024# VSS.t1728 sg13_lv_nmos ad=0.2516p pd=2.16u as=0.1406p ps=1.12u w=0.74u l=0.6u
X1155 a_23355_6734# a_23145_6734# VDD.t963 VDD.t29 sg13_lv_pmos ad=0.2128p pd=1.5u as=0.252p ps=1.57u w=1.12u l=0.13u
X1156 a_9675_13226# a_9465_13226# VSS.t1010 VSS.t2342 sg13_lv_nmos ad=0.1406p pd=1.12u as=0.1665p ps=1.19u w=0.74u l=0.13u
X1157 VSS.t516 a_19203_7532# a_19637_7532# VSS.t843 sg13_lv_nmos ad=0.1406p pd=1.12u as=0.2516p ps=2.16u w=0.74u l=0.13u
X1158 VDD.t1498 a_3171_16074.t7 a_11924_16035# VDD.t20 sg13_lv_pmos ad=0.3808p pd=2.92u as=0.3808p ps=2.92u w=1.12u l=0.13u
X1159 VDD.t1452 a_1544_15316# a_2297_15358# VDD.t20 sg13_lv_pmos ad=0.1918p pd=1.5u as=0.1596p ps=1.22u w=0.84u l=0.13u
X1160 VDD.t801 a_4187_2434# a_21591_14652# VDD.t381 sg13_lv_pmos ad=0.3808p pd=2.92u as=0.2128p ps=1.5u w=1.12u l=0.6u
X1161 VDD.t1229 a_3747_6737.t4 a_21911_6698# VDD.t29 sg13_lv_pmos ad=0.3808p pd=2.92u as=0.3808p ps=2.92u w=1.12u l=0.13u
X1162 a_8155_16071# a_7945_16071# VSS.t1528 VSS.t1936 sg13_lv_nmos ad=0.1406p pd=1.12u as=0.1665p ps=1.19u w=0.74u l=0.13u
X1163 VSS.t1206 a_4003_4687# a_4437_4687# VSS.t2210 sg13_lv_nmos ad=0.1406p pd=1.12u as=0.2516p ps=2.16u w=0.74u l=0.13u
X1164 a_14851_10872# a_14009_10774# a_14757_10872# VSS.t38 sg13_lv_nmos ad=0.12665p pd=1.145u as=0.1428p ps=1.52u w=0.42u l=0.13u
X1165 a_15511_1842# a_15273_1842# a_15403_1842# VSS.t1978 sg13_lv_nmos ad=0.1406p pd=1.12u as=0.2516p ps=2.16u w=0.74u l=0.2u
X1166 a_14751_16869# a_14513_16869# a_14643_16869# VSS.t2348 sg13_lv_nmos ad=0.1406p pd=1.12u as=0.2516p ps=2.16u w=0.74u l=0.2u
X1167 a_27433_7532# a_27237_7532# VDD.t698 VDD.t341 sg13_lv_pmos ad=0.3808p pd=2.92u as=0.2128p ps=1.5u w=1.12u l=0.13u
X1168 a_13470_6734# a_2595_6737.t6 a_14235_6734# VSS.t1374 sg13_lv_nmos ad=0.2516p pd=2.16u as=0.1406p ps=1.12u w=0.74u l=0.13u
X1169 VDD.t929 a_10083_16869# a_10517_16869# VDD.t365 sg13_lv_pmos ad=0.2128p pd=1.5u as=0.3808p ps=2.92u w=1.12u l=0.13u
X1170 a_19073_16869# a_18877_16869# VSS.t451 VSS.t1059 sg13_lv_nmos ad=0.2516p pd=2.16u as=0.1406p ps=1.12u w=0.74u l=0.13u
X1171 VSS.t1050 a_8563_7532# a_8997_7532# VSS.t2205 sg13_lv_nmos ad=0.1406p pd=1.12u as=0.2516p ps=2.16u w=0.74u l=0.13u
X1172 VDD.t1296 a_3747_6001.t3 a_14825_6209# VDD.t29 sg13_lv_pmos ad=0.3808p pd=2.92u as=0.3808p ps=2.92u w=1.12u l=0.13u
X1173 a_6391_17497# a_6153_16869# a_6283_16869# VDD.t365 sg13_lv_pmos ad=0.2128p pd=1.5u as=0.3808p ps=2.92u w=1.12u l=0.2u
X1174 VSS.t869 a_9444_10280# a_9444_10280# VSS.t864 sg13_lv_nmos ad=0.68p pd=4.68u as=0.38p ps=2.38u w=2u l=1u
X1175 a_3543_12513# CHAN1_MUX_SEL2 a_3449_12513# VSS.t131 sg13_lv_nmos ad=0.1216p pd=1.02u as=0.2176p ps=1.96u w=0.64u l=0.13u
X1176 VSS.t1098 a_4187_1764.t85 a_13231_7532# VSS.t1097 sg13_lv_nmos ad=0.2516p pd=2.16u as=0.1406p ps=1.12u w=0.74u l=0.6u
X1177 VSS.t12 a_2019_6737.t3 a_22564_6698# VSS.t1751 sg13_lv_nmos ad=0.2516p pd=2.16u as=0.2516p ps=2.16u w=0.74u l=0.13u
X1178 a_20968_6734# a_20397_7532# VDD.t700 VDD.t29 sg13_lv_pmos ad=0.2128p pd=1.5u as=0.3808p ps=2.92u w=1.12u l=0.13u
X1179 VDD.t1336 a_5957_4687# a_6425_3889# VDD.t9 sg13_lv_pmos ad=0.252p pd=1.57u as=0.3808p ps=2.92u w=1.12u l=0.13u
X1180 VDD.t95 VSS.t624 VDD.t230 VDD.t20 sg13_lv_pmos ad=0.34p pd=2.68u as=0 ps=0 w=1u l=1u
X1181 VSS.t525 a_19203_14024# a_19637_14024# VSS.t524 sg13_lv_nmos ad=0.1406p pd=1.12u as=0.2516p ps=2.16u w=0.74u l=0.13u
X1182 a_3171_6001.t0 a_2873_6021# VDD.t582 VDD.t29 sg13_lv_pmos ad=0.2128p pd=1.5u as=0.1918p ps=1.5u w=1.12u l=0.13u
X1183 VSS.t915 VSS.t915 VSS.t917 VSS.t916 sg13_lv_nmos ad=0.2516p pd=2.16u as=0 ps=0 w=0.74u l=0.13u
X1184 VSS.t774 VDD.t1637 VSS.t777 VSS.t776 sg13_lv_nmos ad=79.8f pd=0.8u as=0 ps=0 w=0.42u l=1u
X1185 VDD.t821 a_4187_2434# a_7151_17497# VDD.t365 sg13_lv_pmos ad=0.3808p pd=2.92u as=0.2128p ps=1.5u w=1.12u l=0.6u
X1186 a_16510_13226# a_3171_13229.t5 a_17928_13226# VSS.t2005 sg13_lv_nmos ad=0.2516p pd=2.16u as=0.1406p ps=1.12u w=0.74u l=0.13u
X1187 a_5731_289# a_11785_519# a_10430_1044# VDD.t0 sg13_lv_pmos ad=0.3808p pd=2.92u as=0.3808p ps=2.92u w=1.12u l=0.13u
X1188 VDD.t1276 a_24523_16869# a_24957_16869# VDD.t365 sg13_lv_pmos ad=0.2128p pd=1.5u as=0.3808p ps=2.92u w=1.12u l=0.13u
X1189 VSS.t914 VSS.t911 VSS.t911 VSS.t912 sg13_lv_nmos ad=0.1406p pd=1.12u as=0 ps=0 w=0.74u l=0.13u
X1190 a_18313_1842# a_18117_1842# VDD.t1081 VDD.t353 sg13_lv_pmos ad=0.3808p pd=2.92u as=0.2128p ps=1.5u w=1.12u l=0.13u
X1191 a_5393_14024# a_5197_14024# VDD.t1152 VDD.t381 sg13_lv_pmos ad=0.3808p pd=2.92u as=0.2128p ps=1.5u w=1.12u l=0.13u
X1192 VDD.t725 a_2297_6021# a_2595_6001.t0 VDD.t29 sg13_lv_pmos ad=0.4256p pd=3u as=0.2128p ps=1.5u w=1.12u l=0.13u
X1193 VDD.t352 a_12907_10876# a_12907_11110# VDD.t351 sg13_lv_pmos ad=1.10612p pd=6.66u as=0.2442p ps=2.06u w=0.66u l=0.13u
X1194 VSS.t471 a_23003_7532# a_23437_7532# VSS.t470 sg13_lv_nmos ad=0.1406p pd=1.12u as=0.2516p ps=2.16u w=0.74u l=0.13u
X1195 a_9431_2470# a_9193_1842# a_9323_1842# VDD.t353 sg13_lv_pmos ad=0.2128p pd=1.5u as=0.3808p ps=2.92u w=1.12u l=0.2u
X1196 a_17275_1044# a_17065_1044# VSS.t1601 VSS.t1600 sg13_lv_nmos ad=0.1406p pd=1.12u as=0.1665p ps=1.19u w=0.74u l=0.13u
X1197 a_19448_3889# a_18877_4687# VSS.t305 VSS.t304 sg13_lv_nmos ad=0.1406p pd=1.12u as=0.2516p ps=2.16u w=0.74u l=0.13u
X1198 VDD.t1 VSS.t421 VDD.t70 VDD.t0 sg13_lv_pmos ad=0.34p pd=2.68u as=0 ps=0 w=1u l=1u
X1199 a_10430_3889# a_3171_3892.t7 a_11848_3889# VSS.t1666 sg13_lv_nmos ad=0.2516p pd=2.16u as=0.1406p ps=1.12u w=0.74u l=0.13u
X1200 a_22873_4687# a_22677_4687# VDD.t998 VDD.t339 sg13_lv_pmos ad=0.3808p pd=2.92u as=0.2128p ps=1.5u w=1.12u l=0.13u
X1201 VDD.t768 a_4187_2434# a_7151_8160# VDD.t341 sg13_lv_pmos ad=0.3808p pd=2.92u as=0.2128p ps=1.5u w=1.12u l=0.6u
X1202 VSS.t349 a_3747_1047.t6 a_15831_1008# VSS.t1003 sg13_lv_nmos ad=0.2516p pd=2.16u as=0.2516p ps=2.16u w=0.74u l=0.13u
X1203 VSS.t413 a_3747_311.t2 a_26985_519# VSS.t412 sg13_lv_nmos ad=0.2516p pd=2.16u as=0.2516p ps=2.16u w=0.74u l=0.13u
X1204 VSS.t1850 a_2019_16074.t5 a_16484_16035# VSS.t1849 sg13_lv_nmos ad=0.2516p pd=2.16u as=0.2516p ps=2.16u w=0.74u l=0.13u
X1205 a_5778_9057# VSS.t2296 VSS.t2295 rppd l=32u w=1u
X1206 VSS.t1326 a_13883_1842# a_14317_1842# VSS.t1325 sg13_lv_nmos ad=0.1406p pd=1.12u as=0.2516p ps=2.16u w=0.74u l=0.13u
X1207 a_23871_2470# a_23633_1842# a_23763_1842# VDD.t353 sg13_lv_pmos ad=0.2128p pd=1.5u as=0.3808p ps=2.92u w=1.12u l=0.2u
X1208 VDD.t1373 a_2019_3892.t6 a_13444_3853# VDD.t9 sg13_lv_pmos ad=0.3808p pd=2.92u as=0.3808p ps=2.92u w=1.12u l=0.13u
X1209 a_8433_1842# a_8237_1842# VDD.t460 VDD.t353 sg13_lv_pmos ad=0.3808p pd=2.92u as=0.2128p ps=1.5u w=1.12u l=0.13u
X1210 VDD.t1043 a_9323_16869# a_9757_16869# VDD.t365 sg13_lv_pmos ad=0.2128p pd=1.5u as=0.3808p ps=2.92u w=1.12u l=0.13u
X1211 VDD.t38 VSS.t672 VDD.t37 VDD.t36 sg13_lv_pmos ad=0.34p pd=2.68u as=0 ps=0 w=1u l=1u
X1212 VDD.t102 VSS.t396 VDD.t101 VDD.t29 sg13_lv_pmos ad=0.34p pd=2.68u as=0 ps=0 w=1u l=1u
X1213 VDD.t386 a_18443_1842# a_18877_1842# VDD.t353 sg13_lv_pmos ad=0.2128p pd=1.5u as=0.3808p ps=2.92u w=1.12u l=0.13u
X1214 a_4350_1044# a_2019_1047.t9 a_4248_1044# VSS.t345 sg13_lv_nmos ad=0.2516p pd=2.16u as=0.1406p ps=1.12u w=0.74u l=0.13u
X1215 a_7288_13226# a_6717_14024# VSS.t6 VSS.t1350 sg13_lv_nmos ad=0.1406p pd=1.12u as=0.2516p ps=2.16u w=0.74u l=0.13u
X1216 a_25630_16071# a_27124_16035# a_27048_16071# VDD.t20 sg13_lv_pmos ad=0.3808p pd=2.92u as=0.2128p ps=1.5u w=1.12u l=0.13u
X1217 a_16793_14024# a_16597_14024# VSS.t1422 VSS.t2175 sg13_lv_nmos ad=0.2516p pd=2.16u as=0.1406p ps=1.12u w=0.74u l=0.13u
X1218 VDD.t1066 a_21157_14024# a_21625_13226# VDD.t36 sg13_lv_pmos ad=0.252p pd=1.57u as=0.3808p ps=2.92u w=1.12u l=0.13u
X1219 a_14888_1044# a_14317_1842# VSS.t1301 VSS.t1451 sg13_lv_nmos ad=0.1406p pd=1.12u as=0.2516p ps=2.16u w=0.74u l=0.13u
X1220 VDD.t319 VSS.t273 VDD.t22 VDD.t20 sg13_lv_pmos ad=0.19p pd=1.38u as=0 ps=0 w=1u l=1u
X1221 a_22113_1842# a_21917_1842# VDD.t1408 VDD.t353 sg13_lv_pmos ad=0.3808p pd=2.92u as=0.2128p ps=1.5u w=1.12u l=0.13u
X1222 a_10951_4687# a_10713_4687# a_10843_4687# VSS.t211 sg13_lv_nmos ad=0.1406p pd=1.12u as=0.2516p ps=2.16u w=0.74u l=0.2u
X1223 a_22113_16869# a_21917_16869# VDD.t681 VDD.t365 sg13_lv_pmos ad=0.3808p pd=2.92u as=0.2128p ps=1.5u w=1.12u l=0.13u
X1224 VDD.t1501 a_2019_13229.t4 a_19524_13190# VDD.t36 sg13_lv_pmos ad=0.3808p pd=2.92u as=0.3808p ps=2.92u w=1.12u l=0.13u
X1225 a_12233_14024# a_12037_14024# VSS.t1066 VSS.t1217 sg13_lv_nmos ad=0.2516p pd=2.16u as=0.1406p ps=1.12u w=0.74u l=0.13u
X1226 VDD.t225 VSS.t652 VDD.t224 VDD.t36 sg13_lv_pmos ad=0.34p pd=2.68u as=0 ps=0 w=1u l=1u
X1227 a_16108_289# a_3747_311.t2 a_25630_1044# VSS.t411 sg13_lv_nmos ad=0.2516p pd=2.16u as=0.2516p ps=2.16u w=0.74u l=0.13u
X1228 VSS.t1898 a_2595_13229.t3 a_23431_13190# VSS.t1897 sg13_lv_nmos ad=0.2516p pd=2.16u as=0.2516p ps=2.16u w=0.74u l=0.13u
X1229 VDD.t757 a_1544_12471# a_2297_12513# VDD.t36 sg13_lv_pmos ad=0.1918p pd=1.5u as=0.1596p ps=1.22u w=0.84u l=0.13u
X1230 a_16510_1044# a_16484_1008# a_16408_1044# VDD.t0 sg13_lv_pmos ad=0.3808p pd=2.92u as=0.2128p ps=1.5u w=1.12u l=0.13u
X1231 VSS.t523 a_4003_1842# a_4437_1842# VSS.t522 sg13_lv_nmos ad=0.1406p pd=1.12u as=0.2516p ps=2.16u w=0.74u l=0.13u
X1232 a_25630_3889# a_2595_3892.t2 a_26395_3889# VSS.t1899 sg13_lv_nmos ad=0.2516p pd=2.16u as=0.1406p ps=1.12u w=0.74u l=0.13u
X1233 VDD.t311 VSS.t587 VDD.t310 VDD.t20 sg13_lv_pmos ad=0.19p pd=1.38u as=0 ps=0 w=1u l=1u
X1234 VSS.t32 a_3747_16074.t4 a_21911_16035# VSS.t31 sg13_lv_nmos ad=0.2516p pd=2.16u as=0.2516p ps=2.16u w=0.74u l=0.13u
X1235 a_15511_7532# a_15273_7532# a_15403_7532# VSS.t870 sg13_lv_nmos ad=0.1406p pd=1.12u as=0.2516p ps=2.16u w=0.74u l=0.2u
X1236 VDD.t916 a_4187_2434# a_12471_2470# VDD.t353 sg13_lv_pmos ad=0.3808p pd=2.92u as=0.2128p ps=1.5u w=1.12u l=0.6u
X1237 a_7390_13226# a_2595_13229.t8 a_8155_13226# VSS.t242 sg13_lv_nmos ad=0.2516p pd=2.16u as=0.1406p ps=1.12u w=0.74u l=0.13u
X1238 VSS.t696 VDD.t1669 VSS.t696 VSS.t698 sg13_lv_nmos ad=79.8f pd=0.8u as=0 ps=0 w=0.42u l=1u
X1239 VDD.t566 a_10083_14024# a_10517_14024# VDD.t381 sg13_lv_pmos ad=0.2128p pd=1.5u as=0.3808p ps=2.92u w=1.12u l=0.13u
X1240 a_19448_6734# a_18877_7532# VDD.t1261 VDD.t29 sg13_lv_pmos ad=0.2128p pd=1.5u as=0.3808p ps=2.92u w=1.12u l=0.13u
X1241 VDD.t677 a_3747_3156.t3 a_14825_3364# VDD.t9 sg13_lv_pmos ad=0.3808p pd=2.92u as=0.3808p ps=2.92u w=1.12u l=0.13u
X1242 a_5115_16071# a_4905_16071# VDD.t967 VDD.t20 sg13_lv_pmos ad=0.2128p pd=1.5u as=0.252p ps=1.57u w=1.12u l=0.13u
X1243 a_3747_13229.t0 a_3449_13577# VDD.t434 VDD.t36 sg13_lv_pmos ad=0.2128p pd=1.5u as=0.1918p ps=1.5u w=1.12u l=0.13u
X1244 a_10430_6734# a_11924_6698# a_11848_6734# VDD.t29 sg13_lv_pmos ad=0.3808p pd=2.92u as=0.2128p ps=1.5u w=1.12u l=0.13u
X1245 VDD.t1208 a_3171_1047.t2 a_27124_1008# VDD.t0 sg13_lv_pmos ad=0.3808p pd=2.92u as=0.3808p ps=2.92u w=1.12u l=0.13u
X1246 VDD.t582 a_1256_5979# a_2873_6021# VDD.t29 sg13_lv_pmos ad=0.1918p pd=1.5u as=0.1596p ps=1.22u w=0.84u l=0.13u
X1247 a_6391_14652# a_6153_14024# a_6283_14024# VDD.t381 sg13_lv_pmos ad=0.2128p pd=1.5u as=0.3808p ps=2.92u w=1.12u l=0.2u
X1248 a_4248_3889# a_4157_4158# VDD.t1398 VDD.t9 sg13_lv_pmos ad=0.2128p pd=1.5u as=0.3808p ps=2.92u w=1.12u l=0.13u
X1249 VDD.t1450 a_1256_15316# a_2873_15358# VDD.t20 sg13_lv_pmos ad=0.1918p pd=1.5u as=0.1596p ps=1.22u w=0.84u l=0.13u
X1250 VDD.t1405 a_22243_1842# a_22677_1842# VDD.t353 sg13_lv_pmos ad=0.2128p pd=1.5u as=0.3808p ps=2.92u w=1.12u l=0.13u
X1251 a_6913_16869# a_6717_16869# VDD.t457 VDD.t365 sg13_lv_pmos ad=0.3808p pd=2.92u as=0.2128p ps=1.5u w=1.12u l=0.13u
X1252 VDD.t1280 a_3747_13229.t3 a_24951_13190# VDD.t36 sg13_lv_pmos ad=0.3808p pd=2.92u as=0.3808p ps=2.92u w=1.12u l=0.13u
X1253 a_3171_3156.t1 a_2873_3176# VSS.t93 VSS.t92 sg13_lv_nmos ad=0.1406p pd=1.12u as=0.1331p ps=1.12u w=0.74u l=0.13u
X1254 VDD.t844 a_4187_2434# a_7151_14652# VDD.t381 sg13_lv_pmos ad=0.3808p pd=2.92u as=0.2128p ps=1.5u w=1.12u l=0.6u
X1255 VDD.t383 a_24523_14024# a_24957_14024# VDD.t381 sg13_lv_pmos ad=0.2128p pd=1.5u as=0.3808p ps=2.92u w=1.12u l=0.13u
X1256 VDD.t287 VSS.t656 VDD.t285 VDD.t36 sg13_lv_pmos ad=0.19p pd=1.38u as=0 ps=0 w=1u l=1u
X1257 a_10206_11525# a_10649_11568# a_10589_11604# VDD.t351 sg13_lv_pmos ad=79.8f pd=0.8u as=63f ps=0.72u w=0.42u l=0.13u
X1258 a_18313_7532# a_18117_7532# VDD.t414 VDD.t341 sg13_lv_pmos ad=0.3808p pd=2.92u as=0.2128p ps=1.5u w=1.12u l=0.13u
X1259 a_2595_311.t0 a_2297_331# VDD.t588 VDD.t0 sg13_lv_pmos ad=0.2128p pd=1.5u as=0.1918p ps=1.5u w=1.12u l=0.13u
X1260 VDD.t1168 CHAN3_MUX_SEL3 a_3449_331# VDD.t0 sg13_lv_pmos ad=0.1918p pd=1.5u as=0.1596p ps=1.22u w=0.84u l=0.13u
X1261 VDD.t499 a_13019_11521# a_12943_11557# VDD.t351 sg13_lv_pmos ad=0.2128p pd=1.5u as=0.2128p ps=1.5u w=1.12u l=0.13u
X1262 a_9431_8160# a_9193_7532# a_9323_7532# VDD.t341 sg13_lv_pmos ad=0.2128p pd=1.5u as=0.3808p ps=2.92u w=1.12u l=0.2u
X1263 a_10430_1044# a_11271_1008# a_11195_1044# VDD.t0 sg13_lv_pmos ad=0.3808p pd=2.92u as=0.2128p ps=1.5u w=1.12u l=0.13u
X1264 VDD.t195 VSS.t614 VDD.t194 VDD.t20 sg13_lv_pmos ad=0.19p pd=1.38u as=0 ps=0 w=1u l=1u
X1265 VSS.t93 a_2297_3176# a_2595_3156.t1 VSS.t1275 sg13_lv_nmos ad=0.2812p pd=2.24u as=0.1406p ps=1.12u w=0.74u l=0.13u
X1266 VSS.t1091 a_4187_1764.t45 a_19311_4687# VSS.t1090 sg13_lv_nmos ad=0.2516p pd=2.16u as=0.1406p ps=1.12u w=0.74u l=0.6u
X1267 VSS.t1385 a_3747_16074.t9 a_6711_16035# VSS.t2219 sg13_lv_nmos ad=0.2516p pd=2.16u as=0.2516p ps=2.16u w=0.74u l=0.13u
X1268 a_26395_13226# a_26185_13226# VSS.t1069 VSS.t2343 sg13_lv_nmos ad=0.1406p pd=1.12u as=0.1665p ps=1.19u w=0.74u l=0.13u
X1269 a_17275_6734# a_17065_6734# VSS.t853 VSS.t852 sg13_lv_nmos ad=0.1406p pd=1.12u as=0.1665p ps=1.19u w=0.74u l=0.13u
X1270 VSS.t861 a_9444_10280# a_9444_10280# VSS.t860 sg13_lv_nmos ad=0.68p pd=4.68u as=0.38p ps=2.38u w=2u l=1u
X1271 a_23355_1044# a_23145_1044# VDD.t704 VDD.t0 sg13_lv_pmos ad=0.2128p pd=1.5u as=0.252p ps=1.57u w=1.12u l=0.13u
X1272 a_19550_3889# a_21911_3853# a_21835_3889# VDD.t9 sg13_lv_pmos ad=0.3808p pd=2.92u as=0.2128p ps=1.5u w=1.12u l=0.13u
X1273 VSS.t2046 a_2873_13577# a_3171_13229.t1 VSS.t2060 sg13_lv_nmos ad=0.2812p pd=2.24u as=0.1406p ps=1.12u w=0.74u l=0.13u
X1274 VSS.t1744 a_3747_6737.t6 a_15831_6698# VSS.t1792 sg13_lv_nmos ad=0.2516p pd=2.16u as=0.2516p ps=2.16u w=0.74u l=0.13u
X1275 VSS.t1947 a_5957_4687# a_6425_3889# VSS.t2214 sg13_lv_nmos ad=0.1665p pd=1.19u as=0.2516p ps=2.16u w=0.74u l=0.13u
X1276 VSS.t650 VDD.t1688 VSS.t650 VSS.t649 sg13_lv_nmos ad=0.1428p pd=1.52u as=0 ps=0 w=0.42u l=1u
X1277 a_10649_11568# REF_CLK VSS.t136 VSS.t1778 sg13_lv_nmos ad=0.2516p pd=2.16u as=1.9998p ps=12.915u w=0.74u l=0.13u
X1278 VDD.t689 a_3747_1047.t4 a_21911_1008# VDD.t0 sg13_lv_pmos ad=0.3808p pd=2.92u as=0.3808p ps=2.92u w=1.12u l=0.13u
X1279 VSS.t857 a_8997_1842# a_9465_1044# VSS.t1826 sg13_lv_nmos ad=0.1665p pd=1.19u as=0.2516p ps=2.16u w=0.74u l=0.13u
X1280 a_17791_14024# a_17553_14024# a_17683_14024# VSS.t285 sg13_lv_nmos ad=0.1406p pd=1.12u as=0.2516p ps=2.16u w=0.74u l=0.2u
X1281 a_23871_8160# a_23633_7532# a_23763_7532# VDD.t341 sg13_lv_pmos ad=0.2128p pd=1.5u as=0.3808p ps=2.92u w=1.12u l=0.2u
X1282 VSS.t157 a_13883_7532# a_14317_7532# VSS.t1827 sg13_lv_nmos ad=0.1406p pd=1.12u as=0.2516p ps=2.16u w=0.74u l=0.13u
X1283 a_1721_3176# a_1256_3134# VDD.t695 VDD.t9 sg13_lv_pmos ad=0.1596p pd=1.22u as=0.2856p ps=2.36u w=0.84u l=0.13u
X1284 a_8433_7532# a_8237_7532# VDD.t1247 VDD.t341 sg13_lv_pmos ad=0.3808p pd=2.92u as=0.2128p ps=1.5u w=1.12u l=0.13u
X1285 a_25630_6734# a_26471_6698# a_26395_6734# VDD.t29 sg13_lv_pmos ad=0.3808p pd=2.92u as=0.2128p ps=1.5u w=1.12u l=0.13u
X1286 a_23111_17497# a_22873_16869# a_23003_16869# VDD.t365 sg13_lv_pmos ad=0.2128p pd=1.5u as=0.3808p ps=2.92u w=1.12u l=0.2u
X1287 VDD.t518 a_9323_14024# a_9757_14024# VDD.t381 sg13_lv_pmos ad=0.2128p pd=1.5u as=0.3808p ps=2.92u w=1.12u l=0.13u
X1288 VDD.t1535 a_3747_13229.t8 a_9751_13190# VDD.t36 sg13_lv_pmos ad=0.3808p pd=2.92u as=0.3808p ps=2.92u w=1.12u l=0.13u
X1289 VSS.t387 a_4187_1764.t58 a_9431_4687# VSS.t386 sg13_lv_nmos ad=0.2516p pd=2.16u as=0.1406p ps=1.12u w=0.74u l=0.6u
X1290 VDD.t735 a_18443_7532# a_18877_7532# VDD.t341 sg13_lv_pmos ad=0.2128p pd=1.5u as=0.3808p ps=2.92u w=1.12u l=0.13u
X1291 VDD.t261 VSS.t758 VDD.t330 VDD.t9 sg13_lv_pmos ad=0.34p pd=2.68u as=0 ps=0 w=1u l=1u
X1292 VSS.t1 a_4187_1764.t112 a_18551_14024# VSS.t0 sg13_lv_nmos ad=0.2516p pd=2.16u as=0.1406p ps=1.12u w=0.74u l=0.6u
X1293 a_4350_6734# a_2019_6737.t9 a_4248_6734# VSS.t1075 sg13_lv_nmos ad=0.2516p pd=2.16u as=0.1406p ps=1.12u w=0.74u l=0.13u
X1294 a_22113_7532# a_21917_7532# VDD.t342 VDD.t341 sg13_lv_pmos ad=0.3808p pd=2.92u as=0.2128p ps=1.5u w=1.12u l=0.13u
X1295 a_14888_6734# a_14317_7532# VSS.t496 VSS.t495 sg13_lv_nmos ad=0.1406p pd=1.12u as=0.2516p ps=2.16u w=0.74u l=0.13u
X1296 VDD.t586 a_2595_13229.t9 a_5191_13190# VDD.t36 sg13_lv_pmos ad=0.3808p pd=2.92u as=0.3808p ps=2.92u w=1.12u l=0.13u
X1297 VDD.t209 VSS.t665 VDD.t207 VDD.t36 sg13_lv_pmos ad=0.19p pd=1.38u as=0 ps=0 w=1u l=1u
X1298 VDD.t387 a_2019_16074.t6 a_13444_16035# VDD.t20 sg13_lv_pmos ad=0.3808p pd=2.92u as=0.3808p ps=2.92u w=1.12u l=0.13u
X1299 a_20968_1044# a_20397_1842# VDD.t982 VDD.t0 sg13_lv_pmos ad=0.2128p pd=1.5u as=0.3808p ps=2.92u w=1.12u l=0.13u
X1300 a_25153_4687# a_24957_4687# VDD.t458 VDD.t339 sg13_lv_pmos ad=0.3808p pd=2.92u as=0.2128p ps=1.5u w=1.12u l=0.13u
X1301 a_9675_16071# a_9465_16071# VSS.t1470 VSS.t1987 sg13_lv_nmos ad=0.1406p pd=1.12u as=0.1665p ps=1.19u w=0.74u l=0.13u
X1302 VDD.t749 a_12849_11557# a_13566_11525# VDD.t351 sg13_lv_pmos ad=0.1563p pd=1.22u as=0.147p ps=1.54u w=0.42u l=0.13u
X1303 a_10951_1842# a_10713_1842# a_10843_1842# VSS.t1955 sg13_lv_nmos ad=0.1406p pd=1.12u as=0.2516p ps=2.16u w=0.74u l=0.2u
X1304 VDD.t1045 a_22677_4687# a_23145_3889# VDD.t9 sg13_lv_pmos ad=0.252p pd=1.57u as=0.3808p ps=2.92u w=1.12u l=0.13u
X1305 VSS.t564 a_4187_1764.t40 a_23111_4687# VSS.t563 sg13_lv_nmos ad=0.2516p pd=2.16u as=0.1406p ps=1.12u w=0.74u l=0.6u
X1306 a_22113_14024# a_21917_14024# VDD.t578 VDD.t381 sg13_lv_pmos ad=0.3808p pd=2.92u as=0.2128p ps=1.5u w=1.12u l=0.13u
X1307 a_6635_13226# a_6425_13226# VSS.t1413 VSS.t2052 sg13_lv_nmos ad=0.1406p pd=1.12u as=0.1665p ps=1.19u w=0.74u l=0.13u
X1308 VSS.t70 a_2019_3892.t6 a_13444_3853# VSS.t1997 sg13_lv_nmos ad=0.2516p pd=2.16u as=0.2516p ps=2.16u w=0.74u l=0.13u
X1309 VSS.t179 a_4003_7532# a_4437_7532# VSS.t1373 sg13_lv_nmos ad=0.1406p pd=1.12u as=0.2516p ps=2.16u w=0.74u l=0.13u
X1310 VSS.t349 a_2019_1047.t5 a_16484_1008# VSS.t348 sg13_lv_nmos ad=0.2516p pd=2.16u as=0.2516p ps=2.16u w=0.74u l=0.13u
X1311 VDD.t240 VSS.t696 VDD.t238 VDD.t29 sg13_lv_pmos ad=0.19p pd=1.38u as=0 ps=0 w=1u l=1u
X1312 a_26151_2470# a_25913_1842# a_26043_1842# VDD.t353 sg13_lv_pmos ad=0.2128p pd=1.5u as=0.3808p ps=2.92u w=1.12u l=0.2u
X1313 VDD.t873 a_4187_2434# a_12471_8160# VDD.t341 sg13_lv_pmos ad=0.3808p pd=2.92u as=0.2128p ps=1.5u w=1.12u l=0.6u
X1314 VDD.t1020 a_1721_331# a_2019_311# VDD.t0 sg13_lv_pmos ad=0.4256p pd=3u as=0.2128p ps=1.5u w=1.12u l=0.13u
X1315 a_7911_17497# a_7673_16869# a_7803_16869# VDD.t365 sg13_lv_pmos ad=0.2128p pd=1.5u as=0.3808p ps=2.92u w=1.12u l=0.2u
X1316 a_16033_16869# a_15837_16869# VSS.t1758 VSS.t1759 sg13_lv_nmos ad=0.2516p pd=2.16u as=0.1406p ps=1.12u w=0.74u l=0.13u
X1317 a_13753_1842# a_13557_1842# VDD.t1078 VDD.t353 sg13_lv_pmos ad=0.3808p pd=2.92u as=0.2128p ps=1.5u w=1.12u l=0.13u
X1318 VSS.t687 VDD.t1673 VSS.t687 VSS.t688 sg13_lv_nmos ad=79.8f pd=0.8u as=0 ps=0 w=0.42u l=1u
X1319 VSS.t806 VDD.t1629 VSS.t806 VSS.t807 sg13_lv_nmos ad=79.8f pd=0.8u as=0 ps=0 w=0.42u l=1u
X1320 VSS.t360 a_3171_1047.t9 a_5844_1008# VSS.t1712 sg13_lv_nmos ad=0.2516p pd=2.16u as=0.2516p ps=2.16u w=0.74u l=0.13u
X1321 a_4871_2470# a_4633_1842# a_4763_1842# VDD.t353 sg13_lv_pmos ad=0.2128p pd=1.5u as=0.3808p ps=2.92u w=1.12u l=0.2u
X1322 VDD.t816 a_4187_2434# a_8671_17497# VDD.t365 sg13_lv_pmos ad=0.3808p pd=2.92u as=0.2128p ps=1.5u w=1.12u l=0.6u
X1323 a_19550_13226# a_2019_13229.t4 a_19448_13226# VSS.t2194 sg13_lv_nmos ad=0.2516p pd=2.16u as=0.1406p ps=1.12u w=0.74u l=0.13u
X1324 VDD.t988 a_1256_12471# a_2873_12513# VDD.t36 sg13_lv_pmos ad=0.1918p pd=1.5u as=0.1596p ps=1.22u w=0.84u l=0.13u
X1325 VDD.t962 a_22243_7532# a_22677_7532# VDD.t341 sg13_lv_pmos ad=0.2128p pd=1.5u as=0.3808p ps=2.92u w=1.12u l=0.13u
X1326 VDD.t537 a_2595_311.t2 a_20905_519# VDD.t0 sg13_lv_pmos ad=0.3808p pd=2.92u as=0.3808p ps=2.92u w=1.12u l=0.13u
X1327 VDD.t1579 a_26043_16869# a_26477_16869# VDD.t365 sg13_lv_pmos ad=0.2128p pd=1.5u as=0.3808p ps=2.92u w=1.12u l=0.13u
X1328 VDD.t472 a_5957_7532# a_6425_6734# VDD.t29 sg13_lv_pmos ad=0.252p pd=1.57u as=0.3808p ps=2.92u w=1.12u l=0.13u
X1329 VDD.t589 a_2297_331# a_2595_311.t0 VDD.t0 sg13_lv_pmos ad=0.4256p pd=3u as=0.2128p ps=1.5u w=1.12u l=0.13u
X1330 VDD.t1106 a_2595_6001.t3 a_8745_6209# VDD.t29 sg13_lv_pmos ad=0.3808p pd=2.92u as=0.3808p ps=2.92u w=1.12u l=0.13u
X1331 a_16510_16071# a_3171_16074.t5 a_17928_16071# VSS.t397 sg13_lv_nmos ad=0.2516p pd=2.16u as=0.1406p ps=1.12u w=0.74u l=0.13u
X1332 a_6913_14024# a_6717_14024# VDD.t1017 VDD.t381 sg13_lv_pmos ad=0.3808p pd=2.92u as=0.2128p ps=1.5u w=1.12u l=0.13u
X1333 a_8155_13226# a_7945_13226# VDD.t1016 VDD.t36 sg13_lv_pmos ad=0.2128p pd=1.5u as=0.252p ps=1.57u w=1.12u l=0.13u
X1334 VSS.t760 VDD.t1641 VSS.t760 VSS.t763 sg13_lv_nmos ad=0.1428p pd=1.52u as=0 ps=0 w=0.42u l=1u
X1335 VSS.t903 VSS.t901 VSS.t901 VSS.t902 sg13_lv_nmos ad=0.68p pd=4.68u as=0 ps=0 w=2u l=1u
X1336 VSS.t339 a_2595_1047.t7 a_11271_1008# VSS.t1705 sg13_lv_nmos ad=0.2516p pd=2.16u as=0.2516p ps=2.16u w=0.74u l=0.13u
X1337 VSS.t1357 a_4187_1764.t13 a_19311_1842# VSS.t1356 sg13_lv_nmos ad=0.2516p pd=2.16u as=0.1406p ps=1.12u w=0.74u l=0.6u
X1338 a_5731_3134# a_2595_3156.t3 a_7390_3889# VSS.t1267 sg13_lv_nmos ad=0.2516p pd=2.16u as=0.2516p ps=2.16u w=0.74u l=0.13u
X1339 VSS.t766 VDD.t1640 VSS.t766 VSS.t765 sg13_lv_nmos ad=0.1428p pd=1.52u as=0 ps=0 w=0.42u l=1u
X1340 a_3171_6737.t0 a_2873_7085# VDD.t407 VDD.t29 sg13_lv_pmos ad=0.2128p pd=1.5u as=0.1918p ps=1.5u w=1.12u l=0.13u
X1341 a_4248_3889# a_4157_4158# VSS.t1532 VSS.t2040 sg13_lv_nmos ad=0.1406p pd=1.12u as=0.2516p ps=2.16u w=0.74u l=0.13u
X1342 a_1815_13577# a_1256_13226# a_1721_13577# VSS.t2044 sg13_lv_nmos ad=0.1216p pd=1.02u as=0.2176p ps=1.96u w=0.64u l=0.13u
X1343 VSS.t1237 a_8997_7532# a_9465_6734# VSS.t1789 sg13_lv_nmos ad=0.1665p pd=1.19u as=0.2516p ps=2.16u w=0.74u l=0.13u
X1344 VDD.t482 a_2297_7085# a_2595_6737.t0 VDD.t29 sg13_lv_pmos ad=0.4256p pd=3u as=0.2128p ps=1.5u w=1.12u l=0.13u
X1345 VDD.t1427 a_24523_1842# a_24957_1842# VDD.t353 sg13_lv_pmos ad=0.2128p pd=1.5u as=0.3808p ps=2.92u w=1.12u l=0.13u
X1346 VSS.t308 a_4763_16869# a_5197_16869# VSS.t307 sg13_lv_nmos ad=0.1406p pd=1.12u as=0.2516p ps=2.16u w=0.74u l=0.13u
X1347 VDD.t1219 a_2019_6737.t6 a_13444_6698# VDD.t29 sg13_lv_pmos ad=0.3808p pd=2.92u as=0.3808p ps=2.92u w=1.12u l=0.13u
X1348 a_15270_10795# a_12849_11557# VSS.t1186 VSS.t1185 sg13_lv_nmos ad=37.8f pd=0.6u as=79.8f ps=0.8u w=0.42u l=0.13u
X1349 VSS.t247 a_3747_1047.t8 a_9751_1008# VSS.t246 sg13_lv_nmos ad=0.2516p pd=2.16u as=0.2516p ps=2.16u w=0.74u l=0.13u
X1350 VSS.t37 a_12907_10876# a_12907_10876# VSS.t1227 sg13_lv_nmos ad=1.45407p pd=9.445u as=0.111p ps=1.34u w=0.3u l=0.13u
X1351 a_8808_13226# a_8237_14024# VSS.t244 VSS.t1938 sg13_lv_nmos ad=0.1406p pd=1.12u as=0.2516p ps=2.16u w=0.74u l=0.13u
X1352 a_23111_14652# a_22873_14024# a_23003_14024# VDD.t381 sg13_lv_pmos ad=0.2128p pd=1.5u as=0.3808p ps=2.92u w=1.12u l=0.2u
X1353 a_6126_9506# a_5974_11413# a_6326_10280# VSS.t959 sg13_lv_nmos ad=0.68p pd=4.68u as=0.38p ps=2.38u w=2u l=1u
X1354 VSS.t1112 a_4187_1764.t26 a_9431_1842# VSS.t1111 sg13_lv_nmos ad=0.2516p pd=2.16u as=0.1406p ps=1.12u w=0.74u l=0.6u
X1355 a_19448_1044# a_18877_1842# VDD.t385 VDD.t0 sg13_lv_pmos ad=0.2128p pd=1.5u as=0.3808p ps=2.92u w=1.12u l=0.13u
X1356 a_10430_3889# a_12791_3853# a_12715_3889# VDD.t9 sg13_lv_pmos ad=0.3808p pd=2.92u as=0.2128p ps=1.5u w=1.12u l=0.13u
X1357 a_7288_16071# a_6717_16869# VSS.t1385 VSS.t1384 sg13_lv_nmos ad=0.1406p pd=1.12u as=0.2516p ps=2.16u w=0.74u l=0.13u
X1358 a_10430_1044# a_11924_1008# a_11848_1044# VDD.t0 sg13_lv_pmos ad=0.3808p pd=2.92u as=0.2128p ps=1.5u w=1.12u l=0.13u
X1359 a_19550_3889# a_3747_3892.t4 a_21835_3889# VSS.t71 sg13_lv_nmos ad=0.2516p pd=2.16u as=0.1406p ps=1.12u w=0.74u l=0.13u
X1360 VDD.t66 VSS.t120 VDD.t65 VDD.t20 sg13_lv_pmos ad=0.34p pd=2.68u as=0 ps=0 w=1u l=1u
X1361 a_4248_13226# a_4157_13495# VSS.t1681 VSS.t2078 sg13_lv_nmos ad=0.1406p pd=1.12u as=0.2516p ps=2.16u w=0.74u l=0.13u
X1362 a_2297_7085# REF_MUX_SEL0 VDD.t743 VDD.t29 sg13_lv_pmos ad=0.1596p pd=1.22u as=0.2856p ps=2.36u w=0.84u l=0.13u
X1363 a_24875_3889# a_24665_3889# VDD.t936 VDD.t9 sg13_lv_pmos ad=0.2128p pd=1.5u as=0.252p ps=1.57u w=1.12u l=0.13u
X1364 a_13753_14024# a_13557_14024# VSS.t1319 VSS.t1318 sg13_lv_nmos ad=0.2516p pd=2.16u as=0.1406p ps=1.12u w=0.74u l=0.13u
X1365 VSS.t501 a_11603_4687# a_12037_4687# VSS.t500 sg13_lv_nmos ad=0.1406p pd=1.12u as=0.2516p ps=2.16u w=0.74u l=0.13u
X1366 a_10951_7532# a_10713_7532# a_10843_7532# VSS.t1604 sg13_lv_nmos ad=0.1406p pd=1.12u as=0.2516p ps=2.16u w=0.74u l=0.2u
X1367 VSS.t467 a_4187_1764.t8 a_23111_1842# VSS.t466 sg13_lv_nmos ad=0.2516p pd=2.16u as=0.1406p ps=1.12u w=0.74u l=0.6u
X1368 a_17791_5315# a_17553_4687# a_17683_4687# VDD.t339 sg13_lv_pmos ad=0.2128p pd=1.5u as=0.3808p ps=2.92u w=1.12u l=0.2u
X1369 VDD.t475 a_1544_6734# a_1721_7085# VDD.t29 sg13_lv_pmos ad=0.1918p pd=1.5u as=0.1596p ps=1.22u w=0.84u l=0.13u
X1370 VDD.t1216 a_2595_3892.t3 a_23431_3853# VDD.t9 sg13_lv_pmos ad=0.3808p pd=2.92u as=0.3808p ps=2.92u w=1.12u l=0.13u
X1371 VSS.t87 a_2595_16074.t3 a_23431_16035# VSS.t1698 sg13_lv_nmos ad=0.2516p pd=2.16u as=0.2516p ps=2.16u w=0.74u l=0.13u
X1372 VDD.t1191 a_2019_13229.t5 a_16484_13190# VDD.t36 sg13_lv_pmos ad=0.3808p pd=2.92u as=0.3808p ps=2.92u w=1.12u l=0.13u
X1373 VSS.t1744 a_2019_6737.t5 a_16484_6698# VSS.t1743 sg13_lv_nmos ad=0.2516p pd=2.16u as=0.2516p ps=2.16u w=0.74u l=0.13u
X1374 VDD.t928 a_4187_2434# a_27671_2470# VDD.t353 sg13_lv_pmos ad=0.3808p pd=2.92u as=0.2128p ps=1.5u w=1.12u l=0.6u
X1375 a_24393_4687# a_24197_4687# VSS.t1198 VSS.t1197 sg13_lv_nmos ad=0.2516p pd=2.16u as=0.1406p ps=1.12u w=0.74u l=0.13u
X1376 a_7390_13226# a_3747_13229.t8 a_9675_13226# VSS.t2249 sg13_lv_nmos ad=0.2516p pd=2.16u as=0.1406p ps=1.12u w=0.74u l=0.13u
X1377 VSS.t1426 a_2595_13229.t4 a_20391_13190# VSS.t1687 sg13_lv_nmos ad=0.2516p pd=2.16u as=0.2516p ps=2.16u w=0.74u l=0.13u
X1378 a_26151_8160# a_25913_7532# a_26043_7532# VDD.t341 sg13_lv_pmos ad=0.2128p pd=1.5u as=0.3808p ps=2.92u w=1.12u l=0.2u
X1379 VDD.t177 VSS.t739 VDD.t175 VDD.t9 sg13_lv_pmos ad=0.19p pd=1.38u as=0 ps=0 w=1u l=1u
X1380 VSS.t725 VDD.t1657 VSS.t725 VSS.t726 sg13_lv_nmos ad=79.8f pd=0.8u as=0 ps=0 w=0.42u l=1u
X1381 a_7390_16071# a_2595_16074.t8 a_8155_16071# VSS.t1855 sg13_lv_nmos ad=0.2516p pd=2.16u as=0.1406p ps=1.12u w=0.74u l=0.13u
X1382 VDD.t136 VSS.t575 VDD.t135 VDD.t20 sg13_lv_pmos ad=0.19p pd=1.38u as=0 ps=0 w=1u l=1u
X1383 a_9444_10280# a_6854_11144# a_6854_11144# VSS.t1242 sg13_lv_nmos ad=0.68p pd=4.68u as=0.38p ps=2.38u w=2u l=1u
X1384 VDD.t246 VSS.t687 VDD.t247 VDD.t29 sg13_lv_pmos ad=0.19p pd=1.38u as=0 ps=0 w=1u l=1u
X1385 a_7911_14652# a_7673_14024# a_7803_14024# VDD.t381 sg13_lv_pmos ad=0.2128p pd=1.5u as=0.3808p ps=2.92u w=1.12u l=0.2u
X1386 VDD.t1253 a_13557_4687# a_14025_3889# VDD.t9 sg13_lv_pmos ad=0.252p pd=1.57u as=0.3808p ps=2.92u w=1.12u l=0.13u
X1387 a_13753_7532# a_13557_7532# VDD.t722 VDD.t341 sg13_lv_pmos ad=0.3808p pd=2.92u as=0.2128p ps=1.5u w=1.12u l=0.13u
X1388 VSS.t1568 a_4187_1764.t98 VSS.t1570 VSS.t1569 sg13_lv_nmos ad=1.33p pd=7.38u as=0 ps=0 w=7u l=7u
X1389 a_4871_8160# a_4633_7532# a_4763_7532# VDD.t341 sg13_lv_pmos ad=0.2128p pd=1.5u as=0.3808p ps=2.92u w=1.12u l=0.2u
X1390 VSS.t1170 a_3171_6737.t9 a_5844_6698# VSS.t1450 sg13_lv_nmos ad=0.2516p pd=2.16u as=0.2516p ps=2.16u w=0.74u l=0.13u
X1391 a_4248_6734# a_4157_7003# VDD.t705 VDD.t29 sg13_lv_pmos ad=0.2128p pd=1.5u as=0.3808p ps=2.92u w=1.12u l=0.13u
X1392 VSS.t1397 a_22677_4687# a_23145_3889# VSS.t1396 sg13_lv_nmos ad=0.1665p pd=1.19u as=0.2516p ps=2.16u w=0.74u l=0.13u
X1393 VSS.t183 a_4187_1764.t51 a_14751_4687# VSS.t1862 sg13_lv_nmos ad=0.2516p pd=2.16u as=0.1406p ps=1.12u w=0.74u l=0.6u
X1394 VDD.t1314 a_1721_16422# a_2019_16074.t0 VDD.t20 sg13_lv_pmos ad=0.4256p pd=3u as=0.2128p ps=1.5u w=1.12u l=0.13u
X1395 VDD.t829 a_4187_2434# a_8671_14652# VDD.t381 sg13_lv_pmos ad=0.3808p pd=2.92u as=0.2128p ps=1.5u w=1.12u l=0.6u
X1396 VDD.t1318 a_1256_3889# a_2873_4240# VDD.t9 sg13_lv_pmos ad=0.1918p pd=1.5u as=0.1596p ps=1.22u w=0.84u l=0.13u
X1397 VDD.t541 a_26043_14024# a_26477_14024# VDD.t381 sg13_lv_pmos ad=0.2128p pd=1.5u as=0.3808p ps=2.92u w=1.12u l=0.13u
X1398 VDD.t971 a_2595_3156.t3 a_8745_3364# VDD.t9 sg13_lv_pmos ad=0.3808p pd=2.92u as=0.3808p ps=2.92u w=1.12u l=0.13u
X1399 a_25630_1044# a_26471_1008# a_26395_1044# VDD.t0 sg13_lv_pmos ad=0.3808p pd=2.92u as=0.2128p ps=1.5u w=1.12u l=0.13u
X1400 a_3171_6001.t1 a_2873_6021# VSS.t191 VSS.t535 sg13_lv_nmos ad=0.1406p pd=1.12u as=0.1331p ps=1.12u w=0.74u l=0.13u
X1401 a_27915_13226# a_27705_13226# VSS.t233 VSS.t2106 sg13_lv_nmos ad=0.1406p pd=1.12u as=0.1665p ps=1.19u w=0.74u l=0.13u
X1402 VDD.t1196 a_3747_13229.t4 a_21911_13190# VDD.t36 sg13_lv_pmos ad=0.3808p pd=2.92u as=0.3808p ps=2.92u w=1.12u l=0.13u
X1403 VSS.t185 a_2595_6737.t7 a_11271_6698# VSS.t1443 sg13_lv_nmos ad=0.2516p pd=2.16u as=0.2516p ps=2.16u w=0.74u l=0.13u
X1404 VSS.t516 a_4187_1764.t77 a_19311_7532# VSS.t2386 sg13_lv_nmos ad=0.2516p pd=2.16u as=0.1406p ps=1.12u w=0.74u l=0.6u
X1405 a_21591_5315# a_21353_4687# a_21483_4687# VDD.t339 sg13_lv_pmos ad=0.2128p pd=1.5u as=0.3808p ps=2.92u w=1.12u l=0.2u
X1406 VSS.t191 a_2297_6021# a_2595_6001.t1 VSS.t1125 sg13_lv_nmos ad=0.2812p pd=2.24u as=0.1406p ps=1.12u w=0.74u l=0.13u
X1407 a_26395_16071# a_26185_16071# VSS.t1316 VSS.t1977 sg13_lv_nmos ad=0.1406p pd=1.12u as=0.1665p ps=1.19u w=0.74u l=0.13u
X1408 VSS.t898 VSS.t898 VSS.t900 VSS.t899 sg13_lv_nmos ad=0.68p pd=4.68u as=0 ps=0 w=2u l=1u
X1409 VSS.t1570 a_4187_1764.t98 VSS.t1572 VSS.t1571 sg13_lv_nmos ad=1.33p pd=7.38u as=0 ps=0 w=7u l=7u
X1410 VSS.t1206 a_4187_1764.t65 a_4111_4687# VSS.t1205 sg13_lv_nmos ad=0.2516p pd=2.16u as=0.1406p ps=1.12u w=0.74u l=0.6u
X1411 a_6153_4687# a_5957_4687# VDD.t964 VDD.t339 sg13_lv_pmos ad=0.3808p pd=2.92u as=0.2128p ps=1.5u w=1.12u l=0.13u
X1412 a_23355_13226# a_23145_13226# VSS.t532 VSS.t2102 sg13_lv_nmos ad=0.1406p pd=1.12u as=0.1665p ps=1.19u w=0.74u l=0.13u
X1413 a_2595_12493.t1 a_2297_12513# VSS.t1174 VSS.t1173 sg13_lv_nmos ad=0.1406p pd=1.12u as=0.1331p ps=1.12u w=0.74u l=0.13u
X1414 a_19550_6734# a_21911_6698# a_21835_6734# VDD.t29 sg13_lv_pmos ad=0.3808p pd=2.92u as=0.2128p ps=1.5u w=1.12u l=0.13u
X1415 VSS.t1834 a_2873_16422# a_3171_16074.t1 VSS.t2022 sg13_lv_nmos ad=0.2812p pd=2.24u as=0.1406p ps=1.12u w=0.74u l=0.13u
X1416 VDD.t560 a_16163_4687# a_16597_4687# VDD.t339 sg13_lv_pmos ad=0.2128p pd=1.5u as=0.3808p ps=2.92u w=1.12u l=0.13u
X1417 a_16033_1842# a_15837_1842# VDD.t947 VDD.t353 sg13_lv_pmos ad=0.3808p pd=2.92u as=0.2128p ps=1.5u w=1.12u l=0.13u
X1418 VDD.t413 a_24523_7532# a_24957_7532# VDD.t341 sg13_lv_pmos ad=0.2128p pd=1.5u as=0.3808p ps=2.92u w=1.12u l=0.13u
X1419 a_7151_2470# a_6913_1842# a_7043_1842# VDD.t353 sg13_lv_pmos ad=0.2128p pd=1.5u as=0.3808p ps=2.92u w=1.12u l=0.2u
X1420 VDD.t500 a_15964_289# a_16851_309# VDD.t0 sg13_lv_pmos ad=0.2086p pd=1.5u as=0.34p ps=2.68u w=1u l=0.13u
X1421 a_24631_17497# a_24393_16869# a_24523_16869# VDD.t365 sg13_lv_pmos ad=0.2128p pd=1.5u as=0.3808p ps=2.92u w=1.12u l=0.2u
X1422 VSS.t1874 a_3747_6737.t8 a_9751_6698# VSS.t1873 sg13_lv_nmos ad=0.2516p pd=2.16u as=0.2516p ps=2.16u w=0.74u l=0.13u
X1423 VDD.t76 VSS.t818 VDD.t75 VDD.t0 sg13_lv_pmos ad=0.34p pd=2.68u as=0 ps=0 w=1u l=1u
X1424 VSS.t93 CHAN2_MUX_SEL3 a_3543_3176# VSS.t1619 sg13_lv_nmos ad=0.1331p pd=1.12u as=0.1216p ps=1.02u w=0.64u l=0.13u
X1425 a_14751_14024# a_14513_14024# a_14643_14024# VSS.t1820 sg13_lv_nmos ad=0.1406p pd=1.12u as=0.2516p ps=2.16u w=0.74u l=0.2u
X1426 a_19073_14024# a_18877_14024# VSS.t1 VSS.t2322 sg13_lv_nmos ad=0.2516p pd=2.16u as=0.1406p ps=1.12u w=0.74u l=0.13u
X1427 VSS.t1131 a_4187_1764.t90 a_9431_7532# VSS.t1696 sg13_lv_nmos ad=0.2516p pd=2.16u as=0.1406p ps=1.12u w=0.74u l=0.6u
X1428 VDD.t836 a_4187_2434# a_25391_17497# VDD.t365 sg13_lv_pmos ad=0.3808p pd=2.92u as=0.2128p ps=1.5u w=1.12u l=0.6u
X1429 VDD.t337 a_3747_13229.t9 a_6711_13190# VDD.t36 sg13_lv_pmos ad=0.3808p pd=2.92u as=0.3808p ps=2.92u w=1.12u l=0.13u
X1430 VSS.t745 VDD.t1648 VSS.t745 VSS.t748 sg13_lv_nmos ad=79.8f pd=0.8u as=0 ps=0 w=0.42u l=1u
X1431 a_20071_17497# a_19833_16869# a_19963_16869# VDD.t365 sg13_lv_pmos ad=0.2128p pd=1.5u as=0.3808p ps=2.92u w=1.12u l=0.2u
X1432 a_2391_13577# CHAN1_MUX_SEL0 a_2297_13577# VSS.t479 sg13_lv_nmos ad=0.1216p pd=1.02u as=0.2176p ps=1.96u w=0.64u l=0.13u
X1433 VDD.t893 a_4187_2434# a_10191_5315# VDD.t339 sg13_lv_pmos ad=0.3808p pd=2.92u as=0.2128p ps=1.5u w=1.12u l=0.6u
X1434 VDD.t350 a_5957_1842# a_6425_1044# VDD.t0 sg13_lv_pmos ad=0.252p pd=1.57u as=0.3808p ps=2.92u w=1.12u l=0.13u
X1435 VSS.t821 VDD.t1625 VSS.t823 VSS.t822 sg13_lv_nmos ad=79.8f pd=0.8u as=0 ps=0 w=0.42u l=1u
X1436 VSS.t1110 a_11603_1842# a_12037_1842# VSS.t1973 sg13_lv_nmos ad=0.1406p pd=1.12u as=0.2516p ps=2.16u w=0.74u l=0.13u
X1437 VSS.t471 a_4187_1764.t72 a_23111_7532# VSS.t2259 sg13_lv_nmos ad=0.2516p pd=2.16u as=0.1406p ps=1.12u w=0.74u l=0.6u
X1438 VDD.t963 a_22677_7532# a_23145_6734# VDD.t29 sg13_lv_pmos ad=0.252p pd=1.57u as=0.3808p ps=2.92u w=1.12u l=0.13u
X1439 VDD.t584 a_2019_16074.t7 a_10404_16035# VDD.t20 sg13_lv_pmos ad=0.3808p pd=2.92u as=0.3808p ps=2.92u w=1.12u l=0.13u
X1440 VDD.t63 VSS.t790 VDD.t79 VDD.t0 sg13_lv_pmos ad=0.34p pd=2.68u as=0 ps=0 w=1u l=1u
X1441 VDD.t189 VSS.t725 VDD.t35 VDD.t29 sg13_lv_pmos ad=0.19p pd=1.38u as=0 ps=0 w=1u l=1u
X1442 a_6635_16071# a_6425_16071# VSS.t1382 VSS.t1951 sg13_lv_nmos ad=0.1406p pd=1.12u as=0.1665p ps=1.19u w=0.74u l=0.13u
X1443 VDD.t889 a_4187_2434# a_27671_8160# VDD.t341 sg13_lv_pmos ad=0.3808p pd=2.92u as=0.2128p ps=1.5u w=1.12u l=0.6u
X1444 a_3747_1047.t1 a_3449_1395# VSS.t2136 VSS.t2165 sg13_lv_nmos ad=0.1406p pd=1.12u as=0.1331p ps=1.12u w=0.74u l=0.13u
X1445 a_24393_1842# a_24197_1842# VSS.t374 VSS.t2090 sg13_lv_nmos ad=0.2516p pd=2.16u as=0.1406p ps=1.12u w=0.74u l=0.13u
X1446 VDD.t1116 a_19963_4687# a_20397_4687# VDD.t339 sg13_lv_pmos ad=0.2128p pd=1.5u as=0.3808p ps=2.92u w=1.12u l=0.13u
X1447 VSS.t628 VDD.t1695 VSS.t628 VSS.t627 sg13_lv_nmos ad=0.1428p pd=1.52u as=0 ps=0 w=0.42u l=1u
X1448 VDD.t305 VSS.t814 VDD.t304 VDD.t0 sg13_lv_pmos ad=0.34p pd=2.68u as=0 ps=0 w=1u l=1u
X1449 a_1544_1044# CHAN3_MUX_SEL1 VSS.t2076 VSS.t1617 sg13_lv_nmos ad=0.2516p pd=2.16u as=0.2516p ps=2.16u w=0.74u l=0.13u
X1450 a_10430_3889# a_3747_3892.t7 a_12715_3889# VSS.t68 sg13_lv_nmos ad=0.2516p pd=2.16u as=0.1406p ps=1.12u w=0.74u l=0.13u
X1451 a_17031_4687# a_16793_4687# a_16923_4687# VSS.t968 sg13_lv_nmos ad=0.1406p pd=1.12u as=0.2516p ps=2.16u w=0.74u l=0.2u
X1452 a_17553_16869# a_17357_16869# VSS.t454 VSS.t2151 sg13_lv_nmos ad=0.2516p pd=2.16u as=0.1406p ps=1.12u w=0.74u l=0.13u
X1453 VDD.t622 VDD.t614 VDD.t440 VDD.t351 sg13_lv_pmos ad=0.68p pd=4.68u as=0 ps=0 w=2u l=1u
X1454 a_13470_1044# a_3747_1047.t6 a_15755_1044# VSS.t1002 sg13_lv_nmos ad=0.2516p pd=2.16u as=0.1406p ps=1.12u w=0.74u l=0.13u
X1455 VDD.t83 VSS.t730 VDD.t84 VDD.t9 sg13_lv_pmos ad=0.19p pd=1.38u as=0 ps=0 w=1u l=1u
X1456 a_3171_1047.t0 a_2873_1395# VDD.t752 VDD.t0 sg13_lv_pmos ad=0.2128p pd=1.5u as=0.1918p ps=1.5u w=1.12u l=0.13u
X1457 a_24875_3889# a_24665_3889# VSS.t1200 VSS.t1960 sg13_lv_nmos ad=0.1406p pd=1.12u as=0.1665p ps=1.19u w=0.74u l=0.13u
X1458 a_4871_17497# a_4633_16869# a_4763_16869# VDD.t365 sg13_lv_pmos ad=0.2128p pd=1.5u as=0.3808p ps=2.92u w=1.12u l=0.2u
X1459 VSS.t1258 a_4187_1764.t163 a_4111_16869# VSS.t1634 sg13_lv_nmos ad=0.2516p pd=2.16u as=0.1406p ps=1.12u w=0.74u l=0.6u
X1460 a_9193_16869# a_8997_16869# VDD.t1046 VDD.t365 sg13_lv_pmos ad=0.3808p pd=2.92u as=0.2128p ps=1.5u w=1.12u l=0.13u
X1461 VDD.t540 a_5523_1842# a_5957_1842# VDD.t353 sg13_lv_pmos ad=0.2128p pd=1.5u as=0.3808p ps=2.92u w=1.12u l=0.13u
X1462 a_9675_13226# a_9465_13226# VDD.t693 VDD.t36 sg13_lv_pmos ad=0.2128p pd=1.5u as=0.252p ps=1.57u w=1.12u l=0.13u
X1463 VSS.t534 a_4187_1764.t99 a_4187_2434# VSS.t533 sg13_lv_nmos ad=0.2516p pd=2.16u as=0.6808p ps=3.32u w=0.74u l=0.6u
X1464 VDD.t1240 a_2297_1395# a_2595_1047.t0 VDD.t0 sg13_lv_pmos ad=0.4256p pd=3u as=0.2128p ps=1.5u w=1.12u l=0.13u
X1465 a_22590_3889# a_24084_3853# a_24008_3889# VDD.t9 sg13_lv_pmos ad=0.3808p pd=2.92u as=0.2128p ps=1.5u w=1.12u l=0.13u
X1466 a_19550_16071# a_2019_16074.t4 a_19448_16071# VSS.t2237 sg13_lv_nmos ad=0.2516p pd=2.16u as=0.1406p ps=1.12u w=0.74u l=0.13u
X1467 VDD.t516 a_2019_1047.t6 a_13444_1008# VDD.t0 sg13_lv_pmos ad=0.3808p pd=2.92u as=0.3808p ps=2.92u w=1.12u l=0.13u
X1468 VSS.t1283 a_4187_1764.t19 a_14751_1842# VSS.t1358 sg13_lv_nmos ad=0.2516p pd=2.16u as=0.1406p ps=1.12u w=0.74u l=0.6u
X1469 VSS.t1466 a_2595_3892.t3 a_23431_3853# VSS.t1741 sg13_lv_nmos ad=0.2516p pd=2.16u as=0.2516p ps=2.16u w=0.74u l=0.13u
X1470 VDD.t803 a_4187_2434# a_5631_17497# VDD.t365 sg13_lv_pmos ad=0.3808p pd=2.92u as=0.2128p ps=1.5u w=1.12u l=0.6u
X1471 VDD.t376 a_23003_16869# a_23437_16869# VDD.t365 sg13_lv_pmos ad=0.2128p pd=1.5u as=0.3808p ps=2.92u w=1.12u l=0.13u
X1472 a_4350_16071# a_5191_16035# a_5115_16071# VDD.t20 sg13_lv_pmos ad=0.3808p pd=2.92u as=0.2128p ps=1.5u w=1.12u l=0.13u
X1473 VSS.t1710 a_2595_1047.t2 a_26471_1008# VSS.t1881 sg13_lv_nmos ad=0.2516p pd=2.16u as=0.2516p ps=2.16u w=0.74u l=0.13u
X1474 a_4350_1044# a_2595_1047.t9 a_5115_1044# VSS.t358 sg13_lv_nmos ad=0.2516p pd=2.16u as=0.1406p ps=1.12u w=0.74u l=0.13u
X1475 a_2967_1395# CHAN3_MUX_SEL1 a_2873_1395# VSS.t1618 sg13_lv_nmos ad=0.1216p pd=1.02u as=0.2176p ps=1.96u w=0.64u l=0.13u
X1476 VSS.t508 CHAN2_MUX_SEL4 a_15765_3308# VSS.t970 sg13_lv_nmos ad=0.2516p pd=2.16u as=0.2516p ps=2.16u w=0.74u l=0.13u
X1477 a_2595_311.t1 a_2297_331# VSS.t435 VSS.t561 sg13_lv_nmos ad=0.1406p pd=1.12u as=0.1331p ps=1.12u w=0.74u l=0.13u
X1478 VSS.t581 VDD.t1707 VSS.t581 VSS.t580 sg13_lv_nmos ad=0.1428p pd=1.52u as=0 ps=0 w=0.42u l=1u
X1479 VSS.t1799 a_13557_4687# a_14025_3889# VSS.t1798 sg13_lv_nmos ad=0.1665p pd=1.19u as=0.2516p ps=2.16u w=0.74u l=0.13u
X1480 a_9946_11995# a_10751_11568# a_10206_11525# VDD.t351 sg13_lv_pmos ad=0.1428p pd=1.52u as=79.8f ps=0.8u w=0.42u l=0.13u
X1481 VSS.t1601 a_16597_1842# a_17065_1044# VSS.t2184 sg13_lv_nmos ad=0.1665p pd=1.19u as=0.2516p ps=2.16u w=0.74u l=0.13u
X1482 a_2297_1395# CHAN3_MUX_SEL0 VDD.t1420 VDD.t0 sg13_lv_pmos ad=0.1596p pd=1.22u as=0.2856p ps=2.36u w=0.84u l=0.13u
X1483 VSS.t523 a_4187_1764.t33 a_4111_1842# VSS.t1103 sg13_lv_nmos ad=0.2516p pd=2.16u as=0.1406p ps=1.12u w=0.74u l=0.6u
X1484 VSS.t674 VDD.t1678 VSS.t674 VSS.t675 sg13_lv_nmos ad=0.1428p pd=1.52u as=0 ps=0 w=0.42u l=1u
X1485 a_12943_11557# a_13121_11521# VDD.t499 VDD.t351 sg13_lv_pmos ad=0.3808p pd=2.92u as=0.2128p ps=1.5u w=1.12u l=0.13u
X1486 VSS.t687 VDD.t1671 VSS.t687 VSS.t691 sg13_lv_nmos ad=0.1428p pd=1.52u as=0 ps=0 w=0.42u l=1u
X1487 VSS.t218 a_6283_16869# a_6717_16869# VSS.t217 sg13_lv_nmos ad=0.1406p pd=1.12u as=0.2516p ps=2.16u w=0.74u l=0.13u
X1488 a_25630_13226# a_2595_13229.t2 a_26395_13226# VSS.t1694 sg13_lv_nmos ad=0.2516p pd=2.16u as=0.1406p ps=1.12u w=0.74u l=0.13u
X1489 a_16033_7532# a_15837_7532# VDD.t473 VDD.t341 sg13_lv_pmos ad=0.3808p pd=2.92u as=0.2128p ps=1.5u w=1.12u l=0.13u
X1490 VDD.t470 a_1544_1044# a_1721_1395# VDD.t0 sg13_lv_pmos ad=0.1918p pd=1.5u as=0.1596p ps=1.22u w=0.84u l=0.13u
X1491 VDD.t792 a_4187_2434# a_8671_2470# VDD.t353 sg13_lv_pmos ad=0.3808p pd=2.92u as=0.2128p ps=1.5u w=1.12u l=0.6u
X1492 a_20831_4687# a_20593_4687# a_20723_4687# VSS.t1521 sg13_lv_nmos ad=0.1406p pd=1.12u as=0.2516p ps=2.16u w=0.74u l=0.2u
X1493 a_1815_16422# a_1256_16071# a_1721_16422# VSS.t1832 sg13_lv_nmos ad=0.1216p pd=1.02u as=0.2176p ps=1.96u w=0.64u l=0.13u
X1494 VSS.t267 a_15108_11799# a_14757_11918# VSS.t266 sg13_lv_nmos ad=79.8f pd=0.8u as=0.1428p ps=1.52u w=0.42u l=0.13u
X1495 a_7151_8160# a_6913_7532# a_7043_7532# VDD.t341 sg13_lv_pmos ad=0.2128p pd=1.5u as=0.3808p ps=2.92u w=1.12u l=0.2u
X1496 a_5393_4687# a_5197_4687# VSS.t503 VSS.t2155 sg13_lv_nmos ad=0.2516p pd=2.16u as=0.1406p ps=1.12u w=0.74u l=0.13u
X1497 VSS.t1074 a_4187_1764.t48 a_17031_4687# VSS.t1073 sg13_lv_nmos ad=0.2516p pd=2.16u as=0.1406p ps=1.12u w=0.74u l=0.6u
X1498 a_16510_13226# a_18004_13190# a_17928_13226# VDD.t36 sg13_lv_pmos ad=0.3808p pd=2.92u as=0.2128p ps=1.5u w=1.12u l=0.13u
X1499 VDD.t81 VSS.t788 VDD.t28 VDD.t0 sg13_lv_pmos ad=0.19p pd=1.38u as=0 ps=0 w=1u l=1u
X1500 a_24631_14652# a_24393_14024# a_24523_14024# VDD.t381 sg13_lv_pmos ad=0.2128p pd=1.5u as=0.3808p ps=2.92u w=1.12u l=0.2u
X1501 VSS.t730 VDD.t1653 VSS.t730 VSS.t735 sg13_lv_nmos ad=79.8f pd=0.8u as=0 ps=0 w=0.42u l=1u
X1502 a_25630_3889# a_27991_3853# a_27915_3889# VDD.t9 sg13_lv_pmos ad=0.3808p pd=2.92u as=0.2128p ps=1.5u w=1.12u l=0.13u
X1503 a_8808_16071# a_8237_16869# VSS.t1390 VSS.t1389 sg13_lv_nmos ad=0.1406p pd=1.12u as=0.2516p ps=2.16u w=0.74u l=0.13u
X1504 VSS.t1348 a_7477_14024# a_7945_13226# VSS.t1347 sg13_lv_nmos ad=0.1665p pd=1.19u as=0.2516p ps=2.16u w=0.74u l=0.13u
X1505 a_3171_12493.t1 a_2873_12513# VSS.t1174 VSS.t1291 sg13_lv_nmos ad=0.1406p pd=1.12u as=0.1331p ps=1.12u w=0.74u l=0.13u
X1506 a_10430_6734# a_12791_6698# a_12715_6734# VDD.t29 sg13_lv_pmos ad=0.3808p pd=2.92u as=0.2128p ps=1.5u w=1.12u l=0.13u
X1507 a_20071_14652# a_19833_14024# a_19963_14024# VDD.t381 sg13_lv_pmos ad=0.2128p pd=1.5u as=0.3808p ps=2.92u w=1.12u l=0.2u
X1508 VDD.t863 a_4187_2434# a_25391_14652# VDD.t381 sg13_lv_pmos ad=0.3808p pd=2.92u as=0.2128p ps=1.5u w=1.12u l=0.6u
X1509 a_5768_13226# a_5197_14024# VSS.t553 VSS.t1622 sg13_lv_nmos ad=0.1406p pd=1.12u as=0.2516p ps=2.16u w=0.74u l=0.13u
X1510 VSS.t1756 a_26803_4687# a_27237_4687# VSS.t2140 sg13_lv_nmos ad=0.1406p pd=1.12u as=0.2516p ps=2.16u w=0.74u l=0.13u
X1511 a_25630_16071# a_25604_16035# a_25528_16071# VDD.t20 sg13_lv_pmos ad=0.3808p pd=2.92u as=0.2128p ps=1.5u w=1.12u l=0.13u
X1512 a_4248_1044# a_4157_1313# VDD.t388 VDD.t0 sg13_lv_pmos ad=0.2128p pd=1.5u as=0.3808p ps=2.92u w=1.12u l=0.13u
X1513 a_4248_16071# a_4157_16340# VSS.t1329 VSS.t1967 sg13_lv_nmos ad=0.1406p pd=1.12u as=0.2516p ps=2.16u w=0.74u l=0.13u
X1514 a_19448_16071# a_18877_16869# VDD.t714 VDD.t20 sg13_lv_pmos ad=0.2128p pd=1.5u as=0.3808p ps=2.92u w=1.12u l=0.13u
X1515 VSS.t1140 a_11603_7532# a_12037_7532# VSS.t1139 sg13_lv_nmos ad=0.1406p pd=1.12u as=0.2516p ps=2.16u w=0.74u l=0.13u
X1516 a_24875_6734# a_24665_6734# VDD.t676 VDD.t29 sg13_lv_pmos ad=0.2128p pd=1.5u as=0.252p ps=1.57u w=1.12u l=0.13u
X1517 a_20593_16869# a_20397_16869# VDD.t938 VDD.t365 sg13_lv_pmos ad=0.3808p pd=2.92u as=0.2128p ps=1.5u w=1.12u l=0.13u
X1518 a_18551_16869# a_18313_16869# a_18443_16869# VSS.t2149 sg13_lv_nmos ad=0.1406p pd=1.12u as=0.2516p ps=2.16u w=0.74u l=0.2u
X1519 VDD.t934 a_13883_16869# a_14317_16869# VDD.t365 sg13_lv_pmos ad=0.2128p pd=1.5u as=0.3808p ps=2.92u w=1.12u l=0.13u
X1520 VDD.t273 VSS.t769 VDD.t15 VDD.t9 sg13_lv_pmos ad=0.19p pd=1.38u as=0 ps=0 w=1u l=1u
X1521 a_3747_6737.t1 a_3449_7085# VSS.t207 VSS.t206 sg13_lv_nmos ad=0.1406p pd=1.12u as=0.1331p ps=1.12u w=0.74u l=0.13u
X1522 a_11473_4687# a_11277_4687# VDD.t487 VDD.t339 sg13_lv_pmos ad=0.3808p pd=2.92u as=0.2128p ps=1.5u w=1.12u l=0.13u
X1523 VDD.t1032 a_2595_6737.t3 a_23431_6698# VDD.t29 sg13_lv_pmos ad=0.3808p pd=2.92u as=0.3808p ps=2.92u w=1.12u l=0.13u
X1524 a_7390_16071# a_3747_16074.t8 a_9675_16071# VSS.t1033 sg13_lv_nmos ad=0.2516p pd=2.16u as=0.1406p ps=1.12u w=0.74u l=0.13u
X1525 a_24393_7532# a_24197_7532# VSS.t144 VSS.t1148 sg13_lv_nmos ad=0.2516p pd=2.16u as=0.1406p ps=1.12u w=0.74u l=0.13u
X1526 VSS.t1084 a_2595_16074.t4 a_20391_16035# VSS.t1083 sg13_lv_nmos ad=0.2516p pd=2.16u as=0.2516p ps=2.16u w=0.74u l=0.13u
X1527 a_1544_6734# REF_MUX_SEL1 VSS.t519 VSS.t518 sg13_lv_nmos ad=0.2516p pd=2.16u as=0.2516p ps=2.16u w=0.74u l=0.13u
X1528 a_4350_13226# a_3747_13229.t9 a_6635_13226# VSS.t4 sg13_lv_nmos ad=0.2516p pd=2.16u as=0.1406p ps=1.12u w=0.74u l=0.13u
X1529 a_17031_1842# a_16793_1842# a_16923_1842# VSS.t1284 sg13_lv_nmos ad=0.1406p pd=1.12u as=0.2516p ps=2.16u w=0.74u l=0.2u
X1530 a_13470_6734# a_3747_6737.t6 a_15755_6734# VSS.t1791 sg13_lv_nmos ad=0.2516p pd=2.16u as=0.1406p ps=1.12u w=0.74u l=0.13u
X1531 a_7288_13226# a_6717_14024# VDD.t1018 VDD.t36 sg13_lv_pmos ad=0.2128p pd=1.5u as=0.3808p ps=2.92u w=1.12u l=0.13u
X1532 VSS.t656 VDD.t1683 VSS.t656 VSS.t663 sg13_lv_nmos ad=79.8f pd=0.8u as=0 ps=0 w=0.42u l=1u
X1533 a_12471_2470# a_12233_1842# a_12363_1842# VDD.t353 sg13_lv_pmos ad=0.2128p pd=1.5u as=0.3808p ps=2.92u w=1.12u l=0.2u
X1534 a_13592_11561# a_14111_11568# a_14851_11918# VSS.t266 sg13_lv_nmos ad=0.3473p pd=2.71u as=0.12665p ps=1.145u w=0.74u l=0.13u
X1535 VDD.t723 a_13557_7532# a_14025_6734# VDD.t29 sg13_lv_pmos ad=0.252p pd=1.57u as=0.3808p ps=2.92u w=1.12u l=0.13u
X1536 a_19550_1044# a_21911_1008# a_21835_1044# VDD.t0 sg13_lv_pmos ad=0.3808p pd=2.92u as=0.2128p ps=1.5u w=1.12u l=0.13u
X1537 VSS.t435 a_1721_331# a_2019_311# VSS.t1354 sg13_lv_nmos ad=0.2812p pd=2.24u as=0.1406p ps=1.12u w=0.74u l=0.13u
X1538 a_4871_14652# a_4633_14024# a_4763_14024# VDD.t381 sg13_lv_pmos ad=0.2128p pd=1.5u as=0.3808p ps=2.92u w=1.12u l=0.2u
X1539 VDD.t552 a_15464_9374# a_9712_9602# VSS.t475 sg13_lv_nmos ad=0.232p pd=2.08u as=0.136p ps=1.14u w=0.4u l=0.2u
X1540 a_9193_14024# a_8997_14024# VDD.t692 VDD.t381 sg13_lv_pmos ad=0.3808p pd=2.92u as=0.2128p ps=1.5u w=1.12u l=0.13u
X1541 VDD.t1508 a_5523_7532# a_5957_7532# VDD.t341 sg13_lv_pmos ad=0.2128p pd=1.5u as=0.3808p ps=2.92u w=1.12u l=0.13u
X1542 a_14851_10872# a_14009_10774# a_13592_11113# VDD.t351 sg13_lv_pmos ad=0.2048p pd=1.63u as=0.34p ps=2.68u w=1u l=0.13u
X1543 VSS.t198 a_4187_1764.t83 a_14751_7532# VSS.t1212 sg13_lv_nmos ad=0.2516p pd=2.16u as=0.1406p ps=1.12u w=0.74u l=0.6u
X1544 a_3449_15358# CHAN0_MUX_SEL2 VDD.t1165 VDD.t20 sg13_lv_pmos ad=0.1596p pd=1.22u as=0.2856p ps=2.36u w=0.84u l=0.13u
X1545 a_6854_11144# a_6326_10280# VDD.t446 VDD.t351 sg13_lv_pmos ad=0.38p pd=2.38u as=0.38p ps=2.38u w=2u l=1u
X1546 VDD.t813 a_4187_2434# a_5631_14652# VDD.t381 sg13_lv_pmos ad=0.3808p pd=2.92u as=0.2128p ps=1.5u w=1.12u l=0.6u
X1547 VDD.t1303 a_2595_13229.t3 a_23431_13190# VDD.t36 sg13_lv_pmos ad=0.3808p pd=2.92u as=0.3808p ps=2.92u w=1.12u l=0.13u
X1548 VSS.t652 VDD.t1688 VSS.t650 VSS.t651 sg13_lv_nmos ad=79.8f pd=0.8u as=0 ps=0 w=0.42u l=1u
X1549 VSS.t1448 a_2595_6737.t2 a_26471_6698# VSS.t2247 sg13_lv_nmos ad=0.2516p pd=2.16u as=0.2516p ps=2.16u w=0.74u l=0.13u
X1550 VSS.t435 a_2297_331# a_2595_311.t1 VSS.t562 sg13_lv_nmos ad=0.2812p pd=2.24u as=0.1406p ps=1.12u w=0.74u l=0.13u
X1551 VDD.t1068 a_23003_14024# a_23437_14024# VDD.t381 sg13_lv_pmos ad=0.2128p pd=1.5u as=0.3808p ps=2.92u w=1.12u l=0.13u
X1552 a_2967_7085# REF_MUX_SEL1 a_2873_7085# VSS.t520 sg13_lv_nmos ad=0.1216p pd=1.02u as=0.2176p ps=1.96u w=0.64u l=0.13u
X1553 a_4350_6734# a_2595_6737.t9 a_5115_6734# VSS.t1745 sg13_lv_nmos ad=0.2516p pd=2.16u as=0.1406p ps=1.12u w=0.74u l=0.13u
X1554 a_16108_289# a_26985_519# a_25630_1044# VDD.t0 sg13_lv_pmos ad=0.3808p pd=2.92u as=0.3808p ps=2.92u w=1.12u l=0.13u
X1555 a_27915_16071# a_27705_16071# VSS.t991 VSS.t1969 sg13_lv_nmos ad=0.1406p pd=1.12u as=0.1665p ps=1.19u w=0.74u l=0.13u
X1556 VDD.t253 VSS.t687 VDD.t252 VDD.t29 sg13_lv_pmos ad=0.34p pd=2.68u as=0 ps=0 w=1u l=1u
X1557 a_24875_13226# a_24665_13226# VSS.t1557 VSS.t2133 sg13_lv_nmos ad=0.1406p pd=1.12u as=0.1665p ps=1.19u w=0.74u l=0.13u
X1558 a_7390_13226# a_8231_13190# a_8155_13226# VDD.t36 sg13_lv_pmos ad=0.3808p pd=2.92u as=0.2128p ps=1.5u w=1.12u l=0.13u
X1559 VDD.t989 a_2873_12513# a_3171_12493.t0 VDD.t36 sg13_lv_pmos ad=0.4256p pd=3u as=0.2128p ps=1.5u w=1.12u l=0.13u
X1560 a_16510_16071# a_16484_16035# a_16408_16071# VDD.t20 sg13_lv_pmos ad=0.3808p pd=2.92u as=0.2128p ps=1.5u w=1.12u l=0.13u
X1561 VSS.t179 a_4187_1764.t97 a_4111_7532# VSS.t452 sg13_lv_nmos ad=0.2516p pd=2.16u as=0.1406p ps=1.12u w=0.74u l=0.6u
X1562 a_18795_1044# a_18585_1044# VSS.t1986 VSS.t2290 sg13_lv_nmos ad=0.1406p pd=1.12u as=0.1665p ps=1.19u w=0.74u l=0.13u
X1563 a_19311_4687# a_19073_4687# a_19203_4687# VSS.t976 sg13_lv_nmos ad=0.1406p pd=1.12u as=0.2516p ps=2.16u w=0.74u l=0.2u
X1564 VSS.t853 a_16597_7532# a_17065_6734# VSS.t2284 sg13_lv_nmos ad=0.1665p pd=1.19u as=0.2516p ps=2.16u w=0.74u l=0.13u
X1565 a_23355_16071# a_23145_16071# VSS.t1990 VSS.t1989 sg13_lv_nmos ad=0.1406p pd=1.12u as=0.1665p ps=1.19u w=0.74u l=0.13u
X1566 VSS.t775 VDD.t1637 VSS.t774 VSS.t773 sg13_lv_nmos ad=0.1428p pd=1.52u as=0 ps=0 w=0.42u l=1u
X1567 VDD.t118 VSS.t556 VDD.t117 VDD.t20 sg13_lv_pmos ad=0.34p pd=2.68u as=0 ps=0 w=1u l=1u
X1568 VDD.t704 a_22677_1842# a_23145_1044# VDD.t0 sg13_lv_pmos ad=0.252p pd=1.57u as=0.3808p ps=2.92u w=1.12u l=0.13u
X1569 a_22590_3889# a_3171_3892.t3 a_24008_3889# VSS.t1672 sg13_lv_nmos ad=0.2516p pd=2.16u as=0.1406p ps=1.12u w=0.74u l=0.13u
X1570 VDD.t776 a_4187_2434# a_8671_8160# VDD.t341 sg13_lv_pmos ad=0.3808p pd=2.92u as=0.2128p ps=1.5u w=1.12u l=0.6u
X1571 VSS.t1701 a_2595_1047.t5 a_17351_1008# VSS.t1700 sg13_lv_nmos ad=0.2516p pd=2.16u as=0.2516p ps=2.16u w=0.74u l=0.13u
X1572 a_20831_1842# a_20593_1842# a_20723_1842# VSS.t1016 sg13_lv_nmos ad=0.1406p pd=1.12u as=0.2516p ps=2.16u w=0.74u l=0.2u
X1573 a_25630_1044# a_3171_1047.t2 a_27048_1044# VSS.t1708 sg13_lv_nmos ad=0.2516p pd=2.16u as=0.1406p ps=1.12u w=0.74u l=0.13u
X1574 a_5393_1842# a_5197_1842# VSS.t568 VSS.t1281 sg13_lv_nmos ad=0.2516p pd=2.16u as=0.1406p ps=1.12u w=0.74u l=0.13u
X1575 VSS.t665 VDD.t1681 VSS.t665 VSS.t668 sg13_lv_nmos ad=79.8f pd=0.8u as=0 ps=0 w=0.42u l=1u
X1576 VSS.t236 a_4187_1764.t16 a_17031_1842# VSS.t1106 sg13_lv_nmos ad=0.2516p pd=2.16u as=0.1406p ps=1.12u w=0.74u l=0.6u
X1577 a_5731_15316# a_2595_15338.t3 a_7390_16071# VSS.t1055 sg13_lv_nmos ad=0.2516p pd=2.16u as=0.2516p ps=2.16u w=0.74u l=0.13u
X1578 VSS.t2065 a_1544_13226# a_1815_13577# VSS.t2068 sg13_lv_nmos ad=0.1331p pd=1.12u as=0.1216p ps=1.02u w=0.64u l=0.13u
X1579 a_9953_1842# a_9757_1842# VDD.t1347 VDD.t353 sg13_lv_pmos ad=0.3808p pd=2.92u as=0.2128p ps=1.5u w=1.12u l=0.13u
X1580 VSS.t191 REF_MUX_SEL3 a_3543_6021# VSS.t1147 sg13_lv_nmos ad=0.1331p pd=1.12u as=0.1216p ps=1.02u w=0.64u l=0.13u
X1581 a_21591_17497# a_21353_16869# a_21483_16869# VDD.t365 sg13_lv_pmos ad=0.2128p pd=1.5u as=0.3808p ps=2.92u w=1.12u l=0.2u
X1582 VDD.t841 a_4187_2434# a_26911_17497# VDD.t365 sg13_lv_pmos ad=0.3808p pd=2.92u as=0.2128p ps=1.5u w=1.12u l=0.6u
X1583 VDD.t520 a_10843_1842# a_11277_1842# VDD.t353 sg13_lv_pmos ad=0.2128p pd=1.5u as=0.3808p ps=2.92u w=1.12u l=0.13u
X1584 a_26395_13226# a_26185_13226# VDD.t716 VDD.t36 sg13_lv_pmos ad=0.2128p pd=1.5u as=0.252p ps=1.57u w=1.12u l=0.13u
X1585 VDD.t904 a_4187_2434# a_25391_5315# VDD.t339 sg13_lv_pmos ad=0.3808p pd=2.92u as=0.2128p ps=1.5u w=1.12u l=0.6u
X1586 VSS.t709 VDD.t1663 VSS.t709 VSS.t712 sg13_lv_nmos ad=79.8f pd=0.8u as=0 ps=0 w=0.42u l=1u
X1587 a_16033_14024# a_15837_14024# VSS.t1037 VSS.t1496 sg13_lv_nmos ad=0.2516p pd=2.16u as=0.1406p ps=1.12u w=0.74u l=0.13u
X1588 a_4350_1044# a_3171_1047.t9 a_5768_1044# VSS.t1711 sg13_lv_nmos ad=0.2516p pd=2.16u as=0.1406p ps=1.12u w=0.74u l=0.13u
X1589 a_9444_10280# a_9444_10280# VSS.t868 VSS.t862 sg13_lv_nmos ad=0.38p pd=2.38u as=0.68p ps=4.68u w=2u l=1u
X1590 VSS.t385 a_26803_1842# a_27237_1842# VSS.t2105 sg13_lv_nmos ad=0.1406p pd=1.12u as=0.2516p ps=2.16u w=0.74u l=0.13u
X1591 a_8155_3889# a_7945_3889# VDD.t1384 VDD.t9 sg13_lv_pmos ad=0.2128p pd=1.5u as=0.252p ps=1.57u w=1.12u l=0.13u
X1592 a_5731_5979# a_8745_6209# a_7390_6734# VDD.t29 sg13_lv_pmos ad=0.3808p pd=2.92u as=0.3808p ps=2.92u w=1.12u l=0.13u
X1593 VDD.t840 a_4187_2434# a_22351_17497# VDD.t365 sg13_lv_pmos ad=0.3808p pd=2.92u as=0.2128p ps=1.5u w=1.12u l=0.6u
X1594 a_2391_16422# CHAN0_MUX_SEL0 a_2297_16422# VSS.t2301 sg13_lv_nmos ad=0.1216p pd=1.02u as=0.2176p ps=1.96u w=0.64u l=0.13u
X1595 a_20593_14024# a_20397_14024# VDD.t579 VDD.t381 sg13_lv_pmos ad=0.3808p pd=2.92u as=0.2128p ps=1.5u w=1.12u l=0.13u
X1596 a_23111_4687# a_22873_4687# a_23003_4687# VSS.t1467 sg13_lv_nmos ad=0.1406p pd=1.12u as=0.2516p ps=2.16u w=0.74u l=0.2u
X1597 VDD.t978 a_13883_14024# a_14317_14024# VDD.t381 sg13_lv_pmos ad=0.2128p pd=1.5u as=0.3808p ps=2.92u w=1.12u l=0.13u
X1598 VDD.t442 a_6326_10280# a_6854_11676# VDD.t351 sg13_lv_pmos ad=0.38p pd=2.38u as=0.38p ps=2.38u w=2u l=1u
X1599 a_25630_3889# a_3747_3892.t2 a_27915_3889# VSS.t65 sg13_lv_nmos ad=0.2516p pd=2.16u as=0.1406p ps=1.12u w=0.74u l=0.13u
X1600 a_3747_3892.t1 a_3449_4240# VSS.t125 VSS.t2073 sg13_lv_nmos ad=0.1406p pd=1.12u as=0.1331p ps=1.12u w=0.74u l=0.13u
X1601 a_27048_3889# a_26477_4687# VDD.t1503 VDD.t9 sg13_lv_pmos ad=0.2128p pd=1.5u as=0.3808p ps=2.92u w=1.12u l=0.13u
X1602 VSS.t512 a_17683_4687# a_18117_4687# VSS.t1519 sg13_lv_nmos ad=0.1406p pd=1.12u as=0.2516p ps=2.16u w=0.74u l=0.13u
X1603 a_17031_7532# a_16793_7532# a_16923_7532# VSS.t2164 sg13_lv_nmos ad=0.1406p pd=1.12u as=0.2516p ps=2.16u w=0.74u l=0.2u
X1604 VSS.t616 VDD.t1698 VSS.t616 VSS.t615 sg13_lv_nmos ad=0.1428p pd=1.52u as=0 ps=0 w=0.42u l=1u
X1605 a_12471_8160# a_12233_7532# a_12363_7532# VDD.t341 sg13_lv_pmos ad=0.2128p pd=1.5u as=0.3808p ps=2.92u w=1.12u l=0.2u
X1606 a_10713_4687# a_10517_4687# VSS.t20 VSS.t2122 sg13_lv_nmos ad=0.2516p pd=2.16u as=0.1406p ps=1.12u w=0.74u l=0.13u
X1607 a_11195_13226# a_10985_13226# VSS.t1492 VSS.t2104 sg13_lv_nmos ad=0.1406p pd=1.12u as=0.1665p ps=1.19u w=0.74u l=0.13u
X1608 a_5768_3889# a_5197_4687# VDD.t1477 VDD.t9 sg13_lv_pmos ad=0.2128p pd=1.5u as=0.3808p ps=2.92u w=1.12u l=0.13u
X1609 a_6153_16869# a_5957_16869# VDD.t455 VDD.t365 sg13_lv_pmos ad=0.3808p pd=2.92u as=0.2128p ps=1.5u w=1.12u l=0.13u
X1610 a_22590_6734# a_24084_6698# a_24008_6734# VDD.t29 sg13_lv_pmos ad=0.3808p pd=2.92u as=0.2128p ps=1.5u w=1.12u l=0.13u
X1611 VSS.t1120 a_4763_14024# a_5197_14024# VSS.t1921 sg13_lv_nmos ad=0.1406p pd=1.12u as=0.2516p ps=2.16u w=0.74u l=0.13u
X1612 a_6635_13226# a_6425_13226# VDD.t1055 VDD.t36 sg13_lv_pmos ad=0.2128p pd=1.5u as=0.252p ps=1.57u w=1.12u l=0.13u
X1613 a_3449_12513# CHAN1_MUX_SEL2 VDD.t404 VDD.t36 sg13_lv_pmos ad=0.1596p pd=1.22u as=0.2856p ps=2.36u w=0.84u l=0.13u
X1614 a_10649_11568# REF_CLK VDD.t352 VDD.t351 sg13_lv_pmos ad=0.4088p pd=2.97u as=1.03698p ps=6.245u w=1.12u l=0.13u
X1615 a_22488_13226# a_21917_14024# VSS.t152 VSS.t526 sg13_lv_nmos ad=0.1406p pd=1.12u as=0.2516p ps=2.16u w=0.74u l=0.13u
X1616 VSS.t196 a_15964_12471# a_16851_12491# VSS.t2221 sg13_lv_nmos ad=0.1371p pd=1.12u as=0.2176p ps=1.96u w=0.64u l=0.13u
X1617 a_2967_4240# CHAN2_MUX_SEL1 a_2873_4240# VSS.t123 sg13_lv_nmos ad=0.1216p pd=1.02u as=0.2176p ps=1.96u w=0.64u l=0.13u
X1618 a_10430_1044# a_12791_1008# a_12715_1044# VDD.t0 sg13_lv_pmos ad=0.3808p pd=2.92u as=0.2128p ps=1.5u w=1.12u l=0.13u
X1619 VSS.t1510 a_7803_4687# a_8237_4687# VSS.t2211 sg13_lv_nmos ad=0.1406p pd=1.12u as=0.2516p ps=2.16u w=0.74u l=0.13u
X1620 VDD.t90 VSS.t730 VDD.t89 VDD.t9 sg13_lv_pmos ad=0.34p pd=2.68u as=0 ps=0 w=1u l=1u
X1621 a_18795_6734# a_18585_6734# VSS.t1155 VSS.t1154 sg13_lv_nmos ad=0.1406p pd=1.12u as=0.1665p ps=1.19u w=0.74u l=0.13u
X1622 a_19311_1842# a_19073_1842# a_19203_1842# VSS.t1458 sg13_lv_nmos ad=0.1406p pd=1.12u as=0.2516p ps=2.16u w=0.74u l=0.2u
X1623 a_25630_13226# a_3747_13229.t2 a_27915_13226# VSS.t7 sg13_lv_nmos ad=0.2516p pd=2.16u as=0.1406p ps=1.12u w=0.74u l=0.13u
X1624 a_24875_1044# a_24665_1044# VDD.t1157 VDD.t0 sg13_lv_pmos ad=0.2128p pd=1.5u as=0.252p ps=1.57u w=1.12u l=0.13u
X1625 a_25630_16071# a_2595_16074.t2 a_26395_16071# VSS.t299 sg13_lv_nmos ad=0.2516p pd=2.16u as=0.1406p ps=1.12u w=0.74u l=0.13u
X1626 VDD.t148 VSS.t633 VDD.t66 VDD.t20 sg13_lv_pmos ad=0.19p pd=1.38u as=0 ps=0 w=1u l=1u
X1627 a_19550_13226# a_19524_13190# a_19448_13226# VDD.t36 sg13_lv_pmos ad=0.3808p pd=2.92u as=0.2128p ps=1.5u w=1.12u l=0.13u
X1628 a_20831_7532# a_20593_7532# a_20723_7532# VSS.t2349 sg13_lv_nmos ad=0.1406p pd=1.12u as=0.2516p ps=2.16u w=0.74u l=0.2u
X1629 VSS.t1438 a_2595_6737.t5 a_17351_6698# VSS.t1437 sg13_lv_nmos ad=0.2516p pd=2.16u as=0.2516p ps=2.16u w=0.74u l=0.13u
X1630 a_5393_7532# a_5197_7532# VSS.t189 VSS.t1171 sg13_lv_nmos ad=0.2516p pd=2.16u as=0.1406p ps=1.12u w=0.74u l=0.13u
X1631 a_25630_6734# a_3171_6737.t2 a_27048_6734# VSS.t1446 sg13_lv_nmos ad=0.2516p pd=2.16u as=0.1406p ps=1.12u w=0.74u l=0.13u
X1632 VDD.t1211 a_2595_1047.t3 a_23431_1008# VDD.t0 sg13_lv_pmos ad=0.3808p pd=2.92u as=0.3808p ps=2.92u w=1.12u l=0.13u
X1633 a_22590_13226# a_2595_13229.t3 a_23355_13226# VSS.t1896 sg13_lv_nmos ad=0.2516p pd=2.16u as=0.1406p ps=1.12u w=0.74u l=0.13u
X1634 VSS.t636 VDD.t1693 VSS.t635 VSS.t634 sg13_lv_nmos ad=0.1428p pd=1.52u as=0 ps=0 w=0.42u l=1u
X1635 VSS.t1174 a_2297_12513# a_2595_12493.t1 VSS.t1175 sg13_lv_nmos ad=0.2812p pd=2.24u as=0.1406p ps=1.12u w=0.74u l=0.13u
X1636 VSS.t1819 a_4187_1764.t80 a_17031_7532# VSS.t1861 sg13_lv_nmos ad=0.2516p pd=2.16u as=0.1406p ps=1.12u w=0.74u l=0.6u
X1637 VSS.t1010 a_8997_14024# a_9465_13226# VSS.t1009 sg13_lv_nmos ad=0.1665p pd=1.19u as=0.2516p ps=2.16u w=0.74u l=0.13u
X1638 VDD.t167 VSS.t709 VDD.t165 VDD.t29 sg13_lv_pmos ad=0.19p pd=1.38u as=0 ps=0 w=1u l=1u
X1639 a_9953_7532# a_9757_7532# VDD.t727 VDD.t341 sg13_lv_pmos ad=0.3808p pd=2.92u as=0.2128p ps=1.5u w=1.12u l=0.13u
X1640 a_25630_6734# a_27991_6698# a_27915_6734# VDD.t29 sg13_lv_pmos ad=0.3808p pd=2.92u as=0.2128p ps=1.5u w=1.12u l=0.13u
X1641 a_20315_16071# a_20105_16071# VDD.t1395 VDD.t20 sg13_lv_pmos ad=0.2128p pd=1.5u as=0.252p ps=1.57u w=1.12u l=0.13u
X1642 VDD.t811 a_4187_2434# a_26911_14652# VDD.t381 sg13_lv_pmos ad=0.3808p pd=2.92u as=0.2128p ps=1.5u w=1.12u l=0.6u
X1643 VDD.t426 a_10843_7532# a_11277_7532# VDD.t341 sg13_lv_pmos ad=0.2128p pd=1.5u as=0.3808p ps=2.92u w=1.12u l=0.13u
X1644 VSS.t1528 a_7477_16869# a_7945_16071# VSS.t1527 sg13_lv_nmos ad=0.1665p pd=1.19u as=0.2516p ps=2.16u w=0.74u l=0.13u
X1645 a_21591_14652# a_21353_14024# a_21483_14024# VDD.t381 sg13_lv_pmos ad=0.2128p pd=1.5u as=0.3808p ps=2.92u w=1.12u l=0.2u
X1646 a_16108_5979# a_2019_6001.t2 a_16510_6734# VSS.t1844 sg13_lv_nmos ad=0.2516p pd=2.16u as=0.2516p ps=2.16u w=0.74u l=0.13u
X1647 a_4350_6734# a_3171_6737.t9 a_5768_6734# VSS.t1449 sg13_lv_nmos ad=0.2516p pd=2.16u as=0.1406p ps=1.12u w=0.74u l=0.13u
X1648 VDD.t672 a_13557_1842# a_14025_1044# VDD.t0 sg13_lv_pmos ad=0.252p pd=1.57u as=0.3808p ps=2.92u w=1.12u l=0.13u
X1649 CHAN2_MUX_OUT a_16851_3154# VDD.t567 VDD.t9 sg13_lv_pmos ad=0.2128p pd=1.5u as=0.2086p ps=1.5u w=1.12u l=0.13u
X1650 a_5768_16071# a_5197_16869# VSS.t155 VSS.t1305 sg13_lv_nmos ad=0.1406p pd=1.12u as=0.2516p ps=2.16u w=0.74u l=0.13u
X1651 VSS.t474 a_26803_7532# a_27237_7532# VSS.t1017 sg13_lv_nmos ad=0.1406p pd=1.12u as=0.2516p ps=2.16u w=0.74u l=0.13u
X1652 a_5731_3134# a_8745_3364# a_7390_3889# VDD.t9 sg13_lv_pmos ad=0.3808p pd=2.92u as=0.3808p ps=2.92u w=1.12u l=0.13u
X1653 VDD.t861 a_4187_2434# a_22351_14652# VDD.t381 sg13_lv_pmos ad=0.3808p pd=2.92u as=0.2128p ps=1.5u w=1.12u l=0.6u
X1654 VSS.t577 VDD.t1708 VSS.t579 VSS.t578 sg13_lv_nmos ad=79.8f pd=0.8u as=0 ps=0 w=0.42u l=1u
X1655 a_26673_4687# a_26477_4687# VDD.t1470 VDD.t339 sg13_lv_pmos ad=0.3808p pd=2.92u as=0.2128p ps=1.5u w=1.12u l=0.13u
X1656 VDD.t936 a_24197_4687# a_24665_3889# VDD.t9 sg13_lv_pmos ad=0.252p pd=1.57u as=0.3808p ps=2.92u w=1.12u l=0.13u
X1657 VDD.t352 a_9547_11862# a_9547_11632# VDD.t351 sg13_lv_pmos ad=1.10612p pd=6.66u as=0.2442p ps=2.06u w=0.66u l=0.13u
X1658 a_23111_1842# a_22873_1842# a_23003_1842# VSS.t2037 sg13_lv_nmos ad=0.1406p pd=1.12u as=0.2516p ps=2.16u w=0.74u l=0.2u
X1659 a_16510_3889# a_18004_3853# a_17928_3889# VDD.t9 sg13_lv_pmos ad=0.3808p pd=2.92u as=0.2128p ps=1.5u w=1.12u l=0.13u
X1660 VDD.t366 a_10843_16869# a_11277_16869# VDD.t365 sg13_lv_pmos ad=0.2128p pd=1.5u as=0.3808p ps=2.92u w=1.12u l=0.13u
X1661 a_8808_13226# a_8237_14024# VDD.t1329 VDD.t36 sg13_lv_pmos ad=0.2128p pd=1.5u as=0.3808p ps=2.92u w=1.12u l=0.13u
X1662 VSS.t1461 a_17683_1842# a_18117_1842# VSS.t1460 sg13_lv_nmos ad=0.1406p pd=1.12u as=0.2516p ps=2.16u w=0.74u l=0.13u
X1663 a_27671_2470# a_27433_1842# a_27563_1842# VDD.t353 sg13_lv_pmos ad=0.2128p pd=1.5u as=0.3808p ps=2.92u w=1.12u l=0.2u
X1664 a_7151_17497# a_6913_16869# a_7043_16869# VDD.t365 sg13_lv_pmos ad=0.2128p pd=1.5u as=0.3808p ps=2.92u w=1.12u l=0.2u
X1665 a_4350_16071# a_3747_16074.t9 a_6635_16071# VSS.t2218 sg13_lv_nmos ad=0.2516p pd=2.16u as=0.1406p ps=1.12u w=0.74u l=0.13u
X1666 VSS.t680 VDD.t1676 VSS.t680 VSS.t679 sg13_lv_nmos ad=0.1428p pd=1.52u as=0 ps=0 w=0.42u l=1u
X1667 VSS.t818 VDD.t1626 VSS.t818 VSS.t819 sg13_lv_nmos ad=79.8f pd=0.8u as=0 ps=0 w=0.42u l=1u
X1668 a_10713_1842# a_10517_1842# VSS.t1331 VSS.t2234 sg13_lv_nmos ad=0.2516p pd=2.16u as=0.1406p ps=1.12u w=0.74u l=0.13u
X1669 VDD.t1614 a_3449_3176# a_3747_3156.t0 VDD.t9 sg13_lv_pmos ad=0.4256p pd=3u as=0.2128p ps=1.5u w=1.12u l=0.13u
X1670 a_8155_3889# a_7945_3889# VSS.t2020 VSS.t2019 sg13_lv_nmos ad=0.1406p pd=1.12u as=0.1665p ps=1.19u w=0.74u l=0.13u
X1671 a_4248_13226# a_4157_13495# VDD.t1422 VDD.t36 sg13_lv_pmos ad=0.2128p pd=1.5u as=0.3808p ps=2.92u w=1.12u l=0.13u
X1672 VSS.t994 a_2019_1047.t8 a_7364_1008# VSS.t1879 sg13_lv_nmos ad=0.2516p pd=2.16u as=0.2516p ps=2.16u w=0.74u l=0.13u
X1673 a_6153_14024# a_5957_14024# VDD.t1013 VDD.t381 sg13_lv_pmos ad=0.3808p pd=2.92u as=0.2128p ps=1.5u w=1.12u l=0.13u
X1674 a_14751_4687# a_14513_4687# a_14643_4687# VSS.t847 sg13_lv_nmos ad=0.1406p pd=1.12u as=0.2516p ps=2.16u w=0.74u l=0.2u
X1675 a_2595_16074.t0 a_2297_16422# VDD.t1389 VDD.t20 sg13_lv_pmos ad=0.2128p pd=1.5u as=0.1918p ps=1.5u w=1.12u l=0.13u
X1676 a_27048_3889# a_26477_4687# VSS.t1737 VSS.t2197 sg13_lv_nmos ad=0.1406p pd=1.12u as=0.2516p ps=2.16u w=0.74u l=0.13u
X1677 a_7390_13226# a_9751_13190# a_9675_13226# VDD.t36 sg13_lv_pmos ad=0.3808p pd=2.92u as=0.2128p ps=1.5u w=1.12u l=0.13u
X1678 VDD.t1193 a_2595_13229.t4 a_20391_13190# VDD.t36 sg13_lv_pmos ad=0.3808p pd=2.92u as=0.3808p ps=2.92u w=1.12u l=0.13u
X1679 VSS.t643 VDD.t1691 VSS.t643 VSS.t644 sg13_lv_nmos ad=79.8f pd=0.8u as=0 ps=0 w=0.42u l=1u
X1680 VDD.t849 a_4187_2434# a_6391_5315# VDD.t339 sg13_lv_pmos ad=0.3808p pd=2.92u as=0.2128p ps=1.5u w=1.12u l=0.6u
X1681 VSS.t228 a_7803_1842# a_8237_1842# VSS.t227 sg13_lv_nmos ad=0.1406p pd=1.12u as=0.2516p ps=2.16u w=0.74u l=0.13u
X1682 VSS.t938 VSS.t935 VSS.t935 VSS.t936 sg13_lv_nmos ad=0.1406p pd=1.12u as=0 ps=0 w=0.74u l=0.13u
X1683 a_24875_16071# a_24665_16071# VSS.t1313 VSS.t1983 sg13_lv_nmos ad=0.1406p pd=1.12u as=0.1665p ps=1.19u w=0.74u l=0.13u
X1684 VDD.t1451 a_2873_15358# a_3171_15338.t0 VDD.t20 sg13_lv_pmos ad=0.4256p pd=3u as=0.2128p ps=1.5u w=1.12u l=0.13u
X1685 VSS.t814 VDD.t1627 VSS.t816 VSS.t815 sg13_lv_nmos ad=79.8f pd=0.8u as=0 ps=0 w=0.42u l=1u
X1686 VSS.t2118 a_2873_15358# a_3171_15338.t1 VSS.t2060 sg13_lv_nmos ad=0.2812p pd=2.24u as=0.1406p ps=1.12u w=0.74u l=0.13u
X1687 a_19311_7532# a_19073_7532# a_19203_7532# VSS.t2283 sg13_lv_nmos ad=0.1406p pd=1.12u as=0.2516p ps=2.16u w=0.74u l=0.2u
X1688 VDD.t912 a_4187_2434# a_16271_2470# VDD.t353 sg13_lv_pmos ad=0.3808p pd=2.92u as=0.2128p ps=1.5u w=1.12u l=0.6u
X1689 VSS.t1399 a_8563_16869# a_8997_16869# VSS.t1398 sg13_lv_nmos ad=0.1406p pd=1.12u as=0.2516p ps=2.16u w=0.74u l=0.13u
X1690 a_21835_13226# a_21625_13226# VSS.t1429 VSS.t2116 sg13_lv_nmos ad=0.1406p pd=1.12u as=0.1665p ps=1.19u w=0.74u l=0.13u
X1691 a_13470_16071# a_13444_16035# a_13368_16071# VDD.t20 sg13_lv_pmos ad=0.3808p pd=2.92u as=0.2128p ps=1.5u w=1.12u l=0.13u
X1692 a_5768_3889# a_5197_4687# VSS.t1542 VSS.t2154 sg13_lv_nmos ad=0.1406p pd=1.12u as=0.2516p ps=2.16u w=0.74u l=0.13u
X1693 a_4111_4687# CHAN2_DELAY_IN a_4003_4687# VSS.t1512 sg13_lv_nmos ad=0.1406p pd=1.12u as=0.2516p ps=2.16u w=0.74u l=0.2u
X1694 VDD.t1183 a_3171_3892.t4 a_21044_3853# VDD.t9 sg13_lv_pmos ad=0.3808p pd=2.92u as=0.3808p ps=2.92u w=1.12u l=0.13u
X1695 VSS.t794 VDD.t1632 VSS.t794 VSS.t793 sg13_lv_nmos ad=0.1428p pd=1.52u as=0 ps=0 w=0.42u l=1u
X1696 VDD.t1284 a_1721_4240# a_2019_3892.t0 VDD.t9 sg13_lv_pmos ad=0.4256p pd=3u as=0.2128p ps=1.5u w=1.12u l=0.13u
X1697 VDD.t781 a_4187_2434# a_20831_5315# VDD.t339 sg13_lv_pmos ad=0.3808p pd=2.92u as=0.2128p ps=1.5u w=1.12u l=0.6u
X1698 VDD.t1437 a_26043_1842# a_26477_1842# VDD.t353 sg13_lv_pmos ad=0.2128p pd=1.5u as=0.3808p ps=2.92u w=1.12u l=0.13u
X1699 a_27915_13226# a_27705_13226# VDD.t462 VDD.t36 sg13_lv_pmos ad=0.2128p pd=1.5u as=0.252p ps=1.57u w=1.12u l=0.13u
X1700 VDD.t130 VSS.t100 VDD.t128 VDD.t9 sg13_lv_pmos ad=0.19p pd=1.38u as=0 ps=0 w=1u l=1u
X1701 VSS.t1918 a_1544_16071# a_1815_16422# VSS.t2038 sg13_lv_nmos ad=0.1331p pd=1.12u as=0.1216p ps=1.02u w=0.64u l=0.13u
X1702 a_17553_14024# a_17357_14024# VSS.t1015 VSS.t1014 sg13_lv_nmos ad=0.2516p pd=2.16u as=0.1406p ps=1.12u w=0.74u l=0.13u
X1703 a_5731_15316# a_2019_15338.t3 a_4350_16071# VSS.t250 sg13_lv_nmos ad=0.2516p pd=2.16u as=0.2516p ps=2.16u w=0.74u l=0.13u
X1704 a_22488_1044# a_21917_1842# VSS.t366 VSS.t2062 sg13_lv_nmos ad=0.1406p pd=1.12u as=0.2516p ps=2.16u w=0.74u l=0.13u
X1705 VDD.t420 REF_MUX_SEL4 a_15765_6153# VDD.t29 sg13_lv_pmos ad=0.3808p pd=2.92u as=0.3808p ps=2.92u w=1.12u l=0.13u
X1706 VDD.t837 a_4187_2434# a_23871_17497# VDD.t365 sg13_lv_pmos ad=0.3808p pd=2.92u as=0.2128p ps=1.5u w=1.12u l=0.6u
X1707 VSS.t1122 a_4187_1764.t131 a_4111_14024# VSS.t1121 sg13_lv_nmos ad=0.2516p pd=2.16u as=0.1406p ps=1.12u w=0.74u l=0.6u
X1708 a_3543_331# CHAN3_MUX_SEL2 a_3449_331# VSS.t1662 sg13_lv_nmos ad=0.1216p pd=1.02u as=0.2176p ps=1.96u w=0.64u l=0.13u
X1709 VSS.t687 VDD.t1673 VSS.t687 VSS.t686 sg13_lv_nmos ad=0.1428p pd=1.52u as=0 ps=0 w=0.42u l=1u
X1710 a_23355_13226# a_23145_13226# VDD.t581 VDD.t36 sg13_lv_pmos ad=0.2128p pd=1.5u as=0.252p ps=1.57u w=1.12u l=0.13u
X1711 a_8155_6734# a_7945_6734# VDD.t490 VDD.t29 sg13_lv_pmos ad=0.2128p pd=1.5u as=0.252p ps=1.57u w=1.12u l=0.13u
X1712 a_22590_1044# a_24084_1008# a_24008_1044# VDD.t0 sg13_lv_pmos ad=0.3808p pd=2.92u as=0.2128p ps=1.5u w=1.12u l=0.13u
X1713 VDD.t328 VSS.t783 VDD.t326 VDD.t0 sg13_lv_pmos ad=0.19p pd=1.38u as=0 ps=0 w=1u l=1u
X1714 VSS.t498 a_13123_4687# a_13557_4687# VSS.t2287 sg13_lv_nmos ad=0.1406p pd=1.12u as=0.2516p ps=2.16u w=0.74u l=0.13u
X1715 a_10191_5315# a_9953_4687# a_10083_4687# VDD.t339 sg13_lv_pmos ad=0.2128p pd=1.5u as=0.3808p ps=2.92u w=1.12u l=0.2u
X1716 a_23111_7532# a_22873_7532# a_23003_7532# VSS.t21 sg13_lv_nmos ad=0.1406p pd=1.12u as=0.2516p ps=2.16u w=0.74u l=0.2u
X1717 a_13106_11047# a_12907_11110# VSS.t37 VSS.t175 sg13_lv_nmos ad=0.27427p pd=2.28u as=1.45407p ps=9.445u w=0.795u l=0.13u
X1718 VDD.t784 a_4187_2434# a_20071_2470# VDD.t353 sg13_lv_pmos ad=0.3808p pd=2.92u as=0.2128p ps=1.5u w=1.12u l=0.6u
X1719 VDD.t944 a_10843_14024# a_11277_14024# VDD.t381 sg13_lv_pmos ad=0.2128p pd=1.5u as=0.3808p ps=2.92u w=1.12u l=0.13u
X1720 a_25913_4687# a_25717_4687# VSS.t1309 VSS.t1406 sg13_lv_nmos ad=0.2516p pd=2.16u as=0.1406p ps=1.12u w=0.74u l=0.13u
X1721 a_27048_6734# a_26477_7532# VDD.t1265 VDD.t29 sg13_lv_pmos ad=0.2128p pd=1.5u as=0.3808p ps=2.92u w=1.12u l=0.13u
X1722 a_5731_12471# a_8745_12701# a_7390_13226# VDD.t36 sg13_lv_pmos ad=0.3808p pd=2.92u as=0.3808p ps=2.92u w=1.12u l=0.13u
X1723 a_27671_8160# a_27433_7532# a_27563_7532# VDD.t341 sg13_lv_pmos ad=0.2128p pd=1.5u as=0.3808p ps=2.92u w=1.12u l=0.2u
X1724 VSS.t165 a_17683_7532# a_18117_7532# VSS.t164 sg13_lv_nmos ad=0.1406p pd=1.12u as=0.2516p ps=2.16u w=0.74u l=0.13u
X1725 a_7151_14652# a_6913_14024# a_7043_14024# VDD.t381 sg13_lv_pmos ad=0.2128p pd=1.5u as=0.3808p ps=2.92u w=1.12u l=0.2u
X1726 a_10713_7532# a_10517_7532# VSS.t392 VSS.t391 sg13_lv_nmos ad=0.2516p pd=2.16u as=0.1406p ps=1.12u w=0.74u l=0.13u
X1727 VDD.t594 VDD.t592 VDD.t593 VDD.t365 sg13_lv_pmos ad=0.3808p pd=2.92u as=0 ps=0 w=1.12u l=0.13u
X1728 a_12715_13226# a_12505_13226# VSS.t1219 VSS.t2341 sg13_lv_nmos ad=0.1406p pd=1.12u as=0.1665p ps=1.19u w=0.74u l=0.13u
X1729 VSS.t1100 a_19963_16869# a_20397_16869# VSS.t2304 sg13_lv_nmos ad=0.1406p pd=1.12u as=0.2516p ps=2.16u w=0.74u l=0.13u
X1730 a_7673_16869# a_7477_16869# VDD.t1042 VDD.t365 sg13_lv_pmos ad=0.3808p pd=2.92u as=0.2128p ps=1.5u w=1.12u l=0.13u
X1731 a_11195_16071# a_10985_16071# VSS.t1191 VSS.t1930 sg13_lv_nmos ad=0.1406p pd=1.12u as=0.1665p ps=1.19u w=0.74u l=0.13u
X1732 VSS.t1046 a_6283_14024# a_6717_14024# VSS.t1934 sg13_lv_nmos ad=0.1406p pd=1.12u as=0.2516p ps=2.16u w=0.74u l=0.13u
X1733 VSS.t1069 a_25717_14024# a_26185_13226# VSS.t1068 sg13_lv_nmos ad=0.1665p pd=1.19u as=0.2516p ps=2.16u w=0.74u l=0.13u
X1734 VSS.t16 a_2019_6737.t8 a_7364_6698# VSS.t2245 sg13_lv_nmos ad=0.2516p pd=2.16u as=0.2516p ps=2.16u w=0.74u l=0.13u
X1735 a_5768_6734# a_5197_7532# VDD.t754 VDD.t29 sg13_lv_pmos ad=0.2128p pd=1.5u as=0.3808p ps=2.92u w=1.12u l=0.13u
X1736 VSS.t1200 a_24197_4687# a_24665_3889# VSS.t1199 sg13_lv_nmos ad=0.1665p pd=1.19u as=0.2516p ps=2.16u w=0.74u l=0.13u
X1737 a_24008_13226# a_23437_14024# VSS.t1898 VSS.t1952 sg13_lv_nmos ad=0.1406p pd=1.12u as=0.2516p ps=2.16u w=0.74u l=0.13u
X1738 VDD.t26 VSS.t834 VDD.t25 VDD.t0 sg13_lv_pmos ad=0.19p pd=1.38u as=0 ps=0 w=1u l=1u
X1739 VSS.t1166 a_2873_1395# a_3171_1047.t1 VSS.t94 sg13_lv_nmos ad=0.2812p pd=2.24u as=0.1406p ps=1.12u w=0.74u l=0.13u
X1740 a_16510_3889# a_3171_3892.t5 a_17928_3889# VSS.t1651 sg13_lv_nmos ad=0.2516p pd=2.16u as=0.1406p ps=1.12u w=0.74u l=0.13u
X1741 a_14751_1842# a_14513_1842# a_14643_1842# VSS.t1504 sg13_lv_nmos ad=0.1406p pd=1.12u as=0.2516p ps=2.16u w=0.74u l=0.2u
X1742 a_22488_16071# a_21917_16869# VSS.t32 VSS.t982 sg13_lv_nmos ad=0.1406p pd=1.12u as=0.2516p ps=2.16u w=0.74u l=0.13u
X1743 a_25630_1044# a_27991_1008# a_27915_1044# VDD.t0 sg13_lv_pmos ad=0.3808p pd=2.92u as=0.2128p ps=1.5u w=1.12u l=0.13u
X1744 VDD.t153 VSS.t643 VDD.t152 VDD.t36 sg13_lv_pmos ad=0.34p pd=2.68u as=0 ps=0 w=1u l=1u
X1745 VSS.t1592 a_4187_1764.t98 VSS.t1590 VSS.t1575 sg13_lv_nmos ad=1.33p pd=7.38u as=0 ps=0 w=7u l=7u
X1746 VSS.t1202 a_7803_7532# a_8237_7532# VSS.t1790 sg13_lv_nmos ad=0.1406p pd=1.12u as=0.2516p ps=2.16u w=0.74u l=0.13u
X1747 a_13132_11110# a_13106_11047# VDD.t352 VDD.t351 sg13_lv_pmos ad=0.3927p pd=2.99u as=1.10612p ps=6.66u w=1.155u l=0.13u
X1748 VSS.t947 VSS.t947 VSS.t949 VSS.t948 sg13_lv_nmos ad=0.1406p pd=1.12u as=0 ps=0 w=0.74u l=0.13u
X1749 VDD.t882 a_4187_2434# a_16271_8160# VDD.t341 sg13_lv_pmos ad=0.3808p pd=2.92u as=0.2128p ps=1.5u w=1.12u l=0.6u
X1750 a_7673_4687# a_7477_4687# VDD.t402 VDD.t339 sg13_lv_pmos ad=0.3808p pd=2.92u as=0.2128p ps=1.5u w=1.12u l=0.13u
X1751 VDD.t599 VDD.t597 VDD.t598 VDD.t365 sg13_lv_pmos ad=0.3808p pd=2.92u as=0 ps=0 w=1.12u l=0.6u
X1752 a_25630_16071# a_3747_16074.t2 a_27915_16071# VSS.t24 sg13_lv_nmos ad=0.2516p pd=2.16u as=0.1406p ps=1.12u w=0.74u l=0.13u
X1753 VDD.t782 a_4187_2434# a_10191_17497# VDD.t365 sg13_lv_pmos ad=0.3808p pd=2.92u as=0.2128p ps=1.5u w=1.12u l=0.6u
X1754 a_4111_1842# CHAN3_DELAY_IN a_4003_1842# VSS.t39 sg13_lv_nmos ad=0.1406p pd=1.12u as=0.2516p ps=2.16u w=0.74u l=0.2u
X1755 a_18551_14024# a_18313_14024# a_18443_14024# VSS.t226 sg13_lv_nmos ad=0.1406p pd=1.12u as=0.2516p ps=2.16u w=0.74u l=0.2u
X1756 a_22590_13226# a_3747_13229.t3 a_24875_13226# VSS.t1837 sg13_lv_nmos ad=0.2516p pd=2.16u as=0.1406p ps=1.12u w=0.74u l=0.13u
X1757 a_3171_16074.t0 a_2873_16422# VDD.t1278 VDD.t20 sg13_lv_pmos ad=0.2128p pd=1.5u as=0.1918p ps=1.5u w=1.12u l=0.13u
X1758 VSS.t1548 a_3747_311.t3 a_14825_519# VSS.t1547 sg13_lv_nmos ad=0.2516p pd=2.16u as=0.2516p ps=2.16u w=0.74u l=0.13u
X1759 a_17553_1842# a_17357_1842# VDD.t463 VDD.t353 sg13_lv_pmos ad=0.3808p pd=2.92u as=0.2128p ps=1.5u w=1.12u l=0.13u
X1760 VDD.t232 VSS.t622 VDD.t100 VDD.t20 sg13_lv_pmos ad=0.19p pd=1.38u as=0 ps=0 w=1u l=1u
X1761 VSS.t435 a_1256_289# a_2967_331# VSS.t434 sg13_lv_nmos ad=0.1331p pd=1.12u as=0.1216p ps=1.02u w=0.64u l=0.13u
X1762 VSS.t1782 a_1544_1044# a_2391_1395# VSS.t1801 sg13_lv_nmos ad=0.1331p pd=1.12u as=0.1216p ps=1.02u w=0.64u l=0.13u
X1763 a_22590_16071# a_2595_16074.t3 a_23355_16071# VSS.t1697 sg13_lv_nmos ad=0.2516p pd=2.16u as=0.1406p ps=1.12u w=0.74u l=0.13u
X1764 VDD.t1266 a_26043_7532# a_26477_7532# VDD.t341 sg13_lv_pmos ad=0.2128p pd=1.5u as=0.3808p ps=2.92u w=1.12u l=0.13u
X1765 a_8671_2470# a_8433_1842# a_8563_1842# VDD.t353 sg13_lv_pmos ad=0.2128p pd=1.5u as=0.3808p ps=2.92u w=1.12u l=0.2u
X1766 VSS.t1470 a_8997_16869# a_9465_16071# VSS.t1469 sg13_lv_nmos ad=0.1665p pd=1.19u as=0.2516p ps=2.16u w=0.74u l=0.13u
X1767 a_13470_1044# a_2019_1047.t6 a_13368_1044# VSS.t361 sg13_lv_nmos ad=0.2516p pd=2.16u as=0.1406p ps=1.12u w=0.74u l=0.13u
X1768 a_2019_1047.t1 a_1721_1395# VSS.t254 VSS.t253 sg13_lv_nmos ad=0.1406p pd=1.12u as=0.1331p ps=1.12u w=0.74u l=0.13u
X1769 VSS.t396 VDD.t1659 VSS.t396 VSS.t720 sg13_lv_nmos ad=79.8f pd=0.8u as=0 ps=0 w=0.42u l=1u
X1770 a_6854_11144# a_6854_11144# a_9444_10280# VSS.t1241 sg13_lv_nmos ad=0.38p pd=2.38u as=0.68p ps=4.68u w=2u l=1u
X1771 a_22488_6734# a_21917_7532# VSS.t12 VSS.t11 sg13_lv_nmos ad=0.1406p pd=1.12u as=0.2516p ps=2.16u w=0.74u l=0.13u
X1772 VSS.t760 a_3171_3156.t2 a_23945_3364# VSS.t1272 sg13_lv_nmos ad=0.2516p pd=2.16u as=0.2516p ps=2.16u w=0.74u l=0.13u
X1773 VSS.t93 a_1256_3134# a_2967_3176# VSS.t1012 sg13_lv_nmos ad=0.1331p pd=1.12u as=0.1216p ps=1.02u w=0.64u l=0.13u
X1774 VDD.t246 VSS.t687 VDD.t245 VDD.t29 sg13_lv_pmos ad=0.34p pd=2.68u as=0 ps=0 w=1u l=1u
X1775 VSS.t2346 a_3449_13577# a_3747_13229.t1 VSS.t2345 sg13_lv_nmos ad=0.2812p pd=2.24u as=0.1406p ps=1.12u w=0.74u l=0.13u
X1776 a_15964_289# a_15765_463# a_5731_289# VSS.t517 sg13_lv_nmos ad=0.2183p pd=1.33u as=0.2516p ps=2.16u w=0.74u l=0.13u
X1777 VDD.t675 CHAN2_MUX_SEL4 a_15765_3308# VDD.t9 sg13_lv_pmos ad=0.3808p pd=2.92u as=0.3808p ps=2.92u w=1.12u l=0.13u
X1778 VSS.t1884 a_3747_6001.t3 a_14825_6209# VSS.t1883 sg13_lv_nmos ad=0.2516p pd=2.16u as=0.2516p ps=2.16u w=0.74u l=0.13u
X1779 VDD.t794 a_4187_2434# a_23871_14652# VDD.t381 sg13_lv_pmos ad=0.3808p pd=2.92u as=0.2128p ps=1.5u w=1.12u l=0.6u
X1780 VSS.t1488 a_3171_3892.t4 a_21044_3853# VSS.t1669 sg13_lv_nmos ad=0.2516p pd=2.16u as=0.2516p ps=2.16u w=0.74u l=0.13u
X1781 a_17928_16071# a_17357_16869# VDD.t1474 VDD.t20 sg13_lv_pmos ad=0.2128p pd=1.5u as=0.3808p ps=2.92u w=1.12u l=0.13u
X1782 VDD.t798 a_4187_2434# a_11711_5315# VDD.t339 sg13_lv_pmos ad=0.3808p pd=2.92u as=0.2128p ps=1.5u w=1.12u l=0.6u
X1783 a_3747_6001.t0 a_3449_6021# VDD.t428 VDD.t29 sg13_lv_pmos ad=0.2128p pd=1.5u as=0.1918p ps=1.5u w=1.12u l=0.13u
X1784 a_25630_13226# a_26471_13190# a_26395_13226# VDD.t36 sg13_lv_pmos ad=0.3808p pd=2.92u as=0.2128p ps=1.5u w=1.12u l=0.13u
X1785 VSS.t1304 a_3171_1047.t3 a_24084_1008# VSS.t1303 sg13_lv_nmos ad=0.2516p pd=2.16u as=0.2516p ps=2.16u w=0.74u l=0.13u
X1786 VSS.t1455 a_13123_1842# a_13557_1842# VSS.t1454 sg13_lv_nmos ad=0.1406p pd=1.12u as=0.2516p ps=2.16u w=0.74u l=0.13u
X1787 VDD.t676 a_24197_7532# a_24665_6734# VDD.t29 sg13_lv_pmos ad=0.252p pd=1.57u as=0.3808p ps=2.92u w=1.12u l=0.13u
X1788 VDD.t679 a_12363_16869# a_12797_16869# VDD.t365 sg13_lv_pmos ad=0.2128p pd=1.5u as=0.3808p ps=2.92u w=1.12u l=0.13u
X1789 VDD.t786 a_4187_2434# a_20071_8160# VDD.t341 sg13_lv_pmos ad=0.3808p pd=2.92u as=0.2128p ps=1.5u w=1.12u l=0.6u
X1790 VDD.t18 VSS.t837 VDD.t322 VDD.t0 sg13_lv_pmos ad=0.34p pd=2.68u as=0 ps=0 w=1u l=1u
X1791 a_16510_6734# a_18004_6698# a_17928_6734# VDD.t29 sg13_lv_pmos ad=0.3808p pd=2.92u as=0.2128p ps=1.5u w=1.12u l=0.13u
X1792 a_8671_17497# a_8433_16869# a_8563_16869# VDD.t365 sg13_lv_pmos ad=0.2128p pd=1.5u as=0.3808p ps=2.92u w=1.12u l=0.2u
X1793 a_25913_1842# a_25717_1842# VSS.t2126 VSS.t2125 sg13_lv_nmos ad=0.2516p pd=2.16u as=0.1406p ps=1.12u w=0.74u l=0.13u
X1794 VDD.t495 a_21483_4687# a_21917_4687# VDD.t339 sg13_lv_pmos ad=0.2128p pd=1.5u as=0.3808p ps=2.92u w=1.12u l=0.13u
X1795 VDD.t1016 a_7477_14024# a_7945_13226# VDD.t36 sg13_lv_pmos ad=0.252p pd=1.57u as=0.3808p ps=2.92u w=1.12u l=0.13u
X1796 a_2297_331# CHAN3_MUX_SEL2 VDD.t1178 VDD.t0 sg13_lv_pmos ad=0.1596p pd=1.22u as=0.2856p ps=2.36u w=0.84u l=0.13u
X1797 a_4187_1764.t0 DLL_RESETN VDD.t361 VDD.t360 sg13_lv_pmos ad=0.158p pd=1.245u as=0.272p ps=2.28u w=0.8u l=0.2u
X1798 VSS.t421 VDD.t1625 VSS.t821 VSS.t820 sg13_lv_nmos ad=0.1428p pd=1.52u as=0 ps=0 w=0.42u l=1u
X1799 a_21353_1842# a_21157_1842# VDD.t522 VDD.t353 sg13_lv_pmos ad=0.3808p pd=2.92u as=0.2128p ps=1.5u w=1.12u l=0.13u
X1800 VDD.t605 VDD.t603 VDD.t604 VDD.t381 sg13_lv_pmos ad=0.3808p pd=2.92u as=0 ps=0 w=1.12u l=0.13u
X1801 a_5768_13226# a_5197_14024# VDD.t1153 VDD.t36 sg13_lv_pmos ad=0.2128p pd=1.5u as=0.3808p ps=2.92u w=1.12u l=0.13u
X1802 a_13368_3889# a_12797_4687# VDD.t1238 VDD.t9 sg13_lv_pmos ad=0.2128p pd=1.5u as=0.3808p ps=2.92u w=1.12u l=0.13u
X1803 VDD.t815 a_4187_2434# a_9431_17497# VDD.t365 sg13_lv_pmos ad=0.3808p pd=2.92u as=0.2128p ps=1.5u w=1.12u l=0.6u
X1804 VDD.t684 a_26803_16869# a_27237_16869# VDD.t365 sg13_lv_pmos ad=0.2128p pd=1.5u as=0.3808p ps=2.92u w=1.12u l=0.13u
X1805 a_16108_15316# a_3747_15338.t2 a_25630_16071# VSS.t2381 sg13_lv_nmos ad=0.2516p pd=2.16u as=0.2516p ps=2.16u w=0.74u l=0.13u
X1806 a_7673_14024# a_7477_14024# VDD.t1015 VDD.t381 sg13_lv_pmos ad=0.3808p pd=2.92u as=0.2128p ps=1.5u w=1.12u l=0.13u
X1807 a_2873_331# CHAN3_MUX_SEL3 VDD.t1166 VDD.t0 sg13_lv_pmos ad=0.1596p pd=1.22u as=0.2856p ps=2.36u w=0.84u l=0.13u
X1808 VDD.t1007 a_7043_1842# a_7477_1842# VDD.t353 sg13_lv_pmos ad=0.2128p pd=1.5u as=0.3808p ps=2.92u w=1.12u l=0.13u
X1809 a_15464_9374# a_14851_10872# VDD.t1258 VDD.t351 sg13_lv_pmos ad=0.4312p pd=3.01u as=0.2639p ps=1.81u w=1.12u l=0.13u
X1810 VSS.t134 a_2873_7085# a_3171_6737.t1 VSS.t477 sg13_lv_nmos ad=0.2812p pd=2.24u as=0.1406p ps=1.12u w=0.74u l=0.13u
X1811 VSS.t696 VDD.t1668 VSS.t696 VSS.t699 sg13_lv_nmos ad=0.1428p pd=1.52u as=0 ps=0 w=0.42u l=1u
X1812 a_10430_13226# a_2595_13229.t7 a_11195_13226# VSS.t1684 sg13_lv_nmos ad=0.2516p pd=2.16u as=0.1406p ps=1.12u w=0.74u l=0.13u
X1813 a_14751_7532# a_14513_7532# a_14643_7532# VSS.t1296 sg13_lv_nmos ad=0.1406p pd=1.12u as=0.2516p ps=2.16u w=0.74u l=0.2u
X1814 VSS.t600 VDD.t1702 VSS.t600 VSS.t599 sg13_lv_nmos ad=0.1428p pd=1.52u as=0 ps=0 w=0.42u l=1u
X1815 a_6326_10280# a_6326_10280# VDD.t439 VDD.t351 sg13_lv_pmos ad=0.38p pd=2.38u as=0.38p ps=2.38u w=2u l=1u
X1816 a_5778_9057# a_6126_9506# a_6326_10280# VSS.t956 sg13_lv_nmos ad=0.68p pd=4.68u as=0.42p ps=2.42u w=2u l=1u
X1817 VSS.t923 VSS.t923 VSS.t925 VSS.t924 sg13_lv_nmos ad=0.1406p pd=1.12u as=0 ps=0 w=0.74u l=0.13u
X1818 VSS.t745 VDD.t1648 VSS.t745 VSS.t747 sg13_lv_nmos ad=0.1428p pd=1.52u as=0 ps=0 w=0.42u l=1u
X1819 a_4350_13226# a_6711_13190# a_6635_13226# VDD.t36 sg13_lv_pmos ad=0.3808p pd=2.92u as=0.2128p ps=1.5u w=1.12u l=0.13u
X1820 VDD.t761 a_12849_11557# a_13306_11995# VDD.t351 sg13_lv_pmos ad=0.36237p pd=2.605u as=79.8f ps=0.8u w=0.42u l=0.13u
X1821 CHAN2_DELAY_OUT_LAST a_27997_4687# VSS.t1204 VSS.t1203 sg13_lv_nmos ad=0.2516p pd=2.16u as=0.1406p ps=1.12u w=0.74u l=0.13u
X1822 a_13470_16071# a_14964_16035# a_14888_16071# VDD.t20 sg13_lv_pmos ad=0.3808p pd=2.92u as=0.2128p ps=1.5u w=1.12u l=0.13u
X1823 a_8155_1044# a_7945_1044# VDD.t523 VDD.t0 sg13_lv_pmos ad=0.2128p pd=1.5u as=0.252p ps=1.57u w=1.12u l=0.13u
X1824 a_21835_16071# a_21625_16071# VSS.t81 VSS.t1937 sg13_lv_nmos ad=0.1406p pd=1.12u as=0.1665p ps=1.19u w=0.74u l=0.13u
X1825 a_4350_3889# a_6711_3853# a_6635_3889# VDD.t9 sg13_lv_pmos ad=0.3808p pd=2.92u as=0.2128p ps=1.5u w=1.12u l=0.13u
X1826 VDD.t611 VDD.t609 VDD.t610 VDD.t381 sg13_lv_pmos ad=0.3808p pd=2.92u as=0 ps=0 w=1.12u l=0.6u
X1827 VSS.t553 a_3171_13229.t9 a_5844_13190# VSS.t1689 sg13_lv_nmos ad=0.2516p pd=2.16u as=0.2516p ps=2.16u w=0.74u l=0.13u
X1828 VSS.t1986 a_18117_1842# a_18585_1044# VSS.t1985 sg13_lv_nmos ad=0.1665p pd=1.19u as=0.2516p ps=2.16u w=0.74u l=0.13u
X1829 VSS.t215 a_5523_16869# a_5957_16869# VSS.t214 sg13_lv_nmos ad=0.1406p pd=1.12u as=0.2516p ps=2.16u w=0.74u l=0.13u
X1830 VDD.t853 a_4187_2434# a_10191_14652# VDD.t381 sg13_lv_pmos ad=0.3808p pd=2.92u as=0.2128p ps=1.5u w=1.12u l=0.6u
X1831 a_4111_7532# REF_CLK a_4003_7532# VSS.t1779 sg13_lv_nmos ad=0.1406p pd=1.12u as=0.2516p ps=2.16u w=0.74u l=0.2u
X1832 VDD.t1289 a_3171_6737.t4 a_21044_6698# VDD.t29 sg13_lv_pmos ad=0.3808p pd=2.92u as=0.3808p ps=2.92u w=1.12u l=0.13u
X1833 a_10430_16071# a_10404_16035# a_10328_16071# VDD.t20 sg13_lv_pmos ad=0.3808p pd=2.92u as=0.2128p ps=1.5u w=1.12u l=0.13u
X1834 a_17553_7532# a_17357_7532# VDD.t1268 VDD.t341 sg13_lv_pmos ad=0.3808p pd=2.92u as=0.2128p ps=1.5u w=1.12u l=0.13u
X1835 VSS.t275 a_1544_6734# a_2391_7085# VSS.t1164 sg13_lv_nmos ad=0.1331p pd=1.12u as=0.1216p ps=1.02u w=0.64u l=0.13u
X1836 VDD.t112 VSS.t396 VDD.t110 VDD.t29 sg13_lv_pmos ad=0.19p pd=1.38u as=0 ps=0 w=1u l=1u
X1837 a_8671_8160# a_8433_7532# a_8563_7532# VDD.t341 sg13_lv_pmos ad=0.2128p pd=1.5u as=0.3808p ps=2.92u w=1.12u l=0.2u
X1838 a_6913_4687# a_6717_4687# VSS.t213 VSS.t414 sg13_lv_nmos ad=0.2516p pd=2.16u as=0.1406p ps=1.12u w=0.74u l=0.13u
X1839 VSS.t303 a_4187_1764.t46 a_18551_4687# VSS.t547 sg13_lv_nmos ad=0.2516p pd=2.16u as=0.1406p ps=1.12u w=0.74u l=0.6u
X1840 a_27048_1044# a_26477_1842# VDD.t1438 VDD.t0 sg13_lv_pmos ad=0.2128p pd=1.5u as=0.3808p ps=2.92u w=1.12u l=0.13u
X1841 a_19550_3889# a_20391_3853# a_20315_3889# VDD.t9 sg13_lv_pmos ad=0.3808p pd=2.92u as=0.2128p ps=1.5u w=1.12u l=0.13u
X1842 a_2019_6737.t1 a_1721_7085# VSS.t264 VSS.t263 sg13_lv_nmos ad=0.1406p pd=1.12u as=0.1331p ps=1.12u w=0.74u l=0.13u
X1843 a_13470_6734# a_2019_6737.t6 a_13368_6734# VSS.t1747 sg13_lv_nmos ad=0.2516p pd=2.16u as=0.1406p ps=1.12u w=0.74u l=0.13u
X1844 a_24393_16869# a_24197_16869# VDD.t539 VDD.t365 sg13_lv_pmos ad=0.3808p pd=2.92u as=0.2128p ps=1.5u w=1.12u l=0.13u
X1845 VDD.t83 VSS.t730 VDD.t82 VDD.t9 sg13_lv_pmos ad=0.34p pd=2.68u as=0 ps=0 w=1u l=1u
X1846 a_24875_13226# a_24665_13226# VDD.t1131 VDD.t36 sg13_lv_pmos ad=0.2128p pd=1.5u as=0.252p ps=1.57u w=1.12u l=0.13u
X1847 VDD.t710 a_17683_16869# a_18117_16869# VDD.t365 sg13_lv_pmos ad=0.2128p pd=1.5u as=0.3808p ps=2.92u w=1.12u l=0.13u
X1848 VSS.t656 VDD.t1685 VSS.t656 VSS.t658 sg13_lv_nmos ad=0.1428p pd=1.52u as=0 ps=0 w=0.42u l=1u
X1849 VDD.t1150 CHAN2_MUX_SEL3 a_3449_3176# VDD.t9 sg13_lv_pmos ad=0.1918p pd=1.5u as=0.1596p ps=1.22u w=0.84u l=0.13u
X1850 VDD.t834 a_4187_2434# a_20831_17497# VDD.t365 sg13_lv_pmos ad=0.3808p pd=2.92u as=0.2128p ps=1.5u w=1.12u l=0.6u
X1851 a_6326_10280# a_6126_9506# a_5778_9057# VSS.t956 sg13_lv_nmos ad=0.38p pd=2.38u as=0.68p ps=4.68u w=2u l=1u
X1852 a_25391_5315# a_25153_4687# a_25283_4687# VDD.t339 sg13_lv_pmos ad=0.2128p pd=1.5u as=0.3808p ps=2.92u w=1.12u l=0.2u
X1853 a_19550_16071# a_20391_16035# a_20315_16071# VDD.t20 sg13_lv_pmos ad=0.3808p pd=2.92u as=0.2128p ps=1.5u w=1.12u l=0.13u
X1854 VSS.t608 VDD.t1700 VSS.t607 VSS.t606 sg13_lv_nmos ad=0.1428p pd=1.52u as=0 ps=0 w=0.42u l=1u
X1855 a_5768_1044# a_5197_1842# VDD.t979 VDD.t0 sg13_lv_pmos ad=0.2128p pd=1.5u as=0.3808p ps=2.92u w=1.12u l=0.13u
X1856 VSS.t1365 a_3171_6737.t3 a_24084_6698# VSS.t1871 sg13_lv_nmos ad=0.2516p pd=2.16u as=0.2516p ps=2.16u w=0.74u l=0.13u
X1857 VDD.t1384 a_7477_4687# a_7945_3889# VDD.t9 sg13_lv_pmos ad=0.252p pd=1.57u as=0.3808p ps=2.92u w=1.12u l=0.13u
X1858 VDD.t1036 a_5957_16869# a_6425_16071# VDD.t20 sg13_lv_pmos ad=0.252p pd=1.57u as=0.3808p ps=2.92u w=1.12u l=0.13u
X1859 VSS.t1098 a_13123_7532# a_13557_7532# VSS.t1462 sg13_lv_nmos ad=0.1406p pd=1.12u as=0.2516p ps=2.16u w=0.74u l=0.13u
X1860 a_3747_3156.t1 a_3449_3176# VSS.t93 VSS.t2357 sg13_lv_nmos ad=0.1406p pd=1.12u as=0.1331p ps=1.12u w=0.74u l=0.13u
X1861 VDD.t1057 a_12363_14024# a_12797_14024# VDD.t381 sg13_lv_pmos ad=0.2128p pd=1.5u as=0.3808p ps=2.92u w=1.12u l=0.13u
X1862 VDD.t1144 a_15964_12471# a_16851_12491# VDD.t36 sg13_lv_pmos ad=0.2086p pd=1.5u as=0.34p ps=2.68u w=1u l=0.13u
X1863 a_12993_4687# a_12797_4687# VDD.t346 VDD.t339 sg13_lv_pmos ad=0.3808p pd=2.92u as=0.2128p ps=1.5u w=1.12u l=0.13u
X1864 a_8671_14652# a_8433_14024# a_8563_14024# VDD.t381 sg13_lv_pmos ad=0.2128p pd=1.5u as=0.3808p ps=2.92u w=1.12u l=0.2u
X1865 a_25913_7532# a_25717_7532# VSS.t2072 VSS.t2146 sg13_lv_nmos ad=0.2516p pd=2.16u as=0.1406p ps=1.12u w=0.74u l=0.13u
X1866 VSS.t766 VDD.t1640 VSS.t766 VSS.t767 sg13_lv_nmos ad=79.8f pd=0.8u as=0 ps=0 w=0.42u l=1u
X1867 a_5731_15316# a_8745_15546# a_7390_16071# VDD.t20 sg13_lv_pmos ad=0.3808p pd=2.92u as=0.3808p ps=2.92u w=1.12u l=0.13u
X1868 a_21353_7532# a_21157_7532# VDD.t1142 VDD.t341 sg13_lv_pmos ad=0.3808p pd=2.92u as=0.2128p ps=1.5u w=1.12u l=0.13u
X1869 VSS.t984 a_21483_16869# a_21917_16869# VSS.t1265 sg13_lv_nmos ad=0.1406p pd=1.12u as=0.2516p ps=2.16u w=0.74u l=0.13u
X1870 a_12715_16071# a_12505_16071# VSS.t1475 VSS.t1920 sg13_lv_nmos ad=0.1406p pd=1.12u as=0.1665p ps=1.19u w=0.74u l=0.13u
X1871 a_5731_12471# a_5705_12701# a_4350_13226# VDD.t36 sg13_lv_pmos ad=0.3808p pd=2.92u as=0.3808p ps=2.92u w=1.12u l=0.13u
X1872 VSS.t1301 a_3171_1047.t6 a_14964_1008# VSS.t1300 sg13_lv_nmos ad=0.2516p pd=2.16u as=0.2516p ps=2.16u w=0.74u l=0.13u
X1873 VSS.t560 a_4187_1764.t41 a_22351_4687# VSS.t559 sg13_lv_nmos ad=0.2516p pd=2.16u as=0.1406p ps=1.12u w=0.74u l=0.6u
X1874 VDD.t806 a_4187_2434# a_9431_14652# VDD.t381 sg13_lv_pmos ad=0.3808p pd=2.92u as=0.2128p ps=1.5u w=1.12u l=0.6u
X1875 VSS.t233 a_27237_14024# a_27705_13226# VSS.t232 sg13_lv_nmos ad=0.1665p pd=1.19u as=0.2516p ps=2.16u w=0.74u l=0.13u
X1876 a_13991_2470# a_13753_1842# a_13883_1842# VDD.t353 sg13_lv_pmos ad=0.2128p pd=1.5u as=0.3808p ps=2.92u w=1.12u l=0.2u
X1877 VDD.t242 VSS.t696 VDD.t241 VDD.t29 sg13_lv_pmos ad=0.34p pd=2.68u as=0 ps=0 w=1u l=1u
X1878 VDD.t461 a_26803_14024# a_27237_14024# VDD.t381 sg13_lv_pmos ad=0.2128p pd=1.5u as=0.3808p ps=2.92u w=1.12u l=0.13u
X1879 a_10232_11561# a_10206_11525# VSS.t47 VSS.t848 sg13_lv_nmos ad=0.2516p pd=2.16u as=0.1626p ps=1.415u w=0.74u l=0.13u
X1880 VSS.t1316 a_25717_16869# a_26185_16071# VSS.t1315 sg13_lv_nmos ad=0.1665p pd=1.19u as=0.2516p ps=2.16u w=0.74u l=0.13u
X1881 VDD.t489 a_7043_7532# a_7477_7532# VDD.t341 sg13_lv_pmos ad=0.2128p pd=1.5u as=0.3808p ps=2.92u w=1.12u l=0.13u
X1882 a_4633_16869# a_4437_16869# VDD.t966 VDD.t365 sg13_lv_pmos ad=0.3808p pd=2.92u as=0.2128p ps=1.5u w=1.12u l=0.13u
X1883 a_24008_16071# a_23437_16869# VSS.t87 VSS.t86 sg13_lv_nmos ad=0.1406p pd=1.12u as=0.2516p ps=2.16u w=0.74u l=0.13u
X1884 VSS.t1923 a_2873_4240# a_3171_3892.t1 VSS.t536 sg13_lv_nmos ad=0.2812p pd=2.24u as=0.1406p ps=1.12u w=0.74u l=0.13u
X1885 VDD.t895 a_4187_2434# a_13991_5315# VDD.t339 sg13_lv_pmos ad=0.3808p pd=2.92u as=0.2128p ps=1.5u w=1.12u l=0.6u
X1886 VSS.t532 a_22677_14024# a_23145_13226# VSS.t531 sg13_lv_nmos ad=0.1665p pd=1.19u as=0.2516p ps=2.16u w=0.74u l=0.13u
X1887 VDD.t1410 a_2873_13577# a_3171_13229.t0 VDD.t36 sg13_lv_pmos ad=0.4256p pd=3u as=0.2128p ps=1.5u w=1.12u l=0.13u
X1888 a_6854_11144# a_6854_11144# a_9444_10280# VSS.t1239 sg13_lv_nmos ad=0.38p pd=2.38u as=0.68p ps=4.68u w=2u l=1u
X1889 a_20968_13226# a_20397_14024# VSS.t1426 VSS.t1425 sg13_lv_nmos ad=0.1406p pd=1.12u as=0.2516p ps=2.16u w=0.74u l=0.13u
X1890 VDD.t957 a_2019_311# a_17865_519# VDD.t0 sg13_lv_pmos ad=0.3808p pd=2.92u as=0.3808p ps=2.92u w=1.12u l=0.13u
X1891 VSS.t638 VDD.t1693 VSS.t635 VSS.t637 sg13_lv_nmos ad=79.8f pd=0.8u as=0 ps=0 w=0.42u l=1u
X1892 a_15964_5979# a_15765_6153# a_5731_5979# VSS.t472 sg13_lv_nmos ad=0.2183p pd=1.33u as=0.2516p ps=2.16u w=0.74u l=0.13u
X1893 a_16108_3134# a_2019_3156.t2 a_16510_3889# VSS.t98 sg13_lv_nmos ad=0.2516p pd=2.16u as=0.2516p ps=2.16u w=0.74u l=0.13u
X1894 a_11195_1044# a_10985_1044# VSS.t2236 VSS.t2297 sg13_lv_nmos ad=0.1406p pd=1.12u as=0.1665p ps=1.19u w=0.74u l=0.13u
X1895 CHAN3_DELAY_OUT_LAST a_27997_1842# VSS.t404 VSS.t1161 sg13_lv_nmos ad=0.2516p pd=2.16u as=0.1406p ps=1.12u w=0.74u l=0.13u
X1896 a_13368_3889# a_12797_4687# VSS.t70 VSS.t1781 sg13_lv_nmos ad=0.1406p pd=1.12u as=0.2516p ps=2.16u w=0.74u l=0.13u
X1897 VDD.t935 a_23763_4687# a_24197_4687# VDD.t339 sg13_lv_pmos ad=0.2128p pd=1.5u as=0.3808p ps=2.92u w=1.12u l=0.13u
X1898 VDD.t826 a_4187_2434# a_11711_17497# VDD.t365 sg13_lv_pmos ad=0.3808p pd=2.92u as=0.2128p ps=1.5u w=1.12u l=0.6u
X1899 VDD.t1390 a_2297_16422# a_2595_16074.t0 VDD.t20 sg13_lv_pmos ad=0.4256p pd=3u as=0.2128p ps=1.5u w=1.12u l=0.13u
X1900 VSS.t737 VDD.t1652 VSS.t737 VSS.t736 sg13_lv_nmos ad=0.1428p pd=1.52u as=0 ps=0 w=0.42u l=1u
X1901 VSS.t1155 a_18117_7532# a_18585_6734# VSS.t2200 sg13_lv_nmos ad=0.1665p pd=1.19u as=0.2516p ps=2.16u w=0.74u l=0.13u
X1902 a_11195_13226# a_10985_13226# VDD.t1097 VDD.t36 sg13_lv_pmos ad=0.2128p pd=1.5u as=0.252p ps=1.57u w=1.12u l=0.13u
X1903 a_25391_17497# a_25153_16869# a_25283_16869# VDD.t365 sg13_lv_pmos ad=0.2128p pd=1.5u as=0.3808p ps=2.92u w=1.12u l=0.2u
X1904 a_22590_16071# a_3747_16074.t3 a_24875_16071# VSS.t408 sg13_lv_nmos ad=0.2516p pd=2.16u as=0.1406p ps=1.12u w=0.74u l=0.13u
X1905 VDD.t1157 a_24197_1842# a_24665_1044# VDD.t0 sg13_lv_pmos ad=0.252p pd=1.57u as=0.3808p ps=2.92u w=1.12u l=0.13u
X1906 a_19550_13226# a_3747_13229.t4 a_21835_13226# VSS.t1692 sg13_lv_nmos ad=0.2516p pd=2.16u as=0.1406p ps=1.12u w=0.74u l=0.13u
X1907 a_16510_1044# a_18004_1008# a_17928_1044# VDD.t0 sg13_lv_pmos ad=0.3808p pd=2.92u as=0.2128p ps=1.5u w=1.12u l=0.13u
X1908 VDD.t270 VSS.t760 VDD.t268 VDD.t9 sg13_lv_pmos ad=0.19p pd=1.38u as=0 ps=0 w=1u l=1u
X1909 VSS.t1409 a_1544_3889# a_2391_4240# VSS.t1134 sg13_lv_nmos ad=0.1331p pd=1.12u as=0.1216p ps=1.02u w=0.64u l=0.13u
X1910 a_6913_1842# a_6717_1842# VSS.t287 VSS.t2325 sg13_lv_nmos ad=0.2516p pd=2.16u as=0.1406p ps=1.12u w=0.74u l=0.13u
X1911 a_22488_13226# a_21917_14024# VDD.t577 VDD.t36 sg13_lv_pmos ad=0.2128p pd=1.5u as=0.3808p ps=2.92u w=1.12u l=0.13u
X1912 VSS.t104 a_4187_1764.t14 a_18551_1842# VSS.t2258 sg13_lv_nmos ad=0.2516p pd=2.16u as=0.1406p ps=1.12u w=0.74u l=0.6u
X1913 VDD.t842 a_4187_2434# a_26151_17497# VDD.t365 sg13_lv_pmos ad=0.3808p pd=2.92u as=0.2128p ps=1.5u w=1.12u l=0.6u
X1914 a_2019_3892.t1 a_1721_4240# VSS.t1409 VSS.t1515 sg13_lv_nmos ad=0.1406p pd=1.12u as=0.1331p ps=1.12u w=0.74u l=0.13u
X1915 VSS.t191 a_1256_5979# a_2967_6021# VSS.t1995 sg13_lv_nmos ad=0.1331p pd=1.12u as=0.1216p ps=1.02u w=0.64u l=0.13u
X1916 VSS.t1976 a_3449_16422# a_3747_16074.t1 VSS.t1975 sg13_lv_nmos ad=0.2812p pd=2.24u as=0.1406p ps=1.12u w=0.74u l=0.13u
X1917 a_24393_14024# a_24197_14024# VDD.t1132 VDD.t381 sg13_lv_pmos ad=0.3808p pd=2.92u as=0.2128p ps=1.5u w=1.12u l=0.13u
X1918 VDD.t1103 a_12363_1842# a_12797_1842# VDD.t353 sg13_lv_pmos ad=0.2128p pd=1.5u as=0.3808p ps=2.92u w=1.12u l=0.13u
X1919 VDD.t766 a_12849_11557# a_13306_10795# VDD.t351 sg13_lv_pmos ad=0.36237p pd=2.605u as=79.8f ps=0.8u w=0.42u l=0.13u
X1920 a_19833_4687# a_19637_4687# VSS.t1091 VSS.t1803 sg13_lv_nmos ad=0.2516p pd=2.16u as=0.1406p ps=1.12u w=0.74u l=0.13u
X1921 a_4350_3889# a_3747_3892.t9 a_6635_3889# VSS.t62 sg13_lv_nmos ad=0.2516p pd=2.16u as=0.1406p ps=1.12u w=0.74u l=0.13u
X1922 VDD.t903 a_4187_2434# a_26911_5315# VDD.t339 sg13_lv_pmos ad=0.3808p pd=2.92u as=0.2128p ps=1.5u w=1.12u l=0.6u
X1923 VDD.t1060 a_17683_14024# a_18117_14024# VDD.t381 sg13_lv_pmos ad=0.2128p pd=1.5u as=0.3808p ps=2.92u w=1.12u l=0.13u
X1924 VDD.t855 a_4187_2434# a_20831_14652# VDD.t381 sg13_lv_pmos ad=0.3808p pd=2.92u as=0.2128p ps=1.5u w=1.12u l=0.6u
X1925 a_25630_13226# a_27991_13190# a_27915_13226# VDD.t36 sg13_lv_pmos ad=0.3808p pd=2.92u as=0.2128p ps=1.5u w=1.12u l=0.13u
X1926 VSS.t680 VDD.t1676 VSS.t680 VSS.t681 sg13_lv_nmos ad=79.8f pd=0.8u as=0 ps=0 w=0.42u l=1u
X1927 VDD.t453 a_6326_10280# a_6854_11676# VDD.t351 sg13_lv_pmos ad=0.38p pd=2.38u as=0.38p ps=2.38u w=2u l=1u
X1928 VSS.t41 CHAN3_MUX_SEL3 a_3543_331# VSS.t1647 sg13_lv_nmos ad=0.1331p pd=1.12u as=0.1216p ps=1.02u w=0.64u l=0.13u
X1929 a_9675_3889# a_9465_3889# VDD.t1308 VDD.t9 sg13_lv_pmos ad=0.2128p pd=1.5u as=0.252p ps=1.57u w=1.12u l=0.13u
X1930 VSS.t1321 a_13557_14024# a_14025_13226# VSS.t1320 sg13_lv_nmos ad=0.1665p pd=1.19u as=0.2516p ps=2.16u w=0.74u l=0.13u
X1931 VSS.t687 a_2595_6001.t3 a_8745_6209# VSS.t1506 sg13_lv_nmos ad=0.2516p pd=2.16u as=0.2516p ps=2.16u w=0.74u l=0.13u
X1932 VDD.t69 VSS.t650 VDD.t68 VDD.t36 sg13_lv_pmos ad=0.34p pd=2.68u as=0 ps=0 w=1u l=1u
X1933 a_4111_16869# CHAN0_DELAY_IN a_4003_16869# VSS.t1606 sg13_lv_nmos ad=0.1406p pd=1.12u as=0.2516p ps=2.16u w=0.74u l=0.2u
X1934 VDD.t1093 a_2595_3892.t8 a_8231_3853# VDD.t9 sg13_lv_pmos ad=0.3808p pd=2.92u as=0.3808p ps=2.92u w=1.12u l=0.13u
X1935 a_22590_13226# a_23431_13190# a_23355_13226# VDD.t36 sg13_lv_pmos ad=0.3808p pd=2.92u as=0.2128p ps=1.5u w=1.12u l=0.13u
X1936 a_19550_3889# a_2595_3892.t4 a_20315_3889# VSS.t1486 sg13_lv_nmos ad=0.2516p pd=2.16u as=0.1406p ps=1.12u w=0.74u l=0.13u
X1937 a_24631_4687# a_24393_4687# a_24523_4687# VSS.t981 sg13_lv_nmos ad=0.1406p pd=1.12u as=0.2516p ps=2.16u w=0.74u l=0.2u
X1938 a_9193_4687# a_8997_4687# VSS.t1333 VSS.t2298 sg13_lv_nmos ad=0.2516p pd=2.16u as=0.1406p ps=1.12u w=0.74u l=0.13u
X1939 VDD.t693 a_8997_14024# a_9465_13226# VDD.t36 sg13_lv_pmos ad=0.252p pd=1.57u as=0.3808p ps=2.92u w=1.12u l=0.13u
X1940 a_22590_1044# a_2595_1047.t3 a_23355_1044# VSS.t1721 sg13_lv_nmos ad=0.2516p pd=2.16u as=0.1406p ps=1.12u w=0.74u l=0.13u
X1941 a_2967_13577# CHAN1_MUX_SEL1 a_2873_13577# VSS.t201 sg13_lv_nmos ad=0.1216p pd=1.02u as=0.2176p ps=1.96u w=0.64u l=0.13u
X1942 a_3747_6737.t0 a_3449_7085# VDD.t436 VDD.t29 sg13_lv_pmos ad=0.2128p pd=1.5u as=0.1918p ps=1.5u w=1.12u l=0.13u
X1943 VSS.t1008 a_8563_14024# a_8997_14024# VSS.t2359 sg13_lv_nmos ad=0.1406p pd=1.12u as=0.2516p ps=2.16u w=0.74u l=0.13u
X1944 a_13991_8160# a_13753_7532# a_13883_7532# VDD.t341 sg13_lv_pmos ad=0.2128p pd=1.5u as=0.3808p ps=2.92u w=1.12u l=0.2u
X1945 VSS.t496 a_3171_6737.t6 a_14964_6698# VSS.t1869 sg13_lv_nmos ad=0.2516p pd=2.16u as=0.2516p ps=2.16u w=0.74u l=0.13u
X1946 a_13368_6734# a_12797_7532# VDD.t1263 VDD.t29 sg13_lv_pmos ad=0.2128p pd=1.5u as=0.3808p ps=2.92u w=1.12u l=0.13u
X1947 VSS.t2054 a_4187_1764.t9 a_22351_1842# VSS.t2373 sg13_lv_nmos ad=0.2516p pd=2.16u as=0.1406p ps=1.12u w=0.74u l=0.6u
X1948 VDD.t514 a_3171_1047.t4 a_21044_1008# VDD.t0 sg13_lv_pmos ad=0.3808p pd=2.92u as=0.3808p ps=2.92u w=1.12u l=0.13u
X1949 VDD.t179 VSS.t739 VDD.t178 VDD.t9 sg13_lv_pmos ad=0.34p pd=2.68u as=0 ps=0 w=1u l=1u
X1950 VSS.t2020 a_7477_4687# a_7945_3889# VSS.t2096 sg13_lv_nmos ad=0.1665p pd=1.19u as=0.2516p ps=2.16u w=0.74u l=0.13u
X1951 a_16108_15316# a_3171_15338.t2 a_22590_16071# VSS.t118 sg13_lv_nmos ad=0.2516p pd=2.16u as=0.2516p ps=2.16u w=0.74u l=0.13u
X1952 a_4633_14024# a_4437_14024# VDD.t1317 VDD.t381 sg13_lv_pmos ad=0.3808p pd=2.92u as=0.2128p ps=1.5u w=1.12u l=0.13u
X1953 a_10430_13226# a_3747_13229.t7 a_12715_13226# VSS.t1690 sg13_lv_nmos ad=0.2516p pd=2.16u as=0.1406p ps=1.12u w=0.74u l=0.13u
X1954 a_23633_4687# a_23437_4687# VSS.t564 VSS.t1464 sg13_lv_nmos ad=0.2516p pd=2.16u as=0.1406p ps=1.12u w=0.74u l=0.13u
X1955 a_10430_16071# a_2595_16074.t7 a_11195_16071# VSS.t1857 sg13_lv_nmos ad=0.2516p pd=2.16u as=0.1406p ps=1.12u w=0.74u l=0.13u
X1956 a_1721_13577# a_1256_13226# VDD.t1402 VDD.t36 sg13_lv_pmos ad=0.1596p pd=1.22u as=0.2856p ps=2.36u w=0.84u l=0.13u
X1957 VSS.t136 a_9547_11862# a_9547_11862# VSS.t158 sg13_lv_nmos ad=2.39977p pd=15.495u as=0.111p ps=1.34u w=0.3u l=0.13u
X1958 VSS.t589 VDD.t1705 VSS.t589 VSS.t588 sg13_lv_nmos ad=0.1428p pd=1.52u as=0 ps=0 w=0.42u l=1u
X1959 a_15273_4687# a_15077_4687# VDD.t424 VDD.t339 sg13_lv_pmos ad=0.3808p pd=2.92u as=0.2128p ps=1.5u w=1.12u l=0.13u
X1960 VSS.t387 a_9323_4687# a_9757_4687# VSS.t1238 sg13_lv_nmos ad=0.1406p pd=1.12u as=0.2516p ps=2.16u w=0.74u l=0.13u
X1961 a_6391_5315# a_6153_4687# a_6283_4687# VDD.t339 sg13_lv_pmos ad=0.2128p pd=1.5u as=0.3808p ps=2.92u w=1.12u l=0.2u
X1962 VSS.t709 VDD.t1663 VSS.t709 VSS.t711 sg13_lv_nmos ad=0.1428p pd=1.52u as=0 ps=0 w=0.42u l=1u
X1963 VSS.t6 a_2019_13229.t8 a_7364_13190# VSS.t566 sg13_lv_nmos ad=0.2516p pd=2.16u as=0.2516p ps=2.16u w=0.74u l=0.13u
X1964 REF_DELAY_OUT_LAST a_27997_7532# VSS.t1298 VSS.t1297 sg13_lv_nmos ad=0.2516p pd=2.16u as=0.1406p ps=1.12u w=0.74u l=0.13u
X1965 a_11195_6734# a_10985_6734# VSS.t167 VSS.t166 sg13_lv_nmos ad=0.1406p pd=1.12u as=0.1665p ps=1.19u w=0.74u l=0.13u
X1966 a_2873_7085# REF_MUX_SEL1 VDD.t573 VDD.t29 sg13_lv_pmos ad=0.1596p pd=1.22u as=0.2856p ps=2.36u w=0.84u l=0.13u
X1967 VSS.t1211 a_7043_16869# a_7477_16869# VSS.t1391 sg13_lv_nmos ad=0.1406p pd=1.12u as=0.2516p ps=2.16u w=0.74u l=0.13u
X1968 VDD.t847 a_4187_2434# a_11711_14652# VDD.t381 sg13_lv_pmos ad=0.3808p pd=2.92u as=0.2128p ps=1.5u w=1.12u l=0.6u
X1969 VDD.t334 VSS.t829 VDD.t332 VDD.t0 sg13_lv_pmos ad=0.19p pd=1.38u as=0 ps=0 w=1u l=1u
X1970 VSS.t2254 a_3171_16074.t9 a_5844_16035# VSS.t2253 sg13_lv_nmos ad=0.2516p pd=2.16u as=0.2516p ps=2.16u w=0.74u l=0.13u
X1971 a_10430_16071# a_11924_16035# a_11848_16071# VDD.t20 sg13_lv_pmos ad=0.3808p pd=2.92u as=0.2128p ps=1.5u w=1.12u l=0.13u
X1972 a_15304_10295# a_14851_11918# VDD.t731 VDD.t351 sg13_lv_pmos ad=0.4312p pd=3.01u as=0.2639p ps=1.81u w=1.12u l=0.13u
X1973 a_4350_6734# a_6711_6698# a_6635_6734# VDD.t29 sg13_lv_pmos ad=0.3808p pd=2.92u as=0.2128p ps=1.5u w=1.12u l=0.13u
X1974 a_16108_12471# a_26985_12701# a_25630_13226# VDD.t36 sg13_lv_pmos ad=0.3808p pd=2.92u as=0.3808p ps=2.92u w=1.12u l=0.13u
X1975 a_16271_2470# a_16033_1842# a_16163_1842# VDD.t353 sg13_lv_pmos ad=0.2128p pd=1.5u as=0.3808p ps=2.92u w=1.12u l=0.2u
X1976 a_25391_14652# a_25153_14024# a_25283_14024# VDD.t381 sg13_lv_pmos ad=0.2128p pd=1.5u as=0.3808p ps=2.92u w=1.12u l=0.2u
X1977 a_13566_11018# a_14009_10774# a_13949_11186# VDD.t351 sg13_lv_pmos ad=79.8f pd=0.8u as=63f ps=0.72u w=0.42u l=0.13u
X1978 a_6913_7532# a_6717_7532# VSS.t18 VSS.t17 sg13_lv_nmos ad=0.2516p pd=2.16u as=0.1406p ps=1.12u w=0.74u l=0.13u
X1979 VDD.t352 a_11748_11799# a_11693_11680# VDD.t351 sg13_lv_pmos ad=1.10612p pd=6.66u as=93.45f ps=0.865u w=0.42u l=0.13u
X1980 a_25913_16869# a_25717_16869# VDD.t378 VDD.t365 sg13_lv_pmos ad=0.3808p pd=2.92u as=0.2128p ps=1.5u w=1.12u l=0.13u
X1981 VDD.t559 a_11491_11918# a_12158_11557# VDD.t351 sg13_lv_pmos ad=0.2128p pd=1.5u as=0.3864p ps=2.93u w=1.12u l=0.13u
X1982 VSS.t1142 a_4187_1764.t78 a_18551_7532# VSS.t1714 sg13_lv_nmos ad=0.2516p pd=2.16u as=0.1406p ps=1.12u w=0.74u l=0.6u
X1983 a_19550_6734# a_20391_6698# a_20315_6734# VDD.t29 sg13_lv_pmos ad=0.3808p pd=2.92u as=0.2128p ps=1.5u w=1.12u l=0.13u
X1984 VDD.t865 a_4187_2434# a_26151_14652# VDD.t381 sg13_lv_pmos ad=0.3808p pd=2.92u as=0.2128p ps=1.5u w=1.12u l=0.6u
X1985 VDD.t324 VSS.t804 VDD.t56 VDD.t0 sg13_lv_pmos ad=0.19p pd=1.38u as=0 ps=0 w=1u l=1u
X1986 VDD.t1029 a_12363_7532# a_12797_7532# VDD.t341 sg13_lv_pmos ad=0.2128p pd=1.5u as=0.3808p ps=2.92u w=1.12u l=0.13u
X1987 a_2595_3156.t0 a_2297_3176# VDD.t975 VDD.t9 sg13_lv_pmos ad=0.2128p pd=1.5u as=0.1918p ps=1.5u w=1.12u l=0.13u
X1988 VDD.t1033 a_15403_4687# a_15837_4687# VDD.t339 sg13_lv_pmos ad=0.2128p pd=1.5u as=0.3808p ps=2.92u w=1.12u l=0.13u
X1989 a_21353_16869# a_21157_16869# VDD.t375 VDD.t365 sg13_lv_pmos ad=0.3808p pd=2.92u as=0.2128p ps=1.5u w=1.12u l=0.13u
X1990 a_19833_1842# a_19637_1842# VSS.t1357 VSS.t1890 sg13_lv_nmos ad=0.2516p pd=2.16u as=0.1406p ps=1.12u w=0.74u l=0.13u
X1991 VSS.t529 a_19963_14024# a_20397_14024# VSS.t528 sg13_lv_nmos ad=0.1406p pd=1.12u as=0.2516p ps=2.16u w=0.74u l=0.13u
X1992 a_21835_13226# a_21625_13226# VDD.t1066 VDD.t36 sg13_lv_pmos ad=0.2128p pd=1.5u as=0.252p ps=1.57u w=1.12u l=0.13u
X1993 VDD.t958 a_2019_311# a_5705_519# VDD.t0 sg13_lv_pmos ad=0.3808p pd=2.92u as=0.3808p ps=2.92u w=1.12u l=0.13u
X1994 VDD.t509 a_14643_16869# a_15077_16869# VDD.t365 sg13_lv_pmos ad=0.2128p pd=1.5u as=0.3808p ps=2.92u w=1.12u l=0.13u
X1995 VDD.t490 a_7477_7532# a_7945_6734# VDD.t29 sg13_lv_pmos ad=0.252p pd=1.57u as=0.3808p ps=2.92u w=1.12u l=0.13u
X1996 a_3747_6001.t1 a_3449_6021# VSS.t191 VSS.t190 sg13_lv_nmos ad=0.1406p pd=1.12u as=0.1331p ps=1.12u w=0.74u l=0.13u
X1997 a_3747_12493.t1 a_3449_12513# VSS.t161 VSS.t1294 sg13_lv_nmos ad=0.1406p pd=1.12u as=0.1331p ps=1.12u w=0.74u l=0.13u
X1998 VSS.t354 a_2019_1047.t7 a_10404_1008# VSS.t353 sg13_lv_nmos ad=0.2516p pd=2.16u as=0.2516p ps=2.16u w=0.74u l=0.13u
X1999 VDD.t315 VSS.t806 VDD.t314 VDD.t0 sg13_lv_pmos ad=0.34p pd=2.68u as=0 ps=0 w=1u l=1u
X2000 a_24631_1842# a_24393_1842# a_24523_1842# VSS.t2083 sg13_lv_nmos ad=0.1406p pd=1.12u as=0.2516p ps=2.16u w=0.74u l=0.2u
X2001 a_22590_6734# a_2595_6737.t3 a_23355_6734# VSS.t1376 sg13_lv_nmos ad=0.2516p pd=2.16u as=0.1406p ps=1.12u w=0.74u l=0.13u
X2002 a_19550_3889# a_19524_3853# a_19448_3889# VDD.t9 sg13_lv_pmos ad=0.3808p pd=2.92u as=0.2128p ps=1.5u w=1.12u l=0.13u
X2003 VDD.t1478 a_4763_4687# a_5197_4687# VDD.t339 sg13_lv_pmos ad=0.2128p pd=1.5u as=0.3808p ps=2.92u w=1.12u l=0.13u
X2004 a_9193_1842# a_8997_1842# VSS.t1108 VSS.t1825 sg13_lv_nmos ad=0.2516p pd=2.16u as=0.1406p ps=1.12u w=0.74u l=0.13u
X2005 a_20071_2470# a_19833_1842# a_19963_1842# VDD.t353 sg13_lv_pmos ad=0.2128p pd=1.5u as=0.3808p ps=2.92u w=1.12u l=0.2u
X2006 VDD.t527 a_3171_6001.t2 a_23945_6209# VDD.t29 sg13_lv_pmos ad=0.3808p pd=2.92u as=0.3808p ps=2.92u w=1.12u l=0.13u
X2007 a_1544_5979# REF_MUX_SEL3 VSS.t170 VSS.t121 sg13_lv_nmos ad=0.2516p pd=2.16u as=0.2516p ps=2.16u w=0.74u l=0.13u
X2008 VDD.t588 a_1544_289# a_2297_331# VDD.t0 sg13_lv_pmos ad=0.1918p pd=1.5u as=0.1596p ps=1.22u w=0.84u l=0.13u
X2009 a_5731_15316# a_5705_15546# a_4350_16071# VDD.t20 sg13_lv_pmos ad=0.3808p pd=2.92u as=0.3808p ps=2.92u w=1.12u l=0.13u
X2010 VDD.t981 a_14643_1842# a_15077_1842# VDD.t353 sg13_lv_pmos ad=0.2128p pd=1.5u as=0.3808p ps=2.92u w=1.12u l=0.13u
X2011 VSS.t991 a_27237_16869# a_27705_16071# VSS.t990 sg13_lv_nmos ad=0.1665p pd=1.19u as=0.2516p ps=2.16u w=0.74u l=0.13u
X2012 VSS.t1251 a_4187_1764.t73 a_22351_7532# VSS.t2362 sg13_lv_nmos ad=0.2516p pd=2.16u as=0.1406p ps=1.12u w=0.74u l=0.6u
X2013 a_9675_3889# a_9465_3889# VSS.t1910 VSS.t1909 sg13_lv_nmos ad=0.1406p pd=1.12u as=0.1665p ps=1.19u w=0.74u l=0.13u
X2014 a_14009_11568# REF_CLK VSS.t136 VSS.t1777 sg13_lv_nmos ad=0.2516p pd=2.16u as=1.9998p ps=12.915u w=0.74u l=0.13u
X2015 VSS.t1557 a_24197_14024# a_24665_13226# VSS.t1556 sg13_lv_nmos ad=0.1665p pd=1.19u as=0.2516p ps=2.16u w=0.74u l=0.13u
X2016 a_2019_311# a_1721_331# VDD.t1019 VDD.t0 sg13_lv_pmos ad=0.2128p pd=1.5u as=0.1918p ps=1.5u w=1.12u l=0.13u
X2017 VSS.t1483 a_2595_3892.t8 a_8231_3853# VSS.t1482 sg13_lv_nmos ad=0.2516p pd=2.16u as=0.2516p ps=2.16u w=0.74u l=0.13u
X2018 VSS.t1990 a_22677_16869# a_23145_16071# VSS.t2306 sg13_lv_nmos ad=0.1665p pd=1.19u as=0.2516p ps=2.16u w=0.74u l=0.13u
X2019 a_23633_1842# a_23437_1842# VSS.t467 VSS.t2043 sg13_lv_nmos ad=0.2516p pd=2.16u as=0.1406p ps=1.12u w=0.74u l=0.13u
X2020 VDD.t165 VSS.t709 VDD.t164 VDD.t29 sg13_lv_pmos ad=0.34p pd=2.68u as=0 ps=0 w=1u l=1u
X2021 a_20968_16071# a_20397_16869# VSS.t1084 VSS.t1214 sg13_lv_nmos ad=0.1406p pd=1.12u as=0.2516p ps=2.16u w=0.74u l=0.13u
X2022 VSS.t818 VDD.t1626 VSS.t818 VSS.t817 sg13_lv_nmos ad=0.1428p pd=1.52u as=0 ps=0 w=0.42u l=1u
X2023 a_26395_1044# a_26185_1044# VSS.t2128 VSS.t2367 sg13_lv_nmos ad=0.1406p pd=1.12u as=0.1665p ps=1.19u w=0.74u l=0.13u
X2024 VDD.t848 a_4187_2434# a_7911_5315# VDD.t339 sg13_lv_pmos ad=0.3808p pd=2.92u as=0.2128p ps=1.5u w=1.12u l=0.6u
X2025 VSS.t624 VDD.t1696 VSS.t626 VSS.t625 sg13_lv_nmos ad=79.8f pd=0.8u as=0 ps=0 w=0.42u l=1u
X2026 VSS.t1112 a_9323_1842# a_9757_1842# VSS.t1962 sg13_lv_nmos ad=0.1406p pd=1.12u as=0.2516p ps=2.16u w=0.74u l=0.13u
X2027 a_13470_3889# a_14311_3853# a_14235_3889# VDD.t9 sg13_lv_pmos ad=0.3808p pd=2.92u as=0.2128p ps=1.5u w=1.12u l=0.13u
X2028 a_12715_13226# a_12505_13226# VDD.t943 VDD.t36 sg13_lv_pmos ad=0.2128p pd=1.5u as=0.252p ps=1.57u w=1.12u l=0.13u
X2029 VSS.t1006 a_3747_1047.t3 a_24951_1008# VSS.t1005 sg13_lv_nmos ad=0.2516p pd=2.16u as=0.2516p ps=2.16u w=0.74u l=0.13u
X2030 a_26911_17497# a_26673_16869# a_26803_16869# VDD.t365 sg13_lv_pmos ad=0.2128p pd=1.5u as=0.3808p ps=2.92u w=1.12u l=0.2u
X2031 VDD.t908 a_4187_2434# a_17791_2470# VDD.t353 sg13_lv_pmos ad=0.3808p pd=2.92u as=0.2128p ps=1.5u w=1.12u l=0.6u
X2032 a_14513_4687# a_14317_4687# VSS.t52 VSS.t1231 sg13_lv_nmos ad=0.2516p pd=2.16u as=0.1406p ps=1.12u w=0.74u l=0.13u
X2033 a_13019_11521# a_15688_11093# VDD.t990 VDD.t351 sg13_lv_pmos ad=0.3808p pd=2.92u as=0.2128p ps=1.5u w=1.12u l=0.13u
X2034 a_16271_8160# a_16033_7532# a_16163_7532# VDD.t341 sg13_lv_pmos ad=0.2128p pd=1.5u as=0.3808p ps=2.92u w=1.12u l=0.2u
X2035 a_5631_4687# a_5393_4687# a_5523_4687# VSS.t2356 sg13_lv_nmos ad=0.1406p pd=1.12u as=0.2516p ps=2.16u w=0.74u l=0.2u
X2036 VDD.t716 a_25717_14024# a_26185_13226# VDD.t36 sg13_lv_pmos ad=0.252p pd=1.57u as=0.3808p ps=2.92u w=1.12u l=0.13u
X2037 VSS.t790 VDD.t1633 VSS.t790 VSS.t789 sg13_lv_nmos ad=0.1428p pd=1.52u as=0 ps=0 w=0.42u l=1u
X2038 VDD.t1374 a_2019_3892.t3 a_22564_3853# VDD.t9 sg13_lv_pmos ad=0.3808p pd=2.92u as=0.3808p ps=2.92u w=1.12u l=0.13u
X2039 a_2297_13577# CHAN1_MUX_SEL0 VDD.t555 VDD.t36 sg13_lv_pmos ad=0.1596p pd=1.22u as=0.2856p ps=2.36u w=0.84u l=0.13u
X2040 a_24008_13226# a_23437_14024# VDD.t1341 VDD.t36 sg13_lv_pmos ad=0.2128p pd=1.5u as=0.3808p ps=2.92u w=1.12u l=0.13u
X2041 a_22351_17497# a_22113_16869# a_22243_16869# VDD.t365 sg13_lv_pmos ad=0.2128p pd=1.5u as=0.3808p ps=2.92u w=1.12u l=0.2u
X2042 VDD.t825 a_4187_2434# a_27671_17497# VDD.t365 sg13_lv_pmos ad=0.3808p pd=2.92u as=0.2128p ps=1.5u w=1.12u l=0.6u
X2043 a_19550_16071# a_3747_16074.t4 a_21835_16071# VSS.t30 sg13_lv_nmos ad=0.2516p pd=2.16u as=0.1406p ps=1.12u w=0.74u l=0.13u
X2044 VDD.t992 a_3449_12513# a_3747_12493.t0 VDD.t36 sg13_lv_pmos ad=0.4256p pd=3u as=0.2128p ps=1.5u w=1.12u l=0.13u
X2045 VDD.t502 CHAN0_MUX_SEL1 a_3449_16422# VDD.t20 sg13_lv_pmos ad=0.1918p pd=1.5u as=0.1596p ps=1.22u w=0.84u l=0.13u
X2046 VSS.t814 VDD.t1627 VSS.t814 VSS.t813 sg13_lv_nmos ad=0.1428p pd=1.52u as=0 ps=0 w=0.42u l=1u
X2047 a_25913_14024# a_25717_14024# VDD.t715 VDD.t381 sg13_lv_pmos ad=0.3808p pd=2.92u as=0.2128p ps=1.5u w=1.12u l=0.13u
X2048 VSS.t9 a_3747_13229.t2 a_27991_13190# VSS.t8 sg13_lv_nmos ad=0.2516p pd=2.16u as=0.2516p ps=2.16u w=0.74u l=0.13u
X2049 VDD.t797 a_4187_2434# a_4187_2434# VDD.t360 sg13_lv_pmos ad=0.3808p pd=2.92u as=1.0304p ps=4.08u w=1.12u l=0.6u
X2050 a_3747_1047.t0 a_3449_1395# VDD.t1464 VDD.t0 sg13_lv_pmos ad=0.2128p pd=1.5u as=0.1918p ps=1.5u w=1.12u l=0.13u
X2051 a_24008_1044# a_23437_1842# VSS.t1304 VSS.t2042 sg13_lv_nmos ad=0.1406p pd=1.12u as=0.2516p ps=2.16u w=0.74u l=0.13u
X2052 a_13368_1044# a_12797_1842# VDD.t1102 VDD.t0 sg13_lv_pmos ad=0.2128p pd=1.5u as=0.3808p ps=2.92u w=1.12u l=0.13u
X2053 a_19833_7532# a_19637_7532# VSS.t516 VSS.t515 sg13_lv_nmos ad=0.2516p pd=2.16u as=0.1406p ps=1.12u w=0.74u l=0.13u
X2054 VSS.t100 VDD.t1646 VSS.t100 VSS.t752 sg13_lv_nmos ad=79.8f pd=0.8u as=0 ps=0 w=0.42u l=1u
X2055 a_21353_14024# a_21157_14024# VDD.t1067 VDD.t381 sg13_lv_pmos ad=0.3808p pd=2.92u as=0.2128p ps=1.5u w=1.12u l=0.13u
X2056 a_9675_6734# a_9465_6734# VDD.t955 VDD.t29 sg13_lv_pmos ad=0.2128p pd=1.5u as=0.252p ps=1.57u w=1.12u l=0.13u
X2057 a_4633_4687# a_4437_4687# VSS.t1206 VSS.t1613 sg13_lv_nmos ad=0.2516p pd=2.16u as=0.1406p ps=1.12u w=0.74u l=0.13u
X2058 a_5631_16869# a_5393_16869# a_5523_16869# VSS.t2223 sg13_lv_nmos ad=0.1406p pd=1.12u as=0.2516p ps=2.16u w=0.74u l=0.2u
X2059 VDD.t568 a_14643_14024# a_15077_14024# VDD.t381 sg13_lv_pmos ad=0.2128p pd=1.5u as=0.3808p ps=2.92u w=1.12u l=0.13u
X2060 a_9444_9602# a_6854_11144# a_9712_9602# VSS.t1242 sg13_lv_nmos ad=0.68p pd=4.68u as=0.38p ps=2.38u w=2u l=1u
X2061 a_22590_13226# a_24951_13190# a_24875_13226# VDD.t36 sg13_lv_pmos ad=0.3808p pd=2.92u as=0.2128p ps=1.5u w=1.12u l=0.13u
X2062 VSS.t674 VDD.t1679 VSS.t672 VSS.t673 sg13_lv_nmos ad=79.8f pd=0.8u as=0 ps=0 w=0.42u l=1u
X2063 a_19833_16869# a_19637_16869# VSS.t1102 VSS.t2227 sg13_lv_nmos ad=0.2516p pd=2.16u as=0.1406p ps=1.12u w=0.74u l=0.13u
X2064 VSS.t1044 a_13557_16869# a_14025_16071# VSS.t1043 sg13_lv_nmos ad=0.1665p pd=1.19u as=0.2516p ps=2.16u w=0.74u l=0.13u
X2065 a_11711_5315# a_11473_4687# a_11603_4687# VDD.t339 sg13_lv_pmos ad=0.2128p pd=1.5u as=0.3808p ps=2.92u w=1.12u l=0.2u
X2066 VDD.t1071 a_2595_6737.t8 a_8231_6698# VDD.t29 sg13_lv_pmos ad=0.3808p pd=2.92u as=0.3808p ps=2.92u w=1.12u l=0.13u
X2067 VSS.t1492 a_10517_14024# a_10985_13226# VSS.t1491 sg13_lv_nmos ad=0.1665p pd=1.19u as=0.2516p ps=2.16u w=0.74u l=0.13u
X2068 a_24631_7532# a_24393_7532# a_24523_7532# VSS.t258 sg13_lv_nmos ad=0.1406p pd=1.12u as=0.2516p ps=2.16u w=0.74u l=0.2u
X2069 VSS.t1079 a_2019_6737.t7 a_10404_6698# VSS.t1078 sg13_lv_nmos ad=0.2516p pd=2.16u as=0.2516p ps=2.16u w=0.74u l=0.13u
X2070 VSS.t218 a_4187_1764.t160 a_6391_16869# VSS.t439 sg13_lv_nmos ad=0.2516p pd=2.16u as=0.1406p ps=1.12u w=0.74u l=0.6u
X2071 VDD.t922 a_4187_2434# a_21591_2470# VDD.t353 sg13_lv_pmos ad=0.3808p pd=2.92u as=0.2128p ps=1.5u w=1.12u l=0.6u
X2072 VSS.t426 a_23763_16869# a_24197_16869# VSS.t425 sg13_lv_nmos ad=0.1406p pd=1.12u as=0.2516p ps=2.16u w=0.74u l=0.13u
X2073 a_20071_8160# a_19833_7532# a_19963_7532# VDD.t341 sg13_lv_pmos ad=0.2128p pd=1.5u as=0.3808p ps=2.92u w=1.12u l=0.2u
X2074 a_9193_7532# a_8997_7532# VSS.t1050 VSS.t1788 sg13_lv_nmos ad=0.2516p pd=2.16u as=0.1406p ps=1.12u w=0.74u l=0.13u
X2075 a_2967_16422# CHAN0_MUX_SEL1 a_2873_16422# VSS.t328 sg13_lv_nmos ad=0.1216p pd=1.02u as=0.2176p ps=1.96u w=0.64u l=0.13u
X2076 VDD.t1023 a_5974_11413# a_5974_11413# VDD.t351 sg13_lv_pmos ad=0.2448p pd=2.08u as=0.2826p ps=2.29u w=0.36u l=2u
X2077 a_2873_1395# CHAN3_MUX_SEL1 VDD.t1462 VDD.t0 sg13_lv_pmos ad=0.1596p pd=1.22u as=0.2856p ps=2.36u w=0.84u l=0.13u
X2078 VDD.t973 a_3171_3156.t2 a_23945_3364# VDD.t9 sg13_lv_pmos ad=0.3808p pd=2.92u as=0.3808p ps=2.92u w=1.12u l=0.13u
X2079 VDD.t431 a_14643_7532# a_15077_7532# VDD.t341 sg13_lv_pmos ad=0.2128p pd=1.5u as=0.3808p ps=2.92u w=1.12u l=0.13u
X2080 a_4350_1044# a_6711_1008# a_6635_1044# VDD.t0 sg13_lv_pmos ad=0.3808p pd=2.92u as=0.2128p ps=1.5u w=1.12u l=0.13u
X2081 a_15964_289# CHAN3_MUX_SEL4 a_5731_289# VDD.t0 sg13_lv_pmos ad=0.3304p pd=1.71u as=0.3808p ps=2.92u w=1.12u l=0.13u
X2082 VDD.t583 a_2873_6021# a_3171_6001.t0 VDD.t29 sg13_lv_pmos ad=0.4256p pd=3u as=0.2128p ps=1.5u w=1.12u l=0.13u
X2083 VSS.t1048 a_5523_14024# a_5957_14024# VSS.t1344 sg13_lv_nmos ad=0.1406p pd=1.12u as=0.2516p ps=2.16u w=0.74u l=0.13u
X2084 a_13231_17497# a_12993_16869# a_13123_16869# VDD.t365 sg13_lv_pmos ad=0.2128p pd=1.5u as=0.3808p ps=2.92u w=1.12u l=0.2u
X2085 a_10430_16071# a_3747_16074.t7 a_12715_16071# VSS.t27 sg13_lv_nmos ad=0.2516p pd=2.16u as=0.1406p ps=1.12u w=0.74u l=0.13u
X2086 a_11748_11799# a_11491_11918# a_11910_11995# VSS.t1156 sg13_lv_nmos ad=0.1428p pd=1.52u as=37.8f ps=0.6u w=0.42u l=0.13u
X2087 a_16108_15316# a_2595_15338.t2 a_19550_16071# VSS.t1057 sg13_lv_nmos ad=0.2516p pd=2.16u as=0.2516p ps=2.16u w=0.74u l=0.13u
X2088 a_23633_7532# a_23437_7532# VSS.t471 VSS.t1363 sg13_lv_nmos ad=0.2516p pd=2.16u as=0.1406p ps=1.12u w=0.74u l=0.13u
X2089 VSS.t786 VDD.t1634 VSS.t788 VSS.t787 sg13_lv_nmos ad=79.8f pd=0.8u as=0 ps=0 w=0.42u l=1u
X2090 a_19550_1044# a_20391_1008# a_20315_1044# VDD.t0 sg13_lv_pmos ad=0.3808p pd=2.92u as=0.2128p ps=1.5u w=1.12u l=0.13u
X2091 VDD.t128 VSS.t100 VDD.t127 VDD.t9 sg13_lv_pmos ad=0.34p pd=2.68u as=0 ps=0 w=1u l=1u
X2092 a_19550_3889# a_2019_3892.t4 a_19448_3889# VSS.t1535 sg13_lv_nmos ad=0.2516p pd=2.16u as=0.1406p ps=1.12u w=0.74u l=0.13u
X2093 a_26395_6734# a_26185_6734# VSS.t294 VSS.t293 sg13_lv_nmos ad=0.1406p pd=1.12u as=0.1665p ps=1.19u w=0.74u l=0.13u
X2094 a_1256_1044# CHAN3_MUX_SEL0 VSS.t2076 VSS.t1595 sg13_lv_nmos ad=0.2516p pd=2.16u as=0.2516p ps=2.16u w=0.74u l=0.13u
X2095 VDD.t827 a_4187_2434# a_13991_17497# VDD.t365 sg13_lv_pmos ad=0.3808p pd=2.92u as=0.2128p ps=1.5u w=1.12u l=0.6u
X2096 VDD.t197 VSS.t628 VDD.t196 VDD.t20 sg13_lv_pmos ad=0.34p pd=2.68u as=0 ps=0 w=1u l=1u
X2097 VSS.t1131 a_9323_7532# a_9757_7532# VSS.t1290 sg13_lv_nmos ad=0.1406p pd=1.12u as=0.2516p ps=2.16u w=0.74u l=0.13u
X2098 VDD.t664 VDD.t666 VDD.t667 VDD.t353 sg13_lv_pmos ad=0.2128p pd=1.5u as=0 ps=0 w=1.12u l=0.2u
X2099 VSS.t446 a_2019_16074.t8 a_7364_16035# VSS.t445 sg13_lv_nmos ad=0.2516p pd=2.16u as=0.2516p ps=2.16u w=0.74u l=0.13u
X2100 VSS.t846 a_3747_6737.t3 a_24951_6698# VSS.t1794 sg13_lv_nmos ad=0.2516p pd=2.16u as=0.2516p ps=2.16u w=0.74u l=0.13u
X2101 VDD.t1395 a_19637_16869# a_20105_16071# VDD.t20 sg13_lv_pmos ad=0.252p pd=1.57u as=0.3808p ps=2.92u w=1.12u l=0.13u
X2102 VDD.t880 a_4187_2434# a_17791_8160# VDD.t341 sg13_lv_pmos ad=0.3808p pd=2.92u as=0.2128p ps=1.5u w=1.12u l=0.6u
X2103 VSS.t421 a_2595_311.t2 a_20905_519# VSS.t420 sg13_lv_nmos ad=0.2516p pd=2.16u as=0.2516p ps=2.16u w=0.74u l=0.13u
X2104 a_26911_14652# a_26673_14024# a_26803_14024# VDD.t381 sg13_lv_pmos ad=0.2128p pd=1.5u as=0.3808p ps=2.92u w=1.12u l=0.2u
X2105 VSS.t1681 a_2019_13229.t9 a_4324_13190# VSS.t1680 sg13_lv_nmos ad=0.2516p pd=2.16u as=0.2516p ps=2.16u w=0.74u l=0.13u
X2106 VDD.t523 a_7477_1842# a_7945_1044# VDD.t0 sg13_lv_pmos ad=0.252p pd=1.57u as=0.3808p ps=2.92u w=1.12u l=0.13u
X2107 VDD.t345 a_10083_4687# a_10517_4687# VDD.t339 sg13_lv_pmos ad=0.2128p pd=1.5u as=0.3808p ps=2.92u w=1.12u l=0.13u
X2108 VSS.t1258 a_4003_16869# a_4437_16869# VSS.t1379 sg13_lv_nmos ad=0.1406p pd=1.12u as=0.2516p ps=2.16u w=0.74u l=0.13u
X2109 VSS.t1341 CHAN0_MUX_SEL4 a_15765_15490# VSS.t2208 sg13_lv_nmos ad=0.2516p pd=2.16u as=0.2516p ps=2.16u w=0.74u l=0.13u
X2110 a_16108_15316# a_26985_15546# a_25630_16071# VDD.t20 sg13_lv_pmos ad=0.3808p pd=2.92u as=0.3808p ps=2.92u w=1.12u l=0.13u
X2111 a_14513_1842# a_14317_1842# VSS.t1326 VSS.t1452 sg13_lv_nmos ad=0.2516p pd=2.16u as=0.1406p ps=1.12u w=0.74u l=0.13u
X2112 a_5631_1842# a_5393_1842# a_5523_1842# VSS.t1322 sg13_lv_nmos ad=0.1406p pd=1.12u as=0.2516p ps=2.16u w=0.74u l=0.2u
X2113 a_16108_12471# a_23945_12701# a_22590_13226# VDD.t36 sg13_lv_pmos ad=0.3808p pd=2.92u as=0.3808p ps=2.92u w=1.12u l=0.13u
X2114 a_2019_6001.t0 a_1721_6021# VDD.t730 VDD.t29 sg13_lv_pmos ad=0.2128p pd=1.5u as=0.1918p ps=1.5u w=1.12u l=0.13u
X2115 VDD.t528 a_3171_16074.t5 a_18004_16035# VDD.t20 sg13_lv_pmos ad=0.3808p pd=2.92u as=0.3808p ps=2.92u w=1.12u l=0.13u
X2116 a_22351_14652# a_22113_14024# a_22243_14024# VDD.t381 sg13_lv_pmos ad=0.2128p pd=1.5u as=0.3808p ps=2.92u w=1.12u l=0.2u
X2117 VDD.t866 a_4187_2434# a_27671_14652# VDD.t381 sg13_lv_pmos ad=0.3808p pd=2.92u as=0.2128p ps=1.5u w=1.12u l=0.6u
X2118 a_10430_13226# a_11271_13190# a_11195_13226# VDD.t36 sg13_lv_pmos ad=0.3808p pd=2.92u as=0.2128p ps=1.5u w=1.12u l=0.13u
X2119 a_22873_16869# a_22677_16869# VDD.t459 VDD.t365 sg13_lv_pmos ad=0.3808p pd=2.92u as=0.2128p ps=1.5u w=1.12u l=0.13u
X2120 a_13470_1044# a_3171_1047.t6 a_14888_1044# VSS.t1299 sg13_lv_nmos ad=0.2516p pd=2.16u as=0.1406p ps=1.12u w=0.74u l=0.13u
X2121 a_13470_3889# a_2595_3892.t6 a_14235_3889# VSS.t1738 sg13_lv_nmos ad=0.2516p pd=2.16u as=0.1406p ps=1.12u w=0.74u l=0.13u
X2122 a_18551_4687# a_18313_4687# a_18443_4687# VSS.t1261 sg13_lv_nmos ad=0.1406p pd=1.12u as=0.2516p ps=2.16u w=0.74u l=0.2u
X2123 VSS.t443 a_21483_14024# a_21917_14024# VSS.t1823 sg13_lv_nmos ad=0.1406p pd=1.12u as=0.2516p ps=2.16u w=0.74u l=0.13u
X2124 a_24008_6734# a_23437_7532# VSS.t1365 VSS.t1364 sg13_lv_nmos ad=0.1406p pd=1.12u as=0.2516p ps=2.16u w=0.74u l=0.13u
X2125 a_17275_3889# a_17065_3889# VDD.t561 VDD.t9 sg13_lv_pmos ad=0.2128p pd=1.5u as=0.252p ps=1.57u w=1.12u l=0.13u
X2126 a_16108_5979# a_17865_6209# a_16510_6734# VDD.t29 sg13_lv_pmos ad=0.3808p pd=2.92u as=0.3808p ps=2.92u w=1.12u l=0.13u
X2127 a_9444_9602# a_9444_10280# VSS.t863 VSS.t862 sg13_lv_nmos ad=0.38p pd=2.38u as=0.68p ps=4.68u w=2u l=1u
X2128 VDD.t1488 a_16163_16869# a_16597_16869# VDD.t365 sg13_lv_pmos ad=0.2128p pd=1.5u as=0.3808p ps=2.92u w=1.12u l=0.13u
X2129 VDD.t120 VSS.t581 VDD.t119 VDD.t20 sg13_lv_pmos ad=0.34p pd=2.68u as=0 ps=0 w=1u l=1u
X2130 a_1256_289# CHAN3_MUX_SEL2 VSS.t1645 VSS.t1660 sg13_lv_nmos ad=0.2516p pd=2.16u as=0.2516p ps=2.16u w=0.74u l=0.13u
X2131 VDD.t1194 a_3171_13229.t9 a_5844_13190# VDD.t36 sg13_lv_pmos ad=0.3808p pd=2.92u as=0.3808p ps=2.92u w=1.12u l=0.13u
X2132 VDD.t372 a_3747_3892.t6 a_15831_3853# VDD.t9 sg13_lv_pmos ad=0.3808p pd=2.92u as=0.3808p ps=2.92u w=1.12u l=0.13u
X2133 VDD.t140 VSS.t674 VDD.t139 VDD.t36 sg13_lv_pmos ad=0.34p pd=2.68u as=0 ps=0 w=1u l=1u
X2134 a_4633_1842# a_4437_1842# VSS.t523 VSS.t1554 sg13_lv_nmos ad=0.2516p pd=2.16u as=0.1406p ps=1.12u w=0.74u l=0.13u
X2135 VSS.t73 a_2019_3892.t3 a_22564_3853# VSS.t1999 sg13_lv_nmos ad=0.2516p pd=2.16u as=0.2516p ps=2.16u w=0.74u l=0.13u
X2136 VDD.t967 a_4437_16869# a_4905_16071# VDD.t20 sg13_lv_pmos ad=0.252p pd=1.57u as=0.3808p ps=2.92u w=1.12u l=0.13u
X2137 a_5731_15316# a_3171_15338.t3 a_10430_16071# VSS.t554 sg13_lv_nmos ad=0.2516p pd=2.16u as=0.2516p ps=2.16u w=0.74u l=0.13u
X2138 VDD.t1048 a_11603_16869# a_12037_16869# VDD.t365 sg13_lv_pmos ad=0.2128p pd=1.5u as=0.3808p ps=2.92u w=1.12u l=0.13u
X2139 VSS.t1877 a_2019_1047.t2 a_25604_1008# VSS.t1876 sg13_lv_nmos ad=0.2516p pd=2.16u as=0.2516p ps=2.16u w=0.74u l=0.13u
X2140 VDD.t775 a_4187_2434# a_21591_8160# VDD.t341 sg13_lv_pmos ad=0.3808p pd=2.92u as=0.2128p ps=1.5u w=1.12u l=0.6u
X2141 a_16108_289# CHAN3_MUX_SEL4 a_15964_289# VSS.t1549 sg13_lv_nmos ad=0.2516p pd=2.16u as=0.2183p ps=1.33u w=0.74u l=0.13u
X2142 a_15964_3134# a_15765_3308# a_5731_3134# VSS.t485 sg13_lv_nmos ad=0.2183p pd=1.33u as=0.2516p ps=2.16u w=0.74u l=0.13u
X2143 a_19550_6734# a_19524_6698# a_19448_6734# VDD.t29 sg13_lv_pmos ad=0.3808p pd=2.92u as=0.2128p ps=1.5u w=1.12u l=0.13u
X2144 VDD.t901 a_4187_2434# a_24631_5315# VDD.t339 sg13_lv_pmos ad=0.3808p pd=2.92u as=0.2128p ps=1.5u w=1.12u l=0.6u
X2145 a_4350_3889# a_4324_3853# a_4248_3889# VDD.t9 sg13_lv_pmos ad=0.3808p pd=2.92u as=0.2128p ps=1.5u w=1.12u l=0.13u
X2146 a_22873_1842# a_22677_1842# VDD.t1405 VDD.t353 sg13_lv_pmos ad=0.3808p pd=2.92u as=0.2128p ps=1.5u w=1.12u l=0.13u
X2147 a_14888_3889# a_14317_4687# VDD.t952 VDD.t9 sg13_lv_pmos ad=0.2128p pd=1.5u as=0.3808p ps=2.92u w=1.12u l=0.13u
X2148 VSS.t93 a_2873_3176# a_3171_3156.t1 VSS.t94 sg13_lv_nmos ad=0.2812p pd=2.24u as=0.1406p ps=1.12u w=0.74u l=0.13u
X2149 VSS.t1313 a_24197_16869# a_24665_16071# VSS.t1312 sg13_lv_nmos ad=0.1665p pd=1.19u as=0.2516p ps=2.16u w=0.74u l=0.13u
X2150 a_21835_1044# a_21625_1044# VSS.t2153 VSS.t2152 sg13_lv_nmos ad=0.1406p pd=1.12u as=0.1665p ps=1.19u w=0.74u l=0.13u
X2151 a_22351_4687# a_22113_4687# a_22243_4687# VSS.t1400 sg13_lv_nmos ad=0.1406p pd=1.12u as=0.2516p ps=2.16u w=0.74u l=0.2u
X2152 VDD.t731 a_14851_11918# a_15108_11799# VDD.t351 sg13_lv_pmos ad=0.2639p pd=1.81u as=79.8f ps=0.8u w=0.42u l=0.13u
X2153 VSS.t1572 a_4187_1764.t98 VSS.t1574 VSS.t1573 sg13_lv_nmos ad=1.33p pd=7.38u as=0 ps=0 w=7u l=7u
X2154 a_13231_14652# a_12993_14024# a_13123_14024# VDD.t381 sg13_lv_pmos ad=0.2128p pd=1.5u as=0.3808p ps=2.92u w=1.12u l=0.2u
X2155 VSS.t357 a_2595_1047.t4 a_20391_1008# VSS.t1707 sg13_lv_nmos ad=0.2516p pd=2.16u as=0.2516p ps=2.16u w=0.74u l=0.13u
X2156 VSS.t1074 a_16923_4687# a_17357_4687# VSS.t1784 sg13_lv_nmos ad=0.1406p pd=1.12u as=0.2516p ps=2.16u w=0.74u l=0.13u
X2157 VSS.t396 VDD.t1659 VSS.t396 VSS.t719 sg13_lv_nmos ad=0.1428p pd=1.52u as=0 ps=0 w=0.42u l=1u
X2158 a_1256_6734# REF_MUX_SEL0 VSS.t519 VSS.t1150 sg13_lv_nmos ad=0.2516p pd=2.16u as=0.2516p ps=2.16u w=0.74u l=0.13u
X2159 VDD.t854 a_4187_2434# a_13991_14652# VDD.t381 sg13_lv_pmos ad=0.3808p pd=2.92u as=0.2128p ps=1.5u w=1.12u l=0.6u
X2160 VDD.t642 VDD.t644 VDD.t645 VDD.t341 sg13_lv_pmos ad=0.2128p pd=1.5u as=0 ps=0 w=1.12u l=0.2u
X2161 VDD.t1287 a_2595_16074.t8 a_8231_16035# VDD.t20 sg13_lv_pmos ad=0.3808p pd=2.92u as=0.3808p ps=2.92u w=1.12u l=0.13u
X2162 a_13470_6734# a_14311_6698# a_14235_6734# VDD.t29 sg13_lv_pmos ad=0.3808p pd=2.92u as=0.2128p ps=1.5u w=1.12u l=0.13u
X2163 a_2297_6021# REF_MUX_SEL2 VDD.t418 VDD.t29 sg13_lv_pmos ad=0.1596p pd=1.22u as=0.2856p ps=2.36u w=0.84u l=0.13u
X2164 VDD.t1413 a_1544_13226# a_1721_13577# VDD.t36 sg13_lv_pmos ad=0.1918p pd=1.5u as=0.1596p ps=1.22u w=0.84u l=0.13u
X2165 a_13400_10795# a_13132_11110# a_13306_10795# VSS.t168 sg13_lv_nmos ad=60.89999f pd=0.71u as=0.1428p ps=1.52u w=0.42u l=0.13u
X2166 VDD.t462 a_27237_14024# a_27705_13226# VDD.t36 sg13_lv_pmos ad=0.252p pd=1.57u as=0.3808p ps=2.92u w=1.12u l=0.13u
X2167 VDD.t291 VSS.t656 VDD.t289 VDD.t36 sg13_lv_pmos ad=0.19p pd=1.38u as=0 ps=0 w=1u l=1u
X2168 VSS.t2236 a_10517_1842# a_10985_1044# VSS.t2235 sg13_lv_nmos ad=0.1665p pd=1.19u as=0.2516p ps=2.16u w=0.74u l=0.13u
X2169 a_9675_1044# a_9465_1044# VDD.t674 VDD.t0 sg13_lv_pmos ad=0.2128p pd=1.5u as=0.252p ps=1.57u w=1.12u l=0.13u
X2170 VSS.t722 VDD.t1658 VSS.t722 VSS.t721 sg13_lv_nmos ad=0.1428p pd=1.52u as=0 ps=0 w=0.42u l=1u
X2171 VDD.t730 a_1544_5979# a_1721_6021# VDD.t29 sg13_lv_pmos ad=0.1918p pd=1.5u as=0.1596p ps=1.22u w=0.84u l=0.13u
X2172 VSS.t85 a_4187_1764.t138 a_23111_16869# VSS.t557 sg13_lv_nmos ad=0.2516p pd=2.16u as=0.1406p ps=1.12u w=0.74u l=0.6u
X2173 a_14513_7532# a_14317_7532# VSS.t157 VSS.t494 sg13_lv_nmos ad=0.2516p pd=2.16u as=0.1406p ps=1.12u w=0.74u l=0.13u
X2174 a_23871_17497# a_23633_16869# a_23763_16869# VDD.t365 sg13_lv_pmos ad=0.2128p pd=1.5u as=0.3808p ps=2.92u w=1.12u l=0.2u
X2175 a_5631_7532# a_5393_7532# a_5523_7532# VSS.t2286 sg13_lv_nmos ad=0.1406p pd=1.12u as=0.2516p ps=2.16u w=0.74u l=0.2u
X2176 VDD.t1220 a_2019_6737.t3 a_22564_6698# VDD.t29 sg13_lv_pmos ad=0.3808p pd=2.92u as=0.3808p ps=2.92u w=1.12u l=0.13u
X2177 CHAN0_DELAY_OUT_LAST a_27997_16869# VDD.t1051 VDD.t365 sg13_lv_pmos ad=0.3808p pd=2.92u as=0.2128p ps=1.5u w=1.12u l=0.13u
X2178 a_4111_14024# CHAN1_DELAY_IN a_4003_14024# VSS.t159 sg13_lv_nmos ad=0.1406p pd=1.12u as=0.2516p ps=2.16u w=0.74u l=0.2u
X2179 VDD.t1205 a_2595_1047.t8 a_8231_1008# VDD.t0 sg13_lv_pmos ad=0.3808p pd=2.92u as=0.3808p ps=2.92u w=1.12u l=0.13u
X2180 VDD.t1599 a_3449_15358# a_3747_15338.t0 VDD.t20 sg13_lv_pmos ad=0.4256p pd=3u as=0.2128p ps=1.5u w=1.12u l=0.13u
X2181 a_1544_15316# CHAN0_MUX_SEL3 VSS.t277 VSS.t199 sg13_lv_nmos ad=0.2516p pd=2.16u as=0.2516p ps=2.16u w=0.74u l=0.13u
X2182 VDD.t581 a_22677_14024# a_23145_13226# VDD.t36 sg13_lv_pmos ad=0.252p pd=1.57u as=0.3808p ps=2.92u w=1.12u l=0.13u
X2183 a_2019_3156.t1 a_1721_3176# VSS.t1215 VSS.t253 sg13_lv_nmos ad=0.1406p pd=1.12u as=0.1331p ps=1.12u w=0.74u l=0.13u
X2184 VSS.t291 a_4187_1764.t56 a_10951_4687# VSS.t1334 sg13_lv_nmos ad=0.2516p pd=2.16u as=0.1406p ps=1.12u w=0.74u l=0.6u
X2185 VDD.t839 a_4187_2434# a_24631_17497# VDD.t365 sg13_lv_pmos ad=0.3808p pd=2.92u as=0.2128p ps=1.5u w=1.12u l=0.6u
X2186 VSS.t279 a_3449_15358# a_3747_15338.t1 VSS.t2338 sg13_lv_nmos ad=0.2812p pd=2.24u as=0.1406p ps=1.12u w=0.74u l=0.13u
X2187 a_20968_13226# a_20397_14024# VDD.t1064 VDD.t36 sg13_lv_pmos ad=0.2128p pd=1.5u as=0.3808p ps=2.92u w=1.12u l=0.13u
X2188 VDD.t219 VSS.t652 VDD.t69 VDD.t36 sg13_lv_pmos ad=0.19p pd=1.38u as=0 ps=0 w=1u l=1u
X2189 VSS.t26 a_3747_16074.t2 a_27991_16035# VSS.t25 sg13_lv_nmos ad=0.2516p pd=2.16u as=0.2516p ps=2.16u w=0.74u l=0.13u
X2190 VSS.t47 DLL_RESETN a_10040_11995# VSS.t46 sg13_lv_nmos ad=0.1626p pd=1.415u as=60.89999f ps=0.71u w=0.42u l=0.13u
X2191 a_13306_10795# a_14111_10917# a_13566_11018# VDD.t351 sg13_lv_pmos ad=0.1428p pd=1.52u as=79.8f ps=0.8u w=0.42u l=0.13u
X2192 a_13470_6734# a_3171_6737.t6 a_14888_6734# VSS.t1868 sg13_lv_nmos ad=0.2516p pd=2.16u as=0.1406p ps=1.12u w=0.74u l=0.13u
X2193 a_18551_1842# a_18313_1842# a_18443_1842# VSS.t1459 sg13_lv_nmos ad=0.1406p pd=1.12u as=0.2516p ps=2.16u w=0.74u l=0.2u
X2194 a_22873_14024# a_22677_14024# VDD.t580 VDD.t381 sg13_lv_pmos ad=0.3808p pd=2.92u as=0.2128p ps=1.5u w=1.12u l=0.13u
X2195 a_16108_3134# a_17865_3364# a_16510_3889# VDD.t9 sg13_lv_pmos ad=0.3808p pd=2.92u as=0.3808p ps=2.92u w=1.12u l=0.13u
X2196 VDD.t1062 a_16163_14024# a_16597_14024# VDD.t381 sg13_lv_pmos ad=0.2128p pd=1.5u as=0.3808p ps=2.92u w=1.12u l=0.13u
X2197 a_13121_11521# a_15688_11557# VDD.t477 VDD.t351 sg13_lv_pmos ad=0.3808p pd=2.92u as=0.2128p ps=1.5u w=1.12u l=0.13u
X2198 VDD.t379 a_1256_3134# a_2873_3176# VDD.t9 sg13_lv_pmos ad=0.1918p pd=1.5u as=0.1596p ps=1.22u w=0.84u l=0.13u
X2199 VSS.t56 a_20723_4687# a_21157_4687# VSS.t216 sg13_lv_nmos ad=0.1406p pd=1.12u as=0.2516p ps=2.16u w=0.74u l=0.13u
X2200 VDD.t648 VDD.t646 VDD.t647 VDD.t339 sg13_lv_pmos ad=0.3808p pd=2.92u as=0 ps=0 w=1.12u l=0.13u
X2201 a_4633_7532# a_4437_7532# VSS.t179 VSS.t178 sg13_lv_nmos ad=0.2516p pd=2.16u as=0.1406p ps=1.12u w=0.74u l=0.13u
X2202 a_26911_5315# a_26673_4687# a_26803_4687# VDD.t339 sg13_lv_pmos ad=0.2128p pd=1.5u as=0.3808p ps=2.92u w=1.12u l=0.2u
X2203 VSS.t1219 a_12037_14024# a_12505_13226# VSS.t1218 sg13_lv_nmos ad=0.1665p pd=1.19u as=0.2516p ps=2.16u w=0.74u l=0.13u
X2204 VSS.t2243 a_2019_6737.t2 a_25604_6698# VSS.t2242 sg13_lv_nmos ad=0.2516p pd=2.16u as=0.2516p ps=2.16u w=0.74u l=0.13u
X2205 VDD.t1308 a_8997_4687# a_9465_3889# VDD.t9 sg13_lv_pmos ad=0.252p pd=1.57u as=0.3808p ps=2.92u w=1.12u l=0.13u
X2206 VSS.t1209 a_4187_1764.t158 a_7911_16869# VSS.t1208 sg13_lv_nmos ad=0.2516p pd=2.16u as=0.1406p ps=1.12u w=0.74u l=0.6u
X2207 VDD.t942 a_11603_14024# a_12037_14024# VDD.t381 sg13_lv_pmos ad=0.2128p pd=1.5u as=0.3808p ps=2.92u w=1.12u l=0.13u
X2208 VSS.t89 a_25283_16869# a_25717_16869# VSS.t88 sg13_lv_nmos ad=0.1406p pd=1.12u as=0.2516p ps=2.16u w=0.74u l=0.13u
X2209 a_19550_13226# a_21911_13190# a_21835_13226# VDD.t36 sg13_lv_pmos ad=0.3808p pd=2.92u as=0.2128p ps=1.5u w=1.12u l=0.13u
X2210 VSS.t1191 a_10517_16869# a_10985_16071# VSS.t1190 sg13_lv_nmos ad=0.1665p pd=1.19u as=0.2516p ps=2.16u w=0.74u l=0.13u
X2211 VDD.t213 VSS.t665 VDD.t211 VDD.t36 sg13_lv_pmos ad=0.19p pd=1.38u as=0 ps=0 w=1u l=1u
X2212 VSS.t267 a_14851_11918# a_15688_11557# VSS.t266 sg13_lv_nmos ad=0.1406p pd=1.12u as=0.2516p ps=2.16u w=0.74u l=0.13u
X2213 VSS.t1426 a_3171_13229.t4 a_21044_13190# VSS.t2013 sg13_lv_nmos ad=0.2516p pd=2.16u as=0.2516p ps=2.16u w=0.74u l=0.13u
X2214 a_17275_3889# a_17065_3889# VSS.t493 VSS.t1925 sg13_lv_nmos ad=0.1406p pd=1.12u as=0.1665p ps=1.19u w=0.74u l=0.13u
X2215 VSS.t83 a_20723_16869# a_21157_16869# VSS.t1311 sg13_lv_nmos ad=0.1406p pd=1.12u as=0.2516p ps=2.16u w=0.74u l=0.13u
X2216 a_8433_16869# a_8237_16869# VDD.t1039 VDD.t365 sg13_lv_pmos ad=0.3808p pd=2.92u as=0.2128p ps=1.5u w=1.12u l=0.13u
X2217 VSS.t589 VDD.t1705 VSS.t591 VSS.t590 sg13_lv_nmos ad=79.8f pd=0.8u as=0 ps=0 w=0.42u l=1u
X2218 a_22873_7532# a_22677_7532# VDD.t962 VDD.t341 sg13_lv_pmos ad=0.3808p pd=2.92u as=0.2128p ps=1.5u w=1.12u l=0.13u
X2219 VSS.t1096 a_7043_14024# a_7477_14024# VSS.t1931 sg13_lv_nmos ad=0.1406p pd=1.12u as=0.2516p ps=2.16u w=0.74u l=0.13u
X2220 VSS.t76 a_3747_3892.t6 a_15831_3853# VSS.t75 sg13_lv_nmos ad=0.2516p pd=2.16u as=0.2516p ps=2.16u w=0.74u l=0.13u
X2221 VSS.t1198 a_4187_1764.t39 a_23871_4687# VSS.t1713 sg13_lv_nmos ad=0.2516p pd=2.16u as=0.1406p ps=1.12u w=0.74u l=0.6u
X2222 a_21835_6734# a_21625_6734# VSS.t1289 VSS.t1288 sg13_lv_nmos ad=0.1406p pd=1.12u as=0.1665p ps=1.19u w=0.74u l=0.13u
X2223 VSS.t102 a_3747_1047.t5 a_18871_1008# VSS.t249 sg13_lv_nmos ad=0.2516p pd=2.16u as=0.2516p ps=2.16u w=0.74u l=0.13u
X2224 a_22351_1842# a_22113_1842# a_22243_1842# VSS.t2051 sg13_lv_nmos ad=0.1406p pd=1.12u as=0.2516p ps=2.16u w=0.74u l=0.2u
X2225 VDD.t538 a_3171_311.t2 a_23945_519# VDD.t0 sg13_lv_pmos ad=0.3808p pd=2.92u as=0.3808p ps=2.92u w=1.12u l=0.13u
X2226 VDD.t110 VSS.t396 VDD.t109 VDD.t29 sg13_lv_pmos ad=0.34p pd=2.68u as=0 ps=0 w=1u l=1u
X2227 VDD.t1006 a_13557_14024# a_14025_13226# VDD.t36 sg13_lv_pmos ad=0.252p pd=1.57u as=0.3808p ps=2.92u w=1.12u l=0.13u
X2228 VDD.t897 a_4187_2434# a_15511_5315# VDD.t339 sg13_lv_pmos ad=0.3808p pd=2.92u as=0.2128p ps=1.5u w=1.12u l=0.6u
X2229 a_10191_17497# a_9953_16869# a_10083_16869# VDD.t365 sg13_lv_pmos ad=0.2128p pd=1.5u as=0.3808p ps=2.92u w=1.12u l=0.2u
X2230 VDD.t831 a_4187_2434# a_15511_17497# VDD.t365 sg13_lv_pmos ad=0.3808p pd=2.92u as=0.2128p ps=1.5u w=1.12u l=0.6u
X2231 VSS.t958 a_6126_9506# a_6126_9506# VSS.t956 sg13_lv_nmos ad=0.68p pd=4.68u as=0.38p ps=2.38u w=2u l=1u
X2232 VSS.t1022 a_2595_6737.t4 a_20391_6698# VSS.t1445 sg13_lv_nmos ad=0.2516p pd=2.16u as=0.2516p ps=2.16u w=0.74u l=0.13u
X2233 a_2019_311# a_1721_331# VSS.t435 VSS.t1353 sg13_lv_nmos ad=0.1406p pd=1.12u as=0.1331p ps=1.12u w=0.74u l=0.13u
X2234 VSS.t236 a_16923_1842# a_17357_1842# VSS.t235 sg13_lv_nmos ad=0.1406p pd=1.12u as=0.2516p ps=2.16u w=0.74u l=0.13u
X2235 VDD.t1122 a_2019_3892.t5 a_16484_3853# VDD.t9 sg13_lv_pmos ad=0.3808p pd=2.92u as=0.3808p ps=2.92u w=1.12u l=0.13u
X2236 REF_MUX_OUT a_16851_5999# VSS.t43 VSS.t114 sg13_lv_nmos ad=0.1406p pd=1.12u as=0.1371p ps=1.12u w=0.74u l=0.13u
X2237 VDD.t554 a_2873_7085# a_3171_6737.t0 VDD.t29 sg13_lv_pmos ad=0.4256p pd=3u as=0.2128p ps=1.5u w=1.12u l=0.13u
X2238 a_4350_3889# a_2019_3892.t9 a_4248_3889# VSS.t1530 sg13_lv_nmos ad=0.2516p pd=2.16u as=0.1406p ps=1.12u w=0.74u l=0.13u
X2239 VDD.t31 VSS.t722 VDD.t30 VDD.t29 sg13_lv_pmos ad=0.34p pd=2.68u as=0 ps=0 w=1u l=1u
X2240 VSS.t1498 a_3747_13229.t6 a_15831_13190# VSS.t1836 sg13_lv_nmos ad=0.2516p pd=2.16u as=0.2516p ps=2.16u w=0.74u l=0.13u
X2241 VDD.t800 a_4187_2434# a_10951_17497# VDD.t365 sg13_lv_pmos ad=0.3808p pd=2.92u as=0.2128p ps=1.5u w=1.12u l=0.6u
X2242 VDD.t374 a_21157_16869# a_21625_16071# VDD.t20 sg13_lv_pmos ad=0.252p pd=1.57u as=0.3808p ps=2.92u w=1.12u l=0.13u
X2243 VDD.t616 VDD.t614 VDD.t441 VDD.t351 sg13_lv_pmos ad=0.68p pd=4.68u as=0 ps=0 w=2u l=1u
X2244 VDD.t203 VSS.t616 VDD.t202 VDD.t20 sg13_lv_pmos ad=0.34p pd=2.68u as=0 ps=0 w=1u l=1u
X2245 VSS.t136 a_14009_11568# a_14111_11568# VSS.t1362 sg13_lv_nmos ad=2.39977p pd=15.495u as=0.2516p ps=2.16u w=0.74u l=0.13u
X2246 a_12715_1044# a_12505_1044# VSS.t1676 VSS.t2091 sg13_lv_nmos ad=0.1406p pd=1.12u as=0.1665p ps=1.19u w=0.74u l=0.13u
X2247 a_14888_3889# a_14317_4687# VSS.t1233 VSS.t1232 sg13_lv_nmos ad=0.1406p pd=1.12u as=0.2516p ps=2.16u w=0.74u l=0.13u
X2248 a_13231_4687# a_12993_4687# a_13123_4687# VSS.t1602 sg13_lv_nmos ad=0.1406p pd=1.12u as=0.2516p ps=2.16u w=0.74u l=0.2u
X2249 VDD.t999 a_25283_4687# a_25717_4687# VDD.t339 sg13_lv_pmos ad=0.2128p pd=1.5u as=0.3808p ps=2.92u w=1.12u l=0.13u
X2250 VSS.t167 a_10517_7532# a_10985_6734# VSS.t390 sg13_lv_nmos ad=0.1665p pd=1.19u as=0.2516p ps=2.16u w=0.74u l=0.13u
X2251 a_17928_1044# a_17357_1842# VSS.t1701 VSS.t1981 sg13_lv_nmos ad=0.1406p pd=1.12u as=0.2516p ps=2.16u w=0.74u l=0.13u
X2252 a_16108_5979# a_2595_6001.t2 a_19550_6734# VSS.t1507 sg13_lv_nmos ad=0.2516p pd=2.16u as=0.2516p ps=2.16u w=0.74u l=0.13u
X2253 VSS.t1329 a_2019_16074.t9 a_4324_16035# VSS.t1328 sg13_lv_nmos ad=0.2516p pd=2.16u as=0.2516p ps=2.16u w=0.74u l=0.13u
X2254 VSS.t279 CHAN0_MUX_SEL3 a_3543_15358# VSS.t278 sg13_lv_nmos ad=0.1331p pd=1.12u as=0.1216p ps=1.02u w=0.64u l=0.13u
X2255 a_25153_1842# a_24957_1842# VDD.t1427 VDD.t353 sg13_lv_pmos ad=0.3808p pd=2.92u as=0.2128p ps=1.5u w=1.12u l=0.13u
X2256 VDD.t1531 a_2019_16074.t4 a_19524_16035# VDD.t20 sg13_lv_pmos ad=0.3808p pd=2.92u as=0.3808p ps=2.92u w=1.12u l=0.13u
X2257 VDD.t1213 a_3171_3892.t9 a_5844_3853# VDD.t9 sg13_lv_pmos ad=0.3808p pd=2.92u as=0.3808p ps=2.92u w=1.12u l=0.13u
X2258 a_23871_14652# a_23633_14024# a_23763_14024# VDD.t381 sg13_lv_pmos ad=0.2128p pd=1.5u as=0.3808p ps=2.92u w=1.12u l=0.2u
X2259 a_1544_13226# CHAN1_MUX_SEL1 VSS.t200 VSS.t199 sg13_lv_nmos ad=0.2516p pd=2.16u as=0.2516p ps=2.16u w=0.74u l=0.13u
X2260 a_16108_15316# a_23945_15546# a_22590_16071# VDD.t20 sg13_lv_pmos ad=0.3808p pd=2.92u as=0.3808p ps=2.92u w=1.12u l=0.13u
X2261 CHAN1_DELAY_OUT_LAST a_27997_14024# VDD.t1344 VDD.t381 sg13_lv_pmos ad=0.3808p pd=2.92u as=0.2128p ps=1.5u w=1.12u l=0.13u
X2262 a_10430_13226# a_12791_13190# a_12715_13226# VDD.t36 sg13_lv_pmos ad=0.3808p pd=2.92u as=0.2128p ps=1.5u w=1.12u l=0.13u
X2263 a_19550_1044# a_3171_1047.t4 a_20968_1044# VSS.t355 sg13_lv_nmos ad=0.2516p pd=2.16u as=0.1406p ps=1.12u w=0.74u l=0.13u
X2264 VDD.t1128 CHAN3_MUX_SEL4 a_15765_463# VDD.t0 sg13_lv_pmos ad=0.3808p pd=2.92u as=0.3808p ps=2.92u w=1.12u l=0.13u
X2265 VDD.t851 a_4187_2434# a_5631_5315# VDD.t339 sg13_lv_pmos ad=0.3808p pd=2.92u as=0.2128p ps=1.5u w=1.12u l=0.6u
X2266 a_16108_12471# a_20905_12701# a_19550_13226# VDD.t36 sg13_lv_pmos ad=0.3808p pd=2.92u as=0.3808p ps=2.92u w=1.12u l=0.13u
X2267 a_19550_1044# a_19524_1008# a_19448_1044# VDD.t0 sg13_lv_pmos ad=0.3808p pd=2.92u as=0.2128p ps=1.5u w=1.12u l=0.13u
X2268 VSS.t379 a_4187_1764.t24 a_10951_1842# VSS.t1113 sg13_lv_nmos ad=0.2516p pd=2.16u as=0.1406p ps=1.12u w=0.74u l=0.6u
X2269 VDD.t864 a_4187_2434# a_24631_14652# VDD.t381 sg13_lv_pmos ad=0.3808p pd=2.92u as=0.2128p ps=1.5u w=1.12u l=0.6u
X2270 VSS.t760 VDD.t1642 VSS.t760 VSS.t762 sg13_lv_nmos ad=79.8f pd=0.8u as=0 ps=0 w=0.42u l=1u
X2271 VDD.t1094 a_2595_3892.t7 a_11271_3853# VDD.t9 sg13_lv_pmos ad=0.3808p pd=2.92u as=0.3808p ps=2.92u w=1.12u l=0.13u
X2272 a_18551_7532# a_18313_7532# a_18443_7532# VSS.t2209 sg13_lv_nmos ad=0.1406p pd=1.12u as=0.2516p ps=2.16u w=0.74u l=0.2u
X2273 VDD.t481 a_1544_6734# a_2297_7085# VDD.t29 sg13_lv_pmos ad=0.1918p pd=1.5u as=0.1596p ps=1.22u w=0.84u l=0.13u
X2274 a_7288_1044# a_6717_1842# VSS.t994 VSS.t2324 sg13_lv_nmos ad=0.1406p pd=1.12u as=0.2516p ps=2.16u w=0.74u l=0.13u
X2275 a_1544_3134# CHAN2_MUX_SEL3 VSS.t1596 VSS.t1617 sg13_lv_nmos ad=0.2516p pd=2.16u as=0.2516p ps=2.16u w=0.74u l=0.13u
X2276 a_12233_4687# a_12037_4687# VSS.t501 VSS.t1636 sg13_lv_nmos ad=0.2516p pd=2.16u as=0.1406p ps=1.12u w=0.74u l=0.13u
X2277 a_17275_6734# a_17065_6734# VDD.t673 VDD.t29 sg13_lv_pmos ad=0.2128p pd=1.5u as=0.252p ps=1.57u w=1.12u l=0.13u
X2278 VSS.t702 VDD.t1666 VSS.t702 VSS.t705 sg13_lv_nmos ad=79.8f pd=0.8u as=0 ps=0 w=0.42u l=1u
X2279 a_3747_16074.t0 a_3449_16422# VDD.t502 VDD.t20 sg13_lv_pmos ad=0.2128p pd=1.5u as=0.1918p ps=1.5u w=1.12u l=0.13u
X2280 VDD.t590 a_2019_13229.t8 a_7364_13190# VDD.t36 sg13_lv_pmos ad=0.3808p pd=2.92u as=0.3808p ps=2.92u w=1.12u l=0.13u
X2281 VSS.t383 a_20723_1842# a_21157_1842# VSS.t382 sg13_lv_nmos ad=0.1406p pd=1.12u as=0.2516p ps=2.16u w=0.74u l=0.13u
X2282 a_2019_6737.t0 a_1721_7085# VDD.t475 VDD.t29 sg13_lv_pmos ad=0.2128p pd=1.5u as=0.1918p ps=1.5u w=1.12u l=0.13u
X2283 VDD.t707 a_13123_16869# a_13557_16869# VDD.t365 sg13_lv_pmos ad=0.2128p pd=1.5u as=0.3808p ps=2.92u w=1.12u l=0.13u
X2284 VDD.t1248 a_3747_6737.t6 a_15831_6698# VDD.t29 sg13_lv_pmos ad=0.3808p pd=2.92u as=0.3808p ps=2.92u w=1.12u l=0.13u
X2285 a_11693_11680# a_10751_11568# a_11491_11918# VDD.t351 sg13_lv_pmos ad=93.45f pd=0.865u as=0.2048p ps=1.63u w=0.42u l=0.13u
X2286 VDD.t430 CHAN1_MUX_SEL4 a_15765_12645# VDD.t36 sg13_lv_pmos ad=0.3808p pd=2.92u as=0.3808p ps=2.92u w=1.12u l=0.13u
X2287 VDD.t532 a_3747_16074.t3 a_24951_16035# VDD.t20 sg13_lv_pmos ad=0.3808p pd=2.92u as=0.3808p ps=2.92u w=1.12u l=0.13u
X2288 a_1544_289# CHAN3_MUX_SEL3 VSS.t1645 VSS.t1644 sg13_lv_nmos ad=0.2516p pd=2.16u as=0.2516p ps=2.16u w=0.74u l=0.13u
X2289 VDD.t1305 a_3747_3892.t8 a_9751_3853# VDD.t9 sg13_lv_pmos ad=0.3808p pd=2.92u as=0.3808p ps=2.92u w=1.12u l=0.13u
X2290 VDD.t93 VSS.t636 VDD.t271 VDD.t20 sg13_lv_pmos ad=0.34p pd=2.68u as=0 ps=0 w=1u l=1u
X2291 a_22590_1044# a_3747_1047.t3 a_24875_1044# VSS.t1004 sg13_lv_nmos ad=0.2516p pd=2.16u as=0.1406p ps=1.12u w=0.74u l=0.13u
X2292 a_13470_1044# a_14311_1008# a_14235_1044# VDD.t0 sg13_lv_pmos ad=0.3808p pd=2.92u as=0.2128p ps=1.5u w=1.12u l=0.13u
X2293 a_4350_6734# a_4324_6698# a_4248_6734# VDD.t29 sg13_lv_pmos ad=0.3808p pd=2.92u as=0.2128p ps=1.5u w=1.12u l=0.13u
X2294 a_8433_14024# a_8237_14024# VDD.t1330 VDD.t381 sg13_lv_pmos ad=0.3808p pd=2.92u as=0.2128p ps=1.5u w=1.12u l=0.13u
X2295 a_3171_3892.t0 a_2873_4240# VDD.t1318 VDD.t9 sg13_lv_pmos ad=0.2128p pd=1.5u as=0.1918p ps=1.5u w=1.12u l=0.13u
X2296 a_14888_6734# a_14317_7532# VDD.t563 VDD.t29 sg13_lv_pmos ad=0.2128p pd=1.5u as=0.3808p ps=2.92u w=1.12u l=0.13u
X2297 VSS.t374 a_4187_1764.t7 a_23871_1842# VSS.t373 sg13_lv_nmos ad=0.2516p pd=2.16u as=0.1406p ps=1.12u w=0.74u l=0.6u
X2298 a_22351_7532# a_22113_7532# a_22243_7532# VSS.t2271 sg13_lv_nmos ad=0.1406p pd=1.12u as=0.2516p ps=2.16u w=0.74u l=0.2u
X2299 VSS.t488 a_3747_6737.t5 a_18871_6698# VSS.t487 sg13_lv_nmos ad=0.2516p pd=2.16u as=0.2516p ps=2.16u w=0.74u l=0.13u
X2300 VDD.t517 a_2019_1047.t3 a_22564_1008# VDD.t0 sg13_lv_pmos ad=0.3808p pd=2.92u as=0.3808p ps=2.92u w=1.12u l=0.13u
X2301 VSS.t1910 a_8997_4687# a_9465_3889# VSS.t2299 sg13_lv_nmos ad=0.1665p pd=1.19u as=0.2516p ps=2.16u w=0.74u l=0.13u
X2302 VSS.t191 a_2873_6021# a_3171_6001.t1 VSS.t536 sg13_lv_nmos ad=0.2812p pd=2.24u as=0.1406p ps=1.12u w=0.74u l=0.13u
X2303 VDD.t268 VSS.t760 VDD.t267 VDD.t9 sg13_lv_pmos ad=0.34p pd=2.68u as=0 ps=0 w=1u l=1u
X2304 VDD.t1053 a_2297_4240# a_2595_3892.t0 VDD.t9 sg13_lv_pmos ad=0.4256p pd=3u as=0.2128p ps=1.5u w=1.12u l=0.13u
X2305 VDD.t116 VSS.t579 VDD.t114 VDD.t20 sg13_lv_pmos ad=0.19p pd=1.38u as=0 ps=0 w=1u l=1u
X2306 a_5731_12471# a_11785_12701# a_10430_13226# VDD.t36 sg13_lv_pmos ad=0.3808p pd=2.92u as=0.3808p ps=2.92u w=1.12u l=0.13u
X2307 a_15964_15316# a_15765_15490# a_5731_15316# VSS.t1339 sg13_lv_nmos ad=0.2183p pd=1.33u as=0.2516p ps=2.16u w=0.74u l=0.13u
X2308 VSS.t1819 a_16923_7532# a_17357_7532# VSS.t2157 sg13_lv_nmos ad=0.1406p pd=1.12u as=0.2516p ps=2.16u w=0.74u l=0.13u
X2309 VDD.t706 a_3747_16074.t8 a_9751_16035# VDD.t20 sg13_lv_pmos ad=0.3808p pd=2.92u as=0.3808p ps=2.92u w=1.12u l=0.13u
X2310 a_10191_14652# a_9953_14024# a_10083_14024# VDD.t381 sg13_lv_pmos ad=0.2128p pd=1.5u as=0.3808p ps=2.92u w=1.12u l=0.2u
X2311 VDD.t858 a_4187_2434# a_15511_14652# VDD.t381 sg13_lv_pmos ad=0.3808p pd=2.92u as=0.2128p ps=1.5u w=1.12u l=0.6u
X2312 VSS.t43 REF_MUX_SEL4 a_15765_6153# VSS.t174 sg13_lv_nmos ad=0.2516p pd=2.16u as=0.2516p ps=2.16u w=0.74u l=0.13u
X2313 a_10713_16869# a_10517_16869# VDD.t929 VDD.t365 sg13_lv_pmos ad=0.3808p pd=2.92u as=0.2128p ps=1.5u w=1.12u l=0.13u
X2314 VDD.t11 VSS.t766 VDD.t10 VDD.t9 sg13_lv_pmos ad=0.34p pd=2.68u as=0 ps=0 w=1u l=1u
X2315 a_16793_4687# a_16597_4687# VDD.t560 VDD.t339 sg13_lv_pmos ad=0.3808p pd=2.92u as=0.2128p ps=1.5u w=1.12u l=0.13u
X2316 VSS.t2128 a_25717_1842# a_26185_1044# VSS.t2127 sg13_lv_nmos ad=0.1665p pd=1.19u as=0.2516p ps=2.16u w=0.74u l=0.13u
X2317 a_7911_5315# a_7673_4687# a_7803_4687# VDD.t339 sg13_lv_pmos ad=0.2128p pd=1.5u as=0.3808p ps=2.92u w=1.12u l=0.2u
X2318 VDD.t410 a_2595_16074.t9 a_5191_16035# VDD.t20 sg13_lv_pmos ad=0.3808p pd=2.92u as=0.3808p ps=2.92u w=1.12u l=0.13u
X2319 VDD.t845 a_4187_2434# a_10951_14652# VDD.t381 sg13_lv_pmos ad=0.3808p pd=2.92u as=0.2128p ps=1.5u w=1.12u l=0.6u
X2320 VDD.t257 VSS.t680 VDD.t256 VDD.t36 sg13_lv_pmos ad=0.34p pd=2.68u as=0 ps=0 w=1u l=1u
X2321 a_12715_6734# a_12505_6734# VSS.t205 VSS.t204 sg13_lv_nmos ad=0.1406p pd=1.12u as=0.1665p ps=1.19u w=0.74u l=0.13u
X2322 a_13231_1842# a_12993_1842# a_13123_1842# VSS.t1968 sg13_lv_nmos ad=0.1406p pd=1.12u as=0.2516p ps=2.16u w=0.74u l=0.2u
X2323 a_2297_4240# CHAN2_MUX_SEL0 VDD.t959 VDD.t9 sg13_lv_pmos ad=0.1596p pd=1.22u as=0.2856p ps=2.36u w=0.84u l=0.13u
X2324 a_25153_7532# a_24957_7532# VDD.t413 VDD.t341 sg13_lv_pmos ad=0.3808p pd=2.92u as=0.2128p ps=1.5u w=1.12u l=0.13u
X2325 a_17928_6734# a_17357_7532# VSS.t1438 VSS.t1817 sg13_lv_nmos ad=0.1406p pd=1.12u as=0.2516p ps=2.16u w=0.74u l=0.13u
X2326 a_5631_14024# a_5393_14024# a_5523_14024# VSS.t1916 sg13_lv_nmos ad=0.1406p pd=1.12u as=0.2516p ps=2.16u w=0.74u l=0.2u
X2327 VSS.t161 CHAN1_MUX_SEL3 a_3543_12513# VSS.t1787 sg13_lv_nmos ad=0.1331p pd=1.12u as=0.1216p ps=1.02u w=0.64u l=0.13u
X2328 VSS.t783 VDD.t1635 VSS.t783 VSS.t784 sg13_lv_nmos ad=79.8f pd=0.8u as=0 ps=0 w=0.42u l=1u
X2329 VDD.t1131 a_24197_14024# a_24665_13226# VDD.t36 sg13_lv_pmos ad=0.252p pd=1.57u as=0.3808p ps=2.92u w=1.12u l=0.13u
X2330 a_19833_14024# a_19637_14024# VSS.t525 VSS.t2178 sg13_lv_nmos ad=0.2516p pd=2.16u as=0.1406p ps=1.12u w=0.74u l=0.13u
X2331 a_17791_2470# a_17553_1842# a_17683_1842# VDD.t353 sg13_lv_pmos ad=0.2128p pd=1.5u as=0.3808p ps=2.92u w=1.12u l=0.2u
X2332 VDD.t1283 a_1544_3889# a_1721_4240# VDD.t9 sg13_lv_pmos ad=0.1918p pd=1.5u as=0.1596p ps=1.22u w=0.84u l=0.13u
X2333 VSS.t1338 a_4187_1764.t36 a_26151_4687# VSS.t1337 sg13_lv_nmos ad=0.2516p pd=2.16u as=0.1406p ps=1.12u w=0.74u l=0.6u
X2334 a_19550_6734# a_3171_6737.t4 a_20968_6734# VSS.t1866 sg13_lv_nmos ad=0.2516p pd=2.16u as=0.1406p ps=1.12u w=0.74u l=0.13u
X2335 VSS.t1100 a_4187_1764.t142 a_20071_16869# VSS.t1099 sg13_lv_nmos ad=0.2516p pd=2.16u as=0.1406p ps=1.12u w=0.74u l=0.6u
X2336 VSS.t1178 a_4437_1842# a_4905_1044# VSS.t1553 sg13_lv_nmos ad=0.1665p pd=1.19u as=0.2516p ps=2.16u w=0.74u l=0.13u
X2337 VSS.t76 a_2019_3892.t5 a_16484_3853# VSS.t1534 sg13_lv_nmos ad=0.2516p pd=2.16u as=0.2516p ps=2.16u w=0.74u l=0.13u
X2338 a_25153_16869# a_24957_16869# VDD.t1276 VDD.t365 sg13_lv_pmos ad=0.3808p pd=2.92u as=0.2128p ps=1.5u w=1.12u l=0.13u
X2339 VSS.t1046 a_4187_1764.t128 a_6391_14024# VSS.t1045 sg13_lv_nmos ad=0.2516p pd=2.16u as=0.1406p ps=1.12u w=0.74u l=0.6u
X2340 VSS.t187 a_4187_1764.t88 a_10951_7532# VSS.t1129 sg13_lv_nmos ad=0.2516p pd=2.16u as=0.1406p ps=1.12u w=0.74u l=0.6u
X2341 a_2019_6001.t1 a_1721_6021# VSS.t1136 VSS.t1515 sg13_lv_nmos ad=0.1406p pd=1.12u as=0.1331p ps=1.12u w=0.74u l=0.13u
X2342 VSS.t469 a_23763_14024# a_24197_14024# VSS.t2182 sg13_lv_nmos ad=0.1406p pd=1.12u as=0.2516p ps=2.16u w=0.74u l=0.13u
X2343 VDD.t48 VSS.t702 VDD.t46 VDD.t29 sg13_lv_pmos ad=0.19p pd=1.38u as=0 ps=0 w=1u l=1u
X2344 VSS.t687 VDD.t1671 VSS.t687 VSS.t692 sg13_lv_nmos ad=79.8f pd=0.8u as=0 ps=0 w=0.42u l=1u
X2345 VSS.t431 a_2595_13229.t2 a_26471_13190# VSS.t1695 sg13_lv_nmos ad=0.2516p pd=2.16u as=0.2516p ps=2.16u w=0.74u l=0.13u
X2346 VDD.t150 VSS.t643 VDD.t151 VDD.t36 sg13_lv_pmos ad=0.19p pd=1.38u as=0 ps=0 w=1u l=1u
X2347 a_7288_6734# a_6717_7532# VSS.t16 VSS.t15 sg13_lv_nmos ad=0.1406p pd=1.12u as=0.2516p ps=2.16u w=0.74u l=0.13u
X2348 VDD.t332 VSS.t829 VDD.t331 VDD.t0 sg13_lv_pmos ad=0.34p pd=2.68u as=0 ps=0 w=1u l=1u
X2349 VSS.t503 a_4187_1764.t64 a_4871_4687# VSS.t502 sg13_lv_nmos ad=0.2516p pd=2.16u as=0.1406p ps=1.12u w=0.74u l=0.6u
X2350 a_5731_5979# a_3171_6001.t3 a_10430_6734# VSS.t1840 sg13_lv_nmos ad=0.2516p pd=2.16u as=0.2516p ps=2.16u w=0.74u l=0.13u
X2351 a_12233_1842# a_12037_1842# VSS.t1110 VSS.t1674 sg13_lv_nmos ad=0.2516p pd=2.16u as=0.1406p ps=1.12u w=0.74u l=0.13u
X2352 VSS.t1609 a_20723_7532# a_21157_7532# VSS.t1774 sg13_lv_nmos ad=0.1406p pd=1.12u as=0.2516p ps=2.16u w=0.74u l=0.13u
X2353 VSS.t1542 a_3171_3892.t9 a_5844_3853# VSS.t1734 sg13_lv_nmos ad=0.2516p pd=2.16u as=0.2516p ps=2.16u w=0.74u l=0.13u
X2354 VDD.t937 a_27563_4687# a_27997_4687# VDD.t339 sg13_lv_pmos ad=0.2128p pd=1.5u as=0.3808p ps=2.92u w=1.12u l=0.13u
X2355 VDD.t1005 a_13123_14024# a_13557_14024# VDD.t381 sg13_lv_pmos ad=0.2128p pd=1.5u as=0.3808p ps=2.92u w=1.12u l=0.13u
X2356 VSS.t336 a_3171_1047.t8 a_8884_1008# VSS.t335 sg13_lv_nmos ad=0.2516p pd=2.16u as=0.2516p ps=2.16u w=0.74u l=0.13u
X2357 VSS.t832 VDD.t1622 VSS.t834 VSS.t833 sg13_lv_nmos ad=79.8f pd=0.8u as=0 ps=0 w=0.42u l=1u
X2358 VSS.t2167 a_3449_1395# a_3747_1047.t1 VSS.t2166 sg13_lv_nmos ad=0.2812p pd=2.24u as=0.1406p ps=1.12u w=0.74u l=0.13u
X2359 VSS.t1475 a_12037_16869# a_12505_16071# VSS.t1474 sg13_lv_nmos ad=0.1665p pd=1.19u as=0.2516p ps=2.16u w=0.74u l=0.13u
X2360 a_20593_4687# a_20397_4687# VDD.t1116 VDD.t339 sg13_lv_pmos ad=0.3808p pd=2.92u as=0.2128p ps=1.5u w=1.12u l=0.13u
X2361 a_8155_16071# a_7945_16071# VDD.t1120 VDD.t20 sg13_lv_pmos ad=0.2128p pd=1.5u as=0.252p ps=1.57u w=1.12u l=0.13u
X2362 a_14009_11568# REF_CLK VDD.t352 VDD.t351 sg13_lv_pmos ad=0.4088p pd=2.97u as=1.03698p ps=6.245u w=1.12u l=0.13u
X2363 VDD.t955 a_8997_7532# a_9465_6734# VDD.t29 sg13_lv_pmos ad=0.252p pd=1.57u as=0.3808p ps=2.92u w=1.12u l=0.13u
X2364 VDD.t56 VSS.t802 VDD.t55 VDD.t0 sg13_lv_pmos ad=0.34p pd=2.68u as=0 ps=0 w=1u l=1u
X2365 VDD.t336 VSS.t812 VDD.t4 VDD.t0 sg13_lv_pmos ad=0.19p pd=1.38u as=0 ps=0 w=1u l=1u
X2366 VSS.t152 a_2019_13229.t3 a_22564_13190# VSS.t151 sg13_lv_nmos ad=0.2516p pd=2.16u as=0.2516p ps=2.16u w=0.74u l=0.13u
X2367 VSS.t308 a_4187_1764.t162 a_4871_16869# VSS.t1633 sg13_lv_nmos ad=0.2516p pd=2.16u as=0.1406p ps=1.12u w=0.74u l=0.6u
X2368 a_1544_12471# CHAN1_MUX_SEL3 VDD.t1242 VDD.t36 sg13_lv_pmos ad=0.3808p pd=2.92u as=0.3808p ps=2.92u w=1.12u l=0.13u
X2369 VDD.t753 a_2873_1395# a_3171_1047.t0 VDD.t0 sg13_lv_pmos ad=0.4256p pd=3u as=0.2128p ps=1.5u w=1.12u l=0.13u
X2370 VSS.t769 VDD.t1638 VSS.t769 VSS.t771 sg13_lv_nmos ad=0.1428p pd=1.52u as=0 ps=0 w=0.42u l=1u
X2371 VSS.t1026 a_2595_3892.t7 a_11271_3853# VSS.t1485 sg13_lv_nmos ad=0.2516p pd=2.16u as=0.2516p ps=2.16u w=0.74u l=0.13u
X2372 a_9953_16869# a_9757_16869# VDD.t1043 VDD.t365 sg13_lv_pmos ad=0.3808p pd=2.92u as=0.2128p ps=1.5u w=1.12u l=0.13u
X2373 VSS.t223 a_22243_16869# a_22677_16869# VSS.t222 sg13_lv_nmos ad=0.1406p pd=1.12u as=0.2516p ps=2.16u w=0.74u l=0.13u
X2374 a_22590_6734# a_3747_6737.t3 a_24875_6734# VSS.t1793 sg13_lv_nmos ad=0.2516p pd=2.16u as=0.1406p ps=1.12u w=0.74u l=0.13u
X2375 VDD.t454 a_6283_4687# a_6717_4687# VDD.t339 sg13_lv_pmos ad=0.2128p pd=1.5u as=0.3808p ps=2.92u w=1.12u l=0.13u
X2376 VSS.t2191 a_3171_16074.t4 a_21044_16035# VSS.t2190 sg13_lv_nmos ad=0.2516p pd=2.16u as=0.2516p ps=2.16u w=0.74u l=0.13u
X2377 VDD.t338 a_3747_13229.t2 a_27991_13190# VDD.t36 sg13_lv_pmos ad=0.3808p pd=2.92u as=0.3808p ps=2.92u w=1.12u l=0.13u
X2378 a_21591_2470# a_21353_1842# a_21483_1842# VDD.t353 sg13_lv_pmos ad=0.2128p pd=1.5u as=0.3808p ps=2.92u w=1.12u l=0.2u
X2379 a_6153_1842# a_5957_1842# VDD.t540 VDD.t353 sg13_lv_pmos ad=0.3808p pd=2.92u as=0.2128p ps=1.5u w=1.12u l=0.13u
X2380 a_7390_13226# a_2019_13229.t8 a_7288_13226# VSS.t565 sg13_lv_nmos ad=0.2516p pd=2.16u as=0.1406p ps=1.12u w=0.74u l=0.13u
X2381 a_3543_1395# CHAN3_MUX_SEL0 a_3449_1395# VSS.t2077 sg13_lv_nmos ad=0.1216p pd=1.02u as=0.2176p ps=1.96u w=0.64u l=0.13u
X2382 VDD.t946 a_16163_1842# a_16597_1842# VDD.t353 sg13_lv_pmos ad=0.2128p pd=1.5u as=0.3808p ps=2.92u w=1.12u l=0.13u
X2383 VSS.t1122 a_4003_14024# a_4437_14024# VSS.t1922 sg13_lv_nmos ad=0.1406p pd=1.12u as=0.2516p ps=2.16u w=0.74u l=0.13u
X2384 VSS.t144 a_4187_1764.t71 a_23871_7532# VSS.t143 sg13_lv_nmos ad=0.2516p pd=2.16u as=0.1406p ps=1.12u w=0.74u l=0.6u
X2385 a_11711_17497# a_11473_16869# a_11603_16869# VDD.t365 sg13_lv_pmos ad=0.2128p pd=1.5u as=0.3808p ps=2.92u w=1.12u l=0.2u
X2386 VSS.t1903 a_3747_3892.t8 a_9751_3853# VSS.t1902 sg13_lv_nmos ad=0.2516p pd=2.16u as=0.2516p ps=2.16u w=0.74u l=0.13u
X2387 VDD.t1097 a_10517_14024# a_10985_13226# VDD.t36 sg13_lv_pmos ad=0.252p pd=1.57u as=0.3808p ps=2.92u w=1.12u l=0.13u
X2388 VDD.t1217 a_2019_6737.t5 a_16484_6698# VDD.t29 sg13_lv_pmos ad=0.3808p pd=2.92u as=0.3808p ps=2.92u w=1.12u l=0.13u
X2389 VSS.t241 a_2595_13229.t5 a_17351_13190# VSS.t240 sg13_lv_nmos ad=0.2516p pd=2.16u as=0.2516p ps=2.16u w=0.74u l=0.13u
X2390 VDD.t824 a_4187_2434# a_12471_17497# VDD.t365 sg13_lv_pmos ad=0.3808p pd=2.92u as=0.2128p ps=1.5u w=1.12u l=0.6u
X2391 VDD.t1239 a_1544_1044# a_2297_1395# VDD.t0 sg13_lv_pmos ad=0.1918p pd=1.5u as=0.1596p ps=1.22u w=0.84u l=0.13u
X2392 a_1544_3889# CHAN2_MUX_SEL1 VDD.t400 VDD.t9 sg13_lv_pmos ad=0.3808p pd=2.92u as=0.3808p ps=2.92u w=1.12u l=0.13u
X2393 a_15964_5979# REF_MUX_SEL4 a_5731_5979# VDD.t29 sg13_lv_pmos ad=0.3304p pd=1.71u as=0.3808p ps=2.92u w=1.12u l=0.13u
X2394 a_27915_1044# a_27705_1044# VSS.t1159 VSS.t1158 sg13_lv_nmos ad=0.1406p pd=1.12u as=0.1665p ps=1.19u w=0.74u l=0.13u
X2395 a_17275_1044# a_17065_1044# VDD.t1140 VDD.t0 sg13_lv_pmos ad=0.2128p pd=1.5u as=0.252p ps=1.57u w=1.12u l=0.13u
X2396 VSS.t942 VSS.t939 VSS.t941 VSS.t940 sg13_lv_nmos ad=0.2516p pd=2.16u as=0 ps=0 w=0.74u l=0.6u
X2397 VSS.t407 a_3747_16074.t6 a_15831_16035# VSS.t406 sg13_lv_nmos ad=0.2516p pd=2.16u as=0.2516p ps=2.16u w=0.74u l=0.13u
X2398 VSS.t294 a_25717_7532# a_26185_6734# VSS.t2145 sg13_lv_nmos ad=0.1665p pd=1.19u as=0.2516p ps=2.16u w=0.74u l=0.13u
X2399 a_10713_14024# a_10517_14024# VDD.t566 VDD.t381 sg13_lv_pmos ad=0.3808p pd=2.92u as=0.2128p ps=1.5u w=1.12u l=0.13u
X2400 a_13470_3889# a_15831_3853# a_15755_3889# VDD.t9 sg13_lv_pmos ad=0.3808p pd=2.92u as=0.2128p ps=1.5u w=1.12u l=0.13u
X2401 a_26151_17497# a_25913_16869# a_26043_16869# VDD.t365 sg13_lv_pmos ad=0.2128p pd=1.5u as=0.3808p ps=2.92u w=1.12u l=0.2u
X2402 VSS.t120 a_3171_15338.t2 a_23945_15546# VSS.t119 sg13_lv_nmos ad=0.2516p pd=2.16u as=0.2516p ps=2.16u w=0.74u l=0.13u
X2403 VSS.t149 a_3747_13229.t7 a_12791_13190# VSS.t1691 sg13_lv_nmos ad=0.2516p pd=2.16u as=0.2516p ps=2.16u w=0.74u l=0.13u
X2404 VDD.t632 VDD.t630 VDD.t631 VDD.t360 sg13_lv_pmos ad=0.3808p pd=2.92u as=0 ps=0 w=1.12u l=0.13u
X2405 a_13231_7532# a_12993_7532# a_13123_7532# VSS.t2163 sg13_lv_nmos ad=0.1406p pd=1.12u as=0.2516p ps=2.16u w=0.74u l=0.2u
X2406 a_2019_1047.t0 a_1721_1395# VDD.t470 VDD.t0 sg13_lv_pmos ad=0.2128p pd=1.5u as=0.1918p ps=1.5u w=1.12u l=0.13u
X2407 VDD.t774 a_4187_2434# a_10191_2470# VDD.t353 sg13_lv_pmos ad=0.3808p pd=2.92u as=0.2128p ps=1.5u w=1.12u l=0.6u
X2408 a_16108_5979# REF_MUX_SEL4 a_15964_5979# VSS.t173 sg13_lv_nmos ad=0.2516p pd=2.16u as=0.2183p ps=1.33u w=0.74u l=0.13u
X2409 VDD.t1606 a_3449_13577# a_3747_13229.t0 VDD.t36 sg13_lv_pmos ad=0.4256p pd=3u as=0.2128p ps=1.5u w=1.12u l=0.13u
X2410 VDD.t690 a_3747_1047.t6 a_15831_1008# VDD.t0 sg13_lv_pmos ad=0.3808p pd=2.92u as=0.3808p ps=2.92u w=1.12u l=0.13u
X2411 a_15108_11015# a_14851_10872# a_15270_10795# VSS.t1806 sg13_lv_nmos ad=0.1428p pd=1.52u as=37.8f ps=0.6u w=0.42u l=0.13u
X2412 a_17791_8160# a_17553_7532# a_17683_7532# VDD.t341 sg13_lv_pmos ad=0.2128p pd=1.5u as=0.3808p ps=2.92u w=1.12u l=0.2u
X2413 VDD.t1075 a_3171_6737.t9 a_5844_6698# VDD.t29 sg13_lv_pmos ad=0.3808p pd=2.92u as=0.3808p ps=2.92u w=1.12u l=0.13u
X2414 VSS.t546 a_4187_1764.t4 a_26151_1842# VSS.t545 sg13_lv_nmos ad=0.2516p pd=2.16u as=0.1406p ps=1.12u w=0.74u l=0.6u
X2415 a_1544_16071# CHAN0_MUX_SEL1 VSS.t327 VSS.t326 sg13_lv_nmos ad=0.2516p pd=2.16u as=0.2516p ps=2.16u w=0.74u l=0.13u
X2416 VDD.t1285 a_2019_16074.t5 a_16484_16035# VDD.t20 sg13_lv_pmos ad=0.3808p pd=2.92u as=0.3808p ps=2.92u w=1.12u l=0.13u
X2417 VSS.t1564 a_4187_1764.t98 VSS.t1566 VSS.t1565 sg13_lv_nmos ad=1.33p pd=7.38u as=0 ps=0 w=7u l=7u
X2418 VSS.t837 VDD.t1621 VSS.t836 VSS.t835 sg13_lv_nmos ad=0.1428p pd=1.52u as=0 ps=0 w=0.42u l=1u
X2419 VDD.t255 VSS.t687 VDD.t253 VDD.t29 sg13_lv_pmos ad=0.19p pd=1.38u as=0 ps=0 w=1u l=1u
X2420 VSS.t181 a_4437_7532# a_4905_6734# VSS.t180 sg13_lv_nmos ad=0.1665p pd=1.19u as=0.2516p ps=2.16u w=0.74u l=0.13u
X2421 VDD.t1304 a_2595_3892.t2 a_26471_3853# VDD.t9 sg13_lv_pmos ad=0.3808p pd=2.92u as=0.3808p ps=2.92u w=1.12u l=0.13u
X2422 a_25153_14024# a_24957_14024# VDD.t383 VDD.t381 sg13_lv_pmos ad=0.3808p pd=2.92u as=0.2128p ps=1.5u w=1.12u l=0.13u
X2423 VDD.t983 a_19963_1842# a_20397_1842# VDD.t353 sg13_lv_pmos ad=0.2128p pd=1.5u as=0.3808p ps=2.92u w=1.12u l=0.13u
X2424 a_16108_15316# a_20905_15546# a_19550_16071# VDD.t20 sg13_lv_pmos ad=0.3808p pd=2.92u as=0.3808p ps=2.92u w=1.12u l=0.13u
X2425 VSS.t674 VDD.t1677 VSS.t674 VSS.t677 sg13_lv_nmos ad=0.1428p pd=1.52u as=0 ps=0 w=0.42u l=1u
X2426 a_4350_3889# a_5191_3853# a_5115_3889# VDD.t9 sg13_lv_pmos ad=0.3808p pd=2.92u as=0.2128p ps=1.5u w=1.12u l=0.13u
X2427 a_27433_4687# a_27237_4687# VSS.t1756 VSS.t1755 sg13_lv_nmos ad=0.2516p pd=2.16u as=0.1406p ps=1.12u w=0.74u l=0.13u
X2428 VSS.t596 VDD.t1703 VSS.t598 VSS.t597 sg13_lv_nmos ad=79.8f pd=0.8u as=0 ps=0 w=0.42u l=1u
X2429 VDD.t1072 a_2595_6737.t7 a_11271_6698# VDD.t29 sg13_lv_pmos ad=0.3808p pd=2.92u as=0.3808p ps=2.92u w=1.12u l=0.13u
X2430 VDD.t299 VSS.t745 VDD.t297 VDD.t9 sg13_lv_pmos ad=0.19p pd=1.38u as=0 ps=0 w=1u l=1u
X2431 a_9431_16869# a_9193_16869# a_9323_16869# VSS.t57 sg13_lv_nmos ad=0.1406p pd=1.12u as=0.2516p ps=2.16u w=0.74u l=0.2u
X2432 a_4350_1044# a_4324_1008# a_4248_1044# VDD.t0 sg13_lv_pmos ad=0.3808p pd=2.92u as=0.2128p ps=1.5u w=1.12u l=0.13u
X2433 a_12233_7532# a_12037_7532# VSS.t1140 VSS.t2279 sg13_lv_nmos ad=0.2516p pd=2.16u as=0.1406p ps=1.12u w=0.74u l=0.13u
X2434 a_14888_1044# a_14317_1842# VDD.t1076 VDD.t0 sg13_lv_pmos ad=0.2128p pd=1.5u as=0.3808p ps=2.92u w=1.12u l=0.13u
X2435 VSS.t568 a_4187_1764.t32 a_4871_1842# VSS.t567 sg13_lv_nmos ad=0.2516p pd=2.16u as=0.1406p ps=1.12u w=0.74u l=0.6u
X2436 a_19073_4687# a_18877_4687# VDD.t492 VDD.t339 sg13_lv_pmos ad=0.3808p pd=2.92u as=0.2128p ps=1.5u w=1.12u l=0.13u
X2437 VDD.t561 a_16597_4687# a_17065_3889# VDD.t9 sg13_lv_pmos ad=0.252p pd=1.57u as=0.3808p ps=2.92u w=1.12u l=0.13u
X2438 VSS.t585 a_2595_15338.t3 a_8745_15546# VSS.t1056 sg13_lv_nmos ad=0.2516p pd=2.16u as=0.2516p ps=2.16u w=0.74u l=0.13u
X2439 VDD.t1190 a_2019_13229.t9 a_4324_13190# VDD.t36 sg13_lv_pmos ad=0.3808p pd=2.92u as=0.3808p ps=2.92u w=1.12u l=0.13u
X2440 VSS.t209 a_3449_7085# a_3747_6737.t1 VSS.t208 sg13_lv_nmos ad=0.2812p pd=2.24u as=0.1406p ps=1.12u w=0.74u l=0.13u
X2441 VSS.t1408 a_27563_16869# a_27997_16869# VSS.t1477 sg13_lv_nmos ad=0.1406p pd=1.12u as=0.2516p ps=2.16u w=0.74u l=0.13u
X2442 VDD.t352 a_15108_11015# a_15053_11110# VDD.t351 sg13_lv_pmos ad=1.10612p pd=6.66u as=93.45f ps=0.865u w=0.42u l=0.13u
X2443 VSS.t1441 a_3171_6737.t8 a_8884_6698# VSS.t2111 sg13_lv_nmos ad=0.2516p pd=2.16u as=0.2516p ps=2.16u w=0.74u l=0.13u
X2444 VDD.t1513 CHAN0_MUX_SEL4 a_15765_15490# VDD.t20 sg13_lv_pmos ad=0.3808p pd=2.92u as=0.3808p ps=2.92u w=1.12u l=0.13u
X2445 VDD.t1292 a_3747_6737.t8 a_9751_6698# VDD.t29 sg13_lv_pmos ad=0.3808p pd=2.92u as=0.3808p ps=2.92u w=1.12u l=0.13u
X2446 VDD.t349 a_3747_16074.t4 a_21911_16035# VDD.t20 sg13_lv_pmos ad=0.3808p pd=2.92u as=0.3808p ps=2.92u w=1.12u l=0.13u
X2447 a_9953_14024# a_9757_14024# VDD.t518 VDD.t381 sg13_lv_pmos ad=0.3808p pd=2.92u as=0.2128p ps=1.5u w=1.12u l=0.13u
X2448 a_21591_8160# a_21353_7532# a_21483_7532# VDD.t341 sg13_lv_pmos ad=0.2128p pd=1.5u as=0.3808p ps=2.92u w=1.12u l=0.2u
X2449 VSS.t737 VDD.t1652 VSS.t739 VSS.t738 sg13_lv_nmos ad=79.8f pd=0.8u as=0 ps=0 w=0.42u l=1u
X2450 a_27048_13226# a_26477_14024# VSS.t431 VSS.t430 sg13_lv_nmos ad=0.1406p pd=1.12u as=0.2516p ps=2.16u w=0.74u l=0.13u
X2451 VSS.t643 VDD.t1689 VSS.t643 VSS.t647 sg13_lv_nmos ad=0.1428p pd=1.52u as=0 ps=0 w=0.42u l=1u
X2452 a_6153_7532# a_5957_7532# VDD.t1508 VDD.t341 sg13_lv_pmos ad=0.3808p pd=2.92u as=0.2128p ps=1.5u w=1.12u l=0.13u
X2453 a_3543_7085# REF_MUX_SEL0 a_3449_7085# VSS.t1152 sg13_lv_nmos ad=0.1216p pd=1.02u as=0.2176p ps=1.96u w=0.64u l=0.13u
X2454 VSS.t127 a_4187_1764.t61 a_7151_4687# VSS.t2047 sg13_lv_nmos ad=0.2516p pd=2.16u as=0.1406p ps=1.12u w=0.74u l=0.6u
X2455 VDD.t389 a_16163_7532# a_16597_7532# VDD.t341 sg13_lv_pmos ad=0.2128p pd=1.5u as=0.3808p ps=2.92u w=1.12u l=0.13u
X2456 VSS.t281 a_4187_1764.t106 a_23111_14024# VSS.t280 sg13_lv_nmos ad=0.2516p pd=2.16u as=0.1406p ps=1.12u w=0.74u l=0.6u
X2457 a_1256_289# CHAN3_MUX_SEL2 VDD.t1177 VDD.t0 sg13_lv_pmos ad=0.3808p pd=2.92u as=0.3808p ps=2.92u w=1.12u l=0.13u
X2458 VDD.t1115 a_19203_4687# a_19637_4687# VDD.t339 sg13_lv_pmos ad=0.2128p pd=1.5u as=0.3808p ps=2.92u w=1.12u l=0.13u
X2459 a_11711_14652# a_11473_14024# a_11603_14024# VDD.t381 sg13_lv_pmos ad=0.2128p pd=1.5u as=0.3808p ps=2.92u w=1.12u l=0.2u
X2460 a_5731_15316# a_11785_15546# a_10430_16071# VDD.t20 sg13_lv_pmos ad=0.3808p pd=2.92u as=0.3808p ps=2.92u w=1.12u l=0.13u
X2461 VSS.t1209 a_7803_16869# a_8237_16869# VSS.t1387 sg13_lv_nmos ad=0.1406p pd=1.12u as=0.2516p ps=2.16u w=0.74u l=0.13u
X2462 VDD.t1521 a_3747_16074.t9 a_6711_16035# VDD.t20 sg13_lv_pmos ad=0.3808p pd=2.92u as=0.3808p ps=2.92u w=1.12u l=0.13u
X2463 VDD.t846 a_4187_2434# a_12471_14652# VDD.t381 sg13_lv_pmos ad=0.3808p pd=2.92u as=0.2128p ps=1.5u w=1.12u l=0.6u
X2464 a_27915_6734# a_27705_6734# VSS.t1632 VSS.t2215 sg13_lv_nmos ad=0.1406p pd=1.12u as=0.1665p ps=1.19u w=0.74u l=0.13u
X2465 a_16108_289# a_15765_463# a_15964_289# VDD.t0 sg13_lv_pmos ad=0.3808p pd=2.92u as=0.3304p ps=1.71u w=1.12u l=0.13u
X2466 VSS.t953 VSS.t950 VSS.t952 VSS.t951 sg13_lv_nmos ad=0.2516p pd=2.16u as=0 ps=0 w=0.74u l=0.6u
X2467 a_15964_3134# CHAN2_MUX_SEL4 a_5731_3134# VDD.t9 sg13_lv_pmos ad=0.3304p pd=1.71u as=0.3808p ps=2.92u w=1.12u l=0.13u
X2468 a_20831_16869# a_20593_16869# a_20723_16869# VSS.t541 sg13_lv_nmos ad=0.1406p pd=1.12u as=0.2516p ps=2.16u w=0.74u l=0.2u
X2469 VSS.t100 VDD.t1646 VSS.t100 VSS.t751 sg13_lv_nmos ad=0.1428p pd=1.52u as=0 ps=0 w=0.42u l=1u
X2470 VDD.t1485 a_8563_4687# a_8997_4687# VDD.t339 sg13_lv_pmos ad=0.2128p pd=1.5u as=0.3808p ps=2.92u w=1.12u l=0.13u
X2471 VDD.t874 a_4187_2434# a_10191_8160# VDD.t341 sg13_lv_pmos ad=0.3808p pd=2.92u as=0.2128p ps=1.5u w=1.12u l=0.6u
X2472 a_26151_14652# a_25913_14024# a_26043_14024# VDD.t381 sg13_lv_pmos ad=0.2128p pd=1.5u as=0.3808p ps=2.92u w=1.12u l=0.2u
X2473 VDD.t777 a_4187_2434# a_13231_5315# VDD.t339 sg13_lv_pmos ad=0.3808p pd=2.92u as=0.2128p ps=1.5u w=1.12u l=0.6u
X2474 VSS.t984 a_4187_1764.t140 a_21591_16869# VSS.t2363 sg13_lv_nmos ad=0.2516p pd=2.16u as=0.1406p ps=1.12u w=0.74u l=0.6u
X2475 VDD.t674 a_8997_1842# a_9465_1044# VDD.t0 sg13_lv_pmos ad=0.252p pd=1.57u as=0.3808p ps=2.92u w=1.12u l=0.13u
X2476 a_26673_16869# a_26477_16869# VDD.t1579 VDD.t365 sg13_lv_pmos ad=0.3808p pd=2.92u as=0.2128p ps=1.5u w=1.12u l=0.13u
X2477 VSS.t1094 a_4187_1764.t126 a_7911_14024# VSS.t1093 sg13_lv_nmos ad=0.2516p pd=2.16u as=0.1406p ps=1.12u w=0.74u l=0.6u
X2478 VSS.t1816 a_4187_1764.t68 a_26151_7532# VSS.t2390 sg13_lv_nmos ad=0.2516p pd=2.16u as=0.1406p ps=1.12u w=0.74u l=0.6u
X2479 VSS.t570 a_25283_14024# a_25717_14024# VSS.t1623 sg13_lv_nmos ad=0.1406p pd=1.12u as=0.2516p ps=2.16u w=0.74u l=0.13u
X2480 a_11473_1842# a_11277_1842# VDD.t520 VDD.t353 sg13_lv_pmos ad=0.3808p pd=2.92u as=0.2128p ps=1.5u w=1.12u l=0.13u
X2481 VDD.t92 VSS.t730 VDD.t90 VDD.t9 sg13_lv_pmos ad=0.19p pd=1.38u as=0 ps=0 w=1u l=1u
X2482 a_2391_331# CHAN3_MUX_SEL2 a_2297_331# VSS.t1661 sg13_lv_nmos ad=0.1216p pd=1.02u as=0.2176p ps=1.96u w=0.64u l=0.13u
X2483 a_22590_13226# a_3171_13229.t3 a_24008_13226# VSS.t2016 sg13_lv_nmos ad=0.2516p pd=2.16u as=0.1406p ps=1.12u w=0.74u l=0.13u
X2484 VDD.t701 a_19963_7532# a_20397_7532# VDD.t341 sg13_lv_pmos ad=0.2128p pd=1.5u as=0.3808p ps=2.92u w=1.12u l=0.13u
X2485 a_1544_3889# CHAN2_MUX_SEL1 VSS.t122 VSS.t121 sg13_lv_nmos ad=0.2516p pd=2.16u as=0.2516p ps=2.16u w=0.74u l=0.13u
X2486 a_16108_5979# a_3747_6001.t2 a_25630_6734# VSS.t1433 sg13_lv_nmos ad=0.2516p pd=2.16u as=0.2516p ps=2.16u w=0.74u l=0.13u
X2487 VDD.t24 VSS.t600 VDD.t23 VDD.t20 sg13_lv_pmos ad=0.34p pd=2.68u as=0 ps=0 w=1u l=1u
X2488 a_15964_12471# CHAN1_MUX_SEL4 a_5731_12471# VDD.t36 sg13_lv_pmos ad=0.3304p pd=1.71u as=0.3808p ps=2.92u w=1.12u l=0.13u
X2489 a_27433_1842# a_27237_1842# VSS.t385 VSS.t2129 sg13_lv_nmos ad=0.2516p pd=2.16u as=0.1406p ps=1.12u w=0.74u l=0.13u
X2490 VDD.t968 a_23003_4687# a_23437_4687# VDD.t339 sg13_lv_pmos ad=0.2128p pd=1.5u as=0.3808p ps=2.92u w=1.12u l=0.13u
X2491 VSS.t301 a_2595_16074.t2 a_26471_16035# VSS.t300 sg13_lv_nmos ad=0.2516p pd=2.16u as=0.2516p ps=2.16u w=0.74u l=0.13u
X2492 VSS.t448 a_20723_14024# a_21157_14024# VSS.t1824 sg13_lv_nmos ad=0.1406p pd=1.12u as=0.2516p ps=2.16u w=0.74u l=0.13u
X2493 VSS.t189 a_4187_1764.t96 a_4871_7532# VSS.t375 sg13_lv_nmos ad=0.2516p pd=2.16u as=0.1406p ps=1.12u w=0.74u l=0.6u
X2494 a_4157_4158# CHAN2_DELAY_IN VDD.t1110 VDD.t9 sg13_lv_pmos ad=0.3808p pd=2.92u as=0.3808p ps=2.92u w=1.12u l=0.13u
X2495 a_13470_3889# a_3747_3892.t6 a_15755_3889# VSS.t74 sg13_lv_nmos ad=0.2516p pd=2.16u as=0.1406p ps=1.12u w=0.74u l=0.13u
X2496 a_13592_11113# a_13566_11018# VDD.t766 VDD.t351 sg13_lv_pmos ad=0.34p pd=2.68u as=0.36237p ps=2.605u w=1u l=0.13u
X2497 a_2967_331# CHAN3_MUX_SEL3 a_2873_331# VSS.t1646 sg13_lv_nmos ad=0.1216p pd=1.02u as=0.2176p ps=1.96u w=0.64u l=0.13u
X2498 a_18795_3889# a_18585_3889# VDD.t1309 VDD.t9 sg13_lv_pmos ad=0.2128p pd=1.5u as=0.252p ps=1.57u w=1.12u l=0.13u
X2499 a_9675_16071# a_9465_16071# VDD.t1086 VDD.t20 sg13_lv_pmos ad=0.2128p pd=1.5u as=0.252p ps=1.57u w=1.12u l=0.13u
X2500 VDD.t1092 a_2595_3892.t5 a_17351_3853# VDD.t9 sg13_lv_pmos ad=0.3808p pd=2.92u as=0.3808p ps=2.92u w=1.12u l=0.13u
X2501 VSS.t2075 a_3449_4240# a_3747_3892.t1 VSS.t2074 sg13_lv_nmos ad=0.2812p pd=2.24u as=0.1406p ps=1.12u w=0.74u l=0.13u
X2502 a_25630_3889# a_27124_3853# a_27048_3889# VDD.t9 sg13_lv_pmos ad=0.3808p pd=2.92u as=0.2128p ps=1.5u w=1.12u l=0.13u
X2503 VSS.t1737 a_2595_3892.t2 a_26471_3853# VSS.t1900 sg13_lv_nmos ad=0.2516p pd=2.16u as=0.2516p ps=2.16u w=0.74u l=0.13u
X2504 a_18313_4687# a_18117_4687# VSS.t512 VSS.t2169 sg13_lv_nmos ad=0.2516p pd=2.16u as=0.1406p ps=1.12u w=0.74u l=0.13u
X2505 a_5393_16869# a_5197_16869# VSS.t308 VSS.t1306 sg13_lv_nmos ad=0.2516p pd=2.16u as=0.1406p ps=1.12u w=0.74u l=0.13u
X2506 VDD.t511 a_2019_1047.t5 a_16484_1008# VDD.t0 sg13_lv_pmos ad=0.3808p pd=2.92u as=0.3808p ps=2.92u w=1.12u l=0.13u
X2507 a_9431_4687# a_9193_4687# a_9323_4687# VSS.t1020 sg13_lv_nmos ad=0.1406p pd=1.12u as=0.2516p ps=2.16u w=0.74u l=0.2u
X2508 a_4350_3889# a_2595_3892.t9 a_5115_3889# VSS.t1540 sg13_lv_nmos ad=0.2516p pd=2.16u as=0.1406p ps=1.12u w=0.74u l=0.13u
X2509 VSS.t1128 a_2019_16074.t3 a_22564_16035# VSS.t1127 sg13_lv_nmos ad=0.2516p pd=2.16u as=0.2516p ps=2.16u w=0.74u l=0.13u
X2510 a_1544_15316# CHAN0_MUX_SEL3 VDD.t484 VDD.t20 sg13_lv_pmos ad=0.3808p pd=2.92u as=0.3808p ps=2.92u w=1.12u l=0.13u
X2511 a_7390_1044# a_2595_1047.t8 a_8155_1044# VSS.t1702 sg13_lv_nmos ad=0.2516p pd=2.16u as=0.1406p ps=1.12u w=0.74u l=0.13u
X2512 CHAN2_MUX_OUT a_16851_3154# VSS.t508 VSS.t1416 sg13_lv_nmos ad=0.1406p pd=1.12u as=0.1371p ps=1.12u w=0.74u l=0.13u
X2513 a_7390_13226# a_3171_13229.t8 a_8808_13226# VSS.t2008 sg13_lv_nmos ad=0.2516p pd=2.16u as=0.1406p ps=1.12u w=0.74u l=0.13u
X2514 a_1544_5979# REF_MUX_SEL3 VDD.t738 VDD.t29 sg13_lv_pmos ad=0.3808p pd=2.92u as=0.3808p ps=2.92u w=1.12u l=0.13u
X2515 a_7390_16071# a_2019_16074.t8 a_7288_16071# VSS.t444 sg13_lv_nmos ad=0.2516p pd=2.16u as=0.1406p ps=1.12u w=0.74u l=0.13u
X2516 a_4350_3889# a_5844_3853# a_5768_3889# VDD.t9 sg13_lv_pmos ad=0.3808p pd=2.92u as=0.2128p ps=1.5u w=1.12u l=0.13u
X2517 a_16108_3134# a_2595_3156.t2 a_19550_3889# VSS.t1269 sg13_lv_nmos ad=0.2516p pd=2.16u as=0.2516p ps=2.16u w=0.74u l=0.13u
X2518 VSS.t493 a_16597_4687# a_17065_3889# VSS.t492 sg13_lv_nmos ad=0.1665p pd=1.19u as=0.2516p ps=2.16u w=0.74u l=0.13u
X2519 a_3543_4240# CHAN2_MUX_SEL0 a_3449_4240# VSS.t1249 sg13_lv_nmos ad=0.1216p pd=1.02u as=0.2176p ps=1.96u w=0.64u l=0.13u
X2520 a_4350_13226# a_2019_13229.t9 a_4248_13226# VSS.t1679 sg13_lv_nmos ad=0.2516p pd=2.16u as=0.1406p ps=1.12u w=0.74u l=0.13u
X2521 VDD.t281 VSS.t656 VDD.t280 VDD.t36 sg13_lv_pmos ad=0.34p pd=2.68u as=0 ps=0 w=1u l=1u
X2522 VDD.t1209 a_3171_1047.t9 a_5844_1008# VDD.t0 sg13_lv_pmos ad=0.3808p pd=2.92u as=0.3808p ps=2.92u w=1.12u l=0.13u
X2523 VSS.t1324 a_4187_1764.t29 a_7151_1842# VSS.t1359 sg13_lv_nmos ad=0.2516p pd=2.16u as=0.1406p ps=1.12u w=0.74u l=0.6u
X2524 VDD.t53 VSS.t608 VDD.t1202 VDD.t20 sg13_lv_pmos ad=0.34p pd=2.68u as=0 ps=0 w=1u l=1u
X2525 VDD.t943 a_12037_14024# a_12505_13226# VDD.t36 sg13_lv_pmos ad=0.252p pd=1.57u as=0.3808p ps=2.92u w=1.12u l=0.13u
X2526 a_23871_4687# a_23633_4687# a_23763_4687# VSS.t1830 sg13_lv_nmos ad=0.1406p pd=1.12u as=0.2516p ps=2.16u w=0.74u l=0.2u
X2527 a_16510_16071# a_18004_16035# a_17928_16071# VDD.t20 sg13_lv_pmos ad=0.3808p pd=2.92u as=0.2128p ps=1.5u w=1.12u l=0.13u
X2528 a_8433_4687# a_8237_4687# VSS.t1510 VSS.t1509 sg13_lv_nmos ad=0.2516p pd=2.16u as=0.1406p ps=1.12u w=0.74u l=0.13u
X2529 a_5731_12471# a_2595_12493.t3 a_7390_13226# VSS.t2262 sg13_lv_nmos ad=0.2516p pd=2.16u as=0.2516p ps=2.16u w=0.74u l=0.13u
X2530 a_12656_11554# DLL_RESETN VSS.t45 VSS.t44 sg13_lv_nmos ad=0.2516p pd=2.16u as=0.2516p ps=2.16u w=0.74u l=0.13u
X2531 VDD.t1206 a_2595_1047.t7 a_11271_1008# VDD.t0 sg13_lv_pmos ad=0.3808p pd=2.92u as=0.3808p ps=2.92u w=1.12u l=0.13u
X2532 VSS.t303 a_18443_4687# a_18877_4687# VSS.t1518 sg13_lv_nmos ad=0.1406p pd=1.12u as=0.2516p ps=2.16u w=0.74u l=0.13u
X2533 a_15511_5315# a_15273_4687# a_15403_4687# VDD.t339 sg13_lv_pmos ad=0.2128p pd=1.5u as=0.3808p ps=2.92u w=1.12u l=0.2u
X2534 VSS.t1854 a_2595_16074.t5 a_17351_16035# VSS.t1853 sg13_lv_nmos ad=0.2516p pd=2.16u as=0.2516p ps=2.16u w=0.74u l=0.13u
X2535 VDD.t1380 a_3171_13229.t4 a_21044_13190# VDD.t36 sg13_lv_pmos ad=0.3808p pd=2.92u as=0.3808p ps=2.92u w=1.12u l=0.13u
X2536 VSS.t929 VSS.t926 VSS.t928 VSS.t927 sg13_lv_nmos ad=0.2516p pd=2.16u as=0 ps=0 w=0.74u l=0.6u
X2537 a_1544_6734# REF_MUX_SEL1 VDD.t574 VDD.t29 sg13_lv_pmos ad=0.3808p pd=2.92u as=0.3808p ps=2.92u w=1.12u l=0.13u
X2538 a_27671_17497# a_27433_16869# a_27563_16869# VDD.t365 sg13_lv_pmos ad=0.2128p pd=1.5u as=0.3808p ps=2.92u w=1.12u l=0.2u
X2539 VSS.t1895 a_2595_13229.t6 a_14311_13190# VSS.t1894 sg13_lv_nmos ad=0.2516p pd=2.16u as=0.2516p ps=2.16u w=0.74u l=0.13u
X2540 VDD.t791 a_4187_2434# a_25391_2470# VDD.t353 sg13_lv_pmos ad=0.3808p pd=2.92u as=0.2128p ps=1.5u w=1.12u l=0.6u
X2541 a_22113_4687# a_21917_4687# VSS.t139 VSS.t309 sg13_lv_nmos ad=0.2516p pd=2.16u as=0.1406p ps=1.12u w=0.74u l=0.13u
X2542 a_13470_6734# a_15831_6698# a_15755_6734# VDD.t29 sg13_lv_pmos ad=0.3808p pd=2.92u as=0.2128p ps=1.5u w=1.12u l=0.13u
X2543 VDD.t74 VSS.t794 VDD.t72 VDD.t0 sg13_lv_pmos ad=0.19p pd=1.38u as=0 ps=0 w=1u l=1u
X2544 VSS.t29 a_3747_16074.t7 a_12791_16035# VSS.t28 sg13_lv_nmos ad=0.2516p pd=2.16u as=0.2516p ps=2.16u w=0.74u l=0.13u
X2545 VSS.t1676 a_12037_1842# a_12505_1044# VSS.t1675 sg13_lv_nmos ad=0.1665p pd=1.19u as=0.2516p ps=2.16u w=0.74u l=0.13u
X2546 VSS.t620 a_2595_15338.t2 a_20905_15546# VSS.t1058 sg13_lv_nmos ad=0.2516p pd=2.16u as=0.2516p ps=2.16u w=0.74u l=0.13u
X2547 a_26673_14024# a_26477_14024# VDD.t541 VDD.t381 sg13_lv_pmos ad=0.3808p pd=2.92u as=0.2128p ps=1.5u w=1.12u l=0.13u
X2548 a_11473_7532# a_11277_7532# VDD.t426 VDD.t341 sg13_lv_pmos ad=0.3808p pd=2.92u as=0.2128p ps=1.5u w=1.12u l=0.13u
X2549 VDD.t467 a_3747_1047.t8 a_9751_1008# VDD.t0 sg13_lv_pmos ad=0.3808p pd=2.92u as=0.3808p ps=2.92u w=1.12u l=0.13u
X2550 VDD.t1059 a_16851_3154# CHAN2_MUX_OUT VDD.t9 sg13_lv_pmos ad=0.7336p pd=3.55u as=0.2128p ps=1.5u w=1.12u l=0.13u
X2551 VSS.t23 a_4187_1764.t54 a_12471_4687# VSS.t1718 sg13_lv_nmos ad=0.2516p pd=2.16u as=0.1406p ps=1.12u w=0.74u l=0.6u
X2552 VDD.t1534 a_2595_6737.t2 a_26471_6698# VDD.t29 sg13_lv_pmos ad=0.3808p pd=2.92u as=0.3808p ps=2.92u w=1.12u l=0.13u
X2553 a_4350_6734# a_5191_6698# a_5115_6734# VDD.t29 sg13_lv_pmos ad=0.3808p pd=2.92u as=0.2128p ps=1.5u w=1.12u l=0.13u
X2554 a_27433_7532# a_27237_7532# VSS.t474 VSS.t1630 sg13_lv_nmos ad=0.2516p pd=2.16u as=0.1406p ps=1.12u w=0.74u l=0.13u
X2555 VSS.t142 a_10083_16869# a_10517_16869# VSS.t1471 sg13_lv_nmos ad=0.1406p pd=1.12u as=0.2516p ps=2.16u w=0.74u l=0.13u
X2556 VDD.t94 VSS.t638 VDD.t93 VDD.t20 sg13_lv_pmos ad=0.19p pd=1.38u as=0 ps=0 w=1u l=1u
X2557 a_7288_16071# a_6717_16869# VDD.t1037 VDD.t20 sg13_lv_pmos ad=0.2128p pd=1.5u as=0.3808p ps=2.92u w=1.12u l=0.13u
X2558 VDD.t1279 a_3747_13229.t6 a_15831_13190# VDD.t36 sg13_lv_pmos ad=0.3808p pd=2.92u as=0.3808p ps=2.92u w=1.12u l=0.13u
X2559 VSS.t665 VDD.t1680 VSS.t665 VSS.t669 sg13_lv_nmos ad=0.1428p pd=1.52u as=0 ps=0 w=0.42u l=1u
X2560 a_6391_16869# a_6153_16869# a_6283_16869# VSS.t306 sg13_lv_nmos ad=0.1406p pd=1.12u as=0.2516p ps=2.16u w=0.74u l=0.2u
X2561 VSS.t640 VDD.t1692 VSS.t640 VSS.t639 sg13_lv_nmos ad=0.1428p pd=1.52u as=0 ps=0 w=0.42u l=1u
X2562 a_2873_13577# CHAN1_MUX_SEL1 VDD.t433 VDD.t36 sg13_lv_pmos ad=0.1596p pd=1.22u as=0.2856p ps=2.36u w=0.84u l=0.13u
X2563 VDD.t673 a_16597_7532# a_17065_6734# VDD.t29 sg13_lv_pmos ad=0.252p pd=1.57u as=0.3808p ps=2.92u w=1.12u l=0.13u
X2564 VSS.t560 a_22243_4687# a_22677_4687# VSS.t1307 sg13_lv_nmos ad=0.1406p pd=1.12u as=0.2516p ps=2.16u w=0.74u l=0.13u
X2565 VDD.t1538 a_3171_12493.t2 a_23945_12701# VDD.t36 sg13_lv_pmos ad=0.3808p pd=2.92u as=0.3808p ps=2.92u w=1.12u l=0.13u
X2566 a_17275_13226# a_17065_13226# VSS.t2177 VSS.t2347 sg13_lv_nmos ad=0.1406p pd=1.12u as=0.1665p ps=1.19u w=0.74u l=0.13u
X2567 VSS.t1211 a_4187_1764.t159 a_7151_16869# VSS.t1210 sg13_lv_nmos ad=0.2516p pd=2.16u as=0.1406p ps=1.12u w=0.74u l=0.6u
X2568 a_1544_13226# CHAN1_MUX_SEL1 VDD.t432 VDD.t36 sg13_lv_pmos ad=0.3808p pd=2.92u as=0.3808p ps=2.92u w=1.12u l=0.13u
X2569 VSS.t1144 a_24523_16869# a_24957_16869# VSS.t1831 sg13_lv_nmos ad=0.1406p pd=1.12u as=0.2516p ps=2.16u w=0.74u l=0.13u
X2570 VDD.t1203 a_2595_16074.t3 a_23431_16035# VDD.t20 sg13_lv_pmos ad=0.3808p pd=2.92u as=0.3808p ps=2.92u w=1.12u l=0.13u
X2571 VSS.t252 a_2019_15338.t3 a_5705_15546# VSS.t251 sg13_lv_nmos ad=0.2516p pd=2.16u as=0.2516p ps=2.16u w=0.74u l=0.13u
X2572 a_18313_1842# a_18117_1842# VSS.t1461 VSS.t1984 sg13_lv_nmos ad=0.2516p pd=2.16u as=0.1406p ps=1.12u w=0.74u l=0.13u
X2573 VDD.t362 a_13883_4687# a_14317_4687# VDD.t339 sg13_lv_pmos ad=0.2128p pd=1.5u as=0.3808p ps=2.92u w=1.12u l=0.13u
X2574 CHAN3_MUX_OUT a_16851_309# VSS.t321 VSS.t2275 sg13_lv_nmos ad=0.1406p pd=1.12u as=0.1371p ps=1.12u w=0.74u l=0.13u
X2575 a_9431_1842# a_9193_1842# a_9323_1842# VSS.t229 sg13_lv_nmos ad=0.1406p pd=1.12u as=0.2516p ps=2.16u w=0.74u l=0.2u
X2576 a_7390_6734# a_2595_6737.t8 a_8155_6734# VSS.t1439 sg13_lv_nmos ad=0.2516p pd=2.16u as=0.1406p ps=1.12u w=0.74u l=0.13u
X2577 a_7390_16071# a_8231_16035# a_8155_16071# VDD.t20 sg13_lv_pmos ad=0.3808p pd=2.92u as=0.2128p ps=1.5u w=1.12u l=0.13u
X2578 VSS.t581 VDD.t1707 VSS.t581 VSS.t582 sg13_lv_nmos ad=79.8f pd=0.8u as=0 ps=0 w=0.42u l=1u
X2579 a_27048_16071# a_26477_16869# VSS.t301 VSS.t2314 sg13_lv_nmos ad=0.1406p pd=1.12u as=0.2516p ps=2.16u w=0.74u l=0.13u
X2580 a_18795_3889# a_18585_3889# VSS.t1912 VSS.t1911 sg13_lv_nmos ad=0.1406p pd=1.12u as=0.1665p ps=1.19u w=0.74u l=0.13u
X2581 VSS.t963 a_6126_9506# a_5974_11413# VSS.t959 sg13_lv_nmos ad=0.68p pd=4.68u as=0.38p ps=2.38u w=2u l=1u
X2582 VSS.t829 VDD.t1623 VSS.t829 VSS.t830 sg13_lv_nmos ad=79.8f pd=0.8u as=0 ps=0 w=0.42u l=1u
X2583 a_1544_3134# CHAN2_MUX_SEL3 VDD.t1149 VDD.t9 sg13_lv_pmos ad=0.3808p pd=2.92u as=0.3808p ps=2.92u w=1.12u l=0.13u
X2584 VDD.t818 a_4187_2434# a_19311_17497# VDD.t365 sg13_lv_pmos ad=0.3808p pd=2.92u as=0.2128p ps=1.5u w=1.12u l=0.6u
X2585 VSS.t2024 a_1544_13226# a_2391_13577# VSS.t2067 sg13_lv_nmos ad=0.1331p pd=1.12u as=0.1216p ps=1.02u w=0.64u l=0.13u
X2586 VSS.t296 a_4187_1764.t93 a_7151_7532# VSS.t1727 sg13_lv_nmos ad=0.2516p pd=2.16u as=0.1406p ps=1.12u w=0.74u l=0.6u
X2587 VDD.t259 VSS.t680 VDD.t257 VDD.t36 sg13_lv_pmos ad=0.19p pd=1.38u as=0 ps=0 w=1u l=1u
X2588 VSS.t1480 a_2595_3892.t5 a_17351_3853# VSS.t1479 sg13_lv_nmos ad=0.2516p pd=2.16u as=0.2516p ps=2.16u w=0.74u l=0.13u
X2589 a_25630_3889# a_3171_3892.t2 a_27048_3889# VSS.t1735 sg13_lv_nmos ad=0.2516p pd=2.16u as=0.1406p ps=1.12u w=0.74u l=0.13u
X2590 VSS.t529 a_4187_1764.t110 a_20071_14024# VSS.t2147 sg13_lv_nmos ad=0.2516p pd=2.16u as=0.1406p ps=1.12u w=0.74u l=0.6u
X2591 VDD.t1539 a_2595_12493.t3 a_8745_12701# VDD.t36 sg13_lv_pmos ad=0.3808p pd=2.92u as=0.3808p ps=2.92u w=1.12u l=0.13u
X2592 VDD.t352 a_14009_11568# a_14111_11568# VDD.t351 sg13_lv_pmos ad=1.10612p pd=6.66u as=0.3864p ps=2.93u w=1.12u l=0.13u
X2593 a_23871_1842# a_23633_1842# a_23763_1842# VSS.t2103 sg13_lv_nmos ad=0.1406p pd=1.12u as=0.2516p ps=2.16u w=0.74u l=0.2u
X2594 VSS.t462 VDD.t1675 VSS.t680 VSS.t682 sg13_lv_nmos ad=0.1428p pd=1.52u as=0 ps=0 w=0.42u l=1u
X2595 VDD.t1146 a_4003_4687# a_4437_4687# VDD.t339 sg13_lv_pmos ad=0.2128p pd=1.5u as=0.3808p ps=2.92u w=1.12u l=0.13u
X2596 a_8433_1842# a_8237_1842# VSS.t228 VSS.t1655 sg13_lv_nmos ad=0.2516p pd=2.16u as=0.1406p ps=1.12u w=0.74u l=0.13u
X2597 VSS.t1394 a_9323_16869# a_9757_16869# VSS.t1393 sg13_lv_nmos ad=0.1406p pd=1.12u as=0.2516p ps=2.16u w=0.74u l=0.13u
X2598 VSS.t802 VDD.t1630 VSS.t804 VSS.t803 sg13_lv_nmos ad=79.8f pd=0.8u as=0 ps=0 w=0.42u l=1u
X2599 VSS.t104 a_18443_1842# a_18877_1842# VSS.t237 sg13_lv_nmos ad=0.1406p pd=1.12u as=0.2516p ps=2.16u w=0.74u l=0.13u
X2600 a_1544_289# CHAN3_MUX_SEL3 VDD.t1167 VDD.t0 sg13_lv_pmos ad=0.3808p pd=2.92u as=0.3808p ps=2.92u w=1.12u l=0.13u
X2601 a_5731_3134# a_3171_3156.t3 a_10430_3889# VSS.t1187 sg13_lv_nmos ad=0.2516p pd=2.16u as=0.2516p ps=2.16u w=0.74u l=0.13u
X2602 a_26395_16071# a_26185_16071# VDD.t1003 VDD.t20 sg13_lv_pmos ad=0.2128p pd=1.5u as=0.252p ps=1.57u w=1.12u l=0.13u
X2603 VDD.t890 a_4187_2434# a_25391_8160# VDD.t341 sg13_lv_pmos ad=0.3808p pd=2.92u as=0.2128p ps=1.5u w=1.12u l=0.6u
X2604 a_27671_14652# a_27433_14024# a_27563_14024# VDD.t381 sg13_lv_pmos ad=0.2128p pd=1.5u as=0.3808p ps=2.92u w=1.12u l=0.2u
X2605 a_4350_3889# a_3171_3892.t9 a_5768_3889# VSS.t1733 sg13_lv_nmos ad=0.2516p pd=2.16u as=0.1406p ps=1.12u w=0.74u l=0.13u
X2606 a_22113_1842# a_21917_1842# VSS.t2058 VSS.t2061 sg13_lv_nmos ad=0.2516p pd=2.16u as=0.1406p ps=1.12u w=0.74u l=0.13u
X2607 a_10328_1044# a_9757_1842# VSS.t1966 VSS.t1965 sg13_lv_nmos ad=0.1406p pd=1.12u as=0.2516p ps=2.16u w=0.74u l=0.13u
X2608 a_22113_16869# a_21917_16869# VSS.t984 VSS.t983 sg13_lv_nmos ad=0.2516p pd=2.16u as=0.1406p ps=1.12u w=0.74u l=0.13u
X2609 VSS.t643 VDD.t1690 VSS.t643 VSS.t646 sg13_lv_nmos ad=79.8f pd=0.8u as=0 ps=0 w=0.42u l=1u
X2610 VSS.t205 a_12037_7532# a_12505_6734# VSS.t2278 sg13_lv_nmos ad=0.1665p pd=1.19u as=0.2516p ps=2.16u w=0.74u l=0.13u
X2611 a_26673_1842# a_26477_1842# VDD.t1437 VDD.t353 sg13_lv_pmos ad=0.3808p pd=2.92u as=0.2128p ps=1.5u w=1.12u l=0.13u
X2612 VDD.t1306 a_2019_3892.t8 a_7364_3853# VDD.t9 sg13_lv_pmos ad=0.3808p pd=2.92u as=0.3808p ps=2.92u w=1.12u l=0.13u
X2613 VDD.t632 VDD.t633 VDD.t634 VDD.t360 sg13_lv_pmos ad=0.2128p pd=1.5u as=0 ps=0 w=1.12u l=0.13u
X2614 VSS.t806 VDD.t1629 VSS.t806 VSS.t805 sg13_lv_nmos ad=0.1428p pd=1.52u as=0 ps=0 w=0.42u l=1u
X2615 a_22590_1044# a_2019_1047.t3 a_22488_1044# VSS.t364 sg13_lv_nmos ad=0.2516p pd=2.16u as=0.1406p ps=1.12u w=0.74u l=0.13u
X2616 a_26151_4687# a_25913_4687# a_26043_4687# VSS.t2141 sg13_lv_nmos ad=0.1406p pd=1.12u as=0.2516p ps=2.16u w=0.74u l=0.2u
X2617 a_23633_16869# a_23437_16869# VDD.t376 VDD.t365 sg13_lv_pmos ad=0.3808p pd=2.92u as=0.2128p ps=1.5u w=1.12u l=0.13u
X2618 a_22590_16071# a_3171_16074.t3 a_24008_16071# VSS.t314 sg13_lv_nmos ad=0.2516p pd=2.16u as=0.1406p ps=1.12u w=0.74u l=0.13u
X2619 VSS.t1120 a_4187_1764.t130 a_4871_14024# VSS.t1119 sg13_lv_nmos ad=0.2516p pd=2.16u as=0.1406p ps=1.12u w=0.74u l=0.6u
X2620 VSS.t283 a_22243_14024# a_22677_14024# VSS.t1561 sg13_lv_nmos ad=0.1406p pd=1.12u as=0.2516p ps=2.16u w=0.74u l=0.13u
X2621 a_6126_9506# a_6326_10280# VDD.t444 VDD.t351 sg13_lv_pmos ad=0.38p pd=2.38u as=0.38p ps=2.38u w=2u l=1u
X2622 VSS.t1501 a_4187_1764.t22 a_12471_1842# VSS.t2248 sg13_lv_nmos ad=0.2516p pd=2.16u as=0.1406p ps=1.12u w=0.74u l=0.6u
X2623 VDD.t1469 a_16923_16869# a_17357_16869# VDD.t365 sg13_lv_pmos ad=0.2128p pd=1.5u as=0.3808p ps=2.92u w=1.12u l=0.13u
X2624 a_15964_15316# CHAN0_MUX_SEL4 a_5731_15316# VDD.t20 sg13_lv_pmos ad=0.3304p pd=1.71u as=0.3808p ps=2.92u w=1.12u l=0.13u
X2625 a_19550_13226# a_3171_13229.t4 a_20968_13226# VSS.t2012 sg13_lv_nmos ad=0.2516p pd=2.16u as=0.1406p ps=1.12u w=0.74u l=0.13u
X2626 VSS.t396 a_3171_6001.t2 a_23945_6209# VSS.t395 sg13_lv_nmos ad=0.2516p pd=2.16u as=0.2516p ps=2.16u w=0.74u l=0.13u
X2627 VDD.t307 VSS.t589 VDD.t306 VDD.t20 sg13_lv_pmos ad=0.34p pd=2.68u as=0 ps=0 w=1u l=1u
X2628 a_8808_1044# a_8237_1842# VSS.t336 VSS.t1656 sg13_lv_nmos ad=0.1406p pd=1.12u as=0.2516p ps=2.16u w=0.74u l=0.13u
X2629 a_13753_4687# a_13557_4687# VSS.t498 VSS.t1797 sg13_lv_nmos ad=0.2516p pd=2.16u as=0.1406p ps=1.12u w=0.74u l=0.13u
X2630 a_13592_11561# a_13566_11525# VSS.t872 VSS.t1773 sg13_lv_nmos ad=0.2516p pd=2.16u as=0.1626p ps=1.415u w=0.74u l=0.13u
X2631 a_5778_9057# a_6126_9506# a_6326_10280# VSS.t956 sg13_lv_nmos ad=0.68p pd=4.68u as=0.38p ps=2.38u w=2u l=1u
X2632 a_18795_6734# a_18585_6734# VDD.t744 VDD.t29 sg13_lv_pmos ad=0.2128p pd=1.5u as=0.252p ps=1.57u w=1.12u l=0.13u
X2633 a_4871_4687# a_4633_4687# a_4763_4687# VSS.t1603 sg13_lv_nmos ad=0.1406p pd=1.12u as=0.2516p ps=2.16u w=0.74u l=0.2u
X2634 VSS.t2054 a_22243_1842# a_22677_1842# VSS.t2053 sg13_lv_nmos ad=0.1406p pd=1.12u as=0.2516p ps=2.16u w=0.74u l=0.13u
X2635 a_6913_16869# a_6717_16869# VSS.t218 VSS.t1386 sg13_lv_nmos ad=0.2516p pd=2.16u as=0.1406p ps=1.12u w=0.74u l=0.13u
X2636 a_15270_11995# a_12849_11557# VSS.t267 VSS.t266 sg13_lv_nmos ad=37.8f pd=0.6u as=79.8f ps=0.8u w=0.42u l=0.13u
X2637 VDD.t1070 a_2595_6737.t5 a_17351_6698# VDD.t29 sg13_lv_pmos ad=0.3808p pd=2.92u as=0.3808p ps=2.92u w=1.12u l=0.13u
X2638 a_6635_16071# a_6425_16071# VDD.t1036 VDD.t20 sg13_lv_pmos ad=0.2128p pd=1.5u as=0.252p ps=1.57u w=1.12u l=0.13u
X2639 a_25630_6734# a_27124_6698# a_27048_6734# VDD.t29 sg13_lv_pmos ad=0.3808p pd=2.92u as=0.2128p ps=1.5u w=1.12u l=0.13u
X2640 a_18313_7532# a_18117_7532# VSS.t165 VSS.t2201 sg13_lv_nmos ad=0.2516p pd=2.16u as=0.1406p ps=1.12u w=0.74u l=0.13u
X2641 a_9431_7532# a_9193_7532# a_9323_7532# VSS.t849 sg13_lv_nmos ad=0.1406p pd=1.12u as=0.2516p ps=2.16u w=0.74u l=0.2u
X2642 VDD.t913 a_4187_2434# a_6391_2470# VDD.t353 sg13_lv_pmos ad=0.3808p pd=2.92u as=0.2128p ps=1.5u w=1.12u l=0.6u
X2643 a_1544_1044# CHAN3_MUX_SEL1 VDD.t1463 VDD.t0 sg13_lv_pmos ad=0.3808p pd=2.92u as=0.3808p ps=2.92u w=1.12u l=0.13u
X2644 a_7390_16071# a_3171_16074.t8 a_8808_16071# VSS.t400 sg13_lv_nmos ad=0.2516p pd=2.16u as=0.1406p ps=1.12u w=0.74u l=0.13u
X2645 VDD.t1197 a_2595_13229.t2 a_26471_13190# VDD.t36 sg13_lv_pmos ad=0.3808p pd=2.92u as=0.3808p ps=2.92u w=1.12u l=0.13u
X2646 a_13470_1044# a_15831_1008# a_15755_1044# VDD.t0 sg13_lv_pmos ad=0.3808p pd=2.92u as=0.2128p ps=1.5u w=1.12u l=0.13u
X2647 a_22488_3889# a_21917_4687# VDD.t496 VDD.t9 sg13_lv_pmos ad=0.2128p pd=1.5u as=0.3808p ps=2.92u w=1.12u l=0.13u
X2648 a_10520_11982# a_10232_11561# a_10458_11982# VSS.t393 sg13_lv_nmos ad=0.1428p pd=1.52u as=37.8f ps=0.6u w=0.42u l=0.13u
X2649 a_16108_3134# CHAN2_MUX_SEL4 a_15964_3134# VSS.t969 sg13_lv_nmos ad=0.2516p pd=2.16u as=0.2183p ps=1.33u w=0.74u l=0.13u
X2650 a_4350_13226# a_3171_13229.t9 a_5768_13226# VSS.t1688 sg13_lv_nmos ad=0.2516p pd=2.16u as=0.1406p ps=1.12u w=0.74u l=0.13u
X2651 VSS.t1174 a_2873_12513# a_3171_12493.t1 VSS.t1292 sg13_lv_nmos ad=0.2812p pd=2.24u as=0.1406p ps=1.12u w=0.74u l=0.13u
X2652 a_4350_6734# a_5844_6698# a_5768_6734# VDD.t29 sg13_lv_pmos ad=0.3808p pd=2.92u as=0.2128p ps=1.5u w=1.12u l=0.13u
X2653 a_4350_16071# a_2019_16074.t9 a_4248_16071# VSS.t1327 sg13_lv_nmos ad=0.2516p pd=2.16u as=0.1406p ps=1.12u w=0.74u l=0.13u
X2654 VDD.t860 a_4187_2434# a_19311_14652# VDD.t381 sg13_lv_pmos ad=0.3808p pd=2.92u as=0.2128p ps=1.5u w=1.12u l=0.6u
X2655 a_10951_5315# a_10713_4687# a_10843_4687# VDD.t339 sg13_lv_pmos ad=0.2128p pd=1.5u as=0.3808p ps=2.92u w=1.12u l=0.2u
X2656 a_19550_16071# a_19524_16035# a_19448_16071# VDD.t20 sg13_lv_pmos ad=0.3808p pd=2.92u as=0.2128p ps=1.5u w=1.12u l=0.13u
X2657 VSS.t220 a_24523_4687# a_24957_4687# VSS.t219 sg13_lv_nmos ad=0.1406p pd=1.12u as=0.2516p ps=2.16u w=0.74u l=0.13u
X2658 a_23871_7532# a_23633_7532# a_23763_7532# VSS.t193 sg13_lv_nmos ad=0.1406p pd=1.12u as=0.2516p ps=2.16u w=0.74u l=0.2u
X2659 VDD.t795 a_4187_2434# a_20831_2470# VDD.t353 sg13_lv_pmos ad=0.3808p pd=2.92u as=0.2128p ps=1.5u w=1.12u l=0.6u
X2660 a_14513_16869# a_14317_16869# VDD.t934 VDD.t365 sg13_lv_pmos ad=0.3808p pd=2.92u as=0.2128p ps=1.5u w=1.12u l=0.13u
X2661 a_8433_7532# a_8237_7532# VSS.t1202 VSS.t2294 sg13_lv_nmos ad=0.2516p pd=2.16u as=0.1406p ps=1.12u w=0.74u l=0.13u
X2662 VDD.t1295 a_2595_1047.t2 a_26471_1008# VDD.t0 sg13_lv_pmos ad=0.3808p pd=2.92u as=0.3808p ps=2.92u w=1.12u l=0.13u
X2663 a_4350_1044# a_5191_1008# a_5115_1044# VDD.t0 sg13_lv_pmos ad=0.3808p pd=2.92u as=0.2128p ps=1.5u w=1.12u l=0.13u
X2664 VDD.t409 a_2019_13229.t3 a_22564_13190# VDD.t36 sg13_lv_pmos ad=0.3808p pd=2.92u as=0.3808p ps=2.92u w=1.12u l=0.13u
X2665 a_23111_16869# a_22873_16869# a_23003_16869# VSS.t2230 sg13_lv_nmos ad=0.1406p pd=1.12u as=0.2516p ps=2.16u w=0.74u l=0.2u
X2666 VSS.t1142 a_18443_7532# a_18877_7532# VSS.t1141 sg13_lv_nmos ad=0.1406p pd=1.12u as=0.2516p ps=2.16u w=0.74u l=0.13u
X2667 VSS.t760 VDD.t1642 VSS.t760 VSS.t761 sg13_lv_nmos ad=0.1428p pd=1.52u as=0 ps=0 w=0.42u l=1u
X2668 a_9431_14024# a_9193_14024# a_9323_14024# VSS.t224 sg13_lv_nmos ad=0.1406p pd=1.12u as=0.2516p ps=2.16u w=0.74u l=0.2u
X2669 a_5731_12471# a_2019_12493.t3 a_4350_13226# VSS.t1649 sg13_lv_nmos ad=0.2516p pd=2.16u as=0.2516p ps=2.16u w=0.74u l=0.13u
X2670 VSS.t961 a_6126_9506# a_5974_11413# VSS.t959 sg13_lv_nmos ad=0.68p pd=4.68u as=0.38p ps=2.38u w=2u l=1u
X2671 VSS.t100 VDD.t1644 VSS.t100 VSS.t756 sg13_lv_nmos ad=79.8f pd=0.8u as=0 ps=0 w=0.42u l=1u
X2672 REF_MUX_OUT a_16851_5999# VDD.t355 VDD.t29 sg13_lv_pmos ad=0.2128p pd=1.5u as=0.2086p ps=1.5u w=1.12u l=0.13u
X2673 a_1256_5979# REF_MUX_SEL2 VSS.t170 VSS.t169 sg13_lv_nmos ad=0.2516p pd=2.16u as=0.2516p ps=2.16u w=0.74u l=0.13u
X2674 VSS.t325 a_2595_16074.t6 a_14311_16035# VSS.t324 sg13_lv_nmos ad=0.2516p pd=2.16u as=0.2516p ps=2.16u w=0.74u l=0.13u
X2675 VSS.t702 VDD.t1666 VSS.t702 VSS.t704 sg13_lv_nmos ad=0.1428p pd=1.52u as=0 ps=0 w=0.42u l=1u
X2676 VSS.t2046 a_1256_13226# a_2967_13577# VSS.t2045 sg13_lv_nmos ad=0.1331p pd=1.12u as=0.1216p ps=1.02u w=0.64u l=0.13u
X2677 a_7390_13226# a_7364_13190# a_7288_13226# VDD.t36 sg13_lv_pmos ad=0.3808p pd=2.92u as=0.2128p ps=1.5u w=1.12u l=0.13u
X2678 a_22113_7532# a_21917_7532# VSS.t14 VSS.t13 sg13_lv_nmos ad=0.2516p pd=2.16u as=0.1406p ps=1.12u w=0.74u l=0.13u
X2679 VSS.t1159 a_27237_1842# a_27705_1044# VSS.t2130 sg13_lv_nmos ad=0.1665p pd=1.19u as=0.2516p ps=2.16u w=0.74u l=0.13u
X2680 VDD.t1140 a_16597_1842# a_17065_1044# VDD.t0 sg13_lv_pmos ad=0.252p pd=1.57u as=0.3808p ps=2.92u w=1.12u l=0.13u
X2681 VSS.t1222 a_2595_13229.t7 a_11271_13190# VSS.t1685 sg13_lv_nmos ad=0.2516p pd=2.16u as=0.2516p ps=2.16u w=0.74u l=0.13u
X2682 a_10328_6734# a_9757_7532# VSS.t1133 VSS.t1132 sg13_lv_nmos ad=0.1406p pd=1.12u as=0.2516p ps=2.16u w=0.74u l=0.13u
X2683 VSS.t745 a_3171_3156.t3 a_11785_3364# VSS.t1188 sg13_lv_nmos ad=0.2516p pd=2.16u as=0.2516p ps=2.16u w=0.74u l=0.13u
X2684 a_2595_1047.t1 a_2297_1395# VSS.t1782 VSS.t1274 sg13_lv_nmos ad=0.1406p pd=1.12u as=0.1331p ps=1.12u w=0.74u l=0.13u
X2685 VSS.t1959 a_27563_14024# a_27997_14024# VSS.t2233 sg13_lv_nmos ad=0.1406p pd=1.12u as=0.2516p ps=2.16u w=0.74u l=0.13u
X2686 a_26673_7532# a_26477_7532# VDD.t1266 VDD.t341 sg13_lv_pmos ad=0.3808p pd=2.92u as=0.2128p ps=1.5u w=1.12u l=0.13u
X2687 a_10191_2470# a_9953_1842# a_10083_1842# VDD.t353 sg13_lv_pmos ad=0.2128p pd=1.5u as=0.3808p ps=2.92u w=1.12u l=0.2u
X2688 VSS.t2366 a_4187_1764.t34 a_27671_4687# VSS.t2365 sg13_lv_nmos ad=0.2516p pd=2.16u as=0.1406p ps=1.12u w=0.74u l=0.6u
X2689 VDD.t485 CHAN0_MUX_SEL3 a_3449_15358# VDD.t20 sg13_lv_pmos ad=0.1918p pd=1.5u as=0.1596p ps=1.22u w=0.84u l=0.13u
X2690 VSS.t1247 a_2019_311# a_17865_519# VSS.t1246 sg13_lv_nmos ad=0.2516p pd=2.16u as=0.2516p ps=2.16u w=0.74u l=0.13u
X2691 a_22590_6734# a_2019_6737.t3 a_22488_6734# VSS.t1750 sg13_lv_nmos ad=0.2516p pd=2.16u as=0.1406p ps=1.12u w=0.74u l=0.13u
X2692 a_26151_1842# a_25913_1842# a_26043_1842# VSS.t2101 sg13_lv_nmos ad=0.1406p pd=1.12u as=0.2516p ps=2.16u w=0.74u l=0.2u
X2693 a_23633_14024# a_23437_14024# VDD.t1068 VDD.t381 sg13_lv_pmos ad=0.3808p pd=2.92u as=0.2128p ps=1.5u w=1.12u l=0.13u
X2694 VSS.t435 a_1544_289# a_2391_331# VSS.t2289 sg13_lv_nmos ad=0.1331p pd=1.12u as=0.1216p ps=1.02u w=0.64u l=0.13u
X2695 VSS.t109 a_4187_1764.t86 a_12471_7532# VSS.t108 sg13_lv_nmos ad=0.2516p pd=2.16u as=0.1406p ps=1.12u w=0.74u l=0.6u
X2696 a_8808_16071# a_8237_16869# VDD.t1041 VDD.t20 sg13_lv_pmos ad=0.2128p pd=1.5u as=0.3808p ps=2.92u w=1.12u l=0.13u
X2697 VDD.t697 a_16923_14024# a_17357_14024# VDD.t381 sg13_lv_pmos ad=0.2128p pd=1.5u as=0.3808p ps=2.92u w=1.12u l=0.13u
X2698 VDD.t465 a_2595_13229.t5 a_17351_13190# VDD.t36 sg13_lv_pmos ad=0.3808p pd=2.92u as=0.3808p ps=2.92u w=1.12u l=0.13u
X2699 a_6326_10280# a_6126_9506# a_5778_9057# VSS.t956 sg13_lv_nmos ad=0.42p pd=2.42u as=0.68p ps=4.68u w=2u l=1u
X2700 VDD.t799 a_4187_2434# a_19311_5315# VDD.t339 sg13_lv_pmos ad=0.3808p pd=2.92u as=0.2128p ps=1.5u w=1.12u l=0.6u
X2701 a_7911_16869# a_7673_16869# a_7803_16869# VSS.t1829 sg13_lv_nmos ad=0.1406p pd=1.12u as=0.2516p ps=2.16u w=0.74u l=0.2u
X2702 a_8808_6734# a_8237_7532# VSS.t1441 VSS.t2293 sg13_lv_nmos ad=0.1406p pd=1.12u as=0.2516p ps=2.16u w=0.74u l=0.13u
X2703 VDD.t429 a_3449_6021# a_3747_6001.t0 VDD.t29 sg13_lv_pmos ad=0.4256p pd=3u as=0.2128p ps=1.5u w=1.12u l=0.13u
X2704 VDD.t96 VSS.t626 VDD.t95 VDD.t20 sg13_lv_pmos ad=0.19p pd=1.38u as=0 ps=0 w=1u l=1u
X2705 a_18795_13226# a_18585_13226# VSS.t1420 VSS.t2086 sg13_lv_nmos ad=0.1406p pd=1.12u as=0.1665p ps=1.19u w=0.74u l=0.13u
X2706 a_13753_1842# a_13557_1842# VSS.t1455 VSS.t1678 sg13_lv_nmos ad=0.2516p pd=2.16u as=0.1406p ps=1.12u w=0.74u l=0.13u
X2707 a_4248_16071# a_4157_16340# VDD.t1351 VDD.t20 sg13_lv_pmos ad=0.2128p pd=1.5u as=0.3808p ps=2.92u w=1.12u l=0.13u
X2708 VDD.t1195 a_3747_13229.t7 a_12791_13190# VDD.t36 sg13_lv_pmos ad=0.3808p pd=2.92u as=0.3808p ps=2.92u w=1.12u l=0.13u
X2709 VSS.t1251 a_22243_7532# a_22677_7532# VSS.t2331 sg13_lv_nmos ad=0.1406p pd=1.12u as=0.2516p ps=2.16u w=0.74u l=0.13u
X2710 a_1815_1395# a_1256_1044# a_1721_1395# VSS.t1011 sg13_lv_nmos ad=0.1216p pd=1.02u as=0.2176p ps=1.96u w=0.64u l=0.13u
X2711 a_4871_1842# a_4633_1842# a_4763_1842# VSS.t1552 sg13_lv_nmos ad=0.1406p pd=1.12u as=0.2516p ps=2.16u w=0.74u l=0.2u
X2712 VSS.t1399 a_4187_1764.t157 a_8671_16869# VSS.t2385 sg13_lv_nmos ad=0.2516p pd=2.16u as=0.1406p ps=1.12u w=0.74u l=0.6u
X2713 VSS.t1725 a_26043_16869# a_26477_16869# VSS.t2312 sg13_lv_nmos ad=0.1406p pd=1.12u as=0.2516p ps=2.16u w=0.74u l=0.13u
X2714 VDD.t395 a_3171_15338.t2 a_23945_15546# VDD.t20 sg13_lv_pmos ad=0.3808p pd=2.92u as=0.3808p ps=2.92u w=1.12u l=0.13u
X2715 a_17275_16071# a_17065_16071# VSS.t2030 VSS.t2029 sg13_lv_nmos ad=0.1406p pd=1.12u as=0.1665p ps=1.19u w=0.74u l=0.13u
X2716 VSS.t64 a_2019_3892.t8 a_7364_3853# VSS.t1905 sg13_lv_nmos ad=0.2516p pd=2.16u as=0.2516p ps=2.16u w=0.74u l=0.13u
X2717 VDD.t1540 a_2595_12493.t2 a_20905_12701# VDD.t36 sg13_lv_pmos ad=0.3808p pd=2.92u as=0.3808p ps=2.92u w=1.12u l=0.13u
X2718 a_14235_13226# a_14025_13226# VSS.t1321 VSS.t2334 sg13_lv_nmos ad=0.1406p pd=1.12u as=0.1665p ps=1.19u w=0.74u l=0.13u
X2719 a_2391_3176# CHAN2_MUX_SEL2 a_2297_3176# VSS.t1597 sg13_lv_nmos ad=0.1216p pd=1.02u as=0.2176p ps=1.96u w=0.64u l=0.13u
X2720 a_7390_16071# a_9751_16035# a_9675_16071# VDD.t20 sg13_lv_pmos ad=0.3808p pd=2.92u as=0.2128p ps=1.5u w=1.12u l=0.13u
X2721 VDD.t787 a_4187_2434# a_6391_8160# VDD.t341 sg13_lv_pmos ad=0.3808p pd=2.92u as=0.2128p ps=1.5u w=1.12u l=0.6u
X2722 VDD.t721 a_2595_16074.t4 a_20391_16035# VDD.t20 sg13_lv_pmos ad=0.3808p pd=2.92u as=0.3808p ps=2.92u w=1.12u l=0.13u
X2723 a_13470_3889# a_13444_3853# a_13368_3889# VDD.t9 sg13_lv_pmos ad=0.3808p pd=2.92u as=0.2128p ps=1.5u w=1.12u l=0.13u
X2724 VSS.t1094 a_7803_14024# a_8237_14024# VSS.t1941 sg13_lv_nmos ad=0.1406p pd=1.12u as=0.2516p ps=2.16u w=0.74u l=0.13u
X2725 a_2019_13229.t1 a_1721_13577# VSS.t2065 VSS.t2064 sg13_lv_nmos ad=0.1406p pd=1.12u as=0.1331p ps=1.12u w=0.74u l=0.13u
X2726 VSS.t1215 a_1544_3134# a_1815_3176# VSS.t1800 sg13_lv_nmos ad=0.1331p pd=1.12u as=0.1216p ps=1.02u w=0.64u l=0.13u
X2727 VDD.t894 a_4187_2434# a_9431_5315# VDD.t339 sg13_lv_pmos ad=0.3808p pd=2.92u as=0.2128p ps=1.5u w=1.12u l=0.6u
X2728 a_20831_14024# a_20593_14024# a_20723_14024# VSS.t288 sg13_lv_nmos ad=0.1406p pd=1.12u as=0.2516p ps=2.16u w=0.74u l=0.2u
X2729 a_25528_13226# a_24957_14024# VSS.t1839 VSS.t2328 sg13_lv_nmos ad=0.1406p pd=1.12u as=0.2516p ps=2.16u w=0.74u l=0.13u
X2730 VSS.t722 VDD.t1658 VSS.t722 VSS.t723 sg13_lv_nmos ad=79.8f pd=0.8u as=0 ps=0 w=0.42u l=1u
X2731 a_15511_17497# a_15273_16869# a_15403_16869# VDD.t365 sg13_lv_pmos ad=0.2128p pd=1.5u as=0.3808p ps=2.92u w=1.12u l=0.2u
X2732 a_10040_11995# a_9772_11533# a_9946_11995# VSS.t571 sg13_lv_nmos ad=60.89999f pd=0.71u as=0.1428p ps=1.52u w=0.42u l=0.13u
X2733 a_1721_331# a_1256_289# VDD.t544 VDD.t0 sg13_lv_pmos ad=0.1596p pd=1.22u as=0.2856p ps=2.36u w=0.84u l=0.13u
X2734 a_7673_1842# a_7477_1842# VDD.t1007 VDD.t353 sg13_lv_pmos ad=0.3808p pd=2.92u as=0.2128p ps=1.5u w=1.12u l=0.13u
X2735 a_12849_11557# a_12656_11554# VSS.t872 VSS.t871 sg13_lv_nmos ad=0.1406p pd=1.12u as=0.2516p ps=2.16u w=0.74u l=0.13u
X2736 a_15053_11110# a_14111_10917# a_14851_10872# VDD.t351 sg13_lv_pmos ad=93.45f pd=0.865u as=0.2048p ps=1.63u w=0.42u l=0.13u
X2737 VSS.t2027 a_1544_16071# a_2391_16422# VSS.t2039 sg13_lv_nmos ad=0.1331p pd=1.12u as=0.1216p ps=1.02u w=0.64u l=0.13u
X2738 CHAN0_MUX_OUT a_16851_15336# VSS.t1341 VSS.t1340 sg13_lv_nmos ad=0.1406p pd=1.12u as=0.1371p ps=1.12u w=0.74u l=0.13u
X2739 a_16033_4687# a_15837_4687# VSS.t1089 VSS.t2138 sg13_lv_nmos ad=0.2516p pd=2.16u as=0.1406p ps=1.12u w=0.74u l=0.13u
X2740 VSS.t443 a_4187_1764.t108 a_21591_14024# VSS.t442 sg13_lv_nmos ad=0.2516p pd=2.16u as=0.1406p ps=1.12u w=0.74u l=0.6u
X2741 VDD.t448 a_6326_10280# a_6854_11144# VDD.t351 sg13_lv_pmos ad=0.38p pd=2.38u as=0.38p ps=2.38u w=2u l=1u
X2742 VDD.t4 VSS.t810 VDD.t3 VDD.t0 sg13_lv_pmos ad=0.34p pd=2.68u as=0 ps=0 w=1u l=1u
X2743 a_7151_4687# a_6913_4687# a_7043_4687# VSS.t1605 sg13_lv_nmos ad=0.1406p pd=1.12u as=0.2516p ps=2.16u w=0.74u l=0.2u
X2744 VDD.t898 a_4187_2434# a_23111_5315# VDD.t339 sg13_lv_pmos ad=0.3808p pd=2.92u as=0.2128p ps=1.5u w=1.12u l=0.6u
X2745 VDD.t830 a_4187_2434# a_16271_17497# VDD.t365 sg13_lv_pmos ad=0.3808p pd=2.92u as=0.2128p ps=1.5u w=1.12u l=0.6u
X2746 a_6635_1044# a_6425_1044# VSS.t34 VSS.t33 sg13_lv_nmos ad=0.1406p pd=1.12u as=0.1665p ps=1.19u w=0.74u l=0.13u
X2747 VDD.t1185 a_3171_3892.t3 a_24084_3853# VDD.t9 sg13_lv_pmos ad=0.3808p pd=2.92u as=0.3808p ps=2.92u w=1.12u l=0.13u
X2748 VDD.t711 a_2595_15338.t3 a_8745_15546# VDD.t20 sg13_lv_pmos ad=0.3808p pd=2.92u as=0.3808p ps=2.92u w=1.12u l=0.13u
X2749 VDD.t883 a_4187_2434# a_20831_8160# VDD.t341 sg13_lv_pmos ad=0.3808p pd=2.92u as=0.2128p ps=1.5u w=1.12u l=0.6u
X2750 VSS.t483 a_24523_1842# a_24957_1842# VSS.t2085 sg13_lv_nmos ad=0.1406p pd=1.12u as=0.2516p ps=2.16u w=0.74u l=0.13u
X2751 VDD.t138 VSS.t674 VDD.t38 VDD.t36 sg13_lv_pmos ad=0.19p pd=1.38u as=0 ps=0 w=1u l=1u
X2752 a_14513_14024# a_14317_14024# VDD.t978 VDD.t381 sg13_lv_pmos ad=0.3808p pd=2.92u as=0.2128p ps=1.5u w=1.12u l=0.13u
X2753 VDD.t1170 a_2019_12493.t3 a_5705_12701# VDD.t36 sg13_lv_pmos ad=0.3808p pd=2.92u as=0.3808p ps=2.92u w=1.12u l=0.13u
X2754 VSS.t360 a_2595_1047.t9 a_5191_1008# VSS.t359 sg13_lv_nmos ad=0.2516p pd=2.16u as=0.2516p ps=2.16u w=0.74u l=0.13u
X2755 a_16108_3134# a_3747_3156.t2 a_25630_3889# VSS.t1255 sg13_lv_nmos ad=0.2516p pd=2.16u as=0.2516p ps=2.16u w=0.74u l=0.13u
X2756 VDD.t46 VSS.t702 VDD.t45 VDD.t29 sg13_lv_pmos ad=0.34p pd=2.68u as=0 ps=0 w=1u l=1u
X2757 a_27915_16071# a_27705_16071# VDD.t685 VDD.t20 sg13_lv_pmos ad=0.2128p pd=1.5u as=0.252p ps=1.57u w=1.12u l=0.13u
X2758 a_10589_11604# a_10232_11561# VDD.t357 VDD.t351 sg13_lv_pmos ad=63f pd=0.72u as=0.1563p ps=1.22u w=0.42u l=0.13u
X2759 a_20315_1044# a_20105_1044# VSS.t177 VSS.t176 sg13_lv_nmos ad=0.1406p pd=1.12u as=0.1665p ps=1.19u w=0.74u l=0.13u
X2760 a_22488_3889# a_21917_4687# VSS.t73 VSS.t310 sg13_lv_nmos ad=0.1406p pd=1.12u as=0.2516p ps=2.16u w=0.74u l=0.13u
X2761 a_27048_13226# a_26477_14024# VDD.t542 VDD.t36 sg13_lv_pmos ad=0.2128p pd=1.5u as=0.3808p ps=2.92u w=1.12u l=0.13u
X2762 a_25528_1044# a_24957_1842# VSS.t1006 VSS.t2340 sg13_lv_nmos ad=0.1406p pd=1.12u as=0.2516p ps=2.16u w=0.74u l=0.13u
X2763 a_18795_1044# a_18585_1044# VDD.t1365 VDD.t0 sg13_lv_pmos ad=0.2128p pd=1.5u as=0.252p ps=1.57u w=1.12u l=0.13u
X2764 VDD.t627 VDD.t625 VDD.t626 VDD.t360 sg13_lv_pmos ad=0.3808p pd=2.92u as=0 ps=0 w=1.12u l=0.13u
X2765 VSS.t1632 a_27237_7532# a_27705_6734# VSS.t1631 sg13_lv_nmos ad=0.1665p pd=1.19u as=0.2516p ps=2.16u w=0.74u l=0.13u
X2766 VDD.t602 VDD.t600 VDD.t599 VDD.t365 sg13_lv_pmos ad=0.2128p pd=1.5u as=0 ps=0 w=1.12u l=0.2u
X2767 a_23355_16071# a_23145_16071# VDD.t1368 VDD.t20 sg13_lv_pmos ad=0.2128p pd=1.5u as=0.252p ps=1.57u w=1.12u l=0.13u
X2768 VSS.t1566 a_4187_1764.t98 VSS.t1568 VSS.t1567 sg13_lv_nmos ad=1.33p pd=7.38u as=0 ps=0 w=7u l=7u
X2769 a_2595_6737.t1 a_2297_7085# VSS.t275 VSS.t274 sg13_lv_nmos ad=0.1406p pd=1.12u as=0.1331p ps=1.12u w=0.74u l=0.13u
X2770 VDD.t919 a_4187_2434# a_11711_2470# VDD.t353 sg13_lv_pmos ad=0.3808p pd=2.92u as=0.2128p ps=1.5u w=1.12u l=0.6u
X2771 a_16108_5979# a_20905_6209# a_19550_6734# VDD.t29 sg13_lv_pmos ad=0.3808p pd=2.92u as=0.3808p ps=2.92u w=1.12u l=0.13u
X2772 VSS.t694 VDD.t1670 VSS.t694 VSS.t693 sg13_lv_nmos ad=0.1428p pd=1.52u as=0 ps=0 w=0.42u l=1u
X2773 a_10191_8160# a_9953_7532# a_10083_7532# VDD.t341 sg13_lv_pmos ad=0.2128p pd=1.5u as=0.3808p ps=2.92u w=1.12u l=0.2u
X2774 VDD.t1204 a_2595_1047.t5 a_17351_1008# VDD.t0 sg13_lv_pmos ad=0.3808p pd=2.92u as=0.3808p ps=2.92u w=1.12u l=0.13u
X2775 a_25630_1044# a_27124_1008# a_27048_1044# VDD.t0 sg13_lv_pmos ad=0.3808p pd=2.92u as=0.2128p ps=1.5u w=1.12u l=0.13u
X2776 VDD.t1533 a_2019_6737.t8 a_7364_6698# VDD.t29 sg13_lv_pmos ad=0.3808p pd=2.92u as=0.3808p ps=2.92u w=1.12u l=0.13u
X2777 a_5731_289# a_3747_311.t3 a_13470_1044# VSS.t1546 sg13_lv_nmos ad=0.2516p pd=2.16u as=0.2516p ps=2.16u w=0.74u l=0.13u
X2778 a_5393_14024# a_5197_14024# VSS.t1120 VSS.t1621 sg13_lv_nmos ad=0.2516p pd=2.16u as=0.1406p ps=1.12u w=0.74u l=0.13u
X2779 VSS.t1864 a_4187_1764.t2 a_27671_1842# VSS.t1863 sg13_lv_nmos ad=0.2516p pd=2.16u as=0.1406p ps=1.12u w=0.74u l=0.6u
X2780 VDD.t549 a_18443_16869# a_18877_16869# VDD.t365 sg13_lv_pmos ad=0.2128p pd=1.5u as=0.3808p ps=2.92u w=1.12u l=0.13u
X2781 VDD.t991 CHAN1_MUX_SEL3 a_3449_12513# VDD.t36 sg13_lv_pmos ad=0.1918p pd=1.5u as=0.1596p ps=1.22u w=0.84u l=0.13u
X2782 a_26151_7532# a_25913_7532# a_26043_7532# VSS.t1624 sg13_lv_nmos ad=0.1406p pd=1.12u as=0.2516p ps=2.16u w=0.74u l=0.2u
X2783 VSS.t739 VDD.t1650 VSS.t739 VSS.t743 sg13_lv_nmos ad=79.8f pd=0.8u as=0 ps=0 w=0.42u l=1u
X2784 a_22590_13226# a_2019_13229.t3 a_22488_13226# VSS.t150 sg13_lv_nmos ad=0.2516p pd=2.16u as=0.1406p ps=1.12u w=0.74u l=0.13u
X2785 VDD.t1408 a_21483_1842# a_21917_1842# VDD.t353 sg13_lv_pmos ad=0.2128p pd=1.5u as=0.3808p ps=2.92u w=1.12u l=0.13u
X2786 a_16408_13226# a_15837_14024# VSS.t1498 VSS.t1497 sg13_lv_nmos ad=0.1406p pd=1.12u as=0.2516p ps=2.16u w=0.74u l=0.13u
X2787 a_19550_16071# a_3171_16074.t4 a_20968_16071# VSS.t2189 sg13_lv_nmos ad=0.2516p pd=2.16u as=0.1406p ps=1.12u w=0.74u l=0.13u
X2788 a_4350_1044# a_5844_1008# a_5768_1044# VDD.t0 sg13_lv_pmos ad=0.3808p pd=2.92u as=0.2128p ps=1.5u w=1.12u l=0.13u
X2789 a_16108_12471# a_3747_12493.t2 a_25630_13226# VSS.t460 sg13_lv_nmos ad=0.2516p pd=2.16u as=0.2516p ps=2.16u w=0.74u l=0.13u
X2790 a_13753_7532# a_13557_7532# VSS.t1098 VSS.t1116 sg13_lv_nmos ad=0.2516p pd=2.16u as=0.1406p ps=1.12u w=0.74u l=0.13u
X2791 VSS.t745 VDD.t1649 VSS.t745 VSS.t746 sg13_lv_nmos ad=79.8f pd=0.8u as=0 ps=0 w=0.42u l=1u
X2792 VSS.t93 a_3449_3176# a_3747_3156.t1 VSS.t2358 sg13_lv_nmos ad=0.2812p pd=2.24u as=0.1406p ps=1.12u w=0.74u l=0.13u
X2793 VSS.t459 a_5523_4687# a_5957_4687# VSS.t1254 sg13_lv_nmos ad=0.1406p pd=1.12u as=0.2516p ps=2.16u w=0.74u l=0.13u
X2794 a_4871_7532# a_4633_7532# a_4763_7532# VSS.t2220 sg13_lv_nmos ad=0.1406p pd=1.12u as=0.2516p ps=2.16u w=0.74u l=0.2u
X2795 a_1815_7085# a_1256_6734# a_1721_7085# VSS.t132 sg13_lv_nmos ad=0.1216p pd=1.02u as=0.2176p ps=1.96u w=0.64u l=0.13u
X2796 VDD.t1309 a_18117_4687# a_18585_3889# VDD.t9 sg13_lv_pmos ad=0.252p pd=1.57u as=0.3808p ps=2.92u w=1.12u l=0.13u
X2797 VSS.t656 VDD.t1684 VSS.t656 VSS.t660 sg13_lv_nmos ad=0.1428p pd=1.52u as=0 ps=0 w=0.42u l=1u
X2798 VDD.t33 VSS.t722 VDD.t31 VDD.t29 sg13_lv_pmos ad=0.19p pd=1.38u as=0 ps=0 w=1u l=1u
X2799 a_22590_13226# a_24084_13190# a_24008_13226# VDD.t36 sg13_lv_pmos ad=0.3808p pd=2.92u as=0.2128p ps=1.5u w=1.12u l=0.13u
X2800 VSS.t612 VDD.t1699 VSS.t612 VSS.t611 sg13_lv_nmos ad=0.1428p pd=1.52u as=0 ps=0 w=0.42u l=1u
X2801 a_16510_13226# a_2595_13229.t5 a_17275_13226# VSS.t239 sg13_lv_nmos ad=0.2516p pd=2.16u as=0.1406p ps=1.12u w=0.74u l=0.13u
X2802 a_6326_10280# a_6126_9506# a_5778_9057# VSS.t956 sg13_lv_nmos ad=0.38p pd=2.38u as=0.68p ps=4.68u w=2u l=1u
X2803 VSS.t321 a_16851_309# CHAN3_MUX_OUT VSS.t2276 sg13_lv_nmos ad=0.2516p pd=2.16u as=0.1406p ps=1.12u w=0.74u l=0.13u
X2804 a_2873_6021# REF_MUX_SEL3 VDD.t737 VDD.t29 sg13_lv_pmos ad=0.1596p pd=1.22u as=0.2856p ps=2.36u w=0.84u l=0.13u
X2805 a_22488_6734# a_21917_7532# VDD.t340 VDD.t29 sg13_lv_pmos ad=0.2128p pd=1.5u as=0.3808p ps=2.92u w=1.12u l=0.13u
X2806 VDD.t1019 a_1544_289# a_1721_331# VDD.t0 sg13_lv_pmos ad=0.1918p pd=1.5u as=0.1596p ps=1.22u w=0.84u l=0.13u
X2807 VSS.t775 a_2019_311# a_5705_519# VSS.t1244 sg13_lv_nmos ad=0.2516p pd=2.16u as=0.2516p ps=2.16u w=0.74u l=0.13u
X2808 a_4350_16071# a_3171_16074.t9 a_5768_16071# VSS.t2252 sg13_lv_nmos ad=0.2516p pd=2.16u as=0.1406p ps=1.12u w=0.74u l=0.13u
X2809 a_15511_14652# a_15273_14024# a_15403_14024# VDD.t381 sg13_lv_pmos ad=0.2128p pd=1.5u as=0.3808p ps=2.92u w=1.12u l=0.2u
X2810 a_7673_7532# a_7477_7532# VDD.t489 VDD.t341 sg13_lv_pmos ad=0.3808p pd=2.92u as=0.2128p ps=1.5u w=1.12u l=0.13u
X2811 VSS.t1333 a_4187_1764.t59 a_8671_4687# VSS.t1332 sg13_lv_nmos ad=0.2516p pd=2.16u as=0.1406p ps=1.12u w=0.74u l=0.6u
X2812 a_16033_1842# a_15837_1842# VSS.t544 VSS.t1457 sg13_lv_nmos ad=0.2516p pd=2.16u as=0.1406p ps=1.12u w=0.74u l=0.13u
X2813 VDD.t564 a_11603_4687# a_12037_4687# VDD.t339 sg13_lv_pmos ad=0.2128p pd=1.5u as=0.3808p ps=2.92u w=1.12u l=0.13u
X2814 VSS.t163 a_24523_7532# a_24957_7532# VSS.t162 sg13_lv_nmos ad=0.1406p pd=1.12u as=0.2516p ps=2.16u w=0.74u l=0.13u
X2815 a_6635_6734# a_6425_6734# VSS.t257 VSS.t256 sg13_lv_nmos ad=0.1406p pd=1.12u as=0.1665p ps=1.19u w=0.74u l=0.13u
X2816 a_7151_1842# a_6913_1842# a_7043_1842# VSS.t2323 sg13_lv_nmos ad=0.1406p pd=1.12u as=0.2516p ps=2.16u w=0.74u l=0.2u
X2817 VDD.t793 a_4187_2434# a_16271_14652# VDD.t381 sg13_lv_pmos ad=0.3808p pd=2.92u as=0.2128p ps=1.5u w=1.12u l=0.6u
X2818 a_9746_11495# a_9547_11632# VSS.t136 VSS.t135 sg13_lv_nmos ad=0.27427p pd=2.28u as=2.39977p ps=15.495u w=0.795u l=0.13u
X2819 a_24631_16869# a_24393_16869# a_24523_16869# VSS.t2309 sg13_lv_nmos ad=0.1406p pd=1.12u as=0.2516p ps=2.16u w=0.74u l=0.2u
X2820 VSS.t1170 a_2595_6737.t9 a_5191_6698# VSS.t1746 sg13_lv_nmos ad=0.2516p pd=2.16u as=0.2516p ps=2.16u w=0.74u l=0.13u
X2821 VDD.t297 VSS.t745 VDD.t296 VDD.t9 sg13_lv_pmos ad=0.34p pd=2.68u as=0 ps=0 w=1u l=1u
X2822 a_13470_3889# a_2019_3892.t6 a_13368_3889# VSS.t1996 sg13_lv_nmos ad=0.2516p pd=2.16u as=0.1406p ps=1.12u w=0.74u l=0.13u
X2823 a_24393_4687# a_24197_4687# VDD.t935 VDD.t339 sg13_lv_pmos ad=0.3808p pd=2.92u as=0.2128p ps=1.5u w=1.12u l=0.13u
X2824 a_11473_16869# a_11277_16869# VDD.t366 VDD.t365 sg13_lv_pmos ad=0.3808p pd=2.92u as=0.2128p ps=1.5u w=1.12u l=0.13u
X2825 VSS.t506 a_10083_14024# a_10517_14024# VSS.t505 sg13_lv_nmos ad=0.1406p pd=1.12u as=0.2516p ps=2.16u w=0.74u l=0.13u
X2826 a_20315_6734# a_20105_6734# VSS.t117 VSS.t116 sg13_lv_nmos ad=0.1406p pd=1.12u as=0.1665p ps=1.19u w=0.74u l=0.13u
X2827 a_20071_16869# a_19833_16869# a_19963_16869# VSS.t1062 sg13_lv_nmos ad=0.1406p pd=1.12u as=0.2516p ps=2.16u w=0.74u l=0.2u
X2828 VSS.t89 a_4187_1764.t135 a_25391_16869# VSS.t1726 sg13_lv_nmos ad=0.2516p pd=2.16u as=0.1406p ps=1.12u w=0.74u l=0.6u
X2829 a_7390_13226# a_8884_13190# a_8808_13226# VDD.t36 sg13_lv_pmos ad=0.3808p pd=2.92u as=0.2128p ps=1.5u w=1.12u l=0.13u
X2830 a_25528_6734# a_24957_7532# VSS.t846 VSS.t845 sg13_lv_nmos ad=0.1406p pd=1.12u as=0.2516p ps=2.16u w=0.74u l=0.13u
X2831 CHAN3_MUX_OUT a_16851_309# VDD.t500 VDD.t0 sg13_lv_pmos ad=0.2128p pd=1.5u as=0.2086p ps=1.5u w=1.12u l=0.13u
X2832 VSS.t769 a_3747_3156.t2 a_26985_3364# VSS.t1256 sg13_lv_nmos ad=0.2516p pd=2.16u as=0.2516p ps=2.16u w=0.74u l=0.13u
X2833 VDD.t98 VSS.t694 VDD.t97 VDD.t29 sg13_lv_pmos ad=0.34p pd=2.68u as=0 ps=0 w=1u l=1u
X2834 a_6126_9506# a_6326_10280# VDD.t438 VDD.t351 sg13_lv_pmos ad=0.38p pd=2.38u as=0.38p ps=2.38u w=2u l=1u
X2835 VSS.t1834 a_1256_16071# a_2967_16422# VSS.t1833 sg13_lv_nmos ad=0.1331p pd=1.12u as=0.1216p ps=1.02u w=0.64u l=0.13u
X2836 a_6391_14024# a_6153_14024# a_6283_14024# VSS.t1935 sg13_lv_nmos ad=0.1406p pd=1.12u as=0.2516p ps=2.16u w=0.74u l=0.2u
X2837 VSS.t61 a_2595_16074.t7 a_11271_16035# VSS.t1858 sg13_lv_nmos ad=0.2516p pd=2.16u as=0.2516p ps=2.16u w=0.74u l=0.13u
X2838 a_25391_2470# a_25153_1842# a_25283_1842# VDD.t353 sg13_lv_pmos ad=0.2128p pd=1.5u as=0.3808p ps=2.92u w=1.12u l=0.2u
X2839 VDD.t1184 a_3171_3892.t6 a_14964_3853# VDD.t9 sg13_lv_pmos ad=0.3808p pd=2.92u as=0.3808p ps=2.92u w=1.12u l=0.13u
X2840 a_5731_5979# a_2019_6001.t3 a_4350_6734# VSS.t1360 sg13_lv_nmos ad=0.2516p pd=2.16u as=0.2516p ps=2.16u w=0.74u l=0.13u
X2841 VDD.t610 VDD.t612 VDD.t613 VDD.t381 sg13_lv_pmos ad=0.2128p pd=1.5u as=0 ps=0 w=1.12u l=0.2u
X2842 VSS.t665 VDD.t1682 VSS.t665 VSS.t664 sg13_lv_nmos ad=0.1428p pd=1.52u as=0 ps=0 w=0.42u l=1u
X2843 VDD.t878 a_4187_2434# a_11711_8160# VDD.t341 sg13_lv_pmos ad=0.3808p pd=2.92u as=0.2128p ps=1.5u w=1.12u l=0.6u
X2844 VDD.t28 VSS.t418 VDD.t27 VDD.t0 sg13_lv_pmos ad=0.34p pd=2.68u as=0 ps=0 w=1u l=1u
X2845 a_16108_3134# a_20905_3364# a_19550_3889# VDD.t9 sg13_lv_pmos ad=0.3808p pd=2.92u as=0.3808p ps=2.92u w=1.12u l=0.13u
X2846 a_2595_3892.t1 a_2297_4240# VSS.t1409 VSS.t1124 sg13_lv_nmos ad=0.1406p pd=1.12u as=0.1331p ps=1.12u w=0.74u l=0.13u
X2847 VSS.t640 VDD.t1692 VSS.t640 VSS.t641 sg13_lv_nmos ad=79.8f pd=0.8u as=0 ps=0 w=0.42u l=1u
X2848 a_4350_13226# a_4324_13190# a_4248_13226# VDD.t36 sg13_lv_pmos ad=0.3808p pd=2.92u as=0.2128p ps=1.5u w=1.12u l=0.13u
X2849 VSS.t1466 a_3171_3892.t3 a_24084_3853# VSS.t1673 sg13_lv_nmos ad=0.2516p pd=2.16u as=0.2516p ps=2.16u w=0.74u l=0.13u
X2850 a_25630_16071# a_26471_16035# a_26395_16071# VDD.t20 sg13_lv_pmos ad=0.3808p pd=2.92u as=0.2128p ps=1.5u w=1.12u l=0.13u
X2851 VSS.t1096 a_4187_1764.t127 a_7151_14024# VSS.t1095 sg13_lv_nmos ad=0.2516p pd=2.16u as=0.1406p ps=1.12u w=0.74u l=0.6u
X2852 CHAN1_MUX_OUT a_16851_12491# VDD.t1144 VDD.t36 sg13_lv_pmos ad=0.2128p pd=1.5u as=0.2086p ps=1.5u w=1.12u l=0.13u
X2853 VSS.t1588 a_4187_1764.t98 VSS.t1586 VSS.t1571 sg13_lv_nmos ad=1.33p pd=7.38u as=0 ps=0 w=7u l=7u
X2854 VDD.t896 a_4187_2434# a_14751_5315# VDD.t339 sg13_lv_pmos ad=0.3808p pd=2.92u as=0.2128p ps=1.5u w=1.12u l=0.6u
X2855 VSS.t97 a_24523_14024# a_24957_14024# VSS.t96 sg13_lv_nmos ad=0.1406p pd=1.12u as=0.2516p ps=2.16u w=0.74u l=0.13u
X2856 VSS.t730 a_2019_3156.t3 a_5705_3364# VSS.t987 sg13_lv_nmos ad=0.2516p pd=2.16u as=0.2516p ps=2.16u w=0.74u l=0.13u
X2857 VSS.t146 a_4187_1764.t66 a_27671_7532# VSS.t145 sg13_lv_nmos ad=0.2516p pd=2.16u as=0.1406p ps=1.12u w=0.74u l=0.6u
X2858 a_12993_1842# a_12797_1842# VDD.t1103 VDD.t353 sg13_lv_pmos ad=0.3808p pd=2.92u as=0.2128p ps=1.5u w=1.12u l=0.13u
X2859 VDD.t382 a_18443_14024# a_18877_14024# VDD.t381 sg13_lv_pmos ad=0.2128p pd=1.5u as=0.3808p ps=2.92u w=1.12u l=0.13u
X2860 a_16408_1044# a_15837_1842# VSS.t349 VSS.t1456 sg13_lv_nmos ad=0.1406p pd=1.12u as=0.2516p ps=2.16u w=0.74u l=0.13u
X2861 VDD.t342 a_21483_7532# a_21917_7532# VDD.t341 sg13_lv_pmos ad=0.2128p pd=1.5u as=0.3808p ps=2.92u w=1.12u l=0.13u
X2862 VDD.t1120 a_7477_16869# a_7945_16071# VDD.t20 sg13_lv_pmos ad=0.252p pd=1.57u as=0.3808p ps=2.92u w=1.12u l=0.13u
X2863 VSS.t730 VDD.t1654 VSS.t730 VSS.t733 sg13_lv_nmos ad=79.8f pd=0.8u as=0 ps=0 w=0.42u l=1u
X2864 a_12471_4687# a_12233_4687# a_12363_4687# VSS.t1115 sg13_lv_nmos ad=0.1406p pd=1.12u as=0.2516p ps=2.16u w=0.74u l=0.2u
X2865 a_5768_16071# a_5197_16869# VDD.t996 VDD.t20 sg13_lv_pmos ad=0.2128p pd=1.5u as=0.3808p ps=2.92u w=1.12u l=0.13u
X2866 VDD.t1302 a_2595_13229.t6 a_14311_13190# VDD.t36 sg13_lv_pmos ad=0.3808p pd=2.92u as=0.3808p ps=2.92u w=1.12u l=0.13u
X2867 a_11195_3889# a_10985_3889# VDD.t1393 VDD.t9 sg13_lv_pmos ad=0.2128p pd=1.5u as=0.252p ps=1.57u w=1.12u l=0.13u
X2868 a_5731_5979# a_11785_6209# a_10430_6734# VDD.t29 sg13_lv_pmos ad=0.3808p pd=2.92u as=0.3808p ps=2.92u w=1.12u l=0.13u
X2869 a_4871_16869# a_4633_16869# a_4763_16869# VSS.t1383 sg13_lv_nmos ad=0.1406p pd=1.12u as=0.2516p ps=2.16u w=0.74u l=0.2u
X2870 VDD.t852 a_4187_2434# a_4111_5315# VDD.t339 sg13_lv_pmos ad=0.3808p pd=2.92u as=0.2128p ps=1.5u w=1.12u l=0.6u
X2871 a_9193_16869# a_8997_16869# VSS.t1399 VSS.t1468 sg13_lv_nmos ad=0.2516p pd=2.16u as=0.1406p ps=1.12u w=0.74u l=0.13u
X2872 a_18795_16071# a_18585_16071# VSS.t1052 VSS.t2018 sg13_lv_nmos ad=0.1406p pd=1.12u as=0.1665p ps=1.19u w=0.74u l=0.13u
X2873 VSS.t368 a_5523_1842# a_5957_1842# VSS.t427 sg13_lv_nmos ad=0.1406p pd=1.12u as=0.2516p ps=2.16u w=0.74u l=0.13u
X2874 a_13566_11525# a_14009_11568# a_13949_11604# VDD.t351 sg13_lv_pmos ad=79.8f pd=0.8u as=63f ps=0.72u w=0.42u l=0.13u
X2875 a_15755_13226# a_15545_13226# VSS.t2088 VSS.t2087 sg13_lv_nmos ad=0.1406p pd=1.12u as=0.1665p ps=1.19u w=0.74u l=0.13u
X2876 a_1815_4240# a_1256_3889# a_1721_4240# VSS.t1994 sg13_lv_nmos ad=0.1216p pd=1.02u as=0.2176p ps=1.96u w=0.64u l=0.13u
X2877 a_5731_289# a_2019_311# a_4350_1044# VSS.t1243 sg13_lv_nmos ad=0.2516p pd=2.16u as=0.2516p ps=2.16u w=0.74u l=0.13u
X2878 VDD.t920 a_4187_2434# a_13991_2470# VDD.t353 sg13_lv_pmos ad=0.3808p pd=2.92u as=0.2128p ps=1.5u w=1.12u l=0.6u
X2879 VSS.t215 a_4187_1764.t161 a_5631_16869# VSS.t440 sg13_lv_nmos ad=0.2516p pd=2.16u as=0.1406p ps=1.12u w=0.74u l=0.6u
X2880 VDD.t712 a_2595_15338.t2 a_20905_15546# VDD.t20 sg13_lv_pmos ad=0.3808p pd=2.92u as=0.3808p ps=2.92u w=1.12u l=0.13u
X2881 VSS.t1186 a_14851_10872# a_15688_11093# VSS.t1808 sg13_lv_nmos ad=0.1406p pd=1.12u as=0.2516p ps=2.16u w=0.74u l=0.13u
X2882 VSS.t85 a_23003_16869# a_23437_16869# VSS.t985 sg13_lv_nmos ad=0.1406p pd=1.12u as=0.2516p ps=2.16u w=0.74u l=0.13u
X2883 a_14235_16071# a_14025_16071# VSS.t1044 VSS.t1914 sg13_lv_nmos ad=0.1406p pd=1.12u as=0.1665p ps=1.19u w=0.74u l=0.13u
X2884 VSS.t370 a_9323_14024# a_9757_14024# VSS.t1885 sg13_lv_nmos ad=0.1406p pd=1.12u as=0.2516p ps=2.16u w=0.74u l=0.13u
X2885 VDD.t13 VSS.t766 VDD.t11 VDD.t9 sg13_lv_pmos ad=0.19p pd=1.38u as=0 ps=0 w=1u l=1u
X2886 a_2391_6021# REF_MUX_SEL2 a_2297_6021# VSS.t171 sg13_lv_nmos ad=0.1216p pd=1.02u as=0.2176p ps=1.96u w=0.64u l=0.13u
X2887 VSS.t462 VDD.t1675 VSS.t462 VSS.t683 sg13_lv_nmos ad=79.8f pd=0.8u as=0 ps=0 w=0.42u l=1u
X2888 VDD.t437 a_3449_7085# a_3747_6737.t0 VDD.t29 sg13_lv_pmos ad=0.4256p pd=3u as=0.2128p ps=1.5u w=1.12u l=0.13u
X2889 a_13470_6734# a_13444_6698# a_13368_6734# VDD.t29 sg13_lv_pmos ad=0.3808p pd=2.92u as=0.2128p ps=1.5u w=1.12u l=0.13u
X2890 a_17031_17497# a_16793_16869# a_16923_16869# VDD.t365 sg13_lv_pmos ad=0.2128p pd=1.5u as=0.3808p ps=2.92u w=1.12u l=0.2u
X2891 a_2019_16074.t1 a_1721_16422# VSS.t1918 VSS.t1917 sg13_lv_nmos ad=0.1406p pd=1.12u as=0.1331p ps=1.12u w=0.74u l=0.13u
X2892 a_10458_11982# DLL_RESETN VSS.t49 VSS.t48 sg13_lv_nmos ad=37.8f pd=0.6u as=0.1701p ps=1.65u w=0.42u l=0.13u
X2893 a_7390_1044# a_3747_1047.t8 a_9675_1044# VSS.t245 sg13_lv_nmos ad=0.2516p pd=2.16u as=0.1406p ps=1.12u w=0.74u l=0.13u
X2894 VSS.t1136 a_1544_5979# a_1815_6021# VSS.t1135 sg13_lv_nmos ad=0.1331p pd=1.12u as=0.1216p ps=1.02u w=0.64u l=0.13u
X2895 a_4350_16071# a_6711_16035# a_6635_16071# VDD.t20 sg13_lv_pmos ad=0.3808p pd=2.92u as=0.2128p ps=1.5u w=1.12u l=0.13u
X2896 VDD.t1423 a_23763_1842# a_24197_1842# VDD.t353 sg13_lv_pmos ad=0.2128p pd=1.5u as=0.3808p ps=2.92u w=1.12u l=0.13u
X2897 a_25528_16071# a_24957_16869# VSS.t410 VSS.t2311 sg13_lv_nmos ad=0.1406p pd=1.12u as=0.2516p ps=2.16u w=0.74u l=0.13u
X2898 a_1256_15316# CHAN0_MUX_SEL2 VSS.t277 VSS.t478 sg13_lv_nmos ad=0.2516p pd=2.16u as=0.2516p ps=2.16u w=0.74u l=0.13u
X2899 a_22113_14024# a_21917_14024# VSS.t443 VSS.t527 sg13_lv_nmos ad=0.2516p pd=2.16u as=0.1406p ps=1.12u w=0.74u l=0.13u
X2900 VSS.t1912 a_18117_4687# a_18585_3889# VSS.t2170 sg13_lv_nmos ad=0.1665p pd=1.19u as=0.2516p ps=2.16u w=0.74u l=0.13u
X2901 a_12471_17497# a_12233_16869# a_12363_16869# VDD.t365 sg13_lv_pmos ad=0.2128p pd=1.5u as=0.3808p ps=2.92u w=1.12u l=0.2u
X2902 VDD.t809 a_4187_2434# a_17791_17497# VDD.t365 sg13_lv_pmos ad=0.3808p pd=2.92u as=0.2128p ps=1.5u w=1.12u l=0.6u
X2903 a_16033_7532# a_15837_7532# VSS.t260 VSS.t1772 sg13_lv_nmos ad=0.2516p pd=2.16u as=0.1406p ps=1.12u w=0.74u l=0.13u
X2904 VDD.t1294 a_2019_1047.t8 a_7364_1008# VDD.t0 sg13_lv_pmos ad=0.3808p pd=2.92u as=0.3808p ps=2.92u w=1.12u l=0.13u
X2905 VSS.t1108 a_4187_1764.t27 a_8671_1842# VSS.t1107 sg13_lv_nmos ad=0.2516p pd=2.16u as=0.1406p ps=1.12u w=0.74u l=0.6u
X2906 a_17275_13226# a_17065_13226# VDD.t1490 VDD.t36 sg13_lv_pmos ad=0.2128p pd=1.5u as=0.252p ps=1.57u w=1.12u l=0.13u
X2907 a_7151_7532# a_6913_7532# a_7043_7532# VSS.t2277 sg13_lv_nmos ad=0.1406p pd=1.12u as=0.2516p ps=2.16u w=0.74u l=0.2u
X2908 VDD.t1291 a_3171_6737.t3 a_24084_6698# VDD.t29 sg13_lv_pmos ad=0.3808p pd=2.92u as=0.3808p ps=2.92u w=1.12u l=0.13u
X2909 a_3449_7085# REF_MUX_SEL0 VDD.t742 VDD.t29 sg13_lv_pmos ad=0.1596p pd=1.22u as=0.2856p ps=2.36u w=0.84u l=0.13u
X2910 VDD.t828 a_4187_2434# a_13231_17497# VDD.t365 sg13_lv_pmos ad=0.3808p pd=2.92u as=0.2128p ps=1.5u w=1.12u l=0.6u
X2911 a_9953_4687# a_9757_4687# VSS.t387 VSS.t1625 sg13_lv_nmos ad=0.2516p pd=2.16u as=0.1406p ps=1.12u w=0.74u l=0.13u
X2912 VDD.t469 a_2019_15338.t3 a_5705_15546# VDD.t20 sg13_lv_pmos ad=0.3808p pd=2.92u as=0.3808p ps=2.92u w=1.12u l=0.13u
X2913 VSS.t291 a_10843_4687# a_11277_4687# VSS.t290 sg13_lv_nmos ad=0.1406p pd=1.12u as=0.2516p ps=2.16u w=0.74u l=0.13u
X2914 a_11473_14024# a_11277_14024# VDD.t944 VDD.t381 sg13_lv_pmos ad=0.3808p pd=2.92u as=0.2128p ps=1.5u w=1.12u l=0.13u
X2915 a_22590_3889# a_23431_3853# a_23355_3889# VDD.t9 sg13_lv_pmos ad=0.3808p pd=2.92u as=0.2128p ps=1.5u w=1.12u l=0.13u
X2916 a_17031_5315# a_16793_4687# a_16923_4687# VDD.t339 sg13_lv_pmos ad=0.2128p pd=1.5u as=0.3808p ps=2.92u w=1.12u l=0.2u
X2917 a_24875_16071# a_24665_16071# VDD.t1001 VDD.t20 sg13_lv_pmos ad=0.2128p pd=1.5u as=0.252p ps=1.57u w=1.12u l=0.13u
X2918 VDD.t172 VSS.t737 VDD.t201 VDD.t9 sg13_lv_pmos ad=0.34p pd=2.68u as=0 ps=0 w=1u l=1u
X2919 VDD.t594 VDD.t595 VDD.t596 VDD.t365 sg13_lv_pmos ad=0.2128p pd=1.5u as=0 ps=0 w=1.12u l=0.13u
X2920 a_4157_13495# CHAN1_DELAY_IN VSS.t161 VSS.t160 sg13_lv_nmos ad=0.2516p pd=2.16u as=0.2553p ps=2.17u w=0.74u l=0.13u
X2921 VDD.t927 a_4187_2434# a_26911_2470# VDD.t353 sg13_lv_pmos ad=0.3808p pd=2.92u as=0.2128p ps=1.5u w=1.12u l=0.6u
X2922 VDD.t309 VSS.t591 VDD.t307 VDD.t20 sg13_lv_pmos ad=0.19p pd=1.38u as=0 ps=0 w=1u l=1u
X2923 a_25391_8160# a_25153_7532# a_25283_7532# VDD.t341 sg13_lv_pmos ad=0.2128p pd=1.5u as=0.3808p ps=2.92u w=1.12u l=0.2u
X2924 a_16108_5979# a_15765_6153# a_15964_5979# VDD.t29 sg13_lv_pmos ad=0.3808p pd=2.92u as=0.3304p ps=1.71u w=1.12u l=0.13u
X2925 a_20593_16869# a_20397_16869# VSS.t1100 VSS.t1213 sg13_lv_nmos ad=0.2516p pd=2.16u as=0.1406p ps=1.12u w=0.74u l=0.13u
X2926 VDD.t8 VSS.t841 VDD.t6 VDD.t0 sg13_lv_pmos ad=0.19p pd=1.38u as=0 ps=0 w=1u l=1u
X2927 VSS.t1196 a_13883_16869# a_14317_16869# VSS.t1264 sg13_lv_nmos ad=0.1406p pd=1.12u as=0.2516p ps=2.16u w=0.74u l=0.13u
X2928 a_6913_14024# a_6717_14024# VSS.t1046 VSS.t1349 sg13_lv_nmos ad=0.2516p pd=2.16u as=0.1406p ps=1.12u w=0.74u l=0.13u
X2929 VSS.t769 VDD.t1638 VSS.t769 VSS.t772 sg13_lv_nmos ad=79.8f pd=0.8u as=0 ps=0 w=0.42u l=1u
X2930 a_12993_7532# a_12797_7532# VDD.t1029 VDD.t341 sg13_lv_pmos ad=0.3808p pd=2.92u as=0.2128p ps=1.5u w=1.12u l=0.13u
X2931 a_22590_16071# a_2019_16074.t3 a_22488_16071# VSS.t1126 sg13_lv_nmos ad=0.2516p pd=2.16u as=0.1406p ps=1.12u w=0.74u l=0.13u
X2932 a_16408_6734# a_15837_7532# VSS.t1744 VSS.t1771 sg13_lv_nmos ad=0.1406p pd=1.12u as=0.2516p ps=2.16u w=0.74u l=0.13u
X2933 VSS.t100 a_2019_3156.t2 a_17865_3364# VSS.t99 sg13_lv_nmos ad=0.2516p pd=2.16u as=0.2516p ps=2.16u w=0.74u l=0.13u
X2934 VDD.t1223 a_15403_16869# a_15837_16869# VDD.t365 sg13_lv_pmos ad=0.2128p pd=1.5u as=0.3808p ps=2.92u w=1.12u l=0.13u
X2935 a_22488_1044# a_21917_1842# VDD.t1412 VDD.t0 sg13_lv_pmos ad=0.2128p pd=1.5u as=0.3808p ps=2.92u w=1.12u l=0.13u
X2936 a_16408_16071# a_15837_16869# VSS.t407 VSS.t1760 sg13_lv_nmos ad=0.1406p pd=1.12u as=0.2516p ps=2.16u w=0.74u l=0.13u
X2937 VSS.t252 VDD.t1709 VSS.t573 VSS.t572 sg13_lv_nmos ad=0.1428p pd=1.52u as=0 ps=0 w=0.42u l=1u
X2938 a_12471_1842# a_12233_1842# a_12363_1842# VSS.t1970 sg13_lv_nmos ad=0.1406p pd=1.12u as=0.2516p ps=2.16u w=0.74u l=0.2u
X2939 a_3747_3892.t0 a_3449_4240# VDD.t401 VDD.t9 sg13_lv_pmos ad=0.2128p pd=1.5u as=0.1918p ps=1.5u w=1.12u l=0.13u
X2940 a_5731_3134# a_11785_3364# a_10430_3889# VDD.t9 sg13_lv_pmos ad=0.3808p pd=2.92u as=0.3808p ps=2.92u w=1.12u l=0.13u
X2941 a_13368_13226# a_12797_14024# VSS.t149 VSS.t1493 sg13_lv_nmos ad=0.1406p pd=1.12u as=0.2516p ps=2.16u w=0.74u l=0.13u
X2942 VSS.t1233 a_3171_3892.t6 a_14964_3853# VSS.t1671 sg13_lv_nmos ad=0.2516p pd=2.16u as=0.2516p ps=2.16u w=0.74u l=0.13u
X2943 VSS.t377 a_5523_7532# a_5957_7532# VSS.t2202 sg13_lv_nmos ad=0.1406p pd=1.12u as=0.2516p ps=2.16u w=0.74u l=0.13u
X2944 VSS.t709 VDD.t1664 VSS.t709 VSS.t710 sg13_lv_nmos ad=79.8f pd=0.8u as=0 ps=0 w=0.42u l=1u
X2945 VSS.t191 a_3449_6021# a_3747_6001.t1 VSS.t192 sg13_lv_nmos ad=0.2812p pd=2.24u as=0.1406p ps=1.12u w=0.74u l=0.13u
X2946 VSS.t333 a_3171_1047.t5 a_18004_1008# VSS.t332 sg13_lv_nmos ad=0.2516p pd=2.16u as=0.2516p ps=2.16u w=0.74u l=0.13u
X2947 VDD.t536 a_2595_311.t3 a_8745_519# VDD.t0 sg13_lv_pmos ad=0.3808p pd=2.92u as=0.3808p ps=2.92u w=1.12u l=0.13u
X2948 VDD.t1281 a_3171_6001.t3 a_11785_6209# VDD.t29 sg13_lv_pmos ad=0.3808p pd=2.92u as=0.3808p ps=2.92u w=1.12u l=0.13u
X2949 a_16108_12471# a_3171_12493.t2 a_22590_13226# VSS.t2260 sg13_lv_nmos ad=0.2516p pd=2.16u as=0.2516p ps=2.16u w=0.74u l=0.13u
X2950 VDD.t744 a_18117_7532# a_18585_6734# VDD.t29 sg13_lv_pmos ad=0.252p pd=1.57u as=0.3808p ps=2.92u w=1.12u l=0.13u
X2951 a_20831_5315# a_20593_4687# a_20723_4687# VDD.t339 sg13_lv_pmos ad=0.2128p pd=1.5u as=0.3808p ps=2.92u w=1.12u l=0.2u
X2952 VSS.t1181 a_12849_11557# a_13400_10795# VSS.t1182 sg13_lv_nmos ad=0.1626p pd=1.415u as=60.89999f ps=0.71u w=0.42u l=0.13u
X2953 VDD.t870 a_4187_2434# a_13991_8160# VDD.t341 sg13_lv_pmos ad=0.3808p pd=2.92u as=0.2128p ps=1.5u w=1.12u l=0.6u
X2954 a_5393_4687# a_5197_4687# VDD.t1478 VDD.t339 sg13_lv_pmos ad=0.3808p pd=2.92u as=0.2128p ps=1.5u w=1.12u l=0.13u
X2955 VDD.t1386 a_2873_16422# a_3171_16074.t0 VDD.t20 sg13_lv_pmos ad=0.4256p pd=3u as=0.2128p ps=1.5u w=1.12u l=0.13u
X2956 a_16510_13226# a_3747_13229.t5 a_18795_13226# VSS.t1730 sg13_lv_nmos ad=0.2516p pd=2.16u as=0.1406p ps=1.12u w=0.74u l=0.13u
X2957 VDD.t451 a_6326_10280# a_6326_10280# VDD.t351 sg13_lv_pmos ad=0.38p pd=2.38u as=0.38p ps=2.38u w=2u l=1u
X2958 VDD.t780 a_4187_2434# a_17031_5315# VDD.t339 sg13_lv_pmos ad=0.3808p pd=2.92u as=0.2128p ps=1.5u w=1.12u l=0.6u
X2959 a_23111_14024# a_22873_14024# a_23003_14024# VSS.t1954 sg13_lv_nmos ad=0.1406p pd=1.12u as=0.2516p ps=2.16u w=0.74u l=0.2u
X2960 VSS.t1594 a_4187_1764.t98 VSS.t1592 VSS.t1577 sg13_lv_nmos ad=1.33p pd=7.38u as=0 ps=0 w=7u l=7u
X2961 a_16510_16071# a_2595_16074.t5 a_17275_16071# VSS.t1852 sg13_lv_nmos ad=0.2516p pd=2.16u as=0.1406p ps=1.12u w=0.74u l=0.13u
X2962 a_15273_1842# a_15077_1842# VDD.t981 VDD.t353 sg13_lv_pmos ad=0.3808p pd=2.92u as=0.2128p ps=1.5u w=1.12u l=0.13u
X2963 a_17031_14652# a_16793_14024# a_16923_14024# VDD.t381 sg13_lv_pmos ad=0.2128p pd=1.5u as=0.3808p ps=2.92u w=1.12u l=0.2u
X2964 VSS.t652 VDD.t1687 VSS.t652 VSS.t653 sg13_lv_nmos ad=0.1428p pd=1.52u as=0 ps=0 w=0.42u l=1u
X2965 a_9444_9602# a_6854_11144# a_9712_9602# VSS.t1240 sg13_lv_nmos ad=0.68p pd=4.68u as=0.38p ps=2.38u w=2u l=1u
X2966 a_7390_6734# a_3747_6737.t8 a_9675_6734# VSS.t1872 sg13_lv_nmos ad=0.2516p pd=2.16u as=0.1406p ps=1.12u w=0.74u l=0.13u
X2967 a_1256_3134# CHAN2_MUX_SEL2 VSS.t1596 VSS.t1595 sg13_lv_nmos ad=0.2516p pd=2.16u as=0.2516p ps=2.16u w=0.74u l=0.13u
X2968 a_1256_13226# CHAN1_MUX_SEL0 VSS.t200 VSS.t478 sg13_lv_nmos ad=0.2516p pd=2.16u as=0.2516p ps=2.16u w=0.74u l=0.13u
X2969 a_13470_13226# a_2595_13229.t6 a_14235_13226# VSS.t1893 sg13_lv_nmos ad=0.2516p pd=2.16u as=0.1406p ps=1.12u w=0.74u l=0.13u
X2970 a_19550_13226# a_21044_13190# a_20968_13226# VDD.t36 sg13_lv_pmos ad=0.3808p pd=2.92u as=0.2128p ps=1.5u w=1.12u l=0.13u
X2971 VDD.t739 a_23763_7532# a_24197_7532# VDD.t341 sg13_lv_pmos ad=0.2128p pd=1.5u as=0.3808p ps=2.92u w=1.12u l=0.13u
X2972 a_6391_2470# a_6153_1842# a_6283_1842# VDD.t353 sg13_lv_pmos ad=0.2128p pd=1.5u as=0.3808p ps=2.92u w=1.12u l=0.2u
X2973 a_11195_3889# a_10985_3889# VSS.t2033 VSS.t2032 sg13_lv_nmos ad=0.1406p pd=1.12u as=0.1665p ps=1.19u w=0.74u l=0.13u
X2974 a_2873_4240# CHAN2_MUX_SEL1 VDD.t399 VDD.t9 sg13_lv_pmos ad=0.1596p pd=1.22u as=0.2856p ps=2.36u w=0.84u l=0.13u
X2975 a_14235_1044# a_14025_1044# VSS.t851 VSS.t850 sg13_lv_nmos ad=0.1406p pd=1.12u as=0.1665p ps=1.19u w=0.74u l=0.13u
X2976 VSS.t745 VDD.t1647 VSS.t745 VSS.t749 sg13_lv_nmos ad=0.1428p pd=1.52u as=0 ps=0 w=0.42u l=1u
X2977 VDD.t1222 a_26803_4687# a_27237_4687# VDD.t339 sg13_lv_pmos ad=0.2128p pd=1.5u as=0.3808p ps=2.92u w=1.12u l=0.13u
X2978 a_11195_16071# a_10985_16071# VDD.t930 VDD.t20 sg13_lv_pmos ad=0.2128p pd=1.5u as=0.252p ps=1.57u w=1.12u l=0.13u
X2979 a_12471_14652# a_12233_14024# a_12363_14024# VDD.t381 sg13_lv_pmos ad=0.2128p pd=1.5u as=0.3808p ps=2.92u w=1.12u l=0.2u
X2980 VDD.t857 a_4187_2434# a_17791_14652# VDD.t381 sg13_lv_pmos ad=0.3808p pd=2.92u as=0.2128p ps=1.5u w=1.12u l=0.6u
X2981 a_10206_11525# a_10649_11568# a_9946_11995# VSS.t1368 sg13_lv_nmos ad=79.8f pd=0.8u as=0.1296p ps=1.52u w=0.42u l=0.13u
X2982 VSS.t1050 a_4187_1764.t91 a_8671_7532# VSS.t1049 sg13_lv_nmos ad=0.2516p pd=2.16u as=0.1406p ps=1.12u w=0.74u l=0.6u
X2983 a_9444_10280# a_9444_10280# VSS.t859 VSS.t858 sg13_lv_nmos ad=0.38p pd=2.38u as=0.68p ps=4.68u w=2u l=1u
X2984 VSS.t363 a_3747_1047.t7 a_12791_1008# VSS.t999 sg13_lv_nmos ad=0.2516p pd=2.16u as=0.2516p ps=2.16u w=0.74u l=0.13u
X2985 a_12993_16869# a_12797_16869# VDD.t679 VDD.t365 sg13_lv_pmos ad=0.3808p pd=2.92u as=0.2128p ps=1.5u w=1.12u l=0.13u
X2986 VSS.t244 a_3171_13229.t8 a_8884_13190# VSS.t2009 sg13_lv_nmos ad=0.2516p pd=2.16u as=0.2516p ps=2.16u w=0.74u l=0.13u
X2987 a_22488_16071# a_21917_16869# VDD.t680 VDD.t20 sg13_lv_pmos ad=0.2128p pd=1.5u as=0.3808p ps=2.92u w=1.12u l=0.13u
X2988 VDD.t812 a_4187_2434# a_13231_14652# VDD.t381 sg13_lv_pmos ad=0.3808p pd=2.92u as=0.2128p ps=1.5u w=1.12u l=0.6u
X2989 VDD.t1124 a_2019_3892.t7 a_10404_3853# VDD.t9 sg13_lv_pmos ad=0.3808p pd=2.92u as=0.3808p ps=2.92u w=1.12u l=0.13u
X2990 a_21591_16869# a_21353_16869# a_21483_16869# VSS.t2229 sg13_lv_nmos ad=0.1406p pd=1.12u as=0.2516p ps=2.16u w=0.74u l=0.2u
X2991 VSS.t989 a_4187_1764.t133 a_26911_16869# VSS.t2379 sg13_lv_nmos ad=0.2516p pd=2.16u as=0.1406p ps=1.12u w=0.74u l=0.6u
X2992 VSS.t379 a_10843_1842# a_11277_1842# VSS.t1663 sg13_lv_nmos ad=0.1406p pd=1.12u as=0.2516p ps=2.16u w=0.74u l=0.13u
X2993 a_9953_1842# a_9757_1842# VSS.t1112 VSS.t1964 sg13_lv_nmos ad=0.2516p pd=2.16u as=0.1406p ps=1.12u w=0.74u l=0.13u
X2994 VSS.t829 VDD.t1623 VSS.t829 VSS.t828 sg13_lv_nmos ad=0.1428p pd=1.52u as=0 ps=0 w=0.42u l=1u
X2995 a_7911_14024# a_7673_14024# a_7803_14024# VSS.t1929 sg13_lv_nmos ad=0.1406p pd=1.12u as=0.2516p ps=2.16u w=0.74u l=0.2u
X2996 VDD.t887 a_4187_2434# a_26911_8160# VDD.t341 sg13_lv_pmos ad=0.3808p pd=2.92u as=0.2128p ps=1.5u w=1.12u l=0.6u
X2997 VDD.t947 a_15403_1842# a_15837_1842# VDD.t353 sg13_lv_pmos ad=0.2128p pd=1.5u as=0.3808p ps=2.92u w=1.12u l=0.13u
X2998 VSS.t223 a_4187_1764.t139 a_22351_16869# VSS.t558 sg13_lv_nmos ad=0.2516p pd=2.16u as=0.1406p ps=1.12u w=0.74u l=0.6u
X2999 a_4350_13226# a_5844_13190# a_5768_13226# VDD.t36 sg13_lv_pmos ad=0.3808p pd=2.92u as=0.2128p ps=1.5u w=1.12u l=0.13u
X3000 a_27433_16869# a_27237_16869# VDD.t684 VDD.t365 sg13_lv_pmos ad=0.3808p pd=2.92u as=0.2128p ps=1.5u w=1.12u l=0.13u
X3001 a_25630_16071# a_27991_16035# a_27915_16071# VDD.t20 sg13_lv_pmos ad=0.3808p pd=2.92u as=0.2128p ps=1.5u w=1.12u l=0.13u
X3002 VDD.t608 VDD.t606 VDD.t604 VDD.t381 sg13_lv_pmos ad=0.2128p pd=1.5u as=0 ps=0 w=1.12u l=0.13u
X3003 VDD.t1290 a_3171_6737.t6 a_14964_6698# VDD.t29 sg13_lv_pmos ad=0.3808p pd=2.92u as=0.3808p ps=2.92u w=1.12u l=0.13u
X3004 a_16108_3134# a_15765_3308# a_15964_3134# VDD.t9 sg13_lv_pmos ad=0.3808p pd=2.92u as=0.3304p ps=1.71u w=1.12u l=0.13u
X3005 VSS.t1008 a_4187_1764.t125 a_8671_14024# VSS.t1717 sg13_lv_nmos ad=0.2516p pd=2.16u as=0.1406p ps=1.12u w=0.74u l=0.6u
X3006 VSS.t429 a_26043_14024# a_26477_14024# VSS.t1657 sg13_lv_nmos ad=0.1406p pd=1.12u as=0.2516p ps=2.16u w=0.74u l=0.13u
X3007 a_3543_13577# CHAN1_MUX_SEL0 a_3449_13577# VSS.t480 sg13_lv_nmos ad=0.1216p pd=1.02u as=0.2176p ps=1.96u w=0.64u l=0.13u
X3008 a_11848_1044# a_11277_1842# VSS.t339 VSS.t380 sg13_lv_nmos ad=0.1406p pd=1.12u as=0.2516p ps=2.16u w=0.74u l=0.13u
X3009 CHAN0_MUX_OUT a_16851_15336# VDD.t1010 VDD.t20 sg13_lv_pmos ad=0.2128p pd=1.5u as=0.2086p ps=1.5u w=1.12u l=0.13u
X3010 VSS.t628 VDD.t1695 VSS.t628 VSS.t629 sg13_lv_nmos ad=79.8f pd=0.8u as=0 ps=0 w=0.42u l=1u
X3011 VDD.t627 VDD.t628 VDD.t629 VDD.t360 sg13_lv_pmos ad=0.2128p pd=1.5u as=0 ps=0 w=1.12u l=0.13u
X3012 VSS.t802 VDD.t1630 VSS.t802 VSS.t801 sg13_lv_nmos ad=0.1428p pd=1.52u as=0 ps=0 w=0.42u l=1u
X3013 a_22590_16071# a_23431_16035# a_23355_16071# VDD.t20 sg13_lv_pmos ad=0.3808p pd=2.92u as=0.2128p ps=1.5u w=1.12u l=0.13u
X3014 a_11491_11918# a_10649_11568# a_10232_11561# VDD.t351 sg13_lv_pmos ad=0.2048p pd=1.63u as=0.34p ps=2.68u w=1u l=0.13u
X3015 VSS.t809 VDD.t1628 VSS.t812 VSS.t811 sg13_lv_nmos ad=79.8f pd=0.8u as=0 ps=0 w=0.42u l=1u
X3016 a_6854_11144# a_6326_10280# VDD.t440 VDD.t351 sg13_lv_pmos ad=0.38p pd=2.38u as=0.38p ps=2.38u w=2u l=1u
X3017 VDD.t1484 a_3449_1395# a_3747_1047.t0 VDD.t0 sg13_lv_pmos ad=0.4256p pd=3u as=0.2128p ps=1.5u w=1.12u l=0.13u
X3018 VDD.t1086 a_8997_16869# a_9465_16071# VDD.t20 sg13_lv_pmos ad=0.252p pd=1.57u as=0.3808p ps=2.92u w=1.12u l=0.13u
X3019 a_13470_1044# a_13444_1008# a_13368_1044# VDD.t0 sg13_lv_pmos ad=0.3808p pd=2.92u as=0.2128p ps=1.5u w=1.12u l=0.13u
X3020 VDD.t980 a_4763_1842# a_5197_1842# VDD.t353 sg13_lv_pmos ad=0.2128p pd=1.5u as=0.3808p ps=2.92u w=1.12u l=0.13u
X3021 a_22590_3889# a_2595_3892.t3 a_23355_3889# VSS.t1740 sg13_lv_nmos ad=0.2516p pd=2.16u as=0.1406p ps=1.12u w=0.74u l=0.13u
X3022 a_27671_4687# a_27433_4687# a_27563_4687# VSS.t2350 sg13_lv_nmos ad=0.1406p pd=1.12u as=0.2516p ps=2.16u w=0.74u l=0.2u
X3023 a_16108_5979# a_26985_6209# a_25630_6734# VDD.t29 sg13_lv_pmos ad=0.3808p pd=2.92u as=0.3808p ps=2.92u w=1.12u l=0.13u
X3024 VDD.t1100 a_15403_14024# a_15837_14024# VDD.t381 sg13_lv_pmos ad=0.2128p pd=1.5u as=0.3808p ps=2.92u w=1.12u l=0.13u
X3025 a_26395_3889# a_26185_3889# VDD.t1049 VDD.t9 sg13_lv_pmos ad=0.2128p pd=1.5u as=0.252p ps=1.57u w=1.12u l=0.13u
X3026 VDD.t163 VSS.t709 VDD.t161 VDD.t29 sg13_lv_pmos ad=0.19p pd=1.38u as=0 ps=0 w=1u l=1u
X3027 a_12471_7532# a_12233_7532# a_12363_7532# VSS.t1153 sg13_lv_nmos ad=0.1406p pd=1.12u as=0.2516p ps=2.16u w=0.74u l=0.2u
X3028 a_19311_5315# a_19073_4687# a_19203_4687# VDD.t339 sg13_lv_pmos ad=0.2128p pd=1.5u as=0.3808p ps=2.92u w=1.12u l=0.2u
X3029 a_11195_6734# a_10985_6734# VDD.t415 VDD.t29 sg13_lv_pmos ad=0.2128p pd=1.5u as=0.252p ps=1.57u w=1.12u l=0.13u
X3030 VDD.t373 a_3747_3892.t3 a_24951_3853# VDD.t9 sg13_lv_pmos ad=0.3808p pd=2.92u as=0.3808p ps=2.92u w=1.12u l=0.13u
X3031 VDD.t1192 a_2595_13229.t7 a_11271_13190# VDD.t36 sg13_lv_pmos ad=0.3808p pd=2.92u as=0.3808p ps=2.92u w=1.12u l=0.13u
X3032 VSS.t2109 a_3171_6737.t5 a_18004_6698# VSS.t2108 sg13_lv_nmos ad=0.2516p pd=2.16u as=0.2516p ps=2.16u w=0.74u l=0.13u
X3033 VDD.t767 a_3171_3156.t3 a_11785_3364# VDD.t9 sg13_lv_pmos ad=0.3808p pd=2.92u as=0.3808p ps=2.92u w=1.12u l=0.13u
X3034 VDD.t995 a_3171_1047.t3 a_24084_1008# VDD.t0 sg13_lv_pmos ad=0.3808p pd=2.92u as=0.3808p ps=2.92u w=1.12u l=0.13u
X3035 a_6153_16869# a_5957_16869# VSS.t215 VSS.t1380 sg13_lv_nmos ad=0.2516p pd=2.16u as=0.1406p ps=1.12u w=0.74u l=0.13u
X3036 a_15755_16071# a_15545_16071# VSS.t342 VSS.t1913 sg13_lv_nmos ad=0.1406p pd=1.12u as=0.1665p ps=1.19u w=0.74u l=0.13u
X3037 a_3449_1395# CHAN3_MUX_SEL0 VDD.t1421 VDD.t0 sg13_lv_pmos ad=0.1596p pd=1.22u as=0.2856p ps=2.36u w=0.84u l=0.13u
X3038 a_2019_12493.t0 a_1721_12513# VDD.t950 VDD.t36 sg13_lv_pmos ad=0.2128p pd=1.5u as=0.1918p ps=1.5u w=1.12u l=0.13u
X3039 a_1721_16422# a_1256_16071# VDD.t1277 VDD.t20 sg13_lv_pmos ad=0.1596p pd=1.22u as=0.2856p ps=2.36u w=0.84u l=0.13u
X3040 a_15273_7532# a_15077_7532# VDD.t431 VDD.t341 sg13_lv_pmos ad=0.3808p pd=2.92u as=0.2128p ps=1.5u w=1.12u l=0.13u
X3041 VDD.t914 a_4187_2434# a_7911_2470# VDD.t353 sg13_lv_pmos ad=0.3808p pd=2.92u as=0.2128p ps=1.5u w=1.12u l=0.6u
X3042 a_13818_10808# a_12849_11557# VSS.t1181 VSS.t1180 sg13_lv_nmos ad=37.8f pd=0.6u as=0.1701p ps=1.65u w=0.42u l=0.13u
X3043 a_6391_8160# a_6153_7532# a_6283_7532# VDD.t341 sg13_lv_pmos ad=0.2128p pd=1.5u as=0.3808p ps=2.92u w=1.12u l=0.2u
X3044 VDD.t60 VSS.t781 VDD.t59 VDD.t0 sg13_lv_pmos ad=0.19p pd=1.38u as=0 ps=0 w=1u l=1u
X3045 VSS.t674 VDD.t1678 VSS.t674 VSS.t676 sg13_lv_nmos ad=79.8f pd=0.8u as=0 ps=0 w=0.42u l=1u
X3046 VSS.t491 a_4187_1764.t49 a_16271_4687# VSS.t1715 sg13_lv_nmos ad=0.2516p pd=2.16u as=0.1406p ps=1.12u w=0.74u l=0.6u
X3047 a_13991_17497# a_13753_16869# a_13883_16869# VDD.t365 sg13_lv_pmos ad=0.2128p pd=1.5u as=0.3808p ps=2.92u w=1.12u l=0.2u
X3048 a_24008_3889# a_23437_4687# VDD.t1084 VDD.t9 sg13_lv_pmos ad=0.2128p pd=1.5u as=0.3808p ps=2.92u w=1.12u l=0.13u
X3049 a_18313_16869# a_18117_16869# VDD.t710 VDD.t365 sg13_lv_pmos ad=0.3808p pd=2.92u as=0.2128p ps=1.5u w=1.12u l=0.13u
X3050 a_14235_6734# a_14025_6734# VSS.t1118 VSS.t1235 sg13_lv_nmos ad=0.1406p pd=1.12u as=0.1665p ps=1.19u w=0.74u l=0.13u
X3051 a_18795_13226# a_18585_13226# VDD.t1061 VDD.t36 sg13_lv_pmos ad=0.2128p pd=1.5u as=0.252p ps=1.57u w=1.12u l=0.13u
X3052 VDD.t823 a_4187_2434# a_14751_17497# VDD.t365 sg13_lv_pmos ad=0.3808p pd=2.92u as=0.2128p ps=1.5u w=1.12u l=0.6u
X3053 VSS.t1749 a_3747_6737.t7 a_12791_6698# VSS.t1768 sg13_lv_nmos ad=0.2516p pd=2.16u as=0.2516p ps=2.16u w=0.74u l=0.13u
X3054 VSS.t1338 a_26043_4687# a_26477_4687# VSS.t2143 sg13_lv_nmos ad=0.1406p pd=1.12u as=0.2516p ps=2.16u w=0.74u l=0.13u
X3055 a_12993_14024# a_12797_14024# VDD.t1057 VDD.t381 sg13_lv_pmos ad=0.3808p pd=2.92u as=0.2128p ps=1.5u w=1.12u l=0.13u
X3056 a_14235_13226# a_14025_13226# VDD.t1006 VDD.t36 sg13_lv_pmos ad=0.2128p pd=1.5u as=0.252p ps=1.57u w=1.12u l=0.13u
X3057 a_23111_5315# a_22873_4687# a_23003_4687# VDD.t339 sg13_lv_pmos ad=0.2128p pd=1.5u as=0.3808p ps=2.92u w=1.12u l=0.2u
X3058 a_9953_7532# a_9757_7532# VSS.t1131 VSS.t1130 sg13_lv_nmos ad=0.2516p pd=2.16u as=0.1406p ps=1.12u w=0.74u l=0.13u
X3059 VDD.t326 VSS.t783 VDD.t325 VDD.t0 sg13_lv_pmos ad=0.34p pd=2.68u as=0 ps=0 w=1u l=1u
X3060 VSS.t187 a_10843_7532# a_11277_7532# VSS.t504 sg13_lv_nmos ad=0.1406p pd=1.12u as=0.2516p ps=2.16u w=0.74u l=0.13u
X3061 VSS.t909 VSS.t909 VSS.t911 VSS.t910 sg13_lv_nmos ad=0.2516p pd=2.16u as=0 ps=0 w=0.74u l=0.13u
X3062 a_22590_6734# a_23431_6698# a_23355_6734# VDD.t29 sg13_lv_pmos ad=0.3808p pd=2.92u as=0.2128p ps=1.5u w=1.12u l=0.13u
X3063 VDD.t1114 a_17683_4687# a_18117_4687# VDD.t339 sg13_lv_pmos ad=0.2128p pd=1.5u as=0.3808p ps=2.92u w=1.12u l=0.13u
X3064 a_4157_7003# REF_CLK VSS.t1776 VSS.t1775 sg13_lv_nmos ad=0.2516p pd=2.16u as=0.2553p ps=2.17u w=0.74u l=0.13u
X3065 a_2595_6001.t0 a_2297_6021# VDD.t724 VDD.t29 sg13_lv_pmos ad=0.2128p pd=1.5u as=0.1918p ps=1.5u w=1.12u l=0.13u
X3066 a_25528_13226# a_24957_14024# VDD.t1589 VDD.t36 sg13_lv_pmos ad=0.2128p pd=1.5u as=0.3808p ps=2.92u w=1.12u l=0.13u
X3067 VDD.t473 a_15403_7532# a_15837_7532# VDD.t341 sg13_lv_pmos ad=0.2128p pd=1.5u as=0.3808p ps=2.92u w=1.12u l=0.13u
X3068 VSS.t177 a_19637_1842# a_20105_1044# VSS.t1889 sg13_lv_nmos ad=0.1665p pd=1.19u as=0.2516p ps=2.16u w=0.74u l=0.13u
X3069 VDD.t1552 a_16851_309# CHAN3_MUX_OUT VDD.t0 sg13_lv_pmos ad=0.7336p pd=3.55u as=0.2128p ps=1.5u w=1.12u l=0.13u
X3070 a_10713_4687# a_10517_4687# VDD.t345 VDD.t339 sg13_lv_pmos ad=0.3808p pd=2.92u as=0.2128p ps=1.5u w=1.12u l=0.13u
X3071 a_21835_16071# a_21625_16071# VDD.t374 VDD.t20 sg13_lv_pmos ad=0.2128p pd=1.5u as=0.252p ps=1.57u w=1.12u l=0.13u
X3072 a_4157_16340# CHAN0_DELAY_IN VSS.t279 VSS.t1607 sg13_lv_nmos ad=0.2516p pd=2.16u as=0.2553p ps=2.17u w=0.74u l=0.13u
X3073 a_1256_12471# CHAN1_MUX_SEL2 VDD.t405 VDD.t36 sg13_lv_pmos ad=0.3808p pd=2.92u as=0.3808p ps=2.92u w=1.12u l=0.13u
X3074 VDD.t1365 a_18117_1842# a_18585_1044# VDD.t0 sg13_lv_pmos ad=0.252p pd=1.57u as=0.3808p ps=2.92u w=1.12u l=0.13u
X3075 a_27433_14024# a_27237_14024# VDD.t461 VDD.t381 sg13_lv_pmos ad=0.3808p pd=2.92u as=0.2128p ps=1.5u w=1.12u l=0.13u
X3076 a_11848_6734# a_11277_7532# VSS.t185 VSS.t184 sg13_lv_nmos ad=0.1406p pd=1.12u as=0.2516p ps=2.16u w=0.74u l=0.13u
X3077 VSS.t424 a_3171_311.t2 a_23945_519# VSS.t423 sg13_lv_nmos ad=0.2516p pd=2.16u as=0.2516p ps=2.16u w=0.74u l=0.13u
X3078 VSS.t1523 a_4187_1764.t44 a_20071_4687# VSS.t2094 sg13_lv_nmos ad=0.2516p pd=2.16u as=0.1406p ps=1.12u w=0.74u l=0.6u
X3079 a_11711_2470# a_11473_1842# a_11603_1842# VDD.t353 sg13_lv_pmos ad=0.2128p pd=1.5u as=0.3808p ps=2.92u w=1.12u l=0.2u
X3080 VSS.t1539 a_2019_3892.t7 a_10404_3853# VSS.t1538 sg13_lv_nmos ad=0.2516p pd=2.16u as=0.2516p ps=2.16u w=0.74u l=0.13u
X3081 VSS.t59 a_10843_16869# a_11277_16869# VSS.t1476 sg13_lv_nmos ad=0.1406p pd=1.12u as=0.2516p ps=2.16u w=0.74u l=0.13u
X3082 VSS.t2177 a_16597_14024# a_17065_13226# VSS.t2176 sg13_lv_nmos ad=0.1665p pd=1.19u as=0.2516p ps=2.16u w=0.74u l=0.13u
X3083 VDD.t427 a_4763_7532# a_5197_7532# VDD.t341 sg13_lv_pmos ad=0.2128p pd=1.5u as=0.3808p ps=2.92u w=1.12u l=0.13u
X3084 a_27671_1842# a_27433_1842# a_27563_1842# VSS.t2132 sg13_lv_nmos ad=0.1406p pd=1.12u as=0.2516p ps=2.16u w=0.74u l=0.2u
X3085 VDD.t1108 a_7803_4687# a_8237_4687# VDD.t339 sg13_lv_pmos ad=0.2128p pd=1.5u as=0.3808p ps=2.92u w=1.12u l=0.13u
X3086 a_7151_16869# a_6913_16869# a_7043_16869# VSS.t2172 sg13_lv_nmos ad=0.1406p pd=1.12u as=0.2516p ps=2.16u w=0.74u l=0.2u
X3087 a_14888_13226# a_14317_14024# VSS.t1895 VSS.t1944 sg13_lv_nmos ad=0.1406p pd=1.12u as=0.2516p ps=2.16u w=0.74u l=0.13u
X3088 a_16108_3134# a_26985_3364# a_25630_3889# VDD.t9 sg13_lv_pmos ad=0.3808p pd=2.92u as=0.3808p ps=2.92u w=1.12u l=0.13u
X3089 VDD.t126 VSS.t100 VDD.t124 VDD.t9 sg13_lv_pmos ad=0.19p pd=1.38u as=0 ps=0 w=1u l=1u
X3090 a_1256_3889# CHAN2_MUX_SEL0 VDD.t960 VDD.t9 sg13_lv_pmos ad=0.3808p pd=2.92u as=0.3808p ps=2.92u w=1.12u l=0.13u
X3091 VDD.t1069 a_3747_6001.t2 a_26985_6209# VDD.t29 sg13_lv_pmos ad=0.3808p pd=2.92u as=0.3808p ps=2.92u w=1.12u l=0.13u
X3092 a_13368_16071# a_12797_16869# VSS.t29 VSS.t978 sg13_lv_nmos ad=0.1406p pd=1.12u as=0.2516p ps=2.16u w=0.74u l=0.13u
X3093 VSS.t920 VSS.t917 VSS.t917 VSS.t918 sg13_lv_nmos ad=0.1406p pd=1.12u as=0 ps=0 w=0.74u l=0.13u
X3094 a_10328_13226# a_9757_14024# VSS.t372 VSS.t371 sg13_lv_nmos ad=0.1406p pd=1.12u as=0.2516p ps=2.16u w=0.74u l=0.13u
X3095 VSS.t1551 CHAN3_MUX_SEL4 a_15765_463# VSS.t1550 sg13_lv_nmos ad=0.2516p pd=2.16u as=0.2516p ps=2.16u w=0.74u l=0.13u
X3096 a_24631_14024# a_24393_14024# a_24523_14024# VSS.t2330 sg13_lv_nmos ad=0.1406p pd=1.12u as=0.2516p ps=2.16u w=0.74u l=0.2u
X3097 a_16108_12471# a_2595_12493.t2 a_19550_13226# VSS.t2264 sg13_lv_nmos ad=0.2516p pd=2.16u as=0.2516p ps=2.16u w=0.74u l=0.13u
X3098 a_19311_17497# a_19073_16869# a_19203_16869# VDD.t365 sg13_lv_pmos ad=0.2128p pd=1.5u as=0.3808p ps=2.92u w=1.12u l=0.2u
X3099 a_16510_1044# a_2595_1047.t5 a_17275_1044# VSS.t1699 sg13_lv_nmos ad=0.2516p pd=2.16u as=0.1406p ps=1.12u w=0.74u l=0.13u
X3100 a_5731_289# a_14825_519# a_13470_1044# VDD.t0 sg13_lv_pmos ad=0.3808p pd=2.92u as=0.3808p ps=2.92u w=1.12u l=0.13u
X3101 a_16510_16071# a_3747_16074.t5 a_18795_16071# VSS.t2192 sg13_lv_nmos ad=0.2516p pd=2.16u as=0.1406p ps=1.12u w=0.74u l=0.13u
X3102 a_13306_11995# a_14111_11568# a_13566_11525# VDD.t351 sg13_lv_pmos ad=0.1428p pd=1.52u as=79.8f ps=0.8u w=0.42u l=0.13u
X3103 VDD.t1021 a_2019_6001.t3 a_5705_6209# VDD.t29 sg13_lv_pmos ad=0.3808p pd=2.92u as=0.3808p ps=2.92u w=1.12u l=0.13u
X3104 a_22590_13226# a_22564_13190# a_22488_13226# VDD.t36 sg13_lv_pmos ad=0.3808p pd=2.92u as=0.2128p ps=1.5u w=1.12u l=0.13u
X3105 a_13470_13226# a_3747_13229.t6 a_15755_13226# VSS.t1835 sg13_lv_nmos ad=0.2516p pd=2.16u as=0.1406p ps=1.12u w=0.74u l=0.13u
X3106 a_5974_11413# a_6126_9506# VSS.t960 VSS.t959 sg13_lv_nmos ad=0.38p pd=2.38u as=0.68p ps=4.68u w=2u l=1u
X3107 VDD.t877 a_4187_2434# a_7911_8160# VDD.t341 sg13_lv_pmos ad=0.3808p pd=2.92u as=0.2128p ps=1.5u w=1.12u l=0.6u
X3108 VSS.t100 VDD.t1644 VSS.t100 VSS.t755 sg13_lv_nmos ad=0.1428p pd=1.52u as=0 ps=0 w=0.42u l=1u
X3109 a_26395_3889# a_26185_3889# VSS.t1405 VSS.t1949 sg13_lv_nmos ad=0.1406p pd=1.12u as=0.1665p ps=1.19u w=0.74u l=0.13u
X3110 a_20071_14024# a_19833_14024# a_19963_14024# VSS.t1423 sg13_lv_nmos ad=0.1406p pd=1.12u as=0.2516p ps=2.16u w=0.74u l=0.2u
X3111 VSS.t570 a_4187_1764.t103 a_25391_14024# VSS.t569 sg13_lv_nmos ad=0.2516p pd=2.16u as=0.1406p ps=1.12u w=0.74u l=0.6u
X3112 a_16408_13226# a_15837_14024# VDD.t1101 VDD.t36 sg13_lv_pmos ad=0.2128p pd=1.5u as=0.3808p ps=2.92u w=1.12u l=0.13u
X3113 VDD.t144 VSS.t674 VDD.t143 VDD.t36 sg13_lv_pmos ad=0.34p pd=2.68u as=0 ps=0 w=1u l=1u
X3114 a_13470_3889# a_14964_3853# a_14888_3889# VDD.t9 sg13_lv_pmos ad=0.3808p pd=2.92u as=0.2128p ps=1.5u w=1.12u l=0.13u
X3115 a_1256_16071# CHAN0_MUX_SEL0 VSS.t327 VSS.t2300 sg13_lv_nmos ad=0.2516p pd=2.16u as=0.2516p ps=2.16u w=0.74u l=0.13u
X3116 VDD.t398 VSS.t598 VDD.t118 VDD.t20 sg13_lv_pmos ad=0.19p pd=1.38u as=0 ps=0 w=1u l=1u
X3117 a_13470_16071# a_2595_16074.t6 a_14235_16071# VSS.t323 sg13_lv_nmos ad=0.2516p pd=2.16u as=0.1406p ps=1.12u w=0.74u l=0.13u
X3118 a_12715_16071# a_12505_16071# VDD.t1089 VDD.t20 sg13_lv_pmos ad=0.2128p pd=1.5u as=0.252p ps=1.57u w=1.12u l=0.13u
X3119 VDD.t25 VSS.t424 VDD.t67 VDD.t0 sg13_lv_pmos ad=0.34p pd=2.68u as=0 ps=0 w=1u l=1u
X3120 VSS.t1105 a_4187_1764.t17 a_16271_1842# VSS.t1104 sg13_lv_nmos ad=0.2516p pd=2.16u as=0.1406p ps=1.12u w=0.74u l=0.6u
X3121 VSS.t79 a_3747_3892.t3 a_24951_3853# VSS.t78 sg13_lv_nmos ad=0.2516p pd=2.16u as=0.2516p ps=2.16u w=0.74u l=0.13u
X3122 a_13991_14652# a_13753_14024# a_13883_14024# VDD.t381 sg13_lv_pmos ad=0.2128p pd=1.5u as=0.3808p ps=2.92u w=1.12u l=0.2u
X3123 VDD.t994 a_3171_1047.t6 a_14964_1008# VDD.t0 sg13_lv_pmos ad=0.3808p pd=2.92u as=0.3808p ps=2.92u w=1.12u l=0.13u
X3124 a_5731_3134# a_2019_3156.t3 a_4350_3889# VSS.t986 sg13_lv_nmos ad=0.2516p pd=2.16u as=0.2516p ps=2.16u w=0.74u l=0.13u
X3125 a_18313_14024# a_18117_14024# VDD.t1060 VDD.t381 sg13_lv_pmos ad=0.3808p pd=2.92u as=0.2128p ps=1.5u w=1.12u l=0.13u
X3126 VDD.t439 a_6326_10280# a_6126_9506# VDD.t351 sg13_lv_pmos ad=0.38p pd=2.38u as=0.38p ps=2.38u w=2u l=1u
X3127 VSS.t997 a_3747_1047.t2 a_27991_1008# VSS.t996 sg13_lv_nmos ad=0.2516p pd=2.16u as=0.2516p ps=2.16u w=0.74u l=0.13u
X3128 VDD.t1346 a_10083_1842# a_10517_1842# VDD.t353 sg13_lv_pmos ad=0.2128p pd=1.5u as=0.3808p ps=2.92u w=1.12u l=0.13u
X3129 VDD.t1003 a_25717_16869# a_26185_16071# VDD.t20 sg13_lv_pmos ad=0.252p pd=1.57u as=0.3808p ps=2.92u w=1.12u l=0.13u
X3130 VSS.t196 CHAN1_MUX_SEL4 a_15765_12645# VSS.t195 sg13_lv_nmos ad=0.2516p pd=2.16u as=0.2516p ps=2.16u w=0.74u l=0.13u
X3131 a_9444_10280# a_6854_11144# a_6854_11144# VSS.t1240 sg13_lv_nmos ad=0.68p pd=4.68u as=0.38p ps=2.38u w=2u l=1u
X3132 a_17553_4687# a_17357_4687# VSS.t1074 VSS.t2268 sg13_lv_nmos ad=0.2516p pd=2.16u as=0.1406p ps=1.12u w=0.74u l=0.13u
X3133 a_2297_16422# CHAN0_MUX_SEL0 VDD.t1572 VDD.t20 sg13_lv_pmos ad=0.1596p pd=1.22u as=0.2856p ps=2.36u w=0.84u l=0.13u
X3134 a_24008_16071# a_23437_16869# VDD.t377 VDD.t20 sg13_lv_pmos ad=0.2128p pd=1.5u as=0.3808p ps=2.92u w=1.12u l=0.13u
X3135 a_8671_4687# a_8433_4687# a_8563_4687# VSS.t1019 sg13_lv_nmos ad=0.1406p pd=1.12u as=0.2516p ps=2.16u w=0.74u l=0.2u
X3136 VDD.t807 a_4187_2434# a_14751_14652# VDD.t381 sg13_lv_pmos ad=0.3808p pd=2.92u as=0.2128p ps=1.5u w=1.12u l=0.6u
X3137 VDD.t1307 a_2019_3892.t2 a_25604_3853# VDD.t9 sg13_lv_pmos ad=0.3808p pd=2.92u as=0.3808p ps=2.92u w=1.12u l=0.13u
X3138 VSS.t402 a_3171_16074.t8 a_8884_16035# VSS.t401 sg13_lv_nmos ad=0.2516p pd=2.16u as=0.2516p ps=2.16u w=0.74u l=0.13u
X3139 VSS.t546 a_26043_1842# a_26477_1842# VSS.t2131 sg13_lv_nmos ad=0.1406p pd=1.12u as=0.2516p ps=2.16u w=0.74u l=0.13u
X3140 VDD.t724 a_1544_5979# a_2297_6021# VDD.t29 sg13_lv_pmos ad=0.1918p pd=1.5u as=0.1596p ps=1.22u w=0.84u l=0.13u
X3141 VDD.t719 a_2019_6737.t7 a_10404_6698# VDD.t29 sg13_lv_pmos ad=0.3808p pd=2.92u as=0.3808p ps=2.92u w=1.12u l=0.13u
X3142 a_16510_13226# a_17351_13190# a_17275_13226# VDD.t36 sg13_lv_pmos ad=0.3808p pd=2.92u as=0.2128p ps=1.5u w=1.12u l=0.13u
X3143 VSS.t994 a_3747_1047.t9 a_6711_1008# VSS.t993 sg13_lv_nmos ad=0.2516p pd=2.16u as=0.2516p ps=2.16u w=0.74u l=0.13u
X3144 VSS.t426 a_4187_1764.t137 a_23871_16869# VSS.t1145 sg13_lv_nmos ad=0.2516p pd=2.16u as=0.1406p ps=1.12u w=0.74u l=0.6u
X3145 a_11195_1044# a_10985_1044# VDD.t1530 VDD.t0 sg13_lv_pmos ad=0.2128p pd=1.5u as=0.252p ps=1.57u w=1.12u l=0.13u
X3146 a_24008_3889# a_23437_4687# VSS.t1466 VSS.t1465 sg13_lv_nmos ad=0.1406p pd=1.12u as=0.2516p ps=2.16u w=0.74u l=0.13u
X3147 a_4871_14024# a_4633_14024# a_4763_14024# VSS.t1543 sg13_lv_nmos ad=0.1406p pd=1.12u as=0.2516p ps=2.16u w=0.74u l=0.2u
X3148 VDD.t157 VSS.t643 VDD.t156 VDD.t36 sg13_lv_pmos ad=0.34p pd=2.68u as=0 ps=0 w=1u l=1u
X3149 VSS.t117 a_19637_7532# a_20105_6734# VSS.t514 sg13_lv_nmos ad=0.1665p pd=1.19u as=0.2516p ps=2.16u w=0.74u l=0.13u
X3150 a_2595_3156.t1 a_2297_3176# VSS.t93 VSS.t1274 sg13_lv_nmos ad=0.1406p pd=1.12u as=0.1331p ps=1.12u w=0.74u l=0.13u
X3151 a_9193_14024# a_8997_14024# VSS.t1008 VSS.t1007 sg13_lv_nmos ad=0.2516p pd=2.16u as=0.1406p ps=1.12u w=0.74u l=0.13u
X3152 a_16108_289# a_2595_311.t2 a_19550_1044# VSS.t419 sg13_lv_nmos ad=0.2516p pd=2.16u as=0.2516p ps=2.16u w=0.74u l=0.13u
X3153 a_3543_16422# CHAN0_MUX_SEL0 a_3449_16422# VSS.t2302 sg13_lv_nmos ad=0.1216p pd=1.02u as=0.2176p ps=1.96u w=0.64u l=0.13u
X3154 a_22590_16071# a_24951_16035# a_24875_16071# VDD.t20 sg13_lv_pmos ad=0.3808p pd=2.92u as=0.2128p ps=1.5u w=1.12u l=0.13u
X3155 a_21835_3889# a_21625_3889# VDD.t363 VDD.t9 sg13_lv_pmos ad=0.2128p pd=1.5u as=0.252p ps=1.57u w=1.12u l=0.13u
X3156 VSS.t1048 a_4187_1764.t129 a_5631_14024# VSS.t1047 sg13_lv_nmos ad=0.2516p pd=2.16u as=0.1406p ps=1.12u w=0.74u l=0.6u
X3157 a_5731_12471# a_3171_12493.t3 a_10430_13226# VSS.t1658 sg13_lv_nmos ad=0.2516p pd=2.16u as=0.2516p ps=2.16u w=0.74u l=0.13u
X3158 a_11711_8160# a_11473_7532# a_11603_7532# VDD.t341 sg13_lv_pmos ad=0.2128p pd=1.5u as=0.3808p ps=2.92u w=1.12u l=0.2u
X3159 VSS.t281 a_23003_14024# a_23437_14024# VSS.t1432 sg13_lv_nmos ad=0.1406p pd=1.12u as=0.2516p ps=2.16u w=0.74u l=0.13u
X3160 VSS.t464 a_4187_1764.t12 a_20071_1842# VSS.t463 sg13_lv_nmos ad=0.2516p pd=2.16u as=0.1406p ps=1.12u w=0.74u l=0.6u
X3161 a_16108_15316# a_2019_15338.t2 a_16510_16071# VSS.t436 sg13_lv_nmos ad=0.2516p pd=2.16u as=0.2516p ps=2.16u w=0.74u l=0.13u
X3162 a_14751_5315# a_14513_4687# a_14643_4687# VDD.t339 sg13_lv_pmos ad=0.2128p pd=1.5u as=0.3808p ps=2.92u w=1.12u l=0.2u
X3163 VDD.t1095 a_2595_3892.t4 a_20391_3853# VDD.t9 sg13_lv_pmos ad=0.3808p pd=2.92u as=0.3808p ps=2.92u w=1.12u l=0.13u
X3164 VSS.t616 VDD.t1698 VSS.t616 VSS.t617 sg13_lv_nmos ad=79.8f pd=0.8u as=0 ps=0 w=0.42u l=1u
X3165 a_27671_7532# a_27433_7532# a_27563_7532# VSS.t1372 sg13_lv_nmos ad=0.1406p pd=1.12u as=0.2516p ps=2.16u w=0.74u l=0.2u
X3166 VDD.t923 a_4187_2434# a_24631_2470# VDD.t353 sg13_lv_pmos ad=0.3808p pd=2.92u as=0.2128p ps=1.5u w=1.12u l=0.6u
X3167 a_21353_4687# a_21157_4687# VSS.t56 VSS.t55 sg13_lv_nmos ad=0.2516p pd=2.16u as=0.1406p ps=1.12u w=0.74u l=0.13u
X3168 VSS.t396 VDD.t1660 VSS.t396 VSS.t718 sg13_lv_nmos ad=79.8f pd=0.8u as=0 ps=0 w=0.42u l=1u
X3169 a_26395_6734# a_26185_6734# VDD.t488 VDD.t29 sg13_lv_pmos ad=0.2128p pd=1.5u as=0.252p ps=1.57u w=1.12u l=0.13u
X3170 VSS.t873 VSS.t873 VSS.t875 VSS.t874 sg13_lv_nmos ad=0.2516p pd=2.16u as=0 ps=0 w=0.74u l=0.13u
X3171 VDD.t651 VDD.t649 VDD.t647 VDD.t339 sg13_lv_pmos ad=0.2128p pd=1.5u as=0 ps=0 w=1.12u l=0.13u
X3172 VDD.t965 a_3747_3156.t2 a_26985_3364# VDD.t9 sg13_lv_pmos ad=0.3808p pd=2.92u as=0.3808p ps=2.92u w=1.12u l=0.13u
X3173 a_7673_16869# a_7477_16869# VSS.t1211 VSS.t1526 sg13_lv_nmos ad=0.2516p pd=2.16u as=0.1406p ps=1.12u w=0.74u l=0.13u
X3174 VDD.t1393 a_10517_4687# a_10985_3889# VDD.t9 sg13_lv_pmos ad=0.252p pd=1.57u as=0.3808p ps=2.92u w=1.12u l=0.13u
X3175 VDD.t1249 a_3747_6737.t3 a_24951_6698# VDD.t29 sg13_lv_pmos ad=0.3808p pd=2.92u as=0.3808p ps=2.92u w=1.12u l=0.13u
X3176 VSS.t127 a_7043_4687# a_7477_4687# VSS.t126 sg13_lv_nmos ad=0.1406p pd=1.12u as=0.2516p ps=2.16u w=0.74u l=0.13u
X3177 a_4111_5315# CHAN2_DELAY_IN a_4003_4687# VDD.t339 sg13_lv_pmos ad=0.2128p pd=1.5u as=0.3808p ps=2.92u w=1.12u l=0.2u
X3178 a_2019_15338.t0 a_1721_15358# VDD.t1446 VDD.t20 sg13_lv_pmos ad=0.2128p pd=1.5u as=0.1918p ps=1.5u w=1.12u l=0.13u
X3179 a_16510_6734# a_2595_6737.t5 a_17275_6734# VSS.t1436 sg13_lv_nmos ad=0.2516p pd=2.16u as=0.1406p ps=1.12u w=0.74u l=0.13u
X3180 a_2019_15338.t1 a_1721_15358# VSS.t2114 VSS.t2064 sg13_lv_nmos ad=0.1406p pd=1.12u as=0.1331p ps=1.12u w=0.74u l=0.13u
X3181 a_19311_14652# a_19073_14024# a_19203_14024# VDD.t381 sg13_lv_pmos ad=0.2128p pd=1.5u as=0.3808p ps=2.92u w=1.12u l=0.2u
X3182 a_11748_11799# DLL_RESETN VDD.t352 VDD.t351 sg13_lv_pmos ad=79.8f pd=0.8u as=1.10612p ps=6.66u w=0.42u l=0.13u
X3183 VDD.t683 a_2019_3156.t3 a_5705_3364# VDD.t9 sg13_lv_pmos ad=0.3808p pd=2.92u as=0.3808p ps=2.92u w=1.12u l=0.13u
X3184 a_12355_11557# a_12158_11557# VDD.t559 VDD.t351 sg13_lv_pmos ad=0.3808p pd=2.92u as=0.2128p ps=1.5u w=1.12u l=0.13u
X3185 a_22590_1044# a_23431_1008# a_23355_1044# VDD.t0 sg13_lv_pmos ad=0.3808p pd=2.92u as=0.2128p ps=1.5u w=1.12u l=0.13u
X3186 a_1256_3889# CHAN2_MUX_SEL0 VSS.t122 VSS.t169 sg13_lv_nmos ad=0.2516p pd=2.16u as=0.2516p ps=2.16u w=0.74u l=0.13u
X3187 VDD.t1282 a_2019_6001.t2 a_17865_6209# VDD.t29 sg13_lv_pmos ad=0.3808p pd=2.92u as=0.3808p ps=2.92u w=1.12u l=0.13u
X3188 a_15304_10295# a_14851_11918# VSS.t267 VSS.t266 sg13_lv_nmos ad=0.2849p pd=2.25u as=0.2516p ps=2.16u w=0.74u l=0.13u
X3189 a_2297_3176# CHAN2_MUX_SEL2 VDD.t1137 VDD.t9 sg13_lv_pmos ad=0.1596p pd=1.22u as=0.2856p ps=2.36u w=0.84u l=0.13u
X3190 a_14851_11918# a_14009_11568# a_14757_11918# VSS.t266 sg13_lv_nmos ad=0.12665p pd=1.145u as=0.1428p ps=1.52u w=0.42u l=0.13u
X3191 VSS.t113 a_4187_1764.t81 a_16271_7532# VSS.t441 sg13_lv_nmos ad=0.2516p pd=2.16u as=0.1406p ps=1.12u w=0.74u l=0.6u
X3192 a_24008_6734# a_23437_7532# VDD.t1025 VDD.t29 sg13_lv_pmos ad=0.2128p pd=1.5u as=0.3808p ps=2.92u w=1.12u l=0.13u
X3193 VSS.t882 VSS.t879 VSS.t881 VSS.t880 sg13_lv_nmos ad=0.2516p pd=2.16u as=0 ps=0 w=0.74u l=0.6u
X3194 VSS.t794 VDD.t1632 VSS.t794 VSS.t795 sg13_lv_nmos ad=79.8f pd=0.8u as=0 ps=0 w=0.42u l=1u
X3195 VSS.t142 a_4187_1764.t155 a_10191_16869# VSS.t141 sg13_lv_nmos ad=0.2516p pd=2.16u as=0.1406p ps=1.12u w=0.74u l=0.6u
X3196 a_20593_14024# a_20397_14024# VSS.t529 VSS.t1427 sg13_lv_nmos ad=0.2516p pd=2.16u as=0.1406p ps=1.12u w=0.74u l=0.13u
X3197 VSS.t1766 a_3747_6737.t2 a_27991_6698# VSS.t1765 sg13_lv_nmos ad=0.2516p pd=2.16u as=0.2516p ps=2.16u w=0.74u l=0.13u
X3198 VDD.t940 a_1544_3134# a_1721_3176# VDD.t9 sg13_lv_pmos ad=0.1918p pd=1.5u as=0.1596p ps=1.22u w=0.84u l=0.13u
X3199 a_10951_17497# a_10713_16869# a_10843_16869# VDD.t365 sg13_lv_pmos ad=0.2128p pd=1.5u as=0.3808p ps=2.92u w=1.12u l=0.2u
X3200 VDD.t525 a_10083_7532# a_10517_7532# VDD.t341 sg13_lv_pmos ad=0.2128p pd=1.5u as=0.3808p ps=2.92u w=1.12u l=0.13u
X3201 a_15273_16869# a_15077_16869# VDD.t509 VDD.t365 sg13_lv_pmos ad=0.3808p pd=2.92u as=0.2128p ps=1.5u w=1.12u l=0.13u
X3202 VSS.t1279 a_13883_14024# a_14317_14024# VSS.t1278 sg13_lv_nmos ad=0.1406p pd=1.12u as=0.2516p ps=2.16u w=0.74u l=0.13u
X3203 VSS.t45 a_11491_11918# a_12158_11557# VSS.t1157 sg13_lv_nmos ad=0.1406p pd=1.12u as=0.2516p ps=2.16u w=0.74u l=0.13u
X3204 VDD.t1252 a_13123_4687# a_13557_4687# VDD.t339 sg13_lv_pmos ad=0.2128p pd=1.5u as=0.3808p ps=2.92u w=1.12u l=0.13u
X3205 a_15755_13226# a_15545_13226# VDD.t1429 VDD.t36 sg13_lv_pmos ad=0.2128p pd=1.5u as=0.252p ps=1.57u w=1.12u l=0.13u
X3206 a_17553_1842# a_17357_1842# VSS.t236 VSS.t1982 sg13_lv_nmos ad=0.2516p pd=2.16u as=0.1406p ps=1.12u w=0.74u l=0.13u
X3207 VSS.t1816 a_26043_7532# a_26477_7532# VSS.t2266 sg13_lv_nmos ad=0.1406p pd=1.12u as=0.2516p ps=2.16u w=0.74u l=0.13u
X3208 a_8671_1842# a_8433_1842# a_8563_1842# VSS.t289 sg13_lv_nmos ad=0.1406p pd=1.12u as=0.2516p ps=2.16u w=0.74u l=0.2u
X3209 VSS.t43 a_16851_5999# REF_MUX_OUT VSS.t115 sg13_lv_nmos ad=0.2516p pd=2.16u as=0.1406p ps=1.12u w=0.74u l=0.13u
X3210 VSS.t593 VDD.t1704 VSS.t593 VSS.t594 sg13_lv_nmos ad=79.8f pd=0.8u as=0 ps=0 w=0.42u l=1u
X3211 a_1544_12471# CHAN1_MUX_SEL3 VSS.t129 VSS.t1785 sg13_lv_nmos ad=0.2516p pd=2.16u as=0.2516p ps=2.16u w=0.74u l=0.13u
X3212 a_5731_289# a_5705_519# a_4350_1044# VDD.t0 sg13_lv_pmos ad=0.3808p pd=2.92u as=0.3808p ps=2.92u w=1.12u l=0.13u
X3213 a_10430_16071# a_11271_16035# a_11195_16071# VDD.t20 sg13_lv_pmos ad=0.3808p pd=2.92u as=0.2128p ps=1.5u w=1.12u l=0.13u
X3214 VSS.t161 a_3449_12513# a_3747_12493.t1 VSS.t1295 sg13_lv_nmos ad=0.2812p pd=2.24u as=0.1406p ps=1.12u w=0.74u l=0.13u
X3215 a_10520_11982# a_10751_11568# a_10206_11525# VSS.t1368 sg13_lv_nmos ad=0.2373p pd=1.97u as=79.8f ps=0.8u w=0.42u l=0.13u
X3216 a_9712_9602# a_13019_11521# a_4187_1764.t1 VSS.t319 sg13_lv_nmos ad=0.136p pd=1.14u as=0.232p ps=2.08u w=0.4u l=0.2u
X3217 VSS.t16 a_3747_6737.t9 a_6711_6698# VSS.t1763 sg13_lv_nmos ad=0.2516p pd=2.16u as=0.2516p ps=2.16u w=0.74u l=0.13u
X3218 a_13470_3889# a_3171_3892.t6 a_14888_3889# VSS.t1670 sg13_lv_nmos ad=0.2516p pd=2.16u as=0.1406p ps=1.12u w=0.74u l=0.13u
X3219 a_25913_4687# a_25717_4687# VDD.t999 VDD.t339 sg13_lv_pmos ad=0.3808p pd=2.92u as=0.2128p ps=1.5u w=1.12u l=0.13u
X3220 VSS.t967 a_6126_9506# a_5974_11413# VSS.t959 sg13_lv_nmos ad=0.68p pd=4.68u as=0.38p ps=2.38u w=2u l=1u
X3221 VSS.t604 VDD.t1701 VSS.t604 VSS.t603 sg13_lv_nmos ad=0.1428p pd=1.52u as=0 ps=0 w=0.42u l=1u
X3222 VSS.t745 VDD.t1649 VSS.t745 VSS.t744 sg13_lv_nmos ad=0.1428p pd=1.52u as=0 ps=0 w=0.42u l=1u
X3223 a_1256_5979# REF_MUX_SEL2 VDD.t419 VDD.t29 sg13_lv_pmos ad=0.3808p pd=2.92u as=0.3808p ps=2.92u w=1.12u l=0.13u
X3224 VDD.t659 VDD.t657 VDD.t658 VDD.t353 sg13_lv_pmos ad=0.3808p pd=2.92u as=0 ps=0 w=1.12u l=0.13u
X3225 VDD.t1536 a_3171_16074.t9 a_5844_16035# VDD.t20 sg13_lv_pmos ad=0.3808p pd=2.92u as=0.3808p ps=2.92u w=1.12u l=0.13u
X3226 a_1256_15316# CHAN0_MUX_SEL2 VDD.t1164 VDD.t20 sg13_lv_pmos ad=0.3808p pd=2.92u as=0.3808p ps=2.92u w=1.12u l=0.13u
X3227 a_26911_2470# a_26673_1842# a_26803_1842# VDD.t353 sg13_lv_pmos ad=0.2128p pd=1.5u as=0.3808p ps=2.92u w=1.12u l=0.2u
X3228 VDD.t1375 a_3747_3892.t5 a_18871_3853# VDD.t9 sg13_lv_pmos ad=0.3808p pd=2.92u as=0.3808p ps=2.92u w=1.12u l=0.13u
X3229 VSS.t980 a_12363_16869# a_12797_16869# VSS.t2355 sg13_lv_nmos ad=0.1406p pd=1.12u as=0.2516p ps=2.16u w=0.74u l=0.13u
X3230 VSS.t1908 a_2019_3892.t2 a_25604_3853# VSS.t1907 sg13_lv_nmos ad=0.2516p pd=2.16u as=0.2516p ps=2.16u w=0.74u l=0.13u
X3231 VSS.t1024 a_4187_1764.t76 a_20071_7532# VSS.t2240 sg13_lv_nmos ad=0.2516p pd=2.16u as=0.1406p ps=1.12u w=0.74u l=0.6u
X3232 VSS.t1420 a_18117_14024# a_18585_13226# VSS.t1419 sg13_lv_nmos ad=0.1665p pd=1.19u as=0.2516p ps=2.16u w=0.74u l=0.13u
X3233 VDD.t108 VSS.t396 VDD.t106 VDD.t29 sg13_lv_pmos ad=0.19p pd=1.38u as=0 ps=0 w=1u l=1u
X3234 a_8671_16869# a_8433_16869# a_8563_16869# VSS.t977 sg13_lv_nmos ad=0.1406p pd=1.12u as=0.2516p ps=2.16u w=0.74u l=0.2u
X3235 a_2595_6737.t0 a_2297_7085# VDD.t481 VDD.t29 sg13_lv_pmos ad=0.2128p pd=1.5u as=0.1918p ps=1.5u w=1.12u l=0.13u
X3236 a_7390_1044# a_2019_1047.t8 a_7288_1044# VSS.t1878 sg13_lv_nmos ad=0.2516p pd=2.16u as=0.1406p ps=1.12u w=0.74u l=0.13u
X3237 VDD.t869 a_4187_2434# a_24631_8160# VDD.t341 sg13_lv_pmos ad=0.3808p pd=2.92u as=0.2128p ps=1.5u w=1.12u l=0.6u
X3238 VSS.t2030 a_16597_16869# a_17065_16071# VSS.t2354 sg13_lv_nmos ad=0.1665p pd=1.19u as=0.2516p ps=2.16u w=0.74u l=0.13u
X3239 a_14888_16071# a_14317_16869# VSS.t325 VSS.t1194 sg13_lv_nmos ad=0.1406p pd=1.12u as=0.2516p ps=2.16u w=0.74u l=0.13u
X3240 a_1256_6734# REF_MUX_SEL0 VDD.t741 VDD.t29 sg13_lv_pmos ad=0.3808p pd=2.92u as=0.3808p ps=2.92u w=1.12u l=0.13u
X3241 a_21353_1842# a_21157_1842# VSS.t383 VSS.t2371 sg13_lv_nmos ad=0.2516p pd=2.16u as=0.1406p ps=1.12u w=0.74u l=0.13u
X3242 VSS.t431 a_3171_13229.t2 a_27124_13190# VSS.t1892 sg13_lv_nmos ad=0.2516p pd=2.16u as=0.2516p ps=2.16u w=0.74u l=0.13u
X3243 a_13991_4687# a_13753_4687# a_13883_4687# VSS.t10 sg13_lv_nmos ad=0.1406p pd=1.12u as=0.2516p ps=2.16u w=0.74u l=0.2u
X3244 VSS.t1394 a_4187_1764.t156 a_9431_16869# VSS.t2384 sg13_lv_nmos ad=0.2516p pd=2.16u as=0.1406p ps=1.12u w=0.74u l=0.6u
X3245 a_11848_13226# a_11277_14024# VSS.t1222 VSS.t1221 sg13_lv_nmos ad=0.1406p pd=1.12u as=0.2516p ps=2.16u w=0.74u l=0.13u
X3246 VSS.t652 VDD.t1687 VSS.t652 VSS.t654 sg13_lv_nmos ad=79.8f pd=0.8u as=0 ps=0 w=0.42u l=1u
X3247 VSS.t989 a_26803_16869# a_27237_16869# VSS.t1273 sg13_lv_nmos ad=0.1406p pd=1.12u as=0.2516p ps=2.16u w=0.74u l=0.13u
X3248 a_12715_3889# a_12505_3889# VDD.t1161 VDD.t9 sg13_lv_pmos ad=0.2128p pd=1.5u as=0.252p ps=1.57u w=1.12u l=0.13u
X3249 a_1815_15358# a_1256_15316# a_1721_15358# VSS.t2044 sg13_lv_nmos ad=0.1216p pd=1.02u as=0.2176p ps=1.96u w=0.64u l=0.13u
X3250 a_10328_16071# a_9757_16869# VSS.t2226 VSS.t2225 sg13_lv_nmos ad=0.1406p pd=1.12u as=0.2516p ps=2.16u w=0.74u l=0.13u
X3251 a_4157_13495# CHAN1_DELAY_IN VDD.t412 VDD.t36 sg13_lv_pmos ad=0.3808p pd=2.92u as=0.3808p ps=2.92u w=1.12u l=0.13u
X3252 VSS.t1324 a_7043_1842# a_7477_1842# VSS.t1323 sg13_lv_nmos ad=0.1406p pd=1.12u as=0.2516p ps=2.16u w=0.74u l=0.13u
X3253 a_17928_3889# a_17357_4687# VDD.t1546 VDD.t9 sg13_lv_pmos ad=0.2128p pd=1.5u as=0.3808p ps=2.92u w=1.12u l=0.13u
X3254 a_21835_3889# a_21625_3889# VSS.t54 VSS.t1980 sg13_lv_nmos ad=0.1406p pd=1.12u as=0.1665p ps=1.19u w=0.74u l=0.13u
X3255 VDD.t1387 a_1544_13226# a_2297_13577# VDD.t36 sg13_lv_pmos ad=0.1918p pd=1.5u as=0.1596p ps=1.22u w=0.84u l=0.13u
X3256 VDD.t921 a_4187_2434# a_15511_2470# VDD.t353 sg13_lv_pmos ad=0.3808p pd=2.92u as=0.2128p ps=1.5u w=1.12u l=0.6u
X3257 a_19550_3889# a_21044_3853# a_20968_3889# VDD.t9 sg13_lv_pmos ad=0.3808p pd=2.92u as=0.2128p ps=1.5u w=1.12u l=0.13u
X3258 VDD.t513 a_2019_1047.t7 a_10404_1008# VDD.t0 sg13_lv_pmos ad=0.3808p pd=2.92u as=0.3808p ps=2.92u w=1.12u l=0.13u
X3259 VSS.t1488 a_2595_3892.t4 a_20391_3853# VSS.t1487 sg13_lv_nmos ad=0.2516p pd=2.16u as=0.2516p ps=2.16u w=0.74u l=0.13u
X3260 a_21591_14024# a_21353_14024# a_21483_14024# VSS.t2326 sg13_lv_nmos ad=0.1406p pd=1.12u as=0.2516p ps=2.16u w=0.74u l=0.2u
X3261 VSS.t231 a_4187_1764.t101 a_26911_14024# VSS.t2387 sg13_lv_nmos ad=0.2516p pd=2.16u as=0.1406p ps=1.12u w=0.74u l=0.6u
X3262 a_1721_7085# a_1256_6734# VDD.t406 VDD.t29 sg13_lv_pmos ad=0.1596p pd=1.22u as=0.2856p ps=2.36u w=0.84u l=0.13u
X3263 a_16271_17497# a_16033_16869# a_16163_16869# VDD.t365 sg13_lv_pmos ad=0.2128p pd=1.5u as=0.3808p ps=2.92u w=1.12u l=0.2u
X3264 a_13470_16071# a_3747_16074.t6 a_15755_16071# VSS.t405 sg13_lv_nmos ad=0.2516p pd=2.16u as=0.1406p ps=1.12u w=0.74u l=0.13u
X3265 VDD.t1319 a_2873_4240# a_3171_3892.t0 VDD.t9 sg13_lv_pmos ad=0.4256p pd=3u as=0.2128p ps=1.5u w=1.12u l=0.13u
X3266 VSS.t725 VDD.t1656 VSS.t725 VSS.t727 sg13_lv_nmos ad=0.1428p pd=1.52u as=0 ps=0 w=0.42u l=1u
X3267 a_13470_6734# a_14964_6698# a_14888_6734# VDD.t29 sg13_lv_pmos ad=0.3808p pd=2.92u as=0.2128p ps=1.5u w=1.12u l=0.13u
X3268 VDD.t384 a_2019_3156.t2 a_17865_3364# VDD.t9 sg13_lv_pmos ad=0.3808p pd=2.92u as=0.3808p ps=2.92u w=1.12u l=0.13u
X3269 a_7288_3889# a_6717_4687# VDD.t535 VDD.t9 sg13_lv_pmos ad=0.2128p pd=1.5u as=0.3808p ps=2.92u w=1.12u l=0.13u
X3270 VDD.t1313 a_1544_16071# a_1721_16422# VDD.t20 sg13_lv_pmos ad=0.1918p pd=1.5u as=0.1596p ps=1.22u w=0.84u l=0.13u
X3271 VSS.t283 a_4187_1764.t107 a_22351_14024# VSS.t282 sg13_lv_nmos ad=0.2516p pd=2.16u as=0.1406p ps=1.12u w=0.74u l=0.6u
X3272 VDD.t1456 a_25283_1842# a_25717_1842# VDD.t353 sg13_lv_pmos ad=0.2128p pd=1.5u as=0.3808p ps=2.92u w=1.12u l=0.13u
X3273 VDD.t685 a_27237_16869# a_27705_16071# VDD.t20 sg13_lv_pmos ad=0.252p pd=1.57u as=0.3808p ps=2.92u w=1.12u l=0.13u
X3274 a_13368_13226# a_12797_14024# VDD.t1098 VDD.t36 sg13_lv_pmos ad=0.2128p pd=1.5u as=0.3808p ps=2.92u w=1.12u l=0.13u
X3275 VDD.t215 VSS.t665 VDD.t214 VDD.t36 sg13_lv_pmos ad=0.34p pd=2.68u as=0 ps=0 w=1u l=1u
X3276 VSS.t2033 a_10517_4687# a_10985_3889# VSS.t2123 sg13_lv_nmos ad=0.1665p pd=1.19u as=0.2516p ps=2.16u w=0.74u l=0.13u
X3277 VDD.t833 a_4187_2434# a_17031_17497# VDD.t365 sg13_lv_pmos ad=0.3808p pd=2.92u as=0.2128p ps=1.5u w=1.12u l=0.6u
X3278 VDD.t227 VSS.t640 VDD.t226 VDD.t20 sg13_lv_pmos ad=0.34p pd=2.68u as=0 ps=0 w=1u l=1u
X3279 a_10951_14652# a_10713_14024# a_10843_14024# VDD.t381 sg13_lv_pmos ad=0.2128p pd=1.5u as=0.3808p ps=2.92u w=1.12u l=0.2u
X3280 a_15273_14024# a_15077_14024# VDD.t568 VDD.t381 sg13_lv_pmos ad=0.3808p pd=2.92u as=0.2128p ps=1.5u w=1.12u l=0.13u
X3281 VSS.t965 a_6126_9506# a_5974_11413# VSS.t959 sg13_lv_nmos ad=0.76p pd=4.76u as=0.38p ps=2.38u w=2u l=1u
X3282 a_17553_7532# a_17357_7532# VSS.t1819 VSS.t1818 sg13_lv_nmos ad=0.2516p pd=2.16u as=0.1406p ps=1.12u w=0.74u l=0.13u
X3283 VDD.t1368 a_22677_16869# a_23145_16071# VDD.t20 sg13_lv_pmos ad=0.252p pd=1.57u as=0.3808p ps=2.92u w=1.12u l=0.13u
X3284 a_8671_7532# a_8433_7532# a_8563_7532# VSS.t2158 sg13_lv_nmos ad=0.1406p pd=1.12u as=0.2516p ps=2.16u w=0.74u l=0.2u
X3285 VDD.t910 a_4187_2434# a_5631_2470# VDD.t353 sg13_lv_pmos ad=0.3808p pd=2.92u as=0.2128p ps=1.5u w=1.12u l=0.6u
X3286 VDD.t1532 a_2019_6737.t2 a_25604_6698# VDD.t29 sg13_lv_pmos ad=0.3808p pd=2.92u as=0.3808p ps=2.92u w=1.12u l=0.13u
X3287 a_20968_16071# a_20397_16869# VDD.t939 VDD.t20 sg13_lv_pmos ad=0.2128p pd=1.5u as=0.3808p ps=2.92u w=1.12u l=0.13u
X3288 a_16510_13226# a_18871_13190# a_18795_13226# VDD.t36 sg13_lv_pmos ad=0.3808p pd=2.92u as=0.2128p ps=1.5u w=1.12u l=0.13u
X3289 a_10232_11561# a_10751_11568# a_11491_11918# VSS.t1463 sg13_lv_nmos ad=0.3473p pd=2.71u as=0.12665p ps=1.145u w=0.74u l=0.13u
X3290 a_26395_1044# a_26185_1044# VDD.t1457 VDD.t0 sg13_lv_pmos ad=0.2128p pd=1.5u as=0.252p ps=1.57u w=1.12u l=0.13u
X3291 a_24393_16869# a_24197_16869# VSS.t426 VSS.t1314 sg13_lv_nmos ad=0.2516p pd=2.16u as=0.1406p ps=1.12u w=0.74u l=0.13u
X3292 VSS.t730 VDD.t1654 VSS.t730 VSS.t732 sg13_lv_nmos ad=0.1428p pd=1.52u as=0 ps=0 w=0.42u l=1u
X3293 VSS.t23 a_12363_4687# a_12797_4687# VSS.t22 sg13_lv_nmos ad=0.1406p pd=1.12u as=0.2516p ps=2.16u w=0.74u l=0.13u
X3294 a_22590_3889# a_24951_3853# a_24875_3889# VDD.t9 sg13_lv_pmos ad=0.3808p pd=2.92u as=0.2128p ps=1.5u w=1.12u l=0.13u
X3295 VDD.t1052 a_1544_3889# a_2297_4240# VDD.t9 sg13_lv_pmos ad=0.1918p pd=1.5u as=0.1596p ps=1.22u w=0.84u l=0.13u
X3296 VSS.t1054 a_17683_16869# a_18117_16869# VSS.t2144 sg13_lv_nmos ad=0.1406p pd=1.12u as=0.2516p ps=2.16u w=0.74u l=0.13u
X3297 a_1256_13226# CHAN1_MUX_SEL0 VDD.t556 VDD.t36 sg13_lv_pmos ad=0.3808p pd=2.92u as=0.3808p ps=2.92u w=1.12u l=0.13u
X3298 VDD.t122 VSS.t581 VDD.t120 VDD.t20 sg13_lv_pmos ad=0.19p pd=1.38u as=0 ps=0 w=1u l=1u
X3299 a_13470_13226# a_14311_13190# a_14235_13226# VDD.t36 sg13_lv_pmos ad=0.3808p pd=2.92u as=0.2128p ps=1.5u w=1.12u l=0.13u
X3300 VDD.t691 a_3747_1047.t3 a_24951_1008# VDD.t0 sg13_lv_pmos ad=0.3808p pd=2.92u as=0.3808p ps=2.92u w=1.12u l=0.13u
X3301 a_1256_3134# CHAN2_MUX_SEL2 VDD.t1136 VDD.t9 sg13_lv_pmos ad=0.3808p pd=2.92u as=0.3808p ps=2.92u w=1.12u l=0.13u
X3302 a_2595_6001.t1 a_2297_6021# VSS.t191 VSS.t1124 sg13_lv_nmos ad=0.1406p pd=1.12u as=0.1331p ps=1.12u w=0.74u l=0.13u
X3303 VSS.t83 a_4187_1764.t141 a_20831_16869# VSS.t2364 sg13_lv_nmos ad=0.2516p pd=2.16u as=0.1406p ps=1.12u w=0.74u l=0.6u
X3304 a_2019_3892.t0 a_1721_4240# VDD.t1283 VDD.t9 sg13_lv_pmos ad=0.2128p pd=1.5u as=0.1918p ps=1.5u w=1.12u l=0.13u
X3305 VDD.t637 VDD.t635 VDD.t636 VDD.t341 sg13_lv_pmos ad=0.3808p pd=2.92u as=0 ps=0 w=1.12u l=0.13u
X3306 a_6153_14024# a_5957_14024# VSS.t1048 VSS.t1411 sg13_lv_nmos ad=0.2516p pd=2.16u as=0.1406p ps=1.12u w=0.74u l=0.13u
X3307 a_26911_8160# a_26673_7532# a_26803_7532# VDD.t341 sg13_lv_pmos ad=0.2128p pd=1.5u as=0.3808p ps=2.92u w=1.12u l=0.2u
X3308 VDD.t1526 a_19203_16869# a_19637_16869# VDD.t365 sg13_lv_pmos ad=0.2128p pd=1.5u as=0.3808p ps=2.92u w=1.12u l=0.13u
X3309 a_21835_6734# a_21625_6734# VDD.t986 VDD.t29 sg13_lv_pmos ad=0.2128p pd=1.5u as=0.252p ps=1.57u w=1.12u l=0.13u
X3310 a_19550_16071# a_21911_16035# a_21835_16071# VDD.t20 sg13_lv_pmos ad=0.3808p pd=2.92u as=0.2128p ps=1.5u w=1.12u l=0.13u
X3311 VDD.t1378 a_3171_13229.t8 a_8884_13190# VDD.t36 sg13_lv_pmos ad=0.3808p pd=2.92u as=0.3808p ps=2.92u w=1.12u l=0.13u
X3312 VDD.t182 VSS.t680 VDD.t260 VDD.t36 sg13_lv_pmos ad=0.34p pd=2.68u as=0 ps=0 w=1u l=1u
X3313 a_7390_6734# a_2019_6737.t8 a_7288_6734# VSS.t2244 sg13_lv_nmos ad=0.2516p pd=2.16u as=0.1406p ps=1.12u w=0.74u l=0.13u
X3314 VDD.t1542 VSS.t827 VDD.t17 VDD.t0 sg13_lv_pmos ad=0.19p pd=1.38u as=0 ps=0 w=1u l=1u
X3315 VDD.t266 VSS.t760 VDD.t264 VDD.t9 sg13_lv_pmos ad=0.19p pd=1.38u as=0 ps=0 w=1u l=1u
X3316 a_5731_15316# a_3747_15338.t3 a_13470_16071# VSS.t271 sg13_lv_nmos ad=0.2516p pd=2.16u as=0.2516p ps=2.16u w=0.74u l=0.13u
X3317 VDD.t1073 a_2595_6737.t4 a_20391_6698# VDD.t29 sg13_lv_pmos ad=0.3808p pd=2.92u as=0.3808p ps=2.92u w=1.12u l=0.13u
X3318 VDD.t941 a_1721_3176# a_2019_3156.t0 VDD.t9 sg13_lv_pmos ad=0.4256p pd=3u as=0.2128p ps=1.5u w=1.12u l=0.13u
X3319 a_21353_7532# a_21157_7532# VSS.t1609 VSS.t1608 sg13_lv_nmos ad=0.2516p pd=2.16u as=0.1406p ps=1.12u w=0.74u l=0.13u
X3320 a_24008_1044# a_23437_1842# VDD.t1399 VDD.t0 sg13_lv_pmos ad=0.2128p pd=1.5u as=0.3808p ps=2.92u w=1.12u l=0.13u
X3321 CHAN2_DELAY_OUT_LAST a_27997_4687# VDD.t937 VDD.t339 sg13_lv_pmos ad=0.3808p pd=2.92u as=0.2128p ps=1.5u w=1.12u l=0.13u
X3322 a_13991_1842# a_13753_1842# a_13883_1842# VSS.t1453 sg13_lv_nmos ad=0.1406p pd=1.12u as=0.2516p ps=2.16u w=0.74u l=0.2u
X3323 VDD.t1049 a_25717_4687# a_26185_3889# VDD.t9 sg13_lv_pmos ad=0.252p pd=1.57u as=0.3808p ps=2.92u w=1.12u l=0.13u
X3324 a_1815_12513# a_1256_12471# a_1721_12513# VSS.t2203 sg13_lv_nmos ad=0.1216p pd=1.02u as=0.2176p ps=1.96u w=0.64u l=0.13u
X3325 VSS.t296 a_7043_7532# a_7477_7532# VSS.t2206 sg13_lv_nmos ad=0.1406p pd=1.12u as=0.2516p ps=2.16u w=0.74u l=0.13u
X3326 VDD.t415 a_10517_7532# a_10985_6734# VDD.t29 sg13_lv_pmos ad=0.252p pd=1.57u as=0.3808p ps=2.92u w=1.12u l=0.13u
X3327 VSS.t102 a_2019_1047.t4 a_19524_1008# VSS.t351 sg13_lv_nmos ad=0.2516p pd=2.16u as=0.2516p ps=2.16u w=0.74u l=0.13u
X3328 VSS.t305 a_3747_3892.t5 a_18871_3853# VSS.t2001 sg13_lv_nmos ad=0.2516p pd=2.16u as=0.2516p ps=2.16u w=0.74u l=0.13u
X3329 a_4633_16869# a_4437_16869# VSS.t1258 VSS.t1257 sg13_lv_nmos ad=0.2516p pd=2.16u as=0.1406p ps=1.12u w=0.74u l=0.13u
X3330 VDD.t62 VSS.t800 VDD.t58 VDD.t0 sg13_lv_pmos ad=0.19p pd=1.38u as=0 ps=0 w=1u l=1u
X3331 VDD.t708 a_13557_16869# a_14025_16071# VDD.t20 sg13_lv_pmos ad=0.252p pd=1.57u as=0.3808p ps=2.92u w=1.12u l=0.13u
X3332 VDD.t155 VSS.t643 VDD.t153 VDD.t36 sg13_lv_pmos ad=0.19p pd=1.38u as=0 ps=0 w=1u l=1u
X3333 VDD.t770 a_4187_2434# a_15511_8160# VDD.t341 sg13_lv_pmos ad=0.3808p pd=2.92u as=0.2128p ps=1.5u w=1.12u l=0.6u
X3334 VDD.t191 VSS.t725 VDD.t190 VDD.t29 sg13_lv_pmos ad=0.34p pd=2.68u as=0 ps=0 w=1u l=1u
X3335 VDD.t1147 a_4437_4687# a_4905_3889# VDD.t9 sg13_lv_pmos ad=0.252p pd=1.57u as=0.3808p ps=2.92u w=1.12u l=0.13u
X3336 a_6913_4687# a_6717_4687# VDD.t454 VDD.t339 sg13_lv_pmos ad=0.3808p pd=2.92u as=0.2128p ps=1.5u w=1.12u l=0.13u
X3337 a_16108_12471# a_17865_12701# a_16510_13226# VDD.t36 sg13_lv_pmos ad=0.3808p pd=2.92u as=0.3808p ps=2.92u w=1.12u l=0.13u
X3338 a_15964_12471# a_15765_12645# a_5731_12471# VSS.t194 sg13_lv_nmos ad=0.2183p pd=1.33u as=0.2516p ps=2.16u w=0.74u l=0.13u
X3339 VDD.t772 a_4187_2434# a_18551_5315# VDD.t339 sg13_lv_pmos ad=0.3808p pd=2.92u as=0.2128p ps=1.5u w=1.12u l=0.6u
X3340 a_16271_14652# a_16033_14024# a_16163_14024# VDD.t381 sg13_lv_pmos ad=0.2128p pd=1.5u as=0.3808p ps=2.92u w=1.12u l=0.2u
X3341 VSS.t867 a_9444_10280# a_9444_9602# VSS.t860 sg13_lv_nmos ad=0.68p pd=4.68u as=0.38p ps=2.38u w=2u l=1u
X3342 VSS.t2136 CHAN3_MUX_SEL1 a_3543_1395# VSS.t2135 sg13_lv_nmos ad=0.1331p pd=1.12u as=0.1216p ps=1.02u w=0.64u l=0.13u
X3343 a_4157_4158# CHAN2_DELAY_IN VSS.t1514 VSS.t1513 sg13_lv_nmos ad=0.2516p pd=2.16u as=0.2553p ps=2.17u w=0.74u l=0.13u
X3344 a_16793_1842# a_16597_1842# VDD.t946 VDD.t353 sg13_lv_pmos ad=0.3808p pd=2.92u as=0.2128p ps=1.5u w=1.12u l=0.13u
X3345 a_2391_15358# CHAN0_MUX_SEL2 a_2297_15358# VSS.t479 sg13_lv_nmos ad=0.1216p pd=1.02u as=0.2176p ps=1.96u w=0.64u l=0.13u
X3346 a_7911_2470# a_7673_1842# a_7803_1842# VDD.t353 sg13_lv_pmos ad=0.2128p pd=1.5u as=0.3808p ps=2.92u w=1.12u l=0.2u
X3347 VSS.t694 VDD.t1670 VSS.t696 VSS.t695 sg13_lv_nmos ad=79.8f pd=0.8u as=0 ps=0 w=0.42u l=1u
X3348 VSS.t1403 a_4187_1764.t153 a_11711_16869# VSS.t2361 sg13_lv_nmos ad=0.2516p pd=2.16u as=0.1406p ps=1.12u w=0.74u l=0.6u
X3349 VDD.t1449 a_25283_7532# a_25717_7532# VDD.t341 sg13_lv_pmos ad=0.2128p pd=1.5u as=0.3808p ps=2.92u w=1.12u l=0.13u
X3350 a_12715_3889# a_12505_3889# VSS.t1638 VSS.t1979 sg13_lv_nmos ad=0.1406p pd=1.12u as=0.1665p ps=1.19u w=0.74u l=0.13u
X3351 a_16793_16869# a_16597_16869# VDD.t1488 VDD.t365 sg13_lv_pmos ad=0.3808p pd=2.92u as=0.2128p ps=1.5u w=1.12u l=0.13u
X3352 VDD.t859 a_4187_2434# a_17031_14652# VDD.t381 sg13_lv_pmos ad=0.3808p pd=2.92u as=0.2128p ps=1.5u w=1.12u l=0.6u
X3353 a_15755_1044# a_15545_1044# VSS.t262 VSS.t261 sg13_lv_nmos ad=0.1406p pd=1.12u as=0.1665p ps=1.19u w=0.74u l=0.13u
X3354 a_17928_3889# a_17357_4687# VSS.t1480 VSS.t2269 sg13_lv_nmos ad=0.1406p pd=1.12u as=0.2516p ps=2.16u w=0.74u l=0.13u
X3355 a_16271_4687# a_16033_4687# a_16163_4687# VSS.t2063 sg13_lv_nmos ad=0.1406p pd=1.12u as=0.2516p ps=2.16u w=0.74u l=0.2u
X3356 a_25391_16869# a_25153_16869# a_25283_16869# VSS.t90 sg13_lv_nmos ad=0.1406p pd=1.12u as=0.2516p ps=2.16u w=0.74u l=0.2u
X3357 VDD.t1401 a_1256_13226# a_2873_13577# VDD.t36 sg13_lv_pmos ad=0.1918p pd=1.5u as=0.1596p ps=1.22u w=0.84u l=0.13u
X3358 a_10430_16071# a_12791_16035# a_12715_16071# VDD.t20 sg13_lv_pmos ad=0.3808p pd=2.92u as=0.2128p ps=1.5u w=1.12u l=0.13u
X3359 VDD.t1181 a_3171_3892.t8 a_8884_3853# VDD.t9 sg13_lv_pmos ad=0.3808p pd=2.92u as=0.3808p ps=2.92u w=1.12u l=0.13u
X3360 a_19550_3889# a_3171_3892.t4 a_20968_3889# VSS.t1668 sg13_lv_nmos ad=0.2516p pd=2.16u as=0.1406p ps=1.12u w=0.74u l=0.13u
X3361 a_12233_16869# a_12037_16869# VDD.t1048 VDD.t365 sg13_lv_pmos ad=0.3808p pd=2.92u as=0.2128p ps=1.5u w=1.12u l=0.13u
X3362 VDD.t867 a_4187_2434# a_5631_8160# VDD.t341 sg13_lv_pmos ad=0.3808p pd=2.92u as=0.2128p ps=1.5u w=1.12u l=0.6u
X3363 VSS.t1301 a_2595_1047.t6 a_14311_1008# VSS.t1720 sg13_lv_nmos ad=0.2516p pd=2.16u as=0.2516p ps=2.16u w=0.74u l=0.13u
X3364 a_2595_1047.t0 a_2297_1395# VDD.t1239 VDD.t0 sg13_lv_pmos ad=0.2128p pd=1.5u as=0.1918p ps=1.5u w=1.12u l=0.13u
X3365 VSS.t620 VDD.t1697 VSS.t619 VSS.t618 sg13_lv_nmos ad=0.1428p pd=1.52u as=0 ps=0 w=0.42u l=1u
X3366 VSS.t1086 a_10843_14024# a_11277_14024# VSS.t1277 sg13_lv_nmos ad=0.1406p pd=1.12u as=0.2516p ps=2.16u w=0.74u l=0.13u
X3367 VSS.t1725 a_4187_1764.t134 a_26151_16869# VSS.t1724 sg13_lv_nmos ad=0.2516p pd=2.16u as=0.1406p ps=1.12u w=0.74u l=0.6u
X3368 a_1256_1044# CHAN3_MUX_SEL0 VDD.t1419 VDD.t0 sg13_lv_pmos ad=0.3808p pd=2.92u as=0.3808p ps=2.92u w=1.12u l=0.13u
X3369 a_7151_14024# a_6913_14024# a_7043_14024# VSS.t1932 sg13_lv_nmos ad=0.1406p pd=1.12u as=0.2516p ps=2.16u w=0.74u l=0.2u
X3370 VSS.t1501 a_12363_1842# a_12797_1842# VSS.t1888 sg13_lv_nmos ad=0.1406p pd=1.12u as=0.2516p ps=2.16u w=0.74u l=0.13u
X3371 a_5115_1044# a_4905_1044# VSS.t1178 VSS.t1177 sg13_lv_nmos ad=0.1406p pd=1.12u as=0.1665p ps=1.19u w=0.74u l=0.13u
X3372 a_7288_3889# a_6717_4687# VSS.t64 VSS.t415 sg13_lv_nmos ad=0.1406p pd=1.12u as=0.2516p ps=2.16u w=0.74u l=0.13u
X3373 VDD.t547 a_2019_16074.t8 a_7364_16035# VDD.t20 sg13_lv_pmos ad=0.3808p pd=2.92u as=0.3808p ps=2.92u w=1.12u l=0.13u
X3374 VSS.t709 VDD.t1664 VSS.t709 VSS.t708 sg13_lv_nmos ad=0.1428p pd=1.52u as=0 ps=0 w=0.42u l=1u
X3375 VDD.t900 a_4187_2434# a_22351_5315# VDD.t339 sg13_lv_pmos ad=0.3808p pd=2.92u as=0.2128p ps=1.5u w=1.12u l=0.6u
X3376 VSS.t593 VDD.t1704 VSS.t593 VSS.t592 sg13_lv_nmos ad=0.1428p pd=1.52u as=0 ps=0 w=0.42u l=1u
X3377 VDD.t530 a_27563_1842# a_27997_1842# VDD.t353 sg13_lv_pmos ad=0.2128p pd=1.5u as=0.3808p ps=2.92u w=1.12u l=0.13u
X3378 a_5731_5979# a_5705_6209# a_4350_6734# VDD.t29 sg13_lv_pmos ad=0.3808p pd=2.92u as=0.3808p ps=2.92u w=1.12u l=0.13u
X3379 a_20593_1842# a_20397_1842# VDD.t983 VDD.t353 sg13_lv_pmos ad=0.3808p pd=2.92u as=0.2128p ps=1.5u w=1.12u l=0.13u
X3380 VDD.t576 a_19203_14024# a_19637_14024# VDD.t381 sg13_lv_pmos ad=0.2128p pd=1.5u as=0.3808p ps=2.92u w=1.12u l=0.13u
X3381 VDD.t558 a_3747_6737.t5 a_18871_6698# VDD.t29 sg13_lv_pmos ad=0.3808p pd=2.92u as=0.3808p ps=2.92u w=1.12u l=0.13u
X3382 a_2967_3176# CHAN2_MUX_SEL3 a_2873_3176# VSS.t1618 sg13_lv_nmos ad=0.1216p pd=1.02u as=0.2176p ps=1.96u w=0.64u l=0.13u
X3383 VSS.t1052 a_18117_16869# a_18585_16071# VSS.t1051 sg13_lv_nmos ad=0.1665p pd=1.19u as=0.2516p ps=2.16u w=0.74u l=0.13u
X3384 a_1721_1395# a_1256_1044# VDD.t984 VDD.t0 sg13_lv_pmos ad=0.1596p pd=1.22u as=0.2856p ps=2.36u w=0.84u l=0.13u
X3385 a_20071_4687# a_19833_4687# a_19963_4687# VSS.t1842 sg13_lv_nmos ad=0.1406p pd=1.12u as=0.2516p ps=2.16u w=0.74u l=0.2u
X3386 VSS.t2088 a_15077_14024# a_15545_13226# VSS.t2319 sg13_lv_nmos ad=0.1665p pd=1.19u as=0.2516p ps=2.16u w=0.74u l=0.13u
X3387 a_13470_1044# a_14964_1008# a_14888_1044# VDD.t0 sg13_lv_pmos ad=0.3808p pd=2.92u as=0.2128p ps=1.5u w=1.12u l=0.13u
X3388 VDD.t486 a_6283_1842# a_6717_1842# VDD.t353 sg13_lv_pmos ad=0.2128p pd=1.5u as=0.3808p ps=2.92u w=1.12u l=0.13u
X3389 a_22590_3889# a_3747_3892.t3 a_24875_3889# VSS.t77 sg13_lv_nmos ad=0.2516p pd=2.16u as=0.1406p ps=1.12u w=0.74u l=0.13u
X3390 a_27915_3889# a_27705_3889# VDD.t1221 VDD.t9 sg13_lv_pmos ad=0.2128p pd=1.5u as=0.252p ps=1.57u w=1.12u l=0.13u
X3391 VSS.t183 a_14643_4687# a_15077_4687# VSS.t182 sg13_lv_nmos ad=0.1406p pd=1.12u as=0.2516p ps=2.16u w=0.74u l=0.13u
X3392 VSS.t2257 a_3171_16074.t2 a_27124_16035# VSS.t2256 sg13_lv_nmos ad=0.2516p pd=2.16u as=0.2516p ps=2.16u w=0.74u l=0.13u
X3393 a_13991_7532# a_13753_7532# a_13883_7532# VSS.t1163 sg13_lv_nmos ad=0.1406p pd=1.12u as=0.2516p ps=2.16u w=0.74u l=0.2u
X3394 a_11848_16071# a_11277_16869# VSS.t61 VSS.t60 sg13_lv_nmos ad=0.1406p pd=1.12u as=0.2516p ps=2.16u w=0.74u l=0.13u
X3395 a_2019_13229.t0 a_1721_13577# VDD.t1413 VDD.t36 sg13_lv_pmos ad=0.2128p pd=1.5u as=0.1918p ps=1.5u w=1.12u l=0.13u
X3396 a_12715_6734# a_12505_6734# VDD.t435 VDD.t29 sg13_lv_pmos ad=0.2128p pd=1.5u as=0.252p ps=1.57u w=1.12u l=0.13u
X3397 VSS.t1898 a_3171_13229.t3 a_24084_13190# VSS.t2017 sg13_lv_nmos ad=0.2516p pd=2.16u as=0.2516p ps=2.16u w=0.74u l=0.13u
X3398 VSS.t810 VDD.t1628 VSS.t809 VSS.t808 sg13_lv_nmos ad=0.1428p pd=1.52u as=0 ps=0 w=0.42u l=1u
X3399 a_4157_16340# CHAN0_DELAY_IN VDD.t1141 VDD.t20 sg13_lv_pmos ad=0.3808p pd=2.92u as=0.3808p ps=2.92u w=1.12u l=0.13u
X3400 VSS.t488 a_2019_6737.t4 a_19524_6698# VSS.t1081 sg13_lv_nmos ad=0.2516p pd=2.16u as=0.2516p ps=2.16u w=0.74u l=0.13u
X3401 a_17928_6734# a_17357_7532# VDD.t1267 VDD.t29 sg13_lv_pmos ad=0.2128p pd=1.5u as=0.3808p ps=2.92u w=1.12u l=0.13u
X3402 VSS.t600 VDD.t1702 VSS.t602 VSS.t601 sg13_lv_nmos ad=79.8f pd=0.8u as=0 ps=0 w=0.42u l=1u
X3403 VDD.t1293 a_2019_1047.t2 a_25604_1008# VDD.t0 sg13_lv_pmos ad=0.3808p pd=2.92u as=0.3808p ps=2.92u w=1.12u l=0.13u
X3404 VDD.t275 VSS.t769 VDD.t274 VDD.t9 sg13_lv_pmos ad=0.34p pd=2.68u as=0 ps=0 w=1u l=1u
X3405 a_17791_17497# a_17553_16869# a_17683_16869# VDD.t365 sg13_lv_pmos ad=0.2128p pd=1.5u as=0.3808p ps=2.92u w=1.12u l=0.2u
X3406 a_19550_6734# a_21044_6698# a_20968_6734# VDD.t29 sg13_lv_pmos ad=0.3808p pd=2.92u as=0.2128p ps=1.5u w=1.12u l=0.13u
X3407 VDD.t236 VSS.t696 VDD.t98 VDD.t29 sg13_lv_pmos ad=0.19p pd=1.38u as=0 ps=0 w=1u l=1u
X3408 VSS.t469 a_4187_1764.t105 a_23871_14024# VSS.t468 sg13_lv_nmos ad=0.2516p pd=2.16u as=0.1406p ps=1.12u w=0.74u l=0.6u
X3409 VDD.t1490 a_16597_14024# a_17065_13226# VDD.t36 sg13_lv_pmos ad=0.252p pd=1.57u as=0.3808p ps=2.92u w=1.12u l=0.13u
X3410 VSS.t207 REF_MUX_SEL1 a_3543_7085# VSS.t521 sg13_lv_nmos ad=0.1331p pd=1.12u as=0.1216p ps=1.02u w=0.64u l=0.13u
X3411 a_14888_13226# a_14317_14024# VDD.t1334 VDD.t36 sg13_lv_pmos ad=0.2128p pd=1.5u as=0.3808p ps=2.92u w=1.12u l=0.13u
X3412 a_16793_7532# a_16597_7532# VDD.t389 VDD.t341 sg13_lv_pmos ad=0.3808p pd=2.92u as=0.2128p ps=1.5u w=1.12u l=0.13u
X3413 VDD.t819 a_4187_2434# a_18551_17497# VDD.t365 sg13_lv_pmos ad=0.3808p pd=2.92u as=0.2128p ps=1.5u w=1.12u l=0.6u
X3414 a_7911_8160# a_7673_7532# a_7803_7532# VDD.t341 sg13_lv_pmos ad=0.2128p pd=1.5u as=0.3808p ps=2.92u w=1.12u l=0.2u
X3415 a_7288_6734# a_6717_7532# VDD.t343 VDD.t29 sg13_lv_pmos ad=0.2128p pd=1.5u as=0.3808p ps=2.92u w=1.12u l=0.13u
X3416 VSS.t1405 a_25717_4687# a_26185_3889# VSS.t1404 sg13_lv_nmos ad=0.1665p pd=1.19u as=0.2516p ps=2.16u w=0.74u l=0.13u
X3417 a_2391_12513# CHAN1_MUX_SEL2 a_2297_12513# VSS.t130 sg13_lv_nmos ad=0.1216p pd=1.02u as=0.2176p ps=1.96u w=0.64u l=0.13u
X3418 a_9712_9602# a_6854_11144# a_9444_9602# VSS.t1239 sg13_lv_nmos ad=0.38p pd=2.38u as=0.68p ps=4.68u w=2u l=1u
X3419 VSS.t512 a_4187_1764.t47 a_17791_4687# VSS.t511 sg13_lv_nmos ad=0.2516p pd=2.16u as=0.1406p ps=1.12u w=0.74u l=0.6u
X3420 a_19833_4687# a_19637_4687# VDD.t1115 VDD.t339 sg13_lv_pmos ad=0.3808p pd=2.92u as=0.2128p ps=1.5u w=1.12u l=0.13u
X3421 a_16793_14024# a_16597_14024# VDD.t1062 VDD.t381 sg13_lv_pmos ad=0.3808p pd=2.92u as=0.2128p ps=1.5u w=1.12u l=0.13u
X3422 VSS.t674 a_3171_12493.t2 a_23945_12701# VSS.t2261 sg13_lv_nmos ad=0.2516p pd=2.16u as=0.2516p ps=2.16u w=0.74u l=0.13u
X3423 a_15755_6734# a_15545_6734# VSS.t270 VSS.t1345 sg13_lv_nmos ad=0.1406p pd=1.12u as=0.1665p ps=1.19u w=0.74u l=0.13u
X3424 a_16271_1842# a_16033_1842# a_16163_1842# VSS.t234 sg13_lv_nmos ad=0.1406p pd=1.12u as=0.2516p ps=2.16u w=0.74u l=0.2u
X3425 VSS.t1732 a_3747_13229.t5 a_18871_13190# VSS.t1731 sg13_lv_nmos ad=0.2516p pd=2.16u as=0.2516p ps=2.16u w=0.74u l=0.13u
X3426 a_10328_13226# a_9757_14024# VDD.t519 VDD.t36 sg13_lv_pmos ad=0.2128p pd=1.5u as=0.3808p ps=2.92u w=1.12u l=0.13u
X3427 a_21835_1044# a_21625_1044# VDD.t1476 VDD.t0 sg13_lv_pmos ad=0.2128p pd=1.5u as=0.252p ps=1.57u w=1.12u l=0.13u
X3428 VDD.t1001 a_24197_16869# a_24665_16071# VDD.t20 sg13_lv_pmos ad=0.252p pd=1.57u as=0.3808p ps=2.92u w=1.12u l=0.13u
X3429 a_12233_14024# a_12037_14024# VDD.t942 VDD.t381 sg13_lv_pmos ad=0.3808p pd=2.92u as=0.2128p ps=1.5u w=1.12u l=0.13u
X3430 VSS.t496 a_2595_6737.t6 a_14311_6698# VSS.t1375 sg13_lv_nmos ad=0.2516p pd=2.16u as=0.2516p ps=2.16u w=0.74u l=0.13u
X3431 VSS.t1615 a_4437_4687# a_4905_3889# VSS.t1614 sg13_lv_nmos ad=0.1665p pd=1.19u as=0.2516p ps=2.16u w=0.74u l=0.13u
X3432 a_25913_16869# a_25717_16869# VSS.t89 VSS.t1317 sg13_lv_nmos ad=0.2516p pd=2.16u as=0.1406p ps=1.12u w=0.74u l=0.13u
X3433 VDD.t1207 a_2595_1047.t4 a_20391_1008# VDD.t0 sg13_lv_pmos ad=0.3808p pd=2.92u as=0.3808p ps=2.92u w=1.12u l=0.13u
X3434 VDD.t59 VSS.t779 VDD.t329 VDD.t0 sg13_lv_pmos ad=0.34p pd=2.68u as=0 ps=0 w=1u l=1u
X3435 a_24631_5315# a_24393_4687# a_24523_4687# VDD.t339 sg13_lv_pmos ad=0.2128p pd=1.5u as=0.3808p ps=2.92u w=1.12u l=0.2u
X3436 a_13121_11521# a_15688_11557# VSS.t267 VSS.t266 sg13_lv_nmos ad=0.2516p pd=2.16u as=0.1406p ps=1.12u w=0.74u l=0.13u
X3437 a_9193_4687# a_8997_4687# VDD.t1485 VDD.t339 sg13_lv_pmos ad=0.3808p pd=2.92u as=0.2128p ps=1.5u w=1.12u l=0.13u
X3438 VDD.t161 VSS.t709 VDD.t160 VDD.t29 sg13_lv_pmos ad=0.34p pd=2.68u as=0 ps=0 w=1u l=1u
X3439 a_13470_13226# a_15831_13190# a_15755_13226# VDD.t36 sg13_lv_pmos ad=0.3808p pd=2.92u as=0.2128p ps=1.5u w=1.12u l=0.13u
X3440 VSS.t656 VDD.t1685 VSS.t656 VSS.t659 sg13_lv_nmos ad=79.8f pd=0.8u as=0 ps=0 w=0.42u l=1u
X3441 a_5778_9057# a_6126_9506# a_6326_10280# VSS.t956 sg13_lv_nmos ad=0.68p pd=4.68u as=0.38p ps=2.38u w=2u l=1u
X3442 VSS.t109 a_12363_7532# a_12797_7532# VSS.t1371 sg13_lv_nmos ad=0.1406p pd=1.12u as=0.2516p ps=2.16u w=0.74u l=0.13u
X3443 VSS.t885 VSS.t885 VSS.t887 VSS.t886 sg13_lv_nmos ad=0.2516p pd=2.16u as=0 ps=0 w=0.74u l=0.13u
X3444 a_5115_6734# a_4905_6734# VSS.t181 VSS.t2281 sg13_lv_nmos ad=0.1406p pd=1.12u as=0.1665p ps=1.19u w=0.74u l=0.13u
X3445 a_22590_6734# a_24951_6698# a_24875_6734# VDD.t29 sg13_lv_pmos ad=0.3808p pd=2.92u as=0.2128p ps=1.5u w=1.12u l=0.13u
X3446 a_21353_16869# a_21157_16869# VSS.t83 VSS.t82 sg13_lv_nmos ad=0.2516p pd=2.16u as=0.1406p ps=1.12u w=0.74u l=0.13u
X3447 VSS.t607 VDD.t1700 VSS.t610 VSS.t609 sg13_lv_nmos ad=79.8f pd=0.8u as=0 ps=0 w=0.42u l=1u
X3448 VSS.t1895 a_3171_13229.t6 a_14964_13190# VSS.t2015 sg13_lv_nmos ad=0.2516p pd=2.16u as=0.2516p ps=2.16u w=0.74u l=0.13u
X3449 a_5731_5979# a_3747_6001.t3 a_13470_6734# VSS.t1882 sg13_lv_nmos ad=0.2516p pd=2.16u as=0.2516p ps=2.16u w=0.74u l=0.13u
X3450 a_7673_14024# a_7477_14024# VSS.t1096 VSS.t1346 sg13_lv_nmos ad=0.2516p pd=2.16u as=0.1406p ps=1.12u w=0.74u l=0.13u
X3451 a_9444_9602# a_9444_10280# VSS.t866 VSS.t858 sg13_lv_nmos ad=0.38p pd=2.38u as=0.68p ps=4.68u w=2u l=1u
X3452 VSS.t1584 a_4187_1764.t98 VSS.t1582 VSS.t1567 sg13_lv_nmos ad=1.33p pd=7.38u as=0 ps=0 w=7u l=7u
X3453 VSS.t2153 a_21157_1842# a_21625_1044# VSS.t2372 sg13_lv_nmos ad=0.1665p pd=1.19u as=0.2516p ps=2.16u w=0.74u l=0.13u
X3454 VDD.t1530 a_10517_1842# a_10985_1044# VDD.t0 sg13_lv_pmos ad=0.252p pd=1.57u as=0.3808p ps=2.92u w=1.12u l=0.13u
X3455 a_19073_1842# a_18877_1842# VDD.t386 VDD.t353 sg13_lv_pmos ad=0.3808p pd=2.92u as=0.2128p ps=1.5u w=1.12u l=0.13u
X3456 VSS.t344 a_14643_16869# a_15077_16869# VSS.t449 sg13_lv_nmos ad=0.1406p pd=1.12u as=0.2516p ps=2.16u w=0.74u l=0.13u
X3457 VDD.t993 a_27563_7532# a_27997_7532# VDD.t341 sg13_lv_pmos ad=0.2128p pd=1.5u as=0.3808p ps=2.92u w=1.12u l=0.13u
X3458 VSS.t643 a_2595_12493.t3 a_8745_12701# VSS.t2263 sg13_lv_nmos ad=0.2516p pd=2.16u as=0.2516p ps=2.16u w=0.74u l=0.13u
X3459 a_5731_3134# a_5705_3364# a_4350_3889# VDD.t9 sg13_lv_pmos ad=0.3808p pd=2.92u as=0.3808p ps=2.92u w=1.12u l=0.13u
X3460 a_20593_7532# a_20397_7532# VDD.t701 VDD.t341 sg13_lv_pmos ad=0.3808p pd=2.92u as=0.2128p ps=1.5u w=1.12u l=0.13u
X3461 VSS.t1483 a_3171_3892.t8 a_8884_3853# VSS.t1665 sg13_lv_nmos ad=0.2516p pd=2.16u as=0.2516p ps=2.16u w=0.74u l=0.13u
X3462 VSS.t139 a_4187_1764.t42 a_21591_4687# VSS.t138 sg13_lv_nmos ad=0.2516p pd=2.16u as=0.1406p ps=1.12u w=0.74u l=0.6u
X3463 a_23633_4687# a_23437_4687# VDD.t968 VDD.t339 sg13_lv_pmos ad=0.3808p pd=2.92u as=0.2128p ps=1.5u w=1.12u l=0.13u
X3464 a_20071_1842# a_19833_1842# a_19963_1842# VSS.t238 sg13_lv_nmos ad=0.1406p pd=1.12u as=0.2516p ps=2.16u w=0.74u l=0.2u
X3465 a_1815_331# a_1256_289# a_1721_331# VSS.t433 sg13_lv_nmos ad=0.1216p pd=1.02u as=0.2176p ps=1.96u w=0.64u l=0.13u
X3466 VDD.t347 a_3747_16074.t2 a_27991_16035# VDD.t20 sg13_lv_pmos ad=0.3808p pd=2.92u as=0.3808p ps=2.92u w=1.12u l=0.13u
X3467 VDD.t344 a_6283_7532# a_6717_7532# VDD.t341 sg13_lv_pmos ad=0.2128p pd=1.5u as=0.3808p ps=2.92u w=1.12u l=0.13u
X3468 VDD.t956 a_9323_4687# a_9757_4687# VDD.t339 sg13_lv_pmos ad=0.2128p pd=1.5u as=0.3808p ps=2.92u w=1.12u l=0.13u
X3469 VSS.t1283 a_14643_1842# a_15077_1842# VSS.t1282 sg13_lv_nmos ad=0.1406p pd=1.12u as=0.2516p ps=2.16u w=0.74u l=0.13u
X3470 VSS.t894 VSS.t891 VSS.t893 VSS.t892 sg13_lv_nmos ad=0.2516p pd=2.16u as=0 ps=0 w=0.74u l=0.6u
X3471 VDD.t488 a_25717_7532# a_26185_6734# VDD.t29 sg13_lv_pmos ad=0.252p pd=1.57u as=0.3808p ps=2.92u w=1.12u l=0.13u
X3472 VSS.t506 a_4187_1764.t123 a_10191_14024# VSS.t1087 sg13_lv_nmos ad=0.2516p pd=2.16u as=0.1406p ps=1.12u w=0.74u l=0.6u
X3473 VDD.t1300 a_19203_1842# a_19637_1842# VDD.t353 sg13_lv_pmos ad=0.2128p pd=1.5u as=0.3808p ps=2.92u w=1.12u l=0.13u
X3474 a_16108_289# a_20905_519# a_19550_1044# VDD.t0 sg13_lv_pmos ad=0.3808p pd=2.92u as=0.3808p ps=2.92u w=1.12u l=0.13u
X3475 VSS.t508 a_16851_3154# CHAN2_MUX_OUT VSS.t1417 sg13_lv_nmos ad=0.2516p pd=2.16u as=0.1406p ps=1.12u w=0.74u l=0.13u
X3476 VSS.t111 a_2019_1047.t9 a_4324_1008# VSS.t346 sg13_lv_nmos ad=0.2516p pd=2.16u as=0.2516p ps=2.16u w=0.74u l=0.13u
X3477 VDD.t930 a_10517_16869# a_10985_16071# VDD.t20 sg13_lv_pmos ad=0.252p pd=1.57u as=0.3808p ps=2.92u w=1.12u l=0.13u
X3478 VSS.t2114 a_1544_15316# a_1815_15358# VSS.t2068 sg13_lv_nmos ad=0.1331p pd=1.12u as=0.1216p ps=1.02u w=0.64u l=0.13u
X3479 a_17791_14652# a_17553_14024# a_17683_14024# VDD.t381 sg13_lv_pmos ad=0.2128p pd=1.5u as=0.3808p ps=2.92u w=1.12u l=0.2u
X3480 VDD.t423 a_4437_7532# a_4905_6734# VDD.t29 sg13_lv_pmos ad=0.252p pd=1.57u as=0.3808p ps=2.92u w=1.12u l=0.13u
X3481 a_16510_1044# a_3747_1047.t5 a_18795_1044# VSS.t248 sg13_lv_nmos ad=0.2516p pd=2.16u as=0.1406p ps=1.12u w=0.74u l=0.13u
X3482 VDD.t173 VSS.t739 VDD.t172 VDD.t9 sg13_lv_pmos ad=0.19p pd=1.38u as=0 ps=0 w=1u l=1u
X3483 a_16108_15316# a_17865_15546# a_16510_16071# VDD.t20 sg13_lv_pmos ad=0.3808p pd=2.92u as=0.3808p ps=2.92u w=1.12u l=0.13u
X3484 VSS.t941 VSS.t943 VSS.t943 VSS.t944 sg13_lv_nmos ad=0.1406p pd=1.12u as=0 ps=0 w=0.74u l=0.2u
X3485 a_27915_3889# a_27705_3889# VSS.t1754 VSS.t1933 sg13_lv_nmos ad=0.1406p pd=1.12u as=0.1665p ps=1.19u w=0.74u l=0.13u
X3486 VSS.t125 CHAN2_MUX_SEL1 a_3543_4240# VSS.t124 sg13_lv_nmos ad=0.1331p pd=1.12u as=0.1216p ps=1.02u w=0.64u l=0.13u
X3487 a_5731_12471# a_14825_12701# a_13470_13226# VDD.t36 sg13_lv_pmos ad=0.3808p pd=2.92u as=0.3808p ps=2.92u w=1.12u l=0.13u
X3488 VDD.t773 a_4187_2434# a_18551_14652# VDD.t381 sg13_lv_pmos ad=0.3808p pd=2.92u as=0.2128p ps=1.5u w=1.12u l=0.6u
X3489 VDD.t1273 a_8563_1842# a_8997_1842# VDD.t353 sg13_lv_pmos ad=0.2128p pd=1.5u as=0.3808p ps=2.92u w=1.12u l=0.13u
X3490 a_26911_16869# a_26673_16869# a_26803_16869# VSS.t1529 sg13_lv_nmos ad=0.1406p pd=1.12u as=0.2516p ps=2.16u w=0.74u l=0.2u
X3491 VDD.t1357 a_3449_16422# a_3747_16074.t0 VDD.t20 sg13_lv_pmos ad=0.4256p pd=3u as=0.2128p ps=1.5u w=1.12u l=0.13u
X3492 VSS.t1461 a_4187_1764.t15 a_17791_1842# VSS.t2389 sg13_lv_nmos ad=0.2516p pd=2.16u as=0.1406p ps=1.12u w=0.74u l=0.6u
X3493 a_16271_7532# a_16033_7532# a_16163_7532# VSS.t1517 sg13_lv_nmos ad=0.1406p pd=1.12u as=0.2516p ps=2.16u w=0.74u l=0.2u
X3494 VSS.t418 VDD.t1634 VSS.t786 VSS.t785 sg13_lv_nmos ad=0.1428p pd=1.52u as=0 ps=0 w=0.42u l=1u
X3495 VDD.t918 a_4187_2434# a_13231_2470# VDD.t353 sg13_lv_pmos ad=0.3808p pd=2.92u as=0.2128p ps=1.5u w=1.12u l=0.6u
X3496 a_13753_16869# a_13557_16869# VDD.t707 VDD.t365 sg13_lv_pmos ad=0.3808p pd=2.92u as=0.2128p ps=1.5u w=1.12u l=0.13u
X3497 VDD.t468 a_3747_1047.t5 a_18871_1008# VDD.t0 sg13_lv_pmos ad=0.3808p pd=2.92u as=0.3808p ps=2.92u w=1.12u l=0.13u
X3498 VSS.t1064 a_12363_14024# a_12797_14024# VSS.t1415 sg13_lv_nmos ad=0.1406p pd=1.12u as=0.2516p ps=2.16u w=0.74u l=0.13u
X3499 VSS.t2378 a_4187_1764.t132 a_27671_16869# VSS.t2377 sg13_lv_nmos ad=0.2516p pd=2.16u as=0.1406p ps=1.12u w=0.74u l=0.6u
X3500 a_14009_10774# REF_DELAY_OUT_LAST VSS.t37 VSS.t1234 sg13_lv_nmos ad=0.2516p pd=2.16u as=1.45407p ps=9.445u w=0.74u l=0.13u
X3501 VDD.t1444 a_3171_6737.t8 a_8884_6698# VDD.t29 sg13_lv_pmos ad=0.3808p pd=2.92u as=0.3808p ps=2.92u w=1.12u l=0.13u
X3502 a_22351_16869# a_22113_16869# a_22243_16869# VSS.t2308 sg13_lv_nmos ad=0.1406p pd=1.12u as=0.2516p ps=2.16u w=0.74u l=0.2u
X3503 a_8671_14024# a_8433_14024# a_8563_14024# VSS.t1940 sg13_lv_nmos ad=0.1406p pd=1.12u as=0.2516p ps=2.16u w=0.74u l=0.2u
X3504 VSS.t1574 a_4187_1764.t98 VSS.t1576 VSS.t1575 sg13_lv_nmos ad=1.33p pd=7.38u as=0 ps=0 w=7u l=7u
X3505 VDD.t285 VSS.t656 VDD.t284 VDD.t36 sg13_lv_pmos ad=0.34p pd=2.68u as=0 ps=0 w=1u l=1u
X3506 VDD.t1400 a_23003_1842# a_23437_1842# VDD.t353 sg13_lv_pmos ad=0.2128p pd=1.5u as=0.3808p ps=2.92u w=1.12u l=0.13u
X3507 VDD.t124 VSS.t100 VDD.t123 VDD.t9 sg13_lv_pmos ad=0.34p pd=2.68u as=0 ps=0 w=1u l=1u
X3508 a_7390_3889# a_8231_3853# a_8155_3889# VDD.t9 sg13_lv_pmos ad=0.3808p pd=2.92u as=0.2128p ps=1.5u w=1.12u l=0.13u
X3509 VDD.t194 VSS.t612 VDD.t200 VDD.t20 sg13_lv_pmos ad=0.34p pd=2.68u as=0 ps=0 w=1u l=1u
X3510 VSS.t370 a_4187_1764.t124 a_9431_14024# VSS.t1716 sg13_lv_nmos ad=0.2516p pd=2.16u as=0.1406p ps=1.12u w=0.74u l=0.6u
X3511 VDD.t453 VDD.t617 VDD.t624 VDD.t351 sg13_lv_pmos ad=0.38p pd=2.38u as=0 ps=0 w=2u l=1u
X3512 VSS.t231 a_26803_14024# a_27237_14024# VSS.t432 sg13_lv_nmos ad=0.1406p pd=1.12u as=0.2516p ps=2.16u w=0.74u l=0.13u
X3513 VSS.t2065 a_1721_13577# a_2019_13229.t1 VSS.t2066 sg13_lv_nmos ad=0.2812p pd=2.24u as=0.1406p ps=1.12u w=0.74u l=0.13u
X3514 a_19073_7532# a_18877_7532# VDD.t735 VDD.t341 sg13_lv_pmos ad=0.3808p pd=2.92u as=0.2128p ps=1.5u w=1.12u l=0.13u
X3515 a_12715_1044# a_12505_1044# VDD.t1187 VDD.t0 sg13_lv_pmos ad=0.2128p pd=1.5u as=0.252p ps=1.57u w=1.12u l=0.13u
X3516 VSS.t1289 a_21157_7532# a_21625_6734# VSS.t1610 sg13_lv_nmos ad=0.1665p pd=1.19u as=0.2516p ps=2.16u w=0.74u l=0.13u
X3517 VDD.t1009 a_2019_16074.t9 a_4324_16035# VDD.t20 sg13_lv_pmos ad=0.3808p pd=2.92u as=0.3808p ps=2.92u w=1.12u l=0.13u
X3518 a_17928_1044# a_17357_1842# VDD.t1361 VDD.t0 sg13_lv_pmos ad=0.2128p pd=1.5u as=0.3808p ps=2.92u w=1.12u l=0.13u
X3519 a_13045_11905# a_13019_11521# a_12849_11557# VSS.t318 sg13_lv_nmos ad=0.1406p pd=1.12u as=0.1406p ps=1.12u w=0.74u l=0.13u
X3520 a_19550_1044# a_21044_1008# a_20968_1044# VDD.t0 sg13_lv_pmos ad=0.3808p pd=2.92u as=0.2128p ps=1.5u w=1.12u l=0.13u
X3521 a_2967_6021# REF_MUX_SEL3 a_2873_6021# VSS.t123 sg13_lv_nmos ad=0.1216p pd=1.02u as=0.2176p ps=1.96u w=0.64u l=0.13u
X3522 VSS.t435 a_1544_289# a_1815_331# VSS.t2288 sg13_lv_nmos ad=0.1331p pd=1.12u as=0.1216p ps=1.02u w=0.64u l=0.13u
X3523 VSS.t2058 a_4187_1764.t10 a_21591_1842# VSS.t2374 sg13_lv_nmos ad=0.2516p pd=2.16u as=0.1406p ps=1.12u w=0.74u l=0.6u
X3524 a_20071_7532# a_19833_7532# a_19963_7532# VSS.t1811 sg13_lv_nmos ad=0.1406p pd=1.12u as=0.2516p ps=2.16u w=0.74u l=0.2u
X3525 VSS.t342 a_15077_16869# a_15545_16071# VSS.t341 sg13_lv_nmos ad=0.1665p pd=1.19u as=0.2516p ps=2.16u w=0.74u l=0.13u
X3526 a_13592_11113# a_13566_11018# VSS.t1181 VSS.t1648 sg13_lv_nmos ad=0.2516p pd=2.16u as=0.1626p ps=1.415u w=0.74u l=0.13u
X3527 a_7288_1044# a_6717_1842# VDD.t1587 VDD.t0 sg13_lv_pmos ad=0.2128p pd=1.5u as=0.3808p ps=2.92u w=1.12u l=0.13u
X3528 a_22873_4687# a_22677_4687# VSS.t560 VSS.t1395 sg13_lv_nmos ad=0.2516p pd=2.16u as=0.1406p ps=1.12u w=0.74u l=0.13u
X3529 VSS.t2004 a_2019_13229.t2 a_25604_13190# VSS.t2003 sg13_lv_nmos ad=0.2516p pd=2.16u as=0.2516p ps=2.16u w=0.74u l=0.13u
X3530 a_13400_11995# a_12355_11557# a_13306_11995# VSS.t1343 sg13_lv_nmos ad=60.89999f pd=0.71u as=0.1428p ps=1.52u w=0.42u l=0.13u
X3531 VSS.t903 VSS.t901 VSS.t901 VSS.t902 sg13_lv_nmos ad=0.68p pd=4.68u as=0 ps=0 w=2u l=1u
X3532 VSS.t198 a_14643_7532# a_15077_7532# VSS.t197 sg13_lv_nmos ad=0.1406p pd=1.12u as=0.2516p ps=2.16u w=0.74u l=0.13u
X3533 a_27915_6734# a_27705_6734# VDD.t1159 VDD.t29 sg13_lv_pmos ad=0.2128p pd=1.5u as=0.252p ps=1.57u w=1.12u l=0.13u
X3534 VSS.t316 a_3171_16074.t3 a_24084_16035# VSS.t315 sg13_lv_nmos ad=0.2516p pd=2.16u as=0.2516p ps=2.16u w=0.74u l=0.13u
X3535 VDD.t571 a_19203_7532# a_19637_7532# VDD.t341 sg13_lv_pmos ad=0.2128p pd=1.5u as=0.3808p ps=2.92u w=1.12u l=0.13u
X3536 VDD.t1161 a_12037_4687# a_12505_3889# VDD.t9 sg13_lv_pmos ad=0.252p pd=1.57u as=0.3808p ps=2.92u w=1.12u l=0.13u
X3537 a_14513_4687# a_14317_4687# VDD.t362 VDD.t339 sg13_lv_pmos ad=0.3808p pd=2.92u as=0.2128p ps=1.5u w=1.12u l=0.13u
X3538 a_13231_16869# a_12993_16869# a_13123_16869# VSS.t2303 sg13_lv_nmos ad=0.1406p pd=1.12u as=0.2516p ps=2.16u w=0.74u l=0.2u
X3539 VDD.t207 VSS.t665 VDD.t206 VDD.t36 sg13_lv_pmos ad=0.34p pd=2.68u as=0 ps=0 w=1u l=1u
X3540 a_5631_5315# a_5393_4687# a_5523_4687# VDD.t339 sg13_lv_pmos ad=0.2128p pd=1.5u as=0.3808p ps=2.92u w=1.12u l=0.2u
X3541 VDD.t229 VSS.t640 VDD.t227 VDD.t20 sg13_lv_pmos ad=0.19p pd=1.38u as=0 ps=0 w=1u l=1u
X3542 VSS.t1032 a_2019_6737.t9 a_4324_6698# VSS.t1076 sg13_lv_nmos ad=0.2516p pd=2.16u as=0.2516p ps=2.16u w=0.74u l=0.13u
X3543 VDD.t1061 a_18117_14024# a_18585_13226# VDD.t36 sg13_lv_pmos ad=0.252p pd=1.57u as=0.3808p ps=2.92u w=1.12u l=0.13u
X3544 VSS.t1229 a_1544_12471# a_1815_12513# VSS.t1228 sg13_lv_nmos ad=0.1331p pd=1.12u as=0.1216p ps=1.02u w=0.64u l=0.13u
X3545 a_16510_6734# a_3747_6737.t5 a_18795_6734# VSS.t486 sg13_lv_nmos ad=0.2516p pd=2.16u as=0.1406p ps=1.12u w=0.74u l=0.13u
X3546 VSS.t1196 a_4187_1764.t150 a_13991_16869# VSS.t2368 sg13_lv_nmos ad=0.2516p pd=2.16u as=0.1406p ps=1.12u w=0.74u l=0.6u
X3547 a_24393_14024# a_24197_14024# VSS.t469 VSS.t1558 sg13_lv_nmos ad=0.2516p pd=2.16u as=0.1406p ps=1.12u w=0.74u l=0.13u
X3548 a_15511_2470# a_15273_1842# a_15403_1842# VDD.t353 sg13_lv_pmos ad=0.2128p pd=1.5u as=0.3808p ps=2.92u w=1.12u l=0.2u
X3549 a_14751_17497# a_14513_16869# a_14643_16869# VDD.t365 sg13_lv_pmos ad=0.2128p pd=1.5u as=0.3808p ps=2.92u w=1.12u l=0.2u
X3550 a_19073_16869# a_18877_16869# VDD.t549 VDD.t365 sg13_lv_pmos ad=0.3808p pd=2.92u as=0.2128p ps=1.5u w=1.12u l=0.13u
X3551 a_22590_1044# a_24951_1008# a_24875_1044# VDD.t0 sg13_lv_pmos ad=0.3808p pd=2.92u as=0.2128p ps=1.5u w=1.12u l=0.13u
X3552 VSS.t953 VSS.t954 VSS.t953 VSS.t955 sg13_lv_nmos ad=0.1406p pd=1.12u as=0 ps=0 w=0.74u l=0.2u
X3553 VSS.t3 a_17683_14024# a_18117_14024# VSS.t1822 sg13_lv_nmos ad=0.1406p pd=1.12u as=0.2516p ps=2.16u w=0.74u l=0.13u
X3554 VDD.t1245 a_8563_7532# a_8997_7532# VDD.t341 sg13_lv_pmos ad=0.2128p pd=1.5u as=0.3808p ps=2.92u w=1.12u l=0.13u
X3555 VSS.t448 a_4187_1764.t109 a_20831_14024# VSS.t447 sg13_lv_nmos ad=0.2516p pd=2.16u as=0.1406p ps=1.12u w=0.74u l=0.6u
X3556 a_11848_13226# a_11277_14024# VDD.t945 VDD.t36 sg13_lv_pmos ad=0.2128p pd=1.5u as=0.3808p ps=2.92u w=1.12u l=0.13u
X3557 VDD.t1301 a_3171_13229.t2 a_27124_13190# VDD.t36 sg13_lv_pmos ad=0.3808p pd=2.92u as=0.3808p ps=2.92u w=1.12u l=0.13u
X3558 a_6126_9506# a_6126_9506# VSS.t957 VSS.t956 sg13_lv_nmos ad=0.38p pd=2.38u as=0.68p ps=4.68u w=2u l=1u
X3559 VSS.t165 a_4187_1764.t79 a_17791_7532# VSS.t457 sg13_lv_nmos ad=0.2516p pd=2.16u as=0.1406p ps=1.12u w=0.74u l=0.6u
X3560 VSS.t841 VDD.t1620 VSS.t841 VSS.t842 sg13_lv_nmos ad=79.8f pd=0.8u as=0 ps=0 w=0.42u l=1u
X3561 VDD.t872 a_4187_2434# a_13231_8160# VDD.t341 sg13_lv_pmos ad=0.3808p pd=2.92u as=0.2128p ps=1.5u w=1.12u l=0.6u
X3562 VSS.t1061 a_3747_16074.t5 a_18871_16035# VSS.t2193 sg13_lv_nmos ad=0.2516p pd=2.16u as=0.2516p ps=2.16u w=0.74u l=0.13u
X3563 VSS.t665 a_2595_12493.t2 a_20905_12701# VSS.t2265 sg13_lv_nmos ad=0.2516p pd=2.16u as=0.2516p ps=2.16u w=0.74u l=0.13u
X3564 a_4633_4687# a_4437_4687# VDD.t1146 VDD.t339 sg13_lv_pmos ad=0.3808p pd=2.92u as=0.2128p ps=1.5u w=1.12u l=0.13u
X3565 a_13753_14024# a_13557_14024# VDD.t1005 VDD.t381 sg13_lv_pmos ad=0.3808p pd=2.92u as=0.2128p ps=1.5u w=1.12u l=0.13u
X3566 VSS.t2383 a_3747_15338.t2 a_26985_15546# VSS.t2382 sg13_lv_nmos ad=0.2516p pd=2.16u as=0.2516p ps=2.16u w=0.74u l=0.13u
X3567 VDD.t551 a_23003_7532# a_23437_7532# VDD.t341 sg13_lv_pmos ad=0.2128p pd=1.5u as=0.3808p ps=2.92u w=1.12u l=0.13u
X3568 a_22873_16869# a_22677_16869# VSS.t223 VSS.t2307 sg13_lv_nmos ad=0.2516p pd=2.16u as=0.1406p ps=1.12u w=0.74u l=0.13u
X3569 VDD.t183 VSS.t462 VDD.t182 VDD.t36 sg13_lv_pmos ad=0.19p pd=1.38u as=0 ps=0 w=1u l=1u
X3570 VSS.t396 VDD.t1660 VSS.t396 VSS.t717 sg13_lv_nmos ad=0.1428p pd=1.52u as=0 ps=0 w=0.42u l=1u
X3571 VSS.t906 VSS.t898 VSS.t898 VSS.t899 sg13_lv_nmos ad=0.68p pd=4.68u as=0 ps=0 w=2u l=1u
X3572 a_10430_1044# a_2019_1047.t7 a_10328_1044# VSS.t352 sg13_lv_nmos ad=0.2516p pd=2.16u as=0.1406p ps=1.12u w=0.74u l=0.13u
X3573 VSS.t709 VDD.t1662 VSS.t709 VSS.t714 sg13_lv_nmos ad=79.8f pd=0.8u as=0 ps=0 w=0.42u l=1u
X3574 a_4157_7003# REF_CLK VDD.t1234 VDD.t29 sg13_lv_pmos ad=0.3808p pd=2.92u as=0.3808p ps=2.92u w=1.12u l=0.13u
X3575 VSS.t456 a_16163_16869# a_16597_16869# VSS.t2173 sg13_lv_nmos ad=0.1406p pd=1.12u as=0.2516p ps=2.16u w=0.74u l=0.13u
X3576 VDD.t1457 a_25717_1842# a_26185_1044# VDD.t0 sg13_lv_pmos ad=0.252p pd=1.57u as=0.3808p ps=2.92u w=1.12u l=0.13u
X3577 VSS.t100 a_2595_3156.t2 a_20905_3364# VSS.t1270 sg13_lv_nmos ad=0.2516p pd=2.16u as=0.2516p ps=2.16u w=0.74u l=0.13u
X3578 VSS.t462 VDD.t1674 VSS.t462 VSS.t684 sg13_lv_nmos ad=0.1428p pd=1.52u as=0 ps=0 w=0.42u l=1u
X3579 VSS.t313 a_3171_16074.t6 a_14964_16035# VSS.t312 sg13_lv_nmos ad=0.2516p pd=2.16u as=0.2516p ps=2.16u w=0.74u l=0.13u
X3580 VSS.t702 a_3171_6001.t3 a_11785_6209# VSS.t1841 sg13_lv_nmos ad=0.2516p pd=2.16u as=0.2516p ps=2.16u w=0.74u l=0.13u
X3581 a_4633_14024# a_4437_14024# VSS.t1122 VSS.t1926 sg13_lv_nmos ad=0.2516p pd=2.16u as=0.1406p ps=1.12u w=0.74u l=0.13u
X3582 VSS.t1222 a_3171_13229.t7 a_11924_13190# VSS.t2011 sg13_lv_nmos ad=0.2516p pd=2.16u as=0.2516p ps=2.16u w=0.74u l=0.13u
X3583 VSS.t1403 a_11603_16869# a_12037_16869# VSS.t1402 sg13_lv_nmos ad=0.1406p pd=1.12u as=0.2516p ps=2.16u w=0.74u l=0.13u
X3584 VSS.t643 a_2019_12493.t3 a_5705_12701# VSS.t1650 sg13_lv_nmos ad=0.2516p pd=2.16u as=0.2516p ps=2.16u w=0.74u l=0.13u
X3585 VDD.t760 a_4437_1842# a_4905_1044# VDD.t0 sg13_lv_pmos ad=0.252p pd=1.57u as=0.3808p ps=2.92u w=1.12u l=0.13u
X3586 VDD.t1008 a_13883_1842# a_14317_1842# VDD.t353 sg13_lv_pmos ad=0.2128p pd=1.5u as=0.3808p ps=2.92u w=1.12u l=0.13u
X3587 VSS.t14 a_4187_1764.t74 a_21591_7532# VSS.t540 sg13_lv_nmos ad=0.2516p pd=2.16u as=0.1406p ps=1.12u w=0.74u l=0.6u
X3588 a_4157_1313# CHAN3_DELAY_IN VSS.t41 VSS.t40 sg13_lv_nmos ad=0.2516p pd=2.16u as=0.2553p ps=2.17u w=0.74u l=0.13u
X3589 a_7390_1044# a_3171_1047.t8 a_8808_1044# VSS.t334 sg13_lv_nmos ad=0.2516p pd=2.16u as=0.1406p ps=1.12u w=0.74u l=0.13u
X3590 a_7390_3889# a_2595_3892.t8 a_8155_3889# VSS.t1481 sg13_lv_nmos ad=0.2516p pd=2.16u as=0.1406p ps=1.12u w=0.74u l=0.13u
X3591 VSS.t643 VDD.t1689 VSS.t643 VSS.t648 sg13_lv_nmos ad=79.8f pd=0.8u as=0 ps=0 w=0.42u l=1u
X3592 VSS.t1066 a_4187_1764.t121 a_11711_14024# VSS.t1065 sg13_lv_nmos ad=0.2516p pd=2.16u as=0.1406p ps=1.12u w=0.74u l=0.6u
X3593 a_22873_1842# a_22677_1842# VSS.t2054 VSS.t2056 sg13_lv_nmos ad=0.2516p pd=2.16u as=0.1406p ps=1.12u w=0.74u l=0.13u
X3594 a_25391_14024# a_25153_14024# a_25283_14024# VSS.t2327 sg13_lv_nmos ad=0.1406p pd=1.12u as=0.2516p ps=2.16u w=0.74u l=0.2u
X3595 a_10328_3889# a_9757_4687# VDD.t1156 VDD.t9 sg13_lv_pmos ad=0.2128p pd=1.5u as=0.3808p ps=2.92u w=1.12u l=0.13u
X3596 VSS.t438 a_2019_15338.t2 a_17865_15546# VSS.t437 sg13_lv_nmos ad=0.2516p pd=2.16u as=0.2516p ps=2.16u w=0.74u l=0.13u
X3597 VDD.t506 a_3171_1047.t8 a_8884_1008# VDD.t0 sg13_lv_pmos ad=0.3808p pd=2.92u as=0.3808p ps=2.92u w=1.12u l=0.13u
X3598 VDD.t1089 a_12037_16869# a_12505_16071# VDD.t20 sg13_lv_pmos ad=0.252p pd=1.57u as=0.3808p ps=2.92u w=1.12u l=0.13u
C0 a_11848_16071# VDD 0.17499f
C1 a_15304_10295# VDD 0.72158f
C2 a_12505_6734# VDD 0.29722f
C3 a_27563_4687# VDD 0.50391f
C4 a_6283_1842# VDD 0.50001f
C5 a_12715_1044# VDD 0.15407f
C6 a_1256_3134# CHAN2_MUX_SEL2 0.33134f
C7 CHAN0_MUX_OUT CHAN1_DELAY_IN 0.05155f
C8 a_20397_16869# a_20593_16869# 0.76914f
C9 a_10083_16869# a_10191_17497# 0.01697f
C10 a_4187_2434# a_15273_14024# 0.11222f
C11 a_24957_14024# a_24523_14024# 0.6972f
C12 a_4187_2434# a_27997_7532# 0.04038f
C13 a_4187_2434# a_6717_4687# 0.0414f
C14 a_11277_7532# a_11473_7532# 0.76914f
C15 a_14317_7532# a_14888_6734# 0.10863f
C16 a_15837_4687# a_16597_4687# 0.06198f
C17 a_20397_1842# a_20723_1842# 0.01427f
C18 a_24875_3889# a_24951_3853# 0.01194f
C19 a_18443_14024# VDD 0.50001f
C20 a_1544_12471# VDD 0.39332f
C21 a_13231_8160# VDD 0.01806f
C22 a_9953_4687# VDD 0.4958f
C23 a_16484_3853# VDD 0.29019f
C24 a_15765_6153# REF_MUX_SEL4 0.65508f
C25 a_4187_2434# a_18443_16869# 0.06627f
C26 a_14317_16869# a_14888_16071# 0.10863f
C27 a_11277_16869# a_12037_16869# 0.03319f
C28 a_15837_14024# a_16033_14024# 0.76914f
C29 a_4187_2434# a_9323_7532# 0.06627f
C30 a_19637_14024# a_19524_13190# 0.05157f
C31 a_4187_2434# a_19073_1842# 0.11222f
C32 a_6717_4687# a_7043_4687# 0.01427f
C33 a_5731_5979# a_13753_4687# 0.01865f
C34 a_6635_6734# a_6711_6698# 0.01194f
C35 a_16108_3134# a_20593_1842# 0.01872f
C36 a_11473_1842# a_12037_1842# 0.0114f
C37 a_23145_3889# a_23355_3889# 0.09424f
C38 a_22677_16869# VDD 0.86715f
C39 a_15403_1842# a_13470_1044# 0.01012f
C40 a_24197_1842# a_24665_1044# 0.2079f
C41 a_13557_7532# VDD 0.86712f
C42 a_4324_13190# VDD 0.28607f
C43 a_21044_6698# VDD 0.28225f
C44 a_22243_1842# VDD 0.50007f
C45 a_2873_16422# CHAN0_MUX_SEL0 0.01504f
C46 a_5731_12471# REF_CLK 0.02937f
C47 CHAN3_MUX_SEL0 CHAN3_MUX_SEL1 3.14917f
C48 a_5731_15316# a_13123_14024# 0.01539f
C49 a_12505_16071# a_12791_16035# 0.01885f
C50 a_6717_14024# a_7477_14024# 0.06198f
C51 a_4187_2434# a_22677_4687# 0.0414f
C52 a_24665_13226# a_22590_13226# 0.03208f
C53 a_12849_11557# a_13566_11525# 0.27346f
C54 a_12715_13226# a_12791_13190# 0.01194f
C55 a_13121_11521# a_13592_11561# 0.01445f
C56 a_1544_6734# a_2297_7085# 0.28651f
C57 a_19073_7532# a_19637_7532# 0.0114f
C58 a_23437_7532# a_24008_6734# 0.10863f
C59 a_15403_4687# a_15511_5315# 0.01697f
C60 a_23633_4687# a_23763_4687# 0.70845f
C61 a_9323_4687# a_9431_4687# 0.01163f
C62 a_4157_4158# a_4248_3889# 0.11672f
C63 a_15964_3134# a_16851_3154# 0.16757f
C64 a_4003_16869# VDD 0.61559f
C65 a_15545_1044# a_13470_1044# 0.03208f
C66 a_8884_16035# VDD 0.28358f
C67 a_23871_14652# VDD 0.01806f
C68 a_25913_4687# VDD 0.49559f
C69 a_3449_7085# VDD 0.46731f
C70 a_9751_1008# VDD 0.2822f
C71 a_4633_1842# VDD 0.49523f
C72 a_1544_1044# CHAN3_MUX_SEL4 0.03407f
C73 a_1256_1044# CHAN3_MUX_OUT 0.02199f
C74 a_2297_1395# CHAN3_MUX_SEL0 0.10655f
C75 a_1256_16071# a_2297_16422# 0.04619f
C76 a_4187_2434# a_13557_14024# 0.0414f
C77 a_23437_16869# a_24008_16071# 0.10863f
C78 a_19073_16869# a_19203_16869# 0.70845f
C79 a_8563_16869# a_8671_17497# 0.01697f
C80 a_22590_16071# a_16108_15316# 0.55709f
C81 a_1544_15316# a_2297_15358# 0.27303f
C82 a_1256_15316# a_2873_15358# 0.27926f
C83 a_4187_2434# a_4003_4687# 0.05992f
C84 a_23633_14024# a_24197_14024# 0.0114f
C85 a_4187_2434# a_25283_7532# 0.064f
C86 a_15964_12471# a_16108_12471# 0.42202f
C87 a_5731_12471# a_6126_9506# 0.02557f
C88 a_9953_7532# a_10083_7532# 0.70361f
C89 a_16108_5979# a_26803_4687# 0.01192f
C90 a_16510_6734# a_17928_6734# 0.38994f
C91 a_15077_4687# a_14643_4687# 0.6972f
C92 a_19637_1842# a_19833_1842# 0.73897f
C93 a_23355_3889# a_23431_3853# 0.01194f
C94 a_22590_3889# a_24084_3853# 0.28279f
C95 a_15837_1842# a_15964_289# 0.01935f
C96 a_22590_1044# a_23945_519# 0.02138f
C97 a_24523_1842# a_22590_1044# 0.01012f
C98 a_1544_289# a_2019_311# 0.01747f
C99 a_16793_14024# VDD 0.54169f
C100 a_7151_8160# VDD 0.01806f
C101 a_25604_13190# VDD 0.28633f
C102 a_8237_4687# VDD 0.8736f
C103 a_14235_3889# VDD 0.1539f
C104 a_12907_10876# DLL_RESETN 0.02177f
C105 a_5731_5979# REF_MUX_SEL4 4.60702f
C106 a_4187_2434# a_16793_16869# 0.11113f
C107 a_10517_16869# a_10083_16869# 0.69698f
C108 a_4187_2434# a_25630_16071# 0.02246f
C109 a_14513_14024# a_14643_14024# 0.70845f
C110 a_16510_16071# a_17351_16035# 0.28268f
C111 a_4187_2434# a_7673_7532# 0.11222f
C112 a_22590_13226# a_24008_13226# 0.38994f
C113 a_4187_2434# a_17357_1842# 0.0414f
C114 a_27237_7532# a_27433_7532# 0.77122f
C115 a_12505_6734# a_10430_6734# 0.03208f
C116 a_5115_6734# a_5191_6698# 0.01194f
C117 a_4350_6734# a_5844_6698# 0.28279f
C118 a_5731_5979# a_12037_4687# 0.01319f
C119 a_5957_4687# a_6153_4687# 0.77122f
C120 a_10430_3889# a_12715_3889# 0.39036f
C121 a_8237_4687# a_8808_3889# 0.10863f
C122 a_16108_3134# a_18877_1842# 0.01307f
C123 a_10517_1842# a_11277_1842# 0.01669f
C124 a_19963_16869# VDD 0.4973f
C125 a_16510_1044# a_18871_1008# 0.26208f
C126 a_5705_15546# VDD 0.29556f
C127 a_21625_13226# VDD 0.29742f
C128 a_10843_7532# VDD 0.4973f
C129 a_18795_6734# VDD 0.15406f
C130 a_1256_16071# CHAN0_MUX_SEL0 0.3314f
C131 a_20593_1842# VDD 0.49593f
C132 a_5705_12701# CHAN1_MUX_SEL4 0.03556f
C133 CHAN2_MUX_SEL4 CHAN2_MUX_OUT 0.91933f
C134 a_10985_16071# a_10430_16071# 0.03209f
C135 a_5957_14024# a_5523_14024# 0.6972f
C136 a_5731_15316# a_11473_14024# 0.01872f
C137 a_4350_16071# a_5768_16071# 0.38994f
C138 a_11195_13226# a_11271_13190# 0.01194f
C139 a_8997_14024# a_7390_13226# 0.05231f
C140 a_10430_13226# a_11924_13190# 0.28279f
C141 a_8237_14024# a_8231_13190# 0.02349f
C142 a_4187_2434# a_19963_4687# 0.06627f
C143 a_12355_11557# a_12849_11557# 0.07687f
C144 a_18117_7532# a_18877_7532# 0.02912f
C145 a_27915_6734# a_27991_6698# 0.01194f
C146 a_7803_4687# a_7911_4687# 0.01163f
C147 a_13883_4687# a_13991_5315# 0.01697f
C148 a_27433_1842# a_27997_1842# 0.0114f
C149 a_6635_16071# VDD 0.15406f
C150 a_17791_14652# VDD 0.01806f
C151 a_16108_3134# VDD 1.67139f
C152 a_24197_4687# VDD 0.93794f
C153 a_7288_1044# VDD 0.17274f
C154 a_7043_16869# a_7151_17497# 0.01697f
C155 a_4187_2434# a_10843_14024# 0.06627f
C156 a_22677_14024# a_23437_14024# 0.01669f
C157 a_4187_2434# a_23633_7532# 0.11286f
C158 a_21917_14024# a_16108_12471# 0.0157f
C159 a_13753_4687# a_14317_4687# 0.0114f
C160 a_16108_5979# a_25153_4687# 0.01872f
C161 a_17357_4687# a_17928_3889# 0.10863f
C162 a_18313_1842# a_18443_1842# 0.70845f
C163 a_1256_1044# a_1544_1044# 1.26509f
C164 a_15077_14024# VDD 0.86076f
C165 a_23355_13226# VDD 0.1539f
C166 a_26803_7532# VDD 0.49671f
C167 a_11271_3853# VDD 0.28357f
C168 a_5523_4687# VDD 0.49684f
C169 a_13470_16071# CHAN0_MUX_SEL4 0.256f
C170 a_2297_6021# REF_MUX_SEL4 0.04338f
C171 a_3449_6021# REF_MUX_SEL2 0.10741f
C172 a_2873_6021# REF_MUX_SEL3 0.12606f
C173 a_9193_16869# a_9757_16869# 0.0114f
C174 a_4187_2434# a_15077_16869# 0.04194f
C175 a_15755_16071# a_15831_16035# 0.01194f
C176 a_16108_15316# a_24523_14024# 0.01361f
C177 a_27705_16071# a_27991_16035# 0.01885f
C178 a_4187_2434# a_5957_7532# 0.04152f
C179 a_17357_14024# a_17351_13190# 0.02349f
C180 a_18117_14024# a_16510_13226# 0.05231f
C181 a_4187_2434# a_14643_1842# 0.06627f
C182 a_25913_7532# a_26043_7532# 0.70845f
C183 a_4633_4687# a_4763_4687# 0.70845f
C184 a_5731_5979# a_9323_4687# 0.01542f
C185 a_18585_3889# a_18871_3853# 0.01885f
C186 a_9757_1842# a_9323_1842# 0.6972f
C187 a_26803_1842# a_26911_1842# 0.01163f
C188 a_16408_1044# a_16510_1044# 0.37183f
C189 a_18313_16869# VDD 0.49288f
C190 a_27915_16071# VDD 0.15389f
C191 a_9465_13226# VDD 0.29742f
C192 a_9193_7532# VDD 0.49409f
C193 a_15831_6698# VDD 0.2816f
C194 a_1256_289# VDD 0.40593f
C195 a_18877_1842# VDD 0.88247f
C196 a_1256_12471# CHAN1_MUX_SEL2 0.33134f
C197 a_15464_9374# REF_DELAY_OUT_LAST 0.02565f
C198 CHAN2_MUX_SEL0 CHAN2_MUX_SEL1 3.14917f
C199 a_26477_16869# a_26043_16869# 0.6972f
C200 a_7945_16071# a_8231_16035# 0.01885f
C201 a_4187_2434# a_26803_14024# 0.06627f
C202 a_4633_14024# a_5197_14024# 0.0114f
C203 a_6717_14024# a_7364_13190# 0.02011f
C204 a_18585_13226# a_18795_13226# 0.09424f
C205 a_4187_2434# a_18313_4687# 0.11222f
C206 a_17357_7532# a_16923_7532# 0.6972f
C207 a_12158_11557# a_12355_11557# 0.12454f
C208 a_12363_4687# a_12471_5315# 0.01697f
C209 a_6283_4687# a_6391_4687# 0.01163f
C210 a_25630_6734# a_27124_6698# 0.28279f
C211 a_21917_4687# a_22113_4687# 0.76914f
C212 a_26395_6734# a_26471_6698# 0.01194f
C213 a_26477_4687# a_27048_3889# 0.10863f
C214 a_26477_1842# a_27237_1842# 0.03319f
C215 a_9465_1044# a_9675_1044# 0.09424f
C216 a_4248_1044# a_4324_1008# 0.01176f
C217 a_11711_14652# VDD 0.01806f
C218 a_21483_4687# VDD 0.50001f
C219 a_4350_1044# VDD 0.87635f
C220 a_15765_15490# CHAN0_MUX_SEL4 0.65508f
C221 a_5523_16869# a_5631_17497# 0.01697f
C222 a_17357_16869# a_17553_16869# 0.7425f
C223 a_4187_2434# a_9193_14024# 0.11222f
C224 a_4187_2434# a_21917_7532# 0.04176f
C225 a_25630_16071# a_27048_16071# 0.38994f
C226 a_16510_16071# a_17865_15546# 0.02165f
C227 a_21917_14024# a_21483_14024# 0.6972f
C228 a_26477_14024# a_26471_13190# 0.02349f
C229 a_27237_14024# a_25630_13226# 0.05253f
C230 a_8237_7532# a_8433_7532# 0.76914f
C231 a_10843_7532# a_10430_6734# 0.01012f
C232 a_13470_6734# a_15755_6734# 0.39036f
C233 a_27705_6734# a_25630_6734# 0.03208f
C234 a_12797_4687# a_13557_4687# 0.06198f
C235 a_16108_5979# a_23437_4687# 0.01319f
C236 a_19550_3889# a_21911_3853# 0.26208f
C237 a_22351_17497# VDD 0.01806f
C238 a_20391_13190# VDD 0.28336f
C239 a_12363_14024# VDD 0.50001f
C240 a_26985_6209# VDD 0.29292f
C241 a_25153_7532# VDD 0.49409f
C242 a_8808_3889# VDD 0.17577f
C243 a_23111_2470# VDD 0.01806f
C244 a_13566_11525# REF_CLK 0.01538f
C245 a_4157_4158# CHAN2_DELAY_IN 0.50642f
C246 a_8237_16869# a_8997_16869# 0.03319f
C247 a_4187_2434# a_12363_16869# 0.06627f
C248 a_13470_16071# a_14964_16035# 0.28279f
C249 a_10843_16869# a_10430_16071# 0.01012f
C250 a_14235_16071# a_14311_16035# 0.01194f
C251 a_26185_16071# a_25630_16071# 0.03209f
C252 a_12797_14024# a_12993_14024# 0.76914f
C253 a_16108_15316# a_22873_14024# 0.01865f
C254 a_15837_14024# a_16484_13190# 0.02011f
C255 a_4187_2434# a_9712_9602# 0.14197f
C256 a_19550_13226# a_21835_13226# 0.39036f
C257 a_13306_10795# a_13592_11113# 0.41329f
C258 a_15304_10295# a_15108_11015# 0.01986f
C259 a_13566_11018# a_14009_10774# 0.02242f
C260 a_4187_2434# a_12993_1842# 0.11222f
C261 a_6425_6734# a_6711_6698# 0.01885f
C262 a_5731_5979# a_7673_4687# 0.01865f
C263 a_17065_3889# a_16510_3889# 0.03209f
C264 a_8433_1842# a_8997_1842# 0.0114f
C265 a_25283_1842# a_25391_1842# 0.01163f
C266 a_11277_1842# a_11848_1044# 0.10863f
C267 a_14888_1044# a_14964_1008# 0.01176f
C268 a_24951_16035# VDD 0.2822f
C269 a_16597_16869# VDD 0.94678f
C270 a_7477_7532# VDD 0.86719f
C271 a_13368_6734# VDD 0.17274f
C272 a_16163_1842# VDD 0.94897f
C273 a_25630_1044# VDD 0.89531f
C274 REF_MUX_SEL4 REF_MUX_OUT 0.91933f
C275 a_25153_16869# a_25717_16869# 0.0114f
C276 a_4187_2434# a_25153_14024# 0.11169f
C277 a_6425_16071# a_6635_16071# 0.09424f
C278 a_5957_14024# a_5844_13190# 0.02055f
C279 a_5731_15316# a_7043_14024# 0.01539f
C280 a_10751_11568# a_11491_11918# 0.26905f
C281 a_4187_2434# a_16597_4687# 0.03917f
C282 a_7390_13226# a_9751_13190# 0.26208f
C283 a_16033_7532# a_16597_7532# 0.0114f
C284 a_19963_7532# a_19550_6734# 0.01012f
C285 a_20593_4687# a_20723_4687# 0.70845f
C286 a_10843_4687# a_10951_5315# 0.01697f
C287 a_4763_4687# a_4871_4687# 0.01163f
C288 a_25630_3889# a_26985_3364# 0.02195f
C289 a_25717_1842# a_25283_1842# 0.69698f
C290 a_17065_16071# VDD 0.3023f
C291 a_5631_14652# VDD 0.01806f
C292 a_10649_11568# VDD 0.24892f
C293 a_19833_4687# VDD 0.49553f
C294 a_3449_3176# VDD 0.47499f
C295 a_20105_1044# VDD 0.30411f
C296 a_5731_15316# CHAN0_MUX_SEL4 4.60702f
C297 a_4003_16869# a_4111_17497# 0.01697f
C298 a_16033_16869# a_16163_16869# 0.70361f
C299 a_4187_2434# a_7477_14024# 0.0414f
C300 a_19963_16869# a_19550_16071# 0.01012f
C301 a_4187_2434# a_19203_7532# 0.06661f
C302 a_20593_14024# a_21157_14024# 0.0114f
C303 a_5705_12701# a_5731_12471# 0.28954f
C304 a_24957_14024# a_25604_13190# 0.02011f
C305 a_9757_7532# a_10328_6734# 0.10864f
C306 a_16597_7532# a_17065_6734# 0.19203f
C307 a_6913_7532# a_7043_7532# 0.70845f
C308 a_12037_4687# a_11603_4687# 0.6972f
C309 a_16108_5979# a_20723_4687# 0.01544f
C310 a_16597_1842# a_16793_1842# 0.73897f
C311 a_19448_3889# a_19550_3889# 0.37183f
C312 a_20397_1842# a_20968_1044# 0.10863f
C313 a_25528_1044# a_25604_1008# 0.01176f
C314 a_16271_17497# VDD 0.02023f
C315 a_10713_14024# VDD 0.49553f
C316 a_17928_13226# VDD 0.17499f
C317 a_23437_7532# VDD 0.86935f
C318 a_14825_6209# VDD 0.29292f
C319 a_17031_2470# VDD 0.01806f
C320 a_5844_3853# VDD 0.28225f
C321 a_12656_11554# DLL_RESETN 0.11782f
C322 a_13019_11521# CHAN1_MUX_OUT 0.31842f
C323 a_12355_11557# REF_CLK 1.0042f
C324 a_1544_3889# CHAN2_MUX_SEL1 0.1672f
C325 a_1721_4240# CHAN2_MUX_SEL0 0.01315f
C326 a_2019_311# CHAN3_MUX_OUT 8.45486f
C327 a_4187_2434# a_10713_16869# 0.11222f
C328 a_9757_16869# a_10328_16071# 0.10864f
C329 a_16597_16869# a_17065_16071# 0.19203f
C330 a_7477_16869# a_7043_16869# 0.69698f
C331 a_23145_16071# a_23431_16035# 0.01885f
C332 a_16108_15316# a_21157_14024# 0.01319f
C333 a_11473_14024# a_11603_14024# 0.70845f
C334 a_15077_14024# a_14964_13190# 0.02055f
C335 a_13106_11047# a_13132_11110# 0.1657f
C336 a_12907_10876# a_12907_11110# 0.1117f
C337 a_4187_2434# a_11277_1842# 0.0414f
C338 a_24197_7532# a_24393_7532# 0.77122f
C339 a_4905_6734# a_4350_6734# 0.03209f
C340 a_16108_5979# a_17865_6209# 0.29564f
C341 a_4157_7003# a_4324_6698# 0.02463f
C342 a_5731_5979# a_5957_4687# 0.01644f
C343 a_7288_3889# a_7364_3853# 0.01176f
C344 a_4763_4687# a_4350_3889# 0.01012f
C345 a_14025_3889# a_14311_3853# 0.01885f
C346 a_5731_3134# a_14643_1842# 0.01544f
C347 a_7477_1842# a_8237_1842# 0.01669f
C348 a_13470_1044# a_13444_1008# 0.277f
C349 a_24665_1044# a_24875_1044# 0.09424f
C350 a_23763_1842# a_23871_1842# 0.01163f
C351 a_13883_16869# VDD 0.4973f
C352 a_22488_16071# VDD 0.17274f
C353 a_1544_13226# VDD 0.45079f
C354 a_4763_7532# VDD 0.4973f
C355 a_26911_5315# VDD 0.01806f
C356 a_10430_6734# VDD 0.88416f
C357 a_14513_1842# VDD 0.49594f
C358 a_22564_1008# VDD 0.28633f
C359 a_4187_2434# CHAN3_DELAY_IN 0.07719f
C360 a_4437_1842# CHAN3_DELAY_IN 0.05007f
C361 a_4633_1842# CHAN2_MUX_SEL4 0.01287f
C362 REF_MUX_SEL0 REF_MUX_SEL1 3.14917f
C363 a_24197_16869# a_24957_16869# 0.02912f
C364 a_16108_15316# a_16851_15336# 0.06181f
C365 a_4187_2434# a_23437_14024# 0.0414f
C366 a_4157_16340# a_4350_16071# 0.04624f
C367 a_8997_14024# a_9465_13226# 0.2079f
C368 a_5197_14024# a_4350_13226# 0.08038f
C369 a_7288_13226# a_7390_13226# 0.37183f
C370 a_4187_2434# a_13883_4687# 0.06627f
C371 a_14025_13226# a_14235_13226# 0.09424f
C372 a_18877_7532# a_19448_6734# 0.10864f
C373 a_15077_7532# a_15837_7532# 0.02912f
C374 a_22590_6734# a_24951_6698# 0.26208f
C375 a_9323_4687# a_9431_5315# 0.01697f
C376 a_24393_1842# a_24957_1842# 0.0114f
C377 a_4905_1044# a_5191_1008# 0.01885f
C378 a_26673_14024# VDD 0.49593f
C379 a_6425_16071# VDD 0.29722f
C380 a_16108_289# a_26985_519# 0.27952f
C381 a_9547_11632# VDD 0.15246f
C382 a_18117_4687# VDD 0.85999f
C383 a_27124_3853# VDD 0.28225f
C384 a_7945_1044# VDD 0.30411f
C385 a_2297_15358# CHAN0_MUX_SEL4 0.04338f
C386 a_3449_15358# CHAN0_MUX_SEL2 0.10741f
C387 a_2873_15358# CHAN0_MUX_SEL3 0.12606f
C388 a_4187_2434# a_4763_14024# 0.06627f
C389 a_18877_16869# a_19448_16071# 0.10864f
C390 a_4187_2434# a_26673_16869# 0.11222f
C391 a_22590_16071# a_24875_16071# 0.39036f
C392 a_24197_14024# a_24084_13190# 0.02055f
C393 a_4187_2434# a_17553_7532# 0.11194f
C394 a_19637_14024# a_20397_14024# 0.01669f
C395 a_4187_2434# a_27237_1842# 0.06189f
C396 a_9757_7532# a_7390_6734# 0.02479f
C397 a_16108_5979# a_19073_4687# 0.01872f
C398 a_10713_4687# a_11277_4687# 0.0114f
C399 a_21625_6734# a_21835_6734# 0.09424f
C400 a_13883_4687# a_13470_3889# 0.01012f
C401 a_17928_3889# a_18004_3853# 0.01176f
C402 a_15273_1842# a_15403_1842# 0.70845f
C403 a_10191_17497# VDD 0.01806f
C404 a_8997_14024# VDD 0.88864f
C405 a_14964_13190# VDD 0.28225f
C406 a_20723_7532# VDD 0.49671f
C407 a_27705_3889# VDD 0.29962f
C408 a_10951_2470# VDD 0.01806f
C409 a_10751_11568# DLL_RESETN 0.45018f
C410 a_1721_331# CHAN3_MUX_SEL2 0.01315f
C411 a_1256_289# CHAN3_MUX_SEL4 0.65005f
C412 VDD CHAN1_MUX_SEL1 0.5478f
C413 a_1544_289# CHAN3_MUX_SEL3 0.15976f
C414 a_9757_16869# a_7390_16071# 0.02479f
C415 a_6153_16869# a_6717_16869# 0.0114f
C416 a_4187_2434# a_8997_16869# 0.04106f
C417 a_10430_16071# a_12791_16035# 0.26208f
C418 a_16108_15316# a_18443_14024# 0.01542f
C419 a_14317_14024# a_13470_13226# 0.08038f
C420 a_22677_14024# a_23145_13226# 0.19203f
C421 a_4187_2434# a_8563_1842# 0.0635f
C422 a_22873_7532# a_23003_7532# 0.70845f
C423 a_7477_4687# a_7945_3889# 0.19203f
C424 a_27997_4687# a_27563_4687# 0.69646f
C425 a_22243_1842# a_22351_1842# 0.01163f
C426 a_5731_3134# a_12993_1842# 0.01872f
C427 a_6717_1842# a_6283_1842# 0.6972f
C428 a_12233_16869# VDD 0.49285f
C429 a_19550_16071# VDD 0.89766f
C430 a_5778_9057# VDD 0.01854f
C431 a_20831_5315# VDD 0.01806f
C432 a_7364_6698# VDD 0.28633f
C433 a_12797_1842# VDD 0.88193f
C434 a_20315_1044# VDD 0.1539f
C435 a_4187_2434# CHAN2_DELAY_IN 0.07974f
C436 a_15964_3134# CHAN2_MUX_OUT 0.01307f
C437 a_16108_3134# CHAN2_MUX_SEL4 0.1283f
C438 a_4350_1044# CHAN3_MUX_SEL4 0.31434f
C439 VDD CHAN3_MUX_SEL4 2.71801f
C440 a_4187_2434# a_20723_14024# 0.06627f
C441 a_23437_16869# a_23003_16869# 0.6972f
C442 a_4187_2434# a_12233_4687# 0.11222f
C443 a_27433_14024# a_27563_14024# 0.70845f
C444 a_5768_13226# a_5844_13190# 0.01176f
C445 a_14317_7532# a_13883_7532# 0.6972f
C446 a_18877_7532# a_16510_6734# 0.02479f
C447 a_7803_4687# a_7911_5315# 0.01697f
C448 a_22488_6734# a_22590_6734# 0.37183f
C449 a_18877_4687# a_19073_4687# 0.76914f
C450 a_1544_3889# a_1721_4240# 0.38063f
C451 a_23003_4687# a_22590_3889# 0.01012f
C452 a_23437_1842# a_24197_1842# 0.03319f
C453 a_1256_3134# a_1721_3176# 0.13421f
C454 a_15765_463# a_15964_289# 0.061f
C455 a_24957_14024# VDD 0.8837f
C456 a_20905_12701# VDD 0.29292f
C457 a_24875_3889# VDD 0.15407f
C458 a_15403_4687# VDD 0.49799f
C459 a_2873_1395# VDD 0.46517f
C460 a_4157_13495# CHAN1_DELAY_IN 0.50642f
C461 a_14317_16869# a_14513_16869# 0.76914f
C462 a_18877_16869# a_16510_16071# 0.02479f
C463 a_4187_2434# a_24957_16869# 0.0414f
C464 a_10430_16071# a_11785_15546# 0.02058f
C465 a_18877_14024# a_18443_14024# 0.6972f
C466 a_4187_2434# a_15837_7532# 0.04182f
C467 a_23437_14024# a_22590_13226# 0.08038f
C468 a_1256_13226# a_1721_13577# 0.13421f
C469 a_1256_12471# a_1544_12471# 1.25711f
C470 a_4187_2434# a_24523_1842# 0.06492f
C471 a_5197_7532# a_5393_7532# 0.76914f
C472 a_7477_7532# a_7364_6698# 0.05157f
C473 a_10328_6734# a_10404_6698# 0.01176f
C474 a_9757_4687# a_10517_4687# 0.05851f
C475 a_16108_5979# a_17357_4687# 0.01319f
C476 a_21157_4687# a_21625_3889# 0.2079f
C477 a_12797_4687# a_13368_3889# 0.10864f
C478 a_16510_3889# a_16484_3853# 0.277f
C479 a_16108_3134# a_26043_1842# 0.01539f
C480 a_14317_1842# a_14643_1842# 0.01427f
C481 a_4111_17497# VDD 0.01866f
C482 a_22590_1044# a_23355_1044# 0.39037f
C483 a_12715_13226# VDD 0.15407f
C484 a_6283_14024# VDD 0.50001f
C485 a_19073_7532# VDD 0.49426f
C486 a_1721_6021# VDD 0.45365f
C487 a_15545_3889# VDD 0.29962f
C488 a_4871_2470# VDD 0.01806f
C489 a_9772_11533# DLL_RESETN 0.06592f
C490 VDD CHAN0_MUX_SEL1 0.5478f
C491 a_5197_16869# a_5957_16869# 0.03319f
C492 a_4187_2434# a_6283_16869# 0.06627f
C493 a_7477_16869# a_7364_16035# 0.05157f
C494 a_9757_14024# a_9953_14024# 0.72407f
C495 a_10328_16071# a_10430_16071# 0.37183f
C496 a_16108_15316# a_16793_14024# 0.01481f
C497 a_12797_14024# a_12791_13190# 0.02354f
C498 a_16408_13226# a_16484_13190# 0.01176f
C499 a_12849_11557# a_14009_10774# 0.03463f
C500 a_14851_11918# a_15688_11557# 0.08776f
C501 a_4187_2434# a_6913_1842# 0.11222f
C502 a_21917_7532# a_22243_7532# 0.01427f
C503 a_26673_4687# a_27237_4687# 0.0114f
C504 a_5731_5979# a_11785_6209# 0.28056f
C505 a_5957_4687# a_6425_3889# 0.2079f
C506 a_4350_3889# a_5115_3889# 0.39037f
C507 a_26803_1842# a_26911_2470# 0.01697f
C508 a_5731_3134# a_11277_1842# 0.01319f
C509 a_20723_1842# a_20831_1842# 0.01163f
C510 a_7803_1842# a_7390_1044# 0.01012f
C511 a_5393_1842# a_5957_1842# 0.0114f
C512 a_10517_16869# VDD 0.86714f
C513 a_16484_16035# VDD 0.29019f
C514 a_20105_1044# a_20315_1044# 0.09424f
C515 a_10430_1044# a_11271_1008# 0.28268f
C516 a_15108_11015# VDD 0.13728f
C517 a_5115_6734# VDD 0.15389f
C518 a_14751_5315# VDD 0.01806f
C519 a_10083_1842# VDD 0.48468f
C520 a_17351_1008# VDD 0.28565f
C521 VDD CHAN2_MUX_SEL4 2.78273f
C522 a_22113_16869# a_22677_16869# 0.0114f
C523 a_4187_2434# a_19073_14024# 0.11222f
C524 a_26477_14024# a_26803_14024# 0.01427f
C525 a_9465_13226# a_9751_13190# 0.01885f
C526 a_4350_13226# a_4324_13190# 0.277f
C527 a_4187_2434# a_10517_4687# 0.0414f
C528 a_5731_12471# a_13121_11521# 0.02518f
C529 a_12993_7532# a_13557_7532# 0.0114f
C530 a_20968_6734# a_21044_6698# 0.01176f
C531 a_16597_7532# a_16484_6698# 0.05157f
C532 a_17553_4687# a_17683_4687# 0.70361f
C533 a_6283_4687# a_6391_5315# 0.01697f
C534 a_21917_4687# a_22488_3889# 0.10864f
C535 a_22677_1842# a_22243_1842# 0.69698f
C536 a_5731_289# a_15964_289# 0.2778f
C537 a_22243_14024# VDD 0.50007f
C538 a_24631_8160# VDD 0.02023f
C539 a_21911_3853# VDD 0.2822f
C540 a_13753_4687# VDD 0.49553f
C541 a_1256_1044# VDD 0.48292f
C542 a_1544_13226# CHAN1_MUX_SEL1 0.1672f
C543 a_1721_13577# CHAN1_MUX_SEL0 0.01315f
C544 a_9712_9602# REF_CLK 0.06509f
C545 a_5864_9057# DLL_RESETN 0.16199f
C546 a_4187_2434# a_22243_16869# 0.06627f
C547 a_12993_16869# a_13123_16869# 0.70845f
C548 a_16597_16869# a_16484_16035# 0.05157f
C549 a_17553_14024# a_18117_14024# 0.0114f
C550 a_4187_2434# a_13123_7532# 0.06627f
C551 a_27048_13226# a_27124_13190# 0.01176f
C552 a_21917_14024# a_21911_13190# 0.02354f
C553 a_4187_2434# a_22873_1842# 0.11222f
C554 a_17065_6734# a_17275_6734# 0.09424f
C555 a_12797_4687# a_10430_3889# 0.02479f
C556 a_8997_4687# a_8563_4687# 0.6972f
C557 a_16923_1842# a_16510_1044# 0.01012f
C558 a_13557_1842# a_13753_1842# 0.73897f
C559 a_4633_14024# VDD 0.49523f
C560 a_26477_16869# VDD 0.86919f
C561 a_9751_13190# VDD 0.2822f
C562 a_26395_6734# VDD 0.15389f
C563 a_17357_7532# VDD 0.86933f
C564 a_4905_3889# VDD 0.3017f
C565 a_26043_1842# VDD 0.5006f
C566 a_4437_16869# a_4003_16869# 0.69698f
C567 a_4187_2434# a_4633_16869# 0.11222f
C568 a_8808_16071# a_8884_16035# 0.01176f
C569 a_18585_16071# a_16510_16071# 0.03208f
C570 a_11277_14024# a_11924_13190# 0.02312f
C571 a_8433_14024# a_8563_14024# 0.70361f
C572 a_4187_2434# a_26477_4687# 0.04145f
C573 a_6854_11144# a_9444_9602# 0.8486f
C574 a_4187_2434# a_5197_1842# 0.0414f
C575 a_21157_7532# a_21353_7532# 0.77122f
C576 a_25717_7532# a_25604_6698# 0.05157f
C577 a_4437_4687# a_4157_4158# 0.01771f
C578 a_25717_4687# a_26477_4687# 0.01669f
C579 a_4437_1842# a_5197_1842# 0.01669f
C580 a_9465_3889# a_7390_3889# 0.03208f
C581 a_12037_1842# a_12505_1044# 0.2079f
C582 a_19203_1842# a_19311_1842# 0.01163f
C583 a_25283_1842# a_25391_2470# 0.01697f
C584 a_6717_1842# a_7288_1044# 0.10864f
C585 a_7803_16869# VDD 0.498f
C586 a_14235_16071# VDD 0.15389f
C587 a_9675_1044# a_9751_1008# 0.01194f
C588 a_13306_10795# VDD 0.79687f
C589 a_23145_6734# VDD 0.30409f
C590 a_8671_5315# VDD 0.02372f
C591 a_8433_1842# VDD 0.55387f
C592 a_14888_1044# VDD 0.17499f
C593 a_13121_11521# REF_DELAY_OUT_LAST 0.13178f
C594 a_3449_3176# CHAN2_MUX_SEL4 0.05166f
C595 CHAN1_DELAY_IN CHAN1_MUX_SEL4 0.0663f
C596 VDD REF_MUX_SEL4 2.78273f
C597 a_21157_16869# a_21917_16869# 0.02912f
C598 a_25717_16869# a_25604_16035# 0.05157f
C599 a_4187_2434# a_17357_14024# 0.0414f
C600 a_25717_14024# a_25913_14024# 0.73897f
C601 a_4187_2434# a_7803_4687# 0.06627f
C602 a_7945_13226# a_7390_13226# 0.03209f
C603 a_6326_10280# a_6854_11676# 1.29266f
C604 a_12037_7532# a_12797_7532# 0.02912f
C605 a_19550_6734# a_19524_6698# 0.277f
C606 a_7390_6734# a_5731_5979# 0.41141f
C607 a_4763_4687# a_4871_5315# 0.01697f
C608 a_21917_4687# a_19550_3889# 0.02479f
C609 a_25630_3889# a_26395_3889# 0.39037f
C610 a_16510_3889# a_16108_3134# 0.56108f
C611 a_26043_1842# a_25630_1044# 0.01012f
C612 a_21353_1842# a_21917_1842# 0.0114f
C613 a_5731_289# a_8745_519# 0.28635f
C614 a_20593_14024# VDD 0.49593f
C615 a_12037_4687# VDD 0.85996f
C616 a_18551_8160# VDD 0.01806f
C617 a_19448_3889# VDD 0.17274f
C618 a_4187_2434# a_20593_16869# 0.11222f
C619 a_19448_16071# a_19524_16035# 0.01176f
C620 a_16597_14024# a_17357_14024# 0.01669f
C621 a_4187_2434# a_11473_7532# 0.11222f
C622 a_20397_14024# a_21044_13190# 0.02312f
C623 a_25630_13226# a_25604_13190# 0.277f
C624 a_5197_7532# a_5191_6698# 0.02349f
C625 a_4187_2434# a_21157_1842# 0.04141f
C626 a_5957_7532# a_4350_6734# 0.05231f
C627 a_15464_9374# a_9712_9602# 0.01237f
C628 a_7390_6734# a_8155_6734# 0.39037f
C629 a_7673_4687# a_8237_4687# 0.0114f
C630 a_10517_4687# a_10404_3853# 0.05157f
C631 a_12233_1842# a_12363_1842# 0.70845f
C632 a_13470_3889# a_14311_3853# 0.28268f
C633 a_16108_3134# a_22677_1842# 0.01314f
C634 a_15837_1842# a_16408_1044# 0.10864f
C635 a_25717_1842# a_26185_1044# 0.19203f
C636 a_16108_15316# VDD 1.67139f
C637 a_19550_1044# a_20968_1044# 0.38994f
C638 a_23763_16869# VDD 0.52729f
C639 a_7288_13226# VDD 0.17274f
C640 a_14643_7532# VDD 0.49681f
C641 a_23431_6698# VDD 0.28357f
C642 a_24393_1842# VDD 0.71859f
C643 a_2297_4240# VDD 0.46536f
C644 a_17865_519# VDD 0.29444f
C645 a_16108_12471# CHAN1_MUX_SEL4 0.1283f
C646 a_15964_12471# CHAN1_MUX_OUT 0.01307f
C647 a_12797_1842# CHAN3_MUX_SEL4 0.01829f
C648 CHAN3_MUX_SEL3 CHAN3_MUX_OUT 0.79533f
C649 a_5957_16869# a_4350_16071# 0.05231f
C650 a_5197_16869# a_5191_16035# 0.02349f
C651 a_7390_16071# a_7364_16035# 0.277f
C652 a_5731_15316# a_15273_14024# 0.01872f
C653 a_10517_14024# a_10430_13226# 0.1088f
C654 a_24665_13226# a_24951_13190# 0.01885f
C655 a_4187_2434# a_23763_4687# 0.06453f
C656 a_13470_13226# a_14235_13226# 0.39037f
C657 a_13121_11521# a_15108_11799# 0.03701f
C658 a_13019_11521# a_14851_11918# 0.01651f
C659 a_12849_11557# a_14111_11568# 0.42174f
C660 a_13592_11561# a_14009_11568# 0.37583f
C661 a_13306_11995# a_13880_11982# 0.31978f
C662 a_19833_7532# a_19963_7532# 0.70845f
C663 a_24957_4687# a_24523_4687# 0.6972f
C664 a_5731_3134# a_6913_1842# 0.01872f
C665 a_17683_1842# a_17791_1842# 0.01163f
C666 a_15545_1044# a_15831_1008# 0.01885f
C667 a_6717_1842# a_4350_1044# 0.02479f
C668 a_7390_1044# a_8884_1008# 0.28279f
C669 a_8155_1044# a_8231_1008# 0.01194f
C670 a_23763_1842# a_23871_2470# 0.01697f
C671 a_6153_16869# VDD 0.49285f
C672 a_11271_16035# VDD 0.28357f
C673 a_10985_6734# VDD 0.30409f
C674 a_27997_4687# VDD 0.76528f
C675 a_6717_1842# VDD 0.88148f
C676 a_11924_1008# VDD 0.28225f
C677 a_3449_1395# CHAN3_MUX_SEL1 0.29404f
C678 CHAN0_MUX_SEL2 CHAN1_MUX_SEL0 0.0126f
C679 CHAN0_MUX_SEL4 CHAN1_DELAY_IN 0.01327f
C680 a_20397_16869# a_19963_16869# 0.6972f
C681 a_4187_2434# a_14643_14024# 0.06627f
C682 a_24393_14024# a_24523_14024# 0.70361f
C683 a_4187_2434# a_27433_7532# 0.11284f
C684 a_4187_2434# a_6153_4687# 0.11222f
C685 a_15077_7532# a_13470_6734# 0.05231f
C686 a_11277_7532# a_10843_7532# 0.6972f
C687 a_14317_7532# a_14311_6698# 0.02349f
C688 a_15837_4687# a_16033_4687# 0.76914f
C689 a_19637_4687# a_19524_3853# 0.05157f
C690 a_20397_1842# a_21157_1842# 0.03319f
C691 a_24957_1842# a_25528_1044# 0.10864f
C692 a_18877_14024# VDD 0.88247f
C693 a_12471_8160# VDD 0.01806f
C694 a_1256_12471# VDD 0.4192f
C695 a_9323_4687# VDD 0.50013f
C696 a_16510_3889# VDD 1.0321f
C697 a_14825_6209# REF_MUX_SEL4 0.03307f
C698 a_14317_16869# a_14311_16035# 0.02349f
C699 a_11277_16869# a_11473_16869# 0.76914f
C700 a_15077_16869# a_13470_16071# 0.05231f
C701 a_4187_2434# a_18877_16869# 0.0414f
C702 a_4350_16071# a_5731_15316# 0.41099f
C703 a_4187_2434# a_9757_7532# 0.04038f
C704 a_15837_14024# a_15403_14024# 0.6972f
C705 a_19637_14024# a_19550_13226# 0.1088f
C706 a_4187_2434# a_18443_1842# 0.06627f
C707 a_9444_10280# a_5864_9057# 0.06515f
C708 a_5731_5979# a_13123_4687# 0.01539f
C709 a_12505_6734# a_12791_6698# 0.01885f
C710 a_6717_4687# a_7477_4687# 0.06198f
C711 a_24665_3889# a_22590_3889# 0.03208f
C712 a_12715_3889# a_12791_3853# 0.01194f
C713 a_11277_1842# a_11603_1842# 0.01427f
C714 a_16108_3134# a_19963_1842# 0.01539f
C715 a_22113_16869# VDD 0.49426f
C716 a_15837_1842# a_13470_1044# 0.02479f
C717 a_4350_13226# VDD 0.87638f
C718 a_12993_7532# VDD 0.49426f
C719 a_20968_6734# VDD 0.17499f
C720 a_22677_1842# VDD 0.87098f
C721 a_5731_12471# DLL_RESETN 0.02297f
C722 a_10430_6734# REF_MUX_SEL4 0.24983f
C723 a_12505_16071# a_12715_16071# 0.09424f
C724 a_6717_14024# a_6913_14024# 0.76914f
C725 a_5731_15316# a_13557_14024# 0.01314f
C726 a_13019_11521# a_13592_11561# 0.04178f
C727 a_13121_11521# a_13566_11525# 0.01158f
C728 a_23145_13226# a_22590_13226# 0.03209f
C729 a_6326_10280# a_9444_10280# 0.01269f
C730 a_4187_2434# a_22113_4687# 0.11222f
C731 a_1256_6734# a_2297_7085# 0.04619f
C732 a_23437_7532# a_23431_6698# 0.02349f
C733 a_24197_7532# a_22590_6734# 0.05231f
C734 a_18877_7532# a_19203_7532# 0.01427f
C735 a_22590_6734# a_16108_5979# 0.55709f
C736 a_1256_5979# a_2873_6021# 0.27926f
C737 a_1544_5979# a_2297_6021# 0.27303f
C738 a_23633_4687# a_24197_4687# 0.0114f
C739 a_4437_1842# a_4324_1008# 0.05157f
C740 a_15964_3134# a_16108_3134# 0.42202f
C741 a_16163_1842# a_16271_1842# 0.01163f
C742 a_22243_1842# a_22351_2470# 0.01697f
C743 a_14025_1044# a_13470_1044# 0.03209f
C744 a_4437_16869# VDD 0.87051f
C745 a_23111_14652# VDD 0.01806f
C746 a_8808_16071# VDD 0.17577f
C747 a_25283_4687# VDD 0.48362f
C748 a_9675_1044# VDD 0.15407f
C749 a_4003_1842# VDD 0.61691f
C750 a_1256_1044# CHAN3_MUX_SEL4 0.04785f
C751 CHAN0_DELAY_IN CHAN0_MUX_SEL4 0.0663f
C752 a_4187_2434# a_12993_14024# 0.11222f
C753 a_19073_16869# a_19637_16869# 0.0114f
C754 a_24197_16869# a_22590_16071# 0.05231f
C755 a_23437_16869# a_23431_16035# 0.02349f
C756 a_1256_15316# a_2297_15358# 0.04261f
C757 a_1544_15316# a_1721_15358# 0.36963f
C758 a_4187_2434# a_25717_7532# 0.04056f
C759 a_23437_14024# a_23763_14024# 0.01427f
C760 a_4187_2434# a_4437_4687# 0.04193f
C761 a_9953_7532# a_10517_7532# 0.0114f
C762 a_15765_12645# a_16108_12471# 0.42004f
C763 a_5731_12471# a_6854_11676# 0.02297f
C764 a_12797_7532# a_13444_6698# 0.02011f
C765 a_27563_7532# a_27671_7532# 0.01163f
C766 a_14513_4687# a_14643_4687# 0.70845f
C767 a_16510_6734# a_17351_6698# 0.28268f
C768 a_19637_1842# a_19203_1842# 0.69698f
C769 a_22590_3889# a_24008_3889# 0.38994f
C770 a_1256_289# a_2019_311# 0.02904f
C771 a_24957_1842# a_22590_1044# 0.02479f
C772 a_1256_1044# a_2873_1395# 0.28892f
C773 a_16163_14024# VDD 0.94897f
C774 a_6391_8160# VDD 0.01806f
C775 a_25630_13226# VDD 0.89531f
C776 a_7673_4687# VDD 0.49562f
C777 a_13444_3853# VDD 0.28633f
C778 a_9757_16869# CHAN0_MUX_SEL4 0.01829f
C779 a_13106_11047# DLL_RESETN 0.01263f
C780 a_27997_1842# CHAN3_DELAY_OUT_LAST 0.70955f
C781 a_4187_2434# a_16163_16869# 0.06315f
C782 a_9953_16869# a_10083_16869# 0.70361f
C783 a_12797_16869# a_13444_16035# 0.02011f
C784 a_27563_16869# a_27671_16869# 0.01163f
C785 a_16108_15316# a_26673_14024# 0.01872f
C786 a_4187_2434# a_7043_7532# 0.06627f
C787 a_16510_16071# a_17275_16071# 0.39037f
C788 a_14513_14024# a_15077_14024# 0.0114f
C789 a_14851_10872# a_15688_11093# 0.08776f
C790 a_22590_13226# a_23431_13190# 0.28268f
C791 a_4187_2434# a_16793_1842# 0.11113f
C792 a_10985_6734# a_10430_6734# 0.03209f
C793 a_27237_7532# a_26803_7532# 0.6972f
C794 a_4350_6734# a_5768_6734# 0.38994f
C795 a_5957_4687# a_5523_4687# 0.6972f
C796 a_5731_5979# a_11473_4687# 0.01872f
C797 a_10430_3889# a_11924_3853# 0.28279f
C798 a_11195_3889# a_11271_3853# 0.01194f
C799 a_8997_4687# a_7390_3889# 0.05231f
C800 a_8237_4687# a_8231_3853# 0.02349f
C801 a_13557_1842# a_13444_1008# 0.05157f
C802 a_10517_1842# a_10713_1842# 0.73897f
C803 a_16108_3134# a_18313_1842# 0.02026f
C804 a_4350_1044# a_2019_311# 0.02042f
C805 a_20397_16869# VDD 0.86919f
C806 a_16510_1044# a_18795_1044# 0.39036f
C807 a_3449_15358# VDD 0.47499f
C808 a_20105_13226# VDD 0.30411f
C809 a_11277_7532# VDD 0.86919f
C810 a_18004_6698# VDD 0.28225f
C811 a_19963_1842# VDD 0.50058f
C812 a_2019_311# VDD 1.43004f
C813 a_3449_12513# CHAN1_MUX_SEL4 0.05166f
C814 CHAN2_MUX_SEL2 CHAN3_DELAY_IN 0.1765f
C815 CHAN2_MUX_SEL3 CHAN2_MUX_OUT 0.79533f
C816 a_27237_16869# a_27433_16869# 0.77122f
C817 a_4350_16071# a_5191_16035# 0.28268f
C818 a_5393_14024# a_5523_14024# 0.70845f
C819 a_5731_15316# a_10843_14024# 0.01539f
C820 a_20105_13226# a_20391_13190# 0.01885f
C821 a_4187_2434# a_20397_4687# 0.04141f
C822 a_10430_13226# a_11848_13226# 0.38994f
C823 a_12656_11554# a_13019_11521# 0.04193f
C824 a_12355_11557# a_13121_11521# 0.05795f
C825 a_18117_7532# a_18313_7532# 0.77122f
C826 a_21917_7532# a_22564_6698# 0.02011f
C827 a_22677_4687# a_23437_4687# 0.01669f
C828 a_21917_4687# a_16108_3134# 0.0157f
C829 a_14643_1842# a_14751_1842# 0.01163f
C830 a_20723_1842# a_20831_2470# 0.01697f
C831 a_10985_1044# a_11271_1008# 0.01885f
C832 a_4350_1044# a_6711_1008# 0.26208f
C833 a_5844_16035# VDD 0.28225f
C834 a_17031_14652# VDD 0.01806f
C835 a_1721_7085# VDD 0.4533f
C836 a_13306_11995# VDD 0.77663f
C837 a_23633_4687# VDD 0.4963f
C838 a_15964_3134# VDD 0.42016f
C839 a_6711_1008# VDD 0.2822f
C840 a_6854_11676# REF_DELAY_OUT_LAST 0.08491f
C841 a_4187_2434# a_11277_14024# 0.0414f
C842 a_18117_16869# a_18877_16869# 0.02912f
C843 a_21917_16869# a_22564_16035# 0.02011f
C844 a_22677_14024# a_22873_14024# 0.73897f
C845 a_4187_2434# a_23003_7532# 0.06661f
C846 a_19550_16071# a_16108_15316# 0.58202f
C847 a_5731_12471# a_16108_12471# 0.01334f
C848 a_8997_7532# a_9757_7532# 0.02912f
C849 a_12037_7532# a_11924_6698# 0.02055f
C850 a_15755_6734# a_15831_6698# 0.01194f
C851 a_27705_6734# a_27991_6698# 0.01885f
C852 a_26043_7532# a_26151_7532# 0.01163f
C853 a_16108_5979# a_24523_4687# 0.01361f
C854 a_18117_4687# a_16510_3889# 0.05231f
C855 a_17357_4687# a_17351_3853# 0.02349f
C856 a_22677_1842# a_22564_1008# 0.05157f
C857 a_18313_1842# a_18877_1842# 0.0114f
C858 a_27671_17497# VDD 0.01806f
C859 a_14513_14024# VDD 0.49594f
C860 a_22564_13190# VDD 0.28633f
C861 a_27237_7532# VDD 0.86022f
C862 a_5957_4687# VDD 0.85996f
C863 a_11195_3889# VDD 0.1539f
C864 a_4157_7003# REF_CLK 0.50643f
C865 a_14111_11568# REF_CLK 0.02263f
C866 a_1721_6021# REF_MUX_SEL4 0.05813f
C867 a_1544_5979# REF_MUX_OUT 0.69943f
C868 a_2873_6021# REF_MUX_SEL2 0.01422f
C869 a_2297_6021# REF_MUX_SEL3 0.01595f
C870 a_16851_309# CHAN3_MUX_OUT 0.45865f
C871 a_4187_2434# a_14513_16869# 0.11222f
C872 a_26043_16869# a_26151_16869# 0.01163f
C873 a_12037_16869# a_11924_16035# 0.02055f
C874 a_4187_2434# a_5393_7532# 0.11222f
C875 a_27705_16071# a_27915_16071# 0.09424f
C876 a_16108_15316# a_24957_14024# 0.01307f
C877 a_13557_14024# a_14317_14024# 0.01669f
C878 a_21835_13226# a_21911_13190# 0.01194f
C879 a_13592_11113# a_14851_10872# 0.01529f
C880 a_4187_2434# a_15077_1842# 0.04141f
C881 a_25913_7532# a_26477_7532# 0.0114f
C882 a_7945_6734# a_8231_6698# 0.01885f
C883 a_6717_4687# a_7364_3853# 0.02011f
C884 a_4633_4687# a_5197_4687# 0.0114f
C885 a_18585_3889# a_18795_3889# 0.09424f
C886 a_9193_1842# a_9323_1842# 0.70845f
C887 a_27124_16035# VDD 0.28225f
C888 a_17683_16869# VDD 0.48136f
C889 a_7945_13226# VDD 0.30411f
C890 a_15755_6734# VDD 0.15389f
C891 a_8563_7532# VDD 0.95429f
C892 a_18313_1842# VDD 0.49462f
C893 a_27991_1008# VDD 0.28201f
C894 a_6717_1842# CHAN3_MUX_SEL4 0.0195f
C895 a_4187_2434# a_27237_14024# 0.06189f
C896 a_7945_16071# a_8155_16071# 0.09424f
C897 a_25913_16869# a_26043_16869# 0.70845f
C898 a_5731_15316# a_9193_14024# 0.01872f
C899 a_4187_2434# a_17683_4687# 0.06492f
C900 a_16793_7532# a_16923_7532# 0.70845f
C901 a_25630_6734# a_27048_6734# 0.38994f
C902 a_21157_7532# a_21044_6698# 0.02055f
C903 a_16510_6734# a_17865_6209# 0.02165f
C904 a_21917_4687# a_21483_4687# 0.6972f
C905 a_27237_4687# a_25630_3889# 0.05253f
C906 a_26477_4687# a_26471_3853# 0.02349f
C907 a_26477_1842# a_26673_1842# 0.76914f
C908 a_19203_1842# a_19311_2470# 0.01697f
C909 a_13123_1842# a_13231_1842# 0.01163f
C910 a_4248_1044# a_4350_1044# 0.37183f
C911 a_27705_16071# VDD 0.29962f
C912 a_10951_14652# VDD 0.01806f
C913 a_8745_3364# VDD 0.29714f
C914 a_21917_4687# VDD 0.88247f
C915 a_4248_1044# VDD 0.17587f
C916 a_14825_15546# CHAN0_MUX_SEL4 0.03307f
C917 a_16108_12471# REF_DELAY_OUT_LAST 0.01024f
C918 a_17357_16869# a_16923_16869# 0.6972f
C919 a_21157_16869# a_21044_16035# 0.02055f
C920 a_4187_2434# a_8563_14024# 0.0635f
C921 a_16510_16071# a_16851_15336# 0.02131f
C922 a_4187_2434# a_21353_7532# 0.11284f
C923 a_21353_14024# a_21483_14024# 0.70845f
C924 a_25630_16071# a_26471_16035# 0.28268f
C925 a_4187_2434# a_5731_5979# 0.15453f
C926 a_8237_7532# a_7803_7532# 0.6972f
C927 a_18117_7532# a_18585_6734# 0.2079f
C928 a_13470_6734# a_14964_6698# 0.28279f
C929 a_14235_6734# a_14311_6698# 0.01194f
C930 a_24523_7532# a_24631_7532# 0.01163f
C931 a_26185_6734# a_25630_6734# 0.03209f
C932 a_11277_7532# a_10430_6734# 0.08038f
C933 a_15837_4687# a_16484_3853# 0.02011f
C934 a_16108_5979# a_22873_4687# 0.01865f
C935 a_12797_4687# a_12993_4687# 0.76914f
C936 a_19550_3889# a_21835_3889# 0.39036f
C937 a_17357_1842# a_18117_1842# 0.02973f
C938 a_12797_14024# VDD 0.88193f
C939 a_21591_17497# VDD 0.01806f
C940 a_25630_1044# a_27991_1008# 0.26208f
C941 a_20315_13226# VDD 0.1539f
C942 a_24523_7532# VDD 0.90814f
C943 a_23945_6209# VDD 0.2935f
C944 a_8231_3853# VDD 0.28357f
C945 a_10430_16071# CHAN0_MUX_SEL4 0.24983f
C946 a_22351_2470# VDD 0.01806f
C947 a_2873_4240# CHAN2_MUX_SEL1 0.13092f
C948 a_3449_4240# CHAN2_DELAY_IN 0.01058f
C949 a_4187_2434# a_12797_16869# 0.0414f
C950 a_8237_16869# a_8433_16869# 0.76914f
C951 a_18117_16869# a_18585_16071# 0.2079f
C952 a_13470_16071# a_14888_16071# 0.38994f
C953 a_11277_16869# a_10430_16071# 0.08038f
C954 a_24523_16869# a_24631_16869# 0.01163f
C955 a_12797_14024# a_12363_14024# 0.6972f
C956 a_16108_15316# a_22243_14024# 0.01539f
C957 a_19550_13226# a_21044_13190# 0.28279f
C958 a_20315_13226# a_20391_13190# 0.01194f
C959 a_15304_10295# a_14851_10872# 0.05156f
C960 a_24957_7532# a_25717_7532# 0.05851f
C961 a_4187_2434# a_12363_1842# 0.06627f
C962 a_13566_11018# a_13592_11113# 0.36952f
C963 a_6425_6734# a_6635_6734# 0.09424f
C964 a_5731_5979# a_7043_4687# 0.01539f
C965 a_5957_4687# a_5844_3853# 0.02055f
C966 a_7390_3889# a_9751_3853# 0.26208f
C967 a_8237_1842# a_8563_1842# 0.01427f
C968 a_12037_1842# a_10430_1044# 0.05231f
C969 a_11277_1842# a_11271_1008# 0.02349f
C970 a_24875_16071# VDD 0.15406f
C971 a_16033_16869# VDD 0.54891f
C972 a_26185_1044# a_26471_1008# 0.01885f
C973 a_6913_7532# VDD 0.49427f
C974 a_2873_13577# VDD 0.46517f
C975 a_12791_6698# VDD 0.2822f
C976 a_16597_1842# VDD 0.94753f
C977 a_25528_1044# VDD 0.17274f
C978 REF_MUX_SEL3 REF_MUX_OUT 0.79533f
C979 REF_MUX_SEL2 CHAN2_DELAY_IN 0.1765f
C980 a_4187_2434# a_24523_14024# 0.06492f
C981 a_5731_15316# a_7477_14024# 0.01314f
C982 a_10517_14024# a_10985_13226# 0.19203f
C983 a_6283_14024# a_4350_13226# 0.01012f
C984 a_10751_11568# a_11748_11799# 0.03061f
C985 a_10649_11568# a_11397_11918# 0.01058f
C986 a_4187_2434# a_16033_4687# 0.11169f
C987 a_7390_13226# a_9675_13226# 0.39036f
C988 a_15837_7532# a_16163_7532# 0.01427f
C989 a_20397_7532# a_19550_6734# 0.08038f
C990 a_24957_4687# a_25604_3853# 0.02011f
C991 a_20593_4687# a_21157_4687# 0.0114f
C992 a_5705_3364# a_5731_3134# 0.28954f
C993 a_17683_1842# a_17791_2470# 0.01697f
C994 a_11603_1842# a_11711_1842# 0.01163f
C995 a_25153_1842# a_25283_1842# 0.70361f
C996 a_15545_16071# VDD 0.29962f
C997 a_4871_14652# VDD 0.01806f
C998 a_10232_11561# VDD 0.07564f
C999 a_19203_4687# VDD 0.50004f
C1000 a_2873_3176# VDD 0.46598f
C1001 a_18585_1044# VDD 0.29742f
C1002 a_16033_16869# a_16597_16869# 0.0114f
C1003 a_24875_16071# a_24951_16035# 0.01194f
C1004 a_20397_16869# a_19550_16071# 0.08038f
C1005 a_4187_2434# a_6913_14024# 0.11222f
C1006 a_20397_14024# a_20723_14024# 0.01427f
C1007 a_4187_2434# a_19637_7532# 0.04176f
C1008 a_9757_7532# a_9751_6698# 0.02354f
C1009 a_6913_7532# a_7477_7532# 0.0114f
C1010 a_23003_7532# a_23111_7532# 0.01163f
C1011 a_23145_6734# a_23431_6698# 0.01885f
C1012 a_15077_4687# a_14964_3853# 0.02055f
C1013 a_11473_4687# a_11603_4687# 0.70845f
C1014 a_16108_5979# a_21157_4687# 0.01319f
C1015 a_16597_1842# a_16163_1842# 0.69698f
C1016 a_21157_1842# a_19550_1044# 0.05231f
C1017 a_20397_1842# a_20391_1008# 0.02349f
C1018 a_15511_17497# VDD 0.01806f
C1019 a_10083_14024# VDD 0.48468f
C1020 a_25528_1044# a_25630_1044# 0.37183f
C1021 a_17351_13190# VDD 0.28565f
C1022 a_22873_7532# VDD 0.49298f
C1023 a_11785_6209# VDD 0.29292f
C1024 a_5768_3889# VDD 0.17499f
C1025 a_16271_2470# VDD 0.02023f
C1026 a_12355_11557# DLL_RESETN 0.04879f
C1027 a_1256_3889# CHAN2_MUX_SEL1 1.44243f
C1028 a_1544_3889# CHAN2_MUX_SEL0 0.07603f
C1029 a_2019_311# CHAN3_MUX_SEL4 0.90276f
C1030 a_23003_16869# a_23111_16869# 0.01163f
C1031 a_6913_16869# a_7043_16869# 0.70845f
C1032 a_4187_2434# a_10083_16869# 0.06492f
C1033 a_9757_16869# a_9751_16035# 0.02354f
C1034 a_23145_16071# a_23355_16071# 0.09424f
C1035 a_16108_15316# a_20593_14024# 0.01872f
C1036 a_24197_14024# a_24665_13226# 0.2079f
C1037 a_11473_14024# a_12037_14024# 0.0114f
C1038 a_15403_14024# a_13470_13226# 0.01012f
C1039 a_4187_2434# a_10713_1842# 0.11222f
C1040 a_13106_11047# a_12907_11110# 0.14994f
C1041 a_24197_7532# a_23763_7532# 0.6972f
C1042 a_16108_5979# a_16851_5999# 0.06181f
C1043 a_4157_7003# a_4350_6734# 0.04624f
C1044 a_5197_4687# a_4350_3889# 0.08038f
C1045 a_7288_3889# a_7390_3889# 0.37183f
C1046 a_8997_4687# a_9465_3889# 0.2079f
C1047 a_14025_3889# a_14235_3889# 0.09424f
C1048 a_5731_3134# a_15077_1842# 0.01319f
C1049 a_7477_1842# a_7673_1842# 0.73897f
C1050 a_13368_1044# a_13444_1008# 0.01176f
C1051 a_9757_1842# a_10404_1008# 0.02011f
C1052 a_14317_16869# VDD 0.86919f
C1053 a_21911_16035# VDD 0.2822f
C1054 a_1256_13226# VDD 0.48292f
C1055 a_5197_7532# VDD 0.86919f
C1056 a_26151_5315# VDD 0.01806f
C1057 a_10328_6734# VDD 0.17274f
C1058 a_13883_1842# VDD 0.50058f
C1059 a_22590_1044# VDD 1.09883f
C1060 a_4187_2434# CHAN2_MUX_OUT 1.24279f
C1061 a_4003_1842# CHAN2_MUX_SEL4 0.01225f
C1062 a_24197_16869# a_24393_16869# 0.77122f
C1063 a_4157_16340# a_4248_16071# 0.11672f
C1064 a_15964_15316# a_16851_15336# 0.16757f
C1065 a_4187_2434# a_22873_14024# 0.11222f
C1066 a_4187_2434# a_14317_4687# 0.04141f
C1067 a_10232_11561# a_10649_11568# 0.37583f
C1068 a_15545_13226# a_13470_13226# 0.03208f
C1069 a_9946_11995# a_10751_11568# 0.097f
C1070 a_15077_7532# a_15273_7532# 0.77122f
C1071 a_18877_7532# a_18871_6698# 0.02354f
C1072 a_22590_6734# a_24875_6734# 0.39036f
C1073 a_19637_4687# a_20397_4687# 0.01669f
C1074 a_24197_4687# a_24084_3853# 0.02055f
C1075 a_10083_1842# a_10191_1842# 0.01163f
C1076 a_16163_1842# a_16271_2470# 0.01697f
C1077 a_4905_1044# a_5115_1044# 0.09424f
C1078 a_4905_16071# VDD 0.3017f
C1079 a_26043_14024# VDD 0.5006f
C1080 a_16108_289# a_23945_519# 0.2906f
C1081 a_6854_11144# VDD 1.04873f
C1082 a_17553_4687# VDD 0.49521f
C1083 a_27048_3889# VDD 0.17499f
C1084 a_1544_15316# CHAN0_MUX_OUT 0.69943f
C1085 a_1721_15358# CHAN0_MUX_SEL4 0.05813f
C1086 a_2297_15358# CHAN0_MUX_SEL3 0.01595f
C1087 a_2873_15358# CHAN0_MUX_SEL2 0.01422f
C1088 a_18877_16869# a_18871_16035# 0.02354f
C1089 a_15077_16869# a_15837_16869# 0.02912f
C1090 a_4187_2434# a_5197_14024# 0.0414f
C1091 a_4187_2434# a_26043_16869# 0.06627f
C1092 a_23355_16071# a_23431_16035# 0.01194f
C1093 a_22590_16071# a_24084_16035# 0.28279f
C1094 a_4187_2434# a_16923_7532# 0.06661f
C1095 a_24523_14024# a_22590_13226# 0.01012f
C1096 a_15837_14024# a_15964_12471# 0.01935f
C1097 a_19637_14024# a_19833_14024# 0.73897f
C1098 a_4187_2434# a_26673_1842# 0.11222f
C1099 a_22590_13226# a_23945_12701# 0.02138f
C1100 a_5957_7532# a_6717_7532# 0.02912f
C1101 a_8237_7532# a_8884_6698# 0.02312f
C1102 a_21483_7532# a_21591_7532# 0.01163f
C1103 a_27563_7532# a_27671_8160# 0.01697f
C1104 a_16108_5979# a_18443_4687# 0.01542f
C1105 a_10430_6734# a_12791_6698# 0.26208f
C1106 a_22677_4687# a_23145_3889# 0.19203f
C1107 a_14317_4687# a_13470_3889# 0.08038f
C1108 a_15273_1842# a_15837_1842# 0.0114f
C1109 a_9431_17497# VDD 0.01806f
C1110 a_24008_1044# a_24084_1008# 0.01176f
C1111 a_18877_1842# a_19524_1008# 0.02011f
C1112 a_8433_14024# VDD 0.55387f
C1113 a_21157_7532# VDD 0.85889f
C1114 a_14888_13226# VDD 0.17499f
C1115 a_26185_3889# VDD 0.30411f
C1116 a_10191_2470# VDD 0.01806f
C1117 VDD CHAN1_MUX_SEL0 0.60193f
C1118 a_1256_289# CHAN3_MUX_SEL3 1.41161f
C1119 a_1544_289# CHAN3_MUX_SEL2 0.07405f
C1120 a_3449_331# CHAN3_DELAY_IN 0.01017f
C1121 a_21483_16869# a_21591_16869# 0.01163f
C1122 a_4187_2434# a_8433_16869# 0.11169f
C1123 a_8237_16869# a_8884_16035# 0.02312f
C1124 a_10430_16071# a_12715_16071# 0.39036f
C1125 a_10517_14024# a_11277_14024# 0.01669f
C1126 a_16108_15316# a_18877_14024# 0.01307f
C1127 a_16510_13226# a_18871_13190# 0.26208f
C1128 a_4187_2434# a_8997_1842# 0.04096f
C1129 a_22873_7532# a_23437_7532# 0.0114f
C1130 a_5768_3889# a_5844_3853# 0.01176f
C1131 a_27433_4687# a_27563_4687# 0.70845f
C1132 a_5731_3134# a_12363_1842# 0.01542f
C1133 a_6153_1842# a_6283_1842# 0.70845f
C1134 a_8997_1842# a_8884_1008# 0.02055f
C1135 a_11603_16869# VDD 0.49671f
C1136 a_19448_16071# VDD 0.17274f
C1137 a_7390_6734# VDD 1.14001f
C1138 a_20071_5315# VDD 0.01806f
C1139 a_12233_1842# VDD 0.4946f
C1140 a_19524_1008# VDD 0.28633f
C1141 a_4187_2434# REF_MUX_OUT 1.24279f
C1142 a_15964_3134# CHAN2_MUX_SEL4 0.5544f
C1143 VDD CHAN3_MUX_SEL3 0.40634f
C1144 a_22873_16869# a_23003_16869# 0.70845f
C1145 a_4187_2434# a_21157_14024# 0.04141f
C1146 a_27433_14024# a_27997_14024# 0.0114f
C1147 a_4187_2434# a_11603_4687# 0.06627f
C1148 a_13753_7532# a_13883_7532# 0.70845f
C1149 a_9772_11533# a_9946_11995# 0.27179f
C1150 a_17357_7532# a_18004_6698# 0.02312f
C1151 a_10430_6734# a_11785_6209# 0.02058f
C1152 a_18877_4687# a_18443_4687# 0.6972f
C1153 a_23437_4687# a_22590_3889# 0.08038f
C1154 a_1256_3889# a_1721_4240# 0.13421f
C1155 a_8563_1842# a_8671_1842# 0.01163f
C1156 a_23437_1842# a_23633_1842# 0.76914f
C1157 a_1256_3134# a_1544_3134# 1.25711f
C1158 a_14643_1842# a_14751_2470# 0.01697f
C1159 a_2297_16422# VDD 0.46536f
C1160 a_24393_14024# VDD 0.71574f
C1161 a_17865_12701# VDD 0.29444f
C1162 a_24084_3853# VDD 0.28297f
C1163 a_15837_4687# VDD 0.8821f
C1164 a_2873_13577# CHAN1_MUX_SEL1 0.13092f
C1165 a_3449_13577# CHAN1_DELAY_IN 0.01058f
C1166 a_4187_2434# a_24393_16869# 0.11005f
C1167 a_14317_16869# a_13883_16869# 0.6972f
C1168 a_17357_16869# a_18004_16035# 0.02312f
C1169 a_18313_14024# a_18443_14024# 0.70845f
C1170 a_4187_2434# a_15273_7532# 0.11297f
C1171 a_1256_13226# a_1544_13226# 1.26509f
C1172 a_4187_2434# a_24957_1842# 0.0414f
C1173 a_5197_7532# a_4763_7532# 0.6972f
C1174 a_10328_6734# a_10430_6734# 0.37183f
C1175 a_19963_7532# a_20071_7532# 0.01163f
C1176 a_7477_7532# a_7390_6734# 0.1088f
C1177 a_26043_7532# a_26151_8160# 0.01697f
C1178 a_16108_5979# a_16793_4687# 0.01481f
C1179 a_9757_4687# a_9953_4687# 0.72407f
C1180 a_12797_4687# a_12791_3853# 0.02354f
C1181 a_16408_3889# a_16484_3853# 0.01176f
C1182 a_16108_3134# a_26477_1842# 0.01319f
C1183 a_18117_1842# a_18004_1008# 0.02055f
C1184 a_14317_1842# a_15077_1842# 0.03319f
C1185 a_13470_1044# a_5731_289# 0.41365f
C1186 a_22590_1044# a_22564_1008# 0.277f
C1187 a_27563_16869# VDD 0.49811f
C1188 a_6717_14024# VDD 0.88148f
C1189 a_11924_13190# VDD 0.28225f
C1190 a_18443_7532# VDD 0.4973f
C1191 a_1544_5979# VDD 0.39372f
C1192 a_14025_3889# VDD 0.30411f
C1193 a_4111_2470# VDD 0.01866f
C1194 VDD CHAN0_MUX_SEL0 0.60193f
C1195 a_4187_2434# a_6717_16869# 0.0414f
C1196 a_5197_16869# a_5393_16869# 0.76914f
C1197 a_7477_16869# a_7390_16071# 0.1088f
C1198 a_19963_16869# a_20071_16869# 0.01163f
C1199 a_18585_16071# a_18871_16035# 0.01885f
C1200 a_9757_14024# a_9323_14024# 0.6972f
C1201 a_4187_2434# a_27563_4687# 0.06629f
C1202 a_16408_13226# a_16510_13226# 0.37183f
C1203 a_26803_14024# a_26911_14024# 0.01163f
C1204 a_12849_11557# a_13592_11113# 0.38497f
C1205 a_4187_2434# a_6283_1842# 0.06627f
C1206 a_26477_7532# a_27124_6698# 0.02312f
C1207 a_21917_7532# a_22677_7532# 0.06198f
C1208 a_26477_4687# a_26803_4687# 0.01427f
C1209 a_4350_3889# a_4324_3853# 0.277f
C1210 a_9465_3889# a_9751_3853# 0.01885f
C1211 a_8237_1842# a_7390_1044# 0.08038f
C1212 a_13557_1842# a_14025_1044# 0.19203f
C1213 a_5197_1842# a_5523_1842# 0.01427f
C1214 a_5731_3134# a_10713_1842# 0.01865f
C1215 a_21625_1044# a_19550_1044# 0.03208f
C1216 a_10430_1044# a_11195_1044# 0.39037f
C1217 a_9953_16869# VDD 0.49351f
C1218 a_16510_16071# VDD 1.0321f
C1219 a_4324_6698# VDD 0.28687f
C1220 a_14851_10872# VDD 0.26676f
C1221 a_13991_5315# VDD 0.01806f
C1222 a_10517_1842# VDD 0.87097f
C1223 a_17275_1044# VDD 0.15389f
C1224 a_2297_7085# REF_MUX_SEL1 0.01995f
C1225 a_1544_6734# REF_MUX_OUT 0.04258f
C1226 a_5731_3134# CHAN2_MUX_OUT 1.04829f
C1227 a_8745_3364# CHAN2_MUX_SEL4 0.04472f
C1228 CHAN1_MUX_SEL4 CHAN1_MUX_OUT 0.91933f
C1229 VDD CHAN2_MUX_SEL3 0.421f
C1230 a_4187_2434# a_18443_14024# 0.06627f
C1231 a_26477_16869# a_27124_16035# 0.02312f
C1232 a_21917_16869# a_22243_16869# 0.01427f
C1233 a_26477_14024# a_27237_14024# 0.03319f
C1234 a_4187_2434# a_9953_4687# 0.11076f
C1235 a_9465_13226# a_9675_13226# 0.09424f
C1236 a_4248_13226# a_4324_13190# 0.01176f
C1237 a_12797_7532# a_13123_7532# 0.01427f
C1238 a_5731_12471# a_13019_11521# 0.01694f
C1239 a_16597_7532# a_16510_6734# 0.1088f
C1240 a_17553_4687# a_18117_4687# 0.0114f
C1241 a_27048_3889# a_27124_3853# 0.01176f
C1242 a_21917_4687# a_21911_3853# 0.02354f
C1243 a_27237_1842# a_27124_1008# 0.02055f
C1244 a_7043_1842# a_7151_1842# 0.01163f
C1245 a_22113_1842# a_22243_1842# 0.70845f
C1246 a_13123_1842# a_13231_2470# 0.01697f
C1247 a_2019_311# a_17865_519# 0.13959f
C1248 a_5731_289# a_15765_463# 0.23301f
C1249 a_22677_14024# VDD 0.87098f
C1250 a_23871_8160# VDD 0.01806f
C1251 a_13123_4687# VDD 0.49994f
C1252 a_21835_3889# VDD 0.15407f
C1253 a_1544_13226# CHAN1_MUX_SEL0 0.07603f
C1254 a_1256_13226# CHAN1_MUX_SEL1 1.44243f
C1255 a_9712_9602# DLL_RESETN 0.43074f
C1256 a_12993_16869# a_13557_16869# 0.0114f
C1257 a_4187_2434# a_22677_16869# 0.0414f
C1258 a_16597_16869# a_16510_16071# 0.1088f
C1259 a_19550_16071# a_21911_16035# 0.26208f
C1260 a_4187_2434# a_13557_7532# 0.0414f
C1261 a_4187_2434# a_22243_1842# 0.06627f
C1262 a_8808_6734# a_8884_6698# 0.01176f
C1263 a_18585_6734# a_16510_6734# 0.03208f
C1264 a_18443_7532# a_18551_7532# 0.01163f
C1265 a_24523_7532# a_24631_8160# 0.01697f
C1266 a_11277_4687# a_11924_3853# 0.02312f
C1267 a_8433_4687# a_8563_4687# 0.70361f
C1268 a_17357_1842# a_16510_1044# 0.08038f
C1269 a_13557_1842# a_13123_1842# 0.69698f
C1270 a_16108_3134# a_23763_1842# 0.01371f
C1271 a_27237_1842# a_27705_1044# 0.2079f
C1272 a_4003_14024# VDD 0.61691f
C1273 a_25913_16869# VDD 0.493f
C1274 a_9675_13226# VDD 0.15407f
C1275 a_16793_7532# VDD 0.54038f
C1276 a_25604_6698# VDD 0.28633f
C1277 a_26477_1842# VDD 0.87175f
C1278 a_4157_4158# VDD 0.48942f
C1279 a_6326_10280# CHAN1_MUX_OUT 0.06947f
C1280 a_4187_2434# a_4003_16869# 0.05992f
C1281 a_17065_16071# a_16510_16071# 0.03209f
C1282 a_18443_16869# a_18551_16869# 0.01163f
C1283 a_11277_14024# a_11848_13226# 0.10863f
C1284 a_8433_14024# a_8997_14024# 0.0114f
C1285 a_25283_14024# a_25391_14024# 0.01163f
C1286 a_14888_13226# a_14964_13190# 0.01176f
C1287 a_4187_2434# a_25913_4687# 0.11222f
C1288 a_21157_7532# a_20723_7532# 0.6972f
C1289 a_12849_11557# a_15304_10295# 0.0606f
C1290 a_6126_9506# a_9444_9602# 0.25721f
C1291 a_4187_2434# a_4633_1842# 0.11222f
C1292 a_5974_11413# a_5864_9057# 0.01697f
C1293 a_6854_11144# a_5778_9057# 0.02695f
C1294 a_6854_11676# a_9712_9602# 0.13866f
C1295 a_13592_11561# a_14851_11918# 0.01529f
C1296 a_25717_7532# a_25630_6734# 0.1088f
C1297 a_25717_4687# a_25913_4687# 0.73897f
C1298 a_4437_1842# a_4633_1842# 0.73897f
C1299 a_7945_3889# a_7390_3889# 0.03209f
C1300 a_6717_1842# a_6711_1008# 0.02354f
C1301 a_8237_16869# VDD 0.87094f
C1302 a_13444_16035# VDD 0.28633f
C1303 a_13566_11018# VDD 0.0947f
C1304 a_21625_6734# VDD 0.29722f
C1305 a_7803_1842# VDD 0.50128f
C1306 a_7911_5315# VDD 0.01806f
C1307 a_14311_1008# VDD 0.28336f
C1308 a_13019_11521# REF_DELAY_OUT_LAST 0.08017f
C1309 a_2873_3176# CHAN2_MUX_SEL4 0.04916f
C1310 a_2297_3176# CHAN2_MUX_OUT 0.01179f
C1311 a_3449_3176# CHAN2_MUX_SEL3 0.28429f
C1312 VDD REF_MUX_SEL3 0.421f
C1313 CHAN1_MUX_SEL0 CHAN1_MUX_SEL1 3.14917f
C1314 a_21157_16869# a_21353_16869# 0.77122f
C1315 a_4187_2434# a_16793_14024# 0.11113f
C1316 a_25717_16869# a_25630_16071# 0.1088f
C1317 a_25717_14024# a_25283_14024# 0.69698f
C1318 a_25630_16071# a_26985_15546# 0.02195f
C1319 a_4187_2434# a_8237_4687# 0.04141f
C1320 a_6326_10280# a_5974_11413# 0.33128f
C1321 a_12037_7532# a_12233_7532# 0.77122f
C1322 a_19448_6734# a_19524_6698# 0.01176f
C1323 a_20397_4687# a_21044_3853# 0.02312f
C1324 a_16597_4687# a_17357_4687# 0.01669f
C1325 a_25630_3889# a_25604_3853# 0.277f
C1326 a_11603_1842# a_11711_2470# 0.01697f
C1327 a_5523_1842# a_5631_1842# 0.01163f
C1328 a_26477_1842# a_25630_1044# 0.08038f
C1329 a_19963_14024# VDD 0.50058f
C1330 a_11473_4687# VDD 0.49593f
C1331 a_17791_8160# VDD 0.01806f
C1332 a_18871_3853# VDD 0.2822f
C1333 a_12037_16869# a_12797_16869# 0.02912f
C1334 a_4187_2434# a_19963_16869# 0.06627f
C1335 a_19448_16071# a_19550_16071# 0.37183f
C1336 a_20397_14024# a_20968_13226# 0.10863f
C1337 a_16597_14024# a_16793_14024# 0.73897f
C1338 a_4187_2434# a_10843_7532# 0.06627f
C1339 a_25528_13226# a_25604_13190# 0.01176f
C1340 a_16923_7532# a_17031_7532# 0.01163f
C1341 a_23003_7532# a_23111_8160# 0.01697f
C1342 a_4187_2434# a_20593_1842# 0.11222f
C1343 a_7390_6734# a_7364_6698# 0.277f
C1344 a_5731_5979# a_15273_4687# 0.01872f
C1345 a_10517_4687# a_10430_3889# 0.1088f
C1346 a_24665_3889# a_24951_3853# 0.01885f
C1347 a_12233_1842# a_12797_1842# 0.0114f
C1348 a_16108_3134# a_22113_1842# 0.01872f
C1349 a_13470_3889# a_14235_3889# 0.39037f
C1350 a_15837_1842# a_15831_1008# 0.02354f
C1351 a_24197_16869# VDD 0.93709f
C1352 a_19550_1044# a_20391_1008# 0.28268f
C1353 a_15964_15316# VDD 0.42016f
C1354 a_15077_7532# VDD 0.86025f
C1355 a_6711_13190# VDD 0.2822f
C1356 a_23355_6734# VDD 0.15389f
C1357 a_23763_1842# VDD 0.52742f
C1358 a_16851_309# VDD 0.51536f
C1359 a_15964_12471# CHAN1_MUX_SEL4 0.5544f
C1360 CHAN3_MUX_SEL3 CHAN3_MUX_SEL4 0.75489f
C1361 CHAN3_MUX_SEL2 CHAN3_MUX_OUT 0.08497f
C1362 a_16923_16869# a_17031_16869# 0.01163f
C1363 a_14025_16071# a_14311_16035# 0.01885f
C1364 a_7288_16071# a_7364_16035# 0.01176f
C1365 a_5731_15316# a_14643_14024# 0.01544f
C1366 a_7477_14024# a_8237_14024# 0.01669f
C1367 a_23763_14024# a_23871_14024# 0.01163f
C1368 a_4187_2434# a_16108_3134# 0.20422f
C1369 a_4187_2434# a_24197_4687# 0.03928f
C1370 a_13566_11525# a_14009_11568# 0.02242f
C1371 a_24665_13226# a_24875_13226# 0.09424f
C1372 a_13470_13226# a_13444_13190# 0.277f
C1373 a_13121_11521# a_14111_11568# 0.0235f
C1374 a_19833_7532# a_20397_7532# 0.0114f
C1375 a_24393_4687# a_24523_4687# 0.70361f
C1376 a_5731_3134# a_6283_1842# 0.01542f
C1377 a_5197_1842# a_5844_1008# 0.02312f
C1378 a_15545_1044# a_15755_1044# 0.09424f
C1379 a_7390_1044# a_8808_1044# 0.38994f
C1380 a_5523_16869# VDD 0.49671f
C1381 a_11195_16071# VDD 0.15389f
C1382 a_9465_6734# VDD 0.29722f
C1383 a_27433_4687# VDD 0.49998f
C1384 a_6153_1842# VDD 0.4946f
C1385 a_11848_1044# VDD 0.17499f
C1386 a_3449_1395# CHAN3_MUX_SEL0 0.10753f
C1387 CHAN0_MUX_SEL4 CHAN0_MUX_OUT 0.91933f
C1388 a_19833_16869# a_19963_16869# 0.70845f
C1389 a_4187_2434# a_15077_14024# 0.04141f
C1390 a_24393_14024# a_24957_14024# 0.0114f
C1391 a_4187_2434# a_26803_7532# 0.06661f
C1392 a_4187_2434# a_5523_4687# 0.06627f
C1393 a_4905_13226# a_5191_13190# 0.01885f
C1394 a_16108_12471# a_26985_12701# 0.27952f
C1395 a_10713_7532# a_10843_7532# 0.70845f
C1396 a_4350_6734# a_5731_5979# 0.41099f
C1397 a_15837_4687# a_15403_4687# 0.6972f
C1398 a_19637_4687# a_19550_3889# 0.1088f
C1399 a_20397_1842# a_20593_1842# 0.76914f
C1400 a_4003_1842# a_4111_1842# 0.01163f
C1401 a_10083_1842# a_10191_2470# 0.01697f
C1402 a_24957_1842# a_24951_1008# 0.02354f
C1403 a_18313_14024# VDD 0.49462f
C1404 a_11711_8160# VDD 0.01806f
C1405 a_27991_13190# VDD 0.28201f
C1406 a_9757_4687# VDD 0.88049f
C1407 a_16408_3889# VDD 0.1824f
C1408 a_13592_11113# REF_CLK 0.03445f
C1409 a_11785_6209# REF_MUX_SEL4 0.03255f
C1410 a_11277_16869# a_10843_16869# 0.6972f
C1411 a_4187_2434# a_18313_16869# 0.11222f
C1412 a_17928_16071# a_18004_16035# 0.01176f
C1413 a_15273_14024# a_15403_14024# 0.70845f
C1414 a_4187_2434# a_9193_7532# 0.11222f
C1415 a_15688_11093# a_15464_9374# 0.1999f
C1416 a_4187_2434# a_18877_1842# 0.0414f
C1417 a_9444_10280# a_9712_9602# 0.68929f
C1418 a_21483_7532# a_21591_8160# 0.01697f
C1419 a_15403_7532# a_15511_7532# 0.01163f
C1420 a_12505_6734# a_12715_6734# 0.09424f
C1421 a_6717_4687# a_6913_4687# 0.76914f
C1422 a_5731_5979# a_13557_4687# 0.01314f
C1423 a_23145_3889# a_22590_3889# 0.03209f
C1424 a_11277_1842# a_12037_1842# 0.03319f
C1425 a_16108_3134# a_20397_1842# 0.01319f
C1426 a_14317_1842# a_14964_1008# 0.02312f
C1427 a_18795_1044# a_18871_1008# 0.01194f
C1428 a_21483_16869# VDD 0.4973f
C1429 a_8745_15546# VDD 0.29714f
C1430 a_4248_13226# VDD 0.17587f
C1431 a_12363_7532# VDD 0.4973f
C1432 a_20391_6698# VDD 0.28357f
C1433 a_22113_1842# VDD 0.49655f
C1434 a_2297_16422# CHAN0_MUX_SEL1 0.01995f
C1435 a_1544_16071# CHAN0_MUX_OUT 0.04258f
C1436 a_5731_12471# CHAN1_MUX_OUT 1.04829f
C1437 a_8745_12701# CHAN1_MUX_SEL4 0.04472f
C1438 CHAN3_DELAY_IN CHAN3_MUX_SEL1 0.01858f
C1439 a_15403_16869# a_15511_16869# 0.01163f
C1440 a_5731_15316# a_12993_14024# 0.01872f
C1441 a_6717_14024# a_6283_14024# 0.6972f
C1442 a_22243_14024# a_22351_14024# 0.01163f
C1443 a_4187_2434# a_21483_4687# 0.06627f
C1444 a_18877_7532# a_19637_7532# 0.06198f
C1445 a_1544_5979# a_1721_6021# 0.36963f
C1446 a_1256_5979# a_2297_6021# 0.04261f
C1447 a_23437_4687# a_23763_4687# 0.01427f
C1448 a_4437_1842# a_4350_1044# 0.1088f
C1449 a_15765_3308# a_16108_3134# 0.42004f
C1450 a_4187_2434# VDD 75.3026f
C1451 a_22351_14652# VDD 0.01806f
C1452 a_8231_16035# VDD 0.28357f
C1453 a_12943_11557# VDD 0.29488f
C1454 a_25717_4687# VDD 0.86974f
C1455 a_4437_1842# VDD 0.87147f
C1456 a_8884_1008# VDD 0.28358f
C1457 CHAN0_MUX_SEL0 CHAN0_MUX_SEL1 3.14917f
C1458 a_4187_2434# a_12363_14024# 0.06627f
C1459 a_1544_16071# a_1721_16422# 0.38063f
C1460 a_18877_16869# a_19203_16869# 0.01427f
C1461 a_1256_15316# a_1721_15358# 0.13421f
C1462 a_4187_2434# a_25153_7532# 0.11231f
C1463 a_23437_14024# a_24197_14024# 0.03319f
C1464 a_15765_12645# a_15964_12471# 0.061f
C1465 a_5731_12471# a_5974_11413# 0.01167f
C1466 a_16510_6734# a_17275_6734# 0.39037f
C1467 a_14513_4687# a_15077_4687# 0.0114f
C1468 a_16108_5979# a_26673_4687# 0.01872f
C1469 a_22590_3889# a_23431_3853# 0.28268f
C1470 a_19073_1842# a_19203_1842# 0.70845f
C1471 a_8563_1842# a_8671_2470# 0.01697f
C1472 a_23437_1842# a_24084_1008# 0.02312f
C1473 a_16597_14024# VDD 0.94753f
C1474 a_5631_8160# VDD 0.01806f
C1475 a_25528_13226# VDD 0.17274f
C1476 a_7043_4687# VDD 0.49996f
C1477 a_13470_3889# VDD 0.88092f
C1478 a_15304_10295# REF_CLK 0.01066f
C1479 CHAN1_MUX_OUT REF_DELAY_OUT_LAST 0.02664f
C1480 a_4187_2434# a_16597_16869# 0.03917f
C1481 a_9953_16869# a_10517_16869# 0.0114f
C1482 a_14317_14024# a_14643_14024# 0.01427f
C1483 a_4187_2434# a_7477_7532# 0.0414f
C1484 a_16510_16071# a_16484_16035# 0.277f
C1485 a_16108_15316# a_26043_14024# 0.01539f
C1486 a_14851_10872# a_15108_11015# 0.29858f
C1487 a_22590_13226# a_23355_13226# 0.39037f
C1488 a_14009_10774# a_14757_10872# 0.01058f
C1489 a_4187_2434# a_16163_1842# 0.06315f
C1490 a_26673_7532# a_26803_7532# 0.70845f
C1491 a_13883_7532# a_13991_7532# 0.01163f
C1492 a_19963_7532# a_20071_8160# 0.01697f
C1493 a_4187_2434# a_25630_1044# 0.01522f
C1494 a_4350_6734# a_5191_6698# 0.28268f
C1495 a_5393_4687# a_5523_4687# 0.70845f
C1496 a_5731_5979# a_10843_4687# 0.01539f
C1497 a_20105_3889# a_20391_3853# 0.01885f
C1498 a_10430_3889# a_11848_3889# 0.38994f
C1499 a_13557_1842# a_13470_1044# 0.1088f
C1500 a_10517_1842# a_10083_1842# 0.69698f
C1501 a_16510_1044# a_18004_1008# 0.28279f
C1502 a_17275_1044# a_17351_1008# 0.01194f
C1503 a_4350_1044# a_5705_519# 0.02005f
C1504 a_19833_16869# VDD 0.49294f
C1505 a_2873_15358# VDD 0.46598f
C1506 a_18585_13226# VDD 0.29742f
C1507 a_10713_7532# VDD 0.49294f
C1508 a_17928_6734# VDD 0.17499f
C1509 a_5705_519# VDD 0.29556f
C1510 a_20397_1842# VDD 0.87175f
C1511 a_3449_12513# CHAN1_MUX_SEL3 0.28429f
C1512 a_2297_12513# CHAN1_MUX_OUT 0.01179f
C1513 a_2873_12513# CHAN1_MUX_SEL4 0.04916f
C1514 a_7390_6734# REF_MUX_SEL4 0.29489f
C1515 CHAN2_MUX_SEL3 CHAN2_MUX_SEL4 0.75489f
C1516 CHAN2_MUX_SEL2 CHAN2_MUX_OUT 0.08497f
C1517 a_4350_16071# a_5115_16071# 0.39037f
C1518 a_13883_16869# a_13991_16869# 0.01163f
C1519 a_27237_16869# a_26803_16869# 0.6972f
C1520 a_5731_15316# a_11277_14024# 0.01319f
C1521 a_5393_14024# a_5957_14024# 0.0114f
C1522 a_4187_2434# a_19833_4687# 0.11222f
C1523 a_10430_13226# a_11271_13190# 0.28268f
C1524 a_20723_14024# a_20831_14024# 0.01163f
C1525 a_26803_14024# a_26911_14652# 0.01697f
C1526 a_20105_13226# a_20315_13226# 0.09424f
C1527 a_7803_14024# a_7390_13226# 0.01012f
C1528 a_12355_11557# a_13019_11521# 0.3846f
C1529 a_18117_7532# a_17683_7532# 0.6972f
C1530 a_19550_6734# a_16108_5979# 0.58202f
C1531 a_22677_4687# a_22873_4687# 0.73897f
C1532 a_5731_3134# a_16108_3134# 0.01334f
C1533 a_10985_1044# a_11195_1044# 0.09424f
C1534 a_5768_16071# VDD 0.17499f
C1535 a_4350_1044# a_6635_1044# 0.39036f
C1536 a_16271_14652# VDD 0.02023f
C1537 a_12849_11557# VDD 2.58319f
C1538 a_1544_6734# VDD 0.45079f
C1539 a_23003_4687# VDD 0.50071f
C1540 a_15765_3308# VDD 0.36528f
C1541 a_6635_1044# VDD 0.15407f
C1542 a_18117_16869# a_18313_16869# 0.77122f
C1543 a_4187_2434# a_10713_14024# 0.11222f
C1544 a_4187_2434# a_23437_7532# 0.04176f
C1545 a_22677_14024# a_22243_14024# 0.69698f
C1546 a_8997_7532# a_9193_7532# 0.77122f
C1547 a_5731_12471# a_15964_12471# 0.2778f
C1548 a_27705_6734# a_27915_6734# 0.09424f
C1549 a_19637_7532# a_20105_6734# 0.19203f
C1550 a_12363_7532# a_10430_6734# 0.01012f
C1551 a_16108_5979# a_24957_4687# 0.01307f
C1552 a_13557_4687# a_14317_4687# 0.01669f
C1553 a_21835_3889# a_21911_3853# 0.01194f
C1554 a_22677_1842# a_22590_1044# 0.1088f
C1555 a_7043_1842# a_7151_2470# 0.01697f
C1556 a_19550_1044# a_20905_519# 0.02165f
C1557 a_26911_17497# VDD 0.01806f
C1558 a_22590_13226# VDD 1.09883f
C1559 a_13883_14024# VDD 0.50058f
C1560 a_26673_7532# VDD 0.49417f
C1561 a_5393_4687# VDD 0.49643f
C1562 a_10404_3853# VDD 0.28633f
C1563 a_27671_2470# VDD 0.01806f
C1564 a_3449_7085# REF_CLK 0.01058f
C1565 a_2297_6021# REF_MUX_SEL2 0.10655f
C1566 a_1256_5979# REF_MUX_OUT 0.1134f
C1567 a_1544_5979# REF_MUX_SEL4 0.47529f
C1568 a_4157_4158# CHAN2_MUX_SEL4 0.08229f
C1569 a_16108_289# CHAN3_MUX_OUT 0.24265f
C1570 a_4187_2434# a_13883_16869# 0.06627f
C1571 a_8997_16869# a_9757_16869# 0.02912f
C1572 a_12363_16869# a_10430_16071# 0.01012f
C1573 a_19637_16869# a_20105_16071# 0.19203f
C1574 a_4187_2434# a_4763_7532# 0.06627f
C1575 a_13557_14024# a_13753_14024# 0.73897f
C1576 a_16923_14024# a_16510_13226# 0.01012f
C1577 a_4187_2434# a_14513_1842# 0.11222f
C1578 a_12363_7532# a_12471_7532# 0.01163f
C1579 a_18443_7532# a_18551_8160# 0.01697f
C1580 a_4437_7532# a_4905_6734# 0.19203f
C1581 a_7945_6734# a_8155_6734# 0.09424f
C1582 a_5731_5979# a_9193_4687# 0.01872f
C1583 a_16108_3134# a_16033_1842# 0.01197f
C1584 a_9193_1842# a_9757_1842# 0.0114f
C1585 a_27048_16071# VDD 0.17499f
C1586 a_18117_16869# VDD 0.85892f
C1587 a_8997_7532# VDD 0.88798f
C1588 a_14964_6698# VDD 0.28225f
C1589 a_17683_1842# VDD 0.48149f
C1590 a_27915_1044# VDD 0.15389f
C1591 CHAN2_DELAY_IN CHAN2_MUX_SEL1 0.01858f
C1592 a_25913_16869# a_26477_16869# 0.0114f
C1593 a_12363_16869# a_12471_16869# 0.01163f
C1594 a_9465_16071# a_7390_16071# 0.03208f
C1595 a_4437_16869# a_4905_16071# 0.19203f
C1596 a_4187_2434# a_26673_14024# 0.11222f
C1597 a_4437_14024# a_5197_14024# 0.01669f
C1598 a_12037_14024# a_12505_13226# 0.2079f
C1599 a_6717_14024# a_7288_13226# 0.10864f
C1600 a_25283_14024# a_25391_14652# 0.01697f
C1601 a_19203_14024# a_19311_14024# 0.01163f
C1602 a_9675_13226# a_9751_13190# 0.01194f
C1603 a_4187_2434# a_18117_4687# 0.04152f
C1604 a_16793_7532# a_17357_7532# 0.0114f
C1605 a_25630_6734# a_26471_6698# 0.28268f
C1606 a_16510_6734# a_16851_5999# 0.02131f
C1607 a_21483_7532# a_19550_6734# 0.01012f
C1608 a_21353_4687# a_21483_4687# 0.70845f
C1609 a_26477_1842# a_26043_1842# 0.6972f
C1610 a_26185_16071# VDD 0.30409f
C1611 a_12158_11557# VDD 0.37941f
C1612 a_10191_14652# VDD 0.01806f
C1613 a_5731_3134# VDD 0.98849f
C1614 a_21353_4687# VDD 0.4946f
C1615 a_11785_15546# CHAN0_MUX_SEL4 0.03255f
C1616 a_16793_16869# a_16923_16869# 0.70845f
C1617 a_21483_16869# a_19550_16071# 0.01012f
C1618 a_4187_2434# a_8997_14024# 0.04096f
C1619 a_4187_2434# a_20723_7532# 0.06661f
C1620 a_25630_16071# a_26395_16071# 0.39037f
C1621 a_16510_16071# a_16108_15316# 0.56108f
C1622 a_21353_14024# a_21917_14024# 0.0114f
C1623 a_26043_14024# a_25630_13226# 0.01012f
C1624 a_5731_12471# a_8745_12701# 0.28635f
C1625 a_7673_7532# a_7803_7532# 0.70845f
C1626 a_13470_6734# a_14888_6734# 0.38994f
C1627 a_16108_5979# a_22243_4687# 0.01539f
C1628 a_12797_4687# a_12363_4687# 0.6972f
C1629 a_19550_3889# a_21044_3853# 0.28279f
C1630 a_20315_3889# a_20391_3853# 0.01194f
C1631 a_5523_1842# a_5631_2470# 0.01697f
C1632 a_17357_1842# a_17553_1842# 0.7425f
C1633 a_25630_1044# a_27915_1044# 0.39036f
C1634 a_12233_14024# VDD 0.4946f
C1635 a_20831_17497# VDD 0.01806f
C1636 a_19524_13190# VDD 0.28633f
C1637 a_20905_6209# VDD 0.29292f
C1638 a_24957_7532# VDD 0.87948f
C1639 a_8155_3889# VDD 0.1539f
C1640 a_21591_2470# VDD 0.01806f
C1641 a_2873_4240# CHAN2_MUX_SEL0 0.01504f
C1642 a_8237_16869# a_7803_16869# 0.6972f
C1643 a_4187_2434# a_12233_16869# 0.11222f
C1644 a_13470_16071# a_14311_16035# 0.28268f
C1645 a_12233_14024# a_12363_14024# 0.70845f
C1646 a_15837_14024# a_16408_13226# 0.10864f
C1647 a_16108_15316# a_22677_14024# 0.01314f
C1648 a_25717_14024# a_26185_13226# 0.19203f
C1649 a_19550_13226# a_20968_13226# 0.38994f
C1650 a_16923_7532# a_17031_8160# 0.01697f
C1651 a_10843_7532# a_10951_7532# 0.01163f
C1652 a_24957_7532# a_25153_7532# 0.74845f
C1653 a_13566_11018# a_13306_10795# 0.75507f
C1654 a_4187_2434# a_12797_1842# 0.0414f
C1655 a_5731_5979# a_7477_4687# 0.01314f
C1656 a_10517_4687# a_10985_3889# 0.19203f
C1657 a_6283_4687# a_4350_3889# 0.01012f
C1658 a_8237_1842# a_8997_1842# 0.03319f
C1659 a_7390_3889# a_9675_3889# 0.39036f
C1660 a_13470_1044# a_15831_1008# 0.26208f
C1661 a_26185_1044# a_26395_1044# 0.09424f
C1662 a_15403_16869# VDD 0.49799f
C1663 a_24084_16035# VDD 0.28297f
C1664 a_6283_7532# VDD 0.4973f
C1665 a_12715_6734# VDD 0.15406f
C1666 a_16033_1842# VDD 0.54891f
C1667 a_24951_1008# VDD 0.2822f
C1668 REF_MUX_SEL2 REF_MUX_OUT 0.08497f
C1669 REF_MUX_SEL3 REF_MUX_SEL4 0.75489f
C1670 a_10843_16869# a_10951_16869# 0.01163f
C1671 a_24957_16869# a_25717_16869# 0.05851f
C1672 a_4187_2434# a_24957_14024# 0.0414f
C1673 a_6717_14024# a_4350_13226# 0.02479f
C1674 a_17683_14024# a_17791_14024# 0.01163f
C1675 a_5731_15316# a_6913_14024# 0.01872f
C1676 a_23763_14024# a_23871_14652# 0.01697f
C1677 a_15545_13226# a_15831_13190# 0.01885f
C1678 a_4187_2434# a_15403_4687# 0.06627f
C1679 a_7390_13226# a_8884_13190# 0.28279f
C1680 a_8155_13226# a_8231_13190# 0.01194f
C1681 a_10232_11561# a_11397_11918# 0.43239f
C1682 a_15837_7532# a_16597_7532# 0.06198f
C1683 a_24875_6734# a_24951_6698# 0.01194f
C1684 a_20397_4687# a_20723_4687# 0.01427f
C1685 a_25153_1842# a_25717_1842# 0.0114f
C1686 a_14025_16071# VDD 0.30409f
C1687 a_4111_14652# VDD 0.01866f
C1688 a_10206_11525# VDD 0.09398f
C1689 a_19637_4687# VDD 0.871f
C1690 a_2297_3176# VDD 0.46603f
C1691 a_17065_1044# VDD 0.30218f
C1692 a_9757_4687# CHAN2_MUX_SEL4 0.01829f
C1693 a_15837_16869# a_16163_16869# 0.01427f
C1694 a_4187_2434# a_6283_14024# 0.06627f
C1695 a_4187_2434# a_19073_7532# 0.11286f
C1696 a_20397_14024# a_21157_14024# 0.03319f
C1697 a_24957_14024# a_25528_13226# 0.10864f
C1698 a_6717_7532# a_7043_7532# 0.01427f
C1699 a_11473_4687# a_12037_4687# 0.0114f
C1700 a_23145_6734# a_23355_6734# 0.09424f
C1701 a_16108_5979# a_20593_4687# 0.01872f
C1702 a_15403_4687# a_13470_3889# 0.01012f
C1703 a_24197_4687# a_24665_3889# 0.2079f
C1704 a_16033_1842# a_16163_1842# 0.70361f
C1705 a_4003_1842# a_4111_2470# 0.01697f
C1706 a_10517_14024# VDD 0.87097f
C1707 a_14751_17497# VDD 0.01806f
C1708 a_22243_7532# VDD 0.4974f
C1709 a_17275_13226# VDD 0.15389f
C1710 a_15511_2470# VDD 0.01806f
C1711 a_5191_3853# VDD 0.28637f
C1712 a_7390_16071# CHAN0_MUX_SEL4 0.29489f
C1713 a_12355_11557# CHAN1_MUX_OUT 0.05729f
C1714 a_1256_3889# CHAN2_MUX_SEL0 0.3314f
C1715 a_2019_311# CHAN3_MUX_SEL3 0.06209f
C1716 VDD REF_CLK 2.53805f
C1717 a_5705_519# CHAN3_MUX_SEL4 0.03556f
C1718 a_6913_16869# a_7477_16869# 0.0114f
C1719 a_4187_2434# a_10517_16869# 0.0414f
C1720 a_12715_16071# a_12791_16035# 0.01194f
C1721 a_24665_16071# a_22590_16071# 0.03208f
C1722 a_16108_15316# a_19963_14024# 0.01539f
C1723 a_11277_14024# a_11603_14024# 0.01427f
C1724 a_15837_14024# a_13470_13226# 0.02479f
C1725 a_4187_2434# a_10083_1842# 0.06492f
C1726 a_13106_11047# a_12907_10876# 0.02437f
C1727 a_13019_11521# a_9712_9602# 0.03275f
C1728 a_23633_7532# a_23763_7532# 0.70845f
C1729 a_9323_7532# a_9431_7532# 0.01163f
C1730 a_15403_7532# a_15511_8160# 0.01697f
C1731 a_4157_7003# a_4248_6734# 0.11672f
C1732 a_15964_5979# a_16851_5999# 0.16757f
C1733 a_15545_3889# a_13470_3889# 0.03208f
C1734 a_5731_3134# a_14513_1842# 0.01872f
C1735 a_7477_1842# a_7043_1842# 0.69698f
C1736 a_13753_16869# VDD 0.49294f
C1737 a_13368_1044# a_13470_1044# 0.37183f
C1738 a_21835_16071# VDD 0.15406f
C1739 a_4633_7532# VDD 0.49285f
C1740 a_25391_5315# VDD 0.01806f
C1741 a_9751_6698# VDD 0.2822f
C1742 a_14317_1842# VDD 0.87175f
C1743 a_22488_1044# VDD 0.17274f
C1744 a_4187_2434# CHAN2_MUX_SEL4 0.01921f
C1745 a_9323_16869# a_9431_16869# 0.01163f
C1746 a_24197_16869# a_23763_16869# 0.6972f
C1747 a_15964_15316# a_16108_15316# 0.42202f
C1748 a_4187_2434# a_22243_14024# 0.06627f
C1749 a_22243_14024# a_22351_14652# 0.01697f
C1750 a_16163_14024# a_16271_14024# 0.01163f
C1751 a_4437_14024# a_4324_13190# 0.05157f
C1752 a_4187_2434# a_13753_4687# 0.11222f
C1753 a_14025_13226# a_13470_13226# 0.03209f
C1754 a_10206_11525# a_10649_11568# 0.02242f
C1755 a_9946_11995# a_10520_11982# 0.31978f
C1756 a_15077_7532# a_14643_7532# 0.6972f
C1757 a_23355_6734# a_23431_6698# 0.01194f
C1758 a_22590_6734# a_24084_6698# 0.28279f
C1759 a_19637_4687# a_19833_4687# 0.73897f
C1760 a_15837_4687# a_15964_3134# 0.01935f
C1761 a_24523_4687# a_22590_3889# 0.01012f
C1762 a_24197_1842# a_24957_1842# 0.02912f
C1763 a_22590_3889# a_23945_3364# 0.02138f
C1764 a_6425_1044# a_4350_1044# 0.03208f
C1765 a_24957_1842# a_16108_289# 0.0157f
C1766 a_16108_289# a_20905_519# 0.2906f
C1767 a_4157_16340# VDD 0.48942f
C1768 a_26477_14024# VDD 0.87175f
C1769 a_6126_9506# VDD 0.90361f
C1770 a_16923_4687# VDD 0.4984f
C1771 a_26471_3853# VDD 0.28357f
C1772 a_6425_1044# VDD 0.29742f
C1773 a_1256_15316# CHAN0_MUX_OUT 0.1134f
C1774 a_4157_13495# CHAN1_MUX_SEL4 0.08229f
C1775 a_1544_15316# CHAN0_MUX_SEL4 0.47529f
C1776 a_2297_15358# CHAN0_MUX_SEL2 0.10655f
C1777 a_13470_3889# CHAN2_MUX_SEL4 0.256f
C1778 a_4187_2434# a_26477_16869# 0.04145f
C1779 a_15077_16869# a_15273_16869# 0.77122f
C1780 a_4187_2434# a_4633_14024# 0.11222f
C1781 a_22590_16071# a_24008_16071# 0.38994f
C1782 a_24957_14024# a_22590_13226# 0.02479f
C1783 a_4187_2434# a_17357_7532# 0.04176f
C1784 a_1256_13226# a_2873_13577# 0.28892f
C1785 a_19637_14024# a_19203_14024# 0.69698f
C1786 a_4187_2434# a_26043_1842# 0.06627f
C1787 a_5957_7532# a_6153_7532# 0.77122f
C1788 a_8237_7532# a_8808_6734# 0.10863f
C1789 a_10430_6734# a_12715_6734# 0.39036f
C1790 a_16108_5979# a_18877_4687# 0.01307f
C1791 a_10517_4687# a_11277_4687# 0.01669f
C1792 a_16510_3889# a_18871_3853# 0.26208f
C1793 a_8671_17497# VDD 0.02372f
C1794 a_13470_1044# a_14825_519# 0.02058f
C1795 a_7803_14024# VDD 0.50128f
C1796 a_14311_13190# VDD 0.28336f
C1797 a_20593_7532# VDD 0.49417f
C1798 a_24665_3889# VDD 0.29742f
C1799 a_9431_2470# VDD 0.01806f
C1800 a_10649_11568# REF_CLK 0.25484f
C1801 VDD CHAN1_DELAY_OUT_LAST 0.46919f
C1802 a_1256_289# CHAN3_MUX_SEL2 0.33134f
C1803 a_4187_2434# a_7803_16869# 0.06627f
C1804 a_5957_16869# a_6717_16869# 0.02912f
C1805 a_8237_16869# a_8808_16071# 0.10863f
C1806 a_27563_16869# a_27671_17497# 0.01697f
C1807 a_10430_16071# a_11924_16035# 0.28279f
C1808 a_11195_16071# a_11271_16035# 0.01194f
C1809 a_10517_14024# a_10713_14024# 0.73897f
C1810 a_16108_15316# a_18313_14024# 0.02026f
C1811 a_13557_14024# a_13444_13190# 0.05157f
C1812 a_16510_13226# a_18795_13226# 0.39036f
C1813 a_13121_11521# a_15688_11093# 0.01441f
C1814 a_4187_2434# a_8433_1842# 0.11169f
C1815 a_12849_11557# a_15108_11015# 0.10521f
C1816 a_7803_7532# a_7911_7532# 0.01163f
C1817 a_13883_7532# a_13991_8160# 0.01697f
C1818 a_27433_4687# a_27997_4687# 0.0114f
C1819 a_5731_3134# a_12797_1842# 0.01307f
C1820 a_15077_1842# a_15545_1044# 0.2079f
C1821 a_9323_1842# a_7390_1044# 0.01012f
C1822 a_6153_1842# a_6717_1842# 0.0114f
C1823 a_11848_1044# a_11924_1008# 0.01176f
C1824 a_21625_1044# a_21911_1008# 0.01885f
C1825 a_12037_16869# VDD 0.85889f
C1826 a_18871_16035# VDD 0.2822f
C1827 a_15464_9374# VDD 0.52511f
C1828 a_7288_6734# VDD 0.17274f
C1829 a_19311_5315# VDD 0.01806f
C1830 a_11603_1842# VDD 0.49684f
C1831 a_19550_1044# VDD 0.89766f
C1832 a_4187_2434# REF_MUX_SEL4 0.01921f
C1833 a_15765_3308# CHAN2_MUX_SEL4 0.65508f
C1834 VDD CHAN3_MUX_SEL2 0.51768f
C1835 a_22873_16869# a_23437_16869# 0.0114f
C1836 a_7803_16869# a_7911_16869# 0.01163f
C1837 a_4187_2434# a_20593_14024# 0.11222f
C1838 a_4187_2434# a_12037_4687# 0.04152f
C1839 a_14643_14024# a_14751_14024# 0.01163f
C1840 a_20723_14024# a_20831_14652# 0.01697f
C1841 a_4350_13226# a_6711_13190# 0.26208f
C1842 a_10985_13226# a_11271_13190# 0.01885f
C1843 a_13753_7532# a_14317_7532# 0.0114f
C1844 a_17357_7532# a_17928_6734# 0.10863f
C1845 a_18313_4687# a_18443_4687# 0.70845f
C1846 a_1256_3889# a_1544_3889# 1.26509f
C1847 a_23437_1842# a_23003_1842# 0.6972f
C1848 a_23763_14024# VDD 0.52741f
C1849 a_16851_12491# VDD 0.51536f
C1850 a_24008_3889# VDD 0.17499f
C1851 a_15273_4687# VDD 0.49468f
C1852 a_2873_13577# CHAN1_MUX_SEL0 0.01504f
C1853 a_4187_2434# a_16108_15316# 0.20422f
C1854 a_4187_2434# a_23763_16869# 0.06453f
C1855 a_17357_16869# a_17928_16071# 0.10863f
C1856 a_13753_16869# a_13883_16869# 0.70845f
C1857 a_4187_2434# a_14643_7532# 0.06668f
C1858 a_18313_14024# a_18877_14024# 0.0114f
C1859 a_22677_14024# a_22564_13190# 0.05157f
C1860 a_4633_7532# a_4763_7532# 0.70845f
C1861 a_4187_2434# a_24393_1842# 0.11005f
C1862 a_18585_6734# a_18871_6698# 0.01885f
C1863 a_9757_4687# a_9323_4687# 0.6972f
C1864 a_16408_3889# a_16510_3889# 0.37183f
C1865 a_26803_4687# a_26911_4687# 0.01163f
C1866 a_16108_3134# a_25913_1842# 0.01865f
C1867 a_14317_1842# a_14513_1842# 0.76914f
C1868 a_18443_1842# a_16510_1044# 0.01012f
C1869 a_22488_1044# a_22564_1008# 0.01176f
C1870 a_27997_16869# VDD 0.76025f
C1871 a_6153_14024# VDD 0.4946f
C1872 a_11848_13226# VDD 0.17499f
C1873 a_18877_7532# VDD 0.87825f
C1874 a_1256_5979# VDD 0.4205f
C1875 a_12505_3889# VDD 0.29742f
C1876 a_27563_1842# VDD 0.50391f
C1877 VDD CHAN0_DELAY_OUT_LAST 0.46312f
C1878 a_4187_2434# a_6153_16869# 0.11222f
C1879 a_5197_16869# a_4763_16869# 0.6972f
C1880 a_18585_16071# a_18795_16071# 0.09424f
C1881 a_26043_16869# a_26151_17497# 0.01697f
C1882 a_9193_14024# a_9323_14024# 0.70845f
C1883 a_4187_2434# a_27997_4687# 0.04001f
C1884 a_21917_7532# a_22113_7532# 0.76914f
C1885 a_15108_11799# a_14851_11918# 0.29858f
C1886 a_6283_7532# a_6391_7532# 0.01163f
C1887 a_12363_7532# a_12471_8160# 0.01697f
C1888 a_4187_2434# a_6717_1842# 0.0414f
C1889 a_12849_11557# a_13306_10795# 0.10976f
C1890 a_26477_7532# a_27048_6734# 0.10863f
C1891 a_26477_4687# a_27237_4687# 0.03319f
C1892 a_4248_3889# a_4324_3853# 0.01176f
C1893 a_9465_3889# a_9675_3889# 0.09424f
C1894 a_5197_1842# a_5957_1842# 0.03319f
C1895 a_10430_1044# a_10404_1008# 0.277f
C1896 a_9323_16869# VDD 0.49742f
C1897 a_20105_1044# a_19550_1044# 0.03209f
C1898 a_16408_16071# VDD 0.1824f
C1899 a_4350_6734# VDD 0.87635f
C1900 a_9953_1842# VDD 0.4958f
C1901 a_13231_5315# VDD 0.01806f
C1902 a_16484_1008# VDD 0.2893f
C1903 a_9757_14024# CHAN1_MUX_SEL4 0.01829f
C1904 a_1544_6734# REF_MUX_SEL4 0.03407f
C1905 a_2297_7085# REF_MUX_SEL0 0.10655f
C1906 a_1256_6734# REF_MUX_OUT 0.02199f
C1907 a_5731_3134# CHAN2_MUX_SEL4 4.60702f
C1908 CHAN1_MUX_SEL3 CHAN1_MUX_OUT 0.79533f
C1909 VDD CHAN2_MUX_SEL2 0.692f
C1910 a_4187_2434# a_18877_14024# 0.0414f
C1911 a_21917_16869# a_22677_16869# 0.06198f
C1912 a_26477_16869# a_27048_16071# 0.10863f
C1913 a_6283_16869# a_6391_16869# 0.01163f
C1914 a_19203_14024# a_19311_14652# 0.01697f
C1915 a_26477_14024# a_26673_14024# 0.76914f
C1916 a_13123_14024# a_13231_14024# 0.01163f
C1917 a_4248_13226# a_4350_13226# 0.37183f
C1918 a_4187_2434# a_9323_4687# 0.06627f
C1919 a_12797_7532# a_13557_7532# 0.06198f
C1920 a_19550_6734# a_21911_6698# 0.26208f
C1921 a_27563_1842# a_25630_1044# 0.01024f
C1922 a_22113_1842# a_22677_1842# 0.0114f
C1923 a_5731_289# a_14825_519# 0.28056f
C1924 a_2019_311# a_16851_309# 0.01299f
C1925 a_22113_14024# VDD 0.49655f
C1926 a_23111_8160# VDD 0.01806f
C1927 a_21044_3853# VDD 0.28225f
C1928 a_13557_4687# VDD 0.871f
C1929 a_1256_13226# CHAN1_MUX_SEL0 0.3314f
C1930 a_9444_9602# DLL_RESETN 0.02808f
C1931 a_4187_2434# a_22113_16869# 0.11222f
C1932 a_12797_16869# a_13123_16869# 0.01427f
C1933 a_19550_16071# a_21835_16071# 0.39036f
C1934 a_17357_14024# a_18117_14024# 0.02973f
C1935 a_4187_2434# a_12993_7532# 0.11222f
C1936 a_25630_13226# a_27991_13190# 0.26208f
C1937 a_4187_2434# a_22677_1842# 0.0414f
C1938 a_17065_6734# a_16510_6734# 0.03209f
C1939 a_8433_4687# a_8997_4687# 0.0114f
C1940 a_25283_4687# a_25391_4687# 0.01163f
C1941 a_11277_4687# a_11848_3889# 0.10863f
C1942 a_14888_3889# a_14964_3853# 0.01176f
C1943 a_12993_1842# a_13123_1842# 0.70845f
C1944 a_10430_1044# a_5731_289# 0.41176f
C1945 a_25283_16869# VDD 0.48141f
C1946 a_4437_14024# VDD 0.87156f
C1947 a_8884_13190# VDD 0.28358f
C1948 a_25630_6734# VDD 0.90165f
C1949 a_16163_7532# VDD 0.94804f
C1950 a_25913_1842# VDD 0.49559f
C1951 a_3449_4240# VDD 0.46731f
C1952 a_4187_2434# a_4437_16869# 0.04193f
C1953 a_24523_16869# a_24631_17497# 0.01697f
C1954 a_7390_16071# a_9751_16035# 0.26208f
C1955 a_12037_14024# a_10430_13226# 0.05231f
C1956 a_11277_14024# a_11271_13190# 0.02349f
C1957 a_8237_14024# a_8563_14024# 0.01427f
C1958 a_4187_2434# a_25283_4687# 0.06391f
C1959 a_26185_13226# a_26471_13190# 0.01885f
C1960 a_6326_10280# a_5864_9057# 0.01889f
C1961 a_10843_7532# a_10951_8160# 0.01697f
C1962 a_5974_11413# a_9712_9602# 0.01152f
C1963 a_4187_2434# a_4003_1842# 0.05992f
C1964 a_13121_11521# a_15304_10295# 0.40921f
C1965 a_4763_7532# a_4871_7532# 0.01163f
C1966 a_20593_7532# a_20723_7532# 0.70845f
C1967 a_6126_9506# a_5778_9057# 1.6143f
C1968 a_14009_11568# a_14111_11568# 0.47795f
C1969 a_25630_6734# a_26985_6209# 0.02195f
C1970 a_25717_4687# a_25283_4687# 0.69698f
C1971 a_4437_1842# a_4003_1842# 0.69698f
C1972 a_5731_3134# a_8433_1842# 0.01746f
C1973 a_17065_1044# a_17351_1008# 0.01885f
C1974 a_7673_16869# VDD 0.49303f
C1975 a_13470_16071# VDD 0.88092f
C1976 a_13132_11110# VDD 0.23866f
C1977 a_20105_6734# VDD 0.30409f
C1978 a_7151_5315# VDD 0.01806f
C1979 a_8237_1842# VDD 0.8735f
C1980 a_14235_1044# VDD 0.1539f
C1981 a_13470_13226# CHAN1_MUX_SEL4 0.256f
C1982 a_2297_3176# CHAN2_MUX_SEL4 0.04338f
C1983 a_2873_3176# CHAN2_MUX_SEL3 0.12606f
C1984 a_3449_3176# CHAN2_MUX_SEL2 0.10741f
C1985 VDD REF_MUX_SEL2 0.692f
C1986 a_21157_16869# a_20723_16869# 0.6972f
C1987 a_4763_16869# a_4871_16869# 0.01163f
C1988 a_4187_2434# a_16163_14024# 0.06315f
C1989 a_11603_14024# a_11711_14024# 0.01163f
C1990 a_25153_14024# a_25283_14024# 0.70361f
C1991 a_4187_2434# a_25630_13226# 0.01522f
C1992 a_5705_15546# a_5731_15316# 0.28954f
C1993 a_17683_14024# a_17791_14652# 0.01697f
C1994 a_4187_2434# a_7673_4687# 0.11222f
C1995 a_12037_7532# a_11603_7532# 0.6972f
C1996 a_19448_6734# a_19550_6734# 0.37183f
C1997 a_20397_4687# a_20968_3889# 0.10863f
C1998 a_16597_4687# a_16793_4687# 0.73897f
C1999 a_25528_3889# a_25604_3853# 0.01176f
C2000 a_21157_1842# a_21917_1842# 0.02912f
C2001 a_18877_1842# a_16108_289# 0.0157f
C2002 a_20397_14024# VDD 0.87175f
C2003 a_5705_12701# VDD 0.29556f
C2004 a_17031_8160# VDD 0.01806f
C2005 a_10843_4687# VDD 0.50058f
C2006 a_18795_3889# VDD 0.15407f
C2007 a_4187_2434# a_20397_16869# 0.04141f
C2008 a_12037_16869# a_12233_16869# 0.77122f
C2009 a_16597_14024# a_16163_14024# 0.69698f
C2010 a_4187_2434# a_11277_7532# 0.04141f
C2011 a_20397_14024# a_20391_13190# 0.02349f
C2012 a_21157_14024# a_19550_13226# 0.05231f
C2013 a_25528_13226# a_25630_13226# 0.37183f
C2014 a_4763_7532# a_4350_6734# 0.01012f
C2015 a_4187_2434# a_19963_1842# 0.06627f
C2016 a_7288_6734# a_7364_6698# 0.01176f
C2017 a_7477_4687# a_8237_4687# 0.01669f
C2018 a_5731_5979# a_14643_4687# 0.01544f
C2019 a_14025_6734# a_14311_6698# 0.01885f
C2020 a_23763_4687# a_23871_4687# 0.01163f
C2021 a_13470_3889# a_13444_3853# 0.277f
C2022 a_16108_3134# a_21483_1842# 0.01542f
C2023 a_24665_3889# a_24875_3889# 0.09424f
C2024 a_7390_1044# a_8745_519# 0.01627f
C2025 a_19550_1044# a_20315_1044# 0.39037f
C2026 a_15765_15490# VDD 0.36528f
C2027 a_23633_16869# VDD 0.49454f
C2028 a_6635_13226# VDD 0.15407f
C2029 a_14513_7532# VDD 0.49438f
C2030 a_22564_6698# VDD 0.28633f
C2031 a_24197_1842# VDD 0.93774f
C2032 a_16108_289# VDD 1.25176f
C2033 a_15765_12645# CHAN1_MUX_SEL4 0.65508f
C2034 CHAN3_MUX_SEL1 CHAN3_MUX_OUT 0.05651f
C2035 CHAN3_MUX_SEL2 CHAN3_MUX_SEL4 0.01978f
C2036 a_23003_16869# a_23111_17497# 0.01697f
C2037 a_4763_16869# a_4350_16071# 0.01012f
C2038 a_7288_16071# a_7390_16071# 0.37183f
C2039 a_14025_16071# a_14235_16071# 0.09424f
C2040 a_7477_14024# a_7673_14024# 0.73897f
C2041 a_9757_14024# a_10404_13190# 0.02011f
C2042 a_5731_15316# a_15077_14024# 0.01319f
C2043 a_13368_13226# a_13444_13190# 0.01176f
C2044 a_4187_2434# a_23633_4687# 0.11222f
C2045 a_13566_11525# a_13592_11561# 0.36952f
C2046 a_9323_7532# a_9431_8160# 0.01697f
C2047 a_4905_3889# a_5191_3853# 0.01885f
C2048 a_24393_4687# a_24957_4687# 0.0114f
C2049 a_5731_3134# a_6717_1842# 0.01307f
C2050 a_16108_3134# a_26985_3364# 0.27952f
C2051 a_5197_1842# a_5768_1044# 0.10863f
C2052 a_7390_1044# a_8231_1008# 0.28268f
C2053 a_5957_16869# VDD 0.85889f
C2054 a_10404_16035# VDD 0.28633f
C2055 a_27671_14652# VDD 0.01806f
C2056 a_26803_4687# VDD 0.49718f
C2057 a_7945_6734# VDD 0.30409f
C2058 a_5523_1842# VDD 0.49684f
C2059 a_11271_1008# VDD 0.28336f
C2060 a_4157_1313# CHAN3_DELAY_IN 0.50642f
C2061 CHAN0_MUX_SEL2 CHAN1_DELAY_IN 0.1765f
C2062 CHAN0_MUX_SEL3 CHAN0_MUX_OUT 0.79533f
C2063 a_19833_16869# a_20397_16869# 0.0114f
C2064 a_4187_2434# a_14513_14024# 0.11222f
C2065 a_4187_2434# a_5957_4687# 0.04152f
C2066 a_4187_2434# a_27237_7532# 0.0629f
C2067 a_4905_13226# a_5115_13226# 0.09424f
C2068 a_16163_14024# a_16271_14652# 0.01697f
C2069 a_10083_14024# a_10191_14024# 0.01163f
C2070 a_16108_12471# a_23945_12701# 0.2906f
C2071 a_13883_7532# a_13470_6734# 0.01012f
C2072 a_10713_7532# a_11277_7532# 0.0114f
C2073 a_17928_6734# a_18004_6698# 0.01176f
C2074 a_15273_4687# a_15403_4687# 0.70845f
C2075 a_20397_1842# a_19963_1842# 0.6972f
C2076 a_17683_14024# VDD 0.48149f
C2077 a_25630_1044# a_16108_289# 0.52614f
C2078 a_5705_519# a_2019_311# 0.13872f
C2079 a_10951_8160# VDD 0.01806f
C2080 a_27915_13226# VDD 0.15389f
C2081 a_9193_4687# VDD 0.49584f
C2082 a_15831_3853# VDD 0.2816f
C2083 a_13306_10795# REF_CLK 0.06166f
C2084 REF_CLK REF_MUX_SEL4 0.0663f
C2085 a_13883_16869# a_13470_16071# 0.01012f
C2086 a_10713_16869# a_10843_16869# 0.70845f
C2087 a_4187_2434# a_17683_16869# 0.06492f
C2088 a_4187_2434# a_8563_7532# 0.0635f
C2089 a_15273_14024# a_15837_14024# 0.0114f
C2090 a_18877_14024# a_19524_13190# 0.02011f
C2091 a_9444_10280# a_9444_9602# 2.19249f
C2092 a_4187_2434# a_18313_1842# 0.11222f
C2093 a_24008_13226# a_24084_13190# 0.01176f
C2094 a_15108_11015# a_15464_9374# 0.12158f
C2095 a_27997_7532# a_27563_7532# 0.69646f
C2096 a_7477_7532# a_7945_6734# 0.19203f
C2097 a_5731_5979# a_12993_4687# 0.01872f
C2098 a_6717_4687# a_6283_4687# 0.6972f
C2099 a_22243_4687# a_22351_4687# 0.01163f
C2100 a_11277_1842# a_11473_1842# 0.76914f
C2101 a_16108_3134# a_19833_1842# 0.01865f
C2102 a_21917_16869# VDD 0.87825f
C2103 a_14317_1842# a_14888_1044# 0.10863f
C2104 a_5731_15316# VDD 0.98849f
C2105 a_12797_7532# VDD 0.87771f
C2106 a_20315_6734# VDD 0.15389f
C2107 a_21483_1842# VDD 0.50001f
C2108 a_2297_16422# CHAN0_MUX_SEL0 0.10655f
C2109 a_1544_16071# CHAN0_MUX_SEL4 0.03407f
C2110 a_1256_16071# CHAN0_MUX_OUT 0.02199f
C2111 a_5731_12471# CHAN1_MUX_SEL4 4.60702f
C2112 CHAN3_DELAY_IN CHAN3_MUX_SEL0 0.10102f
C2113 a_21483_16869# a_21591_17497# 0.01697f
C2114 a_7477_16869# a_7945_16071# 0.19203f
C2115 a_6153_14024# a_6283_14024# 0.70845f
C2116 a_5731_15316# a_12363_14024# 0.01542f
C2117 a_5768_16071# a_5844_16035# 0.01176f
C2118 a_8997_14024# a_8884_13190# 0.02055f
C2119 a_4187_2434# a_21917_4687# 0.0414f
C2120 a_12849_11557# a_13306_11995# 0.12097f
C2121 a_6854_11676# a_13592_11113# 0.01958f
C2122 a_7803_7532# a_7911_8160# 0.01697f
C2123 a_23003_7532# a_22590_6734# 0.01012f
C2124 a_1544_6734# a_1721_7085# 0.38063f
C2125 a_18877_7532# a_19073_7532# 0.76914f
C2126 a_1256_5979# a_1721_6021# 0.13421f
C2127 a_23437_4687# a_24197_4687# 0.03319f
C2128 a_15765_3308# a_15964_3134# 0.061f
C2129 a_6635_1044# a_6711_1008# 0.01194f
C2130 a_8155_16071# VDD 0.15389f
C2131 a_21591_14652# VDD 0.01806f
C2132 a_2873_7085# VDD 0.46517f
C2133 a_25153_4687# VDD 0.49638f
C2134 a_26985_3364# VDD 0.29292f
C2135 a_8808_1044# VDD 0.17577f
C2136 a_1721_1395# CHAN3_MUX_SEL0 0.01315f
C2137 a_1544_1044# CHAN3_MUX_SEL1 0.1672f
C2138 a_23003_16869# a_22590_16071# 0.01012f
C2139 a_18877_16869# a_19637_16869# 0.06198f
C2140 a_1256_16071# a_1721_16422# 0.13421f
C2141 a_4187_2434# a_12797_14024# 0.0414f
C2142 a_1256_15316# a_1544_15316# 1.25711f
C2143 a_4187_2434# a_24523_7532# 0.06522f
C2144 a_23437_14024# a_23633_14024# 0.76914f
C2145 a_14643_14024# a_14751_14652# 0.01697f
C2146 a_8563_14024# a_8671_14024# 0.01163f
C2147 a_9757_7532# a_10517_7532# 0.05851f
C2148 a_5731_12471# a_6326_10280# 0.11352f
C2149 a_12797_7532# a_13368_6734# 0.10864f
C2150 a_21157_7532# a_21625_6734# 0.2079f
C2151 a_14317_4687# a_14643_4687# 0.01427f
C2152 a_16108_5979# a_26043_4687# 0.01539f
C2153 a_16510_6734# a_16484_6698# 0.277f
C2154 a_22590_3889# a_23355_3889# 0.39037f
C2155 a_19073_1842# a_19637_1842# 0.0114f
C2156 a_1544_1044# a_2297_1395# 0.28651f
C2157 a_23437_1842# a_24008_1044# 0.10863f
C2158 a_16033_14024# VDD 0.54891f
C2159 a_24951_13190# VDD 0.2822f
C2160 a_4871_8160# VDD 0.01806f
C2161 a_13368_3889# VDD 0.17274f
C2162 a_7477_4687# VDD 0.87107f
C2163 a_15304_10295# DLL_RESETN 0.03137f
C2164 a_4187_2434# a_16033_16869# 0.11169f
C2165 a_21157_16869# a_21625_16071# 0.2079f
C2166 a_12797_16869# a_13368_16071# 0.10864f
C2167 a_16408_16071# a_16484_16035# 0.01176f
C2168 a_16108_15316# a_26477_14024# 0.01319f
C2169 a_14317_14024# a_15077_14024# 0.03319f
C2170 a_4187_2434# a_6913_7532# 0.11222f
C2171 a_18117_14024# a_18004_13190# 0.02055f
C2172 a_13592_11113# a_14757_10872# 0.43239f
C2173 a_13470_13226# a_5731_12471# 0.41365f
C2174 a_14111_10917# a_13880_10808# 0.12701f
C2175 a_22590_13226# a_22564_13190# 0.277f
C2176 a_4187_2434# a_16597_1842# 0.03917f
C2177 a_26673_7532# a_27237_7532# 0.0114f
C2178 a_5957_7532# a_6425_6734# 0.2079f
C2179 a_4350_6734# a_5115_6734# 0.39037f
C2180 a_5731_5979# a_11277_4687# 0.01319f
C2181 a_5393_4687# a_5957_4687# 0.0114f
C2182 a_20105_3889# a_20315_3889# 0.09424f
C2183 a_26803_4687# a_26911_5315# 0.01697f
C2184 a_10430_3889# a_11271_3853# 0.28268f
C2185 a_20723_4687# a_20831_4687# 0.01163f
C2186 a_7803_4687# a_7390_3889# 0.01012f
C2187 a_16108_3134# a_18117_1842# 0.01644f
C2188 a_9953_1842# a_10083_1842# 0.70361f
C2189 a_16510_1044# a_17928_1044# 0.38994f
C2190 a_19203_16869# VDD 0.49737f
C2191 a_17065_13226# VDD 0.30218f
C2192 a_2297_15358# VDD 0.46603f
C2193 a_17351_6698# VDD 0.28637f
C2194 a_10083_7532# VDD 0.482f
C2195 a_3449_331# VDD 0.46596f
C2196 a_19833_1842# VDD 0.49553f
C2197 a_2873_12513# CHAN1_MUX_SEL3 0.12606f
C2198 a_2297_12513# CHAN1_MUX_SEL4 0.04338f
C2199 a_3449_12513# CHAN1_MUX_SEL2 0.10741f
C2200 CHAN2_MUX_SEL1 CHAN2_MUX_OUT 0.05651f
C2201 CHAN2_MUX_SEL2 CHAN2_MUX_SEL4 0.01978f
C2202 a_4350_16071# a_4324_16035# 0.277f
C2203 a_26673_16869# a_26803_16869# 0.70845f
C2204 a_9465_16071# a_9751_16035# 0.01885f
C2205 a_5957_16869# a_6425_16071# 0.2079f
C2206 a_19963_16869# a_20071_17497# 0.01697f
C2207 a_5731_15316# a_10713_14024# 0.01865f
C2208 a_5197_14024# a_5523_14024# 0.01427f
C2209 a_8237_14024# a_7390_13226# 0.08038f
C2210 a_13557_14024# a_14025_13226# 0.19203f
C2211 a_21625_13226# a_19550_13226# 0.03208f
C2212 a_10430_13226# a_11195_13226# 0.39037f
C2213 a_4187_2434# a_19203_4687# 0.06627f
C2214 a_12355_11557# a_12656_11554# 0.03277f
C2215 a_6283_7532# a_6391_8160# 0.01697f
C2216 a_17553_7532# a_17683_7532# 0.70361f
C2217 a_6854_11676# a_15304_10295# 0.08165f
C2218 a_21917_7532# a_22488_6734# 0.10864f
C2219 a_22677_4687# a_22243_4687# 0.69698f
C2220 a_5731_3134# a_15964_3134# 0.2778f
C2221 a_27237_1842# a_27433_1842# 0.77122f
C2222 a_12505_1044# a_10430_1044# 0.03208f
C2223 a_4350_1044# a_5844_1008# 0.28279f
C2224 a_5191_16035# VDD 0.28637f
C2225 a_5115_1044# a_5191_1008# 0.01194f
C2226 a_15511_14652# VDD 0.01806f
C2227 a_13121_11521# VDD 0.99842f
C2228 a_1256_6734# VDD 0.48292f
C2229 a_23437_4687# VDD 0.87201f
C2230 a_14825_3364# VDD 0.29292f
C2231 a_5844_1008# VDD 0.28225f
C2232 a_18117_16869# a_17683_16869# 0.6972f
C2233 a_21917_16869# a_22488_16071# 0.10864f
C2234 a_4187_2434# a_10083_14024# 0.06492f
C2235 a_13123_14024# a_13231_14652# 0.01697f
C2236 a_4187_2434# a_22873_7532# 0.11284f
C2237 a_22113_14024# a_22243_14024# 0.70845f
C2238 a_27048_16071# a_27124_16035# 0.01176f
C2239 a_7043_14024# a_7151_14024# 0.01163f
C2240 a_27237_14024# a_27124_13190# 0.02055f
C2241 a_8997_7532# a_8563_7532# 0.6972f
C2242 a_5731_12471# a_15765_12645# 0.23301f
C2243 a_12797_7532# a_10430_6734# 0.02479f
C2244 a_13557_4687# a_13753_4687# 0.73897f
C2245 a_16923_4687# a_16510_3889# 0.01012f
C2246 a_18117_1842# a_18877_1842# 0.02912f
C2247 a_26151_17497# VDD 0.01806f
C2248 a_27915_1044# a_27991_1008# 0.01194f
C2249 a_22488_13226# VDD 0.17274f
C2250 a_14317_14024# VDD 0.87175f
C2251 a_4763_4687# VDD 0.49875f
C2252 a_26043_7532# VDD 0.49732f
C2253 a_10430_3889# VDD 0.88416f
C2254 a_26911_2470# VDD 0.01806f
C2255 a_1544_5979# REF_MUX_SEL3 0.15976f
C2256 a_1256_5979# REF_MUX_SEL4 0.65005f
C2257 a_1721_6021# REF_MUX_SEL2 0.01315f
C2258 a_15964_289# CHAN3_MUX_OUT 0.01307f
C2259 a_16108_289# CHAN3_MUX_SEL4 0.1283f
C2260 a_8997_16869# a_9193_16869# 0.77122f
C2261 a_4187_2434# a_14317_16869# 0.04141f
C2262 a_12797_16869# a_10430_16071# 0.02479f
C2263 a_16108_15316# a_23763_14024# 0.01371f
C2264 a_4187_2434# a_5197_7532# 0.04141f
C2265 a_13557_14024# a_13123_14024# 0.69698f
C2266 a_27237_14024# a_27705_13226# 0.2079f
C2267 a_17357_14024# a_16510_13226# 0.08038f
C2268 a_15304_10295# a_14757_10872# 0.02225f
C2269 a_4437_7532# a_4157_7003# 0.01771f
C2270 a_4187_2434# a_13883_1842# 0.06627f
C2271 a_25717_7532# a_26477_7532# 0.01669f
C2272 a_9465_6734# a_7390_6734# 0.03208f
C2273 a_4437_4687# a_5197_4687# 0.01669f
C2274 a_25283_4687# a_25391_5315# 0.01697f
C2275 a_6717_4687# a_7288_3889# 0.10864f
C2276 a_19203_4687# a_19311_4687# 0.01163f
C2277 a_12037_4687# a_12505_3889# 0.2079f
C2278 a_9675_3889# a_9751_3853# 0.01194f
C2279 a_26471_16035# VDD 0.28357f
C2280 a_17553_16869# VDD 0.49346f
C2281 a_6425_13226# VDD 0.2975f
C2282 a_14888_6734# VDD 0.17499f
C2283 a_8433_7532# VDD 0.55212f
C2284 a_18117_1842# VDD 0.85958f
C2285 a_27124_1008# VDD 0.28225f
C2286 a_4350_6734# REF_MUX_SEL4 0.31434f
C2287 CHAN2_DELAY_IN CHAN2_MUX_SEL0 0.10102f
C2288 a_4437_16869# a_4157_16340# 0.01771f
C2289 a_18443_16869# a_18551_17497# 0.01697f
C2290 a_4187_2434# a_26043_14024# 0.06627f
C2291 a_7945_16071# a_7390_16071# 0.03209f
C2292 a_4437_14024# a_4633_14024# 0.73897f
C2293 a_6717_14024# a_6711_13190# 0.02354f
C2294 a_4187_2434# a_17553_4687# 0.11169f
C2295 a_4763_7532# a_4871_8160# 0.01697f
C2296 a_25630_6734# a_26395_6734# 0.39037f
C2297 a_21917_7532# a_19550_6734# 0.02479f
C2298 a_16510_6734# a_16108_5979# 0.56108f
C2299 a_21353_4687# a_21917_4687# 0.0114f
C2300 a_5731_3134# a_8745_3364# 0.28635f
C2301 a_26043_4687# a_25630_3889# 0.01012f
C2302 a_25913_1842# a_26043_1842# 0.70845f
C2303 a_24665_16071# VDD 0.29722f
C2304 a_9431_14652# VDD 0.01806f
C2305 a_11491_11918# VDD 0.16908f
C2306 a_20723_4687# VDD 0.49684f
C2307 a_27705_1044# VDD 0.29918f
C2308 a_16793_16869# a_17357_16869# 0.0114f
C2309 a_21917_16869# a_19550_16071# 0.02479f
C2310 a_25630_16071# a_25604_16035# 0.277f
C2311 a_4187_2434# a_8433_14024# 0.11169f
C2312 a_5523_14024# a_5631_14024# 0.01163f
C2313 a_4187_2434# a_21157_7532# 0.04188f
C2314 a_11603_14024# a_11711_14652# 0.01697f
C2315 a_26477_14024# a_25630_13226# 0.08038f
C2316 a_7673_7532# a_8237_7532# 0.0114f
C2317 a_13470_6734# a_14311_6698# 0.28268f
C2318 a_10517_7532# a_10404_6698# 0.05157f
C2319 a_16108_5979# a_22677_4687# 0.01314f
C2320 a_12233_4687# a_12363_4687# 0.70845f
C2321 a_15837_4687# a_16408_3889# 0.10864f
C2322 a_25717_4687# a_26185_3889# 0.19203f
C2323 a_19550_3889# a_20968_3889# 0.38994f
C2324 a_17357_1842# a_16923_1842# 0.6972f
C2325 a_25630_1044# a_27124_1008# 0.28279f
C2326 a_11603_14024# VDD 0.49684f
C2327 a_26395_1044# a_26471_1008# 0.01194f
C2328 a_20071_17497# VDD 0.01806f
C2329 a_19550_13226# VDD 0.89766f
C2330 a_24393_7532# VDD 0.71684f
C2331 a_17865_6209# VDD 0.29444f
C2332 a_7364_3853# VDD 0.28633f
C2333 a_20831_2470# VDD 0.01806f
C2334 a_13306_11995# REF_CLK 0.05059f
C2335 a_4187_2434# a_11603_16869# 0.06627f
C2336 a_7673_16869# a_7803_16869# 0.70845f
C2337 a_13470_16071# a_14235_16071# 0.39037f
C2338 a_10517_16869# a_10404_16035# 0.05157f
C2339 a_24665_16071# a_24951_16035# 0.01885f
C2340 a_15837_14024# a_15831_13190# 0.02354f
C2341 a_16108_15316# a_22113_14024# 0.01872f
C2342 a_12233_14024# a_12797_14024# 0.0114f
C2343 a_19550_13226# a_20391_13190# 0.28268f
C2344 a_13132_11110# a_13306_10795# 0.27179f
C2345 a_4187_2434# a_12233_1842# 0.11222f
C2346 a_24957_7532# a_24523_7532# 0.6972f
C2347 a_5731_5979# a_6913_4687# 0.01872f
C2348 a_17683_4687# a_17791_4687# 0.01163f
C2349 a_6717_4687# a_4350_3889# 0.02479f
C2350 a_23763_4687# a_23871_5315# 0.01697f
C2351 a_8237_1842# a_8433_1842# 0.76914f
C2352 a_8155_3889# a_8231_3853# 0.01194f
C2353 a_15545_3889# a_15831_3853# 0.01885f
C2354 a_7390_3889# a_8884_3853# 0.28279f
C2355 a_27705_1044# a_25630_1044# 0.03208f
C2356 a_13470_1044# a_15755_1044# 0.39036f
C2357 a_10843_1842# a_10430_1044# 0.01012f
C2358 a_15837_16869# VDD 0.88209f
C2359 a_24008_16071# VDD 0.17499f
C2360 a_6717_7532# VDD 0.87726f
C2361 a_11924_6698# VDD 0.28225f
C2362 a_15403_1842# VDD 0.49799f
C2363 a_24875_1044# VDD 0.15407f
C2364 a_14111_10917# REF_DELAY_OUT_LAST 0.02024f
C2365 REF_MUX_SEL2 REF_MUX_SEL4 0.01978f
C2366 REF_MUX_SEL1 REF_MUX_OUT 0.05651f
C2367 a_24957_16869# a_25153_16869# 0.74845f
C2368 a_16923_16869# a_17031_17497# 0.01697f
C2369 a_4187_2434# a_24393_14024# 0.11005f
C2370 a_5731_15316# a_6283_14024# 0.01542f
C2371 a_5197_14024# a_5844_13190# 0.02312f
C2372 a_15545_13226# a_15755_13226# 0.09424f
C2373 a_4187_2434# a_15837_4687# 0.0414f
C2374 a_10520_11982# a_10751_11568# 0.12701f
C2375 a_7390_13226# a_8808_13226# 0.38994f
C2376 a_15837_7532# a_16033_7532# 0.76914f
C2377 a_19637_7532# a_19524_6698# 0.05157f
C2378 a_24957_4687# a_25528_3889# 0.10864f
C2379 a_20397_4687# a_21157_4687# 0.03319f
C2380 a_6425_1044# a_6711_1008# 0.01885f
C2381 a_27563_14024# VDD 0.50391f
C2382 a_12505_16071# VDD 0.29722f
C2383 a_19073_4687# VDD 0.49655f
C2384 a_15545_1044# VDD 0.29918f
C2385 a_1721_3176# VDD 0.45365f
C2386 a_4187_2434# a_27563_16869# 0.06629f
C2387 a_15837_16869# a_16597_16869# 0.06198f
C2388 a_19637_16869# a_19524_16035# 0.05157f
C2389 a_4187_2434# a_6717_14024# 0.0414f
C2390 a_10083_14024# a_10191_14652# 0.01697f
C2391 a_4003_14024# a_4111_14024# 0.01163f
C2392 a_4187_2434# a_18443_7532# 0.06661f
C2393 a_24957_14024# a_24951_13190# 0.02354f
C2394 a_20397_14024# a_20593_14024# 0.76914f
C2395 a_6717_7532# a_7477_7532# 0.06198f
C2396 a_24665_6734# a_22590_6734# 0.03208f
C2397 a_12715_6734# a_12791_6698# 0.01194f
C2398 a_16108_5979# a_19963_4687# 0.01539f
C2399 a_11277_4687# a_11603_4687# 0.01427f
C2400 a_15837_4687# a_13470_3889# 0.02479f
C2401 a_16033_1842# a_16597_1842# 0.0114f
C2402 a_19963_1842# a_19550_1044# 0.01012f
C2403 a_9953_14024# VDD 0.4958f
C2404 a_13991_17497# VDD 0.01806f
C2405 a_22677_7532# VDD 0.86715f
C2406 a_16484_13190# VDD 0.2893f
C2407 a_4003_16869# CHAN0_DELAY_IN 0.54998f
C2408 a_5115_3889# VDD 0.15389f
C2409 a_14751_2470# VDD 0.01806f
C2410 a_3449_331# CHAN3_MUX_SEL4 0.05166f
C2411 VDD DLL_RESETN 2.60135f
C2412 a_6717_16869# a_7043_16869# 0.01427f
C2413 a_4187_2434# a_9953_16869# 0.11076f
C2414 a_23145_16071# a_22590_16071# 0.03209f
C2415 a_16108_15316# a_20397_14024# 0.01319f
C2416 a_11277_14024# a_12037_14024# 0.03319f
C2417 a_14317_14024# a_14964_13190# 0.02312f
C2418 a_4187_2434# a_10517_1842# 0.0414f
C2419 a_18795_13226# a_18871_13190# 0.01194f
C2420 a_23633_7532# a_24197_7532# 0.0114f
C2421 a_15964_5979# a_16108_5979# 0.42202f
C2422 a_16163_4687# a_16271_4687# 0.01163f
C2423 a_4437_4687# a_4324_3853# 0.05157f
C2424 a_14025_3889# a_13470_3889# 0.03209f
C2425 a_22243_4687# a_22351_5315# 0.01697f
C2426 a_6913_1842# a_7043_1842# 0.70845f
C2427 a_5731_3134# a_13883_1842# 0.01539f
C2428 a_9757_1842# a_10328_1044# 0.10864f
C2429 a_16597_1842# a_17065_1044# 0.19203f
C2430 a_13123_16869# VDD 0.49727f
C2431 a_21044_16035# VDD 0.28225f
C2432 a_4003_7532# VDD 0.61559f
C2433 a_24631_5315# VDD 0.02023f
C2434 a_9675_6734# VDD 0.15406f
C2435 a_21911_1008# VDD 0.2822f
C2436 a_13753_1842# VDD 0.49553f
C2437 a_23633_16869# a_23763_16869# 0.70845f
C2438 a_15403_16869# a_15511_17497# 0.01697f
C2439 a_4187_2434# a_22677_14024# 0.0414f
C2440 a_15765_15490# a_16108_15316# 0.42004f
C2441 a_4187_2434# a_13123_4687# 0.06627f
C2442 a_4437_14024# a_4350_13226# 0.1088f
C2443 a_10206_11525# a_10232_11561# 0.36952f
C2444 a_14513_7532# a_14643_7532# 0.70845f
C2445 a_19637_4687# a_19203_4687# 0.69698f
C2446 a_22590_6734# a_24008_6734# 0.38994f
C2447 a_24957_4687# a_22590_3889# 0.02479f
C2448 a_1256_3889# a_2873_4240# 0.28892f
C2449 a_24197_1842# a_24393_1842# 0.77122f
C2450 a_4157_1313# a_4324_1008# 0.02463f
C2451 a_4905_1044# a_4350_1044# 0.03209f
C2452 a_3449_16422# VDD 0.46731f
C2453 a_16108_289# a_17865_519# 0.29564f
C2454 a_25913_14024# VDD 0.49559f
C2455 a_6854_11676# VDD 1.32214f
C2456 a_17357_4687# VDD 0.8703f
C2457 a_26395_3889# VDD 0.1539f
C2458 a_4905_1044# VDD 0.30126f
C2459 a_1256_15316# CHAN0_MUX_SEL4 0.65005f
C2460 a_1544_15316# CHAN0_MUX_SEL3 0.15976f
C2461 a_1721_15358# CHAN0_MUX_SEL2 0.01315f
C2462 a_4187_2434# a_25913_16869# 0.11222f
C2463 a_4187_2434# a_4003_14024# 0.05992f
C2464 a_15077_16869# a_14643_16869# 0.6972f
C2465 a_22590_16071# a_23431_16035# 0.28268f
C2466 a_19073_14024# a_19203_14024# 0.70845f
C2467 a_4187_2434# a_16793_7532# 0.11164f
C2468 a_23437_14024# a_24084_13190# 0.02312f
C2469 a_8563_14024# a_8671_14652# 0.01697f
C2470 a_5957_7532# a_5523_7532# 0.6972f
C2471 a_4187_2434# a_26477_1842# 0.04144f
C2472 a_8237_7532# a_8231_6698# 0.02349f
C2473 a_8997_7532# a_7390_6734# 0.05231f
C2474 a_11195_6734# a_11271_6698# 0.01194f
C2475 a_10517_4687# a_10713_4687# 0.73897f
C2476 a_16108_5979# a_18313_4687# 0.02026f
C2477 a_10430_6734# a_11924_6698# 0.28279f
C2478 a_13557_4687# a_13444_3853# 0.05157f
C2479 a_16510_3889# a_18795_3889# 0.39036f
C2480 a_15077_1842# a_15837_1842# 0.02912f
C2481 a_22590_1044# a_24951_1008# 0.26208f
C2482 a_7911_17497# VDD 0.01806f
C2483 a_18877_1842# a_19448_1044# 0.10864f
C2484 a_8237_14024# VDD 0.87355f
C2485 a_14235_13226# VDD 0.1539f
C2486 a_19963_7532# VDD 0.4973f
C2487 a_23145_3889# VDD 0.30411f
C2488 a_8671_2470# VDD 0.02372f
C2489 a_4350_16071# CHAN0_MUX_SEL4 0.31434f
C2490 a_10649_11568# DLL_RESETN 0.05713f
C2491 a_10232_11561# REF_CLK 0.08086f
C2492 a_12797_7532# REF_MUX_SEL4 0.01829f
C2493 VDD CHAN1_DELAY_IN 1.50497f
C2494 a_4187_2434# a_8237_16869# 0.04141f
C2495 a_5957_16869# a_6153_16869# 0.77122f
C2496 a_8997_16869# a_7390_16071# 0.05231f
C2497 a_8237_16869# a_8231_16035# 0.02349f
C2498 a_10517_14024# a_10083_14024# 0.69698f
C2499 a_20105_16071# a_20391_16035# 0.01885f
C2500 a_10430_16071# a_11848_16071# 0.38994f
C2501 a_4350_13226# a_5705_12701# 0.02005f
C2502 a_16510_13226# a_18004_13190# 0.28279f
C2503 a_13557_14024# a_13470_13226# 0.1088f
C2504 a_17275_13226# a_17351_13190# 0.01194f
C2505 a_12849_11557# a_14851_10872# 0.13376f
C2506 a_15688_11557# a_15304_10295# 0.19136f
C2507 a_4187_2434# a_7803_1842# 0.06627f
C2508 a_13121_11521# a_15108_11015# 0.05903f
C2509 a_13019_11521# a_15688_11093# 0.1287f
C2510 a_22677_7532# a_23437_7532# 0.01669f
C2511 a_21917_7532# a_16108_5979# 0.0157f
C2512 a_4350_3889# a_6711_3853# 0.26208f
C2513 a_20723_4687# a_20831_5315# 0.01697f
C2514 a_10985_3889# a_11271_3853# 0.01885f
C2515 a_14643_4687# a_14751_4687# 0.01163f
C2516 a_9757_1842# a_7390_1044# 0.02479f
C2517 a_5731_3134# a_12233_1842# 0.01872f
C2518 a_11473_16869# VDD 0.49417f
C2519 a_21625_1044# a_21835_1044# 0.09424f
C2520 a_18795_16071# VDD 0.15406f
C2521 a_6711_6698# VDD 0.2822f
C2522 a_18551_5315# VDD 0.01806f
C2523 a_19448_1044# VDD 0.17274f
C2524 a_12037_1842# VDD 0.85955f
C2525 a_3449_7085# REF_MUX_SEL1 0.29404f
C2526 a_14825_3364# CHAN2_MUX_SEL4 0.03307f
C2527 VDD CHAN3_MUX_SEL1 0.5478f
C2528 a_13883_16869# a_13991_17497# 0.01697f
C2529 a_21917_16869# a_16108_15316# 0.0157f
C2530 a_4187_2434# a_19963_14024# 0.06627f
C2531 a_5731_15316# a_16108_15316# 0.01334f
C2532 a_10985_13226# a_11195_13226# 0.09424f
C2533 a_4350_13226# a_6635_13226# 0.39036f
C2534 a_4187_2434# a_11473_4687# 0.11222f
C2535 a_9746_11495# a_9772_11533# 0.1657f
C2536 a_18117_7532# a_16510_6734# 0.05231f
C2537 a_17357_7532# a_17351_6698# 0.02349f
C2538 a_18313_4687# a_18877_4687# 0.0114f
C2539 a_22677_4687# a_22564_3853# 0.05157f
C2540 a_22873_1842# a_23003_1842# 0.70845f
C2541 a_24197_14024# VDD 0.93753f
C2542 a_16108_12471# VDD 1.25176f
C2543 a_23431_3853# VDD 0.28357f
C2544 a_14643_4687# VDD 0.4969f
C2545 a_2297_1395# VDD 0.46536f
C2546 a_10430_3889# CHAN2_MUX_SEL4 0.24983f
C2547 a_4187_2434# a_24197_16869# 0.03928f
C2548 a_13753_16869# a_14317_16869# 0.0114f
C2549 a_17357_16869# a_17351_16035# 0.02349f
C2550 a_18117_16869# a_16510_16071# 0.05231f
C2551 a_21835_16071# a_21911_16035# 0.01194f
C2552 a_7043_14024# a_7151_14652# 0.01697f
C2553 a_4187_2434# a_15077_7532# 0.04237f
C2554 a_22677_14024# a_22590_13226# 0.1088f
C2555 a_4633_7532# a_5197_7532# 0.0114f
C2556 a_19550_13226# a_20905_12701# 0.02165f
C2557 a_4187_2434# a_23763_1842# 0.06453f
C2558 a_6717_7532# a_7364_6698# 0.02011f
C2559 a_18585_6734# a_18795_6734# 0.09424f
C2560 a_9193_4687# a_9323_4687# 0.70845f
C2561 a_14317_1842# a_13883_1842# 0.6972f
C2562 a_18877_1842# a_16510_1044# 0.02479f
C2563 a_27433_16869# VDD 0.49285f
C2564 a_22488_1044# a_22590_1044# 0.37183f
C2565 a_11271_13190# VDD 0.28336f
C2566 a_5523_14024# VDD 0.49684f
C2567 a_18313_7532# VDD 0.49288f
C2568 a_27991_6698# VDD 0.28273f
C2569 a_10985_3889# VDD 0.30411f
C2570 a_27997_1842# VDD 0.76528f
C2571 VDD CHAN0_DELAY_IN 1.50763f
C2572 a_4187_2434# a_5523_16869# 0.06627f
C2573 a_4633_16869# a_4763_16869# 0.70845f
C2574 a_6717_16869# a_7364_16035# 0.02011f
C2575 a_16108_15316# a_16033_14024# 0.01197f
C2576 a_9193_14024# a_9757_14024# 0.0114f
C2577 a_4187_2434# a_27433_4687# 0.11222f
C2578 a_14111_11568# a_14851_11918# 0.26905f
C2579 a_4187_2434# a_6153_1842# 0.11222f
C2580 a_12849_11557# a_13566_11018# 0.26617f
C2581 a_21917_7532# a_21483_7532# 0.6972f
C2582 a_27237_7532# a_25630_6734# 0.05253f
C2583 a_26477_7532# a_26471_6698# 0.02349f
C2584 a_26477_4687# a_26673_4687# 0.76914f
C2585 a_13123_4687# a_13231_4687# 0.01163f
C2586 a_19203_4687# a_19311_5315# 0.01697f
C2587 a_5731_3134# a_10517_1842# 0.01314f
C2588 a_5197_1842# a_5393_1842# 0.76914f
C2589 a_4248_3889# a_4350_3889# 0.37183f
C2590 a_7477_1842# a_7364_1008# 0.05157f
C2591 a_9757_16869# VDD 0.87677f
C2592 a_15831_16035# VDD 0.2816f
C2593 a_10328_1044# a_10404_1008# 0.01176f
C2594 a_4248_6734# VDD 0.17587f
C2595 a_9444_10280# VDD 0.01458f
C2596 a_12471_5315# VDD 0.01806f
C2597 a_9323_1842# VDD 0.50013f
C2598 a_16510_1044# VDD 1.0321f
C2599 a_1256_6734# REF_MUX_SEL4 0.04785f
C2600 VDD CHAN2_MUX_SEL1 0.5478f
C2601 CHAN1_MUX_SEL3 CHAN1_MUX_SEL4 0.75489f
C2602 CHAN1_MUX_SEL2 CHAN1_MUX_OUT 0.08497f
C2603 a_21917_16869# a_22113_16869# 0.76914f
C2604 a_27237_16869# a_25630_16071# 0.05253f
C2605 a_12363_16869# a_12471_17497# 0.01697f
C2606 a_4187_2434# a_18313_14024# 0.11222f
C2607 a_26477_16869# a_26471_16035# 0.02349f
C2608 a_26477_14024# a_26043_14024# 0.6972f
C2609 a_4187_2434# a_9757_4687# 0.04038f
C2610 a_5731_12471# a_12355_11557# 0.01498f
C2611 a_6126_9506# a_6854_11144# 0.22577f
C2612 a_12797_7532# a_12993_7532# 0.76914f
C2613 a_19550_6734# a_21835_6734# 0.39036f
C2614 a_15837_7532# a_16484_6698# 0.02011f
C2615 a_17357_4687# a_18117_4687# 0.02973f
C2616 a_25630_3889# a_27991_3853# 0.26208f
C2617 a_21917_1842# a_22243_1842# 0.01427f
C2618 a_2019_311# a_16108_289# 0.33889f
C2619 a_5731_289# a_11785_519# 0.28056f
C2620 a_21483_14024# VDD 0.50001f
C2621 a_12993_4687# VDD 0.49655f
C2622 a_22351_8160# VDD 0.01806f
C2623 a_20968_3889# VDD 0.17499f
C2624 a_5778_9057# DLL_RESETN 0.01215f
C2625 a_27997_7532# REF_DELAY_OUT_LAST 0.70957f
C2626 a_4763_4687# REF_MUX_SEL4 0.01225f
C2627 a_12797_16869# a_13557_16869# 0.06198f
C2628 a_4187_2434# a_21483_16869# 0.06627f
C2629 a_15837_16869# a_16484_16035# 0.02011f
C2630 a_19550_16071# a_21044_16035# 0.28279f
C2631 a_20315_16071# a_20391_16035# 0.01194f
C2632 a_4187_2434# a_12363_7532# 0.06627f
C2633 a_17357_14024# a_17553_14024# 0.7425f
C2634 a_5523_14024# a_5631_14652# 0.01697f
C2635 a_25630_13226# a_27915_13226# 0.39036f
C2636 a_4187_2434# a_22113_1842# 0.11222f
C2637 a_5957_7532# a_5844_6698# 0.02055f
C2638 a_7390_6734# a_9751_6698# 0.26208f
C2639 a_12037_4687# a_10430_3889# 0.05231f
C2640 a_11277_4687# a_11271_3853# 0.02349f
C2641 a_8237_4687# a_8563_4687# 0.01427f
C2642 a_26185_3889# a_26471_3853# 0.01885f
C2643 a_12993_1842# a_13557_1842# 0.0114f
C2644 a_16108_3134# a_23633_1842# 0.01872f
C2645 a_16597_1842# a_16484_1008# 0.05157f
C2646 a_26985_15546# VDD 0.29292f
C2647 a_25717_16869# VDD 0.86719f
C2648 a_20968_1044# a_21044_1008# 0.01176f
C2649 a_8808_13226# VDD 0.17577f
C2650 a_25528_6734# VDD 0.17274f
C2651 a_16597_7532# VDD 0.94678f
C2652 a_25283_1842# VDD 0.48362f
C2653 a_5957_16869# a_5844_16035# 0.02055f
C2654 a_7390_16071# a_9675_16071# 0.39036f
C2655 a_8237_14024# a_8997_14024# 0.03319f
C2656 a_26185_13226# a_26395_13226# 0.09424f
C2657 a_13470_13226# a_15831_13190# 0.26208f
C2658 a_4187_2434# a_25717_4687# 0.04049f
C2659 a_6326_10280# a_9712_9602# 0.04737f
C2660 a_20593_7532# a_21157_7532# 0.0114f
C2661 a_14009_11568# a_13880_11982# 0.01562f
C2662 a_4187_2434# a_4437_1842# 0.0414f
C2663 a_13592_11561# a_14111_11568# 0.34102f
C2664 a_13019_11521# a_15304_10295# 0.07025f
C2665 a_5705_6209# a_5731_5979# 0.28954f
C2666 a_24957_7532# a_25604_6698# 0.02011f
C2667 a_11603_4687# a_11711_4687# 0.01163f
C2668 a_17683_4687# a_17791_5315# 0.01697f
C2669 a_25153_4687# a_25283_4687# 0.70361f
C2670 a_5731_3134# a_7803_1842# 0.01539f
C2671 a_17065_1044# a_17275_1044# 0.09424f
C2672 a_7043_16869# VDD 0.49729f
C2673 a_13368_16071# VDD 0.17274f
C2674 a_12907_11110# VDD 0.07753f
C2675 a_18585_6734# VDD 0.29722f
C2676 a_6391_5315# VDD 0.01806f
C2677 a_7673_1842# VDD 0.49562f
C2678 a_13444_1008# VDD 0.28633f
C2679 a_2873_3176# CHAN2_MUX_SEL2 0.01422f
C2680 a_2297_3176# CHAN2_MUX_SEL3 0.01595f
C2681 a_1721_3176# CHAN2_MUX_SEL4 0.05813f
C2682 a_1544_3134# CHAN2_MUX_OUT 0.69943f
C2683 VDD REF_MUX_SEL1 0.5478f
C2684 CHAN1_DELAY_IN CHAN1_MUX_SEL1 0.01858f
C2685 a_20593_16869# a_20723_16869# 0.70845f
C2686 a_10843_16869# a_10951_17497# 0.01697f
C2687 a_4187_2434# a_16597_14024# 0.03917f
C2688 a_24957_16869# a_25604_16035# 0.02011f
C2689 a_25153_14024# a_25717_14024# 0.0114f
C2690 a_4187_2434# a_7043_4687# 0.06627f
C2691 a_11473_7532# a_11603_7532# 0.70845f
C2692 a_15077_7532# a_14964_6698# 0.02055f
C2693 a_20397_4687# a_20391_3853# 0.02349f
C2694 a_16597_4687# a_16163_4687# 0.69698f
C2695 a_21157_4687# a_19550_3889# 0.05231f
C2696 a_25528_3889# a_25630_3889# 0.37183f
C2697 a_21157_1842# a_21353_1842# 0.77122f
C2698 a_25717_1842# a_25604_1008# 0.05157f
C2699 a_19833_14024# VDD 0.49553f
C2700 a_3449_12513# VDD 0.46689f
C2701 a_16271_8160# VDD 0.02023f
C2702 a_11277_4687# VDD 0.87185f
C2703 a_18004_3853# VDD 0.28225f
C2704 a_16851_5999# REF_MUX_OUT 0.45865f
C2705 a_12037_16869# a_11603_16869# 0.6972f
C2706 a_4187_2434# a_19833_16869# 0.11222f
C2707 a_15077_16869# a_14964_16035# 0.02055f
C2708 a_16033_14024# a_16163_14024# 0.70361f
C2709 a_4003_14024# a_4111_14652# 0.01697f
C2710 a_4187_2434# a_10713_7532# 0.11222f
C2711 a_4187_2434# a_20397_1842# 0.0414f
C2712 a_5197_7532# a_4350_6734# 0.08038f
C2713 a_8997_7532# a_9465_6734# 0.2079f
C2714 a_7477_4687# a_7673_4687# 0.73897f
C2715 a_7288_6734# a_7390_6734# 0.37183f
C2716 a_5731_5979# a_15077_4687# 0.01319f
C2717 a_14025_6734# a_14235_6734# 0.09424f
C2718 a_9757_4687# a_10404_3853# 0.02011f
C2719 a_13368_3889# a_13444_3853# 0.01176f
C2720 a_16108_3134# a_21917_1842# 0.01307f
C2721 a_12037_1842# a_12797_1842# 0.02912f
C2722 a_19550_1044# a_19524_1008# 0.277f
C2723 a_7390_1044# a_5731_289# 0.41141f
C2724 a_14825_15546# VDD 0.29292f
C2725 a_23003_16869# VDD 0.49743f
C2726 a_5844_13190# VDD 0.28225f
C2727 a_13883_7532# VDD 0.49742f
C2728 a_22590_6734# VDD 1.09883f
C2729 a_1721_4240# VDD 0.4533f
C2730 a_23633_1842# VDD 0.4963f
C2731 a_3449_16422# CHAN0_MUX_SEL1 0.29404f
C2732 a_15964_289# VDD 0.41556f
C2733 a_14825_12701# CHAN1_MUX_SEL4 0.03307f
C2734 a_6717_7532# REF_MUX_SEL4 0.0195f
C2735 CHAN3_MUX_SEL2 CHAN3_MUX_SEL3 3.21891f
C2736 CHAN3_MUX_SEL1 CHAN3_MUX_SEL4 0.03574f
C2737 a_5197_16869# a_4350_16071# 0.08038f
C2738 a_8997_16869# a_9465_16071# 0.2079f
C2739 a_15545_16071# a_13470_16071# 0.03208f
C2740 a_7477_14024# a_7043_14024# 0.69698f
C2741 a_5731_15316# a_14513_14024# 0.01872f
C2742 a_13368_13226# a_13470_13226# 0.37183f
C2743 a_12849_11557# a_12943_11557# 0.16706f
C2744 a_4187_2434# a_23003_4687# 0.06627f
C2745 a_19637_7532# a_20397_7532# 0.01669f
C2746 a_24197_7532# a_24084_6698# 0.02055f
C2747 a_16163_4687# a_16271_5315# 0.01697f
C2748 a_10083_4687# a_10191_4687# 0.01163f
C2749 a_4905_3889# a_5115_3889# 0.09424f
C2750 a_5731_3134# a_6153_1842# 0.02026f
C2751 a_16108_3134# a_23945_3364# 0.2906f
C2752 a_5393_16869# VDD 0.49417f
C2753 a_5957_1842# a_4350_1044# 0.05231f
C2754 a_7390_1044# a_8155_1044# 0.39037f
C2755 a_5197_1842# a_5191_1008# 0.02349f
C2756 a_10430_16071# VDD 0.88416f
C2757 a_26911_14652# VDD 0.01806f
C2758 a_15688_11557# VDD 0.30345f
C2759 a_27237_4687# VDD 0.86331f
C2760 a_11195_1044# VDD 0.1539f
C2761 a_5957_1842# VDD 0.85955f
C2762 a_10430_13226# CHAN1_MUX_SEL4 0.24983f
C2763 a_2873_1395# CHAN3_MUX_SEL1 0.13092f
C2764 a_3449_1395# CHAN3_DELAY_IN 0.01058f
C2765 CHAN0_MUX_SEL2 CHAN0_MUX_OUT 0.08497f
C2766 CHAN0_MUX_SEL3 CHAN0_MUX_SEL4 0.75489f
C2767 a_9323_16869# a_9431_17497# 0.01697f
C2768 a_22590_16071# a_23945_15546# 0.02138f
C2769 a_4187_2434# a_13883_14024# 0.06627f
C2770 a_24197_16869# a_24084_16035# 0.02055f
C2771 a_4187_2434# a_5393_4687# 0.11222f
C2772 a_4187_2434# a_26673_7532# 0.11284f
C2773 a_24957_14024# a_16108_12471# 0.0157f
C2774 a_6425_13226# a_4350_13226# 0.03208f
C2775 a_24197_14024# a_24957_14024# 0.02912f
C2776 a_16108_12471# a_20905_12701# 0.2906f
C2777 a_14317_7532# a_13470_6734# 0.08038f
C2778 a_22677_7532# a_23145_6734# 0.19203f
C2779 a_15273_4687# a_15837_4687# 0.0114f
C2780 a_18877_4687# a_19524_3853# 0.02011f
C2781 a_24008_3889# a_24084_3853# 0.01176f
C2782 a_19833_1842# a_19963_1842# 0.70845f
C2783 a_3449_331# a_2019_311# 0.01176f
C2784 a_18117_14024# VDD 0.85958f
C2785 a_10191_8160# VDD 0.01806f
C2786 a_27124_13190# VDD 0.28225f
C2787 a_8563_4687# VDD 0.95442f
C2788 a_15755_3889# VDD 0.15389f
C2789 a_13566_11018# REF_CLK 0.01093f
C2790 a_14317_16869# a_13470_16071# 0.08038f
C2791 a_4187_2434# a_18117_16869# 0.04152f
C2792 a_22677_16869# a_23145_16071# 0.19203f
C2793 a_10713_16869# a_11277_16869# 0.0114f
C2794 a_16510_16071# a_18871_16035# 0.26208f
C2795 a_4187_2434# a_8997_7532# 0.04106f
C2796 a_14851_10872# a_15464_9374# 0.04797f
C2797 a_4187_2434# a_17683_1842# 0.06492f
C2798 a_9444_10280# a_5778_9057# 0.19787f
C2799 a_13470_13226# a_14825_12701# 0.02058f
C2800 a_27433_7532# a_27563_7532# 0.70845f
C2801 a_5731_5979# a_12363_4687# 0.01542f
C2802 a_5768_6734# a_5844_6698# 0.01176f
C2803 a_6153_4687# a_6283_4687# 0.70845f
C2804 a_8997_4687# a_8884_3853# 0.02055f
C2805 a_11277_1842# a_10843_1842# 0.6972f
C2806 a_16108_3134# a_19203_1842# 0.01539f
C2807 a_14317_1842# a_14311_1008# 0.02349f
C2808 a_15077_1842# a_13470_1044# 0.05231f
C2809 a_21353_16869# VDD 0.49285f
C2810 a_27705_13226# VDD 0.29918f
C2811 a_12233_7532# VDD 0.49285f
C2812 a_19524_6698# VDD 0.28633f
C2813 a_8745_519# VDD 0.29603f
C2814 a_21917_1842# VDD 0.88247f
C2815 a_1256_16071# CHAN0_MUX_SEL4 0.04785f
C2816 a_27997_16869# a_27563_16869# 0.69646f
C2817 a_5731_15316# a_12797_14024# 0.01307f
C2818 a_6153_14024# a_6717_14024# 0.0114f
C2819 a_15077_14024# a_15545_13226# 0.2079f
C2820 a_11848_13226# a_11924_13190# 0.01176f
C2821 a_4187_2434# a_21353_4687# 0.11222f
C2822 a_21625_13226# a_21911_13190# 0.01885f
C2823 a_9323_14024# a_7390_13226# 0.01012f
C2824 a_13019_11521# a_13045_11905# 0.01249f
C2825 a_4187_2434# a_5731_3134# 0.15453f
C2826 a_13121_11521# a_13306_11995# 0.01008f
C2827 a_18877_7532# a_18443_7532# 0.6972f
C2828 a_23437_7532# a_22590_6734# 0.08038f
C2829 a_1256_6734# a_1721_7085# 0.13421f
C2830 a_1256_5979# a_1544_5979# 1.25711f
C2831 a_23437_4687# a_23633_4687# 0.76914f
C2832 a_8563_4687# a_8671_4687# 0.01163f
C2833 a_14643_4687# a_14751_5315# 0.01697f
C2834 a_12505_1044# a_12791_1008# 0.01885f
C2835 a_7364_16035# VDD 0.28633f
C2836 a_20831_14652# VDD 0.01806f
C2837 a_14009_11568# VDD 0.25384f
C2838 a_24523_4687# VDD 0.91083f
C2839 a_23945_3364# VDD 0.2935f
C2840 a_8231_1008# VDD 0.28336f
C2841 a_4763_14024# CHAN0_MUX_SEL4 0.01225f
C2842 a_1256_1044# CHAN3_MUX_SEL1 1.44243f
C2843 a_1544_1044# CHAN3_MUX_SEL0 0.07603f
C2844 CHAN0_DELAY_IN CHAN0_MUX_SEL1 0.01858f
C2845 a_1256_16071# a_1544_16071# 1.26509f
C2846 a_23437_16869# a_22590_16071# 0.08038f
C2847 a_18877_16869# a_19073_16869# 0.76914f
C2848 a_7803_16869# a_7911_17497# 0.01697f
C2849 a_4187_2434# a_12233_14024# 0.11222f
C2850 a_4187_2434# a_24957_7532# 0.04176f
C2851 a_23437_14024# a_23003_14024# 0.6972f
C2852 a_9757_7532# a_9953_7532# 0.72407f
C2853 a_12797_7532# a_12791_6698# 0.02354f
C2854 a_16408_6734# a_16484_6698# 0.01176f
C2855 a_16108_5979# a_26477_4687# 0.01319f
C2856 a_14317_4687# a_15077_4687# 0.03319f
C2857 a_22590_3889# a_22564_3853# 0.277f
C2858 a_18117_4687# a_18004_3853# 0.02055f
C2859 a_13470_3889# a_5731_3134# 0.41365f
C2860 a_18877_1842# a_19203_1842# 0.01427f
C2861 a_23437_1842# a_23431_1008# 0.02349f
C2862 a_1544_289# a_2297_331# 0.27303f
C2863 a_22590_1044# a_16108_289# 0.55709f
C2864 a_1256_1044# a_2297_1395# 0.04619f
C2865 a_1256_289# a_2873_331# 0.27926f
C2866 a_24197_1842# a_22590_1044# 0.05231f
C2867 a_15403_14024# VDD 0.49799f
C2868 a_24875_13226# VDD 0.15407f
C2869 a_4111_8160# VDD 0.01866f
C2870 a_12791_3853# VDD 0.2822f
C2871 a_6913_4687# VDD 0.49656f
C2872 a_4187_2434# a_15403_16869# 0.06627f
C2873 a_9757_16869# a_10517_16869# 0.05851f
C2874 a_12797_16869# a_12791_16035# 0.02354f
C2875 a_14317_14024# a_14513_14024# 0.76914f
C2876 a_16108_15316# a_25913_14024# 0.01865f
C2877 a_4187_2434# a_6283_7532# 0.06627f
C2878 a_16408_16071# a_16510_16071# 0.37183f
C2879 a_22488_13226# a_22564_13190# 0.01176f
C2880 a_18443_14024# a_16510_13226# 0.01012f
C2881 a_4187_2434# a_16033_1842# 0.11169f
C2882 a_14009_10774# a_13880_10808# 0.01562f
C2883 a_9465_6734# a_9751_6698# 0.01885f
C2884 a_4350_6734# a_4324_6698# 0.277f
C2885 a_26477_7532# a_26803_7532# 0.01427f
C2886 a_5731_5979# a_10713_4687# 0.01865f
C2887 a_5197_4687# a_5523_4687# 0.01427f
C2888 a_10430_3889# a_11195_3889# 0.39037f
C2889 a_13557_4687# a_14025_3889# 0.19203f
C2890 a_21625_3889# a_19550_3889# 0.03208f
C2891 a_8237_4687# a_7390_3889# 0.08038f
C2892 a_12797_1842# a_13444_1008# 0.02011f
C2893 a_27563_1842# a_27671_1842# 0.01163f
C2894 a_9953_1842# a_10517_1842# 0.0114f
C2895 a_16510_1044# a_17351_1008# 0.28268f
C2896 a_19637_16869# VDD 0.86712f
C2897 a_15545_13226# VDD 0.29918f
C2898 a_1721_15358# VDD 0.45365f
C2899 a_17275_6734# VDD 0.15389f
C2900 a_10517_7532# VDD 0.86714f
C2901 a_19203_1842# VDD 0.50004f
C2902 a_2873_331# VDD 0.46491f
C2903 a_1544_12471# CHAN1_MUX_OUT 0.69943f
C2904 a_2297_12513# CHAN1_MUX_SEL3 0.01595f
C2905 a_1721_12513# CHAN1_MUX_SEL4 0.05813f
C2906 a_2873_12513# CHAN1_MUX_SEL2 0.01422f
C2907 CHAN2_MUX_SEL1 CHAN2_MUX_SEL4 0.03574f
C2908 CHAN2_MUX_SEL2 CHAN2_MUX_SEL3 3.21891f
C2909 a_9465_16071# a_9675_16071# 0.09424f
C2910 a_4248_16071# a_4324_16035# 0.01176f
C2911 a_26673_16869# a_27237_16869# 0.0114f
C2912 a_5197_14024# a_5957_14024# 0.03319f
C2913 a_20105_13226# a_19550_13226# 0.03209f
C2914 a_10430_13226# a_10404_13190# 0.277f
C2915 a_4187_2434# a_19637_4687# 0.0414f
C2916 a_17553_7532# a_18117_7532# 0.0114f
C2917 a_21917_7532# a_21911_6698# 0.02354f
C2918 a_13123_4687# a_13231_5315# 0.01697f
C2919 a_22113_4687# a_22243_4687# 0.70845f
C2920 a_27048_6734# a_27124_6698# 0.01176f
C2921 a_7043_4687# a_7151_4687# 0.01163f
C2922 a_27237_4687# a_27124_3853# 0.02055f
C2923 a_5731_3134# a_15765_3308# 0.23301f
C2924 a_27237_1842# a_26803_1842# 0.6972f
C2925 a_4350_1044# a_5768_1044# 0.38994f
C2926 a_5115_16071# VDD 0.15389f
C2927 a_10985_1044# a_10430_1044# 0.03209f
C2928 a_14751_14652# VDD 0.01806f
C2929 a_13019_11521# VDD 0.42215f
C2930 a_11785_3364# VDD 0.29292f
C2931 a_22873_4687# VDD 0.49557f
C2932 a_5768_1044# VDD 0.17499f
C2933 a_16851_15336# CHAN0_MUX_OUT 0.45865f
C2934 a_17553_16869# a_17683_16869# 0.70361f
C2935 a_6283_16869# a_6391_17497# 0.01697f
C2936 a_4187_2434# a_10517_14024# 0.0414f
C2937 a_21917_16869# a_21911_16035# 0.02354f
C2938 a_22113_14024# a_22677_14024# 0.0114f
C2939 a_4187_2434# a_22243_7532# 0.06661f
C2940 a_27563_14024# a_25630_13226# 0.01024f
C2941 a_5731_12471# a_14825_12701# 0.28056f
C2942 a_8433_7532# a_8563_7532# 0.70361f
C2943 a_11277_7532# a_11924_6698# 0.02312f
C2944 a_13557_4687# a_13123_4687# 0.69698f
C2945 a_16108_5979# a_23763_4687# 0.01371f
C2946 a_17357_4687# a_16510_3889# 0.08038f
C2947 a_27237_4687# a_27705_3889# 0.2079f
C2948 a_18117_1842# a_18313_1842# 0.77122f
C2949 a_21917_1842# a_22564_1008# 0.02011f
C2950 a_25391_17497# VDD 0.01806f
C2951 a_13753_14024# VDD 0.49553f
C2952 a_21911_13190# VDD 0.2822f
C2953 a_26477_7532# VDD 0.86919f
C2954 a_5197_4687# VDD 0.87057f
C2955 a_10328_3889# VDD 0.17274f
C2956 a_4187_2434# REF_CLK 2.0411f
C2957 a_26151_2470# VDD 0.01806f
C2958 a_1256_5979# REF_MUX_SEL3 1.41161f
C2959 a_1544_5979# REF_MUX_SEL2 0.07405f
C2960 a_15964_289# CHAN3_MUX_SEL4 0.5544f
C2961 a_8997_16869# a_8563_16869# 0.6972f
C2962 a_4187_2434# a_13753_16869# 0.11222f
C2963 a_14888_16071# a_14964_16035# 0.01176f
C2964 a_11277_16869# a_11924_16035# 0.02312f
C2965 a_4187_2434# a_4633_7532# 0.11222f
C2966 a_12993_14024# a_13123_14024# 0.70845f
C2967 a_10430_13226# a_5731_12471# 0.41176f
C2968 a_4187_2434# a_14317_1842# 0.0414f
C2969 a_25717_7532# a_25913_7532# 0.73897f
C2970 a_14009_10774# a_14111_10917# 0.47622f
C2971 a_7945_6734# a_7390_6734# 0.03209f
C2972 a_6717_4687# a_6711_3853# 0.02354f
C2973 a_4437_4687# a_4633_4687# 0.73897f
C2974 a_8997_1842# a_9757_1842# 0.02912f
C2975 a_12037_1842# a_11924_1008# 0.02055f
C2976 a_26043_1842# a_26151_1842# 0.01163f
C2977 a_27705_1044# a_27991_1008# 0.01885f
C2978 a_26395_16071# VDD 0.15389f
C2979 a_15755_1044# a_15831_1008# 0.01194f
C2980 a_16923_16869# VDD 0.4975f
C2981 a_4905_13226# VDD 0.3013f
C2982 a_14311_6698# VDD 0.28357f
C2983 a_7803_7532# VDD 0.498f
C2984 a_17553_1842# VDD 0.49521f
C2985 a_27048_1044# VDD 0.17499f
C2986 a_25717_16869# a_26477_16869# 0.01669f
C2987 a_4187_2434# a_26477_14024# 0.04144f
C2988 a_4187_2434# a_6126_9506# 0.01376f
C2989 a_5731_15316# a_8433_14024# 0.01746f
C2990 a_4437_14024# a_4003_14024# 0.69698f
C2991 a_17065_13226# a_17351_13190# 0.01885f
C2992 a_4187_2434# a_16923_4687# 0.06627f
C2993 a_16597_7532# a_17357_7532# 0.01669f
C2994 a_11491_11918# a_11397_11918# 0.28931f
C2995 a_25630_6734# a_25604_6698# 0.277f
C2996 a_20397_7532# a_21044_6698# 0.02312f
C2997 a_11603_4687# a_11711_5315# 0.01697f
C2998 a_5523_4687# a_5631_4687# 0.01163f
C2999 a_26477_4687# a_25630_3889# 0.08038f
C3000 a_7945_1044# a_8231_1008# 0.01885f
C3001 a_25913_1842# a_26477_1842# 0.0114f
C3002 a_23145_16071# VDD 0.30409f
C3003 a_8671_14652# VDD 0.02372f
C3004 a_11748_11799# VDD 0.1686f
C3005 a_21157_4687# VDD 0.85996f
C3006 a_26185_1044# VDD 0.30411f
C3007 a_4763_16869# a_4871_17497# 0.01697f
C3008 a_20397_16869# a_21044_16035# 0.02312f
C3009 a_4187_2434# a_7803_14024# 0.06627f
C3010 a_25528_16071# a_25604_16035# 0.01176f
C3011 a_4187_2434# a_20593_7532# 0.11287f
C3012 a_21157_14024# a_21917_14024# 0.02912f
C3013 a_18877_14024# a_16108_12471# 0.0157f
C3014 a_10517_7532# a_10430_6734# 0.1088f
C3015 a_13470_6734# a_14235_6734# 0.39037f
C3016 a_24665_6734# a_24951_6698# 0.01885f
C3017 a_15837_4687# a_15831_3853# 0.02354f
C3018 a_12233_4687# a_12797_4687# 0.0114f
C3019 a_16108_5979# a_22113_4687# 0.01872f
C3020 a_19550_3889# a_20391_3853# 0.28268f
C3021 a_16793_1842# a_16923_1842# 0.70845f
C3022 a_21157_1842# a_21044_1008# 0.02055f
C3023 a_25630_1044# a_27048_1044# 0.38994f
C3024 a_12037_14024# VDD 0.85955f
C3025 a_19311_17497# VDD 0.01806f
C3026 a_16510_1044# a_17865_519# 0.02165f
C3027 a_19448_13226# VDD 0.17274f
C3028 a_16851_5999# VDD 0.52304f
C3029 a_23763_7532# VDD 0.52729f
C3030 a_4187_2434# CHAN1_DELAY_OUT_LAST 0.21225f
C3031 a_7390_3889# VDD 1.14001f
C3032 a_20071_2470# VDD 0.01806f
C3033 a_12849_11557# REF_CLK 0.26382f
C3034 a_1544_3889# CHAN2_MUX_OUT 0.04258f
C3035 a_2297_4240# CHAN2_MUX_SEL1 0.01995f
C3036 a_5731_289# CHAN3_MUX_OUT 1.04829f
C3037 a_8745_519# CHAN3_MUX_SEL4 0.04472f
C3038 a_4187_2434# a_12037_16869# 0.04152f
C3039 a_7673_16869# a_8237_16869# 0.0114f
C3040 a_10517_16869# a_10430_16071# 0.1088f
C3041 a_24665_16071# a_24875_16071# 0.09424f
C3042 a_13470_16071# a_13444_16035# 0.277f
C3043 a_16108_15316# a_21483_14024# 0.01542f
C3044 a_7390_13226# a_8745_12701# 0.01627f
C3045 a_19550_13226# a_20315_13226# 0.39037f
C3046 a_24393_7532# a_24523_7532# 0.70361f
C3047 a_4187_2434# a_11603_1842# 0.06627f
C3048 a_5731_5979# a_6283_4687# 0.01542f
C3049 a_5197_4687# a_5844_3853# 0.02312f
C3050 a_15545_3889# a_15755_3889# 0.09424f
C3051 a_7390_3889# a_8808_3889# 0.38994f
C3052 a_8237_1842# a_7803_1842# 0.6972f
C3053 a_26185_1044# a_25630_1044# 0.03209f
C3054 a_18117_1842# a_18585_1044# 0.2079f
C3055 a_14235_1044# a_14311_1008# 0.01194f
C3056 a_15273_16869# VDD 0.49294f
C3057 a_11277_1842# a_10430_1044# 0.08038f
C3058 a_13470_1044# a_14964_1008# 0.28279f
C3059 a_24523_1842# a_24631_1842# 0.01163f
C3060 a_23431_16035# VDD 0.28357f
C3061 a_2297_13577# VDD 0.46536f
C3062 a_6153_7532# VDD 0.49285f
C3063 a_11848_6734# VDD 0.17499f
C3064 a_15837_1842# VDD 0.8821f
C3065 a_24084_1008# VDD 0.28297f
C3066 a_14009_10774# REF_DELAY_OUT_LAST 0.25594f
C3067 REF_MUX_SEL1 REF_MUX_SEL4 0.03574f
C3068 REF_MUX_SEL2 REF_MUX_SEL3 3.21891f
C3069 a_24957_16869# a_24523_16869# 0.6972f
C3070 a_4905_16071# a_5191_16035# 0.01885f
C3071 a_4187_2434# a_23763_14024# 0.06453f
C3072 a_5731_15316# a_6717_14024# 0.01307f
C3073 a_16108_15316# a_26985_15546# 0.27952f
C3074 a_5197_14024# a_5768_13226# 0.10863f
C3075 a_4187_2434# a_15273_4687# 0.11222f
C3076 a_7390_13226# a_8231_13190# 0.28268f
C3077 a_10232_11561# a_11491_11918# 0.01529f
C3078 a_15837_7532# a_15403_7532# 0.6972f
C3079 a_19637_7532# a_19550_6734# 0.1088f
C3080 a_10083_4687# a_10191_5315# 0.01697f
C3081 a_20397_4687# a_20593_4687# 0.76914f
C3082 a_4003_4687# a_4111_4687# 0.01163f
C3083 a_24957_4687# a_24951_3853# 0.02354f
C3084 a_6425_1044# a_6635_1044# 0.09424f
C3085 a_24957_1842# a_25717_1842# 0.05851f
C3086 a_27997_14024# VDD 0.76528f
C3087 a_10985_16071# VDD 0.30409f
C3088 a_9946_11995# VDD 0.77235f
C3089 a_18443_4687# VDD 0.50001f
C3090 a_14025_1044# VDD 0.30411f
C3091 a_1544_3134# VDD 0.39372f
C3092 a_15837_16869# a_16033_16869# 0.76914f
C3093 a_4187_2434# a_27997_16869# 0.04001f
C3094 a_4187_2434# a_6153_14024# 0.11222f
C3095 a_19637_16869# a_19550_16071# 0.1088f
C3096 a_4187_2434# a_18877_7532# 0.04176f
C3097 a_20397_14024# a_19963_14024# 0.6972f
C3098 a_25630_13226# a_16108_12471# 0.52614f
C3099 a_6717_7532# a_6913_7532# 0.76914f
C3100 a_4187_2434# a_27563_1842# 0.06629f
C3101 a_16108_5979# a_20397_4687# 0.01319f
C3102 a_11277_4687# a_12037_4687# 0.03319f
C3103 a_23145_6734# a_22590_6734# 0.03209f
C3104 a_14317_4687# a_14964_3853# 0.02312f
C3105 a_18795_3889# a_18871_3853# 0.01194f
C3106 a_15837_1842# a_16163_1842# 0.01427f
C3107 a_20397_1842# a_19550_1044# 0.08038f
C3108 a_13231_17497# VDD 0.01806f
C3109 a_9323_14024# VDD 0.50013f
C3110 a_22113_7532# VDD 0.49426f
C3111 a_16510_13226# VDD 1.0321f
C3112 a_4324_3853# VDD 0.28687f
C3113 a_13991_2470# VDD 0.01806f
C3114 a_4437_16869# CHAN0_DELAY_IN 0.05007f
C3115 a_4187_2434# CHAN0_DELAY_OUT_LAST 0.21225f
C3116 a_12158_11557# REF_CLK 0.01309f
C3117 a_2873_331# CHAN3_MUX_SEL4 0.04916f
C3118 a_3449_331# CHAN3_MUX_SEL3 0.28429f
C3119 a_2297_331# CHAN3_MUX_OUT 0.01179f
C3120 VDD CHAN1_MUX_OUT 0.77354f
C3121 a_4187_2434# a_9323_16869# 0.06627f
C3122 a_6717_16869# a_7477_16869# 0.06198f
C3123 a_11277_14024# a_11473_14024# 0.76914f
C3124 a_14317_14024# a_14888_13226# 0.10863f
C3125 a_16108_15316# a_19833_14024# 0.01865f
C3126 a_4187_2434# a_9953_1842# 0.11076f
C3127 a_23437_7532# a_23763_7532# 0.01427f
C3128 a_15765_6153# a_16108_5979# 0.42004f
C3129 a_4437_4687# a_4350_3889# 0.1088f
C3130 a_6913_1842# a_7477_1842# 0.0114f
C3131 a_5731_3134# a_14317_1842# 0.01319f
C3132 a_23003_1842# a_23111_1842# 0.01163f
C3133 a_23145_1044# a_23431_1008# 0.01885f
C3134 a_13557_16869# VDD 0.86712f
C3135 a_9757_1842# a_9751_1008# 0.02354f
C3136 a_20968_16071# VDD 0.17499f
C3137 a_4437_7532# VDD 0.87051f
C3138 a_23871_5315# VDD 0.01806f
C3139 a_8884_6698# VDD 0.28358f
C3140 a_21835_1044# VDD 0.15407f
C3141 a_13123_1842# VDD 0.49994f
C3142 a_23633_16869# a_24197_16869# 0.0114f
C3143 a_4187_2434# a_22113_14024# 0.11222f
C3144 a_15765_15490# a_15964_15316# 0.061f
C3145 a_4187_2434# a_13557_4687# 0.0414f
C3146 a_6635_13226# a_6711_13190# 0.01194f
C3147 a_9946_11995# a_10649_11568# 0.02432f
C3148 a_14513_7532# a_15077_7532# 0.0114f
C3149 a_22590_6734# a_23431_6698# 0.28268f
C3150 a_8563_4687# a_8671_5315# 0.01697f
C3151 a_19073_4687# a_19203_4687# 0.70845f
C3152 a_23437_4687# a_24084_3853# 0.02312f
C3153 a_24197_1842# a_23763_1842# 0.6972f
C3154 a_16108_289# a_16851_309# 0.06181f
C3155 a_4157_1313# a_4350_1044# 0.04624f
C3156 a_25283_14024# VDD 0.48362f
C3157 a_5974_11413# VDD 0.92007f
C3158 a_16793_4687# VDD 0.54169f
C3159 a_25604_3853# VDD 0.28633f
C3160 a_4157_1313# VDD 0.48935f
C3161 a_3449_15358# CHAN0_DELAY_IN 0.01017f
C3162 a_1256_15316# CHAN0_MUX_SEL3 1.41161f
C3163 a_1544_15316# CHAN0_MUX_SEL2 0.07405f
C3164 a_4187_2434# a_25283_16869# 0.06391f
C3165 a_14513_16869# a_14643_16869# 0.70845f
C3166 a_4187_2434# a_4437_14024# 0.0414f
C3167 a_22590_16071# a_23355_16071# 0.39037f
C3168 a_4187_2434# a_25630_6734# 0.02246f
C3169 a_19073_14024# a_19637_14024# 0.0114f
C3170 a_23437_14024# a_24008_13226# 0.10863f
C3171 a_4187_2434# a_16163_7532# 0.06332f
C3172 a_1544_13226# a_2297_13577# 0.28651f
C3173 a_5393_7532# a_5523_7532# 0.70845f
C3174 a_4187_2434# a_25913_1842# 0.11222f
C3175 a_20105_6734# a_20391_6698# 0.01885f
C3176 a_10517_4687# a_10083_4687# 0.69698f
C3177 a_10430_6734# a_11848_6734# 0.38994f
C3178 a_4350_3889# a_5705_3364# 0.02005f
C3179 a_13557_4687# a_13470_3889# 0.1088f
C3180 a_16510_3889# a_18004_3853# 0.28279f
C3181 a_17275_3889# a_17351_3853# 0.01194f
C3182 a_15077_1842# a_15273_1842# 0.77122f
C3183 a_22590_1044# a_24875_1044# 0.39036f
C3184 a_7151_17497# VDD 0.01806f
C3185 a_16510_1044# a_2019_311# 0.03139f
C3186 a_18877_1842# a_18871_1008# 0.02354f
C3187 a_13444_13190# VDD 0.28633f
C3188 a_7673_14024# VDD 0.49562f
C3189 a_20397_7532# VDD 0.86919f
C3190 a_5705_6209# VDD 0.29556f
C3191 a_21625_3889# VDD 0.29742f
C3192 a_7911_2470# VDD 0.01806f
C3193 a_10232_11561# DLL_RESETN 0.39088f
C3194 VDD CHAN0_MUX_OUT 1.0425f
C3195 a_4187_2434# a_7673_16869# 0.11222f
C3196 a_5957_16869# a_5523_16869# 0.6972f
C3197 a_10430_16071# a_11271_16035# 0.28268f
C3198 a_16108_15316# a_18117_14024# 0.01644f
C3199 a_9953_14024# a_10083_14024# 0.70361f
C3200 a_20105_16071# a_20315_16071# 0.09424f
C3201 a_16510_13226# a_17928_13226# 0.38994f
C3202 a_4187_2434# a_8237_1842# 0.0414f
C3203 a_14851_11918# a_15304_10295# 0.12139f
C3204 a_13121_11521# a_14851_10872# 0.03337f
C3205 a_22677_7532# a_22873_7532# 0.73897f
C3206 a_5731_5979# a_16108_5979# 0.01334f
C3207 a_10985_3889# a_11195_3889# 0.09424f
C3208 a_4350_3889# a_6635_3889# 0.39036f
C3209 a_5731_3134# a_11603_1842# 0.01544f
C3210 a_27563_1842# a_27671_2470# 0.01697f
C3211 a_21483_1842# a_21591_1842# 0.01163f
C3212 a_5957_1842# a_6717_1842# 0.02912f
C3213 a_8237_1842# a_8884_1008# 0.02312f
C3214 a_10843_16869# VDD 0.4973f
C3215 a_10430_1044# a_12791_1008# 0.26208f
C3216 a_18004_16035# VDD 0.28225f
C3217 a_6635_6734# VDD 0.15406f
C3218 a_17791_5315# VDD 0.01806f
C3219 a_11473_1842# VDD 0.49593f
C3220 a_18871_1008# VDD 0.2822f
C3221 a_3449_7085# REF_MUX_SEL0 0.10753f
C3222 a_11785_3364# CHAN2_MUX_SEL4 0.03255f
C3223 VDD CHAN3_MUX_SEL0 0.60193f
C3224 a_22677_16869# a_23437_16869# 0.01669f
C3225 a_4187_2434# a_20397_14024# 0.0414f
C3226 a_5731_15316# a_15964_15316# 0.2778f
C3227 a_4350_13226# a_5844_13190# 0.28279f
C3228 a_5115_13226# a_5191_13190# 0.01194f
C3229 a_12505_13226# a_10430_13226# 0.03208f
C3230 a_4187_2434# a_10843_4687# 0.06627f
C3231 a_27237_14024# a_27433_14024# 0.77122f
C3232 a_13557_7532# a_14317_7532# 0.01669f
C3233 a_21835_6734# a_21911_6698# 0.01194f
C3234 a_7043_4687# a_7151_5315# 0.01697f
C3235 a_22677_4687# a_22590_3889# 0.1088f
C3236 a_19550_3889# a_20905_3364# 0.02165f
C3237 a_22873_1842# a_23437_1842# 0.0114f
C3238 a_1721_16422# VDD 0.4533f
C3239 a_15964_12471# VDD 0.41556f
C3240 a_23633_14024# VDD 0.4963f
C3241 a_27671_8160# VDD 0.01806f
C3242 a_15077_4687# VDD 0.86129f
C3243 a_23355_3889# VDD 0.1539f
C3244 a_2297_13577# CHAN1_MUX_SEL1 0.01995f
C3245 a_1544_13226# CHAN1_MUX_OUT 0.04258f
C3246 a_4187_2434# a_23633_16869# 0.11222f
C3247 a_4187_2434# a_14513_7532# 0.12091f
C3248 a_18117_14024# a_18877_14024# 0.02912f
C3249 a_27915_13226# a_27991_13190# 0.01194f
C3250 a_4187_2434# a_24197_1842# 0.03918f
C3251 a_9193_4687# a_9757_4687# 0.0114f
C3252 a_16108_5979# a_16033_4687# 0.01197f
C3253 a_13753_1842# a_13883_1842# 0.70845f
C3254 a_17357_1842# a_18004_1008# 0.02312f
C3255 a_10430_1044# a_11785_519# 0.02058f
C3256 a_26803_16869# VDD 0.49671f
C3257 a_5957_14024# VDD 0.86079f
C3258 a_11195_13226# VDD 0.1539f
C3259 a_17683_7532# VDD 0.48136f
C3260 a_27915_6734# VDD 0.15389f
C3261 a_9465_3889# VDD 0.29742f
C3262 a_27433_1842# VDD 0.49998f
C3263 a_6854_11144# DLL_RESETN 0.02919f
C3264 a_4187_2434# a_5957_16869# 0.04152f
C3265 a_4633_16869# a_5197_16869# 0.0114f
C3266 a_9675_16071# a_9751_16035# 0.01194f
C3267 a_4187_2434# a_26803_4687# 0.06627f
C3268 a_12849_11557# a_13132_11110# 0.06758f
C3269 a_21353_7532# a_21483_7532# 0.70845f
C3270 a_14111_11568# a_15108_11799# 0.03093f
C3271 a_4187_2434# a_5523_1842# 0.06627f
C3272 a_26477_4687# a_26043_4687# 0.6972f
C3273 a_5197_1842# a_4763_1842# 0.6972f
C3274 a_26043_1842# a_26151_2470# 0.01697f
C3275 a_7477_1842# a_7390_1044# 0.1088f
C3276 a_19963_1842# a_20071_1842# 0.01163f
C3277 a_10328_1044# a_10430_1044# 0.37183f
C3278 a_15755_16071# VDD 0.15389f
C3279 a_9193_16869# VDD 0.49409f
C3280 a_9757_1842# VDD 0.88049f
C3281 a_11711_5315# VDD 0.01806f
C3282 a_16408_1044# VDD 0.1824f
C3283 CHAN1_MUX_SEL2 CHAN1_MUX_SEL4 0.01978f
C3284 CHAN1_MUX_SEL1 CHAN1_MUX_OUT 0.05651f
C3285 VDD CHAN2_MUX_SEL0 0.60193f
C3286 a_21917_16869# a_21483_16869# 0.6972f
C3287 a_4187_2434# a_17683_14024# 0.06492f
C3288 a_25913_14024# a_26043_14024# 0.70845f
C3289 a_5731_15316# a_8745_15546# 0.28635f
C3290 a_4187_2434# a_9193_4687# 0.11222f
C3291 a_6854_11676# a_6854_11144# 0.29786f
C3292 a_12797_7532# a_12363_7532# 0.6972f
C3293 a_19550_6734# a_21044_6698# 0.28279f
C3294 a_20315_6734# a_20391_6698# 0.01194f
C3295 a_5523_4687# a_5631_5315# 0.01697f
C3296 a_17357_4687# a_17553_4687# 0.7425f
C3297 a_25630_3889# a_27915_3889# 0.39036f
C3298 a_26477_1842# a_27124_1008# 0.02312f
C3299 a_21917_1842# a_22677_1842# 0.06198f
C3300 a_2019_311# a_15964_289# 0.02413f
C3301 a_8745_12701# VDD 0.29603f
C3302 a_21917_14024# VDD 0.88247f
C3303 a_21591_8160# VDD 0.01806f
C3304 a_12363_4687# VDD 0.50001f
C3305 a_20391_3853# VDD 0.28357f
C3306 a_4003_4687# CHAN2_DELAY_IN 0.54998f
C3307 a_7390_3889# CHAN2_MUX_SEL4 0.29489f
C3308 a_4187_2434# a_21917_16869# 0.0414f
C3309 a_12797_16869# a_12993_16869# 0.76914f
C3310 a_4187_2434# a_5731_15316# 0.15453f
C3311 a_19550_16071# a_20968_16071# 0.38994f
C3312 a_17357_14024# a_16923_14024# 0.6972f
C3313 a_4187_2434# a_12797_7532# 0.0414f
C3314 a_26395_13226# a_26471_13190# 0.01194f
C3315 a_25630_13226# a_27124_13190# 0.28279f
C3316 a_6283_7532# a_4350_6734# 0.01012f
C3317 a_4187_2434# a_21483_1842# 0.06627f
C3318 a_9444_9602# a_5864_9057# 0.02062f
C3319 a_10517_7532# a_10985_6734# 0.19203f
C3320 a_7390_6734# a_9675_6734# 0.39036f
C3321 a_8237_4687# a_8997_4687# 0.03319f
C3322 a_13470_3889# a_15831_3853# 0.26208f
C3323 a_12797_1842# a_13123_1842# 0.01427f
C3324 a_16108_3134# a_23003_1842# 0.01539f
C3325 a_26185_3889# a_26395_3889# 0.09424f
C3326 a_16597_1842# a_16510_1044# 0.1088f
C3327 a_25153_16869# VDD 0.49409f
C3328 a_23945_15546# VDD 0.2935f
C3329 a_8231_13190# VDD 0.28349f
C3330 a_24951_6698# VDD 0.2822f
C3331 a_16033_7532# VDD 0.54891f
C3332 a_25717_1842# VDD 0.86969f
C3333 a_15545_16071# a_15831_16035# 0.01885f
C3334 a_8155_16071# a_8231_16035# 0.01194f
C3335 a_6283_16869# a_4350_16071# 0.01012f
C3336 a_10517_16869# a_10985_16071# 0.19203f
C3337 a_7390_16071# a_8884_16035# 0.28279f
C3338 a_8237_14024# a_8433_14024# 0.76914f
C3339 a_10843_14024# a_10430_13226# 0.01012f
C3340 a_13470_13226# a_15755_13226# 0.39036f
C3341 a_27705_13226# a_25630_13226# 0.03208f
C3342 a_4187_2434# a_25153_4687# 0.11169f
C3343 a_13592_11561# a_13880_11982# 0.43707f
C3344 a_20397_7532# a_20723_7532# 0.01427f
C3345 a_5974_11413# a_5778_9057# 2.88221f
C3346 a_25153_4687# a_25717_4687# 0.0114f
C3347 a_5731_3134# a_8237_1842# 0.01319f
C3348 a_8808_1044# a_8884_1008# 0.01176f
C3349 a_24523_1842# a_24631_2470# 0.01697f
C3350 a_18585_1044# a_16510_1044# 0.03208f
C3351 a_7477_16869# VDD 0.86719f
C3352 a_18443_1842# a_18551_1842# 0.01163f
C3353 a_12791_16035# VDD 0.2822f
C3354 a_12907_10876# VDD 0.0638f
C3355 a_17065_6734# VDD 0.3023f
C3356 a_5631_5315# VDD 0.01806f
C3357 a_7043_1842# VDD 0.49996f
C3358 a_13470_1044# VDD 0.88092f
C3359 a_2297_3176# CHAN2_MUX_SEL2 0.10655f
C3360 a_1544_3134# CHAN2_MUX_SEL4 0.47529f
C3361 a_1256_3134# CHAN2_MUX_OUT 0.1134f
C3362 a_4157_1313# CHAN3_MUX_SEL4 0.08229f
C3363 CHAN1_DELAY_IN CHAN1_MUX_SEL0 0.10102f
C3364 VDD REF_MUX_SEL0 0.60193f
C3365 a_20593_16869# a_21157_16869# 0.0114f
C3366 a_4187_2434# a_16033_14024# 0.11169f
C3367 a_6425_13226# a_6711_13190# 0.01885f
C3368 a_4187_2434# a_7477_4687# 0.0414f
C3369 a_11473_7532# a_12037_7532# 0.0114f
C3370 a_24197_7532# a_24665_6734# 0.2079f
C3371 a_15403_7532# a_13470_6734# 0.01012f
C3372 a_16033_4687# a_16163_4687# 0.70361f
C3373 a_4003_4687# a_4111_5315# 0.01697f
C3374 a_25717_1842# a_25630_1044# 0.1088f
C3375 a_21157_1842# a_20723_1842# 0.6972f
C3376 a_19203_14024# VDD 0.50004f
C3377 a_2873_12513# VDD 0.46585f
C3378 a_15511_8160# VDD 0.01806f
C3379 a_10713_4687# VDD 0.49553f
C3380 a_17928_3889# VDD 0.17499f
C3381 a_12797_16869# CHAN0_MUX_SEL4 0.01829f
C3382 a_16108_5979# REF_MUX_OUT 0.24265f
C3383 a_4187_2434# a_19203_16869# 0.06627f
C3384 a_11473_16869# a_11603_16869# 0.70845f
C3385 a_15403_16869# a_13470_16071# 0.01012f
C3386 a_24197_16869# a_24665_16071# 0.2079f
C3387 a_19963_14024# a_19550_13226# 0.01012f
C3388 a_4187_2434# a_10083_7532# 0.06492f
C3389 a_16033_14024# a_16597_14024# 0.0114f
C3390 a_4187_2434# a_19833_1842# 0.11222f
C3391 a_5731_5979# a_14513_4687# 0.01872f
C3392 a_15545_6734# a_13470_6734# 0.03208f
C3393 a_7477_4687# a_7043_4687# 0.69698f
C3394 a_13368_3889# a_13470_3889# 0.37183f
C3395 a_16108_3134# a_21353_1842# 0.01872f
C3396 a_12037_1842# a_12233_1842# 0.77122f
C3397 a_19448_1044# a_19524_1008# 0.01176f
C3398 a_23437_16869# VDD 0.86935f
C3399 a_11785_15546# VDD 0.29292f
C3400 a_14317_7532# VDD 0.87239f
C3401 a_5768_13226# VDD 0.17499f
C3402 a_22488_6734# VDD 0.17274f
C3403 a_1544_3889# VDD 0.45079f
C3404 a_23003_1842# VDD 0.50071f
C3405 a_15765_463# VDD 0.35368f
C3406 a_3449_16422# CHAN0_MUX_SEL0 0.10753f
C3407 a_11785_12701# CHAN1_MUX_SEL4 0.03255f
C3408 a_5731_15316# a_13883_14024# 0.01539f
C3409 a_14025_16071# a_13470_16071# 0.03209f
C3410 a_6913_14024# a_7043_14024# 0.70845f
C3411 a_16597_14024# a_17065_13226# 0.19203f
C3412 a_9757_14024# a_10328_13226# 0.10864f
C3413 a_13121_11521# a_12943_11557# 0.09118f
C3414 a_13306_11995# a_14009_11568# 0.02432f
C3415 a_6854_11144# a_9444_10280# 1.24134f
C3416 a_4187_2434# a_23437_4687# 0.04141f
C3417 a_19637_7532# a_19833_7532# 0.73897f
C3418 a_22590_6734# a_23945_6209# 0.02138f
C3419 a_15837_7532# a_15964_5979# 0.01935f
C3420 a_24523_7532# a_22590_6734# 0.01012f
C3421 a_6425_3889# a_4350_3889# 0.03208f
C3422 a_24957_4687# a_16108_3134# 0.0157f
C3423 a_24197_4687# a_24957_4687# 0.02912f
C3424 a_5731_3134# a_5523_1842# 0.01562f
C3425 a_16108_3134# a_20905_3364# 0.2906f
C3426 a_4763_16869# VDD 0.4973f
C3427 a_23003_1842# a_23111_2470# 0.01697f
C3428 a_16923_1842# a_17031_1842# 0.01163f
C3429 a_7390_1044# a_7364_1008# 0.277f
C3430 a_10328_16071# VDD 0.17274f
C3431 a_26151_14652# VDD 0.01806f
C3432 a_14851_11918# VDD 0.25841f
C3433 a_6425_6734# VDD 0.29722f
C3434 a_26673_4687# VDD 0.49593f
C3435 a_5393_1842# VDD 0.49643f
C3436 a_10404_1008# VDD 0.28633f
C3437 a_2873_1395# CHAN3_MUX_SEL0 0.01504f
C3438 CHAN0_MUX_SEL1 CHAN0_MUX_OUT 0.05651f
C3439 CHAN0_MUX_SEL2 CHAN0_MUX_SEL4 0.01978f
C3440 a_19637_16869# a_20397_16869# 0.01669f
C3441 a_1256_16071# a_2873_16422# 0.28892f
C3442 a_24523_16869# a_22590_16071# 0.01012f
C3443 a_4187_2434# a_14317_14024# 0.0414f
C3444 a_15837_16869# a_15964_15316# 0.01935f
C3445 a_4187_2434# a_4763_4687# 0.06627f
C3446 a_4157_13495# a_4324_13190# 0.02463f
C3447 a_4187_2434# a_26043_7532# 0.06661f
C3448 a_4905_13226# a_4350_13226# 0.03209f
C3449 a_24197_14024# a_24393_14024# 0.77122f
C3450 a_16108_12471# a_17865_12701# 0.29564f
C3451 a_10517_7532# a_11277_7532# 0.01669f
C3452 a_16510_6734# a_18871_6698# 0.26208f
C3453 a_19833_1842# a_20397_1842# 0.0114f
C3454 a_13470_3889# a_14825_3364# 0.02058f
C3455 a_17553_14024# VDD 0.49521f
C3456 a_9431_8160# VDD 0.01806f
C3457 a_27048_13226# VDD 0.17499f
C3458 a_8997_4687# VDD 0.88905f
C3459 a_14964_3853# VDD 0.28225f
C3460 a_13132_11110# REF_CLK 0.02025f
C3461 a_4187_2434# a_17553_16869# 0.11169f
C3462 a_16510_16071# a_18795_16071# 0.39036f
C3463 a_15077_14024# a_15837_14024# 0.02912f
C3464 a_4187_2434# a_8433_7532# 0.11169f
C3465 a_18877_14024# a_19448_13226# 0.10864f
C3466 a_14851_10872# a_14757_10872# 0.28931f
C3467 a_22590_13226# a_24951_13190# 0.26208f
C3468 a_4187_2434# a_18117_1842# 0.04141f
C3469 a_27433_7532# a_27997_7532# 0.0114f
C3470 a_6153_4687# a_6717_4687# 0.0114f
C3471 a_5731_5979# a_12797_4687# 0.01307f
C3472 a_11848_3889# a_11924_3853# 0.01176f
C3473 a_9323_4687# a_7390_3889# 0.01012f
C3474 a_15077_4687# a_15545_3889# 0.2079f
C3475 a_21625_3889# a_21911_3853# 0.01885f
C3476 a_16108_3134# a_19637_1842# 0.01314f
C3477 a_10713_1842# a_10843_1842# 0.70845f
C3478 a_20723_16869# VDD 0.49671f
C3479 a_4350_1044# a_5731_289# 0.41099f
C3480 a_26185_13226# VDD 0.30411f
C3481 a_11603_7532# VDD 0.49671f
C3482 a_19550_6734# VDD 0.89766f
C3483 a_5731_289# VDD 0.61878f
C3484 a_21353_1842# VDD 0.4946f
C3485 a_9757_1842# CHAN3_MUX_SEL4 0.01829f
C3486 a_27433_16869# a_27563_16869# 0.70845f
C3487 a_4350_16071# a_6711_16035# 0.26208f
C3488 a_10985_16071# a_11271_16035# 0.01885f
C3489 a_5731_15316# a_12233_14024# 0.01872f
C3490 a_21625_13226# a_21835_13226# 0.09424f
C3491 a_4187_2434# a_20723_4687# 0.06627f
C3492 a_9757_14024# a_7390_13226# 0.02479f
C3493 a_13121_11521# a_12849_11557# 0.55272f
C3494 a_1256_6734# a_1544_6734# 1.26509f
C3495 a_18313_7532# a_18443_7532# 0.70845f
C3496 a_23437_4687# a_23003_4687# 0.6972f
C3497 a_15403_1842# a_15511_1842# 0.01163f
C3498 a_21483_1842# a_21591_2470# 0.01697f
C3499 a_12505_1044# a_12715_1044# 0.09424f
C3500 a_20071_14652# VDD 0.01806f
C3501 a_7390_16071# VDD 1.14001f
C3502 a_13592_11561# VDD 0.07382f
C3503 a_24957_4687# VDD 0.8837f
C3504 a_20905_3364# VDD 0.29292f
C3505 a_27997_16869# CHAN0_DELAY_OUT_LAST 0.70955f
C3506 a_8155_1044# VDD 0.1539f
C3507 a_4003_14024# CHAN1_DELAY_IN 0.54998f
C3508 a_7390_13226# CHAN1_MUX_SEL4 0.29489f
C3509 a_1256_1044# CHAN3_MUX_SEL0 0.3314f
C3510 CHAN0_DELAY_IN CHAN0_MUX_SEL0 0.10102f
C3511 a_18877_16869# a_18443_16869# 0.6972f
C3512 a_4187_2434# a_11603_14024# 0.06627f
C3513 a_22873_14024# a_23003_14024# 0.70845f
C3514 a_4187_2434# a_24393_7532# 0.11006f
C3515 a_9757_7532# a_9323_7532# 0.6972f
C3516 a_26803_7532# a_26911_7532# 0.01163f
C3517 a_14317_4687# a_14513_4687# 0.76914f
C3518 a_16408_6734# a_16510_6734# 0.37183f
C3519 a_16108_5979# a_25913_4687# 0.01865f
C3520 a_18443_4687# a_16510_3889# 0.01012f
C3521 a_22488_3889# a_22564_3853# 0.01176f
C3522 a_18877_1842# a_19637_1842# 0.06198f
C3523 a_1544_289# a_1721_331# 0.36963f
C3524 a_1256_289# a_2297_331# 0.04261f
C3525 a_24084_13190# VDD 0.28297f
C3526 a_15837_14024# VDD 0.8821f
C3527 a_27563_7532# VDD 0.49811f
C3528 a_12715_3889# VDD 0.15407f
C3529 a_6283_4687# VDD 0.50001f
C3530 a_5705_6209# REF_MUX_SEL4 0.03556f
C3531 a_9757_16869# a_9953_16869# 0.72407f
C3532 a_4187_2434# a_15837_16869# 0.0414f
C3533 a_26803_16869# a_26911_16869# 0.01163f
C3534 a_14317_14024# a_13883_14024# 0.6972f
C3535 a_4187_2434# a_6717_7532# 0.0414f
C3536 a_18877_14024# a_16510_13226# 0.02479f
C3537 a_22488_13226# a_22590_13226# 0.37183f
C3538 a_4187_2434# a_15403_1842# 0.06627f
C3539 a_13592_11113# a_13880_10808# 0.43707f
C3540 a_26477_7532# a_27237_7532# 0.03319f
C3541 a_9465_6734# a_9675_6734# 0.09424f
C3542 a_4248_6734# a_4324_6698# 0.01176f
C3543 a_5197_4687# a_5957_4687# 0.03319f
C3544 a_10430_3889# a_10404_3853# 0.277f
C3545 a_20105_3889# a_19550_3889# 0.03209f
C3546 a_16108_3134# a_16923_1842# 0.01073f
C3547 a_16510_1044# a_17275_1044# 0.39037f
C3548 a_19073_16869# VDD 0.49426f
C3549 a_14025_13226# VDD 0.30411f
C3550 a_1544_15316# VDD 0.39372f
C3551 a_16484_6698# VDD 0.29019f
C3552 a_9953_7532# VDD 0.49351f
C3553 a_19637_1842# VDD 0.87095f
C3554 a_2297_331# VDD 0.46496f
C3555 a_2297_12513# CHAN1_MUX_SEL2 0.10655f
C3556 a_1544_12471# CHAN1_MUX_SEL4 0.47529f
C3557 a_1256_12471# CHAN1_MUX_OUT 0.1134f
C3558 a_13470_1044# CHAN3_MUX_SEL4 0.256f
C3559 a_26477_16869# a_26803_16869# 0.01427f
C3560 a_4248_16071# a_4350_16071# 0.37183f
C3561 a_4187_2434# a_27563_14024# 0.06629f
C3562 a_5197_14024# a_5393_14024# 0.76914f
C3563 a_5731_15316# a_10517_14024# 0.01314f
C3564 a_10328_13226# a_10404_13190# 0.01176f
C3565 a_4187_2434# a_19073_4687# 0.11222f
C3566 a_7477_14024# a_7364_13190# 0.05157f
C3567 a_22113_4687# a_22677_4687# 0.0114f
C3568 a_5731_3134# a_14825_3364# 0.28056f
C3569 a_27563_4687# a_25630_3889# 0.01024f
C3570 a_26673_1842# a_26803_1842# 0.70845f
C3571 a_13883_1842# a_13991_1842# 0.01163f
C3572 a_19963_1842# a_20071_2470# 0.01697f
C3573 a_4350_1044# a_5191_1008# 0.28268f
C3574 a_4324_16035# VDD 0.28687f
C3575 a_13991_14652# VDD 0.01806f
C3576 a_12656_11554# VDD 0.26377f
C3577 a_22243_4687# VDD 0.50007f
C3578 a_5191_1008# VDD 0.28565f
C3579 a_16108_15316# CHAN0_MUX_OUT 0.24265f
C3580 a_17553_16869# a_18117_16869# 0.0114f
C3581 a_4187_2434# a_9953_14024# 0.11076f
C3582 a_4187_2434# a_22677_7532# 0.04176f
C3583 a_21917_14024# a_22243_14024# 0.01427f
C3584 a_25630_16071# a_27991_16035# 0.26208f
C3585 a_5731_12471# a_11785_12701# 0.28056f
C3586 a_8433_7532# a_8997_7532# 0.0114f
C3587 a_25283_7532# a_25391_7532# 0.01163f
C3588 a_11277_7532# a_11848_6734# 0.10863f
C3589 a_14888_6734# a_14964_6698# 0.01176f
C3590 a_12993_4687# a_13123_4687# 0.70845f
C3591 a_10430_3889# a_5731_3134# 0.41176f
C3592 a_18117_1842# a_17683_1842# 0.6972f
C3593 a_19550_1044# a_16108_289# 0.58202f
C3594 a_24631_17497# VDD 0.02023f
C3595 a_21835_13226# VDD 0.15407f
C3596 a_13123_14024# VDD 0.49994f
C3597 a_4633_4687# VDD 0.49523f
C3598 a_25913_7532# VDD 0.493f
C3599 a_9751_3853# VDD 0.2822f
C3600 a_6717_16869# CHAN0_MUX_SEL4 0.0195f
C3601 a_4187_2434# DLL_RESETN 0.0693f
C3602 a_25391_2470# VDD 0.01806f
C3603 a_12943_11557# DLL_RESETN 0.03616f
C3604 a_1256_5979# REF_MUX_SEL2 0.33134f
C3605 a_15765_463# CHAN3_MUX_SEL4 0.65508f
C3606 a_8433_16869# a_8563_16869# 0.70361f
C3607 a_4187_2434# a_13123_16869# 0.06627f
C3608 a_26185_16071# a_26471_16035# 0.01885f
C3609 a_11277_16869# a_11848_16071# 0.10863f
C3610 a_25283_16869# a_25391_16869# 0.01163f
C3611 a_12993_14024# a_13557_14024# 0.0114f
C3612 a_4187_2434# a_4003_7532# 0.05992f
C3613 a_16108_15316# a_23633_14024# 0.01872f
C3614 a_16597_14024# a_16484_13190# 0.05157f
C3615 a_20968_13226# a_21044_13190# 0.01176f
C3616 a_25717_7532# a_25283_7532# 0.69698f
C3617 a_13592_11113# a_14111_10917# 0.34114f
C3618 a_4187_2434# a_13753_1842# 0.11222f
C3619 a_4437_4687# a_4003_4687# 0.69698f
C3620 a_5731_5979# a_8433_4687# 0.01746f
C3621 a_8997_1842# a_9193_1842# 0.77122f
C3622 a_17065_3889# a_17351_3853# 0.01885f
C3623 a_19637_1842# a_20105_1044# 0.19203f
C3624 a_12363_1842# a_10430_1044# 0.01012f
C3625 a_27705_1044# a_27915_1044# 0.09424f
C3626 a_25604_16035# VDD 0.28633f
C3627 a_17357_16869# VDD 0.86933f
C3628 a_4157_13495# VDD 0.48936f
C3629 a_14235_6734# VDD 0.15389f
C3630 a_8237_7532# VDD 0.87094f
C3631 a_16923_1842# VDD 0.4984f
C3632 a_26471_1008# VDD 0.28336f
C3633 a_15688_11093# REF_DELAY_OUT_LAST 0.01699f
C3634 a_25717_16869# a_25913_16869# 0.73897f
C3635 a_4187_2434# a_25913_14024# 0.11222f
C3636 a_4187_2434# a_6854_11676# 0.01478f
C3637 a_5731_15316# a_7803_14024# 0.01539f
C3638 a_4187_2434# a_17357_4687# 0.04141f
C3639 a_17065_13226# a_17275_13226# 0.09424f
C3640 a_11491_11918# a_12158_11557# 0.0894f
C3641 a_16597_7532# a_16793_7532# 0.73897f
C3642 a_20397_7532# a_20968_6734# 0.10863f
C3643 a_25528_6734# a_25604_6698# 0.01176f
C3644 a_21157_4687# a_21917_4687# 0.02912f
C3645 a_18877_4687# a_16108_3134# 0.0157f
C3646 a_7945_1044# a_8155_1044# 0.09424f
C3647 a_18443_1842# a_18551_2470# 0.01697f
C3648 a_12363_1842# a_12471_1842# 0.01163f
C3649 a_4437_1842# a_4905_1044# 0.19203f
C3650 a_21625_16071# VDD 0.29722f
C3651 a_7911_14652# VDD 0.01806f
C3652 a_10751_11568# VDD 0.20524f
C3653 a_20593_4687# VDD 0.49593f
C3654 a_24665_1044# VDD 0.29742f
C3655 a_16597_16869# a_17357_16869# 0.01669f
C3656 a_25528_16071# a_25630_16071# 0.37183f
C3657 a_20397_16869# a_20968_16071# 0.10863f
C3658 a_4187_2434# a_8237_14024# 0.0414f
C3659 a_4187_2434# a_19963_7532# 0.06661f
C3660 a_21157_14024# a_21353_14024# 0.77122f
C3661 a_25717_14024# a_25604_13190# 0.05157f
C3662 a_23763_7532# a_23871_7532# 0.01163f
C3663 a_7477_7532# a_8237_7532# 0.01669f
C3664 a_13470_6734# a_13444_6698# 0.277f
C3665 a_24665_6734# a_24875_6734# 0.09424f
C3666 a_16108_5979# a_21483_4687# 0.01542f
C3667 a_16793_1842# a_17357_1842# 0.0114f
C3668 a_7390_3889# a_8745_3364# 0.01627f
C3669 a_19550_3889# a_20315_3889# 0.39037f
C3670 a_21483_1842# a_19550_1044# 0.01012f
C3671 a_25630_1044# a_26471_1008# 0.28268f
C3672 a_11473_14024# VDD 0.49593f
C3673 a_18551_17497# VDD 0.01806f
C3674 a_16510_1044# a_16851_309# 0.02131f
C3675 a_18871_13190# VDD 0.2822f
C3676 a_24197_7532# VDD 0.93709f
C3677 a_16108_5979# VDD 1.67139f
C3678 a_4187_2434# CHAN1_DELAY_IN 0.07719f
C3679 a_7288_3889# VDD 0.17274f
C3680 a_19311_2470# VDD 0.01806f
C3681 a_12849_11557# DLL_RESETN 0.3501f
C3682 a_13121_11521# REF_CLK 1.40135f
C3683 a_2297_4240# CHAN2_MUX_SEL0 0.10655f
C3684 a_1256_3889# CHAN2_MUX_OUT 0.02199f
C3685 a_1544_3889# CHAN2_MUX_SEL4 0.03407f
C3686 a_5731_289# CHAN3_MUX_SEL4 4.60702f
C3687 a_4187_2434# a_11473_16869# 0.11222f
C3688 a_13368_16071# a_13444_16035# 0.01176f
C3689 a_23763_16869# a_23871_16869# 0.01163f
C3690 a_16108_15316# a_21917_14024# 0.01307f
C3691 a_12037_14024# a_12797_14024# 0.02912f
C3692 a_19550_13226# a_19524_13190# 0.277f
C3693 a_7390_13226# a_5731_12471# 0.41141f
C3694 a_4187_2434# a_12037_1842# 0.04141f
C3695 a_15304_10295# a_14111_10917# 0.01761f
C3696 a_24393_7532# a_24957_7532# 0.0114f
C3697 a_4905_6734# a_5191_6698# 0.01885f
C3698 a_16108_5979# a_26985_6209# 0.27952f
C3699 a_5731_5979# a_6717_4687# 0.01307f
C3700 a_5197_4687# a_5768_3889# 0.10863f
C3701 a_7673_1842# a_7803_1842# 0.70845f
C3702 a_5731_3134# a_15403_1842# 0.01563f
C3703 a_7390_3889# a_8231_3853# 0.28268f
C3704 a_14643_16869# VDD 0.49677f
C3705 a_13470_1044# a_14888_1044# 0.38994f
C3706 a_4157_1313# a_2019_311# 0.01018f
C3707 a_23355_16071# VDD 0.15389f
C3708 a_5523_7532# VDD 0.49671f
C3709 a_11271_6698# VDD 0.28357f
C3710 a_15273_1842# VDD 0.49468f
C3711 a_24008_1044# VDD 0.17499f
C3712 a_13592_11113# REF_DELAY_OUT_LAST 0.08062f
C3713 a_24393_16869# a_24523_16869# 0.70361f
C3714 a_5731_15316# a_6153_14024# 0.02026f
C3715 a_4187_2434# a_24197_14024# 0.03918f
C3716 a_16108_15316# a_23945_15546# 0.2906f
C3717 a_4905_16071# a_5115_16071# 0.09424f
C3718 a_5957_14024# a_4350_13226# 0.05231f
C3719 a_5197_14024# a_5191_13190# 0.02349f
C3720 a_4187_2434# a_14643_4687# 0.06627f
C3721 a_6854_11676# a_12849_11557# 0.06216f
C3722 a_10649_11568# a_10751_11568# 0.47795f
C3723 a_5731_12471# a_15304_10295# 0.04235f
C3724 a_7390_13226# a_8155_13226# 0.39037f
C3725 a_15273_7532# a_15403_7532# 0.70845f
C3726 a_20397_4687# a_19963_4687# 0.6972f
C3727 a_25630_3889# a_16108_3134# 0.52614f
C3728 a_24957_1842# a_25153_1842# 0.74845f
C3729 a_16923_1842# a_17031_2470# 0.01697f
C3730 a_10843_1842# a_10951_1842# 0.01163f
C3731 a_27433_14024# VDD 0.49998f
C3732 a_9465_16071# VDD 0.29722f
C3733 a_9772_11533# VDD 0.24887f
C3734 a_18877_4687# VDD 0.88247f
C3735 a_12505_1044# VDD 0.29742f
C3736 a_1256_3134# VDD 0.4205f
C3737 a_5705_15546# CHAN0_MUX_SEL4 0.03556f
C3738 a_15837_16869# a_15403_16869# 0.6972f
C3739 a_4187_2434# a_27433_16869# 0.11222f
C3740 a_4187_2434# a_5523_14024# 0.06627f
C3741 a_24008_16071# a_24084_16035# 0.01176f
C3742 a_4187_2434# a_18313_7532# 0.11284f
C3743 a_19833_14024# a_19963_14024# 0.70845f
C3744 a_6717_7532# a_6283_7532# 0.6972f
C3745 a_22243_7532# a_22351_7532# 0.01163f
C3746 a_4187_2434# a_27997_1842# 0.04001f
C3747 a_16108_5979# a_19833_4687# 0.01865f
C3748 a_11277_4687# a_11473_4687# 0.76914f
C3749 a_14317_4687# a_14888_3889# 0.10863f
C3750 a_15837_1842# a_16597_1842# 0.06198f
C3751 a_12471_17497# VDD 0.01806f
C3752 a_24875_1044# a_24951_1008# 0.01194f
C3753 a_9757_14024# VDD 0.88049f
C3754 a_16408_13226# VDD 0.1824f
C3755 a_21483_7532# VDD 0.4973f
C3756 a_4187_2434# CHAN0_DELAY_IN 0.07974f
C3757 a_13231_2470# VDD 0.01806f
C3758 a_4350_3889# VDD 0.87635f
C3759 a_11491_11918# REF_CLK 0.01827f
C3760 a_12158_11557# DLL_RESETN 0.02442f
C3761 VDD CHAN1_MUX_SEL4 2.73437f
C3762 a_2297_331# CHAN3_MUX_SEL4 0.04338f
C3763 a_2873_331# CHAN3_MUX_SEL3 0.12606f
C3764 a_3449_331# CHAN3_MUX_SEL2 0.10741f
C3765 a_6717_16869# a_6913_16869# 0.76914f
C3766 a_4187_2434# a_9757_16869# 0.04038f
C3767 a_22243_16869# a_22351_16869# 0.01163f
C3768 a_16108_15316# a_19203_14024# 0.01539f
C3769 a_11277_14024# a_10843_14024# 0.6972f
C3770 a_15077_14024# a_13470_13226# 0.05231f
C3771 a_14317_14024# a_14311_13190# 0.02349f
C3772 a_4187_2434# a_9323_1842# 0.06627f
C3773 a_13121_11521# a_15464_9374# 0.33256f
C3774 a_23437_7532# a_24197_7532# 0.03319f
C3775 a_15765_6153# a_15964_5979# 0.061f
C3776 a_6635_3889# a_6711_3853# 0.01194f
C3777 a_6717_1842# a_7043_1842# 0.01427f
C3778 a_5731_3134# a_13753_1842# 0.01865f
C3779 a_23145_1044# a_23355_1044# 0.09424f
C3780 a_12993_16869# VDD 0.49426f
C3781 a_20391_16035# VDD 0.28357f
C3782 a_5864_9057# VDD 0.14382f
C3783 a_8808_6734# VDD 0.17577f
C3784 a_23111_5315# VDD 0.01806f
C3785 a_21044_1008# VDD 0.28225f
C3786 a_13557_1842# VDD 0.87095f
C3787 a_15304_10295# REF_DELAY_OUT_LAST 0.05582f
C3788 a_23437_16869# a_23763_16869# 0.01427f
C3789 a_4187_2434# a_21483_14024# 0.06627f
C3790 a_4187_2434# a_12993_4687# 0.11222f
C3791 a_12505_13226# a_12791_13190# 0.01885f
C3792 a_9946_11995# a_10232_11561# 0.41329f
C3793 a_14317_7532# a_14643_7532# 0.01427f
C3794 a_22590_6734# a_23355_6734# 0.39037f
C3795 a_19073_4687# a_19637_4687# 0.0114f
C3796 a_23437_4687# a_24008_3889# 0.10863f
C3797 a_1544_3889# a_2297_4240# 0.28651f
C3798 a_9323_1842# a_9431_1842# 0.01163f
C3799 a_15403_1842# a_15511_2470# 0.01697f
C3800 a_23633_1842# a_23763_1842# 0.70845f
C3801 a_15964_289# a_16851_309# 0.16757f
C3802 a_4157_1313# a_4248_1044# 0.11672f
C3803 a_25717_14024# VDD 0.86969f
C3804 a_6326_10280# VDD 7.64072f
C3805 a_16163_4687# VDD 0.94897f
C3806 a_3449_1395# VDD 0.46731f
C3807 a_25630_3889# VDD 0.90165f
C3808 a_1256_15316# CHAN0_MUX_SEL2 0.33134f
C3809 a_4187_2434# a_25717_16869# 0.04049f
C3810 a_14513_16869# a_15077_16869# 0.0114f
C3811 a_13470_16071# a_5731_15316# 0.41365f
C3812 a_22590_16071# a_22564_16035# 0.277f
C3813 a_23437_14024# a_23431_13190# 0.02349f
C3814 a_18877_14024# a_19203_14024# 0.01427f
C3815 a_4187_2434# a_16597_7532# 0.03917f
C3816 a_1256_13226# a_2297_13577# 0.04619f
C3817 a_24197_14024# a_22590_13226# 0.05231f
C3818 a_22590_13226# a_16108_12471# 0.55709f
C3819 a_1544_12471# a_2297_12513# 0.27303f
C3820 a_5393_7532# a_5957_7532# 0.0114f
C3821 a_1256_12471# a_2873_12513# 0.27926f
C3822 a_4187_2434# a_25283_1842# 0.06391f
C3823 a_26803_7532# a_26911_8160# 0.01697f
C3824 a_7803_7532# a_7390_6734# 0.01012f
C3825 a_20723_7532# a_20831_7532# 0.01163f
C3826 a_10430_6734# a_11271_6698# 0.28268f
C3827 a_20105_6734# a_20315_6734# 0.09424f
C3828 a_9953_4687# a_10083_4687# 0.70361f
C3829 a_16108_5979# a_18117_4687# 0.01644f
C3830 a_16510_3889# a_17928_3889# 0.38994f
C3831 a_15077_1842# a_14643_1842# 0.6972f
C3832 a_16108_3134# a_26803_1842# 0.01192f
C3833 a_6391_17497# VDD 0.01806f
C3834 a_22590_1044# a_24084_1008# 0.28279f
C3835 a_23355_1044# a_23431_1008# 0.01194f
C3836 a_7043_14024# VDD 0.49996f
C3837 a_13470_13226# VDD 0.88092f
C3838 a_19833_7532# VDD 0.49294f
C3839 a_20105_3889# VDD 0.30411f
C3840 a_3449_6021# VDD 0.47499f
C3841 a_7151_2470# VDD 0.01806f
C3842 a_10206_11525# DLL_RESETN 0.27343f
C3843 VDD CHAN0_MUX_SEL4 2.78273f
C3844 a_4187_2434# a_7043_16869# 0.06627f
C3845 a_5393_16869# a_5523_16869# 0.70845f
C3846 a_20723_16869# a_20831_16869# 0.01163f
C3847 a_7803_16869# a_7390_16071# 0.01012f
C3848 a_21625_16071# a_19550_16071# 0.03208f
C3849 a_10430_16071# a_11195_16071# 0.39037f
C3850 a_9953_14024# a_10517_14024# 0.0114f
C3851 a_12797_14024# a_13444_13190# 0.02011f
C3852 a_16510_13226# a_17351_13190# 0.28268f
C3853 a_27563_14024# a_27671_14024# 0.01163f
C3854 a_15108_11799# a_15304_10295# 0.17528f
C3855 a_4187_2434# a_7673_1842# 0.11222f
C3856 a_22677_7532# a_22243_7532# 0.69698f
C3857 a_5731_5979# a_15964_5979# 0.2778f
C3858 a_27237_4687# a_27433_4687# 0.77122f
C3859 a_12505_3889# a_10430_3889# 0.03208f
C3860 a_4350_3889# a_5844_3853# 0.28279f
C3861 a_5115_3889# a_5191_3853# 0.01194f
C3862 a_8237_1842# a_8808_1044# 0.10863f
C3863 a_5957_1842# a_6153_1842# 0.77122f
C3864 a_5731_3134# a_12037_1842# 0.01319f
C3865 a_11277_16869# VDD 0.86919f
C3866 a_10430_1044# a_12715_1044# 0.39036f
C3867 a_17928_16071# VDD 0.17499f
C3868 a_5844_6698# VDD 0.28225f
C3869 a_13880_10808# VDD 0.02994f
C3870 a_17031_5315# VDD 0.01806f
C3871 a_10843_1842# VDD 0.50058f
C3872 a_18795_1044# VDD 0.15407f
C3873 VDD CHAN3_DELAY_OUT_LAST 0.46919f
C3874 DLL_RESETN REF_CLK 10.7499f
C3875 a_4187_2434# a_19833_14024# 0.11222f
C3876 a_22677_16869# a_22873_16869# 0.73897f
C3877 a_5731_15316# a_15765_15490# 0.23301f
C3878 a_27237_14024# a_26803_14024# 0.6972f
C3879 a_4187_2434# a_11277_4687# 0.04141f
C3880 a_10985_13226# a_10430_13226# 0.03209f
C3881 a_4350_13226# a_5768_13226# 0.38994f
C3882 a_13557_7532# a_13753_7532# 0.73897f
C3883 a_9547_11862# a_9746_11495# 0.02437f
C3884 a_9547_11632# a_9772_11533# 0.02416f
C3885 a_16923_7532# a_16510_6734# 0.01012f
C3886 a_18117_4687# a_18877_4687# 0.02912f
C3887 a_27915_3889# a_27991_3853# 0.01194f
C3888 a_13883_1842# a_13991_2470# 0.01697f
C3889 a_7803_1842# a_7911_1842# 0.01163f
C3890 a_1544_16071# VDD 0.45079f
C3891 a_15765_12645# VDD 0.35715f
C3892 a_23003_14024# VDD 0.50071f
C3893 a_26911_8160# VDD 0.01806f
C3894 a_22564_3853# VDD 0.28633f
C3895 a_14513_4687# VDD 0.49594f
C3896 a_1544_13226# CHAN1_MUX_SEL4 0.03407f
C3897 a_1256_13226# CHAN1_MUX_OUT 0.02199f
C3898 a_2297_13577# CHAN1_MUX_SEL0 0.10655f
C3899 a_4003_7532# REF_CLK 0.55467f
C3900 a_13557_16869# a_14317_16869# 0.01669f
C3901 a_4187_2434# a_23003_16869# 0.06627f
C3902 a_16923_16869# a_16510_16071# 0.01012f
C3903 a_4187_2434# a_13883_7532# 0.06627f
C3904 a_18117_14024# a_18313_14024# 0.77122f
C3905 a_21917_14024# a_22564_13190# 0.02011f
C3906 a_4187_2434# a_23633_1842# 0.11222f
C3907 a_4437_7532# a_5197_7532# 0.01669f
C3908 a_9675_6734# a_9751_6698# 0.01194f
C3909 a_6717_7532# a_7288_6734# 0.10864f
C3910 a_25283_7532# a_25391_8160# 0.01697f
C3911 a_19203_7532# a_19311_7532# 0.01163f
C3912 a_12037_7532# a_12505_6734# 0.2079f
C3913 a_17357_1842# a_17928_1044# 0.10863f
C3914 a_13753_1842# a_14317_1842# 0.0114f
C3915 a_16108_3134# a_25153_1842# 0.01872f
C3916 a_27237_16869# VDD 0.86022f
C3917 a_5393_14024# VDD 0.49643f
C3918 a_10404_13190# VDD 0.28633f
C3919 a_18117_7532# VDD 0.85892f
C3920 a_27124_6698# VDD 0.28225f
C3921 a_7945_3889# VDD 0.30411f
C3922 a_26803_1842# VDD 0.49718f
C3923 a_6854_11144# CHAN1_MUX_OUT 0.16652f
C3924 a_6854_11676# REF_CLK 0.05061f
C3925 a_6126_9506# DLL_RESETN 0.06398f
C3926 a_4187_2434# a_5393_16869# 0.11222f
C3927 a_6717_16869# a_7288_16071# 0.10864f
C3928 a_12037_16869# a_12505_16071# 0.2079f
C3929 a_19203_16869# a_19311_16869# 0.01163f
C3930 a_8997_14024# a_9757_14024# 0.02912f
C3931 a_15755_13226# a_15831_13190# 0.01194f
C3932 a_26043_14024# a_26151_14024# 0.01163f
C3933 a_12037_14024# a_11924_13190# 0.02055f
C3934 a_27705_13226# a_27991_13190# 0.01885f
C3935 a_4187_2434# a_27237_4687# 0.06254f
C3936 a_4187_2434# a_5957_1842# 0.04141f
C3937 a_21353_7532# a_21917_7532# 0.0114f
C3938 a_26043_7532# a_25630_6734# 0.01012f
C3939 a_5731_5979# a_8745_6209# 0.28635f
C3940 a_25913_4687# a_26043_4687# 0.70845f
C3941 a_4633_1842# a_4763_1842# 0.70845f
C3942 a_5731_3134# a_9323_1842# 0.01542f
C3943 a_18585_1044# a_18871_1008# 0.01885f
C3944 a_8563_16869# VDD 0.95429f
C3945 a_14964_16035# VDD 0.28225f
C3946 a_14111_10917# VDD 0.33926f
C3947 a_27705_6734# VDD 0.29962f
C3948 a_10951_5315# VDD 0.01806f
C3949 a_9193_1842# VDD 0.49584f
C3950 a_15831_1008# VDD 0.2816f
C3951 a_1721_7085# REF_MUX_SEL0 0.01315f
C3952 a_1544_6734# REF_MUX_SEL1 0.1672f
C3953 VDD CHAN2_DELAY_OUT_LAST 0.46919f
C3954 CHAN1_MUX_SEL1 CHAN1_MUX_SEL4 0.03574f
C3955 CHAN1_MUX_SEL2 CHAN1_MUX_SEL3 3.21891f
C3956 a_21353_16869# a_21483_16869# 0.70845f
C3957 a_4187_2434# a_18117_14024# 0.04141f
C3958 a_26043_16869# a_25630_16071# 0.01012f
C3959 a_25913_14024# a_26477_14024# 0.0114f
C3960 a_4187_2434# a_8563_4687# 0.0635f
C3961 a_7945_13226# a_8231_13190# 0.01885f
C3962 a_6854_11676# a_6126_9506# 0.17842f
C3963 a_5974_11413# a_6854_11144# 0.01757f
C3964 a_12233_7532# a_12363_7532# 0.70845f
C3965 a_19550_6734# a_20968_6734# 0.38994f
C3966 a_15837_7532# a_16408_6734# 0.10864f
C3967 a_25717_7532# a_26185_6734# 0.19203f
C3968 a_17357_4687# a_16923_4687# 0.6972f
C3969 a_26395_3889# a_26471_3853# 0.01194f
C3970 a_25630_3889# a_27124_3853# 0.28279f
C3971 a_12363_1842# a_12471_2470# 0.01697f
C3972 a_26477_1842# a_27048_1044# 0.10863f
C3973 a_21917_1842# a_22113_1842# 0.76914f
C3974 a_6283_1842# a_6391_1842# 0.01163f
C3975 a_2019_311# a_15765_463# 0.05969f
C3976 a_21353_14024# VDD 0.4946f
C3977 a_5731_12471# VDD 0.84475f
C3978 a_12797_4687# VDD 0.88193f
C3979 a_20831_8160# VDD 0.01806f
C3980 a_20315_3889# VDD 0.1539f
C3981 a_4437_4687# CHAN2_DELAY_IN 0.05007f
C3982 a_4633_4687# REF_MUX_SEL4 0.01287f
C3983 a_4187_2434# a_21353_16869# 0.11222f
C3984 a_12797_16869# a_12363_16869# 0.6972f
C3985 a_19550_16071# a_20391_16035# 0.28268f
C3986 a_15837_16869# a_16408_16071# 0.10864f
C3987 a_25717_16869# a_26185_16071# 0.19203f
C3988 a_4187_2434# a_12233_7532# 0.11222f
C3989 a_16793_14024# a_16923_14024# 0.70845f
C3990 a_21157_14024# a_21044_13190# 0.02055f
C3991 a_16510_13226# a_17865_12701# 0.02165f
C3992 a_25630_13226# a_27048_13226# 0.38994f
C3993 a_5778_9057# a_5864_9057# 0.07306f
C3994 a_17683_7532# a_17791_7532# 0.01163f
C3995 a_23763_7532# a_23871_8160# 0.01697f
C3996 a_4187_2434# a_21917_1842# 0.0414f
C3997 a_9444_9602# a_9712_9602# 0.81869f
C3998 a_6717_7532# a_4350_6734# 0.02479f
C3999 a_7390_6734# a_8884_6698# 0.28279f
C4000 a_15545_6734# a_15831_6698# 0.01885f
C4001 a_8155_6734# a_8231_6698# 0.01194f
C4002 a_8237_4687# a_8433_4687# 0.76914f
C4003 a_10843_4687# a_10430_3889# 0.01012f
C4004 a_12797_1842# a_13557_1842# 0.06198f
C4005 a_27705_3889# a_25630_3889# 0.03208f
C4006 a_16108_3134# a_23437_1842# 0.01319f
C4007 a_13470_3889# a_15755_3889# 0.39036f
C4008 a_20905_15546# VDD 0.29292f
C4009 a_19550_1044# a_21911_1008# 0.26208f
C4010 a_24523_16869# VDD 0.90814f
C4011 a_8155_13226# VDD 0.1539f
C4012 a_24875_6734# VDD 0.15406f
C4013 a_15403_7532# VDD 0.49799f
C4014 a_25153_1842# VDD 0.49638f
C4015 a_2873_4240# VDD 0.46517f
C4016 a_26985_519# VDD 0.29292f
C4017 a_6717_16869# a_4350_16071# 0.02479f
C4018 a_17683_16869# a_17791_16869# 0.01163f
C4019 a_7390_16071# a_8808_16071# 0.38994f
C4020 a_15545_16071# a_15755_16071# 0.09424f
C4021 a_18117_14024# a_18585_13226# 0.2079f
C4022 a_8237_14024# a_7803_14024# 0.6972f
C4023 a_11277_14024# a_10430_13226# 0.08038f
C4024 a_24523_14024# a_24631_14024# 0.01163f
C4025 a_13470_13226# a_14964_13190# 0.28279f
C4026 a_14235_13226# a_14311_13190# 0.01194f
C4027 a_26185_13226# a_25630_13226# 0.03209f
C4028 a_4187_2434# a_24523_4687# 0.06492f
C4029 a_20397_7532# a_21157_7532# 0.03319f
C4030 a_6326_10280# a_5778_9057# 0.87712f
C4031 a_24957_7532# a_25528_6734# 0.10864f
C4032 a_6425_3889# a_6711_3853# 0.01885f
C4033 a_5731_3134# a_7673_1842# 0.01865f
C4034 a_17065_1044# a_16510_1044# 0.03209f
C4035 a_6913_16869# VDD 0.49427f
C4036 a_12715_16071# VDD 0.15406f
C4037 a_13106_11047# VDD 0.09231f
C4038 a_4871_5315# VDD 0.01806f
C4039 a_15545_6734# VDD 0.29962f
C4040 a_7477_1842# VDD 0.87102f
C4041 a_13368_1044# VDD 0.17274f
C4042 a_1721_3176# CHAN2_MUX_SEL2 0.01315f
C4043 a_1544_3134# CHAN2_MUX_SEL3 0.15976f
C4044 a_1256_3134# CHAN2_MUX_SEL4 0.65005f
C4045 VDD REF_DELAY_OUT_LAST 0.71332f
C4046 a_20397_16869# a_20723_16869# 0.01427f
C4047 a_24957_16869# a_25528_16071# 0.10864f
C4048 a_4187_2434# a_15403_14024# 0.06627f
C4049 a_24957_14024# a_25717_14024# 0.05851f
C4050 a_4187_2434# a_6913_4687# 0.11222f
C4051 a_6425_13226# a_6635_13226# 0.09424f
C4052 a_15837_7532# a_13470_6734# 0.02479f
C4053 a_11277_7532# a_11603_7532# 0.01427f
C4054 a_16033_4687# a_16597_4687# 0.0114f
C4055 a_19963_4687# a_19550_3889# 0.01012f
C4056 a_10843_1842# a_10951_2470# 0.01697f
C4057 a_20593_1842# a_20723_1842# 0.70845f
C4058 a_4763_1842# a_4871_1842# 0.01163f
C4059 a_19637_14024# VDD 0.87095f
C4060 a_2019_311# a_5731_289# 1.15781f
C4061 a_25630_1044# a_26985_519# 0.02195f
C4062 a_2297_12513# VDD 0.4659f
C4063 a_10083_4687# VDD 0.48468f
C4064 a_14751_8160# VDD 0.01806f
C4065 a_17351_3853# VDD 0.28637f
C4066 a_16108_5979# REF_MUX_SEL4 0.1283f
C4067 a_15964_5979# REF_MUX_OUT 0.01307f
C4068 a_4350_3889# CHAN2_MUX_SEL4 0.31434f
C4069 a_11473_16869# a_12037_16869# 0.0114f
C4070 a_4187_2434# a_19637_16869# 0.0414f
C4071 a_15837_16869# a_13470_16071# 0.02479f
C4072 a_18795_16071# a_18871_16035# 0.01194f
C4073 a_4187_2434# a_10517_7532# 0.0414f
C4074 a_15837_14024# a_16163_14024# 0.01427f
C4075 a_20397_14024# a_19550_13226# 0.08038f
C4076 a_4187_2434# a_19203_1842# 0.06627f
C4077 a_22243_7532# a_22351_8160# 0.01697f
C4078 a_16163_7532# a_16271_7532# 0.01163f
C4079 a_4437_7532# a_4324_6698# 0.05157f
C4080 a_5731_5979# a_13883_4687# 0.01539f
C4081 a_14025_6734# a_13470_6734# 0.03209f
C4082 a_6913_4687# a_7043_4687# 0.70845f
C4083 a_16597_4687# a_17065_3889# 0.19203f
C4084 a_9757_4687# a_10328_3889# 0.10864f
C4085 a_16108_3134# a_20723_1842# 0.01544f
C4086 a_12037_1842# a_11603_1842# 0.6972f
C4087 a_22873_16869# VDD 0.49298f
C4088 a_19448_1044# a_19550_1044# 0.37183f
C4089 a_13753_7532# VDD 0.49349f
C4090 a_5191_13190# VDD 0.28575f
C4091 a_1256_3889# VDD 0.48292f
C4092 a_21911_6698# VDD 0.2822f
C4093 a_23437_1842# VDD 0.87191f
C4094 a_4157_16340# CHAN0_DELAY_IN 0.50642f
C4095 a_14825_519# VDD 0.29292f
C4096 a_4437_16869# a_4324_16035# 0.05157f
C4097 a_16163_16869# a_16271_16869# 0.01163f
C4098 a_6913_14024# a_7477_14024# 0.0114f
C4099 a_5731_15316# a_14317_14024# 0.01319f
C4100 a_4187_2434# a_13019_11521# 0.02377f
C4101 a_23003_14024# a_23111_14024# 0.01163f
C4102 a_9757_14024# a_9751_13190# 0.02354f
C4103 a_23145_13226# a_23431_13190# 0.01885f
C4104 a_13306_11995# a_13592_11561# 0.41329f
C4105 a_6126_9506# a_9444_10280# 0.03029f
C4106 a_13019_11521# a_12943_11557# 0.03346f
C4107 a_12849_11557# a_14009_11568# 0.03525f
C4108 a_4187_2434# a_22873_4687# 0.11222f
C4109 a_1256_6734# a_2873_7085# 0.28892f
C4110 a_24957_7532# a_22590_6734# 0.02479f
C4111 a_19637_7532# a_19203_7532# 0.69698f
C4112 a_4157_4158# a_4324_3853# 0.02463f
C4113 a_24197_4687# a_24393_4687# 0.77122f
C4114 a_4905_3889# a_4350_3889# 0.03209f
C4115 a_5731_3134# a_5957_1842# 0.01644f
C4116 a_16108_3134# a_17865_3364# 0.29564f
C4117 a_4763_1842# a_4350_1044# 0.01012f
C4118 a_14025_1044# a_14311_1008# 0.01885f
C4119 a_7288_1044# a_7364_1008# 0.01176f
C4120 a_5197_16869# VDD 0.86919f
C4121 a_25391_14652# VDD 0.01806f
C4122 a_9751_16035# VDD 0.2822f
C4123 a_15108_11799# VDD 0.135f
C4124 a_4905_6734# VDD 0.3017f
C4125 a_26043_4687# VDD 0.5006f
C4126 a_4763_1842# VDD 0.49875f
C4127 a_10430_1044# VDD 0.88416f
C4128 CHAN0_MUX_SEL2 CHAN0_MUX_SEL3 3.21891f
C4129 CHAN0_MUX_SEL1 CHAN0_MUX_SEL4 0.03574f
C4130 a_19637_16869# a_19833_16869# 0.73897f
C4131 a_24957_16869# a_22590_16071# 0.02479f
C4132 a_4187_2434# a_13753_14024# 0.11222f
C4133 a_4187_2434# a_5197_4687# 0.04141f
C4134 a_4157_13495# a_4350_13226# 0.04624f
C4135 a_24197_14024# a_23763_14024# 0.6972f
C4136 a_4187_2434# a_26477_7532# 0.04182f
C4137 a_16108_12471# a_16851_12491# 0.06181f
C4138 a_13557_7532# a_13444_6698# 0.05157f
C4139 a_10517_7532# a_10713_7532# 0.73897f
C4140 a_16510_6734# a_18795_6734# 0.39036f
C4141 a_15077_4687# a_15837_4687# 0.02912f
C4142 a_18877_4687# a_19448_3889# 0.10864f
C4143 a_22590_3889# a_24951_3853# 0.26208f
C4144 a_9323_1842# a_9431_2470# 0.01697f
C4145 a_2297_331# a_2019_311# 0.04011f
C4146 a_16923_14024# VDD 0.4984f
C4147 a_8671_8160# VDD 0.02372f
C4148 a_26471_13190# VDD 0.28336f
C4149 a_8433_4687# VDD 0.55387f
C4150 a_14888_3889# VDD 0.17499f
C4151 a_13132_11110# DLL_RESETN 0.01689f
C4152 REF_CLK REF_MUX_SEL1 0.01858f
C4153 a_10517_16869# a_11277_16869# 0.01669f
C4154 a_4187_2434# a_16923_16869# 0.06627f
C4155 a_13557_16869# a_13444_16035# 0.05157f
C4156 a_15077_14024# a_15273_14024# 0.77122f
C4157 a_16510_16071# a_18004_16035# 0.28279f
C4158 a_4350_16071# a_5705_15546# 0.02005f
C4159 a_17275_16071# a_17351_16035# 0.01194f
C4160 a_4187_2434# a_7803_7532# 0.06627f
C4161 a_18877_14024# a_18871_13190# 0.02354f
C4162 a_4187_2434# a_17553_1842# 0.11169f
C4163 a_22590_13226# a_24875_13226# 0.39036f
C4164 a_14643_7532# a_14751_7532# 0.01163f
C4165 a_20723_7532# a_20831_8160# 0.01697f
C4166 a_5731_5979# a_12233_4687# 0.01872f
C4167 a_4350_6734# a_6711_6698# 0.26208f
C4168 a_10985_6734# a_11271_6698# 0.01885f
C4169 a_21625_3889# a_21835_3889# 0.09424f
C4170 a_9757_4687# a_7390_3889# 0.02479f
C4171 a_10713_1842# a_11277_1842# 0.0114f
C4172 a_16108_3134# a_19073_1842# 0.01872f
C4173 a_21157_16869# VDD 0.85889f
C4174 a_13883_1842# a_13470_1044# 0.01012f
C4175 a_17928_1044# a_18004_1008# 0.01176f
C4176 a_24665_13226# VDD 0.29742f
C4177 a_12037_7532# VDD 0.85889f
C4178 a_19448_6734# VDD 0.17274f
C4179 a_1544_16071# CHAN0_MUX_SEL1 0.1672f
C4180 a_1721_16422# CHAN0_MUX_SEL0 0.01315f
C4181 a_20723_1842# VDD 0.49684f
C4182 CHAN2_MUX_OUT CHAN3_DELAY_IN 0.05155f
C4183 a_27433_16869# a_27997_16869# 0.0114f
C4184 a_14643_16869# a_14751_16869# 0.01163f
C4185 a_5957_14024# a_6717_14024# 0.02912f
C4186 a_10985_16071# a_11195_16071# 0.09424f
C4187 a_4350_16071# a_6635_16071# 0.39036f
C4188 a_5731_15316# a_11603_14024# 0.01544f
C4189 a_4187_2434# a_21157_4687# 0.04152f
C4190 a_27563_14024# a_27671_14652# 0.01697f
C4191 a_21483_14024# a_21591_14024# 0.01163f
C4192 a_8237_14024# a_8884_13190# 0.02312f
C4193 a_10430_13226# a_12791_13190# 0.26208f
C4194 a_6854_11676# a_13132_11110# 0.01367f
C4195 a_13019_11521# a_12849_11557# 0.12838f
C4196 a_18313_7532# a_18877_7532# 0.0114f
C4197 a_22677_7532# a_22564_6698# 0.05157f
C4198 a_22873_4687# a_23003_4687# 0.70845f
C4199 a_27997_1842# a_27563_1842# 0.69646f
C4200 a_7477_1842# a_7945_1044# 0.19203f
C4201 a_19311_14652# VDD 0.01806f
C4202 a_7288_16071# VDD 0.17274f
C4203 a_13566_11525# VDD 0.09469f
C4204 a_2297_7085# VDD 0.46536f
C4205 a_24393_4687# VDD 0.71574f
C4206 a_17865_3364# VDD 0.29444f
C4207 a_7364_1008# VDD 0.28633f
C4208 a_4437_14024# CHAN1_DELAY_IN 0.05007f
C4209 a_4633_14024# CHAN0_MUX_SEL4 0.01287f
C4210 a_18313_16869# a_18443_16869# 0.70845f
C4211 a_4187_2434# a_12037_14024# 0.04141f
C4212 a_22677_16869# a_22564_16035# 0.05157f
C4213 a_19550_16071# a_20905_15546# 0.02165f
C4214 a_4187_2434# a_23763_7532# 0.06483f
C4215 a_22873_14024# a_23437_14024# 0.0114f
C4216 a_9193_7532# a_9323_7532# 0.70845f
C4217 a_14317_4687# a_13883_4687# 0.6972f
C4218 a_18877_4687# a_16510_3889# 0.02479f
C4219 a_22488_3889# a_22590_3889# 0.37183f
C4220 a_7803_1842# a_7911_2470# 0.01697f
C4221 a_18877_1842# a_19073_1842# 0.76914f
C4222 a_23003_1842# a_22590_1044# 0.01012f
C4223 a_1256_289# a_1721_331# 0.13421f
C4224 a_1544_1044# a_1721_1395# 0.38063f
C4225 a_15273_14024# VDD 0.49468f
C4226 a_24008_13226# VDD 0.17499f
C4227 a_27997_7532# VDD 0.76025f
C4228 a_6717_4687# VDD 0.88148f
C4229 a_11924_3853# VDD 0.28225f
C4230 a_3449_6021# REF_MUX_SEL4 0.05166f
C4231 a_4187_2434# a_15273_16869# 0.11222f
C4232 a_9757_16869# a_9323_16869# 0.6972f
C4233 a_13753_14024# a_13883_14024# 0.70845f
C4234 a_4187_2434# a_6153_7532# 0.11222f
C4235 a_17357_14024# a_18004_13190# 0.02312f
C4236 a_10430_13226# a_11785_12701# 0.02058f
C4237 a_14111_10917# a_15108_11015# 0.03012f
C4238 a_13306_10795# a_13880_10808# 0.31978f
C4239 a_4187_2434# a_15837_1842# 0.0414f
C4240 a_4248_6734# a_4350_6734# 0.37183f
C4241 a_19203_7532# a_19311_8160# 0.01697f
C4242 a_26477_7532# a_26673_7532# 0.76914f
C4243 a_13123_7532# a_13231_7532# 0.01163f
C4244 a_5197_4687# a_5393_4687# 0.76914f
C4245 a_7477_4687# a_7364_3853# 0.05157f
C4246 a_5731_5979# a_10517_4687# 0.01314f
C4247 a_10328_3889# a_10404_3853# 0.01176f
C4248 a_12797_1842# a_13368_1044# 0.10864f
C4249 a_16108_3134# a_17357_1842# 0.01319f
C4250 a_21157_1842# a_21625_1044# 0.2079f
C4251 a_9757_1842# a_10517_1842# 0.05851f
C4252 a_18443_16869# VDD 0.4973f
C4253 a_16510_1044# a_16484_1008# 0.277f
C4254 a_12505_13226# VDD 0.29742f
C4255 a_1256_15316# VDD 0.4205f
C4256 a_16510_6734# VDD 1.0321f
C4257 a_9323_7532# VDD 0.49742f
C4258 a_19073_1842# VDD 0.49655f
C4259 a_1721_331# VDD 0.45259f
C4260 a_1721_12513# CHAN1_MUX_SEL2 0.01315f
C4261 a_1256_12471# CHAN1_MUX_SEL4 0.65005f
C4262 a_1544_12471# CHAN1_MUX_SEL3 0.15976f
C4263 a_4187_2434# a_27997_14024# 0.04001f
C4264 a_13123_16869# a_13231_16869# 0.01163f
C4265 a_26477_16869# a_27237_16869# 0.03319f
C4266 a_5197_14024# a_4763_14024# 0.6972f
C4267 a_7477_14024# a_7390_13226# 0.1088f
C4268 a_4187_2434# a_18443_4687# 0.06627f
C4269 a_26043_14024# a_26151_14652# 0.01697f
C4270 a_10328_13226# a_10430_13226# 0.37183f
C4271 a_19963_14024# a_20071_14024# 0.01163f
C4272 a_17357_7532# a_18117_7532# 0.02973f
C4273 a_21917_4687# a_22243_4687# 0.01427f
C4274 a_25630_6734# a_27991_6698# 0.26208f
C4275 a_5731_3134# a_11785_3364# 0.28056f
C4276 a_5957_1842# a_6425_1044# 0.2079f
C4277 a_26673_1842# a_27237_1842# 0.0114f
C4278 a_4350_1044# a_5115_1044# 0.39037f
C4279 a_4350_16071# VDD 0.87635f
C4280 a_12355_11557# VDD 0.38057f
C4281 a_13231_14652# VDD 0.01806f
C4282 a_22677_4687# VDD 0.87103f
C4283 a_5115_1044# VDD 0.15389f
C4284 a_15964_15316# CHAN0_MUX_OUT 0.01307f
C4285 a_4350_13226# CHAN1_MUX_SEL4 0.31434f
C4286 a_16108_15316# CHAN0_MUX_SEL4 0.1283f
C4287 a_12797_7532# DLL_RESETN 0.0106f
C4288 a_12797_4687# CHAN2_MUX_SEL4 0.01829f
C4289 a_4187_2434# a_9323_14024# 0.06627f
C4290 a_25630_16071# a_27915_16071# 0.39036f
C4291 a_21917_14024# a_22677_14024# 0.06198f
C4292 a_4187_2434# a_22113_7532# 0.11286f
C4293 a_26477_14024# a_27124_13190# 0.02312f
C4294 a_8237_7532# a_8563_7532# 0.01427f
C4295 a_12037_7532# a_10430_6734# 0.05231f
C4296 a_26185_6734# a_26471_6698# 0.01885f
C4297 a_11277_7532# a_11271_6698# 0.02349f
C4298 a_12993_4687# a_13557_4687# 0.0114f
C4299 a_16108_5979# a_23633_4687# 0.01872f
C4300 a_16597_4687# a_16484_3853# 0.05157f
C4301 a_20968_3889# a_21044_3853# 0.01176f
C4302 a_17553_1842# a_17683_1842# 0.70361f
C4303 a_6283_1842# a_6391_2470# 0.01697f
C4304 a_21917_1842# a_22488_1044# 0.10864f
C4305 a_23871_17497# VDD 0.01806f
C4306 a_13557_14024# VDD 0.87095f
C4307 a_21044_13190# VDD 0.28225f
C4308 a_4003_4687# VDD 0.61691f
C4309 a_25283_7532# VDD 0.48141f
C4310 a_9675_3889# VDD 0.15407f
C4311 a_24631_2470# VDD 0.02023f
C4312 a_14009_11568# REF_CLK 0.25847f
C4313 a_3449_4240# CHAN2_MUX_SEL1 0.29404f
C4314 a_14825_519# CHAN3_MUX_SEL4 0.03307f
C4315 a_4187_2434# a_13557_16869# 0.0414f
C4316 a_8433_16869# a_8997_16869# 0.0114f
C4317 a_12037_16869# a_10430_16071# 0.05231f
C4318 a_13470_16071# a_15831_16035# 0.26208f
C4319 a_26185_16071# a_26395_16071# 0.09424f
C4320 a_11277_16869# a_11271_16035# 0.02349f
C4321 a_16108_15316# a_23003_14024# 0.01539f
C4322 a_12797_14024# a_13123_14024# 0.01427f
C4323 a_4187_2434# a_4437_7532# 0.04193f
C4324 a_16597_14024# a_16510_13226# 0.1088f
C4325 a_13306_10795# a_14111_10917# 0.097f
C4326 a_25153_7532# a_25283_7532# 0.70361f
C4327 a_17683_7532# a_17791_8160# 0.01697f
C4328 a_4187_2434# a_13123_1842# 0.06627f
C4329 a_11603_7532# a_11711_7532# 0.01163f
C4330 a_13592_11113# a_14009_10774# 0.3749f
C4331 a_5731_5979# a_7803_4687# 0.01539f
C4332 a_8997_1842# a_8563_1842# 0.6972f
C4333 a_17065_3889# a_17275_3889# 0.09424f
C4334 a_12797_1842# a_10430_1044# 0.02479f
C4335 a_25630_16071# VDD 0.90165f
C4336 a_16793_16869# VDD 0.54038f
C4337 a_7673_7532# VDD 0.49303f
C4338 a_3449_13577# VDD 0.46731f
C4339 a_13444_6698# VDD 0.28633f
C4340 a_17357_1842# VDD 0.8702f
C4341 a_26395_1044# VDD 0.1539f
C4342 a_15108_11015# REF_DELAY_OUT_LAST 0.01399f
C4343 a_10430_1044# CHAN3_MUX_SEL4 0.24983f
C4344 REF_MUX_OUT CHAN2_DELAY_IN 0.05155f
C4345 a_11603_16869# a_11711_16869# 0.01163f
C4346 a_25717_16869# a_25283_16869# 0.69698f
C4347 a_4187_2434# a_25283_14024# 0.06391f
C4348 a_24523_14024# a_24631_14652# 0.01697f
C4349 a_18443_14024# a_18551_14024# 0.01163f
C4350 a_5731_15316# a_8237_14024# 0.01319f
C4351 a_4187_2434# a_16793_4687# 0.11113f
C4352 a_8808_13226# a_8884_13190# 0.01176f
C4353 a_11748_11799# a_12158_11557# 0.10373f
C4354 a_18585_13226# a_16510_13226# 0.03208f
C4355 a_16597_7532# a_16163_7532# 0.69698f
C4356 a_21157_7532# a_19550_6734# 0.05231f
C4357 a_20397_7532# a_20391_6698# 0.02349f
C4358 a_25528_6734# a_25630_6734# 0.37183f
C4359 a_21157_4687# a_21353_4687# 0.77122f
C4360 a_25717_4687# a_25604_3853# 0.05157f
C4361 a_25717_1842# a_26477_1842# 0.01669f
C4362 a_9465_1044# a_7390_1044# 0.03208f
C4363 a_4437_1842# a_4157_1313# 0.01771f
C4364 a_20105_16071# VDD 0.30409f
C4365 a_7151_14652# VDD 0.01806f
C4366 a_19963_4687# VDD 0.50058f
C4367 a_23145_1044# VDD 0.30411f
C4368 a_16597_16869# a_16793_16869# 0.73897f
C4369 a_20397_16869# a_20391_16035# 0.02349f
C4370 a_4187_2434# a_7673_14024# 0.11222f
C4371 a_21157_16869# a_19550_16071# 0.05231f
C4372 a_21157_14024# a_20723_14024# 0.6972f
C4373 a_4187_2434# a_20397_7532# 0.04176f
C4374 a_25717_14024# a_25630_13226# 0.1088f
C4375 a_9757_7532# a_10404_6698# 0.02011f
C4376 a_7477_7532# a_7673_7532# 0.73897f
C4377 a_13368_6734# a_13444_6698# 0.01176f
C4378 a_12037_4687# a_12797_4687# 0.02912f
C4379 a_16108_5979# a_21917_4687# 0.01307f
C4380 a_19550_3889# a_19524_3853# 0.277f
C4381 a_7390_3889# a_5731_3134# 0.41141f
C4382 a_4763_1842# a_4871_2470# 0.01697f
C4383 a_21917_1842# a_19550_1044# 0.02479f
C4384 a_25630_1044# a_26395_1044# 0.39037f
C4385 a_16510_1044# a_16108_289# 0.56108f
C4386 a_17791_17497# VDD 0.01806f
C4387 a_10843_14024# VDD 0.50058f
C4388 a_18795_13226# VDD 0.15407f
C4389 a_23633_7532# VDD 0.49454f
C4390 a_15964_5979# VDD 0.42016f
C4391 a_6711_3853# VDD 0.2822f
C4392 a_4187_2434# CHAN0_MUX_OUT 1.24279f
C4393 a_18551_2470# VDD 0.01806f
C4394 a_13019_11521# REF_CLK 0.35409f
C4395 a_13121_11521# DLL_RESETN 0.04337f
C4396 a_1256_3889# CHAN2_MUX_SEL4 0.04785f
C4397 a_7477_16869# a_8237_16869# 0.01669f
C4398 a_4187_2434# a_10843_16869# 0.06627f
C4399 a_9757_16869# a_10404_16035# 0.02011f
C4400 a_13368_16071# a_13470_16071# 0.37183f
C4401 a_16108_15316# a_21353_14024# 0.01872f
C4402 a_12037_14024# a_12233_14024# 0.77122f
C4403 a_19448_13226# a_19524_13190# 0.01176f
C4404 a_12907_11110# a_13132_11110# 0.02416f
C4405 a_4187_2434# a_11473_1842# 0.11222f
C4406 a_16163_7532# a_16271_8160# 0.01697f
C4407 a_10083_7532# a_10191_7532# 0.01163f
C4408 a_16108_5979# a_23945_6209# 0.2906f
C4409 a_5731_5979# a_6153_4687# 0.02026f
C4410 a_4905_6734# a_5115_6734# 0.09424f
C4411 a_5957_4687# a_4350_3889# 0.05231f
C4412 a_5197_4687# a_5191_3853# 0.02349f
C4413 a_7390_3889# a_8155_3889# 0.39037f
C4414 a_7673_1842# a_8237_1842# 0.0114f
C4415 a_15077_16869# VDD 0.86022f
C4416 a_13470_1044# a_14311_1008# 0.28268f
C4417 a_10517_1842# a_10404_1008# 0.05157f
C4418 a_22564_16035# VDD 0.28633f
C4419 a_5957_7532# VDD 0.85889f
C4420 a_11195_6734# VDD 0.15389f
C4421 a_14643_1842# VDD 0.4969f
C4422 a_23431_1008# VDD 0.28336f
C4423 a_27997_4687# CHAN2_DELAY_OUT_LAST 0.70955f
C4424 a_4763_1842# CHAN2_MUX_SEL4 0.01225f
C4425 a_24393_16869# a_24957_16869# 0.0114f
C4426 a_10083_16869# a_10191_16869# 0.01163f
C4427 a_5731_15316# a_5523_14024# 0.01562f
C4428 a_6425_16071# a_4350_16071# 0.03208f
C4429 a_16108_15316# a_20905_15546# 0.2906f
C4430 a_4187_2434# a_23633_14024# 0.11222f
C4431 a_23003_14024# a_23111_14652# 0.01697f
C4432 a_16923_14024# a_17031_14024# 0.01163f
C4433 a_7390_13226# a_7364_13190# 0.277f
C4434 a_6854_11676# a_13121_11521# 0.10056f
C4435 a_10232_11561# a_10751_11568# 0.34102f
C4436 a_10649_11568# a_10520_11982# 0.01562f
C4437 a_4187_2434# a_15077_4687# 0.04194f
C4438 a_15273_7532# a_15837_7532# 0.0114f
C4439 a_18877_7532# a_19524_6698# 0.02011f
C4440 a_24008_6734# a_24084_6698# 0.01176f
C4441 a_19833_4687# a_19963_4687# 0.70845f
C4442 a_24957_1842# a_24523_1842# 0.6972f
C4443 a_26803_14024# VDD 0.49718f
C4444 a_7945_16071# VDD 0.30409f
C4445 a_9746_11495# VDD 0.0935f
C4446 a_18313_4687# VDD 0.49462f
C4447 a_10985_1044# VDD 0.30411f
C4448 a_27991_3853# VDD 0.28273f
C4449 a_3449_15358# CHAN0_MUX_SEL4 0.05166f
C4450 a_15273_16869# a_15403_16869# 0.70845f
C4451 a_4187_2434# a_26803_16869# 0.06627f
C4452 a_13470_16071# a_14825_15546# 0.02058f
C4453 a_4187_2434# a_5957_14024# 0.04141f
C4454 a_18877_16869# a_19524_16035# 0.02011f
C4455 a_19833_14024# a_20397_14024# 0.0114f
C4456 a_4187_2434# a_17683_7532# 0.06497f
C4457 a_4187_2434# a_27433_1842# 0.11222f
C4458 a_6153_7532# a_6283_7532# 0.70845f
C4459 a_8997_7532# a_8884_6698# 0.02055f
C4460 a_11277_4687# a_10843_4687# 0.6972f
C4461 a_16108_5979# a_19203_4687# 0.01539f
C4462 a_15077_4687# a_13470_3889# 0.05231f
C4463 a_14317_4687# a_14311_3853# 0.02349f
C4464 a_15837_1842# a_16033_1842# 0.76914f
C4465 a_19637_1842# a_19524_1008# 0.05157f
C4466 a_11711_17497# VDD 0.01806f
C4467 a_9193_14024# VDD 0.49584f
C4468 a_21917_7532# VDD 0.87825f
C4469 a_15831_13190# VDD 0.2816f
C4470 a_8745_6209# VDD 0.29714f
C4471 a_4248_3889# VDD 0.17587f
C4472 a_12471_2470# VDD 0.01806f
C4473 a_11748_11799# REF_CLK 0.0148f
C4474 a_11491_11918# DLL_RESETN 0.14622f
C4475 a_1721_331# CHAN3_MUX_SEL4 0.05813f
C4476 a_2873_331# CHAN3_MUX_SEL2 0.01422f
C4477 a_1544_289# CHAN3_MUX_OUT 0.69943f
C4478 VDD CHAN1_MUX_SEL3 0.41538f
C4479 a_2297_331# CHAN3_MUX_SEL3 0.01595f
C4480 a_8997_16869# a_8884_16035# 0.02055f
C4481 a_4187_2434# a_9193_16869# 0.11222f
C4482 a_6717_16869# a_6283_16869# 0.6972f
C4483 a_16108_15316# a_19637_14024# 0.01314f
C4484 a_11848_16071# a_11924_16035# 0.01176f
C4485 a_10713_14024# a_10843_14024# 0.70845f
C4486 a_21625_16071# a_21911_16035# 0.01885f
C4487 a_4350_13226# a_5731_12471# 0.41099f
C4488 a_13019_11521# a_15464_9374# 0.59875f
C4489 a_4187_2434# a_9757_1842# 0.04038f
C4490 a_14643_7532# a_14751_8160# 0.01697f
C4491 a_8563_7532# a_8671_7532# 0.01163f
C4492 a_23437_7532# a_23633_7532# 0.76914f
C4493 a_12505_3889# a_12791_3853# 0.01885f
C4494 a_6717_1842# a_7477_1842# 0.06198f
C4495 a_5731_3134# a_13123_1842# 0.01539f
C4496 a_12715_1044# a_12791_1008# 0.01194f
C4497 a_12363_16869# VDD 0.4973f
C4498 a_24665_1044# a_22590_1044# 0.03208f
C4499 a_20315_16071# VDD 0.15389f
C4500 a_9712_9602# VDD 0.21563f
C4501 a_22351_5315# VDD 0.01806f
C4502 a_8231_6698# VDD 0.28357f
C4503 a_12993_1842# VDD 0.49655f
C4504 a_20968_1044# VDD 0.17499f
C4505 a_12797_14024# CHAN1_MUX_SEL4 0.01829f
C4506 a_16851_3154# CHAN2_MUX_OUT 0.45865f
C4507 a_23437_16869# a_24197_16869# 0.03319f
C4508 a_8563_16869# a_8671_16869# 0.01163f
C4509 a_4187_2434# a_21917_14024# 0.0414f
C4510 a_12505_13226# a_12715_13226# 0.09424f
C4511 a_4187_2434# a_12363_4687# 0.06627f
C4512 a_21483_14024# a_21591_14652# 0.01697f
C4513 a_15403_14024# a_15511_14024# 0.01163f
C4514 a_9946_11995# a_10206_11525# 0.75507f
C4515 a_18117_7532# a_18004_6698# 0.02055f
C4516 a_14317_7532# a_15077_7532# 0.03319f
C4517 a_18877_4687# a_19203_4687# 0.01427f
C4518 a_22590_6734# a_22564_6698# 0.277f
C4519 a_13470_6734# a_5731_5979# 0.41365f
C4520 a_24197_4687# a_22590_3889# 0.05231f
C4521 a_23437_4687# a_23431_3853# 0.02349f
C4522 a_1256_3889# a_2297_4240# 0.04619f
C4523 a_1256_3134# a_2873_3176# 0.27926f
C4524 a_22590_3889# a_16108_3134# 0.55709f
C4525 a_23633_1842# a_24197_1842# 0.0114f
C4526 a_1544_3134# a_2297_3176# 0.27303f
C4527 a_2873_16422# VDD 0.46517f
C4528 a_15964_289# a_16108_289# 0.42202f
C4529 a_25153_14024# VDD 0.49638f
C4530 a_26985_12701# VDD 0.29292f
C4531 a_16597_4687# VDD 0.94763f
C4532 a_25528_3889# VDD 0.17274f
C4533 a_3449_13577# CHAN1_MUX_SEL1 0.29404f
C4534 a_6717_4687# CHAN2_MUX_SEL4 0.0195f
C4535 a_4187_2434# a_25153_16869# 0.11169f
C4536 a_18117_16869# a_18004_16035# 0.02055f
C4537 a_14317_16869# a_14643_16869# 0.01427f
C4538 a_18877_14024# a_19637_14024# 0.06198f
C4539 a_22488_16071# a_22564_16035# 0.01176f
C4540 a_4187_2434# a_16033_7532# 0.11234f
C4541 a_5197_7532# a_5523_7532# 0.01427f
C4542 a_1544_12471# a_1721_12513# 0.36963f
C4543 a_1256_12471# a_2297_12513# 0.04261f
C4544 a_4187_2434# a_25717_1842# 0.04049f
C4545 a_13557_7532# a_14025_6734# 0.19203f
C4546 a_8237_7532# a_7390_6734# 0.08038f
C4547 a_21625_6734# a_19550_6734# 0.03208f
C4548 a_10430_6734# a_11195_6734# 0.39037f
C4549 a_9953_4687# a_10517_4687# 0.0114f
C4550 a_12797_4687# a_13444_3853# 0.02011f
C4551 a_16510_3889# a_17351_3853# 0.28268f
C4552 a_27563_4687# a_27671_4687# 0.01163f
C4553 a_14513_1842# a_14643_1842# 0.70845f
C4554 a_5631_17497# VDD 0.01806f
C4555 a_22590_1044# a_24008_1044# 0.38994f
C4556 a_13368_13226# VDD 0.17274f
C4557 a_7477_14024# VDD 0.87107f
C4558 a_19203_7532# VDD 0.49737f
C4559 a_2873_6021# VDD 0.46598f
C4560 a_18585_3889# VDD 0.29742f
C4561 a_6391_2470# VDD 0.01806f
C4562 VDD CHAN0_MUX_SEL3 0.421f
C4563 a_4187_2434# a_7477_16869# 0.0414f
C4564 a_5393_16869# a_5957_16869# 0.0114f
C4565 a_13557_16869# a_14025_16071# 0.19203f
C4566 a_26803_16869# a_26911_17497# 0.01697f
C4567 a_8237_16869# a_7390_16071# 0.08038f
C4568 a_20105_16071# a_19550_16071# 0.03209f
C4569 a_10430_16071# a_10404_16035# 0.277f
C4570 a_16108_15316# a_16923_14024# 0.01073f
C4571 a_16510_13226# a_17275_13226# 0.39037f
C4572 a_4187_2434# a_7043_1842# 0.06627f
C4573 a_14111_11568# a_15304_10295# 0.01811f
C4574 a_27237_7532# a_27124_6698# 0.02055f
C4575 a_13123_7532# a_13231_8160# 0.01697f
C4576 a_7043_7532# a_7151_7532# 0.01163f
C4577 a_22113_7532# a_22243_7532# 0.70845f
C4578 a_27237_4687# a_26803_4687# 0.6972f
C4579 a_5731_5979# a_15765_6153# 0.23301f
C4580 a_10985_3889# a_10430_3889# 0.03209f
C4581 a_4350_3889# a_5768_3889# 0.38994f
C4582 a_8997_1842# a_7390_1044# 0.05231f
C4583 a_8237_1842# a_8231_1008# 0.02349f
C4584 a_5731_3134# a_11473_1842# 0.01872f
C4585 a_5957_1842# a_5523_1842# 0.6972f
C4586 a_10430_1044# a_11924_1008# 0.28279f
C4587 a_10713_16869# VDD 0.49294f
C4588 a_11195_1044# a_11271_1008# 0.01194f
C4589 a_17351_16035# VDD 0.28637f
C4590 a_5768_6734# VDD 0.17499f
C4591 a_16271_5315# VDD 0.02023f
C4592 a_11277_1842# VDD 0.87175f
C4593 a_18004_1008# VDD 0.28225f
C4594 a_2873_7085# REF_MUX_SEL1 0.13092f
C4595 CHAN1_MUX_OUT REF_CLK 0.07706f
C4596 VDD CHAN3_DELAY_IN 1.50408f
C4597 a_27237_16869# a_27124_16035# 0.02055f
C4598 a_4187_2434# a_19203_14024# 0.06627f
C4599 a_22677_16869# a_22243_16869# 0.69698f
C4600 a_7043_16869# a_7151_16869# 0.01163f
C4601 a_5731_15316# a_14825_15546# 0.28056f
C4602 a_26673_14024# a_26803_14024# 0.70845f
C4603 a_4350_13226# a_5191_13190# 0.28268f
C4604 a_13883_14024# a_13991_14024# 0.01163f
C4605 a_4187_2434# a_10713_4687# 0.11222f
C4606 a_19963_14024# a_20071_14652# 0.01697f
C4607 a_9547_11632# a_9746_11495# 0.14994f
C4608 a_13557_7532# a_13123_7532# 0.69698f
C4609 a_27237_7532# a_27705_6734# 0.2079f
C4610 a_17357_7532# a_16510_6734# 0.08038f
C4611 a_18117_4687# a_18313_4687# 0.77122f
C4612 a_21917_4687# a_22564_3853# 0.02011f
C4613 a_22677_1842# a_23437_1842# 0.01669f
C4614 a_1256_16071# VDD 0.48292f
C4615 a_21917_1842# a_16108_289# 0.0157f
C4616 a_14825_12701# VDD 0.29292f
C4617 a_23437_14024# VDD 0.87191f
C4618 a_26151_8160# VDD 0.01806f
C4619 a_13883_4687# VDD 0.50058f
C4620 a_22590_3889# VDD 1.09883f
C4621 a_1721_1395# VDD 0.4533f
C4622 a_1256_13226# CHAN1_MUX_SEL4 0.04785f
C4623 a_4437_7532# REF_CLK 0.05209f
C4624 a_4187_2434# a_23437_16869# 0.04141f
C4625 a_13557_16869# a_13753_16869# 0.73897f
C4626 a_17357_16869# a_16510_16071# 0.08038f
C4627 a_27237_16869# a_27705_16071# 0.2079f
C4628 a_10430_16071# a_5731_15316# 0.41176f
C4629 a_18117_14024# a_17683_14024# 0.6972f
C4630 a_4187_2434# a_14317_7532# 0.04317f
C4631 a_19550_13226# a_16108_12471# 0.58202f
C4632 a_4187_2434# a_23003_1842# 0.06627f
C4633 a_4437_7532# a_4633_7532# 0.73897f
C4634 a_6717_7532# a_6711_6698# 0.02354f
C4635 a_8997_4687# a_9757_4687# 0.02912f
C4636 a_26043_4687# a_26151_4687# 0.01163f
C4637 a_12037_4687# a_11924_3853# 0.02055f
C4638 a_27705_3889# a_27991_3853# 0.01885f
C4639 a_15755_3889# a_15831_3853# 0.01194f
C4640 a_17357_1842# a_17351_1008# 0.02349f
C4641 a_18117_1842# a_16510_1044# 0.05231f
C4642 a_16108_3134# a_24523_1842# 0.01361f
C4643 a_26673_16869# VDD 0.49417f
C4644 a_10430_13226# VDD 0.88416f
C4645 a_4763_14024# VDD 0.49875f
C4646 a_27048_6734# VDD 0.17499f
C4647 a_17553_7532# VDD 0.49346f
C4648 a_27237_1842# VDD 0.86278f
C4649 a_27997_14024# CHAN1_DELAY_OUT_LAST 0.70955f
C4650 a_6854_11676# DLL_RESETN 0.50331f
C4651 a_4437_16869# a_5197_16869# 0.01669f
C4652 a_4187_2434# a_4763_16869# 0.06627f
C4653 a_17065_16071# a_17351_16035# 0.01885f
C4654 a_25283_16869# a_25391_17497# 0.01697f
C4655 a_6717_16869# a_6711_16035# 0.02354f
C4656 a_8997_14024# a_9193_14024# 0.77122f
C4657 a_27705_13226# a_27915_13226# 0.09424f
C4658 a_12363_14024# a_10430_13226# 0.01012f
C4659 a_19637_14024# a_20105_13226# 0.19203f
C4660 a_4187_2434# a_26673_4687# 0.11222f
C4661 a_11603_7532# a_11711_8160# 0.01697f
C4662 a_14009_11568# a_14757_11918# 0.01058f
C4663 a_4187_2434# a_5393_1842# 0.11222f
C4664 a_6854_11144# a_5864_9057# 0.03661f
C4665 a_13880_11982# a_14111_11568# 0.12701f
C4666 a_5523_7532# a_5631_7532# 0.01163f
C4667 a_26477_7532# a_25630_6734# 0.08038f
C4668 a_25913_4687# a_26477_4687# 0.0114f
C4669 a_4633_1842# a_5197_1842# 0.0114f
C4670 a_7945_3889# a_8231_3853# 0.01885f
C4671 a_6717_1842# a_7364_1008# 0.02011f
C4672 a_14888_16071# VDD 0.17499f
C4673 a_18585_1044# a_18795_1044# 0.09424f
C4674 a_8997_16869# VDD 0.88798f
C4675 a_14009_10774# VDD 0.31815f
C4676 a_26185_6734# VDD 0.30409f
C4677 a_10191_5315# VDD 0.01806f
C4678 a_8563_1842# VDD 0.95442f
C4679 a_15755_1044# VDD 0.15389f
C4680 a_1544_6734# REF_MUX_SEL0 0.07603f
C4681 a_1256_6734# REF_MUX_SEL1 1.44243f
C4682 VDD CHAN2_DELAY_IN 1.50899f
C4683 a_5523_16869# a_5631_16869# 0.01163f
C4684 a_21353_16869# a_21917_16869# 0.0114f
C4685 a_26477_16869# a_25630_16071# 0.08038f
C4686 a_4187_2434# a_17553_14024# 0.11169f
C4687 a_18443_14024# a_18551_14652# 0.01697f
C4688 a_4437_14024# a_4905_13226# 0.19203f
C4689 a_12363_14024# a_12471_14024# 0.01163f
C4690 a_4187_2434# a_8997_4687# 0.04106f
C4691 a_5974_11413# a_6126_9506# 1.74589f
C4692 a_6326_10280# a_6854_11144# 1.25181f
C4693 a_7945_13226# a_8155_13226# 0.09424f
C4694 a_12233_7532# a_12797_7532# 0.0114f
C4695 a_19550_6734# a_20391_6698# 0.28268f
C4696 a_15837_7532# a_15831_6698# 0.02354f
C4697 a_16793_4687# a_16923_4687# 0.70845f
C4698 a_21157_4687# a_21044_3853# 0.02055f
C4699 a_25630_3889# a_27048_3889# 0.38994f
C4700 a_16510_3889# a_17865_3364# 0.02165f
C4701 a_26477_1842# a_26471_1008# 0.02349f
C4702 a_21917_1842# a_21483_1842# 0.6972f
C4703 a_27237_1842# a_25630_1044# 0.05253f
C4704 a_20723_14024# VDD 0.49684f
C4705 a_12233_4687# VDD 0.4946f
C4706 a_20071_8160# VDD 0.01806f
C4707 a_19524_3853# VDD 0.28633f
C4708 a_4003_4687# REF_MUX_SEL4 0.01225f
C4709 a_4187_2434# a_20723_16869# 0.06627f
C4710 a_12233_16869# a_12363_16869# 0.70845f
C4711 a_7390_16071# a_8745_15546# 0.01627f
C4712 a_19550_16071# a_20315_16071# 0.39037f
C4713 a_15837_16869# a_15831_16035# 0.02354f
C4714 a_16793_14024# a_17357_14024# 0.0114f
C4715 a_4187_2434# a_11603_7532# 0.06627f
C4716 a_21483_14024# a_19550_13226# 0.01012f
C4717 a_25630_13226# a_26471_13190# 0.28268f
C4718 a_16510_13226# a_16851_12491# 0.02131f
C4719 a_4187_2434# a_21353_1842# 0.11222f
C4720 a_5197_7532# a_5844_6698# 0.02312f
C4721 a_7390_6734# a_8808_6734# 0.38994f
C4722 a_15545_6734# a_15755_6734# 0.09424f
C4723 a_24523_4687# a_24631_4687# 0.01163f
C4724 a_11277_4687# a_10430_3889# 0.08038f
C4725 a_18117_4687# a_18585_3889# 0.2079f
C4726 a_8237_4687# a_7803_4687# 0.6972f
C4727 a_13470_3889# a_14964_3853# 0.28279f
C4728 a_14235_3889# a_14311_3853# 0.01194f
C4729 a_26185_3889# a_25630_3889# 0.03209f
C4730 a_12797_1842# a_12993_1842# 0.76914f
C4731 a_16108_3134# a_22873_1842# 0.01865f
C4732 a_15837_1842# a_16484_1008# 0.02011f
C4733 a_17865_15546# VDD 0.29444f
C4734 a_24957_16869# VDD 0.87948f
C4735 a_19550_1044# a_21835_1044# 0.39036f
C4736 a_15837_7532# VDD 0.88209f
C4737 a_7364_13190# VDD 0.28633f
C4738 a_24084_6698# VDD 0.28297f
C4739 a_24523_1842# VDD 0.91084f
C4740 a_23945_519# VDD 0.29329f
C4741 a_16851_12491# CHAN1_MUX_OUT 0.45865f
C4742 a_5197_16869# a_5844_16035# 0.02312f
C4743 a_23763_16869# a_23871_17497# 0.01697f
C4744 a_7390_16071# a_8231_16035# 0.28268f
C4745 a_7673_14024# a_7803_14024# 0.70845f
C4746 a_5731_15316# a_15403_14024# 0.01563f
C4747 a_4187_2434# a_24957_4687# 0.0414f
C4748 a_13121_11521# a_15688_11557# 0.17255f
C4749 a_12849_11557# a_14851_11918# 0.13392f
C4750 a_13470_13226# a_14888_13226# 0.38994f
C4751 a_4003_7532# a_4111_7532# 0.01163f
C4752 a_20397_7532# a_20593_7532# 0.76914f
C4753 a_10083_7532# a_10191_8160# 0.01697f
C4754 a_24957_7532# a_24951_6698# 0.02354f
C4755 a_24957_4687# a_25717_4687# 0.05851f
C4756 a_5731_3134# a_7043_1842# 0.01539f
C4757 a_6425_3889# a_6635_3889# 0.09424f
C4758 a_6283_16869# VDD 0.4973f
C4759 a_7390_1044# a_9751_1008# 0.26208f
C4760 a_5957_1842# a_5844_1008# 0.02055f
C4761 a_11924_16035# VDD 0.28225f
C4762 a_4111_5315# VDD 0.01866f
C4763 a_14025_6734# VDD 0.30409f
C4764 a_6913_1842# VDD 0.49656f
C4765 a_6717_14024# CHAN1_MUX_SEL4 0.0195f
C4766 a_12791_1008# VDD 0.2822f
C4767 a_1544_3134# CHAN2_MUX_SEL2 0.07405f
C4768 a_1256_3134# CHAN2_MUX_SEL3 1.41161f
C4769 a_3449_3176# CHAN2_DELAY_IN 0.01017f
C4770 a_4003_16869# a_4111_16869# 0.01163f
C4771 a_20397_16869# a_21157_16869# 0.03319f
C4772 a_25630_16071# a_16108_15316# 0.52614f
C4773 a_24957_16869# a_24951_16035# 0.02354f
C4774 a_4187_2434# a_15837_14024# 0.0414f
C4775 a_10843_14024# a_10951_14024# 0.01163f
C4776 a_16923_14024# a_17031_14652# 0.01697f
C4777 a_4187_2434# a_27563_7532# 0.06663f
C4778 a_24957_14024# a_25153_14024# 0.74845f
C4779 a_4187_2434# a_6283_4687# 0.06627f
C4780 a_11277_7532# a_12037_7532# 0.03319f
C4781 a_14317_7532# a_14964_6698# 0.02312f
C4782 a_18795_6734# a_18871_6698# 0.01194f
C4783 a_20397_4687# a_19550_3889# 0.08038f
C4784 a_15837_4687# a_16163_4687# 0.01427f
C4785 a_20593_1842# a_21157_1842# 0.0114f
C4786 a_24957_1842# a_25604_1008# 0.02011f
C4787 a_5705_519# a_5731_289# 0.28954f
C4788 a_19073_14024# VDD 0.49655f
C4789 a_1721_12513# VDD 0.45352f
C4790 a_10517_4687# VDD 0.87102f
C4791 a_13991_8160# VDD 0.01806f
C4792 a_17275_3889# VDD 0.15389f
C4793 a_9444_10280# DLL_RESETN 0.09163f
C4794 a_15964_5979# REF_MUX_SEL4 0.5544f
C4795 a_14317_16869# a_14964_16035# 0.02312f
C4796 a_4187_2434# a_19073_16869# 0.11222f
C4797 a_11277_16869# a_11603_16869# 0.01427f
C4798 a_4187_2434# a_9953_7532# 0.11076f
C4799 a_15837_14024# a_16597_14024# 0.06198f
C4800 a_24875_13226# a_24951_13190# 0.01194f
C4801 a_4187_2434# a_19637_1842# 0.0414f
C4802 a_4437_7532# a_4350_6734# 0.1088f
C4803 a_5731_5979# a_14317_4687# 0.01319f
C4804 a_6913_4687# a_7477_4687# 0.0114f
C4805 a_9757_4687# a_9751_3853# 0.02354f
C4806 a_23003_4687# a_23111_4687# 0.01163f
C4807 a_23145_3889# a_23431_3853# 0.01885f
C4808 a_16108_3134# a_21157_1842# 0.01319f
C4809 a_11473_1842# a_11603_1842# 0.70845f
C4810 a_15077_1842# a_14964_1008# 0.02055f
C4811 a_22243_16869# VDD 0.4974f
C4812 a_5115_13226# VDD 0.15389f
C4813 a_13123_7532# VDD 0.49727f
C4814 a_21835_6734# VDD 0.15406f
C4815 a_22873_1842# VDD 0.49557f
C4816 a_2873_16422# CHAN0_MUX_SEL1 0.13092f
C4817 a_3449_16422# CHAN0_DELAY_IN 0.01058f
C4818 a_11785_519# VDD 0.29292f
C4819 CHAN3_DELAY_IN CHAN3_MUX_SEL4 0.0663f
C4820 a_22243_16869# a_22351_17497# 0.01697f
C4821 a_4437_16869# a_4350_16071# 0.1088f
C4822 a_6717_14024# a_7043_14024# 0.01427f
C4823 a_5731_15316# a_13753_14024# 0.01865f
C4824 a_6635_16071# a_6711_16035# 0.01194f
C4825 a_23145_13226# a_23355_13226# 0.09424f
C4826 a_12849_11557# a_13592_11561# 0.38817f
C4827 a_4187_2434# a_22243_4687# 0.06627f
C4828 a_13306_11995# a_13566_11525# 0.75507f
C4829 a_6854_11676# a_9444_10280# 0.0353f
C4830 a_13121_11521# a_14009_11568# 0.01604f
C4831 a_8563_7532# a_8671_8160# 0.01697f
C4832 a_19073_7532# a_19203_7532# 0.70845f
C4833 a_23437_7532# a_24084_6698# 0.02312f
C4834 a_24197_4687# a_23763_4687# 0.6972f
C4835 a_4157_4158# a_4350_3889# 0.04624f
C4836 a_5197_1842# a_4350_1044# 0.08038f
C4837 a_16108_3134# a_16851_3154# 0.06181f
C4838 a_8997_1842# a_9465_1044# 0.2079f
C4839 a_14025_1044# a_14235_1044# 0.09424f
C4840 a_4633_16869# VDD 0.49285f
C4841 a_7288_1044# a_7390_1044# 0.37183f
C4842 a_24631_14652# VDD 0.02023f
C4843 a_9675_16071# VDD 0.15406f
C4844 a_14111_11568# VDD 0.21331f
C4845 a_26477_4687# VDD 0.87185f
C4846 a_4157_7003# VDD 0.48942f
C4847 a_10328_1044# VDD 0.17274f
C4848 a_5197_1842# VDD 0.87047f
C4849 a_1544_1044# CHAN3_MUX_OUT 0.04258f
C4850 a_2297_1395# CHAN3_MUX_SEL1 0.01995f
C4851 a_19637_16869# a_19203_16869# 0.69698f
C4852 a_4187_2434# a_13123_14024# 0.06627f
C4853 a_23437_16869# a_24084_16035# 0.02312f
C4854 a_1544_16071# a_2297_16422# 0.28651f
C4855 a_4187_2434# a_25913_7532# 0.11284f
C4856 a_4187_2434# a_4633_4687# 0.11222f
C4857 a_9323_14024# a_9431_14024# 0.01163f
C4858 a_23633_14024# a_23763_14024# 0.70845f
C4859 a_15403_14024# a_15511_14652# 0.01697f
C4860 a_4157_13495# a_4248_13226# 0.11672f
C4861 a_5731_12471# a_6854_11144# 0.05419f
C4862 a_15964_12471# a_16851_12491# 0.16757f
C4863 a_13557_7532# a_13470_6734# 0.1088f
C4864 a_10517_7532# a_10083_7532# 0.69698f
C4865 a_15077_4687# a_15273_4687# 0.77122f
C4866 a_17275_6734# a_17351_6698# 0.01194f
C4867 a_16510_6734# a_18004_6698# 0.28279f
C4868 a_4350_6734# a_5705_6209# 0.02005f
C4869 a_18877_4687# a_18871_3853# 0.02354f
C4870 a_22590_3889# a_24875_3889# 0.39036f
C4871 a_19637_1842# a_20397_1842# 0.01669f
C4872 a_1721_331# a_2019_311# 0.18452f
C4873 a_24197_1842# a_24084_1008# 0.02055f
C4874 a_17357_14024# VDD 0.8702f
C4875 a_7911_8160# VDD 0.01806f
C4876 a_26395_13226# VDD 0.1539f
C4877 a_14311_3853# VDD 0.28357f
C4878 a_7803_4687# VDD 0.50128f
C4879 a_12907_11110# DLL_RESETN 0.04234f
C4880 a_8745_6209# REF_MUX_SEL4 0.04472f
C4881 a_5731_5979# REF_MUX_OUT 1.04829f
C4882 REF_CLK REF_MUX_SEL0 0.10102f
C4883 a_4187_2434# a_17357_16869# 0.04141f
C4884 a_10517_16869# a_10713_16869# 0.73897f
C4885 a_13557_16869# a_13470_16071# 0.1088f
C4886 a_4187_2434# a_8237_7532# 0.04141f
C4887 a_16510_16071# a_17928_16071# 0.38994f
C4888 a_16108_15316# a_26803_14024# 0.01192f
C4889 a_15077_14024# a_14643_14024# 0.6972f
C4890 a_23355_13226# a_23431_13190# 0.01194f
C4891 a_22590_13226# a_24084_13190# 0.28279f
C4892 a_4187_2434# a_16923_1842# 0.06627f
C4893 a_4350_6734# a_6635_6734# 0.39036f
C4894 a_10985_6734# a_11195_6734# 0.09424f
C4895 a_5957_4687# a_6717_4687# 0.02912f
C4896 a_5731_5979# a_11603_4687# 0.01544f
C4897 a_27563_4687# a_27671_5315# 0.01697f
C4898 a_21483_4687# a_21591_4687# 0.01163f
C4899 a_10430_3889# a_12791_3853# 0.26208f
C4900 a_8237_4687# a_8884_3853# 0.02312f
C4901 a_16108_3134# a_18443_1842# 0.01542f
C4902 a_20593_16869# VDD 0.49417f
C4903 a_22677_1842# a_23145_1044# 0.19203f
C4904 a_14317_1842# a_13470_1044# 0.08038f
C4905 a_23145_13226# VDD 0.30411f
C4906 a_11473_7532# VDD 0.49417f
C4907 a_18871_6698# VDD 0.2822f
C4908 a_21157_1842# VDD 0.85955f
C4909 a_1544_16071# CHAN0_MUX_SEL0 0.07603f
C4910 a_1256_16071# CHAN0_MUX_SEL1 1.44243f
C4911 CHAN2_MUX_SEL4 CHAN3_DELAY_IN 0.01327f
C4912 CHAN2_MUX_SEL2 CHAN3_MUX_SEL0 0.0126f
C4913 a_20723_16869# a_20831_17497# 0.01697f
C4914 a_4350_16071# a_5844_16035# 0.28279f
C4915 a_5115_16071# a_5191_16035# 0.01194f
C4916 a_5957_14024# a_6153_14024# 0.77122f
C4917 a_5731_15316# a_12037_14024# 0.01319f
C4918 a_12505_16071# a_10430_16071# 0.03208f
C4919 a_8237_14024# a_8808_13226# 0.10863f
C4920 a_10430_13226# a_12715_13226# 0.39036f
C4921 a_4187_2434# a_20593_4687# 0.11222f
C4922 a_12355_11557# a_13306_11995# 0.26489f
C4923 a_13019_11521# a_13121_11521# 0.56469f
C4924 a_12656_11554# a_12849_11557# 0.33075f
C4925 a_7043_7532# a_7151_8160# 0.01697f
C4926 a_22677_7532# a_22590_6734# 0.1088f
C4927 a_22873_4687# a_23437_4687# 0.0114f
C4928 a_19550_6734# a_20905_6209# 0.02165f
C4929 a_27433_1842# a_27563_1842# 0.70845f
C4930 a_5768_1044# a_5844_1008# 0.01176f
C4931 a_6711_16035# VDD 0.2822f
C4932 a_18551_14652# VDD 0.01806f
C4933 a_23763_4687# VDD 0.52741f
C4934 a_7390_1044# VDD 1.1389f
C4935 a_16851_3154# VDD 0.52304f
C4936 a_4003_14024# CHAN0_MUX_SEL4 0.01225f
C4937 a_18313_16869# a_18877_16869# 0.0114f
C4938 a_4187_2434# a_11473_14024# 0.11222f
C4939 a_22677_16869# a_22590_16071# 0.1088f
C4940 a_7803_14024# a_7911_14024# 0.01163f
C4941 a_27915_16071# a_27991_16035# 0.01194f
C4942 a_13883_14024# a_13991_14652# 0.01697f
C4943 a_4187_2434# a_24197_7532# 0.03928f
C4944 a_4187_2434# a_16108_5979# 0.20422f
C4945 a_9193_7532# a_9757_7532# 0.0114f
C4946 a_13753_4687# a_13883_4687# 0.70845f
C4947 a_10430_3889# a_11785_3364# 0.02058f
C4948 a_17357_4687# a_18004_3853# 0.02312f
C4949 a_18877_1842# a_18443_1842# 0.6972f
C4950 a_23437_1842# a_22590_1044# 0.08038f
C4951 a_1256_289# a_1544_289# 1.25711f
C4952 a_1256_1044# a_1721_1395# 0.13421f
C4953 a_14643_14024# VDD 0.4969f
C4954 a_23431_13190# VDD 0.28336f
C4955 a_27433_7532# VDD 0.49285f
C4956 a_6153_4687# VDD 0.4946f
C4957 a_11848_3889# VDD 0.17499f
C4958 a_2873_6021# REF_MUX_SEL4 0.04916f
C4959 a_3449_6021# REF_MUX_SEL3 0.28429f
C4960 a_2297_6021# REF_MUX_OUT 0.01179f
C4961 a_4187_2434# a_14643_16869# 0.06627f
C4962 a_9193_16869# a_9323_16869# 0.70845f
C4963 a_4187_2434# a_5523_7532# 0.06627f
C4964 a_16108_15316# a_25153_14024# 0.01872f
C4965 a_13753_14024# a_14317_14024# 0.0114f
C4966 a_17357_14024# a_17928_13226# 0.10863f
C4967 a_14111_10917# a_14851_10872# 0.26905f
C4968 a_4187_2434# a_15273_1842# 0.11222f
C4969 a_26477_7532# a_26043_7532# 0.6972f
C4970 a_7477_4687# a_7390_3889# 0.1088f
C4971 a_19963_4687# a_20071_4687# 0.01163f
C4972 a_5197_4687# a_4763_4687# 0.6972f
C4973 a_26043_4687# a_26151_5315# 0.01697f
C4974 a_10328_3889# a_10430_3889# 0.37183f
C4975 a_12797_1842# a_12791_1008# 0.02354f
C4976 a_9757_1842# a_9953_1842# 0.72407f
C4977 a_16108_3134# a_16793_1842# 0.01481f
C4978 a_18877_16869# VDD 0.87825f
C4979 a_16408_1044# a_16484_1008# 0.01176f
C4980 a_10985_13226# VDD 0.30411f
C4981 a_27991_16035# VDD 0.28273f
C4982 a_9757_7532# VDD 0.87677f
C4983 a_16408_6734# VDD 0.1824f
C4984 a_18443_1842# VDD 0.50001f
C4985 a_1544_289# VDD 0.39113f
C4986 a_1256_12471# CHAN1_MUX_SEL3 1.41161f
C4987 a_3449_12513# CHAN1_DELAY_IN 0.01017f
C4988 a_1544_12471# CHAN1_MUX_SEL2 0.07405f
C4989 CHAN2_DELAY_IN CHAN2_MUX_SEL4 0.0663f
C4990 a_4187_2434# a_27433_14024# 0.11222f
C4991 a_19203_16869# a_19311_17497# 0.01697f
C4992 a_26477_16869# a_26673_16869# 0.76914f
C4993 a_5731_15316# a_9323_14024# 0.01542f
C4994 a_4633_14024# a_4763_14024# 0.70845f
C4995 a_18585_13226# a_18871_13190# 0.01885f
C4996 a_4187_2434# a_18877_4687# 0.0414f
C4997 a_17357_7532# a_17553_7532# 0.7425f
C4998 a_5523_7532# a_5631_8160# 0.01697f
C4999 a_21917_4687# a_22677_4687# 0.06198f
C5000 a_25630_6734# a_27915_6734# 0.39036f
C5001 a_26477_4687# a_27124_3853# 0.02312f
C5002 a_26477_1842# a_26803_1842# 0.01427f
C5003 a_9465_1044# a_9751_1008# 0.01885f
C5004 a_4248_16071# VDD 0.17587f
C5005 a_4350_1044# a_4324_1008# 0.277f
C5006 a_12471_14652# VDD 0.01806f
C5007 a_22113_4687# VDD 0.49655f
C5008 a_4324_1008# VDD 0.28597f
C5009 a_15964_15316# CHAN0_MUX_SEL4 0.5544f
C5010 a_17357_16869# a_18117_16869# 0.02973f
C5011 a_4187_2434# a_9757_14024# 0.04038f
C5012 a_6283_14024# a_6391_14024# 0.01163f
C5013 a_4187_2434# a_21483_7532# 0.06661f
C5014 a_25630_16071# a_27124_16035# 0.28279f
C5015 a_12363_14024# a_12471_14652# 0.01697f
C5016 a_26395_16071# a_26471_16035# 0.01194f
C5017 a_21917_14024# a_22113_14024# 0.76914f
C5018 a_26477_14024# a_27048_13226# 0.10863f
C5019 a_8237_7532# a_8997_7532# 0.03319f
C5020 a_26185_6734# a_26395_6734# 0.09424f
C5021 a_13470_6734# a_15831_6698# 0.26208f
C5022 a_16597_4687# a_16510_3889# 0.1088f
C5023 a_16108_5979# a_23003_4687# 0.01539f
C5024 a_12797_4687# a_13123_4687# 0.01427f
C5025 a_17553_1842# a_18117_1842# 0.0114f
C5026 a_21917_1842# a_21911_1008# 0.02354f
C5027 a_23111_17497# VDD 0.01806f
C5028 a_27048_1044# a_27124_1008# 0.01176f
C5029 a_12993_14024# VDD 0.49655f
C5030 a_20968_13226# VDD 0.17499f
C5031 a_4437_4687# VDD 0.872f
C5032 a_25717_7532# VDD 0.86719f
C5033 a_8884_3853# VDD 0.28358f
C5034 a_23871_2470# VDD 0.01806f
C5035 a_13592_11561# REF_CLK 0.11539f
C5036 a_3449_4240# CHAN2_MUX_SEL0 0.10753f
C5037 a_11785_519# CHAN3_MUX_SEL4 0.03255f
C5038 a_8237_16869# a_8563_16869# 0.01427f
C5039 a_4187_2434# a_12993_16869# 0.11222f
C5040 a_27705_16071# a_25630_16071# 0.03208f
C5041 a_13470_16071# a_15755_16071# 0.39036f
C5042 a_16108_15316# a_23437_14024# 0.01319f
C5043 a_4187_2434# a_5864_9057# 0.03057f
C5044 a_12797_14024# a_13557_14024# 0.06198f
C5045 a_19550_13226# a_21911_13190# 0.26208f
C5046 a_4187_2434# a_13557_1842# 0.0414f
C5047 a_13306_10795# a_14009_10774# 0.02454f
C5048 a_25153_7532# a_25717_7532# 0.0114f
C5049 a_24523_4687# a_24631_5315# 0.01697f
C5050 a_18443_4687# a_18551_4687# 0.01163f
C5051 a_5731_5979# a_8237_4687# 0.01319f
C5052 a_8433_1842# a_8563_1842# 0.70361f
C5053 a_8808_3889# a_8884_3853# 0.01176f
C5054 a_18585_3889# a_16510_3889# 0.03208f
C5055 a_11277_1842# a_11924_1008# 0.02312f
C5056 a_25528_16071# VDD 0.17274f
C5057 a_16163_16869# VDD 0.94804f
C5058 a_7043_7532# VDD 0.49729f
C5059 a_13470_6734# VDD 0.88092f
C5060 a_16793_1842# VDD 0.54169f
C5061 a_25604_1008# VDD 0.28633f
C5062 a_14851_10872# REF_DELAY_OUT_LAST 0.02109f
C5063 REF_MUX_SEL2 CHAN2_MUX_SEL0 0.0126f
C5064 REF_MUX_SEL4 CHAN2_DELAY_IN 0.01327f
C5065 a_25153_16869# a_25283_16869# 0.70361f
C5066 a_17683_16869# a_17791_17497# 0.01697f
C5067 a_6425_16071# a_6711_16035# 0.01885f
C5068 a_4187_2434# a_25717_14024# 0.04049f
C5069 a_5731_15316# a_7673_14024# 0.01865f
C5070 a_4187_2434# a_16163_4687# 0.06315f
C5071 a_17065_13226# a_16510_13226# 0.03209f
C5072 a_11748_11799# a_11491_11918# 0.34468f
C5073 a_4187_2434# a_25630_3889# 0.02246f
C5074 a_4003_7532# a_4111_8160# 0.01697f
C5075 a_16033_7532# a_16163_7532# 0.70361f
C5076 a_25717_4687# a_25630_3889# 0.1088f
C5077 a_21157_4687# a_20723_4687# 0.6972f
C5078 a_25717_1842# a_25913_1842# 0.73897f
C5079 a_7945_1044# a_7390_1044# 0.03209f
C5080 a_18585_16071# VDD 0.29722f
C5081 a_6391_14652# VDD 0.01806f
C5082 a_20397_4687# VDD 0.87185f
C5083 a_5705_3364# VDD 0.29556f
C5084 a_21625_1044# VDD 0.29742f
C5085 a_8745_15546# CHAN0_MUX_SEL4 0.04472f
C5086 a_5731_15316# CHAN0_MUX_OUT 1.04829f
C5087 a_16597_16869# a_16163_16869# 0.69698f
C5088 a_4187_2434# a_7043_14024# 0.06627f
C5089 a_4763_14024# a_4871_14024# 0.01163f
C5090 a_10843_14024# a_10951_14652# 0.01697f
C5091 a_4187_2434# a_19833_7532# 0.11284f
C5092 a_20593_14024# a_20723_14024# 0.70845f
C5093 a_25630_13226# a_26985_12701# 0.02195f
C5094 a_7477_7532# a_7043_7532# 0.69698f
C5095 a_13368_6734# a_13470_6734# 0.37183f
C5096 a_16108_5979# a_21353_4687# 0.01872f
C5097 a_12037_4687# a_12233_4687# 0.77122f
C5098 a_16597_1842# a_17357_1842# 0.01669f
C5099 a_19448_3889# a_19524_3853# 0.01176f
C5100 a_20397_1842# a_21044_1008# 0.02312f
C5101 a_25630_1044# a_25604_1008# 0.277f
C5102 a_17031_17497# VDD 0.01806f
C5103 a_11277_14024# VDD 0.87175f
C5104 a_23003_7532# VDD 0.49743f
C5105 a_18004_13190# VDD 0.28225f
C5106 a_15765_6153# VDD 0.36528f
C5107 a_4187_2434# CHAN0_MUX_SEL4 0.01921f
C5108 a_17791_2470# VDD 0.01806f
C5109 a_6635_3889# VDD 0.15407f
C5110 a_12656_11554# REF_CLK 0.01215f
C5111 a_13019_11521# DLL_RESETN 0.01429f
C5112 a_7477_16869# a_7673_16869# 0.73897f
C5113 a_4187_2434# a_11277_16869# 0.04141f
C5114 a_12037_14024# a_11603_14024# 0.6972f
C5115 a_16108_15316# a_20723_14024# 0.01544f
C5116 a_4187_2434# a_10843_1842# 0.06627f
C5117 a_15304_10295# a_13592_11113# 0.01817f
C5118 a_19448_13226# a_19550_13226# 0.37183f
C5119 a_24197_7532# a_24957_7532# 0.02912f
C5120 a_6425_6734# a_4350_6734# 0.03208f
C5121 a_5731_5979# a_5523_4687# 0.01562f
C5122 a_16108_5979# a_20905_6209# 0.2906f
C5123 a_24957_7532# a_16108_5979# 0.0157f
C5124 a_16923_4687# a_17031_4687# 0.01163f
C5125 a_23003_4687# a_23111_5315# 0.01697f
C5126 a_5731_3134# a_15273_1842# 0.01872f
C5127 a_7390_3889# a_7364_3853# 0.277f
C5128 a_24665_1044# a_24951_1008# 0.01885f
C5129 a_10517_1842# a_10430_1044# 0.1088f
C5130 a_14513_16869# VDD 0.49419f
C5131 a_13470_1044# a_14235_1044# 0.39037f
C5132 a_22590_16071# VDD 1.09883f
C5133 a_1721_13577# VDD 0.4533f
C5134 a_5393_7532# VDD 0.49417f
C5135 a_10404_6698# VDD 0.28633f
C5136 a_27671_5315# VDD 0.01806f
C5137 a_15077_1842# VDD 0.86076f
C5138 a_23355_1044# VDD 0.1539f
C5139 a_4187_2434# CHAN3_DELAY_OUT_LAST 0.21225f
C5140 a_4003_1842# CHAN3_DELAY_IN 0.54998f
C5141 a_7390_1044# CHAN3_MUX_SEL4 0.29489f
C5142 a_16163_16869# a_16271_17497# 0.01697f
C5143 a_24957_16869# a_16108_15316# 0.0157f
C5144 a_16108_15316# a_17865_15546# 0.29564f
C5145 a_4905_16071# a_4350_16071# 0.03209f
C5146 a_4187_2434# a_23003_14024# 0.06627f
C5147 a_4157_16340# a_4324_16035# 0.02463f
C5148 a_5731_15316# a_5957_14024# 0.01644f
C5149 a_4763_14024# a_4350_13226# 0.01012f
C5150 a_10232_11561# a_10520_11982# 0.43707f
C5151 a_14025_13226# a_14311_13190# 0.01885f
C5152 a_4187_2434# a_14513_4687# 0.11222f
C5153 a_7288_13226# a_7364_13190# 0.01176f
C5154 a_13470_6734# a_14825_6209# 0.02058f
C5155 a_19833_4687# a_20397_4687# 0.0114f
C5156 a_24393_1842# a_24523_1842# 0.70361f
C5157 a_27237_14024# VDD 0.86278f
C5158 a_9547_11862# VDD 0.08951f
C5159 a_17683_4687# VDD 0.48149f
C5160 a_27915_3889# VDD 0.15389f
C5161 a_9465_1044# VDD 0.29742f
C5162 a_2873_15358# CHAN0_MUX_SEL4 0.04916f
C5163 a_2297_15358# CHAN0_MUX_OUT 0.01179f
C5164 a_3449_15358# CHAN0_MUX_SEL3 0.28429f
C5165 a_15273_16869# a_15837_16869# 0.0114f
C5166 a_4187_2434# a_5393_14024# 0.11222f
C5167 a_4187_2434# a_27237_16869# 0.06254f
C5168 a_22590_16071# a_24951_16035# 0.26208f
C5169 a_4187_2434# a_18117_7532# 0.04188f
C5170 a_9323_14024# a_9431_14652# 0.01697f
C5171 a_9323_7532# a_7390_6734# 0.01012f
C5172 a_15077_7532# a_15545_6734# 0.2079f
C5173 a_4187_2434# a_26803_1842# 0.06627f
C5174 a_6153_7532# a_6717_7532# 0.0114f
C5175 a_10713_4687# a_10843_4687# 0.70845f
C5176 a_11848_6734# a_11924_6698# 0.01176f
C5177 a_21625_6734# a_21911_6698# 0.01885f
C5178 a_16108_5979# a_19637_4687# 0.01314f
C5179 a_4350_3889# a_5731_3134# 0.41099f
C5180 a_15837_1842# a_15403_1842# 0.6972f
C5181 a_19637_1842# a_19550_1044# 0.1088f
C5182 a_10951_17497# VDD 0.01806f
C5183 a_8563_14024# VDD 0.95442f
C5184 a_15755_13226# VDD 0.15389f
C5185 a_21353_7532# VDD 0.49285f
C5186 a_5731_5979# VDD 0.98849f
C5187 a_11711_2470# VDD 0.01806f
C5188 a_10751_11568# REF_CLK 0.01931f
C5189 a_11748_11799# DLL_RESETN 0.11133f
C5190 VDD CHAN1_MUX_SEL2 0.68512f
C5191 a_1544_289# CHAN3_MUX_SEL4 0.47529f
C5192 a_1256_289# CHAN3_MUX_OUT 0.1134f
C5193 a_2297_331# CHAN3_MUX_SEL2 0.10655f
C5194 a_15077_16869# a_15545_16071# 0.2079f
C5195 a_9323_16869# a_7390_16071# 0.01012f
C5196 a_4187_2434# a_8563_16869# 0.0635f
C5197 a_6153_16869# a_6283_16869# 0.70845f
C5198 a_10713_14024# a_11277_14024# 0.0114f
C5199 a_21625_16071# a_21835_16071# 0.09424f
C5200 a_16108_15316# a_19073_14024# 0.01872f
C5201 a_13883_14024# a_13470_13226# 0.01012f
C5202 a_17928_13226# a_18004_13190# 0.01176f
C5203 a_4187_2434# a_9193_1842# 0.11222f
C5204 a_23437_7532# a_23003_7532# 0.6972f
C5205 a_12505_3889# a_12715_3889# 0.09424f
C5206 a_15403_4687# a_15511_4687# 0.01163f
C5207 a_21483_4687# a_21591_5315# 0.01697f
C5208 a_5731_3134# a_13557_1842# 0.01314f
C5209 a_6717_1842# a_6913_1842# 0.76914f
C5210 a_23145_1044# a_22590_1044# 0.03209f
C5211 a_12797_16869# VDD 0.87771f
C5212 a_19524_16035# VDD 0.28633f
C5213 a_21591_5315# VDD 0.01806f
C5214 a_8155_6734# VDD 0.15389f
C5215 a_20391_1008# VDD 0.28336f
C5216 a_12363_1842# VDD 0.50001f
C5217 a_4187_2434# CHAN2_DELAY_OUT_LAST 0.21225f
C5218 a_4157_7003# REF_MUX_SEL4 0.08229f
C5219 a_16108_3134# CHAN2_MUX_OUT 0.24265f
C5220 VDD CHAN3_MUX_OUT 0.55963f
C5221 a_23437_16869# a_23633_16869# 0.76914f
C5222 a_14643_16869# a_14751_17497# 0.01697f
C5223 a_4187_2434# a_21353_14024# 0.11222f
C5224 a_27997_14024# a_27563_14024# 0.69646f
C5225 a_4187_2434# a_12797_4687# 0.0414f
C5226 a_7477_14024# a_7945_13226# 0.19203f
C5227 a_18443_7532# a_16510_6734# 0.01012f
C5228 a_14317_7532# a_14513_7532# 0.76914f
C5229 a_18877_4687# a_19637_4687# 0.06198f
C5230 a_22488_6734# a_22564_6698# 0.01176f
C5231 a_1544_3134# a_1721_3176# 0.36963f
C5232 a_1256_3134# a_2297_3176# 0.04261f
C5233 a_23437_1842# a_23763_1842# 0.01427f
C5234 a_15765_463# a_16108_289# 0.42004f
C5235 a_24523_14024# VDD 0.91083f
C5236 a_23945_12701# VDD 0.29329f
C5237 a_16033_4687# VDD 0.54891f
C5238 a_24951_3853# VDD 0.2822f
C5239 a_3449_13577# CHAN1_MUX_SEL0 0.10753f
C5240 a_18443_16869# a_16510_16071# 0.01012f
C5241 a_4187_2434# a_24523_16869# 0.06492f
C5242 a_14317_16869# a_15077_16869# 0.03319f
C5243 a_7803_14024# a_7911_14652# 0.01697f
C5244 a_4187_2434# a_15403_7532# 0.06668f
C5245 a_18877_14024# a_19073_14024# 0.76914f
C5246 a_22488_16071# a_22590_16071# 0.37183f
C5247 a_1544_13226# a_1721_13577# 0.38063f
C5248 a_23003_14024# a_22590_13226# 0.01012f
C5249 a_5197_7532# a_5957_7532# 0.03319f
C5250 a_4187_2434# a_25153_1842# 0.11169f
C5251 a_1256_12471# a_1721_12513# 0.13421f
C5252 a_10430_6734# a_10404_6698# 0.277f
C5253 a_20105_6734# a_19550_6734# 0.03209f
C5254 a_16108_5979# a_16923_4687# 0.01073f
C5255 a_16510_3889# a_17275_3889# 0.39037f
C5256 a_16108_3134# a_26673_1842# 0.01872f
C5257 a_14513_1842# a_15077_1842# 0.0114f
C5258 a_22590_1044# a_23431_1008# 0.28268f
C5259 a_4871_17497# VDD 0.01806f
C5260 a_6913_14024# VDD 0.49656f
C5261 a_12791_13190# VDD 0.2822f
C5262 a_19637_7532# VDD 0.86712f
C5263 a_17065_3889# VDD 0.3023f
C5264 a_2297_6021# VDD 0.46603f
C5265 a_5631_2470# VDD 0.01806f
C5266 a_9946_11995# DLL_RESETN 0.09997f
C5267 VDD CHAN0_MUX_SEL2 0.692f
C5268 a_5197_16869# a_5523_16869# 0.01427f
C5269 a_4187_2434# a_6913_16869# 0.11222f
C5270 a_10328_16071# a_10404_16035# 0.01176f
C5271 a_16108_15316# a_17357_14024# 0.01319f
C5272 a_9757_14024# a_10517_14024# 0.05851f
C5273 a_16510_13226# a_16484_13190# 0.277f
C5274 a_21157_14024# a_21625_13226# 0.2079f
C5275 a_12797_14024# a_13368_13226# 0.10864f
C5276 a_12849_11557# a_14111_10917# 0.42064f
C5277 a_14851_11918# a_14757_11918# 0.28931f
C5278 a_4187_2434# a_7477_1842# 0.0414f
C5279 a_22113_7532# a_22677_7532# 0.0114f
C5280 a_27563_7532# a_25630_6734# 0.01024f
C5281 a_5731_5979# a_14825_6209# 0.28056f
C5282 a_26673_4687# a_26803_4687# 0.70845f
C5283 a_13883_4687# a_13991_4687# 0.01163f
C5284 a_19963_4687# a_20071_5315# 0.01697f
C5285 a_4350_3889# a_5191_3853# 0.28268f
C5286 a_5393_1842# a_5523_1842# 0.70845f
C5287 a_5731_3134# a_10843_1842# 0.01539f
C5288 a_20105_1044# a_20391_1008# 0.01885f
C5289 a_17275_16071# VDD 0.15389f
C5290 a_10430_1044# a_11848_1044# 0.38994f
C5291 a_10083_16869# VDD 0.482f
C5292 a_5191_6698# VDD 0.28637f
C5293 a_15688_11093# VDD 0.30345f
C5294 a_15511_5315# VDD 0.01806f
C5295 a_17928_1044# VDD 0.17499f
C5296 a_10713_1842# VDD 0.49553f
C5297 a_4187_2434# REF_DELAY_OUT_LAST 1.08837f
C5298 a_2873_7085# REF_MUX_SEL0 0.01504f
C5299 VDD CHAN2_MUX_OUT 1.0425f
C5300 CHAN1_MUX_OUT DLL_RESETN 0.04865f
C5301 a_22113_16869# a_22243_16869# 0.70845f
C5302 a_13123_16869# a_13231_17497# 0.01697f
C5303 a_27563_16869# a_25630_16071# 0.01024f
C5304 a_4187_2434# a_19637_14024# 0.0414f
C5305 a_5731_15316# a_11785_15546# 0.28056f
C5306 a_26673_14024# a_27237_14024# 0.0114f
C5307 a_5957_14024# a_6425_13226# 0.2079f
C5308 a_4350_13226# a_5115_13226# 0.39037f
C5309 a_4187_2434# a_10083_4687# 0.06492f
C5310 a_9547_11632# a_9547_11862# 0.1117f
C5311 a_12993_7532# a_13123_7532# 0.70845f
C5312 a_5731_12471# a_12849_11557# 0.01934f
C5313 a_10430_6734# a_5731_5979# 0.41176f
C5314 a_18117_4687# a_17683_4687# 0.6972f
C5315 a_19550_3889# a_16108_3134# 0.58202f
C5316 a_22677_1842# a_22873_1842# 0.73897f
C5317 a_5731_289# a_16108_289# 0.01334f
C5318 a_22873_14024# VDD 0.49557f
C5319 a_11785_12701# VDD 0.29292f
C5320 a_25391_8160# VDD 0.01806f
C5321 a_14317_4687# VDD 0.87185f
C5322 a_22488_3889# VDD 0.17274f
C5323 a_1544_1044# VDD 0.45079f
C5324 a_13557_16869# a_13123_16869# 0.69698f
C5325 a_4187_2434# a_22873_16869# 0.11222f
C5326 a_20968_16071# a_21044_16035# 0.01176f
C5327 a_6283_14024# a_6391_14652# 0.01697f
C5328 a_4187_2434# a_13753_7532# 0.11222f
C5329 a_17553_14024# a_17683_14024# 0.70361f
C5330 a_21917_14024# a_22488_13226# 0.10864f
C5331 a_4187_2434# a_23437_1842# 0.0414f
C5332 a_4437_7532# a_4003_7532# 0.69698f
C5333 a_17065_6734# a_17351_6698# 0.01885f
C5334 a_19637_4687# a_20105_3889# 0.19203f
C5335 a_12363_4687# a_10430_3889# 0.01012f
C5336 a_8997_4687# a_9193_4687# 0.77122f
C5337 a_27705_3889# a_27915_3889# 0.09424f
C5338 a_16108_3134# a_24957_1842# 0.01307f
C5339 a_13557_1842# a_14317_1842# 0.01669f
C5340 a_26043_16869# VDD 0.49732f
C5341 a_21835_1044# a_21911_1008# 0.01194f
C5342 a_10328_13226# VDD 0.17274f
C5343 a_5197_14024# VDD 0.87049f
C5344 a_26471_6698# VDD 0.28357f
C5345 a_16923_7532# VDD 0.4975f
C5346 a_6425_3889# VDD 0.29742f
C5347 a_26673_1842# VDD 0.49593f
C5348 a_5974_11413# DLL_RESETN 0.02002f
C5349 a_6854_11676# CHAN1_MUX_OUT 0.02972f
C5350 a_9757_7532# REF_MUX_SEL4 0.01829f
C5351 a_4187_2434# a_5197_16869# 0.04141f
C5352 a_4437_16869# a_4633_16869# 0.73897f
C5353 a_17065_16071# a_17275_16071# 0.09424f
C5354 a_8997_14024# a_8563_14024# 0.6972f
C5355 a_12797_14024# a_10430_13226# 0.02479f
C5356 a_4187_2434# a_26043_4687# 0.06627f
C5357 a_21157_7532# a_21917_7532# 0.02912f
C5358 a_6854_11144# a_9712_9602# 0.67835f
C5359 a_6126_9506# a_5864_9057# 0.23738f
C5360 a_4187_2434# a_4763_1842# 0.06627f
C5361 a_13592_11561# a_14757_11918# 0.43239f
C5362 a_18877_7532# a_16108_5979# 0.0157f
C5363 a_12363_4687# a_12471_4687# 0.01163f
C5364 a_4437_4687# a_4905_3889# 0.19203f
C5365 a_18443_4687# a_18551_5315# 0.01697f
C5366 a_7945_3889# a_8155_3889# 0.09424f
C5367 a_5731_3134# a_9193_1842# 0.01872f
C5368 a_8433_16869# VDD 0.55212f
C5369 a_14311_16035# VDD 0.28357f
C5370 a_13592_11113# VDD 0.11685f
C5371 a_24665_6734# VDD 0.29722f
C5372 a_8997_1842# VDD 0.88864f
C5373 a_9431_5315# VDD 0.01806f
C5374 a_14964_1008# VDD 0.28225f
C5375 a_3449_6021# REF_CLK 0.01017f
C5376 a_12849_11557# REF_DELAY_OUT_LAST 0.01791f
C5377 a_1256_6734# REF_MUX_SEL0 0.3314f
C5378 a_5705_3364# CHAN2_MUX_SEL4 0.03556f
C5379 VDD REF_MUX_OUT 1.0425f
C5380 a_11603_16869# a_11711_17497# 0.01697f
C5381 a_18877_16869# a_16108_15316# 0.0157f
C5382 a_4187_2434# a_16923_14024# 0.06627f
C5383 a_25717_14024# a_26477_14024# 0.01669f
C5384 a_4437_14024# a_4157_13495# 0.01771f
C5385 a_5974_11413# a_6854_11676# 0.029f
C5386 a_9465_13226# a_7390_13226# 0.03208f
C5387 a_4187_2434# a_8433_4687# 0.11169f
C5388 a_6326_10280# a_6126_9506# 2.83945f
C5389 a_19550_6734# a_20315_6734# 0.39037f
C5390 a_7390_6734# a_8745_6209# 0.01627f
C5391 a_16793_4687# a_17357_4687# 0.0114f
C5392 a_21483_4687# a_19550_3889# 0.01012f
C5393 a_25630_3889# a_26471_3853# 0.28268f
C5394 a_16510_3889# a_16851_3154# 0.02131f
C5395 a_21353_1842# a_21483_1842# 0.70845f
C5396 a_21157_14024# VDD 0.85955f
C5397 a_11603_4687# VDD 0.49684f
C5398 a_19311_8160# VDD 0.01806f
C5399 a_19550_3889# VDD 0.89766f
C5400 a_4187_2434# a_21157_16869# 0.04152f
C5401 a_12233_16869# a_12797_16869# 0.0114f
C5402 a_7390_16071# a_5731_15316# 0.41141f
C5403 a_19550_16071# a_19524_16035# 0.277f
C5404 a_4763_14024# a_4871_14652# 0.01697f
C5405 a_4187_2434# a_12037_7532# 0.04152f
C5406 a_25630_13226# a_26395_13226# 0.39037f
C5407 a_16510_13226# a_16108_12471# 0.56108f
C5408 a_21917_14024# a_19550_13226# 0.02479f
C5409 a_5197_7532# a_5768_6734# 0.10863f
C5410 a_4187_2434# a_20723_1842# 0.06627f
C5411 a_7390_6734# a_8231_6698# 0.28268f
C5412 a_5731_5979# a_15403_4687# 0.01563f
C5413 a_7673_4687# a_7803_4687# 0.70845f
C5414 a_13470_3889# a_14888_3889# 0.38994f
C5415 a_16108_3134# a_22243_1842# 0.01539f
C5416 a_12797_1842# a_12363_1842# 0.6972f
C5417 a_19550_1044# a_21044_1008# 0.28279f
C5418 a_24393_16869# VDD 0.71684f
C5419 a_20315_1044# a_20391_1008# 0.01194f
C5420 a_16851_15336# VDD 0.52304f
C5421 a_15273_7532# VDD 0.49307f
C5422 a_7390_13226# VDD 1.1389f
C5423 a_24008_6734# VDD 0.17499f
C5424 a_24957_1842# VDD 0.8837f
C5425 a_20905_519# VDD 0.29292f
C5426 a_4157_16340# CHAN0_MUX_SEL4 0.08229f
C5427 a_16108_12471# CHAN1_MUX_OUT 0.24265f
C5428 a_13470_6734# REF_MUX_SEL4 0.256f
C5429 CHAN3_MUX_SEL4 CHAN3_MUX_OUT 0.91933f
C5430 a_5197_16869# a_5768_16071# 0.10863f
C5431 a_7390_16071# a_8155_16071# 0.39037f
C5432 a_10517_14024# a_10404_13190# 0.05157f
C5433 a_7673_14024# a_8237_14024# 0.0114f
C5434 a_13306_11995# a_14111_11568# 0.097f
C5435 a_13470_13226# a_14311_13190# 0.28268f
C5436 a_13019_11521# a_15688_11557# 0.0195f
C5437 a_12849_11557# a_15108_11799# 0.10225f
C5438 a_4187_2434# a_24393_4687# 0.11005f
C5439 a_13121_11521# a_14851_11918# 0.03404f
C5440 a_20397_7532# a_19963_7532# 0.6972f
C5441 a_25630_6734# a_16108_5979# 0.52614f
C5442 a_16923_4687# a_17031_5315# 0.01697f
C5443 a_10843_4687# a_10951_4687# 0.01163f
C5444 a_24957_4687# a_25153_4687# 0.74845f
C5445 a_5731_3134# a_7477_1842# 0.01314f
C5446 a_6283_1842# a_4350_1044# 0.01012f
C5447 a_7390_1044# a_9675_1044# 0.39036f
C5448 a_10517_1842# a_10985_1044# 0.19203f
C5449 a_6717_16869# VDD 0.87726f
R0 VDD.n657 VDD.t357 17.3693
R1 VDD.n647 VDD.t699 17.3693
R2 VDD.n647 VDD.t749 17.3693
R3 VDD.n626 VDD.t591 17.3517
R4 VDD.n650 VDD.t416 17.3517
R5 VDD.n649 VDD.t1012 17.3517
R6 VDD.n443 VDD.t500 17.2438
R7 VDD.n444 VDD.t567 17.2438
R8 VDD.n445 VDD.t355 17.2438
R9 VDD.n446 VDD.t1144 17.2438
R10 VDD.n447 VDD.t1010 17.2438
R11 VDD.n653 VDD.t499 17.2247
R12 VDD.n626 VDD.t356 17.0005
R13 VDD.n650 VDD.t766 17.0005
R14 VDD.n649 VDD.t761 17.0005
R15 VDD.t0 VDD.n1170 17.0005
R16 VDD.n573 VDD.n468 0.189847
R17 VDD.t0 VDD.n1222 17.0005
R18 VDD.n477 VDD.n478 0.188749
R19 VDD.t0 VDD.n1212 17.0005
R20 VDD.n1236 VDD.t0 17.0005
R21 VDD.n1247 VDD.t0 17.0005
R22 VDD.t0 VDD.n1202 17.0005
R23 VDD.t353 VDD.n28 1.09541
R24 VDD.n120 VDD.n121 0.131036
R25 VDD.n127 VDD.n128 0.30103
R26 VDD.n130 VDD.n131 0.116644
R27 VDD.n553 VDD.t353 1.57542
R28 VDD.n531 VDD.t353 1.57523
R29 VDD.n132 VDD.t353 1.61265
R30 VDD.t353 VDD.n585 2.32437
R31 VDD.n147 VDD.t353 0.829345
R32 VDD.t353 VDD.n603 5.62581
R33 VDD.t353 VDD.n597 2.32439
R34 VDD.t353 VDD.n591 2.32439
R35 VDD.t353 VDD.n588 5.62581
R36 VDD.t353 VDD.n574 2.3242
R37 VDD.n153 VDD.t353 2.32433
R38 VDD.n155 VDD.t353 1.20434
R39 VDD.t353 VDD.n456 0.847286
R40 VDD.t353 VDD.n91 8.47732
R41 VDD.n91 VDD.n90 0.0483676
R42 VDD.t353 VDD.n45 1.39038
R43 VDD.t353 VDD.n114 1.38919
R44 VDD.n15 VDD.n25 0.38601
R45 VDD.n344 VDD.n552 0.42444
R46 VDD.t9 VDD.n1371 17.0005
R47 VDD.n572 VDD.n469 0.189847
R48 VDD.t9 VDD.n1424 17.0005
R49 VDD.n479 VDD.n480 0.188749
R50 VDD.t9 VDD.n1414 17.0005
R51 VDD.n1437 VDD.t9 17.0005
R52 VDD.n1448 VDD.t9 17.0005
R53 VDD.n410 VDD.n549 0.424332
R54 VDD.t9 VDD.n1403 17.0005
R55 VDD.n32 VDD.t339 0.892072
R56 VDD.n174 VDD.t339 0.829345
R57 VDD.t339 VDD.n555 1.57516
R58 VDD.n619 VDD.t339 5.62581
R59 VDD.n181 VDD.n180 0.223665
R60 VDD.n185 VDD.n184 0.116687
R61 VDD.t339 VDD.n556 1.57542
R62 VDD.n188 VDD.n187 0.131036
R63 VDD.n605 VDD.t339 5.62581
R64 VDD.t339 VDD.n512 1.57542
R65 VDD.t339 VDD.n198 0.67711
R66 VDD.n314 VDD.t339 0.885204
R67 VDD.n202 VDD.t339 0.829471
R68 VDD.n235 VDD.t339 0.859122
R69 VDD.n93 VDD.t339 8.47732
R70 VDD.n94 VDD.n93 0.0483676
R71 VDD.n48 VDD.t339 1.39038
R72 VDD.n112 VDD.t339 1.38919
R73 VDD.t29 VDD.n1560 17.0005
R74 VDD.n570 VDD.n470 0.189847
R75 VDD.t29 VDD.n1612 17.0005
R76 VDD.n481 VDD.n482 0.188749
R77 VDD.t29 VDD.n1602 17.0005
R78 VDD.n1625 VDD.t29 17.0005
R79 VDD.n1636 VDD.t29 17.0005
R80 VDD.t29 VDD.n1592 17.0005
R81 VDD.n1738 VDD.t341 17.0005
R82 VDD.n62 VDD.n63 0.31081
R83 VDD.t341 VDD.n194 0.920998
R84 VDD.n559 VDD.t341 1.57523
R85 VDD.n208 VDD.n209 0.116663
R86 VDD.t341 VDD.n209 1.14105
R87 VDD.n211 VDD.n212 0.130901
R88 VDD.t341 VDD.n212 1.55358
R89 VDD.n215 VDD.t341 2.32403
R90 VDD.n560 VDD.t341 1.57542
R91 VDD.t341 VDD.n218 1.14093
R92 VDD.t341 VDD.n575 2.32406
R93 VDD.t341 VDD.n223 0.829359
R94 VDD.n561 VDD.t341 1.57542
R95 VDD.t341 VDD.n259 0.795794
R96 VDD.n271 VDD.t341 0.677057
R97 VDD.n562 VDD.t341 1.57542
R98 VDD.n273 VDD.n274 0.116602
R99 VDD.t341 VDD.n261 0.853917
R100 VDD.t341 VDD.n322 0.885204
R101 VDD.n564 VDD.t341 1.57542
R102 VDD.t341 VDD.n614 5.62581
R103 VDD.t341 VDD.n340 0.847286
R104 VDD.t341 VDD.n96 8.47732
R105 VDD.n96 VDD.n95 0.0483676
R106 VDD.t341 VDD.n40 1.39038
R107 VDD.t341 VDD.n108 1.38919
R108 VDD.n17 VDD.n50 0.38601
R109 VDD.n416 VDD.n547 0.42444
R110 VDD.t36 VDD.n1078 17.0005
R111 VDD.n568 VDD.n471 0.189847
R112 VDD.t36 VDD.n1131 17.0005
R113 VDD.t36 VDD.n1121 17.0005
R114 VDD.n1144 VDD.t36 17.0005
R115 VDD.n1155 VDD.t36 17.0005
R116 VDD.t36 VDD.n1111 17.0005
R117 VDD.n404 VDD.n425 0.343341
R118 VDD.n406 VDD.n404 0.233676
R119 VDD.n459 VDD.n406 0.196646
R120 VDD.n284 VDD.n283 0.223787
R121 VDD.t381 VDD.n565 1.57523
R122 VDD.n263 VDD.t381 0.853887
R123 VDD.n593 VDD.t381 2.32439
R124 VDD.n295 VDD.n294 0.130924
R125 VDD.n297 VDD.n467 0.701189
R126 VDD.n297 VDD.t381 0.697906
R127 VDD.n592 VDD.t381 5.62581
R128 VDD.n264 VDD.t381 1.55363
R129 VDD.n302 VDD.n301 0.130931
R130 VDD.n305 VDD.n464 0.701002
R131 VDD.t381 VDD.n305 0.697904
R132 VDD.n609 VDD.t381 5.62581
R133 VDD.n616 VDD.t381 5.62581
R134 VDD.n586 VDD.t381 5.62581
R135 VDD.n458 VDD.n331 0.299176
R136 VDD.n615 VDD.t381 5.62581
R137 VDD.n450 VDD.t381 1.55355
R138 VDD.n463 VDD.n462 0.130931
R139 VDD.n98 VDD.t381 8.47732
R140 VDD.n99 VDD.n98 0.0483676
R141 VDD.n49 VDD.t381 1.39038
R142 VDD.n106 VDD.t381 1.38919
R143 VDD.n12 VDD.n11 0.231209
R144 VDD.n8 VDD.n7 0.244032
R145 VDD.n567 VDD.n472 0.189847
R146 VDD.t20 VDD.n938 17.0005
R147 VDD.n23 VDD.n22 0.179784
R148 VDD.n417 VDD.n1 0.338491
R149 VDD.n1 VDD.n0 0.243985
R150 VDD.n2 VDD.n419 0.338491
R151 VDD.n3 VDD.n2 0.243985
R152 VDD.n959 VDD.t20 17.0005
R153 VDD.n420 VDD.n5 0.338491
R154 VDD.n5 VDD.n4 0.243985
R155 VDD.n413 VDD.n412 0.0954026
R156 VDD.n460 VDD.n408 0.196646
R157 VDD.n8 VDD.n421 0.338461
R158 VDD.n101 VDD.n100 0.0483676
R159 VDD.t365 VDD.n101 8.47732
R160 VDD.t365 VDD.n35 1.39011
R161 VDD.t365 VDD.n102 1.38914
R162 VDD.n80 VDD.n79 0.113175
R163 VDD.t360 VDD.n78 4.22189
R164 VDD.n90 VDD.t663 15.1333
R165 VDD.n94 VDD.t652 15.1333
R166 VDD.n95 VDD.t641 15.1333
R167 VDD.n99 VDD.t609 15.1333
R168 VDD.n100 VDD.t597 15.1333
R169 VDD.n1292 VDD.t666 15.0005
R170 VDD.n27 VDD.t657 15.0005
R171 VDD.n1470 VDD.t655 15.0005
R172 VDD.n1458 VDD.t646 15.0005
R173 VDD.n1681 VDD.t644 15.0005
R174 VDD.n1737 VDD.t635 15.0005
R175 VDD.n987 VDD.t612 15.0005
R176 VDD.n976 VDD.t603 15.0005
R177 VDD.n697 VDD.t600 15.0005
R178 VDD.n21 VDD.t592 15.0005
R179 VDD.n67 VDD.t625 15.0005
R180 VDD.n77 VDD.t630 15.0005
R181 VDD.n642 VDD.t633 15.0005
R182 VDD.n88 VDD.t552 17.9449
R183 VDD.n89 VDD.n88 0.341666
R184 VDD.n1742 VDD.t1023 9.02285
R185 VDD.n645 VDD.n64 4.47071
R186 VDD.n644 VDD.t361 8.95516
R187 VDD.n633 VDD.t1258 8.76054
R188 VDD.n633 VDD.t731 8.76054
R189 VDD.n349 VDD.t544 8.76054
R190 VDD.n349 VDD.t984 8.76054
R191 VDD.n349 VDD.t1019 8.76054
R192 VDD.n349 VDD.t470 8.76054
R193 VDD.n1181 VDD.t1178 8.76054
R194 VDD.n1181 VDD.t1420 8.76054
R195 VDD.n1182 VDD.t588 8.76054
R196 VDD.n1182 VDD.t1239 8.76054
R197 VDD.n1184 VDD.t1166 8.76054
R198 VDD.n1184 VDD.t1462 8.76054
R199 VDD.n1186 VDD.t545 8.76054
R200 VDD.n1186 VDD.t752 8.76054
R201 VDD.n1189 VDD.t1179 8.76054
R202 VDD.n1189 VDD.t1421 8.76054
R203 VDD.n237 VDD.t1168 8.76054
R204 VDD.n237 VDD.t1464 8.76054
R205 VDD.n443 VDD.t1552 8.76054
R206 VDD.n348 VDD.t695 8.76054
R207 VDD.n348 VDD.t1371 8.76054
R208 VDD.n348 VDD.t940 8.76054
R209 VDD.n348 VDD.t1283 8.76054
R210 VDD.n1382 VDD.t1137 8.76054
R211 VDD.n1382 VDD.t959 8.76054
R212 VDD.n1383 VDD.t975 8.76054
R213 VDD.n1383 VDD.t1052 8.76054
R214 VDD.n1385 VDD.t1148 8.76054
R215 VDD.n1385 VDD.t399 8.76054
R216 VDD.n1387 VDD.t379 8.76054
R217 VDD.n1387 VDD.t1318 8.76054
R218 VDD.n1390 VDD.t1138 8.76054
R219 VDD.n1390 VDD.t961 8.76054
R220 VDD.n240 VDD.t1150 8.76054
R221 VDD.n240 VDD.t401 8.76054
R222 VDD.n444 VDD.t1059 8.76054
R223 VDD.n347 VDD.t1481 8.76054
R224 VDD.n347 VDD.t406 8.76054
R225 VDD.n347 VDD.t730 8.76054
R226 VDD.n347 VDD.t475 8.76054
R227 VDD.n1571 VDD.t418 8.76054
R228 VDD.n1571 VDD.t743 8.76054
R229 VDD.n1572 VDD.t724 8.76054
R230 VDD.n1572 VDD.t481 8.76054
R231 VDD.n1574 VDD.t737 8.76054
R232 VDD.n1574 VDD.t573 8.76054
R233 VDD.n1576 VDD.t582 8.76054
R234 VDD.n1576 VDD.t407 8.76054
R235 VDD.n1579 VDD.t417 8.76054
R236 VDD.n1579 VDD.t742 8.76054
R237 VDD.n243 VDD.t428 8.76054
R238 VDD.n243 VDD.t436 8.76054
R239 VDD.n445 VDD.t391 8.76054
R240 VDD.n346 VDD.t1510 8.76054
R241 VDD.n346 VDD.t1402 8.76054
R242 VDD.n346 VDD.t950 8.76054
R243 VDD.n346 VDD.t1413 8.76054
R244 VDD.n1089 VDD.t403 8.76054
R245 VDD.n1089 VDD.t555 8.76054
R246 VDD.n1090 VDD.t757 8.76054
R247 VDD.n1090 VDD.t1387 8.76054
R248 VDD.n1092 VDD.t1243 8.76054
R249 VDD.n1092 VDD.t433 8.76054
R250 VDD.n1094 VDD.t988 8.76054
R251 VDD.n1094 VDD.t1401 8.76054
R252 VDD.n1097 VDD.t404 8.76054
R253 VDD.n1097 VDD.t557 8.76054
R254 VDD.n246 VDD.t991 8.76054
R255 VDD.n246 VDD.t434 8.76054
R256 VDD.n446 VDD.t1145 8.76054
R257 VDD.n345 VDD.t1596 8.76054
R258 VDD.n345 VDD.t1277 8.76054
R259 VDD.n345 VDD.t1446 8.76054
R260 VDD.n345 VDD.t1313 8.76054
R261 VDD.n913 VDD.t1163 8.76054
R262 VDD.n913 VDD.t1572 8.76054
R263 VDD.n914 VDD.t1452 8.76054
R264 VDD.n914 VDD.t1389 8.76054
R265 VDD.n916 VDD.t483 8.76054
R266 VDD.n916 VDD.t503 8.76054
R267 VDD.n918 VDD.t1450 8.76054
R268 VDD.n918 VDD.t1278 8.76054
R269 VDD.n921 VDD.t1165 8.76054
R270 VDD.n921 VDD.t1571 8.76054
R271 VDD.n249 VDD.t485 8.76054
R272 VDD.n249 VDD.t502 8.76054
R273 VDD.n447 VDD.t1011 8.76054
R274 VDD.t9 VDD.n410 0.517918
R275 VDD.n620 VDD.t36 4.21329
R276 VDD.t36 VDD.n416 0.517949
R277 VDD.n23 VDD.t20 0.246903
R278 VDD.t20 VDD.n625 4.21329
R279 VDD.n624 VDD.t20 4.21329
R280 VDD.t20 VDD.n623 4.21329
R281 VDD.n413 VDD.t20 0.308768
R282 VDD.t20 VDD.n622 4.21329
R283 VDD.n47 VDD.t351 0.615507
R284 VDD.t0 VDD.n1190 8.47732
R285 VDD.t0 VDD.n1187 8.47732
R286 VDD.t0 VDD.n1176 8.47732
R287 VDD.t0 VDD.n1179 8.47732
R288 VDD.t0 VDD.n349 1.09559
R289 VDD.t0 VDD.n1220 8.47732
R290 VDD.n392 VDD.t0 0.484969
R291 VDD.n1231 VDD.t0 8.47732
R292 VDD.t0 VDD.n395 0.484969
R293 VDD.t0 VDD.n1210 8.47732
R294 VDD.n398 VDD.t0 0.484969
R295 VDD.n59 VDD.t0 0.662347
R296 VDD.n1253 VDD.t0 8.47732
R297 VDD.t0 VDD.n401 0.484969
R298 VDD.t0 VDD.n1200 8.47732
R299 VDD.n403 VDD.t0 0.302092
R300 VDD.n1257 VDD.t0 8.47732
R301 VDD.t0 VDD.n353 0.484993
R302 VDD.n28 VDD.n27 0.490042
R303 VDD.n1367 VDD.n120 0.354692
R304 VDD.n121 VDD.t353 1.55338
R305 VDD.n607 VDD.t353 2.32425
R306 VDD.n1366 VDD.n607 0.354557
R307 VDD.n123 VDD.n124 0.116616
R308 VDD.n124 VDD.t353 1.14093
R309 VDD.t353 VDD.n128 0.719046
R310 VDD.n256 VDD.t353 1.2979
R311 VDD.n131 VDD.t353 1.14093
R312 VDD.n1364 VDD.n580 0.354692
R313 VDD.n580 VDD.t353 2.32417
R314 VDD.n1361 VDD.n601 0.354557
R315 VDD.n601 VDD.t353 2.32425
R316 VDD.n136 VDD.n137 0.130979
R317 VDD.n137 VDD.t353 1.55344
R318 VDD.n139 VDD.n140 0.130931
R319 VDD.n1358 VDD.n139 0.355071
R320 VDD.n140 VDD.t353 1.5534
R321 VDD.n143 VDD.t353 1.55337
R322 VDD.n1356 VDD.n134 0.2636
R323 VDD.n606 VDD.t353 5.62581
R324 VDD.n617 VDD.t353 5.62581
R325 VDD.n1324 VDD.n591 0.354405
R326 VDD.n149 VDD.n150 0.130924
R327 VDD.n1352 VDD.n149 0.355147
R328 VDD.n150 VDD.t353 1.55355
R329 VDD.n1329 VDD.n574 0.354933
R330 VDD.n596 VDD.t353 2.32417
R331 VDD.n159 VDD.n160 0.130931
R332 VDD.n154 VDD.n159 0.355071
R333 VDD.n160 VDD.t353 1.5534
R334 VDD.n162 VDD.n163 0.131036
R335 VDD.n1345 VDD.n162 0.354692
R336 VDD.n163 VDD.t353 1.55338
R337 VDD.n577 VDD.t353 2.32406
R338 VDD.n611 VDD.t353 5.62581
R339 VDD.t353 VDD.n167 1.58394
R340 VDD.t353 VDD.n1290 8.47732
R341 VDD.t353 VDD.n15 0.937141
R342 VDD.t9 VDD.n550 8.47732
R343 VDD.t9 VDD.n1391 8.47732
R344 VDD.t9 VDD.n1388 8.47732
R345 VDD.t9 VDD.n1377 8.47732
R346 VDD.t9 VDD.n1380 8.47732
R347 VDD.t9 VDD.n348 1.09559
R348 VDD.t9 VDD.n1422 8.47732
R349 VDD.n381 VDD.t9 0.484969
R350 VDD.n1433 VDD.t9 8.47732
R351 VDD.t9 VDD.n384 0.484969
R352 VDD.t9 VDD.n1412 8.47732
R353 VDD.n387 VDD.t9 0.484969
R354 VDD.n57 VDD.t9 0.662347
R355 VDD.t9 VDD.n1407 8.47732
R356 VDD.t9 VDD.n1401 8.47732
R357 VDD.n389 VDD.t9 0.302092
R358 VDD.n1457 VDD.t9 8.47732
R359 VDD.n344 VDD.t9 0.55681
R360 VDD.n171 VDD.t339 1.75596
R361 VDD.n599 VDD.t339 2.32406
R362 VDD.n178 VDD.t339 1.55355
R363 VDD.n1481 VDD.n253 0.263403
R364 VDD.n311 VDD.t339 1.29815
R365 VDD.n181 VDD.t339 0.677053
R366 VDD.n185 VDD.t339 1.14105
R367 VDD.n522 VDD.t339 2.32417
R368 VDD.n578 VDD.t339 5.62581
R369 VDD.n1482 VDD.n187 0.354692
R370 VDD.n188 VDD.t339 1.55338
R371 VDD.n587 VDD.t339 2.32417
R372 VDD.n595 VDD.t339 2.32417
R373 VDD.n252 VDD.t339 3.32623
R374 VDD.n191 VDD.n192 0.19946
R375 VDD.n192 VDD.t339 0.603572
R376 VDD.n602 VDD.t339 5.62581
R377 VDD.n518 VDD.t339 2.32417
R378 VDD.n557 VDD.t339 1.57542
R379 VDD.n557 VDD.n516 0.410004
R380 VDD.n558 VDD.t339 1.57517
R381 VDD.n1489 VDD.n510 0.354557
R382 VDD.n510 VDD.t339 2.32425
R383 VDD.n197 VDD.n198 0.22368
R384 VDD.n608 VDD.t339 5.62581
R385 VDD.n582 VDD.t339 2.32425
R386 VDD.t339 VDD.n594 5.62581
R387 VDD.t339 VDD.n206 1.55355
R388 VDD.n1496 VDD.t339 8.47732
R389 VDD.t29 VDD.n1580 8.47732
R390 VDD.t29 VDD.n1577 8.47732
R391 VDD.t29 VDD.n1566 8.47732
R392 VDD.t29 VDD.n1569 8.47732
R393 VDD.t29 VDD.n347 1.09559
R394 VDD.t29 VDD.n1610 8.47732
R395 VDD.n367 VDD.t29 0.484969
R396 VDD.n1621 VDD.t29 8.47732
R397 VDD.n370 VDD.n369 0.0415457
R398 VDD.t29 VDD.n370 0.484969
R399 VDD.t29 VDD.n1600 8.47732
R400 VDD.n373 VDD.t29 0.484969
R401 VDD.n55 VDD.t29 0.662347
R402 VDD.n1642 VDD.t29 8.47732
R403 VDD.t29 VDD.n376 0.484969
R404 VDD.t29 VDD.n1590 8.47732
R405 VDD.n378 VDD.t29 0.302092
R406 VDD.n1647 VDD.t29 8.47732
R407 VDD.t29 VDD.n350 0.484993
R408 VDD.t341 VDD.n63 5.55427
R409 VDD.n193 VDD.n194 0.141359
R410 VDD.t341 VDD.n317 0.732519
R411 VDD.n217 VDD.n218 0.116616
R412 VDD.n220 VDD.n221 0.130931
R413 VDD.n1733 VDD.n220 0.355071
R414 VDD.n221 VDD.t341 1.5534
R415 VDD.n590 VDD.t341 2.32417
R416 VDD.n612 VDD.t341 5.62581
R417 VDD.t341 VDD.n227 0.632705
R418 VDD.n268 VDD.n259 0.340727
R419 VDD.n271 VDD.n270 0.223662
R420 VDD.n589 VDD.t341 2.32425
R421 VDD.n1729 VDD.n589 0.354557
R422 VDD.n274 VDD.t341 1.14101
R423 VDD.n576 VDD.t341 5.62581
R424 VDD.n1728 VDD.n323 0.2636
R425 VDD.n613 VDD.t341 5.62581
R426 VDD.n1727 VDD.n579 0.35501
R427 VDD.n579 VDD.t341 2.32417
R428 VDD.n563 VDD.t341 1.57532
R429 VDD.t341 VDD.n1679 8.47732
R430 VDD.t341 VDD.n17 0.937141
R431 VDD.t36 VDD.n545 8.47732
R432 VDD.t36 VDD.n1098 8.47732
R433 VDD.t36 VDD.n1095 8.47732
R434 VDD.t36 VDD.n1084 8.47732
R435 VDD.t36 VDD.n1087 8.47732
R436 VDD.t36 VDD.n346 1.09559
R437 VDD.t36 VDD.n1129 8.47732
R438 VDD.n1139 VDD.t36 8.47732
R439 VDD.n358 VDD.n357 0.0415457
R440 VDD.t36 VDD.n358 0.484969
R441 VDD.t36 VDD.n1119 8.47732
R442 VDD.n360 VDD.n361 0.0415457
R443 VDD.n361 VDD.t36 0.484969
R444 VDD.n53 VDD.t36 0.662347
R445 VDD.n1161 VDD.t36 8.47732
R446 VDD.n364 VDD.n363 0.0415457
R447 VDD.t36 VDD.n364 0.484969
R448 VDD.t36 VDD.n1109 8.47732
R449 VDD.n620 VDD.n1107 0.1666
R450 VDD.n404 VDD.t36 0.391527
R451 VDD.n280 VDD.t381 1.75596
R452 VDD.n490 VDD.t381 2.32417
R453 VDD.n284 VDD.t381 0.677016
R454 VDD.n998 VDD.n610 0.354697
R455 VDD.t381 VDD.n610 2.32417
R456 VDD.n604 VDD.t381 5.62581
R457 VDD.n330 VDD.t381 0.784249
R458 VDD.n329 VDD.n330 0.209638
R459 VDD.n287 VDD.n288 0.22375
R460 VDD.n288 VDD.t381 0.676971
R461 VDD.t381 VDD.n621 5.62581
R462 VDD.n295 VDD.t381 1.55355
R463 VDD.n484 VDD.t381 2.32417
R464 VDD.n1004 VDD.n299 0.355452
R465 VDD.n264 VDD.n301 0.355071
R466 VDD.n302 VDD.t381 1.5534
R467 VDD.n1005 VDD.n465 0.354557
R468 VDD.n451 VDD.t381 0.775137
R469 VDD.n308 VDD.n451 0.277069
R470 VDD.n598 VDD.t381 2.32406
R471 VDD.n458 VDD.t381 0.925609
R472 VDD.n1009 VDD.n458 0.696236
R473 VDD.n333 VDD.t381 1.29815
R474 VDD.n1010 VDD.n450 0.355147
R475 VDD.n463 VDD.t381 1.5534
R476 VDD.n1011 VDD.n600 0.35501
R477 VDD.n600 VDD.t381 2.32417
R478 VDD.n1014 VDD.t381 8.47732
R479 VDD.n11 VDD.t381 0.694757
R480 VDD.t20 VDD.n922 8.47732
R481 VDD.t20 VDD.n919 8.47732
R482 VDD.t20 VDD.n908 8.47732
R483 VDD.t20 VDD.n911 8.47732
R484 VDD.t20 VDD.n345 1.09559
R485 VDD.n946 VDD.t20 8.47732
R486 VDD.n947 VDD.n625 0.1666
R487 VDD.t20 VDD.n932 8.47732
R488 VDD.n624 VDD.n930 0.1666
R489 VDD.n51 VDD.t20 0.662347
R490 VDD.n965 VDD.t20 8.47732
R491 VDD.n966 VDD.n623 0.1666
R492 VDD.n408 VDD.n413 0.253102
R493 VDD.n972 VDD.t20 8.47732
R494 VDD.n973 VDD.n622 0.1666
R495 VDD.t365 VDD.n694 8.47732
R496 VDD.t365 VDD.n866 8.47732
R497 VDD.t365 VDD.n805 8.47732
R498 VDD.t365 VDD.n738 8.47732
R499 VDD.t365 VDD.n704 8.47732
R500 VDD.t365 VDD.n700 8.47732
R501 VDD.t360 VDD.n80 2.74415
R502 VDD.t360 VDD.n82 2.03723
R503 VDD.t360 VDD.n81 2.03723
R504 VDD.n1740 VDD.n336 7.8004
R505 VDD.n336 VDD.n1166 7.79868
R506 VDD.n354 VDD.t1637 7.62594
R507 VDD.n355 VDD.t1636 7.62594
R508 VDD.n355 VDD.t1635 7.62594
R509 VDD.n402 VDD.t1634 7.62594
R510 VDD.n441 VDD.t1633 7.62594
R511 VDD.n441 VDD.t1632 7.62594
R512 VDD.n399 VDD.t1631 7.62594
R513 VDD.n400 VDD.t1630 7.62594
R514 VDD.n400 VDD.t1629 7.62594
R515 VDD.n396 VDD.t1628 7.62594
R516 VDD.n397 VDD.t1627 7.62594
R517 VDD.n397 VDD.t1626 7.62594
R518 VDD.n393 VDD.t1625 7.62594
R519 VDD.n394 VDD.t1624 7.62594
R520 VDD.n394 VDD.t1623 7.62594
R521 VDD.n390 VDD.t1622 7.62594
R522 VDD.n391 VDD.t1621 7.62594
R523 VDD.n391 VDD.t1620 7.62594
R524 VDD.n551 VDD.t1655 7.62594
R525 VDD.n344 VDD.t1654 7.62594
R526 VDD.n343 VDD.t1653 7.62594
R527 VDD.n388 VDD.t1652 7.62594
R528 VDD.n436 VDD.t1651 7.62594
R529 VDD.n436 VDD.t1650 7.62594
R530 VDD.n548 VDD.t1649 7.62594
R531 VDD.n410 VDD.t1648 7.62594
R532 VDD.n409 VDD.t1647 7.62594
R533 VDD.n385 VDD.t1646 7.62594
R534 VDD.n386 VDD.t1645 7.62594
R535 VDD.n386 VDD.t1644 7.62594
R536 VDD.n382 VDD.t1643 7.62594
R537 VDD.n383 VDD.t1642 7.62594
R538 VDD.n383 VDD.t1641 7.62594
R539 VDD.n379 VDD.t1640 7.62594
R540 VDD.n380 VDD.t1639 7.62594
R541 VDD.n380 VDD.t1638 7.62594
R542 VDD.n351 VDD.t1673 7.62594
R543 VDD.n352 VDD.t1672 7.62594
R544 VDD.n352 VDD.t1671 7.62594
R545 VDD.n377 VDD.t1670 7.62594
R546 VDD.n430 VDD.t1669 7.62594
R547 VDD.n430 VDD.t1668 7.62594
R548 VDD.n374 VDD.t1667 7.62594
R549 VDD.n375 VDD.t1666 7.62594
R550 VDD.n375 VDD.t1665 7.62594
R551 VDD.n371 VDD.t1664 7.62594
R552 VDD.n372 VDD.t1663 7.62594
R553 VDD.n372 VDD.t1662 7.62594
R554 VDD.n368 VDD.t1661 7.62594
R555 VDD.n369 VDD.t1660 7.62594
R556 VDD.n369 VDD.t1659 7.62594
R557 VDD.n365 VDD.t1658 7.62594
R558 VDD.n366 VDD.t1657 7.62594
R559 VDD.n366 VDD.t1656 7.62594
R560 VDD.n546 VDD.t1691 7.62594
R561 VDD.n416 VDD.t1690 7.62594
R562 VDD.n415 VDD.t1689 7.62594
R563 VDD.n405 VDD.t1688 7.62594
R564 VDD.n425 VDD.t1687 7.62594
R565 VDD.n1162 VDD.t1686 7.62594
R566 VDD.n362 VDD.t1685 7.62594
R567 VDD.n363 VDD.t1684 7.62594
R568 VDD.n363 VDD.t1683 7.62594
R569 VDD.n359 VDD.t1682 7.62594
R570 VDD.n360 VDD.t1681 7.62594
R571 VDD.n360 VDD.t1680 7.62594
R572 VDD.n356 VDD.t1679 7.62594
R573 VDD.n357 VDD.t1678 7.62594
R574 VDD.n357 VDD.t1677 7.62594
R575 VDD.n20 VDD.t1676 7.62594
R576 VDD.n20 VDD.t1675 7.62594
R577 VDD.n18 VDD.t1674 7.62594
R578 VDD.n7 VDD.t1709 7.62594
R579 VDD.n421 VDD.t1708 7.62594
R580 VDD.n974 VDD.t1707 7.62594
R581 VDD.n407 VDD.t1706 7.62594
R582 VDD.n412 VDD.t1705 7.62594
R583 VDD.n411 VDD.t1704 7.62594
R584 VDD.n4 VDD.t1703 7.62594
R585 VDD.n420 VDD.t1702 7.62594
R586 VDD.n967 VDD.t1701 7.62594
R587 VDD.n3 VDD.t1700 7.62594
R588 VDD.n419 VDD.t1699 7.62594
R589 VDD.n950 VDD.t1698 7.62594
R590 VDD.n0 VDD.t1697 7.62594
R591 VDD.n417 VDD.t1696 7.62594
R592 VDD.n948 VDD.t1695 7.62594
R593 VDD.n24 VDD.t1694 7.62594
R594 VDD.n22 VDD.t1693 7.62594
R595 VDD.n414 VDD.t1692 7.62594
R596 VDD.n1226 VDD.t687 6.16445
R597 VDD.n1428 VDD.t369 6.16445
R598 VDD.n1616 VDD.t1227 6.16445
R599 VDD.n1135 VDD.t338 6.16445
R600 VDD.n942 VDD.t347 6.16445
R601 VDD.n1367 VDD.t575 6.09901
R602 VDD.n1366 VDD.t980 6.09901
R603 VDD.n538 VDD.t540 6.09901
R604 VDD.n1365 VDD.t486 6.09901
R605 VDD.n125 VDD.t1007 6.09901
R606 VDD.n127 VDD.t460 6.09901
R607 VDD.n257 VDD.t1273 6.09901
R608 VDD.n310 VDD.t1347 6.09901
R609 VDD.n1364 VDD.t1346 6.09901
R610 VDD.n534 VDD.t520 6.09901
R611 VDD.n1361 VDD.t1186 6.09901
R612 VDD.n532 VDD.t1103 6.09901
R613 VDD.n1359 VDD.t1078 6.09901
R614 VDD.n1358 VDD.t1008 6.09901
R615 VDD.n1357 VDD.t981 6.09901
R616 VDD.n1356 VDD.t947 6.09901
R617 VDD.n144 VDD.t946 6.09901
R618 VDD.n1353 VDD.t463 6.09901
R619 VDD.n146 VDD.t1081 6.09901
R620 VDD.n1316 VDD.t386 6.09901
R621 VDD.n1320 VDD.t1300 6.09901
R622 VDD.n1324 VDD.t983 6.09901
R623 VDD.n1352 VDD.t522 6.09901
R624 VDD.n1329 VDD.t1408 6.09901
R625 VDD.n1349 VDD.t1405 6.09901
R626 VDD.n1346 VDD.t1400 6.09901
R627 VDD.n153 VDD.t1423 6.09901
R628 VDD.n154 VDD.t1427 6.09901
R629 VDD.n1345 VDD.t1456 6.09901
R630 VDD.n1344 VDD.t1437 6.09901
R631 VDD.n166 VDD.t1441 6.09901
R632 VDD.n167 VDD.t530 6.09901
R633 VDD.n1478 VDD.t1146 6.09901
R634 VDD.n173 VDD.t1478 6.09901
R635 VDD.n529 VDD.t964 6.09901
R636 VDD.n1476 VDD.t454 6.09901
R637 VDD.n175 VDD.t402 6.09901
R638 VDD.n1481 VDD.t1108 6.09901
R639 VDD.n254 VDD.t1485 6.09901
R640 VDD.n527 VDD.t956 6.09901
R641 VDD.n180 VDD.t345 6.09901
R642 VDD.n182 VDD.t487 6.09901
R643 VDD.n521 VDD.t564 6.09901
R644 VDD.n524 VDD.t346 6.09901
R645 VDD.n1482 VDD.t1252 6.09901
R646 VDD.n1483 VDD.t362 6.09901
R647 VDD.n1486 VDD.t424 6.09901
R648 VDD.n251 VDD.t1033 6.09901
R649 VDD.n189 VDD.t560 6.09901
R650 VDD.n191 VDD.t1241 6.09901
R651 VDD.n517 VDD.t1114 6.09901
R652 VDD.n520 VDD.t492 6.09901
R653 VDD.n516 VDD.t1115 6.09901
R654 VDD.n514 VDD.t1116 6.09901
R655 VDD.n1489 VDD.t364 6.09901
R656 VDD.n195 VDD.t495 6.09901
R657 VDD.n197 VDD.t998 6.09901
R658 VDD.n1490 VDD.t968 6.09901
R659 VDD.n473 VDD.t935 6.09901
R660 VDD.n313 VDD.t458 6.09901
R661 VDD.n200 VDD.t999 6.09901
R662 VDD.n201 VDD.t1470 6.09901
R663 VDD.n203 VDD.t1222 6.09901
R664 VDD.n233 VDD.t937 6.09901
R665 VDD.n193 VDD.t422 6.09901
R666 VDD.n509 VDD.t427 6.09901
R667 VDD.n507 VDD.t1508 6.09901
R668 VDD.n1686 VDD.t344 6.09901
R669 VDD.n214 VDD.t489 6.09901
R670 VDD.n215 VDD.t1247 6.09901
R671 VDD.n318 VDD.t1245 6.09901
R672 VDD.n316 VDD.t727 6.09901
R673 VDD.n504 VDD.t525 6.09901
R674 VDD.n1692 VDD.t426 6.09901
R675 VDD.n1733 VDD.t734 6.09901
R676 VDD.n1732 VDD.t1029 6.09901
R677 VDD.n1699 VDD.t722 6.09901
R678 VDD.n225 VDD.t562 6.09901
R679 VDD.n222 VDD.t431 6.09901
R680 VDD.n501 VDD.t473 6.09901
R681 VDD.n320 VDD.t389 6.09901
R682 VDD.n226 VDD.t1268 6.09901
R683 VDD.n258 VDD.t414 6.09901
R684 VDD.n268 VDD.t735 6.09901
R685 VDD.n270 VDD.t571 6.09901
R686 VDD.n1729 VDD.t701 6.09901
R687 VDD.n499 VDD.t1142 6.09901
R688 VDD.n497 VDD.t342 6.09901
R689 VDD.n1712 VDD.t962 6.09901
R690 VDD.n260 VDD.t551 6.09901
R691 VDD.n1728 VDD.t739 6.09901
R692 VDD.n323 VDD.t413 6.09901
R693 VDD.n1727 VDD.t1449 6.09901
R694 VDD.n495 VDD.t1266 6.09901
R695 VDD.n493 VDD.t698 6.09901
R696 VDD.n341 VDD.t993 6.09901
R697 VDD.n489 VDD.t1317 6.09901
R698 VDD.n281 VDD.t1152 6.09901
R699 VDD.n283 VDD.t1013 6.09901
R700 VDD.n488 VDD.t1017 6.09901
R701 VDD.n998 VDD.t1015 6.09901
R702 VDD.n999 VDD.t1330 6.09901
R703 VDD.n329 VDD.t692 6.09901
R704 VDD.n285 VDD.t518 6.09901
R705 VDD.n287 VDD.t566 6.09901
R706 VDD.n289 VDD.t944 6.09901
R707 VDD.n262 VDD.t942 6.09901
R708 VDD.n993 VDD.t1057 6.09901
R709 VDD.n292 VDD.t1005 6.09901
R710 VDD.n483 VDD.t978 6.09901
R711 VDD.n467 VDD.t568 6.09901
R712 VDD.n297 VDD.t1100 6.09901
R713 VDD.n1004 VDD.t1062 6.09901
R714 VDD.n264 VDD.t697 6.09901
R715 VDD.n1005 VDD.t1060 6.09901
R716 VDD.n464 VDD.t382 6.09901
R717 VDD.n305 VDD.t576 6.09901
R718 VDD.n991 VDD.t579 6.09901
R719 VDD.n1008 VDD.t1067 6.09901
R720 VDD.n308 VDD.t578 6.09901
R721 VDD.n990 VDD.t580 6.09901
R722 VDD.n1009 VDD.t1068 6.09901
R723 VDD.n331 VDD.t1132 6.09901
R724 VDD.n333 VDD.t383 6.09901
R725 VDD.n1010 VDD.t715 6.09901
R726 VDD.n450 VDD.t541 6.09901
R727 VDD.n1011 VDD.t461 6.09901
R728 VDD.n328 VDD.t1344 6.09901
R729 VDD.n899 VDD.t966 6.09901
R730 VDD.n893 VDD.t494 6.09901
R731 VDD.n887 VDD.t455 6.09901
R732 VDD.n881 VDD.t457 6.09901
R733 VDD.n875 VDD.t1042 6.09901
R734 VDD.n869 VDD.t1039 6.09901
R735 VDD.n862 VDD.t1046 6.09901
R736 VDD.n856 VDD.t1043 6.09901
R737 VDD.n850 VDD.t929 6.09901
R738 VDD.n844 VDD.t366 6.09901
R739 VDD.n838 VDD.t1048 6.09901
R740 VDD.n832 VDD.t679 6.09901
R741 VDD.n826 VDD.t707 6.09901
R742 VDD.n820 VDD.t934 6.09901
R743 VDD.n814 VDD.t509 6.09901
R744 VDD.n808 VDD.t1223 6.09901
R745 VDD.n801 VDD.t1488 6.09901
R746 VDD.n795 VDD.t1469 6.09901
R747 VDD.n789 VDD.t710 6.09901
R748 VDD.n783 VDD.t549 6.09901
R749 VDD.n777 VDD.t1526 6.09901
R750 VDD.n771 VDD.t938 6.09901
R751 VDD.n765 VDD.t375 6.09901
R752 VDD.n759 VDD.t681 6.09901
R753 VDD.n753 VDD.t459 6.09901
R754 VDD.n747 VDD.t376 6.09901
R755 VDD.n741 VDD.t539 6.09901
R756 VDD.n733 VDD.t1276 6.09901
R757 VDD.n727 VDD.t378 6.09901
R758 VDD.n721 VDD.t1579 6.09901
R759 VDD.n715 VDD.t684 6.09901
R760 VDD.n709 VDD.t1051 6.09901
R761 VDD.n355 VDD.t523 5.99122
R762 VDD.n441 VDD.t1530 5.99122
R763 VDD.n400 VDD.t672 5.99122
R764 VDD.n397 VDD.t421 5.99122
R765 VDD.n394 VDD.t704 5.99122
R766 VDD.n391 VDD.t1457 5.99122
R767 VDD.n344 VDD.t1384 5.99122
R768 VDD.n436 VDD.t1393 5.99122
R769 VDD.n410 VDD.t1253 5.99122
R770 VDD.n386 VDD.t1257 5.99122
R771 VDD.n383 VDD.t1045 5.99122
R772 VDD.n380 VDD.t1049 5.99122
R773 VDD.n352 VDD.t490 5.99122
R774 VDD.n430 VDD.t415 5.99122
R775 VDD.n375 VDD.t723 5.99122
R776 VDD.n372 VDD.t393 5.99122
R777 VDD.n369 VDD.t963 5.99122
R778 VDD.n366 VDD.t488 5.99122
R779 VDD.n416 VDD.t1016 5.99122
R780 VDD.n424 VDD.t1097 5.99122
R781 VDD.n363 VDD.t1006 5.99122
R782 VDD.n360 VDD.t1436 5.99122
R783 VDD.n357 VDD.t581 5.99122
R784 VDD.n20 VDD.t716 5.99122
R785 VDD.n975 VDD.t1120 5.99122
R786 VDD.n412 VDD.t930 5.99122
R787 VDD.n968 VDD.t708 5.99122
R788 VDD.n418 VDD.t1395 5.99122
R789 VDD.n949 VDD.t1368 5.99122
R790 VDD.n22 VDD.t1003 5.99122
R791 VDD.n656 VDD.t559 5.9886
R792 VDD.n238 VDD.t354 5.98839
R793 VDD.n241 VDD.t1110 5.98839
R794 VDD.n244 VDD.t1234 5.98839
R795 VDD.n247 VDD.t412 5.98839
R796 VDD.n250 VDD.t1141 5.98839
R797 VDD.n632 VDD.t990 5.97675
R798 VDD.n632 VDD.t477 5.97675
R799 VDD.n1180 VDD.t471 5.97169
R800 VDD.n1177 VDD.t1240 5.97169
R801 VDD.n1188 VDD.t753 5.97169
R802 VDD.n238 VDD.t1484 5.97169
R803 VDD.n1381 VDD.t1284 5.97169
R804 VDD.n1378 VDD.t1053 5.97169
R805 VDD.n1389 VDD.t1319 5.97169
R806 VDD.n241 VDD.t1418 5.97169
R807 VDD.n1570 VDD.t476 5.97169
R808 VDD.n1567 VDD.t482 5.97169
R809 VDD.n1578 VDD.t554 5.97169
R810 VDD.n244 VDD.t437 5.97169
R811 VDD.n1088 VDD.t1414 5.97169
R812 VDD.n1085 VDD.t1388 5.97169
R813 VDD.n1096 VDD.t1410 5.97169
R814 VDD.n247 VDD.t1606 5.97169
R815 VDD.n912 VDD.t1314 5.97169
R816 VDD.n909 VDD.t1390 5.97169
R817 VDD.n920 VDD.t1386 5.97169
R818 VDD.n250 VDD.t1357 5.97169
R819 VDD.n1180 VDD.t1020 5.97146
R820 VDD.n1177 VDD.t589 5.97146
R821 VDD.n1188 VDD.t1027 5.97146
R822 VDD.n238 VDD.t1564 5.97146
R823 VDD.n1381 VDD.t941 5.97146
R824 VDD.n1378 VDD.t976 5.97146
R825 VDD.n1389 VDD.t380 5.97146
R826 VDD.n241 VDD.t1614 5.97146
R827 VDD.n1570 VDD.t1112 5.97146
R828 VDD.n1567 VDD.t725 5.97146
R829 VDD.n1578 VDD.t583 5.97146
R830 VDD.n244 VDD.t429 5.97146
R831 VDD.n1088 VDD.t1251 5.97146
R832 VDD.n1085 VDD.t758 5.97146
R833 VDD.n1096 VDD.t989 5.97146
R834 VDD.n247 VDD.t992 5.97146
R835 VDD.n912 VDD.t1447 5.97146
R836 VDD.n909 VDD.t1453 5.97146
R837 VDD.n920 VDD.t1451 5.97146
R838 VDD.n250 VDD.t1599 5.97146
R839 VDD.n1167 VDD.t39 5.96935
R840 VDD.n355 VDD.t329 5.96935
R841 VDD.n355 VDD.t396 5.96935
R842 VDD.n355 VDD.t325 5.96935
R843 VDD.n355 VDD.t60 5.96935
R844 VDD.n403 VDD.t27 5.96935
R845 VDD.n1258 VDD.t328 5.96935
R846 VDD.n441 VDD.t79 5.96935
R847 VDD.n441 VDD.t81 5.96935
R848 VDD.n441 VDD.t71 5.96935
R849 VDD.n441 VDD.t64 5.96935
R850 VDD.n1205 VDD.t57 5.96935
R851 VDD.n440 VDD.t74 5.96935
R852 VDD.n400 VDD.t55 5.96935
R853 VDD.n400 VDD.t62 5.96935
R854 VDD.n400 VDD.t314 5.96935
R855 VDD.n400 VDD.t324 5.96935
R856 VDD.n1233 VDD.t3 5.96935
R857 VDD.n439 VDD.t317 5.96935
R858 VDD.n397 VDD.t304 5.96935
R859 VDD.n397 VDD.t336 5.96935
R860 VDD.n397 VDD.t75 5.96935
R861 VDD.n397 VDD.t321 5.96935
R862 VDD.n1215 VDD.t70 5.96935
R863 VDD.n438 VDD.t78 5.96935
R864 VDD.n394 VDD.t16 5.96935
R865 VDD.n394 VDD.t2 5.96935
R866 VDD.n394 VDD.t331 5.96935
R867 VDD.n394 VDD.t1542 5.96935
R868 VDD.n1227 VDD.t67 5.96935
R869 VDD.n1232 VDD.t334 5.96935
R870 VDD.n391 VDD.t322 5.96935
R871 VDD.n391 VDD.t26 5.96935
R872 VDD.n391 VDD.t5 5.96935
R873 VDD.n391 VDD.t19 5.96935
R874 VDD.n437 VDD.t8 5.96935
R875 VDD.n1368 VDD.t82 5.96935
R876 VDD.n344 VDD.t85 5.96935
R877 VDD.n344 VDD.t84 5.96935
R878 VDD.n344 VDD.t89 5.96935
R879 VDD.n344 VDD.t88 5.96935
R880 VDD.n389 VDD.t201 5.96935
R881 VDD.n342 VDD.t92 5.96935
R882 VDD.n436 VDD.t174 5.96935
R883 VDD.n436 VDD.t173 5.96935
R884 VDD.n436 VDD.t178 5.96935
R885 VDD.n436 VDD.t177 5.96935
R886 VDD.n1406 VDD.t292 5.96935
R887 VDD.n435 VDD.t181 5.96935
R888 VDD.n410 VDD.t296 5.96935
R889 VDD.n410 VDD.t295 5.96935
R890 VDD.n410 VDD.t300 5.96935
R891 VDD.n410 VDD.t299 5.96935
R892 VDD.n1434 VDD.t123 5.96935
R893 VDD.n410 VDD.t303 5.96935
R894 VDD.n386 VDD.t127 5.96935
R895 VDD.n386 VDD.t126 5.96935
R896 VDD.n386 VDD.t131 5.96935
R897 VDD.n386 VDD.t130 5.96935
R898 VDD.n1417 VDD.t330 5.96935
R899 VDD.n434 VDD.t134 5.96935
R900 VDD.n383 VDD.t263 5.96935
R901 VDD.n383 VDD.t262 5.96935
R902 VDD.n383 VDD.t267 5.96935
R903 VDD.n383 VDD.t266 5.96935
R904 VDD.n1429 VDD.t10 5.96935
R905 VDD.n433 VDD.t270 5.96935
R906 VDD.n380 VDD.t14 5.96935
R907 VDD.n380 VDD.t13 5.96935
R908 VDD.n380 VDD.t274 5.96935
R909 VDD.n380 VDD.t273 5.96935
R910 VDD.n432 VDD.t277 5.96935
R911 VDD.n1557 VDD.t245 5.96935
R912 VDD.n352 VDD.t248 5.96935
R913 VDD.n352 VDD.t247 5.96935
R914 VDD.n352 VDD.t252 5.96935
R915 VDD.n352 VDD.t251 5.96935
R916 VDD.n378 VDD.t97 5.96935
R917 VDD.n431 VDD.t255 5.96935
R918 VDD.n430 VDD.t237 5.96935
R919 VDD.n430 VDD.t236 5.96935
R920 VDD.n430 VDD.t241 5.96935
R921 VDD.n430 VDD.t240 5.96935
R922 VDD.n1595 VDD.t41 5.96935
R923 VDD.n429 VDD.t244 5.96935
R924 VDD.n375 VDD.t45 5.96935
R925 VDD.n375 VDD.t44 5.96935
R926 VDD.n375 VDD.t49 5.96935
R927 VDD.n375 VDD.t48 5.96935
R928 VDD.n1622 VDD.t160 5.96935
R929 VDD.n1643 VDD.t52 5.96935
R930 VDD.n372 VDD.t164 5.96935
R931 VDD.n372 VDD.t163 5.96935
R932 VDD.n372 VDD.t168 5.96935
R933 VDD.n372 VDD.t167 5.96935
R934 VDD.n1605 VDD.t101 5.96935
R935 VDD.n428 VDD.t171 5.96935
R936 VDD.n369 VDD.t105 5.96935
R937 VDD.n369 VDD.t104 5.96935
R938 VDD.n369 VDD.t109 5.96935
R939 VDD.n369 VDD.t108 5.96935
R940 VDD.n1617 VDD.t30 5.96935
R941 VDD.n427 VDD.t112 5.96935
R942 VDD.n366 VDD.t34 5.96935
R943 VDD.n366 VDD.t33 5.96935
R944 VDD.n366 VDD.t190 5.96935
R945 VDD.n366 VDD.t189 5.96935
R946 VDD.n426 VDD.t193 5.96935
R947 VDD.n1075 VDD.t149 5.96935
R948 VDD.n416 VDD.t152 5.96935
R949 VDD.n416 VDD.t151 5.96935
R950 VDD.n416 VDD.t156 5.96935
R951 VDD.n416 VDD.t155 5.96935
R952 VDD.n406 VDD.t68 5.96935
R953 VDD.n416 VDD.t159 5.96935
R954 VDD.n425 VDD.t220 5.96935
R955 VDD.n425 VDD.t219 5.96935
R956 VDD.n425 VDD.t224 5.96935
R957 VDD.n425 VDD.t223 5.96935
R958 VDD.n1114 VDD.t280 5.96935
R959 VDD.n1107 VDD.t279 5.96935
R960 VDD.n363 VDD.t284 5.96935
R961 VDD.n363 VDD.t283 5.96935
R962 VDD.n363 VDD.t288 5.96935
R963 VDD.n363 VDD.t287 5.96935
R964 VDD.n1141 VDD.t206 5.96935
R965 VDD.n423 VDD.t291 5.96935
R966 VDD.n360 VDD.t210 5.96935
R967 VDD.n360 VDD.t209 5.96935
R968 VDD.n360 VDD.t214 5.96935
R969 VDD.n360 VDD.t213 5.96935
R970 VDD.n1124 VDD.t37 5.96935
R971 VDD.n422 VDD.t217 5.96935
R972 VDD.n357 VDD.t139 5.96935
R973 VDD.n357 VDD.t138 5.96935
R974 VDD.n357 VDD.t143 5.96935
R975 VDD.n357 VDD.t142 5.96935
R976 VDD.n20 VDD.t256 5.96935
R977 VDD.n1140 VDD.t146 5.96935
R978 VDD.n20 VDD.t260 5.96935
R979 VDD.n20 VDD.t259 5.96935
R980 VDD.n20 VDD.t184 5.96935
R981 VDD.n20 VDD.t183 5.96935
R982 VDD.n19 VDD.t187 5.96935
R983 VDD.n7 VDD.t313 5.96935
R984 VDD.n421 VDD.t113 5.96935
R985 VDD.n421 VDD.t135 5.96935
R986 VDD.n421 VDD.t119 5.96935
R987 VDD.n421 VDD.t116 5.96935
R988 VDD.n408 VDD.t312 5.96935
R989 VDD.n973 VDD.t122 5.96935
R990 VDD.n412 VDD.t306 5.96935
R991 VDD.n412 VDD.t311 5.96935
R992 VDD.n412 VDD.t1198 5.96935
R993 VDD.n412 VDD.t309 5.96935
R994 VDD.n4 VDD.t117 5.96935
R995 VDD.n412 VDD.t1201 5.96935
R996 VDD.n420 VDD.t23 5.96935
R997 VDD.n420 VDD.t398 5.96935
R998 VDD.n420 VDD.t21 5.96935
R999 VDD.n420 VDD.t234 5.96935
R1000 VDD.n3 VDD.t1202 5.96935
R1001 VDD.n966 VDD.t319 5.96935
R1002 VDD.n419 VDD.t200 5.96935
R1003 VDD.n419 VDD.t54 5.96935
R1004 VDD.n419 VDD.t202 5.96935
R1005 VDD.n419 VDD.t195 5.96935
R1006 VDD.n0 VDD.t99 5.96935
R1007 VDD.n930 VDD.t205 5.96935
R1008 VDD.n417 VDD.t230 5.96935
R1009 VDD.n417 VDD.t232 5.96935
R1010 VDD.n417 VDD.t196 5.96935
R1011 VDD.n417 VDD.t96 5.96935
R1012 VDD.n24 VDD.t65 5.96935
R1013 VDD.n947 VDD.t199 5.96935
R1014 VDD.n22 VDD.t271 5.96935
R1015 VDD.n22 VDD.t148 5.96935
R1016 VDD.n22 VDD.t226 5.96935
R1017 VDD.n22 VDD.t94 5.96935
R1018 VDD.n22 VDD.t229 5.96935
R1019 VDD.n573 VDD.t1419 5.96534
R1020 VDD.n468 VDD.t1463 5.96534
R1021 VDD.n238 VDD.t388 5.96534
R1022 VDD.n1174 VDD.t510 5.96534
R1023 VDD.n1172 VDD.t760 5.96534
R1024 VDD.n1191 VDD.t515 5.96534
R1025 VDD.n1193 VDD.t979 5.96534
R1026 VDD.n1169 VDD.t1209 5.96534
R1027 VDD.n355 VDD.t350 5.96534
R1028 VDD.n355 VDD.t686 5.96534
R1029 VDD.n355 VDD.t1587 5.96534
R1030 VDD.n355 VDD.t1294 5.96534
R1031 VDD.n1256 VDD.t1205 5.96534
R1032 VDD.n1254 VDD.t1174 5.96534
R1033 VDD.n403 VDD.t506 5.96534
R1034 VDD.n403 VDD.t674 5.96534
R1035 VDD.n441 VDD.t467 5.96534
R1036 VDD.n441 VDD.t1350 5.96534
R1037 VDD.n441 VDD.t513 5.96534
R1038 VDD.n1199 VDD.t1206 5.96534
R1039 VDD.n1197 VDD.t521 5.96534
R1040 VDD.n1203 VDD.t507 5.96534
R1041 VDD.n400 VDD.t1187 5.96534
R1042 VDD.n400 VDD.t688 5.96534
R1043 VDD.n400 VDD.t1102 5.96534
R1044 VDD.n400 VDD.t516 5.96534
R1045 VDD.n1252 VDD.t1210 5.96534
R1046 VDD.n1250 VDD.t1076 5.96534
R1047 VDD.n1246 VDD.t994 5.96534
R1048 VDD.n1244 VDD.t474 5.96534
R1049 VDD.n1242 VDD.t690 5.96534
R1050 VDD.n87 VDD.t1079 5.96534
R1051 VDD.n60 VDD.t511 5.96534
R1052 VDD.n443 VDD.t1140 5.96534
R1053 VDD.n1241 VDD.t1204 5.96534
R1054 VDD.n1239 VDD.t1361 5.96534
R1055 VDD.n1235 VDD.t505 5.96534
R1056 VDD.n397 VDD.t1365 5.96534
R1057 VDD.n397 VDD.t468 5.96534
R1058 VDD.n397 VDD.t385 5.96534
R1059 VDD.n397 VDD.t512 5.96534
R1060 VDD.n1209 VDD.t1207 5.96534
R1061 VDD.n1207 VDD.t982 5.96534
R1062 VDD.n1213 VDD.t514 5.96534
R1063 VDD.n394 VDD.t1476 5.96534
R1064 VDD.n394 VDD.t689 5.96534
R1065 VDD.n394 VDD.t1412 5.96534
R1066 VDD.n394 VDD.t517 5.96534
R1067 VDD.n1230 VDD.t1211 5.96534
R1068 VDD.n1228 VDD.t1399 5.96534
R1069 VDD.n477 VDD.t995 5.96534
R1070 VDD.n391 VDD.t1157 5.96534
R1071 VDD.n391 VDD.t691 5.96534
R1072 VDD.n391 VDD.t1601 5.96534
R1073 VDD.n391 VDD.t1293 5.96534
R1074 VDD.n1219 VDD.t1295 5.96534
R1075 VDD.n1217 VDD.t1438 5.96534
R1076 VDD.n1223 VDD.t1208 5.96534
R1077 VDD.n1225 VDD.t747 5.96534
R1078 VDD.n572 VDD.t960 5.96534
R1079 VDD.n469 VDD.t400 5.96534
R1080 VDD.n241 VDD.t1398 5.96534
R1081 VDD.n1375 VDD.t1121 5.96534
R1082 VDD.n1373 VDD.t1147 5.96534
R1083 VDD.n1392 VDD.t1125 5.96534
R1084 VDD.n1394 VDD.t1477 5.96534
R1085 VDD.n1370 VDD.t1213 5.96534
R1086 VDD.n552 VDD.t1336 5.96534
R1087 VDD.n344 VDD.t368 5.96534
R1088 VDD.n344 VDD.t535 5.96534
R1089 VDD.n344 VDD.t1306 5.96534
R1090 VDD.n1456 VDD.t1093 5.96534
R1091 VDD.n1454 VDD.t1109 5.96534
R1092 VDD.n389 VDD.t1181 5.96534
R1093 VDD.n389 VDD.t1308 5.96534
R1094 VDD.n436 VDD.t1305 5.96534
R1095 VDD.n436 VDD.t1156 5.96534
R1096 VDD.n436 VDD.t1124 5.96534
R1097 VDD.n1400 VDD.t1094 5.96534
R1098 VDD.n1398 VDD.t702 5.96534
R1099 VDD.n1404 VDD.t1182 5.96534
R1100 VDD.n549 VDD.t1161 5.96534
R1101 VDD.n410 VDD.t370 5.96534
R1102 VDD.n410 VDD.t1238 5.96534
R1103 VDD.n410 VDD.t1373 5.96534
R1104 VDD.n1453 VDD.t1215 5.96534
R1105 VDD.n1451 VDD.t952 5.96534
R1106 VDD.n1447 VDD.t1184 5.96534
R1107 VDD.n1445 VDD.t1343 5.96534
R1108 VDD.n1443 VDD.t372 5.96534
R1109 VDD.n86 VDD.t1467 5.96534
R1110 VDD.n58 VDD.t1122 5.96534
R1111 VDD.n444 VDD.t561 5.96534
R1112 VDD.n1442 VDD.t1092 5.96534
R1113 VDD.n1440 VDD.t1546 5.96534
R1114 VDD.n1436 VDD.t1171 5.96534
R1115 VDD.n386 VDD.t1309 5.96534
R1116 VDD.n386 VDD.t1375 5.96534
R1117 VDD.n386 VDD.t493 5.96534
R1118 VDD.n386 VDD.t1123 5.96534
R1119 VDD.n1411 VDD.t1095 5.96534
R1120 VDD.n1409 VDD.t1118 5.96534
R1121 VDD.n1415 VDD.t1183 5.96534
R1122 VDD.n383 VDD.t363 5.96534
R1123 VDD.n383 VDD.t371 5.96534
R1124 VDD.n383 VDD.t496 5.96534
R1125 VDD.n383 VDD.t1374 5.96534
R1126 VDD.n1432 VDD.t1216 5.96534
R1127 VDD.n1430 VDD.t1084 5.96534
R1128 VDD.n479 VDD.t1185 5.96534
R1129 VDD.n380 VDD.t936 5.96534
R1130 VDD.n380 VDD.t373 5.96534
R1131 VDD.n380 VDD.t932 5.96534
R1132 VDD.n380 VDD.t1307 5.96534
R1133 VDD.n1421 VDD.t1304 5.96534
R1134 VDD.n1419 VDD.t1503 5.96534
R1135 VDD.n1425 VDD.t1214 5.96534
R1136 VDD.n1427 VDD.t1221 5.96534
R1137 VDD.n570 VDD.t741 5.96534
R1138 VDD.n470 VDD.t574 5.96534
R1139 VDD.n244 VDD.t705 5.96534
R1140 VDD.n1564 VDD.t718 5.96534
R1141 VDD.n1562 VDD.t423 5.96534
R1142 VDD.n1581 VDD.t1218 5.96534
R1143 VDD.n1583 VDD.t754 5.96534
R1144 VDD.n1559 VDD.t1075 5.96534
R1145 VDD.n352 VDD.t472 5.96534
R1146 VDD.n352 VDD.t1226 5.96534
R1147 VDD.n352 VDD.t343 5.96534
R1148 VDD.n352 VDD.t1533 5.96534
R1149 VDD.n1646 VDD.t1071 5.96534
R1150 VDD.n1644 VDD.t1565 5.96534
R1151 VDD.n378 VDD.t1444 5.96534
R1152 VDD.n378 VDD.t955 5.96534
R1153 VDD.n430 VDD.t1292 5.96534
R1154 VDD.n430 VDD.t728 5.96534
R1155 VDD.n430 VDD.t719 5.96534
R1156 VDD.n1589 VDD.t1072 5.96534
R1157 VDD.n1587 VDD.t425 5.96534
R1158 VDD.n1593 VDD.t1445 5.96534
R1159 VDD.n375 VDD.t435 5.96534
R1160 VDD.n375 VDD.t1228 5.96534
R1161 VDD.n375 VDD.t1263 5.96534
R1162 VDD.n375 VDD.t1219 5.96534
R1163 VDD.n1641 VDD.t1031 5.96534
R1164 VDD.n1639 VDD.t563 5.96534
R1165 VDD.n1635 VDD.t1290 5.96534
R1166 VDD.n1633 VDD.t479 5.96534
R1167 VDD.n1631 VDD.t1248 5.96534
R1168 VDD.n85 VDD.t1230 5.96534
R1169 VDD.n56 VDD.t1217 5.96534
R1170 VDD.n445 VDD.t673 5.96534
R1171 VDD.n1630 VDD.t1070 5.96534
R1172 VDD.n1628 VDD.t1267 5.96534
R1173 VDD.n1624 VDD.t1443 5.96534
R1174 VDD.n372 VDD.t744 5.96534
R1175 VDD.n372 VDD.t558 5.96534
R1176 VDD.n372 VDD.t1261 5.96534
R1177 VDD.n372 VDD.t720 5.96534
R1178 VDD.n1599 VDD.t1073 5.96534
R1179 VDD.n1597 VDD.t700 5.96534
R1180 VDD.n1603 VDD.t1289 5.96534
R1181 VDD.n369 VDD.t986 5.96534
R1182 VDD.n369 VDD.t1229 5.96534
R1183 VDD.n369 VDD.t340 5.96534
R1184 VDD.n369 VDD.t1220 5.96534
R1185 VDD.n1620 VDD.t1032 5.96534
R1186 VDD.n1618 VDD.t1025 5.96534
R1187 VDD.n481 VDD.t1291 5.96534
R1188 VDD.n366 VDD.t676 5.96534
R1189 VDD.n366 VDD.t1249 5.96534
R1190 VDD.n366 VDD.t670 5.96534
R1191 VDD.n366 VDD.t1532 5.96534
R1192 VDD.n1609 VDD.t1534 5.96534
R1193 VDD.n1607 VDD.t1265 5.96534
R1194 VDD.n1613 VDD.t1074 5.96534
R1195 VDD.n1615 VDD.t1159 5.96534
R1196 VDD.n568 VDD.t556 5.96534
R1197 VDD.n471 VDD.t432 5.96534
R1198 VDD.n247 VDD.t1422 5.96534
R1199 VDD.n1082 VDD.t1190 5.96534
R1200 VDD.n1080 VDD.t1322 5.96534
R1201 VDD.n1099 VDD.t586 5.96534
R1202 VDD.n1101 VDD.t1153 5.96534
R1203 VDD.n1077 VDD.t1194 5.96534
R1204 VDD.n547 VDD.t1055 5.96534
R1205 VDD.n416 VDD.t337 5.96534
R1206 VDD.n416 VDD.t1018 5.96534
R1207 VDD.n416 VDD.t590 5.96534
R1208 VDD.n1165 VDD.t466 5.96534
R1209 VDD.n1163 VDD.t1329 5.96534
R1210 VDD.n459 VDD.t1378 5.96534
R1211 VDD.n406 VDD.t693 5.96534
R1212 VDD.n425 VDD.t1535 5.96534
R1213 VDD.n425 VDD.t519 5.96534
R1214 VDD.n425 VDD.t585 5.96534
R1215 VDD.n1108 VDD.t1192 5.96534
R1216 VDD.n1105 VDD.t945 5.96534
R1217 VDD.n1112 VDD.t1379 5.96534
R1218 VDD.n363 VDD.t943 5.96534
R1219 VDD.n363 VDD.t1195 5.96534
R1220 VDD.n363 VDD.t1098 5.96534
R1221 VDD.n363 VDD.t408 5.96534
R1222 VDD.n1160 VDD.t1302 5.96534
R1223 VDD.n1158 VDD.t1334 5.96534
R1224 VDD.n1154 VDD.t1381 5.96534
R1225 VDD.n1152 VDD.t1429 5.96534
R1226 VDD.n1150 VDD.t1279 5.96534
R1227 VDD.n84 VDD.t1101 5.96534
R1228 VDD.n54 VDD.t1191 5.96534
R1229 VDD.n446 VDD.t1490 5.96534
R1230 VDD.n1149 VDD.t465 5.96534
R1231 VDD.n1147 VDD.t696 5.96534
R1232 VDD.n1143 VDD.t1377 5.96534
R1233 VDD.n360 VDD.t1061 5.96534
R1234 VDD.n360 VDD.t1212 5.96534
R1235 VDD.n360 VDD.t1585 5.96534
R1236 VDD.n360 VDD.t1501 5.96534
R1237 VDD.n1118 VDD.t1193 5.96534
R1238 VDD.n1116 VDD.t1064 5.96534
R1239 VDD.n1122 VDD.t1380 5.96534
R1240 VDD.n357 VDD.t1066 5.96534
R1241 VDD.n357 VDD.t1196 5.96534
R1242 VDD.n357 VDD.t577 5.96534
R1243 VDD.n357 VDD.t409 5.96534
R1244 VDD.n1138 VDD.t1303 5.96534
R1245 VDD.n1136 VDD.t1341 5.96534
R1246 VDD.n20 VDD.t1382 5.96534
R1247 VDD.n20 VDD.t1131 5.96534
R1248 VDD.n20 VDD.t1280 5.96534
R1249 VDD.n20 VDD.t1589 5.96534
R1250 VDD.n20 VDD.t1376 5.96534
R1251 VDD.n1128 VDD.t1197 5.96534
R1252 VDD.n1126 VDD.t542 5.96534
R1253 VDD.n1132 VDD.t1301 5.96534
R1254 VDD.n1134 VDD.t462 5.96534
R1255 VDD.n567 VDD.t1570 5.96534
R1256 VDD.n472 VDD.t504 5.96534
R1257 VDD.n250 VDD.t1351 5.96534
R1258 VDD.n906 VDD.t1009 5.96534
R1259 VDD.n904 VDD.t967 5.96534
R1260 VDD.n923 VDD.t410 5.96534
R1261 VDD.n6 VDD.t996 5.96534
R1262 VDD.n7 VDD.t1536 5.96534
R1263 VDD.n7 VDD.t1036 5.96534
R1264 VDD.n421 VDD.t1521 5.96534
R1265 VDD.n421 VDD.t1037 5.96534
R1266 VDD.n421 VDD.t547 5.96534
R1267 VDD.n971 VDD.t1287 5.96534
R1268 VDD.n969 VDD.t1041 5.96534
R1269 VDD.n460 VDD.t529 5.96534
R1270 VDD.n408 VDD.t1086 5.96534
R1271 VDD.n412 VDD.t706 5.96534
R1272 VDD.n412 VDD.t1525 5.96534
R1273 VDD.n412 VDD.t584 5.96534
R1274 VDD.n927 VDD.t1288 5.96534
R1275 VDD.n925 VDD.t367 5.96534
R1276 VDD.n4 VDD.t1498 5.96534
R1277 VDD.n4 VDD.t1089 5.96534
R1278 VDD.n420 VDD.t348 5.96534
R1279 VDD.n420 VDD.t678 5.96534
R1280 VDD.n420 VDD.t387 5.96534
R1281 VDD.n964 VDD.t501 5.96534
R1282 VDD.n962 VDD.t933 5.96534
R1283 VDD.n958 VDD.t497 5.96534
R1284 VDD.n956 VDD.t508 5.96534
R1285 VDD.n954 VDD.t531 5.96534
R1286 VDD.n83 VDD.t1225 5.96534
R1287 VDD.n52 VDD.t1285 5.96534
R1288 VDD.n447 VDD.t1391 5.96534
R1289 VDD.n953 VDD.t1286 5.96534
R1290 VDD.n951 VDD.t1474 5.96534
R1291 VDD.n3 VDD.t528 5.96534
R1292 VDD.n3 VDD.t709 5.96534
R1293 VDD.n419 VDD.t1500 5.96534
R1294 VDD.n419 VDD.t714 5.96534
R1295 VDD.n419 VDD.t1531 5.96534
R1296 VDD.n931 VDD.t721 5.96534
R1297 VDD.n928 VDD.t939 5.96534
R1298 VDD.n0 VDD.t1499 5.96534
R1299 VDD.n0 VDD.t374 5.96534
R1300 VDD.n417 VDD.t349 5.96534
R1301 VDD.n417 VDD.t680 5.96534
R1302 VDD.n417 VDD.t726 5.96534
R1303 VDD.n945 VDD.t1203 5.96534
R1304 VDD.n943 VDD.t377 5.96534
R1305 VDD.n24 VDD.t498 5.96534
R1306 VDD.n24 VDD.t1001 5.96534
R1307 VDD.n22 VDD.t532 5.96534
R1308 VDD.n22 VDD.t1578 5.96534
R1309 VDD.n22 VDD.t717 5.96534
R1310 VDD.n936 VDD.t491 5.96534
R1311 VDD.n934 VDD.t1581 5.96534
R1312 VDD.n939 VDD.t1537 5.96534
R1313 VDD.n941 VDD.t685 5.96534
R1314 VDD.n1194 VDD.t958 5.96512
R1315 VDD.n573 VDD.t1177 5.96512
R1316 VDD.n468 VDD.t1167 5.96512
R1317 VDD.n403 VDD.t536 5.96512
R1318 VDD.n1201 VDD.t1126 5.96512
R1319 VDD.n1237 VDD.t957 5.96512
R1320 VDD.n87 VDD.t1128 5.96512
R1321 VDD.n1248 VDD.t1127 5.96512
R1322 VDD.n1211 VDD.t537 5.96512
R1323 VDD.n477 VDD.t538 5.96512
R1324 VDD.n1221 VDD.t533 5.96512
R1325 VDD.n1395 VDD.t683 5.96512
R1326 VDD.n572 VDD.t1136 5.96512
R1327 VDD.n469 VDD.t1149 5.96512
R1328 VDD.n389 VDD.t971 5.96512
R1329 VDD.n1402 VDD.t767 5.96512
R1330 VDD.n1438 VDD.t384 5.96512
R1331 VDD.n86 VDD.t675 5.96512
R1332 VDD.n1449 VDD.t677 5.96512
R1333 VDD.n1413 VDD.t972 5.96512
R1334 VDD.n479 VDD.t973 5.96512
R1335 VDD.n1423 VDD.t965 5.96512
R1336 VDD.n1584 VDD.t1021 5.96512
R1337 VDD.n570 VDD.t419 5.96512
R1338 VDD.n470 VDD.t738 5.96512
R1339 VDD.n378 VDD.t1106 5.96512
R1340 VDD.n1591 VDD.t1281 5.96512
R1341 VDD.n1626 VDD.t1282 5.96512
R1342 VDD.n85 VDD.t420 5.96512
R1343 VDD.n1637 VDD.t1296 5.96512
R1344 VDD.n1601 VDD.t1107 5.96512
R1345 VDD.n481 VDD.t527 5.96512
R1346 VDD.n1611 VDD.t1069 5.96512
R1347 VDD.n1102 VDD.t1170 5.96512
R1348 VDD.n568 VDD.t405 5.96512
R1349 VDD.n471 VDD.t1242 5.96512
R1350 VDD.n459 VDD.t1539 5.96512
R1351 VDD.n1110 VDD.t1176 5.96512
R1352 VDD.n1145 VDD.t1433 5.96512
R1353 VDD.n84 VDD.t430 5.96512
R1354 VDD.n1156 VDD.t569 5.96512
R1355 VDD.n1120 VDD.t1540 5.96512
R1356 VDD.n20 VDD.t1538 5.96512
R1357 VDD.n1130 VDD.t550 5.96512
R1358 VDD.n7 VDD.t469 5.96512
R1359 VDD.n567 VDD.t1164 5.96512
R1360 VDD.n472 VDD.t484 5.96512
R1361 VDD.n460 VDD.t711 5.96512
R1362 VDD.n4 VDD.t587 5.96512
R1363 VDD.n3 VDD.t546 5.96512
R1364 VDD.n83 VDD.t1513 5.96512
R1365 VDD.n960 VDD.t480 5.96512
R1366 VDD.n0 VDD.t712 5.96512
R1367 VDD.n24 VDD.t395 5.96512
R1368 VDD.n937 VDD.t1619 5.96512
R1369 VDD.n654 VDD.t358 5.96478
R1370 VDD.n354 VDD.t40 5.65005
R1371 VDD.n355 VDD.t59 5.65005
R1372 VDD.n355 VDD.t326 5.65005
R1373 VDD.n402 VDD.t28 5.65005
R1374 VDD.n441 VDD.t63 5.65005
R1375 VDD.n441 VDD.t72 5.65005
R1376 VDD.n399 VDD.t58 5.65005
R1377 VDD.n400 VDD.t56 5.65005
R1378 VDD.n400 VDD.t315 5.65005
R1379 VDD.n396 VDD.t4 5.65005
R1380 VDD.n397 VDD.t305 5.65005
R1381 VDD.n397 VDD.t76 5.65005
R1382 VDD.n393 VDD.t1 5.65005
R1383 VDD.n394 VDD.t17 5.65005
R1384 VDD.n394 VDD.t332 5.65005
R1385 VDD.n390 VDD.t25 5.65005
R1386 VDD.n391 VDD.t18 5.65005
R1387 VDD.n391 VDD.t6 5.65005
R1388 VDD.n551 VDD.t83 5.65005
R1389 VDD.n344 VDD.t86 5.65005
R1390 VDD.n343 VDD.t90 5.65005
R1391 VDD.n388 VDD.t172 5.65005
R1392 VDD.n436 VDD.t175 5.65005
R1393 VDD.n436 VDD.t179 5.65005
R1394 VDD.n548 VDD.t293 5.65005
R1395 VDD.n410 VDD.t297 5.65005
R1396 VDD.n409 VDD.t301 5.65005
R1397 VDD.n385 VDD.t124 5.65005
R1398 VDD.n386 VDD.t128 5.65005
R1399 VDD.n386 VDD.t132 5.65005
R1400 VDD.n382 VDD.t261 5.65005
R1401 VDD.n383 VDD.t264 5.65005
R1402 VDD.n383 VDD.t268 5.65005
R1403 VDD.n379 VDD.t11 5.65005
R1404 VDD.n380 VDD.t15 5.65005
R1405 VDD.n380 VDD.t275 5.65005
R1406 VDD.n351 VDD.t246 5.65005
R1407 VDD.n352 VDD.t249 5.65005
R1408 VDD.n352 VDD.t253 5.65005
R1409 VDD.n377 VDD.t98 5.65005
R1410 VDD.n430 VDD.t238 5.65005
R1411 VDD.n430 VDD.t242 5.65005
R1412 VDD.n374 VDD.t42 5.65005
R1413 VDD.n375 VDD.t46 5.65005
R1414 VDD.n375 VDD.t50 5.65005
R1415 VDD.n371 VDD.t161 5.65005
R1416 VDD.n372 VDD.t165 5.65005
R1417 VDD.n372 VDD.t169 5.65005
R1418 VDD.n368 VDD.t102 5.65005
R1419 VDD.n369 VDD.t106 5.65005
R1420 VDD.n369 VDD.t110 5.65005
R1421 VDD.n365 VDD.t31 5.65005
R1422 VDD.n366 VDD.t35 5.65005
R1423 VDD.n366 VDD.t191 5.65005
R1424 VDD.n546 VDD.t150 5.65005
R1425 VDD.n416 VDD.t153 5.65005
R1426 VDD.n415 VDD.t157 5.65005
R1427 VDD.n405 VDD.t69 5.65005
R1428 VDD.n425 VDD.t221 5.65005
R1429 VDD.n1162 VDD.t225 5.65005
R1430 VDD.n362 VDD.t281 5.65005
R1431 VDD.n363 VDD.t285 5.65005
R1432 VDD.n363 VDD.t289 5.65005
R1433 VDD.n359 VDD.t207 5.65005
R1434 VDD.n360 VDD.t211 5.65005
R1435 VDD.n360 VDD.t215 5.65005
R1436 VDD.n356 VDD.t38 5.65005
R1437 VDD.n357 VDD.t140 5.65005
R1438 VDD.n357 VDD.t144 5.65005
R1439 VDD.n20 VDD.t257 5.65005
R1440 VDD.n20 VDD.t182 5.65005
R1441 VDD.n18 VDD.t185 5.65005
R1442 VDD.n7 VDD.t136 5.65005
R1443 VDD.n421 VDD.t114 5.65005
R1444 VDD.n974 VDD.t120 5.65005
R1445 VDD.n407 VDD.t310 5.65005
R1446 VDD.n412 VDD.t307 5.65005
R1447 VDD.n411 VDD.t1199 5.65005
R1448 VDD.n4 VDD.t118 5.65005
R1449 VDD.n420 VDD.t24 5.65005
R1450 VDD.n967 VDD.t22 5.65005
R1451 VDD.n3 VDD.t53 5.65005
R1452 VDD.n419 VDD.t194 5.65005
R1453 VDD.n950 VDD.t203 5.65005
R1454 VDD.n0 VDD.t100 5.65005
R1455 VDD.n417 VDD.t95 5.65005
R1456 VDD.n948 VDD.t197 5.65005
R1457 VDD.n24 VDD.t66 5.65005
R1458 VDD.n22 VDD.t93 5.65005
R1459 VDD.n414 VDD.t227 5.65005
R1460 VDD.t351 VDD.n1743 5.62581
R1461 VDD.t351 VDD.n1741 5.62581
R1462 VDD.t0 VDD.n1192 5.62581
R1463 VDD.t0 VDD.n236 1.33386
R1464 VDD.t0 VDD.n1175 5.62581
R1465 VDD.t0 VDD.n1185 5.62581
R1466 VDD.t0 VDD.n1178 5.62581
R1467 VDD.t0 VDD.n1183 5.62581
R1468 VDD.n349 VDD.n1180 0.233973
R1469 VDD.t0 VDD.n1218 5.62581
R1470 VDD.n1227 VDD.n477 0.253621
R1471 VDD.n1229 VDD.t0 5.62581
R1472 VDD.t0 VDD.n1208 5.62581
R1473 VDD.n1240 VDD.t0 5.62581
R1474 VDD.n443 VDD.n59 0.322864
R1475 VDD.n87 VDD.n70 0.140426
R1476 VDD.n1251 VDD.t0 5.62581
R1477 VDD.t0 VDD.n1198 5.62581
R1478 VDD.n1255 VDD.t0 5.62581
R1479 VDD.n583 VDD.t353 2.32417
R1480 VDD.n1362 VDD.t353 5.62581
R1481 VDD.n1360 VDD.t353 5.62581
R1482 VDD.n142 VDD.n143 0.13099
R1483 VDD.n1357 VDD.n142 0.354838
R1484 VDD.n1354 VDD.t353 5.62581
R1485 VDD.n581 VDD.t353 2.32449
R1486 VDD.n1350 VDD.t353 5.62581
R1487 VDD.n1347 VDD.t353 5.62581
R1488 VDD.n1344 VDD.n577 0.354771
R1489 VDD.t9 VDD.n1393 5.62581
R1490 VDD.t9 VDD.n239 1.33386
R1491 VDD.t9 VDD.n1376 5.62581
R1492 VDD.t9 VDD.n1386 5.62581
R1493 VDD.t9 VDD.n1379 5.62581
R1494 VDD.t9 VDD.n1384 5.62581
R1495 VDD.n348 VDD.n1381 0.233973
R1496 VDD.t9 VDD.n1420 5.62581
R1497 VDD.n1429 VDD.n479 0.253621
R1498 VDD.n1431 VDD.t9 5.62581
R1499 VDD.t9 VDD.n1410 5.62581
R1500 VDD.n1441 VDD.t9 5.62581
R1501 VDD.n444 VDD.n57 0.322864
R1502 VDD.n86 VDD.n71 0.140426
R1503 VDD.n1452 VDD.t9 5.62581
R1504 VDD.t9 VDD.n1399 5.62581
R1505 VDD.n1455 VDD.t9 5.62581
R1506 VDD.n170 VDD.n171 0.133751
R1507 VDD.n1480 VDD.t339 5.62581
R1508 VDD.n177 VDD.n178 0.130922
R1509 VDD.n253 VDD.t339 3.32623
R1510 VDD.n1485 VDD.t339 5.62581
R1511 VDD.n1486 VDD.n595 0.354697
R1512 VDD.n1488 VDD.t339 5.62581
R1513 VDD.n1492 VDD.t339 5.62581
R1514 VDD.n1494 VDD.t339 5.62581
R1515 VDD.n205 VDD.n206 0.130922
R1516 VDD.t29 VDD.n1582 5.62581
R1517 VDD.t29 VDD.n242 1.33386
R1518 VDD.t29 VDD.n1565 5.62581
R1519 VDD.t29 VDD.n1575 5.62581
R1520 VDD.t29 VDD.n1568 5.62581
R1521 VDD.t29 VDD.n1573 5.62581
R1522 VDD.n347 VDD.n1570 0.233973
R1523 VDD.t29 VDD.n1608 5.62581
R1524 VDD.n1617 VDD.n481 0.253621
R1525 VDD.n1619 VDD.t29 5.62581
R1526 VDD.t29 VDD.n1598 5.62581
R1527 VDD.n1629 VDD.t29 5.62581
R1528 VDD.n445 VDD.n55 0.322864
R1529 VDD.n85 VDD.n72 0.140426
R1530 VDD.n1640 VDD.t29 5.62581
R1531 VDD.t29 VDD.n1588 5.62581
R1532 VDD.n1645 VDD.t29 5.62581
R1533 VDD.n1734 VDD.t341 5.62581
R1534 VDD.n1730 VDD.t341 5.62581
R1535 VDD.t36 VDD.n1100 5.62581
R1536 VDD.t36 VDD.n245 1.33386
R1537 VDD.t36 VDD.n1083 5.62581
R1538 VDD.t36 VDD.n1093 5.62581
R1539 VDD.t36 VDD.n1086 5.62581
R1540 VDD.t36 VDD.n1091 5.62581
R1541 VDD.n346 VDD.n1088 0.233973
R1542 VDD.t36 VDD.n1127 5.62581
R1543 VDD.n1137 VDD.t36 5.62581
R1544 VDD.t36 VDD.n1117 5.62581
R1545 VDD.n1148 VDD.t36 5.62581
R1546 VDD.n446 VDD.n53 0.322864
R1547 VDD.n84 VDD.n73 0.140426
R1548 VDD.n1159 VDD.t36 5.62581
R1549 VDD.t36 VDD.n1106 5.62581
R1550 VDD.n1164 VDD.t36 5.62581
R1551 VDD.n279 VDD.n280 0.133751
R1552 VDD.n997 VDD.t381 5.62581
R1553 VDD.n1001 VDD.t381 5.62581
R1554 VDD.n1003 VDD.t381 5.62581
R1555 VDD.n465 VDD.t381 2.32425
R1556 VDD.n584 VDD.t381 2.32411
R1557 VDD.n1007 VDD.t381 5.62581
R1558 VDD.n327 VDD.t381 5.62581
R1559 VDD.n452 VDD.t381 0.860848
R1560 VDD.t20 VDD.n924 5.62581
R1561 VDD.t20 VDD.n248 1.33386
R1562 VDD.t20 VDD.n907 5.62581
R1563 VDD.t20 VDD.n917 5.62581
R1564 VDD.t20 VDD.n910 5.62581
R1565 VDD.t20 VDD.n915 5.62581
R1566 VDD.n345 VDD.n912 0.233973
R1567 VDD.t20 VDD.n935 5.62581
R1568 VDD.n944 VDD.t20 5.62581
R1569 VDD.t20 VDD.n929 5.62581
R1570 VDD.n952 VDD.t20 5.62581
R1571 VDD.n447 VDD.n51 0.322864
R1572 VDD.n83 VDD.n74 0.140426
R1573 VDD.n963 VDD.t20 5.62581
R1574 VDD.t20 VDD.n926 5.62581
R1575 VDD.n970 VDD.t20 5.62581
R1576 VDD.t365 VDD.n900 5.62581
R1577 VDD.t365 VDD.n894 5.62581
R1578 VDD.t365 VDD.n888 5.62581
R1579 VDD.t365 VDD.n882 5.62581
R1580 VDD.t365 VDD.n876 5.62581
R1581 VDD.t365 VDD.n870 5.62581
R1582 VDD.t365 VDD.n863 5.62581
R1583 VDD.t365 VDD.n857 5.62581
R1584 VDD.t365 VDD.n851 5.62581
R1585 VDD.t365 VDD.n845 5.62581
R1586 VDD.t365 VDD.n839 5.62581
R1587 VDD.t365 VDD.n833 5.62581
R1588 VDD.t365 VDD.n827 5.62581
R1589 VDD.t365 VDD.n821 5.62581
R1590 VDD.t365 VDD.n815 5.62581
R1591 VDD.t365 VDD.n809 5.62581
R1592 VDD.t365 VDD.n802 5.62581
R1593 VDD.t365 VDD.n796 5.62581
R1594 VDD.t365 VDD.n790 5.62581
R1595 VDD.t365 VDD.n784 5.62581
R1596 VDD.t365 VDD.n778 5.62581
R1597 VDD.t365 VDD.n772 5.62581
R1598 VDD.t365 VDD.n766 5.62581
R1599 VDD.t365 VDD.n760 5.62581
R1600 VDD.t365 VDD.n754 5.62581
R1601 VDD.t365 VDD.n748 5.62581
R1602 VDD.t365 VDD.n742 5.62581
R1603 VDD.t365 VDD.n734 5.62581
R1604 VDD.t365 VDD.n728 5.62581
R1605 VDD.t365 VDD.n722 5.62581
R1606 VDD.t365 VDD.n716 5.62581
R1607 VDD.t365 VDD.n710 5.62581
R1608 VDD.t365 VDD.n708 5.62581
R1609 VDD.t352 VDD.n618 0.496969
R1610 VDD.t352 VDD.n629 5.61485
R1611 VDD.t352 VDD.n652 5.61485
R1612 VDD.n16 VDD.t659 5.68637
R1613 VDD.n30 VDD.t648 5.60969
R1614 VDD.n1736 VDD.t637 5.60969
R1615 VDD.n9 VDD.t605 5.60969
R1616 VDD.n21 VDD.t593 5.60969
R1617 VDD.n636 VDD.t626 5.60969
R1618 VDD.n639 VDD.t631 5.60969
R1619 VDD.n455 VDD.t667 5.60347
R1620 VDD.n454 VDD.t664 5.60347
R1621 VDD.n15 VDD.t662 5.60347
R1622 VDD.n232 VDD.t656 5.60347
R1623 VDD.n231 VDD.t653 5.60347
R1624 VDD.n31 VDD.t651 5.60347
R1625 VDD.n339 VDD.t645 5.60347
R1626 VDD.n338 VDD.t642 5.60347
R1627 VDD.n17 VDD.t640 5.60347
R1628 VDD.n324 VDD.t613 5.60347
R1629 VDD.n325 VDD.t610 5.60347
R1630 VDD.n11 VDD.t608 5.60347
R1631 VDD.n698 VDD.t602 5.60347
R1632 VDD.t365 VDD.t596 5.60347
R1633 VDD.n702 VDD.t599 5.60347
R1634 VDD.n66 VDD.t629 5.60347
R1635 VDD.n75 VDD.t634 5.60347
R1636 VDD.n453 VDD.t665 5.59675
R1637 VDD.n165 VDD.t928 5.59675
R1638 VDD.n1339 VDD.t927 5.59675
R1639 VDD.n161 VDD.t926 5.59675
R1640 VDD.n158 VDD.t791 5.59675
R1641 VDD.n156 VDD.t923 5.59675
R1642 VDD.n152 VDD.t924 5.59675
R1643 VDD.n1333 VDD.t925 5.59675
R1644 VDD.n1331 VDD.t796 5.59675
R1645 VDD.n148 VDD.t922 5.59675
R1646 VDD.n1326 VDD.t795 5.59675
R1647 VDD.n1322 VDD.t784 5.59675
R1648 VDD.n1318 VDD.t911 5.59675
R1649 VDD.n1314 VDD.t907 5.59675
R1650 VDD.n145 VDD.t908 5.59675
R1651 VDD.n1311 VDD.t788 5.59675
R1652 VDD.n133 VDD.t912 5.59675
R1653 VDD.n141 VDD.t921 5.59675
R1654 VDD.n138 VDD.t769 5.59675
R1655 VDD.n135 VDD.t920 5.59675
R1656 VDD.n1306 VDD.t918 5.59675
R1657 VDD.n530 VDD.t916 5.59675
R1658 VDD.n1303 VDD.t919 5.59675
R1659 VDD.n533 VDD.t917 5.59675
R1660 VDD.n129 VDD.t774 5.59675
R1661 VDD.n535 VDD.t915 5.59675
R1662 VDD.n255 VDD.t792 5.59675
R1663 VDD.n126 VDD.t914 5.59675
R1664 VDD.n536 VDD.t909 5.59675
R1665 VDD.n122 VDD.t913 5.59675
R1666 VDD.n537 VDD.t910 5.59675
R1667 VDD.n119 VDD.t906 5.59675
R1668 VDD.n26 VDD.t802 5.59675
R1669 VDD.n230 VDD.t654 5.59675
R1670 VDD.n204 VDD.t905 5.59675
R1671 VDD.n1469 VDD.t903 5.59675
R1672 VDD.n199 VDD.t902 5.59675
R1673 VDD.n1468 VDD.t904 5.59675
R1674 VDD.n312 VDD.t901 5.59675
R1675 VDD.n1467 VDD.t789 5.59675
R1676 VDD.n1466 VDD.t898 5.59675
R1677 VDD.n196 VDD.t900 5.59675
R1678 VDD.n511 VDD.t899 5.59675
R1679 VDD.n1465 VDD.t781 5.59675
R1680 VDD.n513 VDD.t779 5.59675
R1681 VDD.n515 VDD.t799 5.59675
R1682 VDD.n519 VDD.t772 5.59675
R1683 VDD.n1464 VDD.t804 5.59675
R1684 VDD.n190 VDD.t780 5.59675
R1685 VDD.n42 VDD.t790 5.59675
R1686 VDD.n1463 VDD.t897 5.59675
R1687 VDD.n1462 VDD.t896 5.59675
R1688 VDD.n186 VDD.t895 5.59675
R1689 VDD.n1461 VDD.t777 5.59675
R1690 VDD.n523 VDD.t778 5.59675
R1691 VDD.n183 VDD.t798 5.59675
R1692 VDD.n525 VDD.t892 5.59675
R1693 VDD.n179 VDD.t893 5.59675
R1694 VDD.n526 VDD.t894 5.59675
R1695 VDD.n111 VDD.t771 5.59675
R1696 VDD.n176 VDD.t848 5.59675
R1697 VDD.n1460 VDD.t891 5.59675
R1698 VDD.n1459 VDD.t849 5.59675
R1699 VDD.n528 VDD.t851 5.59675
R1700 VDD.n172 VDD.t850 5.59675
R1701 VDD.n169 VDD.t852 5.59675
R1702 VDD.n337 VDD.t643 5.59675
R1703 VDD.n1723 VDD.t889 5.59675
R1704 VDD.n492 VDD.t887 5.59675
R1705 VDD.n494 VDD.t888 5.59675
R1706 VDD.n1719 VDD.t890 5.59675
R1707 VDD.n321 VDD.t869 5.59675
R1708 VDD.n1715 VDD.t885 5.59675
R1709 VDD.n275 VDD.t886 5.59675
R1710 VDD.n272 VDD.t884 5.59675
R1711 VDD.n496 VDD.t775 5.59675
R1712 VDD.n498 VDD.t883 5.59675
R1713 VDD.n1708 VDD.t786 5.59675
R1714 VDD.n269 VDD.t871 5.59675
R1715 VDD.n267 VDD.t876 5.59675
R1716 VDD.n265 VDD.t880 5.59675
R1717 VDD.n228 VDD.t881 5.59675
R1718 VDD.n319 VDD.t882 5.59675
R1719 VDD.n500 VDD.t770 5.59675
R1720 VDD.n502 VDD.t879 5.59675
R1721 VDD.n224 VDD.t870 5.59675
R1722 VDD.n1697 VDD.t872 5.59675
R1723 VDD.n219 VDD.t873 5.59675
R1724 VDD.n1694 VDD.t878 5.59675
R1725 VDD.n216 VDD.t783 5.59675
R1726 VDD.n503 VDD.t874 5.59675
R1727 VDD.n505 VDD.t875 5.59675
R1728 VDD.n315 VDD.t776 5.59675
R1729 VDD.n213 VDD.t877 5.59675
R1730 VDD.n210 VDD.t768 5.59675
R1731 VDD.n207 VDD.t787 5.59675
R1732 VDD.n506 VDD.t867 5.59675
R1733 VDD.n508 VDD.t868 5.59675
R1734 VDD.n61 VDD.t785 5.59675
R1735 VDD.n326 VDD.t611 5.59675
R1736 VDD.n986 VDD.t866 5.59675
R1737 VDD.n461 VDD.t811 5.59675
R1738 VDD.n449 VDD.t865 5.59675
R1739 VDD.n985 VDD.t863 5.59675
R1740 VDD.n332 VDD.t864 5.59675
R1741 VDD.n457 VDD.t794 5.59675
R1742 VDD.n984 VDD.t862 5.59675
R1743 VDD.n307 VDD.t861 5.59675
R1744 VDD.n306 VDD.t801 5.59675
R1745 VDD.n983 VDD.t855 5.59675
R1746 VDD.n982 VDD.t856 5.59675
R1747 VDD.n303 VDD.t860 5.59675
R1748 VDD.n466 VDD.t773 5.59675
R1749 VDD.n300 VDD.t857 5.59675
R1750 VDD.n298 VDD.t859 5.59675
R1751 VDD.n37 VDD.t793 5.59675
R1752 VDD.n296 VDD.t858 5.59675
R1753 VDD.n485 VDD.t807 5.59675
R1754 VDD.n293 VDD.t854 5.59675
R1755 VDD.n981 VDD.t812 5.59675
R1756 VDD.n980 VDD.t846 5.59675
R1757 VDD.n290 VDD.t847 5.59675
R1758 VDD.n979 VDD.t845 5.59675
R1759 VDD.n286 VDD.t853 5.59675
R1760 VDD.n486 VDD.t806 5.59675
R1761 VDD.n105 VDD.t829 5.59675
R1762 VDD.n978 VDD.t843 5.59675
R1763 VDD.n977 VDD.t844 5.59675
R1764 VDD.n487 VDD.t805 5.59675
R1765 VDD.n282 VDD.t813 5.59675
R1766 VDD.n491 VDD.t810 5.59675
R1767 VDD.n278 VDD.t832 5.59675
R1768 VDD.n901 VDD.t820 5.59675
R1769 VDD.n896 VDD.t808 5.59675
R1770 VDD.n890 VDD.t803 5.59675
R1771 VDD.n884 VDD.t822 5.59675
R1772 VDD.n878 VDD.t821 5.59675
R1773 VDD.n872 VDD.t817 5.59675
R1774 VDD.n864 VDD.t816 5.59675
R1775 VDD.n859 VDD.t815 5.59675
R1776 VDD.n853 VDD.t782 5.59675
R1777 VDD.n847 VDD.t800 5.59675
R1778 VDD.n841 VDD.t826 5.59675
R1779 VDD.n835 VDD.t824 5.59675
R1780 VDD.n829 VDD.t828 5.59675
R1781 VDD.n823 VDD.t827 5.59675
R1782 VDD.n817 VDD.t823 5.59675
R1783 VDD.n811 VDD.t831 5.59675
R1784 VDD.n803 VDD.t830 5.59675
R1785 VDD.n798 VDD.t833 5.59675
R1786 VDD.n792 VDD.t809 5.59675
R1787 VDD.n786 VDD.t819 5.59675
R1788 VDD.n780 VDD.t818 5.59675
R1789 VDD.n774 VDD.t835 5.59675
R1790 VDD.n768 VDD.t834 5.59675
R1791 VDD.n762 VDD.t814 5.59675
R1792 VDD.n756 VDD.t840 5.59675
R1793 VDD.n750 VDD.t838 5.59675
R1794 VDD.n744 VDD.t837 5.59675
R1795 VDD.n736 VDD.t839 5.59675
R1796 VDD.n730 VDD.t836 5.59675
R1797 VDD.n724 VDD.t842 5.59675
R1798 VDD.n718 VDD.t841 5.59675
R1799 VDD.n712 VDD.t825 5.59675
R1800 VDD.n706 VDD.t598 5.59675
R1801 VDD.n638 VDD.t797 5.59675
R1802 VDD.n309 VDD.t647 5.59179
R1803 VDD.n13 VDD.t594 5.68043
R1804 VDD.n65 VDD.t627 5.59179
R1805 VDD.n640 VDD.t632 5.59179
R1806 VDD.n1778 VDD.t617 4.9462
R1807 VDD.n1752 VDD.t614 4.9462
R1808 VDD.n21 VDD.n33 4.9425
R1809 VDD.n33 VDD.t365 4.94216
R1810 VDD.n544 VDD.n25 2.4024
R1811 VDD.n542 VDD.n31 4.94216
R1812 VDD.n168 VDD.n542 4.94216
R1813 VDD.n334 VDD.n50 2.4024
R1814 VDD.n335 VDD.n12 2.44836
R1815 VDD.n646 VDD.n645 4.90372
R1816 VDD.n151 VDD 4.39103
R1817 VDD.n474 VDD 4.39103
R1818 VDD.n323 VDD 4.39103
R1819 VDD.n333 VDD 4.39103
R1820 VDD.n739 VDD 4.39103
R1821 VDD.t0 VDD.n1168 4.19244
R1822 VDD.t0 VDD.n1195 4.19244
R1823 VDD.t0 VDD.n1216 4.19244
R1824 VDD.n478 VDD.t0 1.75602
R1825 VDD.t0 VDD.n1214 4.19244
R1826 VDD.t0 VDD.n1206 4.19244
R1827 VDD.n1234 VDD.t0 4.19244
R1828 VDD.n1238 VDD.t0 4.19244
R1829 VDD.n1249 VDD.t0 4.19244
R1830 VDD.t0 VDD.n1204 4.19244
R1831 VDD.t0 VDD.n1196 4.19244
R1832 VDD.t9 VDD.n1369 4.19244
R1833 VDD.t9 VDD.n1396 4.19244
R1834 VDD.t9 VDD.n1418 4.19244
R1835 VDD.n480 VDD.t9 1.75602
R1836 VDD.t9 VDD.n1416 4.19244
R1837 VDD.t9 VDD.n1408 4.19244
R1838 VDD.n1435 VDD.t9 4.19244
R1839 VDD.n1439 VDD.t9 4.19244
R1840 VDD.n1450 VDD.t9 4.19244
R1841 VDD.t9 VDD.n1405 4.19244
R1842 VDD.t9 VDD.n1397 4.19244
R1843 VDD.t29 VDD.n1558 4.19244
R1844 VDD.t29 VDD.n1585 4.19244
R1845 VDD.t29 VDD.n1606 4.19244
R1846 VDD.n482 VDD.t29 1.75602
R1847 VDD.t29 VDD.n1604 4.19244
R1848 VDD.t29 VDD.n1596 4.19244
R1849 VDD.n1623 VDD.t29 4.19244
R1850 VDD.n1627 VDD.t29 4.19244
R1851 VDD.n1638 VDD.t29 4.19244
R1852 VDD.t29 VDD.n1594 4.19244
R1853 VDD.t29 VDD.n1586 4.19244
R1854 VDD.t36 VDD.n1076 4.19244
R1855 VDD.t36 VDD.n1103 4.19244
R1856 VDD.t36 VDD.n1125 4.19244
R1857 VDD.t36 VDD.n1123 4.19244
R1858 VDD.t36 VDD.n1115 4.19244
R1859 VDD.n1142 VDD.t36 4.19244
R1860 VDD.n1146 VDD.t36 4.19244
R1861 VDD.n1157 VDD.t36 4.19244
R1862 VDD.t36 VDD.n1113 4.19244
R1863 VDD.t36 VDD.n1104 4.19244
R1864 VDD.t20 VDD.n8 0.408271
R1865 VDD.t20 VDD.n933 4.19244
R1866 VDD.n24 VDD.n23 0.584656
R1867 VDD.t20 VDD.n1 0.408269
R1868 VDD.n2 VDD.t20 0.408269
R1869 VDD.n961 VDD.t20 4.19244
R1870 VDD.t20 VDD.n5 0.408269
R1871 VDD.t365 VDD.n686 4.19244
R1872 VDD.t351 VDD.n1772 4.19238
R1873 VDD.t351 VDD.n659 4.19225
R1874 VDD.t351 VDD.n1744 4.19225
R1875 VDD.t353 VDD.n1282 4.19225
R1876 VDD.n1510 VDD.t339 4.19225
R1877 VDD.t341 VDD.n1671 4.19225
R1878 VDD.n1028 VDD.t381 4.19225
R1879 VDD.n403 VDD 4.14317
R1880 VDD.n389 VDD 4.14317
R1881 VDD.n378 VDD 4.14317
R1882 VDD.n459 VDD 4.14317
R1883 VDD.n460 VDD 4.14317
R1884 VDD.n1509 VDD 3.92864
R1885 VDD.n1027 VDD 3.92864
R1886 VDD.n70 VDD 3.92317
R1887 VDD.n1283 VDD 3.92317
R1888 VDD.n46 VDD 3.92317
R1889 VDD.n116 VDD 3.92317
R1890 VDD.n71 VDD 3.92317
R1891 VDD.n44 VDD 3.92317
R1892 VDD.n113 VDD 3.92317
R1893 VDD.n72 VDD 3.92317
R1894 VDD.n1672 VDD 3.92317
R1895 VDD.n41 VDD 3.92317
R1896 VDD.n110 VDD 3.92317
R1897 VDD.n73 VDD 3.92317
R1898 VDD.n39 VDD 3.92317
R1899 VDD.n107 VDD 3.92317
R1900 VDD.n74 VDD 3.92317
R1901 VDD.n687 VDD 3.92317
R1902 VDD.n36 VDD 3.92317
R1903 VDD.n104 VDD 3.92317
R1904 VDD.n442 VDD 3.92317
R1905 VDD.n477 VDD 3.92023
R1906 VDD.n479 VDD 3.92023
R1907 VDD.n481 VDD 3.92023
R1908 VDD.n20 VDD 3.92023
R1909 VDD.n24 VDD 3.92023
R1910 VDD.n134 VDD 3.90557
R1911 VDD.n257 VDD 3.90557
R1912 VDD.n189 VDD 3.90557
R1913 VDD.n254 VDD 3.90557
R1914 VDD.n476 VDD 3.90557
R1915 VDD.n475 VDD 3.90557
R1916 VDD.n297 VDD 3.90557
R1917 VDD.n329 VDD 3.90557
R1918 VDD.n806 VDD 3.90557
R1919 VDD.n867 VDD 3.90557
R1920 VDD.n236 VDD.n1174 0.428743
R1921 VDD.n1241 VDD.n443 0.341
R1922 VDD.n239 VDD.n1375 0.428743
R1923 VDD.n1442 VDD.n444 0.341
R1924 VDD.n242 VDD.n1564 0.428743
R1925 VDD.n1630 VDD.n445 0.341
R1926 VDD.n245 VDD.n1082 0.428743
R1927 VDD.n1149 VDD.n446 0.341
R1928 VDD.n248 VDD.n906 0.428743
R1929 VDD.n953 VDD.n447 0.341
R1930 VDD.t365 VDD.n807 3.32633
R1931 VDD.t365 VDD.n740 3.32633
R1932 VDD.t365 VDD.n868 3.32615
R1933 VDD.t352 VDD.n655 3.31243
R1934 VDD.t352 VDD.n628 3.30723
R1935 VDD.t352 VDD.n630 3.30723
R1936 VDD.t352 VDD.n648 3.30723
R1937 VDD.n541 VDD.n571 0.0192234
R1938 VDD.n540 VDD.n569 0.0192234
R1939 VDD.n539 VDD.n566 0.0192234
R1940 VDD.t352 VDD.n634 2.77558
R1941 VDD.t0 VDD.n1171 2.74446
R1942 VDD.t0 VDD.n1173 2.74446
R1943 VDD.t0 VDD.n1224 2.74446
R1944 VDD.n1243 VDD.t0 2.74446
R1945 VDD.n1245 VDD.t0 2.74446
R1946 VDD.t9 VDD.n1372 2.74446
R1947 VDD.t9 VDD.n1374 2.74446
R1948 VDD.t9 VDD.n1426 2.74446
R1949 VDD.n1444 VDD.t9 2.74446
R1950 VDD.n1446 VDD.t9 2.74446
R1951 VDD.t29 VDD.n1561 2.74446
R1952 VDD.t29 VDD.n1563 2.74446
R1953 VDD.t29 VDD.n1614 2.74446
R1954 VDD.n1632 VDD.t29 2.74446
R1955 VDD.n1634 VDD.t29 2.74446
R1956 VDD.t36 VDD.n1079 2.74446
R1957 VDD.t36 VDD.n1081 2.74446
R1958 VDD.t36 VDD.n1133 2.74446
R1959 VDD.n1151 VDD.t36 2.74446
R1960 VDD.n1153 VDD.t36 2.74446
R1961 VDD.t20 VDD.n903 2.74446
R1962 VDD.t20 VDD.n905 2.74446
R1963 VDD.t20 VDD.n940 2.74446
R1964 VDD.n955 VDD.t20 2.74446
R1965 VDD.n957 VDD.t20 2.74446
R1966 VDD.t365 VDD.n693 2.74414
R1967 VDD.t351 VDD.n658 2.74397
R1968 VDD.t353 VDD.n1289 2.74397
R1969 VDD.t353 VDD.n1284 2.74397
R1970 VDD.n1498 VDD.t339 2.74397
R1971 VDD.n1508 VDD.t339 2.74397
R1972 VDD.t341 VDD.n1678 2.74397
R1973 VDD.t341 VDD.n1673 2.74397
R1974 VDD.n1016 VDD.t381 2.74397
R1975 VDD.n1026 VDD.t381 2.74397
R1976 VDD.t365 VDD.n14 0.246607
R1977 VDD.t365 VDD.n688 2.74397
R1978 VDD.n21 VDD.n902 0.368495
R1979 VDD.n32 VDD.n168 0.0931522
R1980 VDD.t352 VDD 1.48713
R1981 VDD.n1776 VDD.t453 2.6992
R1982 VDD.n1775 VDD.t448 2.6992
R1983 VDD.n1750 VDD.t622 2.6992
R1984 VDD.n1746 VDD.t440 2.6992
R1985 VDD.n1754 VDD.t441 2.6992
R1986 VDD.n1748 VDD.t616 2.6992
R1987 VDD.n1759 VDD.t442 2.6992
R1988 VDD.n1758 VDD.t438 2.6992
R1989 VDD.n1764 VDD.t444 2.6992
R1990 VDD.n1763 VDD.t439 2.6992
R1991 VDD.n1769 VDD.t446 2.6992
R1992 VDD.n1768 VDD.t451 2.6992
R1993 VDD.n1773 VDD.t624 2.6992
R1994 VDD.n1780 VDD.t619 2.6992
R1995 VDD.n47 VDD.n442 0.321568
R1996 VDD.t365 VDD.n843 2.32446
R1997 VDD.n442 VDD.n1767 0.461736
R1998 VDD.t351 VDD.n660 2.32439
R1999 VDD.t351 VDD.n1771 2.32439
R2000 VDD.t365 VDD.n898 2.32439
R2001 VDD.t365 VDD.n837 2.32439
R2002 VDD.t365 VDD.n825 2.32439
R2003 VDD.t365 VDD.n788 2.32439
R2004 VDD.t365 VDD.n764 2.32432
R2005 VDD.t365 VDD.n752 2.32432
R2006 VDD.t365 VDD.n794 2.32425
R2007 VDD.t365 VDD.n770 2.32425
R2008 VDD.t365 VDD.n861 2.32417
R2009 VDD.t365 VDD.n758 2.32417
R2010 VDD.t351 VDD.n662 2.32417
R2011 VDD.t351 VDD.n1766 2.32417
R2012 VDD.t360 VDD.n89 0.570319
R2013 VDD.t365 VDD.n880 2.32417
R2014 VDD.t365 VDD.n855 2.32417
R2015 VDD.t365 VDD.n776 2.32417
R2016 VDD.t365 VDD.n732 2.32417
R2017 VDD.t365 VDD.n714 2.32417
R2018 VDD.t365 VDD.n849 2.32414
R2019 VDD.t365 VDD.n813 2.32414
R2020 VDD.t365 VDD.n782 2.32414
R2021 VDD.t365 VDD.n819 2.32407
R2022 VDD.t365 VDD.n800 2.32407
R2023 VDD.t365 VDD.n726 2.32407
R2024 VDD.t351 VDD.n1756 2.32406
R2025 VDD.t365 VDD.n892 2.32406
R2026 VDD.t365 VDD.n886 2.32406
R2027 VDD.t365 VDD.n874 2.32406
R2028 VDD.t365 VDD.n831 2.32406
R2029 VDD.t365 VDD.n746 2.32406
R2030 VDD.t365 VDD.n720 2.32406
R2031 VDD.t36 VDD.n1135 2.06543
R2032 VDD.t29 VDD.n1616 2.06458
R2033 VDD.t9 VDD.n1428 2.06453
R2034 VDD.t20 VDD.n942 2.06391
R2035 VDD.t0 VDD.n1226 2.06313
R2036 VDD.n336 VDD 2.04405
R2037 VDD.n544 VDD 2.04404
R2038 VDD.n544 VDD 2.04404
R2039 VDD.n542 VDD 2.04404
R2040 VDD.n542 VDD 2.04404
R2041 VDD.n334 VDD 2.04404
R2042 VDD.n334 VDD 2.04404
R2043 VDD.n335 VDD 2.04404
R2044 VDD.n335 VDD 2.04404
R2045 VDD.n336 VDD 2.04399
R2046 VDD.n33 VDD 2.04374
R2047 VDD.n33 VDD 2.04374
R2048 VDD.t351 VDD.n661 2.00629
R2049 VDD.t351 VDD.n1761 2.00629
R2050 VDD.t351 VDD.n1782 1.75854
R2051 VDD.t365 VDD.n676 1.75612
R2052 VDD.t353 VDD.n1272 1.75596
R2053 VDD.n43 VDD.t339 1.75596
R2054 VDD.t341 VDD.n1661 1.75596
R2055 VDD.n38 VDD.t381 1.75596
R2056 VDD.t365 VDD.n103 1.75587
R2057 VDD.t353 VDD.n115 1.7558
R2058 VDD.n1546 VDD.t339 1.7558
R2059 VDD.t341 VDD.n109 1.7558
R2060 VDD.n1064 VDD.t381 1.7558
R2061 VDD.t365 VDD.n695 1.56865
R2062 VDD.t360 VDD.n68 1.5566
R2063 VDD.t365 VDD.n678 1.55387
R2064 VDD.t365 VDD.n666 1.55381
R2065 VDD.t365 VDD.n675 1.55379
R2066 VDD.t353 VDD.n1288 1.55361
R2067 VDD.t353 VDD.n1287 1.55361
R2068 VDD.t353 VDD.n1286 1.55361
R2069 VDD.t353 VDD.n1285 1.55361
R2070 VDD.t353 VDD.n1281 1.55361
R2071 VDD.t353 VDD.n1280 1.55361
R2072 VDD.t353 VDD.n1279 1.55361
R2073 VDD.t353 VDD.n1278 1.55361
R2074 VDD.t353 VDD.n1277 1.55361
R2075 VDD.t353 VDD.n1276 1.55361
R2076 VDD.t353 VDD.n1275 1.55361
R2077 VDD.t353 VDD.n1274 1.55361
R2078 VDD.t353 VDD.n1273 1.55361
R2079 VDD.t353 VDD.n1271 1.55361
R2080 VDD.t353 VDD.n1270 1.55361
R2081 VDD.t353 VDD.n1269 1.55361
R2082 VDD.t353 VDD.n1268 1.55361
R2083 VDD.t353 VDD.n1267 1.55361
R2084 VDD.t353 VDD.n1266 1.55361
R2085 VDD.t353 VDD.n1265 1.55361
R2086 VDD.t353 VDD.n1264 1.55361
R2087 VDD.t353 VDD.n1263 1.55361
R2088 VDD.t353 VDD.n1262 1.55361
R2089 VDD.t353 VDD.n1261 1.55361
R2090 VDD.t353 VDD.n1260 1.55361
R2091 VDD.n1500 VDD.t339 1.55361
R2092 VDD.n1502 VDD.t339 1.55361
R2093 VDD.n1504 VDD.t339 1.55361
R2094 VDD.n1506 VDD.t339 1.55361
R2095 VDD.n1512 VDD.t339 1.55361
R2096 VDD.n1514 VDD.t339 1.55361
R2097 VDD.n1516 VDD.t339 1.55361
R2098 VDD.n1518 VDD.t339 1.55361
R2099 VDD.n1520 VDD.t339 1.55361
R2100 VDD.n1522 VDD.t339 1.55361
R2101 VDD.n1524 VDD.t339 1.55361
R2102 VDD.n1526 VDD.t339 1.55361
R2103 VDD.n1528 VDD.t339 1.55361
R2104 VDD.n1531 VDD.t339 1.55361
R2105 VDD.n1533 VDD.t339 1.55361
R2106 VDD.n1535 VDD.t339 1.55361
R2107 VDD.n1537 VDD.t339 1.55361
R2108 VDD.n1539 VDD.t339 1.55361
R2109 VDD.n1541 VDD.t339 1.55361
R2110 VDD.n1543 VDD.t339 1.55361
R2111 VDD.n1545 VDD.t339 1.55361
R2112 VDD.n1548 VDD.t339 1.55361
R2113 VDD.n1550 VDD.t339 1.55361
R2114 VDD.n1552 VDD.t339 1.55361
R2115 VDD.n1554 VDD.t339 1.55361
R2116 VDD.t341 VDD.n1676 1.55361
R2117 VDD.t341 VDD.n1675 1.55361
R2118 VDD.t341 VDD.n1674 1.55361
R2119 VDD.t341 VDD.n1670 1.55361
R2120 VDD.t341 VDD.n1669 1.55361
R2121 VDD.t341 VDD.n1668 1.55361
R2122 VDD.t341 VDD.n1667 1.55361
R2123 VDD.t341 VDD.n1666 1.55361
R2124 VDD.t341 VDD.n1665 1.55361
R2125 VDD.t341 VDD.n1664 1.55361
R2126 VDD.t341 VDD.n1663 1.55361
R2127 VDD.t341 VDD.n1662 1.55361
R2128 VDD.t341 VDD.n1660 1.55361
R2129 VDD.t341 VDD.n1659 1.55361
R2130 VDD.t341 VDD.n1658 1.55361
R2131 VDD.t341 VDD.n1657 1.55361
R2132 VDD.t341 VDD.n1656 1.55361
R2133 VDD.t341 VDD.n1655 1.55361
R2134 VDD.t341 VDD.n1654 1.55361
R2135 VDD.t341 VDD.n1653 1.55361
R2136 VDD.t341 VDD.n1652 1.55361
R2137 VDD.t341 VDD.n1651 1.55361
R2138 VDD.t341 VDD.n1650 1.55361
R2139 VDD.t341 VDD.n1649 1.55361
R2140 VDD.t341 VDD.n1648 1.55361
R2141 VDD.n1018 VDD.t381 1.55361
R2142 VDD.n1020 VDD.t381 1.55361
R2143 VDD.n1022 VDD.t381 1.55361
R2144 VDD.n1024 VDD.t381 1.55361
R2145 VDD.n1030 VDD.t381 1.55361
R2146 VDD.n1032 VDD.t381 1.55361
R2147 VDD.n1034 VDD.t381 1.55361
R2148 VDD.n1036 VDD.t381 1.55361
R2149 VDD.n1038 VDD.t381 1.55361
R2150 VDD.n1040 VDD.t381 1.55361
R2151 VDD.n1042 VDD.t381 1.55361
R2152 VDD.n1044 VDD.t381 1.55361
R2153 VDD.n1046 VDD.t381 1.55361
R2154 VDD.n1049 VDD.t381 1.55361
R2155 VDD.n1051 VDD.t381 1.55361
R2156 VDD.n1053 VDD.t381 1.55361
R2157 VDD.n1055 VDD.t381 1.55361
R2158 VDD.n1057 VDD.t381 1.55361
R2159 VDD.n1059 VDD.t381 1.55361
R2160 VDD.n1061 VDD.t381 1.55361
R2161 VDD.n1063 VDD.t381 1.55361
R2162 VDD.n1066 VDD.t381 1.55361
R2163 VDD.n1068 VDD.t381 1.55361
R2164 VDD.n1070 VDD.t381 1.55361
R2165 VDD.n1072 VDD.t381 1.55361
R2166 VDD.t365 VDD.n684 1.55361
R2167 VDD.t365 VDD.n685 1.55361
R2168 VDD.t365 VDD.n664 1.55356
R2169 VDD.t365 VDD.n681 1.55354
R2170 VDD.t365 VDD.n671 1.55354
R2171 VDD.t365 VDD.n683 1.55354
R2172 VDD.t365 VDD.n690 1.55354
R2173 VDD.t365 VDD.n668 1.55353
R2174 VDD.t365 VDD.n689 1.5535
R2175 VDD.t365 VDD.n692 1.55344
R2176 VDD.t365 VDD.n691 1.55344
R2177 VDD.t365 VDD.n677 1.55342
R2178 VDD.t365 VDD.n665 1.55341
R2179 VDD.t365 VDD.n670 1.55339
R2180 VDD.t365 VDD.n674 1.55339
R2181 VDD.t365 VDD.n667 1.55338
R2182 VDD.n14 VDD.n895 0.753826
R2183 VDD.t365 VDD.n679 1.55334
R2184 VDD.t365 VDD.n669 1.55334
R2185 VDD.t365 VDD.n680 1.55333
R2186 VDD.t365 VDD.n672 1.55327
R2187 VDD.t365 VDD.n673 1.55327
R2188 VDD.t365 VDD.n682 1.55325
R2189 VDD.t352 VDD.n631 1.20586
R2190 VDD.n89 VDD.n644 0.779651
R2191 VDD.n1759 VDD.n1758 1.11007
R2192 VDD.n1764 VDD.n1763 1.11007
R2193 VDD.n1769 VDD.n1768 1.11007
R2194 VDD.t351 VDD.n663 1.01993
R2195 VDD.n618 VDD.n657 0.971457
R2196 VDD.n336 VDD.n334 0.72826
R2197 VDD.n646 VDD.n631 0.668227
R2198 VDD.n633 VDD.n631 0.668184
R2199 VDD.n1740 VDD.n663 0.632886
R2200 VDD.n1166 VDD.n663 0.618267
R2201 VDD.n1755 VDD.n1754 0.570274
R2202 VDD.n1760 VDD.n1759 0.570274
R2203 VDD.n1765 VDD.n1764 0.570274
R2204 VDD.n1770 VDD.n1769 0.570274
R2205 VDD.n1776 VDD.n442 0.569912
R2206 VDD.n1775 VDD.n1774 0.569912
R2207 VDD.n1750 VDD.n1749 0.569912
R2208 VDD.n1746 VDD.n1745 0.569912
R2209 VDD.n1748 VDD.n1747 0.569912
R2210 VDD.n1758 VDD.n1757 0.569912
R2211 VDD.n1763 VDD.n1762 0.569912
R2212 VDD.n1768 VDD.n1767 0.569912
R2213 VDD.n1773 VDD.n442 0.569912
R2214 VDD.n1781 VDD.n1780 0.569912
R2215 VDD.n168 VDD.n309 0.508375
R2216 VDD.n69 VDD.n65 0.508375
R2217 VDD.n640 VDD.n78 0.508375
R2218 VDD.n453 VDD.n1342 0.495739
R2219 VDD.n165 VDD.n1341 0.495739
R2220 VDD.n1339 VDD.n1338 0.495739
R2221 VDD.n161 VDD.n1337 0.495739
R2222 VDD.n158 VDD.n1336 0.495739
R2223 VDD.n156 VDD.n1335 0.495739
R2224 VDD.n152 VDD.n1334 0.495739
R2225 VDD.n1333 VDD.n1332 0.495739
R2226 VDD.n1331 VDD.n1330 0.495739
R2227 VDD.n148 VDD.n1328 0.495739
R2228 VDD.n1326 VDD.n1325 0.495739
R2229 VDD.n1322 VDD.n1321 0.495739
R2230 VDD.n1318 VDD.n1317 0.495739
R2231 VDD.n1314 VDD.n1313 0.495739
R2232 VDD.n145 VDD.n1312 0.495739
R2233 VDD.n1311 VDD.n1310 0.495739
R2234 VDD.n133 VDD.n46 0.495739
R2235 VDD.n141 VDD.n1309 0.495739
R2236 VDD.n138 VDD.n1308 0.495739
R2237 VDD.n135 VDD.n1307 0.495739
R2238 VDD.n1306 VDD.n1305 0.495739
R2239 VDD.n530 VDD.n1304 0.495739
R2240 VDD.n1303 VDD.n1302 0.495739
R2241 VDD.n533 VDD.n1301 0.495739
R2242 VDD.n129 VDD.n1300 0.495739
R2243 VDD.n535 VDD.n1299 0.495739
R2244 VDD.n255 VDD.n116 0.495739
R2245 VDD.n126 VDD.n1298 0.495739
R2246 VDD.n536 VDD.n1297 0.495739
R2247 VDD.n122 VDD.n1296 0.495739
R2248 VDD.n537 VDD.n1295 0.495739
R2249 VDD.n119 VDD.n1294 0.495739
R2250 VDD.n26 VDD.n1293 0.495739
R2251 VDD.n1497 VDD.n230 0.495739
R2252 VDD.n1499 VDD.n204 0.495739
R2253 VDD.n1501 VDD.n1469 0.495739
R2254 VDD.n1503 VDD.n199 0.495739
R2255 VDD.n1505 VDD.n1468 0.495739
R2256 VDD.n1507 VDD.n312 0.495739
R2257 VDD.n1511 VDD.n1467 0.495739
R2258 VDD.n1513 VDD.n1466 0.495739
R2259 VDD.n1515 VDD.n196 0.495739
R2260 VDD.n1517 VDD.n511 0.495739
R2261 VDD.n1519 VDD.n1465 0.495739
R2262 VDD.n1521 VDD.n513 0.495739
R2263 VDD.n1523 VDD.n515 0.495739
R2264 VDD.n1525 VDD.n519 0.495739
R2265 VDD.n1527 VDD.n1464 0.495739
R2266 VDD.n1529 VDD.n190 0.495739
R2267 VDD.n44 VDD.n42 0.495739
R2268 VDD.n1530 VDD.n1463 0.495739
R2269 VDD.n1532 VDD.n1462 0.495739
R2270 VDD.n1534 VDD.n186 0.495739
R2271 VDD.n1536 VDD.n1461 0.495739
R2272 VDD.n1538 VDD.n523 0.495739
R2273 VDD.n1540 VDD.n183 0.495739
R2274 VDD.n1542 VDD.n525 0.495739
R2275 VDD.n1544 VDD.n179 0.495739
R2276 VDD.n117 VDD.n526 0.495739
R2277 VDD.n113 VDD.n111 0.495739
R2278 VDD.n1547 VDD.n176 0.495739
R2279 VDD.n1549 VDD.n1460 0.495739
R2280 VDD.n1551 VDD.n1459 0.495739
R2281 VDD.n1553 VDD.n528 0.495739
R2282 VDD.n1555 VDD.n172 0.495739
R2283 VDD.n29 VDD.n169 0.495739
R2284 VDD.n337 VDD.n1725 0.495739
R2285 VDD.n1723 VDD.n1722 0.495739
R2286 VDD.n492 VDD.n1721 0.495739
R2287 VDD.n494 VDD.n1720 0.495739
R2288 VDD.n1719 VDD.n1718 0.495739
R2289 VDD.n321 VDD.n1717 0.495739
R2290 VDD.n1715 VDD.n1714 0.495739
R2291 VDD.n275 VDD.n1713 0.495739
R2292 VDD.n272 VDD.n1711 0.495739
R2293 VDD.n496 VDD.n1710 0.495739
R2294 VDD.n498 VDD.n1709 0.495739
R2295 VDD.n1708 VDD.n1707 0.495739
R2296 VDD.n269 VDD.n1706 0.495739
R2297 VDD.n267 VDD.n1705 0.495739
R2298 VDD.n265 VDD.n1704 0.495739
R2299 VDD.n228 VDD.n1703 0.495739
R2300 VDD.n319 VDD.n41 0.495739
R2301 VDD.n500 VDD.n1702 0.495739
R2302 VDD.n502 VDD.n1701 0.495739
R2303 VDD.n224 VDD.n1700 0.495739
R2304 VDD.n1697 VDD.n1696 0.495739
R2305 VDD.n219 VDD.n1695 0.495739
R2306 VDD.n1694 VDD.n1693 0.495739
R2307 VDD.n216 VDD.n1691 0.495739
R2308 VDD.n503 VDD.n1690 0.495739
R2309 VDD.n505 VDD.n1689 0.495739
R2310 VDD.n315 VDD.n110 0.495739
R2311 VDD.n213 VDD.n1688 0.495739
R2312 VDD.n210 VDD.n1687 0.495739
R2313 VDD.n207 VDD.n1685 0.495739
R2314 VDD.n506 VDD.n1684 0.495739
R2315 VDD.n508 VDD.n1683 0.495739
R2316 VDD.n61 VDD.n1682 0.495739
R2317 VDD.n1015 VDD.n326 0.495739
R2318 VDD.n1017 VDD.n986 0.495739
R2319 VDD.n1019 VDD.n461 0.495739
R2320 VDD.n1021 VDD.n449 0.495739
R2321 VDD.n1023 VDD.n985 0.495739
R2322 VDD.n1025 VDD.n332 0.495739
R2323 VDD.n1029 VDD.n457 0.495739
R2324 VDD.n1031 VDD.n984 0.495739
R2325 VDD.n1033 VDD.n307 0.495739
R2326 VDD.n1035 VDD.n306 0.495739
R2327 VDD.n1037 VDD.n983 0.495739
R2328 VDD.n1039 VDD.n982 0.495739
R2329 VDD.n1041 VDD.n303 0.495739
R2330 VDD.n1043 VDD.n466 0.495739
R2331 VDD.n1045 VDD.n300 0.495739
R2332 VDD.n1047 VDD.n298 0.495739
R2333 VDD.n39 VDD.n37 0.495739
R2334 VDD.n1048 VDD.n296 0.495739
R2335 VDD.n1050 VDD.n485 0.495739
R2336 VDD.n1052 VDD.n293 0.495739
R2337 VDD.n1054 VDD.n981 0.495739
R2338 VDD.n1056 VDD.n980 0.495739
R2339 VDD.n1058 VDD.n290 0.495739
R2340 VDD.n1060 VDD.n979 0.495739
R2341 VDD.n1062 VDD.n286 0.495739
R2342 VDD.n118 VDD.n486 0.495739
R2343 VDD.n107 VDD.n105 0.495739
R2344 VDD.n1065 VDD.n978 0.495739
R2345 VDD.n1067 VDD.n977 0.495739
R2346 VDD.n1069 VDD.n487 0.495739
R2347 VDD.n1071 VDD.n282 0.495739
R2348 VDD.n1073 VDD.n491 0.495739
R2349 VDD.n10 VDD.n278 0.495739
R2350 VDD.n901 VDD.n14 0.569552
R2351 VDD.n896 VDD.n895 0.495398
R2352 VDD.n890 VDD.n889 0.495398
R2353 VDD.n884 VDD.n883 0.495398
R2354 VDD.n878 VDD.n877 0.495398
R2355 VDD.n872 VDD.n871 0.495398
R2356 VDD.n864 VDD.n104 0.495398
R2357 VDD.n859 VDD.n858 0.495398
R2358 VDD.n853 VDD.n852 0.495398
R2359 VDD.n847 VDD.n846 0.495398
R2360 VDD.n841 VDD.n840 0.495398
R2361 VDD.n835 VDD.n834 0.495398
R2362 VDD.n829 VDD.n828 0.495398
R2363 VDD.n823 VDD.n822 0.495398
R2364 VDD.n817 VDD.n816 0.495398
R2365 VDD.n811 VDD.n810 0.495398
R2366 VDD.n803 VDD.n36 0.495398
R2367 VDD.n798 VDD.n797 0.495398
R2368 VDD.n792 VDD.n791 0.495398
R2369 VDD.n786 VDD.n785 0.495398
R2370 VDD.n780 VDD.n779 0.495398
R2371 VDD.n774 VDD.n773 0.495398
R2372 VDD.n768 VDD.n767 0.495398
R2373 VDD.n762 VDD.n761 0.495398
R2374 VDD.n756 VDD.n755 0.495398
R2375 VDD.n750 VDD.n749 0.495398
R2376 VDD.n744 VDD.n743 0.495398
R2377 VDD.n736 VDD.n735 0.495398
R2378 VDD.n730 VDD.n729 0.495398
R2379 VDD.n724 VDD.n723 0.495398
R2380 VDD.n718 VDD.n717 0.495398
R2381 VDD.n712 VDD.n711 0.495398
R2382 VDD.n706 VDD.n705 0.495398
R2383 VDD.n638 VDD.n637 0.495398
R2384 VDD.n1777 VDD.n1776 0.492005
R2385 VDD.n1777 VDD.n1775 0.492005
R2386 VDD.n1751 VDD.n1750 0.492005
R2387 VDD.n1753 VDD.n1746 0.492005
R2388 VDD.n1751 VDD.n1748 0.492005
R2389 VDD.n1779 VDD.n1773 0.492005
R2390 VDD.n1780 VDD.n1779 0.492005
R2391 VDD.n1754 VDD.n1753 0.491643
R2392 VDD.n902 VDD.n901 0.478641
R2393 VDD.n897 VDD.n896 0.478641
R2394 VDD.n891 VDD.n890 0.478641
R2395 VDD.n885 VDD.n884 0.478641
R2396 VDD.n879 VDD.n878 0.478641
R2397 VDD.n873 VDD.n872 0.478641
R2398 VDD.n865 VDD.n864 0.478641
R2399 VDD.n860 VDD.n859 0.478641
R2400 VDD.n854 VDD.n853 0.478641
R2401 VDD.n848 VDD.n847 0.478641
R2402 VDD.n842 VDD.n841 0.478641
R2403 VDD.n836 VDD.n835 0.478641
R2404 VDD.n830 VDD.n829 0.478641
R2405 VDD.n824 VDD.n823 0.478641
R2406 VDD.n818 VDD.n817 0.478641
R2407 VDD.n812 VDD.n811 0.478641
R2408 VDD.n804 VDD.n803 0.478641
R2409 VDD.n799 VDD.n798 0.478641
R2410 VDD.n793 VDD.n792 0.478641
R2411 VDD.n787 VDD.n786 0.478641
R2412 VDD.n781 VDD.n780 0.478641
R2413 VDD.n775 VDD.n774 0.478641
R2414 VDD.n769 VDD.n768 0.478641
R2415 VDD.n763 VDD.n762 0.478641
R2416 VDD.n757 VDD.n756 0.478641
R2417 VDD.n751 VDD.n750 0.478641
R2418 VDD.n745 VDD.n744 0.478641
R2419 VDD.n737 VDD.n736 0.478641
R2420 VDD.n731 VDD.n730 0.478641
R2421 VDD.n725 VDD.n724 0.478641
R2422 VDD.n719 VDD.n718 0.478641
R2423 VDD.n713 VDD.n712 0.478641
R2424 VDD.n707 VDD.n706 0.478641
R2425 VDD.n76 VDD.n638 0.478641
R2426 VDD.n164 VDD.n453 0.478299
R2427 VDD.n167 VDD.n165 0.478299
R2428 VDD.n1340 VDD.n1339 0.478299
R2429 VDD.n162 VDD.n161 0.478299
R2430 VDD.n159 VDD.n158 0.478299
R2431 VDD.n157 VDD.n156 0.478299
R2432 VDD.n153 VDD.n152 0.478299
R2433 VDD.n1348 VDD.n1333 0.478299
R2434 VDD.n1351 VDD.n1331 0.478299
R2435 VDD.n149 VDD.n148 0.478299
R2436 VDD.n1327 VDD.n1326 0.478299
R2437 VDD.n1323 VDD.n1322 0.478299
R2438 VDD.n1319 VDD.n1318 0.478299
R2439 VDD.n1315 VDD.n1314 0.478299
R2440 VDD.n146 VDD.n145 0.478299
R2441 VDD.n1355 VDD.n1311 0.478299
R2442 VDD.n134 VDD.n133 0.478299
R2443 VDD.n142 VDD.n141 0.478299
R2444 VDD.n139 VDD.n138 0.478299
R2445 VDD.n136 VDD.n135 0.478299
R2446 VDD.n554 VDD.n1306 0.478299
R2447 VDD.n532 VDD.n530 0.478299
R2448 VDD.n1363 VDD.n1303 0.478299
R2449 VDD.n534 VDD.n533 0.478299
R2450 VDD.n130 VDD.n129 0.478299
R2451 VDD.n310 VDD.n535 0.478299
R2452 VDD.n257 VDD.n255 0.478299
R2453 VDD.n127 VDD.n126 0.478299
R2454 VDD.n125 VDD.n536 0.478299
R2455 VDD.n123 VDD.n122 0.478299
R2456 VDD.n538 VDD.n537 0.478299
R2457 VDD.n120 VDD.n119 0.478299
R2458 VDD.n27 VDD.n26 0.478299
R2459 VDD.n234 VDD.n230 0.478299
R2460 VDD.n205 VDD.n204 0.478299
R2461 VDD.n1493 VDD.n1469 0.478299
R2462 VDD.n201 VDD.n199 0.478299
R2463 VDD.n1471 VDD.n1468 0.478299
R2464 VDD.n313 VDD.n312 0.478299
R2465 VDD.n1491 VDD.n1467 0.478299
R2466 VDD.n1472 VDD.n1466 0.478299
R2467 VDD.n195 VDD.n511 0.478299
R2468 VDD.n1487 VDD.n1465 0.478299
R2469 VDD.n514 VDD.n513 0.478299
R2470 VDD.n516 VDD.n515 0.478299
R2471 VDD.n520 VDD.n519 0.478299
R2472 VDD.n1473 VDD.n1464 0.478299
R2473 VDD.n189 VDD.n42 0.478299
R2474 VDD.n1474 VDD.n1463 0.478299
R2475 VDD.n1484 VDD.n1462 0.478299
R2476 VDD.n187 VDD.n186 0.478299
R2477 VDD.n1475 VDD.n1461 0.478299
R2478 VDD.n524 VDD.n523 0.478299
R2479 VDD.n184 VDD.n183 0.478299
R2480 VDD.n182 VDD.n525 0.478299
R2481 VDD.n527 VDD.n526 0.478299
R2482 VDD.n254 VDD.n111 0.478299
R2483 VDD.n177 VDD.n176 0.478299
R2484 VDD.n1479 VDD.n1460 0.478299
R2485 VDD.n1477 VDD.n1459 0.478299
R2486 VDD.n529 VDD.n528 0.478299
R2487 VDD.n173 VDD.n172 0.478299
R2488 VDD.n170 VDD.n169 0.478299
R2489 VDD.n341 VDD.n337 0.478299
R2490 VDD.n1724 VDD.n1723 0.478299
R2491 VDD.n493 VDD.n492 0.478299
R2492 VDD.n495 VDD.n494 0.478299
R2493 VDD.n448 VDD.n1719 0.478299
R2494 VDD.n323 VDD.n321 0.478299
R2495 VDD.n1716 VDD.n1715 0.478299
R2496 VDD.n276 VDD.n275 0.478299
R2497 VDD.n273 VDD.n272 0.478299
R2498 VDD.n497 VDD.n496 0.478299
R2499 VDD.n499 VDD.n498 0.478299
R2500 VDD.n1731 VDD.n1708 0.478299
R2501 VDD.n268 VDD.n267 0.478299
R2502 VDD.n266 VDD.n265 0.478299
R2503 VDD.n229 VDD.n228 0.478299
R2504 VDD.n320 VDD.n319 0.478299
R2505 VDD.n501 VDD.n500 0.478299
R2506 VDD.n222 VDD.n502 0.478299
R2507 VDD.n225 VDD.n224 0.478299
R2508 VDD.n1698 VDD.n1697 0.478299
R2509 VDD.n220 VDD.n219 0.478299
R2510 VDD.n1735 VDD.n1694 0.478299
R2511 VDD.n217 VDD.n216 0.478299
R2512 VDD.n504 VDD.n503 0.478299
R2513 VDD.n316 VDD.n505 0.478299
R2514 VDD.n318 VDD.n315 0.478299
R2515 VDD.n215 VDD.n213 0.478299
R2516 VDD.n211 VDD.n210 0.478299
R2517 VDD.n208 VDD.n207 0.478299
R2518 VDD.n507 VDD.n506 0.478299
R2519 VDD.n509 VDD.n508 0.478299
R2520 VDD.n62 VDD.n61 0.478299
R2521 VDD.n328 VDD.n326 0.478299
R2522 VDD.n1012 VDD.n986 0.478299
R2523 VDD.n462 VDD.n461 0.478299
R2524 VDD.n450 VDD.n449 0.478299
R2525 VDD.n988 VDD.n985 0.478299
R2526 VDD.n333 VDD.n332 0.478299
R2527 VDD.n331 VDD.n457 0.478299
R2528 VDD.n989 VDD.n984 0.478299
R2529 VDD.n308 VDD.n307 0.478299
R2530 VDD.n308 VDD.n306 0.478299
R2531 VDD.n1006 VDD.n983 0.478299
R2532 VDD.n304 VDD.n982 0.478299
R2533 VDD.n464 VDD.n466 0.478299
R2534 VDD.n301 VDD.n300 0.478299
R2535 VDD.n299 VDD.n298 0.478299
R2536 VDD.n992 VDD.n37 0.478299
R2537 VDD.n467 VDD.n485 0.478299
R2538 VDD.n294 VDD.n293 0.478299
R2539 VDD.n1002 VDD.n981 0.478299
R2540 VDD.n994 VDD.n980 0.478299
R2541 VDD.n291 VDD.n290 0.478299
R2542 VDD.n1000 VDD.n979 0.478299
R2543 VDD.n285 VDD.n486 0.478299
R2544 VDD.n329 VDD.n105 0.478299
R2545 VDD.n995 VDD.n978 0.478299
R2546 VDD.n996 VDD.n977 0.478299
R2547 VDD.n488 VDD.n487 0.478299
R2548 VDD.n281 VDD.n491 0.478299
R2549 VDD.n279 VDD.n278 0.478299
R2550 VDD.n791 VDD.n678 0.467485
R2551 VDD.n883 VDD.n666 0.467341
R2552 VDD.n816 VDD.n675 0.467234
R2553 VDD.n1293 VDD.n1259 0.467143
R2554 VDD.n1294 VDD.n1260 0.467143
R2555 VDD.n1295 VDD.n1261 0.467143
R2556 VDD.n1296 VDD.n1262 0.467143
R2557 VDD.n1297 VDD.n1263 0.467143
R2558 VDD.n116 VDD.n114 0.418089
R2559 VDD.n1299 VDD.n1264 0.467143
R2560 VDD.n1300 VDD.n1265 0.467143
R2561 VDD.n1301 VDD.n1266 0.467143
R2562 VDD.n1302 VDD.n1267 0.467143
R2563 VDD.n1304 VDD.n1268 0.467143
R2564 VDD.n1305 VDD.n1269 0.467143
R2565 VDD.n1307 VDD.n1270 0.467143
R2566 VDD.n1308 VDD.n1271 0.467143
R2567 VDD.n1309 VDD.n45 0.504447
R2568 VDD.n1310 VDD.n1273 0.467143
R2569 VDD.n1312 VDD.n1274 0.467143
R2570 VDD.n1313 VDD.n1275 0.467143
R2571 VDD.n1317 VDD.n1276 0.467143
R2572 VDD.n1321 VDD.n1277 0.467143
R2573 VDD.n1325 VDD.n1278 0.467143
R2574 VDD.n1328 VDD.n1279 0.467143
R2575 VDD.n1330 VDD.n1280 0.467143
R2576 VDD.n1332 VDD.n1281 0.467143
R2577 VDD.n1335 VDD.n1285 0.467143
R2578 VDD.n1336 VDD.n1286 0.467143
R2579 VDD.n1337 VDD.n1287 0.467143
R2580 VDD.n1338 VDD.n1288 0.467143
R2581 VDD.n29 VDD.n1556 0.467143
R2582 VDD.n1555 VDD.n1554 0.467143
R2583 VDD.n1553 VDD.n1552 0.467143
R2584 VDD.n1551 VDD.n1550 0.467143
R2585 VDD.n1549 VDD.n1548 0.467143
R2586 VDD.n113 VDD.n112 0.418089
R2587 VDD.n117 VDD.n1545 0.467143
R2588 VDD.n1544 VDD.n1543 0.467143
R2589 VDD.n1542 VDD.n1541 0.467143
R2590 VDD.n1540 VDD.n1539 0.467143
R2591 VDD.n1538 VDD.n1537 0.467143
R2592 VDD.n1536 VDD.n1535 0.467143
R2593 VDD.n1534 VDD.n1533 0.467143
R2594 VDD.n1532 VDD.n1531 0.467143
R2595 VDD.n1530 VDD.n48 0.504447
R2596 VDD.n1529 VDD.n1528 0.467143
R2597 VDD.n1527 VDD.n1526 0.467143
R2598 VDD.n1525 VDD.n1524 0.467143
R2599 VDD.n1523 VDD.n1522 0.467143
R2600 VDD.n1521 VDD.n1520 0.467143
R2601 VDD.n1519 VDD.n1518 0.467143
R2602 VDD.n1517 VDD.n1516 0.467143
R2603 VDD.n1515 VDD.n1514 0.467143
R2604 VDD.n1513 VDD.n1512 0.467143
R2605 VDD.n1507 VDD.n1506 0.467143
R2606 VDD.n1505 VDD.n1504 0.467143
R2607 VDD.n1503 VDD.n1502 0.467143
R2608 VDD.n1501 VDD.n1500 0.467143
R2609 VDD.n1682 VDD.n1648 0.467143
R2610 VDD.n1683 VDD.n1649 0.467143
R2611 VDD.n1684 VDD.n1650 0.467143
R2612 VDD.n1685 VDD.n1651 0.467143
R2613 VDD.n1687 VDD.n1652 0.467143
R2614 VDD.n110 VDD.n108 0.418089
R2615 VDD.n1689 VDD.n1653 0.467143
R2616 VDD.n1690 VDD.n1654 0.467143
R2617 VDD.n1691 VDD.n1655 0.467143
R2618 VDD.n1693 VDD.n1656 0.467143
R2619 VDD.n1695 VDD.n1657 0.467143
R2620 VDD.n1696 VDD.n1658 0.467143
R2621 VDD.n1700 VDD.n1659 0.467143
R2622 VDD.n1701 VDD.n1660 0.467143
R2623 VDD.n1702 VDD.n40 0.504447
R2624 VDD.n1703 VDD.n1662 0.467143
R2625 VDD.n1704 VDD.n1663 0.467143
R2626 VDD.n1705 VDD.n1664 0.467143
R2627 VDD.n1706 VDD.n1665 0.467143
R2628 VDD.n1707 VDD.n1666 0.467143
R2629 VDD.n1709 VDD.n1667 0.467143
R2630 VDD.n1710 VDD.n1668 0.467143
R2631 VDD.n1711 VDD.n1669 0.467143
R2632 VDD.n1713 VDD.n1670 0.467143
R2633 VDD.n1717 VDD.n1674 0.467143
R2634 VDD.n1718 VDD.n1675 0.467143
R2635 VDD.n1720 VDD.n1676 0.467143
R2636 VDD.n1721 VDD.n1677 0.467143
R2637 VDD.n10 VDD.n1074 0.467143
R2638 VDD.n1073 VDD.n1072 0.467143
R2639 VDD.n1071 VDD.n1070 0.467143
R2640 VDD.n1069 VDD.n1068 0.467143
R2641 VDD.n1067 VDD.n1066 0.467143
R2642 VDD.n107 VDD.n106 0.418089
R2643 VDD.n118 VDD.n1063 0.467143
R2644 VDD.n1062 VDD.n1061 0.467143
R2645 VDD.n1060 VDD.n1059 0.467143
R2646 VDD.n1058 VDD.n1057 0.467143
R2647 VDD.n1056 VDD.n1055 0.467143
R2648 VDD.n1054 VDD.n1053 0.467143
R2649 VDD.n1052 VDD.n1051 0.467143
R2650 VDD.n1050 VDD.n1049 0.467143
R2651 VDD.n1048 VDD.n49 0.504447
R2652 VDD.n1047 VDD.n1046 0.467143
R2653 VDD.n1045 VDD.n1044 0.467143
R2654 VDD.n1043 VDD.n1042 0.467143
R2655 VDD.n1041 VDD.n1040 0.467143
R2656 VDD.n1039 VDD.n1038 0.467143
R2657 VDD.n1037 VDD.n1036 0.467143
R2658 VDD.n1035 VDD.n1034 0.467143
R2659 VDD.n1033 VDD.n1032 0.467143
R2660 VDD.n1031 VDD.n1030 0.467143
R2661 VDD.n1025 VDD.n1024 0.467143
R2662 VDD.n1023 VDD.n1022 0.467143
R2663 VDD.n1021 VDD.n1020 0.467143
R2664 VDD.n1019 VDD.n1018 0.467143
R2665 VDD.n749 VDD.n685 0.467143
R2666 VDD.n755 VDD.n684 0.467143
R2667 VDD.n858 VDD.n668 0.466945
R2668 VDD.n840 VDD.n671 0.466912
R2669 VDD.n761 VDD.n683 0.466912
R2670 VDD.n729 VDD.n690 0.466912
R2671 VDD.n889 VDD.n665 0.466909
R2672 VDD.n877 VDD.n667 0.466801
R2673 VDD.n717 VDD.n692 0.466798
R2674 VDD.n846 VDD.n670 0.466761
R2675 VDD.n822 VDD.n674 0.466761
R2676 VDD.n723 VDD.n691 0.466713
R2677 VDD.n785 VDD.n679 0.466699
R2678 VDD.n797 VDD.n677 0.466622
R2679 VDD.n767 VDD.n682 0.466592
R2680 VDD.n810 VDD.n35 0.50393
R2681 VDD.n828 VDD.n673 0.466464
R2682 VDD.n834 VDD.n672 0.466439
R2683 VDD.n104 VDD.n102 0.417466
R2684 VDD.n735 VDD.n689 0.466426
R2685 VDD.n779 VDD.n680 0.466372
R2686 VDD.n895 VDD.n664 0.466098
R2687 VDD.n852 VDD.n669 0.466076
R2688 VDD.n773 VDD.n681 0.466015
R2689 VDD.n767 VDD.n681 0.451912
R2690 VDD.n846 VDD.n669 0.45184
R2691 VDD.n889 VDD.n664 0.451803
R2692 VDD.n773 VDD.n680 0.451585
R2693 VDD.n858 VDD.n102 0.490023
R2694 VDD.n729 VDD.n689 0.451477
R2695 VDD.n828 VDD.n672 0.451469
R2696 VDD.n822 VDD.n673 0.451456
R2697 VDD.n36 VDD.n35 0.40433
R2698 VDD.n761 VDD.n682 0.451294
R2699 VDD.n791 VDD.n677 0.451269
R2700 VDD.n779 VDD.n679 0.451252
R2701 VDD.n717 VDD.n691 0.451238
R2702 VDD.n840 VDD.n670 0.451204
R2703 VDD.n816 VDD.n674 0.451204
R2704 VDD.n711 VDD.n692 0.451129
R2705 VDD.n871 VDD.n667 0.451113
R2706 VDD.n852 VDD.n668 0.451058
R2707 VDD.n883 VDD.n665 0.451022
R2708 VDD.n834 VDD.n671 0.451015
R2709 VDD.n755 VDD.n683 0.451015
R2710 VDD.n723 VDD.n690 0.451015
R2711 VDD.n1341 VDD.n1288 0.450828
R2712 VDD.n1325 VDD.n1277 0.450828
R2713 VDD.n1321 VDD.n1276 0.450828
R2714 VDD.n1313 VDD.n1274 0.450828
R2715 VDD.n1312 VDD.n1273 0.450828
R2716 VDD.n1309 VDD.n1271 0.450828
R2717 VDD.n1301 VDD.n1265 0.450828
R2718 VDD.n1295 VDD.n1260 0.450828
R2719 VDD.n1294 VDD.n1259 0.450828
R2720 VDD.n1296 VDD.n1261 0.450828
R2721 VDD.n1297 VDD.n1262 0.450828
R2722 VDD.n1298 VDD.n1263 0.450828
R2723 VDD.n1299 VDD.n114 0.489433
R2724 VDD.n1300 VDD.n1264 0.450828
R2725 VDD.n1302 VDD.n1266 0.450828
R2726 VDD.n1304 VDD.n1267 0.450828
R2727 VDD.n1305 VDD.n1268 0.450828
R2728 VDD.n1307 VDD.n1269 0.450828
R2729 VDD.n1308 VDD.n1270 0.450828
R2730 VDD.n46 VDD.n45 0.403852
R2731 VDD.n1317 VDD.n1275 0.450828
R2732 VDD.n1328 VDD.n1278 0.450828
R2733 VDD.n1330 VDD.n1279 0.450828
R2734 VDD.n1332 VDD.n1280 0.450828
R2735 VDD.n1334 VDD.n1281 0.450828
R2736 VDD.n1336 VDD.n1285 0.450828
R2737 VDD.n1337 VDD.n1286 0.450828
R2738 VDD.n1338 VDD.n1287 0.450828
R2739 VDD.n1506 VDD.n1505 0.450828
R2740 VDD.n1518 VDD.n1517 0.450828
R2741 VDD.n1522 VDD.n1521 0.450828
R2742 VDD.n1533 VDD.n1532 0.450828
R2743 VDD.n1537 VDD.n1536 0.450828
R2744 VDD.n1541 VDD.n1540 0.450828
R2745 VDD.n1543 VDD.n1542 0.450828
R2746 VDD.n112 VDD.n117 0.489433
R2747 VDD.n1548 VDD.n1547 0.450828
R2748 VDD.n1550 VDD.n1549 0.450828
R2749 VDD.n1552 VDD.n1551 0.450828
R2750 VDD.n1556 VDD.n1555 0.450828
R2751 VDD.n1554 VDD.n1553 0.450828
R2752 VDD.n1545 VDD.n1544 0.450828
R2753 VDD.n1539 VDD.n1538 0.450828
R2754 VDD.n1535 VDD.n1534 0.450828
R2755 VDD.n1531 VDD.n1530 0.450828
R2756 VDD.n48 VDD.n44 0.403852
R2757 VDD.n1528 VDD.n1527 0.450828
R2758 VDD.n1526 VDD.n1525 0.450828
R2759 VDD.n1524 VDD.n1523 0.450828
R2760 VDD.n1520 VDD.n1519 0.450828
R2761 VDD.n1516 VDD.n1515 0.450828
R2762 VDD.n1514 VDD.n1513 0.450828
R2763 VDD.n1512 VDD.n1511 0.450828
R2764 VDD.n1504 VDD.n1503 0.450828
R2765 VDD.n1502 VDD.n1501 0.450828
R2766 VDD.n1500 VDD.n1499 0.450828
R2767 VDD.n1722 VDD.n1677 0.450828
R2768 VDD.n1718 VDD.n1674 0.450828
R2769 VDD.n1709 VDD.n1666 0.450828
R2770 VDD.n41 VDD.n40 0.403852
R2771 VDD.n1702 VDD.n1660 0.450828
R2772 VDD.n1695 VDD.n1656 0.450828
R2773 VDD.n1689 VDD.n108 0.489433
R2774 VDD.n1685 VDD.n1650 0.450828
R2775 VDD.n1683 VDD.n1648 0.450828
R2776 VDD.n1684 VDD.n1649 0.450828
R2777 VDD.n1687 VDD.n1651 0.450828
R2778 VDD.n1688 VDD.n1652 0.450828
R2779 VDD.n1690 VDD.n1653 0.450828
R2780 VDD.n1691 VDD.n1654 0.450828
R2781 VDD.n1693 VDD.n1655 0.450828
R2782 VDD.n1696 VDD.n1657 0.450828
R2783 VDD.n1700 VDD.n1658 0.450828
R2784 VDD.n1701 VDD.n1659 0.450828
R2785 VDD.n1704 VDD.n1662 0.450828
R2786 VDD.n1705 VDD.n1663 0.450828
R2787 VDD.n1706 VDD.n1664 0.450828
R2788 VDD.n1707 VDD.n1665 0.450828
R2789 VDD.n1710 VDD.n1667 0.450828
R2790 VDD.n1711 VDD.n1668 0.450828
R2791 VDD.n1713 VDD.n1669 0.450828
R2792 VDD.n1714 VDD.n1670 0.450828
R2793 VDD.n1720 VDD.n1675 0.450828
R2794 VDD.n1721 VDD.n1676 0.450828
R2795 VDD.n1018 VDD.n1017 0.450828
R2796 VDD.n1040 VDD.n1039 0.450828
R2797 VDD.n1044 VDD.n1043 0.450828
R2798 VDD.n1046 VDD.n1045 0.450828
R2799 VDD.n49 VDD.n39 0.403852
R2800 VDD.n1051 VDD.n1050 0.450828
R2801 VDD.n1066 VDD.n1065 0.450828
R2802 VDD.n1074 VDD.n1073 0.450828
R2803 VDD.n1072 VDD.n1071 0.450828
R2804 VDD.n1070 VDD.n1069 0.450828
R2805 VDD.n1068 VDD.n1067 0.450828
R2806 VDD.n106 VDD.n118 0.489433
R2807 VDD.n1063 VDD.n1062 0.450828
R2808 VDD.n1061 VDD.n1060 0.450828
R2809 VDD.n1059 VDD.n1058 0.450828
R2810 VDD.n1057 VDD.n1056 0.450828
R2811 VDD.n1055 VDD.n1054 0.450828
R2812 VDD.n1053 VDD.n1052 0.450828
R2813 VDD.n1049 VDD.n1048 0.450828
R2814 VDD.n1042 VDD.n1041 0.450828
R2815 VDD.n1038 VDD.n1037 0.450828
R2816 VDD.n1036 VDD.n1035 0.450828
R2817 VDD.n1034 VDD.n1033 0.450828
R2818 VDD.n1032 VDD.n1031 0.450828
R2819 VDD.n1030 VDD.n1029 0.450828
R2820 VDD.n1024 VDD.n1023 0.450828
R2821 VDD.n1022 VDD.n1021 0.450828
R2822 VDD.n1020 VDD.n1019 0.450828
R2823 VDD.n743 VDD.n685 0.450828
R2824 VDD.n749 VDD.n684 0.450828
R2825 VDD.n810 VDD.n675 0.450709
R2826 VDD.n877 VDD.n666 0.450618
R2827 VDD.n785 VDD.n678 0.450539
R2828 VDD.n454 VDD.n1343 0.446112
R2829 VDD.n92 VDD.n231 0.446112
R2830 VDD.n338 VDD.n1726 0.446112
R2831 VDD.n97 VDD.n325 0.446112
R2832 VDD.n702 VDD.n701 0.446112
R2833 VDD.n1782 VDD.n1781 0.432202
R2834 VDD.n32 VDD.n31 0.222978
R2835 VDD.n69 VDD.n66 0.429929
R2836 VDD.n78 VDD.n75 0.429929
R2837 VDD.n1291 VDD.n456 0.584408
R2838 VDD.n1680 VDD.n340 0.584408
R2839 VDD.n1013 VDD.n452 0.582844
R2840 VDD.n696 VDD.n695 0.428915
R2841 VDD.n699 VDD.n695 0.426918
R2842 VDD.n164 VDD.n455 0.426806
R2843 VDD.n164 VDD.n454 0.426806
R2844 VDD.n234 VDD.n232 0.426806
R2845 VDD.n234 VDD.n231 0.426806
R2846 VDD.n341 VDD.n339 0.426806
R2847 VDD.n341 VDD.n338 0.426806
R2848 VDD.n328 VDD.n324 0.426806
R2849 VDD.n328 VDD.n325 0.426806
R2850 VDD.n699 VDD.n698 0.426806
R2851 VDD.n703 VDD.n702 0.426806
R2852 VDD.n341 VDD.n340 0.230692
R2853 VDD.n452 VDD.n328 0.234913
R2854 VDD.n635 VDD.n68 0.424842
R2855 VDD.n69 VDD.n68 0.424687
R2856 VDD.n1298 VDD.n115 0.424417
R2857 VDD.n1547 VDD.n1546 0.424417
R2858 VDD.n1688 VDD.n109 0.424417
R2859 VDD.n1065 VDD.n1064 0.424417
R2860 VDD.n871 VDD.n103 0.424316
R2861 VDD.n16 VDD.n15 0.241475
R2862 VDD.n31 VDD.n30 0.413465
R2863 VDD.n1736 VDD.n17 0.413465
R2864 VDD.n11 VDD.n9 0.413465
R2865 VDD.n636 VDD.n635 0.413465
R2866 VDD.n639 VDD.n79 0.413465
R2867 VDD.n797 VDD.n676 0.409588
R2868 VDD.n1310 VDD.n1272 0.408574
R2869 VDD.n43 VDD.n1529 0.408574
R2870 VDD.n1703 VDD.n1661 0.408574
R2871 VDD.n38 VDD.n1047 0.408574
R2872 VDD.n544 VDD.n543 0.424317
R2873 VDD.n542 VDD.n541 0.405593
R2874 VDD.n235 VDD.n234 0.234198
R2875 VDD.n1782 VDD.n34 0.404675
R2876 VDD.n1495 VDD.n235 0.582532
R2877 VDD.n1766 VDD.n1765 0.372655
R2878 VDD.n1762 VDD.n662 0.372655
R2879 VDD.n844 VDD.n843 0.35553
R2880 VDD.n789 VDD.n788 0.355452
R2881 VDD.n899 VDD.n898 0.355452
R2882 VDD.n838 VDD.n837 0.355452
R2883 VDD.n826 VDD.n825 0.355452
R2884 VDD.n765 VDD.n764 0.355386
R2885 VDD.n753 VDD.n752 0.355386
R2886 VDD.n795 VDD.n794 0.355312
R2887 VDD.n771 VDD.n770 0.355312
R2888 VDD.n759 VDD.n758 0.355155
R2889 VDD.n862 VDD.n861 0.355155
R2890 VDD.n875 VDD.n874 0.355071
R2891 VDD.n850 VDD.n849 0.354936
R2892 VDD.n814 VDD.n813 0.354936
R2893 VDD.n783 VDD.n782 0.354936
R2894 VDD.n820 VDD.n819 0.354838
R2895 VDD.n801 VDD.n800 0.354838
R2896 VDD.n727 VDD.n726 0.354838
R2897 VDD.n1760 VDD.n1756 0.354771
R2898 VDD.n893 VDD.n892 0.354771
R2899 VDD.n887 VDD.n886 0.354771
R2900 VDD.n832 VDD.n831 0.354771
R2901 VDD.n747 VDD.n746 0.354771
R2902 VDD.n721 VDD.n720 0.354771
R2903 VDD.n881 VDD.n880 0.354697
R2904 VDD.n856 VDD.n855 0.354697
R2905 VDD.n777 VDD.n776 0.354697
R2906 VDD.n733 VDD.n732 0.354697
R2907 VDD.n715 VDD.n714 0.354697
R2908 VDD.n1757 VDD.n660 0.354405
R2909 VDD.n1226 VDD.n1225 0.348249
R2910 VDD.n1428 VDD.n1427 0.348249
R2911 VDD.n1616 VDD.n1615 0.348249
R2912 VDD.n1135 VDD.n1134 0.348249
R2913 VDD.n942 VDD.n941 0.348249
R2914 VDD.n1771 VDD.n1770 0.347952
R2915 VDD.n1761 VDD.n1760 0.347442
R2916 VDD.n1757 VDD.n661 0.347442
R2917 VDD.n657 VDD.n628 0.336433
R2918 VDD.n647 VDD.n630 0.336433
R2919 VDD.n1774 VDD.n1771 0.334405
R2920 VDD.n628 VDD.n627 0.331445
R2921 VDD.n651 VDD.n630 0.331445
R2922 VDD.n1765 VDD.n1761 0.32875
R2923 VDD.n1762 VDD.n661 0.32875
R2924 VDD.n1745 VDD.n660 0.327952
R2925 VDD.n1756 VDD.n1755 0.327571
R2926 VDD.n30 VDD.n1458 0.327154
R2927 VDD.n1737 VDD.n1736 0.327154
R2928 VDD.n9 VDD.n976 0.327154
R2929 VDD.n67 VDD.n636 0.327154
R2930 VDD.n77 VDD.n639 0.327154
R2931 VDD.n655 VDD.n654 0.326739
R2932 VDD.n1284 VDD.n1283 0.323571
R2933 VDD.n1509 VDD.n1508 0.323571
R2934 VDD.n1673 VDD.n1672 0.323571
R2935 VDD.n1027 VDD.n1026 0.323571
R2936 VDD.n688 VDD.n687 0.323218
R2937 VDD.n1749 VDD.n658 0.319468
R2938 VDD.n455 VDD.n1292 0.313353
R2939 VDD.n232 VDD.n1470 0.313353
R2940 VDD.n339 VDD.n1681 0.313353
R2941 VDD.n324 VDD.n987 0.313353
R2942 VDD.n698 VDD.n697 0.313353
R2943 VDD.n880 VDD.n879 0.31015
R2944 VDD.n855 VDD.n854 0.31015
R2945 VDD.n776 VDD.n775 0.31015
R2946 VDD.n732 VDD.n731 0.31015
R2947 VDD.n714 VDD.n713 0.31015
R2948 VDD.n892 VDD.n891 0.310071
R2949 VDD.n886 VDD.n885 0.310071
R2950 VDD.n831 VDD.n830 0.310071
R2951 VDD.n746 VDD.n745 0.310071
R2952 VDD.n720 VDD.n719 0.310071
R2953 VDD.n819 VDD.n818 0.309994
R2954 VDD.n800 VDD.n799 0.309994
R2955 VDD.n726 VDD.n725 0.309994
R2956 VDD.n849 VDD.n848 0.309928
R2957 VDD.n813 VDD.n812 0.309928
R2958 VDD.n782 VDD.n781 0.309928
R2959 VDD.n874 VDD.n873 0.309771
R2960 VDD.n758 VDD.n757 0.309692
R2961 VDD.n1767 VDD.n662 0.309692
R2962 VDD.n1770 VDD.n1766 0.309692
R2963 VDD.n861 VDD.n860 0.309692
R2964 VDD.n794 VDD.n793 0.309557
R2965 VDD.n770 VDD.n769 0.309557
R2966 VDD.n764 VDD.n763 0.309483
R2967 VDD.n752 VDD.n751 0.309483
R2968 VDD.n898 VDD.n897 0.309405
R2969 VDD.n837 VDD.n836 0.309405
R2970 VDD.n825 VDD.n824 0.309405
R2971 VDD.n788 VDD.n787 0.309405
R2972 VDD.n843 VDD.n842 0.309333
R2973 VDD.n634 VDD.n633 0.305596
R2974 VDD.n627 VDD 0.422989
R2975 VDD.t658 VDD.n15 5.72558
R2976 VDD.n309 VDD.n31 0.336945
R2977 VDD.n17 VDD.t636 5.72558
R2978 VDD.t604 VDD.n11 5.72558
R2979 VDD.n641 VDD.n640 0.299294
R2980 VDD.n648 VDD.n646 0.299035
R2981 VDD.n711 VDD.n693 0.29124
R2982 VDD.n1341 VDD.n1289 0.291071
R2983 VDD.n1499 VDD.n1498 0.291071
R2984 VDD.n1722 VDD.n1678 0.291071
R2985 VDD.n1017 VDD.n1016 0.291071
R2986 VDD.n144 VDD.n585 0.354412
R2987 VDD.n584 VDD.n991 0.354712
R2988 VDD.n1172 VDD.n1171 0.284268
R2989 VDD.n1244 VDD.n1243 0.284268
R2990 VDD.n1373 VDD.n1372 0.284268
R2991 VDD.n1445 VDD.n1444 0.284268
R2992 VDD.n1562 VDD.n1561 0.284268
R2993 VDD.n1633 VDD.n1632 0.284268
R2994 VDD.n1080 VDD.n1079 0.284268
R2995 VDD.n1152 VDD.n1151 0.284268
R2996 VDD.n904 VDD.n903 0.284268
R2997 VDD.n956 VDD.n955 0.284268
R2998 VDD.n655 VDD.n653 0.282925
R2999 VDD.n1173 VDD.n1172 0.282549
R3000 VDD.n1245 VDD.n1244 0.282549
R3001 VDD.n1225 VDD.n1224 0.282549
R3002 VDD.n1374 VDD.n1373 0.282549
R3003 VDD.n1446 VDD.n1445 0.282549
R3004 VDD.n1427 VDD.n1426 0.282549
R3005 VDD.n1563 VDD.n1562 0.282549
R3006 VDD.n1634 VDD.n1633 0.282549
R3007 VDD.n1615 VDD.n1614 0.282549
R3008 VDD.n1081 VDD.n1080 0.282549
R3009 VDD.n1153 VDD.n1152 0.282549
R3010 VDD.n1134 VDD.n1133 0.282549
R3011 VDD.n905 VDD.n904 0.282549
R3012 VDD.n957 VDD.n956 0.282549
R3013 VDD.n941 VDD.n940 0.282549
R3014 VDD.n735 VDD.n688 0.276071
R3015 VDD.n1335 VDD.n1284 0.275718
R3016 VDD.n1293 VDD.n15 0.313477
R3017 VDD.n1508 VDD.n1507 0.275718
R3018 VDD.n31 VDD.n29 0.379745
R3019 VDD.n1682 VDD.n17 0.313477
R3020 VDD.n1717 VDD.n1673 0.275718
R3021 VDD.n1026 VDD.n1025 0.275718
R3022 VDD.n11 VDD.n10 0.313477
R3023 VDD.n1191 VDD.n1171 0.268799
R3024 VDD.n1243 VDD.n1242 0.268799
R3025 VDD.n1392 VDD.n1372 0.268799
R3026 VDD.n1444 VDD.n1443 0.268799
R3027 VDD.n1581 VDD.n1561 0.268799
R3028 VDD.n1632 VDD.n1631 0.268799
R3029 VDD.n1099 VDD.n1079 0.268799
R3030 VDD.n1151 VDD.n1150 0.268799
R3031 VDD.n923 VDD.n903 0.268799
R3032 VDD.n955 VDD.n954 0.268799
R3033 VDD.n238 VDD.n236 0.10853
R3034 VDD.n241 VDD.n239 0.10853
R3035 VDD.n244 VDD.n242 0.10853
R3036 VDD.n247 VDD.n245 0.10853
R3037 VDD.n250 VDD.n248 0.10853
R3038 VDD.n808 VDD.n807 0.263915
R3039 VDD.n741 VDD.n740 0.263915
R3040 VDD.n869 VDD.n868 0.2636
R3041 VDD.n648 VDD.n647 0.260195
R3042 VDD.n1166 VDD.n658 0.259821
R3043 VDD.n1778 VDD.n1777 0.253639
R3044 VDD.n1752 VDD.n1751 0.253639
R3045 VDD.n66 VDD.n64 0.25333
R3046 VDD.n75 VDD.n643 0.25333
R3047 VDD.n1779 VDD.n1778 0.253298
R3048 VDD.n1753 VDD.n1752 0.253298
R3049 VDD.n1342 VDD.n1289 0.243218
R3050 VDD.n1498 VDD.n1497 0.243218
R3051 VDD.n1725 VDD.n1678 0.243218
R3052 VDD.n1016 VDD.n1015 0.243218
R3053 VDD.n705 VDD.n693 0.243044
R3054 VDD.n1174 VDD.n1173 0.241768
R3055 VDD.n1246 VDD.n1245 0.241768
R3056 VDD.n1224 VDD.n1223 0.241768
R3057 VDD.n1375 VDD.n1374 0.241768
R3058 VDD.n1447 VDD.n1446 0.241768
R3059 VDD.n1426 VDD.n1425 0.241768
R3060 VDD.n1564 VDD.n1563 0.241768
R3061 VDD.n1635 VDD.n1634 0.241768
R3062 VDD.n1614 VDD.n1613 0.241768
R3063 VDD.n1082 VDD.n1081 0.241768
R3064 VDD.n1154 VDD.n1153 0.241768
R3065 VDD.n1133 VDD.n1132 0.241768
R3066 VDD.n906 VDD.n905 0.241768
R3067 VDD.n958 VDD.n957 0.241768
R3068 VDD.n940 VDD.n939 0.241768
R3069 VDD.n645 VDD.n69 4.71183
R3070 VDD.n1365 VDD.n583 0.35501
R3071 VDD.n1349 VDD.n596 0.355155
R3072 VDD.n587 VDD.n1483 0.355155
R3073 VDD.n1686 VDD.n211 0.355228
R3074 VDD.n226 VDD.n266 0.355228
R3075 VDD.n601 VDD.n532 0.310312
R3076 VDD.n252 VDD.n251 0.263403
R3077 VDD.n518 VDD.n517 0.35501
R3078 VDD.n195 VDD.n510 0.310312
R3079 VDD.n582 VDD.n1490 0.354557
R3080 VDD.n1493 VDD.n202 0.595349
R3081 VDD.n1732 VDD.n590 0.35501
R3082 VDD.n1712 VDD.n276 0.354697
R3083 VDD.n1168 VDD.n1167 0.226543
R3084 VDD.n1205 VDD.n1204 0.226543
R3085 VDD.n1234 VDD.n1233 0.226543
R3086 VDD.n1215 VDD.n1214 0.226543
R3087 VDD.n1369 VDD.n1368 0.226543
R3088 VDD.n1406 VDD.n1405 0.226543
R3089 VDD.n1435 VDD.n1434 0.226543
R3090 VDD.n1417 VDD.n1416 0.226543
R3091 VDD.n1558 VDD.n1557 0.226543
R3092 VDD.n1595 VDD.n1594 0.226543
R3093 VDD.n1623 VDD.n1622 0.226543
R3094 VDD.n1605 VDD.n1604 0.226543
R3095 VDD.n1076 VDD.n1075 0.226543
R3096 VDD.n1114 VDD.n1113 0.226543
R3097 VDD.n1142 VDD.n1141 0.226543
R3098 VDD.n1124 VDD.n1123 0.226543
R3099 VDD.n1195 VDD.n1193 0.221058
R3100 VDD.n1197 VDD.n1196 0.221058
R3101 VDD.n1250 VDD.n1249 0.221058
R3102 VDD.n1239 VDD.n1238 0.221058
R3103 VDD.n1207 VDD.n1206 0.221058
R3104 VDD.n1228 VDD.n478 0.457062
R3105 VDD.n1217 VDD.n1216 0.221058
R3106 VDD.n1396 VDD.n1394 0.221058
R3107 VDD.n1398 VDD.n1397 0.221058
R3108 VDD.n1451 VDD.n1450 0.221058
R3109 VDD.n1440 VDD.n1439 0.221058
R3110 VDD.n1409 VDD.n1408 0.221058
R3111 VDD.n1430 VDD.n480 0.457062
R3112 VDD.n1419 VDD.n1418 0.221058
R3113 VDD.n1585 VDD.n1583 0.221058
R3114 VDD.n1587 VDD.n1586 0.221058
R3115 VDD.n1639 VDD.n1638 0.221058
R3116 VDD.n1628 VDD.n1627 0.221058
R3117 VDD.n1597 VDD.n1596 0.221058
R3118 VDD.n1618 VDD.n482 0.457062
R3119 VDD.n1607 VDD.n1606 0.221058
R3120 VDD.n1103 VDD.n1101 0.221058
R3121 VDD.n1105 VDD.n1104 0.221058
R3122 VDD.n1158 VDD.n1157 0.221058
R3123 VDD.n1147 VDD.n1146 0.221058
R3124 VDD.n1116 VDD.n1115 0.221058
R3125 VDD.n1136 VDD.n20 0.457062
R3126 VDD.n1126 VDD.n1125 0.221058
R3127 VDD.n962 VDD.n961 0.221058
R3128 VDD.n943 VDD.n24 0.457062
R3129 VDD.n934 VDD.n933 0.221058
R3130 VDD.n82 VDD.n64 0.137077
R3131 VDD.n81 VDD.n69 0.137077
R3132 VDD.n543 VDD 2.04432
R3133 VDD.n571 VDD 2.04432
R3134 VDD.n569 VDD 2.04432
R3135 VDD.n336 VDD 2.04432
R3136 VDD.n566 VDD 2.04432
R3137 VDD.n868 VDD.n867 0.216107
R3138 VDD.n807 VDD.n806 0.215797
R3139 VDD.n740 VDD.n739 0.215797
R3140 VDD.n637 VDD.n82 0.349827
R3141 VDD.n76 VDD.n81 0.338577
R3142 VDD.n656 VDD.n629 0.201736
R3143 VDD.n1334 VDD.n1282 0.198174
R3144 VDD.n1511 VDD.n1510 0.198174
R3145 VDD.n1714 VDD.n1671 0.198174
R3146 VDD.n1029 VDD.n1028 0.198174
R3147 VDD.n743 VDD.n686 0.197793
R3148 VDD.n1745 VDD.n659 0.191924
R3149 VDD.n1755 VDD.n1744 0.191924
R3150 VDD.n1359 VDD.n136 0.354903
R3151 VDD.n147 VDD.n1315 0.595208
R3152 VDD.n1316 VDD.n597 0.354405
R3153 VDD.n591 VDD.n1327 0.310452
R3154 VDD.n577 VDD.n1340 0.310071
R3155 VDD.n522 VDD.n521 0.355155
R3156 VDD.n1473 VDD.n192 0.651409
R3157 VDD.n1471 VDD.n314 0.501931
R3158 VDD.n318 VDD.n317 0.112731
R3159 VDD.n564 VDD.n1724 0.410004
R3160 VDD.n490 VDD.n489 0.355155
R3161 VDD.n291 VDD.n289 0.355452
R3162 VDD.n263 VDD.n262 0.131149
R3163 VDD.n593 VDD.n993 0.354405
R3164 VDD.n294 VDD.n292 0.355147
R3165 VDD.n484 VDD.n483 0.355155
R3166 VDD.n598 VDD.n990 0.354771
R3167 VDD.n988 VDD.n333 0.447271
R3168 VDD.n581 VDD.n1323 0.310149
R3169 VDD.n170 VDD.n168 0.272321
R3170 VDD.n177 VDD.n175 0.355153
R3171 VDD.n205 VDD.n203 0.355153
R3172 VDD.n279 VDD.n277 0.272321
R3173 VDD.n1774 VDD.n1772 0.184552
R3174 VDD.n1747 VDD.n1743 0.179888
R3175 VDD.n654 VDD.n629 0.175825
R3176 VDD.n1163 VDD.n459 0.229542
R3177 VDD.n969 VDD.n460 0.229542
R3178 VDD.n653 VDD.n652 0.171736
R3179 VDD.n709 VDD.n708 0.169888
R3180 VDD.n1742 VDD.n1741 0.16955
R3181 VDD.n891 VDD.n888 0.162388
R3182 VDD.n873 VDD.n870 0.162388
R3183 VDD.n842 VDD.n839 0.162388
R3184 VDD.n836 VDD.n833 0.162388
R3185 VDD.n793 VDD.n790 0.162388
R3186 VDD.n781 VDD.n778 0.162388
R3187 VDD.n1363 VDD.n1362 0.16205
R3188 VDD.n554 VDD.n1360 0.16205
R3189 VDD.n1355 VDD.n1354 0.16205
R3190 VDD.n1351 VDD.n1350 0.16205
R3191 VDD.n1348 VDD.n1347 0.16205
R3192 VDD.n1480 VDD.n1479 0.16205
R3193 VDD.n1485 VDD.n1484 0.16205
R3194 VDD.n1488 VDD.n1487 0.16205
R3195 VDD.n1492 VDD.n1491 0.16205
R3196 VDD.n1494 VDD.n1493 0.16205
R3197 VDD.n1735 VDD.n1734 0.16205
R3198 VDD.n1731 VDD.n1730 0.16205
R3199 VDD.n997 VDD.n996 0.16205
R3200 VDD.n1001 VDD.n1000 0.16205
R3201 VDD.n1003 VDD.n1002 0.16205
R3202 VDD.n1007 VDD.n1006 0.16205
R3203 VDD.n327 VDD.n1012 0.16205
R3204 VDD.n902 VDD.n900 0.16205
R3205 VDD.n897 VDD.n894 0.16205
R3206 VDD.n885 VDD.n882 0.16205
R3207 VDD.n879 VDD.n876 0.16205
R3208 VDD.n865 VDD.n863 0.16205
R3209 VDD.n860 VDD.n857 0.16205
R3210 VDD.n854 VDD.n851 0.16205
R3211 VDD.n848 VDD.n845 0.16205
R3212 VDD.n830 VDD.n827 0.16205
R3213 VDD.n824 VDD.n821 0.16205
R3214 VDD.n818 VDD.n815 0.16205
R3215 VDD.n812 VDD.n809 0.16205
R3216 VDD.n804 VDD.n802 0.16205
R3217 VDD.n799 VDD.n796 0.16205
R3218 VDD.n787 VDD.n784 0.16205
R3219 VDD.n775 VDD.n772 0.16205
R3220 VDD.n769 VDD.n766 0.16205
R3221 VDD.n763 VDD.n760 0.16205
R3222 VDD.n757 VDD.n754 0.16205
R3223 VDD.n751 VDD.n748 0.16205
R3224 VDD.n745 VDD.n742 0.16205
R3225 VDD.n737 VDD.n734 0.16205
R3226 VDD.n731 VDD.n728 0.16205
R3227 VDD.n725 VDD.n722 0.16205
R3228 VDD.n719 VDD.n716 0.16205
R3229 VDD.n713 VDD.n710 0.16205
R3230 VDD.n1781 VDD.n1772 0.161793
R3231 VDD.n1185 VDD.n1184 0.159888
R3232 VDD.n1386 VDD.n1385 0.159888
R3233 VDD.n1575 VDD.n1574 0.159888
R3234 VDD.n1093 VDD.n1092 0.159888
R3235 VDD.n917 VDD.n916 0.159888
R3236 VDD.n618 VDD.n656 0.820553
R3237 VDD.t351 VDD.t352 0.405207
R3238 VDD.n1192 VDD.n1191 0.157388
R3239 VDD.n1256 VDD.n1255 0.157388
R3240 VDD.n1199 VDD.n1198 0.157388
R3241 VDD.n1252 VDD.n1251 0.157388
R3242 VDD.n1242 VDD.n87 0.157388
R3243 VDD.n1241 VDD.n1240 0.157388
R3244 VDD.n1209 VDD.n1208 0.157388
R3245 VDD.n1230 VDD.n1229 0.157388
R3246 VDD.n1219 VDD.n1218 0.157388
R3247 VDD.n1393 VDD.n1392 0.157388
R3248 VDD.n1456 VDD.n1455 0.157388
R3249 VDD.n1400 VDD.n1399 0.157388
R3250 VDD.n1453 VDD.n1452 0.157388
R3251 VDD.n1443 VDD.n86 0.157388
R3252 VDD.n1442 VDD.n1441 0.157388
R3253 VDD.n1411 VDD.n1410 0.157388
R3254 VDD.n1432 VDD.n1431 0.157388
R3255 VDD.n1421 VDD.n1420 0.157388
R3256 VDD.n1582 VDD.n1581 0.157388
R3257 VDD.n1646 VDD.n1645 0.157388
R3258 VDD.n1589 VDD.n1588 0.157388
R3259 VDD.n1641 VDD.n1640 0.157388
R3260 VDD.n1631 VDD.n85 0.157388
R3261 VDD.n1630 VDD.n1629 0.157388
R3262 VDD.n1599 VDD.n1598 0.157388
R3263 VDD.n1620 VDD.n1619 0.157388
R3264 VDD.n1609 VDD.n1608 0.157388
R3265 VDD.n1100 VDD.n1099 0.157388
R3266 VDD.n1165 VDD.n1164 0.157388
R3267 VDD.n1108 VDD.n1106 0.157388
R3268 VDD.n1160 VDD.n1159 0.157388
R3269 VDD.n1150 VDD.n84 0.157388
R3270 VDD.n1149 VDD.n1148 0.157388
R3271 VDD.n1118 VDD.n1117 0.157388
R3272 VDD.n1138 VDD.n1137 0.157388
R3273 VDD.n1128 VDD.n1127 0.157388
R3274 VDD.n924 VDD.n923 0.157388
R3275 VDD.n971 VDD.n970 0.157388
R3276 VDD.n927 VDD.n926 0.157388
R3277 VDD.n964 VDD.n963 0.157388
R3278 VDD.n954 VDD.n83 0.157388
R3279 VDD.n953 VDD.n952 0.157388
R3280 VDD.n931 VDD.n929 0.157388
R3281 VDD.n945 VDD.n944 0.157388
R3282 VDD.n936 VDD.n935 0.157388
R3283 VDD.n1747 VDD.n1744 0.154424
R3284 VDD.n1749 VDD.n659 0.154424
R3285 VDD.n1195 VDD.n1194 0.154043
R3286 VDD.n1201 VDD.n1196 0.154043
R3287 VDD.n1249 VDD.n1248 0.154043
R3288 VDD.n1238 VDD.n1237 0.154043
R3289 VDD.n1211 VDD.n1206 0.154043
R3290 VDD.n1221 VDD.n1216 0.154043
R3291 VDD.n1396 VDD.n1395 0.154043
R3292 VDD.n1402 VDD.n1397 0.154043
R3293 VDD.n1450 VDD.n1449 0.154043
R3294 VDD.n1439 VDD.n1438 0.154043
R3295 VDD.n1413 VDD.n1408 0.154043
R3296 VDD.n1423 VDD.n1418 0.154043
R3297 VDD.n1585 VDD.n1584 0.154043
R3298 VDD.n1591 VDD.n1586 0.154043
R3299 VDD.n1638 VDD.n1637 0.154043
R3300 VDD.n1627 VDD.n1626 0.154043
R3301 VDD.n1601 VDD.n1596 0.154043
R3302 VDD.n1611 VDD.n1606 0.154043
R3303 VDD.n1103 VDD.n1102 0.154043
R3304 VDD.n1110 VDD.n1104 0.154043
R3305 VDD.n1157 VDD.n1156 0.154043
R3306 VDD.n1146 VDD.n1145 0.154043
R3307 VDD.n1120 VDD.n1115 0.154043
R3308 VDD.n1130 VDD.n1125 0.154043
R3309 VDD.n961 VDD.n960 0.154043
R3310 VDD.n937 VDD.n933 0.154043
R3311 VDD.n627 VDD.n626 0.152808
R3312 VDD.n651 VDD.n650 0.152808
R3313 VDD.n651 VDD.n649 0.152808
R3314 VDD.n237 VDD.n1175 0.15205
R3315 VDD.n240 VDD.n1376 0.15205
R3316 VDD.n243 VDD.n1565 0.15205
R3317 VDD.n246 VDD.n1083 0.15205
R3318 VDD.n249 VDD.n907 0.15205
R3319 VDD.n687 VDD.n686 0.151058
R3320 VDD.n1283 VDD.n1282 0.150674
R3321 VDD.n1510 VDD.n1509 0.150674
R3322 VDD.n1672 VDD.n1671 0.150674
R3323 VDD.n1028 VDD.n1027 0.150674
R3324 VDD.n1182 VDD.n1178 0.149888
R3325 VDD.n1383 VDD.n1379 0.149888
R3326 VDD.n1572 VDD.n1568 0.149888
R3327 VDD.n1090 VDD.n1086 0.149888
R3328 VDD.n914 VDD.n910 0.149888
R3329 VDD.n1169 VDD.n1168 0.148558
R3330 VDD.n1204 VDD.n1203 0.148558
R3331 VDD.n1235 VDD.n1234 0.148558
R3332 VDD.n1214 VDD.n1213 0.148558
R3333 VDD.n1370 VDD.n1369 0.148558
R3334 VDD.n1405 VDD.n1404 0.148558
R3335 VDD.n1436 VDD.n1435 0.148558
R3336 VDD.n1416 VDD.n1415 0.148558
R3337 VDD.n1559 VDD.n1558 0.148558
R3338 VDD.n1594 VDD.n1593 0.148558
R3339 VDD.n1624 VDD.n1623 0.148558
R3340 VDD.n1604 VDD.n1603 0.148558
R3341 VDD.n1077 VDD.n1076 0.148558
R3342 VDD.n1113 VDD.n1112 0.148558
R3343 VDD.n1143 VDD.n1142 0.148558
R3344 VDD.n1123 VDD.n1122 0.148558
R3345 VDD.n652 VDD.n651 0.147075
R3346 VDD.n256 VDD.n310 0.446818
R3347 VDD.n580 VDD.n534 0.310155
R3348 VDD.n1315 VDD.n603 0.16205
R3349 VDD.n1327 VDD.n588 0.16205
R3350 VDD.n157 VDD.n155 0.0355581
R3351 VDD.n1477 VDD.n555 0.409632
R3352 VDD.n619 VDD.n1477 0.16205
R3353 VDD.n605 VDD.n1474 0.16205
R3354 VDD.n474 VDD.n473 0.2636
R3355 VDD.n1692 VDD.n575 0.354771
R3356 VDD.n229 VDD.n227 0.0191416
R3357 VDD.n1724 VDD.n614 0.16205
R3358 VDD.n994 VDD.n263 0.504981
R3359 VDD.n592 VDD.n992 0.16205
R3360 VDD.n609 VDD.n304 0.16205
R3361 VDD.n586 VDD.n989 0.16205
R3362 VDD.n615 VDD.n988 0.16205
R3363 VDD.n1187 VDD.n1186 0.142118
R3364 VDD.n1388 VDD.n1387 0.142118
R3365 VDD.n1577 VDD.n1576 0.142118
R3366 VDD.n1095 VDD.n1094 0.142118
R3367 VDD.n919 VDD.n918 0.142118
R3368 VDD.n1183 VDD.n1182 0.13705
R3369 VDD.n1384 VDD.n1383 0.13705
R3370 VDD.n1573 VDD.n1572 0.13705
R3371 VDD.n1091 VDD.n1090 0.13705
R3372 VDD.n915 VDD.n914 0.13705
R3373 VDD.n1190 VDD.n1189 0.134618
R3374 VDD.n1391 VDD.n1390 0.134618
R3375 VDD.n1580 VDD.n1579 0.134618
R3376 VDD.n1098 VDD.n1097 0.134618
R3377 VDD.n922 VDD.n921 0.134618
R3378 VDD.n1292 VDD.n1291 0.133259
R3379 VDD.n1495 VDD.n1470 0.133259
R3380 VDD.n1681 VDD.n1680 0.133259
R3381 VDD.n1739 VDD.n1737 0.133259
R3382 VDD.n1013 VDD.n987 0.133259
R3383 VDD.n697 VDD.n696 0.133259
R3384 VDD.n78 VDD.n77 0.133259
R3385 VDD.n573 VDD.n543 1.90206
R3386 VDD.n572 VDD.n571 1.90206
R3387 VDD.n570 VDD.n569 1.90206
R3388 VDD.n568 VDD.n336 1.90206
R3389 VDD.n567 VDD.n566 1.90206
R3390 VDD.t353 VDD.n1259 1.55361
R3391 VDD.t341 VDD.n1677 1.55361
R3392 VDD.n1074 VDD.t381 1.55361
R3393 VDD.n1556 VDD.t339 1.55361
R3394 VDD.n400 VDD.n439 1.12289
R3395 VDD.n397 VDD.n438 1.12289
R3396 VDD.n1232 VDD.n394 1.12289
R3397 VDD.n391 VDD.n437 1.12289
R3398 VDD.n386 VDD.n434 1.12289
R3399 VDD.n383 VDD.n433 1.12289
R3400 VDD.n380 VDD.n432 1.12289
R3401 VDD.n1643 VDD.n375 1.12289
R3402 VDD.n372 VDD.n428 1.12289
R3403 VDD.n369 VDD.n427 1.12289
R3404 VDD.n366 VDD.n426 1.12289
R3405 VDD.n363 VDD.n423 1.12289
R3406 VDD.n360 VDD.n422 1.12289
R3407 VDD.n1140 VDD.n357 1.12289
R3408 VDD.n1258 VDD.n355 1.12284
R3409 VDD.n352 VDD.n431 1.12284
R3410 VDD.n336 VDD.n335 1.07347
R3411 VDD.n333 VDD.n331 0.98163
R3412 VDD.n305 VDD.n304 0.928676
R3413 VDD.n992 VDD.n297 0.928641
R3414 VDD.n191 VDD.n190 0.924738
R3415 VDD.n450 VDD.n462 0.91739
R3416 VDD.n283 VDD.n282 0.887581
R3417 VDD.n197 VDD.n196 0.88746
R3418 VDD.n287 VDD.n286 0.887431
R3419 VDD.n270 VDD.n269 0.887431
R3420 VDD.n180 VDD.n179 0.887431
R3421 VDD.n330 VDD.n999 0.798887
R3422 VDD.n349 VDD.n468 0.818667
R3423 VDD.n348 VDD.n469 0.818667
R3424 VDD.n347 VDD.n470 0.818667
R3425 VDD.n346 VDD.n471 0.818667
R3426 VDD.n345 VDD.n472 0.818667
R3427 VDD.n323 VDD.n322 0.815079
R3428 VDD.n328 VDD.n327 0.792298
R3429 VDD.n614 VDD.n341 0.784613
R3430 VDD.n20 VDD.n18 0.781588
R3431 VDD.n344 VDD.n343 0.781584
R3432 VDD.n425 VDD.n424 0.771447
R3433 VDD.n975 VDD.n421 0.771447
R3434 VDD.n968 VDD.n420 0.771447
R3435 VDD.n419 VDD.n418 0.771447
R3436 VDD.n949 VDD.n417 0.771447
R3437 VDD.n475 VDD.n318 0.767641
R3438 VDD.n476 VDD.n320 0.767513
R3439 VDD.n22 VDD.n936 0.765878
R3440 VDD.n412 VDD.n927 0.765878
R3441 VDD.n1453 VDD.n410 0.765878
R3442 VDD.n1165 VDD.n416 0.765829
R3443 VDD.n47 VDD.n34 0.596429
R3444 VDD.n451 VDD.n1008 0.762519
R3445 VDD.n1254 VDD.n403 0.758958
R3446 VDD.n1454 VDD.n389 0.758958
R3447 VDD.n1644 VDD.n378 0.758958
R3448 VDD.n408 VDD.n407 0.729979
R3449 VDD.n406 VDD.n405 0.729979
R3450 VDD.n378 VDD.n377 0.729979
R3451 VDD.n389 VDD.n388 0.729979
R3452 VDD.n403 VDD.n402 0.729979
R3453 VDD.n164 VDD.n456 0.728529
R3454 VDD.n441 VDD.n403 0.725089
R3455 VDD.n436 VDD.n389 0.725089
R3456 VDD.n430 VDD.n378 0.725089
R3457 VDD.n410 VDD.n409 0.719342
R3458 VDD.n416 VDD.n415 0.719342
R3459 VDD.n412 VDD.n411 0.719342
R3460 VDD.n22 VDD.n414 0.719342
R3461 VDD.n88 VDD.n78 0.706063
R3462 VDD.n474 VDD.n313 0.679686
R3463 VDD.n352 VDD.n350 0.0415536
R3464 VDD.n355 VDD.n353 0.0415536
R3465 VDD.n367 VDD.n366 0.0415457
R3466 VDD.n373 VDD.n372 0.0415457
R3467 VDD.n376 VDD.n375 0.0415457
R3468 VDD.n381 VDD.n380 0.0415457
R3469 VDD.n384 VDD.n383 0.0415457
R3470 VDD.n387 VDD.n386 0.0415457
R3471 VDD.n392 VDD.n391 0.0415457
R3472 VDD.n395 VDD.n394 0.0415457
R3473 VDD.n398 VDD.n397 0.0415457
R3474 VDD.n401 VDD.n400 0.0415457
R3475 VDD.n539 VDD.n33 0.604342
R3476 VDD.n334 VDD.n540 0.60434
R3477 VDD.n497 VDD.n273 0.519742
R3478 VDD.n558 VDD.n514 0.519701
R3479 VDD.n538 VDD.n123 0.519649
R3480 VDD.n504 VDD.n217 0.519649
R3481 VDD.n225 VDD.n223 0.274072
R3482 VDD.n559 VDD.n509 0.519555
R3483 VDD.n565 VDD.n488 0.519555
R3484 VDD.n310 VDD.n130 0.519504
R3485 VDD.n555 VDD.n529 0.519504
R3486 VDD.n527 VDD.n180 0.519504
R3487 VDD.n270 VDD.n268 0.519504
R3488 VDD.n287 VDD.n285 0.519504
R3489 VDD.n127 VDD.n125 0.519501
R3490 VDD.n197 VDD.n195 0.519501
R3491 VDD.n507 VDD.n208 0.519501
R3492 VDD.n147 VDD.n146 0.273989
R3493 VDD.n173 VDD.n174 0.273989
R3494 VDD.n532 VDD.n531 0.519414
R3495 VDD.n184 VDD.n182 0.519394
R3496 VDD.n283 VDD.n281 0.519394
R3497 VDD.n201 VDD.n202 0.273931
R3498 VDD.n563 VDD.n495 0.51931
R3499 VDD.n534 VDD.n553 0.519208
R3500 VDD.n556 VDD.n524 0.519208
R3501 VDD.n557 VDD.n520 0.519208
R3502 VDD.n516 VDD.n512 0.519208
R3503 VDD.n560 VDD.n316 0.519208
R3504 VDD.n222 VDD.n561 0.519208
R3505 VDD.n562 VDD.n499 0.519208
R3506 VDD.n493 VDD.n564 0.519208
R3507 VDD.n541 VDD.n544 0.46794
R3508 VDD.n540 VDD.n542 0.46794
R3509 VDD.n335 VDD.n539 0.46794
R3510 VDD.n167 VDD.n164 0.448327
R3511 VDD.n153 VDD.n151 0.440065
R3512 VDD.n1177 VDD.n1176 0.132118
R3513 VDD.n1378 VDD.n1377 0.132118
R3514 VDD.n1567 VDD.n1566 0.132118
R3515 VDD.n1085 VDD.n1084 0.132118
R3516 VDD.n909 VDD.n908 0.132118
R3517 VDD.n441 VDD.n440 0.532767
R3518 VDD.n344 VDD.n342 0.532722
R3519 VDD.n436 VDD.n435 0.532767
R3520 VDD.n430 VDD.n429 0.532767
R3521 VDD.n424 VDD.n620 0.0651609
R3522 VDD.n20 VDD.n19 0.532767
R3523 VDD.n975 VDD.n622 0.0651609
R3524 VDD.n968 VDD.n623 0.0651609
R3525 VDD.n418 VDD.n624 0.0651609
R3526 VDD.n949 VDD.n625 0.0651609
R3527 VDD.n355 VDD.n354 0.12922
R3528 VDD.n400 VDD.n399 0.12922
R3529 VDD.n397 VDD.n396 0.12922
R3530 VDD.n394 VDD.n393 0.12922
R3531 VDD.n391 VDD.n390 0.12922
R3532 VDD.n552 VDD.n551 0.12922
R3533 VDD.n549 VDD.n548 0.12922
R3534 VDD.n386 VDD.n385 0.12922
R3535 VDD.n383 VDD.n382 0.12922
R3536 VDD.n380 VDD.n379 0.12922
R3537 VDD.n352 VDD.n351 0.12922
R3538 VDD.n375 VDD.n374 0.12922
R3539 VDD.n372 VDD.n371 0.12922
R3540 VDD.n369 VDD.n368 0.12922
R3541 VDD.n366 VDD.n365 0.12922
R3542 VDD.n547 VDD.n546 0.12922
R3543 VDD.n424 VDD.n1162 0.12922
R3544 VDD.n363 VDD.n362 0.12922
R3545 VDD.n360 VDD.n359 0.12922
R3546 VDD.n357 VDD.n356 0.12922
R3547 VDD.n975 VDD.n974 0.12922
R3548 VDD.n968 VDD.n967 0.12922
R3549 VDD.n418 VDD.n950 0.12922
R3550 VDD.n949 VDD.n948 0.12922
R3551 VDD.n634 VDD.n632 0.128662
R3552 VDD.n607 VDD.n538 0.310312
R3553 VDD.n531 VDD.n554 0.409756
R3554 VDD.n585 VDD.n1355 0.310446
R3555 VDD.n182 VDD.n181 0.633198
R3556 VDD.n1491 VDD.n582 0.310312
R3557 VDD.n589 VDD.n499 0.310312
R3558 VDD.n563 VDD.n493 0.4099
R3559 VDD.n1000 VDD.n288 0.633015
R3560 VDD.n464 VDD.n465 0.310312
R3561 VDD.n1006 VDD.n584 0.31013
R3562 VDD.n707 VDD.n704 0.124618
R3563 VDD.n128 VDD.n257 0.699119
R3564 VDD.n254 VDD.n253 0.216315
R3565 VDD.n189 VDD.n252 0.216315
R3566 VDD.n704 VDD.n703 0.122118
R3567 VDD.n1741 VDD.n1740 0.119888
R3568 VDD.n1183 VDD.n1181 0.119888
R3569 VDD.n1384 VDD.n1382 0.119888
R3570 VDD.n1573 VDD.n1571 0.119888
R3571 VDD.n1091 VDD.n1089 0.119888
R3572 VDD.n915 VDD.n913 0.119888
R3573 VDD.n1181 VDD.n1179 0.119618
R3574 VDD.n1382 VDD.n1380 0.119618
R3575 VDD.n1571 VDD.n1569 0.119618
R3576 VDD.n1089 VDD.n1087 0.119618
R3577 VDD.n913 VDD.n911 0.119618
R3578 VDD.n1362 VDD.n1361 0.117388
R3579 VDD.n1360 VDD.n1359 0.117388
R3580 VDD.n1354 VDD.n1353 0.117388
R3581 VDD.n1350 VDD.n1349 0.117388
R3582 VDD.n1347 VDD.n1346 0.117388
R3583 VDD.n175 VDD.n1480 0.117388
R3584 VDD.n1486 VDD.n1485 0.117388
R3585 VDD.n1489 VDD.n1488 0.117388
R3586 VDD.n473 VDD.n1492 0.117388
R3587 VDD.n203 VDD.n1494 0.117388
R3588 VDD.n1734 VDD.n1733 0.117388
R3589 VDD.n1730 VDD.n1729 0.117388
R3590 VDD.n998 VDD.n997 0.117388
R3591 VDD.n289 VDD.n1001 0.117388
R3592 VDD.n292 VDD.n1003 0.117388
R3593 VDD.n1008 VDD.n1007 0.117388
R3594 VDD.n900 VDD.n899 0.117388
R3595 VDD.n894 VDD.n893 0.117388
R3596 VDD.n882 VDD.n881 0.117388
R3597 VDD.n876 VDD.n875 0.117388
R3598 VDD.n863 VDD.n862 0.117388
R3599 VDD.n857 VDD.n856 0.117388
R3600 VDD.n851 VDD.n850 0.117388
R3601 VDD.n845 VDD.n844 0.117388
R3602 VDD.n827 VDD.n826 0.117388
R3603 VDD.n821 VDD.n820 0.117388
R3604 VDD.n815 VDD.n814 0.117388
R3605 VDD.n809 VDD.n808 0.117388
R3606 VDD.n802 VDD.n801 0.117388
R3607 VDD.n796 VDD.n795 0.117388
R3608 VDD.n784 VDD.n783 0.117388
R3609 VDD.n772 VDD.n771 0.117388
R3610 VDD.n766 VDD.n765 0.117388
R3611 VDD.n760 VDD.n759 0.117388
R3612 VDD.n754 VDD.n753 0.117388
R3613 VDD.n748 VDD.n747 0.117388
R3614 VDD.n742 VDD.n741 0.117388
R3615 VDD.n734 VDD.n733 0.117388
R3616 VDD.n728 VDD.n727 0.117388
R3617 VDD.n722 VDD.n721 0.117388
R3618 VDD.n716 VDD.n715 0.117388
R3619 VDD.n710 VDD.n709 0.117388
R3620 VDD.n867 VDD.n866 0.117118
R3621 VDD.n806 VDD.n805 0.117118
R3622 VDD.n739 VDD.n738 0.117118
R3623 VDD.n1743 VDD.n1742 0.11705
R3624 VDD.n888 VDD.n887 0.11705
R3625 VDD.n870 VDD.n869 0.11705
R3626 VDD.n839 VDD.n838 0.11705
R3627 VDD.n833 VDD.n832 0.11705
R3628 VDD.n790 VDD.n789 0.11705
R3629 VDD.n778 VDD.n777 0.11705
R3630 VDD.n1188 VDD.n1187 0.114618
R3631 VDD.n1389 VDD.n1388 0.114618
R3632 VDD.n1578 VDD.n1577 0.114618
R3633 VDD.n1096 VDD.n1095 0.114618
R3634 VDD.n920 VDD.n919 0.114618
R3635 VDD.n708 VDD.n707 0.11455
R3636 VDD.n1193 VDD.n1192 0.1133
R3637 VDD.n1255 VDD.n1254 0.1133
R3638 VDD.n1198 VDD.n1197 0.1133
R3639 VDD.n1251 VDD.n1250 0.1133
R3640 VDD.n1240 VDD.n1239 0.1133
R3641 VDD.n1208 VDD.n1207 0.1133
R3642 VDD.n1229 VDD.n1228 0.1133
R3643 VDD.n1218 VDD.n1217 0.1133
R3644 VDD.n1394 VDD.n1393 0.1133
R3645 VDD.n1455 VDD.n1454 0.1133
R3646 VDD.n1399 VDD.n1398 0.1133
R3647 VDD.n1452 VDD.n1451 0.1133
R3648 VDD.n1441 VDD.n1440 0.1133
R3649 VDD.n1410 VDD.n1409 0.1133
R3650 VDD.n1431 VDD.n1430 0.1133
R3651 VDD.n1420 VDD.n1419 0.1133
R3652 VDD.n1583 VDD.n1582 0.1133
R3653 VDD.n1645 VDD.n1644 0.1133
R3654 VDD.n1588 VDD.n1587 0.1133
R3655 VDD.n1640 VDD.n1639 0.1133
R3656 VDD.n1629 VDD.n1628 0.1133
R3657 VDD.n1598 VDD.n1597 0.1133
R3658 VDD.n1619 VDD.n1618 0.1133
R3659 VDD.n1608 VDD.n1607 0.1133
R3660 VDD.n1101 VDD.n1100 0.1133
R3661 VDD.n1164 VDD.n1163 0.1133
R3662 VDD.n1106 VDD.n1105 0.1133
R3663 VDD.n1159 VDD.n1158 0.1133
R3664 VDD.n1148 VDD.n1147 0.1133
R3665 VDD.n1117 VDD.n1116 0.1133
R3666 VDD.n1137 VDD.n1136 0.1133
R3667 VDD.n1127 VDD.n1126 0.1133
R3668 VDD.n6 VDD.n924 0.1133
R3669 VDD.n970 VDD.n969 0.1133
R3670 VDD.n926 VDD.n925 0.1133
R3671 VDD.n963 VDD.n962 0.1133
R3672 VDD.n952 VDD.n951 0.1133
R3673 VDD.n929 VDD.n928 0.1133
R3674 VDD.n944 VDD.n943 0.1133
R3675 VDD.n935 VDD.n934 0.1133
R3676 VDD.n1178 VDD.n1177 0.10705
R3677 VDD.n1379 VDD.n1378 0.10705
R3678 VDD.n1568 VDD.n1567 0.10705
R3679 VDD.n1086 VDD.n1085 0.10705
R3680 VDD.n910 VDD.n909 0.10705
R3681 VDD.n1189 VDD.n1175 0.104888
R3682 VDD.n1390 VDD.n1376 0.104888
R3683 VDD.n1579 VDD.n1565 0.104888
R3684 VDD.n1097 VDD.n1083 0.104888
R3685 VDD.n921 VDD.n907 0.104888
R3686 VDD.n60 VDD.n59 0.288164
R3687 VDD.n58 VDD.n57 0.288164
R3688 VDD.n56 VDD.n55 0.288164
R3689 VDD.n54 VDD.n53 0.288164
R3690 VDD.n52 VDD.n51 0.288164
R3691 VDD.n644 VDD.n80 0.324122
R3692 VDD.n13 VDD.t365 0.190923
R3693 VDD.n65 VDD.t628 15.0172
R3694 VDD.n642 VDD.n641 0.0976667
R3695 VDD.n1186 VDD.n1185 0.0970502
R3696 VDD.n1387 VDD.n1386 0.0970502
R3697 VDD.n1576 VDD.n1575 0.0970502
R3698 VDD.n1094 VDD.n1093 0.0970502
R3699 VDD.n918 VDD.n917 0.0970502
R3700 VDD.n552 VDD.n550 0.0958676
R3701 VDD.n1407 VDD.n549 0.0958676
R3702 VDD.n547 VDD.n545 0.0958676
R3703 VDD.n643 VDD.n642 0.094
R3704 VDD.n1180 VDD.n1179 0.0921176
R3705 VDD.n1381 VDD.n1380 0.0921176
R3706 VDD.n1570 VDD.n1569 0.0921176
R3707 VDD.n1088 VDD.n1087 0.0921176
R3708 VDD.n912 VDD.n911 0.0921176
R3709 VDD.n1170 VDD.n1169 0.0905
R3710 VDD.n1203 VDD.n1202 0.0905
R3711 VDD.n1247 VDD.n1246 0.0905
R3712 VDD.n1236 VDD.n1235 0.0905
R3713 VDD.n1213 VDD.n1212 0.0905
R3714 VDD.n1223 VDD.n1222 0.0905
R3715 VDD.n1371 VDD.n1370 0.0905
R3716 VDD.n1404 VDD.n1403 0.0905
R3717 VDD.n1448 VDD.n1447 0.0905
R3718 VDD.n1437 VDD.n1436 0.0905
R3719 VDD.n1415 VDD.n1414 0.0905
R3720 VDD.n1425 VDD.n1424 0.0905
R3721 VDD.n1560 VDD.n1559 0.0905
R3722 VDD.n1593 VDD.n1592 0.0905
R3723 VDD.n1636 VDD.n1635 0.0905
R3724 VDD.n1625 VDD.n1624 0.0905
R3725 VDD.n1603 VDD.n1602 0.0905
R3726 VDD.n1613 VDD.n1612 0.0905
R3727 VDD.n1078 VDD.n1077 0.0905
R3728 VDD.n1112 VDD.n1111 0.0905
R3729 VDD.n1155 VDD.n1154 0.0905
R3730 VDD.n1144 VDD.n1143 0.0905
R3731 VDD.n1122 VDD.n1121 0.0905
R3732 VDD.n1132 VDD.n1131 0.0905
R3733 VDD.n959 VDD.n958 0.0905
R3734 VDD.n939 VDD.n938 0.0905
R3735 VDD.n641 VDD.n79 0.0902959
R3736 VDD.n1258 VDD.n1257 0.0896176
R3737 VDD.n1200 VDD.n440 0.0896176
R3738 VDD.n439 VDD.n1253 0.0896176
R3739 VDD.n1210 VDD.n438 0.0896176
R3740 VDD.n1232 VDD.n1231 0.0896176
R3741 VDD.n1220 VDD.n437 0.0896176
R3742 VDD.n342 VDD.n1457 0.0896176
R3743 VDD.n1401 VDD.n435 0.0896176
R3744 VDD.n1412 VDD.n434 0.0896176
R3745 VDD.n433 VDD.n1433 0.0896176
R3746 VDD.n1422 VDD.n432 0.0896176
R3747 VDD.n431 VDD.n1647 0.0896176
R3748 VDD.n1590 VDD.n429 0.0896176
R3749 VDD.n1643 VDD.n1642 0.0896176
R3750 VDD.n1600 VDD.n428 0.0896176
R3751 VDD.n427 VDD.n1621 0.0896176
R3752 VDD.n1610 VDD.n426 0.0896176
R3753 VDD.n1109 VDD.n1107 0.0896176
R3754 VDD.n423 VDD.n1161 0.0896176
R3755 VDD.n1119 VDD.n422 0.0896176
R3756 VDD.n1140 VDD.n1139 0.0896176
R3757 VDD.n1129 VDD.n19 0.0896176
R3758 VDD.n973 VDD.n972 0.0896176
R3759 VDD.n966 VDD.n965 0.0896176
R3760 VDD.n932 VDD.n930 0.0896176
R3761 VDD.n947 VDD.n946 0.0896176
R3762 VDD.n1739 VDD.n1738 0.08925
R3763 VDD.n1342 VDD.n90 0.088
R3764 VDD.n1497 VDD.n94 0.088
R3765 VDD.n1725 VDD.n95 0.088
R3766 VDD.n1015 VDD.n99 0.088
R3767 VDD.n705 VDD.n100 0.088
R3768 VDD.n1194 VDD.n1170 0.08425
R3769 VDD.n1202 VDD.n1201 0.08425
R3770 VDD.n1248 VDD.n1247 0.08425
R3771 VDD.n1237 VDD.n1236 0.08425
R3772 VDD.n1212 VDD.n1211 0.08425
R3773 VDD.n1222 VDD.n1221 0.08425
R3774 VDD.n1395 VDD.n1371 0.08425
R3775 VDD.n1403 VDD.n1402 0.08425
R3776 VDD.n1449 VDD.n1448 0.08425
R3777 VDD.n1438 VDD.n1437 0.08425
R3778 VDD.n1414 VDD.n1413 0.08425
R3779 VDD.n1424 VDD.n1423 0.08425
R3780 VDD.n1584 VDD.n1560 0.08425
R3781 VDD.n1592 VDD.n1591 0.08425
R3782 VDD.n1637 VDD.n1636 0.08425
R3783 VDD.n1626 VDD.n1625 0.08425
R3784 VDD.n1602 VDD.n1601 0.08425
R3785 VDD.n1612 VDD.n1611 0.08425
R3786 VDD.n1102 VDD.n1078 0.08425
R3787 VDD.n1111 VDD.n1110 0.08425
R3788 VDD.n1156 VDD.n1155 0.08425
R3789 VDD.n1145 VDD.n1144 0.08425
R3790 VDD.n1121 VDD.n1120 0.08425
R3791 VDD.n1131 VDD.n1130 0.08425
R3792 VDD.n960 VDD.n959 0.08425
R3793 VDD.n938 VDD.n937 0.08425
R3794 VDD.n1257 VDD.n1256 0.0821176
R3795 VDD.n1200 VDD.n1199 0.0821176
R3796 VDD.n1253 VDD.n1252 0.0821176
R3797 VDD.n1210 VDD.n1209 0.0821176
R3798 VDD.n1231 VDD.n1230 0.0821176
R3799 VDD.n1220 VDD.n1219 0.0821176
R3800 VDD.n1457 VDD.n1456 0.0821176
R3801 VDD.n1401 VDD.n1400 0.0821176
R3802 VDD.n1412 VDD.n1411 0.0821176
R3803 VDD.n1433 VDD.n1432 0.0821176
R3804 VDD.n1422 VDD.n1421 0.0821176
R3805 VDD.n1647 VDD.n1646 0.0821176
R3806 VDD.n1590 VDD.n1589 0.0821176
R3807 VDD.n1642 VDD.n1641 0.0821176
R3808 VDD.n1600 VDD.n1599 0.0821176
R3809 VDD.n1621 VDD.n1620 0.0821176
R3810 VDD.n1610 VDD.n1609 0.0821176
R3811 VDD.n1109 VDD.n1108 0.0821176
R3812 VDD.n1161 VDD.n1160 0.0821176
R3813 VDD.n1119 VDD.n1118 0.0821176
R3814 VDD.n1139 VDD.n1138 0.0821176
R3815 VDD.n1129 VDD.n1128 0.0821176
R3816 VDD.n972 VDD.n971 0.0821176
R3817 VDD.n965 VDD.n964 0.0821176
R3818 VDD.n932 VDD.n931 0.0821176
R3819 VDD.n946 VDD.n945 0.0821176
R3820 VDD.n1184 VDD.n1176 0.0796176
R3821 VDD.n1385 VDD.n1377 0.0796176
R3822 VDD.n1574 VDD.n1566 0.0796176
R3823 VDD.n1092 VDD.n1084 0.0796176
R3824 VDD.n916 VDD.n908 0.0796176
R3825 VDD.n1190 VDD.n1188 0.0771176
R3826 VDD.n583 VDD.n125 0.309837
R3827 VDD.n553 VDD.n1363 0.410004
R3828 VDD.n597 VDD.n1319 0.310452
R3829 VDD.n574 VDD.n1351 0.309903
R3830 VDD.n596 VDD.n1348 0.309692
R3831 VDD.n1291 VDD.n1290 0.0771176
R3832 VDD.n1391 VDD.n1389 0.0771176
R3833 VDD.n529 VDD.n174 0.595208
R3834 VDD.n1479 VDD.n599 0.310071
R3835 VDD.n527 VDD.n311 0.447271
R3836 VDD.n524 VDD.n522 0.309692
R3837 VDD.n556 VDD.n1475 0.410004
R3838 VDD.n1484 VDD.n587 0.309692
R3839 VDD.n595 VDD.n1474 0.31015
R3840 VDD.n520 VDD.n518 0.309837
R3841 VDD.n514 VDD.n512 0.410004
R3842 VDD.n1487 VDD.n558 0.409438
R3843 VDD.n198 VDD.n1472 0.633189
R3844 VDD.n1496 VDD.n1495 0.0771176
R3845 VDD.n1580 VDD.n1578 0.0771176
R3846 VDD.n194 VDD.n509 0.49614
R3847 VDD.n559 VDD.n507 0.40959
R3848 VDD.n317 VDD.n316 0.521931
R3849 VDD.n560 VDD.n504 0.410004
R3850 VDD.n575 VDD.n1735 0.310071
R3851 VDD.n590 VDD.n1698 0.309837
R3852 VDD.n223 VDD.n222 0.59508
R3853 VDD.n561 VDD.n501 0.410004
R3854 VDD.n271 VDD.n1731 0.633203
R3855 VDD.n562 VDD.n497 0.410004
R3856 VDD.n261 VDD.n1716 0.505134
R3857 VDD.n322 VDD.n448 0.501931
R3858 VDD.n579 VDD.n495 0.309837
R3859 VDD.n1680 VDD.n1679 0.0771176
R3860 VDD.n1098 VDD.n1096 0.0771176
R3861 VDD.n281 VDD.n490 0.309692
R3862 VDD.n488 VDD.n284 0.632966
R3863 VDD.n996 VDD.n565 0.40959
R3864 VDD.n610 VDD.n995 0.31015
R3865 VDD.n285 VDD.n329 0.44701
R3866 VDD.n1002 VDD.n593 0.310452
R3867 VDD.n467 VDD.n484 0.309692
R3868 VDD.n598 VDD.n989 0.310071
R3869 VDD.n1012 VDD.n600 0.309837
R3870 VDD.n1014 VDD.n1013 0.0771176
R3871 VDD.n922 VDD.n920 0.0771176
R3872 VDD.n696 VDD.n694 0.0771176
R3873 VDD.n866 VDD.n865 0.0771176
R3874 VDD.n805 VDD.n804 0.0771176
R3875 VDD.n738 VDD.n737 0.0771176
R3876 VDD.n700 VDD.n699 0.0771176
R3877 VDD.n643 VDD.n79 0.0763621
R3878 VDD.n581 VDD.n1320 0.354697
R3879 VDD.n501 VDD.n476 0.440067
R3880 VDD.n215 VDD.n475 0.43994
R3881 VDD.n1343 VDD.n91 0.122118
R3882 VDD.n599 VDD.n1476 0.354771
R3883 VDD.n314 VDD.n313 0.135894
R3884 VDD.n93 VDD.n92 0.122118
R3885 VDD.n261 VDD.n260 0.131043
R3886 VDD.n1726 VDD.n96 0.122118
R3887 VDD.n98 VDD.n97 0.122118
R3888 VDD.n701 VDD.n101 0.122118
R3889 VDD.n635 VDD.n64 0.112835
R3890 VDD.n637 VDD.n79 0.107656
R3891 VDD.n121 VDD.n1366 0.432689
R3892 VDD.n124 VDD.n1365 0.530922
R3893 VDD.n131 VDD.n1364 0.531015
R3894 VDD.n137 VDD.n1358 0.432547
R3895 VDD.n140 VDD.n1357 0.432451
R3896 VDD.n143 VDD.n1356 0.43259
R3897 VDD.n132 VDD.n144 0.229937
R3898 VDD.n603 VDD.n1316 0.117388
R3899 VDD.n606 VDD.n1320 0.117388
R3900 VDD.n617 VDD.n1324 0.117388
R3901 VDD.n588 VDD.n1352 0.117388
R3902 VDD.n150 VDD.n1329 0.432394
R3903 VDD.n155 VDD.n154 0.241335
R3904 VDD.n160 VDD.n1345 0.432451
R3905 VDD.n163 VDD.n1344 0.432689
R3906 VDD.n611 VDD.n166 0.117388
R3907 VDD.n1343 VDD.n1290 0.0696176
R3908 VDD.n1478 VDD.n171 0.390067
R3909 VDD.n619 VDD.n1476 0.117388
R3910 VDD.n1481 VDD.n178 0.432392
R3911 VDD.n521 VDD.n185 0.531102
R3912 VDD.n1482 VDD.n578 0.117388
R3913 VDD.n1483 VDD.n188 0.432689
R3914 VDD.n251 VDD.n605 0.117388
R3915 VDD.n517 VDD.n602 0.117388
R3916 VDD.n1490 VDD.n608 0.117388
R3917 VDD.n594 VDD.n200 0.117388
R3918 VDD.n206 VDD.n233 0.432392
R3919 VDD.n92 VDD.n1496 0.0696176
R3920 VDD.n221 VDD.n1732 0.432451
R3921 VDD.n612 VDD.n1699 0.117388
R3922 VDD.n227 VDD.n226 0.257294
R3923 VDD.n274 VDD.n1712 0.53084
R3924 VDD.n576 VDD.n1728 0.117388
R3925 VDD.n613 VDD.n1727 0.117388
R3926 VDD.n1726 VDD.n1679 0.0696176
R3927 VDD.n489 VDD.n280 0.390067
R3928 VDD.n999 VDD.n604 0.117388
R3929 VDD.n621 VDD.n993 0.117388
R3930 VDD.n483 VDD.n295 0.432394
R3931 VDD.n1004 VDD.n592 0.117388
R3932 VDD.n1005 VDD.n302 0.432451
R3933 VDD.n609 VDD.n991 0.117388
R3934 VDD.n616 VDD.n990 0.117388
R3935 VDD.n1009 VDD.n586 0.117388
R3936 VDD.n1010 VDD.n615 0.117388
R3937 VDD.n1011 VDD.n463 0.432451
R3938 VDD.n97 VDD.n1014 0.0696176
R3939 VDD.n701 VDD.n694 0.0696176
R3940 VDD.n703 VDD.n700 0.0696176
R3941 VDD.n606 VDD.n1319 0.16205
R3942 VDD.n617 VDD.n1323 0.16205
R3943 VDD.n611 VDD.n1340 0.16205
R3944 VDD.n578 VDD.n1475 0.16205
R3945 VDD.n602 VDD.n1473 0.16205
R3946 VDD.n608 VDD.n1472 0.16205
R3947 VDD.n594 VDD.n1471 0.16205
R3948 VDD.n612 VDD.n1698 0.16205
R3949 VDD.n576 VDD.n1716 0.16205
R3950 VDD.n613 VDD.n448 0.16205
R3951 VDD.n604 VDD.n995 0.16205
R3952 VDD.n621 VDD.n994 0.16205
R3953 VDD.n27 VDD.n25 0.30212
R3954 VDD.n1738 VDD.n50 0.203606
R3955 VDD.n1167 VDD.n353 0.678057
R3956 VDD.n401 VDD.n1205 0.677976
R3957 VDD.n1233 VDD.n398 0.677976
R3958 VDD.n395 VDD.n1215 0.677976
R3959 VDD.n1227 VDD.n392 0.677976
R3960 VDD.n1368 VDD.n550 0.0596176
R3961 VDD.n1407 VDD.n1406 0.0596176
R3962 VDD.n1434 VDD.n387 0.677976
R3963 VDD.n384 VDD.n1417 0.677976
R3964 VDD.n1429 VDD.n381 0.677976
R3965 VDD.n1557 VDD.n350 0.678057
R3966 VDD.n376 VDD.n1595 0.677976
R3967 VDD.n1622 VDD.n373 0.677976
R3968 VDD.n370 VDD.n1605 0.677976
R3969 VDD.n1617 VDD.n367 0.677976
R3970 VDD.n1075 VDD.n545 0.0596176
R3971 VDD.n364 VDD.n1114 0.677976
R3972 VDD.n1141 VDD.n361 0.677976
R3973 VDD.n358 VDD.n1124 0.677976
R3974 VDD.n234 VDD.n233 0.675543
R3975 VDD.n257 VDD.n256 0.670927
R3976 VDD.n191 VDD.n189 0.67081
R3977 VDD.n311 VDD.n254 0.670567
R3978 VDD.n1478 VDD.n173 0.664347
R3979 VDD.n1353 VDD.n146 0.664347
R3980 VDD.n1699 VDD.n225 0.664347
R3981 VDD.n1346 VDD.n153 0.664347
R3982 VDD.n201 VDD.n200 0.664346
R3983 VDD.n215 VDD.n214 0.66432
R3984 VDD.n258 VDD.n259 0.228064
R3985 VDD.n305 VDD.n303 0.659907
R3986 VDD.n297 VDD.n296 0.659748
R3987 VDD.n167 VDD.n166 0.653748
R3988 VDD.n320 VDD.n229 0.634154
R3989 VDD.n250 VDD.n249 0.628162
R3990 VDD.n247 VDD.n246 0.628162
R3991 VDD.n244 VDD.n243 0.628162
R3992 VDD.n241 VDD.n240 0.628162
R3993 VDD.n238 VDD.n237 0.628162
R3994 VDD.n616 VDD.n308 0.571211
R3995 VDD.n209 VDD.n1686 0.531023
R3996 VDD.n218 VDD.n1692 0.530922
R3997 VDD.n260 VDD.n276 0.56322
R3998 VDD.n266 VDD.n258 0.562737
R3999 VDD.n264 VDD.n299 0.562557
R4000 VDD.n262 VDD.n291 0.562557
R4001 VDD.n1458 VDD.n168 0.542229
R4002 VDD.n976 VDD.n277 0.540806
R4003 VDD.n62 VDD.n193 0.523791
R4004 VDD.n1272 VDD.n46 0.519543
R4005 VDD.n44 VDD.n43 0.519543
R4006 VDD.n1661 VDD.n41 0.519543
R4007 VDD.n39 VDD.n38 0.519543
R4008 VDD.n676 VDD.n36 0.518511
R4009 VDD.n70 VDD.n60 0.505136
R4010 VDD.n71 VDD.n58 0.505136
R4011 VDD.n72 VDD.n56 0.505136
R4012 VDD.n73 VDD.n54 0.505136
R4013 VDD.n74 VDD.n52 0.505136
R4014 VDD.n104 VDD.n103 0.503823
R4015 VDD.n116 VDD.n115 0.503691
R4016 VDD.n1546 VDD.n113 0.503691
R4017 VDD.n110 VDD.n109 0.503691
R4018 VDD.n1064 VDD.n107 0.503691
R4019 VDD.n151 VDD.n157 0.489077
R4020 VDD.n1739 VDD.n63 0.2096
R4021 VDD.n69 VDD.n67 0.45092
R4022 VDD.n134 VDD.n132 0.448031
R4023 VDD.n212 VDD.n214 0.432336
R4024 VDD.n65 VDD.n64 0.426234
R4025 VDD.n78 VDD.n76 0.41018
R4026 VDD.n28 VDD.n1367 0.594727
R4027 VDD VDD.n34 0.360404
R4028 VDD.n1779 VDD.n34 0.351319
R4029 VDD.t595 VDD.t365 15.0463
R4030 VDD.t606 VDD.n11 15.0485
R4031 VDD.n17 VDD.t638 15.0485
R4032 VDD.t649 VDD.n31 15.0463
R4033 VDD.t660 VDD.n15 15.0485
R4034 VDD.n7 VDD.n6 1.2027
R4035 VDD.n925 VDD.n4 1.2027
R4036 VDD.n951 VDD.n3 1.2027
R4037 VDD.n928 VDD.n0 1.2027
R4038 VDD.n277 VDD.n12 0.0618955
R4039 VDD.n21 VDD.n13 0.287696
R4040 VDD.n62 VDD.n17 1.03163
R4041 VDD.n27 VDD.n16 0.191215
R4042 VDD.n20 VDD.t36 1.02979
R4043 VSS.n1801 VSS.n1800 22369.4
R4044 VSS.n2343 VSS.n2342 8296.08
R4045 VSS.n2837 VSS.n852 8239.29
R4046 VSS.n3209 VSS.n3208 8239.29
R4047 VSS.n569 VSS.n292 7963.82
R4048 VSS.n2004 VSS.n2003 6494.85
R4049 VSS.n684 VSS.n683 3524.8
R4050 VSS.n2972 VSS.n2971 3461.11
R4051 VSS.n2581 VSS.n2580 3456.87
R4052 VSS.n2581 VSS.n962 2770.39
R4053 VSS.n2972 VSS.n684 2315.59
R4054 VSS.n3218 VSS.n684 891.294
R4055 VSS.n2973 VSS.n2972 891.294
R4056 VSS.n2582 VSS.n2581 891.294
R4057 VSS.t1807 VSS.n1612 849.322
R4058 VSS.t959 VSS.t956 571.348
R4059 VSS.n2293 VSS.n2283 560.237
R4060 VSS.n2277 VSS.n2267 560.237
R4061 VSS.n2261 VSS.n2239 560.237
R4062 VSS.n2234 VSS.n2224 560.237
R4063 VSS.n2218 VSS.n2209 560.237
R4064 VSS.n2338 VSS.n2337 560.236
R4065 VSS.n2299 VSS.n2101 544.269
R4066 VSS.n2288 VSS.n2287 544.269
R4067 VSS.n2272 VSS.n2271 544.269
R4068 VSS.n2250 VSS.n2249 544.269
R4069 VSS.n2229 VSS.n2228 544.269
R4070 VSS.n2213 VSS.n2212 544.269
R4071 VSS.n2296 VSS.n2295 544.25
R4072 VSS.n2280 VSS.n2279 544.25
R4073 VSS.n2264 VSS.n2263 544.25
R4074 VSS.n2237 VSS.n2236 544.25
R4075 VSS.n2221 VSS.n2220 544.25
R4076 VSS.n2335 VSS.n2334 544.25
R4077 VSS.n2298 VSS.n2296 544.249
R4078 VSS.n2285 VSS.n2280 544.249
R4079 VSS.n2269 VSS.n2264 544.249
R4080 VSS.n2247 VSS.n2237 544.249
R4081 VSS.n2226 VSS.n2221 544.249
R4082 VSS.n2334 VSS.n2205 544.249
R4083 VSS.n1623 VSS.t855 539.653
R4084 VSS.n2256 VSS.t2208 537.304
R4085 VSS.t174 VSS.n818 537.304
R4086 VSS.t970 VSS.n730 537.304
R4087 VSS.n1626 VSS.t36 522.508
R4088 VSS.n817 VSS.t472 520.833
R4089 VSS.n2244 VSS.t1339 520.833
R4090 VSS.n729 VSS.t485 520.833
R4091 VSS.t1915 VSS.n2245 502.603
R4092 VSS.t42 VSS.n819 502.603
R4093 VSS.t507 VSS.n731 502.603
R4094 VSS.n2339 VSS.t639 495.639
R4095 VSS.n849 VSS.t727 495.639
R4096 VSS.n760 VSS.t771 495.639
R4097 VSS.n795 VSS.t691 495.637
R4098 VSS.n804 VSS.t699 495.637
R4099 VSS.n813 VSS.t706 495.637
R4100 VSS.n832 VSS.t713 495.637
R4101 VSS.n840 VSS.t719 495.637
R4102 VSS.n2290 VSS.t580 495.637
R4103 VSS.n2274 VSS.t592 495.637
R4104 VSS.n2258 VSS.t603 495.637
R4105 VSS.n2231 VSS.t615 495.637
R4106 VSS.n2215 VSS.t627 495.637
R4107 VSS.n980 VSS.t647 495.637
R4108 VSS.n707 VSS.t734 495.637
R4109 VSS.n716 VSS.t742 495.637
R4110 VSS.n725 VSS.t749 495.637
R4111 VSS.n743 VSS.t755 495.637
R4112 VSS.n751 VSS.t763 495.637
R4113 VSS.n1624 VSS.t38 491.87
R4114 VSS.t1147 VSS.n783 486.111
R4115 VSS.n2105 VSS.t278 486.111
R4116 VSS.t1619 VSS.n695 486.111
R4117 VSS.t689 VSS.n792 481.767
R4118 VSS.t697 VSS.n800 481.767
R4119 VSS.t704 VSS.n810 481.767
R4120 VSS.t711 VSS.n829 481.767
R4121 VSS.t717 VSS.n837 481.767
R4122 VSS.t724 VSS.n845 481.767
R4123 VSS.t645 VSS.n977 481.767
R4124 VSS.t732 VSS.n704 481.767
R4125 VSS.t740 VSS.n712 481.767
R4126 VSS.t747 VSS.n722 481.767
R4127 VSS.t753 VSS.n740 481.767
R4128 VSS.t761 VSS.n748 481.767
R4129 VSS.t768 VSS.n756 481.767
R4130 VSS.t173 VSS.n817 479.168
R4131 VSS.t2207 VSS.n2244 479.168
R4132 VSS.t969 VSS.n729 479.168
R4133 VSS.t2137 VSS.n1621 470.019
R4134 VSS.n643 VSS.n524 469.784
R4135 VSS.n629 VSS.n533 469.784
R4136 VSS.n607 VSS.n541 469.784
R4137 VSS.n594 VSS.n550 469.784
R4138 VSS.n581 VSS.n559 469.784
R4139 VSS.n572 VSS.n568 469.783
R4140 VSS.n2295 VSS.t576 465.279
R4141 VSS.n2279 VSS.t588 465.279
R4142 VSS.n2263 VSS.t599 465.279
R4143 VSS.n2236 VSS.t611 465.279
R4144 VSS.n2220 VSS.t623 465.279
R4145 VSS.n2335 VSS.t634 465.279
R4146 VSS.n662 VSS.n661 454.012
R4147 VSS.n648 VSS.n647 454.012
R4148 VSS.n634 VSS.n633 454.012
R4149 VSS.n620 VSS.n619 454.012
R4150 VSS.n599 VSS.n598 454.012
R4151 VSS.n586 VSS.n585 454.012
R4152 VSS.n673 VSS.t1646 453.986
R4153 VSS.n652 VSS.n651 453.986
R4154 VSS.n638 VSS.n637 453.986
R4155 VSS.n625 VSS.n624 453.986
R4156 VSS.n603 VSS.n602 453.986
R4157 VSS.n590 VSS.n589 453.986
R4158 VSS.n576 VSS.n575 453.986
R4159 VSS.n651 VSS.n519 453.986
R4160 VSS.n637 VSS.n528 453.986
R4161 VSS.n624 VSS.n537 453.986
R4162 VSS.n602 VSS.n545 453.986
R4163 VSS.n589 VSS.n554 453.986
R4164 VSS.n575 VSS.n563 453.986
R4165 VSS.t1550 VSS.n613 448.228
R4166 VSS.t899 VSS.n973 446.527
R4167 VSS.t1367 VSS.n669 442.469
R4168 VSS.n612 VSS.t517 431.863
R4169 VSS.t320 VSS.n614 419.464
R4170 VSS.t840 VSS.n571 413.68
R4171 VSS.n644 VSS.t782 413.678
R4172 VSS.n630 VSS.t793 413.678
R4173 VSS.n608 VSS.t805 413.678
R4174 VSS.n595 VSS.t817 413.678
R4175 VSS.n582 VSS.t828 413.678
R4176 VSS.n1968 VSS.n1967 412.522
R4177 VSS.n668 VSS.t1647 403.072
R4178 VSS.t1234 VSS.n1624 401.591
R4179 VSS.n2290 VSS.t582 398.416
R4180 VSS.n2274 VSS.t594 398.416
R4181 VSS.n2258 VSS.t605 398.416
R4182 VSS.n2231 VSS.t617 398.416
R4183 VSS.n2215 VSS.t629 398.416
R4184 VSS.t692 VSS.n795 398.416
R4185 VSS.t700 VSS.n804 398.416
R4186 VSS.t707 VSS.n813 398.416
R4187 VSS.t714 VSS.n832 398.416
R4188 VSS.t720 VSS.n840 398.416
R4189 VSS.t648 VSS.n980 398.416
R4190 VSS.t735 VSS.n707 398.416
R4191 VSS.t743 VSS.n716 398.416
R4192 VSS.t750 VSS.n725 398.416
R4193 VSS.t756 VSS.n743 398.416
R4194 VSS.t764 VSS.n751 398.416
R4195 VSS.t728 VSS.n849 398.414
R4196 VSS.t641 VSS.n2339 398.414
R4197 VSS.t772 VSS.n760 398.414
R4198 VSS.t1549 VSS.n612 397.313
R4199 VSS.t561 VSS.n674 391.555
R4200 VSS.n785 VSS.t190 388.889
R4201 VSS.n821 VSS.t114 388.889
R4202 VSS.t2337 VSS.n2096 388.889
R4203 VSS.t1340 VSS.n2246 388.889
R4204 VSS.n697 VSS.t2357 388.889
R4205 VSS.n733 VSS.t1416 388.889
R4206 VSS.t1807 VSS.n1969 388.781
R4207 VSS.n652 VSS.t778 385.798
R4208 VSS.n638 VSS.t789 385.798
R4209 VSS.n625 VSS.t801 385.798
R4210 VSS.n603 VSS.t813 385.798
R4211 VSS.n590 VSS.t824 385.798
R4212 VSS.n576 VSS.t835 385.798
R4213 VSS.n681 VSS.t433 384.889
R4214 VSS.n792 VSS.t688 384.541
R4215 VSS.n800 VSS.t695 384.541
R4216 VSS.n810 VSS.t703 384.541
R4217 VSS.n829 VSS.t710 384.541
R4218 VSS.n837 VSS.t716 384.541
R4219 VSS.n845 VSS.t723 384.541
R4220 VSS.n977 VSS.t644 384.541
R4221 VSS.n704 VSS.t731 384.541
R4222 VSS.n712 VSS.t738 384.541
R4223 VSS.n722 VSS.t746 384.541
R4224 VSS.n740 VSS.t752 384.541
R4225 VSS.n748 VSS.t759 384.541
R4226 VSS.n756 VSS.t767 384.541
R4227 VSS.n678 VSS.t1354 380.038
R4228 VSS.t686 VSS.n789 370.659
R4229 VSS.t693 VSS.n798 370.659
R4230 VSS.t701 VSS.n807 370.659
R4231 VSS.t708 VSS.n824 370.659
R4232 VSS.t715 VSS.n835 370.659
R4233 VSS.t721 VSS.n843 370.659
R4234 VSS.t642 VSS.n974 370.659
R4235 VSS.t729 VSS.n701 370.659
R4236 VSS.t736 VSS.n710 370.659
R4237 VSS.t744 VSS.n719 370.659
R4238 VSS.t751 VSS.n738 370.659
R4239 VSS.t757 VSS.n746 370.659
R4240 VSS.t765 VSS.n754 370.659
R4241 VSS.n2298 VSS.t574 368.057
R4242 VSS.t586 VSS.n2285 368.057
R4243 VSS.t597 VSS.n2269 368.057
R4244 VSS.t609 VSS.n2247 368.057
R4245 VSS.t621 VSS.n2226 368.057
R4246 VSS.t632 VSS.n2205 368.057
R4247 VSS.t1185 VSS.t1806 359.769
R4248 VSS.t2288 VSS.n679 357.007
R4249 VSS.n2299 VSS.t572 354.168
R4250 VSS.n2287 VSS.t583 354.168
R4251 VSS.n2271 VSS.t595 354.168
R4252 VSS.n2249 VSS.t606 354.168
R4253 VSS.n2228 VSS.t618 354.168
R4254 VSS.n2212 VSS.t630 354.168
R4255 VSS.n2341 VSS.t2381 349.805
R4256 VSS.n851 VSS.t1433 349.805
R4257 VSS.n762 VSS.t1255 349.805
R4258 VSS.n788 VSS.t1360 349.803
R4259 VSS.n797 VSS.t1505 349.803
R4260 VSS.n806 VSS.t1840 349.803
R4261 VSS.n815 VSS.t1882 349.803
R4262 VSS.n823 VSS.t1844 349.803
R4263 VSS.n834 VSS.t1507 349.803
R4264 VSS.n842 VSS.t394 349.803
R4265 VSS.n2099 VSS.t250 349.803
R4266 VSS.n2289 VSS.t1055 349.803
R4267 VSS.n2273 VSS.t554 349.803
R4268 VSS.n2257 VSS.t271 349.803
R4269 VSS.t436 VSS.n2252 349.803
R4270 VSS.n2230 VSS.t1057 349.803
R4271 VSS.n2214 VSS.t118 349.803
R4272 VSS.n982 VSS.t2262 349.803
R4273 VSS.n700 VSS.t986 349.803
R4274 VSS.n709 VSS.t1267 349.803
R4275 VSS.n718 VSS.t1187 349.803
R4276 VSS.n727 VSS.t973 349.803
R4277 VSS.n735 VSS.t98 349.803
R4278 VSS.n745 VSS.t1269 349.803
R4279 VSS.n753 VSS.t1271 349.803
R4280 VSS.n676 VSS.t2289 333.974
R4281 VSS.t784 VSS.n644 333.065
R4282 VSS.t795 VSS.n630 333.065
R4283 VSS.t807 VSS.n608 333.065
R4284 VSS.t819 VSS.n595 333.065
R4285 VSS.t830 VSS.n582 333.065
R4286 VSS.t1644 VSS.n681 333.063
R4287 VSS.n571 VSS.t842 333.063
R4288 VSS.n2102 VSS.t1607 328.99
R4289 VSS.t1775 VSS.n786 328.99
R4290 VSS.t1513 VSS.n698 328.99
R4291 VSS.t956 VSS.n1704 327.81
R4292 VSS.t2291 VSS.n666 322.457
R4293 VSS.n616 VSS.t2275 322.457
R4294 VSS.t192 VSS.n785 319.445
R4295 VSS.t115 VSS.n821 319.445
R4296 VSS.t2338 VSS.n2096 319.445
R4297 VSS.t1342 VSS.n2246 319.445
R4298 VSS.t2358 VSS.n697 319.445
R4299 VSS.t1417 VSS.n733 319.445
R4300 VSS.n1948 VSS.t899 314.327
R4301 VSS.n1627 VSS.t35 313.659
R4302 VSS.n2342 VSS.t2382 308.159
R4303 VSS.n789 VSS.t1361 308.152
R4304 VSS.n798 VSS.t1506 308.152
R4305 VSS.n807 VSS.t1841 308.152
R4306 VSS.n816 VSS.t1883 308.152
R4307 VSS.n824 VSS.t1845 308.152
R4308 VSS.n835 VSS.t1508 308.152
R4309 VSS.n843 VSS.t395 308.152
R4310 VSS.n852 VSS.t1434 308.152
R4311 VSS.n2101 VSS.t251 308.152
R4312 VSS.t1056 VSS.n2288 308.152
R4313 VSS.t555 VSS.n2272 308.152
R4314 VSS.t272 VSS.n2243 308.152
R4315 VSS.t437 VSS.n2250 308.152
R4316 VSS.t1058 VSS.n2229 308.152
R4317 VSS.t119 VSS.n2213 308.152
R4318 VSS.n974 VSS.t1650 308.152
R4319 VSS.n983 VSS.t2263 308.152
R4320 VSS.n701 VSS.t987 308.152
R4321 VSS.n710 VSS.t1268 308.152
R4322 VSS.n719 VSS.t1188 308.152
R4323 VSS.n728 VSS.t974 308.152
R4324 VSS.n738 VSS.t99 308.152
R4325 VSS.n746 VSS.t1270 308.152
R4326 VSS.n754 VSS.t1272 308.152
R4327 VSS.n3209 VSS.t1256 308.152
R4328 VSS.n519 VSS.t776 305.183
R4329 VSS.n528 VSS.t787 305.183
R4330 VSS.n537 VSS.t799 305.183
R4331 VSS.n545 VSS.t811 305.183
R4332 VSS.n554 VSS.t822 305.183
R4333 VSS.n563 VSS.t833 305.183
R4334 VSS.t854 VSS.n1626 299.735
R4335 VSS.n671 VSS.t1366 299.425
R4336 VSS.n661 VSS.t773 293.666
R4337 VSS.n648 VSS.t785 293.666
R4338 VSS.n634 VSS.t796 293.666
R4339 VSS.n620 VSS.t808 293.666
R4340 VSS.n599 VSS.t820 293.666
R4341 VSS.n586 VSS.t831 293.666
R4342 VSS.n573 VSS.t411 292.757
R4343 VSS.t1243 VSS.n663 292.757
R4344 VSS.n646 VSS.t416 292.757
R4345 VSS.n632 VSS.t1544 292.757
R4346 VSS.n610 VSS.t1546 292.757
R4347 VSS.n618 VSS.t1245 292.757
R4348 VSS.n597 VSS.t419 292.757
R4349 VSS.n584 VSS.t422 292.757
R4350 VSS.t434 VSS.n671 287.909
R4351 VSS.n2294 VSS.t578 287.32
R4352 VSS.n2278 VSS.t590 287.32
R4353 VSS.n2262 VSS.t601 287.32
R4354 VSS.n2235 VSS.t613 287.32
R4355 VSS.n2219 VSS.t625 287.32
R4356 VSS.n2201 VSS.t637 287.32
R4357 VSS.t690 VSS.n793 287.32
R4358 VSS.t698 VSS.n802 287.32
R4359 VSS.t705 VSS.n811 287.32
R4360 VSS.t712 VSS.n830 287.32
R4361 VSS.t718 VSS.n838 287.32
R4362 VSS.t726 VSS.n846 287.32
R4363 VSS.t646 VSS.n978 287.32
R4364 VSS.t733 VSS.n705 287.32
R4365 VSS.t741 VSS.n714 287.32
R4366 VSS.t748 VSS.n723 287.32
R4367 VSS.t754 VSS.n741 287.32
R4368 VSS.t762 VSS.n749 287.32
R4369 VSS.t770 VSS.n757 287.32
R4370 VSS.n2977 VSS.t172 277.779
R4371 VSS.t1641 VSS.n2104 277.779
R4372 VSS.t1598 VSS.n694 277.779
R4373 VSS.n665 VSS.t40 275.507
R4374 VSS.n848 VSS.t726 273.432
R4375 VSS.n759 VSS.t770 273.432
R4376 VSS.n2337 VSS.t637 273.432
R4377 VSS.n794 VSS.t690 273.43
R4378 VSS.n803 VSS.t698 273.43
R4379 VSS.n812 VSS.t705 273.43
R4380 VSS.n831 VSS.t712 273.43
R4381 VSS.n839 VSS.t718 273.43
R4382 VSS.n979 VSS.t646 273.43
R4383 VSS.n706 VSS.t733 273.43
R4384 VSS.n715 VSS.t741 273.43
R4385 VSS.n724 VSS.t748 273.43
R4386 VSS.n742 VSS.t754 273.43
R4387 VSS.n750 VSS.t762 273.43
R4388 VSS.t578 VSS.n2293 273.43
R4389 VSS.t590 VSS.n2277 273.43
R4390 VSS.t601 VSS.n2261 273.43
R4391 VSS.t613 VSS.n2234 273.43
R4392 VSS.t625 VSS.n2218 273.43
R4393 VSS.n669 VSS.t1662 269.726
R4394 VSS.n666 VSS.t2292 264.875
R4395 VSS.t2276 VSS.n616 264.875
R4396 VSS.n1581 VSS.n1003 258.741
R4397 VSS.t412 VSS.n569 258.238
R4398 VSS.t1244 VSS.n662 258.231
R4399 VSS.n647 VSS.t417 258.231
R4400 VSS.n633 VSS.t1545 258.231
R4401 VSS.n611 VSS.t1547 258.231
R4402 VSS.n619 VSS.t1246 258.231
R4403 VSS.n598 VSS.t420 258.231
R4404 VSS.n585 VSS.t423 258.231
R4405 VSS.t562 VSS.n673 258.207
R4406 VSS.n1554 VSS.n1018 258.14
R4407 VSS.n1552 VSS.n1023 258.14
R4408 VSS.n1600 VSS.n1038 258.14
R4409 VSS.t1661 VSS.n676 253.359
R4410 VSS.t251 VSS.n2099 252.583
R4411 VSS.n2289 VSS.t1056 252.583
R4412 VSS.n2273 VSS.t555 252.583
R4413 VSS.n2257 VSS.t272 252.583
R4414 VSS.n2252 VSS.t437 252.583
R4415 VSS.n2230 VSS.t1058 252.583
R4416 VSS.n2214 VSS.t119 252.583
R4417 VSS.t1361 VSS.n788 252.583
R4418 VSS.t1506 VSS.n797 252.583
R4419 VSS.t1841 VSS.n806 252.583
R4420 VSS.t1883 VSS.n815 252.583
R4421 VSS.t1845 VSS.n823 252.583
R4422 VSS.t1508 VSS.n834 252.583
R4423 VSS.t395 VSS.n842 252.583
R4424 VSS.t2263 VSS.n982 252.583
R4425 VSS.t987 VSS.n700 252.583
R4426 VSS.t1268 VSS.n709 252.583
R4427 VSS.t1188 VSS.n718 252.583
R4428 VSS.t974 VSS.n727 252.583
R4429 VSS.t99 VSS.n735 252.583
R4430 VSS.t1270 VSS.n745 252.583
R4431 VSS.t1272 VSS.n753 252.583
R4432 VSS.t1434 VSS.n851 252.582
R4433 VSS.t2382 VSS.n2341 252.582
R4434 VSS.t1256 VSS.n762 252.582
R4435 VSS.t2350 VSS.n3197 252.375
R4436 VSS.t1842 VSS.n3127 252.375
R4437 VSS.t1512 VSS.n2981 252.375
R4438 VSS.t1603 VSS.n2987 252.375
R4439 VSS.t1160 VSS.n3001 252.375
R4440 VSS.t317 VSS.n3015 252.375
R4441 VSS.t1020 VSS.n3029 252.375
R4442 VSS.t211 VSS.n3043 252.375
R4443 VSS.t1115 VSS.n3057 252.375
R4444 VSS.t10 VSS.n3071 252.375
R4445 VSS.t1030 VSS.n3085 252.375
R4446 VSS.t968 VSS.n3099 252.375
R4447 VSS.t1261 VSS.n3113 252.375
R4448 VSS.t1467 VSS.n3155 252.375
R4449 VSS.t981 VSS.n3169 252.375
R4450 VSS.t2141 VSS.n3183 252.375
R4451 VSS.n163 VSS.t159 252.375
R4452 VSS.n161 VSS.t1543 252.375
R4453 VSS.n160 VSS.t1935 252.375
R4454 VSS.n157 VSS.t1929 252.375
R4455 VSS.n153 VSS.t224 252.375
R4456 VSS.n152 VSS.t1489 252.375
R4457 VSS.n149 VSS.t1495 252.375
R4458 VSS.n145 VSS.t481 252.375
R4459 VSS.n144 VSS.t484 252.375
R4460 VSS.n141 VSS.t1224 252.375
R4461 VSS.n138 VSS.t226 252.375
R4462 VSS.n137 VSS.t1423 252.375
R4463 VSS.n134 VSS.t2326 252.375
R4464 VSS.t1954 VSS.n102 252.375
R4465 VSS.n130 VSS.t2330 252.375
R4466 VSS.n127 VSS.t1886 252.375
R4467 VSS.t381 VSS.n108 252.375
R4468 VSS.n2547 VSS.t1606 252.375
R4469 VSS.t1383 VSS.n2117 252.375
R4470 VSS.n2518 VSS.t1829 252.375
R4471 VSS.n2505 VSS.t57 252.375
R4472 VSS.t1263 VSS.n2129 252.375
R4473 VSS.t221 VSS.n2132 252.375
R4474 VSS.n2454 VSS.t1991 252.375
R4475 VSS.t1207 VSS.n2137 252.375
R4476 VSS.n2417 VSS.t1062 252.375
R4477 VSS.t2229 VSS.n2144 252.375
R4478 VSS.t2230 VSS.n2148 252.375
R4479 VSS.t2309 VSS.n2150 252.375
R4480 VSS.t2315 VSS.n2154 252.375
R4481 VSS.t91 VSS.n2157 252.375
R4482 VSS.t39 VSS.n192 252.375
R4483 VSS.t1552 VSS.n196 252.375
R4484 VSS.t229 VSS.n212 252.375
R4485 VSS.t1955 VSS.n221 252.375
R4486 VSS.t1453 VSS.n234 252.375
R4487 VSS.t1284 VSS.n244 252.375
R4488 VSS.t1459 VSS.n252 252.375
R4489 VSS.t238 VSS.n258 252.375
R4490 VSS.t2041 VSS.n264 252.375
R4491 VSS.t2083 VSS.n272 252.375
R4492 VSS.t2101 VSS.n279 252.375
R4493 VSS.t2132 VSS.n284 252.375
R4494 VSS.t1616 VSS.n2714 252.375
R4495 VSS.t1604 VSS.n2738 252.375
R4496 VSS.t870 VSS.n2762 252.375
R4497 VSS.t1811 VSS.n2786 252.375
R4498 VSS.t258 VSS.n2810 252.375
R4499 VSS.t2171 VSS.n3141 252.374
R4500 VSS.n2196 VSS.t306 252.374
R4501 VSS.n2188 VSS.t1472 252.374
R4502 VSS.n2176 VSS.t2149 252.374
R4503 VSS.n480 VSS.t1555 252.374
R4504 VSS.n466 VSS.t2232 252.374
R4505 VSS.n432 VSS.t1970 252.374
R4506 VSS.n408 VSS.t1978 252.374
R4507 VSS.n344 VSS.t2037 252.374
R4508 VSS.n2964 VSS.t1779 252.374
R4509 VSS.t2220 VSS.n880 252.374
R4510 VSS.n2946 VSS.t210 252.374
R4511 VSS.t849 VSS.n887 252.374
R4512 VSS.t1153 VSS.n894 252.374
R4513 VSS.t1163 VSS.n897 252.374
R4514 VSS.n2901 VSS.t2164 252.374
R4515 VSS.t2209 VSS.n906 252.374
R4516 VSS.n2877 VSS.t499 252.374
R4517 VSS.t21 VSS.n913 252.374
R4518 VSS.n2852 VSS.t1624 252.374
R4519 VSS.n2844 VSS.t1372 252.374
R4520 VSS.t1322 VSS.n198 252.117
R4521 VSS.n472 VSS.t2323 252.117
R4522 VSS.t1435 VSS.n224 252.117
R4523 VSS.n400 VSS.t234 252.117
R4524 VSS.t2185 VSS.n247 252.117
R4525 VSS.t1458 VSS.n255 252.117
R4526 VSS.n349 VSS.t2051 252.117
R4527 VSS.n335 VSS.t2103 252.117
R4528 VSS.n322 VSS.t2084 252.117
R4529 VSS.t2124 VSS.n282 252.117
R4530 VSS.t2356 VSS.n2995 252.117
R4531 VSS.t1019 VSS.n3023 252.117
R4532 VSS.t1643 VSS.n3037 252.117
R4533 VSS.t1602 VSS.n3065 252.117
R4534 VSS.t847 VSS.n3079 252.117
R4535 VSS.t2063 VSS.n3093 252.117
R4536 VSS.t1802 VSS.n3107 252.117
R4537 VSS.t976 VSS.n3121 252.117
R4538 VSS.t1521 VSS.n3135 252.117
R4539 VSS.t1830 VSS.n3163 252.117
R4540 VSS.t340 VSS.n3177 252.117
R4541 VSS.t1761 VSS.n3191 252.117
R4542 VSS.n159 VSS.t1932 252.117
R4543 VSS.n155 VSS.t1940 252.117
R4544 VSS.n151 VSS.t225 252.117
R4545 VSS.n147 VSS.t2317 252.117
R4546 VSS.n143 VSS.t1223 252.117
R4547 VSS.n139 VSS.t285 252.117
R4548 VSS.n136 VSS.t288 252.117
R4549 VSS.n132 VSS.t2231 252.117
R4550 VSS.t1431 VSS.n104 252.117
R4551 VSS.n129 VSS.t2327 252.117
R4552 VSS.n125 VSS.t1887 252.117
R4553 VSS.t2223 VSS.n2119 252.117
R4554 VSS.n2523 VSS.t2172 252.117
R4555 VSS.t977 VSS.n2124 252.117
R4556 VSS.t1392 VSS.n2128 252.117
R4557 VSS.t2348 VSS.n2134 252.117
R4558 VSS.t1310 VSS.n2141 252.117
R4559 VSS.t289 VSS.n208 252.115
R4560 VSS.t1352 VSS.n215 252.115
R4561 VSS.t1968 VSS.n230 252.115
R4562 VSS.t1504 VSS.n237 252.115
R4563 VSS.t1016 VSS.n260 252.115
R4564 VSS.t1605 VSS.n3009 252.115
R4565 VSS.t2282 VSS.n3051 252.115
R4566 VSS.t1400 VSS.n3149 252.115
R4567 VSS.n111 VSS.t1916 252.115
R4568 VSS.n113 VSS.t1276 252.115
R4569 VSS.n115 VSS.t1820 252.115
R4570 VSS.n117 VSS.t2320 252.115
R4571 VSS.t1843 VSS.n2189 252.115
R4572 VSS.t2303 VSS.n2186 252.115
R4573 VSS.n2180 VSS.t1752 252.115
R4574 VSS.t2174 VSS.n2178 252.115
R4575 VSS.n2171 VSS.t541 252.115
R4576 VSS.n2169 VSS.t2308 252.115
R4577 VSS.t1266 VSS.n2168 252.115
R4578 VSS.t90 VSS.n2167 252.115
R4579 VSS.n2164 VSS.t1529 252.115
R4580 VSS.n2957 VSS.t2286 252.115
R4581 VSS.n2949 VSS.t2277 252.115
R4582 VSS.n2941 VSS.t2158 252.115
R4583 VSS.n2934 VSS.t292 252.115
R4584 VSS.n2926 VSS.t2216 252.115
R4585 VSS.n2920 VSS.t2163 252.115
R4586 VSS.n2912 VSS.t1296 252.115
R4587 VSS.n2904 VSS.t1517 252.115
R4588 VSS.n2897 VSS.t1828 252.115
R4589 VSS.n2888 VSS.t2283 252.115
R4590 VSS.n2880 VSS.t2349 252.115
R4591 VSS.n2873 VSS.t2271 252.115
R4592 VSS.n2865 VSS.t193 252.115
R4593 VSS.n2857 VSS.t2156 252.115
R4594 VSS.n2848 VSS.t1168 252.115
R4595 VSS.t1650 VSS.n973 252.083
R4596 VSS.t1103 VSS.n494 250.837
R4597 VSS.t567 VSS.n490 250.837
R4598 VSS.t367 VSS.n482 250.837
R4599 VSS.t2162 VSS.n478 250.837
R4600 VSS.t1359 VSS.n469 250.837
R4601 VSS.t2375 VSS.n464 250.837
R4602 VSS.t1107 VSS.n456 250.837
R4603 VSS.t1111 VSS.n453 250.837
R4604 VSS.t1330 VSS.n445 250.837
R4605 VSS.t1113 VSS.n442 250.837
R4606 VSS.t1109 VSS.n434 250.837
R4607 VSS.t2248 VSS.n430 250.837
R4608 VSS.t2376 VSS.n422 250.837
R4609 VSS.t1355 VSS.n419 250.837
R4610 VSS.t1358 VSS.n411 250.837
R4611 VSS.t543 VSS.n406 250.837
R4612 VSS.t1104 VSS.n396 250.837
R4613 VSS.t1106 VSS.n393 250.837
R4614 VSS.t2389 VSS.n383 250.837
R4615 VSS.t2258 VSS.n380 250.837
R4616 VSS.t1356 VSS.n371 250.837
R4617 VSS.t463 VSS.n367 250.837
R4618 VSS.t465 VSS.n359 250.837
R4619 VSS.t2374 VSS.n355 250.837
R4620 VSS.t2373 VSS.n346 250.837
R4621 VSS.t466 VSS.n341 250.837
R4622 VSS.t373 VSS.n331 250.837
R4623 VSS.t482 VSS.n328 250.837
R4624 VSS.t2388 VSS.n317 250.837
R4625 VSS.t545 VSS.n314 250.837
R4626 VSS.t384 VSS.n305 250.837
R4627 VSS.t1863 VSS.n300 250.837
R4628 VSS.n2984 VSS.t1205 250.837
R4629 VSS.n2990 VSS.t502 250.837
R4630 VSS.n2998 VSS.t458 250.837
R4631 VSS.n3004 VSS.t1860 250.837
R4632 VSS.n3012 VSS.t2047 250.837
R4633 VSS.n3018 VSS.t1851 250.837
R4634 VSS.n3026 VSS.t1332 250.837
R4635 VSS.n3032 VSS.t386 250.837
R4636 VSS.n3040 VSS.t137 250.837
R4637 VSS.n3046 VSS.t1334 250.837
R4638 VSS.n3054 VSS.t1642 250.837
R4639 VSS.n3060 VSS.t1718 250.837
R4640 VSS.n3068 VSS.t497 250.837
R4641 VSS.n3074 VSS.t1723 250.837
R4642 VSS.n3082 VSS.t1862 250.837
R4643 VSS.n3088 VSS.t1088 250.837
R4644 VSS.n3096 VSS.t1715 250.837
R4645 VSS.n3102 VSS.t1073 250.837
R4646 VSS.n3110 VSS.t511 250.837
R4647 VSS.n3116 VSS.t547 250.837
R4648 VSS.n3124 VSS.t1090 250.837
R4649 VSS.n3130 VSS.t2094 250.837
R4650 VSS.n3138 VSS.t1114 250.837
R4651 VSS.n3144 VSS.t138 250.837
R4652 VSS.n3152 VSS.t559 250.837
R4653 VSS.n3158 VSS.t563 250.837
R4654 VSS.n3166 VSS.t1713 250.837
R4655 VSS.n3172 VSS.t1092 250.837
R4656 VSS.n3180 VSS.t1635 250.837
R4657 VSS.n3186 VSS.t1337 250.837
R4658 VSS.n3194 VSS.t1859 250.837
R4659 VSS.n3200 VSS.t2365 250.837
R4660 VSS.n2963 VSS.t452 250.837
R4661 VSS.n2960 VSS.t375 250.837
R4662 VSS.n2955 VSS.t376 250.837
R4663 VSS.n2952 VSS.t542 250.837
R4664 VSS.n2947 VSS.t1727 250.837
R4665 VSS.n2944 VSS.t1201 250.837
R4666 VSS.n2940 VSS.t1049 250.837
R4667 VSS.n2937 VSS.t1696 250.837
R4668 VSS.n2932 VSS.t1123 250.837
R4669 VSS.n2929 VSS.t1129 250.837
R4670 VSS.n2924 VSS.t2380 250.837
R4671 VSS.n2923 VSS.t108 250.837
R4672 VSS.n2918 VSS.t1097 250.837
R4673 VSS.n2915 VSS.t156 250.837
R4674 VSS.n2910 VSS.t1212 250.837
R4675 VSS.n2907 VSS.t284 250.837
R4676 VSS.n2902 VSS.t441 250.837
R4677 VSS.n2900 VSS.t1861 250.837
R4678 VSS.n2894 VSS.t457 250.837
R4679 VSS.n2891 VSS.t1714 250.837
R4680 VSS.n2886 VSS.t2386 250.837
R4681 VSS.n2883 VSS.t2240 250.837
R4682 VSS.n2878 VSS.t2370 250.837
R4683 VSS.n2876 VSS.t540 250.837
R4684 VSS.n2871 VSS.t2362 250.837
R4685 VSS.n2868 VSS.t2259 250.837
R4686 VSS.n2863 VSS.t143 250.837
R4687 VSS.n2860 VSS.t1865 250.837
R4688 VSS.n2854 VSS.t2071 250.837
R4689 VSS.n2851 VSS.t2390 250.837
R4690 VSS.n2846 VSS.t473 250.837
R4691 VSS.n2842 VSS.t145 250.837
R4692 VSS.n2072 VSS.t1121 250.837
R4693 VSS.n2071 VSS.t1119 250.837
R4694 VSS.n2068 VSS.t1047 250.837
R4695 VSS.n2067 VSS.t1045 250.837
R4696 VSS.n2064 VSS.t1095 250.837
R4697 VSS.n2063 VSS.t1093 250.837
R4698 VSS.n2060 VSS.t1717 250.837
R4699 VSS.n2059 VSS.t1716 250.837
R4700 VSS.n2056 VSS.t1087 250.837
R4701 VSS.n2055 VSS.t1085 250.837
R4702 VSS.n2052 VSS.t1065 250.837
R4703 VSS.n2051 VSS.t1063 250.837
R4704 VSS.n2048 VSS.t2050 250.837
R4705 VSS.n2047 VSS.t2049 250.837
R4706 VSS.n2044 VSS.t1038 250.837
R4707 VSS.n2043 VSS.t1036 250.837
R4708 VSS.n2040 VSS.t1729 250.837
R4709 VSS.n2039 VSS.t1728 250.837
R4710 VSS.n2035 VSS.t2 250.837
R4711 VSS.n2034 VSS.t0 250.837
R4712 VSS.n2031 VSS.t2148 250.837
R4713 VSS.n2030 VSS.t2147 250.837
R4714 VSS.n2027 VSS.t447 250.837
R4715 VSS.n2026 VSS.t442 250.837
R4716 VSS.n2023 VSS.t282 250.837
R4717 VSS.n2022 VSS.t280 250.837
R4718 VSS.n2019 VSS.t468 250.837
R4719 VSS.n2018 VSS.t322 250.837
R4720 VSS.n2014 VSS.t569 250.837
R4721 VSS.n2013 VSS.t1562 250.837
R4722 VSS.n2010 VSS.t2387 250.837
R4723 VSS.n2009 VSS.t1039 250.837
R4724 VSS.t1634 VSS.n2545 250.837
R4725 VSS.t1633 VSS.n2540 250.837
R4726 VSS.t440 VSS.n2533 250.837
R4727 VSS.t439 VSS.n2529 250.837
R4728 VSS.t1210 VSS.n2521 250.837
R4729 VSS.t1208 VSS.n2516 250.837
R4730 VSS.t2385 VSS.n2509 250.837
R4731 VSS.t2384 VSS.n2503 250.837
R4732 VSS.t141 VSS.n2496 250.837
R4733 VSS.t140 VSS.n2489 250.837
R4734 VSS.t2361 VSS.n2481 250.837
R4735 VSS.t2360 VSS.n2476 250.837
R4736 VSS.t2369 VSS.n2468 250.837
R4737 VSS.t2368 VSS.n2464 250.837
R4738 VSS.t2070 VSS.n2457 250.837
R4739 VSS.t2069 VSS.n2452 250.837
R4740 VSS.t455 VSS.n2445 250.837
R4741 VSS.t453 VSS.n2441 250.837
R4742 VSS.t1336 VSS.n2431 250.837
R4743 VSS.t1335 VSS.n2427 250.837
R4744 VSS.t1101 VSS.n2420 250.837
R4745 VSS.t1099 VSS.n2415 250.837
R4746 VSS.t2364 VSS.n2408 250.837
R4747 VSS.t2363 VSS.n2404 250.837
R4748 VSS.t558 VSS.n2397 250.837
R4749 VSS.t557 VSS.n2391 250.837
R4750 VSS.t1145 VSS.n2383 250.837
R4751 VSS.t1143 VSS.n2377 250.837
R4752 VSS.t1726 VSS.n2367 250.837
R4753 VSS.t1724 VSS.n2363 250.837
R4754 VSS.t2379 VSS.n2356 250.837
R4755 VSS.t2377 VSS.n2350 250.837
R4756 VSS.n1610 VSS.n1602 248.252
R4757 VSS.n1583 VSS.n1007 244.186
R4758 VSS.n1550 VSS.n1027 244.186
R4759 VSS.t780 VSS.n523 240.957
R4760 VSS.t791 VSS.n532 240.957
R4761 VSS.t803 VSS.n540 240.957
R4762 VSS.t815 VSS.n549 240.957
R4763 VSS.t826 VSS.n558 240.957
R4764 VSS.t838 VSS.n566 240.957
R4765 VSS.t1660 VSS.n682 240.954
R4766 VSS.t1773 VSS.n1030 240.698
R4767 VSS.n486 VSS.t1281 234.114
R4768 VSS.n474 VSS.t2325 234.114
R4769 VSS.n460 VSS.t1655 234.114
R4770 VSS.n449 VSS.t1964 234.114
R4771 VSS.n438 VSS.t378 234.114
R4772 VSS.n426 VSS.t1500 234.114
R4773 VSS.n415 VSS.t1452 234.114
R4774 VSS.n402 VSS.t1457 234.114
R4775 VSS.n389 VSS.t1982 234.114
R4776 VSS.n376 VSS.t103 234.114
R4777 VSS.n363 VSS.t1286 234.114
R4778 VSS.n351 VSS.t2061 234.114
R4779 VSS.n337 VSS.t2043 234.114
R4780 VSS.n324 VSS.t2339 234.114
R4781 VSS.n310 VSS.t2099 234.114
R4782 VSS.n296 VSS.t1161 234.114
R4783 VSS.t2155 VSS.n2993 234.114
R4784 VSS.t414 VSS.n3007 234.114
R4785 VSS.t1509 VSS.n3021 234.114
R4786 VSS.t1625 VSS.n3035 234.114
R4787 VSS.t1027 VSS.n3049 234.114
R4788 VSS.t1780 VSS.n3063 234.114
R4789 VSS.t1231 VSS.n3077 234.114
R4790 VSS.t2138 VSS.n3091 234.114
R4791 VSS.t2268 VSS.n3105 234.114
R4792 VSS.t302 VSS.n3119 234.114
R4793 VSS.t1524 VSS.n3133 234.114
R4794 VSS.t309 VSS.n3147 234.114
R4795 VSS.t1464 VSS.n3161 234.114
R4796 VSS.t1192 VSS.n3175 234.114
R4797 VSS.t2196 VSS.n3189 234.114
R4798 VSS.t1203 VSS.n3203 234.114
R4799 VSS.t1171 VSS.n2709 234.114
R4800 VSS.t17 VSS.n2717 234.114
R4801 VSS.t2294 VSS.n2725 234.114
R4802 VSS.t1130 VSS.n2734 234.114
R4803 VSS.t186 VSS.n2741 234.114
R4804 VSS.t1813 VSS.n2750 234.114
R4805 VSS.t494 VSS.n2757 234.114
R4806 VSS.t1772 VSS.n2765 234.114
R4807 VSS.t1818 VSS.n2774 234.114
R4808 VSS.t1810 VSS.n2781 234.114
R4809 VSS.t1023 VSS.n2789 234.114
R4810 VSS.t13 VSS.n2798 234.114
R4811 VSS.t1363 VSS.n2805 234.114
R4812 VSS.t844 VSS.n2813 234.114
R4813 VSS.t1815 VSS.n2821 234.114
R4814 VSS.t1297 VSS.n2828 234.114
R4815 VSS.t1621 VSS.n1128 234.114
R4816 VSS.t1349 VSS.n1135 234.114
R4817 VSS.t1939 VSS.n1142 234.114
R4818 VSS.t369 VSS.n1150 234.114
R4819 VSS.t1220 VSS.n1156 234.114
R4820 VSS.t1494 VSS.n1163 234.114
R4821 VSS.t1945 VSS.n1170 234.114
R4822 VSS.t1496 VSS.n1177 234.114
R4823 VSS.t1014 VSS.n1184 234.114
R4824 VSS.t2322 VSS.n1191 234.114
R4825 VSS.t1427 VSS.n1198 234.114
R4826 VSS.t527 VSS.n1205 234.114
R4827 VSS.t1953 VSS.n1212 234.114
R4828 VSS.t2329 VSS.n1219 234.114
R4829 VSS.t428 VSS.n1226 234.114
R4830 VSS.t1958 VSS.n1233 234.114
R4831 VSS.n2537 VSS.t1306 234.114
R4832 VSS.n2525 VSS.t1386 234.114
R4833 VSS.n2513 VSS.t1388 234.114
R4834 VSS.n2500 VSS.t2224 234.114
R4835 VSS.n2486 VSS.t58 234.114
R4836 VSS.n2472 VSS.t979 234.114
R4837 VSS.n2460 VSS.t1195 234.114
R4838 VSS.n2449 VSS.t1759 234.114
R4839 VSS.n2438 VSS.t2151 234.114
R4840 VSS.n2423 VSS.t1059 234.114
R4841 VSS.n2412 VSS.t1213 234.114
R4842 VSS.n2401 VSS.t983 234.114
R4843 VSS.n2388 VSS.t84 234.114
R4844 VSS.n2372 VSS.t2310 234.114
R4845 VSS.n2360 VSS.t2313 234.114
R4846 VSS.n2347 VSS.t1407 234.114
R4847 VSS.t653 VSS.n993 233.721
R4848 VSS.n787 VSS.t1775 231.763
R4849 VSS.t1607 VSS.n2098 231.763
R4850 VSS.n699 VSS.t1513 231.763
R4851 VSS.n679 VSS.t1353 230.327
R4852 VSS.n1558 VSS.n1009 230.233
R4853 VSS.n1567 VSS.n987 230.233
R4854 VSS.n1568 VSS.n990 230.233
R4855 VSS.n568 VSS.t838 229.44
R4856 VSS.n524 VSS.t780 229.439
R4857 VSS.n533 VSS.t791 229.439
R4858 VSS.n541 VSS.t803 229.439
R4859 VSS.n550 VSS.t815 229.439
R4860 VSS.n559 VSS.t826 229.439
R4861 VSS.n683 VSS.t1660 228.827
R4862 VSS.n497 VSS.t110 225.361
R4863 VSS.t1656 VSS.n209 225.361
R4864 VSS.t1499 VSS.n231 225.361
R4865 VSS.n399 VSS.t1456 225.361
R4866 VSS.n387 VSS.t1981 225.361
R4867 VSS.n374 VSS.t101 225.361
R4868 VSS.t1285 VSS.n261 225.361
R4869 VSS.t2062 VSS.n266 225.361
R4870 VSS.n334 VSS.t2042 225.361
R4871 VSS.n321 VSS.t2340 225.361
R4872 VSS.n308 VSS.t2100 225.361
R4873 VSS.t2154 VSS.n2996 225.361
R4874 VSS.t415 VSS.n3010 225.361
R4875 VSS.t1626 VSS.n3038 225.361
R4876 VSS.t1025 VSS.n3052 225.361
R4877 VSS.t1232 VSS.n3080 225.361
R4878 VSS.t2269 VSS.n3108 225.361
R4879 VSS.t304 VSS.n3122 225.361
R4880 VSS.t1525 VSS.n3136 225.361
R4881 VSS.t310 VSS.n3150 225.361
R4882 VSS.t1193 VSS.n3178 225.361
R4883 VSS.t2197 VSS.n3192 225.361
R4884 VSS.t2078 VSS.n81 225.361
R4885 VSS.t1622 VSS.n83 225.361
R4886 VSS.t1938 VSS.n86 225.361
R4887 VSS.t371 VSS.n88 225.361
R4888 VSS.t1493 VSS.n91 225.361
R4889 VSS.t1944 VSS.n93 225.361
R4890 VSS.t1013 VSS.n96 225.361
R4891 VSS.t2321 VSS.n99 225.361
R4892 VSS.t526 VSS.n101 225.361
R4893 VSS.t1952 VSS.n105 225.361
R4894 VSS.t430 VSS.n107 225.361
R4895 VSS.t1967 VSS.n2115 225.361
R4896 VSS.t1384 VSS.n2122 225.361
R4897 VSS.t1389 VSS.n2125 225.361
R4898 VSS.n2483 VSS.t60 225.361
R4899 VSS.n2470 VSS.t978 225.361
R4900 VSS.n2435 VSS.t2150 225.361
R4901 VSS.t982 VSS.n2147 225.361
R4902 VSS.n2385 VSS.t86 225.361
R4903 VSS.n2370 VSS.t2311 225.361
R4904 VSS.t2314 VSS.n2156 225.361
R4905 VSS.t1280 VSS.n199 225.359
R4906 VSS.t2324 VSS.n204 225.359
R4907 VSS.t1965 VSS.n216 225.359
R4908 VSS.t380 VSS.n225 225.359
R4909 VSS.t1451 VSS.n238 225.359
R4910 VSS.t2040 VSS.n2982 225.359
R4911 VSS.t1511 VSS.n3024 225.359
R4912 VSS.t1781 VSS.n3066 225.359
R4913 VSS.t2139 VSS.n3094 225.359
R4914 VSS.t1465 VSS.n3164 225.359
R4915 VSS.t1350 VSS.n112 225.359
R4916 VSS.t1221 VSS.n114 225.359
R4917 VSS.t1497 VSS.n116 225.359
R4918 VSS.t1425 VSS.n119 225.359
R4919 VSS.t2328 VSS.n121 225.359
R4920 VSS.t1305 VSS.n2197 225.359
R4921 VSS.t2225 VSS.n2191 225.359
R4922 VSS.t1194 VSS.n2183 225.359
R4923 VSS.t1760 VSS.n2179 225.359
R4924 VSS.t1060 VSS.n2174 225.359
R4925 VSS.t1214 VSS.n2170 225.359
R4926 VSS.t1031 VSS.n2701 225.359
R4927 VSS.n2956 VSS.t1169 225.359
R4928 VSS.n2948 VSS.t15 225.359
R4929 VSS.t2293 VSS.n2726 225.359
R4930 VSS.n2933 VSS.t1132 225.359
R4931 VSS.n2925 VSS.t184 225.359
R4932 VSS.n2919 VSS.t1812 225.359
R4933 VSS.n2911 VSS.t495 225.359
R4934 VSS.n2903 VSS.t1771 225.359
R4935 VSS.n2895 VSS.t1817 225.359
R4936 VSS.n2887 VSS.t1809 225.359
R4937 VSS.n2879 VSS.t1021 225.359
R4938 VSS.n2872 VSS.t11 225.359
R4939 VSS.n2864 VSS.t1364 225.359
R4940 VSS.n2855 VSS.t845 225.359
R4941 VSS.n2847 VSS.t1814 225.359
R4942 VSS.n822 VSS.t115 224.82
R4943 VSS.n2253 VSS.t1342 224.82
R4944 VSS.n734 VSS.t1417 224.82
R4945 VSS.n786 VSS.t192 224.82
R4946 VSS.n2102 VSS.t2338 224.82
R4947 VSS.n698 VSS.t2358 224.82
R4948 VSS.n783 VSS.t172 222.222
R4949 VSS.n2105 VSS.t1641 222.222
R4950 VSS.n695 VSS.t1598 222.222
R4951 VSS.n1044 VSS.t1777 216.784
R4952 VSS.n1587 VSS.n1016 216.28
R4953 VSS.n1593 VSS.n1025 216.28
R4954 VSS.n1546 VSS.n1036 216.28
R4955 VSS.n1574 VSS.n995 216.28
R4956 VSS.t2295 VSS.n1914 215.731
R4957 VSS.n1948 VSS.t2295 215.731
R4958 VSS.n663 VSS.t1244 212.143
R4959 VSS.t417 VSS.n646 212.143
R4960 VSS.t1545 VSS.n632 212.143
R4961 VSS.t1547 VSS.n610 212.143
R4962 VSS.t1246 VSS.n618 212.143
R4963 VSS.t420 VSS.n597 212.143
R4964 VSS.t423 VSS.n584 212.143
R4965 VSS.n573 VSS.t412 212.143
R4966 VSS.t345 VSS.n194 211.982
R4967 VSS.t334 VSS.n210 211.982
R4968 VSS.t352 VSS.n220 211.982
R4969 VSS.t361 VSS.n232 211.982
R4970 VSS.t350 VSS.n256 211.982
R4971 VSS.t355 VSS.n263 211.982
R4972 VSS.t364 VSS.n268 211.982
R4973 VSS.t1302 VSS.n270 211.982
R4974 VSS.n3013 VSS.t1904 211.982
R4975 VSS.n3055 VSS.t1666 211.982
R4976 VSS.n3083 VSS.t1670 211.982
R4977 VSS.n3153 VSS.t1998 211.982
R4978 VSS.t2194 VSS.n118 211.982
R4979 VSS.t2016 VSS.n120 211.982
R4980 VSS.t444 VSS.n2194 211.982
R4981 VSS.t537 VSS.n2190 211.982
R4982 VSS.t105 VSS.n2185 211.982
R4983 VSS.t311 VSS.n2182 211.982
R4984 VSS.t397 VSS.n2177 211.982
R4985 VSS.t2237 VSS.n2173 211.982
R4986 VSS.t1327 VSS.n2116 211.982
R4987 VSS.t2252 VSS.n2120 211.982
R4988 VSS.t400 VSS.n2508 211.982
R4989 VSS.t2186 VSS.n2480 211.982
R4990 VSS.t1848 VSS.n2136 211.982
R4991 VSS.t2189 VSS.n2143 211.982
R4992 VSS.t1126 VSS.n2396 211.982
R4993 VSS.t314 VSS.n2382 211.982
R4994 VSS.t1070 VSS.n2153 211.982
R4995 VSS.t2255 VSS.n2355 211.982
R4996 VSS.t1711 VSS.n200 211.982
R4997 VSS.t1878 VSS.n468 211.982
R4998 VSS.t337 VSS.n227 211.982
R4999 VSS.t1299 VSS.n410 211.982
R5000 VSS.t347 VSS.n242 211.982
R5001 VSS.t331 VSS.n250 211.982
R5002 VSS.t1875 VSS.n277 211.982
R5003 VSS.t1708 VSS.n304 211.982
R5004 VSS.n2985 VSS.t1530 211.982
R5005 VSS.n2999 VSS.t1733 211.982
R5006 VSS.n3027 VSS.t1664 211.982
R5007 VSS.n3041 VSS.t1537 211.982
R5008 VSS.n3069 VSS.t1996 211.982
R5009 VSS.n3097 VSS.t1533 211.982
R5010 VSS.n3111 VSS.t1651 211.982
R5011 VSS.n3125 VSS.t1535 211.982
R5012 VSS.n3139 VSS.t1668 211.982
R5013 VSS.n3167 VSS.t1672 211.982
R5014 VSS.n3181 VSS.t1906 211.982
R5015 VSS.n3195 VSS.t1735 211.982
R5016 VSS.t1679 VSS.n162 211.982
R5017 VSS.t1688 VSS.n84 211.982
R5018 VSS.t565 VSS.n158 211.982
R5019 VSS.t2008 VSS.n154 211.982
R5020 VSS.t548 VSS.n89 211.982
R5021 VSS.t2010 VSS.n150 211.982
R5022 VSS.t147 VSS.n146 211.982
R5023 VSS.t2014 VSS.n94 211.982
R5024 VSS.t1682 VSS.n142 211.982
R5025 VSS.t2005 VSS.n97 211.982
R5026 VSS.t2012 VSS.n135 211.982
R5027 VSS.t150 VSS.n131 211.982
R5028 VSS.t2002 VSS.n128 211.982
R5029 VSS.t1891 VSS.n124 211.982
R5030 VSS.t1075 VSS.n2962 211.982
R5031 VSS.t1449 VSS.n2954 211.982
R5032 VSS.t2110 VSS.n2939 211.982
R5033 VSS.t1077 VSS.n2931 211.982
R5034 VSS.t1747 VSS.n2917 211.982
R5035 VSS.t1868 VSS.n2909 211.982
R5036 VSS.t2107 VSS.n2893 211.982
R5037 VSS.t1080 VSS.n2885 211.982
R5038 VSS.t1750 VSS.n2870 211.982
R5039 VSS.t1870 VSS.n2862 211.982
R5040 VSS.t2241 VSS.n2853 211.982
R5041 VSS.t1446 VSS.n2845 211.982
R5042 VSS.t2244 VSS.n2720 211.982
R5043 VSS.t2112 VSS.n2744 211.982
R5044 VSS.t1742 VSS.n2768 211.982
R5045 VSS.t1866 VSS.n2792 211.982
R5046 VSS.t250 VSS.n2098 210.948
R5047 VSS.t1360 VSS.n787 210.948
R5048 VSS.t986 VSS.n699 210.948
R5049 VSS.n2253 VSS.t436 210.939
R5050 VSS.t1844 VSS.n822 210.939
R5051 VSS.t98 VSS.n734 210.939
R5052 VSS.t1055 VSS.n2284 210.935
R5053 VSS.t554 VSS.n2268 210.935
R5054 VSS.t271 VSS.n2241 210.935
R5055 VSS.t1057 VSS.n2225 210.935
R5056 VSS.t118 VSS.n2210 210.935
R5057 VSS.t1505 VSS.n796 210.935
R5058 VSS.t1840 VSS.n805 210.935
R5059 VSS.t1882 VSS.n814 210.935
R5060 VSS.t1507 VSS.n833 210.935
R5061 VSS.t394 VSS.n841 210.935
R5062 VSS.t2262 VSS.n981 210.935
R5063 VSS.t1267 VSS.n708 210.935
R5064 VSS.t1187 VSS.n717 210.935
R5065 VSS.t973 VSS.n726 210.935
R5066 VSS.t1269 VSS.n744 210.935
R5067 VSS.t1271 VSS.n752 210.935
R5068 VSS.t1433 VSS.n850 210.933
R5069 VSS.t1255 VSS.n761 210.931
R5070 VSS.t2381 VSS.n2340 210.93
R5071 VSS.n1625 VSS.t1234 208.828
R5072 VSS.t1353 VSS.n678 207.294
R5073 VSS.n1544 VSS.n1041 202.798
R5074 VSS.n1543 VSS.n1042 202.798
R5075 VSS.n1002 VSS.t655 202.798
R5076 VSS.n1627 VSS.t854 202.362
R5077 VSS.n1589 VSS.n1020 202.327
R5078 VSS.n1590 VSS.n1021 202.327
R5079 VSS.n1578 VSS.n999 202.327
R5080 VSS.n1580 VSS.n1000 202.327
R5081 VSS.n677 VSS.t1661 200.649
R5082 VSS.n9 VSS.n1801 197.518
R5083 VSS.n674 VSS.t562 195.778
R5084 VSS.n492 VSS.t1553 195.26
R5085 VSS.t2180 VSS.n202 195.26
R5086 VSS.t2235 VSS.n222 195.26
R5087 VSS.t1502 VSS.n240 195.26
R5088 VSS.t2184 VSS.n245 195.26
R5089 VSS.n369 VSS.t1889 195.26
R5090 VSS.n357 VSS.t2372 195.26
R5091 VSS.n343 VSS.t2055 195.26
R5092 VSS.t2089 VSS.n273 195.26
R5093 VSS.t2127 VSS.n280 195.26
R5094 VSS.n302 VSS.t2130 195.26
R5095 VSS.t1614 VSS.n2988 195.26
R5096 VSS.t2214 VSS.n3002 195.26
R5097 VSS.t2096 VSS.n3016 195.26
R5098 VSS.t2299 VSS.n3030 195.26
R5099 VSS.t2123 VSS.n3044 195.26
R5100 VSS.t1637 VSS.n3058 195.26
R5101 VSS.t1798 VSS.n3072 195.26
R5102 VSS.t2273 VSS.n3086 195.26
R5103 VSS.t2170 VSS.n3114 195.26
R5104 VSS.t1804 VSS.n3128 195.26
R5105 VSS.t53 VSS.n3142 195.26
R5106 VSS.t1396 VSS.n3156 195.26
R5107 VSS.t1404 VSS.n3184 195.26
R5108 VSS.t1753 VSS.n3198 195.26
R5109 VSS.t1927 VSS.n82 195.26
R5110 VSS.t1412 VSS.n85 195.26
R5111 VSS.n156 VSS.t1347 195.26
R5112 VSS.t1009 VSS.n87 195.26
R5113 VSS.t1491 VSS.n90 195.26
R5114 VSS.n148 VSS.t1218 195.26
R5115 VSS.t1320 VSS.n92 195.26
R5116 VSS.t2319 VSS.n95 195.26
R5117 VSS.n140 VSS.t2176 195.26
R5118 VSS.t1419 VSS.n98 195.26
R5119 VSS.t2179 VSS.n100 195.26
R5120 VSS.n133 VSS.t1428 195.26
R5121 VSS.t531 VSS.n103 195.26
R5122 VSS.t1556 VSS.n106 195.26
R5123 VSS.n126 VSS.t1068 195.26
R5124 VSS.t232 VSS.n109 195.26
R5125 VSS.n2491 VSS.t1190 195.26
R5126 VSS.t2354 VSS.n2138 195.26
R5127 VSS.t80 VSS.n2145 195.26
R5128 VSS.n2393 VSS.t2306 195.26
R5129 VSS.n2379 VSS.t1312 195.26
R5130 VSS.n2352 VSS.t990 195.26
R5131 VSS.t1559 VSS.n206 195.26
R5132 VSS.t1826 VSS.n213 195.26
R5133 VSS.t1675 VSS.n228 195.26
R5134 VSS.t1677 VSS.n235 195.26
R5135 VSS.t1985 VSS.n253 195.26
R5136 VSS.t492 VSS.n3100 195.26
R5137 VSS.t1199 VSS.n3170 195.26
R5138 VSS.t1259 VSS.n2198 195.26
R5139 VSS.t1381 VSS.n2195 195.26
R5140 VSS.t1527 VSS.n2193 195.26
R5141 VSS.t1469 VSS.n2192 195.26
R5142 VSS.t1474 VSS.n2187 195.26
R5143 VSS.t1043 VSS.n2184 195.26
R5144 VSS.t341 VSS.n2181 195.26
R5145 VSS.t1051 VSS.n2175 195.26
R5146 VSS.t2228 VSS.n2172 195.26
R5147 VSS.t1315 VSS.n2165 195.26
R5148 VSS.n2961 VSS.t180 195.26
R5149 VSS.n2953 VSS.t2351 195.26
R5150 VSS.n2945 VSS.t297 195.26
R5151 VSS.n2938 VSS.t1789 195.26
R5152 VSS.n2930 VSS.t390 195.26
R5153 VSS.t2278 VSS.n2747 195.26
R5154 VSS.n2916 VSS.t1117 195.26
R5155 VSS.n2908 VSS.t269 195.26
R5156 VSS.t2284 VSS.n2771 195.26
R5157 VSS.n2892 VSS.t2200 195.26
R5158 VSS.n2884 VSS.t514 195.26
R5159 VSS.t1610 VSS.n2795 195.26
R5160 VSS.n2869 VSS.t1252 195.26
R5161 VSS.n2861 VSS.t1149 195.26
R5162 VSS.t2145 VSS.n2818 195.26
R5163 VSS.n2843 VSS.t1631 195.26
R5164 VSS.t40 VSS.n664 194.891
R5165 VSS.t1807 VSS.n2 194.514
R5166 VSS.t657 VSS.n1005 192.309
R5167 VSS.n791 VSS.t686 190.096
R5168 VSS.n799 VSS.t693 190.096
R5169 VSS.n809 VSS.t701 190.096
R5170 VSS.n828 VSS.t708 190.096
R5171 VSS.n836 VSS.t715 190.096
R5172 VSS.n844 VSS.t721 190.096
R5173 VSS.t572 VSS.n2297 190.096
R5174 VSS.t583 VSS.n2286 190.096
R5175 VSS.t595 VSS.n2270 190.096
R5176 VSS.t606 VSS.n2248 190.096
R5177 VSS.t618 VSS.n2227 190.096
R5178 VSS.t630 VSS.n2211 190.096
R5179 VSS.n975 VSS.t642 190.096
R5180 VSS.n703 VSS.t729 190.096
R5181 VSS.n711 VSS.t736 190.096
R5182 VSS.n721 VSS.t744 190.096
R5183 VSS.n739 VSS.t751 190.096
R5184 VSS.n747 VSS.t757 190.096
R5185 VSS.n755 VSS.t765 190.096
R5186 VSS.n617 VSS.t2276 189.132
R5187 VSS.t2292 VSS.n665 189.132
R5188 VSS.n1561 VSS.n1004 188.811
R5189 VSS.n1545 VSS.n1037 188.373
R5190 VSS.t35 VSS.n1619 187.895
R5191 VSS.t1177 VSS.n488 187.292
R5192 VSS.t33 VSS.n476 187.292
R5193 VSS.t388 VSS.n462 187.292
R5194 VSS.t856 VSS.n451 187.292
R5195 VSS.t2297 VSS.n440 187.292
R5196 VSS.t2091 VSS.n428 187.292
R5197 VSS.t850 VSS.n417 187.292
R5198 VSS.t261 VSS.n404 187.292
R5199 VSS.t1600 VSS.n391 187.292
R5200 VSS.t2290 VSS.n378 187.292
R5201 VSS.t176 VSS.n365 187.292
R5202 VSS.t2152 VSS.n353 187.292
R5203 VSS.t1028 VSS.n339 187.292
R5204 VSS.t1628 VSS.n326 187.292
R5205 VSS.t2367 VSS.n312 187.292
R5206 VSS.t1158 VSS.n298 187.292
R5207 VSS.n2991 VSS.t2048 187.292
R5208 VSS.n3005 VSS.t1946 187.292
R5209 VSS.n3019 VSS.t2019 187.292
R5210 VSS.n3033 VSS.t1909 187.292
R5211 VSS.n3047 VSS.t2032 187.292
R5212 VSS.n3061 VSS.t1979 187.292
R5213 VSS.n3075 VSS.t1971 187.292
R5214 VSS.n3089 VSS.t1956 187.292
R5215 VSS.n3103 VSS.t1925 187.292
R5216 VSS.n3117 VSS.t1911 187.292
R5217 VSS.n3131 VSS.t2034 187.292
R5218 VSS.n3145 VSS.t1980 187.292
R5219 VSS.n3159 VSS.t1972 187.292
R5220 VSS.n3173 VSS.t1960 187.292
R5221 VSS.n3187 VSS.t1949 187.292
R5222 VSS.n3201 VSS.t1933 187.292
R5223 VSS.t2281 VSS.n2708 187.292
R5224 VSS.t256 VSS.n2716 187.292
R5225 VSS.t1639 VSS.n2724 187.292
R5226 VSS.t1236 VSS.n2732 187.292
R5227 VSS.t166 VSS.n2740 187.292
R5228 VSS.t204 VSS.n2749 187.292
R5229 VSS.t1235 VSS.n2756 187.292
R5230 VSS.t1345 VSS.n2764 187.292
R5231 VSS.t852 VSS.n2773 187.292
R5232 VSS.t1154 VSS.n2780 187.292
R5233 VSS.t116 VSS.n2788 187.292
R5234 VSS.t1288 VSS.n2797 187.292
R5235 VSS.t2217 VSS.n2804 187.292
R5236 VSS.t971 VSS.n2812 187.292
R5237 VSS.t293 VSS.n2820 187.292
R5238 VSS.t2215 VSS.n2827 187.292
R5239 VSS.t2081 VSS.n1127 187.292
R5240 VSS.t2052 VSS.n1134 187.292
R5241 VSS.t2082 VSS.n1141 187.292
R5242 VSS.t2342 VSS.n1148 187.292
R5243 VSS.t2104 VSS.n1155 187.292
R5244 VSS.t2341 VSS.n1162 187.292
R5245 VSS.t2334 VSS.n1169 187.292
R5246 VSS.t2087 VSS.n1176 187.292
R5247 VSS.t2347 VSS.n1183 187.292
R5248 VSS.t2086 VSS.n1190 187.292
R5249 VSS.t2097 VSS.n1197 187.292
R5250 VSS.t2116 VSS.n1204 187.292
R5251 VSS.t2102 VSS.n1211 187.292
R5252 VSS.t2133 VSS.n1218 187.292
R5253 VSS.t2343 VSS.n1225 187.292
R5254 VSS.t2106 VSS.n1232 187.292
R5255 VSS.t1963 VSS.n2539 187.292
R5256 VSS.t1951 VSS.n2528 187.292
R5257 VSS.t1936 VSS.n2515 187.292
R5258 VSS.t1987 VSS.n2502 187.292
R5259 VSS.t1930 VSS.n2488 187.292
R5260 VSS.t1920 VSS.n2475 187.292
R5261 VSS.t1914 VSS.n2463 187.292
R5262 VSS.t1913 VSS.n2451 187.292
R5263 VSS.t2029 VSS.n2440 187.292
R5264 VSS.t2018 VSS.n2426 187.292
R5265 VSS.t2035 VSS.n2414 187.292
R5266 VSS.t1937 VSS.n2403 187.292
R5267 VSS.t1989 VSS.n2390 187.292
R5268 VSS.t1983 VSS.n2376 187.292
R5269 VSS.t1977 VSS.n2362 187.292
R5270 VSS.t1969 VSS.n2349 187.292
R5271 VSS.t659 VSS.n1024 184.885
R5272 VSS.n989 VSS.t651 184.885
R5273 VSS.t848 VSS.n992 184.885
R5274 VSS.t1662 VSS.n668 184.262
R5275 VSS.n3 VSS.t475 177.713
R5276 VSS.n664 VSS.t1243 177.633
R5277 VSS.t1245 VSS.n617 177.624
R5278 VSS.t416 VSS.n645 177.62
R5279 VSS.t1544 VSS.n631 177.62
R5280 VSS.t1546 VSS.n609 177.62
R5281 VSS.t419 VSS.n596 177.62
R5282 VSS.t422 VSS.n583 177.62
R5283 VSS.t411 VSS.n570 177.615
R5284 VSS.t574 VSS.n2297 176.209
R5285 VSS.n2286 VSS.t586 176.209
R5286 VSS.n2270 VSS.t597 176.209
R5287 VSS.n2248 VSS.t609 176.209
R5288 VSS.n2227 VSS.t621 176.209
R5289 VSS.n2211 VSS.t632 176.209
R5290 VSS.t688 VSS.n791 176.209
R5291 VSS.t695 VSS.n799 176.209
R5292 VSS.t703 VSS.n809 176.209
R5293 VSS.t710 VSS.n828 176.209
R5294 VSS.t716 VSS.n836 176.209
R5295 VSS.t723 VSS.n844 176.209
R5296 VSS.t644 VSS.n975 176.209
R5297 VSS.t731 VSS.n703 176.209
R5298 VSS.t738 VSS.n711 176.209
R5299 VSS.t746 VSS.n721 176.209
R5300 VSS.t752 VSS.n739 176.209
R5301 VSS.t759 VSS.n747 176.209
R5302 VSS.t767 VSS.n755 176.209
R5303 VSS.t266 VSS.n1972 175.31
R5304 VSS.n1559 VSS.n1008 174.419
R5305 VSS.n1547 VSS.n1033 174.419
R5306 VSS.n1565 VSS.n986 174.419
R5307 VSS.n485 VSS.t359 173.913
R5308 VSS.n473 VSS.t993 173.913
R5309 VSS.n459 VSS.t1703 173.913
R5310 VSS.n448 VSS.t246 173.913
R5311 VSS.n437 VSS.t1705 173.913
R5312 VSS.n425 VSS.t999 173.913
R5313 VSS.n414 VSS.t1720 173.913
R5314 VSS.n401 VSS.t1003 173.913
R5315 VSS.n388 VSS.t1700 173.913
R5316 VSS.n375 VSS.t249 173.913
R5317 VSS.n362 VSS.t1707 173.913
R5318 VSS.n350 VSS.t1001 173.913
R5319 VSS.n336 VSS.t1722 173.913
R5320 VSS.n323 VSS.t1005 173.913
R5321 VSS.n309 VSS.t1881 173.913
R5322 VSS.n295 VSS.t996 173.913
R5323 VSS.t1541 VSS.n2994 173.913
R5324 VSS.t63 VSS.n3008 173.913
R5325 VSS.t1482 VSS.n3022 173.913
R5326 VSS.t1902 VSS.n3036 173.913
R5327 VSS.t1485 VSS.n3050 173.913
R5328 VSS.t69 VSS.n3064 173.913
R5329 VSS.t1739 VSS.n3078 173.913
R5330 VSS.t75 VSS.n3092 173.913
R5331 VSS.t1479 VSS.n3106 173.913
R5332 VSS.t2001 VSS.n3120 173.913
R5333 VSS.t1487 VSS.n3134 173.913
R5334 VSS.t72 VSS.n3148 173.913
R5335 VSS.t1741 VSS.n3162 173.913
R5336 VSS.t78 VSS.n3176 173.913
R5337 VSS.t1900 VSS.n3190 173.913
R5338 VSS.t66 VSS.n3204 173.913
R5339 VSS.n3208 VSS.n3207 173.913
R5340 VSS.n2958 VSS.t1746 173.913
R5341 VSS.n2950 VSS.t1763 173.913
R5342 VSS.n2942 VSS.t1440 173.913
R5343 VSS.n2935 VSS.t1873 173.913
R5344 VSS.n2927 VSS.t1443 173.913
R5345 VSS.n2921 VSS.t1768 173.913
R5346 VSS.n2913 VSS.t1375 173.913
R5347 VSS.n2905 VSS.t1792 173.913
R5348 VSS.n2898 VSS.t1437 173.913
R5349 VSS.n2889 VSS.t487 173.913
R5350 VSS.n2881 VSS.t1445 173.913
R5351 VSS.n2874 VSS.t1770 173.913
R5352 VSS.n2866 VSS.t1377 173.913
R5353 VSS.n2858 VSS.t1794 173.913
R5354 VSS.n2849 VSS.t2247 173.913
R5355 VSS.n2840 VSS.t1765 173.913
R5356 VSS.n2838 VSS.n2837 173.913
R5357 VSS.n2069 VSS.t552 173.913
R5358 VSS.n2065 VSS.t5 173.913
R5359 VSS.n2061 VSS.t243 173.913
R5360 VSS.n2057 VSS.t2250 173.913
R5361 VSS.n2053 VSS.t1685 173.913
R5362 VSS.n2049 VSS.t1691 173.913
R5363 VSS.n2045 VSS.t1894 173.913
R5364 VSS.n2041 VSS.t1836 173.913
R5365 VSS.n2037 VSS.t240 173.913
R5366 VSS.n2032 VSS.t1731 173.913
R5367 VSS.n2028 VSS.t1687 173.913
R5368 VSS.n2024 VSS.t1693 173.913
R5369 VSS.n2020 VSS.t1897 173.913
R5370 VSS.n2016 VSS.t1838 173.913
R5371 VSS.n2011 VSS.t1695 173.913
R5372 VSS.n2007 VSS.t8 173.913
R5373 VSS.n2005 VSS.n2004 173.913
R5374 VSS.n2535 VSS.t154 173.913
R5375 VSS.n2524 VSS.t2219 173.913
R5376 VSS.n2511 VSS.t1856 173.913
R5377 VSS.n2498 VSS.t1034 173.913
R5378 VSS.n2484 VSS.t1858 173.913
R5379 VSS.n2471 VSS.t28 173.913
R5380 VSS.n2459 VSS.t324 173.913
R5381 VSS.n2447 VSS.t406 173.913
R5382 VSS.n2436 VSS.t1853 173.913
R5383 VSS.n2422 VSS.t2193 173.913
R5384 VSS.n2410 VSS.t1083 173.913
R5385 VSS.n2399 VSS.t31 173.913
R5386 VSS.n2386 VSS.t1698 173.913
R5387 VSS.n2371 VSS.t409 173.913
R5388 VSS.n2358 VSS.t300 173.913
R5389 VSS.n2346 VSS.t25 173.913
R5390 VSS.n1610 VSS.t194 173.119
R5391 VSS.t1658 VSS.n1011 167.442
R5392 VSS.n672 VSS.t434 165.488
R5393 VSS.t346 VSS.t1554 163.881
R5394 VSS.t1712 VSS.t2181 163.881
R5395 VSS.t1879 VSS.t1560 163.881
R5396 VSS.t335 VSS.t1825 163.881
R5397 VSS.t353 VSS.t2234 163.881
R5398 VSS.t338 VSS.t1674 163.881
R5399 VSS.t362 VSS.t1678 163.881
R5400 VSS.t1300 VSS.t1503 163.881
R5401 VSS.t348 VSS.t2183 163.881
R5402 VSS.t332 VSS.t1984 163.881
R5403 VSS.t351 VSS.t1890 163.881
R5404 VSS.t356 VSS.t2371 163.881
R5405 VSS.t365 VSS.t2056 163.881
R5406 VSS.t1303 VSS.t2090 163.881
R5407 VSS.t1876 VSS.t2125 163.881
R5408 VSS.t1709 VSS.t2129 163.881
R5409 VSS.t1613 VSS.t1531 163.881
R5410 VSS.t2213 VSS.t1734 163.881
R5411 VSS.t2095 VSS.t1905 163.881
R5412 VSS.t2298 VSS.t1665 163.881
R5413 VSS.t2122 VSS.t1538 163.881
R5414 VSS.t1636 VSS.t1667 163.881
R5415 VSS.t1797 VSS.t1997 163.881
R5416 VSS.t2272 VSS.t1671 163.881
R5417 VSS.t490 VSS.t1534 163.881
R5418 VSS.t2169 VSS.t1652 163.881
R5419 VSS.t1803 VSS.t1536 163.881
R5420 VSS.t55 VSS.t1669 163.881
R5421 VSS.t1395 VSS.t1999 163.881
R5422 VSS.t1197 VSS.t1673 163.881
R5423 VSS.t1406 VSS.t1907 163.881
R5424 VSS.t1755 VSS.t1736 163.881
R5425 VSS.t1076 VSS.t178 163.881
R5426 VSS.t2352 VSS.t1450 163.881
R5427 VSS.t295 VSS.t2245 163.881
R5428 VSS.t2111 VSS.t1788 163.881
R5429 VSS.t391 VSS.t1078 163.881
R5430 VSS.t2113 VSS.t2279 163.881
R5431 VSS.t1748 VSS.t1116 163.881
R5432 VSS.t268 VSS.t1869 163.881
R5433 VSS.t2285 VSS.t1743 163.881
R5434 VSS.t2108 VSS.t2201 163.881
R5435 VSS.t515 VSS.t1081 163.881
R5436 VSS.t1608 VSS.t1867 163.881
R5437 VSS.t1751 VSS.t1250 163.881
R5438 VSS.t1148 VSS.t1871 163.881
R5439 VSS.t2146 VSS.t2242 163.881
R5440 VSS.t1630 VSS.t1447 163.881
R5441 VSS.t1926 VSS.t1680 163.881
R5442 VSS.t1411 VSS.t1689 163.881
R5443 VSS.t1346 VSS.t566 163.881
R5444 VSS.t1007 VSS.t2009 163.881
R5445 VSS.t1490 VSS.t549 163.881
R5446 VSS.t1217 VSS.t2011 163.881
R5447 VSS.t1318 VSS.t148 163.881
R5448 VSS.t2318 VSS.t2015 163.881
R5449 VSS.t2175 VSS.t1683 163.881
R5450 VSS.t1418 VSS.t2006 163.881
R5451 VSS.t2178 VSS.t2195 163.881
R5452 VSS.t1430 VSS.t2013 163.881
R5453 VSS.t151 VSS.t530 163.881
R5454 VSS.t1558 VSS.t2017 163.881
R5455 VSS.t1067 VSS.t2003 163.881
R5456 VSS.t1892 VSS.t230 163.881
R5457 VSS.t1328 VSS.t1257 163.881
R5458 VSS.t2253 VSS.t1380 163.881
R5459 VSS.t445 VSS.t1526 163.881
R5460 VSS.t401 VSS.t1468 163.881
R5461 VSS.t538 VSS.t1189 163.881
R5462 VSS.t2187 VSS.t1473 163.881
R5463 VSS.t106 VSS.t1041 163.881
R5464 VSS.t312 VSS.t343 163.881
R5465 VSS.t1849 VSS.t2353 163.881
R5466 VSS.t398 VSS.t1053 163.881
R5467 VSS.t2238 VSS.t2227 163.881
R5468 VSS.t2190 VSS.t82 163.881
R5469 VSS.t1127 VSS.t2307 163.881
R5470 VSS.t315 VSS.t1314 163.881
R5471 VSS.t1071 VSS.t1317 163.881
R5472 VSS.t2256 VSS.t988 163.881
R5473 VSS.n2340 VSS.t641 162.322
R5474 VSS.n850 VSS.t728 162.321
R5475 VSS.n761 VSS.t772 162.321
R5476 VSS.n796 VSS.t692 162.32
R5477 VSS.n805 VSS.t700 162.32
R5478 VSS.n814 VSS.t707 162.32
R5479 VSS.n833 VSS.t714 162.32
R5480 VSS.n841 VSS.t720 162.32
R5481 VSS.t582 VSS.n2284 162.32
R5482 VSS.t594 VSS.n2268 162.32
R5483 VSS.t605 VSS.n2241 162.32
R5484 VSS.t617 VSS.n2225 162.32
R5485 VSS.t629 VSS.n2210 162.32
R5486 VSS.n981 VSS.t648 162.32
R5487 VSS.n708 VSS.t735 162.32
R5488 VSS.n717 VSS.t743 162.32
R5489 VSS.n726 VSS.t750 162.32
R5490 VSS.n744 VSS.t756 162.32
R5491 VSS.n752 VSS.t764 162.32
R5492 VSS.n1597 VSS.n1033 160.465
R5493 VSS.n1569 VSS.n991 160.465
R5494 VSS.n518 VSS.t773 160.34
R5495 VSS.t785 VSS.n527 160.34
R5496 VSS.t796 VSS.n536 160.34
R5497 VSS.t808 VSS.n544 160.34
R5498 VSS.t820 VSS.n553 160.34
R5499 VSS.t831 VSS.n562 160.34
R5500 VSS.n933 VSS.t520 157.601
R5501 VSS.n2563 VSS.t328 157.062
R5502 VSS.t1162 VSS.n1034 156.977
R5503 VSS.n1564 VSS.t649 156.977
R5504 VSS.n928 VSS.t1152 156.464
R5505 VSS.n2559 VSS.t2302 156.429
R5506 VSS.t427 VSS.n200 155.126
R5507 VSS.n468 VSS.t1323 155.126
R5508 VSS.t1973 VSS.n227 155.126
R5509 VSS.n410 VSS.t1282 155.126
R5510 VSS.t1225 VSS.n242 155.126
R5511 VSS.t1460 VSS.n250 155.126
R5512 VSS.t2335 VSS.n277 155.126
R5513 VSS.n304 VSS.t2105 155.126
R5514 VSS.t2210 VSS.n2985 155.126
R5515 VSS.t1254 VSS.n2999 155.126
R5516 VSS.t2168 VSS.n3027 155.126
R5517 VSS.t19 VSS.n3041 155.126
R5518 VSS.t2287 VSS.n3069 155.126
R5519 VSS.t1176 VSS.n3097 155.126
R5520 VSS.t1519 VSS.n3111 155.126
R5521 VSS.t1520 VSS.n3125 155.126
R5522 VSS.t216 VSS.n3139 155.126
R5523 VSS.t1654 VSS.n3167 155.126
R5524 VSS.t1308 VSS.n3181 155.126
R5525 VSS.t2140 VSS.n3195 155.126
R5526 VSS.n162 VSS.t1922 155.126
R5527 VSS.t1344 VSS.n84 155.126
R5528 VSS.n158 VSS.t1931 155.126
R5529 VSS.n154 VSS.t2359 155.126
R5530 VSS.t505 VSS.n89 155.126
R5531 VSS.n150 VSS.t1414 155.126
R5532 VSS.n146 VSS.t2316 155.126
R5533 VSS.t509 VSS.n94 155.126
R5534 VSS.n142 VSS.t1421 155.126
R5535 VSS.t1822 VSS.n97 155.126
R5536 VSS.n135 VSS.t1824 155.126
R5537 VSS.n131 VSS.t1561 155.126
R5538 VSS.n128 VSS.t1623 155.126
R5539 VSS.n124 VSS.t432 155.126
R5540 VSS.t1379 VSS.n2116 155.126
R5541 VSS.t214 VSS.n2120 155.126
R5542 VSS.n2508 VSS.t1398 155.126
R5543 VSS.n2480 VSS.t1402 155.126
R5544 VSS.t2173 VSS.n2136 155.126
R5545 VSS.t1311 VSS.n2143 155.126
R5546 VSS.n2396 VSS.t222 155.126
R5547 VSS.n2382 VSS.t425 155.126
R5548 VSS.t88 VSS.n2153 155.126
R5549 VSS.n2355 VSS.t1273 155.126
R5550 VSS.t522 VSS.n194 155.125
R5551 VSS.t1950 VSS.n210 155.125
R5552 VSS.t1961 VSS.n220 155.125
R5553 VSS.t1454 VSS.n232 155.125
R5554 VSS.t2031 VSS.n256 155.125
R5555 VSS.t382 VSS.n263 155.125
R5556 VSS.t2053 VSS.n268 155.125
R5557 VSS.t2079 VSS.n270 155.125
R5558 VSS.t126 VSS.n3013 155.125
R5559 VSS.t500 VSS.n3055 155.125
R5560 VSS.t182 VSS.n3083 155.125
R5561 VSS.t1307 VSS.n3153 155.125
R5562 VSS.t524 VSS.n118 155.125
R5563 VSS.t2182 VSS.n120 155.125
R5564 VSS.t1391 VSS.n2194 155.125
R5565 VSS.t1471 VSS.n2190 155.125
R5566 VSS.t1620 VSS.n2185 155.125
R5567 VSS.t449 VSS.n2182 155.125
R5568 VSS.t2144 VSS.n2177 155.125
R5569 VSS.t2305 VSS.n2173 155.125
R5570 VSS.n2962 VSS.t1373 155.125
R5571 VSS.n2954 VSS.t2202 155.125
R5572 VSS.t2206 VSS.n2720 155.125
R5573 VSS.n2939 VSS.t2205 155.125
R5574 VSS.n2931 VSS.t2270 155.125
R5575 VSS.t1139 VSS.n2744 155.125
R5576 VSS.n2917 VSS.t1462 155.125
R5577 VSS.n2909 VSS.t197 155.125
R5578 VSS.t112 VSS.n2768 155.125
R5579 VSS.n2893 VSS.t164 155.125
R5580 VSS.n2885 VSS.t843 155.125
R5581 VSS.t1774 VSS.n2792 155.125
R5582 VSS.n2870 VSS.t2331 155.125
R5583 VSS.n2862 VSS.t2199 155.125
R5584 VSS.n2853 VSS.t2117 155.125
R5585 VSS.n2845 VSS.t1017 155.125
R5586 VSS.t190 VSS.n784 154.862
R5587 VSS.t114 VSS.n820 154.862
R5588 VSS.n2103 VSS.t2337 154.862
R5589 VSS.n2255 VSS.t1340 154.862
R5590 VSS.t2357 VSS.n696 154.862
R5591 VSS.t1416 VSS.n732 154.862
R5592 VSS.n1802 VSS.t910 154.613
R5593 VSS.n1803 VSS.t916 154.613
R5594 VSS.t1366 VSS.n670 153.971
R5595 VSS.t477 VSS.n928 153.851
R5596 VSS.n498 VSS.t2166 153.846
R5597 VSS.n488 VSS.t358 153.846
R5598 VSS.n476 VSS.t992 153.846
R5599 VSS.n462 VSS.t1702 153.846
R5600 VSS.n451 VSS.t245 153.846
R5601 VSS.n440 VSS.t1704 153.846
R5602 VSS.n428 VSS.t998 153.846
R5603 VSS.n417 VSS.t1719 153.846
R5604 VSS.n404 VSS.t1002 153.846
R5605 VSS.n391 VSS.t1699 153.846
R5606 VSS.n378 VSS.t248 153.846
R5607 VSS.n365 VSS.t1706 153.846
R5608 VSS.n353 VSS.t1000 153.846
R5609 VSS.n339 VSS.t1721 153.846
R5610 VSS.n326 VSS.t1004 153.846
R5611 VSS.n312 VSS.t1880 153.846
R5612 VSS.n298 VSS.t995 153.846
R5613 VSS.t2074 VSS.n2980 153.846
R5614 VSS.t1540 VSS.n2991 153.846
R5615 VSS.t62 VSS.n3005 153.846
R5616 VSS.t1481 VSS.n3019 153.846
R5617 VSS.t1901 VSS.n3033 153.846
R5618 VSS.t1484 VSS.n3047 153.846
R5619 VSS.t68 VSS.n3061 153.846
R5620 VSS.t1738 VSS.n3075 153.846
R5621 VSS.t74 VSS.n3089 153.846
R5622 VSS.t1478 VSS.n3103 153.846
R5623 VSS.t2000 VSS.n3117 153.846
R5624 VSS.t1486 VSS.n3131 153.846
R5625 VSS.t71 VSS.n3145 153.846
R5626 VSS.t1740 VSS.n3159 153.846
R5627 VSS.t77 VSS.n3173 153.846
R5628 VSS.t1899 VSS.n3187 153.846
R5629 VSS.t65 VSS.n3201 153.846
R5630 VSS.t208 VSS.n2700 153.846
R5631 VSS.t1745 VSS.n2708 153.846
R5632 VSS.t1762 VSS.n2716 153.846
R5633 VSS.t1439 VSS.n2724 153.846
R5634 VSS.t1872 VSS.n2732 153.846
R5635 VSS.t1442 VSS.n2740 153.846
R5636 VSS.t1767 VSS.n2749 153.846
R5637 VSS.t1374 VSS.n2756 153.846
R5638 VSS.t1791 VSS.n2764 153.846
R5639 VSS.t1436 VSS.n2773 153.846
R5640 VSS.t486 VSS.n2780 153.846
R5641 VSS.t1444 VSS.n2788 153.846
R5642 VSS.t1769 VSS.n2797 153.846
R5643 VSS.t1376 VSS.n2804 153.846
R5644 VSS.t1793 VSS.n2812 153.846
R5645 VSS.t2246 VSS.n2820 153.846
R5646 VSS.t1764 VSS.n2827 153.846
R5647 VSS.t2345 VSS.n1120 153.846
R5648 VSS.t551 VSS.n1127 153.846
R5649 VSS.t4 VSS.n1134 153.846
R5650 VSS.t242 VSS.n1141 153.846
R5651 VSS.t2249 VSS.n1148 153.846
R5652 VSS.t1684 VSS.n1155 153.846
R5653 VSS.t1690 VSS.n1162 153.846
R5654 VSS.t1893 VSS.n1169 153.846
R5655 VSS.t1835 VSS.n1176 153.846
R5656 VSS.t239 VSS.n1183 153.846
R5657 VSS.t1730 VSS.n1190 153.846
R5658 VSS.t1686 VSS.n1197 153.846
R5659 VSS.t1692 VSS.n1204 153.846
R5660 VSS.t1896 VSS.n1211 153.846
R5661 VSS.t1837 VSS.n1218 153.846
R5662 VSS.t1694 VSS.n1225 153.846
R5663 VSS.t7 VSS.n1232 153.846
R5664 VSS.n2549 VSS.t1975 153.846
R5665 VSS.n2539 VSS.t153 153.846
R5666 VSS.n2528 VSS.t2218 153.846
R5667 VSS.n2515 VSS.t1855 153.846
R5668 VSS.n2502 VSS.t1033 153.846
R5669 VSS.n2488 VSS.t1857 153.846
R5670 VSS.n2475 VSS.t27 153.846
R5671 VSS.n2463 VSS.t323 153.846
R5672 VSS.n2451 VSS.t405 153.846
R5673 VSS.n2440 VSS.t1852 153.846
R5674 VSS.n2426 VSS.t2192 153.846
R5675 VSS.n2414 VSS.t1082 153.846
R5676 VSS.n2403 VSS.t30 153.846
R5677 VSS.n2390 VSS.t1697 153.846
R5678 VSS.n2376 VSS.t408 153.846
R5679 VSS.n2362 VSS.t299 153.846
R5680 VSS.n2349 VSS.t24 153.846
R5681 VSS.t2022 VSS.n2559 153.327
R5682 VSS.t2135 VSS.n188 153.236
R5683 VSS.t124 VSS.n2978 153.236
R5684 VSS.t521 VSS.n873 153.236
R5685 VSS.t202 VSS.n80 153.236
R5686 VSS.n2557 VSS.t329 153.236
R5687 VSS.n1562 VSS.n983 152.106
R5688 VSS.t1463 VSS.n1008 150
R5689 VSS.t776 VSS.n518 148.827
R5690 VSS.t787 VSS.n527 148.827
R5691 VSS.t799 VSS.n536 148.827
R5692 VSS.t811 VSS.n544 148.827
R5693 VSS.t822 VSS.n553 148.827
R5694 VSS.t833 VSS.n562 148.827
R5695 VSS.t319 VSS.n6 147.453
R5696 VSS.n487 VSS.t1424 147.157
R5697 VSS.n475 VSS.t286 147.157
R5698 VSS.n461 VSS.t227 147.157
R5699 VSS.n450 VSS.t1962 147.157
R5700 VSS.n439 VSS.t1663 147.157
R5701 VSS.n427 VSS.t1888 147.157
R5702 VSS.n416 VSS.t1325 147.157
R5703 VSS.n403 VSS.t1226 147.157
R5704 VSS.n390 VSS.t235 147.157
R5705 VSS.n377 VSS.t237 147.157
R5706 VSS.n364 VSS.t1988 147.157
R5707 VSS.n352 VSS.t2057 147.157
R5708 VSS.n338 VSS.t2080 147.157
R5709 VSS.n325 VSS.t2085 147.157
R5710 VSS.n311 VSS.t2131 147.157
R5711 VSS.n297 VSS.t403 147.157
R5712 VSS.t2274 VSS.n2992 147.157
R5713 VSS.t212 VSS.n3006 147.157
R5714 VSS.t2211 VSS.n3020 147.157
R5715 VSS.t1238 VSS.n3034 147.157
R5716 VSS.t290 VSS.n3048 147.157
R5717 VSS.t22 VSS.n3062 147.157
R5718 VSS.t51 VSS.n3076 147.157
R5719 VSS.t1378 VSS.n3090 147.157
R5720 VSS.t1784 VSS.n3104 147.157
R5721 VSS.t1518 VSS.n3118 147.157
R5722 VSS.t1522 VSS.n3132 147.157
R5723 VSS.t1401 VSS.n3146 147.157
R5724 VSS.t1262 VSS.n3160 147.157
R5725 VSS.t219 VSS.n3174 147.157
R5726 VSS.t2143 VSS.n3188 147.157
R5727 VSS.t2198 VSS.n3202 147.157
R5728 VSS.n2959 VSS.t188 147.157
R5729 VSS.n2951 VSS.t1599 147.157
R5730 VSS.n2943 VSS.t1790 147.157
R5731 VSS.n2936 VSS.t1290 147.157
R5732 VSS.n2928 VSS.t504 147.157
R5733 VSS.n2922 VSS.t1371 147.157
R5734 VSS.n2914 VSS.t1827 147.157
R5735 VSS.n2906 VSS.t259 147.157
R5736 VSS.n2899 VSS.t2157 147.157
R5737 VSS.n2890 VSS.t1141 147.157
R5738 VSS.n2882 VSS.t2222 147.157
R5739 VSS.n2875 VSS.t2280 147.157
R5740 VSS.n2867 VSS.t470 147.157
R5741 VSS.n2859 VSS.t162 147.157
R5742 VSS.n2850 VSS.t2266 147.157
R5743 VSS.n2841 VSS.t2212 147.157
R5744 VSS.n2070 VSS.t1921 147.157
R5745 VSS.n2066 VSS.t1934 147.157
R5746 VSS.n2062 VSS.t1941 147.157
R5747 VSS.n2058 VSS.t1885 147.157
R5748 VSS.n2054 VSS.t1277 147.157
R5749 VSS.n2050 VSS.t1415 147.157
R5750 VSS.n2046 VSS.t1278 147.157
R5751 VSS.n2042 VSS.t1948 147.157
R5752 VSS.n2038 VSS.t1821 147.157
R5753 VSS.n2033 VSS.t95 147.157
R5754 VSS.n2029 VSS.t528 147.157
R5755 VSS.n2025 VSS.t1823 147.157
R5756 VSS.n2021 VSS.t1432 147.157
R5757 VSS.n2017 VSS.t96 147.157
R5758 VSS.n2012 VSS.t1657 147.157
R5759 VSS.n2008 VSS.t2233 147.157
R5760 VSS.n2538 VSS.t307 147.157
R5761 VSS.n2527 VSS.t217 147.157
R5762 VSS.n2514 VSS.t1387 147.157
R5763 VSS.n2501 VSS.t1393 147.157
R5764 VSS.n2487 VSS.t1476 147.157
R5765 VSS.n2474 VSS.t2355 147.157
R5766 VSS.n2461 VSS.t1264 147.157
R5767 VSS.n2450 VSS.t1757 147.157
R5768 VSS.n2439 VSS.t2142 147.157
R5769 VSS.n2424 VSS.t450 147.157
R5770 VSS.n2413 VSS.t2304 147.157
R5771 VSS.n2402 VSS.t1265 147.157
R5772 VSS.n2389 VSS.t985 147.157
R5773 VSS.n2375 VSS.t1831 147.157
R5774 VSS.n2361 VSS.t2312 147.157
R5775 VSS.n2348 VSS.t1477 147.157
R5776 VSS.n1040 VSS.t663 146.853
R5777 VSS.n1582 VSS.n1004 146.853
R5778 VSS.n1555 VSS.n1017 146.512
R5779 VSS.n1551 VSS.n1024 146.512
R5780 VSS.n1599 VSS.n1037 146.512
R5781 VSS.t931 VSS.n923 145.093
R5782 VSS.t884 VSS.n2162 145.093
R5783 VSS.t955 VSS.n288 145.093
R5784 VSS.t944 VSS.n3206 145.091
R5785 VSS.t896 VSS.n122 145.091
R5786 VSS.n1562 VSS.n984 144.138
R5787 VSS.n1594 VSS.t660 143.024
R5788 VSS.t489 VSS.n1017 139.536
R5789 VSS.t135 VSS.n986 139.536
R5790 VSS.n288 VSS.t951 138.404
R5791 VSS.t880 VSS.n2162 138.404
R5792 VSS.n923 VSS.t927 138.404
R5793 VSS.n3206 VSS.t940 138.403
R5794 VSS.n122 VSS.t892 138.403
R5795 VSS.t842 VSS.n570 137.311
R5796 VSS.n682 VSS.t1644 137.31
R5797 VSS.n645 VSS.t784 137.309
R5798 VSS.n631 VSS.t795 137.309
R5799 VSS.n609 VSS.t807 137.309
R5800 VSS.n596 VSS.t819 137.309
R5801 VSS.n583 VSS.t830 137.309
R5802 VSS.t654 VSS.n997 136.048
R5803 VSS.n2572 VSS.t1832 134.661
R5804 VSS.n694 VSS.t2077 133.78
R5805 VSS.t1249 VSS.n2977 133.78
R5806 VSS.n2104 VSS.t480 133.78
R5807 VSS.n1972 VSS.n1971 132.891
R5808 VSS.n1601 VSS.n1042 132.868
R5809 VSS.n1579 VSS.n999 132.559
R5810 VSS.n1579 VSS.n1000 132.559
R5811 VSS.t951 VSS.n285 131.974
R5812 VSS.t927 VSS.n922 131.974
R5813 VSS.n2163 VSS.t880 131.974
R5814 VSS.t940 VSS.n3205 131.971
R5815 VSS.t892 VSS.n110 131.971
R5816 VSS.n667 VSS.t2291 130.939
R5817 VSS.t2275 VSS.n615 130.939
R5818 VSS.t1156 VSS.n1012 129.071
R5819 VSS.t44 VSS.n1020 129.071
R5820 VSS.n1595 VSS.t1183 129.071
R5821 VSS.t661 VSS.n1032 129.071
R5822 VSS.n1572 VSS.t46 129.071
R5823 VSS.t274 VSS.n934 127.421
R5824 VSS.t2026 VSS.n2564 126.945
R5825 VSS.n1556 VSS.t1659 125.582
R5826 VSS.t533 VSS.n8 125.359
R5827 VSS.n938 VSS.t265 123.674
R5828 VSS.n2569 VSS.t1919 123.212
R5829 VSS.n292 VSS.t955 122.516
R5830 VSS.n2343 VSS.t884 122.516
R5831 VSS.n1801 VSS.n1619 122.129
R5832 VSS.n1577 VSS.t654 122.094
R5833 VSS.n1621 VSS.t1185 121.858
R5834 VSS.t2077 VSS.n188 120.691
R5835 VSS.n2978 VSS.t1249 120.691
R5836 VSS.t1152 VSS.n873 120.691
R5837 VSS.t480 VSS.n80 120.691
R5838 VSS.t2302 VSS.n2557 120.691
R5839 VSS.t2289 VSS.n675 119.422
R5840 VSS.t1659 VSS.n1013 118.606
R5841 VSS.t663 VSS.n1039 118.606
R5842 VSS.n1575 VSS.n995 118.606
R5843 VSS.t518 VSS.n941 118.249
R5844 VSS.t326 VSS.n2572 117.858
R5845 VSS.n3207 VSS.t944 117.058
R5846 VSS.n2838 VSS.t931 117.058
R5847 VSS.n2005 VSS.t896 117.058
R5848 VSS.t1165 VSS.n939 116.177
R5849 VSS.t2038 VSS.n2570 115.745
R5850 VSS.t48 VSS.n996 115.117
R5851 VSS.t175 VSS.n1613 112.174
R5852 VSS.n858 VSS.n856 112.15
R5853 VSS.n1582 VSS.t1778 111.888
R5854 VSS.n692 VSS.t94 109.198
R5855 VSS.t536 VSS.n782 109.198
R5856 VSS.t2060 VSS.n1071 109.198
R5857 VSS.n936 VSS.t1164 108.683
R5858 VSS.n2566 VSS.t2039 108.276
R5859 VSS.n493 VSS.t522 107.023
R5860 VSS.t1424 VSS.n486 107.023
R5861 VSS.n481 VSS.t427 107.023
R5862 VSS.t286 VSS.n474 107.023
R5863 VSS.t1323 VSS.n467 107.023
R5864 VSS.t227 VSS.n460 107.023
R5865 VSS.n455 VSS.t1950 107.023
R5866 VSS.t1962 VSS.n449 107.023
R5867 VSS.n444 VSS.t1961 107.023
R5868 VSS.t1663 VSS.n438 107.023
R5869 VSS.n433 VSS.t1973 107.023
R5870 VSS.t1888 VSS.n426 107.023
R5871 VSS.n421 VSS.t1454 107.023
R5872 VSS.t1325 VSS.n415 107.023
R5873 VSS.t1282 VSS.n409 107.023
R5874 VSS.t1226 VSS.n402 107.023
R5875 VSS.n395 VSS.t1225 107.023
R5876 VSS.t235 VSS.n389 107.023
R5877 VSS.n382 VSS.t1460 107.023
R5878 VSS.t237 VSS.n376 107.023
R5879 VSS.n370 VSS.t2031 107.023
R5880 VSS.t1988 VSS.n363 107.023
R5881 VSS.n358 VSS.t382 107.023
R5882 VSS.t2057 VSS.n351 107.023
R5883 VSS.n345 VSS.t2053 107.023
R5884 VSS.t2080 VSS.n337 107.023
R5885 VSS.n330 VSS.t2079 107.023
R5886 VSS.t2085 VSS.n324 107.023
R5887 VSS.n316 VSS.t2335 107.023
R5888 VSS.t2131 VSS.n310 107.023
R5889 VSS.t2105 VSS.n303 107.023
R5890 VSS.t403 VSS.n296 107.023
R5891 VSS.n2986 VSS.t2210 107.023
R5892 VSS.n2993 VSS.t2274 107.023
R5893 VSS.n3000 VSS.t1254 107.023
R5894 VSS.n3007 VSS.t212 107.023
R5895 VSS.n3014 VSS.t126 107.023
R5896 VSS.n3021 VSS.t2211 107.023
R5897 VSS.n3028 VSS.t2168 107.023
R5898 VSS.n3035 VSS.t1238 107.023
R5899 VSS.n3042 VSS.t19 107.023
R5900 VSS.n3049 VSS.t290 107.023
R5901 VSS.n3056 VSS.t500 107.023
R5902 VSS.n3063 VSS.t22 107.023
R5903 VSS.n3070 VSS.t2287 107.023
R5904 VSS.n3077 VSS.t51 107.023
R5905 VSS.n3084 VSS.t182 107.023
R5906 VSS.n3091 VSS.t1378 107.023
R5907 VSS.n3098 VSS.t1176 107.023
R5908 VSS.n3105 VSS.t1784 107.023
R5909 VSS.n3112 VSS.t1519 107.023
R5910 VSS.n3119 VSS.t1518 107.023
R5911 VSS.n3126 VSS.t1520 107.023
R5912 VSS.n3133 VSS.t1522 107.023
R5913 VSS.n3140 VSS.t216 107.023
R5914 VSS.n3147 VSS.t1401 107.023
R5915 VSS.n3154 VSS.t1307 107.023
R5916 VSS.n3161 VSS.t1262 107.023
R5917 VSS.n3168 VSS.t1654 107.023
R5918 VSS.n3175 VSS.t219 107.023
R5919 VSS.n3182 VSS.t1308 107.023
R5920 VSS.n3189 VSS.t2143 107.023
R5921 VSS.n3196 VSS.t2140 107.023
R5922 VSS.n3203 VSS.t2198 107.023
R5923 VSS.t1373 VSS.n2706 107.023
R5924 VSS.t188 VSS.n2709 107.023
R5925 VSS.t2202 VSS.n2713 107.023
R5926 VSS.t1599 VSS.n2717 107.023
R5927 VSS.n2722 VSS.t2206 107.023
R5928 VSS.t1790 VSS.n2725 107.023
R5929 VSS.t2205 VSS.n2730 107.023
R5930 VSS.t1290 VSS.n2734 107.023
R5931 VSS.t2270 VSS.n2737 107.023
R5932 VSS.t504 VSS.n2741 107.023
R5933 VSS.n2746 VSS.t1139 107.023
R5934 VSS.t1371 VSS.n2750 107.023
R5935 VSS.t1462 VSS.n2754 107.023
R5936 VSS.t1827 VSS.n2757 107.023
R5937 VSS.t197 VSS.n2761 107.023
R5938 VSS.t259 VSS.n2765 107.023
R5939 VSS.n2770 VSS.t112 107.023
R5940 VSS.t2157 VSS.n2774 107.023
R5941 VSS.t164 VSS.n2778 107.023
R5942 VSS.t1141 VSS.n2781 107.023
R5943 VSS.t843 VSS.n2785 107.023
R5944 VSS.t2222 VSS.n2789 107.023
R5945 VSS.n2794 VSS.t1774 107.023
R5946 VSS.t2280 VSS.n2798 107.023
R5947 VSS.t2331 VSS.n2802 107.023
R5948 VSS.t470 VSS.n2805 107.023
R5949 VSS.t2199 VSS.n2809 107.023
R5950 VSS.t162 VSS.n2813 107.023
R5951 VSS.t2117 VSS.n2817 107.023
R5952 VSS.t2266 VSS.n2821 107.023
R5953 VSS.t1017 VSS.n2825 107.023
R5954 VSS.t2212 VSS.n2828 107.023
R5955 VSS.t1922 VSS.n1125 107.023
R5956 VSS.t1921 VSS.n1128 107.023
R5957 VSS.n1132 VSS.t1344 107.023
R5958 VSS.t1934 VSS.n1135 107.023
R5959 VSS.t1931 VSS.n1139 107.023
R5960 VSS.t1941 VSS.n1142 107.023
R5961 VSS.t2359 VSS.n1146 107.023
R5962 VSS.t1885 VSS.n1150 107.023
R5963 VSS.n1153 VSS.t505 107.023
R5964 VSS.t1277 VSS.n1156 107.023
R5965 VSS.t1414 VSS.n1160 107.023
R5966 VSS.t1415 VSS.n1163 107.023
R5967 VSS.t2316 VSS.n1167 107.023
R5968 VSS.t1278 VSS.n1170 107.023
R5969 VSS.n1174 VSS.t509 107.023
R5970 VSS.t1948 VSS.n1177 107.023
R5971 VSS.t1421 VSS.n1181 107.023
R5972 VSS.t1821 VSS.n1184 107.023
R5973 VSS.n1188 VSS.t1822 107.023
R5974 VSS.t95 VSS.n1191 107.023
R5975 VSS.n1195 VSS.t524 107.023
R5976 VSS.t528 VSS.n1198 107.023
R5977 VSS.t1824 VSS.n1202 107.023
R5978 VSS.t1823 VSS.n1205 107.023
R5979 VSS.t1561 VSS.n1209 107.023
R5980 VSS.t1432 VSS.n1212 107.023
R5981 VSS.n1216 VSS.t2182 107.023
R5982 VSS.t96 VSS.n1219 107.023
R5983 VSS.t1623 VSS.n1223 107.023
R5984 VSS.t1657 VSS.n1226 107.023
R5985 VSS.t432 VSS.n1230 107.023
R5986 VSS.t2233 VSS.n1233 107.023
R5987 VSS.n2543 VSS.t1379 107.023
R5988 VSS.t307 VSS.n2537 107.023
R5989 VSS.n2532 VSS.t214 107.023
R5990 VSS.t217 VSS.n2525 107.023
R5991 VSS.n2519 VSS.t1391 107.023
R5992 VSS.t1387 VSS.n2513 107.023
R5993 VSS.t1398 VSS.n2507 107.023
R5994 VSS.t1393 VSS.n2500 107.023
R5995 VSS.n2492 VSS.t1471 107.023
R5996 VSS.t1476 VSS.n2486 107.023
R5997 VSS.t1402 VSS.n2479 107.023
R5998 VSS.t2355 VSS.n2472 107.023
R5999 VSS.n2466 VSS.t1620 107.023
R6000 VSS.t1264 VSS.n2460 107.023
R6001 VSS.n2455 VSS.t449 107.023
R6002 VSS.t1757 VSS.n2449 107.023
R6003 VSS.n2444 VSS.t2173 107.023
R6004 VSS.t2142 VSS.n2438 107.023
R6005 VSS.n2429 VSS.t2144 107.023
R6006 VSS.t450 VSS.n2423 107.023
R6007 VSS.n2418 VSS.t2305 107.023
R6008 VSS.t2304 VSS.n2412 107.023
R6009 VSS.n2407 VSS.t1311 107.023
R6010 VSS.t1265 VSS.n2401 107.023
R6011 VSS.t222 VSS.n2395 107.023
R6012 VSS.t985 VSS.n2388 107.023
R6013 VSS.t425 VSS.n2381 107.023
R6014 VSS.t1831 VSS.n2372 107.023
R6015 VSS.n2366 VSS.t88 107.023
R6016 VSS.t2312 VSS.n2360 107.023
R6017 VSS.t1273 VSS.n2354 107.023
R6018 VSS.t1477 VSS.n2347 107.023
R6019 VSS.n1055 VSS.t132 106.808
R6020 VSS.n1584 VSS.n1009 104.651
R6021 VSS.n1557 VSS.n1011 104.651
R6022 VSS.t318 VSS.n1025 104.651
R6023 VSS.n1549 VSS.n1029 104.651
R6024 VSS.n1597 VSS.n1032 104.651
R6025 VSS.n1566 VSS.n987 104.651
R6026 VSS.n1622 VSS.t2137 103.538
R6027 VSS.n1629 VSS.t168 103.379
R6028 VSS.t1183 VSS.n1029 101.163
R6029 VSS.n1548 VSS.t661 101.163
R6030 VSS.t393 VSS.n996 101.163
R6031 VSS.n508 VSS.t1274 100.344
R6032 VSS.n859 VSS.t1124 100.344
R6033 VSS.t2023 VSS.n2080 100.344
R6034 VSS.t946 VSS.n498 100.335
R6035 VSS.t358 VSS.n487 100.335
R6036 VSS.t992 VSS.n475 100.335
R6037 VSS.t1702 VSS.n461 100.335
R6038 VSS.t245 VSS.n450 100.335
R6039 VSS.t1704 VSS.n439 100.335
R6040 VSS.t998 VSS.n427 100.335
R6041 VSS.t1719 VSS.n416 100.335
R6042 VSS.t1002 VSS.n403 100.335
R6043 VSS.t1699 VSS.n390 100.335
R6044 VSS.t248 VSS.n377 100.335
R6045 VSS.t1706 VSS.n364 100.335
R6046 VSS.t1000 VSS.n352 100.335
R6047 VSS.t1721 VSS.n338 100.335
R6048 VSS.t1004 VSS.n325 100.335
R6049 VSS.t1880 VSS.n311 100.335
R6050 VSS.t995 VSS.n297 100.335
R6051 VSS.n2980 VSS.t934 100.335
R6052 VSS.n2992 VSS.t1540 100.335
R6053 VSS.n3006 VSS.t62 100.335
R6054 VSS.n3020 VSS.t1481 100.335
R6055 VSS.n3034 VSS.t1901 100.335
R6056 VSS.n3048 VSS.t1484 100.335
R6057 VSS.n3062 VSS.t68 100.335
R6058 VSS.n3076 VSS.t1738 100.335
R6059 VSS.n3090 VSS.t74 100.335
R6060 VSS.n3104 VSS.t1478 100.335
R6061 VSS.n3118 VSS.t2000 100.335
R6062 VSS.n3132 VSS.t1486 100.335
R6063 VSS.n3146 VSS.t71 100.335
R6064 VSS.n3160 VSS.t1740 100.335
R6065 VSS.n3174 VSS.t77 100.335
R6066 VSS.n3188 VSS.t1899 100.335
R6067 VSS.n3202 VSS.t65 100.335
R6068 VSS.t922 VSS.n2700 100.335
R6069 VSS.n2959 VSS.t1745 100.335
R6070 VSS.n2951 VSS.t1762 100.335
R6071 VSS.n2943 VSS.t1439 100.335
R6072 VSS.n2936 VSS.t1872 100.335
R6073 VSS.n2928 VSS.t1442 100.335
R6074 VSS.n2922 VSS.t1767 100.335
R6075 VSS.n2914 VSS.t1374 100.335
R6076 VSS.n2906 VSS.t1791 100.335
R6077 VSS.n2899 VSS.t1436 100.335
R6078 VSS.n2890 VSS.t486 100.335
R6079 VSS.n2882 VSS.t1444 100.335
R6080 VSS.n2875 VSS.t1769 100.335
R6081 VSS.n2867 VSS.t1376 100.335
R6082 VSS.n2859 VSS.t1793 100.335
R6083 VSS.n2850 VSS.t2246 100.335
R6084 VSS.n2841 VSS.t1764 100.335
R6085 VSS.t886 VSS.n1120 100.335
R6086 VSS.n2070 VSS.t551 100.335
R6087 VSS.n2066 VSS.t4 100.335
R6088 VSS.n2062 VSS.t242 100.335
R6089 VSS.n2058 VSS.t2249 100.335
R6090 VSS.n2054 VSS.t1684 100.335
R6091 VSS.n2050 VSS.t1690 100.335
R6092 VSS.n2046 VSS.t1893 100.335
R6093 VSS.n2042 VSS.t1835 100.335
R6094 VSS.n2038 VSS.t239 100.335
R6095 VSS.n2033 VSS.t1730 100.335
R6096 VSS.n2029 VSS.t1686 100.335
R6097 VSS.n2025 VSS.t1692 100.335
R6098 VSS.n2021 VSS.t1896 100.335
R6099 VSS.n2017 VSS.t1837 100.335
R6100 VSS.n2012 VSS.t1694 100.335
R6101 VSS.n2008 VSS.t7 100.335
R6102 VSS.t874 VSS.n2549 100.335
R6103 VSS.t153 VSS.n2538 100.335
R6104 VSS.t2218 VSS.n2527 100.335
R6105 VSS.t1855 VSS.n2514 100.335
R6106 VSS.t1033 VSS.n2501 100.335
R6107 VSS.t1857 VSS.n2487 100.335
R6108 VSS.t27 VSS.n2474 100.335
R6109 VSS.t323 VSS.n2461 100.335
R6110 VSS.t405 VSS.n2450 100.335
R6111 VSS.t1852 VSS.n2439 100.335
R6112 VSS.t2192 VSS.n2424 100.335
R6113 VSS.t1082 VSS.n2413 100.335
R6114 VSS.t30 VSS.n2402 100.335
R6115 VSS.t1697 VSS.n2389 100.335
R6116 VSS.t408 VSS.n2375 100.335
R6117 VSS.t299 VSS.n2361 100.335
R6118 VSS.t24 VSS.n2348 100.335
R6119 VSS.n1802 VSS.t912 99.7511
R6120 VSS.t918 VSS.n1803 99.7511
R6121 VSS.n1628 VSS.t1648 98.4633
R6122 VSS.t912 VSS.n8 97.9276
R6123 VSS.n4 VSS.t918 97.9266
R6124 VSS.n931 VSS.t476 97.4396
R6125 VSS.n512 VSS.t255 97.3935
R6126 VSS.n867 VSS.t1516 97.3935
R6127 VSS.n2083 VSS.t2066 97.3935
R6128 VSS.n2561 VSS.t2021 97.0758
R6129 VSS.n680 VSS.t2288 96.3896
R6130 VSS.n514 VSS.t1011 94.4422
R6131 VSS.n871 VSS.t1994 94.4422
R6132 VSS.t2044 VSS.n2084 94.4422
R6133 VSS.n1599 VSS.t662 94.1866
R6134 VSS.t276 VSS.n933 93.8889
R6135 VSS.t133 VSS.n931 93.6919
R6136 VSS.t2028 VSS.n2563 93.5889
R6137 VSS.t1833 VSS.n2561 93.3421
R6138 VSS.t1800 VSS.n178 91.4909
R6139 VSS.t1135 VSS.n773 91.4909
R6140 VSS.t2068 VSS.n1064 91.4909
R6141 VSS.t1362 VSS.n1041 90.9096
R6142 VSS.n1586 VSS.n1013 90.6982
R6143 VSS.n1594 VSS.n1027 90.6982
R6144 VSS.n1565 VSS.n985 90.6982
R6145 VSS.n1572 VSS.n992 90.6982
R6146 VSS.n3205 VSS.t66 88.495
R6147 VSS.t8 VSS.n110 88.495
R6148 VSS.t996 VSS.n285 88.4947
R6149 VSS.t1765 VSS.n922 88.4945
R6150 VSS.t25 VSS.n2163 88.4945
R6151 VSS.n942 VSS.t1150 88.4111
R6152 VSS.t36 VSS.n1625 88.3462
R6153 VSS.t1703 VSS.n208 88.2366
R6154 VSS.t246 VSS.n215 88.2366
R6155 VSS.t999 VSS.n230 88.2366
R6156 VSS.t1720 VSS.n237 88.2366
R6157 VSS.t1707 VSS.n260 88.2366
R6158 VSS.n3009 VSS.t63 88.2366
R6159 VSS.n3051 VSS.t1485 88.2366
R6160 VSS.n3149 VSS.t72 88.2366
R6161 VSS.t552 VSS.n111 88.2366
R6162 VSS.t2250 VSS.n113 88.2366
R6163 VSS.t1894 VSS.n115 88.2366
R6164 VSS.t1731 VSS.n117 88.2366
R6165 VSS.t1858 VSS.n2189 88.2366
R6166 VSS.t28 VSS.n2186 88.2366
R6167 VSS.t406 VSS.n2180 88.2366
R6168 VSS.t1853 VSS.n2178 88.2366
R6169 VSS.t1083 VSS.n2171 88.2366
R6170 VSS.t31 VSS.n2169 88.2366
R6171 VSS.t1698 VSS.n2168 88.2366
R6172 VSS.t409 VSS.n2167 88.2366
R6173 VSS.t300 VSS.n2164 88.2366
R6174 VSS.t154 VSS.n2119 88.2359
R6175 VSS.t2219 VSS.n2523 88.2359
R6176 VSS.t1856 VSS.n2124 88.2359
R6177 VSS.t1034 VSS.n2128 88.2359
R6178 VSS.t324 VSS.n2134 88.2359
R6179 VSS.t2193 VSS.n2141 88.2359
R6180 VSS.t359 VSS.n198 88.2359
R6181 VSS.t993 VSS.n472 88.2359
R6182 VSS.t1705 VSS.n224 88.2359
R6183 VSS.t1003 VSS.n400 88.2359
R6184 VSS.t1700 VSS.n247 88.2359
R6185 VSS.t249 VSS.n255 88.2359
R6186 VSS.t1001 VSS.n349 88.2359
R6187 VSS.t1722 VSS.n335 88.2359
R6188 VSS.t1005 VSS.n322 88.2359
R6189 VSS.t1881 VSS.n282 88.2359
R6190 VSS.n2995 VSS.t1541 88.2359
R6191 VSS.n3023 VSS.t1482 88.2359
R6192 VSS.n3037 VSS.t1902 88.2359
R6193 VSS.n3065 VSS.t69 88.2359
R6194 VSS.n3079 VSS.t1739 88.2359
R6195 VSS.n3093 VSS.t75 88.2359
R6196 VSS.n3107 VSS.t1479 88.2359
R6197 VSS.n3121 VSS.t2001 88.2359
R6198 VSS.n3135 VSS.t1487 88.2359
R6199 VSS.n3163 VSS.t1741 88.2359
R6200 VSS.n3177 VSS.t78 88.2359
R6201 VSS.n3191 VSS.t1900 88.2359
R6202 VSS.t5 VSS.n159 88.2359
R6203 VSS.t243 VSS.n155 88.2359
R6204 VSS.t1685 VSS.n151 88.2359
R6205 VSS.t1691 VSS.n147 88.2359
R6206 VSS.t1836 VSS.n143 88.2359
R6207 VSS.t240 VSS.n139 88.2359
R6208 VSS.t1687 VSS.n136 88.2359
R6209 VSS.t1693 VSS.n132 88.2359
R6210 VSS.t1897 VSS.n104 88.2359
R6211 VSS.t1838 VSS.n129 88.2359
R6212 VSS.t1695 VSS.n125 88.2359
R6213 VSS.t1746 VSS.n2957 88.2357
R6214 VSS.t1763 VSS.n2949 88.2357
R6215 VSS.t1440 VSS.n2941 88.2357
R6216 VSS.t1873 VSS.n2934 88.2357
R6217 VSS.t1443 VSS.n2926 88.2357
R6218 VSS.t1768 VSS.n2920 88.2357
R6219 VSS.t1375 VSS.n2912 88.2357
R6220 VSS.t1792 VSS.n2904 88.2357
R6221 VSS.t1437 VSS.n2897 88.2357
R6222 VSS.t487 VSS.n2888 88.2357
R6223 VSS.t1445 VSS.n2880 88.2357
R6224 VSS.t1770 VSS.n2873 88.2357
R6225 VSS.t1377 VSS.n2865 88.2357
R6226 VSS.t1794 VSS.n2857 88.2357
R6227 VSS.t2247 VSS.n2848 88.2357
R6228 VSS.n2573 VSS.t2300 88.133
R6229 VSS.n2004 VSS.n123 88.2779
R6230 VSS.t50 VSS.n1012 87.2098
R6231 VSS.t658 VSS.n1021 87.2098
R6232 VSS.n1549 VSS.t1343 87.2098
R6233 VSS.n1569 VSS.t571 87.2098
R6234 VSS.t2165 VSS.t946 86.957
R6235 VSS.t2166 VSS.t948 86.957
R6236 VSS.t934 VSS.t2073 86.957
R6237 VSS.t936 VSS.t2074 86.957
R6238 VSS.t206 VSS.t922 86.957
R6239 VSS.t924 VSS.t208 86.957
R6240 VSS.t2344 VSS.t886 86.957
R6241 VSS.t888 VSS.t2345 86.957
R6242 VSS.t1974 VSS.t874 86.957
R6243 VSS.t1975 VSS.t876 86.957
R6244 VSS.t1801 VSS.n180 85.5883
R6245 VSS.t1134 VSS.n775 85.5883
R6246 VSS.t2067 VSS.n1066 85.5883
R6247 VSS.t433 VSS.n680 84.8733
R6248 VSS.n2971 VSS.t1150 83.0562
R6249 VSS.n2580 VSS.t2300 82.7875
R6250 VSS.t1151 VSS.n936 82.449
R6251 VSS.t2301 VSS.n2566 82.1411
R6252 VSS.t38 VSS.n1623 81.2384
R6253 VSS.n3215 VSS.t1617 81.1613
R6254 VSS.n770 VSS.t121 81.1613
R6255 VSS.n2113 VSS.t199 81.1613
R6256 VSS.n7 VSS.t533 80.4712
R6257 VSS.n2837 VSS.n2831 80.2681
R6258 VSS.t651 VSS.n988 80.2331
R6259 VSS.n793 VSS.t689 78.9856
R6260 VSS.n802 VSS.t697 78.9856
R6261 VSS.n811 VSS.t704 78.9856
R6262 VSS.n830 VSS.t711 78.9856
R6263 VSS.n838 VSS.t717 78.9856
R6264 VSS.n846 VSS.t724 78.9856
R6265 VSS.t576 VSS.n2294 78.9856
R6266 VSS.t588 VSS.n2278 78.9856
R6267 VSS.t599 VSS.n2262 78.9856
R6268 VSS.t611 VSS.n2235 78.9856
R6269 VSS.t623 VSS.n2219 78.9856
R6270 VSS.t634 VSS.n2201 78.9856
R6271 VSS.n978 VSS.t645 78.9856
R6272 VSS.n705 VSS.t732 78.9856
R6273 VSS.n714 VSS.t740 78.9856
R6274 VSS.n723 VSS.t747 78.9856
R6275 VSS.n741 VSS.t753 78.9856
R6276 VSS.n749 VSS.t761 78.9856
R6277 VSS.n757 VSS.t768 78.9856
R6278 VSS.n1784 VSS.t1239 77.8798
R6279 VSS.n1589 VSS.n1019 77.8593
R6280 VSS.n1590 VSS.n1022 77.8593
R6281 VSS.n1578 VSS.n998 77.8593
R6282 VSS.n1968 VSS.t1227 77.2751
R6283 VSS.t1018 VSS.t1180 77.2751
R6284 VSS.n1588 VSS.n1018 76.7447
R6285 VSS.n1545 VSS.n1038 76.7447
R6286 VSS.n1576 VSS.n997 76.7447
R6287 VSS.n506 VSS.t92 76.7344
R6288 VSS.n855 VSS.t535 76.7344
R6289 VSS.t2059 VSS.n2078 76.7344
R6290 VSS.n1969 VSS.t1806 75.4357
R6291 VSS.n937 VSS.t1151 75.2962
R6292 VSS.n2568 VSS.t2301 75.0671
R6293 VSS.n939 VSS.t263 74.9537
R6294 VSS.n504 VSS.t2165 74.8587
R6295 VSS.n164 VSS.t2344 74.8587
R6296 VSS.t2073 VSS.n2979 74.8579
R6297 VSS.n2969 VSS.t206 74.8578
R6298 VSS.n2555 VSS.t1974 74.8578
R6299 VSS.t1293 VSS.n1970 74.7824
R6300 VSS.n2570 VSS.t1917 74.6738
R6301 VSS.t1354 VSS.n677 73.9682
R6302 VSS.n506 VSS.t1012 73.7831
R6303 VSS.n855 VSS.t1995 73.7831
R6304 VSS.n2078 VSS.t2045 73.7831
R6305 VSS.t1182 VSS.n1614 73.536
R6306 VSS.n1800 VSS.n1615 73.536
R6307 VSS.n1557 VSS.t50 73.2563
R6308 VSS.t1343 VSS.n1028 73.2563
R6309 VSS.n493 VSS.t346 70.2346
R6310 VSS.n481 VSS.t1712 70.2346
R6311 VSS.n467 VSS.t1879 70.2346
R6312 VSS.n455 VSS.t335 70.2346
R6313 VSS.n444 VSS.t353 70.2346
R6314 VSS.n433 VSS.t338 70.2346
R6315 VSS.n421 VSS.t362 70.2346
R6316 VSS.n409 VSS.t1300 70.2346
R6317 VSS.n395 VSS.t348 70.2346
R6318 VSS.n382 VSS.t332 70.2346
R6319 VSS.n370 VSS.t351 70.2346
R6320 VSS.n358 VSS.t356 70.2346
R6321 VSS.n345 VSS.t365 70.2346
R6322 VSS.n330 VSS.t1303 70.2346
R6323 VSS.n316 VSS.t1876 70.2346
R6324 VSS.n303 VSS.t1709 70.2346
R6325 VSS.t1531 VSS.n2986 70.2346
R6326 VSS.t1734 VSS.n3000 70.2346
R6327 VSS.t1905 VSS.n3014 70.2346
R6328 VSS.t1665 VSS.n3028 70.2346
R6329 VSS.t1538 VSS.n3042 70.2346
R6330 VSS.t1667 VSS.n3056 70.2346
R6331 VSS.t1997 VSS.n3070 70.2346
R6332 VSS.t1671 VSS.n3084 70.2346
R6333 VSS.t1534 VSS.n3098 70.2346
R6334 VSS.t1652 VSS.n3112 70.2346
R6335 VSS.t1536 VSS.n3126 70.2346
R6336 VSS.t1669 VSS.n3140 70.2346
R6337 VSS.t1999 VSS.n3154 70.2346
R6338 VSS.t1673 VSS.n3168 70.2346
R6339 VSS.t1907 VSS.n3182 70.2346
R6340 VSS.t1736 VSS.n3196 70.2346
R6341 VSS.n2706 VSS.t1076 70.2346
R6342 VSS.t1450 VSS.n2713 70.2346
R6343 VSS.t2245 VSS.n2722 70.2346
R6344 VSS.n2730 VSS.t2111 70.2346
R6345 VSS.t1078 VSS.n2737 70.2346
R6346 VSS.n2746 VSS.t2113 70.2346
R6347 VSS.n2754 VSS.t1748 70.2346
R6348 VSS.t1869 VSS.n2761 70.2346
R6349 VSS.t1743 VSS.n2770 70.2346
R6350 VSS.n2778 VSS.t2108 70.2346
R6351 VSS.t1081 VSS.n2785 70.2346
R6352 VSS.t1867 VSS.n2794 70.2346
R6353 VSS.n2802 VSS.t1751 70.2346
R6354 VSS.t1871 VSS.n2809 70.2346
R6355 VSS.t2242 VSS.n2817 70.2346
R6356 VSS.t1447 VSS.n2825 70.2346
R6357 VSS.t1680 VSS.n1125 70.2346
R6358 VSS.t1689 VSS.n1132 70.2346
R6359 VSS.t566 VSS.n1139 70.2346
R6360 VSS.t2009 VSS.n1146 70.2346
R6361 VSS.t549 VSS.n1153 70.2346
R6362 VSS.t2011 VSS.n1160 70.2346
R6363 VSS.t148 VSS.n1167 70.2346
R6364 VSS.t2015 VSS.n1174 70.2346
R6365 VSS.t1683 VSS.n1181 70.2346
R6366 VSS.t2006 VSS.n1188 70.2346
R6367 VSS.t2195 VSS.n1195 70.2346
R6368 VSS.t2013 VSS.n1202 70.2346
R6369 VSS.n1209 VSS.t151 70.2346
R6370 VSS.t2017 VSS.n1216 70.2346
R6371 VSS.t2003 VSS.n1223 70.2346
R6372 VSS.n1230 VSS.t1892 70.2346
R6373 VSS.n2543 VSS.t1328 70.2346
R6374 VSS.n2532 VSS.t2253 70.2346
R6375 VSS.n2519 VSS.t445 70.2346
R6376 VSS.n2507 VSS.t401 70.2346
R6377 VSS.n2492 VSS.t538 70.2346
R6378 VSS.n2479 VSS.t2187 70.2346
R6379 VSS.n2466 VSS.t106 70.2346
R6380 VSS.n2455 VSS.t312 70.2346
R6381 VSS.n2444 VSS.t1849 70.2346
R6382 VSS.n2429 VSS.t398 70.2346
R6383 VSS.n2418 VSS.t2238 70.2346
R6384 VSS.n2407 VSS.t2190 70.2346
R6385 VSS.n2395 VSS.t1127 70.2346
R6386 VSS.n2381 VSS.t315 70.2346
R6387 VSS.n2366 VSS.t1071 70.2346
R6388 VSS.n2354 VSS.t2256 70.2346
R6389 VSS.n1555 VSS.t1157 69.7679
R6390 VSS.t871 VSS.n1023 69.7679
R6391 VSS.n1760 VSS.t864 69.1047
R6392 VSS.t1786 VSS.n968 68.9334
R6393 VSS.t778 VSS.n523 68.21
R6394 VSS.t789 VSS.n532 68.21
R6395 VSS.t801 VSS.n540 68.21
R6396 VSS.t813 VSS.n549 68.21
R6397 VSS.t824 VSS.n558 68.21
R6398 VSS.t835 VSS.n566 68.21
R6399 VSS.t1292 VSS.n970 67.4615
R6400 VSS.t263 VSS.n938 67.4583
R6401 VSS.t1917 VSS.n2569 67.2065
R6402 VSS.t1241 VSS.n1740 66.9109
R6403 VSS.t1553 VSS.n491 66.8901
R6404 VSS.n490 VSS.t1177 66.8901
R6405 VSS.n479 VSS.t2180 66.8901
R6406 VSS.n478 VSS.t33 66.8901
R6407 VSS.n465 VSS.t1559 66.8901
R6408 VSS.n464 VSS.t388 66.8901
R6409 VSS.n454 VSS.t1826 66.8901
R6410 VSS.n453 VSS.t856 66.8901
R6411 VSS.n443 VSS.t2235 66.8901
R6412 VSS.n442 VSS.t2297 66.8901
R6413 VSS.n431 VSS.t1675 66.8901
R6414 VSS.n430 VSS.t2091 66.8901
R6415 VSS.n420 VSS.t1677 66.8901
R6416 VSS.n419 VSS.t850 66.8901
R6417 VSS.n407 VSS.t1502 66.8901
R6418 VSS.n406 VSS.t261 66.8901
R6419 VSS.n394 VSS.t2184 66.8901
R6420 VSS.n393 VSS.t1600 66.8901
R6421 VSS.n381 VSS.t1985 66.8901
R6422 VSS.n380 VSS.t2290 66.8901
R6423 VSS.t1889 VSS.n368 66.8901
R6424 VSS.n367 VSS.t176 66.8901
R6425 VSS.t2372 VSS.n356 66.8901
R6426 VSS.n355 VSS.t2152 66.8901
R6427 VSS.t2055 VSS.n342 66.8901
R6428 VSS.n341 VSS.t1028 66.8901
R6429 VSS.n329 VSS.t2089 66.8901
R6430 VSS.n328 VSS.t1628 66.8901
R6431 VSS.n315 VSS.t2127 66.8901
R6432 VSS.n314 VSS.t2367 66.8901
R6433 VSS.t2130 VSS.n301 66.8901
R6434 VSS.n300 VSS.t1158 66.8901
R6435 VSS.n2989 VSS.t1614 66.8901
R6436 VSS.t2048 VSS.n2990 66.8901
R6437 VSS.n3003 VSS.t2214 66.8901
R6438 VSS.t1946 VSS.n3004 66.8901
R6439 VSS.n3017 VSS.t2096 66.8901
R6440 VSS.t2019 VSS.n3018 66.8901
R6441 VSS.n3031 VSS.t2299 66.8901
R6442 VSS.t1909 VSS.n3032 66.8901
R6443 VSS.n3045 VSS.t2123 66.8901
R6444 VSS.t2032 VSS.n3046 66.8901
R6445 VSS.n3059 VSS.t1637 66.8901
R6446 VSS.t1979 VSS.n3060 66.8901
R6447 VSS.n3073 VSS.t1798 66.8901
R6448 VSS.t1971 VSS.n3074 66.8901
R6449 VSS.n3087 VSS.t2273 66.8901
R6450 VSS.t1956 VSS.n3088 66.8901
R6451 VSS.n3101 VSS.t492 66.8901
R6452 VSS.t1925 VSS.n3102 66.8901
R6453 VSS.n3115 VSS.t2170 66.8901
R6454 VSS.t1911 VSS.n3116 66.8901
R6455 VSS.n3129 VSS.t1804 66.8901
R6456 VSS.t2034 VSS.n3130 66.8901
R6457 VSS.n3143 VSS.t53 66.8901
R6458 VSS.t1980 VSS.n3144 66.8901
R6459 VSS.n3157 VSS.t1396 66.8901
R6460 VSS.t1972 VSS.n3158 66.8901
R6461 VSS.n3171 VSS.t1199 66.8901
R6462 VSS.t1960 VSS.n3172 66.8901
R6463 VSS.n3185 VSS.t1404 66.8901
R6464 VSS.t1949 VSS.n3186 66.8901
R6465 VSS.n3199 VSS.t1753 66.8901
R6466 VSS.t1933 VSS.n3200 66.8901
R6467 VSS.t180 VSS.n2707 66.8901
R6468 VSS.n2960 VSS.t2281 66.8901
R6469 VSS.t2351 VSS.n2715 66.8901
R6470 VSS.n2952 VSS.t256 66.8901
R6471 VSS.t297 VSS.n2723 66.8901
R6472 VSS.n2944 VSS.t1639 66.8901
R6473 VSS.t1789 VSS.n2731 66.8901
R6474 VSS.n2937 VSS.t1236 66.8901
R6475 VSS.t390 VSS.n2739 66.8901
R6476 VSS.n2929 VSS.t166 66.8901
R6477 VSS.n2748 VSS.t2278 66.8901
R6478 VSS.n2923 VSS.t204 66.8901
R6479 VSS.t1117 VSS.n2755 66.8901
R6480 VSS.n2915 VSS.t1235 66.8901
R6481 VSS.t269 VSS.n2763 66.8901
R6482 VSS.n2907 VSS.t1345 66.8901
R6483 VSS.n2772 VSS.t2284 66.8901
R6484 VSS.n2900 VSS.t852 66.8901
R6485 VSS.t2200 VSS.n2779 66.8901
R6486 VSS.n2891 VSS.t1154 66.8901
R6487 VSS.t514 VSS.n2787 66.8901
R6488 VSS.n2883 VSS.t116 66.8901
R6489 VSS.n2796 VSS.t1610 66.8901
R6490 VSS.n2876 VSS.t1288 66.8901
R6491 VSS.t1252 VSS.n2803 66.8901
R6492 VSS.n2868 VSS.t2217 66.8901
R6493 VSS.t1149 VSS.n2811 66.8901
R6494 VSS.n2860 VSS.t971 66.8901
R6495 VSS.n2819 VSS.t2145 66.8901
R6496 VSS.n2851 VSS.t293 66.8901
R6497 VSS.t1631 VSS.n2826 66.8901
R6498 VSS.n2842 VSS.t2215 66.8901
R6499 VSS.n1126 VSS.t1927 66.8901
R6500 VSS.n2071 VSS.t2081 66.8901
R6501 VSS.n1133 VSS.t1412 66.8901
R6502 VSS.n2067 VSS.t2052 66.8901
R6503 VSS.t1347 VSS.n1140 66.8901
R6504 VSS.n2063 VSS.t2082 66.8901
R6505 VSS.n1147 VSS.t1009 66.8901
R6506 VSS.n2059 VSS.t2342 66.8901
R6507 VSS.n1154 VSS.t1491 66.8901
R6508 VSS.n2055 VSS.t2104 66.8901
R6509 VSS.t1218 VSS.n1161 66.8901
R6510 VSS.n2051 VSS.t2341 66.8901
R6511 VSS.n1168 VSS.t1320 66.8901
R6512 VSS.n2047 VSS.t2334 66.8901
R6513 VSS.n1175 VSS.t2319 66.8901
R6514 VSS.n2043 VSS.t2087 66.8901
R6515 VSS.t2176 VSS.n1182 66.8901
R6516 VSS.n2039 VSS.t2347 66.8901
R6517 VSS.n1189 VSS.t1419 66.8901
R6518 VSS.n2034 VSS.t2086 66.8901
R6519 VSS.n1196 VSS.t2179 66.8901
R6520 VSS.n2030 VSS.t2097 66.8901
R6521 VSS.t1428 VSS.n1203 66.8901
R6522 VSS.n2026 VSS.t2116 66.8901
R6523 VSS.n1210 VSS.t531 66.8901
R6524 VSS.n2022 VSS.t2102 66.8901
R6525 VSS.n1217 VSS.t1556 66.8901
R6526 VSS.n2018 VSS.t2133 66.8901
R6527 VSS.t1068 VSS.n1224 66.8901
R6528 VSS.n2013 VSS.t2343 66.8901
R6529 VSS.n1231 VSS.t232 66.8901
R6530 VSS.n2009 VSS.t2106 66.8901
R6531 VSS.n2541 VSS.t1259 66.8901
R6532 VSS.n2540 VSS.t1963 66.8901
R6533 VSS.n2530 VSS.t1381 66.8901
R6534 VSS.n2529 VSS.t1951 66.8901
R6535 VSS.n2517 VSS.t1527 66.8901
R6536 VSS.n2516 VSS.t1936 66.8901
R6537 VSS.n2504 VSS.t1469 66.8901
R6538 VSS.n2503 VSS.t1987 66.8901
R6539 VSS.t1190 VSS.n2490 66.8901
R6540 VSS.n2489 VSS.t1930 66.8901
R6541 VSS.n2477 VSS.t1474 66.8901
R6542 VSS.n2476 VSS.t1920 66.8901
R6543 VSS.n2465 VSS.t1043 66.8901
R6544 VSS.n2464 VSS.t1914 66.8901
R6545 VSS.n2453 VSS.t341 66.8901
R6546 VSS.n2452 VSS.t1913 66.8901
R6547 VSS.n2442 VSS.t2354 66.8901
R6548 VSS.n2441 VSS.t2029 66.8901
R6549 VSS.n2428 VSS.t1051 66.8901
R6550 VSS.n2427 VSS.t2018 66.8901
R6551 VSS.n2416 VSS.t2228 66.8901
R6552 VSS.n2415 VSS.t2035 66.8901
R6553 VSS.n2405 VSS.t80 66.8901
R6554 VSS.n2404 VSS.t1937 66.8901
R6555 VSS.t2306 VSS.n2392 66.8901
R6556 VSS.n2391 VSS.t1989 66.8901
R6557 VSS.t1312 VSS.n2378 66.8901
R6558 VSS.n2377 VSS.t1983 66.8901
R6559 VSS.n2364 VSS.t1315 66.8901
R6560 VSS.n2363 VSS.t1977 66.8901
R6561 VSS.t990 VSS.n2351 66.8901
R6562 VSS.n2350 VSS.t1969 66.8901
R6563 VSS.t691 VSS.n794 65.1012
R6564 VSS.t699 VSS.n803 65.1012
R6565 VSS.t706 VSS.n812 65.1012
R6566 VSS.t713 VSS.n831 65.1012
R6567 VSS.t719 VSS.n839 65.1012
R6568 VSS.t647 VSS.n979 65.1012
R6569 VSS.t734 VSS.n706 65.1012
R6570 VSS.t742 VSS.n715 65.1012
R6571 VSS.t749 VSS.n724 65.1012
R6572 VSS.t755 VSS.n742 65.1012
R6573 VSS.t763 VSS.n750 65.1012
R6574 VSS.t727 VSS.n848 65.0992
R6575 VSS.t771 VSS.n759 65.0992
R6576 VSS.n818 VSS.t173 65.0816
R6577 VSS.n2256 VSS.t2207 65.0816
R6578 VSS.n730 VSS.t969 65.0816
R6579 VSS.t1597 VSS.n180 64.9292
R6580 VSS.t171 VSS.n775 64.9292
R6581 VSS.t479 VSS.n1066 64.9292
R6582 VSS.t580 VSS.n2283 64.5832
R6583 VSS.t592 VSS.n2267 64.5832
R6584 VSS.t603 VSS.n2239 64.5832
R6585 VSS.t615 VSS.n2224 64.5832
R6586 VSS.t627 VSS.n2209 64.5832
R6587 VSS.t639 VSS.n2338 64.5832
R6588 VSS.n1560 VSS.n1006 64.0227
R6589 VSS.n1587 VSS.n1014 63.9058
R6590 VSS.n1546 VSS.n1035 63.9058
R6591 VSS.n934 VSS.t276 63.7107
R6592 VSS.n2564 VSS.t2028 63.4728
R6593 VSS.n1544 VSS.n1040 62.9376
R6594 VSS.n1543 VSS.n1043 62.9376
R6595 VSS.n1580 VSS.n1001 62.7912
R6596 VSS.t655 VSS.n1001 62.7912
R6597 VSS.n932 VSS.t133 62.4441
R6598 VSS.n2562 VSS.t1833 62.2523
R6599 VSS.n689 VSS.t1275 61.9779
R6600 VSS.t1125 VSS.n777 61.9779
R6601 VSS.n2091 VSS.t2025 61.9779
R6602 VSS.n675 VSS.t561 61.8407
R6603 VSS.n1800 VSS.n1618 59.3547
R6604 VSS.t1184 VSS.n1034 59.3028
R6605 VSS.t649 VSS.t158 59.3028
R6606 VSS.n1573 VSS.t848 59.3028
R6607 VSS.t253 VSS.n178 59.0266
R6608 VSS.t1515 VSS.n773 59.0266
R6609 VSS.t2064 VSS.n1064 59.0266
R6610 VSS.t476 VSS.n930 58.6964
R6611 VSS.t2021 VSS.n2560 58.5186
R6612 VSS.t860 VSS.n1650 58.1358
R6613 VSS.n1971 VSS.t1293 58.1084
R6614 VSS.n4 VSS.t319 58.0281
R6615 VSS.n784 VSS.t1147 57.6388
R6616 VSS.n820 VSS.t42 57.6388
R6617 VSS.t278 VSS.n2103 57.6388
R6618 VSS.n2255 VSS.t1915 57.6388
R6619 VSS.n696 VSS.t1619 57.6388
R6620 VSS.n732 VSS.t507 57.6388
R6621 VSS.n516 VSS.t1595 57.5509
R6622 VSS.n765 VSS.t169 57.5509
R6623 VSS.n2585 VSS.t478 57.5509
R6624 VSS.n613 VSS.t1549 56.6724
R6625 VSS.t782 VSS.n643 56.0825
R6626 VSS.t793 VSS.n629 56.0825
R6627 VSS.t805 VSS.n607 56.0825
R6628 VSS.t817 VSS.n594 56.0825
R6629 VSS.t828 VSS.n581 56.0825
R6630 VSS.n572 VSS.t840 56.0825
R6631 VSS.n1771 VSS.t858 55.942
R6632 VSS.t1351 VSS.t1162 55.8145
R6633 VSS.t1368 VSS.t393 55.8145
R6634 VSS.n942 VSS.t518 54.6841
R6635 VSS.t1595 VSS.n174 54.5996
R6636 VSS.t169 VSS.n764 54.5996
R6637 VSS.n2086 VSS.t478 54.5996
R6638 VSS.n2573 VSS.t326 54.532
R6639 VSS.t899 VSS.n1633 53.7482
R6640 VSS.t1785 VSS.n1056 53.4875
R6641 VSS.n512 VSS.t253 53.124
R6642 VSS.n867 VSS.t1515 53.124
R6643 VSS.n2083 VSS.t2064 53.124
R6644 VSS.n1970 VSS.t1808 52.3478
R6645 VSS.n1585 VSS.t1172 52.3261
R6646 VSS.n1049 VSS.t1787 51.4837
R6647 VSS.n1849 VSS.n1241 51.0224
R6648 VSS.n2003 VSS.n51 51.0224
R6649 VSS.n1541 VSS.n1247 50.7482
R6650 VSS.n1974 VSS.n1248 50.7482
R6651 VSS.n1975 VSS.n1249 50.7482
R6652 VSS.n1976 VSS.n1250 50.7482
R6653 VSS.n1977 VSS.n1251 50.7482
R6654 VSS.n1978 VSS.n1252 50.7482
R6655 VSS.n1979 VSS.n1253 50.7482
R6656 VSS.n1981 VSS.n1255 50.7482
R6657 VSS.n1984 VSS.n1258 50.7482
R6658 VSS.n1985 VSS.n1259 50.7482
R6659 VSS.n1986 VSS.n1260 50.7482
R6660 VSS.n1987 VSS.n1261 50.7482
R6661 VSS.n1988 VSS.n1262 50.7482
R6662 VSS.n1989 VSS.n1263 50.7482
R6663 VSS.n1990 VSS.n1264 50.7482
R6664 VSS.n1991 VSS.n1265 50.7482
R6665 VSS.n1992 VSS.n1266 50.7482
R6666 VSS.n1996 VSS.n1269 50.7482
R6667 VSS.n1997 VSS.n1270 50.7482
R6668 VSS.n1538 VSS.n1272 50.7482
R6669 VSS.n1407 VSS.n1273 50.7482
R6670 VSS.n1537 VSS.n1274 50.7482
R6671 VSS.n1408 VSS.n1275 50.7482
R6672 VSS.n1536 VSS.n1276 50.7482
R6673 VSS.n1535 VSS.n1278 50.7482
R6674 VSS.n1534 VSS.n1280 50.7482
R6675 VSS.n1411 VSS.n1281 50.7482
R6676 VSS.n1533 VSS.n1282 50.7482
R6677 VSS.n1532 VSS.n1284 50.7482
R6678 VSS.n1413 VSS.n1285 50.7482
R6679 VSS.n1531 VSS.n1286 50.7482
R6680 VSS.n1414 VSS.n1287 50.7482
R6681 VSS.n1415 VSS.n1289 50.7482
R6682 VSS.n1529 VSS.n1290 50.7482
R6683 VSS.n1416 VSS.n1291 50.7482
R6684 VSS.n1417 VSS.n1293 50.7482
R6685 VSS.n1527 VSS.n1294 50.7482
R6686 VSS.n1418 VSS.n1295 50.7482
R6687 VSS.n1419 VSS.n1297 50.7482
R6688 VSS.t669 VSS.n1298 50.7482
R6689 VSS.n1420 VSS.n1299 50.7482
R6690 VSS.n1525 VSS.n1300 50.7482
R6691 VSS.n1524 VSS.n1302 50.7482
R6692 VSS.n1422 VSS.n1303 50.7482
R6693 VSS.n1523 VSS.n1304 50.7482
R6694 VSS.n1423 VSS.n1305 50.7482
R6695 VSS.n1522 VSS.n1306 50.7482
R6696 VSS.n1424 VSS.n1307 50.7482
R6697 VSS.n1425 VSS.n1309 50.7482
R6698 VSS.n1520 VSS.n1310 50.7482
R6699 VSS.n1519 VSS.n1312 50.7482
R6700 VSS.n1427 VSS.n1313 50.7482
R6701 VSS.n1518 VSS.n1314 50.7482
R6702 VSS.n1428 VSS.n1315 50.7482
R6703 VSS.n1429 VSS.n1317 50.7482
R6704 VSS.n1516 VSS.n1318 50.7482
R6705 VSS.n1515 VSS.n1320 50.7482
R6706 VSS.n1431 VSS.n1321 50.7482
R6707 VSS.n1514 VSS.n1322 50.7482
R6708 VSS.n1513 VSS.n1324 50.7482
R6709 VSS.n1433 VSS.n1325 50.7482
R6710 VSS.n1512 VSS.n1326 50.7482
R6711 VSS.n1434 VSS.n1327 50.7482
R6712 VSS.n1435 VSS.n1329 50.7482
R6713 VSS.n1510 VSS.n1330 50.7482
R6714 VSS.n1436 VSS.n1331 50.7482
R6715 VSS.n1437 VSS.n1333 50.7482
R6716 VSS.n1508 VSS.n1334 50.7482
R6717 VSS.n1507 VSS.n1336 50.7482
R6718 VSS.n1439 VSS.n1337 50.7482
R6719 VSS.t677 VSS.n1338 50.7482
R6720 VSS.n1440 VSS.n1339 50.7482
R6721 VSS.n1506 VSS.n1340 50.7482
R6722 VSS.n1505 VSS.n1342 50.7482
R6723 VSS.n1442 VSS.n1343 50.7482
R6724 VSS.n1504 VSS.n1344 50.7482
R6725 VSS.n1443 VSS.n1345 50.7482
R6726 VSS.n1503 VSS.n1346 50.7482
R6727 VSS.n1444 VSS.n1347 50.7482
R6728 VSS.n1445 VSS.n1349 50.7482
R6729 VSS.n1501 VSS.n1350 50.7482
R6730 VSS.n1500 VSS.n1352 50.7482
R6731 VSS.n1447 VSS.n1353 50.7482
R6732 VSS.n1499 VSS.n1354 50.7482
R6733 VSS.n1498 VSS.n1356 50.7482
R6734 VSS.n1449 VSS.n1357 50.7482
R6735 VSS.n1497 VSS.n1358 50.7482
R6736 VSS.n1496 VSS.n1360 50.7482
R6737 VSS.n1451 VSS.n1361 50.7482
R6738 VSS.n1495 VSS.n1362 50.7482
R6739 VSS.n1494 VSS.n1364 50.7482
R6740 VSS.n1453 VSS.n1365 50.7482
R6741 VSS.n1493 VSS.n1366 50.7482
R6742 VSS.n1455 VSS.n1367 50.7482
R6743 VSS.n1456 VSS.n1369 50.7482
R6744 VSS.n1491 VSS.n1370 50.7482
R6745 VSS.n1457 VSS.n1371 50.7482
R6746 VSS.n1459 VSS.n1374 50.7482
R6747 VSS.n1460 VSS.n1376 50.7482
R6748 VSS.n1488 VSS.n1377 50.7482
R6749 VSS.n1461 VSS.n1378 50.7482
R6750 VSS.t684 VSS.n1379 50.7482
R6751 VSS.n1462 VSS.n1380 50.7482
R6752 VSS.n1487 VSS.n1381 50.7482
R6753 VSS.n1486 VSS.n1383 50.7482
R6754 VSS.n1464 VSS.n1384 50.7482
R6755 VSS.n1485 VSS.n1385 50.7482
R6756 VSS.n1465 VSS.n1386 50.7482
R6757 VSS.n1484 VSS.n1387 50.7482
R6758 VSS.n1466 VSS.n1388 50.7482
R6759 VSS.n1467 VSS.n1390 50.7482
R6760 VSS.n1482 VSS.n1391 50.7482
R6761 VSS.n1481 VSS.n1393 50.7482
R6762 VSS.n1480 VSS.n1395 50.7482
R6763 VSS.n1470 VSS.n1396 50.7482
R6764 VSS.n1479 VSS.n1397 50.7482
R6765 VSS.n1471 VSS.n1398 50.7482
R6766 VSS.n1478 VSS.n1399 50.7482
R6767 VSS.n1472 VSS.n1400 50.7482
R6768 VSS.n1477 VSS.n1401 50.7482
R6769 VSS.n1473 VSS.n1402 50.7482
R6770 VSS.n1476 VSS.n1403 50.7482
R6771 VSS.n1474 VSS.n1404 50.7482
R6772 VSS.n2000 VSS.n1999 50.7482
R6773 VSS.t1647 VSS.n667 50.3244
R6774 VSS.n615 VSS.t320 50.3244
R6775 VSS.t1275 VSS.n508 50.1727
R6776 VSS.n859 VSS.t1125 50.1727
R6777 VSS.t2025 VSS.n2080 50.1727
R6778 VSS.n494 VSS.t345 50.1677
R6779 VSS.n482 VSS.t1711 50.1677
R6780 VSS.n469 VSS.t1878 50.1677
R6781 VSS.n456 VSS.t334 50.1677
R6782 VSS.n445 VSS.t352 50.1677
R6783 VSS.n434 VSS.t337 50.1677
R6784 VSS.n422 VSS.t361 50.1677
R6785 VSS.n411 VSS.t1299 50.1677
R6786 VSS.n396 VSS.t347 50.1677
R6787 VSS.n383 VSS.t331 50.1677
R6788 VSS.n371 VSS.t350 50.1677
R6789 VSS.n359 VSS.t355 50.1677
R6790 VSS.n346 VSS.t364 50.1677
R6791 VSS.n331 VSS.t1302 50.1677
R6792 VSS.n317 VSS.t1875 50.1677
R6793 VSS.n305 VSS.t1708 50.1677
R6794 VSS.t1530 VSS.n2984 50.1677
R6795 VSS.t1733 VSS.n2998 50.1677
R6796 VSS.t1904 VSS.n3012 50.1677
R6797 VSS.t1664 VSS.n3026 50.1677
R6798 VSS.t1537 VSS.n3040 50.1677
R6799 VSS.t1666 VSS.n3054 50.1677
R6800 VSS.t1996 VSS.n3068 50.1677
R6801 VSS.t1670 VSS.n3082 50.1677
R6802 VSS.t1533 VSS.n3096 50.1677
R6803 VSS.t1651 VSS.n3110 50.1677
R6804 VSS.t1535 VSS.n3124 50.1677
R6805 VSS.t1668 VSS.n3138 50.1677
R6806 VSS.t1998 VSS.n3152 50.1677
R6807 VSS.t1672 VSS.n3166 50.1677
R6808 VSS.t1906 VSS.n3180 50.1677
R6809 VSS.t1735 VSS.n3194 50.1677
R6810 VSS.n2963 VSS.t1075 50.1677
R6811 VSS.n2955 VSS.t1449 50.1677
R6812 VSS.n2947 VSS.t2244 50.1677
R6813 VSS.n2940 VSS.t2110 50.1677
R6814 VSS.n2932 VSS.t1077 50.1677
R6815 VSS.n2924 VSS.t2112 50.1677
R6816 VSS.n2918 VSS.t1747 50.1677
R6817 VSS.n2910 VSS.t1868 50.1677
R6818 VSS.n2902 VSS.t1742 50.1677
R6819 VSS.n2894 VSS.t2107 50.1677
R6820 VSS.n2886 VSS.t1080 50.1677
R6821 VSS.n2878 VSS.t1866 50.1677
R6822 VSS.n2871 VSS.t1750 50.1677
R6823 VSS.n2863 VSS.t1870 50.1677
R6824 VSS.n2854 VSS.t2241 50.1677
R6825 VSS.n2846 VSS.t1446 50.1677
R6826 VSS.n2072 VSS.t1679 50.1677
R6827 VSS.n2068 VSS.t1688 50.1677
R6828 VSS.n2064 VSS.t565 50.1677
R6829 VSS.n2060 VSS.t2008 50.1677
R6830 VSS.n2056 VSS.t548 50.1677
R6831 VSS.n2052 VSS.t2010 50.1677
R6832 VSS.n2048 VSS.t147 50.1677
R6833 VSS.n2044 VSS.t2014 50.1677
R6834 VSS.n2040 VSS.t1682 50.1677
R6835 VSS.n2035 VSS.t2005 50.1677
R6836 VSS.n2031 VSS.t2194 50.1677
R6837 VSS.n2027 VSS.t2012 50.1677
R6838 VSS.n2023 VSS.t150 50.1677
R6839 VSS.n2019 VSS.t2016 50.1677
R6840 VSS.n2014 VSS.t2002 50.1677
R6841 VSS.n2010 VSS.t1891 50.1677
R6842 VSS.n2545 VSS.t1327 50.1677
R6843 VSS.n2533 VSS.t2252 50.1677
R6844 VSS.n2521 VSS.t444 50.1677
R6845 VSS.n2509 VSS.t400 50.1677
R6846 VSS.n2496 VSS.t537 50.1677
R6847 VSS.n2481 VSS.t2186 50.1677
R6848 VSS.n2468 VSS.t105 50.1677
R6849 VSS.n2457 VSS.t311 50.1677
R6850 VSS.n2445 VSS.t1848 50.1677
R6851 VSS.n2431 VSS.t397 50.1677
R6852 VSS.n2420 VSS.t2237 50.1677
R6853 VSS.n2408 VSS.t2189 50.1677
R6854 VSS.n2397 VSS.t1126 50.1677
R6855 VSS.n2383 VSS.t314 50.1677
R6856 VSS.n2367 VSS.t1070 50.1677
R6857 VSS.n2356 VSS.t2255 50.1677
R6858 VSS.n1052 VSS.t1173 50.0128
R6859 VSS.n1540 VSS.t195 50.0128
R6860 VSS.n1469 VSS.t1577 50.0128
R6861 VSS.n1558 VSS.n1010 49.9524
R6862 VSS.n1585 VSS.n1010 49.9524
R6863 VSS.n1755 VSS.t902 49.3606
R6864 VSS.t1777 VSS.n1043 48.9515
R6865 VSS.n1559 VSS.t1370 48.8377
R6866 VSS.t1157 VSS.n1016 48.8377
R6867 VSS.n1588 VSS.t489 48.8377
R6868 VSS.n1574 VSS.n994 48.8377
R6869 VSS.n1053 VSS.t1796 48.5418
R6870 VSS.t1573 VSS.n1355 47.8063
R6871 VSS.t1164 VSS.n935 47.4535
R6872 VSS.t2039 VSS.n2565 47.3176
R6873 VSS.n510 VSS.t1597 47.2214
R6874 VSS.n862 VSS.t171 47.2214
R6875 VSS.n2081 VSS.t479 47.2214
R6876 VSS.n1781 VSS.t1240 47.1669
R6877 VSS.t1242 VSS.n1643 47.1669
R6878 VSS.n1047 VSS.t160 46.737
R6879 VSS.n1980 VSS.t2221 46.3354
R6880 VSS.n1628 VSS.t1182 46.116
R6881 VSS.t1228 VSS.n963 45.5999
R6882 VSS.t131 VSS.n970 45.3982
R6883 VSS.n1586 VSS.t1156 45.3493
R6884 VSS.n1553 VSS.t658 45.3493
R6885 VSS.t46 VSS.n991 45.3493
R6886 VSS.t862 VSS.n1749 44.9731
R6887 VSS.n1530 VSS.t667 44.129
R6888 VSS.n1526 VSS.t1567 44.129
R6889 VSS.n1511 VSS.t675 44.129
R6890 VSS.n1492 VSS.t682 44.129
R6891 VSS.t1175 VSS.n968 43.9263
R6892 VSS.t916 VSS.n7 43.0632
R6893 VSS.t910 VSS.n9 43.0619
R6894 VSS.t1230 VSS.n966 42.658
R6895 VSS.t1227 VSS.n1613 42.3769
R6896 VSS.n1057 VSS.t128 42.222
R6897 VSS.n1601 VSS.t1362 41.9585
R6898 VSS.n1561 VSS.t1369 41.9585
R6899 VSS.n1055 VSS.t2203 41.9225
R6900 VSS.t1370 VSS.n1007 41.861
R6901 VSS.t1294 VSS.n971 41.1871
R6902 VSS.t1611 VSS.n1256 41.1871
R6903 VSS.n940 VSS.t1165 39.9582
R6904 VSS.n2571 VSS.t2038 39.8503
R6905 VSS.t666 VSS.n1283 38.9806
R6906 VSS.t1569 VSS.n1316 38.9806
R6907 VSS.t673 VSS.n1323 38.9806
R6908 VSS.t681 VSS.n1363 38.9806
R6909 VSS.n1763 VSS.t862 38.3917
R6910 VSS.t1012 VSS.n183 38.3674
R6911 VSS.t1995 VSS.n780 38.3674
R6912 VSS.t2045 VSS.n1069 38.3674
R6913 VSS.n1051 VSS.t1291 38.2452
R6914 VSS.t128 VSS.n962 37.7839
R6915 VSS.n2591 VSS.n961 37.5097
R6916 VSS.t130 VSS.n965 37.0756
R6917 VSS.t110 VSS.n496 36.7898
R6918 VSS.n484 VSS.t1280 36.7898
R6919 VSS.n471 VSS.t2324 36.7898
R6920 VSS.n458 VSS.t1656 36.7898
R6921 VSS.n446 VSS.t1965 36.7898
R6922 VSS.n436 VSS.t380 36.7898
R6923 VSS.n424 VSS.t1499 36.7898
R6924 VSS.n413 VSS.t1451 36.7898
R6925 VSS.t1456 VSS.n398 36.7898
R6926 VSS.t1981 VSS.n385 36.7898
R6927 VSS.t101 VSS.n373 36.7898
R6928 VSS.n361 VSS.t1285 36.7898
R6929 VSS.n348 VSS.t2062 36.7898
R6930 VSS.t2042 VSS.n333 36.7898
R6931 VSS.t2340 VSS.n319 36.7898
R6932 VSS.t2100 VSS.n307 36.7898
R6933 VSS.n2983 VSS.t2040 36.7898
R6934 VSS.n2997 VSS.t2154 36.7898
R6935 VSS.n3011 VSS.t415 36.7898
R6936 VSS.n3025 VSS.t1511 36.7898
R6937 VSS.n3039 VSS.t1626 36.7898
R6938 VSS.n3053 VSS.t1025 36.7898
R6939 VSS.n3067 VSS.t1781 36.7898
R6940 VSS.n3081 VSS.t1232 36.7898
R6941 VSS.n3095 VSS.t2139 36.7898
R6942 VSS.n3109 VSS.t2269 36.7898
R6943 VSS.n3123 VSS.t304 36.7898
R6944 VSS.n3137 VSS.t1525 36.7898
R6945 VSS.n3151 VSS.t310 36.7898
R6946 VSS.n3165 VSS.t1465 36.7898
R6947 VSS.n3179 VSS.t1193 36.7898
R6948 VSS.n3193 VSS.t2197 36.7898
R6949 VSS.n2702 VSS.t1031 36.7898
R6950 VSS.t1169 VSS.n2710 36.7898
R6951 VSS.t15 VSS.n2718 36.7898
R6952 VSS.n2727 VSS.t2293 36.7898
R6953 VSS.t1132 VSS.n2735 36.7898
R6954 VSS.t184 VSS.n2742 36.7898
R6955 VSS.t1812 VSS.n2751 36.7898
R6956 VSS.t495 VSS.n2758 36.7898
R6957 VSS.t1771 VSS.n2766 36.7898
R6958 VSS.t1817 VSS.n2775 36.7898
R6959 VSS.t1809 VSS.n2782 36.7898
R6960 VSS.t1021 VSS.n2790 36.7898
R6961 VSS.t11 VSS.n2799 36.7898
R6962 VSS.t1364 VSS.n2806 36.7898
R6963 VSS.t845 VSS.n2814 36.7898
R6964 VSS.t1814 VSS.n2822 36.7898
R6965 VSS.n1121 VSS.t2078 36.7898
R6966 VSS.n1129 VSS.t1622 36.7898
R6967 VSS.n1136 VSS.t1350 36.7898
R6968 VSS.n1143 VSS.t1938 36.7898
R6969 VSS.n1151 VSS.t371 36.7898
R6970 VSS.n1157 VSS.t1221 36.7898
R6971 VSS.n1164 VSS.t1493 36.7898
R6972 VSS.n1171 VSS.t1944 36.7898
R6973 VSS.n1178 VSS.t1497 36.7898
R6974 VSS.n1185 VSS.t1013 36.7898
R6975 VSS.n1192 VSS.t2321 36.7898
R6976 VSS.n1199 VSS.t1425 36.7898
R6977 VSS.n1206 VSS.t526 36.7898
R6978 VSS.n1213 VSS.t1952 36.7898
R6979 VSS.n1220 VSS.t2328 36.7898
R6980 VSS.n1227 VSS.t430 36.7898
R6981 VSS.n2546 VSS.t1967 36.7898
R6982 VSS.n2534 VSS.t1305 36.7898
R6983 VSS.n2522 VSS.t1384 36.7898
R6984 VSS.n2510 VSS.t1389 36.7898
R6985 VSS.n2497 VSS.t2225 36.7898
R6986 VSS.t60 VSS.n2482 36.7898
R6987 VSS.t978 VSS.n2469 36.7898
R6988 VSS.n2458 VSS.t1194 36.7898
R6989 VSS.n2446 VSS.t1760 36.7898
R6990 VSS.t2150 VSS.n2432 36.7898
R6991 VSS.n2421 VSS.t1060 36.7898
R6992 VSS.n2409 VSS.t1214 36.7898
R6993 VSS.n2398 VSS.t982 36.7898
R6994 VSS.t86 VSS.n2384 36.7898
R6995 VSS.t2311 VSS.n2368 36.7898
R6996 VSS.n2357 VSS.t2314 36.7898
R6997 VSS.n1051 VSS.t2204 36.7742
R6998 VSS.t160 VSS.n960 36.4618
R6999 VSS.t132 VSS.n940 36.2105
R7000 VSS.t1240 VSS.n1637 36.1979
R7001 VSS.n1742 VSS.t1242 36.1979
R7002 VSS.t1832 VSS.n2571 36.1166
R7003 VSS.n1583 VSS.n1006 36.0019
R7004 VSS.n1556 VSS.n1014 35.9989
R7005 VSS.n1550 VSS.n1026 35.9989
R7006 VSS.n1598 VSS.n1035 35.9989
R7007 VSS.n1564 VSS.n984 35.9989
R7008 VSS.n1047 VSS.t1295 35.702
R7009 VSS.t92 VSS.n184 35.4161
R7010 VSS.t535 VSS.n781 35.4161
R7011 VSS.n2094 VSS.t2059 35.4161
R7012 VSS.t2092 VSS.n1267 35.3033
R7013 VSS.n1421 VSS.t670 35.3033
R7014 VSS.t2264 VSS.n1308 35.3033
R7015 VSS.n1438 VSS.t1571 35.3033
R7016 VSS.n1441 VSS.t678 35.3033
R7017 VSS.t2260 VSS.n1348 35.3033
R7018 VSS.n1463 VSS.t685 35.3033
R7019 VSS.t460 VSS.n1389 35.3033
R7020 VSS.n2592 VSS.n960 35.2213
R7021 VSS.t1369 VSS.n1003 34.9655
R7022 VSS.n1593 VSS.t2161 34.8842
R7023 VSS.n1595 VSS.n1030 34.8842
R7024 VSS.n1548 VSS.n1031 34.8842
R7025 VSS.n1567 VSS.n988 34.8842
R7026 VSS.n1568 VSS.n989 34.8842
R7027 VSS.t265 VSS.n937 34.07
R7028 VSS.t902 VSS.n1661 34.0042
R7029 VSS.t1919 VSS.n2568 33.9948
R7030 VSS.t855 VSS.n1622 33.9067
R7031 VSS.t1295 VSS.n971 33.8323
R7032 VSS.n966 VSS.t130 32.3614
R7033 VSS.n1410 VSS.t664 32.3614
R7034 VSS.n1430 VSS.t671 32.3614
R7035 VSS.n1450 VSS.t679 32.3614
R7036 VSS.t660 VSS.n1028 31.3958
R7037 VSS.n1547 VSS.t1184 31.3958
R7038 VSS.n1598 VSS.t1351 31.3958
R7039 VSS.n994 VSS.t653 31.3958
R7040 VSS.n1575 VSS.t48 31.3958
R7041 VSS.n1576 VSS.t1368 31.3958
R7042 VSS.t168 VSS.n1614 31.1596
R7043 VSS.t1617 VSS.n175 30.9892
R7044 VSS.t121 VSS.n769 30.9892
R7045 VSS.t199 VSS.n1062 30.9892
R7046 VSS.t2093 VSS.n1271 30.8904
R7047 VSS.t2265 VSS.n1311 30.8904
R7048 VSS.t2261 VSS.n1351 30.8904
R7049 VSS.t461 VSS.n1392 30.8904
R7050 VSS.t1565 VSS.n1277 30.1549
R7051 VSS.t2204 VSS.n969 29.6937
R7052 VSS.t1795 VSS.n963 29.4195
R7053 VSS.t2161 VSS.n1026 29.0221
R7054 VSS.n1057 VSS.t1785 28.9853
R7055 VSS.n935 VSS.t274 28.7152
R7056 VSS.n1983 VSS.t1612 28.684
R7057 VSS.n2565 VSS.t2026 28.6493
R7058 VSS.n1055 VSS.n941 28.3058
R7059 VSS.t2181 VSS.n480 28.2943
R7060 VSS.t1560 VSS.n466 28.2943
R7061 VSS.t1674 VSS.n432 28.2943
R7062 VSS.t1503 VSS.n408 28.2943
R7063 VSS.t2056 VSS.n344 28.2943
R7064 VSS.t178 VSS.n880 28.2943
R7065 VSS.n2946 VSS.t295 28.2943
R7066 VSS.t1788 VSS.n887 28.2943
R7067 VSS.t2279 VSS.n894 28.2943
R7068 VSS.t1116 VSS.n897 28.2943
R7069 VSS.n2901 VSS.t2285 28.2943
R7070 VSS.t2201 VSS.n906 28.2943
R7071 VSS.n2877 VSS.t1608 28.2943
R7072 VSS.t1250 VSS.n913 28.2943
R7073 VSS.n2852 VSS.t2146 28.2943
R7074 VSS.n2844 VSS.t1630 28.2943
R7075 VSS.t1554 VSS.n196 28.2941
R7076 VSS.t1825 VSS.n212 28.2941
R7077 VSS.t2234 VSS.n221 28.2941
R7078 VSS.t1678 VSS.n234 28.2941
R7079 VSS.t2183 VSS.n244 28.2941
R7080 VSS.t1984 VSS.n252 28.2941
R7081 VSS.t1890 VSS.n258 28.2941
R7082 VSS.t2371 VSS.n264 28.2941
R7083 VSS.t2090 VSS.n272 28.2941
R7084 VSS.t2125 VSS.n279 28.2941
R7085 VSS.t2129 VSS.n284 28.2941
R7086 VSS.n2714 VSS.t2352 28.2941
R7087 VSS.n2738 VSS.t391 28.2941
R7088 VSS.n2762 VSS.t268 28.2941
R7089 VSS.n2786 VSS.t515 28.2941
R7090 VSS.n2810 VSS.t1148 28.2941
R7091 VSS.n2987 VSS.t1613 28.2938
R7092 VSS.n3015 VSS.t2095 28.2938
R7093 VSS.n3029 VSS.t2298 28.2938
R7094 VSS.n3057 VSS.t1636 28.2938
R7095 VSS.n3071 VSS.t1797 28.2938
R7096 VSS.n3085 VSS.t2272 28.2938
R7097 VSS.n3099 VSS.t490 28.2938
R7098 VSS.n3113 VSS.t2169 28.2938
R7099 VSS.n3155 VSS.t1395 28.2938
R7100 VSS.n3169 VSS.t1197 28.2938
R7101 VSS.n3183 VSS.t1406 28.2938
R7102 VSS.n3001 VSS.t2213 28.2938
R7103 VSS.n3043 VSS.t2122 28.2938
R7104 VSS.n3127 VSS.t1803 28.2938
R7105 VSS.n3197 VSS.t1755 28.2938
R7106 VSS.n160 VSS.t1411 28.2938
R7107 VSS.n157 VSS.t1346 28.2938
R7108 VSS.n152 VSS.t1490 28.2938
R7109 VSS.n149 VSS.t1217 28.2938
R7110 VSS.n144 VSS.t2318 28.2938
R7111 VSS.n141 VSS.t2175 28.2938
R7112 VSS.n137 VSS.t2178 28.2938
R7113 VSS.n134 VSS.t1430 28.2938
R7114 VSS.n130 VSS.t1558 28.2938
R7115 VSS.n127 VSS.t1067 28.2938
R7116 VSS.n161 VSS.t1926 28.2938
R7117 VSS.n153 VSS.t1007 28.2938
R7118 VSS.n145 VSS.t1318 28.2938
R7119 VSS.n138 VSS.t1418 28.2938
R7120 VSS.t530 VSS.n102 28.2938
R7121 VSS.t230 VSS.n108 28.2938
R7122 VSS.t1257 VSS.n2117 28.2938
R7123 VSS.t1526 VSS.n2518 28.2938
R7124 VSS.t1468 VSS.n2505 28.2938
R7125 VSS.t1189 VSS.n2129 28.2938
R7126 VSS.t1041 VSS.n2132 28.2938
R7127 VSS.t343 VSS.n2454 28.2938
R7128 VSS.t2353 VSS.n2137 28.2938
R7129 VSS.t2227 VSS.n2417 28.2938
R7130 VSS.t82 VSS.n2144 28.2938
R7131 VSS.t2307 VSS.n2148 28.2938
R7132 VSS.t1314 VSS.n2150 28.2938
R7133 VSS.t1317 VSS.n2154 28.2938
R7134 VSS.t988 VSS.n2157 28.2938
R7135 VSS.n3141 VSS.t55 28.2936
R7136 VSS.t1380 VSS.n2196 28.2936
R7137 VSS.t1473 VSS.n2188 28.2936
R7138 VSS.t1053 VSS.n2176 28.2936
R7139 VSS.t1291 VSS.n1050 28.2227
R7140 VSS.n2979 VSS.t124 28.0359
R7141 VSS.n504 VSS.t2135 28.0352
R7142 VSS.n164 VSS.t202 28.0352
R7143 VSS.n2969 VSS.t521 28.035
R7144 VSS.t329 VSS.n2555 28.035
R7145 VSS.t158 VSS.n985 27.9075
R7146 VSS.t475 VSS.n6 27.7516
R7147 VSS.t858 VSS.n1746 27.4228
R7148 VSS.n670 VSS.t1367 27.2918
R7149 VSS.t668 VSS.n1292 27.2131
R7150 VSS.t676 VSS.n1332 27.2131
R7151 VSS.t683 VSS.n1373 27.2131
R7152 VSS.n509 VSS.t1801 26.5622
R7153 VSS.n861 VSS.t1134 26.5622
R7154 VSS.n2108 VSS.t2067 26.5622
R7155 VSS.n1053 VSS.t1795 26.4776
R7156 VSS.n1489 VSS.t1575 26.4776
R7157 VSS.n685 VSS.n515 26.0918
R7158 VSS.n3211 VSS.n511 26.0918
R7159 VSS.n693 VSS.n186 26.0918
R7160 VSS.n686 VSS.n515 26.0918
R7161 VSS.n3214 VSS.n176 26.0918
R7162 VSS.n3212 VSS.n511 26.0918
R7163 VSS.n690 VSS.n507 26.0918
R7164 VSS.n690 VSS.n182 26.0918
R7165 VSS.n768 VSS.n767 26.0918
R7166 VSS.n870 VSS.n771 26.0918
R7167 VSS.n864 VSS.n863 26.0918
R7168 VSS.n2975 VSS.n763 26.0918
R7169 VSS.n767 VSS.n766 26.0918
R7170 VSS.n865 VSS.n864 26.0918
R7171 VSS.n2087 VSS.n1061 26.0918
R7172 VSS.n2112 VSS.n2085 26.0918
R7173 VSS.n2109 VSS.n2082 26.0918
R7174 VSS.n2106 VSS.n1072 26.0918
R7175 VSS.n2584 VSS.n1061 26.0918
R7176 VSS.n2110 VSS.n2082 26.0918
R7177 VSS.n2092 VSS.n2079 26.0918
R7178 VSS.n2092 VSS.n1068 26.0918
R7179 VSS.n1048 VSS.t1294 25.2808
R7180 VSS.n1768 VSS.t860 25.229
R7181 VSS.n1052 VSS.t1175 25.0066
R7182 VSS.n1560 VSS.t657 24.476
R7183 VSS.t1180 VSS.n1618 24.4565
R7184 VSS.n1031 VSS.t1773 24.4191
R7185 VSS.t662 VSS.n1036 24.4191
R7186 VSS.t1575 VSS.n1375 24.2712
R7187 VSS.n967 VSS.t1230 23.8099
R7188 VSS.n1049 VSS.t131 23.5357
R7189 VSS.n1528 VSS.t668 23.5357
R7190 VSS.n1509 VSS.t676 23.5357
R7191 VSS.n1490 VSS.t683 23.5357
R7192 VSS.t1339 VSS.n2243 23.4405
R7193 VSS.t472 VSS.n816 23.4405
R7194 VSS.t485 VSS.n728 23.4405
R7195 VSS.n819 VSS.t174 23.4305
R7196 VSS.t2208 VSS.n2245 23.4305
R7197 VSS.n731 VSS.t970 23.4305
R7198 VSS.n2592 VSS.n2591 22.4784
R7199 VSS.n1629 VSS.t175 22.3643
R7200 VSS.t517 VSS.n611 22.1556
R7201 VSS.n614 VSS.t1550 22.1456
R7202 VSS.t1612 VSS.n1257 22.0647
R7203 VSS.n1554 VSS.n1019 22.0454
R7204 VSS.n1552 VSS.n1022 22.0454
R7205 VSS.n1577 VSS.n998 22.0454
R7206 VSS.n2964 VSS.t924 21.6054
R7207 VSS.t948 VSS.n192 21.6051
R7208 VSS.n2981 VSS.t936 21.6048
R7209 VSS.n163 VSS.t888 21.6048
R7210 VSS.t876 VSS.n2547 21.6048
R7211 VSS.t1648 VSS.n1615 21.1887
R7212 VSS.n1566 VSS.t135 20.9307
R7213 VSS.n1573 VSS.n993 20.9307
R7214 VSS.t1796 VSS.n965 20.8932
R7215 VSS.n1054 VSS.t1228 20.868
R7216 VSS.n513 VSS.t1800 20.6596
R7217 VSS.n869 VSS.t1135 20.6596
R7218 VSS.n2111 VSS.t2068 20.6596
R7219 VSS.n1045 VSS.t1649 20.5938
R7220 VSS.n1409 VSS.t1565 20.5938
R7221 VSS.t1281 VSS.n485 20.0674
R7222 VSS.t2325 VSS.n473 20.0674
R7223 VSS.t1655 VSS.n459 20.0674
R7224 VSS.t1964 VSS.n448 20.0674
R7225 VSS.t378 VSS.n437 20.0674
R7226 VSS.t1500 VSS.n425 20.0674
R7227 VSS.t1452 VSS.n414 20.0674
R7228 VSS.t1457 VSS.n401 20.0674
R7229 VSS.t1982 VSS.n388 20.0674
R7230 VSS.t103 VSS.n375 20.0674
R7231 VSS.t1286 VSS.n362 20.0674
R7232 VSS.t2061 VSS.n350 20.0674
R7233 VSS.t2043 VSS.n336 20.0674
R7234 VSS.t2339 VSS.n323 20.0674
R7235 VSS.t2099 VSS.n309 20.0674
R7236 VSS.t1161 VSS.n295 20.0674
R7237 VSS.n2994 VSS.t2155 20.0674
R7238 VSS.n3008 VSS.t414 20.0674
R7239 VSS.n3022 VSS.t1509 20.0674
R7240 VSS.n3036 VSS.t1625 20.0674
R7241 VSS.n3050 VSS.t1027 20.0674
R7242 VSS.n3064 VSS.t1780 20.0674
R7243 VSS.n3078 VSS.t1231 20.0674
R7244 VSS.n3092 VSS.t2138 20.0674
R7245 VSS.n3106 VSS.t2268 20.0674
R7246 VSS.n3120 VSS.t302 20.0674
R7247 VSS.n3134 VSS.t1524 20.0674
R7248 VSS.n3148 VSS.t309 20.0674
R7249 VSS.n3162 VSS.t1464 20.0674
R7250 VSS.n3176 VSS.t1192 20.0674
R7251 VSS.n3190 VSS.t2196 20.0674
R7252 VSS.n3204 VSS.t1203 20.0674
R7253 VSS.n2958 VSS.t1171 20.0674
R7254 VSS.n2950 VSS.t17 20.0674
R7255 VSS.n2942 VSS.t2294 20.0674
R7256 VSS.n2935 VSS.t1130 20.0674
R7257 VSS.n2927 VSS.t186 20.0674
R7258 VSS.n2921 VSS.t1813 20.0674
R7259 VSS.n2913 VSS.t494 20.0674
R7260 VSS.n2905 VSS.t1772 20.0674
R7261 VSS.n2898 VSS.t1818 20.0674
R7262 VSS.n2889 VSS.t1810 20.0674
R7263 VSS.n2881 VSS.t1023 20.0674
R7264 VSS.n2874 VSS.t13 20.0674
R7265 VSS.n2866 VSS.t1363 20.0674
R7266 VSS.n2858 VSS.t844 20.0674
R7267 VSS.n2849 VSS.t1815 20.0674
R7268 VSS.n2840 VSS.t1297 20.0674
R7269 VSS.n2069 VSS.t1621 20.0674
R7270 VSS.n2065 VSS.t1349 20.0674
R7271 VSS.n2061 VSS.t1939 20.0674
R7272 VSS.n2057 VSS.t369 20.0674
R7273 VSS.n2053 VSS.t1220 20.0674
R7274 VSS.n2049 VSS.t1494 20.0674
R7275 VSS.n2045 VSS.t1945 20.0674
R7276 VSS.n2041 VSS.t1496 20.0674
R7277 VSS.n2037 VSS.t1014 20.0674
R7278 VSS.n2032 VSS.t2322 20.0674
R7279 VSS.n2028 VSS.t1427 20.0674
R7280 VSS.n2024 VSS.t527 20.0674
R7281 VSS.n2020 VSS.t1953 20.0674
R7282 VSS.n2016 VSS.t2329 20.0674
R7283 VSS.n2011 VSS.t428 20.0674
R7284 VSS.n2007 VSS.t1958 20.0674
R7285 VSS.t1306 VSS.n2535 20.0674
R7286 VSS.t1386 VSS.n2524 20.0674
R7287 VSS.t1388 VSS.n2511 20.0674
R7288 VSS.t2224 VSS.n2498 20.0674
R7289 VSS.t58 VSS.n2484 20.0674
R7290 VSS.t979 VSS.n2471 20.0674
R7291 VSS.t1195 VSS.n2459 20.0674
R7292 VSS.t1759 VSS.n2447 20.0674
R7293 VSS.t2151 VSS.n2436 20.0674
R7294 VSS.t1059 VSS.n2422 20.0674
R7295 VSS.t1213 VSS.n2410 20.0674
R7296 VSS.t983 VSS.n2399 20.0674
R7297 VSS.t84 VSS.n2386 20.0674
R7298 VSS.t2310 VSS.n2371 20.0674
R7299 VSS.t2313 VSS.n2358 20.0674
R7300 VSS.t1407 VSS.n2346 20.0674
R7301 VSS.t1808 VSS.t1807 19.9423
R7302 VSS.n1406 VSS.t2093 19.8583
R7303 VSS.n1426 VSS.t2265 19.8583
R7304 VSS.n1446 VSS.t2261 19.8583
R7305 VSS.n1468 VSS.t461 19.8583
R7306 VSS.t2203 VSS.n1054 19.397
R7307 VSS.n1045 VSS.n961 18.3874
R7308 VSS.n972 VSS.n953 18.3874
R7309 VSS.t664 VSS.n1279 18.3874
R7310 VSS.t671 VSS.n1319 18.3874
R7311 VSS.t679 VSS.n1359 18.3874
R7312 VSS.n1056 VSS.n1055 18.1856
R7313 VSS.n199 VSS.t1322 18.0025
R7314 VSS.t2323 VSS.n204 18.0025
R7315 VSS.t2232 VSS.n206 18.0025
R7316 VSS.n213 VSS.t229 18.0025
R7317 VSS.n216 VSS.t1352 18.0025
R7318 VSS.n225 VSS.t1435 18.0025
R7319 VSS.t1970 VSS.n228 18.0025
R7320 VSS.n235 VSS.t1453 18.0025
R7321 VSS.n238 VSS.t1504 18.0025
R7322 VSS.n253 VSS.t1459 18.0025
R7323 VSS.n2982 VSS.t1512 18.0025
R7324 VSS.n3024 VSS.t1019 18.0025
R7325 VSS.n3066 VSS.t1602 18.0025
R7326 VSS.n3094 VSS.t2063 18.0025
R7327 VSS.n3100 VSS.t968 18.0025
R7328 VSS.n3164 VSS.t1830 18.0025
R7329 VSS.n3170 VSS.t981 18.0025
R7330 VSS.t1932 VSS.n112 18.0025
R7331 VSS.t225 VSS.n114 18.0025
R7332 VSS.t1223 VSS.n116 18.0025
R7333 VSS.t288 VSS.n119 18.0025
R7334 VSS.t2327 VSS.n121 18.0025
R7335 VSS.n2198 VSS.t1383 18.0025
R7336 VSS.n2197 VSS.t2223 18.0025
R7337 VSS.t306 VSS.n2195 18.0025
R7338 VSS.t1829 VSS.n2193 18.0025
R7339 VSS.t57 VSS.n2192 18.0025
R7340 VSS.n2191 VSS.t1392 18.0025
R7341 VSS.t1472 VSS.n2187 18.0025
R7342 VSS.n2184 VSS.t221 18.0025
R7343 VSS.n2183 VSS.t2348 18.0025
R7344 VSS.t1991 VSS.n2181 18.0025
R7345 VSS.t1752 VSS.n2179 18.0025
R7346 VSS.t2149 VSS.n2175 18.0025
R7347 VSS.n2174 VSS.t1310 18.0025
R7348 VSS.t1062 VSS.n2172 18.0025
R7349 VSS.t541 VSS.n2170 18.0025
R7350 VSS.n2165 VSS.t2315 18.0025
R7351 VSS.t1606 VSS.n2115 18.0017
R7352 VSS.t2172 VSS.n2122 18.0017
R7353 VSS.n2125 VSS.t977 18.0017
R7354 VSS.n2491 VSS.t1263 18.0017
R7355 VSS.n2483 VSS.t1843 18.0017
R7356 VSS.n2470 VSS.t2303 18.0017
R7357 VSS.n2138 VSS.t1207 18.0017
R7358 VSS.n2435 VSS.t2174 18.0017
R7359 VSS.n2145 VSS.t2229 18.0017
R7360 VSS.t2308 VSS.n2147 18.0017
R7361 VSS.n2393 VSS.t2230 18.0017
R7362 VSS.n2385 VSS.t1266 18.0017
R7363 VSS.n2379 VSS.t2309 18.0017
R7364 VSS.n2370 VSS.t90 18.0017
R7365 VSS.t1529 VSS.n2156 18.0017
R7366 VSS.n2352 VSS.t91 18.0017
R7367 VSS.n497 VSS.t39 18.0017
R7368 VSS.n492 VSS.t1552 18.0017
R7369 VSS.t1555 VSS.n202 18.0017
R7370 VSS.n209 VSS.t289 18.0017
R7371 VSS.n222 VSS.t1955 18.0017
R7372 VSS.n231 VSS.t1968 18.0017
R7373 VSS.t1978 VSS.n240 18.0017
R7374 VSS.t234 VSS.n399 18.0017
R7375 VSS.n245 VSS.t1284 18.0017
R7376 VSS.n387 VSS.t2185 18.0017
R7377 VSS.n374 VSS.t1458 18.0017
R7378 VSS.n369 VSS.t238 18.0017
R7379 VSS.n261 VSS.t1016 18.0017
R7380 VSS.n357 VSS.t2041 18.0017
R7381 VSS.t2051 VSS.n266 18.0017
R7382 VSS.t2037 VSS.n343 18.0017
R7383 VSS.t2103 VSS.n334 18.0017
R7384 VSS.n273 VSS.t2083 18.0017
R7385 VSS.t2084 VSS.n321 18.0017
R7386 VSS.n280 VSS.t2101 18.0017
R7387 VSS.n308 VSS.t2124 18.0017
R7388 VSS.n302 VSS.t2132 18.0017
R7389 VSS.n2988 VSS.t1603 18.0017
R7390 VSS.n2996 VSS.t2356 18.0017
R7391 VSS.n3002 VSS.t1160 18.0017
R7392 VSS.n3010 VSS.t1605 18.0017
R7393 VSS.n3016 VSS.t317 18.0017
R7394 VSS.n3030 VSS.t1020 18.0017
R7395 VSS.n3038 VSS.t1643 18.0017
R7396 VSS.n3044 VSS.t211 18.0017
R7397 VSS.n3052 VSS.t2282 18.0017
R7398 VSS.n3058 VSS.t1115 18.0017
R7399 VSS.n3072 VSS.t10 18.0017
R7400 VSS.n3080 VSS.t847 18.0017
R7401 VSS.n3086 VSS.t1030 18.0017
R7402 VSS.n3108 VSS.t1802 18.0017
R7403 VSS.n3114 VSS.t1261 18.0017
R7404 VSS.n3122 VSS.t976 18.0017
R7405 VSS.n3128 VSS.t1842 18.0017
R7406 VSS.n3136 VSS.t1521 18.0017
R7407 VSS.n3142 VSS.t2171 18.0017
R7408 VSS.n3150 VSS.t1400 18.0017
R7409 VSS.n3156 VSS.t1467 18.0017
R7410 VSS.n3178 VSS.t340 18.0017
R7411 VSS.n3184 VSS.t2141 18.0017
R7412 VSS.n3192 VSS.t1761 18.0017
R7413 VSS.n3198 VSS.t2350 18.0017
R7414 VSS.t159 VSS.n81 18.0017
R7415 VSS.t1543 VSS.n82 18.0017
R7416 VSS.t1916 VSS.n83 18.0017
R7417 VSS.t1935 VSS.n85 18.0017
R7418 VSS.t1929 VSS.n156 18.0017
R7419 VSS.t1940 VSS.n86 18.0017
R7420 VSS.t224 VSS.n87 18.0017
R7421 VSS.t1276 VSS.n88 18.0017
R7422 VSS.t1489 VSS.n90 18.0017
R7423 VSS.t1495 VSS.n148 18.0017
R7424 VSS.t2317 VSS.n91 18.0017
R7425 VSS.t481 VSS.n92 18.0017
R7426 VSS.t1820 VSS.n93 18.0017
R7427 VSS.t484 VSS.n95 18.0017
R7428 VSS.t1224 VSS.n140 18.0017
R7429 VSS.t285 VSS.n96 18.0017
R7430 VSS.t226 VSS.n98 18.0017
R7431 VSS.t2320 VSS.n99 18.0017
R7432 VSS.t1423 VSS.n100 18.0017
R7433 VSS.t2326 VSS.n133 18.0017
R7434 VSS.t2231 VSS.n101 18.0017
R7435 VSS.n103 VSS.t1954 18.0017
R7436 VSS.n105 VSS.t1431 18.0017
R7437 VSS.t2330 VSS.n106 18.0017
R7438 VSS.t1886 VSS.n126 18.0017
R7439 VSS.t1887 VSS.n107 18.0017
R7440 VSS.n109 VSS.t381 18.0017
R7441 VSS.n2961 VSS.t2220 18.0016
R7442 VSS.t2286 VSS.n2956 18.0016
R7443 VSS.n2953 VSS.t1616 18.0016
R7444 VSS.t2277 VSS.n2948 18.0016
R7445 VSS.t210 VSS.n2945 18.0016
R7446 VSS.n2938 VSS.t849 18.0016
R7447 VSS.t292 VSS.n2933 18.0016
R7448 VSS.n2930 VSS.t1604 18.0016
R7449 VSS.t2216 VSS.n2925 18.0016
R7450 VSS.t2163 VSS.n2919 18.0016
R7451 VSS.n2916 VSS.t1163 18.0016
R7452 VSS.t1296 VSS.n2911 18.0016
R7453 VSS.n2908 VSS.t870 18.0016
R7454 VSS.t1517 VSS.n2903 18.0016
R7455 VSS.t1828 VSS.n2895 18.0016
R7456 VSS.n2892 VSS.t2209 18.0016
R7457 VSS.t2283 VSS.n2887 18.0016
R7458 VSS.n2884 VSS.t1811 18.0016
R7459 VSS.t2349 VSS.n2879 18.0016
R7460 VSS.t2271 VSS.n2872 18.0016
R7461 VSS.n2869 VSS.t21 18.0016
R7462 VSS.t193 VSS.n2864 18.0016
R7463 VSS.n2861 VSS.t258 18.0016
R7464 VSS.t2156 VSS.n2855 18.0016
R7465 VSS.t1168 VSS.n2847 18.0016
R7466 VSS.t1372 VSS.n2843 18.0016
R7467 VSS.t1779 VSS.n2701 18.0016
R7468 VSS.t2158 VSS.n2726 18.0016
R7469 VSS.n2747 VSS.t1153 18.0016
R7470 VSS.t2164 VSS.n2771 18.0016
R7471 VSS.t499 VSS.n2795 18.0016
R7472 VSS.t1624 VSS.n2818 18.0016
R7473 VSS.t1011 VSS.n177 17.7083
R7474 VSS.t1994 VSS.n772 17.7083
R7475 VSS.n2088 VSS.t2044 17.7083
R7476 VSS.n930 VSS.t477 17.4722
R7477 VSS.n2560 VSS.t2022 17.4483
R7478 VSS.t571 VSS.n990 17.4424
R7479 VSS.n2579 VSS.n2578 17.0005
R7480 VSS.n2579 VSS.t1976 17.0005
R7481 VSS.n2579 VSS.n2161 17.0005
R7482 VSS.n2583 VSS.n2582 17.0005
R7483 VSS.n2583 VSS.n2086 17.0005
R7484 VSS.n2583 VSS.n2113 17.0005
R7485 VSS.n2583 VSS.n2088 17.0005
R7486 VSS.n2583 VSS.n2111 17.0005
R7487 VSS.n2583 VSS.n1064 17.0005
R7488 VSS.n2583 VSS.n2083 17.0005
R7489 VSS.n2583 VSS.n1066 17.0005
R7490 VSS.n2583 VSS.n2108 17.0005
R7491 VSS.n2583 VSS.n2090 17.0005
R7492 VSS.n2583 VSS.n2080 17.0005
R7493 VSS.n2583 VSS.n2091 17.0005
R7494 VSS.n2583 VSS.n2078 17.0005
R7495 VSS.n2583 VSS.n2094 17.0005
R7496 VSS.n2583 VSS.n2107 17.0005
R7497 VSS.n2583 VSS.n2095 17.0005
R7498 VSS.n2583 VSS.n2105 17.0005
R7499 VSS.n2583 VSS.n2096 17.0005
R7500 VSS.n2300 VSS.n2299 17.0005
R7501 VSS.n2300 VSS.n2298 17.0005
R7502 VSS.n2302 VSS.n2292 17.0005
R7503 VSS.n2295 VSS.n2291 17.0005
R7504 VSS.n2287 VSS.n2281 17.0005
R7505 VSS.n2285 VSS.n2281 17.0005
R7506 VSS.n2309 VSS.n2276 17.0005
R7507 VSS.n2279 VSS.n2275 17.0005
R7508 VSS.n2271 VSS.n2265 17.0005
R7509 VSS.n2269 VSS.n2265 17.0005
R7510 VSS.n2315 VSS.n2260 17.0005
R7511 VSS.n2263 VSS.n2259 17.0005
R7512 VSS.n2318 VSS.n2244 17.0005
R7513 VSS.n2318 VSS.n2246 17.0005
R7514 VSS.n2249 VSS.n2238 17.0005
R7515 VSS.n2247 VSS.n2238 17.0005
R7516 VSS.n2321 VSS.n2233 17.0005
R7517 VSS.n2236 VSS.n2232 17.0005
R7518 VSS.n2228 VSS.n2222 17.0005
R7519 VSS.n2226 VSS.n2222 17.0005
R7520 VSS.n2327 VSS.n2217 17.0005
R7521 VSS.n2220 VSS.n2216 17.0005
R7522 VSS.n2212 VSS.n2207 17.0005
R7523 VSS.n2207 VSS.n2205 17.0005
R7524 VSS.n2333 VSS.n2206 17.0005
R7525 VSS.n2336 VSS.n2335 17.0005
R7526 VSS.n291 VSS.n3218 17.0005
R7527 VSS.n291 VSS.n174 17.0005
R7528 VSS.n291 VSS.n516 17.0005
R7529 VSS.n291 VSS.n175 17.0005
R7530 VSS.n291 VSS.n514 17.0005
R7531 VSS.n291 VSS.n177 17.0005
R7532 VSS.n291 VSS.n513 17.0005
R7533 VSS.n291 VSS.n178 17.0005
R7534 VSS.n291 VSS.n512 17.0005
R7535 VSS.n291 VSS.n179 17.0005
R7536 VSS.n291 VSS.n510 17.0005
R7537 VSS.n291 VSS.n180 17.0005
R7538 VSS.n291 VSS.n509 17.0005
R7539 VSS.n291 VSS.n181 17.0005
R7540 VSS.n291 VSS.n508 17.0005
R7541 VSS.n291 VSS.n183 17.0005
R7542 VSS.n291 VSS.n506 17.0005
R7543 VSS.n291 VSS.n184 17.0005
R7544 VSS.n291 VSS.n505 17.0005
R7545 VSS.n291 VSS.n187 17.0005
R7546 VSS.n291 VSS.n191 17.0005
R7547 VSS.n291 VSS.n189 17.0005
R7548 VSS.n291 VSS.t2167 17.0005
R7549 VSS.n291 VSS.n290 17.0005
R7550 VSS.n679 VSS.n517 17.0005
R7551 VSS.n678 VSS.n517 17.0005
R7552 VSS.n676 VSS.n517 17.0005
R7553 VSS.n674 VSS.n517 17.0005
R7554 VSS.n671 VSS.n517 17.0005
R7555 VSS.n668 VSS.n517 17.0005
R7556 VSS.n666 VSS.n517 17.0005
R7557 VSS.n661 VSS.n660 17.0005
R7558 VSS.n660 VSS.n519 17.0005
R7559 VSS.n654 VSS.n520 17.0005
R7560 VSS.n653 VSS.n652 17.0005
R7561 VSS.n649 VSS.n648 17.0005
R7562 VSS.n649 VSS.n528 17.0005
R7563 VSS.n640 VSS.n529 17.0005
R7564 VSS.n639 VSS.n638 17.0005
R7565 VSS.n635 VSS.n634 17.0005
R7566 VSS.n635 VSS.n537 17.0005
R7567 VSS.n627 VSS.n538 17.0005
R7568 VSS.n626 VSS.n625 17.0005
R7569 VSS.n612 VSS.n542 17.0005
R7570 VSS.n616 VSS.n542 17.0005
R7571 VSS.n621 VSS.n620 17.0005
R7572 VSS.n621 VSS.n545 17.0005
R7573 VSS.n605 VSS.n546 17.0005
R7574 VSS.n604 VSS.n603 17.0005
R7575 VSS.n600 VSS.n599 17.0005
R7576 VSS.n600 VSS.n554 17.0005
R7577 VSS.n592 VSS.n555 17.0005
R7578 VSS.n591 VSS.n590 17.0005
R7579 VSS.n587 VSS.n586 17.0005
R7580 VSS.n587 VSS.n563 17.0005
R7581 VSS.n579 VSS.n564 17.0005
R7582 VSS.n577 VSS.n576 17.0005
R7583 VSS.n3216 VSS.n3215 17.0005
R7584 VSS.n3216 VSS.n178 17.0005
R7585 VSS.n3216 VSS.n512 17.0005
R7586 VSS.n3216 VSS.n180 17.0005
R7587 VSS.n3216 VSS.n508 17.0005
R7588 VSS.n3216 VSS.n689 17.0005
R7589 VSS.n3216 VSS.n506 17.0005
R7590 VSS.n3216 VSS.n692 17.0005
R7591 VSS.n2974 VSS.n2973 17.0005
R7592 VSS.n2974 VSS.n764 17.0005
R7593 VSS.n2974 VSS.n871 17.0005
R7594 VSS.n2974 VSS.n772 17.0005
R7595 VSS.n2974 VSS.n869 17.0005
R7596 VSS.n2974 VSS.n773 17.0005
R7597 VSS.n2974 VSS.n867 17.0005
R7598 VSS.n2974 VSS.n775 17.0005
R7599 VSS.n2974 VSS.n861 17.0005
R7600 VSS.n2974 VSS.n776 17.0005
R7601 VSS.n2974 VSS.n859 17.0005
R7602 VSS.n2974 VSS.n777 17.0005
R7603 VSS.n2974 VSS.n858 17.0005
R7604 VSS.n2974 VSS.n780 17.0005
R7605 VSS.n2974 VSS.n855 17.0005
R7606 VSS.n2974 VSS.n781 17.0005
R7607 VSS.n2974 VSS.n854 17.0005
R7608 VSS.n2974 VSS.n782 17.0005
R7609 VSS.n765 VSS.n170 17.0005
R7610 VSS.n769 VSS.n170 17.0005
R7611 VSS.n770 VSS.n170 17.0005
R7612 VSS.n773 VSS.n170 17.0005
R7613 VSS.n867 VSS.n170 17.0005
R7614 VSS.n866 VSS.n170 17.0005
R7615 VSS.n862 VSS.n170 17.0005
R7616 VSS.n775 VSS.n170 17.0005
R7617 VSS.n859 VSS.n170 17.0005
R7618 VSS.n856 VSS.n170 17.0005
R7619 VSS.n855 VSS.n170 17.0005
R7620 VSS.n2976 VSS.n170 17.0005
R7621 VSS.n2691 VSS.n170 17.0005
R7622 VSS.t2075 VSS.n170 17.0005
R7623 VSS.n2669 VSS.n170 17.0005
R7624 VSS.n2683 VSS.n170 17.0005
R7625 VSS.n2673 VSS.n170 17.0005
R7626 VSS.n2694 VSS.n170 17.0005
R7627 VSS.n2974 VSS.n783 17.0005
R7628 VSS.n2974 VSS.n785 17.0005
R7629 VSS.n2974 VSS.n817 17.0005
R7630 VSS.n2974 VSS.n821 17.0005
R7631 VSS.n2970 VSS.t209 17.0005
R7632 VSS.n2970 VSS.n2830 17.0005
R7633 VSS.n2970 VSS.n2836 17.0005
R7634 VSS.n2970 VSS.n877 17.0005
R7635 VSS.n2970 VSS.n875 17.0005
R7636 VSS.n2970 VSS.n939 17.0005
R7637 VSS.n2970 VSS.n938 17.0005
R7638 VSS.n2970 VSS.n936 17.0005
R7639 VSS.n2970 VSS.n934 17.0005
R7640 VSS.n2970 VSS.n931 17.0005
R7641 VSS.n31 VSS.n963 17.0005
R7642 VSS.n31 VSS.n1053 17.0005
R7643 VSS.n31 VSS.n966 17.0005
R7644 VSS.n31 VSS.n1052 17.0005
R7645 VSS.n31 VSS.n1051 17.0005
R7646 VSS.n31 VSS.n1049 17.0005
R7647 VSS.n31 VSS.n971 17.0005
R7648 VSS.n2591 VSS.n31 17.0005
R7649 VSS.n31 VSS.n1045 17.0005
R7650 VSS.n31 VSS.n972 17.0005
R7651 VSS.n2593 VSS.n10 17.0005
R7652 VSS.n1724 VSS.n953 17.0005
R7653 VSS.n78 VSS.n2585 17.0005
R7654 VSS.n78 VSS.n1062 17.0005
R7655 VSS.n78 VSS.n2084 17.0005
R7656 VSS.n78 VSS.n1064 17.0005
R7657 VSS.n78 VSS.n2083 17.0005
R7658 VSS.n78 VSS.n1065 17.0005
R7659 VSS.n78 VSS.n2081 17.0005
R7660 VSS.n78 VSS.n1066 17.0005
R7661 VSS.n78 VSS.n2080 17.0005
R7662 VSS.n78 VSS.n1069 17.0005
R7663 VSS.n78 VSS.n2078 17.0005
R7664 VSS.n78 VSS.n1071 17.0005
R7665 VSS.n78 VSS.n1119 17.0005
R7666 VSS.n78 VSS.t2346 17.0005
R7667 VSS.n78 VSS.n1235 17.0005
R7668 VSS.n78 VSS.n1240 17.0005
R7669 VSS.n78 VSS.n1075 17.0005
R7670 VSS.n78 VSS.n1073 17.0005
R7671 VSS.n2579 VSS.n2556 17.0005
R7672 VSS.n2579 VSS.n2548 17.0005
R7673 VSS.n2579 VSS.n2570 17.0005
R7674 VSS.n2579 VSS.n2569 17.0005
R7675 VSS.n2579 VSS.n2566 17.0005
R7676 VSS.n2579 VSS.n2564 17.0005
R7677 VSS.n2579 VSS.n2561 17.0005
R7678 VSS.n2002 VSS.n1245 17.0005
R7679 VSS.n2002 VSS.n1246 17.0005
R7680 VSS.n2002 VSS.n1247 17.0005
R7681 VSS.n2002 VSS.n1248 17.0005
R7682 VSS.n2002 VSS.n1249 17.0005
R7683 VSS.n2002 VSS.n1250 17.0005
R7684 VSS.n2002 VSS.n1251 17.0005
R7685 VSS.n2002 VSS.n1252 17.0005
R7686 VSS.n2002 VSS.n1253 17.0005
R7687 VSS.n2002 VSS.n1254 17.0005
R7688 VSS.n2002 VSS.n1255 17.0005
R7689 VSS.n2002 VSS.n1256 17.0005
R7690 VSS.n2002 VSS.n1257 17.0005
R7691 VSS.n2002 VSS.n1258 17.0005
R7692 VSS.n2002 VSS.n1259 17.0005
R7693 VSS.n2002 VSS.n1260 17.0005
R7694 VSS.n2002 VSS.n1261 17.0005
R7695 VSS.n2002 VSS.n1262 17.0005
R7696 VSS.n2002 VSS.n1263 17.0005
R7697 VSS.n2002 VSS.n1264 17.0005
R7698 VSS.n2002 VSS.n1265 17.0005
R7699 VSS.n2002 VSS.n1266 17.0005
R7700 VSS.n2002 VSS.n1267 17.0005
R7701 VSS.n2002 VSS.n1269 17.0005
R7702 VSS.n2002 VSS.n1270 17.0005
R7703 VSS.n2002 VSS.n1271 17.0005
R7704 VSS.n2002 VSS.n1272 17.0005
R7705 VSS.n2002 VSS.n1273 17.0005
R7706 VSS.n2002 VSS.n1274 17.0005
R7707 VSS.n2002 VSS.n1275 17.0005
R7708 VSS.n2002 VSS.n1276 17.0005
R7709 VSS.n2002 VSS.n1277 17.0005
R7710 VSS.n2002 VSS.n1278 17.0005
R7711 VSS.n2002 VSS.n1279 17.0005
R7712 VSS.n2002 VSS.n1280 17.0005
R7713 VSS.n2002 VSS.n1281 17.0005
R7714 VSS.n2002 VSS.n1282 17.0005
R7715 VSS.n2002 VSS.n1283 17.0005
R7716 VSS.n2002 VSS.n1284 17.0005
R7717 VSS.n2002 VSS.n1285 17.0005
R7718 VSS.n2002 VSS.n1286 17.0005
R7719 VSS.n2002 VSS.n1287 17.0005
R7720 VSS.n2002 VSS.n1288 17.0005
R7721 VSS.n2002 VSS.n1289 17.0005
R7722 VSS.n2002 VSS.n1290 17.0005
R7723 VSS.n2002 VSS.n1291 17.0005
R7724 VSS.n2002 VSS.n1292 17.0005
R7725 VSS.n2002 VSS.n1293 17.0005
R7726 VSS.n2002 VSS.n1294 17.0005
R7727 VSS.n2002 VSS.n1295 17.0005
R7728 VSS.n2002 VSS.n1296 17.0005
R7729 VSS.n2002 VSS.n1297 17.0005
R7730 VSS.n2002 VSS.n1298 17.0005
R7731 VSS.n2002 VSS.n1299 17.0005
R7732 VSS.n2002 VSS.n1300 17.0005
R7733 VSS.n2002 VSS.n1301 17.0005
R7734 VSS.n2002 VSS.n1302 17.0005
R7735 VSS.n2002 VSS.n1303 17.0005
R7736 VSS.n2002 VSS.n1304 17.0005
R7737 VSS.n2002 VSS.n1305 17.0005
R7738 VSS.n2002 VSS.n1306 17.0005
R7739 VSS.n2002 VSS.n1307 17.0005
R7740 VSS.n2002 VSS.n1308 17.0005
R7741 VSS.n2002 VSS.n1309 17.0005
R7742 VSS.n2002 VSS.n1310 17.0005
R7743 VSS.n2002 VSS.n1311 17.0005
R7744 VSS.n2002 VSS.n1312 17.0005
R7745 VSS.n2002 VSS.n1313 17.0005
R7746 VSS.n2002 VSS.n1314 17.0005
R7747 VSS.n2002 VSS.n1315 17.0005
R7748 VSS.n2002 VSS.n1316 17.0005
R7749 VSS.n2002 VSS.n1317 17.0005
R7750 VSS.n2002 VSS.n1318 17.0005
R7751 VSS.n2002 VSS.n1319 17.0005
R7752 VSS.n2002 VSS.n1320 17.0005
R7753 VSS.n2002 VSS.n1321 17.0005
R7754 VSS.n2002 VSS.n1322 17.0005
R7755 VSS.n2002 VSS.n1323 17.0005
R7756 VSS.n2002 VSS.n1324 17.0005
R7757 VSS.n2002 VSS.n1325 17.0005
R7758 VSS.n2002 VSS.n1326 17.0005
R7759 VSS.n2002 VSS.n1327 17.0005
R7760 VSS.n2002 VSS.n1328 17.0005
R7761 VSS.n2002 VSS.n1329 17.0005
R7762 VSS.n2002 VSS.n1330 17.0005
R7763 VSS.n2002 VSS.n1331 17.0005
R7764 VSS.n2002 VSS.n1332 17.0005
R7765 VSS.n2002 VSS.n1333 17.0005
R7766 VSS.n2002 VSS.n1334 17.0005
R7767 VSS.n2002 VSS.n1335 17.0005
R7768 VSS.n2002 VSS.n1336 17.0005
R7769 VSS.n2002 VSS.n1337 17.0005
R7770 VSS.n2002 VSS.n1338 17.0005
R7771 VSS.n2002 VSS.n1339 17.0005
R7772 VSS.n2002 VSS.n1340 17.0005
R7773 VSS.n2002 VSS.n1341 17.0005
R7774 VSS.n2002 VSS.n1342 17.0005
R7775 VSS.n2002 VSS.n1343 17.0005
R7776 VSS.n2002 VSS.n1344 17.0005
R7777 VSS.n2002 VSS.n1345 17.0005
R7778 VSS.n2002 VSS.n1346 17.0005
R7779 VSS.n2002 VSS.n1347 17.0005
R7780 VSS.n2002 VSS.n1348 17.0005
R7781 VSS.n2002 VSS.n1349 17.0005
R7782 VSS.n2002 VSS.n1350 17.0005
R7783 VSS.n2002 VSS.n1351 17.0005
R7784 VSS.n2002 VSS.n1352 17.0005
R7785 VSS.n2002 VSS.n1353 17.0005
R7786 VSS.n2002 VSS.n1354 17.0005
R7787 VSS.n2002 VSS.n1355 17.0005
R7788 VSS.n2002 VSS.n1356 17.0005
R7789 VSS.n2002 VSS.n1357 17.0005
R7790 VSS.n2002 VSS.n1358 17.0005
R7791 VSS.n2002 VSS.n1359 17.0005
R7792 VSS.n2002 VSS.n1360 17.0005
R7793 VSS.n2002 VSS.n1361 17.0005
R7794 VSS.n2002 VSS.n1362 17.0005
R7795 VSS.n2002 VSS.n1363 17.0005
R7796 VSS.n2002 VSS.n1364 17.0005
R7797 VSS.n2002 VSS.n1365 17.0005
R7798 VSS.n2002 VSS.n1366 17.0005
R7799 VSS.n2002 VSS.n1367 17.0005
R7800 VSS.n2002 VSS.n1368 17.0005
R7801 VSS.n2002 VSS.n1369 17.0005
R7802 VSS.n2002 VSS.n1370 17.0005
R7803 VSS.n2002 VSS.n1371 17.0005
R7804 VSS.n2002 VSS.n2000 17.0005
R7805 VSS.n2002 VSS.n1404 17.0005
R7806 VSS.n2002 VSS.n1403 17.0005
R7807 VSS.n2002 VSS.n1402 17.0005
R7808 VSS.n2002 VSS.n1401 17.0005
R7809 VSS.n2002 VSS.n1400 17.0005
R7810 VSS.n2002 VSS.n1399 17.0005
R7811 VSS.n2002 VSS.n1398 17.0005
R7812 VSS.n2002 VSS.n1397 17.0005
R7813 VSS.n2002 VSS.n1396 17.0005
R7814 VSS.n2002 VSS.n1395 17.0005
R7815 VSS.n2002 VSS.n1394 17.0005
R7816 VSS.n2002 VSS.n1393 17.0005
R7817 VSS.n2002 VSS.n1392 17.0005
R7818 VSS.n2002 VSS.n1391 17.0005
R7819 VSS.n2002 VSS.n1390 17.0005
R7820 VSS.n2002 VSS.n1389 17.0005
R7821 VSS.n2002 VSS.n1388 17.0005
R7822 VSS.n2002 VSS.n1387 17.0005
R7823 VSS.n2002 VSS.n1386 17.0005
R7824 VSS.n2002 VSS.n1385 17.0005
R7825 VSS.n2002 VSS.n1384 17.0005
R7826 VSS.n2002 VSS.n1383 17.0005
R7827 VSS.n2002 VSS.n1382 17.0005
R7828 VSS.n2002 VSS.n1381 17.0005
R7829 VSS.n2002 VSS.n1380 17.0005
R7830 VSS.n2002 VSS.n1379 17.0005
R7831 VSS.n2002 VSS.n1378 17.0005
R7832 VSS.n2002 VSS.n1377 17.0005
R7833 VSS.n2002 VSS.n1376 17.0005
R7834 VSS.n2002 VSS.n1375 17.0005
R7835 VSS.n2002 VSS.n1374 17.0005
R7836 VSS.n2002 VSS.n1373 17.0005
R7837 VSS.n1998 VSS.n1997 17.0005
R7838 VSS.n1998 VSS.n1406 17.0005
R7839 VSS.n1998 VSS.n1538 17.0005
R7840 VSS.n1998 VSS.n1407 17.0005
R7841 VSS.n1998 VSS.n1537 17.0005
R7842 VSS.n1998 VSS.n1408 17.0005
R7843 VSS.n1998 VSS.n1536 17.0005
R7844 VSS.n1998 VSS.n1409 17.0005
R7845 VSS.n1998 VSS.n1535 17.0005
R7846 VSS.n1998 VSS.n1410 17.0005
R7847 VSS.n1998 VSS.n1534 17.0005
R7848 VSS.n1998 VSS.n1411 17.0005
R7849 VSS.n1998 VSS.n1533 17.0005
R7850 VSS.n1998 VSS.n1412 17.0005
R7851 VSS.n1998 VSS.n1532 17.0005
R7852 VSS.n1998 VSS.n1413 17.0005
R7853 VSS.n1998 VSS.n1531 17.0005
R7854 VSS.n1998 VSS.n1414 17.0005
R7855 VSS.n1998 VSS.n1530 17.0005
R7856 VSS.n1998 VSS.n1415 17.0005
R7857 VSS.n1998 VSS.n1529 17.0005
R7858 VSS.n1998 VSS.n1416 17.0005
R7859 VSS.n1998 VSS.n1528 17.0005
R7860 VSS.n1998 VSS.n1417 17.0005
R7861 VSS.n1998 VSS.n1527 17.0005
R7862 VSS.n1998 VSS.n1418 17.0005
R7863 VSS.n1998 VSS.n1526 17.0005
R7864 VSS.n1998 VSS.n1419 17.0005
R7865 VSS.n1998 VSS.t669 17.0005
R7866 VSS.n1998 VSS.n1420 17.0005
R7867 VSS.n1998 VSS.n1525 17.0005
R7868 VSS.n1998 VSS.n1421 17.0005
R7869 VSS.n1998 VSS.n1524 17.0005
R7870 VSS.n1998 VSS.n1422 17.0005
R7871 VSS.n1998 VSS.n1523 17.0005
R7872 VSS.n1998 VSS.n1423 17.0005
R7873 VSS.n1998 VSS.n1522 17.0005
R7874 VSS.n1998 VSS.n1424 17.0005
R7875 VSS.n1998 VSS.n1521 17.0005
R7876 VSS.n1998 VSS.n1425 17.0005
R7877 VSS.n1998 VSS.n1520 17.0005
R7878 VSS.n1998 VSS.n1426 17.0005
R7879 VSS.n1998 VSS.n1519 17.0005
R7880 VSS.n1998 VSS.n1427 17.0005
R7881 VSS.n1998 VSS.n1518 17.0005
R7882 VSS.n1998 VSS.n1428 17.0005
R7883 VSS.n1998 VSS.n1517 17.0005
R7884 VSS.n1998 VSS.n1429 17.0005
R7885 VSS.n1998 VSS.n1516 17.0005
R7886 VSS.n1998 VSS.n1430 17.0005
R7887 VSS.n1998 VSS.n1515 17.0005
R7888 VSS.n1998 VSS.n1431 17.0005
R7889 VSS.n1998 VSS.n1514 17.0005
R7890 VSS.n1998 VSS.n1432 17.0005
R7891 VSS.n1998 VSS.n1513 17.0005
R7892 VSS.n1998 VSS.n1433 17.0005
R7893 VSS.n1998 VSS.n1512 17.0005
R7894 VSS.n1998 VSS.n1434 17.0005
R7895 VSS.n1998 VSS.n1511 17.0005
R7896 VSS.n1998 VSS.n1435 17.0005
R7897 VSS.n1998 VSS.n1510 17.0005
R7898 VSS.n1998 VSS.n1436 17.0005
R7899 VSS.n1998 VSS.n1509 17.0005
R7900 VSS.n1998 VSS.n1437 17.0005
R7901 VSS.n1998 VSS.n1508 17.0005
R7902 VSS.n1998 VSS.n1438 17.0005
R7903 VSS.n1998 VSS.n1507 17.0005
R7904 VSS.n1998 VSS.n1439 17.0005
R7905 VSS.n1998 VSS.t677 17.0005
R7906 VSS.n1998 VSS.n1440 17.0005
R7907 VSS.n1998 VSS.n1506 17.0005
R7908 VSS.n1998 VSS.n1441 17.0005
R7909 VSS.n1998 VSS.n1505 17.0005
R7910 VSS.n1998 VSS.n1442 17.0005
R7911 VSS.n1998 VSS.n1504 17.0005
R7912 VSS.n1998 VSS.n1443 17.0005
R7913 VSS.n1998 VSS.n1503 17.0005
R7914 VSS.n1998 VSS.n1444 17.0005
R7915 VSS.n1998 VSS.n1502 17.0005
R7916 VSS.n1998 VSS.n1445 17.0005
R7917 VSS.n1998 VSS.n1501 17.0005
R7918 VSS.n1998 VSS.n1446 17.0005
R7919 VSS.n1998 VSS.n1500 17.0005
R7920 VSS.n1998 VSS.n1447 17.0005
R7921 VSS.n1998 VSS.n1499 17.0005
R7922 VSS.n1998 VSS.n1448 17.0005
R7923 VSS.n1998 VSS.n1498 17.0005
R7924 VSS.n1998 VSS.n1449 17.0005
R7925 VSS.n1998 VSS.n1497 17.0005
R7926 VSS.n1998 VSS.n1450 17.0005
R7927 VSS.n1998 VSS.n1496 17.0005
R7928 VSS.n1998 VSS.n1451 17.0005
R7929 VSS.n1998 VSS.n1495 17.0005
R7930 VSS.n1998 VSS.n1452 17.0005
R7931 VSS.n1998 VSS.n1494 17.0005
R7932 VSS.n1998 VSS.n1453 17.0005
R7933 VSS.n1998 VSS.n1493 17.0005
R7934 VSS.n1998 VSS.n1455 17.0005
R7935 VSS.n1998 VSS.n1492 17.0005
R7936 VSS.n1998 VSS.n1456 17.0005
R7937 VSS.n1998 VSS.n1491 17.0005
R7938 VSS.n1998 VSS.n1457 17.0005
R7939 VSS.n1998 VSS.n1490 17.0005
R7940 VSS.n1998 VSS.n1459 17.0005
R7941 VSS.n1998 VSS.n1489 17.0005
R7942 VSS.n1998 VSS.n1460 17.0005
R7943 VSS.n1998 VSS.n1488 17.0005
R7944 VSS.n1998 VSS.n1461 17.0005
R7945 VSS.n1998 VSS.t684 17.0005
R7946 VSS.n1998 VSS.n1462 17.0005
R7947 VSS.n1998 VSS.n1487 17.0005
R7948 VSS.n1998 VSS.n1463 17.0005
R7949 VSS.n1998 VSS.n1486 17.0005
R7950 VSS.n1998 VSS.n1464 17.0005
R7951 VSS.n1998 VSS.n1485 17.0005
R7952 VSS.n1998 VSS.n1465 17.0005
R7953 VSS.n1998 VSS.n1484 17.0005
R7954 VSS.n1998 VSS.n1466 17.0005
R7955 VSS.n1998 VSS.n1483 17.0005
R7956 VSS.n1998 VSS.n1467 17.0005
R7957 VSS.n1998 VSS.n1482 17.0005
R7958 VSS.n1998 VSS.n1468 17.0005
R7959 VSS.n1998 VSS.n1481 17.0005
R7960 VSS.n1998 VSS.n1469 17.0005
R7961 VSS.n1998 VSS.n1480 17.0005
R7962 VSS.n1998 VSS.n1470 17.0005
R7963 VSS.n1998 VSS.n1479 17.0005
R7964 VSS.n1998 VSS.n1471 17.0005
R7965 VSS.n1998 VSS.n1478 17.0005
R7966 VSS.n1998 VSS.n1472 17.0005
R7967 VSS.n1998 VSS.n1477 17.0005
R7968 VSS.n1998 VSS.n1473 17.0005
R7969 VSS.n1998 VSS.n1476 17.0005
R7970 VSS.n1998 VSS.n1474 17.0005
R7971 VSS.n1999 VSS.n1998 17.0005
R7972 VSS.n1998 VSS.n1405 17.0005
R7973 VSS.n1999 VSS.n37 17.0005
R7974 VSS.n1474 VSS.n37 17.0005
R7975 VSS.n1476 VSS.n37 17.0005
R7976 VSS.n1473 VSS.n37 17.0005
R7977 VSS.n1477 VSS.n37 17.0005
R7978 VSS.n1472 VSS.n37 17.0005
R7979 VSS.n1478 VSS.n37 17.0005
R7980 VSS.n1471 VSS.n37 17.0005
R7981 VSS.n1479 VSS.n37 17.0005
R7982 VSS.n1470 VSS.n37 17.0005
R7983 VSS.n1480 VSS.n37 17.0005
R7984 VSS.n1469 VSS.n37 17.0005
R7985 VSS.n1481 VSS.n37 17.0005
R7986 VSS.n1468 VSS.n37 17.0005
R7987 VSS.n1482 VSS.n37 17.0005
R7988 VSS.n1467 VSS.n37 17.0005
R7989 VSS.n1483 VSS.n37 17.0005
R7990 VSS.n1466 VSS.n37 17.0005
R7991 VSS.n1484 VSS.n37 17.0005
R7992 VSS.n1465 VSS.n37 17.0005
R7993 VSS.n1485 VSS.n37 17.0005
R7994 VSS.n1464 VSS.n37 17.0005
R7995 VSS.n1486 VSS.n37 17.0005
R7996 VSS.n1463 VSS.n37 17.0005
R7997 VSS.n1487 VSS.n37 17.0005
R7998 VSS.n1462 VSS.n37 17.0005
R7999 VSS.t684 VSS.n37 17.0005
R8000 VSS.n1461 VSS.n37 17.0005
R8001 VSS.n1488 VSS.n37 17.0005
R8002 VSS.n1460 VSS.n37 17.0005
R8003 VSS.n1489 VSS.n37 17.0005
R8004 VSS.n1459 VSS.n37 17.0005
R8005 VSS.n1490 VSS.n37 17.0005
R8006 VSS.n1851 VSS.n37 17.0005
R8007 VSS.n1457 VSS.n37 17.0005
R8008 VSS.n1491 VSS.n37 17.0005
R8009 VSS.n1456 VSS.n37 17.0005
R8010 VSS.n1492 VSS.n37 17.0005
R8011 VSS.n1455 VSS.n37 17.0005
R8012 VSS.n1493 VSS.n37 17.0005
R8013 VSS.n1453 VSS.n37 17.0005
R8014 VSS.n1494 VSS.n37 17.0005
R8015 VSS.n1452 VSS.n37 17.0005
R8016 VSS.n1495 VSS.n37 17.0005
R8017 VSS.n1451 VSS.n37 17.0005
R8018 VSS.n1496 VSS.n37 17.0005
R8019 VSS.n1450 VSS.n37 17.0005
R8020 VSS.n1497 VSS.n37 17.0005
R8021 VSS.n1449 VSS.n37 17.0005
R8022 VSS.n1498 VSS.n37 17.0005
R8023 VSS.n1448 VSS.n37 17.0005
R8024 VSS.n1499 VSS.n37 17.0005
R8025 VSS.n1447 VSS.n37 17.0005
R8026 VSS.n1500 VSS.n37 17.0005
R8027 VSS.n1446 VSS.n37 17.0005
R8028 VSS.n1501 VSS.n37 17.0005
R8029 VSS.n1445 VSS.n37 17.0005
R8030 VSS.n1502 VSS.n37 17.0005
R8031 VSS.n1444 VSS.n37 17.0005
R8032 VSS.n1503 VSS.n37 17.0005
R8033 VSS.n1443 VSS.n37 17.0005
R8034 VSS.n1504 VSS.n37 17.0005
R8035 VSS.n1442 VSS.n37 17.0005
R8036 VSS.n1505 VSS.n37 17.0005
R8037 VSS.n1441 VSS.n37 17.0005
R8038 VSS.n1506 VSS.n37 17.0005
R8039 VSS.n1440 VSS.n37 17.0005
R8040 VSS.t677 VSS.n37 17.0005
R8041 VSS.n1439 VSS.n37 17.0005
R8042 VSS.n1507 VSS.n37 17.0005
R8043 VSS.n1438 VSS.n37 17.0005
R8044 VSS.n1508 VSS.n37 17.0005
R8045 VSS.n1437 VSS.n37 17.0005
R8046 VSS.n1509 VSS.n37 17.0005
R8047 VSS.n1436 VSS.n37 17.0005
R8048 VSS.n1510 VSS.n37 17.0005
R8049 VSS.n1435 VSS.n37 17.0005
R8050 VSS.n1511 VSS.n37 17.0005
R8051 VSS.n1434 VSS.n37 17.0005
R8052 VSS.n1512 VSS.n37 17.0005
R8053 VSS.n1433 VSS.n37 17.0005
R8054 VSS.n1513 VSS.n37 17.0005
R8055 VSS.n1432 VSS.n37 17.0005
R8056 VSS.n1514 VSS.n37 17.0005
R8057 VSS.n1431 VSS.n37 17.0005
R8058 VSS.n1515 VSS.n37 17.0005
R8059 VSS.n1430 VSS.n37 17.0005
R8060 VSS.n1516 VSS.n37 17.0005
R8061 VSS.n1429 VSS.n37 17.0005
R8062 VSS.n1517 VSS.n37 17.0005
R8063 VSS.n1428 VSS.n37 17.0005
R8064 VSS.n1518 VSS.n37 17.0005
R8065 VSS.n1427 VSS.n37 17.0005
R8066 VSS.n1519 VSS.n37 17.0005
R8067 VSS.n1426 VSS.n37 17.0005
R8068 VSS.n1520 VSS.n37 17.0005
R8069 VSS.n1425 VSS.n37 17.0005
R8070 VSS.n1521 VSS.n37 17.0005
R8071 VSS.n1424 VSS.n37 17.0005
R8072 VSS.n1522 VSS.n37 17.0005
R8073 VSS.n1423 VSS.n37 17.0005
R8074 VSS.n1523 VSS.n37 17.0005
R8075 VSS.n1422 VSS.n37 17.0005
R8076 VSS.n1524 VSS.n37 17.0005
R8077 VSS.n1421 VSS.n37 17.0005
R8078 VSS.n1525 VSS.n37 17.0005
R8079 VSS.n1420 VSS.n37 17.0005
R8080 VSS.t669 VSS.n37 17.0005
R8081 VSS.n1419 VSS.n37 17.0005
R8082 VSS.n1526 VSS.n37 17.0005
R8083 VSS.n1418 VSS.n37 17.0005
R8084 VSS.n1527 VSS.n37 17.0005
R8085 VSS.n1417 VSS.n37 17.0005
R8086 VSS.n1528 VSS.n37 17.0005
R8087 VSS.n1416 VSS.n37 17.0005
R8088 VSS.n1529 VSS.n37 17.0005
R8089 VSS.n1415 VSS.n37 17.0005
R8090 VSS.n1530 VSS.n37 17.0005
R8091 VSS.n1414 VSS.n37 17.0005
R8092 VSS.n1531 VSS.n37 17.0005
R8093 VSS.n1413 VSS.n37 17.0005
R8094 VSS.n1532 VSS.n37 17.0005
R8095 VSS.n1412 VSS.n37 17.0005
R8096 VSS.n1533 VSS.n37 17.0005
R8097 VSS.n1411 VSS.n37 17.0005
R8098 VSS.n1534 VSS.n37 17.0005
R8099 VSS.n1410 VSS.n37 17.0005
R8100 VSS.n1535 VSS.n37 17.0005
R8101 VSS.n1409 VSS.n37 17.0005
R8102 VSS.n1536 VSS.n37 17.0005
R8103 VSS.n1408 VSS.n37 17.0005
R8104 VSS.n1537 VSS.n37 17.0005
R8105 VSS.n1407 VSS.n37 17.0005
R8106 VSS.n1538 VSS.n37 17.0005
R8107 VSS.n1406 VSS.n37 17.0005
R8108 VSS.n1997 VSS.n37 17.0005
R8109 VSS.n1996 VSS.n37 17.0005
R8110 VSS.n1993 VSS.n37 17.0005
R8111 VSS.n1992 VSS.n37 17.0005
R8112 VSS.n1991 VSS.n37 17.0005
R8113 VSS.n1990 VSS.n37 17.0005
R8114 VSS.n1989 VSS.n37 17.0005
R8115 VSS.n1988 VSS.n37 17.0005
R8116 VSS.n1987 VSS.n37 17.0005
R8117 VSS.n1986 VSS.n37 17.0005
R8118 VSS.n1985 VSS.n37 17.0005
R8119 VSS.n1984 VSS.n37 17.0005
R8120 VSS.n1983 VSS.n37 17.0005
R8121 VSS.n1982 VSS.n37 17.0005
R8122 VSS.n1981 VSS.n37 17.0005
R8123 VSS.n1980 VSS.n37 17.0005
R8124 VSS.n1979 VSS.n37 17.0005
R8125 VSS.n1978 VSS.n37 17.0005
R8126 VSS.n1977 VSS.n37 17.0005
R8127 VSS.n1976 VSS.n37 17.0005
R8128 VSS.n1975 VSS.n37 17.0005
R8129 VSS.n1974 VSS.n37 17.0005
R8130 VSS.n1541 VSS.n37 17.0005
R8131 VSS.n1540 VSS.n37 17.0005
R8132 VSS.n1998 VSS.n1540 17.0005
R8133 VSS.n1998 VSS.n1541 17.0005
R8134 VSS.n1998 VSS.n1974 17.0005
R8135 VSS.n1998 VSS.n1975 17.0005
R8136 VSS.n1998 VSS.n1976 17.0005
R8137 VSS.n1998 VSS.n1977 17.0005
R8138 VSS.n1998 VSS.n1978 17.0005
R8139 VSS.n1998 VSS.n1979 17.0005
R8140 VSS.n1998 VSS.n1980 17.0005
R8141 VSS.n1998 VSS.n1981 17.0005
R8142 VSS.n1998 VSS.n1982 17.0005
R8143 VSS.n1998 VSS.n1983 17.0005
R8144 VSS.n1998 VSS.n1984 17.0005
R8145 VSS.n1998 VSS.n1985 17.0005
R8146 VSS.n1998 VSS.n1986 17.0005
R8147 VSS.n1998 VSS.n1987 17.0005
R8148 VSS.n1998 VSS.n1988 17.0005
R8149 VSS.n1998 VSS.n1989 17.0005
R8150 VSS.n1998 VSS.n1990 17.0005
R8151 VSS.n1998 VSS.n1996 17.0005
R8152 VSS.n1998 VSS.n1993 17.0005
R8153 VSS.n1998 VSS.n1992 17.0005
R8154 VSS.n1998 VSS.n1991 17.0005
R8155 VSS.n1970 VSS.n1611 17.0005
R8156 VSS.n31 VSS.n1040 17.0005
R8157 VSS.n31 VSS.n1041 17.0005
R8158 VSS.n31 VSS.n1042 17.0005
R8159 VSS.n31 VSS.n1043 17.0005
R8160 VSS.n31 VSS.n1044 17.0005
R8161 VSS.t136 VSS.n1602 17.0005
R8162 VSS.t136 VSS.n1543 17.0005
R8163 VSS.t136 VSS.n1601 17.0005
R8164 VSS.t136 VSS.n1544 17.0005
R8165 VSS.n31 VSS.n1007 17.0005
R8166 VSS.n31 VSS.n1008 17.0005
R8167 VSS.n31 VSS.n1009 17.0005
R8168 VSS.n31 VSS.n1011 17.0005
R8169 VSS.n31 VSS.n1012 17.0005
R8170 VSS.n31 VSS.n1013 17.0005
R8171 VSS.n31 VSS.n1016 17.0005
R8172 VSS.n31 VSS.n1017 17.0005
R8173 VSS.n31 VSS.n1018 17.0005
R8174 VSS.n31 VSS.n1020 17.0005
R8175 VSS.n31 VSS.n1021 17.0005
R8176 VSS.n31 VSS.n1023 17.0005
R8177 VSS.n31 VSS.n1024 17.0005
R8178 VSS.n31 VSS.n1025 17.0005
R8179 VSS.n31 VSS.n1027 17.0005
R8180 VSS.n31 VSS.n1028 17.0005
R8181 VSS.n31 VSS.n1029 17.0005
R8182 VSS.n31 VSS.n1030 17.0005
R8183 VSS.n31 VSS.n1031 17.0005
R8184 VSS.n31 VSS.n1032 17.0005
R8185 VSS.n31 VSS.n1033 17.0005
R8186 VSS.n31 VSS.n1034 17.0005
R8187 VSS.n31 VSS.n1036 17.0005
R8188 VSS.n31 VSS.n1037 17.0005
R8189 VSS.n31 VSS.n1038 17.0005
R8190 VSS.n31 VSS.n1039 17.0005
R8191 VSS.t136 VSS.n1600 17.0005
R8192 VSS.t136 VSS.n1545 17.0005
R8193 VSS.t136 VSS.n1599 17.0005
R8194 VSS.t136 VSS.n1546 17.0005
R8195 VSS.t136 VSS.n1598 17.0005
R8196 VSS.t136 VSS.n1547 17.0005
R8197 VSS.t136 VSS.n1597 17.0005
R8198 VSS.t136 VSS.n1548 17.0005
R8199 VSS.t136 VSS.n1595 17.0005
R8200 VSS.t136 VSS.n1549 17.0005
R8201 VSS.t136 VSS.n1594 17.0005
R8202 VSS.t136 VSS.n1550 17.0005
R8203 VSS.t136 VSS.n1593 17.0005
R8204 VSS.t136 VSS.n1551 17.0005
R8205 VSS.t136 VSS.n1591 17.0005
R8206 VSS.t136 VSS.n1552 17.0005
R8207 VSS.t136 VSS.n1590 17.0005
R8208 VSS.t136 VSS.n1553 17.0005
R8209 VSS.t136 VSS.n1589 17.0005
R8210 VSS.t136 VSS.n1554 17.0005
R8211 VSS.t136 VSS.n1588 17.0005
R8212 VSS.t136 VSS.n1555 17.0005
R8213 VSS.t136 VSS.n1587 17.0005
R8214 VSS.t136 VSS.n1556 17.0005
R8215 VSS.t136 VSS.n1586 17.0005
R8216 VSS.t136 VSS.n1557 17.0005
R8217 VSS.t136 VSS.n1585 17.0005
R8218 VSS.t136 VSS.n1558 17.0005
R8219 VSS.t136 VSS.n1584 17.0005
R8220 VSS.t136 VSS.n1559 17.0005
R8221 VSS.t136 VSS.n1583 17.0005
R8222 VSS.n31 VSS.n1002 17.0005
R8223 VSS.n31 VSS.n1003 17.0005
R8224 VSS.n31 VSS.n1004 17.0005
R8225 VSS.n31 VSS.n1005 17.0005
R8226 VSS.t136 VSS.n1560 17.0005
R8227 VSS.t136 VSS.n1582 17.0005
R8228 VSS.t136 VSS.n1561 17.0005
R8229 VSS.t136 VSS.n1581 17.0005
R8230 VSS.n31 VSS.n985 17.0005
R8231 VSS.n31 VSS.n986 17.0005
R8232 VSS.n31 VSS.n987 17.0005
R8233 VSS.n31 VSS.n988 17.0005
R8234 VSS.n31 VSS.n989 17.0005
R8235 VSS.n31 VSS.n990 17.0005
R8236 VSS.n31 VSS.n991 17.0005
R8237 VSS.n31 VSS.n992 17.0005
R8238 VSS.n31 VSS.n993 17.0005
R8239 VSS.n31 VSS.n994 17.0005
R8240 VSS.n31 VSS.n995 17.0005
R8241 VSS.n31 VSS.n996 17.0005
R8242 VSS.n31 VSS.n997 17.0005
R8243 VSS.n31 VSS.n999 17.0005
R8244 VSS.n31 VSS.n1000 17.0005
R8245 VSS.n31 VSS.n1001 17.0005
R8246 VSS.t136 VSS.n1580 17.0005
R8247 VSS.t136 VSS.n1579 17.0005
R8248 VSS.t136 VSS.n1578 17.0005
R8249 VSS.t136 VSS.n1577 17.0005
R8250 VSS.t136 VSS.n1576 17.0005
R8251 VSS.t136 VSS.n1575 17.0005
R8252 VSS.t136 VSS.n1574 17.0005
R8253 VSS.t136 VSS.n1573 17.0005
R8254 VSS.t136 VSS.n1572 17.0005
R8255 VSS.t136 VSS.n1569 17.0005
R8256 VSS.t136 VSS.n1568 17.0005
R8257 VSS.t136 VSS.n1567 17.0005
R8258 VSS.t136 VSS.n1566 17.0005
R8259 VSS.t136 VSS.n1565 17.0005
R8260 VSS.t136 VSS.n1564 17.0005
R8261 VSS.t37 VSS.n1968 17.0005
R8262 VSS.t37 VSS.n1613 17.0005
R8263 VSS.t37 VSS.n1614 17.0005
R8264 VSS.t37 VSS.n1628 17.0005
R8265 VSS.t37 VSS.n1615 17.0005
R8266 VSS.t37 VSS.n1627 17.0005
R8267 VSS.n1969 VSS.t37 17.0005
R8268 VSS.t37 VSS.n1621 17.0005
R8269 VSS.t37 VSS.n1623 17.0005
R8270 VSS.n1785 VSS.n1633 17.0005
R8271 VSS.n1785 VSS.n1736 17.0005
R8272 VSS.n1785 VSS.n1784 17.0005
R8273 VSS.n1785 VSS.n1737 17.0005
R8274 VSS.n1785 VSS.n1783 17.0005
R8275 VSS.n1785 VSS.n1738 17.0005
R8276 VSS.n1785 VSS.n1781 17.0005
R8277 VSS.n1785 VSS.n1637 17.0005
R8278 VSS.n1785 VSS.n1780 17.0005
R8279 VSS.n1785 VSS.n1739 17.0005
R8280 VSS.n1785 VSS.n1778 17.0005
R8281 VSS.n1785 VSS.n1740 17.0005
R8282 VSS.n1785 VSS.n1776 17.0005
R8283 VSS.n1785 VSS.n1741 17.0005
R8284 VSS.n1785 VSS.n1775 17.0005
R8285 VSS.n1785 VSS.n1742 17.0005
R8286 VSS.n1785 VSS.n1643 17.0005
R8287 VSS.n1785 VSS.n1744 17.0005
R8288 VSS.n1785 VSS.n1773 17.0005
R8289 VSS.n1785 VSS.n1745 17.0005
R8290 VSS.n1785 VSS.n1771 17.0005
R8291 VSS.n1785 VSS.n1746 17.0005
R8292 VSS.n1785 VSS.n1770 17.0005
R8293 VSS.n1785 VSS.n1747 17.0005
R8294 VSS.n1785 VSS.n1768 17.0005
R8295 VSS.n1785 VSS.n1650 17.0005
R8296 VSS.n1785 VSS.n1767 17.0005
R8297 VSS.n1785 VSS.n1748 17.0005
R8298 VSS.n1785 VSS.n1765 17.0005
R8299 VSS.n1785 VSS.n1749 17.0005
R8300 VSS.n1785 VSS.n1763 17.0005
R8301 VSS.n1785 VSS.n1750 17.0005
R8302 VSS.n1785 VSS.n1762 17.0005
R8303 VSS.n1785 VSS.n1751 17.0005
R8304 VSS.n1785 VSS.n1760 17.0005
R8305 VSS.n1785 VSS.n1752 17.0005
R8306 VSS.n1785 VSS.n1759 17.0005
R8307 VSS.n1785 VSS.n1754 17.0005
R8308 VSS.n1785 VSS.n1661 17.0005
R8309 VSS.n1785 VSS.n1755 17.0005
R8310 VSS.n1785 VSS.n1757 17.0005
R8311 VSS.n1784 VSS.n1631 17.0005
R8312 VSS.n1737 VSS.n1631 17.0005
R8313 VSS.n1781 VSS.n1631 17.0005
R8314 VSS.n1740 VSS.n1631 17.0005
R8315 VSS.n1776 VSS.n1631 17.0005
R8316 VSS.n1742 VSS.n1631 17.0005
R8317 VSS.n1771 VSS.n1631 17.0005
R8318 VSS.n1746 VSS.n1631 17.0005
R8319 VSS.n1768 VSS.n1631 17.0005
R8320 VSS.n1958 VSS.n1631 17.0005
R8321 VSS.n1749 VSS.n1631 17.0005
R8322 VSS.n1763 VSS.n1631 17.0005
R8323 VSS.n1751 VSS.n1631 17.0005
R8324 VSS.n1760 VSS.n1631 17.0005
R8325 VSS.n1965 VSS.n1633 17.0005
R8326 VSS.n1965 VSS.n1637 17.0005
R8327 VSS.n1965 VSS.n1643 17.0005
R8328 VSS.n1965 VSS.n1650 17.0005
R8329 VSS.n1965 VSS.n1653 17.0005
R8330 VSS.n1965 VSS.n1661 17.0005
R8331 VSS.n1965 VSS.n1664 17.0005
R8332 VSS.n1755 VSS.n1631 17.0005
R8333 VSS.n1671 VSS.n1631 17.0005
R8334 VSS.n1789 VSS.n1785 17.0005
R8335 VSS.n1817 VSS.n0 17.0005
R8336 VSS.n1807 VSS.n0 17.0005
R8337 VSS.n1841 VSS.n0 17.0005
R8338 VSS.n1810 VSS.n0 17.0005
R8339 VSS.n1813 VSS.n0 17.0005
R8340 VSS.n1831 VSS.n0 17.0005
R8341 VSS.n3216 VSS.n695 17.0005
R8342 VSS.n3216 VSS.n697 17.0005
R8343 VSS.n3216 VSS.n729 17.0005
R8344 VSS.n3216 VSS.n733 17.0005
R8345 VSS.t1649 VSS.n953 16.9164
R8346 VSS.t1173 VSS.n967 16.4551
R8347 VSS.n1776 VSS.t1241 16.4539
R8348 VSS.t1646 VSS.n672 15.7754
R8349 VSS.n1849 VSS.n1245 15.4455
R8350 VSS.n1993 VSS.t2092 15.4455
R8351 VSS.t670 VSS.n1301 15.4455
R8352 VSS.n1521 VSS.t2264 15.4455
R8353 VSS.t1571 VSS.n1335 15.4455
R8354 VSS.t678 VSS.n1341 15.4455
R8355 VSS.n1502 VSS.t2260 15.4455
R8356 VSS.t685 VSS.n1382 15.4455
R8357 VSS.n1483 VSS.t460 15.4455
R8358 VSS.t1787 VSS.n1048 14.9842
R8359 VSS.t255 VSS.n179 14.757
R8360 VSS.t1516 VSS.n866 14.757
R8361 VSS.t2066 VSS.n1065 14.757
R8362 VSS.t864 VSS.n1751 14.2601
R8363 VSS.n1551 VSS.t318 13.954
R8364 VSS.t520 VSS.n932 13.7246
R8365 VSS.t328 VSS.n2562 13.7147
R8366 VSS.t899 VSS.t959 13.4836
R8367 VSS.n2585 VSS.n2584 13.0461
R8368 VSS.n2110 VSS.n1065 13.0461
R8369 VSS.n2093 VSS.t201 13.0461
R8370 VSS.n2106 VSS.n1071 13.0461
R8371 VSS.n3215 VSS.n176 13.0461
R8372 VSS.n689 VSS.n507 13.0461
R8373 VSS.t1618 VSS.n182 13.0461
R8374 VSS.n3218 VSS.n3217 13.0461
R8375 VSS.n685 VSS.n516 13.0461
R8376 VSS.n3213 VSS.n177 13.0461
R8377 VSS.n3212 VSS.n179 13.0461
R8378 VSS.n688 VSS.n509 13.0461
R8379 VSS.n691 VSS.t1618 13.0461
R8380 VSS.n3210 VSS.n184 13.0461
R8381 VSS.n3217 VSS.n174 13.0461
R8382 VSS.n686 VSS.n175 13.0461
R8383 VSS.n3214 VSS.n514 13.0461
R8384 VSS.n3213 VSS.n513 13.0461
R8385 VSS.n3211 VSS.n510 13.0461
R8386 VSS.n688 VSS.n181 13.0461
R8387 VSS.n691 VSS.n183 13.0461
R8388 VSS.n3210 VSS.n505 13.0461
R8389 VSS.n692 VSS.n186 13.0461
R8390 VSS.n693 VSS.n187 13.0461
R8391 VSS.n766 VSS.n765 13.0461
R8392 VSS.n771 VSS.n770 13.0461
R8393 VSS.n866 VSS.n865 13.0461
R8394 VSS.t123 VSS.n778 13.0461
R8395 VSS.n872 VSS.n764 13.0461
R8396 VSS.n868 VSS.n772 13.0461
R8397 VSS.n860 VSS.n776 13.0461
R8398 VSS.n858 VSS.n857 13.0461
R8399 VSS.n780 VSS.n779 13.0461
R8400 VSS.n853 VSS.n781 13.0461
R8401 VSS.n2973 VSS.n872 13.0461
R8402 VSS.n769 VSS.n768 13.0461
R8403 VSS.n871 VSS.n870 13.0461
R8404 VSS.n869 VSS.n868 13.0461
R8405 VSS.n863 VSS.n862 13.0461
R8406 VSS.n861 VSS.n860 13.0461
R8407 VSS.n857 VSS.n777 13.0461
R8408 VSS.n856 VSS.n778 13.0461
R8409 VSS.n779 VSS.t123 13.0461
R8410 VSS.n854 VSS.n853 13.0461
R8411 VSS.n782 VSS.n763 13.0461
R8412 VSS.n2976 VSS.n2975 13.0461
R8413 VSS.n2582 VSS.n1060 13.0461
R8414 VSS.n2111 VSS.n1063 13.0461
R8415 VSS.n2108 VSS.n1067 13.0461
R8416 VSS.n2091 VSS.n2079 13.0461
R8417 VSS.t201 VSS.n1068 13.0461
R8418 VSS.n2094 VSS.n2077 13.0461
R8419 VSS.n2086 VSS.n1060 13.0461
R8420 VSS.n2087 VSS.n1062 13.0461
R8421 VSS.n2113 VSS.n2085 13.0461
R8422 VSS.n2112 VSS.n2084 13.0461
R8423 VSS.n2088 VSS.n1063 13.0461
R8424 VSS.n2109 VSS.n2081 13.0461
R8425 VSS.n2090 VSS.n1067 13.0461
R8426 VSS.n2093 VSS.n1069 13.0461
R8427 VSS.n2107 VSS.n2077 13.0461
R8428 VSS.n2095 VSS.n1072 13.0461
R8429 VSS.n1664 VSS.n1630 12.4713
R8430 VSS.n1736 VSS.n1735 12.0761
R8431 VSS.n1782 VSS.n1738 12.0761
R8432 VSS.n1779 VSS.n1637 12.0761
R8433 VSS.n1778 VSS.n1777 12.0761
R8434 VSS.n1775 VSS.n1774 12.0761
R8435 VSS.n1743 VSS.n1643 12.0761
R8436 VSS.n1772 VSS.n1745 12.0761
R8437 VSS.n1769 VSS.n1747 12.0761
R8438 VSS.n1767 VSS.n1766 12.0761
R8439 VSS.n1765 VSS.n1764 12.0761
R8440 VSS.n1761 VSS.n1750 12.0761
R8441 VSS.n1759 VSS.n1758 12.0761
R8442 VSS.n1784 VSS.n1634 12.0761
R8443 VSS.n1783 VSS.n1635 12.0761
R8444 VSS.n1781 VSS.n1636 12.0761
R8445 VSS.n1739 VSS.n1638 12.0761
R8446 VSS.n1740 VSS.n1640 12.0761
R8447 VSS.n1741 VSS.n1641 12.0761
R8448 VSS.n1742 VSS.n1642 12.0761
R8449 VSS.n1773 VSS.n1644 12.0761
R8450 VSS.n1771 VSS.n1647 12.0761
R8451 VSS.n1770 VSS.n1648 12.0761
R8452 VSS.n1768 VSS.n1649 12.0761
R8453 VSS.n1748 VSS.n1651 12.0761
R8454 VSS.n1749 VSS.n1654 12.0761
R8455 VSS.n1750 VSS.n1655 12.0761
R8456 VSS.n1751 VSS.n1656 12.0761
R8457 VSS.n1752 VSS.n1657 12.0761
R8458 VSS.n1754 VSS.n1660 12.0761
R8459 VSS.n1757 VSS.n1662 12.0761
R8460 VSS.n1753 VSS.n1661 12.0761
R8461 VSS.n1756 VSS.n1664 12.0761
R8462 VSS.n1735 VSS.n1633 12.0761
R8463 VSS.n1736 VSS.n1634 12.0761
R8464 VSS.n1737 VSS.n1635 12.0761
R8465 VSS.n1783 VSS.n1782 12.0761
R8466 VSS.n1738 VSS.n1636 12.0761
R8467 VSS.n1780 VSS.n1779 12.0761
R8468 VSS.n1780 VSS.n1638 12.0761
R8469 VSS.n1777 VSS.n1739 12.0761
R8470 VSS.n1778 VSS.n1640 12.0761
R8471 VSS.n1776 VSS.n1641 12.0761
R8472 VSS.n1774 VSS.n1741 12.0761
R8473 VSS.n1775 VSS.n1642 12.0761
R8474 VSS.n1744 VSS.n1743 12.0761
R8475 VSS.n1744 VSS.n1644 12.0761
R8476 VSS.n1773 VSS.n1772 12.0761
R8477 VSS.n1745 VSS.n1647 12.0761
R8478 VSS.n1746 VSS.n1648 12.0761
R8479 VSS.n1770 VSS.n1769 12.0761
R8480 VSS.n1747 VSS.n1649 12.0761
R8481 VSS.n1766 VSS.n1650 12.0761
R8482 VSS.n1767 VSS.n1651 12.0761
R8483 VSS.n1764 VSS.n1748 12.0761
R8484 VSS.n1765 VSS.n1654 12.0761
R8485 VSS.n1763 VSS.n1655 12.0761
R8486 VSS.n1762 VSS.n1761 12.0761
R8487 VSS.n1762 VSS.n1656 12.0761
R8488 VSS.n1760 VSS.n1657 12.0761
R8489 VSS.n1758 VSS.n1752 12.0761
R8490 VSS.n1759 VSS.n1660 12.0761
R8491 VSS.n1754 VSS.n1753 12.0761
R8492 VSS.n1755 VSS.n1662 12.0761
R8493 VSS.n1757 VSS.n1756 12.0761
R8494 VSS.n1050 VSS.t1292 12.0423
R8495 VSS.n1972 VSS.n1241 12.0423
R8496 VSS.t1274 VSS.n181 11.8057
R8497 VSS.t1124 VSS.n776 11.8057
R8498 VSS.n2090 VSS.t2023 11.8057
R8499 VSS.n1412 VSS.t666 11.7681
R8500 VSS.n1517 VSS.t1569 11.7681
R8501 VSS.n1432 VSS.t673 11.7681
R8502 VSS.n1452 VSS.t681 11.7681
R8503 VSS.n969 VSS.t1786 10.5714
R8504 VSS.n1584 VSS.t1463 10.4656
R8505 VSS.t1172 VSS.t1658 10.4656
R8506 VSS.t899 VSS.n972 10.2971
R8507 VSS.n1982 VSS.t1611 9.56167
R8508 VSS.n1842 VSS.t2160 9.08698
R8509 VSS.n1840 VSS.t2160 9.0445
R8510 VSS.n1820 VSS.n1790 9.0005
R8511 VSS.n1833 VSS.n1790 9.0005
R8512 VSS.n1838 VSS.n1837 9.0005
R8513 VSS.n1837 VSS.n1836 9.0005
R8514 VSS.t252 VSS.n2100 8.501
R8515 VSS.n2301 VSS.t575 8.501
R8516 VSS.t577 VSS.n2303 8.501
R8517 VSS.n2304 VSS.t581 8.501
R8518 VSS.t585 VSS.n2306 8.501
R8519 VSS.n2308 VSS.t587 8.501
R8520 VSS.t589 VSS.n2310 8.501
R8521 VSS.n2311 VSS.t593 8.501
R8522 VSS.t556 VSS.n2313 8.501
R8523 VSS.n2314 VSS.t598 8.501
R8524 VSS.t600 VSS.n2316 8.501
R8525 VSS.n2317 VSS.t604 8.501
R8526 VSS.t608 VSS.n2319 8.501
R8527 VSS.n2320 VSS.t610 8.501
R8528 VSS.t612 VSS.n2322 8.501
R8529 VSS.n2323 VSS.t616 8.501
R8530 VSS.t620 VSS.n2325 8.501
R8531 VSS.n2326 VSS.t622 8.501
R8532 VSS.t624 VSS.n2328 8.501
R8533 VSS.n2329 VSS.t628 8.501
R8534 VSS.t120 VSS.n2331 8.501
R8535 VSS.n2332 VSS.t633 8.501
R8536 VSS.t636 VSS.n2204 8.501
R8537 VSS.t640 VSS.n2203 8.501
R8538 VSS.n659 VSS.t775 8.501
R8539 VSS.n655 VSS.t777 8.501
R8540 VSS.t779 VSS.n521 8.501
R8541 VSS.n650 VSS.t783 8.501
R8542 VSS.t418 VSS.n526 8.501
R8543 VSS.n642 VSS.t788 8.501
R8544 VSS.t790 VSS.n530 8.501
R8545 VSS.n636 VSS.t794 8.501
R8546 VSS.t798 VSS.n535 8.501
R8547 VSS.n628 VSS.t800 8.501
R8548 VSS.t802 VSS.n539 8.501
R8549 VSS.n623 VSS.t806 8.501
R8550 VSS.t810 VSS.n543 8.501
R8551 VSS.n606 VSS.t812 8.501
R8552 VSS.t814 VSS.n547 8.501
R8553 VSS.n601 VSS.t818 8.501
R8554 VSS.t421 VSS.n552 8.501
R8555 VSS.n593 VSS.t823 8.501
R8556 VSS.t825 VSS.n556 8.501
R8557 VSS.n588 VSS.t829 8.501
R8558 VSS.t424 VSS.n561 8.501
R8559 VSS.n580 VSS.t834 8.501
R8560 VSS.t837 VSS.n565 8.501
R8561 VSS.t841 VSS.n567 8.501
R8562 VSS.n3208 VSS.n168 88.4708
R8563 VSS.n165 VSS.n2831 233.198
R8564 VSS.n165 VSS.n167 0.00235708
R8565 VSS.n76 VSS.n1239 8.501
R8566 VSS.n1239 VSS.n79 8.501
R8567 VSS.n1239 VSS.n123 5.34012
R8568 VSS.n39 VSS.n1849 8.501
R8569 VSS.n1849 VSS.n41 2.83428
R8570 VSS.n41 VSS.n42 0.00249992
R8571 VSS.n1849 VSS.n44 4.25113
R8572 VSS.n1849 VSS.n45 4.251
R8573 VSS.n45 VSS.n48 0.00149997
R8574 VSS.n1849 VSS.n49 0.740404
R8575 VSS.n50 VSS.n51 0.471731
R8576 VSS.n52 VSS.n37 0.00173273
R8577 VSS.n54 VSS.n52 0.00172462
R8578 VSS.n55 VSS.n54 0.00170812
R8579 VSS.n56 VSS.n55 0.00166658
R8580 VSS.n59 VSS.n56 0.00149997
R8581 VSS.n60 VSS.n51 3.40102
R8582 VSS.n64 VSS.n51 3.40102
R8583 VSS.n66 VSS.n67 0.00216959
R8584 VSS.n68 VSS.n66 0.00170812
R8585 VSS.n69 VSS.n68 0.00166658
R8586 VSS.n72 VSS.n69 0.00149997
R8587 VSS.n73 VSS.n51 3.40102
R8588 VSS.t194 VSS.n32 2.42956
R8589 VSS.t194 VSS.n35 3.40102
R8590 VSS.n1914 VSS.n1725 8.501
R8591 VSS.n1914 VSS.n1723 8.501
R8592 VSS.n1914 VSS.n1722 8.501
R8593 VSS.n1914 VSS.n1721 8.501
R8594 VSS.n1914 VSS.n1726 8.501
R8595 VSS.n1914 VSS.n1728 8.501
R8596 VSS.n1914 VSS.n1720 8.501
R8597 VSS.n1914 VSS.n1729 8.501
R8598 VSS.n1914 VSS.n1730 8.501
R8599 VSS.n1914 VSS.n1731 8.501
R8600 VSS.n1914 VSS.n1719 8.501
R8601 VSS.n1914 VSS.n1717 8.501
R8602 VSS.n1914 VSS.n1732 8.501
R8603 VSS.n1914 VSS.n1716 8.501
R8604 VSS.n1914 VSS.n1733 8.501
R8605 VSS.n1914 VSS.n1734 8.501
R8606 VSS.n1914 VSS.n1714 8.501
R8607 VSS.n1948 VSS.n951 8.501
R8608 VSS.n1948 VSS.n1915 8.501
R8609 VSS.n1948 VSS.n1916 8.501
R8610 VSS.n1948 VSS.n1917 8.501
R8611 VSS.n1948 VSS.n1712 8.501
R8612 VSS.n1948 VSS.n1711 8.501
R8613 VSS.n1948 VSS.n1710 8.501
R8614 VSS.n1948 VSS.n1709 8.501
R8615 VSS.n1948 VSS.n1919 8.501
R8616 VSS.n1948 VSS.n1707 8.501
R8617 VSS.n1948 VSS.n1921 8.501
R8618 VSS.n1948 VSS.n1947 8.501
R8619 VSS.n1949 VSS.n1948 8.501
R8620 VSS.n1948 VSS.n1681 8.501
R8621 VSS.n1704 VSS.n11 2.42956
R8622 VSS.n15 VSS.n14 0.00216959
R8623 VSS.n14 VSS.n16 0.00170812
R8624 VSS.n16 VSS.n17 0.00166658
R8625 VSS.n17 VSS.n18 0.00149997
R8626 VSS.n1704 VSS.n19 3.40102
R8627 VSS.n1704 VSS.n21 3.40102
R8628 VSS.n24 VSS.n23 0.00216959
R8629 VSS.n23 VSS.n25 0.00170812
R8630 VSS.n25 VSS.n26 0.00166658
R8631 VSS.n26 VSS.n27 0.00149997
R8632 VSS.n1704 VSS.n28 3.40102
R8633 VSS.t2296 VSS.n1786 8.501
R8634 VSS.n3 VSS.n2 5.41263
R8635 VSS.n291 VSS.n498 8.5005
R8636 VSS.n291 VSS.n496 8.5005
R8637 VSS.n291 VSS.n494 8.5005
R8638 VSS.n291 VSS.n493 8.5005
R8639 VSS.n291 VSS.n491 8.5005
R8640 VSS.n291 VSS.n490 8.5005
R8641 VSS.n291 VSS.n488 8.5005
R8642 VSS.n291 VSS.n487 8.5005
R8643 VSS.n291 VSS.n486 8.5005
R8644 VSS.n291 VSS.n485 8.5005
R8645 VSS.n291 VSS.n484 8.5005
R8646 VSS.n291 VSS.n482 8.5005
R8647 VSS.n291 VSS.n481 8.5005
R8648 VSS.n291 VSS.n479 8.5005
R8649 VSS.n291 VSS.n478 8.5005
R8650 VSS.n291 VSS.n476 8.5005
R8651 VSS.n291 VSS.n475 8.5005
R8652 VSS.n291 VSS.n474 8.5005
R8653 VSS.n291 VSS.n473 8.5005
R8654 VSS.n291 VSS.n471 8.5005
R8655 VSS.n291 VSS.n469 8.5005
R8656 VSS.n291 VSS.n467 8.5005
R8657 VSS.n291 VSS.n465 8.5005
R8658 VSS.n291 VSS.n464 8.5005
R8659 VSS.n291 VSS.n462 8.5005
R8660 VSS.n291 VSS.n461 8.5005
R8661 VSS.n291 VSS.n460 8.5005
R8662 VSS.n291 VSS.n459 8.5005
R8663 VSS.n291 VSS.n458 8.5005
R8664 VSS.n291 VSS.n456 8.5005
R8665 VSS.n291 VSS.n455 8.5005
R8666 VSS.n291 VSS.n454 8.5005
R8667 VSS.n291 VSS.n453 8.5005
R8668 VSS.n291 VSS.n451 8.5005
R8669 VSS.n291 VSS.n450 8.5005
R8670 VSS.n291 VSS.n449 8.5005
R8671 VSS.n291 VSS.n448 8.5005
R8672 VSS.n291 VSS.n446 8.5005
R8673 VSS.n291 VSS.n445 8.5005
R8674 VSS.n291 VSS.n444 8.5005
R8675 VSS.n291 VSS.n443 8.5005
R8676 VSS.n291 VSS.n442 8.5005
R8677 VSS.n291 VSS.n440 8.5005
R8678 VSS.n291 VSS.n439 8.5005
R8679 VSS.n291 VSS.n438 8.5005
R8680 VSS.n291 VSS.n437 8.5005
R8681 VSS.n291 VSS.n436 8.5005
R8682 VSS.n291 VSS.n434 8.5005
R8683 VSS.n291 VSS.n433 8.5005
R8684 VSS.n291 VSS.n431 8.5005
R8685 VSS.n291 VSS.n430 8.5005
R8686 VSS.n291 VSS.n428 8.5005
R8687 VSS.n291 VSS.n427 8.5005
R8688 VSS.n291 VSS.n426 8.5005
R8689 VSS.n291 VSS.n425 8.5005
R8690 VSS.n291 VSS.n424 8.5005
R8691 VSS.n291 VSS.n422 8.5005
R8692 VSS.n291 VSS.n421 8.5005
R8693 VSS.n291 VSS.n420 8.5005
R8694 VSS.n291 VSS.n419 8.5005
R8695 VSS.n291 VSS.n417 8.5005
R8696 VSS.n291 VSS.n416 8.5005
R8697 VSS.n291 VSS.n415 8.5005
R8698 VSS.n291 VSS.n414 8.5005
R8699 VSS.n291 VSS.n413 8.5005
R8700 VSS.n291 VSS.n411 8.5005
R8701 VSS.n291 VSS.n409 8.5005
R8702 VSS.n291 VSS.n407 8.5005
R8703 VSS.n291 VSS.n406 8.5005
R8704 VSS.n291 VSS.n404 8.5005
R8705 VSS.n291 VSS.n403 8.5005
R8706 VSS.n291 VSS.n402 8.5005
R8707 VSS.n291 VSS.n401 8.5005
R8708 VSS.n291 VSS.n398 8.5005
R8709 VSS.n291 VSS.n396 8.5005
R8710 VSS.n291 VSS.n395 8.5005
R8711 VSS.n291 VSS.n394 8.5005
R8712 VSS.n291 VSS.n393 8.5005
R8713 VSS.n291 VSS.n391 8.5005
R8714 VSS.n291 VSS.n390 8.5005
R8715 VSS.n291 VSS.n389 8.5005
R8716 VSS.n291 VSS.n388 8.5005
R8717 VSS.n291 VSS.n385 8.5005
R8718 VSS.n291 VSS.n383 8.5005
R8719 VSS.n291 VSS.n382 8.5005
R8720 VSS.n291 VSS.n381 8.5005
R8721 VSS.n291 VSS.n380 8.5005
R8722 VSS.n291 VSS.n378 8.5005
R8723 VSS.n291 VSS.n377 8.5005
R8724 VSS.n291 VSS.n376 8.5005
R8725 VSS.n291 VSS.n375 8.5005
R8726 VSS.n291 VSS.n373 8.5005
R8727 VSS.n291 VSS.n371 8.5005
R8728 VSS.n291 VSS.n370 8.5005
R8729 VSS.n291 VSS.n368 8.5005
R8730 VSS.n291 VSS.n367 8.5005
R8731 VSS.n291 VSS.n365 8.5005
R8732 VSS.n291 VSS.n364 8.5005
R8733 VSS.n291 VSS.n363 8.5005
R8734 VSS.n291 VSS.n362 8.5005
R8735 VSS.n291 VSS.n361 8.5005
R8736 VSS.n291 VSS.n359 8.5005
R8737 VSS.n291 VSS.n358 8.5005
R8738 VSS.n291 VSS.n356 8.5005
R8739 VSS.n291 VSS.n355 8.5005
R8740 VSS.n291 VSS.n353 8.5005
R8741 VSS.n291 VSS.n352 8.5005
R8742 VSS.n291 VSS.n351 8.5005
R8743 VSS.n291 VSS.n350 8.5005
R8744 VSS.n291 VSS.n348 8.5005
R8745 VSS.n291 VSS.n346 8.5005
R8746 VSS.n291 VSS.n345 8.5005
R8747 VSS.n291 VSS.n342 8.5005
R8748 VSS.n291 VSS.n341 8.5005
R8749 VSS.n291 VSS.n339 8.5005
R8750 VSS.n291 VSS.n338 8.5005
R8751 VSS.n291 VSS.n337 8.5005
R8752 VSS.n291 VSS.n336 8.5005
R8753 VSS.n291 VSS.n333 8.5005
R8754 VSS.n291 VSS.n331 8.5005
R8755 VSS.n291 VSS.n330 8.5005
R8756 VSS.n291 VSS.n329 8.5005
R8757 VSS.n291 VSS.n328 8.5005
R8758 VSS.n291 VSS.n326 8.5005
R8759 VSS.n291 VSS.n325 8.5005
R8760 VSS.n291 VSS.n324 8.5005
R8761 VSS.n291 VSS.n323 8.5005
R8762 VSS.n291 VSS.n319 8.5005
R8763 VSS.n291 VSS.n317 8.5005
R8764 VSS.n291 VSS.n316 8.5005
R8765 VSS.n291 VSS.n315 8.5005
R8766 VSS.n291 VSS.n314 8.5005
R8767 VSS.n291 VSS.n312 8.5005
R8768 VSS.n291 VSS.n311 8.5005
R8769 VSS.n291 VSS.n310 8.5005
R8770 VSS.n291 VSS.n309 8.5005
R8771 VSS.n291 VSS.n307 8.5005
R8772 VSS.n291 VSS.n305 8.5005
R8773 VSS.n291 VSS.n303 8.5005
R8774 VSS.n291 VSS.n301 8.5005
R8775 VSS.n291 VSS.n300 8.5005
R8776 VSS.n291 VSS.n298 8.5005
R8777 VSS.n291 VSS.n297 8.5005
R8778 VSS.n291 VSS.n296 8.5005
R8779 VSS.n291 VSS.n295 8.5005
R8780 VSS.n2980 VSS.n170 8.5005
R8781 VSS.n2983 VSS.n170 8.5005
R8782 VSS.n2984 VSS.n170 8.5005
R8783 VSS.n2986 VSS.n170 8.5005
R8784 VSS.n2989 VSS.n170 8.5005
R8785 VSS.n2990 VSS.n170 8.5005
R8786 VSS.n2991 VSS.n170 8.5005
R8787 VSS.n2992 VSS.n170 8.5005
R8788 VSS.n2993 VSS.n170 8.5005
R8789 VSS.n2994 VSS.n170 8.5005
R8790 VSS.n2997 VSS.n170 8.5005
R8791 VSS.n2998 VSS.n170 8.5005
R8792 VSS.n3000 VSS.n170 8.5005
R8793 VSS.n3003 VSS.n170 8.5005
R8794 VSS.n3004 VSS.n170 8.5005
R8795 VSS.n3005 VSS.n170 8.5005
R8796 VSS.n3006 VSS.n170 8.5005
R8797 VSS.n3007 VSS.n170 8.5005
R8798 VSS.n3008 VSS.n170 8.5005
R8799 VSS.n3011 VSS.n170 8.5005
R8800 VSS.n3012 VSS.n170 8.5005
R8801 VSS.n3014 VSS.n170 8.5005
R8802 VSS.n3017 VSS.n170 8.5005
R8803 VSS.n3018 VSS.n170 8.5005
R8804 VSS.n3019 VSS.n170 8.5005
R8805 VSS.n3020 VSS.n170 8.5005
R8806 VSS.n3021 VSS.n170 8.5005
R8807 VSS.n3022 VSS.n170 8.5005
R8808 VSS.n3025 VSS.n170 8.5005
R8809 VSS.n3026 VSS.n170 8.5005
R8810 VSS.n3028 VSS.n170 8.5005
R8811 VSS.n3031 VSS.n170 8.5005
R8812 VSS.n3032 VSS.n170 8.5005
R8813 VSS.n3033 VSS.n170 8.5005
R8814 VSS.n3034 VSS.n170 8.5005
R8815 VSS.n3035 VSS.n170 8.5005
R8816 VSS.n3036 VSS.n170 8.5005
R8817 VSS.n3039 VSS.n170 8.5005
R8818 VSS.n3040 VSS.n170 8.5005
R8819 VSS.n3042 VSS.n170 8.5005
R8820 VSS.n3045 VSS.n170 8.5005
R8821 VSS.n3046 VSS.n170 8.5005
R8822 VSS.n3047 VSS.n170 8.5005
R8823 VSS.n3048 VSS.n170 8.5005
R8824 VSS.n3049 VSS.n170 8.5005
R8825 VSS.n3050 VSS.n170 8.5005
R8826 VSS.n3053 VSS.n170 8.5005
R8827 VSS.n3054 VSS.n170 8.5005
R8828 VSS.n3056 VSS.n170 8.5005
R8829 VSS.n3059 VSS.n170 8.5005
R8830 VSS.n3060 VSS.n170 8.5005
R8831 VSS.n3061 VSS.n170 8.5005
R8832 VSS.n3062 VSS.n170 8.5005
R8833 VSS.n3063 VSS.n170 8.5005
R8834 VSS.n3064 VSS.n170 8.5005
R8835 VSS.n3067 VSS.n170 8.5005
R8836 VSS.n3068 VSS.n170 8.5005
R8837 VSS.n3070 VSS.n170 8.5005
R8838 VSS.n3073 VSS.n170 8.5005
R8839 VSS.n3074 VSS.n170 8.5005
R8840 VSS.n3075 VSS.n170 8.5005
R8841 VSS.n3076 VSS.n170 8.5005
R8842 VSS.n3077 VSS.n170 8.5005
R8843 VSS.n3078 VSS.n170 8.5005
R8844 VSS.n3081 VSS.n170 8.5005
R8845 VSS.n3082 VSS.n170 8.5005
R8846 VSS.n3084 VSS.n170 8.5005
R8847 VSS.n3087 VSS.n170 8.5005
R8848 VSS.n3088 VSS.n170 8.5005
R8849 VSS.n3089 VSS.n170 8.5005
R8850 VSS.n3090 VSS.n170 8.5005
R8851 VSS.n3091 VSS.n170 8.5005
R8852 VSS.n3092 VSS.n170 8.5005
R8853 VSS.n3095 VSS.n170 8.5005
R8854 VSS.n3096 VSS.n170 8.5005
R8855 VSS.n3098 VSS.n170 8.5005
R8856 VSS.n3101 VSS.n170 8.5005
R8857 VSS.n3102 VSS.n170 8.5005
R8858 VSS.n3103 VSS.n170 8.5005
R8859 VSS.n3104 VSS.n170 8.5005
R8860 VSS.n3105 VSS.n170 8.5005
R8861 VSS.n3106 VSS.n170 8.5005
R8862 VSS.n3109 VSS.n170 8.5005
R8863 VSS.n3110 VSS.n170 8.5005
R8864 VSS.n3112 VSS.n170 8.5005
R8865 VSS.n3115 VSS.n170 8.5005
R8866 VSS.n3116 VSS.n170 8.5005
R8867 VSS.n3117 VSS.n170 8.5005
R8868 VSS.n3118 VSS.n170 8.5005
R8869 VSS.n3119 VSS.n170 8.5005
R8870 VSS.n3120 VSS.n170 8.5005
R8871 VSS.n3123 VSS.n170 8.5005
R8872 VSS.n3124 VSS.n170 8.5005
R8873 VSS.n3126 VSS.n170 8.5005
R8874 VSS.n3129 VSS.n170 8.5005
R8875 VSS.n3130 VSS.n170 8.5005
R8876 VSS.n3131 VSS.n170 8.5005
R8877 VSS.n3132 VSS.n170 8.5005
R8878 VSS.n3133 VSS.n170 8.5005
R8879 VSS.n3134 VSS.n170 8.5005
R8880 VSS.n3137 VSS.n170 8.5005
R8881 VSS.n3138 VSS.n170 8.5005
R8882 VSS.n3140 VSS.n170 8.5005
R8883 VSS.n3143 VSS.n170 8.5005
R8884 VSS.n3144 VSS.n170 8.5005
R8885 VSS.n3145 VSS.n170 8.5005
R8886 VSS.n3146 VSS.n170 8.5005
R8887 VSS.n3147 VSS.n170 8.5005
R8888 VSS.n3148 VSS.n170 8.5005
R8889 VSS.n3151 VSS.n170 8.5005
R8890 VSS.n3152 VSS.n170 8.5005
R8891 VSS.n3154 VSS.n170 8.5005
R8892 VSS.n3157 VSS.n170 8.5005
R8893 VSS.n3158 VSS.n170 8.5005
R8894 VSS.n3159 VSS.n170 8.5005
R8895 VSS.n3160 VSS.n170 8.5005
R8896 VSS.n3161 VSS.n170 8.5005
R8897 VSS.n3162 VSS.n170 8.5005
R8898 VSS.n3165 VSS.n170 8.5005
R8899 VSS.n3166 VSS.n170 8.5005
R8900 VSS.n3168 VSS.n170 8.5005
R8901 VSS.n3171 VSS.n170 8.5005
R8902 VSS.n3172 VSS.n170 8.5005
R8903 VSS.n3173 VSS.n170 8.5005
R8904 VSS.n3174 VSS.n170 8.5005
R8905 VSS.n3175 VSS.n170 8.5005
R8906 VSS.n3176 VSS.n170 8.5005
R8907 VSS.n3179 VSS.n170 8.5005
R8908 VSS.n3180 VSS.n170 8.5005
R8909 VSS.n3182 VSS.n170 8.5005
R8910 VSS.n3185 VSS.n170 8.5005
R8911 VSS.n3186 VSS.n170 8.5005
R8912 VSS.n3187 VSS.n170 8.5005
R8913 VSS.n3188 VSS.n170 8.5005
R8914 VSS.n3189 VSS.n170 8.5005
R8915 VSS.n3190 VSS.n170 8.5005
R8916 VSS.n3193 VSS.n170 8.5005
R8917 VSS.n3194 VSS.n170 8.5005
R8918 VSS.n3196 VSS.n170 8.5005
R8919 VSS.n3199 VSS.n170 8.5005
R8920 VSS.n3200 VSS.n170 8.5005
R8921 VSS.n3201 VSS.n170 8.5005
R8922 VSS.n3202 VSS.n170 8.5005
R8923 VSS.n3203 VSS.n170 8.5005
R8924 VSS.n3204 VSS.n170 8.5005
R8925 VSS.n3207 VSS.n170 8.5005
R8926 VSS.n2970 VSS.n2700 8.5005
R8927 VSS.n2970 VSS.n2702 8.5005
R8928 VSS.n2970 VSS.n2963 8.5005
R8929 VSS.n2970 VSS.n2706 8.5005
R8930 VSS.n2970 VSS.n2707 8.5005
R8931 VSS.n2970 VSS.n2960 8.5005
R8932 VSS.n2970 VSS.n2708 8.5005
R8933 VSS.n2970 VSS.n2959 8.5005
R8934 VSS.n2970 VSS.n2709 8.5005
R8935 VSS.n2970 VSS.n2958 8.5005
R8936 VSS.n2970 VSS.n2710 8.5005
R8937 VSS.n2970 VSS.n2955 8.5005
R8938 VSS.n2970 VSS.n2713 8.5005
R8939 VSS.n2970 VSS.n2715 8.5005
R8940 VSS.n2970 VSS.n2952 8.5005
R8941 VSS.n2970 VSS.n2716 8.5005
R8942 VSS.n2970 VSS.n2951 8.5005
R8943 VSS.n2970 VSS.n2717 8.5005
R8944 VSS.n2970 VSS.n2950 8.5005
R8945 VSS.n2970 VSS.n2718 8.5005
R8946 VSS.n2970 VSS.n2947 8.5005
R8947 VSS.n2970 VSS.n2722 8.5005
R8948 VSS.n2970 VSS.n2723 8.5005
R8949 VSS.n2970 VSS.n2944 8.5005
R8950 VSS.n2970 VSS.n2724 8.5005
R8951 VSS.n2970 VSS.n2943 8.5005
R8952 VSS.n2970 VSS.n2725 8.5005
R8953 VSS.n2970 VSS.n2942 8.5005
R8954 VSS.n2970 VSS.n2727 8.5005
R8955 VSS.n2970 VSS.n2940 8.5005
R8956 VSS.n2970 VSS.n2730 8.5005
R8957 VSS.n2970 VSS.n2731 8.5005
R8958 VSS.n2970 VSS.n2937 8.5005
R8959 VSS.n2970 VSS.n2732 8.5005
R8960 VSS.n2970 VSS.n2936 8.5005
R8961 VSS.n2970 VSS.n2734 8.5005
R8962 VSS.n2970 VSS.n2935 8.5005
R8963 VSS.n2970 VSS.n2735 8.5005
R8964 VSS.n2970 VSS.n2932 8.5005
R8965 VSS.n2970 VSS.n2737 8.5005
R8966 VSS.n2970 VSS.n2739 8.5005
R8967 VSS.n2970 VSS.n2929 8.5005
R8968 VSS.n2970 VSS.n2740 8.5005
R8969 VSS.n2970 VSS.n2928 8.5005
R8970 VSS.n2970 VSS.n2741 8.5005
R8971 VSS.n2970 VSS.n2927 8.5005
R8972 VSS.n2970 VSS.n2742 8.5005
R8973 VSS.n2970 VSS.n2924 8.5005
R8974 VSS.n2970 VSS.n2746 8.5005
R8975 VSS.n2970 VSS.n2748 8.5005
R8976 VSS.n2970 VSS.n2923 8.5005
R8977 VSS.n2970 VSS.n2749 8.5005
R8978 VSS.n2970 VSS.n2922 8.5005
R8979 VSS.n2970 VSS.n2750 8.5005
R8980 VSS.n2970 VSS.n2921 8.5005
R8981 VSS.n2970 VSS.n2751 8.5005
R8982 VSS.n2970 VSS.n2918 8.5005
R8983 VSS.n2970 VSS.n2754 8.5005
R8984 VSS.n2970 VSS.n2755 8.5005
R8985 VSS.n2970 VSS.n2915 8.5005
R8986 VSS.n2970 VSS.n2756 8.5005
R8987 VSS.n2970 VSS.n2914 8.5005
R8988 VSS.n2970 VSS.n2757 8.5005
R8989 VSS.n2970 VSS.n2913 8.5005
R8990 VSS.n2970 VSS.n2758 8.5005
R8991 VSS.n2970 VSS.n2910 8.5005
R8992 VSS.n2970 VSS.n2761 8.5005
R8993 VSS.n2970 VSS.n2763 8.5005
R8994 VSS.n2970 VSS.n2907 8.5005
R8995 VSS.n2970 VSS.n2764 8.5005
R8996 VSS.n2970 VSS.n2906 8.5005
R8997 VSS.n2970 VSS.n2765 8.5005
R8998 VSS.n2970 VSS.n2905 8.5005
R8999 VSS.n2970 VSS.n2766 8.5005
R9000 VSS.n2970 VSS.n2902 8.5005
R9001 VSS.n2970 VSS.n2770 8.5005
R9002 VSS.n2970 VSS.n2772 8.5005
R9003 VSS.n2970 VSS.n2900 8.5005
R9004 VSS.n2970 VSS.n2773 8.5005
R9005 VSS.n2970 VSS.n2899 8.5005
R9006 VSS.n2970 VSS.n2774 8.5005
R9007 VSS.n2970 VSS.n2898 8.5005
R9008 VSS.n2970 VSS.n2775 8.5005
R9009 VSS.n2970 VSS.n2894 8.5005
R9010 VSS.n2970 VSS.n2778 8.5005
R9011 VSS.n2970 VSS.n2779 8.5005
R9012 VSS.n2970 VSS.n2891 8.5005
R9013 VSS.n2970 VSS.n2780 8.5005
R9014 VSS.n2970 VSS.n2890 8.5005
R9015 VSS.n2970 VSS.n2781 8.5005
R9016 VSS.n2970 VSS.n2889 8.5005
R9017 VSS.n2970 VSS.n2782 8.5005
R9018 VSS.n2970 VSS.n2886 8.5005
R9019 VSS.n2970 VSS.n2785 8.5005
R9020 VSS.n2970 VSS.n2787 8.5005
R9021 VSS.n2970 VSS.n2883 8.5005
R9022 VSS.n2970 VSS.n2788 8.5005
R9023 VSS.n2970 VSS.n2882 8.5005
R9024 VSS.n2970 VSS.n2789 8.5005
R9025 VSS.n2970 VSS.n2881 8.5005
R9026 VSS.n2970 VSS.n2790 8.5005
R9027 VSS.n2970 VSS.n2878 8.5005
R9028 VSS.n2970 VSS.n2794 8.5005
R9029 VSS.n2970 VSS.n2796 8.5005
R9030 VSS.n2970 VSS.n2876 8.5005
R9031 VSS.n2970 VSS.n2797 8.5005
R9032 VSS.n2970 VSS.n2875 8.5005
R9033 VSS.n2970 VSS.n2798 8.5005
R9034 VSS.n2970 VSS.n2874 8.5005
R9035 VSS.n2970 VSS.n2799 8.5005
R9036 VSS.n2970 VSS.n2871 8.5005
R9037 VSS.n2970 VSS.n2802 8.5005
R9038 VSS.n2970 VSS.n2803 8.5005
R9039 VSS.n2970 VSS.n2868 8.5005
R9040 VSS.n2970 VSS.n2804 8.5005
R9041 VSS.n2970 VSS.n2867 8.5005
R9042 VSS.n2970 VSS.n2805 8.5005
R9043 VSS.n2970 VSS.n2866 8.5005
R9044 VSS.n2970 VSS.n2806 8.5005
R9045 VSS.n2970 VSS.n2863 8.5005
R9046 VSS.n2970 VSS.n2809 8.5005
R9047 VSS.n2970 VSS.n2811 8.5005
R9048 VSS.n2970 VSS.n2860 8.5005
R9049 VSS.n2970 VSS.n2812 8.5005
R9050 VSS.n2970 VSS.n2859 8.5005
R9051 VSS.n2970 VSS.n2813 8.5005
R9052 VSS.n2970 VSS.n2858 8.5005
R9053 VSS.n2970 VSS.n2814 8.5005
R9054 VSS.n2970 VSS.n2854 8.5005
R9055 VSS.n2970 VSS.n2817 8.5005
R9056 VSS.n2970 VSS.n2819 8.5005
R9057 VSS.n2970 VSS.n2851 8.5005
R9058 VSS.n2970 VSS.n2820 8.5005
R9059 VSS.n2970 VSS.n2850 8.5005
R9060 VSS.n2970 VSS.n2821 8.5005
R9061 VSS.n2970 VSS.n2849 8.5005
R9062 VSS.n2970 VSS.n2822 8.5005
R9063 VSS.n2970 VSS.n2846 8.5005
R9064 VSS.n2970 VSS.n2825 8.5005
R9065 VSS.n2970 VSS.n2826 8.5005
R9066 VSS.n2970 VSS.n2842 8.5005
R9067 VSS.n2970 VSS.n2827 8.5005
R9068 VSS.n2970 VSS.n2841 8.5005
R9069 VSS.n2970 VSS.n2828 8.5005
R9070 VSS.n2970 VSS.n2840 8.5005
R9071 VSS.n2970 VSS.n2838 8.5005
R9072 VSS.n2970 VSS.n2831 8.5005
R9073 VSS.n10 VSS.n953 8.5005
R9074 VSS.n78 VSS.n1120 8.5005
R9075 VSS.n78 VSS.n1121 8.5005
R9076 VSS.n78 VSS.n2072 8.5005
R9077 VSS.n78 VSS.n1125 8.5005
R9078 VSS.n78 VSS.n1126 8.5005
R9079 VSS.n78 VSS.n2071 8.5005
R9080 VSS.n78 VSS.n1127 8.5005
R9081 VSS.n78 VSS.n2070 8.5005
R9082 VSS.n78 VSS.n1128 8.5005
R9083 VSS.n78 VSS.n2069 8.5005
R9084 VSS.n78 VSS.n1129 8.5005
R9085 VSS.n78 VSS.n2068 8.5005
R9086 VSS.n78 VSS.n1132 8.5005
R9087 VSS.n78 VSS.n1133 8.5005
R9088 VSS.n78 VSS.n2067 8.5005
R9089 VSS.n78 VSS.n1134 8.5005
R9090 VSS.n78 VSS.n2066 8.5005
R9091 VSS.n78 VSS.n1135 8.5005
R9092 VSS.n78 VSS.n2065 8.5005
R9093 VSS.n78 VSS.n1136 8.5005
R9094 VSS.n78 VSS.n2064 8.5005
R9095 VSS.n78 VSS.n1139 8.5005
R9096 VSS.n78 VSS.n1140 8.5005
R9097 VSS.n78 VSS.n2063 8.5005
R9098 VSS.n78 VSS.n1141 8.5005
R9099 VSS.n78 VSS.n2062 8.5005
R9100 VSS.n78 VSS.n1142 8.5005
R9101 VSS.n78 VSS.n2061 8.5005
R9102 VSS.n78 VSS.n1143 8.5005
R9103 VSS.n78 VSS.n2060 8.5005
R9104 VSS.n78 VSS.n1146 8.5005
R9105 VSS.n78 VSS.n1147 8.5005
R9106 VSS.n78 VSS.n2059 8.5005
R9107 VSS.n78 VSS.n1148 8.5005
R9108 VSS.n78 VSS.n2058 8.5005
R9109 VSS.n78 VSS.n1150 8.5005
R9110 VSS.n78 VSS.n2057 8.5005
R9111 VSS.n78 VSS.n1151 8.5005
R9112 VSS.n78 VSS.n2056 8.5005
R9113 VSS.n78 VSS.n1153 8.5005
R9114 VSS.n78 VSS.n1154 8.5005
R9115 VSS.n78 VSS.n2055 8.5005
R9116 VSS.n78 VSS.n1155 8.5005
R9117 VSS.n78 VSS.n2054 8.5005
R9118 VSS.n78 VSS.n1156 8.5005
R9119 VSS.n78 VSS.n2053 8.5005
R9120 VSS.n78 VSS.n1157 8.5005
R9121 VSS.n78 VSS.n2052 8.5005
R9122 VSS.n78 VSS.n1160 8.5005
R9123 VSS.n78 VSS.n1161 8.5005
R9124 VSS.n78 VSS.n2051 8.5005
R9125 VSS.n78 VSS.n1162 8.5005
R9126 VSS.n78 VSS.n2050 8.5005
R9127 VSS.n78 VSS.n1163 8.5005
R9128 VSS.n78 VSS.n2049 8.5005
R9129 VSS.n78 VSS.n1164 8.5005
R9130 VSS.n78 VSS.n2048 8.5005
R9131 VSS.n78 VSS.n1167 8.5005
R9132 VSS.n78 VSS.n1168 8.5005
R9133 VSS.n78 VSS.n2047 8.5005
R9134 VSS.n78 VSS.n1169 8.5005
R9135 VSS.n78 VSS.n2046 8.5005
R9136 VSS.n78 VSS.n1170 8.5005
R9137 VSS.n78 VSS.n2045 8.5005
R9138 VSS.n78 VSS.n1171 8.5005
R9139 VSS.n78 VSS.n2044 8.5005
R9140 VSS.n78 VSS.n1174 8.5005
R9141 VSS.n78 VSS.n1175 8.5005
R9142 VSS.n78 VSS.n2043 8.5005
R9143 VSS.n78 VSS.n1176 8.5005
R9144 VSS.n78 VSS.n2042 8.5005
R9145 VSS.n78 VSS.n1177 8.5005
R9146 VSS.n78 VSS.n2041 8.5005
R9147 VSS.n78 VSS.n1178 8.5005
R9148 VSS.n78 VSS.n2040 8.5005
R9149 VSS.n78 VSS.n1181 8.5005
R9150 VSS.n78 VSS.n1182 8.5005
R9151 VSS.n78 VSS.n2039 8.5005
R9152 VSS.n78 VSS.n1183 8.5005
R9153 VSS.n78 VSS.n2038 8.5005
R9154 VSS.n78 VSS.n1184 8.5005
R9155 VSS.n78 VSS.n2037 8.5005
R9156 VSS.n78 VSS.n1185 8.5005
R9157 VSS.n78 VSS.n2035 8.5005
R9158 VSS.n78 VSS.n1188 8.5005
R9159 VSS.n78 VSS.n1189 8.5005
R9160 VSS.n78 VSS.n2034 8.5005
R9161 VSS.n78 VSS.n1190 8.5005
R9162 VSS.n78 VSS.n2033 8.5005
R9163 VSS.n78 VSS.n1191 8.5005
R9164 VSS.n78 VSS.n2032 8.5005
R9165 VSS.n78 VSS.n1192 8.5005
R9166 VSS.n78 VSS.n2031 8.5005
R9167 VSS.n78 VSS.n1195 8.5005
R9168 VSS.n78 VSS.n1196 8.5005
R9169 VSS.n78 VSS.n2030 8.5005
R9170 VSS.n78 VSS.n1197 8.5005
R9171 VSS.n78 VSS.n2029 8.5005
R9172 VSS.n78 VSS.n1198 8.5005
R9173 VSS.n78 VSS.n2028 8.5005
R9174 VSS.n78 VSS.n1199 8.5005
R9175 VSS.n78 VSS.n2027 8.5005
R9176 VSS.n78 VSS.n1202 8.5005
R9177 VSS.n78 VSS.n1203 8.5005
R9178 VSS.n78 VSS.n2026 8.5005
R9179 VSS.n78 VSS.n1204 8.5005
R9180 VSS.n78 VSS.n2025 8.5005
R9181 VSS.n78 VSS.n1205 8.5005
R9182 VSS.n78 VSS.n2024 8.5005
R9183 VSS.n78 VSS.n1206 8.5005
R9184 VSS.n78 VSS.n2023 8.5005
R9185 VSS.n78 VSS.n1209 8.5005
R9186 VSS.n78 VSS.n1210 8.5005
R9187 VSS.n78 VSS.n2022 8.5005
R9188 VSS.n78 VSS.n1211 8.5005
R9189 VSS.n78 VSS.n2021 8.5005
R9190 VSS.n78 VSS.n1212 8.5005
R9191 VSS.n78 VSS.n2020 8.5005
R9192 VSS.n78 VSS.n1213 8.5005
R9193 VSS.n78 VSS.n2019 8.5005
R9194 VSS.n78 VSS.n1216 8.5005
R9195 VSS.n78 VSS.n1217 8.5005
R9196 VSS.n78 VSS.n2018 8.5005
R9197 VSS.n78 VSS.n1218 8.5005
R9198 VSS.n78 VSS.n2017 8.5005
R9199 VSS.n78 VSS.n1219 8.5005
R9200 VSS.n78 VSS.n2016 8.5005
R9201 VSS.n78 VSS.n1220 8.5005
R9202 VSS.n78 VSS.n2014 8.5005
R9203 VSS.n78 VSS.n1223 8.5005
R9204 VSS.n78 VSS.n1224 8.5005
R9205 VSS.n78 VSS.n2013 8.5005
R9206 VSS.n78 VSS.n1225 8.5005
R9207 VSS.n78 VSS.n2012 8.5005
R9208 VSS.n78 VSS.n1226 8.5005
R9209 VSS.n78 VSS.n2011 8.5005
R9210 VSS.n78 VSS.n1227 8.5005
R9211 VSS.n78 VSS.n2010 8.5005
R9212 VSS.n78 VSS.n1230 8.5005
R9213 VSS.n78 VSS.n1231 8.5005
R9214 VSS.n78 VSS.n2009 8.5005
R9215 VSS.n78 VSS.n1232 8.5005
R9216 VSS.n78 VSS.n2008 8.5005
R9217 VSS.n78 VSS.n1233 8.5005
R9218 VSS.n78 VSS.n2007 8.5005
R9219 VSS.n78 VSS.n2005 8.5005
R9220 VSS.n2579 VSS.n2549 8.5005
R9221 VSS.n2579 VSS.n2546 8.5005
R9222 VSS.n2579 VSS.n2545 8.5005
R9223 VSS.n2579 VSS.n2543 8.5005
R9224 VSS.n2579 VSS.n2541 8.5005
R9225 VSS.n2579 VSS.n2540 8.5005
R9226 VSS.n2579 VSS.n2539 8.5005
R9227 VSS.n2579 VSS.n2538 8.5005
R9228 VSS.n2579 VSS.n2537 8.5005
R9229 VSS.n2579 VSS.n2535 8.5005
R9230 VSS.n2579 VSS.n2534 8.5005
R9231 VSS.n2579 VSS.n2533 8.5005
R9232 VSS.n2579 VSS.n2532 8.5005
R9233 VSS.n2579 VSS.n2530 8.5005
R9234 VSS.n2579 VSS.n2529 8.5005
R9235 VSS.n2579 VSS.n2528 8.5005
R9236 VSS.n2579 VSS.n2527 8.5005
R9237 VSS.n2579 VSS.n2525 8.5005
R9238 VSS.n2579 VSS.n2524 8.5005
R9239 VSS.n2579 VSS.n2522 8.5005
R9240 VSS.n2579 VSS.n2521 8.5005
R9241 VSS.n2579 VSS.n2519 8.5005
R9242 VSS.n2579 VSS.n2517 8.5005
R9243 VSS.n2579 VSS.n2516 8.5005
R9244 VSS.n2579 VSS.n2515 8.5005
R9245 VSS.n2579 VSS.n2514 8.5005
R9246 VSS.n2579 VSS.n2513 8.5005
R9247 VSS.n2579 VSS.n2511 8.5005
R9248 VSS.n2579 VSS.n2510 8.5005
R9249 VSS.n2579 VSS.n2509 8.5005
R9250 VSS.n2579 VSS.n2507 8.5005
R9251 VSS.n2579 VSS.n2504 8.5005
R9252 VSS.n2579 VSS.n2503 8.5005
R9253 VSS.n2579 VSS.n2502 8.5005
R9254 VSS.n2579 VSS.n2501 8.5005
R9255 VSS.n2579 VSS.n2500 8.5005
R9256 VSS.n2579 VSS.n2498 8.5005
R9257 VSS.n2579 VSS.n2496 8.5005
R9258 VSS.n2579 VSS.n2492 8.5005
R9259 VSS.n2579 VSS.n2490 8.5005
R9260 VSS.n2579 VSS.n2489 8.5005
R9261 VSS.n2579 VSS.n2488 8.5005
R9262 VSS.n2579 VSS.n2487 8.5005
R9263 VSS.n2579 VSS.n2486 8.5005
R9264 VSS.n2579 VSS.n2484 8.5005
R9265 VSS.n2579 VSS.n2482 8.5005
R9266 VSS.n2579 VSS.n2481 8.5005
R9267 VSS.n2579 VSS.n2479 8.5005
R9268 VSS.n2579 VSS.n2477 8.5005
R9269 VSS.n2579 VSS.n2476 8.5005
R9270 VSS.n2579 VSS.n2475 8.5005
R9271 VSS.n2579 VSS.n2474 8.5005
R9272 VSS.n2579 VSS.n2472 8.5005
R9273 VSS.n2579 VSS.n2471 8.5005
R9274 VSS.n2579 VSS.n2469 8.5005
R9275 VSS.n2579 VSS.n2468 8.5005
R9276 VSS.n2579 VSS.n2466 8.5005
R9277 VSS.n2579 VSS.n2465 8.5005
R9278 VSS.n2579 VSS.n2464 8.5005
R9279 VSS.n2579 VSS.n2463 8.5005
R9280 VSS.n2579 VSS.n2461 8.5005
R9281 VSS.n2579 VSS.n2460 8.5005
R9282 VSS.n2579 VSS.n2459 8.5005
R9283 VSS.n2579 VSS.n2458 8.5005
R9284 VSS.n2579 VSS.n2457 8.5005
R9285 VSS.n2579 VSS.n2455 8.5005
R9286 VSS.n2579 VSS.n2453 8.5005
R9287 VSS.n2579 VSS.n2452 8.5005
R9288 VSS.n2579 VSS.n2451 8.5005
R9289 VSS.n2579 VSS.n2450 8.5005
R9290 VSS.n2579 VSS.n2449 8.5005
R9291 VSS.n2579 VSS.n2447 8.5005
R9292 VSS.n2579 VSS.n2446 8.5005
R9293 VSS.n2579 VSS.n2445 8.5005
R9294 VSS.n2579 VSS.n2444 8.5005
R9295 VSS.n2579 VSS.n2442 8.5005
R9296 VSS.n2579 VSS.n2441 8.5005
R9297 VSS.n2579 VSS.n2440 8.5005
R9298 VSS.n2579 VSS.n2439 8.5005
R9299 VSS.n2579 VSS.n2438 8.5005
R9300 VSS.n2579 VSS.n2436 8.5005
R9301 VSS.n2579 VSS.n2431 8.5005
R9302 VSS.n2579 VSS.n2429 8.5005
R9303 VSS.n2579 VSS.n2428 8.5005
R9304 VSS.n2579 VSS.n2427 8.5005
R9305 VSS.n2579 VSS.n2426 8.5005
R9306 VSS.n2579 VSS.n2424 8.5005
R9307 VSS.n2579 VSS.n2423 8.5005
R9308 VSS.n2579 VSS.n2422 8.5005
R9309 VSS.n2579 VSS.n2421 8.5005
R9310 VSS.n2579 VSS.n2420 8.5005
R9311 VSS.n2579 VSS.n2418 8.5005
R9312 VSS.n2579 VSS.n2416 8.5005
R9313 VSS.n2579 VSS.n2415 8.5005
R9314 VSS.n2579 VSS.n2414 8.5005
R9315 VSS.n2579 VSS.n2413 8.5005
R9316 VSS.n2579 VSS.n2412 8.5005
R9317 VSS.n2579 VSS.n2410 8.5005
R9318 VSS.n2579 VSS.n2409 8.5005
R9319 VSS.n2579 VSS.n2408 8.5005
R9320 VSS.n2579 VSS.n2407 8.5005
R9321 VSS.n2579 VSS.n2405 8.5005
R9322 VSS.n2579 VSS.n2404 8.5005
R9323 VSS.n2579 VSS.n2403 8.5005
R9324 VSS.n2579 VSS.n2402 8.5005
R9325 VSS.n2579 VSS.n2401 8.5005
R9326 VSS.n2579 VSS.n2399 8.5005
R9327 VSS.n2579 VSS.n2398 8.5005
R9328 VSS.n2579 VSS.n2397 8.5005
R9329 VSS.n2579 VSS.n2395 8.5005
R9330 VSS.n2579 VSS.n2392 8.5005
R9331 VSS.n2579 VSS.n2391 8.5005
R9332 VSS.n2579 VSS.n2390 8.5005
R9333 VSS.n2579 VSS.n2389 8.5005
R9334 VSS.n2579 VSS.n2388 8.5005
R9335 VSS.n2579 VSS.n2386 8.5005
R9336 VSS.n2579 VSS.n2384 8.5005
R9337 VSS.n2579 VSS.n2383 8.5005
R9338 VSS.n2579 VSS.n2381 8.5005
R9339 VSS.n2579 VSS.n2378 8.5005
R9340 VSS.n2579 VSS.n2377 8.5005
R9341 VSS.n2579 VSS.n2376 8.5005
R9342 VSS.n2579 VSS.n2375 8.5005
R9343 VSS.n2579 VSS.n2372 8.5005
R9344 VSS.n2579 VSS.n2371 8.5005
R9345 VSS.n2579 VSS.n2367 8.5005
R9346 VSS.n2579 VSS.n2366 8.5005
R9347 VSS.n2579 VSS.n2364 8.5005
R9348 VSS.n2579 VSS.n2363 8.5005
R9349 VSS.n2579 VSS.n2362 8.5005
R9350 VSS.n2579 VSS.n2361 8.5005
R9351 VSS.n2579 VSS.n2360 8.5005
R9352 VSS.n2579 VSS.n2358 8.5005
R9353 VSS.n2579 VSS.n2357 8.5005
R9354 VSS.n2579 VSS.n2356 8.5005
R9355 VSS.n2579 VSS.n2354 8.5005
R9356 VSS.n2579 VSS.n2351 8.5005
R9357 VSS.n2579 VSS.n2350 8.5005
R9358 VSS.n2579 VSS.n2349 8.5005
R9359 VSS.n2579 VSS.n2348 8.5005
R9360 VSS.n2579 VSS.n2347 8.5005
R9361 VSS.n2579 VSS.n2346 8.5005
R9362 VSS.n2579 VSS.n2368 8.5005
R9363 VSS.n2579 VSS.n2432 8.5005
R9364 VSS.n2579 VSS.n2497 8.5005
R9365 VSS.n0 VSS.n1803 8.5005
R9366 VSS.n0 VSS.n1802 8.5005
R9367 VSS.n291 VSS.n289 8.49944
R9368 VSS.n2970 VSS.n927 8.49944
R9369 VSS.n1846 VSS.n1796 8.49109
R9370 VSS.n1832 VSS.n0 8.48883
R9371 VSS.n1819 VSS.n0 8.48883
R9372 VSS.n1788 VSS.n1631 8.48385
R9373 VSS.n2672 VSS.n170 8.48012
R9374 VSS.n2970 VSS.n2832 8.48012
R9375 VSS.n78 VSS.n1236 8.48012
R9376 VSS.n1866 VSS.n52 8.47784
R9377 VSS.n54 VSS.n53 8.47784
R9378 VSS.n55 VSS.n1865 8.47784
R9379 VSS.n1864 VSS.n56 8.47784
R9380 VSS.n59 VSS.n58 8.47784
R9381 VSS.n1862 VSS.n62 8.47784
R9382 VSS.n63 VSS.n1861 8.47784
R9383 VSS.n66 VSS.n65 8.47784
R9384 VSS.n68 VSS.n1858 8.47784
R9385 VSS.n1857 VSS.n69 8.47784
R9386 VSS.n72 VSS.n71 8.47784
R9387 VSS.n1855 VSS.n75 8.47784
R9388 VSS.n2579 VSS.n2114 8.47732
R9389 VSS.n2579 VSS.n2166 8.47732
R9390 VSS.n2579 VSS.t879 8.47732
R9391 VSS.n2336 VSS.n2202 8.47732
R9392 VSS.n291 VSS.n286 8.47732
R9393 VSS.n291 VSS.n276 8.47732
R9394 VSS.n291 VSS.n249 8.47732
R9395 VSS.n291 VSS.n218 8.47732
R9396 VSS.n291 VSS.n190 8.47732
R9397 VSS.n291 VSS.n503 8.47732
R9398 VSS.n291 VSS.n384 8.47732
R9399 VSS.n291 VSS.n318 8.47732
R9400 VSS.n291 VSS.t950 8.47732
R9401 VSS.n578 VSS.n577 8.47732
R9402 VSS.n2690 VSS.n170 8.47732
R9403 VSS.n2686 VSS.n170 8.47732
R9404 VSS.n2685 VSS.n170 8.47732
R9405 VSS.t939 VSS.n170 8.47732
R9406 VSS.n2670 VSS.n170 8.47732
R9407 VSS.n2668 VSS.n170 8.47732
R9408 VSS.n2659 VSS.n170 8.47732
R9409 VSS.n2639 VSS.n170 8.47732
R9410 VSS.n2619 VSS.n170 8.47732
R9411 VSS.n2602 VSS.n170 8.47732
R9412 VSS.n2970 VSS.n2968 8.47732
R9413 VSS.n2970 VSS.n2776 8.47732
R9414 VSS.n2970 VSS.n2815 8.47732
R9415 VSS.n2970 VSS.t926 8.47732
R9416 VSS.n2833 VSS.n166 8.47732
R9417 VSS.n167 VSS.n2834 8.47732
R9418 VSS.n2970 VSS.n925 8.47732
R9419 VSS.n2970 VSS.n924 8.47732
R9420 VSS.n2970 VSS.n918 8.47732
R9421 VSS.n2970 VSS.n904 8.47732
R9422 VSS.n2970 VSS.n890 8.47732
R9423 VSS.n2970 VSS.n876 8.47732
R9424 VSS.n10 VSS.n946 8.47732
R9425 VSS.n10 VSS.n959 8.47732
R9426 VSS.n10 VSS.n952 8.47732
R9427 VSS.n78 VSS.n2076 8.47732
R9428 VSS.n78 VSS.n1186 8.47732
R9429 VSS.n78 VSS.n1221 8.47732
R9430 VSS.n78 VSS.t891 8.47732
R9431 VSS.n1237 VSS.n76 8.47732
R9432 VSS.n79 VSS.n1238 8.47732
R9433 VSS.n78 VSS.n1115 8.47732
R9434 VSS.n78 VSS.n1114 8.47732
R9435 VSS.n78 VSS.n1110 8.47732
R9436 VSS.n78 VSS.n1098 8.47732
R9437 VSS.n78 VSS.n1086 8.47732
R9438 VSS.n78 VSS.n1074 8.47732
R9439 VSS.n2579 VSS.n2554 8.47732
R9440 VSS.n2579 VSS.n2495 8.47732
R9441 VSS.n2579 VSS.n2345 8.47732
R9442 VSS.n2579 VSS.n2369 8.47732
R9443 VSS.n2579 VSS.n2434 8.47732
R9444 VSS.n1605 VSS.n33 8.47732
R9445 VSS.t513 VSS.n34 8.47732
R9446 VSS.n1606 VSS.n36 8.47732
R9447 VSS.n1892 VSS.n1891 8.47732
R9448 VSS.n1893 VSS.n1890 8.47732
R9449 VSS.n1894 VSS.n1889 8.47732
R9450 VSS.n1895 VSS.n1888 8.47732
R9451 VSS.n1897 VSS.n1886 8.47732
R9452 VSS.n1898 VSS.n1885 8.47732
R9453 VSS.n1899 VSS.n1884 8.47732
R9454 VSS.n1900 VSS.n1883 8.47732
R9455 VSS.n1901 VSS.n1882 8.47732
R9456 VSS.n1902 VSS.n1881 8.47732
R9457 VSS.n1904 VSS.n1879 8.47732
R9458 VSS.n1905 VSS.n1878 8.47732
R9459 VSS.n1906 VSS.n1877 8.47732
R9460 VSS.n1907 VSS.n1876 8.47732
R9461 VSS.n1908 VSS.n1875 8.47732
R9462 VSS.n1910 VSS.n1873 8.47732
R9463 VSS.t906 VSS.n1936 8.47732
R9464 VSS.t960 VSS.n1937 8.47732
R9465 VSS.n1935 VSS.n1934 8.47732
R9466 VSS.t961 VSS.n1938 8.47732
R9467 VSS.t962 VSS.n1939 8.47732
R9468 VSS.n1940 VSS.n1931 8.47732
R9469 VSS.n1941 VSS.n1930 8.47732
R9470 VSS.t963 VSS.n1943 8.47732
R9471 VSS.n1926 VSS.n1927 8.47732
R9472 VSS.n1924 VSS.n1923 8.47732
R9473 VSS.n1946 VSS.n1945 8.47732
R9474 VSS.n1922 VSS.n1682 8.47732
R9475 VSS.t967 VSS.n1950 8.47732
R9476 VSS.n1951 VSS.n1678 8.47732
R9477 VSS.n1672 VSS.n1631 8.47732
R9478 VSS.t900 VSS.n12 8.47732
R9479 VSS.n1689 VSS.n13 8.47732
R9480 VSS.n1691 VSS.n14 8.47732
R9481 VSS.n1692 VSS.n16 8.47732
R9482 VSS.n1693 VSS.n17 8.47732
R9483 VSS.n1694 VSS.n18 8.47732
R9484 VSS.t957 VSS.n20 8.47732
R9485 VSS.n1696 VSS.n22 8.47732
R9486 VSS.n1684 VSS.n23 8.47732
R9487 VSS.n1698 VSS.n25 8.47732
R9488 VSS.n1699 VSS.n26 8.47732
R9489 VSS.n1700 VSS.n27 8.47732
R9490 VSS.n1702 VSS.n30 8.47732
R9491 VSS.n1965 VSS.n1659 8.47732
R9492 VSS.n1814 VSS.n0 8.47732
R9493 VSS.n1809 VSS.n0 8.47732
R9494 VSS.n1804 VSS.n0 8.47732
R9495 VSS.n0 VSS.n5 8.47732
R9496 VSS.n1825 VSS.n0 8.47732
R9497 VSS.n1829 VSS.n0 8.47732
R9498 VSS.n1850 VSS.n39 8.47677
R9499 VSS.n38 VSS.n40 8.47677
R9500 VSS.n1798 VSS.n42 8.47677
R9501 VSS.n1847 VSS.n44 8.47677
R9502 VSS.n43 VSS.n1848 8.47677
R9503 VSS.n1795 VSS.n46 8.47677
R9504 VSS.n1794 VSS.n48 8.47677
R9505 VSS.n1793 VSS.n47 8.47677
R9506 VSS.n1965 VSS.n1665 8.46924
R9507 VSS.n1602 VSS.n1044 6.99351
R9508 VSS.n1581 VSS.n1002 6.99351
R9509 VSS.t1778 VSS.n1005 6.99351
R9510 VSS.n1591 VSS.t871 6.97724
R9511 VSS.n1600 VSS.n1039 6.97724
R9512 VSS.t667 VSS.n1288 6.61977
R9513 VSS.t1567 VSS.n1296 6.61977
R9514 VSS.t675 VSS.n1328 6.61977
R9515 VSS.t682 VSS.n1368 6.61977
R9516 VSS.n37 VSS.n50 0.77815
R9517 VSS.n1967 VSS.n1630 6.23614
R9518 VSS.n694 VSS.n187 5.90311
R9519 VSS.n2977 VSS.n2976 5.90311
R9520 VSS.n2104 VSS.n2095 5.90311
R9521 VSS.n961 VSS.n948 5.66778
R9522 VSS.n1849 VSS.n1791 5.66778
R9523 VSS.n57 VSS.n60 0.00229996
R9524 VSS.n61 VSS.n64 0.00229996
R9525 VSS.n67 VSS.n51 1.54575
R9526 VSS.n70 VSS.n73 0.00229996
R9527 VSS.n1475 VSS.n51 5.66778
R9528 VSS.n32 VSS.n31 0.00249991
R9529 VSS.n35 VSS.n1603 0.00229996
R9530 VSS.t194 VSS.n1609 5.66778
R9531 VSS.t194 VSS.n1244 5.66778
R9532 VSS.n1914 VSS.n1727 5.66778
R9533 VSS.n1914 VSS.n1718 5.66778
R9534 VSS.n1914 VSS.n1715 5.66778
R9535 VSS.n1948 VSS.n1713 5.66778
R9536 VSS.n1948 VSS.n1918 5.66778
R9537 VSS.n1948 VSS.n1708 5.66778
R9538 VSS.n1948 VSS.n1920 5.66778
R9539 VSS.n1948 VSS.n1706 5.66778
R9540 VSS.n11 VSS.n10 0.00249991
R9541 VSS.n1704 VSS.n15 1.54575
R9542 VSS.n19 VSS.n1687 0.00229996
R9543 VSS.n21 VSS.n1685 0.00229996
R9544 VSS.n1704 VSS.n24 1.54575
R9545 VSS.n28 VSS.n1683 0.00229996
R9546 VSS.n1704 VSS.n1632 5.66778
R9547 VSS.n2970 VSS.n926 5.63915
R9548 VSS.n2682 VSS.n170 5.63915
R9549 VSS.n78 VSS.n1116 5.63915
R9550 VSS.n57 VSS.n1863 5.62674
R9551 VSS.n61 VSS.n1854 5.62674
R9552 VSS.n1860 VSS.n1859 5.62674
R9553 VSS.n70 VSS.n1856 5.62674
R9554 VSS.n74 VSS.t1578 5.62674
R9555 VSS.n1724 VSS.n945 5.62581
R9556 VSS.n10 VSS.n947 5.62581
R9557 VSS.n1604 VSS.n1603 5.62581
R9558 VSS.n1608 VSS.n1607 5.62581
R9559 VSS.t196 VSS.n1243 5.62581
R9560 VSS.n1896 VSS.n1887 5.62581
R9561 VSS.n1903 VSS.n1880 5.62581
R9562 VSS.n1909 VSS.n1874 5.62581
R9563 VSS.n1912 VSS.n1911 5.62581
R9564 VSS.n1932 VSS.n1933 5.62581
R9565 VSS.n1929 VSS.n1942 5.62581
R9566 VSS.n1944 VSS.n1928 5.62581
R9567 VSS.t965 VSS.n1925 5.62581
R9568 VSS.n1680 VSS.n1679 5.62581
R9569 VSS.n1690 VSS.n1688 5.62581
R9570 VSS.n1695 VSS.n1687 5.62581
R9571 VSS.n1686 VSS.n1685 5.62581
R9572 VSS.t958 VSS.n1697 5.62581
R9573 VSS.n1701 VSS.n1683 5.62581
R9574 VSS.n29 VSS.n1703 5.62581
R9575 VSS.n1843 VSS.n0 5.62581
R9576 VSS.n1799 VSS.n1797 5.62484
R9577 VSS.t136 VSS.n1571 5.61485
R9578 VSS.t1239 VSS.n1737 5.48496
R9579 VSS.n2577 VSS.n2575 5.45726
R9580 VSS.n3221 VSS.n3220 5.31969
R9581 VSS.n1117 VSS.n1058 5.31969
R9582 VSS.n2596 VSS.n2595 5.31969
R9583 VSS.n2589 VSS.n2588 5.31969
R9584 VSS.n2599 VSS.n2598 5.31969
R9585 VSS.n2697 VSS.n2696 5.31969
R9586 VSS.n957 VSS.n943 5.31791
R9587 VSS.n1540 VSS.n1245 5.14882
R9588 VSS.n1541 VSS.n1246 5.14882
R9589 VSS.n1974 VSS.n1247 5.14882
R9590 VSS.n1975 VSS.n1248 5.14882
R9591 VSS.n1976 VSS.n1249 5.14882
R9592 VSS.n1977 VSS.n1250 5.14882
R9593 VSS.n1978 VSS.n1251 5.14882
R9594 VSS.n1979 VSS.n1252 5.14882
R9595 VSS.n1980 VSS.n1253 5.14882
R9596 VSS.n1981 VSS.n1254 5.14882
R9597 VSS.n1982 VSS.n1255 5.14882
R9598 VSS.n1984 VSS.n1257 5.14882
R9599 VSS.n1985 VSS.n1258 5.14882
R9600 VSS.n1986 VSS.n1259 5.14882
R9601 VSS.n1987 VSS.n1260 5.14882
R9602 VSS.n1988 VSS.n1261 5.14882
R9603 VSS.n1989 VSS.n1262 5.14882
R9604 VSS.n1990 VSS.n1263 5.14882
R9605 VSS.n1991 VSS.n1264 5.14882
R9606 VSS.n1992 VSS.n1265 5.14882
R9607 VSS.n1993 VSS.n1266 5.14882
R9608 VSS.n1996 VSS.n1267 5.14882
R9609 VSS.n1997 VSS.n1269 5.14882
R9610 VSS.n1406 VSS.n1270 5.14882
R9611 VSS.n1538 VSS.n1271 5.14882
R9612 VSS.n1407 VSS.n1272 5.14882
R9613 VSS.n1537 VSS.n1273 5.14882
R9614 VSS.n1408 VSS.n1274 5.14882
R9615 VSS.n1536 VSS.n1275 5.14882
R9616 VSS.n1409 VSS.n1276 5.14882
R9617 VSS.n1535 VSS.n1277 5.14882
R9618 VSS.n1410 VSS.n1278 5.14882
R9619 VSS.n1534 VSS.n1279 5.14882
R9620 VSS.n1411 VSS.n1280 5.14882
R9621 VSS.n1533 VSS.n1281 5.14882
R9622 VSS.n1412 VSS.n1282 5.14882
R9623 VSS.n1532 VSS.n1283 5.14882
R9624 VSS.n1413 VSS.n1284 5.14882
R9625 VSS.n1531 VSS.n1285 5.14882
R9626 VSS.n1414 VSS.n1286 5.14882
R9627 VSS.n1530 VSS.n1287 5.14882
R9628 VSS.n1415 VSS.n1288 5.14882
R9629 VSS.n1529 VSS.n1289 5.14882
R9630 VSS.n1416 VSS.n1290 5.14882
R9631 VSS.n1528 VSS.n1291 5.14882
R9632 VSS.n1417 VSS.n1292 5.14882
R9633 VSS.n1527 VSS.n1293 5.14882
R9634 VSS.n1418 VSS.n1294 5.14882
R9635 VSS.n1526 VSS.n1295 5.14882
R9636 VSS.n1419 VSS.n1296 5.14882
R9637 VSS.t669 VSS.n1297 5.14882
R9638 VSS.n1420 VSS.n1298 5.14882
R9639 VSS.n1525 VSS.n1299 5.14882
R9640 VSS.n1421 VSS.n1300 5.14882
R9641 VSS.n1524 VSS.n1301 5.14882
R9642 VSS.n1422 VSS.n1302 5.14882
R9643 VSS.n1523 VSS.n1303 5.14882
R9644 VSS.n1423 VSS.n1304 5.14882
R9645 VSS.n1522 VSS.n1305 5.14882
R9646 VSS.n1424 VSS.n1306 5.14882
R9647 VSS.n1521 VSS.n1307 5.14882
R9648 VSS.n1425 VSS.n1308 5.14882
R9649 VSS.n1520 VSS.n1309 5.14882
R9650 VSS.n1426 VSS.n1310 5.14882
R9651 VSS.n1519 VSS.n1311 5.14882
R9652 VSS.n1427 VSS.n1312 5.14882
R9653 VSS.n1518 VSS.n1313 5.14882
R9654 VSS.n1428 VSS.n1314 5.14882
R9655 VSS.n1517 VSS.n1315 5.14882
R9656 VSS.n1429 VSS.n1316 5.14882
R9657 VSS.n1516 VSS.n1317 5.14882
R9658 VSS.n1430 VSS.n1318 5.14882
R9659 VSS.n1515 VSS.n1319 5.14882
R9660 VSS.n1431 VSS.n1320 5.14882
R9661 VSS.n1514 VSS.n1321 5.14882
R9662 VSS.n1432 VSS.n1322 5.14882
R9663 VSS.n1513 VSS.n1323 5.14882
R9664 VSS.n1433 VSS.n1324 5.14882
R9665 VSS.n1512 VSS.n1325 5.14882
R9666 VSS.n1434 VSS.n1326 5.14882
R9667 VSS.n1511 VSS.n1327 5.14882
R9668 VSS.n1435 VSS.n1328 5.14882
R9669 VSS.n1510 VSS.n1329 5.14882
R9670 VSS.n1436 VSS.n1330 5.14882
R9671 VSS.n1509 VSS.n1331 5.14882
R9672 VSS.n1437 VSS.n1332 5.14882
R9673 VSS.n1508 VSS.n1333 5.14882
R9674 VSS.n1438 VSS.n1334 5.14882
R9675 VSS.n1507 VSS.n1335 5.14882
R9676 VSS.n1439 VSS.n1336 5.14882
R9677 VSS.t677 VSS.n1337 5.14882
R9678 VSS.n1440 VSS.n1338 5.14882
R9679 VSS.n1506 VSS.n1339 5.14882
R9680 VSS.n1441 VSS.n1340 5.14882
R9681 VSS.n1505 VSS.n1341 5.14882
R9682 VSS.n1442 VSS.n1342 5.14882
R9683 VSS.n1504 VSS.n1343 5.14882
R9684 VSS.n1443 VSS.n1344 5.14882
R9685 VSS.n1503 VSS.n1345 5.14882
R9686 VSS.n1444 VSS.n1346 5.14882
R9687 VSS.n1502 VSS.n1347 5.14882
R9688 VSS.n1445 VSS.n1348 5.14882
R9689 VSS.n1501 VSS.n1349 5.14882
R9690 VSS.n1446 VSS.n1350 5.14882
R9691 VSS.n1500 VSS.n1351 5.14882
R9692 VSS.n1447 VSS.n1352 5.14882
R9693 VSS.n1499 VSS.n1353 5.14882
R9694 VSS.n1448 VSS.n1354 5.14882
R9695 VSS.n1498 VSS.n1355 5.14882
R9696 VSS.n1449 VSS.n1356 5.14882
R9697 VSS.n1497 VSS.n1357 5.14882
R9698 VSS.n1450 VSS.n1358 5.14882
R9699 VSS.n1496 VSS.n1359 5.14882
R9700 VSS.n1451 VSS.n1360 5.14882
R9701 VSS.n1495 VSS.n1361 5.14882
R9702 VSS.n1452 VSS.n1362 5.14882
R9703 VSS.n1494 VSS.n1363 5.14882
R9704 VSS.n1453 VSS.n1364 5.14882
R9705 VSS.n1493 VSS.n1365 5.14882
R9706 VSS.n1455 VSS.n1366 5.14882
R9707 VSS.n1492 VSS.n1367 5.14882
R9708 VSS.n1456 VSS.n1368 5.14882
R9709 VSS.n1491 VSS.n1369 5.14882
R9710 VSS.n1457 VSS.n1370 5.14882
R9711 VSS.n1490 VSS.n1371 5.14882
R9712 VSS.n1459 VSS.n1373 5.14882
R9713 VSS.n1489 VSS.n1374 5.14882
R9714 VSS.n1460 VSS.n1375 5.14882
R9715 VSS.n1488 VSS.n1376 5.14882
R9716 VSS.n1461 VSS.n1377 5.14882
R9717 VSS.t684 VSS.n1378 5.14882
R9718 VSS.n1462 VSS.n1379 5.14882
R9719 VSS.n1487 VSS.n1380 5.14882
R9720 VSS.n1463 VSS.n1381 5.14882
R9721 VSS.n1486 VSS.n1382 5.14882
R9722 VSS.n1464 VSS.n1383 5.14882
R9723 VSS.n1485 VSS.n1384 5.14882
R9724 VSS.n1465 VSS.n1385 5.14882
R9725 VSS.n1484 VSS.n1386 5.14882
R9726 VSS.n1466 VSS.n1387 5.14882
R9727 VSS.n1483 VSS.n1388 5.14882
R9728 VSS.n1467 VSS.n1389 5.14882
R9729 VSS.n1482 VSS.n1390 5.14882
R9730 VSS.n1468 VSS.n1391 5.14882
R9731 VSS.n1481 VSS.n1392 5.14882
R9732 VSS.n1469 VSS.n1393 5.14882
R9733 VSS.n1480 VSS.n1394 5.14882
R9734 VSS.n1470 VSS.n1395 5.14882
R9735 VSS.n1479 VSS.n1396 5.14882
R9736 VSS.n1471 VSS.n1397 5.14882
R9737 VSS.n1478 VSS.n1398 5.14882
R9738 VSS.n1472 VSS.n1399 5.14882
R9739 VSS.n1477 VSS.n1400 5.14882
R9740 VSS.n1473 VSS.n1401 5.14882
R9741 VSS.n1476 VSS.n1402 5.14882
R9742 VSS.n1474 VSS.n1403 5.14882
R9743 VSS.n1999 VSS.n1404 5.14882
R9744 VSS.n2000 VSS.n1405 5.14882
R9745 VSS.n1818 VSS.n1596 5.13648
R9746 VSS.n1801 VSS.t1018 4.98596
R9747 VSS.n1868 VSS.n1790 4.63796
R9748 VSS.n1818 VSS.t1181 4.4712
R9749 VSS.t2221 VSS.n1254 4.41335
R9750 VSS.n3219 VSS.t1645 4.28393
R9751 VSS.n1563 VSS.n1562 4.25123
R9752 VSS.n1914 VSS.n1913 4.25119
R9753 VSS.n1948 VSS.n1705 4.251
R9754 VSS.n2494 VSS 4.19743
R9755 VSS.n1085 VSS 4.19743
R9756 VSS.n889 VSS 4.19743
R9757 VSS.n2677 VSS 4.19743
R9758 VSS.n217 VSS 4.19743
R9759 VSS.n1867 VSS.n37 4.19666
R9760 VSS.n1965 VSS.n1666 4.19639
R9761 VSS.n2974 VSS.n826 4.19238
R9762 VSS.t573 VSS.n2300 4.19225
R9763 VSS.t584 VSS.n2281 4.19225
R9764 VSS.t596 VSS.n2265 4.19225
R9765 VSS.t607 VSS.n2238 4.19225
R9766 VSS.t619 VSS.n2222 4.19225
R9767 VSS.t631 VSS.n2207 4.19225
R9768 VSS.n660 VSS.t774 4.19225
R9769 VSS.t786 VSS.n649 4.19225
R9770 VSS.t797 VSS.n635 4.19225
R9771 VSS.t809 VSS.n621 4.19225
R9772 VSS.t821 VSS.n600 4.19225
R9773 VSS.t832 VSS.n587 4.19225
R9774 VSS.n2002 VSS.n1268 4.19225
R9775 VSS.n1965 VSS.n1663 4.19225
R9776 VSS.n1962 VSS.n1631 4.19225
R9777 VSS.n1839 VSS.n0 4.19225
R9778 VSS.n3216 VSS.n737 4.19225
R9779 VSS.t1186 VSS.n1611 4.177
R9780 VSS.n2595 VSS.n2594 4.07175
R9781 VSS.n958 VSS.n957 4.07175
R9782 VSS.n2588 VSS.n2587 4.07175
R9783 VSS.n50 VSS.n1405 6.12122
R9784 VSS.n2433 VSS 3.94223
R9785 VSS.n1097 VSS 3.94223
R9786 VSS.n903 VSS 3.94223
R9787 VSS.n2679 VSS 3.94223
R9788 VSS.n248 VSS 3.94223
R9789 VSS VSS.n3221 3.92317
R9790 VSS.t435 VSS 3.92317
R9791 VSS.n641 VSS 3.92317
R9792 VSS.t321 VSS 3.92317
R9793 VSS.t836 VSS 3.92317
R9794 VSS.n2575 VSS 3.92317
R9795 VSS.t1918 VSS 3.92317
R9796 VSS.n1117 VSS 3.92317
R9797 VSS.t241 VSS 3.92317
R9798 VSS.t2251 VSS 3.92317
R9799 VSS.n2588 VSS 3.92317
R9800 VSS.n1645 VSS 3.92317
R9801 VSS.n1953 VSS 3.92317
R9802 VSS.n957 VSS 3.92317
R9803 VSS.t1580 VSS 3.92317
R9804 VSS.n1871 VSS 3.92317
R9805 VSS.n2595 VSS 3.92317
R9806 VSS.t1590 VSS 3.92317
R9807 VSS.t1229 VSS 3.92317
R9808 VSS.t2065 VSS 3.92317
R9809 VSS.n2598 VSS 3.92317
R9810 VSS.t1136 VSS 3.92317
R9811 VSS.t696 VSS 3.92317
R9812 VSS.n825 VSS 3.92317
R9813 VSS.t725 VSS 3.92317
R9814 VSS.t1438 VSS 3.92317
R9815 VSS.t1874 VSS 3.92317
R9816 VSS.t264 VSS 3.92317
R9817 VSS.n2696 VSS 3.92317
R9818 VSS.t1480 VSS 3.92317
R9819 VSS.t1903 VSS 3.92317
R9820 VSS.t1215 VSS 3.92317
R9821 VSS.t739 VSS 3.92317
R9822 VSS.n736 VSS 3.92317
R9823 VSS.t769 VSS 3.92317
R9824 VSS.t1409 VSS 3.92317
R9825 VSS.t1701 VSS 3.92317
R9826 VSS.t247 VSS 3.92317
R9827 VSS.t254 VSS 3.92317
R9828 VSS.t2114 VSS 3.92317
R9829 VSS.n2307 VSS 3.92317
R9830 VSS.n2251 VSS 3.92317
R9831 VSS.t635 VSS 3.92317
R9832 VSS.t1035 VSS 3.92317
R9833 VSS.n2374 VSS 3.90557
R9834 VSS.n1109 VSS 3.90557
R9835 VSS.t1839 VSS 3.90557
R9836 VSS.t846 VSS 3.90557
R9837 VSS.n917 VSS 3.90557
R9838 VSS.n2681 VSS 3.90557
R9839 VSS.t79 VSS 3.90557
R9840 VSS.t1006 VSS 3.90557
R9841 VSS.n275 VSS 3.90557
R9842 VSS.t410 VSS 3.90557
R9843 VSS.n3219 VSS.t2076 3.84219
R9844 VSS.t327 VSS.n2577 3.84219
R9845 VSS.n2586 VSS.t200 3.84219
R9846 VSS.t519 VSS.n2699 3.84219
R9847 VSS.t122 VSS.n2600 3.84219
R9848 VSS.n2576 VSS.t277 3.84119
R9849 VSS.t129 VSS.n2590 3.84041
R9850 VSS.n2698 VSS.t170 3.84041
R9851 VSS.t1596 VSS.n172 3.84041
R9852 VSS.n1553 VSS.t44 3.48887
R9853 VSS.n1591 VSS.t659 3.48887
R9854 VSS.n847 VSS.n2835 3.47694
R9855 VSS.n1372 VSS.n2001 3.47693
R9856 VSS.n758 VSS.n2684 3.47693
R9857 VSS.t2383 VSS.t883 3.39224
R9858 VSS.t413 VSS.t954 3.39224
R9859 VSS.n2336 VSS.t638 3.35686
R9860 VSS.n577 VSS.t839 3.35686
R9861 VSS.n496 VSS.t1103 3.34498
R9862 VSS.n491 VSS.t567 3.34498
R9863 VSS.n484 VSS.t367 3.34498
R9864 VSS.n479 VSS.t2162 3.34498
R9865 VSS.n471 VSS.t1359 3.34498
R9866 VSS.n465 VSS.t2375 3.34498
R9867 VSS.n458 VSS.t1107 3.34498
R9868 VSS.n454 VSS.t1111 3.34498
R9869 VSS.n446 VSS.t1330 3.34498
R9870 VSS.n443 VSS.t1113 3.34498
R9871 VSS.n436 VSS.t1109 3.34498
R9872 VSS.n431 VSS.t2248 3.34498
R9873 VSS.n424 VSS.t2376 3.34498
R9874 VSS.n420 VSS.t1355 3.34498
R9875 VSS.n413 VSS.t1358 3.34498
R9876 VSS.n407 VSS.t543 3.34498
R9877 VSS.n398 VSS.t1104 3.34498
R9878 VSS.n394 VSS.t1106 3.34498
R9879 VSS.n385 VSS.t2389 3.34498
R9880 VSS.n381 VSS.t2258 3.34498
R9881 VSS.n373 VSS.t1356 3.34498
R9882 VSS.n368 VSS.t463 3.34498
R9883 VSS.n361 VSS.t465 3.34498
R9884 VSS.n356 VSS.t2374 3.34498
R9885 VSS.n348 VSS.t2373 3.34498
R9886 VSS.n342 VSS.t466 3.34498
R9887 VSS.n333 VSS.t373 3.34498
R9888 VSS.n329 VSS.t482 3.34498
R9889 VSS.n319 VSS.t2388 3.34498
R9890 VSS.n315 VSS.t545 3.34498
R9891 VSS.n307 VSS.t384 3.34498
R9892 VSS.n301 VSS.t1863 3.34498
R9893 VSS.t1205 VSS.n2983 3.34498
R9894 VSS.t502 VSS.n2989 3.34498
R9895 VSS.t458 VSS.n2997 3.34498
R9896 VSS.t1860 VSS.n3003 3.34498
R9897 VSS.t2047 VSS.n3011 3.34498
R9898 VSS.t1851 VSS.n3017 3.34498
R9899 VSS.t1332 VSS.n3025 3.34498
R9900 VSS.t386 VSS.n3031 3.34498
R9901 VSS.t137 VSS.n3039 3.34498
R9902 VSS.t1334 VSS.n3045 3.34498
R9903 VSS.t1642 VSS.n3053 3.34498
R9904 VSS.t1718 VSS.n3059 3.34498
R9905 VSS.t497 VSS.n3067 3.34498
R9906 VSS.t1723 VSS.n3073 3.34498
R9907 VSS.t1862 VSS.n3081 3.34498
R9908 VSS.t1088 VSS.n3087 3.34498
R9909 VSS.t1715 VSS.n3095 3.34498
R9910 VSS.t1073 VSS.n3101 3.34498
R9911 VSS.t511 VSS.n3109 3.34498
R9912 VSS.t547 VSS.n3115 3.34498
R9913 VSS.t1090 VSS.n3123 3.34498
R9914 VSS.t2094 VSS.n3129 3.34498
R9915 VSS.t1114 VSS.n3137 3.34498
R9916 VSS.t138 VSS.n3143 3.34498
R9917 VSS.t559 VSS.n3151 3.34498
R9918 VSS.t563 VSS.n3157 3.34498
R9919 VSS.t1713 VSS.n3165 3.34498
R9920 VSS.t1092 VSS.n3171 3.34498
R9921 VSS.t1635 VSS.n3179 3.34498
R9922 VSS.t1337 VSS.n3185 3.34498
R9923 VSS.t1859 VSS.n3193 3.34498
R9924 VSS.t2365 VSS.n3199 3.34498
R9925 VSS.t452 VSS.n2702 3.34498
R9926 VSS.t375 VSS.n2707 3.34498
R9927 VSS.t376 VSS.n2710 3.34498
R9928 VSS.t542 VSS.n2715 3.34498
R9929 VSS.t1727 VSS.n2718 3.34498
R9930 VSS.t1201 VSS.n2723 3.34498
R9931 VSS.t1049 VSS.n2727 3.34498
R9932 VSS.t1696 VSS.n2731 3.34498
R9933 VSS.t1123 VSS.n2735 3.34498
R9934 VSS.t1129 VSS.n2739 3.34498
R9935 VSS.t2380 VSS.n2742 3.34498
R9936 VSS.t108 VSS.n2748 3.34498
R9937 VSS.t1097 VSS.n2751 3.34498
R9938 VSS.t156 VSS.n2755 3.34498
R9939 VSS.t1212 VSS.n2758 3.34498
R9940 VSS.t284 VSS.n2763 3.34498
R9941 VSS.t441 VSS.n2766 3.34498
R9942 VSS.t1861 VSS.n2772 3.34498
R9943 VSS.t457 VSS.n2775 3.34498
R9944 VSS.t1714 VSS.n2779 3.34498
R9945 VSS.t2386 VSS.n2782 3.34498
R9946 VSS.t2240 VSS.n2787 3.34498
R9947 VSS.t2370 VSS.n2790 3.34498
R9948 VSS.t540 VSS.n2796 3.34498
R9949 VSS.t2362 VSS.n2799 3.34498
R9950 VSS.t2259 VSS.n2803 3.34498
R9951 VSS.t143 VSS.n2806 3.34498
R9952 VSS.t1865 VSS.n2811 3.34498
R9953 VSS.t2071 VSS.n2814 3.34498
R9954 VSS.t2390 VSS.n2819 3.34498
R9955 VSS.t473 VSS.n2822 3.34498
R9956 VSS.t145 VSS.n2826 3.34498
R9957 VSS.t1121 VSS.n1121 3.34498
R9958 VSS.t1119 VSS.n1126 3.34498
R9959 VSS.t1047 VSS.n1129 3.34498
R9960 VSS.t1045 VSS.n1133 3.34498
R9961 VSS.t1095 VSS.n1136 3.34498
R9962 VSS.t1093 VSS.n1140 3.34498
R9963 VSS.t1717 VSS.n1143 3.34498
R9964 VSS.t1716 VSS.n1147 3.34498
R9965 VSS.t1087 VSS.n1151 3.34498
R9966 VSS.t1085 VSS.n1154 3.34498
R9967 VSS.t1065 VSS.n1157 3.34498
R9968 VSS.t1063 VSS.n1161 3.34498
R9969 VSS.t2050 VSS.n1164 3.34498
R9970 VSS.t2049 VSS.n1168 3.34498
R9971 VSS.t1038 VSS.n1171 3.34498
R9972 VSS.t1036 VSS.n1175 3.34498
R9973 VSS.t1729 VSS.n1178 3.34498
R9974 VSS.t1728 VSS.n1182 3.34498
R9975 VSS.t2 VSS.n1185 3.34498
R9976 VSS.t0 VSS.n1189 3.34498
R9977 VSS.t2148 VSS.n1192 3.34498
R9978 VSS.t2147 VSS.n1196 3.34498
R9979 VSS.t447 VSS.n1199 3.34498
R9980 VSS.t442 VSS.n1203 3.34498
R9981 VSS.t282 VSS.n1206 3.34498
R9982 VSS.t280 VSS.n1210 3.34498
R9983 VSS.t468 VSS.n1213 3.34498
R9984 VSS.t322 VSS.n1217 3.34498
R9985 VSS.t569 VSS.n1220 3.34498
R9986 VSS.t1562 VSS.n1224 3.34498
R9987 VSS.t2387 VSS.n1227 3.34498
R9988 VSS.t1039 VSS.n1231 3.34498
R9989 VSS.n2546 VSS.t1634 3.34498
R9990 VSS.n2541 VSS.t1633 3.34498
R9991 VSS.n2534 VSS.t440 3.34498
R9992 VSS.n2530 VSS.t439 3.34498
R9993 VSS.n2522 VSS.t1210 3.34498
R9994 VSS.n2517 VSS.t1208 3.34498
R9995 VSS.n2510 VSS.t2385 3.34498
R9996 VSS.n2504 VSS.t2384 3.34498
R9997 VSS.n2497 VSS.t141 3.34498
R9998 VSS.n2490 VSS.t140 3.34498
R9999 VSS.n2482 VSS.t2361 3.34498
R10000 VSS.n2477 VSS.t2360 3.34498
R10001 VSS.n2469 VSS.t2369 3.34498
R10002 VSS.n2465 VSS.t2368 3.34498
R10003 VSS.n2458 VSS.t2070 3.34498
R10004 VSS.n2453 VSS.t2069 3.34498
R10005 VSS.n2446 VSS.t455 3.34498
R10006 VSS.n2442 VSS.t453 3.34498
R10007 VSS.n2432 VSS.t1336 3.34498
R10008 VSS.n2428 VSS.t1335 3.34498
R10009 VSS.n2421 VSS.t1101 3.34498
R10010 VSS.n2416 VSS.t1099 3.34498
R10011 VSS.n2409 VSS.t2364 3.34498
R10012 VSS.n2405 VSS.t2363 3.34498
R10013 VSS.n2398 VSS.t558 3.34498
R10014 VSS.n2392 VSS.t557 3.34498
R10015 VSS.n2384 VSS.t1145 3.34498
R10016 VSS.n2378 VSS.t1143 3.34498
R10017 VSS.n2368 VSS.t1726 3.34498
R10018 VSS.n2364 VSS.t1724 3.34498
R10019 VSS.n2357 VSS.t2379 3.34498
R10020 VSS.n2351 VSS.t2377 3.34498
R10021 VSS.n291 VSS.n185 3.32778
R10022 VSS.n2970 VSS.n874 3.32778
R10023 VSS.n1834 VSS.n0 3.32697
R10024 VSS.n2579 VSS.n2126 3.3265
R10025 VSS.n2618 VSS.n170 3.3265
R10026 VSS.n2970 VSS.n2733 3.3265
R10027 VSS.n78 VSS.n1149 3.3265
R10028 VSS.n10 VSS.n944 3.32633
R10029 VSS.n291 VSS.n447 3.32623
R10030 VSS.n291 VSS.t1966 3.32623
R10031 VSS.n1965 VSS.n1667 3.32623
R10032 VSS.n1812 VSS.n0 3.32623
R10033 VSS.n2579 VSS.t2226 3.32615
R10034 VSS.t1627 VSS.n170 3.32615
R10035 VSS.n2970 VSS.t1133 3.32615
R10036 VSS.n78 VSS.t372 3.32615
R10037 VSS.n31 VSS.n962 3.21582
R10038 VSS.n31 VSS.n1054 3.21582
R10039 VSS.n31 VSS.n967 3.21582
R10040 VSS.n31 VSS.n969 3.21582
R10041 VSS.n31 VSS.n1050 3.21582
R10042 VSS.n31 VSS.n1048 3.21582
R10043 VSS.n2003 VSS.n2002 3.21582
R10044 VSS.n2002 VSS.n1241 3.21582
R10045 VSS.t94 VSS.n505 2.9518
R10046 VSS.n854 VSS.t536 2.9518
R10047 VSS.n2107 VSS.t2060 2.9518
R10048 VSS.n1983 VSS.t1563 2.9424
R10049 VSS.n1448 VSS.t1573 2.9424
R10050 VSS.n2579 VSS.n2343 2.77707
R10051 VSS.n291 VSS.n292 2.77706
R10052 VSS.n2318 VSS.n2240 2.75331
R10053 VSS.n1868 VSS.t1579 2.7456
R10054 VSS.n2601 VSS.n170 2.74446
R10055 VSS.n78 VSS.n1070 2.74446
R10056 VSS.n2579 VSS.n2558 2.74446
R10057 VSS.n2579 VSS.n2159 2.7443
R10058 VSS.n2666 VSS.n170 2.7443
R10059 VSS.n2970 VSS.n2839 2.7443
R10060 VSS.n78 VSS.n2006 2.7443
R10061 VSS.n291 VSS.n294 2.74422
R10062 VSS.n291 VSS.n193 2.74414
R10063 VSS.n2970 VSS.n878 2.74414
R10064 VSS.n2579 VSS.n2544 2.74414
R10065 VSS.n291 VSS.n495 2.74405
R10066 VSS.t1204 VSS.n170 2.74402
R10067 VSS.n78 VSS.t1959 2.74402
R10068 VSS.n2579 VSS.t1408 2.74402
R10069 VSS.n2579 VSS.n2199 2.74397
R10070 VSS.n2687 VSS.n170 2.74397
R10071 VSS.n2970 VSS.n2703 2.74397
R10072 VSS.n78 VSS.n1122 2.74397
R10073 VSS.n2603 VSS.n170 2.74397
R10074 VSS.n78 VSS.n1076 2.74397
R10075 VSS.n1827 VSS.n0 2.74397
R10076 VSS.n291 VSS.t404 2.74386
R10077 VSS.n2970 VSS.t1298 2.74386
R10078 VSS.n1735 VSS.n1631 2.46343
R10079 VSS.n1782 VSS.n1631 2.46343
R10080 VSS.n1779 VSS.n1631 2.46343
R10081 VSS.n1777 VSS.n1631 2.46343
R10082 VSS.n1774 VSS.n1631 2.46343
R10083 VSS.n1743 VSS.n1631 2.46343
R10084 VSS.n1772 VSS.n1631 2.46343
R10085 VSS.n1769 VSS.n1631 2.46343
R10086 VSS.n1766 VSS.n1631 2.46343
R10087 VSS.n1764 VSS.n1631 2.46343
R10088 VSS.n1761 VSS.n1631 2.46343
R10089 VSS.n1758 VSS.n1631 2.46343
R10090 VSS.n1965 VSS.n1634 2.46343
R10091 VSS.n1965 VSS.n1635 2.46343
R10092 VSS.n1965 VSS.n1636 2.46343
R10093 VSS.n1965 VSS.n1638 2.46343
R10094 VSS.n1965 VSS.n1640 2.46343
R10095 VSS.n1965 VSS.n1641 2.46343
R10096 VSS.n1965 VSS.n1642 2.46343
R10097 VSS.n1965 VSS.n1644 2.46343
R10098 VSS.n1965 VSS.n1647 2.46343
R10099 VSS.n1965 VSS.n1648 2.46343
R10100 VSS.n1965 VSS.n1649 2.46343
R10101 VSS.n1965 VSS.n1651 2.46343
R10102 VSS.n1965 VSS.n1654 2.46343
R10103 VSS.n1965 VSS.n1655 2.46343
R10104 VSS.n1965 VSS.n1656 2.46343
R10105 VSS.n1965 VSS.n1657 2.46343
R10106 VSS.n1965 VSS.n1660 2.46343
R10107 VSS.n1965 VSS.n1662 2.46343
R10108 VSS.n1753 VSS.n1631 2.46343
R10109 VSS.n1756 VSS.n1631 2.46343
R10110 VSS.t579 VSS.n2291 2.34888
R10111 VSS.t591 VSS.n2275 2.34888
R10112 VSS.t602 VSS.n2259 2.34888
R10113 VSS.t614 VSS.n2232 2.34888
R10114 VSS.t626 VSS.n2216 2.34888
R10115 VSS.t781 VSS.n653 2.34888
R10116 VSS.t792 VSS.n639 2.34888
R10117 VSS.t804 VSS.n626 2.34888
R10118 VSS.t816 VSS.n604 2.34888
R10119 VSS.t827 VSS.n591 2.34888
R10120 VSS.n1960 VSS.n1631 2.32483
R10121 VSS.n1965 VSS.n1658 2.32417
R10122 VSS.t1563 VSS.n1256 2.20692
R10123 VSS.n1972 VSS.n1610 2.19188
R10124 VSS.n1965 VSS.n1964 2.01633
R10125 VSS.n1956 VSS.n1631 2.00687
R10126 VSS.n1965 VSS.n1652 2.00628
R10127 VSS.n2579 VSS.n2151 2.006
R10128 VSS.n2638 VSS.n170 2.006
R10129 VSS.n2658 VSS.n170 2.006
R10130 VSS.n2970 VSS.n2896 2.006
R10131 VSS.n2970 VSS.n2856 2.006
R10132 VSS.n78 VSS.n2036 2.006
R10133 VSS.n78 VSS.n2015 2.006
R10134 VSS.n291 VSS.n386 2.00599
R10135 VSS.n2579 VSS.n2373 2.00599
R10136 VSS.n2680 VSS.n170 2.00599
R10137 VSS.n2678 VSS.n170 2.00599
R10138 VSS.n2676 VSS.n170 2.00599
R10139 VSS.n78 VSS.n1108 2.00599
R10140 VSS.n78 VSS.n1096 2.00599
R10141 VSS.n78 VSS.n1084 2.00599
R10142 VSS.n2579 VSS.n2499 2.00599
R10143 VSS.n2579 VSS.n2437 2.00599
R10144 VSS.n291 VSS.n274 2.00592
R10145 VSS.n291 VSS.n246 2.00592
R10146 VSS.n291 VSS.n214 2.00592
R10147 VSS.n2970 VSS.n902 2.00592
R10148 VSS.n2970 VSS.n888 2.00592
R10149 VSS.n2970 VSS.n916 2.00592
R10150 VSS.n291 VSS.n320 2.00592
R10151 VSS.n2584 VSS.n2583 1.97843
R10152 VSS.n2583 VSS.n2087 1.97843
R10153 VSS.n2583 VSS.n2112 1.97843
R10154 VSS.n2583 VSS.n2110 1.97843
R10155 VSS.n2583 VSS.n2109 1.97843
R10156 VSS.n2583 VSS.n2092 1.97843
R10157 VSS.n2583 VSS.n2093 1.97843
R10158 VSS.n2583 VSS.n2106 1.97843
R10159 VSS.n291 VSS.n515 1.97843
R10160 VSS.n291 VSS.n176 1.97843
R10161 VSS.n291 VSS.n511 1.97843
R10162 VSS.n291 VSS.n507 1.97843
R10163 VSS.n291 VSS.n182 1.97843
R10164 VSS.n291 VSS.n186 1.97843
R10165 VSS.n3217 VSS.n3216 1.97843
R10166 VSS.n3216 VSS.n685 1.97843
R10167 VSS.n3216 VSS.n686 1.97843
R10168 VSS.n3216 VSS.n3214 1.97843
R10169 VSS.n3216 VSS.n3213 1.97843
R10170 VSS.n3216 VSS.n3212 1.97843
R10171 VSS.n3216 VSS.n3211 1.97843
R10172 VSS.n3216 VSS.n688 1.97843
R10173 VSS.n3216 VSS.n690 1.97843
R10174 VSS.n3216 VSS.n691 1.97843
R10175 VSS.n3216 VSS.n3210 1.97843
R10176 VSS.n3216 VSS.n693 1.97843
R10177 VSS.n2974 VSS.n766 1.97843
R10178 VSS.n2974 VSS.n768 1.97843
R10179 VSS.n2974 VSS.n771 1.97843
R10180 VSS.n2974 VSS.n865 1.97843
R10181 VSS.n2974 VSS.n863 1.97843
R10182 VSS.n2974 VSS.n778 1.97843
R10183 VSS.n2975 VSS.n2974 1.97843
R10184 VSS.n872 VSS.n170 1.97843
R10185 VSS.n767 VSS.n170 1.97843
R10186 VSS.n870 VSS.n170 1.97843
R10187 VSS.n868 VSS.n170 1.97843
R10188 VSS.n864 VSS.n170 1.97843
R10189 VSS.n860 VSS.n170 1.97843
R10190 VSS.n857 VSS.n170 1.97843
R10191 VSS.n779 VSS.n170 1.97843
R10192 VSS.n853 VSS.n170 1.97843
R10193 VSS.n763 VSS.n170 1.97843
R10194 VSS.n78 VSS.n1060 1.97843
R10195 VSS.n78 VSS.n1061 1.97843
R10196 VSS.n78 VSS.n2085 1.97843
R10197 VSS.n78 VSS.n1063 1.97843
R10198 VSS.n78 VSS.n2082 1.97843
R10199 VSS.n78 VSS.n1067 1.97843
R10200 VSS.n78 VSS.n2079 1.97843
R10201 VSS.n78 VSS.n1068 1.97843
R10202 VSS.n78 VSS.n2077 1.97843
R10203 VSS.n78 VSS.n1072 1.97843
R10204 VSS.t47 VSS.n1563 1.91439
R10205 VSS.n1971 VSS.n1611 1.88189
R10206 VSS.t37 VSS.n1618 1.88189
R10207 VSS.n1869 VSS.n1868 1.83435
R10208 VSS.n1458 VSS.t462 1.81686
R10209 VSS.t1574 VSS.n1458 1.81686
R10210 VSS.n1570 VSS.t652 1.81686
R10211 VSS.t47 VSS.n1570 1.81686
R10212 VSS.n1995 VSS.n1994 1.81676
R10213 VSS.t1564 VSS.n1995 1.81676
R10214 VSS.n1954 VSS.n1631 1.75689
R10215 VSS.n10 VSS.n949 1.7562
R10216 VSS.n1965 VSS.n1646 1.75603
R10217 VSS.n10 VSS.n950 1.75596
R10218 VSS.n2318 VSS.t438 1.75592
R10219 VSS.t1247 VSS.n542 1.75592
R10220 VSS.n1823 VSS.n0 1.75507
R10221 VSS.n1836 VSS.n1835 1.66925
R10222 VSS.n2580 VSS.n2579 1.64417
R10223 VSS.n2579 VSS.n2571 1.64417
R10224 VSS.n2579 VSS.n2565 1.64417
R10225 VSS.n2579 VSS.n2562 1.64417
R10226 VSS.n2579 VSS.n2560 1.64417
R10227 VSS.n2971 VSS.n2970 1.63922
R10228 VSS.n2970 VSS.n940 1.63922
R10229 VSS.n2970 VSS.n935 1.63922
R10230 VSS.n2970 VSS.n932 1.63922
R10231 VSS.n2970 VSS.n930 1.63922
R10232 VSS.n2579 VSS.n2118 1.55386
R10233 VSS.n2579 VSS.n2121 1.55386
R10234 VSS.n2579 VSS.n2123 1.55386
R10235 VSS.n2579 VSS.n2127 1.55386
R10236 VSS.n2579 VSS.n2130 1.55386
R10237 VSS.n2579 VSS.n2131 1.55386
R10238 VSS.n2579 VSS.n2133 1.55386
R10239 VSS.n2579 VSS.n2135 1.55386
R10240 VSS.n2579 VSS.n2139 1.55386
R10241 VSS.n2579 VSS.n2140 1.55386
R10242 VSS.n2579 VSS.n2142 1.55386
R10243 VSS.n2579 VSS.n2146 1.55386
R10244 VSS.n2579 VSS.n2149 1.55386
R10245 VSS.n2579 VSS.n2152 1.55386
R10246 VSS.n2579 VSS.n2155 1.55386
R10247 VSS.n2579 VSS.n2158 1.55386
R10248 VSS.n2604 VSS.n170 1.55386
R10249 VSS.n2608 VSS.n170 1.55386
R10250 VSS.n2612 VSS.n170 1.55386
R10251 VSS.n2616 VSS.n170 1.55386
R10252 VSS.n2620 VSS.n170 1.55386
R10253 VSS.n2624 VSS.n170 1.55386
R10254 VSS.n2628 VSS.n170 1.55386
R10255 VSS.n2632 VSS.n170 1.55386
R10256 VSS.n2636 VSS.n170 1.55386
R10257 VSS.n2640 VSS.n170 1.55386
R10258 VSS.n2644 VSS.n170 1.55386
R10259 VSS.n2648 VSS.n170 1.55386
R10260 VSS.n2652 VSS.n170 1.55386
R10261 VSS.n2656 VSS.n170 1.55386
R10262 VSS.n2660 VSS.n170 1.55386
R10263 VSS.n2664 VSS.n170 1.55386
R10264 VSS.n2970 VSS.n2705 1.55386
R10265 VSS.n2970 VSS.n2712 1.55386
R10266 VSS.n2970 VSS.n2721 1.55386
R10267 VSS.n2970 VSS.n2729 1.55386
R10268 VSS.n2970 VSS.n2736 1.55386
R10269 VSS.n2970 VSS.n2745 1.55386
R10270 VSS.n2970 VSS.n2753 1.55386
R10271 VSS.n2970 VSS.n2760 1.55386
R10272 VSS.n2970 VSS.n2769 1.55386
R10273 VSS.n2970 VSS.n2777 1.55386
R10274 VSS.n2970 VSS.n2784 1.55386
R10275 VSS.n2970 VSS.n2793 1.55386
R10276 VSS.n2970 VSS.n2801 1.55386
R10277 VSS.n2970 VSS.n2808 1.55386
R10278 VSS.n2970 VSS.n2816 1.55386
R10279 VSS.n2970 VSS.n2824 1.55386
R10280 VSS.n78 VSS.n1124 1.55386
R10281 VSS.n78 VSS.n1131 1.55386
R10282 VSS.n78 VSS.n1138 1.55386
R10283 VSS.n78 VSS.n1145 1.55386
R10284 VSS.n78 VSS.n1152 1.55386
R10285 VSS.n78 VSS.n1159 1.55386
R10286 VSS.n78 VSS.n1166 1.55386
R10287 VSS.n78 VSS.n1173 1.55386
R10288 VSS.n78 VSS.n1180 1.55386
R10289 VSS.n78 VSS.n1187 1.55386
R10290 VSS.n78 VSS.n1194 1.55386
R10291 VSS.n78 VSS.n1201 1.55386
R10292 VSS.n78 VSS.n1208 1.55386
R10293 VSS.n78 VSS.n1215 1.55386
R10294 VSS.n78 VSS.n1222 1.55386
R10295 VSS.n78 VSS.n1229 1.55386
R10296 VSS.n291 VSS.n489 1.5537
R10297 VSS.n291 VSS.n429 1.5537
R10298 VSS.n291 VSS.n405 1.55368
R10299 VSS.n291 VSS.n366 1.55368
R10300 VSS.n291 VSS.n463 1.55365
R10301 VSS.n291 VSS.n441 1.55365
R10302 VSS.n291 VSS.n392 1.55365
R10303 VSS.n291 VSS.n354 1.55365
R10304 VSS.n291 VSS.n313 1.55365
R10305 VSS.n291 VSS.n452 1.55363
R10306 VSS.n291 VSS.n327 1.55363
R10307 VSS.n291 VSS.n470 1.55361
R10308 VSS.n291 VSS.n477 1.55358
R10309 VSS.n291 VSS.n418 1.55358
R10310 VSS.n291 VSS.n412 1.55358
R10311 VSS.n291 VSS.n379 1.55358
R10312 VSS.n291 VSS.n340 1.55358
R10313 VSS.n291 VSS.n299 1.55358
R10314 VSS.n291 VSS.n457 1.55354
R10315 VSS.n291 VSS.n397 1.55354
R10316 VSS.n291 VSS.n372 1.55354
R10317 VSS.n291 VSS.n360 1.55354
R10318 VSS.n291 VSS.n332 1.55354
R10319 VSS.n291 VSS.n483 1.5535
R10320 VSS.n291 VSS.n423 1.5535
R10321 VSS.n291 VSS.n347 1.5535
R10322 VSS.n291 VSS.n306 1.5535
R10323 VSS.n291 VSS.n435 1.55347
R10324 VSS.n2579 VSS.n2531 1.55347
R10325 VSS.n2579 VSS.n2512 1.55347
R10326 VSS.n2579 VSS.t155 1.55345
R10327 VSS.n2579 VSS.t1385 1.55345
R10328 VSS.n2579 VSS.t1390 1.55345
R10329 VSS.n2579 VSS.t61 1.55345
R10330 VSS.n2579 VSS.t29 1.55345
R10331 VSS.n2579 VSS.t325 1.55345
R10332 VSS.n2579 VSS.t407 1.55345
R10333 VSS.n2579 VSS.t1854 1.55345
R10334 VSS.n2579 VSS.t1061 1.55345
R10335 VSS.n2579 VSS.t1084 1.55345
R10336 VSS.n2579 VSS.t32 1.55345
R10337 VSS.n2579 VSS.t87 1.55345
R10338 VSS.n2579 VSS.t301 1.55345
R10339 VSS.n2606 VSS.n170 1.55345
R10340 VSS.n2610 VSS.n170 1.55345
R10341 VSS.n2614 VSS.n170 1.55345
R10342 VSS.n2622 VSS.n170 1.55345
R10343 VSS.n2626 VSS.n170 1.55345
R10344 VSS.n2630 VSS.n170 1.55345
R10345 VSS.n2634 VSS.n170 1.55345
R10346 VSS.n2642 VSS.n170 1.55345
R10347 VSS.n2646 VSS.n170 1.55345
R10348 VSS.n2650 VSS.n170 1.55345
R10349 VSS.n2654 VSS.n170 1.55345
R10350 VSS.n2662 VSS.n170 1.55345
R10351 VSS.n2970 VSS.n2711 1.55345
R10352 VSS.n2970 VSS.n2719 1.55345
R10353 VSS.n2970 VSS.n2728 1.55345
R10354 VSS.n2970 VSS.n2743 1.55345
R10355 VSS.n2970 VSS.n2752 1.55345
R10356 VSS.n2970 VSS.n2759 1.55345
R10357 VSS.n2970 VSS.n2767 1.55345
R10358 VSS.n2970 VSS.n2783 1.55345
R10359 VSS.n2970 VSS.n2791 1.55345
R10360 VSS.n2970 VSS.n2800 1.55345
R10361 VSS.n2970 VSS.n2807 1.55345
R10362 VSS.n2970 VSS.n2823 1.55345
R10363 VSS.n78 VSS.n1130 1.55345
R10364 VSS.n78 VSS.n1137 1.55345
R10365 VSS.n78 VSS.n1144 1.55345
R10366 VSS.n78 VSS.n1158 1.55345
R10367 VSS.n78 VSS.n1165 1.55345
R10368 VSS.n78 VSS.n1172 1.55345
R10369 VSS.n78 VSS.n1179 1.55345
R10370 VSS.n78 VSS.n1193 1.55345
R10371 VSS.n78 VSS.n1200 1.55345
R10372 VSS.n78 VSS.n1207 1.55345
R10373 VSS.n78 VSS.n1214 1.55345
R10374 VSS.n78 VSS.n1228 1.55345
R10375 VSS.n2579 VSS.n2542 1.55344
R10376 VSS.n2579 VSS.n2443 1.55344
R10377 VSS.n2579 VSS.n2536 1.5534
R10378 VSS.n2579 VSS.n2506 1.55338
R10379 VSS.n2579 VSS.n2448 1.55338
R10380 VSS.n2579 VSS.n2411 1.55338
R10381 VSS.n2579 VSS.n2406 1.55338
R10382 VSS.n2579 VSS.n2365 1.55338
R10383 VSS.n2665 VSS.n170 1.55338
R10384 VSS.n2663 VSS.n170 1.55338
R10385 VSS.n2661 VSS.n170 1.55338
R10386 VSS.n2657 VSS.n170 1.55338
R10387 VSS.n2655 VSS.n170 1.55338
R10388 VSS.n2653 VSS.n170 1.55338
R10389 VSS.n2651 VSS.n170 1.55338
R10390 VSS.n2649 VSS.n170 1.55338
R10391 VSS.n2647 VSS.n170 1.55338
R10392 VSS.n2645 VSS.n170 1.55338
R10393 VSS.n2643 VSS.n170 1.55338
R10394 VSS.n2641 VSS.n170 1.55338
R10395 VSS.n2637 VSS.n170 1.55338
R10396 VSS.n2635 VSS.n170 1.55338
R10397 VSS.n2633 VSS.n170 1.55338
R10398 VSS.n2631 VSS.n170 1.55338
R10399 VSS.n2629 VSS.n170 1.55338
R10400 VSS.n2627 VSS.n170 1.55338
R10401 VSS.n2625 VSS.n170 1.55338
R10402 VSS.n2623 VSS.n170 1.55338
R10403 VSS.n2621 VSS.n170 1.55338
R10404 VSS.n2617 VSS.n170 1.55338
R10405 VSS.n2615 VSS.n170 1.55338
R10406 VSS.n2613 VSS.n170 1.55338
R10407 VSS.n2611 VSS.n170 1.55338
R10408 VSS.n2609 VSS.n170 1.55338
R10409 VSS.n2607 VSS.n170 1.55338
R10410 VSS.n2605 VSS.n170 1.55338
R10411 VSS.n78 VSS.n1113 1.55338
R10412 VSS.n78 VSS.n1112 1.55338
R10413 VSS.n78 VSS.n1111 1.55338
R10414 VSS.n78 VSS.n1107 1.55338
R10415 VSS.n78 VSS.n1106 1.55338
R10416 VSS.n78 VSS.n1105 1.55338
R10417 VSS.n78 VSS.n1104 1.55338
R10418 VSS.n78 VSS.n1103 1.55338
R10419 VSS.n78 VSS.n1102 1.55338
R10420 VSS.n78 VSS.n1101 1.55338
R10421 VSS.n78 VSS.n1100 1.55338
R10422 VSS.n78 VSS.n1099 1.55338
R10423 VSS.n78 VSS.n1095 1.55338
R10424 VSS.n78 VSS.n1094 1.55338
R10425 VSS.n78 VSS.n1093 1.55338
R10426 VSS.n78 VSS.n1092 1.55338
R10427 VSS.n78 VSS.n1091 1.55338
R10428 VSS.n78 VSS.n1090 1.55338
R10429 VSS.n78 VSS.n1089 1.55338
R10430 VSS.n78 VSS.n1088 1.55338
R10431 VSS.n78 VSS.n1087 1.55338
R10432 VSS.n78 VSS.n1083 1.55338
R10433 VSS.n78 VSS.n1082 1.55338
R10434 VSS.n78 VSS.n1081 1.55338
R10435 VSS.n78 VSS.n1080 1.55338
R10436 VSS.n78 VSS.n1079 1.55338
R10437 VSS.n78 VSS.n1078 1.55338
R10438 VSS.n78 VSS.n1077 1.55338
R10439 VSS.n2579 VSS.n2400 1.55338
R10440 VSS.n2579 VSS.n2394 1.55338
R10441 VSS.n2579 VSS.n2359 1.55338
R10442 VSS.n2579 VSS.n2353 1.55338
R10443 VSS.n2579 VSS.n2520 1.55338
R10444 VSS.n291 VSS.n281 1.55337
R10445 VSS.n291 VSS.n278 1.55337
R10446 VSS.n291 VSS.n271 1.55337
R10447 VSS.n291 VSS.n267 1.55337
R10448 VSS.n291 VSS.n265 1.55337
R10449 VSS.n291 VSS.n259 1.55337
R10450 VSS.n291 VSS.n254 1.55337
R10451 VSS.n291 VSS.n251 1.55337
R10452 VSS.n291 VSS.n243 1.55337
R10453 VSS.n291 VSS.n239 1.55337
R10454 VSS.n291 VSS.n229 1.55337
R10455 VSS.n291 VSS.n226 1.55337
R10456 VSS.n291 VSS.n219 1.55337
R10457 VSS.n291 VSS.n207 1.55337
R10458 VSS.n291 VSS.n205 1.55337
R10459 VSS.n291 VSS.n197 1.55337
R10460 VSS.n291 VSS.n195 1.55337
R10461 VSS.n2970 VSS.n919 1.55337
R10462 VSS.n2970 VSS.n915 1.55337
R10463 VSS.n2970 VSS.n911 1.55337
R10464 VSS.n2970 VSS.n910 1.55337
R10465 VSS.n2970 VSS.n909 1.55337
R10466 VSS.n2970 VSS.n908 1.55337
R10467 VSS.n2970 VSS.n901 1.55337
R10468 VSS.n2970 VSS.n900 1.55337
R10469 VSS.n2970 VSS.n899 1.55337
R10470 VSS.n2970 VSS.n895 1.55337
R10471 VSS.n2970 VSS.n893 1.55337
R10472 VSS.n2970 VSS.n892 1.55337
R10473 VSS.n2970 VSS.n885 1.55337
R10474 VSS.n2970 VSS.n884 1.55337
R10475 VSS.n2970 VSS.n883 1.55337
R10476 VSS.n2579 VSS.n2462 1.55337
R10477 VSS.n2579 VSS.n2456 1.55337
R10478 VSS.n2579 VSS.n2425 1.55337
R10479 VSS.n2579 VSS.n2419 1.55337
R10480 VSS.n2579 VSS.n2485 1.55335
R10481 VSS.n2579 VSS.n2478 1.55335
R10482 VSS.n2579 VSS.n2387 1.55335
R10483 VSS.n2579 VSS.n2380 1.55335
R10484 VSS.n2579 VSS.n2526 1.55334
R10485 VSS.n2579 VSS.n2493 1.55334
R10486 VSS.n2579 VSS.n2473 1.55333
R10487 VSS.n2579 VSS.n2467 1.55333
R10488 VSS.n2579 VSS.n2430 1.55333
R10489 VSS.n291 VSS.n283 1.55328
R10490 VSS.n291 VSS.n269 1.55328
R10491 VSS.n291 VSS.n262 1.55328
R10492 VSS.n291 VSS.n257 1.55328
R10493 VSS.n291 VSS.n241 1.55328
R10494 VSS.n291 VSS.n236 1.55328
R10495 VSS.n291 VSS.n233 1.55328
R10496 VSS.n291 VSS.n223 1.55328
R10497 VSS.n291 VSS.n211 1.55328
R10498 VSS.n291 VSS.n203 1.55328
R10499 VSS.n291 VSS.n201 1.55328
R10500 VSS.n2970 VSS.n921 1.55328
R10501 VSS.n2970 VSS.n920 1.55328
R10502 VSS.n2970 VSS.n914 1.55328
R10503 VSS.n2970 VSS.n912 1.55328
R10504 VSS.n2970 VSS.n907 1.55328
R10505 VSS.n2970 VSS.n905 1.55328
R10506 VSS.n2970 VSS.n898 1.55328
R10507 VSS.n2970 VSS.n896 1.55328
R10508 VSS.n2970 VSS.n891 1.55328
R10509 VSS.n2970 VSS.n886 1.55328
R10510 VSS.n2970 VSS.n882 1.55328
R10511 VSS.n2970 VSS.n881 1.55328
R10512 VSS.n2970 VSS.n879 1.55328
R10513 VSS.n3221 VSS.n171 1.54175
R10514 VSS.n2575 VSS.n2574 1.54175
R10515 VSS.n1118 VSS.n1117 1.54175
R10516 VSS.n2598 VSS.n2597 1.54175
R10517 VSS.n2696 VSS.n2695 1.54175
R10518 VSS.n1785 VSS.n1630 1.51091
R10519 VSS.t901 VSS.n1668 1.43372
R10520 VSS.t903 VSS.n1669 1.43372
R10521 VSS.t903 VSS.n1670 1.42949
R10522 VSS.n1673 VSS.t901 1.42949
R10523 VSS.t869 VSS.t865 1.41892
R10524 VSS.t868 VSS.t863 1.41892
R10525 VSS.t867 VSS.t861 1.41892
R10526 VSS.t866 VSS.t859 1.41892
R10527 VSS.n1965 VSS.n1639 1.38637
R10528 VSS.n954 VSS.t898 1.37661
R10529 VSS.t898 VSS.n955 1.37661
R10530 VSS.n2579 VSS.n2160 1.35632
R10531 VSS.n291 VSS.n287 1.35591
R10532 VSS.t45 VSS.t872 1.25399
R10533 VSS.n1872 VSS.n1785 1.24628
R10534 VSS.n2318 VSS.n2254 1.24547
R10535 VSS.t1578 VSS.t1576 1.24475
R10536 VSS.t267 VSS.n1542 1.24196
R10537 VSS.t136 VSS.t266 1.21479
R10538 VSS.t1580 VSS.t1582 1.18945
R10539 VSS.t1564 VSS.t1566 1.18411
R10540 VSS.n1046 VSS.t161 1.17663
R10541 VSS.t279 VSS.n2097 1.17656
R10542 VSS.t43 VSS.t1884 1.15699
R10543 VSS.t508 VSS.t975 1.15589
R10544 VSS.t1584 VSS.t1586 1.1528
R10545 VSS.t650 VSS.t643 1.14741
R10546 VSS.t1570 VSS.t1568 1.14741
R10547 VSS.t1566 VSS.t1568 1.14726
R10548 VSS.t1570 VSS.t1572 1.14252
R10549 VSS.t1582 VSS.t1584 1.13908
R10550 VSS.t1576 VSS.t1574 1.13501
R10551 VSS.t1586 VSS.t1588 1.13381
R10552 VSS.n1015 VSS.n1605 1.1296
R10553 VSS.n1952 VSS.n1631 1.12565
R10554 VSS.n1620 VSS.t1186 1.12123
R10555 VSS.t672 VSS.t665 1.11999
R10556 VSS.t758 VSS.t100 1.1198
R10557 VSS.n1870 VSS.n1869 1.11367
R10558 VSS.t1590 VSS.t1592 1.10449
R10559 VSS.n656 VSS.t41 1.09998
R10560 VSS.t37 VSS.n1616 1.09664
R10561 VSS.n1871 VSS.n1870 1.09549
R10562 VSS.n2242 VSS.t1341 1.09246
R10563 VSS.t1592 VSS.t1594 1.08937
R10564 VSS.t45 VSS.t49 1.08789
R10565 VSS.t775 VSS.n656 1.08744
R10566 VSS.t196 VSS.n1242 1.08266
R10567 VSS.t508 VSS.n736 1.08211
R10568 VSS.n825 VSS.t43 1.08181
R10569 VSS.n827 VSS.t709 1.07623
R10570 VSS.t1548 VSS.t1551 1.06241
R10571 VSS.t722 VSS.t396 1.05694
R10572 VSS.t273 VSS.n2242 1.04404
R10573 VSS.t252 VSS.n2097 1.04128
R10574 VSS.t737 VSS.t730 1.03034
R10575 VSS.t694 VSS.t687 1.03031
R10576 VSS.n790 VSS.t1776 1.02553
R10577 VSS.n702 VSS.t1514 1.02498
R10578 VSS.n1616 VSS.n1617 1.02454
R10579 VSS.n1596 VSS.n1542 1.02217
R10580 VSS.n1015 VSS.t656 1.01932
R10581 VSS.n808 VSS.t702 1.01621
R10582 VSS.n720 VSS.t745 1.016
R10583 VSS.t650 VSS.t652 1.01525
R10584 VSS.t766 VSS.t760 1.00907
R10585 VSS.t680 VSS.t674 1.00904
R10586 VSS.n720 VSS.t975 1.00662
R10587 VSS.n808 VSS.t1884 1.00635
R10588 VSS.t694 VSS.t696 1.00334
R10589 VSS.t737 VSS.t739 1.0033
R10590 VSS.n827 VSS.t396 0.989733
R10591 VSS.t725 VSS.t722 0.985933
R10592 VSS.n1995 VSS 0.981521
R10593 VSS.n1570 VSS 0.98107
R10594 VSS.n1458 VSS 0.98107
R10595 VSS.n31 VSS.n1010 0.967179
R10596 VSS.n31 VSS.n1014 0.967179
R10597 VSS.n31 VSS.n1019 0.967179
R10598 VSS.n31 VSS.n1022 0.967179
R10599 VSS.n31 VSS.n1026 0.967179
R10600 VSS.n31 VSS.n1035 0.967179
R10601 VSS.n31 VSS.n984 0.967179
R10602 VSS.n31 VSS.n998 0.967179
R10603 VSS.n31 VSS.n1006 0.965685
R10604 VSS.t806 VSS.t1548 0.965284
R10605 VSS.t1588 VSS.n1853 0.958108
R10606 VSS.t93 VSS.t1514 0.95739
R10607 VSS.t1776 VSS.t191 0.957281
R10608 VSS.t1572 VSS.n1454 0.952838
R10609 VSS.t640 VSS.t2383 0.951385
R10610 VSS.t841 VSS.t413 0.951385
R10611 VSS.t674 VSS.t672 0.941319
R10612 VSS.t758 VSS.t760 0.941211
R10613 VSS.n1372 VSS.t462 0.933358
R10614 VSS.n758 VSS.t769 0.933358
R10615 VSS.n847 VSS.t725 0.933347
R10616 VSS.t462 VSS.t680 0.9304
R10617 VSS.t769 VSS.t766 0.930382
R10618 VSS.t1574 VSS.n1454 0.923564
R10619 VSS.t1590 VSS.n1853 0.919719
R10620 VSS.t2114 VSS.t2118 0.915066
R10621 VSS.t1229 VSS.t1174 0.915066
R10622 VSS.t191 VSS.t1136 0.915026
R10623 VSS.t93 VSS.t1215 0.915004
R10624 VSS.n1994 VSS.n1242 0.903261
R10625 VSS.t730 VSS.n702 0.900244
R10626 VSS.t687 VSS.n790 0.899707
R10627 VSS.n1620 VSS.t1181 0.885254
R10628 VSS.t136 VSS.n1592 0.882405
R10629 VSS.t1579 VSS.n1852 0.858434
R10630 VSS.n1973 VSS.t267 0.857806
R10631 VSS.n173 VSS.n291 0.8471
R10632 VSS.n658 VSS.n517 0.8471
R10633 VSS.n2693 VSS.n170 0.8471
R10634 VSS.n1059 VSS.n78 0.8471
R10635 VSS.n2970 VSS.t275 0.847022
R10636 VSS.n2583 VSS.n2089 0.847021
R10637 VSS.n3216 VSS.n687 0.847021
R10638 VSS.n2974 VSS.n774 0.847021
R10639 VSS.n31 VSS.n964 0.847021
R10640 VSS.n291 VSS.t1782 0.847018
R10641 VSS.n78 VSS.t2024 0.847018
R10642 VSS.n2579 VSS.n2567 0.846994
R10643 VSS.n2579 VSS.t2027 0.846981
R10644 VSS.n2692 VSS.n170 0.846958
R10645 VSS.n2970 VSS.n929 0.84688
R10646 VSS.n31 VSS.n976 0.841881
R10647 VSS.n801 VSS.t702 0.838467
R10648 VSS.n713 VSS.t745 0.838221
R10649 VSS.n657 VSS.t435 0.837563
R10650 VSS.t267 VSS.n1539 0.832974
R10651 VSS.n657 VSS.t41 0.821725
R10652 VSS.t1564 VSS.n1973 0.820807
R10653 VSS.n1852 VSS.t1580 0.820297
R10654 VSS.n1967 VSS.n1966 0.810955
R10655 VSS.t933 VSS.t125 0.806856
R10656 VSS.t207 VSS.t921 0.806855
R10657 VSS.t330 VSS.t873 0.806855
R10658 VSS.t203 VSS.t885 0.806855
R10659 VSS.n1821 VSS.t909 0.806855
R10660 VSS.t915 VSS.n1808 0.806855
R10661 VSS.t2136 VSS.t945 0.806855
R10662 VSS.n1596 VSS.n1592 0.804611
R10663 VSS.n1046 VSS.t643 0.802868
R10664 VSS.t181 VSS.t189 0.802775
R10665 VSS.t257 VSS.t18 0.802775
R10666 VSS.t298 VSS.t1202 0.802775
R10667 VSS.t1237 VSS.t1131 0.802775
R10668 VSS.t1079 VSS.t392 0.802775
R10669 VSS.t167 VSS.t187 0.802775
R10670 VSS.t205 VSS.t109 0.802775
R10671 VSS.t1118 VSS.t157 0.802775
R10672 VSS.t270 VSS.t260 0.802775
R10673 VSS.t853 VSS.t1819 0.802775
R10674 VSS.t1155 VSS.t1142 0.802775
R10675 VSS.t117 VSS.t1024 0.802775
R10676 VSS.t1289 VSS.t14 0.802775
R10677 VSS.t1253 VSS.t471 0.802775
R10678 VSS.t972 VSS.t163 0.802775
R10679 VSS.t294 VSS.t1816 0.802775
R10680 VSS.t1632 VSS.t146 0.802775
R10681 VSS.t1766 VSS.t928 0.802775
R10682 VSS.t1448 VSS.t474 0.802775
R10683 VSS.t2243 VSS.t2072 0.802775
R10684 VSS.t1365 VSS.t144 0.802775
R10685 VSS.t12 VSS.t1251 0.802775
R10686 VSS.t1022 VSS.t1609 0.802775
R10687 VSS.t488 VSS.t516 0.802775
R10688 VSS.t2109 VSS.t165 0.802775
R10689 VSS.t1744 VSS.t113 0.802775
R10690 VSS.t496 VSS.t198 0.802775
R10691 VSS.t1749 VSS.t1098 0.802775
R10692 VSS.t185 VSS.t1140 0.802775
R10693 VSS.t1441 VSS.t1050 0.802775
R10694 VSS.t16 VSS.t296 0.802775
R10695 VSS.t1170 VSS.t377 0.802775
R10696 VSS.t1032 VSS.t179 0.802775
R10697 VSS.t942 VSS.t67 0.802775
R10698 VSS.t2366 VSS.t1754 0.802775
R10699 VSS.t1756 VSS.t1737 0.802775
R10700 VSS.t1338 VSS.t1405 0.802775
R10701 VSS.t1309 VSS.t1908 0.802775
R10702 VSS.t220 VSS.t1200 0.802775
R10703 VSS.t1198 VSS.t1466 0.802775
R10704 VSS.t564 VSS.t1397 0.802775
R10705 VSS.t560 VSS.t73 0.802775
R10706 VSS.t139 VSS.t54 0.802775
R10707 VSS.t56 VSS.t1488 0.802775
R10708 VSS.t1523 VSS.t1805 0.802775
R10709 VSS.t1091 VSS.t305 0.802775
R10710 VSS.t303 VSS.t1912 0.802775
R10711 VSS.t512 VSS.t1653 0.802775
R10712 VSS.t1074 VSS.t493 0.802775
R10713 VSS.t491 VSS.t76 0.802775
R10714 VSS.t1089 VSS.t1957 0.802775
R10715 VSS.t183 VSS.t1233 0.802775
R10716 VSS.t52 VSS.t1799 0.802775
R10717 VSS.t498 VSS.t70 0.802775
R10718 VSS.t23 VSS.t1638 0.802775
R10719 VSS.t501 VSS.t1026 0.802775
R10720 VSS.t291 VSS.t2033 0.802775
R10721 VSS.t20 VSS.t1539 0.802775
R10722 VSS.t387 VSS.t1910 0.802775
R10723 VSS.t1333 VSS.t1483 0.802775
R10724 VSS.t1510 VSS.t2020 0.802775
R10725 VSS.t127 VSS.t64 0.802775
R10726 VSS.t213 VSS.t1947 0.802775
R10727 VSS.t459 VSS.t1542 0.802775
R10728 VSS.t503 VSS.t1615 0.802775
R10729 VSS.t1206 VSS.t1532 0.802775
R10730 VSS.t1258 VSS.t1329 0.802775
R10731 VSS.t308 VSS.t1260 0.802775
R10732 VSS.t215 VSS.t2254 0.802775
R10733 VSS.t218 VSS.t1382 0.802775
R10734 VSS.t1211 VSS.t446 0.802775
R10735 VSS.t1209 VSS.t1528 0.802775
R10736 VSS.t1399 VSS.t402 0.802775
R10737 VSS.t1394 VSS.t1470 0.802775
R10738 VSS.t142 VSS.t539 0.802775
R10739 VSS.t59 VSS.t1191 0.802775
R10740 VSS.t1403 VSS.t2188 0.802775
R10741 VSS.t980 VSS.t1475 0.802775
R10742 VSS.t1042 VSS.t107 0.802775
R10743 VSS.t1196 VSS.t1044 0.802775
R10744 VSS.t344 VSS.t313 0.802775
R10745 VSS.t1758 VSS.t342 0.802775
R10746 VSS.t456 VSS.t1850 0.802775
R10747 VSS.t454 VSS.t2030 0.802775
R10748 VSS.t1054 VSS.t399 0.802775
R10749 VSS.t451 VSS.t1052 0.802775
R10750 VSS.t1102 VSS.t2239 0.802775
R10751 VSS.t1100 VSS.t2036 0.802775
R10752 VSS.t83 VSS.t2191 0.802775
R10753 VSS.t984 VSS.t81 0.802775
R10754 VSS.t223 VSS.t1128 0.802775
R10755 VSS.t426 VSS.t316 0.802775
R10756 VSS.t85 VSS.t1990 0.802775
R10757 VSS.t1144 VSS.t1313 0.802775
R10758 VSS.t89 VSS.t1072 0.802775
R10759 VSS.t1725 VSS.t1316 0.802775
R10760 VSS.t989 VSS.t2257 0.802775
R10761 VSS.t882 VSS.t26 0.802775
R10762 VSS.t2378 VSS.t991 0.802775
R10763 VSS.t1928 VSS.t1120 0.802775
R10764 VSS.t1413 VSS.t1046 0.802775
R10765 VSS.t1348 VSS.t1094 0.802775
R10766 VSS.t1010 VSS.t370 0.802775
R10767 VSS.t550 VSS.t506 0.802775
R10768 VSS.t1492 VSS.t1086 0.802775
R10769 VSS.t1219 VSS.t1064 0.802775
R10770 VSS.t1321 VSS.t1279 0.802775
R10771 VSS.t2088 VSS.t1037 0.802775
R10772 VSS.t2177 VSS.t1015 0.802775
R10773 VSS.t1420 VSS.t1 0.802775
R10774 VSS.t2098 VSS.t529 0.802775
R10775 VSS.t1429 VSS.t443 0.802775
R10776 VSS.t532 VSS.t281 0.802775
R10777 VSS.t1557 VSS.t97 0.802775
R10778 VSS.t1069 VSS.t429 0.802775
R10779 VSS.t233 VSS.t1040 0.802775
R10780 VSS.t9 VSS.t894 0.802775
R10781 VSS.t534 VSS.n1811 0.802775
R10782 VSS.t431 VSS.t231 0.802775
R10783 VSS.t2004 VSS.t570 0.802775
R10784 VSS.t1898 VSS.t469 0.802775
R10785 VSS.t152 VSS.t283 0.802775
R10786 VSS.t1426 VSS.t448 0.802775
R10787 VSS.t1732 VSS.t525 0.802775
R10788 VSS.t2007 VSS.t3 0.802775
R10789 VSS.t1498 VSS.t1422 0.802775
R10790 VSS.t1895 VSS.t510 0.802775
R10791 VSS.t149 VSS.t1319 0.802775
R10792 VSS.t1222 VSS.t1066 0.802775
R10793 VSS.t244 VSS.t1008 0.802775
R10794 VSS.t6 VSS.t1096 0.802775
R10795 VSS.t553 VSS.t1048 0.802775
R10796 VSS.t1681 VSS.t1122 0.802775
R10797 VSS.t111 VSS.t523 0.802775
R10798 VSS.t1178 VSS.t568 0.802775
R10799 VSS.t360 VSS.t368 0.802775
R10800 VSS.t34 VSS.t287 0.802775
R10801 VSS.t994 VSS.t1324 0.802775
R10802 VSS.t389 VSS.t228 0.802775
R10803 VSS.t336 VSS.t1108 0.802775
R10804 VSS.t857 VSS.t1112 0.802775
R10805 VSS.t354 VSS.t1331 0.802775
R10806 VSS.t2236 VSS.t379 0.802775
R10807 VSS.t339 VSS.t1110 0.802775
R10808 VSS.t1676 VSS.t1501 0.802775
R10809 VSS.t363 VSS.t1455 0.802775
R10810 VSS.t851 VSS.t1326 0.802775
R10811 VSS.t1301 VSS.t1283 0.802775
R10812 VSS.t262 VSS.t544 0.802775
R10813 VSS.t349 VSS.t1105 0.802775
R10814 VSS.t1601 VSS.t236 0.802775
R10815 VSS.t333 VSS.t1461 0.802775
R10816 VSS.t1986 VSS.t104 0.802775
R10817 VSS.t102 VSS.t1357 0.802775
R10818 VSS.t177 VSS.t464 0.802775
R10819 VSS.t357 VSS.t383 0.802775
R10820 VSS.t2153 VSS.t2058 0.802775
R10821 VSS.t366 VSS.t2054 0.802775
R10822 VSS.t1029 VSS.t467 0.802775
R10823 VSS.t1304 VSS.t374 0.802775
R10824 VSS.t1629 VSS.t483 0.802775
R10825 VSS.t1877 VSS.t2126 0.802775
R10826 VSS.t2128 VSS.t546 0.802775
R10827 VSS.t1710 VSS.t385 0.802775
R10828 VSS.t1159 VSS.t1864 0.802775
R10829 VSS.t997 VSS.t952 0.802775
R10830 VSS.t1551 VSS.n622 0.797502
R10831 VSS.t585 VSS.n2282 0.790172
R10832 VSS.t556 VSS.n2266 0.790172
R10833 VSS.t620 VSS.n2223 0.790172
R10834 VSS.t120 VSS.n2208 0.790172
R10835 VSS.n522 VSS.t418 0.789617
R10836 VSS.n531 VSS.t798 0.789617
R10837 VSS.n548 VSS.t421 0.789617
R10838 VSS.n557 VSS.t424 0.789617
R10839 VSS.n622 VSS.t321 0.777368
R10840 VSS.t2118 VSS.t279 0.774024
R10841 VSS.t1174 VSS.t161 0.774024
R10842 VSS.t195 VSS.n1246 0.735974
R10843 VSS.t1577 VSS.n1394 0.735974
R10844 VSS.t37 VSS.n1620 0.728354
R10845 VSS.t829 VSS.n557 0.723953
R10846 VSS.t818 VSS.n548 0.723953
R10847 VSS.t794 VSS.n531 0.723953
R10848 VSS.t783 VSS.n522 0.723953
R10849 VSS.n2829 VSS.t929 0.723599
R10850 VSS.t930 VSS.t932 0.723599
R10851 VSS.n2671 VSS.t943 0.723599
R10852 VSS.t941 VSS.n2667 0.723599
R10853 VSS.t881 VSS.n2344 0.723599
R10854 VSS.n1234 VSS.t893 0.723599
R10855 VSS.t895 VSS.t897 0.723599
R10856 VSS.n293 VSS.t953 0.723599
R10857 VSS.t581 VSS.n2282 0.723386
R10858 VSS.t593 VSS.n2266 0.723386
R10859 VSS.t616 VSS.n2223 0.723386
R10860 VSS.t628 VSS.n2208 0.723386
R10861 VSS.n1961 VSS.t869 0.722582
R10862 VSS.n1959 VSS.t868 0.722582
R10863 VSS.n1957 VSS.t867 0.722582
R10864 VSS.n1955 VSS.t866 0.722582
R10865 VSS.t865 VSS.n1674 0.72222
R10866 VSS.t863 VSS.n1675 0.72222
R10867 VSS.t861 VSS.n1676 0.72222
R10868 VSS.t859 VSS.n1677 0.72222
R10869 VSS.n2692 VSS.t1923 0.712549
R10870 VSS.t2046 VSS.t2024 0.711103
R10871 VSS.t1166 VSS.t1782 0.711103
R10872 VSS.t2027 VSS.t1834 0.710931
R10873 VSS.t275 VSS.t134 0.710836
R10874 VSS.n1792 VSS.n1539 0.710232
R10875 VSS.t1181 VSS.n1616 0.699997
R10876 VSS.n713 VSS.t739 0.696245
R10877 VSS.n801 VSS.t696 0.696189
R10878 VSS.n1845 VSS.n1844 0.6955
R10879 VSS.n173 VSS.t254 0.691359
R10880 VSS.t435 VSS.n658 0.691359
R10881 VSS.t1409 VSS.n2693 0.691359
R10882 VSS.n1059 VSS.t2065 0.691359
R10883 VSS.n2089 VSS.t2114 0.69004
R10884 VSS.n964 VSS.t1229 0.69004
R10885 VSS.n774 VSS.t1136 0.69004
R10886 VSS.n687 VSS.t1215 0.69004
R10887 VSS.t264 VSS.n929 0.689807
R10888 VSS.n2567 VSS.t1918 0.689648
R10889 VSS.t275 VSS.t264 0.686143
R10890 VSS.t2027 VSS.t1918 0.685982
R10891 VSS.t2024 VSS.t2065 0.685835
R10892 VSS.t1782 VSS.t254 0.685835
R10893 VSS.n2692 VSS.t1409 0.684389
R10894 VSS.n1911 VSS.n1872 0.68121
R10895 VSS.n1952 VSS.n1951 0.672055
R10896 VSS.n1703 VSS.n1639 0.644461
R10897 VSS.n2567 VSS.t327 0.640921
R10898 VSS.n929 VSS.t519 0.640672
R10899 VSS.n2089 VSS.t277 0.640485
R10900 VSS.n687 VSS.t1596 0.640485
R10901 VSS.n774 VSS.t170 0.640485
R10902 VSS.n964 VSS.t129 0.640485
R10903 VSS.n2693 VSS.t122 0.639194
R10904 VSS.n173 VSS.t2076 0.639194
R10905 VSS.n658 VSS.t1645 0.639194
R10906 VSS.n1059 VSS.t200 0.639194
R10907 VSS.n31 VSS.n1056 0.631585
R10908 VSS.n31 VSS.n968 0.631585
R10909 VSS.n31 VSS.n970 0.631585
R10910 VSS.n1592 VSS.t872 0.623153
R10911 VSS.n2305 VSS.n2282 0.620417
R10912 VSS.n2312 VSS.n2266 0.620417
R10913 VSS.n2324 VSS.n2223 0.620417
R10914 VSS.n2330 VSS.n2208 0.620417
R10915 VSS.n522 VSS.n525 0.620133
R10916 VSS.n531 VSS.n534 0.620133
R10917 VSS.n548 VSS.n551 0.620133
R10918 VSS.n557 VSS.n560 0.620133
R10919 VSS.n683 VSS.n517 0.613782
R10920 VSS.n680 VSS.n517 0.613782
R10921 VSS.n675 VSS.n517 0.613782
R10922 VSS.n672 VSS.n517 0.613782
R10923 VSS.n670 VSS.n517 0.613782
R10924 VSS.n667 VSS.n517 0.613782
R10925 VSS.n643 VSS.n525 0.613782
R10926 VSS.n629 VSS.n534 0.613782
R10927 VSS.n607 VSS.n542 0.613782
R10928 VSS.n615 VSS.n542 0.613782
R10929 VSS.n594 VSS.n551 0.613782
R10930 VSS.n581 VSS.n560 0.613782
R10931 VSS.n574 VSS.n572 0.613782
R10932 VSS.n622 VSS.n542 0.600879
R10933 VSS.n1998 VSS.n1539 0.599811
R10934 VSS.t925 VSS.n2966 0.595317
R10935 VSS.t923 VSS.n2965 0.595317
R10936 VSS.n2675 VSS.t935 0.595317
R10937 VSS.n2674 VSS.t938 0.595317
R10938 VSS.n2553 VSS.t875 0.595317
R10939 VSS.t878 VSS.n2552 0.595317
R10940 VSS.t890 VSS.n2074 0.595317
R10941 VSS.t887 VSS.n2073 0.595317
R10942 VSS.t911 VSS.n1816 0.595317
R10943 VSS.n1815 VSS.t914 0.595317
R10944 VSS.t917 VSS.n1806 0.595317
R10945 VSS.n1805 VSS.t920 0.595317
R10946 VSS.t949 VSS.n500 0.595317
R10947 VSS.t947 VSS.n499 0.595317
R10948 VSS.n170 VSS.n168 0.00105281
R10949 VSS.n78 VSS.n123 0.1979
R10950 VSS.t37 VSS.n1619 0.557126
R10951 VSS.n291 VSS.n188 0.556788
R10952 VSS.n2978 VSS.n170 0.556788
R10953 VSS.n2970 VSS.n873 0.556788
R10954 VSS.n78 VSS.n80 0.556788
R10955 VSS.n2579 VSS.n2557 0.556788
R10956 VSS.n657 VSS.n517 0.553637
R10957 VSS.t656 VSS.n976 0.549435
R10958 VSS.n1953 VSS.n1952 0.548496
R10959 VSS.t1341 VSS.n2254 0.530149
R10960 VSS.n1823 VSS.n1822 0.52186
R10961 VSS.n2583 VSS.n2103 0.515438
R10962 VSS.n2305 VSS.n2283 0.515438
R10963 VSS.n2312 VSS.n2267 0.515438
R10964 VSS.n2318 VSS.n2239 0.515438
R10965 VSS.n2318 VSS.n2255 0.515438
R10966 VSS.n2324 VSS.n2224 0.515438
R10967 VSS.n2330 VSS.n2209 0.515438
R10968 VSS.n2338 VSS.n2200 0.515438
R10969 VSS.n2974 VSS.n784 0.515438
R10970 VSS.n2974 VSS.n820 0.515438
R10971 VSS.n31 VSS.n973 0.515438
R10972 VSS.n3216 VSS.n696 0.515438
R10973 VSS.n3216 VSS.n732 0.515438
R10974 VSS.n1852 VSS.n37 0.511374
R10975 VSS.n1998 VSS.n1973 0.511068
R10976 VSS.n1872 VSS.n1871 0.50929
R10977 VSS.n1542 VSS.t136 0.505816
R10978 VSS.n2254 VSS.n2251 0.50463
R10979 VSS.t901 VSS.t903 0.492336
R10980 VSS.n2462 VSS.t1196 0.477743
R10981 VSS.n2456 VSS.t344 0.477743
R10982 VSS.n2425 VSS.t451 0.477743
R10983 VSS.n2419 VSS.t1102 0.477743
R10984 VSS.n919 VSS.t2072 0.477743
R10985 VSS.n915 VSS.t144 0.477743
R10986 VSS.n911 VSS.t14 0.477743
R10987 VSS.n910 VSS.t1609 0.477743
R10988 VSS.n909 VSS.t1024 0.477743
R10989 VSS.n908 VSS.t516 0.477743
R10990 VSS.n901 VSS.t113 0.477743
R10991 VSS.n900 VSS.t260 0.477743
R10992 VSS.n899 VSS.t198 0.477743
R10993 VSS.n895 VSS.t109 0.477743
R10994 VSS.n893 VSS.t1140 0.477743
R10995 VSS.n892 VSS.t187 0.477743
R10996 VSS.n885 VSS.t1202 0.477743
R10997 VSS.n884 VSS.t296 0.477743
R10998 VSS.n883 VSS.t18 0.477743
R10999 VSS.n281 VSS.t546 0.477743
R11000 VSS.n278 VSS.t2126 0.477743
R11001 VSS.n271 VSS.t374 0.477743
R11002 VSS.n267 VSS.t2054 0.477743
R11003 VSS.n265 VSS.t2058 0.477743
R11004 VSS.n259 VSS.t464 0.477743
R11005 VSS.n254 VSS.t104 0.477743
R11006 VSS.n251 VSS.t1461 0.477743
R11007 VSS.n243 VSS.t1105 0.477743
R11008 VSS.n239 VSS.t1283 0.477743
R11009 VSS.n229 VSS.t1501 0.477743
R11010 VSS.n226 VSS.t1110 0.477743
R11011 VSS.n219 VSS.t1331 0.477743
R11012 VSS.n207 VSS.t228 0.477743
R11013 VSS.n205 VSS.t1324 0.477743
R11014 VSS.n197 VSS.t568 0.477743
R11015 VSS.n195 VSS.t523 0.477743
R11016 VSS.n2665 VSS.t1756 0.477689
R11017 VSS.n2663 VSS.t1338 0.477689
R11018 VSS.n2661 VSS.t1309 0.477689
R11019 VSS.n2657 VSS.t1198 0.477689
R11020 VSS.n2655 VSS.t564 0.477689
R11021 VSS.n2653 VSS.t560 0.477689
R11022 VSS.n2651 VSS.t139 0.477689
R11023 VSS.n2649 VSS.t56 0.477689
R11024 VSS.n2647 VSS.t1523 0.477689
R11025 VSS.n2645 VSS.t1091 0.477689
R11026 VSS.n2643 VSS.t303 0.477689
R11027 VSS.n2641 VSS.t512 0.477689
R11028 VSS.n2637 VSS.t491 0.477689
R11029 VSS.n2635 VSS.t1089 0.477689
R11030 VSS.n2633 VSS.t183 0.477689
R11031 VSS.n2631 VSS.t52 0.477689
R11032 VSS.n2629 VSS.t498 0.477689
R11033 VSS.n2627 VSS.t23 0.477689
R11034 VSS.n2625 VSS.t501 0.477689
R11035 VSS.n2623 VSS.t291 0.477689
R11036 VSS.n2621 VSS.t20 0.477689
R11037 VSS.n2617 VSS.t1333 0.477689
R11038 VSS.n2615 VSS.t1510 0.477689
R11039 VSS.n2613 VSS.t127 0.477689
R11040 VSS.n2611 VSS.t213 0.477689
R11041 VSS.n2609 VSS.t459 0.477689
R11042 VSS.n2607 VSS.t503 0.477689
R11043 VSS.n2605 VSS.t1206 0.477689
R11044 VSS.t984 VSS.n2400 0.477689
R11045 VSS.t223 VSS.n2394 0.477689
R11046 VSS.t1725 VSS.n2359 0.477689
R11047 VSS.t989 VSS.n2353 0.477689
R11048 VSS.t231 VSS.n1113 0.477689
R11049 VSS.t429 VSS.n1112 0.477689
R11050 VSS.t570 VSS.n1111 0.477689
R11051 VSS.t469 VSS.n1107 0.477689
R11052 VSS.t281 VSS.n1106 0.477689
R11053 VSS.t283 VSS.n1105 0.477689
R11054 VSS.t443 VSS.n1104 0.477689
R11055 VSS.t448 VSS.n1103 0.477689
R11056 VSS.t529 VSS.n1102 0.477689
R11057 VSS.t525 VSS.n1101 0.477689
R11058 VSS.t1 VSS.n1100 0.477689
R11059 VSS.t3 VSS.n1099 0.477689
R11060 VSS.t1422 VSS.n1095 0.477689
R11061 VSS.t1037 VSS.n1094 0.477689
R11062 VSS.t510 VSS.n1093 0.477689
R11063 VSS.t1279 VSS.n1092 0.477689
R11064 VSS.t1319 VSS.n1091 0.477689
R11065 VSS.t1064 VSS.n1090 0.477689
R11066 VSS.t1066 VSS.n1089 0.477689
R11067 VSS.t1086 VSS.n1088 0.477689
R11068 VSS.t506 VSS.n1087 0.477689
R11069 VSS.t1008 VSS.n1083 0.477689
R11070 VSS.t1094 VSS.n1082 0.477689
R11071 VSS.t1096 VSS.n1081 0.477689
R11072 VSS.t1046 VSS.n1080 0.477689
R11073 VSS.t1048 VSS.n1079 0.477689
R11074 VSS.t1120 VSS.n1078 0.477689
R11075 VSS.t1122 VSS.n1077 0.477689
R11076 VSS.t1399 VSS.n2506 0.477685
R11077 VSS.t1758 VSS.n2448 0.477685
R11078 VSS.t1100 VSS.n2411 0.477685
R11079 VSS.t83 VSS.n2406 0.477685
R11080 VSS.t89 VSS.n2365 0.477685
R11081 VSS.t980 VSS.n2473 0.47766
R11082 VSS.t1042 VSS.n2467 0.47766
R11083 VSS.t1054 VSS.n2430 0.47766
R11084 VSS.t59 VSS.n2485 0.47764
R11085 VSS.t1403 VSS.n2478 0.47764
R11086 VSS.n2387 VSS.t85 0.47764
R11087 VSS.t426 VSS.n2380 0.47764
R11088 VSS.t1258 VSS.n2542 0.477528
R11089 VSS.n921 VSS.t474 0.477515
R11090 VSS.n920 VSS.t1816 0.477515
R11091 VSS.n914 VSS.t471 0.477515
R11092 VSS.n912 VSS.t1251 0.477515
R11093 VSS.n907 VSS.t1142 0.477515
R11094 VSS.n905 VSS.t165 0.477515
R11095 VSS.n898 VSS.t157 0.477515
R11096 VSS.n896 VSS.t1098 0.477515
R11097 VSS.n891 VSS.t392 0.477515
R11098 VSS.n886 VSS.t1050 0.477515
R11099 VSS.n882 VSS.t377 0.477515
R11100 VSS.n881 VSS.t189 0.477515
R11101 VSS.n879 VSS.t179 0.477515
R11102 VSS.n283 VSS.t385 0.477515
R11103 VSS.n269 VSS.t467 0.477515
R11104 VSS.n262 VSS.t383 0.477515
R11105 VSS.n257 VSS.t1357 0.477515
R11106 VSS.n241 VSS.t544 0.477515
R11107 VSS.n236 VSS.t1326 0.477515
R11108 VSS.n233 VSS.t1455 0.477515
R11109 VSS.n223 VSS.t379 0.477515
R11110 VSS.n211 VSS.t1108 0.477515
R11111 VSS.n203 VSS.t287 0.477515
R11112 VSS.n201 VSS.t368 0.477515
R11113 VSS.t456 VSS.n2443 0.477488
R11114 VSS.t308 VSS.n2536 0.477451
R11115 VSS.t1211 VSS.n2520 0.477403
R11116 VSS.t1209 VSS.n2512 0.4774
R11117 VSS.t215 VSS.n2531 0.477396
R11118 VSS.t218 VSS.n2526 0.477326
R11119 VSS.t142 VSS.n2493 0.477326
R11120 VSS.t37 VSS.n1624 0.477286
R11121 VSS.t37 VSS.n1625 0.472981
R11122 VSS.t652 VSS.n976 0.470239
R11123 VSS.t851 VSS.n412 0.467137
R11124 VSS.n397 VSS.t262 0.467079
R11125 VSS.n360 VSS.t177 0.467079
R11126 VSS.t389 VSS.n457 0.467079
R11127 VSS.t1986 VSS.n372 0.467079
R11128 VSS.t1029 VSS.n332 0.467079
R11129 VSS.t111 VSS.n489 0.467061
R11130 VSS.t339 VSS.n429 0.467061
R11131 VSS.n470 VSS.t34 0.467049
R11132 VSS.t2236 VSS.n435 0.46695
R11133 VSS.n463 VSS.t994 0.466877
R11134 VSS.t354 VSS.n441 0.466877
R11135 VSS.t349 VSS.n392 0.466877
R11136 VSS.t357 VSS.n354 0.466877
R11137 VSS.t1877 VSS.n313 0.466877
R11138 VSS.t1178 VSS.n483 0.466867
R11139 VSS.t1676 VSS.n423 0.466867
R11140 VSS.t2153 VSS.n347 0.466867
R11141 VSS.t2128 VSS.n306 0.466867
R11142 VSS.t336 VSS.n452 0.466777
R11143 VSS.t1304 VSS.n327 0.466777
R11144 VSS.t360 VSS.n477 0.466752
R11145 VSS.t363 VSS.n418 0.466752
R11146 VSS.n379 VSS.t333 0.466752
R11147 VSS.n340 VSS.t366 0.466752
R11148 VSS.n299 VSS.t1710 0.466752
R11149 VSS.t1301 VSS.n405 0.466686
R11150 VSS.t102 VSS.n366 0.466686
R11151 VSS.t1069 VSS.n1228 0.466542
R11152 VSS.t532 VSS.n1214 0.466542
R11153 VSS.t1429 VSS.n1207 0.466542
R11154 VSS.t2098 VSS.n1200 0.466542
R11155 VSS.t1420 VSS.n1193 0.466542
R11156 VSS.t2088 VSS.n1179 0.466542
R11157 VSS.t1321 VSS.n1172 0.466542
R11158 VSS.t1219 VSS.n1165 0.466542
R11159 VSS.t1492 VSS.n1158 0.466542
R11160 VSS.t1348 VSS.n1144 0.466542
R11161 VSS.t1413 VSS.n1137 0.466542
R11162 VSS.t1928 VSS.n1130 0.466542
R11163 VSS.t1405 VSS.n2662 0.466542
R11164 VSS.t1397 VSS.n2654 0.466542
R11165 VSS.t54 VSS.n2650 0.466542
R11166 VSS.t1805 VSS.n2646 0.466542
R11167 VSS.t1912 VSS.n2642 0.466542
R11168 VSS.t1957 VSS.n2634 0.466542
R11169 VSS.t1799 VSS.n2630 0.466542
R11170 VSS.t1638 VSS.n2626 0.466542
R11171 VSS.t2033 VSS.n2622 0.466542
R11172 VSS.t2020 VSS.n2614 0.466542
R11173 VSS.t1947 VSS.n2610 0.466542
R11174 VSS.t1615 VSS.n2606 0.466542
R11175 VSS.t294 VSS.n2823 0.466542
R11176 VSS.t1253 VSS.n2807 0.466542
R11177 VSS.t1289 VSS.n2800 0.466542
R11178 VSS.t117 VSS.n2791 0.466542
R11179 VSS.t1155 VSS.n2783 0.466542
R11180 VSS.t270 VSS.n2767 0.466542
R11181 VSS.t1118 VSS.n2759 0.466542
R11182 VSS.t205 VSS.n2752 0.466542
R11183 VSS.t167 VSS.n2743 0.466542
R11184 VSS.t298 VSS.n2728 0.466542
R11185 VSS.t257 VSS.n2719 0.466542
R11186 VSS.t181 VSS.n2711 0.466542
R11187 VSS.t301 VSS.t1316 0.466542
R11188 VSS.t87 VSS.t1990 0.466542
R11189 VSS.t32 VSS.t81 0.466542
R11190 VSS.t1084 VSS.t2036 0.466542
R11191 VSS.t1061 VSS.t1052 0.466542
R11192 VSS.t1854 VSS.t2030 0.466542
R11193 VSS.t407 VSS.t342 0.466542
R11194 VSS.t325 VSS.t1044 0.466542
R11195 VSS.t29 VSS.t1475 0.466542
R11196 VSS.t61 VSS.t1191 0.466542
R11197 VSS.t1390 VSS.t1528 0.466542
R11198 VSS.t1385 VSS.t1382 0.466542
R11199 VSS.t155 VSS.t1260 0.466542
R11200 VSS.n2118 VSS.t1329 0.466192
R11201 VSS.n2121 VSS.t2254 0.466192
R11202 VSS.n2123 VSS.t446 0.466192
R11203 VSS.n2127 VSS.t402 0.466192
R11204 VSS.n2130 VSS.t539 0.466192
R11205 VSS.n2131 VSS.t2188 0.466192
R11206 VSS.n2133 VSS.t107 0.466192
R11207 VSS.n2135 VSS.t313 0.466192
R11208 VSS.n2139 VSS.t1850 0.466192
R11209 VSS.n2140 VSS.t399 0.466192
R11210 VSS.n2142 VSS.t2239 0.466192
R11211 VSS.n2146 VSS.t2191 0.466192
R11212 VSS.n2149 VSS.t1128 0.466192
R11213 VSS.n2152 VSS.t316 0.466192
R11214 VSS.n2155 VSS.t1072 0.466192
R11215 VSS.n2158 VSS.t2257 0.466192
R11216 VSS.t1532 VSS.n2604 0.466192
R11217 VSS.t1542 VSS.n2608 0.466192
R11218 VSS.t64 VSS.n2612 0.466192
R11219 VSS.t1483 VSS.n2616 0.466192
R11220 VSS.t1539 VSS.n2620 0.466192
R11221 VSS.t1026 VSS.n2624 0.466192
R11222 VSS.t70 VSS.n2628 0.466192
R11223 VSS.t1233 VSS.n2632 0.466192
R11224 VSS.t76 VSS.n2636 0.466192
R11225 VSS.t1653 VSS.n2640 0.466192
R11226 VSS.t305 VSS.n2644 0.466192
R11227 VSS.t1488 VSS.n2648 0.466192
R11228 VSS.t73 VSS.n2652 0.466192
R11229 VSS.t1466 VSS.n2656 0.466192
R11230 VSS.t1908 VSS.n2660 0.466192
R11231 VSS.t1737 VSS.n2664 0.466192
R11232 VSS.n2824 VSS.t1448 0.466192
R11233 VSS.n2816 VSS.t2243 0.466192
R11234 VSS.n2808 VSS.t1365 0.466192
R11235 VSS.n2801 VSS.t12 0.466192
R11236 VSS.n2793 VSS.t1022 0.466192
R11237 VSS.n2784 VSS.t488 0.466192
R11238 VSS.n2777 VSS.t2109 0.466192
R11239 VSS.n2769 VSS.t1744 0.466192
R11240 VSS.n2760 VSS.t496 0.466192
R11241 VSS.n2753 VSS.t1749 0.466192
R11242 VSS.n2745 VSS.t185 0.466192
R11243 VSS.n2736 VSS.t1079 0.466192
R11244 VSS.n2729 VSS.t1441 0.466192
R11245 VSS.n2721 VSS.t16 0.466192
R11246 VSS.n2712 VSS.t1170 0.466192
R11247 VSS.n2705 VSS.t1032 0.466192
R11248 VSS.n1229 VSS.t431 0.466192
R11249 VSS.n1222 VSS.t2004 0.466192
R11250 VSS.n1215 VSS.t1898 0.466192
R11251 VSS.n1208 VSS.t152 0.466192
R11252 VSS.n1201 VSS.t1426 0.466192
R11253 VSS.n1194 VSS.t1732 0.466192
R11254 VSS.n1187 VSS.t2007 0.466192
R11255 VSS.n1180 VSS.t1498 0.466192
R11256 VSS.n1173 VSS.t1895 0.466192
R11257 VSS.n1166 VSS.t149 0.466192
R11258 VSS.n1159 VSS.t1222 0.466192
R11259 VSS.n1152 VSS.t550 0.466192
R11260 VSS.n1145 VSS.t244 0.466192
R11261 VSS.n1138 VSS.t6 0.466192
R11262 VSS.n1131 VSS.t553 0.466192
R11263 VSS.n1124 VSS.t1681 0.466192
R11264 VSS.n1645 VSS.n1639 0.465499
R11265 VSS.n1792 VSS.t1186 0.464894
R11266 VSS.n2251 VSS.t438 0.453491
R11267 VSS.t321 VSS.t1247 0.453491
R11268 VSS.n1955 VSS.n1954 0.452018
R11269 VSS.n2705 VSS.t181 0.451785
R11270 VSS.n2712 VSS.t257 0.451785
R11271 VSS.n2721 VSS.t298 0.451785
R11272 VSS.n2729 VSS.t1237 0.451785
R11273 VSS.n2736 VSS.t167 0.451785
R11274 VSS.n2745 VSS.t205 0.451785
R11275 VSS.n2753 VSS.t1118 0.451785
R11276 VSS.n2760 VSS.t270 0.451785
R11277 VSS.n2769 VSS.t853 0.451785
R11278 VSS.n2777 VSS.t1155 0.451785
R11279 VSS.n2784 VSS.t117 0.451785
R11280 VSS.n2793 VSS.t1289 0.451785
R11281 VSS.n2801 VSS.t1253 0.451785
R11282 VSS.n2808 VSS.t972 0.451785
R11283 VSS.n2816 VSS.t294 0.451785
R11284 VSS.n2824 VSS.t1632 0.451785
R11285 VSS.n2604 VSS.t1615 0.451785
R11286 VSS.n2608 VSS.t1947 0.451785
R11287 VSS.n2612 VSS.t2020 0.451785
R11288 VSS.n2616 VSS.t1910 0.451785
R11289 VSS.n2620 VSS.t2033 0.451785
R11290 VSS.n2624 VSS.t1638 0.451785
R11291 VSS.n2628 VSS.t1799 0.451785
R11292 VSS.n2632 VSS.t1957 0.451785
R11293 VSS.n2636 VSS.t493 0.451785
R11294 VSS.n2640 VSS.t1912 0.451785
R11295 VSS.n2644 VSS.t1805 0.451785
R11296 VSS.n2648 VSS.t54 0.451785
R11297 VSS.n2652 VSS.t1397 0.451785
R11298 VSS.n2656 VSS.t1200 0.451785
R11299 VSS.n2660 VSS.t1405 0.451785
R11300 VSS.n2664 VSS.t1754 0.451785
R11301 VSS.t991 VSS.n2158 0.451785
R11302 VSS.t1316 VSS.n2155 0.451785
R11303 VSS.t1313 VSS.n2152 0.451785
R11304 VSS.t1990 VSS.n2149 0.451785
R11305 VSS.t81 VSS.n2146 0.451785
R11306 VSS.t2036 VSS.n2142 0.451785
R11307 VSS.t1052 VSS.n2140 0.451785
R11308 VSS.t2030 VSS.n2139 0.451785
R11309 VSS.t342 VSS.n2135 0.451785
R11310 VSS.t1044 VSS.n2133 0.451785
R11311 VSS.t1475 VSS.n2131 0.451785
R11312 VSS.t1191 VSS.n2130 0.451785
R11313 VSS.t1470 VSS.n2127 0.451785
R11314 VSS.t1528 VSS.n2123 0.451785
R11315 VSS.t1382 VSS.n2121 0.451785
R11316 VSS.t1260 VSS.n2118 0.451785
R11317 VSS.n1124 VSS.t1928 0.451785
R11318 VSS.n1131 VSS.t1413 0.451785
R11319 VSS.n1138 VSS.t1348 0.451785
R11320 VSS.n1145 VSS.t1010 0.451785
R11321 VSS.n1152 VSS.t1492 0.451785
R11322 VSS.n1159 VSS.t1219 0.451785
R11323 VSS.n1166 VSS.t1321 0.451785
R11324 VSS.n1173 VSS.t2088 0.451785
R11325 VSS.n1180 VSS.t2177 0.451785
R11326 VSS.n1187 VSS.t1420 0.451785
R11327 VSS.n1194 VSS.t2098 0.451785
R11328 VSS.n1201 VSS.t1429 0.451785
R11329 VSS.n1208 VSS.t532 0.451785
R11330 VSS.n1215 VSS.t1557 0.451785
R11331 VSS.n1222 VSS.t1069 0.451785
R11332 VSS.n1229 VSS.t233 0.451785
R11333 VSS.t1448 VSS.n2823 0.451337
R11334 VSS.t1365 VSS.n2807 0.451337
R11335 VSS.t12 VSS.n2800 0.451337
R11336 VSS.t1022 VSS.n2791 0.451337
R11337 VSS.t488 VSS.n2783 0.451337
R11338 VSS.t1744 VSS.n2767 0.451337
R11339 VSS.t496 VSS.n2759 0.451337
R11340 VSS.t1749 VSS.n2752 0.451337
R11341 VSS.t185 VSS.n2743 0.451337
R11342 VSS.t1441 VSS.n2728 0.451337
R11343 VSS.t16 VSS.n2719 0.451337
R11344 VSS.t1170 VSS.n2711 0.451337
R11345 VSS.n2606 VSS.t1542 0.451337
R11346 VSS.n2610 VSS.t64 0.451337
R11347 VSS.n2614 VSS.t1483 0.451337
R11348 VSS.n2622 VSS.t1026 0.451337
R11349 VSS.n2626 VSS.t70 0.451337
R11350 VSS.n2630 VSS.t1233 0.451337
R11351 VSS.n2634 VSS.t76 0.451337
R11352 VSS.n2642 VSS.t305 0.451337
R11353 VSS.n2646 VSS.t1488 0.451337
R11354 VSS.n2650 VSS.t73 0.451337
R11355 VSS.n2654 VSS.t1466 0.451337
R11356 VSS.n2662 VSS.t1737 0.451337
R11357 VSS.t431 VSS.n1228 0.451337
R11358 VSS.t1898 VSS.n1214 0.451337
R11359 VSS.t152 VSS.n1207 0.451337
R11360 VSS.t1426 VSS.n1200 0.451337
R11361 VSS.t1732 VSS.n1193 0.451337
R11362 VSS.t1498 VSS.n1179 0.451337
R11363 VSS.t1895 VSS.n1172 0.451337
R11364 VSS.t149 VSS.n1165 0.451337
R11365 VSS.t1222 VSS.n1158 0.451337
R11366 VSS.t244 VSS.n1144 0.451337
R11367 VSS.t6 VSS.n1137 0.451337
R11368 VSS.t553 VSS.n1130 0.451337
R11369 VSS.t2254 VSS.t155 0.451337
R11370 VSS.t446 VSS.t1385 0.451337
R11371 VSS.t402 VSS.t1390 0.451337
R11372 VSS.t2188 VSS.t61 0.451337
R11373 VSS.t107 VSS.t29 0.451337
R11374 VSS.t313 VSS.t325 0.451337
R11375 VSS.t1850 VSS.t407 0.451337
R11376 VSS.t399 VSS.t1854 0.451337
R11377 VSS.t2239 VSS.t1061 0.451337
R11378 VSS.t2191 VSS.t1084 0.451337
R11379 VSS.t1128 VSS.t32 0.451337
R11380 VSS.t316 VSS.t87 0.451337
R11381 VSS.t2257 VSS.t301 0.451337
R11382 VSS.n405 VSS.t262 0.451261
R11383 VSS.n366 VSS.t177 0.451261
R11384 VSS.n452 VSS.t857 0.451143
R11385 VSS.n327 VSS.t1629 0.451143
R11386 VSS.n477 VSS.t34 0.451136
R11387 VSS.n418 VSS.t851 0.451136
R11388 VSS.n379 VSS.t1986 0.451136
R11389 VSS.n340 VSS.t1029 0.451136
R11390 VSS.n299 VSS.t1159 0.451136
R11391 VSS.n483 VSS.t360 0.451074
R11392 VSS.n423 VSS.t363 0.451074
R11393 VSS.n347 VSS.t366 0.451074
R11394 VSS.n306 VSS.t1710 0.451074
R11395 VSS.n463 VSS.t389 0.451048
R11396 VSS.n441 VSS.t2236 0.451048
R11397 VSS.n392 VSS.t1601 0.451048
R11398 VSS.n354 VSS.t2153 0.451048
R11399 VSS.n313 VSS.t2128 0.451048
R11400 VSS.n435 VSS.t339 0.450975
R11401 VSS.n470 VSS.t994 0.450937
R11402 VSS.n1646 VSS.n1645 0.450926
R11403 VSS.n457 VSS.t336 0.450883
R11404 VSS.n397 VSS.t349 0.450883
R11405 VSS.n372 VSS.t102 0.450883
R11406 VSS.n360 VSS.t357 0.450883
R11407 VSS.n332 VSS.t1304 0.450883
R11408 VSS.n489 VSS.t1178 0.450853
R11409 VSS.n429 VSS.t1676 0.450853
R11410 VSS.n412 VSS.t1301 0.450834
R11411 VSS.n1677 VSS.n1646 0.449723
R11412 VSS.n1954 VSS.n1953 0.448738
R11413 VSS.n1824 VSS.n1823 0.447348
R11414 VSS.n2600 VSS.n172 0.44402
R11415 VSS.n2699 VSS.n2698 0.44402
R11416 VSS.n2590 VSS.n2586 0.44402
R11417 VSS.n2577 VSS.n2576 0.44402
R11418 VSS.n2493 VSS.t59 0.44059
R11419 VSS.n2526 VSS.t1211 0.44059
R11420 VSS.n2531 VSS.t218 0.44057
R11421 VSS.n2512 VSS.t1399 0.440566
R11422 VSS.n2536 VSS.t215 0.440502
R11423 VSS.n2520 VSS.t1209 0.440492
R11424 VSS.n2443 VSS.t454 0.440463
R11425 VSS.n2542 VSS.t308 0.440404
R11426 VSS.n283 VSS.t1864 0.440369
R11427 VSS.n269 VSS.t374 0.440369
R11428 VSS.n262 VSS.t2058 0.440369
R11429 VSS.n257 VSS.t464 0.440369
R11430 VSS.n241 VSS.t1105 0.440369
R11431 VSS.n236 VSS.t1283 0.440369
R11432 VSS.n233 VSS.t1326 0.440369
R11433 VSS.n223 VSS.t1110 0.440369
R11434 VSS.n211 VSS.t1112 0.440369
R11435 VSS.n203 VSS.t1324 0.440369
R11436 VSS.n201 VSS.t287 0.440369
R11437 VSS.n921 VSS.t146 0.440369
R11438 VSS.n920 VSS.t474 0.440369
R11439 VSS.n914 VSS.t144 0.440369
R11440 VSS.n912 VSS.t471 0.440369
R11441 VSS.n907 VSS.t516 0.440369
R11442 VSS.n905 VSS.t1142 0.440369
R11443 VSS.n898 VSS.t198 0.440369
R11444 VSS.n896 VSS.t157 0.440369
R11445 VSS.n891 VSS.t187 0.440369
R11446 VSS.n886 VSS.t1131 0.440369
R11447 VSS.n882 VSS.t18 0.440369
R11448 VSS.n881 VSS.t377 0.440369
R11449 VSS.n879 VSS.t189 0.440369
R11450 VSS.n2380 VSS.t1144 0.44028
R11451 VSS.n2387 VSS.t426 0.44028
R11452 VSS.n2478 VSS.t980 0.44028
R11453 VSS.n2485 VSS.t1403 0.44028
R11454 VSS.n2506 VSS.t1394 0.440231
R11455 VSS.n2365 VSS.t1725 0.440231
R11456 VSS.n2406 VSS.t984 0.440231
R11457 VSS.n2411 VSS.t83 0.440231
R11458 VSS.n2448 VSS.t456 0.440231
R11459 VSS.t1046 VSS.n1079 0.440228
R11460 VSS.t1094 VSS.n1081 0.440228
R11461 VSS.t1086 VSS.n1087 0.440228
R11462 VSS.t1066 VSS.n1088 0.440228
R11463 VSS.t1064 VSS.n1089 0.440228
R11464 VSS.t1037 VSS.n1093 0.440228
R11465 VSS.t1422 VSS.n1094 0.440228
R11466 VSS.t529 VSS.n1101 0.440228
R11467 VSS.t448 VSS.n1102 0.440228
R11468 VSS.t97 VSS.n1107 0.440228
R11469 VSS.t503 VSS.n2605 0.440228
R11470 VSS.t1510 VSS.n2613 0.440228
R11471 VSS.t1333 VSS.n2615 0.440228
R11472 VSS.t23 VSS.n2625 0.440228
R11473 VSS.t498 VSS.n2627 0.440228
R11474 VSS.t1089 VSS.n2633 0.440228
R11475 VSS.t1523 VSS.n2645 0.440228
R11476 VSS.t139 VSS.n2649 0.440228
R11477 VSS.t560 VSS.n2651 0.440228
R11478 VSS.t564 VSS.n2653 0.440228
R11479 VSS.t2366 VSS.n2665 0.440228
R11480 VSS.t1120 VSS.n1077 0.440228
R11481 VSS.t1048 VSS.n1078 0.440228
R11482 VSS.t1096 VSS.n1080 0.440228
R11483 VSS.t1008 VSS.n1082 0.440228
R11484 VSS.t370 VSS.n1083 0.440228
R11485 VSS.t1319 VSS.n1090 0.440228
R11486 VSS.t1279 VSS.n1091 0.440228
R11487 VSS.t510 VSS.n1092 0.440228
R11488 VSS.t1015 VSS.n1095 0.440228
R11489 VSS.t1 VSS.n1099 0.440228
R11490 VSS.t525 VSS.n1100 0.440228
R11491 VSS.t443 VSS.n1103 0.440228
R11492 VSS.t283 VSS.n1104 0.440228
R11493 VSS.t281 VSS.n1105 0.440228
R11494 VSS.t469 VSS.n1106 0.440228
R11495 VSS.t429 VSS.n1111 0.440228
R11496 VSS.t231 VSS.n1112 0.440228
R11497 VSS.t1040 VSS.n1113 0.440228
R11498 VSS.t459 VSS.n2607 0.440228
R11499 VSS.t213 VSS.n2609 0.440228
R11500 VSS.t127 VSS.n2611 0.440228
R11501 VSS.t387 VSS.n2617 0.440228
R11502 VSS.t291 VSS.n2621 0.440228
R11503 VSS.t501 VSS.n2623 0.440228
R11504 VSS.t52 VSS.n2629 0.440228
R11505 VSS.t183 VSS.n2631 0.440228
R11506 VSS.t491 VSS.n2635 0.440228
R11507 VSS.t1074 VSS.n2637 0.440228
R11508 VSS.t303 VSS.n2641 0.440228
R11509 VSS.t1091 VSS.n2643 0.440228
R11510 VSS.t56 VSS.n2647 0.440228
R11511 VSS.t1198 VSS.n2655 0.440228
R11512 VSS.t220 VSS.n2657 0.440228
R11513 VSS.t1338 VSS.n2661 0.440228
R11514 VSS.t1756 VSS.n2663 0.440228
R11515 VSS.n2400 VSS.t223 0.440228
R11516 VSS.n2394 VSS.t85 0.440228
R11517 VSS.n2359 VSS.t989 0.440228
R11518 VSS.n2353 VSS.t2378 0.440228
R11519 VSS.n2430 VSS.t451 0.440225
R11520 VSS.n2467 VSS.t1196 0.440225
R11521 VSS.n2473 VSS.t1042 0.440225
R11522 VSS.n2419 VSS.t1100 0.440116
R11523 VSS.n2425 VSS.t1102 0.440116
R11524 VSS.n2456 VSS.t1758 0.440116
R11525 VSS.n2462 VSS.t344 0.440116
R11526 VSS.t568 VSS.n195 0.440116
R11527 VSS.t368 VSS.n197 0.440116
R11528 VSS.t228 VSS.n205 0.440116
R11529 VSS.t1108 VSS.n207 0.440116
R11530 VSS.t379 VSS.n219 0.440116
R11531 VSS.t1501 VSS.n226 0.440116
R11532 VSS.t1455 VSS.n229 0.440116
R11533 VSS.t544 VSS.n239 0.440116
R11534 VSS.t236 VSS.n243 0.440116
R11535 VSS.t104 VSS.n251 0.440116
R11536 VSS.t1357 VSS.n254 0.440116
R11537 VSS.t383 VSS.n259 0.440116
R11538 VSS.t2054 VSS.n265 0.440116
R11539 VSS.t467 VSS.n267 0.440116
R11540 VSS.t483 VSS.n271 0.440116
R11541 VSS.t546 VSS.n278 0.440116
R11542 VSS.t385 VSS.n281 0.440116
R11543 VSS.t296 VSS.n883 0.440116
R11544 VSS.t1202 VSS.n884 0.440116
R11545 VSS.t1050 VSS.n885 0.440116
R11546 VSS.t1140 VSS.n892 0.440116
R11547 VSS.t109 VSS.n893 0.440116
R11548 VSS.t1098 VSS.n895 0.440116
R11549 VSS.t260 VSS.n899 0.440116
R11550 VSS.t113 VSS.n900 0.440116
R11551 VSS.t1819 VSS.n901 0.440116
R11552 VSS.t1024 VSS.n908 0.440116
R11553 VSS.t1609 VSS.n909 0.440116
R11554 VSS.t14 VSS.n910 0.440116
R11555 VSS.t1251 VSS.n911 0.440116
R11556 VSS.t163 VSS.n915 0.440116
R11557 VSS.t1816 VSS.n919 0.440116
R11558 VSS.n2590 VSS.n2589 0.435807
R11559 VSS.n3216 VSS.t93 0.434903
R11560 VSS.n2583 VSS.t2118 0.434883
R11561 VSS.n31 VSS.t1174 0.434883
R11562 VSS.n2974 VSS.t191 0.434882
R11563 VSS.n2589 VSS.n943 0.427593
R11564 VSS.t136 VSS.t45 0.424001
R11565 VSS.t608 VSS.t438 0.418405
R11566 VSS.t1247 VSS.t810 0.418405
R11567 VSS.n956 VSS.n949 0.417336
R11568 VSS.n958 VSS.n950 0.417043
R11569 VSS.n956 VSS.n950 0.416074
R11570 VSS.n2587 VSS.n949 0.415796
R11571 VSS.n1837 VSS.n1818 0.41014
R11572 VSS.n1998 VSS.n1454 0.403182
R11573 VSS.n1853 VSS.n37 0.402853
R11574 VSS.n2002 VSS.n1242 0.402112
R11575 VSS.n2974 VSS.n801 0.401105
R11576 VSS.n3216 VSS.n713 0.401072
R11577 VSS.n902 VSS.t1819 0.39181
R11578 VSS.n888 VSS.t1131 0.39181
R11579 VSS.n274 VSS.t483 0.39181
R11580 VSS.n246 VSS.t236 0.39181
R11581 VSS.n214 VSS.t1112 0.39181
R11582 VSS.n2680 VSS.t220 0.391779
R11583 VSS.n2678 VSS.t1074 0.391779
R11584 VSS.n2676 VSS.t387 0.391779
R11585 VSS.t1394 VSS.n2499 0.391779
R11586 VSS.t454 VSS.n2437 0.391779
R11587 VSS.t97 VSS.n1108 0.391779
R11588 VSS.t1015 VSS.n1096 0.391779
R11589 VSS.t370 VSS.n1084 0.391779
R11590 VSS.n916 VSS.t163 0.391632
R11591 VSS.t1144 VSS.n2373 0.391516
R11592 VSS.t1629 VSS.n320 0.380784
R11593 VSS.t1601 VSS.n386 0.380674
R11594 VSS.n2015 VSS.t1557 0.380287
R11595 VSS.n2036 VSS.t2177 0.380287
R11596 VSS.t1313 VSS.n2151 0.380287
R11597 VSS.t1200 VSS.n2658 0.380287
R11598 VSS.t493 VSS.n2638 0.380287
R11599 VSS.n2856 VSS.t972 0.380287
R11600 VSS.n2896 VSS.t853 0.380287
R11601 VSS.n1961 VSS.n1960 0.376066
R11602 VSS.n1674 VSS.n1658 0.374692
R11603 VSS.n1964 VSS.n1963 0.36227
R11604 VSS.n2373 VSS.n2374 0.352182
R11605 VSS.n2856 VSS.t846 0.352129
R11606 VSS.n2658 VSS.t79 0.352129
R11607 VSS.t410 VSS.n2151 0.352129
R11608 VSS.n2015 VSS.t1839 0.352129
R11609 VSS.n916 VSS.n917 0.352039
R11610 VSS.n2499 VSS.n2494 0.351918
R11611 VSS.n2437 VSS.n2433 0.351918
R11612 VSS.n2679 VSS.n2678 0.351918
R11613 VSS.n2681 VSS.n2680 0.351918
R11614 VSS.n2677 VSS.n2676 0.351918
R11615 VSS.n1085 VSS.n1084 0.351918
R11616 VSS.n1097 VSS.n1096 0.351918
R11617 VSS.n1109 VSS.n1108 0.351918
R11618 VSS.n217 VSS.n214 0.351842
R11619 VSS.n248 VSS.n246 0.351842
R11620 VSS.n275 VSS.n274 0.351842
R11621 VSS.n889 VSS.n888 0.351842
R11622 VSS.n903 VSS.n902 0.351842
R11623 VSS.n320 VSS.t1006 0.351637
R11624 VSS.n0 VSS.n6 0.351198
R11625 VSS.n1677 VSS.n1652 0.339937
R11626 VSS.n1957 VSS.n1956 0.338265
R11627 VSS.n1956 VSS.n1955 0.338019
R11628 VSS.n1676 VSS.n1652 0.336254
R11629 VSS.n2896 VSS.t1438 0.335879
R11630 VSS.n2638 VSS.t1480 0.335879
R11631 VSS.n2036 VSS.t241 0.335879
R11632 VSS.n386 VSS.t1701 0.335525
R11633 VSS.n2695 VSS.n2601 0.330412
R11634 VSS.n1070 VSS.n1118 0.330412
R11635 VSS.n2574 VSS.n2558 0.330412
R11636 VSS.n1828 VSS.n1827 0.312321
R11637 VSS.n2599 VSS.n2596 0.31114
R11638 VSS.n1675 VSS.n1658 0.307655
R11639 VSS.n1960 VSS.n1959 0.306341
R11640 VSS.t626 VSS.t624 0.305925
R11641 VSS.t614 VSS.t612 0.305925
R11642 VSS.t602 VSS.t600 0.305925
R11643 VSS.t591 VSS.t589 0.305925
R11644 VSS.t579 VSS.t577 0.305925
R11645 VSS.t827 VSS.t825 0.305925
R11646 VSS.t816 VSS.t814 0.305925
R11647 VSS.t804 VSS.t802 0.305925
R11648 VSS.t792 VSS.t790 0.305925
R11649 VSS.t781 VSS.t779 0.305925
R11650 VSS.t1204 VSS.t2366 0.302153
R11651 VSS.t2378 VSS.t1408 0.302153
R11652 VSS.t1040 VSS.t1959 0.302153
R11653 VSS.t146 VSS.t1298 0.302137
R11654 VSS.t1864 VSS.t404 0.302137
R11655 VSS.n2160 VSS.t881 0.301136
R11656 VSS.n287 VSS.t953 0.300523
R11657 VSS.n1834 VSS.n1833 0.291601
R11658 VSS.t1159 VSS.n294 0.291418
R11659 VSS.n2159 VSS.t991 0.290734
R11660 VSS.t1754 VSS.n2666 0.290734
R11661 VSS.n2839 VSS.t1632 0.290734
R11662 VSS.n2006 VSS.t233 0.290734
R11663 VSS.t1166 VSS.n185 0.289639
R11664 VSS.t134 VSS.n874 0.289639
R11665 VSS.n1836 VSS.n1834 0.287886
R11666 VSS.n1607 VSS.t196 0.286439
R11667 VSS.n185 VSS.n171 0.28352
R11668 VSS.n2597 VSS.n874 0.28352
R11669 VSS.t2383 VSS.n2200 0.282582
R11670 VSS.t413 VSS.n574 0.282582
R11671 VSS.n1867 VSS.n1866 0.278666
R11672 VSS.t1032 VSS.n2703 0.275961
R11673 VSS.n2687 VSS.t1532 0.275961
R11674 VSS.t1329 VSS.n2199 0.275961
R11675 VSS.t1681 VSS.n1122 0.275961
R11676 VSS.t534 VSS.n1812 0.275903
R11677 VSS.n495 VSS.t111 0.275633
R11678 VSS.n2583 VSS.n2097 0.275232
R11679 VSS.n31 VSS.n1046 0.275169
R11680 VSS.n500 VSS.n193 0.27249
R11681 VSS.n2552 VSS.n2544 0.27249
R11682 VSS.n2966 VSS.n878 0.27249
R11683 VSS.n501 VSS.n495 0.27241
R11684 VSS.n2074 VSS.n1076 0.272321
R11685 VSS.n2603 VSS.n2674 0.272321
R11686 VSS.n2551 VSS.n2199 0.272065
R11687 VSS.n2688 VSS.n2687 0.272065
R11688 VSS.n2703 VSS.n2704 0.272065
R11689 VSS.n1122 VSS.n1123 0.272065
R11690 VSS.t1874 VSS.n2733 0.267977
R11691 VSS.n2618 VSS.t1903 0.267977
R11692 VSS.n2126 VSS.t1035 0.267977
R11693 VSS.t2251 VSS.n1149 0.267977
R11694 VSS.n2579 VSS.n2115 0.267794
R11695 VSS.n2579 VSS.n2116 0.267794
R11696 VSS.n2579 VSS.n2198 0.267794
R11697 VSS.n2579 VSS.n2119 0.267794
R11698 VSS.n2579 VSS.n2197 0.267794
R11699 VSS.n2579 VSS.n2120 0.267794
R11700 VSS.n2579 VSS.n2195 0.267794
R11701 VSS.n2579 VSS.n2122 0.267794
R11702 VSS.n2579 VSS.n2194 0.267794
R11703 VSS.n2579 VSS.n2193 0.267794
R11704 VSS.n2579 VSS.n2124 0.267794
R11705 VSS.n2579 VSS.n2125 0.267794
R11706 VSS.n2579 VSS.n2192 0.267794
R11707 VSS.n2579 VSS.n2128 0.267794
R11708 VSS.n2579 VSS.n2191 0.267794
R11709 VSS.n2579 VSS.n2190 0.267794
R11710 VSS.n2579 VSS.n2189 0.267794
R11711 VSS.n2579 VSS.n2187 0.267794
R11712 VSS.n2579 VSS.n2186 0.267794
R11713 VSS.n2579 VSS.n2185 0.267794
R11714 VSS.n2579 VSS.n2184 0.267794
R11715 VSS.n2579 VSS.n2134 0.267794
R11716 VSS.n2579 VSS.n2183 0.267794
R11717 VSS.n2579 VSS.n2182 0.267794
R11718 VSS.n2579 VSS.n2181 0.267794
R11719 VSS.n2579 VSS.n2180 0.267794
R11720 VSS.n2579 VSS.n2179 0.267794
R11721 VSS.n2579 VSS.n2136 0.267794
R11722 VSS.n2579 VSS.n2138 0.267794
R11723 VSS.n2579 VSS.n2178 0.267794
R11724 VSS.n2579 VSS.n2177 0.267794
R11725 VSS.n2579 VSS.n2175 0.267794
R11726 VSS.n2579 VSS.n2141 0.267794
R11727 VSS.n2579 VSS.n2174 0.267794
R11728 VSS.n2579 VSS.n2173 0.267794
R11729 VSS.n2579 VSS.n2172 0.267794
R11730 VSS.n2579 VSS.n2171 0.267794
R11731 VSS.n2579 VSS.n2170 0.267794
R11732 VSS.n2579 VSS.n2143 0.267794
R11733 VSS.n2579 VSS.n2145 0.267794
R11734 VSS.n2579 VSS.n2169 0.267794
R11735 VSS.n2579 VSS.n2147 0.267794
R11736 VSS.n2579 VSS.n2168 0.267794
R11737 VSS.n2579 VSS.n2167 0.267794
R11738 VSS.n2579 VSS.n2153 0.267794
R11739 VSS.n2579 VSS.n2165 0.267794
R11740 VSS.n2579 VSS.n2164 0.267794
R11741 VSS.n2579 VSS.n2156 0.267794
R11742 VSS.n2579 VSS.n2162 0.267794
R11743 VSS.n291 VSS.n288 0.267794
R11744 VSS.n291 VSS.n282 0.267794
R11745 VSS.n291 VSS.n280 0.267794
R11746 VSS.n291 VSS.n277 0.267794
R11747 VSS.n291 VSS.n273 0.267794
R11748 VSS.n291 VSS.n270 0.267794
R11749 VSS.n291 VSS.n268 0.267794
R11750 VSS.n291 VSS.n266 0.267794
R11751 VSS.n291 VSS.n263 0.267794
R11752 VSS.n291 VSS.n261 0.267794
R11753 VSS.n291 VSS.n260 0.267794
R11754 VSS.n291 VSS.n256 0.267794
R11755 VSS.n291 VSS.n255 0.267794
R11756 VSS.n291 VSS.n253 0.267794
R11757 VSS.n291 VSS.n250 0.267794
R11758 VSS.n291 VSS.n247 0.267794
R11759 VSS.n291 VSS.n245 0.267794
R11760 VSS.n291 VSS.n242 0.267794
R11761 VSS.n291 VSS.n240 0.267794
R11762 VSS.n291 VSS.n238 0.267794
R11763 VSS.n291 VSS.n237 0.267794
R11764 VSS.n291 VSS.n235 0.267794
R11765 VSS.n291 VSS.n232 0.267794
R11766 VSS.n291 VSS.n231 0.267794
R11767 VSS.n291 VSS.n230 0.267794
R11768 VSS.n291 VSS.n228 0.267794
R11769 VSS.n291 VSS.n227 0.267794
R11770 VSS.n291 VSS.n225 0.267794
R11771 VSS.n291 VSS.n224 0.267794
R11772 VSS.n291 VSS.n222 0.267794
R11773 VSS.n291 VSS.n220 0.267794
R11774 VSS.n291 VSS.n216 0.267794
R11775 VSS.n291 VSS.n215 0.267794
R11776 VSS.n291 VSS.n213 0.267794
R11777 VSS.n291 VSS.n210 0.267794
R11778 VSS.n291 VSS.n209 0.267794
R11779 VSS.n291 VSS.n208 0.267794
R11780 VSS.n291 VSS.n206 0.267794
R11781 VSS.n291 VSS.n204 0.267794
R11782 VSS.n291 VSS.n202 0.267794
R11783 VSS.n291 VSS.n200 0.267794
R11784 VSS.n291 VSS.n199 0.267794
R11785 VSS.n291 VSS.n198 0.267794
R11786 VSS.n291 VSS.n194 0.267794
R11787 VSS.n291 VSS.n504 0.267794
R11788 VSS.n291 VSS.n497 0.267794
R11789 VSS.n291 VSS.n492 0.267794
R11790 VSS.n291 VSS.n472 0.267794
R11791 VSS.n291 VSS.n468 0.267794
R11792 VSS.n291 VSS.n410 0.267794
R11793 VSS.n291 VSS.n400 0.267794
R11794 VSS.n291 VSS.n399 0.267794
R11795 VSS.n291 VSS.n387 0.267794
R11796 VSS.n291 VSS.n374 0.267794
R11797 VSS.n291 VSS.n369 0.267794
R11798 VSS.n291 VSS.n357 0.267794
R11799 VSS.n291 VSS.n349 0.267794
R11800 VSS.n291 VSS.n343 0.267794
R11801 VSS.n291 VSS.n335 0.267794
R11802 VSS.n291 VSS.n334 0.267794
R11803 VSS.n291 VSS.n322 0.267794
R11804 VSS.n291 VSS.n321 0.267794
R11805 VSS.n291 VSS.n308 0.267794
R11806 VSS.n291 VSS.n304 0.267794
R11807 VSS.n291 VSS.n302 0.267794
R11808 VSS.n2979 VSS.n170 0.267794
R11809 VSS.n2982 VSS.n170 0.267794
R11810 VSS.n2985 VSS.n170 0.267794
R11811 VSS.n2988 VSS.n170 0.267794
R11812 VSS.n2995 VSS.n170 0.267794
R11813 VSS.n2999 VSS.n170 0.267794
R11814 VSS.n3009 VSS.n170 0.267794
R11815 VSS.n3013 VSS.n170 0.267794
R11816 VSS.n3023 VSS.n170 0.267794
R11817 VSS.n3024 VSS.n170 0.267794
R11818 VSS.n3027 VSS.n170 0.267794
R11819 VSS.n3030 VSS.n170 0.267794
R11820 VSS.n3037 VSS.n170 0.267794
R11821 VSS.n3051 VSS.n170 0.267794
R11822 VSS.n3055 VSS.n170 0.267794
R11823 VSS.n3065 VSS.n170 0.267794
R11824 VSS.n3066 VSS.n170 0.267794
R11825 VSS.n3069 VSS.n170 0.267794
R11826 VSS.n3072 VSS.n170 0.267794
R11827 VSS.n3079 VSS.n170 0.267794
R11828 VSS.n3083 VSS.n170 0.267794
R11829 VSS.n3086 VSS.n170 0.267794
R11830 VSS.n3093 VSS.n170 0.267794
R11831 VSS.n3094 VSS.n170 0.267794
R11832 VSS.n3097 VSS.n170 0.267794
R11833 VSS.n3100 VSS.n170 0.267794
R11834 VSS.n3107 VSS.n170 0.267794
R11835 VSS.n3108 VSS.n170 0.267794
R11836 VSS.n3111 VSS.n170 0.267794
R11837 VSS.n3114 VSS.n170 0.267794
R11838 VSS.n3122 VSS.n170 0.267794
R11839 VSS.n3128 VSS.n170 0.267794
R11840 VSS.n3136 VSS.n170 0.267794
R11841 VSS.n3142 VSS.n170 0.267794
R11842 VSS.n3149 VSS.n170 0.267794
R11843 VSS.n3150 VSS.n170 0.267794
R11844 VSS.n3153 VSS.n170 0.267794
R11845 VSS.n3156 VSS.n170 0.267794
R11846 VSS.n3163 VSS.n170 0.267794
R11847 VSS.n3164 VSS.n170 0.267794
R11848 VSS.n3167 VSS.n170 0.267794
R11849 VSS.n3170 VSS.n170 0.267794
R11850 VSS.n3177 VSS.n170 0.267794
R11851 VSS.n3178 VSS.n170 0.267794
R11852 VSS.n3181 VSS.n170 0.267794
R11853 VSS.n3184 VSS.n170 0.267794
R11854 VSS.n3192 VSS.n170 0.267794
R11855 VSS.n3198 VSS.n170 0.267794
R11856 VSS.n3195 VSS.n170 0.267794
R11857 VSS.n3191 VSS.n170 0.267794
R11858 VSS.n3139 VSS.n170 0.267794
R11859 VSS.n3135 VSS.n170 0.267794
R11860 VSS.n3125 VSS.n170 0.267794
R11861 VSS.n3121 VSS.n170 0.267794
R11862 VSS.n3080 VSS.n170 0.267794
R11863 VSS.n3058 VSS.n170 0.267794
R11864 VSS.n3052 VSS.n170 0.267794
R11865 VSS.n3044 VSS.n170 0.267794
R11866 VSS.n3041 VSS.n170 0.267794
R11867 VSS.n3038 VSS.n170 0.267794
R11868 VSS.n3016 VSS.n170 0.267794
R11869 VSS.n3010 VSS.n170 0.267794
R11870 VSS.n3002 VSS.n170 0.267794
R11871 VSS.n2996 VSS.n170 0.267794
R11872 VSS.n2970 VSS.n923 0.267794
R11873 VSS.n78 VSS.n164 0.267794
R11874 VSS.n78 VSS.n162 0.267794
R11875 VSS.n78 VSS.n111 0.267794
R11876 VSS.n78 VSS.n159 0.267794
R11877 VSS.n78 VSS.n112 0.267794
R11878 VSS.n78 VSS.n158 0.267794
R11879 VSS.n78 VSS.n156 0.267794
R11880 VSS.n78 VSS.n155 0.267794
R11881 VSS.n78 VSS.n154 0.267794
R11882 VSS.n78 VSS.n113 0.267794
R11883 VSS.n78 VSS.n151 0.267794
R11884 VSS.n78 VSS.n114 0.267794
R11885 VSS.n78 VSS.n150 0.267794
R11886 VSS.n78 VSS.n148 0.267794
R11887 VSS.n78 VSS.n147 0.267794
R11888 VSS.n78 VSS.n146 0.267794
R11889 VSS.n78 VSS.n115 0.267794
R11890 VSS.n78 VSS.n143 0.267794
R11891 VSS.n78 VSS.n116 0.267794
R11892 VSS.n78 VSS.n142 0.267794
R11893 VSS.n78 VSS.n140 0.267794
R11894 VSS.n78 VSS.n139 0.267794
R11895 VSS.n78 VSS.n117 0.267794
R11896 VSS.n78 VSS.n118 0.267794
R11897 VSS.n78 VSS.n136 0.267794
R11898 VSS.n78 VSS.n119 0.267794
R11899 VSS.n78 VSS.n135 0.267794
R11900 VSS.n78 VSS.n133 0.267794
R11901 VSS.n78 VSS.n132 0.267794
R11902 VSS.n78 VSS.n131 0.267794
R11903 VSS.n78 VSS.n120 0.267794
R11904 VSS.n78 VSS.n129 0.267794
R11905 VSS.n78 VSS.n121 0.267794
R11906 VSS.n78 VSS.n128 0.267794
R11907 VSS.n78 VSS.n126 0.267794
R11908 VSS.n78 VSS.n125 0.267794
R11909 VSS.n78 VSS.n124 0.267794
R11910 VSS.n78 VSS.n109 0.267794
R11911 VSS.n78 VSS.n107 0.267794
R11912 VSS.n78 VSS.n106 0.267794
R11913 VSS.n78 VSS.n105 0.267794
R11914 VSS.n78 VSS.n104 0.267794
R11915 VSS.n78 VSS.n103 0.267794
R11916 VSS.n78 VSS.n101 0.267794
R11917 VSS.n78 VSS.n100 0.267794
R11918 VSS.n78 VSS.n99 0.267794
R11919 VSS.n78 VSS.n98 0.267794
R11920 VSS.n78 VSS.n97 0.267794
R11921 VSS.n78 VSS.n96 0.267794
R11922 VSS.n78 VSS.n95 0.267794
R11923 VSS.n78 VSS.n94 0.267794
R11924 VSS.n78 VSS.n93 0.267794
R11925 VSS.n78 VSS.n92 0.267794
R11926 VSS.n78 VSS.n91 0.267794
R11927 VSS.n78 VSS.n90 0.267794
R11928 VSS.n78 VSS.n89 0.267794
R11929 VSS.n78 VSS.n88 0.267794
R11930 VSS.n78 VSS.n87 0.267794
R11931 VSS.n78 VSS.n86 0.267794
R11932 VSS.n78 VSS.n85 0.267794
R11933 VSS.n78 VSS.n84 0.267794
R11934 VSS.n78 VSS.n83 0.267794
R11935 VSS.n78 VSS.n82 0.267794
R11936 VSS.n78 VSS.n81 0.267794
R11937 VSS.n2579 VSS.n2523 0.267794
R11938 VSS.n2579 VSS.n2508 0.267794
R11939 VSS.n2579 VSS.n2491 0.267794
R11940 VSS.n2579 VSS.n2483 0.267794
R11941 VSS.n2579 VSS.n2480 0.267794
R11942 VSS.n2579 VSS.n2470 0.267794
R11943 VSS.n2579 VSS.n2435 0.267794
R11944 VSS.n2579 VSS.n2396 0.267794
R11945 VSS.n2579 VSS.n2393 0.267794
R11946 VSS.n2579 VSS.n2385 0.267794
R11947 VSS.n2579 VSS.n2382 0.267794
R11948 VSS.n2579 VSS.n2379 0.267794
R11949 VSS.n2579 VSS.n2370 0.267794
R11950 VSS.n2579 VSS.n2355 0.267794
R11951 VSS.n2579 VSS.n2352 0.267794
R11952 VSS.n3206 VSS.n170 0.267428
R11953 VSS.n2970 VSS.n2969 0.267428
R11954 VSS.n2970 VSS.n2701 0.267428
R11955 VSS.n2970 VSS.n2962 0.267428
R11956 VSS.n2970 VSS.n2961 0.267428
R11957 VSS.n2970 VSS.n2957 0.267428
R11958 VSS.n2970 VSS.n2956 0.267428
R11959 VSS.n2970 VSS.n2954 0.267428
R11960 VSS.n2970 VSS.n2953 0.267428
R11961 VSS.n2970 VSS.n2949 0.267428
R11962 VSS.n2970 VSS.n2948 0.267428
R11963 VSS.n2970 VSS.n2720 0.267428
R11964 VSS.n2970 VSS.n2945 0.267428
R11965 VSS.n2970 VSS.n2941 0.267428
R11966 VSS.n2970 VSS.n2726 0.267428
R11967 VSS.n2970 VSS.n2939 0.267428
R11968 VSS.n2970 VSS.n2938 0.267428
R11969 VSS.n2970 VSS.n2934 0.267428
R11970 VSS.n2970 VSS.n2933 0.267428
R11971 VSS.n2970 VSS.n2931 0.267428
R11972 VSS.n2970 VSS.n2930 0.267428
R11973 VSS.n2970 VSS.n2926 0.267428
R11974 VSS.n2970 VSS.n2925 0.267428
R11975 VSS.n2970 VSS.n2744 0.267428
R11976 VSS.n2970 VSS.n2747 0.267428
R11977 VSS.n2970 VSS.n2920 0.267428
R11978 VSS.n2970 VSS.n2919 0.267428
R11979 VSS.n2970 VSS.n2917 0.267428
R11980 VSS.n2970 VSS.n2916 0.267428
R11981 VSS.n2970 VSS.n2912 0.267428
R11982 VSS.n2970 VSS.n2911 0.267428
R11983 VSS.n2970 VSS.n2909 0.267428
R11984 VSS.n2970 VSS.n2908 0.267428
R11985 VSS.n2970 VSS.n2904 0.267428
R11986 VSS.n2970 VSS.n2903 0.267428
R11987 VSS.n2970 VSS.n2768 0.267428
R11988 VSS.n2970 VSS.n2771 0.267428
R11989 VSS.n2970 VSS.n2897 0.267428
R11990 VSS.n2970 VSS.n2895 0.267428
R11991 VSS.n2970 VSS.n2893 0.267428
R11992 VSS.n2970 VSS.n2892 0.267428
R11993 VSS.n2970 VSS.n2888 0.267428
R11994 VSS.n2970 VSS.n2887 0.267428
R11995 VSS.n2970 VSS.n2885 0.267428
R11996 VSS.n2970 VSS.n2884 0.267428
R11997 VSS.n2970 VSS.n2880 0.267428
R11998 VSS.n2970 VSS.n2879 0.267428
R11999 VSS.n2970 VSS.n2792 0.267428
R12000 VSS.n2970 VSS.n2795 0.267428
R12001 VSS.n2970 VSS.n2873 0.267428
R12002 VSS.n2970 VSS.n2872 0.267428
R12003 VSS.n2970 VSS.n2870 0.267428
R12004 VSS.n2970 VSS.n2869 0.267428
R12005 VSS.n2970 VSS.n2865 0.267428
R12006 VSS.n2970 VSS.n2864 0.267428
R12007 VSS.n2970 VSS.n2862 0.267428
R12008 VSS.n2970 VSS.n2861 0.267428
R12009 VSS.n2970 VSS.n2857 0.267428
R12010 VSS.n2970 VSS.n2855 0.267428
R12011 VSS.n2970 VSS.n2853 0.267428
R12012 VSS.n2970 VSS.n2818 0.267428
R12013 VSS.n2970 VSS.n2848 0.267428
R12014 VSS.n2970 VSS.n2847 0.267428
R12015 VSS.n2970 VSS.n2845 0.267428
R12016 VSS.n2970 VSS.n2843 0.267428
R12017 VSS.n78 VSS.n122 0.267428
R12018 VSS.n2579 VSS.n2555 0.267428
R12019 VSS.n447 VSS.t247 0.267153
R12020 VSS.n1812 VSS.n1815 0.266315
R12021 VSS.n958 VSS.n944 0.265797
R12022 VSS.t1122 VSS.n1076 0.264468
R12023 VSS.t1206 VSS.n2603 0.264468
R12024 VSS.t523 VSS.n193 0.264294
R12025 VSS.n2544 VSS.t1258 0.264294
R12026 VSS.t179 VSS.n878 0.264294
R12027 VSS.n2594 VSS.n944 0.263915
R12028 VSS.t1548 VSS.n542 0.26243
R12029 VSS.n2240 VSS.t604 0.261997
R12030 VSS.t581 VSS.t579 0.255774
R12031 VSS.t593 VSS.t591 0.255774
R12032 VSS.t604 VSS.t602 0.255774
R12033 VSS.t616 VSS.t614 0.255774
R12034 VSS.t628 VSS.t626 0.255774
R12035 VSS.t829 VSS.t827 0.255774
R12036 VSS.t818 VSS.t816 0.255774
R12037 VSS.t806 VSS.t804 0.255774
R12038 VSS.t794 VSS.t792 0.255774
R12039 VSS.t783 VSS.t781 0.255774
R12040 VSS.t1408 VSS.t882 0.254653
R12041 VSS.t942 VSS.t1204 0.254653
R12042 VSS.t894 VSS.t1959 0.254653
R12043 VSS.t928 VSS.t1298 0.254637
R12044 VSS.t952 VSS.t404 0.254637
R12045 VSS.t954 VSS.n287 0.254083
R12046 VSS.n3220 VSS.n172 0.25394
R12047 VSS.n2698 VSS.n2697 0.25394
R12048 VSS.n2576 VSS.n1058 0.25394
R12049 VSS.t883 VSS.n2160 0.253481
R12050 VSS.n1964 VSS.n1617 0.248324
R12051 VSS.t857 VSS.n447 0.245065
R12052 VSS.t1470 VSS.n2126 0.244247
R12053 VSS.t1010 VSS.n1149 0.244247
R12054 VSS.t1237 VSS.n2733 0.244247
R12055 VSS.t1910 VSS.n2618 0.244247
R12056 VSS.n1799 VSS.n1798 0.24416
R12057 VSS.n2839 VSS.t1766 0.24355
R12058 VSS.n2666 VSS.t67 0.24355
R12059 VSS.t26 VSS.n2159 0.24355
R12060 VSS.n2006 VSS.t9 0.24355
R12061 VSS.n294 VSS.t997 0.242883
R12062 VSS.t1923 VSS.n2601 0.239685
R12063 VSS.t2046 VSS.n1070 0.239685
R12064 VSS.t1834 VSS.n2558 0.239685
R12065 VSS.n1870 VSS.n1785 0.239202
R12066 VSS.n1606 VSS.n1604 0.239006
R12067 VSS.n1892 VSS.n945 0.239006
R12068 VSS.n1897 VSS.n1896 0.239006
R12069 VSS.n1904 VSS.n1903 0.239006
R12070 VSS.n1910 VSS.n1909 0.239006
R12071 VSS.n1929 VSS.n1941 0.239006
R12072 VSS.t961 VSS.n1932 0.239006
R12073 VSS.n1926 VSS.n1944 0.239006
R12074 VSS.n1951 VSS.n1680 0.239006
R12075 VSS.t958 VSS.n1696 0.239006
R12076 VSS.n1691 VSS.n1690 0.239006
R12077 VSS.t957 VSS.n1695 0.239006
R12078 VSS.n1696 VSS.n1686 0.239006
R12079 VSS.n1702 VSS.n1701 0.239006
R12080 VSS.n1924 VSS.t965 0.239006
R12081 VSS.t900 VSS.n947 0.239006
R12082 VSS.n1607 VSS.n1606 0.238668
R12083 VSS.n1896 VSS.n1895 0.238668
R12084 VSS.n1903 VSS.n1902 0.238668
R12085 VSS.n1909 VSS.n1908 0.238668
R12086 VSS.n1911 VSS.n1910 0.238668
R12087 VSS.n1932 VSS.n1935 0.238668
R12088 VSS.n1944 VSS.t963 0.238668
R12089 VSS.n1690 VSS.n1689 0.238668
R12090 VSS.n1695 VSS.n1694 0.238668
R12091 VSS.n1701 VSS.n1700 0.238668
R12092 VSS.n1703 VSS.n1702 0.238668
R12093 VSS.t965 VSS.n1926 0.238668
R12094 VSS.t963 VSS.n1929 0.238668
R12095 VSS.n1686 VSS.t957 0.238668
R12096 VSS.n1684 VSS.t958 0.238668
R12097 VSS.n1680 VSS.t967 0.238668
R12098 VSS.n1604 VSS.t513 0.238668
R12099 VSS.n1827 VSS.n1811 0.238218
R12100 VSS.n3216 VSS.n702 0.237031
R12101 VSS.n2974 VSS.n790 0.236935
R12102 VSS.n1963 VSS.n1667 0.235903
R12103 VSS.n1863 VSS.n1862 0.233757
R12104 VSS.n1861 VSS.n1854 0.233757
R12105 VSS.n1860 VSS.n65 0.233757
R12106 VSS.n1856 VSS.n1855 0.233757
R12107 VSS.n1863 VSS.n58 0.233419
R12108 VSS.n1862 VSS.n1854 0.233419
R12109 VSS.n1861 VSS.n1860 0.233419
R12110 VSS.n1856 VSS.n71 0.233419
R12111 VSS.n1855 VSS.t1578 0.233419
R12112 VSS.t539 VSS.t2226 0.22985
R12113 VSS.t372 VSS.t550 0.22985
R12114 VSS.t1133 VSS.t1079 0.22985
R12115 VSS.t1627 VSS.t1539 0.22985
R12116 VSS.t1966 VSS.t354 0.229653
R12117 VSS.n826 VSS.n825 0.228302
R12118 VSS.n1994 VSS.n1268 0.228174
R12119 VSS.n737 VSS.n736 0.228174
R12120 VSS.n1840 VSS.n1839 0.225674
R12121 VSS.t633 VSS.t631 0.224424
R12122 VSS.t622 VSS.t619 0.224424
R12123 VSS.t610 VSS.t607 0.224424
R12124 VSS.t598 VSS.t596 0.224424
R12125 VSS.t587 VSS.t584 0.224424
R12126 VSS.t575 VSS.t573 0.224424
R12127 VSS.t834 VSS.t832 0.224424
R12128 VSS.t823 VSS.t821 0.224424
R12129 VSS.t812 VSS.t809 0.224424
R12130 VSS.t800 VSS.t797 0.224424
R12131 VSS.t788 VSS.t786 0.224424
R12132 VSS.t777 VSS.t774 0.224424
R12133 VSS.t631 VSS.t120 0.220674
R12134 VSS.t619 VSS.t620 0.220674
R12135 VSS.t607 VSS.t608 0.220674
R12136 VSS.t596 VSS.t556 0.220674
R12137 VSS.t584 VSS.t585 0.220674
R12138 VSS.t573 VSS.t252 0.220674
R12139 VSS.t832 VSS.t424 0.220674
R12140 VSS.t821 VSS.t421 0.220674
R12141 VSS.t809 VSS.t810 0.220674
R12142 VSS.t797 VSS.t798 0.220674
R12143 VSS.t786 VSS.t418 0.220674
R12144 VSS.t774 VSS.t775 0.220674
R12145 VSS.n1839 VSS.n1805 0.219424
R12146 VSS.n656 VSS.n517 0.219405
R12147 VSS.t1592 VSS.n37 0.218237
R12148 VSS.n2318 VSS.n2242 0.217878
R12149 VSS.t37 VSS.n1629 0.211735
R12150 VSS.t247 VSS.t1966 0.207565
R12151 VSS.t1874 VSS.t1133 0.207357
R12152 VSS.t1903 VSS.t1627 0.207357
R12153 VSS.t2226 VSS.t1035 0.207357
R12154 VSS.t2251 VSS.t372 0.207357
R12155 VSS.n1837 VSS.n1790 0.20686
R12156 VSS.n2834 VSS.n926 0.202646
R12157 VSS.n1238 VSS.n1116 0.20231
R12158 VSS.n169 VSS.n2682 0.297117
R12159 VSS.n1571 VSS.t47 0.200486
R12160 VSS.t638 VSS.t635 0.200427
R12161 VSS.t839 VSS.t836 0.200427
R12162 VSS.n1835 VSS.n1667 0.197565
R12163 VSS.n1850 VSS.n40 0.195641
R12164 VSS.n1798 VSS.n40 0.195641
R12165 VSS.n1848 VSS.n1847 0.195641
R12166 VSS.n1848 VSS.n1795 0.195641
R12167 VSS.n1795 VSS.n1794 0.195641
R12168 VSS.n1794 VSS.n1793 0.195641
R12169 VSS.t513 VSS.n1605 0.191235
R12170 VSS.n1238 VSS.n1237 0.191235
R12171 VSS.n1893 VSS.n1892 0.191235
R12172 VSS.n1894 VSS.n1893 0.191235
R12173 VSS.n1895 VSS.n1894 0.191235
R12174 VSS.n1898 VSS.n1897 0.191235
R12175 VSS.n1899 VSS.n1898 0.191235
R12176 VSS.n1900 VSS.n1899 0.191235
R12177 VSS.n1901 VSS.n1900 0.191235
R12178 VSS.n1902 VSS.n1901 0.191235
R12179 VSS.n1905 VSS.n1904 0.191235
R12180 VSS.n1906 VSS.n1905 0.191235
R12181 VSS.n1907 VSS.n1906 0.191235
R12182 VSS.n1908 VSS.n1907 0.191235
R12183 VSS.t906 VSS.n952 0.191235
R12184 VSS.n1940 VSS.t962 0.191235
R12185 VSS.n1941 VSS.n1940 0.191235
R12186 VSS.n1945 VSS.n1924 0.191235
R12187 VSS.n1945 VSS.n1922 0.191235
R12188 VSS.n1922 VSS.t967 0.191235
R12189 VSS.n1689 VSS.t900 0.191235
R12190 VSS.n1692 VSS.n1691 0.191235
R12191 VSS.n1693 VSS.n1692 0.191235
R12192 VSS.n1694 VSS.n1693 0.191235
R12193 VSS.n1698 VSS.n1684 0.191235
R12194 VSS.n1699 VSS.n1698 0.191235
R12195 VSS.n1700 VSS.n1699 0.191235
R12196 VSS.n1822 VSS.n5 0.191235
R12197 VSS.n2834 VSS.n2833 0.191235
R12198 VSS.n2672 VSS.n169 0.23732
R12199 VSS.t960 VSS.t906 0.191235
R12200 VSS.n1935 VSS.t960 0.191235
R12201 VSS.t962 VSS.t961 0.191235
R12202 VSS.n2593 VSS.n945 0.1908
R12203 VSS.t923 VSS.t925 0.1875
R12204 VSS.t938 VSS.t935 0.1875
R12205 VSS.t875 VSS.t878 0.1875
R12206 VSS.t887 VSS.t890 0.1875
R12207 VSS.t920 VSS.t917 0.1875
R12208 VSS.t914 VSS.t911 0.1875
R12209 VSS.t947 VSS.t949 0.1875
R12210 VSS.n1866 VSS.n53 0.187025
R12211 VSS.n1865 VSS.n53 0.187025
R12212 VSS.n1865 VSS.n1864 0.187025
R12213 VSS.n1864 VSS.n58 0.187025
R12214 VSS.n1858 VSS.n65 0.187025
R12215 VSS.n1858 VSS.n1857 0.187025
R12216 VSS.n1857 VSS.n71 0.187025
R12217 VSS.n1787 VSS.n1666 0.185168
R12218 VSS.n1668 VSS.n1663 0.181924
R12219 VSS.n1962 VSS.n1673 0.181924
R12220 VSS.n2002 VSS.n1372 0.181075
R12221 VSS.n3216 VSS.n758 0.181075
R12222 VSS.n2974 VSS.n847 0.181048
R12223 VSS.t273 VSS.n2240 0.180216
R12224 VSS.t638 VSS.t640 0.176255
R12225 VSS.t839 VSS.t841 0.176255
R12226 VSS.n3216 VSS.n720 0.176035
R12227 VSS.n2974 VSS.n808 0.176001
R12228 VSS.n1998 VSS.t1576 0.174608
R12229 VSS.n2974 VSS.t43 0.173503
R12230 VSS.n3216 VSS.t508 0.17341
R12231 VSS.t49 VSS.n1571 0.172075
R12232 VSS.t898 VSS.n956 0.167615
R12233 VSS.n1847 VSS.n1846 0.167615
R12234 VSS.n1669 VSS.n1663 0.164424
R12235 VSS.n1670 VSS.n1962 0.164424
R12236 VSS.n2579 VSS.n2572 0.16137
R12237 VSS.n2579 VSS.n2563 0.16137
R12238 VSS.n2579 VSS.n2559 0.16137
R12239 VSS.n2970 VSS.n941 0.160396
R12240 VSS.n2970 VSS.n933 0.160396
R12241 VSS.n2970 VSS.n928 0.160396
R12242 VSS.n10 VSS.n2592 0.160336
R12243 VSS.n955 VSS.n947 0.15955
R12244 VSS.t1594 VSS.n1867 0.158174
R12245 VSS.n1844 VSS.n1843 0.156138
R12246 VSS.t665 VSS.n1268 0.154424
R12247 VSS.t100 VSS.n737 0.154424
R12248 VSS.t709 VSS.n826 0.154293
R12249 VSS.n2596 VSS.n943 0.150687
R12250 VSS.n1998 VSS.t1566 0.150099
R12251 VSS.t1582 VSS.n37 0.149502
R12252 VSS.n1851 VSS.n1850 0.146675
R12253 VSS.n2002 VSS.t680 0.142519
R12254 VSS.n1237 VSS.n1236 0.142513
R12255 VSS.n2833 VSS.n2832 0.142513
R12256 VSS.n3216 VSS.t766 0.14245
R12257 VSS.n1617 VSS.n1665 0.142012
R12258 VSS.n1998 VSS.t1570 0.139355
R12259 VSS.n2682 VSS.n2671 0.139294
R12260 VSS.t897 VSS.n1116 0.139294
R12261 VSS.n1845 VSS.n1799 0.139253
R12262 VSS.t932 VSS.n926 0.138956
R12263 VSS.t1586 VSS.n37 0.138705
R12264 VSS.n1669 VSS.n1665 0.138262
R12265 VSS.n3220 VSS.n3219 0.138073
R12266 VSS.n2697 VSS.n2600 0.138073
R12267 VSS.n2699 VSS.n2599 0.138073
R12268 VSS.n2586 VSS.n1058 0.138073
R12269 VSS.t1766 VSS.t926 0.135868
R12270 VSS.t67 VSS.t939 0.135868
R12271 VSS.t26 VSS.t879 0.135868
R12272 VSS.t9 VSS.t891 0.135868
R12273 VSS.t997 VSS.t950 0.135868
R12274 VSS.t1438 VSS.n2776 0.133368
R12275 VSS.t1480 VSS.n2686 0.133368
R12276 VSS.t241 VSS.n1186 0.133368
R12277 VSS.t1701 VSS.n384 0.133368
R12278 VSS.n1835 VSS.n1666 0.126532
R12279 VSS.n31 VSS.n1057 0.124938
R12280 VSS.n31 VSS.n965 0.124938
R12281 VSS.t952 VSS.n286 0.124618
R12282 VSS.t882 VSS.n2345 0.124618
R12283 VSS.t894 VSS.n1114 0.124618
R12284 VSS.t928 VSS.n924 0.124618
R12285 VSS.n2668 VSS.t942 0.124618
R12286 VSS.n2344 VSS.t879 0.122118
R12287 VSS.t953 VSS.n286 0.122118
R12288 VSS.t950 VSS.n293 0.122118
R12289 VSS.n2345 VSS.t881 0.122118
R12290 VSS.t891 VSS.n1234 0.122118
R12291 VSS.t893 VSS.n1114 0.122118
R12292 VSS.t929 VSS.n924 0.122118
R12293 VSS.t926 VSS.n2829 0.122118
R12294 VSS.t939 VSS.n2667 0.122118
R12295 VSS.t941 VSS.n2668 0.122118
R12296 VSS.n2166 VSS.t410 0.117118
R12297 VSS.n218 VSS.n217 0.117118
R12298 VSS.n249 VSS.n248 0.117118
R12299 VSS.n276 VSS.n275 0.117118
R12300 VSS.t1006 VSS.n318 0.117118
R12301 VSS.n2495 VSS.n2494 0.117118
R12302 VSS.n2434 VSS.n2433 0.117118
R12303 VSS.n2374 VSS.n2369 0.117118
R12304 VSS.t1839 VSS.n1221 0.117118
R12305 VSS.n1086 VSS.n1085 0.117118
R12306 VSS.n1098 VSS.n1097 0.117118
R12307 VSS.n1110 VSS.n1109 0.117118
R12308 VSS.n890 VSS.n889 0.117118
R12309 VSS.n904 VSS.n903 0.117118
R12310 VSS.n918 VSS.n917 0.117118
R12311 VSS.t846 VSS.n2815 0.117118
R12312 VSS.t79 VSS.n2685 0.117118
R12313 VSS.n2619 VSS.n2677 0.117118
R12314 VSS.n2639 VSS.n2679 0.117118
R12315 VSS.n2659 VSS.n2681 0.117118
R12316 VSS.n1963 VSS.t903 0.1171
R12317 VSS.n1793 VSS.n1792 0.115978
R12318 VSS.n31 VSS.n1015 0.114601
R12319 VSS.n2974 VSS.t694 0.112457
R12320 VSS.n3216 VSS.t737 0.112451
R12321 VSS.n954 VSS.n952 0.112118
R12322 VSS.n1788 VSS.n1787 0.111556
R12323 VSS.t895 VSS.n1236 0.109642
R12324 VSS.t930 VSS.n2832 0.109642
R12325 VSS.t943 VSS.n2672 0.109642
R12326 VSS.n2974 VSS.n827 0.107948
R12327 VSS.t636 VSS.n2202 0.105868
R12328 VSS.t837 VSS.n578 0.105868
R12329 VSS.n1673 VSS.n1672 0.104618
R12330 VSS.n1668 VSS.n1659 0.104618
R12331 VSS.n31 VSS.t650 0.0993007
R12332 VSS.t915 VSS.n1809 0.0971176
R12333 VSS.n1844 VSS.n5 0.0971176
R12334 VSS.n1843 VSS.n1842 0.0958002
R12335 VSS.n1842 VSS.n1841 0.0955
R12336 VSS.n1811 VSS.n1813 0.093
R12337 VSS.t207 VSS.n927 0.0928744
R12338 VSS.t2136 VSS.n289 0.0928744
R12339 VSS.t945 VSS.n189 0.08925
R12340 VSS.t873 VSS.n2556 0.08925
R12341 VSS.t885 VSS.n1073 0.08925
R12342 VSS.t921 VSS.n875 0.08925
R12343 VSS.n2694 VSS.t933 0.08925
R12344 VSS.t125 VSS.n2691 0.08925
R12345 VSS.n2578 VSS.t330 0.08925
R12346 VSS.t203 VSS.n1119 0.08925
R12347 VSS.t1072 VSS.n2166 0.0883676
R12348 VSS.n384 VSS.t333 0.0883676
R12349 VSS.n318 VSS.t1877 0.0883676
R12350 VSS.t2007 VSS.n1186 0.0883676
R12351 VSS.t2004 VSS.n1221 0.0883676
R12352 VSS.t2109 VSS.n2776 0.0883676
R12353 VSS.t2243 VSS.n2815 0.0883676
R12354 VSS.n2686 VSS.t1653 0.0883676
R12355 VSS.n2685 VSS.t1908 0.0883676
R12356 VSS.t635 VSS.n2202 0.0858676
R12357 VSS.n578 VSS.t836 0.0858676
R12358 VSS.t875 VSS.n2550 0.0851154
R12359 VSS.t878 VSS.n2551 0.0851154
R12360 VSS.n2075 VSS.t887 0.0851154
R12361 VSS.t890 VSS.n1123 0.0851154
R12362 VSS.n1826 VSS.t917 0.0851154
R12363 VSS.n1824 VSS.t920 0.0851154
R12364 VSS.n1830 VSS.t911 0.0851154
R12365 VSS.n1828 VSS.t914 0.0851154
R12366 VSS.n2967 VSS.t923 0.0851154
R12367 VSS.t925 VSS.n2704 0.0851154
R12368 VSS.n2689 VSS.t935 0.0851154
R12369 VSS.n2688 VSS.t938 0.0851154
R12370 VSS.n502 VSS.t947 0.0851154
R12371 VSS.t949 VSS.n501 0.0851154
R12372 VSS.n1958 VSS.n1957 0.08425
R12373 VSS.n1676 VSS.n1653 0.08425
R12374 VSS.n2974 VSS.t722 0.0833907
R12375 VSS.n1831 VSS.n1830 0.08175
R12376 VSS.n1810 VSS.n1826 0.08175
R12377 VSS.n1816 VSS.n1817 0.08175
R12378 VSS.n1806 VSS.n1807 0.08175
R12379 VSS.t883 VSS.n2161 0.0805
R12380 VSS.t954 VSS.n290 0.0805
R12381 VSS.n2001 VSS.n1235 0.0805
R12382 VSS.n1787 VSS.n1671 0.0805
R12383 VSS.n2835 VSS.n2830 0.0805
R12384 VSS.n2669 VSS.n2684 0.0805
R12385 VSS.n959 VSS.n954 0.0796176
R12386 VSS.n955 VSS.n946 0.0796176
R12387 VSS.t1331 VSS.n218 0.0771176
R12388 VSS.t1461 VSS.n249 0.0771176
R12389 VSS.t2126 VSS.n276 0.0771176
R12390 VSS.n2495 VSS.t142 0.0771176
R12391 VSS.n2434 VSS.t1054 0.0771176
R12392 VSS.n2369 VSS.t89 0.0771176
R12393 VSS.t506 VSS.n1086 0.0771176
R12394 VSS.t3 VSS.n1098 0.0771176
R12395 VSS.t570 VSS.n1110 0.0771176
R12396 VSS.t897 VSS.n1115 0.0771176
R12397 VSS.t392 VSS.n890 0.0771176
R12398 VSS.t165 VSS.n904 0.0771176
R12399 VSS.t2072 VSS.n918 0.0771176
R12400 VSS.t932 VSS.n925 0.0771176
R12401 VSS.t20 VSS.n2619 0.0771176
R12402 VSS.t512 VSS.n2639 0.0771176
R12403 VSS.t1309 VSS.n2659 0.0771176
R12404 VSS.n2671 VSS.n2670 0.0771176
R12405 VSS.n959 VSS.n958 0.0758676
R12406 VSS.n2587 VSS.n946 0.0758676
R12407 VSS.n2550 VSS.n2114 0.0746176
R12408 VSS.n499 VSS.n190 0.0746176
R12409 VSS.n503 VSS.n502 0.0746176
R12410 VSS.n2554 VSS.n2553 0.0746176
R12411 VSS.n2076 VSS.n2075 0.0746176
R12412 VSS.n2073 VSS.n1074 0.0746176
R12413 VSS.n2965 VSS.n876 0.0746176
R12414 VSS.n2968 VSS.n2967 0.0746176
R12415 VSS.n2690 VSS.n2689 0.0746176
R12416 VSS.n2675 VSS.n2602 0.0746176
R12417 VSS.n1869 VSS.n1789 0.07425
R12418 VSS.n1670 VSS.n1671 0.07425
R12419 VSS.n1832 VSS.n1821 0.0740901
R12420 VSS.n1819 VSS.t909 0.0740901
R12421 VSS.n1789 VSS.t2296 0.07175
R12422 VSS.t893 VSS.n1115 0.0696176
R12423 VSS.t929 VSS.n925 0.0696176
R12424 VSS.n2670 VSS.t941 0.0696176
R12425 VSS.n2550 VSS.t1976 0.06925
R12426 VSS.n2206 VSS.t636 0.06925
R12427 VSS.t624 VSS.n2217 0.06925
R12428 VSS.t612 VSS.n2233 0.06925
R12429 VSS.t600 VSS.n2260 0.06925
R12430 VSS.t589 VSS.n2276 0.06925
R12431 VSS.t577 VSS.n2292 0.06925
R12432 VSS.n499 VSS.n191 0.06925
R12433 VSS.n502 VSS.t2167 0.06925
R12434 VSS.n579 VSS.t837 0.06925
R12435 VSS.n592 VSS.t825 0.06925
R12436 VSS.n605 VSS.t814 0.06925
R12437 VSS.n627 VSS.t802 0.06925
R12438 VSS.n640 VSS.t790 0.06925
R12439 VSS.n654 VSS.t779 0.06925
R12440 VSS.n2553 VSS.n2548 0.06925
R12441 VSS.n2075 VSS.t2346 0.06925
R12442 VSS.n2073 VSS.n1075 0.06925
R12443 VSS.n1959 VSS.n1958 0.06925
R12444 VSS.n1675 VSS.n1653 0.06925
R12445 VSS.n2965 VSS.n877 0.06925
R12446 VSS.n2967 VSS.t209 0.06925
R12447 VSS.n2689 VSS.t2075 0.06925
R12448 VSS.n2673 VSS.n2675 0.06925
R12449 VSS.n1829 VSS.n1828 0.0671176
R12450 VSS.n1825 VSS.n1824 0.0671176
R12451 VSS.n1815 VSS.n1814 0.0671176
R12452 VSS.n1805 VSS.n1804 0.0671176
R12453 VSS.n1830 VSS.n1829 0.0621177
R12454 VSS.n1826 VSS.n1825 0.0621177
R12455 VSS.n1814 VSS.n1816 0.0621177
R12456 VSS.n1804 VSS.n1806 0.0621177
R12457 VSS.n2002 VSS.t672 0.0608542
R12458 VSS.n3216 VSS.t758 0.060853
R12459 VSS.n500 VSS.n191 0.05925
R12460 VSS.n2552 VSS.n2548 0.05925
R12461 VSS.n2074 VSS.n1075 0.05925
R12462 VSS.n2966 VSS.n877 0.05925
R12463 VSS.n2674 VSS.n2673 0.05925
R12464 VSS.n2704 VSS.t209 0.05925
R12465 VSS.t2075 VSS.n2688 0.05925
R12466 VSS.n2551 VSS.t1976 0.05925
R12467 VSS.n1123 VSS.t2346 0.05925
R12468 VSS.n501 VSS.t2167 0.05925
R12469 VSS.n1809 VSS.t534 0.0571176
R12470 VSS.t1579 VSS.n1851 0.0567791
R12471 VSS.t330 VSS.n2114 0.0546176
R12472 VSS.t945 VSS.n190 0.0546176
R12473 VSS.n503 VSS.t2136 0.0546176
R12474 VSS.t873 VSS.n2554 0.0546176
R12475 VSS.n2076 VSS.t203 0.0546176
R12476 VSS.t885 VSS.n1074 0.0546176
R12477 VSS.t921 VSS.n876 0.0546176
R12478 VSS.n2968 VSS.t207 0.0546176
R12479 VSS.t125 VSS.n2690 0.0546176
R12480 VSS.t933 VSS.n2602 0.0546176
R12481 VSS.t633 VSS.n2206 0.05175
R12482 VSS.t622 VSS.n2217 0.05175
R12483 VSS.t610 VSS.n2233 0.05175
R12484 VSS.t598 VSS.n2260 0.05175
R12485 VSS.t575 VSS.n2292 0.05175
R12486 VSS.t834 VSS.n579 0.05175
R12487 VSS.t823 VSS.n592 0.05175
R12488 VSS.t812 VSS.n605 0.05175
R12489 VSS.t800 VSS.n627 0.05175
R12490 VSS.t777 VSS.n654 0.05175
R12491 VSS.n1672 VSS.n1961 0.0496177
R12492 VSS.n1674 VSS.n1659 0.0496177
R12493 VSS.n1813 VSS.n1808 0.04925
R12494 VSS.n1808 VSS.n1810 0.04675
R12495 VSS.n1807 VSS.t915 0.04675
R12496 VSS.n0 VSS.n3 0.0161289
R12497 VSS.t2296 VSS.n1788 0.0353056
R12498 VSS.t587 VSS.n2307 0.03425
R12499 VSS.t788 VSS.n641 0.03425
R12500 VSS.n1820 VSS.n1831 0.0305
R12501 VSS.n1817 VSS.n1838 0.0305
R12502 VSS.n1240 VSS.t895 0.02925
R12503 VSS.n2836 VSS.t930 0.02925
R12504 VSS.n2683 VSS.t943 0.02925
R12505 VSS.n2594 VSS.n2593 0.028
R12506 VSS.n31 VSS.n1047 0.0254395
R12507 VSS.n1836 VSS.n1819 0.0253401
R12508 VSS.n1833 VSS.n1832 0.0253401
R12509 VSS.n574 VSS.n573 0.023135
R12510 VSS.n681 VSS.n517 0.023135
R12511 VSS.n673 VSS.n517 0.023135
R12512 VSS.n669 VSS.n517 0.023135
R12513 VSS.n663 VSS.n517 0.023135
R12514 VSS.n651 VSS.n520 0.023135
R12515 VSS.n644 VSS.n525 0.023135
R12516 VSS.n646 VSS.n525 0.023135
R12517 VSS.n637 VSS.n529 0.023135
R12518 VSS.n630 VSS.n534 0.023135
R12519 VSS.n632 VSS.n534 0.023135
R12520 VSS.n624 VSS.n538 0.023135
R12521 VSS.n608 VSS.n542 0.023135
R12522 VSS.n610 VSS.n542 0.023135
R12523 VSS.n613 VSS.n542 0.023135
R12524 VSS.n618 VSS.n542 0.023135
R12525 VSS.n602 VSS.n546 0.023135
R12526 VSS.n595 VSS.n551 0.023135
R12527 VSS.n597 VSS.n551 0.023135
R12528 VSS.n589 VSS.n555 0.023135
R12529 VSS.n582 VSS.n560 0.023135
R12530 VSS.n584 VSS.n560 0.023135
R12531 VSS.n575 VSS.n564 0.023135
R12532 VSS.n574 VSS.n571 0.023135
R12533 VSS.n2344 VSS.n2161 0.02175
R12534 VSS.n293 VSS.n290 0.02175
R12535 VSS.n1234 VSS.n1235 0.02175
R12536 VSS.n2829 VSS.n2830 0.02175
R12537 VSS.n2667 VSS.n2669 0.02175
R12538 VSS.n1846 VSS.n1845 0.0214413
R12539 VSS.n2307 VSS.n2276 0.018
R12540 VSS.n641 VSS.n640 0.018
R12541 VSS.t37 VSS.n1626 0.0173993
R12542 VSS.n1821 VSS.n1820 0.01675
R12543 VSS.n1838 VSS.t909 0.01675
R12544 VSS.n2579 VSS.n2573 0.0166972
R12545 VSS.n2579 VSS.n2568 0.0166972
R12546 VSS.n2341 VSS.n2200 0.0165968
R12547 VSS.n2583 VSS.n2099 0.0165968
R12548 VSS.n2302 VSS.n2296 0.0165968
R12549 VSS.n2305 VSS.n2290 0.0165968
R12550 VSS.n2305 VSS.n2289 0.0165968
R12551 VSS.n2309 VSS.n2280 0.0165968
R12552 VSS.n2312 VSS.n2274 0.0165968
R12553 VSS.n2312 VSS.n2273 0.0165968
R12554 VSS.n2315 VSS.n2264 0.0165968
R12555 VSS.n2318 VSS.n2258 0.0165968
R12556 VSS.n2318 VSS.n2257 0.0165968
R12557 VSS.n2318 VSS.n2256 0.0165968
R12558 VSS.n2318 VSS.n2252 0.0165968
R12559 VSS.n2321 VSS.n2237 0.0165968
R12560 VSS.n2324 VSS.n2231 0.0165968
R12561 VSS.n2324 VSS.n2230 0.0165968
R12562 VSS.n2327 VSS.n2221 0.0165968
R12563 VSS.n2330 VSS.n2215 0.0165968
R12564 VSS.n2330 VSS.n2214 0.0165968
R12565 VSS.n2334 VSS.n2333 0.0165968
R12566 VSS.n2339 VSS.n2200 0.0165968
R12567 VSS.n2974 VSS.n788 0.0165968
R12568 VSS.n2974 VSS.n795 0.0165968
R12569 VSS.n2974 VSS.n797 0.0165968
R12570 VSS.n2974 VSS.n804 0.0165968
R12571 VSS.n2974 VSS.n806 0.0165968
R12572 VSS.n2974 VSS.n813 0.0165968
R12573 VSS.n2974 VSS.n815 0.0165968
R12574 VSS.n2974 VSS.n818 0.0165968
R12575 VSS.n2974 VSS.n823 0.0165968
R12576 VSS.n2974 VSS.n832 0.0165968
R12577 VSS.n2974 VSS.n834 0.0165968
R12578 VSS.n2974 VSS.n840 0.0165968
R12579 VSS.n2974 VSS.n842 0.0165968
R12580 VSS.n2974 VSS.n851 0.0165968
R12581 VSS.n2974 VSS.n849 0.0165968
R12582 VSS.n31 VSS.n980 0.0165968
R12583 VSS.n31 VSS.n982 0.0165968
R12584 VSS.n3216 VSS.n700 0.0165968
R12585 VSS.n3216 VSS.n707 0.0165968
R12586 VSS.n3216 VSS.n709 0.0165968
R12587 VSS.n3216 VSS.n716 0.0165968
R12588 VSS.n3216 VSS.n718 0.0165968
R12589 VSS.n3216 VSS.n725 0.0165968
R12590 VSS.n3216 VSS.n727 0.0165968
R12591 VSS.n3216 VSS.n730 0.0165968
R12592 VSS.n3216 VSS.n735 0.0165968
R12593 VSS.n3216 VSS.n743 0.0165968
R12594 VSS.n3216 VSS.n745 0.0165968
R12595 VSS.n3216 VSS.n751 0.0165968
R12596 VSS.n3216 VSS.n753 0.0165968
R12597 VSS.n3216 VSS.n762 0.0165968
R12598 VSS.n3216 VSS.n760 0.0165968
R12599 VSS.n2970 VSS.n942 0.0165542
R12600 VSS.n2970 VSS.n937 0.0165542
R12601 VSS.n2001 VSS.n1240 0.0155
R12602 VSS.n2836 VSS.n2835 0.0155
R12603 VSS.n2684 VSS.n2683 0.0155
R12604 VSS.t37 VSS.n1622 0.0150892
R12605 VSS.n1841 VSS.n1840 0.013
R12606 VSS.n2579 VSS.n2196 0.00962826
R12607 VSS.n2579 VSS.n2188 0.00962826
R12608 VSS.n2579 VSS.n2176 0.00962826
R12609 VSS.n3141 VSS.n170 0.00962826
R12610 VSS.n291 VSS.n480 0.00938635
R12611 VSS.n291 VSS.n466 0.00938635
R12612 VSS.n291 VSS.n432 0.00938635
R12613 VSS.n291 VSS.n408 0.00938635
R12614 VSS.n291 VSS.n344 0.00938635
R12615 VSS.n3205 VSS.n170 0.00938635
R12616 VSS.n2970 VSS.n2964 0.00938635
R12617 VSS.n2970 VSS.n2946 0.00938635
R12618 VSS.n2970 VSS.n2901 0.00938635
R12619 VSS.n2970 VSS.n2877 0.00938635
R12620 VSS.n2970 VSS.n2852 0.00938635
R12621 VSS.n2970 VSS.n2844 0.00938635
R12622 VSS.n2970 VSS.n913 0.00938635
R12623 VSS.n2970 VSS.n906 0.00938635
R12624 VSS.n2970 VSS.n897 0.00938635
R12625 VSS.n2970 VSS.n894 0.00938635
R12626 VSS.n2970 VSS.n887 0.00938635
R12627 VSS.n2970 VSS.n880 0.00938635
R12628 VSS.n78 VSS.n110 0.00938635
R12629 VSS.n291 VSS.n285 0.00938222
R12630 VSS.n2579 VSS.n2117 0.00937856
R12631 VSS.n2579 VSS.n2137 0.00937856
R12632 VSS.n2579 VSS.n2144 0.00937856
R12633 VSS.n2579 VSS.n2148 0.00937856
R12634 VSS.n2579 VSS.n2150 0.00937856
R12635 VSS.n2579 VSS.n2154 0.00937856
R12636 VSS.n2579 VSS.n2157 0.00937856
R12637 VSS.n2579 VSS.n2163 0.00937856
R12638 VSS.n291 VSS.n279 0.00937856
R12639 VSS.n291 VSS.n272 0.00937856
R12640 VSS.n291 VSS.n264 0.00937856
R12641 VSS.n291 VSS.n252 0.00937856
R12642 VSS.n291 VSS.n244 0.00937856
R12643 VSS.n291 VSS.n234 0.00937856
R12644 VSS.n291 VSS.n221 0.00937856
R12645 VSS.n291 VSS.n212 0.00937856
R12646 VSS.n291 VSS.n196 0.00937856
R12647 VSS.n291 VSS.n192 0.00937856
R12648 VSS.n3001 VSS.n170 0.00937856
R12649 VSS.n3043 VSS.n170 0.00937856
R12650 VSS.n3197 VSS.n170 0.00937856
R12651 VSS.n3127 VSS.n170 0.00937856
R12652 VSS.n2970 VSS.n2714 0.00937856
R12653 VSS.n2970 VSS.n2738 0.00937856
R12654 VSS.n2970 VSS.n2762 0.00937856
R12655 VSS.n2970 VSS.n2786 0.00937856
R12656 VSS.n2970 VSS.n2810 0.00937856
R12657 VSS.n78 VSS.n161 0.00937856
R12658 VSS.n78 VSS.n153 0.00937856
R12659 VSS.n78 VSS.n145 0.00937856
R12660 VSS.n78 VSS.n138 0.00937856
R12661 VSS.n2579 VSS.n2129 0.00937856
R12662 VSS.n2579 VSS.n2132 0.00937856
R12663 VSS.n291 VSS.n284 0.00937856
R12664 VSS.n291 VSS.n258 0.00937856
R12665 VSS.n2981 VSS.n170 0.00937856
R12666 VSS.n2987 VSS.n170 0.00937856
R12667 VSS.n3015 VSS.n170 0.00937856
R12668 VSS.n3029 VSS.n170 0.00937856
R12669 VSS.n3057 VSS.n170 0.00937856
R12670 VSS.n3071 VSS.n170 0.00937856
R12671 VSS.n3099 VSS.n170 0.00937856
R12672 VSS.n3155 VSS.n170 0.00937856
R12673 VSS.n3169 VSS.n170 0.00937856
R12674 VSS.n3183 VSS.n170 0.00937856
R12675 VSS.n3113 VSS.n170 0.00937856
R12676 VSS.n3085 VSS.n170 0.00937856
R12677 VSS.n2970 VSS.n922 0.00937856
R12678 VSS.n78 VSS.n163 0.00937856
R12679 VSS.n78 VSS.n160 0.00937856
R12680 VSS.n78 VSS.n157 0.00937856
R12681 VSS.n78 VSS.n152 0.00937856
R12682 VSS.n78 VSS.n149 0.00937856
R12683 VSS.n78 VSS.n144 0.00937856
R12684 VSS.n78 VSS.n141 0.00937856
R12685 VSS.n78 VSS.n137 0.00937856
R12686 VSS.n78 VSS.n134 0.00937856
R12687 VSS.n78 VSS.n130 0.00937856
R12688 VSS.n78 VSS.n127 0.00937856
R12689 VSS.n78 VSS.n108 0.00937856
R12690 VSS.n78 VSS.n102 0.00937856
R12691 VSS.n2579 VSS.n2547 0.00937856
R12692 VSS.n2579 VSS.n2518 0.00937856
R12693 VSS.n2579 VSS.n2505 0.00937856
R12694 VSS.n2579 VSS.n2454 0.00937856
R12695 VSS.n2579 VSS.n2417 0.00937856
R12696 VSS.n2578 VSS.t1834 0.00675
R12697 VSS.n189 VSS.n171 0.00675
R12698 VSS.n2574 VSS.n2556 0.00675
R12699 VSS.n1119 VSS.t2046 0.00675
R12700 VSS.n1118 VSS.n1073 0.00675
R12701 VSS.n2597 VSS.n875 0.00675
R12702 VSS.n2691 VSS.t1923 0.00675
R12703 VSS.n2695 VSS.n2694 0.00675
R12704 VSS.n289 VSS.t1166 0.00412443
R12705 VSS.t134 VSS.n927 0.00412443
R12706 VSS.n0 VSS.n9 0.00296307
R12707 VSS.n168 VSS.n169 4.1957
R12708 VSS.n39 VSS.n37 0.00566376
R12709 VSS.n1859 VSS.n67 0.00495229
R12710 VSS.n24 VSS.n1697 0.00495229
R12711 VSS.n15 VSS.n1688 0.00495229
R12712 VSS.n33 VSS.n34 0.00299994
R12713 VSS.n12 VSS.n13 0.00299994
R12714 VSS.n47 VSS.n49 0.0023258
R12715 VSS.n44 VSS.n43 0.00224999
R12716 VSS.n0 VSS.n7 0.00186142
R12717 VSS.n682 VSS.n517 0.00181696
R12718 VSS.n677 VSS.n517 0.00181696
R12719 VSS.n660 VSS.n518 0.00181696
R12720 VSS.n653 VSS.n523 0.00181696
R12721 VSS.n653 VSS.n524 0.00181696
R12722 VSS.n649 VSS.n527 0.00181696
R12723 VSS.n639 VSS.n532 0.00181696
R12724 VSS.n639 VSS.n533 0.00181696
R12725 VSS.n635 VSS.n536 0.00181696
R12726 VSS.n626 VSS.n540 0.00181696
R12727 VSS.n626 VSS.n541 0.00181696
R12728 VSS.n621 VSS.n544 0.00181696
R12729 VSS.n604 VSS.n549 0.00181696
R12730 VSS.n604 VSS.n550 0.00181696
R12731 VSS.n600 VSS.n553 0.00181696
R12732 VSS.n591 VSS.n558 0.00181696
R12733 VSS.n591 VSS.n559 0.00181696
R12734 VSS.n587 VSS.n562 0.00181696
R12735 VSS.n577 VSS.n566 0.00181696
R12736 VSS.n577 VSS.n568 0.00179957
R12737 VSS.n1705 VSS.n1678 0.00175
R12738 VSS.n33 VSS.n32 0.00149995
R12739 VSS.n1938 VSS.n1713 0.00166667
R12740 VSS.n1943 VSS.n1918 0.00166667
R12741 VSS.n1927 VSS.n1708 0.00166667
R12742 VSS.n1923 VSS.n1920 0.00166667
R12743 VSS.n1706 VSS.n1678 0.00166667
R12744 VSS.n1724 VSS.n948 0.00166667
R12745 VSS.n1886 VSS.n1727 0.00166667
R12746 VSS.n1879 VSS.n1718 0.00166667
R12747 VSS.n1873 VSS.n1715 0.00166667
R12748 VSS.n12 VSS.n11 0.00149995
R12749 VSS.n20 VSS.n19 0.00169993
R12750 VSS.n22 VSS.n21 0.00169993
R12751 VSS.n30 VSS.n28 0.00169993
R12752 VSS.n1965 VSS.n1632 0.00166667
R12753 VSS.n36 VSS.n35 0.00169993
R12754 VSS.n1609 VSS.n1243 0.00166667
R12755 VSS.n2002 VSS.n1244 0.00166667
R12756 VSS.n1796 VSS.n1791 0.00166667
R12757 VSS.n62 VSS.n60 0.00169993
R12758 VSS.n64 VSS.n63 0.00169993
R12759 VSS.n75 VSS.n73 0.00169993
R12760 VSS.n1998 VSS.n1475 0.00166667
R12761 VSS.n1913 VSS.n1785 0.00162501
R12762 VSS.n1966 VSS.n1631 0.00152382
R12763 VSS.n166 VSS.n165 0.00214264
R12764 VSS.n39 VSS.n38 0.002
R12765 VSS.n78 VSS.n77 0.00125
R12766 VSS.n2970 VSS.n166 0.0015
R12767 VSS.n77 VSS.n76 0.0015
R12768 VSS.n75 VSS.n74 0.0015
R12769 VSS.n1859 VSS.n63 0.0015
R12770 VSS.n62 VSS.n61 0.0015
R12771 VSS.n48 VSS.n47 0.0015
R12772 VSS.n2300 VSS.n2297 0.00148755
R12773 VSS.n2294 VSS.n2291 0.00148755
R12774 VSS.n2293 VSS.n2291 0.00148755
R12775 VSS.n2286 VSS.n2281 0.00148755
R12776 VSS.n2278 VSS.n2275 0.00148755
R12777 VSS.n2277 VSS.n2275 0.00148755
R12778 VSS.n2270 VSS.n2265 0.00148755
R12779 VSS.n2262 VSS.n2259 0.00148755
R12780 VSS.n2261 VSS.n2259 0.00148755
R12781 VSS.n2248 VSS.n2238 0.00148755
R12782 VSS.n2235 VSS.n2232 0.00148755
R12783 VSS.n2234 VSS.n2232 0.00148755
R12784 VSS.n2227 VSS.n2222 0.00148755
R12785 VSS.n2219 VSS.n2216 0.00148755
R12786 VSS.n2218 VSS.n2216 0.00148755
R12787 VSS.n2211 VSS.n2207 0.00148755
R12788 VSS.n2336 VSS.n2201 0.00148755
R12789 VSS.n2974 VSS.n791 0.00148755
R12790 VSS.n2974 VSS.n793 0.00148755
R12791 VSS.n2974 VSS.n799 0.00148755
R12792 VSS.n2974 VSS.n802 0.00148755
R12793 VSS.n2974 VSS.n809 0.00148755
R12794 VSS.n2974 VSS.n811 0.00148755
R12795 VSS.n2974 VSS.n828 0.00148755
R12796 VSS.n2974 VSS.n830 0.00148755
R12797 VSS.n2974 VSS.n836 0.00148755
R12798 VSS.n2974 VSS.n838 0.00148755
R12799 VSS.n2974 VSS.n844 0.00148755
R12800 VSS.n2974 VSS.n846 0.00148755
R12801 VSS.n31 VSS.n975 0.00148755
R12802 VSS.n31 VSS.n978 0.00148755
R12803 VSS.n3216 VSS.n703 0.00148755
R12804 VSS.n3216 VSS.n705 0.00148755
R12805 VSS.n3216 VSS.n711 0.00148755
R12806 VSS.n3216 VSS.n714 0.00148755
R12807 VSS.n3216 VSS.n721 0.00148755
R12808 VSS.n3216 VSS.n723 0.00148755
R12809 VSS.n3216 VSS.n739 0.00148755
R12810 VSS.n3216 VSS.n741 0.00148755
R12811 VSS.n3216 VSS.n747 0.00148755
R12812 VSS.n3216 VSS.n749 0.00148755
R12813 VSS.n3216 VSS.n755 0.00148755
R12814 VSS.n3216 VSS.n757 0.00148755
R12815 VSS.n1966 VSS.n1965 0.00147616
R12816 VSS.n2337 VSS.n2336 0.00147287
R12817 VSS.n1913 VSS.n1912 0.00137498
R12818 VSS.n10 VSS.n948 0.00133332
R12819 VSS.n1797 VSS.n1791 0.00133332
R12820 VSS.n74 VSS.n1475 0.00133332
R12821 VSS.n1609 VSS.n1608 0.00133332
R12822 VSS.n1243 VSS.n1244 0.00133332
R12823 VSS.n1887 VSS.n1727 0.00133332
R12824 VSS.n1880 VSS.n1718 0.00133332
R12825 VSS.n1874 VSS.n1715 0.00133332
R12826 VSS.n1933 VSS.n1713 0.00133332
R12827 VSS.n1942 VSS.n1918 0.00133332
R12828 VSS.n1928 VSS.n1708 0.00133332
R12829 VSS.n1925 VSS.n1920 0.00133332
R12830 VSS.n1706 VSS.n1679 0.00133332
R12831 VSS.n29 VSS.n1632 0.00133332
R12832 VSS.n0 VSS.n4 0.00128573
R12833 VSS.t136 VSS.n1563 0.00127036
R12834 VSS.n1705 VSS.n1631 0.00124998
R12835 VSS.n31 VSS.n960 0.0011222
R12836 VSS.n1998 VSS.n49 0.00167395
R12837 VSS.n46 VSS.n45 0.00149997
R12838 VSS.n43 VSS.n46 0.0015
R12839 VSS.n665 VSS.n517 0.00104753
R12840 VSS.n2583 VSS.n2102 0.00102991
R12841 VSS.n2974 VSS.n786 0.00102991
R12842 VSS.n2974 VSS.n792 0.00102991
R12843 VSS.n2974 VSS.n800 0.00102991
R12844 VSS.n2974 VSS.n810 0.00102991
R12845 VSS.n2974 VSS.n829 0.00102991
R12846 VSS.n2974 VSS.n837 0.00102991
R12847 VSS.n2974 VSS.n845 0.00102991
R12848 VSS.n31 VSS.n977 0.00102991
R12849 VSS.n3216 VSS.n698 0.00102991
R12850 VSS.n3216 VSS.n704 0.00102991
R12851 VSS.n3216 VSS.n712 0.00102991
R12852 VSS.n3216 VSS.n722 0.00102991
R12853 VSS.n3216 VSS.n740 0.00102991
R12854 VSS.n3216 VSS.n748 0.00102991
R12855 VSS.n3216 VSS.n756 0.00102991
R12856 VSS.n0 VSS.n8 0.00102591
R12857 VSS.n662 VSS.n517 0.00101876
R12858 VSS.n645 VSS.n525 0.00101876
R12859 VSS.n647 VSS.n525 0.00101876
R12860 VSS.n631 VSS.n534 0.00101876
R12861 VSS.n633 VSS.n534 0.00101876
R12862 VSS.n609 VSS.n542 0.00101876
R12863 VSS.n619 VSS.n542 0.00101876
R12864 VSS.n596 VSS.n551 0.00101876
R12865 VSS.n598 VSS.n551 0.00101876
R12866 VSS.n583 VSS.n560 0.00101876
R12867 VSS.n585 VSS.n560 0.00101876
R12868 VSS.n614 VSS.n542 0.00101872
R12869 VSS.n664 VSS.n517 0.00101872
R12870 VSS.n611 VSS.n542 0.00101872
R12871 VSS.n617 VSS.n542 0.00101872
R12872 VSS.n574 VSS.n570 0.00101811
R12873 VSS.n31 VSS.n983 0.00101641
R12874 VSS.n2974 VSS.n794 0.00101605
R12875 VSS.n2974 VSS.n803 0.00101605
R12876 VSS.n2974 VSS.n812 0.00101605
R12877 VSS.n2974 VSS.n831 0.00101605
R12878 VSS.n2974 VSS.n839 0.00101605
R12879 VSS.n31 VSS.n979 0.00101605
R12880 VSS.n3216 VSS.n706 0.00101605
R12881 VSS.n3216 VSS.n715 0.00101605
R12882 VSS.n3216 VSS.n724 0.00101605
R12883 VSS.n3216 VSS.n742 0.00101605
R12884 VSS.n3216 VSS.n750 0.00101605
R12885 VSS.n2583 VSS.n2101 0.00101563
R12886 VSS.n2305 VSS.n2284 0.00101563
R12887 VSS.n2305 VSS.n2288 0.00101563
R12888 VSS.n2312 VSS.n2268 0.00101563
R12889 VSS.n2312 VSS.n2272 0.00101563
R12890 VSS.n2318 VSS.n2241 0.00101563
R12891 VSS.n2318 VSS.n2250 0.00101563
R12892 VSS.n2324 VSS.n2225 0.00101563
R12893 VSS.n2324 VSS.n2229 0.00101563
R12894 VSS.n2330 VSS.n2210 0.00101563
R12895 VSS.n2330 VSS.n2213 0.00101563
R12896 VSS.n2974 VSS.n796 0.00101563
R12897 VSS.n2974 VSS.n805 0.00101563
R12898 VSS.n2974 VSS.n814 0.00101563
R12899 VSS.n2974 VSS.n833 0.00101563
R12900 VSS.n2974 VSS.n841 0.00101563
R12901 VSS.n31 VSS.n981 0.00101563
R12902 VSS.n3216 VSS.n708 0.00101563
R12903 VSS.n3216 VSS.n717 0.00101563
R12904 VSS.n3216 VSS.n726 0.00101563
R12905 VSS.n3216 VSS.n744 0.00101563
R12906 VSS.n3216 VSS.n752 0.00101563
R12907 VSS.n2318 VSS.n2245 0.00101562
R12908 VSS.n2974 VSS.n789 0.00101562
R12909 VSS.n2974 VSS.n798 0.00101562
R12910 VSS.n2974 VSS.n807 0.00101562
R12911 VSS.n2974 VSS.n819 0.00101562
R12912 VSS.n2974 VSS.n824 0.00101562
R12913 VSS.n2974 VSS.n835 0.00101562
R12914 VSS.n2974 VSS.n843 0.00101562
R12915 VSS.n31 VSS.n974 0.00101562
R12916 VSS.n3216 VSS.n701 0.00101562
R12917 VSS.n3216 VSS.n710 0.00101562
R12918 VSS.n3216 VSS.n719 0.00101562
R12919 VSS.n3216 VSS.n731 0.00101562
R12920 VSS.n3216 VSS.n738 0.00101562
R12921 VSS.n3216 VSS.n746 0.00101562
R12922 VSS.n3216 VSS.n754 0.00101562
R12923 VSS.n2583 VSS.n2098 0.00101562
R12924 VSS.n2318 VSS.n2243 0.00101562
R12925 VSS.n2318 VSS.n2253 0.00101562
R12926 VSS.n2974 VSS.n787 0.00101562
R12927 VSS.n2974 VSS.n816 0.00101562
R12928 VSS.n2974 VSS.n822 0.00101562
R12929 VSS.n3216 VSS.n699 0.00101562
R12930 VSS.n3216 VSS.n728 0.00101562
R12931 VSS.n3216 VSS.n734 0.00101562
R12932 VSS.n2340 VSS.n2200 0.00101517
R12933 VSS.n2974 VSS.n852 0.00101516
R12934 VSS.n3216 VSS.n3209 0.00101516
R12935 VSS.n2974 VSS.n848 0.00100089
R12936 VSS.n3216 VSS.n759 0.00100089
R12937 VSS.n574 VSS.n569 0.00100065
R12938 VSS.n3216 VSS.n761 0.00100049
R12939 VSS.n2342 VSS.n2200 0.00100046
R12940 VSS.n2974 VSS.n850 0.00100003
R12941 VSS.n2300 VSS.n2100 0.001
R12942 VSS.n2302 VSS.n2301 0.001
R12943 VSS.n2303 VSS.n2291 0.001
R12944 VSS.n2305 VSS.n2304 0.001
R12945 VSS.n2306 VSS.n2281 0.001
R12946 VSS.n2309 VSS.n2308 0.001
R12947 VSS.n2310 VSS.n2275 0.001
R12948 VSS.n2312 VSS.n2311 0.001
R12949 VSS.n2313 VSS.n2265 0.001
R12950 VSS.n2315 VSS.n2314 0.001
R12951 VSS.n2316 VSS.n2259 0.001
R12952 VSS.n2318 VSS.n2317 0.001
R12953 VSS.n2319 VSS.n2238 0.001
R12954 VSS.n2321 VSS.n2320 0.001
R12955 VSS.n2322 VSS.n2232 0.001
R12956 VSS.n2324 VSS.n2323 0.001
R12957 VSS.n2325 VSS.n2222 0.001
R12958 VSS.n2327 VSS.n2326 0.001
R12959 VSS.n2328 VSS.n2216 0.001
R12960 VSS.n2330 VSS.n2329 0.001
R12961 VSS.n2331 VSS.n2207 0.001
R12962 VSS.n2333 VSS.n2332 0.001
R12963 VSS.n2336 VSS.n2204 0.001
R12964 VSS.n2336 VSS.n2203 0.001
R12965 VSS.n2583 VSS.n2100 0.001
R12966 VSS.n2301 VSS.n2300 0.001
R12967 VSS.n2303 VSS.n2302 0.001
R12968 VSS.n2304 VSS.n2291 0.001
R12969 VSS.n2306 VSS.n2305 0.001
R12970 VSS.n2308 VSS.n2281 0.001
R12971 VSS.n2310 VSS.n2309 0.001
R12972 VSS.n2311 VSS.n2275 0.001
R12973 VSS.n2313 VSS.n2312 0.001
R12974 VSS.n2314 VSS.n2265 0.001
R12975 VSS.n2316 VSS.n2315 0.001
R12976 VSS.n2317 VSS.n2259 0.001
R12977 VSS.n2319 VSS.n2318 0.001
R12978 VSS.n2320 VSS.n2238 0.001
R12979 VSS.n2322 VSS.n2321 0.001
R12980 VSS.n2323 VSS.n2232 0.001
R12981 VSS.n2325 VSS.n2324 0.001
R12982 VSS.n2326 VSS.n2222 0.001
R12983 VSS.n2328 VSS.n2327 0.001
R12984 VSS.n2329 VSS.n2216 0.001
R12985 VSS.n2331 VSS.n2330 0.001
R12986 VSS.n2332 VSS.n2207 0.001
R12987 VSS.n2333 VSS.n2204 0.001
R12988 VSS.n2203 VSS.n2200 0.001
R12989 VSS.n660 VSS.n659 0.001
R12990 VSS.n655 VSS.n520 0.001
R12991 VSS.n653 VSS.n521 0.001
R12992 VSS.n650 VSS.n525 0.001
R12993 VSS.n649 VSS.n526 0.001
R12994 VSS.n642 VSS.n529 0.001
R12995 VSS.n639 VSS.n530 0.001
R12996 VSS.n636 VSS.n534 0.001
R12997 VSS.n635 VSS.n535 0.001
R12998 VSS.n628 VSS.n538 0.001
R12999 VSS.n626 VSS.n539 0.001
R13000 VSS.n623 VSS.n542 0.001
R13001 VSS.n621 VSS.n543 0.001
R13002 VSS.n606 VSS.n546 0.001
R13003 VSS.n604 VSS.n547 0.001
R13004 VSS.n601 VSS.n551 0.001
R13005 VSS.n600 VSS.n552 0.001
R13006 VSS.n593 VSS.n555 0.001
R13007 VSS.n591 VSS.n556 0.001
R13008 VSS.n588 VSS.n560 0.001
R13009 VSS.n587 VSS.n561 0.001
R13010 VSS.n580 VSS.n564 0.001
R13011 VSS.n577 VSS.n565 0.001
R13012 VSS.n577 VSS.n567 0.001
R13013 VSS.n659 VSS.n517 0.001
R13014 VSS.n660 VSS.n655 0.001
R13015 VSS.n521 VSS.n520 0.001
R13016 VSS.n653 VSS.n650 0.001
R13017 VSS.n526 VSS.n525 0.001
R13018 VSS.n649 VSS.n642 0.001
R13019 VSS.n530 VSS.n529 0.001
R13020 VSS.n639 VSS.n636 0.001
R13021 VSS.n535 VSS.n534 0.001
R13022 VSS.n635 VSS.n628 0.001
R13023 VSS.n539 VSS.n538 0.001
R13024 VSS.n626 VSS.n623 0.001
R13025 VSS.n543 VSS.n542 0.001
R13026 VSS.n621 VSS.n606 0.001
R13027 VSS.n547 VSS.n546 0.001
R13028 VSS.n604 VSS.n601 0.001
R13029 VSS.n552 VSS.n551 0.001
R13030 VSS.n600 VSS.n593 0.001
R13031 VSS.n556 VSS.n555 0.001
R13032 VSS.n591 VSS.n588 0.001
R13033 VSS.n561 VSS.n560 0.001
R13034 VSS.n587 VSS.n580 0.001
R13035 VSS.n565 VSS.n564 0.001
R13036 VSS.n574 VSS.n567 0.001
R13037 VSS.n2970 VSS.n167 0.001
R13038 VSS.n79 VSS.n77 0.00116667
R13039 VSS.n1797 VSS.n42 0.001
R13040 VSS.n1796 VSS.n44 0.00174999
R13041 VSS.n41 VSS.n38 0.00199984
R13042 VSS.n1608 VSS.n36 0.0015
R13043 VSS.n30 VSS.n29 0.0015
R13044 VSS.n1697 VSS.n22 0.0015
R13045 VSS.n1685 VSS.n20 0.0015
R13046 VSS.n1 VSS.n0 0.00125
R13047 VSS.n59 VSS.n57 0.001
R13048 VSS.n72 VSS.n70 0.001
R13049 VSS.n1603 VSS.n34 0.001
R13050 VSS.n1612 VSS.n1611 0.001
R13051 VSS.t37 VSS.n1612 0.001
R13052 VSS.n1891 VSS.n1725 0.001
R13053 VSS.n1891 VSS.n1723 0.001
R13054 VSS.n1890 VSS.n1722 0.001
R13055 VSS.n1889 VSS.n1721 0.001
R13056 VSS.n1887 VSS.n1726 0.001
R13057 VSS.n1886 VSS.n1728 0.001
R13058 VSS.n1884 VSS.n1720 0.001
R13059 VSS.n1884 VSS.n1729 0.001
R13060 VSS.n1883 VSS.n1730 0.001
R13061 VSS.n1882 VSS.n1731 0.001
R13062 VSS.n1880 VSS.n1719 0.001
R13063 VSS.n1879 VSS.n1717 0.001
R13064 VSS.n1877 VSS.n1732 0.001
R13065 VSS.n1877 VSS.n1716 0.001
R13066 VSS.n1875 VSS.n1733 0.001
R13067 VSS.n1874 VSS.n1734 0.001
R13068 VSS.n1912 VSS.n1714 0.001
R13069 VSS.n1936 VSS.n951 0.001
R13070 VSS.n1937 VSS.n1915 0.001
R13071 VSS.n1934 VSS.n1916 0.001
R13072 VSS.n1933 VSS.n1917 0.001
R13073 VSS.n1939 VSS.n1712 0.001
R13074 VSS.n1931 VSS.n1711 0.001
R13075 VSS.n1930 VSS.n1710 0.001
R13076 VSS.n1942 VSS.n1709 0.001
R13077 VSS.n1928 VSS.n1919 0.001
R13078 VSS.n1925 VSS.n1707 0.001
R13079 VSS.n1946 VSS.n1921 0.001
R13080 VSS.n1947 VSS.n1682 0.001
R13081 VSS.n1950 VSS.n1949 0.001
R13082 VSS.n1681 VSS.n1679 0.001
R13083 VSS.n1688 VSS.n13 0.001
R13084 VSS.n1687 VSS.n18 0.001
R13085 VSS.n1683 VSS.n27 0.001
R13086 VSS.n10 VSS.n951 0.001
R13087 VSS.n1936 VSS.n1915 0.001
R13088 VSS.n1937 VSS.n1916 0.001
R13089 VSS.n1934 VSS.n1917 0.001
R13090 VSS.n1938 VSS.n1712 0.001
R13091 VSS.n1939 VSS.n1711 0.001
R13092 VSS.n1931 VSS.n1710 0.001
R13093 VSS.n1930 VSS.n1709 0.001
R13094 VSS.n1943 VSS.n1919 0.001
R13095 VSS.n1927 VSS.n1707 0.001
R13096 VSS.n1923 VSS.n1921 0.001
R13097 VSS.n1947 VSS.n1946 0.001
R13098 VSS.n1949 VSS.n1682 0.001
R13099 VSS.n1950 VSS.n1681 0.001
R13100 VSS.n1725 VSS.n1724 0.001
R13101 VSS.n1890 VSS.n1723 0.001
R13102 VSS.n1889 VSS.n1722 0.001
R13103 VSS.n1888 VSS.n1721 0.001
R13104 VSS.n1888 VSS.n1726 0.001
R13105 VSS.n1885 VSS.n1728 0.001
R13106 VSS.n1885 VSS.n1720 0.001
R13107 VSS.n1883 VSS.n1729 0.001
R13108 VSS.n1882 VSS.n1730 0.001
R13109 VSS.n1881 VSS.n1731 0.001
R13110 VSS.n1881 VSS.n1719 0.001
R13111 VSS.n1878 VSS.n1717 0.001
R13112 VSS.n1878 VSS.n1732 0.001
R13113 VSS.n1876 VSS.n1716 0.001
R13114 VSS.n1876 VSS.n1733 0.001
R13115 VSS.n1875 VSS.n1734 0.001
R13116 VSS.n1873 VSS.n1714 0.001
R13117 VSS.n1786 VSS.n1631 0.001
R13118 VSS.n1786 VSS.n1785 0.001
R13119 VSS.n2 VSS.n1 8.50163
R13120 VSS.n1822 VSS.n1 8.47807
R13121 a_3747_311.n0 a_3747_311.t2 52.0388
R13122 a_3747_311.t1 a_3747_311.n0 35.4491
R13123 a_3747_311.n0 a_3747_311.t3 33.5891
R13124 a_3747_311.t0 a_3747_311.t1 5.61942
R13125 a_3171_311.n0 a_3171_311.t2 51.8377
R13126 a_3171_311.n0 a_3171_311.t3 33.3881
R13127 a_3171_311.t1 a_3171_311.n0 31.8923
R13128 a_3171_311.t0 a_3171_311.t1 5.61777
R13129 a_2595_311.n0 a_2595_311.t2 51.6367
R13130 a_2595_311.n0 a_2595_311.t3 33.187
R13131 a_2595_311.t1 a_2595_311.n0 27.993
R13132 a_2595_311.t0 a_2595_311.t1 5.73018
R13133 a_3747_1047.n0 a_3747_1047.t2 38.0081
R13134 a_3747_1047.n0 a_3747_1047.t3 33.3957
R13135 a_3747_1047.n1 a_3747_1047.t4 33.3957
R13136 a_3747_1047.n2 a_3747_1047.t5 33.3957
R13137 a_3747_1047.n3 a_3747_1047.t6 33.3957
R13138 a_3747_1047.n4 a_3747_1047.t7 33.3957
R13139 a_3747_1047.n5 a_3747_1047.t8 33.3957
R13140 a_3747_1047.n6 a_3747_1047.t9 33.3957
R13141 a_3747_1047.t1 a_3747_1047.n6 23.2419
R13142 a_3747_1047.t0 a_3747_1047.t1 5.61942
R13143 a_3747_1047.n6 a_3747_1047.n5 4.61291
R13144 a_3747_1047.n5 a_3747_1047.n4 4.61291
R13145 a_3747_1047.n4 a_3747_1047.n3 4.61291
R13146 a_3747_1047.n3 a_3747_1047.n2 4.61291
R13147 a_3747_1047.n2 a_3747_1047.n1 4.61291
R13148 a_3747_1047.n1 a_3747_1047.n0 4.61291
R13149 a_3171_1047.n0 a_3171_1047.t2 37.8054
R13150 a_3171_1047.n0 a_3171_1047.t3 33.193
R13151 a_3171_1047.n1 a_3171_1047.t4 33.193
R13152 a_3171_1047.n2 a_3171_1047.t5 33.193
R13153 a_3171_1047.n3 a_3171_1047.t6 33.193
R13154 a_3171_1047.n4 a_3171_1047.t7 33.193
R13155 a_3171_1047.n5 a_3171_1047.t8 33.193
R13156 a_3171_1047.n6 a_3171_1047.t9 33.193
R13157 a_3171_1047.t1 a_3171_1047.n6 23.0313
R13158 a_3171_1047.t0 a_3171_1047.t1 5.61777
R13159 a_3171_1047.n6 a_3171_1047.n5 4.61291
R13160 a_3171_1047.n5 a_3171_1047.n4 4.61291
R13161 a_3171_1047.n4 a_3171_1047.n3 4.61291
R13162 a_3171_1047.n3 a_3171_1047.n2 4.61291
R13163 a_3171_1047.n2 a_3171_1047.n1 4.61291
R13164 a_3171_1047.n1 a_3171_1047.n0 4.61291
R13165 a_2595_1047.n0 a_2595_1047.t2 37.7691
R13166 a_2595_1047.n0 a_2595_1047.t3 33.1567
R13167 a_2595_1047.n1 a_2595_1047.t4 33.1567
R13168 a_2595_1047.n2 a_2595_1047.t5 33.1567
R13169 a_2595_1047.n3 a_2595_1047.t6 33.1567
R13170 a_2595_1047.n4 a_2595_1047.t7 33.1567
R13171 a_2595_1047.n5 a_2595_1047.t8 33.1567
R13172 a_2595_1047.n6 a_2595_1047.t9 33.1567
R13173 a_2595_1047.t1 a_2595_1047.n6 22.7941
R13174 a_2595_1047.t0 a_2595_1047.t1 5.65522
R13175 a_2595_1047.n6 a_2595_1047.n5 4.61291
R13176 a_2595_1047.n5 a_2595_1047.n4 4.61291
R13177 a_2595_1047.n4 a_2595_1047.n3 4.61291
R13178 a_2595_1047.n3 a_2595_1047.n2 4.61291
R13179 a_2595_1047.n2 a_2595_1047.n1 4.61291
R13180 a_2595_1047.n1 a_2595_1047.n0 4.61291
R13181 a_2019_1047.n0 a_2019_1047.t2 37.9701
R13182 a_2019_1047.n0 a_2019_1047.t3 33.3577
R13183 a_2019_1047.n1 a_2019_1047.t4 33.3577
R13184 a_2019_1047.n2 a_2019_1047.t5 33.3577
R13185 a_2019_1047.n3 a_2019_1047.t6 33.3577
R13186 a_2019_1047.n4 a_2019_1047.t7 33.3577
R13187 a_2019_1047.n5 a_2019_1047.t8 33.3577
R13188 a_2019_1047.t1 a_2019_1047.t9 22.5945
R13189 a_2019_1047.t0 a_2019_1047.t1 5.62052
R13190 a_2019_1047.t9 a_2019_1047.n5 4.61291
R13191 a_2019_1047.n5 a_2019_1047.n4 4.61291
R13192 a_2019_1047.n4 a_2019_1047.n3 4.61291
R13193 a_2019_1047.n3 a_2019_1047.n2 4.61291
R13194 a_2019_1047.n2 a_2019_1047.n1 4.61291
R13195 a_2019_1047.n1 a_2019_1047.n0 4.61291
R13196 a_3747_3156.n0 a_3747_3156.t2 52.0388
R13197 a_3747_3156.t1 a_3747_3156.n0 35.4491
R13198 a_3747_3156.n0 a_3747_3156.t3 33.5891
R13199 a_3747_3156.t0 a_3747_3156.t1 5.61942
R13200 a_3171_3156.n0 a_3171_3156.t2 51.8377
R13201 a_3171_3156.n0 a_3171_3156.t3 33.3881
R13202 a_3171_3156.t1 a_3171_3156.n0 31.8923
R13203 a_3171_3156.t0 a_3171_3156.t1 5.61777
R13204 a_2595_3156.n0 a_2595_3156.t2 51.6367
R13205 a_2595_3156.n0 a_2595_3156.t3 33.187
R13206 a_2595_3156.t1 a_2595_3156.n0 27.993
R13207 a_2595_3156.t0 a_2595_3156.t1 5.73018
R13208 a_2019_3156.t3 a_2019_3156.t2 51.6139
R13209 a_2019_3156.t1 a_2019_3156.t3 24.5351
R13210 a_2019_3156.t0 a_2019_3156.t1 5.62052
R13211 a_3747_3892.n0 a_3747_3892.t2 38.0081
R13212 a_3747_3892.n0 a_3747_3892.t3 33.3957
R13213 a_3747_3892.n1 a_3747_3892.t4 33.3957
R13214 a_3747_3892.n2 a_3747_3892.t5 33.3957
R13215 a_3747_3892.n3 a_3747_3892.t6 33.3957
R13216 a_3747_3892.n4 a_3747_3892.t7 33.3957
R13217 a_3747_3892.n5 a_3747_3892.t8 33.3957
R13218 a_3747_3892.n6 a_3747_3892.t9 33.3957
R13219 a_3747_3892.t1 a_3747_3892.n6 23.2419
R13220 a_3747_3892.t0 a_3747_3892.t1 5.61942
R13221 a_3747_3892.n6 a_3747_3892.n5 4.61291
R13222 a_3747_3892.n5 a_3747_3892.n4 4.61291
R13223 a_3747_3892.n4 a_3747_3892.n3 4.61291
R13224 a_3747_3892.n3 a_3747_3892.n2 4.61291
R13225 a_3747_3892.n2 a_3747_3892.n1 4.61291
R13226 a_3747_3892.n1 a_3747_3892.n0 4.61291
R13227 a_3171_3892.n0 a_3171_3892.t2 37.8054
R13228 a_3171_3892.n0 a_3171_3892.t3 33.193
R13229 a_3171_3892.n1 a_3171_3892.t4 33.193
R13230 a_3171_3892.n2 a_3171_3892.t5 33.193
R13231 a_3171_3892.n3 a_3171_3892.t6 33.193
R13232 a_3171_3892.n4 a_3171_3892.t7 33.193
R13233 a_3171_3892.n5 a_3171_3892.t8 33.193
R13234 a_3171_3892.n6 a_3171_3892.t9 33.193
R13235 a_3171_3892.t1 a_3171_3892.n6 23.0313
R13236 a_3171_3892.t0 a_3171_3892.t1 5.61777
R13237 a_3171_3892.n6 a_3171_3892.n5 4.61291
R13238 a_3171_3892.n5 a_3171_3892.n4 4.61291
R13239 a_3171_3892.n4 a_3171_3892.n3 4.61291
R13240 a_3171_3892.n3 a_3171_3892.n2 4.61291
R13241 a_3171_3892.n2 a_3171_3892.n1 4.61291
R13242 a_3171_3892.n1 a_3171_3892.n0 4.61291
R13243 a_2595_3892.n0 a_2595_3892.t2 37.7691
R13244 a_2595_3892.n0 a_2595_3892.t3 33.1567
R13245 a_2595_3892.n1 a_2595_3892.t4 33.1567
R13246 a_2595_3892.n2 a_2595_3892.t5 33.1567
R13247 a_2595_3892.n3 a_2595_3892.t6 33.1567
R13248 a_2595_3892.n4 a_2595_3892.t7 33.1567
R13249 a_2595_3892.n5 a_2595_3892.t8 33.1567
R13250 a_2595_3892.n6 a_2595_3892.t9 33.1567
R13251 a_2595_3892.t1 a_2595_3892.n6 22.7941
R13252 a_2595_3892.t0 a_2595_3892.t1 5.65522
R13253 a_2595_3892.n6 a_2595_3892.n5 4.61291
R13254 a_2595_3892.n5 a_2595_3892.n4 4.61291
R13255 a_2595_3892.n4 a_2595_3892.n3 4.61291
R13256 a_2595_3892.n3 a_2595_3892.n2 4.61291
R13257 a_2595_3892.n2 a_2595_3892.n1 4.61291
R13258 a_2595_3892.n1 a_2595_3892.n0 4.61291
R13259 a_2019_3892.n0 a_2019_3892.t2 37.9701
R13260 a_2019_3892.n0 a_2019_3892.t3 33.3577
R13261 a_2019_3892.n1 a_2019_3892.t4 33.3577
R13262 a_2019_3892.n2 a_2019_3892.t5 33.3577
R13263 a_2019_3892.n3 a_2019_3892.t6 33.3577
R13264 a_2019_3892.n4 a_2019_3892.t7 33.3577
R13265 a_2019_3892.n5 a_2019_3892.t8 33.3577
R13266 a_2019_3892.t1 a_2019_3892.t9 22.5945
R13267 a_2019_3892.t0 a_2019_3892.t1 5.62052
R13268 a_2019_3892.t9 a_2019_3892.n5 4.61291
R13269 a_2019_3892.n5 a_2019_3892.n4 4.61291
R13270 a_2019_3892.n4 a_2019_3892.n3 4.61291
R13271 a_2019_3892.n3 a_2019_3892.n2 4.61291
R13272 a_2019_3892.n2 a_2019_3892.n1 4.61291
R13273 a_2019_3892.n1 a_2019_3892.n0 4.61291
R13274 a_3747_6001.n0 a_3747_6001.t2 52.0388
R13275 a_3747_6001.t1 a_3747_6001.n0 35.4491
R13276 a_3747_6001.n0 a_3747_6001.t3 33.5891
R13277 a_3747_6001.t0 a_3747_6001.t1 5.61942
R13278 a_3171_6001.n0 a_3171_6001.t2 51.8377
R13279 a_3171_6001.n0 a_3171_6001.t3 33.3881
R13280 a_3171_6001.t1 a_3171_6001.n0 31.8923
R13281 a_3171_6001.t0 a_3171_6001.t1 5.61777
R13282 a_2595_6001.n0 a_2595_6001.t2 51.6367
R13283 a_2595_6001.n0 a_2595_6001.t3 33.187
R13284 a_2595_6001.t1 a_2595_6001.n0 27.993
R13285 a_2595_6001.t0 a_2595_6001.t1 5.73018
R13286 a_2019_6001.t3 a_2019_6001.t2 51.6139
R13287 a_2019_6001.t1 a_2019_6001.t3 24.5351
R13288 a_2019_6001.t0 a_2019_6001.t1 5.62052
R13289 a_3747_6737.n0 a_3747_6737.t2 38.0081
R13290 a_3747_6737.n0 a_3747_6737.t3 33.3957
R13291 a_3747_6737.n1 a_3747_6737.t4 33.3957
R13292 a_3747_6737.n2 a_3747_6737.t5 33.3957
R13293 a_3747_6737.n3 a_3747_6737.t6 33.3957
R13294 a_3747_6737.n4 a_3747_6737.t7 33.3957
R13295 a_3747_6737.n5 a_3747_6737.t8 33.3957
R13296 a_3747_6737.n6 a_3747_6737.t9 33.3957
R13297 a_3747_6737.t1 a_3747_6737.n6 23.2419
R13298 a_3747_6737.t0 a_3747_6737.t1 5.61942
R13299 a_3747_6737.n6 a_3747_6737.n5 4.61291
R13300 a_3747_6737.n5 a_3747_6737.n4 4.61291
R13301 a_3747_6737.n4 a_3747_6737.n3 4.61291
R13302 a_3747_6737.n3 a_3747_6737.n2 4.61291
R13303 a_3747_6737.n2 a_3747_6737.n1 4.61291
R13304 a_3747_6737.n1 a_3747_6737.n0 4.61291
R13305 a_3171_6737.n0 a_3171_6737.t2 37.8054
R13306 a_3171_6737.n0 a_3171_6737.t3 33.193
R13307 a_3171_6737.n1 a_3171_6737.t4 33.193
R13308 a_3171_6737.n2 a_3171_6737.t5 33.193
R13309 a_3171_6737.n3 a_3171_6737.t6 33.193
R13310 a_3171_6737.n4 a_3171_6737.t7 33.193
R13311 a_3171_6737.n5 a_3171_6737.t8 33.193
R13312 a_3171_6737.n6 a_3171_6737.t9 33.193
R13313 a_3171_6737.t1 a_3171_6737.n6 23.0313
R13314 a_3171_6737.t0 a_3171_6737.t1 5.61777
R13315 a_3171_6737.n6 a_3171_6737.n5 4.61291
R13316 a_3171_6737.n5 a_3171_6737.n4 4.61291
R13317 a_3171_6737.n4 a_3171_6737.n3 4.61291
R13318 a_3171_6737.n3 a_3171_6737.n2 4.61291
R13319 a_3171_6737.n2 a_3171_6737.n1 4.61291
R13320 a_3171_6737.n1 a_3171_6737.n0 4.61291
R13321 a_2595_6737.n0 a_2595_6737.t2 37.7691
R13322 a_2595_6737.n0 a_2595_6737.t3 33.1567
R13323 a_2595_6737.n1 a_2595_6737.t4 33.1567
R13324 a_2595_6737.n2 a_2595_6737.t5 33.1567
R13325 a_2595_6737.n3 a_2595_6737.t6 33.1567
R13326 a_2595_6737.n4 a_2595_6737.t7 33.1567
R13327 a_2595_6737.n5 a_2595_6737.t8 33.1567
R13328 a_2595_6737.n6 a_2595_6737.t9 33.1567
R13329 a_2595_6737.t1 a_2595_6737.n6 22.7941
R13330 a_2595_6737.t0 a_2595_6737.t1 5.65522
R13331 a_2595_6737.n6 a_2595_6737.n5 4.61291
R13332 a_2595_6737.n5 a_2595_6737.n4 4.61291
R13333 a_2595_6737.n4 a_2595_6737.n3 4.61291
R13334 a_2595_6737.n3 a_2595_6737.n2 4.61291
R13335 a_2595_6737.n2 a_2595_6737.n1 4.61291
R13336 a_2595_6737.n1 a_2595_6737.n0 4.61291
R13337 a_2019_6737.n0 a_2019_6737.t2 37.9701
R13338 a_2019_6737.n0 a_2019_6737.t3 33.3577
R13339 a_2019_6737.n1 a_2019_6737.t4 33.3577
R13340 a_2019_6737.n2 a_2019_6737.t5 33.3577
R13341 a_2019_6737.n3 a_2019_6737.t6 33.3577
R13342 a_2019_6737.n4 a_2019_6737.t7 33.3577
R13343 a_2019_6737.n5 a_2019_6737.t8 33.3577
R13344 a_2019_6737.t1 a_2019_6737.t9 22.5945
R13345 a_2019_6737.t0 a_2019_6737.t1 5.62052
R13346 a_2019_6737.t9 a_2019_6737.n5 4.61291
R13347 a_2019_6737.n5 a_2019_6737.n4 4.61291
R13348 a_2019_6737.n4 a_2019_6737.n3 4.61291
R13349 a_2019_6737.n3 a_2019_6737.n2 4.61291
R13350 a_2019_6737.n2 a_2019_6737.n1 4.61291
R13351 a_2019_6737.n1 a_2019_6737.n0 4.61291
R13352 a_3747_12493.n0 a_3747_12493.t2 52.0388
R13353 a_3747_12493.t1 a_3747_12493.n0 35.4491
R13354 a_3747_12493.n0 a_3747_12493.t3 33.5891
R13355 a_3747_12493.t0 a_3747_12493.t1 5.61942
R13356 a_3171_12493.n0 a_3171_12493.t2 51.8377
R13357 a_3171_12493.n0 a_3171_12493.t3 33.3881
R13358 a_3171_12493.t1 a_3171_12493.n0 31.8923
R13359 a_3171_12493.t0 a_3171_12493.t1 5.61777
R13360 a_2595_12493.n0 a_2595_12493.t2 51.6367
R13361 a_2595_12493.n0 a_2595_12493.t3 33.187
R13362 a_2595_12493.t1 a_2595_12493.n0 27.993
R13363 a_2595_12493.t0 a_2595_12493.t1 5.73018
R13364 a_2019_12493.t3 a_2019_12493.t2 51.6139
R13365 a_2019_12493.t1 a_2019_12493.t3 24.5351
R13366 a_2019_12493.t0 a_2019_12493.t1 5.62052
R13367 a_3747_13229.n0 a_3747_13229.t2 38.0081
R13368 a_3747_13229.n0 a_3747_13229.t3 33.3957
R13369 a_3747_13229.n1 a_3747_13229.t4 33.3957
R13370 a_3747_13229.n2 a_3747_13229.t5 33.3957
R13371 a_3747_13229.n3 a_3747_13229.t6 33.3957
R13372 a_3747_13229.n4 a_3747_13229.t7 33.3957
R13373 a_3747_13229.n5 a_3747_13229.t8 33.3957
R13374 a_3747_13229.n6 a_3747_13229.t9 33.3957
R13375 a_3747_13229.t1 a_3747_13229.n6 23.2419
R13376 a_3747_13229.t0 a_3747_13229.t1 5.61942
R13377 a_3747_13229.n6 a_3747_13229.n5 4.61291
R13378 a_3747_13229.n5 a_3747_13229.n4 4.61291
R13379 a_3747_13229.n4 a_3747_13229.n3 4.61291
R13380 a_3747_13229.n3 a_3747_13229.n2 4.61291
R13381 a_3747_13229.n2 a_3747_13229.n1 4.61291
R13382 a_3747_13229.n1 a_3747_13229.n0 4.61291
R13383 a_3171_13229.n0 a_3171_13229.t2 37.8054
R13384 a_3171_13229.n0 a_3171_13229.t3 33.193
R13385 a_3171_13229.n1 a_3171_13229.t4 33.193
R13386 a_3171_13229.n2 a_3171_13229.t5 33.193
R13387 a_3171_13229.n3 a_3171_13229.t6 33.193
R13388 a_3171_13229.n4 a_3171_13229.t7 33.193
R13389 a_3171_13229.n5 a_3171_13229.t8 33.193
R13390 a_3171_13229.n6 a_3171_13229.t9 33.193
R13391 a_3171_13229.t1 a_3171_13229.n6 23.0313
R13392 a_3171_13229.t0 a_3171_13229.t1 5.61777
R13393 a_3171_13229.n6 a_3171_13229.n5 4.61291
R13394 a_3171_13229.n5 a_3171_13229.n4 4.61291
R13395 a_3171_13229.n4 a_3171_13229.n3 4.61291
R13396 a_3171_13229.n3 a_3171_13229.n2 4.61291
R13397 a_3171_13229.n2 a_3171_13229.n1 4.61291
R13398 a_3171_13229.n1 a_3171_13229.n0 4.61291
R13399 a_2595_13229.n0 a_2595_13229.t2 37.7691
R13400 a_2595_13229.n0 a_2595_13229.t3 33.1567
R13401 a_2595_13229.n1 a_2595_13229.t4 33.1567
R13402 a_2595_13229.n2 a_2595_13229.t5 33.1567
R13403 a_2595_13229.n3 a_2595_13229.t6 33.1567
R13404 a_2595_13229.n4 a_2595_13229.t7 33.1567
R13405 a_2595_13229.n5 a_2595_13229.t8 33.1567
R13406 a_2595_13229.n6 a_2595_13229.t9 33.1567
R13407 a_2595_13229.t1 a_2595_13229.n6 22.7941
R13408 a_2595_13229.t0 a_2595_13229.t1 5.65522
R13409 a_2595_13229.n6 a_2595_13229.n5 4.61291
R13410 a_2595_13229.n5 a_2595_13229.n4 4.61291
R13411 a_2595_13229.n4 a_2595_13229.n3 4.61291
R13412 a_2595_13229.n3 a_2595_13229.n2 4.61291
R13413 a_2595_13229.n2 a_2595_13229.n1 4.61291
R13414 a_2595_13229.n1 a_2595_13229.n0 4.61291
R13415 a_2019_13229.n0 a_2019_13229.t2 37.9701
R13416 a_2019_13229.n0 a_2019_13229.t3 33.3577
R13417 a_2019_13229.n1 a_2019_13229.t4 33.3577
R13418 a_2019_13229.n2 a_2019_13229.t5 33.3577
R13419 a_2019_13229.n3 a_2019_13229.t6 33.3577
R13420 a_2019_13229.n4 a_2019_13229.t7 33.3577
R13421 a_2019_13229.n5 a_2019_13229.t8 33.3577
R13422 a_2019_13229.t1 a_2019_13229.t9 22.5945
R13423 a_2019_13229.t0 a_2019_13229.t1 5.62052
R13424 a_2019_13229.t9 a_2019_13229.n5 4.61291
R13425 a_2019_13229.n5 a_2019_13229.n4 4.61291
R13426 a_2019_13229.n4 a_2019_13229.n3 4.61291
R13427 a_2019_13229.n3 a_2019_13229.n2 4.61291
R13428 a_2019_13229.n2 a_2019_13229.n1 4.61291
R13429 a_2019_13229.n1 a_2019_13229.n0 4.61291
R13430 a_3747_15338.n0 a_3747_15338.t2 52.0388
R13431 a_3747_15338.t1 a_3747_15338.n0 35.4491
R13432 a_3747_15338.n0 a_3747_15338.t3 33.5891
R13433 a_3747_15338.t0 a_3747_15338.t1 5.61942
R13434 a_3171_15338.n0 a_3171_15338.t2 51.8377
R13435 a_3171_15338.n0 a_3171_15338.t3 33.3881
R13436 a_3171_15338.t1 a_3171_15338.n0 31.8923
R13437 a_3171_15338.t0 a_3171_15338.t1 5.61777
R13438 a_2595_15338.n0 a_2595_15338.t2 51.6367
R13439 a_2595_15338.n0 a_2595_15338.t3 33.187
R13440 a_2595_15338.t1 a_2595_15338.n0 27.993
R13441 a_2595_15338.t0 a_2595_15338.t1 5.73018
R13442 a_2019_15338.t3 a_2019_15338.t2 51.6139
R13443 a_2019_15338.t1 a_2019_15338.t3 24.5351
R13444 a_2019_15338.t0 a_2019_15338.t1 5.62052
R13445 a_3747_16074.n0 a_3747_16074.t2 38.0081
R13446 a_3747_16074.n0 a_3747_16074.t3 33.3957
R13447 a_3747_16074.n1 a_3747_16074.t4 33.3957
R13448 a_3747_16074.n2 a_3747_16074.t5 33.3957
R13449 a_3747_16074.n3 a_3747_16074.t6 33.3957
R13450 a_3747_16074.n4 a_3747_16074.t7 33.3957
R13451 a_3747_16074.n5 a_3747_16074.t8 33.3957
R13452 a_3747_16074.n6 a_3747_16074.t9 33.3957
R13453 a_3747_16074.t1 a_3747_16074.n6 23.2419
R13454 a_3747_16074.t0 a_3747_16074.t1 5.61942
R13455 a_3747_16074.n6 a_3747_16074.n5 4.61291
R13456 a_3747_16074.n5 a_3747_16074.n4 4.61291
R13457 a_3747_16074.n4 a_3747_16074.n3 4.61291
R13458 a_3747_16074.n3 a_3747_16074.n2 4.61291
R13459 a_3747_16074.n2 a_3747_16074.n1 4.61291
R13460 a_3747_16074.n1 a_3747_16074.n0 4.61291
R13461 a_3171_16074.n0 a_3171_16074.t2 37.8054
R13462 a_3171_16074.n0 a_3171_16074.t3 33.193
R13463 a_3171_16074.n1 a_3171_16074.t4 33.193
R13464 a_3171_16074.n2 a_3171_16074.t5 33.193
R13465 a_3171_16074.n3 a_3171_16074.t6 33.193
R13466 a_3171_16074.n4 a_3171_16074.t7 33.193
R13467 a_3171_16074.n5 a_3171_16074.t8 33.193
R13468 a_3171_16074.n6 a_3171_16074.t9 33.193
R13469 a_3171_16074.t1 a_3171_16074.n6 23.0313
R13470 a_3171_16074.t0 a_3171_16074.t1 5.61777
R13471 a_3171_16074.n6 a_3171_16074.n5 4.61291
R13472 a_3171_16074.n5 a_3171_16074.n4 4.61291
R13473 a_3171_16074.n4 a_3171_16074.n3 4.61291
R13474 a_3171_16074.n3 a_3171_16074.n2 4.61291
R13475 a_3171_16074.n2 a_3171_16074.n1 4.61291
R13476 a_3171_16074.n1 a_3171_16074.n0 4.61291
R13477 a_2595_16074.n0 a_2595_16074.t2 37.7691
R13478 a_2595_16074.n0 a_2595_16074.t3 33.1567
R13479 a_2595_16074.n1 a_2595_16074.t4 33.1567
R13480 a_2595_16074.n2 a_2595_16074.t5 33.1567
R13481 a_2595_16074.n3 a_2595_16074.t6 33.1567
R13482 a_2595_16074.n4 a_2595_16074.t7 33.1567
R13483 a_2595_16074.n5 a_2595_16074.t8 33.1567
R13484 a_2595_16074.n6 a_2595_16074.t9 33.1567
R13485 a_2595_16074.t1 a_2595_16074.n6 22.7941
R13486 a_2595_16074.t0 a_2595_16074.t1 5.65522
R13487 a_2595_16074.n6 a_2595_16074.n5 4.61291
R13488 a_2595_16074.n5 a_2595_16074.n4 4.61291
R13489 a_2595_16074.n4 a_2595_16074.n3 4.61291
R13490 a_2595_16074.n3 a_2595_16074.n2 4.61291
R13491 a_2595_16074.n2 a_2595_16074.n1 4.61291
R13492 a_2595_16074.n1 a_2595_16074.n0 4.61291
R13493 a_2019_16074.n0 a_2019_16074.t2 37.9701
R13494 a_2019_16074.n0 a_2019_16074.t3 33.3577
R13495 a_2019_16074.n1 a_2019_16074.t4 33.3577
R13496 a_2019_16074.n2 a_2019_16074.t5 33.3577
R13497 a_2019_16074.n3 a_2019_16074.t6 33.3577
R13498 a_2019_16074.n4 a_2019_16074.t7 33.3577
R13499 a_2019_16074.n5 a_2019_16074.t8 33.3577
R13500 a_2019_16074.t1 a_2019_16074.t9 22.5945
R13501 a_2019_16074.t0 a_2019_16074.t1 5.62052
R13502 a_2019_16074.t9 a_2019_16074.n5 4.61291
R13503 a_2019_16074.n5 a_2019_16074.n4 4.61291
R13504 a_2019_16074.n4 a_2019_16074.n3 4.61291
R13505 a_2019_16074.n3 a_2019_16074.n2 4.61291
R13506 a_2019_16074.n2 a_2019_16074.n1 4.61291
R13507 a_2019_16074.n1 a_2019_16074.n0 4.61291
R13508 a_4187_1764.n0 a_4187_1764.t163 34.3755
R13509 a_4187_1764.n31 a_4187_1764.t131 34.3755
R13510 a_4187_1764.n126 a_4187_1764.t97 34.3755
R13511 a_4187_1764.n94 a_4187_1764.t65 34.3755
R13512 a_4187_1764.n63 a_4187_1764.t33 34.3755
R13513 a_4187_1764.n0 a_4187_1764.t162 33.0005
R13514 a_4187_1764.n1 a_4187_1764.t161 33.0005
R13515 a_4187_1764.n2 a_4187_1764.t160 33.0005
R13516 a_4187_1764.n3 a_4187_1764.t159 33.0005
R13517 a_4187_1764.n4 a_4187_1764.t158 33.0005
R13518 a_4187_1764.n5 a_4187_1764.t157 33.0005
R13519 a_4187_1764.n6 a_4187_1764.t156 33.0005
R13520 a_4187_1764.n7 a_4187_1764.t155 33.0005
R13521 a_4187_1764.n8 a_4187_1764.t154 33.0005
R13522 a_4187_1764.n9 a_4187_1764.t153 33.0005
R13523 a_4187_1764.n10 a_4187_1764.t152 33.0005
R13524 a_4187_1764.n11 a_4187_1764.t151 33.0005
R13525 a_4187_1764.n12 a_4187_1764.t150 33.0005
R13526 a_4187_1764.n13 a_4187_1764.t149 33.0005
R13527 a_4187_1764.n14 a_4187_1764.t148 33.0005
R13528 a_4187_1764.n15 a_4187_1764.t147 33.0005
R13529 a_4187_1764.n16 a_4187_1764.t146 33.0005
R13530 a_4187_1764.n17 a_4187_1764.t145 33.0005
R13531 a_4187_1764.n18 a_4187_1764.t144 33.0005
R13532 a_4187_1764.n19 a_4187_1764.t143 33.0005
R13533 a_4187_1764.n20 a_4187_1764.t142 33.0005
R13534 a_4187_1764.n21 a_4187_1764.t141 33.0005
R13535 a_4187_1764.n22 a_4187_1764.t140 33.0005
R13536 a_4187_1764.n23 a_4187_1764.t139 33.0005
R13537 a_4187_1764.n24 a_4187_1764.t138 33.0005
R13538 a_4187_1764.n25 a_4187_1764.t137 33.0005
R13539 a_4187_1764.n26 a_4187_1764.t136 33.0005
R13540 a_4187_1764.n27 a_4187_1764.t135 33.0005
R13541 a_4187_1764.n28 a_4187_1764.t134 33.0005
R13542 a_4187_1764.n29 a_4187_1764.t133 33.0005
R13543 a_4187_1764.n30 a_4187_1764.t132 33.0005
R13544 a_4187_1764.n31 a_4187_1764.t130 33.0005
R13545 a_4187_1764.n32 a_4187_1764.t129 33.0005
R13546 a_4187_1764.n33 a_4187_1764.t128 33.0005
R13547 a_4187_1764.n34 a_4187_1764.t127 33.0005
R13548 a_4187_1764.n35 a_4187_1764.t126 33.0005
R13549 a_4187_1764.n36 a_4187_1764.t125 33.0005
R13550 a_4187_1764.n37 a_4187_1764.t124 33.0005
R13551 a_4187_1764.n38 a_4187_1764.t123 33.0005
R13552 a_4187_1764.n39 a_4187_1764.t122 33.0005
R13553 a_4187_1764.n40 a_4187_1764.t121 33.0005
R13554 a_4187_1764.n41 a_4187_1764.t120 33.0005
R13555 a_4187_1764.n42 a_4187_1764.t119 33.0005
R13556 a_4187_1764.n43 a_4187_1764.t118 33.0005
R13557 a_4187_1764.n44 a_4187_1764.t117 33.0005
R13558 a_4187_1764.n45 a_4187_1764.t116 33.0005
R13559 a_4187_1764.n46 a_4187_1764.t115 33.0005
R13560 a_4187_1764.n47 a_4187_1764.t114 33.0005
R13561 a_4187_1764.n48 a_4187_1764.t113 33.0005
R13562 a_4187_1764.n49 a_4187_1764.t112 33.0005
R13563 a_4187_1764.n50 a_4187_1764.t111 33.0005
R13564 a_4187_1764.n51 a_4187_1764.t110 33.0005
R13565 a_4187_1764.n52 a_4187_1764.t109 33.0005
R13566 a_4187_1764.n53 a_4187_1764.t108 33.0005
R13567 a_4187_1764.n54 a_4187_1764.t107 33.0005
R13568 a_4187_1764.n55 a_4187_1764.t106 33.0005
R13569 a_4187_1764.n56 a_4187_1764.t105 33.0005
R13570 a_4187_1764.n57 a_4187_1764.t104 33.0005
R13571 a_4187_1764.n58 a_4187_1764.t103 33.0005
R13572 a_4187_1764.n59 a_4187_1764.t102 33.0005
R13573 a_4187_1764.n60 a_4187_1764.t101 33.0005
R13574 a_4187_1764.n61 a_4187_1764.t100 33.0005
R13575 a_4187_1764.n126 a_4187_1764.t96 33.0005
R13576 a_4187_1764.n127 a_4187_1764.t95 33.0005
R13577 a_4187_1764.n128 a_4187_1764.t94 33.0005
R13578 a_4187_1764.n129 a_4187_1764.t93 33.0005
R13579 a_4187_1764.n130 a_4187_1764.t92 33.0005
R13580 a_4187_1764.n131 a_4187_1764.t91 33.0005
R13581 a_4187_1764.n132 a_4187_1764.t90 33.0005
R13582 a_4187_1764.n133 a_4187_1764.t89 33.0005
R13583 a_4187_1764.n134 a_4187_1764.t88 33.0005
R13584 a_4187_1764.n135 a_4187_1764.t87 33.0005
R13585 a_4187_1764.n136 a_4187_1764.t86 33.0005
R13586 a_4187_1764.n137 a_4187_1764.t85 33.0005
R13587 a_4187_1764.n138 a_4187_1764.t84 33.0005
R13588 a_4187_1764.n139 a_4187_1764.t83 33.0005
R13589 a_4187_1764.n140 a_4187_1764.t82 33.0005
R13590 a_4187_1764.n141 a_4187_1764.t81 33.0005
R13591 a_4187_1764.n142 a_4187_1764.t80 33.0005
R13592 a_4187_1764.n143 a_4187_1764.t79 33.0005
R13593 a_4187_1764.n144 a_4187_1764.t78 33.0005
R13594 a_4187_1764.n145 a_4187_1764.t77 33.0005
R13595 a_4187_1764.n146 a_4187_1764.t76 33.0005
R13596 a_4187_1764.n147 a_4187_1764.t75 33.0005
R13597 a_4187_1764.n148 a_4187_1764.t74 33.0005
R13598 a_4187_1764.n149 a_4187_1764.t73 33.0005
R13599 a_4187_1764.n150 a_4187_1764.t72 33.0005
R13600 a_4187_1764.n151 a_4187_1764.t71 33.0005
R13601 a_4187_1764.n152 a_4187_1764.t70 33.0005
R13602 a_4187_1764.n153 a_4187_1764.t69 33.0005
R13603 a_4187_1764.n154 a_4187_1764.t68 33.0005
R13604 a_4187_1764.n155 a_4187_1764.t67 33.0005
R13605 a_4187_1764.n156 a_4187_1764.t66 33.0005
R13606 a_4187_1764.n94 a_4187_1764.t64 33.0005
R13607 a_4187_1764.n95 a_4187_1764.t63 33.0005
R13608 a_4187_1764.n96 a_4187_1764.t62 33.0005
R13609 a_4187_1764.n97 a_4187_1764.t61 33.0005
R13610 a_4187_1764.n98 a_4187_1764.t60 33.0005
R13611 a_4187_1764.n99 a_4187_1764.t59 33.0005
R13612 a_4187_1764.n100 a_4187_1764.t58 33.0005
R13613 a_4187_1764.n101 a_4187_1764.t57 33.0005
R13614 a_4187_1764.n102 a_4187_1764.t56 33.0005
R13615 a_4187_1764.n103 a_4187_1764.t55 33.0005
R13616 a_4187_1764.n104 a_4187_1764.t54 33.0005
R13617 a_4187_1764.n105 a_4187_1764.t53 33.0005
R13618 a_4187_1764.n106 a_4187_1764.t52 33.0005
R13619 a_4187_1764.n107 a_4187_1764.t51 33.0005
R13620 a_4187_1764.n108 a_4187_1764.t50 33.0005
R13621 a_4187_1764.n109 a_4187_1764.t49 33.0005
R13622 a_4187_1764.n110 a_4187_1764.t48 33.0005
R13623 a_4187_1764.n111 a_4187_1764.t47 33.0005
R13624 a_4187_1764.n112 a_4187_1764.t46 33.0005
R13625 a_4187_1764.n113 a_4187_1764.t45 33.0005
R13626 a_4187_1764.n114 a_4187_1764.t44 33.0005
R13627 a_4187_1764.n115 a_4187_1764.t43 33.0005
R13628 a_4187_1764.n116 a_4187_1764.t42 33.0005
R13629 a_4187_1764.n117 a_4187_1764.t41 33.0005
R13630 a_4187_1764.n118 a_4187_1764.t40 33.0005
R13631 a_4187_1764.n119 a_4187_1764.t39 33.0005
R13632 a_4187_1764.n120 a_4187_1764.t38 33.0005
R13633 a_4187_1764.n121 a_4187_1764.t37 33.0005
R13634 a_4187_1764.n122 a_4187_1764.t36 33.0005
R13635 a_4187_1764.n123 a_4187_1764.t35 33.0005
R13636 a_4187_1764.n124 a_4187_1764.t34 33.0005
R13637 a_4187_1764.n63 a_4187_1764.t32 33.0005
R13638 a_4187_1764.n64 a_4187_1764.t31 33.0005
R13639 a_4187_1764.n65 a_4187_1764.t30 33.0005
R13640 a_4187_1764.n66 a_4187_1764.t29 33.0005
R13641 a_4187_1764.n67 a_4187_1764.t28 33.0005
R13642 a_4187_1764.n68 a_4187_1764.t27 33.0005
R13643 a_4187_1764.n69 a_4187_1764.t26 33.0005
R13644 a_4187_1764.n70 a_4187_1764.t25 33.0005
R13645 a_4187_1764.n71 a_4187_1764.t24 33.0005
R13646 a_4187_1764.n72 a_4187_1764.t23 33.0005
R13647 a_4187_1764.n73 a_4187_1764.t22 33.0005
R13648 a_4187_1764.n74 a_4187_1764.t21 33.0005
R13649 a_4187_1764.n75 a_4187_1764.t20 33.0005
R13650 a_4187_1764.n76 a_4187_1764.t19 33.0005
R13651 a_4187_1764.n77 a_4187_1764.t18 33.0005
R13652 a_4187_1764.n78 a_4187_1764.t17 33.0005
R13653 a_4187_1764.n79 a_4187_1764.t16 33.0005
R13654 a_4187_1764.n80 a_4187_1764.t15 33.0005
R13655 a_4187_1764.n81 a_4187_1764.t14 33.0005
R13656 a_4187_1764.n82 a_4187_1764.t13 33.0005
R13657 a_4187_1764.n83 a_4187_1764.t12 33.0005
R13658 a_4187_1764.n84 a_4187_1764.t11 33.0005
R13659 a_4187_1764.n85 a_4187_1764.t10 33.0005
R13660 a_4187_1764.n86 a_4187_1764.t9 33.0005
R13661 a_4187_1764.n87 a_4187_1764.t8 33.0005
R13662 a_4187_1764.n88 a_4187_1764.t7 33.0005
R13663 a_4187_1764.n89 a_4187_1764.t6 33.0005
R13664 a_4187_1764.n90 a_4187_1764.t5 33.0005
R13665 a_4187_1764.n91 a_4187_1764.t4 33.0005
R13666 a_4187_1764.n92 a_4187_1764.t3 33.0005
R13667 a_4187_1764.n93 a_4187_1764.t2 33.0005
R13668 a_4187_1764.n159 a_4187_1764.t99 25.0885
R13669 a_4187_1764.n125 a_4187_1764.n93 15.1797
R13670 a_4187_1764.n62 a_4187_1764.n30 15.1797
R13671 a_4187_1764.n158 a_4187_1764.t98 11.19
R13672 a_4187_1764.t0 a_4187_1764.n160 13.9108
R13673 a_4187_1764.n160 a_4187_1764.t1 12.9887
R13674 a_4187_1764.n62 a_4187_1764.n61 10.8632
R13675 a_4187_1764.n157 a_4187_1764.n156 10.8632
R13676 a_4187_1764.n125 a_4187_1764.n124 10.8632
R13677 a_4187_1764.n158 a_4187_1764.n62 5.26657
R13678 a_4187_1764.n158 a_4187_1764.n157 4.58443
R13679 a_4187_1764.n157 a_4187_1764.n125 4.31705
R13680 a_4187_1764.n30 a_4187_1764.n29 1.3755
R13681 a_4187_1764.n29 a_4187_1764.n28 1.3755
R13682 a_4187_1764.n28 a_4187_1764.n27 1.3755
R13683 a_4187_1764.n27 a_4187_1764.n26 1.3755
R13684 a_4187_1764.n26 a_4187_1764.n25 1.3755
R13685 a_4187_1764.n25 a_4187_1764.n24 1.3755
R13686 a_4187_1764.n24 a_4187_1764.n23 1.3755
R13687 a_4187_1764.n23 a_4187_1764.n22 1.3755
R13688 a_4187_1764.n22 a_4187_1764.n21 1.3755
R13689 a_4187_1764.n21 a_4187_1764.n20 1.3755
R13690 a_4187_1764.n20 a_4187_1764.n19 1.3755
R13691 a_4187_1764.n19 a_4187_1764.n18 1.3755
R13692 a_4187_1764.n18 a_4187_1764.n17 1.3755
R13693 a_4187_1764.n17 a_4187_1764.n16 1.3755
R13694 a_4187_1764.n16 a_4187_1764.n15 1.3755
R13695 a_4187_1764.n15 a_4187_1764.n14 1.3755
R13696 a_4187_1764.n14 a_4187_1764.n13 1.3755
R13697 a_4187_1764.n13 a_4187_1764.n12 1.3755
R13698 a_4187_1764.n12 a_4187_1764.n11 1.3755
R13699 a_4187_1764.n11 a_4187_1764.n10 1.3755
R13700 a_4187_1764.n10 a_4187_1764.n9 1.3755
R13701 a_4187_1764.n9 a_4187_1764.n8 1.3755
R13702 a_4187_1764.n8 a_4187_1764.n7 1.3755
R13703 a_4187_1764.n7 a_4187_1764.n6 1.3755
R13704 a_4187_1764.n6 a_4187_1764.n5 1.3755
R13705 a_4187_1764.n5 a_4187_1764.n4 1.3755
R13706 a_4187_1764.n4 a_4187_1764.n3 1.3755
R13707 a_4187_1764.n3 a_4187_1764.n2 1.3755
R13708 a_4187_1764.n2 a_4187_1764.n1 1.3755
R13709 a_4187_1764.n1 a_4187_1764.n0 1.3755
R13710 a_4187_1764.n61 a_4187_1764.n60 1.3755
R13711 a_4187_1764.n60 a_4187_1764.n59 1.3755
R13712 a_4187_1764.n59 a_4187_1764.n58 1.3755
R13713 a_4187_1764.n58 a_4187_1764.n57 1.3755
R13714 a_4187_1764.n57 a_4187_1764.n56 1.3755
R13715 a_4187_1764.n56 a_4187_1764.n55 1.3755
R13716 a_4187_1764.n55 a_4187_1764.n54 1.3755
R13717 a_4187_1764.n54 a_4187_1764.n53 1.3755
R13718 a_4187_1764.n53 a_4187_1764.n52 1.3755
R13719 a_4187_1764.n52 a_4187_1764.n51 1.3755
R13720 a_4187_1764.n51 a_4187_1764.n50 1.3755
R13721 a_4187_1764.n50 a_4187_1764.n49 1.3755
R13722 a_4187_1764.n49 a_4187_1764.n48 1.3755
R13723 a_4187_1764.n48 a_4187_1764.n47 1.3755
R13724 a_4187_1764.n47 a_4187_1764.n46 1.3755
R13725 a_4187_1764.n46 a_4187_1764.n45 1.3755
R13726 a_4187_1764.n45 a_4187_1764.n44 1.3755
R13727 a_4187_1764.n44 a_4187_1764.n43 1.3755
R13728 a_4187_1764.n43 a_4187_1764.n42 1.3755
R13729 a_4187_1764.n42 a_4187_1764.n41 1.3755
R13730 a_4187_1764.n41 a_4187_1764.n40 1.3755
R13731 a_4187_1764.n40 a_4187_1764.n39 1.3755
R13732 a_4187_1764.n39 a_4187_1764.n38 1.3755
R13733 a_4187_1764.n38 a_4187_1764.n37 1.3755
R13734 a_4187_1764.n37 a_4187_1764.n36 1.3755
R13735 a_4187_1764.n36 a_4187_1764.n35 1.3755
R13736 a_4187_1764.n35 a_4187_1764.n34 1.3755
R13737 a_4187_1764.n34 a_4187_1764.n33 1.3755
R13738 a_4187_1764.n33 a_4187_1764.n32 1.3755
R13739 a_4187_1764.n32 a_4187_1764.n31 1.3755
R13740 a_4187_1764.n156 a_4187_1764.n155 1.3755
R13741 a_4187_1764.n155 a_4187_1764.n154 1.3755
R13742 a_4187_1764.n154 a_4187_1764.n153 1.3755
R13743 a_4187_1764.n153 a_4187_1764.n152 1.3755
R13744 a_4187_1764.n152 a_4187_1764.n151 1.3755
R13745 a_4187_1764.n151 a_4187_1764.n150 1.3755
R13746 a_4187_1764.n150 a_4187_1764.n149 1.3755
R13747 a_4187_1764.n149 a_4187_1764.n148 1.3755
R13748 a_4187_1764.n148 a_4187_1764.n147 1.3755
R13749 a_4187_1764.n147 a_4187_1764.n146 1.3755
R13750 a_4187_1764.n146 a_4187_1764.n145 1.3755
R13751 a_4187_1764.n145 a_4187_1764.n144 1.3755
R13752 a_4187_1764.n144 a_4187_1764.n143 1.3755
R13753 a_4187_1764.n143 a_4187_1764.n142 1.3755
R13754 a_4187_1764.n142 a_4187_1764.n141 1.3755
R13755 a_4187_1764.n141 a_4187_1764.n140 1.3755
R13756 a_4187_1764.n140 a_4187_1764.n139 1.3755
R13757 a_4187_1764.n139 a_4187_1764.n138 1.3755
R13758 a_4187_1764.n138 a_4187_1764.n137 1.3755
R13759 a_4187_1764.n137 a_4187_1764.n136 1.3755
R13760 a_4187_1764.n136 a_4187_1764.n135 1.3755
R13761 a_4187_1764.n135 a_4187_1764.n134 1.3755
R13762 a_4187_1764.n134 a_4187_1764.n133 1.3755
R13763 a_4187_1764.n133 a_4187_1764.n132 1.3755
R13764 a_4187_1764.n132 a_4187_1764.n131 1.3755
R13765 a_4187_1764.n131 a_4187_1764.n130 1.3755
R13766 a_4187_1764.n130 a_4187_1764.n129 1.3755
R13767 a_4187_1764.n129 a_4187_1764.n128 1.3755
R13768 a_4187_1764.n128 a_4187_1764.n127 1.3755
R13769 a_4187_1764.n127 a_4187_1764.n126 1.3755
R13770 a_4187_1764.n124 a_4187_1764.n123 1.3755
R13771 a_4187_1764.n123 a_4187_1764.n122 1.3755
R13772 a_4187_1764.n122 a_4187_1764.n121 1.3755
R13773 a_4187_1764.n121 a_4187_1764.n120 1.3755
R13774 a_4187_1764.n120 a_4187_1764.n119 1.3755
R13775 a_4187_1764.n119 a_4187_1764.n118 1.3755
R13776 a_4187_1764.n118 a_4187_1764.n117 1.3755
R13777 a_4187_1764.n117 a_4187_1764.n116 1.3755
R13778 a_4187_1764.n116 a_4187_1764.n115 1.3755
R13779 a_4187_1764.n115 a_4187_1764.n114 1.3755
R13780 a_4187_1764.n114 a_4187_1764.n113 1.3755
R13781 a_4187_1764.n113 a_4187_1764.n112 1.3755
R13782 a_4187_1764.n112 a_4187_1764.n111 1.3755
R13783 a_4187_1764.n111 a_4187_1764.n110 1.3755
R13784 a_4187_1764.n110 a_4187_1764.n109 1.3755
R13785 a_4187_1764.n109 a_4187_1764.n108 1.3755
R13786 a_4187_1764.n108 a_4187_1764.n107 1.3755
R13787 a_4187_1764.n107 a_4187_1764.n106 1.3755
R13788 a_4187_1764.n106 a_4187_1764.n105 1.3755
R13789 a_4187_1764.n105 a_4187_1764.n104 1.3755
R13790 a_4187_1764.n104 a_4187_1764.n103 1.3755
R13791 a_4187_1764.n103 a_4187_1764.n102 1.3755
R13792 a_4187_1764.n102 a_4187_1764.n101 1.3755
R13793 a_4187_1764.n101 a_4187_1764.n100 1.3755
R13794 a_4187_1764.n100 a_4187_1764.n99 1.3755
R13795 a_4187_1764.n99 a_4187_1764.n98 1.3755
R13796 a_4187_1764.n98 a_4187_1764.n97 1.3755
R13797 a_4187_1764.n97 a_4187_1764.n96 1.3755
R13798 a_4187_1764.n96 a_4187_1764.n95 1.3755
R13799 a_4187_1764.n95 a_4187_1764.n94 1.3755
R13800 a_4187_1764.n93 a_4187_1764.n92 1.3755
R13801 a_4187_1764.n92 a_4187_1764.n91 1.3755
R13802 a_4187_1764.n91 a_4187_1764.n90 1.3755
R13803 a_4187_1764.n90 a_4187_1764.n89 1.3755
R13804 a_4187_1764.n89 a_4187_1764.n88 1.3755
R13805 a_4187_1764.n88 a_4187_1764.n87 1.3755
R13806 a_4187_1764.n87 a_4187_1764.n86 1.3755
R13807 a_4187_1764.n86 a_4187_1764.n85 1.3755
R13808 a_4187_1764.n85 a_4187_1764.n84 1.3755
R13809 a_4187_1764.n84 a_4187_1764.n83 1.3755
R13810 a_4187_1764.n83 a_4187_1764.n82 1.3755
R13811 a_4187_1764.n82 a_4187_1764.n81 1.3755
R13812 a_4187_1764.n81 a_4187_1764.n80 1.3755
R13813 a_4187_1764.n80 a_4187_1764.n79 1.3755
R13814 a_4187_1764.n79 a_4187_1764.n78 1.3755
R13815 a_4187_1764.n78 a_4187_1764.n77 1.3755
R13816 a_4187_1764.n77 a_4187_1764.n76 1.3755
R13817 a_4187_1764.n76 a_4187_1764.n75 1.3755
R13818 a_4187_1764.n75 a_4187_1764.n74 1.3755
R13819 a_4187_1764.n74 a_4187_1764.n73 1.3755
R13820 a_4187_1764.n73 a_4187_1764.n72 1.3755
R13821 a_4187_1764.n72 a_4187_1764.n71 1.3755
R13822 a_4187_1764.n71 a_4187_1764.n70 1.3755
R13823 a_4187_1764.n70 a_4187_1764.n69 1.3755
R13824 a_4187_1764.n69 a_4187_1764.n68 1.3755
R13825 a_4187_1764.n68 a_4187_1764.n67 1.3755
R13826 a_4187_1764.n67 a_4187_1764.n66 1.3755
R13827 a_4187_1764.n66 a_4187_1764.n65 1.3755
R13828 a_4187_1764.n65 a_4187_1764.n64 1.3755
R13829 a_4187_1764.n64 a_4187_1764.n63 1.3755
R13830 a_4187_1764.n160 a_4187_1764.n159 0.735818
R13831 a_4187_1764.n159 a_4187_1764.t98 7.58765
C5450 CHAN3_MUX_OUT VSS 3.38792f
C5451 CHAN3_MUX_SEL4 VSS 1.60804f
C5452 CHAN3_MUX_SEL3 VSS 0.90961f
C5453 CHAN3_MUX_SEL2 VSS 2.16639f
C5454 CHAN3_MUX_SEL1 VSS 0.94892f
C5455 CHAN3_MUX_SEL0 VSS 1.91644f
C5456 CHAN3_DELAY_OUT_LAST VSS 0.38565f
C5457 CHAN3_DELAY_IN VSS 1.55907f
C5458 CHAN2_MUX_OUT VSS 1.5998f
C5459 CHAN2_MUX_SEL4 VSS 1.40898f
C5460 CHAN2_MUX_SEL3 VSS 0.89413f
C5461 CHAN2_MUX_SEL2 VSS 1.81186f
C5462 CHAN2_MUX_SEL1 VSS 0.94892f
C5463 CHAN2_MUX_SEL0 VSS 1.91644f
C5464 CHAN2_DELAY_OUT_LAST VSS 0.38565f
C5465 CHAN2_DELAY_IN VSS 1.5514f
C5466 REF_MUX_OUT VSS 1.5998f
C5467 REF_MUX_SEL4 VSS 1.40898f
C5468 REF_MUX_SEL3 VSS 0.89413f
C5469 REF_MUX_SEL2 VSS 1.81186f
C5470 REF_MUX_SEL1 VSS 0.95341f
C5471 REF_MUX_SEL0 VSS 1.93453f
C5472 REF_DELAY_OUT_LAST VSS 2.8263f
C5473 REF_CLK VSS 3.06113f
C5474 DLL_RESETN VSS 4.6015f
C5475 CHAN1_MUX_OUT VSS 2.17245f
C5476 CHAN1_MUX_SEL4 VSS 1.59207f
C5477 CHAN1_MUX_SEL3 VSS 0.90548f
C5478 CHAN1_MUX_SEL2 VSS 2.06125f
C5479 CHAN1_MUX_SEL1 VSS 0.94892f
C5480 CHAN1_MUX_SEL0 VSS 1.91644f
C5481 CHAN1_DELAY_OUT_LAST VSS 0.38565f
C5482 CHAN1_DELAY_IN VSS 1.55908f
C5483 CHAN0_MUX_OUT VSS 1.5998f
C5484 CHAN0_MUX_SEL4 VSS 1.40898f
C5485 CHAN0_MUX_SEL3 VSS 0.89413f
C5486 CHAN0_MUX_SEL2 VSS 1.81186f
C5487 CHAN0_MUX_SEL1 VSS 0.95342f
C5488 CHAN0_MUX_SEL0 VSS 1.93463f
C5489 CHAN0_DELAY_OUT_LAST VSS 0.39284f
C5490 CHAN0_DELAY_IN VSS 1.85909f
C5491 VDD VSS 0.27942p
C5492 a_26985_519# VSS 0.17928f ; **FLOATING
C5493 a_23945_519# VSS 0.17928f ; **FLOATING
C5494 a_20905_519# VSS 0.17928f ; **FLOATING
C5495 a_17865_519# VSS 0.17881f ; **FLOATING
C5496 a_16851_309# VSS 0.38699f ; **FLOATING
C5497 a_16108_289# VSS 3.82102f ; **FLOATING
C5498 a_15964_289# VSS 0.17459f ; **FLOATING
C5499 a_15765_463# VSS 0.36132f ; **FLOATING
C5500 a_14825_519# VSS 0.17928f ; **FLOATING
C5501 a_11785_519# VSS 0.17928f ; **FLOATING
C5502 a_8745_519# VSS 0.17928f ; **FLOATING
C5503 a_5731_289# VSS 3.43588f ; **FLOATING
C5504 a_2019_311# VSS 1.63512f ; **FLOATING
C5505 a_5705_519# VSS 0.17638f ; **FLOATING
C5506 a_3449_331# VSS 0.18478f ; **FLOATING
C5507 a_2873_331# VSS 0.18321f ; **FLOATING
C5508 a_2297_331# VSS 0.18331f ; **FLOATING
C5509 a_1721_331# VSS 0.17178f ; **FLOATING
C5510 a_1544_289# VSS 0.30084f ; **FLOATING
C5511 a_1256_289# VSS 0.87117f ; **FLOATING
C5512 a_27991_1008# VSS 0.18706f ; **FLOATING
C5513 a_27915_1044# VSS 0.10926f ; **FLOATING
C5514 a_27124_1008# VSS 0.17878f ; **FLOATING
C5515 a_27048_1044# VSS 0.12122f ; **FLOATING
C5516 a_26471_1008# VSS 0.18175f ; **FLOATING
C5517 a_26395_1044# VSS 0.11073f ; **FLOATING
C5518 a_25604_1008# VSS 0.18257f ; **FLOATING
C5519 a_25630_1044# VSS 0.38585f ; **FLOATING
C5520 a_25528_1044# VSS 0.13246f ; **FLOATING
C5521 a_24951_1008# VSS 0.18335f ; **FLOATING
C5522 a_24875_1044# VSS 0.11016f ; **FLOATING
C5523 a_24084_1008# VSS 0.17878f ; **FLOATING
C5524 a_24008_1044# VSS 0.12122f ; **FLOATING
C5525 a_23431_1008# VSS 0.18175f ; **FLOATING
C5526 a_23355_1044# VSS 0.11073f ; **FLOATING
C5527 a_22564_1008# VSS 0.18087f ; **FLOATING
C5528 a_22590_1044# VSS 0.32818f ; **FLOATING
C5529 a_22488_1044# VSS 0.12433f ; **FLOATING
C5530 a_21911_1008# VSS 0.18335f ; **FLOATING
C5531 a_21835_1044# VSS 0.11016f ; **FLOATING
C5532 a_21044_1008# VSS 0.17878f ; **FLOATING
C5533 a_20968_1044# VSS 0.12122f ; **FLOATING
C5534 a_20391_1008# VSS 0.18175f ; **FLOATING
C5535 a_20315_1044# VSS 0.11073f ; **FLOATING
C5536 a_19524_1008# VSS 0.18087f ; **FLOATING
C5537 a_19550_1044# VSS 0.33563f ; **FLOATING
C5538 a_19448_1044# VSS 0.12433f ; **FLOATING
C5539 a_18871_1008# VSS 0.18335f ; **FLOATING
C5540 a_18795_1044# VSS 0.11016f ; **FLOATING
C5541 a_18004_1008# VSS 0.1797f ; **FLOATING
C5542 a_17928_1044# VSS 0.12899f ; **FLOATING
C5543 a_17351_1008# VSS 0.18022f ; **FLOATING
C5544 a_17275_1044# VSS 0.10926f ; **FLOATING
C5545 a_16484_1008# VSS 0.18023f ; **FLOATING
C5546 a_16510_1044# VSS 0.30718f ; **FLOATING
C5547 a_16408_1044# VSS 0.1229f ; **FLOATING
C5548 a_15831_1008# VSS 0.17846f ; **FLOATING
C5549 a_15755_1044# VSS 0.10926f ; **FLOATING
C5550 a_14964_1008# VSS 0.17878f ; **FLOATING
C5551 a_14888_1044# VSS 0.12122f ; **FLOATING
C5552 a_14311_1008# VSS 0.18175f ; **FLOATING
C5553 a_14235_1044# VSS 0.11073f ; **FLOATING
C5554 a_13444_1008# VSS 0.18087f ; **FLOATING
C5555 a_13470_1044# VSS 0.30113f ; **FLOATING
C5556 a_13368_1044# VSS 0.12433f ; **FLOATING
C5557 a_12791_1008# VSS 0.18335f ; **FLOATING
C5558 a_12715_1044# VSS 0.11016f ; **FLOATING
C5559 a_11924_1008# VSS 0.17878f ; **FLOATING
C5560 a_11848_1044# VSS 0.12122f ; **FLOATING
C5561 a_11271_1008# VSS 0.18175f ; **FLOATING
C5562 a_11195_1044# VSS 0.11073f ; **FLOATING
C5563 a_10404_1008# VSS 0.18087f ; **FLOATING
C5564 a_10430_1044# VSS 0.31665f ; **FLOATING
C5565 a_10328_1044# VSS 0.12433f ; **FLOATING
C5566 a_9751_1008# VSS 0.18359f ; **FLOATING
C5567 a_9675_1044# VSS 0.11016f ; **FLOATING
C5568 a_8884_1008# VSS 0.17878f ; **FLOATING
C5569 a_8808_1044# VSS 0.12122f ; **FLOATING
C5570 a_8231_1008# VSS 0.18175f ; **FLOATING
C5571 a_8155_1044# VSS 0.11073f ; **FLOATING
C5572 a_7364_1008# VSS 0.18087f ; **FLOATING
C5573 a_7390_1044# VSS 0.31136f ; **FLOATING
C5574 a_7288_1044# VSS 0.12433f ; **FLOATING
C5575 a_6711_1008# VSS 0.18335f ; **FLOATING
C5576 a_6635_1044# VSS 0.11016f ; **FLOATING
C5577 a_5844_1008# VSS 0.17878f ; **FLOATING
C5578 a_5768_1044# VSS 0.12122f ; **FLOATING
C5579 a_5191_1008# VSS 0.18022f ; **FLOATING
C5580 a_5115_1044# VSS 0.10926f ; **FLOATING
C5581 a_4324_1008# VSS 0.18023f ; **FLOATING
C5582 a_4350_1044# VSS 0.26655f ; **FLOATING
C5583 a_4248_1044# VSS 0.12443f ; **FLOATING
C5584 a_27705_1044# VSS 0.25297f ; **FLOATING
C5585 a_26185_1044# VSS 0.23475f ; **FLOATING
C5586 a_24665_1044# VSS 0.25405f ; **FLOATING
C5587 a_23145_1044# VSS 0.23475f ; **FLOATING
C5588 a_21625_1044# VSS 0.25405f ; **FLOATING
C5589 a_20105_1044# VSS 0.23475f ; **FLOATING
C5590 a_18585_1044# VSS 0.25405f ; **FLOATING
C5591 a_17065_1044# VSS 0.23387f ; **FLOATING
C5592 a_15545_1044# VSS 0.25297f ; **FLOATING
C5593 a_14025_1044# VSS 0.23475f ; **FLOATING
C5594 a_12505_1044# VSS 0.25405f ; **FLOATING
C5595 a_10985_1044# VSS 0.23475f ; **FLOATING
C5596 a_9465_1044# VSS 0.25405f ; **FLOATING
C5597 a_7945_1044# VSS 0.23475f ; **FLOATING
C5598 a_6425_1044# VSS 0.25405f ; **FLOATING
C5599 a_4905_1044# VSS 0.2355f ; **FLOATING
C5600 a_4157_1313# VSS 0.32875f ; **FLOATING
C5601 a_3449_1395# VSS 0.18619f ; **FLOATING
C5602 a_2873_1395# VSS 0.18296f ; **FLOATING
C5603 a_2297_1395# VSS 0.18306f ; **FLOATING
C5604 a_1721_1395# VSS 0.172f ; **FLOATING
C5605 a_1544_1044# VSS 0.29854f ; **FLOATING
C5606 a_1256_1044# VSS 0.85418f ; **FLOATING
C5607 a_27671_1842# VSS 0.01336f ; **FLOATING
C5608 a_26911_1842# VSS 0.01336f ; **FLOATING
C5609 a_26151_1842# VSS 0.01336f ; **FLOATING
C5610 a_25391_1842# VSS 0.01733f ; **FLOATING
C5611 a_24631_1842# VSS 0.01336f ; **FLOATING
C5612 a_23871_1842# VSS 0.01336f ; **FLOATING
C5613 a_23111_1842# VSS 0.01336f ; **FLOATING
C5614 a_22351_1842# VSS 0.01336f ; **FLOATING
C5615 a_21591_1842# VSS 0.01336f ; **FLOATING
C5616 a_20831_1842# VSS 0.01336f ; **FLOATING
C5617 a_20071_1842# VSS 0.01336f ; **FLOATING
C5618 a_19311_1842# VSS 0.01336f ; **FLOATING
C5619 a_18551_1842# VSS 0.01336f ; **FLOATING
C5620 a_17791_1842# VSS 0.01733f ; **FLOATING
C5621 a_17031_1842# VSS 0.01336f ; **FLOATING
C5622 a_16271_1842# VSS 0.01336f ; **FLOATING
C5623 a_15511_1842# VSS 0.01336f ; **FLOATING
C5624 a_14751_1842# VSS 0.01336f ; **FLOATING
C5625 a_13991_1842# VSS 0.01336f ; **FLOATING
C5626 a_13231_1842# VSS 0.01336f ; **FLOATING
C5627 a_12471_1842# VSS 0.01336f ; **FLOATING
C5628 a_11711_1842# VSS 0.01336f ; **FLOATING
C5629 a_10951_1842# VSS 0.01336f ; **FLOATING
C5630 a_10191_1842# VSS 0.01733f ; **FLOATING
C5631 a_9431_1842# VSS 0.01336f ; **FLOATING
C5632 a_8671_1842# VSS 0.01336f ; **FLOATING
C5633 a_7911_1842# VSS 0.01336f ; **FLOATING
C5634 a_7151_1842# VSS 0.01336f ; **FLOATING
C5635 a_6391_1842# VSS 0.01336f ; **FLOATING
C5636 a_5631_1842# VSS 0.01336f ; **FLOATING
C5637 a_4871_1842# VSS 0.01336f ; **FLOATING
C5638 a_4111_1842# VSS 0.0139f ; **FLOATING
C5639 a_27563_1842# VSS 0.49473f ; **FLOATING
C5640 a_27997_1842# VSS 0.64441f ; **FLOATING
C5641 a_27433_1842# VSS 0.44435f ; **FLOATING
C5642 a_26803_1842# VSS 0.4868f ; **FLOATING
C5643 a_27237_1842# VSS 0.92464f ; **FLOATING
C5644 a_26673_1842# VSS 0.44356f ; **FLOATING
C5645 a_26043_1842# VSS 0.48789f ; **FLOATING
C5646 a_26477_1842# VSS 0.95173f ; **FLOATING
C5647 a_25913_1842# VSS 0.44813f ; **FLOATING
C5648 a_25283_1842# VSS 0.96055f ; **FLOATING
C5649 a_25717_1842# VSS 0.97151f ; **FLOATING
C5650 a_25153_1842# VSS 0.56638f ; **FLOATING
C5651 a_24523_1842# VSS 0.47217f ; **FLOATING
C5652 a_24957_1842# VSS 1.11567f ; **FLOATING
C5653 a_24393_1842# VSS 0.43117f ; **FLOATING
C5654 a_23763_1842# VSS 0.48642f ; **FLOATING
C5655 a_24197_1842# VSS 0.91212f ; **FLOATING
C5656 a_23633_1842# VSS 0.4435f ; **FLOATING
C5657 a_23003_1842# VSS 0.48774f ; **FLOATING
C5658 a_23437_1842# VSS 0.95131f ; **FLOATING
C5659 a_22873_1842# VSS 0.44619f ; **FLOATING
C5660 a_22243_1842# VSS 0.48565f ; **FLOATING
C5661 a_22677_1842# VSS 0.86118f ; **FLOATING
C5662 a_22113_1842# VSS 0.44414f ; **FLOATING
C5663 a_21483_1842# VSS 0.48744f ; **FLOATING
C5664 a_21917_1842# VSS 0.95513f ; **FLOATING
C5665 a_21353_1842# VSS 0.44136f ; **FLOATING
C5666 a_20723_1842# VSS 0.48671f ; **FLOATING
C5667 a_21157_1842# VSS 0.91928f ; **FLOATING
C5668 a_20593_1842# VSS 0.44348f ; **FLOATING
C5669 a_19963_1842# VSS 0.48774f ; **FLOATING
C5670 a_20397_1842# VSS 0.95131f ; **FLOATING
C5671 a_19833_1842# VSS 0.44619f ; **FLOATING
C5672 a_19203_1842# VSS 0.48566f ; **FLOATING
C5673 a_19637_1842# VSS 0.8612f ; **FLOATING
C5674 a_19073_1842# VSS 0.4442f ; **FLOATING
C5675 a_18443_1842# VSS 0.48753f ; **FLOATING
C5676 a_18877_1842# VSS 0.95528f ; **FLOATING
C5677 a_18313_1842# VSS 0.44124f ; **FLOATING
C5678 a_17683_1842# VSS 0.93629f ; **FLOATING
C5679 a_18117_1842# VSS 0.96994f ; **FLOATING
C5680 a_17553_1842# VSS 0.60625f ; **FLOATING
C5681 a_16923_1842# VSS 0.49071f ; **FLOATING
C5682 a_17357_1842# VSS 1.12986f ; **FLOATING
C5683 a_16793_1842# VSS 0.44263f ; **FLOATING
C5684 a_16163_1842# VSS 0.46958f ; **FLOATING
C5685 a_16597_1842# VSS 0.85055f ; **FLOATING
C5686 a_16033_1842# VSS 0.43619f ; **FLOATING
C5687 a_15403_1842# VSS 0.48909f ; **FLOATING
C5688 a_15837_1842# VSS 0.94699f ; **FLOATING
C5689 a_15273_1842# VSS 0.44136f ; **FLOATING
C5690 a_14643_1842# VSS 0.48671f ; **FLOATING
C5691 a_15077_1842# VSS 0.91814f ; **FLOATING
C5692 a_14513_1842# VSS 0.44348f ; **FLOATING
C5693 a_13883_1842# VSS 0.48774f ; **FLOATING
C5694 a_14317_1842# VSS 0.95131f ; **FLOATING
C5695 a_13753_1842# VSS 0.44619f ; **FLOATING
C5696 a_13123_1842# VSS 0.48563f ; **FLOATING
C5697 a_13557_1842# VSS 0.86118f ; **FLOATING
C5698 a_12993_1842# VSS 0.44414f ; **FLOATING
C5699 a_12363_1842# VSS 0.48744f ; **FLOATING
C5700 a_12797_1842# VSS 0.95346f ; **FLOATING
C5701 a_12233_1842# VSS 0.44136f ; **FLOATING
C5702 a_11603_1842# VSS 0.48672f ; **FLOATING
C5703 a_12037_1842# VSS 0.91928f ; **FLOATING
C5704 a_11473_1842# VSS 0.44354f ; **FLOATING
C5705 a_10843_1842# VSS 0.48784f ; **FLOATING
C5706 a_11277_1842# VSS 0.95144f ; **FLOATING
C5707 a_10713_1842# VSS 0.44684f ; **FLOATING
C5708 a_10083_1842# VSS 0.9169f ; **FLOATING
C5709 a_10517_1842# VSS 0.87094f ; **FLOATING
C5710 a_9953_1842# VSS 0.70713f ; **FLOATING
C5711 a_9323_1842# VSS 0.48995f ; **FLOATING
C5712 a_9757_1842# VSS 1.31734f ; **FLOATING
C5713 a_9193_1842# VSS 0.44151f ; **FLOATING
C5714 a_8563_1842# VSS 0.46677f ; **FLOATING
C5715 a_8997_1842# VSS 0.91705f ; **FLOATING
C5716 a_8433_1842# VSS 0.44288f ; **FLOATING
C5717 a_7803_1842# VSS 0.48776f ; **FLOATING
C5718 a_8237_1842# VSS 0.95135f ; **FLOATING
C5719 a_7673_1842# VSS 0.44619f ; **FLOATING
C5720 a_7043_1842# VSS 0.48563f ; **FLOATING
C5721 a_7477_1842# VSS 0.86118f ; **FLOATING
C5722 a_6913_1842# VSS 0.44414f ; **FLOATING
C5723 a_6283_1842# VSS 0.48744f ; **FLOATING
C5724 a_6717_1842# VSS 0.95287f ; **FLOATING
C5725 a_6153_1842# VSS 0.44059f ; **FLOATING
C5726 a_5523_1842# VSS 0.48671f ; **FLOATING
C5727 a_5957_1842# VSS 0.91647f ; **FLOATING
C5728 a_5393_1842# VSS 0.44587f ; **FLOATING
C5729 a_4763_1842# VSS 0.49323f ; **FLOATING
C5730 a_5197_1842# VSS 0.9541f ; **FLOATING
C5731 a_4633_1842# VSS 0.44882f ; **FLOATING
C5732 a_4003_1842# VSS 0.57066f ; **FLOATING
C5733 a_4437_1842# VSS 0.86497f ; **FLOATING
C5734 a_26985_3364# VSS 0.17928f ; **FLOATING
C5735 a_23945_3364# VSS 0.17928f ; **FLOATING
C5736 a_20905_3364# VSS 0.17928f ; **FLOATING
C5737 a_17865_3364# VSS 0.17881f ; **FLOATING
C5738 a_16851_3154# VSS 0.37653f ; **FLOATING
C5739 a_16108_3134# VSS 2.61391f ; **FLOATING
C5740 a_15964_3134# VSS 0.1695f ; **FLOATING
C5741 a_15765_3308# VSS 0.33587f ; **FLOATING
C5742 a_14825_3364# VSS 0.17928f ; **FLOATING
C5743 a_11785_3364# VSS 0.17928f ; **FLOATING
C5744 a_8745_3364# VSS 0.17928f ; **FLOATING
C5745 a_5731_3134# VSS 2.24392f ; **FLOATING
C5746 a_5705_3364# VSS 0.17638f ; **FLOATING
C5747 a_3449_3176# VSS 0.17702f ; **FLOATING
C5748 a_2873_3176# VSS 0.1828f ; **FLOATING
C5749 a_2297_3176# VSS 0.1829f ; **FLOATING
C5750 a_1721_3176# VSS 0.17136f ; **FLOATING
C5751 a_1544_3134# VSS 0.29772f ; **FLOATING
C5752 a_1256_3134# VSS 0.85178f ; **FLOATING
C5753 a_27991_3853# VSS 0.18561f ; **FLOATING
C5754 a_27915_3889# VSS 0.10926f ; **FLOATING
C5755 a_27124_3853# VSS 0.17878f ; **FLOATING
C5756 a_27048_3889# VSS 0.12122f ; **FLOATING
C5757 a_26471_3853# VSS 0.18126f ; **FLOATING
C5758 a_26395_3889# VSS 0.11073f ; **FLOATING
C5759 a_25604_3853# VSS 0.18257f ; **FLOATING
C5760 a_25630_3889# VSS 0.33852f ; **FLOATING
C5761 a_25528_3889# VSS 0.13246f ; **FLOATING
C5762 a_24951_3853# VSS 0.18335f ; **FLOATING
C5763 a_24875_3889# VSS 0.11016f ; **FLOATING
C5764 a_24084_3853# VSS 0.17878f ; **FLOATING
C5765 a_24008_3889# VSS 0.12122f ; **FLOATING
C5766 a_23431_3853# VSS 0.18126f ; **FLOATING
C5767 a_23355_3889# VSS 0.11073f ; **FLOATING
C5768 a_22564_3853# VSS 0.18087f ; **FLOATING
C5769 a_22590_3889# VSS 0.32818f ; **FLOATING
C5770 a_22488_3889# VSS 0.12433f ; **FLOATING
C5771 a_21911_3853# VSS 0.18335f ; **FLOATING
C5772 a_21835_3889# VSS 0.11016f ; **FLOATING
C5773 a_21044_3853# VSS 0.17878f ; **FLOATING
C5774 a_20968_3889# VSS 0.12122f ; **FLOATING
C5775 a_20391_3853# VSS 0.18126f ; **FLOATING
C5776 a_20315_3889# VSS 0.11073f ; **FLOATING
C5777 a_19524_3853# VSS 0.18087f ; **FLOATING
C5778 a_19550_3889# VSS 0.33563f ; **FLOATING
C5779 a_19448_3889# VSS 0.12433f ; **FLOATING
C5780 a_18871_3853# VSS 0.18335f ; **FLOATING
C5781 a_18795_3889# VSS 0.11016f ; **FLOATING
C5782 a_18004_3853# VSS 0.1797f ; **FLOATING
C5783 a_17928_3889# VSS 0.12899f ; **FLOATING
C5784 a_17351_3853# VSS 0.17877f ; **FLOATING
C5785 a_17275_3889# VSS 0.10926f ; **FLOATING
C5786 a_16484_3853# VSS 0.17947f ; **FLOATING
C5787 a_16510_3889# VSS 0.30718f ; **FLOATING
C5788 a_16408_3889# VSS 0.1229f ; **FLOATING
C5789 a_15831_3853# VSS 0.17846f ; **FLOATING
C5790 a_15755_3889# VSS 0.10926f ; **FLOATING
C5791 a_14964_3853# VSS 0.17878f ; **FLOATING
C5792 a_14888_3889# VSS 0.12122f ; **FLOATING
C5793 a_14311_3853# VSS 0.18126f ; **FLOATING
C5794 a_14235_3889# VSS 0.11073f ; **FLOATING
C5795 a_13444_3853# VSS 0.18087f ; **FLOATING
C5796 a_13470_3889# VSS 0.30113f ; **FLOATING
C5797 a_13368_3889# VSS 0.12433f ; **FLOATING
C5798 a_12791_3853# VSS 0.18335f ; **FLOATING
C5799 a_12715_3889# VSS 0.11016f ; **FLOATING
C5800 a_11924_3853# VSS 0.17878f ; **FLOATING
C5801 a_11848_3889# VSS 0.12122f ; **FLOATING
C5802 a_11271_3853# VSS 0.18126f ; **FLOATING
C5803 a_11195_3889# VSS 0.11073f ; **FLOATING
C5804 a_10404_3853# VSS 0.18087f ; **FLOATING
C5805 a_10430_3889# VSS 0.31665f ; **FLOATING
C5806 a_10328_3889# VSS 0.12433f ; **FLOATING
C5807 a_9751_3853# VSS 0.18359f ; **FLOATING
C5808 a_9675_3889# VSS 0.11016f ; **FLOATING
C5809 a_8884_3853# VSS 0.17878f ; **FLOATING
C5810 a_8808_3889# VSS 0.12122f ; **FLOATING
C5811 a_8231_3853# VSS 0.18126f ; **FLOATING
C5812 a_8155_3889# VSS 0.11073f ; **FLOATING
C5813 a_7364_3853# VSS 0.18087f ; **FLOATING
C5814 a_7390_3889# VSS 0.31136f ; **FLOATING
C5815 a_7288_3889# VSS 0.12433f ; **FLOATING
C5816 a_6711_3853# VSS 0.18335f ; **FLOATING
C5817 a_6635_3889# VSS 0.11016f ; **FLOATING
C5818 a_5844_3853# VSS 0.17878f ; **FLOATING
C5819 a_5768_3889# VSS 0.12122f ; **FLOATING
C5820 a_5191_3853# VSS 0.17877f ; **FLOATING
C5821 a_5115_3889# VSS 0.10926f ; **FLOATING
C5822 a_4324_3853# VSS 0.17947f ; **FLOATING
C5823 a_4350_3889# VSS 0.26655f ; **FLOATING
C5824 a_4248_3889# VSS 0.12443f ; **FLOATING
C5825 a_27705_3889# VSS 0.25232f ; **FLOATING
C5826 a_26185_3889# VSS 0.23475f ; **FLOATING
C5827 a_24665_3889# VSS 0.25405f ; **FLOATING
C5828 a_23145_3889# VSS 0.23475f ; **FLOATING
C5829 a_21625_3889# VSS 0.25405f ; **FLOATING
C5830 a_20105_3889# VSS 0.23475f ; **FLOATING
C5831 a_18585_3889# VSS 0.25405f ; **FLOATING
C5832 a_17065_3889# VSS 0.23379f ; **FLOATING
C5833 a_15545_3889# VSS 0.25232f ; **FLOATING
C5834 a_14025_3889# VSS 0.23475f ; **FLOATING
C5835 a_12505_3889# VSS 0.25405f ; **FLOATING
C5836 a_10985_3889# VSS 0.23475f ; **FLOATING
C5837 a_9465_3889# VSS 0.25405f ; **FLOATING
C5838 a_7945_3889# VSS 0.23475f ; **FLOATING
C5839 a_6425_3889# VSS 0.25405f ; **FLOATING
C5840 a_4905_3889# VSS 0.23484f ; **FLOATING
C5841 a_4157_4158# VSS 0.32839f ; **FLOATING
C5842 a_3449_4240# VSS 0.18619f ; **FLOATING
C5843 a_2873_4240# VSS 0.18296f ; **FLOATING
C5844 a_2297_4240# VSS 0.18306f ; **FLOATING
C5845 a_1721_4240# VSS 0.172f ; **FLOATING
C5846 a_1544_3889# VSS 0.29854f ; **FLOATING
C5847 a_1256_3889# VSS 0.85418f ; **FLOATING
C5848 a_27671_4687# VSS 0.01336f ; **FLOATING
C5849 a_26911_4687# VSS 0.01336f ; **FLOATING
C5850 a_26151_4687# VSS 0.01336f ; **FLOATING
C5851 a_25391_4687# VSS 0.01733f ; **FLOATING
C5852 a_24631_4687# VSS 0.01336f ; **FLOATING
C5853 a_23871_4687# VSS 0.01336f ; **FLOATING
C5854 a_23111_4687# VSS 0.01336f ; **FLOATING
C5855 a_22351_4687# VSS 0.01336f ; **FLOATING
C5856 a_21591_4687# VSS 0.01336f ; **FLOATING
C5857 a_20831_4687# VSS 0.01336f ; **FLOATING
C5858 a_20071_4687# VSS 0.01336f ; **FLOATING
C5859 a_19311_4687# VSS 0.01336f ; **FLOATING
C5860 a_18551_4687# VSS 0.01336f ; **FLOATING
C5861 a_17791_4687# VSS 0.01733f ; **FLOATING
C5862 a_17031_4687# VSS 0.01336f ; **FLOATING
C5863 a_16271_4687# VSS 0.01336f ; **FLOATING
C5864 a_15511_4687# VSS 0.01336f ; **FLOATING
C5865 a_14751_4687# VSS 0.01336f ; **FLOATING
C5866 a_13991_4687# VSS 0.01336f ; **FLOATING
C5867 a_13231_4687# VSS 0.01336f ; **FLOATING
C5868 a_12471_4687# VSS 0.01336f ; **FLOATING
C5869 a_11711_4687# VSS 0.01336f ; **FLOATING
C5870 a_10951_4687# VSS 0.01336f ; **FLOATING
C5871 a_10191_4687# VSS 0.01733f ; **FLOATING
C5872 a_9431_4687# VSS 0.01336f ; **FLOATING
C5873 a_8671_4687# VSS 0.01336f ; **FLOATING
C5874 a_7911_4687# VSS 0.01336f ; **FLOATING
C5875 a_7151_4687# VSS 0.01336f ; **FLOATING
C5876 a_6391_4687# VSS 0.01336f ; **FLOATING
C5877 a_5631_4687# VSS 0.01336f ; **FLOATING
C5878 a_4871_4687# VSS 0.01336f ; **FLOATING
C5879 a_4111_4687# VSS 0.0139f ; **FLOATING
C5880 a_27563_4687# VSS 0.49473f ; **FLOATING
C5881 a_27997_4687# VSS 0.64441f ; **FLOATING
C5882 a_27433_4687# VSS 0.44435f ; **FLOATING
C5883 a_26803_4687# VSS 0.4868f ; **FLOATING
C5884 a_27237_4687# VSS 0.92283f ; **FLOATING
C5885 a_26673_4687# VSS 0.44356f ; **FLOATING
C5886 a_26043_4687# VSS 0.48789f ; **FLOATING
C5887 a_26477_4687# VSS 0.95165f ; **FLOATING
C5888 a_25913_4687# VSS 0.44813f ; **FLOATING
C5889 a_25283_4687# VSS 0.96055f ; **FLOATING
C5890 a_25717_4687# VSS 0.97119f ; **FLOATING
C5891 a_25153_4687# VSS 0.56638f ; **FLOATING
C5892 a_24523_4687# VSS 0.47217f ; **FLOATING
C5893 a_24957_4687# VSS 1.11567f ; **FLOATING
C5894 a_24393_4687# VSS 0.43117f ; **FLOATING
C5895 a_23763_4687# VSS 0.48642f ; **FLOATING
C5896 a_24197_4687# VSS 0.91099f ; **FLOATING
C5897 a_23633_4687# VSS 0.4435f ; **FLOATING
C5898 a_23003_4687# VSS 0.48774f ; **FLOATING
C5899 a_23437_4687# VSS 0.95122f ; **FLOATING
C5900 a_22873_4687# VSS 0.44619f ; **FLOATING
C5901 a_22243_4687# VSS 0.48565f ; **FLOATING
C5902 a_22677_4687# VSS 0.86086f ; **FLOATING
C5903 a_22113_4687# VSS 0.44414f ; **FLOATING
C5904 a_21483_4687# VSS 0.48744f ; **FLOATING
C5905 a_21917_4687# VSS 0.95513f ; **FLOATING
C5906 a_21353_4687# VSS 0.44136f ; **FLOATING
C5907 a_20723_4687# VSS 0.48671f ; **FLOATING
C5908 a_21157_4687# VSS 0.91814f ; **FLOATING
C5909 a_20593_4687# VSS 0.44348f ; **FLOATING
C5910 a_19963_4687# VSS 0.48774f ; **FLOATING
C5911 a_20397_4687# VSS 0.95122f ; **FLOATING
C5912 a_19833_4687# VSS 0.44619f ; **FLOATING
C5913 a_19203_4687# VSS 0.48566f ; **FLOATING
C5914 a_19637_4687# VSS 0.86088f ; **FLOATING
C5915 a_19073_4687# VSS 0.4442f ; **FLOATING
C5916 a_18443_4687# VSS 0.48753f ; **FLOATING
C5917 a_18877_4687# VSS 0.95528f ; **FLOATING
C5918 a_18313_4687# VSS 0.44124f ; **FLOATING
C5919 a_17683_4687# VSS 0.93629f ; **FLOATING
C5920 a_18117_4687# VSS 0.96881f ; **FLOATING
C5921 a_17553_4687# VSS 0.60625f ; **FLOATING
C5922 a_16923_4687# VSS 0.49071f ; **FLOATING
C5923 a_17357_4687# VSS 1.12977f ; **FLOATING
C5924 a_16793_4687# VSS 0.44263f ; **FLOATING
C5925 a_16163_4687# VSS 0.46958f ; **FLOATING
C5926 a_16597_4687# VSS 0.84991f ; **FLOATING
C5927 a_16033_4687# VSS 0.43619f ; **FLOATING
C5928 a_15403_4687# VSS 0.48909f ; **FLOATING
C5929 a_15837_4687# VSS 0.94699f ; **FLOATING
C5930 a_15273_4687# VSS 0.44136f ; **FLOATING
C5931 a_14643_4687# VSS 0.48671f ; **FLOATING
C5932 a_15077_4687# VSS 0.91634f ; **FLOATING
C5933 a_14513_4687# VSS 0.44348f ; **FLOATING
C5934 a_13883_4687# VSS 0.48774f ; **FLOATING
C5935 a_14317_4687# VSS 0.95122f ; **FLOATING
C5936 a_13753_4687# VSS 0.44619f ; **FLOATING
C5937 a_13123_4687# VSS 0.48563f ; **FLOATING
C5938 a_13557_4687# VSS 0.86086f ; **FLOATING
C5939 a_12993_4687# VSS 0.44414f ; **FLOATING
C5940 a_12363_4687# VSS 0.48744f ; **FLOATING
C5941 a_12797_4687# VSS 0.95346f ; **FLOATING
C5942 a_12233_4687# VSS 0.44136f ; **FLOATING
C5943 a_11603_4687# VSS 0.48672f ; **FLOATING
C5944 a_12037_4687# VSS 0.91814f ; **FLOATING
C5945 a_11473_4687# VSS 0.44354f ; **FLOATING
C5946 a_10843_4687# VSS 0.48784f ; **FLOATING
C5947 a_11277_4687# VSS 0.95135f ; **FLOATING
C5948 a_10713_4687# VSS 0.44684f ; **FLOATING
C5949 a_10083_4687# VSS 0.9169f ; **FLOATING
C5950 a_10517_4687# VSS 0.87062f ; **FLOATING
C5951 a_9953_4687# VSS 0.70713f ; **FLOATING
C5952 a_9323_4687# VSS 0.48995f ; **FLOATING
C5953 a_9757_4687# VSS 1.31734f ; **FLOATING
C5954 a_9193_4687# VSS 0.44151f ; **FLOATING
C5955 a_8563_4687# VSS 0.46677f ; **FLOATING
C5956 a_8997_4687# VSS 0.91591f ; **FLOATING
C5957 a_8433_4687# VSS 0.44288f ; **FLOATING
C5958 a_7803_4687# VSS 0.48776f ; **FLOATING
C5959 a_8237_4687# VSS 0.95126f ; **FLOATING
C5960 a_7673_4687# VSS 0.44619f ; **FLOATING
C5961 a_7043_4687# VSS 0.48563f ; **FLOATING
C5962 a_7477_4687# VSS 0.86086f ; **FLOATING
C5963 a_6913_4687# VSS 0.44414f ; **FLOATING
C5964 a_6283_4687# VSS 0.48744f ; **FLOATING
C5965 a_6717_4687# VSS 0.95287f ; **FLOATING
C5966 a_6153_4687# VSS 0.44059f ; **FLOATING
C5967 a_5523_4687# VSS 0.48671f ; **FLOATING
C5968 a_5957_4687# VSS 0.91534f ; **FLOATING
C5969 a_5393_4687# VSS 0.44587f ; **FLOATING
C5970 a_4763_4687# VSS 0.49323f ; **FLOATING
C5971 a_5197_4687# VSS 0.95402f ; **FLOATING
C5972 a_4633_4687# VSS 0.44882f ; **FLOATING
C5973 a_4003_4687# VSS 0.57066f ; **FLOATING
C5974 a_4437_4687# VSS 0.86317f ; **FLOATING
C5975 a_26985_6209# VSS 0.17928f ; **FLOATING
C5976 a_23945_6209# VSS 0.17928f ; **FLOATING
C5977 a_20905_6209# VSS 0.17928f ; **FLOATING
C5978 a_17865_6209# VSS 0.17881f ; **FLOATING
C5979 a_16851_5999# VSS 0.37653f ; **FLOATING
C5980 a_16108_5979# VSS 2.61391f ; **FLOATING
C5981 a_15964_5979# VSS 0.1695f ; **FLOATING
C5982 a_15765_6153# VSS 0.33587f ; **FLOATING
C5983 a_14825_6209# VSS 0.17928f ; **FLOATING
C5984 a_11785_6209# VSS 0.17928f ; **FLOATING
C5985 a_8745_6209# VSS 0.17928f ; **FLOATING
C5986 a_5731_5979# VSS 2.24392f ; **FLOATING
C5987 a_5705_6209# VSS 0.17638f ; **FLOATING
C5988 a_3449_6021# VSS 0.17702f ; **FLOATING
C5989 a_2873_6021# VSS 0.1828f ; **FLOATING
C5990 a_2297_6021# VSS 0.1829f ; **FLOATING
C5991 a_1721_6021# VSS 0.17136f ; **FLOATING
C5992 a_1544_5979# VSS 0.29772f ; **FLOATING
C5993 a_1256_5979# VSS 0.85178f ; **FLOATING
C5994 a_27991_6698# VSS 0.18561f ; **FLOATING
C5995 a_27915_6734# VSS 0.10926f ; **FLOATING
C5996 a_27124_6698# VSS 0.17878f ; **FLOATING
C5997 a_27048_6734# VSS 0.12122f ; **FLOATING
C5998 a_26471_6698# VSS 0.18126f ; **FLOATING
C5999 a_26395_6734# VSS 0.11073f ; **FLOATING
C6000 a_25604_6698# VSS 0.18257f ; **FLOATING
C6001 a_25630_6734# VSS 0.33852f ; **FLOATING
C6002 a_25528_6734# VSS 0.13246f ; **FLOATING
C6003 a_24951_6698# VSS 0.18335f ; **FLOATING
C6004 a_24875_6734# VSS 0.11016f ; **FLOATING
C6005 a_24084_6698# VSS 0.17878f ; **FLOATING
C6006 a_24008_6734# VSS 0.12122f ; **FLOATING
C6007 a_23431_6698# VSS 0.18126f ; **FLOATING
C6008 a_23355_6734# VSS 0.11073f ; **FLOATING
C6009 a_22564_6698# VSS 0.18087f ; **FLOATING
C6010 a_22590_6734# VSS 0.32818f ; **FLOATING
C6011 a_22488_6734# VSS 0.12433f ; **FLOATING
C6012 a_21911_6698# VSS 0.18335f ; **FLOATING
C6013 a_21835_6734# VSS 0.11016f ; **FLOATING
C6014 a_21044_6698# VSS 0.17878f ; **FLOATING
C6015 a_20968_6734# VSS 0.12122f ; **FLOATING
C6016 a_20391_6698# VSS 0.18126f ; **FLOATING
C6017 a_20315_6734# VSS 0.11073f ; **FLOATING
C6018 a_19524_6698# VSS 0.18087f ; **FLOATING
C6019 a_19550_6734# VSS 0.33563f ; **FLOATING
C6020 a_19448_6734# VSS 0.12433f ; **FLOATING
C6021 a_18871_6698# VSS 0.18335f ; **FLOATING
C6022 a_18795_6734# VSS 0.11016f ; **FLOATING
C6023 a_18004_6698# VSS 0.1797f ; **FLOATING
C6024 a_17928_6734# VSS 0.12899f ; **FLOATING
C6025 a_17351_6698# VSS 0.17877f ; **FLOATING
C6026 a_17275_6734# VSS 0.10926f ; **FLOATING
C6027 a_16484_6698# VSS 0.17947f ; **FLOATING
C6028 a_16510_6734# VSS 0.30718f ; **FLOATING
C6029 a_16408_6734# VSS 0.1229f ; **FLOATING
C6030 a_15831_6698# VSS 0.17846f ; **FLOATING
C6031 a_15755_6734# VSS 0.10926f ; **FLOATING
C6032 a_14964_6698# VSS 0.17878f ; **FLOATING
C6033 a_14888_6734# VSS 0.12122f ; **FLOATING
C6034 a_14311_6698# VSS 0.18126f ; **FLOATING
C6035 a_14235_6734# VSS 0.11073f ; **FLOATING
C6036 a_13444_6698# VSS 0.18087f ; **FLOATING
C6037 a_13470_6734# VSS 0.30113f ; **FLOATING
C6038 a_13368_6734# VSS 0.12433f ; **FLOATING
C6039 a_12791_6698# VSS 0.18335f ; **FLOATING
C6040 a_12715_6734# VSS 0.11016f ; **FLOATING
C6041 a_11924_6698# VSS 0.17878f ; **FLOATING
C6042 a_11848_6734# VSS 0.12122f ; **FLOATING
C6043 a_11271_6698# VSS 0.18126f ; **FLOATING
C6044 a_11195_6734# VSS 0.11073f ; **FLOATING
C6045 a_10404_6698# VSS 0.18087f ; **FLOATING
C6046 a_10430_6734# VSS 0.31665f ; **FLOATING
C6047 a_10328_6734# VSS 0.12433f ; **FLOATING
C6048 a_9751_6698# VSS 0.18359f ; **FLOATING
C6049 a_9675_6734# VSS 0.11016f ; **FLOATING
C6050 a_8884_6698# VSS 0.17878f ; **FLOATING
C6051 a_8808_6734# VSS 0.12122f ; **FLOATING
C6052 a_8231_6698# VSS 0.18126f ; **FLOATING
C6053 a_8155_6734# VSS 0.11073f ; **FLOATING
C6054 a_7364_6698# VSS 0.18087f ; **FLOATING
C6055 a_7390_6734# VSS 0.31136f ; **FLOATING
C6056 a_7288_6734# VSS 0.12433f ; **FLOATING
C6057 a_6711_6698# VSS 0.18335f ; **FLOATING
C6058 a_6635_6734# VSS 0.11016f ; **FLOATING
C6059 a_5844_6698# VSS 0.17878f ; **FLOATING
C6060 a_5768_6734# VSS 0.12122f ; **FLOATING
C6061 a_5191_6698# VSS 0.17877f ; **FLOATING
C6062 a_5115_6734# VSS 0.10926f ; **FLOATING
C6063 a_4324_6698# VSS 0.17947f ; **FLOATING
C6064 a_4350_6734# VSS 0.26655f ; **FLOATING
C6065 a_4248_6734# VSS 0.12443f ; **FLOATING
C6066 a_27705_6734# VSS 0.25231f ; **FLOATING
C6067 a_26185_6734# VSS 0.23475f ; **FLOATING
C6068 a_24665_6734# VSS 0.25433f ; **FLOATING
C6069 a_23145_6734# VSS 0.23475f ; **FLOATING
C6070 a_21625_6734# VSS 0.25433f ; **FLOATING
C6071 a_20105_6734# VSS 0.23475f ; **FLOATING
C6072 a_18585_6734# VSS 0.25433f ; **FLOATING
C6073 a_17065_6734# VSS 0.23378f ; **FLOATING
C6074 a_15545_6734# VSS 0.25231f ; **FLOATING
C6075 a_14025_6734# VSS 0.23475f ; **FLOATING
C6076 a_12505_6734# VSS 0.25433f ; **FLOATING
C6077 a_10985_6734# VSS 0.23475f ; **FLOATING
C6078 a_9465_6734# VSS 0.25433f ; **FLOATING
C6079 a_7945_6734# VSS 0.23475f ; **FLOATING
C6080 a_6425_6734# VSS 0.25433f ; **FLOATING
C6081 a_4905_6734# VSS 0.23483f ; **FLOATING
C6082 a_4157_7003# VSS 0.32839f ; **FLOATING
C6083 a_3449_7085# VSS 0.18629f ; **FLOATING
C6084 a_2873_7085# VSS 0.18349f ; **FLOATING
C6085 a_2297_7085# VSS 0.18359f ; **FLOATING
C6086 a_1721_7085# VSS 0.17253f ; **FLOATING
C6087 a_1544_6734# VSS 0.29907f ; **FLOATING
C6088 a_1256_6734# VSS 0.86052f ; **FLOATING
C6089 a_27671_7532# VSS 0.01336f ; **FLOATING
C6090 a_26911_7532# VSS 0.01336f ; **FLOATING
C6091 a_26151_7532# VSS 0.01336f ; **FLOATING
C6092 a_25391_7532# VSS 0.01733f ; **FLOATING
C6093 a_24631_7532# VSS 0.01336f ; **FLOATING
C6094 a_23871_7532# VSS 0.01336f ; **FLOATING
C6095 a_23111_7532# VSS 0.01336f ; **FLOATING
C6096 a_22351_7532# VSS 0.01336f ; **FLOATING
C6097 a_21591_7532# VSS 0.01336f ; **FLOATING
C6098 a_20831_7532# VSS 0.01336f ; **FLOATING
C6099 a_20071_7532# VSS 0.01336f ; **FLOATING
C6100 a_19311_7532# VSS 0.01336f ; **FLOATING
C6101 a_18551_7532# VSS 0.01336f ; **FLOATING
C6102 a_17791_7532# VSS 0.01733f ; **FLOATING
C6103 a_17031_7532# VSS 0.01336f ; **FLOATING
C6104 a_16271_7532# VSS 0.01336f ; **FLOATING
C6105 a_15511_7532# VSS 0.01336f ; **FLOATING
C6106 a_14751_7532# VSS 0.01336f ; **FLOATING
C6107 a_13991_7532# VSS 0.01336f ; **FLOATING
C6108 a_13231_7532# VSS 0.01336f ; **FLOATING
C6109 a_12471_7532# VSS 0.01336f ; **FLOATING
C6110 a_11711_7532# VSS 0.01336f ; **FLOATING
C6111 a_10951_7532# VSS 0.01336f ; **FLOATING
C6112 a_10191_7532# VSS 0.01733f ; **FLOATING
C6113 a_9431_7532# VSS 0.01336f ; **FLOATING
C6114 a_8671_7532# VSS 0.01336f ; **FLOATING
C6115 a_7911_7532# VSS 0.01336f ; **FLOATING
C6116 a_7151_7532# VSS 0.01336f ; **FLOATING
C6117 a_6391_7532# VSS 0.01336f ; **FLOATING
C6118 a_5631_7532# VSS 0.01336f ; **FLOATING
C6119 a_4871_7532# VSS 0.01336f ; **FLOATING
C6120 a_4111_7532# VSS 0.0139f ; **FLOATING
C6121 a_27563_7532# VSS 0.50316f ; **FLOATING
C6122 a_27997_7532# VSS 0.6484f ; **FLOATING
C6123 a_27433_7532# VSS 0.44631f ; **FLOATING
C6124 a_26803_7532# VSS 0.49938f ; **FLOATING
C6125 a_27237_7532# VSS 0.92793f ; **FLOATING
C6126 a_26673_7532# VSS 0.44928f ; **FLOATING
C6127 a_26043_7532# VSS 0.50183f ; **FLOATING
C6128 a_26477_7532# VSS 0.95962f ; **FLOATING
C6129 a_25913_7532# VSS 0.45274f ; **FLOATING
C6130 a_25283_7532# VSS 0.96338f ; **FLOATING
C6131 a_25717_7532# VSS 0.96691f ; **FLOATING
C6132 a_25153_7532# VSS 0.57259f ; **FLOATING
C6133 a_24523_7532# VSS 0.48419f ; **FLOATING
C6134 a_24957_7532# VSS 1.12395f ; **FLOATING
C6135 a_24393_7532# VSS 0.42956f ; **FLOATING
C6136 a_23763_7532# VSS 0.4977f ; **FLOATING
C6137 a_24197_7532# VSS 0.91041f ; **FLOATING
C6138 a_23633_7532# VSS 0.45063f ; **FLOATING
C6139 a_23003_7532# VSS 0.50169f ; **FLOATING
C6140 a_23437_7532# VSS 0.95761f ; **FLOATING
C6141 a_22873_7532# VSS 0.4508f ; **FLOATING
C6142 a_22243_7532# VSS 0.49938f ; **FLOATING
C6143 a_22677_7532# VSS 0.86809f ; **FLOATING
C6144 a_22113_7532# VSS 0.45249f ; **FLOATING
C6145 a_21483_7532# VSS 0.50075f ; **FLOATING
C6146 a_21917_7532# VSS 0.96341f ; **FLOATING
C6147 a_21353_7532# VSS 0.4463f ; **FLOATING
C6148 a_20723_7532# VSS 0.49992f ; **FLOATING
C6149 a_21157_7532# VSS 0.92429f ; **FLOATING
C6150 a_20593_7532# VSS 0.45196f ; **FLOATING
C6151 a_19963_7532# VSS 0.50169f ; **FLOATING
C6152 a_20397_7532# VSS 0.95761f ; **FLOATING
C6153 a_19833_7532# VSS 0.4508f ; **FLOATING
C6154 a_19203_7532# VSS 0.50051f ; **FLOATING
C6155 a_19637_7532# VSS 0.86811f ; **FLOATING
C6156 a_19073_7532# VSS 0.44953f ; **FLOATING
C6157 a_18443_7532# VSS 0.50084f ; **FLOATING
C6158 a_18877_7532# VSS 0.96357f ; **FLOATING
C6159 a_18313_7532# VSS 0.44695f ; **FLOATING
C6160 a_17683_7532# VSS 0.93681f ; **FLOATING
C6161 a_18117_7532# VSS 0.97776f ; **FLOATING
C6162 a_17553_7532# VSS 0.59872f ; **FLOATING
C6163 a_16923_7532# VSS 0.50246f ; **FLOATING
C6164 a_17357_7532# VSS 1.13534f ; **FLOATING
C6165 a_16793_7532# VSS 0.44734f ; **FLOATING
C6166 a_16163_7532# VSS 0.47058f ; **FLOATING
C6167 a_16597_7532# VSS 0.84935f ; **FLOATING
C6168 a_16033_7532# VSS 0.44557f ; **FLOATING
C6169 a_15403_7532# VSS 0.49465f ; **FLOATING
C6170 a_15837_7532# VSS 0.95171f ; **FLOATING
C6171 a_15273_7532# VSS 0.44439f ; **FLOATING
C6172 a_14643_7532# VSS 0.49305f ; **FLOATING
C6173 a_15077_7532# VSS 0.91936f ; **FLOATING
C6174 a_14513_7532# VSS 0.44501f ; **FLOATING
C6175 a_13883_7532# VSS 0.50862f ; **FLOATING
C6176 a_14317_7532# VSS 0.96f ; **FLOATING
C6177 a_13753_7532# VSS 0.46427f ; **FLOATING
C6178 a_13123_7532# VSS 0.50173f ; **FLOATING
C6179 a_13557_7532# VSS 0.87556f ; **FLOATING
C6180 a_12993_7532# VSS 0.45643f ; **FLOATING
C6181 a_12363_7532# VSS 0.50854f ; **FLOATING
C6182 a_12797_7532# VSS 0.96142f ; **FLOATING
C6183 a_12233_7532# VSS 0.45757f ; **FLOATING
C6184 a_11603_7532# VSS 0.50268f ; **FLOATING
C6185 a_12037_7532# VSS 0.92753f ; **FLOATING
C6186 a_11473_7532# VSS 0.45182f ; **FLOATING
C6187 a_10843_7532# VSS 0.505f ; **FLOATING
C6188 a_11277_7532# VSS 0.96057f ; **FLOATING
C6189 a_10713_7532# VSS 0.44965f ; **FLOATING
C6190 a_10083_7532# VSS 0.9252f ; **FLOATING
C6191 a_10517_7532# VSS 0.87997f ; **FLOATING
C6192 a_9953_7532# VSS 0.69129f ; **FLOATING
C6193 a_9323_7532# VSS 0.50511f ; **FLOATING
C6194 a_9757_7532# VSS 1.3217f ; **FLOATING
C6195 a_9193_7532# VSS 0.44376f ; **FLOATING
C6196 a_8563_7532# VSS 0.46642f ; **FLOATING
C6197 a_8997_7532# VSS 0.91716f ; **FLOATING
C6198 a_8433_7532# VSS 0.44379f ; **FLOATING
C6199 a_7803_7532# VSS 0.49437f ; **FLOATING
C6200 a_8237_7532# VSS 0.95417f ; **FLOATING
C6201 a_7673_7532# VSS 0.44737f ; **FLOATING
C6202 a_7043_7532# VSS 0.49204f ; **FLOATING
C6203 a_7477_7532# VSS 0.86461f ; **FLOATING
C6204 a_6913_7532# VSS 0.44442f ; **FLOATING
C6205 a_6283_7532# VSS 0.49343f ; **FLOATING
C6206 a_6717_7532# VSS 0.95763f ; **FLOATING
C6207 a_6153_7532# VSS 0.44292f ; **FLOATING
C6208 a_5523_7532# VSS 0.50322f ; **FLOATING
C6209 a_5957_7532# VSS 0.92533f ; **FLOATING
C6210 a_5393_7532# VSS 0.4596f ; **FLOATING
C6211 a_4763_7532# VSS 0.51043f ; **FLOATING
C6212 a_5197_7532# VSS 0.96501f ; **FLOATING
C6213 a_4633_7532# VSS 0.46282f ; **FLOATING
C6214 a_4003_7532# VSS 0.58808f ; **FLOATING
C6215 a_4437_7532# VSS 0.87448f ; **FLOATING
C6216 a_9712_9602# VSS 1.26241f ; **FLOATING
C6217 a_9444_9602# VSS 2.18725f ; **FLOATING
C6218 a_5778_9057# VSS 5.26045f ; **FLOATING
C6219 a_15464_9374# VSS 0.75391f ; **FLOATING
C6220 a_14757_10872# VSS 0.09495f ; **FLOATING
C6221 a_13880_10808# VSS 0.06985f ; **FLOATING
C6222 a_15688_11093# VSS 0.26291f ; **FLOATING
C6223 a_15108_11015# VSS 0.24458f ; **FLOATING
C6224 a_14851_10872# VSS 0.38123f ; **FLOATING
C6225 a_9444_10280# VSS 6.11161f ; **FLOATING
C6226 a_14111_10917# VSS 0.19866f ; **FLOATING
C6227 a_14009_10774# VSS 0.44622f ; **FLOATING
C6228 a_13592_11113# VSS 1.57456f ; **FLOATING
C6229 a_13306_10795# VSS 0.30095f ; **FLOATING
C6230 a_13566_11018# VSS 0.15441f ; **FLOATING
C6231 a_13132_11110# VSS 0.13036f ; **FLOATING
C6232 a_12907_11110# VSS 0.14379f ; **FLOATING
C6233 a_12907_10876# VSS 0.14787f ; **FLOATING
C6234 a_13106_11047# VSS 0.06341f ; **FLOATING
C6235 a_15304_10295# VSS 0.32071f ; **FLOATING
C6236 a_14757_11918# VSS 0.09586f ; **FLOATING
C6237 a_15688_11557# VSS 0.26296f ; **FLOATING
C6238 a_14851_11918# VSS 0.39011f ; **FLOATING
C6239 a_15108_11799# VSS 0.24509f ; **FLOATING
C6240 a_14111_11568# VSS 0.21578f ; **FLOATING
C6241 a_13880_11982# VSS 0.07345f ; **FLOATING
C6242 a_14009_11568# VSS 0.46644f ; **FLOATING
C6243 a_13592_11561# VSS 1.58178f ; **FLOATING
C6244 a_13566_11525# VSS 0.15442f ; **FLOATING
C6245 a_13045_11905# VSS 0.01124f ; **FLOATING
C6246 a_13306_11995# VSS 0.31701f ; **FLOATING
C6247 a_12849_11557# VSS 1.37418f ; **FLOATING
C6248 a_13121_11521# VSS 0.77226f ; **FLOATING
C6249 a_13019_11521# VSS 1.84445f ; **FLOATING
C6250 a_12656_11554# VSS 0.28138f ; **FLOATING
C6251 a_12355_11557# VSS 0.53943f ; **FLOATING
C6252 a_11397_11918# VSS 0.09495f ; **FLOATING
C6253 a_12158_11557# VSS 0.25842f ; **FLOATING
C6254 a_11491_11918# VSS 0.29538f ; **FLOATING
C6255 a_11748_11799# VSS 0.16909f ; **FLOATING
C6256 a_10751_11568# VSS 0.1982f ; **FLOATING
C6257 a_10520_11982# VSS 0.03671f ; **FLOATING
C6258 a_10649_11568# VSS 0.46311f ; **FLOATING
C6259 a_10232_11561# VSS 1.53233f ; **FLOATING
C6260 a_10206_11525# VSS 0.09081f ; **FLOATING
C6261 a_9946_11995# VSS 0.19792f ; **FLOATING
C6262 a_9772_11533# VSS 0.13527f ; **FLOATING
C6263 a_9746_11495# VSS 0.06443f ; **FLOATING
C6264 a_9547_11862# VSS 0.15766f ; **FLOATING
C6265 a_9547_11632# VSS 0.11843f ; **FLOATING
C6266 a_6854_11144# VSS 3.48691f ; **FLOATING
C6267 a_6126_9506# VSS 13.5683f ; **FLOATING
C6268 a_6854_11676# VSS 1.35244f ; **FLOATING
C6269 a_5974_11413# VSS 2.38934f ; **FLOATING
C6270 a_6326_10280# VSS 0.85322f ; **FLOATING
C6271 a_26985_12701# VSS 0.17928f ; **FLOATING
C6272 a_23945_12701# VSS 0.17928f ; **FLOATING
C6273 a_20905_12701# VSS 0.17928f ; **FLOATING
C6274 a_17865_12701# VSS 0.17881f ; **FLOATING
C6275 a_16851_12491# VSS 0.3805f ; **FLOATING
C6276 a_16108_12471# VSS 3.26027f ; **FLOATING
C6277 a_15964_12471# VSS 0.17082f ; **FLOATING
C6278 a_15765_12645# VSS 0.34456f ; **FLOATING
C6279 a_14825_12701# VSS 0.17928f ; **FLOATING
C6280 a_11785_12701# VSS 0.17928f ; **FLOATING
C6281 a_8745_12701# VSS 0.17928f ; **FLOATING
C6282 a_5731_12471# VSS 2.66204f ; **FLOATING
C6283 a_5705_12701# VSS 0.17638f ; **FLOATING
C6284 a_3449_12513# VSS 0.18479f ; **FLOATING
C6285 a_2873_12513# VSS 0.18322f ; **FLOATING
C6286 a_2297_12513# VSS 0.18332f ; **FLOATING
C6287 a_1721_12513# VSS 0.17179f ; **FLOATING
C6288 a_1544_12471# VSS 0.29908f ; **FLOATING
C6289 a_1256_12471# VSS 0.86127f ; **FLOATING
C6290 a_27991_13190# VSS 0.18558f ; **FLOATING
C6291 a_27915_13226# VSS 0.10926f ; **FLOATING
C6292 a_27124_13190# VSS 0.17878f ; **FLOATING
C6293 a_27048_13226# VSS 0.12122f ; **FLOATING
C6294 a_26471_13190# VSS 0.18115f ; **FLOATING
C6295 a_26395_13226# VSS 0.11073f ; **FLOATING
C6296 a_25604_13190# VSS 0.18257f ; **FLOATING
C6297 a_25630_13226# VSS 0.3731f ; **FLOATING
C6298 a_25528_13226# VSS 0.13246f ; **FLOATING
C6299 a_24951_13190# VSS 0.18335f ; **FLOATING
C6300 a_24875_13226# VSS 0.11016f ; **FLOATING
C6301 a_24084_13190# VSS 0.17878f ; **FLOATING
C6302 a_24008_13226# VSS 0.12122f ; **FLOATING
C6303 a_23431_13190# VSS 0.18104f ; **FLOATING
C6304 a_23355_13226# VSS 0.11073f ; **FLOATING
C6305 a_22564_13190# VSS 0.18087f ; **FLOATING
C6306 a_22590_13226# VSS 0.32818f ; **FLOATING
C6307 a_22488_13226# VSS 0.12433f ; **FLOATING
C6308 a_21911_13190# VSS 0.18335f ; **FLOATING
C6309 a_21835_13226# VSS 0.11016f ; **FLOATING
C6310 a_21044_13190# VSS 0.17878f ; **FLOATING
C6311 a_20968_13226# VSS 0.12122f ; **FLOATING
C6312 a_20391_13190# VSS 0.18104f ; **FLOATING
C6313 a_20315_13226# VSS 0.11073f ; **FLOATING
C6314 a_19524_13190# VSS 0.18087f ; **FLOATING
C6315 a_19550_13226# VSS 0.33563f ; **FLOATING
C6316 a_19448_13226# VSS 0.12433f ; **FLOATING
C6317 a_18871_13190# VSS 0.18335f ; **FLOATING
C6318 a_18795_13226# VSS 0.11016f ; **FLOATING
C6319 a_18004_13190# VSS 0.1797f ; **FLOATING
C6320 a_17928_13226# VSS 0.12899f ; **FLOATING
C6321 a_17351_13190# VSS 0.17808f ; **FLOATING
C6322 a_17275_13226# VSS 0.10926f ; **FLOATING
C6323 a_16484_13190# VSS 0.17809f ; **FLOATING
C6324 a_16510_13226# VSS 0.30718f ; **FLOATING
C6325 a_16408_13226# VSS 0.1229f ; **FLOATING
C6326 a_15831_13190# VSS 0.17846f ; **FLOATING
C6327 a_15755_13226# VSS 0.10926f ; **FLOATING
C6328 a_14964_13190# VSS 0.17878f ; **FLOATING
C6329 a_14888_13226# VSS 0.12122f ; **FLOATING
C6330 a_14311_13190# VSS 0.18138f ; **FLOATING
C6331 a_14235_13226# VSS 0.11073f ; **FLOATING
C6332 a_13444_13190# VSS 0.18087f ; **FLOATING
C6333 a_13470_13226# VSS 0.30113f ; **FLOATING
C6334 a_13368_13226# VSS 0.12433f ; **FLOATING
C6335 a_12791_13190# VSS 0.18335f ; **FLOATING
C6336 a_12715_13226# VSS 0.11016f ; **FLOATING
C6337 a_11924_13190# VSS 0.17878f ; **FLOATING
C6338 a_11848_13226# VSS 0.12122f ; **FLOATING
C6339 a_11271_13190# VSS 0.18178f ; **FLOATING
C6340 a_11195_13226# VSS 0.11073f ; **FLOATING
C6341 a_10404_13190# VSS 0.18087f ; **FLOATING
C6342 a_10430_13226# VSS 0.31665f ; **FLOATING
C6343 a_10328_13226# VSS 0.12433f ; **FLOATING
C6344 a_9751_13190# VSS 0.18359f ; **FLOATING
C6345 a_9675_13226# VSS 0.11016f ; **FLOATING
C6346 a_8884_13190# VSS 0.17878f ; **FLOATING
C6347 a_8808_13226# VSS 0.12122f ; **FLOATING
C6348 a_8231_13190# VSS 0.1809f ; **FLOATING
C6349 a_8155_13226# VSS 0.11073f ; **FLOATING
C6350 a_7364_13190# VSS 0.18087f ; **FLOATING
C6351 a_7390_13226# VSS 0.31136f ; **FLOATING
C6352 a_7288_13226# VSS 0.12433f ; **FLOATING
C6353 a_6711_13190# VSS 0.18335f ; **FLOATING
C6354 a_6635_13226# VSS 0.11016f ; **FLOATING
C6355 a_5844_13190# VSS 0.17878f ; **FLOATING
C6356 a_5768_13226# VSS 0.12122f ; **FLOATING
C6357 a_5191_13190# VSS 0.18022f ; **FLOATING
C6358 a_5115_13226# VSS 0.10926f ; **FLOATING
C6359 a_4324_13190# VSS 0.18023f ; **FLOATING
C6360 a_4350_13226# VSS 0.26655f ; **FLOATING
C6361 a_4248_13226# VSS 0.12443f ; **FLOATING
C6362 a_27705_13226# VSS 0.25204f ; **FLOATING
C6363 a_26185_13226# VSS 0.23475f ; **FLOATING
C6364 a_24665_13226# VSS 0.25405f ; **FLOATING
C6365 a_23145_13226# VSS 0.23475f ; **FLOATING
C6366 a_21625_13226# VSS 0.25405f ; **FLOATING
C6367 a_20105_13226# VSS 0.23475f ; **FLOATING
C6368 a_18585_13226# VSS 0.25405f ; **FLOATING
C6369 a_17065_13226# VSS 0.23373f ; **FLOATING
C6370 a_15545_13226# VSS 0.25216f ; **FLOATING
C6371 a_14025_13226# VSS 0.23475f ; **FLOATING
C6372 a_12505_13226# VSS 0.25405f ; **FLOATING
C6373 a_10985_13226# VSS 0.23475f ; **FLOATING
C6374 a_9465_13226# VSS 0.25405f ; **FLOATING
C6375 a_7945_13226# VSS 0.23475f ; **FLOATING
C6376 a_6425_13226# VSS 0.25405f ; **FLOATING
C6377 a_4905_13226# VSS 0.2355f ; **FLOATING
C6378 a_4157_13495# VSS 0.32875f ; **FLOATING
C6379 a_3449_13577# VSS 0.18619f ; **FLOATING
C6380 a_2873_13577# VSS 0.18296f ; **FLOATING
C6381 a_2297_13577# VSS 0.18306f ; **FLOATING
C6382 a_1721_13577# VSS 0.172f ; **FLOATING
C6383 a_1544_13226# VSS 0.29854f ; **FLOATING
C6384 a_1256_13226# VSS 0.85418f ; **FLOATING
C6385 a_27671_14024# VSS 0.01336f ; **FLOATING
C6386 a_26911_14024# VSS 0.01336f ; **FLOATING
C6387 a_26151_14024# VSS 0.01336f ; **FLOATING
C6388 a_25391_14024# VSS 0.01733f ; **FLOATING
C6389 a_24631_14024# VSS 0.01336f ; **FLOATING
C6390 a_23871_14024# VSS 0.01336f ; **FLOATING
C6391 a_23111_14024# VSS 0.01336f ; **FLOATING
C6392 a_22351_14024# VSS 0.01336f ; **FLOATING
C6393 a_21591_14024# VSS 0.01336f ; **FLOATING
C6394 a_20831_14024# VSS 0.01336f ; **FLOATING
C6395 a_20071_14024# VSS 0.01336f ; **FLOATING
C6396 a_19311_14024# VSS 0.01336f ; **FLOATING
C6397 a_18551_14024# VSS 0.01336f ; **FLOATING
C6398 a_17791_14024# VSS 0.01733f ; **FLOATING
C6399 a_17031_14024# VSS 0.01336f ; **FLOATING
C6400 a_16271_14024# VSS 0.01336f ; **FLOATING
C6401 a_15511_14024# VSS 0.01336f ; **FLOATING
C6402 a_14751_14024# VSS 0.01336f ; **FLOATING
C6403 a_13991_14024# VSS 0.01336f ; **FLOATING
C6404 a_13231_14024# VSS 0.01336f ; **FLOATING
C6405 a_12471_14024# VSS 0.01336f ; **FLOATING
C6406 a_11711_14024# VSS 0.01336f ; **FLOATING
C6407 a_10951_14024# VSS 0.01336f ; **FLOATING
C6408 a_10191_14024# VSS 0.01733f ; **FLOATING
C6409 a_9431_14024# VSS 0.01336f ; **FLOATING
C6410 a_8671_14024# VSS 0.01336f ; **FLOATING
C6411 a_7911_14024# VSS 0.01336f ; **FLOATING
C6412 a_7151_14024# VSS 0.01336f ; **FLOATING
C6413 a_6391_14024# VSS 0.01336f ; **FLOATING
C6414 a_5631_14024# VSS 0.01336f ; **FLOATING
C6415 a_4871_14024# VSS 0.01336f ; **FLOATING
C6416 a_4111_14024# VSS 0.0139f ; **FLOATING
C6417 a_27563_14024# VSS 0.49473f ; **FLOATING
C6418 a_27997_14024# VSS 0.64441f ; **FLOATING
C6419 a_27433_14024# VSS 0.44435f ; **FLOATING
C6420 a_26803_14024# VSS 0.4868f ; **FLOATING
C6421 a_27237_14024# VSS 0.92251f ; **FLOATING
C6422 a_26673_14024# VSS 0.44356f ; **FLOATING
C6423 a_26043_14024# VSS 0.48789f ; **FLOATING
C6424 a_26477_14024# VSS 0.95142f ; **FLOATING
C6425 a_25913_14024# VSS 0.44813f ; **FLOATING
C6426 a_25283_14024# VSS 0.96055f ; **FLOATING
C6427 a_25717_14024# VSS 0.97124f ; **FLOATING
C6428 a_25153_14024# VSS 0.56638f ; **FLOATING
C6429 a_24523_14024# VSS 0.47217f ; **FLOATING
C6430 a_24957_14024# VSS 1.11567f ; **FLOATING
C6431 a_24393_14024# VSS 0.43117f ; **FLOATING
C6432 a_23763_14024# VSS 0.48642f ; **FLOATING
C6433 a_24197_14024# VSS 0.91053f ; **FLOATING
C6434 a_23633_14024# VSS 0.4435f ; **FLOATING
C6435 a_23003_14024# VSS 0.48774f ; **FLOATING
C6436 a_23437_14024# VSS 0.951f ; **FLOATING
C6437 a_22873_14024# VSS 0.44619f ; **FLOATING
C6438 a_22243_14024# VSS 0.48565f ; **FLOATING
C6439 a_22677_14024# VSS 0.86092f ; **FLOATING
C6440 a_22113_14024# VSS 0.44414f ; **FLOATING
C6441 a_21483_14024# VSS 0.48744f ; **FLOATING
C6442 a_21917_14024# VSS 0.95513f ; **FLOATING
C6443 a_21353_14024# VSS 0.44136f ; **FLOATING
C6444 a_20723_14024# VSS 0.48671f ; **FLOATING
C6445 a_21157_14024# VSS 0.91769f ; **FLOATING
C6446 a_20593_14024# VSS 0.44348f ; **FLOATING
C6447 a_19963_14024# VSS 0.48774f ; **FLOATING
C6448 a_20397_14024# VSS 0.951f ; **FLOATING
C6449 a_19833_14024# VSS 0.44619f ; **FLOATING
C6450 a_19203_14024# VSS 0.48566f ; **FLOATING
C6451 a_19637_14024# VSS 0.86093f ; **FLOATING
C6452 a_19073_14024# VSS 0.4442f ; **FLOATING
C6453 a_18443_14024# VSS 0.48753f ; **FLOATING
C6454 a_18877_14024# VSS 0.95528f ; **FLOATING
C6455 a_18313_14024# VSS 0.44124f ; **FLOATING
C6456 a_17683_14024# VSS 0.93629f ; **FLOATING
C6457 a_18117_14024# VSS 0.96835f ; **FLOATING
C6458 a_17553_14024# VSS 0.60625f ; **FLOATING
C6459 a_16923_14024# VSS 0.49071f ; **FLOATING
C6460 a_17357_14024# VSS 1.12991f ; **FLOATING
C6461 a_16793_14024# VSS 0.44263f ; **FLOATING
C6462 a_16163_14024# VSS 0.46958f ; **FLOATING
C6463 a_16597_14024# VSS 0.85002f ; **FLOATING
C6464 a_16033_14024# VSS 0.43619f ; **FLOATING
C6465 a_15403_14024# VSS 0.48909f ; **FLOATING
C6466 a_15837_14024# VSS 0.94699f ; **FLOATING
C6467 a_15273_14024# VSS 0.44136f ; **FLOATING
C6468 a_14643_14024# VSS 0.48671f ; **FLOATING
C6469 a_15077_14024# VSS 0.91627f ; **FLOATING
C6470 a_14513_14024# VSS 0.44348f ; **FLOATING
C6471 a_13883_14024# VSS 0.48774f ; **FLOATING
C6472 a_14317_14024# VSS 0.95132f ; **FLOATING
C6473 a_13753_14024# VSS 0.44619f ; **FLOATING
C6474 a_13123_14024# VSS 0.48563f ; **FLOATING
C6475 a_13557_14024# VSS 0.86121f ; **FLOATING
C6476 a_12993_14024# VSS 0.44414f ; **FLOATING
C6477 a_12363_14024# VSS 0.48744f ; **FLOATING
C6478 a_12797_14024# VSS 0.95346f ; **FLOATING
C6479 a_12233_14024# VSS 0.44136f ; **FLOATING
C6480 a_11603_14024# VSS 0.48672f ; **FLOATING
C6481 a_12037_14024# VSS 0.91935f ; **FLOATING
C6482 a_11473_14024# VSS 0.44354f ; **FLOATING
C6483 a_10843_14024# VSS 0.48784f ; **FLOATING
C6484 a_11277_14024# VSS 0.95142f ; **FLOATING
C6485 a_10713_14024# VSS 0.44684f ; **FLOATING
C6486 a_10083_14024# VSS 0.9169f ; **FLOATING
C6487 a_10517_14024# VSS 0.87068f ; **FLOATING
C6488 a_9953_14024# VSS 0.70713f ; **FLOATING
C6489 a_9323_14024# VSS 0.48995f ; **FLOATING
C6490 a_9757_14024# VSS 1.31734f ; **FLOATING
C6491 a_9193_14024# VSS 0.44151f ; **FLOATING
C6492 a_8563_14024# VSS 0.46677f ; **FLOATING
C6493 a_8997_14024# VSS 0.91719f ; **FLOATING
C6494 a_8433_14024# VSS 0.44288f ; **FLOATING
C6495 a_7803_14024# VSS 0.48776f ; **FLOATING
C6496 a_8237_14024# VSS 0.95098f ; **FLOATING
C6497 a_7673_14024# VSS 0.44619f ; **FLOATING
C6498 a_7043_14024# VSS 0.48563f ; **FLOATING
C6499 a_7477_14024# VSS 0.86086f ; **FLOATING
C6500 a_6913_14024# VSS 0.44414f ; **FLOATING
C6501 a_6283_14024# VSS 0.48744f ; **FLOATING
C6502 a_6717_14024# VSS 0.95287f ; **FLOATING
C6503 a_6153_14024# VSS 0.44059f ; **FLOATING
C6504 a_5523_14024# VSS 0.48671f ; **FLOATING
C6505 a_5957_14024# VSS 0.91503f ; **FLOATING
C6506 a_5393_14024# VSS 0.44587f ; **FLOATING
C6507 a_4763_14024# VSS 0.49323f ; **FLOATING
C6508 a_5197_14024# VSS 0.9541f ; **FLOATING
C6509 a_4633_14024# VSS 0.44882f ; **FLOATING
C6510 a_4003_14024# VSS 0.57066f ; **FLOATING
C6511 a_4437_14024# VSS 0.86497f ; **FLOATING
C6512 a_26985_15546# VSS 0.17928f ; **FLOATING
C6513 a_23945_15546# VSS 0.17928f ; **FLOATING
C6514 a_20905_15546# VSS 0.17928f ; **FLOATING
C6515 a_17865_15546# VSS 0.17881f ; **FLOATING
C6516 a_16851_15336# VSS 0.37653f ; **FLOATING
C6517 a_16108_15316# VSS 2.61391f ; **FLOATING
C6518 a_15964_15316# VSS 0.1695f ; **FLOATING
C6519 a_15765_15490# VSS 0.33587f ; **FLOATING
C6520 a_14825_15546# VSS 0.17928f ; **FLOATING
C6521 a_11785_15546# VSS 0.17928f ; **FLOATING
C6522 a_8745_15546# VSS 0.17928f ; **FLOATING
C6523 a_5731_15316# VSS 2.24392f ; **FLOATING
C6524 a_5705_15546# VSS 0.17638f ; **FLOATING
C6525 a_3449_15358# VSS 0.17702f ; **FLOATING
C6526 a_2873_15358# VSS 0.1828f ; **FLOATING
C6527 a_2297_15358# VSS 0.1829f ; **FLOATING
C6528 a_1721_15358# VSS 0.17136f ; **FLOATING
C6529 a_1544_15316# VSS 0.29772f ; **FLOATING
C6530 a_1256_15316# VSS 0.85178f ; **FLOATING
C6531 a_27991_16035# VSS 0.18561f ; **FLOATING
C6532 a_27915_16071# VSS 0.10926f ; **FLOATING
C6533 a_27124_16035# VSS 0.17878f ; **FLOATING
C6534 a_27048_16071# VSS 0.12122f ; **FLOATING
C6535 a_26471_16035# VSS 0.18126f ; **FLOATING
C6536 a_26395_16071# VSS 0.11073f ; **FLOATING
C6537 a_25604_16035# VSS 0.18257f ; **FLOATING
C6538 a_25630_16071# VSS 0.33852f ; **FLOATING
C6539 a_25528_16071# VSS 0.13246f ; **FLOATING
C6540 a_24951_16035# VSS 0.18335f ; **FLOATING
C6541 a_24875_16071# VSS 0.11016f ; **FLOATING
C6542 a_24084_16035# VSS 0.17878f ; **FLOATING
C6543 a_24008_16071# VSS 0.12122f ; **FLOATING
C6544 a_23431_16035# VSS 0.18126f ; **FLOATING
C6545 a_23355_16071# VSS 0.11073f ; **FLOATING
C6546 a_22564_16035# VSS 0.18087f ; **FLOATING
C6547 a_22590_16071# VSS 0.32818f ; **FLOATING
C6548 a_22488_16071# VSS 0.12433f ; **FLOATING
C6549 a_21911_16035# VSS 0.18335f ; **FLOATING
C6550 a_21835_16071# VSS 0.11016f ; **FLOATING
C6551 a_21044_16035# VSS 0.17878f ; **FLOATING
C6552 a_20968_16071# VSS 0.12122f ; **FLOATING
C6553 a_20391_16035# VSS 0.18126f ; **FLOATING
C6554 a_20315_16071# VSS 0.11073f ; **FLOATING
C6555 a_19524_16035# VSS 0.18087f ; **FLOATING
C6556 a_19550_16071# VSS 0.33563f ; **FLOATING
C6557 a_19448_16071# VSS 0.12433f ; **FLOATING
C6558 a_18871_16035# VSS 0.18335f ; **FLOATING
C6559 a_18795_16071# VSS 0.11016f ; **FLOATING
C6560 a_18004_16035# VSS 0.1797f ; **FLOATING
C6561 a_17928_16071# VSS 0.12899f ; **FLOATING
C6562 a_17351_16035# VSS 0.17877f ; **FLOATING
C6563 a_17275_16071# VSS 0.10926f ; **FLOATING
C6564 a_16484_16035# VSS 0.17947f ; **FLOATING
C6565 a_16510_16071# VSS 0.30718f ; **FLOATING
C6566 a_16408_16071# VSS 0.1229f ; **FLOATING
C6567 a_15831_16035# VSS 0.17846f ; **FLOATING
C6568 a_15755_16071# VSS 0.10926f ; **FLOATING
C6569 a_14964_16035# VSS 0.17878f ; **FLOATING
C6570 a_14888_16071# VSS 0.12122f ; **FLOATING
C6571 a_14311_16035# VSS 0.18126f ; **FLOATING
C6572 a_14235_16071# VSS 0.11073f ; **FLOATING
C6573 a_13444_16035# VSS 0.18087f ; **FLOATING
C6574 a_13470_16071# VSS 0.30113f ; **FLOATING
C6575 a_13368_16071# VSS 0.12433f ; **FLOATING
C6576 a_12791_16035# VSS 0.18335f ; **FLOATING
C6577 a_12715_16071# VSS 0.11016f ; **FLOATING
C6578 a_11924_16035# VSS 0.17878f ; **FLOATING
C6579 a_11848_16071# VSS 0.12122f ; **FLOATING
C6580 a_11271_16035# VSS 0.18126f ; **FLOATING
C6581 a_11195_16071# VSS 0.11073f ; **FLOATING
C6582 a_10404_16035# VSS 0.18087f ; **FLOATING
C6583 a_10430_16071# VSS 0.31665f ; **FLOATING
C6584 a_10328_16071# VSS 0.12433f ; **FLOATING
C6585 a_9751_16035# VSS 0.18359f ; **FLOATING
C6586 a_9675_16071# VSS 0.11016f ; **FLOATING
C6587 a_8884_16035# VSS 0.17878f ; **FLOATING
C6588 a_8808_16071# VSS 0.12122f ; **FLOATING
C6589 a_8231_16035# VSS 0.18126f ; **FLOATING
C6590 a_8155_16071# VSS 0.11073f ; **FLOATING
C6591 a_7364_16035# VSS 0.18087f ; **FLOATING
C6592 a_7390_16071# VSS 0.31136f ; **FLOATING
C6593 a_7288_16071# VSS 0.12433f ; **FLOATING
C6594 a_6711_16035# VSS 0.18335f ; **FLOATING
C6595 a_6635_16071# VSS 0.11016f ; **FLOATING
C6596 a_5844_16035# VSS 0.17878f ; **FLOATING
C6597 a_5768_16071# VSS 0.12122f ; **FLOATING
C6598 a_5191_16035# VSS 0.17877f ; **FLOATING
C6599 a_5115_16071# VSS 0.10926f ; **FLOATING
C6600 a_4324_16035# VSS 0.17947f ; **FLOATING
C6601 a_4350_16071# VSS 0.26655f ; **FLOATING
C6602 a_4248_16071# VSS 0.12443f ; **FLOATING
C6603 a_27705_16071# VSS 0.25231f ; **FLOATING
C6604 a_26185_16071# VSS 0.23475f ; **FLOATING
C6605 a_24665_16071# VSS 0.25432f ; **FLOATING
C6606 a_23145_16071# VSS 0.23475f ; **FLOATING
C6607 a_21625_16071# VSS 0.25432f ; **FLOATING
C6608 a_20105_16071# VSS 0.23475f ; **FLOATING
C6609 a_18585_16071# VSS 0.25432f ; **FLOATING
C6610 a_17065_16071# VSS 0.23378f ; **FLOATING
C6611 a_15545_16071# VSS 0.25231f ; **FLOATING
C6612 a_14025_16071# VSS 0.23475f ; **FLOATING
C6613 a_12505_16071# VSS 0.25432f ; **FLOATING
C6614 a_10985_16071# VSS 0.23475f ; **FLOATING
C6615 a_9465_16071# VSS 0.25432f ; **FLOATING
C6616 a_7945_16071# VSS 0.23475f ; **FLOATING
C6617 a_6425_16071# VSS 0.25432f ; **FLOATING
C6618 a_4905_16071# VSS 0.23483f ; **FLOATING
C6619 a_4157_16340# VSS 0.32839f ; **FLOATING
C6620 a_3449_16422# VSS 0.18629f ; **FLOATING
C6621 a_2873_16422# VSS 0.18349f ; **FLOATING
C6622 a_2297_16422# VSS 0.18359f ; **FLOATING
C6623 a_1721_16422# VSS 0.17252f ; **FLOATING
C6624 a_1544_16071# VSS 0.29907f ; **FLOATING
C6625 a_1256_16071# VSS 0.86055f ; **FLOATING
C6626 a_27671_16869# VSS 0.01336f ; **FLOATING
C6627 a_26911_16869# VSS 0.01336f ; **FLOATING
C6628 a_26151_16869# VSS 0.01336f ; **FLOATING
C6629 a_25391_16869# VSS 0.01733f ; **FLOATING
C6630 a_24631_16869# VSS 0.01336f ; **FLOATING
C6631 a_23871_16869# VSS 0.01336f ; **FLOATING
C6632 a_23111_16869# VSS 0.01336f ; **FLOATING
C6633 a_22351_16869# VSS 0.01336f ; **FLOATING
C6634 a_21591_16869# VSS 0.01336f ; **FLOATING
C6635 a_20831_16869# VSS 0.01336f ; **FLOATING
C6636 a_20071_16869# VSS 0.01336f ; **FLOATING
C6637 a_19311_16869# VSS 0.01336f ; **FLOATING
C6638 a_18551_16869# VSS 0.01336f ; **FLOATING
C6639 a_17791_16869# VSS 0.01733f ; **FLOATING
C6640 a_17031_16869# VSS 0.01336f ; **FLOATING
C6641 a_16271_16869# VSS 0.01336f ; **FLOATING
C6642 a_15511_16869# VSS 0.01336f ; **FLOATING
C6643 a_14751_16869# VSS 0.01336f ; **FLOATING
C6644 a_13991_16869# VSS 0.01336f ; **FLOATING
C6645 a_13231_16869# VSS 0.01336f ; **FLOATING
C6646 a_12471_16869# VSS 0.01336f ; **FLOATING
C6647 a_11711_16869# VSS 0.01336f ; **FLOATING
C6648 a_10951_16869# VSS 0.01336f ; **FLOATING
C6649 a_10191_16869# VSS 0.01733f ; **FLOATING
C6650 a_9431_16869# VSS 0.01336f ; **FLOATING
C6651 a_8671_16869# VSS 0.01336f ; **FLOATING
C6652 a_7911_16869# VSS 0.01336f ; **FLOATING
C6653 a_7151_16869# VSS 0.01336f ; **FLOATING
C6654 a_6391_16869# VSS 0.01336f ; **FLOATING
C6655 a_5631_16869# VSS 0.01336f ; **FLOATING
C6656 a_4871_16869# VSS 0.01336f ; **FLOATING
C6657 a_4111_16869# VSS 0.0139f ; **FLOATING
C6658 a_27563_16869# VSS 0.51284f ; **FLOATING
C6659 a_27997_16869# VSS 0.6533f ; **FLOATING
C6660 a_27433_16869# VSS 0.45843f ; **FLOATING
C6661 a_26803_16869# VSS 0.50906f ; **FLOATING
C6662 a_27237_16869# VSS 0.93572f ; **FLOATING
C6663 a_26673_16869# VSS 0.46002f ; **FLOATING
C6664 a_26043_16869# VSS 0.51151f ; **FLOATING
C6665 a_26477_16869# VSS 0.96582f ; **FLOATING
C6666 a_25913_16869# VSS 0.46487f ; **FLOATING
C6667 a_25283_16869# VSS 0.96998f ; **FLOATING
C6668 a_25717_16869# VSS 0.9696f ; **FLOATING
C6669 a_25153_16869# VSS 0.58221f ; **FLOATING
C6670 a_24523_16869# VSS 0.49301f ; **FLOATING
C6671 a_24957_16869# VSS 1.13175f ; **FLOATING
C6672 a_24393_16869# VSS 0.43231f ; **FLOATING
C6673 a_23763_16869# VSS 0.50664f ; **FLOATING
C6674 a_24197_16869# VSS 0.91194f ; **FLOATING
C6675 a_23633_16869# VSS 0.45996f ; **FLOATING
C6676 a_23003_16869# VSS 0.51137f ; **FLOATING
C6677 a_23437_16869# VSS 0.9654f ; **FLOATING
C6678 a_22873_16869# VSS 0.46292f ; **FLOATING
C6679 a_22243_16869# VSS 0.50906f ; **FLOATING
C6680 a_22677_16869# VSS 0.87587f ; **FLOATING
C6681 a_22113_16869# VSS 0.45997f ; **FLOATING
C6682 a_21483_16869# VSS 0.51043f ; **FLOATING
C6683 a_21917_16869# VSS 0.97121f ; **FLOATING
C6684 a_21353_16869# VSS 0.45843f ; **FLOATING
C6685 a_20723_16869# VSS 0.50902f ; **FLOATING
C6686 a_21157_16869# VSS 0.93209f ; **FLOATING
C6687 a_20593_16869# VSS 0.45994f ; **FLOATING
C6688 a_19963_16869# VSS 0.51137f ; **FLOATING
C6689 a_20397_16869# VSS 0.9654f ; **FLOATING
C6690 a_19833_16869# VSS 0.46292f ; **FLOATING
C6691 a_19203_16869# VSS 0.50907f ; **FLOATING
C6692 a_19637_16869# VSS 0.87589f ; **FLOATING
C6693 a_19073_16869# VSS 0.46002f ; **FLOATING
C6694 a_18443_16869# VSS 0.51052f ; **FLOATING
C6695 a_18877_16869# VSS 0.97136f ; **FLOATING
C6696 a_18313_16869# VSS 0.45908f ; **FLOATING
C6697 a_17683_16869# VSS 0.94317f ; **FLOATING
C6698 a_18117_16869# VSS 0.98556f ; **FLOATING
C6699 a_17553_16869# VSS 0.60412f ; **FLOATING
C6700 a_16923_16869# VSS 0.51214f ; **FLOATING
C6701 a_17357_16869# VSS 1.14313f ; **FLOATING
C6702 a_16793_16869# VSS 0.45759f ; **FLOATING
C6703 a_16163_16869# VSS 0.48061f ; **FLOATING
C6704 a_16597_16869# VSS 0.85088f ; **FLOATING
C6705 a_16033_16869# VSS 0.45798f ; **FLOATING
C6706 a_15403_16869# VSS 0.51041f ; **FLOATING
C6707 a_15837_16869# VSS 0.9618f ; **FLOATING
C6708 a_15273_16869# VSS 0.45843f ; **FLOATING
C6709 a_14643_16869# VSS 0.50902f ; **FLOATING
C6710 a_15077_16869# VSS 0.93029f ; **FLOATING
C6711 a_14513_16869# VSS 0.45994f ; **FLOATING
C6712 a_13883_16869# VSS 0.51137f ; **FLOATING
C6713 a_14317_16869# VSS 0.9654f ; **FLOATING
C6714 a_13753_16869# VSS 0.46292f ; **FLOATING
C6715 a_13123_16869# VSS 0.50904f ; **FLOATING
C6716 a_13557_16869# VSS 0.87587f ; **FLOATING
C6717 a_12993_16869# VSS 0.45997f ; **FLOATING
C6718 a_12363_16869# VSS 0.51043f ; **FLOATING
C6719 a_12797_16869# VSS 0.96954f ; **FLOATING
C6720 a_12233_16869# VSS 0.45843f ; **FLOATING
C6721 a_11603_16869# VSS 0.50904f ; **FLOATING
C6722 a_12037_16869# VSS 0.93209f ; **FLOATING
C6723 a_11473_16869# VSS 0.46f ; **FLOATING
C6724 a_10843_16869# VSS 0.51146f ; **FLOATING
C6725 a_11277_16869# VSS 0.96553f ; **FLOATING
C6726 a_10713_16869# VSS 0.46357f ; **FLOATING
C6727 a_10083_16869# VSS 0.93134f ; **FLOATING
C6728 a_10517_16869# VSS 0.88563f ; **FLOATING
C6729 a_9953_16869# VSS 0.69246f ; **FLOATING
C6730 a_9323_16869# VSS 0.51294f ; **FLOATING
C6731 a_9757_16869# VSS 1.32604f ; **FLOATING
C6732 a_9193_16869# VSS 0.45858f ; **FLOATING
C6733 a_8563_16869# VSS 0.46821f ; **FLOATING
C6734 a_8997_16869# VSS 0.92397f ; **FLOATING
C6735 a_8433_16869# VSS 0.45934f ; **FLOATING
C6736 a_7803_16869# VSS 0.51139f ; **FLOATING
C6737 a_8237_16869# VSS 0.96544f ; **FLOATING
C6738 a_7673_16869# VSS 0.46292f ; **FLOATING
C6739 a_7043_16869# VSS 0.50904f ; **FLOATING
C6740 a_7477_16869# VSS 0.87587f ; **FLOATING
C6741 a_6913_16869# VSS 0.45997f ; **FLOATING
C6742 a_6283_16869# VSS 0.51043f ; **FLOATING
C6743 a_6717_16869# VSS 0.96895f ; **FLOATING
C6744 a_6153_16869# VSS 0.45843f ; **FLOATING
C6745 a_5523_16869# VSS 0.50902f ; **FLOATING
C6746 a_5957_16869# VSS 0.93209f ; **FLOATING
C6747 a_5393_16869# VSS 0.45994f ; **FLOATING
C6748 a_4763_16869# VSS 0.51133f ; **FLOATING
C6749 a_5197_16869# VSS 0.9654f ; **FLOATING
C6750 a_4633_16869# VSS 0.4629f ; **FLOATING
C6751 a_4003_16869# VSS 0.58899f ; **FLOATING
C6752 a_4437_16869# VSS 0.87486f ; **FLOATING
C6753 a_4187_2434# VSS 18.8228f ; **FLOATING
C6754 a_4187_1764.t98 VSS 69.1825f ; **FLOATING
C6755 a_4187_1764.t163 VSS 0.05797f ; **FLOATING
C6756 a_4187_1764.t162 VSS 0.05627f ; **FLOATING
C6757 a_4187_1764.n0 VSS 0.13318f ; **FLOATING
C6758 a_4187_1764.t161 VSS 0.05627f ; **FLOATING
C6759 a_4187_1764.n1 VSS 0.09238f ; **FLOATING
C6760 a_4187_1764.t160 VSS 0.05627f ; **FLOATING
C6761 a_4187_1764.n2 VSS 0.09238f ; **FLOATING
C6762 a_4187_1764.t159 VSS 0.05627f ; **FLOATING
C6763 a_4187_1764.n3 VSS 0.09238f ; **FLOATING
C6764 a_4187_1764.t158 VSS 0.05627f ; **FLOATING
C6765 a_4187_1764.n4 VSS 0.09238f ; **FLOATING
C6766 a_4187_1764.t157 VSS 0.05627f ; **FLOATING
C6767 a_4187_1764.n5 VSS 0.09238f ; **FLOATING
C6768 a_4187_1764.t156 VSS 0.05627f ; **FLOATING
C6769 a_4187_1764.n6 VSS 0.09238f ; **FLOATING
C6770 a_4187_1764.t155 VSS 0.05627f ; **FLOATING
C6771 a_4187_1764.n7 VSS 0.09238f ; **FLOATING
C6772 a_4187_1764.t154 VSS 0.05627f ; **FLOATING
C6773 a_4187_1764.n8 VSS 0.09238f ; **FLOATING
C6774 a_4187_1764.t153 VSS 0.05627f ; **FLOATING
C6775 a_4187_1764.n9 VSS 0.09238f ; **FLOATING
C6776 a_4187_1764.t152 VSS 0.05627f ; **FLOATING
C6777 a_4187_1764.n10 VSS 0.09238f ; **FLOATING
C6778 a_4187_1764.t151 VSS 0.05627f ; **FLOATING
C6779 a_4187_1764.n11 VSS 0.09238f ; **FLOATING
C6780 a_4187_1764.t150 VSS 0.05627f ; **FLOATING
C6781 a_4187_1764.n12 VSS 0.09238f ; **FLOATING
C6782 a_4187_1764.t149 VSS 0.05627f ; **FLOATING
C6783 a_4187_1764.n13 VSS 0.09238f ; **FLOATING
C6784 a_4187_1764.t148 VSS 0.05627f ; **FLOATING
C6785 a_4187_1764.n14 VSS 0.09238f ; **FLOATING
C6786 a_4187_1764.t147 VSS 0.05627f ; **FLOATING
C6787 a_4187_1764.n15 VSS 0.09238f ; **FLOATING
C6788 a_4187_1764.t146 VSS 0.05627f ; **FLOATING
C6789 a_4187_1764.n16 VSS 0.09238f ; **FLOATING
C6790 a_4187_1764.t145 VSS 0.05627f ; **FLOATING
C6791 a_4187_1764.n17 VSS 0.09238f ; **FLOATING
C6792 a_4187_1764.t144 VSS 0.05627f ; **FLOATING
C6793 a_4187_1764.n18 VSS 0.09238f ; **FLOATING
C6794 a_4187_1764.t143 VSS 0.05627f ; **FLOATING
C6795 a_4187_1764.n19 VSS 0.09238f ; **FLOATING
C6796 a_4187_1764.t142 VSS 0.05627f ; **FLOATING
C6797 a_4187_1764.n20 VSS 0.09238f ; **FLOATING
C6798 a_4187_1764.t141 VSS 0.05627f ; **FLOATING
C6799 a_4187_1764.n21 VSS 0.09238f ; **FLOATING
C6800 a_4187_1764.t140 VSS 0.05627f ; **FLOATING
C6801 a_4187_1764.n22 VSS 0.09238f ; **FLOATING
C6802 a_4187_1764.t139 VSS 0.05627f ; **FLOATING
C6803 a_4187_1764.n23 VSS 0.09238f ; **FLOATING
C6804 a_4187_1764.t138 VSS 0.05627f ; **FLOATING
C6805 a_4187_1764.n24 VSS 0.09238f ; **FLOATING
C6806 a_4187_1764.t137 VSS 0.05627f ; **FLOATING
C6807 a_4187_1764.n25 VSS 0.09238f ; **FLOATING
C6808 a_4187_1764.t136 VSS 0.05627f ; **FLOATING
C6809 a_4187_1764.n26 VSS 0.09238f ; **FLOATING
C6810 a_4187_1764.t135 VSS 0.05627f ; **FLOATING
C6811 a_4187_1764.n27 VSS 0.09238f ; **FLOATING
C6812 a_4187_1764.t134 VSS 0.05627f ; **FLOATING
C6813 a_4187_1764.n28 VSS 0.09238f ; **FLOATING
C6814 a_4187_1764.t133 VSS 0.05627f ; **FLOATING
C6815 a_4187_1764.n29 VSS 0.09238f ; **FLOATING
C6816 a_4187_1764.t132 VSS 0.05627f ; **FLOATING
C6817 a_4187_1764.n30 VSS 0.22629f ; **FLOATING
C6818 a_4187_1764.t131 VSS 0.05797f ; **FLOATING
C6819 a_4187_1764.t130 VSS 0.05627f ; **FLOATING
C6820 a_4187_1764.n31 VSS 0.13318f ; **FLOATING
C6821 a_4187_1764.t129 VSS 0.05627f ; **FLOATING
C6822 a_4187_1764.n32 VSS 0.09238f ; **FLOATING
C6823 a_4187_1764.t128 VSS 0.05627f ; **FLOATING
C6824 a_4187_1764.n33 VSS 0.09238f ; **FLOATING
C6825 a_4187_1764.t127 VSS 0.05627f ; **FLOATING
C6826 a_4187_1764.n34 VSS 0.09238f ; **FLOATING
C6827 a_4187_1764.t126 VSS 0.05627f ; **FLOATING
C6828 a_4187_1764.n35 VSS 0.09238f ; **FLOATING
C6829 a_4187_1764.t125 VSS 0.05627f ; **FLOATING
C6830 a_4187_1764.n36 VSS 0.09238f ; **FLOATING
C6831 a_4187_1764.t124 VSS 0.05627f ; **FLOATING
C6832 a_4187_1764.n37 VSS 0.09238f ; **FLOATING
C6833 a_4187_1764.t123 VSS 0.05627f ; **FLOATING
C6834 a_4187_1764.n38 VSS 0.09238f ; **FLOATING
C6835 a_4187_1764.t122 VSS 0.05627f ; **FLOATING
C6836 a_4187_1764.n39 VSS 0.09238f ; **FLOATING
C6837 a_4187_1764.t121 VSS 0.05627f ; **FLOATING
C6838 a_4187_1764.n40 VSS 0.09238f ; **FLOATING
C6839 a_4187_1764.t120 VSS 0.05627f ; **FLOATING
C6840 a_4187_1764.n41 VSS 0.09238f ; **FLOATING
C6841 a_4187_1764.t119 VSS 0.05627f ; **FLOATING
C6842 a_4187_1764.n42 VSS 0.09238f ; **FLOATING
C6843 a_4187_1764.t118 VSS 0.05627f ; **FLOATING
C6844 a_4187_1764.n43 VSS 0.09238f ; **FLOATING
C6845 a_4187_1764.t117 VSS 0.05627f ; **FLOATING
C6846 a_4187_1764.n44 VSS 0.09238f ; **FLOATING
C6847 a_4187_1764.t116 VSS 0.05627f ; **FLOATING
C6848 a_4187_1764.n45 VSS 0.09238f ; **FLOATING
C6849 a_4187_1764.t115 VSS 0.05627f ; **FLOATING
C6850 a_4187_1764.n46 VSS 0.09238f ; **FLOATING
C6851 a_4187_1764.t114 VSS 0.05627f ; **FLOATING
C6852 a_4187_1764.n47 VSS 0.09238f ; **FLOATING
C6853 a_4187_1764.t113 VSS 0.05627f ; **FLOATING
C6854 a_4187_1764.n48 VSS 0.09238f ; **FLOATING
C6855 a_4187_1764.t112 VSS 0.05627f ; **FLOATING
C6856 a_4187_1764.n49 VSS 0.09238f ; **FLOATING
C6857 a_4187_1764.t111 VSS 0.05627f ; **FLOATING
C6858 a_4187_1764.n50 VSS 0.09238f ; **FLOATING
C6859 a_4187_1764.t110 VSS 0.05627f ; **FLOATING
C6860 a_4187_1764.n51 VSS 0.09238f ; **FLOATING
C6861 a_4187_1764.t109 VSS 0.05627f ; **FLOATING
C6862 a_4187_1764.n52 VSS 0.09238f ; **FLOATING
C6863 a_4187_1764.t108 VSS 0.05627f ; **FLOATING
C6864 a_4187_1764.n53 VSS 0.09238f ; **FLOATING
C6865 a_4187_1764.t107 VSS 0.05627f ; **FLOATING
C6866 a_4187_1764.n54 VSS 0.09238f ; **FLOATING
C6867 a_4187_1764.t106 VSS 0.05627f ; **FLOATING
C6868 a_4187_1764.n55 VSS 0.09238f ; **FLOATING
C6869 a_4187_1764.t105 VSS 0.05627f ; **FLOATING
C6870 a_4187_1764.n56 VSS 0.09238f ; **FLOATING
C6871 a_4187_1764.t104 VSS 0.05627f ; **FLOATING
C6872 a_4187_1764.n57 VSS 0.09238f ; **FLOATING
C6873 a_4187_1764.t103 VSS 0.05627f ; **FLOATING
C6874 a_4187_1764.n58 VSS 0.09238f ; **FLOATING
C6875 a_4187_1764.t102 VSS 0.05627f ; **FLOATING
C6876 a_4187_1764.n59 VSS 0.09238f ; **FLOATING
C6877 a_4187_1764.t101 VSS 0.05627f ; **FLOATING
C6878 a_4187_1764.n60 VSS 0.09238f ; **FLOATING
C6879 a_4187_1764.t100 VSS 0.05627f ; **FLOATING
C6880 a_4187_1764.n61 VSS 0.13875f ; **FLOATING
C6881 a_4187_1764.n62 VSS 0.60289f ; **FLOATING
C6882 a_4187_1764.t33 VSS 0.05797f ; **FLOATING
C6883 a_4187_1764.t32 VSS 0.05627f ; **FLOATING
C6884 a_4187_1764.n63 VSS 0.13318f ; **FLOATING
C6885 a_4187_1764.t31 VSS 0.05627f ; **FLOATING
C6886 a_4187_1764.n64 VSS 0.09238f ; **FLOATING
C6887 a_4187_1764.t30 VSS 0.05627f ; **FLOATING
C6888 a_4187_1764.n65 VSS 0.09238f ; **FLOATING
C6889 a_4187_1764.t29 VSS 0.05627f ; **FLOATING
C6890 a_4187_1764.n66 VSS 0.09238f ; **FLOATING
C6891 a_4187_1764.t28 VSS 0.05627f ; **FLOATING
C6892 a_4187_1764.n67 VSS 0.09238f ; **FLOATING
C6893 a_4187_1764.t27 VSS 0.05627f ; **FLOATING
C6894 a_4187_1764.n68 VSS 0.09238f ; **FLOATING
C6895 a_4187_1764.t26 VSS 0.05627f ; **FLOATING
C6896 a_4187_1764.n69 VSS 0.09238f ; **FLOATING
C6897 a_4187_1764.t25 VSS 0.05627f ; **FLOATING
C6898 a_4187_1764.n70 VSS 0.09238f ; **FLOATING
C6899 a_4187_1764.t24 VSS 0.05627f ; **FLOATING
C6900 a_4187_1764.n71 VSS 0.09238f ; **FLOATING
C6901 a_4187_1764.t23 VSS 0.05627f ; **FLOATING
C6902 a_4187_1764.n72 VSS 0.09238f ; **FLOATING
C6903 a_4187_1764.t22 VSS 0.05627f ; **FLOATING
C6904 a_4187_1764.n73 VSS 0.09238f ; **FLOATING
C6905 a_4187_1764.t21 VSS 0.05627f ; **FLOATING
C6906 a_4187_1764.n74 VSS 0.09238f ; **FLOATING
C6907 a_4187_1764.t20 VSS 0.05627f ; **FLOATING
C6908 a_4187_1764.n75 VSS 0.09238f ; **FLOATING
C6909 a_4187_1764.t19 VSS 0.05627f ; **FLOATING
C6910 a_4187_1764.n76 VSS 0.09238f ; **FLOATING
C6911 a_4187_1764.t18 VSS 0.05627f ; **FLOATING
C6912 a_4187_1764.n77 VSS 0.09238f ; **FLOATING
C6913 a_4187_1764.t17 VSS 0.05627f ; **FLOATING
C6914 a_4187_1764.n78 VSS 0.09238f ; **FLOATING
C6915 a_4187_1764.t16 VSS 0.05627f ; **FLOATING
C6916 a_4187_1764.n79 VSS 0.09238f ; **FLOATING
C6917 a_4187_1764.t15 VSS 0.05627f ; **FLOATING
C6918 a_4187_1764.n80 VSS 0.09238f ; **FLOATING
C6919 a_4187_1764.t14 VSS 0.05627f ; **FLOATING
C6920 a_4187_1764.n81 VSS 0.09238f ; **FLOATING
C6921 a_4187_1764.t13 VSS 0.05627f ; **FLOATING
C6922 a_4187_1764.n82 VSS 0.09238f ; **FLOATING
C6923 a_4187_1764.t12 VSS 0.05627f ; **FLOATING
C6924 a_4187_1764.n83 VSS 0.09238f ; **FLOATING
C6925 a_4187_1764.t11 VSS 0.05627f ; **FLOATING
C6926 a_4187_1764.n84 VSS 0.09238f ; **FLOATING
C6927 a_4187_1764.t10 VSS 0.05627f ; **FLOATING
C6928 a_4187_1764.n85 VSS 0.09238f ; **FLOATING
C6929 a_4187_1764.t9 VSS 0.05627f ; **FLOATING
C6930 a_4187_1764.n86 VSS 0.09238f ; **FLOATING
C6931 a_4187_1764.t8 VSS 0.05627f ; **FLOATING
C6932 a_4187_1764.n87 VSS 0.09238f ; **FLOATING
C6933 a_4187_1764.t7 VSS 0.05627f ; **FLOATING
C6934 a_4187_1764.n88 VSS 0.09238f ; **FLOATING
C6935 a_4187_1764.t6 VSS 0.05627f ; **FLOATING
C6936 a_4187_1764.n89 VSS 0.09238f ; **FLOATING
C6937 a_4187_1764.t5 VSS 0.05627f ; **FLOATING
C6938 a_4187_1764.n90 VSS 0.09238f ; **FLOATING
C6939 a_4187_1764.t4 VSS 0.05627f ; **FLOATING
C6940 a_4187_1764.n91 VSS 0.09238f ; **FLOATING
C6941 a_4187_1764.t3 VSS 0.05627f ; **FLOATING
C6942 a_4187_1764.n92 VSS 0.09238f ; **FLOATING
C6943 a_4187_1764.t2 VSS 0.05627f ; **FLOATING
C6944 a_4187_1764.n93 VSS 0.24948f ; **FLOATING
C6945 a_4187_1764.t65 VSS 0.05797f ; **FLOATING
C6946 a_4187_1764.t64 VSS 0.05627f ; **FLOATING
C6947 a_4187_1764.n94 VSS 0.13318f ; **FLOATING
C6948 a_4187_1764.t63 VSS 0.05627f ; **FLOATING
C6949 a_4187_1764.n95 VSS 0.09238f ; **FLOATING
C6950 a_4187_1764.t62 VSS 0.05627f ; **FLOATING
C6951 a_4187_1764.n96 VSS 0.09238f ; **FLOATING
C6952 a_4187_1764.t61 VSS 0.05627f ; **FLOATING
C6953 a_4187_1764.n97 VSS 0.09238f ; **FLOATING
C6954 a_4187_1764.t60 VSS 0.05627f ; **FLOATING
C6955 a_4187_1764.n98 VSS 0.09238f ; **FLOATING
C6956 a_4187_1764.t59 VSS 0.05627f ; **FLOATING
C6957 a_4187_1764.n99 VSS 0.09238f ; **FLOATING
C6958 a_4187_1764.t58 VSS 0.05627f ; **FLOATING
C6959 a_4187_1764.n100 VSS 0.09238f ; **FLOATING
C6960 a_4187_1764.t57 VSS 0.05627f ; **FLOATING
C6961 a_4187_1764.n101 VSS 0.09238f ; **FLOATING
C6962 a_4187_1764.t56 VSS 0.05627f ; **FLOATING
C6963 a_4187_1764.n102 VSS 0.09238f ; **FLOATING
C6964 a_4187_1764.t55 VSS 0.05627f ; **FLOATING
C6965 a_4187_1764.n103 VSS 0.09238f ; **FLOATING
C6966 a_4187_1764.t54 VSS 0.05627f ; **FLOATING
C6967 a_4187_1764.n104 VSS 0.09238f ; **FLOATING
C6968 a_4187_1764.t53 VSS 0.05627f ; **FLOATING
C6969 a_4187_1764.n105 VSS 0.09238f ; **FLOATING
C6970 a_4187_1764.t52 VSS 0.05627f ; **FLOATING
C6971 a_4187_1764.n106 VSS 0.09238f ; **FLOATING
C6972 a_4187_1764.t51 VSS 0.05627f ; **FLOATING
C6973 a_4187_1764.n107 VSS 0.09238f ; **FLOATING
C6974 a_4187_1764.t50 VSS 0.05627f ; **FLOATING
C6975 a_4187_1764.n108 VSS 0.09238f ; **FLOATING
C6976 a_4187_1764.t49 VSS 0.05627f ; **FLOATING
C6977 a_4187_1764.n109 VSS 0.09238f ; **FLOATING
C6978 a_4187_1764.t48 VSS 0.05627f ; **FLOATING
C6979 a_4187_1764.n110 VSS 0.09238f ; **FLOATING
C6980 a_4187_1764.t47 VSS 0.05627f ; **FLOATING
C6981 a_4187_1764.n111 VSS 0.09238f ; **FLOATING
C6982 a_4187_1764.t46 VSS 0.05627f ; **FLOATING
C6983 a_4187_1764.n112 VSS 0.09238f ; **FLOATING
C6984 a_4187_1764.t45 VSS 0.05627f ; **FLOATING
C6985 a_4187_1764.n113 VSS 0.09238f ; **FLOATING
C6986 a_4187_1764.t44 VSS 0.05627f ; **FLOATING
C6987 a_4187_1764.n114 VSS 0.09238f ; **FLOATING
C6988 a_4187_1764.t43 VSS 0.05627f ; **FLOATING
C6989 a_4187_1764.n115 VSS 0.09238f ; **FLOATING
C6990 a_4187_1764.t42 VSS 0.05627f ; **FLOATING
C6991 a_4187_1764.n116 VSS 0.09238f ; **FLOATING
C6992 a_4187_1764.t41 VSS 0.05627f ; **FLOATING
C6993 a_4187_1764.n117 VSS 0.09238f ; **FLOATING
C6994 a_4187_1764.t40 VSS 0.05627f ; **FLOATING
C6995 a_4187_1764.n118 VSS 0.09238f ; **FLOATING
C6996 a_4187_1764.t39 VSS 0.05627f ; **FLOATING
C6997 a_4187_1764.n119 VSS 0.09238f ; **FLOATING
C6998 a_4187_1764.t38 VSS 0.05627f ; **FLOATING
C6999 a_4187_1764.n120 VSS 0.09238f ; **FLOATING
C7000 a_4187_1764.t37 VSS 0.05627f ; **FLOATING
C7001 a_4187_1764.n121 VSS 0.09238f ; **FLOATING
C7002 a_4187_1764.t36 VSS 0.05627f ; **FLOATING
C7003 a_4187_1764.n122 VSS 0.09238f ; **FLOATING
C7004 a_4187_1764.t35 VSS 0.05627f ; **FLOATING
C7005 a_4187_1764.n123 VSS 0.09238f ; **FLOATING
C7006 a_4187_1764.t34 VSS 0.05627f ; **FLOATING
C7007 a_4187_1764.n124 VSS 0.13875f ; **FLOATING
C7008 a_4187_1764.n125 VSS 0.62402f ; **FLOATING
C7009 a_4187_1764.t97 VSS 0.05797f ; **FLOATING
C7010 a_4187_1764.t96 VSS 0.05627f ; **FLOATING
C7011 a_4187_1764.n126 VSS 0.13318f ; **FLOATING
C7012 a_4187_1764.t95 VSS 0.05627f ; **FLOATING
C7013 a_4187_1764.n127 VSS 0.09238f ; **FLOATING
C7014 a_4187_1764.t94 VSS 0.05627f ; **FLOATING
C7015 a_4187_1764.n128 VSS 0.09238f ; **FLOATING
C7016 a_4187_1764.t93 VSS 0.05627f ; **FLOATING
C7017 a_4187_1764.n129 VSS 0.09238f ; **FLOATING
C7018 a_4187_1764.t92 VSS 0.05627f ; **FLOATING
C7019 a_4187_1764.n130 VSS 0.09238f ; **FLOATING
C7020 a_4187_1764.t91 VSS 0.05627f ; **FLOATING
C7021 a_4187_1764.n131 VSS 0.09238f ; **FLOATING
C7022 a_4187_1764.t90 VSS 0.05627f ; **FLOATING
C7023 a_4187_1764.n132 VSS 0.09238f ; **FLOATING
C7024 a_4187_1764.t89 VSS 0.05627f ; **FLOATING
C7025 a_4187_1764.n133 VSS 0.09238f ; **FLOATING
C7026 a_4187_1764.t88 VSS 0.05627f ; **FLOATING
C7027 a_4187_1764.n134 VSS 0.09238f ; **FLOATING
C7028 a_4187_1764.t87 VSS 0.05627f ; **FLOATING
C7029 a_4187_1764.n135 VSS 0.09238f ; **FLOATING
C7030 a_4187_1764.t86 VSS 0.05627f ; **FLOATING
C7031 a_4187_1764.n136 VSS 0.09238f ; **FLOATING
C7032 a_4187_1764.t85 VSS 0.05627f ; **FLOATING
C7033 a_4187_1764.n137 VSS 0.09238f ; **FLOATING
C7034 a_4187_1764.t84 VSS 0.05627f ; **FLOATING
C7035 a_4187_1764.n138 VSS 0.09238f ; **FLOATING
C7036 a_4187_1764.t83 VSS 0.05627f ; **FLOATING
C7037 a_4187_1764.n139 VSS 0.09238f ; **FLOATING
C7038 a_4187_1764.t82 VSS 0.05627f ; **FLOATING
C7039 a_4187_1764.n140 VSS 0.09238f ; **FLOATING
C7040 a_4187_1764.t81 VSS 0.05627f ; **FLOATING
C7041 a_4187_1764.n141 VSS 0.09238f ; **FLOATING
C7042 a_4187_1764.t80 VSS 0.05627f ; **FLOATING
C7043 a_4187_1764.n142 VSS 0.09238f ; **FLOATING
C7044 a_4187_1764.t79 VSS 0.05627f ; **FLOATING
C7045 a_4187_1764.n143 VSS 0.09238f ; **FLOATING
C7046 a_4187_1764.t78 VSS 0.05627f ; **FLOATING
C7047 a_4187_1764.n144 VSS 0.09238f ; **FLOATING
C7048 a_4187_1764.t77 VSS 0.05627f ; **FLOATING
C7049 a_4187_1764.n145 VSS 0.09238f ; **FLOATING
C7050 a_4187_1764.t76 VSS 0.05627f ; **FLOATING
C7051 a_4187_1764.n146 VSS 0.09238f ; **FLOATING
C7052 a_4187_1764.t75 VSS 0.05627f ; **FLOATING
C7053 a_4187_1764.n147 VSS 0.09238f ; **FLOATING
C7054 a_4187_1764.t74 VSS 0.05627f ; **FLOATING
C7055 a_4187_1764.n148 VSS 0.09238f ; **FLOATING
C7056 a_4187_1764.t73 VSS 0.05627f ; **FLOATING
C7057 a_4187_1764.n149 VSS 0.09238f ; **FLOATING
C7058 a_4187_1764.t72 VSS 0.05627f ; **FLOATING
C7059 a_4187_1764.n150 VSS 0.09238f ; **FLOATING
C7060 a_4187_1764.t71 VSS 0.05627f ; **FLOATING
C7061 a_4187_1764.n151 VSS 0.09238f ; **FLOATING
C7062 a_4187_1764.t70 VSS 0.05627f ; **FLOATING
C7063 a_4187_1764.n152 VSS 0.09238f ; **FLOATING
C7064 a_4187_1764.t69 VSS 0.05627f ; **FLOATING
C7065 a_4187_1764.n153 VSS 0.09238f ; **FLOATING
C7066 a_4187_1764.t68 VSS 0.05627f ; **FLOATING
C7067 a_4187_1764.n154 VSS 0.09238f ; **FLOATING
C7068 a_4187_1764.t67 VSS 0.05627f ; **FLOATING
C7069 a_4187_1764.n155 VSS 0.09238f ; **FLOATING
C7070 a_4187_1764.t66 VSS 0.05627f ; **FLOATING
C7071 a_4187_1764.n156 VSS 0.13875f ; **FLOATING
C7072 a_4187_1764.n157 VSS 0.35587f ; **FLOATING
C7073 a_4187_1764.n158 VSS 0.47683f ; **FLOATING
C7074 a_4187_1764.t99 VSS 0.05197f ; **FLOATING
C7075 a_4187_1764.n159 VSS 0.3952f ; **FLOATING
C7076 a_4187_1764.t1 VSS 0.01312f ; **FLOATING
C7077 a_4187_1764.n160 VSS 0.13421f ; **FLOATING
C7078 a_4187_1764.t0 VSS 0.03557f ; **FLOATING
C7079 a_2019_16074.t2 VSS 0.92363f ; **FLOATING
C7080 a_2019_16074.t3 VSS 0.7012f ; **FLOATING
C7081 a_2019_16074.n0 VSS 4.9731f ; **FLOATING
C7082 a_2019_16074.t4 VSS 0.7012f ; **FLOATING
C7083 a_2019_16074.n1 VSS 3.36444f ; **FLOATING
C7084 a_2019_16074.t5 VSS 0.7012f ; **FLOATING
C7085 a_2019_16074.n2 VSS 3.36444f ; **FLOATING
C7086 a_2019_16074.t6 VSS 0.7012f ; **FLOATING
C7087 a_2019_16074.n3 VSS 3.36444f ; **FLOATING
C7088 a_2019_16074.t7 VSS 0.7012f ; **FLOATING
C7089 a_2019_16074.n4 VSS 3.36444f ; **FLOATING
C7090 a_2019_16074.t8 VSS 0.7012f ; **FLOATING
C7091 a_2019_16074.n5 VSS 3.36444f ; **FLOATING
C7092 a_2019_16074.t9 VSS 5.41594f ; **FLOATING
C7093 a_2019_16074.t1 VSS 1.06492f ; **FLOATING
C7094 a_2019_16074.t0 VSS 0.30268f ; **FLOATING
C7095 a_2595_16074.t2 VSS 1.36715f ; **FLOATING
C7096 a_2595_16074.t3 VSS 1.02103f ; **FLOATING
C7097 a_2595_16074.n0 VSS 7.76194f ; **FLOATING
C7098 a_2595_16074.t4 VSS 1.02103f ; **FLOATING
C7099 a_2595_16074.n1 VSS 5.27388f ; **FLOATING
C7100 a_2595_16074.t5 VSS 1.02103f ; **FLOATING
C7101 a_2595_16074.n2 VSS 5.27388f ; **FLOATING
C7102 a_2595_16074.t6 VSS 1.02103f ; **FLOATING
C7103 a_2595_16074.n3 VSS 5.27388f ; **FLOATING
C7104 a_2595_16074.t7 VSS 1.02103f ; **FLOATING
C7105 a_2595_16074.n4 VSS 5.27388f ; **FLOATING
C7106 a_2595_16074.t8 VSS 1.02103f ; **FLOATING
C7107 a_2595_16074.n5 VSS 5.27388f ; **FLOATING
C7108 a_2595_16074.t9 VSS 1.02103f ; **FLOATING
C7109 a_2595_16074.n6 VSS 7.58616f ; **FLOATING
C7110 a_2595_16074.t1 VSS 1.75135f ; **FLOATING
C7111 a_2595_16074.t0 VSS 0.48231f ; **FLOATING
C7112 a_3171_16074.t2 VSS 1.38462f ; **FLOATING
C7113 a_3171_16074.t3 VSS 1.03749f ; **FLOATING
C7114 a_3171_16074.n0 VSS 7.77971f ; **FLOATING
C7115 a_3171_16074.t4 VSS 1.03749f ; **FLOATING
C7116 a_3171_16074.n1 VSS 5.2816f ; **FLOATING
C7117 a_3171_16074.t5 VSS 1.03749f ; **FLOATING
C7118 a_3171_16074.n2 VSS 5.2816f ; **FLOATING
C7119 a_3171_16074.t6 VSS 1.03749f ; **FLOATING
C7120 a_3171_16074.n3 VSS 5.2816f ; **FLOATING
C7121 a_3171_16074.t7 VSS 1.03749f ; **FLOATING
C7122 a_3171_16074.n4 VSS 5.2816f ; **FLOATING
C7123 a_3171_16074.t8 VSS 1.03749f ; **FLOATING
C7124 a_3171_16074.n5 VSS 5.2816f ; **FLOATING
C7125 a_3171_16074.t9 VSS 1.03749f ; **FLOATING
C7126 a_3171_16074.n6 VSS 7.6846f ; **FLOATING
C7127 a_3171_16074.t1 VSS 1.77052f ; **FLOATING
C7128 a_3171_16074.t0 VSS 0.48091f ; **FLOATING
C7129 a_3747_16074.t2 VSS 0.9727f ; **FLOATING
C7130 a_3747_16074.t3 VSS 0.74053f ; **FLOATING
C7131 a_3747_16074.n0 VSS 5.18798f ; **FLOATING
C7132 a_3747_16074.t4 VSS 0.74053f ; **FLOATING
C7133 a_3747_16074.n1 VSS 3.50701f ; **FLOATING
C7134 a_3747_16074.t5 VSS 0.74053f ; **FLOATING
C7135 a_3747_16074.n2 VSS 3.50701f ; **FLOATING
C7136 a_3747_16074.t6 VSS 0.74053f ; **FLOATING
C7137 a_3747_16074.n3 VSS 3.50701f ; **FLOATING
C7138 a_3747_16074.t7 VSS 0.74053f ; **FLOATING
C7139 a_3747_16074.n4 VSS 3.50701f ; **FLOATING
C7140 a_3747_16074.t8 VSS 0.74053f ; **FLOATING
C7141 a_3747_16074.n5 VSS 3.50701f ; **FLOATING
C7142 a_3747_16074.t9 VSS 0.74053f ; **FLOATING
C7143 a_3747_16074.n6 VSS 5.20749f ; **FLOATING
C7144 a_3747_16074.t1 VSS 1.19006f ; **FLOATING
C7145 a_3747_16074.t0 VSS 0.31462f ; **FLOATING
C7146 a_2019_15338.t2 VSS 4.06443f ; **FLOATING
C7147 a_2019_15338.t3 VSS 21.8734f ; **FLOATING
C7148 a_2019_15338.t1 VSS 1.98687f ; **FLOATING
C7149 a_2019_15338.t0 VSS 0.44612f ; **FLOATING
C7150 a_2595_15338.t1 VSS 3.29781f ; **FLOATING
C7151 a_2595_15338.t2 VSS 5.08375f ; **FLOATING
C7152 a_2595_15338.t3 VSS 1.21644f ; **FLOATING
C7153 a_2595_15338.n0 VSS 27.0922f ; **FLOATING
C7154 a_2595_15338.t0 VSS 0.49988f ; **FLOATING
C7155 a_3171_15338.t2 VSS 5.08436f ; **FLOATING
C7156 a_3171_15338.t3 VSS 1.21971f ; **FLOATING
C7157 a_3171_15338.n0 VSS 30.0525f ; **FLOATING
C7158 a_3171_15338.t1 VSS 4.64283f ; **FLOATING
C7159 a_3171_15338.t0 VSS 0.50068f ; **FLOATING
C7160 a_3747_15338.t2 VSS 3.16182f ; **FLOATING
C7161 a_3747_15338.t3 VSS 0.76102f ; **FLOATING
C7162 a_3747_15338.n0 VSS 20.3375f ; **FLOATING
C7163 a_3747_15338.t1 VSS 3.77219f ; **FLOATING
C7164 a_3747_15338.t0 VSS 0.31226f ; **FLOATING
C7165 a_2019_13229.t2 VSS 0.92372f ; **FLOATING
C7166 a_2019_13229.t3 VSS 0.70126f ; **FLOATING
C7167 a_2019_13229.n0 VSS 4.97358f ; **FLOATING
C7168 a_2019_13229.t4 VSS 0.70126f ; **FLOATING
C7169 a_2019_13229.n1 VSS 3.36476f ; **FLOATING
C7170 a_2019_13229.t5 VSS 0.70126f ; **FLOATING
C7171 a_2019_13229.n2 VSS 3.36476f ; **FLOATING
C7172 a_2019_13229.t6 VSS 0.70126f ; **FLOATING
C7173 a_2019_13229.n3 VSS 3.36476f ; **FLOATING
C7174 a_2019_13229.t7 VSS 0.70126f ; **FLOATING
C7175 a_2019_13229.n4 VSS 3.36476f ; **FLOATING
C7176 a_2019_13229.t8 VSS 0.70126f ; **FLOATING
C7177 a_2019_13229.n5 VSS 3.36476f ; **FLOATING
C7178 a_2019_13229.t9 VSS 5.41645f ; **FLOATING
C7179 a_2019_13229.t1 VSS 1.06502f ; **FLOATING
C7180 a_2019_13229.t0 VSS 0.30271f ; **FLOATING
C7181 a_2595_13229.t2 VSS 1.36716f ; **FLOATING
C7182 a_2595_13229.t3 VSS 1.02104f ; **FLOATING
C7183 a_2595_13229.n0 VSS 7.762f ; **FLOATING
C7184 a_2595_13229.t4 VSS 1.02104f ; **FLOATING
C7185 a_2595_13229.n1 VSS 5.27392f ; **FLOATING
C7186 a_2595_13229.t5 VSS 1.02104f ; **FLOATING
C7187 a_2595_13229.n2 VSS 5.27392f ; **FLOATING
C7188 a_2595_13229.t6 VSS 1.02104f ; **FLOATING
C7189 a_2595_13229.n3 VSS 5.27392f ; **FLOATING
C7190 a_2595_13229.t7 VSS 1.02104f ; **FLOATING
C7191 a_2595_13229.n4 VSS 5.27392f ; **FLOATING
C7192 a_2595_13229.t8 VSS 1.02104f ; **FLOATING
C7193 a_2595_13229.n5 VSS 5.27392f ; **FLOATING
C7194 a_2595_13229.t9 VSS 1.02104f ; **FLOATING
C7195 a_2595_13229.n6 VSS 7.58622f ; **FLOATING
C7196 a_2595_13229.t1 VSS 1.75136f ; **FLOATING
C7197 a_2595_13229.t0 VSS 0.48232f ; **FLOATING
C7198 a_3171_13229.t2 VSS 1.38476f ; **FLOATING
C7199 a_3171_13229.t3 VSS 1.03759f ; **FLOATING
C7200 a_3171_13229.n0 VSS 7.78049f ; **FLOATING
C7201 a_3171_13229.t4 VSS 1.03759f ; **FLOATING
C7202 a_3171_13229.n1 VSS 5.28214f ; **FLOATING
C7203 a_3171_13229.t5 VSS 1.03759f ; **FLOATING
C7204 a_3171_13229.n2 VSS 5.28214f ; **FLOATING
C7205 a_3171_13229.t6 VSS 1.03759f ; **FLOATING
C7206 a_3171_13229.n3 VSS 5.28214f ; **FLOATING
C7207 a_3171_13229.t7 VSS 1.03759f ; **FLOATING
C7208 a_3171_13229.n4 VSS 5.28214f ; **FLOATING
C7209 a_3171_13229.t8 VSS 1.03759f ; **FLOATING
C7210 a_3171_13229.n5 VSS 5.28214f ; **FLOATING
C7211 a_3171_13229.t9 VSS 1.03759f ; **FLOATING
C7212 a_3171_13229.n6 VSS 7.68538f ; **FLOATING
C7213 a_3171_13229.t1 VSS 1.7707f ; **FLOATING
C7214 a_3171_13229.t0 VSS 0.48096f ; **FLOATING
C7215 a_3747_13229.t2 VSS 0.97193f ; **FLOATING
C7216 a_3747_13229.t3 VSS 0.73994f ; **FLOATING
C7217 a_3747_13229.n0 VSS 5.18389f ; **FLOATING
C7218 a_3747_13229.t4 VSS 0.73994f ; **FLOATING
C7219 a_3747_13229.n1 VSS 3.50424f ; **FLOATING
C7220 a_3747_13229.t5 VSS 0.73994f ; **FLOATING
C7221 a_3747_13229.n2 VSS 3.50424f ; **FLOATING
C7222 a_3747_13229.t6 VSS 0.73994f ; **FLOATING
C7223 a_3747_13229.n3 VSS 3.50424f ; **FLOATING
C7224 a_3747_13229.t7 VSS 0.73994f ; **FLOATING
C7225 a_3747_13229.n4 VSS 3.50424f ; **FLOATING
C7226 a_3747_13229.t8 VSS 0.73994f ; **FLOATING
C7227 a_3747_13229.n5 VSS 3.50424f ; **FLOATING
C7228 a_3747_13229.t9 VSS 0.73994f ; **FLOATING
C7229 a_3747_13229.n6 VSS 5.20338f ; **FLOATING
C7230 a_3747_13229.t1 VSS 1.18912f ; **FLOATING
C7231 a_3747_13229.t0 VSS 0.31437f ; **FLOATING
C7232 a_2019_12493.t2 VSS 4.05842f ; **FLOATING
C7233 a_2019_12493.t3 VSS 21.8411f ; **FLOATING
C7234 a_2019_12493.t1 VSS 1.98394f ; **FLOATING
C7235 a_2019_12493.t0 VSS 0.44546f ; **FLOATING
C7236 a_2595_12493.t1 VSS 3.28575f ; **FLOATING
C7237 a_2595_12493.t2 VSS 5.06516f ; **FLOATING
C7238 a_2595_12493.t3 VSS 1.21199f ; **FLOATING
C7239 a_2595_12493.n0 VSS 26.9932f ; **FLOATING
C7240 a_2595_12493.t0 VSS 0.49805f ; **FLOATING
C7241 a_3171_12493.t2 VSS 5.06696f ; **FLOATING
C7242 a_3171_12493.t3 VSS 1.21554f ; **FLOATING
C7243 a_3171_12493.n0 VSS 29.9497f ; **FLOATING
C7244 a_3171_12493.t1 VSS 4.62694f ; **FLOATING
C7245 a_3171_12493.t0 VSS 0.49896f ; **FLOATING
C7246 a_3747_12493.t2 VSS 3.14808f ; **FLOATING
C7247 a_3747_12493.t3 VSS 0.75771f ; **FLOATING
C7248 a_3747_12493.n0 VSS 20.2491f ; **FLOATING
C7249 a_3747_12493.t1 VSS 3.7558f ; **FLOATING
C7250 a_3747_12493.t0 VSS 0.31091f ; **FLOATING
C7251 a_2019_6737.t2 VSS 0.92373f ; **FLOATING
C7252 a_2019_6737.t3 VSS 0.70127f ; **FLOATING
C7253 a_2019_6737.n0 VSS 4.97364f ; **FLOATING
C7254 a_2019_6737.t4 VSS 0.70127f ; **FLOATING
C7255 a_2019_6737.n1 VSS 3.36481f ; **FLOATING
C7256 a_2019_6737.t5 VSS 0.70127f ; **FLOATING
C7257 a_2019_6737.n2 VSS 3.36481f ; **FLOATING
C7258 a_2019_6737.t6 VSS 0.70127f ; **FLOATING
C7259 a_2019_6737.n3 VSS 3.36481f ; **FLOATING
C7260 a_2019_6737.t7 VSS 0.70127f ; **FLOATING
C7261 a_2019_6737.n4 VSS 3.36481f ; **FLOATING
C7262 a_2019_6737.t8 VSS 0.70127f ; **FLOATING
C7263 a_2019_6737.n5 VSS 3.36481f ; **FLOATING
C7264 a_2019_6737.t9 VSS 5.41652f ; **FLOATING
C7265 a_2019_6737.t1 VSS 1.06504f ; **FLOATING
C7266 a_2019_6737.t0 VSS 0.30271f ; **FLOATING
C7267 a_2595_6737.t2 VSS 1.36716f ; **FLOATING
C7268 a_2595_6737.t3 VSS 1.02104f ; **FLOATING
C7269 a_2595_6737.n0 VSS 7.76198f ; **FLOATING
C7270 a_2595_6737.t4 VSS 1.02104f ; **FLOATING
C7271 a_2595_6737.n1 VSS 5.2739f ; **FLOATING
C7272 a_2595_6737.t5 VSS 1.02104f ; **FLOATING
C7273 a_2595_6737.n2 VSS 5.2739f ; **FLOATING
C7274 a_2595_6737.t6 VSS 1.02104f ; **FLOATING
C7275 a_2595_6737.n3 VSS 5.2739f ; **FLOATING
C7276 a_2595_6737.t7 VSS 1.02104f ; **FLOATING
C7277 a_2595_6737.n4 VSS 5.2739f ; **FLOATING
C7278 a_2595_6737.t8 VSS 1.02104f ; **FLOATING
C7279 a_2595_6737.n5 VSS 5.2739f ; **FLOATING
C7280 a_2595_6737.t9 VSS 1.02104f ; **FLOATING
C7281 a_2595_6737.n6 VSS 7.58619f ; **FLOATING
C7282 a_2595_6737.t1 VSS 1.75136f ; **FLOATING
C7283 a_2595_6737.t0 VSS 0.48231f ; **FLOATING
C7284 a_3171_6737.t2 VSS 1.38463f ; **FLOATING
C7285 a_3171_6737.t3 VSS 1.0375f ; **FLOATING
C7286 a_3171_6737.n0 VSS 7.77976f ; **FLOATING
C7287 a_3171_6737.t4 VSS 1.0375f ; **FLOATING
C7288 a_3171_6737.n1 VSS 5.28164f ; **FLOATING
C7289 a_3171_6737.t5 VSS 1.0375f ; **FLOATING
C7290 a_3171_6737.n2 VSS 5.28164f ; **FLOATING
C7291 a_3171_6737.t6 VSS 1.0375f ; **FLOATING
C7292 a_3171_6737.n3 VSS 5.28164f ; **FLOATING
C7293 a_3171_6737.t7 VSS 1.0375f ; **FLOATING
C7294 a_3171_6737.n4 VSS 5.28164f ; **FLOATING
C7295 a_3171_6737.t8 VSS 1.0375f ; **FLOATING
C7296 a_3171_6737.n5 VSS 5.28164f ; **FLOATING
C7297 a_3171_6737.t9 VSS 1.0375f ; **FLOATING
C7298 a_3171_6737.n6 VSS 7.68465f ; **FLOATING
C7299 a_3171_6737.t1 VSS 1.77054f ; **FLOATING
C7300 a_3171_6737.t0 VSS 0.48092f ; **FLOATING
C7301 a_3747_6737.t2 VSS 0.97271f ; **FLOATING
C7302 a_3747_6737.t3 VSS 0.74053f ; **FLOATING
C7303 a_3747_6737.n0 VSS 5.18803f ; **FLOATING
C7304 a_3747_6737.t4 VSS 0.74053f ; **FLOATING
C7305 a_3747_6737.n1 VSS 3.50704f ; **FLOATING
C7306 a_3747_6737.t5 VSS 0.74053f ; **FLOATING
C7307 a_3747_6737.n2 VSS 3.50704f ; **FLOATING
C7308 a_3747_6737.t6 VSS 0.74053f ; **FLOATING
C7309 a_3747_6737.n3 VSS 3.50704f ; **FLOATING
C7310 a_3747_6737.t7 VSS 0.74053f ; **FLOATING
C7311 a_3747_6737.n4 VSS 3.50704f ; **FLOATING
C7312 a_3747_6737.t8 VSS 0.74053f ; **FLOATING
C7313 a_3747_6737.n5 VSS 3.50704f ; **FLOATING
C7314 a_3747_6737.t9 VSS 0.74053f ; **FLOATING
C7315 a_3747_6737.n6 VSS 5.20754f ; **FLOATING
C7316 a_3747_6737.t1 VSS 1.19007f ; **FLOATING
C7317 a_3747_6737.t0 VSS 0.31462f ; **FLOATING
C7318 a_2019_6001.t2 VSS 4.06443f ; **FLOATING
C7319 a_2019_6001.t3 VSS 21.8734f ; **FLOATING
C7320 a_2019_6001.t1 VSS 1.98687f ; **FLOATING
C7321 a_2019_6001.t0 VSS 0.44612f ; **FLOATING
C7322 a_2595_6001.t1 VSS 3.29781f ; **FLOATING
C7323 a_2595_6001.t2 VSS 5.08375f ; **FLOATING
C7324 a_2595_6001.t3 VSS 1.21644f ; **FLOATING
C7325 a_2595_6001.n0 VSS 27.0923f ; **FLOATING
C7326 a_2595_6001.t0 VSS 0.49988f ; **FLOATING
C7327 a_3171_6001.t2 VSS 5.08436f ; **FLOATING
C7328 a_3171_6001.t3 VSS 1.21971f ; **FLOATING
C7329 a_3171_6001.n0 VSS 30.0525f ; **FLOATING
C7330 a_3171_6001.t1 VSS 4.64283f ; **FLOATING
C7331 a_3171_6001.t0 VSS 0.50068f ; **FLOATING
C7332 a_3747_6001.t2 VSS 3.16182f ; **FLOATING
C7333 a_3747_6001.t3 VSS 0.76102f ; **FLOATING
C7334 a_3747_6001.n0 VSS 20.3374f ; **FLOATING
C7335 a_3747_6001.t1 VSS 3.77219f ; **FLOATING
C7336 a_3747_6001.t0 VSS 0.31226f ; **FLOATING
C7337 a_2019_3892.t2 VSS 0.92375f ; **FLOATING
C7338 a_2019_3892.t3 VSS 0.70129f ; **FLOATING
C7339 a_2019_3892.n0 VSS 4.97376f ; **FLOATING
C7340 a_2019_3892.t4 VSS 0.70129f ; **FLOATING
C7341 a_2019_3892.n1 VSS 3.36488f ; **FLOATING
C7342 a_2019_3892.t5 VSS 0.70129f ; **FLOATING
C7343 a_2019_3892.n2 VSS 3.36488f ; **FLOATING
C7344 a_2019_3892.t6 VSS 0.70129f ; **FLOATING
C7345 a_2019_3892.n3 VSS 3.36488f ; **FLOATING
C7346 a_2019_3892.t7 VSS 0.70129f ; **FLOATING
C7347 a_2019_3892.n4 VSS 3.36488f ; **FLOATING
C7348 a_2019_3892.t8 VSS 0.70129f ; **FLOATING
C7349 a_2019_3892.n5 VSS 3.36488f ; **FLOATING
C7350 a_2019_3892.t9 VSS 5.41665f ; **FLOATING
C7351 a_2019_3892.t1 VSS 1.06506f ; **FLOATING
C7352 a_2019_3892.t0 VSS 0.30272f ; **FLOATING
C7353 a_2595_3892.t2 VSS 1.36719f ; **FLOATING
C7354 a_2595_3892.t3 VSS 1.02106f ; **FLOATING
C7355 a_2595_3892.n0 VSS 7.76214f ; **FLOATING
C7356 a_2595_3892.t4 VSS 1.02106f ; **FLOATING
C7357 a_2595_3892.n1 VSS 5.27402f ; **FLOATING
C7358 a_2595_3892.t5 VSS 1.02106f ; **FLOATING
C7359 a_2595_3892.n2 VSS 5.27402f ; **FLOATING
C7360 a_2595_3892.t6 VSS 1.02106f ; **FLOATING
C7361 a_2595_3892.n3 VSS 5.27402f ; **FLOATING
C7362 a_2595_3892.t7 VSS 1.02106f ; **FLOATING
C7363 a_2595_3892.n4 VSS 5.27402f ; **FLOATING
C7364 a_2595_3892.t8 VSS 1.02106f ; **FLOATING
C7365 a_2595_3892.n5 VSS 5.27402f ; **FLOATING
C7366 a_2595_3892.t9 VSS 1.02106f ; **FLOATING
C7367 a_2595_3892.n6 VSS 7.58636f ; **FLOATING
C7368 a_2595_3892.t1 VSS 1.7514f ; **FLOATING
C7369 a_2595_3892.t0 VSS 0.48232f ; **FLOATING
C7370 a_3171_3892.t2 VSS 1.38481f ; **FLOATING
C7371 a_3171_3892.t3 VSS 1.03763f ; **FLOATING
C7372 a_3171_3892.n0 VSS 7.78078f ; **FLOATING
C7373 a_3171_3892.t4 VSS 1.03763f ; **FLOATING
C7374 a_3171_3892.n1 VSS 5.28233f ; **FLOATING
C7375 a_3171_3892.t5 VSS 1.03763f ; **FLOATING
C7376 a_3171_3892.n2 VSS 5.28233f ; **FLOATING
C7377 a_3171_3892.t6 VSS 1.03763f ; **FLOATING
C7378 a_3171_3892.n3 VSS 5.28233f ; **FLOATING
C7379 a_3171_3892.t7 VSS 1.03763f ; **FLOATING
C7380 a_3171_3892.n4 VSS 5.28233f ; **FLOATING
C7381 a_3171_3892.t8 VSS 1.03763f ; **FLOATING
C7382 a_3171_3892.n5 VSS 5.28233f ; **FLOATING
C7383 a_3171_3892.t9 VSS 1.03763f ; **FLOATING
C7384 a_3171_3892.n6 VSS 7.68566f ; **FLOATING
C7385 a_3171_3892.t1 VSS 1.77077f ; **FLOATING
C7386 a_3171_3892.t0 VSS 0.48098f ; **FLOATING
C7387 a_3747_3892.t2 VSS 0.97281f ; **FLOATING
C7388 a_3747_3892.t3 VSS 0.74061f ; **FLOATING
C7389 a_3747_3892.n0 VSS 5.18859f ; **FLOATING
C7390 a_3747_3892.t4 VSS 0.74061f ; **FLOATING
C7391 a_3747_3892.n1 VSS 3.50742f ; **FLOATING
C7392 a_3747_3892.t5 VSS 0.74061f ; **FLOATING
C7393 a_3747_3892.n2 VSS 3.50742f ; **FLOATING
C7394 a_3747_3892.t6 VSS 0.74061f ; **FLOATING
C7395 a_3747_3892.n3 VSS 3.50742f ; **FLOATING
C7396 a_3747_3892.t7 VSS 0.74061f ; **FLOATING
C7397 a_3747_3892.n4 VSS 3.50742f ; **FLOATING
C7398 a_3747_3892.t8 VSS 0.74061f ; **FLOATING
C7399 a_3747_3892.n5 VSS 3.50742f ; **FLOATING
C7400 a_3747_3892.t9 VSS 0.74061f ; **FLOATING
C7401 a_3747_3892.n6 VSS 5.2081f ; **FLOATING
C7402 a_3747_3892.t1 VSS 1.1902f ; **FLOATING
C7403 a_3747_3892.t0 VSS 0.31466f ; **FLOATING
C7404 a_2019_3156.t2 VSS 4.06443f ; **FLOATING
C7405 a_2019_3156.t3 VSS 21.8734f ; **FLOATING
C7406 a_2019_3156.t1 VSS 1.98687f ; **FLOATING
C7407 a_2019_3156.t0 VSS 0.44612f ; **FLOATING
C7408 a_2595_3156.t1 VSS 3.29781f ; **FLOATING
C7409 a_2595_3156.t2 VSS 5.08375f ; **FLOATING
C7410 a_2595_3156.t3 VSS 1.21644f ; **FLOATING
C7411 a_2595_3156.n0 VSS 27.0922f ; **FLOATING
C7412 a_2595_3156.t0 VSS 0.49988f ; **FLOATING
C7413 a_3171_3156.t2 VSS 5.08436f ; **FLOATING
C7414 a_3171_3156.t3 VSS 1.21971f ; **FLOATING
C7415 a_3171_3156.n0 VSS 30.0525f ; **FLOATING
C7416 a_3171_3156.t1 VSS 4.64283f ; **FLOATING
C7417 a_3171_3156.t0 VSS 0.50068f ; **FLOATING
C7418 a_3747_3156.t2 VSS 3.16182f ; **FLOATING
C7419 a_3747_3156.t3 VSS 0.76102f ; **FLOATING
C7420 a_3747_3156.n0 VSS 20.3375f ; **FLOATING
C7421 a_3747_3156.t1 VSS 3.77219f ; **FLOATING
C7422 a_3747_3156.t0 VSS 0.31226f ; **FLOATING
C7423 a_2019_1047.t2 VSS 0.92361f ; **FLOATING
C7424 a_2019_1047.t3 VSS 0.70118f ; **FLOATING
C7425 a_2019_1047.n0 VSS 4.97301f ; **FLOATING
C7426 a_2019_1047.t4 VSS 0.70118f ; **FLOATING
C7427 a_2019_1047.n1 VSS 3.36438f ; **FLOATING
C7428 a_2019_1047.t5 VSS 0.70118f ; **FLOATING
C7429 a_2019_1047.n2 VSS 3.36438f ; **FLOATING
C7430 a_2019_1047.t6 VSS 0.70118f ; **FLOATING
C7431 a_2019_1047.n3 VSS 3.36438f ; **FLOATING
C7432 a_2019_1047.t7 VSS 0.70118f ; **FLOATING
C7433 a_2019_1047.n4 VSS 3.36438f ; **FLOATING
C7434 a_2019_1047.t8 VSS 0.70118f ; **FLOATING
C7435 a_2019_1047.n5 VSS 3.36438f ; **FLOATING
C7436 a_2019_1047.t9 VSS 5.41584f ; **FLOATING
C7437 a_2019_1047.t1 VSS 1.0649f ; **FLOATING
C7438 a_2019_1047.t0 VSS 0.30268f ; **FLOATING
C7439 a_2595_1047.t2 VSS 1.36702f ; **FLOATING
C7440 a_2595_1047.t3 VSS 1.02094f ; **FLOATING
C7441 a_2595_1047.n0 VSS 7.76121f ; **FLOATING
C7442 a_2595_1047.t4 VSS 1.02094f ; **FLOATING
C7443 a_2595_1047.n1 VSS 5.27338f ; **FLOATING
C7444 a_2595_1047.t5 VSS 1.02094f ; **FLOATING
C7445 a_2595_1047.n2 VSS 5.27338f ; **FLOATING
C7446 a_2595_1047.t6 VSS 1.02094f ; **FLOATING
C7447 a_2595_1047.n3 VSS 5.27338f ; **FLOATING
C7448 a_2595_1047.t7 VSS 1.02094f ; **FLOATING
C7449 a_2595_1047.n4 VSS 5.27338f ; **FLOATING
C7450 a_2595_1047.t8 VSS 1.02094f ; **FLOATING
C7451 a_2595_1047.n5 VSS 5.27338f ; **FLOATING
C7452 a_2595_1047.t9 VSS 1.02094f ; **FLOATING
C7453 a_2595_1047.n6 VSS 7.58544f ; **FLOATING
C7454 a_2595_1047.t1 VSS 1.75118f ; **FLOATING
C7455 a_2595_1047.t0 VSS 0.48227f ; **FLOATING
C7456 a_3171_1047.t2 VSS 1.38457f ; **FLOATING
C7457 a_3171_1047.t3 VSS 1.03745f ; **FLOATING
C7458 a_3171_1047.n0 VSS 7.77938f ; **FLOATING
C7459 a_3171_1047.t4 VSS 1.03745f ; **FLOATING
C7460 a_3171_1047.n1 VSS 5.28138f ; **FLOATING
C7461 a_3171_1047.t5 VSS 1.03745f ; **FLOATING
C7462 a_3171_1047.n2 VSS 5.28138f ; **FLOATING
C7463 a_3171_1047.t6 VSS 1.03745f ; **FLOATING
C7464 a_3171_1047.n3 VSS 5.28138f ; **FLOATING
C7465 a_3171_1047.t7 VSS 1.03745f ; **FLOATING
C7466 a_3171_1047.n4 VSS 5.28138f ; **FLOATING
C7467 a_3171_1047.t8 VSS 1.03745f ; **FLOATING
C7468 a_3171_1047.n5 VSS 5.28138f ; **FLOATING
C7469 a_3171_1047.t9 VSS 1.03745f ; **FLOATING
C7470 a_3171_1047.n6 VSS 7.68428f ; **FLOATING
C7471 a_3171_1047.t1 VSS 1.77045f ; **FLOATING
C7472 a_3171_1047.t0 VSS 0.48089f ; **FLOATING
C7473 a_3747_1047.t2 VSS 0.97157f ; **FLOATING
C7474 a_3747_1047.t3 VSS 0.73967f ; **FLOATING
C7475 a_3747_1047.n0 VSS 5.18198f ; **FLOATING
C7476 a_3747_1047.t4 VSS 0.73967f ; **FLOATING
C7477 a_3747_1047.n1 VSS 3.50295f ; **FLOATING
C7478 a_3747_1047.t5 VSS 0.73967f ; **FLOATING
C7479 a_3747_1047.n2 VSS 3.50295f ; **FLOATING
C7480 a_3747_1047.t6 VSS 0.73967f ; **FLOATING
C7481 a_3747_1047.n3 VSS 3.50295f ; **FLOATING
C7482 a_3747_1047.t7 VSS 0.73967f ; **FLOATING
C7483 a_3747_1047.n4 VSS 3.50295f ; **FLOATING
C7484 a_3747_1047.t8 VSS 0.73967f ; **FLOATING
C7485 a_3747_1047.n5 VSS 3.50295f ; **FLOATING
C7486 a_3747_1047.t9 VSS 0.73967f ; **FLOATING
C7487 a_3747_1047.n6 VSS 5.20147f ; **FLOATING
C7488 a_3747_1047.t1 VSS 1.18868f ; **FLOATING
C7489 a_3747_1047.t0 VSS 0.31426f ; **FLOATING
C7490 a_2595_311.t1 VSS 3.27058f ; **FLOATING
C7491 a_2595_311.t2 VSS 5.04178f ; **FLOATING
C7492 a_2595_311.t3 VSS 1.2064f ; **FLOATING
C7493 a_2595_311.n0 VSS 26.8686f ; **FLOATING
C7494 a_2595_311.t0 VSS 0.49575f ; **FLOATING
C7495 a_3171_311.t2 VSS 5.05127f ; **FLOATING
C7496 a_3171_311.t3 VSS 1.21178f ; **FLOATING
C7497 a_3171_311.n0 VSS 29.8569f ; **FLOATING
C7498 a_3171_311.t1 VSS 4.61261f ; **FLOATING
C7499 a_3171_311.t0 VSS 0.49742f ; **FLOATING
C7500 a_3747_311.t2 VSS 3.13711f ; **FLOATING
C7501 a_3747_311.t3 VSS 0.75507f ; **FLOATING
C7502 a_3747_311.n0 VSS 20.1785f ; **FLOATING
C7503 a_3747_311.t1 VSS 3.74272f ; **FLOATING
C7504 a_3747_311.t0 VSS 0.30982f ; **FLOATING
C7505 VSS.t2296 VSS 3.25285f ; **FLOATING
C7506 VDD.n0 VSS 0.50879f ; **FLOATING
C7507 VDD.t20 VSS 53.7701f ; **FLOATING
C7508 VDD.n3 VSS 0.50879f ; **FLOATING
C7509 VDD.n4 VSS 0.50879f ; **FLOATING
C7510 VDD.n6 VSS 0.06436f ; **FLOATING
C7511 VDD.n7 VSS 0.50876f ; **FLOATING
C7512 VDD.n9 VSS 0.02323f ; **FLOATING
C7513 VDD.n10 VSS 0.09648f ; **FLOATING
C7514 VDD.n11 VSS 0.32867f ; **FLOATING
C7515 VDD.n12 VSS 0.31447f ; **FLOATING
C7516 VDD.t365 VSS 47.7356f ; **FLOATING
C7517 VDD.n13 VSS 0.01897f ; **FLOATING
C7518 VDD.n14 VSS 0.11895f ; **FLOATING
C7519 VDD.n15 VSS 0.37013f ; **FLOATING
C7520 VDD.n16 VSS 0.02292f ; **FLOATING
C7521 VDD.t636 VSS 0.0387f ; **FLOATING
C7522 VDD.n17 VSS 0.37013f ; **FLOATING
C7523 VDD.n18 VSS 0.14383f ; **FLOATING
C7524 VDD.n19 VSS 0.06128f ; **FLOATING
C7525 VDD.t36 VSS 53.7701f ; **FLOATING
C7526 VDD.n20 VSS 1.25266f ; **FLOATING
C7527 VDD.n21 VSS 0.58724f ; **FLOATING
C7528 VDD.n22 VSS 0.78416f ; **FLOATING
C7529 VDD.n24 VSS 0.53433f ; **FLOATING
C7530 VDD.n25 VSS 0.49309f ; **FLOATING
C7531 VDD.n26 VSS 0.02538f ; **FLOATING
C7532 VDD.n27 VSS 0.40544f ; **FLOATING
C7533 VDD.n29 VSS 0.1009f ; **FLOATING
C7534 VDD.n30 VSS 0.02323f ; **FLOATING
C7535 VDD.n31 VSS 0.59952f ; **FLOATING
C7536 VDD.n33 VSS 1.37671f ; **FLOATING
C7537 VDD.t638 VSS 0.02015f ; **FLOATING
C7538 VDD.n34 VSS 0.15217f ; **FLOATING
C7539 VDD.n35 VSS 0.04824f ; **FLOATING
C7540 VDD.n36 VSS 0.1623f ; **FLOATING
C7541 VDD.n37 VSS 0.02538f ; **FLOATING
C7542 VDD.n38 VSS 0.04278f ; **FLOATING
C7543 VDD.n39 VSS 0.16226f ; **FLOATING
C7544 VDD.n40 VSS 0.04818f ; **FLOATING
C7545 VDD.n41 VSS 0.16226f ; **FLOATING
C7546 VDD.n42 VSS 0.02538f ; **FLOATING
C7547 VDD.n43 VSS 0.04278f ; **FLOATING
C7548 VDD.n44 VSS 0.16226f ; **FLOATING
C7549 VDD.n45 VSS 0.04818f ; **FLOATING
C7550 VDD.n46 VSS 0.16226f ; **FLOATING
C7551 VDD.t339 VSS 47.1229f ; **FLOATING
C7552 VDD.t381 VSS 47.1207f ; **FLOATING
C7553 VDD.n47 VSS 0.01044f ; **FLOATING
C7554 VDD.n48 VSS 0.04818f ; **FLOATING
C7555 VDD.n49 VSS 0.04818f ; **FLOATING
C7556 VDD.n50 VSS 0.40005f ; **FLOATING
C7557 VDD.n52 VSS 0.07659f ; **FLOATING
C7558 VDD.n54 VSS 0.07659f ; **FLOATING
C7559 VDD.t29 VSS 53.7701f ; **FLOATING
C7560 VDD.n56 VSS 0.07659f ; **FLOATING
C7561 VDD.t9 VSS 53.7701f ; **FLOATING
C7562 VDD.n58 VSS 0.07659f ; **FLOATING
C7563 VDD.t0 VSS 53.7701f ; **FLOATING
C7564 VDD.n60 VSS 0.07659f ; **FLOATING
C7565 VDD.n61 VSS 0.02538f ; **FLOATING
C7566 VDD.n62 VSS 0.17341f ; **FLOATING
C7567 VDD.t628 VSS 0.02013f ; **FLOATING
C7568 VDD.n64 VSS 0.09065f ; **FLOATING
C7569 VDD.n65 VSS 0.04223f ; **FLOATING
C7570 VDD.n66 VSS 0.02041f ; **FLOATING
C7571 VDD.n67 VSS 0.01701f ; **FLOATING
C7572 VDD.n68 VSS 0.05012f ; **FLOATING
C7573 VDD.n69 VSS 0.16897f ; **FLOATING
C7574 VDD.n70 VSS 0.077f ; **FLOATING
C7575 VDD.n71 VSS 0.077f ; **FLOATING
C7576 VDD.n72 VSS 0.077f ; **FLOATING
C7577 VDD.n73 VSS 0.077f ; **FLOATING
C7578 VDD.n74 VSS 0.077f ; **FLOATING
C7579 VDD.n75 VSS 0.02041f ; **FLOATING
C7580 VDD.n76 VSS 0.05807f ; **FLOATING
C7581 VDD.n77 VSS 0.01701f ; **FLOATING
C7582 VDD.n78 VSS 0.1201f ; **FLOATING
C7583 VDD.n79 VSS 0.08007f ; **FLOATING
C7584 VDD.n81 VSS 0.01869f ; **FLOATING
C7585 VDD.n82 VSS 0.01978f ; **FLOATING
C7586 VDD.n83 VSS 0.10755f ; **FLOATING
C7587 VDD.n84 VSS 0.10755f ; **FLOATING
C7588 VDD.n85 VSS 0.10755f ; **FLOATING
C7589 VDD.n86 VSS 0.10755f ; **FLOATING
C7590 VDD.n87 VSS 0.10755f ; **FLOATING
C7591 VDD.n88 VSS 0.21984f ; **FLOATING
C7592 VDD.n89 VSS 0.06366f ; **FLOATING
C7593 VDD.n90 VSS 0.03105f ; **FLOATING
C7594 VDD.n92 VSS 0.0341f ; **FLOATING
C7595 VDD.n94 VSS 0.03105f ; **FLOATING
C7596 VDD.n95 VSS 0.03105f ; **FLOATING
C7597 VDD.n97 VSS 0.0341f ; **FLOATING
C7598 VDD.n99 VSS 0.03105f ; **FLOATING
C7599 VDD.n100 VSS 0.03105f ; **FLOATING
C7600 VDD.n102 VSS 0.04788f ; **FLOATING
C7601 VDD.n103 VSS 0.04743f ; **FLOATING
C7602 VDD.n104 VSS 0.15767f ; **FLOATING
C7603 VDD.n105 VSS 0.02538f ; **FLOATING
C7604 VDD.n106 VSS 0.04793f ; **FLOATING
C7605 VDD.n107 VSS 0.15764f ; **FLOATING
C7606 VDD.n108 VSS 0.04793f ; **FLOATING
C7607 VDD.n109 VSS 0.04739f ; **FLOATING
C7608 VDD.n110 VSS 0.15764f ; **FLOATING
C7609 VDD.n111 VSS 0.02538f ; **FLOATING
C7610 VDD.n112 VSS 0.04793f ; **FLOATING
C7611 VDD.n113 VSS 0.15764f ; **FLOATING
C7612 VDD.n114 VSS 0.04793f ; **FLOATING
C7613 VDD.n115 VSS 0.04739f ; **FLOATING
C7614 VDD.n116 VSS 0.15764f ; **FLOATING
C7615 VDD.n117 VSS 0.11657f ; **FLOATING
C7616 VDD.n118 VSS 0.11657f ; **FLOATING
C7617 VDD.n119 VSS 0.02538f ; **FLOATING
C7618 VDD.n120 VSS 0.10025f ; **FLOATING
C7619 VDD.n122 VSS 0.02538f ; **FLOATING
C7620 VDD.n123 VSS 0.10027f ; **FLOATING
C7621 VDD.n125 VSS 0.16214f ; **FLOATING
C7622 VDD.n126 VSS 0.02538f ; **FLOATING
C7623 VDD.n127 VSS 0.1888f ; **FLOATING
C7624 VDD.n129 VSS 0.02538f ; **FLOATING
C7625 VDD.n130 VSS 0.10024f ; **FLOATING
C7626 VDD.n133 VSS 0.02538f ; **FLOATING
C7627 VDD.n134 VSS 0.14657f ; **FLOATING
C7628 VDD.n135 VSS 0.02538f ; **FLOATING
C7629 VDD.n136 VSS 0.10024f ; **FLOATING
C7630 VDD.n138 VSS 0.02538f ; **FLOATING
C7631 VDD.n139 VSS 0.10027f ; **FLOATING
C7632 VDD.n141 VSS 0.02538f ; **FLOATING
C7633 VDD.n142 VSS 0.10025f ; **FLOATING
C7634 VDD.n144 VSS 0.09091f ; **FLOATING
C7635 VDD.n145 VSS 0.02538f ; **FLOATING
C7636 VDD.n146 VSS 0.19871f ; **FLOATING
C7637 VDD.n147 VSS 0.01908f ; **FLOATING
C7638 VDD.n148 VSS 0.02538f ; **FLOATING
C7639 VDD.n149 VSS 0.10024f ; **FLOATING
C7640 VDD.n151 VSS 0.10515f ; **FLOATING
C7641 VDD.n152 VSS 0.02538f ; **FLOATING
C7642 VDD.n153 VSS 0.18885f ; **FLOATING
C7643 VDD.n154 VSS 0.09122f ; **FLOATING
C7644 VDD.n156 VSS 0.02538f ; **FLOATING
C7645 VDD.n157 VSS 0.04964f ; **FLOATING
C7646 VDD.n158 VSS 0.02538f ; **FLOATING
C7647 VDD.n159 VSS 0.10027f ; **FLOATING
C7648 VDD.n161 VSS 0.02538f ; **FLOATING
C7649 VDD.n162 VSS 0.10025f ; **FLOATING
C7650 VDD.n164 VSS 0.18698f ; **FLOATING
C7651 VDD.n165 VSS 0.02538f ; **FLOATING
C7652 VDD.n166 VSS 0.09087f ; **FLOATING
C7653 VDD.n167 VSS 0.17154f ; **FLOATING
C7654 VDD.n168 VSS 0.53163f ; **FLOATING
C7655 VDD.n169 VSS 0.02538f ; **FLOATING
C7656 VDD.n170 VSS 0.08623f ; **FLOATING
C7657 VDD.n172 VSS 0.02538f ; **FLOATING
C7658 VDD.n173 VSS 0.19871f ; **FLOATING
C7659 VDD.n174 VSS 0.01908f ; **FLOATING
C7660 VDD.n175 VSS 0.0836f ; **FLOATING
C7661 VDD.n176 VSS 0.02538f ; **FLOATING
C7662 VDD.n177 VSS 0.10024f ; **FLOATING
C7663 VDD.n179 VSS 0.02538f ; **FLOATING
C7664 VDD.n180 VSS 0.19873f ; **FLOATING
C7665 VDD.n181 VSS 0.01794f ; **FLOATING
C7666 VDD.n182 VSS 0.1808f ; **FLOATING
C7667 VDD.n183 VSS 0.02538f ; **FLOATING
C7668 VDD.n184 VSS 0.1002f ; **FLOATING
C7669 VDD.n186 VSS 0.02538f ; **FLOATING
C7670 VDD.n187 VSS 0.10025f ; **FLOATING
C7671 VDD.n189 VSS 0.21895f ; **FLOATING
C7672 VDD.n190 VSS 0.02538f ; **FLOATING
C7673 VDD.n191 VSS 0.19873f ; **FLOATING
C7674 VDD.n192 VSS 0.01743f ; **FLOATING
C7675 VDD.n193 VSS 0.09846f ; **FLOATING
C7676 VDD.n194 VSS 0.02286f ; **FLOATING
C7677 VDD.n195 VSS 0.16209f ; **FLOATING
C7678 VDD.n196 VSS 0.02538f ; **FLOATING
C7679 VDD.n197 VSS 0.1987f ; **FLOATING
C7680 VDD.n198 VSS 0.01793f ; **FLOATING
C7681 VDD.n199 VSS 0.02538f ; **FLOATING
C7682 VDD.n200 VSS 0.08363f ; **FLOATING
C7683 VDD.n201 VSS 0.19866f ; **FLOATING
C7684 VDD.n202 VSS 0.01911f ; **FLOATING
C7685 VDD.n203 VSS 0.0836f ; **FLOATING
C7686 VDD.n204 VSS 0.02538f ; **FLOATING
C7687 VDD.n205 VSS 0.10024f ; **FLOATING
C7688 VDD.n207 VSS 0.02538f ; **FLOATING
C7689 VDD.n208 VSS 0.10021f ; **FLOATING
C7690 VDD.n210 VSS 0.02538f ; **FLOATING
C7691 VDD.n211 VSS 0.10022f ; **FLOATING
C7692 VDD.n213 VSS 0.02538f ; **FLOATING
C7693 VDD.n214 VSS 0.09445f ; **FLOATING
C7694 VDD.n215 VSS 0.18888f ; **FLOATING
C7695 VDD.n216 VSS 0.02538f ; **FLOATING
C7696 VDD.n217 VSS 0.10027f ; **FLOATING
C7697 VDD.n219 VSS 0.02538f ; **FLOATING
C7698 VDD.n220 VSS 0.10027f ; **FLOATING
C7699 VDD.n222 VSS 0.1797f ; **FLOATING
C7700 VDD.n223 VSS 0.01906f ; **FLOATING
C7701 VDD.n224 VSS 0.02538f ; **FLOATING
C7702 VDD.n225 VSS 0.19866f ; **FLOATING
C7703 VDD.n226 VSS 0.09172f ; **FLOATING
C7704 VDD.n228 VSS 0.02538f ; **FLOATING
C7705 VDD.n229 VSS 0.10021f ; **FLOATING
C7706 VDD.n230 VSS 0.02538f ; **FLOATING
C7707 VDD.n231 VSS 0.02775f ; **FLOATING
C7708 VDD.n232 VSS 0.02273f ; **FLOATING
C7709 VDD.n233 VSS 0.07456f ; **FLOATING
C7710 VDD.n234 VSS 0.18697f ; **FLOATING
C7711 VDD.n235 VSS 0.04041f ; **FLOATING
C7712 VDD.n236 VSS 0.02147f ; **FLOATING
C7713 VDD.n237 VSS 0.07503f ; **FLOATING
C7714 VDD.n238 VSS 0.23218f ; **FLOATING
C7715 VDD.n239 VSS 0.02147f ; **FLOATING
C7716 VDD.n240 VSS 0.07503f ; **FLOATING
C7717 VDD.n241 VSS 0.23218f ; **FLOATING
C7718 VDD.n242 VSS 0.02147f ; **FLOATING
C7719 VDD.n243 VSS 0.07503f ; **FLOATING
C7720 VDD.n244 VSS 0.23218f ; **FLOATING
C7721 VDD.n245 VSS 0.02147f ; **FLOATING
C7722 VDD.n246 VSS 0.07503f ; **FLOATING
C7723 VDD.n247 VSS 0.23218f ; **FLOATING
C7724 VDD.n248 VSS 0.02147f ; **FLOATING
C7725 VDD.n249 VSS 0.07503f ; **FLOATING
C7726 VDD.n250 VSS 0.23218f ; **FLOATING
C7727 VDD.n251 VSS 0.07372f ; **FLOATING
C7728 VDD.n252 VSS 0.02611f ; **FLOATING
C7729 VDD.n253 VSS 0.02611f ; **FLOATING
C7730 VDD.n254 VSS 0.21713f ; **FLOATING
C7731 VDD.n255 VSS 0.02538f ; **FLOATING
C7732 VDD.n256 VSS 0.0254f ; **FLOATING
C7733 VDD.n257 VSS 0.23513f ; **FLOATING
C7734 VDD.n258 VSS 0.09846f ; **FLOATING
C7735 VDD.n260 VSS 0.09845f ; **FLOATING
C7736 VDD.n261 VSS 0.02249f ; **FLOATING
C7737 VDD.n262 VSS 0.09844f ; **FLOATING
C7738 VDD.n263 VSS 0.02247f ; **FLOATING
C7739 VDD.n264 VSS 0.09844f ; **FLOATING
C7740 VDD.n265 VSS 0.02538f ; **FLOATING
C7741 VDD.n266 VSS 0.10022f ; **FLOATING
C7742 VDD.n267 VSS 0.02538f ; **FLOATING
C7743 VDD.n268 VSS 0.19873f ; **FLOATING
C7744 VDD.n269 VSS 0.02538f ; **FLOATING
C7745 VDD.n270 VSS 0.19873f ; **FLOATING
C7746 VDD.n271 VSS 0.01793f ; **FLOATING
C7747 VDD.n272 VSS 0.02538f ; **FLOATING
C7748 VDD.n273 VSS 0.10022f ; **FLOATING
C7749 VDD.n275 VSS 0.02538f ; **FLOATING
C7750 VDD.n276 VSS 0.1002f ; **FLOATING
C7751 VDD.n277 VSS 0.52004f ; **FLOATING
C7752 VDD.n278 VSS 0.02538f ; **FLOATING
C7753 VDD.n279 VSS 0.08623f ; **FLOATING
C7754 VDD.n281 VSS 0.16215f ; **FLOATING
C7755 VDD.n282 VSS 0.02538f ; **FLOATING
C7756 VDD.n283 VSS 0.19866f ; **FLOATING
C7757 VDD.n284 VSS 0.01794f ; **FLOATING
C7758 VDD.n285 VSS 0.17333f ; **FLOATING
C7759 VDD.n286 VSS 0.02538f ; **FLOATING
C7760 VDD.n287 VSS 0.1987f ; **FLOATING
C7761 VDD.n288 VSS 0.01794f ; **FLOATING
C7762 VDD.n289 VSS 0.08358f ; **FLOATING
C7763 VDD.n290 VSS 0.02538f ; **FLOATING
C7764 VDD.n291 VSS 0.10026f ; **FLOATING
C7765 VDD.n292 VSS 0.0836f ; **FLOATING
C7766 VDD.n293 VSS 0.02538f ; **FLOATING
C7767 VDD.n294 VSS 0.10024f ; **FLOATING
C7768 VDD.n296 VSS 0.02538f ; **FLOATING
C7769 VDD.n297 VSS 0.28073f ; **FLOATING
C7770 VDD.n298 VSS 0.02538f ; **FLOATING
C7771 VDD.n299 VSS 0.10026f ; **FLOATING
C7772 VDD.n300 VSS 0.02538f ; **FLOATING
C7773 VDD.n301 VSS 0.10027f ; **FLOATING
C7774 VDD.n303 VSS 0.02538f ; **FLOATING
C7775 VDD.n304 VSS 0.07256f ; **FLOATING
C7776 VDD.n305 VSS 0.21919f ; **FLOATING
C7777 VDD.n306 VSS 0.02538f ; **FLOATING
C7778 VDD.n307 VSS 0.02538f ; **FLOATING
C7779 VDD.n308 VSS 0.26233f ; **FLOATING
C7780 VDD.n309 VSS 0.01927f ; **FLOATING
C7781 VDD.n310 VSS 0.17335f ; **FLOATING
C7782 VDD.n311 VSS 0.0254f ; **FLOATING
C7783 VDD.n312 VSS 0.02538f ; **FLOATING
C7784 VDD.n313 VSS 0.14813f ; **FLOATING
C7785 VDD.n314 VSS 0.02263f ; **FLOATING
C7786 VDD.n315 VSS 0.02538f ; **FLOATING
C7787 VDD.n316 VSS 0.17699f ; **FLOATING
C7788 VDD.n317 VSS 0.02176f ; **FLOATING
C7789 VDD.n318 VSS 0.1481f ; **FLOATING
C7790 VDD.n319 VSS 0.02538f ; **FLOATING
C7791 VDD.n320 VSS 0.14815f ; **FLOATING
C7792 VDD.n321 VSS 0.02538f ; **FLOATING
C7793 VDD.n322 VSS 0.02263f ; **FLOATING
C7794 VDD.n323 VSS 0.25329f ; **FLOATING
C7795 VDD.n324 VSS 0.02273f ; **FLOATING
C7796 VDD.n325 VSS 0.02775f ; **FLOATING
C7797 VDD.n326 VSS 0.02538f ; **FLOATING
C7798 VDD.n327 VSS 0.01488f ; **FLOATING
C7799 VDD.n328 VSS 0.25068f ; **FLOATING
C7800 VDD.n329 VSS 0.24254f ; **FLOATING
C7801 VDD.n331 VSS 0.17025f ; **FLOATING
C7802 VDD.n332 VSS 0.02538f ; **FLOATING
C7803 VDD.n333 VSS 0.26062f ; **FLOATING
C7804 VDD.n334 VSS 2.15635f ; **FLOATING
C7805 VDD.n335 VSS 1.63111f ; **FLOATING
C7806 VDD.n336 VSS 3.66912f ; **FLOATING
C7807 VDD.n337 VSS 0.02538f ; **FLOATING
C7808 VDD.n338 VSS 0.02775f ; **FLOATING
C7809 VDD.n339 VSS 0.02273f ; **FLOATING
C7810 VDD.n340 VSS 0.04028f ; **FLOATING
C7811 VDD.n341 VSS 0.25068f ; **FLOATING
C7812 VDD.n342 VSS 0.06128f ; **FLOATING
C7813 VDD.n343 VSS 0.14383f ; **FLOATING
C7814 VDD.n344 VSS 0.71836f ; **FLOATING
C7815 VDD.n345 VSS 0.18708f ; **FLOATING
C7816 VDD.n346 VSS 0.18708f ; **FLOATING
C7817 VDD.n347 VSS 0.18708f ; **FLOATING
C7818 VDD.n348 VSS 0.18708f ; **FLOATING
C7819 VDD.n349 VSS 0.18708f ; **FLOATING
C7820 VDD.n351 VSS 0.14383f ; **FLOATING
C7821 VDD.n352 VSS 0.998f ; **FLOATING
C7822 VDD.n354 VSS 0.14383f ; **FLOATING
C7823 VDD.n355 VSS 0.998f ; **FLOATING
C7824 VDD.n356 VSS 0.14383f ; **FLOATING
C7825 VDD.n357 VSS 0.998f ; **FLOATING
C7826 VDD.n359 VSS 0.14383f ; **FLOATING
C7827 VDD.n360 VSS 0.998f ; **FLOATING
C7828 VDD.n362 VSS 0.14383f ; **FLOATING
C7829 VDD.n363 VSS 0.998f ; **FLOATING
C7830 VDD.n365 VSS 0.14383f ; **FLOATING
C7831 VDD.n366 VSS 0.998f ; **FLOATING
C7832 VDD.n368 VSS 0.14383f ; **FLOATING
C7833 VDD.n369 VSS 0.998f ; **FLOATING
C7834 VDD.n371 VSS 0.14383f ; **FLOATING
C7835 VDD.n372 VSS 0.998f ; **FLOATING
C7836 VDD.n374 VSS 0.14383f ; **FLOATING
C7837 VDD.n375 VSS 0.998f ; **FLOATING
C7838 VDD.n377 VSS 0.14383f ; **FLOATING
C7839 VDD.n378 VSS 0.40413f ; **FLOATING
C7840 VDD.n379 VSS 0.14383f ; **FLOATING
C7841 VDD.n380 VSS 0.998f ; **FLOATING
C7842 VDD.n382 VSS 0.14383f ; **FLOATING
C7843 VDD.n383 VSS 0.998f ; **FLOATING
C7844 VDD.n385 VSS 0.14383f ; **FLOATING
C7845 VDD.n386 VSS 0.998f ; **FLOATING
C7846 VDD.n388 VSS 0.14383f ; **FLOATING
C7847 VDD.n389 VSS 0.40413f ; **FLOATING
C7848 VDD.n390 VSS 0.14383f ; **FLOATING
C7849 VDD.n391 VSS 0.998f ; **FLOATING
C7850 VDD.n393 VSS 0.14383f ; **FLOATING
C7851 VDD.n394 VSS 0.998f ; **FLOATING
C7852 VDD.n396 VSS 0.14383f ; **FLOATING
C7853 VDD.n397 VSS 0.998f ; **FLOATING
C7854 VDD.n399 VSS 0.14383f ; **FLOATING
C7855 VDD.n400 VSS 0.998f ; **FLOATING
C7856 VDD.n402 VSS 0.14383f ; **FLOATING
C7857 VDD.n403 VSS 0.40413f ; **FLOATING
C7858 VDD.n405 VSS 0.14383f ; **FLOATING
C7859 VDD.n406 VSS 0.22261f ; **FLOATING
C7860 VDD.n407 VSS 0.14383f ; **FLOATING
C7861 VDD.n408 VSS 0.22261f ; **FLOATING
C7862 VDD.n409 VSS 0.14383f ; **FLOATING
C7863 VDD.n410 VSS 0.78416f ; **FLOATING
C7864 VDD.n411 VSS 0.14383f ; **FLOATING
C7865 VDD.n412 VSS 0.78416f ; **FLOATING
C7866 VDD.n414 VSS 0.14383f ; **FLOATING
C7867 VDD.n415 VSS 0.14383f ; **FLOATING
C7868 VDD.n416 VSS 0.78419f ; **FLOATING
C7869 VDD.n417 VSS 0.58867f ; **FLOATING
C7870 VDD.n418 VSS 0.12548f ; **FLOATING
C7871 VDD.n419 VSS 0.58867f ; **FLOATING
C7872 VDD.n420 VSS 0.58867f ; **FLOATING
C7873 VDD.n421 VSS 0.5887f ; **FLOATING
C7874 VDD.n422 VSS 0.06128f ; **FLOATING
C7875 VDD.n423 VSS 0.06128f ; **FLOATING
C7876 VDD.n424 VSS 0.12548f ; **FLOATING
C7877 VDD.n425 VSS 0.58869f ; **FLOATING
C7878 VDD.n426 VSS 0.06128f ; **FLOATING
C7879 VDD.n427 VSS 0.06128f ; **FLOATING
C7880 VDD.n428 VSS 0.06128f ; **FLOATING
C7881 VDD.n429 VSS 0.06128f ; **FLOATING
C7882 VDD.n430 VSS 0.86216f ; **FLOATING
C7883 VDD.n431 VSS 0.06128f ; **FLOATING
C7884 VDD.n432 VSS 0.06128f ; **FLOATING
C7885 VDD.n433 VSS 0.06128f ; **FLOATING
C7886 VDD.n434 VSS 0.06128f ; **FLOATING
C7887 VDD.n435 VSS 0.06128f ; **FLOATING
C7888 VDD.n436 VSS 0.86216f ; **FLOATING
C7889 VDD.n437 VSS 0.06128f ; **FLOATING
C7890 VDD.n438 VSS 0.06128f ; **FLOATING
C7891 VDD.n439 VSS 0.06128f ; **FLOATING
C7892 VDD.n440 VSS 0.06128f ; **FLOATING
C7893 VDD.n441 VSS 0.86216f ; **FLOATING
C7894 VDD.n442 VSS 0.23116f ; **FLOATING
C7895 VDD.n443 VSS 0.18236f ; **FLOATING
C7896 VDD.n444 VSS 0.18236f ; **FLOATING
C7897 VDD.n445 VSS 0.18236f ; **FLOATING
C7898 VDD.n446 VSS 0.18236f ; **FLOATING
C7899 VDD.n447 VSS 0.18236f ; **FLOATING
C7900 VDD.n448 VSS 0.07759f ; **FLOATING
C7901 VDD.n449 VSS 0.02538f ; **FLOATING
C7902 VDD.n450 VSS 0.19868f ; **FLOATING
C7903 VDD.n451 VSS 0.01703f ; **FLOATING
C7904 VDD.n452 VSS 0.04039f ; **FLOATING
C7905 VDD.n453 VSS 0.02538f ; **FLOATING
C7906 VDD.n454 VSS 0.02775f ; **FLOATING
C7907 VDD.n455 VSS 0.02273f ; **FLOATING
C7908 VDD.n456 VSS 0.04028f ; **FLOATING
C7909 VDD.n457 VSS 0.02538f ; **FLOATING
C7910 VDD.n458 VSS 0.01867f ; **FLOATING
C7911 VDD.n459 VSS 0.18151f ; **FLOATING
C7912 VDD.n460 VSS 0.18151f ; **FLOATING
C7913 VDD.n461 VSS 0.02538f ; **FLOATING
C7914 VDD.n462 VSS 0.10027f ; **FLOATING
C7915 VDD.n464 VSS 0.16926f ; **FLOATING
C7916 VDD.n465 VSS 0.03669f ; **FLOATING
C7917 VDD.n466 VSS 0.02538f ; **FLOATING
C7918 VDD.n467 VSS 0.16928f ; **FLOATING
C7919 VDD.n468 VSS 0.11687f ; **FLOATING
C7920 VDD.n469 VSS 0.11687f ; **FLOATING
C7921 VDD.n470 VSS 0.11687f ; **FLOATING
C7922 VDD.n471 VSS 0.11687f ; **FLOATING
C7923 VDD.n472 VSS 0.11687f ; **FLOATING
C7924 VDD.n473 VSS 0.07373f ; **FLOATING
C7925 VDD.n474 VSS 0.10515f ; **FLOATING
C7926 VDD.n475 VSS 0.09506f ; **FLOATING
C7927 VDD.n476 VSS 0.09689f ; **FLOATING
C7928 VDD.n477 VSS 0.17613f ; **FLOATING
C7929 VDD.n479 VSS 0.17613f ; **FLOATING
C7930 VDD.n481 VSS 0.17613f ; **FLOATING
C7931 VDD.n483 VSS 0.09443f ; **FLOATING
C7932 VDD.n484 VSS 0.03663f ; **FLOATING
C7933 VDD.n485 VSS 0.02538f ; **FLOATING
C7934 VDD.n486 VSS 0.02538f ; **FLOATING
C7935 VDD.n487 VSS 0.02538f ; **FLOATING
C7936 VDD.n488 VSS 0.1808f ; **FLOATING
C7937 VDD.n489 VSS 0.09399f ; **FLOATING
C7938 VDD.n490 VSS 0.03663f ; **FLOATING
C7939 VDD.n491 VSS 0.02538f ; **FLOATING
C7940 VDD.n492 VSS 0.02538f ; **FLOATING
C7941 VDD.n493 VSS 0.171f ; **FLOATING
C7942 VDD.n494 VSS 0.02538f ; **FLOATING
C7943 VDD.n495 VSS 0.16208f ; **FLOATING
C7944 VDD.n496 VSS 0.02538f ; **FLOATING
C7945 VDD.n497 VSS 0.17101f ; **FLOATING
C7946 VDD.n498 VSS 0.02538f ; **FLOATING
C7947 VDD.n499 VSS 0.16207f ; **FLOATING
C7948 VDD.n500 VSS 0.02538f ; **FLOATING
C7949 VDD.n501 VSS 0.16115f ; **FLOATING
C7950 VDD.n502 VSS 0.02538f ; **FLOATING
C7951 VDD.n503 VSS 0.02538f ; **FLOATING
C7952 VDD.n504 VSS 0.17096f ; **FLOATING
C7953 VDD.n505 VSS 0.02538f ; **FLOATING
C7954 VDD.n506 VSS 0.02538f ; **FLOATING
C7955 VDD.n507 VSS 0.17107f ; **FLOATING
C7956 VDD.n508 VSS 0.02538f ; **FLOATING
C7957 VDD.n509 VSS 0.17588f ; **FLOATING
C7958 VDD.n510 VSS 0.03669f ; **FLOATING
C7959 VDD.n511 VSS 0.02538f ; **FLOATING
C7960 VDD.n512 VSS 0.02771f ; **FLOATING
C7961 VDD.n513 VSS 0.02538f ; **FLOATING
C7962 VDD.n514 VSS 0.17097f ; **FLOATING
C7963 VDD.n515 VSS 0.02538f ; **FLOATING
C7964 VDD.n516 VSS 0.17101f ; **FLOATING
C7965 VDD.n517 VSS 0.08358f ; **FLOATING
C7966 VDD.n518 VSS 0.03663f ; **FLOATING
C7967 VDD.n519 VSS 0.02538f ; **FLOATING
C7968 VDD.n520 VSS 0.16212f ; **FLOATING
C7969 VDD.n521 VSS 0.09517f ; **FLOATING
C7970 VDD.n522 VSS 0.03663f ; **FLOATING
C7971 VDD.n523 VSS 0.02538f ; **FLOATING
C7972 VDD.n524 VSS 0.16213f ; **FLOATING
C7973 VDD.n525 VSS 0.02538f ; **FLOATING
C7974 VDD.n526 VSS 0.02538f ; **FLOATING
C7975 VDD.n527 VSS 0.1733f ; **FLOATING
C7976 VDD.n528 VSS 0.02538f ; **FLOATING
C7977 VDD.n529 VSS 0.17966f ; **FLOATING
C7978 VDD.n530 VSS 0.02538f ; **FLOATING
C7979 VDD.n531 VSS 0.02772f ; **FLOATING
C7980 VDD.n532 VSS 0.16205f ; **FLOATING
C7981 VDD.n533 VSS 0.02538f ; **FLOATING
C7982 VDD.n534 VSS 0.1621f ; **FLOATING
C7983 VDD.n535 VSS 0.02538f ; **FLOATING
C7984 VDD.n536 VSS 0.02538f ; **FLOATING
C7985 VDD.n537 VSS 0.02538f ; **FLOATING
C7986 VDD.n538 VSS 0.16202f ; **FLOATING
C7987 VDD.n539 VSS 0.78565f ; **FLOATING
C7988 VDD.n540 VSS 0.78565f ; **FLOATING
C7989 VDD.n541 VSS 0.78565f ; **FLOATING
C7990 VDD.n542 VSS 1.62886f ; **FLOATING
C7991 VDD.n543 VSS 1.0272f ; **FLOATING
C7992 VDD.n544 VSS 1.6747f ; **FLOATING
C7993 VDD.n546 VSS 0.14383f ; **FLOATING
C7994 VDD.n547 VSS 0.13581f ; **FLOATING
C7995 VDD.n548 VSS 0.14383f ; **FLOATING
C7996 VDD.n549 VSS 0.13584f ; **FLOATING
C7997 VDD.n551 VSS 0.14383f ; **FLOATING
C7998 VDD.n552 VSS 0.13581f ; **FLOATING
C7999 VDD.n553 VSS 0.02771f ; **FLOATING
C8000 VDD.n554 VSS 0.07253f ; **FLOATING
C8001 VDD.n555 VSS 0.02768f ; **FLOATING
C8002 VDD.n556 VSS 0.02771f ; **FLOATING
C8003 VDD.n557 VSS 0.02771f ; **FLOATING
C8004 VDD.n558 VSS 0.0277f ; **FLOATING
C8005 VDD.n559 VSS 0.02768f ; **FLOATING
C8006 VDD.n560 VSS 0.02771f ; **FLOATING
C8007 VDD.n561 VSS 0.02771f ; **FLOATING
C8008 VDD.n562 VSS 0.02771f ; **FLOATING
C8009 VDD.n563 VSS 0.02776f ; **FLOATING
C8010 VDD.n564 VSS 0.02771f ; **FLOATING
C8011 VDD.n565 VSS 0.02768f ; **FLOATING
C8012 VDD.t341 VSS 47.1207f ; **FLOATING
C8013 VDD.t353 VSS 47.1207f ; **FLOATING
C8014 VDD.n566 VSS 0.03528f ; **FLOATING
C8015 VDD.n567 VSS 0.16329f ; **FLOATING
C8016 VDD.n568 VSS 0.16329f ; **FLOATING
C8017 VDD.n569 VSS 0.03528f ; **FLOATING
C8018 VDD.n570 VSS 0.16329f ; **FLOATING
C8019 VDD.n571 VSS 0.03528f ; **FLOATING
C8020 VDD.n572 VSS 0.16329f ; **FLOATING
C8021 VDD.n573 VSS 0.16329f ; **FLOATING
C8022 VDD.n574 VSS 0.03659f ; **FLOATING
C8023 VDD.n575 VSS 0.03666f ; **FLOATING
C8024 VDD.n576 VSS 0.01488f ; **FLOATING
C8025 VDD.n577 VSS 0.03666f ; **FLOATING
C8026 VDD.n578 VSS 0.01488f ; **FLOATING
C8027 VDD.t352 VSS 8.81914f ; **FLOATING
C8028 VDD.n579 VSS 0.03663f ; **FLOATING
C8029 VDD.n580 VSS 0.03664f ; **FLOATING
C8030 VDD.n581 VSS 0.03654f ; **FLOATING
C8031 VDD.n582 VSS 0.03669f ; **FLOATING
C8032 VDD.n583 VSS 0.03663f ; **FLOATING
C8033 VDD.n584 VSS 0.03664f ; **FLOATING
C8034 VDD.n585 VSS 0.03662f ; **FLOATING
C8035 VDD.n586 VSS 0.01488f ; **FLOATING
C8036 VDD.n587 VSS 0.03663f ; **FLOATING
C8037 VDD.n588 VSS 0.01488f ; **FLOATING
C8038 VDD.n589 VSS 0.03669f ; **FLOATING
C8039 VDD.n590 VSS 0.03663f ; **FLOATING
C8040 VDD.n591 VSS 0.03661f ; **FLOATING
C8041 VDD.n592 VSS 0.01488f ; **FLOATING
C8042 VDD.n593 VSS 0.03661f ; **FLOATING
C8043 VDD.n594 VSS 0.01488f ; **FLOATING
C8044 VDD.n595 VSS 0.03664f ; **FLOATING
C8045 VDD.n596 VSS 0.03663f ; **FLOATING
C8046 VDD.n597 VSS 0.03661f ; **FLOATING
C8047 VDD.n598 VSS 0.03666f ; **FLOATING
C8048 VDD.n599 VSS 0.03666f ; **FLOATING
C8049 VDD.n600 VSS 0.03663f ; **FLOATING
C8050 VDD.n601 VSS 0.03669f ; **FLOATING
C8051 VDD.n602 VSS 0.01488f ; **FLOATING
C8052 VDD.n603 VSS 0.01488f ; **FLOATING
C8053 VDD.n604 VSS 0.01488f ; **FLOATING
C8054 VDD.n605 VSS 0.01488f ; **FLOATING
C8055 VDD.n606 VSS 0.01488f ; **FLOATING
C8056 VDD.n607 VSS 0.03669f ; **FLOATING
C8057 VDD.n608 VSS 0.01488f ; **FLOATING
C8058 VDD.n609 VSS 0.01488f ; **FLOATING
C8059 VDD.n610 VSS 0.03664f ; **FLOATING
C8060 VDD.n611 VSS 0.01488f ; **FLOATING
C8061 VDD.n612 VSS 0.01488f ; **FLOATING
C8062 VDD.n613 VSS 0.01488f ; **FLOATING
C8063 VDD.n614 VSS 0.01488f ; **FLOATING
C8064 VDD.n615 VSS 0.01488f ; **FLOATING
C8065 VDD.n616 VSS 0.01488f ; **FLOATING
C8066 VDD.n617 VSS 0.01488f ; **FLOATING
C8067 VDD.n618 VSS 0.14148f ; **FLOATING
C8068 VDD.n619 VSS 0.01488f ; **FLOATING
C8069 VDD.n621 VSS 0.01488f ; **FLOATING
C8070 VDD.t591 VSS 0.01309f ; **FLOATING
C8071 VDD.t356 VSS 0.06514f ; **FLOATING
C8072 VDD.n626 VSS 0.02638f ; **FLOATING
C8073 VDD.n627 VSS 0.07929f ; **FLOATING
C8074 VDD.n628 VSS 0.03978f ; **FLOATING
C8075 VDD.n629 VSS 0.02164f ; **FLOATING
C8076 VDD.n630 VSS 0.03978f ; **FLOATING
C8077 VDD.n631 VSS 0.08083f ; **FLOATING
C8078 VDD.t477 VSS 0.0397f ; **FLOATING
C8079 VDD.t990 VSS 0.0397f ; **FLOATING
C8080 VDD.n632 VSS 0.1354f ; **FLOATING
C8081 VDD.t731 VSS 0.04802f ; **FLOATING
C8082 VDD.t1258 VSS 0.04802f ; **FLOATING
C8083 VDD.n633 VSS 0.15283f ; **FLOATING
C8084 VDD.n634 VSS 0.01719f ; **FLOATING
C8085 VDD.n635 VSS 0.07763f ; **FLOATING
C8086 VDD.t626 VSS 0.03423f ; **FLOATING
C8087 VDD.n636 VSS 0.02323f ; **FLOATING
C8088 VDD.t625 VSS 0.02471f ; **FLOATING
C8089 VDD.t627 VSS 0.03825f ; **FLOATING
C8090 VDD.t629 VSS 0.03423f ; **FLOATING
C8091 VDD.t797 VSS 0.03423f ; **FLOATING
C8092 VDD.n637 VSS 0.05802f ; **FLOATING
C8093 VDD.n638 VSS 0.02538f ; **FLOATING
C8094 VDD.t631 VSS 0.03423f ; **FLOATING
C8095 VDD.n639 VSS 0.02323f ; **FLOATING
C8096 VDD.t630 VSS 0.02471f ; **FLOATING
C8097 VDD.t632 VSS 0.03825f ; **FLOATING
C8098 VDD.n640 VSS 0.01726f ; **FLOATING
C8099 VDD.n641 VSS 0.01797f ; **FLOATING
C8100 VDD.t633 VSS 0.02012f ; **FLOATING
C8101 VDD.n643 VSS 0.02057f ; **FLOATING
C8102 VDD.t634 VSS 0.03423f ; **FLOATING
C8103 VDD.t552 VSS 0.03758f ; **FLOATING
C8104 VDD.t361 VSS 0.02556f ; **FLOATING
C8105 VDD.n644 VSS 0.13343f ; **FLOATING
C8106 VDD.t360 VSS 3.59222f ; **FLOATING
C8107 VDD.n645 VSS 0.69946f ; **FLOATING
C8108 VDD.n646 VSS 0.12456f ; **FLOATING
C8109 VDD.t749 VSS 0.02823f ; **FLOATING
C8110 VDD.t699 VSS 0.02823f ; **FLOATING
C8111 VDD.n647 VSS 0.0838f ; **FLOATING
C8112 VDD.n648 VSS 0.0294f ; **FLOATING
C8113 VDD.t1012 VSS 0.01309f ; **FLOATING
C8114 VDD.t761 VSS 0.06514f ; **FLOATING
C8115 VDD.n649 VSS 0.02638f ; **FLOATING
C8116 VDD.t416 VSS 0.01309f ; **FLOATING
C8117 VDD.t766 VSS 0.06514f ; **FLOATING
C8118 VDD.n650 VSS 0.02638f ; **FLOATING
C8119 VDD.n651 VSS 0.05827f ; **FLOATING
C8120 VDD.n652 VSS 0.01549f ; **FLOATING
C8121 VDD.t499 VSS 0.03837f ; **FLOATING
C8122 VDD.n653 VSS 0.06894f ; **FLOATING
C8123 VDD.t358 VSS 0.03543f ; **FLOATING
C8124 VDD.n654 VSS 0.08222f ; **FLOATING
C8125 VDD.n655 VSS 0.03796f ; **FLOATING
C8126 VDD.t559 VSS 0.0397f ; **FLOATING
C8127 VDD.n656 VSS 0.17746f ; **FLOATING
C8128 VDD.t357 VSS 0.02823f ; **FLOATING
C8129 VDD.n657 VSS 0.15925f ; **FLOATING
C8130 VDD.n658 VSS 0.03193f ; **FLOATING
C8131 VDD.n659 VSS 0.01687f ; **FLOATING
C8132 VDD.n660 VSS 0.03848f ; **FLOATING
C8133 VDD.n661 VSS 0.03349f ; **FLOATING
C8134 VDD.n662 VSS 0.03839f ; **FLOATING
C8135 VDD.n663 VSS 0.07692f ; **FLOATING
C8136 VDD.t351 VSS 13.5425f ; **FLOATING
C8137 VDD.n664 VSS 0.05195f ; **FLOATING
C8138 VDD.n665 VSS 0.05204f ; **FLOATING
C8139 VDD.n666 VSS 0.05195f ; **FLOATING
C8140 VDD.n667 VSS 0.05203f ; **FLOATING
C8141 VDD.n668 VSS 0.05211f ; **FLOATING
C8142 VDD.n669 VSS 0.05205f ; **FLOATING
C8143 VDD.n670 VSS 0.0521f ; **FLOATING
C8144 VDD.n671 VSS 0.05199f ; **FLOATING
C8145 VDD.n672 VSS 0.05205f ; **FLOATING
C8146 VDD.n673 VSS 0.05207f ; **FLOATING
C8147 VDD.n674 VSS 0.0521f ; **FLOATING
C8148 VDD.n675 VSS 0.05193f ; **FLOATING
C8149 VDD.n676 VSS 0.04268f ; **FLOATING
C8150 VDD.n677 VSS 0.05198f ; **FLOATING
C8151 VDD.n678 VSS 0.05203f ; **FLOATING
C8152 VDD.n679 VSS 0.0521f ; **FLOATING
C8153 VDD.n680 VSS 0.05211f ; **FLOATING
C8154 VDD.n681 VSS 0.052f ; **FLOATING
C8155 VDD.n682 VSS 0.05203f ; **FLOATING
C8156 VDD.n683 VSS 0.05199f ; **FLOATING
C8157 VDD.n684 VSS 0.05203f ; **FLOATING
C8158 VDD.n685 VSS 0.05203f ; **FLOATING
C8159 VDD.n686 VSS 0.01705f ; **FLOATING
C8160 VDD.n687 VSS 0.08549f ; **FLOATING
C8161 VDD.n688 VSS 0.03405f ; **FLOATING
C8162 VDD.n689 VSS 0.05197f ; **FLOATING
C8163 VDD.n690 VSS 0.05199f ; **FLOATING
C8164 VDD.n691 VSS 0.05206f ; **FLOATING
C8165 VDD.n692 VSS 0.05203f ; **FLOATING
C8166 VDD.n693 VSS 0.02709f ; **FLOATING
C8167 VDD.t597 VSS 0.0718f ; **FLOATING
C8168 VDD.n695 VSS 0.05467f ; **FLOATING
C8169 VDD.n696 VSS 0.06388f ; **FLOATING
C8170 VDD.t600 VSS 0.03308f ; **FLOATING
C8171 VDD.n697 VSS 0.01687f ; **FLOATING
C8172 VDD.t602 VSS 0.03423f ; **FLOATING
C8173 VDD.n698 VSS 0.02273f ; **FLOATING
C8174 VDD.n699 VSS 0.07519f ; **FLOATING
C8175 VDD.n701 VSS 0.0341f ; **FLOATING
C8176 VDD.t599 VSS 0.03825f ; **FLOATING
C8177 VDD.n702 VSS 0.02775f ; **FLOATING
C8178 VDD.n703 VSS 0.03493f ; **FLOATING
C8179 VDD.n704 VSS 0.01642f ; **FLOATING
C8180 VDD.t598 VSS 0.03423f ; **FLOATING
C8181 VDD.n705 VSS 0.04894f ; **FLOATING
C8182 VDD.n706 VSS 0.02538f ; **FLOATING
C8183 VDD.n707 VSS 0.03867f ; **FLOATING
C8184 VDD.n708 VSS 0.01529f ; **FLOATING
C8185 VDD.t1051 VSS 0.04014f ; **FLOATING
C8186 VDD.n709 VSS 0.0637f ; **FLOATING
C8187 VDD.n710 VSS 0.01488f ; **FLOATING
C8188 VDD.t825 VSS 0.03423f ; **FLOATING
C8189 VDD.n711 VSS 0.09309f ; **FLOATING
C8190 VDD.n712 VSS 0.02538f ; **FLOATING
C8191 VDD.n713 VSS 0.06361f ; **FLOATING
C8192 VDD.n714 VSS 0.03664f ; **FLOATING
C8193 VDD.t684 VSS 0.04014f ; **FLOATING
C8194 VDD.n715 VSS 0.08359f ; **FLOATING
C8195 VDD.n716 VSS 0.01488f ; **FLOATING
C8196 VDD.t841 VSS 0.03423f ; **FLOATING
C8197 VDD.n717 VSS 0.11244f ; **FLOATING
C8198 VDD.n718 VSS 0.02538f ; **FLOATING
C8199 VDD.n719 VSS 0.06361f ; **FLOATING
C8200 VDD.n720 VSS 0.03666f ; **FLOATING
C8201 VDD.t1579 VSS 0.04014f ; **FLOATING
C8202 VDD.n721 VSS 0.08358f ; **FLOATING
C8203 VDD.n722 VSS 0.01488f ; **FLOATING
C8204 VDD.t842 VSS 0.03423f ; **FLOATING
C8205 VDD.n723 VSS 0.11247f ; **FLOATING
C8206 VDD.n724 VSS 0.02538f ; **FLOATING
C8207 VDD.n725 VSS 0.06363f ; **FLOATING
C8208 VDD.n726 VSS 0.03662f ; **FLOATING
C8209 VDD.t378 VSS 0.04014f ; **FLOATING
C8210 VDD.n727 VSS 0.08359f ; **FLOATING
C8211 VDD.n728 VSS 0.01488f ; **FLOATING
C8212 VDD.t836 VSS 0.03423f ; **FLOATING
C8213 VDD.n729 VSS 0.11249f ; **FLOATING
C8214 VDD.n730 VSS 0.02538f ; **FLOATING
C8215 VDD.n731 VSS 0.06361f ; **FLOATING
C8216 VDD.n732 VSS 0.03664f ; **FLOATING
C8217 VDD.t1276 VSS 0.04014f ; **FLOATING
C8218 VDD.n733 VSS 0.08359f ; **FLOATING
C8219 VDD.n734 VSS 0.01488f ; **FLOATING
C8220 VDD.t839 VSS 0.03423f ; **FLOATING
C8221 VDD.n735 VSS 0.09304f ; **FLOATING
C8222 VDD.n736 VSS 0.02538f ; **FLOATING
C8223 VDD.n737 VSS 0.03834f ; **FLOATING
C8224 VDD.n738 VSS 0.01131f ; **FLOATING
C8225 VDD.n739 VSS 0.07912f ; **FLOATING
C8226 VDD.n740 VSS 0.02603f ; **FLOATING
C8227 VDD.t539 VSS 0.04014f ; **FLOATING
C8228 VDD.n741 VSS 0.07373f ; **FLOATING
C8229 VDD.n742 VSS 0.01488f ; **FLOATING
C8230 VDD.t837 VSS 0.03423f ; **FLOATING
C8231 VDD.n743 VSS 0.08313f ; **FLOATING
C8232 VDD.n744 VSS 0.02538f ; **FLOATING
C8233 VDD.n745 VSS 0.06361f ; **FLOATING
C8234 VDD.n746 VSS 0.03666f ; **FLOATING
C8235 VDD.t376 VSS 0.04014f ; **FLOATING
C8236 VDD.n747 VSS 0.08358f ; **FLOATING
C8237 VDD.n748 VSS 0.01488f ; **FLOATING
C8238 VDD.t838 VSS 0.03423f ; **FLOATING
C8239 VDD.n749 VSS 0.11246f ; **FLOATING
C8240 VDD.n750 VSS 0.02538f ; **FLOATING
C8241 VDD.n751 VSS 0.06364f ; **FLOATING
C8242 VDD.n752 VSS 0.03665f ; **FLOATING
C8243 VDD.t459 VSS 0.04014f ; **FLOATING
C8244 VDD.n753 VSS 0.08356f ; **FLOATING
C8245 VDD.n754 VSS 0.01488f ; **FLOATING
C8246 VDD.t840 VSS 0.03423f ; **FLOATING
C8247 VDD.n755 VSS 0.11247f ; **FLOATING
C8248 VDD.n756 VSS 0.02538f ; **FLOATING
C8249 VDD.n757 VSS 0.06364f ; **FLOATING
C8250 VDD.n758 VSS 0.03663f ; **FLOATING
C8251 VDD.t681 VSS 0.04014f ; **FLOATING
C8252 VDD.n759 VSS 0.08358f ; **FLOATING
C8253 VDD.n760 VSS 0.01488f ; **FLOATING
C8254 VDD.t814 VSS 0.03423f ; **FLOATING
C8255 VDD.n761 VSS 0.11247f ; **FLOATING
C8256 VDD.n762 VSS 0.02538f ; **FLOATING
C8257 VDD.n763 VSS 0.06364f ; **FLOATING
C8258 VDD.n764 VSS 0.03665f ; **FLOATING
C8259 VDD.t375 VSS 0.04014f ; **FLOATING
C8260 VDD.n765 VSS 0.08356f ; **FLOATING
C8261 VDD.n766 VSS 0.01488f ; **FLOATING
C8262 VDD.t834 VSS 0.03423f ; **FLOATING
C8263 VDD.n767 VSS 0.11246f ; **FLOATING
C8264 VDD.n768 VSS 0.02538f ; **FLOATING
C8265 VDD.n769 VSS 0.06362f ; **FLOATING
C8266 VDD.n770 VSS 0.03667f ; **FLOATING
C8267 VDD.t938 VSS 0.04014f ; **FLOATING
C8268 VDD.n771 VSS 0.08355f ; **FLOATING
C8269 VDD.n772 VSS 0.01488f ; **FLOATING
C8270 VDD.t835 VSS 0.03423f ; **FLOATING
C8271 VDD.n773 VSS 0.11245f ; **FLOATING
C8272 VDD.n774 VSS 0.02538f ; **FLOATING
C8273 VDD.n775 VSS 0.06361f ; **FLOATING
C8274 VDD.n776 VSS 0.03664f ; **FLOATING
C8275 VDD.t1526 VSS 0.04014f ; **FLOATING
C8276 VDD.n777 VSS 0.08362f ; **FLOATING
C8277 VDD.n778 VSS 0.01486f ; **FLOATING
C8278 VDD.t818 VSS 0.03423f ; **FLOATING
C8279 VDD.n779 VSS 0.1124f ; **FLOATING
C8280 VDD.n780 VSS 0.02538f ; **FLOATING
C8281 VDD.n781 VSS 0.06358f ; **FLOATING
C8282 VDD.n782 VSS 0.0367f ; **FLOATING
C8283 VDD.t549 VSS 0.04014f ; **FLOATING
C8284 VDD.n783 VSS 0.08355f ; **FLOATING
C8285 VDD.n784 VSS 0.01488f ; **FLOATING
C8286 VDD.t819 VSS 0.03423f ; **FLOATING
C8287 VDD.n785 VSS 0.11246f ; **FLOATING
C8288 VDD.n786 VSS 0.02538f ; **FLOATING
C8289 VDD.n787 VSS 0.06367f ; **FLOATING
C8290 VDD.n788 VSS 0.03659f ; **FLOATING
C8291 VDD.t710 VSS 0.04014f ; **FLOATING
C8292 VDD.n789 VSS 0.08361f ; **FLOATING
C8293 VDD.n790 VSS 0.01486f ; **FLOATING
C8294 VDD.t809 VSS 0.03423f ; **FLOATING
C8295 VDD.n791 VSS 0.11245f ; **FLOATING
C8296 VDD.n792 VSS 0.02538f ; **FLOATING
C8297 VDD.n793 VSS 0.06361f ; **FLOATING
C8298 VDD.n794 VSS 0.03667f ; **FLOATING
C8299 VDD.t1469 VSS 0.04014f ; **FLOATING
C8300 VDD.n795 VSS 0.08355f ; **FLOATING
C8301 VDD.n796 VSS 0.01488f ; **FLOATING
C8302 VDD.t833 VSS 0.03423f ; **FLOATING
C8303 VDD.n797 VSS 0.10772f ; **FLOATING
C8304 VDD.n798 VSS 0.02538f ; **FLOATING
C8305 VDD.n799 VSS 0.06363f ; **FLOATING
C8306 VDD.n800 VSS 0.03662f ; **FLOATING
C8307 VDD.t1488 VSS 0.04014f ; **FLOATING
C8308 VDD.n801 VSS 0.08359f ; **FLOATING
C8309 VDD.n802 VSS 0.01488f ; **FLOATING
C8310 VDD.t830 VSS 0.03423f ; **FLOATING
C8311 VDD.n803 VSS 0.02538f ; **FLOATING
C8312 VDD.n804 VSS 0.03834f ; **FLOATING
C8313 VDD.n805 VSS 0.01131f ; **FLOATING
C8314 VDD.n806 VSS 0.0709f ; **FLOATING
C8315 VDD.n807 VSS 0.02603f ; **FLOATING
C8316 VDD.t1223 VSS 0.04014f ; **FLOATING
C8317 VDD.n808 VSS 0.07373f ; **FLOATING
C8318 VDD.n809 VSS 0.01488f ; **FLOATING
C8319 VDD.t831 VSS 0.03423f ; **FLOATING
C8320 VDD.n810 VSS 0.11636f ; **FLOATING
C8321 VDD.n811 VSS 0.02538f ; **FLOATING
C8322 VDD.n812 VSS 0.06359f ; **FLOATING
C8323 VDD.n813 VSS 0.0367f ; **FLOATING
C8324 VDD.t509 VSS 0.04014f ; **FLOATING
C8325 VDD.n814 VSS 0.08355f ; **FLOATING
C8326 VDD.n815 VSS 0.01488f ; **FLOATING
C8327 VDD.t823 VSS 0.03423f ; **FLOATING
C8328 VDD.n816 VSS 0.11245f ; **FLOATING
C8329 VDD.n817 VSS 0.02538f ; **FLOATING
C8330 VDD.n818 VSS 0.06363f ; **FLOATING
C8331 VDD.n819 VSS 0.03662f ; **FLOATING
C8332 VDD.t934 VSS 0.04014f ; **FLOATING
C8333 VDD.n820 VSS 0.08359f ; **FLOATING
C8334 VDD.n821 VSS 0.01488f ; **FLOATING
C8335 VDD.t827 VSS 0.03423f ; **FLOATING
C8336 VDD.n822 VSS 0.11239f ; **FLOATING
C8337 VDD.n823 VSS 0.02538f ; **FLOATING
C8338 VDD.n824 VSS 0.06367f ; **FLOATING
C8339 VDD.n825 VSS 0.03659f ; **FLOATING
C8340 VDD.t707 VSS 0.04014f ; **FLOATING
C8341 VDD.n826 VSS 0.08358f ; **FLOATING
C8342 VDD.n827 VSS 0.01488f ; **FLOATING
C8343 VDD.t828 VSS 0.03423f ; **FLOATING
C8344 VDD.n828 VSS 0.11243f ; **FLOATING
C8345 VDD.n829 VSS 0.02538f ; **FLOATING
C8346 VDD.n830 VSS 0.06361f ; **FLOATING
C8347 VDD.n831 VSS 0.03666f ; **FLOATING
C8348 VDD.t679 VSS 0.04014f ; **FLOATING
C8349 VDD.n832 VSS 0.08361f ; **FLOATING
C8350 VDD.n833 VSS 0.01486f ; **FLOATING
C8351 VDD.t824 VSS 0.03423f ; **FLOATING
C8352 VDD.n834 VSS 0.11248f ; **FLOATING
C8353 VDD.n835 VSS 0.02538f ; **FLOATING
C8354 VDD.n836 VSS 0.06366f ; **FLOATING
C8355 VDD.n837 VSS 0.03659f ; **FLOATING
C8356 VDD.t1048 VSS 0.04014f ; **FLOATING
C8357 VDD.n838 VSS 0.08361f ; **FLOATING
C8358 VDD.n839 VSS 0.01486f ; **FLOATING
C8359 VDD.t826 VSS 0.03423f ; **FLOATING
C8360 VDD.n840 VSS 0.11244f ; **FLOATING
C8361 VDD.n841 VSS 0.02538f ; **FLOATING
C8362 VDD.n842 VSS 0.06367f ; **FLOATING
C8363 VDD.n843 VSS 0.03658f ; **FLOATING
C8364 VDD.t366 VSS 0.04014f ; **FLOATING
C8365 VDD.n844 VSS 0.08358f ; **FLOATING
C8366 VDD.n845 VSS 0.01488f ; **FLOATING
C8367 VDD.t800 VSS 0.03423f ; **FLOATING
C8368 VDD.n846 VSS 0.11239f ; **FLOATING
C8369 VDD.n847 VSS 0.02538f ; **FLOATING
C8370 VDD.n848 VSS 0.06359f ; **FLOATING
C8371 VDD.n849 VSS 0.0367f ; **FLOATING
C8372 VDD.t929 VSS 0.04014f ; **FLOATING
C8373 VDD.n850 VSS 0.08355f ; **FLOATING
C8374 VDD.n851 VSS 0.01488f ; **FLOATING
C8375 VDD.t782 VSS 0.03423f ; **FLOATING
C8376 VDD.n852 VSS 0.11244f ; **FLOATING
C8377 VDD.n853 VSS 0.02538f ; **FLOATING
C8378 VDD.n854 VSS 0.06361f ; **FLOATING
C8379 VDD.n855 VSS 0.03664f ; **FLOATING
C8380 VDD.t1043 VSS 0.04014f ; **FLOATING
C8381 VDD.n856 VSS 0.08359f ; **FLOATING
C8382 VDD.n857 VSS 0.01488f ; **FLOATING
C8383 VDD.t815 VSS 0.03423f ; **FLOATING
C8384 VDD.n858 VSS 0.11653f ; **FLOATING
C8385 VDD.n859 VSS 0.02538f ; **FLOATING
C8386 VDD.n860 VSS 0.06364f ; **FLOATING
C8387 VDD.n861 VSS 0.03663f ; **FLOATING
C8388 VDD.t1046 VSS 0.04014f ; **FLOATING
C8389 VDD.n862 VSS 0.08358f ; **FLOATING
C8390 VDD.n863 VSS 0.01488f ; **FLOATING
C8391 VDD.t816 VSS 0.03423f ; **FLOATING
C8392 VDD.n864 VSS 0.02538f ; **FLOATING
C8393 VDD.n865 VSS 0.03834f ; **FLOATING
C8394 VDD.n866 VSS 0.01131f ; **FLOATING
C8395 VDD.n867 VSS 0.06903f ; **FLOATING
C8396 VDD.n868 VSS 0.02607f ; **FLOATING
C8397 VDD.t1039 VSS 0.04014f ; **FLOATING
C8398 VDD.n869 VSS 0.07376f ; **FLOATING
C8399 VDD.n870 VSS 0.01486f ; **FLOATING
C8400 VDD.t817 VSS 0.03423f ; **FLOATING
C8401 VDD.n871 VSS 0.10766f ; **FLOATING
C8402 VDD.n872 VSS 0.02538f ; **FLOATING
C8403 VDD.n873 VSS 0.06361f ; **FLOATING
C8404 VDD.n874 VSS 0.03665f ; **FLOATING
C8405 VDD.t1042 VSS 0.04014f ; **FLOATING
C8406 VDD.n875 VSS 0.08357f ; **FLOATING
C8407 VDD.n876 VSS 0.01488f ; **FLOATING
C8408 VDD.t821 VSS 0.03423f ; **FLOATING
C8409 VDD.n877 VSS 0.11253f ; **FLOATING
C8410 VDD.n878 VSS 0.02538f ; **FLOATING
C8411 VDD.n879 VSS 0.06361f ; **FLOATING
C8412 VDD.n880 VSS 0.03664f ; **FLOATING
C8413 VDD.t457 VSS 0.04014f ; **FLOATING
C8414 VDD.n881 VSS 0.08359f ; **FLOATING
C8415 VDD.n882 VSS 0.01488f ; **FLOATING
C8416 VDD.t822 VSS 0.03423f ; **FLOATING
C8417 VDD.n883 VSS 0.11248f ; **FLOATING
C8418 VDD.n884 VSS 0.02538f ; **FLOATING
C8419 VDD.n885 VSS 0.06361f ; **FLOATING
C8420 VDD.n886 VSS 0.03666f ; **FLOATING
C8421 VDD.t455 VSS 0.04014f ; **FLOATING
C8422 VDD.n887 VSS 0.08361f ; **FLOATING
C8423 VDD.n888 VSS 0.01486f ; **FLOATING
C8424 VDD.t803 VSS 0.03423f ; **FLOATING
C8425 VDD.n889 VSS 0.11247f ; **FLOATING
C8426 VDD.n890 VSS 0.02538f ; **FLOATING
C8427 VDD.n891 VSS 0.0636f ; **FLOATING
C8428 VDD.n892 VSS 0.03666f ; **FLOATING
C8429 VDD.t494 VSS 0.04014f ; **FLOATING
C8430 VDD.n893 VSS 0.08358f ; **FLOATING
C8431 VDD.n894 VSS 0.01488f ; **FLOATING
C8432 VDD.t808 VSS 0.03423f ; **FLOATING
C8433 VDD.n895 VSS 0.13336f ; **FLOATING
C8434 VDD.n896 VSS 0.02538f ; **FLOATING
C8435 VDD.n897 VSS 0.06367f ; **FLOATING
C8436 VDD.n898 VSS 0.03659f ; **FLOATING
C8437 VDD.t966 VSS 0.04014f ; **FLOATING
C8438 VDD.n899 VSS 0.08358f ; **FLOATING
C8439 VDD.n900 VSS 0.01488f ; **FLOATING
C8440 VDD.t820 VSS 0.03423f ; **FLOATING
C8441 VDD.n901 VSS 0.03854f ; **FLOATING
C8442 VDD.n902 VSS 0.06649f ; **FLOATING
C8443 VDD.t596 VSS 0.03423f ; **FLOATING
C8444 VDD.t595 VSS 0.02015f ; **FLOATING
C8445 VDD.t594 VSS 0.03855f ; **FLOATING
C8446 VDD.t593 VSS 0.03423f ; **FLOATING
C8447 VDD.t592 VSS 0.02471f ; **FLOATING
C8448 VDD.t1570 VSS 0.03543f ; **FLOATING
C8449 VDD.t1164 VSS 0.03543f ; **FLOATING
C8450 VDD.t313 VSS 0.03182f ; **FLOATING
C8451 VDD.t1536 VSS 0.03543f ; **FLOATING
C8452 VDD.n903 VSS 0.02926f ; **FLOATING
C8453 VDD.t967 VSS 0.04651f ; **FLOATING
C8454 VDD.n904 VSS 0.0892f ; **FLOATING
C8455 VDD.n905 VSS 0.02609f ; **FLOATING
C8456 VDD.t1009 VSS 0.03543f ; **FLOATING
C8457 VDD.n906 VSS 0.09607f ; **FLOATING
C8458 VDD.n907 VSS 0.01242f ; **FLOATING
C8459 VDD.n908 VSS 0.01294f ; **FLOATING
C8460 VDD.t1390 VSS 0.03949f ; **FLOATING
C8461 VDD.t1453 VSS 0.03949f ; **FLOATING
C8462 VDD.n909 VSS 0.08483f ; **FLOATING
C8463 VDD.n910 VSS 0.01245f ; **FLOATING
C8464 VDD.n911 VSS 0.01311f ; **FLOATING
C8465 VDD.t1314 VSS 0.03949f ; **FLOATING
C8466 VDD.t1447 VSS 0.03949f ; **FLOATING
C8467 VDD.n912 VSS 0.08886f ; **FLOATING
C8468 VDD.t504 VSS 0.03543f ; **FLOATING
C8469 VDD.t484 VSS 0.03543f ; **FLOATING
C8470 VDD.t1277 VSS 0.02617f ; **FLOATING
C8471 VDD.t1596 VSS 0.02617f ; **FLOATING
C8472 VDD.t1313 VSS 0.03498f ; **FLOATING
C8473 VDD.t1446 VSS 0.03498f ; **FLOATING
C8474 VDD.t1572 VSS 0.02617f ; **FLOATING
C8475 VDD.t1163 VSS 0.02617f ; **FLOATING
C8476 VDD.n913 VSS 0.07007f ; **FLOATING
C8477 VDD.t1389 VSS 0.03498f ; **FLOATING
C8478 VDD.t1452 VSS 0.03498f ; **FLOATING
C8479 VDD.n914 VSS 0.07502f ; **FLOATING
C8480 VDD.n915 VSS 0.01264f ; **FLOATING
C8481 VDD.t503 VSS 0.02617f ; **FLOATING
C8482 VDD.t483 VSS 0.02617f ; **FLOATING
C8483 VDD.n916 VSS 0.06983f ; **FLOATING
C8484 VDD.n917 VSS 0.01218f ; **FLOATING
C8485 VDD.t1278 VSS 0.03498f ; **FLOATING
C8486 VDD.t1450 VSS 0.03498f ; **FLOATING
C8487 VDD.n918 VSS 0.07079f ; **FLOATING
C8488 VDD.n919 VSS 0.01729f ; **FLOATING
C8489 VDD.t1386 VSS 0.03949f ; **FLOATING
C8490 VDD.t1451 VSS 0.03949f ; **FLOATING
C8491 VDD.n920 VSS 0.07913f ; **FLOATING
C8492 VDD.t1571 VSS 0.02617f ; **FLOATING
C8493 VDD.t1165 VSS 0.02617f ; **FLOATING
C8494 VDD.n921 VSS 0.07047f ; **FLOATING
C8495 VDD.n922 VSS 0.01289f ; **FLOATING
C8496 VDD.t502 VSS 0.03498f ; **FLOATING
C8497 VDD.t485 VSS 0.03498f ; **FLOATING
C8498 VDD.t1357 VSS 0.03949f ; **FLOATING
C8499 VDD.t1599 VSS 0.03949f ; **FLOATING
C8500 VDD.t1351 VSS 0.03543f ; **FLOATING
C8501 VDD.t1141 VSS 0.03555f ; **FLOATING
C8502 VDD.t410 VSS 0.03543f ; **FLOATING
C8503 VDD.n923 VSS 0.07423f ; **FLOATING
C8504 VDD.n924 VSS 0.01394f ; **FLOATING
C8505 VDD.t996 VSS 0.03543f ; **FLOATING
C8506 VDD.t469 VSS 0.03543f ; **FLOATING
C8507 VDD.t1521 VSS 0.03543f ; **FLOATING
C8508 VDD.t135 VSS 0.03181f ; **FLOATING
C8509 VDD.t113 VSS 0.03182f ; **FLOATING
C8510 VDD.t1037 VSS 0.03543f ; **FLOATING
C8511 VDD.t136 VSS 0.03416f ; **FLOATING
C8512 VDD.t1709 VSS 0.11751f ; **FLOATING
C8513 VDD.t1036 VSS 0.04651f ; **FLOATING
C8514 VDD.t114 VSS 0.03416f ; **FLOATING
C8515 VDD.t1708 VSS 0.11751f ; **FLOATING
C8516 VDD.t547 VSS 0.03543f ; **FLOATING
C8517 VDD.t116 VSS 0.03181f ; **FLOATING
C8518 VDD.t119 VSS 0.03182f ; **FLOATING
C8519 VDD.t122 VSS 0.03181f ; **FLOATING
C8520 VDD.t1287 VSS 0.03543f ; **FLOATING
C8521 VDD.t1041 VSS 0.03543f ; **FLOATING
C8522 VDD.t711 VSS 0.03543f ; **FLOATING
C8523 VDD.t529 VSS 0.03543f ; **FLOATING
C8524 VDD.t312 VSS 0.03182f ; **FLOATING
C8525 VDD.t1086 VSS 0.04651f ; **FLOATING
C8526 VDD.t706 VSS 0.03543f ; **FLOATING
C8527 VDD.t311 VSS 0.03181f ; **FLOATING
C8528 VDD.t1525 VSS 0.03543f ; **FLOATING
C8529 VDD.t306 VSS 0.03182f ; **FLOATING
C8530 VDD.t584 VSS 0.03543f ; **FLOATING
C8531 VDD.t309 VSS 0.03181f ; **FLOATING
C8532 VDD.t1198 VSS 0.03182f ; **FLOATING
C8533 VDD.t930 VSS 0.04668f ; **FLOATING
C8534 VDD.t367 VSS 0.03543f ; **FLOATING
C8535 VDD.n925 VSS 0.06436f ; **FLOATING
C8536 VDD.n926 VSS 0.01394f ; **FLOATING
C8537 VDD.t1201 VSS 0.03181f ; **FLOATING
C8538 VDD.t1288 VSS 0.03543f ; **FLOATING
C8539 VDD.n927 VSS 0.05847f ; **FLOATING
C8540 VDD.t587 VSS 0.03543f ; **FLOATING
C8541 VDD.t1498 VSS 0.03543f ; **FLOATING
C8542 VDD.t117 VSS 0.03182f ; **FLOATING
C8543 VDD.t1089 VSS 0.04651f ; **FLOATING
C8544 VDD.t398 VSS 0.03181f ; **FLOATING
C8545 VDD.t348 VSS 0.03543f ; **FLOATING
C8546 VDD.t23 VSS 0.03182f ; **FLOATING
C8547 VDD.t678 VSS 0.03543f ; **FLOATING
C8548 VDD.t387 VSS 0.03543f ; **FLOATING
C8549 VDD.t234 VSS 0.03181f ; **FLOATING
C8550 VDD.t21 VSS 0.03182f ; **FLOATING
C8551 VDD.t319 VSS 0.03181f ; **FLOATING
C8552 VDD.t501 VSS 0.03543f ; **FLOATING
C8553 VDD.t933 VSS 0.03543f ; **FLOATING
C8554 VDD.t480 VSS 0.03543f ; **FLOATING
C8555 VDD.t497 VSS 0.03543f ; **FLOATING
C8556 VDD.t508 VSS 0.04651f ; **FLOATING
C8557 VDD.t531 VSS 0.03543f ; **FLOATING
C8558 VDD.t1225 VSS 0.03543f ; **FLOATING
C8559 VDD.t1513 VSS 0.03543f ; **FLOATING
C8560 VDD.t1285 VSS 0.03543f ; **FLOATING
C8561 VDD.t1010 VSS 0.03762f ; **FLOATING
C8562 VDD.t1391 VSS 0.04651f ; **FLOATING
C8563 VDD.t1011 VSS 0.06643f ; **FLOATING
C8564 VDD.t1286 VSS 0.03543f ; **FLOATING
C8565 VDD.t1474 VSS 0.03543f ; **FLOATING
C8566 VDD.t546 VSS 0.03543f ; **FLOATING
C8567 VDD.t528 VSS 0.03543f ; **FLOATING
C8568 VDD.t1202 VSS 0.03182f ; **FLOATING
C8569 VDD.t709 VSS 0.04651f ; **FLOATING
C8570 VDD.t1500 VSS 0.03543f ; **FLOATING
C8571 VDD.t54 VSS 0.03181f ; **FLOATING
C8572 VDD.t714 VSS 0.03543f ; **FLOATING
C8573 VDD.t200 VSS 0.03182f ; **FLOATING
C8574 VDD.t1531 VSS 0.03543f ; **FLOATING
C8575 VDD.t195 VSS 0.03181f ; **FLOATING
C8576 VDD.t202 VSS 0.03182f ; **FLOATING
C8577 VDD.t1395 VSS 0.04668f ; **FLOATING
C8578 VDD.t939 VSS 0.03543f ; **FLOATING
C8579 VDD.n928 VSS 0.06436f ; **FLOATING
C8580 VDD.n929 VSS 0.01394f ; **FLOATING
C8581 VDD.t205 VSS 0.03181f ; **FLOATING
C8582 VDD.n930 VSS 0.05497f ; **FLOATING
C8583 VDD.t721 VSS 0.03543f ; **FLOATING
C8584 VDD.n931 VSS 0.05382f ; **FLOATING
C8585 VDD.t712 VSS 0.03543f ; **FLOATING
C8586 VDD.t1499 VSS 0.03543f ; **FLOATING
C8587 VDD.t99 VSS 0.03182f ; **FLOATING
C8588 VDD.t374 VSS 0.04651f ; **FLOATING
C8589 VDD.t232 VSS 0.03181f ; **FLOATING
C8590 VDD.t349 VSS 0.03543f ; **FLOATING
C8591 VDD.t230 VSS 0.03182f ; **FLOATING
C8592 VDD.t680 VSS 0.03543f ; **FLOATING
C8593 VDD.t726 VSS 0.03543f ; **FLOATING
C8594 VDD.t96 VSS 0.03181f ; **FLOATING
C8595 VDD.t196 VSS 0.03182f ; **FLOATING
C8596 VDD.t199 VSS 0.03181f ; **FLOATING
C8597 VDD.t1203 VSS 0.03543f ; **FLOATING
C8598 VDD.t377 VSS 0.03543f ; **FLOATING
C8599 VDD.t395 VSS 0.03543f ; **FLOATING
C8600 VDD.t498 VSS 0.03543f ; **FLOATING
C8601 VDD.t65 VSS 0.03182f ; **FLOATING
C8602 VDD.t1001 VSS 0.04651f ; **FLOATING
C8603 VDD.t532 VSS 0.03543f ; **FLOATING
C8604 VDD.t148 VSS 0.03181f ; **FLOATING
C8605 VDD.t1578 VSS 0.03543f ; **FLOATING
C8606 VDD.t271 VSS 0.03182f ; **FLOATING
C8607 VDD.t717 VSS 0.03543f ; **FLOATING
C8608 VDD.t94 VSS 0.03181f ; **FLOATING
C8609 VDD.t226 VSS 0.03182f ; **FLOATING
C8610 VDD.t1003 VSS 0.04668f ; **FLOATING
C8611 VDD.n933 VSS 0.01969f ; **FLOATING
C8612 VDD.t1581 VSS 0.03543f ; **FLOATING
C8613 VDD.n934 VSS 0.06436f ; **FLOATING
C8614 VDD.n935 VSS 0.01394f ; **FLOATING
C8615 VDD.t229 VSS 0.03181f ; **FLOATING
C8616 VDD.t491 VSS 0.03543f ; **FLOATING
C8617 VDD.n936 VSS 0.05847f ; **FLOATING
C8618 VDD.t1619 VSS 0.03543f ; **FLOATING
C8619 VDD.n937 VSS 0.05437f ; **FLOATING
C8620 VDD.n938 VSS 0.01374f ; **FLOATING
C8621 VDD.t1537 VSS 0.03543f ; **FLOATING
C8622 VDD.n939 VSS 0.06447f ; **FLOATING
C8623 VDD.n940 VSS 0.02609f ; **FLOATING
C8624 VDD.t685 VSS 0.04651f ; **FLOATING
C8625 VDD.n941 VSS 0.09458f ; **FLOATING
C8626 VDD.t347 VSS 0.03885f ; **FLOATING
C8627 VDD.n942 VSS 0.12607f ; **FLOATING
C8628 VDD.t227 VSS 0.03416f ; **FLOATING
C8629 VDD.t1692 VSS 0.11751f ; **FLOATING
C8630 VDD.t93 VSS 0.03416f ; **FLOATING
C8631 VDD.t1693 VSS 0.11751f ; **FLOATING
C8632 VDD.t66 VSS 0.03416f ; **FLOATING
C8633 VDD.t1694 VSS 0.11751f ; **FLOATING
C8634 VDD.n943 VSS 0.07454f ; **FLOATING
C8635 VDD.n944 VSS 0.01394f ; **FLOATING
C8636 VDD.n945 VSS 0.05382f ; **FLOATING
C8637 VDD.n947 VSS 0.05497f ; **FLOATING
C8638 VDD.t1368 VSS 0.04668f ; **FLOATING
C8639 VDD.t197 VSS 0.03416f ; **FLOATING
C8640 VDD.t1695 VSS 0.11751f ; **FLOATING
C8641 VDD.n948 VSS 0.14383f ; **FLOATING
C8642 VDD.n949 VSS 0.12548f ; **FLOATING
C8643 VDD.t95 VSS 0.03416f ; **FLOATING
C8644 VDD.t1696 VSS 0.11751f ; **FLOATING
C8645 VDD.t100 VSS 0.03416f ; **FLOATING
C8646 VDD.t1697 VSS 0.11751f ; **FLOATING
C8647 VDD.t203 VSS 0.03416f ; **FLOATING
C8648 VDD.t1698 VSS 0.11751f ; **FLOATING
C8649 VDD.n950 VSS 0.14383f ; **FLOATING
C8650 VDD.t194 VSS 0.03416f ; **FLOATING
C8651 VDD.t1699 VSS 0.11751f ; **FLOATING
C8652 VDD.t53 VSS 0.03416f ; **FLOATING
C8653 VDD.t1700 VSS 0.11751f ; **FLOATING
C8654 VDD.n951 VSS 0.06436f ; **FLOATING
C8655 VDD.n952 VSS 0.01394f ; **FLOATING
C8656 VDD.n953 VSS 0.07893f ; **FLOATING
C8657 VDD.n954 VSS 0.07423f ; **FLOATING
C8658 VDD.n955 VSS 0.02926f ; **FLOATING
C8659 VDD.n956 VSS 0.0892f ; **FLOATING
C8660 VDD.n957 VSS 0.02609f ; **FLOATING
C8661 VDD.n958 VSS 0.06447f ; **FLOATING
C8662 VDD.n959 VSS 0.01374f ; **FLOATING
C8663 VDD.n960 VSS 0.05437f ; **FLOATING
C8664 VDD.n961 VSS 0.01969f ; **FLOATING
C8665 VDD.n962 VSS 0.06436f ; **FLOATING
C8666 VDD.n963 VSS 0.01394f ; **FLOATING
C8667 VDD.n964 VSS 0.05382f ; **FLOATING
C8668 VDD.n966 VSS 0.05497f ; **FLOATING
C8669 VDD.t708 VSS 0.04668f ; **FLOATING
C8670 VDD.t22 VSS 0.03416f ; **FLOATING
C8671 VDD.t1701 VSS 0.11751f ; **FLOATING
C8672 VDD.n967 VSS 0.14383f ; **FLOATING
C8673 VDD.n968 VSS 0.12548f ; **FLOATING
C8674 VDD.t24 VSS 0.03416f ; **FLOATING
C8675 VDD.t1702 VSS 0.11751f ; **FLOATING
C8676 VDD.t118 VSS 0.03416f ; **FLOATING
C8677 VDD.t1703 VSS 0.11751f ; **FLOATING
C8678 VDD.t1199 VSS 0.03416f ; **FLOATING
C8679 VDD.t1704 VSS 0.11751f ; **FLOATING
C8680 VDD.t307 VSS 0.03416f ; **FLOATING
C8681 VDD.t1705 VSS 0.11751f ; **FLOATING
C8682 VDD.t310 VSS 0.03416f ; **FLOATING
C8683 VDD.t1706 VSS 0.11751f ; **FLOATING
C8684 VDD.n969 VSS 0.06386f ; **FLOATING
C8685 VDD.n970 VSS 0.01394f ; **FLOATING
C8686 VDD.n971 VSS 0.05382f ; **FLOATING
C8687 VDD.n973 VSS 0.05497f ; **FLOATING
C8688 VDD.t1120 VSS 0.04668f ; **FLOATING
C8689 VDD.t120 VSS 0.03416f ; **FLOATING
C8690 VDD.t1707 VSS 0.11751f ; **FLOATING
C8691 VDD.n974 VSS 0.14383f ; **FLOATING
C8692 VDD.n975 VSS 0.12548f ; **FLOATING
C8693 VDD.t608 VSS 0.03423f ; **FLOATING
C8694 VDD.t605 VSS 0.03423f ; **FLOATING
C8695 VDD.t603 VSS 0.02471f ; **FLOATING
C8696 VDD.n976 VSS 0.01701f ; **FLOATING
C8697 VDD.t832 VSS 0.03423f ; **FLOATING
C8698 VDD.t810 VSS 0.03423f ; **FLOATING
C8699 VDD.t813 VSS 0.03423f ; **FLOATING
C8700 VDD.t805 VSS 0.03423f ; **FLOATING
C8701 VDD.t844 VSS 0.03423f ; **FLOATING
C8702 VDD.n977 VSS 0.02538f ; **FLOATING
C8703 VDD.t843 VSS 0.03423f ; **FLOATING
C8704 VDD.n978 VSS 0.02538f ; **FLOATING
C8705 VDD.t829 VSS 0.03423f ; **FLOATING
C8706 VDD.t806 VSS 0.03423f ; **FLOATING
C8707 VDD.t853 VSS 0.03423f ; **FLOATING
C8708 VDD.t845 VSS 0.03423f ; **FLOATING
C8709 VDD.n979 VSS 0.02538f ; **FLOATING
C8710 VDD.t847 VSS 0.03423f ; **FLOATING
C8711 VDD.t846 VSS 0.03423f ; **FLOATING
C8712 VDD.n980 VSS 0.02538f ; **FLOATING
C8713 VDD.t812 VSS 0.03423f ; **FLOATING
C8714 VDD.n981 VSS 0.02538f ; **FLOATING
C8715 VDD.t854 VSS 0.03423f ; **FLOATING
C8716 VDD.t807 VSS 0.03423f ; **FLOATING
C8717 VDD.t858 VSS 0.03423f ; **FLOATING
C8718 VDD.t793 VSS 0.03423f ; **FLOATING
C8719 VDD.t859 VSS 0.03423f ; **FLOATING
C8720 VDD.t857 VSS 0.03423f ; **FLOATING
C8721 VDD.t773 VSS 0.03423f ; **FLOATING
C8722 VDD.t860 VSS 0.03423f ; **FLOATING
C8723 VDD.t856 VSS 0.03423f ; **FLOATING
C8724 VDD.n982 VSS 0.02538f ; **FLOATING
C8725 VDD.t855 VSS 0.03423f ; **FLOATING
C8726 VDD.n983 VSS 0.02538f ; **FLOATING
C8727 VDD.t801 VSS 0.03423f ; **FLOATING
C8728 VDD.t861 VSS 0.03423f ; **FLOATING
C8729 VDD.t862 VSS 0.03423f ; **FLOATING
C8730 VDD.n984 VSS 0.02538f ; **FLOATING
C8731 VDD.t794 VSS 0.03423f ; **FLOATING
C8732 VDD.t864 VSS 0.03423f ; **FLOATING
C8733 VDD.t863 VSS 0.03423f ; **FLOATING
C8734 VDD.n985 VSS 0.02538f ; **FLOATING
C8735 VDD.t865 VSS 0.03423f ; **FLOATING
C8736 VDD.t811 VSS 0.03423f ; **FLOATING
C8737 VDD.t866 VSS 0.03423f ; **FLOATING
C8738 VDD.n986 VSS 0.02538f ; **FLOATING
C8739 VDD.t611 VSS 0.03423f ; **FLOATING
C8740 VDD.t609 VSS 0.0718f ; **FLOATING
C8741 VDD.t610 VSS 0.03825f ; **FLOATING
C8742 VDD.t612 VSS 0.03308f ; **FLOATING
C8743 VDD.n987 VSS 0.01687f ; **FLOATING
C8744 VDD.t613 VSS 0.03423f ; **FLOATING
C8745 VDD.t1344 VSS 0.04014f ; **FLOATING
C8746 VDD.t461 VSS 0.04014f ; **FLOATING
C8747 VDD.t541 VSS 0.04014f ; **FLOATING
C8748 VDD.t715 VSS 0.04014f ; **FLOATING
C8749 VDD.n988 VSS 0.07482f ; **FLOATING
C8750 VDD.t383 VSS 0.04014f ; **FLOATING
C8751 VDD.t1132 VSS 0.04014f ; **FLOATING
C8752 VDD.t1068 VSS 0.04014f ; **FLOATING
C8753 VDD.n989 VSS 0.0636f ; **FLOATING
C8754 VDD.t580 VSS 0.04014f ; **FLOATING
C8755 VDD.n990 VSS 0.08358f ; **FLOATING
C8756 VDD.t578 VSS 0.04014f ; **FLOATING
C8757 VDD.t1067 VSS 0.04014f ; **FLOATING
C8758 VDD.t579 VSS 0.04014f ; **FLOATING
C8759 VDD.n991 VSS 0.08359f ; **FLOATING
C8760 VDD.t576 VSS 0.04014f ; **FLOATING
C8761 VDD.t382 VSS 0.04014f ; **FLOATING
C8762 VDD.t1060 VSS 0.04014f ; **FLOATING
C8763 VDD.t697 VSS 0.04014f ; **FLOATING
C8764 VDD.t1062 VSS 0.04014f ; **FLOATING
C8765 VDD.n992 VSS 0.04752f ; **FLOATING
C8766 VDD.t1100 VSS 0.04014f ; **FLOATING
C8767 VDD.t568 VSS 0.04014f ; **FLOATING
C8768 VDD.t978 VSS 0.04014f ; **FLOATING
C8769 VDD.t1005 VSS 0.04014f ; **FLOATING
C8770 VDD.t1057 VSS 0.04014f ; **FLOATING
C8771 VDD.n993 VSS 0.08362f ; **FLOATING
C8772 VDD.n994 VSS 0.0778f ; **FLOATING
C8773 VDD.t942 VSS 0.04014f ; **FLOATING
C8774 VDD.t944 VSS 0.04014f ; **FLOATING
C8775 VDD.t566 VSS 0.04014f ; **FLOATING
C8776 VDD.t518 VSS 0.04014f ; **FLOATING
C8777 VDD.t692 VSS 0.04014f ; **FLOATING
C8778 VDD.t1330 VSS 0.04014f ; **FLOATING
C8779 VDD.n995 VSS 0.06361f ; **FLOATING
C8780 VDD.t1015 VSS 0.04014f ; **FLOATING
C8781 VDD.t1017 VSS 0.04014f ; **FLOATING
C8782 VDD.t1013 VSS 0.04014f ; **FLOATING
C8783 VDD.t1152 VSS 0.04014f ; **FLOATING
C8784 VDD.t1317 VSS 0.04014f ; **FLOATING
C8785 VDD.n996 VSS 0.07256f ; **FLOATING
C8786 VDD.n997 VSS 0.01488f ; **FLOATING
C8787 VDD.n998 VSS 0.08359f ; **FLOATING
C8788 VDD.n999 VSS 0.09121f ; **FLOATING
C8789 VDD.n1000 VSS 0.08231f ; **FLOATING
C8790 VDD.n1001 VSS 0.01488f ; **FLOATING
C8791 VDD.n1002 VSS 0.06361f ; **FLOATING
C8792 VDD.n1003 VSS 0.01488f ; **FLOATING
C8793 VDD.n1004 VSS 0.08358f ; **FLOATING
C8794 VDD.n1005 VSS 0.09443f ; **FLOATING
C8795 VDD.n1006 VSS 0.06361f ; **FLOATING
C8796 VDD.n1007 VSS 0.01488f ; **FLOATING
C8797 VDD.n1008 VSS 0.1032f ; **FLOATING
C8798 VDD.n1009 VSS 0.10159f ; **FLOATING
C8799 VDD.n1010 VSS 0.0836f ; **FLOATING
C8800 VDD.n1011 VSS 0.09443f ; **FLOATING
C8801 VDD.n1012 VSS 0.06363f ; **FLOATING
C8802 VDD.n1013 VSS 0.0782f ; **FLOATING
C8803 VDD.n1015 VSS 0.04888f ; **FLOATING
C8804 VDD.n1016 VSS 0.02718f ; **FLOATING
C8805 VDD.n1017 VSS 0.09307f ; **FLOATING
C8806 VDD.n1018 VSS 0.05203f ; **FLOATING
C8807 VDD.n1019 VSS 0.11246f ; **FLOATING
C8808 VDD.n1020 VSS 0.05203f ; **FLOATING
C8809 VDD.n1021 VSS 0.11246f ; **FLOATING
C8810 VDD.n1022 VSS 0.05203f ; **FLOATING
C8811 VDD.n1023 VSS 0.11246f ; **FLOATING
C8812 VDD.n1024 VSS 0.05203f ; **FLOATING
C8813 VDD.n1025 VSS 0.09301f ; **FLOATING
C8814 VDD.n1026 VSS 0.03405f ; **FLOATING
C8815 VDD.n1027 VSS 0.08499f ; **FLOATING
C8816 VDD.n1028 VSS 0.01707f ; **FLOATING
C8817 VDD.n1029 VSS 0.0831f ; **FLOATING
C8818 VDD.n1030 VSS 0.05203f ; **FLOATING
C8819 VDD.n1031 VSS 0.11246f ; **FLOATING
C8820 VDD.n1032 VSS 0.05203f ; **FLOATING
C8821 VDD.n1033 VSS 0.11246f ; **FLOATING
C8822 VDD.n1034 VSS 0.05203f ; **FLOATING
C8823 VDD.n1035 VSS 0.11246f ; **FLOATING
C8824 VDD.n1036 VSS 0.05203f ; **FLOATING
C8825 VDD.n1037 VSS 0.11246f ; **FLOATING
C8826 VDD.n1038 VSS 0.05203f ; **FLOATING
C8827 VDD.n1039 VSS 0.11246f ; **FLOATING
C8828 VDD.n1040 VSS 0.05203f ; **FLOATING
C8829 VDD.n1041 VSS 0.11246f ; **FLOATING
C8830 VDD.n1042 VSS 0.05203f ; **FLOATING
C8831 VDD.n1043 VSS 0.11246f ; **FLOATING
C8832 VDD.n1044 VSS 0.05203f ; **FLOATING
C8833 VDD.n1045 VSS 0.11246f ; **FLOATING
C8834 VDD.n1046 VSS 0.05203f ; **FLOATING
C8835 VDD.n1047 VSS 0.10768f ; **FLOATING
C8836 VDD.n1048 VSS 0.11631f ; **FLOATING
C8837 VDD.n1049 VSS 0.05203f ; **FLOATING
C8838 VDD.n1050 VSS 0.11246f ; **FLOATING
C8839 VDD.n1051 VSS 0.05203f ; **FLOATING
C8840 VDD.n1052 VSS 0.11246f ; **FLOATING
C8841 VDD.n1053 VSS 0.05203f ; **FLOATING
C8842 VDD.n1054 VSS 0.11246f ; **FLOATING
C8843 VDD.n1055 VSS 0.05203f ; **FLOATING
C8844 VDD.n1056 VSS 0.11246f ; **FLOATING
C8845 VDD.n1057 VSS 0.05203f ; **FLOATING
C8846 VDD.n1058 VSS 0.11246f ; **FLOATING
C8847 VDD.n1059 VSS 0.05203f ; **FLOATING
C8848 VDD.n1060 VSS 0.11246f ; **FLOATING
C8849 VDD.n1061 VSS 0.05203f ; **FLOATING
C8850 VDD.n1062 VSS 0.11246f ; **FLOATING
C8851 VDD.n1063 VSS 0.05203f ; **FLOATING
C8852 VDD.n1064 VSS 0.04739f ; **FLOATING
C8853 VDD.n1065 VSS 0.10769f ; **FLOATING
C8854 VDD.n1066 VSS 0.05203f ; **FLOATING
C8855 VDD.n1067 VSS 0.11246f ; **FLOATING
C8856 VDD.n1068 VSS 0.05203f ; **FLOATING
C8857 VDD.n1069 VSS 0.11246f ; **FLOATING
C8858 VDD.n1070 VSS 0.05203f ; **FLOATING
C8859 VDD.n1071 VSS 0.11246f ; **FLOATING
C8860 VDD.n1072 VSS 0.05203f ; **FLOATING
C8861 VDD.n1073 VSS 0.11246f ; **FLOATING
C8862 VDD.n1074 VSS 0.05203f ; **FLOATING
C8863 VDD.t606 VSS 0.02015f ; **FLOATING
C8864 VDD.t604 VSS 0.0387f ; **FLOATING
C8865 VDD.t556 VSS 0.03543f ; **FLOATING
C8866 VDD.t405 VSS 0.03543f ; **FLOATING
C8867 VDD.t149 VSS 0.03182f ; **FLOATING
C8868 VDD.n1075 VSS 0.05995f ; **FLOATING
C8869 VDD.n1076 VSS 0.0196f ; **FLOATING
C8870 VDD.t1194 VSS 0.03543f ; **FLOATING
C8871 VDD.n1077 VSS 0.05455f ; **FLOATING
C8872 VDD.n1078 VSS 0.01374f ; **FLOATING
C8873 VDD.n1079 VSS 0.02926f ; **FLOATING
C8874 VDD.t1322 VSS 0.04651f ; **FLOATING
C8875 VDD.n1080 VSS 0.0892f ; **FLOATING
C8876 VDD.n1081 VSS 0.02609f ; **FLOATING
C8877 VDD.t1190 VSS 0.03543f ; **FLOATING
C8878 VDD.n1082 VSS 0.09607f ; **FLOATING
C8879 VDD.n1083 VSS 0.01242f ; **FLOATING
C8880 VDD.n1084 VSS 0.01294f ; **FLOATING
C8881 VDD.t1388 VSS 0.03949f ; **FLOATING
C8882 VDD.t758 VSS 0.03949f ; **FLOATING
C8883 VDD.n1085 VSS 0.08483f ; **FLOATING
C8884 VDD.n1086 VSS 0.01245f ; **FLOATING
C8885 VDD.n1087 VSS 0.01311f ; **FLOATING
C8886 VDD.t1414 VSS 0.03949f ; **FLOATING
C8887 VDD.t1251 VSS 0.03949f ; **FLOATING
C8888 VDD.n1088 VSS 0.08886f ; **FLOATING
C8889 VDD.t432 VSS 0.03543f ; **FLOATING
C8890 VDD.t1242 VSS 0.03543f ; **FLOATING
C8891 VDD.t1402 VSS 0.02617f ; **FLOATING
C8892 VDD.t1510 VSS 0.02617f ; **FLOATING
C8893 VDD.t1413 VSS 0.03498f ; **FLOATING
C8894 VDD.t950 VSS 0.03498f ; **FLOATING
C8895 VDD.t555 VSS 0.02617f ; **FLOATING
C8896 VDD.t403 VSS 0.02617f ; **FLOATING
C8897 VDD.n1089 VSS 0.07007f ; **FLOATING
C8898 VDD.t1387 VSS 0.03498f ; **FLOATING
C8899 VDD.t757 VSS 0.03498f ; **FLOATING
C8900 VDD.n1090 VSS 0.07502f ; **FLOATING
C8901 VDD.n1091 VSS 0.01264f ; **FLOATING
C8902 VDD.t433 VSS 0.02617f ; **FLOATING
C8903 VDD.t1243 VSS 0.02617f ; **FLOATING
C8904 VDD.n1092 VSS 0.06983f ; **FLOATING
C8905 VDD.n1093 VSS 0.01218f ; **FLOATING
C8906 VDD.t1401 VSS 0.03498f ; **FLOATING
C8907 VDD.t988 VSS 0.03498f ; **FLOATING
C8908 VDD.n1094 VSS 0.07079f ; **FLOATING
C8909 VDD.n1095 VSS 0.01729f ; **FLOATING
C8910 VDD.t1410 VSS 0.03949f ; **FLOATING
C8911 VDD.t989 VSS 0.03949f ; **FLOATING
C8912 VDD.n1096 VSS 0.07913f ; **FLOATING
C8913 VDD.t557 VSS 0.02617f ; **FLOATING
C8914 VDD.t404 VSS 0.02617f ; **FLOATING
C8915 VDD.n1097 VSS 0.07047f ; **FLOATING
C8916 VDD.n1098 VSS 0.01289f ; **FLOATING
C8917 VDD.t434 VSS 0.03498f ; **FLOATING
C8918 VDD.t991 VSS 0.03498f ; **FLOATING
C8919 VDD.t1606 VSS 0.03949f ; **FLOATING
C8920 VDD.t992 VSS 0.03949f ; **FLOATING
C8921 VDD.t1422 VSS 0.03543f ; **FLOATING
C8922 VDD.t412 VSS 0.03555f ; **FLOATING
C8923 VDD.t586 VSS 0.03543f ; **FLOATING
C8924 VDD.n1099 VSS 0.07423f ; **FLOATING
C8925 VDD.n1100 VSS 0.01394f ; **FLOATING
C8926 VDD.t1153 VSS 0.03543f ; **FLOATING
C8927 VDD.n1101 VSS 0.06436f ; **FLOATING
C8928 VDD.t1170 VSS 0.03543f ; **FLOATING
C8929 VDD.n1102 VSS 0.05437f ; **FLOATING
C8930 VDD.n1103 VSS 0.01969f ; **FLOATING
C8931 VDD.t337 VSS 0.03543f ; **FLOATING
C8932 VDD.t151 VSS 0.03181f ; **FLOATING
C8933 VDD.t152 VSS 0.03182f ; **FLOATING
C8934 VDD.t1018 VSS 0.03543f ; **FLOATING
C8935 VDD.t150 VSS 0.03416f ; **FLOATING
C8936 VDD.t1691 VSS 0.11751f ; **FLOATING
C8937 VDD.t1055 VSS 0.04651f ; **FLOATING
C8938 VDD.t153 VSS 0.03416f ; **FLOATING
C8939 VDD.t1690 VSS 0.11751f ; **FLOATING
C8940 VDD.t590 VSS 0.03543f ; **FLOATING
C8941 VDD.t155 VSS 0.03181f ; **FLOATING
C8942 VDD.t156 VSS 0.03182f ; **FLOATING
C8943 VDD.t159 VSS 0.03181f ; **FLOATING
C8944 VDD.t466 VSS 0.03543f ; **FLOATING
C8945 VDD.t1329 VSS 0.03543f ; **FLOATING
C8946 VDD.t1539 VSS 0.03543f ; **FLOATING
C8947 VDD.t1378 VSS 0.03543f ; **FLOATING
C8948 VDD.t68 VSS 0.03182f ; **FLOATING
C8949 VDD.t693 VSS 0.04651f ; **FLOATING
C8950 VDD.t1535 VSS 0.03543f ; **FLOATING
C8951 VDD.t219 VSS 0.03181f ; **FLOATING
C8952 VDD.t519 VSS 0.03543f ; **FLOATING
C8953 VDD.t220 VSS 0.03182f ; **FLOATING
C8954 VDD.t585 VSS 0.03543f ; **FLOATING
C8955 VDD.t223 VSS 0.03181f ; **FLOATING
C8956 VDD.t224 VSS 0.03182f ; **FLOATING
C8957 VDD.t1097 VSS 0.04668f ; **FLOATING
C8958 VDD.n1104 VSS 0.01969f ; **FLOATING
C8959 VDD.t945 VSS 0.03543f ; **FLOATING
C8960 VDD.n1105 VSS 0.06436f ; **FLOATING
C8961 VDD.n1106 VSS 0.01394f ; **FLOATING
C8962 VDD.t279 VSS 0.03181f ; **FLOATING
C8963 VDD.n1107 VSS 0.05497f ; **FLOATING
C8964 VDD.t1192 VSS 0.03543f ; **FLOATING
C8965 VDD.n1108 VSS 0.05382f ; **FLOATING
C8966 VDD.t1176 VSS 0.03543f ; **FLOATING
C8967 VDD.n1110 VSS 0.05437f ; **FLOATING
C8968 VDD.n1111 VSS 0.01374f ; **FLOATING
C8969 VDD.t1379 VSS 0.03543f ; **FLOATING
C8970 VDD.n1112 VSS 0.05455f ; **FLOATING
C8971 VDD.n1113 VSS 0.0196f ; **FLOATING
C8972 VDD.t280 VSS 0.03182f ; **FLOATING
C8973 VDD.n1114 VSS 0.06654f ; **FLOATING
C8974 VDD.t943 VSS 0.04651f ; **FLOATING
C8975 VDD.t283 VSS 0.03181f ; **FLOATING
C8976 VDD.t1195 VSS 0.03543f ; **FLOATING
C8977 VDD.t284 VSS 0.03182f ; **FLOATING
C8978 VDD.t1098 VSS 0.03543f ; **FLOATING
C8979 VDD.t408 VSS 0.03543f ; **FLOATING
C8980 VDD.t287 VSS 0.03181f ; **FLOATING
C8981 VDD.t288 VSS 0.03182f ; **FLOATING
C8982 VDD.t291 VSS 0.03181f ; **FLOATING
C8983 VDD.t1302 VSS 0.03543f ; **FLOATING
C8984 VDD.t1334 VSS 0.03543f ; **FLOATING
C8985 VDD.t569 VSS 0.03543f ; **FLOATING
C8986 VDD.t1381 VSS 0.03543f ; **FLOATING
C8987 VDD.t1429 VSS 0.04651f ; **FLOATING
C8988 VDD.t1279 VSS 0.03543f ; **FLOATING
C8989 VDD.t1101 VSS 0.03543f ; **FLOATING
C8990 VDD.t430 VSS 0.03543f ; **FLOATING
C8991 VDD.t1191 VSS 0.03543f ; **FLOATING
C8992 VDD.t1144 VSS 0.03762f ; **FLOATING
C8993 VDD.t1490 VSS 0.04651f ; **FLOATING
C8994 VDD.t1145 VSS 0.06643f ; **FLOATING
C8995 VDD.t465 VSS 0.03543f ; **FLOATING
C8996 VDD.t696 VSS 0.03543f ; **FLOATING
C8997 VDD.t1433 VSS 0.03543f ; **FLOATING
C8998 VDD.t1377 VSS 0.03543f ; **FLOATING
C8999 VDD.t206 VSS 0.03182f ; **FLOATING
C9000 VDD.t1061 VSS 0.04651f ; **FLOATING
C9001 VDD.t1212 VSS 0.03543f ; **FLOATING
C9002 VDD.t209 VSS 0.03181f ; **FLOATING
C9003 VDD.t1585 VSS 0.03543f ; **FLOATING
C9004 VDD.t210 VSS 0.03182f ; **FLOATING
C9005 VDD.t1501 VSS 0.03543f ; **FLOATING
C9006 VDD.t213 VSS 0.03181f ; **FLOATING
C9007 VDD.t214 VSS 0.03182f ; **FLOATING
C9008 VDD.t1436 VSS 0.04668f ; **FLOATING
C9009 VDD.n1115 VSS 0.01969f ; **FLOATING
C9010 VDD.t1064 VSS 0.03543f ; **FLOATING
C9011 VDD.n1116 VSS 0.06436f ; **FLOATING
C9012 VDD.n1117 VSS 0.01394f ; **FLOATING
C9013 VDD.t217 VSS 0.03181f ; **FLOATING
C9014 VDD.t1193 VSS 0.03543f ; **FLOATING
C9015 VDD.n1118 VSS 0.05382f ; **FLOATING
C9016 VDD.t1540 VSS 0.03543f ; **FLOATING
C9017 VDD.n1120 VSS 0.05437f ; **FLOATING
C9018 VDD.n1121 VSS 0.01374f ; **FLOATING
C9019 VDD.t1380 VSS 0.03543f ; **FLOATING
C9020 VDD.n1122 VSS 0.05455f ; **FLOATING
C9021 VDD.n1123 VSS 0.0196f ; **FLOATING
C9022 VDD.t37 VSS 0.03182f ; **FLOATING
C9023 VDD.n1124 VSS 0.06654f ; **FLOATING
C9024 VDD.t1066 VSS 0.04651f ; **FLOATING
C9025 VDD.t138 VSS 0.03181f ; **FLOATING
C9026 VDD.t1196 VSS 0.03543f ; **FLOATING
C9027 VDD.t139 VSS 0.03182f ; **FLOATING
C9028 VDD.t577 VSS 0.03543f ; **FLOATING
C9029 VDD.t409 VSS 0.03543f ; **FLOATING
C9030 VDD.t142 VSS 0.03181f ; **FLOATING
C9031 VDD.t143 VSS 0.03182f ; **FLOATING
C9032 VDD.t146 VSS 0.03181f ; **FLOATING
C9033 VDD.t1303 VSS 0.03543f ; **FLOATING
C9034 VDD.t1341 VSS 0.03543f ; **FLOATING
C9035 VDD.t1538 VSS 0.03543f ; **FLOATING
C9036 VDD.t1382 VSS 0.03543f ; **FLOATING
C9037 VDD.t256 VSS 0.03182f ; **FLOATING
C9038 VDD.t1131 VSS 0.04651f ; **FLOATING
C9039 VDD.t1280 VSS 0.03543f ; **FLOATING
C9040 VDD.t259 VSS 0.03181f ; **FLOATING
C9041 VDD.t1589 VSS 0.03543f ; **FLOATING
C9042 VDD.t260 VSS 0.03182f ; **FLOATING
C9043 VDD.t1376 VSS 0.03543f ; **FLOATING
C9044 VDD.t183 VSS 0.03181f ; **FLOATING
C9045 VDD.t184 VSS 0.03182f ; **FLOATING
C9046 VDD.t716 VSS 0.04668f ; **FLOATING
C9047 VDD.n1125 VSS 0.01969f ; **FLOATING
C9048 VDD.t542 VSS 0.03543f ; **FLOATING
C9049 VDD.n1126 VSS 0.06436f ; **FLOATING
C9050 VDD.n1127 VSS 0.01394f ; **FLOATING
C9051 VDD.t187 VSS 0.03181f ; **FLOATING
C9052 VDD.t1197 VSS 0.03543f ; **FLOATING
C9053 VDD.n1128 VSS 0.05382f ; **FLOATING
C9054 VDD.t550 VSS 0.03543f ; **FLOATING
C9055 VDD.n1130 VSS 0.05437f ; **FLOATING
C9056 VDD.n1131 VSS 0.01374f ; **FLOATING
C9057 VDD.t1301 VSS 0.03543f ; **FLOATING
C9058 VDD.n1132 VSS 0.06447f ; **FLOATING
C9059 VDD.n1133 VSS 0.02609f ; **FLOATING
C9060 VDD.t462 VSS 0.04651f ; **FLOATING
C9061 VDD.n1134 VSS 0.09458f ; **FLOATING
C9062 VDD.t338 VSS 0.03885f ; **FLOATING
C9063 VDD.n1135 VSS 0.12607f ; **FLOATING
C9064 VDD.t185 VSS 0.03416f ; **FLOATING
C9065 VDD.t1674 VSS 0.11751f ; **FLOATING
C9066 VDD.t182 VSS 0.03416f ; **FLOATING
C9067 VDD.t1675 VSS 0.11751f ; **FLOATING
C9068 VDD.t257 VSS 0.03416f ; **FLOATING
C9069 VDD.t1676 VSS 0.11751f ; **FLOATING
C9070 VDD.n1136 VSS 0.07454f ; **FLOATING
C9071 VDD.n1137 VSS 0.01394f ; **FLOATING
C9072 VDD.n1138 VSS 0.05382f ; **FLOATING
C9073 VDD.n1140 VSS 0.06128f ; **FLOATING
C9074 VDD.t581 VSS 0.04668f ; **FLOATING
C9075 VDD.t144 VSS 0.03416f ; **FLOATING
C9076 VDD.t1677 VSS 0.11751f ; **FLOATING
C9077 VDD.t140 VSS 0.03416f ; **FLOATING
C9078 VDD.t1678 VSS 0.11751f ; **FLOATING
C9079 VDD.t38 VSS 0.03416f ; **FLOATING
C9080 VDD.t1679 VSS 0.11751f ; **FLOATING
C9081 VDD.t215 VSS 0.03416f ; **FLOATING
C9082 VDD.t1680 VSS 0.11751f ; **FLOATING
C9083 VDD.t211 VSS 0.03416f ; **FLOATING
C9084 VDD.t1681 VSS 0.11751f ; **FLOATING
C9085 VDD.t207 VSS 0.03416f ; **FLOATING
C9086 VDD.t1682 VSS 0.11751f ; **FLOATING
C9087 VDD.n1141 VSS 0.06654f ; **FLOATING
C9088 VDD.n1142 VSS 0.0196f ; **FLOATING
C9089 VDD.n1143 VSS 0.05455f ; **FLOATING
C9090 VDD.n1144 VSS 0.01374f ; **FLOATING
C9091 VDD.n1145 VSS 0.05437f ; **FLOATING
C9092 VDD.n1146 VSS 0.01969f ; **FLOATING
C9093 VDD.n1147 VSS 0.06436f ; **FLOATING
C9094 VDD.n1148 VSS 0.01394f ; **FLOATING
C9095 VDD.n1149 VSS 0.07893f ; **FLOATING
C9096 VDD.n1150 VSS 0.07423f ; **FLOATING
C9097 VDD.n1151 VSS 0.02926f ; **FLOATING
C9098 VDD.n1152 VSS 0.0892f ; **FLOATING
C9099 VDD.n1153 VSS 0.02609f ; **FLOATING
C9100 VDD.n1154 VSS 0.06447f ; **FLOATING
C9101 VDD.n1155 VSS 0.01374f ; **FLOATING
C9102 VDD.n1156 VSS 0.05437f ; **FLOATING
C9103 VDD.n1157 VSS 0.01969f ; **FLOATING
C9104 VDD.n1158 VSS 0.06436f ; **FLOATING
C9105 VDD.n1159 VSS 0.01394f ; **FLOATING
C9106 VDD.n1160 VSS 0.05382f ; **FLOATING
C9107 VDD.t1006 VSS 0.04668f ; **FLOATING
C9108 VDD.t289 VSS 0.03416f ; **FLOATING
C9109 VDD.t1683 VSS 0.11751f ; **FLOATING
C9110 VDD.t285 VSS 0.03416f ; **FLOATING
C9111 VDD.t1684 VSS 0.11751f ; **FLOATING
C9112 VDD.t281 VSS 0.03416f ; **FLOATING
C9113 VDD.t1685 VSS 0.11751f ; **FLOATING
C9114 VDD.t225 VSS 0.03416f ; **FLOATING
C9115 VDD.t1686 VSS 0.11751f ; **FLOATING
C9116 VDD.n1162 VSS 0.14383f ; **FLOATING
C9117 VDD.t221 VSS 0.03416f ; **FLOATING
C9118 VDD.t1687 VSS 0.11751f ; **FLOATING
C9119 VDD.t69 VSS 0.03416f ; **FLOATING
C9120 VDD.t1688 VSS 0.11751f ; **FLOATING
C9121 VDD.n1163 VSS 0.06386f ; **FLOATING
C9122 VDD.n1164 VSS 0.01394f ; **FLOATING
C9123 VDD.n1165 VSS 0.05847f ; **FLOATING
C9124 VDD.t1016 VSS 0.04668f ; **FLOATING
C9125 VDD.t157 VSS 0.03416f ; **FLOATING
C9126 VDD.t1689 VSS 0.11751f ; **FLOATING
C9127 VDD.n1166 VSS 0.69517f ; **FLOATING
C9128 VDD.t1419 VSS 0.03543f ; **FLOATING
C9129 VDD.t1177 VSS 0.03543f ; **FLOATING
C9130 VDD.t39 VSS 0.03182f ; **FLOATING
C9131 VDD.n1167 VSS 0.06654f ; **FLOATING
C9132 VDD.n1168 VSS 0.0196f ; **FLOATING
C9133 VDD.t1209 VSS 0.03543f ; **FLOATING
C9134 VDD.n1169 VSS 0.05455f ; **FLOATING
C9135 VDD.n1170 VSS 0.01374f ; **FLOATING
C9136 VDD.n1171 VSS 0.02926f ; **FLOATING
C9137 VDD.t760 VSS 0.04651f ; **FLOATING
C9138 VDD.n1172 VSS 0.0892f ; **FLOATING
C9139 VDD.n1173 VSS 0.02609f ; **FLOATING
C9140 VDD.t510 VSS 0.03543f ; **FLOATING
C9141 VDD.n1174 VSS 0.09607f ; **FLOATING
C9142 VDD.n1175 VSS 0.01242f ; **FLOATING
C9143 VDD.n1176 VSS 0.01294f ; **FLOATING
C9144 VDD.t1240 VSS 0.03949f ; **FLOATING
C9145 VDD.t589 VSS 0.03949f ; **FLOATING
C9146 VDD.n1177 VSS 0.08483f ; **FLOATING
C9147 VDD.n1178 VSS 0.01245f ; **FLOATING
C9148 VDD.n1179 VSS 0.01311f ; **FLOATING
C9149 VDD.t471 VSS 0.03949f ; **FLOATING
C9150 VDD.t1020 VSS 0.03949f ; **FLOATING
C9151 VDD.n1180 VSS 0.08886f ; **FLOATING
C9152 VDD.t1463 VSS 0.03543f ; **FLOATING
C9153 VDD.t1167 VSS 0.03543f ; **FLOATING
C9154 VDD.t984 VSS 0.02617f ; **FLOATING
C9155 VDD.t544 VSS 0.02617f ; **FLOATING
C9156 VDD.t470 VSS 0.03498f ; **FLOATING
C9157 VDD.t1019 VSS 0.03498f ; **FLOATING
C9158 VDD.t1420 VSS 0.02617f ; **FLOATING
C9159 VDD.t1178 VSS 0.02617f ; **FLOATING
C9160 VDD.n1181 VSS 0.07007f ; **FLOATING
C9161 VDD.t1239 VSS 0.03498f ; **FLOATING
C9162 VDD.t588 VSS 0.03498f ; **FLOATING
C9163 VDD.n1182 VSS 0.07502f ; **FLOATING
C9164 VDD.n1183 VSS 0.01264f ; **FLOATING
C9165 VDD.t1462 VSS 0.02617f ; **FLOATING
C9166 VDD.t1166 VSS 0.02617f ; **FLOATING
C9167 VDD.n1184 VSS 0.06983f ; **FLOATING
C9168 VDD.n1185 VSS 0.01218f ; **FLOATING
C9169 VDD.t752 VSS 0.03498f ; **FLOATING
C9170 VDD.t545 VSS 0.03498f ; **FLOATING
C9171 VDD.n1186 VSS 0.07079f ; **FLOATING
C9172 VDD.n1187 VSS 0.01729f ; **FLOATING
C9173 VDD.t753 VSS 0.03949f ; **FLOATING
C9174 VDD.t1027 VSS 0.03949f ; **FLOATING
C9175 VDD.n1188 VSS 0.07913f ; **FLOATING
C9176 VDD.t1421 VSS 0.02617f ; **FLOATING
C9177 VDD.t1179 VSS 0.02617f ; **FLOATING
C9178 VDD.n1189 VSS 0.07047f ; **FLOATING
C9179 VDD.n1190 VSS 0.01289f ; **FLOATING
C9180 VDD.t1464 VSS 0.03498f ; **FLOATING
C9181 VDD.t1168 VSS 0.03498f ; **FLOATING
C9182 VDD.t1484 VSS 0.03949f ; **FLOATING
C9183 VDD.t1564 VSS 0.03949f ; **FLOATING
C9184 VDD.t388 VSS 0.03543f ; **FLOATING
C9185 VDD.t354 VSS 0.03555f ; **FLOATING
C9186 VDD.t515 VSS 0.03543f ; **FLOATING
C9187 VDD.n1191 VSS 0.07423f ; **FLOATING
C9188 VDD.n1192 VSS 0.01394f ; **FLOATING
C9189 VDD.t979 VSS 0.03543f ; **FLOATING
C9190 VDD.n1193 VSS 0.06436f ; **FLOATING
C9191 VDD.t958 VSS 0.03543f ; **FLOATING
C9192 VDD.n1194 VSS 0.05437f ; **FLOATING
C9193 VDD.n1195 VSS 0.01969f ; **FLOATING
C9194 VDD.t686 VSS 0.03543f ; **FLOATING
C9195 VDD.t396 VSS 0.03181f ; **FLOATING
C9196 VDD.t329 VSS 0.03182f ; **FLOATING
C9197 VDD.t1587 VSS 0.03543f ; **FLOATING
C9198 VDD.t40 VSS 0.03416f ; **FLOATING
C9199 VDD.t1637 VSS 0.11751f ; **FLOATING
C9200 VDD.t350 VSS 0.04651f ; **FLOATING
C9201 VDD.t59 VSS 0.03416f ; **FLOATING
C9202 VDD.t1636 VSS 0.11751f ; **FLOATING
C9203 VDD.t1294 VSS 0.03543f ; **FLOATING
C9204 VDD.t60 VSS 0.03181f ; **FLOATING
C9205 VDD.t325 VSS 0.03182f ; **FLOATING
C9206 VDD.t328 VSS 0.03181f ; **FLOATING
C9207 VDD.t1205 VSS 0.03543f ; **FLOATING
C9208 VDD.t1174 VSS 0.03543f ; **FLOATING
C9209 VDD.t536 VSS 0.03543f ; **FLOATING
C9210 VDD.t506 VSS 0.03543f ; **FLOATING
C9211 VDD.t27 VSS 0.03182f ; **FLOATING
C9212 VDD.t674 VSS 0.04651f ; **FLOATING
C9213 VDD.t467 VSS 0.03543f ; **FLOATING
C9214 VDD.t81 VSS 0.03181f ; **FLOATING
C9215 VDD.t1350 VSS 0.03543f ; **FLOATING
C9216 VDD.t79 VSS 0.03182f ; **FLOATING
C9217 VDD.t513 VSS 0.03543f ; **FLOATING
C9218 VDD.t64 VSS 0.03181f ; **FLOATING
C9219 VDD.t71 VSS 0.03182f ; **FLOATING
C9220 VDD.t1530 VSS 0.04668f ; **FLOATING
C9221 VDD.n1196 VSS 0.01969f ; **FLOATING
C9222 VDD.t521 VSS 0.03543f ; **FLOATING
C9223 VDD.n1197 VSS 0.06436f ; **FLOATING
C9224 VDD.n1198 VSS 0.01394f ; **FLOATING
C9225 VDD.t74 VSS 0.03181f ; **FLOATING
C9226 VDD.t1206 VSS 0.03543f ; **FLOATING
C9227 VDD.n1199 VSS 0.05382f ; **FLOATING
C9228 VDD.t1126 VSS 0.03543f ; **FLOATING
C9229 VDD.n1201 VSS 0.05437f ; **FLOATING
C9230 VDD.n1202 VSS 0.01374f ; **FLOATING
C9231 VDD.t507 VSS 0.03543f ; **FLOATING
C9232 VDD.n1203 VSS 0.05455f ; **FLOATING
C9233 VDD.n1204 VSS 0.0196f ; **FLOATING
C9234 VDD.t57 VSS 0.03182f ; **FLOATING
C9235 VDD.n1205 VSS 0.06654f ; **FLOATING
C9236 VDD.t1187 VSS 0.04651f ; **FLOATING
C9237 VDD.t62 VSS 0.03181f ; **FLOATING
C9238 VDD.t688 VSS 0.03543f ; **FLOATING
C9239 VDD.t55 VSS 0.03182f ; **FLOATING
C9240 VDD.t1102 VSS 0.03543f ; **FLOATING
C9241 VDD.t516 VSS 0.03543f ; **FLOATING
C9242 VDD.t324 VSS 0.03181f ; **FLOATING
C9243 VDD.t314 VSS 0.03182f ; **FLOATING
C9244 VDD.t317 VSS 0.03181f ; **FLOATING
C9245 VDD.t1210 VSS 0.03543f ; **FLOATING
C9246 VDD.t1076 VSS 0.03543f ; **FLOATING
C9247 VDD.t1127 VSS 0.03543f ; **FLOATING
C9248 VDD.t994 VSS 0.03543f ; **FLOATING
C9249 VDD.t474 VSS 0.04651f ; **FLOATING
C9250 VDD.t690 VSS 0.03543f ; **FLOATING
C9251 VDD.t1079 VSS 0.03543f ; **FLOATING
C9252 VDD.t1128 VSS 0.03543f ; **FLOATING
C9253 VDD.t511 VSS 0.03543f ; **FLOATING
C9254 VDD.t500 VSS 0.03762f ; **FLOATING
C9255 VDD.t1140 VSS 0.04651f ; **FLOATING
C9256 VDD.t1552 VSS 0.06643f ; **FLOATING
C9257 VDD.t1204 VSS 0.03543f ; **FLOATING
C9258 VDD.t1361 VSS 0.03543f ; **FLOATING
C9259 VDD.t957 VSS 0.03543f ; **FLOATING
C9260 VDD.t505 VSS 0.03543f ; **FLOATING
C9261 VDD.t3 VSS 0.03182f ; **FLOATING
C9262 VDD.t1365 VSS 0.04651f ; **FLOATING
C9263 VDD.t468 VSS 0.03543f ; **FLOATING
C9264 VDD.t336 VSS 0.03181f ; **FLOATING
C9265 VDD.t385 VSS 0.03543f ; **FLOATING
C9266 VDD.t304 VSS 0.03182f ; **FLOATING
C9267 VDD.t512 VSS 0.03543f ; **FLOATING
C9268 VDD.t321 VSS 0.03181f ; **FLOATING
C9269 VDD.t75 VSS 0.03182f ; **FLOATING
C9270 VDD.t421 VSS 0.04668f ; **FLOATING
C9271 VDD.n1206 VSS 0.01969f ; **FLOATING
C9272 VDD.t982 VSS 0.03543f ; **FLOATING
C9273 VDD.n1207 VSS 0.06436f ; **FLOATING
C9274 VDD.n1208 VSS 0.01394f ; **FLOATING
C9275 VDD.t78 VSS 0.03181f ; **FLOATING
C9276 VDD.t1207 VSS 0.03543f ; **FLOATING
C9277 VDD.n1209 VSS 0.05382f ; **FLOATING
C9278 VDD.t537 VSS 0.03543f ; **FLOATING
C9279 VDD.n1211 VSS 0.05437f ; **FLOATING
C9280 VDD.n1212 VSS 0.01374f ; **FLOATING
C9281 VDD.t514 VSS 0.03543f ; **FLOATING
C9282 VDD.n1213 VSS 0.05455f ; **FLOATING
C9283 VDD.n1214 VSS 0.0196f ; **FLOATING
C9284 VDD.t70 VSS 0.03182f ; **FLOATING
C9285 VDD.n1215 VSS 0.06654f ; **FLOATING
C9286 VDD.t1476 VSS 0.04651f ; **FLOATING
C9287 VDD.t2 VSS 0.03181f ; **FLOATING
C9288 VDD.t689 VSS 0.03543f ; **FLOATING
C9289 VDD.t16 VSS 0.03182f ; **FLOATING
C9290 VDD.t1412 VSS 0.03543f ; **FLOATING
C9291 VDD.t517 VSS 0.03543f ; **FLOATING
C9292 VDD.t1542 VSS 0.03181f ; **FLOATING
C9293 VDD.t331 VSS 0.03182f ; **FLOATING
C9294 VDD.t334 VSS 0.03181f ; **FLOATING
C9295 VDD.t1211 VSS 0.03543f ; **FLOATING
C9296 VDD.t1399 VSS 0.03543f ; **FLOATING
C9297 VDD.t538 VSS 0.03543f ; **FLOATING
C9298 VDD.t995 VSS 0.03543f ; **FLOATING
C9299 VDD.t67 VSS 0.03182f ; **FLOATING
C9300 VDD.t1157 VSS 0.04651f ; **FLOATING
C9301 VDD.t691 VSS 0.03543f ; **FLOATING
C9302 VDD.t26 VSS 0.03181f ; **FLOATING
C9303 VDD.t1601 VSS 0.03543f ; **FLOATING
C9304 VDD.t322 VSS 0.03182f ; **FLOATING
C9305 VDD.t1293 VSS 0.03543f ; **FLOATING
C9306 VDD.t19 VSS 0.03181f ; **FLOATING
C9307 VDD.t5 VSS 0.03182f ; **FLOATING
C9308 VDD.t1457 VSS 0.04668f ; **FLOATING
C9309 VDD.n1216 VSS 0.01969f ; **FLOATING
C9310 VDD.t1438 VSS 0.03543f ; **FLOATING
C9311 VDD.n1217 VSS 0.06436f ; **FLOATING
C9312 VDD.n1218 VSS 0.01394f ; **FLOATING
C9313 VDD.t8 VSS 0.03181f ; **FLOATING
C9314 VDD.t1295 VSS 0.03543f ; **FLOATING
C9315 VDD.n1219 VSS 0.05382f ; **FLOATING
C9316 VDD.t533 VSS 0.03543f ; **FLOATING
C9317 VDD.n1221 VSS 0.05437f ; **FLOATING
C9318 VDD.n1222 VSS 0.01374f ; **FLOATING
C9319 VDD.t1208 VSS 0.03543f ; **FLOATING
C9320 VDD.n1223 VSS 0.06447f ; **FLOATING
C9321 VDD.n1224 VSS 0.02609f ; **FLOATING
C9322 VDD.t747 VSS 0.04651f ; **FLOATING
C9323 VDD.n1225 VSS 0.09458f ; **FLOATING
C9324 VDD.t687 VSS 0.03885f ; **FLOATING
C9325 VDD.n1226 VSS 0.12607f ; **FLOATING
C9326 VDD.t6 VSS 0.03416f ; **FLOATING
C9327 VDD.t1620 VSS 0.11751f ; **FLOATING
C9328 VDD.t18 VSS 0.03416f ; **FLOATING
C9329 VDD.t1621 VSS 0.11751f ; **FLOATING
C9330 VDD.t25 VSS 0.03416f ; **FLOATING
C9331 VDD.t1622 VSS 0.11751f ; **FLOATING
C9332 VDD.n1227 VSS 0.06839f ; **FLOATING
C9333 VDD.n1228 VSS 0.07454f ; **FLOATING
C9334 VDD.n1229 VSS 0.01394f ; **FLOATING
C9335 VDD.n1230 VSS 0.05382f ; **FLOATING
C9336 VDD.n1232 VSS 0.06128f ; **FLOATING
C9337 VDD.t704 VSS 0.04668f ; **FLOATING
C9338 VDD.t332 VSS 0.03416f ; **FLOATING
C9339 VDD.t1623 VSS 0.11751f ; **FLOATING
C9340 VDD.t17 VSS 0.03416f ; **FLOATING
C9341 VDD.t1624 VSS 0.11751f ; **FLOATING
C9342 VDD.t1 VSS 0.03416f ; **FLOATING
C9343 VDD.t1625 VSS 0.11751f ; **FLOATING
C9344 VDD.t76 VSS 0.03416f ; **FLOATING
C9345 VDD.t1626 VSS 0.11751f ; **FLOATING
C9346 VDD.t305 VSS 0.03416f ; **FLOATING
C9347 VDD.t1627 VSS 0.11751f ; **FLOATING
C9348 VDD.t4 VSS 0.03416f ; **FLOATING
C9349 VDD.t1628 VSS 0.11751f ; **FLOATING
C9350 VDD.n1233 VSS 0.06654f ; **FLOATING
C9351 VDD.n1234 VSS 0.0196f ; **FLOATING
C9352 VDD.n1235 VSS 0.05455f ; **FLOATING
C9353 VDD.n1236 VSS 0.01374f ; **FLOATING
C9354 VDD.n1237 VSS 0.05437f ; **FLOATING
C9355 VDD.n1238 VSS 0.01969f ; **FLOATING
C9356 VDD.n1239 VSS 0.06436f ; **FLOATING
C9357 VDD.n1240 VSS 0.01394f ; **FLOATING
C9358 VDD.n1241 VSS 0.07893f ; **FLOATING
C9359 VDD.n1242 VSS 0.07423f ; **FLOATING
C9360 VDD.n1243 VSS 0.02926f ; **FLOATING
C9361 VDD.n1244 VSS 0.0892f ; **FLOATING
C9362 VDD.n1245 VSS 0.02609f ; **FLOATING
C9363 VDD.n1246 VSS 0.06447f ; **FLOATING
C9364 VDD.n1247 VSS 0.01374f ; **FLOATING
C9365 VDD.n1248 VSS 0.05437f ; **FLOATING
C9366 VDD.n1249 VSS 0.01969f ; **FLOATING
C9367 VDD.n1250 VSS 0.06436f ; **FLOATING
C9368 VDD.n1251 VSS 0.01394f ; **FLOATING
C9369 VDD.n1252 VSS 0.05382f ; **FLOATING
C9370 VDD.t672 VSS 0.04668f ; **FLOATING
C9371 VDD.t315 VSS 0.03416f ; **FLOATING
C9372 VDD.t1629 VSS 0.11751f ; **FLOATING
C9373 VDD.t56 VSS 0.03416f ; **FLOATING
C9374 VDD.t1630 VSS 0.11751f ; **FLOATING
C9375 VDD.t58 VSS 0.03416f ; **FLOATING
C9376 VDD.t1631 VSS 0.11751f ; **FLOATING
C9377 VDD.t72 VSS 0.03416f ; **FLOATING
C9378 VDD.t1632 VSS 0.11751f ; **FLOATING
C9379 VDD.t63 VSS 0.03416f ; **FLOATING
C9380 VDD.t1633 VSS 0.11751f ; **FLOATING
C9381 VDD.t28 VSS 0.03416f ; **FLOATING
C9382 VDD.t1634 VSS 0.11751f ; **FLOATING
C9383 VDD.n1254 VSS 0.06386f ; **FLOATING
C9384 VDD.n1255 VSS 0.01394f ; **FLOATING
C9385 VDD.n1256 VSS 0.05382f ; **FLOATING
C9386 VDD.n1258 VSS 0.06128f ; **FLOATING
C9387 VDD.t523 VSS 0.04668f ; **FLOATING
C9388 VDD.t326 VSS 0.03416f ; **FLOATING
C9389 VDD.t1635 VSS 0.11751f ; **FLOATING
C9390 VDD.n1259 VSS 0.05203f ; **FLOATING
C9391 VDD.n1260 VSS 0.05203f ; **FLOATING
C9392 VDD.n1261 VSS 0.05203f ; **FLOATING
C9393 VDD.n1262 VSS 0.05203f ; **FLOATING
C9394 VDD.n1263 VSS 0.05203f ; **FLOATING
C9395 VDD.n1264 VSS 0.05203f ; **FLOATING
C9396 VDD.n1265 VSS 0.05203f ; **FLOATING
C9397 VDD.n1266 VSS 0.05203f ; **FLOATING
C9398 VDD.n1267 VSS 0.05203f ; **FLOATING
C9399 VDD.n1268 VSS 0.05203f ; **FLOATING
C9400 VDD.n1269 VSS 0.05203f ; **FLOATING
C9401 VDD.n1270 VSS 0.05203f ; **FLOATING
C9402 VDD.n1271 VSS 0.05203f ; **FLOATING
C9403 VDD.n1272 VSS 0.04278f ; **FLOATING
C9404 VDD.n1273 VSS 0.05203f ; **FLOATING
C9405 VDD.n1274 VSS 0.05203f ; **FLOATING
C9406 VDD.n1275 VSS 0.05203f ; **FLOATING
C9407 VDD.n1276 VSS 0.05203f ; **FLOATING
C9408 VDD.n1277 VSS 0.05203f ; **FLOATING
C9409 VDD.n1278 VSS 0.05203f ; **FLOATING
C9410 VDD.n1279 VSS 0.05203f ; **FLOATING
C9411 VDD.n1280 VSS 0.05203f ; **FLOATING
C9412 VDD.n1281 VSS 0.05203f ; **FLOATING
C9413 VDD.n1282 VSS 0.01707f ; **FLOATING
C9414 VDD.n1283 VSS 0.08549f ; **FLOATING
C9415 VDD.n1284 VSS 0.03405f ; **FLOATING
C9416 VDD.n1285 VSS 0.05203f ; **FLOATING
C9417 VDD.n1286 VSS 0.05203f ; **FLOATING
C9418 VDD.n1287 VSS 0.05203f ; **FLOATING
C9419 VDD.n1288 VSS 0.05203f ; **FLOATING
C9420 VDD.n1289 VSS 0.02718f ; **FLOATING
C9421 VDD.t663 VSS 0.0718f ; **FLOATING
C9422 VDD.n1291 VSS 0.0783f ; **FLOATING
C9423 VDD.t666 VSS 0.03308f ; **FLOATING
C9424 VDD.n1292 VSS 0.01687f ; **FLOATING
C9425 VDD.t667 VSS 0.03423f ; **FLOATING
C9426 VDD.t662 VSS 0.03423f ; **FLOATING
C9427 VDD.n1293 VSS 0.09648f ; **FLOATING
C9428 VDD.t802 VSS 0.03423f ; **FLOATING
C9429 VDD.t575 VSS 0.04014f ; **FLOATING
C9430 VDD.n1294 VSS 0.11246f ; **FLOATING
C9431 VDD.t906 VSS 0.03423f ; **FLOATING
C9432 VDD.t980 VSS 0.04014f ; **FLOATING
C9433 VDD.n1295 VSS 0.11246f ; **FLOATING
C9434 VDD.t910 VSS 0.03423f ; **FLOATING
C9435 VDD.t540 VSS 0.04014f ; **FLOATING
C9436 VDD.n1296 VSS 0.11246f ; **FLOATING
C9437 VDD.t913 VSS 0.03423f ; **FLOATING
C9438 VDD.t486 VSS 0.04014f ; **FLOATING
C9439 VDD.n1297 VSS 0.11246f ; **FLOATING
C9440 VDD.t909 VSS 0.03423f ; **FLOATING
C9441 VDD.t1007 VSS 0.04014f ; **FLOATING
C9442 VDD.n1298 VSS 0.10769f ; **FLOATING
C9443 VDD.t914 VSS 0.03423f ; **FLOATING
C9444 VDD.t460 VSS 0.04014f ; **FLOATING
C9445 VDD.t792 VSS 0.03423f ; **FLOATING
C9446 VDD.t1273 VSS 0.04014f ; **FLOATING
C9447 VDD.n1299 VSS 0.11657f ; **FLOATING
C9448 VDD.t915 VSS 0.03423f ; **FLOATING
C9449 VDD.t1347 VSS 0.04014f ; **FLOATING
C9450 VDD.n1300 VSS 0.11246f ; **FLOATING
C9451 VDD.t774 VSS 0.03423f ; **FLOATING
C9452 VDD.t1346 VSS 0.04014f ; **FLOATING
C9453 VDD.n1301 VSS 0.11246f ; **FLOATING
C9454 VDD.t917 VSS 0.03423f ; **FLOATING
C9455 VDD.t520 VSS 0.04014f ; **FLOATING
C9456 VDD.n1302 VSS 0.11246f ; **FLOATING
C9457 VDD.t919 VSS 0.03423f ; **FLOATING
C9458 VDD.n1303 VSS 0.02538f ; **FLOATING
C9459 VDD.t1186 VSS 0.04014f ; **FLOATING
C9460 VDD.n1304 VSS 0.11246f ; **FLOATING
C9461 VDD.t916 VSS 0.03423f ; **FLOATING
C9462 VDD.t1103 VSS 0.04014f ; **FLOATING
C9463 VDD.n1305 VSS 0.11246f ; **FLOATING
C9464 VDD.t918 VSS 0.03423f ; **FLOATING
C9465 VDD.n1306 VSS 0.02538f ; **FLOATING
C9466 VDD.t1078 VSS 0.04014f ; **FLOATING
C9467 VDD.n1307 VSS 0.11246f ; **FLOATING
C9468 VDD.t920 VSS 0.03423f ; **FLOATING
C9469 VDD.t1008 VSS 0.04014f ; **FLOATING
C9470 VDD.n1308 VSS 0.11246f ; **FLOATING
C9471 VDD.t769 VSS 0.03423f ; **FLOATING
C9472 VDD.t981 VSS 0.04014f ; **FLOATING
C9473 VDD.n1309 VSS 0.11631f ; **FLOATING
C9474 VDD.t921 VSS 0.03423f ; **FLOATING
C9475 VDD.t947 VSS 0.04014f ; **FLOATING
C9476 VDD.t912 VSS 0.03423f ; **FLOATING
C9477 VDD.t946 VSS 0.04014f ; **FLOATING
C9478 VDD.n1310 VSS 0.10768f ; **FLOATING
C9479 VDD.t788 VSS 0.03423f ; **FLOATING
C9480 VDD.n1311 VSS 0.02538f ; **FLOATING
C9481 VDD.t463 VSS 0.04014f ; **FLOATING
C9482 VDD.n1312 VSS 0.11246f ; **FLOATING
C9483 VDD.t908 VSS 0.03423f ; **FLOATING
C9484 VDD.t1081 VSS 0.04014f ; **FLOATING
C9485 VDD.n1313 VSS 0.11246f ; **FLOATING
C9486 VDD.t907 VSS 0.03423f ; **FLOATING
C9487 VDD.n1314 VSS 0.02538f ; **FLOATING
C9488 VDD.n1315 VSS 0.08118f ; **FLOATING
C9489 VDD.t386 VSS 0.04014f ; **FLOATING
C9490 VDD.n1316 VSS 0.08362f ; **FLOATING
C9491 VDD.n1317 VSS 0.11246f ; **FLOATING
C9492 VDD.t911 VSS 0.03423f ; **FLOATING
C9493 VDD.n1318 VSS 0.02538f ; **FLOATING
C9494 VDD.n1319 VSS 0.06361f ; **FLOATING
C9495 VDD.t1300 VSS 0.04014f ; **FLOATING
C9496 VDD.n1320 VSS 0.08364f ; **FLOATING
C9497 VDD.n1321 VSS 0.11246f ; **FLOATING
C9498 VDD.t784 VSS 0.03423f ; **FLOATING
C9499 VDD.n1322 VSS 0.02538f ; **FLOATING
C9500 VDD.n1323 VSS 0.06367f ; **FLOATING
C9501 VDD.t983 VSS 0.04014f ; **FLOATING
C9502 VDD.n1324 VSS 0.08362f ; **FLOATING
C9503 VDD.n1325 VSS 0.11246f ; **FLOATING
C9504 VDD.t795 VSS 0.03423f ; **FLOATING
C9505 VDD.n1326 VSS 0.02538f ; **FLOATING
C9506 VDD.n1327 VSS 0.06361f ; **FLOATING
C9507 VDD.t522 VSS 0.04014f ; **FLOATING
C9508 VDD.n1328 VSS 0.11246f ; **FLOATING
C9509 VDD.t922 VSS 0.03423f ; **FLOATING
C9510 VDD.t1408 VSS 0.04014f ; **FLOATING
C9511 VDD.n1329 VSS 0.09445f ; **FLOATING
C9512 VDD.n1330 VSS 0.11246f ; **FLOATING
C9513 VDD.t796 VSS 0.03423f ; **FLOATING
C9514 VDD.n1331 VSS 0.02538f ; **FLOATING
C9515 VDD.t1405 VSS 0.04014f ; **FLOATING
C9516 VDD.n1332 VSS 0.11246f ; **FLOATING
C9517 VDD.t925 VSS 0.03423f ; **FLOATING
C9518 VDD.n1333 VSS 0.02538f ; **FLOATING
C9519 VDD.t1400 VSS 0.04014f ; **FLOATING
C9520 VDD.n1334 VSS 0.0831f ; **FLOATING
C9521 VDD.t924 VSS 0.03423f ; **FLOATING
C9522 VDD.t1423 VSS 0.04014f ; **FLOATING
C9523 VDD.n1335 VSS 0.09301f ; **FLOATING
C9524 VDD.t923 VSS 0.03423f ; **FLOATING
C9525 VDD.t1427 VSS 0.04014f ; **FLOATING
C9526 VDD.n1336 VSS 0.11246f ; **FLOATING
C9527 VDD.t791 VSS 0.03423f ; **FLOATING
C9528 VDD.t1456 VSS 0.04014f ; **FLOATING
C9529 VDD.n1337 VSS 0.11246f ; **FLOATING
C9530 VDD.t926 VSS 0.03423f ; **FLOATING
C9531 VDD.t1437 VSS 0.04014f ; **FLOATING
C9532 VDD.n1338 VSS 0.11246f ; **FLOATING
C9533 VDD.t927 VSS 0.03423f ; **FLOATING
C9534 VDD.n1339 VSS 0.02538f ; **FLOATING
C9535 VDD.n1340 VSS 0.0636f ; **FLOATING
C9536 VDD.t1441 VSS 0.04014f ; **FLOATING
C9537 VDD.n1341 VSS 0.09307f ; **FLOATING
C9538 VDD.t928 VSS 0.03423f ; **FLOATING
C9539 VDD.t530 VSS 0.04014f ; **FLOATING
C9540 VDD.n1342 VSS 0.04888f ; **FLOATING
C9541 VDD.t665 VSS 0.03423f ; **FLOATING
C9542 VDD.n1343 VSS 0.0341f ; **FLOATING
C9543 VDD.t664 VSS 0.03825f ; **FLOATING
C9544 VDD.n1344 VSS 0.09443f ; **FLOATING
C9545 VDD.n1345 VSS 0.09444f ; **FLOATING
C9546 VDD.n1346 VSS 0.0836f ; **FLOATING
C9547 VDD.n1347 VSS 0.01488f ; **FLOATING
C9548 VDD.n1348 VSS 0.06363f ; **FLOATING
C9549 VDD.n1349 VSS 0.08358f ; **FLOATING
C9550 VDD.n1350 VSS 0.01488f ; **FLOATING
C9551 VDD.n1351 VSS 0.06364f ; **FLOATING
C9552 VDD.n1352 VSS 0.0836f ; **FLOATING
C9553 VDD.n1353 VSS 0.08359f ; **FLOATING
C9554 VDD.n1354 VSS 0.01488f ; **FLOATING
C9555 VDD.n1355 VSS 0.06361f ; **FLOATING
C9556 VDD.n1356 VSS 0.08458f ; **FLOATING
C9557 VDD.n1357 VSS 0.09444f ; **FLOATING
C9558 VDD.n1358 VSS 0.09442f ; **FLOATING
C9559 VDD.n1359 VSS 0.0836f ; **FLOATING
C9560 VDD.n1360 VSS 0.01488f ; **FLOATING
C9561 VDD.n1361 VSS 0.08358f ; **FLOATING
C9562 VDD.n1362 VSS 0.01488f ; **FLOATING
C9563 VDD.n1363 VSS 0.07251f ; **FLOATING
C9564 VDD.n1364 VSS 0.09519f ; **FLOATING
C9565 VDD.n1365 VSS 0.09518f ; **FLOATING
C9566 VDD.n1366 VSS 0.09443f ; **FLOATING
C9567 VDD.n1367 VSS 0.09554f ; **FLOATING
C9568 VDD.t660 VSS 0.02015f ; **FLOATING
C9569 VDD.t658 VSS 0.0387f ; **FLOATING
C9570 VDD.t659 VSS 0.03454f ; **FLOATING
C9571 VDD.t657 VSS 0.02471f ; **FLOATING
C9572 VDD.t960 VSS 0.03543f ; **FLOATING
C9573 VDD.t1136 VSS 0.03543f ; **FLOATING
C9574 VDD.t82 VSS 0.03182f ; **FLOATING
C9575 VDD.n1368 VSS 0.05995f ; **FLOATING
C9576 VDD.n1369 VSS 0.0196f ; **FLOATING
C9577 VDD.t1213 VSS 0.03543f ; **FLOATING
C9578 VDD.n1370 VSS 0.05455f ; **FLOATING
C9579 VDD.n1371 VSS 0.01374f ; **FLOATING
C9580 VDD.n1372 VSS 0.02926f ; **FLOATING
C9581 VDD.t1147 VSS 0.04651f ; **FLOATING
C9582 VDD.n1373 VSS 0.0892f ; **FLOATING
C9583 VDD.n1374 VSS 0.02609f ; **FLOATING
C9584 VDD.t1121 VSS 0.03543f ; **FLOATING
C9585 VDD.n1375 VSS 0.09607f ; **FLOATING
C9586 VDD.n1376 VSS 0.01242f ; **FLOATING
C9587 VDD.n1377 VSS 0.01294f ; **FLOATING
C9588 VDD.t1053 VSS 0.03949f ; **FLOATING
C9589 VDD.t976 VSS 0.03949f ; **FLOATING
C9590 VDD.n1378 VSS 0.08483f ; **FLOATING
C9591 VDD.n1379 VSS 0.01245f ; **FLOATING
C9592 VDD.n1380 VSS 0.01311f ; **FLOATING
C9593 VDD.t1284 VSS 0.03949f ; **FLOATING
C9594 VDD.t941 VSS 0.03949f ; **FLOATING
C9595 VDD.n1381 VSS 0.08886f ; **FLOATING
C9596 VDD.t400 VSS 0.03543f ; **FLOATING
C9597 VDD.t1149 VSS 0.03543f ; **FLOATING
C9598 VDD.t1371 VSS 0.02617f ; **FLOATING
C9599 VDD.t695 VSS 0.02617f ; **FLOATING
C9600 VDD.t1283 VSS 0.03498f ; **FLOATING
C9601 VDD.t940 VSS 0.03498f ; **FLOATING
C9602 VDD.t959 VSS 0.02617f ; **FLOATING
C9603 VDD.t1137 VSS 0.02617f ; **FLOATING
C9604 VDD.n1382 VSS 0.07007f ; **FLOATING
C9605 VDD.t1052 VSS 0.03498f ; **FLOATING
C9606 VDD.t975 VSS 0.03498f ; **FLOATING
C9607 VDD.n1383 VSS 0.07502f ; **FLOATING
C9608 VDD.n1384 VSS 0.01264f ; **FLOATING
C9609 VDD.t399 VSS 0.02617f ; **FLOATING
C9610 VDD.t1148 VSS 0.02617f ; **FLOATING
C9611 VDD.n1385 VSS 0.06983f ; **FLOATING
C9612 VDD.n1386 VSS 0.01218f ; **FLOATING
C9613 VDD.t1318 VSS 0.03498f ; **FLOATING
C9614 VDD.t379 VSS 0.03498f ; **FLOATING
C9615 VDD.n1387 VSS 0.07079f ; **FLOATING
C9616 VDD.n1388 VSS 0.01729f ; **FLOATING
C9617 VDD.t1319 VSS 0.03949f ; **FLOATING
C9618 VDD.t380 VSS 0.03949f ; **FLOATING
C9619 VDD.n1389 VSS 0.07913f ; **FLOATING
C9620 VDD.t961 VSS 0.02617f ; **FLOATING
C9621 VDD.t1138 VSS 0.02617f ; **FLOATING
C9622 VDD.n1390 VSS 0.07047f ; **FLOATING
C9623 VDD.n1391 VSS 0.01289f ; **FLOATING
C9624 VDD.t401 VSS 0.03498f ; **FLOATING
C9625 VDD.t1150 VSS 0.03498f ; **FLOATING
C9626 VDD.t1418 VSS 0.03949f ; **FLOATING
C9627 VDD.t1614 VSS 0.03949f ; **FLOATING
C9628 VDD.t1398 VSS 0.03543f ; **FLOATING
C9629 VDD.t1110 VSS 0.03555f ; **FLOATING
C9630 VDD.t1125 VSS 0.03543f ; **FLOATING
C9631 VDD.n1392 VSS 0.07423f ; **FLOATING
C9632 VDD.n1393 VSS 0.01394f ; **FLOATING
C9633 VDD.t1477 VSS 0.03543f ; **FLOATING
C9634 VDD.n1394 VSS 0.06436f ; **FLOATING
C9635 VDD.t683 VSS 0.03543f ; **FLOATING
C9636 VDD.n1395 VSS 0.05437f ; **FLOATING
C9637 VDD.n1396 VSS 0.01969f ; **FLOATING
C9638 VDD.t368 VSS 0.03543f ; **FLOATING
C9639 VDD.t84 VSS 0.03181f ; **FLOATING
C9640 VDD.t85 VSS 0.03182f ; **FLOATING
C9641 VDD.t535 VSS 0.03543f ; **FLOATING
C9642 VDD.t83 VSS 0.03416f ; **FLOATING
C9643 VDD.t1655 VSS 0.11751f ; **FLOATING
C9644 VDD.t1336 VSS 0.04651f ; **FLOATING
C9645 VDD.t86 VSS 0.03416f ; **FLOATING
C9646 VDD.t1654 VSS 0.11751f ; **FLOATING
C9647 VDD.t1306 VSS 0.03543f ; **FLOATING
C9648 VDD.t88 VSS 0.03181f ; **FLOATING
C9649 VDD.t89 VSS 0.03182f ; **FLOATING
C9650 VDD.t92 VSS 0.03181f ; **FLOATING
C9651 VDD.t1093 VSS 0.03543f ; **FLOATING
C9652 VDD.t1109 VSS 0.03543f ; **FLOATING
C9653 VDD.t971 VSS 0.03543f ; **FLOATING
C9654 VDD.t1181 VSS 0.03543f ; **FLOATING
C9655 VDD.t201 VSS 0.03182f ; **FLOATING
C9656 VDD.t1308 VSS 0.04651f ; **FLOATING
C9657 VDD.t1305 VSS 0.03543f ; **FLOATING
C9658 VDD.t173 VSS 0.03181f ; **FLOATING
C9659 VDD.t1156 VSS 0.03543f ; **FLOATING
C9660 VDD.t174 VSS 0.03182f ; **FLOATING
C9661 VDD.t1124 VSS 0.03543f ; **FLOATING
C9662 VDD.t177 VSS 0.03181f ; **FLOATING
C9663 VDD.t178 VSS 0.03182f ; **FLOATING
C9664 VDD.t1393 VSS 0.04668f ; **FLOATING
C9665 VDD.n1397 VSS 0.01969f ; **FLOATING
C9666 VDD.t702 VSS 0.03543f ; **FLOATING
C9667 VDD.n1398 VSS 0.06436f ; **FLOATING
C9668 VDD.n1399 VSS 0.01394f ; **FLOATING
C9669 VDD.t181 VSS 0.03181f ; **FLOATING
C9670 VDD.t1094 VSS 0.03543f ; **FLOATING
C9671 VDD.n1400 VSS 0.05382f ; **FLOATING
C9672 VDD.t767 VSS 0.03543f ; **FLOATING
C9673 VDD.n1402 VSS 0.05437f ; **FLOATING
C9674 VDD.n1403 VSS 0.01374f ; **FLOATING
C9675 VDD.t1182 VSS 0.03543f ; **FLOATING
C9676 VDD.n1404 VSS 0.05455f ; **FLOATING
C9677 VDD.n1405 VSS 0.0196f ; **FLOATING
C9678 VDD.t292 VSS 0.03182f ; **FLOATING
C9679 VDD.n1406 VSS 0.05995f ; **FLOATING
C9680 VDD.t1161 VSS 0.04651f ; **FLOATING
C9681 VDD.t295 VSS 0.03181f ; **FLOATING
C9682 VDD.t370 VSS 0.03543f ; **FLOATING
C9683 VDD.t296 VSS 0.03182f ; **FLOATING
C9684 VDD.t1238 VSS 0.03543f ; **FLOATING
C9685 VDD.t1373 VSS 0.03543f ; **FLOATING
C9686 VDD.t299 VSS 0.03181f ; **FLOATING
C9687 VDD.t300 VSS 0.03182f ; **FLOATING
C9688 VDD.t303 VSS 0.03181f ; **FLOATING
C9689 VDD.t1215 VSS 0.03543f ; **FLOATING
C9690 VDD.t952 VSS 0.03543f ; **FLOATING
C9691 VDD.t677 VSS 0.03543f ; **FLOATING
C9692 VDD.t1184 VSS 0.03543f ; **FLOATING
C9693 VDD.t1343 VSS 0.04651f ; **FLOATING
C9694 VDD.t372 VSS 0.03543f ; **FLOATING
C9695 VDD.t1467 VSS 0.03543f ; **FLOATING
C9696 VDD.t675 VSS 0.03543f ; **FLOATING
C9697 VDD.t1122 VSS 0.03543f ; **FLOATING
C9698 VDD.t567 VSS 0.03762f ; **FLOATING
C9699 VDD.t561 VSS 0.04651f ; **FLOATING
C9700 VDD.t1059 VSS 0.06643f ; **FLOATING
C9701 VDD.t1092 VSS 0.03543f ; **FLOATING
C9702 VDD.t1546 VSS 0.03543f ; **FLOATING
C9703 VDD.t384 VSS 0.03543f ; **FLOATING
C9704 VDD.t1171 VSS 0.03543f ; **FLOATING
C9705 VDD.t123 VSS 0.03182f ; **FLOATING
C9706 VDD.t1309 VSS 0.04651f ; **FLOATING
C9707 VDD.t1375 VSS 0.03543f ; **FLOATING
C9708 VDD.t126 VSS 0.03181f ; **FLOATING
C9709 VDD.t493 VSS 0.03543f ; **FLOATING
C9710 VDD.t127 VSS 0.03182f ; **FLOATING
C9711 VDD.t1123 VSS 0.03543f ; **FLOATING
C9712 VDD.t130 VSS 0.03181f ; **FLOATING
C9713 VDD.t131 VSS 0.03182f ; **FLOATING
C9714 VDD.t1257 VSS 0.04668f ; **FLOATING
C9715 VDD.n1408 VSS 0.01969f ; **FLOATING
C9716 VDD.t1118 VSS 0.03543f ; **FLOATING
C9717 VDD.n1409 VSS 0.06436f ; **FLOATING
C9718 VDD.n1410 VSS 0.01394f ; **FLOATING
C9719 VDD.t134 VSS 0.03181f ; **FLOATING
C9720 VDD.t1095 VSS 0.03543f ; **FLOATING
C9721 VDD.n1411 VSS 0.05382f ; **FLOATING
C9722 VDD.t972 VSS 0.03543f ; **FLOATING
C9723 VDD.n1413 VSS 0.05437f ; **FLOATING
C9724 VDD.n1414 VSS 0.01374f ; **FLOATING
C9725 VDD.t1183 VSS 0.03543f ; **FLOATING
C9726 VDD.n1415 VSS 0.05455f ; **FLOATING
C9727 VDD.n1416 VSS 0.0196f ; **FLOATING
C9728 VDD.t330 VSS 0.03182f ; **FLOATING
C9729 VDD.n1417 VSS 0.06654f ; **FLOATING
C9730 VDD.t363 VSS 0.04651f ; **FLOATING
C9731 VDD.t262 VSS 0.03181f ; **FLOATING
C9732 VDD.t371 VSS 0.03543f ; **FLOATING
C9733 VDD.t263 VSS 0.03182f ; **FLOATING
C9734 VDD.t496 VSS 0.03543f ; **FLOATING
C9735 VDD.t1374 VSS 0.03543f ; **FLOATING
C9736 VDD.t266 VSS 0.03181f ; **FLOATING
C9737 VDD.t267 VSS 0.03182f ; **FLOATING
C9738 VDD.t270 VSS 0.03181f ; **FLOATING
C9739 VDD.t1216 VSS 0.03543f ; **FLOATING
C9740 VDD.t1084 VSS 0.03543f ; **FLOATING
C9741 VDD.t973 VSS 0.03543f ; **FLOATING
C9742 VDD.t1185 VSS 0.03543f ; **FLOATING
C9743 VDD.t10 VSS 0.03182f ; **FLOATING
C9744 VDD.t936 VSS 0.04651f ; **FLOATING
C9745 VDD.t373 VSS 0.03543f ; **FLOATING
C9746 VDD.t13 VSS 0.03181f ; **FLOATING
C9747 VDD.t932 VSS 0.03543f ; **FLOATING
C9748 VDD.t14 VSS 0.03182f ; **FLOATING
C9749 VDD.t1307 VSS 0.03543f ; **FLOATING
C9750 VDD.t273 VSS 0.03181f ; **FLOATING
C9751 VDD.t274 VSS 0.03182f ; **FLOATING
C9752 VDD.t1049 VSS 0.04668f ; **FLOATING
C9753 VDD.n1418 VSS 0.01969f ; **FLOATING
C9754 VDD.t1503 VSS 0.03543f ; **FLOATING
C9755 VDD.n1419 VSS 0.06436f ; **FLOATING
C9756 VDD.n1420 VSS 0.01394f ; **FLOATING
C9757 VDD.t277 VSS 0.03181f ; **FLOATING
C9758 VDD.t1304 VSS 0.03543f ; **FLOATING
C9759 VDD.n1421 VSS 0.05382f ; **FLOATING
C9760 VDD.t965 VSS 0.03543f ; **FLOATING
C9761 VDD.n1423 VSS 0.05437f ; **FLOATING
C9762 VDD.n1424 VSS 0.01374f ; **FLOATING
C9763 VDD.t1214 VSS 0.03543f ; **FLOATING
C9764 VDD.n1425 VSS 0.06447f ; **FLOATING
C9765 VDD.n1426 VSS 0.02609f ; **FLOATING
C9766 VDD.t1221 VSS 0.04651f ; **FLOATING
C9767 VDD.n1427 VSS 0.09458f ; **FLOATING
C9768 VDD.t369 VSS 0.03885f ; **FLOATING
C9769 VDD.n1428 VSS 0.12607f ; **FLOATING
C9770 VDD.t275 VSS 0.03416f ; **FLOATING
C9771 VDD.t1638 VSS 0.11751f ; **FLOATING
C9772 VDD.t15 VSS 0.03416f ; **FLOATING
C9773 VDD.t1639 VSS 0.11751f ; **FLOATING
C9774 VDD.t11 VSS 0.03416f ; **FLOATING
C9775 VDD.t1640 VSS 0.11751f ; **FLOATING
C9776 VDD.n1429 VSS 0.06839f ; **FLOATING
C9777 VDD.n1430 VSS 0.07454f ; **FLOATING
C9778 VDD.n1431 VSS 0.01394f ; **FLOATING
C9779 VDD.n1432 VSS 0.05382f ; **FLOATING
C9780 VDD.t1045 VSS 0.04668f ; **FLOATING
C9781 VDD.t268 VSS 0.03416f ; **FLOATING
C9782 VDD.t1641 VSS 0.11751f ; **FLOATING
C9783 VDD.t264 VSS 0.03416f ; **FLOATING
C9784 VDD.t1642 VSS 0.11751f ; **FLOATING
C9785 VDD.t261 VSS 0.03416f ; **FLOATING
C9786 VDD.t1643 VSS 0.11751f ; **FLOATING
C9787 VDD.t132 VSS 0.03416f ; **FLOATING
C9788 VDD.t1644 VSS 0.11751f ; **FLOATING
C9789 VDD.t128 VSS 0.03416f ; **FLOATING
C9790 VDD.t1645 VSS 0.11751f ; **FLOATING
C9791 VDD.t124 VSS 0.03416f ; **FLOATING
C9792 VDD.t1646 VSS 0.11751f ; **FLOATING
C9793 VDD.n1434 VSS 0.06654f ; **FLOATING
C9794 VDD.n1435 VSS 0.0196f ; **FLOATING
C9795 VDD.n1436 VSS 0.05455f ; **FLOATING
C9796 VDD.n1437 VSS 0.01374f ; **FLOATING
C9797 VDD.n1438 VSS 0.05437f ; **FLOATING
C9798 VDD.n1439 VSS 0.01969f ; **FLOATING
C9799 VDD.n1440 VSS 0.06436f ; **FLOATING
C9800 VDD.n1441 VSS 0.01394f ; **FLOATING
C9801 VDD.n1442 VSS 0.07893f ; **FLOATING
C9802 VDD.n1443 VSS 0.07423f ; **FLOATING
C9803 VDD.n1444 VSS 0.02926f ; **FLOATING
C9804 VDD.n1445 VSS 0.0892f ; **FLOATING
C9805 VDD.n1446 VSS 0.02609f ; **FLOATING
C9806 VDD.n1447 VSS 0.06447f ; **FLOATING
C9807 VDD.n1448 VSS 0.01374f ; **FLOATING
C9808 VDD.n1449 VSS 0.05437f ; **FLOATING
C9809 VDD.n1450 VSS 0.01969f ; **FLOATING
C9810 VDD.n1451 VSS 0.06436f ; **FLOATING
C9811 VDD.n1452 VSS 0.01394f ; **FLOATING
C9812 VDD.n1453 VSS 0.05847f ; **FLOATING
C9813 VDD.t1253 VSS 0.04668f ; **FLOATING
C9814 VDD.t301 VSS 0.03416f ; **FLOATING
C9815 VDD.t1647 VSS 0.11751f ; **FLOATING
C9816 VDD.t297 VSS 0.03416f ; **FLOATING
C9817 VDD.t1648 VSS 0.11751f ; **FLOATING
C9818 VDD.t293 VSS 0.03416f ; **FLOATING
C9819 VDD.t1649 VSS 0.11751f ; **FLOATING
C9820 VDD.t179 VSS 0.03416f ; **FLOATING
C9821 VDD.t1650 VSS 0.11751f ; **FLOATING
C9822 VDD.t175 VSS 0.03416f ; **FLOATING
C9823 VDD.t1651 VSS 0.11751f ; **FLOATING
C9824 VDD.t172 VSS 0.03416f ; **FLOATING
C9825 VDD.t1652 VSS 0.11751f ; **FLOATING
C9826 VDD.n1454 VSS 0.06386f ; **FLOATING
C9827 VDD.n1455 VSS 0.01394f ; **FLOATING
C9828 VDD.n1456 VSS 0.05382f ; **FLOATING
C9829 VDD.t1384 VSS 0.04668f ; **FLOATING
C9830 VDD.t90 VSS 0.03416f ; **FLOATING
C9831 VDD.t1653 VSS 0.11751f ; **FLOATING
C9832 VDD.t651 VSS 0.03423f ; **FLOATING
C9833 VDD.t648 VSS 0.03423f ; **FLOATING
C9834 VDD.t646 VSS 0.02471f ; **FLOATING
C9835 VDD.n1458 VSS 0.01701f ; **FLOATING
C9836 VDD.t852 VSS 0.03423f ; **FLOATING
C9837 VDD.t850 VSS 0.03423f ; **FLOATING
C9838 VDD.t851 VSS 0.03423f ; **FLOATING
C9839 VDD.t849 VSS 0.03423f ; **FLOATING
C9840 VDD.n1459 VSS 0.02538f ; **FLOATING
C9841 VDD.t891 VSS 0.03423f ; **FLOATING
C9842 VDD.n1460 VSS 0.02538f ; **FLOATING
C9843 VDD.t848 VSS 0.03423f ; **FLOATING
C9844 VDD.t771 VSS 0.03423f ; **FLOATING
C9845 VDD.t894 VSS 0.03423f ; **FLOATING
C9846 VDD.t893 VSS 0.03423f ; **FLOATING
C9847 VDD.t892 VSS 0.03423f ; **FLOATING
C9848 VDD.t798 VSS 0.03423f ; **FLOATING
C9849 VDD.t778 VSS 0.03423f ; **FLOATING
C9850 VDD.t777 VSS 0.03423f ; **FLOATING
C9851 VDD.n1461 VSS 0.02538f ; **FLOATING
C9852 VDD.t895 VSS 0.03423f ; **FLOATING
C9853 VDD.t896 VSS 0.03423f ; **FLOATING
C9854 VDD.n1462 VSS 0.02538f ; **FLOATING
C9855 VDD.t897 VSS 0.03423f ; **FLOATING
C9856 VDD.n1463 VSS 0.02538f ; **FLOATING
C9857 VDD.t790 VSS 0.03423f ; **FLOATING
C9858 VDD.t780 VSS 0.03423f ; **FLOATING
C9859 VDD.t804 VSS 0.03423f ; **FLOATING
C9860 VDD.n1464 VSS 0.02538f ; **FLOATING
C9861 VDD.t772 VSS 0.03423f ; **FLOATING
C9862 VDD.t799 VSS 0.03423f ; **FLOATING
C9863 VDD.t779 VSS 0.03423f ; **FLOATING
C9864 VDD.t781 VSS 0.03423f ; **FLOATING
C9865 VDD.n1465 VSS 0.02538f ; **FLOATING
C9866 VDD.t899 VSS 0.03423f ; **FLOATING
C9867 VDD.t900 VSS 0.03423f ; **FLOATING
C9868 VDD.t898 VSS 0.03423f ; **FLOATING
C9869 VDD.n1466 VSS 0.02538f ; **FLOATING
C9870 VDD.t789 VSS 0.03423f ; **FLOATING
C9871 VDD.n1467 VSS 0.02538f ; **FLOATING
C9872 VDD.t901 VSS 0.03423f ; **FLOATING
C9873 VDD.t904 VSS 0.03423f ; **FLOATING
C9874 VDD.n1468 VSS 0.02538f ; **FLOATING
C9875 VDD.t902 VSS 0.03423f ; **FLOATING
C9876 VDD.t903 VSS 0.03423f ; **FLOATING
C9877 VDD.n1469 VSS 0.02538f ; **FLOATING
C9878 VDD.t905 VSS 0.03423f ; **FLOATING
C9879 VDD.t654 VSS 0.03423f ; **FLOATING
C9880 VDD.t652 VSS 0.0718f ; **FLOATING
C9881 VDD.t653 VSS 0.03825f ; **FLOATING
C9882 VDD.t655 VSS 0.03308f ; **FLOATING
C9883 VDD.n1470 VSS 0.01687f ; **FLOATING
C9884 VDD.t656 VSS 0.03423f ; **FLOATING
C9885 VDD.t937 VSS 0.04014f ; **FLOATING
C9886 VDD.t1222 VSS 0.04014f ; **FLOATING
C9887 VDD.t1470 VSS 0.04014f ; **FLOATING
C9888 VDD.t999 VSS 0.04014f ; **FLOATING
C9889 VDD.n1471 VSS 0.07759f ; **FLOATING
C9890 VDD.t458 VSS 0.04014f ; **FLOATING
C9891 VDD.t935 VSS 0.04014f ; **FLOATING
C9892 VDD.t968 VSS 0.04014f ; **FLOATING
C9893 VDD.n1472 VSS 0.08229f ; **FLOATING
C9894 VDD.t998 VSS 0.04014f ; **FLOATING
C9895 VDD.t495 VSS 0.04014f ; **FLOATING
C9896 VDD.t364 VSS 0.04014f ; **FLOATING
C9897 VDD.t1116 VSS 0.04014f ; **FLOATING
C9898 VDD.t1115 VSS 0.04014f ; **FLOATING
C9899 VDD.t492 VSS 0.04014f ; **FLOATING
C9900 VDD.t1114 VSS 0.04014f ; **FLOATING
C9901 VDD.n1473 VSS 0.08279f ; **FLOATING
C9902 VDD.t1241 VSS 0.04014f ; **FLOATING
C9903 VDD.t560 VSS 0.04014f ; **FLOATING
C9904 VDD.t1033 VSS 0.04014f ; **FLOATING
C9905 VDD.n1474 VSS 0.06361f ; **FLOATING
C9906 VDD.t424 VSS 0.04014f ; **FLOATING
C9907 VDD.t362 VSS 0.04014f ; **FLOATING
C9908 VDD.t1252 VSS 0.04014f ; **FLOATING
C9909 VDD.n1475 VSS 0.07251f ; **FLOATING
C9910 VDD.t346 VSS 0.04014f ; **FLOATING
C9911 VDD.t564 VSS 0.04014f ; **FLOATING
C9912 VDD.t487 VSS 0.04014f ; **FLOATING
C9913 VDD.t345 VSS 0.04014f ; **FLOATING
C9914 VDD.t956 VSS 0.04014f ; **FLOATING
C9915 VDD.t1485 VSS 0.04014f ; **FLOATING
C9916 VDD.t1108 VSS 0.04014f ; **FLOATING
C9917 VDD.t402 VSS 0.04014f ; **FLOATING
C9918 VDD.t454 VSS 0.04014f ; **FLOATING
C9919 VDD.n1476 VSS 0.08358f ; **FLOATING
C9920 VDD.n1477 VSS 0.07255f ; **FLOATING
C9921 VDD.t964 VSS 0.04014f ; **FLOATING
C9922 VDD.t1478 VSS 0.04014f ; **FLOATING
C9923 VDD.t1146 VSS 0.04014f ; **FLOATING
C9924 VDD.n1478 VSS 0.094f ; **FLOATING
C9925 VDD.n1479 VSS 0.0636f ; **FLOATING
C9926 VDD.n1480 VSS 0.01488f ; **FLOATING
C9927 VDD.n1481 VSS 0.08457f ; **FLOATING
C9928 VDD.n1482 VSS 0.08359f ; **FLOATING
C9929 VDD.n1483 VSS 0.09443f ; **FLOATING
C9930 VDD.n1484 VSS 0.06363f ; **FLOATING
C9931 VDD.n1485 VSS 0.01488f ; **FLOATING
C9932 VDD.n1486 VSS 0.08359f ; **FLOATING
C9933 VDD.n1487 VSS 0.07257f ; **FLOATING
C9934 VDD.n1488 VSS 0.01488f ; **FLOATING
C9935 VDD.n1489 VSS 0.08358f ; **FLOATING
C9936 VDD.n1490 VSS 0.08358f ; **FLOATING
C9937 VDD.n1491 VSS 0.06358f ; **FLOATING
C9938 VDD.n1492 VSS 0.01488f ; **FLOATING
C9939 VDD.n1493 VSS 0.08116f ; **FLOATING
C9940 VDD.n1494 VSS 0.01488f ; **FLOATING
C9941 VDD.n1495 VSS 0.07817f ; **FLOATING
C9942 VDD.n1497 VSS 0.04888f ; **FLOATING
C9943 VDD.n1498 VSS 0.02718f ; **FLOATING
C9944 VDD.n1499 VSS 0.09307f ; **FLOATING
C9945 VDD.n1500 VSS 0.05203f ; **FLOATING
C9946 VDD.n1501 VSS 0.11246f ; **FLOATING
C9947 VDD.n1502 VSS 0.05203f ; **FLOATING
C9948 VDD.n1503 VSS 0.11246f ; **FLOATING
C9949 VDD.n1504 VSS 0.05203f ; **FLOATING
C9950 VDD.n1505 VSS 0.11246f ; **FLOATING
C9951 VDD.n1506 VSS 0.05203f ; **FLOATING
C9952 VDD.n1507 VSS 0.09301f ; **FLOATING
C9953 VDD.n1508 VSS 0.03405f ; **FLOATING
C9954 VDD.n1509 VSS 0.08499f ; **FLOATING
C9955 VDD.n1510 VSS 0.01707f ; **FLOATING
C9956 VDD.n1511 VSS 0.0831f ; **FLOATING
C9957 VDD.n1512 VSS 0.05203f ; **FLOATING
C9958 VDD.n1513 VSS 0.11246f ; **FLOATING
C9959 VDD.n1514 VSS 0.05203f ; **FLOATING
C9960 VDD.n1515 VSS 0.11246f ; **FLOATING
C9961 VDD.n1516 VSS 0.05203f ; **FLOATING
C9962 VDD.n1517 VSS 0.11246f ; **FLOATING
C9963 VDD.n1518 VSS 0.05203f ; **FLOATING
C9964 VDD.n1519 VSS 0.11246f ; **FLOATING
C9965 VDD.n1520 VSS 0.05203f ; **FLOATING
C9966 VDD.n1521 VSS 0.11246f ; **FLOATING
C9967 VDD.n1522 VSS 0.05203f ; **FLOATING
C9968 VDD.n1523 VSS 0.11246f ; **FLOATING
C9969 VDD.n1524 VSS 0.05203f ; **FLOATING
C9970 VDD.n1525 VSS 0.11246f ; **FLOATING
C9971 VDD.n1526 VSS 0.05203f ; **FLOATING
C9972 VDD.n1527 VSS 0.11246f ; **FLOATING
C9973 VDD.n1528 VSS 0.05203f ; **FLOATING
C9974 VDD.n1529 VSS 0.10768f ; **FLOATING
C9975 VDD.n1530 VSS 0.11631f ; **FLOATING
C9976 VDD.n1531 VSS 0.05203f ; **FLOATING
C9977 VDD.n1532 VSS 0.11246f ; **FLOATING
C9978 VDD.n1533 VSS 0.05203f ; **FLOATING
C9979 VDD.n1534 VSS 0.11246f ; **FLOATING
C9980 VDD.n1535 VSS 0.05203f ; **FLOATING
C9981 VDD.n1536 VSS 0.11246f ; **FLOATING
C9982 VDD.n1537 VSS 0.05203f ; **FLOATING
C9983 VDD.n1538 VSS 0.11246f ; **FLOATING
C9984 VDD.n1539 VSS 0.05203f ; **FLOATING
C9985 VDD.n1540 VSS 0.11246f ; **FLOATING
C9986 VDD.n1541 VSS 0.05203f ; **FLOATING
C9987 VDD.n1542 VSS 0.11246f ; **FLOATING
C9988 VDD.n1543 VSS 0.05203f ; **FLOATING
C9989 VDD.n1544 VSS 0.11246f ; **FLOATING
C9990 VDD.n1545 VSS 0.05203f ; **FLOATING
C9991 VDD.n1546 VSS 0.04739f ; **FLOATING
C9992 VDD.n1547 VSS 0.10769f ; **FLOATING
C9993 VDD.n1548 VSS 0.05203f ; **FLOATING
C9994 VDD.n1549 VSS 0.11246f ; **FLOATING
C9995 VDD.n1550 VSS 0.05203f ; **FLOATING
C9996 VDD.n1551 VSS 0.11246f ; **FLOATING
C9997 VDD.n1552 VSS 0.05203f ; **FLOATING
C9998 VDD.n1553 VSS 0.11246f ; **FLOATING
C9999 VDD.n1554 VSS 0.05203f ; **FLOATING
C10000 VDD.n1555 VSS 0.11246f ; **FLOATING
C10001 VDD.n1556 VSS 0.05203f ; **FLOATING
C10002 VDD.t649 VSS 0.02015f ; **FLOATING
C10003 VDD.t647 VSS 0.03825f ; **FLOATING
C10004 VDD.t741 VSS 0.03543f ; **FLOATING
C10005 VDD.t419 VSS 0.03543f ; **FLOATING
C10006 VDD.t245 VSS 0.03182f ; **FLOATING
C10007 VDD.n1557 VSS 0.06654f ; **FLOATING
C10008 VDD.n1558 VSS 0.0196f ; **FLOATING
C10009 VDD.t1075 VSS 0.03543f ; **FLOATING
C10010 VDD.n1559 VSS 0.05455f ; **FLOATING
C10011 VDD.n1560 VSS 0.01374f ; **FLOATING
C10012 VDD.n1561 VSS 0.02926f ; **FLOATING
C10013 VDD.t423 VSS 0.04651f ; **FLOATING
C10014 VDD.n1562 VSS 0.0892f ; **FLOATING
C10015 VDD.n1563 VSS 0.02609f ; **FLOATING
C10016 VDD.t718 VSS 0.03543f ; **FLOATING
C10017 VDD.n1564 VSS 0.09607f ; **FLOATING
C10018 VDD.n1565 VSS 0.01242f ; **FLOATING
C10019 VDD.n1566 VSS 0.01294f ; **FLOATING
C10020 VDD.t482 VSS 0.03949f ; **FLOATING
C10021 VDD.t725 VSS 0.03949f ; **FLOATING
C10022 VDD.n1567 VSS 0.08483f ; **FLOATING
C10023 VDD.n1568 VSS 0.01245f ; **FLOATING
C10024 VDD.n1569 VSS 0.01311f ; **FLOATING
C10025 VDD.t476 VSS 0.03949f ; **FLOATING
C10026 VDD.t1112 VSS 0.03949f ; **FLOATING
C10027 VDD.n1570 VSS 0.08886f ; **FLOATING
C10028 VDD.t574 VSS 0.03543f ; **FLOATING
C10029 VDD.t738 VSS 0.03543f ; **FLOATING
C10030 VDD.t406 VSS 0.02617f ; **FLOATING
C10031 VDD.t1481 VSS 0.02617f ; **FLOATING
C10032 VDD.t475 VSS 0.03498f ; **FLOATING
C10033 VDD.t730 VSS 0.03498f ; **FLOATING
C10034 VDD.t743 VSS 0.02617f ; **FLOATING
C10035 VDD.t418 VSS 0.02617f ; **FLOATING
C10036 VDD.n1571 VSS 0.07007f ; **FLOATING
C10037 VDD.t481 VSS 0.03498f ; **FLOATING
C10038 VDD.t724 VSS 0.03498f ; **FLOATING
C10039 VDD.n1572 VSS 0.07502f ; **FLOATING
C10040 VDD.n1573 VSS 0.01264f ; **FLOATING
C10041 VDD.t573 VSS 0.02617f ; **FLOATING
C10042 VDD.t737 VSS 0.02617f ; **FLOATING
C10043 VDD.n1574 VSS 0.06983f ; **FLOATING
C10044 VDD.n1575 VSS 0.01218f ; **FLOATING
C10045 VDD.t407 VSS 0.03498f ; **FLOATING
C10046 VDD.t582 VSS 0.03498f ; **FLOATING
C10047 VDD.n1576 VSS 0.07079f ; **FLOATING
C10048 VDD.n1577 VSS 0.01729f ; **FLOATING
C10049 VDD.t554 VSS 0.03949f ; **FLOATING
C10050 VDD.t583 VSS 0.03949f ; **FLOATING
C10051 VDD.n1578 VSS 0.07913f ; **FLOATING
C10052 VDD.t742 VSS 0.02617f ; **FLOATING
C10053 VDD.t417 VSS 0.02617f ; **FLOATING
C10054 VDD.n1579 VSS 0.07047f ; **FLOATING
C10055 VDD.n1580 VSS 0.01289f ; **FLOATING
C10056 VDD.t436 VSS 0.03498f ; **FLOATING
C10057 VDD.t428 VSS 0.03498f ; **FLOATING
C10058 VDD.t437 VSS 0.03949f ; **FLOATING
C10059 VDD.t429 VSS 0.03949f ; **FLOATING
C10060 VDD.t705 VSS 0.03543f ; **FLOATING
C10061 VDD.t1234 VSS 0.03555f ; **FLOATING
C10062 VDD.t1218 VSS 0.03543f ; **FLOATING
C10063 VDD.n1581 VSS 0.07423f ; **FLOATING
C10064 VDD.n1582 VSS 0.01394f ; **FLOATING
C10065 VDD.t754 VSS 0.03543f ; **FLOATING
C10066 VDD.n1583 VSS 0.06436f ; **FLOATING
C10067 VDD.t1021 VSS 0.03543f ; **FLOATING
C10068 VDD.n1584 VSS 0.05437f ; **FLOATING
C10069 VDD.n1585 VSS 0.01969f ; **FLOATING
C10070 VDD.t1226 VSS 0.03543f ; **FLOATING
C10071 VDD.t247 VSS 0.03181f ; **FLOATING
C10072 VDD.t248 VSS 0.03182f ; **FLOATING
C10073 VDD.t343 VSS 0.03543f ; **FLOATING
C10074 VDD.t246 VSS 0.03416f ; **FLOATING
C10075 VDD.t1673 VSS 0.11751f ; **FLOATING
C10076 VDD.t472 VSS 0.04651f ; **FLOATING
C10077 VDD.t249 VSS 0.03416f ; **FLOATING
C10078 VDD.t1672 VSS 0.11751f ; **FLOATING
C10079 VDD.t1533 VSS 0.03543f ; **FLOATING
C10080 VDD.t251 VSS 0.03181f ; **FLOATING
C10081 VDD.t252 VSS 0.03182f ; **FLOATING
C10082 VDD.t255 VSS 0.03181f ; **FLOATING
C10083 VDD.t1071 VSS 0.03543f ; **FLOATING
C10084 VDD.t1565 VSS 0.03543f ; **FLOATING
C10085 VDD.t1106 VSS 0.03543f ; **FLOATING
C10086 VDD.t1444 VSS 0.03543f ; **FLOATING
C10087 VDD.t97 VSS 0.03182f ; **FLOATING
C10088 VDD.t955 VSS 0.04651f ; **FLOATING
C10089 VDD.t1292 VSS 0.03543f ; **FLOATING
C10090 VDD.t236 VSS 0.03181f ; **FLOATING
C10091 VDD.t728 VSS 0.03543f ; **FLOATING
C10092 VDD.t237 VSS 0.03182f ; **FLOATING
C10093 VDD.t719 VSS 0.03543f ; **FLOATING
C10094 VDD.t240 VSS 0.03181f ; **FLOATING
C10095 VDD.t241 VSS 0.03182f ; **FLOATING
C10096 VDD.t415 VSS 0.04668f ; **FLOATING
C10097 VDD.n1586 VSS 0.01969f ; **FLOATING
C10098 VDD.t425 VSS 0.03543f ; **FLOATING
C10099 VDD.n1587 VSS 0.06436f ; **FLOATING
C10100 VDD.n1588 VSS 0.01394f ; **FLOATING
C10101 VDD.t244 VSS 0.03181f ; **FLOATING
C10102 VDD.t1072 VSS 0.03543f ; **FLOATING
C10103 VDD.n1589 VSS 0.05382f ; **FLOATING
C10104 VDD.t1281 VSS 0.03543f ; **FLOATING
C10105 VDD.n1591 VSS 0.05437f ; **FLOATING
C10106 VDD.n1592 VSS 0.01374f ; **FLOATING
C10107 VDD.t1445 VSS 0.03543f ; **FLOATING
C10108 VDD.n1593 VSS 0.05455f ; **FLOATING
C10109 VDD.n1594 VSS 0.0196f ; **FLOATING
C10110 VDD.t41 VSS 0.03182f ; **FLOATING
C10111 VDD.n1595 VSS 0.06654f ; **FLOATING
C10112 VDD.t435 VSS 0.04651f ; **FLOATING
C10113 VDD.t44 VSS 0.03181f ; **FLOATING
C10114 VDD.t1228 VSS 0.03543f ; **FLOATING
C10115 VDD.t45 VSS 0.03182f ; **FLOATING
C10116 VDD.t1263 VSS 0.03543f ; **FLOATING
C10117 VDD.t1219 VSS 0.03543f ; **FLOATING
C10118 VDD.t48 VSS 0.03181f ; **FLOATING
C10119 VDD.t49 VSS 0.03182f ; **FLOATING
C10120 VDD.t52 VSS 0.03181f ; **FLOATING
C10121 VDD.t1031 VSS 0.03543f ; **FLOATING
C10122 VDD.t563 VSS 0.03543f ; **FLOATING
C10123 VDD.t1296 VSS 0.03543f ; **FLOATING
C10124 VDD.t1290 VSS 0.03543f ; **FLOATING
C10125 VDD.t479 VSS 0.04651f ; **FLOATING
C10126 VDD.t1248 VSS 0.03543f ; **FLOATING
C10127 VDD.t1230 VSS 0.03543f ; **FLOATING
C10128 VDD.t420 VSS 0.03543f ; **FLOATING
C10129 VDD.t1217 VSS 0.03543f ; **FLOATING
C10130 VDD.t355 VSS 0.03762f ; **FLOATING
C10131 VDD.t673 VSS 0.04651f ; **FLOATING
C10132 VDD.t391 VSS 0.06643f ; **FLOATING
C10133 VDD.t1070 VSS 0.03543f ; **FLOATING
C10134 VDD.t1267 VSS 0.03543f ; **FLOATING
C10135 VDD.t1282 VSS 0.03543f ; **FLOATING
C10136 VDD.t1443 VSS 0.03543f ; **FLOATING
C10137 VDD.t160 VSS 0.03182f ; **FLOATING
C10138 VDD.t744 VSS 0.04651f ; **FLOATING
C10139 VDD.t558 VSS 0.03543f ; **FLOATING
C10140 VDD.t163 VSS 0.03181f ; **FLOATING
C10141 VDD.t1261 VSS 0.03543f ; **FLOATING
C10142 VDD.t164 VSS 0.03182f ; **FLOATING
C10143 VDD.t720 VSS 0.03543f ; **FLOATING
C10144 VDD.t167 VSS 0.03181f ; **FLOATING
C10145 VDD.t168 VSS 0.03182f ; **FLOATING
C10146 VDD.t393 VSS 0.04668f ; **FLOATING
C10147 VDD.n1596 VSS 0.01969f ; **FLOATING
C10148 VDD.t700 VSS 0.03543f ; **FLOATING
C10149 VDD.n1597 VSS 0.06436f ; **FLOATING
C10150 VDD.n1598 VSS 0.01394f ; **FLOATING
C10151 VDD.t171 VSS 0.03181f ; **FLOATING
C10152 VDD.t1073 VSS 0.03543f ; **FLOATING
C10153 VDD.n1599 VSS 0.05382f ; **FLOATING
C10154 VDD.t1107 VSS 0.03543f ; **FLOATING
C10155 VDD.n1601 VSS 0.05437f ; **FLOATING
C10156 VDD.n1602 VSS 0.01374f ; **FLOATING
C10157 VDD.t1289 VSS 0.03543f ; **FLOATING
C10158 VDD.n1603 VSS 0.05455f ; **FLOATING
C10159 VDD.n1604 VSS 0.0196f ; **FLOATING
C10160 VDD.t101 VSS 0.03182f ; **FLOATING
C10161 VDD.n1605 VSS 0.06654f ; **FLOATING
C10162 VDD.t986 VSS 0.04651f ; **FLOATING
C10163 VDD.t104 VSS 0.03181f ; **FLOATING
C10164 VDD.t1229 VSS 0.03543f ; **FLOATING
C10165 VDD.t105 VSS 0.03182f ; **FLOATING
C10166 VDD.t340 VSS 0.03543f ; **FLOATING
C10167 VDD.t1220 VSS 0.03543f ; **FLOATING
C10168 VDD.t108 VSS 0.03181f ; **FLOATING
C10169 VDD.t109 VSS 0.03182f ; **FLOATING
C10170 VDD.t112 VSS 0.03181f ; **FLOATING
C10171 VDD.t1032 VSS 0.03543f ; **FLOATING
C10172 VDD.t1025 VSS 0.03543f ; **FLOATING
C10173 VDD.t527 VSS 0.03543f ; **FLOATING
C10174 VDD.t1291 VSS 0.03543f ; **FLOATING
C10175 VDD.t30 VSS 0.03182f ; **FLOATING
C10176 VDD.t676 VSS 0.04651f ; **FLOATING
C10177 VDD.t1249 VSS 0.03543f ; **FLOATING
C10178 VDD.t33 VSS 0.03181f ; **FLOATING
C10179 VDD.t670 VSS 0.03543f ; **FLOATING
C10180 VDD.t34 VSS 0.03182f ; **FLOATING
C10181 VDD.t1532 VSS 0.03543f ; **FLOATING
C10182 VDD.t189 VSS 0.03181f ; **FLOATING
C10183 VDD.t190 VSS 0.03182f ; **FLOATING
C10184 VDD.t488 VSS 0.04668f ; **FLOATING
C10185 VDD.n1606 VSS 0.01969f ; **FLOATING
C10186 VDD.t1265 VSS 0.03543f ; **FLOATING
C10187 VDD.n1607 VSS 0.06436f ; **FLOATING
C10188 VDD.n1608 VSS 0.01394f ; **FLOATING
C10189 VDD.t193 VSS 0.03181f ; **FLOATING
C10190 VDD.t1534 VSS 0.03543f ; **FLOATING
C10191 VDD.n1609 VSS 0.05382f ; **FLOATING
C10192 VDD.t1069 VSS 0.03543f ; **FLOATING
C10193 VDD.n1611 VSS 0.05437f ; **FLOATING
C10194 VDD.n1612 VSS 0.01374f ; **FLOATING
C10195 VDD.t1074 VSS 0.03543f ; **FLOATING
C10196 VDD.n1613 VSS 0.06447f ; **FLOATING
C10197 VDD.n1614 VSS 0.02609f ; **FLOATING
C10198 VDD.t1159 VSS 0.04651f ; **FLOATING
C10199 VDD.n1615 VSS 0.09458f ; **FLOATING
C10200 VDD.t1227 VSS 0.03885f ; **FLOATING
C10201 VDD.n1616 VSS 0.12607f ; **FLOATING
C10202 VDD.t191 VSS 0.03416f ; **FLOATING
C10203 VDD.t1656 VSS 0.11751f ; **FLOATING
C10204 VDD.t35 VSS 0.03416f ; **FLOATING
C10205 VDD.t1657 VSS 0.11751f ; **FLOATING
C10206 VDD.t31 VSS 0.03416f ; **FLOATING
C10207 VDD.t1658 VSS 0.11751f ; **FLOATING
C10208 VDD.n1617 VSS 0.06839f ; **FLOATING
C10209 VDD.n1618 VSS 0.07454f ; **FLOATING
C10210 VDD.n1619 VSS 0.01394f ; **FLOATING
C10211 VDD.n1620 VSS 0.05382f ; **FLOATING
C10212 VDD.t963 VSS 0.04668f ; **FLOATING
C10213 VDD.t110 VSS 0.03416f ; **FLOATING
C10214 VDD.t1659 VSS 0.11751f ; **FLOATING
C10215 VDD.t106 VSS 0.03416f ; **FLOATING
C10216 VDD.t1660 VSS 0.11751f ; **FLOATING
C10217 VDD.t102 VSS 0.03416f ; **FLOATING
C10218 VDD.t1661 VSS 0.11751f ; **FLOATING
C10219 VDD.t169 VSS 0.03416f ; **FLOATING
C10220 VDD.t1662 VSS 0.11751f ; **FLOATING
C10221 VDD.t165 VSS 0.03416f ; **FLOATING
C10222 VDD.t1663 VSS 0.11751f ; **FLOATING
C10223 VDD.t161 VSS 0.03416f ; **FLOATING
C10224 VDD.t1664 VSS 0.11751f ; **FLOATING
C10225 VDD.n1622 VSS 0.06654f ; **FLOATING
C10226 VDD.n1623 VSS 0.0196f ; **FLOATING
C10227 VDD.n1624 VSS 0.05455f ; **FLOATING
C10228 VDD.n1625 VSS 0.01374f ; **FLOATING
C10229 VDD.n1626 VSS 0.05437f ; **FLOATING
C10230 VDD.n1627 VSS 0.01969f ; **FLOATING
C10231 VDD.n1628 VSS 0.06436f ; **FLOATING
C10232 VDD.n1629 VSS 0.01394f ; **FLOATING
C10233 VDD.n1630 VSS 0.07893f ; **FLOATING
C10234 VDD.n1631 VSS 0.07423f ; **FLOATING
C10235 VDD.n1632 VSS 0.02926f ; **FLOATING
C10236 VDD.n1633 VSS 0.0892f ; **FLOATING
C10237 VDD.n1634 VSS 0.02609f ; **FLOATING
C10238 VDD.n1635 VSS 0.06447f ; **FLOATING
C10239 VDD.n1636 VSS 0.01374f ; **FLOATING
C10240 VDD.n1637 VSS 0.05437f ; **FLOATING
C10241 VDD.n1638 VSS 0.01969f ; **FLOATING
C10242 VDD.n1639 VSS 0.06436f ; **FLOATING
C10243 VDD.n1640 VSS 0.01394f ; **FLOATING
C10244 VDD.n1641 VSS 0.05382f ; **FLOATING
C10245 VDD.n1643 VSS 0.06128f ; **FLOATING
C10246 VDD.t723 VSS 0.04668f ; **FLOATING
C10247 VDD.t50 VSS 0.03416f ; **FLOATING
C10248 VDD.t1665 VSS 0.11751f ; **FLOATING
C10249 VDD.t46 VSS 0.03416f ; **FLOATING
C10250 VDD.t1666 VSS 0.11751f ; **FLOATING
C10251 VDD.t42 VSS 0.03416f ; **FLOATING
C10252 VDD.t1667 VSS 0.11751f ; **FLOATING
C10253 VDD.t242 VSS 0.03416f ; **FLOATING
C10254 VDD.t1668 VSS 0.11751f ; **FLOATING
C10255 VDD.t238 VSS 0.03416f ; **FLOATING
C10256 VDD.t1669 VSS 0.11751f ; **FLOATING
C10257 VDD.t98 VSS 0.03416f ; **FLOATING
C10258 VDD.t1670 VSS 0.11751f ; **FLOATING
C10259 VDD.n1644 VSS 0.06386f ; **FLOATING
C10260 VDD.n1645 VSS 0.01394f ; **FLOATING
C10261 VDD.n1646 VSS 0.05382f ; **FLOATING
C10262 VDD.t490 VSS 0.04668f ; **FLOATING
C10263 VDD.t253 VSS 0.03416f ; **FLOATING
C10264 VDD.t1671 VSS 0.11751f ; **FLOATING
C10265 VDD.n1648 VSS 0.05203f ; **FLOATING
C10266 VDD.n1649 VSS 0.05203f ; **FLOATING
C10267 VDD.n1650 VSS 0.05203f ; **FLOATING
C10268 VDD.n1651 VSS 0.05203f ; **FLOATING
C10269 VDD.n1652 VSS 0.05203f ; **FLOATING
C10270 VDD.n1653 VSS 0.05203f ; **FLOATING
C10271 VDD.n1654 VSS 0.05203f ; **FLOATING
C10272 VDD.n1655 VSS 0.05203f ; **FLOATING
C10273 VDD.n1656 VSS 0.05203f ; **FLOATING
C10274 VDD.n1657 VSS 0.05203f ; **FLOATING
C10275 VDD.n1658 VSS 0.05203f ; **FLOATING
C10276 VDD.n1659 VSS 0.05203f ; **FLOATING
C10277 VDD.n1660 VSS 0.05203f ; **FLOATING
C10278 VDD.n1661 VSS 0.04278f ; **FLOATING
C10279 VDD.n1662 VSS 0.05203f ; **FLOATING
C10280 VDD.n1663 VSS 0.05203f ; **FLOATING
C10281 VDD.n1664 VSS 0.05203f ; **FLOATING
C10282 VDD.n1665 VSS 0.05203f ; **FLOATING
C10283 VDD.n1666 VSS 0.05203f ; **FLOATING
C10284 VDD.n1667 VSS 0.05203f ; **FLOATING
C10285 VDD.n1668 VSS 0.05203f ; **FLOATING
C10286 VDD.n1669 VSS 0.05203f ; **FLOATING
C10287 VDD.n1670 VSS 0.05203f ; **FLOATING
C10288 VDD.n1671 VSS 0.01707f ; **FLOATING
C10289 VDD.n1672 VSS 0.08549f ; **FLOATING
C10290 VDD.n1673 VSS 0.03405f ; **FLOATING
C10291 VDD.n1674 VSS 0.05203f ; **FLOATING
C10292 VDD.n1675 VSS 0.05203f ; **FLOATING
C10293 VDD.n1676 VSS 0.05203f ; **FLOATING
C10294 VDD.n1677 VSS 0.05203f ; **FLOATING
C10295 VDD.n1678 VSS 0.02718f ; **FLOATING
C10296 VDD.t641 VSS 0.0718f ; **FLOATING
C10297 VDD.n1680 VSS 0.0783f ; **FLOATING
C10298 VDD.t644 VSS 0.03308f ; **FLOATING
C10299 VDD.n1681 VSS 0.01687f ; **FLOATING
C10300 VDD.t645 VSS 0.03423f ; **FLOATING
C10301 VDD.t640 VSS 0.03423f ; **FLOATING
C10302 VDD.n1682 VSS 0.09648f ; **FLOATING
C10303 VDD.t785 VSS 0.03423f ; **FLOATING
C10304 VDD.t422 VSS 0.04014f ; **FLOATING
C10305 VDD.n1683 VSS 0.11246f ; **FLOATING
C10306 VDD.t868 VSS 0.03423f ; **FLOATING
C10307 VDD.t427 VSS 0.04014f ; **FLOATING
C10308 VDD.n1684 VSS 0.11246f ; **FLOATING
C10309 VDD.t867 VSS 0.03423f ; **FLOATING
C10310 VDD.t1508 VSS 0.04014f ; **FLOATING
C10311 VDD.n1685 VSS 0.11246f ; **FLOATING
C10312 VDD.t787 VSS 0.03423f ; **FLOATING
C10313 VDD.t344 VSS 0.04014f ; **FLOATING
C10314 VDD.n1686 VSS 0.09522f ; **FLOATING
C10315 VDD.n1687 VSS 0.11246f ; **FLOATING
C10316 VDD.t768 VSS 0.03423f ; **FLOATING
C10317 VDD.t489 VSS 0.04014f ; **FLOATING
C10318 VDD.n1688 VSS 0.10769f ; **FLOATING
C10319 VDD.t877 VSS 0.03423f ; **FLOATING
C10320 VDD.t1247 VSS 0.04014f ; **FLOATING
C10321 VDD.t776 VSS 0.03423f ; **FLOATING
C10322 VDD.t1245 VSS 0.04014f ; **FLOATING
C10323 VDD.n1689 VSS 0.11657f ; **FLOATING
C10324 VDD.t875 VSS 0.03423f ; **FLOATING
C10325 VDD.t727 VSS 0.04014f ; **FLOATING
C10326 VDD.n1690 VSS 0.11246f ; **FLOATING
C10327 VDD.t874 VSS 0.03423f ; **FLOATING
C10328 VDD.t525 VSS 0.04014f ; **FLOATING
C10329 VDD.n1691 VSS 0.11246f ; **FLOATING
C10330 VDD.t783 VSS 0.03423f ; **FLOATING
C10331 VDD.t426 VSS 0.04014f ; **FLOATING
C10332 VDD.n1692 VSS 0.09518f ; **FLOATING
C10333 VDD.n1693 VSS 0.11246f ; **FLOATING
C10334 VDD.t878 VSS 0.03423f ; **FLOATING
C10335 VDD.n1694 VSS 0.02538f ; **FLOATING
C10336 VDD.t734 VSS 0.04014f ; **FLOATING
C10337 VDD.n1695 VSS 0.11246f ; **FLOATING
C10338 VDD.t873 VSS 0.03423f ; **FLOATING
C10339 VDD.t1029 VSS 0.04014f ; **FLOATING
C10340 VDD.n1696 VSS 0.11246f ; **FLOATING
C10341 VDD.t872 VSS 0.03423f ; **FLOATING
C10342 VDD.n1697 VSS 0.02538f ; **FLOATING
C10343 VDD.n1698 VSS 0.06363f ; **FLOATING
C10344 VDD.t722 VSS 0.04014f ; **FLOATING
C10345 VDD.n1699 VSS 0.08363f ; **FLOATING
C10346 VDD.n1700 VSS 0.11246f ; **FLOATING
C10347 VDD.t870 VSS 0.03423f ; **FLOATING
C10348 VDD.t562 VSS 0.04014f ; **FLOATING
C10349 VDD.n1701 VSS 0.11246f ; **FLOATING
C10350 VDD.t879 VSS 0.03423f ; **FLOATING
C10351 VDD.t431 VSS 0.04014f ; **FLOATING
C10352 VDD.n1702 VSS 0.11631f ; **FLOATING
C10353 VDD.t770 VSS 0.03423f ; **FLOATING
C10354 VDD.t473 VSS 0.04014f ; **FLOATING
C10355 VDD.t882 VSS 0.03423f ; **FLOATING
C10356 VDD.t389 VSS 0.04014f ; **FLOATING
C10357 VDD.n1703 VSS 0.10768f ; **FLOATING
C10358 VDD.t881 VSS 0.03423f ; **FLOATING
C10359 VDD.t1268 VSS 0.04014f ; **FLOATING
C10360 VDD.n1704 VSS 0.11246f ; **FLOATING
C10361 VDD.t880 VSS 0.03423f ; **FLOATING
C10362 VDD.t414 VSS 0.04014f ; **FLOATING
C10363 VDD.n1705 VSS 0.11246f ; **FLOATING
C10364 VDD.t876 VSS 0.03423f ; **FLOATING
C10365 VDD.t735 VSS 0.04014f ; **FLOATING
C10366 VDD.n1706 VSS 0.11246f ; **FLOATING
C10367 VDD.t871 VSS 0.03423f ; **FLOATING
C10368 VDD.t571 VSS 0.04014f ; **FLOATING
C10369 VDD.n1707 VSS 0.11246f ; **FLOATING
C10370 VDD.t786 VSS 0.03423f ; **FLOATING
C10371 VDD.n1708 VSS 0.02538f ; **FLOATING
C10372 VDD.t701 VSS 0.04014f ; **FLOATING
C10373 VDD.n1709 VSS 0.11246f ; **FLOATING
C10374 VDD.t883 VSS 0.03423f ; **FLOATING
C10375 VDD.t1142 VSS 0.04014f ; **FLOATING
C10376 VDD.n1710 VSS 0.11246f ; **FLOATING
C10377 VDD.t775 VSS 0.03423f ; **FLOATING
C10378 VDD.t342 VSS 0.04014f ; **FLOATING
C10379 VDD.n1711 VSS 0.11246f ; **FLOATING
C10380 VDD.t884 VSS 0.03423f ; **FLOATING
C10381 VDD.t962 VSS 0.04014f ; **FLOATING
C10382 VDD.n1712 VSS 0.09524f ; **FLOATING
C10383 VDD.n1713 VSS 0.11246f ; **FLOATING
C10384 VDD.t886 VSS 0.03423f ; **FLOATING
C10385 VDD.t551 VSS 0.04014f ; **FLOATING
C10386 VDD.n1714 VSS 0.0831f ; **FLOATING
C10387 VDD.t885 VSS 0.03423f ; **FLOATING
C10388 VDD.n1715 VSS 0.02538f ; **FLOATING
C10389 VDD.n1716 VSS 0.07777f ; **FLOATING
C10390 VDD.t739 VSS 0.04014f ; **FLOATING
C10391 VDD.n1717 VSS 0.09301f ; **FLOATING
C10392 VDD.t869 VSS 0.03423f ; **FLOATING
C10393 VDD.t413 VSS 0.04014f ; **FLOATING
C10394 VDD.n1718 VSS 0.11246f ; **FLOATING
C10395 VDD.t890 VSS 0.03423f ; **FLOATING
C10396 VDD.n1719 VSS 0.02538f ; **FLOATING
C10397 VDD.t1449 VSS 0.04014f ; **FLOATING
C10398 VDD.n1720 VSS 0.11246f ; **FLOATING
C10399 VDD.t888 VSS 0.03423f ; **FLOATING
C10400 VDD.t1266 VSS 0.04014f ; **FLOATING
C10401 VDD.n1721 VSS 0.11246f ; **FLOATING
C10402 VDD.t887 VSS 0.03423f ; **FLOATING
C10403 VDD.t698 VSS 0.04014f ; **FLOATING
C10404 VDD.n1722 VSS 0.09307f ; **FLOATING
C10405 VDD.t889 VSS 0.03423f ; **FLOATING
C10406 VDD.n1723 VSS 0.02538f ; **FLOATING
C10407 VDD.n1724 VSS 0.07251f ; **FLOATING
C10408 VDD.t993 VSS 0.04014f ; **FLOATING
C10409 VDD.n1725 VSS 0.04888f ; **FLOATING
C10410 VDD.t643 VSS 0.03423f ; **FLOATING
C10411 VDD.n1726 VSS 0.0341f ; **FLOATING
C10412 VDD.t642 VSS 0.03825f ; **FLOATING
C10413 VDD.n1727 VSS 0.08358f ; **FLOATING
C10414 VDD.n1728 VSS 0.07373f ; **FLOATING
C10415 VDD.n1729 VSS 0.08358f ; **FLOATING
C10416 VDD.n1730 VSS 0.01488f ; **FLOATING
C10417 VDD.n1731 VSS 0.08229f ; **FLOATING
C10418 VDD.n1732 VSS 0.09443f ; **FLOATING
C10419 VDD.n1733 VSS 0.08357f ; **FLOATING
C10420 VDD.n1734 VSS 0.01488f ; **FLOATING
C10421 VDD.n1735 VSS 0.0636f ; **FLOATING
C10422 VDD.t637 VSS 0.03423f ; **FLOATING
C10423 VDD.n1736 VSS 0.02323f ; **FLOATING
C10424 VDD.t635 VSS 0.02471f ; **FLOATING
C10425 VDD.n1737 VSS 0.01701f ; **FLOATING
C10426 VDD.n1738 VSS 0.28486f ; **FLOATING
C10427 VDD.n1739 VSS 0.02215f ; **FLOATING
C10428 VDD.n1740 VSS 0.68112f ; **FLOATING
C10429 VDD.n1741 VSS 0.01588f ; **FLOATING
C10430 VDD.t1023 VSS 0.02338f ; **FLOATING
C10431 VDD.n1742 VSS 0.066f ; **FLOATING
C10432 VDD.n1743 VSS 0.01653f ; **FLOATING
C10433 VDD.n1744 VSS 0.01687f ; **FLOATING
C10434 VDD.n1745 VSS 0.073f ; **FLOATING
C10435 VDD.t440 VSS 0.06831f ; **FLOATING
C10436 VDD.n1746 VSS 0.02385f ; **FLOATING
C10437 VDD.n1747 VSS 0.05342f ; **FLOATING
C10438 VDD.t616 VSS 0.06112f ; **FLOATING
C10439 VDD.n1748 VSS 0.02385f ; **FLOATING
C10440 VDD.n1749 VSS 0.06834f ; **FLOATING
C10441 VDD.t622 VSS 0.06112f ; **FLOATING
C10442 VDD.n1750 VSS 0.02385f ; **FLOATING
C10443 VDD.n1751 VSS 0.04824f ; **FLOATING
C10444 VDD.t614 VSS 0.38649f ; **FLOATING
C10445 VDD.n1752 VSS 0.0156f ; **FLOATING
C10446 VDD.n1753 VSS 0.04824f ; **FLOATING
C10447 VDD.t441 VSS 0.06831f ; **FLOATING
C10448 VDD.n1754 VSS 0.02385f ; **FLOATING
C10449 VDD.n1755 VSS 0.07299f ; **FLOATING
C10450 VDD.n1756 VSS 0.03853f ; **FLOATING
C10451 VDD.n1757 VSS 0.09297f ; **FLOATING
C10452 VDD.t438 VSS 0.06831f ; **FLOATING
C10453 VDD.n1758 VSS 0.04431f ; **FLOATING
C10454 VDD.t442 VSS 0.06831f ; **FLOATING
C10455 VDD.n1759 VSS 0.04433f ; **FLOATING
C10456 VDD.n1760 VSS 0.09293f ; **FLOATING
C10457 VDD.n1761 VSS 0.03349f ; **FLOATING
C10458 VDD.n1762 VSS 0.09319f ; **FLOATING
C10459 VDD.t439 VSS 0.06831f ; **FLOATING
C10460 VDD.n1763 VSS 0.04431f ; **FLOATING
C10461 VDD.t444 VSS 0.06831f ; **FLOATING
C10462 VDD.n1764 VSS 0.04433f ; **FLOATING
C10463 VDD.n1765 VSS 0.09319f ; **FLOATING
C10464 VDD.n1766 VSS 0.03839f ; **FLOATING
C10465 VDD.n1767 VSS 0.0975f ; **FLOATING
C10466 VDD.t451 VSS 0.06831f ; **FLOATING
C10467 VDD.n1768 VSS 0.04431f ; **FLOATING
C10468 VDD.t446 VSS 0.06831f ; **FLOATING
C10469 VDD.n1769 VSS 0.04433f ; **FLOATING
C10470 VDD.n1770 VSS 0.088f ; **FLOATING
C10471 VDD.n1771 VSS 0.0385f ; **FLOATING
C10472 VDD.n1772 VSS 0.01687f ; **FLOATING
C10473 VDD.t619 VSS 0.06112f ; **FLOATING
C10474 VDD.t624 VSS 0.06112f ; **FLOATING
C10475 VDD.n1773 VSS 0.02385f ; **FLOATING
C10476 VDD.n1774 VSS 0.07307f ; **FLOATING
C10477 VDD.t448 VSS 0.06831f ; **FLOATING
C10478 VDD.n1775 VSS 0.02385f ; **FLOATING
C10479 VDD.t453 VSS 0.06831f ; **FLOATING
C10480 VDD.n1776 VSS 0.02385f ; **FLOATING
C10481 VDD.n1777 VSS 0.04824f ; **FLOATING
C10482 VDD.t617 VSS 0.38649f ; **FLOATING
C10483 VDD.n1778 VSS 0.0156f ; **FLOATING
C10484 VDD.n1779 VSS 0.05168f ; **FLOATING
C10485 VDD.n1780 VSS 0.02385f ; **FLOATING
C10486 VDD.n1781 VSS 0.08694f ; **FLOATING
C10487 VDD.n1782 VSS 0.05089f ; **FLOATING
.ends
