* NGSPICE file created from hx_charge_pump_current_generator.ext - technology: ihp-sg13g2

.subckt hx_charge_pump_current_generator VDD VSS CURRENT_SINK CURRENT_SOURCE
X0 VSS.t14 VSS.t12 VSS.t12 VSS.t13 sg13_lv_nmos ad=0.68p pd=4.68u as=0 ps=0 w=2u l=1u
X1 a_3921_1423# a_3921_1423# VSS.t10 VSS.t4 sg13_lv_nmos ad=0.38p pd=2.38u as=0.68p ps=4.68u w=2u l=1u
X2 CURRENT_SOURCE a_803_1423# VDD VDD sg13_lv_pmos ad=0.38p pd=2.38u as=0.38p ps=2.38u w=2u l=1u
X3 a_1331_2287# a_803_1423# VDD VDD sg13_lv_pmos ad=0.38p pd=2.38u as=0.38p ps=2.38u w=2u l=1u
X4 a_255_200# a_603_649# a_803_1423# VSS.t32 sg13_lv_nmos ad=0.68p pd=4.68u as=0.38p ps=2.38u w=2u l=1u
X5 CURRENT_SINK a_1331_2287# a_3921_745# VSS.t25 sg13_lv_nmos ad=0.38p pd=2.38u as=0.68p ps=4.68u w=2u l=1u
X6 a_803_1423# a_603_649# a_255_200# VSS.t36 sg13_lv_nmos ad=0.42p pd=2.42u as=0.68p ps=4.68u w=2u l=1u
X7 VSS.t17 VSS.t15 VSS.t15 VSS.t16 sg13_lv_nmos ad=0.68p pd=4.68u as=0 ps=0 w=2u l=1u
X8 VDD VDD VDD VDD sg13_lv_pmos ad=0.68p pd=4.68u as=30.9901p ps=0.16929m w=2u l=1u
X9 a_803_1423# a_603_649# a_255_200# VSS.t31 sg13_lv_nmos ad=0.38p pd=2.38u as=0.68p ps=4.68u w=2u l=1u
X10 VDD VDD VDD VDD sg13_lv_pmos ad=0.68p pd=4.68u as=0 ps=0 w=2u l=1u
X11 VSS.t7 a_3921_1423# a_3921_745# VSS.t6 sg13_lv_nmos ad=0.68p pd=4.68u as=0.38p ps=2.38u w=2u l=1u
X12 a_603_649# a_451_2556# a_803_1423# VSS.t39 sg13_lv_nmos ad=0.68p pd=4.68u as=0.38p ps=2.38u w=2u l=1u
X13 a_1331_2287# a_1331_2287# a_3921_1423# VSS.t23 sg13_lv_nmos ad=0.38p pd=2.38u as=0.68p ps=4.68u w=2u l=1u
X14 VDD VDD VDD VDD sg13_lv_pmos ad=0.38p pd=2.38u as=0 ps=0 w=2u l=1u
X15 VDD VDD VDD VDD sg13_lv_pmos ad=0.38p pd=2.38u as=0 ps=0 w=2u l=1u
X16 a_603_649# a_603_649# VSS.t34 VSS.t33 sg13_lv_nmos ad=0.38p pd=2.38u as=0.68p ps=4.68u w=2u l=1u
X17 a_3921_745# a_3921_1423# VSS.t5 VSS.t4 sg13_lv_nmos ad=0.38p pd=2.38u as=0.68p ps=4.68u w=2u l=1u
X18 a_3921_745# a_1331_2287# CURRENT_SINK VSS.t24 sg13_lv_nmos ad=0.68p pd=4.68u as=0.38p ps=2.38u w=2u l=1u
X19 a_255_200# VSS.t28 VSS.t27 rppd l=32u w=1u
X20 VSS.t47 a_603_649# a_451_2556# VSS.t37 sg13_lv_nmos ad=0.68p pd=4.68u as=0.38p ps=2.38u w=2u l=1u
X21 a_451_2556# a_603_649# VSS.t41 VSS.t46 sg13_lv_nmos ad=0.38p pd=2.38u as=0.68p ps=4.68u w=2u l=1u
X22 VDD a_803_1423# a_803_1423# VDD sg13_lv_pmos ad=0.38p pd=2.38u as=0.38p ps=2.38u w=2u l=1u
X23 a_1331_2287# a_803_1423# VDD VDD sg13_lv_pmos ad=0.38p pd=2.38u as=0.38p ps=2.38u w=2u l=1u
X24 VDD a_803_1423# a_603_649# VDD sg13_lv_pmos ad=0.38p pd=2.38u as=0.38p ps=2.38u w=2u l=1u
X25 a_255_200# a_603_649# a_803_1423# VSS.t30 sg13_lv_nmos ad=0.68p pd=4.68u as=0.38p ps=2.38u w=2u l=1u
X26 VSS.t3 a_3921_1423# a_3921_1423# VSS.t2 sg13_lv_nmos ad=0.68p pd=4.68u as=0.38p ps=2.38u w=2u l=1u
X27 VSS.t41 a_603_649# a_451_2556# VSS.t32 sg13_lv_nmos ad=0.68p pd=4.68u as=0.38p ps=2.38u w=2u l=1u
X28 CURRENT_SOURCE a_803_1423# VDD VDD sg13_lv_pmos ad=0.38p pd=2.38u as=0.38p ps=2.38u w=2u l=1u
X29 a_3921_1423# a_1331_2287# a_1331_2287# VSS.t24 sg13_lv_nmos ad=0.68p pd=4.68u as=0.38p ps=2.38u w=2u l=1u
X30 VSS.t20 VSS.t12 VSS.t12 VSS.t13 sg13_lv_nmos ad=0.68p pd=4.68u as=0 ps=0 w=2u l=1u
X31 a_803_1423# a_603_649# a_255_200# VSS.t29 sg13_lv_nmos ad=0.38p pd=2.38u as=0.68p ps=4.68u w=2u l=1u
X32 a_3921_1423# a_3921_1423# VSS.t1 VSS.t0 sg13_lv_nmos ad=0.38p pd=2.38u as=0.68p ps=4.68u w=2u l=1u
X33 a_451_2556# a_603_649# VSS.t41 VSS.t31 sg13_lv_nmos ad=0.38p pd=2.38u as=0.68p ps=4.68u w=2u l=1u
X34 VDD a_803_1423# a_603_649# VDD sg13_lv_pmos ad=0.38p pd=2.38u as=0.38p ps=2.38u w=2u l=1u
X35 VDD a_803_1423# a_803_1423# VDD sg13_lv_pmos ad=0.38p pd=2.38u as=0.38p ps=2.38u w=2u l=1u
X36 VSS.t34 a_603_649# a_603_649# VSS.t35 sg13_lv_nmos ad=0.68p pd=4.68u as=0.38p ps=2.38u w=2u l=1u
X37 VSS.t41 a_603_649# a_451_2556# VSS.t35 sg13_lv_nmos ad=0.76p pd=4.76u as=0.38p ps=2.38u w=2u l=1u
X38 a_803_1423# a_451_2556# a_603_649# VSS.t38 sg13_lv_nmos ad=0.38p pd=2.38u as=0.68p ps=4.68u w=2u l=1u
X39 VSS.t41 a_603_649# a_451_2556# VSS.t30 sg13_lv_nmos ad=0.68p pd=4.68u as=0.38p ps=2.38u w=2u l=1u
X40 VDD a_803_1423# CURRENT_SOURCE VDD sg13_lv_pmos ad=0.38p pd=2.38u as=0.38p ps=2.38u w=2u l=1u
X41 a_603_649# a_803_1423# VDD VDD sg13_lv_pmos ad=0.38p pd=2.38u as=0.38p ps=2.38u w=2u l=1u
X42 VDD a_803_1423# a_1331_2287# VDD sg13_lv_pmos ad=0.38p pd=2.38u as=0.38p ps=2.38u w=2u l=1u
X43 a_3921_745# a_1331_2287# CURRENT_SINK VSS.t26 sg13_lv_nmos ad=0.68p pd=4.68u as=0.38p ps=2.38u w=2u l=1u
X44 VDD a_803_1423# a_1331_2287# VDD sg13_lv_pmos ad=0.38p pd=2.38u as=0.38p ps=2.38u w=2u l=1u
X45 a_803_1423# a_803_1423# VDD VDD sg13_lv_pmos ad=0.38p pd=2.38u as=0.38p ps=2.38u w=2u l=1u
X46 VDD a_803_1423# CURRENT_SOURCE VDD sg13_lv_pmos ad=0.38p pd=2.38u as=0.38p ps=2.38u w=2u l=1u
X47 CURRENT_SINK a_1331_2287# a_3921_745# VSS.t23 sg13_lv_nmos ad=0.38p pd=2.38u as=0.68p ps=4.68u w=2u l=1u
X48 VSS.t11 a_3921_1423# a_3921_1423# VSS.t6 sg13_lv_nmos ad=0.68p pd=4.68u as=0.38p ps=2.38u w=2u l=1u
X49 VSS.t17 VSS.t15 VSS.t15 VSS.t16 sg13_lv_nmos ad=0.68p pd=4.68u as=0 ps=0 w=2u l=1u
X50 a_3921_1423# a_1331_2287# a_1331_2287# VSS.t26 sg13_lv_nmos ad=0.68p pd=4.68u as=0.38p ps=2.38u w=2u l=1u
X51 a_803_1423# a_803_1423# VDD VDD sg13_lv_pmos ad=0.38p pd=2.38u as=0.38p ps=2.38u w=2u l=1u
X52 a_1331_2287# a_1331_2287# a_3921_1423# VSS.t25 sg13_lv_nmos ad=0.38p pd=2.38u as=0.68p ps=4.68u w=2u l=1u
X53 a_603_649# a_803_1423# VDD VDD sg13_lv_pmos ad=0.38p pd=2.38u as=0.38p ps=2.38u w=2u l=1u
X54 a_803_1423# a_603_649# a_255_200# VSS.t38 sg13_lv_nmos ad=0.38p pd=2.38u as=0.68p ps=4.68u w=2u l=1u
X55 VSS.t9 a_3921_1423# a_3921_745# VSS.t2 sg13_lv_nmos ad=0.68p pd=4.68u as=0.38p ps=2.38u w=2u l=1u
X56 VDD a_451_2556# a_451_2556# VDD sg13_lv_pmos ad=0.2448p pd=2.08u as=0.2826p ps=2.29u w=0.36u l=2u
X57 a_3921_745# a_3921_1423# VSS.t8 VSS.t0 sg13_lv_nmos ad=0.38p pd=2.38u as=0.68p ps=4.68u w=2u l=1u
X58 a_255_200# a_603_649# a_803_1423# VSS.t37 sg13_lv_nmos ad=0.68p pd=4.68u as=0.42p ps=2.42u w=2u l=1u
X59 a_451_2556# a_603_649# VSS.t20 VSS.t29 sg13_lv_nmos ad=0.38p pd=2.38u as=0.68p ps=4.68u w=2u l=1u
X60 a_451_2556# a_603_649# VSS.t41 VSS.t33 sg13_lv_nmos ad=0.38p pd=2.38u as=0.68p ps=4.68u w=2u l=1u
X61 a_255_200# a_603_649# a_803_1423# VSS.t39 sg13_lv_nmos ad=0.68p pd=4.68u as=0.38p ps=2.38u w=2u l=1u
C0 a_803_1423# a_603_649# 2.8107f
C1 VDD a_451_2556# 0.90492f
C2 a_3921_745# a_341_200# 0.02483f
C3 a_255_200# a_341_200# 0.07306f
C4 a_3921_1423# a_803_1423# 0.01269f
C5 a_1331_2287# a_341_200# 0.03661f
C6 CURRENT_SINK a_3921_1423# 0.17053f
C7 VDD a_603_649# 0.89062f
C8 a_451_2556# a_341_200# 0.01697f
C9 a_1331_2287# CURRENT_SOURCE 0.13605f
C10 CURRENT_SINK a_803_1423# 0.04737f
C11 a_341_200# a_603_649# 0.23738f
C12 VDD a_803_1423# 7.53633f
C13 a_451_2556# CURRENT_SOURCE 0.02585f
C14 a_3921_1423# a_341_200# 0.06832f
C15 CURRENT_SOURCE a_603_649# 0.16988f
C16 a_341_200# a_803_1423# 0.01889f
C17 a_1331_2287# a_3921_745# 0.8486f
C18 a_255_200# a_1331_2287# 0.02724f
C19 a_255_200# a_451_2556# 2.88221f
C20 a_1331_2287# a_451_2556# 0.01757f
C21 CURRENT_SOURCE a_803_1423# 1.24737f
C22 a_255_200# a_603_649# 1.6143f
C23 a_3921_745# a_603_649# 0.25721f
C24 a_3921_745# a_3921_1423# 2.20455f
C25 a_255_200# a_3921_1423# 0.19787f
C26 a_1331_2287# a_603_649# 0.23035f
C27 a_1331_2287# a_3921_1423# 1.25684f
C28 VDD CURRENT_SOURCE 0.59444f
C29 a_451_2556# a_603_649# 1.74556f
C30 a_255_200# a_803_1423# 0.87838f
C31 a_1331_2287# a_803_1423# 1.26342f
C32 CURRENT_SINK a_3921_745# 0.68395f
C33 a_451_2556# a_803_1423# 0.33136f
C34 a_3921_1423# a_603_649# 0.03029f
C35 a_1331_2287# CURRENT_SINK 0.63956f
C36 a_1331_2287# VDD 0.95263f
C37 CURRENT_SINK a_451_2556# 0.01152f
R0 VSS.n0 VSS.n2 0.00488591
R1 VSS.t32 VSS.n1 6.43584
R2 VSS.t37 VSS.n10 19.1261
R3 VSS.n10 VSS.t46 92.3759
R4 VSS.n11 VSS.t33 22.2659
R5 VSS.n8 VSS.t27 35.2576
R6 VSS.t27 VSS.n9 83.2264
R7 VSS.n7 VSS.n0 0.00340055
R8 VSS.n6 VSS.t6 13.0462
R9 VSS.t25 VSS.n14 58.6703
R10 VSS.t0 VSS.n4 17.5829
R11 VSS.t29 VSS.t13 46.7499
R12 VSS.t31 VSS.n1 27.7278
R13 VSS.n0 VSS.n5 0.00252762
R14 VSS.n6 VSS.n0 0.00253735
R15 VSS.n8 VSS.t39 25.8676
R16 VSS.n6 VSS.t4 19.1756
R17 VSS.n14 VSS.t24 34.1512
R18 VSS.t26 VSS.n5 19.0153
R19 VSS.n11 VSS.n0 0.00430052
R20 VSS.t2 VSS.n4 17.0263
R21 VSS.n0 VSS.n10 0.00366528
R22 VSS.n13 VSS.t35 21.0853
R23 VSS.n46 VSS.n0 17.0005
R24 VSS.n15 VSS.n0 17.0005
R25 VSS.n32 VSS.n0 17.0005
R26 VSS.n54 VSS.n0 17.0005
R27 VSS.t36 VSS.n13 15.381
R28 VSS.t38 VSS.n9 10.6217
R29 VSS.t46 VSS.t36 11.4073
R30 VSS.n7 VSS.t23 8.42703
R31 VSS.n21 VSS.n0 8.48416
R32 VSS.n20 VSS.n0 8.47732
R33 VSS.n18 VSS.n0 8.47732
R34 VSS.n28 VSS.n0 8.47732
R35 VSS.n26 VSS 8.34175
R36 VSS.n0 VSS.n1 0.00146416
R37 VSS.t30 VSS.n2 6.43469
R38 VSS.n9 VSS.n0 0.595492
R39 VSS.n16 VSS.n0 4.19225
R40 VSS.n25 VSS.n0 4.19225
R41 VSS.n56 VSS.n0 3.32615
R42 VSS.n30 VSS.n0 2.32417
R43 VSS.n48 VSS.n0 2.32406
R44 VSS.n44 VSS.n0 2.0061
R45 VSS.n34 VSS.n0 2.0061
R46 VSS.n37 VSS.n0 1.75596
R47 VSS.n52 VSS.n0 1.75596
R48 VSS.n23 VSS.n0 1.75589
R49 VSS.n39 VSS.n0 1.7558
R50 VSS.n50 VSS.n0 1.55203
R51 VSS.n19 VSS.t15 1.43372
R52 VSS.n17 VSS.t17 1.43372
R53 VSS.n27 VSS.t15 1.42949
R54 VSS.n24 VSS.t17 1.42949
R55 VSS.t8 VSS.t1 1.41891
R56 VSS.t9 VSS.t3 1.41891
R57 VSS.t10 VSS.t5 1.41891
R58 VSS.t11 VSS.t7 1.41891
R59 VSS.t12 VSS.t20 1.3766
R60 VSS.t14 VSS.t12 1.3766
R61 VSS.n3 VSS.t28 1.08867
R62 VSS.n43 VSS.n42 1.16292
R63 VSS.n42 VSS.t34 1.11572
R64 VSS.n22 VSS.t20 1.05423
R65 VSS.t34 VSS.n41 1.05291
R66 VSS.n41 VSS.t14 1.05206
R67 VSS.n22 VSS.t41 1.05131
R68 VSS.n36 VSS.n35 1.03228
R69 VSS.t47 VSS.n36 1.00218
R70 VSS.n43 VSS.t1 0.722752
R71 VSS.n45 VSS.t3 0.722752
R72 VSS.n47 VSS.t5 0.722752
R73 VSS.n49 VSS.t7 0.722752
R74 VSS.n35 VSS.t8 0.722041
R75 VSS.n33 VSS.t9 0.722041
R76 VSS.n31 VSS.t10 0.722041
R77 VSS.n29 VSS.t11 0.722041
R78 VSS.n50 VSS.n17 0.515255
R79 VSS.t15 VSS.t17 0.492336
R80 VSS.n37 VSS.n12 0.472043
R81 VSS.n51 VSS.n50 0.4613
R82 VSS.n23 VSS.t47 0.420422
R83 VSS.n53 VSS.n52 0.417043
R84 VSS.n39 VSS.n38 0.416917
R85 VSS.n40 VSS.n39 0.416191
R86 VSS.n38 VSS.n37 0.416074
R87 VSS.n52 VSS.n51 0.414824
R88 VSS.t41 VSS.n23 0.400161
R89 VSS.n49 VSS.n48 0.374771
R90 VSS.n30 VSS.n29 0.374692
R91 VSS.n44 VSS.n43 0.339754
R92 VSS.n35 VSS.n34 0.339754
R93 VSS.n45 VSS.n44 0.336447
R94 VSS.n34 VSS.n33 0.336447
R95 VSS.n56 VSS.n12 0.321107
R96 VSS.n36 VSS.n0 0.320091
R97 VSS.n56 VSS.n55 0.3186
R98 VSS.n31 VSS.n30 0.307655
R99 VSS.n48 VSS.n47 0.307571
R100 VSS.n22 VSS.n0 0.273426
R101 VSS.n41 VSS.n0 0.273424
R102 VSS.n8 VSS.n0 0.087215
R103 VSS.n16 VSS.n19 0.181924
R104 VSS.n38 VSS.t12 0.167615
R105 VSS.n17 VSS.n16 0.164424
R106 VSS.n25 VSS.n24 0.164424
R107 VSS.n42 VSS.n0 0.161111
R108 VSS.n26 VSS.n25 0.149424
R109 VSS.n51 VSS.t17 0.1171
R110 VSS.n12 VSS 0.1105
R111 VSS.n55 VSS 0.1105
R112 VSS.n19 VSS.n18 0.104618
R113 VSS.n28 VSS.n27 0.104618
R114 VSS.n46 VSS.n45 0.08425
R115 VSS.n33 VSS.n32 0.08425
R116 VSS.n53 VSS.n15 0.0805
R117 VSS.t14 VSS.n20 0.0796176
R118 VSS.n54 VSS.n53 0.07675
R119 VSS.n20 VSS.n40 0.0758676
R120 VSS.n24 VSS.n15 0.07425
R121 VSS.n47 VSS.n46 0.06925
R122 VSS.n32 VSS.n31 0.06925
R123 VSS.t28 VSS.n54 0.06925
R124 VSS.t20 VSS.n21 0.0659331
R125 VSS.n55 VSS 0.0555
R126 VSS.n40 VSS 0.0555
R127 VSS.n18 VSS.n49 0.0496177
R128 VSS.n29 VSS.n28 0.0496177
R129 VSS.n21 VSS.n12 0.0346831
R130 VSS.n27 VSS.n26 0.033
R131 VSS.t35 VSS.n11 98.0782
R132 VSS.n55 VSS.n3 1.24235
R133 VSS.n4 VSS.n0 0.00251526
R134 VSS.t25 VSS.n5 18.3886
R135 VSS.t24 VSS.n7 42.9063
R136 VSS.t16 VSS.n0 18.7779
R137 VSS.n13 VSS.n0 0.00218964
R138 VSS.n14 VSS.n0 0.00184353
R139 VSS.t13 VSS.n0 0.00173994
R140 VSS.n3 VSS.n0 0.00578489
R141 VSS.t29 VSS.n2 72.4152
C38 CURRENT_SINK VSS 0.12345f
C39 CURRENT_SOURCE VSS 0.13759f
C40 VDD VSS 1.245f
C41 a_3921_745# VSS 2.19855f ; **FLOATING
C42 a_255_200# VSS 5.33579f ; **FLOATING
C43 a_3921_1423# VSS 6.40889f ; **FLOATING
C44 a_1331_2287# VSS 3.77945f ; **FLOATING
C45 a_603_649# VSS 13.8355f ; **FLOATING
C46 a_451_2556# VSS 2.41286f ; **FLOATING
C47 a_803_1423# VSS 1.04511f ; **FLOATING
C48 VSS.t28 VSS 3.31349f ; **FLOATING
.ends
