* NGSPICE file created from hx_charge_pump_current_generator.ext - technology: ihp-sg13g2

.subckt hx_charge_pump_current_generator CURRENT_SINK VDD CURRENT_SOURCE VSS
X0 VSS.t14 VSS.t12 VSS.t12 VSS.t13 sg13_lv_nmos ad=0.68p pd=4.68u as=0 ps=0 w=2u l=1u
X1 a_3921_1423# a_3921_1423# VSS.t10 VSS.t4 sg13_lv_nmos ad=0.38p pd=2.38u as=0.68p ps=4.68u w=2u l=1u
X2 CURRENT_SOURCE a_803_1423# VDD VDD sg13_lv_pmos ad=0.38p pd=2.38u as=0.38p ps=2.38u w=2u l=1u
X3 a_1331_2287# a_803_1423# VDD VDD sg13_lv_pmos ad=0.38p pd=2.38u as=0.38p ps=2.38u w=2u l=1u
X4 a_255_200# a_603_649# a_803_1423# VSS.t30 sg13_lv_nmos ad=0.68p pd=4.68u as=0.38p ps=2.38u w=2u l=1u
X5 CURRENT_SINK a_1331_2287# a_3921_745# VSS.t24 sg13_lv_nmos ad=0.38p pd=2.38u as=0.68p ps=4.68u w=2u l=1u
X6 a_803_1423# a_603_649# a_255_200# VSS.t34 sg13_lv_nmos ad=0.42p pd=2.42u as=0.68p ps=4.68u w=2u l=1u
X7 VSS.t15 VSS.t15 VSS.t15 VSS.t16 sg13_lv_nmos ad=0.68p pd=4.68u as=0 ps=0 w=2u l=1u
X8 VDD VDD VDD VDD sg13_lv_pmos ad=0.68p pd=4.68u as=30.9901p ps=0.16929m w=2u l=1u
X9 a_803_1423# a_603_649# a_255_200# VSS.t29 sg13_lv_nmos ad=0.38p pd=2.38u as=0.68p ps=4.68u w=2u l=1u
X10 VDD VDD VDD VDD sg13_lv_pmos ad=0.68p pd=4.68u as=0 ps=0 w=2u l=1u
X11 VSS.t7 a_3921_1423# a_3921_745# VSS.t6 sg13_lv_nmos ad=0.68p pd=4.68u as=0.38p ps=2.38u w=2u l=1u
X12 a_603_649# a_451_2556# a_803_1423# VSS.t37 sg13_lv_nmos ad=0.68p pd=4.68u as=0.38p ps=2.38u w=2u l=1u
X13 a_1331_2287# a_1331_2287# a_3921_1423# VSS.t22 sg13_lv_nmos ad=0.38p pd=2.38u as=0.68p ps=4.68u w=2u l=1u
X14 VDD VDD VDD VDD sg13_lv_pmos ad=0.38p pd=2.38u as=0 ps=0 w=2u l=1u
X15 VDD VDD VDD VDD sg13_lv_pmos ad=0.38p pd=2.38u as=0 ps=0 w=2u l=1u
X16 a_603_649# a_603_649# VSS.t32 VSS.t31 sg13_lv_nmos ad=0.38p pd=2.38u as=0.68p ps=4.68u w=2u l=1u
X17 a_3921_745# a_3921_1423# VSS.t5 VSS.t4 sg13_lv_nmos ad=0.38p pd=2.38u as=0.68p ps=4.68u w=2u l=1u
X18 a_3921_745# a_1331_2287# CURRENT_SINK VSS.t23 sg13_lv_nmos ad=0.68p pd=4.68u as=0.38p ps=2.38u w=2u l=1u
X19 a_255_200# VSS.t15 VSS.t26 rppd l=32u w=1u
X20 VSS.t45 a_603_649# a_451_2556# VSS.t35 sg13_lv_nmos ad=0.68p pd=4.68u as=0.38p ps=2.38u w=2u l=1u
X21 a_451_2556# a_603_649# VSS.t43 VSS.t44 sg13_lv_nmos ad=0.38p pd=2.38u as=0.68p ps=4.68u w=2u l=1u
X22 VDD a_803_1423# a_803_1423# VDD sg13_lv_pmos ad=0.38p pd=2.38u as=0.38p ps=2.38u w=2u l=1u
X23 a_1331_2287# a_803_1423# VDD VDD sg13_lv_pmos ad=0.38p pd=2.38u as=0.38p ps=2.38u w=2u l=1u
X24 VDD a_803_1423# a_603_649# VDD sg13_lv_pmos ad=0.38p pd=2.38u as=0.38p ps=2.38u w=2u l=1u
X25 a_255_200# a_603_649# a_803_1423# VSS.t28 sg13_lv_nmos ad=0.68p pd=4.68u as=0.38p ps=2.38u w=2u l=1u
X26 VSS.t3 a_3921_1423# a_3921_1423# VSS.t2 sg13_lv_nmos ad=0.68p pd=4.68u as=0.38p ps=2.38u w=2u l=1u
X27 VSS.t19 a_603_649# a_451_2556# VSS.t30 sg13_lv_nmos ad=0.68p pd=4.68u as=0.38p ps=2.38u w=2u l=1u
X28 CURRENT_SOURCE a_803_1423# VDD VDD sg13_lv_pmos ad=0.38p pd=2.38u as=0.38p ps=2.38u w=2u l=1u
X29 a_3921_1423# a_1331_2287# a_1331_2287# VSS.t23 sg13_lv_nmos ad=0.68p pd=4.68u as=0.38p ps=2.38u w=2u l=1u
X30 VSS.t19 VSS.t12 VSS.t12 VSS.t13 sg13_lv_nmos ad=0.68p pd=4.68u as=0 ps=0 w=2u l=1u
X31 a_803_1423# a_603_649# a_255_200# VSS.t27 sg13_lv_nmos ad=0.38p pd=2.38u as=0.68p ps=4.68u w=2u l=1u
X32 a_3921_1423# a_3921_1423# VSS.t1 VSS.t0 sg13_lv_nmos ad=0.38p pd=2.38u as=0.68p ps=4.68u w=2u l=1u
X33 a_451_2556# a_603_649# VSS.t19 VSS.t29 sg13_lv_nmos ad=0.38p pd=2.38u as=0.68p ps=4.68u w=2u l=1u
X34 VDD a_803_1423# a_603_649# VDD sg13_lv_pmos ad=0.38p pd=2.38u as=0.38p ps=2.38u w=2u l=1u
X35 VDD a_803_1423# a_803_1423# VDD sg13_lv_pmos ad=0.38p pd=2.38u as=0.38p ps=2.38u w=2u l=1u
X36 VSS.t32 a_603_649# a_603_649# VSS.t33 sg13_lv_nmos ad=0.68p pd=4.68u as=0.38p ps=2.38u w=2u l=1u
X37 VSS.t43 a_603_649# a_451_2556# VSS.t33 sg13_lv_nmos ad=0.76p pd=4.76u as=0.38p ps=2.38u w=2u l=1u
X38 a_803_1423# a_451_2556# a_603_649# VSS.t36 sg13_lv_nmos ad=0.38p pd=2.38u as=0.68p ps=4.68u w=2u l=1u
X39 VSS.t19 a_603_649# a_451_2556# VSS.t28 sg13_lv_nmos ad=0.68p pd=4.68u as=0.38p ps=2.38u w=2u l=1u
X40 VDD a_803_1423# CURRENT_SOURCE VDD sg13_lv_pmos ad=0.38p pd=2.38u as=0.38p ps=2.38u w=2u l=1u
X41 a_603_649# a_803_1423# VDD VDD sg13_lv_pmos ad=0.38p pd=2.38u as=0.38p ps=2.38u w=2u l=1u
X42 VDD a_803_1423# a_1331_2287# VDD sg13_lv_pmos ad=0.38p pd=2.38u as=0.38p ps=2.38u w=2u l=1u
X43 a_3921_745# a_1331_2287# CURRENT_SINK VSS.t25 sg13_lv_nmos ad=0.68p pd=4.68u as=0.38p ps=2.38u w=2u l=1u
X44 VDD a_803_1423# a_1331_2287# VDD sg13_lv_pmos ad=0.38p pd=2.38u as=0.38p ps=2.38u w=2u l=1u
X45 a_803_1423# a_803_1423# VDD VDD sg13_lv_pmos ad=0.38p pd=2.38u as=0.38p ps=2.38u w=2u l=1u
X46 VDD a_803_1423# CURRENT_SOURCE VDD sg13_lv_pmos ad=0.38p pd=2.38u as=0.38p ps=2.38u w=2u l=1u
X47 CURRENT_SINK a_1331_2287# a_3921_745# VSS.t22 sg13_lv_nmos ad=0.38p pd=2.38u as=0.68p ps=4.68u w=2u l=1u
X48 VSS.t11 a_3921_1423# a_3921_1423# VSS.t6 sg13_lv_nmos ad=0.68p pd=4.68u as=0.38p ps=2.38u w=2u l=1u
X49 VSS.t15 VSS.t15 VSS.t15 VSS.t16 sg13_lv_nmos ad=0.68p pd=4.68u as=0 ps=0 w=2u l=1u
X50 a_3921_1423# a_1331_2287# a_1331_2287# VSS.t25 sg13_lv_nmos ad=0.68p pd=4.68u as=0.38p ps=2.38u w=2u l=1u
X51 a_803_1423# a_803_1423# VDD VDD sg13_lv_pmos ad=0.38p pd=2.38u as=0.38p ps=2.38u w=2u l=1u
X52 a_1331_2287# a_1331_2287# a_3921_1423# VSS.t24 sg13_lv_nmos ad=0.38p pd=2.38u as=0.68p ps=4.68u w=2u l=1u
X53 a_603_649# a_803_1423# VDD VDD sg13_lv_pmos ad=0.38p pd=2.38u as=0.38p ps=2.38u w=2u l=1u
X54 a_803_1423# a_603_649# a_255_200# VSS.t36 sg13_lv_nmos ad=0.38p pd=2.38u as=0.68p ps=4.68u w=2u l=1u
X55 VSS.t9 a_3921_1423# a_3921_745# VSS.t2 sg13_lv_nmos ad=0.68p pd=4.68u as=0.38p ps=2.38u w=2u l=1u
X56 VDD a_451_2556# a_451_2556# VDD sg13_lv_pmos ad=0.2448p pd=2.08u as=0.2826p ps=2.29u w=0.36u l=2u
X57 a_3921_745# a_3921_1423# VSS.t8 VSS.t0 sg13_lv_nmos ad=0.38p pd=2.38u as=0.68p ps=4.68u w=2u l=1u
X58 a_255_200# a_603_649# a_803_1423# VSS.t35 sg13_lv_nmos ad=0.68p pd=4.68u as=0.42p ps=2.42u w=2u l=1u
X59 a_451_2556# a_603_649# VSS.t19 VSS.t27 sg13_lv_nmos ad=0.38p pd=2.38u as=0.68p ps=4.68u w=2u l=1u
X60 a_451_2556# a_603_649# VSS.t19 VSS.t31 sg13_lv_nmos ad=0.38p pd=2.38u as=0.68p ps=4.68u w=2u l=1u
X61 a_255_200# a_603_649# a_803_1423# VSS.t37 sg13_lv_nmos ad=0.68p pd=4.68u as=0.38p ps=2.38u w=2u l=1u
C0 a_341_200# a_603_649# 0.12761f
C1 a_3921_1423# a_3921_745# 2.20455f
C2 CURRENT_SINK a_451_2556# 0.01152f
C3 CURRENT_SOURCE a_451_2556# 0.02579f
C4 a_3921_1423# a_603_649# 0.03029f
C5 a_603_649# VDD 1.02877f
C6 a_1331_2287# a_451_2556# 0.01501f
C7 a_1331_2287# a_255_200# 0.02497f
C8 a_3921_1423# CURRENT_SINK 0.17053f
C9 a_341_200# a_1331_2287# 0.03661f
C10 CURRENT_SOURCE VDD 1.17789f
C11 a_803_1423# a_451_2556# 0.32939f
C12 a_3921_745# a_603_649# 0.25721f
C13 a_3921_1423# a_1331_2287# 1.254f
C14 a_803_1423# a_255_200# 0.87631f
C15 a_1331_2287# VDD 1.69217f
C16 a_3921_745# CURRENT_SINK 0.68395f
C17 a_3921_1423# a_803_1423# 0.01269f
C18 a_803_1423# VDD 8.14075f
C19 CURRENT_SOURCE a_603_649# 0.11973f
C20 a_3921_745# a_1331_2287# 0.84817f
C21 a_1331_2287# a_603_649# 0.19218f
C22 a_1331_2287# CURRENT_SINK 0.63956f
C23 a_803_1423# a_603_649# 2.71042f
C24 CURRENT_SOURCE a_1331_2287# 0.13605f
C25 a_255_200# a_451_2556# 2.87939f
C26 a_341_200# a_451_2556# 0.01697f
C27 a_341_200# a_255_200# 0.07051f
C28 a_803_1423# CURRENT_SINK 0.04737f
C29 a_803_1423# CURRENT_SOURCE 1.13406f
C30 a_3921_1423# a_255_200# 0.19787f
C31 a_451_2556# VDD 1.00935f
C32 a_803_1423# a_1331_2287# 1.24846f
C33 a_3921_1423# a_341_200# 0.04218f
C34 a_603_649# a_451_2556# 1.74523f
C35 a_603_649# a_255_200# 1.6143f
R0 VSS.t30 VSS.t15 6.43803
R1 VSS.t36 VSS.t15 11.0392
R2 VSS.t15 VSS.t37 25.8659
R3 VSS.t24 VSS.t15 14.0014
R4 VSS.t23 VSS.t15 19.0163
R5 VSS.t15 VSS.t4 19.1753
R6 VSS.t15 VSS.t6 13.0467
R7 VSS.t16 VSS.t15 18.7797
R8 VSS.t15 VSS.t0 17.5836
R9 VSS.t31 VSS.t15 22.2693
R10 VSS VSS.n78 18.0005
R11 VSS.t15 VSS.t26 24.6445
R12 VSS.t15 VSS.t29 27.7277
R13 VSS.t15 VSS.t13 17.3574
R14 VSS.n2 VSS.n78 0.568216
R15 VSS.t35 VSS.t15 19.1272
R16 VSS.t27 VSS.t15 28.4107
R17 VSS.n4 VSS.t44 8.84343
R18 VSS.n4 VSS.t34 1.47352
R19 VSS.n80 VSS.n15 4.44439
R20 VSS.n221 VSS.n207 9.0005
R21 VSS.n223 VSS.n222 9.0005
R22 VSS.n224 VSS.n74 9.0005
R23 VSS.n226 VSS.n225 9.0005
R24 VSS.n227 VSS.n206 9.0005
R25 VSS.n229 VSS.n228 9.0005
R26 VSS.n233 VSS.n205 9.0005
R27 VSS.n235 VSS.n234 9.0005
R28 VSS.n236 VSS.n72 9.0005
R29 VSS.n238 VSS.n237 9.0005
R30 VSS.n239 VSS.n204 9.0005
R31 VSS.n241 VSS.n240 9.0005
R32 VSS.n245 VSS.n203 9.0005
R33 VSS.n247 VSS.n246 9.0005
R34 VSS.n248 VSS.n70 9.0005
R35 VSS.n250 VSS.n249 9.0005
R36 VSS.n251 VSS.n202 9.0005
R37 VSS.n253 VSS.n252 9.0005
R38 VSS.n257 VSS.n201 9.0005
R39 VSS.n259 VSS.n258 9.0005
R40 VSS.n260 VSS.n68 9.0005
R41 VSS.n262 VSS.n261 9.0005
R42 VSS.n263 VSS.n200 9.0005
R43 VSS.n265 VSS.n264 9.0005
R44 VSS.n209 VSS 9.0005
R45 VSS.n210 VSS 9.0005
R46 VSS VSS.n211 9.0005
R47 VSS.n212 VSS.n76 9.0005
R48 VSS.n214 VSS.n213 9.0005
R49 VSS.n215 VSS.n208 9.0005
R50 VSS.n217 VSS.n216 9.0005
R51 VSS.n218 VSS.n75 9.0005
R52 VSS.n220 VSS.n219 9.0005
R53 VSS.n230 VSS.n73 9.0005
R54 VSS.n232 VSS.n231 9.0005
R55 VSS.n242 VSS.n71 9.0005
R56 VSS.n244 VSS.n243 9.0005
R57 VSS.n254 VSS.n69 9.0005
R58 VSS.n256 VSS.n255 9.0005
R59 VSS.n266 VSS.n67 9.0005
R60 VSS.n268 VSS.n267 9.0005
R61 VSS.n221 VSS.n48 0.114852
R62 VSS.n49 VSS.n8 4.44407
R63 VSS.n49 VSS.n74 0.114852
R64 VSS.n50 VSS.n8 4.44407
R65 VSS.n227 VSS.n50 0.114852
R66 VSS.n51 VSS.n8 4.44407
R67 VSS.n233 VSS.n52 0.114852
R68 VSS.n53 VSS.n8 4.44407
R69 VSS.n53 VSS.n72 0.114852
R70 VSS.n54 VSS.n9 4.44407
R71 VSS.n239 VSS.n54 0.114852
R72 VSS.n55 VSS.n9 4.44407
R73 VSS.n245 VSS.n56 0.114852
R74 VSS.n57 VSS.n9 4.44407
R75 VSS.n57 VSS.n70 0.114852
R76 VSS.n58 VSS.n12 4.44407
R77 VSS.n251 VSS.n58 0.114852
R78 VSS.n59 VSS.n12 4.44407
R79 VSS.n257 VSS.n60 0.114852
R80 VSS.n61 VSS.n12 4.44407
R81 VSS.n61 VSS.n68 0.114852
R82 VSS.n62 VSS.n11 4.44407
R83 VSS.n263 VSS.n62 0.114852
R84 VSS.n63 VSS.n11 4.44407
R85 VSS.n209 VSS.n80 0.114844
R86 VSS.n77 VSS.n15 4.44407
R87 VSS.n211 VSS.n77 0.114852
R88 VSS.n15 VSS.n76 9.0005
R89 VSS.n46 VSS.n15 4.44407
R90 VSS.n215 VSS.n46 0.114852
R91 VSS.n47 VSS.n15 4.44407
R92 VSS.n47 VSS.n75 0.114852
R93 VSS.n48 VSS.n8 4.44407
R94 VSS.n51 VSS.n73 0.114852
R95 VSS.n52 VSS.n8 4.44407
R96 VSS.n55 VSS.n71 0.114852
R97 VSS.n56 VSS.n9 4.44407
R98 VSS.n59 VSS.n69 0.114852
R99 VSS.n60 VSS.n12 4.44407
R100 VSS.n63 VSS.n67 0.114852
R101 VSS.n64 VSS.n11 4.44407
R102 VSS.n20 VSS.n64 0.364303
R103 VSS.n17 VSS.n20 3.09815
R104 VSS.n6 VSS.t14 0.895252
R105 VSS.n169 VSS.t14 9.0005
R106 VSS.n23 VSS.t32 4.44407
R107 VSS.n177 VSS.n27 0.114852
R108 VSS.n184 VSS.n18 9.0005
R109 VSS.n185 VSS.n26 0.114852
R110 VSS.n194 VSS.n19 0.114852
R111 VSS.n19 VSS.n0 4.44407
R112 VSS.n0 VSS.n66 4.44407
R113 VSS.n146 VSS.n66 0.114852
R114 VSS.n44 VSS.n0 4.44407
R115 VSS.n149 VSS.n44 0.114852
R116 VSS.n0 VSS.n81 9.0005
R117 VSS.n79 VSS.n0 4.44407
R118 VSS.n26 VSS.n18 4.44407
R119 VSS.n189 VSS.n188 9.0005
R120 VSS.n190 VSS.n65 0.114852
R121 VSS.n65 VSS.n0 4.44407
R122 VSS.n27 VSS.t32 4.44407
R123 VSS.n179 VSS.t32 9.0005
R124 VSS.n45 VSS.t32 4.44407
R125 VSS.n181 VSS.n45 0.114852
R126 VSS.n24 VSS.n18 4.44407
R127 VSS.n183 VSS.n24 0.114852
R128 VSS.n35 VSS.t14 4.44407
R129 VSS.n171 VSS.n35 0.114852
R130 VSS.n172 VSS.n34 0.114852
R131 VSS.n34 VSS.t32 4.44407
R132 VSS.n14 VSS.n6 1.41697
R133 VSS.n33 VSS.t19 4.44407
R134 VSS.n114 VSS.n33 0.114852
R135 VSS.n115 VSS.n32 0.114852
R136 VSS.n32 VSS.t19 4.44407
R137 VSS.n117 VSS.n22 0.114852
R138 VSS.n22 VSS.t19 4.44407
R139 VSS.n31 VSS.t19 4.44407
R140 VSS.n21 VSS.t43 4.44407
R141 VSS.n129 VSS.n25 0.114852
R142 VSS.n136 VSS.n41 0.114852
R143 VSS.n40 VSS.t45 4.44407
R144 VSS.n144 VSS.n37 0.114852
R145 VSS.n36 VSS.n16 4.44407
R146 VSS.n197 VSS.n36 0.114852
R147 VSS.n198 VSS.n28 0.114852
R148 VSS.n28 VSS.n16 4.44407
R149 VSS.n138 VSS.n40 0.114852
R150 VSS.n39 VSS.t45 4.44407
R151 VSS.n140 VSS.n39 0.114852
R152 VSS.n38 VSS.t45 4.44407
R153 VSS.n142 VSS.n38 0.114852
R154 VSS.n37 VSS.n16 4.44407
R155 VSS.n25 VSS.t43 4.44407
R156 VSS.n131 VSS.n43 0.114852
R157 VSS.n43 VSS.t45 4.44407
R158 VSS.n42 VSS.t45 4.44407
R159 VSS.n134 VSS.n42 0.114852
R160 VSS.n41 VSS.t45 4.44407
R161 VSS.n120 VSS.n31 0.114852
R162 VSS.n30 VSS.t19 4.44407
R163 VSS.n122 VSS.n30 0.114852
R164 VSS.n123 VSS.n29 0.114852
R165 VSS.n29 VSS.t43 4.44407
R166 VSS.n127 VSS.n21 0.114852
R167 VSS.n114 VSS.n113 9.0005
R168 VSS.n115 VSS.n112 9.0005
R169 VSS.n116 VSS.n111 9.0005
R170 VSS.n117 VSS.n110 9.0005
R171 VSS.n118 VSS.n109 9.0005
R172 VSS.n119 VSS.n108 9.0005
R173 VSS.n128 VSS.n103 9.0005
R174 VSS.n129 VSS.n102 9.0005
R175 VSS.n136 VSS.n95 9.0005
R176 VSS.n137 VSS.n94 9.0005
R177 VSS.n144 VSS.n87 9.0005
R178 VSS.n145 VSS.n86 9.0005
R179 VSS.n197 VSS.n85 9.0005
R180 VSS.n198 VSS.n84 9.0005
R181 VSS.n28 VSS.n13 0.615229
R182 VSS.n138 VSS.n93 9.0005
R183 VSS.n139 VSS.n92 9.0005
R184 VSS.n140 VSS.n91 9.0005
R185 VSS.n141 VSS.n90 9.0005
R186 VSS.n142 VSS.n89 9.0005
R187 VSS.n143 VSS.n88 9.0005
R188 VSS.n130 VSS.n101 9.0005
R189 VSS.n131 VSS.n100 9.0005
R190 VSS.n132 VSS.n99 9.0005
R191 VSS.n133 VSS.n98 9.0005
R192 VSS.n134 VSS.n97 9.0005
R193 VSS.n135 VSS.n96 9.0005
R194 VSS.n120 VSS.n107 9.0005
R195 VSS.n121 VSS.n106 9.0005
R196 VSS.n122 VSS.n105 9.0005
R197 VSS.n124 VSS.n123 9.0005
R198 VSS.n125 VSS.n104 9.0005
R199 VSS.n127 VSS.n126 9.0005
R200 VSS.n169 VSS.n14 0.319457
R201 VSS.n170 VSS.n167 9.0005
R202 VSS.n171 VSS.n166 9.0005
R203 VSS.n172 VSS.n165 9.0005
R204 VSS.n173 VSS.n34 9.11485
R205 VSS.n177 VSS.n164 9.0005
R206 VSS.n184 VSS.n157 9.0005
R207 VSS.n185 VSS.n156 9.0005
R208 VSS.n186 VSS.n26 9.11485
R209 VSS.n174 VSS.n23 9.11485
R210 VSS.n178 VSS.n163 9.0005
R211 VSS.n179 VSS.n162 9.0005
R212 VSS.n180 VSS.n161 9.0005
R213 VSS.n181 VSS.n160 9.0005
R214 VSS.n182 VSS.n159 9.0005
R215 VSS.n183 VSS.n158 9.0005
R216 VSS.n195 VSS.n154 9.0005
R217 VSS.n192 VSS.n155 9.0005
R218 VSS.n191 VSS.n190 9.0005
R219 VSS.n189 VSS.n187 9.0005
R220 VSS.n196 VSS.n153 9.0005
R221 VSS.n152 VSS.n146 9.0005
R222 VSS.n151 VSS.n150 9.0005
R223 VSS.n149 VSS.n148 9.0005
R224 VSS.n147 VSS.n81 9.0005
R225 VSS.n199 VSS.n83 9.0005
R226 VSS.n194 VSS.n193 9.0005
R227 VSS.n176 VSS.n175 9.0005
R228 VSS.t25 VSS.t15 19.0162
R229 VSS.n11 VSS.n17 0.247761
R230 VSS.n9 VSS.n10 0.380242
R231 VSS.n8 VSS.t15 0.36552
R232 VSS.n2 VSS.t15 0.325778
R233 VSS.t15 VSS.t19 0.546546
R234 VSS.t15 VSS.t33 17.3532
R235 VSS.n4 VSS.t15 11.9258
R236 VSS.t15 VSS.n18 0.333782
R237 VSS.t15 VSS.t22 8.42964
R238 VSS.t15 VSS.n5 0.853099
R239 VSS.n5 VSS.n168 0.600522
R240 VSS.t15 VSS.n82 1.55301
R241 VSS.t28 VSS.t15 6.43706
R242 VSS.t8 VSS.t1 1.41892
R243 VSS.t9 VSS.t3 1.41892
R244 VSS.t5 VSS.t10 1.41892
R245 VSS.t7 VSS.n1 0.358659
R246 VSS.t14 VSS.t12 1.37661
R247 VSS.t12 VSS.n78 1.37661
R248 VSS.t15 VSS.t2 17.0267
R249 VSS.n16 VSS.t8 0.722582
R250 VSS.t15 VSS.t9 0.722582
R251 VSS.t10 VSS.t15 0.722582
R252 VSS.t11 VSS.n1 0.358839
R253 VSS.t1 VSS.n0 0.72222
R254 VSS.t3 VSS.n0 0.72222
R255 VSS.n0 VSS.t5 0.72222
R256 VSS.n187 VSS.n186 0.692362
R257 VSS.n6 VSS 4.40406
R258 VSS.n174 VSS.n173 0.461741
R259 VSS.n168 VSS.n82 0.459425
R260 VSS.n82 VSS.n78 0.418111
R261 VSS.n213 VSS.n212 0.231121
R262 VSS.n213 VSS.n208 0.231121
R263 VSS.n217 VSS.n208 0.231121
R264 VSS.n218 VSS.n217 0.231121
R265 VSS.n219 VSS.n218 0.231121
R266 VSS.n219 VSS.n207 0.231121
R267 VSS.n223 VSS.n207 0.231121
R268 VSS.n224 VSS.n223 0.231121
R269 VSS.n225 VSS.n224 0.231121
R270 VSS.n225 VSS.n206 0.231121
R271 VSS.n229 VSS.n206 0.231121
R272 VSS.n230 VSS.n229 0.231121
R273 VSS.n231 VSS.n230 0.231121
R274 VSS.n231 VSS.n205 0.231121
R275 VSS.n235 VSS.n205 0.231121
R276 VSS.n236 VSS.n235 0.231121
R277 VSS.n237 VSS.n236 0.231121
R278 VSS.n237 VSS.n204 0.231121
R279 VSS.n241 VSS.n204 0.231121
R280 VSS.n242 VSS.n241 0.231121
R281 VSS.n243 VSS.n242 0.231121
R282 VSS.n243 VSS.n203 0.231121
R283 VSS.n247 VSS.n203 0.231121
R284 VSS.n248 VSS.n247 0.231121
R285 VSS.n249 VSS.n248 0.231121
R286 VSS.n249 VSS.n202 0.231121
R287 VSS.n253 VSS.n202 0.231121
R288 VSS.n254 VSS.n253 0.231121
R289 VSS.n255 VSS.n254 0.231121
R290 VSS.n255 VSS.n201 0.231121
R291 VSS.n259 VSS.n201 0.231121
R292 VSS.n260 VSS.n259 0.231121
R293 VSS.n261 VSS.n260 0.231121
R294 VSS.n261 VSS.n200 0.231121
R295 VSS.n265 VSS.n200 0.231121
R296 VSS.n266 VSS.n265 0.231121
R297 VSS.n267 VSS.n266 0.231121
R298 VSS.n20 VSS.n267 2.60738
R299 VSS.n80 VSS 9.11486
R300 VSS.n210 VSS.n209 0.231121
R301 VSS.n77 VSS.n210 0.114852
R302 VSS.n211 VSS.n76 0.231121
R303 VSS.n214 VSS.n76 0.231121
R304 VSS.n46 VSS.n214 0.114852
R305 VSS.n216 VSS.n215 0.231121
R306 VSS.n216 VSS.n47 0.114852
R307 VSS.n220 VSS.n75 0.231121
R308 VSS.n48 VSS.n220 0.114852
R309 VSS.n222 VSS.n221 0.231121
R310 VSS.n222 VSS.n49 0.114852
R311 VSS.n226 VSS.n74 0.231121
R312 VSS.n50 VSS.n226 0.114852
R313 VSS.n228 VSS.n227 0.231121
R314 VSS.n228 VSS.n51 0.114852
R315 VSS.n232 VSS.n73 0.231121
R316 VSS.n52 VSS.n232 0.114852
R317 VSS.n234 VSS.n233 0.231121
R318 VSS.n234 VSS.n53 0.114852
R319 VSS.n238 VSS.n72 0.231121
R320 VSS.n54 VSS.n238 0.114852
R321 VSS.n240 VSS.n239 0.231121
R322 VSS.n240 VSS.n55 0.114852
R323 VSS.n244 VSS.n71 0.231121
R324 VSS.n56 VSS.n244 0.114852
R325 VSS.n246 VSS.n245 0.231121
R326 VSS.n246 VSS.n57 0.114852
R327 VSS.n250 VSS.n70 0.231121
R328 VSS.n58 VSS.n250 0.114852
R329 VSS.n252 VSS.n251 0.231121
R330 VSS.n252 VSS.n59 0.114852
R331 VSS.n256 VSS.n69 0.231121
R332 VSS.n60 VSS.n256 0.114852
R333 VSS.n258 VSS.n257 0.231121
R334 VSS.n258 VSS.n61 0.114852
R335 VSS.n262 VSS.n68 0.231121
R336 VSS.n62 VSS.n262 0.114852
R337 VSS.n264 VSS.n263 0.231121
R338 VSS.n264 VSS.n63 0.114852
R339 VSS.n268 VSS.n67 0.231121
R340 VSS.n64 VSS.n268 0.114852
R341 VSS.n113 VSS.n112 0.231121
R342 VSS.n112 VSS.n111 0.231121
R343 VSS.n111 VSS.n110 0.231121
R344 VSS.n110 VSS.n109 0.231121
R345 VSS.n109 VSS.n108 0.231121
R346 VSS.n108 VSS.n107 0.231121
R347 VSS.n107 VSS.n106 0.231121
R348 VSS.n106 VSS.n105 0.231121
R349 VSS.n124 VSS.n105 0.231121
R350 VSS.n125 VSS.n124 0.231121
R351 VSS.n126 VSS.n125 0.231121
R352 VSS.n126 VSS.n103 0.231121
R353 VSS.n103 VSS.n102 0.231121
R354 VSS.n102 VSS.n101 0.231121
R355 VSS.n101 VSS.n100 0.231121
R356 VSS.n100 VSS.n99 0.231121
R357 VSS.n99 VSS.n98 0.231121
R358 VSS.n98 VSS.n97 0.231121
R359 VSS.n97 VSS.n96 0.231121
R360 VSS.n96 VSS.n95 0.231121
R361 VSS.n95 VSS.n94 0.231121
R362 VSS.n94 VSS.n93 0.231121
R363 VSS.n93 VSS.n92 0.231121
R364 VSS.n92 VSS.n91 0.231121
R365 VSS.n91 VSS.n90 0.231121
R366 VSS.n90 VSS.n89 0.231121
R367 VSS.n89 VSS.n88 0.231121
R368 VSS.n88 VSS.n87 0.231121
R369 VSS.n87 VSS.n86 0.231121
R370 VSS.n86 VSS.n85 0.231121
R371 VSS.n85 VSS.n84 0.231121
R372 VSS.n84 VSS.n13 1.57313
R373 VSS.n13 VSS.t15 1.1555
R374 VSS.n33 VSS 9.11485
R375 VSS.n115 VSS.n114 0.231121
R376 VSS.n116 VSS.n32 0.114852
R377 VSS.n117 VSS.n116 0.231121
R378 VSS.n118 VSS.n22 0.114852
R379 VSS.n119 VSS.n118 0.231121
R380 VSS.n31 VSS.n119 0.114852
R381 VSS.n121 VSS.n120 0.231121
R382 VSS.n30 VSS.n121 0.114852
R383 VSS.n123 VSS.n122 0.231121
R384 VSS.n29 VSS.n104 0.114852
R385 VSS.n127 VSS.n104 0.231121
R386 VSS.n128 VSS.n21 0.114852
R387 VSS.n129 VSS.n128 0.231121
R388 VSS.n130 VSS.n25 0.114852
R389 VSS.n131 VSS.n130 0.231121
R390 VSS.n132 VSS.n43 0.114852
R391 VSS.n133 VSS.n132 0.231121
R392 VSS.n42 VSS.n133 0.114852
R393 VSS.n135 VSS.n134 0.231121
R394 VSS.n41 VSS.n135 0.114852
R395 VSS.n137 VSS.n136 0.231121
R396 VSS.n40 VSS.n137 0.114852
R397 VSS.n139 VSS.n138 0.231121
R398 VSS.n39 VSS.n139 0.114852
R399 VSS.n141 VSS.n140 0.231121
R400 VSS.n38 VSS.n141 0.114852
R401 VSS.n143 VSS.n142 0.231121
R402 VSS.n37 VSS.n143 0.114852
R403 VSS.n145 VSS.n144 0.231121
R404 VSS.n36 VSS.n145 0.114852
R405 VSS.n198 VSS.n197 0.231121
R406 VSS.n170 VSS.n169 0.231121
R407 VSS.n35 VSS.n170 0.114852
R408 VSS.n172 VSS.n171 0.231121
R409 VSS.n14 VSS.n167 2.53844
R410 VSS.n167 VSS.n166 0.231121
R411 VSS.n166 VSS.n165 0.231121
R412 VSS.n173 VSS.n165 0.231121
R413 VSS.n175 VSS.n174 0.231121
R414 VSS.n175 VSS.n164 0.231121
R415 VSS.n164 VSS.n163 0.231121
R416 VSS.n163 VSS.n162 0.231121
R417 VSS.n162 VSS.n161 0.231121
R418 VSS.n161 VSS.n160 0.231121
R419 VSS.n160 VSS.n159 0.231121
R420 VSS.n159 VSS.n158 0.231121
R421 VSS.n158 VSS.n157 0.231121
R422 VSS.n157 VSS.n156 0.231121
R423 VSS.n186 VSS.n156 0.231121
R424 VSS.n191 VSS.n187 0.231121
R425 VSS.n192 VSS.n191 0.231121
R426 VSS.n193 VSS.n192 0.231121
R427 VSS.n193 VSS.n154 0.231121
R428 VSS.n154 VSS.n153 0.231121
R429 VSS.n153 VSS.n152 0.231121
R430 VSS.n152 VSS.n151 0.231121
R431 VSS.n151 VSS.n148 0.231121
R432 VSS.n148 VSS.n147 0.231121
R433 VSS.n147 VSS.n83 0.231121
R434 VSS.n83 VSS.n7 1.97954
R435 VSS.n7 VSS.t15 1.9069
R436 VSS.t43 VSS.t15 0.269964
R437 VSS.n12 VSS.n11 1.37512
R438 VSS.n8 VSS.n9 1.37512
R439 VSS.n10 VSS.n12 0.380242
R440 VSS.n176 VSS.n23 0.114852
R441 VSS.n177 VSS.n176 0.231121
R442 VSS.n178 VSS.n27 0.114852
R443 VSS.n179 VSS.n178 0.231121
R444 VSS.n180 VSS.n179 0.231121
R445 VSS.n45 VSS.n180 0.114852
R446 VSS.n182 VSS.n181 0.231121
R447 VSS.n24 VSS.n182 0.114852
R448 VSS.n184 VSS.n183 0.231121
R449 VSS.n185 VSS.n184 0.231121
R450 VSS.n190 VSS.n189 0.231121
R451 VSS.n65 VSS.n155 0.114852
R452 VSS.n194 VSS.n155 0.231121
R453 VSS.n195 VSS.n19 0.114852
R454 VSS.n196 VSS.n195 0.231121
R455 VSS.n196 VSS.n66 0.114852
R456 VSS.n150 VSS.n146 0.231121
R457 VSS.n150 VSS.n44 0.114852
R458 VSS.n149 VSS.n81 0.231121
R459 VSS.n199 VSS.n81 0.231121
R460 VSS.n79 VSS.n199 0.114852
R461 VSS.n7 VSS.n79 0.474586
R462 VSS.t12 VSS.n168 0.167615
R463 VSS.n188 VSS.n18 1.31528
R464 VSS.n3 VSS.t15 0.268875
R465 VSS.n78 VSS.t19 1.19327
R466 VSS.t15 VSS.n0 1.18575
R467 VSS.n3 VSS.t45 0.184917
R468 VSS.n188 VSS.n0 0.995305
R469 VSS.t14 VSS.n5 0.972658
R470 VSS.t32 VSS.t15 0.278947
R471 VSS.n17 VSS.t15 0.403674
R472 VSS.n212 VSS 0.922983
R473 VSS.n113 VSS 0.922983
R474 VSS.n3 VSS.n16 0.417579
R475 VSS.n15 VSS.n2 0.373407
R476 VSS.t15 VSS.n1 1.06818
R477 VSS.n10 VSS.t15 1.06479
R478 VSS.t32 VSS.t14 1.02128
C36 CURRENT_SINK VSS 0.1489f
C37 CURRENT_SOURCE VSS 0.04312f
C38 VDD VSS 4.43397f
C39 a_3921_745# VSS 2.35f ; **FLOATING
C40 a_255_200# VSS 5.97722f ; **FLOATING
C41 a_3921_1423# VSS 6.67258f ; **FLOATING
C42 a_1331_2287# VSS 3.79893f ; **FLOATING
C43 a_603_649# VSS 17.1218f ; **FLOATING
C44 a_451_2556# VSS 2.53824f ; **FLOATING
C45 a_803_1423# VSS 1.17658f ; **FLOATING
C46 VSS.t15 VSS 3.78188f ; **FLOATING
.ends
