* NGSPICE file created from hx_charge_pump_current_generator.ext - technology: ihp-sg13g2

.subckt hx_charge_pump_current_generator CURRENT_SINK VDD CURRENT_SOURCE VSS
X0 VSS.t14 VSS.t12 VSS.t12 VSS.t13 sg13_lv_nmos ad=0.68p pd=4.68u as=0 ps=0 w=2u l=1u
X1 a_3921_1423# a_3921_1423# VSS.t10 VSS.t4 sg13_lv_nmos ad=0.38p pd=2.38u as=0.68p ps=4.68u w=2u l=1u
X2 CURRENT_SOURCE a_803_1423# VDD VDD sg13_lv_pmos ad=0.38p pd=2.38u as=0.38p ps=2.38u w=2u l=1u
X3 a_1331_2287# a_803_1423# VDD VDD sg13_lv_pmos ad=0.38p pd=2.38u as=0.38p ps=2.38u w=2u l=1u
X4 a_255_200# a_603_649# a_803_1423# VSS.t32 sg13_lv_nmos ad=0.68p pd=4.68u as=0.38p ps=2.38u w=2u l=1u
X5 CURRENT_SINK a_1331_2287# a_3921_745# VSS.t25 sg13_lv_nmos ad=0.38p pd=2.38u as=0.68p ps=4.68u w=2u l=1u
X6 a_803_1423# a_603_649# a_255_200# VSS.t36 sg13_lv_nmos ad=0.42p pd=2.42u as=0.68p ps=4.68u w=2u l=1u
X7 VSS.t17 VSS.t15 VSS.t15 VSS.t16 sg13_lv_nmos ad=0.68p pd=4.68u as=0 ps=0 w=2u l=1u
X8 VDD VDD VDD VDD sg13_lv_pmos ad=0.68p pd=4.68u as=30.9901p ps=0.16929m w=2u l=1u
X9 a_803_1423# a_603_649# a_255_200# VSS.t31 sg13_lv_nmos ad=0.38p pd=2.38u as=0.68p ps=4.68u w=2u l=1u
X10 VDD VDD VDD VDD sg13_lv_pmos ad=0.68p pd=4.68u as=0 ps=0 w=2u l=1u
X11 VSS.t7 a_3921_1423# a_3921_745# VSS.t6 sg13_lv_nmos ad=0.68p pd=4.68u as=0.38p ps=2.38u w=2u l=1u
X12 a_603_649# a_451_2556# a_803_1423# VSS.t39 sg13_lv_nmos ad=0.68p pd=4.68u as=0.38p ps=2.38u w=2u l=1u
X13 a_1331_2287# a_1331_2287# a_3921_1423# VSS.t23 sg13_lv_nmos ad=0.38p pd=2.38u as=0.68p ps=4.68u w=2u l=1u
X14 VDD VDD VDD VDD sg13_lv_pmos ad=0.38p pd=2.38u as=0 ps=0 w=2u l=1u
X15 VDD VDD VDD VDD sg13_lv_pmos ad=0.38p pd=2.38u as=0 ps=0 w=2u l=1u
X16 a_603_649# a_603_649# VSS.t14 VSS.t33 sg13_lv_nmos ad=0.38p pd=2.38u as=0.68p ps=4.68u w=2u l=1u
X17 a_3921_745# a_3921_1423# VSS.t5 VSS.t4 sg13_lv_nmos ad=0.38p pd=2.38u as=0.68p ps=4.68u w=2u l=1u
X18 a_3921_745# a_1331_2287# CURRENT_SINK VSS.t24 sg13_lv_nmos ad=0.68p pd=4.68u as=0.38p ps=2.38u w=2u l=1u
X19 a_255_200# VSS.t28 VSS.t27 rppd l=32u w=1u
X20 VSS.t47 a_603_649# a_451_2556# VSS.t37 sg13_lv_nmos ad=0.68p pd=4.68u as=0.38p ps=2.38u w=2u l=1u
X21 a_451_2556# a_603_649# VSS.t45 VSS.t46 sg13_lv_nmos ad=0.38p pd=2.38u as=0.68p ps=4.68u w=2u l=1u
X22 VDD a_803_1423# a_803_1423# VDD sg13_lv_pmos ad=0.38p pd=2.38u as=0.38p ps=2.38u w=2u l=1u
X23 a_1331_2287# a_803_1423# VDD VDD sg13_lv_pmos ad=0.38p pd=2.38u as=0.38p ps=2.38u w=2u l=1u
X24 VDD a_803_1423# a_603_649# VDD sg13_lv_pmos ad=0.38p pd=2.38u as=0.38p ps=2.38u w=2u l=1u
X25 a_255_200# a_603_649# a_803_1423# VSS.t30 sg13_lv_nmos ad=0.68p pd=4.68u as=0.38p ps=2.38u w=2u l=1u
X26 VSS.t3 a_3921_1423# a_3921_1423# VSS.t2 sg13_lv_nmos ad=0.68p pd=4.68u as=0.38p ps=2.38u w=2u l=1u
X27 VSS.t20 a_603_649# a_451_2556# VSS.t32 sg13_lv_nmos ad=0.68p pd=4.68u as=0.38p ps=2.38u w=2u l=1u
X28 CURRENT_SOURCE a_803_1423# VDD VDD sg13_lv_pmos ad=0.38p pd=2.38u as=0.38p ps=2.38u w=2u l=1u
X29 a_3921_1423# a_1331_2287# a_1331_2287# VSS.t24 sg13_lv_nmos ad=0.68p pd=4.68u as=0.38p ps=2.38u w=2u l=1u
X30 VSS.t20 VSS.t12 VSS.t12 VSS.t13 sg13_lv_nmos ad=0.68p pd=4.68u as=0 ps=0 w=2u l=1u
X31 a_803_1423# a_603_649# a_255_200# VSS.t29 sg13_lv_nmos ad=0.38p pd=2.38u as=0.68p ps=4.68u w=2u l=1u
X32 a_3921_1423# a_3921_1423# VSS.t1 VSS.t0 sg13_lv_nmos ad=0.38p pd=2.38u as=0.68p ps=4.68u w=2u l=1u
X33 a_451_2556# a_603_649# VSS.t20 VSS.t31 sg13_lv_nmos ad=0.38p pd=2.38u as=0.68p ps=4.68u w=2u l=1u
X34 VDD a_803_1423# a_603_649# VDD sg13_lv_pmos ad=0.38p pd=2.38u as=0.38p ps=2.38u w=2u l=1u
X35 VDD a_803_1423# a_803_1423# VDD sg13_lv_pmos ad=0.38p pd=2.38u as=0.38p ps=2.38u w=2u l=1u
X36 VSS.t35 a_603_649# a_603_649# VSS.t34 sg13_lv_nmos ad=0.68p pd=4.68u as=0.38p ps=2.38u w=2u l=1u
X37 VSS.t45 a_603_649# a_451_2556# VSS.t34 sg13_lv_nmos ad=0.76p pd=4.76u as=0.38p ps=2.38u w=2u l=1u
X38 a_803_1423# a_451_2556# a_603_649# VSS.t38 sg13_lv_nmos ad=0.38p pd=2.38u as=0.68p ps=4.68u w=2u l=1u
X39 VSS.t20 a_603_649# a_451_2556# VSS.t30 sg13_lv_nmos ad=0.68p pd=4.68u as=0.38p ps=2.38u w=2u l=1u
X40 VDD a_803_1423# CURRENT_SOURCE VDD sg13_lv_pmos ad=0.38p pd=2.38u as=0.38p ps=2.38u w=2u l=1u
X41 a_603_649# a_803_1423# VDD VDD sg13_lv_pmos ad=0.38p pd=2.38u as=0.38p ps=2.38u w=2u l=1u
X42 VDD a_803_1423# a_1331_2287# VDD sg13_lv_pmos ad=0.38p pd=2.38u as=0.38p ps=2.38u w=2u l=1u
X43 a_3921_745# a_1331_2287# CURRENT_SINK VSS.t26 sg13_lv_nmos ad=0.68p pd=4.68u as=0.38p ps=2.38u w=2u l=1u
X44 VDD a_803_1423# a_1331_2287# VDD sg13_lv_pmos ad=0.38p pd=2.38u as=0.38p ps=2.38u w=2u l=1u
X45 a_803_1423# a_803_1423# VDD VDD sg13_lv_pmos ad=0.38p pd=2.38u as=0.38p ps=2.38u w=2u l=1u
X46 VDD a_803_1423# CURRENT_SOURCE VDD sg13_lv_pmos ad=0.38p pd=2.38u as=0.38p ps=2.38u w=2u l=1u
X47 CURRENT_SINK a_1331_2287# a_3921_745# VSS.t23 sg13_lv_nmos ad=0.38p pd=2.38u as=0.68p ps=4.68u w=2u l=1u
X48 VSS.t11 a_3921_1423# a_3921_1423# VSS.t6 sg13_lv_nmos ad=0.68p pd=4.68u as=0.38p ps=2.38u w=2u l=1u
X49 VSS.t17 VSS.t15 VSS.t15 VSS.t16 sg13_lv_nmos ad=0.68p pd=4.68u as=0 ps=0 w=2u l=1u
X50 a_3921_1423# a_1331_2287# a_1331_2287# VSS.t26 sg13_lv_nmos ad=0.68p pd=4.68u as=0.38p ps=2.38u w=2u l=1u
X51 a_803_1423# a_803_1423# VDD VDD sg13_lv_pmos ad=0.38p pd=2.38u as=0.38p ps=2.38u w=2u l=1u
X52 a_1331_2287# a_1331_2287# a_3921_1423# VSS.t25 sg13_lv_nmos ad=0.38p pd=2.38u as=0.68p ps=4.68u w=2u l=1u
X53 a_603_649# a_803_1423# VDD VDD sg13_lv_pmos ad=0.38p pd=2.38u as=0.38p ps=2.38u w=2u l=1u
X54 a_803_1423# a_603_649# a_255_200# VSS.t38 sg13_lv_nmos ad=0.38p pd=2.38u as=0.68p ps=4.68u w=2u l=1u
X55 VSS.t9 a_3921_1423# a_3921_745# VSS.t2 sg13_lv_nmos ad=0.68p pd=4.68u as=0.38p ps=2.38u w=2u l=1u
X56 VDD a_451_2556# a_451_2556# VDD sg13_lv_pmos ad=0.2448p pd=2.08u as=0.2826p ps=2.29u w=0.36u l=2u
X57 a_3921_745# a_3921_1423# VSS.t8 VSS.t0 sg13_lv_nmos ad=0.38p pd=2.38u as=0.68p ps=4.68u w=2u l=1u
X58 a_255_200# a_603_649# a_803_1423# VSS.t37 sg13_lv_nmos ad=0.68p pd=4.68u as=0.42p ps=2.42u w=2u l=1u
X59 a_451_2556# a_603_649# VSS.t20 VSS.t29 sg13_lv_nmos ad=0.38p pd=2.38u as=0.68p ps=4.68u w=2u l=1u
X60 a_451_2556# a_603_649# VSS.t20 VSS.t33 sg13_lv_nmos ad=0.38p pd=2.38u as=0.68p ps=4.68u w=2u l=1u
X61 a_255_200# a_603_649# a_803_1423# VSS.t39 sg13_lv_nmos ad=0.68p pd=4.68u as=0.38p ps=2.38u w=2u l=1u
C0 a_803_1423# a_1331_2287# 1.24846f
C1 a_3921_745# a_1331_2287# 0.84817f
C2 CURRENT_SOURCE a_1331_2287# 0.13605f
C3 a_803_1423# a_451_2556# 0.32939f
C4 a_603_649# VDD 1.02877f
C5 CURRENT_SOURCE a_451_2556# 0.02579f
C6 a_603_649# a_341_200# 0.12761f
C7 a_255_200# a_341_200# 0.07051f
C8 VDD a_1331_2287# 1.69217f
C9 a_341_200# a_1331_2287# 0.03661f
C10 CURRENT_SINK a_1331_2287# 0.63956f
C11 a_603_649# a_255_200# 1.6143f
C12 a_603_649# a_1331_2287# 0.19218f
C13 a_451_2556# VDD 1.00935f
C14 a_451_2556# a_341_200# 0.01697f
C15 a_803_1423# a_3921_1423# 0.01269f
C16 CURRENT_SINK a_451_2556# 0.01152f
C17 a_255_200# a_1331_2287# 0.02497f
C18 a_3921_745# a_3921_1423# 2.20455f
C19 a_603_649# a_451_2556# 1.74523f
C20 a_803_1423# CURRENT_SOURCE 1.13406f
C21 a_255_200# a_451_2556# 2.87939f
C22 a_451_2556# a_1331_2287# 0.01501f
C23 a_3921_1423# a_341_200# 0.04218f
C24 a_803_1423# VDD 8.14075f
C25 CURRENT_SINK a_3921_1423# 0.17053f
C26 a_803_1423# CURRENT_SINK 0.04737f
C27 CURRENT_SOURCE VDD 1.17789f
C28 a_603_649# a_3921_1423# 0.03029f
C29 CURRENT_SINK a_3921_745# 0.68395f
C30 a_803_1423# a_603_649# 2.71042f
C31 a_603_649# a_3921_745# 0.25721f
C32 a_255_200# a_3921_1423# 0.19787f
C33 a_603_649# CURRENT_SOURCE 0.11973f
C34 a_3921_1423# a_1331_2287# 1.254f
C35 a_803_1423# a_255_200# 0.87631f
R0 VSS.t32 VSS.t35 6.43755
R1 VSS.t38 VSS.t35 11.0391
R2 VSS.t27 VSS.t35 24.6442
R3 VSS.t29 VSS.t35 28.4109
R4 VSS.t35 VSS.t31 27.7278
R5 VSS.t24 VSS.t35 19.0167
R6 VSS.t4 VSS.t35 19.1756
R7 VSS.t25 VSS.t35 14.0003
R8 VSS.t35 VSS.t0 17.5845
R9 VSS VSS.n71 18.0005
R10 VSS.t35 VSS.t2 17.0258
R11 VSS.t35 VSS.t37 19.1271
R12 VSS.t35 VSS.t33 22.2695
R13 VSS.t13 VSS.t35 17.3563
R14 VSS.t36 VSS.n9 1.47349
R15 VSS.t35 VSS.t6 13.0464
R16 VSS.t35 VSS.n9 11.9255
R17 VSS.n201 VSS.n190 9.0005
R18 VSS.n203 VSS.n202 9.0005
R19 VSS.n204 VSS.n69 9.0005
R20 VSS.n206 VSS.n205 9.0005
R21 VSS.n207 VSS.n189 9.0005
R22 VSS.n209 VSS.n208 9.0005
R23 VSS.n213 VSS.n188 9.0005
R24 VSS.n215 VSS.n214 9.0005
R25 VSS.n216 VSS.n67 9.0005
R26 VSS.n218 VSS.n217 9.0005
R27 VSS.n219 VSS.n187 9.0005
R28 VSS.n221 VSS.n220 9.0005
R29 VSS.n225 VSS.n186 9.0005
R30 VSS.n227 VSS.n226 9.0005
R31 VSS.n228 VSS.n65 9.0005
R32 VSS.n230 VSS.n229 9.0005
R33 VSS.n231 VSS.n185 9.0005
R34 VSS.n233 VSS.n232 9.0005
R35 VSS.n237 VSS.n184 9.0005
R36 VSS.n239 VSS.n238 9.0005
R37 VSS.n240 VSS.n63 9.0005
R38 VSS.n17 VSS 3.08816
R39 VSS VSS.n192 9.0005
R40 VSS VSS.n8 9.0005
R41 VSS.n194 VSS.n193 9.0005
R42 VSS.n195 VSS.n191 9.0005
R43 VSS.n197 VSS.n196 9.0005
R44 VSS.n198 VSS.n70 9.0005
R45 VSS.n200 VSS.n199 9.0005
R46 VSS.n210 VSS.n68 9.0005
R47 VSS.n212 VSS.n211 9.0005
R48 VSS.n222 VSS.n66 9.0005
R49 VSS.n224 VSS.n223 9.0005
R50 VSS.n234 VSS.n64 9.0005
R51 VSS.n236 VSS.n235 9.0005
R52 VSS.n201 VSS.n36 0.114852
R53 VSS.n36 VSS.n0 4.44407
R54 VSS.n37 VSS.n69 0.114852
R55 VSS.n37 VSS.n0 4.44407
R56 VSS.n207 VSS.n38 0.114852
R57 VSS.n38 VSS.n12 4.44407
R58 VSS.n213 VSS.n40 0.114852
R59 VSS.n40 VSS.n12 4.44407
R60 VSS.n41 VSS.n67 0.114852
R61 VSS.n41 VSS.n12 4.44407
R62 VSS.n219 VSS.n42 0.114852
R63 VSS.n42 VSS.n12 4.44407
R64 VSS.n225 VSS.n44 0.114852
R65 VSS.n44 VSS.n12 4.44407
R66 VSS.n45 VSS.n65 0.114852
R67 VSS.n45 VSS.n12 4.44407
R68 VSS.n231 VSS.n46 0.114852
R69 VSS.n46 VSS.n13 4.44407
R70 VSS.n237 VSS.n48 0.114852
R71 VSS.n48 VSS.n13 4.44407
R72 VSS.n49 VSS.n63 0.114852
R73 VSS.n49 VSS.n13 4.44407
R74 VSS.n33 VSS.n8 0.114852
R75 VSS.n33 VSS.n0 4.44407
R76 VSS.n195 VSS.n34 0.114852
R77 VSS.n34 VSS.n0 4.44407
R78 VSS.n35 VSS.n70 0.114852
R79 VSS.n35 VSS.n0 4.44407
R80 VSS.n39 VSS.n68 0.114852
R81 VSS.n39 VSS.n12 4.44407
R82 VSS.n43 VSS.n66 0.114852
R83 VSS.n43 VSS.n12 4.44407
R84 VSS.n47 VSS.n64 0.114852
R85 VSS.n47 VSS.n13 4.44407
R86 VSS.n10 VSS.t14 0.895252
R87 VSS.n156 VSS.t14 9.0005
R88 VSS.n21 VSS.t35 4.44407
R89 VSS.n164 VSS.t35 9.0005
R90 VSS.n171 VSS.t35 9.0005
R91 VSS.n172 VSS.n23 0.114852
R92 VSS.n180 VSS.n18 0.114852
R93 VSS.n18 VSS.n16 4.44407
R94 VSS.n16 VSS.n62 4.44407
R95 VSS.n135 VSS.n62 0.114852
R96 VSS.n57 VSS.n16 4.44407
R97 VSS.n137 VSS.n57 0.114852
R98 VSS.n16 VSS.n73 9.0005
R99 VSS.n23 VSS.t35 4.44407
R100 VSS.n175 VSS.t35 9.0005
R101 VSS.n176 VSS.n58 0.114852
R102 VSS.n58 VSS.n16 4.44407
R103 VSS.n30 VSS.t35 4.44407
R104 VSS.n166 VSS.n30 0.114852
R105 VSS.n29 VSS.t35 4.44407
R106 VSS.n168 VSS.n29 0.114852
R107 VSS.n169 VSS.n59 0.114852
R108 VSS.n59 VSS.t35 4.44407
R109 VSS.n32 VSS.t14 4.44407
R110 VSS.n158 VSS.n32 0.114852
R111 VSS.n159 VSS.n31 0.114852
R112 VSS.n31 VSS.t14 4.44407
R113 VSS.n15 VSS.n10 1.41697
R114 VSS.n28 VSS.t20 4.44407
R115 VSS.n103 VSS.n28 0.114852
R116 VSS.n104 VSS.n27 0.114852
R117 VSS.n27 VSS.t20 4.44407
R118 VSS.n106 VSS.n20 0.114852
R119 VSS.n20 VSS.t20 4.44407
R120 VSS.n26 VSS.t20 4.44407
R121 VSS.n19 VSS.t45 4.44407
R122 VSS.n118 VSS.n22 0.114852
R123 VSS.n125 VSS.n54 0.114852
R124 VSS.n53 VSS.t47 4.44407
R125 VSS.n133 VSS.n50 0.114852
R126 VSS.n134 VSS.n1 9.0005
R127 VSS.n183 VSS.n61 0.114852
R128 VSS.n61 VSS.n1 4.44407
R129 VSS.n127 VSS.n53 0.114852
R130 VSS.n52 VSS.t47 4.44407
R131 VSS.n129 VSS.n52 0.114852
R132 VSS.n51 VSS.t47 4.44407
R133 VSS.n131 VSS.n51 0.114852
R134 VSS.n50 VSS.t47 4.44407
R135 VSS.n22 VSS.t45 4.44407
R136 VSS.n120 VSS.n56 0.114852
R137 VSS.n56 VSS.t47 4.44407
R138 VSS.n55 VSS.t47 4.44407
R139 VSS.n123 VSS.n55 0.114852
R140 VSS.n54 VSS.t47 4.44407
R141 VSS.n109 VSS.n26 0.114852
R142 VSS.n25 VSS.t20 4.44407
R143 VSS.n111 VSS.n25 0.114852
R144 VSS.n112 VSS.n24 0.114852
R145 VSS.n24 VSS.t45 4.44407
R146 VSS.n116 VSS.n19 0.114852
R147 VSS.n103 VSS.n102 9.0005
R148 VSS.n104 VSS.n101 9.0005
R149 VSS.n105 VSS.n100 9.0005
R150 VSS.n106 VSS.n99 9.0005
R151 VSS.n107 VSS.n98 9.0005
R152 VSS.n108 VSS.n97 9.0005
R153 VSS.n117 VSS.n92 9.0005
R154 VSS.n118 VSS.n91 9.0005
R155 VSS.n125 VSS.n84 9.0005
R156 VSS.n126 VSS.n83 9.0005
R157 VSS.n133 VSS.n76 9.0005
R158 VSS.n134 VSS.n75 9.0005
R159 VSS.n183 VSS.n74 9.0005
R160 VSS.n127 VSS.n82 9.0005
R161 VSS.n128 VSS.n81 9.0005
R162 VSS.n129 VSS.n80 9.0005
R163 VSS.n130 VSS.n79 9.0005
R164 VSS.n131 VSS.n78 9.0005
R165 VSS.n132 VSS.n77 9.0005
R166 VSS.n119 VSS.n90 9.0005
R167 VSS.n120 VSS.n89 9.0005
R168 VSS.n121 VSS.n88 9.0005
R169 VSS.n122 VSS.n87 9.0005
R170 VSS.n123 VSS.n86 9.0005
R171 VSS.n124 VSS.n85 9.0005
R172 VSS.n109 VSS.n96 9.0005
R173 VSS.n110 VSS.n95 9.0005
R174 VSS.n111 VSS.n94 9.0005
R175 VSS.n113 VSS.n112 9.0005
R176 VSS.n114 VSS.n93 9.0005
R177 VSS.n116 VSS.n115 9.0005
R178 VSS.n156 VSS.n15 0.319457
R179 VSS.n157 VSS.n155 9.0005
R180 VSS.n158 VSS.n154 9.0005
R181 VSS.n159 VSS.n153 9.0005
R182 VSS.n160 VSS.n31 9.11485
R183 VSS.n164 VSS.n152 9.0005
R184 VSS.n171 VSS.n145 9.0005
R185 VSS.n172 VSS.n144 9.0005
R186 VSS.n173 VSS.n23 9.11485
R187 VSS.n161 VSS.n21 9.11485
R188 VSS.n165 VSS.n151 9.0005
R189 VSS.n166 VSS.n150 9.0005
R190 VSS.n167 VSS.n149 9.0005
R191 VSS.n168 VSS.n148 9.0005
R192 VSS.n169 VSS.n147 9.0005
R193 VSS.n170 VSS.n146 9.0005
R194 VSS.n181 VSS.n142 9.0005
R195 VSS.n178 VSS.n143 9.0005
R196 VSS.n177 VSS.n176 9.0005
R197 VSS.n175 VSS.n174 9.0005
R198 VSS.n182 VSS.n141 9.0005
R199 VSS.n140 VSS.n135 9.0005
R200 VSS.n139 VSS.n138 9.0005
R201 VSS.n137 VSS.n136 9.0005
R202 VSS.n3 VSS.n73 0.442785
R203 VSS.n3 VSS.n2 1.41315
R204 VSS.n180 VSS.n179 9.0005
R205 VSS.n163 VSS.n162 9.0005
R206 VSS.n13 VSS.n6 0.27854
R207 VSS.n6 VSS.n12 1.47453
R208 VSS.n12 VSS.n0 1.54486
R209 VSS.t35 VSS.n1 0.58245
R210 VSS.t45 VSS.t47 0.568767
R211 VSS.t35 VSS.t20 0.518895
R212 VSS.n4 VSS.n2 0.789752
R213 VSS.n4 VSS.n16 0.111787
R214 VSS.t35 VSS.t14 0.379115
R215 VSS.t35 VSS.t34 17.3545
R216 VSS.t39 VSS.t35 25.8667
R217 VSS.t26 VSS.t35 19.0169
R218 VSS.t16 VSS.t35 18.7791
R219 VSS.t35 VSS.t23 8.42949
R220 VSS.n7 VSS.n71 0.381353
R221 VSS.t15 VSS.n72 0.210902
R222 VSS.n2 VSS.n72 0.612661
R223 VSS.n1 VSS.t15 1.42949
R224 VSS.t35 VSS.t30 6.43705
R225 VSS.t8 VSS.t1 1.41892
R226 VSS.t9 VSS.t3 1.41892
R227 VSS.t5 VSS.t10 1.41892
R228 VSS.t7 VSS.t11 1.41892
R229 VSS.t14 VSS.t12 1.37661
R230 VSS.t12 VSS.n7 0.191681
R231 VSS.n9 VSS.t46 8.84346
R232 VSS.n1 VSS.t8 0.722582
R233 VSS.n1 VSS.t9 0.722582
R234 VSS.t10 VSS.n1 0.722582
R235 VSS.t11 VSS.n1 0.722582
R236 VSS.t1 VSS.n16 0.72222
R237 VSS.t3 VSS.n16 0.72222
R238 VSS.n2 VSS.t5 0.72222
R239 VSS.n2 VSS.t7 0.72222
R240 VSS.n174 VSS.n173 0.692362
R241 VSS.n72 VSS.t17 0.210902
R242 VSS.n10 VSS 4.40406
R243 VSS.n161 VSS.n160 0.461741
R244 VSS.n7 VSS.t35 0.627152
R245 VSS.n193 VSS.n191 0.231121
R246 VSS.n197 VSS.n191 0.231121
R247 VSS.n198 VSS.n197 0.231121
R248 VSS.n199 VSS.n198 0.231121
R249 VSS.n199 VSS.n190 0.231121
R250 VSS.n203 VSS.n190 0.231121
R251 VSS.n204 VSS.n203 0.231121
R252 VSS.n205 VSS.n204 0.231121
R253 VSS.n205 VSS.n189 0.231121
R254 VSS.n209 VSS.n189 0.231121
R255 VSS.n210 VSS.n209 0.231121
R256 VSS.n211 VSS.n210 0.231121
R257 VSS.n211 VSS.n188 0.231121
R258 VSS.n215 VSS.n188 0.231121
R259 VSS.n216 VSS.n215 0.231121
R260 VSS.n217 VSS.n216 0.231121
R261 VSS.n217 VSS.n187 0.231121
R262 VSS.n221 VSS.n187 0.231121
R263 VSS.n222 VSS.n221 0.231121
R264 VSS.n223 VSS.n222 0.231121
R265 VSS.n223 VSS.n186 0.231121
R266 VSS.n227 VSS.n186 0.231121
R267 VSS.n228 VSS.n227 0.231121
R268 VSS.n229 VSS.n228 0.231121
R269 VSS.n229 VSS.n185 0.231121
R270 VSS.n233 VSS.n185 0.231121
R271 VSS.n234 VSS.n233 0.231121
R272 VSS.n235 VSS.n234 0.231121
R273 VSS.n235 VSS.n184 0.231121
R274 VSS.n239 VSS.n184 0.231121
R275 VSS.n240 VSS.n239 0.231121
R276 VSS.n14 VSS.n240 1.63073
R277 VSS.n14 VSS.t28 1.26574
R278 VSS.n0 VSS.n17 2.1869
R279 VSS.n192 VSS.n17 0.259433
R280 VSS.n192 VSS.n8 0.231121
R281 VSS.n194 VSS.n33 0.114852
R282 VSS.n195 VSS.n194 0.231121
R283 VSS.n196 VSS.n34 0.114852
R284 VSS.n196 VSS.n70 0.231121
R285 VSS.n200 VSS.n35 0.114852
R286 VSS.n201 VSS.n200 0.231121
R287 VSS.n202 VSS.n36 0.114852
R288 VSS.n202 VSS.n69 0.231121
R289 VSS.n206 VSS.n37 0.114852
R290 VSS.n207 VSS.n206 0.231121
R291 VSS.n208 VSS.n38 0.114852
R292 VSS.n208 VSS.n68 0.231121
R293 VSS.n212 VSS.n39 0.114852
R294 VSS.n213 VSS.n212 0.231121
R295 VSS.n214 VSS.n40 0.114852
R296 VSS.n214 VSS.n67 0.231121
R297 VSS.n218 VSS.n41 0.114852
R298 VSS.n219 VSS.n218 0.231121
R299 VSS.n220 VSS.n42 0.114852
R300 VSS.n220 VSS.n66 0.231121
R301 VSS.n224 VSS.n43 0.114852
R302 VSS.n225 VSS.n224 0.231121
R303 VSS.n226 VSS.n44 0.114852
R304 VSS.n226 VSS.n65 0.231121
R305 VSS.n230 VSS.n45 0.114852
R306 VSS.n231 VSS.n230 0.231121
R307 VSS.n232 VSS.n46 0.114852
R308 VSS.n232 VSS.n64 0.231121
R309 VSS.n236 VSS.n47 0.114852
R310 VSS.n237 VSS.n236 0.231121
R311 VSS.n238 VSS.n48 0.114852
R312 VSS.n238 VSS.n63 0.231121
R313 VSS.n14 VSS.n49 0.588982
R314 VSS.n102 VSS.n60 0.231121
R315 VSS.n102 VSS.n101 0.231121
R316 VSS.n101 VSS.n100 0.231121
R317 VSS.n100 VSS.n99 0.231121
R318 VSS.n99 VSS.n98 0.231121
R319 VSS.n98 VSS.n97 0.231121
R320 VSS.n97 VSS.n96 0.231121
R321 VSS.n96 VSS.n95 0.231121
R322 VSS.n95 VSS.n94 0.231121
R323 VSS.n113 VSS.n94 0.231121
R324 VSS.n114 VSS.n113 0.231121
R325 VSS.n115 VSS.n114 0.231121
R326 VSS.n115 VSS.n92 0.231121
R327 VSS.n92 VSS.n91 0.231121
R328 VSS.n91 VSS.n90 0.231121
R329 VSS.n90 VSS.n89 0.231121
R330 VSS.n89 VSS.n88 0.231121
R331 VSS.n88 VSS.n87 0.231121
R332 VSS.n87 VSS.n86 0.231121
R333 VSS.n86 VSS.n85 0.231121
R334 VSS.n85 VSS.n84 0.231121
R335 VSS.n84 VSS.n83 0.231121
R336 VSS.n83 VSS.n82 0.231121
R337 VSS.n82 VSS.n81 0.231121
R338 VSS.n81 VSS.n80 0.231121
R339 VSS.n80 VSS.n79 0.231121
R340 VSS.n79 VSS.n78 0.231121
R341 VSS.n78 VSS.n77 0.231121
R342 VSS.n77 VSS.n76 0.231121
R343 VSS.n76 VSS.n75 0.231121
R344 VSS.n75 VSS.n74 0.231121
R345 VSS.n74 VSS.n11 1.32937
R346 VSS.n11 VSS.t28 1.29478
R347 VSS.n28 VSS.n60 9.11485
R348 VSS.n104 VSS.n103 0.231121
R349 VSS.n105 VSS.n27 0.114852
R350 VSS.n106 VSS.n105 0.231121
R351 VSS.n107 VSS.n20 0.114852
R352 VSS.n108 VSS.n107 0.231121
R353 VSS.n26 VSS.n108 0.114852
R354 VSS.n110 VSS.n109 0.231121
R355 VSS.n25 VSS.n110 0.114852
R356 VSS.n112 VSS.n111 0.231121
R357 VSS.n24 VSS.n93 0.114852
R358 VSS.n116 VSS.n93 0.231121
R359 VSS.n117 VSS.n19 0.114852
R360 VSS.n118 VSS.n117 0.231121
R361 VSS.n119 VSS.n22 0.114852
R362 VSS.n120 VSS.n119 0.231121
R363 VSS.n121 VSS.n56 0.114852
R364 VSS.n122 VSS.n121 0.231121
R365 VSS.n55 VSS.n122 0.114852
R366 VSS.n124 VSS.n123 0.231121
R367 VSS.n54 VSS.n124 0.114852
R368 VSS.n126 VSS.n125 0.231121
R369 VSS.n53 VSS.n126 0.114852
R370 VSS.n128 VSS.n127 0.231121
R371 VSS.n52 VSS.n128 0.114852
R372 VSS.n130 VSS.n129 0.231121
R373 VSS.n51 VSS.n130 0.114852
R374 VSS.n132 VSS.n131 0.231121
R375 VSS.n50 VSS.n132 0.114852
R376 VSS.n134 VSS.n133 0.231121
R377 VSS.n183 VSS.n134 0.231121
R378 VSS.n11 VSS.n61 0.866614
R379 VSS.n157 VSS.n156 0.231121
R380 VSS.n32 VSS.n157 0.114852
R381 VSS.n159 VSS.n158 0.231121
R382 VSS.n15 VSS.n155 2.53844
R383 VSS.n155 VSS.n154 0.231121
R384 VSS.n154 VSS.n153 0.231121
R385 VSS.n160 VSS.n153 0.231121
R386 VSS.n162 VSS.n161 0.231121
R387 VSS.n162 VSS.n152 0.231121
R388 VSS.n152 VSS.n151 0.231121
R389 VSS.n151 VSS.n150 0.231121
R390 VSS.n150 VSS.n149 0.231121
R391 VSS.n149 VSS.n148 0.231121
R392 VSS.n148 VSS.n147 0.231121
R393 VSS.n147 VSS.n146 0.231121
R394 VSS.n146 VSS.n145 0.231121
R395 VSS.n145 VSS.n144 0.231121
R396 VSS.n173 VSS.n144 0.231121
R397 VSS.n177 VSS.n174 0.231121
R398 VSS.n178 VSS.n177 0.231121
R399 VSS.n179 VSS.n178 0.231121
R400 VSS.n179 VSS.n142 0.231121
R401 VSS.n142 VSS.n141 0.231121
R402 VSS.n141 VSS.n140 0.231121
R403 VSS.n140 VSS.n139 0.231121
R404 VSS.n139 VSS.n136 0.231121
R405 VSS.n136 VSS.n3 1.7097
R406 VSS.n5 VSS.n2 1.47547
R407 VSS.n0 VSS.t35 1.41022
R408 VSS.t45 VSS.t35 0.344366
R409 VSS.n1 VSS.t47 1.213
R410 VSS.t35 VSS.n5 0.133048
R411 VSS VSS.n60 0.692362
R412 VSS.n163 VSS.n21 0.114852
R413 VSS.n164 VSS.n163 0.231121
R414 VSS.n165 VSS.n164 0.231121
R415 VSS.n30 VSS.n165 0.114852
R416 VSS.n167 VSS.n166 0.231121
R417 VSS.n29 VSS.n167 0.114852
R418 VSS.n169 VSS.n168 0.231121
R419 VSS.n170 VSS.n59 0.114852
R420 VSS.n171 VSS.n170 0.231121
R421 VSS.n172 VSS.n171 0.231121
R422 VSS.n176 VSS.n175 0.231121
R423 VSS.n58 VSS.n143 0.114852
R424 VSS.n180 VSS.n143 0.231121
R425 VSS.n181 VSS.n18 0.114852
R426 VSS.n182 VSS.n181 0.231121
R427 VSS.n182 VSS.n62 0.114852
R428 VSS.n138 VSS.n135 0.231121
R429 VSS.n138 VSS.n57 0.114852
R430 VSS.n137 VSS.n73 0.231121
R431 VSS.n71 VSS.t20 1.19327
R432 VSS.t17 VSS.t28 1.18194
R433 VSS.n193 VSS 1.1536
R434 VSS.n0 VSS.n71 1.12105
R435 VSS.n6 VSS.t35 0.213769
R436 VSS.t35 VSS.n4 1.08288
R437 VSS.t28 VSS.n1 1.05126
R438 VSS.n5 VSS.t28 1.03147
C36 CURRENT_SINK VSS 0.1489f
C37 CURRENT_SOURCE VSS 0.04312f
C38 VDD VSS 4.43397f
C39 a_3921_745# VSS 2.35f ; **FLOATING
C40 a_255_200# VSS 5.97722f ; **FLOATING
C41 a_3921_1423# VSS 6.67258f ; **FLOATING
C42 a_1331_2287# VSS 3.79893f ; **FLOATING
C43 a_603_649# VSS 17.1218f ; **FLOATING
C44 a_451_2556# VSS 2.53824f ; **FLOATING
C45 a_803_1423# VSS 1.17658f ; **FLOATING
C46 VSS.t28 VSS 3.78188f ; **FLOATING
.ends
