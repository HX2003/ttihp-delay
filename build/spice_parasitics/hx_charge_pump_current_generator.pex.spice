* NGSPICE file created from hx_charge_pump_current_generator.ext - technology: ihp-sg13g2

.subckt hx_charge_pump_current_generator VDD VSS CURRENT_SINK CURRENT_SOURCE
X0 VSS.t14 VSS.t12 VSS.t12 VSS.t13 sg13_lv_nmos ad=0.68p pd=4.68u as=0 ps=0 w=2u l=1u
X1 a_3921_1423# a_3921_1423# VSS.t10 VSS.t4 sg13_lv_nmos ad=0.38p pd=2.38u as=0.68p ps=4.68u w=2u l=1u
X2 CURRENT_SOURCE a_803_1423# VDD VDD sg13_lv_pmos ad=0.38p pd=2.38u as=0.38p ps=2.38u w=2u l=1u
X3 a_1331_2287# a_803_1423# VDD VDD sg13_lv_pmos ad=0.38p pd=2.38u as=0.38p ps=2.38u w=2u l=1u
X4 a_255_200# a_603_649# a_803_1423# VSS.t32 sg13_lv_nmos ad=0.68p pd=4.68u as=0.38p ps=2.38u w=2u l=1u
X5 CURRENT_SINK a_1331_2287# a_3921_745# VSS.t25 sg13_lv_nmos ad=0.38p pd=2.38u as=0.68p ps=4.68u w=2u l=1u
X6 a_803_1423# a_603_649# a_255_200# VSS.t36 sg13_lv_nmos ad=0.42p pd=2.42u as=0.68p ps=4.68u w=2u l=1u
X7 VSS.t17 VSS.t15 VSS.t15 VSS.t16 sg13_lv_nmos ad=0.68p pd=4.68u as=0 ps=0 w=2u l=1u
X8 VDD VDD VDD VDD sg13_lv_pmos ad=0.68p pd=4.68u as=30.9901p ps=0.16929m w=2u l=1u
X9 a_803_1423# a_603_649# a_255_200# VSS.t31 sg13_lv_nmos ad=0.38p pd=2.38u as=0.68p ps=4.68u w=2u l=1u
X10 VDD VDD VDD VDD sg13_lv_pmos ad=0.68p pd=4.68u as=0 ps=0 w=2u l=1u
X11 VSS.t7 a_3921_1423# a_3921_745# VSS.t6 sg13_lv_nmos ad=0.68p pd=4.68u as=0.38p ps=2.38u w=2u l=1u
X12 a_603_649# a_451_2556# a_803_1423# VSS.t39 sg13_lv_nmos ad=0.68p pd=4.68u as=0.38p ps=2.38u w=2u l=1u
X13 a_1331_2287# a_1331_2287# a_3921_1423# VSS.t23 sg13_lv_nmos ad=0.38p pd=2.38u as=0.68p ps=4.68u w=2u l=1u
X14 VDD VDD VDD VDD sg13_lv_pmos ad=0.38p pd=2.38u as=0 ps=0 w=2u l=1u
X15 VDD VDD VDD VDD sg13_lv_pmos ad=0.38p pd=2.38u as=0 ps=0 w=2u l=1u
X16 a_603_649# a_603_649# VSS.t34 VSS.t33 sg13_lv_nmos ad=0.38p pd=2.38u as=0.68p ps=4.68u w=2u l=1u
X17 a_3921_745# a_3921_1423# VSS.t5 VSS.t4 sg13_lv_nmos ad=0.38p pd=2.38u as=0.68p ps=4.68u w=2u l=1u
X18 a_3921_745# a_1331_2287# CURRENT_SINK VSS.t24 sg13_lv_nmos ad=0.68p pd=4.68u as=0.38p ps=2.38u w=2u l=1u
X19 a_255_200# VSS.t28 VSS.t27 rppd l=32u w=1u
X20 VSS.t47 a_603_649# a_451_2556# VSS.t37 sg13_lv_nmos ad=0.68p pd=4.68u as=0.38p ps=2.38u w=2u l=1u
X21 a_451_2556# a_603_649# VSS.t41 VSS.t46 sg13_lv_nmos ad=0.38p pd=2.38u as=0.68p ps=4.68u w=2u l=1u
X22 VDD a_803_1423# a_803_1423# VDD sg13_lv_pmos ad=0.38p pd=2.38u as=0.38p ps=2.38u w=2u l=1u
X23 a_1331_2287# a_803_1423# VDD VDD sg13_lv_pmos ad=0.38p pd=2.38u as=0.38p ps=2.38u w=2u l=1u
X24 VDD a_803_1423# a_603_649# VDD sg13_lv_pmos ad=0.38p pd=2.38u as=0.38p ps=2.38u w=2u l=1u
X25 a_255_200# a_603_649# a_803_1423# VSS.t30 sg13_lv_nmos ad=0.68p pd=4.68u as=0.38p ps=2.38u w=2u l=1u
X26 VSS.t3 a_3921_1423# a_3921_1423# VSS.t2 sg13_lv_nmos ad=0.68p pd=4.68u as=0.38p ps=2.38u w=2u l=1u
X27 VSS.t41 a_603_649# a_451_2556# VSS.t32 sg13_lv_nmos ad=0.68p pd=4.68u as=0.38p ps=2.38u w=2u l=1u
X28 CURRENT_SOURCE a_803_1423# VDD VDD sg13_lv_pmos ad=0.38p pd=2.38u as=0.38p ps=2.38u w=2u l=1u
X29 a_3921_1423# a_1331_2287# a_1331_2287# VSS.t24 sg13_lv_nmos ad=0.68p pd=4.68u as=0.38p ps=2.38u w=2u l=1u
X30 VSS.t20 VSS.t12 VSS.t12 VSS.t13 sg13_lv_nmos ad=0.68p pd=4.68u as=0 ps=0 w=2u l=1u
X31 a_803_1423# a_603_649# a_255_200# VSS.t29 sg13_lv_nmos ad=0.38p pd=2.38u as=0.68p ps=4.68u w=2u l=1u
X32 a_3921_1423# a_3921_1423# VSS.t1 VSS.t0 sg13_lv_nmos ad=0.38p pd=2.38u as=0.68p ps=4.68u w=2u l=1u
X33 a_451_2556# a_603_649# VSS.t41 VSS.t31 sg13_lv_nmos ad=0.38p pd=2.38u as=0.68p ps=4.68u w=2u l=1u
X34 VDD a_803_1423# a_603_649# VDD sg13_lv_pmos ad=0.38p pd=2.38u as=0.38p ps=2.38u w=2u l=1u
X35 VDD a_803_1423# a_803_1423# VDD sg13_lv_pmos ad=0.38p pd=2.38u as=0.38p ps=2.38u w=2u l=1u
X36 VSS.t34 a_603_649# a_603_649# VSS.t35 sg13_lv_nmos ad=0.68p pd=4.68u as=0.38p ps=2.38u w=2u l=1u
X37 VSS.t41 a_603_649# a_451_2556# VSS.t35 sg13_lv_nmos ad=0.76p pd=4.76u as=0.38p ps=2.38u w=2u l=1u
X38 a_803_1423# a_451_2556# a_603_649# VSS.t38 sg13_lv_nmos ad=0.38p pd=2.38u as=0.68p ps=4.68u w=2u l=1u
X39 VSS.t41 a_603_649# a_451_2556# VSS.t30 sg13_lv_nmos ad=0.68p pd=4.68u as=0.38p ps=2.38u w=2u l=1u
X40 VDD a_803_1423# CURRENT_SOURCE VDD sg13_lv_pmos ad=0.38p pd=2.38u as=0.38p ps=2.38u w=2u l=1u
X41 a_603_649# a_803_1423# VDD VDD sg13_lv_pmos ad=0.38p pd=2.38u as=0.38p ps=2.38u w=2u l=1u
X42 VDD a_803_1423# a_1331_2287# VDD sg13_lv_pmos ad=0.38p pd=2.38u as=0.38p ps=2.38u w=2u l=1u
X43 a_3921_745# a_1331_2287# CURRENT_SINK VSS.t26 sg13_lv_nmos ad=0.68p pd=4.68u as=0.38p ps=2.38u w=2u l=1u
X44 VDD a_803_1423# a_1331_2287# VDD sg13_lv_pmos ad=0.38p pd=2.38u as=0.38p ps=2.38u w=2u l=1u
X45 a_803_1423# a_803_1423# VDD VDD sg13_lv_pmos ad=0.38p pd=2.38u as=0.38p ps=2.38u w=2u l=1u
X46 VDD a_803_1423# CURRENT_SOURCE VDD sg13_lv_pmos ad=0.38p pd=2.38u as=0.38p ps=2.38u w=2u l=1u
X47 CURRENT_SINK a_1331_2287# a_3921_745# VSS.t23 sg13_lv_nmos ad=0.38p pd=2.38u as=0.68p ps=4.68u w=2u l=1u
X48 VSS.t11 a_3921_1423# a_3921_1423# VSS.t6 sg13_lv_nmos ad=0.68p pd=4.68u as=0.38p ps=2.38u w=2u l=1u
X49 VSS.t17 VSS.t15 VSS.t15 VSS.t16 sg13_lv_nmos ad=0.68p pd=4.68u as=0 ps=0 w=2u l=1u
X50 a_3921_1423# a_1331_2287# a_1331_2287# VSS.t26 sg13_lv_nmos ad=0.68p pd=4.68u as=0.38p ps=2.38u w=2u l=1u
X51 a_803_1423# a_803_1423# VDD VDD sg13_lv_pmos ad=0.38p pd=2.38u as=0.38p ps=2.38u w=2u l=1u
X52 a_1331_2287# a_1331_2287# a_3921_1423# VSS.t25 sg13_lv_nmos ad=0.38p pd=2.38u as=0.68p ps=4.68u w=2u l=1u
X53 a_603_649# a_803_1423# VDD VDD sg13_lv_pmos ad=0.38p pd=2.38u as=0.38p ps=2.38u w=2u l=1u
X54 a_803_1423# a_603_649# a_255_200# VSS.t38 sg13_lv_nmos ad=0.38p pd=2.38u as=0.68p ps=4.68u w=2u l=1u
X55 VSS.t9 a_3921_1423# a_3921_745# VSS.t2 sg13_lv_nmos ad=0.68p pd=4.68u as=0.38p ps=2.38u w=2u l=1u
X56 VDD a_451_2556# a_451_2556# VDD sg13_lv_pmos ad=0.2448p pd=2.08u as=0.2826p ps=2.29u w=0.36u l=2u
X57 a_3921_745# a_3921_1423# VSS.t8 VSS.t0 sg13_lv_nmos ad=0.38p pd=2.38u as=0.68p ps=4.68u w=2u l=1u
X58 a_255_200# a_603_649# a_803_1423# VSS.t37 sg13_lv_nmos ad=0.68p pd=4.68u as=0.42p ps=2.42u w=2u l=1u
X59 a_451_2556# a_603_649# VSS.t20 VSS.t29 sg13_lv_nmos ad=0.38p pd=2.38u as=0.68p ps=4.68u w=2u l=1u
X60 a_451_2556# a_603_649# VSS.t41 VSS.t33 sg13_lv_nmos ad=0.38p pd=2.38u as=0.68p ps=4.68u w=2u l=1u
X61 a_255_200# a_603_649# a_803_1423# VSS.t39 sg13_lv_nmos ad=0.68p pd=4.68u as=0.38p ps=2.38u w=2u l=1u
C0 a_341_200# a_451_2556# 0.01697f
C1 a_3921_745# a_3921_1423# 2.20455f
C2 CURRENT_SINK a_1331_2287# 0.63956f
C3 a_255_200# a_1331_2287# 0.02724f
C4 a_3921_745# a_1331_2287# 0.8486f
C5 a_603_649# a_255_200# 1.6143f
C6 a_803_1423# CURRENT_SINK 0.04737f
C7 a_803_1423# a_255_200# 0.87838f
C8 CURRENT_SINK a_451_2556# 0.01152f
C9 a_255_200# a_451_2556# 2.88221f
C10 a_3921_745# a_603_649# 0.25721f
C11 VDD a_1331_2287# 0.95263f
C12 a_1331_2287# a_3921_1423# 1.25684f
C13 a_255_200# a_341_200# 0.07306f
C14 a_603_649# VDD 0.89062f
C15 VDD CURRENT_SOURCE 0.59444f
C16 a_803_1423# VDD 7.53633f
C17 a_603_649# a_3921_1423# 0.03029f
C18 a_3921_745# a_341_200# 0.02483f
C19 VDD a_451_2556# 0.90492f
C20 a_803_1423# a_3921_1423# 0.01269f
C21 a_603_649# a_1331_2287# 0.23035f
C22 a_341_200# a_3921_1423# 0.06832f
C23 a_1331_2287# CURRENT_SOURCE 0.13605f
C24 a_803_1423# a_1331_2287# 1.26342f
C25 a_1331_2287# a_451_2556# 0.01757f
C26 a_603_649# CURRENT_SOURCE 0.16988f
C27 a_803_1423# a_603_649# 2.8107f
C28 a_3921_745# CURRENT_SINK 0.68395f
C29 a_803_1423# CURRENT_SOURCE 1.24737f
C30 a_603_649# a_451_2556# 1.74556f
C31 a_1331_2287# a_341_200# 0.03661f
C32 CURRENT_SOURCE a_451_2556# 0.02585f
C33 a_803_1423# a_451_2556# 0.33136f
C34 a_603_649# a_341_200# 0.23738f
C35 a_803_1423# a_341_200# 0.01889f
C36 CURRENT_SINK a_3921_1423# 0.17053f
C37 a_255_200# a_3921_1423# 0.19787f
R0 VSS.t13 VSS.t30 6.43577
R1 VSS.n4 VSS.t46 8.84355
R2 VSS.t35 VSS.t13 17.3547
R3 VSS.t27 VSS.t13 24.6429
R4 VSS.t32 VSS.t13 6.43674
R5 VSS.t23 VSS.t13 8.42869
R6 VSS.t13 VSS.t2 17.0264
R7 VSS.t29 VSS.t13 28.4102
R8 VSS.t13 VSS.t26 19.0156
R9 VSS.t24 VSS.t13 19.0162
R10 VSS.t13 VSS.t39 25.8676
R11 VSS.t33 VSS.t13 22.268
R12 VSS.t13 VSS.t0 17.5828
R13 VSS.t13 VSS.t37 19.1261
R14 VSS.t13 VSS.t25 14.0018
R15 VSS.n31 VSS.t13 17.0005
R16 VSS.n8 VSS.t13 17.0005
R17 VSS.n21 VSS.t13 17.0005
R18 VSS.t6 VSS.t13 13.0467
R19 VSS.n4 VSS.t13 11.9247
R20 VSS.t38 VSS.t13 11.0388
R21 VSS.n4 VSS.t36 1.47338
R22 VSS.n1 VSS.t13 0.932023
R23 VSS.n38 VSS.n5 0.142556
R24 VSS.n2 VSS.t13 1.02094
R25 VSS.n11 VSS.t13 8.47732
R26 VSS.n17 VSS.t13 8.47732
R27 VSS.n15 VSS 8.34175
R28 VSS.n9 VSS.t13 4.19238
R29 VSS.n14 VSS.t13 4.19225
R30 VSS.n6 VSS.t13 0.846168
R31 VSS.n19 VSS.t13 2.32417
R32 VSS.n33 VSS.t13 2.32406
R33 VSS.n23 VSS.t13 2.0061
R34 VSS.n3 VSS.t13 0.665348
R35 VSS.n26 VSS.t13 1.75596
R36 VSS.n37 VSS.t13 1.75589
R37 VSS.t47 VSS.n0 0.639761
R38 VSS.n28 VSS.t13 1.7558
R39 VSS.n35 VSS.t13 1.55203
R40 VSS.n12 VSS.t15 1.43372
R41 VSS.n10 VSS.t17 1.43372
R42 VSS.n16 VSS.t15 1.42949
R43 VSS.n13 VSS.t17 1.42949
R44 VSS.t8 VSS.t1 1.41891
R45 VSS.t9 VSS.t3 1.41891
R46 VSS.t10 VSS.t5 1.41891
R47 VSS.t11 VSS.t7 1.41891
R48 VSS.t12 VSS.t20 1.3766
R49 VSS.t14 VSS.t12 1.3766
R50 VSS.t13 VSS.n5 1.01992
R51 VSS.n1 VSS.t20 0.00818083
R52 VSS.t34 VSS.t13 0.482304
R53 VSS.t13 VSS.n0 0.576366
R54 VSS.n25 VSS.n24 1.03228
R55 VSS.t47 VSS.n25 1.00218
R56 VSS.n3 VSS.t1 0.835504
R57 VSS.n30 VSS.t3 0.722752
R58 VSS.n32 VSS.t5 0.722752
R59 VSS.n34 VSS.t7 0.722752
R60 VSS.n24 VSS.t8 0.722041
R61 VSS.n22 VSS.t9 0.722041
R62 VSS.n20 VSS.t10 0.722041
R63 VSS.n18 VSS.t11 0.722041
R64 VSS.n35 VSS.n10 0.515255
R65 VSS.t15 VSS.t17 0.492336
R66 VSS.n26 VSS.n7 0.472043
R67 VSS.n36 VSS.n35 0.4613
R68 VSS.n28 VSS.n27 0.416917
R69 VSS.n38 VSS.n37 0.416411
R70 VSS.n29 VSS.n28 0.416191
R71 VSS.n27 VSS.n26 0.416074
R72 VSS.n37 VSS.n36 0.415422
R73 VSS.t41 VSS.n0 0.131997
R74 VSS.n34 VSS.n33 0.374771
R75 VSS.n19 VSS.n18 0.374692
R76 VSS.n24 VSS.n23 0.339754
R77 VSS.n30 VSS.n3 0.531186
R78 VSS.n23 VSS.n22 0.336447
R79 VSS.n6 VSS.n7 0.538154
R80 VSS.n20 VSS.n19 0.307655
R81 VSS.n33 VSS.n32 0.307571
R82 VSS.t14 VSS.n2 0.0105195
R83 VSS.n9 VSS.n12 0.182052
R84 VSS.n27 VSS.t12 0.167615
R85 VSS.n14 VSS.n13 0.164424
R86 VSS.n10 VSS.n9 0.164293
R87 VSS.n15 VSS.n14 0.149424
R88 VSS.n36 VSS.t17 0.1171
R89 VSS.n7 VSS 0.1105
R90 VSS.n39 VSS 0.1105
R91 VSS.n12 VSS.n11 0.104618
R92 VSS.n17 VSS.n16 0.104618
R93 VSS.n31 VSS.n30 0.08425
R94 VSS.n22 VSS.n21 0.08425
R95 VSS.n38 VSS.n8 0.0805
R96 VSS.n2 VSS.n29 0.145322
R97 VSS.n13 VSS.n8 0.07425
R98 VSS.n32 VSS.n31 0.06925
R99 VSS.n21 VSS.n20 0.06925
R100 VSS.n1 VSS.n7 0.0929896
R101 VSS.n39 VSS 0.0555
R102 VSS.n29 VSS 0.0555
R103 VSS.n11 VSS.n34 0.0496177
R104 VSS.n18 VSS.n17 0.0496177
R105 VSS.t28 VSS.n5 0.00518045
R106 VSS.n16 VSS.n15 0.033
R107 VSS.n39 VSS.n6 0.0818407
R108 VSS.t4 VSS.t13 19.1746
R109 VSS.t16 VSS.t13 18.7778
R110 VSS.t31 VSS.t13 27.7283
R111 VSS.n25 VSS.t13 1.17019
C38 CURRENT_SINK VSS 0.12345f
C39 CURRENT_SOURCE VSS 0.13759f
C40 VDD VSS 1.245f
C41 a_3921_745# VSS 2.19855f ; **FLOATING
C42 a_255_200# VSS 5.33579f ; **FLOATING
C43 a_3921_1423# VSS 6.40889f ; **FLOATING
C44 a_1331_2287# VSS 3.77945f ; **FLOATING
C45 a_603_649# VSS 13.8355f ; **FLOATING
C46 a_451_2556# VSS 2.41286f ; **FLOATING
C47 a_803_1423# VSS 1.04511f ; **FLOATING
C48 VSS.t28 VSS 3.31349f ; **FLOATING
.ends
