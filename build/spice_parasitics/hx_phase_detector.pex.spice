* NGSPICE file created from hx_phase_detector.ext - technology: ihp-sg13g2

.subckt hx_phase_detector UP_INV DOWN DOWN_INV DLL_RESETN DELAY_IN UP DELAY_OUT VSS
+ VDD
X0 UP_INV a_5375_1437# VSS.t24 VSS.t23 sg13_lv_nmos ad=0.2849p pd=2.25u as=0.2516p ps=2.16u w=0.74u l=0.13u
X1 a_4116_1080# a_4635_1087# a_5375_1437# VSS.t21 sg13_lv_nmos ad=0.3473p pd=2.71u as=0.12665p ps=1.145u w=0.74u l=0.13u
X2 VDD a_5632_1318# a_5577_1199# VDD sg13_lv_pmos ad=1.06255p pd=6.38u as=93.45f ps=0.865u w=0.42u l=0.13u
X3 a_4342_327# a_3373_1076# VSS.t68 VSS.t67 sg13_lv_nmos ad=37.8f pd=0.6u as=0.1701p ps=1.65u w=0.42u l=0.13u
X4 UP a_6212_1076# VSS.t26 VSS.t32 sg13_lv_nmos ad=0.2516p pd=2.16u as=0.1406p ps=1.12u w=0.74u l=0.13u
X5 a_5577_629# a_4635_436# a_5375_391# VDD sg13_lv_pmos ad=93.45f pd=0.865u as=0.2048p ps=1.63u w=0.42u l=0.13u
X6 a_5375_391# a_4533_293# a_4116_632# VDD sg13_lv_pmos ad=0.2048p pd=1.63u as=0.34p ps=2.68u w=1u l=0.13u
X7 a_4473_1123# a_4116_1080# VDD VDD sg13_lv_pmos ad=63f pd=0.72u as=0.1563p ps=1.22u w=0.42u l=0.13u
X8 a_756_1080# a_1275_1087# a_2015_1437# VSS.t4 sg13_lv_nmos ad=0.3473p pd=2.71u as=0.12665p ps=1.145u w=0.74u l=0.13u
X9 a_2272_1318# DLL_RESETN VDD VDD sg13_lv_pmos ad=79.8f pd=0.8u as=1.06255p ps=6.38u w=0.42u l=0.13u
X10 a_3373_1076# a_3180_1073# VSS.t17 VSS.t16 sg13_lv_nmos ad=0.1406p pd=1.12u as=0.2516p ps=2.16u w=0.74u l=0.13u
X11 a_1173_1087# DELAY_IN VDD VDD sg13_lv_pmos ad=0.4088p pd=2.97u as=0.99612p ps=5.98u w=1.12u l=0.13u
X12 a_2879_1076# a_2682_1076# VSS.t6 VSS.t11 sg13_lv_nmos ad=0.2516p pd=2.16u as=0.1406p ps=1.12u w=0.74u l=0.13u
X13 a_1113_1123# a_756_1080# VDD VDD sg13_lv_pmos ad=63f pd=0.72u as=0.1563p ps=1.22u w=0.42u l=0.13u
X14 a_4090_537# a_4533_293# a_4473_705# VDD sg13_lv_pmos ad=79.8f pd=0.8u as=63f ps=0.72u w=0.42u l=0.13u
X15 VSS.t3 a_1173_1087# a_1275_1087# VSS.t15 sg13_lv_nmos ad=2.30077p pd=14.835u as=0.2516p ps=2.16u w=0.74u l=0.13u
X16 a_3180_1073# DLL_RESETN VDD VDD sg13_lv_pmos ad=0.3808p pd=2.92u as=0.3808p ps=2.92u w=1.12u l=0.13u
X17 a_4342_1501# a_3373_1076# VSS.t63 VSS.t62 sg13_lv_nmos ad=37.8f pd=0.6u as=0.1701p ps=1.65u w=0.42u l=0.13u
X18 a_4090_1044# a_4533_1087# a_4473_1123# VDD sg13_lv_pmos ad=79.8f pd=0.8u as=63f ps=0.72u w=0.42u l=0.13u
X19 VSS.t13 a_4533_293# a_4635_436# VSS.t34 sg13_lv_nmos ad=1.45407p pd=9.445u as=0.2516p ps=2.16u w=0.74u l=0.13u
X20 VDD a_4533_293# a_4635_436# VDD sg13_lv_pmos ad=1.06255p pd=6.38u as=0.3864p ps=2.93u w=1.12u l=0.13u
X21 a_3830_314# a_4635_436# a_4090_537# VDD sg13_lv_pmos ad=0.1428p pd=1.52u as=79.8f ps=0.8u w=0.42u l=0.13u
X22 a_3830_314# a_3656_629# VDD VDD sg13_lv_pmos ad=79.8f pd=0.8u as=0.1428p ps=1.52u w=0.42u l=0.13u
X23 a_730_1044# a_1173_1087# a_1113_1123# VDD sg13_lv_pmos ad=79.8f pd=0.8u as=63f ps=0.72u w=0.42u l=0.13u
X24 a_982_1501# DLL_RESETN VSS.t56 VSS.t55 sg13_lv_nmos ad=37.8f pd=0.6u as=0.1701p ps=1.65u w=0.42u l=0.13u
X25 a_296_1052# a_270_1014# VDD VDD sg13_lv_pmos ad=0.3927p pd=2.99u as=1.06255p ps=6.38u w=1.155u l=0.13u
X26 VDD a_3373_1076# a_3830_314# VDD sg13_lv_pmos ad=0.36237p pd=2.605u as=79.8f ps=0.8u w=0.42u l=0.13u
X27 VSS.t54 a_3373_1076# a_3924_314# VSS.t53 sg13_lv_nmos ad=0.1626p pd=1.415u as=60.89999f ps=0.71u w=0.42u l=0.13u
X28 a_5632_1318# a_3373_1076# VDD VDD sg13_lv_pmos ad=79.8f pd=0.8u as=0.99612p ps=5.98u w=0.42u l=0.13u
X29 DOWN_INV a_5375_391# VDD VDD sg13_lv_pmos ad=0.4312p pd=3.01u as=0.2639p ps=1.81u w=1.12u l=0.13u
X30 VDD a_3373_1076# a_4090_1044# VDD sg13_lv_pmos ad=0.1563p pd=1.22u as=0.147p ps=1.54u w=0.42u l=0.13u
X31 a_3830_1514# a_2879_1076# VDD VDD sg13_lv_pmos ad=79.8f pd=0.8u as=0.1428p ps=1.52u w=0.42u l=0.13u
X32 VSS.t7 a_2272_1318# a_1921_1437# VSS.t4 sg13_lv_nmos ad=79.8f pd=0.8u as=0.1428p ps=1.52u w=0.42u l=0.13u
X33 a_3569_1424# DOWN a_3373_1076# VSS.t39 sg13_lv_nmos ad=0.1406p pd=1.12u as=0.1406p ps=1.12u w=0.74u l=0.13u
X34 VSS.t3 a_4533_1087# a_4635_1087# VSS.t20 sg13_lv_nmos ad=2.30077p pd=14.835u as=0.2516p ps=2.16u w=0.74u l=0.13u
X35 a_4533_1087# DELAY_IN VDD VDD sg13_lv_pmos ad=0.4088p pd=2.97u as=0.99612p ps=5.98u w=1.12u l=0.13u
X36 VDD DLL_RESETN a_730_1044# VDD sg13_lv_pmos ad=0.1563p pd=1.22u as=0.147p ps=1.54u w=0.42u l=0.13u
X37 a_5375_391# a_4533_293# a_5281_391# VSS.t35 sg13_lv_nmos ad=0.12665p pd=1.145u as=0.1428p ps=1.52u w=0.42u l=0.13u
X38 a_3924_314# a_3656_629# a_3830_314# VSS.t27 sg13_lv_nmos ad=60.89999f pd=0.71u as=0.1428p ps=1.52u w=0.42u l=0.13u
X39 a_3830_1514# a_4635_1087# a_4090_1044# VDD sg13_lv_pmos ad=0.1428p pd=1.52u as=79.8f ps=0.8u w=0.42u l=0.13u
X40 VDD a_5632_534# a_5577_629# VDD sg13_lv_pmos ad=1.06255p pd=6.38u as=93.45f ps=0.865u w=0.42u l=0.13u
X41 VSS.t50 a_3373_1076# a_3924_1514# VSS.t61 sg13_lv_nmos ad=0.1626p pd=1.415u as=60.89999f ps=0.71u w=0.42u l=0.13u
X42 VDD a_71_1381# a_71_1151# VDD sg13_lv_pmos ad=1.06255p pd=6.38u as=0.2442p ps=2.06u w=0.66u l=0.13u
X43 a_470_1514# a_1275_1087# a_730_1044# VDD sg13_lv_pmos ad=0.1428p pd=1.52u as=79.8f ps=0.8u w=0.42u l=0.13u
X44 a_756_1080# a_730_1044# VSS.t1 VSS.t0 sg13_lv_nmos ad=0.2516p pd=2.16u as=0.1626p ps=1.415u w=0.74u l=0.13u
X45 VSS.t37 a_5375_391# a_6212_612# VSS.t48 sg13_lv_nmos ad=0.1406p pd=1.12u as=0.2516p ps=2.16u w=0.74u l=0.13u
X46 a_5632_534# a_3373_1076# VDD VDD sg13_lv_pmos ad=79.8f pd=0.8u as=0.99612p ps=5.98u w=0.42u l=0.13u
X47 a_470_1514# a_296_1052# VDD VDD sg13_lv_pmos ad=79.8f pd=0.8u as=0.1428p ps=1.52u w=0.42u l=0.13u
X48 a_4116_632# a_4635_436# a_5375_391# VSS.t30 sg13_lv_nmos ad=0.3473p pd=2.71u as=0.12665p ps=1.145u w=0.74u l=0.13u
X49 a_5632_1318# a_5375_1437# a_5794_1514# VSS.t21 sg13_lv_nmos ad=0.1428p pd=1.52u as=37.8f ps=0.6u w=0.42u l=0.13u
X50 a_2015_1437# a_1173_1087# a_756_1080# VDD sg13_lv_pmos ad=0.2048p pd=1.63u as=0.34p ps=2.68u w=1u l=0.13u
X51 VDD a_5375_391# a_5632_534# VDD sg13_lv_pmos ad=0.2639p pd=1.81u as=79.8f ps=0.8u w=0.42u l=0.13u
X52 a_3467_1076# a_3180_1073# a_3373_1076# VDD sg13_lv_pmos ad=0.2128p pd=1.5u as=0.3808p ps=2.92u w=1.12u l=0.13u
X53 a_3630_566# a_3431_629# VSS.t13 VSS.t27 sg13_lv_nmos ad=0.27427p pd=2.28u as=1.45407p ps=9.445u w=0.795u l=0.13u
X54 VDD a_5375_1437# a_6212_1076# VDD sg13_lv_pmos ad=0.2128p pd=1.5u as=0.3864p ps=2.93u w=1.12u l=0.13u
X55 a_2015_1437# a_1173_1087# a_1921_1437# VSS.t4 sg13_lv_nmos ad=0.12665p pd=1.145u as=0.1428p ps=1.52u w=0.42u l=0.13u
X56 VSS.t3 a_71_1381# a_71_1381# VSS.t2 sg13_lv_nmos ad=2.30077p pd=14.835u as=0.111p ps=1.34u w=0.3u l=0.13u
X57 DOWN a_6212_612# VSS.t37 VSS.t36 sg13_lv_nmos ad=0.2516p pd=2.16u as=0.1406p ps=1.12u w=0.74u l=0.13u
X58 VDD a_1173_1087# a_1275_1087# VDD sg13_lv_pmos ad=1.06255p pd=6.38u as=0.3864p ps=2.93u w=1.12u l=0.13u
X59 a_2272_1318# a_2015_1437# a_2434_1514# VSS.t4 sg13_lv_nmos ad=0.1428p pd=1.52u as=37.8f ps=0.6u w=0.42u l=0.13u
X60 VSS.t28 a_5632_1318# a_5281_1437# VSS.t21 sg13_lv_nmos ad=79.8f pd=0.8u as=0.1428p ps=1.52u w=0.42u l=0.13u
X61 VDD a_3431_395# a_3431_629# VDD sg13_lv_pmos ad=1.06255p pd=6.38u as=0.2442p ps=2.06u w=0.66u l=0.13u
X62 VDD a_2015_1437# a_2682_1076# VDD sg13_lv_pmos ad=0.2128p pd=1.5u as=0.3864p ps=2.93u w=1.12u l=0.13u
X63 VSS.t41 UP a_3569_1424# VSS.t40 sg13_lv_nmos ad=0.2516p pd=2.16u as=0.1406p ps=1.12u w=0.74u l=0.13u
X64 VSS.t1 DLL_RESETN a_564_1514# VSS.t57 sg13_lv_nmos ad=0.1626p pd=1.415u as=60.89999f ps=0.71u w=0.42u l=0.13u
X65 a_2434_1514# DLL_RESETN VSS.t7 VSS.t4 sg13_lv_nmos ad=37.8f pd=0.6u as=79.8f ps=0.8u w=0.42u l=0.13u
X66 a_3656_629# a_3630_566# VDD VDD sg13_lv_pmos ad=0.3927p pd=2.99u as=1.06255p ps=6.38u w=1.155u l=0.13u
X67 VDD a_2015_1437# a_2272_1318# VDD sg13_lv_pmos ad=1.06255p pd=6.38u as=79.8f ps=0.8u w=0.42u l=0.13u
X68 a_4090_1044# a_4533_1087# a_3830_1514# VSS.t19 sg13_lv_nmos ad=79.8f pd=0.8u as=0.1296p ps=1.52u w=0.42u l=0.13u
X69 a_756_1080# a_730_1044# VDD VDD sg13_lv_pmos ad=0.34p pd=2.68u as=0.36237p ps=2.605u w=1u l=0.13u
X70 a_1044_1501# a_756_1080# a_982_1501# VSS.t10 sg13_lv_nmos ad=0.1428p pd=1.52u as=37.8f ps=0.6u w=0.42u l=0.13u
X71 a_4116_1080# a_4090_1044# VSS.t50 VSS.t49 sg13_lv_nmos ad=0.2516p pd=2.16u as=0.1626p ps=1.415u w=0.74u l=0.13u
X72 a_730_1044# a_1173_1087# a_470_1514# VSS.t14 sg13_lv_nmos ad=79.8f pd=0.8u as=0.1296p ps=1.52u w=0.42u l=0.13u
X73 a_270_1014# a_71_1151# VSS.t3 VSS.t2 sg13_lv_nmos ad=0.27427p pd=2.28u as=2.30077p ps=14.835u w=0.795u l=0.13u
X74 a_5375_1437# a_4533_1087# a_4116_1080# VDD sg13_lv_pmos ad=0.2048p pd=1.63u as=0.34p ps=2.68u w=1u l=0.13u
X75 a_1173_1087# DELAY_IN VSS.t3 VSS.t42 sg13_lv_nmos ad=0.2516p pd=2.16u as=1.9173p ps=12.365u w=0.74u l=0.13u
X76 UP_INV a_5375_1437# VDD VDD sg13_lv_pmos ad=0.4312p pd=3.01u as=0.2639p ps=1.81u w=1.12u l=0.13u
X77 VDD a_4533_1087# a_4635_1087# VDD sg13_lv_pmos ad=1.06255p pd=6.38u as=0.3864p ps=2.93u w=1.12u l=0.13u
X78 VDD DOWN a_3467_1076# VDD sg13_lv_pmos ad=0.2128p pd=1.5u as=0.2128p ps=1.5u w=1.12u l=0.13u
X79 UP a_6212_1076# VDD VDD sg13_lv_pmos ad=0.3808p pd=2.92u as=0.2128p ps=1.5u w=1.12u l=0.13u
X80 a_4116_1080# a_4090_1044# VDD VDD sg13_lv_pmos ad=0.34p pd=2.68u as=0.36237p ps=2.605u w=1u l=0.13u
X81 a_5794_1514# a_3373_1076# VSS.t28 VSS.t21 sg13_lv_nmos ad=37.8f pd=0.6u as=79.8f ps=0.8u w=0.42u l=0.13u
X82 VDD a_5375_1437# a_5632_1318# VDD sg13_lv_pmos ad=0.2639p pd=1.81u as=79.8f ps=0.8u w=0.42u l=0.13u
X83 a_2879_1076# a_2682_1076# VDD VDD sg13_lv_pmos ad=0.3808p pd=2.92u as=0.2128p ps=1.5u w=1.12u l=0.13u
X84 a_5375_1437# a_4533_1087# a_5281_1437# VSS.t21 sg13_lv_nmos ad=0.12665p pd=1.145u as=0.1428p ps=1.52u w=0.42u l=0.13u
X85 a_3180_1073# DLL_RESETN VSS.t60 VSS.t59 sg13_lv_nmos ad=0.2516p pd=2.16u as=0.2516p ps=2.16u w=0.74u l=0.13u
X86 VSS.t26 a_5375_1437# a_6212_1076# VSS.t25 sg13_lv_nmos ad=0.1406p pd=1.12u as=0.2516p ps=2.16u w=0.74u l=0.13u
X87 a_3924_1514# a_2879_1076# a_3830_1514# VSS.t18 sg13_lv_nmos ad=60.89999f pd=0.71u as=0.1428p ps=1.52u w=0.42u l=0.13u
X88 a_4404_1501# a_4116_1080# a_4342_1501# VSS.t22 sg13_lv_nmos ad=0.1428p pd=1.52u as=37.8f ps=0.6u w=0.42u l=0.13u
X89 VDD a_2272_1318# a_2217_1199# VDD sg13_lv_pmos ad=1.06255p pd=6.38u as=93.45f ps=0.865u w=0.42u l=0.13u
X90 a_4404_1501# a_4635_1087# a_4090_1044# VSS.t31 sg13_lv_nmos ad=0.2373p pd=1.97u as=79.8f ps=0.8u w=0.42u l=0.13u
X91 a_4533_293# DELAY_OUT VSS.t13 VSS.t12 sg13_lv_nmos ad=0.2516p pd=2.16u as=1.45407p ps=9.445u w=0.74u l=0.13u
X92 a_4090_537# a_4533_293# a_3830_314# VSS.t33 sg13_lv_nmos ad=79.8f pd=0.8u as=0.1296p ps=1.52u w=0.42u l=0.13u
X93 a_5577_1199# a_4635_1087# a_5375_1437# VDD sg13_lv_pmos ad=93.45f pd=0.865u as=0.2048p ps=1.63u w=0.42u l=0.13u
X94 a_4404_327# a_4116_632# a_4342_327# VSS.t38 sg13_lv_nmos ad=0.1428p pd=1.52u as=37.8f ps=0.6u w=0.42u l=0.13u
X95 a_4533_293# DELAY_OUT VDD VDD sg13_lv_pmos ad=0.4088p pd=2.97u as=1.06255p ps=6.38u w=1.12u l=0.13u
X96 VSS.t6 a_2015_1437# a_2682_1076# VSS.t5 sg13_lv_nmos ad=0.1406p pd=1.12u as=0.2516p ps=2.16u w=0.74u l=0.13u
X97 DOWN_INV a_5375_391# VSS.t47 VSS.t46 sg13_lv_nmos ad=0.2849p pd=2.25u as=0.2516p ps=2.16u w=0.74u l=0.13u
X98 VDD a_5375_391# a_6212_612# VDD sg13_lv_pmos ad=0.2128p pd=1.5u as=0.3864p ps=2.93u w=1.12u l=0.13u
X99 a_4473_705# a_4116_632# VDD VDD sg13_lv_pmos ad=63f pd=0.72u as=0.1563p ps=1.22u w=0.42u l=0.13u
X100 a_1044_1501# a_1275_1087# a_730_1044# VSS.t8 sg13_lv_nmos ad=0.2373p pd=1.97u as=79.8f ps=0.8u w=0.42u l=0.13u
X101 VDD a_3373_1076# a_3830_1514# VDD sg13_lv_pmos ad=0.36237p pd=2.605u as=79.8f ps=0.8u w=0.42u l=0.13u
X102 a_2217_1199# a_1275_1087# a_2015_1437# VDD sg13_lv_pmos ad=93.45f pd=0.865u as=0.2048p ps=1.63u w=0.42u l=0.13u
X103 VSS.t52 a_5632_534# a_5281_391# VSS.t51 sg13_lv_nmos ad=79.8f pd=0.8u as=0.1428p ps=1.52u w=0.42u l=0.13u
X104 a_4404_327# a_4635_436# a_4090_537# VSS.t29 sg13_lv_nmos ad=0.2373p pd=1.97u as=79.8f ps=0.8u w=0.42u l=0.13u
X105 a_4116_632# a_4090_537# VDD VDD sg13_lv_pmos ad=0.34p pd=2.68u as=0.36237p ps=2.605u w=1u l=0.13u
X106 VSS.t13 a_3431_395# a_3431_395# VSS.t27 sg13_lv_nmos ad=1.45407p pd=9.445u as=0.111p ps=1.34u w=0.3u l=0.13u
X107 DOWN a_6212_612# VDD VDD sg13_lv_pmos ad=0.3808p pd=2.92u as=0.2128p ps=1.5u w=1.12u l=0.13u
X108 VDD a_3373_1076# a_4090_537# VDD sg13_lv_pmos ad=0.1563p pd=1.22u as=0.147p ps=1.54u w=0.42u l=0.13u
X109 a_5794_314# a_3373_1076# VSS.t52 VSS.t65 sg13_lv_nmos ad=37.8f pd=0.6u as=79.8f ps=0.8u w=0.42u l=0.13u
X110 VDD DLL_RESETN a_470_1514# VDD sg13_lv_pmos ad=0.36237p pd=2.605u as=79.8f ps=0.8u w=0.42u l=0.13u
X111 a_3467_1076# UP VDD VDD sg13_lv_pmos ad=0.3808p pd=2.92u as=0.2128p ps=1.5u w=1.12u l=0.13u
X112 a_564_1514# a_296_1052# a_470_1514# VSS.t2 sg13_lv_nmos ad=60.89999f pd=0.71u as=0.1428p ps=1.52u w=0.42u l=0.13u
X113 a_4533_1087# DELAY_IN VSS.t3 VSS.t43 sg13_lv_nmos ad=0.2516p pd=2.16u as=1.9173p ps=12.365u w=0.74u l=0.13u
X114 a_5632_534# a_5375_391# a_5794_314# VSS.t45 sg13_lv_nmos ad=0.1428p pd=1.52u as=37.8f ps=0.6u w=0.42u l=0.13u
X115 a_4116_632# a_4090_537# VSS.t54 VSS.t53 sg13_lv_nmos ad=0.2516p pd=2.16u as=0.1626p ps=1.415u w=0.74u l=0.13u
C0 a_4404_327# a_4533_293# 0.01562f
C1 DELAY_IN a_4635_1087# 0.02263f
C2 UP a_6212_1076# 0.17255f
C3 a_3431_629# a_3630_566# 0.14994f
C4 a_4635_436# a_5375_391# 0.26905f
C5 a_4533_1087# a_4090_1044# 0.02242f
C6 VDD a_5375_1437# 0.25849f
C7 a_3830_314# a_4090_537# 0.75507f
C8 VDD a_3656_629# 0.25347f
C9 a_3431_395# a_3630_566# 0.02437f
C10 VDD UP_INV 0.40674f
C11 a_3373_1076# a_2879_1076# 0.07687f
C12 UP a_5632_1318# 0.03701f
C13 a_3373_1076# a_4635_436# 0.42064f
C14 UP DELAY_OUT 0.04332f
C15 DELAY_IN a_2682_1076# 0.01309f
C16 VDD a_3830_314# 0.80534f
C17 a_2682_1076# DLL_RESETN 0.02442f
C18 DOWN a_5375_1437# 0.01651f
C19 UP_INV DOWN 0.06562f
C20 UP a_5375_391# 0.02457f
C21 a_2272_1318# VDD 0.1754f
C22 a_3830_1514# a_3373_1076# 0.12097f
C23 DLL_RESETN a_3630_566# 0.01259f
C24 a_2272_1318# a_1275_1087# 0.03061f
C25 a_3180_1073# a_2879_1076# 0.03277f
C26 DELAY_IN a_4116_1080# 0.11539f
C27 a_470_1514# a_1173_1087# 0.02432f
C28 a_3373_1076# UP 0.54766f
C29 a_4635_436# a_4116_632# 0.34114f
C30 a_270_1014# a_71_1151# 0.14994f
C31 a_4116_1080# a_5281_1437# 0.43239f
C32 a_3830_1514# a_4404_1501# 0.31978f
C33 a_730_1044# a_756_1080# 0.36952f
C34 a_3830_1514# a_4533_1087# 0.02432f
C35 a_3467_1076# UP 0.09118f
C36 a_4533_1087# UP 0.01604f
C37 DOWN_INV a_5632_534# 0.12158f
C38 a_470_1514# VDD 0.81635f
C39 a_470_1514# a_1275_1087# 0.097f
C40 a_4635_436# UP_INV 0.0176f
C41 a_6212_612# DOWN_INV 0.1953f
C42 a_4635_436# a_3830_314# 0.097f
C43 a_2015_1437# a_756_1080# 0.01529f
C44 UP a_5375_1437# 0.03388f
C45 a_470_1514# a_1044_1501# 0.31978f
C46 UP UP_INV 0.3345f
C47 VDD a_71_1381# 0.06702f
C48 a_1173_1087# VDD 0.24968f
C49 a_3373_1076# DELAY_IN 0.25632f
C50 a_1173_1087# a_1275_1087# 0.47795f
C51 a_730_1044# DLL_RESETN 0.27343f
C52 a_3373_1076# DLL_RESETN 0.34333f
C53 a_4116_1080# a_4635_1087# 0.34102f
C54 VDD a_4090_537# 0.09979f
C55 a_3467_1076# DLL_RESETN 0.03616f
C56 DELAY_OUT a_5632_534# 0.01399f
C57 a_470_1514# a_296_1052# 0.27179f
C58 a_4533_1087# DELAY_IN 0.25847f
C59 a_3180_1073# DELAY_IN 0.01215f
C60 a_1173_1087# a_1044_1501# 0.01562f
C61 DELAY_IN a_4116_632# 0.03445f
C62 a_3180_1073# DLL_RESETN 0.11782f
C63 a_6212_612# DELAY_OUT 0.01702f
C64 a_3656_629# a_3431_629# 0.02416f
C65 a_4533_1087# a_5281_1437# 0.01058f
C66 a_1275_1087# VDD 0.23078f
C67 a_4404_327# a_4116_632# 0.43707f
C68 a_5632_534# a_5375_391# 0.29858f
C69 a_2015_1437# DELAY_IN 0.01827f
C70 a_6212_612# a_5375_391# 0.08776f
C71 a_3373_1076# a_5632_534# 0.10521f
C72 a_2015_1437# DLL_RESETN 0.14622f
C73 VDD DOWN 0.47901f
C74 a_5632_1318# a_4635_1087# 0.03093f
C75 DELAY_OUT a_4533_293# 0.25594f
C76 DELAY_IN a_3656_629# 0.02025f
C77 DELAY_IN UP_INV 0.01066f
C78 a_1275_1087# a_1044_1501# 0.12701f
C79 VDD a_4090_1044# 0.09483f
C80 a_3656_629# DLL_RESETN 0.01683f
C81 a_470_1514# a_756_1080# 0.41329f
C82 a_5281_1437# a_5375_1437# 0.28931f
C83 DELAY_IN a_3830_314# 0.06166f
C84 a_4404_327# a_3830_314# 0.31978f
C85 a_3373_1076# a_4533_293# 0.03463f
C86 a_2272_1318# DELAY_IN 0.0148f
C87 a_3373_1076# a_4635_1087# 0.42174f
C88 a_2272_1318# DLL_RESETN 0.11133f
C89 a_296_1052# VDD 0.2537f
C90 a_2015_1437# a_1921_1437# 0.28931f
C91 VDD a_2879_1076# 0.40041f
C92 DELAY_OUT DOWN_INV 0.01904f
C93 a_4635_436# VDD 0.3501f
C94 a_4404_1501# a_4635_1087# 0.12701f
C95 a_1173_1087# a_756_1080# 0.37583f
C96 UP_INV a_5632_534# 0.01776f
C97 DOWN_INV a_5375_391# 0.04511f
C98 a_4533_1087# a_4635_1087# 0.47795f
C99 a_4533_293# a_4116_632# 0.3749f
C100 DOWN a_2879_1076# 0.3846f
C101 a_3830_1514# VDD 0.78103f
C102 UP VDD 1.09349f
C103 a_270_1014# a_71_1381# 0.02437f
C104 a_3373_1076# a_4116_1080# 0.38817f
C105 a_470_1514# DLL_RESETN 0.09997f
C106 a_756_1080# VDD 0.09601f
C107 a_1275_1087# a_756_1080# 0.34102f
C108 UP DOWN 0.54929f
C109 a_4404_1501# a_4116_1080# 0.43707f
C110 a_5375_1437# a_4635_1087# 0.26905f
C111 UP_INV a_4635_1087# 0.01811f
C112 a_2015_1437# a_2682_1076# 0.0894f
C113 a_4533_1087# a_4116_1080# 0.37583f
C114 a_3830_1514# a_4090_1044# 0.75507f
C115 a_3830_314# a_4533_293# 0.02454f
C116 UP a_4090_1044# 0.01158f
C117 a_270_1014# VDD 0.09704f
C118 a_1173_1087# DELAY_IN 0.25484f
C119 VDD a_3431_629# 0.08229f
C120 a_756_1080# a_1044_1501# 0.43707f
C121 a_1173_1087# DLL_RESETN 0.05713f
C122 DELAY_OUT a_5375_391# 0.02109f
C123 VDD a_3431_395# 0.0643f
C124 a_3373_1076# a_5632_1318# 0.10225f
C125 a_3830_1514# a_2879_1076# 0.26489f
C126 DELAY_IN a_4090_537# 0.01093f
C127 a_3373_1076# DELAY_OUT 0.01467f
C128 a_3656_629# a_3630_566# 0.1657f
C129 UP a_2879_1076# 0.05795f
C130 a_4116_1080# a_5375_1437# 0.01529f
C131 a_5281_391# a_4533_293# 0.01058f
C132 a_3373_1076# a_5375_391# 0.13376f
C133 DELAY_IN VDD 0.38114f
C134 a_2272_1318# a_2682_1076# 0.10373f
C135 VDD a_4404_327# 0.03137f
C136 VDD DLL_RESETN 2.08693f
C137 a_1275_1087# DELAY_IN 0.01931f
C138 DOWN a_3569_1424# 0.01249f
C139 a_1275_1087# DLL_RESETN 0.45018f
C140 a_3830_1514# UP 0.01008f
C141 DELAY_OUT a_4116_632# 0.08062f
C142 DELAY_IN DOWN 0.35409f
C143 a_1173_1087# a_1921_1437# 0.01058f
C144 DOWN DLL_RESETN 0.01405f
C145 a_6212_1076# a_5375_1437# 0.08776f
C146 a_3373_1076# a_3467_1076# 0.16706f
C147 UP_INV a_6212_1076# 0.19136f
C148 a_5375_391# a_4116_632# 0.01529f
C149 a_296_1052# a_270_1014# 0.1657f
C150 a_3373_1076# a_4533_1087# 0.03525f
C151 a_3373_1076# a_3180_1073# 0.33075f
C152 DELAY_IN a_4090_1044# 0.01538f
C153 a_3373_1076# a_4116_632# 0.38072f
C154 a_5375_1437# a_5632_1318# 0.29858f
C155 UP_INV a_5632_1318# 0.17494f
C156 VDD a_5632_534# 0.13846f
C157 a_4533_1087# a_4404_1501# 0.01562f
C158 DELAY_OUT UP_INV 0.05118f
C159 VDD a_6212_612# 0.31892f
C160 UP_INV a_5375_391# 0.04856f
C161 DELAY_IN a_2879_1076# 1.0042f
C162 a_296_1052# DLL_RESETN 0.06592f
C163 a_3373_1076# a_5375_1437# 0.13392f
C164 a_4533_293# a_4090_537# 0.02242f
C165 DLL_RESETN a_2879_1076# 0.04879f
C166 a_3373_1076# a_3656_629# 0.06256f
C167 a_4635_436# a_4404_327# 0.12701f
C168 a_3373_1076# UP_INV 0.0589f
C169 a_6212_612# DOWN 0.12861f
C170 VDD a_4533_293# 0.30274f
C171 a_3373_1076# a_3830_314# 0.10675f
C172 a_3830_1514# DELAY_IN 0.05059f
C173 VDD a_4635_1087# 0.22908f
C174 UP DELAY_IN 1.40135f
C175 UP DLL_RESETN 0.04333f
C176 UP_INV a_4116_632# 0.01817f
C177 a_5281_391# a_5375_391# 0.28931f
C178 DELAY_IN a_756_1080# 0.08086f
C179 VDD a_2682_1076# 0.39251f
C180 a_4635_436# a_5632_534# 0.03012f
C181 a_756_1080# DLL_RESETN 0.39088f
C182 a_3830_314# a_4116_632# 0.41329f
C183 a_3431_395# a_3431_629# 0.1117f
C184 VDD DOWN_INV 0.16479f
C185 VDD a_3630_566# 0.10008f
C186 VDD a_4116_1080# 0.07868f
C187 UP_INV a_5375_1437# 0.12121f
C188 a_470_1514# a_730_1044# 0.75507f
C189 a_71_1151# a_71_1381# 0.1117f
C190 DOWN_INV DOWN 0.0413f
C191 a_2015_1437# a_2272_1318# 0.34468f
C192 UP a_5632_534# 0.05693f
C193 DLL_RESETN a_3431_629# 0.04228f
C194 a_3830_314# a_3656_629# 0.27179f
C195 a_5281_391# a_4116_632# 0.43239f
C196 a_4116_1080# DOWN 0.04178f
C197 a_3431_395# DLL_RESETN 0.02116f
C198 a_4635_436# a_4533_293# 0.47622f
C199 a_1921_1437# a_756_1080# 0.43239f
C200 VDD a_6212_1076# 0.31235f
C201 a_4116_1080# a_4090_1044# 0.36952f
C202 DELAY_IN DLL_RESETN 1.60875f
C203 a_71_1151# VDD 0.08599f
C204 a_1173_1087# a_730_1044# 0.02242f
C205 a_3830_1514# a_4635_1087# 0.097f
C206 a_2682_1076# a_2879_1076# 0.12454f
C207 VDD a_5632_1318# 0.13564f
C208 a_5281_391# UP_INV 0.02171f
C209 DOWN a_6212_1076# 0.0195f
C210 VDD DELAY_OUT 0.30669f
C211 UP a_4635_1087# 0.0235f
C212 a_3373_1076# a_4090_537# 0.26312f
C213 VDD a_5375_391# 0.26425f
C214 DELAY_OUT DOWN 0.0709f
C215 a_3373_1076# VDD 2.97599f
C216 a_730_1044# VDD 0.11162f
C217 UP DOWN_INV 0.25465f
C218 a_3830_1514# a_4116_1080# 0.41329f
C219 a_4116_632# a_4090_537# 0.36952f
C220 a_3467_1076# VDD 0.3011f
C221 a_3373_1076# DOWN 0.12815f
C222 UP a_4116_1080# 0.01445f
C223 a_4533_1087# VDD 0.25176f
C224 a_3180_1073# VDD 0.27069f
C225 VDD a_4116_632# 0.13053f
C226 a_296_1052# a_71_1151# 0.02416f
C227 a_3467_1076# DOWN 0.03346f
C228 a_3373_1076# a_4090_1044# 0.27346f
C229 a_2015_1437# VDD 0.18135f
C230 a_4635_436# DELAY_OUT 0.02024f
C231 a_2015_1437# a_1275_1087# 0.26905f
C232 a_3180_1073# DOWN 0.04193f
R0 VSS.n270 VSS.n269 16686.3
R1 VSS.t61 VSS.n14 365.469
R2 VSS.t2 VSS.t3 499.64
R3 VSS.t59 VSS.n9 23.2162
R4 VSS.t16 VSS.n4 29.6918
R5 VSS.n10 VSS.t23 22.6691
R6 VSS.n122 VSS.t39 679.803
R7 VSS.n3 VSS.t40 651.692
R8 VSS.t20 VSS.n6 640.337
R9 VSS.t15 VSS.n2 640.337
R10 VSS.t11 VSS.n114 605.912
R11 VSS.t5 VSS.n5 577.799
R12 VSS.t18 VSS.n3 540.855
R13 VSS.n273 VSS.t46 534.125
R14 VSS.t21 VSS.n13 293.077
R15 VSS.t4 VSS.n12 293.077
R16 VSS.n276 VSS.t30 492.065
R17 VSS.n279 VSS.t34 476.291
R18 VSS.t43 VSS.n13 482.704
R19 VSS.n12 VSS.t42 482.704
R20 VSS.n277 VSS.t35 449.822
R21 VSS.t49 VSS.n59 444.89
R22 VSS.t0 VSS.n160 444.89
R23 VSS.n11 VSS.t32 450.452
R24 VSS.t51 VSS.n274 428.572
R25 VSS.n11 VSS.t3 9.51091
R26 VSS.t62 VSS.t22 372.747
R27 VSS.t19 VSS.n55 372.747
R28 VSS.t55 VSS.t10 372.747
R29 VSS.t14 VSS.n156 372.747
R30 VSS.t12 VSS.n277 366.325
R31 VSS.n15 VSS.t27 255.85
R32 VSS.t31 VSS.n6 353.19
R33 VSS.t8 VSS.n2 353.19
R34 VSS.t53 VSS.n282 345.257
R35 VSS.t65 VSS.t45 328.043
R36 VSS.n271 VSS.t36 327.274
R37 VSS.t18 VSS.n14 187.441
R38 VSS.n272 VSS.t48 311.012
R39 VSS.n11 VSS.t25 173.609
R40 VSS.t67 VSS.t38 289.269
R41 VSS.t33 VSS.n280 289.269
R42 VSS.n269 VSS.t32 282.233
R43 VSS.t29 VSS.n279 277.658
R44 VSS.n8 VSS.t43 253.851
R45 VSS.t42 VSS.n0 253.851
R46 VSS.n55 VSS.t31 240.482
R47 VSS.n156 VSS.t8 240.482
R48 VSS.t4 VSS.n5 230.51
R49 VSS.t48 VSS.n271 229.091
R50 VSS.n7 VSS.t19 220.464
R51 VSS.n1 VSS.t14 220.464
R52 VSS.n10 VSS.t21 230.349
R53 VSS.t36 VSS.n270 212.328
R54 VSS.n278 VSS.t12 191.15
R55 VSS.n280 VSS.t29 186.625
R56 VSS.n281 VSS.t33 174.433
R57 VSS.t22 VSS.n7 166.356
R58 VSS.t10 VSS.n1 166.356
R59 VSS.n114 VSS.t5 147.784
R60 VSS.t38 VSS.n281 132.442
R61 VSS.t27 VSS.t53 112.361
R62 VSS.n274 VSS.t65 111.112
R63 VSS.n8 VSS.t20 105.337
R64 VSS.n0 VSS.t15 105.337
R65 VSS.t2 VSS.t57 101.124
R66 VSS.n275 VSS.t51 95.8155
R67 VSS.t45 VSS.n273 84.7268
R68 VSS.t34 VSS.n278 81.6614
R69 VSS.t35 VSS.n276 74.0746
R70 VSS.t40 VSS.n122 73.8921
R71 VSS.n59 VSS.t62 54.1087
R72 VSS.n160 VSS.t55 54.1087
R73 VSS.t39 VSS.n4 45.7968
R74 VSS.n282 VSS.t67 41.9912
R75 VSS.t30 VSS.n275 32.3245
R76 VSS.n10 VSS.t3 0.549965
R77 VSS.t3 VSS.n9 0.00247198
R78 VSS.t46 VSS.n272 21.922
R79 VSS.n194 VSS.t3 17.174
R80 VSS.n271 VSS.t13 17.0005
R81 VSS.n274 VSS.t13 17.0005
R82 VSS.n276 VSS.t13 17.0005
R83 VSS.n280 VSS.t13 17.0005
R84 VSS.n282 VSS.t13 17.0005
R85 VSS.n42 VSS.t13 17.0005
R86 VSS.t3 VSS.n268 17.0005
R87 VSS.t3 VSS.t28 17.0005
R88 VSS.t3 VSS.n60 17.0005
R89 VSS.t3 VSS.n59 17.0005
R90 VSS.t3 VSS.n56 17.0005
R91 VSS.t3 VSS.n55 17.0005
R92 VSS.t3 VSS.n114 17.0005
R93 VSS.t3 VSS.n120 17.0005
R94 VSS.t3 VSS.n122 17.0005
R95 VSS.t3 VSS.n14 14.1445
R96 VSS.n220 VSS.t3 17.0005
R97 VSS.t3 VSS.t7 17.0005
R98 VSS.t3 VSS.n161 17.0005
R99 VSS.t3 VSS.n160 17.0005
R100 VSS.t3 VSS.n159 17.0005
R101 VSS.t3 VSS.n156 17.0005
R102 VSS.t3 VSS.n182 17.0005
R103 VSS.t61 VSS.t49 11.2365
R104 VSS.t57 VSS.t0 11.2365
R105 VSS.n199 VSS.n198 9.13412
R106 VSS.n71 VSS.n51 9.13412
R107 VSS.n28 VSS.n21 9.07383
R108 VSS.n283 VSS.n45 9.07383
R109 VSS.n293 VSS.n292 9.0005
R110 VSS.n20 VSS.n18 9.0005
R111 VSS.n290 VSS.n289 9.0005
R112 VSS.n288 VSS.n44 9.0005
R113 VSS.n41 VSS.n40 9.0005
R114 VSS.n287 VSS.n286 9.0005
R115 VSS.n34 VSS.n33 9.0005
R116 VSS.n36 VSS.n35 9.0005
R117 VSS.n37 VSS.n29 9.0005
R118 VSS.n39 VSS.n38 9.0005
R119 VSS.n33 VSS.n32 9.0005
R120 VSS.n36 VSS.n31 9.0005
R121 VSS.n37 VSS.n30 9.0005
R122 VSS.n38 VSS.t52 9.0005
R123 VSS.n48 VSS.n46 9.0005
R124 VSS.n286 VSS.n285 9.0005
R125 VSS.n47 VSS.n44 9.0005
R126 VSS.t68 VSS.n290 9.0005
R127 VSS.n42 VSS.n20 9.0005
R128 VSS.n292 VSS.n291 9.0005
R129 VSS.n26 VSS.n41 9.0005
R130 VSS.n27 VSS.t37 9.0005
R131 VSS.n184 VSS.n183 9.0005
R132 VSS.n196 VSS.n195 9.0005
R133 VSS.n192 VSS.n191 9.0005
R134 VSS.n190 VSS.n182 9.0005
R135 VSS.n186 VSS.n181 9.0005
R136 VSS.t1 VSS.n179 9.0005
R137 VSS.n201 VSS.n180 9.0005
R138 VSS.n202 VSS.t56 9.0005
R139 VSS.n203 VSS.n159 9.0005
R140 VSS.n205 VSS.n204 9.0005
R141 VSS.n207 VSS.n206 9.0005
R142 VSS.n209 VSS.n208 9.0005
R143 VSS.n211 VSS.n210 9.0005
R144 VSS.n213 VSS.n212 9.0005
R145 VSS.n215 VSS.n214 9.0005
R146 VSS.n216 VSS.n161 9.0005
R147 VSS.n218 VSS.n217 9.0005
R148 VSS.n162 VSS.n153 9.0005
R149 VSS.n220 VSS.n152 9.0005
R150 VSS.n221 VSS.n151 9.0005
R151 VSS.n223 VSS.n150 9.0005
R152 VSS.n224 VSS.n147 9.0005
R153 VSS.n225 VSS.n149 9.0005
R154 VSS.n226 VSS.t7 9.0005
R155 VSS.n228 VSS.n227 9.0005
R156 VSS.n230 VSS.n229 9.0005
R157 VSS.n232 VSS.n231 9.0005
R158 VSS.t6 VSS.n233 9.0005
R159 VSS.n235 VSS.n234 9.0005
R160 VSS.n237 VSS.n236 9.0005
R161 VSS.n238 VSS.t60 9.0005
R162 VSS.n239 VSS.n118 9.0005
R163 VSS.n241 VSS.n240 9.0005
R164 VSS.n242 VSS.t17 9.0005
R165 VSS.n243 VSS.n120 9.0005
R166 VSS.n245 VSS.n244 9.0005
R167 VSS.n125 VSS.n246 9.0005
R168 VSS.t41 VSS.n124 9.0005
R169 VSS.n129 VSS.n123 9.0005
R170 VSS.n128 VSS.n112 9.0005
R171 VSS.t50 VSS.n110 9.0005
R172 VSS.n249 VSS.n111 9.0005
R173 VSS.t63 VSS.n250 9.0005
R174 VSS.n252 VSS.n251 9.0005
R175 VSS.n106 VSS.n105 9.0005
R176 VSS.n258 VSS.n257 9.0005
R177 VSS.n260 VSS.n259 9.0005
R178 VSS.n262 VSS.n261 9.0005
R179 VSS.n263 VSS.n60 9.0005
R180 VSS.n265 VSS.n264 9.0005
R181 VSS.n267 VSS.n266 9.0005
R182 VSS.n268 VSS.n63 9.0005
R183 VSS.n96 VSS.n62 9.0005
R184 VSS.n95 VSS.n94 9.0005
R185 VSS.n92 VSS.n65 9.0005
R186 VSS.n66 VSS.n90 9.0005
R187 VSS.n67 VSS.t28 9.0005
R188 VSS.n85 VSS.n84 9.0005
R189 VSS.n83 VSS.t24 9.0005
R190 VSS.n82 VSS.n81 9.0005
R191 VSS.n75 VSS.n69 9.0005
R192 VSS.n77 VSS.n76 9.0005
R193 VSS.n74 VSS.t26 9.0005
R194 VSS.n73 VSS.n72 9.0005
R195 VSS.n257 VSS.n104 9.0005
R196 VSS.n260 VSS.n103 9.0005
R197 VSS.n262 VSS.n102 9.0005
R198 VSS.n263 VSS.n101 9.0005
R199 VSS.n265 VSS.n100 9.0005
R200 VSS.n266 VSS.n99 9.0005
R201 VSS.n98 VSS.n63 9.0005
R202 VSS.n97 VSS.n96 9.0005
R203 VSS.n95 VSS.n64 9.0005
R204 VSS.n88 VSS.n65 9.0005
R205 VSS.n90 VSS.n89 9.0005
R206 VSS.n87 VSS.n67 9.0005
R207 VSS.n86 VSS.n85 9.0005
R208 VSS.n83 VSS.n68 9.0005
R209 VSS.n81 VSS.n80 9.0005
R210 VSS.n79 VSS.n69 9.0005
R211 VSS.n78 VSS.n77 9.0005
R212 VSS.n74 VSS.n70 9.0005
R213 VSS.n197 VSS.n196 9.0005
R214 VSS.n191 VSS.n185 9.0005
R215 VSS.n190 VSS.n189 9.0005
R216 VSS.n188 VSS.n186 9.0005
R217 VSS.n187 VSS.n179 9.0005
R218 VSS.n201 VSS.n178 9.0005
R219 VSS.n202 VSS.n177 9.0005
R220 VSS.n203 VSS.n176 9.0005
R221 VSS.n205 VSS.n175 9.0005
R222 VSS.n206 VSS.n174 9.0005
R223 VSS.n209 VSS.n173 9.0005
R224 VSS.n210 VSS.n172 9.0005
R225 VSS.n213 VSS.n171 9.0005
R226 VSS.n215 VSS.n170 9.0005
R227 VSS.n216 VSS.n169 9.0005
R228 VSS.n217 VSS.n168 9.0005
R229 VSS.n167 VSS.n162 9.0005
R230 VSS.n166 VSS.n152 9.0005
R231 VSS.n165 VSS.n151 9.0005
R232 VSS.n164 VSS.n150 9.0005
R233 VSS.n163 VSS.n147 9.0005
R234 VSS.n225 VSS.n146 9.0005
R235 VSS.n226 VSS.n145 9.0005
R236 VSS.n228 VSS.n144 9.0005
R237 VSS.n229 VSS.n143 9.0005
R238 VSS.n232 VSS.n142 9.0005
R239 VSS.n233 VSS.n141 9.0005
R240 VSS.n235 VSS.n140 9.0005
R241 VSS.n237 VSS.n139 9.0005
R242 VSS.n238 VSS.n138 9.0005
R243 VSS.n239 VSS.n137 9.0005
R244 VSS.n241 VSS.n136 9.0005
R245 VSS.n242 VSS.n135 9.0005
R246 VSS.n243 VSS.n134 9.0005
R247 VSS.n245 VSS.n133 9.0005
R248 VSS.n246 VSS.n132 9.0005
R249 VSS.n131 VSS.n124 9.0005
R250 VSS.n130 VSS.n129 9.0005
R251 VSS.n128 VSS.n127 9.0005
R252 VSS.n126 VSS.n110 9.0005
R253 VSS.n249 VSS.n109 9.0005
R254 VSS.n250 VSS.n108 9.0005
R255 VSS.n253 VSS.n252 9.0005
R256 VSS.n254 VSS.n106 9.0005
R257 VSS.t13 VSS.n21 8.53039
R258 VSS.t13 VSS.n15 0.00216378
R259 VSS.n13 VSS.t3 9.30615
R260 VSS.n12 VSS.t3 9.30615
R261 VSS.t13 VSS.n22 8.47111
R262 VSS.t13 VSS.n23 8.47111
R263 VSS.t13 VSS.n16 8.47111
R264 VSS.n43 VSS.t13 8.47111
R265 VSS.t54 VSS.t13 8.47111
R266 VSS.n284 VSS.t13 8.47111
R267 VSS.t3 VSS.n52 8.47111
R268 VSS.t3 VSS.n49 8.47111
R269 VSS.t3 VSS.n50 8.47111
R270 VSS.t3 VSS.n51 8.47111
R271 VSS.n93 VSS.t3 8.47111
R272 VSS.n91 VSS.t3 8.47111
R273 VSS.t3 VSS.n53 8.47111
R274 VSS.t3 VSS.n61 8.47111
R275 VSS.t3 VSS.n58 8.47111
R276 VSS.t3 VSS.n54 8.47111
R277 VSS.n248 VSS.t3 8.47111
R278 VSS.t3 VSS.n57 8.47111
R279 VSS.t3 VSS.n113 8.47111
R280 VSS.t3 VSS.n115 8.47111
R281 VSS.t3 VSS.n116 8.47111
R282 VSS.t3 VSS.n117 8.47111
R283 VSS.t3 VSS.n119 8.47111
R284 VSS.t3 VSS.n121 8.47111
R285 VSS.t3 VSS.n247 8.47111
R286 VSS.n222 VSS.t3 8.47111
R287 VSS.n148 VSS.t3 8.47111
R288 VSS.t3 VSS.n154 8.47111
R289 VSS.t3 VSS.n219 8.47111
R290 VSS.t3 VSS.n157 8.47111
R291 VSS.t3 VSS.n155 8.47111
R292 VSS.n200 VSS.t3 8.47111
R293 VSS.t3 VSS.n158 8.47111
R294 VSS.n193 VSS.t3 8.47111
R295 VSS.t3 VSS.n199 8.47576
R296 VSS.n287 VSS.n45 4.64666
R297 VSS.n40 VSS.n28 4.64666
R298 VSS.n198 VSS.n197 4.64666
R299 VSS.n71 VSS.n70 4.64666
R300 VSS.n24 VSS.n19 4.4712
R301 VSS.n256 VSS.n107 4.4712
R302 VSS.n19 VSS.n17 4.46488
R303 VSS.n256 VSS.n255 4.46488
R304 VSS.t13 VSS.n25 2.72142
R305 VSS.t13 VSS.t47 1.72291
R306 VSS.n40 VSS.n39 1.3114
R307 VSS.n34 VSS.n17 0.801519
R308 VSS.n256 VSS.n19 0.66578
R309 VSS.n281 VSS.t13 0.600709
R310 VSS.n26 VSS.t47 0.580003
R311 VSS.n273 VSS.t13 0.529646
R312 VSS.n277 VSS.t13 0.521757
R313 VSS.n270 VSS.t13 0.519259
R314 VSS.n278 VSS.t13 0.517489
R315 VSS.t3 VSS.n7 0.473876
R316 VSS.t3 VSS.n1 0.473876
R317 VSS.t52 VSS.t47 0.46045
R318 VSS.n288 VSS.n287 0.437466
R319 VSS.n269 VSS.t3 0.389775
R320 VSS.t3 VSS.n5 0.389775
R321 VSS.t3 VSS.n4 0.37382
R322 VSS.t3 VSS.n3 0.389775
R323 VSS.t3 VSS.n8 0.387948
R324 VSS.t3 VSS.n0 0.387948
R325 VSS.n25 VSS.n24 0.356695
R326 VSS.n32 VSS.n25 0.294861
R327 VSS.n293 VSS.n17 0.218898
R328 VSS.n255 VSS.n254 0.218898
R329 VSS.n255 VSS.n104 0.218898
R330 VSS.n285 VSS.t54 0.180789
R331 VSS.t54 VSS.n47 0.180789
R332 VSS.n289 VSS.n288 0.146155
R333 VSS.n289 VSS.n18 0.146155
R334 VSS.n293 VSS.n18 0.146155
R335 VSS.n35 VSS.n34 0.146155
R336 VSS.n35 VSS.n29 0.146155
R337 VSS.n39 VSS.n29 0.146155
R338 VSS.n36 VSS.n33 0.146155
R339 VSS.n37 VSS.n36 0.146155
R340 VSS.n38 VSS.n37 0.146155
R341 VSS.n260 VSS.n257 0.146155
R342 VSS.n262 VSS.n260 0.146155
R343 VSS.n263 VSS.n262 0.146155
R344 VSS.n265 VSS.n263 0.146155
R345 VSS.n266 VSS.n265 0.146155
R346 VSS.n266 VSS.n63 0.146155
R347 VSS.n96 VSS.n63 0.146155
R348 VSS.n96 VSS.n95 0.146155
R349 VSS.n95 VSS.n65 0.146155
R350 VSS.n90 VSS.n65 0.146155
R351 VSS.n90 VSS.n67 0.146155
R352 VSS.n85 VSS.n67 0.146155
R353 VSS.n85 VSS.n83 0.146155
R354 VSS.n83 VSS.n81 0.146155
R355 VSS.n81 VSS.n69 0.146155
R356 VSS.n77 VSS.n69 0.146155
R357 VSS.n77 VSS.n74 0.146155
R358 VSS.n74 VSS.n72 0.146155
R359 VSS.n197 VSS.n185 0.146155
R360 VSS.n189 VSS.n185 0.146155
R361 VSS.n189 VSS.n188 0.146155
R362 VSS.n188 VSS.n187 0.146155
R363 VSS.n187 VSS.n178 0.146155
R364 VSS.n178 VSS.n177 0.146155
R365 VSS.n177 VSS.n176 0.146155
R366 VSS.n176 VSS.n175 0.146155
R367 VSS.n175 VSS.n174 0.146155
R368 VSS.n174 VSS.n173 0.146155
R369 VSS.n173 VSS.n172 0.146155
R370 VSS.n172 VSS.n171 0.146155
R371 VSS.n171 VSS.n170 0.146155
R372 VSS.n170 VSS.n169 0.146155
R373 VSS.n169 VSS.n168 0.146155
R374 VSS.n168 VSS.n167 0.146155
R375 VSS.n167 VSS.n166 0.146155
R376 VSS.n166 VSS.n165 0.146155
R377 VSS.n165 VSS.n164 0.146155
R378 VSS.n164 VSS.n163 0.146155
R379 VSS.n163 VSS.n146 0.146155
R380 VSS.n146 VSS.n145 0.146155
R381 VSS.n145 VSS.n144 0.146155
R382 VSS.n144 VSS.n143 0.146155
R383 VSS.n143 VSS.n142 0.146155
R384 VSS.n142 VSS.n141 0.146155
R385 VSS.n141 VSS.n140 0.146155
R386 VSS.n140 VSS.n139 0.146155
R387 VSS.n139 VSS.n138 0.146155
R388 VSS.n138 VSS.n137 0.146155
R389 VSS.n137 VSS.n136 0.146155
R390 VSS.n136 VSS.n135 0.146155
R391 VSS.n135 VSS.n134 0.146155
R392 VSS.n134 VSS.n133 0.146155
R393 VSS.n133 VSS.n132 0.146155
R394 VSS.n132 VSS.n131 0.146155
R395 VSS.n131 VSS.n130 0.146155
R396 VSS.n130 VSS.n127 0.146155
R397 VSS.n127 VSS.n126 0.146155
R398 VSS.n126 VSS.n109 0.146155
R399 VSS.n109 VSS.n108 0.146155
R400 VSS.n253 VSS.n108 0.146155
R401 VSS.n254 VSS.n253 0.146155
R402 VSS.n104 VSS.n103 0.146155
R403 VSS.n103 VSS.n102 0.146155
R404 VSS.n102 VSS.n101 0.146155
R405 VSS.n101 VSS.n100 0.146155
R406 VSS.n100 VSS.n99 0.146155
R407 VSS.n99 VSS.n98 0.146155
R408 VSS.n98 VSS.n97 0.146155
R409 VSS.n97 VSS.n64 0.146155
R410 VSS.n88 VSS.n64 0.146155
R411 VSS.n89 VSS.n88 0.146155
R412 VSS.n89 VSS.n87 0.146155
R413 VSS.n87 VSS.n86 0.146155
R414 VSS.n86 VSS.n68 0.146155
R415 VSS.n80 VSS.n68 0.146155
R416 VSS.n80 VSS.n79 0.146155
R417 VSS.n79 VSS.n78 0.146155
R418 VSS.n78 VSS.n70 0.146155
R419 VSS.n196 VSS.n184 0.146155
R420 VSS.n196 VSS.n191 0.146155
R421 VSS.n191 VSS.n190 0.146155
R422 VSS.n190 VSS.n186 0.146155
R423 VSS.n186 VSS.n179 0.146155
R424 VSS.n201 VSS.n179 0.146155
R425 VSS.n202 VSS.n201 0.146155
R426 VSS.n203 VSS.n202 0.146155
R427 VSS.n205 VSS.n203 0.146155
R428 VSS.n206 VSS.n205 0.146155
R429 VSS.n209 VSS.n206 0.146155
R430 VSS.n210 VSS.n209 0.146155
R431 VSS.n213 VSS.n210 0.146155
R432 VSS.n215 VSS.n213 0.146155
R433 VSS.n216 VSS.n215 0.146155
R434 VSS.n217 VSS.n216 0.146155
R435 VSS.n217 VSS.n162 0.146155
R436 VSS.n162 VSS.n152 0.146155
R437 VSS.n152 VSS.n151 0.146155
R438 VSS.n151 VSS.n150 0.146155
R439 VSS.n150 VSS.n147 0.146155
R440 VSS.n225 VSS.n147 0.146155
R441 VSS.n226 VSS.n225 0.146155
R442 VSS.n228 VSS.n226 0.146155
R443 VSS.n229 VSS.n228 0.146155
R444 VSS.n232 VSS.n229 0.146155
R445 VSS.n233 VSS.n232 0.146155
R446 VSS.n235 VSS.n233 0.146155
R447 VSS.n237 VSS.n235 0.146155
R448 VSS.n238 VSS.n237 0.146155
R449 VSS.n239 VSS.n238 0.146155
R450 VSS.n241 VSS.n239 0.146155
R451 VSS.n242 VSS.n241 0.146155
R452 VSS.n243 VSS.n242 0.146155
R453 VSS.n245 VSS.n243 0.146155
R454 VSS.n246 VSS.n245 0.146155
R455 VSS.n246 VSS.n124 0.146155
R456 VSS.n129 VSS.n124 0.146155
R457 VSS.n129 VSS.n128 0.146155
R458 VSS.n128 VSS.n110 0.146155
R459 VSS.n249 VSS.n110 0.146155
R460 VSS.n250 VSS.n249 0.146155
R461 VSS.n252 VSS.n250 0.146155
R462 VSS.n252 VSS.n106 0.146155
R463 VSS.n41 VSS.n27 0.146155
R464 VSS.n290 VSS.n44 0.146155
R465 VSS.n290 VSS.n20 0.146155
R466 VSS.n292 VSS.n20 0.146155
R467 VSS.n286 VSS.n46 0.146155
R468 VSS.n24 VSS.n16 0.120892
R469 VSS.n107 VSS.n54 0.120892
R470 VSS.n283 VSS.n48 0.1205
R471 VSS.n291 VSS.n42 0.1205
R472 VSS.n32 VSS.n31 0.1205
R473 VSS.n30 VSS.t52 0.1205
R474 VSS.n192 VSS.n182 0.1205
R475 VSS.n182 VSS.n181 0.1205
R476 VSS.n204 VSS.n159 0.1205
R477 VSS.n208 VSS.n207 0.1205
R478 VSS.n212 VSS.n211 0.1205
R479 VSS.n214 VSS.n161 0.1205
R480 VSS.n218 VSS.n161 0.1205
R481 VSS.n220 VSS.n153 0.1205
R482 VSS.n221 VSS.n220 0.1205
R483 VSS.n224 VSS.n223 0.1205
R484 VSS.n227 VSS.t7 0.1205
R485 VSS.n231 VSS.n230 0.1205
R486 VSS.n236 VSS.t60 0.1205
R487 VSS.n240 VSS.n118 0.1205
R488 VSS.n244 VSS.n120 0.1205
R489 VSS.n123 VSS.n112 0.1205
R490 VSS.n105 VSS.n56 0.1205
R491 VSS.n259 VSS.n258 0.1205
R492 VSS.n261 VSS.n60 0.1205
R493 VSS.n264 VSS.n60 0.1205
R494 VSS.n268 VSS.n267 0.1205
R495 VSS.n268 VSS.n62 0.1205
R496 VSS.n94 VSS.n92 0.1205
R497 VSS.n84 VSS.t28 0.1205
R498 VSS.n76 VSS.n75 0.1205
R499 VSS.n42 VSS.t68 0.1205
R500 VSS.n251 VSS.t63 0.1205
R501 VSS.n111 VSS.t50 0.1205
R502 VSS.t41 VSS.n125 0.1205
R503 VSS.t17 VSS.n120 0.1205
R504 VSS.n234 VSS.t6 0.1205
R505 VSS.t56 VSS.n159 0.1205
R506 VSS.n180 VSS.t1 0.1205
R507 VSS.n149 VSS.t7 0.1205
R508 VSS.t24 VSS.n82 0.1205
R509 VSS.t26 VSS.n73 0.1205
R510 VSS.n66 VSS.t28 0.1205
R511 VSS.t37 VSS.n21 0.1205
R512 VSS.n195 VSS.n194 0.078
R513 VSS.n28 VSS.n27 0.0726677
R514 VSS.n46 VSS.n45 0.0726677
R515 VSS.n72 VSS.n71 0.0726677
R516 VSS.n198 VSS.n184 0.0726677
R517 VSS.n257 VSS.n256 0.0672586
R518 VSS.n256 VSS.n106 0.0672586
R519 VSS.n292 VSS.n19 0.0672586
R520 VSS.t37 VSS.n22 0.060789
R521 VSS.n31 VSS.n23 0.060789
R522 VSS.t68 VSS.n43 0.060789
R523 VSS.n285 VSS.n284 0.060789
R524 VSS.n284 VSS.n48 0.060789
R525 VSS.n47 VSS.n43 0.060789
R526 VSS.n291 VSS.n16 0.060789
R527 VSS.n30 VSS.n23 0.060789
R528 VSS.n26 VSS.n22 0.060789
R529 VSS.n75 VSS.n49 0.060789
R530 VSS.t26 VSS.n50 0.060789
R531 VSS.n94 VSS.n93 0.060789
R532 VSS.n91 VSS.n66 0.060789
R533 VSS.n84 VSS.n52 0.060789
R534 VSS.n267 VSS.n61 0.060789
R535 VSS.n105 VSS.n58 0.060789
R536 VSS.n258 VSS.n54 0.060789
R537 VSS.n259 VSS.n53 0.060789
R538 VSS.t63 VSS.n57 0.060789
R539 VSS.n231 VSS.n115 0.060789
R540 VSS.n236 VSS.n116 0.060789
R541 VSS.n117 VSS.t60 0.060789
R542 VSS.n240 VSS.n119 0.060789
R543 VSS.n125 VSS.n121 0.060789
R544 VSS.n247 VSS.t41 0.060789
R545 VSS.n248 VSS.n112 0.060789
R546 VSS.n223 VSS.n222 0.060789
R547 VSS.n149 VSS.n148 0.060789
R548 VSS.n227 VSS.n113 0.060789
R549 VSS.n219 VSS.n153 0.060789
R550 VSS.n207 VSS.n157 0.060789
R551 VSS.n211 VSS.n155 0.060789
R552 VSS.n212 VSS.n154 0.060789
R553 VSS.t56 VSS.n158 0.060789
R554 VSS.n199 VSS.n183 0.060789
R555 VSS.n193 VSS.n192 0.060789
R556 VSS.n200 VSS.n181 0.060789
R557 VSS.n195 VSS.n193 0.060789
R558 VSS.t1 VSS.n200 0.060789
R559 VSS.n180 VSS.n158 0.060789
R560 VSS.n204 VSS.n157 0.060789
R561 VSS.n208 VSS.n155 0.060789
R562 VSS.n214 VSS.n154 0.060789
R563 VSS.n219 VSS.n218 0.060789
R564 VSS.n222 VSS.n221 0.060789
R565 VSS.n148 VSS.n224 0.060789
R566 VSS.n230 VSS.n113 0.060789
R567 VSS.t6 VSS.n115 0.060789
R568 VSS.n234 VSS.n116 0.060789
R569 VSS.t17 VSS.n119 0.060789
R570 VSS.n244 VSS.n121 0.060789
R571 VSS.n247 VSS.n123 0.060789
R572 VSS.t50 VSS.n248 0.060789
R573 VSS.n111 VSS.n57 0.060789
R574 VSS.n251 VSS.n58 0.060789
R575 VSS.n261 VSS.n53 0.060789
R576 VSS.n264 VSS.n61 0.060789
R577 VSS.n93 VSS.n62 0.060789
R578 VSS.n92 VSS.n91 0.060789
R579 VSS.t24 VSS.n52 0.060789
R580 VSS.n82 VSS.n49 0.060789
R581 VSS.n76 VSS.n50 0.060789
R582 VSS.n73 VSS.n51 0.060789
R583 VSS.n118 VSS.n117 0.060789
R584 VSS.n107 VSS.n56 0.0606026
R585 VSS.n194 VSS.n183 0.043
R586 VSS.n279 VSS.t13 0.0202581
R587 VSS.n275 VSS.t13 0.0177604
R588 VSS.n272 VSS.t13 0.0168295
R589 VSS.t3 VSS.n6 0.0125723
R590 VSS.t3 VSS.n2 0.0125723
R591 VSS.n15 VSS.n283 4.32671
R592 VSS.n9 VSS.t11 120.096
C233 DOWN_INV 0 0.23137f
C234 DELAY_OUT 0 0.40351f
C235 UP_INV 0 0.4657f
C236 UP 0 0.71071f
C237 DOWN 0 3.20475f
C238 DELAY_IN 0 0.81864f
C239 DLL_RESETN 0 1.13937f
C240 VDD 0 2.74906f
C241 a_5281_391# 0 0.1031f ; **FLOATING
C242 a_4404_327# 0 0.0742f ; **FLOATING
C243 a_6212_612# 0 0.28346f ; **FLOATING
C244 a_5632_534# 0 0.24946f ; **FLOATING
C245 a_5375_391# 0 0.40589f ; **FLOATING
C246 a_4635_436# 0 0.20602f ; **FLOATING
C247 a_4533_293# 0 0.48727f ; **FLOATING
C248 a_4116_632# 0 1.6282f ; **FLOATING
C249 a_3830_314# 0 0.31124f ; **FLOATING
C250 a_4090_537# 0 0.1634f ; **FLOATING
C251 a_3656_629# 0 0.14203f ; **FLOATING
C252 a_3431_629# 0 0.14728f ; **FLOATING
C253 a_3431_395# 0 0.14751f ; **FLOATING
C254 a_3630_566# 0 0.07343f ; **FLOATING
C255 a_5281_1437# 0 0.10568f ; **FLOATING
C256 a_6212_1076# 0 0.27741f ; **FLOATING
C257 a_5375_1437# 0 0.40535f ; **FLOATING
C258 a_5632_1318# 0 0.25077f ; **FLOATING
C259 a_4635_1087# 0 0.23266f ; **FLOATING
C260 a_4404_1501# 0 0.0799f ; **FLOATING
C261 a_4533_1087# 0 0.494f ; **FLOATING
C262 a_4116_1080# 0 1.63328f ; **FLOATING
C263 a_4090_1044# 0 0.1587f ; **FLOATING
C264 a_3569_1424# 0 0.01186f ; **FLOATING
C265 a_3830_1514# 0 0.32799f ; **FLOATING
C266 a_3373_1076# 0 1.40686f ; **FLOATING
C267 a_3180_1073# 0 0.29726f ; **FLOATING
C268 a_2879_1076# 0 0.76639f ; **FLOATING
C269 a_1921_1437# 0 0.10938f ; **FLOATING
C270 a_2682_1076# 0 0.27441f ; **FLOATING
C271 a_2015_1437# 0 0.32294f ; **FLOATING
C272 a_2272_1318# 0 0.18392f ; **FLOATING
C273 a_1275_1087# 0 0.22122f ; **FLOATING
C274 a_1044_1501# 0 0.05232f ; **FLOATING
C275 a_1173_1087# 0 0.49661f ; **FLOATING
C276 a_756_1080# 0 1.59913f ; **FLOATING
C277 a_730_1044# 0 0.09742f ; **FLOATING
C278 a_470_1514# 0 0.20737f ; **FLOATING
C279 a_296_1052# 0 0.14808f ; **FLOATING
C280 a_270_1014# 0 0.0792f ; **FLOATING
C281 a_71_1381# 0 0.15767f ; **FLOATING
C282 a_71_1151# 0 0.15425f ; **FLOATING
.ends
