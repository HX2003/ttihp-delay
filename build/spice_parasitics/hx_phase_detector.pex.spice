* NGSPICE file created from hx_phase_detector.ext - technology: ihp-sg13g2

.subckt hx_phase_detector VSS VDD UP_INV DOWN DOWN_INV DLL_RESETN DELAY_IN UP DELAY_OUT
X0 UP_INV a_5375_1437# VSS.t28 VSS.t27 sg13_lv_nmos ad=0.2849p pd=2.25u as=0.2516p ps=2.16u w=0.74u l=0.13u
X1 a_4116_1080# a_4635_1087# a_5375_1437# VSS.t36 sg13_lv_nmos ad=0.3473p pd=2.71u as=0.12665p ps=1.145u w=0.74u l=0.13u
X2 VDD.t0 a_5632_1318# a_5577_1199# VDD.t0 sg13_lv_pmos ad=1.06255p pd=6.38u as=93.45f ps=0.865u w=0.42u l=0.13u
X3 a_4342_327# a_3373_1076# VSS.t74 VSS.t73 sg13_lv_nmos ad=37.8f pd=0.6u as=0.1701p ps=1.65u w=0.42u l=0.13u
X4 UP a_6212_1076# VSS.t30 VSS.t37 sg13_lv_nmos ad=0.2516p pd=2.16u as=0.1406p ps=1.12u w=0.74u l=0.13u
X5 a_5577_629# a_4635_436# a_5375_391# VDD.t0 sg13_lv_pmos ad=93.45f pd=0.865u as=0.2048p ps=1.63u w=0.42u l=0.13u
X6 a_5375_391# a_4533_293# a_4116_632# VDD.t0 sg13_lv_pmos ad=0.2048p pd=1.63u as=0.34p ps=2.68u w=1u l=0.13u
X7 a_4473_1123# a_4116_1080# VDD.t14 VDD.t0 sg13_lv_pmos ad=63f pd=0.72u as=0.1563p ps=1.22u w=0.42u l=0.13u
X8 a_756_1080# a_1275_1087# a_2015_1437# VSS.t10 sg13_lv_nmos ad=0.3473p pd=2.71u as=0.12665p ps=1.145u w=0.74u l=0.13u
X9 a_2272_1318# DLL_RESETN VDD.t0 VDD.t0 sg13_lv_pmos ad=79.8f pd=0.8u as=1.06255p ps=6.38u w=0.42u l=0.13u
X10 a_3373_1076# a_3180_1073# VSS.t20 VSS.t19 sg13_lv_nmos ad=0.1406p pd=1.12u as=0.2516p ps=2.16u w=0.74u l=0.13u
X11 a_1173_1087# DELAY_IN VDD.t0 VDD.t0 sg13_lv_pmos ad=0.4088p pd=2.97u as=0.99612p ps=5.98u w=1.12u l=0.13u
X12 a_2879_1076# a_2682_1076# VSS.t7 VSS.t13 sg13_lv_nmos ad=0.2516p pd=2.16u as=0.1406p ps=1.12u w=0.74u l=0.13u
X13 a_1113_1123# a_756_1080# VDD.t8 VDD.t0 sg13_lv_pmos ad=63f pd=0.72u as=0.1563p ps=1.22u w=0.42u l=0.13u
X14 a_4090_537# a_4533_293# a_4473_705# VDD.t0 sg13_lv_pmos ad=79.8f pd=0.8u as=63f ps=0.72u w=0.42u l=0.13u
X15 VSS.t3 a_1173_1087# a_1275_1087# VSS.t17 sg13_lv_nmos ad=2.30077p pd=14.835u as=0.2516p ps=2.16u w=0.74u l=0.13u
X16 a_3180_1073# DLL_RESETN VDD.t39 VDD.t0 sg13_lv_pmos ad=0.3808p pd=2.92u as=0.3808p ps=2.92u w=1.12u l=0.13u
X17 a_4342_1501# a_3373_1076# VSS.t69 VSS.t68 sg13_lv_nmos ad=37.8f pd=0.6u as=0.1701p ps=1.65u w=0.42u l=0.13u
X18 a_4090_1044# a_4533_1087# a_4473_1123# VDD.t0 sg13_lv_pmos ad=79.8f pd=0.8u as=63f ps=0.72u w=0.42u l=0.13u
X19 VSS.t15 a_4533_293# a_4635_436# VSS.t39 sg13_lv_nmos ad=1.45407p pd=9.445u as=0.2516p ps=2.16u w=0.74u l=0.13u
X20 VDD.t0 a_4533_293# a_4635_436# VDD.t0 sg13_lv_pmos ad=1.06255p pd=6.38u as=0.3864p ps=2.93u w=1.12u l=0.13u
X21 a_3830_314# a_4635_436# a_4090_537# VDD.t0 sg13_lv_pmos ad=0.1428p pd=1.52u as=79.8f ps=0.8u w=0.42u l=0.13u
X22 a_3830_314# a_3656_629# VDD.t27 VDD.t0 sg13_lv_pmos ad=79.8f pd=0.8u as=0.1428p ps=1.52u w=0.42u l=0.13u
X23 a_730_1044# a_1173_1087# a_1113_1123# VDD.t0 sg13_lv_pmos ad=79.8f pd=0.8u as=63f ps=0.72u w=0.42u l=0.13u
X24 a_982_1501# DLL_RESETN VSS.t62 VSS.t61 sg13_lv_nmos ad=37.8f pd=0.6u as=0.1701p ps=1.65u w=0.42u l=0.13u
X25 a_296_1052# a_270_1014# VDD.t0 VDD.t0 sg13_lv_pmos ad=0.3927p pd=2.99u as=1.06255p ps=6.38u w=1.155u l=0.13u
X26 VDD.t35 a_3373_1076# a_3830_314# VDD.t0 sg13_lv_pmos ad=0.36237p pd=2.605u as=79.8f ps=0.8u w=0.42u l=0.13u
X27 VSS.t60 a_3373_1076# a_3924_314# VSS.t70 sg13_lv_nmos ad=0.1626p pd=1.415u as=60.89999f ps=0.71u w=0.42u l=0.13u
X28 a_5632_1318# a_3373_1076# VDD.t0 VDD.t0 sg13_lv_pmos ad=79.8f pd=0.8u as=0.99612p ps=5.98u w=0.42u l=0.13u
X29 DOWN_INV a_5375_391# VDD.t30 VDD.t0 sg13_lv_pmos ad=0.4312p pd=3.01u as=0.2639p ps=1.81u w=1.12u l=0.13u
X30 VDD.t14 a_3373_1076# a_4090_1044# VDD.t0 sg13_lv_pmos ad=0.1563p pd=1.22u as=0.147p ps=1.54u w=0.42u l=0.13u
X31 a_3830_1514# a_2879_1076# VDD.t12 VDD.t0 sg13_lv_pmos ad=79.8f pd=0.8u as=0.1428p ps=1.52u w=0.42u l=0.13u
X32 VSS.t8 a_2272_1318# a_1921_1437# VSS.t5 sg13_lv_nmos ad=79.8f pd=0.8u as=0.1428p ps=1.52u w=0.42u l=0.13u
X33 a_3569_1424# DOWN a_3373_1076# VSS.t44 sg13_lv_nmos ad=0.1406p pd=1.12u as=0.1406p ps=1.12u w=0.74u l=0.13u
X34 VSS.t3 a_4533_1087# a_4635_1087# VSS.t23 sg13_lv_nmos ad=2.30077p pd=14.835u as=0.2516p ps=2.16u w=0.74u l=0.13u
X35 a_4533_1087# DELAY_IN VDD.t0 VDD.t0 sg13_lv_pmos ad=0.4088p pd=2.97u as=0.99612p ps=5.98u w=1.12u l=0.13u
X36 VDD.t8 DLL_RESETN a_730_1044# VDD.t0 sg13_lv_pmos ad=0.1563p pd=1.22u as=0.147p ps=1.54u w=0.42u l=0.13u
X37 a_5375_391# a_4533_293# a_5281_391# VSS.t40 sg13_lv_nmos ad=0.12665p pd=1.145u as=0.1428p ps=1.52u w=0.42u l=0.13u
X38 a_3924_314# a_3656_629# a_3830_314# VSS.t47 sg13_lv_nmos ad=60.89999f pd=0.71u as=0.1428p ps=1.52u w=0.42u l=0.13u
X39 a_3830_1514# a_4635_1087# a_4090_1044# VDD.t0 sg13_lv_pmos ad=0.1428p pd=1.52u as=79.8f ps=0.8u w=0.42u l=0.13u
X40 VDD.t0 a_5632_534# a_5577_629# VDD.t0 sg13_lv_pmos ad=1.06255p pd=6.38u as=93.45f ps=0.865u w=0.42u l=0.13u
X41 VSS.t56 a_3373_1076# a_3924_1514# VSS.t67 sg13_lv_nmos ad=0.1626p pd=1.415u as=60.89999f ps=0.71u w=0.42u l=0.13u
X42 VDD.t0 a_71_1381# a_71_1151# VDD.t0 sg13_lv_pmos ad=1.06255p pd=6.38u as=0.2442p ps=2.06u w=0.66u l=0.13u
X43 a_470_1514# a_1275_1087# a_730_1044# VDD.t0 sg13_lv_pmos ad=0.1428p pd=1.52u as=79.8f ps=0.8u w=0.42u l=0.13u
X44 a_756_1080# a_730_1044# VSS.t1 VSS.t0 sg13_lv_nmos ad=0.2516p pd=2.16u as=0.1626p ps=1.415u w=0.74u l=0.13u
X45 VSS.t42 a_5375_391# a_6212_612# VSS.t54 sg13_lv_nmos ad=0.1406p pd=1.12u as=0.2516p ps=2.16u w=0.74u l=0.13u
X46 a_5632_534# a_3373_1076# VDD.t0 VDD.t0 sg13_lv_pmos ad=79.8f pd=0.8u as=0.99612p ps=5.98u w=0.42u l=0.13u
X47 a_470_1514# a_296_1052# VDD.t2 VDD.t0 sg13_lv_pmos ad=79.8f pd=0.8u as=0.1428p ps=1.52u w=0.42u l=0.13u
X48 a_4116_632# a_4635_436# a_5375_391# VSS.t34 sg13_lv_nmos ad=0.3473p pd=2.71u as=0.12665p ps=1.145u w=0.74u l=0.13u
X49 a_5632_1318# a_5375_1437# a_5794_1514# VSS.t26 sg13_lv_nmos ad=0.1428p pd=1.52u as=37.8f ps=0.6u w=0.42u l=0.13u
X50 a_2015_1437# a_1173_1087# a_756_1080# VDD.t0 sg13_lv_pmos ad=0.2048p pd=1.63u as=0.34p ps=2.68u w=1u l=0.13u
X51 VDD.t30 a_5375_391# a_5632_534# VDD.t0 sg13_lv_pmos ad=0.2639p pd=1.81u as=79.8f ps=0.8u w=0.42u l=0.13u
X52 a_3467_1076# a_3180_1073# a_3373_1076# VDD.t0 sg13_lv_pmos ad=0.2128p pd=1.5u as=0.3808p ps=2.92u w=1.12u l=0.13u
X53 a_3630_566# a_3431_629# VSS.t15 VSS.t50 sg13_lv_nmos ad=0.27427p pd=2.28u as=1.45407p ps=9.445u w=0.795u l=0.13u
X54 VDD.t17 a_5375_1437# a_6212_1076# VDD.t0 sg13_lv_pmos ad=0.2128p pd=1.5u as=0.3864p ps=2.93u w=1.12u l=0.13u
X55 a_2015_1437# a_1173_1087# a_1921_1437# VSS.t18 sg13_lv_nmos ad=0.12665p pd=1.145u as=0.1428p ps=1.52u w=0.42u l=0.13u
X56 VSS.t3 a_71_1381# a_71_1381# VSS.t11 sg13_lv_nmos ad=2.30077p pd=14.835u as=0.111p ps=1.34u w=0.3u l=0.13u
X57 DOWN a_6212_612# VSS.t42 VSS.t41 sg13_lv_nmos ad=0.2516p pd=2.16u as=0.1406p ps=1.12u w=0.74u l=0.13u
X58 VDD.t0 a_1173_1087# a_1275_1087# VDD.t0 sg13_lv_pmos ad=1.06255p pd=6.38u as=0.3864p ps=2.93u w=1.12u l=0.13u
X59 a_2272_1318# a_2015_1437# a_2434_1514# VSS.t5 sg13_lv_nmos ad=0.1428p pd=1.52u as=37.8f ps=0.6u w=0.42u l=0.13u
X60 VSS.t32 a_5632_1318# a_5281_1437# VSS.t26 sg13_lv_nmos ad=79.8f pd=0.8u as=0.1428p ps=1.52u w=0.42u l=0.13u
X61 VDD.t0 a_3431_395# a_3431_629# VDD.t0 sg13_lv_pmos ad=1.06255p pd=6.38u as=0.2442p ps=2.06u w=0.66u l=0.13u
X62 VDD.t5 a_2015_1437# a_2682_1076# VDD.t0 sg13_lv_pmos ad=0.2128p pd=1.5u as=0.3864p ps=2.93u w=1.12u l=0.13u
X63 VSS.t46 UP a_3569_1424# VSS.t45 sg13_lv_nmos ad=0.2516p pd=2.16u as=0.1406p ps=1.12u w=0.74u l=0.13u
X64 VSS.t1 DLL_RESETN a_564_1514# VSS.t63 sg13_lv_nmos ad=0.1626p pd=1.415u as=60.89999f ps=0.71u w=0.42u l=0.13u
X65 a_2434_1514# DLL_RESETN VSS.t8 VSS.t5 sg13_lv_nmos ad=37.8f pd=0.6u as=79.8f ps=0.8u w=0.42u l=0.13u
X66 a_3656_629# a_3630_566# VDD.t0 VDD.t0 sg13_lv_pmos ad=0.3927p pd=2.99u as=1.06255p ps=6.38u w=1.155u l=0.13u
X67 VDD.t0 a_2015_1437# a_2272_1318# VDD.t0 sg13_lv_pmos ad=1.06255p pd=6.38u as=79.8f ps=0.8u w=0.42u l=0.13u
X68 a_4090_1044# a_4533_1087# a_3830_1514# VSS.t22 sg13_lv_nmos ad=79.8f pd=0.8u as=0.1296p ps=1.52u w=0.42u l=0.13u
X69 a_756_1080# a_730_1044# VDD.t1 VDD.t0 sg13_lv_pmos ad=0.34p pd=2.68u as=0.36237p ps=2.605u w=1u l=0.13u
X70 a_1044_1501# a_756_1080# a_982_1501# VSS.t12 sg13_lv_nmos ad=0.1428p pd=1.52u as=37.8f ps=0.6u w=0.42u l=0.13u
X71 a_4116_1080# a_4090_1044# VSS.t56 VSS.t55 sg13_lv_nmos ad=0.2516p pd=2.16u as=0.1626p ps=1.415u w=0.74u l=0.13u
X72 a_730_1044# a_1173_1087# a_470_1514# VSS.t16 sg13_lv_nmos ad=79.8f pd=0.8u as=0.1296p ps=1.52u w=0.42u l=0.13u
X73 a_270_1014# a_71_1151# VSS.t3 VSS.t2 sg13_lv_nmos ad=0.27427p pd=2.28u as=2.30077p ps=14.835u w=0.795u l=0.13u
X74 a_5375_1437# a_4533_1087# a_4116_1080# VDD.t0 sg13_lv_pmos ad=0.2048p pd=1.63u as=0.34p ps=2.68u w=1u l=0.13u
X75 a_1173_1087# DELAY_IN VSS.t3 VSS.t48 sg13_lv_nmos ad=0.2516p pd=2.16u as=1.9173p ps=12.365u w=0.74u l=0.13u
X76 UP_INV a_5375_1437# VDD.t15 VDD.t0 sg13_lv_pmos ad=0.4312p pd=3.01u as=0.2639p ps=1.81u w=1.12u l=0.13u
X77 VDD.t0 a_4533_1087# a_4635_1087# VDD.t0 sg13_lv_pmos ad=1.06255p pd=6.38u as=0.3864p ps=2.93u w=1.12u l=0.13u
X78 VDD.t24 DOWN a_3467_1076# VDD.t0 sg13_lv_pmos ad=0.2128p pd=1.5u as=0.2128p ps=1.5u w=1.12u l=0.13u
X79 UP a_6212_1076# VDD.t17 VDD.t0 sg13_lv_pmos ad=0.3808p pd=2.92u as=0.2128p ps=1.5u w=1.12u l=0.13u
X80 a_4116_1080# a_4090_1044# VDD.t33 VDD.t0 sg13_lv_pmos ad=0.34p pd=2.68u as=0.36237p ps=2.605u w=1u l=0.13u
X81 a_5794_1514# a_3373_1076# VSS.t32 VSS.t26 sg13_lv_nmos ad=37.8f pd=0.6u as=79.8f ps=0.8u w=0.42u l=0.13u
X82 VDD.t15 a_5375_1437# a_5632_1318# VDD.t0 sg13_lv_pmos ad=0.2639p pd=1.81u as=79.8f ps=0.8u w=0.42u l=0.13u
X83 a_2879_1076# a_2682_1076# VDD.t5 VDD.t0 sg13_lv_pmos ad=0.3808p pd=2.92u as=0.2128p ps=1.5u w=1.12u l=0.13u
X84 a_5375_1437# a_4533_1087# a_5281_1437# VSS.t24 sg13_lv_nmos ad=0.12665p pd=1.145u as=0.1428p ps=1.52u w=0.42u l=0.13u
X85 a_3180_1073# DLL_RESETN VSS.t66 VSS.t65 sg13_lv_nmos ad=0.2516p pd=2.16u as=0.2516p ps=2.16u w=0.74u l=0.13u
X86 VSS.t30 a_5375_1437# a_6212_1076# VSS.t29 sg13_lv_nmos ad=0.1406p pd=1.12u as=0.2516p ps=2.16u w=0.74u l=0.13u
X87 a_3924_1514# a_2879_1076# a_3830_1514# VSS.t21 sg13_lv_nmos ad=60.89999f pd=0.71u as=0.1428p ps=1.52u w=0.42u l=0.13u
X88 a_4404_1501# a_4116_1080# a_4342_1501# VSS.t25 sg13_lv_nmos ad=0.1428p pd=1.52u as=37.8f ps=0.6u w=0.42u l=0.13u
X89 VDD.t0 a_2272_1318# a_2217_1199# VDD.t0 sg13_lv_pmos ad=1.06255p pd=6.38u as=93.45f ps=0.865u w=0.42u l=0.13u
X90 a_4404_1501# a_4635_1087# a_4090_1044# VSS.t35 sg13_lv_nmos ad=0.2373p pd=1.97u as=79.8f ps=0.8u w=0.42u l=0.13u
X91 a_4533_293# DELAY_OUT VSS.t15 VSS.t14 sg13_lv_nmos ad=0.2516p pd=2.16u as=1.45407p ps=9.445u w=0.74u l=0.13u
X92 a_4090_537# a_4533_293# a_3830_314# VSS.t38 sg13_lv_nmos ad=79.8f pd=0.8u as=0.1296p ps=1.52u w=0.42u l=0.13u
X93 a_5577_1199# a_4635_1087# a_5375_1437# VDD.t0 sg13_lv_pmos ad=93.45f pd=0.865u as=0.2048p ps=1.63u w=0.42u l=0.13u
X94 a_4404_327# a_4116_632# a_4342_327# VSS.t43 sg13_lv_nmos ad=0.1428p pd=1.52u as=37.8f ps=0.6u w=0.42u l=0.13u
X95 a_4533_293# DELAY_OUT VDD.t0 VDD.t0 sg13_lv_pmos ad=0.4088p pd=2.97u as=1.06255p ps=6.38u w=1.12u l=0.13u
X96 VSS.t7 a_2015_1437# a_2682_1076# VSS.t6 sg13_lv_nmos ad=0.1406p pd=1.12u as=0.2516p ps=2.16u w=0.74u l=0.13u
X97 DOWN_INV a_5375_391# VSS.t53 VSS.t52 sg13_lv_nmos ad=0.2849p pd=2.25u as=0.2516p ps=2.16u w=0.74u l=0.13u
X98 VDD.t22 a_5375_391# a_6212_612# VDD.t0 sg13_lv_pmos ad=0.2128p pd=1.5u as=0.3864p ps=2.93u w=1.12u l=0.13u
X99 a_4473_705# a_4116_632# VDD.t23 VDD.t0 sg13_lv_pmos ad=63f pd=0.72u as=0.1563p ps=1.22u w=0.42u l=0.13u
X100 a_1044_1501# a_1275_1087# a_730_1044# VSS.t9 sg13_lv_nmos ad=0.2373p pd=1.97u as=79.8f ps=0.8u w=0.42u l=0.13u
X101 VDD.t33 a_3373_1076# a_3830_1514# VDD.t0 sg13_lv_pmos ad=0.36237p pd=2.605u as=79.8f ps=0.8u w=0.42u l=0.13u
X102 a_2217_1199# a_1275_1087# a_2015_1437# VDD.t0 sg13_lv_pmos ad=93.45f pd=0.865u as=0.2048p ps=1.63u w=0.42u l=0.13u
X103 VSS.t58 a_5632_534# a_5281_391# VSS.t57 sg13_lv_nmos ad=79.8f pd=0.8u as=0.1428p ps=1.52u w=0.42u l=0.13u
X104 a_4404_327# a_4635_436# a_4090_537# VSS.t33 sg13_lv_nmos ad=0.2373p pd=1.97u as=79.8f ps=0.8u w=0.42u l=0.13u
X105 a_4116_632# a_4090_537# VDD.t35 VDD.t0 sg13_lv_pmos ad=0.34p pd=2.68u as=0.36237p ps=2.605u w=1u l=0.13u
X106 VSS.t15 a_3431_395# a_3431_395# VSS.t31 sg13_lv_nmos ad=1.45407p pd=9.445u as=0.111p ps=1.34u w=0.3u l=0.13u
X107 DOWN a_6212_612# VDD.t22 VDD.t0 sg13_lv_pmos ad=0.3808p pd=2.92u as=0.2128p ps=1.5u w=1.12u l=0.13u
X108 VDD.t23 a_3373_1076# a_4090_537# VDD.t0 sg13_lv_pmos ad=0.1563p pd=1.22u as=0.147p ps=1.54u w=0.42u l=0.13u
X109 a_5794_314# a_3373_1076# VSS.t58 VSS.t71 sg13_lv_nmos ad=37.8f pd=0.6u as=79.8f ps=0.8u w=0.42u l=0.13u
X110 VDD.t1 DLL_RESETN a_470_1514# VDD.t0 sg13_lv_pmos ad=0.36237p pd=2.605u as=79.8f ps=0.8u w=0.42u l=0.13u
X111 a_3467_1076# UP VDD.t24 VDD.t0 sg13_lv_pmos ad=0.3808p pd=2.92u as=0.2128p ps=1.5u w=1.12u l=0.13u
X112 a_564_1514# a_296_1052# a_470_1514# VSS.t4 sg13_lv_nmos ad=60.89999f pd=0.71u as=0.1428p ps=1.52u w=0.42u l=0.13u
X113 a_4533_1087# DELAY_IN VSS.t3 VSS.t49 sg13_lv_nmos ad=0.2516p pd=2.16u as=1.9173p ps=12.365u w=0.74u l=0.13u
X114 a_5632_534# a_5375_391# a_5794_314# VSS.t51 sg13_lv_nmos ad=0.1428p pd=1.52u as=37.8f ps=0.6u w=0.42u l=0.13u
X115 a_4116_632# a_4090_537# VSS.t60 VSS.t59 sg13_lv_nmos ad=0.2516p pd=2.16u as=0.1626p ps=1.415u w=0.74u l=0.13u
C0 a_1173_1087# a_470_1514# 0.02432f
C1 DELAY_IN a_3656_629# 0.02025f
C2 a_4533_1087# a_4116_1080# 0.37583f
C3 VDD a_71_1381# 0.0617f
C4 a_3373_1076# a_2879_1076# 0.07687f
C5 UP a_5632_1318# 0.03701f
C6 a_4116_632# a_5281_391# 0.43239f
C7 a_296_1052# a_470_1514# 0.27179f
C8 VDD a_3830_314# 0.79678f
C9 a_1275_1087# a_2015_1437# 0.26905f
C10 a_4404_327# a_4635_436# 0.12701f
C11 a_4116_1080# a_4090_1044# 0.36952f
C12 DLL_RESETN a_1275_1087# 0.45018f
C13 a_4533_293# a_4635_436# 0.47622f
C14 VDD a_5632_1318# 0.1349f
C15 VDD a_3431_629# 0.07751f
C16 a_4533_1087# a_4090_1044# 0.02242f
C17 a_3569_1424# DOWN 0.01249f
C18 a_4404_327# a_4533_293# 0.01562f
C19 DLL_RESETN a_3630_566# 0.01259f
C20 DELAY_IN a_1275_1087# 0.01931f
C21 a_756_1080# a_1275_1087# 0.34102f
C22 VDD a_4116_632# 0.11456f
C23 a_3656_629# a_3830_314# 0.27179f
C24 a_5375_1437# a_5281_1437# 0.28931f
C25 DELAY_OUT a_4116_632# 0.08062f
C26 a_5375_1437# a_3373_1076# 0.13392f
C27 a_3656_629# a_3431_629# 0.02416f
C28 a_3830_1514# a_2879_1076# 0.26489f
C29 VDD a_2272_1318# 0.16819f
C30 a_3373_1076# a_5632_534# 0.10521f
C31 DLL_RESETN a_2879_1076# 0.04879f
C32 a_3373_1076# a_3830_1514# 0.12097f
C33 a_1275_1087# a_1044_1501# 0.12701f
C34 UP_INV a_4635_1087# 0.01811f
C35 VDD a_1173_1087# 0.23431f
C36 a_6212_1076# DOWN 0.0195f
C37 UP_INV DOWN 0.06562f
C38 a_5375_391# a_4116_632# 0.01529f
C39 a_3180_1073# DOWN 0.04193f
C40 a_3373_1076# DLL_RESETN 0.34978f
C41 a_3467_1076# DOWN 0.03346f
C42 DELAY_IN a_2879_1076# 1.0042f
C43 a_730_1044# DLL_RESETN 0.27343f
C44 a_3373_1076# DELAY_IN 0.26308f
C45 VDD a_296_1052# 0.2371f
C46 UP_INV a_5281_391# 0.02171f
C47 a_4635_1087# a_4404_1501# 0.12701f
C48 a_3431_629# a_3630_566# 0.14994f
C49 a_756_1080# a_730_1044# 0.36952f
C50 VDD a_270_1014# 0.08925f
C51 VDD a_4090_537# 0.0947f
C52 a_6212_1076# UP 0.17255f
C53 a_4635_1087# a_4116_1080# 0.34102f
C54 UP_INV UP 0.33738f
C55 a_4116_1080# DOWN 0.04178f
C56 a_3467_1076# UP 0.09118f
C57 a_4533_1087# a_4635_1087# 0.47795f
C58 VDD a_6212_1076# 0.30345f
C59 VDD UP_INV 0.35144f
C60 VDD a_3180_1073# 0.26066f
C61 a_3467_1076# VDD 0.29479f
C62 DLL_RESETN a_2015_1437# 0.14622f
C63 a_1275_1087# a_2272_1318# 0.03061f
C64 a_1921_1437# a_2015_1437# 0.28931f
C65 DELAY_OUT UP_INV 0.05562f
C66 a_1275_1087# a_1173_1087# 0.47795f
C67 a_3373_1076# a_3830_314# 0.10976f
C68 DELAY_IN a_3830_1514# 0.05059f
C69 a_3373_1076# a_5632_1318# 0.10225f
C70 DELAY_IN a_2015_1437# 0.01827f
C71 DELAY_IN DLL_RESETN 1.62072f
C72 a_756_1080# a_2015_1437# 0.01529f
C73 a_756_1080# DLL_RESETN 0.39088f
C74 a_4533_293# a_5281_391# 0.01058f
C75 a_756_1080# a_1921_1437# 0.43239f
C76 a_5375_391# UP_INV 0.04856f
C77 UP a_4116_1080# 0.01445f
C78 a_4533_1087# UP 0.01604f
C79 a_3373_1076# a_4116_632# 0.38497f
C80 a_756_1080# DELAY_IN 0.08086f
C81 a_71_1381# a_71_1151# 0.1117f
C82 VDD a_4116_1080# 0.07242f
C83 a_4533_1087# VDD 0.23872f
C84 VDD a_2682_1076# 0.37862f
C85 VDD a_4635_436# 0.33467f
C86 UP a_4090_1044# 0.01158f
C87 a_4404_327# VDD 0.02994f
C88 a_5375_1437# a_5632_1318# 0.29858f
C89 VDD a_4533_293# 0.28344f
C90 DELAY_OUT a_4635_436# 0.02024f
C91 VDD a_4090_1044# 0.09466f
C92 DELAY_OUT a_4533_293# 0.25594f
C93 a_756_1080# a_1044_1501# 0.43707f
C94 a_730_1044# a_1173_1087# 0.02242f
C95 DLL_RESETN a_3431_629# 0.04228f
C96 a_5375_391# a_4635_436# 0.26905f
C97 DELAY_IN a_3830_314# 0.06166f
C98 a_3373_1076# a_4090_537# 0.26617f
C99 a_4116_632# DELAY_IN 0.03445f
C100 a_3180_1073# a_2879_1076# 0.03277f
C101 a_2015_1437# a_2272_1318# 0.34468f
C102 DLL_RESETN a_2272_1318# 0.11133f
C103 a_3373_1076# UP_INV 0.0589f
C104 a_3373_1076# a_3180_1073# 0.33075f
C105 a_71_1151# a_296_1052# 0.02416f
C106 DLL_RESETN a_1173_1087# 0.05713f
C107 a_3467_1076# a_3373_1076# 0.16706f
C108 a_1921_1437# a_1173_1087# 0.01058f
C109 VDD a_3431_395# 0.06323f
C110 DELAY_IN a_2272_1318# 0.0148f
C111 DELAY_IN a_1173_1087# 0.25484f
C112 a_71_1151# a_270_1014# 0.14994f
C113 VDD a_470_1514# 0.77198f
C114 a_756_1080# a_1173_1087# 0.37583f
C115 DLL_RESETN a_296_1052# 0.06592f
C116 UP a_4635_1087# 0.0235f
C117 UP DOWN 0.56441f
C118 a_5375_1437# a_6212_1076# 0.08776f
C119 a_5281_1437# a_4116_1080# 0.43239f
C120 VDD a_4635_1087# 0.21331f
C121 a_4116_632# a_3830_314# 0.41329f
C122 a_5375_1437# UP_INV 0.12121f
C123 VDD DOWN 0.40918f
C124 a_2682_1076# a_2879_1076# 0.12454f
C125 a_3373_1076# a_4116_1080# 0.38817f
C126 a_4533_1087# a_5281_1437# 0.01058f
C127 a_4533_1087# a_3373_1076# 0.03525f
C128 a_6212_612# DOWN 0.12861f
C129 a_1044_1501# a_1173_1087# 0.01562f
C130 a_3373_1076# a_4635_436# 0.42064f
C131 a_5632_534# UP_INV 0.01776f
C132 DELAY_OUT DOWN 0.074f
C133 DOWN_INV DOWN 0.04649f
C134 DELAY_IN a_4090_537# 0.01093f
C135 a_3373_1076# a_4533_293# 0.03463f
C136 a_3180_1073# DLL_RESETN 0.11782f
C137 a_3467_1076# DLL_RESETN 0.03616f
C138 a_3373_1076# a_4090_1044# 0.27346f
C139 UP_INV DELAY_IN 0.01066f
C140 a_3180_1073# DELAY_IN 0.01215f
C141 a_3830_1514# a_4404_1501# 0.31978f
C142 VDD UP 0.67925f
C143 a_5375_1437# a_4116_1080# 0.01529f
C144 a_71_1381# a_270_1014# 0.02437f
C145 a_3431_395# a_3630_566# 0.02437f
C146 a_1275_1087# a_470_1514# 0.097f
C147 a_5375_391# a_5281_391# 0.28931f
C148 UP a_6212_612# 0.01441f
C149 DELAY_OUT UP 0.13024f
C150 a_3830_1514# a_4116_1080# 0.41329f
C151 UP DOWN_INV 0.26094f
C152 a_4533_1087# a_3830_1514# 0.02432f
C153 a_5632_534# a_4635_436# 0.03012f
C154 VDD a_6212_612# 0.30345f
C155 a_2682_1076# a_2015_1437# 0.0894f
C156 DELAY_OUT VDD 0.16332f
C157 a_4090_537# a_3830_314# 0.75507f
C158 DLL_RESETN a_2682_1076# 0.02442f
C159 VDD DOWN_INV 0.15129f
C160 a_5375_391# UP 0.02915f
C161 DELAY_IN a_4116_1080# 0.11539f
C162 DELAY_OUT a_6212_612# 0.01702f
C163 a_3830_1514# a_4090_1044# 0.75507f
C164 DOWN_INV a_6212_612# 0.1953f
C165 a_4533_1087# DELAY_IN 0.25847f
C166 DELAY_IN a_2682_1076# 0.01309f
C167 DELAY_OUT DOWN_INV 0.02074f
C168 VDD a_5375_391# 0.25563f
C169 VDD a_3656_629# 0.23863f
C170 UP_INV a_5632_1318# 0.17494f
C171 a_4116_632# a_4090_537# 0.36952f
C172 a_5375_391# a_6212_612# 0.08776f
C173 DELAY_OUT a_5375_391# 0.02109f
C174 DELAY_IN a_4090_1044# 0.01538f
C175 a_5375_391# DOWN_INV 0.04511f
C176 a_4116_632# UP_INV 0.01817f
C177 a_730_1044# a_470_1514# 0.75507f
C178 DOWN a_2879_1076# 0.3846f
C179 a_3373_1076# a_4635_1087# 0.42174f
C180 a_3373_1076# DOWN 0.12815f
C181 VDD a_1275_1087# 0.20377f
C182 a_296_1052# a_270_1014# 0.1657f
C183 VDD a_3630_566# 0.09228f
C184 a_3830_314# a_4635_436# 0.097f
C185 a_4404_327# a_3830_314# 0.31978f
C186 a_4533_293# a_3830_314# 0.02454f
C187 DLL_RESETN a_3431_395# 0.02116f
C188 UP a_2879_1076# 0.05795f
C189 a_5375_1437# a_4635_1087# 0.26905f
C190 a_4116_632# a_4635_436# 0.34114f
C191 DLL_RESETN a_470_1514# 0.09997f
C192 a_5375_1437# DOWN 0.01651f
C193 a_3373_1076# UP 0.55272f
C194 a_3656_629# a_3630_566# 0.1657f
C195 a_4404_327# a_4116_632# 0.43707f
C196 VDD a_2879_1076# 0.37639f
C197 a_4116_632# a_4533_293# 0.3749f
C198 a_3830_1514# a_4635_1087# 0.097f
C199 a_3373_1076# VDD 2.5684f
C200 a_756_1080# a_470_1514# 0.41329f
C201 a_2682_1076# a_2272_1318# 0.10373f
C202 DLL_RESETN DOWN 0.01405f
C203 VDD a_730_1044# 0.09392f
C204 a_3373_1076# DELAY_OUT 0.01791f
C205 a_6212_1076# UP_INV 0.19136f
C206 DELAY_IN a_4635_1087# 0.02263f
C207 DELAY_IN DOWN 0.35409f
C208 a_5375_1437# UP 0.03388f
C209 a_3373_1076# a_5375_391# 0.13376f
C210 a_3373_1076# a_3656_629# 0.06758f
C211 a_1044_1501# a_470_1514# 0.31978f
C212 a_5632_534# UP 0.05882f
C213 UP a_3830_1514# 0.01008f
C214 a_5375_1437# VDD 0.25326f
C215 VDD a_71_1151# 0.07668f
C216 a_3431_629# a_3431_395# 0.1117f
C217 UP DLL_RESETN 0.04333f
C218 VDD a_5632_534# 0.13493f
C219 VDD a_3830_1514# 0.77573f
C220 VDD a_2015_1437# 0.16753f
C221 UP DELAY_IN 1.40135f
C222 VDD DLL_RESETN 1.55643f
C223 a_4533_293# a_4090_537# 0.02242f
C224 DELAY_OUT a_5632_534# 0.01399f
C225 a_5632_534# DOWN_INV 0.12158f
C226 UP_INV a_4635_436# 0.0176f
C227 VDD DELAY_IN 0.27641f
C228 a_4635_1087# a_5632_1318# 0.03093f
C229 VDD a_756_1080# 0.07206f
C230 a_5375_391# a_5632_534# 0.29858f
C231 a_4116_1080# a_4404_1501# 0.43707f
C232 a_4533_1087# a_4404_1501# 0.01562f
C233 DLL_RESETN a_3656_629# 0.01683f
R0 VDD.n1 VDD.t8 17.6089
R1 VDD.t0 VDD.t23 17.3693
R2 VDD.t0 VDD.t14 17.3693
R3 VDD.n3 VDD.t2 17.3517
R4 VDD.n0 VDD.t27 17.3517
R5 VDD.n0 VDD.t12 17.3517
R6 VDD.n0 VDD.t24 17.2247
R7 VDD.n3 VDD.t1 17.0005
R8 VDD.n0 VDD.t35 17.0005
R9 VDD.n0 VDD.t33 17.0005
R10 VDD VDD.t0 4.47317
R11 VDD.n2 VDD.t30 8.76054
R12 VDD.n2 VDD.t15 8.76054
R13 VDD.n0 VDD.t5 5.9886
R14 VDD.n2 VDD.t22 5.97675
R15 VDD.n2 VDD.t17 5.97675
R16 VDD.n0 VDD.t39 5.96478
R17 VDD.t0 VDD.n0 1.14326
R18 VDD.n1 VDD.n3 0.369183
R19 VDD.t0 VDD.n2 0.826274
R20 VDD.t0 VDD.n1 1.1115
R21 VSS.n31 VSS.n30 16686.3
R22 VSS.t67 VSS.n20 365.469
R23 VSS.t70 VSS.t59 865.169
R24 VSS.n25 VSS.t55 853.933
R25 VSS.n28 VSS.t0 853.933
R26 VSS.n34 VSS.t70 797.754
R27 VSS.n14 VSS.t13 97.9194
R28 VSS.n22 VSS.n19 230.349
R29 VSS.t44 VSS.n21 679.803
R30 VSS.n5 VSS.t45 651.692
R31 VSS.t3 VSS.t17 90.4096
R32 VSS.t6 VSS.n14 161.648
R33 VSS.t6 VSS.n1 577.799
R34 VSS.t21 VSS.n5 540.855
R35 VSS.t15 VSS.t52 21.0382
R36 VSS.t49 VSS.n6 164.31
R37 VSS.n26 VSS.n9 299.099
R38 VSS.t3 VSS.n27 499.642
R39 VSS.n7 VSS.t34 29.5487
R40 VSS.t15 VSS.n7 0.846453
R41 VSS.n25 VSS.n24 444.89
R42 VSS.n29 VSS.n28 444.89
R43 VSS.n18 VSS.t37 450.452
R44 VSS.t57 VSS.n15 75.8499
R45 VSS.n18 VSS.t3 9.51091
R46 VSS.n35 VSS.t47 392.57
R47 VSS.t68 VSS.t25 372.747
R48 VSS.t22 VSS.n12 379.442
R49 VSS.t61 VSS.t12 372.747
R50 VSS.n12 VSS.t3 9.83317
R51 VSS.n16 VSS.t9 139.087
R52 VSS.n34 VSS.n33 345.257
R53 VSS.t71 VSS.t51 328.043
R54 VSS.n11 VSS.t41 334.264
R55 VSS.t21 VSS.n20 187.441
R56 VSS.t15 VSS.n11 9.49153
R57 VSS.n18 VSS.t29 173.609
R58 VSS.t73 VSS.t43 289.269
R59 VSS.n30 VSS.t37 282.233
R60 VSS.t33 VSS.n13 107.668
R61 VSS.t15 VSS.n35 255.849
R62 VSS.t50 VSS.t31 242.327
R63 VSS.n12 VSS.t35 139.087
R64 VSS.n16 VSS.t16 379.442
R65 VSS.t2 VSS.t11 237.481
R66 VSS.n26 VSS.n1 230.51
R67 VSS.t54 VSS.n11 127.894
R68 VSS.n23 VSS.t22 220.464
R69 VSS.n0 VSS.t16 220.464
R70 VSS.t41 VSS.n31 212.328
R71 VSS.t26 VSS.t36 202.096
R72 VSS.t5 VSS.t10 202.096
R73 VSS.t15 VSS.t14 125.523
R74 VSS.t38 VSS.n13 295.863
R75 VSS.n32 VSS.t38 174.433
R76 VSS.t25 VSS.n23 166.356
R77 VSS.t12 VSS.n0 166.356
R78 VSS.t36 VSS.t24 143.714
R79 VSS.t10 VSS.t18 143.714
R80 VSS.t43 VSS.n32 132.442
R81 VSS.n35 VSS.n34 112.361
R82 VSS.n15 VSS.t71 124.57
R83 VSS.t23 VSS.t3 90.4096
R84 VSS.n9 VSS.t48 164.31
R85 VSS.t63 VSS.n27 101.124
R86 VSS.t4 VSS.t2 96.931
R87 VSS.t15 VSS.n15 3.00967
R88 VSS.t47 VSS.t50 92.0845
R89 VSS.t39 VSS.t15 69.6456
R90 VSS.t40 VSS.n7 74.5356
R91 VSS.t45 VSS.n21 73.8921
R92 VSS.n24 VSS.t68 54.1087
R93 VSS.n29 VSS.t61 54.1087
R94 VSS.n27 VSS.t4 43.6192
R95 VSS.n33 VSS.t73 41.9912
R96 VSS.n22 VSS.t26 40.4197
R97 VSS.n26 VSS.t5 40.4197
R98 VSS.t19 VSS.n17 29.6918
R99 VSS.t27 VSS.n19 22.6691
R100 VSS.t3 VSS.t65 23.217
R101 VSS.n4 VSS.t20 17.267
R102 VSS.t3 VSS.t69 17.2395
R103 VSS.n10 VSS.t62 17.2395
R104 VSS VSS.t74 17.2395
R105 VSS.t3 VSS.t28 17.2297
R106 VSS.n8 VSS.t53 17.2297
R107 VSS.n4 VSS.t8 17.212
R108 VSS.n8 VSS.t58 17.212
R109 VSS.t3 VSS.t56 17.2042
R110 VSS.n10 VSS.t1 17.2398
R111 VSS VSS.t60 17.2042
R112 VSS.t3 VSS.n29 17.0005
R113 VSS.t3 VSS.n16 9.83317
R114 VSS.t3 VSS.n14 2.74829
R115 VSS.t3 VSS.n21 17.0005
R116 VSS.t3 VSS.n20 14.1445
R117 VSS.n24 VSS.t3 17.0005
R118 VSS.t3 VSS.n19 0.549965
R119 VSS.n13 VSS.t15 9.80849
R120 VSS.n33 VSS.t15 17.0005
R121 VSS.t67 VSS.n25 11.2365
R122 VSS.n28 VSS.t63 11.2365
R123 VSS.t3 VSS.t30 9.08858
R124 VSS.n8 VSS.t42 8.87472
R125 VSS.n2 VSS.t46 9.00704
R126 VSS.n4 VSS.t66 8.75631
R127 VSS.n4 VSS.t7 8.74785
R128 VSS.t3 VSS.n9 3.1686
R129 VSS.n22 VSS.n6 299.099
R130 VSS.n3 VSS.t3 0.431646
R131 VSS.n4 VSS.n2 1.32429
R132 VSS.t3 VSS 5.13648
R133 VSS.t3 VSS.n2 0.422275
R134 VSS.n8 VSS.t15 0.916632
R135 VSS.n10 VSS.n3 0.512265
R136 VSS.n32 VSS.t15 0.600709
R137 VSS.t32 VSS.t3 17.4008
R138 VSS.t51 VSS.t15 85.2351
R139 VSS.t3 VSS.n0 0.473876
R140 VSS.n23 VSS.t3 0.473876
R141 VSS.t3 VSS.n1 0.389775
R142 VSS.n17 VSS.t44 45.7968
R143 VSS.n6 VSS.t3 3.1686
R144 VSS.n31 VSS.t15 1.40105
R145 VSS.n30 VSS.t3 1.22092
R146 VSS.t3 VSS.n5 1.10394
R147 VSS VSS.t15 0.571389
R148 VSS.n4 VSS.n3 1.07266
R149 VSS.t3 VSS.n17 1.06041
C234 DOWN_INV VSS 0.17401f
C235 DELAY_OUT VSS 0.38023f
C236 UP_INV VSS 0.36891f
C237 UP VSS 0.74384f
C238 DOWN VSS 1.48041f
C239 DELAY_IN VSS 0.69997f
C240 DLL_RESETN VSS 1.36665f
C241 VDD VSS 1.76639f
C242 a_5281_391# VSS 0.09495f ; **FLOATING
C243 a_4404_327# VSS 0.06985f ; **FLOATING
C244 a_6212_612# VSS 0.26771f ; **FLOATING
C245 a_5632_534# VSS 0.24716f ; **FLOATING
C246 a_5375_391# VSS 0.39443f ; **FLOATING
C247 a_4635_436# VSS 0.20246f ; **FLOATING
C248 a_4533_293# VSS 0.47328f ; **FLOATING
C249 a_4116_632# VSS 1.57614f ; **FLOATING
C250 a_3830_314# VSS 0.30118f ; **FLOATING
C251 a_4090_537# VSS 0.15441f ; **FLOATING
C252 a_3656_629# VSS 0.13029f ; **FLOATING
C253 a_3431_629# VSS 0.14345f ; **FLOATING
C254 a_3431_395# VSS 0.14751f ; **FLOATING
C255 a_3630_566# VSS 0.06318f ; **FLOATING
C256 a_5281_1437# VSS 0.09586f ; **FLOATING
C257 a_6212_1076# VSS 0.26777f ; **FLOATING
C258 a_5375_1437# VSS 0.39588f ; **FLOATING
C259 a_5632_1318# VSS 0.24582f ; **FLOATING
C260 a_4635_1087# VSS 0.21915f ; **FLOATING
C261 a_4404_1501# VSS 0.07345f ; **FLOATING
C262 a_4533_1087# VSS 0.48187f ; **FLOATING
C263 a_4116_1080# VSS 1.58208f ; **FLOATING
C264 a_4090_1044# VSS 0.15442f ; **FLOATING
C265 a_3569_1424# VSS 0.01124f ; **FLOATING
C266 a_3830_1514# VSS 0.31701f ; **FLOATING
C267 a_3373_1076# VSS 1.48165f ; **FLOATING
C268 a_3180_1073# VSS 0.28391f ; **FLOATING
C269 a_2879_1076# VSS 0.6229f ; **FLOATING
C270 a_1921_1437# VSS 0.09495f ; **FLOATING
C271 a_2682_1076# VSS 0.2589f ; **FLOATING
C272 a_2015_1437# VSS 0.3013f ; **FLOATING
C273 a_2272_1318# VSS 0.17078f ; **FLOATING
C274 a_1275_1087# VSS 0.20089f ; **FLOATING
C275 a_1044_1501# VSS 0.03671f ; **FLOATING
C276 a_1173_1087# VSS 0.47618f ; **FLOATING
C277 a_756_1080# VSS 1.52123f ; **FLOATING
C278 a_730_1044# VSS 0.08582f ; **FLOATING
C279 a_470_1514# VSS 0.18138f ; **FLOATING
C280 a_296_1052# VSS 0.13365f ; **FLOATING
C281 a_270_1014# VSS 0.06894f ; **FLOATING
C282 a_71_1381# VSS 0.15f ; **FLOATING
C283 a_71_1151# VSS 0.14459f ; **FLOATING
C284 VDD.n0 VSS 0.5847f ; **FLOATING
C285 VDD.n1 VSS 0.18992f ; **FLOATING
C286 VDD.t0 VSS 12.0383f ; **FLOATING
C287 VDD.n2 VSS 0.35795f ; **FLOATING
C288 VDD.n3 VSS 0.20596f ; **FLOATING
C289 VDD.t14 VSS 0.0316f ; **FLOATING
C290 VDD.t23 VSS 0.0316f ; **FLOATING
C291 VDD.t24 VSS 0.04295f ; **FLOATING
C292 VDD.t39 VSS 0.03966f ; **FLOATING
C293 VDD.t2 VSS 0.01466f ; **FLOATING
C294 VDD.t1 VSS 0.07291f ; **FLOATING
C295 VDD.t8 VSS 0.03422f ; **FLOATING
C296 VDD.t5 VSS 0.04444f ; **FLOATING
C297 VDD.t12 VSS 0.01466f ; **FLOATING
C298 VDD.t33 VSS 0.07291f ; **FLOATING
C299 VDD.t27 VSS 0.01466f ; **FLOATING
C300 VDD.t35 VSS 0.07291f ; **FLOATING
C301 VDD.t15 VSS 0.05374f ; **FLOATING
C302 VDD.t30 VSS 0.05374f ; **FLOATING
C303 VDD.t17 VSS 0.04444f ; **FLOATING
C304 VDD.t22 VSS 0.04444f ; **FLOATING
.ends
