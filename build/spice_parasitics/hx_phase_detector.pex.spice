* NGSPICE file created from hx_phase_detector.ext - technology: ihp-sg13g2

.subckt hx_phase_detector VSS VDD UP_INV DOWN DOWN_INV DLL_RESETN DELAY_IN UP DELAY_OUT
X0 UP_INV a_5375_1437# VSS.t28 VSS.t27 sg13_lv_nmos ad=0.2849p pd=2.25u as=0.2516p ps=2.16u w=0.74u l=0.13u
X1 a_4116_1080# a_4635_1087# a_5375_1437# VSS.t36 sg13_lv_nmos ad=0.3473p pd=2.71u as=0.12665p ps=1.145u w=0.74u l=0.13u
X2 VDD.t0 a_5632_1318# a_5577_1199# VDD.t0 sg13_lv_pmos ad=1.06255p pd=6.38u as=93.45f ps=0.865u w=0.42u l=0.13u
X3 a_4342_327# a_3373_1076# VSS.t74 VSS.t73 sg13_lv_nmos ad=37.8f pd=0.6u as=0.1701p ps=1.65u w=0.42u l=0.13u
X4 UP a_6212_1076# VSS.t30 VSS.t37 sg13_lv_nmos ad=0.2516p pd=2.16u as=0.1406p ps=1.12u w=0.74u l=0.13u
X5 a_5577_629# a_4635_436# a_5375_391# VDD.t0 sg13_lv_pmos ad=93.45f pd=0.865u as=0.2048p ps=1.63u w=0.42u l=0.13u
X6 a_5375_391# a_4533_293# a_4116_632# VDD.t0 sg13_lv_pmos ad=0.2048p pd=1.63u as=0.34p ps=2.68u w=1u l=0.13u
X7 a_4473_1123# a_4116_1080# VDD.t14 VDD.t0 sg13_lv_pmos ad=63f pd=0.72u as=0.1563p ps=1.22u w=0.42u l=0.13u
X8 a_756_1080# a_1275_1087# a_2015_1437# VSS.t10 sg13_lv_nmos ad=0.3473p pd=2.71u as=0.12665p ps=1.145u w=0.74u l=0.13u
X9 a_2272_1318# DLL_RESETN VDD.t0 VDD.t0 sg13_lv_pmos ad=79.8f pd=0.8u as=1.06255p ps=6.38u w=0.42u l=0.13u
X10 a_3373_1076# a_3180_1073# VSS.t20 VSS.t19 sg13_lv_nmos ad=0.1406p pd=1.12u as=0.2516p ps=2.16u w=0.74u l=0.13u
X11 a_1173_1087# DELAY_IN VDD.t0 VDD.t0 sg13_lv_pmos ad=0.4088p pd=2.97u as=0.99612p ps=5.98u w=1.12u l=0.13u
X12 a_2879_1076# a_2682_1076# VSS.t7 VSS.t13 sg13_lv_nmos ad=0.2516p pd=2.16u as=0.1406p ps=1.12u w=0.74u l=0.13u
X13 a_1113_1123# a_756_1080# VDD.t8 VDD.t0 sg13_lv_pmos ad=63f pd=0.72u as=0.1563p ps=1.22u w=0.42u l=0.13u
X14 a_4090_537# a_4533_293# a_4473_705# VDD.t0 sg13_lv_pmos ad=79.8f pd=0.8u as=63f ps=0.72u w=0.42u l=0.13u
X15 VSS.t3 a_1173_1087# a_1275_1087# VSS.t17 sg13_lv_nmos ad=2.30077p pd=14.835u as=0.2516p ps=2.16u w=0.74u l=0.13u
X16 a_3180_1073# DLL_RESETN VDD.t39 VDD.t0 sg13_lv_pmos ad=0.3808p pd=2.92u as=0.3808p ps=2.92u w=1.12u l=0.13u
X17 a_4342_1501# a_3373_1076# VSS.t69 VSS.t68 sg13_lv_nmos ad=37.8f pd=0.6u as=0.1701p ps=1.65u w=0.42u l=0.13u
X18 a_4090_1044# a_4533_1087# a_4473_1123# VDD.t0 sg13_lv_pmos ad=79.8f pd=0.8u as=63f ps=0.72u w=0.42u l=0.13u
X19 VSS.t15 a_4533_293# a_4635_436# VSS.t39 sg13_lv_nmos ad=1.45407p pd=9.445u as=0.2516p ps=2.16u w=0.74u l=0.13u
X20 VDD.t0 a_4533_293# a_4635_436# VDD.t0 sg13_lv_pmos ad=1.06255p pd=6.38u as=0.3864p ps=2.93u w=1.12u l=0.13u
X21 a_3830_314# a_4635_436# a_4090_537# VDD.t0 sg13_lv_pmos ad=0.1428p pd=1.52u as=79.8f ps=0.8u w=0.42u l=0.13u
X22 a_3830_314# a_3656_629# VDD.t27 VDD.t0 sg13_lv_pmos ad=79.8f pd=0.8u as=0.1428p ps=1.52u w=0.42u l=0.13u
X23 a_730_1044# a_1173_1087# a_1113_1123# VDD.t0 sg13_lv_pmos ad=79.8f pd=0.8u as=63f ps=0.72u w=0.42u l=0.13u
X24 a_982_1501# DLL_RESETN VSS.t62 VSS.t61 sg13_lv_nmos ad=37.8f pd=0.6u as=0.1701p ps=1.65u w=0.42u l=0.13u
X25 a_296_1052# a_270_1014# VDD.t0 VDD.t0 sg13_lv_pmos ad=0.3927p pd=2.99u as=1.06255p ps=6.38u w=1.155u l=0.13u
X26 VDD.t35 a_3373_1076# a_3830_314# VDD.t0 sg13_lv_pmos ad=0.36237p pd=2.605u as=79.8f ps=0.8u w=0.42u l=0.13u
X27 VSS.t60 a_3373_1076# a_3924_314# VSS.t70 sg13_lv_nmos ad=0.1626p pd=1.415u as=60.89999f ps=0.71u w=0.42u l=0.13u
X28 a_5632_1318# a_3373_1076# VDD.t0 VDD.t0 sg13_lv_pmos ad=79.8f pd=0.8u as=0.99612p ps=5.98u w=0.42u l=0.13u
X29 DOWN_INV a_5375_391# VDD.t30 VDD.t0 sg13_lv_pmos ad=0.4312p pd=3.01u as=0.2639p ps=1.81u w=1.12u l=0.13u
X30 VDD.t14 a_3373_1076# a_4090_1044# VDD.t0 sg13_lv_pmos ad=0.1563p pd=1.22u as=0.147p ps=1.54u w=0.42u l=0.13u
X31 a_3830_1514# a_2879_1076# VDD.t12 VDD.t0 sg13_lv_pmos ad=79.8f pd=0.8u as=0.1428p ps=1.52u w=0.42u l=0.13u
X32 VSS.t8 a_2272_1318# a_1921_1437# VSS.t5 sg13_lv_nmos ad=79.8f pd=0.8u as=0.1428p ps=1.52u w=0.42u l=0.13u
X33 a_3569_1424# DOWN a_3373_1076# VSS.t44 sg13_lv_nmos ad=0.1406p pd=1.12u as=0.1406p ps=1.12u w=0.74u l=0.13u
X34 VSS.t3 a_4533_1087# a_4635_1087# VSS.t23 sg13_lv_nmos ad=2.30077p pd=14.835u as=0.2516p ps=2.16u w=0.74u l=0.13u
X35 a_4533_1087# DELAY_IN VDD.t0 VDD.t0 sg13_lv_pmos ad=0.4088p pd=2.97u as=0.99612p ps=5.98u w=1.12u l=0.13u
X36 VDD.t8 DLL_RESETN a_730_1044# VDD.t0 sg13_lv_pmos ad=0.1563p pd=1.22u as=0.147p ps=1.54u w=0.42u l=0.13u
X37 a_5375_391# a_4533_293# a_5281_391# VSS.t40 sg13_lv_nmos ad=0.12665p pd=1.145u as=0.1428p ps=1.52u w=0.42u l=0.13u
X38 a_3924_314# a_3656_629# a_3830_314# VSS.t47 sg13_lv_nmos ad=60.89999f pd=0.71u as=0.1428p ps=1.52u w=0.42u l=0.13u
X39 a_3830_1514# a_4635_1087# a_4090_1044# VDD.t0 sg13_lv_pmos ad=0.1428p pd=1.52u as=79.8f ps=0.8u w=0.42u l=0.13u
X40 VDD.t0 a_5632_534# a_5577_629# VDD.t0 sg13_lv_pmos ad=1.06255p pd=6.38u as=93.45f ps=0.865u w=0.42u l=0.13u
X41 VSS.t56 a_3373_1076# a_3924_1514# VSS.t67 sg13_lv_nmos ad=0.1626p pd=1.415u as=60.89999f ps=0.71u w=0.42u l=0.13u
X42 VDD.t0 a_71_1381# a_71_1151# VDD.t0 sg13_lv_pmos ad=1.06255p pd=6.38u as=0.2442p ps=2.06u w=0.66u l=0.13u
X43 a_470_1514# a_1275_1087# a_730_1044# VDD.t0 sg13_lv_pmos ad=0.1428p pd=1.52u as=79.8f ps=0.8u w=0.42u l=0.13u
X44 a_756_1080# a_730_1044# VSS.t1 VSS.t0 sg13_lv_nmos ad=0.2516p pd=2.16u as=0.1626p ps=1.415u w=0.74u l=0.13u
X45 VSS.t42 a_5375_391# a_6212_612# VSS.t54 sg13_lv_nmos ad=0.1406p pd=1.12u as=0.2516p ps=2.16u w=0.74u l=0.13u
X46 a_5632_534# a_3373_1076# VDD.t0 VDD.t0 sg13_lv_pmos ad=79.8f pd=0.8u as=0.99612p ps=5.98u w=0.42u l=0.13u
X47 a_470_1514# a_296_1052# VDD.t2 VDD.t0 sg13_lv_pmos ad=79.8f pd=0.8u as=0.1428p ps=1.52u w=0.42u l=0.13u
X48 a_4116_632# a_4635_436# a_5375_391# VSS.t34 sg13_lv_nmos ad=0.3473p pd=2.71u as=0.12665p ps=1.145u w=0.74u l=0.13u
X49 a_5632_1318# a_5375_1437# a_5794_1514# VSS.t26 sg13_lv_nmos ad=0.1428p pd=1.52u as=37.8f ps=0.6u w=0.42u l=0.13u
X50 a_2015_1437# a_1173_1087# a_756_1080# VDD.t0 sg13_lv_pmos ad=0.2048p pd=1.63u as=0.34p ps=2.68u w=1u l=0.13u
X51 VDD.t30 a_5375_391# a_5632_534# VDD.t0 sg13_lv_pmos ad=0.2639p pd=1.81u as=79.8f ps=0.8u w=0.42u l=0.13u
X52 a_3467_1076# a_3180_1073# a_3373_1076# VDD.t0 sg13_lv_pmos ad=0.2128p pd=1.5u as=0.3808p ps=2.92u w=1.12u l=0.13u
X53 a_3630_566# a_3431_629# VSS.t15 VSS.t50 sg13_lv_nmos ad=0.27427p pd=2.28u as=1.45407p ps=9.445u w=0.795u l=0.13u
X54 VDD.t17 a_5375_1437# a_6212_1076# VDD.t0 sg13_lv_pmos ad=0.2128p pd=1.5u as=0.3864p ps=2.93u w=1.12u l=0.13u
X55 a_2015_1437# a_1173_1087# a_1921_1437# VSS.t18 sg13_lv_nmos ad=0.12665p pd=1.145u as=0.1428p ps=1.52u w=0.42u l=0.13u
X56 VSS.t3 a_71_1381# a_71_1381# VSS.t11 sg13_lv_nmos ad=2.30077p pd=14.835u as=0.111p ps=1.34u w=0.3u l=0.13u
X57 DOWN a_6212_612# VSS.t42 VSS.t41 sg13_lv_nmos ad=0.2516p pd=2.16u as=0.1406p ps=1.12u w=0.74u l=0.13u
X58 VDD.t0 a_1173_1087# a_1275_1087# VDD.t0 sg13_lv_pmos ad=1.06255p pd=6.38u as=0.3864p ps=2.93u w=1.12u l=0.13u
X59 a_2272_1318# a_2015_1437# a_2434_1514# VSS.t5 sg13_lv_nmos ad=0.1428p pd=1.52u as=37.8f ps=0.6u w=0.42u l=0.13u
X60 VSS.t32 a_5632_1318# a_5281_1437# VSS.t26 sg13_lv_nmos ad=79.8f pd=0.8u as=0.1428p ps=1.52u w=0.42u l=0.13u
X61 VDD.t0 a_3431_395# a_3431_629# VDD.t0 sg13_lv_pmos ad=1.06255p pd=6.38u as=0.2442p ps=2.06u w=0.66u l=0.13u
X62 VDD.t5 a_2015_1437# a_2682_1076# VDD.t0 sg13_lv_pmos ad=0.2128p pd=1.5u as=0.3864p ps=2.93u w=1.12u l=0.13u
X63 VSS.t46 UP a_3569_1424# VSS.t45 sg13_lv_nmos ad=0.2516p pd=2.16u as=0.1406p ps=1.12u w=0.74u l=0.13u
X64 VSS.t1 DLL_RESETN a_564_1514# VSS.t63 sg13_lv_nmos ad=0.1626p pd=1.415u as=60.89999f ps=0.71u w=0.42u l=0.13u
X65 a_2434_1514# DLL_RESETN VSS.t8 VSS.t5 sg13_lv_nmos ad=37.8f pd=0.6u as=79.8f ps=0.8u w=0.42u l=0.13u
X66 a_3656_629# a_3630_566# VDD.t0 VDD.t0 sg13_lv_pmos ad=0.3927p pd=2.99u as=1.06255p ps=6.38u w=1.155u l=0.13u
X67 VDD.t0 a_2015_1437# a_2272_1318# VDD.t0 sg13_lv_pmos ad=1.06255p pd=6.38u as=79.8f ps=0.8u w=0.42u l=0.13u
X68 a_4090_1044# a_4533_1087# a_3830_1514# VSS.t22 sg13_lv_nmos ad=79.8f pd=0.8u as=0.1296p ps=1.52u w=0.42u l=0.13u
X69 a_756_1080# a_730_1044# VDD.t1 VDD.t0 sg13_lv_pmos ad=0.34p pd=2.68u as=0.36237p ps=2.605u w=1u l=0.13u
X70 a_1044_1501# a_756_1080# a_982_1501# VSS.t12 sg13_lv_nmos ad=0.1428p pd=1.52u as=37.8f ps=0.6u w=0.42u l=0.13u
X71 a_4116_1080# a_4090_1044# VSS.t56 VSS.t55 sg13_lv_nmos ad=0.2516p pd=2.16u as=0.1626p ps=1.415u w=0.74u l=0.13u
X72 a_730_1044# a_1173_1087# a_470_1514# VSS.t16 sg13_lv_nmos ad=79.8f pd=0.8u as=0.1296p ps=1.52u w=0.42u l=0.13u
X73 a_270_1014# a_71_1151# VSS.t3 VSS.t2 sg13_lv_nmos ad=0.27427p pd=2.28u as=2.30077p ps=14.835u w=0.795u l=0.13u
X74 a_5375_1437# a_4533_1087# a_4116_1080# VDD.t0 sg13_lv_pmos ad=0.2048p pd=1.63u as=0.34p ps=2.68u w=1u l=0.13u
X75 a_1173_1087# DELAY_IN VSS.t3 VSS.t48 sg13_lv_nmos ad=0.2516p pd=2.16u as=1.9173p ps=12.365u w=0.74u l=0.13u
X76 UP_INV a_5375_1437# VDD.t15 VDD.t0 sg13_lv_pmos ad=0.4312p pd=3.01u as=0.2639p ps=1.81u w=1.12u l=0.13u
X77 VDD.t0 a_4533_1087# a_4635_1087# VDD.t0 sg13_lv_pmos ad=1.06255p pd=6.38u as=0.3864p ps=2.93u w=1.12u l=0.13u
X78 VDD.t24 DOWN a_3467_1076# VDD.t0 sg13_lv_pmos ad=0.2128p pd=1.5u as=0.2128p ps=1.5u w=1.12u l=0.13u
X79 UP a_6212_1076# VDD.t17 VDD.t0 sg13_lv_pmos ad=0.3808p pd=2.92u as=0.2128p ps=1.5u w=1.12u l=0.13u
X80 a_4116_1080# a_4090_1044# VDD.t33 VDD.t0 sg13_lv_pmos ad=0.34p pd=2.68u as=0.36237p ps=2.605u w=1u l=0.13u
X81 a_5794_1514# a_3373_1076# VSS.t32 VSS.t26 sg13_lv_nmos ad=37.8f pd=0.6u as=79.8f ps=0.8u w=0.42u l=0.13u
X82 VDD.t15 a_5375_1437# a_5632_1318# VDD.t0 sg13_lv_pmos ad=0.2639p pd=1.81u as=79.8f ps=0.8u w=0.42u l=0.13u
X83 a_2879_1076# a_2682_1076# VDD.t5 VDD.t0 sg13_lv_pmos ad=0.3808p pd=2.92u as=0.2128p ps=1.5u w=1.12u l=0.13u
X84 a_5375_1437# a_4533_1087# a_5281_1437# VSS.t24 sg13_lv_nmos ad=0.12665p pd=1.145u as=0.1428p ps=1.52u w=0.42u l=0.13u
X85 a_3180_1073# DLL_RESETN VSS.t66 VSS.t65 sg13_lv_nmos ad=0.2516p pd=2.16u as=0.2516p ps=2.16u w=0.74u l=0.13u
X86 VSS.t30 a_5375_1437# a_6212_1076# VSS.t29 sg13_lv_nmos ad=0.1406p pd=1.12u as=0.2516p ps=2.16u w=0.74u l=0.13u
X87 a_3924_1514# a_2879_1076# a_3830_1514# VSS.t21 sg13_lv_nmos ad=60.89999f pd=0.71u as=0.1428p ps=1.52u w=0.42u l=0.13u
X88 a_4404_1501# a_4116_1080# a_4342_1501# VSS.t25 sg13_lv_nmos ad=0.1428p pd=1.52u as=37.8f ps=0.6u w=0.42u l=0.13u
X89 VDD.t0 a_2272_1318# a_2217_1199# VDD.t0 sg13_lv_pmos ad=1.06255p pd=6.38u as=93.45f ps=0.865u w=0.42u l=0.13u
X90 a_4404_1501# a_4635_1087# a_4090_1044# VSS.t35 sg13_lv_nmos ad=0.2373p pd=1.97u as=79.8f ps=0.8u w=0.42u l=0.13u
X91 a_4533_293# DELAY_OUT VSS.t15 VSS.t14 sg13_lv_nmos ad=0.2516p pd=2.16u as=1.45407p ps=9.445u w=0.74u l=0.13u
X92 a_4090_537# a_4533_293# a_3830_314# VSS.t38 sg13_lv_nmos ad=79.8f pd=0.8u as=0.1296p ps=1.52u w=0.42u l=0.13u
X93 a_5577_1199# a_4635_1087# a_5375_1437# VDD.t0 sg13_lv_pmos ad=93.45f pd=0.865u as=0.2048p ps=1.63u w=0.42u l=0.13u
X94 a_4404_327# a_4116_632# a_4342_327# VSS.t43 sg13_lv_nmos ad=0.1428p pd=1.52u as=37.8f ps=0.6u w=0.42u l=0.13u
X95 a_4533_293# DELAY_OUT VDD.t0 VDD.t0 sg13_lv_pmos ad=0.4088p pd=2.97u as=1.06255p ps=6.38u w=1.12u l=0.13u
X96 VSS.t7 a_2015_1437# a_2682_1076# VSS.t6 sg13_lv_nmos ad=0.1406p pd=1.12u as=0.2516p ps=2.16u w=0.74u l=0.13u
X97 DOWN_INV a_5375_391# VSS.t53 VSS.t52 sg13_lv_nmos ad=0.2849p pd=2.25u as=0.2516p ps=2.16u w=0.74u l=0.13u
X98 VDD.t22 a_5375_391# a_6212_612# VDD.t0 sg13_lv_pmos ad=0.2128p pd=1.5u as=0.3864p ps=2.93u w=1.12u l=0.13u
X99 a_4473_705# a_4116_632# VDD.t23 VDD.t0 sg13_lv_pmos ad=63f pd=0.72u as=0.1563p ps=1.22u w=0.42u l=0.13u
X100 a_1044_1501# a_1275_1087# a_730_1044# VSS.t9 sg13_lv_nmos ad=0.2373p pd=1.97u as=79.8f ps=0.8u w=0.42u l=0.13u
X101 VDD.t33 a_3373_1076# a_3830_1514# VDD.t0 sg13_lv_pmos ad=0.36237p pd=2.605u as=79.8f ps=0.8u w=0.42u l=0.13u
X102 a_2217_1199# a_1275_1087# a_2015_1437# VDD.t0 sg13_lv_pmos ad=93.45f pd=0.865u as=0.2048p ps=1.63u w=0.42u l=0.13u
X103 VSS.t58 a_5632_534# a_5281_391# VSS.t57 sg13_lv_nmos ad=79.8f pd=0.8u as=0.1428p ps=1.52u w=0.42u l=0.13u
X104 a_4404_327# a_4635_436# a_4090_537# VSS.t33 sg13_lv_nmos ad=0.2373p pd=1.97u as=79.8f ps=0.8u w=0.42u l=0.13u
X105 a_4116_632# a_4090_537# VDD.t35 VDD.t0 sg13_lv_pmos ad=0.34p pd=2.68u as=0.36237p ps=2.605u w=1u l=0.13u
X106 VSS.t15 a_3431_395# a_3431_395# VSS.t31 sg13_lv_nmos ad=1.45407p pd=9.445u as=0.111p ps=1.34u w=0.3u l=0.13u
X107 DOWN a_6212_612# VDD.t22 VDD.t0 sg13_lv_pmos ad=0.3808p pd=2.92u as=0.2128p ps=1.5u w=1.12u l=0.13u
X108 VDD.t23 a_3373_1076# a_4090_537# VDD.t0 sg13_lv_pmos ad=0.1563p pd=1.22u as=0.147p ps=1.54u w=0.42u l=0.13u
X109 a_5794_314# a_3373_1076# VSS.t58 VSS.t71 sg13_lv_nmos ad=37.8f pd=0.6u as=79.8f ps=0.8u w=0.42u l=0.13u
X110 VDD.t1 DLL_RESETN a_470_1514# VDD.t0 sg13_lv_pmos ad=0.36237p pd=2.605u as=79.8f ps=0.8u w=0.42u l=0.13u
X111 a_3467_1076# UP VDD.t24 VDD.t0 sg13_lv_pmos ad=0.3808p pd=2.92u as=0.2128p ps=1.5u w=1.12u l=0.13u
X112 a_564_1514# a_296_1052# a_470_1514# VSS.t4 sg13_lv_nmos ad=60.89999f pd=0.71u as=0.1428p ps=1.52u w=0.42u l=0.13u
X113 a_4533_1087# DELAY_IN VSS.t3 VSS.t49 sg13_lv_nmos ad=0.2516p pd=2.16u as=1.9173p ps=12.365u w=0.74u l=0.13u
X114 a_5632_534# a_5375_391# a_5794_314# VSS.t51 sg13_lv_nmos ad=0.1428p pd=1.52u as=37.8f ps=0.6u w=0.42u l=0.13u
X115 a_4116_632# a_4090_537# VSS.t60 VSS.t59 sg13_lv_nmos ad=0.2516p pd=2.16u as=0.1626p ps=1.415u w=0.74u l=0.13u
C0 a_4116_1080# UP 0.01445f
C1 a_5375_1437# UP_INV 0.12121f
C2 a_6212_1076# UP 0.17255f
C3 a_3373_1076# a_2879_1076# 0.07687f
C4 VDD a_4533_293# 0.28344f
C5 a_5281_391# UP_INV 0.02171f
C6 a_3830_314# a_4635_436# 0.097f
C7 DLL_RESETN a_2879_1076# 0.04879f
C8 DELAY_IN a_4090_537# 0.01093f
C9 DLL_RESETN a_2682_1076# 0.02442f
C10 a_270_1014# a_71_1381# 0.02437f
C11 a_3373_1076# a_3467_1076# 0.16706f
C12 a_3180_1073# DOWN 0.04193f
C13 DOWN_INV DOWN 0.04649f
C14 DLL_RESETN a_3467_1076# 0.03616f
C15 VDD a_3656_629# 0.23863f
C16 DELAY_IN a_3180_1073# 0.01215f
C17 a_756_1080# a_1044_1501# 0.43707f
C18 DELAY_IN a_3830_1514# 0.05059f
C19 a_470_1514# a_1173_1087# 0.02432f
C20 UP a_4635_1087# 0.0235f
C21 a_4635_436# a_4533_293# 0.47622f
C22 a_5632_1318# UP 0.03701f
C23 UP a_3373_1076# 0.55272f
C24 DLL_RESETN a_1173_1087# 0.05713f
C25 a_2015_1437# DELAY_IN 0.01827f
C26 UP_INV a_4116_632# 0.01817f
C27 DLL_RESETN UP 0.04333f
C28 VDD DOWN 0.40918f
C29 a_6212_612# UP 0.01441f
C30 DELAY_OUT DOWN_INV 0.02074f
C31 a_4116_1080# a_4635_1087# 0.34102f
C32 VDD DELAY_IN 0.27641f
C33 a_1921_1437# a_1173_1087# 0.01058f
C34 a_4116_1080# a_3373_1076# 0.38817f
C35 DLL_RESETN a_3431_395# 0.02116f
C36 a_756_1080# DELAY_IN 0.08086f
C37 a_4116_1080# a_4404_1501# 0.43707f
C38 VDD DELAY_OUT 0.16332f
C39 VDD a_71_1381# 0.0617f
C40 a_5632_1318# a_4635_1087# 0.03093f
C41 a_3373_1076# a_4635_1087# 0.42174f
C42 a_4533_1087# a_4090_1044# 0.02242f
C43 VDD a_5375_1437# 0.25326f
C44 a_5632_1318# a_3373_1076# 0.10225f
C45 a_296_1052# a_270_1014# 0.1657f
C46 a_4090_537# a_4116_632# 0.36952f
C47 DLL_RESETN a_470_1514# 0.09997f
C48 a_3830_314# a_4404_327# 0.31978f
C49 DLL_RESETN a_3373_1076# 0.34978f
C50 DELAY_OUT a_5375_391# 0.02109f
C51 a_4635_1087# a_4404_1501# 0.12701f
C52 DELAY_OUT a_4635_436# 0.02024f
C53 a_1173_1087# a_1044_1501# 0.01562f
C54 a_1275_1087# a_2272_1318# 0.03061f
C55 DOWN a_2879_1076# 0.3846f
C56 DELAY_IN a_2879_1076# 1.0042f
C57 DELAY_IN a_2682_1076# 0.01309f
C58 DELAY_OUT a_5632_534# 0.01399f
C59 a_5281_391# a_5375_391# 0.28931f
C60 a_3467_1076# DOWN 0.03346f
C61 a_4404_327# a_4533_293# 0.01562f
C62 a_3630_566# a_3431_629# 0.14994f
C63 a_3830_314# a_3373_1076# 0.10976f
C64 VDD a_4116_632# 0.11456f
C65 a_3830_1514# a_4090_1044# 0.75507f
C66 DELAY_IN a_1173_1087# 0.25484f
C67 UP DOWN 0.56441f
C68 a_4533_1087# a_3830_1514# 0.02432f
C69 VDD a_296_1052# 0.2371f
C70 UP DELAY_IN 1.40135f
C71 VDD UP_INV 0.35144f
C72 a_3373_1076# a_4533_293# 0.03463f
C73 a_1275_1087# a_2015_1437# 0.26905f
C74 a_5375_391# a_4116_632# 0.01529f
C75 a_4116_1080# DOWN 0.04178f
C76 a_6212_1076# DOWN 0.0195f
C77 VDD a_4090_1044# 0.09466f
C78 a_470_1514# a_1044_1501# 0.31978f
C79 a_4635_436# a_4116_632# 0.34114f
C80 a_4116_1080# DELAY_IN 0.11539f
C81 a_2015_1437# a_2272_1318# 0.34468f
C82 a_3431_629# VDD 0.07751f
C83 a_4533_1087# VDD 0.23872f
C84 VDD a_1275_1087# 0.20377f
C85 DELAY_OUT UP 0.13024f
C86 a_3373_1076# a_3656_629# 0.06758f
C87 VDD a_2272_1318# 0.16819f
C88 a_4116_1080# a_5281_1437# 0.43239f
C89 UP_INV a_5375_391# 0.04856f
C90 DLL_RESETN a_3656_629# 0.01683f
C91 UP_INV a_4635_436# 0.0176f
C92 VDD a_270_1014# 0.08925f
C93 a_1275_1087# a_756_1080# 0.34102f
C94 a_5375_1437# UP 0.03388f
C95 a_3830_314# a_4533_293# 0.02454f
C96 a_3373_1076# DOWN 0.12815f
C97 a_5632_534# UP_INV 0.01776f
C98 DELAY_IN a_4635_1087# 0.02263f
C99 a_3630_566# VDD 0.09228f
C100 VDD a_4090_537# 0.0947f
C101 VDD a_730_1044# 0.09392f
C102 DELAY_IN a_3373_1076# 0.26308f
C103 DLL_RESETN DOWN 0.01405f
C104 a_5375_1437# a_4116_1080# 0.01529f
C105 a_6212_1076# a_5375_1437# 0.08776f
C106 a_6212_612# DOWN 0.12861f
C107 DLL_RESETN DELAY_IN 1.62072f
C108 a_3830_314# a_3656_629# 0.27179f
C109 VDD a_3180_1073# 0.26066f
C110 VDD DOWN_INV 0.15129f
C111 a_756_1080# a_730_1044# 0.36952f
C112 VDD a_3830_1514# 0.77573f
C113 DELAY_OUT a_3373_1076# 0.01791f
C114 VDD a_2015_1437# 0.16753f
C115 DELAY_OUT a_6212_612# 0.01702f
C116 a_5375_1437# a_4635_1087# 0.26905f
C117 a_5632_1318# a_5375_1437# 0.29858f
C118 DOWN_INV a_5375_391# 0.04511f
C119 a_5375_1437# a_3373_1076# 0.13392f
C120 a_3830_314# DELAY_IN 0.06166f
C121 a_2015_1437# a_756_1080# 0.01529f
C122 a_2272_1318# a_2682_1076# 0.10373f
C123 UP UP_INV 0.33738f
C124 a_4404_327# a_4116_632# 0.43707f
C125 VDD a_756_1080# 0.07206f
C126 UP a_4090_1044# 0.01158f
C127 a_5632_534# DOWN_INV 0.12158f
C128 a_1275_1087# a_1173_1087# 0.47795f
C129 VDD a_5375_391# 0.25563f
C130 a_3569_1424# DOWN 0.01249f
C131 a_4533_1087# UP 0.01604f
C132 a_6212_1076# UP_INV 0.19136f
C133 VDD a_4635_436# 0.33467f
C134 a_4116_1080# a_4090_1044# 0.36952f
C135 a_3431_629# a_3431_395# 0.1117f
C136 a_71_1151# a_71_1381# 0.1117f
C137 a_3180_1073# a_2879_1076# 0.03277f
C138 a_4533_1087# a_4116_1080# 0.37583f
C139 a_3830_1514# a_2879_1076# 0.26489f
C140 a_3373_1076# a_4116_632# 0.38497f
C141 DELAY_IN a_3656_629# 0.02025f
C142 VDD a_5632_534# 0.13493f
C143 DELAY_OUT a_4533_293# 0.25594f
C144 a_730_1044# a_1173_1087# 0.02242f
C145 a_4635_436# a_5375_391# 0.26905f
C146 a_2015_1437# a_2682_1076# 0.0894f
C147 UP_INV a_4635_1087# 0.01811f
C148 a_296_1052# a_470_1514# 0.27179f
C149 a_5632_1318# UP_INV 0.17494f
C150 UP_INV a_3373_1076# 0.0589f
C151 VDD a_2879_1076# 0.37639f
C152 DLL_RESETN a_296_1052# 0.06592f
C153 VDD a_2682_1076# 0.37862f
C154 DELAY_IN DOWN 0.35409f
C155 a_3630_566# a_3431_395# 0.02437f
C156 a_5632_534# a_5375_391# 0.29858f
C157 a_5281_391# a_4533_293# 0.01058f
C158 a_3373_1076# a_4090_1044# 0.27346f
C159 a_4533_1087# a_4635_1087# 0.47795f
C160 UP DOWN_INV 0.26094f
C161 VDD a_3467_1076# 0.29479f
C162 a_5632_534# a_4635_436# 0.03012f
C163 UP a_3830_1514# 0.01008f
C164 a_4533_1087# a_3373_1076# 0.03525f
C165 a_1275_1087# a_470_1514# 0.097f
C166 DLL_RESETN a_3431_629# 0.04228f
C167 a_3830_314# a_4116_632# 0.41329f
C168 DLL_RESETN a_1275_1087# 0.45018f
C169 DELAY_OUT DOWN 0.074f
C170 a_4116_1080# a_3830_1514# 0.41329f
C171 a_4533_1087# a_4404_1501# 0.01562f
C172 VDD a_1173_1087# 0.23431f
C173 DLL_RESETN a_2272_1318# 0.11133f
C174 VDD UP 0.67925f
C175 a_756_1080# a_1173_1087# 0.37583f
C176 a_5375_1437# DOWN 0.01651f
C177 a_4533_293# a_4116_632# 0.3749f
C178 VDD a_3431_395# 0.06323f
C179 a_730_1044# a_470_1514# 0.75507f
C180 a_4090_537# a_3373_1076# 0.26617f
C181 a_71_1151# a_296_1052# 0.02416f
C182 VDD a_4116_1080# 0.07242f
C183 a_6212_1076# VDD 0.30345f
C184 a_3630_566# DLL_RESETN 0.01259f
C185 VDD a_4404_327# 0.02994f
C186 DLL_RESETN a_730_1044# 0.27343f
C187 UP a_5375_391# 0.02915f
C188 a_3830_1514# a_4635_1087# 0.097f
C189 a_3373_1076# a_3180_1073# 0.33075f
C190 a_5375_1437# a_5281_1437# 0.28931f
C191 a_3830_1514# a_3373_1076# 0.12097f
C192 DLL_RESETN a_3180_1073# 0.11782f
C193 a_2682_1076# a_2879_1076# 0.12454f
C194 a_6212_612# DOWN_INV 0.1953f
C195 a_3830_1514# a_4404_1501# 0.31978f
C196 a_5632_534# UP 0.05882f
C197 DLL_RESETN a_2015_1437# 0.14622f
C198 VDD a_4635_1087# 0.21331f
C199 a_71_1151# a_270_1014# 0.14994f
C200 a_4404_327# a_4635_436# 0.12701f
C201 a_5632_1318# VDD 0.1349f
C202 VDD a_470_1514# 0.77198f
C203 VDD a_3373_1076# 2.5684f
C204 a_3830_314# a_4090_537# 0.75507f
C205 a_1275_1087# a_1044_1501# 0.12701f
C206 DELAY_IN a_4116_632# 0.03445f
C207 DLL_RESETN VDD 1.55643f
C208 a_1921_1437# a_2015_1437# 0.28931f
C209 a_3431_629# a_3656_629# 0.02416f
C210 VDD a_6212_612# 0.30345f
C211 UP a_2879_1076# 0.05795f
C212 a_756_1080# a_470_1514# 0.41329f
C213 UP_INV DOWN 0.06562f
C214 DLL_RESETN a_756_1080# 0.39088f
C215 DELAY_IN UP_INV 0.01066f
C216 UP a_3467_1076# 0.09118f
C217 DELAY_OUT a_4116_632# 0.08062f
C218 a_3373_1076# a_5375_391# 0.13376f
C219 a_4090_537# a_4533_293# 0.02242f
C220 a_4635_436# a_3373_1076# 0.42064f
C221 a_1921_1437# a_756_1080# 0.43239f
C222 DELAY_IN a_4090_1044# 0.01538f
C223 a_6212_612# a_5375_391# 0.08776f
C224 a_4533_1087# DELAY_IN 0.25847f
C225 VDD a_3830_314# 0.79678f
C226 a_1275_1087# DELAY_IN 0.01931f
C227 a_3630_566# a_3656_629# 0.1657f
C228 DELAY_OUT UP_INV 0.05562f
C229 a_5632_534# a_3373_1076# 0.10521f
C230 a_2272_1318# DELAY_IN 0.0148f
C231 a_5281_391# a_4116_632# 0.43239f
C232 a_4533_1087# a_5281_1437# 0.01058f
C233 VDD a_71_1151# 0.07668f
R0 VDD.t0 VDD.t8 17.6089
R1 VDD.n0 VDD.t23 17.3693
R2 VDD.n0 VDD.t14 17.3693
R3 VDD.t0 VDD.t2 17.3517
R4 VDD.t0 VDD.t27 17.3517
R5 VDD.t0 VDD.t12 17.3517
R6 VDD.t0 VDD.t24 17.2247
R7 VDD.t0 VDD.t1 17.0005
R8 VDD.t0 VDD.t35 17.0005
R9 VDD.t0 VDD.t33 17.0005
R10 VDD.n1 VDD.t30 8.76054
R11 VDD.n1 VDD.t15 8.76054
R12 VDD.t0 VDD.t5 5.9886
R13 VDD.n1 VDD.t22 5.97675
R14 VDD.n1 VDD.t17 5.97675
R15 VDD.t0 VDD.t39 5.96478
R16 VDD VDD.n0 4.89096
R17 VDD.n0 VDD.t0 1.93927
R18 VDD.n0 VDD.n1 1.53357
R19 VSS.n30 VSS.t3 16686.3
R20 VSS.t70 VSS.t59 865.169
R21 VSS.n25 VSS.t55 853.933
R22 VSS.n28 VSS.t0 853.933
R23 VSS.n33 VSS.t70 797.754
R24 VSS.n18 VSS.t13 97.9194
R25 VSS.n21 VSS.t27 22.6691
R26 VSS.t44 VSS.n0 42.051
R27 VSS.t3 VSS.t17 90.4096
R28 VSS.t3 VSS.t23 90.4096
R29 VSS.t6 VSS.n18 161.648
R30 VSS.t6 VSS.n4 577.799
R31 VSS.n7 VSS.t3 10.3046
R32 VSS.t15 VSS.t52 21.0382
R33 VSS.n5 VSS.n22 299.099
R34 VSS.n26 VSS.n13 299.099
R35 VSS.t3 VSS.n27 499.642
R36 VSS.t40 VSS.n6 74.5356
R37 VSS.t15 VSS.t39 69.6456
R38 VSS.t15 VSS.n6 0.846453
R39 VSS.n25 VSS.n24 444.89
R40 VSS.n29 VSS.n28 444.89
R41 VSS.t29 VSS.n8 179.382
R42 VSS.n34 VSS.t47 392.57
R43 VSS.t68 VSS.t25 372.747
R44 VSS.t22 VSS.n16 379.442
R45 VSS.t61 VSS.t12 372.747
R46 VSS.t16 VSS.n20 379.442
R47 VSS.t14 VSS.t15 125.523
R48 VSS.n16 VSS.t3 9.83317
R49 VSS.t3 VSS.n20 9.83317
R50 VSS.n33 VSS.n32 345.257
R51 VSS.t71 VSS.t51 328.043
R52 VSS.n15 VSS.t41 334.264
R53 VSS.n7 VSS.t67 369.041
R54 VSS.n15 VSS.t54 127.894
R55 VSS.t73 VSS.t43 289.269
R56 VSS.t38 VSS.n17 295.863
R57 VSS.n8 VSS.t37 171.293
R58 VSS.n17 VSS.t15 9.80849
R59 VSS.t15 VSS.n34 255.849
R60 VSS.t50 VSS.t31 242.327
R61 VSS.n16 VSS.t35 139.087
R62 VSS.t9 VSS.n20 139.087
R63 VSS.t2 VSS.t11 237.481
R64 VSS.n26 VSS.n4 230.51
R65 VSS.n23 VSS.t22 220.464
R66 VSS.n1 VSS.t16 220.464
R67 VSS.n22 VSS.n21 230.349
R68 VSS.t41 VSS.n30 212.328
R69 VSS.t26 VSS.t36 202.096
R70 VSS.t5 VSS.t10 202.096
R71 VSS.n17 VSS.t33 107.668
R72 VSS.n7 VSS.t21 136.548
R73 VSS.n31 VSS.t38 174.433
R74 VSS.t25 VSS.n23 166.356
R75 VSS.t12 VSS.n1 166.356
R76 VSS.t36 VSS.t24 143.714
R77 VSS.t10 VSS.t18 143.714
R78 VSS.t43 VSS.n31 132.442
R79 VSS.n34 VSS.n33 112.361
R80 VSS.n19 VSS.t71 124.57
R81 VSS.n5 VSS.t49 164.31
R82 VSS.n13 VSS.t48 164.31
R83 VSS.t63 VSS.n27 101.124
R84 VSS.t4 VSS.t2 96.931
R85 VSS.n19 VSS.t57 75.8499
R86 VSS.t47 VSS.t50 92.0845
R87 VSS.t45 VSS.n0 78.548
R88 VSS.n24 VSS.t68 54.1087
R89 VSS.n29 VSS.t61 54.1087
R90 VSS.n27 VSS.t4 43.6192
R91 VSS.n32 VSS.t73 41.9912
R92 VSS.n22 VSS.t26 40.4197
R93 VSS.n26 VSS.t5 40.4197
R94 VSS.t34 VSS.n6 29.5487
R95 VSS.t19 VSS.t3 29.6918
R96 VSS.n21 VSS.t3 0.549965
R97 VSS.t3 VSS.t65 23.217
R98 VSS.n3 VSS.t20 17.267
R99 VSS.n9 VSS.t69 17.2395
R100 VSS.n14 VSS.t62 17.2395
R101 VSS VSS.t74 17.2395
R102 VSS.t3 VSS.t28 17.2297
R103 VSS.n12 VSS.t53 17.2297
R104 VSS.n9 VSS.t32 17.212
R105 VSS.n3 VSS.t8 17.212
R106 VSS.n12 VSS.t58 17.212
R107 VSS.n9 VSS.t56 17.2042
R108 VSS.n14 VSS.t1 17.2398
R109 VSS VSS.t60 17.2042
R110 VSS.t3 VSS.n29 17.0005
R111 VSS.t3 VSS.n13 3.1686
R112 VSS.t3 VSS.n18 2.74829
R113 VSS.n24 VSS.t3 17.0005
R114 VSS.t3 VSS.n8 3.6175
R115 VSS.n15 VSS.t15 9.49153
R116 VSS.n19 VSS.t15 3.00967
R117 VSS.n32 VSS.t15 17.0005
R118 VSS.t67 VSS.n25 11.2365
R119 VSS.n28 VSS.t63 11.2365
R120 VSS.t3 VSS.t30 9.08858
R121 VSS.n12 VSS.t42 8.87472
R122 VSS.n10 VSS.t46 8.80285
R123 VSS.n3 VSS.t66 8.75631
R124 VSS.n3 VSS.t7 8.74785
R125 VSS.n5 VSS.t3 3.1686
R126 VSS.n14 VSS.n2 0.512265
R127 VSS.n11 VSS.n10 0.525713
R128 VSS.n9 VSS 5.13648
R129 VSS.t3 VSS.n9 0.689047
R130 VSS.t3 VSS.n11 1.08677
R131 VSS.n12 VSS.t15 0.916632
R132 VSS.n31 VSS.t15 0.600709
R133 VSS.t51 VSS.t15 85.2351
R134 VSS.n23 VSS.t3 0.473876
R135 VSS.t3 VSS.n0 0.921585
R136 VSS.t3 VSS.n1 1.43322
R137 VSS.n30 VSS.t15 1.40105
R138 VSS.n2 VSS.t3 1.19424
R139 VSS.n11 VSS.n3 1.10706
R140 VSS.t3 VSS.n4 1.10394
R141 VSS VSS.t15 0.571389
R142 VSS.n3 VSS.n2 1.07266
R143 VSS.n9 VSS.n10 1.02138
C234 DOWN_INV VSS 0.17401f
C235 DELAY_OUT VSS 0.38023f
C236 UP_INV VSS 0.36891f
C237 UP VSS 0.74384f
C238 DOWN VSS 1.48041f
C239 DELAY_IN VSS 0.69997f
C240 DLL_RESETN VSS 1.36665f
C241 VDD VSS 1.74409f
C242 a_5281_391# VSS 0.09495f ; **FLOATING
C243 a_4404_327# VSS 0.06985f ; **FLOATING
C244 a_6212_612# VSS 0.26771f ; **FLOATING
C245 a_5632_534# VSS 0.24716f ; **FLOATING
C246 a_5375_391# VSS 0.39443f ; **FLOATING
C247 a_4635_436# VSS 0.20246f ; **FLOATING
C248 a_4533_293# VSS 0.47328f ; **FLOATING
C249 a_4116_632# VSS 1.57614f ; **FLOATING
C250 a_3830_314# VSS 0.30118f ; **FLOATING
C251 a_4090_537# VSS 0.15441f ; **FLOATING
C252 a_3656_629# VSS 0.13029f ; **FLOATING
C253 a_3431_629# VSS 0.14345f ; **FLOATING
C254 a_3431_395# VSS 0.14751f ; **FLOATING
C255 a_3630_566# VSS 0.06318f ; **FLOATING
C256 a_5281_1437# VSS 0.09586f ; **FLOATING
C257 a_6212_1076# VSS 0.26777f ; **FLOATING
C258 a_5375_1437# VSS 0.39588f ; **FLOATING
C259 a_5632_1318# VSS 0.24582f ; **FLOATING
C260 a_4635_1087# VSS 0.21915f ; **FLOATING
C261 a_4404_1501# VSS 0.07345f ; **FLOATING
C262 a_4533_1087# VSS 0.48187f ; **FLOATING
C263 a_4116_1080# VSS 1.58208f ; **FLOATING
C264 a_4090_1044# VSS 0.15442f ; **FLOATING
C265 a_3569_1424# VSS 0.01124f ; **FLOATING
C266 a_3830_1514# VSS 0.31701f ; **FLOATING
C267 a_3373_1076# VSS 1.48165f ; **FLOATING
C268 a_3180_1073# VSS 0.28391f ; **FLOATING
C269 a_2879_1076# VSS 0.6229f ; **FLOATING
C270 a_1921_1437# VSS 0.09495f ; **FLOATING
C271 a_2682_1076# VSS 0.2589f ; **FLOATING
C272 a_2015_1437# VSS 0.3013f ; **FLOATING
C273 a_2272_1318# VSS 0.17078f ; **FLOATING
C274 a_1275_1087# VSS 0.20089f ; **FLOATING
C275 a_1044_1501# VSS 0.03671f ; **FLOATING
C276 a_1173_1087# VSS 0.47618f ; **FLOATING
C277 a_756_1080# VSS 1.52123f ; **FLOATING
C278 a_730_1044# VSS 0.08582f ; **FLOATING
C279 a_470_1514# VSS 0.18138f ; **FLOATING
C280 a_296_1052# VSS 0.13365f ; **FLOATING
C281 a_270_1014# VSS 0.06894f ; **FLOATING
C282 a_71_1381# VSS 0.15f ; **FLOATING
C283 a_71_1151# VSS 0.14459f ; **FLOATING
C284 VDD.t0 VSS 12.677f ; **FLOATING
C285 VDD.n0 VSS 0.38006f ; **FLOATING
C286 VDD.n1 VSS 0.34206f ; **FLOATING
C287 VDD.t8 VSS 0.03422f ; **FLOATING
C288 VDD.t5 VSS 0.04444f ; **FLOATING
C289 VDD.t39 VSS 0.03966f ; **FLOATING
C290 VDD.t24 VSS 0.04295f ; **FLOATING
C291 VDD.t15 VSS 0.05374f ; **FLOATING
C292 VDD.t30 VSS 0.05374f ; **FLOATING
C293 VDD.t17 VSS 0.04444f ; **FLOATING
C294 VDD.t22 VSS 0.04444f ; **FLOATING
C295 VDD.t2 VSS 0.01466f ; **FLOATING
C296 VDD.t1 VSS 0.07291f ; **FLOATING
C297 VDD.t14 VSS 0.0316f ; **FLOATING
C298 VDD.t23 VSS 0.0316f ; **FLOATING
C299 VDD.t12 VSS 0.01466f ; **FLOATING
C300 VDD.t33 VSS 0.07291f ; **FLOATING
C301 VDD.t27 VSS 0.01466f ; **FLOATING
C302 VDD.t35 VSS 0.07291f ; **FLOATING
.ends
