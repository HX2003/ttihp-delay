* NGSPICE file created from hx_mux.ext - technology: ihp-sg13g2

.subckt hx_mux VSS VDD DELAY_OUT_TAP0 DELAY_OUT_TAP1 DELAY_OUT_TAP2 DELAY_OUT_TAP3
+ DELAY_OUT_TAP4 DELAY_OUT_TAP5 DELAY_OUT_TAP6 DELAY_OUT_TAP7 DELAY_OUT_TAP8 DELAY_OUT_TAP9
+ DELAY_OUT_TAP10 DELAY_OUT_TAP11 DELAY_OUT_TAP12 DELAY_OUT_TAP13 DELAY_OUT_TAP14
+ DELAY_OUT_TAP15 DELAY_OUT_TAP16 DELAY_OUT_TAP17 DELAY_OUT_TAP18 DELAY_OUT_TAP19
+ DELAY_OUT_TAP20 DELAY_OUT_TAP21 DELAY_OUT_TAP22 DELAY_OUT_TAP23 DELAY_OUT_TAP24
+ DELAY_OUT_TAP25 DELAY_OUT_TAP26 DELAY_OUT_TAP27 DELAY_OUT_TAP28 DELAY_OUT_TAP29
+ DELAY_OUT_TAP30 DELAY_OUT_TAP31 MUX_SEL0 MUX_SEL1 MUX_OUT MUX_SEL4 MUX_SEL2 MUX_SEL3
X0 VDD a_2019_952.t9 a_4324_913# VDD sg13_lv_pmos ad=0.3808p pd=2.92u as=0.3808p ps=2.92u w=1.12u l=0.13u
X1 a_1256_194# MUX_SEL2 VDD VDD sg13_lv_pmos ad=0.3808p pd=2.92u as=0.3808p ps=2.92u w=1.12u l=0.13u
X2 VDD a_3171_952.t8 a_8884_913# VDD sg13_lv_pmos ad=0.3808p pd=2.92u as=0.3808p ps=2.92u w=1.12u l=0.13u
X3 a_16108_194# a_15765_368# a_15964_194# VDD sg13_lv_pmos ad=0.3808p pd=2.92u as=0.3304p ps=1.71u w=1.12u l=0.13u
X4 a_22590_949# a_24951_913# a_24875_949# VDD sg13_lv_pmos ad=0.3808p pd=2.92u as=0.2128p ps=1.5u w=1.12u l=0.13u
X5 VDD a_2595_952.t7 a_11271_913# VDD sg13_lv_pmos ad=0.3808p pd=2.92u as=0.3808p ps=2.92u w=1.12u l=0.13u
X6 VSS.t199 VDD VSS.t197 VSS.t198 sg13_lv_nmos ad=79.8f pd=0.8u as=0 ps=0 w=0.42u l=1u
X7 a_7390_949# a_2595_952.t8 a_8155_949# VSS.t26 sg13_lv_nmos ad=0.2516p pd=2.16u as=0.1406p ps=1.12u w=0.74u l=0.13u
X8 VSS.t202 VDD VSS.t201 VSS.t200 sg13_lv_nmos ad=0.1428p pd=1.52u as=0 ps=0 w=0.42u l=1u
X9 VDD VSS.t381 VDD VDD sg13_lv_pmos ad=0.19p pd=1.38u as=0.14315n ps=0.71478m w=1u l=1u
X10 VSS.t154 DELAY_OUT_TAP11 a_12505_949# VSS.t185 sg13_lv_nmos ad=0.1665p pd=1.19u as=0.2516p ps=2.16u w=0.74u l=0.13u
X11 MUX_OUT a_16851_214# VSS.t157 VSS.t156 sg13_lv_nmos ad=0.1406p pd=1.12u as=0.1371p ps=1.12u w=0.74u l=0.13u
X12 VDD a_3747_952.t9 a_6711_913# VDD sg13_lv_pmos ad=0.3808p pd=2.92u as=0.3808p ps=2.92u w=1.12u l=0.13u
X13 VSS.t267 VDD VSS.t266 VSS.t265 sg13_lv_nmos ad=0.1428p pd=1.52u as=0 ps=0 w=0.42u l=1u
X14 a_1544_194# MUX_SEL3 VDD VDD sg13_lv_pmos ad=0.3808p pd=2.92u as=0.3808p ps=2.92u w=1.12u l=0.13u
X15 VSS.t181 a_2595_216.t3 a_8745_424# VSS.t180 sg13_lv_nmos ad=0.2516p pd=2.16u as=0.2516p ps=2.16u w=0.74u l=0.13u
X16 a_10328_949# DELAY_OUT_TAP8 VSS.t294 VSS.t293 sg13_lv_nmos ad=0.1406p pd=1.12u as=0.2516p ps=2.16u w=0.74u l=0.13u
X17 a_22590_949# a_2019_952.t3 a_22488_949# VSS.t121 sg13_lv_nmos ad=0.2516p pd=2.16u as=0.1406p ps=1.12u w=0.74u l=0.13u
X18 a_8808_949# DELAY_OUT_TAP6 VSS.t298 VSS.t297 sg13_lv_nmos ad=0.1406p pd=1.12u as=0.2516p ps=2.16u w=0.74u l=0.13u
X19 VSS.t47 DELAY_OUT_TAP31 a_27705_949# VSS.t46 sg13_lv_nmos ad=0.1665p pd=1.19u as=0.2516p ps=2.16u w=0.74u l=0.13u
X20 a_11848_949# DELAY_OUT_TAP10 VDD VDD sg13_lv_pmos ad=0.2128p pd=1.5u as=0.3808p ps=2.92u w=1.12u l=0.13u
X21 VDD a_3171_952.t3 a_24084_913# VDD sg13_lv_pmos ad=0.3808p pd=2.92u as=0.3808p ps=2.92u w=1.12u l=0.13u
X22 a_1721_236# a_1256_194# VDD VDD sg13_lv_pmos ad=0.1596p pd=1.22u as=0.2856p ps=2.36u w=0.84u l=0.13u
X23 a_6635_949# a_6425_949# VSS.t134 VSS.t133 sg13_lv_nmos ad=0.1406p pd=1.12u as=0.1665p ps=1.19u w=0.74u l=0.13u
X24 VDD VSS.t374 VDD VDD sg13_lv_pmos ad=0.34p pd=2.68u as=0 ps=0 w=1u l=1u
X25 VSS.t68 a_2595_952.t9 a_5191_913# VSS.t67 sg13_lv_nmos ad=0.2516p pd=2.16u as=0.2516p ps=2.16u w=0.74u l=0.13u
X26 VSS.t286 a_1256_949# a_2967_1300# VSS.t285 sg13_lv_nmos ad=0.1331p pd=1.12u as=0.1216p ps=1.02u w=0.64u l=0.13u
X27 a_4157_1218# DELAY_OUT_TAP0 VDD VDD sg13_lv_pmos ad=0.3808p pd=2.92u as=0.3808p ps=2.92u w=1.12u l=0.13u
X28 a_25528_949# DELAY_OUT_TAP28 VSS.t309 VSS.t308 sg13_lv_nmos ad=0.1406p pd=1.12u as=0.2516p ps=2.16u w=0.74u l=0.13u
X29 a_20315_949# a_20105_949# VSS.t140 VSS.t139 sg13_lv_nmos ad=0.1406p pd=1.12u as=0.1665p ps=1.19u w=0.74u l=0.13u
X30 a_5731_194# a_3747_216.t3 a_13470_949# VSS.t130 sg13_lv_nmos ad=0.2516p pd=2.16u as=0.2516p ps=2.16u w=0.74u l=0.13u
X31 VSS.t259 VDD VSS.t257 VSS.t258 sg13_lv_nmos ad=79.8f pd=0.8u as=0 ps=0 w=0.42u l=1u
X32 VSS.t224 VDD VSS.t222 VSS.t223 sg13_lv_nmos ad=79.8f pd=0.8u as=0 ps=0 w=0.42u l=1u
X33 VSS.t159 a_16851_214# MUX_OUT VSS.t158 sg13_lv_nmos ad=0.2516p pd=2.16u as=0.1406p ps=1.12u w=0.74u l=0.13u
X34 VDD a_1544_194# a_1721_236# VDD sg13_lv_pmos ad=0.1918p pd=1.5u as=0.1596p ps=1.22u w=0.84u l=0.13u
X35 VDD a_3747_952.t3 a_24951_913# VDD sg13_lv_pmos ad=0.3808p pd=2.92u as=0.3808p ps=2.92u w=1.12u l=0.13u
X36 VDD VSS.t386 VDD VDD sg13_lv_pmos ad=0.34p pd=2.68u as=0 ps=0 w=1u l=1u
X37 a_16408_949# DELAY_OUT_TAP16 VSS.t348 VSS.t347 sg13_lv_nmos ad=0.1406p pd=1.12u as=0.2516p ps=2.16u w=0.74u l=0.13u
X38 a_5731_194# a_2019_216# a_4350_949# VSS.t91 sg13_lv_nmos ad=0.2516p pd=2.16u as=0.2516p ps=2.16u w=0.74u l=0.13u
X39 VDD a_2595_952.t2 a_26471_913# VDD sg13_lv_pmos ad=0.3808p pd=2.92u as=0.3808p ps=2.92u w=1.12u l=0.13u
X40 a_7390_949# a_3747_952.t8 a_9675_949# VSS.t31 sg13_lv_nmos ad=0.2516p pd=2.16u as=0.1406p ps=1.12u w=0.74u l=0.13u
X41 VSS.t197 VDD VSS.t196 VSS.t195 sg13_lv_nmos ad=0.1428p pd=1.52u as=0 ps=0 w=0.42u l=1u
X42 VDD VSS.t357 VDD VDD sg13_lv_pmos ad=0.19p pd=1.38u as=0 ps=0 w=1u l=1u
X43 VDD DELAY_OUT_TAP13 a_14025_949# VDD sg13_lv_pmos ad=0.252p pd=1.57u as=0.3808p ps=2.92u w=1.12u l=0.13u
X44 a_10430_949# a_11924_913# a_11848_949# VDD sg13_lv_pmos ad=0.3808p pd=2.92u as=0.2128p ps=1.5u w=1.12u l=0.13u
X45 VDD a_2595_216.t3 a_8745_424# VDD sg13_lv_pmos ad=0.3808p pd=2.92u as=0.3808p ps=2.92u w=1.12u l=0.13u
X46 VSS.t45 a_3171_952.t5 a_18004_913# VSS.t44 sg13_lv_nmos ad=0.2516p pd=2.16u as=0.2516p ps=2.16u w=0.74u l=0.13u
X47 VDD DELAY_OUT_TAP15 a_15545_949# VDD sg13_lv_pmos ad=0.252p pd=1.57u as=0.3808p ps=2.92u w=1.12u l=0.13u
X48 a_3171_216.t1 a_2873_236# VDD VDD sg13_lv_pmos ad=0.2128p pd=1.5u as=0.1918p ps=1.5u w=1.12u l=0.13u
X49 a_14235_949# a_14025_949# VSS.t87 VSS.t86 sg13_lv_nmos ad=0.1406p pd=1.12u as=0.1665p ps=1.19u w=0.74u l=0.13u
X50 VSS.t42 a_3747_952.t7 a_12791_913# VSS.t41 sg13_lv_nmos ad=0.2516p pd=2.16u as=0.2516p ps=2.16u w=0.74u l=0.13u
X51 a_3747_216.t1 a_3449_236# VDD VDD sg13_lv_pmos ad=0.2128p pd=1.5u as=0.1918p ps=1.5u w=1.12u l=0.13u
X52 a_12715_949# a_12505_949# VDD VDD sg13_lv_pmos ad=0.2128p pd=1.5u as=0.252p ps=1.57u w=1.12u l=0.13u
X53 a_11848_949# DELAY_OUT_TAP10 VSS.t184 VSS.t183 sg13_lv_nmos ad=0.1406p pd=1.12u as=0.2516p ps=2.16u w=0.74u l=0.13u
X54 a_17275_949# a_17065_949# VDD VDD sg13_lv_pmos ad=0.2128p pd=1.5u as=0.252p ps=1.57u w=1.12u l=0.13u
X55 VDD VSS.t389 VDD VDD sg13_lv_pmos ad=0.19p pd=1.38u as=0 ps=0 w=1u l=1u
X56 VDD VSS.t388 VDD VDD sg13_lv_pmos ad=0.34p pd=2.68u as=0 ps=0 w=1u l=1u
X57 a_10430_949# a_12791_913# a_12715_949# VDD sg13_lv_pmos ad=0.3808p pd=2.92u as=0.2128p ps=1.5u w=1.12u l=0.13u
X58 VSS.t140 DELAY_OUT_TAP21 a_20105_949# VSS.t355 sg13_lv_nmos ad=0.1665p pd=1.19u as=0.2516p ps=2.16u w=0.74u l=0.13u
X59 a_16510_949# a_17351_913# a_17275_949# VDD sg13_lv_pmos ad=0.3808p pd=2.92u as=0.2128p ps=1.5u w=1.12u l=0.13u
X60 VSS.t189 a_1721_1300# a_2019_952.t0 VSS.t188 sg13_lv_nmos ad=0.2812p pd=2.24u as=0.1406p ps=1.12u w=0.74u l=0.13u
X61 a_5731_194# a_14825_424# a_13470_949# VDD sg13_lv_pmos ad=0.3808p pd=2.92u as=0.3808p ps=2.92u w=1.12u l=0.13u
X62 a_16510_949# a_2595_952.t5 a_17275_949# VSS.t335 sg13_lv_nmos ad=0.2516p pd=2.16u as=0.1406p ps=1.12u w=0.74u l=0.13u
X63 a_8155_949# a_7945_949# VDD VDD sg13_lv_pmos ad=0.2128p pd=1.5u as=0.252p ps=1.57u w=1.12u l=0.13u
X64 VDD VSS.t362 VDD VDD sg13_lv_pmos ad=0.34p pd=2.68u as=0 ps=0 w=1u l=1u
X65 VSS.t129 a_3747_952.t2 a_27991_913# VSS.t128 sg13_lv_nmos ad=0.2516p pd=2.16u as=0.2516p ps=2.16u w=0.74u l=0.13u
X66 VSS.t59 a_3747_952.t9 a_6711_913# VSS.t58 sg13_lv_nmos ad=0.2516p pd=2.16u as=0.2516p ps=2.16u w=0.74u l=0.13u
X67 a_16108_194# a_2595_216.t2 a_19550_949# VSS.t48 sg13_lv_nmos ad=0.2516p pd=2.16u as=0.2516p ps=2.16u w=0.74u l=0.13u
X68 VSS.t257 VDD VSS.t256 VSS.t255 sg13_lv_nmos ad=0.1428p pd=1.52u as=0 ps=0 w=0.42u l=1u
X69 a_7390_949# a_8231_913# a_8155_949# VDD sg13_lv_pmos ad=0.3808p pd=2.92u as=0.2128p ps=1.5u w=1.12u l=0.13u
X70 VSS.t222 VDD VSS.t221 VSS.t220 sg13_lv_nmos ad=0.1428p pd=1.52u as=0 ps=0 w=0.42u l=1u
X71 a_3171_216.t0 a_2873_236# VSS.t85 VSS.t332 sg13_lv_nmos ad=0.1406p pd=1.12u as=0.1331p ps=1.12u w=0.74u l=0.13u
X72 a_5731_194# a_5705_424# a_4350_949# VDD sg13_lv_pmos ad=0.3808p pd=2.92u as=0.3808p ps=2.92u w=1.12u l=0.13u
X73 VDD a_2873_236# a_3171_216.t1 VDD sg13_lv_pmos ad=0.4256p pd=3u as=0.2128p ps=1.5u w=1.12u l=0.13u
X74 a_3747_216.t0 a_3449_236# VSS.t6 VSS.t97 sg13_lv_nmos ad=0.1406p pd=1.12u as=0.1331p ps=1.12u w=0.74u l=0.13u
X75 VDD a_3449_236# a_3747_216.t1 VDD sg13_lv_pmos ad=0.4256p pd=3u as=0.2128p ps=1.5u w=1.12u l=0.13u
X76 a_7390_949# a_2019_952.t8 a_7288_949# VSS.t118 sg13_lv_nmos ad=0.2516p pd=2.16u as=0.1406p ps=1.12u w=0.74u l=0.13u
X77 VDD DELAY_OUT_TAP21 a_20105_949# VDD sg13_lv_pmos ad=0.252p pd=1.57u as=0.3808p ps=2.92u w=1.12u l=0.13u
X78 a_19550_949# a_21044_913# a_20968_949# VDD sg13_lv_pmos ad=0.3808p pd=2.92u as=0.2128p ps=1.5u w=1.12u l=0.13u
X79 VDD VSS.t365 VDD VDD sg13_lv_pmos ad=0.19p pd=1.38u as=0 ps=0 w=1u l=1u
X80 VDD VSS.t379 VDD VDD sg13_lv_pmos ad=0.19p pd=1.38u as=0 ps=0 w=1u l=1u
X81 VDD a_3171_952.t7 a_11924_913# VDD sg13_lv_pmos ad=0.3808p pd=2.92u as=0.3808p ps=2.92u w=1.12u l=0.13u
X82 VSS.t77 a_2019_952.t4 a_19524_913# VSS.t76 sg13_lv_nmos ad=0.2516p pd=2.16u as=0.2516p ps=2.16u w=0.74u l=0.13u
X83 a_15755_949# a_15545_949# VSS.t142 VSS.t141 sg13_lv_nmos ad=0.1406p pd=1.12u as=0.1665p ps=1.19u w=0.74u l=0.13u
X84 VSS.t340 a_2595_952.t6 a_14311_913# VSS.t339 sg13_lv_nmos ad=0.2516p pd=2.16u as=0.2516p ps=2.16u w=0.74u l=0.13u
X85 a_5115_949# a_4905_949# VSS.t145 VSS.t144 sg13_lv_nmos ad=0.1406p pd=1.12u as=0.1665p ps=1.19u w=0.74u l=0.13u
X86 a_27915_949# a_27705_949# VDD VDD sg13_lv_pmos ad=0.2128p pd=1.5u as=0.252p ps=1.57u w=1.12u l=0.13u
X87 VSS.t214 VDD VSS.t212 VSS.t213 sg13_lv_nmos ad=79.8f pd=0.8u as=0 ps=0 w=0.42u l=1u
X88 a_23355_949# a_23145_949# VDD VDD sg13_lv_pmos ad=0.2128p pd=1.5u as=0.252p ps=1.57u w=1.12u l=0.13u
X89 VDD a_2019_952.t8 a_7364_913# VDD sg13_lv_pmos ad=0.3808p pd=2.92u as=0.3808p ps=2.92u w=1.12u l=0.13u
X90 VSS.t334 a_2873_236# a_3171_216.t0 VSS.t333 sg13_lv_nmos ad=0.2812p pd=2.24u as=0.1406p ps=1.12u w=0.74u l=0.13u
X91 VDD VSS.t390 VDD VDD sg13_lv_pmos ad=0.34p pd=2.68u as=0 ps=0 w=1u l=1u
X92 a_25630_949# a_27991_913# a_27915_949# VDD sg13_lv_pmos ad=0.3808p pd=2.92u as=0.2128p ps=1.5u w=1.12u l=0.13u
X93 VSS.t99 a_3449_236# a_3747_216.t0 VSS.t98 sg13_lv_nmos ad=0.2812p pd=2.24u as=0.1406p ps=1.12u w=0.74u l=0.13u
X94 VSS.t30 DELAY_OUT_TAP23 a_21625_949# VSS.t29 sg13_lv_nmos ad=0.1665p pd=1.19u as=0.2516p ps=2.16u w=0.74u l=0.13u
X95 a_22590_949# a_23431_913# a_23355_949# VDD sg13_lv_pmos ad=0.3808p pd=2.92u as=0.2128p ps=1.5u w=1.12u l=0.13u
X96 a_16108_194# a_20905_424# a_19550_949# VDD sg13_lv_pmos ad=0.3808p pd=2.92u as=0.3808p ps=2.92u w=1.12u l=0.13u
X97 VDD a_2595_952.t6 a_14311_913# VDD sg13_lv_pmos ad=0.3808p pd=2.92u as=0.3808p ps=2.92u w=1.12u l=0.13u
X98 VSS.t71 a_2019_952.t9 a_4324_913# VSS.t70 sg13_lv_nmos ad=0.2516p pd=2.16u as=0.2516p ps=2.16u w=0.74u l=0.13u
X99 a_16510_949# a_3747_952.t5 a_18795_949# VSS.t317 sg13_lv_nmos ad=0.2516p pd=2.16u as=0.1406p ps=1.12u w=0.74u l=0.13u
X100 VDD a_3747_952.t5 a_18871_913# VDD sg13_lv_pmos ad=0.3808p pd=2.92u as=0.3808p ps=2.92u w=1.12u l=0.13u
X101 VSS.t82 a_3171_216.t3 a_11785_424# VSS.t81 sg13_lv_nmos ad=0.2516p pd=2.16u as=0.2516p ps=2.16u w=0.74u l=0.13u
X102 VDD a_3747_952.t8 a_9751_913# VDD sg13_lv_pmos ad=0.3808p pd=2.92u as=0.3808p ps=2.92u w=1.12u l=0.13u
X103 VDD a_2595_952.t9 a_5191_913# VDD sg13_lv_pmos ad=0.3808p pd=2.92u as=0.3808p ps=2.92u w=1.12u l=0.13u
X104 a_10430_949# a_2019_952.t7 a_10328_949# VSS.t20 sg13_lv_nmos ad=0.2516p pd=2.16u as=0.1406p ps=1.12u w=0.74u l=0.13u
X105 a_4157_1218# DELAY_OUT_TAP0 VSS.t24 VSS.t23 sg13_lv_nmos ad=0.2516p pd=2.16u as=0.2553p ps=2.17u w=0.74u l=0.13u
X106 a_7390_949# a_3171_952.t8 a_8808_949# VSS.t124 sg13_lv_nmos ad=0.2516p pd=2.16u as=0.1406p ps=1.12u w=0.74u l=0.13u
X107 VSS.t142 DELAY_OUT_TAP15 a_15545_949# VSS.t299 sg13_lv_nmos ad=0.1665p pd=1.19u as=0.2516p ps=2.16u w=0.74u l=0.13u
X108 VDD a_2019_952.t3 a_22564_913# VDD sg13_lv_pmos ad=0.3808p pd=2.92u as=0.3808p ps=2.92u w=1.12u l=0.13u
X109 a_14888_949# DELAY_OUT_TAP14 VDD VDD sg13_lv_pmos ad=0.2128p pd=1.5u as=0.3808p ps=2.92u w=1.12u l=0.13u
X110 VSS.t102 a_3171_952.t7 a_11924_913# VSS.t101 sg13_lv_nmos ad=0.2516p pd=2.16u as=0.2516p ps=2.16u w=0.74u l=0.13u
X111 VDD VSS.t366 VDD VDD sg13_lv_pmos ad=0.34p pd=2.68u as=0 ps=0 w=1u l=1u
X112 VDD a_3171_952.t2 a_27124_913# VDD sg13_lv_pmos ad=0.3808p pd=2.92u as=0.3808p ps=2.92u w=1.12u l=0.13u
X113 a_10328_949# DELAY_OUT_TAP8 VDD VDD sg13_lv_pmos ad=0.2128p pd=1.5u as=0.3808p ps=2.92u w=1.12u l=0.13u
X114 a_19448_949# DELAY_OUT_TAP20 VDD VDD sg13_lv_pmos ad=0.2128p pd=1.5u as=0.3808p ps=2.92u w=1.12u l=0.13u
X115 VDD VSS.t380 VDD VDD sg13_lv_pmos ad=0.34p pd=2.68u as=0 ps=0 w=1u l=1u
X116 a_3171_952.t0 a_2873_1300# VSS.t286 VSS.t300 sg13_lv_nmos ad=0.1406p pd=1.12u as=0.1331p ps=1.12u w=0.74u l=0.13u
X117 a_25630_949# a_2019_952.t2 a_25528_949# VSS.t37 sg13_lv_nmos ad=0.2516p pd=2.16u as=0.1406p ps=1.12u w=0.74u l=0.13u
X118 VSS.t351 a_2297_1300# a_2595_952.t0 VSS.t350 sg13_lv_nmos ad=0.2812p pd=2.24u as=0.1406p ps=1.12u w=0.74u l=0.13u
X119 a_16108_194# a_2019_216# a_16510_949# VSS.t94 sg13_lv_nmos ad=0.2516p pd=2.16u as=0.2516p ps=2.16u w=0.74u l=0.13u
X120 a_2391_1300# MUX_SEL0 a_2297_1300# VSS.t170 sg13_lv_nmos ad=0.1216p pd=1.02u as=0.2176p ps=1.96u w=0.64u l=0.13u
X121 VSS.t274 VDD VSS.t272 VSS.t273 sg13_lv_nmos ad=79.8f pd=0.8u as=0 ps=0 w=0.42u l=1u
X122 VSS.t187 a_1544_949# a_1815_1300# VSS.t280 sg13_lv_nmos ad=0.1331p pd=1.12u as=0.1216p ps=1.02u w=0.64u l=0.13u
X123 a_5768_949# DELAY_OUT_TAP2 VDD VDD sg13_lv_pmos ad=0.2128p pd=1.5u as=0.3808p ps=2.92u w=1.12u l=0.13u
X124 VSS.t277 VDD VSS.t276 VSS.t275 sg13_lv_nmos ad=0.1428p pd=1.52u as=0 ps=0 w=0.42u l=1u
X125 a_16510_949# a_2019_952.t5 a_16408_949# VSS.t344 sg13_lv_nmos ad=0.2516p pd=2.16u as=0.1406p ps=1.12u w=0.74u l=0.13u
X126 VDD a_2595_952.t4 a_20391_913# VDD sg13_lv_pmos ad=0.3808p pd=2.92u as=0.3808p ps=2.92u w=1.12u l=0.13u
X127 VSS.t322 a_3171_952.t2 a_27124_913# VSS.t321 sg13_lv_nmos ad=0.2516p pd=2.16u as=0.2516p ps=2.16u w=0.74u l=0.13u
X128 a_5731_194# a_2595_216.t3 a_7390_949# VSS.t179 sg13_lv_nmos ad=0.2516p pd=2.16u as=0.2516p ps=2.16u w=0.74u l=0.13u
X129 VDD a_3171_216.t3 a_11785_424# VDD sg13_lv_pmos ad=0.3808p pd=2.92u as=0.3808p ps=2.92u w=1.12u l=0.13u
X130 a_10430_949# a_2595_952.t7 a_11195_949# VSS.t112 sg13_lv_nmos ad=0.2516p pd=2.16u as=0.1406p ps=1.12u w=0.74u l=0.13u
X131 a_23355_949# a_23145_949# VSS.t73 VSS.t74 sg13_lv_nmos ad=0.1406p pd=1.12u as=0.1665p ps=1.19u w=0.74u l=0.13u
X132 VSS.t194 VDD VSS.t191 VSS.t193 sg13_lv_nmos ad=79.8f pd=0.8u as=0 ps=0 w=0.42u l=1u
X133 VSS.t56 a_3747_952.t4 a_21911_913# VSS.t55 sg13_lv_nmos ad=0.2516p pd=2.16u as=0.2516p ps=2.16u w=0.74u l=0.13u
X134 VSS.t162 a_3747_216.t2 a_26985_424# VSS.t161 sg13_lv_nmos ad=0.2516p pd=2.16u as=0.2516p ps=2.16u w=0.74u l=0.13u
X135 a_20968_949# DELAY_OUT_TAP22 VSS.t324 VSS.t323 sg13_lv_nmos ad=0.1406p pd=1.12u as=0.2516p ps=2.16u w=0.74u l=0.13u
X136 VDD VSS.t383 VDD VDD sg13_lv_pmos ad=0.19p pd=1.38u as=0 ps=0 w=1u l=1u
X137 a_13470_949# a_14964_913# a_14888_949# VDD sg13_lv_pmos ad=0.3808p pd=2.92u as=0.2128p ps=1.5u w=1.12u l=0.13u
X138 VDD DELAY_OUT_TAP19 a_18585_949# VDD sg13_lv_pmos ad=0.252p pd=1.57u as=0.3808p ps=2.92u w=1.12u l=0.13u
X139 a_10430_949# a_10404_913# a_10328_949# VDD sg13_lv_pmos ad=0.3808p pd=2.92u as=0.2128p ps=1.5u w=1.12u l=0.13u
X140 a_19550_949# a_19524_913# a_19448_949# VDD sg13_lv_pmos ad=0.3808p pd=2.92u as=0.2128p ps=1.5u w=1.12u l=0.13u
X141 a_2595_216.t1 a_2297_236# VDD VDD sg13_lv_pmos ad=0.2128p pd=1.5u as=0.1918p ps=1.5u w=1.12u l=0.13u
X142 a_19448_949# DELAY_OUT_TAP20 VSS.t305 VSS.t304 sg13_lv_nmos ad=0.1406p pd=1.12u as=0.2516p ps=2.16u w=0.74u l=0.13u
X143 a_10430_949# a_3171_952.t7 a_11848_949# VSS.t100 sg13_lv_nmos ad=0.2516p pd=2.16u as=0.1406p ps=1.12u w=0.74u l=0.13u
X144 a_11195_949# a_10985_949# VDD VDD sg13_lv_pmos ad=0.2128p pd=1.5u as=0.252p ps=1.57u w=1.12u l=0.13u
X145 a_25630_949# a_2595_952.t2 a_26395_949# VSS.t103 sg13_lv_nmos ad=0.2516p pd=2.16u as=0.1406p ps=1.12u w=0.74u l=0.13u
X146 VDD a_1721_236# a_2019_216# VDD sg13_lv_pmos ad=0.4256p pd=3u as=0.2128p ps=1.5u w=1.12u l=0.13u
X147 VDD DELAY_OUT_TAP1 a_4905_949# VDD sg13_lv_pmos ad=0.252p pd=1.57u as=0.3808p ps=2.92u w=1.12u l=0.13u
X148 VSS.t234 VDD VSS.t232 VSS.t233 sg13_lv_nmos ad=79.8f pd=0.8u as=0 ps=0 w=0.42u l=1u
X149 VDD a_2297_236# a_2595_216.t1 VDD sg13_lv_pmos ad=0.4256p pd=3u as=0.2128p ps=1.5u w=1.12u l=0.13u
X150 a_4350_949# a_5844_913# a_5768_949# VDD sg13_lv_pmos ad=0.3808p pd=2.92u as=0.2128p ps=1.5u w=1.12u l=0.13u
X151 a_3449_1300# MUX_SEL0 VDD VDD sg13_lv_pmos ad=0.1596p pd=1.22u as=0.2856p ps=2.36u w=0.84u l=0.13u
X152 VDD DELAY_OUT_TAP7 a_9465_949# VDD sg13_lv_pmos ad=0.252p pd=1.57u as=0.3808p ps=2.92u w=1.12u l=0.13u
X153 VSS.t134 DELAY_OUT_TAP3 a_6425_949# VSS.t174 sg13_lv_nmos ad=0.1665p pd=1.19u as=0.2516p ps=2.16u w=0.74u l=0.13u
X154 a_10430_949# a_11271_913# a_11195_949# VDD sg13_lv_pmos ad=0.3808p pd=2.92u as=0.2128p ps=1.5u w=1.12u l=0.13u
X155 a_20968_949# DELAY_OUT_TAP22 VDD VDD sg13_lv_pmos ad=0.2128p pd=1.5u as=0.3808p ps=2.92u w=1.12u l=0.13u
X156 VSS.t65 a_2019_952.t6 a_13444_913# VSS.t64 sg13_lv_nmos ad=0.2516p pd=2.16u as=0.2516p ps=2.16u w=0.74u l=0.13u
X157 a_16108_194# a_17865_424# a_16510_949# VDD sg13_lv_pmos ad=0.3808p pd=2.92u as=0.3808p ps=2.92u w=1.12u l=0.13u
X158 VSS.t157 a_15964_194# a_16851_214# VSS.t163 sg13_lv_nmos ad=0.1371p pd=1.12u as=0.2176p ps=1.96u w=0.64u l=0.13u
X159 a_25528_949# DELAY_OUT_TAP28 VDD VDD sg13_lv_pmos ad=0.2128p pd=1.5u as=0.3808p ps=2.92u w=1.12u l=0.13u
X160 VDD a_1256_949# a_2873_1300# VDD sg13_lv_pmos ad=0.1918p pd=1.5u as=0.1596p ps=1.22u w=0.84u l=0.13u
X161 a_4248_949# a_4157_1218# VSS.t136 VSS.t135 sg13_lv_nmos ad=0.1406p pd=1.12u as=0.2516p ps=2.16u w=0.74u l=0.13u
X162 a_16108_194# a_3171_216.t2 a_22590_949# VSS.t88 sg13_lv_nmos ad=0.2516p pd=2.16u as=0.2516p ps=2.16u w=0.74u l=0.13u
X163 VSS.t254 VDD VSS.t252 VSS.t253 sg13_lv_nmos ad=79.8f pd=0.8u as=0 ps=0 w=0.42u l=1u
X164 a_19550_949# a_3747_952.t4 a_21835_949# VSS.t54 sg13_lv_nmos ad=0.2516p pd=2.16u as=0.1406p ps=1.12u w=0.74u l=0.13u
X165 VSS.t73 DELAY_OUT_TAP25 a_23145_949# VSS.t72 sg13_lv_nmos ad=0.1665p pd=1.19u as=0.2516p ps=2.16u w=0.74u l=0.13u
X166 a_5731_194# a_8745_424# a_7390_949# VDD sg13_lv_pmos ad=0.3808p pd=2.92u as=0.3808p ps=2.92u w=1.12u l=0.13u
X167 a_2595_216.t0 a_2297_236# VSS.t12 VSS.t51 sg13_lv_nmos ad=0.1406p pd=1.12u as=0.1331p ps=1.12u w=0.74u l=0.13u
X168 VDD a_3747_216.t2 a_26985_424# VDD sg13_lv_pmos ad=0.3808p pd=2.92u as=0.3808p ps=2.92u w=1.12u l=0.13u
X169 a_10430_949# a_3747_952.t7 a_12715_949# VSS.t40 sg13_lv_nmos ad=0.2516p pd=2.16u as=0.1406p ps=1.12u w=0.74u l=0.13u
X170 VSS.t331 a_1721_236# a_2019_216# VSS.t330 sg13_lv_nmos ad=0.2812p pd=2.24u as=0.1406p ps=1.12u w=0.74u l=0.13u
X171 a_24875_949# a_24665_949# VSS.t8 VSS.t7 sg13_lv_nmos ad=0.1406p pd=1.12u as=0.1665p ps=1.19u w=0.74u l=0.13u
X172 VSS.t53 a_2297_236# a_2595_216.t0 VSS.t52 sg13_lv_nmos ad=0.2812p pd=2.24u as=0.1406p ps=1.12u w=0.74u l=0.13u
X173 VSS.t343 a_2595_952.t3 a_23431_913# VSS.t342 sg13_lv_nmos ad=0.2516p pd=2.16u as=0.2516p ps=2.16u w=0.74u l=0.13u
X174 VDD MUX_SEL1 a_3449_1300# VDD sg13_lv_pmos ad=0.1918p pd=1.5u as=0.1596p ps=1.22u w=0.84u l=0.13u
X175 VSS.t192 VDD VSS.t191 VSS.t190 sg13_lv_nmos ad=0.1428p pd=1.52u as=0 ps=0 w=0.42u l=1u
X176 VSS.t87 DELAY_OUT_TAP13 a_14025_949# VSS.t292 sg13_lv_nmos ad=0.1665p pd=1.19u as=0.2516p ps=2.16u w=0.74u l=0.13u
X177 a_22590_949# a_24084_913# a_24008_949# VDD sg13_lv_pmos ad=0.3808p pd=2.92u as=0.2128p ps=1.5u w=1.12u l=0.13u
X178 VDD VSS.t359 VDD VDD sg13_lv_pmos ad=0.19p pd=1.38u as=0 ps=0 w=1u l=1u
X179 VDD DELAY_OUT_TAP27 a_24665_949# VDD sg13_lv_pmos ad=0.252p pd=1.57u as=0.3808p ps=2.92u w=1.12u l=0.13u
X180 VDD a_3171_952.t6 a_14964_913# VDD sg13_lv_pmos ad=0.3808p pd=2.92u as=0.3808p ps=2.92u w=1.12u l=0.13u
X181 a_25630_949# a_25604_913# a_25528_949# VDD sg13_lv_pmos ad=0.3808p pd=2.92u as=0.2128p ps=1.5u w=1.12u l=0.13u
X182 a_3171_952.t1 a_2873_1300# VDD VDD sg13_lv_pmos ad=0.2128p pd=1.5u as=0.1918p ps=1.5u w=1.12u l=0.13u
X183 a_3747_952.t1 a_3449_1300# VDD VDD sg13_lv_pmos ad=0.2128p pd=1.5u as=0.1918p ps=1.5u w=1.12u l=0.13u
X184 VDD VSS.t358 VDD VDD sg13_lv_pmos ad=0.34p pd=2.68u as=0 ps=0 w=1u l=1u
X185 VDD a_2019_952.t5 a_16484_913# VDD sg13_lv_pmos ad=0.3808p pd=2.92u as=0.3808p ps=2.92u w=1.12u l=0.13u
X186 a_22590_949# a_3171_952.t3 a_24008_949# VSS.t109 sg13_lv_nmos ad=0.2516p pd=2.16u as=0.1406p ps=1.12u w=0.74u l=0.13u
X187 VDD a_15964_194# a_16851_214# VDD sg13_lv_pmos ad=0.2086p pd=1.5u as=0.34p ps=2.68u w=1u l=0.13u
X188 a_26395_949# a_26185_949# VDD VDD sg13_lv_pmos ad=0.2128p pd=1.5u as=0.252p ps=1.57u w=1.12u l=0.13u
X189 a_3747_952.t0 a_3449_1300# VSS.t147 VSS.t146 sg13_lv_nmos ad=0.1406p pd=1.12u as=0.1331p ps=1.12u w=0.74u l=0.13u
X190 a_25630_949# a_3747_952.t2 a_27915_949# VSS.t127 sg13_lv_nmos ad=0.2516p pd=2.16u as=0.1406p ps=1.12u w=0.74u l=0.13u
X191 VSS.t249 VDD VSS.t247 VSS.t248 sg13_lv_nmos ad=79.8f pd=0.8u as=0 ps=0 w=0.42u l=1u
X192 VDD VSS.t391 VDD VDD sg13_lv_pmos ad=0.19p pd=1.38u as=0 ps=0 w=1u l=1u
X193 a_2967_1300# MUX_SEL1 a_2873_1300# VSS.t177 sg13_lv_nmos ad=0.1216p pd=1.02u as=0.2176p ps=1.96u w=0.64u l=0.13u
X194 VDD a_3171_952.t9 a_5844_913# VDD sg13_lv_pmos ad=0.3808p pd=2.92u as=0.3808p ps=2.92u w=1.12u l=0.13u
X195 VSS.t244 VDD VSS.t242 VSS.t243 sg13_lv_nmos ad=79.8f pd=0.8u as=0 ps=0 w=0.42u l=1u
X196 VSS.t217 VDD VSS.t216 VSS.t215 sg13_lv_nmos ad=0.1428p pd=1.52u as=0 ps=0 w=0.42u l=1u
X197 a_25630_949# a_26471_913# a_26395_949# VDD sg13_lv_pmos ad=0.3808p pd=2.92u as=0.2128p ps=1.5u w=1.12u l=0.13u
X198 a_3543_236# MUX_SEL2 a_3449_236# VSS.t328 sg13_lv_nmos ad=0.1216p pd=1.02u as=0.2176p ps=1.96u w=0.64u l=0.13u
X199 a_16108_194# a_23945_424# a_22590_949# VDD sg13_lv_pmos ad=0.3808p pd=2.92u as=0.3808p ps=2.92u w=1.12u l=0.13u
X200 VDD a_2595_952.t5 a_17351_913# VDD sg13_lv_pmos ad=0.3808p pd=2.92u as=0.3808p ps=2.92u w=1.12u l=0.13u
X201 VDD a_3747_952.t7 a_12791_913# VDD sg13_lv_pmos ad=0.3808p pd=2.92u as=0.3808p ps=2.92u w=1.12u l=0.13u
X202 a_8155_949# a_7945_949# VSS.t312 VSS.t311 sg13_lv_nmos ad=0.1406p pd=1.12u as=0.1665p ps=1.19u w=0.74u l=0.13u
X203 a_27048_949# DELAY_OUT_TAP30 VSS.t165 VSS.t164 sg13_lv_nmos ad=0.1406p pd=1.12u as=0.2516p ps=2.16u w=0.74u l=0.13u
X204 a_5768_949# DELAY_OUT_TAP2 VSS.t167 VSS.t166 sg13_lv_nmos ad=0.1406p pd=1.12u as=0.2516p ps=2.16u w=0.74u l=0.13u
X205 VSS.t132 a_3747_216.t3 a_14825_424# VSS.t131 sg13_lv_nmos ad=0.2516p pd=2.16u as=0.2516p ps=2.16u w=0.74u l=0.13u
X206 VSS.t85 a_1256_194# a_2967_236# VSS.t84 sg13_lv_nmos ad=0.1331p pd=1.12u as=0.1216p ps=1.02u w=0.64u l=0.13u
X207 VSS.t252 VDD VSS.t251 VSS.t250 sg13_lv_nmos ad=0.1428p pd=1.52u as=0 ps=0 w=0.42u l=1u
X208 VDD VSS.t375 VDD VDD sg13_lv_pmos ad=0.19p pd=1.38u as=0 ps=0 w=1u l=1u
X209 VDD a_2873_1300# a_3171_952.t1 VDD sg13_lv_pmos ad=0.4256p pd=3u as=0.2128p ps=1.5u w=1.12u l=0.13u
X210 VSS.t8 DELAY_OUT_TAP27 a_24665_949# VSS.t310 sg13_lv_nmos ad=0.1665p pd=1.19u as=0.2516p ps=2.16u w=0.74u l=0.13u
X211 VDD a_2595_952.t8 a_8231_913# VDD sg13_lv_pmos ad=0.3808p pd=2.92u as=0.3808p ps=2.92u w=1.12u l=0.13u
X212 a_16510_949# a_3171_952.t5 a_17928_949# VSS.t43 sg13_lv_nmos ad=0.2516p pd=2.16u as=0.1406p ps=1.12u w=0.74u l=0.13u
X213 VDD a_3449_1300# a_3747_952.t1 VDD sg13_lv_pmos ad=0.4256p pd=3u as=0.2128p ps=1.5u w=1.12u l=0.13u
X214 VSS.t15 a_3171_952.t4 a_21044_913# VSS.t14 sg13_lv_nmos ad=0.2516p pd=2.16u as=0.2516p ps=2.16u w=0.74u l=0.13u
X215 VDD VSS.t367 VDD VDD sg13_lv_pmos ad=0.19p pd=1.38u as=0 ps=0 w=1u l=1u
X216 VSS.t6 MUX_SEL3 a_3543_236# VSS.t5 sg13_lv_nmos ad=0.1331p pd=1.12u as=0.1216p ps=1.02u w=0.64u l=0.13u
X217 VDD a_3171_952.t4 a_21044_913# VDD sg13_lv_pmos ad=0.3808p pd=2.92u as=0.3808p ps=2.92u w=1.12u l=0.13u
X218 a_13368_949# DELAY_OUT_TAP12 VDD VDD sg13_lv_pmos ad=0.2128p pd=1.5u as=0.3808p ps=2.92u w=1.12u l=0.13u
X219 VSS.t302 a_2873_1300# a_3171_952.t0 VSS.t301 sg13_lv_nmos ad=0.2812p pd=2.24u as=0.1406p ps=1.12u w=0.74u l=0.13u
X220 a_13368_949# DELAY_OUT_TAP12 VSS.t353 VSS.t352 sg13_lv_nmos ad=0.1406p pd=1.12u as=0.2516p ps=2.16u w=0.74u l=0.13u
X221 a_5731_194# a_3171_216.t3 a_10430_949# VSS.t80 sg13_lv_nmos ad=0.2516p pd=2.16u as=0.2516p ps=2.16u w=0.74u l=0.13u
X222 VSS.t282 a_1544_949# a_2391_1300# VSS.t281 sg13_lv_nmos ad=0.1331p pd=1.12u as=0.1216p ps=1.02u w=0.64u l=0.13u
X223 a_2019_952.t0 a_1721_1300# VSS.t187 VSS.t186 sg13_lv_nmos ad=0.1406p pd=1.12u as=0.1331p ps=1.12u w=0.74u l=0.13u
X224 a_4350_949# a_3747_952.t9 a_6635_949# VSS.t57 sg13_lv_nmos ad=0.2516p pd=2.16u as=0.1406p ps=1.12u w=0.74u l=0.13u
X225 a_19550_949# a_2595_952.t4 a_20315_949# VSS.t34 sg13_lv_nmos ad=0.2516p pd=2.16u as=0.1406p ps=1.12u w=0.74u l=0.13u
X226 a_8808_949# DELAY_OUT_TAP6 VDD VDD sg13_lv_pmos ad=0.2128p pd=1.5u as=0.3808p ps=2.92u w=1.12u l=0.13u
X227 VSS.t312 DELAY_OUT_TAP5 a_7945_949# VSS.t356 sg13_lv_nmos ad=0.1665p pd=1.19u as=0.2516p ps=2.16u w=0.74u l=0.13u
X228 a_2019_216# a_1721_236# VDD VDD sg13_lv_pmos ad=0.2128p pd=1.5u as=0.1918p ps=1.5u w=1.12u l=0.13u
X229 VSS.t247 VDD VSS.t246 VSS.t245 sg13_lv_nmos ad=0.1428p pd=1.52u as=0 ps=0 w=0.42u l=1u
X230 a_4248_949# a_4157_1218# VDD VDD sg13_lv_pmos ad=0.2128p pd=1.5u as=0.3808p ps=2.92u w=1.12u l=0.13u
X231 VDD VSS.t392 VDD VDD sg13_lv_pmos ad=0.34p pd=2.68u as=0 ps=0 w=1u l=1u
X232 VSS.t212 VDD VSS.t211 VSS.t210 sg13_lv_nmos ad=0.1428p pd=1.52u as=0 ps=0 w=0.42u l=1u
X233 VSS.t242 VDD VSS.t241 VSS.t240 sg13_lv_nmos ad=0.1428p pd=1.52u as=0 ps=0 w=0.42u l=1u
X234 VDD a_2595_952.t3 a_23431_913# VDD sg13_lv_pmos ad=0.3808p pd=2.92u as=0.3808p ps=2.92u w=1.12u l=0.13u
X235 VDD a_3747_216.t3 a_14825_424# VDD sg13_lv_pmos ad=0.3808p pd=2.92u as=0.3808p ps=2.92u w=1.12u l=0.13u
X236 VDD a_3747_952.t2 a_27991_913# VDD sg13_lv_pmos ad=0.3808p pd=2.92u as=0.3808p ps=2.92u w=1.12u l=0.13u
X237 a_2297_1300# MUX_SEL0 VDD VDD sg13_lv_pmos ad=0.1596p pd=1.22u as=0.2856p ps=2.36u w=0.84u l=0.13u
X238 a_9675_949# a_9465_949# VSS.t296 VSS.t313 sg13_lv_nmos ad=0.1406p pd=1.12u as=0.1665p ps=1.19u w=0.74u l=0.13u
X239 VSS.t209 VDD VSS.t207 VSS.t208 sg13_lv_nmos ad=79.8f pd=0.8u as=0 ps=0 w=0.42u l=1u
X240 a_2873_1300# MUX_SEL1 VDD VDD sg13_lv_pmos ad=0.1596p pd=1.22u as=0.2856p ps=2.36u w=0.84u l=0.13u
X241 VSS.t28 a_2595_952.t8 a_8231_913# VSS.t27 sg13_lv_nmos ad=0.2516p pd=2.16u as=0.2516p ps=2.16u w=0.74u l=0.13u
X242 VSS.t50 a_2595_216.t2 a_20905_424# VSS.t49 sg13_lv_nmos ad=0.2516p pd=2.16u as=0.2516p ps=2.16u w=0.74u l=0.13u
X243 a_3449_236# MUX_SEL2 VDD VDD sg13_lv_pmos ad=0.1596p pd=1.22u as=0.2856p ps=2.36u w=0.84u l=0.13u
X244 VDD DELAY_OUT_TAP11 a_12505_949# VDD sg13_lv_pmos ad=0.252p pd=1.57u as=0.3808p ps=2.92u w=1.12u l=0.13u
X245 VDD VSS.t369 VDD VDD sg13_lv_pmos ad=0.19p pd=1.38u as=0 ps=0 w=1u l=1u
X246 a_13470_949# a_13444_913# a_13368_949# VDD sg13_lv_pmos ad=0.3808p pd=2.92u as=0.2128p ps=1.5u w=1.12u l=0.13u
X247 VDD DELAY_OUT_TAP17 a_17065_949# VDD sg13_lv_pmos ad=0.252p pd=1.57u as=0.3808p ps=2.92u w=1.12u l=0.13u
X248 a_16510_949# a_18004_913# a_17928_949# VDD sg13_lv_pmos ad=0.3808p pd=2.92u as=0.2128p ps=1.5u w=1.12u l=0.13u
X249 a_19550_949# a_2019_952.t4 a_19448_949# VSS.t75 sg13_lv_nmos ad=0.2516p pd=2.16u as=0.1406p ps=1.12u w=0.74u l=0.13u
X250 VDD VSS.t371 VDD VDD sg13_lv_pmos ad=0.19p pd=1.38u as=0 ps=0 w=1u l=1u
X251 VDD VSS.t382 VDD VDD sg13_lv_pmos ad=0.34p pd=2.68u as=0 ps=0 w=1u l=1u
X252 VDD a_1256_194# a_2873_236# VDD sg13_lv_pmos ad=0.1918p pd=1.5u as=0.1596p ps=1.22u w=0.84u l=0.13u
X253 a_13470_949# a_2595_952.t6 a_14235_949# VSS.t338 sg13_lv_nmos ad=0.2516p pd=2.16u as=0.1406p ps=1.12u w=0.74u l=0.13u
X254 VSS.t123 a_2019_952.t3 a_22564_913# VSS.t122 sg13_lv_nmos ad=0.2516p pd=2.16u as=0.2516p ps=2.16u w=0.74u l=0.13u
X255 a_15755_949# a_15545_949# VDD VDD sg13_lv_pmos ad=0.2128p pd=1.5u as=0.252p ps=1.57u w=1.12u l=0.13u
X256 a_7390_949# a_8884_913# a_8808_949# VDD sg13_lv_pmos ad=0.3808p pd=2.92u as=0.2128p ps=1.5u w=1.12u l=0.13u
X257 a_2019_216# a_1721_236# VSS.t10 VSS.t329 sg13_lv_nmos ad=0.1406p pd=1.12u as=0.1331p ps=1.12u w=0.74u l=0.13u
X258 a_4350_949# a_4324_913# a_4248_949# VDD sg13_lv_pmos ad=0.3808p pd=2.92u as=0.2128p ps=1.5u w=1.12u l=0.13u
X259 VDD DELAY_OUT_TAP5 a_7945_949# VDD sg13_lv_pmos ad=0.252p pd=1.57u as=0.3808p ps=2.92u w=1.12u l=0.13u
X260 a_24008_949# DELAY_OUT_TAP26 VDD VDD sg13_lv_pmos ad=0.2128p pd=1.5u as=0.3808p ps=2.92u w=1.12u l=0.13u
X261 a_5731_194# a_11785_424# a_10430_949# VDD sg13_lv_pmos ad=0.3808p pd=2.92u as=0.3808p ps=2.92u w=1.12u l=0.13u
X262 a_5115_949# a_4905_949# VDD VDD sg13_lv_pmos ad=0.2128p pd=1.5u as=0.252p ps=1.57u w=1.12u l=0.13u
X263 VDD VSS.t368 VDD VDD sg13_lv_pmos ad=0.34p pd=2.68u as=0 ps=0 w=1u l=1u
X264 a_13470_949# a_15831_913# a_15755_949# VDD sg13_lv_pmos ad=0.3808p pd=2.92u as=0.2128p ps=1.5u w=1.12u l=0.13u
X265 a_17275_949# a_17065_949# VSS.t152 VSS.t151 sg13_lv_nmos ad=0.1406p pd=1.12u as=0.1665p ps=1.19u w=0.74u l=0.13u
X266 VDD a_1544_949# a_2297_1300# VDD sg13_lv_pmos ad=0.1918p pd=1.5u as=0.1596p ps=1.22u w=0.84u l=0.13u
X267 VSS.t108 a_3747_952.t6 a_15831_913# VSS.t107 sg13_lv_nmos ad=0.2516p pd=2.16u as=0.2516p ps=2.16u w=0.74u l=0.13u
X268 a_4350_949# a_2019_952.t9 a_4248_949# VSS.t69 sg13_lv_nmos ad=0.2516p pd=2.16u as=0.1406p ps=1.12u w=0.74u l=0.13u
X269 VSS.t204 VDD VSS.t202 VSS.t203 sg13_lv_nmos ad=79.8f pd=0.8u as=0 ps=0 w=0.42u l=1u
X270 a_6635_949# a_6425_949# VDD VDD sg13_lv_pmos ad=0.2128p pd=1.5u as=0.252p ps=1.57u w=1.12u l=0.13u
X271 a_14888_949# DELAY_OUT_TAP14 VSS.t307 VSS.t306 sg13_lv_nmos ad=0.1406p pd=1.12u as=0.2516p ps=2.16u w=0.74u l=0.13u
X272 a_16108_194# a_3747_216.t2 a_25630_949# VSS.t160 sg13_lv_nmos ad=0.2516p pd=2.16u as=0.2516p ps=2.16u w=0.74u l=0.13u
X273 VSS.t269 VDD VSS.t267 VSS.t268 sg13_lv_nmos ad=79.8f pd=0.8u as=0 ps=0 w=0.42u l=1u
X274 a_4350_949# a_5191_913# a_5115_949# VDD sg13_lv_pmos ad=0.3808p pd=2.92u as=0.2128p ps=1.5u w=1.12u l=0.13u
X275 VDD MUX_SEL3 a_3449_236# VDD sg13_lv_pmos ad=0.1918p pd=1.5u as=0.1596p ps=1.22u w=0.84u l=0.13u
X276 VSS.t296 DELAY_OUT_TAP7 a_9465_949# VSS.t295 sg13_lv_nmos ad=0.1665p pd=1.19u as=0.2516p ps=2.16u w=0.74u l=0.13u
X277 a_4350_949# a_6711_913# a_6635_949# VDD sg13_lv_pmos ad=0.3808p pd=2.92u as=0.2128p ps=1.5u w=1.12u l=0.13u
X278 VSS.t272 VDD VSS.t271 VSS.t270 sg13_lv_nmos ad=0.1428p pd=1.52u as=0 ps=0 w=0.42u l=1u
X279 VSS.t346 a_2019_952.t5 a_16484_913# VSS.t345 sg13_lv_nmos ad=0.2516p pd=2.16u as=0.2516p ps=2.16u w=0.74u l=0.13u
X280 VSS.t62 a_3171_952.t9 a_5844_913# VSS.t61 sg13_lv_nmos ad=0.2516p pd=2.16u as=0.2516p ps=2.16u w=0.74u l=0.13u
X281 VDD a_2595_216.t2 a_20905_424# VDD sg13_lv_pmos ad=0.3808p pd=2.92u as=0.3808p ps=2.92u w=1.12u l=0.13u
X282 VSS.t114 a_2595_952.t7 a_11271_913# VSS.t113 sg13_lv_nmos ad=0.2516p pd=2.16u as=0.2516p ps=2.16u w=0.74u l=0.13u
X283 VSS.t33 a_3747_952.t8 a_9751_913# VSS.t32 sg13_lv_nmos ad=0.2516p pd=2.16u as=0.2516p ps=2.16u w=0.74u l=0.13u
X284 a_1256_949# MUX_SEL0 VDD VDD sg13_lv_pmos ad=0.3808p pd=2.92u as=0.3808p ps=2.92u w=1.12u l=0.13u
X285 a_2391_236# MUX_SEL2 a_2297_236# VSS.t327 sg13_lv_nmos ad=0.1216p pd=1.02u as=0.2176p ps=1.96u w=0.64u l=0.13u
X286 a_2967_236# MUX_SEL3 a_2873_236# VSS.t4 sg13_lv_nmos ad=0.1216p pd=1.02u as=0.2176p ps=1.96u w=0.64u l=0.13u
X287 VDD DELAY_OUT_TAP31 a_27705_949# VDD sg13_lv_pmos ad=0.252p pd=1.57u as=0.3808p ps=2.92u w=1.12u l=0.13u
X288 VDD DELAY_OUT_TAP25 a_23145_949# VDD sg13_lv_pmos ad=0.252p pd=1.57u as=0.3808p ps=2.92u w=1.12u l=0.13u
X289 a_2595_952.t1 a_2297_1300# VDD VDD sg13_lv_pmos ad=0.2128p pd=1.5u as=0.1918p ps=1.5u w=1.12u l=0.13u
X290 VDD VSS.t370 VDD VDD sg13_lv_pmos ad=0.34p pd=2.68u as=0 ps=0 w=1u l=1u
X291 VDD a_2019_952.t7 a_10404_913# VDD sg13_lv_pmos ad=0.3808p pd=2.92u as=0.3808p ps=2.92u w=1.12u l=0.13u
X292 VDD a_2019_952.t4 a_19524_913# VDD sg13_lv_pmos ad=0.3808p pd=2.92u as=0.3808p ps=2.92u w=1.12u l=0.13u
X293 VDD VSS.t384 VDD VDD sg13_lv_pmos ad=0.34p pd=2.68u as=0 ps=0 w=1u l=1u
X294 a_20315_949# a_20105_949# VDD VDD sg13_lv_pmos ad=0.2128p pd=1.5u as=0.252p ps=1.57u w=1.12u l=0.13u
X295 a_1544_949# MUX_SEL1 VSS.t176 VSS.t175 sg13_lv_nmos ad=0.2516p pd=2.16u as=0.2516p ps=2.16u w=0.74u l=0.13u
X296 VDD VSS.t372 VDD VDD sg13_lv_pmos ad=0.34p pd=2.68u as=0 ps=0 w=1u l=1u
X297 a_13470_949# a_3747_952.t6 a_15755_949# VSS.t106 sg13_lv_nmos ad=0.2516p pd=2.16u as=0.1406p ps=1.12u w=0.74u l=0.13u
X298 VSS.t149 a_3449_1300# a_3747_952.t0 VSS.t148 sg13_lv_nmos ad=0.2812p pd=2.24u as=0.1406p ps=1.12u w=0.74u l=0.13u
X299 a_4350_949# a_2595_952.t9 a_5115_949# VSS.t66 sg13_lv_nmos ad=0.2516p pd=2.16u as=0.1406p ps=1.12u w=0.74u l=0.13u
X300 VDD a_1721_1300# a_2019_952.t1 VDD sg13_lv_pmos ad=0.4256p pd=3u as=0.2128p ps=1.5u w=1.12u l=0.13u
X301 VSS.t105 a_2595_952.t2 a_26471_913# VSS.t104 sg13_lv_nmos ad=0.2516p pd=2.16u as=0.2516p ps=2.16u w=0.74u l=0.13u
X302 VSS.t264 VDD VSS.t262 VSS.t263 sg13_lv_nmos ad=79.8f pd=0.8u as=0 ps=0 w=0.42u l=1u
X303 a_21835_949# a_21625_949# VDD VDD sg13_lv_pmos ad=0.2128p pd=1.5u as=0.252p ps=1.57u w=1.12u l=0.13u
X304 a_3543_1300# MUX_SEL0 a_3449_1300# VSS.t171 sg13_lv_nmos ad=0.1216p pd=1.02u as=0.2176p ps=1.96u w=0.64u l=0.13u
X305 VDD a_2297_1300# a_2595_952.t1 VDD sg13_lv_pmos ad=0.4256p pd=3u as=0.2128p ps=1.5u w=1.12u l=0.13u
X306 VSS.t152 DELAY_OUT_TAP17 a_17065_949# VSS.t303 sg13_lv_nmos ad=0.1665p pd=1.19u as=0.2516p ps=2.16u w=0.74u l=0.13u
X307 VDD VSS.t385 VDD VDD sg13_lv_pmos ad=0.19p pd=1.38u as=0 ps=0 w=1u l=1u
X308 VSS.t229 VDD VSS.t227 VSS.t228 sg13_lv_nmos ad=79.8f pd=0.8u as=0 ps=0 w=0.42u l=1u
X309 a_19550_949# a_20391_913# a_20315_949# VDD sg13_lv_pmos ad=0.3808p pd=2.92u as=0.2128p ps=1.5u w=1.12u l=0.13u
X310 VSS.t232 VDD VSS.t231 VSS.t230 sg13_lv_nmos ad=0.1428p pd=1.52u as=0 ps=0 w=0.42u l=1u
X311 a_1544_949# MUX_SEL1 VDD VDD sg13_lv_pmos ad=0.3808p pd=2.92u as=0.3808p ps=2.92u w=1.12u l=0.13u
X312 a_16108_194# a_26985_424# a_25630_949# VDD sg13_lv_pmos ad=0.3808p pd=2.92u as=0.3808p ps=2.92u w=1.12u l=0.13u
X313 a_19550_949# a_21911_913# a_21835_949# VDD sg13_lv_pmos ad=0.3808p pd=2.92u as=0.2128p ps=1.5u w=1.12u l=0.13u
X314 VDD a_3747_952.t6 a_15831_913# VDD sg13_lv_pmos ad=0.3808p pd=2.92u as=0.3808p ps=2.92u w=1.12u l=0.13u
X315 a_18795_949# a_18585_949# VSS.t79 VSS.t78 sg13_lv_nmos ad=0.1406p pd=1.12u as=0.1665p ps=1.19u w=0.74u l=0.13u
X316 a_25630_949# a_3171_952.t2 a_27048_949# VSS.t320 sg13_lv_nmos ad=0.2516p pd=2.16u as=0.1406p ps=1.12u w=0.74u l=0.13u
X317 VSS.t337 a_2595_952.t5 a_17351_913# VSS.t336 sg13_lv_nmos ad=0.2516p pd=2.16u as=0.2516p ps=2.16u w=0.74u l=0.13u
X318 a_4350_949# a_3171_952.t9 a_5768_949# VSS.t60 sg13_lv_nmos ad=0.2516p pd=2.16u as=0.1406p ps=1.12u w=0.74u l=0.13u
X319 VSS.t96 a_2019_216# a_17865_424# VSS.t95 sg13_lv_nmos ad=0.2516p pd=2.16u as=0.2516p ps=2.16u w=0.74u l=0.13u
X320 VSS.t12 a_1544_194# a_2391_236# VSS.t11 sg13_lv_nmos ad=0.1331p pd=1.12u as=0.1216p ps=1.02u w=0.64u l=0.13u
X321 VSS.t120 a_2019_952.t8 a_7364_913# VSS.t119 sg13_lv_nmos ad=0.2516p pd=2.16u as=0.2516p ps=2.16u w=0.74u l=0.13u
X322 VSS.t93 a_2019_216# a_5705_424# VSS.t92 sg13_lv_nmos ad=0.2516p pd=2.16u as=0.2516p ps=2.16u w=0.74u l=0.13u
X323 MUX_OUT a_16851_214# VDD VDD sg13_lv_pmos ad=0.2128p pd=1.5u as=0.2086p ps=1.5u w=1.12u l=0.13u
X324 a_22488_949# DELAY_OUT_TAP24 VSS.t19 VSS.t18 sg13_lv_nmos ad=0.1406p pd=1.12u as=0.2516p ps=2.16u w=0.74u l=0.13u
X325 VDD VSS.t387 VDD VDD sg13_lv_pmos ad=0.19p pd=1.38u as=0 ps=0 w=1u l=1u
X326 VDD VSS.t361 VDD VDD sg13_lv_pmos ad=0.19p pd=1.38u as=0 ps=0 w=1u l=1u
X327 a_16408_949# DELAY_OUT_TAP16 VDD VDD sg13_lv_pmos ad=0.2128p pd=1.5u as=0.3808p ps=2.92u w=1.12u l=0.13u
X328 a_13470_949# a_2019_952.t6 a_13368_949# VSS.t63 sg13_lv_nmos ad=0.2516p pd=2.16u as=0.1406p ps=1.12u w=0.74u l=0.13u
X329 a_15964_194# a_15765_368# a_5731_194# VSS.t25 sg13_lv_nmos ad=0.2183p pd=1.33u as=0.2516p ps=2.16u w=0.74u l=0.13u
X330 VDD a_2019_952.t2 a_25604_913# VDD sg13_lv_pmos ad=0.3808p pd=2.92u as=0.3808p ps=2.92u w=1.12u l=0.13u
X331 a_2595_952.t0 a_2297_1300# VSS.t282 VSS.t349 sg13_lv_nmos ad=0.1406p pd=1.12u as=0.1331p ps=1.12u w=0.74u l=0.13u
X332 a_17928_949# DELAY_OUT_TAP18 VDD VDD sg13_lv_pmos ad=0.2128p pd=1.5u as=0.3808p ps=2.92u w=1.12u l=0.13u
X333 VSS.t111 a_3171_952.t3 a_24084_913# VSS.t110 sg13_lv_nmos ad=0.2516p pd=2.16u as=0.2516p ps=2.16u w=0.74u l=0.13u
X334 VDD VSS.t360 VDD VDD sg13_lv_pmos ad=0.34p pd=2.68u as=0 ps=0 w=1u l=1u
X335 a_2297_236# MUX_SEL2 VDD VDD sg13_lv_pmos ad=0.1596p pd=1.22u as=0.2856p ps=2.36u w=0.84u l=0.13u
X336 a_1815_1300# a_1256_949# a_1721_1300# VSS.t284 sg13_lv_nmos ad=0.1216p pd=1.02u as=0.2176p ps=1.96u w=0.64u l=0.13u
X337 a_2873_236# MUX_SEL3 VDD VDD sg13_lv_pmos ad=0.1596p pd=1.22u as=0.2856p ps=2.36u w=0.84u l=0.13u
X338 VSS.t79 DELAY_OUT_TAP19 a_18585_949# VSS.t354 sg13_lv_nmos ad=0.1665p pd=1.19u as=0.2516p ps=2.16u w=0.74u l=0.13u
X339 VSS.t262 VDD VSS.t261 VSS.t260 sg13_lv_nmos ad=0.1428p pd=1.52u as=0 ps=0 w=0.42u l=1u
X340 a_7288_949# DELAY_OUT_TAP4 VDD VDD sg13_lv_pmos ad=0.2128p pd=1.5u as=0.3808p ps=2.92u w=1.12u l=0.13u
X341 VSS.t227 VDD VSS.t226 VSS.t225 sg13_lv_nmos ad=0.1428p pd=1.52u as=0 ps=0 w=0.42u l=1u
X342 VSS.t239 VDD VSS.t237 VSS.t238 sg13_lv_nmos ad=79.8f pd=0.8u as=0 ps=0 w=0.42u l=1u
X343 VSS.t289 a_3171_952.t6 a_14964_913# VSS.t288 sg13_lv_nmos ad=0.2516p pd=2.16u as=0.2516p ps=2.16u w=0.74u l=0.13u
X344 VDD a_2019_216# a_17865_424# VDD sg13_lv_pmos ad=0.3808p pd=2.92u as=0.3808p ps=2.92u w=1.12u l=0.13u
X345 VDD a_3747_952.t4 a_21911_913# VDD sg13_lv_pmos ad=0.3808p pd=2.92u as=0.3808p ps=2.92u w=1.12u l=0.13u
X346 a_11195_949# a_10985_949# VSS.t138 VSS.t137 sg13_lv_nmos ad=0.1406p pd=1.12u as=0.1665p ps=1.19u w=0.74u l=0.13u
X347 a_1721_1300# a_1256_949# VDD VDD sg13_lv_pmos ad=0.1596p pd=1.22u as=0.2856p ps=2.36u w=0.84u l=0.13u
X348 VDD a_16851_214# MUX_OUT VDD sg13_lv_pmos ad=0.7336p pd=3.55u as=0.2128p ps=1.5u w=1.12u l=0.13u
X349 VSS.t90 a_3171_216.t2 a_23945_424# VSS.t89 sg13_lv_nmos ad=0.2516p pd=2.16u as=0.2516p ps=2.16u w=0.74u l=0.13u
X350 a_22590_949# a_2595_952.t3 a_23355_949# VSS.t341 sg13_lv_nmos ad=0.2516p pd=2.16u as=0.1406p ps=1.12u w=0.74u l=0.13u
X351 VSS.t117 MUX_SEL4 a_15765_368# VSS.t116 sg13_lv_nmos ad=0.2516p pd=2.16u as=0.2516p ps=2.16u w=0.74u l=0.13u
X352 a_16510_949# a_16484_913# a_16408_949# VDD sg13_lv_pmos ad=0.3808p pd=2.92u as=0.2128p ps=1.5u w=1.12u l=0.13u
X353 VDD VSS.t363 VDD VDD sg13_lv_pmos ad=0.19p pd=1.38u as=0 ps=0 w=1u l=1u
X354 VDD DELAY_OUT_TAP9 a_10985_949# VDD sg13_lv_pmos ad=0.252p pd=1.57u as=0.3808p ps=2.92u w=1.12u l=0.13u
X355 VDD a_1544_949# a_1721_1300# VDD sg13_lv_pmos ad=0.1918p pd=1.5u as=0.1596p ps=1.22u w=0.84u l=0.13u
X356 VDD VSS.t377 VDD VDD sg13_lv_pmos ad=0.19p pd=1.38u as=0 ps=0 w=1u l=1u
X357 VDD a_2019_216# a_5705_424# VDD sg13_lv_pmos ad=0.3808p pd=2.92u as=0.3808p ps=2.92u w=1.12u l=0.13u
X358 VDD VSS.t376 VDD VDD sg13_lv_pmos ad=0.34p pd=2.68u as=0 ps=0 w=1u l=1u
X359 VSS.t22 a_2019_952.t7 a_10404_913# VSS.t21 sg13_lv_nmos ad=0.2516p pd=2.16u as=0.2516p ps=2.16u w=0.74u l=0.13u
X360 VDD a_1544_194# a_2297_236# VDD sg13_lv_pmos ad=0.1918p pd=1.5u as=0.1596p ps=1.22u w=0.84u l=0.13u
X361 a_26395_949# a_26185_949# VSS.t17 VSS.t143 sg13_lv_nmos ad=0.1406p pd=1.12u as=0.1665p ps=1.19u w=0.74u l=0.13u
X362 VSS.t219 VDD VSS.t217 VSS.t218 sg13_lv_nmos ad=79.8f pd=0.8u as=0 ps=0 w=0.42u l=1u
X363 VSS.t316 a_3747_952.t3 a_24951_913# VSS.t315 sg13_lv_nmos ad=0.2516p pd=2.16u as=0.2516p ps=2.16u w=0.74u l=0.13u
X364 a_18795_949# a_18585_949# VDD VDD sg13_lv_pmos ad=0.2128p pd=1.5u as=0.252p ps=1.57u w=1.12u l=0.13u
X365 a_14235_949# a_14025_949# VDD VDD sg13_lv_pmos ad=0.2128p pd=1.5u as=0.252p ps=1.57u w=1.12u l=0.13u
X366 VDD DELAY_OUT_TAP3 a_6425_949# VDD sg13_lv_pmos ad=0.252p pd=1.57u as=0.3808p ps=2.92u w=1.12u l=0.13u
X367 a_7390_949# a_7364_913# a_7288_949# VDD sg13_lv_pmos ad=0.3808p pd=2.92u as=0.2128p ps=1.5u w=1.12u l=0.13u
X368 a_24008_949# DELAY_OUT_TAP26 VSS.t1 VSS.t0 sg13_lv_nmos ad=0.1406p pd=1.12u as=0.2516p ps=2.16u w=0.74u l=0.13u
X369 a_15964_194# MUX_SEL4 a_5731_194# VDD sg13_lv_pmos ad=0.3304p pd=1.71u as=0.3808p ps=2.92u w=1.12u l=0.13u
X370 a_1256_949# MUX_SEL0 VSS.t169 VSS.t168 sg13_lv_nmos ad=0.2516p pd=2.16u as=0.2516p ps=2.16u w=0.74u l=0.13u
X371 a_22488_949# DELAY_OUT_TAP24 VDD VDD sg13_lv_pmos ad=0.2128p pd=1.5u as=0.3808p ps=2.92u w=1.12u l=0.13u
X372 a_16510_949# a_18871_913# a_18795_949# VDD sg13_lv_pmos ad=0.3808p pd=2.92u as=0.2128p ps=1.5u w=1.12u l=0.13u
X373 a_27048_949# DELAY_OUT_TAP30 VDD VDD sg13_lv_pmos ad=0.2128p pd=1.5u as=0.3808p ps=2.92u w=1.12u l=0.13u
X374 a_13470_949# a_14311_913# a_14235_949# VDD sg13_lv_pmos ad=0.3808p pd=2.92u as=0.2128p ps=1.5u w=1.12u l=0.13u
X375 a_13470_949# a_3171_952.t6 a_14888_949# VSS.t287 sg13_lv_nmos ad=0.2516p pd=2.16u as=0.1406p ps=1.12u w=0.74u l=0.13u
X376 a_1256_194# MUX_SEL2 VSS.t326 VSS.t325 sg13_lv_nmos ad=0.2516p pd=2.16u as=0.2516p ps=2.16u w=0.74u l=0.13u
X377 a_9675_949# a_9465_949# VDD VDD sg13_lv_pmos ad=0.2128p pd=1.5u as=0.252p ps=1.57u w=1.12u l=0.13u
X378 VSS.t39 a_2019_952.t2 a_25604_913# VSS.t38 sg13_lv_nmos ad=0.2516p pd=2.16u as=0.2516p ps=2.16u w=0.74u l=0.13u
X379 a_16108_194# MUX_SEL4 a_15964_194# VSS.t115 sg13_lv_nmos ad=0.2516p pd=2.16u as=0.2183p ps=1.33u w=0.74u l=0.13u
X380 a_21835_949# a_21625_949# VSS.t30 VSS.t150 sg13_lv_nmos ad=0.1406p pd=1.12u as=0.1665p ps=1.19u w=0.74u l=0.13u
X381 VSS.t36 a_2595_952.t4 a_20391_913# VSS.t35 sg13_lv_nmos ad=0.2516p pd=2.16u as=0.2516p ps=2.16u w=0.74u l=0.13u
X382 a_2019_952.t1 a_1721_1300# VDD VDD sg13_lv_pmos ad=0.2128p pd=1.5u as=0.1918p ps=1.5u w=1.12u l=0.13u
X383 VSS.t138 DELAY_OUT_TAP9 a_10985_949# VSS.t283 sg13_lv_nmos ad=0.1665p pd=1.19u as=0.2516p ps=2.16u w=0.74u l=0.13u
X384 a_7390_949# a_9751_913# a_9675_949# VDD sg13_lv_pmos ad=0.3808p pd=2.92u as=0.2128p ps=1.5u w=1.12u l=0.13u
X385 VSS.t237 VDD VSS.t236 VSS.t235 sg13_lv_nmos ad=0.1428p pd=1.52u as=0 ps=0 w=0.42u l=1u
X386 VDD a_3171_216.t2 a_23945_424# VDD sg13_lv_pmos ad=0.3808p pd=2.92u as=0.3808p ps=2.92u w=1.12u l=0.13u
X387 VSS.t319 a_3747_952.t5 a_18871_913# VSS.t318 sg13_lv_nmos ad=0.2516p pd=2.16u as=0.2516p ps=2.16u w=0.74u l=0.13u
X388 a_12715_949# a_12505_949# VSS.t154 VSS.t153 sg13_lv_nmos ad=0.1406p pd=1.12u as=0.1665p ps=1.19u w=0.74u l=0.13u
X389 a_17928_949# DELAY_OUT_TAP18 VSS.t291 VSS.t290 sg13_lv_nmos ad=0.1406p pd=1.12u as=0.2516p ps=2.16u w=0.74u l=0.13u
X390 VDD MUX_SEL4 a_15765_368# VDD sg13_lv_pmos ad=0.3808p pd=2.92u as=0.3808p ps=2.92u w=1.12u l=0.13u
X391 a_19550_949# a_3171_952.t4 a_20968_949# VSS.t13 sg13_lv_nmos ad=0.2516p pd=2.16u as=0.1406p ps=1.12u w=0.74u l=0.13u
X392 a_7288_949# DELAY_OUT_TAP4 VSS.t173 VSS.t172 sg13_lv_nmos ad=0.1406p pd=1.12u as=0.2516p ps=2.16u w=0.74u l=0.13u
X393 a_1815_236# a_1256_194# a_1721_236# VSS.t83 sg13_lv_nmos ad=0.1216p pd=1.02u as=0.2176p ps=1.96u w=0.64u l=0.13u
X394 a_1544_194# MUX_SEL3 VSS.t3 VSS.t2 sg13_lv_nmos ad=0.2516p pd=2.16u as=0.2516p ps=2.16u w=0.74u l=0.13u
X395 a_22590_949# a_3747_952.t3 a_24875_949# VSS.t314 sg13_lv_nmos ad=0.2516p pd=2.16u as=0.1406p ps=1.12u w=0.74u l=0.13u
X396 VDD DELAY_OUT_TAP23 a_21625_949# VDD sg13_lv_pmos ad=0.252p pd=1.57u as=0.3808p ps=2.92u w=1.12u l=0.13u
X397 a_22590_949# a_22564_913# a_22488_949# VDD sg13_lv_pmos ad=0.3808p pd=2.92u as=0.2128p ps=1.5u w=1.12u l=0.13u
X398 VSS.t17 DELAY_OUT_TAP29 a_26185_949# VSS.t16 sg13_lv_nmos ad=0.1665p pd=1.19u as=0.2516p ps=2.16u w=0.74u l=0.13u
X399 VSS.t207 VDD VSS.t206 VSS.t205 sg13_lv_nmos ad=0.1428p pd=1.52u as=0 ps=0 w=0.42u l=1u
X400 VDD DELAY_OUT_TAP29 a_26185_949# VDD sg13_lv_pmos ad=0.252p pd=1.57u as=0.3808p ps=2.92u w=1.12u l=0.13u
X401 VSS.t145 DELAY_OUT_TAP1 a_4905_949# VSS.t182 sg13_lv_nmos ad=0.1665p pd=1.19u as=0.2516p ps=2.16u w=0.74u l=0.13u
X402 a_25630_949# a_27124_913# a_27048_949# VDD sg13_lv_pmos ad=0.3808p pd=2.92u as=0.2128p ps=1.5u w=1.12u l=0.13u
X403 VDD VSS.t364 VDD VDD sg13_lv_pmos ad=0.34p pd=2.68u as=0 ps=0 w=1u l=1u
X404 VDD a_2019_952.t6 a_13444_913# VDD sg13_lv_pmos ad=0.3808p pd=2.92u as=0.3808p ps=2.92u w=1.12u l=0.13u
X405 VSS.t126 a_3171_952.t8 a_8884_913# VSS.t125 sg13_lv_nmos ad=0.2516p pd=2.16u as=0.2516p ps=2.16u w=0.74u l=0.13u
X406 VDD VSS.t378 VDD VDD sg13_lv_pmos ad=0.34p pd=2.68u as=0 ps=0 w=1u l=1u
X407 VDD VSS.t373 VDD VDD sg13_lv_pmos ad=0.19p pd=1.38u as=0 ps=0 w=1u l=1u
X408 VSS.t10 a_1544_194# a_1815_236# VSS.t9 sg13_lv_nmos ad=0.1331p pd=1.12u as=0.1216p ps=1.02u w=0.64u l=0.13u
X409 VDD a_3171_952.t5 a_18004_913# VDD sg13_lv_pmos ad=0.3808p pd=2.92u as=0.3808p ps=2.92u w=1.12u l=0.13u
X410 VSS.t147 MUX_SEL1 a_3543_1300# VSS.t178 sg13_lv_nmos ad=0.1331p pd=1.12u as=0.1216p ps=1.02u w=0.64u l=0.13u
X411 a_27915_949# a_27705_949# VSS.t47 VSS.t155 sg13_lv_nmos ad=0.1406p pd=1.12u as=0.1665p ps=1.19u w=0.74u l=0.13u
X412 VSS.t279 VDD VSS.t277 VSS.t278 sg13_lv_nmos ad=79.8f pd=0.8u as=0 ps=0 w=0.42u l=1u
X413 a_24875_949# a_24665_949# VDD VDD sg13_lv_pmos ad=0.2128p pd=1.5u as=0.252p ps=1.57u w=1.12u l=0.13u
C0 a_27124_913# VDD 0.28225f
C1 DELAY_OUT_TAP9 DELAY_OUT_TAP10 0.02068f
C2 a_10985_949# VDD 0.30333f
C3 a_26471_913# a_26395_949# 0.01194f
C4 a_7945_949# VDD 0.30333f
C5 a_15765_368# MUX_SEL4 0.65508f
C6 a_4350_949# DELAY_OUT_TAP1 0.10838f
C7 DELAY_OUT_TAP0 a_3449_1300# 0.01044f
C8 DELAY_OUT_TAP11 a_11924_913# 0.02053f
C9 a_1721_236# MUX_SEL4 0.05813f
C10 a_10430_949# a_11271_913# 0.28268f
C11 a_26395_949# VDD 0.15389f
C12 VDD a_14964_913# 0.28225f
C13 a_22488_949# a_22564_913# 0.01176f
C14 a_20315_949# VDD 0.15389f
C15 DELAY_OUT_TAP10 VDD 0.13878f
C16 a_13470_949# a_15755_949# 0.39036f
C17 a_1544_194# MUX_SEL4 0.47529f
C18 a_15545_949# a_15831_913# 0.01885f
C19 a_20315_949# a_20391_913# 0.01194f
C20 a_20315_949# a_19550_949# 0.39037f
C21 a_5731_194# a_11785_424# 0.28056f
C22 a_15765_368# a_15964_194# 0.061f
C23 a_22488_949# a_22590_949# 0.37183f
C24 a_6635_949# a_6711_913# 0.01194f
C25 a_7364_913# DELAY_OUT_TAP5 0.0501f
C26 a_16408_949# DELAY_OUT_TAP16 0.10864f
C27 a_4905_949# DELAY_OUT_TAP1 0.19203f
C28 a_25630_949# a_27915_949# 0.39036f
C29 a_10430_949# a_12791_913# 0.26208f
C30 a_7390_949# MUX_SEL4 0.34655f
C31 a_25630_949# DELAY_OUT_TAP31 0.05211f
C32 DELAY_OUT_TAP7 a_9465_949# 0.2079f
C33 a_13444_913# a_13368_949# 0.01176f
C34 DELAY_OUT_TAP15 VDD 0.12874f
C35 DELAY_OUT_TAP2 DELAY_OUT_TAP3 0.03717f
C36 a_12791_913# a_12505_949# 0.01885f
C37 MUX_SEL1 a_2297_1300# 0.01995f
C38 a_10430_949# a_12715_949# 0.39036f
C39 DELAY_OUT_TAP26 a_23431_913# 0.02334f
C40 a_26185_949# a_26471_913# 0.01885f
C41 DELAY_OUT_TAP16 a_13470_949# 0.02437f
C42 a_22564_913# VDD 0.28633f
C43 DELAY_OUT_TAP17 a_16484_913# 0.0501f
C44 a_23945_424# a_22590_949# 0.02165f
C45 VDD MUX_SEL4 2.63157f
C46 a_12715_949# a_12505_949# 0.09424f
C47 a_20968_949# DELAY_OUT_TAP22 0.10863f
C48 VDD a_1256_949# 0.47094f
C49 a_2297_236# MUX_SEL2 0.10655f
C50 a_5191_913# VDD 0.28565f
C51 a_1544_194# a_1721_236# 0.36963f
C52 VDD DELAY_OUT_TAP22 0.13878f
C53 a_26185_949# VDD 0.30333f
C54 DELAY_OUT_TAP17 a_16510_949# 0.10838f
C55 a_14888_949# a_14964_913# 0.01176f
C56 a_22590_949# VDD 0.89557f
C57 a_5705_424# VDD 0.29556f
C58 a_9465_949# a_9675_949# 0.09424f
C59 DELAY_OUT_TAP0 a_4157_1218# 0.50642f
C60 a_20391_913# DELAY_OUT_TAP22 0.02334f
C61 a_19550_949# DELAY_OUT_TAP22 0.07996f
C62 a_5115_949# a_5191_913# 0.01194f
C63 MUX_SEL1 DELAY_OUT_TAP0 0.01783f
C64 a_3449_236# MUX_SEL4 0.05166f
C65 a_15964_194# VDD 0.31311f
C66 a_6711_913# VDD 0.2822f
C67 MUX_SEL2 a_1256_194# 0.33134f
C68 a_9675_949# a_9751_913# 0.01194f
C69 a_10430_949# a_11785_424# 0.02058f
C70 DELAY_OUT_TAP21 DELAY_OUT_TAP22 0.02068f
C71 VDD a_18585_949# 0.29646f
C72 DELAY_OUT_TAP20 a_19524_913# 0.02011f
C73 a_1721_1300# a_1256_949# 0.13421f
C74 a_2873_1300# MUX_SEL1 0.13092f
C75 a_15765_368# VDD 0.35368f
C76 a_6635_949# VDD 0.15406f
C77 a_16851_214# a_16510_949# 0.02131f
C78 a_1721_236# VDD 0.45259f
C79 DELAY_OUT_TAP8 MUX_SEL4 0.01829f
C80 a_4157_1218# a_2019_216# 0.01018f
C81 a_27048_949# DELAY_OUT_TAP30 0.10863f
C82 a_15831_913# a_15755_949# 0.01194f
C83 a_25630_949# a_16108_194# 0.52614f
C84 a_27705_949# a_25630_949# 0.03208f
C85 a_22488_949# VDD 0.17274f
C86 a_10430_949# a_11924_913# 0.28279f
C87 a_1544_194# VDD 0.39113f
C88 a_2873_236# MUX_SEL3 0.12606f
C89 DELAY_OUT_TAP20 VDD 0.14794f
C90 a_2019_216# a_16510_949# 0.03139f
C91 a_26471_913# DELAY_OUT_TAP30 0.02334f
C92 a_10430_949# a_11195_949# 0.39037f
C93 a_25604_913# VDD 0.28633f
C94 a_27048_949# VDD 0.17499f
C95 a_19524_913# VDD 0.28633f
C96 DELAY_OUT_TAP9 VDD 0.13651f
C97 a_10985_949# a_11271_913# 0.01885f
C98 a_13470_949# a_14964_913# 0.28279f
C99 DELAY_OUT_TAP11 DELAY_OUT_TAP12 0.0331f
C100 a_4248_949# a_4157_1218# 0.11672f
C101 a_26985_424# VDD 0.29292f
C102 VDD DELAY_OUT_TAP30 0.13878f
C103 a_19524_913# a_19550_949# 0.277f
C104 a_7390_949# VDD 0.8686f
C105 a_26471_913# VDD 0.28336f
C106 MUX_SEL0 MUX_SEL2 0.01204f
C107 DELAY_OUT_TAP20 DELAY_OUT_TAP21 0.06596f
C108 a_20315_949# a_20105_949# 0.09424f
C109 a_13444_913# DELAY_OUT_TAP13 0.0501f
C110 VDD a_17351_913# 0.28565f
C111 a_25528_949# DELAY_OUT_TAP28 0.10864f
C112 a_15831_913# DELAY_OUT_TAP16 0.02339f
C113 a_23945_424# VDD 0.29292f
C114 a_4157_1218# DELAY_OUT_TAP1 0.01771f
C115 a_25630_949# a_27124_913# 0.28279f
C116 a_20968_949# VDD 0.17499f
C117 a_19524_913# DELAY_OUT_TAP21 0.0501f
C118 a_2297_236# a_2019_216# 0.04011f
C119 a_14025_949# DELAY_OUT_TAP13 0.19203f
C120 DELAY_OUT_TAP10 a_11271_913# 0.02334f
C121 a_20968_949# a_19550_949# 0.38994f
C122 a_4350_949# MUX_SEL4 0.31434f
C123 MUX_SEL0 a_2297_1300# 0.10655f
C124 a_26185_949# DELAY_OUT_TAP29 0.19203f
C125 a_5191_913# a_4350_949# 0.28268f
C126 a_20391_913# VDD 0.28336f
C127 a_19550_949# VDD 0.89766f
C128 DELAY_OUT_TAP19 a_18585_949# 0.2079f
C129 a_14825_424# MUX_SEL4 0.03307f
C130 a_6425_949# a_6711_913# 0.01885f
C131 DELAY_OUT_TAP15 a_13470_949# 0.05189f
C132 a_25630_949# a_26395_949# 0.39037f
C133 VDD a_21625_949# 0.29646f
C134 a_5705_424# a_4350_949# 0.02005f
C135 a_20391_913# a_19550_949# 0.28268f
C136 a_18871_913# a_18585_949# 0.01885f
C137 a_2019_216# a_1256_194# 0.02904f
C138 a_5115_949# VDD 0.15389f
C139 DELAY_OUT_TAP8 DELAY_OUT_TAP9 0.06596f
C140 a_19550_949# a_21625_949# 0.03208f
C141 a_13470_949# MUX_SEL4 0.256f
C142 VDD DELAY_OUT_TAP21 0.13651f
C143 DELAY_OUT_TAP16 a_16484_913# 0.02011f
C144 a_6425_949# a_6635_949# 0.09424f
C145 a_3449_236# VDD 0.46596f
C146 DELAY_OUT_TAP8 a_7390_949# 0.02437f
C147 a_18795_949# a_18585_949# 0.09424f
C148 a_4350_949# a_6711_913# 0.26208f
C149 a_19550_949# DELAY_OUT_TAP21 0.10838f
C150 a_13444_913# DELAY_OUT_TAP12 0.02011f
C151 a_1721_1300# VDD 0.45305f
C152 a_18004_913# VDD 0.28225f
C153 a_17351_913# a_17065_949# 0.01885f
C154 DELAY_OUT_TAP19 DELAY_OUT_TAP20 0.0331f
C155 a_5191_913# a_4905_949# 0.01885f
C156 a_4350_949# a_6635_949# 0.39036f
C157 DELAY_OUT_TAP20 a_18871_913# 0.02339f
C158 VDD a_17065_949# 0.30142f
C159 DELAY_OUT_TAP8 VDD 0.1474f
C160 MUX_SEL1 MUX_OUT 0.09357f
C161 MUX_SEL1 a_1544_949# 0.1672f
C162 DELAY_OUT_TAP4 MUX_SEL4 0.0195f
C163 a_2873_1300# MUX_SEL0 0.01504f
C164 a_20905_424# a_16108_194# 0.2906f
C165 a_14888_949# VDD 0.17499f
C166 a_16108_194# a_16510_949# 0.56108f
C167 a_25604_913# DELAY_OUT_TAP29 0.0501f
C168 a_17865_424# a_2019_216# 0.13959f
C169 a_21911_913# VDD 0.2822f
C170 a_26185_949# a_25630_949# 0.03209f
C171 a_14311_913# VDD 0.28336f
C172 a_10430_949# a_11848_949# 0.38994f
C173 a_5731_194# a_8745_424# 0.28635f
C174 DELAY_OUT_TAP14 a_14964_913# 0.02312f
C175 a_2297_236# MUX_SEL3 0.01595f
C176 DELAY_OUT_TAP29 DELAY_OUT_TAP30 0.02068f
C177 DELAY_OUT_TAP19 VDD 0.12759f
C178 a_7288_949# a_7390_949# 0.37183f
C179 a_19550_949# a_21911_913# 0.26208f
C180 a_6711_913# DELAY_OUT_TAP4 0.02339f
C181 a_21044_913# DELAY_OUT_TAP23 0.02053f
C182 a_2297_236# MUX_OUT 0.01179f
C183 a_2873_236# MUX_SEL4 0.04916f
C184 a_18871_913# VDD 0.2822f
C185 a_6425_949# VDD 0.29646f
C186 DELAY_OUT_TAP20 a_19448_949# 0.10864f
C187 a_5844_913# VDD 0.28225f
C188 a_21911_913# a_21625_949# 0.01885f
C189 DELAY_OUT_TAP17 DELAY_OUT_TAP18 0.02068f
C190 a_4324_913# VDD 0.28597f
C191 a_10430_949# DELAY_OUT_TAP12 0.02437f
C192 a_10985_949# a_11195_949# 0.09424f
C193 a_17275_949# a_17351_913# 0.01194f
C194 DELAY_OUT_TAP23 DELAY_OUT_TAP24 0.0331f
C195 a_19524_913# a_19448_949# 0.01176f
C196 a_7288_949# VDD 0.17274f
C197 VDD DELAY_OUT_TAP29 0.13651f
C198 a_18795_949# VDD 0.15406f
C199 a_23431_913# a_23145_949# 0.01885f
C200 MUX_SEL3 a_1256_194# 1.41161f
C201 a_16408_949# VDD 0.17274f
C202 VDD a_17275_949# 0.15389f
C203 a_24084_913# DELAY_OUT_TAP26 0.02312f
C204 a_4350_949# VDD 0.87635f
C205 a_14025_949# a_14235_949# 0.09424f
C206 MUX_OUT a_1256_194# 0.1134f
C207 VDD a_14825_424# 0.29292f
C208 DELAY_OUT_TAP10 a_11924_913# 0.02312f
C209 DELAY_OUT_TAP14 DELAY_OUT_TAP15 0.03717f
C210 DELAY_OUT_TAP19 a_18004_913# 0.02053f
C211 a_7945_949# a_8231_913# 0.01885f
C212 a_13470_949# VDD 0.87936f
C213 a_5115_949# a_4350_949# 0.39037f
C214 a_19448_949# VDD 0.17274f
C215 a_11785_424# MUX_SEL4 0.03255f
C216 a_25630_949# a_25604_913# 0.277f
C217 VDD a_20105_949# 0.30333f
C218 a_25630_949# a_27048_949# 0.38994f
C219 a_19448_949# a_19550_949# 0.37183f
C220 a_7945_949# a_8155_949# 0.09424f
C221 a_20391_913# a_20105_949# 0.01885f
C222 a_25630_949# a_26985_424# 0.02195f
C223 a_19550_949# a_20105_949# 0.03209f
C224 a_4905_949# VDD 0.3005f
C225 a_25630_949# DELAY_OUT_TAP30 0.07996f
C226 a_11271_913# VDD 0.28336f
C227 a_25630_949# a_26471_913# 0.28268f
C228 DELAY_OUT_TAP7 a_7390_949# 0.05189f
C229 DELAY_OUT_TAP25 DELAY_OUT_TAP24 0.06596f
C230 a_17928_949# VDD 0.17499f
C231 a_17275_949# a_17065_949# 0.09424f
C232 a_4157_1218# MUX_SEL4 0.08229f
C233 DELAY_OUT_TAP21 a_20105_949# 0.19203f
C234 VDD DELAY_OUT_TAP4 0.14695f
C235 a_27915_949# a_27991_913# 0.01194f
C236 a_5115_949# a_4905_949# 0.09424f
C237 a_25630_949# VDD 0.89531f
C238 DELAY_OUT_TAP7 VDD 0.12759f
C239 MUX_SEL1 MUX_SEL4 0.03574f
C240 MUX_SEL0 a_1544_949# 0.07603f
C241 MUX_SEL1 a_1256_949# 1.44243f
C242 a_17865_424# a_16108_194# 0.29564f
C243 a_12791_913# VDD 0.2822f
C244 a_9675_949# a_7390_949# 0.39036f
C245 a_3449_1300# VDD 0.46654f
C246 a_14888_949# a_13470_949# 0.38994f
C247 a_18795_949# a_18871_913# 0.01194f
C248 a_2873_236# VDD 0.46491f
C249 a_17928_949# a_18004_913# 0.01176f
C250 a_12715_949# VDD 0.15406f
C251 a_4350_949# a_6425_949# 0.03208f
C252 a_5844_913# a_4350_949# 0.28279f
C253 a_15964_194# a_16510_949# 0.05416f
C254 a_4350_949# a_4324_913# 0.277f
C255 a_14311_913# a_13470_949# 0.28268f
C256 a_9675_949# VDD 0.15406f
C257 a_16510_949# a_18585_949# 0.03208f
C258 a_2297_236# MUX_SEL4 0.04338f
C259 a_5768_949# VDD 0.17499f
C260 a_7945_949# DELAY_OUT_TAP5 0.19203f
C261 DELAY_OUT_TAP25 DELAY_OUT_TAP26 0.02068f
C262 a_10430_949# DELAY_OUT_TAP11 0.05189f
C263 DELAY_OUT_TAP7 DELAY_OUT_TAP8 0.0331f
C264 a_23431_913# a_22590_949# 0.28268f
C265 a_23355_949# a_23145_949# 0.09424f
C266 a_15831_913# VDD 0.2816f
C267 a_12505_949# DELAY_OUT_TAP11 0.2079f
C268 a_24008_949# DELAY_OUT_TAP26 0.10863f
C269 MUX_SEL4 a_1256_194# 0.65005f
C270 DELAY_OUT_TAP14 VDD 0.13878f
C271 a_10404_913# a_10328_949# 0.01176f
C272 VDD a_11785_424# 0.29292f
C273 DELAY_OUT_TAP20 a_16510_949# 0.02437f
C274 DELAY_OUT_TAP10 a_11848_949# 0.10863f
C275 a_13470_949# a_14825_424# 0.02058f
C276 a_24008_949# a_24084_913# 0.01176f
C277 a_7390_949# DELAY_OUT_TAP6 0.07996f
C278 a_27705_949# a_27991_913# 0.01885f
C279 a_10430_949# a_10328_949# 0.37183f
C280 a_13368_949# VDD 0.17274f
C281 a_16108_194# DELAY_OUT_TAP24 0.0157f
C282 a_4905_949# a_4350_949# 0.03209f
C283 a_25528_949# a_25604_913# 0.01176f
C284 a_5731_194# a_2019_216# 1.15781f
C285 a_8808_949# a_7390_949# 0.38994f
C286 a_7288_949# DELAY_OUT_TAP4 0.10864f
C287 VDD DELAY_OUT_TAP6 0.13878f
C288 a_17351_913# a_16510_949# 0.28268f
C289 VDD a_11924_913# 0.28225f
C290 VDD a_16484_913# 0.28597f
C291 a_4157_1218# VDD 0.48906f
C292 a_4350_949# DELAY_OUT_TAP4 0.02437f
C293 a_10430_949# a_5731_194# 0.41176f
C294 a_25630_949# DELAY_OUT_TAP29 0.10838f
C295 a_20905_424# VDD 0.29292f
C296 a_11195_949# VDD 0.15389f
C297 a_8231_913# a_7390_949# 0.28268f
C298 a_2297_236# a_1544_194# 0.27303f
C299 MUX_SEL1 VDD 0.49936f
C300 VDD a_16510_949# 0.8795f
C301 a_19550_949# a_20905_424# 0.02165f
C302 a_8808_949# VDD 0.17499f
C303 DELAY_OUT_TAP1 DELAY_OUT_TAP2 0.02068f
C304 VDD DELAY_OUT_TAP3 0.12759f
C305 a_1721_236# a_1256_194# 0.13421f
C306 a_25528_949# VDD 0.17274f
C307 a_8231_913# VDD 0.28336f
C308 a_14888_949# DELAY_OUT_TAP14 0.10863f
C309 MUX_SEL0 a_1256_949# 0.3314f
C310 a_8155_949# a_7390_949# 0.39037f
C311 a_1544_194# a_1256_194# 1.25711f
C312 MUX_SEL4 DELAY_OUT_TAP12 0.01829f
C313 a_5768_949# a_5844_913# 0.01176f
C314 a_2019_216# a_16851_214# 0.01299f
C315 a_8884_913# a_7390_949# 0.28279f
C316 MUX_SEL3 MUX_SEL2 3.21891f
C317 a_15545_949# a_15755_949# 0.09424f
C318 a_14311_913# DELAY_OUT_TAP14 0.02334f
C319 a_18004_913# a_16510_949# 0.28279f
C320 a_2297_236# VDD 0.46496f
C321 a_8155_949# VDD 0.15389f
C322 MUX_OUT MUX_SEL2 0.08497f
C323 a_23431_913# VDD 0.28336f
C324 a_5768_949# a_4350_949# 0.38994f
C325 DELAY_OUT_TAP0 DELAY_OUT_TAP1 0.04252f
C326 a_10430_949# a_10404_913# 0.277f
C327 a_8884_913# VDD 0.28225f
C328 a_16510_949# a_17065_949# 0.03209f
C329 a_21835_949# VDD 0.15406f
C330 VDD a_1256_194# 0.40292f
C331 a_2297_1300# a_1544_949# 0.28651f
C332 a_21835_949# a_19550_949# 0.39036f
C333 DELAY_OUT_TAP26 DELAY_OUT_TAP27 0.03717f
C334 a_23355_949# a_22590_949# 0.39037f
C335 DELAY_OUT_TAP16 DELAY_OUT_TAP17 0.06596f
C336 a_21835_949# a_21625_949# 0.09424f
C337 a_10430_949# a_12505_949# 0.03208f
C338 a_5731_194# MUX_OUT 1.04829f
C339 a_24951_913# DELAY_OUT_TAP28 0.02339f
C340 a_8745_424# MUX_SEL4 0.04472f
C341 DELAY_OUT_TAP13 VDD 0.13651f
C342 a_15831_913# a_13470_949# 0.26208f
C343 a_21044_913# DELAY_OUT_TAP22 0.02312f
C344 DELAY_OUT_TAP19 a_16510_949# 0.05189f
C345 a_24084_913# DELAY_OUT_TAP27 0.02053f
C346 a_22564_913# DELAY_OUT_TAP24 0.02011f
C347 a_4157_1218# a_4324_913# 0.02463f
C348 DELAY_OUT_TAP14 a_13470_949# 0.07996f
C349 a_5731_194# a_16108_194# 0.01334f
C350 a_24875_949# a_24951_913# 0.01194f
C351 a_7390_949# DELAY_OUT_TAP5 0.10838f
C352 a_18871_913# a_16510_949# 0.26208f
C353 a_16408_949# a_16484_913# 0.01176f
C354 a_6425_949# DELAY_OUT_TAP3 0.2079f
C355 a_5844_913# DELAY_OUT_TAP3 0.02053f
C356 a_4157_1218# a_4350_949# 0.04624f
C357 a_12715_949# a_12791_913# 0.01194f
C358 DELAY_OUT_TAP10 DELAY_OUT_TAP11 0.03717f
C359 a_13368_949# a_13470_949# 0.37183f
C360 a_18795_949# a_16510_949# 0.39036f
C361 a_9465_949# a_9751_913# 0.01885f
C362 a_16408_949# a_16510_949# 0.37183f
C363 VDD DELAY_OUT_TAP5 0.13651f
C364 VDD a_11848_949# 0.17499f
C365 a_17275_949# a_16510_949# 0.39037f
C366 a_4350_949# DELAY_OUT_TAP3 0.05189f
C367 a_17865_424# VDD 0.29444f
C368 a_16851_214# MUX_OUT 0.45865f
C369 MUX_SEL0 VDD 0.51342f
C370 MUX_SEL3 a_2019_216# 0.06209f
C371 VDD DELAY_OUT_TAP12 0.1474f
C372 a_16108_194# a_16851_214# 0.06181f
C373 a_21835_949# a_21911_913# 0.01194f
C374 a_2019_216# MUX_OUT 8.45486f
C375 a_7364_913# a_7390_949# 0.277f
C376 a_22488_949# DELAY_OUT_TAP24 0.10864f
C377 a_11195_949# a_11271_913# 0.01194f
C378 a_2019_216# a_16108_194# 0.33889f
C379 a_24951_913# a_24665_949# 0.01885f
C380 DELAY_OUT_TAP26 a_22590_949# 0.07996f
C381 DELAY_OUT_TAP25 a_23145_949# 0.19203f
C382 a_1721_1300# MUX_SEL0 0.01315f
C383 DELAY_OUT_TAP7 DELAY_OUT_TAP6 0.03717f
C384 a_8745_424# a_7390_949# 0.01756f
C385 a_17928_949# a_16510_949# 0.38994f
C386 MUX_SEL4 MUX_SEL2 0.01978f
C387 a_7364_913# VDD 0.28633f
C388 a_23355_949# VDD 0.15389f
C389 a_24875_949# a_24665_949# 0.09424f
C390 a_16108_194# DELAY_OUT_TAP28 0.0157f
C391 DELAY_OUT_TAP3 DELAY_OUT_TAP4 0.0331f
C392 a_27705_949# a_27915_949# 0.09424f
C393 a_24084_913# a_22590_949# 0.28279f
C394 a_20968_949# a_21044_913# 0.01176f
C395 a_27705_949# DELAY_OUT_TAP31 0.2079f
C396 a_17351_913# DELAY_OUT_TAP18 0.02334f
C397 a_21044_913# VDD 0.28225f
C398 a_8745_424# VDD 0.29292f
C399 a_5191_913# DELAY_OUT_TAP2 0.02334f
C400 a_25528_949# a_25630_949# 0.37183f
C401 VDD a_27991_913# 0.28201f
C402 a_2297_1300# a_1256_949# 0.04619f
C403 a_21044_913# a_19550_949# 0.28279f
C404 VDD DELAY_OUT_TAP18 0.13878f
C405 VDD DELAY_OUT_TAP24 0.14794f
C406 a_14235_949# VDD 0.15389f
C407 MUX_SEL1 a_3449_1300# 0.29404f
C408 a_15545_949# DELAY_OUT_TAP15 0.2079f
C409 a_10430_949# a_10985_949# 0.03209f
C410 a_5731_194# MUX_SEL4 4.60702f
C411 DELAY_OUT_TAP27 DELAY_OUT_TAP28 0.0331f
C412 a_19550_949# DELAY_OUT_TAP24 0.02437f
C413 DELAY_OUT_TAP13 a_13470_949# 0.10838f
C414 a_5731_194# a_5705_424# 0.28954f
C415 a_27124_913# DELAY_OUT_TAP31 0.02053f
C416 a_1721_236# MUX_SEL2 0.01315f
C417 DELAY_OUT_TAP22 DELAY_OUT_TAP23 0.03717f
C418 DELAY_OUT_TAP0 MUX_SEL4 0.06593f
C419 MUX_SEL3 MUX_OUT 0.79533f
C420 DELAY_OUT_TAP7 a_8884_913# 0.02053f
C421 a_10430_949# DELAY_OUT_TAP10 0.07996f
C422 a_1544_194# MUX_SEL2 0.07405f
C423 a_18004_913# DELAY_OUT_TAP18 0.02312f
C424 a_5731_194# a_15964_194# 0.2778f
C425 MUX_OUT a_1544_949# 0.04258f
C426 a_2873_1300# a_1256_949# 0.28892f
C427 a_5731_194# a_15765_368# 0.23301f
C428 a_16108_194# MUX_OUT 0.24265f
C429 DELAY_OUT_TAP26 VDD 0.13878f
C430 VDD DELAY_OUT_TAP11 0.12759f
C431 a_2873_236# a_1256_194# 0.27926f
C432 a_2019_216# MUX_SEL4 0.90276f
C433 a_7364_913# a_7288_949# 0.01176f
C434 DELAY_OUT_TAP25 a_22564_913# 0.0501f
C435 a_24084_913# VDD 0.28225f
C436 a_14235_949# a_14311_913# 0.01194f
C437 a_21911_913# DELAY_OUT_TAP24 0.02339f
C438 VDD MUX_SEL2 0.50938f
C439 a_16510_949# a_16484_913# 0.277f
C440 a_10430_949# MUX_SEL4 0.24983f
C441 a_8808_949# DELAY_OUT_TAP6 0.10863f
C442 DELAY_OUT_TAP19 DELAY_OUT_TAP18 0.03717f
C443 a_15964_194# a_16851_214# 0.16757f
C444 a_5705_424# a_2019_216# 0.13872f
C445 DELAY_OUT_TAP4 DELAY_OUT_TAP5 0.06596f
C446 a_24665_949# DELAY_OUT_TAP27 0.2079f
C447 DELAY_OUT_TAP25 a_22590_949# 0.10838f
C448 a_10328_949# VDD 0.17274f
C449 a_8231_913# DELAY_OUT_TAP6 0.02334f
C450 a_5731_194# a_7390_949# 0.41331f
C451 DELAY_OUT_TAP2 VDD 0.13878f
C452 a_24951_913# a_22590_949# 0.26208f
C453 a_22590_949# DELAY_OUT_TAP28 0.02437f
C454 a_15964_194# a_2019_216# 0.02413f
C455 a_2297_1300# VDD 0.4651f
C456 a_24008_949# a_22590_949# 0.38994f
C457 a_3449_236# MUX_SEL2 0.10741f
C458 a_24875_949# a_22590_949# 0.39036f
C459 a_15765_368# a_2019_216# 0.05969f
C460 a_5731_194# VDD 0.6143f
C461 a_2019_216# a_1721_236# 0.18452f
C462 VDD DELAY_OUT_TAP17 0.1382f
C463 a_12791_913# DELAY_OUT_TAP12 0.02339f
C464 a_15545_949# VDD 0.29842f
C465 a_13444_913# VDD 0.28633f
C466 VDD DELAY_OUT_TAP23 0.12759f
C467 DELAY_OUT_TAP13 DELAY_OUT_TAP14 0.02068f
C468 MUX_SEL0 a_3449_1300# 0.10753f
C469 a_8884_913# DELAY_OUT_TAP6 0.02312f
C470 a_14235_949# a_13470_949# 0.39037f
C471 a_19550_949# DELAY_OUT_TAP23 0.05189f
C472 a_7364_913# DELAY_OUT_TAP4 0.02011f
C473 a_2019_216# a_1544_194# 0.01747f
C474 a_14025_949# VDD 0.30333f
C475 DELAY_OUT_TAP0 VDD 0.50967f
C476 DELAY_OUT_TAP23 a_21625_949# 0.2079f
C477 DELAY_OUT_TAP15 DELAY_OUT_TAP16 0.0331f
C478 a_8884_913# a_8808_949# 0.01176f
C479 a_10404_913# DELAY_OUT_TAP9 0.0501f
C480 DELAY_OUT_TAP8 a_10328_949# 0.10864f
C481 a_8155_949# a_8231_913# 0.01194f
C482 a_2873_1300# VDD 0.46491f
C483 MUX_SEL3 MUX_SEL4 0.75489f
C484 a_25604_913# DELAY_OUT_TAP28 0.02011f
C485 a_10430_949# DELAY_OUT_TAP9 0.10838f
C486 a_16851_214# VDD 0.51536f
C487 a_17928_949# DELAY_OUT_TAP18 0.10863f
C488 MUX_SEL4 MUX_OUT 0.91933f
C489 MUX_SEL4 a_1544_949# 0.03407f
C490 MUX_OUT a_1256_949# 0.02466f
C491 a_1256_949# a_1544_949# 1.26509f
C492 a_3449_236# DELAY_OUT_TAP0 0.01017f
C493 a_25630_949# a_27991_913# 0.26208f
C494 a_10404_913# VDD 0.28633f
C495 a_22590_949# a_24665_949# 0.03208f
C496 DELAY_OUT_TAP17 a_17065_949# 0.19203f
C497 a_16108_194# MUX_SEL4 0.1283f
C498 a_2019_216# VDD 1.43004f
C499 DELAY_OUT_TAP16 a_15964_194# 0.02f
C500 a_9465_949# a_7390_949# 0.03208f
C501 DELAY_OUT_TAP30 DELAY_OUT_TAP31 0.03717f
C502 DELAY_OUT_TAP25 VDD 0.13651f
C503 a_5844_913# DELAY_OUT_TAP2 0.02312f
C504 a_10430_949# VDD 0.88416f
C505 a_22590_949# a_23145_949# 0.03209f
C506 a_22590_949# a_16108_194# 0.58202f
C507 DELAY_OUT_TAP5 DELAY_OUT_TAP6 0.02068f
C508 a_11848_949# a_11924_913# 0.01176f
C509 a_2297_236# a_1256_194# 0.04261f
C510 a_15964_194# MUX_OUT 0.01307f
C511 a_24951_913# VDD 0.2822f
C512 a_13368_949# DELAY_OUT_TAP12 0.10864f
C513 VDD DELAY_OUT_TAP28 0.14794f
C514 a_7390_949# a_9751_913# 0.26208f
C515 a_12505_949# VDD 0.29646f
C516 a_27915_949# VDD 0.15389f
C517 a_24008_949# VDD 0.17499f
C518 a_9465_949# VDD 0.29646f
C519 VDD DELAY_OUT_TAP31 0.1288f
C520 a_15964_194# a_16108_194# 0.42202f
C521 a_4248_949# VDD 0.17587f
C522 a_4350_949# DELAY_OUT_TAP2 0.07996f
C523 a_3449_236# a_2019_216# 0.01176f
C524 a_24875_949# VDD 0.15406f
C525 a_17865_424# a_16510_949# 0.02165f
C526 a_14025_949# a_14311_913# 0.01885f
C527 MUX_SEL0 MUX_SEL1 3.14917f
C528 a_9751_913# VDD 0.2822f
C529 DELAY_OUT_TAP1 VDD 0.13941f
C530 a_15765_368# a_16108_194# 0.42004f
C531 VDD a_15755_949# 0.15389f
C532 MUX_SEL3 a_1544_194# 0.15976f
C533 a_22590_949# DELAY_OUT_TAP27 0.05189f
C534 DELAY_OUT_TAP15 a_14964_913# 0.02053f
C535 a_10404_913# DELAY_OUT_TAP8 0.02011f
C536 a_5731_194# a_4350_949# 0.41099f
C537 a_1544_194# MUX_OUT 0.69943f
C538 a_5731_194# a_14825_424# 0.28056f
C539 DELAY_OUT_TAP20 a_16108_194# 0.0157f
C540 a_5731_194# a_13470_949# 0.41365f
C541 a_26185_949# a_26395_949# 0.09424f
C542 a_15545_949# a_13470_949# 0.03208f
C543 a_13444_913# a_13470_949# 0.277f
C544 a_26985_424# a_16108_194# 0.27952f
C545 DELAY_OUT_TAP16 VDD 0.14932f
C546 MUX_SEL3 VDD 0.4053f
C547 a_14025_949# a_13470_949# 0.03209f
C548 DELAY_OUT_TAP8 a_9751_913# 0.02339f
C549 a_24665_949# VDD 0.29646f
C550 a_23945_424# a_16108_194# 0.2906f
C551 VDD MUX_OUT 0.35871f
C552 VDD a_1544_949# 0.45004f
C553 a_2873_236# MUX_SEL2 0.01422f
C554 DELAY_OUT_TAP18 a_16510_949# 0.07996f
C555 a_27705_949# VDD 0.29842f
C556 a_16108_194# VDD 1.22378f
C557 a_23145_949# VDD 0.30333f
C558 a_4350_949# a_2019_216# 0.02042f
C559 MUX_SEL4 a_1256_949# 0.04908f
C560 a_27048_949# a_27124_913# 0.01176f
C561 a_3449_236# MUX_SEL3 0.28429f
C562 a_19550_949# a_16108_194# 0.58202f
C563 DELAY_OUT_TAP9 a_10985_949# 0.19203f
C564 DELAY_OUT_TAP28 DELAY_OUT_TAP29 0.06596f
C565 a_22590_949# a_22564_913# 0.277f
C566 a_23355_949# a_23431_913# 0.01194f
C567 a_5705_424# MUX_SEL4 0.03556f
C568 a_4248_949# a_4324_913# 0.01176f
C569 a_27124_913# DELAY_OUT_TAP30 0.02312f
C570 DELAY_OUT_TAP13 DELAY_OUT_TAP12 0.06596f
C571 a_7945_949# a_7390_949# 0.03209f
C572 a_1721_1300# a_1544_949# 0.38063f
C573 a_5768_949# DELAY_OUT_TAP2 0.10863f
C574 a_4248_949# a_4350_949# 0.37183f
C575 a_4324_913# DELAY_OUT_TAP1 0.0501f
C576 a_15964_194# MUX_SEL4 0.5544f
C577 VDD DELAY_OUT_TAP27 0.12759f
R0 VSS.n17 VSS.n24 3664.01
R1 VSS.t193 VSS.n24 122.412
R2 VSS.t210 VSS.n24 68.6481
R3 VSS.n22 VSS.t333 28.4523
R4 VSS.n63 VSS.t4 15.5226
R5 VSS.n24 VSS.t25 22.4812
R6 VSS.n73 VSS.n24 0.456674
R7 VSS.t278 VSS.n24 116.828
R8 VSS.n24 VSS.t233 116.828
R9 VSS.t215 VSS.n24 58.1721
R10 VSS.n24 VSS.t203 116.828
R11 VSS.t5 VSS.n32 499.695
R12 VSS.n24 VSS.t115 58.0914
R13 VSS.t51 VSS.n64 486.031
R14 VSS.n30 VSS.n17 0.567373
R15 VSS.t195 VSS.n24 68.6471
R16 VSS.t225 VSS.n24 68.6471
R17 VSS.t240 VSS.n24 68.6471
R18 VSS.t255 VSS.n24 68.6471
R19 VSS.t270 VSS.n24 68.6471
R20 VSS.t330 VSS.n57 71.035
R21 VSS.t301 VSS.n16 26.3107
R22 VSS.n111 VSS.t9 436.62
R23 VSS.n28 VSS.t178 430.062
R24 VSS.n36 VSS.n17 0.382621
R25 VSS.n35 VSS.n17 0.382621
R26 VSS.t293 VSS.n0 68.5978
R27 VSS.t183 VSS.n31 68.5978
R28 VSS.n34 VSS.n17 0.382621
R29 VSS.n37 VSS.n17 0.382621
R30 VSS.t18 VSS.n2 68.5978
R31 VSS.n33 VSS.n17 0.382621
R32 VSS.t164 VSS.n17 68.5978
R33 VSS.n56 VSS.t11 417.714
R34 VSS.t2 VSS.n24 116.822
R35 VSS.t248 VSS.n24 116.828
R36 VSS.t263 VSS.n24 116.828
R37 VSS.n17 VSS.n53 0.481029
R38 VSS.n58 VSS.t188 62.2552
R39 VSS.n72 VSS.t97 404.05
R40 VSS.t280 VSS.n193 375
R41 VSS.n24 VSS.t208 122.412
R42 VSS.n24 VSS.t223 122.412
R43 VSS.n24 VSS.t238 122.412
R44 VSS.n24 VSS.t253 122.412
R45 VSS.n24 VSS.t268 122.412
R46 VSS.t332 VSS.n104 366.197
R47 VSS.t205 VSS.n24 127.3
R48 VSS.t220 VSS.n24 127.3
R49 VSS.n24 VSS.t235 127.3
R50 VSS.t250 VSS.n24 127.3
R51 VSS.t265 VSS.n24 127.3
R52 VSS.n13 VSS.t182 98.6395
R53 VSS.n17 VSS.n66 0.423468
R54 VSS.n11 VSS.t356 98.6395
R55 VSS.n10 VSS.t295 98.6395
R56 VSS.n9 VSS.t283 98.6395
R57 VSS.n8 VSS.t185 98.6395
R58 VSS.n17 VSS.n61 0.423468
R59 VSS.n17 VSS.n67 0.423468
R60 VSS.n6 VSS.t303 98.6395
R61 VSS.n17 VSS.n68 0.423468
R62 VSS.n17 VSS.n55 0.423468
R63 VSS.n17 VSS.n69 0.423468
R64 VSS.n17 VSS.n54 0.423468
R65 VSS.n4 VSS.t310 98.6395
R66 VSS.n17 VSS.n60 0.423468
R67 VSS.n17 VSS.n71 0.423468
R68 VSS.n24 VSS.t91 133.32
R69 VSS.n24 VSS.t160 133.319
R70 VSS.t88 VSS.n24 133.32
R71 VSS.t48 VSS.n24 133.32
R72 VSS.n24 VSS.t95 140.651
R73 VSS.n24 VSS.t131 140.653
R74 VSS.t80 VSS.n24 133.32
R75 VSS.t179 VSS.n24 133.32
R76 VSS.t84 VSS.n104 352.113
R77 VSS.t281 VSS.n59 359.983
R78 VSS.n17 VSS.t70 101.647
R79 VSS.n17 VSS.t61 101.647
R80 VSS.n17 VSS.t101 101.647
R81 VSS.n17 VSS.t64 101.647
R82 VSS.n17 VSS.t288 101.647
R83 VSS.n17 VSS.t345 101.647
R84 VSS.n17 VSS.t321 101.647
R85 VSS.t175 VSS.n17 101.656
R86 VSS.t146 VSS.n65 348.303
R87 VSS.t144 VSS.n38 348.303
R88 VSS.t311 VSS.n40 348.303
R89 VSS.t137 VSS.n52 348.303
R90 VSS.t153 VSS.n51 348.303
R91 VSS.t74 VSS.n45 348.303
R92 VSS.t143 VSS.n47 348.303
R93 VSS.t155 VSS.n27 348.303
R94 VSS.n38 VSS.n17 6.82258
R95 VSS.t57 VSS.n39 111.644
R96 VSS.n40 VSS.n17 6.82258
R97 VSS.t31 VSS.n41 111.644
R98 VSS.n17 VSS.t113 108.561
R99 VSS.n17 VSS.t41 108.561
R100 VSS.n17 VSS.t339 108.561
R101 VSS.t106 VSS.n42 111.644
R102 VSS.n17 VSS.t336 108.561
R103 VSS.t317 VSS.n43 111.644
R104 VSS.t34 VSS.n44 111.644
R105 VSS.n17 VSS.t55 108.561
R106 VSS.n45 VSS.n17 6.82258
R107 VSS.t314 VSS.n46 111.644
R108 VSS.n17 VSS.t104 108.561
R109 VSS.n17 VSS.t128 108.49
R110 VSS.n32 VSS.t328 129.317
R111 VSS.n72 VSS.t98 129.738
R112 VSS.t156 VSS.n62 404.05
R113 VSS.n194 VSS.t300 314.517
R114 VSS.n24 VSS.t81 140.651
R115 VSS.n24 VSS.t49 140.651
R116 VSS.n24 VSS.n64 9.33546
R117 VSS.n56 VSS.t327 131.77
R118 VSS.n194 VSS.t285 302.42
R119 VSS.n28 VSS.n17 9.74178
R120 VSS.n111 VSS.t329 281.69
R121 VSS.t148 VSS.n65 111.647
R122 VSS.t66 VSS.n38 111.644
R123 VSS.n39 VSS.t133 348.303
R124 VSS.t26 VSS.n40 111.644
R125 VSS.n41 VSS.t313 348.303
R126 VSS.t112 VSS.n52 111.644
R127 VSS.t40 VSS.n51 111.644
R128 VSS.n50 VSS.t86 348.303
R129 VSS.n42 VSS.t141 348.303
R130 VSS.n49 VSS.t151 348.303
R131 VSS.n43 VSS.t78 348.303
R132 VSS.n44 VSS.t139 348.303
R133 VSS.n48 VSS.t150 348.303
R134 VSS.t341 VSS.n45 111.644
R135 VSS.n46 VSS.t7 348.303
R136 VSS.t103 VSS.n47 111.644
R137 VSS.t127 VSS.n27 111.639
R138 VSS.n24 VSS.t198 141.964
R139 VSS.n24 VSS.t213 141.964
R140 VSS.n24 VSS.t228 141.964
R141 VSS.n24 VSS.t243 141.964
R142 VSS.n24 VSS.t258 141.964
R143 VSS.n24 VSS.t273 141.964
R144 VSS.n24 VSS.t325 141.702
R145 VSS.t350 VSS.n29 112.787
R146 VSS.n59 VSS.t170 113.322
R147 VSS.n24 VSS.t161 140.653
R148 VSS.t329 VSS.n57 267.416
R149 VSS.t186 VSS.n193 241.935
R150 VSS.n56 VSS.n24 7.23036
R151 VSS.t168 VSS.n17 122.856
R152 VSS.t52 VSS.n64 131.472
R153 VSS.n24 VSS.t23 137.776
R154 VSS.t158 VSS.n62 129.738
R155 VSS.n72 VSS.n24 6.80937
R156 VSS.n58 VSS.t186 231.506
R157 VSS.n24 VSS.t94 133.32
R158 VSS.n24 VSS.t130 133.319
R159 VSS.n59 VSS.n17 7.23977
R160 VSS.t349 VSS.n29 418.382
R161 VSS.n17 VSS.n65 6.82269
R162 VSS.n17 VSS.n27 6.82228
R163 VSS.n28 VSS.t171 110.901
R164 VSS.n24 VSS.t190 127.299
R165 VSS.n63 VSS.t84 199.099
R166 VSS.n24 VSS.t218 116.828
R167 VSS.t67 VSS.n17 108.561
R168 VSS.t58 VSS.n17 108.561
R169 VSS.t27 VSS.n17 108.561
R170 VSS.t32 VSS.n17 108.561
R171 VSS.t107 VSS.n17 108.561
R172 VSS.t318 VSS.n17 108.561
R173 VSS.t35 VSS.n17 108.561
R174 VSS.t342 VSS.n17 108.561
R175 VSS.t315 VSS.n17 108.561
R176 VSS.t300 VSS.n16 161.025
R177 VSS.t97 VSS.n23 156.831
R178 VSS.t156 VSS.n73 156.883
R179 VSS.n14 VSS.t69 83.4525
R180 VSS.n12 VSS.t60 83.4525
R181 VSS.t119 VSS.n17 101.647
R182 VSS.t125 VSS.n17 101.647
R183 VSS.t21 VSS.n17 101.647
R184 VSS.n7 VSS.t63 83.4525
R185 VSS.t44 VSS.n17 101.647
R186 VSS.t76 VSS.n17 101.647
R187 VSS.t14 VSS.n17 101.647
R188 VSS.t122 VSS.n17 101.647
R189 VSS.t110 VSS.n17 101.647
R190 VSS.t38 VSS.n17 101.647
R191 VSS.t11 VSS.n20 142.746
R192 VSS.n15 VSS.t146 136.798
R193 VSS.n13 VSS.t144 136.962
R194 VSS.t174 VSS.n66 98.6395
R195 VSS.n11 VSS.t311 136.962
R196 VSS.n10 VSS.t313 136.962
R197 VSS.n9 VSS.t137 136.962
R198 VSS.n8 VSS.t153 136.962
R199 VSS.t292 VSS.n61 98.6395
R200 VSS.t299 VSS.n67 98.6395
R201 VSS.n6 VSS.t151 136.962
R202 VSS.t354 VSS.n68 98.6395
R203 VSS.t355 VSS.n55 98.6395
R204 VSS.t29 VSS.n69 98.6395
R205 VSS.t72 VSS.n54 98.6395
R206 VSS.n4 VSS.t7 136.962
R207 VSS.t16 VSS.n60 98.6395
R208 VSS.t46 VSS.n71 98.6395
R209 VSS.n3 VSS.t281 124.701
R210 VSS.t9 VSS.n21 114.668
R211 VSS.t284 VSS.n53 72.4354
R212 VSS.n24 VSS.n57 2.59912
R213 VSS.t135 VSS.n14 68.5978
R214 VSS.n12 VSS.t166 68.5978
R215 VSS.n36 VSS.t172 68.5978
R216 VSS.n35 VSS.t297 68.5978
R217 VSS.t20 VSS.n0 83.4525
R218 VSS.t100 VSS.n31 83.4525
R219 VSS.n7 VSS.t352 68.5978
R220 VSS.n17 VSS.t306 68.5978
R221 VSS.n17 VSS.t347 68.5978
R222 VSS.n34 VSS.t290 68.5978
R223 VSS.n37 VSS.t304 68.5978
R224 VSS.n5 VSS.t323 68.5978
R225 VSS.t121 VSS.n2 83.4525
R226 VSS.n33 VSS.t0 68.5978
R227 VSS.n1 VSS.t308 68.5978
R228 VSS.t320 VSS.n17 83.4525
R229 VSS.n58 VSS.n17 2.65215
R230 VSS.n20 VSS.t51 72.3236
R231 VSS.n24 VSS.t200 58.1721
R232 VSS.n24 VSS.t230 58.1721
R233 VSS.n24 VSS.t245 58.1721
R234 VSS.n24 VSS.t260 58.1721
R235 VSS.t275 VSS.n24 58.1721
R236 VSS.t349 VSS.n3 64.2173
R237 VSS.n23 VSS.t5 58.2391
R238 VSS.n73 VSS.t163 52.2182
R239 VSS.t178 VSS.n15 52.1205
R240 VSS.n22 VSS.t332 185.028
R241 VSS.n24 VSS.t116 22.5629
R242 VSS.n112 VSS.t10 17.3368
R243 VSS.n115 VSS.t12 17.3368
R244 VSS.n105 VSS.t85 17.3368
R245 VSS.n119 VSS.t6 17.3368
R246 VSS.n211 VSS.t147 17.3368
R247 VSS.n207 VSS.t286 17.3368
R248 VSS.n203 VSS.t282 17.3368
R249 VSS.n199 VSS.t187 17.3368
R250 VSS.n157 VSS.t157 17.2607
R251 VSS.n123 VSS.t191 17.2313
R252 VSS.n402 VSS.t197 17.2313
R253 VSS.n130 VSS.t202 17.2313
R254 VSS.n395 VSS.t207 17.2313
R255 VSS.n390 VSS.t212 17.2313
R256 VSS.n140 VSS.t217 17.2313
R257 VSS.n383 VSS.t222 17.2313
R258 VSS.n378 VSS.t227 17.2313
R259 VSS.n84 VSS.t232 17.2313
R260 VSS.n165 VSS.t237 17.2313
R261 VSS.n371 VSS.t242 17.2313
R262 VSS.n89 VSS.t247 17.2313
R263 VSS.n364 VSS.t252 17.2313
R264 VSS.n359 VSS.t257 17.2313
R265 VSS.n94 VSS.t262 17.2313
R266 VSS.n352 VSS.t267 17.2313
R267 VSS.n347 VSS.t272 17.2313
R268 VSS.n99 VSS.t277 17.2313
R269 VSS.n24 VSS.n32 9.75628
R270 VSS.n24 VSS.n104 17.0005
R271 VSS.n24 VSS.n111 17.0005
R272 VSS.n407 VSS.n24 17.0005
R273 VSS.n405 VSS.t192 17.0005
R274 VSS.n24 VSS.n97 5.65652
R275 VSS.n24 VSS.n92 5.65652
R276 VSS.n24 VSS.n87 5.65652
R277 VSS.n24 VSS.n62 6.8094
R278 VSS.n24 VSS.n82 5.65652
R279 VSS.n24 VSS.n78 5.65652
R280 VSS.n24 VSS.n74 5.65652
R281 VSS.n125 VSS.t194 17.0005
R282 VSS.n403 VSS.t196 17.0005
R283 VSS.n127 VSS.t199 17.0005
R284 VSS.n128 VSS.t201 17.0005
R285 VSS.n132 VSS.t204 17.0005
R286 VSS.n396 VSS.t206 17.0005
R287 VSS.n136 VSS.t209 17.0005
R288 VSS.n391 VSS.t211 17.0005
R289 VSS.n137 VSS.t214 17.0005
R290 VSS.n138 VSS.t216 17.0005
R291 VSS.n142 VSS.t219 17.0005
R292 VSS.n384 VSS.t221 17.0005
R293 VSS.n146 VSS.t224 17.0005
R294 VSS.n379 VSS.t226 17.0005
R295 VSS.n147 VSS.t229 17.0005
R296 VSS.n148 VSS.t231 17.0005
R297 VSS.n152 VSS.t234 17.0005
R298 VSS.n163 VSS.t236 17.0005
R299 VSS.n166 VSS.t239 17.0005
R300 VSS.n372 VSS.t241 17.0005
R301 VSS.n168 VSS.t244 17.0005
R302 VSS.n169 VSS.t246 17.0005
R303 VSS.n172 VSS.t249 17.0005
R304 VSS.n365 VSS.t251 17.0005
R305 VSS.n176 VSS.t254 17.0005
R306 VSS.n360 VSS.t256 17.0005
R307 VSS.n177 VSS.t259 17.0005
R308 VSS.n178 VSS.t261 17.0005
R309 VSS.n181 VSS.t264 17.0005
R310 VSS.n353 VSS.t266 17.0005
R311 VSS.n185 VSS.t269 17.0005
R312 VSS.n348 VSS.t271 17.0005
R313 VSS.n186 VSS.t274 17.0005
R314 VSS.n187 VSS.t276 17.0005
R315 VSS.n189 VSS.t279 17.0005
R316 VSS.n17 VSS.n70 17.0005
R317 VSS.n17 VSS.n193 17.0005
R318 VSS.n17 VSS.n29 9.3247
R319 VSS.n17 VSS.n194 17.0005
R320 VSS.n17 VSS.n39 6.82258
R321 VSS.n17 VSS.n41 6.82258
R322 VSS.n17 VSS.n50 6.82258
R323 VSS.n17 VSS.n42 6.82258
R324 VSS.n17 VSS.n49 6.82258
R325 VSS.n17 VSS.n43 6.82258
R326 VSS.n17 VSS.n44 6.82258
R327 VSS.n17 VSS.n48 6.82258
R328 VSS.n17 VSS.n46 6.82258
R329 VSS.n63 VSS.n24 0.494014
R330 VSS.n30 VSS.t177 15.3031
R331 VSS.n125 VSS.t391 15.3099
R332 VSS.n127 VSS.t389 15.3099
R333 VSS.n132 VSS.t387 15.3099
R334 VSS.n136 VSS.t385 15.3099
R335 VSS.n137 VSS.t383 15.3099
R336 VSS.n142 VSS.t381 15.3099
R337 VSS.n146 VSS.t379 15.3099
R338 VSS.n147 VSS.t377 15.3099
R339 VSS.n152 VSS.t375 15.3099
R340 VSS.n166 VSS.t373 15.3099
R341 VSS.n168 VSS.t371 15.3099
R342 VSS.n172 VSS.t369 15.3099
R343 VSS.n176 VSS.t367 15.3099
R344 VSS.n177 VSS.t365 15.3099
R345 VSS.n181 VSS.t363 15.3099
R346 VSS.n185 VSS.t361 15.3099
R347 VSS.n186 VSS.t359 15.3099
R348 VSS.n189 VSS.t357 15.3099
R349 VSS.n405 VSS.t392 15.2696
R350 VSS.n403 VSS.t390 15.2696
R351 VSS.n128 VSS.t388 15.2696
R352 VSS.n396 VSS.t386 15.2696
R353 VSS.n391 VSS.t384 15.2696
R354 VSS.n138 VSS.t382 15.2696
R355 VSS.n384 VSS.t380 15.2696
R356 VSS.n379 VSS.t378 15.2696
R357 VSS.n148 VSS.t376 15.2696
R358 VSS.n163 VSS.t374 15.2696
R359 VSS.n372 VSS.t372 15.2696
R360 VSS.n169 VSS.t370 15.2696
R361 VSS.n365 VSS.t368 15.2696
R362 VSS.n360 VSS.t366 15.2696
R363 VSS.n178 VSS.t364 15.2696
R364 VSS.n353 VSS.t362 15.2696
R365 VSS.n348 VSS.t360 15.2696
R366 VSS.n187 VSS.t358 15.2696
R367 VSS.n213 VSS.t149 8.80385
R368 VSS.n209 VSS.t302 8.80385
R369 VSS.n205 VSS.t351 8.80385
R370 VSS.n201 VSS.t189 8.80385
R371 VSS.n113 VSS.t331 8.80285
R372 VSS.n116 VSS.t53 8.80285
R373 VSS.n118 VSS.t334 8.80285
R374 VSS.n121 VSS.t99 8.80285
R375 VSS.n341 VSS.t129 8.77423
R376 VSS.n339 VSS.t47 8.77423
R377 VSS.n337 VSS.t322 8.77423
R378 VSS.n335 VSS.t165 8.77423
R379 VSS.n333 VSS.t105 8.77423
R380 VSS.n331 VSS.t17 8.77423
R381 VSS.n329 VSS.t39 8.77423
R382 VSS.n327 VSS.t309 8.77423
R383 VSS.n325 VSS.t316 8.77423
R384 VSS.n323 VSS.t8 8.77423
R385 VSS.n321 VSS.t111 8.77423
R386 VSS.n319 VSS.t1 8.77423
R387 VSS.n317 VSS.t343 8.77423
R388 VSS.n315 VSS.t73 8.77423
R389 VSS.n313 VSS.t123 8.77423
R390 VSS.n311 VSS.t19 8.77423
R391 VSS.n309 VSS.t56 8.77423
R392 VSS.n307 VSS.t30 8.77423
R393 VSS.n305 VSS.t15 8.77423
R394 VSS.n303 VSS.t324 8.77423
R395 VSS.n301 VSS.t36 8.77423
R396 VSS.n299 VSS.t140 8.77423
R397 VSS.n297 VSS.t77 8.77423
R398 VSS.n295 VSS.t305 8.77423
R399 VSS.n293 VSS.t319 8.77423
R400 VSS.n291 VSS.t79 8.77423
R401 VSS.n289 VSS.t45 8.77423
R402 VSS.n287 VSS.t291 8.77423
R403 VSS.n285 VSS.t337 8.77423
R404 VSS.n283 VSS.t152 8.77423
R405 VSS.n281 VSS.t346 8.77423
R406 VSS.n279 VSS.t348 8.77423
R407 VSS.n277 VSS.t108 8.77423
R408 VSS.n275 VSS.t142 8.77423
R409 VSS.n273 VSS.t289 8.77423
R410 VSS.n271 VSS.t307 8.77423
R411 VSS.n269 VSS.t340 8.77423
R412 VSS.n267 VSS.t87 8.77423
R413 VSS.n265 VSS.t65 8.77423
R414 VSS.n263 VSS.t353 8.77423
R415 VSS.n261 VSS.t42 8.77423
R416 VSS.n259 VSS.t154 8.77423
R417 VSS.n257 VSS.t102 8.77423
R418 VSS.n255 VSS.t184 8.77423
R419 VSS.n253 VSS.t114 8.77423
R420 VSS.n251 VSS.t138 8.77423
R421 VSS.n249 VSS.t22 8.77423
R422 VSS.n247 VSS.t294 8.77423
R423 VSS.n245 VSS.t33 8.77423
R424 VSS.n243 VSS.t296 8.77423
R425 VSS.n241 VSS.t126 8.77423
R426 VSS.n239 VSS.t298 8.77423
R427 VSS.n237 VSS.t28 8.77423
R428 VSS.n235 VSS.t312 8.77423
R429 VSS.n233 VSS.t120 8.77423
R430 VSS.n231 VSS.t173 8.77423
R431 VSS.n229 VSS.t59 8.77423
R432 VSS.n227 VSS.t134 8.77423
R433 VSS.n225 VSS.t62 8.77423
R434 VSS.n223 VSS.t167 8.77423
R435 VSS.n221 VSS.t68 8.77423
R436 VSS.n219 VSS.t145 8.77423
R437 VSS.n217 VSS.t71 8.77423
R438 VSS.n215 VSS.t136 8.77423
R439 VSS.n26 VSS.t93 8.82841
R440 VSS.n134 VSS.t181 8.77323
R441 VSS.n144 VSS.t82 8.77323
R442 VSS.n155 VSS.t132 8.77323
R443 VSS.n156 VSS.t117 8.77323
R444 VSS.n160 VSS.t96 8.77323
R445 VSS.n174 VSS.t50 8.77323
R446 VSS.n183 VSS.t90 8.77323
R447 VSS.n192 VSS.t162 8.77323
R448 VSS.n25 VSS.t24 8.79211
R449 VSS.n159 VSS.t159 8.76678
R450 VSS.n197 VSS.t176 8.75731
R451 VSS.n195 VSS.t169 8.75731
R452 VSS.n101 VSS.t326 8.75631
R453 VSS.n109 VSS.t3 8.75631
R454 VSS.n343 VSS.n100 0.0435295
R455 VSS.n98 VSS.n349 0.0534319
R456 VSS.n350 VSS.n97 0.0180497
R457 VSS.n96 VSS.n354 0.0633111
R458 VSS.n355 VSS.n95 0.0435295
R459 VSS.n93 VSS.n361 0.0534319
R460 VSS.n362 VSS.n92 0.0180497
R461 VSS.n91 VSS.n366 0.0633111
R462 VSS.n367 VSS.n90 0.0435295
R463 VSS.n88 VSS.n373 0.0534319
R464 VSS.n167 VSS.n87 0.0180497
R465 VSS.n164 VSS.n86 0.0633111
R466 VSS.n374 VSS.n85 0.0435295
R467 VSS.n83 VSS.n380 0.0534319
R468 VSS.n381 VSS.n82 0.0180497
R469 VSS.n81 VSS.n385 0.0633111
R470 VSS.n80 VSS.n24 4.22409
R471 VSS.n79 VSS.n392 0.0534319
R472 VSS.n393 VSS.n78 0.0180497
R473 VSS.n77 VSS.n397 0.0633111
R474 VSS.n76 VSS.n24 4.22409
R475 VSS.n75 VSS.n404 0.0534319
R476 VSS.n126 VSS.n74 0.0180497
R477 VSS.n344 VSS.n24 8.49319
R478 VSS.n356 VSS.n24 8.49319
R479 VSS.n368 VSS.n24 8.49319
R480 VSS.n375 VSS.n24 8.49319
R481 VSS.n387 VSS.n24 8.49319
R482 VSS.n399 VSS.n24 8.49319
R483 VSS.n24 VSS.n103 8.47732
R484 VSS.n24 VSS.n100 4.22409
R485 VSS.n98 VSS.n24 4.21914
R486 VSS.n351 VSS.n24 8.47732
R487 VSS.n96 VSS.n24 4.21421
R488 VSS.n24 VSS.n95 4.22409
R489 VSS.n93 VSS.n24 4.21914
R490 VSS.n363 VSS.n24 8.47732
R491 VSS.n91 VSS.n24 4.21421
R492 VSS.n24 VSS.n90 4.22409
R493 VSS.n88 VSS.n24 4.21914
R494 VSS.n24 VSS.n162 8.47732
R495 VSS.n24 VSS.n86 4.21421
R496 VSS.n24 VSS.n85 4.22409
R497 VSS.n83 VSS.n24 4.21914
R498 VSS.n382 VSS.n24 8.47732
R499 VSS.n81 VSS.n24 4.21421
R500 VSS.n80 VSS.n140 0.176279
R501 VSS.n79 VSS.n24 4.21914
R502 VSS.n394 VSS.n24 8.47732
R503 VSS.n77 VSS.n24 4.21421
R504 VSS.n76 VSS.n130 0.176279
R505 VSS.n75 VSS.n24 4.21914
R506 VSS.n24 VSS.n124 8.47732
R507 VSS.n208 VSS.n17 8.47732
R508 VSS.n342 VSS.n17 8.47732
R509 VSS.n24 VSS.n102 5.62581
R510 VSS.n24 VSS.n117 5.62581
R511 VSS.n24 VSS.n114 5.62581
R512 VSS.n24 VSS.n191 5.62581
R513 VSS.n346 VSS.n24 5.62581
R514 VSS.n24 VSS.n180 5.62581
R515 VSS.n358 VSS.n24 5.62581
R516 VSS.n24 VSS.n171 5.62581
R517 VSS.n370 VSS.n24 5.62581
R518 VSS.n24 VSS.n150 5.62581
R519 VSS.n24 VSS.n151 5.62581
R520 VSS.n377 VSS.n24 5.62581
R521 VSS.n24 VSS.n141 5.62581
R522 VSS.n389 VSS.n24 5.62581
R523 VSS.n24 VSS.n131 5.62581
R524 VSS.n401 VSS.n24 5.62581
R525 VSS.n200 VSS.n17 5.62581
R526 VSS.n204 VSS.n17 5.62581
R527 VSS.n212 VSS.n17 5.62581
R528 VSS.n222 VSS.n17 5.62581
R529 VSS.n230 VSS.n17 5.62581
R530 VSS.n238 VSS.n17 5.62581
R531 VSS.n246 VSS.n17 5.62581
R532 VSS.n254 VSS.n17 5.62581
R533 VSS.n262 VSS.n17 5.62581
R534 VSS.n270 VSS.n17 5.62581
R535 VSS.n278 VSS.n17 5.62581
R536 VSS.n286 VSS.n17 5.62581
R537 VSS.n294 VSS.n17 5.62581
R538 VSS.n302 VSS.n17 5.62581
R539 VSS.n310 VSS.n17 5.62581
R540 VSS.n318 VSS.n17 5.62581
R541 VSS.n326 VSS.n17 5.62581
R542 VSS.n334 VSS.n17 5.62581
R543 VSS.n24 VSS.n122 4.21408
R544 VSS.n24 VSS.n110 4.19244
R545 VSS.n196 VSS.n17 4.19244
R546 VSS.n214 VSS.n17 4.19244
R547 VSS.n18 VSS.n342 3.33613
R548 VSS.n26 VSS.n406 0.440892
R549 VSS.n24 VSS.n120 3.3265
R550 VSS.n24 VSS.n106 3.3265
R551 VSS.n24 VSS.n107 3.3265
R552 VSS.n24 VSS.n179 3.3265
R553 VSS.n24 VSS.n170 3.3265
R554 VSS.n24 VSS.n149 3.3265
R555 VSS.n24 VSS.n139 3.3265
R556 VSS.n24 VSS.n129 3.3265
R557 VSS.n202 VSS.n17 3.3265
R558 VSS.n206 VSS.n17 3.3265
R559 VSS.n210 VSS.n17 3.3265
R560 VSS.n216 VSS.n17 3.3265
R561 VSS.n224 VSS.n17 3.3265
R562 VSS.n232 VSS.n17 3.3265
R563 VSS.n240 VSS.n17 3.3265
R564 VSS.n248 VSS.n17 3.3265
R565 VSS.n256 VSS.n17 3.3265
R566 VSS.n264 VSS.n17 3.3265
R567 VSS.n272 VSS.n17 3.3265
R568 VSS.n280 VSS.n17 3.3265
R569 VSS.n288 VSS.n17 3.3265
R570 VSS.n296 VSS.n17 3.3265
R571 VSS.n304 VSS.n17 3.3265
R572 VSS.n312 VSS.n17 3.3265
R573 VSS.n320 VSS.n17 3.3265
R574 VSS.n328 VSS.n17 3.3265
R575 VSS.n336 VSS.n17 3.3265
R576 VSS.n24 VSS.n108 2.74446
R577 VSS.n198 VSS.n17 2.74446
R578 VSS.n218 VSS.n17 2.74446
R579 VSS.n220 VSS.n17 2.74446
R580 VSS.n226 VSS.n17 2.74446
R581 VSS.n228 VSS.n17 2.74446
R582 VSS.n234 VSS.n17 2.74446
R583 VSS.n236 VSS.n17 2.74446
R584 VSS.n242 VSS.n17 2.74446
R585 VSS.n244 VSS.n17 2.74446
R586 VSS.n250 VSS.n17 2.74446
R587 VSS.n252 VSS.n17 2.74446
R588 VSS.n258 VSS.n17 2.74446
R589 VSS.n260 VSS.n17 2.74446
R590 VSS.n266 VSS.n17 2.74446
R591 VSS.n268 VSS.n17 2.74446
R592 VSS.n274 VSS.n17 2.74446
R593 VSS.n276 VSS.n17 2.74446
R594 VSS.n282 VSS.n17 2.74446
R595 VSS.n284 VSS.n17 2.74446
R596 VSS.n290 VSS.n17 2.74446
R597 VSS.n292 VSS.n17 2.74446
R598 VSS.n298 VSS.n17 2.74446
R599 VSS.n300 VSS.n17 2.74446
R600 VSS.n306 VSS.n17 2.74446
R601 VSS.n308 VSS.n17 2.74446
R602 VSS.n314 VSS.n17 2.74446
R603 VSS.n316 VSS.n17 2.74446
R604 VSS.n322 VSS.n17 2.74446
R605 VSS.n324 VSS.n17 2.74446
R606 VSS.n330 VSS.n17 2.74446
R607 VSS.n332 VSS.n17 2.74446
R608 VSS.n338 VSS.n17 2.74446
R609 VSS.n340 VSS.n17 2.74446
R610 VSS.n24 VSS.n158 2.00687
R611 VSS.n24 VSS.n188 1.56144
R612 VSS.n24 VSS.n184 1.56144
R613 VSS.n24 VSS.n175 1.56144
R614 VSS.n24 VSS.n154 1.56144
R615 VSS.n24 VSS.n145 1.56144
R616 VSS.n24 VSS.n135 1.56144
R617 VSS.n24 VSS.n161 1.12565
R618 VSS.n24 VSS.n18 0.92982
R619 VSS.n25 VSS.n24 0.761893
R620 VSS.n26 VSS.n24 0.665344
R621 VSS.n24 VSS.n19 0.849178
R622 VSS.n19 VSS.n155 0.728316
R623 VSS.n156 VSS.n19 0.69965
R624 VSS.n18 VSS.n192 0.69304
R625 VSS.n161 VSS.n159 0.603496
R626 VSS.n53 VSS.t280 100.614
R627 VSS.n17 VSS.n3 0.586403
R628 VSS.n30 VSS.t285 173.107
R629 VSS.n17 VSS.n16 0.552982
R630 VSS.n17 VSS.n15 0.586403
R631 VSS.n17 VSS.n14 0.382621
R632 VSS.n17 VSS.n13 0.423468
R633 VSS.n17 VSS.n12 0.382621
R634 VSS.n66 VSS.t133 136.962
R635 VSS.n17 VSS.n11 0.423468
R636 VSS.n17 VSS.n10 0.423468
R637 VSS.n17 VSS.n9 0.423468
R638 VSS.n17 VSS.n8 0.423468
R639 VSS.n17 VSS.n7 0.382621
R640 VSS.n61 VSS.t86 136.962
R641 VSS.n17 VSS.t287 83.4525
R642 VSS.n67 VSS.t141 136.962
R643 VSS.n17 VSS.t344 83.4525
R644 VSS.n17 VSS.n6 0.423468
R645 VSS.n68 VSS.t78 136.962
R646 VSS.n55 VSS.t139 136.962
R647 VSS.n17 VSS.n5 0.382621
R648 VSS.n69 VSS.t150 136.962
R649 VSS.n54 VSS.t74 136.962
R650 VSS.n17 VSS.n4 0.423468
R651 VSS.n1 VSS.t37 83.4525
R652 VSS.n60 VSS.t143 136.962
R653 VSS.n71 VSS.t155 136.962
R654 VSS.n161 VSS.n160 0.540438
R655 VSS.n24 VSS.n23 0.50872
R656 VSS.n24 VSS.n22 0.481869
R657 VSS.n24 VSS.n20 0.50872
R658 VSS.n135 VSS.n134 0.413418
R659 VSS.n145 VSS.n144 0.413418
R660 VSS.n155 VSS.n154 0.413418
R661 VSS.n175 VSS.n174 0.413418
R662 VSS.n184 VSS.n183 0.413418
R663 VSS.n192 VSS.n188 0.413418
R664 VSS.n158 VSS.n157 0.380519
R665 VSS.n158 VSS.n156 0.359515
R666 VSS.n190 VSS.n188 0.340858
R667 VSS.n184 VSS.n182 0.340858
R668 VSS.n175 VSS.n173 0.340858
R669 VSS.n154 VSS.n153 0.340858
R670 VSS.n145 VSS.n143 0.340858
R671 VSS.n135 VSS.n133 0.340858
R672 VSS.n199 VSS.n198 0.318018
R673 VSS.n112 VSS.n108 0.316299
R674 VSS.n219 VSS.n218 0.284268
R675 VSS.n227 VSS.n226 0.284268
R676 VSS.n235 VSS.n234 0.284268
R677 VSS.n243 VSS.n242 0.284268
R678 VSS.n251 VSS.n250 0.284268
R679 VSS.n259 VSS.n258 0.284268
R680 VSS.n267 VSS.n266 0.284268
R681 VSS.n275 VSS.n274 0.284268
R682 VSS.n283 VSS.n282 0.284268
R683 VSS.n291 VSS.n290 0.284268
R684 VSS.n299 VSS.n298 0.284268
R685 VSS.n307 VSS.n306 0.284268
R686 VSS.n315 VSS.n314 0.284268
R687 VSS.n323 VSS.n322 0.284268
R688 VSS.n331 VSS.n330 0.284268
R689 VSS.n339 VSS.n338 0.284268
R690 VSS.n220 VSS.n219 0.282549
R691 VSS.n228 VSS.n227 0.282549
R692 VSS.n236 VSS.n235 0.282549
R693 VSS.n244 VSS.n243 0.282549
R694 VSS.n252 VSS.n251 0.282549
R695 VSS.n260 VSS.n259 0.282549
R696 VSS.n268 VSS.n267 0.282549
R697 VSS.n276 VSS.n275 0.282549
R698 VSS.n284 VSS.n283 0.282549
R699 VSS.n292 VSS.n291 0.282549
R700 VSS.n300 VSS.n299 0.282549
R701 VSS.n308 VSS.n307 0.282549
R702 VSS.n316 VSS.n315 0.282549
R703 VSS.n324 VSS.n323 0.282549
R704 VSS.n332 VSS.n331 0.282549
R705 VSS.n340 VSS.n339 0.282549
R706 VSS.n217 VSS.n216 0.280477
R707 VSS.n225 VSS.n224 0.280477
R708 VSS.n233 VSS.n232 0.280477
R709 VSS.n241 VSS.n240 0.280477
R710 VSS.n249 VSS.n248 0.280477
R711 VSS.n257 VSS.n256 0.280477
R712 VSS.n265 VSS.n264 0.280477
R713 VSS.n273 VSS.n272 0.280477
R714 VSS.n281 VSS.n280 0.280477
R715 VSS.n289 VSS.n288 0.280477
R716 VSS.n297 VSS.n296 0.280477
R717 VSS.n305 VSS.n304 0.280477
R718 VSS.n313 VSS.n312 0.280477
R719 VSS.n321 VSS.n320 0.280477
R720 VSS.n329 VSS.n328 0.280477
R721 VSS.n337 VSS.n336 0.280477
R722 VSS.n109 VSS.n108 0.274268
R723 VSS.n116 VSS.n106 0.274227
R724 VSS.n134 VSS.n129 0.274227
R725 VSS.n144 VSS.n139 0.274227
R726 VSS.n160 VSS.n149 0.274227
R727 VSS.n174 VSS.n170 0.274227
R728 VSS.n183 VSS.n179 0.274227
R729 VSS.n206 VSS.n205 0.272997
R730 VSS.n198 VSS.n197 0.272549
R731 VSS.n221 VSS.n220 0.270518
R732 VSS.n229 VSS.n228 0.270518
R733 VSS.n237 VSS.n236 0.270518
R734 VSS.n245 VSS.n244 0.270518
R735 VSS.n253 VSS.n252 0.270518
R736 VSS.n261 VSS.n260 0.270518
R737 VSS.n269 VSS.n268 0.270518
R738 VSS.n277 VSS.n276 0.270518
R739 VSS.n285 VSS.n284 0.270518
R740 VSS.n293 VSS.n292 0.270518
R741 VSS.n301 VSS.n300 0.270518
R742 VSS.n309 VSS.n308 0.270518
R743 VSS.n317 VSS.n316 0.270518
R744 VSS.n325 VSS.n324 0.270518
R745 VSS.n333 VSS.n332 0.270518
R746 VSS.n341 VSS.n340 0.270518
R747 VSS.n216 VSS.n215 0.266747
R748 VSS.n224 VSS.n223 0.266747
R749 VSS.n232 VSS.n231 0.266747
R750 VSS.n240 VSS.n239 0.266747
R751 VSS.n248 VSS.n247 0.266747
R752 VSS.n256 VSS.n255 0.266747
R753 VSS.n264 VSS.n263 0.266747
R754 VSS.n272 VSS.n271 0.266747
R755 VSS.n280 VSS.n279 0.266747
R756 VSS.n288 VSS.n287 0.266747
R757 VSS.n296 VSS.n295 0.266747
R758 VSS.n304 VSS.n303 0.266747
R759 VSS.n312 VSS.n311 0.266747
R760 VSS.n320 VSS.n319 0.266747
R761 VSS.n328 VSS.n327 0.266747
R762 VSS.n336 VSS.n335 0.266747
R763 VSS.n211 VSS.n210 0.246727
R764 VSS.n120 VSS.n119 0.245497
R765 VSS.n218 VSS.n217 0.240049
R766 VSS.n226 VSS.n225 0.240049
R767 VSS.n234 VSS.n233 0.240049
R768 VSS.n242 VSS.n241 0.240049
R769 VSS.n250 VSS.n249 0.240049
R770 VSS.n258 VSS.n257 0.240049
R771 VSS.n266 VSS.n265 0.240049
R772 VSS.n274 VSS.n273 0.240049
R773 VSS.n282 VSS.n281 0.240049
R774 VSS.n290 VSS.n289 0.240049
R775 VSS.n298 VSS.n297 0.240049
R776 VSS.n306 VSS.n305 0.240049
R777 VSS.n314 VSS.n313 0.240049
R778 VSS.n322 VSS.n321 0.240049
R779 VSS.n330 VSS.n329 0.240049
R780 VSS.n338 VSS.n337 0.240049
R781 VSS.n397 VSS.n129 0.237997
R782 VSS.n385 VSS.n139 0.237997
R783 VSS.n164 VSS.n149 0.237997
R784 VSS.n366 VSS.n170 0.237997
R785 VSS.n354 VSS.n179 0.237997
R786 VSS.n113 VSS.n107 0.234227
R787 VSS.n202 VSS.n201 0.232997
R788 VSS.n203 VSS.n202 0.231727
R789 VSS.n115 VSS.n107 0.230497
R790 VSS.n120 VSS.n118 0.219227
R791 VSS.n210 VSS.n209 0.217997
R792 VSS.n214 VSS.n213 0.211543
R793 VSS.n197 VSS.n196 0.201058
R794 VSS.n110 VSS.n109 0.200293
R795 VSS.n207 VSS.n206 0.191727
R796 VSS.n106 VSS.n105 0.190497
R797 VSS.n25 VSS.n121 0.318488
R798 VSS.n110 VSS.n101 0.161058
R799 VSS.n215 VSS.n214 0.161058
R800 VSS.n196 VSS.n195 0.160293
R801 VSS.n222 VSS.n221 0.15705
R802 VSS.n230 VSS.n229 0.15705
R803 VSS.n238 VSS.n237 0.15705
R804 VSS.n246 VSS.n245 0.15705
R805 VSS.n254 VSS.n253 0.15705
R806 VSS.n262 VSS.n261 0.15705
R807 VSS.n270 VSS.n269 0.15705
R808 VSS.n278 VSS.n277 0.15705
R809 VSS.n286 VSS.n285 0.15705
R810 VSS.n294 VSS.n293 0.15705
R811 VSS.n302 VSS.n301 0.15705
R812 VSS.n310 VSS.n309 0.15705
R813 VSS.n318 VSS.n317 0.15705
R814 VSS.n326 VSS.n325 0.15705
R815 VSS.n334 VSS.n333 0.15705
R816 VSS.n123 VSS.n122 0.156007
R817 VSS.n126 VSS.n125 0.155582
R818 VSS.n400 VSS.n127 0.155582
R819 VSS.n133 VSS.n132 0.155582
R820 VSS.n393 VSS.n136 0.155582
R821 VSS.n388 VSS.n137 0.155582
R822 VSS.n143 VSS.n142 0.155582
R823 VSS.n381 VSS.n146 0.155582
R824 VSS.n376 VSS.n147 0.155582
R825 VSS.n153 VSS.n152 0.155582
R826 VSS.n167 VSS.n166 0.155582
R827 VSS.n369 VSS.n168 0.155582
R828 VSS.n173 VSS.n172 0.155582
R829 VSS.n362 VSS.n176 0.155582
R830 VSS.n357 VSS.n177 0.155582
R831 VSS.n182 VSS.n181 0.155582
R832 VSS.n350 VSS.n185 0.155582
R833 VSS.n345 VSS.n186 0.155582
R834 VSS.n190 VSS.n189 0.155582
R835 VSS.n117 VSS.n115 0.149888
R836 VSS.n204 VSS.n203 0.14955
R837 VSS.n406 VSS.n405 0.149476
R838 VSS.n404 VSS.n403 0.149476
R839 VSS.n398 VSS.n128 0.149476
R840 VSS.n397 VSS.n396 0.149476
R841 VSS.n392 VSS.n391 0.149476
R842 VSS.n386 VSS.n138 0.149476
R843 VSS.n385 VSS.n384 0.149476
R844 VSS.n380 VSS.n379 0.149476
R845 VSS.n374 VSS.n148 0.149476
R846 VSS.n164 VSS.n163 0.149476
R847 VSS.n373 VSS.n372 0.149476
R848 VSS.n367 VSS.n169 0.149476
R849 VSS.n366 VSS.n365 0.149476
R850 VSS.n361 VSS.n360 0.149476
R851 VSS.n355 VSS.n178 0.149476
R852 VSS.n354 VSS.n353 0.149476
R853 VSS.n349 VSS.n348 0.149476
R854 VSS.n343 VSS.n187 0.149476
R855 VSS.n201 VSS.n200 0.147388
R856 VSS.n114 VSS.n113 0.14705
R857 VSS.n105 VSS.n103 0.142118
R858 VSS.n208 VSS.n207 0.142118
R859 VSS.n119 VSS.n102 0.134888
R860 VSS.n157 VSS.n150 0.134888
R861 VSS.n212 VSS.n211 0.13455
R862 VSS.n126 VSS.n124 0.129618
R863 VSS.n394 VSS.n393 0.129618
R864 VSS.n382 VSS.n381 0.129618
R865 VSS.n167 VSS.n162 0.129618
R866 VSS.n363 VSS.n362 0.129618
R867 VSS.n351 VSS.n350 0.129618
R868 VSS.n402 VSS.n401 0.126138
R869 VSS.n390 VSS.n389 0.126138
R870 VSS.n378 VSS.n377 0.126138
R871 VSS.n371 VSS.n370 0.126138
R872 VSS.n359 VSS.n358 0.126138
R873 VSS.n347 VSS.n346 0.126138
R874 VSS.n77 VSS.n395 0.156005
R875 VSS.n81 VSS.n383 0.156005
R876 VSS.n165 VSS.n86 0.156005
R877 VSS.n91 VSS.n364 0.156005
R878 VSS.n96 VSS.n352 0.156005
R879 VSS.n213 VSS.n212 0.122388
R880 VSS.n121 VSS.n102 0.12205
R881 VSS.n133 VSS.n131 0.12205
R882 VSS.n143 VSS.n141 0.12205
R883 VSS.n153 VSS.n151 0.12205
R884 VSS.n159 VSS.n150 0.12205
R885 VSS.n173 VSS.n171 0.12205
R886 VSS.n182 VSS.n180 0.12205
R887 VSS.n191 VSS.n190 0.12205
R888 VSS.n118 VSS.n103 0.114618
R889 VSS.n209 VSS.n208 0.114618
R890 VSS.n223 VSS.n222 0.113638
R891 VSS.n231 VSS.n230 0.113638
R892 VSS.n239 VSS.n238 0.113638
R893 VSS.n247 VSS.n246 0.113638
R894 VSS.n255 VSS.n254 0.113638
R895 VSS.n263 VSS.n262 0.113638
R896 VSS.n271 VSS.n270 0.113638
R897 VSS.n279 VSS.n278 0.113638
R898 VSS.n287 VSS.n286 0.113638
R899 VSS.n295 VSS.n294 0.113638
R900 VSS.n303 VSS.n302 0.113638
R901 VSS.n311 VSS.n310 0.113638
R902 VSS.n319 VSS.n318 0.113638
R903 VSS.n327 VSS.n326 0.113638
R904 VSS.n335 VSS.n334 0.113638
R905 VSS.n114 VSS.n112 0.109888
R906 VSS.n342 VSS.n341 0.109618
R907 VSS.n200 VSS.n199 0.10955
R908 VSS.n205 VSS.n204 0.107388
R909 VSS.n117 VSS.n116 0.10705
R910 VSS.n131 VSS.n130 0.106138
R911 VSS.n141 VSS.n140 0.106138
R912 VSS.n151 VSS.n84 0.106138
R913 VSS.n171 VSS.n89 0.106138
R914 VSS.n180 VSS.n94 0.106138
R915 VSS.n191 VSS.n99 0.106138
R916 VSS.n75 VSS.n402 0.166153
R917 VSS.n79 VSS.n390 0.166153
R918 VSS.n83 VSS.n378 0.166153
R919 VSS.n88 VSS.n371 0.166153
R920 VSS.n93 VSS.n359 0.166153
R921 VSS.n98 VSS.n347 0.166153
R922 VSS.n399 VSS.n398 0.105361
R923 VSS.n387 VSS.n386 0.105361
R924 VSS.n375 VSS.n374 0.105361
R925 VSS.n368 VSS.n367 0.105361
R926 VSS.n356 VSS.n355 0.105361
R927 VSS.n344 VSS.n343 0.105361
R928 VSS.n401 VSS.n400 0.10205
R929 VSS.n389 VSS.n388 0.10205
R930 VSS.n377 VSS.n376 0.10205
R931 VSS.n370 VSS.n369 0.10205
R932 VSS.n358 VSS.n357 0.10205
R933 VSS.n346 VSS.n345 0.10205
R934 VSS.n124 VSS.n123 0.0983676
R935 VSS.n395 VSS.n394 0.0983676
R936 VSS.n383 VSS.n382 0.0983676
R937 VSS.n165 VSS.n162 0.0983676
R938 VSS.n364 VSS.n363 0.0983676
R939 VSS.n352 VSS.n351 0.0983676
R940 VSS.n398 VSS.n76 0.0435295
R941 VSS.n386 VSS.n80 0.0435295
R942 VSS.n85 VSS.n84 0.176279
R943 VSS.n90 VSS.n89 0.176279
R944 VSS.n95 VSS.n94 0.176279
R945 VSS.n100 VSS.n99 0.176279
R946 VSS.n407 VSS.n101 0.078
R947 VSS.n195 VSS.n70 0.078
R948 VSS.n404 VSS.n74 0.103847
R949 VSS.n392 VSS.n78 0.103847
R950 VSS.n380 VSS.n82 0.103847
R951 VSS.n373 VSS.n87 0.103847
R952 VSS.n361 VSS.n92 0.103847
R953 VSS.n349 VSS.n97 0.103847
R954 VSS.n406 VSS.n122 0.0633093
R955 VSS VSS.n407 0.038
R956 VSS VSS.n70 0.038
R957 VSS.n36 VSS.t118 83.4525
R958 VSS.n35 VSS.t124 83.4525
R959 VSS.n17 VSS.n52 6.82258
R960 VSS.n17 VSS.n51 6.82258
R961 VSS.n50 VSS.t338 111.644
R962 VSS.n49 VSS.t335 111.644
R963 VSS.n34 VSS.t43 83.4525
R964 VSS.n37 VSS.t75 83.4525
R965 VSS.n5 VSS.t13 83.4525
R966 VSS.n48 VSS.t54 111.644
R967 VSS.n17 VSS.n2 0.382621
R968 VSS.n33 VSS.t109 83.4525
R969 VSS.n17 VSS.n1 0.382621
R970 VSS.n17 VSS.n47 6.82258
R971 VSS.n345 VSS.n344 0.0166107
R972 VSS.n357 VSS.n356 0.0166107
R973 VSS.n369 VSS.n368 0.0166107
R974 VSS.n376 VSS.n375 0.0166107
R975 VSS.n388 VSS.n387 0.0166107
R976 VSS.n400 VSS.n399 0.0166107
R977 VSS.n24 VSS.t92 140.651
R978 VSS.n21 VSS.t83 82.6299
R979 VSS.n24 VSS.t89 140.651
R980 VSS.n24 VSS.t180 140.651
R981 VSS.n17 VSS.n0 1.35318
R982 VSS.n24 VSS.n21 1.27471
R983 VSS.n17 VSS.n31 1.12935
R984 a_3747_216.n0 a_3747_216.t2 52.0388
R985 a_3747_216.t0 a_3747_216.n0 35.4491
R986 a_3747_216.n0 a_3747_216.t3 33.5891
R987 a_3747_216.t1 a_3747_216.t0 5.61942
R988 a_3171_216.n0 a_3171_216.t2 51.8377
R989 a_3171_216.n0 a_3171_216.t3 33.3881
R990 a_3171_216.t0 a_3171_216.n0 31.8923
R991 a_3171_216.t1 a_3171_216.t0 5.61777
R992 a_2595_216.n0 a_2595_216.t2 51.6367
R993 a_2595_216.n0 a_2595_216.t3 33.187
R994 a_2595_216.t0 a_2595_216.n0 27.993
R995 a_2595_216.t1 a_2595_216.t0 5.73018
R996 a_3747_952.n0 a_3747_952.t2 38.0081
R997 a_3747_952.n0 a_3747_952.t3 33.3957
R998 a_3747_952.n1 a_3747_952.t4 33.3957
R999 a_3747_952.n2 a_3747_952.t5 33.3957
R1000 a_3747_952.n3 a_3747_952.t6 33.3957
R1001 a_3747_952.n4 a_3747_952.t7 33.3957
R1002 a_3747_952.n5 a_3747_952.t8 33.3957
R1003 a_3747_952.n6 a_3747_952.t9 33.3957
R1004 a_3747_952.t0 a_3747_952.n6 23.2419
R1005 a_3747_952.t1 a_3747_952.t0 5.61942
R1006 a_3747_952.n6 a_3747_952.n5 4.61291
R1007 a_3747_952.n5 a_3747_952.n4 4.61291
R1008 a_3747_952.n4 a_3747_952.n3 4.61291
R1009 a_3747_952.n3 a_3747_952.n2 4.61291
R1010 a_3747_952.n2 a_3747_952.n1 4.61291
R1011 a_3747_952.n1 a_3747_952.n0 4.61291
R1012 a_3171_952.n0 a_3171_952.t2 37.8054
R1013 a_3171_952.n0 a_3171_952.t3 33.193
R1014 a_3171_952.n1 a_3171_952.t4 33.193
R1015 a_3171_952.n2 a_3171_952.t5 33.193
R1016 a_3171_952.n3 a_3171_952.t6 33.193
R1017 a_3171_952.n4 a_3171_952.t7 33.193
R1018 a_3171_952.n5 a_3171_952.t8 33.193
R1019 a_3171_952.n6 a_3171_952.t9 33.193
R1020 a_3171_952.t0 a_3171_952.n6 23.0313
R1021 a_3171_952.t1 a_3171_952.t0 5.61777
R1022 a_3171_952.n6 a_3171_952.n5 4.61291
R1023 a_3171_952.n5 a_3171_952.n4 4.61291
R1024 a_3171_952.n4 a_3171_952.n3 4.61291
R1025 a_3171_952.n3 a_3171_952.n2 4.61291
R1026 a_3171_952.n2 a_3171_952.n1 4.61291
R1027 a_3171_952.n1 a_3171_952.n0 4.61291
R1028 a_2595_952.n0 a_2595_952.t2 37.7691
R1029 a_2595_952.n0 a_2595_952.t3 33.1567
R1030 a_2595_952.n1 a_2595_952.t4 33.1567
R1031 a_2595_952.n2 a_2595_952.t5 33.1567
R1032 a_2595_952.n3 a_2595_952.t6 33.1567
R1033 a_2595_952.n4 a_2595_952.t7 33.1567
R1034 a_2595_952.n5 a_2595_952.t8 33.1567
R1035 a_2595_952.n6 a_2595_952.t9 33.1567
R1036 a_2595_952.t0 a_2595_952.n6 22.7941
R1037 a_2595_952.t1 a_2595_952.t0 5.65522
R1038 a_2595_952.n6 a_2595_952.n5 4.61291
R1039 a_2595_952.n5 a_2595_952.n4 4.61291
R1040 a_2595_952.n4 a_2595_952.n3 4.61291
R1041 a_2595_952.n3 a_2595_952.n2 4.61291
R1042 a_2595_952.n2 a_2595_952.n1 4.61291
R1043 a_2595_952.n1 a_2595_952.n0 4.61291
R1044 a_2019_952.n0 a_2019_952.t2 37.9701
R1045 a_2019_952.n0 a_2019_952.t3 33.3577
R1046 a_2019_952.n1 a_2019_952.t4 33.3577
R1047 a_2019_952.n2 a_2019_952.t5 33.3577
R1048 a_2019_952.n3 a_2019_952.t6 33.3577
R1049 a_2019_952.n4 a_2019_952.t7 33.3577
R1050 a_2019_952.t0 a_2019_952.t9 22.5945
R1051 a_2019_952.t1 a_2019_952.t0 5.62052
R1052 a_2019_952.t9 a_2019_952.t8 4.61291
R1053 a_2019_952.t8 a_2019_952.n4 4.61291
R1054 a_2019_952.n4 a_2019_952.n3 4.61291
R1055 a_2019_952.n3 a_2019_952.n2 4.61291
R1056 a_2019_952.n2 a_2019_952.n1 4.61291
R1057 a_2019_952.n1 a_2019_952.n0 4.61291
C578 MUX_OUT VSS 3.24057f
C579 MUX_SEL4 VSS 1.63591f
C580 DELAY_OUT_TAP0 VSS 0.37425f
C581 MUX_SEL3 VSS 0.90686f
C582 MUX_SEL2 VSS 1.81137f
C583 DELAY_OUT_TAP31 VSS 0.41949f
C584 DELAY_OUT_TAP30 VSS 0.43238f
C585 DELAY_OUT_TAP29 VSS 0.30856f
C586 DELAY_OUT_TAP28 VSS 0.4381f
C587 DELAY_OUT_TAP27 VSS 0.38455f
C588 DELAY_OUT_TAP26 VSS 0.43238f
C589 DELAY_OUT_TAP25 VSS 0.30856f
C590 DELAY_OUT_TAP24 VSS 0.4381f
C591 DELAY_OUT_TAP23 VSS 0.38455f
C592 DELAY_OUT_TAP22 VSS 0.43238f
C593 DELAY_OUT_TAP21 VSS 0.30856f
C594 DELAY_OUT_TAP20 VSS 0.4381f
C595 DELAY_OUT_TAP19 VSS 0.38455f
C596 DELAY_OUT_TAP18 VSS 0.43238f
C597 DELAY_OUT_TAP17 VSS 0.30374f
C598 DELAY_OUT_TAP16 VSS 0.42869f
C599 DELAY_OUT_TAP15 VSS 0.38342f
C600 DELAY_OUT_TAP14 VSS 0.43238f
C601 DELAY_OUT_TAP13 VSS 0.30856f
C602 DELAY_OUT_TAP12 VSS 0.43643f
C603 DELAY_OUT_TAP11 VSS 0.38455f
C604 DELAY_OUT_TAP10 VSS 0.43238f
C605 DELAY_OUT_TAP9 VSS 0.30856f
C606 DELAY_OUT_TAP8 VSS 0.43643f
C607 DELAY_OUT_TAP7 VSS 0.38455f
C608 DELAY_OUT_TAP6 VSS 0.43238f
C609 DELAY_OUT_TAP5 VSS 0.30856f
C610 DELAY_OUT_TAP4 VSS 0.43585f
C611 DELAY_OUT_TAP3 VSS 0.38455f
C612 DELAY_OUT_TAP2 VSS 0.43238f
C613 DELAY_OUT_TAP1 VSS 0.30776f
C614 MUX_SEL1 VSS 0.9549f
C615 MUX_SEL0 VSS 1.81267f
C616 VDD VSS 26.9372f
C617 a_26985_424# VSS 0.18005f ; **FLOATING
C618 a_23945_424# VSS 0.18005f ; **FLOATING
C619 a_20905_424# VSS 0.18005f ; **FLOATING
C620 a_17865_424# VSS 0.1767f ; **FLOATING
C621 a_16851_214# VSS 0.38749f ; **FLOATING
C622 a_16108_194# VSS 3.72469f ; **FLOATING
C623 a_15964_194# VSS 0.18406f ; **FLOATING
C624 a_15765_368# VSS 0.36264f ; **FLOATING
C625 a_14825_424# VSS 0.18005f ; **FLOATING
C626 a_11785_424# VSS 0.18005f ; **FLOATING
C627 a_8745_424# VSS 0.18005f ; **FLOATING
C628 a_5731_194# VSS 3.39133f ; **FLOATING
C629 a_2019_216# VSS 1.616f ; **FLOATING
C630 a_5705_424# VSS 0.17716f ; **FLOATING
C631 a_3449_236# VSS 0.18478f ; **FLOATING
C632 a_2873_236# VSS 0.18321f ; **FLOATING
C633 a_2297_236# VSS 0.18321f ; **FLOATING
C634 a_1721_236# VSS 0.17001f ; **FLOATING
C635 a_1544_194# VSS 0.30014f ; **FLOATING
C636 a_1256_194# VSS 0.84266f ; **FLOATING
C637 a_27991_913# VSS 0.18706f ; **FLOATING
C638 a_27915_949# VSS 0.10926f ; **FLOATING
C639 a_27124_913# VSS 0.17878f ; **FLOATING
C640 a_27048_949# VSS 0.12122f ; **FLOATING
C641 a_26471_913# VSS 0.18175f ; **FLOATING
C642 a_26395_949# VSS 0.11073f ; **FLOATING
C643 a_25604_913# VSS 0.18087f ; **FLOATING
C644 a_25630_949# VSS 0.46834f ; **FLOATING
C645 a_25528_949# VSS 0.12433f ; **FLOATING
C646 a_24951_913# VSS 0.18335f ; **FLOATING
C647 a_24875_949# VSS 0.11016f ; **FLOATING
C648 a_24084_913# VSS 0.17878f ; **FLOATING
C649 a_24008_949# VSS 0.12122f ; **FLOATING
C650 a_23431_913# VSS 0.18175f ; **FLOATING
C651 a_23355_949# VSS 0.11073f ; **FLOATING
C652 a_22564_913# VSS 0.18087f ; **FLOATING
C653 a_22590_949# VSS 0.40111f ; **FLOATING
C654 a_22488_949# VSS 0.12433f ; **FLOATING
C655 a_21911_913# VSS 0.18335f ; **FLOATING
C656 a_21835_949# VSS 0.11016f ; **FLOATING
C657 a_21044_913# VSS 0.17878f ; **FLOATING
C658 a_20968_949# VSS 0.12122f ; **FLOATING
C659 a_20391_913# VSS 0.18175f ; **FLOATING
C660 a_20315_949# VSS 0.11073f ; **FLOATING
C661 a_19524_913# VSS 0.18087f ; **FLOATING
C662 a_19550_949# VSS 0.4036f ; **FLOATING
C663 a_19448_949# VSS 0.12433f ; **FLOATING
C664 a_18871_913# VSS 0.18335f ; **FLOATING
C665 a_18795_949# VSS 0.11016f ; **FLOATING
C666 a_18004_913# VSS 0.17878f ; **FLOATING
C667 a_17928_949# VSS 0.12122f ; **FLOATING
C668 a_17351_913# VSS 0.18022f ; **FLOATING
C669 a_17275_949# VSS 0.10926f ; **FLOATING
C670 a_16484_913# VSS 0.18023f ; **FLOATING
C671 a_16510_949# VSS 0.35732f ; **FLOATING
C672 a_16408_949# VSS 0.1229f ; **FLOATING
C673 a_15831_913# VSS 0.17846f ; **FLOATING
C674 a_15755_949# VSS 0.10926f ; **FLOATING
C675 a_14964_913# VSS 0.17878f ; **FLOATING
C676 a_14888_949# VSS 0.12122f ; **FLOATING
C677 a_14311_913# VSS 0.18175f ; **FLOATING
C678 a_14235_949# VSS 0.11073f ; **FLOATING
C679 a_13444_913# VSS 0.18087f ; **FLOATING
C680 a_13470_949# VSS 0.3713f ; **FLOATING
C681 a_13368_949# VSS 0.12433f ; **FLOATING
C682 a_12791_913# VSS 0.18335f ; **FLOATING
C683 a_12715_949# VSS 0.11016f ; **FLOATING
C684 a_11924_913# VSS 0.17878f ; **FLOATING
C685 a_11848_949# VSS 0.12122f ; **FLOATING
C686 a_11271_913# VSS 0.18175f ; **FLOATING
C687 a_11195_949# VSS 0.11073f ; **FLOATING
C688 a_10404_913# VSS 0.18087f ; **FLOATING
C689 a_10430_949# VSS 0.38462f ; **FLOATING
C690 a_10328_949# VSS 0.12433f ; **FLOATING
C691 a_9751_913# VSS 0.18335f ; **FLOATING
C692 a_9675_949# VSS 0.11016f ; **FLOATING
C693 a_8884_913# VSS 0.17878f ; **FLOATING
C694 a_8808_949# VSS 0.12122f ; **FLOATING
C695 a_8231_913# VSS 0.18175f ; **FLOATING
C696 a_8155_949# VSS 0.11073f ; **FLOATING
C697 a_7364_913# VSS 0.18087f ; **FLOATING
C698 a_7390_949# VSS 0.38153f ; **FLOATING
C699 a_7288_949# VSS 0.12433f ; **FLOATING
C700 a_6711_913# VSS 0.18335f ; **FLOATING
C701 a_6635_949# VSS 0.11016f ; **FLOATING
C702 a_5844_913# VSS 0.17878f ; **FLOATING
C703 a_5768_949# VSS 0.12122f ; **FLOATING
C704 a_5191_913# VSS 0.18022f ; **FLOATING
C705 a_5115_949# VSS 0.10926f ; **FLOATING
C706 a_4324_913# VSS 0.18023f ; **FLOATING
C707 a_4350_949# VSS 0.33452f ; **FLOATING
C708 a_4248_949# VSS 0.12443f ; **FLOATING
C709 a_27705_949# VSS 0.2535f ; **FLOATING
C710 a_26185_949# VSS 0.23529f ; **FLOATING
C711 a_24665_949# VSS 0.25486f ; **FLOATING
C712 a_23145_949# VSS 0.23529f ; **FLOATING
C713 a_21625_949# VSS 0.25486f ; **FLOATING
C714 a_20105_949# VSS 0.23529f ; **FLOATING
C715 a_18585_949# VSS 0.25486f ; **FLOATING
C716 a_17065_949# VSS 0.23439f ; **FLOATING
C717 a_15545_949# VSS 0.2535f ; **FLOATING
C718 a_14025_949# VSS 0.23529f ; **FLOATING
C719 a_12505_949# VSS 0.25486f ; **FLOATING
C720 a_10985_949# VSS 0.23529f ; **FLOATING
C721 a_9465_949# VSS 0.25486f ; **FLOATING
C722 a_7945_949# VSS 0.23529f ; **FLOATING
C723 a_6425_949# VSS 0.25486f ; **FLOATING
C724 a_4905_949# VSS 0.23602f ; **FLOATING
C725 a_4157_1218# VSS 0.3431f ; **FLOATING
C726 a_3449_1300# VSS 0.18603f ; **FLOATING
C727 a_2873_1300# VSS 0.18321f ; **FLOATING
C728 a_2297_1300# VSS 0.18321f ; **FLOATING
C729 a_1721_1300# VSS 0.17001f ; **FLOATING
C730 a_1544_949# VSS 0.29963f ; **FLOATING
C731 a_1256_949# VSS 0.83916f ; **FLOATING
C732 a_2019_952.t2 VSS 0.8244f ; **FLOATING
C733 a_2019_952.t3 VSS 0.62586f ; **FLOATING
C734 a_2019_952.n0 VSS 4.43882f ; **FLOATING
C735 a_2019_952.t4 VSS 0.62586f ; **FLOATING
C736 a_2019_952.n1 VSS 3.00299f ; **FLOATING
C737 a_2019_952.t5 VSS 0.62586f ; **FLOATING
C738 a_2019_952.n2 VSS 3.00299f ; **FLOATING
C739 a_2019_952.t6 VSS 0.62586f ; **FLOATING
C740 a_2019_952.n3 VSS 3.00299f ; **FLOATING
C741 a_2019_952.t7 VSS 0.62586f ; **FLOATING
C742 a_2019_952.n4 VSS 3.00299f ; **FLOATING
C743 a_2019_952.t8 VSS 3.62885f ; **FLOATING
C744 a_2019_952.t9 VSS 4.83408f ; **FLOATING
C745 a_2019_952.t0 VSS 0.95051f ; **FLOATING
C746 a_2019_952.t1 VSS 0.27016f ; **FLOATING
C747 a_2595_952.t2 VSS 1.35979f ; **FLOATING
C748 a_2595_952.t3 VSS 1.01554f ; **FLOATING
C749 a_2595_952.n0 VSS 7.72017f ; **FLOATING
C750 a_2595_952.t4 VSS 1.01554f ; **FLOATING
C751 a_2595_952.n1 VSS 5.2455f ; **FLOATING
C752 a_2595_952.t5 VSS 1.01554f ; **FLOATING
C753 a_2595_952.n2 VSS 5.2455f ; **FLOATING
C754 a_2595_952.t6 VSS 1.01554f ; **FLOATING
C755 a_2595_952.n3 VSS 5.2455f ; **FLOATING
C756 a_2595_952.t7 VSS 1.01554f ; **FLOATING
C757 a_2595_952.n4 VSS 5.2455f ; **FLOATING
C758 a_2595_952.t8 VSS 1.01554f ; **FLOATING
C759 a_2595_952.n5 VSS 5.2455f ; **FLOATING
C760 a_2595_952.t9 VSS 1.01554f ; **FLOATING
C761 a_2595_952.n6 VSS 7.54534f ; **FLOATING
C762 a_2595_952.t0 VSS 1.74193f ; **FLOATING
C763 a_2595_952.t1 VSS 0.47972f ; **FLOATING
C764 a_3171_952.t2 VSS 1.37934f ; **FLOATING
C765 a_3171_952.t3 VSS 1.03353f ; **FLOATING
C766 a_3171_952.n0 VSS 7.75002f ; **FLOATING
C767 a_3171_952.t4 VSS 1.03353f ; **FLOATING
C768 a_3171_952.n1 VSS 5.26145f ; **FLOATING
C769 a_3171_952.t5 VSS 1.03353f ; **FLOATING
C770 a_3171_952.n2 VSS 5.26145f ; **FLOATING
C771 a_3171_952.t6 VSS 1.03353f ; **FLOATING
C772 a_3171_952.n3 VSS 5.26145f ; **FLOATING
C773 a_3171_952.t7 VSS 1.03353f ; **FLOATING
C774 a_3171_952.n4 VSS 5.26145f ; **FLOATING
C775 a_3171_952.t8 VSS 1.03353f ; **FLOATING
C776 a_3171_952.n5 VSS 5.26145f ; **FLOATING
C777 a_3171_952.t9 VSS 1.03353f ; **FLOATING
C778 a_3171_952.n6 VSS 7.65527f ; **FLOATING
C779 a_3171_952.t0 VSS 1.76377f ; **FLOATING
C780 a_3171_952.t1 VSS 0.47908f ; **FLOATING
C781 a_3747_952.t2 VSS 0.96134f ; **FLOATING
C782 a_3747_952.t3 VSS 0.73188f ; **FLOATING
C783 a_3747_952.n0 VSS 5.12738f ; **FLOATING
C784 a_3747_952.t4 VSS 0.73188f ; **FLOATING
C785 a_3747_952.n1 VSS 3.46604f ; **FLOATING
C786 a_3747_952.t5 VSS 0.73188f ; **FLOATING
C787 a_3747_952.n2 VSS 3.46604f ; **FLOATING
C788 a_3747_952.t6 VSS 0.73188f ; **FLOATING
C789 a_3747_952.n3 VSS 3.46604f ; **FLOATING
C790 a_3747_952.t7 VSS 0.73188f ; **FLOATING
C791 a_3747_952.n4 VSS 3.46604f ; **FLOATING
C792 a_3747_952.t8 VSS 0.73188f ; **FLOATING
C793 a_3747_952.n5 VSS 3.46604f ; **FLOATING
C794 a_3747_952.t9 VSS 0.73188f ; **FLOATING
C795 a_3747_952.n6 VSS 5.14666f ; **FLOATING
C796 a_3747_952.t0 VSS 1.17616f ; **FLOATING
C797 a_3747_952.t1 VSS 0.31095f ; **FLOATING
C798 a_2595_216.t0 VSS 3.2703f ; **FLOATING
C799 a_2595_216.t2 VSS 5.04135f ; **FLOATING
C800 a_2595_216.t3 VSS 1.20629f ; **FLOATING
C801 a_2595_216.n0 VSS 26.8663f ; **FLOATING
C802 a_2595_216.t1 VSS 0.49571f ; **FLOATING
C803 a_3171_216.t2 VSS 5.0499f ; **FLOATING
C804 a_3171_216.t3 VSS 1.21145f ; **FLOATING
C805 a_3171_216.n0 VSS 29.8488f ; **FLOATING
C806 a_3171_216.t0 VSS 4.61136f ; **FLOATING
C807 a_3171_216.t1 VSS 0.49728f ; **FLOATING
C808 a_3747_216.t2 VSS 3.08713f ; **FLOATING
C809 a_3747_216.t3 VSS 0.74304f ; **FLOATING
C810 a_3747_216.n0 VSS 19.8571f ; **FLOATING
C811 a_3747_216.t0 VSS 3.68309f ; **FLOATING
C812 a_3747_216.t1 VSS 0.30489f ; **FLOATING
.ends
