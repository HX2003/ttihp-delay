* NGSPICE file created from hx_mux.ext - technology: ihp-sg13g2

.subckt hx_mux VSS VDD DELAY_OUT_TAP0 DELAY_OUT_TAP1 DELAY_OUT_TAP2 DELAY_OUT_TAP3
+ DELAY_OUT_TAP4 DELAY_OUT_TAP5 DELAY_OUT_TAP6 DELAY_OUT_TAP7 DELAY_OUT_TAP8 DELAY_OUT_TAP9
+ DELAY_OUT_TAP10 DELAY_OUT_TAP11 DELAY_OUT_TAP12 DELAY_OUT_TAP13 DELAY_OUT_TAP14
+ DELAY_OUT_TAP15 DELAY_OUT_TAP16 DELAY_OUT_TAP17 DELAY_OUT_TAP18 DELAY_OUT_TAP19
+ DELAY_OUT_TAP20 DELAY_OUT_TAP21 DELAY_OUT_TAP22 DELAY_OUT_TAP23 DELAY_OUT_TAP24
+ DELAY_OUT_TAP25 DELAY_OUT_TAP26 DELAY_OUT_TAP27 DELAY_OUT_TAP28 DELAY_OUT_TAP29
+ DELAY_OUT_TAP30 DELAY_OUT_TAP31 MUX_SEL0 MUX_SEL1 MUX_OUT MUX_SEL4 MUX_SEL2 MUX_SEL3
X0 VDD a_2019_952.t9 a_4324_913# VDD sg13_lv_pmos ad=0.3808p pd=2.92u as=0.3808p ps=2.92u w=1.12u l=0.13u
X1 a_1256_194# MUX_SEL2 VDD VDD sg13_lv_pmos ad=0.3808p pd=2.92u as=0.3808p ps=2.92u w=1.12u l=0.13u
X2 VDD a_3171_952.t8 a_8884_913# VDD sg13_lv_pmos ad=0.3808p pd=2.92u as=0.3808p ps=2.92u w=1.12u l=0.13u
X3 a_16108_194# a_15765_368# a_15964_194# VDD sg13_lv_pmos ad=0.3808p pd=2.92u as=0.3304p ps=1.71u w=1.12u l=0.13u
X4 a_22590_949# a_24951_913# a_24875_949# VDD sg13_lv_pmos ad=0.3808p pd=2.92u as=0.2128p ps=1.5u w=1.12u l=0.13u
X5 VDD a_2595_952.t7 a_11271_913# VDD sg13_lv_pmos ad=0.3808p pd=2.92u as=0.3808p ps=2.92u w=1.12u l=0.13u
X6 VSS.t202 VDD VSS.t200 VSS.t201 sg13_lv_nmos ad=79.8f pd=0.8u as=0 ps=0 w=0.42u l=1u
X7 a_7390_949# a_2595_952.t8 a_8155_949# VSS.t79 sg13_lv_nmos ad=0.2516p pd=2.16u as=0.1406p ps=1.12u w=0.74u l=0.13u
X8 VSS.t205 VDD VSS.t204 VSS.t203 sg13_lv_nmos ad=0.1428p pd=1.52u as=0 ps=0 w=0.42u l=1u
X9 VDD VSS.t381 VDD VDD sg13_lv_pmos ad=0.19p pd=1.38u as=0.14315n ps=0.71478m w=1u l=1u
X10 VSS.t152 DELAY_OUT_TAP11 a_12505_949# VSS.t192 sg13_lv_nmos ad=0.1665p pd=1.19u as=0.2516p ps=2.16u w=0.74u l=0.13u
X11 MUX_OUT a_16851_214# VSS.t170 VSS.t169 sg13_lv_nmos ad=0.1406p pd=1.12u as=0.1371p ps=1.12u w=0.74u l=0.13u
X12 VDD a_3747_952.t9 a_6711_913# VDD sg13_lv_pmos ad=0.3808p pd=2.92u as=0.3808p ps=2.92u w=1.12u l=0.13u
X13 VSS.t270 VDD VSS.t269 VSS.t268 sg13_lv_nmos ad=0.1428p pd=1.52u as=0 ps=0 w=0.42u l=1u
X14 a_1544_194# MUX_SEL3 VDD VDD sg13_lv_pmos ad=0.3808p pd=2.92u as=0.3808p ps=2.92u w=1.12u l=0.13u
X15 VSS.t165 a_2595_216.t3 a_8745_424# VSS.t164 sg13_lv_nmos ad=0.2516p pd=2.16u as=0.2516p ps=2.16u w=0.74u l=0.13u
X16 a_10328_949# DELAY_OUT_TAP8 VSS.t303 VSS.t302 sg13_lv_nmos ad=0.1406p pd=1.12u as=0.2516p ps=2.16u w=0.74u l=0.13u
X17 a_22590_949# a_2019_952.t3 a_22488_949# VSS.t36 sg13_lv_nmos ad=0.2516p pd=2.16u as=0.1406p ps=1.12u w=0.74u l=0.13u
X18 a_8808_949# DELAY_OUT_TAP6 VSS.t305 VSS.t304 sg13_lv_nmos ad=0.1406p pd=1.12u as=0.2516p ps=2.16u w=0.74u l=0.13u
X19 VSS.t22 DELAY_OUT_TAP31 a_27705_949# VSS.t21 sg13_lv_nmos ad=0.1665p pd=1.19u as=0.2516p ps=2.16u w=0.74u l=0.13u
X20 a_11848_949# DELAY_OUT_TAP10 VDD VDD sg13_lv_pmos ad=0.2128p pd=1.5u as=0.3808p ps=2.92u w=1.12u l=0.13u
X21 VDD a_3171_952.t3 a_24084_913# VDD sg13_lv_pmos ad=0.3808p pd=2.92u as=0.3808p ps=2.92u w=1.12u l=0.13u
X22 a_1721_236# a_1256_194# VDD VDD sg13_lv_pmos ad=0.1596p pd=1.22u as=0.2856p ps=2.36u w=0.84u l=0.13u
X23 a_6635_949# a_6425_949# VSS.t137 VSS.t136 sg13_lv_nmos ad=0.1406p pd=1.12u as=0.1665p ps=1.19u w=0.74u l=0.13u
X24 VDD VSS.t374 VDD VDD sg13_lv_pmos ad=0.34p pd=2.68u as=0 ps=0 w=1u l=1u
X25 VSS.t13 a_2595_952.t9 a_5191_913# VSS.t12 sg13_lv_nmos ad=0.2516p pd=2.16u as=0.2516p ps=2.16u w=0.74u l=0.13u
X26 VSS.t286 a_1256_949# a_2967_1300# VSS.t295 sg13_lv_nmos ad=0.1331p pd=1.12u as=0.1216p ps=1.02u w=0.64u l=0.13u
X27 a_4157_1218# DELAY_OUT_TAP0 VDD VDD sg13_lv_pmos ad=0.3808p pd=2.92u as=0.3808p ps=2.92u w=1.12u l=0.13u
X28 a_25528_949# DELAY_OUT_TAP28 VSS.t315 VSS.t314 sg13_lv_nmos ad=0.1406p pd=1.12u as=0.2516p ps=2.16u w=0.74u l=0.13u
X29 a_20315_949# a_20105_949# VSS.t120 VSS.t119 sg13_lv_nmos ad=0.1406p pd=1.12u as=0.1665p ps=1.19u w=0.74u l=0.13u
X30 a_5731_194# a_3747_216.t3 a_13470_949# VSS.t157 sg13_lv_nmos ad=0.2516p pd=2.16u as=0.2516p ps=2.16u w=0.74u l=0.13u
X31 VSS.t262 VDD VSS.t260 VSS.t261 sg13_lv_nmos ad=79.8f pd=0.8u as=0 ps=0 w=0.42u l=1u
X32 VSS.t227 VDD VSS.t225 VSS.t226 sg13_lv_nmos ad=79.8f pd=0.8u as=0 ps=0 w=0.42u l=1u
X33 VSS.t172 a_16851_214# MUX_OUT VSS.t171 sg13_lv_nmos ad=0.2516p pd=2.16u as=0.1406p ps=1.12u w=0.74u l=0.13u
X34 VDD a_1544_194# a_1721_236# VDD sg13_lv_pmos ad=0.1918p pd=1.5u as=0.1596p ps=1.22u w=0.84u l=0.13u
X35 VDD a_3747_952.t3 a_24951_913# VDD sg13_lv_pmos ad=0.3808p pd=2.92u as=0.3808p ps=2.92u w=1.12u l=0.13u
X36 VDD VSS.t386 VDD VDD sg13_lv_pmos ad=0.34p pd=2.68u as=0 ps=0 w=1u l=1u
X37 a_16408_949# DELAY_OUT_TAP16 VSS.t348 VSS.t347 sg13_lv_nmos ad=0.1406p pd=1.12u as=0.2516p ps=2.16u w=0.74u l=0.13u
X38 a_5731_194# a_2019_216# a_4350_949# VSS.t94 sg13_lv_nmos ad=0.2516p pd=2.16u as=0.2516p ps=2.16u w=0.74u l=0.13u
X39 VDD a_2595_952.t2 a_26471_913# VDD sg13_lv_pmos ad=0.3808p pd=2.92u as=0.3808p ps=2.92u w=1.12u l=0.13u
X40 a_7390_949# a_3747_952.t8 a_9675_949# VSS.t8 sg13_lv_nmos ad=0.2516p pd=2.16u as=0.1406p ps=1.12u w=0.74u l=0.13u
X41 VSS.t200 VDD VSS.t199 VSS.t198 sg13_lv_nmos ad=0.1428p pd=1.52u as=0 ps=0 w=0.42u l=1u
X42 VDD VSS.t357 VDD VDD sg13_lv_pmos ad=0.19p pd=1.38u as=0 ps=0 w=1u l=1u
X43 VDD DELAY_OUT_TAP13 a_14025_949# VDD sg13_lv_pmos ad=0.252p pd=1.57u as=0.3808p ps=2.92u w=1.12u l=0.13u
X44 a_10430_949# a_11924_913# a_11848_949# VDD sg13_lv_pmos ad=0.3808p pd=2.92u as=0.2128p ps=1.5u w=1.12u l=0.13u
X45 VDD a_2595_216.t3 a_8745_424# VDD sg13_lv_pmos ad=0.3808p pd=2.92u as=0.3808p ps=2.92u w=1.12u l=0.13u
X46 VSS.t51 a_3171_952.t5 a_18004_913# VSS.t50 sg13_lv_nmos ad=0.2516p pd=2.16u as=0.2516p ps=2.16u w=0.74u l=0.13u
X47 VDD DELAY_OUT_TAP15 a_15545_949# VDD sg13_lv_pmos ad=0.252p pd=1.57u as=0.3808p ps=2.92u w=1.12u l=0.13u
X48 a_3171_216.t1 a_2873_236# VDD VDD sg13_lv_pmos ad=0.2128p pd=1.5u as=0.1918p ps=1.5u w=1.12u l=0.13u
X49 a_14235_949# a_14025_949# VSS.t90 VSS.t89 sg13_lv_nmos ad=0.1406p pd=1.12u as=0.1665p ps=1.19u w=0.74u l=0.13u
X50 VSS.t343 a_3747_952.t7 a_12791_913# VSS.t342 sg13_lv_nmos ad=0.2516p pd=2.16u as=0.2516p ps=2.16u w=0.74u l=0.13u
X51 a_3747_216.t1 a_3449_236# VDD VDD sg13_lv_pmos ad=0.2128p pd=1.5u as=0.1918p ps=1.5u w=1.12u l=0.13u
X52 a_12715_949# a_12505_949# VDD VDD sg13_lv_pmos ad=0.2128p pd=1.5u as=0.252p ps=1.57u w=1.12u l=0.13u
X53 a_11848_949# DELAY_OUT_TAP10 VSS.t187 VSS.t186 sg13_lv_nmos ad=0.1406p pd=1.12u as=0.2516p ps=2.16u w=0.74u l=0.13u
X54 a_17275_949# a_17065_949# VDD VDD sg13_lv_pmos ad=0.2128p pd=1.5u as=0.252p ps=1.57u w=1.12u l=0.13u
X55 VDD VSS.t389 VDD VDD sg13_lv_pmos ad=0.19p pd=1.38u as=0 ps=0 w=1u l=1u
X56 VDD VSS.t388 VDD VDD sg13_lv_pmos ad=0.34p pd=2.68u as=0 ps=0 w=1u l=1u
X57 a_10430_949# a_12791_913# a_12715_949# VDD sg13_lv_pmos ad=0.3808p pd=2.92u as=0.2128p ps=1.5u w=1.12u l=0.13u
X58 VSS.t120 DELAY_OUT_TAP21 a_20105_949# VSS.t349 sg13_lv_nmos ad=0.1665p pd=1.19u as=0.2516p ps=2.16u w=0.74u l=0.13u
X59 a_16510_949# a_17351_913# a_17275_949# VDD sg13_lv_pmos ad=0.3808p pd=2.92u as=0.2128p ps=1.5u w=1.12u l=0.13u
X60 VSS.t298 a_1721_1300# a_2019_952.t0 VSS.t297 sg13_lv_nmos ad=0.2812p pd=2.24u as=0.1406p ps=1.12u w=0.74u l=0.13u
X61 a_5731_194# a_14825_424# a_13470_949# VDD sg13_lv_pmos ad=0.3808p pd=2.92u as=0.3808p ps=2.92u w=1.12u l=0.13u
X62 a_16510_949# a_2595_952.t5 a_17275_949# VSS.t84 sg13_lv_nmos ad=0.2516p pd=2.16u as=0.1406p ps=1.12u w=0.74u l=0.13u
X63 a_8155_949# a_7945_949# VDD VDD sg13_lv_pmos ad=0.2128p pd=1.5u as=0.252p ps=1.57u w=1.12u l=0.13u
X64 VDD VSS.t362 VDD VDD sg13_lv_pmos ad=0.34p pd=2.68u as=0 ps=0 w=1u l=1u
X65 VSS.t123 a_3747_952.t2 a_27991_913# VSS.t122 sg13_lv_nmos ad=0.2516p pd=2.16u as=0.2516p ps=2.16u w=0.74u l=0.13u
X66 VSS.t325 a_3747_952.t9 a_6711_913# VSS.t324 sg13_lv_nmos ad=0.2516p pd=2.16u as=0.2516p ps=2.16u w=0.74u l=0.13u
X67 a_16108_194# a_2595_216.t2 a_19550_949# VSS.t166 sg13_lv_nmos ad=0.2516p pd=2.16u as=0.2516p ps=2.16u w=0.74u l=0.13u
X68 VSS.t260 VDD VSS.t259 VSS.t258 sg13_lv_nmos ad=0.1428p pd=1.52u as=0 ps=0 w=0.42u l=1u
X69 a_7390_949# a_8231_913# a_8155_949# VDD sg13_lv_pmos ad=0.3808p pd=2.92u as=0.2128p ps=1.5u w=1.12u l=0.13u
X70 VSS.t225 VDD VSS.t224 VSS.t223 sg13_lv_nmos ad=0.1428p pd=1.52u as=0 ps=0 w=0.42u l=1u
X71 a_3171_216.t0 a_2873_236# VSS.t106 VSS.t335 sg13_lv_nmos ad=0.1406p pd=1.12u as=0.1331p ps=1.12u w=0.74u l=0.13u
X72 a_5731_194# a_5705_424# a_4350_949# VDD sg13_lv_pmos ad=0.3808p pd=2.92u as=0.3808p ps=2.92u w=1.12u l=0.13u
X73 VDD a_2873_236# a_3171_216.t1 VDD sg13_lv_pmos ad=0.4256p pd=3u as=0.2128p ps=1.5u w=1.12u l=0.13u
X74 a_3747_216.t0 a_3449_236# VSS.t101 VSS.t100 sg13_lv_nmos ad=0.1406p pd=1.12u as=0.1331p ps=1.12u w=0.74u l=0.13u
X75 VDD a_3449_236# a_3747_216.t1 VDD sg13_lv_pmos ad=0.4256p pd=3u as=0.2128p ps=1.5u w=1.12u l=0.13u
X76 a_7390_949# a_2019_952.t8 a_7288_949# VSS.t113 sg13_lv_nmos ad=0.2516p pd=2.16u as=0.1406p ps=1.12u w=0.74u l=0.13u
X77 VDD DELAY_OUT_TAP21 a_20105_949# VDD sg13_lv_pmos ad=0.252p pd=1.57u as=0.3808p ps=2.92u w=1.12u l=0.13u
X78 a_19550_949# a_21044_913# a_20968_949# VDD sg13_lv_pmos ad=0.3808p pd=2.92u as=0.2128p ps=1.5u w=1.12u l=0.13u
X79 VDD VSS.t365 VDD VDD sg13_lv_pmos ad=0.19p pd=1.38u as=0 ps=0 w=1u l=1u
X80 VDD VSS.t379 VDD VDD sg13_lv_pmos ad=0.19p pd=1.38u as=0 ps=0 w=1u l=1u
X81 VDD a_3171_952.t7 a_11924_913# VDD sg13_lv_pmos ad=0.3808p pd=2.92u as=0.3808p ps=2.92u w=1.12u l=0.13u
X82 VSS.t57 a_2019_952.t4 a_19524_913# VSS.t56 sg13_lv_nmos ad=0.2516p pd=2.16u as=0.2516p ps=2.16u w=0.74u l=0.13u
X83 a_15755_949# a_15545_949# VSS.t134 VSS.t133 sg13_lv_nmos ad=0.1406p pd=1.12u as=0.1665p ps=1.19u w=0.74u l=0.13u
X84 VSS.t41 a_2595_952.t6 a_14311_913# VSS.t40 sg13_lv_nmos ad=0.2516p pd=2.16u as=0.2516p ps=2.16u w=0.74u l=0.13u
X85 a_5115_949# a_4905_949# VSS.t139 VSS.t138 sg13_lv_nmos ad=0.1406p pd=1.12u as=0.1665p ps=1.19u w=0.74u l=0.13u
X86 a_27915_949# a_27705_949# VDD VDD sg13_lv_pmos ad=0.2128p pd=1.5u as=0.252p ps=1.57u w=1.12u l=0.13u
X87 VSS.t217 VDD VSS.t215 VSS.t216 sg13_lv_nmos ad=79.8f pd=0.8u as=0 ps=0 w=0.42u l=1u
X88 a_23355_949# a_23145_949# VDD VDD sg13_lv_pmos ad=0.2128p pd=1.5u as=0.252p ps=1.57u w=1.12u l=0.13u
X89 VDD a_2019_952.t8 a_7364_913# VDD sg13_lv_pmos ad=0.3808p pd=2.92u as=0.3808p ps=2.92u w=1.12u l=0.13u
X90 VSS.t337 a_2873_236# a_3171_216.t0 VSS.t336 sg13_lv_nmos ad=0.2812p pd=2.24u as=0.1406p ps=1.12u w=0.74u l=0.13u
X91 VDD VSS.t390 VDD VDD sg13_lv_pmos ad=0.34p pd=2.68u as=0 ps=0 w=1u l=1u
X92 a_25630_949# a_27991_913# a_27915_949# VDD sg13_lv_pmos ad=0.3808p pd=2.92u as=0.2128p ps=1.5u w=1.12u l=0.13u
X93 VSS.t103 a_3449_236# a_3747_216.t0 VSS.t102 sg13_lv_nmos ad=0.2812p pd=2.24u as=0.1406p ps=1.12u w=0.74u l=0.13u
X94 VSS.t15 DELAY_OUT_TAP23 a_21625_949# VSS.t14 sg13_lv_nmos ad=0.1665p pd=1.19u as=0.2516p ps=2.16u w=0.74u l=0.13u
X95 a_22590_949# a_23431_913# a_23355_949# VDD sg13_lv_pmos ad=0.3808p pd=2.92u as=0.2128p ps=1.5u w=1.12u l=0.13u
X96 a_16108_194# a_20905_424# a_19550_949# VDD sg13_lv_pmos ad=0.3808p pd=2.92u as=0.3808p ps=2.92u w=1.12u l=0.13u
X97 VDD a_2595_952.t6 a_14311_913# VDD sg13_lv_pmos ad=0.3808p pd=2.92u as=0.3808p ps=2.92u w=1.12u l=0.13u
X98 VSS.t60 a_2019_952.t9 a_4324_913# VSS.t59 sg13_lv_nmos ad=0.2516p pd=2.16u as=0.2516p ps=2.16u w=0.74u l=0.13u
X99 a_16510_949# a_3747_952.t5 a_18795_949# VSS.t338 sg13_lv_nmos ad=0.2516p pd=2.16u as=0.1406p ps=1.12u w=0.74u l=0.13u
X100 VDD a_3747_952.t5 a_18871_913# VDD sg13_lv_pmos ad=0.3808p pd=2.92u as=0.3808p ps=2.92u w=1.12u l=0.13u
X101 VSS.t155 a_3171_216.t3 a_11785_424# VSS.t154 sg13_lv_nmos ad=0.2516p pd=2.16u as=0.2516p ps=2.16u w=0.74u l=0.13u
X102 VDD a_3747_952.t8 a_9751_913# VDD sg13_lv_pmos ad=0.3808p pd=2.92u as=0.3808p ps=2.92u w=1.12u l=0.13u
X103 VDD a_2595_952.t9 a_5191_913# VDD sg13_lv_pmos ad=0.3808p pd=2.92u as=0.3808p ps=2.92u w=1.12u l=0.13u
X104 a_10430_949# a_2019_952.t7 a_10328_949# VSS.t67 sg13_lv_nmos ad=0.2516p pd=2.16u as=0.1406p ps=1.12u w=0.74u l=0.13u
X105 a_4157_1218# DELAY_OUT_TAP0 VSS.t83 VSS.t82 sg13_lv_nmos ad=0.2516p pd=2.16u as=0.2553p ps=2.17u w=0.74u l=0.13u
X106 a_7390_949# a_3171_952.t8 a_8808_949# VSS.t26 sg13_lv_nmos ad=0.2516p pd=2.16u as=0.1406p ps=1.12u w=0.74u l=0.13u
X107 VSS.t134 DELAY_OUT_TAP15 a_15545_949# VSS.t321 sg13_lv_nmos ad=0.1665p pd=1.19u as=0.2516p ps=2.16u w=0.74u l=0.13u
X108 VDD a_2019_952.t3 a_22564_913# VDD sg13_lv_pmos ad=0.3808p pd=2.92u as=0.3808p ps=2.92u w=1.12u l=0.13u
X109 a_14888_949# DELAY_OUT_TAP14 VDD VDD sg13_lv_pmos ad=0.2128p pd=1.5u as=0.3808p ps=2.92u w=1.12u l=0.13u
X110 VSS.t20 a_3171_952.t7 a_11924_913# VSS.t19 sg13_lv_nmos ad=0.2516p pd=2.16u as=0.2516p ps=2.16u w=0.74u l=0.13u
X111 VDD VSS.t366 VDD VDD sg13_lv_pmos ad=0.34p pd=2.68u as=0 ps=0 w=1u l=1u
X112 VDD a_3171_952.t2 a_27124_913# VDD sg13_lv_pmos ad=0.3808p pd=2.92u as=0.3808p ps=2.92u w=1.12u l=0.13u
X113 a_10328_949# DELAY_OUT_TAP8 VDD VDD sg13_lv_pmos ad=0.2128p pd=1.5u as=0.3808p ps=2.92u w=1.12u l=0.13u
X114 a_19448_949# DELAY_OUT_TAP20 VDD VDD sg13_lv_pmos ad=0.2128p pd=1.5u as=0.3808p ps=2.92u w=1.12u l=0.13u
X115 VDD VSS.t380 VDD VDD sg13_lv_pmos ad=0.34p pd=2.68u as=0 ps=0 w=1u l=1u
X116 a_3171_952.t0 a_2873_1300# VSS.t286 VSS.t285 sg13_lv_nmos ad=0.1406p pd=1.12u as=0.1331p ps=1.12u w=0.74u l=0.13u
X117 a_25630_949# a_2019_952.t2 a_25528_949# VSS.t33 sg13_lv_nmos ad=0.2516p pd=2.16u as=0.1406p ps=1.12u w=0.74u l=0.13u
X118 VSS.t352 a_2297_1300# a_2595_952.t0 VSS.t351 sg13_lv_nmos ad=0.2812p pd=2.24u as=0.1406p ps=1.12u w=0.74u l=0.13u
X119 a_16108_194# a_2019_216# a_16510_949# VSS.t97 sg13_lv_nmos ad=0.2516p pd=2.16u as=0.2516p ps=2.16u w=0.74u l=0.13u
X120 a_2391_1300# MUX_SEL0 a_2297_1300# VSS.t190 sg13_lv_nmos ad=0.1216p pd=1.02u as=0.2176p ps=1.96u w=0.64u l=0.13u
X121 VSS.t277 VDD VSS.t275 VSS.t276 sg13_lv_nmos ad=79.8f pd=0.8u as=0 ps=0 w=0.42u l=1u
X122 VSS.t290 a_1544_949# a_1815_1300# VSS.t289 sg13_lv_nmos ad=0.1331p pd=1.12u as=0.1216p ps=1.02u w=0.64u l=0.13u
X123 a_5768_949# DELAY_OUT_TAP2 VDD VDD sg13_lv_pmos ad=0.2128p pd=1.5u as=0.3808p ps=2.92u w=1.12u l=0.13u
X124 VSS.t280 VDD VSS.t279 VSS.t278 sg13_lv_nmos ad=0.1428p pd=1.52u as=0 ps=0 w=0.42u l=1u
X125 a_16510_949# a_2019_952.t5 a_16408_949# VSS.t124 sg13_lv_nmos ad=0.2516p pd=2.16u as=0.1406p ps=1.12u w=0.74u l=0.13u
X126 VDD a_2595_952.t4 a_20391_913# VDD sg13_lv_pmos ad=0.3808p pd=2.92u as=0.3808p ps=2.92u w=1.12u l=0.13u
X127 VSS.t48 a_3171_952.t2 a_27124_913# VSS.t47 sg13_lv_nmos ad=0.2516p pd=2.16u as=0.2516p ps=2.16u w=0.74u l=0.13u
X128 a_5731_194# a_2595_216.t3 a_7390_949# VSS.t163 sg13_lv_nmos ad=0.2516p pd=2.16u as=0.2516p ps=2.16u w=0.74u l=0.13u
X129 VDD a_3171_216.t3 a_11785_424# VDD sg13_lv_pmos ad=0.3808p pd=2.92u as=0.3808p ps=2.92u w=1.12u l=0.13u
X130 a_10430_949# a_2595_952.t7 a_11195_949# VSS.t344 sg13_lv_nmos ad=0.2516p pd=2.16u as=0.1406p ps=1.12u w=0.74u l=0.13u
X131 a_23355_949# a_23145_949# VSS.t32 VSS.t135 sg13_lv_nmos ad=0.1406p pd=1.12u as=0.1665p ps=1.19u w=0.74u l=0.13u
X132 VSS.t197 VDD VSS.t194 VSS.t196 sg13_lv_nmos ad=79.8f pd=0.8u as=0 ps=0 w=0.42u l=1u
X133 VSS.t118 a_3747_952.t4 a_21911_913# VSS.t117 sg13_lv_nmos ad=0.2516p pd=2.16u as=0.2516p ps=2.16u w=0.74u l=0.13u
X134 VSS.t162 a_3747_216.t2 a_26985_424# VSS.t161 sg13_lv_nmos ad=0.2516p pd=2.16u as=0.2516p ps=2.16u w=0.74u l=0.13u
X135 a_20968_949# DELAY_OUT_TAP22 VSS.t30 VSS.t29 sg13_lv_nmos ad=0.1406p pd=1.12u as=0.2516p ps=2.16u w=0.74u l=0.13u
X136 VDD VSS.t383 VDD VDD sg13_lv_pmos ad=0.19p pd=1.38u as=0 ps=0 w=1u l=1u
X137 a_13470_949# a_14964_913# a_14888_949# VDD sg13_lv_pmos ad=0.3808p pd=2.92u as=0.2128p ps=1.5u w=1.12u l=0.13u
X138 VDD DELAY_OUT_TAP19 a_18585_949# VDD sg13_lv_pmos ad=0.252p pd=1.57u as=0.3808p ps=2.92u w=1.12u l=0.13u
X139 a_10430_949# a_10404_913# a_10328_949# VDD sg13_lv_pmos ad=0.3808p pd=2.92u as=0.2128p ps=1.5u w=1.12u l=0.13u
X140 a_19550_949# a_19524_913# a_19448_949# VDD sg13_lv_pmos ad=0.3808p pd=2.92u as=0.2128p ps=1.5u w=1.12u l=0.13u
X141 a_2595_216.t1 a_2297_236# VDD VDD sg13_lv_pmos ad=0.2128p pd=1.5u as=0.1918p ps=1.5u w=1.12u l=0.13u
X142 a_19448_949# DELAY_OUT_TAP20 VSS.t311 VSS.t310 sg13_lv_nmos ad=0.1406p pd=1.12u as=0.2516p ps=2.16u w=0.74u l=0.13u
X143 a_10430_949# a_3171_952.t7 a_11848_949# VSS.t18 sg13_lv_nmos ad=0.2516p pd=2.16u as=0.1406p ps=1.12u w=0.74u l=0.13u
X144 a_11195_949# a_10985_949# VDD VDD sg13_lv_pmos ad=0.2128p pd=1.5u as=0.252p ps=1.57u w=1.12u l=0.13u
X145 a_25630_949# a_2595_952.t2 a_26395_949# VSS.t76 sg13_lv_nmos ad=0.2516p pd=2.16u as=0.1406p ps=1.12u w=0.74u l=0.13u
X146 VDD a_1721_236# a_2019_216# VDD sg13_lv_pmos ad=0.4256p pd=3u as=0.2128p ps=1.5u w=1.12u l=0.13u
X147 VDD DELAY_OUT_TAP1 a_4905_949# VDD sg13_lv_pmos ad=0.252p pd=1.57u as=0.3808p ps=2.92u w=1.12u l=0.13u
X148 VSS.t237 VDD VSS.t235 VSS.t236 sg13_lv_nmos ad=79.8f pd=0.8u as=0 ps=0 w=0.42u l=1u
X149 VDD a_2297_236# a_2595_216.t1 VDD sg13_lv_pmos ad=0.4256p pd=3u as=0.2128p ps=1.5u w=1.12u l=0.13u
X150 a_4350_949# a_5844_913# a_5768_949# VDD sg13_lv_pmos ad=0.3808p pd=2.92u as=0.2128p ps=1.5u w=1.12u l=0.13u
X151 a_3449_1300# MUX_SEL0 VDD VDD sg13_lv_pmos ad=0.1596p pd=1.22u as=0.2856p ps=2.36u w=0.84u l=0.13u
X152 VDD DELAY_OUT_TAP7 a_9465_949# VDD sg13_lv_pmos ad=0.252p pd=1.57u as=0.3808p ps=2.92u w=1.12u l=0.13u
X153 VSS.t137 DELAY_OUT_TAP3 a_6425_949# VSS.t180 sg13_lv_nmos ad=0.1665p pd=1.19u as=0.2516p ps=2.16u w=0.74u l=0.13u
X154 a_10430_949# a_11271_913# a_11195_949# VDD sg13_lv_pmos ad=0.3808p pd=2.92u as=0.2128p ps=1.5u w=1.12u l=0.13u
X155 a_20968_949# DELAY_OUT_TAP22 VDD VDD sg13_lv_pmos ad=0.2128p pd=1.5u as=0.3808p ps=2.92u w=1.12u l=0.13u
X156 VSS.t2 a_2019_952.t6 a_13444_913# VSS.t1 sg13_lv_nmos ad=0.2516p pd=2.16u as=0.2516p ps=2.16u w=0.74u l=0.13u
X157 a_16108_194# a_17865_424# a_16510_949# VDD sg13_lv_pmos ad=0.3808p pd=2.92u as=0.3808p ps=2.92u w=1.12u l=0.13u
X158 VSS.t170 a_15964_194# a_16851_214# VSS.t173 sg13_lv_nmos ad=0.1371p pd=1.12u as=0.2176p ps=1.96u w=0.64u l=0.13u
X159 a_25528_949# DELAY_OUT_TAP28 VDD VDD sg13_lv_pmos ad=0.2128p pd=1.5u as=0.3808p ps=2.92u w=1.12u l=0.13u
X160 VDD a_1256_949# a_2873_1300# VDD sg13_lv_pmos ad=0.1918p pd=1.5u as=0.1596p ps=1.22u w=0.84u l=0.13u
X161 a_4248_949# a_4157_1218# VSS.t141 VSS.t140 sg13_lv_nmos ad=0.1406p pd=1.12u as=0.2516p ps=2.16u w=0.74u l=0.13u
X162 a_16108_194# a_3171_216.t2 a_22590_949# VSS.t130 sg13_lv_nmos ad=0.2516p pd=2.16u as=0.2516p ps=2.16u w=0.74u l=0.13u
X163 VSS.t257 VDD VSS.t255 VSS.t256 sg13_lv_nmos ad=79.8f pd=0.8u as=0 ps=0 w=0.42u l=1u
X164 a_19550_949# a_3747_952.t4 a_21835_949# VSS.t116 sg13_lv_nmos ad=0.2516p pd=2.16u as=0.1406p ps=1.12u w=0.74u l=0.13u
X165 VSS.t32 DELAY_OUT_TAP25 a_23145_949# VSS.t31 sg13_lv_nmos ad=0.1665p pd=1.19u as=0.2516p ps=2.16u w=0.74u l=0.13u
X166 a_5731_194# a_8745_424# a_7390_949# VDD sg13_lv_pmos ad=0.3808p pd=2.92u as=0.3808p ps=2.92u w=1.12u l=0.13u
X167 a_2595_216.t0 a_2297_236# VSS.t73 VSS.t72 sg13_lv_nmos ad=0.1406p pd=1.12u as=0.1331p ps=1.12u w=0.74u l=0.13u
X168 VDD a_3747_216.t2 a_26985_424# VDD sg13_lv_pmos ad=0.3808p pd=2.92u as=0.3808p ps=2.92u w=1.12u l=0.13u
X169 a_10430_949# a_3747_952.t7 a_12715_949# VSS.t341 sg13_lv_nmos ad=0.2516p pd=2.16u as=0.1406p ps=1.12u w=0.74u l=0.13u
X170 VSS.t334 a_1721_236# a_2019_216# VSS.t333 sg13_lv_nmos ad=0.2812p pd=2.24u as=0.1406p ps=1.12u w=0.74u l=0.13u
X171 a_24875_949# a_24665_949# VSS.t7 VSS.t6 sg13_lv_nmos ad=0.1406p pd=1.12u as=0.1665p ps=1.19u w=0.74u l=0.13u
X172 VSS.t75 a_2297_236# a_2595_216.t0 VSS.t74 sg13_lv_nmos ad=0.2812p pd=2.24u as=0.1406p ps=1.12u w=0.74u l=0.13u
X173 VSS.t66 a_2595_952.t3 a_23431_913# VSS.t65 sg13_lv_nmos ad=0.2516p pd=2.16u as=0.2516p ps=2.16u w=0.74u l=0.13u
X174 VDD MUX_SEL1 a_3449_1300# VDD sg13_lv_pmos ad=0.1918p pd=1.5u as=0.1596p ps=1.22u w=0.84u l=0.13u
X175 VSS.t195 VDD VSS.t194 VSS.t193 sg13_lv_nmos ad=0.1428p pd=1.52u as=0 ps=0 w=0.42u l=1u
X176 VSS.t90 DELAY_OUT_TAP13 a_14025_949# VSS.t319 sg13_lv_nmos ad=0.1665p pd=1.19u as=0.2516p ps=2.16u w=0.74u l=0.13u
X177 a_22590_949# a_24084_913# a_24008_949# VDD sg13_lv_pmos ad=0.3808p pd=2.92u as=0.2128p ps=1.5u w=1.12u l=0.13u
X178 VDD VSS.t359 VDD VDD sg13_lv_pmos ad=0.19p pd=1.38u as=0 ps=0 w=1u l=1u
X179 VDD DELAY_OUT_TAP27 a_24665_949# VDD sg13_lv_pmos ad=0.252p pd=1.57u as=0.3808p ps=2.92u w=1.12u l=0.13u
X180 VDD a_3171_952.t6 a_14964_913# VDD sg13_lv_pmos ad=0.3808p pd=2.92u as=0.3808p ps=2.92u w=1.12u l=0.13u
X181 a_25630_949# a_25604_913# a_25528_949# VDD sg13_lv_pmos ad=0.3808p pd=2.92u as=0.2128p ps=1.5u w=1.12u l=0.13u
X182 a_3171_952.t1 a_2873_1300# VDD VDD sg13_lv_pmos ad=0.2128p pd=1.5u as=0.1918p ps=1.5u w=1.12u l=0.13u
X183 a_3747_952.t1 a_3449_1300# VDD VDD sg13_lv_pmos ad=0.2128p pd=1.5u as=0.1918p ps=1.5u w=1.12u l=0.13u
X184 VDD VSS.t358 VDD VDD sg13_lv_pmos ad=0.34p pd=2.68u as=0 ps=0 w=1u l=1u
X185 VDD a_2019_952.t5 a_16484_913# VDD sg13_lv_pmos ad=0.3808p pd=2.92u as=0.3808p ps=2.92u w=1.12u l=0.13u
X186 a_22590_949# a_3171_952.t3 a_24008_949# VSS.t107 sg13_lv_nmos ad=0.2516p pd=2.16u as=0.1406p ps=1.12u w=0.74u l=0.13u
X187 VDD a_15964_194# a_16851_214# VDD sg13_lv_pmos ad=0.2086p pd=1.5u as=0.34p ps=2.68u w=1u l=0.13u
X188 a_26395_949# a_26185_949# VDD VDD sg13_lv_pmos ad=0.2128p pd=1.5u as=0.252p ps=1.57u w=1.12u l=0.13u
X189 a_3747_952.t0 a_3449_1300# VSS.t143 VSS.t142 sg13_lv_nmos ad=0.1406p pd=1.12u as=0.1331p ps=1.12u w=0.74u l=0.13u
X190 a_25630_949# a_3747_952.t2 a_27915_949# VSS.t121 sg13_lv_nmos ad=0.2516p pd=2.16u as=0.1406p ps=1.12u w=0.74u l=0.13u
X191 VSS.t252 VDD VSS.t250 VSS.t251 sg13_lv_nmos ad=79.8f pd=0.8u as=0 ps=0 w=0.42u l=1u
X192 VDD VSS.t391 VDD VDD sg13_lv_pmos ad=0.19p pd=1.38u as=0 ps=0 w=1u l=1u
X193 a_2967_1300# MUX_SEL1 a_2873_1300# VSS.t184 sg13_lv_nmos ad=0.1216p pd=1.02u as=0.2176p ps=1.96u w=0.64u l=0.13u
X194 VDD a_3171_952.t9 a_5844_913# VDD sg13_lv_pmos ad=0.3808p pd=2.92u as=0.3808p ps=2.92u w=1.12u l=0.13u
X195 VSS.t247 VDD VSS.t245 VSS.t246 sg13_lv_nmos ad=79.8f pd=0.8u as=0 ps=0 w=0.42u l=1u
X196 VSS.t220 VDD VSS.t219 VSS.t218 sg13_lv_nmos ad=0.1428p pd=1.52u as=0 ps=0 w=0.42u l=1u
X197 a_25630_949# a_26471_913# a_26395_949# VDD sg13_lv_pmos ad=0.3808p pd=2.92u as=0.2128p ps=1.5u w=1.12u l=0.13u
X198 a_3543_236# MUX_SEL2 a_3449_236# VSS.t45 sg13_lv_nmos ad=0.1216p pd=1.02u as=0.2176p ps=1.96u w=0.64u l=0.13u
X199 a_16108_194# a_23945_424# a_22590_949# VDD sg13_lv_pmos ad=0.3808p pd=2.92u as=0.3808p ps=2.92u w=1.12u l=0.13u
X200 VDD a_2595_952.t5 a_17351_913# VDD sg13_lv_pmos ad=0.3808p pd=2.92u as=0.3808p ps=2.92u w=1.12u l=0.13u
X201 VDD a_3747_952.t7 a_12791_913# VDD sg13_lv_pmos ad=0.3808p pd=2.92u as=0.3808p ps=2.92u w=1.12u l=0.13u
X202 a_8155_949# a_7945_949# VSS.t284 VSS.t309 sg13_lv_nmos ad=0.1406p pd=1.12u as=0.1665p ps=1.19u w=0.74u l=0.13u
X203 a_27048_949# DELAY_OUT_TAP30 VSS.t175 VSS.t174 sg13_lv_nmos ad=0.1406p pd=1.12u as=0.2516p ps=2.16u w=0.74u l=0.13u
X204 a_5768_949# DELAY_OUT_TAP2 VSS.t177 VSS.t176 sg13_lv_nmos ad=0.1406p pd=1.12u as=0.2516p ps=2.16u w=0.74u l=0.13u
X205 VSS.t159 a_3747_216.t3 a_14825_424# VSS.t158 sg13_lv_nmos ad=0.2516p pd=2.16u as=0.2516p ps=2.16u w=0.74u l=0.13u
X206 VSS.t106 a_1256_194# a_2967_236# VSS.t105 sg13_lv_nmos ad=0.1331p pd=1.12u as=0.1216p ps=1.02u w=0.64u l=0.13u
X207 VSS.t255 VDD VSS.t254 VSS.t253 sg13_lv_nmos ad=0.1428p pd=1.52u as=0 ps=0 w=0.42u l=1u
X208 VDD VSS.t375 VDD VDD sg13_lv_pmos ad=0.19p pd=1.38u as=0 ps=0 w=1u l=1u
X209 VDD a_2873_1300# a_3171_952.t1 VDD sg13_lv_pmos ad=0.4256p pd=3u as=0.2128p ps=1.5u w=1.12u l=0.13u
X210 VSS.t7 DELAY_OUT_TAP27 a_24665_949# VSS.t316 sg13_lv_nmos ad=0.1665p pd=1.19u as=0.2516p ps=2.16u w=0.74u l=0.13u
X211 VDD a_2595_952.t8 a_8231_913# VDD sg13_lv_pmos ad=0.3808p pd=2.92u as=0.3808p ps=2.92u w=1.12u l=0.13u
X212 a_16510_949# a_3171_952.t5 a_17928_949# VSS.t49 sg13_lv_nmos ad=0.2516p pd=2.16u as=0.1406p ps=1.12u w=0.74u l=0.13u
X213 VDD a_3449_1300# a_3747_952.t1 VDD sg13_lv_pmos ad=0.4256p pd=3u as=0.2128p ps=1.5u w=1.12u l=0.13u
X214 VSS.t5 a_3171_952.t4 a_21044_913# VSS.t4 sg13_lv_nmos ad=0.2516p pd=2.16u as=0.2516p ps=2.16u w=0.74u l=0.13u
X215 VDD VSS.t367 VDD VDD sg13_lv_pmos ad=0.19p pd=1.38u as=0 ps=0 w=1u l=1u
X216 VSS.t101 MUX_SEL3 a_3543_236# VSS.t331 sg13_lv_nmos ad=0.1331p pd=1.12u as=0.1216p ps=1.02u w=0.64u l=0.13u
X217 VDD a_3171_952.t4 a_21044_913# VDD sg13_lv_pmos ad=0.3808p pd=2.92u as=0.3808p ps=2.92u w=1.12u l=0.13u
X218 a_13368_949# DELAY_OUT_TAP12 VDD VDD sg13_lv_pmos ad=0.2128p pd=1.5u as=0.3808p ps=2.92u w=1.12u l=0.13u
X219 VSS.t288 a_2873_1300# a_3171_952.t0 VSS.t287 sg13_lv_nmos ad=0.2812p pd=2.24u as=0.1406p ps=1.12u w=0.74u l=0.13u
X220 a_13368_949# DELAY_OUT_TAP12 VSS.t354 VSS.t353 sg13_lv_nmos ad=0.1406p pd=1.12u as=0.2516p ps=2.16u w=0.74u l=0.13u
X221 a_5731_194# a_3171_216.t3 a_10430_949# VSS.t153 sg13_lv_nmos ad=0.2516p pd=2.16u as=0.2516p ps=2.16u w=0.74u l=0.13u
X222 VSS.t292 a_1544_949# a_2391_1300# VSS.t291 sg13_lv_nmos ad=0.1331p pd=1.12u as=0.1216p ps=1.02u w=0.64u l=0.13u
X223 a_2019_952.t0 a_1721_1300# VSS.t290 VSS.t296 sg13_lv_nmos ad=0.1406p pd=1.12u as=0.1331p ps=1.12u w=0.74u l=0.13u
X224 a_4350_949# a_3747_952.t9 a_6635_949# VSS.t323 sg13_lv_nmos ad=0.2516p pd=2.16u as=0.1406p ps=1.12u w=0.74u l=0.13u
X225 a_19550_949# a_2595_952.t4 a_20315_949# VSS.t61 sg13_lv_nmos ad=0.2516p pd=2.16u as=0.1406p ps=1.12u w=0.74u l=0.13u
X226 a_8808_949# DELAY_OUT_TAP6 VDD VDD sg13_lv_pmos ad=0.2128p pd=1.5u as=0.3808p ps=2.92u w=1.12u l=0.13u
X227 VSS.t284 DELAY_OUT_TAP5 a_7945_949# VSS.t283 sg13_lv_nmos ad=0.1665p pd=1.19u as=0.2516p ps=2.16u w=0.74u l=0.13u
X228 a_2019_216# a_1721_236# VDD VDD sg13_lv_pmos ad=0.2128p pd=1.5u as=0.1918p ps=1.5u w=1.12u l=0.13u
X229 VSS.t250 VDD VSS.t249 VSS.t248 sg13_lv_nmos ad=0.1428p pd=1.52u as=0 ps=0 w=0.42u l=1u
X230 a_4248_949# a_4157_1218# VDD VDD sg13_lv_pmos ad=0.2128p pd=1.5u as=0.3808p ps=2.92u w=1.12u l=0.13u
X231 VDD VSS.t392 VDD VDD sg13_lv_pmos ad=0.34p pd=2.68u as=0 ps=0 w=1u l=1u
X232 VSS.t215 VDD VSS.t214 VSS.t213 sg13_lv_nmos ad=0.1428p pd=1.52u as=0 ps=0 w=0.42u l=1u
X233 VSS.t245 VDD VSS.t244 VSS.t243 sg13_lv_nmos ad=0.1428p pd=1.52u as=0 ps=0 w=0.42u l=1u
X234 VDD a_2595_952.t3 a_23431_913# VDD sg13_lv_pmos ad=0.3808p pd=2.92u as=0.3808p ps=2.92u w=1.12u l=0.13u
X235 VDD a_3747_216.t3 a_14825_424# VDD sg13_lv_pmos ad=0.3808p pd=2.92u as=0.3808p ps=2.92u w=1.12u l=0.13u
X236 VDD a_3747_952.t2 a_27991_913# VDD sg13_lv_pmos ad=0.3808p pd=2.92u as=0.3808p ps=2.92u w=1.12u l=0.13u
X237 a_2297_1300# MUX_SEL0 VDD VDD sg13_lv_pmos ad=0.1596p pd=1.22u as=0.2856p ps=2.36u w=0.84u l=0.13u
X238 a_9675_949# a_9465_949# VSS.t318 VSS.t322 sg13_lv_nmos ad=0.1406p pd=1.12u as=0.1665p ps=1.19u w=0.74u l=0.13u
X239 VSS.t212 VDD VSS.t210 VSS.t211 sg13_lv_nmos ad=79.8f pd=0.8u as=0 ps=0 w=0.42u l=1u
X240 a_2873_1300# MUX_SEL1 VDD VDD sg13_lv_pmos ad=0.1596p pd=1.22u as=0.2856p ps=2.36u w=0.84u l=0.13u
X241 VSS.t81 a_2595_952.t8 a_8231_913# VSS.t80 sg13_lv_nmos ad=0.2516p pd=2.16u as=0.2516p ps=2.16u w=0.74u l=0.13u
X242 VSS.t168 a_2595_216.t2 a_20905_424# VSS.t167 sg13_lv_nmos ad=0.2516p pd=2.16u as=0.2516p ps=2.16u w=0.74u l=0.13u
X243 a_3449_236# MUX_SEL2 VDD VDD sg13_lv_pmos ad=0.1596p pd=1.22u as=0.2856p ps=2.36u w=0.84u l=0.13u
X244 VDD DELAY_OUT_TAP11 a_12505_949# VDD sg13_lv_pmos ad=0.252p pd=1.57u as=0.3808p ps=2.92u w=1.12u l=0.13u
X245 VDD VSS.t369 VDD VDD sg13_lv_pmos ad=0.19p pd=1.38u as=0 ps=0 w=1u l=1u
X246 a_13470_949# a_13444_913# a_13368_949# VDD sg13_lv_pmos ad=0.3808p pd=2.92u as=0.2128p ps=1.5u w=1.12u l=0.13u
X247 VDD DELAY_OUT_TAP17 a_17065_949# VDD sg13_lv_pmos ad=0.252p pd=1.57u as=0.3808p ps=2.92u w=1.12u l=0.13u
X248 a_16510_949# a_18004_913# a_17928_949# VDD sg13_lv_pmos ad=0.3808p pd=2.92u as=0.2128p ps=1.5u w=1.12u l=0.13u
X249 a_19550_949# a_2019_952.t4 a_19448_949# VSS.t55 sg13_lv_nmos ad=0.2516p pd=2.16u as=0.1406p ps=1.12u w=0.74u l=0.13u
X250 VDD VSS.t371 VDD VDD sg13_lv_pmos ad=0.19p pd=1.38u as=0 ps=0 w=1u l=1u
X251 VDD VSS.t382 VDD VDD sg13_lv_pmos ad=0.34p pd=2.68u as=0 ps=0 w=1u l=1u
X252 VDD a_1256_194# a_2873_236# VDD sg13_lv_pmos ad=0.1918p pd=1.5u as=0.1596p ps=1.22u w=0.84u l=0.13u
X253 a_13470_949# a_2595_952.t6 a_14235_949# VSS.t39 sg13_lv_nmos ad=0.2516p pd=2.16u as=0.1406p ps=1.12u w=0.74u l=0.13u
X254 VSS.t38 a_2019_952.t3 a_22564_913# VSS.t37 sg13_lv_nmos ad=0.2516p pd=2.16u as=0.2516p ps=2.16u w=0.74u l=0.13u
X255 a_15755_949# a_15545_949# VDD VDD sg13_lv_pmos ad=0.2128p pd=1.5u as=0.252p ps=1.57u w=1.12u l=0.13u
X256 a_7390_949# a_8884_913# a_8808_949# VDD sg13_lv_pmos ad=0.3808p pd=2.92u as=0.2128p ps=1.5u w=1.12u l=0.13u
X257 a_2019_216# a_1721_236# VSS.t92 VSS.t332 sg13_lv_nmos ad=0.1406p pd=1.12u as=0.1331p ps=1.12u w=0.74u l=0.13u
X258 a_4350_949# a_4324_913# a_4248_949# VDD sg13_lv_pmos ad=0.3808p pd=2.92u as=0.2128p ps=1.5u w=1.12u l=0.13u
X259 VDD DELAY_OUT_TAP5 a_7945_949# VDD sg13_lv_pmos ad=0.252p pd=1.57u as=0.3808p ps=2.92u w=1.12u l=0.13u
X260 a_24008_949# DELAY_OUT_TAP26 VDD VDD sg13_lv_pmos ad=0.2128p pd=1.5u as=0.3808p ps=2.92u w=1.12u l=0.13u
X261 a_5731_194# a_11785_424# a_10430_949# VDD sg13_lv_pmos ad=0.3808p pd=2.92u as=0.3808p ps=2.92u w=1.12u l=0.13u
X262 a_5115_949# a_4905_949# VDD VDD sg13_lv_pmos ad=0.2128p pd=1.5u as=0.252p ps=1.57u w=1.12u l=0.13u
X263 VDD VSS.t368 VDD VDD sg13_lv_pmos ad=0.34p pd=2.68u as=0 ps=0 w=1u l=1u
X264 a_13470_949# a_15831_913# a_15755_949# VDD sg13_lv_pmos ad=0.3808p pd=2.92u as=0.2128p ps=1.5u w=1.12u l=0.13u
X265 a_17275_949# a_17065_949# VSS.t150 VSS.t149 sg13_lv_nmos ad=0.1406p pd=1.12u as=0.1665p ps=1.19u w=0.74u l=0.13u
X266 VDD a_1544_949# a_2297_1300# VDD sg13_lv_pmos ad=0.1918p pd=1.5u as=0.1596p ps=1.22u w=0.84u l=0.13u
X267 VSS.t308 a_3747_952.t6 a_15831_913# VSS.t307 sg13_lv_nmos ad=0.2516p pd=2.16u as=0.2516p ps=2.16u w=0.74u l=0.13u
X268 a_4350_949# a_2019_952.t9 a_4248_949# VSS.t58 sg13_lv_nmos ad=0.2516p pd=2.16u as=0.1406p ps=1.12u w=0.74u l=0.13u
X269 VSS.t207 VDD VSS.t205 VSS.t206 sg13_lv_nmos ad=79.8f pd=0.8u as=0 ps=0 w=0.42u l=1u
X270 a_6635_949# a_6425_949# VDD VDD sg13_lv_pmos ad=0.2128p pd=1.5u as=0.252p ps=1.57u w=1.12u l=0.13u
X271 a_14888_949# DELAY_OUT_TAP14 VSS.t313 VSS.t312 sg13_lv_nmos ad=0.1406p pd=1.12u as=0.2516p ps=2.16u w=0.74u l=0.13u
X272 a_16108_194# a_3747_216.t2 a_25630_949# VSS.t160 sg13_lv_nmos ad=0.2516p pd=2.16u as=0.2516p ps=2.16u w=0.74u l=0.13u
X273 VSS.t272 VDD VSS.t270 VSS.t271 sg13_lv_nmos ad=79.8f pd=0.8u as=0 ps=0 w=0.42u l=1u
X274 a_4350_949# a_5191_913# a_5115_949# VDD sg13_lv_pmos ad=0.3808p pd=2.92u as=0.2128p ps=1.5u w=1.12u l=0.13u
X275 VDD MUX_SEL3 a_3449_236# VDD sg13_lv_pmos ad=0.1918p pd=1.5u as=0.1596p ps=1.22u w=0.84u l=0.13u
X276 VSS.t318 DELAY_OUT_TAP7 a_9465_949# VSS.t317 sg13_lv_nmos ad=0.1665p pd=1.19u as=0.2516p ps=2.16u w=0.74u l=0.13u
X277 a_4350_949# a_6711_913# a_6635_949# VDD sg13_lv_pmos ad=0.3808p pd=2.92u as=0.2128p ps=1.5u w=1.12u l=0.13u
X278 VSS.t275 VDD VSS.t274 VSS.t273 sg13_lv_nmos ad=0.1428p pd=1.52u as=0 ps=0 w=0.42u l=1u
X279 VSS.t126 a_2019_952.t5 a_16484_913# VSS.t125 sg13_lv_nmos ad=0.2516p pd=2.16u as=0.2516p ps=2.16u w=0.74u l=0.13u
X280 VSS.t54 a_3171_952.t9 a_5844_913# VSS.t53 sg13_lv_nmos ad=0.2516p pd=2.16u as=0.2516p ps=2.16u w=0.74u l=0.13u
X281 VDD a_2595_216.t2 a_20905_424# VDD sg13_lv_pmos ad=0.3808p pd=2.92u as=0.3808p ps=2.92u w=1.12u l=0.13u
X282 VSS.t346 a_2595_952.t7 a_11271_913# VSS.t345 sg13_lv_nmos ad=0.2516p pd=2.16u as=0.2516p ps=2.16u w=0.74u l=0.13u
X283 VSS.t10 a_3747_952.t8 a_9751_913# VSS.t9 sg13_lv_nmos ad=0.2516p pd=2.16u as=0.2516p ps=2.16u w=0.74u l=0.13u
X284 a_1256_949# MUX_SEL0 VDD VDD sg13_lv_pmos ad=0.3808p pd=2.92u as=0.3808p ps=2.92u w=1.12u l=0.13u
X285 a_2391_236# MUX_SEL2 a_2297_236# VSS.t44 sg13_lv_nmos ad=0.1216p pd=1.02u as=0.2176p ps=1.96u w=0.64u l=0.13u
X286 a_2967_236# MUX_SEL3 a_2873_236# VSS.t330 sg13_lv_nmos ad=0.1216p pd=1.02u as=0.2176p ps=1.96u w=0.64u l=0.13u
X287 VDD DELAY_OUT_TAP31 a_27705_949# VDD sg13_lv_pmos ad=0.252p pd=1.57u as=0.3808p ps=2.92u w=1.12u l=0.13u
X288 VDD DELAY_OUT_TAP25 a_23145_949# VDD sg13_lv_pmos ad=0.252p pd=1.57u as=0.3808p ps=2.92u w=1.12u l=0.13u
X289 a_2595_952.t1 a_2297_1300# VDD VDD sg13_lv_pmos ad=0.2128p pd=1.5u as=0.1918p ps=1.5u w=1.12u l=0.13u
X290 VDD VSS.t370 VDD VDD sg13_lv_pmos ad=0.34p pd=2.68u as=0 ps=0 w=1u l=1u
X291 VDD a_2019_952.t7 a_10404_913# VDD sg13_lv_pmos ad=0.3808p pd=2.92u as=0.3808p ps=2.92u w=1.12u l=0.13u
X292 VDD a_2019_952.t4 a_19524_913# VDD sg13_lv_pmos ad=0.3808p pd=2.92u as=0.3808p ps=2.92u w=1.12u l=0.13u
X293 VDD VSS.t384 VDD VDD sg13_lv_pmos ad=0.34p pd=2.68u as=0 ps=0 w=1u l=1u
X294 a_20315_949# a_20105_949# VDD VDD sg13_lv_pmos ad=0.2128p pd=1.5u as=0.252p ps=1.57u w=1.12u l=0.13u
X295 a_1544_949# MUX_SEL1 VSS.t183 VSS.t182 sg13_lv_nmos ad=0.2516p pd=2.16u as=0.2516p ps=2.16u w=0.74u l=0.13u
X296 VDD VSS.t372 VDD VDD sg13_lv_pmos ad=0.34p pd=2.68u as=0 ps=0 w=1u l=1u
X297 a_13470_949# a_3747_952.t6 a_15755_949# VSS.t306 sg13_lv_nmos ad=0.2516p pd=2.16u as=0.1406p ps=1.12u w=0.74u l=0.13u
X298 VSS.t145 a_3449_1300# a_3747_952.t0 VSS.t144 sg13_lv_nmos ad=0.2812p pd=2.24u as=0.1406p ps=1.12u w=0.74u l=0.13u
X299 a_4350_949# a_2595_952.t9 a_5115_949# VSS.t11 sg13_lv_nmos ad=0.2516p pd=2.16u as=0.1406p ps=1.12u w=0.74u l=0.13u
X300 VDD a_1721_1300# a_2019_952.t1 VDD sg13_lv_pmos ad=0.4256p pd=3u as=0.2128p ps=1.5u w=1.12u l=0.13u
X301 VSS.t78 a_2595_952.t2 a_26471_913# VSS.t77 sg13_lv_nmos ad=0.2516p pd=2.16u as=0.2516p ps=2.16u w=0.74u l=0.13u
X302 VSS.t267 VDD VSS.t265 VSS.t266 sg13_lv_nmos ad=79.8f pd=0.8u as=0 ps=0 w=0.42u l=1u
X303 a_21835_949# a_21625_949# VDD VDD sg13_lv_pmos ad=0.2128p pd=1.5u as=0.252p ps=1.57u w=1.12u l=0.13u
X304 a_3543_1300# MUX_SEL0 a_3449_1300# VSS.t191 sg13_lv_nmos ad=0.1216p pd=1.02u as=0.2176p ps=1.96u w=0.64u l=0.13u
X305 VDD a_2297_1300# a_2595_952.t1 VDD sg13_lv_pmos ad=0.4256p pd=3u as=0.2128p ps=1.5u w=1.12u l=0.13u
X306 VSS.t150 DELAY_OUT_TAP17 a_17065_949# VSS.t301 sg13_lv_nmos ad=0.1665p pd=1.19u as=0.2516p ps=2.16u w=0.74u l=0.13u
X307 VDD VSS.t385 VDD VDD sg13_lv_pmos ad=0.19p pd=1.38u as=0 ps=0 w=1u l=1u
X308 VSS.t232 VDD VSS.t230 VSS.t231 sg13_lv_nmos ad=79.8f pd=0.8u as=0 ps=0 w=0.42u l=1u
X309 a_19550_949# a_20391_913# a_20315_949# VDD sg13_lv_pmos ad=0.3808p pd=2.92u as=0.2128p ps=1.5u w=1.12u l=0.13u
X310 VSS.t235 VDD VSS.t234 VSS.t233 sg13_lv_nmos ad=0.1428p pd=1.52u as=0 ps=0 w=0.42u l=1u
X311 a_1544_949# MUX_SEL1 VDD VDD sg13_lv_pmos ad=0.3808p pd=2.92u as=0.3808p ps=2.92u w=1.12u l=0.13u
X312 a_16108_194# a_26985_424# a_25630_949# VDD sg13_lv_pmos ad=0.3808p pd=2.92u as=0.3808p ps=2.92u w=1.12u l=0.13u
X313 a_19550_949# a_21911_913# a_21835_949# VDD sg13_lv_pmos ad=0.3808p pd=2.92u as=0.2128p ps=1.5u w=1.12u l=0.13u
X314 VDD a_3747_952.t6 a_15831_913# VDD sg13_lv_pmos ad=0.3808p pd=2.92u as=0.3808p ps=2.92u w=1.12u l=0.13u
X315 a_18795_949# a_18585_949# VSS.t88 VSS.t87 sg13_lv_nmos ad=0.1406p pd=1.12u as=0.1665p ps=1.19u w=0.74u l=0.13u
X316 a_25630_949# a_3171_952.t2 a_27048_949# VSS.t46 sg13_lv_nmos ad=0.2516p pd=2.16u as=0.1406p ps=1.12u w=0.74u l=0.13u
X317 VSS.t86 a_2595_952.t5 a_17351_913# VSS.t85 sg13_lv_nmos ad=0.2516p pd=2.16u as=0.2516p ps=2.16u w=0.74u l=0.13u
X318 a_4350_949# a_3171_952.t9 a_5768_949# VSS.t52 sg13_lv_nmos ad=0.2516p pd=2.16u as=0.1406p ps=1.12u w=0.74u l=0.13u
X319 VSS.t99 a_2019_216# a_17865_424# VSS.t98 sg13_lv_nmos ad=0.2516p pd=2.16u as=0.2516p ps=2.16u w=0.74u l=0.13u
X320 VSS.t73 a_1544_194# a_2391_236# VSS.t93 sg13_lv_nmos ad=0.1331p pd=1.12u as=0.1216p ps=1.02u w=0.64u l=0.13u
X321 VSS.t115 a_2019_952.t8 a_7364_913# VSS.t114 sg13_lv_nmos ad=0.2516p pd=2.16u as=0.2516p ps=2.16u w=0.74u l=0.13u
X322 VSS.t96 a_2019_216# a_5705_424# VSS.t95 sg13_lv_nmos ad=0.2516p pd=2.16u as=0.2516p ps=2.16u w=0.74u l=0.13u
X323 MUX_OUT a_16851_214# VDD VDD sg13_lv_pmos ad=0.2128p pd=1.5u as=0.2086p ps=1.5u w=1.12u l=0.13u
X324 a_22488_949# DELAY_OUT_TAP24 VSS.t327 VSS.t326 sg13_lv_nmos ad=0.1406p pd=1.12u as=0.2516p ps=2.16u w=0.74u l=0.13u
X325 VDD VSS.t387 VDD VDD sg13_lv_pmos ad=0.19p pd=1.38u as=0 ps=0 w=1u l=1u
X326 VDD VSS.t361 VDD VDD sg13_lv_pmos ad=0.19p pd=1.38u as=0 ps=0 w=1u l=1u
X327 a_16408_949# DELAY_OUT_TAP16 VDD VDD sg13_lv_pmos ad=0.2128p pd=1.5u as=0.3808p ps=2.92u w=1.12u l=0.13u
X328 a_13470_949# a_2019_952.t6 a_13368_949# VSS.t0 sg13_lv_nmos ad=0.2516p pd=2.16u as=0.1406p ps=1.12u w=0.74u l=0.13u
X329 a_15964_194# a_15765_368# a_5731_194# VSS.t356 sg13_lv_nmos ad=0.2183p pd=1.33u as=0.2516p ps=2.16u w=0.74u l=0.13u
X330 VDD a_2019_952.t2 a_25604_913# VDD sg13_lv_pmos ad=0.3808p pd=2.92u as=0.3808p ps=2.92u w=1.12u l=0.13u
X331 a_2595_952.t0 a_2297_1300# VSS.t292 VSS.t350 sg13_lv_nmos ad=0.1406p pd=1.12u as=0.1331p ps=1.12u w=0.74u l=0.13u
X332 a_17928_949# DELAY_OUT_TAP18 VDD VDD sg13_lv_pmos ad=0.2128p pd=1.5u as=0.3808p ps=2.92u w=1.12u l=0.13u
X333 VSS.t109 a_3171_952.t3 a_24084_913# VSS.t108 sg13_lv_nmos ad=0.2516p pd=2.16u as=0.2516p ps=2.16u w=0.74u l=0.13u
X334 VDD VSS.t360 VDD VDD sg13_lv_pmos ad=0.34p pd=2.68u as=0 ps=0 w=1u l=1u
X335 a_2297_236# MUX_SEL2 VDD VDD sg13_lv_pmos ad=0.1596p pd=1.22u as=0.2856p ps=2.36u w=0.84u l=0.13u
X336 a_1815_1300# a_1256_949# a_1721_1300# VSS.t294 sg13_lv_nmos ad=0.1216p pd=1.02u as=0.2176p ps=1.96u w=0.64u l=0.13u
X337 a_2873_236# MUX_SEL3 VDD VDD sg13_lv_pmos ad=0.1596p pd=1.22u as=0.2856p ps=2.36u w=0.84u l=0.13u
X338 VSS.t88 DELAY_OUT_TAP19 a_18585_949# VSS.t320 sg13_lv_nmos ad=0.1665p pd=1.19u as=0.2516p ps=2.16u w=0.74u l=0.13u
X339 VSS.t265 VDD VSS.t264 VSS.t263 sg13_lv_nmos ad=0.1428p pd=1.52u as=0 ps=0 w=0.42u l=1u
X340 a_7288_949# DELAY_OUT_TAP4 VDD VDD sg13_lv_pmos ad=0.2128p pd=1.5u as=0.3808p ps=2.92u w=1.12u l=0.13u
X341 VSS.t230 VDD VSS.t229 VSS.t228 sg13_lv_nmos ad=0.1428p pd=1.52u as=0 ps=0 w=0.42u l=1u
X342 VSS.t242 VDD VSS.t240 VSS.t241 sg13_lv_nmos ad=79.8f pd=0.8u as=0 ps=0 w=0.42u l=1u
X343 VSS.t129 a_3171_952.t6 a_14964_913# VSS.t128 sg13_lv_nmos ad=0.2516p pd=2.16u as=0.2516p ps=2.16u w=0.74u l=0.13u
X344 VDD a_2019_216# a_17865_424# VDD sg13_lv_pmos ad=0.3808p pd=2.92u as=0.3808p ps=2.92u w=1.12u l=0.13u
X345 VDD a_3747_952.t4 a_21911_913# VDD sg13_lv_pmos ad=0.3808p pd=2.92u as=0.3808p ps=2.92u w=1.12u l=0.13u
X346 a_11195_949# a_10985_949# VSS.t147 VSS.t146 sg13_lv_nmos ad=0.1406p pd=1.12u as=0.1665p ps=1.19u w=0.74u l=0.13u
X347 a_1721_1300# a_1256_949# VDD VDD sg13_lv_pmos ad=0.1596p pd=1.22u as=0.2856p ps=2.36u w=0.84u l=0.13u
X348 VDD a_16851_214# MUX_OUT VDD sg13_lv_pmos ad=0.7336p pd=3.55u as=0.2128p ps=1.5u w=1.12u l=0.13u
X349 VSS.t132 a_3171_216.t2 a_23945_424# VSS.t131 sg13_lv_nmos ad=0.2516p pd=2.16u as=0.2516p ps=2.16u w=0.74u l=0.13u
X350 a_22590_949# a_2595_952.t3 a_23355_949# VSS.t64 sg13_lv_nmos ad=0.2516p pd=2.16u as=0.1406p ps=1.12u w=0.74u l=0.13u
X351 VSS.t25 MUX_SEL4 a_15765_368# VSS.t24 sg13_lv_nmos ad=0.2516p pd=2.16u as=0.2516p ps=2.16u w=0.74u l=0.13u
X352 a_16510_949# a_16484_913# a_16408_949# VDD sg13_lv_pmos ad=0.3808p pd=2.92u as=0.2128p ps=1.5u w=1.12u l=0.13u
X353 VDD VSS.t363 VDD VDD sg13_lv_pmos ad=0.19p pd=1.38u as=0 ps=0 w=1u l=1u
X354 VDD DELAY_OUT_TAP9 a_10985_949# VDD sg13_lv_pmos ad=0.252p pd=1.57u as=0.3808p ps=2.92u w=1.12u l=0.13u
X355 VDD a_1544_949# a_1721_1300# VDD sg13_lv_pmos ad=0.1918p pd=1.5u as=0.1596p ps=1.22u w=0.84u l=0.13u
X356 VDD VSS.t377 VDD VDD sg13_lv_pmos ad=0.19p pd=1.38u as=0 ps=0 w=1u l=1u
X357 VDD a_2019_216# a_5705_424# VDD sg13_lv_pmos ad=0.3808p pd=2.92u as=0.3808p ps=2.92u w=1.12u l=0.13u
X358 VDD VSS.t376 VDD VDD sg13_lv_pmos ad=0.34p pd=2.68u as=0 ps=0 w=1u l=1u
X359 VSS.t69 a_2019_952.t7 a_10404_913# VSS.t68 sg13_lv_nmos ad=0.2516p pd=2.16u as=0.2516p ps=2.16u w=0.74u l=0.13u
X360 VDD a_1544_194# a_2297_236# VDD sg13_lv_pmos ad=0.1918p pd=1.5u as=0.1596p ps=1.22u w=0.84u l=0.13u
X361 a_26395_949# a_26185_949# VSS.t71 VSS.t355 sg13_lv_nmos ad=0.1406p pd=1.12u as=0.1665p ps=1.19u w=0.74u l=0.13u
X362 VSS.t222 VDD VSS.t220 VSS.t221 sg13_lv_nmos ad=79.8f pd=0.8u as=0 ps=0 w=0.42u l=1u
X363 VSS.t112 a_3747_952.t3 a_24951_913# VSS.t111 sg13_lv_nmos ad=0.2516p pd=2.16u as=0.2516p ps=2.16u w=0.74u l=0.13u
X364 a_18795_949# a_18585_949# VDD VDD sg13_lv_pmos ad=0.2128p pd=1.5u as=0.252p ps=1.57u w=1.12u l=0.13u
X365 a_14235_949# a_14025_949# VDD VDD sg13_lv_pmos ad=0.2128p pd=1.5u as=0.252p ps=1.57u w=1.12u l=0.13u
X366 VDD DELAY_OUT_TAP3 a_6425_949# VDD sg13_lv_pmos ad=0.252p pd=1.57u as=0.3808p ps=2.92u w=1.12u l=0.13u
X367 a_7390_949# a_7364_913# a_7288_949# VDD sg13_lv_pmos ad=0.3808p pd=2.92u as=0.2128p ps=1.5u w=1.12u l=0.13u
X368 a_24008_949# DELAY_OUT_TAP26 VSS.t17 VSS.t16 sg13_lv_nmos ad=0.1406p pd=1.12u as=0.2516p ps=2.16u w=0.74u l=0.13u
X369 a_15964_194# MUX_SEL4 a_5731_194# VDD sg13_lv_pmos ad=0.3304p pd=1.71u as=0.3808p ps=2.92u w=1.12u l=0.13u
X370 a_1256_949# MUX_SEL0 VSS.t189 VSS.t188 sg13_lv_nmos ad=0.2516p pd=2.16u as=0.2516p ps=2.16u w=0.74u l=0.13u
X371 a_22488_949# DELAY_OUT_TAP24 VDD VDD sg13_lv_pmos ad=0.2128p pd=1.5u as=0.3808p ps=2.92u w=1.12u l=0.13u
X372 a_16510_949# a_18871_913# a_18795_949# VDD sg13_lv_pmos ad=0.3808p pd=2.92u as=0.2128p ps=1.5u w=1.12u l=0.13u
X373 a_27048_949# DELAY_OUT_TAP30 VDD VDD sg13_lv_pmos ad=0.2128p pd=1.5u as=0.3808p ps=2.92u w=1.12u l=0.13u
X374 a_13470_949# a_14311_913# a_14235_949# VDD sg13_lv_pmos ad=0.3808p pd=2.92u as=0.2128p ps=1.5u w=1.12u l=0.13u
X375 a_13470_949# a_3171_952.t6 a_14888_949# VSS.t127 sg13_lv_nmos ad=0.2516p pd=2.16u as=0.1406p ps=1.12u w=0.74u l=0.13u
X376 a_1256_194# MUX_SEL2 VSS.t43 VSS.t42 sg13_lv_nmos ad=0.2516p pd=2.16u as=0.2516p ps=2.16u w=0.74u l=0.13u
X377 a_9675_949# a_9465_949# VDD VDD sg13_lv_pmos ad=0.2128p pd=1.5u as=0.252p ps=1.57u w=1.12u l=0.13u
X378 VSS.t35 a_2019_952.t2 a_25604_913# VSS.t34 sg13_lv_nmos ad=0.2516p pd=2.16u as=0.2516p ps=2.16u w=0.74u l=0.13u
X379 a_16108_194# MUX_SEL4 a_15964_194# VSS.t23 sg13_lv_nmos ad=0.2516p pd=2.16u as=0.2183p ps=1.33u w=0.74u l=0.13u
X380 a_21835_949# a_21625_949# VSS.t15 VSS.t148 sg13_lv_nmos ad=0.1406p pd=1.12u as=0.1665p ps=1.19u w=0.74u l=0.13u
X381 VSS.t63 a_2595_952.t4 a_20391_913# VSS.t62 sg13_lv_nmos ad=0.2516p pd=2.16u as=0.2516p ps=2.16u w=0.74u l=0.13u
X382 a_2019_952.t1 a_1721_1300# VDD VDD sg13_lv_pmos ad=0.2128p pd=1.5u as=0.1918p ps=1.5u w=1.12u l=0.13u
X383 VSS.t147 DELAY_OUT_TAP9 a_10985_949# VSS.t293 sg13_lv_nmos ad=0.1665p pd=1.19u as=0.2516p ps=2.16u w=0.74u l=0.13u
X384 a_7390_949# a_9751_913# a_9675_949# VDD sg13_lv_pmos ad=0.3808p pd=2.92u as=0.2128p ps=1.5u w=1.12u l=0.13u
X385 VSS.t240 VDD VSS.t239 VSS.t238 sg13_lv_nmos ad=0.1428p pd=1.52u as=0 ps=0 w=0.42u l=1u
X386 VDD a_3171_216.t2 a_23945_424# VDD sg13_lv_pmos ad=0.3808p pd=2.92u as=0.3808p ps=2.92u w=1.12u l=0.13u
X387 VSS.t340 a_3747_952.t5 a_18871_913# VSS.t339 sg13_lv_nmos ad=0.2516p pd=2.16u as=0.2516p ps=2.16u w=0.74u l=0.13u
X388 a_12715_949# a_12505_949# VSS.t152 VSS.t151 sg13_lv_nmos ad=0.1406p pd=1.12u as=0.1665p ps=1.19u w=0.74u l=0.13u
X389 a_17928_949# DELAY_OUT_TAP18 VSS.t300 VSS.t299 sg13_lv_nmos ad=0.1406p pd=1.12u as=0.2516p ps=2.16u w=0.74u l=0.13u
X390 VDD MUX_SEL4 a_15765_368# VDD sg13_lv_pmos ad=0.3808p pd=2.92u as=0.3808p ps=2.92u w=1.12u l=0.13u
X391 a_19550_949# a_3171_952.t4 a_20968_949# VSS.t3 sg13_lv_nmos ad=0.2516p pd=2.16u as=0.1406p ps=1.12u w=0.74u l=0.13u
X392 a_7288_949# DELAY_OUT_TAP4 VSS.t179 VSS.t178 sg13_lv_nmos ad=0.1406p pd=1.12u as=0.2516p ps=2.16u w=0.74u l=0.13u
X393 a_1815_236# a_1256_194# a_1721_236# VSS.t104 sg13_lv_nmos ad=0.1216p pd=1.02u as=0.2176p ps=1.96u w=0.64u l=0.13u
X394 a_1544_194# MUX_SEL3 VSS.t329 VSS.t328 sg13_lv_nmos ad=0.2516p pd=2.16u as=0.2516p ps=2.16u w=0.74u l=0.13u
X395 a_22590_949# a_3747_952.t3 a_24875_949# VSS.t110 sg13_lv_nmos ad=0.2516p pd=2.16u as=0.1406p ps=1.12u w=0.74u l=0.13u
X396 VDD DELAY_OUT_TAP23 a_21625_949# VDD sg13_lv_pmos ad=0.252p pd=1.57u as=0.3808p ps=2.92u w=1.12u l=0.13u
X397 a_22590_949# a_22564_913# a_22488_949# VDD sg13_lv_pmos ad=0.3808p pd=2.92u as=0.2128p ps=1.5u w=1.12u l=0.13u
X398 VSS.t71 DELAY_OUT_TAP29 a_26185_949# VSS.t70 sg13_lv_nmos ad=0.1665p pd=1.19u as=0.2516p ps=2.16u w=0.74u l=0.13u
X399 VSS.t210 VDD VSS.t209 VSS.t208 sg13_lv_nmos ad=0.1428p pd=1.52u as=0 ps=0 w=0.42u l=1u
X400 VDD DELAY_OUT_TAP29 a_26185_949# VDD sg13_lv_pmos ad=0.252p pd=1.57u as=0.3808p ps=2.92u w=1.12u l=0.13u
X401 VSS.t139 DELAY_OUT_TAP1 a_4905_949# VSS.t181 sg13_lv_nmos ad=0.1665p pd=1.19u as=0.2516p ps=2.16u w=0.74u l=0.13u
X402 a_25630_949# a_27124_913# a_27048_949# VDD sg13_lv_pmos ad=0.3808p pd=2.92u as=0.2128p ps=1.5u w=1.12u l=0.13u
X403 VDD VSS.t364 VDD VDD sg13_lv_pmos ad=0.34p pd=2.68u as=0 ps=0 w=1u l=1u
X404 VDD a_2019_952.t6 a_13444_913# VDD sg13_lv_pmos ad=0.3808p pd=2.92u as=0.3808p ps=2.92u w=1.12u l=0.13u
X405 VSS.t28 a_3171_952.t8 a_8884_913# VSS.t27 sg13_lv_nmos ad=0.2516p pd=2.16u as=0.2516p ps=2.16u w=0.74u l=0.13u
X406 VDD VSS.t378 VDD VDD sg13_lv_pmos ad=0.34p pd=2.68u as=0 ps=0 w=1u l=1u
X407 VDD VSS.t373 VDD VDD sg13_lv_pmos ad=0.19p pd=1.38u as=0 ps=0 w=1u l=1u
X408 VSS.t92 a_1544_194# a_1815_236# VSS.t91 sg13_lv_nmos ad=0.1331p pd=1.12u as=0.1216p ps=1.02u w=0.64u l=0.13u
X409 VDD a_3171_952.t5 a_18004_913# VDD sg13_lv_pmos ad=0.3808p pd=2.92u as=0.3808p ps=2.92u w=1.12u l=0.13u
X410 VSS.t143 MUX_SEL1 a_3543_1300# VSS.t185 sg13_lv_nmos ad=0.1331p pd=1.12u as=0.1216p ps=1.02u w=0.64u l=0.13u
X411 a_27915_949# a_27705_949# VSS.t22 VSS.t156 sg13_lv_nmos ad=0.1406p pd=1.12u as=0.1665p ps=1.19u w=0.74u l=0.13u
X412 VSS.t282 VDD VSS.t280 VSS.t281 sg13_lv_nmos ad=79.8f pd=0.8u as=0 ps=0 w=0.42u l=1u
X413 a_24875_949# a_24665_949# VDD VDD sg13_lv_pmos ad=0.2128p pd=1.5u as=0.252p ps=1.57u w=1.12u l=0.13u
C0 VDD a_12715_949# 0.15406f
C1 a_4324_913# DELAY_OUT_TAP1 0.0501f
C2 a_5191_913# a_4350_949# 0.28268f
C3 VDD a_2873_1300# 0.46491f
C4 a_16484_913# DELAY_OUT_TAP16 0.02011f
C5 a_16484_913# a_16510_949# 0.277f
C6 VDD DELAY_OUT_TAP18 0.13878f
C7 a_13444_913# DELAY_OUT_TAP13 0.0501f
C8 VDD a_11924_913# 0.28225f
C9 DELAY_OUT_TAP8 MUX_SEL4 0.01829f
C10 VDD a_17065_949# 0.30142f
C11 a_24084_913# DELAY_OUT_TAP27 0.02053f
C12 DELAY_OUT_TAP18 DELAY_OUT_TAP19 0.03717f
C13 a_25528_949# a_25630_949# 0.37183f
C14 a_16484_913# a_16408_949# 0.01176f
C15 a_27048_949# a_27124_913# 0.01176f
C16 MUX_OUT a_16851_214# 0.45865f
C17 a_12505_949# DELAY_OUT_TAP11 0.2079f
C18 VDD DELAY_OUT_TAP0 0.50967f
C19 DELAY_OUT_TAP6 DELAY_OUT_TAP7 0.03717f
C20 DELAY_OUT_TAP3 a_5844_913# 0.02053f
C21 a_10328_949# a_10430_949# 0.37183f
C22 a_5115_949# a_5191_913# 0.01194f
C23 MUX_OUT a_1544_949# 0.04258f
C24 DELAY_OUT_TAP12 DELAY_OUT_TAP13 0.06596f
C25 DELAY_OUT_TAP4 a_7364_913# 0.02011f
C26 DELAY_OUT_TAP5 a_7390_949# 0.10838f
C27 a_4324_913# a_4157_1218# 0.02463f
C28 a_16851_214# a_16510_949# 0.02131f
C29 VDD MUX_SEL2 0.50938f
C30 VDD a_17275_949# 0.15389f
C31 a_25630_949# a_27705_949# 0.03208f
C32 MUX_SEL2 a_2873_236# 0.01422f
C33 a_24008_949# a_24084_913# 0.01176f
C34 a_27991_913# a_27705_949# 0.01885f
C35 a_16108_194# a_5731_194# 0.01334f
C36 a_22590_949# DELAY_OUT_TAP27 0.05189f
C37 DELAY_OUT_TAP0 MUX_SEL4 0.06593f
C38 a_8231_913# a_7945_949# 0.01885f
C39 DELAY_OUT_TAP3 DELAY_OUT_TAP4 0.0331f
C40 VDD a_11848_949# 0.17499f
C41 a_6635_949# a_6425_949# 0.09424f
C42 a_4324_913# a_4350_949# 0.277f
C43 a_19448_949# a_19524_913# 0.01176f
C44 a_14825_424# a_13470_949# 0.02058f
C45 a_15765_368# a_15964_194# 0.061f
C46 DELAY_OUT_TAP15 a_14964_913# 0.02053f
C47 MUX_SEL4 MUX_SEL2 0.01978f
C48 a_14235_949# a_14311_913# 0.01194f
C49 a_11924_913# DELAY_OUT_TAP10 0.02312f
C50 a_8155_949# a_7945_949# 0.09424f
C51 a_6635_949# a_6711_913# 0.01194f
C52 a_2019_216# a_17865_424# 0.13959f
C53 a_15831_913# DELAY_OUT_TAP16 0.02339f
C54 a_22590_949# a_23355_949# 0.39037f
C55 VDD a_17865_424# 0.29444f
C56 a_4324_913# a_4248_949# 0.01176f
C57 a_3449_1300# MUX_SEL1 0.29404f
C58 a_18004_913# a_17928_949# 0.01176f
C59 MUX_SEL2 MUX_SEL3 3.21891f
C60 VDD a_7288_949# 0.17274f
C61 a_22590_949# a_24008_949# 0.38994f
C62 a_2297_236# a_1544_194# 0.27303f
C63 VDD a_14025_949# 0.30333f
C64 VDD a_1721_1300# 0.45305f
C65 a_26985_424# VDD 0.29292f
C66 a_10430_949# DELAY_OUT_TAP12 0.02437f
C67 DELAY_OUT_TAP29 VDD 0.13651f
C68 VDD a_8231_913# 0.28336f
C69 a_26185_949# a_26471_913# 0.01885f
C70 a_27124_913# DELAY_OUT_TAP31 0.02053f
C71 a_2297_236# a_1256_194# 0.04261f
C72 VDD a_12505_949# 0.29646f
C73 DELAY_OUT_TAP14 DELAY_OUT_TAP13 0.02068f
C74 a_22488_949# DELAY_OUT_TAP24 0.10864f
C75 DELAY_OUT_TAP28 DELAY_OUT_TAP27 0.0331f
C76 a_13470_949# a_15755_949# 0.39036f
C77 DELAY_OUT_TAP9 a_10985_949# 0.19203f
C78 VDD a_8155_949# 0.15389f
C79 a_19550_949# a_20905_424# 0.02165f
C80 a_26185_949# a_26395_949# 0.09424f
C81 a_19448_949# DELAY_OUT_TAP20 0.10864f
C82 DELAY_OUT_TAP4 a_6711_913# 0.02339f
C83 a_11848_949# DELAY_OUT_TAP10 0.10863f
C84 a_7390_949# a_8808_949# 0.38994f
C85 VDD a_24875_949# 0.15406f
C86 a_26185_949# a_25630_949# 0.03209f
C87 VDD a_10985_949# 0.30333f
C88 a_8884_913# DELAY_OUT_TAP7 0.02053f
C89 VDD a_7364_913# 0.28633f
C90 VDD a_24084_913# 0.28225f
C91 a_9751_913# a_9465_949# 0.01885f
C92 a_13444_913# DELAY_OUT_TAP12 0.02011f
C93 a_13470_949# DELAY_OUT_TAP13 0.10838f
C94 VDD a_15545_949# 0.29842f
C95 a_24084_913# DELAY_OUT_TAP26 0.02312f
C96 a_19524_913# DELAY_OUT_TAP21 0.0501f
C97 a_9751_913# a_7390_949# 0.26208f
C98 VDD DELAY_OUT_TAP3 0.12759f
C99 DELAY_OUT_TAP2 a_5844_913# 0.02312f
C100 MUX_OUT a_1256_949# 0.02466f
C101 DELAY_OUT_TAP14 DELAY_OUT_TAP15 0.03717f
C102 a_13470_949# a_5731_194# 0.41365f
C103 a_25528_949# VDD 0.17274f
C104 VDD a_16484_913# 0.28597f
C105 VDD a_22590_949# 0.89557f
C106 a_14311_913# a_14025_949# 0.01885f
C107 a_27915_949# a_27705_949# 0.09424f
C108 a_15964_194# a_5731_194# 0.2778f
C109 a_22590_949# DELAY_OUT_TAP26 0.07996f
C110 a_17065_949# a_17275_949# 0.09424f
C111 MUX_OUT a_2297_236# 0.01179f
C112 VDD a_23945_424# 0.29292f
C113 VDD a_22488_949# 0.17274f
C114 a_13368_949# a_13444_913# 0.01176f
C115 VDD a_11271_913# 0.28336f
C116 VDD a_27705_949# 0.29842f
C117 a_14235_949# a_14025_949# 0.09424f
C118 a_19448_949# a_19550_949# 0.37183f
C119 a_17928_949# a_16510_949# 0.38994f
C120 DELAY_OUT_TAP14 a_14964_913# 0.02312f
C121 VDD a_6425_949# 0.29646f
C122 a_11924_913# a_11848_949# 0.01176f
C123 DELAY_OUT_TAP20 DELAY_OUT_TAP21 0.06596f
C124 a_2019_216# a_16851_214# 0.01299f
C125 VDD a_16851_214# 0.51536f
C126 DELAY_OUT_TAP15 a_13470_949# 0.05189f
C127 a_22590_949# a_22564_913# 0.277f
C128 a_22590_949# a_23431_913# 0.28268f
C129 VDD a_6711_913# 0.2822f
C130 VDD a_4905_949# 0.3005f
C131 a_13368_949# DELAY_OUT_TAP12 0.10864f
C132 a_1721_236# a_1544_194# 0.36963f
C133 VDD a_1544_949# 0.45004f
C134 a_22488_949# a_22564_913# 0.01176f
C135 a_7945_949# a_7390_949# 0.03209f
C136 a_12715_949# a_12505_949# 0.09424f
C137 a_14888_949# a_14964_913# 0.01176f
C138 DELAY_OUT_TAP28 VDD 0.14794f
C139 a_27124_913# DELAY_OUT_TAP30 0.02312f
C140 a_1721_236# a_1256_194# 0.13421f
C141 a_18795_949# a_18871_913# 0.01194f
C142 a_13470_949# a_14964_913# 0.28279f
C143 a_16108_194# DELAY_OUT_TAP20 0.0157f
C144 VDD a_15831_913# 0.2816f
C145 MUX_SEL4 a_1544_949# 0.03407f
C146 a_18871_913# DELAY_OUT_TAP20 0.02339f
C147 VDD a_2297_1300# 0.4651f
C148 a_11271_913# DELAY_OUT_TAP10 0.02334f
C149 MUX_OUT a_5731_194# 1.04829f
C150 DELAY_OUT_TAP23 a_21625_949# 0.2079f
C151 a_13470_949# a_13444_913# 0.277f
C152 a_27124_913# a_25630_949# 0.28279f
C153 a_5844_913# a_5768_949# 0.01176f
C154 VDD a_9465_949# 0.29646f
C155 a_8884_913# DELAY_OUT_TAP6 0.02312f
C156 VDD a_11195_949# 0.15389f
C157 DELAY_OUT_TAP22 DELAY_OUT_TAP21 0.02068f
C158 a_6635_949# a_4350_949# 0.39036f
C159 VDD a_7390_949# 0.8686f
C160 a_10430_949# a_12791_913# 0.26208f
C161 a_9675_949# a_9465_949# 0.09424f
C162 VDD a_26185_949# 0.30333f
C163 a_15964_194# a_16108_194# 0.42202f
C164 a_5844_913# a_4350_949# 0.28279f
C165 a_19550_949# DELAY_OUT_TAP21 0.10838f
C166 a_19524_913# DELAY_OUT_TAP20 0.02011f
C167 a_9675_949# a_7390_949# 0.39036f
C168 a_24665_949# DELAY_OUT_TAP27 0.2079f
C169 VDD DELAY_OUT_TAP2 0.13878f
C170 MUX_OUT MUX_SEL1 0.09357f
C171 MUX_SEL4 a_7390_949# 0.34655f
C172 a_24951_913# VDD 0.2822f
C173 DELAY_OUT_TAP15 DELAY_OUT_TAP16 0.0331f
C174 DELAY_OUT_TAP5 DELAY_OUT_TAP6 0.02068f
C175 a_15765_368# a_2019_216# 0.05969f
C176 DELAY_OUT_TAP4 a_4350_949# 0.02437f
C177 a_15765_368# VDD 0.35368f
C178 VDD MUX_SEL0 0.51342f
C179 VDD a_20905_424# 0.29292f
C180 a_16108_194# a_19550_949# 0.58202f
C181 a_13368_949# a_13470_949# 0.37183f
C182 a_20315_949# a_20391_913# 0.01194f
C183 a_14825_424# VDD 0.29292f
C184 a_17351_913# a_16510_949# 0.28268f
C185 DELAY_OUT_TAP14 a_14888_949# 0.10863f
C186 DELAY_OUT_TAP22 DELAY_OUT_TAP23 0.03717f
C187 a_15765_368# MUX_SEL4 0.65508f
C188 a_8155_949# a_8231_913# 0.01194f
C189 DELAY_OUT_TAP14 a_13470_949# 0.07996f
C190 VDD DELAY_OUT_TAP1 0.13941f
C191 DELAY_OUT_TAP21 a_20105_949# 0.19203f
C192 a_7288_949# a_7364_913# 0.01176f
C193 a_21044_913# DELAY_OUT_TAP23 0.02053f
C194 MUX_OUT a_16108_194# 0.24265f
C195 a_12791_913# DELAY_OUT_TAP12 0.02339f
C196 VDD a_1256_949# 0.47094f
C197 DELAY_OUT_TAP23 a_19550_949# 0.05189f
C198 a_14825_424# MUX_SEL4 0.03307f
C199 a_1256_194# a_1544_194# 1.25711f
C200 a_27048_949# DELAY_OUT_TAP30 0.10863f
C201 VDD a_17928_949# 0.17499f
C202 a_16108_194# a_16510_949# 0.56108f
C203 a_19550_949# a_19524_913# 0.277f
C204 a_2297_236# a_2019_216# 0.04011f
C205 a_18871_913# a_16510_949# 0.26208f
C206 VDD a_2297_236# 0.46496f
C207 a_13470_949# a_14888_949# 0.38994f
C208 MUX_SEL4 a_1256_949# 0.04908f
C209 VDD a_15755_949# 0.15389f
C210 a_23145_949# DELAY_OUT_TAP25 0.19203f
C211 VDD a_5768_949# 0.17499f
C212 a_4157_1218# a_2019_216# 0.01018f
C213 a_16108_194# a_25630_949# 0.55833f
C214 DELAY_OUT_TAP9 a_10404_913# 0.0501f
C215 VDD a_4157_1218# 0.48906f
C216 a_27048_949# a_25630_949# 0.38994f
C217 DELAY_OUT_TAP8 a_7390_949# 0.02437f
C218 DELAY_OUT_TAP22 a_20391_913# 0.02334f
C219 a_10430_949# DELAY_OUT_TAP11 0.05189f
C220 a_11785_424# a_5731_194# 0.28056f
C221 a_8808_949# DELAY_OUT_TAP6 0.10863f
C222 MUX_SEL4 a_2297_236# 0.04338f
C223 VDD a_10404_913# 0.28633f
C224 a_21625_949# a_19550_949# 0.03208f
C225 a_2019_216# a_4350_949# 0.02042f
C226 VDD a_27124_913# 0.28225f
C227 VDD a_19448_949# 0.17274f
C228 a_19550_949# a_20391_913# 0.28268f
C229 VDD a_4350_949# 0.87635f
C230 VDD DELAY_OUT_TAP7 0.12759f
C231 VDD a_24665_949# 0.29646f
C232 a_8745_424# VDD 0.29292f
C233 VDD DELAY_OUT_TAP13 0.13651f
C234 a_4157_1218# MUX_SEL4 0.08229f
C235 MUX_SEL3 a_2297_236# 0.01595f
C236 a_5705_424# a_4350_949# 0.02005f
C237 a_19550_949# a_20315_949# 0.39037f
C238 VDD a_4248_949# 0.17587f
C239 a_11785_424# a_10430_949# 0.02058f
C240 a_22590_949# a_24875_949# 0.39036f
C241 a_2019_216# a_5731_194# 1.15781f
C242 MUX_SEL4 a_4350_949# 0.31434f
C243 a_8745_424# MUX_SEL4 0.04472f
C244 VDD a_5731_194# 0.6143f
C245 a_5115_949# VDD 0.15389f
C246 a_1544_949# a_1721_1300# 0.38063f
C247 DELAY_OUT_TAP30 DELAY_OUT_TAP31 0.03717f
C248 MUX_OUT a_1544_194# 0.69943f
C249 a_5705_424# a_5731_194# 0.28954f
C250 a_22590_949# a_24084_913# 0.28279f
C251 a_11271_913# a_10985_949# 0.01885f
C252 a_16108_194# DELAY_OUT_TAP24 0.0157f
C253 a_18795_949# a_16510_949# 0.39036f
C254 a_16510_949# DELAY_OUT_TAP17 0.10838f
C255 DELAY_OUT_TAP16 DELAY_OUT_TAP17 0.06596f
C256 MUX_SEL0 a_2873_1300# 0.01504f
C257 DELAY_OUT_TAP9 a_10430_949# 0.10838f
C258 DELAY_OUT_TAP28 DELAY_OUT_TAP29 0.06596f
C259 a_16510_949# DELAY_OUT_TAP20 0.02437f
C260 MUX_OUT a_1256_194# 0.1134f
C261 MUX_SEL4 a_5731_194# 4.60702f
C262 DELAY_OUT_TAP31 a_25630_949# 0.05211f
C263 a_18004_913# a_16510_949# 0.28279f
C264 a_20391_913# a_20105_949# 0.01885f
C265 VDD a_10430_949# 0.88416f
C266 DELAY_OUT_TAP11 DELAY_OUT_TAP12 0.0331f
C267 DELAY_OUT_TAP23 DELAY_OUT_TAP24 0.0331f
C268 VDD DELAY_OUT_TAP15 0.12874f
C269 VDD MUX_SEL1 0.49936f
C270 a_7288_949# a_7390_949# 0.37183f
C271 a_21044_913# DELAY_OUT_TAP22 0.02312f
C272 MUX_OUT a_15964_194# 0.01307f
C273 a_20315_949# a_20105_949# 0.09424f
C274 DELAY_OUT_TAP22 a_19550_949# 0.07996f
C275 VDD a_10328_949# 0.17274f
C276 a_13470_949# DELAY_OUT_TAP16 0.02437f
C277 a_1256_949# a_2873_1300# 0.28892f
C278 a_25630_949# a_25604_913# 0.277f
C279 DELAY_OUT_TAP3 a_6425_949# 0.2079f
C280 MUX_SEL0 MUX_SEL2 0.01204f
C281 MUX_SEL4 a_10430_949# 0.24983f
C282 a_8808_949# a_8884_913# 0.01176f
C283 a_22590_949# a_23945_424# 0.02165f
C284 VDD DELAY_OUT_TAP21 0.13651f
C285 a_22488_949# a_22590_949# 0.37183f
C286 a_8231_913# a_7390_949# 0.28268f
C287 a_21044_913# a_19550_949# 0.28279f
C288 a_23355_949# a_23145_949# 0.09424f
C289 a_15964_194# DELAY_OUT_TAP16 0.02f
C290 a_15964_194# a_16510_949# 0.05416f
C291 VDD a_17351_913# 0.28565f
C292 a_1721_236# a_2019_216# 0.18452f
C293 DELAY_OUT_TAP0 DELAY_OUT_TAP1 0.04252f
C294 MUX_SEL4 MUX_SEL1 0.03574f
C295 DELAY_OUT_TAP29 a_26185_949# 0.19203f
C296 VDD a_1721_236# 0.45259f
C297 a_17928_949# DELAY_OUT_TAP18 0.10863f
C298 VDD a_14964_913# 0.28225f
C299 VDD a_5191_913# 0.28565f
C300 a_8155_949# a_7390_949# 0.39037f
C301 DELAY_OUT_TAP8 a_10404_913# 0.02011f
C302 VDD a_3449_1300# 0.46654f
C303 VDD a_13444_913# 0.28633f
C304 a_11195_949# a_10985_949# 0.09424f
C305 a_15545_949# a_15831_913# 0.01885f
C306 a_18871_913# a_18585_949# 0.01885f
C307 a_10430_949# DELAY_OUT_TAP10 0.07996f
C308 DELAY_OUT_TAP8 DELAY_OUT_TAP7 0.0331f
C309 a_16108_194# a_2019_216# 0.33889f
C310 MUX_SEL4 a_1721_236# 0.05813f
C311 DELAY_OUT_TAP28 a_25528_949# 0.10864f
C312 VDD a_16108_194# 1.25759f
C313 a_7390_949# a_7364_913# 0.277f
C314 DELAY_OUT_TAP28 a_22590_949# 0.02437f
C315 a_21625_949# a_21911_913# 0.01885f
C316 VDD a_27048_949# 0.17499f
C317 VDD a_18871_913# 0.2822f
C318 MUX_SEL0 a_1721_1300# 0.01315f
C319 VDD DELAY_OUT_TAP6 0.13878f
C320 a_6711_913# a_6425_949# 0.01885f
C321 a_4157_1218# DELAY_OUT_TAP0 0.50642f
C322 VDD DELAY_OUT_TAP12 0.1474f
C323 MUX_SEL2 a_2297_236# 0.10655f
C324 MUX_SEL4 a_16108_194# 0.1283f
C325 VDD DELAY_OUT_TAP23 0.12759f
C326 a_24951_913# a_24875_949# 0.01194f
C327 a_19550_949# a_20105_949# 0.03209f
C328 DELAY_OUT_TAP30 a_26471_913# 0.02334f
C329 MUX_SEL4 DELAY_OUT_TAP12 0.01829f
C330 a_1721_1300# a_1256_949# 0.13421f
C331 a_4324_913# VDD 0.28597f
C332 DELAY_OUT_TAP2 DELAY_OUT_TAP3 0.03717f
C333 a_26395_949# a_26471_913# 0.01194f
C334 VDD a_19524_913# 0.28633f
C335 a_11195_949# a_11271_913# 0.01194f
C336 a_26471_913# a_25630_949# 0.28268f
C337 DELAY_OUT_TAP4 DELAY_OUT_TAP5 0.06596f
C338 VDD a_13368_949# 0.17274f
C339 a_12715_949# a_10430_949# 0.39036f
C340 DELAY_OUT_TAP30 a_25630_949# 0.07996f
C341 VDD a_23145_949# 0.30333f
C342 a_16408_949# a_16510_949# 0.37183f
C343 a_16408_949# DELAY_OUT_TAP16 0.10864f
C344 a_1544_949# a_2297_1300# 0.28651f
C345 a_18795_949# a_18585_949# 0.09424f
C346 DELAY_OUT_TAP8 a_10328_949# 0.10864f
C347 a_26395_949# a_25630_949# 0.39037f
C348 a_24951_913# a_22590_949# 0.26208f
C349 VDD DELAY_OUT_TAP14 0.13878f
C350 a_11924_913# a_10430_949# 0.28279f
C351 VDD a_21625_949# 0.29646f
C352 a_2873_1300# MUX_SEL1 0.13092f
C353 a_20968_949# DELAY_OUT_TAP22 0.10863f
C354 VDD DELAY_OUT_TAP31 0.1288f
C355 VDD a_20391_913# 0.28336f
C356 DELAY_OUT_TAP24 DELAY_OUT_TAP25 0.06596f
C357 VDD a_18795_949# 0.15406f
C358 VDD DELAY_OUT_TAP17 0.1382f
C359 a_25630_949# a_27991_913# 0.26208f
C360 a_19550_949# DELAY_OUT_TAP24 0.02437f
C361 a_20968_949# a_21044_913# 0.01176f
C362 a_2019_216# a_1544_194# 0.01747f
C363 VDD DELAY_OUT_TAP20 0.14794f
C364 a_14025_949# DELAY_OUT_TAP13 0.19203f
C365 a_20968_949# a_19550_949# 0.38994f
C366 VDD a_20315_949# 0.15389f
C367 VDD a_1544_194# 0.39113f
C368 VDD a_18004_913# 0.28225f
C369 a_23431_913# a_23145_949# 0.01885f
C370 a_19550_949# a_21911_913# 0.26208f
C371 DELAY_OUT_TAP19 DELAY_OUT_TAP20 0.0331f
C372 VDD a_25604_913# 0.28633f
C373 DELAY_OUT_TAP0 MUX_SEL1 0.01783f
C374 a_18004_913# DELAY_OUT_TAP19 0.02053f
C375 a_17351_913# DELAY_OUT_TAP18 0.02334f
C376 VDD a_8884_913# 0.28225f
C377 VDD a_14888_949# 0.17499f
C378 a_2019_216# a_1256_194# 0.02904f
C379 a_17065_949# a_17351_913# 0.01885f
C380 VDD a_1256_194# 0.40292f
C381 DELAY_OUT_TAP5 a_7945_949# 0.19203f
C382 a_1256_194# a_2873_236# 0.27926f
C383 VDD a_13470_949# 0.87936f
C384 a_15545_949# a_15755_949# 0.09424f
C385 MUX_SEL4 a_1544_194# 0.47529f
C386 a_10430_949# a_11848_949# 0.38994f
C387 a_9465_949# a_7390_949# 0.03208f
C388 a_15964_194# a_2019_216# 0.02413f
C389 DELAY_OUT_TAP28 a_24951_913# 0.02339f
C390 a_24665_949# a_24875_949# 0.09424f
C391 VDD a_15964_194# 0.31311f
C392 MUX_SEL3 a_1544_194# 0.15976f
C393 a_21625_949# a_21835_949# 0.09424f
C394 a_17275_949# a_17351_913# 0.01194f
C395 MUX_SEL4 a_1256_194# 0.65005f
C396 MUX_SEL0 a_1544_949# 0.07603f
C397 MUX_SEL4 a_13470_949# 0.256f
C398 a_3449_1300# DELAY_OUT_TAP0 0.01044f
C399 MUX_SEL2 a_1721_236# 0.01315f
C400 MUX_SEL3 a_1256_194# 1.41161f
C401 a_4905_949# DELAY_OUT_TAP1 0.19203f
C402 VDD DELAY_OUT_TAP5 0.13651f
C403 MUX_SEL4 a_15964_194# 0.5544f
C404 VDD DELAY_OUT_TAP22 0.13878f
C405 DELAY_OUT_TAP3 a_4350_949# 0.05189f
C406 MUX_SEL0 a_2297_1300# 0.10655f
C407 a_10430_949# a_12505_949# 0.03208f
C408 VDD DELAY_OUT_TAP25 0.13651f
C409 DELAY_OUT_TAP14 a_14311_913# 0.02334f
C410 a_1544_949# a_1256_949# 1.26509f
C411 VDD a_21044_913# 0.28225f
C412 VDD a_19550_949# 0.89766f
C413 DELAY_OUT_TAP26 DELAY_OUT_TAP25 0.02068f
C414 a_22590_949# a_24665_949# 0.03208f
C415 VDD a_12791_913# 0.2822f
C416 a_10430_949# a_10985_949# 0.03209f
C417 a_1256_949# a_2297_1300# 0.04619f
C418 MUX_OUT a_2019_216# 8.45486f
C419 VDD MUX_OUT 0.35871f
C420 a_16510_949# a_18585_949# 0.03208f
C421 a_22564_913# DELAY_OUT_TAP25 0.0501f
C422 a_4350_949# a_6425_949# 0.03208f
C423 a_16108_194# a_17865_424# 0.29564f
C424 VDD a_26471_913# 0.28336f
C425 a_13470_949# a_14311_913# 0.28268f
C426 a_2019_216# a_16510_949# 0.03139f
C427 VDD DELAY_OUT_TAP30 0.13878f
C428 a_15755_949# a_15831_913# 0.01194f
C429 VDD a_16510_949# 0.8795f
C430 a_6711_913# a_4350_949# 0.26208f
C431 VDD DELAY_OUT_TAP16 0.14932f
C432 a_26985_424# a_16108_194# 0.2906f
C433 a_4350_949# a_4905_949# 0.03209f
C434 a_25630_949# a_27915_949# 0.39036f
C435 a_27915_949# a_27991_913# 0.01194f
C436 VDD a_26395_949# 0.15389f
C437 a_15545_949# DELAY_OUT_TAP15 0.2079f
C438 MUX_OUT MUX_SEL4 0.91933f
C439 DELAY_OUT_TAP17 DELAY_OUT_TAP18 0.02068f
C440 a_13470_949# a_14235_949# 0.39037f
C441 a_16510_949# DELAY_OUT_TAP19 0.05189f
C442 a_21911_913# DELAY_OUT_TAP24 0.02339f
C443 a_17065_949# DELAY_OUT_TAP17 0.19203f
C444 DELAY_OUT_TAP2 DELAY_OUT_TAP1 0.02068f
C445 VDD a_16408_949# 0.17274f
C446 a_19550_949# a_21835_949# 0.39036f
C447 VDD a_25630_949# 0.89531f
C448 a_8231_913# DELAY_OUT_TAP6 0.02334f
C449 VDD a_27991_913# 0.28201f
C450 VDD a_20105_949# 0.30333f
C451 MUX_OUT MUX_SEL3 0.79533f
C452 a_18004_913# DELAY_OUT_TAP18 0.02312f
C453 VDD a_8808_949# 0.17499f
C454 VDD a_6635_949# 0.15406f
C455 a_5115_949# a_4905_949# 0.09424f
C456 a_2019_216# a_3449_236# 0.01176f
C457 VDD a_3449_236# 0.46596f
C458 a_10430_949# a_11271_913# 0.28268f
C459 VDD a_5844_913# 0.28225f
C460 VDD DELAY_OUT_TAP27 0.12759f
C461 a_9465_949# DELAY_OUT_TAP7 0.2079f
C462 DELAY_OUT_TAP2 a_5768_949# 0.10863f
C463 MUX_SEL0 a_1256_949# 0.3314f
C464 MUX_SEL2 a_1544_194# 0.07405f
C465 VDD a_9751_913# 0.2822f
C466 DELAY_OUT_TAP26 DELAY_OUT_TAP27 0.03717f
C467 a_7390_949# DELAY_OUT_TAP7 0.05189f
C468 a_8745_424# a_7390_949# 0.01756f
C469 MUX_SEL4 a_3449_236# 0.05166f
C470 MUX_SEL2 a_1256_194# 0.33134f
C471 VDD a_23355_949# 0.15389f
C472 a_9675_949# a_9751_913# 0.01194f
C473 VDD DELAY_OUT_TAP4 0.14695f
C474 VDD a_24008_949# 0.17499f
C475 MUX_SEL3 a_3449_236# 0.28429f
C476 DELAY_OUT_TAP2 a_4350_949# 0.07996f
C477 a_1544_949# MUX_SEL1 0.1672f
C478 a_7390_949# a_5731_194# 0.41331f
C479 a_24008_949# DELAY_OUT_TAP26 0.10863f
C480 VDD DELAY_OUT_TAP24 0.14794f
C481 a_22590_949# a_16108_194# 0.58202f
C482 VDD a_20968_949# 0.17499f
C483 VDD DELAY_OUT_TAP11 0.12759f
C484 VDD a_21911_913# 0.2822f
C485 a_24951_913# a_24665_949# 0.01885f
C486 MUX_SEL4 DELAY_OUT_TAP4 0.0195f
C487 a_12715_949# a_12791_913# 0.01194f
C488 a_16108_194# a_23945_424# 0.2906f
C489 a_2297_1300# MUX_SEL1 0.01995f
C490 a_5191_913# a_4905_949# 0.01885f
C491 a_23355_949# a_23431_913# 0.01194f
C492 a_4157_1218# DELAY_OUT_TAP1 0.01771f
C493 DELAY_OUT_TAP29 a_25604_913# 0.0501f
C494 a_10430_949# a_11195_949# 0.39037f
C495 a_13470_949# a_14025_949# 0.03209f
C496 a_22564_913# DELAY_OUT_TAP24 0.02011f
C497 a_16108_194# a_16851_214# 0.06181f
C498 VDD a_7945_949# 0.30333f
C499 VDD a_11785_424# 0.29292f
C500 a_15765_368# a_5731_194# 0.23301f
C501 a_4350_949# DELAY_OUT_TAP1 0.10838f
C502 a_16510_949# DELAY_OUT_TAP18 0.07996f
C503 DELAY_OUT_TAP28 a_16108_194# 0.0157f
C504 a_14825_424# a_5731_194# 0.28056f
C505 a_17065_949# a_16510_949# 0.03209f
C506 a_21835_949# a_21911_913# 0.01194f
C507 a_22590_949# a_23145_949# 0.03209f
C508 DELAY_OUT_TAP10 DELAY_OUT_TAP11 0.03717f
C509 a_11785_424# MUX_SEL4 0.03255f
C510 VDD a_18585_949# 0.29646f
C511 VDD a_27915_949# 0.15389f
C512 VDD DELAY_OUT_TAP9 0.13651f
C513 MUX_OUT MUX_SEL2 0.08497f
C514 DELAY_OUT_TAP19 a_18585_949# 0.2079f
C515 VDD a_2019_216# 1.43004f
C516 a_5768_949# a_4350_949# 0.38994f
C517 VDD a_2873_236# 0.46491f
C518 a_16484_913# DELAY_OUT_TAP17 0.0501f
C519 DELAY_OUT_TAP8 a_9751_913# 0.02339f
C520 a_17275_949# a_16510_949# 0.39037f
C521 a_4157_1218# a_4350_949# 0.04624f
C522 a_5705_424# a_2019_216# 0.13872f
C523 VDD DELAY_OUT_TAP19 0.12759f
C524 MUX_SEL0 MUX_SEL1 3.14917f
C525 VDD DELAY_OUT_TAP26 0.13878f
C526 a_15545_949# a_13470_949# 0.03208f
C527 VDD a_5705_424# 0.29556f
C528 DELAY_OUT_TAP2 a_5191_913# 0.02334f
C529 VDD a_9675_949# 0.15406f
C530 a_25528_949# a_25604_913# 0.01176f
C531 DELAY_OUT_TAP31 a_27705_949# 0.2079f
C532 a_4157_1218# a_4248_949# 0.11672f
C533 MUX_SEL4 a_2019_216# 0.90276f
C534 a_7390_949# DELAY_OUT_TAP6 0.07996f
C535 VDD MUX_SEL4 2.63157f
C536 DELAY_OUT_TAP0 a_3449_236# 0.01017f
C537 MUX_SEL4 a_2873_236# 0.04916f
C538 MUX_SEL3 a_2019_216# 0.06209f
C539 DELAY_OUT_TAP5 a_7364_913# 0.0501f
C540 VDD a_22564_913# 0.28633f
C541 MUX_SEL4 a_5705_424# 0.03556f
C542 a_12791_913# a_12505_949# 0.01885f
C543 a_1256_949# MUX_SEL1 1.44243f
C544 VDD a_23431_913# 0.28336f
C545 a_17865_424# a_16510_949# 0.02165f
C546 VDD MUX_SEL3 0.4053f
C547 MUX_SEL2 a_3449_236# 0.10741f
C548 MUX_SEL3 a_2873_236# 0.12606f
C549 a_4248_949# a_4350_949# 0.37183f
C550 DELAY_OUT_TAP9 DELAY_OUT_TAP10 0.02068f
C551 a_23431_913# DELAY_OUT_TAP26 0.02334f
C552 MUX_SEL0 a_3449_1300# 0.10753f
C553 a_4350_949# a_5731_194# 0.41099f
C554 DELAY_OUT_TAP29 DELAY_OUT_TAP30 0.02068f
C555 a_8745_424# a_5731_194# 0.28635f
C556 VDD DELAY_OUT_TAP10 0.13878f
C557 VDD a_21835_949# 0.15406f
C558 a_15765_368# a_16108_194# 0.42004f
C559 a_5115_949# a_4350_949# 0.39037f
C560 MUX_SEL4 MUX_SEL3 0.75489f
C561 a_11924_913# DELAY_OUT_TAP11 0.02053f
C562 a_16108_194# a_20905_424# 0.2906f
C563 a_26985_424# a_25630_949# 0.02165f
C564 DELAY_OUT_TAP29 a_25630_949# 0.10838f
C565 DELAY_OUT_TAP28 a_25604_913# 0.02011f
C566 a_10430_949# a_10404_913# 0.277f
C567 a_22590_949# DELAY_OUT_TAP25 0.10838f
C568 a_15964_194# a_16851_214# 0.16757f
C569 VDD a_14311_913# 0.28336f
C570 a_10328_949# a_10404_913# 0.01176f
C571 DELAY_OUT_TAP8 DELAY_OUT_TAP9 0.06596f
C572 a_13470_949# a_15831_913# 0.26208f
C573 VDD a_14235_949# 0.15389f
C574 DELAY_OUT_TAP4 a_7288_949# 0.10864f
C575 a_10430_949# a_5731_194# 0.41176f
C576 VDD DELAY_OUT_TAP8 0.1474f
C577 a_7390_949# a_8884_913# 0.28279f
R0 VSS.n31 VSS.n7 3663.98
R1 VSS.t213 VSS.n7 68.6481
R2 VSS.t24 VSS.n7 22.5629
R3 VSS.n1 VSS.t336 28.4523
R4 VSS.n71 VSS.t330 15.5226
R5 VSS.t173 VSS.n5 52.2182
R6 VSS.n7 VSS.t278 58.1721
R7 VSS.t248 VSS.n7 58.1721
R8 VSS.t233 VSS.n7 58.1721
R9 VSS.t218 VSS.n7 58.1721
R10 VSS.t203 VSS.n7 58.1721
R11 VSS.t331 VSS.n40 499.695
R12 VSS.n7 VSS.t23 58.0914
R13 VSS.t184 VSS.n15 15.3031
R14 VSS.t198 VSS.n7 68.6471
R15 VSS.t228 VSS.n7 68.6471
R16 VSS.t243 VSS.n7 68.6471
R17 VSS.t258 VSS.n7 68.6471
R18 VSS.t273 VSS.n7 68.6471
R19 VSS.n63 VSS.t332 267.416
R20 VSS.n34 VSS.n30 0.552982
R21 VSS.n114 VSS.t91 436.62
R22 VSS.n33 VSS.t185 430.062
R23 VSS.n44 VSS.t140 68.5978
R24 VSS.n42 VSS.n30 0.382621
R25 VSS.n41 VSS.n30 0.382621
R26 VSS.n45 VSS.n30 0.382621
R27 VSS.n39 VSS.n30 0.382621
R28 VSS.t312 VSS.n11 68.5978
R29 VSS.t347 VSS.n38 68.5978
R30 VSS.t310 VSS.n12 68.5978
R31 VSS.t16 VSS.n36 68.5978
R32 VSS.n64 VSS.t93 417.714
R33 VSS.t328 VSS.n7 116.822
R34 VSS.t206 VSS.n7 116.828
R35 VSS.t221 VSS.n7 116.828
R36 VSS.t236 VSS.n7 116.828
R37 VSS.t266 VSS.n7 116.828
R38 VSS.n7 VSS.t281 116.828
R39 VSS.n30 VSS.n61 0.481029
R40 VSS.t296 VSS.n66 231.506
R41 VSS.n77 VSS.t100 404.05
R42 VSS.t289 VSS.n202 375
R43 VSS.n7 VSS.t196 122.412
R44 VSS.n7 VSS.t211 122.412
R45 VSS.n7 VSS.t226 122.412
R46 VSS.n7 VSS.t241 122.412
R47 VSS.n7 VSS.t256 122.412
R48 VSS.n7 VSS.t271 122.412
R49 VSS.t335 VSS.n107 366.197
R50 VSS.t208 VSS.n7 127.3
R51 VSS.t223 VSS.n7 127.3
R52 VSS.n7 VSS.t238 127.3
R53 VSS.t253 VSS.n7 127.3
R54 VSS.n7 VSS.t268 127.3
R55 VSS.n28 VSS.t181 98.6395
R56 VSS.n27 VSS.t180 98.6395
R57 VSS.n26 VSS.t283 98.6395
R58 VSS.n25 VSS.t317 98.6395
R59 VSS.n24 VSS.t293 98.6395
R60 VSS.n30 VSS.n74 0.423468
R61 VSS.n30 VSS.n69 0.423468
R62 VSS.n22 VSS.t321 98.6395
R63 VSS.n30 VSS.n67 0.423468
R64 VSS.n30 VSS.n75 0.423468
R65 VSS.n21 VSS.t349 98.6395
R66 VSS.n20 VSS.t14 98.6395
R67 VSS.n30 VSS.n62 0.423468
R68 VSS.n19 VSS.t316 98.6395
R69 VSS.n30 VSS.n68 0.423468
R70 VSS.n16 VSS.t21 98.6395
R71 VSS.n7 VSS.t94 133.32
R72 VSS.t161 VSS.n7 140.653
R73 VSS.t130 VSS.n7 133.32
R74 VSS.n7 VSS.t167 140.651
R75 VSS.n7 VSS.t98 140.651
R76 VSS.t157 VSS.n7 133.319
R77 VSS.t153 VSS.n7 133.32
R78 VSS.t163 VSS.n7 133.32
R79 VSS.t105 VSS.n107 352.113
R80 VSS.t291 VSS.n65 359.983
R81 VSS.n30 VSS.t59 101.647
R82 VSS.n30 VSS.t53 101.647
R83 VSS.n30 VSS.t114 101.647
R84 VSS.n30 VSS.t27 101.647
R85 VSS.n30 VSS.t19 101.647
R86 VSS.n30 VSS.t125 101.647
R87 VSS.n30 VSS.t50 101.647
R88 VSS.n30 VSS.t108 101.647
R89 VSS.n30 VSS.t34 101.647
R90 VSS.n30 VSS.t47 101.647
R91 VSS.t136 VSS.n46 348.303
R92 VSS.t309 VSS.n47 348.303
R93 VSS.t146 VSS.n59 348.303
R94 VSS.t151 VSS.n49 348.303
R95 VSS.t133 VSS.n51 348.303
R96 VSS.t135 VSS.n54 348.303
R97 VSS.t355 VSS.n53 348.303
R98 VSS.t156 VSS.n32 348.303
R99 VSS.n30 VSS.t12 108.561
R100 VSS.n46 VSS.n30 6.82258
R101 VSS.n47 VSS.n30 6.82258
R102 VSS.t8 VSS.n48 111.644
R103 VSS.n30 VSS.t345 108.561
R104 VSS.n49 VSS.n30 6.82258
R105 VSS.t39 VSS.n50 111.644
R106 VSS.n51 VSS.n30 6.82258
R107 VSS.n30 VSS.t85 108.561
R108 VSS.n30 VSS.t339 108.561
R109 VSS.n30 VSS.t62 108.561
R110 VSS.n30 VSS.t117 108.561
R111 VSS.n30 VSS.t65 108.561
R112 VSS.t110 VSS.n52 111.644
R113 VSS.n30 VSS.t77 108.561
R114 VSS.n40 VSS.t45 129.317
R115 VSS.n77 VSS.t102 129.738
R116 VSS.t169 VSS.n70 404.05
R117 VSS.n203 VSS.t285 314.517
R118 VSS.n7 VSS.t158 140.653
R119 VSS.n7 VSS.t131 140.651
R120 VSS.t95 VSS.n7 140.651
R121 VSS.n7 VSS.t164 140.651
R122 VSS.n7 VSS.t154 140.651
R123 VSS.n72 VSS.t74 131.472
R124 VSS.n64 VSS.t44 131.77
R125 VSS.n203 VSS.t295 302.42
R126 VSS.t42 VSS.n7 141.702
R127 VSS.t191 VSS.n33 110.901
R128 VSS.n114 VSS.t332 281.69
R129 VSS.n73 VSS.t142 348.303
R130 VSS.n60 VSS.t138 348.303
R131 VSS.t323 VSS.n46 111.644
R132 VSS.t79 VSS.n47 111.644
R133 VSS.n48 VSS.t322 348.303
R134 VSS.t344 VSS.n59 111.644
R135 VSS.t341 VSS.n49 111.644
R136 VSS.n50 VSS.t89 348.303
R137 VSS.t306 VSS.n51 111.644
R138 VSS.n58 VSS.t149 348.303
R139 VSS.n57 VSS.t87 348.303
R140 VSS.n56 VSS.t119 348.303
R141 VSS.n55 VSS.t148 348.303
R142 VSS.t64 VSS.n54 111.644
R143 VSS.n52 VSS.t6 348.303
R144 VSS.t76 VSS.n53 111.644
R145 VSS.t121 VSS.n32 111.639
R146 VSS.n7 VSS.t201 141.964
R147 VSS.n7 VSS.t216 141.964
R148 VSS.n7 VSS.t231 141.964
R149 VSS.n7 VSS.t246 141.964
R150 VSS.n7 VSS.t261 141.964
R151 VSS.n7 VSS.t276 141.964
R152 VSS.n30 VSS.n31 0.147224
R153 VSS.t351 VSS.n35 112.787
R154 VSS.n65 VSS.t190 113.322
R155 VSS.n30 VSS.t188 122.754
R156 VSS.t296 VSS.n202 241.935
R157 VSS.n64 VSS.n7 7.23036
R158 VSS.n72 VSS.t72 486.031
R159 VSS.n7 VSS.t82 137.776
R160 VSS.t171 VSS.n70 129.738
R161 VSS.n77 VSS.n7 6.80937
R162 VSS.n7 VSS.t97 133.32
R163 VSS.n7 VSS.t166 133.32
R164 VSS.t160 VSS.n7 133.319
R165 VSS.n65 VSS.n30 7.23977
R166 VSS.t350 VSS.n35 418.382
R167 VSS.n73 VSS.t144 111.647
R168 VSS.n30 VSS.n32 6.82228
R169 VSS.n7 VSS.t193 127.299
R170 VSS.n71 VSS.t105 199.099
R171 VSS.n7 VSS.t251 116.828
R172 VSS.t324 VSS.n30 108.561
R173 VSS.t80 VSS.n30 108.561
R174 VSS.t9 VSS.n30 108.561
R175 VSS.t342 VSS.n30 108.561
R176 VSS.t40 VSS.n30 108.561
R177 VSS.t307 VSS.n30 108.561
R178 VSS.t111 VSS.n30 108.561
R179 VSS.t122 VSS.n31 109.016
R180 VSS.t285 VSS.n34 161.025
R181 VSS.t100 VSS.n0 156.831
R182 VSS.t169 VSS.n5 156.883
R183 VSS.n30 VSS.t182 101.656
R184 VSS.n30 VSS.n44 0.382621
R185 VSS.n30 VSS.n43 0.382621
R186 VSS.n42 VSS.t113 83.4525
R187 VSS.n41 VSS.t26 83.4525
R188 VSS.t68 VSS.n30 101.647
R189 VSS.n39 VSS.t18 83.4525
R190 VSS.t1 VSS.n30 101.647
R191 VSS.t128 VSS.n30 101.647
R192 VSS.n30 VSS.n38 0.382621
R193 VSS.n30 VSS.n37 0.382621
R194 VSS.t56 VSS.n30 101.647
R195 VSS.t4 VSS.n30 101.647
R196 VSS.t37 VSS.n30 101.647
R197 VSS.n30 VSS.n36 0.382621
R198 VSS.n18 VSS.t33 83.4525
R199 VSS.n17 VSS.t46 83.4525
R200 VSS.t93 VSS.n3 142.746
R201 VSS.n29 VSS.t142 136.798
R202 VSS.n28 VSS.t138 136.962
R203 VSS.n27 VSS.t136 136.962
R204 VSS.n26 VSS.t309 136.962
R205 VSS.n25 VSS.t322 136.962
R206 VSS.n24 VSS.t146 136.962
R207 VSS.t192 VSS.n74 98.6395
R208 VSS.t319 VSS.n69 98.6395
R209 VSS.n22 VSS.t133 136.962
R210 VSS.t301 VSS.n67 98.6395
R211 VSS.t320 VSS.n75 98.6395
R212 VSS.n21 VSS.t119 136.962
R213 VSS.n20 VSS.t148 136.962
R214 VSS.t31 VSS.n62 98.6395
R215 VSS.n19 VSS.t6 136.962
R216 VSS.t70 VSS.n68 98.6395
R217 VSS.n16 VSS.t156 136.962
R218 VSS.n14 VSS.t291 124.701
R219 VSS.t91 VSS.n2 114.668
R220 VSS.t294 VSS.n61 72.4354
R221 VSS.n63 VSS.t333 71.035
R222 VSS.n44 VSS.t58 83.4525
R223 VSS.n43 VSS.t176 68.5978
R224 VSS.n42 VSS.t178 68.5978
R225 VSS.n41 VSS.t304 68.5978
R226 VSS.n45 VSS.t302 68.5978
R227 VSS.n39 VSS.t186 68.5978
R228 VSS.n23 VSS.t353 68.5978
R229 VSS.t127 VSS.n11 83.4525
R230 VSS.t124 VSS.n38 83.4525
R231 VSS.n37 VSS.t299 68.5978
R232 VSS.t55 VSS.n12 83.4525
R233 VSS.n10 VSS.t29 68.5978
R234 VSS.n13 VSS.t326 68.5978
R235 VSS.t107 VSS.n36 83.4525
R236 VSS.n18 VSS.t314 68.5978
R237 VSS.n17 VSS.t174 68.5978
R238 VSS.t297 VSS.n66 62.2552
R239 VSS.n3 VSS.t72 72.3236
R240 VSS.n7 VSS.t263 58.1721
R241 VSS.t350 VSS.n14 64.2173
R242 VSS.n0 VSS.t331 58.2391
R243 VSS.t185 VSS.n29 52.1205
R244 VSS.n1 VSS.t335 185.028
R245 VSS.n34 VSS.t287 26.3107
R246 VSS.t356 VSS.n7 22.4812
R247 VSS.n115 VSS.t92 17.3368
R248 VSS.n118 VSS.t73 17.3368
R249 VSS.n108 VSS.t106 17.3368
R250 VSS.n122 VSS.t101 17.3368
R251 VSS.n220 VSS.t143 17.3368
R252 VSS.n216 VSS.t286 17.3368
R253 VSS.n212 VSS.t292 17.3368
R254 VSS.n208 VSS.t290 17.3368
R255 VSS.n160 VSS.t170 17.2607
R256 VSS.n126 VSS.t194 17.2313
R257 VSS.n406 VSS.t200 17.2313
R258 VSS.n133 VSS.t205 17.2313
R259 VSS.n399 VSS.t210 17.2313
R260 VSS.n394 VSS.t215 17.2313
R261 VSS.n84 VSS.t220 17.2313
R262 VSS.n387 VSS.t225 17.2313
R263 VSS.n382 VSS.t230 17.2313
R264 VSS.n153 VSS.t235 17.2313
R265 VSS.n168 VSS.t240 17.2313
R266 VSS.n375 VSS.t245 17.2313
R267 VSS.n93 VSS.t250 17.2313
R268 VSS.n368 VSS.t255 17.2313
R269 VSS.n363 VSS.t260 17.2313
R270 VSS.n183 VSS.t265 17.2313
R271 VSS.n192 VSS.t270 17.2313
R272 VSS.n356 VSS.t275 17.2313
R273 VSS.n102 VSS.t280 17.2313
R274 VSS.n7 VSS.n40 9.75628
R275 VSS.n7 VSS.n107 17.0005
R276 VSS.n7 VSS.n72 9.33546
R277 VSS.n7 VSS.n63 2.59912
R278 VSS.n7 VSS.n114 17.0005
R279 VSS.n411 VSS.n7 17.0005
R280 VSS.n409 VSS.t195 17.0005
R281 VSS.n7 VSS.n100 5.65652
R282 VSS.n7 VSS.n96 5.65652
R283 VSS.n7 VSS.n91 5.65652
R284 VSS.n7 VSS.n70 6.8094
R285 VSS.n7 VSS.n87 5.65652
R286 VSS.n7 VSS.n82 5.65652
R287 VSS.n7 VSS.n78 5.65652
R288 VSS.n128 VSS.t197 17.0005
R289 VSS.n407 VSS.t199 17.0005
R290 VSS.n130 VSS.t202 17.0005
R291 VSS.n131 VSS.t204 17.0005
R292 VSS.n135 VSS.t207 17.0005
R293 VSS.n400 VSS.t209 17.0005
R294 VSS.n139 VSS.t212 17.0005
R295 VSS.n395 VSS.t214 17.0005
R296 VSS.n140 VSS.t217 17.0005
R297 VSS.n141 VSS.t219 17.0005
R298 VSS.n144 VSS.t222 17.0005
R299 VSS.n388 VSS.t224 17.0005
R300 VSS.n148 VSS.t227 17.0005
R301 VSS.n383 VSS.t229 17.0005
R302 VSS.n149 VSS.t232 17.0005
R303 VSS.n150 VSS.t234 17.0005
R304 VSS.n155 VSS.t237 17.0005
R305 VSS.n166 VSS.t239 17.0005
R306 VSS.n169 VSS.t242 17.0005
R307 VSS.n376 VSS.t244 17.0005
R308 VSS.n171 VSS.t247 17.0005
R309 VSS.n172 VSS.t249 17.0005
R310 VSS.n175 VSS.t252 17.0005
R311 VSS.n369 VSS.t254 17.0005
R312 VSS.n179 VSS.t257 17.0005
R313 VSS.n364 VSS.t259 17.0005
R314 VSS.n180 VSS.t262 17.0005
R315 VSS.n181 VSS.t264 17.0005
R316 VSS.n185 VSS.t267 17.0005
R317 VSS.n190 VSS.t269 17.0005
R318 VSS.n193 VSS.t272 17.0005
R319 VSS.n357 VSS.t274 17.0005
R320 VSS.n195 VSS.t277 17.0005
R321 VSS.n196 VSS.t279 17.0005
R322 VSS.n198 VSS.t282 17.0005
R323 VSS.n30 VSS.n76 17.0005
R324 VSS.n30 VSS.n202 17.0005
R325 VSS.n30 VSS.n66 2.65215
R326 VSS.n30 VSS.n35 9.3247
R327 VSS.n30 VSS.n203 17.0005
R328 VSS.n30 VSS.n33 9.74178
R329 VSS.n30 VSS.n73 6.82269
R330 VSS.n30 VSS.n60 6.82258
R331 VSS.n30 VSS.n48 6.82258
R332 VSS.n30 VSS.n50 6.82258
R333 VSS.n30 VSS.n58 6.82258
R334 VSS.n30 VSS.n57 6.82258
R335 VSS.n30 VSS.n56 6.82258
R336 VSS.n30 VSS.n55 6.82258
R337 VSS.n30 VSS.n52 6.82258
R338 VSS.n71 VSS.n7 0.494014
R339 VSS.t295 VSS.n15 173.107
R340 VSS.n128 VSS.t391 15.3099
R341 VSS.n130 VSS.t389 15.3099
R342 VSS.n135 VSS.t387 15.3099
R343 VSS.n139 VSS.t385 15.3099
R344 VSS.n140 VSS.t383 15.3099
R345 VSS.n144 VSS.t381 15.3099
R346 VSS.n148 VSS.t379 15.3099
R347 VSS.n149 VSS.t377 15.3099
R348 VSS.n155 VSS.t375 15.3099
R349 VSS.n169 VSS.t373 15.3099
R350 VSS.n171 VSS.t371 15.3099
R351 VSS.n175 VSS.t369 15.3099
R352 VSS.n179 VSS.t367 15.3099
R353 VSS.n180 VSS.t365 15.3099
R354 VSS.n185 VSS.t363 15.3099
R355 VSS.n193 VSS.t361 15.3099
R356 VSS.n195 VSS.t359 15.3099
R357 VSS.n198 VSS.t357 15.3099
R358 VSS.n409 VSS.t392 15.2696
R359 VSS.n407 VSS.t390 15.2696
R360 VSS.n131 VSS.t388 15.2696
R361 VSS.n400 VSS.t386 15.2696
R362 VSS.n395 VSS.t384 15.2696
R363 VSS.n141 VSS.t382 15.2696
R364 VSS.n388 VSS.t380 15.2696
R365 VSS.n383 VSS.t378 15.2696
R366 VSS.n150 VSS.t376 15.2696
R367 VSS.n166 VSS.t374 15.2696
R368 VSS.n376 VSS.t372 15.2696
R369 VSS.n172 VSS.t370 15.2696
R370 VSS.n369 VSS.t368 15.2696
R371 VSS.n364 VSS.t366 15.2696
R372 VSS.n181 VSS.t364 15.2696
R373 VSS.n190 VSS.t362 15.2696
R374 VSS.n357 VSS.t360 15.2696
R375 VSS.n196 VSS.t358 15.2696
R376 VSS.n222 VSS.t145 8.80385
R377 VSS.n218 VSS.t288 8.80385
R378 VSS.n214 VSS.t352 8.80385
R379 VSS.n210 VSS.t298 8.80385
R380 VSS.n116 VSS.t334 8.80285
R381 VSS.n119 VSS.t75 8.80285
R382 VSS.n121 VSS.t337 8.80285
R383 VSS.n124 VSS.t103 8.80285
R384 VSS.n350 VSS.t123 8.77423
R385 VSS.n348 VSS.t22 8.77423
R386 VSS.n346 VSS.t48 8.77423
R387 VSS.n344 VSS.t175 8.77423
R388 VSS.n342 VSS.t78 8.77423
R389 VSS.n340 VSS.t71 8.77423
R390 VSS.n338 VSS.t35 8.77423
R391 VSS.n336 VSS.t315 8.77423
R392 VSS.n334 VSS.t112 8.77423
R393 VSS.n332 VSS.t7 8.77423
R394 VSS.n330 VSS.t109 8.77423
R395 VSS.n328 VSS.t17 8.77423
R396 VSS.n326 VSS.t66 8.77423
R397 VSS.n324 VSS.t32 8.77423
R398 VSS.n322 VSS.t38 8.77423
R399 VSS.n320 VSS.t327 8.77423
R400 VSS.n318 VSS.t118 8.77423
R401 VSS.n316 VSS.t15 8.77423
R402 VSS.n314 VSS.t5 8.77423
R403 VSS.n312 VSS.t30 8.77423
R404 VSS.n310 VSS.t63 8.77423
R405 VSS.n308 VSS.t120 8.77423
R406 VSS.n306 VSS.t57 8.77423
R407 VSS.n304 VSS.t311 8.77423
R408 VSS.n302 VSS.t340 8.77423
R409 VSS.n300 VSS.t88 8.77423
R410 VSS.n298 VSS.t51 8.77423
R411 VSS.n296 VSS.t300 8.77423
R412 VSS.n294 VSS.t86 8.77423
R413 VSS.n292 VSS.t150 8.77423
R414 VSS.n290 VSS.t126 8.77423
R415 VSS.n288 VSS.t348 8.77423
R416 VSS.n286 VSS.t308 8.77423
R417 VSS.n284 VSS.t134 8.77423
R418 VSS.n282 VSS.t129 8.77423
R419 VSS.n280 VSS.t313 8.77423
R420 VSS.n278 VSS.t41 8.77423
R421 VSS.n276 VSS.t90 8.77423
R422 VSS.n274 VSS.t2 8.77423
R423 VSS.n272 VSS.t354 8.77423
R424 VSS.n270 VSS.t343 8.77423
R425 VSS.n268 VSS.t152 8.77423
R426 VSS.n266 VSS.t20 8.77423
R427 VSS.n264 VSS.t187 8.77423
R428 VSS.n262 VSS.t346 8.77423
R429 VSS.n260 VSS.t147 8.77423
R430 VSS.n258 VSS.t69 8.77423
R431 VSS.n256 VSS.t303 8.77423
R432 VSS.n254 VSS.t10 8.77423
R433 VSS.n252 VSS.t318 8.77423
R434 VSS.n250 VSS.t28 8.77423
R435 VSS.n248 VSS.t305 8.77423
R436 VSS.n246 VSS.t81 8.77423
R437 VSS.n244 VSS.t284 8.77423
R438 VSS.n242 VSS.t115 8.77423
R439 VSS.n240 VSS.t179 8.77423
R440 VSS.n238 VSS.t325 8.77423
R441 VSS.n236 VSS.t137 8.77423
R442 VSS.n234 VSS.t54 8.77423
R443 VSS.n232 VSS.t177 8.77423
R444 VSS.n230 VSS.t13 8.77423
R445 VSS.n228 VSS.t139 8.77423
R446 VSS.n226 VSS.t60 8.77423
R447 VSS.n224 VSS.t141 8.77423
R448 VSS.n9 VSS.t96 8.82841
R449 VSS.n137 VSS.t165 8.77323
R450 VSS.n146 VSS.t155 8.77323
R451 VSS.n158 VSS.t159 8.77323
R452 VSS.n159 VSS.t25 8.77323
R453 VSS.n163 VSS.t99 8.77323
R454 VSS.n177 VSS.t168 8.77323
R455 VSS.n187 VSS.t132 8.77323
R456 VSS.n201 VSS.t162 8.77323
R457 VSS.n8 VSS.t83 8.79211
R458 VSS.n162 VSS.t172 8.76678
R459 VSS.n206 VSS.t183 8.75731
R460 VSS.n204 VSS.t189 8.75731
R461 VSS.n104 VSS.t43 8.75631
R462 VSS.n112 VSS.t329 8.75631
R463 VSS.n352 VSS.n103 0.0435295
R464 VSS.n101 VSS.n358 0.0534319
R465 VSS.n194 VSS.n100 0.0180497
R466 VSS.n191 VSS.n99 0.0633111
R467 VSS.n98 VSS.n7 4.22409
R468 VSS.n97 VSS.n365 0.0534319
R469 VSS.n366 VSS.n96 0.0180497
R470 VSS.n95 VSS.n370 0.0633111
R471 VSS.n371 VSS.n94 0.0435295
R472 VSS.n92 VSS.n377 0.0534319
R473 VSS.n170 VSS.n91 0.0180497
R474 VSS.n167 VSS.n90 0.0633111
R475 VSS.n89 VSS.n7 4.22409
R476 VSS.n88 VSS.n384 0.0534319
R477 VSS.n385 VSS.n87 0.0180497
R478 VSS.n86 VSS.n389 0.0633111
R479 VSS.n390 VSS.n85 0.0435295
R480 VSS.n83 VSS.n396 0.0534319
R481 VSS.n397 VSS.n82 0.0180497
R482 VSS.n81 VSS.n401 0.0633111
R483 VSS.n80 VSS.n7 4.22409
R484 VSS.n79 VSS.n408 0.0534319
R485 VSS.n129 VSS.n78 0.0180497
R486 VSS.n353 VSS.n7 8.49319
R487 VSS.n360 VSS.n7 8.49319
R488 VSS.n372 VSS.n7 8.49319
R489 VSS.n379 VSS.n7 8.49319
R490 VSS.n391 VSS.n7 8.49319
R491 VSS.n403 VSS.n7 8.49319
R492 VSS.n7 VSS.n106 8.47732
R493 VSS.n7 VSS.n103 4.22409
R494 VSS.n101 VSS.n7 4.21914
R495 VSS.n7 VSS.n189 8.47732
R496 VSS.n7 VSS.n99 4.21421
R497 VSS.n98 VSS.n183 0.176279
R498 VSS.n97 VSS.n7 4.21914
R499 VSS.n367 VSS.n7 8.47732
R500 VSS.n95 VSS.n7 4.21421
R501 VSS.n7 VSS.n94 4.22409
R502 VSS.n92 VSS.n7 4.21914
R503 VSS.n7 VSS.n165 8.47732
R504 VSS.n7 VSS.n90 4.21421
R505 VSS.n89 VSS.n153 0.176279
R506 VSS.n88 VSS.n7 4.21914
R507 VSS.n386 VSS.n7 8.47732
R508 VSS.n86 VSS.n7 4.21421
R509 VSS.n7 VSS.n85 4.22409
R510 VSS.n83 VSS.n7 4.21914
R511 VSS.n398 VSS.n7 8.47732
R512 VSS.n81 VSS.n7 4.21421
R513 VSS.n80 VSS.n133 0.176279
R514 VSS.n79 VSS.n7 4.21914
R515 VSS.n7 VSS.n127 8.47732
R516 VSS.n217 VSS.n30 8.47732
R517 VSS.n351 VSS.n30 8.47732
R518 VSS.n7 VSS.n105 5.62581
R519 VSS.n7 VSS.n120 5.62581
R520 VSS.n7 VSS.n117 5.62581
R521 VSS.n7 VSS.n200 5.62581
R522 VSS.n355 VSS.n7 5.62581
R523 VSS.n7 VSS.n184 5.62581
R524 VSS.n362 VSS.n7 5.62581
R525 VSS.n7 VSS.n174 5.62581
R526 VSS.n374 VSS.n7 5.62581
R527 VSS.n7 VSS.n152 5.62581
R528 VSS.n7 VSS.n154 5.62581
R529 VSS.n381 VSS.n7 5.62581
R530 VSS.n7 VSS.n143 5.62581
R531 VSS.n393 VSS.n7 5.62581
R532 VSS.n7 VSS.n134 5.62581
R533 VSS.n405 VSS.n7 5.62581
R534 VSS.n209 VSS.n30 5.62581
R535 VSS.n213 VSS.n30 5.62581
R536 VSS.n221 VSS.n30 5.62581
R537 VSS.n231 VSS.n30 5.62581
R538 VSS.n239 VSS.n30 5.62581
R539 VSS.n247 VSS.n30 5.62581
R540 VSS.n255 VSS.n30 5.62581
R541 VSS.n263 VSS.n30 5.62581
R542 VSS.n271 VSS.n30 5.62581
R543 VSS.n279 VSS.n30 5.62581
R544 VSS.n287 VSS.n30 5.62581
R545 VSS.n295 VSS.n30 5.62581
R546 VSS.n303 VSS.n30 5.62581
R547 VSS.n311 VSS.n30 5.62581
R548 VSS.n319 VSS.n30 5.62581
R549 VSS.n327 VSS.n30 5.62581
R550 VSS.n335 VSS.n30 5.62581
R551 VSS.n343 VSS.n30 5.62581
R552 VSS.n7 VSS.n125 4.21408
R553 VSS.n7 VSS.n113 4.19244
R554 VSS.n205 VSS.n30 4.19244
R555 VSS.n223 VSS.n30 4.19244
R556 VSS.n6 VSS.n351 3.33613
R557 VSS.n7 VSS.n9 0.665344
R558 VSS.n7 VSS.n123 3.3265
R559 VSS.n7 VSS.n109 3.3265
R560 VSS.n7 VSS.n110 3.3265
R561 VSS.n7 VSS.n182 3.3265
R562 VSS.n7 VSS.n173 3.3265
R563 VSS.n7 VSS.n151 3.3265
R564 VSS.n7 VSS.n142 3.3265
R565 VSS.n7 VSS.n132 3.3265
R566 VSS.n211 VSS.n30 3.3265
R567 VSS.n215 VSS.n30 3.3265
R568 VSS.n219 VSS.n30 3.3265
R569 VSS.n225 VSS.n30 3.3265
R570 VSS.n233 VSS.n30 3.3265
R571 VSS.n241 VSS.n30 3.3265
R572 VSS.n249 VSS.n30 3.3265
R573 VSS.n257 VSS.n30 3.3265
R574 VSS.n265 VSS.n30 3.3265
R575 VSS.n273 VSS.n30 3.3265
R576 VSS.n281 VSS.n30 3.3265
R577 VSS.n289 VSS.n30 3.3265
R578 VSS.n297 VSS.n30 3.3265
R579 VSS.n305 VSS.n30 3.3265
R580 VSS.n313 VSS.n30 3.3265
R581 VSS.n321 VSS.n30 3.3265
R582 VSS.n329 VSS.n30 3.3265
R583 VSS.n337 VSS.n30 3.3265
R584 VSS.n345 VSS.n30 3.3265
R585 VSS.n7 VSS.n111 2.74446
R586 VSS.n207 VSS.n30 2.74446
R587 VSS.n227 VSS.n30 2.74446
R588 VSS.n229 VSS.n30 2.74446
R589 VSS.n235 VSS.n30 2.74446
R590 VSS.n237 VSS.n30 2.74446
R591 VSS.n243 VSS.n30 2.74446
R592 VSS.n245 VSS.n30 2.74446
R593 VSS.n251 VSS.n30 2.74446
R594 VSS.n253 VSS.n30 2.74446
R595 VSS.n259 VSS.n30 2.74446
R596 VSS.n261 VSS.n30 2.74446
R597 VSS.n267 VSS.n30 2.74446
R598 VSS.n269 VSS.n30 2.74446
R599 VSS.n275 VSS.n30 2.74446
R600 VSS.n277 VSS.n30 2.74446
R601 VSS.n283 VSS.n30 2.74446
R602 VSS.n285 VSS.n30 2.74446
R603 VSS.n291 VSS.n30 2.74446
R604 VSS.n293 VSS.n30 2.74446
R605 VSS.n299 VSS.n30 2.74446
R606 VSS.n301 VSS.n30 2.74446
R607 VSS.n307 VSS.n30 2.74446
R608 VSS.n309 VSS.n30 2.74446
R609 VSS.n315 VSS.n30 2.74446
R610 VSS.n317 VSS.n30 2.74446
R611 VSS.n323 VSS.n30 2.74446
R612 VSS.n325 VSS.n30 2.74446
R613 VSS.n331 VSS.n30 2.74446
R614 VSS.n333 VSS.n30 2.74446
R615 VSS.n339 VSS.n30 2.74446
R616 VSS.n341 VSS.n30 2.74446
R617 VSS.n347 VSS.n30 2.74446
R618 VSS.n349 VSS.n30 2.74446
R619 VSS.n7 VSS.n161 2.00687
R620 VSS.n7 VSS.n197 1.56144
R621 VSS.n7 VSS.n188 1.56144
R622 VSS.n7 VSS.n178 1.56144
R623 VSS.n7 VSS.n157 1.56144
R624 VSS.n7 VSS.n147 1.56144
R625 VSS.n7 VSS.n138 1.56144
R626 VSS.n7 VSS.n164 1.12565
R627 VSS.n7 VSS.n6 0.92982
R628 VSS.n8 VSS.n7 0.761893
R629 VSS.n7 VSS.n4 0.849178
R630 VSS.n4 VSS.n158 0.728316
R631 VSS.n159 VSS.n4 0.69965
R632 VSS.n6 VSS.n201 0.69304
R633 VSS.n164 VSS.n162 0.603496
R634 VSS.n61 VSS.t289 100.614
R635 VSS.n30 VSS.n14 0.586403
R636 VSS.n30 VSS.n15 0.567373
R637 VSS.n30 VSS.n29 0.586403
R638 VSS.n30 VSS.n28 0.423468
R639 VSS.n43 VSS.t52 83.4525
R640 VSS.n30 VSS.n27 0.423468
R641 VSS.n30 VSS.n26 0.423468
R642 VSS.n30 VSS.n25 0.423468
R643 VSS.n30 VSS.n24 0.423468
R644 VSS.n74 VSS.t151 136.962
R645 VSS.n30 VSS.n23 0.382621
R646 VSS.n69 VSS.t89 136.962
R647 VSS.n30 VSS.n22 0.423468
R648 VSS.n67 VSS.t149 136.962
R649 VSS.n37 VSS.t49 83.4525
R650 VSS.n75 VSS.t87 136.962
R651 VSS.n30 VSS.n21 0.423468
R652 VSS.n10 VSS.t3 83.4525
R653 VSS.n30 VSS.n20 0.423468
R654 VSS.n13 VSS.t36 83.4525
R655 VSS.n62 VSS.t135 136.962
R656 VSS.n30 VSS.n19 0.423468
R657 VSS.n30 VSS.n18 0.382621
R658 VSS.n68 VSS.t355 136.962
R659 VSS.n30 VSS.n17 0.382621
R660 VSS.n30 VSS.n16 0.423468
R661 VSS.n164 VSS.n163 0.540438
R662 VSS.n7 VSS.n0 0.50872
R663 VSS.n7 VSS.n1 0.481869
R664 VSS.n7 VSS.n3 0.50872
R665 VSS.n7 VSS.n5 0.456674
R666 VSS.n138 VSS.n137 0.413418
R667 VSS.n147 VSS.n146 0.413418
R668 VSS.n158 VSS.n157 0.413418
R669 VSS.n178 VSS.n177 0.413418
R670 VSS.n188 VSS.n187 0.413418
R671 VSS.n201 VSS.n197 0.413418
R672 VSS.n161 VSS.n160 0.380519
R673 VSS.n161 VSS.n159 0.359515
R674 VSS.n199 VSS.n197 0.340858
R675 VSS.n188 VSS.n186 0.340858
R676 VSS.n178 VSS.n176 0.340858
R677 VSS.n157 VSS.n156 0.340858
R678 VSS.n147 VSS.n145 0.340858
R679 VSS.n138 VSS.n136 0.340858
R680 VSS.n208 VSS.n207 0.318018
R681 VSS.n115 VSS.n111 0.316299
R682 VSS.n228 VSS.n227 0.284268
R683 VSS.n236 VSS.n235 0.284268
R684 VSS.n244 VSS.n243 0.284268
R685 VSS.n252 VSS.n251 0.284268
R686 VSS.n260 VSS.n259 0.284268
R687 VSS.n268 VSS.n267 0.284268
R688 VSS.n276 VSS.n275 0.284268
R689 VSS.n284 VSS.n283 0.284268
R690 VSS.n292 VSS.n291 0.284268
R691 VSS.n300 VSS.n299 0.284268
R692 VSS.n308 VSS.n307 0.284268
R693 VSS.n316 VSS.n315 0.284268
R694 VSS.n324 VSS.n323 0.284268
R695 VSS.n332 VSS.n331 0.284268
R696 VSS.n340 VSS.n339 0.284268
R697 VSS.n348 VSS.n347 0.284268
R698 VSS.n229 VSS.n228 0.282549
R699 VSS.n237 VSS.n236 0.282549
R700 VSS.n245 VSS.n244 0.282549
R701 VSS.n253 VSS.n252 0.282549
R702 VSS.n261 VSS.n260 0.282549
R703 VSS.n269 VSS.n268 0.282549
R704 VSS.n277 VSS.n276 0.282549
R705 VSS.n285 VSS.n284 0.282549
R706 VSS.n293 VSS.n292 0.282549
R707 VSS.n301 VSS.n300 0.282549
R708 VSS.n309 VSS.n308 0.282549
R709 VSS.n317 VSS.n316 0.282549
R710 VSS.n325 VSS.n324 0.282549
R711 VSS.n333 VSS.n332 0.282549
R712 VSS.n341 VSS.n340 0.282549
R713 VSS.n349 VSS.n348 0.282549
R714 VSS.n226 VSS.n225 0.280477
R715 VSS.n234 VSS.n233 0.280477
R716 VSS.n242 VSS.n241 0.280477
R717 VSS.n250 VSS.n249 0.280477
R718 VSS.n258 VSS.n257 0.280477
R719 VSS.n266 VSS.n265 0.280477
R720 VSS.n274 VSS.n273 0.280477
R721 VSS.n282 VSS.n281 0.280477
R722 VSS.n290 VSS.n289 0.280477
R723 VSS.n298 VSS.n297 0.280477
R724 VSS.n306 VSS.n305 0.280477
R725 VSS.n314 VSS.n313 0.280477
R726 VSS.n322 VSS.n321 0.280477
R727 VSS.n330 VSS.n329 0.280477
R728 VSS.n338 VSS.n337 0.280477
R729 VSS.n346 VSS.n345 0.280477
R730 VSS.n112 VSS.n111 0.274268
R731 VSS.n119 VSS.n109 0.274227
R732 VSS.n410 VSS.n9 0.440892
R733 VSS.n137 VSS.n132 0.274227
R734 VSS.n146 VSS.n142 0.274227
R735 VSS.n163 VSS.n151 0.274227
R736 VSS.n177 VSS.n173 0.274227
R737 VSS.n187 VSS.n182 0.274227
R738 VSS.n215 VSS.n214 0.272997
R739 VSS.n207 VSS.n206 0.272549
R740 VSS.n230 VSS.n229 0.270518
R741 VSS.n238 VSS.n237 0.270518
R742 VSS.n246 VSS.n245 0.270518
R743 VSS.n254 VSS.n253 0.270518
R744 VSS.n262 VSS.n261 0.270518
R745 VSS.n270 VSS.n269 0.270518
R746 VSS.n278 VSS.n277 0.270518
R747 VSS.n286 VSS.n285 0.270518
R748 VSS.n294 VSS.n293 0.270518
R749 VSS.n302 VSS.n301 0.270518
R750 VSS.n310 VSS.n309 0.270518
R751 VSS.n318 VSS.n317 0.270518
R752 VSS.n326 VSS.n325 0.270518
R753 VSS.n334 VSS.n333 0.270518
R754 VSS.n342 VSS.n341 0.270518
R755 VSS.n350 VSS.n349 0.270518
R756 VSS.n225 VSS.n224 0.266747
R757 VSS.n233 VSS.n232 0.266747
R758 VSS.n241 VSS.n240 0.266747
R759 VSS.n249 VSS.n248 0.266747
R760 VSS.n257 VSS.n256 0.266747
R761 VSS.n265 VSS.n264 0.266747
R762 VSS.n273 VSS.n272 0.266747
R763 VSS.n281 VSS.n280 0.266747
R764 VSS.n289 VSS.n288 0.266747
R765 VSS.n297 VSS.n296 0.266747
R766 VSS.n305 VSS.n304 0.266747
R767 VSS.n313 VSS.n312 0.266747
R768 VSS.n321 VSS.n320 0.266747
R769 VSS.n329 VSS.n328 0.266747
R770 VSS.n337 VSS.n336 0.266747
R771 VSS.n345 VSS.n344 0.266747
R772 VSS.n220 VSS.n219 0.246727
R773 VSS.n123 VSS.n122 0.245497
R774 VSS.n227 VSS.n226 0.240049
R775 VSS.n235 VSS.n234 0.240049
R776 VSS.n243 VSS.n242 0.240049
R777 VSS.n251 VSS.n250 0.240049
R778 VSS.n259 VSS.n258 0.240049
R779 VSS.n267 VSS.n266 0.240049
R780 VSS.n275 VSS.n274 0.240049
R781 VSS.n283 VSS.n282 0.240049
R782 VSS.n291 VSS.n290 0.240049
R783 VSS.n299 VSS.n298 0.240049
R784 VSS.n307 VSS.n306 0.240049
R785 VSS.n315 VSS.n314 0.240049
R786 VSS.n323 VSS.n322 0.240049
R787 VSS.n331 VSS.n330 0.240049
R788 VSS.n339 VSS.n338 0.240049
R789 VSS.n347 VSS.n346 0.240049
R790 VSS.n401 VSS.n132 0.237997
R791 VSS.n389 VSS.n142 0.237997
R792 VSS.n167 VSS.n151 0.237997
R793 VSS.n370 VSS.n173 0.237997
R794 VSS.n191 VSS.n182 0.237997
R795 VSS.n116 VSS.n110 0.234227
R796 VSS.n211 VSS.n210 0.232997
R797 VSS.n212 VSS.n211 0.231727
R798 VSS.n118 VSS.n110 0.230497
R799 VSS.n123 VSS.n121 0.219227
R800 VSS.n219 VSS.n218 0.217997
R801 VSS.n223 VSS.n222 0.211543
R802 VSS.n206 VSS.n205 0.201058
R803 VSS.n113 VSS.n112 0.200293
R804 VSS.n216 VSS.n215 0.191727
R805 VSS.n109 VSS.n108 0.190497
R806 VSS.n8 VSS.n124 0.318488
R807 VSS.n113 VSS.n104 0.161058
R808 VSS.n224 VSS.n223 0.161058
R809 VSS.n205 VSS.n204 0.160293
R810 VSS.n231 VSS.n230 0.15705
R811 VSS.n239 VSS.n238 0.15705
R812 VSS.n247 VSS.n246 0.15705
R813 VSS.n255 VSS.n254 0.15705
R814 VSS.n263 VSS.n262 0.15705
R815 VSS.n271 VSS.n270 0.15705
R816 VSS.n279 VSS.n278 0.15705
R817 VSS.n287 VSS.n286 0.15705
R818 VSS.n295 VSS.n294 0.15705
R819 VSS.n303 VSS.n302 0.15705
R820 VSS.n311 VSS.n310 0.15705
R821 VSS.n319 VSS.n318 0.15705
R822 VSS.n327 VSS.n326 0.15705
R823 VSS.n335 VSS.n334 0.15705
R824 VSS.n343 VSS.n342 0.15705
R825 VSS.n126 VSS.n125 0.156007
R826 VSS.n129 VSS.n128 0.155582
R827 VSS.n404 VSS.n130 0.155582
R828 VSS.n136 VSS.n135 0.155582
R829 VSS.n397 VSS.n139 0.155582
R830 VSS.n392 VSS.n140 0.155582
R831 VSS.n145 VSS.n144 0.155582
R832 VSS.n385 VSS.n148 0.155582
R833 VSS.n380 VSS.n149 0.155582
R834 VSS.n156 VSS.n155 0.155582
R835 VSS.n170 VSS.n169 0.155582
R836 VSS.n373 VSS.n171 0.155582
R837 VSS.n176 VSS.n175 0.155582
R838 VSS.n366 VSS.n179 0.155582
R839 VSS.n361 VSS.n180 0.155582
R840 VSS.n186 VSS.n185 0.155582
R841 VSS.n194 VSS.n193 0.155582
R842 VSS.n354 VSS.n195 0.155582
R843 VSS.n199 VSS.n198 0.155582
R844 VSS.n120 VSS.n118 0.149888
R845 VSS.n213 VSS.n212 0.14955
R846 VSS.n410 VSS.n409 0.149476
R847 VSS.n408 VSS.n407 0.149476
R848 VSS.n402 VSS.n131 0.149476
R849 VSS.n401 VSS.n400 0.149476
R850 VSS.n396 VSS.n395 0.149476
R851 VSS.n390 VSS.n141 0.149476
R852 VSS.n389 VSS.n388 0.149476
R853 VSS.n384 VSS.n383 0.149476
R854 VSS.n378 VSS.n150 0.149476
R855 VSS.n167 VSS.n166 0.149476
R856 VSS.n377 VSS.n376 0.149476
R857 VSS.n371 VSS.n172 0.149476
R858 VSS.n370 VSS.n369 0.149476
R859 VSS.n365 VSS.n364 0.149476
R860 VSS.n359 VSS.n181 0.149476
R861 VSS.n191 VSS.n190 0.149476
R862 VSS.n358 VSS.n357 0.149476
R863 VSS.n352 VSS.n196 0.149476
R864 VSS.n210 VSS.n209 0.147388
R865 VSS.n117 VSS.n116 0.14705
R866 VSS.n108 VSS.n106 0.142118
R867 VSS.n217 VSS.n216 0.142118
R868 VSS.n122 VSS.n105 0.134888
R869 VSS.n160 VSS.n152 0.134888
R870 VSS.n221 VSS.n220 0.13455
R871 VSS.n129 VSS.n127 0.129618
R872 VSS.n398 VSS.n397 0.129618
R873 VSS.n386 VSS.n385 0.129618
R874 VSS.n170 VSS.n165 0.129618
R875 VSS.n367 VSS.n366 0.129618
R876 VSS.n194 VSS.n189 0.129618
R877 VSS.n406 VSS.n405 0.126138
R878 VSS.n394 VSS.n393 0.126138
R879 VSS.n382 VSS.n381 0.126138
R880 VSS.n375 VSS.n374 0.126138
R881 VSS.n363 VSS.n362 0.126138
R882 VSS.n356 VSS.n355 0.126138
R883 VSS.n81 VSS.n399 0.156005
R884 VSS.n86 VSS.n387 0.156005
R885 VSS.n168 VSS.n90 0.156005
R886 VSS.n95 VSS.n368 0.156005
R887 VSS.n192 VSS.n99 0.156005
R888 VSS.n222 VSS.n221 0.122388
R889 VSS.n124 VSS.n105 0.12205
R890 VSS.n136 VSS.n134 0.12205
R891 VSS.n145 VSS.n143 0.12205
R892 VSS.n156 VSS.n154 0.12205
R893 VSS.n162 VSS.n152 0.12205
R894 VSS.n176 VSS.n174 0.12205
R895 VSS.n186 VSS.n184 0.12205
R896 VSS.n200 VSS.n199 0.12205
R897 VSS.n121 VSS.n106 0.114618
R898 VSS.n218 VSS.n217 0.114618
R899 VSS.n232 VSS.n231 0.113638
R900 VSS.n240 VSS.n239 0.113638
R901 VSS.n248 VSS.n247 0.113638
R902 VSS.n256 VSS.n255 0.113638
R903 VSS.n264 VSS.n263 0.113638
R904 VSS.n272 VSS.n271 0.113638
R905 VSS.n280 VSS.n279 0.113638
R906 VSS.n288 VSS.n287 0.113638
R907 VSS.n296 VSS.n295 0.113638
R908 VSS.n304 VSS.n303 0.113638
R909 VSS.n312 VSS.n311 0.113638
R910 VSS.n320 VSS.n319 0.113638
R911 VSS.n328 VSS.n327 0.113638
R912 VSS.n336 VSS.n335 0.113638
R913 VSS.n344 VSS.n343 0.113638
R914 VSS.n117 VSS.n115 0.109888
R915 VSS.n351 VSS.n350 0.109618
R916 VSS.n209 VSS.n208 0.10955
R917 VSS.n214 VSS.n213 0.107388
R918 VSS.n120 VSS.n119 0.10705
R919 VSS.n134 VSS.n133 0.106138
R920 VSS.n143 VSS.n84 0.106138
R921 VSS.n154 VSS.n153 0.106138
R922 VSS.n174 VSS.n93 0.106138
R923 VSS.n184 VSS.n183 0.106138
R924 VSS.n200 VSS.n102 0.106138
R925 VSS.n79 VSS.n406 0.166153
R926 VSS.n83 VSS.n394 0.166153
R927 VSS.n88 VSS.n382 0.166153
R928 VSS.n92 VSS.n375 0.166153
R929 VSS.n97 VSS.n363 0.166153
R930 VSS.n101 VSS.n356 0.166153
R931 VSS.n403 VSS.n402 0.105361
R932 VSS.n391 VSS.n390 0.105361
R933 VSS.n379 VSS.n378 0.105361
R934 VSS.n372 VSS.n371 0.105361
R935 VSS.n360 VSS.n359 0.105361
R936 VSS.n353 VSS.n352 0.105361
R937 VSS.n405 VSS.n404 0.10205
R938 VSS.n393 VSS.n392 0.10205
R939 VSS.n381 VSS.n380 0.10205
R940 VSS.n374 VSS.n373 0.10205
R941 VSS.n362 VSS.n361 0.10205
R942 VSS.n355 VSS.n354 0.10205
R943 VSS.n127 VSS.n126 0.0983676
R944 VSS.n399 VSS.n398 0.0983676
R945 VSS.n387 VSS.n386 0.0983676
R946 VSS.n168 VSS.n165 0.0983676
R947 VSS.n368 VSS.n367 0.0983676
R948 VSS.n192 VSS.n189 0.0983676
R949 VSS.n402 VSS.n80 0.0435295
R950 VSS.n85 VSS.n84 0.176279
R951 VSS.n378 VSS.n89 0.0435295
R952 VSS.n94 VSS.n93 0.176279
R953 VSS.n359 VSS.n98 0.0435295
R954 VSS.n103 VSS.n102 0.176279
R955 VSS.n411 VSS.n104 0.078
R956 VSS.n204 VSS.n76 0.078
R957 VSS.n408 VSS.n78 0.103847
R958 VSS.n396 VSS.n82 0.103847
R959 VSS.n384 VSS.n87 0.103847
R960 VSS.n377 VSS.n91 0.103847
R961 VSS.n365 VSS.n96 0.103847
R962 VSS.n358 VSS.n100 0.103847
R963 VSS.n410 VSS.n125 0.0633093
R964 VSS VSS.n411 0.038
R965 VSS VSS.n76 0.038
R966 VSS.n60 VSS.t11 111.644
R967 VSS.n45 VSS.t67 83.4525
R968 VSS.n30 VSS.n59 6.82258
R969 VSS.n23 VSS.t0 83.4525
R970 VSS.n30 VSS.n11 0.382621
R971 VSS.n58 VSS.t84 111.644
R972 VSS.n57 VSS.t338 111.644
R973 VSS.n30 VSS.n12 0.382621
R974 VSS.n56 VSS.t61 111.644
R975 VSS.n30 VSS.n10 0.382621
R976 VSS.n55 VSS.t116 111.644
R977 VSS.n30 VSS.n13 0.382621
R978 VSS.n30 VSS.n54 6.82258
R979 VSS.n30 VSS.n53 6.82258
R980 VSS.n354 VSS.n353 0.0166107
R981 VSS.n361 VSS.n360 0.0166107
R982 VSS.n373 VSS.n372 0.0166107
R983 VSS.n380 VSS.n379 0.0166107
R984 VSS.n392 VSS.n391 0.0166107
R985 VSS.n404 VSS.n403 0.0166107
R986 VSS.n2 VSS.t104 82.6299
R987 VSS.n7 VSS.n2 1.27471
R988 a_3747_216.n0 a_3747_216.t2 52.0388
R989 a_3747_216.t0 a_3747_216.n0 35.4491
R990 a_3747_216.n0 a_3747_216.t3 33.5891
R991 a_3747_216.t1 a_3747_216.t0 5.61942
R992 a_3171_216.n0 a_3171_216.t2 51.8377
R993 a_3171_216.n0 a_3171_216.t3 33.3881
R994 a_3171_216.t0 a_3171_216.n0 31.8923
R995 a_3171_216.t1 a_3171_216.t0 5.61777
R996 a_2595_216.n0 a_2595_216.t2 51.6367
R997 a_2595_216.n0 a_2595_216.t3 33.187
R998 a_2595_216.t0 a_2595_216.n0 27.993
R999 a_2595_216.t1 a_2595_216.t0 5.73018
R1000 a_3747_952.n0 a_3747_952.t2 38.0081
R1001 a_3747_952.n0 a_3747_952.t3 33.3957
R1002 a_3747_952.n1 a_3747_952.t4 33.3957
R1003 a_3747_952.n2 a_3747_952.t5 33.3957
R1004 a_3747_952.n3 a_3747_952.t6 33.3957
R1005 a_3747_952.n4 a_3747_952.t7 33.3957
R1006 a_3747_952.n5 a_3747_952.t8 33.3957
R1007 a_3747_952.n6 a_3747_952.t9 33.3957
R1008 a_3747_952.t0 a_3747_952.n6 23.2419
R1009 a_3747_952.t1 a_3747_952.t0 5.61942
R1010 a_3747_952.n6 a_3747_952.n5 4.61291
R1011 a_3747_952.n5 a_3747_952.n4 4.61291
R1012 a_3747_952.n4 a_3747_952.n3 4.61291
R1013 a_3747_952.n3 a_3747_952.n2 4.61291
R1014 a_3747_952.n2 a_3747_952.n1 4.61291
R1015 a_3747_952.n1 a_3747_952.n0 4.61291
R1016 a_3171_952.n0 a_3171_952.t2 37.8054
R1017 a_3171_952.n0 a_3171_952.t3 33.193
R1018 a_3171_952.n1 a_3171_952.t4 33.193
R1019 a_3171_952.n2 a_3171_952.t5 33.193
R1020 a_3171_952.n3 a_3171_952.t6 33.193
R1021 a_3171_952.n4 a_3171_952.t7 33.193
R1022 a_3171_952.n5 a_3171_952.t8 33.193
R1023 a_3171_952.n6 a_3171_952.t9 33.193
R1024 a_3171_952.t0 a_3171_952.n6 23.0313
R1025 a_3171_952.t1 a_3171_952.t0 5.61777
R1026 a_3171_952.n6 a_3171_952.n5 4.61291
R1027 a_3171_952.n5 a_3171_952.n4 4.61291
R1028 a_3171_952.n4 a_3171_952.n3 4.61291
R1029 a_3171_952.n3 a_3171_952.n2 4.61291
R1030 a_3171_952.n2 a_3171_952.n1 4.61291
R1031 a_3171_952.n1 a_3171_952.n0 4.61291
R1032 a_2595_952.n0 a_2595_952.t2 37.7691
R1033 a_2595_952.n0 a_2595_952.t3 33.1567
R1034 a_2595_952.n1 a_2595_952.t4 33.1567
R1035 a_2595_952.n2 a_2595_952.t5 33.1567
R1036 a_2595_952.n3 a_2595_952.t6 33.1567
R1037 a_2595_952.n4 a_2595_952.t7 33.1567
R1038 a_2595_952.n5 a_2595_952.t8 33.1567
R1039 a_2595_952.n6 a_2595_952.t9 33.1567
R1040 a_2595_952.t0 a_2595_952.n6 22.7941
R1041 a_2595_952.t1 a_2595_952.t0 5.65522
R1042 a_2595_952.n6 a_2595_952.n5 4.61291
R1043 a_2595_952.n5 a_2595_952.n4 4.61291
R1044 a_2595_952.n4 a_2595_952.n3 4.61291
R1045 a_2595_952.n3 a_2595_952.n2 4.61291
R1046 a_2595_952.n2 a_2595_952.n1 4.61291
R1047 a_2595_952.n1 a_2595_952.n0 4.61291
R1048 a_2019_952.n0 a_2019_952.t2 37.9701
R1049 a_2019_952.n0 a_2019_952.t3 33.3577
R1050 a_2019_952.n1 a_2019_952.t4 33.3577
R1051 a_2019_952.n2 a_2019_952.t5 33.3577
R1052 a_2019_952.n3 a_2019_952.t6 33.3577
R1053 a_2019_952.n4 a_2019_952.t7 33.3577
R1054 a_2019_952.t0 a_2019_952.t9 22.5945
R1055 a_2019_952.t1 a_2019_952.t0 5.62052
R1056 a_2019_952.t9 a_2019_952.t8 4.61291
R1057 a_2019_952.t8 a_2019_952.n4 4.61291
R1058 a_2019_952.n4 a_2019_952.n3 4.61291
R1059 a_2019_952.n3 a_2019_952.n2 4.61291
R1060 a_2019_952.n2 a_2019_952.n1 4.61291
R1061 a_2019_952.n1 a_2019_952.n0 4.61291
C578 MUX_OUT VSS 3.24057f
C579 MUX_SEL4 VSS 1.63591f
C580 DELAY_OUT_TAP0 VSS 0.37425f
C581 MUX_SEL3 VSS 0.90686f
C582 MUX_SEL2 VSS 1.81137f
C583 DELAY_OUT_TAP31 VSS 0.41949f
C584 DELAY_OUT_TAP30 VSS 0.43238f
C585 DELAY_OUT_TAP29 VSS 0.30856f
C586 DELAY_OUT_TAP28 VSS 0.4381f
C587 DELAY_OUT_TAP27 VSS 0.38455f
C588 DELAY_OUT_TAP26 VSS 0.43238f
C589 DELAY_OUT_TAP25 VSS 0.30856f
C590 DELAY_OUT_TAP24 VSS 0.4381f
C591 DELAY_OUT_TAP23 VSS 0.38455f
C592 DELAY_OUT_TAP22 VSS 0.43238f
C593 DELAY_OUT_TAP21 VSS 0.30856f
C594 DELAY_OUT_TAP20 VSS 0.4381f
C595 DELAY_OUT_TAP19 VSS 0.38455f
C596 DELAY_OUT_TAP18 VSS 0.43238f
C597 DELAY_OUT_TAP17 VSS 0.30374f
C598 DELAY_OUT_TAP16 VSS 0.42869f
C599 DELAY_OUT_TAP15 VSS 0.38342f
C600 DELAY_OUT_TAP14 VSS 0.43238f
C601 DELAY_OUT_TAP13 VSS 0.30856f
C602 DELAY_OUT_TAP12 VSS 0.43643f
C603 DELAY_OUT_TAP11 VSS 0.38455f
C604 DELAY_OUT_TAP10 VSS 0.43238f
C605 DELAY_OUT_TAP9 VSS 0.30856f
C606 DELAY_OUT_TAP8 VSS 0.43643f
C607 DELAY_OUT_TAP7 VSS 0.38455f
C608 DELAY_OUT_TAP6 VSS 0.43238f
C609 DELAY_OUT_TAP5 VSS 0.30856f
C610 DELAY_OUT_TAP4 VSS 0.43585f
C611 DELAY_OUT_TAP3 VSS 0.38455f
C612 DELAY_OUT_TAP2 VSS 0.43238f
C613 DELAY_OUT_TAP1 VSS 0.30776f
C614 MUX_SEL1 VSS 0.9549f
C615 MUX_SEL0 VSS 1.81267f
C616 VDD VSS 26.9372f
C617 a_26985_424# VSS 0.18005f ; **FLOATING
C618 a_23945_424# VSS 0.18005f ; **FLOATING
C619 a_20905_424# VSS 0.18005f ; **FLOATING
C620 a_17865_424# VSS 0.1767f ; **FLOATING
C621 a_16851_214# VSS 0.38749f ; **FLOATING
C622 a_16108_194# VSS 3.87256f ; **FLOATING
C623 a_15964_194# VSS 0.18406f ; **FLOATING
C624 a_15765_368# VSS 0.36264f ; **FLOATING
C625 a_14825_424# VSS 0.18005f ; **FLOATING
C626 a_11785_424# VSS 0.18005f ; **FLOATING
C627 a_8745_424# VSS 0.18005f ; **FLOATING
C628 a_5731_194# VSS 3.39133f ; **FLOATING
C629 a_2019_216# VSS 1.616f ; **FLOATING
C630 a_5705_424# VSS 0.17716f ; **FLOATING
C631 a_3449_236# VSS 0.18478f ; **FLOATING
C632 a_2873_236# VSS 0.18321f ; **FLOATING
C633 a_2297_236# VSS 0.18321f ; **FLOATING
C634 a_1721_236# VSS 0.17001f ; **FLOATING
C635 a_1544_194# VSS 0.30014f ; **FLOATING
C636 a_1256_194# VSS 0.84266f ; **FLOATING
C637 a_27991_913# VSS 0.18706f ; **FLOATING
C638 a_27915_949# VSS 0.10926f ; **FLOATING
C639 a_27124_913# VSS 0.17878f ; **FLOATING
C640 a_27048_949# VSS 0.12122f ; **FLOATING
C641 a_26471_913# VSS 0.18175f ; **FLOATING
C642 a_26395_949# VSS 0.11073f ; **FLOATING
C643 a_25604_913# VSS 0.18087f ; **FLOATING
C644 a_25630_949# VSS 0.43187f ; **FLOATING
C645 a_25528_949# VSS 0.12433f ; **FLOATING
C646 a_24951_913# VSS 0.18335f ; **FLOATING
C647 a_24875_949# VSS 0.11016f ; **FLOATING
C648 a_24084_913# VSS 0.17878f ; **FLOATING
C649 a_24008_949# VSS 0.12122f ; **FLOATING
C650 a_23431_913# VSS 0.18175f ; **FLOATING
C651 a_23355_949# VSS 0.11073f ; **FLOATING
C652 a_22564_913# VSS 0.18087f ; **FLOATING
C653 a_22590_949# VSS 0.40111f ; **FLOATING
C654 a_22488_949# VSS 0.12433f ; **FLOATING
C655 a_21911_913# VSS 0.18335f ; **FLOATING
C656 a_21835_949# VSS 0.11016f ; **FLOATING
C657 a_21044_913# VSS 0.17878f ; **FLOATING
C658 a_20968_949# VSS 0.12122f ; **FLOATING
C659 a_20391_913# VSS 0.18175f ; **FLOATING
C660 a_20315_949# VSS 0.11073f ; **FLOATING
C661 a_19524_913# VSS 0.18087f ; **FLOATING
C662 a_19550_949# VSS 0.4036f ; **FLOATING
C663 a_19448_949# VSS 0.12433f ; **FLOATING
C664 a_18871_913# VSS 0.18335f ; **FLOATING
C665 a_18795_949# VSS 0.11016f ; **FLOATING
C666 a_18004_913# VSS 0.17878f ; **FLOATING
C667 a_17928_949# VSS 0.12122f ; **FLOATING
C668 a_17351_913# VSS 0.18022f ; **FLOATING
C669 a_17275_949# VSS 0.10926f ; **FLOATING
C670 a_16484_913# VSS 0.18023f ; **FLOATING
C671 a_16510_949# VSS 0.35732f ; **FLOATING
C672 a_16408_949# VSS 0.1229f ; **FLOATING
C673 a_15831_913# VSS 0.17846f ; **FLOATING
C674 a_15755_949# VSS 0.10926f ; **FLOATING
C675 a_14964_913# VSS 0.17878f ; **FLOATING
C676 a_14888_949# VSS 0.12122f ; **FLOATING
C677 a_14311_913# VSS 0.18175f ; **FLOATING
C678 a_14235_949# VSS 0.11073f ; **FLOATING
C679 a_13444_913# VSS 0.18087f ; **FLOATING
C680 a_13470_949# VSS 0.3713f ; **FLOATING
C681 a_13368_949# VSS 0.12433f ; **FLOATING
C682 a_12791_913# VSS 0.18335f ; **FLOATING
C683 a_12715_949# VSS 0.11016f ; **FLOATING
C684 a_11924_913# VSS 0.17878f ; **FLOATING
C685 a_11848_949# VSS 0.12122f ; **FLOATING
C686 a_11271_913# VSS 0.18175f ; **FLOATING
C687 a_11195_949# VSS 0.11073f ; **FLOATING
C688 a_10404_913# VSS 0.18087f ; **FLOATING
C689 a_10430_949# VSS 0.38462f ; **FLOATING
C690 a_10328_949# VSS 0.12433f ; **FLOATING
C691 a_9751_913# VSS 0.18335f ; **FLOATING
C692 a_9675_949# VSS 0.11016f ; **FLOATING
C693 a_8884_913# VSS 0.17878f ; **FLOATING
C694 a_8808_949# VSS 0.12122f ; **FLOATING
C695 a_8231_913# VSS 0.18175f ; **FLOATING
C696 a_8155_949# VSS 0.11073f ; **FLOATING
C697 a_7364_913# VSS 0.18087f ; **FLOATING
C698 a_7390_949# VSS 0.38153f ; **FLOATING
C699 a_7288_949# VSS 0.12433f ; **FLOATING
C700 a_6711_913# VSS 0.18335f ; **FLOATING
C701 a_6635_949# VSS 0.11016f ; **FLOATING
C702 a_5844_913# VSS 0.17878f ; **FLOATING
C703 a_5768_949# VSS 0.12122f ; **FLOATING
C704 a_5191_913# VSS 0.18022f ; **FLOATING
C705 a_5115_949# VSS 0.10926f ; **FLOATING
C706 a_4324_913# VSS 0.18023f ; **FLOATING
C707 a_4350_949# VSS 0.33452f ; **FLOATING
C708 a_4248_949# VSS 0.12443f ; **FLOATING
C709 a_27705_949# VSS 0.2535f ; **FLOATING
C710 a_26185_949# VSS 0.23529f ; **FLOATING
C711 a_24665_949# VSS 0.25486f ; **FLOATING
C712 a_23145_949# VSS 0.23529f ; **FLOATING
C713 a_21625_949# VSS 0.25486f ; **FLOATING
C714 a_20105_949# VSS 0.23529f ; **FLOATING
C715 a_18585_949# VSS 0.25486f ; **FLOATING
C716 a_17065_949# VSS 0.23439f ; **FLOATING
C717 a_15545_949# VSS 0.2535f ; **FLOATING
C718 a_14025_949# VSS 0.23529f ; **FLOATING
C719 a_12505_949# VSS 0.25486f ; **FLOATING
C720 a_10985_949# VSS 0.23529f ; **FLOATING
C721 a_9465_949# VSS 0.25486f ; **FLOATING
C722 a_7945_949# VSS 0.23529f ; **FLOATING
C723 a_6425_949# VSS 0.25486f ; **FLOATING
C724 a_4905_949# VSS 0.23602f ; **FLOATING
C725 a_4157_1218# VSS 0.3431f ; **FLOATING
C726 a_3449_1300# VSS 0.18603f ; **FLOATING
C727 a_2873_1300# VSS 0.18321f ; **FLOATING
C728 a_2297_1300# VSS 0.18321f ; **FLOATING
C729 a_1721_1300# VSS 0.17001f ; **FLOATING
C730 a_1544_949# VSS 0.29963f ; **FLOATING
C731 a_1256_949# VSS 0.83916f ; **FLOATING
C732 a_2019_952.t2 VSS 0.8244f ; **FLOATING
C733 a_2019_952.t3 VSS 0.62586f ; **FLOATING
C734 a_2019_952.n0 VSS 4.43882f ; **FLOATING
C735 a_2019_952.t4 VSS 0.62586f ; **FLOATING
C736 a_2019_952.n1 VSS 3.00299f ; **FLOATING
C737 a_2019_952.t5 VSS 0.62586f ; **FLOATING
C738 a_2019_952.n2 VSS 3.00299f ; **FLOATING
C739 a_2019_952.t6 VSS 0.62586f ; **FLOATING
C740 a_2019_952.n3 VSS 3.00299f ; **FLOATING
C741 a_2019_952.t7 VSS 0.62586f ; **FLOATING
C742 a_2019_952.n4 VSS 3.00299f ; **FLOATING
C743 a_2019_952.t8 VSS 3.62885f ; **FLOATING
C744 a_2019_952.t9 VSS 4.83408f ; **FLOATING
C745 a_2019_952.t0 VSS 0.95051f ; **FLOATING
C746 a_2019_952.t1 VSS 0.27016f ; **FLOATING
C747 a_2595_952.t2 VSS 1.35979f ; **FLOATING
C748 a_2595_952.t3 VSS 1.01554f ; **FLOATING
C749 a_2595_952.n0 VSS 7.72017f ; **FLOATING
C750 a_2595_952.t4 VSS 1.01554f ; **FLOATING
C751 a_2595_952.n1 VSS 5.2455f ; **FLOATING
C752 a_2595_952.t5 VSS 1.01554f ; **FLOATING
C753 a_2595_952.n2 VSS 5.2455f ; **FLOATING
C754 a_2595_952.t6 VSS 1.01554f ; **FLOATING
C755 a_2595_952.n3 VSS 5.2455f ; **FLOATING
C756 a_2595_952.t7 VSS 1.01554f ; **FLOATING
C757 a_2595_952.n4 VSS 5.2455f ; **FLOATING
C758 a_2595_952.t8 VSS 1.01554f ; **FLOATING
C759 a_2595_952.n5 VSS 5.2455f ; **FLOATING
C760 a_2595_952.t9 VSS 1.01554f ; **FLOATING
C761 a_2595_952.n6 VSS 7.54534f ; **FLOATING
C762 a_2595_952.t0 VSS 1.74193f ; **FLOATING
C763 a_2595_952.t1 VSS 0.47972f ; **FLOATING
C764 a_3171_952.t2 VSS 1.37934f ; **FLOATING
C765 a_3171_952.t3 VSS 1.03353f ; **FLOATING
C766 a_3171_952.n0 VSS 7.75003f ; **FLOATING
C767 a_3171_952.t4 VSS 1.03353f ; **FLOATING
C768 a_3171_952.n1 VSS 5.26146f ; **FLOATING
C769 a_3171_952.t5 VSS 1.03353f ; **FLOATING
C770 a_3171_952.n2 VSS 5.26146f ; **FLOATING
C771 a_3171_952.t6 VSS 1.03353f ; **FLOATING
C772 a_3171_952.n3 VSS 5.26146f ; **FLOATING
C773 a_3171_952.t7 VSS 1.03353f ; **FLOATING
C774 a_3171_952.n4 VSS 5.26146f ; **FLOATING
C775 a_3171_952.t8 VSS 1.03353f ; **FLOATING
C776 a_3171_952.n5 VSS 5.26146f ; **FLOATING
C777 a_3171_952.t9 VSS 1.03353f ; **FLOATING
C778 a_3171_952.n6 VSS 7.65529f ; **FLOATING
C779 a_3171_952.t0 VSS 1.76377f ; **FLOATING
C780 a_3171_952.t1 VSS 0.47908f ; **FLOATING
C781 a_3747_952.t2 VSS 0.96135f ; **FLOATING
C782 a_3747_952.t3 VSS 0.73189f ; **FLOATING
C783 a_3747_952.n0 VSS 5.12748f ; **FLOATING
C784 a_3747_952.t4 VSS 0.73189f ; **FLOATING
C785 a_3747_952.n1 VSS 3.46611f ; **FLOATING
C786 a_3747_952.t5 VSS 0.73189f ; **FLOATING
C787 a_3747_952.n2 VSS 3.46611f ; **FLOATING
C788 a_3747_952.t6 VSS 0.73189f ; **FLOATING
C789 a_3747_952.n3 VSS 3.46611f ; **FLOATING
C790 a_3747_952.t7 VSS 0.73189f ; **FLOATING
C791 a_3747_952.n4 VSS 3.46611f ; **FLOATING
C792 a_3747_952.t8 VSS 0.73189f ; **FLOATING
C793 a_3747_952.n5 VSS 3.46611f ; **FLOATING
C794 a_3747_952.t9 VSS 0.73189f ; **FLOATING
C795 a_3747_952.n6 VSS 5.14677f ; **FLOATING
C796 a_3747_952.t0 VSS 1.17618f ; **FLOATING
C797 a_3747_952.t1 VSS 0.31095f ; **FLOATING
C798 a_2595_216.t0 VSS 3.2703f ; **FLOATING
C799 a_2595_216.t2 VSS 5.04135f ; **FLOATING
C800 a_2595_216.t3 VSS 1.20629f ; **FLOATING
C801 a_2595_216.n0 VSS 26.8663f ; **FLOATING
C802 a_2595_216.t1 VSS 0.49571f ; **FLOATING
C803 a_3171_216.t2 VSS 5.0499f ; **FLOATING
C804 a_3171_216.t3 VSS 1.21145f ; **FLOATING
C805 a_3171_216.n0 VSS 29.8488f ; **FLOATING
C806 a_3171_216.t0 VSS 4.61136f ; **FLOATING
C807 a_3171_216.t1 VSS 0.49728f ; **FLOATING
C808 a_3747_216.t2 VSS 3.09124f ; **FLOATING
C809 a_3747_216.t3 VSS 0.74403f ; **FLOATING
C810 a_3747_216.n0 VSS 19.8835f ; **FLOATING
C811 a_3747_216.t0 VSS 3.68799f ; **FLOATING
C812 a_3747_216.t1 VSS 0.30529f ; **FLOATING
.ends
