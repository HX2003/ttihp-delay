* NGSPICE file created from hx_mux.ext - technology: ihp-sg13g2

.subckt hx_mux VSS VDD DELAY_OUT_TAP0 DELAY_OUT_TAP1 DELAY_OUT_TAP2 DELAY_OUT_TAP3
+ DELAY_OUT_TAP4 DELAY_OUT_TAP5 DELAY_OUT_TAP6 DELAY_OUT_TAP7 DELAY_OUT_TAP8 DELAY_OUT_TAP9
+ DELAY_OUT_TAP10 DELAY_OUT_TAP11 DELAY_OUT_TAP12 DELAY_OUT_TAP13 DELAY_OUT_TAP14
+ DELAY_OUT_TAP15 DELAY_OUT_TAP16 DELAY_OUT_TAP17 DELAY_OUT_TAP18 DELAY_OUT_TAP19
+ DELAY_OUT_TAP20 DELAY_OUT_TAP21 DELAY_OUT_TAP22 DELAY_OUT_TAP23 DELAY_OUT_TAP24
+ DELAY_OUT_TAP25 DELAY_OUT_TAP26 DELAY_OUT_TAP27 DELAY_OUT_TAP28 DELAY_OUT_TAP29
+ DELAY_OUT_TAP30 DELAY_OUT_TAP31 MUX_SEL0 MUX_SEL1 MUX_OUT MUX_SEL4 MUX_SEL2 MUX_SEL3
X0 VDD a_2019_952.t9 a_4324_913# VDD sg13_lv_pmos ad=0.3808p pd=2.92u as=0.3808p ps=2.92u w=1.12u l=0.13u
X1 a_1256_194# MUX_SEL2 VDD VDD sg13_lv_pmos ad=0.3808p pd=2.92u as=0.3808p ps=2.92u w=1.12u l=0.13u
X2 VDD a_3171_952.t8 a_8884_913# VDD sg13_lv_pmos ad=0.3808p pd=2.92u as=0.3808p ps=2.92u w=1.12u l=0.13u
X3 a_16108_194# a_15765_368# a_15964_194# VDD sg13_lv_pmos ad=0.3808p pd=2.92u as=0.3304p ps=1.71u w=1.12u l=0.13u
X4 a_22590_949# a_24951_913# a_24875_949# VDD sg13_lv_pmos ad=0.3808p pd=2.92u as=0.2128p ps=1.5u w=1.12u l=0.13u
X5 VDD a_2595_952.t7 a_11271_913# VDD sg13_lv_pmos ad=0.3808p pd=2.92u as=0.3808p ps=2.92u w=1.12u l=0.13u
X6 VSS.t201 VDD VSS.t199 VSS.t200 sg13_lv_nmos ad=79.8f pd=0.8u as=0 ps=0 w=0.42u l=1u
X7 a_7390_949# a_2595_952.t8 a_8155_949# VSS.t125 sg13_lv_nmos ad=0.2516p pd=2.16u as=0.1406p ps=1.12u w=0.74u l=0.13u
X8 VSS.t204 VDD VSS.t203 VSS.t202 sg13_lv_nmos ad=0.1428p pd=1.52u as=0 ps=0 w=0.42u l=1u
X9 VDD VSS.t381 VDD VDD sg13_lv_pmos ad=0.19p pd=1.38u as=0.14315n ps=0.71478m w=1u l=1u
X10 VSS.t174 DELAY_OUT_TAP11 a_12505_949# VSS.t292 sg13_lv_nmos ad=0.1665p pd=1.19u as=0.2516p ps=2.16u w=0.74u l=0.13u
X11 MUX_OUT a_16851_214# VSS.t182 VSS.t181 sg13_lv_nmos ad=0.1406p pd=1.12u as=0.1371p ps=1.12u w=0.74u l=0.13u
X12 VDD a_3747_952.t9 a_6711_913# VDD sg13_lv_pmos ad=0.3808p pd=2.92u as=0.3808p ps=2.92u w=1.12u l=0.13u
X13 VSS.t269 VDD VSS.t268 VSS.t267 sg13_lv_nmos ad=0.1428p pd=1.52u as=0 ps=0 w=0.42u l=1u
X14 a_1544_194# MUX_SEL3 VDD VDD sg13_lv_pmos ad=0.3808p pd=2.92u as=0.3808p ps=2.92u w=1.12u l=0.13u
X15 VSS.t295 a_2595_216.t3 a_8745_424# VSS.t294 sg13_lv_nmos ad=0.2516p pd=2.16u as=0.2516p ps=2.16u w=0.74u l=0.13u
X16 a_10328_949# DELAY_OUT_TAP8 VSS.t352 VSS.t351 sg13_lv_nmos ad=0.1406p pd=1.12u as=0.2516p ps=2.16u w=0.74u l=0.13u
X17 a_22590_949# a_2019_952.t3 a_22488_949# VSS.t32 sg13_lv_nmos ad=0.2516p pd=2.16u as=0.1406p ps=1.12u w=0.74u l=0.13u
X18 a_8808_949# DELAY_OUT_TAP6 VSS.t306 VSS.t305 sg13_lv_nmos ad=0.1406p pd=1.12u as=0.2516p ps=2.16u w=0.74u l=0.13u
X19 VSS.t39 DELAY_OUT_TAP31 a_27705_949# VSS.t38 sg13_lv_nmos ad=0.1665p pd=1.19u as=0.2516p ps=2.16u w=0.74u l=0.13u
X20 a_11848_949# DELAY_OUT_TAP10 VDD VDD sg13_lv_pmos ad=0.2128p pd=1.5u as=0.3808p ps=2.92u w=1.12u l=0.13u
X21 VDD a_3171_952.t3 a_24084_913# VDD sg13_lv_pmos ad=0.3808p pd=2.92u as=0.3808p ps=2.92u w=1.12u l=0.13u
X22 a_1721_236# a_1256_194# VDD VDD sg13_lv_pmos ad=0.1596p pd=1.22u as=0.2856p ps=2.36u w=0.84u l=0.13u
X23 a_6635_949# a_6425_949# VSS.t161 VSS.t160 sg13_lv_nmos ad=0.1406p pd=1.12u as=0.1665p ps=1.19u w=0.74u l=0.13u
X24 VDD VSS.t374 VDD VDD sg13_lv_pmos ad=0.34p pd=2.68u as=0 ps=0 w=1u l=1u
X25 VSS.t340 a_2595_952.t9 a_5191_913# VSS.t339 sg13_lv_nmos ad=0.2516p pd=2.16u as=0.2516p ps=2.16u w=0.74u l=0.13u
X26 VSS.t299 a_1256_949# a_2967_1300# VSS.t304 sg13_lv_nmos ad=0.1331p pd=1.12u as=0.1216p ps=1.02u w=0.64u l=0.13u
X27 a_4157_1218# DELAY_OUT_TAP0 VDD VDD sg13_lv_pmos ad=0.3808p pd=2.92u as=0.3808p ps=2.92u w=1.12u l=0.13u
X28 a_25528_949# DELAY_OUT_TAP28 VSS.t330 VSS.t329 sg13_lv_nmos ad=0.1406p pd=1.12u as=0.2516p ps=2.16u w=0.74u l=0.13u
X29 a_20315_949# a_20105_949# VSS.t132 VSS.t131 sg13_lv_nmos ad=0.1406p pd=1.12u as=0.1665p ps=1.19u w=0.74u l=0.13u
X30 a_5731_194# a_3747_216.t3 a_13470_949# VSS.t178 sg13_lv_nmos ad=0.2516p pd=2.16u as=0.2516p ps=2.16u w=0.74u l=0.13u
X31 VSS.t261 VDD VSS.t259 VSS.t260 sg13_lv_nmos ad=79.8f pd=0.8u as=0 ps=0 w=0.42u l=1u
X32 VSS.t226 VDD VSS.t224 VSS.t225 sg13_lv_nmos ad=79.8f pd=0.8u as=0 ps=0 w=0.42u l=1u
X33 VSS.t184 a_16851_214# MUX_OUT VSS.t183 sg13_lv_nmos ad=0.2516p pd=2.16u as=0.1406p ps=1.12u w=0.74u l=0.13u
X34 VDD a_1544_194# a_1721_236# VDD sg13_lv_pmos ad=0.1918p pd=1.5u as=0.1596p ps=1.22u w=0.84u l=0.13u
X35 VDD a_3747_952.t3 a_24951_913# VDD sg13_lv_pmos ad=0.3808p pd=2.92u as=0.3808p ps=2.92u w=1.12u l=0.13u
X36 VDD VSS.t386 VDD VDD sg13_lv_pmos ad=0.34p pd=2.68u as=0 ps=0 w=1u l=1u
X37 a_16408_949# DELAY_OUT_TAP16 VSS.t332 VSS.t331 sg13_lv_nmos ad=0.1406p pd=1.12u as=0.2516p ps=2.16u w=0.74u l=0.13u
X38 a_5731_194# a_2019_216# a_4350_949# VSS.t110 sg13_lv_nmos ad=0.2516p pd=2.16u as=0.2516p ps=2.16u w=0.74u l=0.13u
X39 VDD a_2595_952.t2 a_26471_913# VDD sg13_lv_pmos ad=0.3808p pd=2.92u as=0.3808p ps=2.92u w=1.12u l=0.13u
X40 a_7390_949# a_3747_952.t8 a_9675_949# VSS.t153 sg13_lv_nmos ad=0.2516p pd=2.16u as=0.1406p ps=1.12u w=0.74u l=0.13u
X41 VSS.t199 VDD VSS.t198 VSS.t197 sg13_lv_nmos ad=0.1428p pd=1.52u as=0 ps=0 w=0.42u l=1u
X42 VDD VSS.t357 VDD VDD sg13_lv_pmos ad=0.19p pd=1.38u as=0 ps=0 w=1u l=1u
X43 VDD DELAY_OUT_TAP13 a_14025_949# VDD sg13_lv_pmos ad=0.252p pd=1.57u as=0.3808p ps=2.92u w=1.12u l=0.13u
X44 a_10430_949# a_11924_913# a_11848_949# VDD sg13_lv_pmos ad=0.3808p pd=2.92u as=0.2128p ps=1.5u w=1.12u l=0.13u
X45 VDD a_2595_216.t3 a_8745_424# VDD sg13_lv_pmos ad=0.3808p pd=2.92u as=0.3808p ps=2.92u w=1.12u l=0.13u
X46 VSS.t346 a_3171_952.t5 a_18004_913# VSS.t345 sg13_lv_nmos ad=0.2516p pd=2.16u as=0.2516p ps=2.16u w=0.74u l=0.13u
X47 VDD DELAY_OUT_TAP15 a_15545_949# VDD sg13_lv_pmos ad=0.252p pd=1.57u as=0.3808p ps=2.92u w=1.12u l=0.13u
X48 a_3171_216.t1 a_2873_236# VDD VDD sg13_lv_pmos ad=0.2128p pd=1.5u as=0.1918p ps=1.5u w=1.12u l=0.13u
X49 a_14235_949# a_14025_949# VSS.t105 VSS.t104 sg13_lv_nmos ad=0.1406p pd=1.12u as=0.1665p ps=1.19u w=0.74u l=0.13u
X50 VSS.t124 a_3747_952.t7 a_12791_913# VSS.t123 sg13_lv_nmos ad=0.2516p pd=2.16u as=0.2516p ps=2.16u w=0.74u l=0.13u
X51 a_3747_216.t1 a_3449_236# VDD VDD sg13_lv_pmos ad=0.2128p pd=1.5u as=0.1918p ps=1.5u w=1.12u l=0.13u
X52 a_12715_949# a_12505_949# VDD VDD sg13_lv_pmos ad=0.2128p pd=1.5u as=0.252p ps=1.57u w=1.12u l=0.13u
X53 a_11848_949# DELAY_OUT_TAP10 VSS.t354 VSS.t353 sg13_lv_nmos ad=0.1406p pd=1.12u as=0.2516p ps=2.16u w=0.74u l=0.13u
X54 a_17275_949# a_17065_949# VDD VDD sg13_lv_pmos ad=0.2128p pd=1.5u as=0.252p ps=1.57u w=1.12u l=0.13u
X55 VDD VSS.t389 VDD VDD sg13_lv_pmos ad=0.19p pd=1.38u as=0 ps=0 w=1u l=1u
X56 VDD VSS.t388 VDD VDD sg13_lv_pmos ad=0.34p pd=2.68u as=0 ps=0 w=1u l=1u
X57 a_10430_949# a_12791_913# a_12715_949# VDD sg13_lv_pmos ad=0.3808p pd=2.92u as=0.2128p ps=1.5u w=1.12u l=0.13u
X58 VSS.t132 DELAY_OUT_TAP21 a_20105_949# VSS.t350 sg13_lv_nmos ad=0.1665p pd=1.19u as=0.2516p ps=2.16u w=0.74u l=0.13u
X59 a_16510_949# a_17351_913# a_17275_949# VDD sg13_lv_pmos ad=0.3808p pd=2.92u as=0.2128p ps=1.5u w=1.12u l=0.13u
X60 VSS.t310 a_1721_1300# a_2019_952.t0 VSS.t309 sg13_lv_nmos ad=0.2812p pd=2.24u as=0.1406p ps=1.12u w=0.74u l=0.13u
X61 a_5731_194# a_14825_424# a_13470_949# VDD sg13_lv_pmos ad=0.3808p pd=2.92u as=0.3808p ps=2.92u w=1.12u l=0.13u
X62 a_16510_949# a_2595_952.t5 a_17275_949# VSS.t40 sg13_lv_nmos ad=0.2516p pd=2.16u as=0.1406p ps=1.12u w=0.74u l=0.13u
X63 a_8155_949# a_7945_949# VDD VDD sg13_lv_pmos ad=0.2128p pd=1.5u as=0.252p ps=1.57u w=1.12u l=0.13u
X64 VDD VSS.t362 VDD VDD sg13_lv_pmos ad=0.34p pd=2.68u as=0 ps=0 w=1u l=1u
X65 VSS.t54 a_3747_952.t2 a_27991_913# VSS.t53 sg13_lv_nmos ad=0.2516p pd=2.16u as=0.2516p ps=2.16u w=0.74u l=0.13u
X66 VSS.t48 a_3747_952.t9 a_6711_913# VSS.t47 sg13_lv_nmos ad=0.2516p pd=2.16u as=0.2516p ps=2.16u w=0.74u l=0.13u
X67 a_16108_194# a_2595_216.t2 a_19550_949# VSS.t80 sg13_lv_nmos ad=0.2516p pd=2.16u as=0.2516p ps=2.16u w=0.74u l=0.13u
X68 VSS.t259 VDD VSS.t258 VSS.t257 sg13_lv_nmos ad=0.1428p pd=1.52u as=0 ps=0 w=0.42u l=1u
X69 a_7390_949# a_8231_913# a_8155_949# VDD sg13_lv_pmos ad=0.3808p pd=2.92u as=0.2128p ps=1.5u w=1.12u l=0.13u
X70 VSS.t224 VDD VSS.t223 VSS.t222 sg13_lv_nmos ad=0.1428p pd=1.52u as=0 ps=0 w=0.42u l=1u
X71 a_3171_216.t0 a_2873_236# VSS.t29 VSS.t28 sg13_lv_nmos ad=0.1406p pd=1.12u as=0.1331p ps=1.12u w=0.74u l=0.13u
X72 a_5731_194# a_5705_424# a_4350_949# VDD sg13_lv_pmos ad=0.3808p pd=2.92u as=0.3808p ps=2.92u w=1.12u l=0.13u
X73 VDD a_2873_236# a_3171_216.t1 VDD sg13_lv_pmos ad=0.4256p pd=3u as=0.2128p ps=1.5u w=1.12u l=0.13u
X74 a_3747_216.t0 a_3449_236# VSS.t89 VSS.t116 sg13_lv_nmos ad=0.1406p pd=1.12u as=0.1331p ps=1.12u w=0.74u l=0.13u
X75 VDD a_3449_236# a_3747_216.t1 VDD sg13_lv_pmos ad=0.4256p pd=3u as=0.2128p ps=1.5u w=1.12u l=0.13u
X76 a_7390_949# a_2019_952.t8 a_7288_949# VSS.t55 sg13_lv_nmos ad=0.2516p pd=2.16u as=0.1406p ps=1.12u w=0.74u l=0.13u
X77 VDD DELAY_OUT_TAP21 a_20105_949# VDD sg13_lv_pmos ad=0.252p pd=1.57u as=0.3808p ps=2.92u w=1.12u l=0.13u
X78 a_19550_949# a_21044_913# a_20968_949# VDD sg13_lv_pmos ad=0.3808p pd=2.92u as=0.2128p ps=1.5u w=1.12u l=0.13u
X79 VDD VSS.t365 VDD VDD sg13_lv_pmos ad=0.19p pd=1.38u as=0 ps=0 w=1u l=1u
X80 VDD VSS.t379 VDD VDD sg13_lv_pmos ad=0.19p pd=1.38u as=0 ps=0 w=1u l=1u
X81 VDD a_3171_952.t7 a_11924_913# VDD sg13_lv_pmos ad=0.3808p pd=2.92u as=0.3808p ps=2.92u w=1.12u l=0.13u
X82 VSS.t25 a_2019_952.t4 a_19524_913# VSS.t24 sg13_lv_nmos ad=0.2516p pd=2.16u as=0.2516p ps=2.16u w=0.74u l=0.13u
X83 a_15755_949# a_15545_949# VSS.t134 VSS.t133 sg13_lv_nmos ad=0.1406p pd=1.12u as=0.1665p ps=1.19u w=0.74u l=0.13u
X84 VSS.t130 a_2595_952.t6 a_14311_913# VSS.t129 sg13_lv_nmos ad=0.2516p pd=2.16u as=0.2516p ps=2.16u w=0.74u l=0.13u
X85 a_5115_949# a_4905_949# VSS.t95 VSS.t94 sg13_lv_nmos ad=0.1406p pd=1.12u as=0.1665p ps=1.19u w=0.74u l=0.13u
X86 a_27915_949# a_27705_949# VDD VDD sg13_lv_pmos ad=0.2128p pd=1.5u as=0.252p ps=1.57u w=1.12u l=0.13u
X87 VSS.t216 VDD VSS.t214 VSS.t215 sg13_lv_nmos ad=79.8f pd=0.8u as=0 ps=0 w=0.42u l=1u
X88 a_23355_949# a_23145_949# VDD VDD sg13_lv_pmos ad=0.2128p pd=1.5u as=0.252p ps=1.57u w=1.12u l=0.13u
X89 VDD a_2019_952.t8 a_7364_913# VDD sg13_lv_pmos ad=0.3808p pd=2.92u as=0.3808p ps=2.92u w=1.12u l=0.13u
X90 VSS.t31 a_2873_236# a_3171_216.t0 VSS.t30 sg13_lv_nmos ad=0.2812p pd=2.24u as=0.1406p ps=1.12u w=0.74u l=0.13u
X91 VDD VSS.t390 VDD VDD sg13_lv_pmos ad=0.34p pd=2.68u as=0 ps=0 w=1u l=1u
X92 a_25630_949# a_27991_913# a_27915_949# VDD sg13_lv_pmos ad=0.3808p pd=2.92u as=0.2128p ps=1.5u w=1.12u l=0.13u
X93 VSS.t118 a_3449_236# a_3747_216.t0 VSS.t117 sg13_lv_nmos ad=0.2812p pd=2.24u as=0.1406p ps=1.12u w=0.74u l=0.13u
X94 VSS.t27 DELAY_OUT_TAP23 a_21625_949# VSS.t26 sg13_lv_nmos ad=0.1665p pd=1.19u as=0.2516p ps=2.16u w=0.74u l=0.13u
X95 a_22590_949# a_23431_913# a_23355_949# VDD sg13_lv_pmos ad=0.3808p pd=2.92u as=0.2128p ps=1.5u w=1.12u l=0.13u
X96 a_16108_194# a_20905_424# a_19550_949# VDD sg13_lv_pmos ad=0.3808p pd=2.92u as=0.3808p ps=2.92u w=1.12u l=0.13u
X97 VDD a_2595_952.t6 a_14311_913# VDD sg13_lv_pmos ad=0.3808p pd=2.92u as=0.3808p ps=2.92u w=1.12u l=0.13u
X98 VSS.t5 a_2019_952.t9 a_4324_913# VSS.t4 sg13_lv_nmos ad=0.2516p pd=2.16u as=0.2516p ps=2.16u w=0.74u l=0.13u
X99 a_16510_949# a_3747_952.t5 a_18795_949# VSS.t141 sg13_lv_nmos ad=0.2516p pd=2.16u as=0.1406p ps=1.12u w=0.74u l=0.13u
X100 VDD a_3747_952.t5 a_18871_913# VDD sg13_lv_pmos ad=0.3808p pd=2.92u as=0.3808p ps=2.92u w=1.12u l=0.13u
X101 VSS.t79 a_3171_216.t3 a_11785_424# VSS.t78 sg13_lv_nmos ad=0.2516p pd=2.16u as=0.2516p ps=2.16u w=0.74u l=0.13u
X102 VDD a_3747_952.t8 a_9751_913# VDD sg13_lv_pmos ad=0.3808p pd=2.92u as=0.3808p ps=2.92u w=1.12u l=0.13u
X103 VDD a_2595_952.t9 a_5191_913# VDD sg13_lv_pmos ad=0.3808p pd=2.92u as=0.3808p ps=2.92u w=1.12u l=0.13u
X104 a_10430_949# a_2019_952.t7 a_10328_949# VSS.t9 sg13_lv_nmos ad=0.2516p pd=2.16u as=0.1406p ps=1.12u w=0.74u l=0.13u
X105 a_4157_1218# DELAY_OUT_TAP0 VSS.t17 VSS.t16 sg13_lv_nmos ad=0.2516p pd=2.16u as=0.2553p ps=2.17u w=0.74u l=0.13u
X106 a_7390_949# a_3171_952.t8 a_8808_949# VSS.t144 sg13_lv_nmos ad=0.2516p pd=2.16u as=0.1406p ps=1.12u w=0.74u l=0.13u
X107 VSS.t134 DELAY_OUT_TAP15 a_15545_949# VSS.t326 sg13_lv_nmos ad=0.1665p pd=1.19u as=0.2516p ps=2.16u w=0.74u l=0.13u
X108 VDD a_2019_952.t3 a_22564_913# VDD sg13_lv_pmos ad=0.3808p pd=2.92u as=0.3808p ps=2.92u w=1.12u l=0.13u
X109 a_14888_949# DELAY_OUT_TAP14 VDD VDD sg13_lv_pmos ad=0.2128p pd=1.5u as=0.3808p ps=2.92u w=1.12u l=0.13u
X110 VSS.t149 a_3171_952.t7 a_11924_913# VSS.t148 sg13_lv_nmos ad=0.2516p pd=2.16u as=0.2516p ps=2.16u w=0.74u l=0.13u
X111 VDD VSS.t366 VDD VDD sg13_lv_pmos ad=0.34p pd=2.68u as=0 ps=0 w=1u l=1u
X112 VDD a_3171_952.t2 a_27124_913# VDD sg13_lv_pmos ad=0.3808p pd=2.92u as=0.3808p ps=2.92u w=1.12u l=0.13u
X113 a_10328_949# DELAY_OUT_TAP8 VDD VDD sg13_lv_pmos ad=0.2128p pd=1.5u as=0.3808p ps=2.92u w=1.12u l=0.13u
X114 a_19448_949# DELAY_OUT_TAP20 VDD VDD sg13_lv_pmos ad=0.2128p pd=1.5u as=0.3808p ps=2.92u w=1.12u l=0.13u
X115 VDD VSS.t380 VDD VDD sg13_lv_pmos ad=0.34p pd=2.68u as=0 ps=0 w=1u l=1u
X116 a_3171_952.t0 a_2873_1300# VSS.t299 VSS.t298 sg13_lv_nmos ad=0.1406p pd=1.12u as=0.1331p ps=1.12u w=0.74u l=0.13u
X117 a_25630_949# a_2019_952.t2 a_25528_949# VSS.t119 sg13_lv_nmos ad=0.2516p pd=2.16u as=0.1406p ps=1.12u w=0.74u l=0.13u
X118 VSS.t349 a_2297_1300# a_2595_952.t0 VSS.t348 sg13_lv_nmos ad=0.2812p pd=2.24u as=0.1406p ps=1.12u w=0.74u l=0.13u
X119 a_16108_194# a_2019_216# a_16510_949# VSS.t113 sg13_lv_nmos ad=0.2516p pd=2.16u as=0.2516p ps=2.16u w=0.74u l=0.13u
X120 a_2391_1300# MUX_SEL0 a_2297_1300# VSS.t288 sg13_lv_nmos ad=0.1216p pd=1.02u as=0.2176p ps=1.96u w=0.64u l=0.13u
X121 VSS.t276 VDD VSS.t274 VSS.t275 sg13_lv_nmos ad=79.8f pd=0.8u as=0 ps=0 w=0.42u l=1u
X122 VSS.t308 a_1544_949# a_1815_1300# VSS.t312 sg13_lv_nmos ad=0.1331p pd=1.12u as=0.1216p ps=1.02u w=0.64u l=0.13u
X123 a_5768_949# DELAY_OUT_TAP2 VDD VDD sg13_lv_pmos ad=0.2128p pd=1.5u as=0.3808p ps=2.92u w=1.12u l=0.13u
X124 VSS.t279 VDD VSS.t278 VSS.t277 sg13_lv_nmos ad=0.1428p pd=1.52u as=0 ps=0 w=0.42u l=1u
X125 a_16510_949# a_2019_952.t5 a_16408_949# VSS.t58 sg13_lv_nmos ad=0.2516p pd=2.16u as=0.1406p ps=1.12u w=0.74u l=0.13u
X126 VDD a_2595_952.t4 a_20391_913# VDD sg13_lv_pmos ad=0.3808p pd=2.92u as=0.3808p ps=2.92u w=1.12u l=0.13u
X127 VSS.t8 a_3171_952.t2 a_27124_913# VSS.t7 sg13_lv_nmos ad=0.2516p pd=2.16u as=0.2516p ps=2.16u w=0.74u l=0.13u
X128 a_5731_194# a_2595_216.t3 a_7390_949# VSS.t293 sg13_lv_nmos ad=0.2516p pd=2.16u as=0.2516p ps=2.16u w=0.74u l=0.13u
X129 VDD a_3171_216.t3 a_11785_424# VDD sg13_lv_pmos ad=0.3808p pd=2.92u as=0.3808p ps=2.92u w=1.12u l=0.13u
X130 a_10430_949# a_2595_952.t7 a_11195_949# VSS.t43 sg13_lv_nmos ad=0.2516p pd=2.16u as=0.1406p ps=1.12u w=0.74u l=0.13u
X131 a_23355_949# a_23145_949# VSS.t84 VSS.t159 sg13_lv_nmos ad=0.1406p pd=1.12u as=0.1665p ps=1.19u w=0.74u l=0.13u
X132 VSS.t196 VDD VSS.t193 VSS.t195 sg13_lv_nmos ad=79.8f pd=0.8u as=0 ps=0 w=0.42u l=1u
X133 VSS.t103 a_3747_952.t4 a_21911_913# VSS.t102 sg13_lv_nmos ad=0.2516p pd=2.16u as=0.2516p ps=2.16u w=0.74u l=0.13u
X134 VSS.t158 a_3747_216.t2 a_26985_424# VSS.t157 sg13_lv_nmos ad=0.2516p pd=2.16u as=0.2516p ps=2.16u w=0.74u l=0.13u
X135 a_20968_949# DELAY_OUT_TAP22 VSS.t334 VSS.t333 sg13_lv_nmos ad=0.1406p pd=1.12u as=0.2516p ps=2.16u w=0.74u l=0.13u
X136 VDD VSS.t383 VDD VDD sg13_lv_pmos ad=0.19p pd=1.38u as=0 ps=0 w=1u l=1u
X137 a_13470_949# a_14964_913# a_14888_949# VDD sg13_lv_pmos ad=0.3808p pd=2.92u as=0.2128p ps=1.5u w=1.12u l=0.13u
X138 VDD DELAY_OUT_TAP19 a_18585_949# VDD sg13_lv_pmos ad=0.252p pd=1.57u as=0.3808p ps=2.92u w=1.12u l=0.13u
X139 a_10430_949# a_10404_913# a_10328_949# VDD sg13_lv_pmos ad=0.3808p pd=2.92u as=0.2128p ps=1.5u w=1.12u l=0.13u
X140 a_19550_949# a_19524_913# a_19448_949# VDD sg13_lv_pmos ad=0.3808p pd=2.92u as=0.2128p ps=1.5u w=1.12u l=0.13u
X141 a_2595_216.t1 a_2297_236# VDD VDD sg13_lv_pmos ad=0.2128p pd=1.5u as=0.1918p ps=1.5u w=1.12u l=0.13u
X142 a_19448_949# DELAY_OUT_TAP20 VSS.t318 VSS.t317 sg13_lv_nmos ad=0.1406p pd=1.12u as=0.2516p ps=2.16u w=0.74u l=0.13u
X143 a_10430_949# a_3171_952.t7 a_11848_949# VSS.t147 sg13_lv_nmos ad=0.2516p pd=2.16u as=0.1406p ps=1.12u w=0.74u l=0.13u
X144 a_11195_949# a_10985_949# VDD VDD sg13_lv_pmos ad=0.2128p pd=1.5u as=0.252p ps=1.57u w=1.12u l=0.13u
X145 a_25630_949# a_2595_952.t2 a_26395_949# VSS.t72 sg13_lv_nmos ad=0.2516p pd=2.16u as=0.1406p ps=1.12u w=0.74u l=0.13u
X146 VDD a_1721_236# a_2019_216# VDD sg13_lv_pmos ad=0.4256p pd=3u as=0.2128p ps=1.5u w=1.12u l=0.13u
X147 VDD DELAY_OUT_TAP1 a_4905_949# VDD sg13_lv_pmos ad=0.252p pd=1.57u as=0.3808p ps=2.92u w=1.12u l=0.13u
X148 VSS.t236 VDD VSS.t234 VSS.t235 sg13_lv_nmos ad=79.8f pd=0.8u as=0 ps=0 w=0.42u l=1u
X149 VDD a_2297_236# a_2595_216.t1 VDD sg13_lv_pmos ad=0.4256p pd=3u as=0.2128p ps=1.5u w=1.12u l=0.13u
X150 a_4350_949# a_5844_913# a_5768_949# VDD sg13_lv_pmos ad=0.3808p pd=2.92u as=0.2128p ps=1.5u w=1.12u l=0.13u
X151 a_3449_1300# MUX_SEL0 VDD VDD sg13_lv_pmos ad=0.1596p pd=1.22u as=0.2856p ps=2.36u w=0.84u l=0.13u
X152 VDD DELAY_OUT_TAP7 a_9465_949# VDD sg13_lv_pmos ad=0.252p pd=1.57u as=0.3808p ps=2.92u w=1.12u l=0.13u
X153 VSS.t161 DELAY_OUT_TAP3 a_6425_949# VSS.t188 sg13_lv_nmos ad=0.1665p pd=1.19u as=0.2516p ps=2.16u w=0.74u l=0.13u
X154 a_10430_949# a_11271_913# a_11195_949# VDD sg13_lv_pmos ad=0.3808p pd=2.92u as=0.2128p ps=1.5u w=1.12u l=0.13u
X155 a_20968_949# DELAY_OUT_TAP22 VDD VDD sg13_lv_pmos ad=0.2128p pd=1.5u as=0.3808p ps=2.92u w=1.12u l=0.13u
X156 VSS.t343 a_2019_952.t6 a_13444_913# VSS.t342 sg13_lv_nmos ad=0.2516p pd=2.16u as=0.2516p ps=2.16u w=0.74u l=0.13u
X157 a_16108_194# a_17865_424# a_16510_949# VDD sg13_lv_pmos ad=0.3808p pd=2.92u as=0.3808p ps=2.92u w=1.12u l=0.13u
X158 VSS.t182 a_15964_194# a_16851_214# VSS.t185 sg13_lv_nmos ad=0.1371p pd=1.12u as=0.2176p ps=1.96u w=0.64u l=0.13u
X159 a_25528_949# DELAY_OUT_TAP28 VDD VDD sg13_lv_pmos ad=0.2128p pd=1.5u as=0.3808p ps=2.92u w=1.12u l=0.13u
X160 VDD a_1256_949# a_2873_1300# VDD sg13_lv_pmos ad=0.1918p pd=1.5u as=0.1596p ps=1.22u w=0.84u l=0.13u
X161 a_4248_949# a_4157_1218# VSS.t163 VSS.t162 sg13_lv_nmos ad=0.1406p pd=1.12u as=0.2516p ps=2.16u w=0.74u l=0.13u
X162 a_16108_194# a_3171_216.t2 a_22590_949# VSS.t168 sg13_lv_nmos ad=0.2516p pd=2.16u as=0.2516p ps=2.16u w=0.74u l=0.13u
X163 VSS.t256 VDD VSS.t254 VSS.t255 sg13_lv_nmos ad=79.8f pd=0.8u as=0 ps=0 w=0.42u l=1u
X164 a_19550_949# a_3747_952.t4 a_21835_949# VSS.t101 sg13_lv_nmos ad=0.2516p pd=2.16u as=0.1406p ps=1.12u w=0.74u l=0.13u
X165 VSS.t84 DELAY_OUT_TAP25 a_23145_949# VSS.t83 sg13_lv_nmos ad=0.1665p pd=1.19u as=0.2516p ps=2.16u w=0.74u l=0.13u
X166 a_5731_194# a_8745_424# a_7390_949# VDD sg13_lv_pmos ad=0.3808p pd=2.92u as=0.3808p ps=2.92u w=1.12u l=0.13u
X167 a_2595_216.t0 a_2297_236# VSS.t69 VSS.t68 sg13_lv_nmos ad=0.1406p pd=1.12u as=0.1331p ps=1.12u w=0.74u l=0.13u
X168 VDD a_3747_216.t2 a_26985_424# VDD sg13_lv_pmos ad=0.3808p pd=2.92u as=0.3808p ps=2.92u w=1.12u l=0.13u
X169 a_10430_949# a_3747_952.t7 a_12715_949# VSS.t122 sg13_lv_nmos ad=0.2516p pd=2.16u as=0.1406p ps=1.12u w=0.74u l=0.13u
X170 VSS.t93 a_1721_236# a_2019_216# VSS.t92 sg13_lv_nmos ad=0.2812p pd=2.24u as=0.1406p ps=1.12u w=0.74u l=0.13u
X171 a_24875_949# a_24665_949# VSS.t22 VSS.t21 sg13_lv_nmos ad=0.1406p pd=1.12u as=0.1665p ps=1.19u w=0.74u l=0.13u
X172 VSS.t71 a_2297_236# a_2595_216.t0 VSS.t70 sg13_lv_nmos ad=0.2812p pd=2.24u as=0.1406p ps=1.12u w=0.74u l=0.13u
X173 VSS.t140 a_2595_952.t3 a_23431_913# VSS.t139 sg13_lv_nmos ad=0.2516p pd=2.16u as=0.2516p ps=2.16u w=0.74u l=0.13u
X174 VDD MUX_SEL1 a_3449_1300# VDD sg13_lv_pmos ad=0.1918p pd=1.5u as=0.1596p ps=1.22u w=0.84u l=0.13u
X175 VSS.t194 VDD VSS.t193 VSS.t192 sg13_lv_nmos ad=0.1428p pd=1.52u as=0 ps=0 w=0.42u l=1u
X176 VSS.t105 DELAY_OUT_TAP13 a_14025_949# VSS.t324 sg13_lv_nmos ad=0.1665p pd=1.19u as=0.2516p ps=2.16u w=0.74u l=0.13u
X177 a_22590_949# a_24084_913# a_24008_949# VDD sg13_lv_pmos ad=0.3808p pd=2.92u as=0.2128p ps=1.5u w=1.12u l=0.13u
X178 VDD VSS.t359 VDD VDD sg13_lv_pmos ad=0.19p pd=1.38u as=0 ps=0 w=1u l=1u
X179 VDD DELAY_OUT_TAP27 a_24665_949# VDD sg13_lv_pmos ad=0.252p pd=1.57u as=0.3808p ps=2.92u w=1.12u l=0.13u
X180 VDD a_3171_952.t6 a_14964_913# VDD sg13_lv_pmos ad=0.3808p pd=2.92u as=0.3808p ps=2.92u w=1.12u l=0.13u
X181 a_25630_949# a_25604_913# a_25528_949# VDD sg13_lv_pmos ad=0.3808p pd=2.92u as=0.2128p ps=1.5u w=1.12u l=0.13u
X182 a_3171_952.t1 a_2873_1300# VDD VDD sg13_lv_pmos ad=0.2128p pd=1.5u as=0.1918p ps=1.5u w=1.12u l=0.13u
X183 a_3747_952.t1 a_3449_1300# VDD VDD sg13_lv_pmos ad=0.2128p pd=1.5u as=0.1918p ps=1.5u w=1.12u l=0.13u
X184 VDD VSS.t358 VDD VDD sg13_lv_pmos ad=0.34p pd=2.68u as=0 ps=0 w=1u l=1u
X185 VDD a_2019_952.t5 a_16484_913# VDD sg13_lv_pmos ad=0.3808p pd=2.92u as=0.3808p ps=2.92u w=1.12u l=0.13u
X186 a_22590_949# a_3171_952.t3 a_24008_949# VSS.t150 sg13_lv_nmos ad=0.2516p pd=2.16u as=0.1406p ps=1.12u w=0.74u l=0.13u
X187 VDD a_15964_194# a_16851_214# VDD sg13_lv_pmos ad=0.2086p pd=1.5u as=0.34p ps=2.68u w=1u l=0.13u
X188 a_26395_949# a_26185_949# VDD VDD sg13_lv_pmos ad=0.2128p pd=1.5u as=0.252p ps=1.57u w=1.12u l=0.13u
X189 a_3747_952.t0 a_3449_1300# VSS.t98 VSS.t97 sg13_lv_nmos ad=0.1406p pd=1.12u as=0.1331p ps=1.12u w=0.74u l=0.13u
X190 a_25630_949# a_3747_952.t2 a_27915_949# VSS.t52 sg13_lv_nmos ad=0.2516p pd=2.16u as=0.1406p ps=1.12u w=0.74u l=0.13u
X191 VSS.t251 VDD VSS.t249 VSS.t250 sg13_lv_nmos ad=79.8f pd=0.8u as=0 ps=0 w=0.42u l=1u
X192 VDD VSS.t391 VDD VDD sg13_lv_pmos ad=0.19p pd=1.38u as=0 ps=0 w=1u l=1u
X193 a_2967_1300# MUX_SEL1 a_2873_1300# VSS.t284 sg13_lv_nmos ad=0.1216p pd=1.02u as=0.2176p ps=1.96u w=0.64u l=0.13u
X194 VDD a_3171_952.t9 a_5844_913# VDD sg13_lv_pmos ad=0.3808p pd=2.92u as=0.3808p ps=2.92u w=1.12u l=0.13u
X195 VSS.t246 VDD VSS.t244 VSS.t245 sg13_lv_nmos ad=79.8f pd=0.8u as=0 ps=0 w=0.42u l=1u
X196 VSS.t219 VDD VSS.t218 VSS.t217 sg13_lv_nmos ad=0.1428p pd=1.52u as=0 ps=0 w=0.42u l=1u
X197 a_25630_949# a_26471_913# a_26395_949# VDD sg13_lv_pmos ad=0.3808p pd=2.92u as=0.2128p ps=1.5u w=1.12u l=0.13u
X198 a_3543_236# MUX_SEL2 a_3449_236# VSS.t67 sg13_lv_nmos ad=0.1216p pd=1.02u as=0.2176p ps=1.96u w=0.64u l=0.13u
X199 a_16108_194# a_23945_424# a_22590_949# VDD sg13_lv_pmos ad=0.3808p pd=2.92u as=0.3808p ps=2.92u w=1.12u l=0.13u
X200 VDD a_2595_952.t5 a_17351_913# VDD sg13_lv_pmos ad=0.3808p pd=2.92u as=0.3808p ps=2.92u w=1.12u l=0.13u
X201 VDD a_3747_952.t7 a_12791_913# VDD sg13_lv_pmos ad=0.3808p pd=2.92u as=0.3808p ps=2.92u w=1.12u l=0.13u
X202 a_8155_949# a_7945_949# VSS.t297 VSS.t321 sg13_lv_nmos ad=0.1406p pd=1.12u as=0.1665p ps=1.19u w=0.74u l=0.13u
X203 a_27048_949# DELAY_OUT_TAP30 VSS.t187 VSS.t186 sg13_lv_nmos ad=0.1406p pd=1.12u as=0.2516p ps=2.16u w=0.74u l=0.13u
X204 a_5768_949# DELAY_OUT_TAP2 VSS.t191 VSS.t190 sg13_lv_nmos ad=0.1406p pd=1.12u as=0.2516p ps=2.16u w=0.74u l=0.13u
X205 VSS.t180 a_3747_216.t3 a_14825_424# VSS.t179 sg13_lv_nmos ad=0.2516p pd=2.16u as=0.2516p ps=2.16u w=0.74u l=0.13u
X206 VSS.t29 a_1256_194# a_2967_236# VSS.t109 sg13_lv_nmos ad=0.1331p pd=1.12u as=0.1216p ps=1.02u w=0.64u l=0.13u
X207 VSS.t254 VDD VSS.t253 VSS.t252 sg13_lv_nmos ad=0.1428p pd=1.52u as=0 ps=0 w=0.42u l=1u
X208 VDD VSS.t375 VDD VDD sg13_lv_pmos ad=0.19p pd=1.38u as=0 ps=0 w=1u l=1u
X209 VDD a_2873_1300# a_3171_952.t1 VDD sg13_lv_pmos ad=0.4256p pd=3u as=0.2128p ps=1.5u w=1.12u l=0.13u
X210 VSS.t22 DELAY_OUT_TAP27 a_24665_949# VSS.t322 sg13_lv_nmos ad=0.1665p pd=1.19u as=0.2516p ps=2.16u w=0.74u l=0.13u
X211 VDD a_2595_952.t8 a_8231_913# VDD sg13_lv_pmos ad=0.3808p pd=2.92u as=0.3808p ps=2.92u w=1.12u l=0.13u
X212 a_16510_949# a_3171_952.t5 a_17928_949# VSS.t344 sg13_lv_nmos ad=0.2516p pd=2.16u as=0.1406p ps=1.12u w=0.74u l=0.13u
X213 VDD a_3449_1300# a_3747_952.t1 VDD sg13_lv_pmos ad=0.4256p pd=3u as=0.2128p ps=1.5u w=1.12u l=0.13u
X214 VSS.t63 a_3171_952.t4 a_21044_913# VSS.t62 sg13_lv_nmos ad=0.2516p pd=2.16u as=0.2516p ps=2.16u w=0.74u l=0.13u
X215 VDD VSS.t367 VDD VDD sg13_lv_pmos ad=0.19p pd=1.38u as=0 ps=0 w=1u l=1u
X216 VSS.t89 MUX_SEL3 a_3543_236# VSS.t88 sg13_lv_nmos ad=0.1331p pd=1.12u as=0.1216p ps=1.02u w=0.64u l=0.13u
X217 VDD a_3171_952.t4 a_21044_913# VDD sg13_lv_pmos ad=0.3808p pd=2.92u as=0.3808p ps=2.92u w=1.12u l=0.13u
X218 a_13368_949# DELAY_OUT_TAP12 VDD VDD sg13_lv_pmos ad=0.2128p pd=1.5u as=0.3808p ps=2.92u w=1.12u l=0.13u
X219 VSS.t301 a_2873_1300# a_3171_952.t0 VSS.t300 sg13_lv_nmos ad=0.2812p pd=2.24u as=0.1406p ps=1.12u w=0.74u l=0.13u
X220 a_13368_949# DELAY_OUT_TAP12 VSS.t291 VSS.t290 sg13_lv_nmos ad=0.1406p pd=1.12u as=0.2516p ps=2.16u w=0.74u l=0.13u
X221 a_5731_194# a_3171_216.t3 a_10430_949# VSS.t77 sg13_lv_nmos ad=0.2516p pd=2.16u as=0.2516p ps=2.16u w=0.74u l=0.13u
X222 VSS.t314 a_1544_949# a_2391_1300# VSS.t313 sg13_lv_nmos ad=0.1331p pd=1.12u as=0.1216p ps=1.02u w=0.64u l=0.13u
X223 a_2019_952.t0 a_1721_1300# VSS.t308 VSS.t307 sg13_lv_nmos ad=0.1406p pd=1.12u as=0.1331p ps=1.12u w=0.74u l=0.13u
X224 a_4350_949# a_3747_952.t9 a_6635_949# VSS.t46 sg13_lv_nmos ad=0.2516p pd=2.16u as=0.1406p ps=1.12u w=0.74u l=0.13u
X225 a_19550_949# a_2595_952.t4 a_20315_949# VSS.t135 sg13_lv_nmos ad=0.2516p pd=2.16u as=0.1406p ps=1.12u w=0.74u l=0.13u
X226 a_8808_949# DELAY_OUT_TAP6 VDD VDD sg13_lv_pmos ad=0.2128p pd=1.5u as=0.3808p ps=2.92u w=1.12u l=0.13u
X227 VSS.t297 DELAY_OUT_TAP5 a_7945_949# VSS.t296 sg13_lv_nmos ad=0.1665p pd=1.19u as=0.2516p ps=2.16u w=0.74u l=0.13u
X228 a_2019_216# a_1721_236# VDD VDD sg13_lv_pmos ad=0.2128p pd=1.5u as=0.1918p ps=1.5u w=1.12u l=0.13u
X229 VSS.t249 VDD VSS.t248 VSS.t247 sg13_lv_nmos ad=0.1428p pd=1.52u as=0 ps=0 w=0.42u l=1u
X230 a_4248_949# a_4157_1218# VDD VDD sg13_lv_pmos ad=0.2128p pd=1.5u as=0.3808p ps=2.92u w=1.12u l=0.13u
X231 VDD VSS.t392 VDD VDD sg13_lv_pmos ad=0.34p pd=2.68u as=0 ps=0 w=1u l=1u
X232 VSS.t214 VDD VSS.t213 VSS.t212 sg13_lv_nmos ad=0.1428p pd=1.52u as=0 ps=0 w=0.42u l=1u
X233 VSS.t244 VDD VSS.t243 VSS.t242 sg13_lv_nmos ad=0.1428p pd=1.52u as=0 ps=0 w=0.42u l=1u
X234 VDD a_2595_952.t3 a_23431_913# VDD sg13_lv_pmos ad=0.3808p pd=2.92u as=0.3808p ps=2.92u w=1.12u l=0.13u
X235 VDD a_3747_216.t3 a_14825_424# VDD sg13_lv_pmos ad=0.3808p pd=2.92u as=0.3808p ps=2.92u w=1.12u l=0.13u
X236 VDD a_3747_952.t2 a_27991_913# VDD sg13_lv_pmos ad=0.3808p pd=2.92u as=0.3808p ps=2.92u w=1.12u l=0.13u
X237 a_2297_1300# MUX_SEL0 VDD VDD sg13_lv_pmos ad=0.1596p pd=1.22u as=0.2856p ps=2.36u w=0.84u l=0.13u
X238 a_9675_949# a_9465_949# VSS.t320 VSS.t319 sg13_lv_nmos ad=0.1406p pd=1.12u as=0.1665p ps=1.19u w=0.74u l=0.13u
X239 VSS.t211 VDD VSS.t209 VSS.t210 sg13_lv_nmos ad=79.8f pd=0.8u as=0 ps=0 w=0.42u l=1u
X240 a_2873_1300# MUX_SEL1 VDD VDD sg13_lv_pmos ad=0.1596p pd=1.22u as=0.2856p ps=2.36u w=0.84u l=0.13u
X241 VSS.t127 a_2595_952.t8 a_8231_913# VSS.t126 sg13_lv_nmos ad=0.2516p pd=2.16u as=0.2516p ps=2.16u w=0.74u l=0.13u
X242 VSS.t82 a_2595_216.t2 a_20905_424# VSS.t81 sg13_lv_nmos ad=0.2516p pd=2.16u as=0.2516p ps=2.16u w=0.74u l=0.13u
X243 a_3449_236# MUX_SEL2 VDD VDD sg13_lv_pmos ad=0.1596p pd=1.22u as=0.2856p ps=2.36u w=0.84u l=0.13u
X244 VDD DELAY_OUT_TAP11 a_12505_949# VDD sg13_lv_pmos ad=0.252p pd=1.57u as=0.3808p ps=2.92u w=1.12u l=0.13u
X245 VDD VSS.t369 VDD VDD sg13_lv_pmos ad=0.19p pd=1.38u as=0 ps=0 w=1u l=1u
X246 a_13470_949# a_13444_913# a_13368_949# VDD sg13_lv_pmos ad=0.3808p pd=2.92u as=0.2128p ps=1.5u w=1.12u l=0.13u
X247 VDD DELAY_OUT_TAP17 a_17065_949# VDD sg13_lv_pmos ad=0.252p pd=1.57u as=0.3808p ps=2.92u w=1.12u l=0.13u
X248 a_16510_949# a_18004_913# a_17928_949# VDD sg13_lv_pmos ad=0.3808p pd=2.92u as=0.2128p ps=1.5u w=1.12u l=0.13u
X249 a_19550_949# a_2019_952.t4 a_19448_949# VSS.t23 sg13_lv_nmos ad=0.2516p pd=2.16u as=0.1406p ps=1.12u w=0.74u l=0.13u
X250 VDD VSS.t371 VDD VDD sg13_lv_pmos ad=0.19p pd=1.38u as=0 ps=0 w=1u l=1u
X251 VDD VSS.t382 VDD VDD sg13_lv_pmos ad=0.34p pd=2.68u as=0 ps=0 w=1u l=1u
X252 VDD a_1256_194# a_2873_236# VDD sg13_lv_pmos ad=0.1918p pd=1.5u as=0.1596p ps=1.22u w=0.84u l=0.13u
X253 a_13470_949# a_2595_952.t6 a_14235_949# VSS.t128 sg13_lv_nmos ad=0.2516p pd=2.16u as=0.1406p ps=1.12u w=0.74u l=0.13u
X254 VSS.t34 a_2019_952.t3 a_22564_913# VSS.t33 sg13_lv_nmos ad=0.2516p pd=2.16u as=0.2516p ps=2.16u w=0.74u l=0.13u
X255 a_15755_949# a_15545_949# VDD VDD sg13_lv_pmos ad=0.2128p pd=1.5u as=0.252p ps=1.57u w=1.12u l=0.13u
X256 a_7390_949# a_8884_913# a_8808_949# VDD sg13_lv_pmos ad=0.3808p pd=2.92u as=0.2128p ps=1.5u w=1.12u l=0.13u
X257 a_2019_216# a_1721_236# VSS.t91 VSS.t90 sg13_lv_nmos ad=0.1406p pd=1.12u as=0.1331p ps=1.12u w=0.74u l=0.13u
X258 a_4350_949# a_4324_913# a_4248_949# VDD sg13_lv_pmos ad=0.3808p pd=2.92u as=0.2128p ps=1.5u w=1.12u l=0.13u
X259 VDD DELAY_OUT_TAP5 a_7945_949# VDD sg13_lv_pmos ad=0.252p pd=1.57u as=0.3808p ps=2.92u w=1.12u l=0.13u
X260 a_24008_949# DELAY_OUT_TAP26 VDD VDD sg13_lv_pmos ad=0.2128p pd=1.5u as=0.3808p ps=2.92u w=1.12u l=0.13u
X261 a_5731_194# a_11785_424# a_10430_949# VDD sg13_lv_pmos ad=0.3808p pd=2.92u as=0.3808p ps=2.92u w=1.12u l=0.13u
X262 a_5115_949# a_4905_949# VDD VDD sg13_lv_pmos ad=0.2128p pd=1.5u as=0.252p ps=1.57u w=1.12u l=0.13u
X263 VDD VSS.t368 VDD VDD sg13_lv_pmos ad=0.34p pd=2.68u as=0 ps=0 w=1u l=1u
X264 a_13470_949# a_15831_913# a_15755_949# VDD sg13_lv_pmos ad=0.3808p pd=2.92u as=0.2128p ps=1.5u w=1.12u l=0.13u
X265 a_17275_949# a_17065_949# VSS.t172 VSS.t171 sg13_lv_nmos ad=0.1406p pd=1.12u as=0.1665p ps=1.19u w=0.74u l=0.13u
X266 VDD a_1544_949# a_2297_1300# VDD sg13_lv_pmos ad=0.1918p pd=1.5u as=0.1596p ps=1.22u w=0.84u l=0.13u
X267 VSS.t37 a_3747_952.t6 a_15831_913# VSS.t36 sg13_lv_nmos ad=0.2516p pd=2.16u as=0.2516p ps=2.16u w=0.74u l=0.13u
X268 a_4350_949# a_2019_952.t9 a_4248_949# VSS.t3 sg13_lv_nmos ad=0.2516p pd=2.16u as=0.1406p ps=1.12u w=0.74u l=0.13u
X269 VSS.t206 VDD VSS.t204 VSS.t205 sg13_lv_nmos ad=79.8f pd=0.8u as=0 ps=0 w=0.42u l=1u
X270 a_6635_949# a_6425_949# VDD VDD sg13_lv_pmos ad=0.2128p pd=1.5u as=0.252p ps=1.57u w=1.12u l=0.13u
X271 a_14888_949# DELAY_OUT_TAP14 VSS.t328 VSS.t327 sg13_lv_nmos ad=0.1406p pd=1.12u as=0.2516p ps=2.16u w=0.74u l=0.13u
X272 a_16108_194# a_3747_216.t2 a_25630_949# VSS.t156 sg13_lv_nmos ad=0.2516p pd=2.16u as=0.2516p ps=2.16u w=0.74u l=0.13u
X273 VSS.t271 VDD VSS.t269 VSS.t270 sg13_lv_nmos ad=79.8f pd=0.8u as=0 ps=0 w=0.42u l=1u
X274 a_4350_949# a_5191_913# a_5115_949# VDD sg13_lv_pmos ad=0.3808p pd=2.92u as=0.2128p ps=1.5u w=1.12u l=0.13u
X275 VDD MUX_SEL3 a_3449_236# VDD sg13_lv_pmos ad=0.1918p pd=1.5u as=0.1596p ps=1.22u w=0.84u l=0.13u
X276 VSS.t320 DELAY_OUT_TAP7 a_9465_949# VSS.t323 sg13_lv_nmos ad=0.1665p pd=1.19u as=0.2516p ps=2.16u w=0.74u l=0.13u
X277 a_4350_949# a_6711_913# a_6635_949# VDD sg13_lv_pmos ad=0.3808p pd=2.92u as=0.2128p ps=1.5u w=1.12u l=0.13u
X278 VSS.t274 VDD VSS.t273 VSS.t272 sg13_lv_nmos ad=0.1428p pd=1.52u as=0 ps=0 w=0.42u l=1u
X279 VSS.t60 a_2019_952.t5 a_16484_913# VSS.t59 sg13_lv_nmos ad=0.2516p pd=2.16u as=0.2516p ps=2.16u w=0.74u l=0.13u
X280 VSS.t2 a_3171_952.t9 a_5844_913# VSS.t1 sg13_lv_nmos ad=0.2516p pd=2.16u as=0.2516p ps=2.16u w=0.74u l=0.13u
X281 VDD a_2595_216.t2 a_20905_424# VDD sg13_lv_pmos ad=0.3808p pd=2.92u as=0.3808p ps=2.92u w=1.12u l=0.13u
X282 VSS.t45 a_2595_952.t7 a_11271_913# VSS.t44 sg13_lv_nmos ad=0.2516p pd=2.16u as=0.2516p ps=2.16u w=0.74u l=0.13u
X283 VSS.t155 a_3747_952.t8 a_9751_913# VSS.t154 sg13_lv_nmos ad=0.2516p pd=2.16u as=0.2516p ps=2.16u w=0.74u l=0.13u
X284 a_1256_949# MUX_SEL0 VDD VDD sg13_lv_pmos ad=0.3808p pd=2.92u as=0.3808p ps=2.92u w=1.12u l=0.13u
X285 a_2391_236# MUX_SEL2 a_2297_236# VSS.t66 sg13_lv_nmos ad=0.1216p pd=1.02u as=0.2176p ps=1.96u w=0.64u l=0.13u
X286 a_2967_236# MUX_SEL3 a_2873_236# VSS.t87 sg13_lv_nmos ad=0.1216p pd=1.02u as=0.2176p ps=1.96u w=0.64u l=0.13u
X287 VDD DELAY_OUT_TAP31 a_27705_949# VDD sg13_lv_pmos ad=0.252p pd=1.57u as=0.3808p ps=2.92u w=1.12u l=0.13u
X288 VDD DELAY_OUT_TAP25 a_23145_949# VDD sg13_lv_pmos ad=0.252p pd=1.57u as=0.3808p ps=2.92u w=1.12u l=0.13u
X289 a_2595_952.t1 a_2297_1300# VDD VDD sg13_lv_pmos ad=0.2128p pd=1.5u as=0.1918p ps=1.5u w=1.12u l=0.13u
X290 VDD VSS.t370 VDD VDD sg13_lv_pmos ad=0.34p pd=2.68u as=0 ps=0 w=1u l=1u
X291 VDD a_2019_952.t7 a_10404_913# VDD sg13_lv_pmos ad=0.3808p pd=2.92u as=0.3808p ps=2.92u w=1.12u l=0.13u
X292 VDD a_2019_952.t4 a_19524_913# VDD sg13_lv_pmos ad=0.3808p pd=2.92u as=0.3808p ps=2.92u w=1.12u l=0.13u
X293 VDD VSS.t384 VDD VDD sg13_lv_pmos ad=0.34p pd=2.68u as=0 ps=0 w=1u l=1u
X294 a_20315_949# a_20105_949# VDD VDD sg13_lv_pmos ad=0.2128p pd=1.5u as=0.252p ps=1.57u w=1.12u l=0.13u
X295 a_1544_949# MUX_SEL1 VSS.t283 VSS.t282 sg13_lv_nmos ad=0.2516p pd=2.16u as=0.2516p ps=2.16u w=0.74u l=0.13u
X296 VDD VSS.t372 VDD VDD sg13_lv_pmos ad=0.34p pd=2.68u as=0 ps=0 w=1u l=1u
X297 a_13470_949# a_3747_952.t6 a_15755_949# VSS.t35 sg13_lv_nmos ad=0.2516p pd=2.16u as=0.1406p ps=1.12u w=0.74u l=0.13u
X298 VSS.t100 a_3449_1300# a_3747_952.t0 VSS.t99 sg13_lv_nmos ad=0.2812p pd=2.24u as=0.1406p ps=1.12u w=0.74u l=0.13u
X299 a_4350_949# a_2595_952.t9 a_5115_949# VSS.t338 sg13_lv_nmos ad=0.2516p pd=2.16u as=0.1406p ps=1.12u w=0.74u l=0.13u
X300 VDD a_1721_1300# a_2019_952.t1 VDD sg13_lv_pmos ad=0.4256p pd=3u as=0.2128p ps=1.5u w=1.12u l=0.13u
X301 VSS.t74 a_2595_952.t2 a_26471_913# VSS.t73 sg13_lv_nmos ad=0.2516p pd=2.16u as=0.2516p ps=2.16u w=0.74u l=0.13u
X302 VSS.t266 VDD VSS.t264 VSS.t265 sg13_lv_nmos ad=79.8f pd=0.8u as=0 ps=0 w=0.42u l=1u
X303 a_21835_949# a_21625_949# VDD VDD sg13_lv_pmos ad=0.2128p pd=1.5u as=0.252p ps=1.57u w=1.12u l=0.13u
X304 a_3543_1300# MUX_SEL0 a_3449_1300# VSS.t289 sg13_lv_nmos ad=0.1216p pd=1.02u as=0.2176p ps=1.96u w=0.64u l=0.13u
X305 VDD a_2297_1300# a_2595_952.t1 VDD sg13_lv_pmos ad=0.4256p pd=3u as=0.2128p ps=1.5u w=1.12u l=0.13u
X306 VSS.t172 DELAY_OUT_TAP17 a_17065_949# VSS.t311 sg13_lv_nmos ad=0.1665p pd=1.19u as=0.2516p ps=2.16u w=0.74u l=0.13u
X307 VDD VSS.t385 VDD VDD sg13_lv_pmos ad=0.19p pd=1.38u as=0 ps=0 w=1u l=1u
X308 VSS.t231 VDD VSS.t229 VSS.t230 sg13_lv_nmos ad=79.8f pd=0.8u as=0 ps=0 w=0.42u l=1u
X309 a_19550_949# a_20391_913# a_20315_949# VDD sg13_lv_pmos ad=0.3808p pd=2.92u as=0.2128p ps=1.5u w=1.12u l=0.13u
X310 VSS.t234 VDD VSS.t233 VSS.t232 sg13_lv_nmos ad=0.1428p pd=1.52u as=0 ps=0 w=0.42u l=1u
X311 a_1544_949# MUX_SEL1 VDD VDD sg13_lv_pmos ad=0.3808p pd=2.92u as=0.3808p ps=2.92u w=1.12u l=0.13u
X312 a_16108_194# a_26985_424# a_25630_949# VDD sg13_lv_pmos ad=0.3808p pd=2.92u as=0.3808p ps=2.92u w=1.12u l=0.13u
X313 a_19550_949# a_21911_913# a_21835_949# VDD sg13_lv_pmos ad=0.3808p pd=2.92u as=0.2128p ps=1.5u w=1.12u l=0.13u
X314 VDD a_3747_952.t6 a_15831_913# VDD sg13_lv_pmos ad=0.3808p pd=2.92u as=0.3808p ps=2.92u w=1.12u l=0.13u
X315 a_18795_949# a_18585_949# VSS.t167 VSS.t166 sg13_lv_nmos ad=0.1406p pd=1.12u as=0.1665p ps=1.19u w=0.74u l=0.13u
X316 a_25630_949# a_3171_952.t2 a_27048_949# VSS.t6 sg13_lv_nmos ad=0.2516p pd=2.16u as=0.1406p ps=1.12u w=0.74u l=0.13u
X317 VSS.t42 a_2595_952.t5 a_17351_913# VSS.t41 sg13_lv_nmos ad=0.2516p pd=2.16u as=0.2516p ps=2.16u w=0.74u l=0.13u
X318 a_4350_949# a_3171_952.t9 a_5768_949# VSS.t0 sg13_lv_nmos ad=0.2516p pd=2.16u as=0.1406p ps=1.12u w=0.74u l=0.13u
X319 VSS.t115 a_2019_216# a_17865_424# VSS.t114 sg13_lv_nmos ad=0.2516p pd=2.16u as=0.2516p ps=2.16u w=0.74u l=0.13u
X320 VSS.t69 a_1544_194# a_2391_236# VSS.t106 sg13_lv_nmos ad=0.1331p pd=1.12u as=0.1216p ps=1.02u w=0.64u l=0.13u
X321 VSS.t57 a_2019_952.t8 a_7364_913# VSS.t56 sg13_lv_nmos ad=0.2516p pd=2.16u as=0.2516p ps=2.16u w=0.74u l=0.13u
X322 VSS.t112 a_2019_216# a_5705_424# VSS.t111 sg13_lv_nmos ad=0.2516p pd=2.16u as=0.2516p ps=2.16u w=0.74u l=0.13u
X323 MUX_OUT a_16851_214# VDD VDD sg13_lv_pmos ad=0.2128p pd=1.5u as=0.2086p ps=1.5u w=1.12u l=0.13u
X324 a_22488_949# DELAY_OUT_TAP24 VSS.t15 VSS.t14 sg13_lv_nmos ad=0.1406p pd=1.12u as=0.2516p ps=2.16u w=0.74u l=0.13u
X325 VDD VSS.t387 VDD VDD sg13_lv_pmos ad=0.19p pd=1.38u as=0 ps=0 w=1u l=1u
X326 VDD VSS.t361 VDD VDD sg13_lv_pmos ad=0.19p pd=1.38u as=0 ps=0 w=1u l=1u
X327 a_16408_949# DELAY_OUT_TAP16 VDD VDD sg13_lv_pmos ad=0.2128p pd=1.5u as=0.3808p ps=2.92u w=1.12u l=0.13u
X328 a_13470_949# a_2019_952.t6 a_13368_949# VSS.t341 sg13_lv_nmos ad=0.2516p pd=2.16u as=0.1406p ps=1.12u w=0.74u l=0.13u
X329 a_15964_194# a_15765_368# a_5731_194# VSS.t356 sg13_lv_nmos ad=0.2183p pd=1.33u as=0.2516p ps=2.16u w=0.74u l=0.13u
X330 VDD a_2019_952.t2 a_25604_913# VDD sg13_lv_pmos ad=0.3808p pd=2.92u as=0.3808p ps=2.92u w=1.12u l=0.13u
X331 a_2595_952.t0 a_2297_1300# VSS.t314 VSS.t347 sg13_lv_nmos ad=0.1406p pd=1.12u as=0.1331p ps=1.12u w=0.74u l=0.13u
X332 a_17928_949# DELAY_OUT_TAP18 VDD VDD sg13_lv_pmos ad=0.2128p pd=1.5u as=0.3808p ps=2.92u w=1.12u l=0.13u
X333 VSS.t152 a_3171_952.t3 a_24084_913# VSS.t151 sg13_lv_nmos ad=0.2516p pd=2.16u as=0.2516p ps=2.16u w=0.74u l=0.13u
X334 VDD VSS.t360 VDD VDD sg13_lv_pmos ad=0.34p pd=2.68u as=0 ps=0 w=1u l=1u
X335 a_2297_236# MUX_SEL2 VDD VDD sg13_lv_pmos ad=0.1596p pd=1.22u as=0.2856p ps=2.36u w=0.84u l=0.13u
X336 a_1815_1300# a_1256_949# a_1721_1300# VSS.t303 sg13_lv_nmos ad=0.1216p pd=1.02u as=0.2176p ps=1.96u w=0.64u l=0.13u
X337 a_2873_236# MUX_SEL3 VDD VDD sg13_lv_pmos ad=0.1596p pd=1.22u as=0.2856p ps=2.36u w=0.84u l=0.13u
X338 VSS.t167 DELAY_OUT_TAP19 a_18585_949# VSS.t325 sg13_lv_nmos ad=0.1665p pd=1.19u as=0.2516p ps=2.16u w=0.74u l=0.13u
X339 VSS.t264 VDD VSS.t263 VSS.t262 sg13_lv_nmos ad=0.1428p pd=1.52u as=0 ps=0 w=0.42u l=1u
X340 a_7288_949# DELAY_OUT_TAP4 VDD VDD sg13_lv_pmos ad=0.2128p pd=1.5u as=0.3808p ps=2.92u w=1.12u l=0.13u
X341 VSS.t229 VDD VSS.t228 VSS.t227 sg13_lv_nmos ad=0.1428p pd=1.52u as=0 ps=0 w=0.42u l=1u
X342 VSS.t241 VDD VSS.t239 VSS.t240 sg13_lv_nmos ad=79.8f pd=0.8u as=0 ps=0 w=0.42u l=1u
X343 VSS.t337 a_3171_952.t6 a_14964_913# VSS.t336 sg13_lv_nmos ad=0.2516p pd=2.16u as=0.2516p ps=2.16u w=0.74u l=0.13u
X344 VDD a_2019_216# a_17865_424# VDD sg13_lv_pmos ad=0.3808p pd=2.92u as=0.3808p ps=2.92u w=1.12u l=0.13u
X345 VDD a_3747_952.t4 a_21911_913# VDD sg13_lv_pmos ad=0.3808p pd=2.92u as=0.3808p ps=2.92u w=1.12u l=0.13u
X346 a_11195_949# a_10985_949# VSS.t165 VSS.t164 sg13_lv_nmos ad=0.1406p pd=1.12u as=0.1665p ps=1.19u w=0.74u l=0.13u
X347 a_1721_1300# a_1256_949# VDD VDD sg13_lv_pmos ad=0.1596p pd=1.22u as=0.2856p ps=2.36u w=0.84u l=0.13u
X348 VDD a_16851_214# MUX_OUT VDD sg13_lv_pmos ad=0.7336p pd=3.55u as=0.2128p ps=1.5u w=1.12u l=0.13u
X349 VSS.t170 a_3171_216.t2 a_23945_424# VSS.t169 sg13_lv_nmos ad=0.2516p pd=2.16u as=0.2516p ps=2.16u w=0.74u l=0.13u
X350 a_22590_949# a_2595_952.t3 a_23355_949# VSS.t138 sg13_lv_nmos ad=0.2516p pd=2.16u as=0.1406p ps=1.12u w=0.74u l=0.13u
X351 VSS.t20 MUX_SEL4 a_15765_368# VSS.t19 sg13_lv_nmos ad=0.2516p pd=2.16u as=0.2516p ps=2.16u w=0.74u l=0.13u
X352 a_16510_949# a_16484_913# a_16408_949# VDD sg13_lv_pmos ad=0.3808p pd=2.92u as=0.2128p ps=1.5u w=1.12u l=0.13u
X353 VDD VSS.t363 VDD VDD sg13_lv_pmos ad=0.19p pd=1.38u as=0 ps=0 w=1u l=1u
X354 VDD DELAY_OUT_TAP9 a_10985_949# VDD sg13_lv_pmos ad=0.252p pd=1.57u as=0.3808p ps=2.92u w=1.12u l=0.13u
X355 VDD a_1544_949# a_1721_1300# VDD sg13_lv_pmos ad=0.1918p pd=1.5u as=0.1596p ps=1.22u w=0.84u l=0.13u
X356 VDD VSS.t377 VDD VDD sg13_lv_pmos ad=0.19p pd=1.38u as=0 ps=0 w=1u l=1u
X357 VDD a_2019_216# a_5705_424# VDD sg13_lv_pmos ad=0.3808p pd=2.92u as=0.3808p ps=2.92u w=1.12u l=0.13u
X358 VDD VSS.t376 VDD VDD sg13_lv_pmos ad=0.34p pd=2.68u as=0 ps=0 w=1u l=1u
X359 VSS.t11 a_2019_952.t7 a_10404_913# VSS.t10 sg13_lv_nmos ad=0.2516p pd=2.16u as=0.2516p ps=2.16u w=0.74u l=0.13u
X360 VDD a_1544_194# a_2297_236# VDD sg13_lv_pmos ad=0.1918p pd=1.5u as=0.1596p ps=1.22u w=0.84u l=0.13u
X361 a_26395_949# a_26185_949# VSS.t13 VSS.t355 sg13_lv_nmos ad=0.1406p pd=1.12u as=0.1665p ps=1.19u w=0.74u l=0.13u
X362 VSS.t221 VDD VSS.t219 VSS.t220 sg13_lv_nmos ad=79.8f pd=0.8u as=0 ps=0 w=0.42u l=1u
X363 VSS.t51 a_3747_952.t3 a_24951_913# VSS.t50 sg13_lv_nmos ad=0.2516p pd=2.16u as=0.2516p ps=2.16u w=0.74u l=0.13u
X364 a_18795_949# a_18585_949# VDD VDD sg13_lv_pmos ad=0.2128p pd=1.5u as=0.252p ps=1.57u w=1.12u l=0.13u
X365 a_14235_949# a_14025_949# VDD VDD sg13_lv_pmos ad=0.2128p pd=1.5u as=0.252p ps=1.57u w=1.12u l=0.13u
X366 VDD DELAY_OUT_TAP3 a_6425_949# VDD sg13_lv_pmos ad=0.252p pd=1.57u as=0.3808p ps=2.92u w=1.12u l=0.13u
X367 a_7390_949# a_7364_913# a_7288_949# VDD sg13_lv_pmos ad=0.3808p pd=2.92u as=0.2128p ps=1.5u w=1.12u l=0.13u
X368 a_24008_949# DELAY_OUT_TAP26 VSS.t76 VSS.t75 sg13_lv_nmos ad=0.1406p pd=1.12u as=0.2516p ps=2.16u w=0.74u l=0.13u
X369 a_15964_194# MUX_SEL4 a_5731_194# VDD sg13_lv_pmos ad=0.3304p pd=1.71u as=0.3808p ps=2.92u w=1.12u l=0.13u
X370 a_1256_949# MUX_SEL0 VSS.t287 VSS.t286 sg13_lv_nmos ad=0.2516p pd=2.16u as=0.2516p ps=2.16u w=0.74u l=0.13u
X371 a_22488_949# DELAY_OUT_TAP24 VDD VDD sg13_lv_pmos ad=0.2128p pd=1.5u as=0.3808p ps=2.92u w=1.12u l=0.13u
X372 a_16510_949# a_18871_913# a_18795_949# VDD sg13_lv_pmos ad=0.3808p pd=2.92u as=0.2128p ps=1.5u w=1.12u l=0.13u
X373 a_27048_949# DELAY_OUT_TAP30 VDD VDD sg13_lv_pmos ad=0.2128p pd=1.5u as=0.3808p ps=2.92u w=1.12u l=0.13u
X374 a_13470_949# a_14311_913# a_14235_949# VDD sg13_lv_pmos ad=0.3808p pd=2.92u as=0.2128p ps=1.5u w=1.12u l=0.13u
X375 a_13470_949# a_3171_952.t6 a_14888_949# VSS.t335 sg13_lv_nmos ad=0.2516p pd=2.16u as=0.1406p ps=1.12u w=0.74u l=0.13u
X376 a_1256_194# MUX_SEL2 VSS.t65 VSS.t64 sg13_lv_nmos ad=0.2516p pd=2.16u as=0.2516p ps=2.16u w=0.74u l=0.13u
X377 a_9675_949# a_9465_949# VDD VDD sg13_lv_pmos ad=0.2128p pd=1.5u as=0.252p ps=1.57u w=1.12u l=0.13u
X378 VSS.t121 a_2019_952.t2 a_25604_913# VSS.t120 sg13_lv_nmos ad=0.2516p pd=2.16u as=0.2516p ps=2.16u w=0.74u l=0.13u
X379 a_16108_194# MUX_SEL4 a_15964_194# VSS.t18 sg13_lv_nmos ad=0.2516p pd=2.16u as=0.2183p ps=1.33u w=0.74u l=0.13u
X380 a_21835_949# a_21625_949# VSS.t27 VSS.t96 sg13_lv_nmos ad=0.1406p pd=1.12u as=0.1665p ps=1.19u w=0.74u l=0.13u
X381 VSS.t137 a_2595_952.t4 a_20391_913# VSS.t136 sg13_lv_nmos ad=0.2516p pd=2.16u as=0.2516p ps=2.16u w=0.74u l=0.13u
X382 a_2019_952.t1 a_1721_1300# VDD VDD sg13_lv_pmos ad=0.2128p pd=1.5u as=0.1918p ps=1.5u w=1.12u l=0.13u
X383 VSS.t165 DELAY_OUT_TAP9 a_10985_949# VSS.t302 sg13_lv_nmos ad=0.1665p pd=1.19u as=0.2516p ps=2.16u w=0.74u l=0.13u
X384 a_7390_949# a_9751_913# a_9675_949# VDD sg13_lv_pmos ad=0.3808p pd=2.92u as=0.2128p ps=1.5u w=1.12u l=0.13u
X385 VSS.t239 VDD VSS.t238 VSS.t237 sg13_lv_nmos ad=0.1428p pd=1.52u as=0 ps=0 w=0.42u l=1u
X386 VDD a_3171_216.t2 a_23945_424# VDD sg13_lv_pmos ad=0.3808p pd=2.92u as=0.3808p ps=2.92u w=1.12u l=0.13u
X387 VSS.t143 a_3747_952.t5 a_18871_913# VSS.t142 sg13_lv_nmos ad=0.2516p pd=2.16u as=0.2516p ps=2.16u w=0.74u l=0.13u
X388 a_12715_949# a_12505_949# VSS.t174 VSS.t173 sg13_lv_nmos ad=0.1406p pd=1.12u as=0.1665p ps=1.19u w=0.74u l=0.13u
X389 a_17928_949# DELAY_OUT_TAP18 VSS.t316 VSS.t315 sg13_lv_nmos ad=0.1406p pd=1.12u as=0.2516p ps=2.16u w=0.74u l=0.13u
X390 VDD MUX_SEL4 a_15765_368# VDD sg13_lv_pmos ad=0.3808p pd=2.92u as=0.3808p ps=2.92u w=1.12u l=0.13u
X391 a_19550_949# a_3171_952.t4 a_20968_949# VSS.t61 sg13_lv_nmos ad=0.2516p pd=2.16u as=0.1406p ps=1.12u w=0.74u l=0.13u
X392 a_7288_949# DELAY_OUT_TAP4 VSS.t177 VSS.t176 sg13_lv_nmos ad=0.1406p pd=1.12u as=0.2516p ps=2.16u w=0.74u l=0.13u
X393 a_1815_236# a_1256_194# a_1721_236# VSS.t108 sg13_lv_nmos ad=0.1216p pd=1.02u as=0.2176p ps=1.96u w=0.64u l=0.13u
X394 a_1544_194# MUX_SEL3 VSS.t86 VSS.t85 sg13_lv_nmos ad=0.2516p pd=2.16u as=0.2516p ps=2.16u w=0.74u l=0.13u
X395 a_22590_949# a_3747_952.t3 a_24875_949# VSS.t49 sg13_lv_nmos ad=0.2516p pd=2.16u as=0.1406p ps=1.12u w=0.74u l=0.13u
X396 VDD DELAY_OUT_TAP23 a_21625_949# VDD sg13_lv_pmos ad=0.252p pd=1.57u as=0.3808p ps=2.92u w=1.12u l=0.13u
X397 a_22590_949# a_22564_913# a_22488_949# VDD sg13_lv_pmos ad=0.3808p pd=2.92u as=0.2128p ps=1.5u w=1.12u l=0.13u
X398 VSS.t13 DELAY_OUT_TAP29 a_26185_949# VSS.t12 sg13_lv_nmos ad=0.1665p pd=1.19u as=0.2516p ps=2.16u w=0.74u l=0.13u
X399 VSS.t209 VDD VSS.t208 VSS.t207 sg13_lv_nmos ad=0.1428p pd=1.52u as=0 ps=0 w=0.42u l=1u
X400 VDD DELAY_OUT_TAP29 a_26185_949# VDD sg13_lv_pmos ad=0.252p pd=1.57u as=0.3808p ps=2.92u w=1.12u l=0.13u
X401 VSS.t95 DELAY_OUT_TAP1 a_4905_949# VSS.t189 sg13_lv_nmos ad=0.1665p pd=1.19u as=0.2516p ps=2.16u w=0.74u l=0.13u
X402 a_25630_949# a_27124_913# a_27048_949# VDD sg13_lv_pmos ad=0.3808p pd=2.92u as=0.2128p ps=1.5u w=1.12u l=0.13u
X403 VDD VSS.t364 VDD VDD sg13_lv_pmos ad=0.34p pd=2.68u as=0 ps=0 w=1u l=1u
X404 VDD a_2019_952.t6 a_13444_913# VDD sg13_lv_pmos ad=0.3808p pd=2.92u as=0.3808p ps=2.92u w=1.12u l=0.13u
X405 VSS.t146 a_3171_952.t8 a_8884_913# VSS.t145 sg13_lv_nmos ad=0.2516p pd=2.16u as=0.2516p ps=2.16u w=0.74u l=0.13u
X406 VDD VSS.t378 VDD VDD sg13_lv_pmos ad=0.34p pd=2.68u as=0 ps=0 w=1u l=1u
X407 VDD VSS.t373 VDD VDD sg13_lv_pmos ad=0.19p pd=1.38u as=0 ps=0 w=1u l=1u
X408 VSS.t91 a_1544_194# a_1815_236# VSS.t107 sg13_lv_nmos ad=0.1331p pd=1.12u as=0.1216p ps=1.02u w=0.64u l=0.13u
X409 VDD a_3171_952.t5 a_18004_913# VDD sg13_lv_pmos ad=0.3808p pd=2.92u as=0.3808p ps=2.92u w=1.12u l=0.13u
X410 VSS.t98 MUX_SEL1 a_3543_1300# VSS.t285 sg13_lv_nmos ad=0.1331p pd=1.12u as=0.1216p ps=1.02u w=0.64u l=0.13u
X411 a_27915_949# a_27705_949# VSS.t39 VSS.t175 sg13_lv_nmos ad=0.1406p pd=1.12u as=0.1665p ps=1.19u w=0.74u l=0.13u
X412 VSS.t281 VDD VSS.t279 VSS.t280 sg13_lv_nmos ad=79.8f pd=0.8u as=0 ps=0 w=0.42u l=1u
X413 a_24875_949# a_24665_949# VDD VDD sg13_lv_pmos ad=0.2128p pd=1.5u as=0.252p ps=1.57u w=1.12u l=0.13u
C0 a_5705_424# a_4350_949# 0.02005f
C1 VDD DELAY_OUT_TAP31 0.1288f
C2 a_11924_913# DELAY_OUT_TAP10 0.02312f
C3 a_15831_913# DELAY_OUT_TAP16 0.02339f
C4 VDD a_25528_949# 0.17274f
C5 VDD a_19524_913# 0.28633f
C6 MUX_SEL4 DELAY_OUT_TAP4 0.0195f
C7 a_23431_913# DELAY_OUT_TAP26 0.02334f
C8 a_1256_194# a_2019_216# 0.02904f
C9 VDD a_4905_949# 0.3005f
C10 a_1256_194# a_1721_236# 0.13421f
C11 VDD a_13470_949# 0.87936f
C12 MUX_SEL2 MUX_SEL0 0.01204f
C13 MUX_SEL4 a_3449_236# 0.05166f
C14 a_16510_949# DELAY_OUT_TAP19 0.05189f
C15 VDD a_27048_949# 0.17499f
C16 a_19524_913# a_19550_949# 0.277f
C17 DELAY_OUT_TAP7 DELAY_OUT_TAP6 0.03717f
C18 a_16108_194# a_20905_424# 0.2906f
C19 VDD a_13368_949# 0.17274f
C20 a_21625_949# a_21911_913# 0.01885f
C21 a_16108_194# a_16851_214# 0.06181f
C22 VDD a_10404_913# 0.28633f
C23 a_6711_913# a_4350_949# 0.26208f
C24 MUX_OUT a_1544_949# 0.04258f
C25 a_19524_913# a_19448_949# 0.01176f
C26 VDD a_10328_949# 0.17274f
C27 a_23945_424# VDD 0.29292f
C28 VDD a_21835_949# 0.15406f
C29 a_12505_949# DELAY_OUT_TAP11 0.2079f
C30 a_1256_949# MUX_SEL0 0.3314f
C31 DELAY_OUT_TAP28 VDD 0.14794f
C32 a_1544_949# a_1721_1300# 0.38063f
C33 a_22590_949# a_24875_949# 0.39036f
C34 DELAY_OUT_TAP24 a_21911_913# 0.02339f
C35 a_16408_949# a_16510_949# 0.37183f
C36 a_9465_949# DELAY_OUT_TAP7 0.2079f
C37 VDD a_21044_913# 0.28225f
C38 a_3449_236# a_2019_216# 0.01176f
C39 a_19550_949# a_21835_949# 0.39036f
C40 a_4157_1218# a_4248_949# 0.11672f
C41 VDD a_13444_913# 0.28633f
C42 a_6635_949# a_6425_949# 0.09424f
C43 VDD a_24008_949# 0.17499f
C44 MUX_OUT a_15964_194# 0.01307f
C45 VDD a_2297_1300# 0.4651f
C46 DELAY_OUT_TAP1 DELAY_OUT_TAP2 0.02068f
C47 a_16510_949# a_16484_913# 0.277f
C48 a_5731_194# MUX_SEL4 4.60702f
C49 a_11195_949# a_11271_913# 0.01194f
C50 a_19550_949# a_21044_913# 0.28279f
C51 a_17275_949# a_17351_913# 0.01194f
C52 a_20105_949# DELAY_OUT_TAP21 0.19203f
C53 DELAY_OUT_TAP27 a_24665_949# 0.2079f
C54 a_24084_913# a_22590_949# 0.28279f
C55 MUX_SEL4 a_2019_216# 0.90276f
C56 DELAY_OUT_TAP3 DELAY_OUT_TAP4 0.0331f
C57 a_15964_194# DELAY_OUT_TAP16 0.02f
C58 MUX_OUT a_1544_194# 0.69943f
C59 MUX_SEL4 a_1721_236# 0.05813f
C60 a_21625_949# DELAY_OUT_TAP23 0.2079f
C61 VDD a_8155_949# 0.15389f
C62 a_14888_949# a_13470_949# 0.38994f
C63 a_2297_1300# MUX_SEL1 0.01995f
C64 DELAY_OUT_TAP4 a_4350_949# 0.02437f
C65 VDD DELAY_OUT_TAP2 0.13878f
C66 DELAY_OUT_TAP1 a_4157_1218# 0.01771f
C67 a_15545_949# a_13470_949# 0.03208f
C68 a_18004_913# DELAY_OUT_TAP19 0.02053f
C69 a_5768_949# a_4350_949# 0.38994f
C70 a_4350_949# a_4324_913# 0.277f
C71 DELAY_OUT_TAP23 DELAY_OUT_TAP24 0.0331f
C72 a_5731_194# a_2019_216# 1.15781f
C73 a_13368_949# DELAY_OUT_TAP12 0.10864f
C74 a_8155_949# a_7390_949# 0.39037f
C75 a_11848_949# DELAY_OUT_TAP10 0.10863f
C76 MUX_SEL4 a_14825_424# 0.03307f
C77 a_1721_236# a_2019_216# 0.18452f
C78 VDD a_15755_949# 0.15389f
C79 DELAY_OUT_TAP18 DELAY_OUT_TAP19 0.03717f
C80 a_6425_949# DELAY_OUT_TAP3 0.2079f
C81 MUX_OUT MUX_SEL2 0.08497f
C82 VDD a_20905_424# 0.29292f
C83 a_17351_913# a_16510_949# 0.28268f
C84 VDD a_4157_1218# 0.48906f
C85 VDD a_16851_214# 0.51536f
C86 a_1256_194# a_1544_194# 1.25711f
C87 MUX_SEL4 a_4350_949# 0.31434f
C88 VDD a_14964_913# 0.28225f
C89 a_6425_949# a_4350_949# 0.03208f
C90 a_17275_949# a_16510_949# 0.39037f
C91 a_14235_949# a_14311_913# 0.01194f
C92 VDD a_26471_913# 0.28336f
C93 a_26395_949# a_25630_949# 0.39037f
C94 a_5731_194# a_14825_424# 0.28056f
C95 VDD a_16108_194# 1.25759f
C96 a_13444_913# DELAY_OUT_TAP12 0.02011f
C97 a_20105_949# a_20391_913# 0.01885f
C98 a_16108_194# a_17865_424# 0.29564f
C99 a_19550_949# a_20905_424# 0.02165f
C100 a_11271_913# DELAY_OUT_TAP10 0.02334f
C101 a_14235_949# a_14025_949# 0.09424f
C102 MUX_OUT a_1256_949# 0.02466f
C103 VDD a_10430_949# 0.88416f
C104 DELAY_OUT_TAP14 a_13470_949# 0.07996f
C105 MUX_SEL4 a_1544_949# 0.03407f
C106 a_6635_949# a_4350_949# 0.39036f
C107 a_2019_216# a_16510_949# 0.03139f
C108 a_26185_949# DELAY_OUT_TAP29 0.19203f
C109 VDD a_9751_913# 0.2822f
C110 a_19524_913# DELAY_OUT_TAP20 0.02011f
C111 a_5731_194# a_4350_949# 0.41099f
C112 VDD a_24665_949# 0.29646f
C113 DELAY_OUT_TAP27 VDD 0.12759f
C114 a_16510_949# a_18871_913# 0.26208f
C115 a_1256_949# a_1721_1300# 0.13421f
C116 a_19550_949# a_16108_194# 0.58202f
C117 a_23945_424# a_22590_949# 0.02165f
C118 a_4350_949# a_2019_216# 0.02042f
C119 a_1256_194# MUX_SEL2 0.33134f
C120 DELAY_OUT_TAP28 a_22590_949# 0.02437f
C121 DELAY_OUT_TAP7 a_8884_913# 0.02053f
C122 a_27991_913# a_27705_949# 0.01885f
C123 VDD a_4248_949# 0.17587f
C124 a_9751_913# a_7390_949# 0.26208f
C125 a_5115_949# a_5191_913# 0.01194f
C126 a_18585_949# DELAY_OUT_TAP19 0.2079f
C127 MUX_SEL4 a_15964_194# 0.5544f
C128 DELAY_OUT_TAP25 DELAY_OUT_TAP24 0.06596f
C129 a_1256_949# a_2873_1300# 0.28892f
C130 a_4350_949# a_5191_913# 0.28268f
C131 DELAY_OUT_TAP8 MUX_SEL4 0.01829f
C132 a_24008_949# a_22590_949# 0.38994f
C133 MUX_SEL4 a_1544_194# 0.47529f
C134 a_7945_949# a_8155_949# 0.09424f
C135 VDD a_7364_913# 0.28633f
C136 DELAY_OUT_TAP0 a_3449_236# 0.01017f
C137 a_15755_949# a_15545_949# 0.09424f
C138 a_14311_913# a_13470_949# 0.28268f
C139 a_4350_949# a_5115_949# 0.39037f
C140 a_2297_1300# MUX_SEL0 0.10655f
C141 a_14964_913# a_14888_949# 0.01176f
C142 a_5731_194# a_15964_194# 0.2778f
C143 DELAY_OUT_TAP3 a_4350_949# 0.05189f
C144 VDD DELAY_OUT_TAP1 0.13941f
C145 MUX_SEL2 a_3449_236# 0.10741f
C146 a_14025_949# a_13470_949# 0.03209f
C147 a_15964_194# a_2019_216# 0.02413f
C148 a_17351_913# DELAY_OUT_TAP18 0.02334f
C149 a_7364_913# a_7390_949# 0.277f
C150 MUX_OUT MUX_SEL3 0.79533f
C151 MUX_SEL4 DELAY_OUT_TAP0 0.06593f
C152 DELAY_OUT_TAP16 DELAY_OUT_TAP17 0.06596f
C153 a_10430_949# DELAY_OUT_TAP12 0.02437f
C154 DELAY_OUT_TAP30 a_27124_913# 0.02312f
C155 MUX_OUT a_2297_236# 0.01179f
C156 MUX_SEL4 a_11785_424# 0.03255f
C157 a_3449_1300# VDD 0.46654f
C158 a_1544_194# a_2019_216# 0.01747f
C159 a_7364_913# a_7288_949# 0.01176f
C160 a_1544_194# a_1721_236# 0.36963f
C161 DELAY_OUT_TAP30 a_25630_949# 0.07996f
C162 MUX_SEL4 MUX_SEL2 0.01978f
C163 VDD a_17865_424# 0.29444f
C164 DELAY_OUT_TAP31 DELAY_OUT_TAP30 0.03717f
C165 a_18795_949# a_18871_913# 0.01194f
C166 VDD a_22564_913# 0.28633f
C167 a_3449_1300# MUX_SEL1 0.29404f
C168 a_15964_194# a_16510_949# 0.05416f
C169 a_9465_949# a_9751_913# 0.01885f
C170 a_25604_913# a_25630_949# 0.277f
C171 a_5731_194# a_11785_424# 0.28056f
C172 VDD MUX_SEL1 0.49936f
C173 VDD a_19550_949# 0.89766f
C174 DELAY_OUT_TAP22 a_21044_913# 0.02312f
C175 a_16510_949# a_18004_913# 0.28279f
C176 VDD a_7390_949# 0.8686f
C177 a_1256_194# a_2873_236# 0.27926f
C178 DELAY_OUT_TAP13 a_13470_949# 0.10838f
C179 MUX_SEL4 a_1256_949# 0.04908f
C180 DELAY_OUT_TAP14 a_14964_913# 0.02312f
C181 a_25604_913# a_25528_949# 0.01176f
C182 DELAY_OUT_TAP25 DELAY_OUT_TAP26 0.02068f
C183 a_16108_194# a_22590_949# 0.58202f
C184 VDD a_19448_949# 0.17274f
C185 VDD a_23145_949# 0.30333f
C186 a_13470_949# DELAY_OUT_TAP16 0.02437f
C187 a_1256_194# MUX_SEL3 1.41161f
C188 a_16510_949# a_18795_949# 0.39036f
C189 a_20315_949# a_20391_913# 0.01194f
C190 VDD a_7288_949# 0.17274f
C191 DELAY_OUT_TAP30 a_27048_949# 0.10863f
C192 a_1256_194# a_2297_236# 0.04261f
C193 MUX_SEL2 a_1721_236# 0.01315f
C194 a_16510_949# DELAY_OUT_TAP18 0.07996f
C195 a_16484_913# DELAY_OUT_TAP17 0.0501f
C196 a_12791_913# a_12505_949# 0.01885f
C197 a_24665_949# a_22590_949# 0.03208f
C198 DELAY_OUT_TAP27 a_22590_949# 0.05189f
C199 a_19448_949# a_19550_949# 0.37183f
C200 a_16108_194# DELAY_OUT_TAP20 0.0157f
C201 a_26395_949# a_26471_913# 0.01194f
C202 a_17351_913# a_17065_949# 0.01885f
C203 MUX_SEL4 a_15765_368# 0.65508f
C204 a_7288_949# a_7390_949# 0.37183f
C205 a_17275_949# a_17065_949# 0.09424f
C206 DELAY_OUT_TAP2 a_5844_913# 0.02312f
C207 VDD a_14888_949# 0.17499f
C208 a_13444_913# DELAY_OUT_TAP13 0.0501f
C209 a_20105_949# a_20315_949# 0.09424f
C210 DELAY_OUT_TAP28 a_25604_913# 0.02011f
C211 VDD DELAY_OUT_TAP6 0.13878f
C212 VDD DELAY_OUT_TAP12 0.1474f
C213 MUX_SEL3 a_3449_236# 0.28429f
C214 a_12715_949# a_12791_913# 0.01194f
C215 a_18585_949# a_18871_913# 0.01885f
C216 VDD a_15545_949# 0.29842f
C217 a_5731_194# a_15765_368# 0.23301f
C218 a_20968_949# a_21044_913# 0.01176f
C219 a_10985_949# a_11271_913# 0.01885f
C220 DELAY_OUT_TAP21 a_19524_913# 0.0501f
C221 a_15765_368# a_2019_216# 0.05969f
C222 MUX_SEL4 a_2873_236# 0.04916f
C223 a_10985_949# a_11195_949# 0.09424f
C224 a_7390_949# DELAY_OUT_TAP6 0.07996f
C225 VDD a_9465_949# 0.29646f
C226 MUX_SEL4 MUX_SEL3 0.75489f
C227 a_18585_949# a_16510_949# 0.03208f
C228 a_10430_949# DELAY_OUT_TAP11 0.05189f
C229 MUX_SEL4 a_2297_236# 0.04338f
C230 a_21625_949# a_21835_949# 0.09424f
C231 DELAY_OUT_TAP9 DELAY_OUT_TAP10 0.02068f
C232 VDD a_7945_949# 0.30333f
C233 DELAY_OUT_TAP29 a_25630_949# 0.10838f
C234 a_17065_949# a_16510_949# 0.03209f
C235 a_18004_913# DELAY_OUT_TAP18 0.02312f
C236 a_9751_913# a_9675_949# 0.01194f
C237 a_10430_949# a_11924_913# 0.28279f
C238 a_9465_949# a_7390_949# 0.03208f
C239 a_24084_913# DELAY_OUT_TAP26 0.02312f
C240 VDD a_22590_949# 0.89557f
C241 a_27991_913# a_27915_949# 0.01194f
C242 a_3449_1300# MUX_SEL0 0.10753f
C243 a_1256_949# a_1544_949# 1.26509f
C244 MUX_OUT a_16851_214# 0.45865f
C245 VDD DELAY_OUT_TAP14 0.13878f
C246 MUX_SEL4 a_13470_949# 0.256f
C247 VDD MUX_SEL0 0.51342f
C248 a_7945_949# a_7390_949# 0.03209f
C249 a_16510_949# a_17928_949# 0.38994f
C250 MUX_SEL3 a_2019_216# 0.06209f
C251 a_22590_949# a_22564_913# 0.277f
C252 a_2019_216# a_2297_236# 0.04011f
C253 MUX_OUT a_16108_194# 0.24265f
C254 a_13470_949# DELAY_OUT_TAP15 0.05189f
C255 a_27991_913# a_25630_949# 0.26208f
C256 VDD DELAY_OUT_TAP20 0.14794f
C257 a_7364_913# DELAY_OUT_TAP5 0.0501f
C258 DELAY_OUT_TAP30 a_26471_913# 0.02334f
C259 VDD a_26395_949# 0.15389f
C260 MUX_SEL2 a_1544_194# 0.07405f
C261 MUX_SEL0 MUX_SEL1 3.14917f
C262 a_12715_949# a_12505_949# 0.09424f
C263 a_5731_194# a_13470_949# 0.41365f
C264 a_16510_949# DELAY_OUT_TAP17 0.10838f
C265 a_24875_949# a_24951_913# 0.01194f
C266 a_23145_949# a_22590_949# 0.03209f
C267 DELAY_OUT_TAP8 DELAY_OUT_TAP9 0.06596f
C268 a_27705_949# a_27915_949# 0.09424f
C269 DELAY_OUT_TAP28 DELAY_OUT_TAP29 0.06596f
C270 a_19448_949# DELAY_OUT_TAP20 0.10864f
C271 DELAY_OUT_TAP2 a_5768_949# 0.10863f
C272 a_27705_949# a_25630_949# 0.03208f
C273 a_15831_913# a_13470_949# 0.26208f
C274 VDD a_14311_913# 0.28336f
C275 a_4905_949# a_5191_913# 0.01885f
C276 VDD DELAY_OUT_TAP5 0.13651f
C277 a_21835_949# a_21911_913# 0.01194f
C278 VDD DELAY_OUT_TAP11 0.12759f
C279 a_18585_949# a_18795_949# 0.09424f
C280 a_15765_368# a_15964_194# 0.061f
C281 a_27705_949# DELAY_OUT_TAP31 0.2079f
C282 VDD a_14025_949# 0.30333f
C283 a_26185_949# a_25630_949# 0.03209f
C284 a_4905_949# a_5115_949# 0.09424f
C285 VDD DELAY_OUT_TAP22 0.13878f
C286 a_14825_424# a_13470_949# 0.02058f
C287 DELAY_OUT_TAP14 a_14888_949# 0.10863f
C288 VDD a_9675_949# 0.15406f
C289 VDD a_5844_913# 0.28225f
C290 VDD a_11924_913# 0.28225f
C291 a_7390_949# DELAY_OUT_TAP5 0.10838f
C292 a_17928_949# a_18004_913# 0.01176f
C293 VDD a_5705_424# 0.29556f
C294 DELAY_OUT_TAP7 DELAY_OUT_TAP8 0.0331f
C295 a_4157_1218# a_4324_913# 0.02463f
C296 a_4905_949# a_4350_949# 0.03209f
C297 VDD a_8884_913# 0.28225f
C298 DELAY_OUT_TAP22 a_19550_949# 0.07996f
C299 a_16108_194# DELAY_OUT_TAP24 0.0157f
C300 a_7390_949# a_9675_949# 0.39036f
C301 a_17928_949# DELAY_OUT_TAP18 0.10863f
C302 a_24008_949# DELAY_OUT_TAP26 0.10863f
C303 a_10430_949# a_11848_949# 0.38994f
C304 VDD MUX_OUT 0.35871f
C305 MUX_SEL4 a_4157_1218# 0.08229f
C306 a_7390_949# a_8884_913# 0.28279f
C307 VDD DELAY_OUT_TAP13 0.13651f
C308 VDD a_1721_1300# 0.45305f
C309 VDD DELAY_OUT_TAP30 0.13878f
C310 VDD DELAY_OUT_TAP16 0.14932f
C311 DELAY_OUT_TAP17 DELAY_OUT_TAP18 0.02068f
C312 MUX_SEL3 a_1544_194# 0.15976f
C313 a_21044_913# DELAY_OUT_TAP23 0.02053f
C314 MUX_SEL4 a_16108_194# 0.1283f
C315 a_6711_913# VDD 0.2822f
C316 MUX_OUT MUX_SEL1 0.09357f
C317 a_1544_194# a_2297_236# 0.27303f
C318 VDD DELAY_OUT_TAP19 0.12759f
C319 VDD a_23431_913# 0.28336f
C320 a_8745_424# VDD 0.29292f
C321 a_14964_913# DELAY_OUT_TAP15 0.02053f
C322 a_4248_949# a_4324_913# 0.01176f
C323 DELAY_OUT_TAP5 DELAY_OUT_TAP6 0.02068f
C324 MUX_SEL4 a_10430_949# 0.24983f
C325 VDD a_25604_913# 0.28633f
C326 DELAY_OUT_TAP11 DELAY_OUT_TAP12 0.0331f
C327 VDD a_20968_949# 0.17499f
C328 a_10430_949# a_11271_913# 0.28268f
C329 DELAY_OUT_TAP2 a_5191_913# 0.02334f
C330 VDD a_22488_949# 0.17274f
C331 VDD a_23355_949# 0.15389f
C332 DELAY_OUT_TAP4 a_7364_913# 0.02011f
C333 VDD a_2873_1300# 0.46491f
C334 a_4157_1218# a_2019_216# 0.01018f
C335 DELAY_OUT_TAP28 a_24951_913# 0.02339f
C336 a_2019_216# a_16851_214# 0.01299f
C337 a_5731_194# a_16108_194# 0.01334f
C338 a_1256_194# VDD 0.40292f
C339 a_10430_949# a_11195_949# 0.39037f
C340 MUX_SEL2 a_2873_236# 0.01422f
C341 a_10985_949# DELAY_OUT_TAP9 0.19203f
C342 a_22564_913# a_22488_949# 0.01176f
C343 a_8745_424# a_7390_949# 0.01756f
C344 DELAY_OUT_TAP2 DELAY_OUT_TAP3 0.03717f
C345 a_15831_913# a_15755_949# 0.01194f
C346 a_19550_949# a_20968_949# 0.38994f
C347 a_5731_194# a_10430_949# 0.41176f
C348 a_1544_949# a_2297_1300# 0.28651f
C349 a_8231_913# a_8155_949# 0.01194f
C350 VDD a_16408_949# 0.17274f
C351 a_2019_216# a_16108_194# 0.33889f
C352 MUX_SEL3 MUX_SEL2 3.21891f
C353 a_8884_913# DELAY_OUT_TAP6 0.02312f
C354 a_23145_949# a_23431_913# 0.01885f
C355 a_2873_1300# MUX_SEL1 0.13092f
C356 DELAY_OUT_TAP2 a_4350_949# 0.07996f
C357 DELAY_OUT_TAP8 a_10404_913# 0.02011f
C358 DELAY_OUT_TAP1 a_4324_913# 0.0501f
C359 MUX_SEL2 a_2297_236# 0.10655f
C360 DELAY_OUT_TAP8 a_10328_949# 0.10864f
C361 a_7945_949# DELAY_OUT_TAP5 0.19203f
C362 VDD a_21625_949# 0.29646f
C363 VDD a_16484_913# 0.28597f
C364 a_9465_949# a_9675_949# 0.09424f
C365 a_23145_949# a_23355_949# 0.09424f
C366 VDD DELAY_OUT_TAP4 0.14695f
C367 a_16510_949# a_16851_214# 0.02131f
C368 VDD DELAY_OUT_TAP21 0.13651f
C369 DELAY_OUT_TAP14 a_14311_913# 0.02334f
C370 DELAY_OUT_TAP13 DELAY_OUT_TAP12 0.06596f
C371 VDD a_4324_913# 0.28597f
C372 VDD a_5768_949# 0.17499f
C373 VDD a_11848_949# 0.17499f
C374 VDD DELAY_OUT_TAP24 0.14794f
C375 a_17065_949# DELAY_OUT_TAP17 0.19203f
C376 a_21625_949# a_19550_949# 0.03208f
C377 a_16510_949# a_16108_194# 0.56108f
C378 VDD a_3449_236# 0.46596f
C379 DELAY_OUT_TAP27 DELAY_OUT_TAP26 0.03717f
C380 a_4157_1218# a_4350_949# 0.04624f
C381 VDD a_8808_949# 0.17499f
C382 a_26985_424# a_25630_949# 0.02165f
C383 DELAY_OUT_TAP21 a_19550_949# 0.10838f
C384 DELAY_OUT_TAP24 a_22564_913# 0.02011f
C385 a_12791_913# a_10430_949# 0.26208f
C386 a_19550_949# DELAY_OUT_TAP24 0.02437f
C387 a_26185_949# a_26471_913# 0.01885f
C388 DELAY_OUT_TAP4 a_7288_949# 0.10864f
C389 a_8808_949# a_7390_949# 0.38994f
C390 VDD MUX_SEL4 2.63157f
C391 VDD a_6425_949# 0.29646f
C392 a_10404_913# DELAY_OUT_TAP9 0.0501f
C393 VDD a_11271_913# 0.28336f
C394 a_10430_949# DELAY_OUT_TAP10 0.07996f
C395 VDD a_17351_913# 0.28565f
C396 VDD DELAY_OUT_TAP29 0.13651f
C397 VDD DELAY_OUT_TAP15 0.12874f
C398 a_6635_949# VDD 0.15406f
C399 VDD a_11195_949# 0.15389f
C400 MUX_SEL4 MUX_SEL1 0.03574f
C401 VDD a_17275_949# 0.15389f
C402 a_25630_949# a_27915_949# 0.39036f
C403 a_4248_949# a_4350_949# 0.37183f
C404 a_5731_194# VDD 0.6143f
C405 MUX_SEL4 a_7390_949# 0.34655f
C406 DELAY_OUT_TAP13 DELAY_OUT_TAP14 0.02068f
C407 a_15964_194# a_16851_214# 0.16757f
C408 a_14311_913# a_14025_949# 0.01885f
C409 VDD a_20391_913# 0.28336f
C410 a_1721_1300# MUX_SEL0 0.01315f
C411 MUX_SEL3 a_2873_236# 0.12606f
C412 VDD a_21911_913# 0.2822f
C413 VDD a_2019_216# 1.43004f
C414 a_25630_949# a_27124_913# 0.28279f
C415 a_2019_216# a_17865_424# 0.13959f
C416 a_23431_913# a_22590_949# 0.28268f
C417 a_14235_949# a_13470_949# 0.39037f
C418 a_24665_949# a_24951_913# 0.01885f
C419 VDD a_1721_236# 0.45259f
C420 a_15964_194# a_16108_194# 0.42202f
C421 VDD a_18871_913# 0.2822f
C422 a_27991_913# VDD 0.28201f
C423 DELAY_OUT_TAP31 a_27124_913# 0.02053f
C424 a_22590_949# a_22488_949# 0.37183f
C425 MUX_SEL3 a_2297_236# 0.01595f
C426 a_5731_194# a_7390_949# 0.41331f
C427 a_19550_949# a_20391_913# 0.28268f
C428 a_23355_949# a_22590_949# 0.39037f
C429 a_11924_913# DELAY_OUT_TAP11 0.02053f
C430 a_8808_949# DELAY_OUT_TAP6 0.10863f
C431 a_1256_949# a_2297_1300# 0.04619f
C432 VDD a_15831_913# 0.2816f
C433 a_19550_949# a_21911_913# 0.26208f
C434 VDD DELAY_OUT_TAP26 0.13878f
C435 DELAY_OUT_TAP31 a_25630_949# 0.05211f
C436 a_25528_949# a_25630_949# 0.37183f
C437 DELAY_OUT_TAP19 DELAY_OUT_TAP20 0.0331f
C438 a_2873_1300# MUX_SEL0 0.01504f
C439 DELAY_OUT_TAP1 a_4350_949# 0.10838f
C440 VDD a_5191_913# 0.28565f
C441 DELAY_OUT_TAP8 a_9751_913# 0.02339f
C442 VDD a_20105_949# 0.30333f
C443 VDD a_16510_949# 0.8795f
C444 DELAY_OUT_TAP0 a_4157_1218# 0.50642f
C445 a_12505_949# a_10430_949# 0.03208f
C446 a_16510_949# a_17865_424# 0.02165f
C447 VDD a_14825_424# 0.29292f
C448 VDD a_5115_949# 0.15389f
C449 a_27124_913# a_27048_949# 0.01176f
C450 VDD DELAY_OUT_TAP3 0.12759f
C451 VDD a_12791_913# 0.2822f
C452 MUX_SEL4 DELAY_OUT_TAP12 0.01829f
C453 a_25630_949# a_27048_949# 0.38994f
C454 a_27705_949# VDD 0.29842f
C455 VDD a_4350_949# 0.87635f
C456 VDD DELAY_OUT_TAP23 0.12759f
C457 a_20105_949# a_19550_949# 0.03209f
C458 VDD a_8231_913# 0.28336f
C459 DELAY_OUT_TAP13 a_14025_949# 0.19203f
C460 a_24008_949# a_24084_913# 0.01176f
C461 VDD DELAY_OUT_TAP10 0.13878f
C462 a_26185_949# VDD 0.30333f
C463 a_15545_949# DELAY_OUT_TAP15 0.2079f
C464 a_11785_424# a_10430_949# 0.02058f
C465 VDD a_1544_949# 0.45004f
C466 a_12715_949# a_10430_949# 0.39036f
C467 a_19550_949# DELAY_OUT_TAP23 0.05189f
C468 DELAY_OUT_TAP21 DELAY_OUT_TAP20 0.06596f
C469 a_8231_913# a_7390_949# 0.28268f
C470 DELAY_OUT_TAP28 a_25528_949# 0.10864f
C471 a_13368_949# a_13470_949# 0.37183f
C472 VDD a_24951_913# 0.2822f
C473 DELAY_OUT_TAP22 a_20968_949# 0.10863f
C474 a_10430_949# DELAY_OUT_TAP9 0.10838f
C475 a_1544_949# MUX_SEL1 0.1672f
C476 a_15831_913# a_15545_949# 0.01885f
C477 VDD a_15964_194# 0.31311f
C478 a_26985_424# a_16108_194# 0.2906f
C479 a_10404_913# a_10328_949# 0.01176f
C480 VDD DELAY_OUT_TAP8 0.1474f
C481 VDD a_18004_913# 0.28225f
C482 DELAY_OUT_TAP14 DELAY_OUT_TAP15 0.03717f
C483 DELAY_OUT_TAP4 DELAY_OUT_TAP5 0.06596f
C484 VDD a_1544_194# 0.39113f
C485 a_24665_949# a_24875_949# 0.09424f
C486 a_13444_913# a_13470_949# 0.277f
C487 DELAY_OUT_TAP0 DELAY_OUT_TAP1 0.04252f
C488 a_12791_913# DELAY_OUT_TAP12 0.02339f
C489 a_15765_368# a_16108_194# 0.42004f
C490 VDD a_12505_949# 0.29646f
C491 VDD a_18795_949# 0.15406f
C492 a_8231_913# DELAY_OUT_TAP6 0.02334f
C493 VDD DELAY_OUT_TAP18 0.13878f
C494 a_13444_913# a_13368_949# 0.01176f
C495 VDD DELAY_OUT_TAP25 0.13651f
C496 DELAY_OUT_TAP21 DELAY_OUT_TAP22 0.02068f
C497 DELAY_OUT_TAP8 a_7390_949# 0.02437f
C498 a_1256_194# MUX_OUT 0.1134f
C499 a_3449_1300# DELAY_OUT_TAP0 0.01044f
C500 VDD DELAY_OUT_TAP0 0.50967f
C501 DELAY_OUT_TAP25 a_22564_913# 0.0501f
C502 DELAY_OUT_TAP26 a_22590_949# 0.07996f
C503 a_5768_949# a_5844_913# 0.01176f
C504 a_10985_949# a_10430_949# 0.03209f
C505 a_11848_949# a_11924_913# 0.01176f
C506 DELAY_OUT_TAP27 a_24084_913# 0.02053f
C507 VDD a_11785_424# 0.29292f
C508 a_23355_949# a_23431_913# 0.01194f
C509 VDD MUX_SEL2 0.50938f
C510 VDD a_12715_949# 0.15406f
C511 a_16408_949# DELAY_OUT_TAP16 0.10864f
C512 DELAY_OUT_TAP20 a_18871_913# 0.02339f
C513 a_25630_949# a_26471_913# 0.28268f
C514 a_8808_949# a_8884_913# 0.01176f
C515 VDD a_20315_949# 0.15389f
C516 a_25630_949# a_16108_194# 0.55833f
C517 DELAY_OUT_TAP0 MUX_SEL1 0.01783f
C518 a_23145_949# DELAY_OUT_TAP25 0.19203f
C519 a_7945_949# a_8231_913# 0.01885f
C520 a_15755_949# a_13470_949# 0.39036f
C521 VDD DELAY_OUT_TAP9 0.13651f
C522 a_16484_913# DELAY_OUT_TAP16 0.02011f
C523 MUX_SEL4 a_5705_424# 0.03556f
C524 VDD a_1256_949# 0.47094f
C525 a_16510_949# DELAY_OUT_TAP20 0.02437f
C526 a_6711_913# DELAY_OUT_TAP4 0.02339f
C527 a_20315_949# a_19550_949# 0.39037f
C528 a_14964_913# a_13470_949# 0.28279f
C529 VDD a_18585_949# 0.29646f
C530 VDD a_24875_949# 0.15406f
C531 a_26985_424# VDD 0.29292f
C532 DELAY_OUT_TAP22 a_20391_913# 0.02334f
C533 a_1256_949# MUX_SEL1 1.44243f
C534 VDD a_17065_949# 0.30142f
C535 a_1544_949# MUX_SEL0 0.07603f
C536 a_5731_194# a_5705_424# 0.28954f
C537 MUX_SEL4 MUX_OUT 0.91933f
C538 a_22590_949# a_24951_913# 0.26208f
C539 DELAY_OUT_TAP24 a_22488_949# 0.10864f
C540 a_16408_949# a_16484_913# 0.01176f
C541 a_26185_949# a_26395_949# 0.09424f
C542 a_5705_424# a_2019_216# 0.13872f
C543 VDD a_15765_368# 0.35368f
C544 a_23945_424# a_16108_194# 0.2906f
C545 a_10430_949# a_10404_913# 0.277f
C546 DELAY_OUT_TAP28 a_16108_194# 0.0157f
C547 a_10430_949# a_10328_949# 0.37183f
C548 VDD a_14235_949# 0.15389f
C549 a_6711_913# a_6425_949# 0.01885f
C550 VDD a_17928_949# 0.17499f
C551 VDD DELAY_OUT_TAP7 0.12759f
C552 VDD a_24084_913# 0.28225f
C553 DELAY_OUT_TAP29 DELAY_OUT_TAP30 0.02068f
C554 a_8745_424# MUX_SEL4 0.04472f
C555 a_5731_194# MUX_OUT 1.04829f
C556 DELAY_OUT_TAP15 DELAY_OUT_TAP16 0.0331f
C557 VDD a_10985_949# 0.30333f
C558 VDD a_27915_949# 0.15389f
C559 DELAY_OUT_TAP27 DELAY_OUT_TAP28 0.0331f
C560 MUX_OUT a_2019_216# 8.45486f
C561 a_6635_949# a_6711_913# 0.01194f
C562 DELAY_OUT_TAP29 a_25604_913# 0.0501f
C563 VDD DELAY_OUT_TAP17 0.1382f
C564 a_1256_194# MUX_SEL4 0.65005f
C565 DELAY_OUT_TAP7 a_7390_949# 0.05189f
C566 DELAY_OUT_TAP3 a_5844_913# 0.02053f
C567 VDD a_27124_913# 0.28225f
C568 DELAY_OUT_TAP10 DELAY_OUT_TAP11 0.03717f
C569 VDD a_2873_236# 0.46491f
C570 a_5731_194# a_8745_424# 0.28635f
C571 DELAY_OUT_TAP22 DELAY_OUT_TAP23 0.03717f
C572 VDD MUX_SEL3 0.4053f
C573 VDD a_25630_949# 0.89531f
C574 DELAY_OUT_TAP1 a_4905_949# 0.19203f
C575 DELAY_OUT_TAP25 a_22590_949# 0.10838f
C576 a_5844_913# a_4350_949# 0.28279f
C577 VDD a_2297_236# 0.46496f
R0 VSS.n28 VSS.n6 3663.98
R1 VSS.t114 VSS.n6 140.651
R2 VSS.t81 VSS.n6 140.651
R3 VSS.t195 VSS.n6 122.412
R4 VSS.t212 VSS.n6 68.6481
R5 VSS.n6 VSS.n37 0.481869
R6 VSS.n69 VSS.t87 15.5226
R7 VSS.n6 VSS.t356 22.4812
R8 VSS.t185 VSS.n1 52.2182
R9 VSS.n6 VSS.t277 58.1721
R10 VSS.t262 VSS.n6 58.1721
R11 VSS.t247 VSS.n6 58.1721
R12 VSS.n6 VSS.t235 116.828
R13 VSS.n6 VSS.t220 116.828
R14 VSS.n6 VSS.t205 116.828
R15 VSS.t88 VSS.n36 499.695
R16 VSS.n6 VSS.t18 58.0914
R17 VSS.t284 VSS.n14 15.3031
R18 VSS.t197 VSS.n6 68.6471
R19 VSS.t227 VSS.n6 68.6471
R20 VSS.t242 VSS.n6 68.6471
R21 VSS.t257 VSS.n6 68.6471
R22 VSS.t272 VSS.n6 68.6471
R23 VSS.n59 VSS.t90 267.416
R24 VSS.t300 VSS.n26 26.3107
R25 VSS.n114 VSS.t107 436.62
R26 VSS.n30 VSS.t285 430.062
R27 VSS.n31 VSS.t347 418.382
R28 VSS.n27 VSS.n41 0.382621
R29 VSS.t190 VSS.n11 68.5978
R30 VSS.t353 VSS.n38 68.5978
R31 VSS.t290 VSS.n12 68.5978
R32 VSS.t327 VSS.n9 68.5978
R33 VSS.n33 VSS.n27 0.382621
R34 VSS.n40 VSS.n27 0.382621
R35 VSS.t329 VSS.n32 68.5978
R36 VSS.n60 VSS.t106 417.714
R37 VSS.t85 VSS.n6 116.822
R38 VSS.t250 VSS.n6 116.828
R39 VSS.n6 VSS.t280 116.828
R40 VSS.n27 VSS.n57 0.481029
R41 VSS.n62 VSS.t309 62.2552
R42 VSS.n77 VSS.t116 404.05
R43 VSS.t312 VSS.n202 375
R44 VSS.n6 VSS.t210 122.412
R45 VSS.n6 VSS.t225 122.412
R46 VSS.n6 VSS.t240 122.412
R47 VSS.n6 VSS.t255 122.412
R48 VSS.n6 VSS.t270 122.412
R49 VSS.t28 VSS.n107 366.197
R50 VSS.t207 VSS.n6 127.3
R51 VSS.t222 VSS.n6 127.3
R52 VSS.n6 VSS.t237 127.3
R53 VSS.n6 VSS.t252 127.3
R54 VSS.t267 VSS.n6 127.3
R55 VSS.n27 VSS.n67 0.423468
R56 VSS.n27 VSS.n72 0.423468
R57 VSS.n27 VSS.n66 0.423468
R58 VSS.n23 VSS.t323 98.6395
R59 VSS.n27 VSS.n65 0.423468
R60 VSS.n27 VSS.n73 0.423468
R61 VSS.n22 VSS.t324 98.6395
R62 VSS.n27 VSS.n74 0.423468
R63 VSS.n27 VSS.n63 0.423468
R64 VSS.n20 VSS.t325 98.6395
R65 VSS.n27 VSS.n58 0.423468
R66 VSS.n19 VSS.t26 98.6395
R67 VSS.n17 VSS.t83 98.6395
R68 VSS.n16 VSS.t322 98.6395
R69 VSS.n27 VSS.n64 0.423468
R70 VSS.n27 VSS.n76 0.423468
R71 VSS.t111 VSS.n6 140.651
R72 VSS.t168 VSS.n6 133.32
R73 VSS.t80 VSS.n6 133.32
R74 VSS.t113 VSS.n6 133.32
R75 VSS.n6 VSS.t179 140.653
R76 VSS.t77 VSS.n6 133.32
R77 VSS.t293 VSS.n6 133.32
R78 VSS.t109 VSS.n107 352.113
R79 VSS.t313 VSS.n61 359.983
R80 VSS.n27 VSS.t56 101.647
R81 VSS.n27 VSS.t10 101.647
R82 VSS.n27 VSS.t148 101.647
R83 VSS.n27 VSS.t59 101.647
R84 VSS.n27 VSS.t345 101.647
R85 VSS.n27 VSS.t24 101.647
R86 VSS.n27 VSS.t62 101.647
R87 VSS.n27 VSS.t33 101.647
R88 VSS.n27 VSS.t120 101.647
R89 VSS.t282 VSS.n27 101.656
R90 VSS.t97 VSS.n71 348.303
R91 VSS.t94 VSS.n42 348.303
R92 VSS.t164 VSS.n45 348.303
R93 VSS.t104 VSS.n47 348.303
R94 VSS.t133 VSS.n55 348.303
R95 VSS.t166 VSS.n54 348.303
R96 VSS.t131 VSS.n49 348.303
R97 VSS.t96 VSS.n53 348.303
R98 VSS.t21 VSS.n51 348.303
R99 VSS.t355 VSS.n52 348.303
R100 VSS.n42 VSS.n27 6.82258
R101 VSS.t46 VSS.n43 111.644
R102 VSS.t125 VSS.n44 111.644
R103 VSS.n27 VSS.t154 108.561
R104 VSS.n45 VSS.n27 6.82258
R105 VSS.t122 VSS.n46 111.644
R106 VSS.n47 VSS.n27 6.82258
R107 VSS.n27 VSS.t36 108.561
R108 VSS.t40 VSS.n48 111.644
R109 VSS.n27 VSS.t142 108.561
R110 VSS.n49 VSS.n27 6.82258
R111 VSS.n27 VSS.t102 108.561
R112 VSS.t138 VSS.n50 111.644
R113 VSS.n51 VSS.n27 6.82258
R114 VSS.n27 VSS.t73 108.561
R115 VSS.n6 VSS.n36 9.75628
R116 VSS.n77 VSS.t117 129.738
R117 VSS.t181 VSS.n68 404.05
R118 VSS.n203 VSS.t298 314.517
R119 VSS.n6 VSS.t294 140.651
R120 VSS.n6 VSS.t169 140.651
R121 VSS.n70 VSS.t70 131.472
R122 VSS.n203 VSS.t304 302.42
R123 VSS.t289 VSS.n30 110.901
R124 VSS.n114 VSS.t90 281.69
R125 VSS.t99 VSS.n71 111.647
R126 VSS.t338 VSS.n42 111.644
R127 VSS.n43 VSS.t160 348.303
R128 VSS.n44 VSS.t321 348.303
R129 VSS.n56 VSS.t319 348.303
R130 VSS.t43 VSS.n45 111.644
R131 VSS.n46 VSS.t173 348.303
R132 VSS.t128 VSS.n47 111.644
R133 VSS.t35 VSS.n55 111.644
R134 VSS.n48 VSS.t171 348.303
R135 VSS.t141 VSS.n54 111.644
R136 VSS.t135 VSS.n49 111.644
R137 VSS.t101 VSS.n53 111.644
R138 VSS.n50 VSS.t159 348.303
R139 VSS.t49 VSS.n51 111.644
R140 VSS.t72 VSS.n52 111.644
R141 VSS.n29 VSS.t175 348.303
R142 VSS.n6 VSS.t200 141.964
R143 VSS.n6 VSS.t215 141.964
R144 VSS.n6 VSS.t230 141.964
R145 VSS.n6 VSS.t245 141.964
R146 VSS.n6 VSS.t260 141.964
R147 VSS.n6 VSS.t275 141.964
R148 VSS.n6 VSS.t64 141.702
R149 VSS.n31 VSS.n27 9.3247
R150 VSS.n6 VSS.t157 140.653
R151 VSS.n27 VSS.t286 122.754
R152 VSS.t307 VSS.n202 241.935
R153 VSS.t66 VSS.n60 131.77
R154 VSS.n70 VSS.t68 486.031
R155 VSS.n6 VSS.t16 137.776
R156 VSS.t183 VSS.n68 129.738
R157 VSS.n77 VSS.n6 6.80937
R158 VSS.t67 VSS.n36 129.317
R159 VSS.n62 VSS.t307 231.506
R160 VSS.t110 VSS.n6 133.32
R161 VSS.n6 VSS.t178 133.319
R162 VSS.t156 VSS.n6 133.319
R163 VSS.t288 VSS.n61 113.322
R164 VSS.n31 VSS.t348 112.787
R165 VSS.n27 VSS.n71 6.82269
R166 VSS.n29 VSS.t52 111.639
R167 VSS.n6 VSS.t192 127.299
R168 VSS.n69 VSS.t109 199.099
R169 VSS.n6 VSS.t265 116.828
R170 VSS.t339 VSS.n27 108.561
R171 VSS.t47 VSS.n27 108.561
R172 VSS.t126 VSS.n27 108.561
R173 VSS.t44 VSS.n27 108.561
R174 VSS.t123 VSS.n27 108.561
R175 VSS.t129 VSS.n27 108.561
R176 VSS.t41 VSS.n27 108.561
R177 VSS.t136 VSS.n27 108.561
R178 VSS.t139 VSS.n27 108.561
R179 VSS.t50 VSS.n27 108.561
R180 VSS.t53 VSS.n28 109.016
R181 VSS.t298 VSS.n26 161.025
R182 VSS.t116 VSS.n3 156.831
R183 VSS.t181 VSS.n1 156.883
R184 VSS.t4 VSS.n27 101.647
R185 VSS.t1 VSS.n27 101.647
R186 VSS.n24 VSS.t55 83.4525
R187 VSS.t145 VSS.n27 101.647
R188 VSS.n27 VSS.n39 0.382621
R189 VSS.n27 VSS.n38 0.382621
R190 VSS.t342 VSS.n27 101.647
R191 VSS.t336 VSS.n27 101.647
R192 VSS.n27 VSS.n35 0.382621
R193 VSS.n21 VSS.t344 83.4525
R194 VSS.n27 VSS.n34 0.382621
R195 VSS.n33 VSS.t61 83.4525
R196 VSS.n18 VSS.t32 83.4525
R197 VSS.t151 VSS.n27 101.647
R198 VSS.n27 VSS.n32 0.382621
R199 VSS.t7 VSS.n27 101.647
R200 VSS.t106 VSS.n5 142.746
R201 VSS.n25 VSS.t97 136.798
R202 VSS.t189 VSS.n67 98.6395
R203 VSS.t188 VSS.n72 98.6395
R204 VSS.t296 VSS.n66 98.6395
R205 VSS.n23 VSS.t319 136.962
R206 VSS.t302 VSS.n65 98.6395
R207 VSS.t292 VSS.n73 98.6395
R208 VSS.n22 VSS.t104 136.962
R209 VSS.t326 VSS.n74 98.6395
R210 VSS.t311 VSS.n63 98.6395
R211 VSS.n20 VSS.t166 136.962
R212 VSS.t350 VSS.n58 98.6395
R213 VSS.n19 VSS.t96 136.962
R214 VSS.n17 VSS.t159 136.962
R215 VSS.n16 VSS.t21 136.962
R216 VSS.t12 VSS.n64 98.6395
R217 VSS.t38 VSS.n76 98.6395
R218 VSS.n13 VSS.t313 124.701
R219 VSS.t107 VSS.n4 114.668
R220 VSS.t303 VSS.n57 72.4354
R221 VSS.n59 VSS.t92 71.035
R222 VSS.t162 VSS.n41 68.5978
R223 VSS.t0 VSS.n11 83.4525
R224 VSS.n24 VSS.t176 68.5978
R225 VSS.n10 VSS.t305 68.5978
R226 VSS.n39 VSS.t351 68.5978
R227 VSS.t147 VSS.n38 83.4525
R228 VSS.t341 VSS.n12 83.4525
R229 VSS.t335 VSS.n9 83.4525
R230 VSS.n35 VSS.t331 68.5978
R231 VSS.n21 VSS.t315 68.5978
R232 VSS.n34 VSS.t317 68.5978
R233 VSS.n33 VSS.t333 68.5978
R234 VSS.n18 VSS.t14 68.5978
R235 VSS.n40 VSS.t75 68.5978
R236 VSS.t119 VSS.n32 83.4525
R237 VSS.n15 VSS.t186 68.5978
R238 VSS.n62 VSS.n27 2.65215
R239 VSS.n5 VSS.t68 72.3236
R240 VSS.n6 VSS.t202 58.1721
R241 VSS.n6 VSS.t217 58.1721
R242 VSS.n6 VSS.t232 58.1721
R243 VSS.t347 VSS.n13 64.2173
R244 VSS.n3 VSS.t88 58.2391
R245 VSS.t285 VSS.n25 52.1205
R246 VSS.t30 VSS.n37 28.4523
R247 VSS.n6 VSS.t19 22.5629
R248 VSS.n115 VSS.t91 17.3368
R249 VSS.n118 VSS.t69 17.3368
R250 VSS.n108 VSS.t29 17.3368
R251 VSS.n122 VSS.t89 17.3368
R252 VSS.n220 VSS.t98 17.3368
R253 VSS.n216 VSS.t299 17.3368
R254 VSS.n212 VSS.t314 17.3368
R255 VSS.n208 VSS.t308 17.3368
R256 VSS.n159 VSS.t182 17.2607
R257 VSS.n126 VSS.t193 17.2313
R258 VSS.n406 VSS.t199 17.2313
R259 VSS.n80 VSS.t204 17.2313
R260 VSS.n399 VSS.t209 17.2313
R261 VSS.n394 VSS.t214 17.2313
R262 VSS.n142 VSS.t219 17.2313
R263 VSS.n387 VSS.t224 17.2313
R264 VSS.n382 VSS.t229 17.2313
R265 VSS.n89 VSS.t234 17.2313
R266 VSS.n167 VSS.t239 17.2313
R267 VSS.n375 VSS.t244 17.2313
R268 VSS.n94 VSS.t249 17.2313
R269 VSS.n181 VSS.t254 17.2313
R270 VSS.n368 VSS.t259 17.2313
R271 VSS.n187 VSS.t264 17.2313
R272 VSS.n361 VSS.t269 17.2313
R273 VSS.n356 VSS.t274 17.2313
R274 VSS.n197 VSS.t279 17.2313
R275 VSS.n6 VSS.n107 17.0005
R276 VSS.n6 VSS.n70 9.33546
R277 VSS.n6 VSS.n60 7.23036
R278 VSS.n6 VSS.n59 2.59912
R279 VSS.n6 VSS.n114 17.0005
R280 VSS.n411 VSS.n6 17.0005
R281 VSS.n409 VSS.t194 17.0005
R282 VSS.n6 VSS.n101 5.65652
R283 VSS.n6 VSS.n97 5.65652
R284 VSS.n6 VSS.n92 5.65652
R285 VSS.n6 VSS.n68 6.8094
R286 VSS.n6 VSS.n87 5.65652
R287 VSS.n6 VSS.n83 5.65652
R288 VSS.n6 VSS.n78 5.65652
R289 VSS.n128 VSS.t196 17.0005
R290 VSS.n407 VSS.t198 17.0005
R291 VSS.n130 VSS.t201 17.0005
R292 VSS.n131 VSS.t203 17.0005
R293 VSS.n134 VSS.t206 17.0005
R294 VSS.n400 VSS.t208 17.0005
R295 VSS.n138 VSS.t211 17.0005
R296 VSS.n395 VSS.t213 17.0005
R297 VSS.n139 VSS.t216 17.0005
R298 VSS.n140 VSS.t218 17.0005
R299 VSS.n144 VSS.t221 17.0005
R300 VSS.n388 VSS.t223 17.0005
R301 VSS.n148 VSS.t226 17.0005
R302 VSS.n383 VSS.t228 17.0005
R303 VSS.n149 VSS.t231 17.0005
R304 VSS.n150 VSS.t233 17.0005
R305 VSS.n154 VSS.t236 17.0005
R306 VSS.n165 VSS.t238 17.0005
R307 VSS.n168 VSS.t241 17.0005
R308 VSS.n376 VSS.t243 17.0005
R309 VSS.n170 VSS.t246 17.0005
R310 VSS.n171 VSS.t248 17.0005
R311 VSS.n174 VSS.t251 17.0005
R312 VSS.n179 VSS.t253 17.0005
R313 VSS.n182 VSS.t256 17.0005
R314 VSS.n369 VSS.t258 17.0005
R315 VSS.n184 VSS.t261 17.0005
R316 VSS.n185 VSS.t263 17.0005
R317 VSS.n189 VSS.t266 17.0005
R318 VSS.n362 VSS.t268 17.0005
R319 VSS.n193 VSS.t271 17.0005
R320 VSS.n357 VSS.t273 17.0005
R321 VSS.n194 VSS.t276 17.0005
R322 VSS.n195 VSS.t278 17.0005
R323 VSS.n198 VSS.t281 17.0005
R324 VSS.n27 VSS.n75 17.0005
R325 VSS.n27 VSS.n202 17.0005
R326 VSS.n27 VSS.n61 7.23977
R327 VSS.n27 VSS.n203 17.0005
R328 VSS.n27 VSS.n30 9.74178
R329 VSS.n27 VSS.n43 6.82258
R330 VSS.n27 VSS.n44 6.82258
R331 VSS.n27 VSS.n56 6.82258
R332 VSS.n27 VSS.n46 6.82258
R333 VSS.n27 VSS.n48 6.82258
R334 VSS.n27 VSS.n50 6.82258
R335 VSS.n27 VSS.n29 6.82228
R336 VSS.n69 VSS.n6 0.494014
R337 VSS.t304 VSS.n14 173.107
R338 VSS.n128 VSS.t391 15.3099
R339 VSS.n130 VSS.t389 15.3099
R340 VSS.n134 VSS.t387 15.3099
R341 VSS.n138 VSS.t385 15.3099
R342 VSS.n139 VSS.t383 15.3099
R343 VSS.n144 VSS.t381 15.3099
R344 VSS.n148 VSS.t379 15.3099
R345 VSS.n149 VSS.t377 15.3099
R346 VSS.n154 VSS.t375 15.3099
R347 VSS.n168 VSS.t373 15.3099
R348 VSS.n170 VSS.t371 15.3099
R349 VSS.n174 VSS.t369 15.3099
R350 VSS.n182 VSS.t367 15.3099
R351 VSS.n184 VSS.t365 15.3099
R352 VSS.n189 VSS.t363 15.3099
R353 VSS.n193 VSS.t361 15.3099
R354 VSS.n194 VSS.t359 15.3099
R355 VSS.n198 VSS.t357 15.3099
R356 VSS.n409 VSS.t392 15.2696
R357 VSS.n407 VSS.t390 15.2696
R358 VSS.n131 VSS.t388 15.2696
R359 VSS.n400 VSS.t386 15.2696
R360 VSS.n395 VSS.t384 15.2696
R361 VSS.n140 VSS.t382 15.2696
R362 VSS.n388 VSS.t380 15.2696
R363 VSS.n383 VSS.t378 15.2696
R364 VSS.n150 VSS.t376 15.2696
R365 VSS.n165 VSS.t374 15.2696
R366 VSS.n376 VSS.t372 15.2696
R367 VSS.n171 VSS.t370 15.2696
R368 VSS.n179 VSS.t368 15.2696
R369 VSS.n369 VSS.t366 15.2696
R370 VSS.n185 VSS.t364 15.2696
R371 VSS.n362 VSS.t362 15.2696
R372 VSS.n357 VSS.t360 15.2696
R373 VSS.n195 VSS.t358 15.2696
R374 VSS.n222 VSS.t100 8.80385
R375 VSS.n218 VSS.t301 8.80385
R376 VSS.n214 VSS.t349 8.80385
R377 VSS.n210 VSS.t310 8.80385
R378 VSS.n116 VSS.t93 8.80285
R379 VSS.n119 VSS.t71 8.80285
R380 VSS.n121 VSS.t31 8.80285
R381 VSS.n124 VSS.t118 8.80285
R382 VSS.n350 VSS.t54 8.77423
R383 VSS.n348 VSS.t39 8.77423
R384 VSS.n346 VSS.t8 8.77423
R385 VSS.n344 VSS.t187 8.77423
R386 VSS.n342 VSS.t74 8.77423
R387 VSS.n340 VSS.t13 8.77423
R388 VSS.n338 VSS.t121 8.77423
R389 VSS.n336 VSS.t330 8.77423
R390 VSS.n334 VSS.t51 8.77423
R391 VSS.n332 VSS.t22 8.77423
R392 VSS.n330 VSS.t152 8.77423
R393 VSS.n328 VSS.t76 8.77423
R394 VSS.n326 VSS.t140 8.77423
R395 VSS.n324 VSS.t84 8.77423
R396 VSS.n322 VSS.t34 8.77423
R397 VSS.n320 VSS.t15 8.77423
R398 VSS.n318 VSS.t103 8.77423
R399 VSS.n316 VSS.t27 8.77423
R400 VSS.n314 VSS.t63 8.77423
R401 VSS.n312 VSS.t334 8.77423
R402 VSS.n310 VSS.t137 8.77423
R403 VSS.n308 VSS.t132 8.77423
R404 VSS.n306 VSS.t25 8.77423
R405 VSS.n304 VSS.t318 8.77423
R406 VSS.n302 VSS.t143 8.77423
R407 VSS.n300 VSS.t167 8.77423
R408 VSS.n298 VSS.t346 8.77423
R409 VSS.n296 VSS.t316 8.77423
R410 VSS.n294 VSS.t42 8.77423
R411 VSS.n292 VSS.t172 8.77423
R412 VSS.n290 VSS.t60 8.77423
R413 VSS.n288 VSS.t332 8.77423
R414 VSS.n286 VSS.t37 8.77423
R415 VSS.n284 VSS.t134 8.77423
R416 VSS.n282 VSS.t337 8.77423
R417 VSS.n280 VSS.t328 8.77423
R418 VSS.n278 VSS.t130 8.77423
R419 VSS.n276 VSS.t105 8.77423
R420 VSS.n274 VSS.t343 8.77423
R421 VSS.n272 VSS.t291 8.77423
R422 VSS.n270 VSS.t124 8.77423
R423 VSS.n268 VSS.t174 8.77423
R424 VSS.n266 VSS.t149 8.77423
R425 VSS.n264 VSS.t354 8.77423
R426 VSS.n262 VSS.t45 8.77423
R427 VSS.n260 VSS.t165 8.77423
R428 VSS.n258 VSS.t11 8.77423
R429 VSS.n256 VSS.t352 8.77423
R430 VSS.n254 VSS.t155 8.77423
R431 VSS.n252 VSS.t320 8.77423
R432 VSS.n250 VSS.t146 8.77423
R433 VSS.n248 VSS.t306 8.77423
R434 VSS.n246 VSS.t127 8.77423
R435 VSS.n244 VSS.t297 8.77423
R436 VSS.n242 VSS.t57 8.77423
R437 VSS.n240 VSS.t177 8.77423
R438 VSS.n238 VSS.t48 8.77423
R439 VSS.n236 VSS.t161 8.77423
R440 VSS.n234 VSS.t2 8.77423
R441 VSS.n232 VSS.t191 8.77423
R442 VSS.n230 VSS.t340 8.77423
R443 VSS.n228 VSS.t95 8.77423
R444 VSS.n226 VSS.t5 8.77423
R445 VSS.n224 VSS.t163 8.77423
R446 VSS.n7 VSS.t112 8.82841
R447 VSS.n136 VSS.t295 8.77323
R448 VSS.n146 VSS.t79 8.77323
R449 VSS.n157 VSS.t180 8.77323
R450 VSS.n158 VSS.t20 8.77323
R451 VSS.n162 VSS.t115 8.77323
R452 VSS.n176 VSS.t82 8.77323
R453 VSS.n191 VSS.t170 8.77323
R454 VSS.n201 VSS.t158 8.77323
R455 VSS.n8 VSS.t17 8.79211
R456 VSS.n161 VSS.t184 8.76678
R457 VSS.n206 VSS.t283 8.75731
R458 VSS.n204 VSS.t287 8.75731
R459 VSS.n104 VSS.t65 8.75631
R460 VSS.n112 VSS.t86 8.75631
R461 VSS.n103 VSS.n6 4.22409
R462 VSS.n102 VSS.n358 0.0534319
R463 VSS.n359 VSS.n101 0.0180497
R464 VSS.n100 VSS.n363 0.0633111
R465 VSS.n99 VSS.n6 4.22409
R466 VSS.n98 VSS.n370 0.0534319
R467 VSS.n183 VSS.n97 0.0180497
R468 VSS.n180 VSS.n96 0.0633111
R469 VSS.n371 VSS.n95 0.0435295
R470 VSS.n93 VSS.n377 0.0534319
R471 VSS.n169 VSS.n92 0.0180497
R472 VSS.n166 VSS.n91 0.0633111
R473 VSS.n378 VSS.n90 0.0435295
R474 VSS.n88 VSS.n384 0.0534319
R475 VSS.n385 VSS.n87 0.0180497
R476 VSS.n86 VSS.n389 0.0633111
R477 VSS.n85 VSS.n6 4.22409
R478 VSS.n84 VSS.n396 0.0534319
R479 VSS.n397 VSS.n83 0.0180497
R480 VSS.n82 VSS.n401 0.0633111
R481 VSS.n402 VSS.n81 0.0435295
R482 VSS.n79 VSS.n408 0.0534319
R483 VSS.n129 VSS.n78 0.0180497
R484 VSS.n353 VSS.n6 8.49319
R485 VSS.n365 VSS.n6 8.49319
R486 VSS.n372 VSS.n6 8.49319
R487 VSS.n379 VSS.n6 8.49319
R488 VSS.n391 VSS.n6 8.49319
R489 VSS.n403 VSS.n6 8.49319
R490 VSS.n6 VSS.n106 8.47732
R491 VSS.n103 VSS.n197 0.176279
R492 VSS.n102 VSS.n6 4.21914
R493 VSS.n360 VSS.n6 8.47732
R494 VSS.n100 VSS.n6 4.21421
R495 VSS.n99 VSS.n187 0.176279
R496 VSS.n98 VSS.n6 4.21914
R497 VSS.n6 VSS.n178 8.47732
R498 VSS.n6 VSS.n96 4.21421
R499 VSS.n6 VSS.n95 4.22409
R500 VSS.n93 VSS.n6 4.21914
R501 VSS.n6 VSS.n164 8.47732
R502 VSS.n6 VSS.n91 4.21421
R503 VSS.n6 VSS.n90 4.22409
R504 VSS.n88 VSS.n6 4.21914
R505 VSS.n386 VSS.n6 8.47732
R506 VSS.n86 VSS.n6 4.21421
R507 VSS.n85 VSS.n142 0.176279
R508 VSS.n84 VSS.n6 4.21914
R509 VSS.n398 VSS.n6 8.47732
R510 VSS.n82 VSS.n6 4.21421
R511 VSS.n6 VSS.n81 4.22409
R512 VSS.n79 VSS.n6 4.21914
R513 VSS.n6 VSS.n127 8.47732
R514 VSS.n217 VSS.n27 8.47732
R515 VSS.n351 VSS.n27 8.47732
R516 VSS.n6 VSS.n105 5.62581
R517 VSS.n6 VSS.n120 5.62581
R518 VSS.n6 VSS.n117 5.62581
R519 VSS.n6 VSS.n200 5.62581
R520 VSS.n355 VSS.n6 5.62581
R521 VSS.n6 VSS.n188 5.62581
R522 VSS.n367 VSS.n6 5.62581
R523 VSS.n6 VSS.n173 5.62581
R524 VSS.n374 VSS.n6 5.62581
R525 VSS.n6 VSS.n152 5.62581
R526 VSS.n6 VSS.n153 5.62581
R527 VSS.n381 VSS.n6 5.62581
R528 VSS.n6 VSS.n143 5.62581
R529 VSS.n393 VSS.n6 5.62581
R530 VSS.n6 VSS.n133 5.62581
R531 VSS.n405 VSS.n6 5.62581
R532 VSS.n209 VSS.n27 5.62581
R533 VSS.n213 VSS.n27 5.62581
R534 VSS.n221 VSS.n27 5.62581
R535 VSS.n231 VSS.n27 5.62581
R536 VSS.n239 VSS.n27 5.62581
R537 VSS.n247 VSS.n27 5.62581
R538 VSS.n255 VSS.n27 5.62581
R539 VSS.n263 VSS.n27 5.62581
R540 VSS.n271 VSS.n27 5.62581
R541 VSS.n279 VSS.n27 5.62581
R542 VSS.n287 VSS.n27 5.62581
R543 VSS.n295 VSS.n27 5.62581
R544 VSS.n303 VSS.n27 5.62581
R545 VSS.n311 VSS.n27 5.62581
R546 VSS.n319 VSS.n27 5.62581
R547 VSS.n327 VSS.n27 5.62581
R548 VSS.n335 VSS.n27 5.62581
R549 VSS.n343 VSS.n27 5.62581
R550 VSS.n6 VSS.n125 4.21408
R551 VSS.n6 VSS.n113 4.19244
R552 VSS.n205 VSS.n27 4.19244
R553 VSS.n223 VSS.n27 4.19244
R554 VSS.n0 VSS.n351 3.33613
R555 VSS.n7 VSS.n410 0.440892
R556 VSS.n6 VSS.n123 3.3265
R557 VSS.n6 VSS.n109 3.3265
R558 VSS.n6 VSS.n110 3.3265
R559 VSS.n6 VSS.n186 3.3265
R560 VSS.n6 VSS.n172 3.3265
R561 VSS.n6 VSS.n151 3.3265
R562 VSS.n6 VSS.n141 3.3265
R563 VSS.n6 VSS.n132 3.3265
R564 VSS.n211 VSS.n27 3.3265
R565 VSS.n215 VSS.n27 3.3265
R566 VSS.n219 VSS.n27 3.3265
R567 VSS.n225 VSS.n27 3.3265
R568 VSS.n233 VSS.n27 3.3265
R569 VSS.n241 VSS.n27 3.3265
R570 VSS.n249 VSS.n27 3.3265
R571 VSS.n257 VSS.n27 3.3265
R572 VSS.n265 VSS.n27 3.3265
R573 VSS.n273 VSS.n27 3.3265
R574 VSS.n281 VSS.n27 3.3265
R575 VSS.n289 VSS.n27 3.3265
R576 VSS.n297 VSS.n27 3.3265
R577 VSS.n305 VSS.n27 3.3265
R578 VSS.n313 VSS.n27 3.3265
R579 VSS.n321 VSS.n27 3.3265
R580 VSS.n329 VSS.n27 3.3265
R581 VSS.n337 VSS.n27 3.3265
R582 VSS.n345 VSS.n27 3.3265
R583 VSS.n6 VSS.n111 2.74446
R584 VSS.n207 VSS.n27 2.74446
R585 VSS.n227 VSS.n27 2.74446
R586 VSS.n229 VSS.n27 2.74446
R587 VSS.n235 VSS.n27 2.74446
R588 VSS.n237 VSS.n27 2.74446
R589 VSS.n243 VSS.n27 2.74446
R590 VSS.n245 VSS.n27 2.74446
R591 VSS.n251 VSS.n27 2.74446
R592 VSS.n253 VSS.n27 2.74446
R593 VSS.n259 VSS.n27 2.74446
R594 VSS.n261 VSS.n27 2.74446
R595 VSS.n267 VSS.n27 2.74446
R596 VSS.n269 VSS.n27 2.74446
R597 VSS.n275 VSS.n27 2.74446
R598 VSS.n277 VSS.n27 2.74446
R599 VSS.n283 VSS.n27 2.74446
R600 VSS.n285 VSS.n27 2.74446
R601 VSS.n291 VSS.n27 2.74446
R602 VSS.n293 VSS.n27 2.74446
R603 VSS.n299 VSS.n27 2.74446
R604 VSS.n301 VSS.n27 2.74446
R605 VSS.n307 VSS.n27 2.74446
R606 VSS.n309 VSS.n27 2.74446
R607 VSS.n315 VSS.n27 2.74446
R608 VSS.n317 VSS.n27 2.74446
R609 VSS.n323 VSS.n27 2.74446
R610 VSS.n325 VSS.n27 2.74446
R611 VSS.n331 VSS.n27 2.74446
R612 VSS.n333 VSS.n27 2.74446
R613 VSS.n339 VSS.n27 2.74446
R614 VSS.n341 VSS.n27 2.74446
R615 VSS.n347 VSS.n27 2.74446
R616 VSS.n349 VSS.n27 2.74446
R617 VSS.n6 VSS.n160 2.00687
R618 VSS.n6 VSS.n196 1.56144
R619 VSS.n6 VSS.n192 1.56144
R620 VSS.n6 VSS.n177 1.56144
R621 VSS.n6 VSS.n156 1.56144
R622 VSS.n6 VSS.n147 1.56144
R623 VSS.n6 VSS.n137 1.56144
R624 VSS.n6 VSS.n163 1.12565
R625 VSS.n6 VSS.n0 0.92982
R626 VSS.n8 VSS.n6 0.761893
R627 VSS.n7 VSS.n6 0.665344
R628 VSS.n6 VSS.n2 0.849178
R629 VSS.n2 VSS.n157 0.728316
R630 VSS.n158 VSS.n2 0.69965
R631 VSS.n0 VSS.n201 0.69304
R632 VSS.n163 VSS.n161 0.603496
R633 VSS.n57 VSS.t312 100.614
R634 VSS.n27 VSS.n13 0.586403
R635 VSS.n27 VSS.n14 0.567373
R636 VSS.n27 VSS.n26 0.552982
R637 VSS.n27 VSS.n25 0.586403
R638 VSS.n67 VSS.t94 136.962
R639 VSS.n72 VSS.t160 136.962
R640 VSS.n27 VSS.n24 0.382621
R641 VSS.n66 VSS.t321 136.962
R642 VSS.n10 VSS.t144 83.4525
R643 VSS.n27 VSS.n23 0.423468
R644 VSS.n39 VSS.t9 83.4525
R645 VSS.n65 VSS.t164 136.962
R646 VSS.n73 VSS.t173 136.962
R647 VSS.n27 VSS.n22 0.423468
R648 VSS.n74 VSS.t133 136.962
R649 VSS.n35 VSS.t58 83.4525
R650 VSS.n63 VSS.t171 136.962
R651 VSS.n27 VSS.n21 0.382621
R652 VSS.n27 VSS.n20 0.423468
R653 VSS.n34 VSS.t23 83.4525
R654 VSS.n58 VSS.t131 136.962
R655 VSS.n27 VSS.n19 0.423468
R656 VSS.n27 VSS.n18 0.382621
R657 VSS.n27 VSS.n17 0.423468
R658 VSS.n27 VSS.n16 0.423468
R659 VSS.n64 VSS.t355 136.962
R660 VSS.n27 VSS.n15 0.382621
R661 VSS.n76 VSS.t175 136.962
R662 VSS.n163 VSS.n162 0.540438
R663 VSS.n6 VSS.n3 0.50872
R664 VSS.n37 VSS.t28 185.028
R665 VSS.n6 VSS.n5 0.50872
R666 VSS.n28 VSS.n27 0.147224
R667 VSS.n6 VSS.n1 0.456674
R668 VSS.n137 VSS.n136 0.413418
R669 VSS.n147 VSS.n146 0.413418
R670 VSS.n157 VSS.n156 0.413418
R671 VSS.n177 VSS.n176 0.413418
R672 VSS.n192 VSS.n191 0.413418
R673 VSS.n201 VSS.n196 0.413418
R674 VSS.n160 VSS.n159 0.380519
R675 VSS.n160 VSS.n158 0.359515
R676 VSS.n199 VSS.n196 0.340858
R677 VSS.n192 VSS.n190 0.340858
R678 VSS.n177 VSS.n175 0.340858
R679 VSS.n156 VSS.n155 0.340858
R680 VSS.n147 VSS.n145 0.340858
R681 VSS.n137 VSS.n135 0.340858
R682 VSS.n208 VSS.n207 0.318018
R683 VSS.n115 VSS.n111 0.316299
R684 VSS.n228 VSS.n227 0.284268
R685 VSS.n236 VSS.n235 0.284268
R686 VSS.n244 VSS.n243 0.284268
R687 VSS.n252 VSS.n251 0.284268
R688 VSS.n260 VSS.n259 0.284268
R689 VSS.n268 VSS.n267 0.284268
R690 VSS.n276 VSS.n275 0.284268
R691 VSS.n284 VSS.n283 0.284268
R692 VSS.n292 VSS.n291 0.284268
R693 VSS.n300 VSS.n299 0.284268
R694 VSS.n308 VSS.n307 0.284268
R695 VSS.n316 VSS.n315 0.284268
R696 VSS.n324 VSS.n323 0.284268
R697 VSS.n332 VSS.n331 0.284268
R698 VSS.n340 VSS.n339 0.284268
R699 VSS.n348 VSS.n347 0.284268
R700 VSS.n229 VSS.n228 0.282549
R701 VSS.n237 VSS.n236 0.282549
R702 VSS.n245 VSS.n244 0.282549
R703 VSS.n253 VSS.n252 0.282549
R704 VSS.n261 VSS.n260 0.282549
R705 VSS.n269 VSS.n268 0.282549
R706 VSS.n277 VSS.n276 0.282549
R707 VSS.n285 VSS.n284 0.282549
R708 VSS.n293 VSS.n292 0.282549
R709 VSS.n301 VSS.n300 0.282549
R710 VSS.n309 VSS.n308 0.282549
R711 VSS.n317 VSS.n316 0.282549
R712 VSS.n325 VSS.n324 0.282549
R713 VSS.n333 VSS.n332 0.282549
R714 VSS.n341 VSS.n340 0.282549
R715 VSS.n349 VSS.n348 0.282549
R716 VSS.n226 VSS.n225 0.280477
R717 VSS.n234 VSS.n233 0.280477
R718 VSS.n242 VSS.n241 0.280477
R719 VSS.n250 VSS.n249 0.280477
R720 VSS.n258 VSS.n257 0.280477
R721 VSS.n266 VSS.n265 0.280477
R722 VSS.n274 VSS.n273 0.280477
R723 VSS.n282 VSS.n281 0.280477
R724 VSS.n290 VSS.n289 0.280477
R725 VSS.n298 VSS.n297 0.280477
R726 VSS.n306 VSS.n305 0.280477
R727 VSS.n314 VSS.n313 0.280477
R728 VSS.n322 VSS.n321 0.280477
R729 VSS.n330 VSS.n329 0.280477
R730 VSS.n338 VSS.n337 0.280477
R731 VSS.n346 VSS.n345 0.280477
R732 VSS.n112 VSS.n111 0.274268
R733 VSS.n119 VSS.n109 0.274227
R734 VSS.n136 VSS.n132 0.274227
R735 VSS.n146 VSS.n141 0.274227
R736 VSS.n162 VSS.n151 0.274227
R737 VSS.n176 VSS.n172 0.274227
R738 VSS.n191 VSS.n186 0.274227
R739 VSS.n215 VSS.n214 0.272997
R740 VSS.n207 VSS.n206 0.272549
R741 VSS.n230 VSS.n229 0.270518
R742 VSS.n238 VSS.n237 0.270518
R743 VSS.n246 VSS.n245 0.270518
R744 VSS.n254 VSS.n253 0.270518
R745 VSS.n262 VSS.n261 0.270518
R746 VSS.n270 VSS.n269 0.270518
R747 VSS.n278 VSS.n277 0.270518
R748 VSS.n286 VSS.n285 0.270518
R749 VSS.n294 VSS.n293 0.270518
R750 VSS.n302 VSS.n301 0.270518
R751 VSS.n310 VSS.n309 0.270518
R752 VSS.n318 VSS.n317 0.270518
R753 VSS.n326 VSS.n325 0.270518
R754 VSS.n334 VSS.n333 0.270518
R755 VSS.n342 VSS.n341 0.270518
R756 VSS.n350 VSS.n349 0.270518
R757 VSS.n225 VSS.n224 0.266747
R758 VSS.n233 VSS.n232 0.266747
R759 VSS.n241 VSS.n240 0.266747
R760 VSS.n249 VSS.n248 0.266747
R761 VSS.n257 VSS.n256 0.266747
R762 VSS.n265 VSS.n264 0.266747
R763 VSS.n273 VSS.n272 0.266747
R764 VSS.n281 VSS.n280 0.266747
R765 VSS.n289 VSS.n288 0.266747
R766 VSS.n297 VSS.n296 0.266747
R767 VSS.n305 VSS.n304 0.266747
R768 VSS.n313 VSS.n312 0.266747
R769 VSS.n321 VSS.n320 0.266747
R770 VSS.n329 VSS.n328 0.266747
R771 VSS.n337 VSS.n336 0.266747
R772 VSS.n345 VSS.n344 0.266747
R773 VSS.n220 VSS.n219 0.246727
R774 VSS.n123 VSS.n122 0.245497
R775 VSS.n227 VSS.n226 0.240049
R776 VSS.n235 VSS.n234 0.240049
R777 VSS.n243 VSS.n242 0.240049
R778 VSS.n251 VSS.n250 0.240049
R779 VSS.n259 VSS.n258 0.240049
R780 VSS.n267 VSS.n266 0.240049
R781 VSS.n275 VSS.n274 0.240049
R782 VSS.n283 VSS.n282 0.240049
R783 VSS.n291 VSS.n290 0.240049
R784 VSS.n299 VSS.n298 0.240049
R785 VSS.n307 VSS.n306 0.240049
R786 VSS.n315 VSS.n314 0.240049
R787 VSS.n323 VSS.n322 0.240049
R788 VSS.n331 VSS.n330 0.240049
R789 VSS.n339 VSS.n338 0.240049
R790 VSS.n347 VSS.n346 0.240049
R791 VSS.n401 VSS.n132 0.237997
R792 VSS.n389 VSS.n141 0.237997
R793 VSS.n166 VSS.n151 0.237997
R794 VSS.n180 VSS.n172 0.237997
R795 VSS.n363 VSS.n186 0.237997
R796 VSS.n116 VSS.n110 0.234227
R797 VSS.n211 VSS.n210 0.232997
R798 VSS.n212 VSS.n211 0.231727
R799 VSS.n118 VSS.n110 0.230497
R800 VSS.n123 VSS.n121 0.219227
R801 VSS.n219 VSS.n218 0.217997
R802 VSS.n223 VSS.n222 0.211543
R803 VSS.n206 VSS.n205 0.201058
R804 VSS.n113 VSS.n112 0.200293
R805 VSS.n216 VSS.n215 0.191727
R806 VSS.n109 VSS.n108 0.190497
R807 VSS.n8 VSS.n124 0.318488
R808 VSS.n113 VSS.n104 0.161058
R809 VSS.n224 VSS.n223 0.161058
R810 VSS.n205 VSS.n204 0.160293
R811 VSS.n231 VSS.n230 0.15705
R812 VSS.n239 VSS.n238 0.15705
R813 VSS.n247 VSS.n246 0.15705
R814 VSS.n255 VSS.n254 0.15705
R815 VSS.n263 VSS.n262 0.15705
R816 VSS.n271 VSS.n270 0.15705
R817 VSS.n279 VSS.n278 0.15705
R818 VSS.n287 VSS.n286 0.15705
R819 VSS.n295 VSS.n294 0.15705
R820 VSS.n303 VSS.n302 0.15705
R821 VSS.n311 VSS.n310 0.15705
R822 VSS.n319 VSS.n318 0.15705
R823 VSS.n327 VSS.n326 0.15705
R824 VSS.n335 VSS.n334 0.15705
R825 VSS.n343 VSS.n342 0.15705
R826 VSS.n126 VSS.n125 0.156007
R827 VSS.n129 VSS.n128 0.155582
R828 VSS.n404 VSS.n130 0.155582
R829 VSS.n135 VSS.n134 0.155582
R830 VSS.n397 VSS.n138 0.155582
R831 VSS.n392 VSS.n139 0.155582
R832 VSS.n145 VSS.n144 0.155582
R833 VSS.n385 VSS.n148 0.155582
R834 VSS.n380 VSS.n149 0.155582
R835 VSS.n155 VSS.n154 0.155582
R836 VSS.n169 VSS.n168 0.155582
R837 VSS.n373 VSS.n170 0.155582
R838 VSS.n175 VSS.n174 0.155582
R839 VSS.n183 VSS.n182 0.155582
R840 VSS.n366 VSS.n184 0.155582
R841 VSS.n190 VSS.n189 0.155582
R842 VSS.n359 VSS.n193 0.155582
R843 VSS.n354 VSS.n194 0.155582
R844 VSS.n199 VSS.n198 0.155582
R845 VSS.n120 VSS.n118 0.149888
R846 VSS.n213 VSS.n212 0.14955
R847 VSS.n410 VSS.n409 0.149476
R848 VSS.n408 VSS.n407 0.149476
R849 VSS.n402 VSS.n131 0.149476
R850 VSS.n401 VSS.n400 0.149476
R851 VSS.n396 VSS.n395 0.149476
R852 VSS.n390 VSS.n140 0.149476
R853 VSS.n389 VSS.n388 0.149476
R854 VSS.n384 VSS.n383 0.149476
R855 VSS.n378 VSS.n150 0.149476
R856 VSS.n166 VSS.n165 0.149476
R857 VSS.n377 VSS.n376 0.149476
R858 VSS.n371 VSS.n171 0.149476
R859 VSS.n180 VSS.n179 0.149476
R860 VSS.n370 VSS.n369 0.149476
R861 VSS.n364 VSS.n185 0.149476
R862 VSS.n363 VSS.n362 0.149476
R863 VSS.n358 VSS.n357 0.149476
R864 VSS.n352 VSS.n195 0.149476
R865 VSS.n210 VSS.n209 0.147388
R866 VSS.n117 VSS.n116 0.14705
R867 VSS.n108 VSS.n106 0.142118
R868 VSS.n217 VSS.n216 0.142118
R869 VSS.n122 VSS.n105 0.134888
R870 VSS.n159 VSS.n152 0.134888
R871 VSS.n221 VSS.n220 0.13455
R872 VSS.n129 VSS.n127 0.129618
R873 VSS.n398 VSS.n397 0.129618
R874 VSS.n386 VSS.n385 0.129618
R875 VSS.n169 VSS.n164 0.129618
R876 VSS.n183 VSS.n178 0.129618
R877 VSS.n360 VSS.n359 0.129618
R878 VSS.n406 VSS.n405 0.126138
R879 VSS.n394 VSS.n393 0.126138
R880 VSS.n382 VSS.n381 0.126138
R881 VSS.n375 VSS.n374 0.126138
R882 VSS.n368 VSS.n367 0.126138
R883 VSS.n356 VSS.n355 0.126138
R884 VSS.n82 VSS.n399 0.156005
R885 VSS.n86 VSS.n387 0.156005
R886 VSS.n167 VSS.n91 0.156005
R887 VSS.n181 VSS.n96 0.156005
R888 VSS.n100 VSS.n361 0.156005
R889 VSS.n222 VSS.n221 0.122388
R890 VSS.n124 VSS.n105 0.12205
R891 VSS.n135 VSS.n133 0.12205
R892 VSS.n145 VSS.n143 0.12205
R893 VSS.n155 VSS.n153 0.12205
R894 VSS.n161 VSS.n152 0.12205
R895 VSS.n175 VSS.n173 0.12205
R896 VSS.n190 VSS.n188 0.12205
R897 VSS.n200 VSS.n199 0.12205
R898 VSS.n121 VSS.n106 0.114618
R899 VSS.n218 VSS.n217 0.114618
R900 VSS.n232 VSS.n231 0.113638
R901 VSS.n240 VSS.n239 0.113638
R902 VSS.n248 VSS.n247 0.113638
R903 VSS.n256 VSS.n255 0.113638
R904 VSS.n264 VSS.n263 0.113638
R905 VSS.n272 VSS.n271 0.113638
R906 VSS.n280 VSS.n279 0.113638
R907 VSS.n288 VSS.n287 0.113638
R908 VSS.n296 VSS.n295 0.113638
R909 VSS.n304 VSS.n303 0.113638
R910 VSS.n312 VSS.n311 0.113638
R911 VSS.n320 VSS.n319 0.113638
R912 VSS.n328 VSS.n327 0.113638
R913 VSS.n336 VSS.n335 0.113638
R914 VSS.n344 VSS.n343 0.113638
R915 VSS.n117 VSS.n115 0.109888
R916 VSS.n351 VSS.n350 0.109618
R917 VSS.n209 VSS.n208 0.10955
R918 VSS.n214 VSS.n213 0.107388
R919 VSS.n120 VSS.n119 0.10705
R920 VSS.n133 VSS.n80 0.106138
R921 VSS.n143 VSS.n142 0.106138
R922 VSS.n153 VSS.n89 0.106138
R923 VSS.n173 VSS.n94 0.106138
R924 VSS.n188 VSS.n187 0.106138
R925 VSS.n200 VSS.n197 0.106138
R926 VSS.n79 VSS.n406 0.166153
R927 VSS.n84 VSS.n394 0.166153
R928 VSS.n88 VSS.n382 0.166153
R929 VSS.n93 VSS.n375 0.166153
R930 VSS.n98 VSS.n368 0.166153
R931 VSS.n102 VSS.n356 0.166153
R932 VSS.n403 VSS.n402 0.105361
R933 VSS.n391 VSS.n390 0.105361
R934 VSS.n379 VSS.n378 0.105361
R935 VSS.n372 VSS.n371 0.105361
R936 VSS.n365 VSS.n364 0.105361
R937 VSS.n353 VSS.n352 0.105361
R938 VSS.n405 VSS.n404 0.10205
R939 VSS.n393 VSS.n392 0.10205
R940 VSS.n381 VSS.n380 0.10205
R941 VSS.n374 VSS.n373 0.10205
R942 VSS.n367 VSS.n366 0.10205
R943 VSS.n355 VSS.n354 0.10205
R944 VSS.n127 VSS.n126 0.0983676
R945 VSS.n399 VSS.n398 0.0983676
R946 VSS.n387 VSS.n386 0.0983676
R947 VSS.n167 VSS.n164 0.0983676
R948 VSS.n181 VSS.n178 0.0983676
R949 VSS.n361 VSS.n360 0.0983676
R950 VSS.n81 VSS.n80 0.176279
R951 VSS.n390 VSS.n85 0.0435295
R952 VSS.n90 VSS.n89 0.176279
R953 VSS.n95 VSS.n94 0.176279
R954 VSS.n364 VSS.n99 0.0435295
R955 VSS.n352 VSS.n103 0.0435295
R956 VSS.n411 VSS.n104 0.078
R957 VSS.n204 VSS.n75 0.078
R958 VSS.n408 VSS.n78 0.103847
R959 VSS.n396 VSS.n83 0.103847
R960 VSS.n384 VSS.n87 0.103847
R961 VSS.n377 VSS.n92 0.103847
R962 VSS.n370 VSS.n97 0.103847
R963 VSS.n358 VSS.n101 0.103847
R964 VSS.n410 VSS.n125 0.0633093
R965 VSS VSS.n411 0.038
R966 VSS VSS.n75 0.038
R967 VSS.n41 VSS.t3 83.4525
R968 VSS.n27 VSS.n11 0.382621
R969 VSS.n27 VSS.n10 0.382621
R970 VSS.n56 VSS.t153 111.644
R971 VSS.n27 VSS.n12 0.382621
R972 VSS.n27 VSS.n9 0.382621
R973 VSS.n27 VSS.n55 6.82258
R974 VSS.n27 VSS.n54 6.82258
R975 VSS.n27 VSS.n53 6.82258
R976 VSS.n40 VSS.t150 83.4525
R977 VSS.n27 VSS.n52 6.82258
R978 VSS.n15 VSS.t6 83.4525
R979 VSS.n354 VSS.n353 0.0166107
R980 VSS.n366 VSS.n365 0.0166107
R981 VSS.n373 VSS.n372 0.0166107
R982 VSS.n380 VSS.n379 0.0166107
R983 VSS.n392 VSS.n391 0.0166107
R984 VSS.n404 VSS.n403 0.0166107
R985 VSS.n4 VSS.t108 82.6299
R986 VSS.n6 VSS.t78 140.651
R987 VSS.n6 VSS.n4 1.27471
R988 a_3747_216.n0 a_3747_216.t2 52.0388
R989 a_3747_216.t0 a_3747_216.n0 35.4491
R990 a_3747_216.n0 a_3747_216.t3 33.5891
R991 a_3747_216.t1 a_3747_216.t0 5.61942
R992 a_3171_216.n0 a_3171_216.t2 51.8377
R993 a_3171_216.n0 a_3171_216.t3 33.3881
R994 a_3171_216.t0 a_3171_216.n0 31.8923
R995 a_3171_216.t1 a_3171_216.t0 5.61777
R996 a_2595_216.n0 a_2595_216.t2 51.6367
R997 a_2595_216.n0 a_2595_216.t3 33.187
R998 a_2595_216.t0 a_2595_216.n0 27.993
R999 a_2595_216.t1 a_2595_216.t0 5.73018
R1000 a_3747_952.n0 a_3747_952.t2 38.0081
R1001 a_3747_952.n0 a_3747_952.t3 33.3957
R1002 a_3747_952.n1 a_3747_952.t4 33.3957
R1003 a_3747_952.n2 a_3747_952.t5 33.3957
R1004 a_3747_952.n3 a_3747_952.t6 33.3957
R1005 a_3747_952.n4 a_3747_952.t7 33.3957
R1006 a_3747_952.n5 a_3747_952.t8 33.3957
R1007 a_3747_952.n6 a_3747_952.t9 33.3957
R1008 a_3747_952.t0 a_3747_952.n6 23.2419
R1009 a_3747_952.t1 a_3747_952.t0 5.61942
R1010 a_3747_952.n6 a_3747_952.n5 4.61291
R1011 a_3747_952.n5 a_3747_952.n4 4.61291
R1012 a_3747_952.n4 a_3747_952.n3 4.61291
R1013 a_3747_952.n3 a_3747_952.n2 4.61291
R1014 a_3747_952.n2 a_3747_952.n1 4.61291
R1015 a_3747_952.n1 a_3747_952.n0 4.61291
R1016 a_3171_952.n0 a_3171_952.t2 37.8054
R1017 a_3171_952.n0 a_3171_952.t3 33.193
R1018 a_3171_952.n1 a_3171_952.t4 33.193
R1019 a_3171_952.n2 a_3171_952.t5 33.193
R1020 a_3171_952.n3 a_3171_952.t6 33.193
R1021 a_3171_952.n4 a_3171_952.t7 33.193
R1022 a_3171_952.n5 a_3171_952.t8 33.193
R1023 a_3171_952.n6 a_3171_952.t9 33.193
R1024 a_3171_952.t0 a_3171_952.n6 23.0313
R1025 a_3171_952.t1 a_3171_952.t0 5.61777
R1026 a_3171_952.n6 a_3171_952.n5 4.61291
R1027 a_3171_952.n5 a_3171_952.n4 4.61291
R1028 a_3171_952.n4 a_3171_952.n3 4.61291
R1029 a_3171_952.n3 a_3171_952.n2 4.61291
R1030 a_3171_952.n2 a_3171_952.n1 4.61291
R1031 a_3171_952.n1 a_3171_952.n0 4.61291
R1032 a_2595_952.n0 a_2595_952.t2 37.7691
R1033 a_2595_952.n0 a_2595_952.t3 33.1567
R1034 a_2595_952.n1 a_2595_952.t4 33.1567
R1035 a_2595_952.n2 a_2595_952.t5 33.1567
R1036 a_2595_952.n3 a_2595_952.t6 33.1567
R1037 a_2595_952.n4 a_2595_952.t7 33.1567
R1038 a_2595_952.n5 a_2595_952.t8 33.1567
R1039 a_2595_952.n6 a_2595_952.t9 33.1567
R1040 a_2595_952.t0 a_2595_952.n6 22.7941
R1041 a_2595_952.t1 a_2595_952.t0 5.65522
R1042 a_2595_952.n6 a_2595_952.n5 4.61291
R1043 a_2595_952.n5 a_2595_952.n4 4.61291
R1044 a_2595_952.n4 a_2595_952.n3 4.61291
R1045 a_2595_952.n3 a_2595_952.n2 4.61291
R1046 a_2595_952.n2 a_2595_952.n1 4.61291
R1047 a_2595_952.n1 a_2595_952.n0 4.61291
R1048 a_2019_952.n0 a_2019_952.t2 37.9701
R1049 a_2019_952.n0 a_2019_952.t3 33.3577
R1050 a_2019_952.n1 a_2019_952.t4 33.3577
R1051 a_2019_952.n2 a_2019_952.t5 33.3577
R1052 a_2019_952.n3 a_2019_952.t6 33.3577
R1053 a_2019_952.n4 a_2019_952.t7 33.3577
R1054 a_2019_952.t0 a_2019_952.t9 22.5945
R1055 a_2019_952.t1 a_2019_952.t0 5.62052
R1056 a_2019_952.t9 a_2019_952.t8 4.61291
R1057 a_2019_952.t8 a_2019_952.n4 4.61291
R1058 a_2019_952.n4 a_2019_952.n3 4.61291
R1059 a_2019_952.n3 a_2019_952.n2 4.61291
R1060 a_2019_952.n2 a_2019_952.n1 4.61291
R1061 a_2019_952.n1 a_2019_952.n0 4.61291
C578 MUX_OUT VSS 3.24057f
C579 MUX_SEL4 VSS 1.63591f
C580 DELAY_OUT_TAP0 VSS 0.37425f
C581 MUX_SEL3 VSS 0.90686f
C582 MUX_SEL2 VSS 1.81137f
C583 DELAY_OUT_TAP31 VSS 0.41949f
C584 DELAY_OUT_TAP30 VSS 0.43238f
C585 DELAY_OUT_TAP29 VSS 0.30856f
C586 DELAY_OUT_TAP28 VSS 0.4381f
C587 DELAY_OUT_TAP27 VSS 0.38455f
C588 DELAY_OUT_TAP26 VSS 0.43238f
C589 DELAY_OUT_TAP25 VSS 0.30856f
C590 DELAY_OUT_TAP24 VSS 0.4381f
C591 DELAY_OUT_TAP23 VSS 0.38455f
C592 DELAY_OUT_TAP22 VSS 0.43238f
C593 DELAY_OUT_TAP21 VSS 0.30856f
C594 DELAY_OUT_TAP20 VSS 0.4381f
C595 DELAY_OUT_TAP19 VSS 0.38455f
C596 DELAY_OUT_TAP18 VSS 0.43238f
C597 DELAY_OUT_TAP17 VSS 0.30374f
C598 DELAY_OUT_TAP16 VSS 0.42869f
C599 DELAY_OUT_TAP15 VSS 0.38342f
C600 DELAY_OUT_TAP14 VSS 0.43238f
C601 DELAY_OUT_TAP13 VSS 0.30856f
C602 DELAY_OUT_TAP12 VSS 0.43643f
C603 DELAY_OUT_TAP11 VSS 0.38455f
C604 DELAY_OUT_TAP10 VSS 0.43238f
C605 DELAY_OUT_TAP9 VSS 0.30856f
C606 DELAY_OUT_TAP8 VSS 0.43643f
C607 DELAY_OUT_TAP7 VSS 0.38455f
C608 DELAY_OUT_TAP6 VSS 0.43238f
C609 DELAY_OUT_TAP5 VSS 0.30856f
C610 DELAY_OUT_TAP4 VSS 0.43585f
C611 DELAY_OUT_TAP3 VSS 0.38455f
C612 DELAY_OUT_TAP2 VSS 0.43238f
C613 DELAY_OUT_TAP1 VSS 0.30776f
C614 MUX_SEL1 VSS 0.9549f
C615 MUX_SEL0 VSS 1.81267f
C616 VDD VSS 26.9372f
C617 a_26985_424# VSS 0.18005f ; **FLOATING
C618 a_23945_424# VSS 0.18005f ; **FLOATING
C619 a_20905_424# VSS 0.18005f ; **FLOATING
C620 a_17865_424# VSS 0.1767f ; **FLOATING
C621 a_16851_214# VSS 0.38749f ; **FLOATING
C622 a_16108_194# VSS 3.87256f ; **FLOATING
C623 a_15964_194# VSS 0.18406f ; **FLOATING
C624 a_15765_368# VSS 0.36264f ; **FLOATING
C625 a_14825_424# VSS 0.18005f ; **FLOATING
C626 a_11785_424# VSS 0.18005f ; **FLOATING
C627 a_8745_424# VSS 0.18005f ; **FLOATING
C628 a_5731_194# VSS 3.39133f ; **FLOATING
C629 a_2019_216# VSS 1.616f ; **FLOATING
C630 a_5705_424# VSS 0.17716f ; **FLOATING
C631 a_3449_236# VSS 0.18478f ; **FLOATING
C632 a_2873_236# VSS 0.18321f ; **FLOATING
C633 a_2297_236# VSS 0.18321f ; **FLOATING
C634 a_1721_236# VSS 0.17001f ; **FLOATING
C635 a_1544_194# VSS 0.30014f ; **FLOATING
C636 a_1256_194# VSS 0.84266f ; **FLOATING
C637 a_27991_913# VSS 0.18706f ; **FLOATING
C638 a_27915_949# VSS 0.10926f ; **FLOATING
C639 a_27124_913# VSS 0.17878f ; **FLOATING
C640 a_27048_949# VSS 0.12122f ; **FLOATING
C641 a_26471_913# VSS 0.18175f ; **FLOATING
C642 a_26395_949# VSS 0.11073f ; **FLOATING
C643 a_25604_913# VSS 0.18087f ; **FLOATING
C644 a_25630_949# VSS 0.43187f ; **FLOATING
C645 a_25528_949# VSS 0.12433f ; **FLOATING
C646 a_24951_913# VSS 0.18335f ; **FLOATING
C647 a_24875_949# VSS 0.11016f ; **FLOATING
C648 a_24084_913# VSS 0.17878f ; **FLOATING
C649 a_24008_949# VSS 0.12122f ; **FLOATING
C650 a_23431_913# VSS 0.18175f ; **FLOATING
C651 a_23355_949# VSS 0.11073f ; **FLOATING
C652 a_22564_913# VSS 0.18087f ; **FLOATING
C653 a_22590_949# VSS 0.40111f ; **FLOATING
C654 a_22488_949# VSS 0.12433f ; **FLOATING
C655 a_21911_913# VSS 0.18335f ; **FLOATING
C656 a_21835_949# VSS 0.11016f ; **FLOATING
C657 a_21044_913# VSS 0.17878f ; **FLOATING
C658 a_20968_949# VSS 0.12122f ; **FLOATING
C659 a_20391_913# VSS 0.18175f ; **FLOATING
C660 a_20315_949# VSS 0.11073f ; **FLOATING
C661 a_19524_913# VSS 0.18087f ; **FLOATING
C662 a_19550_949# VSS 0.4036f ; **FLOATING
C663 a_19448_949# VSS 0.12433f ; **FLOATING
C664 a_18871_913# VSS 0.18335f ; **FLOATING
C665 a_18795_949# VSS 0.11016f ; **FLOATING
C666 a_18004_913# VSS 0.17878f ; **FLOATING
C667 a_17928_949# VSS 0.12122f ; **FLOATING
C668 a_17351_913# VSS 0.18022f ; **FLOATING
C669 a_17275_949# VSS 0.10926f ; **FLOATING
C670 a_16484_913# VSS 0.18023f ; **FLOATING
C671 a_16510_949# VSS 0.35732f ; **FLOATING
C672 a_16408_949# VSS 0.1229f ; **FLOATING
C673 a_15831_913# VSS 0.17846f ; **FLOATING
C674 a_15755_949# VSS 0.10926f ; **FLOATING
C675 a_14964_913# VSS 0.17878f ; **FLOATING
C676 a_14888_949# VSS 0.12122f ; **FLOATING
C677 a_14311_913# VSS 0.18175f ; **FLOATING
C678 a_14235_949# VSS 0.11073f ; **FLOATING
C679 a_13444_913# VSS 0.18087f ; **FLOATING
C680 a_13470_949# VSS 0.3713f ; **FLOATING
C681 a_13368_949# VSS 0.12433f ; **FLOATING
C682 a_12791_913# VSS 0.18335f ; **FLOATING
C683 a_12715_949# VSS 0.11016f ; **FLOATING
C684 a_11924_913# VSS 0.17878f ; **FLOATING
C685 a_11848_949# VSS 0.12122f ; **FLOATING
C686 a_11271_913# VSS 0.18175f ; **FLOATING
C687 a_11195_949# VSS 0.11073f ; **FLOATING
C688 a_10404_913# VSS 0.18087f ; **FLOATING
C689 a_10430_949# VSS 0.38462f ; **FLOATING
C690 a_10328_949# VSS 0.12433f ; **FLOATING
C691 a_9751_913# VSS 0.18335f ; **FLOATING
C692 a_9675_949# VSS 0.11016f ; **FLOATING
C693 a_8884_913# VSS 0.17878f ; **FLOATING
C694 a_8808_949# VSS 0.12122f ; **FLOATING
C695 a_8231_913# VSS 0.18175f ; **FLOATING
C696 a_8155_949# VSS 0.11073f ; **FLOATING
C697 a_7364_913# VSS 0.18087f ; **FLOATING
C698 a_7390_949# VSS 0.38153f ; **FLOATING
C699 a_7288_949# VSS 0.12433f ; **FLOATING
C700 a_6711_913# VSS 0.18335f ; **FLOATING
C701 a_6635_949# VSS 0.11016f ; **FLOATING
C702 a_5844_913# VSS 0.17878f ; **FLOATING
C703 a_5768_949# VSS 0.12122f ; **FLOATING
C704 a_5191_913# VSS 0.18022f ; **FLOATING
C705 a_5115_949# VSS 0.10926f ; **FLOATING
C706 a_4324_913# VSS 0.18023f ; **FLOATING
C707 a_4350_949# VSS 0.33452f ; **FLOATING
C708 a_4248_949# VSS 0.12443f ; **FLOATING
C709 a_27705_949# VSS 0.2535f ; **FLOATING
C710 a_26185_949# VSS 0.23529f ; **FLOATING
C711 a_24665_949# VSS 0.25486f ; **FLOATING
C712 a_23145_949# VSS 0.23529f ; **FLOATING
C713 a_21625_949# VSS 0.25486f ; **FLOATING
C714 a_20105_949# VSS 0.23529f ; **FLOATING
C715 a_18585_949# VSS 0.25486f ; **FLOATING
C716 a_17065_949# VSS 0.23439f ; **FLOATING
C717 a_15545_949# VSS 0.2535f ; **FLOATING
C718 a_14025_949# VSS 0.23529f ; **FLOATING
C719 a_12505_949# VSS 0.25486f ; **FLOATING
C720 a_10985_949# VSS 0.23529f ; **FLOATING
C721 a_9465_949# VSS 0.25486f ; **FLOATING
C722 a_7945_949# VSS 0.23529f ; **FLOATING
C723 a_6425_949# VSS 0.25486f ; **FLOATING
C724 a_4905_949# VSS 0.23602f ; **FLOATING
C725 a_4157_1218# VSS 0.3431f ; **FLOATING
C726 a_3449_1300# VSS 0.18603f ; **FLOATING
C727 a_2873_1300# VSS 0.18321f ; **FLOATING
C728 a_2297_1300# VSS 0.18321f ; **FLOATING
C729 a_1721_1300# VSS 0.17001f ; **FLOATING
C730 a_1544_949# VSS 0.29963f ; **FLOATING
C731 a_1256_949# VSS 0.83916f ; **FLOATING
C732 a_2019_952.t2 VSS 0.8244f ; **FLOATING
C733 a_2019_952.t3 VSS 0.62586f ; **FLOATING
C734 a_2019_952.n0 VSS 4.43882f ; **FLOATING
C735 a_2019_952.t4 VSS 0.62586f ; **FLOATING
C736 a_2019_952.n1 VSS 3.00298f ; **FLOATING
C737 a_2019_952.t5 VSS 0.62586f ; **FLOATING
C738 a_2019_952.n2 VSS 3.00298f ; **FLOATING
C739 a_2019_952.t6 VSS 0.62586f ; **FLOATING
C740 a_2019_952.n3 VSS 3.00298f ; **FLOATING
C741 a_2019_952.t7 VSS 0.62586f ; **FLOATING
C742 a_2019_952.n4 VSS 3.00298f ; **FLOATING
C743 a_2019_952.t8 VSS 3.62885f ; **FLOATING
C744 a_2019_952.t9 VSS 4.83408f ; **FLOATING
C745 a_2019_952.t0 VSS 0.95051f ; **FLOATING
C746 a_2019_952.t1 VSS 0.27016f ; **FLOATING
C747 a_2595_952.t2 VSS 1.35979f ; **FLOATING
C748 a_2595_952.t3 VSS 1.01554f ; **FLOATING
C749 a_2595_952.n0 VSS 7.72017f ; **FLOATING
C750 a_2595_952.t4 VSS 1.01554f ; **FLOATING
C751 a_2595_952.n1 VSS 5.2455f ; **FLOATING
C752 a_2595_952.t5 VSS 1.01554f ; **FLOATING
C753 a_2595_952.n2 VSS 5.2455f ; **FLOATING
C754 a_2595_952.t6 VSS 1.01554f ; **FLOATING
C755 a_2595_952.n3 VSS 5.2455f ; **FLOATING
C756 a_2595_952.t7 VSS 1.01554f ; **FLOATING
C757 a_2595_952.n4 VSS 5.2455f ; **FLOATING
C758 a_2595_952.t8 VSS 1.01554f ; **FLOATING
C759 a_2595_952.n5 VSS 5.2455f ; **FLOATING
C760 a_2595_952.t9 VSS 1.01554f ; **FLOATING
C761 a_2595_952.n6 VSS 7.54534f ; **FLOATING
C762 a_2595_952.t0 VSS 1.74193f ; **FLOATING
C763 a_2595_952.t1 VSS 0.47972f ; **FLOATING
C764 a_3171_952.t2 VSS 1.37934f ; **FLOATING
C765 a_3171_952.t3 VSS 1.03353f ; **FLOATING
C766 a_3171_952.n0 VSS 7.75003f ; **FLOATING
C767 a_3171_952.t4 VSS 1.03353f ; **FLOATING
C768 a_3171_952.n1 VSS 5.26146f ; **FLOATING
C769 a_3171_952.t5 VSS 1.03353f ; **FLOATING
C770 a_3171_952.n2 VSS 5.26146f ; **FLOATING
C771 a_3171_952.t6 VSS 1.03353f ; **FLOATING
C772 a_3171_952.n3 VSS 5.26146f ; **FLOATING
C773 a_3171_952.t7 VSS 1.03353f ; **FLOATING
C774 a_3171_952.n4 VSS 5.26146f ; **FLOATING
C775 a_3171_952.t8 VSS 1.03353f ; **FLOATING
C776 a_3171_952.n5 VSS 5.26146f ; **FLOATING
C777 a_3171_952.t9 VSS 1.03353f ; **FLOATING
C778 a_3171_952.n6 VSS 7.65529f ; **FLOATING
C779 a_3171_952.t0 VSS 1.76377f ; **FLOATING
C780 a_3171_952.t1 VSS 0.47908f ; **FLOATING
C781 a_3747_952.t2 VSS 0.96135f ; **FLOATING
C782 a_3747_952.t3 VSS 0.73189f ; **FLOATING
C783 a_3747_952.n0 VSS 5.12748f ; **FLOATING
C784 a_3747_952.t4 VSS 0.73189f ; **FLOATING
C785 a_3747_952.n1 VSS 3.46611f ; **FLOATING
C786 a_3747_952.t5 VSS 0.73189f ; **FLOATING
C787 a_3747_952.n2 VSS 3.46611f ; **FLOATING
C788 a_3747_952.t6 VSS 0.73189f ; **FLOATING
C789 a_3747_952.n3 VSS 3.46611f ; **FLOATING
C790 a_3747_952.t7 VSS 0.73189f ; **FLOATING
C791 a_3747_952.n4 VSS 3.46611f ; **FLOATING
C792 a_3747_952.t8 VSS 0.73189f ; **FLOATING
C793 a_3747_952.n5 VSS 3.46611f ; **FLOATING
C794 a_3747_952.t9 VSS 0.73189f ; **FLOATING
C795 a_3747_952.n6 VSS 5.14677f ; **FLOATING
C796 a_3747_952.t0 VSS 1.17618f ; **FLOATING
C797 a_3747_952.t1 VSS 0.31095f ; **FLOATING
C798 a_2595_216.t0 VSS 3.2703f ; **FLOATING
C799 a_2595_216.t2 VSS 5.04135f ; **FLOATING
C800 a_2595_216.t3 VSS 1.20629f ; **FLOATING
C801 a_2595_216.n0 VSS 26.8663f ; **FLOATING
C802 a_2595_216.t1 VSS 0.49571f ; **FLOATING
C803 a_3171_216.t2 VSS 5.0499f ; **FLOATING
C804 a_3171_216.t3 VSS 1.21145f ; **FLOATING
C805 a_3171_216.n0 VSS 29.8488f ; **FLOATING
C806 a_3171_216.t0 VSS 4.61136f ; **FLOATING
C807 a_3171_216.t1 VSS 0.49728f ; **FLOATING
C808 a_3747_216.t2 VSS 3.09124f ; **FLOATING
C809 a_3747_216.t3 VSS 0.74403f ; **FLOATING
C810 a_3747_216.n0 VSS 19.8835f ; **FLOATING
C811 a_3747_216.t0 VSS 3.68799f ; **FLOATING
C812 a_3747_216.t1 VSS 0.30529f ; **FLOATING
.ends
