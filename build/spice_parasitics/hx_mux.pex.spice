* NGSPICE file created from hx_mux.ext - technology: ihp-sg13g2

.subckt hx_mux VSS VDD DELAY_OUT_TAP0 DELAY_OUT_TAP1 DELAY_OUT_TAP2 DELAY_OUT_TAP3
+ DELAY_OUT_TAP4 DELAY_OUT_TAP5 DELAY_OUT_TAP6 DELAY_OUT_TAP7 DELAY_OUT_TAP8 DELAY_OUT_TAP9
+ DELAY_OUT_TAP10 DELAY_OUT_TAP11 DELAY_OUT_TAP12 DELAY_OUT_TAP13 DELAY_OUT_TAP14
+ DELAY_OUT_TAP15 DELAY_OUT_TAP16 DELAY_OUT_TAP17 DELAY_OUT_TAP18 DELAY_OUT_TAP19
+ DELAY_OUT_TAP20 DELAY_OUT_TAP21 DELAY_OUT_TAP22 DELAY_OUT_TAP23 DELAY_OUT_TAP24
+ DELAY_OUT_TAP25 DELAY_OUT_TAP26 DELAY_OUT_TAP27 DELAY_OUT_TAP28 DELAY_OUT_TAP29
+ DELAY_OUT_TAP30 DELAY_OUT_TAP31 MUX_SEL0 MUX_SEL1 MUX_OUT MUX_SEL4 MUX_SEL2 MUX_SEL3
X0 VDD a_2019_952.t9 a_4324_913# VDD sg13_lv_pmos ad=0.3808p pd=2.92u as=0.3808p ps=2.92u w=1.12u l=0.13u
X1 a_1256_194# MUX_SEL2 VDD VDD sg13_lv_pmos ad=0.3808p pd=2.92u as=0.3808p ps=2.92u w=1.12u l=0.13u
X2 VDD a_3171_952.t8 a_8884_913# VDD sg13_lv_pmos ad=0.3808p pd=2.92u as=0.3808p ps=2.92u w=1.12u l=0.13u
X3 a_16108_194# a_15765_368# a_15964_194# VDD sg13_lv_pmos ad=0.3808p pd=2.92u as=0.3304p ps=1.71u w=1.12u l=0.13u
X4 a_22590_949# a_24951_913# a_24875_949# VDD sg13_lv_pmos ad=0.3808p pd=2.92u as=0.2128p ps=1.5u w=1.12u l=0.13u
X5 VDD a_2595_952.t7 a_11271_913# VDD sg13_lv_pmos ad=0.3808p pd=2.92u as=0.3808p ps=2.92u w=1.12u l=0.13u
X6 VSS.t275 VDD VSS.t273 VSS.t274 sg13_lv_nmos ad=79.8f pd=0.8u as=0 ps=0 w=0.42u l=1u
X7 a_7390_949# a_2595_952.t8 a_8155_949# VSS.t240 sg13_lv_nmos ad=0.2516p pd=2.16u as=0.1406p ps=1.12u w=0.74u l=0.13u
X8 VSS.t278 VDD VSS.t277 VSS.t276 sg13_lv_nmos ad=0.1428p pd=1.52u as=0 ps=0 w=0.42u l=1u
X9 VDD VSS.t381 VDD VDD sg13_lv_pmos ad=0.19p pd=1.38u as=0.14315n ps=0.71478m w=1u l=1u
X10 VSS.t104 DELAY_OUT_TAP11 a_12505_949# VSS.t191 sg13_lv_nmos ad=0.1665p pd=1.19u as=0.2516p ps=2.16u w=0.74u l=0.13u
X11 MUX_OUT a_16851_214# VSS.t172 VSS.t171 sg13_lv_nmos ad=0.1406p pd=1.12u as=0.1371p ps=1.12u w=0.74u l=0.13u
X12 VDD a_3747_952.t9 a_6711_913# VDD sg13_lv_pmos ad=0.3808p pd=2.92u as=0.3808p ps=2.92u w=1.12u l=0.13u
X13 VSS.t343 VDD VSS.t342 VSS.t341 sg13_lv_nmos ad=0.1428p pd=1.52u as=0 ps=0 w=0.42u l=1u
X14 a_1544_194# MUX_SEL3 VDD VDD sg13_lv_pmos ad=0.3808p pd=2.92u as=0.3808p ps=2.92u w=1.12u l=0.13u
X15 VSS.t178 a_2595_216.t3 a_8745_424# VSS.t177 sg13_lv_nmos ad=0.2516p pd=2.16u as=0.2516p ps=2.16u w=0.74u l=0.13u
X16 a_10328_949# DELAY_OUT_TAP8 VSS.t216 VSS.t215 sg13_lv_nmos ad=0.1406p pd=1.12u as=0.2516p ps=2.16u w=0.74u l=0.13u
X17 a_22590_949# a_2019_952.t3 a_22488_949# VSS.t132 sg13_lv_nmos ad=0.2516p pd=2.16u as=0.1406p ps=1.12u w=0.74u l=0.13u
X18 a_8808_949# DELAY_OUT_TAP6 VSS.t213 VSS.t212 sg13_lv_nmos ad=0.1406p pd=1.12u as=0.2516p ps=2.16u w=0.74u l=0.13u
X19 VSS.t13 DELAY_OUT_TAP31 a_27705_949# VSS.t12 sg13_lv_nmos ad=0.1665p pd=1.19u as=0.2516p ps=2.16u w=0.74u l=0.13u
X20 a_11848_949# DELAY_OUT_TAP10 VDD VDD sg13_lv_pmos ad=0.2128p pd=1.5u as=0.3808p ps=2.92u w=1.12u l=0.13u
X21 VDD a_3171_952.t3 a_24084_913# VDD sg13_lv_pmos ad=0.3808p pd=2.92u as=0.3808p ps=2.92u w=1.12u l=0.13u
X22 a_1721_236# a_1256_194# VDD VDD sg13_lv_pmos ad=0.1596p pd=1.22u as=0.2856p ps=2.36u w=0.84u l=0.13u
X23 a_6635_949# a_6425_949# VSS.t158 VSS.t157 sg13_lv_nmos ad=0.1406p pd=1.12u as=0.1665p ps=1.19u w=0.74u l=0.13u
X24 VDD VSS.t374 VDD VDD sg13_lv_pmos ad=0.34p pd=2.68u as=0 ps=0 w=1u l=1u
X25 VSS.t107 a_2595_952.t9 a_5191_913# VSS.t106 sg13_lv_nmos ad=0.2516p pd=2.16u as=0.2516p ps=2.16u w=0.74u l=0.13u
X26 VSS.t209 a_1256_949# a_2967_1300# VSS.t260 sg13_lv_nmos ad=0.1331p pd=1.12u as=0.1216p ps=1.02u w=0.64u l=0.13u
X27 a_4157_1218# DELAY_OUT_TAP0 VDD VDD sg13_lv_pmos ad=0.3808p pd=2.92u as=0.3808p ps=2.92u w=1.12u l=0.13u
X28 a_25528_949# DELAY_OUT_TAP28 VSS.t235 VSS.t234 sg13_lv_nmos ad=0.1406p pd=1.12u as=0.2516p ps=2.16u w=0.74u l=0.13u
X29 a_20315_949# a_20105_949# VSS.t115 VSS.t114 sg13_lv_nmos ad=0.1406p pd=1.12u as=0.1665p ps=1.19u w=0.74u l=0.13u
X30 a_5731_194# a_3747_216.t3 a_13470_949# VSS.t168 sg13_lv_nmos ad=0.2516p pd=2.16u as=0.2516p ps=2.16u w=0.74u l=0.13u
X31 VSS.t335 VDD VSS.t333 VSS.t334 sg13_lv_nmos ad=79.8f pd=0.8u as=0 ps=0 w=0.42u l=1u
X32 VSS.t300 VDD VSS.t298 VSS.t299 sg13_lv_nmos ad=79.8f pd=0.8u as=0 ps=0 w=0.42u l=1u
X33 VSS.t174 a_16851_214# MUX_OUT VSS.t173 sg13_lv_nmos ad=0.2516p pd=2.16u as=0.1406p ps=1.12u w=0.74u l=0.13u
X34 VDD a_1544_194# a_1721_236# VDD sg13_lv_pmos ad=0.1918p pd=1.5u as=0.1596p ps=1.22u w=0.84u l=0.13u
X35 VDD a_3747_952.t3 a_24951_913# VDD sg13_lv_pmos ad=0.3808p pd=2.92u as=0.3808p ps=2.92u w=1.12u l=0.13u
X36 VDD VSS.t386 VDD VDD sg13_lv_pmos ad=0.34p pd=2.68u as=0 ps=0 w=1u l=1u
X37 a_16408_949# DELAY_OUT_TAP16 VSS.t220 VSS.t219 sg13_lv_nmos ad=0.1406p pd=1.12u as=0.2516p ps=2.16u w=0.74u l=0.13u
X38 a_5731_194# a_2019_216# a_4350_949# VSS.t43 sg13_lv_nmos ad=0.2516p pd=2.16u as=0.2516p ps=2.16u w=0.74u l=0.13u
X39 VDD a_2595_952.t2 a_26471_913# VDD sg13_lv_pmos ad=0.3808p pd=2.92u as=0.3808p ps=2.92u w=1.12u l=0.13u
X40 a_7390_949# a_3747_952.t8 a_9675_949# VSS.t138 sg13_lv_nmos ad=0.2516p pd=2.16u as=0.1406p ps=1.12u w=0.74u l=0.13u
X41 VSS.t273 VDD VSS.t272 VSS.t271 sg13_lv_nmos ad=0.1428p pd=1.52u as=0 ps=0 w=0.42u l=1u
X42 VDD VSS.t357 VDD VDD sg13_lv_pmos ad=0.19p pd=1.38u as=0 ps=0 w=1u l=1u
X43 VDD DELAY_OUT_TAP13 a_14025_949# VDD sg13_lv_pmos ad=0.252p pd=1.57u as=0.3808p ps=2.92u w=1.12u l=0.13u
X44 a_10430_949# a_11924_913# a_11848_949# VDD sg13_lv_pmos ad=0.3808p pd=2.92u as=0.2128p ps=1.5u w=1.12u l=0.13u
X45 VDD a_2595_216.t3 a_8745_424# VDD sg13_lv_pmos ad=0.3808p pd=2.92u as=0.3808p ps=2.92u w=1.12u l=0.13u
X46 VSS.t69 a_3171_952.t5 a_18004_913# VSS.t68 sg13_lv_nmos ad=0.2516p pd=2.16u as=0.2516p ps=2.16u w=0.74u l=0.13u
X47 VDD DELAY_OUT_TAP15 a_15545_949# VDD sg13_lv_pmos ad=0.252p pd=1.57u as=0.3808p ps=2.92u w=1.12u l=0.13u
X48 a_3171_216.t1 a_2873_236# VDD VDD sg13_lv_pmos ad=0.2128p pd=1.5u as=0.1918p ps=1.5u w=1.12u l=0.13u
X49 a_14235_949# a_14025_949# VSS.t166 VSS.t165 sg13_lv_nmos ad=0.1406p pd=1.12u as=0.1665p ps=1.19u w=0.74u l=0.13u
X50 VSS.t102 a_3747_952.t7 a_12791_913# VSS.t101 sg13_lv_nmos ad=0.2516p pd=2.16u as=0.2516p ps=2.16u w=0.74u l=0.13u
X51 a_3747_216.t1 a_3449_236# VDD VDD sg13_lv_pmos ad=0.2128p pd=1.5u as=0.1918p ps=1.5u w=1.12u l=0.13u
X52 a_12715_949# a_12505_949# VDD VDD sg13_lv_pmos ad=0.2128p pd=1.5u as=0.252p ps=1.57u w=1.12u l=0.13u
X53 a_11848_949# DELAY_OUT_TAP10 VSS.t199 VSS.t198 sg13_lv_nmos ad=0.1406p pd=1.12u as=0.2516p ps=2.16u w=0.74u l=0.13u
X54 a_17275_949# a_17065_949# VDD VDD sg13_lv_pmos ad=0.2128p pd=1.5u as=0.252p ps=1.57u w=1.12u l=0.13u
X55 VDD VSS.t389 VDD VDD sg13_lv_pmos ad=0.19p pd=1.38u as=0 ps=0 w=1u l=1u
X56 VDD VSS.t388 VDD VDD sg13_lv_pmos ad=0.34p pd=2.68u as=0 ps=0 w=1u l=1u
X57 a_10430_949# a_12791_913# a_12715_949# VDD sg13_lv_pmos ad=0.3808p pd=2.92u as=0.2128p ps=1.5u w=1.12u l=0.13u
X58 VSS.t115 DELAY_OUT_TAP21 a_20105_949# VSS.t228 sg13_lv_nmos ad=0.1665p pd=1.19u as=0.2516p ps=2.16u w=0.74u l=0.13u
X59 a_16510_949# a_17351_913# a_17275_949# VDD sg13_lv_pmos ad=0.3808p pd=2.92u as=0.2128p ps=1.5u w=1.12u l=0.13u
X60 VSS.t203 a_1721_1300# a_2019_952.t0 VSS.t202 sg13_lv_nmos ad=0.2812p pd=2.24u as=0.1406p ps=1.12u w=0.74u l=0.13u
X61 a_5731_194# a_14825_424# a_13470_949# VDD sg13_lv_pmos ad=0.3808p pd=2.92u as=0.3808p ps=2.92u w=1.12u l=0.13u
X62 a_16510_949# a_2595_952.t5 a_17275_949# VSS.t49 sg13_lv_nmos ad=0.2516p pd=2.16u as=0.1406p ps=1.12u w=0.74u l=0.13u
X63 a_8155_949# a_7945_949# VDD VDD sg13_lv_pmos ad=0.2128p pd=1.5u as=0.252p ps=1.57u w=1.12u l=0.13u
X64 VDD VSS.t362 VDD VDD sg13_lv_pmos ad=0.34p pd=2.68u as=0 ps=0 w=1u l=1u
X65 VSS.t5 a_3747_952.t2 a_27991_913# VSS.t4 sg13_lv_nmos ad=0.2516p pd=2.16u as=0.2516p ps=2.16u w=0.74u l=0.13u
X66 VSS.t31 a_3747_952.t9 a_6711_913# VSS.t30 sg13_lv_nmos ad=0.2516p pd=2.16u as=0.2516p ps=2.16u w=0.74u l=0.13u
X67 a_16108_194# a_2595_216.t2 a_19550_949# VSS.t95 sg13_lv_nmos ad=0.2516p pd=2.16u as=0.2516p ps=2.16u w=0.74u l=0.13u
X68 VSS.t333 VDD VSS.t332 VSS.t331 sg13_lv_nmos ad=0.1428p pd=1.52u as=0 ps=0 w=0.42u l=1u
X69 a_7390_949# a_8231_913# a_8155_949# VDD sg13_lv_pmos ad=0.3808p pd=2.92u as=0.2128p ps=1.5u w=1.12u l=0.13u
X70 VSS.t298 VDD VSS.t297 VSS.t296 sg13_lv_nmos ad=0.1428p pd=1.52u as=0 ps=0 w=0.42u l=1u
X71 a_3171_216.t0 a_2873_236# VSS.t23 VSS.t22 sg13_lv_nmos ad=0.1406p pd=1.12u as=0.1331p ps=1.12u w=0.74u l=0.13u
X72 a_5731_194# a_5705_424# a_4350_949# VDD sg13_lv_pmos ad=0.3808p pd=2.92u as=0.3808p ps=2.92u w=1.12u l=0.13u
X73 VDD a_2873_236# a_3171_216.t1 VDD sg13_lv_pmos ad=0.4256p pd=3u as=0.2128p ps=1.5u w=1.12u l=0.13u
X74 a_3747_216.t0 a_3449_236# VSS.t42 VSS.t246 sg13_lv_nmos ad=0.1406p pd=1.12u as=0.1331p ps=1.12u w=0.74u l=0.13u
X75 VDD a_3449_236# a_3747_216.t1 VDD sg13_lv_pmos ad=0.4256p pd=3u as=0.2128p ps=1.5u w=1.12u l=0.13u
X76 a_7390_949# a_2019_952.t8 a_7288_949# VSS.t126 sg13_lv_nmos ad=0.2516p pd=2.16u as=0.1406p ps=1.12u w=0.74u l=0.13u
X77 VDD DELAY_OUT_TAP21 a_20105_949# VDD sg13_lv_pmos ad=0.252p pd=1.57u as=0.3808p ps=2.92u w=1.12u l=0.13u
X78 a_19550_949# a_21044_913# a_20968_949# VDD sg13_lv_pmos ad=0.3808p pd=2.92u as=0.2128p ps=1.5u w=1.12u l=0.13u
X79 VDD VSS.t365 VDD VDD sg13_lv_pmos ad=0.19p pd=1.38u as=0 ps=0 w=1u l=1u
X80 VDD VSS.t379 VDD VDD sg13_lv_pmos ad=0.19p pd=1.38u as=0 ps=0 w=1u l=1u
X81 VDD a_3171_952.t7 a_11924_913# VDD sg13_lv_pmos ad=0.3808p pd=2.92u as=0.3808p ps=2.92u w=1.12u l=0.13u
X82 VSS.t54 a_2019_952.t4 a_19524_913# VSS.t53 sg13_lv_nmos ad=0.2516p pd=2.16u as=0.2516p ps=2.16u w=0.74u l=0.13u
X83 a_15755_949# a_15545_949# VSS.t125 VSS.t124 sg13_lv_nmos ad=0.1406p pd=1.12u as=0.1665p ps=1.19u w=0.74u l=0.13u
X84 VSS.t11 a_2595_952.t6 a_14311_913# VSS.t10 sg13_lv_nmos ad=0.2516p pd=2.16u as=0.2516p ps=2.16u w=0.74u l=0.13u
X85 a_5115_949# a_4905_949# VSS.t148 VSS.t147 sg13_lv_nmos ad=0.1406p pd=1.12u as=0.1665p ps=1.19u w=0.74u l=0.13u
X86 a_27915_949# a_27705_949# VDD VDD sg13_lv_pmos ad=0.2128p pd=1.5u as=0.252p ps=1.57u w=1.12u l=0.13u
X87 VSS.t290 VDD VSS.t288 VSS.t289 sg13_lv_nmos ad=79.8f pd=0.8u as=0 ps=0 w=0.42u l=1u
X88 a_23355_949# a_23145_949# VDD VDD sg13_lv_pmos ad=0.2128p pd=1.5u as=0.252p ps=1.57u w=1.12u l=0.13u
X89 VDD a_2019_952.t8 a_7364_913# VDD sg13_lv_pmos ad=0.3808p pd=2.92u as=0.3808p ps=2.92u w=1.12u l=0.13u
X90 VSS.t25 a_2873_236# a_3171_216.t0 VSS.t24 sg13_lv_nmos ad=0.2812p pd=2.24u as=0.1406p ps=1.12u w=0.74u l=0.13u
X91 VDD VSS.t390 VDD VDD sg13_lv_pmos ad=0.34p pd=2.68u as=0 ps=0 w=1u l=1u
X92 a_25630_949# a_27991_913# a_27915_949# VDD sg13_lv_pmos ad=0.3808p pd=2.92u as=0.2128p ps=1.5u w=1.12u l=0.13u
X93 VSS.t248 a_3449_236# a_3747_216.t0 VSS.t247 sg13_lv_nmos ad=0.2812p pd=2.24u as=0.1406p ps=1.12u w=0.74u l=0.13u
X94 VSS.t92 DELAY_OUT_TAP23 a_21625_949# VSS.t91 sg13_lv_nmos ad=0.1665p pd=1.19u as=0.2516p ps=2.16u w=0.74u l=0.13u
X95 a_22590_949# a_23431_913# a_23355_949# VDD sg13_lv_pmos ad=0.3808p pd=2.92u as=0.2128p ps=1.5u w=1.12u l=0.13u
X96 a_16108_194# a_20905_424# a_19550_949# VDD sg13_lv_pmos ad=0.3808p pd=2.92u as=0.3808p ps=2.92u w=1.12u l=0.13u
X97 VDD a_2595_952.t6 a_14311_913# VDD sg13_lv_pmos ad=0.3808p pd=2.92u as=0.3808p ps=2.92u w=1.12u l=0.13u
X98 VSS.t257 a_2019_952.t9 a_4324_913# VSS.t256 sg13_lv_nmos ad=0.2516p pd=2.16u as=0.2516p ps=2.16u w=0.74u l=0.13u
X99 a_16510_949# a_3747_952.t5 a_18795_949# VSS.t108 sg13_lv_nmos ad=0.2516p pd=2.16u as=0.1406p ps=1.12u w=0.74u l=0.13u
X100 VDD a_3747_952.t5 a_18871_913# VDD sg13_lv_pmos ad=0.3808p pd=2.92u as=0.3808p ps=2.92u w=1.12u l=0.13u
X101 VSS.t57 a_3171_216.t3 a_11785_424# VSS.t56 sg13_lv_nmos ad=0.2516p pd=2.16u as=0.2516p ps=2.16u w=0.74u l=0.13u
X102 VDD a_3747_952.t8 a_9751_913# VDD sg13_lv_pmos ad=0.3808p pd=2.92u as=0.3808p ps=2.92u w=1.12u l=0.13u
X103 VDD a_2595_952.t9 a_5191_913# VDD sg13_lv_pmos ad=0.3808p pd=2.92u as=0.3808p ps=2.92u w=1.12u l=0.13u
X104 a_10430_949# a_2019_952.t7 a_10328_949# VSS.t129 sg13_lv_nmos ad=0.2516p pd=2.16u as=0.1406p ps=1.12u w=0.74u l=0.13u
X105 a_4157_1218# DELAY_OUT_TAP0 VSS.t94 VSS.t93 sg13_lv_nmos ad=0.2516p pd=2.16u as=0.2553p ps=2.17u w=0.74u l=0.13u
X106 a_7390_949# a_3171_952.t8 a_8808_949# VSS.t82 sg13_lv_nmos ad=0.2516p pd=2.16u as=0.1406p ps=1.12u w=0.74u l=0.13u
X107 VSS.t125 DELAY_OUT_TAP15 a_15545_949# VSS.t227 sg13_lv_nmos ad=0.1665p pd=1.19u as=0.2516p ps=2.16u w=0.74u l=0.13u
X108 VDD a_2019_952.t3 a_22564_913# VDD sg13_lv_pmos ad=0.3808p pd=2.92u as=0.3808p ps=2.92u w=1.12u l=0.13u
X109 a_14888_949# DELAY_OUT_TAP14 VDD VDD sg13_lv_pmos ad=0.2128p pd=1.5u as=0.3808p ps=2.92u w=1.12u l=0.13u
X110 VSS.t8 a_3171_952.t7 a_11924_913# VSS.t7 sg13_lv_nmos ad=0.2516p pd=2.16u as=0.2516p ps=2.16u w=0.74u l=0.13u
X111 VDD VSS.t366 VDD VDD sg13_lv_pmos ad=0.34p pd=2.68u as=0 ps=0 w=1u l=1u
X112 VDD a_3171_952.t2 a_27124_913# VDD sg13_lv_pmos ad=0.3808p pd=2.92u as=0.3808p ps=2.92u w=1.12u l=0.13u
X113 a_10328_949# DELAY_OUT_TAP8 VDD VDD sg13_lv_pmos ad=0.2128p pd=1.5u as=0.3808p ps=2.92u w=1.12u l=0.13u
X114 a_19448_949# DELAY_OUT_TAP20 VDD VDD sg13_lv_pmos ad=0.2128p pd=1.5u as=0.3808p ps=2.92u w=1.12u l=0.13u
X115 VDD VSS.t380 VDD VDD sg13_lv_pmos ad=0.34p pd=2.68u as=0 ps=0 w=1u l=1u
X116 a_3171_952.t0 a_2873_1300# VSS.t209 VSS.t208 sg13_lv_nmos ad=0.1406p pd=1.12u as=0.1331p ps=1.12u w=0.74u l=0.13u
X117 a_25630_949# a_2019_952.t2 a_25528_949# VSS.t85 sg13_lv_nmos ad=0.2516p pd=2.16u as=0.1406p ps=1.12u w=0.74u l=0.13u
X118 VSS.t225 a_2297_1300# a_2595_952.t0 VSS.t224 sg13_lv_nmos ad=0.2812p pd=2.24u as=0.1406p ps=1.12u w=0.74u l=0.13u
X119 a_16108_194# a_2019_216# a_16510_949# VSS.t46 sg13_lv_nmos ad=0.2516p pd=2.16u as=0.2516p ps=2.16u w=0.74u l=0.13u
X120 a_2391_1300# MUX_SEL0 a_2297_1300# VSS.t196 sg13_lv_nmos ad=0.1216p pd=1.02u as=0.2176p ps=1.96u w=0.64u l=0.13u
X121 VSS.t350 VDD VSS.t348 VSS.t349 sg13_lv_nmos ad=79.8f pd=0.8u as=0 ps=0 w=0.42u l=1u
X122 VSS.t201 a_1544_949# a_1815_1300# VSS.t204 sg13_lv_nmos ad=0.1331p pd=1.12u as=0.1216p ps=1.02u w=0.64u l=0.13u
X123 a_5768_949# DELAY_OUT_TAP2 VDD VDD sg13_lv_pmos ad=0.2128p pd=1.5u as=0.3808p ps=2.92u w=1.12u l=0.13u
X124 VSS.t353 VDD VSS.t352 VSS.t351 sg13_lv_nmos ad=0.1428p pd=1.52u as=0 ps=0 w=0.42u l=1u
X125 a_16510_949# a_2019_952.t5 a_16408_949# VSS.t35 sg13_lv_nmos ad=0.2516p pd=2.16u as=0.1406p ps=1.12u w=0.74u l=0.13u
X126 VDD a_2595_952.t4 a_20391_913# VDD sg13_lv_pmos ad=0.3808p pd=2.92u as=0.3808p ps=2.92u w=1.12u l=0.13u
X127 VSS.t34 a_3171_952.t2 a_27124_913# VSS.t33 sg13_lv_nmos ad=0.2516p pd=2.16u as=0.2516p ps=2.16u w=0.74u l=0.13u
X128 a_5731_194# a_2595_216.t3 a_7390_949# VSS.t176 sg13_lv_nmos ad=0.2516p pd=2.16u as=0.2516p ps=2.16u w=0.74u l=0.13u
X129 VDD a_3171_216.t3 a_11785_424# VDD sg13_lv_pmos ad=0.3808p pd=2.92u as=0.3808p ps=2.92u w=1.12u l=0.13u
X130 a_10430_949# a_2595_952.t7 a_11195_949# VSS.t73 sg13_lv_nmos ad=0.2516p pd=2.16u as=0.1406p ps=1.12u w=0.74u l=0.13u
X131 a_23355_949# a_23145_949# VSS.t90 VSS.t167 sg13_lv_nmos ad=0.1406p pd=1.12u as=0.1665p ps=1.19u w=0.74u l=0.13u
X132 VSS.t270 VDD VSS.t267 VSS.t269 sg13_lv_nmos ad=79.8f pd=0.8u as=0 ps=0 w=0.42u l=1u
X133 VSS.t2 a_3747_952.t4 a_21911_913# VSS.t1 sg13_lv_nmos ad=0.2516p pd=2.16u as=0.2516p ps=2.16u w=0.74u l=0.13u
X134 VSS.t113 a_3747_216.t2 a_26985_424# VSS.t112 sg13_lv_nmos ad=0.2516p pd=2.16u as=0.2516p ps=2.16u w=0.74u l=0.13u
X135 a_20968_949# DELAY_OUT_TAP22 VSS.t21 VSS.t20 sg13_lv_nmos ad=0.1406p pd=1.12u as=0.2516p ps=2.16u w=0.74u l=0.13u
X136 VDD VSS.t383 VDD VDD sg13_lv_pmos ad=0.19p pd=1.38u as=0 ps=0 w=1u l=1u
X137 a_13470_949# a_14964_913# a_14888_949# VDD sg13_lv_pmos ad=0.3808p pd=2.92u as=0.2128p ps=1.5u w=1.12u l=0.13u
X138 VDD DELAY_OUT_TAP19 a_18585_949# VDD sg13_lv_pmos ad=0.252p pd=1.57u as=0.3808p ps=2.92u w=1.12u l=0.13u
X139 a_10430_949# a_10404_913# a_10328_949# VDD sg13_lv_pmos ad=0.3808p pd=2.92u as=0.2128p ps=1.5u w=1.12u l=0.13u
X140 a_19550_949# a_19524_913# a_19448_949# VDD sg13_lv_pmos ad=0.3808p pd=2.92u as=0.2128p ps=1.5u w=1.12u l=0.13u
X141 a_2595_216.t1 a_2297_236# VDD VDD sg13_lv_pmos ad=0.2128p pd=1.5u as=0.1918p ps=1.5u w=1.12u l=0.13u
X142 a_19448_949# DELAY_OUT_TAP20 VSS.t263 VSS.t262 sg13_lv_nmos ad=0.1406p pd=1.12u as=0.2516p ps=2.16u w=0.74u l=0.13u
X143 a_10430_949# a_3171_952.t7 a_11848_949# VSS.t6 sg13_lv_nmos ad=0.2516p pd=2.16u as=0.1406p ps=1.12u w=0.74u l=0.13u
X144 a_11195_949# a_10985_949# VDD VDD sg13_lv_pmos ad=0.2128p pd=1.5u as=0.252p ps=1.57u w=1.12u l=0.13u
X145 a_25630_949# a_2595_952.t2 a_26395_949# VSS.t141 sg13_lv_nmos ad=0.2516p pd=2.16u as=0.1406p ps=1.12u w=0.74u l=0.13u
X146 VDD a_1721_236# a_2019_216# VDD sg13_lv_pmos ad=0.4256p pd=3u as=0.2128p ps=1.5u w=1.12u l=0.13u
X147 VDD DELAY_OUT_TAP1 a_4905_949# VDD sg13_lv_pmos ad=0.252p pd=1.57u as=0.3808p ps=2.92u w=1.12u l=0.13u
X148 VSS.t310 VDD VSS.t308 VSS.t309 sg13_lv_nmos ad=79.8f pd=0.8u as=0 ps=0 w=0.42u l=1u
X149 VDD a_2297_236# a_2595_216.t1 VDD sg13_lv_pmos ad=0.4256p pd=3u as=0.2128p ps=1.5u w=1.12u l=0.13u
X150 a_4350_949# a_5844_913# a_5768_949# VDD sg13_lv_pmos ad=0.3808p pd=2.92u as=0.2128p ps=1.5u w=1.12u l=0.13u
X151 a_3449_1300# MUX_SEL0 VDD VDD sg13_lv_pmos ad=0.1596p pd=1.22u as=0.2856p ps=2.36u w=0.84u l=0.13u
X152 VDD DELAY_OUT_TAP7 a_9465_949# VDD sg13_lv_pmos ad=0.252p pd=1.57u as=0.3808p ps=2.92u w=1.12u l=0.13u
X153 VSS.t158 DELAY_OUT_TAP3 a_6425_949# VSS.t181 sg13_lv_nmos ad=0.1665p pd=1.19u as=0.2516p ps=2.16u w=0.74u l=0.13u
X154 a_10430_949# a_11271_913# a_11195_949# VDD sg13_lv_pmos ad=0.3808p pd=2.92u as=0.2128p ps=1.5u w=1.12u l=0.13u
X155 a_20968_949# DELAY_OUT_TAP22 VDD VDD sg13_lv_pmos ad=0.2128p pd=1.5u as=0.3808p ps=2.92u w=1.12u l=0.13u
X156 VSS.t78 a_2019_952.t6 a_13444_913# VSS.t77 sg13_lv_nmos ad=0.2516p pd=2.16u as=0.2516p ps=2.16u w=0.74u l=0.13u
X157 a_16108_194# a_17865_424# a_16510_949# VDD sg13_lv_pmos ad=0.3808p pd=2.92u as=0.3808p ps=2.92u w=1.12u l=0.13u
X158 VSS.t172 a_15964_194# a_16851_214# VSS.t175 sg13_lv_nmos ad=0.1371p pd=1.12u as=0.2176p ps=1.96u w=0.64u l=0.13u
X159 a_25528_949# DELAY_OUT_TAP28 VDD VDD sg13_lv_pmos ad=0.2128p pd=1.5u as=0.3808p ps=2.92u w=1.12u l=0.13u
X160 VDD a_1256_949# a_2873_1300# VDD sg13_lv_pmos ad=0.1918p pd=1.5u as=0.1596p ps=1.22u w=0.84u l=0.13u
X161 a_4248_949# a_4157_1218# VSS.t160 VSS.t159 sg13_lv_nmos ad=0.1406p pd=1.12u as=0.2516p ps=2.16u w=0.74u l=0.13u
X162 a_16108_194# a_3171_216.t2 a_22590_949# VSS.t135 sg13_lv_nmos ad=0.2516p pd=2.16u as=0.2516p ps=2.16u w=0.74u l=0.13u
X163 VSS.t330 VDD VSS.t328 VSS.t329 sg13_lv_nmos ad=79.8f pd=0.8u as=0 ps=0 w=0.42u l=1u
X164 a_19550_949# a_3747_952.t4 a_21835_949# VSS.t0 sg13_lv_nmos ad=0.2516p pd=2.16u as=0.1406p ps=1.12u w=0.74u l=0.13u
X165 VSS.t90 DELAY_OUT_TAP25 a_23145_949# VSS.t89 sg13_lv_nmos ad=0.1665p pd=1.19u as=0.2516p ps=2.16u w=0.74u l=0.13u
X166 a_5731_194# a_8745_424# a_7390_949# VDD sg13_lv_pmos ad=0.3808p pd=2.92u as=0.3808p ps=2.92u w=1.12u l=0.13u
X167 a_2595_216.t0 a_2297_236# VSS.t117 VSS.t116 sg13_lv_nmos ad=0.1406p pd=1.12u as=0.1331p ps=1.12u w=0.74u l=0.13u
X168 VDD a_3747_216.t2 a_26985_424# VDD sg13_lv_pmos ad=0.3808p pd=2.92u as=0.3808p ps=2.92u w=1.12u l=0.13u
X169 a_10430_949# a_3747_952.t7 a_12715_949# VSS.t100 sg13_lv_nmos ad=0.2516p pd=2.16u as=0.1406p ps=1.12u w=0.74u l=0.13u
X170 VSS.t19 a_1721_236# a_2019_216# VSS.t18 sg13_lv_nmos ad=0.2812p pd=2.24u as=0.1406p ps=1.12u w=0.74u l=0.13u
X171 a_24875_949# a_24665_949# VSS.t230 VSS.t356 sg13_lv_nmos ad=0.1406p pd=1.12u as=0.1665p ps=1.19u w=0.74u l=0.13u
X172 VSS.t119 a_2297_236# a_2595_216.t0 VSS.t118 sg13_lv_nmos ad=0.2812p pd=2.24u as=0.1406p ps=1.12u w=0.74u l=0.13u
X173 VSS.t251 a_2595_952.t3 a_23431_913# VSS.t250 sg13_lv_nmos ad=0.2516p pd=2.16u as=0.2516p ps=2.16u w=0.74u l=0.13u
X174 VDD MUX_SEL1 a_3449_1300# VDD sg13_lv_pmos ad=0.1918p pd=1.5u as=0.1596p ps=1.22u w=0.84u l=0.13u
X175 VSS.t268 VDD VSS.t267 VSS.t266 sg13_lv_nmos ad=0.1428p pd=1.52u as=0 ps=0 w=0.42u l=1u
X176 VSS.t166 DELAY_OUT_TAP13 a_14025_949# VSS.t226 sg13_lv_nmos ad=0.1665p pd=1.19u as=0.2516p ps=2.16u w=0.74u l=0.13u
X177 a_22590_949# a_24084_913# a_24008_949# VDD sg13_lv_pmos ad=0.3808p pd=2.92u as=0.2128p ps=1.5u w=1.12u l=0.13u
X178 VDD VSS.t359 VDD VDD sg13_lv_pmos ad=0.19p pd=1.38u as=0 ps=0 w=1u l=1u
X179 VDD DELAY_OUT_TAP27 a_24665_949# VDD sg13_lv_pmos ad=0.252p pd=1.57u as=0.3808p ps=2.92u w=1.12u l=0.13u
X180 VDD a_3171_952.t6 a_14964_913# VDD sg13_lv_pmos ad=0.3808p pd=2.92u as=0.3808p ps=2.92u w=1.12u l=0.13u
X181 a_25630_949# a_25604_913# a_25528_949# VDD sg13_lv_pmos ad=0.3808p pd=2.92u as=0.2128p ps=1.5u w=1.12u l=0.13u
X182 a_3171_952.t1 a_2873_1300# VDD VDD sg13_lv_pmos ad=0.2128p pd=1.5u as=0.1918p ps=1.5u w=1.12u l=0.13u
X183 a_3747_952.t1 a_3449_1300# VDD VDD sg13_lv_pmos ad=0.2128p pd=1.5u as=0.1918p ps=1.5u w=1.12u l=0.13u
X184 VDD VSS.t358 VDD VDD sg13_lv_pmos ad=0.34p pd=2.68u as=0 ps=0 w=1u l=1u
X185 VDD a_2019_952.t5 a_16484_913# VDD sg13_lv_pmos ad=0.3808p pd=2.92u as=0.3808p ps=2.92u w=1.12u l=0.13u
X186 a_22590_949# a_3171_952.t3 a_24008_949# VSS.t252 sg13_lv_nmos ad=0.2516p pd=2.16u as=0.1406p ps=1.12u w=0.74u l=0.13u
X187 VDD a_15964_194# a_16851_214# VDD sg13_lv_pmos ad=0.2086p pd=1.5u as=0.34p ps=2.68u w=1u l=0.13u
X188 a_26395_949# a_26185_949# VDD VDD sg13_lv_pmos ad=0.2128p pd=1.5u as=0.252p ps=1.57u w=1.12u l=0.13u
X189 a_3747_952.t0 a_3449_1300# VSS.t150 VSS.t149 sg13_lv_nmos ad=0.1406p pd=1.12u as=0.1331p ps=1.12u w=0.74u l=0.13u
X190 a_25630_949# a_3747_952.t2 a_27915_949# VSS.t3 sg13_lv_nmos ad=0.2516p pd=2.16u as=0.1406p ps=1.12u w=0.74u l=0.13u
X191 VSS.t325 VDD VSS.t323 VSS.t324 sg13_lv_nmos ad=79.8f pd=0.8u as=0 ps=0 w=0.42u l=1u
X192 VDD VSS.t391 VDD VDD sg13_lv_pmos ad=0.19p pd=1.38u as=0 ps=0 w=1u l=1u
X193 a_2967_1300# MUX_SEL1 a_2873_1300# VSS.t184 sg13_lv_nmos ad=0.1216p pd=1.02u as=0.2176p ps=1.96u w=0.64u l=0.13u
X194 VDD a_3171_952.t9 a_5844_913# VDD sg13_lv_pmos ad=0.3808p pd=2.92u as=0.3808p ps=2.92u w=1.12u l=0.13u
X195 VSS.t320 VDD VSS.t318 VSS.t319 sg13_lv_nmos ad=79.8f pd=0.8u as=0 ps=0 w=0.42u l=1u
X196 VSS.t293 VDD VSS.t292 VSS.t291 sg13_lv_nmos ad=0.1428p pd=1.52u as=0 ps=0 w=0.42u l=1u
X197 a_25630_949# a_26471_913# a_26395_949# VDD sg13_lv_pmos ad=0.3808p pd=2.92u as=0.2128p ps=1.5u w=1.12u l=0.13u
X198 a_3543_236# MUX_SEL2 a_3449_236# VSS.t239 sg13_lv_nmos ad=0.1216p pd=1.02u as=0.2176p ps=1.96u w=0.64u l=0.13u
X199 a_16108_194# a_23945_424# a_22590_949# VDD sg13_lv_pmos ad=0.3808p pd=2.92u as=0.3808p ps=2.92u w=1.12u l=0.13u
X200 VDD a_2595_952.t5 a_17351_913# VDD sg13_lv_pmos ad=0.3808p pd=2.92u as=0.3808p ps=2.92u w=1.12u l=0.13u
X201 VDD a_3747_952.t7 a_12791_913# VDD sg13_lv_pmos ad=0.3808p pd=2.92u as=0.3808p ps=2.92u w=1.12u l=0.13u
X202 a_8155_949# a_7945_949# VSS.t233 VSS.t232 sg13_lv_nmos ad=0.1406p pd=1.12u as=0.1665p ps=1.19u w=0.74u l=0.13u
X203 a_27048_949# DELAY_OUT_TAP30 VSS.t180 VSS.t179 sg13_lv_nmos ad=0.1406p pd=1.12u as=0.2516p ps=2.16u w=0.74u l=0.13u
X204 a_5768_949# DELAY_OUT_TAP2 VSS.t190 VSS.t189 sg13_lv_nmos ad=0.1406p pd=1.12u as=0.2516p ps=2.16u w=0.74u l=0.13u
X205 VSS.t170 a_3747_216.t3 a_14825_424# VSS.t169 sg13_lv_nmos ad=0.2516p pd=2.16u as=0.2516p ps=2.16u w=0.74u l=0.13u
X206 VSS.t23 a_1256_194# a_2967_236# VSS.t123 sg13_lv_nmos ad=0.1331p pd=1.12u as=0.1216p ps=1.02u w=0.64u l=0.13u
X207 VSS.t328 VDD VSS.t327 VSS.t326 sg13_lv_nmos ad=0.1428p pd=1.52u as=0 ps=0 w=0.42u l=1u
X208 VDD VSS.t375 VDD VDD sg13_lv_pmos ad=0.19p pd=1.38u as=0 ps=0 w=1u l=1u
X209 VDD a_2873_1300# a_3171_952.t1 VDD sg13_lv_pmos ad=0.4256p pd=3u as=0.2128p ps=1.5u w=1.12u l=0.13u
X210 VSS.t230 DELAY_OUT_TAP27 a_24665_949# VSS.t229 sg13_lv_nmos ad=0.1665p pd=1.19u as=0.2516p ps=2.16u w=0.74u l=0.13u
X211 VDD a_2595_952.t8 a_8231_913# VDD sg13_lv_pmos ad=0.3808p pd=2.92u as=0.3808p ps=2.92u w=1.12u l=0.13u
X212 a_16510_949# a_3171_952.t5 a_17928_949# VSS.t67 sg13_lv_nmos ad=0.2516p pd=2.16u as=0.1406p ps=1.12u w=0.74u l=0.13u
X213 VDD a_3449_1300# a_3747_952.t1 VDD sg13_lv_pmos ad=0.4256p pd=3u as=0.2128p ps=1.5u w=1.12u l=0.13u
X214 VSS.t146 a_3171_952.t4 a_21044_913# VSS.t145 sg13_lv_nmos ad=0.2516p pd=2.16u as=0.2516p ps=2.16u w=0.74u l=0.13u
X215 VDD VSS.t367 VDD VDD sg13_lv_pmos ad=0.19p pd=1.38u as=0 ps=0 w=1u l=1u
X216 VSS.t42 MUX_SEL3 a_3543_236# VSS.t41 sg13_lv_nmos ad=0.1331p pd=1.12u as=0.1216p ps=1.02u w=0.64u l=0.13u
X217 VDD a_3171_952.t4 a_21044_913# VDD sg13_lv_pmos ad=0.3808p pd=2.92u as=0.3808p ps=2.92u w=1.12u l=0.13u
X218 a_13368_949# DELAY_OUT_TAP12 VDD VDD sg13_lv_pmos ad=0.2128p pd=1.5u as=0.3808p ps=2.92u w=1.12u l=0.13u
X219 VSS.t211 a_2873_1300# a_3171_952.t0 VSS.t210 sg13_lv_nmos ad=0.2812p pd=2.24u as=0.1406p ps=1.12u w=0.74u l=0.13u
X220 a_13368_949# DELAY_OUT_TAP12 VSS.t193 VSS.t192 sg13_lv_nmos ad=0.1406p pd=1.12u as=0.2516p ps=2.16u w=0.74u l=0.13u
X221 a_5731_194# a_3171_216.t3 a_10430_949# VSS.t55 sg13_lv_nmos ad=0.2516p pd=2.16u as=0.2516p ps=2.16u w=0.74u l=0.13u
X222 VSS.t206 a_1544_949# a_2391_1300# VSS.t205 sg13_lv_nmos ad=0.1331p pd=1.12u as=0.1216p ps=1.02u w=0.64u l=0.13u
X223 a_2019_952.t0 a_1721_1300# VSS.t201 VSS.t200 sg13_lv_nmos ad=0.1406p pd=1.12u as=0.1331p ps=1.12u w=0.74u l=0.13u
X224 a_4350_949# a_3747_952.t9 a_6635_949# VSS.t29 sg13_lv_nmos ad=0.2516p pd=2.16u as=0.1406p ps=1.12u w=0.74u l=0.13u
X225 a_19550_949# a_2595_952.t4 a_20315_949# VSS.t58 sg13_lv_nmos ad=0.2516p pd=2.16u as=0.1406p ps=1.12u w=0.74u l=0.13u
X226 a_8808_949# DELAY_OUT_TAP6 VDD VDD sg13_lv_pmos ad=0.2128p pd=1.5u as=0.3808p ps=2.92u w=1.12u l=0.13u
X227 VSS.t233 DELAY_OUT_TAP5 a_7945_949# VSS.t261 sg13_lv_nmos ad=0.1665p pd=1.19u as=0.2516p ps=2.16u w=0.74u l=0.13u
X228 a_2019_216# a_1721_236# VDD VDD sg13_lv_pmos ad=0.2128p pd=1.5u as=0.1918p ps=1.5u w=1.12u l=0.13u
X229 VSS.t323 VDD VSS.t322 VSS.t321 sg13_lv_nmos ad=0.1428p pd=1.52u as=0 ps=0 w=0.42u l=1u
X230 a_4248_949# a_4157_1218# VDD VDD sg13_lv_pmos ad=0.2128p pd=1.5u as=0.3808p ps=2.92u w=1.12u l=0.13u
X231 VDD VSS.t392 VDD VDD sg13_lv_pmos ad=0.34p pd=2.68u as=0 ps=0 w=1u l=1u
X232 VSS.t288 VDD VSS.t287 VSS.t286 sg13_lv_nmos ad=0.1428p pd=1.52u as=0 ps=0 w=0.42u l=1u
X233 VSS.t318 VDD VSS.t317 VSS.t316 sg13_lv_nmos ad=0.1428p pd=1.52u as=0 ps=0 w=0.42u l=1u
X234 VDD a_2595_952.t3 a_23431_913# VDD sg13_lv_pmos ad=0.3808p pd=2.92u as=0.3808p ps=2.92u w=1.12u l=0.13u
X235 VDD a_3747_216.t3 a_14825_424# VDD sg13_lv_pmos ad=0.3808p pd=2.92u as=0.3808p ps=2.92u w=1.12u l=0.13u
X236 VDD a_3747_952.t2 a_27991_913# VDD sg13_lv_pmos ad=0.3808p pd=2.92u as=0.3808p ps=2.92u w=1.12u l=0.13u
X237 a_2297_1300# MUX_SEL0 VDD VDD sg13_lv_pmos ad=0.1596p pd=1.22u as=0.2856p ps=2.36u w=0.84u l=0.13u
X238 a_9675_949# a_9465_949# VSS.t218 VSS.t231 sg13_lv_nmos ad=0.1406p pd=1.12u as=0.1665p ps=1.19u w=0.74u l=0.13u
X239 VSS.t285 VDD VSS.t283 VSS.t284 sg13_lv_nmos ad=79.8f pd=0.8u as=0 ps=0 w=0.42u l=1u
X240 a_2873_1300# MUX_SEL1 VDD VDD sg13_lv_pmos ad=0.1596p pd=1.22u as=0.2856p ps=2.36u w=0.84u l=0.13u
X241 VSS.t242 a_2595_952.t8 a_8231_913# VSS.t241 sg13_lv_nmos ad=0.2516p pd=2.16u as=0.2516p ps=2.16u w=0.74u l=0.13u
X242 VSS.t97 a_2595_216.t2 a_20905_424# VSS.t96 sg13_lv_nmos ad=0.2516p pd=2.16u as=0.2516p ps=2.16u w=0.74u l=0.13u
X243 a_3449_236# MUX_SEL2 VDD VDD sg13_lv_pmos ad=0.1596p pd=1.22u as=0.2856p ps=2.36u w=0.84u l=0.13u
X244 VDD DELAY_OUT_TAP11 a_12505_949# VDD sg13_lv_pmos ad=0.252p pd=1.57u as=0.3808p ps=2.92u w=1.12u l=0.13u
X245 VDD VSS.t369 VDD VDD sg13_lv_pmos ad=0.19p pd=1.38u as=0 ps=0 w=1u l=1u
X246 a_13470_949# a_13444_913# a_13368_949# VDD sg13_lv_pmos ad=0.3808p pd=2.92u as=0.2128p ps=1.5u w=1.12u l=0.13u
X247 VDD DELAY_OUT_TAP17 a_17065_949# VDD sg13_lv_pmos ad=0.252p pd=1.57u as=0.3808p ps=2.92u w=1.12u l=0.13u
X248 a_16510_949# a_18004_913# a_17928_949# VDD sg13_lv_pmos ad=0.3808p pd=2.92u as=0.2128p ps=1.5u w=1.12u l=0.13u
X249 a_19550_949# a_2019_952.t4 a_19448_949# VSS.t52 sg13_lv_nmos ad=0.2516p pd=2.16u as=0.1406p ps=1.12u w=0.74u l=0.13u
X250 VDD VSS.t371 VDD VDD sg13_lv_pmos ad=0.19p pd=1.38u as=0 ps=0 w=1u l=1u
X251 VDD VSS.t382 VDD VDD sg13_lv_pmos ad=0.34p pd=2.68u as=0 ps=0 w=1u l=1u
X252 VDD a_1256_194# a_2873_236# VDD sg13_lv_pmos ad=0.1918p pd=1.5u as=0.1596p ps=1.22u w=0.84u l=0.13u
X253 a_13470_949# a_2595_952.t6 a_14235_949# VSS.t9 sg13_lv_nmos ad=0.2516p pd=2.16u as=0.1406p ps=1.12u w=0.74u l=0.13u
X254 VSS.t134 a_2019_952.t3 a_22564_913# VSS.t133 sg13_lv_nmos ad=0.2516p pd=2.16u as=0.2516p ps=2.16u w=0.74u l=0.13u
X255 a_15755_949# a_15545_949# VDD VDD sg13_lv_pmos ad=0.2128p pd=1.5u as=0.252p ps=1.57u w=1.12u l=0.13u
X256 a_7390_949# a_8884_913# a_8808_949# VDD sg13_lv_pmos ad=0.3808p pd=2.92u as=0.2128p ps=1.5u w=1.12u l=0.13u
X257 a_2019_216# a_1721_236# VSS.t17 VSS.t16 sg13_lv_nmos ad=0.1406p pd=1.12u as=0.1331p ps=1.12u w=0.74u l=0.13u
X258 a_4350_949# a_4324_913# a_4248_949# VDD sg13_lv_pmos ad=0.3808p pd=2.92u as=0.2128p ps=1.5u w=1.12u l=0.13u
X259 VDD DELAY_OUT_TAP5 a_7945_949# VDD sg13_lv_pmos ad=0.252p pd=1.57u as=0.3808p ps=2.92u w=1.12u l=0.13u
X260 a_24008_949# DELAY_OUT_TAP26 VDD VDD sg13_lv_pmos ad=0.2128p pd=1.5u as=0.3808p ps=2.92u w=1.12u l=0.13u
X261 a_5731_194# a_11785_424# a_10430_949# VDD sg13_lv_pmos ad=0.3808p pd=2.92u as=0.3808p ps=2.92u w=1.12u l=0.13u
X262 a_5115_949# a_4905_949# VDD VDD sg13_lv_pmos ad=0.2128p pd=1.5u as=0.252p ps=1.57u w=1.12u l=0.13u
X263 VDD VSS.t368 VDD VDD sg13_lv_pmos ad=0.34p pd=2.68u as=0 ps=0 w=1u l=1u
X264 a_13470_949# a_15831_913# a_15755_949# VDD sg13_lv_pmos ad=0.3808p pd=2.92u as=0.2128p ps=1.5u w=1.12u l=0.13u
X265 a_17275_949# a_17065_949# VSS.t155 VSS.t154 sg13_lv_nmos ad=0.1406p pd=1.12u as=0.1665p ps=1.19u w=0.74u l=0.13u
X266 VDD a_1544_949# a_2297_1300# VDD sg13_lv_pmos ad=0.1918p pd=1.5u as=0.1596p ps=1.22u w=0.84u l=0.13u
X267 VSS.t72 a_3747_952.t6 a_15831_913# VSS.t71 sg13_lv_nmos ad=0.2516p pd=2.16u as=0.2516p ps=2.16u w=0.74u l=0.13u
X268 a_4350_949# a_2019_952.t9 a_4248_949# VSS.t255 sg13_lv_nmos ad=0.2516p pd=2.16u as=0.1406p ps=1.12u w=0.74u l=0.13u
X269 VSS.t280 VDD VSS.t278 VSS.t279 sg13_lv_nmos ad=79.8f pd=0.8u as=0 ps=0 w=0.42u l=1u
X270 a_6635_949# a_6425_949# VDD VDD sg13_lv_pmos ad=0.2128p pd=1.5u as=0.252p ps=1.57u w=1.12u l=0.13u
X271 a_14888_949# DELAY_OUT_TAP14 VSS.t265 VSS.t264 sg13_lv_nmos ad=0.1406p pd=1.12u as=0.2516p ps=2.16u w=0.74u l=0.13u
X272 a_16108_194# a_3747_216.t2 a_25630_949# VSS.t111 sg13_lv_nmos ad=0.2516p pd=2.16u as=0.2516p ps=2.16u w=0.74u l=0.13u
X273 VSS.t345 VDD VSS.t343 VSS.t344 sg13_lv_nmos ad=79.8f pd=0.8u as=0 ps=0 w=0.42u l=1u
X274 a_4350_949# a_5191_913# a_5115_949# VDD sg13_lv_pmos ad=0.3808p pd=2.92u as=0.2128p ps=1.5u w=1.12u l=0.13u
X275 VDD MUX_SEL3 a_3449_236# VDD sg13_lv_pmos ad=0.1918p pd=1.5u as=0.1596p ps=1.22u w=0.84u l=0.13u
X276 VSS.t218 DELAY_OUT_TAP7 a_9465_949# VSS.t217 sg13_lv_nmos ad=0.1665p pd=1.19u as=0.2516p ps=2.16u w=0.74u l=0.13u
X277 a_4350_949# a_6711_913# a_6635_949# VDD sg13_lv_pmos ad=0.3808p pd=2.92u as=0.2128p ps=1.5u w=1.12u l=0.13u
X278 VSS.t348 VDD VSS.t347 VSS.t346 sg13_lv_nmos ad=0.1428p pd=1.52u as=0 ps=0 w=0.42u l=1u
X279 VSS.t37 a_2019_952.t5 a_16484_913# VSS.t36 sg13_lv_nmos ad=0.2516p pd=2.16u as=0.2516p ps=2.16u w=0.74u l=0.13u
X280 VSS.t28 a_3171_952.t9 a_5844_913# VSS.t27 sg13_lv_nmos ad=0.2516p pd=2.16u as=0.2516p ps=2.16u w=0.74u l=0.13u
X281 VDD a_2595_216.t2 a_20905_424# VDD sg13_lv_pmos ad=0.3808p pd=2.92u as=0.3808p ps=2.92u w=1.12u l=0.13u
X282 VSS.t75 a_2595_952.t7 a_11271_913# VSS.t74 sg13_lv_nmos ad=0.2516p pd=2.16u as=0.2516p ps=2.16u w=0.74u l=0.13u
X283 VSS.t140 a_3747_952.t8 a_9751_913# VSS.t139 sg13_lv_nmos ad=0.2516p pd=2.16u as=0.2516p ps=2.16u w=0.74u l=0.13u
X284 a_1256_949# MUX_SEL0 VDD VDD sg13_lv_pmos ad=0.3808p pd=2.92u as=0.3808p ps=2.92u w=1.12u l=0.13u
X285 a_2391_236# MUX_SEL2 a_2297_236# VSS.t238 sg13_lv_nmos ad=0.1216p pd=1.02u as=0.2176p ps=1.96u w=0.64u l=0.13u
X286 a_2967_236# MUX_SEL3 a_2873_236# VSS.t40 sg13_lv_nmos ad=0.1216p pd=1.02u as=0.2176p ps=1.96u w=0.64u l=0.13u
X287 VDD DELAY_OUT_TAP31 a_27705_949# VDD sg13_lv_pmos ad=0.252p pd=1.57u as=0.3808p ps=2.92u w=1.12u l=0.13u
X288 VDD DELAY_OUT_TAP25 a_23145_949# VDD sg13_lv_pmos ad=0.252p pd=1.57u as=0.3808p ps=2.92u w=1.12u l=0.13u
X289 a_2595_952.t1 a_2297_1300# VDD VDD sg13_lv_pmos ad=0.2128p pd=1.5u as=0.1918p ps=1.5u w=1.12u l=0.13u
X290 VDD VSS.t370 VDD VDD sg13_lv_pmos ad=0.34p pd=2.68u as=0 ps=0 w=1u l=1u
X291 VDD a_2019_952.t7 a_10404_913# VDD sg13_lv_pmos ad=0.3808p pd=2.92u as=0.3808p ps=2.92u w=1.12u l=0.13u
X292 VDD a_2019_952.t4 a_19524_913# VDD sg13_lv_pmos ad=0.3808p pd=2.92u as=0.3808p ps=2.92u w=1.12u l=0.13u
X293 VDD VSS.t384 VDD VDD sg13_lv_pmos ad=0.34p pd=2.68u as=0 ps=0 w=1u l=1u
X294 a_20315_949# a_20105_949# VDD VDD sg13_lv_pmos ad=0.2128p pd=1.5u as=0.252p ps=1.57u w=1.12u l=0.13u
X295 a_1544_949# MUX_SEL1 VSS.t183 VSS.t182 sg13_lv_nmos ad=0.2516p pd=2.16u as=0.2516p ps=2.16u w=0.74u l=0.13u
X296 VDD VSS.t372 VDD VDD sg13_lv_pmos ad=0.34p pd=2.68u as=0 ps=0 w=1u l=1u
X297 a_13470_949# a_3747_952.t6 a_15755_949# VSS.t70 sg13_lv_nmos ad=0.2516p pd=2.16u as=0.1406p ps=1.12u w=0.74u l=0.13u
X298 VSS.t152 a_3449_1300# a_3747_952.t0 VSS.t151 sg13_lv_nmos ad=0.2812p pd=2.24u as=0.1406p ps=1.12u w=0.74u l=0.13u
X299 a_4350_949# a_2595_952.t9 a_5115_949# VSS.t105 sg13_lv_nmos ad=0.2516p pd=2.16u as=0.1406p ps=1.12u w=0.74u l=0.13u
X300 VDD a_1721_1300# a_2019_952.t1 VDD sg13_lv_pmos ad=0.4256p pd=3u as=0.2128p ps=1.5u w=1.12u l=0.13u
X301 VSS.t143 a_2595_952.t2 a_26471_913# VSS.t142 sg13_lv_nmos ad=0.2516p pd=2.16u as=0.2516p ps=2.16u w=0.74u l=0.13u
X302 VSS.t340 VDD VSS.t338 VSS.t339 sg13_lv_nmos ad=79.8f pd=0.8u as=0 ps=0 w=0.42u l=1u
X303 a_21835_949# a_21625_949# VDD VDD sg13_lv_pmos ad=0.2128p pd=1.5u as=0.252p ps=1.57u w=1.12u l=0.13u
X304 a_3543_1300# MUX_SEL0 a_3449_1300# VSS.t197 sg13_lv_nmos ad=0.1216p pd=1.02u as=0.2176p ps=1.96u w=0.64u l=0.13u
X305 VDD a_2297_1300# a_2595_952.t1 VDD sg13_lv_pmos ad=0.4256p pd=3u as=0.2128p ps=1.5u w=1.12u l=0.13u
X306 VSS.t155 DELAY_OUT_TAP17 a_17065_949# VSS.t258 sg13_lv_nmos ad=0.1665p pd=1.19u as=0.2516p ps=2.16u w=0.74u l=0.13u
X307 VDD VSS.t385 VDD VDD sg13_lv_pmos ad=0.19p pd=1.38u as=0 ps=0 w=1u l=1u
X308 VSS.t305 VDD VSS.t303 VSS.t304 sg13_lv_nmos ad=79.8f pd=0.8u as=0 ps=0 w=0.42u l=1u
X309 a_19550_949# a_20391_913# a_20315_949# VDD sg13_lv_pmos ad=0.3808p pd=2.92u as=0.2128p ps=1.5u w=1.12u l=0.13u
X310 VSS.t308 VDD VSS.t307 VSS.t306 sg13_lv_nmos ad=0.1428p pd=1.52u as=0 ps=0 w=0.42u l=1u
X311 a_1544_949# MUX_SEL1 VDD VDD sg13_lv_pmos ad=0.3808p pd=2.92u as=0.3808p ps=2.92u w=1.12u l=0.13u
X312 a_16108_194# a_26985_424# a_25630_949# VDD sg13_lv_pmos ad=0.3808p pd=2.92u as=0.3808p ps=2.92u w=1.12u l=0.13u
X313 a_19550_949# a_21911_913# a_21835_949# VDD sg13_lv_pmos ad=0.3808p pd=2.92u as=0.2128p ps=1.5u w=1.12u l=0.13u
X314 VDD a_3747_952.t6 a_15831_913# VDD sg13_lv_pmos ad=0.3808p pd=2.92u as=0.3808p ps=2.92u w=1.12u l=0.13u
X315 a_18795_949# a_18585_949# VSS.t164 VSS.t163 sg13_lv_nmos ad=0.1406p pd=1.12u as=0.1665p ps=1.19u w=0.74u l=0.13u
X316 a_25630_949# a_3171_952.t2 a_27048_949# VSS.t32 sg13_lv_nmos ad=0.2516p pd=2.16u as=0.1406p ps=1.12u w=0.74u l=0.13u
X317 VSS.t51 a_2595_952.t5 a_17351_913# VSS.t50 sg13_lv_nmos ad=0.2516p pd=2.16u as=0.2516p ps=2.16u w=0.74u l=0.13u
X318 a_4350_949# a_3171_952.t9 a_5768_949# VSS.t26 sg13_lv_nmos ad=0.2516p pd=2.16u as=0.1406p ps=1.12u w=0.74u l=0.13u
X319 VSS.t48 a_2019_216# a_17865_424# VSS.t47 sg13_lv_nmos ad=0.2516p pd=2.16u as=0.2516p ps=2.16u w=0.74u l=0.13u
X320 VSS.t117 a_1544_194# a_2391_236# VSS.t120 sg13_lv_nmos ad=0.1331p pd=1.12u as=0.1216p ps=1.02u w=0.64u l=0.13u
X321 VSS.t128 a_2019_952.t8 a_7364_913# VSS.t127 sg13_lv_nmos ad=0.2516p pd=2.16u as=0.2516p ps=2.16u w=0.74u l=0.13u
X322 VSS.t45 a_2019_216# a_5705_424# VSS.t44 sg13_lv_nmos ad=0.2516p pd=2.16u as=0.2516p ps=2.16u w=0.74u l=0.13u
X323 MUX_OUT a_16851_214# VDD VDD sg13_lv_pmos ad=0.2128p pd=1.5u as=0.2086p ps=1.5u w=1.12u l=0.13u
X324 a_22488_949# DELAY_OUT_TAP24 VSS.t62 VSS.t61 sg13_lv_nmos ad=0.1406p pd=1.12u as=0.2516p ps=2.16u w=0.74u l=0.13u
X325 VDD VSS.t387 VDD VDD sg13_lv_pmos ad=0.19p pd=1.38u as=0 ps=0 w=1u l=1u
X326 VDD VSS.t361 VDD VDD sg13_lv_pmos ad=0.19p pd=1.38u as=0 ps=0 w=1u l=1u
X327 a_16408_949# DELAY_OUT_TAP16 VDD VDD sg13_lv_pmos ad=0.2128p pd=1.5u as=0.3808p ps=2.92u w=1.12u l=0.13u
X328 a_13470_949# a_2019_952.t6 a_13368_949# VSS.t76 sg13_lv_nmos ad=0.2516p pd=2.16u as=0.1406p ps=1.12u w=0.74u l=0.13u
X329 a_15964_194# a_15765_368# a_5731_194# VSS.t66 sg13_lv_nmos ad=0.2183p pd=1.33u as=0.2516p ps=2.16u w=0.74u l=0.13u
X330 VDD a_2019_952.t2 a_25604_913# VDD sg13_lv_pmos ad=0.3808p pd=2.92u as=0.3808p ps=2.92u w=1.12u l=0.13u
X331 a_2595_952.t0 a_2297_1300# VSS.t206 VSS.t223 sg13_lv_nmos ad=0.1406p pd=1.12u as=0.1331p ps=1.12u w=0.74u l=0.13u
X332 a_17928_949# DELAY_OUT_TAP18 VDD VDD sg13_lv_pmos ad=0.2128p pd=1.5u as=0.3808p ps=2.92u w=1.12u l=0.13u
X333 VSS.t254 a_3171_952.t3 a_24084_913# VSS.t253 sg13_lv_nmos ad=0.2516p pd=2.16u as=0.2516p ps=2.16u w=0.74u l=0.13u
X334 VDD VSS.t360 VDD VDD sg13_lv_pmos ad=0.34p pd=2.68u as=0 ps=0 w=1u l=1u
X335 a_2297_236# MUX_SEL2 VDD VDD sg13_lv_pmos ad=0.1596p pd=1.22u as=0.2856p ps=2.36u w=0.84u l=0.13u
X336 a_1815_1300# a_1256_949# a_1721_1300# VSS.t259 sg13_lv_nmos ad=0.1216p pd=1.02u as=0.2176p ps=1.96u w=0.64u l=0.13u
X337 a_2873_236# MUX_SEL3 VDD VDD sg13_lv_pmos ad=0.1596p pd=1.22u as=0.2856p ps=2.36u w=0.84u l=0.13u
X338 VSS.t164 DELAY_OUT_TAP19 a_18585_949# VSS.t207 sg13_lv_nmos ad=0.1665p pd=1.19u as=0.2516p ps=2.16u w=0.74u l=0.13u
X339 VSS.t338 VDD VSS.t337 VSS.t336 sg13_lv_nmos ad=0.1428p pd=1.52u as=0 ps=0 w=0.42u l=1u
X340 a_7288_949# DELAY_OUT_TAP4 VDD VDD sg13_lv_pmos ad=0.2128p pd=1.5u as=0.3808p ps=2.92u w=1.12u l=0.13u
X341 VSS.t303 VDD VSS.t302 VSS.t301 sg13_lv_nmos ad=0.1428p pd=1.52u as=0 ps=0 w=0.42u l=1u
X342 VSS.t315 VDD VSS.t313 VSS.t314 sg13_lv_nmos ad=79.8f pd=0.8u as=0 ps=0 w=0.42u l=1u
X343 VSS.t81 a_3171_952.t6 a_14964_913# VSS.t80 sg13_lv_nmos ad=0.2516p pd=2.16u as=0.2516p ps=2.16u w=0.74u l=0.13u
X344 VDD a_2019_216# a_17865_424# VDD sg13_lv_pmos ad=0.3808p pd=2.92u as=0.3808p ps=2.92u w=1.12u l=0.13u
X345 VDD a_3747_952.t4 a_21911_913# VDD sg13_lv_pmos ad=0.3808p pd=2.92u as=0.3808p ps=2.92u w=1.12u l=0.13u
X346 a_11195_949# a_10985_949# VSS.t162 VSS.t161 sg13_lv_nmos ad=0.1406p pd=1.12u as=0.1665p ps=1.19u w=0.74u l=0.13u
X347 a_1721_1300# a_1256_949# VDD VDD sg13_lv_pmos ad=0.1596p pd=1.22u as=0.2856p ps=2.36u w=0.84u l=0.13u
X348 VDD a_16851_214# MUX_OUT VDD sg13_lv_pmos ad=0.7336p pd=3.55u as=0.2128p ps=1.5u w=1.12u l=0.13u
X349 VSS.t137 a_3171_216.t2 a_23945_424# VSS.t136 sg13_lv_nmos ad=0.2516p pd=2.16u as=0.2516p ps=2.16u w=0.74u l=0.13u
X350 a_22590_949# a_2595_952.t3 a_23355_949# VSS.t249 sg13_lv_nmos ad=0.2516p pd=2.16u as=0.1406p ps=1.12u w=0.74u l=0.13u
X351 VSS.t65 MUX_SEL4 a_15765_368# VSS.t64 sg13_lv_nmos ad=0.2516p pd=2.16u as=0.2516p ps=2.16u w=0.74u l=0.13u
X352 a_16510_949# a_16484_913# a_16408_949# VDD sg13_lv_pmos ad=0.3808p pd=2.92u as=0.2128p ps=1.5u w=1.12u l=0.13u
X353 VDD VSS.t363 VDD VDD sg13_lv_pmos ad=0.19p pd=1.38u as=0 ps=0 w=1u l=1u
X354 VDD DELAY_OUT_TAP9 a_10985_949# VDD sg13_lv_pmos ad=0.252p pd=1.57u as=0.3808p ps=2.92u w=1.12u l=0.13u
X355 VDD a_1544_949# a_1721_1300# VDD sg13_lv_pmos ad=0.1918p pd=1.5u as=0.1596p ps=1.22u w=0.84u l=0.13u
X356 VDD VSS.t377 VDD VDD sg13_lv_pmos ad=0.19p pd=1.38u as=0 ps=0 w=1u l=1u
X357 VDD a_2019_216# a_5705_424# VDD sg13_lv_pmos ad=0.3808p pd=2.92u as=0.3808p ps=2.92u w=1.12u l=0.13u
X358 VDD VSS.t376 VDD VDD sg13_lv_pmos ad=0.34p pd=2.68u as=0 ps=0 w=1u l=1u
X359 VSS.t131 a_2019_952.t7 a_10404_913# VSS.t130 sg13_lv_nmos ad=0.2516p pd=2.16u as=0.2516p ps=2.16u w=0.74u l=0.13u
X360 VDD a_1544_194# a_2297_236# VDD sg13_lv_pmos ad=0.1918p pd=1.5u as=0.1596p ps=1.22u w=0.84u l=0.13u
X361 a_26395_949# a_26185_949# VSS.t15 VSS.t14 sg13_lv_nmos ad=0.1406p pd=1.12u as=0.1665p ps=1.19u w=0.74u l=0.13u
X362 VSS.t295 VDD VSS.t293 VSS.t294 sg13_lv_nmos ad=79.8f pd=0.8u as=0 ps=0 w=0.42u l=1u
X363 VSS.t245 a_3747_952.t3 a_24951_913# VSS.t244 sg13_lv_nmos ad=0.2516p pd=2.16u as=0.2516p ps=2.16u w=0.74u l=0.13u
X364 a_18795_949# a_18585_949# VDD VDD sg13_lv_pmos ad=0.2128p pd=1.5u as=0.252p ps=1.57u w=1.12u l=0.13u
X365 a_14235_949# a_14025_949# VDD VDD sg13_lv_pmos ad=0.2128p pd=1.5u as=0.252p ps=1.57u w=1.12u l=0.13u
X366 VDD DELAY_OUT_TAP3 a_6425_949# VDD sg13_lv_pmos ad=0.252p pd=1.57u as=0.3808p ps=2.92u w=1.12u l=0.13u
X367 a_7390_949# a_7364_913# a_7288_949# VDD sg13_lv_pmos ad=0.3808p pd=2.92u as=0.2128p ps=1.5u w=1.12u l=0.13u
X368 a_24008_949# DELAY_OUT_TAP26 VSS.t99 VSS.t98 sg13_lv_nmos ad=0.1406p pd=1.12u as=0.2516p ps=2.16u w=0.74u l=0.13u
X369 a_15964_194# MUX_SEL4 a_5731_194# VDD sg13_lv_pmos ad=0.3304p pd=1.71u as=0.3808p ps=2.92u w=1.12u l=0.13u
X370 a_1256_949# MUX_SEL0 VSS.t195 VSS.t194 sg13_lv_nmos ad=0.2516p pd=2.16u as=0.2516p ps=2.16u w=0.74u l=0.13u
X371 a_22488_949# DELAY_OUT_TAP24 VDD VDD sg13_lv_pmos ad=0.2128p pd=1.5u as=0.3808p ps=2.92u w=1.12u l=0.13u
X372 a_16510_949# a_18871_913# a_18795_949# VDD sg13_lv_pmos ad=0.3808p pd=2.92u as=0.2128p ps=1.5u w=1.12u l=0.13u
X373 a_27048_949# DELAY_OUT_TAP30 VDD VDD sg13_lv_pmos ad=0.2128p pd=1.5u as=0.3808p ps=2.92u w=1.12u l=0.13u
X374 a_13470_949# a_14311_913# a_14235_949# VDD sg13_lv_pmos ad=0.3808p pd=2.92u as=0.2128p ps=1.5u w=1.12u l=0.13u
X375 a_13470_949# a_3171_952.t6 a_14888_949# VSS.t79 sg13_lv_nmos ad=0.2516p pd=2.16u as=0.1406p ps=1.12u w=0.74u l=0.13u
X376 a_1256_194# MUX_SEL2 VSS.t237 VSS.t236 sg13_lv_nmos ad=0.2516p pd=2.16u as=0.2516p ps=2.16u w=0.74u l=0.13u
X377 a_9675_949# a_9465_949# VDD VDD sg13_lv_pmos ad=0.2128p pd=1.5u as=0.252p ps=1.57u w=1.12u l=0.13u
X378 VSS.t87 a_2019_952.t2 a_25604_913# VSS.t86 sg13_lv_nmos ad=0.2516p pd=2.16u as=0.2516p ps=2.16u w=0.74u l=0.13u
X379 a_16108_194# MUX_SEL4 a_15964_194# VSS.t63 sg13_lv_nmos ad=0.2516p pd=2.16u as=0.2183p ps=1.33u w=0.74u l=0.13u
X380 a_21835_949# a_21625_949# VSS.t92 VSS.t153 sg13_lv_nmos ad=0.1406p pd=1.12u as=0.1665p ps=1.19u w=0.74u l=0.13u
X381 VSS.t60 a_2595_952.t4 a_20391_913# VSS.t59 sg13_lv_nmos ad=0.2516p pd=2.16u as=0.2516p ps=2.16u w=0.74u l=0.13u
X382 a_2019_952.t1 a_1721_1300# VDD VDD sg13_lv_pmos ad=0.2128p pd=1.5u as=0.1918p ps=1.5u w=1.12u l=0.13u
X383 VSS.t162 DELAY_OUT_TAP9 a_10985_949# VSS.t214 sg13_lv_nmos ad=0.1665p pd=1.19u as=0.2516p ps=2.16u w=0.74u l=0.13u
X384 a_7390_949# a_9751_913# a_9675_949# VDD sg13_lv_pmos ad=0.3808p pd=2.92u as=0.2128p ps=1.5u w=1.12u l=0.13u
X385 VSS.t313 VDD VSS.t312 VSS.t311 sg13_lv_nmos ad=0.1428p pd=1.52u as=0 ps=0 w=0.42u l=1u
X386 VDD a_3171_216.t2 a_23945_424# VDD sg13_lv_pmos ad=0.3808p pd=2.92u as=0.3808p ps=2.92u w=1.12u l=0.13u
X387 VSS.t110 a_3747_952.t5 a_18871_913# VSS.t109 sg13_lv_nmos ad=0.2516p pd=2.16u as=0.2516p ps=2.16u w=0.74u l=0.13u
X388 a_12715_949# a_12505_949# VSS.t104 VSS.t103 sg13_lv_nmos ad=0.1406p pd=1.12u as=0.1665p ps=1.19u w=0.74u l=0.13u
X389 a_17928_949# DELAY_OUT_TAP18 VSS.t222 VSS.t221 sg13_lv_nmos ad=0.1406p pd=1.12u as=0.2516p ps=2.16u w=0.74u l=0.13u
X390 VDD MUX_SEL4 a_15765_368# VDD sg13_lv_pmos ad=0.3808p pd=2.92u as=0.3808p ps=2.92u w=1.12u l=0.13u
X391 a_19550_949# a_3171_952.t4 a_20968_949# VSS.t144 sg13_lv_nmos ad=0.2516p pd=2.16u as=0.1406p ps=1.12u w=0.74u l=0.13u
X392 a_7288_949# DELAY_OUT_TAP4 VSS.t187 VSS.t186 sg13_lv_nmos ad=0.1406p pd=1.12u as=0.2516p ps=2.16u w=0.74u l=0.13u
X393 a_1815_236# a_1256_194# a_1721_236# VSS.t122 sg13_lv_nmos ad=0.1216p pd=1.02u as=0.2176p ps=1.96u w=0.64u l=0.13u
X394 a_1544_194# MUX_SEL3 VSS.t39 VSS.t38 sg13_lv_nmos ad=0.2516p pd=2.16u as=0.2516p ps=2.16u w=0.74u l=0.13u
X395 a_22590_949# a_3747_952.t3 a_24875_949# VSS.t243 sg13_lv_nmos ad=0.2516p pd=2.16u as=0.1406p ps=1.12u w=0.74u l=0.13u
X396 VDD DELAY_OUT_TAP23 a_21625_949# VDD sg13_lv_pmos ad=0.252p pd=1.57u as=0.3808p ps=2.92u w=1.12u l=0.13u
X397 a_22590_949# a_22564_913# a_22488_949# VDD sg13_lv_pmos ad=0.3808p pd=2.92u as=0.2128p ps=1.5u w=1.12u l=0.13u
X398 VSS.t15 DELAY_OUT_TAP29 a_26185_949# VSS.t88 sg13_lv_nmos ad=0.1665p pd=1.19u as=0.2516p ps=2.16u w=0.74u l=0.13u
X399 VSS.t283 VDD VSS.t282 VSS.t281 sg13_lv_nmos ad=0.1428p pd=1.52u as=0 ps=0 w=0.42u l=1u
X400 VDD DELAY_OUT_TAP29 a_26185_949# VDD sg13_lv_pmos ad=0.252p pd=1.57u as=0.3808p ps=2.92u w=1.12u l=0.13u
X401 VSS.t148 DELAY_OUT_TAP1 a_4905_949# VSS.t188 sg13_lv_nmos ad=0.1665p pd=1.19u as=0.2516p ps=2.16u w=0.74u l=0.13u
X402 a_25630_949# a_27124_913# a_27048_949# VDD sg13_lv_pmos ad=0.3808p pd=2.92u as=0.2128p ps=1.5u w=1.12u l=0.13u
X403 VDD VSS.t364 VDD VDD sg13_lv_pmos ad=0.34p pd=2.68u as=0 ps=0 w=1u l=1u
X404 VDD a_2019_952.t6 a_13444_913# VDD sg13_lv_pmos ad=0.3808p pd=2.92u as=0.3808p ps=2.92u w=1.12u l=0.13u
X405 VSS.t84 a_3171_952.t8 a_8884_913# VSS.t83 sg13_lv_nmos ad=0.2516p pd=2.16u as=0.2516p ps=2.16u w=0.74u l=0.13u
X406 VDD VSS.t378 VDD VDD sg13_lv_pmos ad=0.34p pd=2.68u as=0 ps=0 w=1u l=1u
X407 VDD VSS.t373 VDD VDD sg13_lv_pmos ad=0.19p pd=1.38u as=0 ps=0 w=1u l=1u
X408 VSS.t17 a_1544_194# a_1815_236# VSS.t121 sg13_lv_nmos ad=0.1331p pd=1.12u as=0.1216p ps=1.02u w=0.64u l=0.13u
X409 VDD a_3171_952.t5 a_18004_913# VDD sg13_lv_pmos ad=0.3808p pd=2.92u as=0.3808p ps=2.92u w=1.12u l=0.13u
X410 VSS.t150 MUX_SEL1 a_3543_1300# VSS.t185 sg13_lv_nmos ad=0.1331p pd=1.12u as=0.1216p ps=1.02u w=0.64u l=0.13u
X411 a_27915_949# a_27705_949# VSS.t13 VSS.t156 sg13_lv_nmos ad=0.1406p pd=1.12u as=0.1665p ps=1.19u w=0.74u l=0.13u
X412 VSS.t355 VDD VSS.t353 VSS.t354 sg13_lv_nmos ad=79.8f pd=0.8u as=0 ps=0 w=0.42u l=1u
X413 a_24875_949# a_24665_949# VDD VDD sg13_lv_pmos ad=0.2128p pd=1.5u as=0.252p ps=1.57u w=1.12u l=0.13u
C0 a_2297_1300# MUX_SEL1 0.01995f
C1 a_1721_1300# MUX_SEL0 0.01315f
C2 VDD MUX_SEL0 0.51342f
C3 DELAY_OUT_TAP3 a_6425_949# 0.2079f
C4 a_20105_949# a_20315_949# 0.09424f
C5 a_15755_949# a_15545_949# 0.09424f
C6 a_19448_949# VDD 0.17274f
C7 VDD a_24084_913# 0.28225f
C8 a_4248_949# a_4350_949# 0.37183f
C9 VDD MUX_SEL1 0.49936f
C10 a_1544_949# a_2297_1300# 0.28651f
C11 a_18004_913# DELAY_OUT_TAP19 0.02053f
C12 a_14888_949# a_14964_913# 0.01176f
C13 a_15964_194# a_16108_194# 0.42202f
C14 a_4248_949# VDD 0.17587f
C15 VDD a_14888_949# 0.17499f
C16 a_15964_194# VDD 0.31311f
C17 a_1544_194# MUX_SEL2 0.07405f
C18 a_3449_236# a_2019_216# 0.01176f
C19 a_1256_194# MUX_SEL3 1.41161f
C20 a_14025_949# VDD 0.30333f
C21 a_4350_949# a_5731_194# 0.41099f
C22 a_8231_913# a_7945_949# 0.01885f
C23 a_1544_949# a_1721_1300# 0.38063f
C24 a_1544_949# VDD 0.45004f
C25 DELAY_OUT_TAP4 a_7288_949# 0.10864f
C26 DELAY_OUT_TAP0 MUX_SEL1 0.01783f
C27 a_16108_194# a_5731_194# 0.01334f
C28 VDD DELAY_OUT_TAP7 0.12759f
C29 a_15755_949# a_15831_913# 0.01194f
C30 a_5731_194# VDD 0.6143f
C31 a_24951_913# a_24665_949# 0.01885f
C32 a_10430_949# a_12791_913# 0.26208f
C33 a_5844_913# a_5768_949# 0.01176f
C34 DELAY_OUT_TAP10 a_10430_949# 0.07996f
C35 a_15964_194# a_16851_214# 0.16757f
C36 DELAY_OUT_TAP20 a_19524_913# 0.02011f
C37 a_11924_913# VDD 0.28225f
C38 DELAY_OUT_TAP16 a_13470_949# 0.02437f
C39 a_7390_949# a_7945_949# 0.03209f
C40 a_1721_236# MUX_SEL2 0.01315f
C41 DELAY_OUT_TAP23 a_19550_949# 0.05189f
C42 a_10430_949# a_11848_949# 0.38994f
C43 a_8808_949# DELAY_OUT_TAP6 0.10863f
C44 a_5115_949# a_4905_949# 0.09424f
C45 a_21835_949# a_21911_913# 0.01194f
C46 a_23431_913# a_23145_949# 0.01885f
C47 a_1256_949# a_2873_1300# 0.28892f
C48 a_16108_194# a_20905_424# 0.2906f
C49 a_22590_949# DELAY_OUT_TAP26 0.07996f
C50 a_20905_424# VDD 0.29292f
C51 a_10430_949# a_11271_913# 0.28268f
C52 a_20105_949# a_19550_949# 0.03209f
C53 VDD DELAY_OUT_TAP13 0.13651f
C54 VDD DELAY_OUT_TAP19 0.12759f
C55 a_8884_913# a_7390_949# 0.28279f
C56 DELAY_OUT_TAP10 a_11848_949# 0.10863f
C57 a_21625_949# a_19550_949# 0.03208f
C58 MUX_OUT MUX_SEL2 0.08497f
C59 DELAY_OUT_TAP23 DELAY_OUT_TAP24 0.0331f
C60 DELAY_OUT_TAP8 DELAY_OUT_TAP7 0.0331f
C61 MUX_SEL0 MUX_SEL1 3.14917f
C62 DELAY_OUT_TAP10 a_11271_913# 0.02334f
C63 a_27124_913# VDD 0.28225f
C64 MUX_SEL4 DELAY_OUT_TAP12 0.01829f
C65 DELAY_OUT_TAP14 a_13470_949# 0.07996f
C66 a_18795_949# a_18585_949# 0.09424f
C67 a_11195_949# a_10430_949# 0.39037f
C68 a_1544_949# MUX_SEL0 0.07603f
C69 a_17351_913# a_17065_949# 0.01885f
C70 DELAY_OUT_TAP4 DELAY_OUT_TAP5 0.06596f
C71 a_17928_949# a_18004_913# 0.01176f
C72 a_18871_913# VDD 0.2822f
C73 a_1544_949# MUX_SEL1 0.1672f
C74 a_18004_913# DELAY_OUT_TAP18 0.02312f
C75 MUX_SEL4 a_2297_236# 0.04338f
C76 a_3449_236# MUX_SEL3 0.28429f
C77 a_10985_949# DELAY_OUT_TAP9 0.19203f
C78 a_16510_949# DELAY_OUT_TAP17 0.10838f
C79 MUX_SEL2 MUX_SEL3 3.21891f
C80 DELAY_OUT_TAP28 a_22590_949# 0.02437f
C81 a_1256_194# MUX_SEL2 0.33134f
C82 a_12505_949# VDD 0.29646f
C83 a_10328_949# a_10430_949# 0.37183f
C84 a_16510_949# a_17275_949# 0.39037f
C85 a_8155_949# a_7945_949# 0.09424f
C86 DELAY_OUT_TAP4 a_6711_913# 0.02339f
C87 DELAY_OUT_TAP21 VDD 0.13651f
C88 VDD DELAY_OUT_TAP6 0.13878f
C89 a_15964_194# a_5731_194# 0.2778f
C90 a_20315_949# a_20391_913# 0.01194f
C91 DELAY_OUT_TAP23 a_21044_913# 0.02053f
C92 a_2873_236# MUX_SEL3 0.12606f
C93 DELAY_OUT_TAP14 a_14311_913# 0.02334f
C94 a_1256_194# a_2873_236# 0.27926f
C95 MUX_SEL4 a_8745_424# 0.04472f
C96 VDD DELAY_OUT_TAP27 0.12759f
C97 a_16108_194# a_26985_424# 0.2906f
C98 a_12715_949# a_12505_949# 0.09424f
C99 a_24008_949# DELAY_OUT_TAP26 0.10863f
C100 a_26985_424# VDD 0.29292f
C101 a_11195_949# a_11271_913# 0.01194f
C102 a_26471_913# VDD 0.28336f
C103 a_23145_949# VDD 0.30333f
C104 a_23431_913# DELAY_OUT_TAP26 0.02334f
C105 MUX_SEL4 a_7390_949# 0.34655f
C106 a_10985_949# VDD 0.30333f
C107 DELAY_OUT_TAP22 a_19550_949# 0.07996f
C108 a_25604_913# VDD 0.28633f
C109 a_27705_949# VDD 0.29842f
C110 a_17928_949# VDD 0.17499f
C111 DELAY_OUT_TAP3 a_5844_913# 0.02053f
C112 a_16108_194# a_25630_949# 0.55833f
C113 DELAY_OUT_TAP5 a_7945_949# 0.19203f
C114 a_9465_949# VDD 0.29646f
C115 a_14025_949# DELAY_OUT_TAP13 0.19203f
C116 a_25630_949# VDD 0.89531f
C117 a_5115_949# a_5191_913# 0.01194f
C118 VDD DELAY_OUT_TAP12 0.1474f
C119 MUX_SEL4 a_13470_949# 0.256f
C120 a_27991_913# VDD 0.28201f
C121 VDD DELAY_OUT_TAP18 0.13878f
C122 a_8808_949# a_7390_949# 0.38994f
C123 a_17351_913# VDD 0.28565f
C124 a_22590_949# a_24951_913# 0.26208f
C125 MUX_SEL4 a_2019_216# 0.90276f
C126 MUX_SEL4 a_1544_194# 0.47529f
C127 a_4350_949# a_6425_949# 0.03208f
C128 a_27915_949# VDD 0.15389f
C129 DELAY_OUT_TAP29 VDD 0.13651f
C130 a_27048_949# VDD 0.17499f
C131 DELAY_OUT_TAP16 DELAY_OUT_TAP17 0.06596f
C132 a_6425_949# VDD 0.29646f
C133 a_16484_913# DELAY_OUT_TAP17 0.0501f
C134 a_10404_913# a_10430_949# 0.277f
C135 a_20391_913# a_19550_949# 0.28268f
C136 a_2297_236# VDD 0.46496f
C137 a_21911_913# a_19550_949# 0.26208f
C138 a_8231_913# VDD 0.28336f
C139 MUX_SEL4 a_1721_236# 0.05813f
C140 MUX_SEL4 a_15765_368# 0.65508f
C141 a_3449_236# MUX_SEL2 0.10741f
C142 a_8745_424# VDD 0.29292f
C143 a_21835_949# a_19550_949# 0.39036f
C144 a_16108_194# DELAY_OUT_TAP20 0.0157f
C145 a_4157_1218# a_2019_216# 0.01018f
C146 DELAY_OUT_TAP27 a_24084_913# 0.02053f
C147 a_16510_949# a_16484_913# 0.277f
C148 DELAY_OUT_TAP20 VDD 0.14794f
C149 a_9751_913# VDD 0.2822f
C150 DELAY_OUT_TAP6 DELAY_OUT_TAP7 0.03717f
C151 DELAY_OUT_TAP22 a_21044_913# 0.02312f
C152 a_2873_236# MUX_SEL2 0.01422f
C153 a_7364_913# VDD 0.28633f
C154 VDD DELAY_OUT_TAP23 0.12759f
C155 a_22590_949# a_24665_949# 0.03208f
C156 a_21911_913# DELAY_OUT_TAP24 0.02339f
C157 DELAY_OUT_TAP15 DELAY_OUT_TAP16 0.0331f
C158 a_9675_949# VDD 0.15406f
C159 VDD DELAY_OUT_TAP26 0.13878f
C160 MUX_SEL4 a_11785_424# 0.03255f
C161 a_7390_949# VDD 0.8686f
C162 MUX_SEL4 MUX_OUT 0.91933f
C163 a_20105_949# VDD 0.30333f
C164 a_16408_949# a_16510_949# 0.37183f
C165 VDD a_13444_913# 0.28633f
C166 a_25528_949# VDD 0.17274f
C167 a_26395_949# VDD 0.15389f
C168 a_6635_949# a_4350_949# 0.39036f
C169 a_21625_949# VDD 0.29646f
C170 a_13470_949# a_14964_913# 0.28279f
C171 a_18585_949# VDD 0.29646f
C172 a_6635_949# VDD 0.15406f
C173 VDD a_13470_949# 0.87936f
C174 a_4350_949# a_2019_216# 0.02042f
C175 a_16108_194# a_2019_216# 0.33889f
C176 a_18795_949# a_16510_949# 0.39036f
C177 DELAY_OUT_TAP3 DELAY_OUT_TAP4 0.0331f
C178 DELAY_OUT_TAP2 a_5844_913# 0.02312f
C179 a_1544_194# VDD 0.39113f
C180 a_2019_216# VDD 1.43004f
C181 a_9465_949# DELAY_OUT_TAP7 0.2079f
C182 MUX_SEL4 a_1256_949# 0.04908f
C183 a_17865_424# a_2019_216# 0.13959f
C184 a_4905_949# DELAY_OUT_TAP1 0.19203f
C185 a_7288_949# VDD 0.17274f
C186 DELAY_OUT_TAP14 DELAY_OUT_TAP15 0.03717f
C187 MUX_SEL4 MUX_SEL3 0.75489f
C188 VDD a_13368_949# 0.17274f
C189 MUX_SEL4 a_10430_949# 0.24983f
C190 MUX_SEL4 a_1256_194# 0.65005f
C191 a_15545_949# a_13470_949# 0.03208f
C192 a_16108_194# DELAY_OUT_TAP28 0.0157f
C193 MUX_SEL4 a_5705_424# 0.03556f
C194 DELAY_OUT_TAP11 VDD 0.12759f
C195 a_4350_949# a_4905_949# 0.03209f
C196 a_9751_913# DELAY_OUT_TAP8 0.02339f
C197 DELAY_OUT_TAP28 VDD 0.14794f
C198 a_16851_214# a_2019_216# 0.01299f
C199 VDD DELAY_OUT_TAP31 0.1288f
C200 a_16484_913# DELAY_OUT_TAP16 0.02011f
C201 a_4905_949# VDD 0.3005f
C202 a_22590_949# DELAY_OUT_TAP25 0.10838f
C203 a_14311_913# VDD 0.28336f
C204 a_10404_913# a_10328_949# 0.01176f
C205 a_20315_949# a_19550_949# 0.39037f
C206 a_15765_368# a_16108_194# 0.42004f
C207 VDD a_26185_949# 0.30333f
C208 a_1721_236# VDD 0.45259f
C209 DELAY_OUT_TAP8 a_7390_949# 0.02437f
C210 DELAY_OUT_TAP2 a_5768_949# 0.10863f
C211 a_15765_368# VDD 0.35368f
C212 a_15831_913# a_13470_949# 0.26208f
C213 a_19448_949# DELAY_OUT_TAP20 0.10864f
C214 a_8155_949# VDD 0.15389f
C215 DELAY_OUT_TAP2 a_5191_913# 0.02334f
C216 DELAY_OUT_TAP24 DELAY_OUT_TAP25 0.06596f
C217 a_15755_949# a_13470_949# 0.39036f
C218 MUX_SEL4 a_14825_424# 0.03307f
C219 a_16408_949# DELAY_OUT_TAP16 0.10864f
C220 a_23355_949# a_22590_949# 0.39037f
C221 DELAY_OUT_TAP26 a_24084_913# 0.02312f
C222 a_16408_949# a_16484_913# 0.01176f
C223 a_5731_194# a_8745_424# 0.28635f
C224 DELAY_OUT_TAP12 DELAY_OUT_TAP13 0.06596f
C225 a_11785_424# VDD 0.29292f
C226 MUX_OUT a_16108_194# 0.24265f
C227 a_17065_949# DELAY_OUT_TAP17 0.19203f
C228 DELAY_OUT_TAP9 a_10430_949# 0.10838f
C229 DELAY_OUT_TAP18 DELAY_OUT_TAP19 0.03717f
C230 DELAY_OUT_TAP22 a_20968_949# 0.10863f
C231 MUX_OUT VDD 0.35871f
C232 a_17065_949# a_17275_949# 0.09424f
C233 VDD DELAY_OUT_TAP22 0.13878f
C234 a_24951_913# a_24875_949# 0.01194f
C235 a_25630_949# a_27124_913# 0.28279f
C236 a_22564_913# DELAY_OUT_TAP25 0.0501f
C237 a_7390_949# DELAY_OUT_TAP7 0.05189f
C238 a_1256_949# a_2297_1300# 0.04619f
C239 DELAY_OUT_TAP9 DELAY_OUT_TAP10 0.02068f
C240 a_7390_949# a_5731_194# 0.41331f
C241 MUX_OUT a_16851_214# 0.45865f
C242 a_24951_913# VDD 0.2822f
C243 a_5844_913# a_4350_949# 0.28279f
C244 a_27048_949# a_27124_913# 0.01176f
C245 a_16510_949# a_17065_949# 0.03209f
C246 a_19550_949# a_19524_913# 0.277f
C247 a_1256_949# a_1721_1300# 0.13421f
C248 a_13470_949# a_14888_949# 0.38994f
C249 a_14025_949# a_13470_949# 0.03209f
C250 a_1256_949# VDD 0.47094f
C251 a_5844_913# VDD 0.28225f
C252 DELAY_OUT_TAP5 VDD 0.13651f
C253 a_4350_949# a_5705_424# 0.02005f
C254 a_5731_194# a_13470_949# 0.41365f
C255 a_15964_194# a_2019_216# 0.02413f
C256 VDD MUX_SEL3 0.4053f
C257 a_18004_913# a_16510_949# 0.28279f
C258 a_10430_949# VDD 0.88416f
C259 a_1256_194# VDD 0.40292f
C260 a_5705_424# VDD 0.29556f
C261 a_20391_913# VDD 0.28336f
C262 a_4350_949# a_6711_913# 0.26208f
C263 MUX_SEL4 DELAY_OUT_TAP4 0.0195f
C264 a_2019_216# a_5731_194# 1.15781f
C265 DELAY_OUT_TAP20 DELAY_OUT_TAP19 0.0331f
C266 a_6711_913# VDD 0.2822f
C267 MUX_SEL4 a_3449_236# 0.05166f
C268 MUX_SEL4 MUX_SEL2 0.01978f
C269 VDD a_12791_913# 0.2822f
C270 a_21911_913# VDD 0.2822f
C271 a_24875_949# a_24665_949# 0.09424f
C272 a_4350_949# a_5768_949# 0.38994f
C273 DELAY_OUT_TAP10 VDD 0.13878f
C274 a_12715_949# a_10430_949# 0.39036f
C275 a_25630_949# a_26985_424# 0.02165f
C276 a_19550_949# DELAY_OUT_TAP24 0.02437f
C277 MUX_SEL4 a_2873_236# 0.04916f
C278 a_5768_949# VDD 0.17499f
C279 a_21835_949# VDD 0.15406f
C280 a_14311_913# a_14025_949# 0.01885f
C281 VDD DELAY_OUT_TAP30 0.13878f
C282 a_4350_949# a_5191_913# 0.28268f
C283 a_26471_913# a_25630_949# 0.28268f
C284 DELAY_OUT_TAP13 a_13444_913# 0.0501f
C285 a_14235_949# VDD 0.15389f
C286 a_15765_368# a_15964_194# 0.061f
C287 VDD a_24665_949# 0.29646f
C288 VDD DELAY_OUT_TAP17 0.1382f
C289 a_14825_424# VDD 0.29292f
C290 a_23355_949# a_23431_913# 0.01194f
C291 a_12715_949# a_12791_913# 0.01194f
C292 a_5191_913# VDD 0.28565f
C293 a_11848_949# VDD 0.17499f
C294 a_11924_913# DELAY_OUT_TAP11 0.02053f
C295 VDD a_17275_949# 0.15389f
C296 a_15765_368# a_5731_194# 0.23301f
C297 a_25630_949# a_25604_913# 0.277f
C298 a_18871_913# DELAY_OUT_TAP20 0.02339f
C299 a_18585_949# DELAY_OUT_TAP19 0.2079f
C300 DELAY_OUT_TAP13 a_13470_949# 0.10838f
C301 a_8231_913# DELAY_OUT_TAP6 0.02334f
C302 a_27705_949# a_25630_949# 0.03208f
C303 MUX_OUT MUX_SEL1 0.09357f
C304 a_27705_949# a_27991_913# 0.01885f
C305 a_11271_913# VDD 0.28336f
C306 a_17928_949# DELAY_OUT_TAP18 0.10863f
C307 a_22564_913# a_22590_949# 0.277f
C308 VDD a_2873_1300# 0.46491f
C309 a_25630_949# a_27991_913# 0.26208f
C310 DELAY_OUT_TAP29 a_25604_913# 0.0501f
C311 MUX_OUT a_15964_194# 0.01307f
C312 DELAY_OUT_TAP20 DELAY_OUT_TAP21 0.06596f
C313 a_16108_194# a_16510_949# 0.56108f
C314 MUX_OUT a_1544_949# 0.04258f
C315 a_27705_949# a_27915_949# 0.09424f
C316 a_5731_194# a_11785_424# 0.28056f
C317 a_16510_949# VDD 0.8795f
C318 a_17351_913# DELAY_OUT_TAP18 0.02334f
C319 DELAY_OUT_TAP2 DELAY_OUT_TAP3 0.03717f
C320 MUX_OUT a_5731_194# 1.04829f
C321 a_1256_949# MUX_SEL0 0.3314f
C322 a_25630_949# a_27915_949# 0.39036f
C323 DELAY_OUT_TAP29 a_25630_949# 0.10838f
C324 a_25630_949# a_27048_949# 0.38994f
C325 a_19550_949# a_21044_913# 0.28279f
C326 a_17865_424# a_16510_949# 0.02165f
C327 a_27915_949# a_27991_913# 0.01194f
C328 a_18871_913# a_18585_949# 0.01885f
C329 a_22564_913# DELAY_OUT_TAP24 0.02011f
C330 a_1256_949# MUX_SEL1 1.44243f
C331 a_7390_949# DELAY_OUT_TAP6 0.07996f
C332 DELAY_OUT_TAP15 a_14964_913# 0.02053f
C333 a_11195_949# VDD 0.15389f
C334 DELAY_OUT_TAP21 a_20105_949# 0.19203f
C335 DELAY_OUT_TAP15 VDD 0.12874f
C336 a_16851_214# a_16510_949# 0.02131f
C337 a_24008_949# a_22590_949# 0.38994f
C338 DELAY_OUT_TAP4 a_4350_949# 0.02437f
C339 DELAY_OUT_TAP26 DELAY_OUT_TAP27 0.03717f
C340 a_1256_949# a_1544_949# 1.26509f
C341 a_27124_913# DELAY_OUT_TAP31 0.02053f
C342 DELAY_OUT_TAP4 VDD 0.14695f
C343 a_23431_913# a_22590_949# 0.28268f
C344 VDD DELAY_OUT_TAP25 0.13651f
C345 a_3449_236# VDD 0.46596f
C346 VDD MUX_SEL2 0.50938f
C347 a_10328_949# VDD 0.17274f
C348 a_9751_913# a_9465_949# 0.01885f
C349 DELAY_OUT_TAP15 a_15545_949# 0.2079f
C350 a_20315_949# VDD 0.15389f
C351 a_10430_949# a_5731_194# 0.41176f
C352 a_26395_949# a_26471_913# 0.01194f
C353 a_5705_424# a_5731_194# 0.28954f
C354 a_4350_949# a_5115_949# 0.39037f
C355 a_22488_949# a_22590_949# 0.37183f
C356 a_2873_236# VDD 0.46491f
C357 DELAY_OUT_TAP0 a_3449_236# 0.01017f
C358 a_12505_949# DELAY_OUT_TAP11 0.2079f
C359 a_9675_949# a_9465_949# 0.09424f
C360 a_5115_949# VDD 0.15389f
C361 a_8808_949# a_8884_913# 0.01176f
C362 a_25604_913# a_25528_949# 0.01176f
C363 a_9465_949# a_7390_949# 0.03208f
C364 a_11924_913# a_10430_949# 0.28279f
C365 a_23355_949# VDD 0.15389f
C366 a_14235_949# a_14025_949# 0.09424f
C367 a_25630_949# a_25528_949# 0.37183f
C368 a_22488_949# DELAY_OUT_TAP24 0.10864f
C369 a_26395_949# a_25630_949# 0.39037f
C370 DELAY_OUT_TAP12 a_13444_913# 0.02011f
C371 MUX_SEL0 a_2873_1300# 0.01504f
C372 VDD DELAY_OUT_TAP16 0.14932f
C373 DELAY_OUT_TAP28 DELAY_OUT_TAP27 0.0331f
C374 DELAY_OUT_TAP9 a_10404_913# 0.0501f
C375 a_11924_913# DELAY_OUT_TAP10 0.02312f
C376 VDD a_16484_913# 0.28597f
C377 a_14825_424# a_5731_194# 0.28056f
C378 MUX_SEL1 a_2873_1300# 0.13092f
C379 DELAY_OUT_TAP3 a_4350_949# 0.05189f
C380 a_22564_913# a_22488_949# 0.01176f
C381 DELAY_OUT_TAP3 VDD 0.12759f
C382 a_7945_949# VDD 0.30333f
C383 DELAY_OUT_TAP28 a_25604_913# 0.02011f
C384 a_26471_913# a_26185_949# 0.01885f
C385 a_15964_194# a_16510_949# 0.05416f
C386 a_11924_913# a_11848_949# 0.01176f
C387 DELAY_OUT_TAP8 a_10328_949# 0.10864f
C388 a_6635_949# a_6425_949# 0.09424f
C389 a_22590_949# a_24875_949# 0.39036f
C390 a_8231_913# a_7390_949# 0.28268f
C391 VDD a_19524_913# 0.28633f
C392 a_16408_949# VDD 0.17274f
C393 DELAY_OUT_TAP12 a_13368_949# 0.10864f
C394 DELAY_OUT_TAP21 DELAY_OUT_TAP22 0.02068f
C395 DELAY_OUT_TAP11 DELAY_OUT_TAP12 0.0331f
C396 a_7390_949# a_8745_424# 0.01756f
C397 a_4324_913# a_4157_1218# 0.02463f
C398 a_27705_949# DELAY_OUT_TAP31 0.2079f
C399 a_16108_194# a_19550_949# 0.58202f
C400 a_19550_949# a_20968_949# 0.38994f
C401 a_9675_949# a_9751_913# 0.01194f
C402 VDD a_19550_949# 0.89766f
C403 a_16108_194# a_22590_949# 0.58202f
C404 a_25630_949# DELAY_OUT_TAP31 0.05211f
C405 a_9751_913# a_7390_949# 0.26208f
C406 DELAY_OUT_TAP14 a_14964_913# 0.02312f
C407 a_10404_913# VDD 0.28633f
C408 MUX_SEL0 MUX_SEL2 0.01204f
C409 a_1544_194# a_2297_236# 0.27303f
C410 a_22590_949# VDD 0.89557f
C411 a_2019_216# a_2297_236# 0.04011f
C412 a_7390_949# a_7364_913# 0.277f
C413 DELAY_OUT_TAP14 VDD 0.13878f
C414 a_15831_913# DELAY_OUT_TAP16 0.02339f
C415 a_25630_949# a_26185_949# 0.03209f
C416 a_8884_913# VDD 0.28225f
C417 a_18795_949# VDD 0.15406f
C418 DELAY_OUT_TAP28 DELAY_OUT_TAP29 0.06596f
C419 a_9675_949# a_7390_949# 0.39036f
C420 a_27124_913# DELAY_OUT_TAP30 0.02312f
C421 a_21625_949# DELAY_OUT_TAP23 0.2079f
C422 DELAY_OUT_TAP5 DELAY_OUT_TAP6 0.02068f
C423 a_16108_194# DELAY_OUT_TAP24 0.0157f
C424 DELAY_OUT_TAP29 a_26185_949# 0.19203f
C425 VDD DELAY_OUT_TAP24 0.14794f
C426 a_12505_949# a_10430_949# 0.03208f
C427 a_4324_913# DELAY_OUT_TAP1 0.0501f
C428 a_4350_949# a_4324_913# 0.277f
C429 a_12505_949# a_12791_913# 0.01885f
C430 MUX_SEL4 a_4157_1218# 0.08229f
C431 a_16510_949# DELAY_OUT_TAP19 0.05189f
C432 a_4324_913# VDD 0.28597f
C433 a_13470_949# a_13444_913# 0.277f
C434 a_7364_913# a_7288_949# 0.01176f
C435 a_22564_913# VDD 0.28633f
C436 a_23945_424# a_22590_949# 0.02165f
C437 a_7390_949# a_7288_949# 0.37183f
C438 a_15964_194# DELAY_OUT_TAP16 0.02f
C439 a_8155_949# a_8231_913# 0.01194f
C440 a_10985_949# a_10430_949# 0.03209f
C441 DELAY_OUT_TAP8 a_10404_913# 0.02011f
C442 MUX_OUT a_2297_236# 0.01179f
C443 a_13444_913# a_13368_949# 0.01176f
C444 a_20968_949# a_21044_913# 0.01176f
C445 DELAY_OUT_TAP2 DELAY_OUT_TAP1 0.02068f
C446 VDD a_21044_913# 0.28225f
C447 DELAY_OUT_TAP28 a_25528_949# 0.10864f
C448 a_19448_949# a_19524_913# 0.01176f
C449 a_18871_913# a_16510_949# 0.26208f
C450 a_1544_194# a_2019_216# 0.01747f
C451 DELAY_OUT_TAP2 a_4350_949# 0.07996f
C452 DELAY_OUT_TAP27 a_24665_949# 0.2079f
C453 a_13470_949# a_13368_949# 0.37183f
C454 a_10430_949# DELAY_OUT_TAP12 0.02437f
C455 a_24008_949# VDD 0.17499f
C456 a_26471_913# DELAY_OUT_TAP30 0.02334f
C457 MUX_SEL4 a_4350_949# 0.31434f
C458 a_19448_949# a_19550_949# 0.37183f
C459 DELAY_OUT_TAP2 VDD 0.13878f
C460 a_26395_949# a_26185_949# 0.09424f
C461 MUX_SEL4 a_16108_194# 0.1283f
C462 a_22590_949# a_24084_913# 0.28279f
C463 a_8155_949# a_7390_949# 0.39037f
C464 a_23431_913# VDD 0.28336f
C465 MUX_SEL4 VDD 2.63157f
C466 a_14311_913# a_13470_949# 0.28268f
C467 DELAY_OUT_TAP12 a_12791_913# 0.02339f
C468 a_17065_949# VDD 0.30142f
C469 DELAY_OUT_TAP22 DELAY_OUT_TAP23 0.03717f
C470 a_25630_949# DELAY_OUT_TAP30 0.07996f
C471 a_2297_236# MUX_SEL3 0.01595f
C472 DELAY_OUT_TAP14 a_14888_949# 0.10863f
C473 DELAY_OUT_TAP0 MUX_SEL4 0.06593f
C474 a_22488_949# VDD 0.17274f
C475 a_1544_194# a_1721_236# 0.36963f
C476 a_1256_194# a_2297_236# 0.04261f
C477 a_2019_216# a_1721_236# 0.18452f
C478 a_15765_368# a_2019_216# 0.05969f
C479 a_8808_949# VDD 0.17499f
C480 a_6425_949# a_6711_913# 0.01885f
C481 a_8884_913# DELAY_OUT_TAP7 0.02053f
C482 a_10985_949# a_11271_913# 0.01885f
C483 a_4157_1218# DELAY_OUT_TAP1 0.01771f
C484 a_18004_913# VDD 0.28225f
C485 DELAY_OUT_TAP17 DELAY_OUT_TAP18 0.02068f
C486 DELAY_OUT_TAP29 DELAY_OUT_TAP30 0.02068f
C487 a_4350_949# a_4157_1218# 0.04624f
C488 a_27048_949# DELAY_OUT_TAP30 0.10863f
C489 a_17351_913# a_17275_949# 0.01194f
C490 DELAY_OUT_TAP5 a_7364_913# 0.0501f
C491 a_4157_1218# VDD 0.48906f
C492 MUX_OUT a_1544_194# 0.69943f
C493 a_17928_949# a_16510_949# 0.38994f
C494 DELAY_OUT_TAP9 VDD 0.13651f
C495 MUX_OUT a_2019_216# 8.45486f
C496 a_4248_949# a_4324_913# 0.01176f
C497 DELAY_OUT_TAP5 a_7390_949# 0.10838f
C498 a_10985_949# a_11195_949# 0.09424f
C499 a_3449_1300# VDD 0.46654f
C500 DELAY_OUT_TAP0 a_4157_1218# 0.50642f
C501 a_16510_949# DELAY_OUT_TAP18 0.07996f
C502 a_17351_913# a_16510_949# 0.28268f
C503 a_20905_424# a_19550_949# 0.02165f
C504 MUX_SEL4 DELAY_OUT_TAP8 0.01829f
C505 a_23145_949# DELAY_OUT_TAP25 0.19203f
C506 a_4350_949# DELAY_OUT_TAP1 0.10838f
C507 DELAY_OUT_TAP0 a_3449_1300# 0.01044f
C508 a_20105_949# a_20391_913# 0.01885f
C509 VDD a_24875_949# 0.15406f
C510 DELAY_OUT_TAP14 DELAY_OUT_TAP13 0.02068f
C511 VDD DELAY_OUT_TAP1 0.13941f
C512 a_24008_949# a_24084_913# 0.01176f
C513 a_2297_1300# VDD 0.4651f
C514 a_4350_949# VDD 0.87635f
C515 a_21911_913# a_21625_949# 0.01885f
C516 a_16108_194# VDD 1.25759f
C517 VDD a_14964_913# 0.28225f
C518 a_1544_194# MUX_SEL3 0.15976f
C519 VDD a_20968_949# 0.17499f
C520 a_2019_216# MUX_SEL3 0.06209f
C521 DELAY_OUT_TAP28 a_24951_913# 0.02339f
C522 a_1721_1300# VDD 0.45305f
C523 a_1256_194# a_1544_194# 1.25711f
C524 a_6635_949# a_6711_913# 0.01194f
C525 a_1256_194# a_2019_216# 0.02904f
C526 DELAY_OUT_TAP0 DELAY_OUT_TAP1 0.04252f
C527 MUX_SEL4 MUX_SEL1 0.03574f
C528 a_5705_424# a_2019_216# 0.13872f
C529 a_23355_949# a_23145_949# 0.09424f
C530 a_16108_194# a_17865_424# 0.29564f
C531 a_21835_949# a_21625_949# 0.09424f
C532 a_17865_424# VDD 0.29444f
C533 MUX_SEL4 a_15964_194# 0.5544f
C534 MUX_SEL4 a_1544_949# 0.03407f
C535 a_16108_194# a_16851_214# 0.06181f
C536 DELAY_OUT_TAP11 a_10430_949# 0.05189f
C537 DELAY_OUT_TAP0 VDD 0.50967f
C538 DELAY_OUT_TAP21 a_19524_913# 0.0501f
C539 a_16510_949# DELAY_OUT_TAP20 0.02437f
C540 a_14235_949# a_13470_949# 0.39037f
C541 a_16851_214# VDD 0.51536f
C542 a_18871_913# a_18795_949# 0.01194f
C543 MUX_SEL4 a_5731_194# 4.60702f
C544 DELAY_OUT_TAP8 DELAY_OUT_TAP9 0.06596f
C545 a_12715_949# VDD 0.15406f
C546 a_15545_949# VDD 0.29842f
C547 a_14825_424# a_13470_949# 0.02058f
C548 DELAY_OUT_TAP21 a_19550_949# 0.10838f
C549 a_2297_236# MUX_SEL2 0.10655f
C550 DELAY_OUT_TAP10 DELAY_OUT_TAP11 0.03717f
C551 a_1256_194# a_1721_236# 0.13421f
C552 a_8884_913# DELAY_OUT_TAP6 0.02312f
C553 a_3449_1300# MUX_SEL0 0.10753f
C554 a_16108_194# a_23945_424# 0.2906f
C555 a_4248_949# a_4157_1218# 0.11672f
C556 a_22590_949# DELAY_OUT_TAP27 0.05189f
C557 a_15831_913# VDD 0.2816f
C558 a_23945_424# VDD 0.29292f
C559 a_1256_949# MUX_OUT 0.02466f
C560 a_3449_1300# MUX_SEL1 0.29404f
C561 a_16510_949# a_18585_949# 0.03208f
C562 DELAY_OUT_TAP30 DELAY_OUT_TAP31 0.03717f
C563 DELAY_OUT_TAP4 a_7364_913# 0.02011f
C564 a_10430_949# a_11785_424# 0.02058f
C565 MUX_OUT MUX_SEL3 0.79533f
C566 a_14235_949# a_14311_913# 0.01194f
C567 a_23145_949# a_22590_949# 0.03209f
C568 a_15755_949# VDD 0.15389f
C569 a_4905_949# a_5191_913# 0.01885f
C570 MUX_OUT a_1256_194# 0.1134f
C571 DELAY_OUT_TAP8 VDD 0.1474f
C572 a_16510_949# a_2019_216# 0.03139f
C573 a_2297_1300# MUX_SEL0 0.10655f
C574 DELAY_OUT_TAP25 DELAY_OUT_TAP26 0.02068f
C575 a_20391_913# DELAY_OUT_TAP22 0.02334f
C576 DELAY_OUT_TAP15 a_13470_949# 0.05189f
C577 a_15831_913# a_15545_949# 0.01885f
R0 VSS.n20 VSS.n26 3664.01
R1 VSS.t269 VSS.n26 122.415
R2 VSS.t286 VSS.n26 68.654
R3 VSS.t64 VSS.n26 22.5629
R4 VSS.n26 VSS.n37 0.481869
R5 VSS.n26 VSS.t66 22.4812
R6 VSS.n73 VSS.n26 0.456674
R7 VSS.n26 VSS.t351 58.1759
R8 VSS.t336 VSS.n26 58.1721
R9 VSS.t321 VSS.n26 58.1721
R10 VSS.n26 VSS.t309 116.828
R11 VSS.t291 VSS.n26 58.1721
R12 VSS.t276 VSS.n26 58.1721
R13 VSS.t41 VSS.n38 499.695
R14 VSS.n26 VSS.t63 58.0914
R15 VSS.t184 VSS.n5 15.3031
R16 VSS.t271 VSS.n26 68.6471
R17 VSS.t301 VSS.n26 68.6471
R18 VSS.t316 VSS.n26 68.6481
R19 VSS.t331 VSS.n26 68.6471
R20 VSS.t346 VSS.n26 68.6471
R21 VSS.t18 VSS.n56 71.035
R22 VSS.n32 VSS.n20 0.552982
R23 VSS.n111 VSS.t121 436.62
R24 VSS.n31 VSS.t185 430.062
R25 VSS.n33 VSS.t223 418.382
R26 VSS.n36 VSS.t159 68.5978
R27 VSS.t212 VSS.n0 68.5978
R28 VSS.t198 VSS.n20 68.5978
R29 VSS.t192 VSS.n2 68.5978
R30 VSS.n35 VSS.n20 0.382621
R31 VSS.n34 VSS.n20 0.382621
R32 VSS.t20 VSS.n29 68.5978
R33 VSS.n57 VSS.t120 417.714
R34 VSS.t38 VSS.n26 116.822
R35 VSS.t294 VSS.n26 116.828
R36 VSS.t324 VSS.n26 116.828
R37 VSS.n20 VSS.n54 0.481029
R38 VSS.n59 VSS.t202 62.2552
R39 VSS.t266 VSS.n26 127.299
R40 VSS.t204 VSS.n203 375
R41 VSS.n26 VSS.t284 122.412
R42 VSS.n26 VSS.t299 122.412
R43 VSS.n26 VSS.t314 122.412
R44 VSS.n26 VSS.t329 122.412
R45 VSS.n26 VSS.t344 122.412
R46 VSS.t22 VSS.n104 366.197
R47 VSS.t281 VSS.n26 127.3
R48 VSS.n26 VSS.t296 127.3
R49 VSS.n26 VSS.t311 127.3
R50 VSS.t326 VSS.n26 127.3
R51 VSS.n26 VSS.t341 127.3
R52 VSS.n20 VSS.n62 0.423468
R53 VSS.n20 VSS.n67 0.423468
R54 VSS.n20 VSS.n61 0.423468
R55 VSS.n16 VSS.t217 98.6395
R56 VSS.n15 VSS.t214 98.6395
R57 VSS.n14 VSS.t191 98.6395
R58 VSS.n13 VSS.t226 98.6395
R59 VSS.n20 VSS.n68 0.423468
R60 VSS.n11 VSS.t258 98.6395
R61 VSS.n20 VSS.n69 0.423468
R62 VSS.n20 VSS.n58 0.423468
R63 VSS.n20 VSS.n70 0.423468
R64 VSS.n20 VSS.n55 0.423468
R65 VSS.n8 VSS.t229 98.6395
R66 VSS.n7 VSS.t88 98.6395
R67 VSS.n6 VSS.t12 98.6395
R68 VSS.t44 VSS.n26 140.651
R69 VSS.n26 VSS.t136 140.651
R70 VSS.t95 VSS.n26 133.32
R71 VSS.t46 VSS.n26 133.32
R72 VSS.t168 VSS.n26 133.319
R73 VSS.n26 VSS.t56 140.651
R74 VSS.t176 VSS.n26 133.32
R75 VSS.t123 VSS.n104 352.113
R76 VSS.t205 VSS.n60 359.983
R77 VSS.n20 VSS.t256 101.647
R78 VSS.n20 VSS.t27 101.647
R79 VSS.n20 VSS.t127 101.647
R80 VSS.n20 VSS.t7 101.647
R81 VSS.n20 VSS.t80 101.647
R82 VSS.n20 VSS.t36 101.647
R83 VSS.n20 VSS.t53 101.647
R84 VSS.n20 VSS.t133 101.647
R85 VSS.t149 VSS.n66 348.303
R86 VSS.t157 VSS.n52 348.303
R87 VSS.t231 VSS.n51 348.303
R88 VSS.t161 VSS.n40 348.303
R89 VSS.t103 VSS.n50 348.303
R90 VSS.t124 VSS.n41 348.303
R91 VSS.t154 VSS.n42 348.303
R92 VSS.t153 VSS.n48 348.303
R93 VSS.t167 VSS.n45 348.303
R94 VSS.t356 VSS.n47 348.303
R95 VSS.t156 VSS.n30 348.303
R96 VSS.t105 VSS.n39 111.644
R97 VSS.n20 VSS.t30 108.561
R98 VSS.n20 VSS.t241 108.561
R99 VSS.n20 VSS.t139 108.561
R100 VSS.n40 VSS.n20 6.82258
R101 VSS.n20 VSS.t101 108.561
R102 VSS.n20 VSS.t10 108.561
R103 VSS.n41 VSS.n20 6.82258
R104 VSS.n42 VSS.n20 6.82258
R105 VSS.t108 VSS.n43 111.644
R106 VSS.t58 VSS.n44 111.644
R107 VSS.n20 VSS.t1 108.561
R108 VSS.n45 VSS.n20 6.82258
R109 VSS.n20 VSS.t244 108.561
R110 VSS.n20 VSS.t142 108.561
R111 VSS.n20 VSS.t4 108.49
R112 VSS.n38 VSS.t239 129.317
R113 VSS.t246 VSS.n72 404.05
R114 VSS.t171 VSS.n63 404.05
R115 VSS.n204 VSS.t208 314.517
R116 VSS.n26 VSS.t47 140.651
R117 VSS.n26 VSS.t177 140.651
R118 VSS.n26 VSS.t96 140.651
R119 VSS.n65 VSS.t118 131.472
R120 VSS.n57 VSS.t238 131.77
R121 VSS.n204 VSS.t260 302.42
R122 VSS.t197 VSS.n31 110.901
R123 VSS.n111 VSS.t16 281.69
R124 VSS.t151 VSS.n66 111.647
R125 VSS.n39 VSS.t147 348.303
R126 VSS.t29 VSS.n52 111.644
R127 VSS.n53 VSS.t232 348.303
R128 VSS.t138 VSS.n51 111.644
R129 VSS.t73 VSS.n40 111.644
R130 VSS.t100 VSS.n50 111.644
R131 VSS.n49 VSS.t165 348.303
R132 VSS.t70 VSS.n41 111.644
R133 VSS.t49 VSS.n42 111.644
R134 VSS.n43 VSS.t163 348.303
R135 VSS.n44 VSS.t114 348.303
R136 VSS.t0 VSS.n48 111.644
R137 VSS.t249 VSS.n45 111.644
R138 VSS.t243 VSS.n47 111.644
R139 VSS.n46 VSS.t14 348.303
R140 VSS.t3 VSS.n30 111.639
R141 VSS.n26 VSS.t274 141.964
R142 VSS.n26 VSS.t289 141.964
R143 VSS.n26 VSS.t304 141.964
R144 VSS.n26 VSS.t319 141.964
R145 VSS.n26 VSS.t334 141.964
R146 VSS.n26 VSS.t349 141.964
R147 VSS.n26 VSS.t236 141.702
R148 VSS.n33 VSS.n20 9.3247
R149 VSS.n60 VSS.t196 113.322
R150 VSS.t169 VSS.n26 140.653
R151 VSS.n26 VSS.t112 140.653
R152 VSS.t16 VSS.n56 267.416
R153 VSS.t200 VSS.n203 241.935
R154 VSS.n57 VSS.n26 7.23036
R155 VSS.t194 VSS.n20 122.856
R156 VSS.n65 VSS.t116 486.031
R157 VSS.n26 VSS.t93 137.776
R158 VSS.t173 VSS.n63 129.738
R159 VSS.t247 VSS.n72 129.738
R160 VSS.n59 VSS.t200 231.506
R161 VSS.t43 VSS.n26 133.32
R162 VSS.n26 VSS.t55 133.32
R163 VSS.n26 VSS.t135 133.32
R164 VSS.t111 VSS.n26 133.319
R165 VSS.n60 VSS.n20 7.23977
R166 VSS.n33 VSS.t224 112.787
R167 VSS.n20 VSS.n66 6.82269
R168 VSS.n20 VSS.n30 6.82228
R169 VSS.n64 VSS.t123 199.099
R170 VSS.t354 VSS.n26 116.826
R171 VSS.n26 VSS.t339 116.828
R172 VSS.n26 VSS.t279 116.828
R173 VSS.t106 VSS.n20 108.561
R174 VSS.t74 VSS.n20 108.561
R175 VSS.t71 VSS.n20 108.561
R176 VSS.t50 VSS.n20 108.561
R177 VSS.t109 VSS.n20 108.561
R178 VSS.t59 VSS.n20 108.561
R179 VSS.t250 VSS.n20 108.561
R180 VSS.t208 VSS.n32 161.025
R181 VSS.t246 VSS.n24 156.831
R182 VSS.t171 VSS.n73 156.883
R183 VSS.n20 VSS.t182 101.656
R184 VSS.n20 VSS.n36 0.382621
R185 VSS.n18 VSS.t26 83.4525
R186 VSS.n17 VSS.t126 83.4525
R187 VSS.t83 VSS.n20 101.647
R188 VSS.t130 VSS.n20 101.647
R189 VSS.t77 VSS.n20 101.647
R190 VSS.n35 VSS.t79 83.4525
R191 VSS.n12 VSS.t35 83.4525
R192 VSS.t68 VSS.n20 101.647
R193 VSS.n34 VSS.t52 83.4525
R194 VSS.t145 VSS.n20 101.647
R195 VSS.n9 VSS.t132 83.4525
R196 VSS.t253 VSS.n20 101.647
R197 VSS.t86 VSS.n20 101.647
R198 VSS.t33 VSS.n20 101.647
R199 VSS.t120 VSS.n22 142.746
R200 VSS.n19 VSS.t149 136.798
R201 VSS.t188 VSS.n62 98.6395
R202 VSS.t181 VSS.n67 98.6395
R203 VSS.t261 VSS.n61 98.6395
R204 VSS.n16 VSS.t231 136.962
R205 VSS.n15 VSS.t161 136.962
R206 VSS.n14 VSS.t103 136.962
R207 VSS.n13 VSS.t165 136.962
R208 VSS.t227 VSS.n68 98.6395
R209 VSS.n11 VSS.t154 136.962
R210 VSS.t207 VSS.n69 98.6395
R211 VSS.t228 VSS.n58 98.6395
R212 VSS.t91 VSS.n70 98.6395
R213 VSS.t89 VSS.n55 98.6395
R214 VSS.n8 VSS.t356 136.962
R215 VSS.n7 VSS.t14 136.962
R216 VSS.n6 VSS.t156 136.962
R217 VSS.n4 VSS.t205 124.701
R218 VSS.t121 VSS.n23 114.668
R219 VSS.t259 VSS.n54 72.4354
R220 VSS.n26 VSS.n56 2.59912
R221 VSS.n36 VSS.t255 83.4525
R222 VSS.n18 VSS.t189 68.5978
R223 VSS.n17 VSS.t186 68.5978
R224 VSS.t82 VSS.n0 83.4525
R225 VSS.n1 VSS.t215 68.5978
R226 VSS.t6 VSS.n20 83.4525
R227 VSS.t76 VSS.n2 83.4525
R228 VSS.n35 VSS.t264 68.5978
R229 VSS.n12 VSS.t219 68.5978
R230 VSS.n10 VSS.t221 68.5978
R231 VSS.n34 VSS.t262 68.5978
R232 VSS.t144 VSS.n29 83.4525
R233 VSS.n9 VSS.t61 68.5978
R234 VSS.n20 VSS.t98 68.5978
R235 VSS.n3 VSS.t234 68.5978
R236 VSS.n20 VSS.t179 68.5978
R237 VSS.n59 VSS.n20 2.65215
R238 VSS.n22 VSS.t116 72.3236
R239 VSS.n26 VSS.t306 58.1721
R240 VSS.t223 VSS.n4 64.2173
R241 VSS.n24 VSS.t41 58.2391
R242 VSS.n73 VSS.t175 52.2182
R243 VSS.t185 VSS.n19 52.1205
R244 VSS.t24 VSS.n37 28.4523
R245 VSS.n32 VSS.t210 26.3107
R246 VSS.n112 VSS.t17 17.3368
R247 VSS.n115 VSS.t117 17.3368
R248 VSS.n105 VSS.t23 17.3368
R249 VSS.n119 VSS.t42 17.3368
R250 VSS.n221 VSS.t150 17.3368
R251 VSS.n217 VSS.t209 17.3368
R252 VSS.n213 VSS.t206 17.3368
R253 VSS.n209 VSS.t201 17.3368
R254 VSS.n162 VSS.t172 17.2607
R255 VSS.n123 VSS.t267 17.2313
R256 VSS.n402 VSS.t273 17.2313
R257 VSS.n130 VSS.t278 17.2313
R258 VSS.n395 VSS.t283 17.2313
R259 VSS.n390 VSS.t288 17.2313
R260 VSS.n140 VSS.t293 17.2313
R261 VSS.n149 VSS.t298 17.2313
R262 VSS.n383 VSS.t303 17.2313
R263 VSS.n84 VSS.t308 17.2313
R264 VSS.n170 VSS.t313 17.2313
R265 VSS.n376 VSS.t318 17.2313
R266 VSS.n89 VSS.t323 17.2313
R267 VSS.n369 VSS.t328 17.2313
R268 VSS.n364 VSS.t333 17.2313
R269 VSS.n94 VSS.t338 17.2313
R270 VSS.n193 VSS.t343 17.2313
R271 VSS.n357 VSS.t348 17.2313
R272 VSS.n99 VSS.t353 17.2313
R273 VSS.n26 VSS.n72 6.80937
R274 VSS.n26 VSS.n38 9.75628
R275 VSS.n26 VSS.n104 17.0005
R276 VSS.n26 VSS.n64 0.494014
R277 VSS.n26 VSS.n65 9.33546
R278 VSS.n26 VSS.n111 17.0005
R279 VSS.n407 VSS.n26 17.0005
R280 VSS.n405 VSS.t268 17.0005
R281 VSS.n26 VSS.n97 5.65652
R282 VSS.n26 VSS.n92 5.65652
R283 VSS.n26 VSS.n87 5.65652
R284 VSS.n26 VSS.n63 6.8094
R285 VSS.n26 VSS.n82 5.65652
R286 VSS.n26 VSS.n78 5.65652
R287 VSS.n26 VSS.n74 5.65652
R288 VSS.n125 VSS.t270 17.0005
R289 VSS.n403 VSS.t272 17.0005
R290 VSS.n127 VSS.t275 17.0005
R291 VSS.n128 VSS.t277 17.0005
R292 VSS.n132 VSS.t280 17.0005
R293 VSS.n396 VSS.t282 17.0005
R294 VSS.n136 VSS.t285 17.0005
R295 VSS.n391 VSS.t287 17.0005
R296 VSS.n137 VSS.t290 17.0005
R297 VSS.n138 VSS.t292 17.0005
R298 VSS.n142 VSS.t295 17.0005
R299 VSS.n147 VSS.t297 17.0005
R300 VSS.n150 VSS.t300 17.0005
R301 VSS.n384 VSS.t302 17.0005
R302 VSS.n152 VSS.t305 17.0005
R303 VSS.n153 VSS.t307 17.0005
R304 VSS.n157 VSS.t310 17.0005
R305 VSS.n168 VSS.t312 17.0005
R306 VSS.n171 VSS.t315 17.0005
R307 VSS.n377 VSS.t317 17.0005
R308 VSS.n173 VSS.t320 17.0005
R309 VSS.n174 VSS.t322 17.0005
R310 VSS.n177 VSS.t325 17.0005
R311 VSS.n370 VSS.t327 17.0005
R312 VSS.n181 VSS.t330 17.0005
R313 VSS.n365 VSS.t332 17.0005
R314 VSS.n182 VSS.t335 17.0005
R315 VSS.n183 VSS.t337 17.0005
R316 VSS.n186 VSS.t340 17.0005
R317 VSS.n191 VSS.t342 17.0005
R318 VSS.n194 VSS.t345 17.0005
R319 VSS.n358 VSS.t347 17.0005
R320 VSS.n196 VSS.t350 17.0005
R321 VSS.n197 VSS.t352 17.0005
R322 VSS.n199 VSS.t355 17.0005
R323 VSS.n20 VSS.n71 17.0005
R324 VSS.n20 VSS.n203 17.0005
R325 VSS.n20 VSS.n204 17.0005
R326 VSS.n20 VSS.n31 9.74178
R327 VSS.n20 VSS.n39 6.82258
R328 VSS.n20 VSS.n53 6.82258
R329 VSS.n20 VSS.n49 6.82258
R330 VSS.n20 VSS.n43 6.82258
R331 VSS.n20 VSS.n44 6.82258
R332 VSS.n20 VSS.n46 6.82258
R333 VSS.t40 VSS.n64 15.5226
R334 VSS.t260 VSS.n5 173.107
R335 VSS.n125 VSS.t391 15.3099
R336 VSS.n127 VSS.t389 15.3099
R337 VSS.n132 VSS.t387 15.3099
R338 VSS.n136 VSS.t385 15.3099
R339 VSS.n137 VSS.t383 15.3099
R340 VSS.n142 VSS.t381 15.3099
R341 VSS.n150 VSS.t379 15.3099
R342 VSS.n152 VSS.t377 15.3099
R343 VSS.n157 VSS.t375 15.3099
R344 VSS.n171 VSS.t373 15.3099
R345 VSS.n173 VSS.t371 15.3099
R346 VSS.n177 VSS.t369 15.3099
R347 VSS.n181 VSS.t367 15.3099
R348 VSS.n182 VSS.t365 15.3099
R349 VSS.n186 VSS.t363 15.3099
R350 VSS.n194 VSS.t361 15.3099
R351 VSS.n196 VSS.t359 15.3099
R352 VSS.n199 VSS.t357 15.3099
R353 VSS.n405 VSS.t392 15.2696
R354 VSS.n403 VSS.t390 15.2696
R355 VSS.n128 VSS.t388 15.2696
R356 VSS.n396 VSS.t386 15.2696
R357 VSS.n391 VSS.t384 15.2696
R358 VSS.n138 VSS.t382 15.2696
R359 VSS.n147 VSS.t380 15.2696
R360 VSS.n384 VSS.t378 15.2696
R361 VSS.n153 VSS.t376 15.2696
R362 VSS.n168 VSS.t374 15.2696
R363 VSS.n377 VSS.t372 15.2696
R364 VSS.n174 VSS.t370 15.2696
R365 VSS.n370 VSS.t368 15.2696
R366 VSS.n365 VSS.t366 15.2696
R367 VSS.n183 VSS.t364 15.2696
R368 VSS.n191 VSS.t362 15.2696
R369 VSS.n358 VSS.t360 15.2696
R370 VSS.n197 VSS.t358 15.2696
R371 VSS.n223 VSS.t152 8.80385
R372 VSS.n219 VSS.t211 8.80385
R373 VSS.n215 VSS.t225 8.80385
R374 VSS.n211 VSS.t203 8.80385
R375 VSS.n113 VSS.t19 8.80285
R376 VSS.n116 VSS.t119 8.80285
R377 VSS.n118 VSS.t25 8.80285
R378 VSS.n121 VSS.t248 8.80285
R379 VSS.n351 VSS.t5 8.77423
R380 VSS.n349 VSS.t13 8.77423
R381 VSS.n347 VSS.t34 8.77423
R382 VSS.n345 VSS.t180 8.77423
R383 VSS.n343 VSS.t143 8.77423
R384 VSS.n341 VSS.t15 8.77423
R385 VSS.n339 VSS.t87 8.77423
R386 VSS.n337 VSS.t235 8.77423
R387 VSS.n335 VSS.t245 8.77423
R388 VSS.n333 VSS.t230 8.77423
R389 VSS.n331 VSS.t254 8.77423
R390 VSS.n329 VSS.t99 8.77423
R391 VSS.n327 VSS.t251 8.77423
R392 VSS.n325 VSS.t90 8.77423
R393 VSS.n323 VSS.t134 8.77423
R394 VSS.n321 VSS.t62 8.77423
R395 VSS.n319 VSS.t2 8.77423
R396 VSS.n317 VSS.t92 8.77423
R397 VSS.n315 VSS.t146 8.77423
R398 VSS.n313 VSS.t21 8.77423
R399 VSS.n311 VSS.t60 8.77423
R400 VSS.n309 VSS.t115 8.77423
R401 VSS.n307 VSS.t54 8.77423
R402 VSS.n305 VSS.t263 8.77423
R403 VSS.n303 VSS.t110 8.77423
R404 VSS.n301 VSS.t164 8.77423
R405 VSS.n299 VSS.t69 8.77423
R406 VSS.n297 VSS.t222 8.77423
R407 VSS.n295 VSS.t51 8.77423
R408 VSS.n293 VSS.t155 8.77423
R409 VSS.n291 VSS.t37 8.77423
R410 VSS.n289 VSS.t220 8.77423
R411 VSS.n287 VSS.t72 8.77423
R412 VSS.n285 VSS.t125 8.77423
R413 VSS.n283 VSS.t81 8.77423
R414 VSS.n281 VSS.t265 8.77423
R415 VSS.n279 VSS.t11 8.77423
R416 VSS.n277 VSS.t166 8.77423
R417 VSS.n275 VSS.t78 8.77423
R418 VSS.n273 VSS.t193 8.77423
R419 VSS.n271 VSS.t102 8.77423
R420 VSS.n269 VSS.t104 8.77423
R421 VSS.n267 VSS.t8 8.77423
R422 VSS.n265 VSS.t199 8.77423
R423 VSS.n263 VSS.t75 8.77423
R424 VSS.n261 VSS.t162 8.77423
R425 VSS.n259 VSS.t131 8.77423
R426 VSS.n257 VSS.t216 8.77423
R427 VSS.n255 VSS.t140 8.77423
R428 VSS.n253 VSS.t218 8.77423
R429 VSS.n251 VSS.t84 8.77423
R430 VSS.n249 VSS.t213 8.77423
R431 VSS.n247 VSS.t242 8.77423
R432 VSS.n245 VSS.t233 8.77423
R433 VSS.n243 VSS.t128 8.77423
R434 VSS.n241 VSS.t187 8.77423
R435 VSS.n239 VSS.t31 8.77423
R436 VSS.n237 VSS.t158 8.77423
R437 VSS.n235 VSS.t28 8.77423
R438 VSS.n233 VSS.t190 8.77423
R439 VSS.n231 VSS.t107 8.77423
R440 VSS.n229 VSS.t148 8.77423
R441 VSS.n227 VSS.t257 8.77423
R442 VSS.n225 VSS.t160 8.77423
R443 VSS.n28 VSS.t45 8.82841
R444 VSS.n134 VSS.t178 8.77323
R445 VSS.n144 VSS.t57 8.77323
R446 VSS.n160 VSS.t170 8.77323
R447 VSS.n161 VSS.t65 8.77323
R448 VSS.n165 VSS.t48 8.77323
R449 VSS.n179 VSS.t97 8.77323
R450 VSS.n188 VSS.t137 8.77323
R451 VSS.n202 VSS.t113 8.77323
R452 VSS.n27 VSS.t94 8.79211
R453 VSS.n164 VSS.t174 8.76678
R454 VSS.n207 VSS.t183 8.75731
R455 VSS.n205 VSS.t195 8.75731
R456 VSS.n101 VSS.t237 8.75631
R457 VSS.n109 VSS.t39 8.75631
R458 VSS.n353 VSS.n100 0.0435295
R459 VSS.n98 VSS.n359 0.0534319
R460 VSS.n195 VSS.n97 0.0180497
R461 VSS.n192 VSS.n96 0.0633111
R462 VSS.n360 VSS.n95 0.0435295
R463 VSS.n93 VSS.n366 0.0534319
R464 VSS.n367 VSS.n92 0.0180497
R465 VSS.n91 VSS.n371 0.0633111
R466 VSS.n372 VSS.n90 0.0435295
R467 VSS.n88 VSS.n378 0.0534319
R468 VSS.n172 VSS.n87 0.0180497
R469 VSS.n169 VSS.n86 0.0633111
R470 VSS.n379 VSS.n85 0.0435295
R471 VSS.n83 VSS.n385 0.0534319
R472 VSS.n151 VSS.n82 0.0180497
R473 VSS.n148 VSS.n81 0.0633111
R474 VSS.n80 VSS.n26 4.22409
R475 VSS.n79 VSS.n392 0.0534319
R476 VSS.n393 VSS.n78 0.0180497
R477 VSS.n77 VSS.n397 0.0633111
R478 VSS.n76 VSS.n26 4.22409
R479 VSS.n75 VSS.n404 0.0534319
R480 VSS.n126 VSS.n74 0.0180497
R481 VSS.n354 VSS.n26 8.49319
R482 VSS.n361 VSS.n26 8.49319
R483 VSS.n373 VSS.n26 8.49319
R484 VSS.n380 VSS.n26 8.49319
R485 VSS.n387 VSS.n26 8.49319
R486 VSS.n399 VSS.n26 8.49319
R487 VSS.n26 VSS.n103 8.47732
R488 VSS.n26 VSS.n100 4.22409
R489 VSS.n98 VSS.n26 4.21914
R490 VSS.n26 VSS.n190 8.47732
R491 VSS.n26 VSS.n96 4.21421
R492 VSS.n26 VSS.n95 4.22409
R493 VSS.n93 VSS.n26 4.21914
R494 VSS.n368 VSS.n26 8.47732
R495 VSS.n91 VSS.n26 4.21421
R496 VSS.n26 VSS.n90 4.22409
R497 VSS.n88 VSS.n26 4.21914
R498 VSS.n26 VSS.n167 8.47732
R499 VSS.n26 VSS.n86 4.21421
R500 VSS.n26 VSS.n85 4.22409
R501 VSS.n83 VSS.n26 4.21914
R502 VSS.n26 VSS.n146 8.47732
R503 VSS.n26 VSS.n81 4.21421
R504 VSS.n80 VSS.n140 0.176279
R505 VSS.n79 VSS.n26 4.21914
R506 VSS.n394 VSS.n26 8.47732
R507 VSS.n77 VSS.n26 4.21421
R508 VSS.n76 VSS.n130 0.176279
R509 VSS.n75 VSS.n26 4.21914
R510 VSS.n26 VSS.n124 8.47732
R511 VSS.n218 VSS.n20 8.47732
R512 VSS.n352 VSS.n20 8.47732
R513 VSS.n26 VSS.n102 5.62581
R514 VSS.n26 VSS.n117 5.62581
R515 VSS.n26 VSS.n114 5.62581
R516 VSS.n26 VSS.n201 5.62581
R517 VSS.n356 VSS.n26 5.62581
R518 VSS.n26 VSS.n185 5.62581
R519 VSS.n363 VSS.n26 5.62581
R520 VSS.n26 VSS.n176 5.62581
R521 VSS.n375 VSS.n26 5.62581
R522 VSS.n26 VSS.n155 5.62581
R523 VSS.n26 VSS.n156 5.62581
R524 VSS.n382 VSS.n26 5.62581
R525 VSS.n26 VSS.n141 5.62581
R526 VSS.n389 VSS.n26 5.62581
R527 VSS.n26 VSS.n131 5.62581
R528 VSS.n401 VSS.n26 5.62581
R529 VSS.n210 VSS.n20 5.62581
R530 VSS.n214 VSS.n20 5.62581
R531 VSS.n222 VSS.n20 5.62581
R532 VSS.n232 VSS.n20 5.62581
R533 VSS.n240 VSS.n20 5.62581
R534 VSS.n248 VSS.n20 5.62581
R535 VSS.n256 VSS.n20 5.62581
R536 VSS.n264 VSS.n20 5.62581
R537 VSS.n272 VSS.n20 5.62581
R538 VSS.n280 VSS.n20 5.62581
R539 VSS.n288 VSS.n20 5.62581
R540 VSS.n296 VSS.n20 5.62581
R541 VSS.n304 VSS.n20 5.62581
R542 VSS.n312 VSS.n20 5.62581
R543 VSS.n320 VSS.n20 5.62581
R544 VSS.n328 VSS.n20 5.62581
R545 VSS.n336 VSS.n20 5.62581
R546 VSS.n344 VSS.n20 5.62581
R547 VSS.n26 VSS.n122 4.21408
R548 VSS.n26 VSS.n110 4.19244
R549 VSS.n206 VSS.n20 4.19244
R550 VSS.n224 VSS.n20 4.19244
R551 VSS.n25 VSS.n352 3.33613
R552 VSS.n26 VSS.n28 0.665344
R553 VSS.n26 VSS.n120 3.3265
R554 VSS.n26 VSS.n106 3.3265
R555 VSS.n26 VSS.n107 3.3265
R556 VSS.n26 VSS.n184 3.3265
R557 VSS.n26 VSS.n175 3.3265
R558 VSS.n26 VSS.n154 3.3265
R559 VSS.n26 VSS.n139 3.3265
R560 VSS.n26 VSS.n129 3.3265
R561 VSS.n212 VSS.n20 3.3265
R562 VSS.n216 VSS.n20 3.3265
R563 VSS.n220 VSS.n20 3.3265
R564 VSS.n226 VSS.n20 3.3265
R565 VSS.n234 VSS.n20 3.3265
R566 VSS.n242 VSS.n20 3.3265
R567 VSS.n250 VSS.n20 3.3265
R568 VSS.n258 VSS.n20 3.3265
R569 VSS.n266 VSS.n20 3.3265
R570 VSS.n274 VSS.n20 3.3265
R571 VSS.n282 VSS.n20 3.3265
R572 VSS.n290 VSS.n20 3.3265
R573 VSS.n298 VSS.n20 3.3265
R574 VSS.n306 VSS.n20 3.3265
R575 VSS.n314 VSS.n20 3.3265
R576 VSS.n322 VSS.n20 3.3265
R577 VSS.n330 VSS.n20 3.3265
R578 VSS.n338 VSS.n20 3.3265
R579 VSS.n346 VSS.n20 3.3265
R580 VSS.n26 VSS.n108 2.74446
R581 VSS.n208 VSS.n20 2.74446
R582 VSS.n228 VSS.n20 2.74446
R583 VSS.n230 VSS.n20 2.74446
R584 VSS.n236 VSS.n20 2.74446
R585 VSS.n238 VSS.n20 2.74446
R586 VSS.n244 VSS.n20 2.74446
R587 VSS.n246 VSS.n20 2.74446
R588 VSS.n252 VSS.n20 2.74446
R589 VSS.n254 VSS.n20 2.74446
R590 VSS.n260 VSS.n20 2.74446
R591 VSS.n262 VSS.n20 2.74446
R592 VSS.n268 VSS.n20 2.74446
R593 VSS.n270 VSS.n20 2.74446
R594 VSS.n276 VSS.n20 2.74446
R595 VSS.n278 VSS.n20 2.74446
R596 VSS.n284 VSS.n20 2.74446
R597 VSS.n286 VSS.n20 2.74446
R598 VSS.n292 VSS.n20 2.74446
R599 VSS.n294 VSS.n20 2.74446
R600 VSS.n300 VSS.n20 2.74446
R601 VSS.n302 VSS.n20 2.74446
R602 VSS.n308 VSS.n20 2.74446
R603 VSS.n310 VSS.n20 2.74446
R604 VSS.n316 VSS.n20 2.74446
R605 VSS.n318 VSS.n20 2.74446
R606 VSS.n324 VSS.n20 2.74446
R607 VSS.n326 VSS.n20 2.74446
R608 VSS.n332 VSS.n20 2.74446
R609 VSS.n334 VSS.n20 2.74446
R610 VSS.n340 VSS.n20 2.74446
R611 VSS.n342 VSS.n20 2.74446
R612 VSS.n348 VSS.n20 2.74446
R613 VSS.n350 VSS.n20 2.74446
R614 VSS.n26 VSS.n163 2.00687
R615 VSS.n26 VSS.n198 1.56144
R616 VSS.n26 VSS.n189 1.56144
R617 VSS.n26 VSS.n180 1.56144
R618 VSS.n26 VSS.n159 1.56144
R619 VSS.n26 VSS.n145 1.56144
R620 VSS.n26 VSS.n135 1.56144
R621 VSS.n26 VSS.n166 1.12565
R622 VSS.n26 VSS.n25 0.92982
R623 VSS.n27 VSS.n26 0.761893
R624 VSS.n26 VSS.n21 0.849178
R625 VSS.n21 VSS.n160 0.728316
R626 VSS.n161 VSS.n21 0.69965
R627 VSS.n25 VSS.n202 0.69304
R628 VSS.n166 VSS.n164 0.603496
R629 VSS.n54 VSS.t204 100.614
R630 VSS.n20 VSS.n4 0.586403
R631 VSS.n20 VSS.n5 0.567373
R632 VSS.n20 VSS.n19 0.586403
R633 VSS.n62 VSS.t147 136.962
R634 VSS.n20 VSS.n18 0.382621
R635 VSS.n67 VSS.t157 136.962
R636 VSS.n20 VSS.n17 0.382621
R637 VSS.n61 VSS.t232 136.962
R638 VSS.n20 VSS.n16 0.423468
R639 VSS.n1 VSS.t129 83.4525
R640 VSS.n20 VSS.n15 0.423468
R641 VSS.n20 VSS.n14 0.423468
R642 VSS.n20 VSS.n13 0.423468
R643 VSS.n68 VSS.t124 136.962
R644 VSS.n20 VSS.n12 0.382621
R645 VSS.n20 VSS.n11 0.423468
R646 VSS.n20 VSS.n10 0.382621
R647 VSS.n69 VSS.t163 136.962
R648 VSS.n58 VSS.t114 136.962
R649 VSS.n70 VSS.t153 136.962
R650 VSS.n20 VSS.n9 0.382621
R651 VSS.n55 VSS.t167 136.962
R652 VSS.n20 VSS.t252 83.4525
R653 VSS.n20 VSS.n8 0.423468
R654 VSS.n3 VSS.t85 83.4525
R655 VSS.n20 VSS.n7 0.423468
R656 VSS.n20 VSS.t32 83.4525
R657 VSS.n20 VSS.n6 0.423468
R658 VSS.n166 VSS.n165 0.540438
R659 VSS.n26 VSS.n24 0.50872
R660 VSS.n37 VSS.t22 185.028
R661 VSS.n26 VSS.n22 0.50872
R662 VSS.n135 VSS.n134 0.413418
R663 VSS.n145 VSS.n144 0.413418
R664 VSS.n160 VSS.n159 0.413418
R665 VSS.n180 VSS.n179 0.413418
R666 VSS.n189 VSS.n188 0.413418
R667 VSS.n202 VSS.n198 0.413418
R668 VSS.n163 VSS.n162 0.380519
R669 VSS.n163 VSS.n161 0.359515
R670 VSS.n200 VSS.n198 0.340858
R671 VSS.n189 VSS.n187 0.340858
R672 VSS.n180 VSS.n178 0.340858
R673 VSS.n159 VSS.n158 0.340858
R674 VSS.n145 VSS.n143 0.340858
R675 VSS.n135 VSS.n133 0.340858
R676 VSS.n209 VSS.n208 0.318018
R677 VSS.n112 VSS.n108 0.316299
R678 VSS.n229 VSS.n228 0.284268
R679 VSS.n237 VSS.n236 0.284268
R680 VSS.n245 VSS.n244 0.284268
R681 VSS.n253 VSS.n252 0.284268
R682 VSS.n261 VSS.n260 0.284268
R683 VSS.n269 VSS.n268 0.284268
R684 VSS.n277 VSS.n276 0.284268
R685 VSS.n285 VSS.n284 0.284268
R686 VSS.n293 VSS.n292 0.284268
R687 VSS.n301 VSS.n300 0.284268
R688 VSS.n309 VSS.n308 0.284268
R689 VSS.n317 VSS.n316 0.284268
R690 VSS.n325 VSS.n324 0.284268
R691 VSS.n333 VSS.n332 0.284268
R692 VSS.n341 VSS.n340 0.284268
R693 VSS.n349 VSS.n348 0.284268
R694 VSS.n230 VSS.n229 0.282549
R695 VSS.n238 VSS.n237 0.282549
R696 VSS.n246 VSS.n245 0.282549
R697 VSS.n254 VSS.n253 0.282549
R698 VSS.n262 VSS.n261 0.282549
R699 VSS.n270 VSS.n269 0.282549
R700 VSS.n278 VSS.n277 0.282549
R701 VSS.n286 VSS.n285 0.282549
R702 VSS.n294 VSS.n293 0.282549
R703 VSS.n302 VSS.n301 0.282549
R704 VSS.n310 VSS.n309 0.282549
R705 VSS.n318 VSS.n317 0.282549
R706 VSS.n326 VSS.n325 0.282549
R707 VSS.n334 VSS.n333 0.282549
R708 VSS.n342 VSS.n341 0.282549
R709 VSS.n350 VSS.n349 0.282549
R710 VSS.n227 VSS.n226 0.280477
R711 VSS.n235 VSS.n234 0.280477
R712 VSS.n243 VSS.n242 0.280477
R713 VSS.n251 VSS.n250 0.280477
R714 VSS.n259 VSS.n258 0.280477
R715 VSS.n267 VSS.n266 0.280477
R716 VSS.n275 VSS.n274 0.280477
R717 VSS.n283 VSS.n282 0.280477
R718 VSS.n291 VSS.n290 0.280477
R719 VSS.n299 VSS.n298 0.280477
R720 VSS.n307 VSS.n306 0.280477
R721 VSS.n315 VSS.n314 0.280477
R722 VSS.n323 VSS.n322 0.280477
R723 VSS.n331 VSS.n330 0.280477
R724 VSS.n339 VSS.n338 0.280477
R725 VSS.n347 VSS.n346 0.280477
R726 VSS.n109 VSS.n108 0.274268
R727 VSS.n116 VSS.n106 0.274227
R728 VSS.n406 VSS.n28 0.440892
R729 VSS.n134 VSS.n129 0.274227
R730 VSS.n144 VSS.n139 0.274227
R731 VSS.n165 VSS.n154 0.274227
R732 VSS.n179 VSS.n175 0.274227
R733 VSS.n188 VSS.n184 0.274227
R734 VSS.n216 VSS.n215 0.272997
R735 VSS.n208 VSS.n207 0.272549
R736 VSS.n231 VSS.n230 0.270518
R737 VSS.n239 VSS.n238 0.270518
R738 VSS.n247 VSS.n246 0.270518
R739 VSS.n255 VSS.n254 0.270518
R740 VSS.n263 VSS.n262 0.270518
R741 VSS.n271 VSS.n270 0.270518
R742 VSS.n279 VSS.n278 0.270518
R743 VSS.n287 VSS.n286 0.270518
R744 VSS.n295 VSS.n294 0.270518
R745 VSS.n303 VSS.n302 0.270518
R746 VSS.n311 VSS.n310 0.270518
R747 VSS.n319 VSS.n318 0.270518
R748 VSS.n327 VSS.n326 0.270518
R749 VSS.n335 VSS.n334 0.270518
R750 VSS.n343 VSS.n342 0.270518
R751 VSS.n351 VSS.n350 0.270518
R752 VSS.n226 VSS.n225 0.266747
R753 VSS.n234 VSS.n233 0.266747
R754 VSS.n242 VSS.n241 0.266747
R755 VSS.n250 VSS.n249 0.266747
R756 VSS.n258 VSS.n257 0.266747
R757 VSS.n266 VSS.n265 0.266747
R758 VSS.n274 VSS.n273 0.266747
R759 VSS.n282 VSS.n281 0.266747
R760 VSS.n290 VSS.n289 0.266747
R761 VSS.n298 VSS.n297 0.266747
R762 VSS.n306 VSS.n305 0.266747
R763 VSS.n314 VSS.n313 0.266747
R764 VSS.n322 VSS.n321 0.266747
R765 VSS.n330 VSS.n329 0.266747
R766 VSS.n338 VSS.n337 0.266747
R767 VSS.n346 VSS.n345 0.266747
R768 VSS.n221 VSS.n220 0.246727
R769 VSS.n120 VSS.n119 0.245497
R770 VSS.n228 VSS.n227 0.240049
R771 VSS.n236 VSS.n235 0.240049
R772 VSS.n244 VSS.n243 0.240049
R773 VSS.n252 VSS.n251 0.240049
R774 VSS.n260 VSS.n259 0.240049
R775 VSS.n268 VSS.n267 0.240049
R776 VSS.n276 VSS.n275 0.240049
R777 VSS.n284 VSS.n283 0.240049
R778 VSS.n292 VSS.n291 0.240049
R779 VSS.n300 VSS.n299 0.240049
R780 VSS.n308 VSS.n307 0.240049
R781 VSS.n316 VSS.n315 0.240049
R782 VSS.n324 VSS.n323 0.240049
R783 VSS.n332 VSS.n331 0.240049
R784 VSS.n340 VSS.n339 0.240049
R785 VSS.n348 VSS.n347 0.240049
R786 VSS.n397 VSS.n129 0.237997
R787 VSS.n148 VSS.n139 0.237997
R788 VSS.n169 VSS.n154 0.237997
R789 VSS.n371 VSS.n175 0.237997
R790 VSS.n192 VSS.n184 0.237997
R791 VSS.n113 VSS.n107 0.234227
R792 VSS.n212 VSS.n211 0.232997
R793 VSS.n213 VSS.n212 0.231727
R794 VSS.n115 VSS.n107 0.230497
R795 VSS.n120 VSS.n118 0.219227
R796 VSS.n220 VSS.n219 0.217997
R797 VSS.n224 VSS.n223 0.211543
R798 VSS.n207 VSS.n206 0.201058
R799 VSS.n110 VSS.n109 0.200293
R800 VSS.n217 VSS.n216 0.191727
R801 VSS.n106 VSS.n105 0.190497
R802 VSS.n27 VSS.n121 0.318488
R803 VSS.n110 VSS.n101 0.161058
R804 VSS.n225 VSS.n224 0.161058
R805 VSS.n206 VSS.n205 0.160293
R806 VSS.n232 VSS.n231 0.15705
R807 VSS.n240 VSS.n239 0.15705
R808 VSS.n248 VSS.n247 0.15705
R809 VSS.n256 VSS.n255 0.15705
R810 VSS.n264 VSS.n263 0.15705
R811 VSS.n272 VSS.n271 0.15705
R812 VSS.n280 VSS.n279 0.15705
R813 VSS.n288 VSS.n287 0.15705
R814 VSS.n296 VSS.n295 0.15705
R815 VSS.n304 VSS.n303 0.15705
R816 VSS.n312 VSS.n311 0.15705
R817 VSS.n320 VSS.n319 0.15705
R818 VSS.n328 VSS.n327 0.15705
R819 VSS.n336 VSS.n335 0.15705
R820 VSS.n344 VSS.n343 0.15705
R821 VSS.n123 VSS.n122 0.156007
R822 VSS.n126 VSS.n125 0.155582
R823 VSS.n400 VSS.n127 0.155582
R824 VSS.n133 VSS.n132 0.155582
R825 VSS.n393 VSS.n136 0.155582
R826 VSS.n388 VSS.n137 0.155582
R827 VSS.n143 VSS.n142 0.155582
R828 VSS.n151 VSS.n150 0.155582
R829 VSS.n381 VSS.n152 0.155582
R830 VSS.n158 VSS.n157 0.155582
R831 VSS.n172 VSS.n171 0.155582
R832 VSS.n374 VSS.n173 0.155582
R833 VSS.n178 VSS.n177 0.155582
R834 VSS.n367 VSS.n181 0.155582
R835 VSS.n362 VSS.n182 0.155582
R836 VSS.n187 VSS.n186 0.155582
R837 VSS.n195 VSS.n194 0.155582
R838 VSS.n355 VSS.n196 0.155582
R839 VSS.n200 VSS.n199 0.155582
R840 VSS.n117 VSS.n115 0.149888
R841 VSS.n214 VSS.n213 0.14955
R842 VSS.n406 VSS.n405 0.149476
R843 VSS.n404 VSS.n403 0.149476
R844 VSS.n398 VSS.n128 0.149476
R845 VSS.n397 VSS.n396 0.149476
R846 VSS.n392 VSS.n391 0.149476
R847 VSS.n386 VSS.n138 0.149476
R848 VSS.n148 VSS.n147 0.149476
R849 VSS.n385 VSS.n384 0.149476
R850 VSS.n379 VSS.n153 0.149476
R851 VSS.n169 VSS.n168 0.149476
R852 VSS.n378 VSS.n377 0.149476
R853 VSS.n372 VSS.n174 0.149476
R854 VSS.n371 VSS.n370 0.149476
R855 VSS.n366 VSS.n365 0.149476
R856 VSS.n360 VSS.n183 0.149476
R857 VSS.n192 VSS.n191 0.149476
R858 VSS.n359 VSS.n358 0.149476
R859 VSS.n353 VSS.n197 0.149476
R860 VSS.n211 VSS.n210 0.147388
R861 VSS.n114 VSS.n113 0.14705
R862 VSS.n105 VSS.n103 0.142118
R863 VSS.n218 VSS.n217 0.142118
R864 VSS.n119 VSS.n102 0.134888
R865 VSS.n162 VSS.n155 0.134888
R866 VSS.n222 VSS.n221 0.13455
R867 VSS.n126 VSS.n124 0.129618
R868 VSS.n394 VSS.n393 0.129618
R869 VSS.n151 VSS.n146 0.129618
R870 VSS.n172 VSS.n167 0.129618
R871 VSS.n368 VSS.n367 0.129618
R872 VSS.n195 VSS.n190 0.129618
R873 VSS.n402 VSS.n401 0.126138
R874 VSS.n390 VSS.n389 0.126138
R875 VSS.n383 VSS.n382 0.126138
R876 VSS.n376 VSS.n375 0.126138
R877 VSS.n364 VSS.n363 0.126138
R878 VSS.n357 VSS.n356 0.126138
R879 VSS.n77 VSS.n395 0.156005
R880 VSS.n149 VSS.n81 0.156005
R881 VSS.n170 VSS.n86 0.156005
R882 VSS.n91 VSS.n369 0.156005
R883 VSS.n193 VSS.n96 0.156005
R884 VSS.n223 VSS.n222 0.122388
R885 VSS.n121 VSS.n102 0.12205
R886 VSS.n133 VSS.n131 0.12205
R887 VSS.n143 VSS.n141 0.12205
R888 VSS.n158 VSS.n156 0.12205
R889 VSS.n164 VSS.n155 0.12205
R890 VSS.n178 VSS.n176 0.12205
R891 VSS.n187 VSS.n185 0.12205
R892 VSS.n201 VSS.n200 0.12205
R893 VSS.n118 VSS.n103 0.114618
R894 VSS.n219 VSS.n218 0.114618
R895 VSS.n233 VSS.n232 0.113638
R896 VSS.n241 VSS.n240 0.113638
R897 VSS.n249 VSS.n248 0.113638
R898 VSS.n257 VSS.n256 0.113638
R899 VSS.n265 VSS.n264 0.113638
R900 VSS.n273 VSS.n272 0.113638
R901 VSS.n281 VSS.n280 0.113638
R902 VSS.n289 VSS.n288 0.113638
R903 VSS.n297 VSS.n296 0.113638
R904 VSS.n305 VSS.n304 0.113638
R905 VSS.n313 VSS.n312 0.113638
R906 VSS.n321 VSS.n320 0.113638
R907 VSS.n329 VSS.n328 0.113638
R908 VSS.n337 VSS.n336 0.113638
R909 VSS.n345 VSS.n344 0.113638
R910 VSS.n114 VSS.n112 0.109888
R911 VSS.n352 VSS.n351 0.109618
R912 VSS.n210 VSS.n209 0.10955
R913 VSS.n215 VSS.n214 0.107388
R914 VSS.n117 VSS.n116 0.10705
R915 VSS.n131 VSS.n130 0.106138
R916 VSS.n141 VSS.n140 0.106138
R917 VSS.n156 VSS.n84 0.106138
R918 VSS.n176 VSS.n89 0.106138
R919 VSS.n185 VSS.n94 0.106138
R920 VSS.n201 VSS.n99 0.106138
R921 VSS.n75 VSS.n402 0.166153
R922 VSS.n79 VSS.n390 0.166153
R923 VSS.n83 VSS.n383 0.166153
R924 VSS.n88 VSS.n376 0.166153
R925 VSS.n93 VSS.n364 0.166153
R926 VSS.n98 VSS.n357 0.166153
R927 VSS.n399 VSS.n398 0.105361
R928 VSS.n387 VSS.n386 0.105361
R929 VSS.n380 VSS.n379 0.105361
R930 VSS.n373 VSS.n372 0.105361
R931 VSS.n361 VSS.n360 0.105361
R932 VSS.n354 VSS.n353 0.105361
R933 VSS.n401 VSS.n400 0.10205
R934 VSS.n389 VSS.n388 0.10205
R935 VSS.n382 VSS.n381 0.10205
R936 VSS.n375 VSS.n374 0.10205
R937 VSS.n363 VSS.n362 0.10205
R938 VSS.n356 VSS.n355 0.10205
R939 VSS.n124 VSS.n123 0.0983676
R940 VSS.n395 VSS.n394 0.0983676
R941 VSS.n149 VSS.n146 0.0983676
R942 VSS.n170 VSS.n167 0.0983676
R943 VSS.n369 VSS.n368 0.0983676
R944 VSS.n193 VSS.n190 0.0983676
R945 VSS.n398 VSS.n76 0.0435295
R946 VSS.n386 VSS.n80 0.0435295
R947 VSS.n85 VSS.n84 0.176279
R948 VSS.n90 VSS.n89 0.176279
R949 VSS.n95 VSS.n94 0.176279
R950 VSS.n100 VSS.n99 0.176279
R951 VSS.n407 VSS.n101 0.078
R952 VSS.n205 VSS.n71 0.078
R953 VSS.n404 VSS.n74 0.103847
R954 VSS.n392 VSS.n78 0.103847
R955 VSS.n385 VSS.n82 0.103847
R956 VSS.n378 VSS.n87 0.103847
R957 VSS.n366 VSS.n92 0.103847
R958 VSS.n359 VSS.n97 0.103847
R959 VSS.n406 VSS.n122 0.0633093
R960 VSS VSS.n407 0.038
R961 VSS VSS.n71 0.038
R962 VSS.n20 VSS.n52 6.82258
R963 VSS.n53 VSS.t240 111.644
R964 VSS.n20 VSS.n51 6.82258
R965 VSS.n20 VSS.n1 0.382621
R966 VSS.n20 VSS.n50 6.82258
R967 VSS.n20 VSS.n2 0.382621
R968 VSS.n49 VSS.t9 111.644
R969 VSS.n10 VSS.t67 83.4525
R970 VSS.n20 VSS.n48 6.82258
R971 VSS.n20 VSS.n47 6.82258
R972 VSS.n20 VSS.n3 0.382621
R973 VSS.n46 VSS.t141 111.644
R974 VSS.n355 VSS.n354 0.0166107
R975 VSS.n362 VSS.n361 0.0166107
R976 VSS.n374 VSS.n373 0.0166107
R977 VSS.n381 VSS.n380 0.0166107
R978 VSS.n388 VSS.n387 0.0166107
R979 VSS.n400 VSS.n399 0.0166107
R980 VSS.n23 VSS.t122 82.6299
R981 VSS.n20 VSS.n0 1.35318
R982 VSS.n26 VSS.n23 1.26296
R983 VSS.n20 VSS.n29 1.12935
R984 a_3747_216.n0 a_3747_216.t2 52.0388
R985 a_3747_216.t0 a_3747_216.n0 35.4491
R986 a_3747_216.n0 a_3747_216.t3 33.5891
R987 a_3747_216.t1 a_3747_216.t0 5.61942
R988 a_3171_216.n0 a_3171_216.t2 51.8377
R989 a_3171_216.n0 a_3171_216.t3 33.3881
R990 a_3171_216.t0 a_3171_216.n0 31.8923
R991 a_3171_216.t1 a_3171_216.t0 5.61777
R992 a_2595_216.n0 a_2595_216.t2 51.6367
R993 a_2595_216.n0 a_2595_216.t3 33.187
R994 a_2595_216.t0 a_2595_216.n0 27.993
R995 a_2595_216.t1 a_2595_216.t0 5.73018
R996 a_3747_952.n0 a_3747_952.t2 38.0081
R997 a_3747_952.n0 a_3747_952.t3 33.3957
R998 a_3747_952.n1 a_3747_952.t4 33.3957
R999 a_3747_952.n2 a_3747_952.t5 33.3957
R1000 a_3747_952.n3 a_3747_952.t6 33.3957
R1001 a_3747_952.n4 a_3747_952.t7 33.3957
R1002 a_3747_952.n5 a_3747_952.t8 33.3957
R1003 a_3747_952.n6 a_3747_952.t9 33.3957
R1004 a_3747_952.t0 a_3747_952.n6 23.2419
R1005 a_3747_952.t1 a_3747_952.t0 5.61942
R1006 a_3747_952.n6 a_3747_952.n5 4.61291
R1007 a_3747_952.n5 a_3747_952.n4 4.61291
R1008 a_3747_952.n4 a_3747_952.n3 4.61291
R1009 a_3747_952.n3 a_3747_952.n2 4.61291
R1010 a_3747_952.n2 a_3747_952.n1 4.61291
R1011 a_3747_952.n1 a_3747_952.n0 4.61291
R1012 a_3171_952.n0 a_3171_952.t2 37.8054
R1013 a_3171_952.n0 a_3171_952.t3 33.193
R1014 a_3171_952.n1 a_3171_952.t4 33.193
R1015 a_3171_952.n2 a_3171_952.t5 33.193
R1016 a_3171_952.n3 a_3171_952.t6 33.193
R1017 a_3171_952.n4 a_3171_952.t7 33.193
R1018 a_3171_952.n5 a_3171_952.t8 33.193
R1019 a_3171_952.n6 a_3171_952.t9 33.193
R1020 a_3171_952.t0 a_3171_952.n6 23.0313
R1021 a_3171_952.t1 a_3171_952.t0 5.61777
R1022 a_3171_952.n6 a_3171_952.n5 4.61291
R1023 a_3171_952.n5 a_3171_952.n4 4.61291
R1024 a_3171_952.n4 a_3171_952.n3 4.61291
R1025 a_3171_952.n3 a_3171_952.n2 4.61291
R1026 a_3171_952.n2 a_3171_952.n1 4.61291
R1027 a_3171_952.n1 a_3171_952.n0 4.61291
R1028 a_2595_952.n0 a_2595_952.t2 37.7691
R1029 a_2595_952.n0 a_2595_952.t3 33.1567
R1030 a_2595_952.n1 a_2595_952.t4 33.1567
R1031 a_2595_952.n2 a_2595_952.t5 33.1567
R1032 a_2595_952.n3 a_2595_952.t6 33.1567
R1033 a_2595_952.n4 a_2595_952.t7 33.1567
R1034 a_2595_952.n5 a_2595_952.t8 33.1567
R1035 a_2595_952.n6 a_2595_952.t9 33.1567
R1036 a_2595_952.t0 a_2595_952.n6 22.7941
R1037 a_2595_952.t1 a_2595_952.t0 5.65522
R1038 a_2595_952.n6 a_2595_952.n5 4.61291
R1039 a_2595_952.n5 a_2595_952.n4 4.61291
R1040 a_2595_952.n4 a_2595_952.n3 4.61291
R1041 a_2595_952.n3 a_2595_952.n2 4.61291
R1042 a_2595_952.n2 a_2595_952.n1 4.61291
R1043 a_2595_952.n1 a_2595_952.n0 4.61291
R1044 a_2019_952.n0 a_2019_952.t2 37.9701
R1045 a_2019_952.n0 a_2019_952.t3 33.3577
R1046 a_2019_952.n1 a_2019_952.t4 33.3577
R1047 a_2019_952.n2 a_2019_952.t5 33.3577
R1048 a_2019_952.n3 a_2019_952.t6 33.3577
R1049 a_2019_952.n4 a_2019_952.t7 33.3577
R1050 a_2019_952.t0 a_2019_952.t9 22.5945
R1051 a_2019_952.t1 a_2019_952.t0 5.62052
R1052 a_2019_952.t9 a_2019_952.t8 4.61291
R1053 a_2019_952.t8 a_2019_952.n4 4.61291
R1054 a_2019_952.n4 a_2019_952.n3 4.61291
R1055 a_2019_952.n3 a_2019_952.n2 4.61291
R1056 a_2019_952.n2 a_2019_952.n1 4.61291
R1057 a_2019_952.n1 a_2019_952.n0 4.61291
C578 MUX_OUT VSS 3.24057f
C579 MUX_SEL4 VSS 1.63591f
C580 DELAY_OUT_TAP0 VSS 0.37425f
C581 MUX_SEL3 VSS 0.90686f
C582 MUX_SEL2 VSS 1.81137f
C583 DELAY_OUT_TAP31 VSS 0.41949f
C584 DELAY_OUT_TAP30 VSS 0.43238f
C585 DELAY_OUT_TAP29 VSS 0.30856f
C586 DELAY_OUT_TAP28 VSS 0.4381f
C587 DELAY_OUT_TAP27 VSS 0.38455f
C588 DELAY_OUT_TAP26 VSS 0.43238f
C589 DELAY_OUT_TAP25 VSS 0.30856f
C590 DELAY_OUT_TAP24 VSS 0.4381f
C591 DELAY_OUT_TAP23 VSS 0.38455f
C592 DELAY_OUT_TAP22 VSS 0.43238f
C593 DELAY_OUT_TAP21 VSS 0.30856f
C594 DELAY_OUT_TAP20 VSS 0.4381f
C595 DELAY_OUT_TAP19 VSS 0.38455f
C596 DELAY_OUT_TAP18 VSS 0.43238f
C597 DELAY_OUT_TAP17 VSS 0.30374f
C598 DELAY_OUT_TAP16 VSS 0.42869f
C599 DELAY_OUT_TAP15 VSS 0.38342f
C600 DELAY_OUT_TAP14 VSS 0.43238f
C601 DELAY_OUT_TAP13 VSS 0.30856f
C602 DELAY_OUT_TAP12 VSS 0.43643f
C603 DELAY_OUT_TAP11 VSS 0.38455f
C604 DELAY_OUT_TAP10 VSS 0.43238f
C605 DELAY_OUT_TAP9 VSS 0.30856f
C606 DELAY_OUT_TAP8 VSS 0.43643f
C607 DELAY_OUT_TAP7 VSS 0.38455f
C608 DELAY_OUT_TAP6 VSS 0.43238f
C609 DELAY_OUT_TAP5 VSS 0.30856f
C610 DELAY_OUT_TAP4 VSS 0.43585f
C611 DELAY_OUT_TAP3 VSS 0.38455f
C612 DELAY_OUT_TAP2 VSS 0.43238f
C613 DELAY_OUT_TAP1 VSS 0.30776f
C614 MUX_SEL1 VSS 0.9549f
C615 MUX_SEL0 VSS 1.81267f
C616 VDD VSS 26.9372f
C617 a_26985_424# VSS 0.18005f ; **FLOATING
C618 a_23945_424# VSS 0.18005f ; **FLOATING
C619 a_20905_424# VSS 0.18005f ; **FLOATING
C620 a_17865_424# VSS 0.1767f ; **FLOATING
C621 a_16851_214# VSS 0.38749f ; **FLOATING
C622 a_16108_194# VSS 3.87256f ; **FLOATING
C623 a_15964_194# VSS 0.18406f ; **FLOATING
C624 a_15765_368# VSS 0.36264f ; **FLOATING
C625 a_14825_424# VSS 0.18005f ; **FLOATING
C626 a_11785_424# VSS 0.18005f ; **FLOATING
C627 a_8745_424# VSS 0.18005f ; **FLOATING
C628 a_5731_194# VSS 3.39133f ; **FLOATING
C629 a_2019_216# VSS 1.616f ; **FLOATING
C630 a_5705_424# VSS 0.17716f ; **FLOATING
C631 a_3449_236# VSS 0.18478f ; **FLOATING
C632 a_2873_236# VSS 0.18321f ; **FLOATING
C633 a_2297_236# VSS 0.18321f ; **FLOATING
C634 a_1721_236# VSS 0.17001f ; **FLOATING
C635 a_1544_194# VSS 0.30014f ; **FLOATING
C636 a_1256_194# VSS 0.84266f ; **FLOATING
C637 a_27991_913# VSS 0.18706f ; **FLOATING
C638 a_27915_949# VSS 0.10926f ; **FLOATING
C639 a_27124_913# VSS 0.17878f ; **FLOATING
C640 a_27048_949# VSS 0.12122f ; **FLOATING
C641 a_26471_913# VSS 0.18175f ; **FLOATING
C642 a_26395_949# VSS 0.11073f ; **FLOATING
C643 a_25604_913# VSS 0.18087f ; **FLOATING
C644 a_25630_949# VSS 0.43187f ; **FLOATING
C645 a_25528_949# VSS 0.12433f ; **FLOATING
C646 a_24951_913# VSS 0.18335f ; **FLOATING
C647 a_24875_949# VSS 0.11016f ; **FLOATING
C648 a_24084_913# VSS 0.17878f ; **FLOATING
C649 a_24008_949# VSS 0.12122f ; **FLOATING
C650 a_23431_913# VSS 0.18175f ; **FLOATING
C651 a_23355_949# VSS 0.11073f ; **FLOATING
C652 a_22564_913# VSS 0.18087f ; **FLOATING
C653 a_22590_949# VSS 0.40111f ; **FLOATING
C654 a_22488_949# VSS 0.12433f ; **FLOATING
C655 a_21911_913# VSS 0.18335f ; **FLOATING
C656 a_21835_949# VSS 0.11016f ; **FLOATING
C657 a_21044_913# VSS 0.17878f ; **FLOATING
C658 a_20968_949# VSS 0.12122f ; **FLOATING
C659 a_20391_913# VSS 0.18175f ; **FLOATING
C660 a_20315_949# VSS 0.11073f ; **FLOATING
C661 a_19524_913# VSS 0.18087f ; **FLOATING
C662 a_19550_949# VSS 0.4036f ; **FLOATING
C663 a_19448_949# VSS 0.12433f ; **FLOATING
C664 a_18871_913# VSS 0.18335f ; **FLOATING
C665 a_18795_949# VSS 0.11016f ; **FLOATING
C666 a_18004_913# VSS 0.17878f ; **FLOATING
C667 a_17928_949# VSS 0.12122f ; **FLOATING
C668 a_17351_913# VSS 0.18022f ; **FLOATING
C669 a_17275_949# VSS 0.10926f ; **FLOATING
C670 a_16484_913# VSS 0.18023f ; **FLOATING
C671 a_16510_949# VSS 0.35732f ; **FLOATING
C672 a_16408_949# VSS 0.1229f ; **FLOATING
C673 a_15831_913# VSS 0.17846f ; **FLOATING
C674 a_15755_949# VSS 0.10926f ; **FLOATING
C675 a_14964_913# VSS 0.17878f ; **FLOATING
C676 a_14888_949# VSS 0.12122f ; **FLOATING
C677 a_14311_913# VSS 0.18175f ; **FLOATING
C678 a_14235_949# VSS 0.11073f ; **FLOATING
C679 a_13444_913# VSS 0.18087f ; **FLOATING
C680 a_13470_949# VSS 0.3713f ; **FLOATING
C681 a_13368_949# VSS 0.12433f ; **FLOATING
C682 a_12791_913# VSS 0.18335f ; **FLOATING
C683 a_12715_949# VSS 0.11016f ; **FLOATING
C684 a_11924_913# VSS 0.17878f ; **FLOATING
C685 a_11848_949# VSS 0.12122f ; **FLOATING
C686 a_11271_913# VSS 0.18175f ; **FLOATING
C687 a_11195_949# VSS 0.11073f ; **FLOATING
C688 a_10404_913# VSS 0.18087f ; **FLOATING
C689 a_10430_949# VSS 0.38462f ; **FLOATING
C690 a_10328_949# VSS 0.12433f ; **FLOATING
C691 a_9751_913# VSS 0.18335f ; **FLOATING
C692 a_9675_949# VSS 0.11016f ; **FLOATING
C693 a_8884_913# VSS 0.17878f ; **FLOATING
C694 a_8808_949# VSS 0.12122f ; **FLOATING
C695 a_8231_913# VSS 0.18175f ; **FLOATING
C696 a_8155_949# VSS 0.11073f ; **FLOATING
C697 a_7364_913# VSS 0.18087f ; **FLOATING
C698 a_7390_949# VSS 0.38153f ; **FLOATING
C699 a_7288_949# VSS 0.12433f ; **FLOATING
C700 a_6711_913# VSS 0.18335f ; **FLOATING
C701 a_6635_949# VSS 0.11016f ; **FLOATING
C702 a_5844_913# VSS 0.17878f ; **FLOATING
C703 a_5768_949# VSS 0.12122f ; **FLOATING
C704 a_5191_913# VSS 0.18022f ; **FLOATING
C705 a_5115_949# VSS 0.10926f ; **FLOATING
C706 a_4324_913# VSS 0.18023f ; **FLOATING
C707 a_4350_949# VSS 0.33452f ; **FLOATING
C708 a_4248_949# VSS 0.12443f ; **FLOATING
C709 a_27705_949# VSS 0.2535f ; **FLOATING
C710 a_26185_949# VSS 0.23529f ; **FLOATING
C711 a_24665_949# VSS 0.25486f ; **FLOATING
C712 a_23145_949# VSS 0.23529f ; **FLOATING
C713 a_21625_949# VSS 0.25486f ; **FLOATING
C714 a_20105_949# VSS 0.23529f ; **FLOATING
C715 a_18585_949# VSS 0.25486f ; **FLOATING
C716 a_17065_949# VSS 0.23439f ; **FLOATING
C717 a_15545_949# VSS 0.2535f ; **FLOATING
C718 a_14025_949# VSS 0.23529f ; **FLOATING
C719 a_12505_949# VSS 0.25486f ; **FLOATING
C720 a_10985_949# VSS 0.23529f ; **FLOATING
C721 a_9465_949# VSS 0.25486f ; **FLOATING
C722 a_7945_949# VSS 0.23529f ; **FLOATING
C723 a_6425_949# VSS 0.25486f ; **FLOATING
C724 a_4905_949# VSS 0.23602f ; **FLOATING
C725 a_4157_1218# VSS 0.3431f ; **FLOATING
C726 a_3449_1300# VSS 0.18603f ; **FLOATING
C727 a_2873_1300# VSS 0.18321f ; **FLOATING
C728 a_2297_1300# VSS 0.18321f ; **FLOATING
C729 a_1721_1300# VSS 0.17001f ; **FLOATING
C730 a_1544_949# VSS 0.29963f ; **FLOATING
C731 a_1256_949# VSS 0.83916f ; **FLOATING
C732 a_2019_952.t2 VSS 0.8244f ; **FLOATING
C733 a_2019_952.t3 VSS 0.62586f ; **FLOATING
C734 a_2019_952.n0 VSS 4.43882f ; **FLOATING
C735 a_2019_952.t4 VSS 0.62586f ; **FLOATING
C736 a_2019_952.n1 VSS 3.00299f ; **FLOATING
C737 a_2019_952.t5 VSS 0.62586f ; **FLOATING
C738 a_2019_952.n2 VSS 3.00299f ; **FLOATING
C739 a_2019_952.t6 VSS 0.62586f ; **FLOATING
C740 a_2019_952.n3 VSS 3.00299f ; **FLOATING
C741 a_2019_952.t7 VSS 0.62586f ; **FLOATING
C742 a_2019_952.n4 VSS 3.00299f ; **FLOATING
C743 a_2019_952.t8 VSS 3.62885f ; **FLOATING
C744 a_2019_952.t9 VSS 4.83408f ; **FLOATING
C745 a_2019_952.t0 VSS 0.95051f ; **FLOATING
C746 a_2019_952.t1 VSS 0.27016f ; **FLOATING
C747 a_2595_952.t2 VSS 1.35979f ; **FLOATING
C748 a_2595_952.t3 VSS 1.01554f ; **FLOATING
C749 a_2595_952.n0 VSS 7.72017f ; **FLOATING
C750 a_2595_952.t4 VSS 1.01554f ; **FLOATING
C751 a_2595_952.n1 VSS 5.2455f ; **FLOATING
C752 a_2595_952.t5 VSS 1.01554f ; **FLOATING
C753 a_2595_952.n2 VSS 5.2455f ; **FLOATING
C754 a_2595_952.t6 VSS 1.01554f ; **FLOATING
C755 a_2595_952.n3 VSS 5.2455f ; **FLOATING
C756 a_2595_952.t7 VSS 1.01554f ; **FLOATING
C757 a_2595_952.n4 VSS 5.2455f ; **FLOATING
C758 a_2595_952.t8 VSS 1.01554f ; **FLOATING
C759 a_2595_952.n5 VSS 5.2455f ; **FLOATING
C760 a_2595_952.t9 VSS 1.01554f ; **FLOATING
C761 a_2595_952.n6 VSS 7.54534f ; **FLOATING
C762 a_2595_952.t0 VSS 1.74193f ; **FLOATING
C763 a_2595_952.t1 VSS 0.47972f ; **FLOATING
C764 a_3171_952.t2 VSS 1.37934f ; **FLOATING
C765 a_3171_952.t3 VSS 1.03353f ; **FLOATING
C766 a_3171_952.n0 VSS 7.75003f ; **FLOATING
C767 a_3171_952.t4 VSS 1.03353f ; **FLOATING
C768 a_3171_952.n1 VSS 5.26146f ; **FLOATING
C769 a_3171_952.t5 VSS 1.03353f ; **FLOATING
C770 a_3171_952.n2 VSS 5.26146f ; **FLOATING
C771 a_3171_952.t6 VSS 1.03353f ; **FLOATING
C772 a_3171_952.n3 VSS 5.26146f ; **FLOATING
C773 a_3171_952.t7 VSS 1.03353f ; **FLOATING
C774 a_3171_952.n4 VSS 5.26146f ; **FLOATING
C775 a_3171_952.t8 VSS 1.03353f ; **FLOATING
C776 a_3171_952.n5 VSS 5.26146f ; **FLOATING
C777 a_3171_952.t9 VSS 1.03353f ; **FLOATING
C778 a_3171_952.n6 VSS 7.65529f ; **FLOATING
C779 a_3171_952.t0 VSS 1.76377f ; **FLOATING
C780 a_3171_952.t1 VSS 0.47908f ; **FLOATING
C781 a_3747_952.t2 VSS 0.96135f ; **FLOATING
C782 a_3747_952.t3 VSS 0.73189f ; **FLOATING
C783 a_3747_952.n0 VSS 5.12748f ; **FLOATING
C784 a_3747_952.t4 VSS 0.73189f ; **FLOATING
C785 a_3747_952.n1 VSS 3.46611f ; **FLOATING
C786 a_3747_952.t5 VSS 0.73189f ; **FLOATING
C787 a_3747_952.n2 VSS 3.46611f ; **FLOATING
C788 a_3747_952.t6 VSS 0.73189f ; **FLOATING
C789 a_3747_952.n3 VSS 3.46611f ; **FLOATING
C790 a_3747_952.t7 VSS 0.73189f ; **FLOATING
C791 a_3747_952.n4 VSS 3.46611f ; **FLOATING
C792 a_3747_952.t8 VSS 0.73189f ; **FLOATING
C793 a_3747_952.n5 VSS 3.46611f ; **FLOATING
C794 a_3747_952.t9 VSS 0.73189f ; **FLOATING
C795 a_3747_952.n6 VSS 5.14677f ; **FLOATING
C796 a_3747_952.t0 VSS 1.17618f ; **FLOATING
C797 a_3747_952.t1 VSS 0.31095f ; **FLOATING
C798 a_2595_216.t0 VSS 3.2703f ; **FLOATING
C799 a_2595_216.t2 VSS 5.04135f ; **FLOATING
C800 a_2595_216.t3 VSS 1.20629f ; **FLOATING
C801 a_2595_216.n0 VSS 26.8663f ; **FLOATING
C802 a_2595_216.t1 VSS 0.49571f ; **FLOATING
C803 a_3171_216.t2 VSS 5.0499f ; **FLOATING
C804 a_3171_216.t3 VSS 1.21145f ; **FLOATING
C805 a_3171_216.n0 VSS 29.8488f ; **FLOATING
C806 a_3171_216.t0 VSS 4.61136f ; **FLOATING
C807 a_3171_216.t1 VSS 0.49728f ; **FLOATING
C808 a_3747_216.t2 VSS 3.09124f ; **FLOATING
C809 a_3747_216.t3 VSS 0.74403f ; **FLOATING
C810 a_3747_216.n0 VSS 19.8835f ; **FLOATING
C811 a_3747_216.t0 VSS 3.68799f ; **FLOATING
C812 a_3747_216.t1 VSS 0.30529f ; **FLOATING
.ends
