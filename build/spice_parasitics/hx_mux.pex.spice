* NGSPICE file created from hx_mux.ext - technology: ihp-sg13g2

.subckt hx_mux VSS VDD DELAY_OUT_TAP0 DELAY_OUT_TAP1 DELAY_OUT_TAP2 DELAY_OUT_TAP3
+ DELAY_OUT_TAP4 DELAY_OUT_TAP5 DELAY_OUT_TAP6 DELAY_OUT_TAP7 DELAY_OUT_TAP8 DELAY_OUT_TAP9
+ DELAY_OUT_TAP10 DELAY_OUT_TAP11 DELAY_OUT_TAP12 DELAY_OUT_TAP13 DELAY_OUT_TAP14
+ DELAY_OUT_TAP15 DELAY_OUT_TAP16 DELAY_OUT_TAP17 DELAY_OUT_TAP18 DELAY_OUT_TAP19
+ DELAY_OUT_TAP20 DELAY_OUT_TAP21 DELAY_OUT_TAP22 DELAY_OUT_TAP23 DELAY_OUT_TAP24
+ DELAY_OUT_TAP25 DELAY_OUT_TAP26 DELAY_OUT_TAP27 DELAY_OUT_TAP28 DELAY_OUT_TAP29
+ DELAY_OUT_TAP30 DELAY_OUT_TAP31 MUX_SEL0 MUX_SEL1 MUX_OUT MUX_SEL4 MUX_SEL2 MUX_SEL3
X0 VDD a_2019_952.t9 a_4324_913# VDD sg13_lv_pmos ad=0.3808p pd=2.92u as=0.3808p ps=2.92u w=1.12u l=0.13u
X1 a_1256_194# MUX_SEL2 VDD VDD sg13_lv_pmos ad=0.3808p pd=2.92u as=0.3808p ps=2.92u w=1.12u l=0.13u
X2 VDD a_3171_952.t8 a_8884_913# VDD sg13_lv_pmos ad=0.3808p pd=2.92u as=0.3808p ps=2.92u w=1.12u l=0.13u
X3 a_16108_194# a_15765_368# a_15964_194# VDD sg13_lv_pmos ad=0.3808p pd=2.92u as=0.3304p ps=1.71u w=1.12u l=0.13u
X4 a_22590_949# a_24951_913# a_24875_949# VDD sg13_lv_pmos ad=0.3808p pd=2.92u as=0.2128p ps=1.5u w=1.12u l=0.13u
X5 VDD a_2595_952.t7 a_11271_913# VDD sg13_lv_pmos ad=0.3808p pd=2.92u as=0.3808p ps=2.92u w=1.12u l=0.13u
X6 VSS.t195 VDD VSS.t193 VSS.t194 sg13_lv_nmos ad=79.8f pd=0.8u as=0 ps=0 w=0.42u l=1u
X7 a_7390_949# a_2595_952.t8 a_8155_949# VSS.t344 sg13_lv_nmos ad=0.2516p pd=2.16u as=0.1406p ps=1.12u w=0.74u l=0.13u
X8 VSS.t198 VDD VSS.t197 VSS.t196 sg13_lv_nmos ad=0.1428p pd=1.52u as=0 ps=0 w=0.42u l=1u
X9 VDD VSS.t381 VDD VDD sg13_lv_pmos ad=0.19p pd=1.38u as=0.14315n ps=0.71478m w=1u l=1u
X10 VSS.t149 DELAY_OUT_TAP11 a_12505_949# VSS.t181 sg13_lv_nmos ad=0.1665p pd=1.19u as=0.2516p ps=2.16u w=0.74u l=0.13u
X11 MUX_OUT a_16851_214# VSS.t153 VSS.t152 sg13_lv_nmos ad=0.1406p pd=1.12u as=0.1371p ps=1.12u w=0.74u l=0.13u
X12 VDD a_3747_952.t9 a_6711_913# VDD sg13_lv_pmos ad=0.3808p pd=2.92u as=0.3808p ps=2.92u w=1.12u l=0.13u
X13 VSS.t263 VDD VSS.t262 VSS.t261 sg13_lv_nmos ad=0.1428p pd=1.52u as=0 ps=0 w=0.42u l=1u
X14 a_1544_194# MUX_SEL3 VDD VDD sg13_lv_pmos ad=0.3808p pd=2.92u as=0.3808p ps=2.92u w=1.12u l=0.13u
X15 VSS.t158 a_2595_216.t3 a_8745_424# VSS.t157 sg13_lv_nmos ad=0.2516p pd=2.16u as=0.2516p ps=2.16u w=0.74u l=0.13u
X16 a_10328_949# DELAY_OUT_TAP8 VSS.t293 VSS.t292 sg13_lv_nmos ad=0.1406p pd=1.12u as=0.2516p ps=2.16u w=0.74u l=0.13u
X17 a_22590_949# a_2019_952.t3 a_22488_949# VSS.t23 sg13_lv_nmos ad=0.2516p pd=2.16u as=0.1406p ps=1.12u w=0.74u l=0.13u
X18 a_8808_949# DELAY_OUT_TAP6 VSS.t297 VSS.t296 sg13_lv_nmos ad=0.1406p pd=1.12u as=0.2516p ps=2.16u w=0.74u l=0.13u
X19 VSS.t151 DELAY_OUT_TAP31 a_27705_949# VSS.t313 sg13_lv_nmos ad=0.1665p pd=1.19u as=0.2516p ps=2.16u w=0.74u l=0.13u
X20 a_11848_949# DELAY_OUT_TAP10 VDD VDD sg13_lv_pmos ad=0.2128p pd=1.5u as=0.3808p ps=2.92u w=1.12u l=0.13u
X21 VDD a_3171_952.t3 a_24084_913# VDD sg13_lv_pmos ad=0.3808p pd=2.92u as=0.3808p ps=2.92u w=1.12u l=0.13u
X22 a_1721_236# a_1256_194# VDD VDD sg13_lv_pmos ad=0.1596p pd=1.22u as=0.2856p ps=2.36u w=0.84u l=0.13u
X23 a_6635_949# a_6425_949# VSS.t129 VSS.t128 sg13_lv_nmos ad=0.1406p pd=1.12u as=0.1665p ps=1.19u w=0.74u l=0.13u
X24 VDD VSS.t374 VDD VDD sg13_lv_pmos ad=0.34p pd=2.68u as=0 ps=0 w=1u l=1u
X25 VSS.t337 a_2595_952.t9 a_5191_913# VSS.t336 sg13_lv_nmos ad=0.2516p pd=2.16u as=0.2516p ps=2.16u w=0.74u l=0.13u
X26 VSS.t285 a_1256_949# a_2967_1300# VSS.t284 sg13_lv_nmos ad=0.1331p pd=1.12u as=0.1216p ps=1.02u w=0.64u l=0.13u
X27 a_4157_1218# DELAY_OUT_TAP0 VDD VDD sg13_lv_pmos ad=0.3808p pd=2.92u as=0.3808p ps=2.92u w=1.12u l=0.13u
X28 a_25528_949# DELAY_OUT_TAP28 VSS.t308 VSS.t307 sg13_lv_nmos ad=0.1406p pd=1.12u as=0.2516p ps=2.16u w=0.74u l=0.13u
X29 a_20315_949# a_20105_949# VSS.t135 VSS.t134 sg13_lv_nmos ad=0.1406p pd=1.12u as=0.1665p ps=1.19u w=0.74u l=0.13u
X30 a_5731_194# a_3747_216.t3 a_13470_949# VSS.t125 sg13_lv_nmos ad=0.2516p pd=2.16u as=0.2516p ps=2.16u w=0.74u l=0.13u
X31 VSS.t255 VDD VSS.t253 VSS.t254 sg13_lv_nmos ad=79.8f pd=0.8u as=0 ps=0 w=0.42u l=1u
X32 VSS.t220 VDD VSS.t218 VSS.t219 sg13_lv_nmos ad=79.8f pd=0.8u as=0 ps=0 w=0.42u l=1u
X33 VSS.t155 a_16851_214# MUX_OUT VSS.t154 sg13_lv_nmos ad=0.2516p pd=2.16u as=0.1406p ps=1.12u w=0.74u l=0.13u
X34 VDD a_1544_194# a_1721_236# VDD sg13_lv_pmos ad=0.1918p pd=1.5u as=0.1596p ps=1.22u w=0.84u l=0.13u
X35 VDD a_3747_952.t3 a_24951_913# VDD sg13_lv_pmos ad=0.3808p pd=2.92u as=0.3808p ps=2.92u w=1.12u l=0.13u
X36 VDD VSS.t386 VDD VDD sg13_lv_pmos ad=0.34p pd=2.68u as=0 ps=0 w=1u l=1u
X37 a_16408_949# DELAY_OUT_TAP16 VSS.t348 VSS.t347 sg13_lv_nmos ad=0.1406p pd=1.12u as=0.2516p ps=2.16u w=0.74u l=0.13u
X38 a_5731_194# a_2019_216# a_4350_949# VSS.t104 sg13_lv_nmos ad=0.2516p pd=2.16u as=0.2516p ps=2.16u w=0.74u l=0.13u
X39 VDD a_2595_952.t2 a_26471_913# VDD sg13_lv_pmos ad=0.3808p pd=2.92u as=0.3808p ps=2.92u w=1.12u l=0.13u
X40 a_7390_949# a_3747_952.t8 a_9675_949# VSS.t332 sg13_lv_nmos ad=0.2516p pd=2.16u as=0.1406p ps=1.12u w=0.74u l=0.13u
X41 VSS.t193 VDD VSS.t192 VSS.t191 sg13_lv_nmos ad=0.1428p pd=1.52u as=0 ps=0 w=0.42u l=1u
X42 VDD VSS.t357 VDD VDD sg13_lv_pmos ad=0.19p pd=1.38u as=0 ps=0 w=1u l=1u
X43 VDD DELAY_OUT_TAP13 a_14025_949# VDD sg13_lv_pmos ad=0.252p pd=1.57u as=0.3808p ps=2.92u w=1.12u l=0.13u
X44 a_10430_949# a_11924_913# a_11848_949# VDD sg13_lv_pmos ad=0.3808p pd=2.92u as=0.2128p ps=1.5u w=1.12u l=0.13u
X45 VDD a_2595_216.t3 a_8745_424# VDD sg13_lv_pmos ad=0.3808p pd=2.92u as=0.3808p ps=2.92u w=1.12u l=0.13u
X46 VSS.t93 a_3171_952.t5 a_18004_913# VSS.t92 sg13_lv_nmos ad=0.2516p pd=2.16u as=0.2516p ps=2.16u w=0.74u l=0.13u
X47 VDD DELAY_OUT_TAP15 a_15545_949# VDD sg13_lv_pmos ad=0.252p pd=1.57u as=0.3808p ps=2.92u w=1.12u l=0.13u
X48 a_3171_216.t1 a_2873_236# VDD VDD sg13_lv_pmos ad=0.2128p pd=1.5u as=0.1918p ps=1.5u w=1.12u l=0.13u
X49 a_14235_949# a_14025_949# VSS.t103 VSS.t102 sg13_lv_nmos ad=0.1406p pd=1.12u as=0.1665p ps=1.19u w=0.74u l=0.13u
X50 VSS.t34 a_3747_952.t7 a_12791_913# VSS.t33 sg13_lv_nmos ad=0.2516p pd=2.16u as=0.2516p ps=2.16u w=0.74u l=0.13u
X51 a_3747_216.t1 a_3449_236# VDD VDD sg13_lv_pmos ad=0.2128p pd=1.5u as=0.1918p ps=1.5u w=1.12u l=0.13u
X52 a_12715_949# a_12505_949# VDD VDD sg13_lv_pmos ad=0.2128p pd=1.5u as=0.252p ps=1.57u w=1.12u l=0.13u
X53 a_11848_949# DELAY_OUT_TAP10 VSS.t180 VSS.t179 sg13_lv_nmos ad=0.1406p pd=1.12u as=0.2516p ps=2.16u w=0.74u l=0.13u
X54 a_17275_949# a_17065_949# VDD VDD sg13_lv_pmos ad=0.2128p pd=1.5u as=0.252p ps=1.57u w=1.12u l=0.13u
X55 VDD VSS.t389 VDD VDD sg13_lv_pmos ad=0.19p pd=1.38u as=0 ps=0 w=1u l=1u
X56 VDD VSS.t388 VDD VDD sg13_lv_pmos ad=0.34p pd=2.68u as=0 ps=0 w=1u l=1u
X57 a_10430_949# a_12791_913# a_12715_949# VDD sg13_lv_pmos ad=0.3808p pd=2.92u as=0.2128p ps=1.5u w=1.12u l=0.13u
X58 VSS.t135 DELAY_OUT_TAP21 a_20105_949# VSS.t355 sg13_lv_nmos ad=0.1665p pd=1.19u as=0.2516p ps=2.16u w=0.74u l=0.13u
X59 a_16510_949# a_17351_913# a_17275_949# VDD sg13_lv_pmos ad=0.3808p pd=2.92u as=0.2128p ps=1.5u w=1.12u l=0.13u
X60 VSS.t185 a_1721_1300# a_2019_952.t0 VSS.t184 sg13_lv_nmos ad=0.2812p pd=2.24u as=0.1406p ps=1.12u w=0.74u l=0.13u
X61 a_5731_194# a_14825_424# a_13470_949# VDD sg13_lv_pmos ad=0.3808p pd=2.92u as=0.3808p ps=2.92u w=1.12u l=0.13u
X62 a_16510_949# a_2595_952.t5 a_17275_949# VSS.t314 sg13_lv_nmos ad=0.2516p pd=2.16u as=0.1406p ps=1.12u w=0.74u l=0.13u
X63 a_8155_949# a_7945_949# VDD VDD sg13_lv_pmos ad=0.2128p pd=1.5u as=0.252p ps=1.57u w=1.12u l=0.13u
X64 VDD VSS.t362 VDD VDD sg13_lv_pmos ad=0.34p pd=2.68u as=0 ps=0 w=1u l=1u
X65 VSS.t11 a_3747_952.t2 a_27991_913# VSS.t10 sg13_lv_nmos ad=0.2516p pd=2.16u as=0.2516p ps=2.16u w=0.74u l=0.13u
X66 VSS.t5 a_3747_952.t9 a_6711_913# VSS.t4 sg13_lv_nmos ad=0.2516p pd=2.16u as=0.2516p ps=2.16u w=0.74u l=0.13u
X67 a_16108_194# a_2595_216.t2 a_19550_949# VSS.t87 sg13_lv_nmos ad=0.2516p pd=2.16u as=0.2516p ps=2.16u w=0.74u l=0.13u
X68 VSS.t253 VDD VSS.t252 VSS.t251 sg13_lv_nmos ad=0.1428p pd=1.52u as=0 ps=0 w=0.42u l=1u
X69 a_7390_949# a_8231_913# a_8155_949# VDD sg13_lv_pmos ad=0.3808p pd=2.92u as=0.2128p ps=1.5u w=1.12u l=0.13u
X70 VSS.t218 VDD VSS.t217 VSS.t216 sg13_lv_nmos ad=0.1428p pd=1.52u as=0 ps=0 w=0.42u l=1u
X71 a_3171_216.t0 a_2873_236# VSS.t101 VSS.t329 sg13_lv_nmos ad=0.1406p pd=1.12u as=0.1331p ps=1.12u w=0.74u l=0.13u
X72 a_5731_194# a_5705_424# a_4350_949# VDD sg13_lv_pmos ad=0.3808p pd=2.92u as=0.3808p ps=2.92u w=1.12u l=0.13u
X73 VDD a_2873_236# a_3171_216.t1 VDD sg13_lv_pmos ad=0.4256p pd=3u as=0.2128p ps=1.5u w=1.12u l=0.13u
X74 a_3747_216.t0 a_3449_236# VSS.t83 VSS.t110 sg13_lv_nmos ad=0.1406p pd=1.12u as=0.1331p ps=1.12u w=0.74u l=0.13u
X75 VDD a_3449_236# a_3747_216.t1 VDD sg13_lv_pmos ad=0.4256p pd=3u as=0.2128p ps=1.5u w=1.12u l=0.13u
X76 a_7390_949# a_2019_952.t8 a_7288_949# VSS.t119 sg13_lv_nmos ad=0.2516p pd=2.16u as=0.1406p ps=1.12u w=0.74u l=0.13u
X77 VDD DELAY_OUT_TAP21 a_20105_949# VDD sg13_lv_pmos ad=0.252p pd=1.57u as=0.3808p ps=2.92u w=1.12u l=0.13u
X78 a_19550_949# a_21044_913# a_20968_949# VDD sg13_lv_pmos ad=0.3808p pd=2.92u as=0.2128p ps=1.5u w=1.12u l=0.13u
X79 VDD VSS.t365 VDD VDD sg13_lv_pmos ad=0.19p pd=1.38u as=0 ps=0 w=1u l=1u
X80 VDD VSS.t379 VDD VDD sg13_lv_pmos ad=0.19p pd=1.38u as=0 ps=0 w=1u l=1u
X81 VDD a_3171_952.t7 a_11924_913# VDD sg13_lv_pmos ad=0.3808p pd=2.92u as=0.3808p ps=2.92u w=1.12u l=0.13u
X82 VSS.t343 a_2019_952.t4 a_19524_913# VSS.t342 sg13_lv_nmos ad=0.2516p pd=2.16u as=0.2516p ps=2.16u w=0.74u l=0.13u
X83 a_15755_949# a_15545_949# VSS.t137 VSS.t136 sg13_lv_nmos ad=0.1406p pd=1.12u as=0.1665p ps=1.19u w=0.74u l=0.13u
X84 VSS.t124 a_2595_952.t6 a_14311_913# VSS.t123 sg13_lv_nmos ad=0.2516p pd=2.16u as=0.2516p ps=2.16u w=0.74u l=0.13u
X85 a_5115_949# a_4905_949# VSS.t140 VSS.t139 sg13_lv_nmos ad=0.1406p pd=1.12u as=0.1665p ps=1.19u w=0.74u l=0.13u
X86 a_27915_949# a_27705_949# VDD VDD sg13_lv_pmos ad=0.2128p pd=1.5u as=0.252p ps=1.57u w=1.12u l=0.13u
X87 VSS.t210 VDD VSS.t208 VSS.t209 sg13_lv_nmos ad=79.8f pd=0.8u as=0 ps=0 w=0.42u l=1u
X88 a_23355_949# a_23145_949# VDD VDD sg13_lv_pmos ad=0.2128p pd=1.5u as=0.252p ps=1.57u w=1.12u l=0.13u
X89 VDD a_2019_952.t8 a_7364_913# VDD sg13_lv_pmos ad=0.3808p pd=2.92u as=0.3808p ps=2.92u w=1.12u l=0.13u
X90 VSS.t331 a_2873_236# a_3171_216.t0 VSS.t330 sg13_lv_nmos ad=0.2812p pd=2.24u as=0.1406p ps=1.12u w=0.74u l=0.13u
X91 VDD VSS.t390 VDD VDD sg13_lv_pmos ad=0.34p pd=2.68u as=0 ps=0 w=1u l=1u
X92 a_25630_949# a_27991_913# a_27915_949# VDD sg13_lv_pmos ad=0.3808p pd=2.92u as=0.2128p ps=1.5u w=1.12u l=0.13u
X93 VSS.t112 a_3449_236# a_3747_216.t0 VSS.t111 sg13_lv_nmos ad=0.2812p pd=2.24u as=0.1406p ps=1.12u w=0.74u l=0.13u
X94 VSS.t48 DELAY_OUT_TAP23 a_21625_949# VSS.t47 sg13_lv_nmos ad=0.1665p pd=1.19u as=0.2516p ps=2.16u w=0.74u l=0.13u
X95 a_22590_949# a_23431_913# a_23355_949# VDD sg13_lv_pmos ad=0.3808p pd=2.92u as=0.2128p ps=1.5u w=1.12u l=0.13u
X96 a_16108_194# a_20905_424# a_19550_949# VDD sg13_lv_pmos ad=0.3808p pd=2.92u as=0.3808p ps=2.92u w=1.12u l=0.13u
X97 VDD a_2595_952.t6 a_14311_913# VDD sg13_lv_pmos ad=0.3808p pd=2.92u as=0.3808p ps=2.92u w=1.12u l=0.13u
X98 VSS.t340 a_2019_952.t9 a_4324_913# VSS.t339 sg13_lv_nmos ad=0.2516p pd=2.16u as=0.2516p ps=2.16u w=0.74u l=0.13u
X99 a_16510_949# a_3747_952.t5 a_18795_949# VSS.t54 sg13_lv_nmos ad=0.2516p pd=2.16u as=0.1406p ps=1.12u w=0.74u l=0.13u
X100 VDD a_3747_952.t5 a_18871_913# VDD sg13_lv_pmos ad=0.3808p pd=2.92u as=0.3808p ps=2.92u w=1.12u l=0.13u
X101 VSS.t98 a_3171_216.t3 a_11785_424# VSS.t97 sg13_lv_nmos ad=0.2516p pd=2.16u as=0.2516p ps=2.16u w=0.74u l=0.13u
X102 VDD a_3747_952.t8 a_9751_913# VDD sg13_lv_pmos ad=0.3808p pd=2.92u as=0.3808p ps=2.92u w=1.12u l=0.13u
X103 VDD a_2595_952.t9 a_5191_913# VDD sg13_lv_pmos ad=0.3808p pd=2.92u as=0.3808p ps=2.92u w=1.12u l=0.13u
X104 a_10430_949# a_2019_952.t7 a_10328_949# VSS.t63 sg13_lv_nmos ad=0.2516p pd=2.16u as=0.1406p ps=1.12u w=0.74u l=0.13u
X105 a_4157_1218# DELAY_OUT_TAP0 VSS.t50 VSS.t49 sg13_lv_nmos ad=0.2516p pd=2.16u as=0.2553p ps=2.17u w=0.74u l=0.13u
X106 a_7390_949# a_3171_952.t8 a_8808_949# VSS.t26 sg13_lv_nmos ad=0.2516p pd=2.16u as=0.1406p ps=1.12u w=0.74u l=0.13u
X107 VSS.t137 DELAY_OUT_TAP15 a_15545_949# VSS.t298 sg13_lv_nmos ad=0.1665p pd=1.19u as=0.2516p ps=2.16u w=0.74u l=0.13u
X108 VDD a_2019_952.t3 a_22564_913# VDD sg13_lv_pmos ad=0.3808p pd=2.92u as=0.3808p ps=2.92u w=1.12u l=0.13u
X109 a_14888_949# DELAY_OUT_TAP14 VDD VDD sg13_lv_pmos ad=0.2128p pd=1.5u as=0.3808p ps=2.92u w=1.12u l=0.13u
X110 VSS.t322 a_3171_952.t7 a_11924_913# VSS.t321 sg13_lv_nmos ad=0.2516p pd=2.16u as=0.2516p ps=2.16u w=0.74u l=0.13u
X111 VDD VSS.t366 VDD VDD sg13_lv_pmos ad=0.34p pd=2.68u as=0 ps=0 w=1u l=1u
X112 VDD a_3171_952.t2 a_27124_913# VDD sg13_lv_pmos ad=0.3808p pd=2.92u as=0.3808p ps=2.92u w=1.12u l=0.13u
X113 a_10328_949# DELAY_OUT_TAP8 VDD VDD sg13_lv_pmos ad=0.2128p pd=1.5u as=0.3808p ps=2.92u w=1.12u l=0.13u
X114 a_19448_949# DELAY_OUT_TAP20 VDD VDD sg13_lv_pmos ad=0.2128p pd=1.5u as=0.3808p ps=2.92u w=1.12u l=0.13u
X115 VDD VSS.t380 VDD VDD sg13_lv_pmos ad=0.34p pd=2.68u as=0 ps=0 w=1u l=1u
X116 a_3171_952.t0 a_2873_1300# VSS.t285 VSS.t299 sg13_lv_nmos ad=0.1406p pd=1.12u as=0.1331p ps=1.12u w=0.74u l=0.13u
X117 a_25630_949# a_2019_952.t2 a_25528_949# VSS.t29 sg13_lv_nmos ad=0.2516p pd=2.16u as=0.1406p ps=1.12u w=0.74u l=0.13u
X118 VSS.t351 a_2297_1300# a_2595_952.t0 VSS.t350 sg13_lv_nmos ad=0.2812p pd=2.24u as=0.1406p ps=1.12u w=0.74u l=0.13u
X119 a_16108_194# a_2019_216# a_16510_949# VSS.t107 sg13_lv_nmos ad=0.2516p pd=2.16u as=0.2516p ps=2.16u w=0.74u l=0.13u
X120 a_2391_1300# MUX_SEL0 a_2297_1300# VSS.t169 sg13_lv_nmos ad=0.1216p pd=1.02u as=0.2176p ps=1.96u w=0.64u l=0.13u
X121 VSS.t270 VDD VSS.t268 VSS.t269 sg13_lv_nmos ad=79.8f pd=0.8u as=0 ps=0 w=0.42u l=1u
X122 VSS.t183 a_1544_949# a_1815_1300# VSS.t276 sg13_lv_nmos ad=0.1331p pd=1.12u as=0.1216p ps=1.02u w=0.64u l=0.13u
X123 a_5768_949# DELAY_OUT_TAP2 VDD VDD sg13_lv_pmos ad=0.2128p pd=1.5u as=0.3808p ps=2.92u w=1.12u l=0.13u
X124 VSS.t273 VDD VSS.t272 VSS.t271 sg13_lv_nmos ad=0.1428p pd=1.52u as=0 ps=0 w=0.42u l=1u
X125 a_16510_949# a_2019_952.t5 a_16408_949# VSS.t72 sg13_lv_nmos ad=0.2516p pd=2.16u as=0.1406p ps=1.12u w=0.74u l=0.13u
X126 VDD a_2595_952.t4 a_20391_913# VDD sg13_lv_pmos ad=0.3808p pd=2.92u as=0.3808p ps=2.92u w=1.12u l=0.13u
X127 VSS.t71 a_3171_952.t2 a_27124_913# VSS.t70 sg13_lv_nmos ad=0.2516p pd=2.16u as=0.2516p ps=2.16u w=0.74u l=0.13u
X128 a_5731_194# a_2595_216.t3 a_7390_949# VSS.t156 sg13_lv_nmos ad=0.2516p pd=2.16u as=0.2516p ps=2.16u w=0.74u l=0.13u
X129 VDD a_3171_216.t3 a_11785_424# VDD sg13_lv_pmos ad=0.3808p pd=2.92u as=0.3808p ps=2.92u w=1.12u l=0.13u
X130 a_10430_949# a_2595_952.t7 a_11195_949# VSS.t57 sg13_lv_nmos ad=0.2516p pd=2.16u as=0.1406p ps=1.12u w=0.74u l=0.13u
X131 a_23355_949# a_23145_949# VSS.t39 VSS.t90 sg13_lv_nmos ad=0.1406p pd=1.12u as=0.1665p ps=1.19u w=0.74u l=0.13u
X132 VSS.t190 VDD VSS.t187 VSS.t189 sg13_lv_nmos ad=79.8f pd=0.8u as=0 ps=0 w=0.42u l=1u
X133 VSS.t46 a_3747_952.t4 a_21911_913# VSS.t45 sg13_lv_nmos ad=0.2516p pd=2.16u as=0.2516p ps=2.16u w=0.74u l=0.13u
X134 VSS.t161 a_3747_216.t2 a_26985_424# VSS.t160 sg13_lv_nmos ad=0.2516p pd=2.16u as=0.2516p ps=2.16u w=0.74u l=0.13u
X135 a_20968_949# DELAY_OUT_TAP22 VSS.t78 VSS.t77 sg13_lv_nmos ad=0.1406p pd=1.12u as=0.2516p ps=2.16u w=0.74u l=0.13u
X136 VDD VSS.t383 VDD VDD sg13_lv_pmos ad=0.19p pd=1.38u as=0 ps=0 w=1u l=1u
X137 a_13470_949# a_14964_913# a_14888_949# VDD sg13_lv_pmos ad=0.3808p pd=2.92u as=0.2128p ps=1.5u w=1.12u l=0.13u
X138 VDD DELAY_OUT_TAP19 a_18585_949# VDD sg13_lv_pmos ad=0.252p pd=1.57u as=0.3808p ps=2.92u w=1.12u l=0.13u
X139 a_10430_949# a_10404_913# a_10328_949# VDD sg13_lv_pmos ad=0.3808p pd=2.92u as=0.2128p ps=1.5u w=1.12u l=0.13u
X140 a_19550_949# a_19524_913# a_19448_949# VDD sg13_lv_pmos ad=0.3808p pd=2.92u as=0.2128p ps=1.5u w=1.12u l=0.13u
X141 a_2595_216.t1 a_2297_236# VDD VDD sg13_lv_pmos ad=0.2128p pd=1.5u as=0.1918p ps=1.5u w=1.12u l=0.13u
X142 a_19448_949# DELAY_OUT_TAP20 VSS.t304 VSS.t303 sg13_lv_nmos ad=0.1406p pd=1.12u as=0.2516p ps=2.16u w=0.74u l=0.13u
X143 a_10430_949# a_3171_952.t7 a_11848_949# VSS.t320 sg13_lv_nmos ad=0.2516p pd=2.16u as=0.1406p ps=1.12u w=0.74u l=0.13u
X144 a_11195_949# a_10985_949# VDD VDD sg13_lv_pmos ad=0.2128p pd=1.5u as=0.252p ps=1.57u w=1.12u l=0.13u
X145 a_25630_949# a_2595_952.t2 a_26395_949# VSS.t286 sg13_lv_nmos ad=0.2516p pd=2.16u as=0.1406p ps=1.12u w=0.74u l=0.13u
X146 VDD a_1721_236# a_2019_216# VDD sg13_lv_pmos ad=0.4256p pd=3u as=0.2128p ps=1.5u w=1.12u l=0.13u
X147 VDD DELAY_OUT_TAP1 a_4905_949# VDD sg13_lv_pmos ad=0.252p pd=1.57u as=0.3808p ps=2.92u w=1.12u l=0.13u
X148 VSS.t230 VDD VSS.t228 VSS.t229 sg13_lv_nmos ad=79.8f pd=0.8u as=0 ps=0 w=0.42u l=1u
X149 VDD a_2297_236# a_2595_216.t1 VDD sg13_lv_pmos ad=0.4256p pd=3u as=0.2128p ps=1.5u w=1.12u l=0.13u
X150 a_4350_949# a_5844_913# a_5768_949# VDD sg13_lv_pmos ad=0.3808p pd=2.92u as=0.2128p ps=1.5u w=1.12u l=0.13u
X151 a_3449_1300# MUX_SEL0 VDD VDD sg13_lv_pmos ad=0.1596p pd=1.22u as=0.2856p ps=2.36u w=0.84u l=0.13u
X152 VDD DELAY_OUT_TAP7 a_9465_949# VDD sg13_lv_pmos ad=0.252p pd=1.57u as=0.3808p ps=2.92u w=1.12u l=0.13u
X153 VSS.t129 DELAY_OUT_TAP3 a_6425_949# VSS.t173 sg13_lv_nmos ad=0.1665p pd=1.19u as=0.2516p ps=2.16u w=0.74u l=0.13u
X154 a_10430_949# a_11271_913# a_11195_949# VDD sg13_lv_pmos ad=0.3808p pd=2.92u as=0.2128p ps=1.5u w=1.12u l=0.13u
X155 a_20968_949# DELAY_OUT_TAP22 VDD VDD sg13_lv_pmos ad=0.2128p pd=1.5u as=0.3808p ps=2.92u w=1.12u l=0.13u
X156 VSS.t282 a_2019_952.t6 a_13444_913# VSS.t281 sg13_lv_nmos ad=0.2516p pd=2.16u as=0.2516p ps=2.16u w=0.74u l=0.13u
X157 a_16108_194# a_17865_424# a_16510_949# VDD sg13_lv_pmos ad=0.3808p pd=2.92u as=0.3808p ps=2.92u w=1.12u l=0.13u
X158 VSS.t153 a_15964_194# a_16851_214# VSS.t162 sg13_lv_nmos ad=0.1371p pd=1.12u as=0.2176p ps=1.96u w=0.64u l=0.13u
X159 a_25528_949# DELAY_OUT_TAP28 VDD VDD sg13_lv_pmos ad=0.2128p pd=1.5u as=0.3808p ps=2.92u w=1.12u l=0.13u
X160 VDD a_1256_949# a_2873_1300# VDD sg13_lv_pmos ad=0.1918p pd=1.5u as=0.1596p ps=1.22u w=0.84u l=0.13u
X161 a_4248_949# a_4157_1218# VSS.t131 VSS.t130 sg13_lv_nmos ad=0.1406p pd=1.12u as=0.2516p ps=2.16u w=0.74u l=0.13u
X162 a_16108_194# a_3171_216.t2 a_22590_949# VSS.t84 sg13_lv_nmos ad=0.2516p pd=2.16u as=0.2516p ps=2.16u w=0.74u l=0.13u
X163 VSS.t250 VDD VSS.t248 VSS.t249 sg13_lv_nmos ad=79.8f pd=0.8u as=0 ps=0 w=0.42u l=1u
X164 a_19550_949# a_3747_952.t4 a_21835_949# VSS.t44 sg13_lv_nmos ad=0.2516p pd=2.16u as=0.1406p ps=1.12u w=0.74u l=0.13u
X165 VSS.t39 DELAY_OUT_TAP25 a_23145_949# VSS.t38 sg13_lv_nmos ad=0.1665p pd=1.19u as=0.2516p ps=2.16u w=0.74u l=0.13u
X166 a_5731_194# a_8745_424# a_7390_949# VDD sg13_lv_pmos ad=0.3808p pd=2.92u as=0.3808p ps=2.92u w=1.12u l=0.13u
X167 a_2595_216.t0 a_2297_236# VSS.t17 VSS.t51 sg13_lv_nmos ad=0.1406p pd=1.12u as=0.1331p ps=1.12u w=0.74u l=0.13u
X168 VDD a_3747_216.t2 a_26985_424# VDD sg13_lv_pmos ad=0.3808p pd=2.92u as=0.3808p ps=2.92u w=1.12u l=0.13u
X169 a_10430_949# a_3747_952.t7 a_12715_949# VSS.t32 sg13_lv_nmos ad=0.2516p pd=2.16u as=0.1406p ps=1.12u w=0.74u l=0.13u
X170 VSS.t328 a_1721_236# a_2019_216# VSS.t327 sg13_lv_nmos ad=0.2812p pd=2.24u as=0.1406p ps=1.12u w=0.74u l=0.13u
X171 a_24875_949# a_24665_949# VSS.t13 VSS.t12 sg13_lv_nmos ad=0.1406p pd=1.12u as=0.1665p ps=1.19u w=0.74u l=0.13u
X172 VSS.t53 a_2297_236# a_2595_216.t0 VSS.t52 sg13_lv_nmos ad=0.2812p pd=2.24u as=0.1406p ps=1.12u w=0.74u l=0.13u
X173 VSS.t62 a_2595_952.t3 a_23431_913# VSS.t61 sg13_lv_nmos ad=0.2516p pd=2.16u as=0.2516p ps=2.16u w=0.74u l=0.13u
X174 VDD MUX_SEL1 a_3449_1300# VDD sg13_lv_pmos ad=0.1918p pd=1.5u as=0.1596p ps=1.22u w=0.84u l=0.13u
X175 VSS.t188 VDD VSS.t187 VSS.t186 sg13_lv_nmos ad=0.1428p pd=1.52u as=0 ps=0 w=0.42u l=1u
X176 VSS.t103 DELAY_OUT_TAP13 a_14025_949# VSS.t291 sg13_lv_nmos ad=0.1665p pd=1.19u as=0.2516p ps=2.16u w=0.74u l=0.13u
X177 a_22590_949# a_24084_913# a_24008_949# VDD sg13_lv_pmos ad=0.3808p pd=2.92u as=0.2128p ps=1.5u w=1.12u l=0.13u
X178 VDD VSS.t359 VDD VDD sg13_lv_pmos ad=0.19p pd=1.38u as=0 ps=0 w=1u l=1u
X179 VDD DELAY_OUT_TAP27 a_24665_949# VDD sg13_lv_pmos ad=0.252p pd=1.57u as=0.3808p ps=2.92u w=1.12u l=0.13u
X180 VDD a_3171_952.t6 a_14964_913# VDD sg13_lv_pmos ad=0.3808p pd=2.92u as=0.3808p ps=2.92u w=1.12u l=0.13u
X181 a_25630_949# a_25604_913# a_25528_949# VDD sg13_lv_pmos ad=0.3808p pd=2.92u as=0.2128p ps=1.5u w=1.12u l=0.13u
X182 a_3171_952.t1 a_2873_1300# VDD VDD sg13_lv_pmos ad=0.2128p pd=1.5u as=0.1918p ps=1.5u w=1.12u l=0.13u
X183 a_3747_952.t1 a_3449_1300# VDD VDD sg13_lv_pmos ad=0.2128p pd=1.5u as=0.1918p ps=1.5u w=1.12u l=0.13u
X184 VDD VSS.t358 VDD VDD sg13_lv_pmos ad=0.34p pd=2.68u as=0 ps=0 w=1u l=1u
X185 VDD a_2019_952.t5 a_16484_913# VDD sg13_lv_pmos ad=0.3808p pd=2.92u as=0.3808p ps=2.92u w=1.12u l=0.13u
X186 a_22590_949# a_3171_952.t3 a_24008_949# VSS.t66 sg13_lv_nmos ad=0.2516p pd=2.16u as=0.1406p ps=1.12u w=0.74u l=0.13u
X187 VDD a_15964_194# a_16851_214# VDD sg13_lv_pmos ad=0.2086p pd=1.5u as=0.34p ps=2.68u w=1u l=0.13u
X188 a_26395_949# a_26185_949# VDD VDD sg13_lv_pmos ad=0.2128p pd=1.5u as=0.252p ps=1.57u w=1.12u l=0.13u
X189 a_3747_952.t0 a_3449_1300# VSS.t142 VSS.t141 sg13_lv_nmos ad=0.1406p pd=1.12u as=0.1331p ps=1.12u w=0.74u l=0.13u
X190 a_25630_949# a_3747_952.t2 a_27915_949# VSS.t9 sg13_lv_nmos ad=0.2516p pd=2.16u as=0.1406p ps=1.12u w=0.74u l=0.13u
X191 VSS.t245 VDD VSS.t243 VSS.t244 sg13_lv_nmos ad=79.8f pd=0.8u as=0 ps=0 w=0.42u l=1u
X192 VDD VSS.t391 VDD VDD sg13_lv_pmos ad=0.19p pd=1.38u as=0 ps=0 w=1u l=1u
X193 a_2967_1300# MUX_SEL1 a_2873_1300# VSS.t176 sg13_lv_nmos ad=0.1216p pd=1.02u as=0.2176p ps=1.96u w=0.64u l=0.13u
X194 VDD a_3171_952.t9 a_5844_913# VDD sg13_lv_pmos ad=0.3808p pd=2.92u as=0.3808p ps=2.92u w=1.12u l=0.13u
X195 VSS.t240 VDD VSS.t238 VSS.t239 sg13_lv_nmos ad=79.8f pd=0.8u as=0 ps=0 w=0.42u l=1u
X196 VSS.t213 VDD VSS.t212 VSS.t211 sg13_lv_nmos ad=0.1428p pd=1.52u as=0 ps=0 w=0.42u l=1u
X197 a_25630_949# a_26471_913# a_26395_949# VDD sg13_lv_pmos ad=0.3808p pd=2.92u as=0.2128p ps=1.5u w=1.12u l=0.13u
X198 a_3543_236# MUX_SEL2 a_3449_236# VSS.t43 sg13_lv_nmos ad=0.1216p pd=1.02u as=0.2176p ps=1.96u w=0.64u l=0.13u
X199 a_16108_194# a_23945_424# a_22590_949# VDD sg13_lv_pmos ad=0.3808p pd=2.92u as=0.3808p ps=2.92u w=1.12u l=0.13u
X200 VDD a_2595_952.t5 a_17351_913# VDD sg13_lv_pmos ad=0.3808p pd=2.92u as=0.3808p ps=2.92u w=1.12u l=0.13u
X201 VDD a_3747_952.t7 a_12791_913# VDD sg13_lv_pmos ad=0.3808p pd=2.92u as=0.3808p ps=2.92u w=1.12u l=0.13u
X202 a_8155_949# a_7945_949# VSS.t311 VSS.t310 sg13_lv_nmos ad=0.1406p pd=1.12u as=0.1665p ps=1.19u w=0.74u l=0.13u
X203 a_27048_949# DELAY_OUT_TAP30 VSS.t164 VSS.t163 sg13_lv_nmos ad=0.1406p pd=1.12u as=0.2516p ps=2.16u w=0.74u l=0.13u
X204 a_5768_949# DELAY_OUT_TAP2 VSS.t166 VSS.t165 sg13_lv_nmos ad=0.1406p pd=1.12u as=0.2516p ps=2.16u w=0.74u l=0.13u
X205 VSS.t127 a_3747_216.t3 a_14825_424# VSS.t126 sg13_lv_nmos ad=0.2516p pd=2.16u as=0.2516p ps=2.16u w=0.74u l=0.13u
X206 VSS.t101 a_1256_194# a_2967_236# VSS.t100 sg13_lv_nmos ad=0.1331p pd=1.12u as=0.1216p ps=1.02u w=0.64u l=0.13u
X207 VSS.t248 VDD VSS.t247 VSS.t246 sg13_lv_nmos ad=0.1428p pd=1.52u as=0 ps=0 w=0.42u l=1u
X208 VDD VSS.t375 VDD VDD sg13_lv_pmos ad=0.19p pd=1.38u as=0 ps=0 w=1u l=1u
X209 VDD a_2873_1300# a_3171_952.t1 VDD sg13_lv_pmos ad=0.4256p pd=3u as=0.2128p ps=1.5u w=1.12u l=0.13u
X210 VSS.t13 DELAY_OUT_TAP27 a_24665_949# VSS.t309 sg13_lv_nmos ad=0.1665p pd=1.19u as=0.2516p ps=2.16u w=0.74u l=0.13u
X211 VDD a_2595_952.t8 a_8231_913# VDD sg13_lv_pmos ad=0.3808p pd=2.92u as=0.3808p ps=2.92u w=1.12u l=0.13u
X212 a_16510_949# a_3171_952.t5 a_17928_949# VSS.t91 sg13_lv_nmos ad=0.2516p pd=2.16u as=0.1406p ps=1.12u w=0.74u l=0.13u
X213 VDD a_3449_1300# a_3747_952.t1 VDD sg13_lv_pmos ad=0.4256p pd=3u as=0.2128p ps=1.5u w=1.12u l=0.13u
X214 VSS.t118 a_3171_952.t4 a_21044_913# VSS.t117 sg13_lv_nmos ad=0.2516p pd=2.16u as=0.2516p ps=2.16u w=0.74u l=0.13u
X215 VDD VSS.t367 VDD VDD sg13_lv_pmos ad=0.19p pd=1.38u as=0 ps=0 w=1u l=1u
X216 VSS.t83 MUX_SEL3 a_3543_236# VSS.t82 sg13_lv_nmos ad=0.1331p pd=1.12u as=0.1216p ps=1.02u w=0.64u l=0.13u
X217 VDD a_3171_952.t4 a_21044_913# VDD sg13_lv_pmos ad=0.3808p pd=2.92u as=0.3808p ps=2.92u w=1.12u l=0.13u
X218 a_13368_949# DELAY_OUT_TAP12 VDD VDD sg13_lv_pmos ad=0.2128p pd=1.5u as=0.3808p ps=2.92u w=1.12u l=0.13u
X219 VSS.t301 a_2873_1300# a_3171_952.t0 VSS.t300 sg13_lv_nmos ad=0.2812p pd=2.24u as=0.1406p ps=1.12u w=0.74u l=0.13u
X220 a_13368_949# DELAY_OUT_TAP12 VSS.t353 VSS.t352 sg13_lv_nmos ad=0.1406p pd=1.12u as=0.2516p ps=2.16u w=0.74u l=0.13u
X221 a_5731_194# a_3171_216.t3 a_10430_949# VSS.t96 sg13_lv_nmos ad=0.2516p pd=2.16u as=0.2516p ps=2.16u w=0.74u l=0.13u
X222 VSS.t278 a_1544_949# a_2391_1300# VSS.t277 sg13_lv_nmos ad=0.1331p pd=1.12u as=0.1216p ps=1.02u w=0.64u l=0.13u
X223 a_2019_952.t0 a_1721_1300# VSS.t183 VSS.t182 sg13_lv_nmos ad=0.1406p pd=1.12u as=0.1331p ps=1.12u w=0.74u l=0.13u
X224 a_4350_949# a_3747_952.t9 a_6635_949# VSS.t3 sg13_lv_nmos ad=0.2516p pd=2.16u as=0.1406p ps=1.12u w=0.74u l=0.13u
X225 a_19550_949# a_2595_952.t4 a_20315_949# VSS.t113 sg13_lv_nmos ad=0.2516p pd=2.16u as=0.1406p ps=1.12u w=0.74u l=0.13u
X226 a_8808_949# DELAY_OUT_TAP6 VDD VDD sg13_lv_pmos ad=0.2128p pd=1.5u as=0.3808p ps=2.92u w=1.12u l=0.13u
X227 VSS.t311 DELAY_OUT_TAP5 a_7945_949# VSS.t356 sg13_lv_nmos ad=0.1665p pd=1.19u as=0.2516p ps=2.16u w=0.74u l=0.13u
X228 a_2019_216# a_1721_236# VDD VDD sg13_lv_pmos ad=0.2128p pd=1.5u as=0.1918p ps=1.5u w=1.12u l=0.13u
X229 VSS.t243 VDD VSS.t242 VSS.t241 sg13_lv_nmos ad=0.1428p pd=1.52u as=0 ps=0 w=0.42u l=1u
X230 a_4248_949# a_4157_1218# VDD VDD sg13_lv_pmos ad=0.2128p pd=1.5u as=0.3808p ps=2.92u w=1.12u l=0.13u
X231 VDD VSS.t392 VDD VDD sg13_lv_pmos ad=0.34p pd=2.68u as=0 ps=0 w=1u l=1u
X232 VSS.t208 VDD VSS.t207 VSS.t206 sg13_lv_nmos ad=0.1428p pd=1.52u as=0 ps=0 w=0.42u l=1u
X233 VSS.t238 VDD VSS.t237 VSS.t236 sg13_lv_nmos ad=0.1428p pd=1.52u as=0 ps=0 w=0.42u l=1u
X234 VDD a_2595_952.t3 a_23431_913# VDD sg13_lv_pmos ad=0.3808p pd=2.92u as=0.3808p ps=2.92u w=1.12u l=0.13u
X235 VDD a_3747_216.t3 a_14825_424# VDD sg13_lv_pmos ad=0.3808p pd=2.92u as=0.3808p ps=2.92u w=1.12u l=0.13u
X236 VDD a_3747_952.t2 a_27991_913# VDD sg13_lv_pmos ad=0.3808p pd=2.92u as=0.3808p ps=2.92u w=1.12u l=0.13u
X237 a_2297_1300# MUX_SEL0 VDD VDD sg13_lv_pmos ad=0.1596p pd=1.22u as=0.2856p ps=2.36u w=0.84u l=0.13u
X238 a_9675_949# a_9465_949# VSS.t295 VSS.t312 sg13_lv_nmos ad=0.1406p pd=1.12u as=0.1665p ps=1.19u w=0.74u l=0.13u
X239 VSS.t205 VDD VSS.t203 VSS.t204 sg13_lv_nmos ad=79.8f pd=0.8u as=0 ps=0 w=0.42u l=1u
X240 a_2873_1300# MUX_SEL1 VDD VDD sg13_lv_pmos ad=0.1596p pd=1.22u as=0.2856p ps=2.36u w=0.84u l=0.13u
X241 VSS.t346 a_2595_952.t8 a_8231_913# VSS.t345 sg13_lv_nmos ad=0.2516p pd=2.16u as=0.2516p ps=2.16u w=0.74u l=0.13u
X242 VSS.t89 a_2595_216.t2 a_20905_424# VSS.t88 sg13_lv_nmos ad=0.2516p pd=2.16u as=0.2516p ps=2.16u w=0.74u l=0.13u
X243 a_3449_236# MUX_SEL2 VDD VDD sg13_lv_pmos ad=0.1596p pd=1.22u as=0.2856p ps=2.36u w=0.84u l=0.13u
X244 VDD DELAY_OUT_TAP11 a_12505_949# VDD sg13_lv_pmos ad=0.252p pd=1.57u as=0.3808p ps=2.92u w=1.12u l=0.13u
X245 VDD VSS.t369 VDD VDD sg13_lv_pmos ad=0.19p pd=1.38u as=0 ps=0 w=1u l=1u
X246 a_13470_949# a_13444_913# a_13368_949# VDD sg13_lv_pmos ad=0.3808p pd=2.92u as=0.2128p ps=1.5u w=1.12u l=0.13u
X247 VDD DELAY_OUT_TAP17 a_17065_949# VDD sg13_lv_pmos ad=0.252p pd=1.57u as=0.3808p ps=2.92u w=1.12u l=0.13u
X248 a_16510_949# a_18004_913# a_17928_949# VDD sg13_lv_pmos ad=0.3808p pd=2.92u as=0.2128p ps=1.5u w=1.12u l=0.13u
X249 a_19550_949# a_2019_952.t4 a_19448_949# VSS.t341 sg13_lv_nmos ad=0.2516p pd=2.16u as=0.1406p ps=1.12u w=0.74u l=0.13u
X250 VDD VSS.t371 VDD VDD sg13_lv_pmos ad=0.19p pd=1.38u as=0 ps=0 w=1u l=1u
X251 VDD VSS.t382 VDD VDD sg13_lv_pmos ad=0.34p pd=2.68u as=0 ps=0 w=1u l=1u
X252 VDD a_1256_194# a_2873_236# VDD sg13_lv_pmos ad=0.1918p pd=1.5u as=0.1596p ps=1.22u w=0.84u l=0.13u
X253 a_13470_949# a_2595_952.t6 a_14235_949# VSS.t122 sg13_lv_nmos ad=0.2516p pd=2.16u as=0.1406p ps=1.12u w=0.74u l=0.13u
X254 VSS.t25 a_2019_952.t3 a_22564_913# VSS.t24 sg13_lv_nmos ad=0.2516p pd=2.16u as=0.2516p ps=2.16u w=0.74u l=0.13u
X255 a_15755_949# a_15545_949# VDD VDD sg13_lv_pmos ad=0.2128p pd=1.5u as=0.252p ps=1.57u w=1.12u l=0.13u
X256 a_7390_949# a_8884_913# a_8808_949# VDD sg13_lv_pmos ad=0.3808p pd=2.92u as=0.2128p ps=1.5u w=1.12u l=0.13u
X257 a_2019_216# a_1721_236# VSS.t15 VSS.t326 sg13_lv_nmos ad=0.1406p pd=1.12u as=0.1331p ps=1.12u w=0.74u l=0.13u
X258 a_4350_949# a_4324_913# a_4248_949# VDD sg13_lv_pmos ad=0.3808p pd=2.92u as=0.2128p ps=1.5u w=1.12u l=0.13u
X259 VDD DELAY_OUT_TAP5 a_7945_949# VDD sg13_lv_pmos ad=0.252p pd=1.57u as=0.3808p ps=2.92u w=1.12u l=0.13u
X260 a_24008_949# DELAY_OUT_TAP26 VDD VDD sg13_lv_pmos ad=0.2128p pd=1.5u as=0.3808p ps=2.92u w=1.12u l=0.13u
X261 a_5731_194# a_11785_424# a_10430_949# VDD sg13_lv_pmos ad=0.3808p pd=2.92u as=0.3808p ps=2.92u w=1.12u l=0.13u
X262 a_5115_949# a_4905_949# VDD VDD sg13_lv_pmos ad=0.2128p pd=1.5u as=0.252p ps=1.57u w=1.12u l=0.13u
X263 VDD VSS.t368 VDD VDD sg13_lv_pmos ad=0.34p pd=2.68u as=0 ps=0 w=1u l=1u
X264 a_13470_949# a_15831_913# a_15755_949# VDD sg13_lv_pmos ad=0.3808p pd=2.92u as=0.2128p ps=1.5u w=1.12u l=0.13u
X265 a_17275_949# a_17065_949# VSS.t147 VSS.t146 sg13_lv_nmos ad=0.1406p pd=1.12u as=0.1665p ps=1.19u w=0.74u l=0.13u
X266 VDD a_1544_949# a_2297_1300# VDD sg13_lv_pmos ad=0.1918p pd=1.5u as=0.1596p ps=1.22u w=0.84u l=0.13u
X267 VSS.t319 a_3747_952.t6 a_15831_913# VSS.t318 sg13_lv_nmos ad=0.2516p pd=2.16u as=0.2516p ps=2.16u w=0.74u l=0.13u
X268 a_4350_949# a_2019_952.t9 a_4248_949# VSS.t338 sg13_lv_nmos ad=0.2516p pd=2.16u as=0.1406p ps=1.12u w=0.74u l=0.13u
X269 VSS.t200 VDD VSS.t198 VSS.t199 sg13_lv_nmos ad=79.8f pd=0.8u as=0 ps=0 w=0.42u l=1u
X270 a_6635_949# a_6425_949# VDD VDD sg13_lv_pmos ad=0.2128p pd=1.5u as=0.252p ps=1.57u w=1.12u l=0.13u
X271 a_14888_949# DELAY_OUT_TAP14 VSS.t306 VSS.t305 sg13_lv_nmos ad=0.1406p pd=1.12u as=0.2516p ps=2.16u w=0.74u l=0.13u
X272 a_16108_194# a_3747_216.t2 a_25630_949# VSS.t159 sg13_lv_nmos ad=0.2516p pd=2.16u as=0.2516p ps=2.16u w=0.74u l=0.13u
X273 VSS.t265 VDD VSS.t263 VSS.t264 sg13_lv_nmos ad=79.8f pd=0.8u as=0 ps=0 w=0.42u l=1u
X274 a_4350_949# a_5191_913# a_5115_949# VDD sg13_lv_pmos ad=0.3808p pd=2.92u as=0.2128p ps=1.5u w=1.12u l=0.13u
X275 VDD MUX_SEL3 a_3449_236# VDD sg13_lv_pmos ad=0.1918p pd=1.5u as=0.1596p ps=1.22u w=0.84u l=0.13u
X276 VSS.t295 DELAY_OUT_TAP7 a_9465_949# VSS.t294 sg13_lv_nmos ad=0.1665p pd=1.19u as=0.2516p ps=2.16u w=0.74u l=0.13u
X277 a_4350_949# a_6711_913# a_6635_949# VDD sg13_lv_pmos ad=0.3808p pd=2.92u as=0.2128p ps=1.5u w=1.12u l=0.13u
X278 VSS.t268 VDD VSS.t267 VSS.t266 sg13_lv_nmos ad=0.1428p pd=1.52u as=0 ps=0 w=0.42u l=1u
X279 VSS.t74 a_2019_952.t5 a_16484_913# VSS.t73 sg13_lv_nmos ad=0.2516p pd=2.16u as=0.2516p ps=2.16u w=0.74u l=0.13u
X280 VSS.t20 a_3171_952.t9 a_5844_913# VSS.t19 sg13_lv_nmos ad=0.2516p pd=2.16u as=0.2516p ps=2.16u w=0.74u l=0.13u
X281 VDD a_2595_216.t2 a_20905_424# VDD sg13_lv_pmos ad=0.3808p pd=2.92u as=0.3808p ps=2.92u w=1.12u l=0.13u
X282 VSS.t59 a_2595_952.t7 a_11271_913# VSS.t58 sg13_lv_nmos ad=0.2516p pd=2.16u as=0.2516p ps=2.16u w=0.74u l=0.13u
X283 VSS.t334 a_3747_952.t8 a_9751_913# VSS.t333 sg13_lv_nmos ad=0.2516p pd=2.16u as=0.2516p ps=2.16u w=0.74u l=0.13u
X284 a_1256_949# MUX_SEL0 VDD VDD sg13_lv_pmos ad=0.3808p pd=2.92u as=0.3808p ps=2.92u w=1.12u l=0.13u
X285 a_2391_236# MUX_SEL2 a_2297_236# VSS.t42 sg13_lv_nmos ad=0.1216p pd=1.02u as=0.2176p ps=1.96u w=0.64u l=0.13u
X286 a_2967_236# MUX_SEL3 a_2873_236# VSS.t81 sg13_lv_nmos ad=0.1216p pd=1.02u as=0.2176p ps=1.96u w=0.64u l=0.13u
X287 VDD DELAY_OUT_TAP31 a_27705_949# VDD sg13_lv_pmos ad=0.252p pd=1.57u as=0.3808p ps=2.92u w=1.12u l=0.13u
X288 VDD DELAY_OUT_TAP25 a_23145_949# VDD sg13_lv_pmos ad=0.252p pd=1.57u as=0.3808p ps=2.92u w=1.12u l=0.13u
X289 a_2595_952.t1 a_2297_1300# VDD VDD sg13_lv_pmos ad=0.2128p pd=1.5u as=0.1918p ps=1.5u w=1.12u l=0.13u
X290 VDD VSS.t370 VDD VDD sg13_lv_pmos ad=0.34p pd=2.68u as=0 ps=0 w=1u l=1u
X291 VDD a_2019_952.t7 a_10404_913# VDD sg13_lv_pmos ad=0.3808p pd=2.92u as=0.3808p ps=2.92u w=1.12u l=0.13u
X292 VDD a_2019_952.t4 a_19524_913# VDD sg13_lv_pmos ad=0.3808p pd=2.92u as=0.3808p ps=2.92u w=1.12u l=0.13u
X293 VDD VSS.t384 VDD VDD sg13_lv_pmos ad=0.34p pd=2.68u as=0 ps=0 w=1u l=1u
X294 a_20315_949# a_20105_949# VDD VDD sg13_lv_pmos ad=0.2128p pd=1.5u as=0.252p ps=1.57u w=1.12u l=0.13u
X295 a_1544_949# MUX_SEL1 VSS.t175 VSS.t174 sg13_lv_nmos ad=0.2516p pd=2.16u as=0.2516p ps=2.16u w=0.74u l=0.13u
X296 VDD VSS.t372 VDD VDD sg13_lv_pmos ad=0.34p pd=2.68u as=0 ps=0 w=1u l=1u
X297 a_13470_949# a_3747_952.t6 a_15755_949# VSS.t317 sg13_lv_nmos ad=0.2516p pd=2.16u as=0.1406p ps=1.12u w=0.74u l=0.13u
X298 VSS.t144 a_3449_1300# a_3747_952.t0 VSS.t143 sg13_lv_nmos ad=0.2812p pd=2.24u as=0.1406p ps=1.12u w=0.74u l=0.13u
X299 a_4350_949# a_2595_952.t9 a_5115_949# VSS.t335 sg13_lv_nmos ad=0.2516p pd=2.16u as=0.1406p ps=1.12u w=0.74u l=0.13u
X300 VDD a_1721_1300# a_2019_952.t1 VDD sg13_lv_pmos ad=0.4256p pd=3u as=0.2128p ps=1.5u w=1.12u l=0.13u
X301 VSS.t288 a_2595_952.t2 a_26471_913# VSS.t287 sg13_lv_nmos ad=0.2516p pd=2.16u as=0.2516p ps=2.16u w=0.74u l=0.13u
X302 VSS.t260 VDD VSS.t258 VSS.t259 sg13_lv_nmos ad=79.8f pd=0.8u as=0 ps=0 w=0.42u l=1u
X303 a_21835_949# a_21625_949# VDD VDD sg13_lv_pmos ad=0.2128p pd=1.5u as=0.252p ps=1.57u w=1.12u l=0.13u
X304 a_3543_1300# MUX_SEL0 a_3449_1300# VSS.t170 sg13_lv_nmos ad=0.1216p pd=1.02u as=0.2176p ps=1.96u w=0.64u l=0.13u
X305 VDD a_2297_1300# a_2595_952.t1 VDD sg13_lv_pmos ad=0.4256p pd=3u as=0.2128p ps=1.5u w=1.12u l=0.13u
X306 VSS.t147 DELAY_OUT_TAP17 a_17065_949# VSS.t302 sg13_lv_nmos ad=0.1665p pd=1.19u as=0.2516p ps=2.16u w=0.74u l=0.13u
X307 VDD VSS.t385 VDD VDD sg13_lv_pmos ad=0.19p pd=1.38u as=0 ps=0 w=1u l=1u
X308 VSS.t225 VDD VSS.t223 VSS.t224 sg13_lv_nmos ad=79.8f pd=0.8u as=0 ps=0 w=0.42u l=1u
X309 a_19550_949# a_20391_913# a_20315_949# VDD sg13_lv_pmos ad=0.3808p pd=2.92u as=0.2128p ps=1.5u w=1.12u l=0.13u
X310 VSS.t228 VDD VSS.t227 VSS.t226 sg13_lv_nmos ad=0.1428p pd=1.52u as=0 ps=0 w=0.42u l=1u
X311 a_1544_949# MUX_SEL1 VDD VDD sg13_lv_pmos ad=0.3808p pd=2.92u as=0.3808p ps=2.92u w=1.12u l=0.13u
X312 a_16108_194# a_26985_424# a_25630_949# VDD sg13_lv_pmos ad=0.3808p pd=2.92u as=0.3808p ps=2.92u w=1.12u l=0.13u
X313 a_19550_949# a_21911_913# a_21835_949# VDD sg13_lv_pmos ad=0.3808p pd=2.92u as=0.2128p ps=1.5u w=1.12u l=0.13u
X314 VDD a_3747_952.t6 a_15831_913# VDD sg13_lv_pmos ad=0.3808p pd=2.92u as=0.3808p ps=2.92u w=1.12u l=0.13u
X315 a_18795_949# a_18585_949# VSS.t95 VSS.t94 sg13_lv_nmos ad=0.1406p pd=1.12u as=0.1665p ps=1.19u w=0.74u l=0.13u
X316 a_25630_949# a_3171_952.t2 a_27048_949# VSS.t69 sg13_lv_nmos ad=0.2516p pd=2.16u as=0.1406p ps=1.12u w=0.74u l=0.13u
X317 VSS.t316 a_2595_952.t5 a_17351_913# VSS.t315 sg13_lv_nmos ad=0.2516p pd=2.16u as=0.2516p ps=2.16u w=0.74u l=0.13u
X318 a_4350_949# a_3171_952.t9 a_5768_949# VSS.t18 sg13_lv_nmos ad=0.2516p pd=2.16u as=0.1406p ps=1.12u w=0.74u l=0.13u
X319 VSS.t109 a_2019_216# a_17865_424# VSS.t108 sg13_lv_nmos ad=0.2516p pd=2.16u as=0.2516p ps=2.16u w=0.74u l=0.13u
X320 VSS.t17 a_1544_194# a_2391_236# VSS.t16 sg13_lv_nmos ad=0.1331p pd=1.12u as=0.1216p ps=1.02u w=0.64u l=0.13u
X321 VSS.t121 a_2019_952.t8 a_7364_913# VSS.t120 sg13_lv_nmos ad=0.2516p pd=2.16u as=0.2516p ps=2.16u w=0.74u l=0.13u
X322 VSS.t106 a_2019_216# a_5705_424# VSS.t105 sg13_lv_nmos ad=0.2516p pd=2.16u as=0.2516p ps=2.16u w=0.74u l=0.13u
X323 MUX_OUT a_16851_214# VDD VDD sg13_lv_pmos ad=0.2128p pd=1.5u as=0.2086p ps=1.5u w=1.12u l=0.13u
X324 a_22488_949# DELAY_OUT_TAP24 VSS.t76 VSS.t75 sg13_lv_nmos ad=0.1406p pd=1.12u as=0.2516p ps=2.16u w=0.74u l=0.13u
X325 VDD VSS.t387 VDD VDD sg13_lv_pmos ad=0.19p pd=1.38u as=0 ps=0 w=1u l=1u
X326 VDD VSS.t361 VDD VDD sg13_lv_pmos ad=0.19p pd=1.38u as=0 ps=0 w=1u l=1u
X327 a_16408_949# DELAY_OUT_TAP16 VDD VDD sg13_lv_pmos ad=0.2128p pd=1.5u as=0.3808p ps=2.92u w=1.12u l=0.13u
X328 a_13470_949# a_2019_952.t6 a_13368_949# VSS.t280 sg13_lv_nmos ad=0.2516p pd=2.16u as=0.1406p ps=1.12u w=0.74u l=0.13u
X329 a_15964_194# a_15765_368# a_5731_194# VSS.t37 sg13_lv_nmos ad=0.2183p pd=1.33u as=0.2516p ps=2.16u w=0.74u l=0.13u
X330 VDD a_2019_952.t2 a_25604_913# VDD sg13_lv_pmos ad=0.3808p pd=2.92u as=0.3808p ps=2.92u w=1.12u l=0.13u
X331 a_2595_952.t0 a_2297_1300# VSS.t278 VSS.t349 sg13_lv_nmos ad=0.1406p pd=1.12u as=0.1331p ps=1.12u w=0.74u l=0.13u
X332 a_17928_949# DELAY_OUT_TAP18 VDD VDD sg13_lv_pmos ad=0.2128p pd=1.5u as=0.3808p ps=2.92u w=1.12u l=0.13u
X333 VSS.t68 a_3171_952.t3 a_24084_913# VSS.t67 sg13_lv_nmos ad=0.2516p pd=2.16u as=0.2516p ps=2.16u w=0.74u l=0.13u
X334 VDD VSS.t360 VDD VDD sg13_lv_pmos ad=0.34p pd=2.68u as=0 ps=0 w=1u l=1u
X335 a_2297_236# MUX_SEL2 VDD VDD sg13_lv_pmos ad=0.1596p pd=1.22u as=0.2856p ps=2.36u w=0.84u l=0.13u
X336 a_1815_1300# a_1256_949# a_1721_1300# VSS.t283 sg13_lv_nmos ad=0.1216p pd=1.02u as=0.2176p ps=1.96u w=0.64u l=0.13u
X337 a_2873_236# MUX_SEL3 VDD VDD sg13_lv_pmos ad=0.1596p pd=1.22u as=0.2856p ps=2.36u w=0.84u l=0.13u
X338 VSS.t95 DELAY_OUT_TAP19 a_18585_949# VSS.t354 sg13_lv_nmos ad=0.1665p pd=1.19u as=0.2516p ps=2.16u w=0.74u l=0.13u
X339 VSS.t258 VDD VSS.t257 VSS.t256 sg13_lv_nmos ad=0.1428p pd=1.52u as=0 ps=0 w=0.42u l=1u
X340 a_7288_949# DELAY_OUT_TAP4 VDD VDD sg13_lv_pmos ad=0.2128p pd=1.5u as=0.3808p ps=2.92u w=1.12u l=0.13u
X341 VSS.t223 VDD VSS.t222 VSS.t221 sg13_lv_nmos ad=0.1428p pd=1.52u as=0 ps=0 w=0.42u l=1u
X342 VSS.t235 VDD VSS.t233 VSS.t234 sg13_lv_nmos ad=79.8f pd=0.8u as=0 ps=0 w=0.42u l=1u
X343 VSS.t2 a_3171_952.t6 a_14964_913# VSS.t1 sg13_lv_nmos ad=0.2516p pd=2.16u as=0.2516p ps=2.16u w=0.74u l=0.13u
X344 VDD a_2019_216# a_17865_424# VDD sg13_lv_pmos ad=0.3808p pd=2.92u as=0.3808p ps=2.92u w=1.12u l=0.13u
X345 VDD a_3747_952.t4 a_21911_913# VDD sg13_lv_pmos ad=0.3808p pd=2.92u as=0.3808p ps=2.92u w=1.12u l=0.13u
X346 a_11195_949# a_10985_949# VSS.t133 VSS.t132 sg13_lv_nmos ad=0.1406p pd=1.12u as=0.1665p ps=1.19u w=0.74u l=0.13u
X347 a_1721_1300# a_1256_949# VDD VDD sg13_lv_pmos ad=0.1596p pd=1.22u as=0.2856p ps=2.36u w=0.84u l=0.13u
X348 VDD a_16851_214# MUX_OUT VDD sg13_lv_pmos ad=0.7336p pd=3.55u as=0.2128p ps=1.5u w=1.12u l=0.13u
X349 VSS.t86 a_3171_216.t2 a_23945_424# VSS.t85 sg13_lv_nmos ad=0.2516p pd=2.16u as=0.2516p ps=2.16u w=0.74u l=0.13u
X350 a_22590_949# a_2595_952.t3 a_23355_949# VSS.t60 sg13_lv_nmos ad=0.2516p pd=2.16u as=0.1406p ps=1.12u w=0.74u l=0.13u
X351 VSS.t325 MUX_SEL4 a_15765_368# VSS.t324 sg13_lv_nmos ad=0.2516p pd=2.16u as=0.2516p ps=2.16u w=0.74u l=0.13u
X352 a_16510_949# a_16484_913# a_16408_949# VDD sg13_lv_pmos ad=0.3808p pd=2.92u as=0.2128p ps=1.5u w=1.12u l=0.13u
X353 VDD VSS.t363 VDD VDD sg13_lv_pmos ad=0.19p pd=1.38u as=0 ps=0 w=1u l=1u
X354 VDD DELAY_OUT_TAP9 a_10985_949# VDD sg13_lv_pmos ad=0.252p pd=1.57u as=0.3808p ps=2.92u w=1.12u l=0.13u
X355 VDD a_1544_949# a_1721_1300# VDD sg13_lv_pmos ad=0.1918p pd=1.5u as=0.1596p ps=1.22u w=0.84u l=0.13u
X356 VDD VSS.t377 VDD VDD sg13_lv_pmos ad=0.19p pd=1.38u as=0 ps=0 w=1u l=1u
X357 VDD a_2019_216# a_5705_424# VDD sg13_lv_pmos ad=0.3808p pd=2.92u as=0.3808p ps=2.92u w=1.12u l=0.13u
X358 VDD VSS.t376 VDD VDD sg13_lv_pmos ad=0.34p pd=2.68u as=0 ps=0 w=1u l=1u
X359 VSS.t65 a_2019_952.t7 a_10404_913# VSS.t64 sg13_lv_nmos ad=0.2516p pd=2.16u as=0.2516p ps=2.16u w=0.74u l=0.13u
X360 VDD a_1544_194# a_2297_236# VDD sg13_lv_pmos ad=0.1918p pd=1.5u as=0.1596p ps=1.22u w=0.84u l=0.13u
X361 a_26395_949# a_26185_949# VSS.t36 VSS.t138 sg13_lv_nmos ad=0.1406p pd=1.12u as=0.1665p ps=1.19u w=0.74u l=0.13u
X362 VSS.t215 VDD VSS.t213 VSS.t214 sg13_lv_nmos ad=79.8f pd=0.8u as=0 ps=0 w=0.42u l=1u
X363 VSS.t8 a_3747_952.t3 a_24951_913# VSS.t7 sg13_lv_nmos ad=0.2516p pd=2.16u as=0.2516p ps=2.16u w=0.74u l=0.13u
X364 a_18795_949# a_18585_949# VDD VDD sg13_lv_pmos ad=0.2128p pd=1.5u as=0.252p ps=1.57u w=1.12u l=0.13u
X365 a_14235_949# a_14025_949# VDD VDD sg13_lv_pmos ad=0.2128p pd=1.5u as=0.252p ps=1.57u w=1.12u l=0.13u
X366 VDD DELAY_OUT_TAP3 a_6425_949# VDD sg13_lv_pmos ad=0.252p pd=1.57u as=0.3808p ps=2.92u w=1.12u l=0.13u
X367 a_7390_949# a_7364_913# a_7288_949# VDD sg13_lv_pmos ad=0.3808p pd=2.92u as=0.2128p ps=1.5u w=1.12u l=0.13u
X368 a_24008_949# DELAY_OUT_TAP26 VSS.t22 VSS.t21 sg13_lv_nmos ad=0.1406p pd=1.12u as=0.2516p ps=2.16u w=0.74u l=0.13u
X369 a_15964_194# MUX_SEL4 a_5731_194# VDD sg13_lv_pmos ad=0.3304p pd=1.71u as=0.3808p ps=2.92u w=1.12u l=0.13u
X370 a_1256_949# MUX_SEL0 VSS.t168 VSS.t167 sg13_lv_nmos ad=0.2516p pd=2.16u as=0.2516p ps=2.16u w=0.74u l=0.13u
X371 a_22488_949# DELAY_OUT_TAP24 VDD VDD sg13_lv_pmos ad=0.2128p pd=1.5u as=0.3808p ps=2.92u w=1.12u l=0.13u
X372 a_16510_949# a_18871_913# a_18795_949# VDD sg13_lv_pmos ad=0.3808p pd=2.92u as=0.2128p ps=1.5u w=1.12u l=0.13u
X373 a_27048_949# DELAY_OUT_TAP30 VDD VDD sg13_lv_pmos ad=0.2128p pd=1.5u as=0.3808p ps=2.92u w=1.12u l=0.13u
X374 a_13470_949# a_14311_913# a_14235_949# VDD sg13_lv_pmos ad=0.3808p pd=2.92u as=0.2128p ps=1.5u w=1.12u l=0.13u
X375 a_13470_949# a_3171_952.t6 a_14888_949# VSS.t0 sg13_lv_nmos ad=0.2516p pd=2.16u as=0.1406p ps=1.12u w=0.74u l=0.13u
X376 a_1256_194# MUX_SEL2 VSS.t41 VSS.t40 sg13_lv_nmos ad=0.2516p pd=2.16u as=0.2516p ps=2.16u w=0.74u l=0.13u
X377 a_9675_949# a_9465_949# VDD VDD sg13_lv_pmos ad=0.2128p pd=1.5u as=0.252p ps=1.57u w=1.12u l=0.13u
X378 VSS.t31 a_2019_952.t2 a_25604_913# VSS.t30 sg13_lv_nmos ad=0.2516p pd=2.16u as=0.2516p ps=2.16u w=0.74u l=0.13u
X379 a_16108_194# MUX_SEL4 a_15964_194# VSS.t323 sg13_lv_nmos ad=0.2516p pd=2.16u as=0.2183p ps=1.33u w=0.74u l=0.13u
X380 a_21835_949# a_21625_949# VSS.t48 VSS.t145 sg13_lv_nmos ad=0.1406p pd=1.12u as=0.1665p ps=1.19u w=0.74u l=0.13u
X381 VSS.t115 a_2595_952.t4 a_20391_913# VSS.t114 sg13_lv_nmos ad=0.2516p pd=2.16u as=0.2516p ps=2.16u w=0.74u l=0.13u
X382 a_2019_952.t1 a_1721_1300# VDD VDD sg13_lv_pmos ad=0.2128p pd=1.5u as=0.1918p ps=1.5u w=1.12u l=0.13u
X383 VSS.t133 DELAY_OUT_TAP9 a_10985_949# VSS.t279 sg13_lv_nmos ad=0.1665p pd=1.19u as=0.2516p ps=2.16u w=0.74u l=0.13u
X384 a_7390_949# a_9751_913# a_9675_949# VDD sg13_lv_pmos ad=0.3808p pd=2.92u as=0.2128p ps=1.5u w=1.12u l=0.13u
X385 VSS.t233 VDD VSS.t232 VSS.t231 sg13_lv_nmos ad=0.1428p pd=1.52u as=0 ps=0 w=0.42u l=1u
X386 VDD a_3171_216.t2 a_23945_424# VDD sg13_lv_pmos ad=0.3808p pd=2.92u as=0.3808p ps=2.92u w=1.12u l=0.13u
X387 VSS.t56 a_3747_952.t5 a_18871_913# VSS.t55 sg13_lv_nmos ad=0.2516p pd=2.16u as=0.2516p ps=2.16u w=0.74u l=0.13u
X388 a_12715_949# a_12505_949# VSS.t149 VSS.t148 sg13_lv_nmos ad=0.1406p pd=1.12u as=0.1665p ps=1.19u w=0.74u l=0.13u
X389 a_17928_949# DELAY_OUT_TAP18 VSS.t290 VSS.t289 sg13_lv_nmos ad=0.1406p pd=1.12u as=0.2516p ps=2.16u w=0.74u l=0.13u
X390 VDD MUX_SEL4 a_15765_368# VDD sg13_lv_pmos ad=0.3808p pd=2.92u as=0.3808p ps=2.92u w=1.12u l=0.13u
X391 a_19550_949# a_3171_952.t4 a_20968_949# VSS.t116 sg13_lv_nmos ad=0.2516p pd=2.16u as=0.1406p ps=1.12u w=0.74u l=0.13u
X392 a_7288_949# DELAY_OUT_TAP4 VSS.t172 VSS.t171 sg13_lv_nmos ad=0.1406p pd=1.12u as=0.2516p ps=2.16u w=0.74u l=0.13u
X393 a_1815_236# a_1256_194# a_1721_236# VSS.t99 sg13_lv_nmos ad=0.1216p pd=1.02u as=0.2176p ps=1.96u w=0.64u l=0.13u
X394 a_1544_194# MUX_SEL3 VSS.t80 VSS.t79 sg13_lv_nmos ad=0.2516p pd=2.16u as=0.2516p ps=2.16u w=0.74u l=0.13u
X395 a_22590_949# a_3747_952.t3 a_24875_949# VSS.t6 sg13_lv_nmos ad=0.2516p pd=2.16u as=0.1406p ps=1.12u w=0.74u l=0.13u
X396 VDD DELAY_OUT_TAP23 a_21625_949# VDD sg13_lv_pmos ad=0.252p pd=1.57u as=0.3808p ps=2.92u w=1.12u l=0.13u
X397 a_22590_949# a_22564_913# a_22488_949# VDD sg13_lv_pmos ad=0.3808p pd=2.92u as=0.2128p ps=1.5u w=1.12u l=0.13u
X398 VSS.t36 DELAY_OUT_TAP29 a_26185_949# VSS.t35 sg13_lv_nmos ad=0.1665p pd=1.19u as=0.2516p ps=2.16u w=0.74u l=0.13u
X399 VSS.t203 VDD VSS.t202 VSS.t201 sg13_lv_nmos ad=0.1428p pd=1.52u as=0 ps=0 w=0.42u l=1u
X400 VDD DELAY_OUT_TAP29 a_26185_949# VDD sg13_lv_pmos ad=0.252p pd=1.57u as=0.3808p ps=2.92u w=1.12u l=0.13u
X401 VSS.t140 DELAY_OUT_TAP1 a_4905_949# VSS.t178 sg13_lv_nmos ad=0.1665p pd=1.19u as=0.2516p ps=2.16u w=0.74u l=0.13u
X402 a_25630_949# a_27124_913# a_27048_949# VDD sg13_lv_pmos ad=0.3808p pd=2.92u as=0.2128p ps=1.5u w=1.12u l=0.13u
X403 VDD VSS.t364 VDD VDD sg13_lv_pmos ad=0.34p pd=2.68u as=0 ps=0 w=1u l=1u
X404 VDD a_2019_952.t6 a_13444_913# VDD sg13_lv_pmos ad=0.3808p pd=2.92u as=0.3808p ps=2.92u w=1.12u l=0.13u
X405 VSS.t28 a_3171_952.t8 a_8884_913# VSS.t27 sg13_lv_nmos ad=0.2516p pd=2.16u as=0.2516p ps=2.16u w=0.74u l=0.13u
X406 VDD VSS.t378 VDD VDD sg13_lv_pmos ad=0.34p pd=2.68u as=0 ps=0 w=1u l=1u
X407 VDD VSS.t373 VDD VDD sg13_lv_pmos ad=0.19p pd=1.38u as=0 ps=0 w=1u l=1u
X408 VSS.t15 a_1544_194# a_1815_236# VSS.t14 sg13_lv_nmos ad=0.1331p pd=1.12u as=0.1216p ps=1.02u w=0.64u l=0.13u
X409 VDD a_3171_952.t5 a_18004_913# VDD sg13_lv_pmos ad=0.3808p pd=2.92u as=0.3808p ps=2.92u w=1.12u l=0.13u
X410 VSS.t142 MUX_SEL1 a_3543_1300# VSS.t177 sg13_lv_nmos ad=0.1331p pd=1.12u as=0.1216p ps=1.02u w=0.64u l=0.13u
X411 a_27915_949# a_27705_949# VSS.t151 VSS.t150 sg13_lv_nmos ad=0.1406p pd=1.12u as=0.1665p ps=1.19u w=0.74u l=0.13u
X412 VSS.t275 VDD VSS.t273 VSS.t274 sg13_lv_nmos ad=79.8f pd=0.8u as=0 ps=0 w=0.42u l=1u
X413 a_24875_949# a_24665_949# VDD VDD sg13_lv_pmos ad=0.2128p pd=1.5u as=0.252p ps=1.57u w=1.12u l=0.13u
C0 a_19550_949# DELAY_OUT_TAP22 0.07996f
C1 a_22590_949# a_24665_949# 0.03208f
C2 VDD a_27915_949# 0.15389f
C3 VDD a_15755_949# 0.15389f
C4 a_14025_949# DELAY_OUT_TAP13 0.19203f
C5 a_9465_949# a_7390_949# 0.03208f
C6 DELAY_OUT_TAP11 DELAY_OUT_TAP10 0.03717f
C7 a_18795_949# a_18585_949# 0.09424f
C8 DELAY_OUT_TAP27 VDD 0.12759f
C9 a_19550_949# a_21911_913# 0.26208f
C10 a_7945_949# DELAY_OUT_TAP5 0.19203f
C11 DELAY_OUT_TAP6 a_7390_949# 0.07996f
C12 VDD a_22590_949# 0.89557f
C13 a_2873_1300# MUX_SEL1 0.13092f
C14 a_16510_949# a_16484_913# 0.277f
C15 a_22564_913# a_22488_949# 0.01176f
C16 VDD a_17865_424# 0.29444f
C17 a_11848_949# VDD 0.17499f
C18 MUX_SEL3 a_3449_236# 0.28429f
C19 DELAY_OUT_TAP26 VDD 0.13878f
C20 VDD DELAY_OUT_TAP31 0.1288f
C21 a_13368_949# DELAY_OUT_TAP12 0.10864f
C22 VDD a_16851_214# 0.51536f
C23 a_7945_949# VDD 0.30333f
C24 MUX_SEL2 a_3449_236# 0.10741f
C25 a_23355_949# a_23145_949# 0.09424f
C26 VDD a_3449_1300# 0.46654f
C27 a_7390_949# a_8745_424# 0.01756f
C28 VDD a_11785_424# 0.29292f
C29 DELAY_OUT_TAP5 VDD 0.13651f
C30 a_5731_194# a_11785_424# 0.28056f
C31 DELAY_OUT_TAP2 DELAY_OUT_TAP1 0.02068f
C32 a_11924_913# DELAY_OUT_TAP10 0.02312f
C33 a_25630_949# a_25604_913# 0.277f
C34 VDD a_24665_949# 0.29646f
C35 a_19550_949# DELAY_OUT_TAP24 0.02437f
C36 a_17865_424# a_16510_949# 0.02165f
C37 a_7390_949# a_8155_949# 0.39037f
C38 a_4324_913# DELAY_OUT_TAP1 0.0501f
C39 DELAY_OUT_TAP5 a_7364_913# 0.0501f
C40 a_12505_949# DELAY_OUT_TAP11 0.2079f
C41 a_22564_913# DELAY_OUT_TAP25 0.0501f
C42 DELAY_OUT_TAP16 VDD 0.14932f
C43 a_17275_949# a_17065_949# 0.09424f
C44 a_16510_949# a_16851_214# 0.02131f
C45 a_7390_949# a_8231_913# 0.28268f
C46 a_4248_949# VDD 0.17587f
C47 a_18004_913# DELAY_OUT_TAP18 0.02312f
C48 VDD a_5731_194# 0.6143f
C49 a_19448_949# a_19524_913# 0.01176f
C50 DELAY_OUT_TAP31 a_27124_913# 0.02053f
C51 VDD a_20315_949# 0.15389f
C52 VDD a_7364_913# 0.28633f
C53 DELAY_OUT_TAP7 DELAY_OUT_TAP8 0.0331f
C54 a_22488_949# a_22590_949# 0.37183f
C55 a_13470_949# a_14825_424# 0.02058f
C56 a_26185_949# a_26395_949# 0.09424f
C57 a_19550_949# a_20105_949# 0.03209f
C58 a_22590_949# a_16108_194# 0.58202f
C59 a_17865_424# a_16108_194# 0.29564f
C60 VDD a_16510_949# 0.8795f
C61 DELAY_OUT_TAP0 a_3449_1300# 0.01044f
C62 VDD a_2297_236# 0.46496f
C63 a_13444_913# a_13470_949# 0.277f
C64 a_4350_949# a_4157_1218# 0.04624f
C65 VDD a_9751_913# 0.2822f
C66 DELAY_OUT_TAP30 DELAY_OUT_TAP31 0.03717f
C67 a_10404_913# DELAY_OUT_TAP9 0.0501f
C68 a_10430_949# DELAY_OUT_TAP10 0.07996f
C69 a_16108_194# a_16851_214# 0.06181f
C70 a_19550_949# DELAY_OUT_TAP21 0.10838f
C71 a_22590_949# a_23145_949# 0.03209f
C72 VDD a_1721_236# 0.45259f
C73 VDD a_27124_913# 0.28225f
C74 VDD a_14964_913# 0.28225f
C75 MUX_SEL4 DELAY_OUT_TAP4 0.0195f
C76 a_17351_913# VDD 0.28565f
C77 DELAY_OUT_TAP25 a_22590_949# 0.10838f
C78 a_10404_913# DELAY_OUT_TAP8 0.02011f
C79 a_15964_194# a_16851_214# 0.16757f
C80 a_7945_949# a_7390_949# 0.03209f
C81 a_6711_913# DELAY_OUT_TAP4 0.02339f
C82 MUX_OUT MUX_SEL1 0.09357f
C83 DELAY_OUT_TAP3 DELAY_OUT_TAP4 0.0331f
C84 VDD DELAY_OUT_TAP0 0.50967f
C85 VDD a_27048_949# 0.17499f
C86 DELAY_OUT_TAP25 DELAY_OUT_TAP26 0.02068f
C87 DELAY_OUT_TAP22 a_20391_913# 0.02334f
C88 VDD a_22488_949# 0.17274f
C89 a_2873_1300# MUX_SEL0 0.01504f
C90 DELAY_OUT_TAP5 a_7390_949# 0.10838f
C91 MUX_OUT a_2019_216# 8.45486f
C92 MUX_SEL4 MUX_SEL1 0.03574f
C93 VDD DELAY_OUT_TAP30 0.13878f
C94 a_25630_949# a_27915_949# 0.39036f
C95 VDD a_16108_194# 1.25759f
C96 a_5731_194# a_16108_194# 0.01334f
C97 MUX_SEL4 a_2019_216# 0.90276f
C98 a_12715_949# a_12791_913# 0.01194f
C99 a_17351_913# a_16510_949# 0.28268f
C100 DELAY_OUT_TAP16 a_15964_194# 0.02f
C101 VDD a_1544_949# 0.45004f
C102 a_7390_949# VDD 0.8686f
C103 DELAY_OUT_TAP28 a_25528_949# 0.10864f
C104 a_12505_949# a_10430_949# 0.03208f
C105 VDD DELAY_OUT_TAP29 0.13651f
C106 a_7390_949# a_5731_194# 0.41331f
C107 VDD a_15964_194# 0.31311f
C108 a_5191_913# DELAY_OUT_TAP2 0.02334f
C109 a_5731_194# a_15964_194# 0.2778f
C110 DELAY_OUT_TAP18 DELAY_OUT_TAP19 0.03717f
C111 MUX_SEL3 a_2873_236# 0.12606f
C112 a_11848_949# DELAY_OUT_TAP10 0.10863f
C113 a_13470_949# a_15755_949# 0.39036f
C114 a_5115_949# a_5191_913# 0.01194f
C115 a_20968_949# a_21044_913# 0.01176f
C116 VDD a_23145_949# 0.30333f
C117 a_25528_949# a_25604_913# 0.01176f
C118 a_19550_949# DELAY_OUT_TAP23 0.05189f
C119 a_7390_949# a_7364_913# 0.277f
C120 DELAY_OUT_TAP15 DELAY_OUT_TAP16 0.0331f
C121 a_4350_949# DELAY_OUT_TAP1 0.10838f
C122 DELAY_OUT_TAP28 a_24951_913# 0.02339f
C123 MUX_SEL0 MUX_SEL1 3.14917f
C124 DELAY_OUT_TAP25 VDD 0.13651f
C125 a_22564_913# DELAY_OUT_TAP24 0.02011f
C126 DELAY_OUT_TAP31 a_25630_949# 0.05211f
C127 MUX_SEL2 a_2873_236# 0.01422f
C128 a_27048_949# a_27124_913# 0.01176f
C129 DELAY_OUT_TAP15 VDD 0.12874f
C130 a_16510_949# a_16108_194# 0.56108f
C131 a_17928_949# DELAY_OUT_TAP18 0.10863f
C132 VDD a_1544_194# 0.39113f
C133 a_27705_949# a_27915_949# 0.09424f
C134 DELAY_OUT_TAP14 VDD 0.13878f
C135 a_5705_424# a_2019_216# 0.13872f
C136 a_22590_949# a_24875_949# 0.39036f
C137 a_18795_949# a_18871_913# 0.01194f
C138 a_16510_949# a_15964_194# 0.05416f
C139 DELAY_OUT_TAP30 a_27124_913# 0.02312f
C140 DELAY_OUT_TAP12 a_12791_913# 0.02339f
C141 a_14235_949# a_14025_949# 0.09424f
C142 VDD a_19524_913# 0.28633f
C143 a_7390_949# a_9751_913# 0.26208f
C144 DELAY_OUT_TAP30 a_27048_949# 0.10863f
C145 VDD DELAY_OUT_TAP10 0.13878f
C146 MUX_SEL4 MUX_OUT 0.91933f
C147 VDD a_25630_949# 0.89531f
C148 a_19550_949# a_21835_949# 0.39036f
C149 VDD a_21625_949# 0.29646f
C150 DELAY_OUT_TAP31 a_27705_949# 0.2079f
C151 a_2873_236# a_1256_194# 0.27926f
C152 a_2297_236# a_1544_194# 0.27303f
C153 a_13444_913# a_13368_949# 0.01176f
C154 VDD a_4905_949# 0.3005f
C155 DELAY_OUT_TAP16 a_13470_949# 0.02437f
C156 DELAY_OUT_TAP19 a_18585_949# 0.2079f
C157 a_24665_949# a_24875_949# 0.09424f
C158 a_10430_949# DELAY_OUT_TAP9 0.10838f
C159 a_20105_949# a_20391_913# 0.01885f
C160 DELAY_OUT_TAP15 a_14964_913# 0.02053f
C161 a_13470_949# VDD 0.87936f
C162 a_13470_949# a_5731_194# 0.41365f
C163 a_1721_236# a_1544_194# 0.36963f
C164 DELAY_OUT_TAP29 DELAY_OUT_TAP30 0.02068f
C165 DELAY_OUT_TAP22 VDD 0.13878f
C166 a_17275_949# VDD 0.15389f
C167 DELAY_OUT_TAP12 DELAY_OUT_TAP13 0.06596f
C168 a_15964_194# a_16108_194# 0.42202f
C169 DELAY_OUT_TAP14 a_14964_913# 0.02312f
C170 VDD a_24875_949# 0.15406f
C171 a_19448_949# DELAY_OUT_TAP20 0.10864f
C172 VDD MUX_SEL3 0.4053f
C173 VDD a_21911_913# 0.2822f
C174 a_15545_949# a_15755_949# 0.09424f
C175 VDD a_1721_1300# 0.45305f
C176 VDD a_27705_949# 0.29842f
C177 a_18871_913# DELAY_OUT_TAP20 0.02339f
C178 a_12505_949# VDD 0.29646f
C179 VDD MUX_SEL2 0.50938f
C180 DELAY_OUT_TAP2 DELAY_OUT_TAP3 0.03717f
C181 a_6425_949# a_6711_913# 0.01885f
C182 DELAY_OUT_TAP8 a_10328_949# 0.10864f
C183 a_6425_949# DELAY_OUT_TAP3 0.2079f
C184 a_25630_949# a_27124_913# 0.28279f
C185 a_4350_949# DELAY_OUT_TAP4 0.02437f
C186 MUX_SEL4 a_5705_424# 0.03556f
C187 a_17275_949# a_16510_949# 0.39037f
C188 VDD a_1256_949# 0.47094f
C189 DELAY_OUT_TAP25 a_23145_949# 0.19203f
C190 a_15765_368# a_2019_216# 0.05969f
C191 a_7288_949# VDD 0.17274f
C192 a_10985_949# a_10430_949# 0.03209f
C193 a_25630_949# a_27048_949# 0.38994f
C194 MUX_SEL3 a_2297_236# 0.01595f
C195 a_13470_949# a_14964_913# 0.28279f
C196 a_10430_949# a_11271_913# 0.28268f
C197 a_4350_949# a_5191_913# 0.28268f
C198 a_7288_949# a_7364_913# 0.01176f
C199 MUX_SEL4 DELAY_OUT_TAP12 0.01829f
C200 a_17275_949# a_17351_913# 0.01194f
C201 a_14235_949# a_14311_913# 0.01194f
C202 DELAY_OUT_TAP3 a_5844_913# 0.02053f
C203 DELAY_OUT_TAP24 VDD 0.14794f
C204 DELAY_OUT_TAP30 a_25630_949# 0.07996f
C205 a_22590_949# a_24951_913# 0.26208f
C206 MUX_SEL2 a_2297_236# 0.10655f
C207 a_16108_194# a_25630_949# 0.55833f
C208 a_4350_949# a_2019_216# 0.02042f
C209 a_9465_949# a_9675_949# 0.09424f
C210 DELAY_OUT_TAP14 DELAY_OUT_TAP15 0.03717f
C211 VDD a_1256_194# 0.40292f
C212 DELAY_OUT_TAP27 a_24084_913# 0.02053f
C213 a_18795_949# VDD 0.15406f
C214 DELAY_OUT_TAP2 a_5844_913# 0.02312f
C215 DELAY_OUT_TAP7 a_8884_913# 0.02053f
C216 DELAY_OUT_TAP29 a_25630_949# 0.10838f
C217 MUX_SEL2 a_1721_236# 0.01315f
C218 a_26395_949# a_26471_913# 0.01194f
C219 a_22590_949# a_24084_913# 0.28279f
C220 a_3449_236# a_2019_216# 0.01176f
C221 DELAY_OUT_TAP26 a_24084_913# 0.02312f
C222 a_15545_949# VDD 0.29842f
C223 VDD DELAY_OUT_TAP9 0.13651f
C224 a_24665_949# a_24951_913# 0.01885f
C225 a_19550_949# a_21044_913# 0.28279f
C226 VDD a_25528_949# 0.17274f
C227 VDD a_20105_949# 0.30333f
C228 a_2297_236# a_1256_194# 0.04261f
C229 VDD a_2297_1300# 0.4651f
C230 a_18795_949# a_16510_949# 0.39036f
C231 VDD DELAY_OUT_TAP8 0.1474f
C232 a_4248_949# a_4157_1218# 0.11672f
C233 VDD a_4157_1218# 0.48906f
C234 DELAY_OUT_TAP15 a_13470_949# 0.05189f
C235 a_20105_949# a_20315_949# 0.09424f
C236 a_1721_1300# a_1544_949# 0.38063f
C237 VDD a_24951_913# 0.2822f
C238 a_19550_949# a_20968_949# 0.38994f
C239 a_13368_949# VDD 0.17274f
C240 MUX_SEL4 a_15765_368# 0.65508f
C241 a_27991_913# a_27915_949# 0.01194f
C242 a_1721_236# a_1256_194# 0.13421f
C243 a_16408_949# a_16484_913# 0.01176f
C244 DELAY_OUT_TAP21 VDD 0.13651f
C245 DELAY_OUT_TAP14 a_13470_949# 0.07996f
C246 a_8884_913# a_8808_949# 0.01176f
C247 a_6635_949# a_6711_913# 0.01194f
C248 DELAY_OUT_TAP24 a_22488_949# 0.10864f
C249 VDD a_24084_913# 0.28225f
C250 a_1256_949# a_1544_949# 1.26509f
C251 MUX_SEL3 a_1544_194# 0.15976f
C252 a_7288_949# a_7390_949# 0.37183f
C253 DELAY_OUT_TAP20 VDD 0.14794f
C254 DELAY_OUT_TAP24 a_16108_194# 0.0157f
C255 a_4350_949# MUX_SEL4 0.31434f
C256 VDD a_26185_949# 0.30333f
C257 a_10985_949# VDD 0.30333f
C258 MUX_SEL2 a_1544_194# 0.07405f
C259 a_6425_949# a_6635_949# 0.09424f
C260 DELAY_OUT_TAP8 a_9751_913# 0.02339f
C261 a_6711_913# a_4350_949# 0.26208f
C262 VDD a_11271_913# 0.28336f
C263 MUX_SEL4 a_3449_236# 0.05166f
C264 a_4350_949# DELAY_OUT_TAP3 0.05189f
C265 a_4350_949# DELAY_OUT_TAP2 0.07996f
C266 DELAY_OUT_TAP24 DELAY_OUT_TAP25 0.06596f
C267 DELAY_OUT_TAP17 DELAY_OUT_TAP18 0.02068f
C268 a_21911_913# a_21625_949# 0.01885f
C269 a_10430_949# a_11195_949# 0.39037f
C270 DELAY_OUT_TAP20 a_16510_949# 0.02437f
C271 a_6425_949# a_4350_949# 0.03208f
C272 a_4350_949# a_5115_949# 0.39037f
C273 DELAY_OUT_TAP0 a_4157_1218# 0.50642f
C274 a_4350_949# a_4324_913# 0.277f
C275 a_27705_949# a_25630_949# 0.03208f
C276 VDD DELAY_OUT_TAP1 0.13941f
C277 DELAY_OUT_TAP23 VDD 0.12759f
C278 a_10430_949# a_12791_913# 0.26208f
C279 a_4350_949# a_5705_424# 0.02005f
C280 VDD a_14888_949# 0.17499f
C281 a_1256_194# a_1544_194# 1.25711f
C282 VDD a_27991_913# 0.28201f
C283 a_18004_913# VDD 0.28225f
C284 DELAY_OUT_TAP2 a_5768_949# 0.10863f
C285 DELAY_OUT_TAP6 a_8884_913# 0.02312f
C286 a_22590_949# a_24008_949# 0.38994f
C287 a_2297_1300# a_1544_949# 0.28651f
C288 a_13444_913# DELAY_OUT_TAP13 0.0501f
C289 a_7390_949# DELAY_OUT_TAP8 0.02437f
C290 DELAY_OUT_TAP16 a_16408_949# 0.10864f
C291 a_4350_949# a_5844_913# 0.28279f
C292 DELAY_OUT_TAP15 a_15545_949# 0.2079f
C293 DELAY_OUT_TAP26 a_24008_949# 0.10863f
C294 VDD a_16408_949# 0.17274f
C295 MUX_SEL2 MUX_SEL3 3.21891f
C296 a_14025_949# VDD 0.30333f
C297 a_9675_949# VDD 0.15406f
C298 DELAY_OUT_TAP20 a_16108_194# 0.0157f
C299 VDD a_21835_949# 0.15406f
C300 a_5768_949# a_5844_913# 0.01176f
C301 a_18004_913# a_16510_949# 0.28279f
C302 a_1721_1300# a_1256_949# 0.13421f
C303 DELAY_OUT_TAP29 a_26185_949# 0.19203f
C304 MUX_SEL4 a_14825_424# 0.03307f
C305 a_14888_949# a_14964_913# 0.01176f
C306 DELAY_OUT_TAP0 DELAY_OUT_TAP1 0.04252f
C307 DELAY_OUT_TAP9 DELAY_OUT_TAP10 0.02068f
C308 a_16408_949# a_16510_949# 0.37183f
C309 DELAY_OUT_TAP11 DELAY_OUT_TAP12 0.0331f
C310 DELAY_OUT_TAP24 a_21911_913# 0.02339f
C311 VDD a_24008_949# 0.17499f
C312 DELAY_OUT_TAP5 DELAY_OUT_TAP4 0.06596f
C313 MUX_SEL3 a_1256_194# 1.41161f
C314 a_25528_949# a_25630_949# 0.37183f
C315 DELAY_OUT_TAP21 a_19524_913# 0.0501f
C316 a_17865_424# a_2019_216# 0.13959f
C317 VDD a_2873_1300# 0.46491f
C318 a_15545_949# a_13470_949# 0.03208f
C319 a_9675_949# a_9751_913# 0.01194f
C320 a_15755_949# a_15831_913# 0.01194f
C321 MUX_SEL4 a_8745_424# 0.04472f
C322 MUX_SEL2 a_1256_194# 0.33134f
C323 DELAY_OUT_TAP20 a_19524_913# 0.02011f
C324 a_3449_1300# MUX_SEL1 0.29404f
C325 a_16851_214# a_2019_216# 0.01299f
C326 a_6635_949# a_4350_949# 0.39036f
C327 VDD a_11195_949# 0.15389f
C328 DELAY_OUT_TAP4 VDD 0.14695f
C329 MUX_SEL4 a_10430_949# 0.24983f
C330 a_13368_949# a_13470_949# 0.37183f
C331 VDD a_12791_913# 0.2822f
C332 DELAY_OUT_TAP4 a_7364_913# 0.02011f
C333 DELAY_OUT_TAP19 VDD 0.12759f
C334 a_5191_913# VDD 0.28565f
C335 a_24951_913# a_24875_949# 0.01194f
C336 a_26185_949# a_25630_949# 0.03209f
C337 VDD MUX_SEL1 0.49936f
C338 DELAY_OUT_TAP10 a_11271_913# 0.02334f
C339 DELAY_OUT_TAP21 DELAY_OUT_TAP22 0.02068f
C340 MUX_SEL4 a_2873_236# 0.04916f
C341 a_10430_949# a_12715_949# 0.39036f
C342 VDD a_2019_216# 1.43004f
C343 VDD a_14311_913# 0.28336f
C344 a_5731_194# a_2019_216# 1.15781f
C345 a_7390_949# a_9675_949# 0.39036f
C346 a_17928_949# VDD 0.17499f
C347 DELAY_OUT_TAP14 a_14888_949# 0.10863f
C348 a_2297_1300# a_1256_949# 0.04619f
C349 a_4350_949# a_5768_949# 0.38994f
C350 DELAY_OUT_TAP16 a_15831_913# 0.02339f
C351 a_13444_913# DELAY_OUT_TAP12 0.02011f
C352 DELAY_OUT_TAP19 a_16510_949# 0.05189f
C353 VDD a_15831_913# 0.2816f
C354 DELAY_OUT_TAP13 VDD 0.13651f
C355 DELAY_OUT_TAP23 a_21625_949# 0.2079f
C356 MUX_OUT a_16851_214# 0.45865f
C357 a_4905_949# DELAY_OUT_TAP1 0.19203f
C358 a_8884_913# VDD 0.28225f
C359 a_16510_949# a_2019_216# 0.03139f
C360 a_27991_913# a_25630_949# 0.26208f
C361 a_2297_236# a_2019_216# 0.04011f
C362 a_17928_949# a_16510_949# 0.38994f
C363 VDD a_21044_913# 0.28225f
C364 a_10430_949# DELAY_OUT_TAP12 0.02437f
C365 DELAY_OUT_TAP17 a_17065_949# 0.19203f
C366 DELAY_OUT_TAP23 DELAY_OUT_TAP22 0.03717f
C367 a_13470_949# a_14888_949# 0.38994f
C368 a_1721_236# a_2019_216# 0.18452f
C369 a_9465_949# DELAY_OUT_TAP7 0.2079f
C370 a_19550_949# a_20905_424# 0.02165f
C371 VDD a_20968_949# 0.17499f
C372 MUX_SEL4 a_11785_424# 0.03255f
C373 DELAY_OUT_TAP0 MUX_SEL1 0.01783f
C374 a_18871_913# a_18585_949# 0.01885f
C375 VDD a_26471_913# 0.28336f
C376 DELAY_OUT_TAP6 DELAY_OUT_TAP7 0.03717f
C377 MUX_OUT VDD 0.35871f
C378 MUX_OUT a_5731_194# 1.04829f
C379 DELAY_OUT_TAP8 DELAY_OUT_TAP9 0.06596f
C380 a_14025_949# a_13470_949# 0.03209f
C381 a_21835_949# a_21625_949# 0.09424f
C382 a_26985_424# VDD 0.29292f
C383 MUX_SEL4 VDD 2.63157f
C384 a_27705_949# a_27991_913# 0.01885f
C385 MUX_SEL4 a_5731_194# 4.60702f
C386 MUX_SEL1 a_1544_949# 0.1672f
C387 a_16108_194# a_2019_216# 0.33889f
C388 a_3449_1300# MUX_SEL0 0.10753f
C389 a_6711_913# VDD 0.2822f
C390 a_23355_949# a_23431_913# 0.01194f
C391 DELAY_OUT_TAP3 VDD 0.12759f
C392 DELAY_OUT_TAP21 a_20105_949# 0.19203f
C393 a_15964_194# a_2019_216# 0.02413f
C394 a_11924_913# DELAY_OUT_TAP11 0.02053f
C395 a_19448_949# a_19550_949# 0.37183f
C396 MUX_OUT a_2297_236# 0.01179f
C397 VDD a_12715_949# 0.15406f
C398 DELAY_OUT_TAP2 VDD 0.13878f
C399 DELAY_OUT_TAP23 DELAY_OUT_TAP24 0.0331f
C400 a_10985_949# DELAY_OUT_TAP9 0.19203f
C401 DELAY_OUT_TAP18 VDD 0.13878f
C402 a_6425_949# VDD 0.29646f
C403 a_5115_949# VDD 0.15389f
C404 a_21911_913# a_21835_949# 0.01194f
C405 a_4324_913# a_4248_949# 0.01176f
C406 a_4324_913# VDD 0.28597f
C407 VDD MUX_SEL0 0.51342f
C408 DELAY_OUT_TAP6 a_8808_949# 0.10863f
C409 MUX_SEL4 a_2297_236# 0.04338f
C410 a_19550_949# a_20391_913# 0.28268f
C411 a_2019_216# a_1544_194# 0.01747f
C412 VDD a_5705_424# 0.29556f
C413 DELAY_OUT_TAP28 a_25604_913# 0.02011f
C414 a_5731_194# a_5705_424# 0.28954f
C415 a_7390_949# a_8884_913# 0.28279f
C416 DELAY_OUT_TAP20 DELAY_OUT_TAP21 0.06596f
C417 a_22590_949# a_23945_424# 0.02165f
C418 DELAY_OUT_TAP14 a_14311_913# 0.02334f
C419 MUX_SEL4 a_1721_236# 0.05813f
C420 VDD a_5844_913# 0.28225f
C421 DELAY_OUT_TAP30 a_26471_913# 0.02334f
C422 DELAY_OUT_TAP18 a_16510_949# 0.07996f
C423 DELAY_OUT_TAP17 a_16484_913# 0.0501f
C424 MUX_SEL4 DELAY_OUT_TAP0 0.06593f
C425 DELAY_OUT_TAP12 VDD 0.1474f
C426 a_10430_949# a_10404_913# 0.277f
C427 MUX_OUT a_16108_194# 0.24265f
C428 a_5191_913# a_4905_949# 0.01885f
C429 DELAY_OUT_TAP14 DELAY_OUT_TAP13 0.02068f
C430 a_4157_1218# DELAY_OUT_TAP1 0.01771f
C431 MUX_OUT a_1544_949# 0.04258f
C432 a_17351_913# DELAY_OUT_TAP18 0.02334f
C433 a_26985_424# a_16108_194# 0.2906f
C434 a_10430_949# DELAY_OUT_TAP11 0.05189f
C435 MUX_SEL4 a_16108_194# 0.1283f
C436 MUX_OUT a_15964_194# 0.01307f
C437 a_2873_1300# a_1256_949# 0.28892f
C438 a_10985_949# a_11271_913# 0.01885f
C439 a_23431_913# a_22590_949# 0.28268f
C440 a_10404_913# a_10328_949# 0.01176f
C441 MUX_SEL4 a_1544_949# 0.03407f
C442 a_13470_949# a_14311_913# 0.28268f
C443 VDD a_18585_949# 0.29646f
C444 a_7390_949# MUX_SEL4 0.34655f
C445 MUX_SEL4 a_15964_194# 0.5544f
C446 a_23431_913# DELAY_OUT_TAP26 0.02334f
C447 a_12505_949# a_12791_913# 0.01885f
C448 VDD a_23945_424# 0.29292f
C449 a_7288_949# DELAY_OUT_TAP4 0.10864f
C450 VDD a_26395_949# 0.15389f
C451 MUX_SEL3 a_2019_216# 0.06209f
C452 MUX_OUT a_1544_194# 0.69943f
C453 a_13470_949# a_15831_913# 0.26208f
C454 a_13470_949# DELAY_OUT_TAP13 0.10838f
C455 MUX_SEL4 a_1544_194# 0.47529f
C456 a_11924_913# a_10430_949# 0.28279f
C457 MUX_SEL1 a_1256_949# 1.44243f
C458 MUX_SEL0 a_1544_949# 0.07603f
C459 a_16510_949# a_18585_949# 0.03208f
C460 a_6635_949# VDD 0.15406f
C461 VDD a_15765_368# 0.35368f
C462 DELAY_OUT_TAP7 VDD 0.12759f
C463 a_5731_194# a_15765_368# 0.23301f
C464 a_25630_949# a_26471_913# 0.28268f
C465 DELAY_OUT_TAP22 a_21044_913# 0.02312f
C466 a_23431_913# VDD 0.28336f
C467 DELAY_OUT_TAP16 DELAY_OUT_TAP17 0.06596f
C468 a_14235_949# VDD 0.15389f
C469 a_19550_949# VDD 0.89766f
C470 DELAY_OUT_TAP17 VDD 0.1382f
C471 a_4350_949# a_4248_949# 0.37183f
C472 DELAY_OUT_TAP22 a_20968_949# 0.10863f
C473 a_26985_424# a_25630_949# 0.02165f
C474 a_4350_949# VDD 0.87635f
C475 a_4350_949# a_5731_194# 0.41099f
C476 DELAY_OUT_TAP6 a_8231_913# 0.02334f
C477 DELAY_OUT_TAP27 DELAY_OUT_TAP28 0.0331f
C478 a_19550_949# a_20315_949# 0.39037f
C479 DELAY_OUT_TAP28 a_22590_949# 0.02437f
C480 a_2019_216# a_1256_194# 0.02904f
C481 VDD a_3449_236# 0.46596f
C482 a_24008_949# a_24084_913# 0.01176f
C483 MUX_SEL4 a_13470_949# 0.256f
C484 a_10404_913# VDD 0.28633f
C485 MUX_OUT MUX_SEL3 0.79533f
C486 VDD a_5768_949# 0.17499f
C487 VDD a_8808_949# 0.17499f
C488 a_11848_949# a_11924_913# 0.01176f
C489 DELAY_OUT_TAP17 a_16510_949# 0.10838f
C490 MUX_SEL4 MUX_SEL3 0.75489f
C491 MUX_OUT MUX_SEL2 0.08497f
C492 a_23945_424# a_16108_194# 0.2906f
C493 DELAY_OUT_TAP11 VDD 0.12759f
C494 a_2297_1300# MUX_SEL1 0.01995f
C495 a_5115_949# a_4905_949# 0.09424f
C496 a_8155_949# a_8231_913# 0.01194f
C497 MUX_SEL4 MUX_SEL2 0.01978f
C498 MUX_OUT a_1256_949# 0.02466f
C499 a_4157_1218# a_2019_216# 0.01018f
C500 a_10985_949# a_11195_949# 0.09424f
C501 a_15545_949# a_15831_913# 0.01885f
C502 a_23355_949# a_22590_949# 0.39037f
C503 a_10430_949# a_10328_949# 0.37183f
C504 a_15765_368# a_16108_194# 0.42004f
C505 a_11195_949# a_11271_913# 0.01194f
C506 VDD a_17065_949# 0.30142f
C507 MUX_SEL4 a_1256_949# 0.04908f
C508 DELAY_OUT_TAP28 VDD 0.14794f
C509 DELAY_OUT_TAP19 DELAY_OUT_TAP20 0.0331f
C510 a_12505_949# a_12715_949# 0.09424f
C511 DELAY_OUT_TAP7 a_7390_949# 0.05189f
C512 VDD a_20905_424# 0.29292f
C513 a_22564_913# a_22590_949# 0.277f
C514 VDD a_25604_913# 0.28633f
C515 a_15765_368# a_15964_194# 0.061f
C516 DELAY_OUT_TAP5 DELAY_OUT_TAP6 0.02068f
C517 DELAY_OUT_TAP0 a_3449_236# 0.01017f
C518 a_11924_913# VDD 0.28225f
C519 MUX_OUT a_1256_194# 0.1134f
C520 a_1721_1300# MUX_SEL0 0.01315f
C521 a_19550_949# a_16108_194# 0.58202f
C522 MUX_SEL2 MUX_SEL0 0.01204f
C523 a_9465_949# VDD 0.29646f
C524 MUX_SEL4 a_1256_194# 0.65005f
C525 a_11848_949# a_10430_949# 0.38994f
C526 a_23431_913# a_23145_949# 0.01885f
C527 MUX_SEL0 a_1256_949# 0.3314f
C528 a_16510_949# a_17065_949# 0.03209f
C529 VDD a_14825_424# 0.29292f
C530 DELAY_OUT_TAP6 VDD 0.13878f
C531 a_5731_194# a_14825_424# 0.28056f
C532 a_7945_949# a_8155_949# 0.09424f
C533 a_25630_949# a_26395_949# 0.39037f
C534 a_23355_949# VDD 0.15389f
C535 a_13444_913# VDD 0.28633f
C536 a_10430_949# a_11785_424# 0.02058f
C537 a_7945_949# a_8231_913# 0.01885f
C538 a_17351_913# a_17065_949# 0.01885f
C539 a_19448_949# VDD 0.17274f
C540 a_7390_949# a_8808_949# 0.38994f
C541 a_18004_913# DELAY_OUT_TAP19 0.02053f
C542 VDD a_8745_424# 0.29292f
C543 a_22564_913# VDD 0.28633f
C544 a_5731_194# a_8745_424# 0.28635f
C545 a_19550_949# a_19524_913# 0.277f
C546 a_9465_949# a_9751_913# 0.01885f
C547 MUX_SEL4 DELAY_OUT_TAP8 0.01829f
C548 a_18871_913# VDD 0.2822f
C549 MUX_SEL4 a_4157_1218# 0.08229f
C550 DELAY_OUT_TAP27 a_22590_949# 0.05189f
C551 VDD a_20391_913# 0.28336f
C552 VDD a_8155_949# 0.15389f
C553 DELAY_OUT_TAP26 DELAY_OUT_TAP27 0.03717f
C554 a_10430_949# VDD 0.88416f
C555 a_17928_949# a_18004_913# 0.01176f
C556 a_10430_949# a_5731_194# 0.41176f
C557 a_20315_949# a_20391_913# 0.01194f
C558 DELAY_OUT_TAP26 a_22590_949# 0.07996f
C559 DELAY_OUT_TAP28 a_16108_194# 0.0157f
C560 VDD a_8231_913# 0.28336f
C561 a_26185_949# a_26471_913# 0.01885f
C562 a_19550_949# a_21625_949# 0.03208f
C563 DELAY_OUT_TAP16 a_16484_913# 0.02011f
C564 a_14025_949# a_14311_913# 0.01885f
C565 a_20905_424# a_16108_194# 0.2906f
C566 VDD a_16484_913# 0.28597f
C567 DELAY_OUT_TAP28 DELAY_OUT_TAP29 0.06596f
C568 VDD a_2873_236# 0.46491f
C569 a_2297_1300# MUX_SEL0 0.10655f
C570 a_14235_949# a_13470_949# 0.39037f
C571 a_4350_949# a_4905_949# 0.03209f
C572 DELAY_OUT_TAP23 a_21044_913# 0.02053f
C573 a_4324_913# a_4157_1218# 0.02463f
C574 VDD a_10328_949# 0.17274f
C575 a_18871_913# a_16510_949# 0.26208f
C576 DELAY_OUT_TAP29 a_25604_913# 0.0501f
C577 DELAY_OUT_TAP27 a_24665_949# 0.2079f
R0 VSS.n45 VSS.n5 16832
R1 VSS.t97 VSS.n5 140.651
R2 VSS.t189 VSS.n5 122.415
R3 VSS.n5 VSS.t236 68.6481
R4 VSS.t251 VSS.n5 68.6501
R5 VSS.n5 VSS.n10 0.481869
R6 VSS.n5 VSS.t37 22.4812
R7 VSS.n118 VSS.n5 0.456674
R8 VSS.n5 VSS.t271 58.1755
R9 VSS.n5 VSS.t229 116.828
R10 VSS.t211 VSS.n5 58.1721
R11 VSS.t82 VSS.n9 499.695
R12 VSS.t51 VSS.n14 486.031
R13 VSS.t176 VSS.n18 476.074
R14 VSS.t191 VSS.n5 68.6471
R15 VSS.t206 VSS.n5 68.6471
R16 VSS.t221 VSS.n5 68.6471
R17 VSS.t266 VSS.n5 68.6471
R18 VSS.t327 VSS.n11 71.035
R19 VSS.t300 VSS.n20 463.976
R20 VSS.n156 VSS.t14 436.62
R21 VSS.n266 VSS.t177 423.387
R22 VSS.n268 VSS.t349 411.291
R23 VSS.n99 VSS.t130 68.4917
R24 VSS.t165 VSS.n22 409.562
R25 VSS.t171 VSS.n24 409.562
R26 VSS.t296 VSS.n26 409.562
R27 VSS.t292 VSS.n27 409.562
R28 VSS.t179 VSS.n29 409.562
R29 VSS.t352 VSS.n30 409.562
R30 VSS.t305 VSS.n32 409.562
R31 VSS.t347 VSS.n33 409.562
R32 VSS.t289 VSS.n35 409.562
R33 VSS.t303 VSS.n36 409.562
R34 VSS.t77 VSS.n38 409.562
R35 VSS.t75 VSS.n39 409.562
R36 VSS.t21 VSS.n41 409.562
R37 VSS.t307 VSS.n42 409.562
R38 VSS.t163 VSS.n44 409.562
R39 VSS.n12 VSS.t16 417.714
R40 VSS.t79 VSS.n5 116.822
R41 VSS.t199 VSS.n5 116.828
R42 VSS.t214 VSS.n5 116.828
R43 VSS.t244 VSS.n5 116.828
R44 VSS.t259 VSS.n5 116.828
R45 VSS.n103 VSS.t283 403.493
R46 VSS.n269 VSS.t184 399.195
R47 VSS.n117 VSS.t110 404.05
R48 VSS.t338 VSS.n21 385.346
R49 VSS.t119 VSS.n25 385.346
R50 VSS.t63 VSS.n28 385.346
R51 VSS.t280 VSS.n31 385.346
R52 VSS.t72 VSS.n34 385.346
R53 VSS.t341 VSS.n37 385.346
R54 VSS.t23 VSS.n40 385.346
R55 VSS.t29 VSS.n43 385.346
R56 VSS.t186 VSS.n5 127.299
R57 VSS.t276 VSS.n248 375
R58 VSS.n5 VSS.t204 122.412
R59 VSS.n5 VSS.t219 122.412
R60 VSS.n5 VSS.t234 122.412
R61 VSS.n5 VSS.t249 122.412
R62 VSS.n5 VSS.t264 122.412
R63 VSS.t329 VSS.n149 366.197
R64 VSS.t201 VSS.n5 127.3
R65 VSS.n5 VSS.t216 127.3
R66 VSS.n5 VSS.t231 127.3
R67 VSS.t246 VSS.n5 127.3
R68 VSS.n5 VSS.t261 127.3
R69 VSS.n98 VSS.t178 355.127
R70 VSS.n94 VSS.t173 98.6395
R71 VSS.n91 VSS.t356 355.127
R72 VSS.n87 VSS.t294 98.6395
R73 VSS.n84 VSS.t279 355.127
R74 VSS.n80 VSS.t181 98.6395
R75 VSS.n77 VSS.t291 355.127
R76 VSS.n105 VSS.n110 0.423468
R77 VSS.n71 VSS.t302 355.127
R78 VSS.n105 VSS.n112 0.423468
R79 VSS.n65 VSS.t355 355.127
R80 VSS.n61 VSS.t47 98.6395
R81 VSS.n58 VSS.t38 355.127
R82 VSS.n54 VSS.t309 98.6395
R83 VSS.n51 VSS.t35 355.127
R84 VSS.n47 VSS.t313 98.6395
R85 VSS.n5 VSS.t104 133.32
R86 VSS.n5 VSS.t159 133.319
R87 VSS.n5 VSS.t85 140.651
R88 VSS.t87 VSS.n5 133.32
R89 VSS.t107 VSS.n5 133.32
R90 VSS.t125 VSS.n5 133.319
R91 VSS.t96 VSS.n5 133.32
R92 VSS.t156 VSS.n5 133.32
R93 VSS.t100 VSS.n149 352.113
R94 VSS.t277 VSS.n249 350.807
R95 VSS.n98 VSS.t339 349.077
R96 VSS.n23 VSS.t19 101.647
R97 VSS.n91 VSS.t120 349.077
R98 VSS.n105 VSS.n107 0.0156714
R99 VSS.n84 VSS.t64 349.077
R100 VSS.n105 VSS.n108 0.0156714
R101 VSS.n77 VSS.t281 349.077
R102 VSS.n105 VSS.n109 0.0156714
R103 VSS.n71 VSS.t73 349.077
R104 VSS.n105 VSS.n111 0.0156714
R105 VSS.n65 VSS.t342 349.077
R106 VSS.n105 VSS.n113 0.0156714
R107 VSS.n58 VSS.t24 349.077
R108 VSS.n105 VSS.n114 0.0156714
R109 VSS.n51 VSS.t30 349.077
R110 VSS.n105 VSS.n116 0.0156714
R111 VSS.t174 VSS.n103 349.057
R112 VSS.t141 VSS.n106 348.303
R113 VSS.t139 VSS.n250 338.711
R114 VSS.t128 VSS.n251 338.711
R115 VSS.t310 VSS.n252 338.711
R116 VSS.t312 VSS.n253 338.711
R117 VSS.t132 VSS.n254 338.711
R118 VSS.t148 VSS.n255 338.711
R119 VSS.t102 VSS.n256 338.711
R120 VSS.t136 VSS.n257 338.711
R121 VSS.t146 VSS.n258 338.711
R122 VSS.t94 VSS.n259 338.711
R123 VSS.t134 VSS.n260 338.711
R124 VSS.t145 VSS.n261 338.711
R125 VSS.t90 VSS.n262 338.711
R126 VSS.t12 VSS.n263 338.711
R127 VSS.t138 VSS.n264 338.711
R128 VSS.t150 VSS.n265 338.711
R129 VSS.n96 VSS.t336 330.911
R130 VSS.n93 VSS.t4 330.911
R131 VSS.n89 VSS.t345 330.911
R132 VSS.n86 VSS.t333 330.911
R133 VSS.n82 VSS.t58 330.911
R134 VSS.n79 VSS.t33 330.911
R135 VSS.n75 VSS.t123 330.911
R136 VSS.n73 VSS.t318 330.911
R137 VSS.n69 VSS.t315 330.911
R138 VSS.n67 VSS.t55 330.911
R139 VSS.n63 VSS.t114 330.911
R140 VSS.n60 VSS.t45 330.911
R141 VSS.n56 VSS.t61 330.911
R142 VSS.n53 VSS.t7 330.911
R143 VSS.n49 VSS.t287 330.911
R144 VSS.n46 VSS.t10 330.911
R145 VSS.n9 VSS.t43 129.317
R146 VSS.n117 VSS.t111 129.738
R147 VSS.t152 VSS.n13 404.05
R148 VSS.n267 VSS.t299 314.517
R149 VSS.t160 VSS.n5 140.653
R150 VSS.n5 VSS.t126 140.653
R151 VSS.n5 VSS.t108 140.651
R152 VSS.n5 VSS.t157 140.651
R153 VSS.n5 VSS.t88 140.651
R154 VSS.n5 VSS.n14 9.33546
R155 VSS.n12 VSS.t42 131.77
R156 VSS.n267 VSS.t284 302.42
R157 VSS.t170 VSS.n20 282.524
R158 VSS.n156 VSS.t326 281.69
R159 VSS.t143 VSS.n106 111.647
R160 VSS.t335 VSS.n250 278.226
R161 VSS.t3 VSS.n251 278.226
R162 VSS.t344 VSS.n252 278.226
R163 VSS.t332 VSS.n253 278.226
R164 VSS.t57 VSS.n254 278.226
R165 VSS.t32 VSS.n255 278.226
R166 VSS.t122 VSS.n256 278.226
R167 VSS.t317 VSS.n257 278.226
R168 VSS.t314 VSS.n258 278.226
R169 VSS.t54 VSS.n259 278.226
R170 VSS.t113 VSS.n260 278.226
R171 VSS.t44 VSS.n261 278.226
R172 VSS.t60 VSS.n262 278.226
R173 VSS.t6 VSS.n263 278.226
R174 VSS.t286 VSS.n264 278.226
R175 VSS.t9 VSS.n265 278.226
R176 VSS.n5 VSS.t194 141.964
R177 VSS.n5 VSS.t209 141.964
R178 VSS.n5 VSS.t224 141.964
R179 VSS.n5 VSS.t239 141.964
R180 VSS.n5 VSS.t254 141.964
R181 VSS.n5 VSS.t269 141.964
R182 VSS.n5 VSS.t40 141.702
R183 VSS.t350 VSS.n18 270.426
R184 VSS.n249 VSS.t169 266.13
R185 VSS.t326 VSS.n11 267.416
R186 VSS.n104 VSS.t167 252.302
R187 VSS.t182 VSS.n248 241.935
R188 VSS.n12 VSS.n5 7.23036
R189 VSS.t167 VSS.n8 239.62
R190 VSS.t52 VSS.n14 131.472
R191 VSS.n5 VSS.t49 137.776
R192 VSS.t154 VSS.n13 129.738
R193 VSS.n117 VSS.n5 6.80937
R194 VSS.n269 VSS.t182 217.743
R195 VSS.n5 VSS.t84 133.32
R196 VSS.t169 VSS.n16 209.964
R197 VSS.n268 VSS.t350 205.645
R198 VSS.n105 VSS.n106 6.82269
R199 VSS.n96 VSS.t335 197.846
R200 VSS.n93 VSS.t3 197.846
R201 VSS.n89 VSS.t344 197.846
R202 VSS.n86 VSS.t332 197.846
R203 VSS.n82 VSS.t57 197.846
R204 VSS.n79 VSS.t32 197.846
R205 VSS.n75 VSS.t122 197.846
R206 VSS.n73 VSS.t317 197.846
R207 VSS.n69 VSS.t314 197.846
R208 VSS.n67 VSS.t54 197.846
R209 VSS.n63 VSS.t113 197.846
R210 VSS.n60 VSS.t44 197.846
R211 VSS.n56 VSS.t60 197.846
R212 VSS.n53 VSS.t6 197.846
R213 VSS.n49 VSS.t286 197.846
R214 VSS.n46 VSS.t9 197.846
R215 VSS.n266 VSS.t170 193.548
R216 VSS.n15 VSS.t100 199.099
R217 VSS.t284 VSS.n19 173.089
R218 VSS.t274 VSS.n5 116.826
R219 VSS.t336 VSS.n22 161.576
R220 VSS.t4 VSS.n24 161.576
R221 VSS.t345 VSS.n26 161.576
R222 VSS.t333 VSS.n27 161.576
R223 VSS.t58 VSS.n29 161.576
R224 VSS.t33 VSS.n30 161.576
R225 VSS.t123 VSS.n32 161.576
R226 VSS.t318 VSS.n33 161.576
R227 VSS.t315 VSS.n35 161.576
R228 VSS.t55 VSS.n36 161.576
R229 VSS.t114 VSS.n38 161.576
R230 VSS.t45 VSS.n39 161.576
R231 VSS.t61 VSS.n41 161.576
R232 VSS.t7 VSS.n42 161.576
R233 VSS.t287 VSS.n44 161.576
R234 VSS.t10 VSS.n45 161.555
R235 VSS.t299 VSS.n101 160.992
R236 VSS.t110 VSS.n3 156.831
R237 VSS.t152 VSS.n118 156.883
R238 VSS.n104 VSS.t174 143.433
R239 VSS.t339 VSS.n21 143.411
R240 VSS.n23 VSS.t18 385.353
R241 VSS.t120 VSS.n25 143.411
R242 VSS.t27 VSS.n107 101.647
R243 VSS.t64 VSS.n28 143.411
R244 VSS.t321 VSS.n108 101.647
R245 VSS.t281 VSS.n31 143.411
R246 VSS.t1 VSS.n109 101.647
R247 VSS.t73 VSS.n34 143.411
R248 VSS.t92 VSS.n111 101.647
R249 VSS.t342 VSS.n37 143.411
R250 VSS.t117 VSS.n113 101.647
R251 VSS.t24 VSS.n40 143.411
R252 VSS.t67 VSS.n114 101.647
R253 VSS.t30 VSS.n43 143.411
R254 VSS.t70 VSS.n116 101.647
R255 VSS.t16 VSS.n1 142.746
R256 VSS.n100 VSS.t141 136.798
R257 VSS.t178 VSS.n97 136.798
R258 VSS.n97 VSS.t139 136.798
R259 VSS.n94 VSS.t128 136.962
R260 VSS.t356 VSS.n90 136.798
R261 VSS.n90 VSS.t310 136.798
R262 VSS.n87 VSS.t312 136.962
R263 VSS.t279 VSS.n83 136.798
R264 VSS.n83 VSS.t132 136.798
R265 VSS.n80 VSS.t148 136.962
R266 VSS.t291 VSS.n76 136.798
R267 VSS.n76 VSS.t102 136.798
R268 VSS.t298 VSS.n110 98.6395
R269 VSS.t302 VSS.n70 136.798
R270 VSS.n70 VSS.t146 136.798
R271 VSS.t354 VSS.n112 98.6395
R272 VSS.t355 VSS.n64 136.798
R273 VSS.n64 VSS.t134 136.798
R274 VSS.n61 VSS.t145 136.962
R275 VSS.t38 VSS.n57 136.798
R276 VSS.n57 VSS.t90 136.798
R277 VSS.n54 VSS.t12 136.962
R278 VSS.t35 VSS.n50 136.798
R279 VSS.n50 VSS.t138 136.798
R280 VSS.n47 VSS.t150 136.962
R281 VSS.n17 VSS.t277 124.701
R282 VSS.t14 VSS.n2 114.668
R283 VSS.n95 VSS.t18 106.555
R284 VSS.n92 VSS.t119 106.555
R285 VSS.n88 VSS.t26 106.555
R286 VSS.n85 VSS.t63 106.555
R287 VSS.n81 VSS.t320 106.555
R288 VSS.n78 VSS.t280 106.555
R289 VSS.n74 VSS.t0 106.555
R290 VSS.n72 VSS.t72 106.555
R291 VSS.n68 VSS.t91 106.555
R292 VSS.n66 VSS.t341 106.555
R293 VSS.n62 VSS.t116 106.555
R294 VSS.n59 VSS.t23 106.555
R295 VSS.n55 VSS.t66 106.555
R296 VSS.n52 VSS.t29 106.555
R297 VSS.n48 VSS.t69 106.555
R298 VSS.n102 VSS.t276 100.507
R299 VSS.t283 VSS.n102 88.4108
R300 VSS.n5 VSS.n11 2.59912
R301 VSS.n99 VSS.t338 106.654
R302 VSS.n95 VSS.t165 82.3625
R303 VSS.n92 VSS.t171 82.3625
R304 VSS.n88 VSS.t296 82.3625
R305 VSS.n85 VSS.t292 82.3625
R306 VSS.n81 VSS.t179 82.3625
R307 VSS.n78 VSS.t352 82.3625
R308 VSS.n74 VSS.t305 82.3625
R309 VSS.n72 VSS.t347 82.3625
R310 VSS.n68 VSS.t289 82.3625
R311 VSS.n66 VSS.t303 82.3625
R312 VSS.n62 VSS.t77 82.3625
R313 VSS.n59 VSS.t75 82.3625
R314 VSS.n55 VSS.t21 82.3625
R315 VSS.n52 VSS.t307 82.3625
R316 VSS.n48 VSS.t163 82.3625
R317 VSS.t184 VSS.n16 76.8981
R318 VSS.n1 VSS.t51 72.3236
R319 VSS.t323 VSS.n5 58.0914
R320 VSS.n5 VSS.t196 58.1721
R321 VSS.n5 VSS.t226 58.1721
R322 VSS.n5 VSS.t241 58.1721
R323 VSS.n5 VSS.t256 58.1721
R324 VSS.t349 VSS.n17 64.2173
R325 VSS.n3 VSS.t82 58.2391
R326 VSS.n118 VSS.t162 52.2182
R327 VSS.t177 VSS.n100 52.1205
R328 VSS.t330 VSS.n10 28.4523
R329 VSS.n101 VSS.t300 27.927
R330 VSS.n5 VSS.t324 22.5629
R331 VSS.n157 VSS.t15 17.3368
R332 VSS.n160 VSS.t17 17.3368
R333 VSS.n150 VSS.t101 17.3368
R334 VSS.n164 VSS.t83 17.3368
R335 VSS.n286 VSS.t142 17.3368
R336 VSS.n282 VSS.t285 17.3368
R337 VSS.n278 VSS.t278 17.3368
R338 VSS.n274 VSS.t183 17.3368
R339 VSS.n207 VSS.t153 17.2607
R340 VSS.n168 VSS.t187 17.2313
R341 VSS.n467 VSS.t193 17.2313
R342 VSS.n175 VSS.t198 17.2313
R343 VSS.n460 VSS.t203 17.2313
R344 VSS.n455 VSS.t208 17.2313
R345 VSS.n185 VSS.t213 17.2313
R346 VSS.n194 VSS.t218 17.2313
R347 VSS.n448 VSS.t223 17.2313
R348 VSS.n129 VSS.t228 17.2313
R349 VSS.n215 VSS.t233 17.2313
R350 VSS.n441 VSS.t238 17.2313
R351 VSS.n134 VSS.t243 17.2313
R352 VSS.n434 VSS.t248 17.2313
R353 VSS.n429 VSS.t253 17.2313
R354 VSS.n139 VSS.t258 17.2313
R355 VSS.n238 VSS.t263 17.2313
R356 VSS.n422 VSS.t268 17.2313
R357 VSS.n144 VSS.t273 17.2313
R358 VSS.n5 VSS.n9 9.75628
R359 VSS.n5 VSS.n149 17.0005
R360 VSS.n5 VSS.n15 0.494014
R361 VSS.n5 VSS.n156 17.0005
R362 VSS.n472 VSS.n5 17.0005
R363 VSS.n470 VSS.t188 17.0005
R364 VSS.n5 VSS.n142 5.65652
R365 VSS.n5 VSS.n137 5.65652
R366 VSS.n5 VSS.n132 5.65652
R367 VSS.n5 VSS.n13 6.8094
R368 VSS.n5 VSS.n127 5.65652
R369 VSS.n5 VSS.n123 5.65652
R370 VSS.n5 VSS.n119 5.65652
R371 VSS.n170 VSS.t190 17.0005
R372 VSS.n468 VSS.t192 17.0005
R373 VSS.n172 VSS.t195 17.0005
R374 VSS.n173 VSS.t197 17.0005
R375 VSS.n177 VSS.t200 17.0005
R376 VSS.n461 VSS.t202 17.0005
R377 VSS.n181 VSS.t205 17.0005
R378 VSS.n456 VSS.t207 17.0005
R379 VSS.n182 VSS.t210 17.0005
R380 VSS.n183 VSS.t212 17.0005
R381 VSS.n187 VSS.t215 17.0005
R382 VSS.n192 VSS.t217 17.0005
R383 VSS.n195 VSS.t220 17.0005
R384 VSS.n449 VSS.t222 17.0005
R385 VSS.n197 VSS.t225 17.0005
R386 VSS.n198 VSS.t227 17.0005
R387 VSS.n202 VSS.t230 17.0005
R388 VSS.n213 VSS.t232 17.0005
R389 VSS.n216 VSS.t235 17.0005
R390 VSS.n442 VSS.t237 17.0005
R391 VSS.n218 VSS.t240 17.0005
R392 VSS.n219 VSS.t242 17.0005
R393 VSS.n222 VSS.t245 17.0005
R394 VSS.n435 VSS.t247 17.0005
R395 VSS.n226 VSS.t250 17.0005
R396 VSS.n430 VSS.t252 17.0005
R397 VSS.n227 VSS.t255 17.0005
R398 VSS.n228 VSS.t257 17.0005
R399 VSS.n231 VSS.t260 17.0005
R400 VSS.n236 VSS.t262 17.0005
R401 VSS.n239 VSS.t265 17.0005
R402 VSS.n423 VSS.t267 17.0005
R403 VSS.n241 VSS.t270 17.0005
R404 VSS.n242 VSS.t272 17.0005
R405 VSS.n244 VSS.t275 17.0005
R406 VSS.n105 VSS.n115 17.0005
R407 VSS.n105 VSS.n248 17.0005
R408 VSS.n105 VSS.n269 17.0005
R409 VSS.n105 VSS.n249 17.0005
R410 VSS.n105 VSS.n268 17.0005
R411 VSS.n105 VSS.n267 17.0005
R412 VSS.n105 VSS.n266 17.0005
R413 VSS.n105 VSS.n250 17.0005
R414 VSS.n105 VSS.n251 17.0005
R415 VSS.n105 VSS.n252 17.0005
R416 VSS.n105 VSS.n253 17.0005
R417 VSS.n105 VSS.n254 17.0005
R418 VSS.n105 VSS.n255 17.0005
R419 VSS.n105 VSS.n256 17.0005
R420 VSS.n105 VSS.n257 17.0005
R421 VSS.n105 VSS.n258 17.0005
R422 VSS.n105 VSS.n259 17.0005
R423 VSS.n105 VSS.n260 17.0005
R424 VSS.n105 VSS.n261 17.0005
R425 VSS.n105 VSS.n262 17.0005
R426 VSS.n105 VSS.n263 17.0005
R427 VSS.n105 VSS.n264 17.0005
R428 VSS.n105 VSS.n265 17.0005
R429 VSS.t81 VSS.n15 15.5226
R430 VSS.n19 VSS.t176 15.8302
R431 VSS.n170 VSS.t391 15.3099
R432 VSS.n172 VSS.t389 15.3099
R433 VSS.n177 VSS.t387 15.3099
R434 VSS.n181 VSS.t385 15.3099
R435 VSS.n182 VSS.t383 15.3099
R436 VSS.n187 VSS.t381 15.3099
R437 VSS.n195 VSS.t379 15.3099
R438 VSS.n197 VSS.t377 15.3099
R439 VSS.n202 VSS.t375 15.3099
R440 VSS.n216 VSS.t373 15.3099
R441 VSS.n218 VSS.t371 15.3099
R442 VSS.n222 VSS.t369 15.3099
R443 VSS.n226 VSS.t367 15.3099
R444 VSS.n227 VSS.t365 15.3099
R445 VSS.n231 VSS.t363 15.3099
R446 VSS.n239 VSS.t361 15.3099
R447 VSS.n241 VSS.t359 15.3099
R448 VSS.n244 VSS.t357 15.3099
R449 VSS.n470 VSS.t392 15.2696
R450 VSS.n468 VSS.t390 15.2696
R451 VSS.n173 VSS.t388 15.2696
R452 VSS.n461 VSS.t386 15.2696
R453 VSS.n456 VSS.t384 15.2696
R454 VSS.n183 VSS.t382 15.2696
R455 VSS.n192 VSS.t380 15.2696
R456 VSS.n449 VSS.t378 15.2696
R457 VSS.n198 VSS.t376 15.2696
R458 VSS.n213 VSS.t374 15.2696
R459 VSS.n442 VSS.t372 15.2696
R460 VSS.n219 VSS.t370 15.2696
R461 VSS.n435 VSS.t368 15.2696
R462 VSS.n430 VSS.t366 15.2696
R463 VSS.n228 VSS.t364 15.2696
R464 VSS.n236 VSS.t362 15.2696
R465 VSS.n423 VSS.t360 15.2696
R466 VSS.n242 VSS.t358 15.2696
R467 VSS.n288 VSS.t144 8.80385
R468 VSS.n284 VSS.t301 8.80385
R469 VSS.n280 VSS.t351 8.80385
R470 VSS.n276 VSS.t185 8.80385
R471 VSS.n158 VSS.t328 8.80285
R472 VSS.n161 VSS.t53 8.80285
R473 VSS.n163 VSS.t331 8.80285
R474 VSS.n166 VSS.t112 8.80285
R475 VSS.n416 VSS.t11 8.77423
R476 VSS.n414 VSS.t151 8.77423
R477 VSS.n412 VSS.t71 8.77423
R478 VSS.n410 VSS.t164 8.77423
R479 VSS.n408 VSS.t288 8.77423
R480 VSS.n406 VSS.t36 8.77423
R481 VSS.n404 VSS.t31 8.77423
R482 VSS.n402 VSS.t308 8.77423
R483 VSS.n400 VSS.t8 8.77423
R484 VSS.n398 VSS.t13 8.77423
R485 VSS.n396 VSS.t68 8.77423
R486 VSS.n394 VSS.t22 8.77423
R487 VSS.n392 VSS.t62 8.77423
R488 VSS.n390 VSS.t39 8.77423
R489 VSS.n388 VSS.t25 8.77423
R490 VSS.n386 VSS.t76 8.77423
R491 VSS.n384 VSS.t46 8.77423
R492 VSS.n382 VSS.t48 8.77423
R493 VSS.n380 VSS.t118 8.77423
R494 VSS.n378 VSS.t78 8.77423
R495 VSS.n376 VSS.t115 8.77423
R496 VSS.n374 VSS.t135 8.77423
R497 VSS.n372 VSS.t343 8.77423
R498 VSS.n370 VSS.t304 8.77423
R499 VSS.n368 VSS.t56 8.77423
R500 VSS.n366 VSS.t95 8.77423
R501 VSS.n364 VSS.t93 8.77423
R502 VSS.n362 VSS.t290 8.77423
R503 VSS.n360 VSS.t316 8.77423
R504 VSS.n358 VSS.t147 8.77423
R505 VSS.n356 VSS.t74 8.77423
R506 VSS.n354 VSS.t348 8.77423
R507 VSS.n352 VSS.t319 8.77423
R508 VSS.n350 VSS.t137 8.77423
R509 VSS.n348 VSS.t2 8.77423
R510 VSS.n346 VSS.t306 8.77423
R511 VSS.n344 VSS.t124 8.77423
R512 VSS.n342 VSS.t103 8.77423
R513 VSS.n340 VSS.t282 8.77423
R514 VSS.n338 VSS.t353 8.77423
R515 VSS.n336 VSS.t34 8.77423
R516 VSS.n334 VSS.t149 8.77423
R517 VSS.n332 VSS.t322 8.77423
R518 VSS.n330 VSS.t180 8.77423
R519 VSS.n328 VSS.t59 8.77423
R520 VSS.n326 VSS.t133 8.77423
R521 VSS.n324 VSS.t65 8.77423
R522 VSS.n322 VSS.t293 8.77423
R523 VSS.n320 VSS.t334 8.77423
R524 VSS.n318 VSS.t295 8.77423
R525 VSS.n316 VSS.t28 8.77423
R526 VSS.n314 VSS.t297 8.77423
R527 VSS.n312 VSS.t346 8.77423
R528 VSS.n310 VSS.t311 8.77423
R529 VSS.n308 VSS.t121 8.77423
R530 VSS.n306 VSS.t172 8.77423
R531 VSS.n304 VSS.t5 8.77423
R532 VSS.n302 VSS.t129 8.77423
R533 VSS.n300 VSS.t20 8.77423
R534 VSS.n298 VSS.t166 8.77423
R535 VSS.n296 VSS.t337 8.77423
R536 VSS.n294 VSS.t140 8.77423
R537 VSS.n292 VSS.t340 8.77423
R538 VSS.n290 VSS.t131 8.77423
R539 VSS.n6 VSS.t106 8.82841
R540 VSS.n179 VSS.t158 8.77323
R541 VSS.n189 VSS.t98 8.77323
R542 VSS.n205 VSS.t127 8.77323
R543 VSS.n206 VSS.t325 8.77323
R544 VSS.n210 VSS.t109 8.77323
R545 VSS.n224 VSS.t89 8.77323
R546 VSS.n233 VSS.t86 8.77323
R547 VSS.n247 VSS.t161 8.77323
R548 VSS.n7 VSS.t50 8.79211
R549 VSS.n209 VSS.t155 8.76678
R550 VSS.n272 VSS.t175 8.75731
R551 VSS.n270 VSS.t168 8.75731
R552 VSS.n146 VSS.t41 8.75631
R553 VSS.n154 VSS.t80 8.75631
R554 VSS.n418 VSS.n145 0.0435295
R555 VSS.n143 VSS.n424 0.0534319
R556 VSS.n240 VSS.n142 0.0180497
R557 VSS.n237 VSS.n141 0.0633111
R558 VSS.n425 VSS.n140 0.0435295
R559 VSS.n138 VSS.n431 0.0534319
R560 VSS.n432 VSS.n137 0.0180497
R561 VSS.n136 VSS.n436 0.0633111
R562 VSS.n437 VSS.n135 0.0435295
R563 VSS.n133 VSS.n443 0.0534319
R564 VSS.n217 VSS.n132 0.0180497
R565 VSS.n214 VSS.n131 0.0633111
R566 VSS.n444 VSS.n130 0.0435295
R567 VSS.n128 VSS.n450 0.0534319
R568 VSS.n196 VSS.n127 0.0180497
R569 VSS.n193 VSS.n126 0.0633111
R570 VSS.n125 VSS.n5 4.22409
R571 VSS.n124 VSS.n457 0.0534319
R572 VSS.n458 VSS.n123 0.0180497
R573 VSS.n122 VSS.n462 0.0633111
R574 VSS.n121 VSS.n5 4.22409
R575 VSS.n120 VSS.n469 0.0534319
R576 VSS.n171 VSS.n119 0.0180497
R577 VSS.n419 VSS.n5 8.49319
R578 VSS.n426 VSS.n5 8.49319
R579 VSS.n438 VSS.n5 8.49319
R580 VSS.n445 VSS.n5 8.49319
R581 VSS.n452 VSS.n5 8.49319
R582 VSS.n464 VSS.n5 8.49319
R583 VSS.n5 VSS.n148 8.47732
R584 VSS.n5 VSS.n145 4.22409
R585 VSS.n143 VSS.n5 4.21914
R586 VSS.n5 VSS.n235 8.47732
R587 VSS.n5 VSS.n141 4.21421
R588 VSS.n5 VSS.n140 4.22409
R589 VSS.n138 VSS.n5 4.21914
R590 VSS.n433 VSS.n5 8.47732
R591 VSS.n136 VSS.n5 4.21421
R592 VSS.n5 VSS.n135 4.22409
R593 VSS.n133 VSS.n5 4.21914
R594 VSS.n5 VSS.n212 8.47732
R595 VSS.n5 VSS.n131 4.21421
R596 VSS.n5 VSS.n130 4.22409
R597 VSS.n128 VSS.n5 4.21914
R598 VSS.n5 VSS.n191 8.47732
R599 VSS.n5 VSS.n126 4.21421
R600 VSS.n125 VSS.n185 0.176279
R601 VSS.n124 VSS.n5 4.21914
R602 VSS.n459 VSS.n5 8.47732
R603 VSS.n122 VSS.n5 4.21421
R604 VSS.n121 VSS.n175 0.176279
R605 VSS.n120 VSS.n5 4.21914
R606 VSS.n5 VSS.n169 8.47732
R607 VSS.n283 VSS.n105 8.47732
R608 VSS.n417 VSS.n105 8.47732
R609 VSS.n5 VSS.n147 5.62581
R610 VSS.n5 VSS.n162 5.62581
R611 VSS.n5 VSS.n159 5.62581
R612 VSS.n5 VSS.n246 5.62581
R613 VSS.n421 VSS.n5 5.62581
R614 VSS.n5 VSS.n230 5.62581
R615 VSS.n428 VSS.n5 5.62581
R616 VSS.n5 VSS.n221 5.62581
R617 VSS.n440 VSS.n5 5.62581
R618 VSS.n5 VSS.n200 5.62581
R619 VSS.n5 VSS.n201 5.62581
R620 VSS.n447 VSS.n5 5.62581
R621 VSS.n5 VSS.n186 5.62581
R622 VSS.n454 VSS.n5 5.62581
R623 VSS.n5 VSS.n176 5.62581
R624 VSS.n466 VSS.n5 5.62581
R625 VSS.n275 VSS.n105 5.62581
R626 VSS.n279 VSS.n105 5.62581
R627 VSS.n287 VSS.n105 5.62581
R628 VSS.n297 VSS.n105 5.62581
R629 VSS.n305 VSS.n105 5.62581
R630 VSS.n313 VSS.n105 5.62581
R631 VSS.n321 VSS.n105 5.62581
R632 VSS.n329 VSS.n105 5.62581
R633 VSS.n337 VSS.n105 5.62581
R634 VSS.n345 VSS.n105 5.62581
R635 VSS.n353 VSS.n105 5.62581
R636 VSS.n361 VSS.n105 5.62581
R637 VSS.n369 VSS.n105 5.62581
R638 VSS.n377 VSS.n105 5.62581
R639 VSS.n385 VSS.n105 5.62581
R640 VSS.n393 VSS.n105 5.62581
R641 VSS.n401 VSS.n105 5.62581
R642 VSS.n409 VSS.n105 5.62581
R643 VSS.n5 VSS.n167 4.21408
R644 VSS.n5 VSS.n155 4.19244
R645 VSS.n271 VSS.n105 4.19244
R646 VSS.n289 VSS.n105 4.19244
R647 VSS.n4 VSS.n417 3.33613
R648 VSS.n6 VSS.n471 0.440892
R649 VSS.n5 VSS.n165 3.3265
R650 VSS.n5 VSS.n151 3.3265
R651 VSS.n5 VSS.n152 3.3265
R652 VSS.n5 VSS.n229 3.3265
R653 VSS.n5 VSS.n220 3.3265
R654 VSS.n5 VSS.n199 3.3265
R655 VSS.n5 VSS.n184 3.3265
R656 VSS.n5 VSS.n174 3.3265
R657 VSS.n277 VSS.n105 3.3265
R658 VSS.n281 VSS.n105 3.3265
R659 VSS.n285 VSS.n105 3.3265
R660 VSS.n291 VSS.n105 3.3265
R661 VSS.n299 VSS.n105 3.3265
R662 VSS.n307 VSS.n105 3.3265
R663 VSS.n315 VSS.n105 3.3265
R664 VSS.n323 VSS.n105 3.3265
R665 VSS.n331 VSS.n105 3.3265
R666 VSS.n339 VSS.n105 3.3265
R667 VSS.n347 VSS.n105 3.3265
R668 VSS.n355 VSS.n105 3.3265
R669 VSS.n363 VSS.n105 3.3265
R670 VSS.n371 VSS.n105 3.3265
R671 VSS.n379 VSS.n105 3.3265
R672 VSS.n387 VSS.n105 3.3265
R673 VSS.n395 VSS.n105 3.3265
R674 VSS.n403 VSS.n105 3.3265
R675 VSS.n411 VSS.n105 3.3265
R676 VSS.n5 VSS.n153 2.74446
R677 VSS.n273 VSS.n105 2.74446
R678 VSS.n293 VSS.n105 2.74446
R679 VSS.n295 VSS.n105 2.74446
R680 VSS.n301 VSS.n105 2.74446
R681 VSS.n303 VSS.n105 2.74446
R682 VSS.n309 VSS.n105 2.74446
R683 VSS.n311 VSS.n105 2.74446
R684 VSS.n317 VSS.n105 2.74446
R685 VSS.n319 VSS.n105 2.74446
R686 VSS.n325 VSS.n105 2.74446
R687 VSS.n327 VSS.n105 2.74446
R688 VSS.n333 VSS.n105 2.74446
R689 VSS.n335 VSS.n105 2.74446
R690 VSS.n341 VSS.n105 2.74446
R691 VSS.n343 VSS.n105 2.74446
R692 VSS.n349 VSS.n105 2.74446
R693 VSS.n351 VSS.n105 2.74446
R694 VSS.n357 VSS.n105 2.74446
R695 VSS.n359 VSS.n105 2.74446
R696 VSS.n365 VSS.n105 2.74446
R697 VSS.n367 VSS.n105 2.74446
R698 VSS.n373 VSS.n105 2.74446
R699 VSS.n375 VSS.n105 2.74446
R700 VSS.n381 VSS.n105 2.74446
R701 VSS.n383 VSS.n105 2.74446
R702 VSS.n389 VSS.n105 2.74446
R703 VSS.n391 VSS.n105 2.74446
R704 VSS.n397 VSS.n105 2.74446
R705 VSS.n399 VSS.n105 2.74446
R706 VSS.n405 VSS.n105 2.74446
R707 VSS.n407 VSS.n105 2.74446
R708 VSS.n413 VSS.n105 2.74446
R709 VSS.n415 VSS.n105 2.74446
R710 VSS.n5 VSS.n208 2.00687
R711 VSS.n5 VSS.n243 1.56144
R712 VSS.n5 VSS.n234 1.56144
R713 VSS.n5 VSS.n225 1.56144
R714 VSS.n5 VSS.n204 1.56144
R715 VSS.n5 VSS.n190 1.56144
R716 VSS.n5 VSS.n180 1.56144
R717 VSS.n5 VSS.n211 1.12565
R718 VSS.n5 VSS.n4 0.92982
R719 VSS.n7 VSS.n5 0.761893
R720 VSS.n6 VSS.n5 0.665344
R721 VSS.n5 VSS.n0 0.849178
R722 VSS.n0 VSS.n205 0.728316
R723 VSS.n206 VSS.n0 0.69965
R724 VSS.n4 VSS.n247 0.69304
R725 VSS.n211 VSS.n209 0.603496
R726 VSS.n105 VSS.n8 0.586403
R727 VSS.n105 VSS.n102 0.586403
R728 VSS.n105 VSS.n17 0.586403
R729 VSS.n105 VSS.n19 0.586403
R730 VSS.n105 VSS.n101 0.586403
R731 VSS.n105 VSS.n100 0.586403
R732 VSS.n105 VSS.n99 0.488226
R733 VSS.n105 VSS.n97 0.586403
R734 VSS.n105 VSS.n95 0.586403
R735 VSS.n105 VSS.n94 0.423468
R736 VSS.n105 VSS.n92 0.586403
R737 VSS.n105 VSS.n90 0.586403
R738 VSS.n105 VSS.n88 0.586403
R739 VSS.n105 VSS.n87 0.423468
R740 VSS.n105 VSS.n85 0.586403
R741 VSS.n105 VSS.n83 0.586403
R742 VSS.n105 VSS.n81 0.586403
R743 VSS.n105 VSS.n80 0.423468
R744 VSS.n105 VSS.n78 0.586403
R745 VSS.n105 VSS.n76 0.586403
R746 VSS.n105 VSS.n74 0.586403
R747 VSS.n110 VSS.t136 136.962
R748 VSS.n105 VSS.n72 0.586403
R749 VSS.n105 VSS.n70 0.586403
R750 VSS.n105 VSS.n68 0.586403
R751 VSS.n112 VSS.t94 136.962
R752 VSS.n105 VSS.n66 0.586403
R753 VSS.n105 VSS.n64 0.586403
R754 VSS.n105 VSS.n62 0.586403
R755 VSS.n105 VSS.n61 0.423468
R756 VSS.n105 VSS.n59 0.586403
R757 VSS.n105 VSS.n57 0.586403
R758 VSS.n105 VSS.n55 0.586403
R759 VSS.n105 VSS.n54 0.423468
R760 VSS.n105 VSS.n52 0.586403
R761 VSS.n105 VSS.n50 0.586403
R762 VSS.n105 VSS.n48 0.586403
R763 VSS.n105 VSS.n47 0.423468
R764 VSS.n211 VSS.n210 0.540438
R765 VSS.n5 VSS.n3 0.50872
R766 VSS.n10 VSS.t329 185.028
R767 VSS.n5 VSS.n1 0.50872
R768 VSS.n5 VSS.n8 4683.36
R769 VSS.n180 VSS.n179 0.413418
R770 VSS.n190 VSS.n189 0.413418
R771 VSS.n205 VSS.n204 0.413418
R772 VSS.n225 VSS.n224 0.413418
R773 VSS.n234 VSS.n233 0.413418
R774 VSS.n247 VSS.n243 0.413418
R775 VSS.n208 VSS.n207 0.380519
R776 VSS.n208 VSS.n206 0.359515
R777 VSS.n245 VSS.n243 0.340858
R778 VSS.n234 VSS.n232 0.340858
R779 VSS.n225 VSS.n223 0.340858
R780 VSS.n204 VSS.n203 0.340858
R781 VSS.n190 VSS.n188 0.340858
R782 VSS.n180 VSS.n178 0.340858
R783 VSS.n274 VSS.n273 0.318018
R784 VSS.n157 VSS.n153 0.316299
R785 VSS.n294 VSS.n293 0.284268
R786 VSS.n302 VSS.n301 0.284268
R787 VSS.n310 VSS.n309 0.284268
R788 VSS.n318 VSS.n317 0.284268
R789 VSS.n326 VSS.n325 0.284268
R790 VSS.n334 VSS.n333 0.284268
R791 VSS.n342 VSS.n341 0.284268
R792 VSS.n350 VSS.n349 0.284268
R793 VSS.n358 VSS.n357 0.284268
R794 VSS.n366 VSS.n365 0.284268
R795 VSS.n374 VSS.n373 0.284268
R796 VSS.n382 VSS.n381 0.284268
R797 VSS.n390 VSS.n389 0.284268
R798 VSS.n398 VSS.n397 0.284268
R799 VSS.n406 VSS.n405 0.284268
R800 VSS.n414 VSS.n413 0.284268
R801 VSS.n295 VSS.n294 0.282549
R802 VSS.n303 VSS.n302 0.282549
R803 VSS.n311 VSS.n310 0.282549
R804 VSS.n319 VSS.n318 0.282549
R805 VSS.n327 VSS.n326 0.282549
R806 VSS.n335 VSS.n334 0.282549
R807 VSS.n343 VSS.n342 0.282549
R808 VSS.n351 VSS.n350 0.282549
R809 VSS.n359 VSS.n358 0.282549
R810 VSS.n367 VSS.n366 0.282549
R811 VSS.n375 VSS.n374 0.282549
R812 VSS.n383 VSS.n382 0.282549
R813 VSS.n391 VSS.n390 0.282549
R814 VSS.n399 VSS.n398 0.282549
R815 VSS.n407 VSS.n406 0.282549
R816 VSS.n415 VSS.n414 0.282549
R817 VSS.n292 VSS.n291 0.280477
R818 VSS.n300 VSS.n299 0.280477
R819 VSS.n308 VSS.n307 0.280477
R820 VSS.n316 VSS.n315 0.280477
R821 VSS.n324 VSS.n323 0.280477
R822 VSS.n332 VSS.n331 0.280477
R823 VSS.n340 VSS.n339 0.280477
R824 VSS.n348 VSS.n347 0.280477
R825 VSS.n356 VSS.n355 0.280477
R826 VSS.n364 VSS.n363 0.280477
R827 VSS.n372 VSS.n371 0.280477
R828 VSS.n380 VSS.n379 0.280477
R829 VSS.n388 VSS.n387 0.280477
R830 VSS.n396 VSS.n395 0.280477
R831 VSS.n404 VSS.n403 0.280477
R832 VSS.n412 VSS.n411 0.280477
R833 VSS.n154 VSS.n153 0.274268
R834 VSS.n161 VSS.n151 0.274227
R835 VSS.n179 VSS.n174 0.274227
R836 VSS.n189 VSS.n184 0.274227
R837 VSS.n210 VSS.n199 0.274227
R838 VSS.n224 VSS.n220 0.274227
R839 VSS.n233 VSS.n229 0.274227
R840 VSS.n281 VSS.n280 0.272997
R841 VSS.n273 VSS.n272 0.272549
R842 VSS.n296 VSS.n295 0.270518
R843 VSS.n304 VSS.n303 0.270518
R844 VSS.n312 VSS.n311 0.270518
R845 VSS.n320 VSS.n319 0.270518
R846 VSS.n328 VSS.n327 0.270518
R847 VSS.n336 VSS.n335 0.270518
R848 VSS.n344 VSS.n343 0.270518
R849 VSS.n352 VSS.n351 0.270518
R850 VSS.n360 VSS.n359 0.270518
R851 VSS.n368 VSS.n367 0.270518
R852 VSS.n376 VSS.n375 0.270518
R853 VSS.n384 VSS.n383 0.270518
R854 VSS.n392 VSS.n391 0.270518
R855 VSS.n400 VSS.n399 0.270518
R856 VSS.n408 VSS.n407 0.270518
R857 VSS.n416 VSS.n415 0.270518
R858 VSS.n291 VSS.n290 0.266747
R859 VSS.n299 VSS.n298 0.266747
R860 VSS.n307 VSS.n306 0.266747
R861 VSS.n315 VSS.n314 0.266747
R862 VSS.n323 VSS.n322 0.266747
R863 VSS.n331 VSS.n330 0.266747
R864 VSS.n339 VSS.n338 0.266747
R865 VSS.n347 VSS.n346 0.266747
R866 VSS.n355 VSS.n354 0.266747
R867 VSS.n363 VSS.n362 0.266747
R868 VSS.n371 VSS.n370 0.266747
R869 VSS.n379 VSS.n378 0.266747
R870 VSS.n387 VSS.n386 0.266747
R871 VSS.n395 VSS.n394 0.266747
R872 VSS.n403 VSS.n402 0.266747
R873 VSS.n411 VSS.n410 0.266747
R874 VSS.n286 VSS.n285 0.246727
R875 VSS.n165 VSS.n164 0.245497
R876 VSS.n293 VSS.n292 0.240049
R877 VSS.n301 VSS.n300 0.240049
R878 VSS.n309 VSS.n308 0.240049
R879 VSS.n317 VSS.n316 0.240049
R880 VSS.n325 VSS.n324 0.240049
R881 VSS.n333 VSS.n332 0.240049
R882 VSS.n341 VSS.n340 0.240049
R883 VSS.n349 VSS.n348 0.240049
R884 VSS.n357 VSS.n356 0.240049
R885 VSS.n365 VSS.n364 0.240049
R886 VSS.n373 VSS.n372 0.240049
R887 VSS.n381 VSS.n380 0.240049
R888 VSS.n389 VSS.n388 0.240049
R889 VSS.n397 VSS.n396 0.240049
R890 VSS.n405 VSS.n404 0.240049
R891 VSS.n413 VSS.n412 0.240049
R892 VSS.n462 VSS.n174 0.237997
R893 VSS.n193 VSS.n184 0.237997
R894 VSS.n214 VSS.n199 0.237997
R895 VSS.n436 VSS.n220 0.237997
R896 VSS.n237 VSS.n229 0.237997
R897 VSS.n158 VSS.n152 0.234227
R898 VSS.n277 VSS.n276 0.232997
R899 VSS.n278 VSS.n277 0.231727
R900 VSS.n160 VSS.n152 0.230497
R901 VSS.n165 VSS.n163 0.219227
R902 VSS.n285 VSS.n284 0.217997
R903 VSS.n289 VSS.n288 0.211543
R904 VSS.n272 VSS.n271 0.201058
R905 VSS.n155 VSS.n154 0.200293
R906 VSS.n282 VSS.n281 0.191727
R907 VSS.n151 VSS.n150 0.190497
R908 VSS.n7 VSS.n166 0.318488
R909 VSS.n155 VSS.n146 0.161058
R910 VSS.n290 VSS.n289 0.161058
R911 VSS.n271 VSS.n270 0.160293
R912 VSS.n297 VSS.n296 0.15705
R913 VSS.n305 VSS.n304 0.15705
R914 VSS.n313 VSS.n312 0.15705
R915 VSS.n321 VSS.n320 0.15705
R916 VSS.n329 VSS.n328 0.15705
R917 VSS.n337 VSS.n336 0.15705
R918 VSS.n345 VSS.n344 0.15705
R919 VSS.n353 VSS.n352 0.15705
R920 VSS.n361 VSS.n360 0.15705
R921 VSS.n369 VSS.n368 0.15705
R922 VSS.n377 VSS.n376 0.15705
R923 VSS.n385 VSS.n384 0.15705
R924 VSS.n393 VSS.n392 0.15705
R925 VSS.n401 VSS.n400 0.15705
R926 VSS.n409 VSS.n408 0.15705
R927 VSS.n168 VSS.n167 0.156007
R928 VSS.n171 VSS.n170 0.155582
R929 VSS.n465 VSS.n172 0.155582
R930 VSS.n178 VSS.n177 0.155582
R931 VSS.n458 VSS.n181 0.155582
R932 VSS.n453 VSS.n182 0.155582
R933 VSS.n188 VSS.n187 0.155582
R934 VSS.n196 VSS.n195 0.155582
R935 VSS.n446 VSS.n197 0.155582
R936 VSS.n203 VSS.n202 0.155582
R937 VSS.n217 VSS.n216 0.155582
R938 VSS.n439 VSS.n218 0.155582
R939 VSS.n223 VSS.n222 0.155582
R940 VSS.n432 VSS.n226 0.155582
R941 VSS.n427 VSS.n227 0.155582
R942 VSS.n232 VSS.n231 0.155582
R943 VSS.n240 VSS.n239 0.155582
R944 VSS.n420 VSS.n241 0.155582
R945 VSS.n245 VSS.n244 0.155582
R946 VSS.n162 VSS.n160 0.149888
R947 VSS.n279 VSS.n278 0.14955
R948 VSS.n471 VSS.n470 0.149476
R949 VSS.n469 VSS.n468 0.149476
R950 VSS.n463 VSS.n173 0.149476
R951 VSS.n462 VSS.n461 0.149476
R952 VSS.n457 VSS.n456 0.149476
R953 VSS.n451 VSS.n183 0.149476
R954 VSS.n193 VSS.n192 0.149476
R955 VSS.n450 VSS.n449 0.149476
R956 VSS.n444 VSS.n198 0.149476
R957 VSS.n214 VSS.n213 0.149476
R958 VSS.n443 VSS.n442 0.149476
R959 VSS.n437 VSS.n219 0.149476
R960 VSS.n436 VSS.n435 0.149476
R961 VSS.n431 VSS.n430 0.149476
R962 VSS.n425 VSS.n228 0.149476
R963 VSS.n237 VSS.n236 0.149476
R964 VSS.n424 VSS.n423 0.149476
R965 VSS.n418 VSS.n242 0.149476
R966 VSS.n276 VSS.n275 0.147388
R967 VSS.n159 VSS.n158 0.14705
R968 VSS.n150 VSS.n148 0.142118
R969 VSS.n283 VSS.n282 0.142118
R970 VSS.n164 VSS.n147 0.134888
R971 VSS.n207 VSS.n200 0.134888
R972 VSS.n287 VSS.n286 0.13455
R973 VSS.n171 VSS.n169 0.129618
R974 VSS.n459 VSS.n458 0.129618
R975 VSS.n196 VSS.n191 0.129618
R976 VSS.n217 VSS.n212 0.129618
R977 VSS.n433 VSS.n432 0.129618
R978 VSS.n240 VSS.n235 0.129618
R979 VSS.n467 VSS.n466 0.126138
R980 VSS.n455 VSS.n454 0.126138
R981 VSS.n448 VSS.n447 0.126138
R982 VSS.n441 VSS.n440 0.126138
R983 VSS.n429 VSS.n428 0.126138
R984 VSS.n422 VSS.n421 0.126138
R985 VSS.n122 VSS.n460 0.156005
R986 VSS.n194 VSS.n126 0.156005
R987 VSS.n215 VSS.n131 0.156005
R988 VSS.n136 VSS.n434 0.156005
R989 VSS.n238 VSS.n141 0.156005
R990 VSS.n288 VSS.n287 0.122388
R991 VSS.n166 VSS.n147 0.12205
R992 VSS.n178 VSS.n176 0.12205
R993 VSS.n188 VSS.n186 0.12205
R994 VSS.n203 VSS.n201 0.12205
R995 VSS.n209 VSS.n200 0.12205
R996 VSS.n223 VSS.n221 0.12205
R997 VSS.n232 VSS.n230 0.12205
R998 VSS.n246 VSS.n245 0.12205
R999 VSS.n163 VSS.n148 0.114618
R1000 VSS.n284 VSS.n283 0.114618
R1001 VSS.n298 VSS.n297 0.113638
R1002 VSS.n306 VSS.n305 0.113638
R1003 VSS.n314 VSS.n313 0.113638
R1004 VSS.n322 VSS.n321 0.113638
R1005 VSS.n330 VSS.n329 0.113638
R1006 VSS.n338 VSS.n337 0.113638
R1007 VSS.n346 VSS.n345 0.113638
R1008 VSS.n354 VSS.n353 0.113638
R1009 VSS.n362 VSS.n361 0.113638
R1010 VSS.n370 VSS.n369 0.113638
R1011 VSS.n378 VSS.n377 0.113638
R1012 VSS.n386 VSS.n385 0.113638
R1013 VSS.n394 VSS.n393 0.113638
R1014 VSS.n402 VSS.n401 0.113638
R1015 VSS.n410 VSS.n409 0.113638
R1016 VSS.n159 VSS.n157 0.109888
R1017 VSS.n417 VSS.n416 0.109618
R1018 VSS.n275 VSS.n274 0.10955
R1019 VSS.n280 VSS.n279 0.107388
R1020 VSS.n162 VSS.n161 0.10705
R1021 VSS.n176 VSS.n175 0.106138
R1022 VSS.n186 VSS.n185 0.106138
R1023 VSS.n201 VSS.n129 0.106138
R1024 VSS.n221 VSS.n134 0.106138
R1025 VSS.n230 VSS.n139 0.106138
R1026 VSS.n246 VSS.n144 0.106138
R1027 VSS.n120 VSS.n467 0.166153
R1028 VSS.n124 VSS.n455 0.166153
R1029 VSS.n128 VSS.n448 0.166153
R1030 VSS.n133 VSS.n441 0.166153
R1031 VSS.n138 VSS.n429 0.166153
R1032 VSS.n143 VSS.n422 0.166153
R1033 VSS.n464 VSS.n463 0.105361
R1034 VSS.n452 VSS.n451 0.105361
R1035 VSS.n445 VSS.n444 0.105361
R1036 VSS.n438 VSS.n437 0.105361
R1037 VSS.n426 VSS.n425 0.105361
R1038 VSS.n419 VSS.n418 0.105361
R1039 VSS.n466 VSS.n465 0.10205
R1040 VSS.n454 VSS.n453 0.10205
R1041 VSS.n447 VSS.n446 0.10205
R1042 VSS.n440 VSS.n439 0.10205
R1043 VSS.n428 VSS.n427 0.10205
R1044 VSS.n421 VSS.n420 0.10205
R1045 VSS.n169 VSS.n168 0.0983676
R1046 VSS.n460 VSS.n459 0.0983676
R1047 VSS.n194 VSS.n191 0.0983676
R1048 VSS.n215 VSS.n212 0.0983676
R1049 VSS.n434 VSS.n433 0.0983676
R1050 VSS.n238 VSS.n235 0.0983676
R1051 VSS.n463 VSS.n121 0.0435295
R1052 VSS.n451 VSS.n125 0.0435295
R1053 VSS.n130 VSS.n129 0.176279
R1054 VSS.n135 VSS.n134 0.176279
R1055 VSS.n140 VSS.n139 0.176279
R1056 VSS.n145 VSS.n144 0.176279
R1057 VSS.n472 VSS.n146 0.078
R1058 VSS.n270 VSS.n115 0.078
R1059 VSS.n469 VSS.n119 0.103847
R1060 VSS.n457 VSS.n123 0.103847
R1061 VSS.n450 VSS.n127 0.103847
R1062 VSS.n443 VSS.n132 0.103847
R1063 VSS.n431 VSS.n137 0.103847
R1064 VSS.n424 VSS.n142 0.103847
R1065 VSS.n471 VSS.n167 0.0633093
R1066 VSS VSS.n472 0.038
R1067 VSS VSS.n115 0.038
R1068 VSS.n105 VSS.n103 0.0211997
R1069 VSS.n105 VSS.n18 0.0211997
R1070 VSS.n105 VSS.n20 0.0211997
R1071 VSS.n105 VSS.n21 0.0211997
R1072 VSS.n105 VSS.n96 0.0211997
R1073 VSS.n105 VSS.n23 0.0156714
R1074 VSS.n105 VSS.n93 0.0211997
R1075 VSS.n105 VSS.n25 0.0211997
R1076 VSS.n105 VSS.n89 0.0211997
R1077 VSS.n107 VSS.t26 385.353
R1078 VSS.n105 VSS.n86 0.0211997
R1079 VSS.n105 VSS.n28 0.0211997
R1080 VSS.n105 VSS.n82 0.0211997
R1081 VSS.n108 VSS.t320 385.353
R1082 VSS.n105 VSS.n79 0.0211997
R1083 VSS.n105 VSS.n31 0.0211997
R1084 VSS.n105 VSS.n75 0.0211997
R1085 VSS.n109 VSS.t0 385.353
R1086 VSS.n105 VSS.n73 0.0211997
R1087 VSS.n105 VSS.n34 0.0211997
R1088 VSS.n105 VSS.n69 0.0211997
R1089 VSS.n111 VSS.t91 385.353
R1090 VSS.n105 VSS.n67 0.0211997
R1091 VSS.n105 VSS.n37 0.0211997
R1092 VSS.n105 VSS.n63 0.0211997
R1093 VSS.n113 VSS.t116 385.353
R1094 VSS.n105 VSS.n60 0.0211997
R1095 VSS.n105 VSS.n40 0.0211997
R1096 VSS.n105 VSS.n56 0.0211997
R1097 VSS.n114 VSS.t66 385.353
R1098 VSS.n105 VSS.n53 0.0211997
R1099 VSS.n105 VSS.n43 0.0211997
R1100 VSS.n105 VSS.n49 0.0211997
R1101 VSS.n116 VSS.t69 385.353
R1102 VSS.n105 VSS.n46 0.0211997
R1103 VSS.n105 VSS.n45 0.0211997
R1104 VSS.n420 VSS.n419 0.0166107
R1105 VSS.n427 VSS.n426 0.0166107
R1106 VSS.n439 VSS.n438 0.0166107
R1107 VSS.n446 VSS.n445 0.0166107
R1108 VSS.n453 VSS.n452 0.0166107
R1109 VSS.n465 VSS.n464 0.0166107
R1110 VSS.n2 VSS.t99 82.6299
R1111 VSS.n105 VSS.n51 0.00212553
R1112 VSS.n105 VSS.n104 0.00171365
R1113 VSS.n105 VSS.n16 0.00171365
R1114 VSS.n105 VSS.n22 0.00171365
R1115 VSS.n105 VSS.n24 0.00171365
R1116 VSS.n105 VSS.n26 0.00171365
R1117 VSS.n105 VSS.n27 0.00171365
R1118 VSS.n105 VSS.n29 0.00171365
R1119 VSS.n105 VSS.n30 0.00171365
R1120 VSS.n105 VSS.n32 0.00171365
R1121 VSS.n105 VSS.n33 0.00171365
R1122 VSS.n105 VSS.n35 0.00171365
R1123 VSS.n105 VSS.n36 0.00171365
R1124 VSS.n105 VSS.n38 0.00171365
R1125 VSS.n105 VSS.n39 0.00171365
R1126 VSS.n105 VSS.n41 0.00171365
R1127 VSS.n105 VSS.n42 0.00171365
R1128 VSS.n105 VSS.n44 0.00171365
R1129 VSS.n105 VSS.n58 0.00158368
R1130 VSS.n105 VSS.n65 0.00158368
R1131 VSS.n105 VSS.n71 0.00158368
R1132 VSS.n105 VSS.n77 0.00158368
R1133 VSS.n105 VSS.n84 0.00158368
R1134 VSS.n105 VSS.n91 0.00158368
R1135 VSS.n105 VSS.n98 0.00158368
R1136 VSS.n5 VSS.t105 140.651
R1137 VSS.n5 VSS.n2 1.26736
R1138 a_3747_216.n0 a_3747_216.t2 52.0388
R1139 a_3747_216.t0 a_3747_216.n0 35.4491
R1140 a_3747_216.n0 a_3747_216.t3 33.5891
R1141 a_3747_216.t1 a_3747_216.t0 5.61942
R1142 a_3171_216.n0 a_3171_216.t2 51.8377
R1143 a_3171_216.n0 a_3171_216.t3 33.3881
R1144 a_3171_216.t0 a_3171_216.n0 31.8923
R1145 a_3171_216.t1 a_3171_216.t0 5.61777
R1146 a_2595_216.n0 a_2595_216.t2 51.6367
R1147 a_2595_216.n0 a_2595_216.t3 33.187
R1148 a_2595_216.t0 a_2595_216.n0 27.993
R1149 a_2595_216.t1 a_2595_216.t0 5.73018
R1150 a_3747_952.n0 a_3747_952.t2 38.0081
R1151 a_3747_952.n0 a_3747_952.t3 33.3957
R1152 a_3747_952.n1 a_3747_952.t4 33.3957
R1153 a_3747_952.n2 a_3747_952.t5 33.3957
R1154 a_3747_952.n3 a_3747_952.t6 33.3957
R1155 a_3747_952.n4 a_3747_952.t7 33.3957
R1156 a_3747_952.n5 a_3747_952.t8 33.3957
R1157 a_3747_952.n6 a_3747_952.t9 33.3957
R1158 a_3747_952.t0 a_3747_952.n6 23.2419
R1159 a_3747_952.t1 a_3747_952.t0 5.61942
R1160 a_3747_952.n6 a_3747_952.n5 4.61291
R1161 a_3747_952.n5 a_3747_952.n4 4.61291
R1162 a_3747_952.n4 a_3747_952.n3 4.61291
R1163 a_3747_952.n3 a_3747_952.n2 4.61291
R1164 a_3747_952.n2 a_3747_952.n1 4.61291
R1165 a_3747_952.n1 a_3747_952.n0 4.61291
R1166 a_3171_952.n0 a_3171_952.t2 37.8054
R1167 a_3171_952.n0 a_3171_952.t3 33.193
R1168 a_3171_952.n1 a_3171_952.t4 33.193
R1169 a_3171_952.n2 a_3171_952.t5 33.193
R1170 a_3171_952.n3 a_3171_952.t6 33.193
R1171 a_3171_952.n4 a_3171_952.t7 33.193
R1172 a_3171_952.n5 a_3171_952.t8 33.193
R1173 a_3171_952.n6 a_3171_952.t9 33.193
R1174 a_3171_952.t0 a_3171_952.n6 23.0313
R1175 a_3171_952.t1 a_3171_952.t0 5.61777
R1176 a_3171_952.n6 a_3171_952.n5 4.61291
R1177 a_3171_952.n5 a_3171_952.n4 4.61291
R1178 a_3171_952.n4 a_3171_952.n3 4.61291
R1179 a_3171_952.n3 a_3171_952.n2 4.61291
R1180 a_3171_952.n2 a_3171_952.n1 4.61291
R1181 a_3171_952.n1 a_3171_952.n0 4.61291
R1182 a_2595_952.n0 a_2595_952.t2 37.7691
R1183 a_2595_952.n0 a_2595_952.t3 33.1567
R1184 a_2595_952.n1 a_2595_952.t4 33.1567
R1185 a_2595_952.n2 a_2595_952.t5 33.1567
R1186 a_2595_952.n3 a_2595_952.t6 33.1567
R1187 a_2595_952.n4 a_2595_952.t7 33.1567
R1188 a_2595_952.n5 a_2595_952.t8 33.1567
R1189 a_2595_952.n6 a_2595_952.t9 33.1567
R1190 a_2595_952.t0 a_2595_952.n6 22.7941
R1191 a_2595_952.t1 a_2595_952.t0 5.65522
R1192 a_2595_952.n6 a_2595_952.n5 4.61291
R1193 a_2595_952.n5 a_2595_952.n4 4.61291
R1194 a_2595_952.n4 a_2595_952.n3 4.61291
R1195 a_2595_952.n3 a_2595_952.n2 4.61291
R1196 a_2595_952.n2 a_2595_952.n1 4.61291
R1197 a_2595_952.n1 a_2595_952.n0 4.61291
R1198 a_2019_952.n0 a_2019_952.t2 37.9701
R1199 a_2019_952.n0 a_2019_952.t3 33.3577
R1200 a_2019_952.n1 a_2019_952.t4 33.3577
R1201 a_2019_952.n2 a_2019_952.t5 33.3577
R1202 a_2019_952.n3 a_2019_952.t6 33.3577
R1203 a_2019_952.n4 a_2019_952.t7 33.3577
R1204 a_2019_952.t0 a_2019_952.t9 22.5945
R1205 a_2019_952.t1 a_2019_952.t0 5.62052
R1206 a_2019_952.t9 a_2019_952.t8 4.61291
R1207 a_2019_952.t8 a_2019_952.n4 4.61291
R1208 a_2019_952.n4 a_2019_952.n3 4.61291
R1209 a_2019_952.n3 a_2019_952.n2 4.61291
R1210 a_2019_952.n2 a_2019_952.n1 4.61291
R1211 a_2019_952.n1 a_2019_952.n0 4.61291
C578 MUX_OUT VSS 3.24057f
C579 MUX_SEL4 VSS 1.63591f
C580 DELAY_OUT_TAP0 VSS 0.37425f
C581 MUX_SEL3 VSS 0.90686f
C582 MUX_SEL2 VSS 1.81137f
C583 DELAY_OUT_TAP31 VSS 0.41949f
C584 DELAY_OUT_TAP30 VSS 0.43238f
C585 DELAY_OUT_TAP29 VSS 0.30856f
C586 DELAY_OUT_TAP28 VSS 0.4381f
C587 DELAY_OUT_TAP27 VSS 0.38455f
C588 DELAY_OUT_TAP26 VSS 0.43238f
C589 DELAY_OUT_TAP25 VSS 0.30856f
C590 DELAY_OUT_TAP24 VSS 0.4381f
C591 DELAY_OUT_TAP23 VSS 0.38455f
C592 DELAY_OUT_TAP22 VSS 0.43238f
C593 DELAY_OUT_TAP21 VSS 0.30856f
C594 DELAY_OUT_TAP20 VSS 0.4381f
C595 DELAY_OUT_TAP19 VSS 0.38455f
C596 DELAY_OUT_TAP18 VSS 0.43238f
C597 DELAY_OUT_TAP17 VSS 0.30374f
C598 DELAY_OUT_TAP16 VSS 0.42869f
C599 DELAY_OUT_TAP15 VSS 0.38342f
C600 DELAY_OUT_TAP14 VSS 0.43238f
C601 DELAY_OUT_TAP13 VSS 0.30856f
C602 DELAY_OUT_TAP12 VSS 0.43643f
C603 DELAY_OUT_TAP11 VSS 0.38455f
C604 DELAY_OUT_TAP10 VSS 0.43238f
C605 DELAY_OUT_TAP9 VSS 0.30856f
C606 DELAY_OUT_TAP8 VSS 0.43643f
C607 DELAY_OUT_TAP7 VSS 0.38455f
C608 DELAY_OUT_TAP6 VSS 0.43238f
C609 DELAY_OUT_TAP5 VSS 0.30856f
C610 DELAY_OUT_TAP4 VSS 0.43585f
C611 DELAY_OUT_TAP3 VSS 0.38455f
C612 DELAY_OUT_TAP2 VSS 0.43238f
C613 DELAY_OUT_TAP1 VSS 0.30776f
C614 MUX_SEL1 VSS 0.9549f
C615 MUX_SEL0 VSS 1.81267f
C616 VDD VSS 26.9372f
C617 a_26985_424# VSS 0.18005f ; **FLOATING
C618 a_23945_424# VSS 0.18005f ; **FLOATING
C619 a_20905_424# VSS 0.18005f ; **FLOATING
C620 a_17865_424# VSS 0.1767f ; **FLOATING
C621 a_16851_214# VSS 0.38749f ; **FLOATING
C622 a_16108_194# VSS 3.87256f ; **FLOATING
C623 a_15964_194# VSS 0.18406f ; **FLOATING
C624 a_15765_368# VSS 0.36264f ; **FLOATING
C625 a_14825_424# VSS 0.18005f ; **FLOATING
C626 a_11785_424# VSS 0.18005f ; **FLOATING
C627 a_8745_424# VSS 0.18005f ; **FLOATING
C628 a_5731_194# VSS 3.39133f ; **FLOATING
C629 a_2019_216# VSS 1.616f ; **FLOATING
C630 a_5705_424# VSS 0.17716f ; **FLOATING
C631 a_3449_236# VSS 0.18478f ; **FLOATING
C632 a_2873_236# VSS 0.18321f ; **FLOATING
C633 a_2297_236# VSS 0.18321f ; **FLOATING
C634 a_1721_236# VSS 0.17001f ; **FLOATING
C635 a_1544_194# VSS 0.30014f ; **FLOATING
C636 a_1256_194# VSS 0.84266f ; **FLOATING
C637 a_27991_913# VSS 0.18706f ; **FLOATING
C638 a_27915_949# VSS 0.10926f ; **FLOATING
C639 a_27124_913# VSS 0.17878f ; **FLOATING
C640 a_27048_949# VSS 0.12122f ; **FLOATING
C641 a_26471_913# VSS 0.18175f ; **FLOATING
C642 a_26395_949# VSS 0.11073f ; **FLOATING
C643 a_25604_913# VSS 0.18087f ; **FLOATING
C644 a_25630_949# VSS 0.43187f ; **FLOATING
C645 a_25528_949# VSS 0.12433f ; **FLOATING
C646 a_24951_913# VSS 0.18335f ; **FLOATING
C647 a_24875_949# VSS 0.11016f ; **FLOATING
C648 a_24084_913# VSS 0.17878f ; **FLOATING
C649 a_24008_949# VSS 0.12122f ; **FLOATING
C650 a_23431_913# VSS 0.18175f ; **FLOATING
C651 a_23355_949# VSS 0.11073f ; **FLOATING
C652 a_22564_913# VSS 0.18087f ; **FLOATING
C653 a_22590_949# VSS 0.40111f ; **FLOATING
C654 a_22488_949# VSS 0.12433f ; **FLOATING
C655 a_21911_913# VSS 0.18335f ; **FLOATING
C656 a_21835_949# VSS 0.11016f ; **FLOATING
C657 a_21044_913# VSS 0.17878f ; **FLOATING
C658 a_20968_949# VSS 0.12122f ; **FLOATING
C659 a_20391_913# VSS 0.18175f ; **FLOATING
C660 a_20315_949# VSS 0.11073f ; **FLOATING
C661 a_19524_913# VSS 0.18087f ; **FLOATING
C662 a_19550_949# VSS 0.4036f ; **FLOATING
C663 a_19448_949# VSS 0.12433f ; **FLOATING
C664 a_18871_913# VSS 0.18335f ; **FLOATING
C665 a_18795_949# VSS 0.11016f ; **FLOATING
C666 a_18004_913# VSS 0.17878f ; **FLOATING
C667 a_17928_949# VSS 0.12122f ; **FLOATING
C668 a_17351_913# VSS 0.18022f ; **FLOATING
C669 a_17275_949# VSS 0.10926f ; **FLOATING
C670 a_16484_913# VSS 0.18023f ; **FLOATING
C671 a_16510_949# VSS 0.35732f ; **FLOATING
C672 a_16408_949# VSS 0.1229f ; **FLOATING
C673 a_15831_913# VSS 0.17846f ; **FLOATING
C674 a_15755_949# VSS 0.10926f ; **FLOATING
C675 a_14964_913# VSS 0.17878f ; **FLOATING
C676 a_14888_949# VSS 0.12122f ; **FLOATING
C677 a_14311_913# VSS 0.18175f ; **FLOATING
C678 a_14235_949# VSS 0.11073f ; **FLOATING
C679 a_13444_913# VSS 0.18087f ; **FLOATING
C680 a_13470_949# VSS 0.3713f ; **FLOATING
C681 a_13368_949# VSS 0.12433f ; **FLOATING
C682 a_12791_913# VSS 0.18335f ; **FLOATING
C683 a_12715_949# VSS 0.11016f ; **FLOATING
C684 a_11924_913# VSS 0.17878f ; **FLOATING
C685 a_11848_949# VSS 0.12122f ; **FLOATING
C686 a_11271_913# VSS 0.18175f ; **FLOATING
C687 a_11195_949# VSS 0.11073f ; **FLOATING
C688 a_10404_913# VSS 0.18087f ; **FLOATING
C689 a_10430_949# VSS 0.38462f ; **FLOATING
C690 a_10328_949# VSS 0.12433f ; **FLOATING
C691 a_9751_913# VSS 0.18335f ; **FLOATING
C692 a_9675_949# VSS 0.11016f ; **FLOATING
C693 a_8884_913# VSS 0.17878f ; **FLOATING
C694 a_8808_949# VSS 0.12122f ; **FLOATING
C695 a_8231_913# VSS 0.18175f ; **FLOATING
C696 a_8155_949# VSS 0.11073f ; **FLOATING
C697 a_7364_913# VSS 0.18087f ; **FLOATING
C698 a_7390_949# VSS 0.38153f ; **FLOATING
C699 a_7288_949# VSS 0.12433f ; **FLOATING
C700 a_6711_913# VSS 0.18335f ; **FLOATING
C701 a_6635_949# VSS 0.11016f ; **FLOATING
C702 a_5844_913# VSS 0.17878f ; **FLOATING
C703 a_5768_949# VSS 0.12122f ; **FLOATING
C704 a_5191_913# VSS 0.18022f ; **FLOATING
C705 a_5115_949# VSS 0.10926f ; **FLOATING
C706 a_4324_913# VSS 0.18023f ; **FLOATING
C707 a_4350_949# VSS 0.33452f ; **FLOATING
C708 a_4248_949# VSS 0.12443f ; **FLOATING
C709 a_27705_949# VSS 0.2535f ; **FLOATING
C710 a_26185_949# VSS 0.23529f ; **FLOATING
C711 a_24665_949# VSS 0.25486f ; **FLOATING
C712 a_23145_949# VSS 0.23529f ; **FLOATING
C713 a_21625_949# VSS 0.25486f ; **FLOATING
C714 a_20105_949# VSS 0.23529f ; **FLOATING
C715 a_18585_949# VSS 0.25486f ; **FLOATING
C716 a_17065_949# VSS 0.23439f ; **FLOATING
C717 a_15545_949# VSS 0.2535f ; **FLOATING
C718 a_14025_949# VSS 0.23529f ; **FLOATING
C719 a_12505_949# VSS 0.25486f ; **FLOATING
C720 a_10985_949# VSS 0.23529f ; **FLOATING
C721 a_9465_949# VSS 0.25486f ; **FLOATING
C722 a_7945_949# VSS 0.23529f ; **FLOATING
C723 a_6425_949# VSS 0.25486f ; **FLOATING
C724 a_4905_949# VSS 0.23602f ; **FLOATING
C725 a_4157_1218# VSS 0.3431f ; **FLOATING
C726 a_3449_1300# VSS 0.18603f ; **FLOATING
C727 a_2873_1300# VSS 0.18321f ; **FLOATING
C728 a_2297_1300# VSS 0.18321f ; **FLOATING
C729 a_1721_1300# VSS 0.17001f ; **FLOATING
C730 a_1544_949# VSS 0.29963f ; **FLOATING
C731 a_1256_949# VSS 0.83916f ; **FLOATING
C732 a_2019_952.t2 VSS 0.8244f ; **FLOATING
C733 a_2019_952.t3 VSS 0.62586f ; **FLOATING
C734 a_2019_952.n0 VSS 4.43882f ; **FLOATING
C735 a_2019_952.t4 VSS 0.62586f ; **FLOATING
C736 a_2019_952.n1 VSS 3.00298f ; **FLOATING
C737 a_2019_952.t5 VSS 0.62586f ; **FLOATING
C738 a_2019_952.n2 VSS 3.00298f ; **FLOATING
C739 a_2019_952.t6 VSS 0.62586f ; **FLOATING
C740 a_2019_952.n3 VSS 3.00298f ; **FLOATING
C741 a_2019_952.t7 VSS 0.62586f ; **FLOATING
C742 a_2019_952.n4 VSS 3.00298f ; **FLOATING
C743 a_2019_952.t8 VSS 3.62885f ; **FLOATING
C744 a_2019_952.t9 VSS 4.83408f ; **FLOATING
C745 a_2019_952.t0 VSS 0.95051f ; **FLOATING
C746 a_2019_952.t1 VSS 0.27016f ; **FLOATING
C747 a_2595_952.t2 VSS 1.35979f ; **FLOATING
C748 a_2595_952.t3 VSS 1.01554f ; **FLOATING
C749 a_2595_952.n0 VSS 7.72017f ; **FLOATING
C750 a_2595_952.t4 VSS 1.01554f ; **FLOATING
C751 a_2595_952.n1 VSS 5.2455f ; **FLOATING
C752 a_2595_952.t5 VSS 1.01554f ; **FLOATING
C753 a_2595_952.n2 VSS 5.2455f ; **FLOATING
C754 a_2595_952.t6 VSS 1.01554f ; **FLOATING
C755 a_2595_952.n3 VSS 5.2455f ; **FLOATING
C756 a_2595_952.t7 VSS 1.01554f ; **FLOATING
C757 a_2595_952.n4 VSS 5.2455f ; **FLOATING
C758 a_2595_952.t8 VSS 1.01554f ; **FLOATING
C759 a_2595_952.n5 VSS 5.2455f ; **FLOATING
C760 a_2595_952.t9 VSS 1.01554f ; **FLOATING
C761 a_2595_952.n6 VSS 7.54534f ; **FLOATING
C762 a_2595_952.t0 VSS 1.74193f ; **FLOATING
C763 a_2595_952.t1 VSS 0.47972f ; **FLOATING
C764 a_3171_952.t2 VSS 1.37934f ; **FLOATING
C765 a_3171_952.t3 VSS 1.03353f ; **FLOATING
C766 a_3171_952.n0 VSS 7.75003f ; **FLOATING
C767 a_3171_952.t4 VSS 1.03353f ; **FLOATING
C768 a_3171_952.n1 VSS 5.26146f ; **FLOATING
C769 a_3171_952.t5 VSS 1.03353f ; **FLOATING
C770 a_3171_952.n2 VSS 5.26146f ; **FLOATING
C771 a_3171_952.t6 VSS 1.03353f ; **FLOATING
C772 a_3171_952.n3 VSS 5.26146f ; **FLOATING
C773 a_3171_952.t7 VSS 1.03353f ; **FLOATING
C774 a_3171_952.n4 VSS 5.26146f ; **FLOATING
C775 a_3171_952.t8 VSS 1.03353f ; **FLOATING
C776 a_3171_952.n5 VSS 5.26146f ; **FLOATING
C777 a_3171_952.t9 VSS 1.03353f ; **FLOATING
C778 a_3171_952.n6 VSS 7.65529f ; **FLOATING
C779 a_3171_952.t0 VSS 1.76377f ; **FLOATING
C780 a_3171_952.t1 VSS 0.47908f ; **FLOATING
C781 a_3747_952.t2 VSS 0.96135f ; **FLOATING
C782 a_3747_952.t3 VSS 0.73189f ; **FLOATING
C783 a_3747_952.n0 VSS 5.12748f ; **FLOATING
C784 a_3747_952.t4 VSS 0.73189f ; **FLOATING
C785 a_3747_952.n1 VSS 3.46611f ; **FLOATING
C786 a_3747_952.t5 VSS 0.73189f ; **FLOATING
C787 a_3747_952.n2 VSS 3.46611f ; **FLOATING
C788 a_3747_952.t6 VSS 0.73189f ; **FLOATING
C789 a_3747_952.n3 VSS 3.46611f ; **FLOATING
C790 a_3747_952.t7 VSS 0.73189f ; **FLOATING
C791 a_3747_952.n4 VSS 3.46611f ; **FLOATING
C792 a_3747_952.t8 VSS 0.73189f ; **FLOATING
C793 a_3747_952.n5 VSS 3.46611f ; **FLOATING
C794 a_3747_952.t9 VSS 0.73189f ; **FLOATING
C795 a_3747_952.n6 VSS 5.14677f ; **FLOATING
C796 a_3747_952.t0 VSS 1.17618f ; **FLOATING
C797 a_3747_952.t1 VSS 0.31095f ; **FLOATING
C798 a_2595_216.t0 VSS 3.2703f ; **FLOATING
C799 a_2595_216.t2 VSS 5.04135f ; **FLOATING
C800 a_2595_216.t3 VSS 1.20629f ; **FLOATING
C801 a_2595_216.n0 VSS 26.8663f ; **FLOATING
C802 a_2595_216.t1 VSS 0.49571f ; **FLOATING
C803 a_3171_216.t2 VSS 5.0499f ; **FLOATING
C804 a_3171_216.t3 VSS 1.21145f ; **FLOATING
C805 a_3171_216.n0 VSS 29.8488f ; **FLOATING
C806 a_3171_216.t0 VSS 4.61136f ; **FLOATING
C807 a_3171_216.t1 VSS 0.49728f ; **FLOATING
C808 a_3747_216.t2 VSS 3.09124f ; **FLOATING
C809 a_3747_216.t3 VSS 0.74403f ; **FLOATING
C810 a_3747_216.n0 VSS 19.8835f ; **FLOATING
C811 a_3747_216.t0 VSS 3.68799f ; **FLOATING
C812 a_3747_216.t1 VSS 0.30529f ; **FLOATING
.ends
