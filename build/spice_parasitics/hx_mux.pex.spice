* NGSPICE file created from hx_mux.ext - technology: ihp-sg13g2

.subckt hx_mux DELAY_OUT_TAP0 DELAY_OUT_TAP1 DELAY_OUT_TAP2 DELAY_OUT_TAP3 DELAY_OUT_TAP4
+ DELAY_OUT_TAP5 DELAY_OUT_TAP6 DELAY_OUT_TAP7 DELAY_OUT_TAP8 DELAY_OUT_TAP9 DELAY_OUT_TAP10
+ DELAY_OUT_TAP11 DELAY_OUT_TAP12 DELAY_OUT_TAP13 DELAY_OUT_TAP14 DELAY_OUT_TAP15
+ DELAY_OUT_TAP16 DELAY_OUT_TAP17 DELAY_OUT_TAP18 DELAY_OUT_TAP19 DELAY_OUT_TAP20
+ DELAY_OUT_TAP21 DELAY_OUT_TAP22 DELAY_OUT_TAP23 DELAY_OUT_TAP24 DELAY_OUT_TAP25
+ DELAY_OUT_TAP26 DELAY_OUT_TAP27 DELAY_OUT_TAP28 DELAY_OUT_TAP29 DELAY_OUT_TAP30
+ DELAY_OUT_TAP31 VSS VDD MUX_SEL0 MUX_SEL1 MUX_OUT MUX_SEL4 MUX_SEL2 MUX_SEL3
X0 VDD.t80 a_2019_952.t9 a_4324_913# VDD.t0 sg13_lv_pmos ad=0.3808p pd=2.92u as=0.3808p ps=2.92u w=1.12u l=0.13u
X1 a_1256_194# MUX_SEL2 VDD.t162 VDD.t0 sg13_lv_pmos ad=0.3808p pd=2.92u as=0.3808p ps=2.92u w=1.12u l=0.13u
X2 VDD.t16 a_3171_952.t8 a_8884_913# VDD.t0 sg13_lv_pmos ad=0.3808p pd=2.92u as=0.3808p ps=2.92u w=1.12u l=0.13u
X3 a_16108_194# a_15765_368# a_15964_194# VDD.t0 sg13_lv_pmos ad=0.3808p pd=2.92u as=0.3304p ps=1.71u w=1.12u l=0.13u
X4 a_22590_949# a_24951_913# a_24875_949# VDD.t0 sg13_lv_pmos ad=0.3808p pd=2.92u as=0.2128p ps=1.5u w=1.12u l=0.13u
X5 VDD.t84 a_2595_952.t7 a_11271_913# VDD.t0 sg13_lv_pmos ad=0.3808p pd=2.92u as=0.3808p ps=2.92u w=1.12u l=0.13u
X6 VSS.t183 VDD.t206 VSS.t181 VSS.t182 sg13_lv_nmos ad=79.8f pd=0.8u as=0 ps=0 w=0.42u l=1u
X7 a_7390_949# a_2595_952.t8 a_8155_949# VSS.t48 sg13_lv_nmos ad=0.2516p pd=2.16u as=0.1406p ps=1.12u w=0.74u l=0.13u
X8 VSS.t186 VDD.t205 VSS.t185 VSS.t184 sg13_lv_nmos ad=0.1428p pd=1.52u as=0 ps=0 w=0.42u l=1u
X9 VDD.t43 VSS.t203 VDD.t91 VDD.t0 sg13_lv_pmos ad=0.19p pd=1.38u as=0 ps=0 w=1u l=1u
X10 VSS.t31 DELAY_OUT_TAP11 a_12505_949# VSS.t264 sg13_lv_nmos ad=0.1665p pd=1.19u as=0.2516p ps=2.16u w=0.74u l=0.13u
X11 MUX_OUT a_16851_214# VSS.t143 VSS.t142 sg13_lv_nmos ad=0.1406p pd=1.12u as=0.1371p ps=1.12u w=0.74u l=0.13u
X12 VDD.t85 a_3747_952.t9 a_6711_913# VDD.t0 sg13_lv_pmos ad=0.3808p pd=2.92u as=0.3808p ps=2.92u w=1.12u l=0.13u
X13 VSS.t251 VDD.t192 VSS.t250 VSS.t249 sg13_lv_nmos ad=0.1428p pd=1.52u as=0 ps=0 w=0.42u l=1u
X14 a_1544_194# MUX_SEL3 VDD.t164 VDD.t0 sg13_lv_pmos ad=0.3808p pd=2.92u as=0.3808p ps=2.92u w=1.12u l=0.13u
X15 VSS.t127 a_2595_216.t3 a_8745_424# VSS.t126 sg13_lv_nmos ad=0.2516p pd=2.16u as=0.2516p ps=2.16u w=0.74u l=0.13u
X16 a_10328_949# DELAY_OUT_TAP8 VSS.t37 VSS.t318 sg13_lv_nmos ad=0.1406p pd=1.12u as=0.2516p ps=2.16u w=0.74u l=0.13u
X17 a_22590_949# a_2019_952.t3 a_22488_949# VSS.t73 sg13_lv_nmos ad=0.2516p pd=2.16u as=0.1406p ps=1.12u w=0.74u l=0.13u
X18 a_8808_949# DELAY_OUT_TAP6 VSS.t50 VSS.t320 sg13_lv_nmos ad=0.1406p pd=1.12u as=0.2516p ps=2.16u w=0.74u l=0.13u
X19 VSS.t24 DELAY_OUT_TAP31 a_27705_949# VSS.t305 sg13_lv_nmos ad=0.1665p pd=1.19u as=0.2516p ps=2.16u w=0.74u l=0.13u
X20 a_11848_949# DELAY_OUT_TAP10 VDD.t140 VDD.t0 sg13_lv_pmos ad=0.2128p pd=1.5u as=0.3808p ps=2.92u w=1.12u l=0.13u
X21 VDD.t53 a_3171_952.t3 a_24084_913# VDD.t0 sg13_lv_pmos ad=0.3808p pd=2.92u as=0.3808p ps=2.92u w=1.12u l=0.13u
X22 a_1721_236# a_1256_194# VDD.t73 VDD.t0 sg13_lv_pmos ad=0.1596p pd=1.22u as=0.2856p ps=2.36u w=0.84u l=0.13u
X23 a_6635_949# a_6425_949# VSS.t56 VSS.t136 sg13_lv_nmos ad=0.1406p pd=1.12u as=0.1665p ps=1.19u w=0.74u l=0.13u
X24 VDD.t121 VSS.t220 VDD.t178 VDD.t0 sg13_lv_pmos ad=0.34p pd=2.68u as=0 ps=0 w=1u l=1u
X25 VSS.t27 a_2595_952.t9 a_5191_913# VSS.t26 sg13_lv_nmos ad=0.2516p pd=2.16u as=0.2516p ps=2.16u w=0.74u l=0.13u
X26 VSS.t280 a_1256_949# a_2967_1300# VSS.t279 sg13_lv_nmos ad=0.1331p pd=1.12u as=0.1216p ps=1.02u w=0.64u l=0.13u
X27 a_4157_1218# DELAY_OUT_TAP0 VDD.t59 VDD.t0 sg13_lv_pmos ad=0.3808p pd=2.92u as=0.3808p ps=2.92u w=1.12u l=0.13u
X28 a_25528_949# DELAY_OUT_TAP28 VSS.t72 VSS.t290 sg13_lv_nmos ad=0.1406p pd=1.12u as=0.2516p ps=2.16u w=0.74u l=0.13u
X29 a_20315_949# a_20105_949# VSS.t64 VSS.t140 sg13_lv_nmos ad=0.1406p pd=1.12u as=0.1665p ps=1.19u w=0.74u l=0.13u
X30 a_5731_194# a_3747_216.t3 a_13470_949# VSS.t153 sg13_lv_nmos ad=0.2516p pd=2.16u as=0.2516p ps=2.16u w=0.74u l=0.13u
X31 VSS.t243 VDD.t194 VSS.t241 VSS.t242 sg13_lv_nmos ad=79.8f pd=0.8u as=0 ps=0 w=0.42u l=1u
X32 VSS.t208 VDD.t201 VSS.t206 VSS.t207 sg13_lv_nmos ad=79.8f pd=0.8u as=0 ps=0 w=0.42u l=1u
X33 VSS.t145 a_16851_214# MUX_OUT VSS.t144 sg13_lv_nmos ad=0.2516p pd=2.16u as=0.1406p ps=1.12u w=0.74u l=0.13u
X34 VDD.t3 a_1544_194# a_1721_236# VDD.t0 sg13_lv_pmos ad=0.1918p pd=1.5u as=0.1596p ps=1.22u w=0.84u l=0.13u
X35 VDD.t55 a_3747_952.t3 a_24951_913# VDD.t0 sg13_lv_pmos ad=0.3808p pd=2.92u as=0.3808p ps=2.92u w=1.12u l=0.13u
X36 VDD.t90 VSS.t190 VDD.t174 VDD.t0 sg13_lv_pmos ad=0.34p pd=2.68u as=0 ps=0 w=1u l=1u
X37 a_16408_949# DELAY_OUT_TAP16 VSS.t12 VSS.t284 sg13_lv_nmos ad=0.1406p pd=1.12u as=0.2516p ps=2.16u w=0.74u l=0.13u
X38 a_5731_194# a_2019_216.t3 a_4350_949# VSS.t3 sg13_lv_nmos ad=0.2516p pd=2.16u as=0.2516p ps=2.16u w=0.74u l=0.13u
X39 VDD.t9 a_2595_952.t2 a_26471_913# VDD.t0 sg13_lv_pmos ad=0.3808p pd=2.92u as=0.3808p ps=2.92u w=1.12u l=0.13u
X40 a_7390_949# a_3747_952.t8 a_9675_949# VSS.t35 sg13_lv_nmos ad=0.2516p pd=2.16u as=0.1406p ps=1.12u w=0.74u l=0.13u
X41 VSS.t181 VDD.t206 VSS.t180 VSS.t179 sg13_lv_nmos ad=0.1428p pd=1.52u as=0 ps=0 w=0.42u l=1u
X42 VDD.t155 VSS.t263 VDD.t189 VDD.t0 sg13_lv_pmos ad=0.19p pd=1.38u as=0 ps=0 w=1u l=1u
X43 VDD.t77 DELAY_OUT_TAP13 a_14025_949# VDD.t0 sg13_lv_pmos ad=0.252p pd=1.57u as=0.3808p ps=2.92u w=1.12u l=0.13u
X44 a_10430_949# a_11924_913# a_11848_949# VDD.t0 sg13_lv_pmos ad=0.3808p pd=2.92u as=0.2128p ps=1.5u w=1.12u l=0.13u
X45 VDD.t93 a_2595_216.t3 a_8745_424# VDD.t0 sg13_lv_pmos ad=0.3808p pd=2.92u as=0.3808p ps=2.92u w=1.12u l=0.13u
X46 VSS.t102 a_3171_952.t5 a_18004_913# VSS.t129 sg13_lv_nmos ad=0.2516p pd=2.16u as=0.2516p ps=2.16u w=0.74u l=0.13u
X47 VDD.t68 DELAY_OUT_TAP15 a_15545_949# VDD.t0 sg13_lv_pmos ad=0.252p pd=1.57u as=0.3808p ps=2.92u w=1.12u l=0.13u
X48 a_3171_216.t1 a_2873_236# VDD.t74 VDD.t0 sg13_lv_pmos ad=0.2128p pd=1.5u as=0.1918p ps=1.5u w=1.12u l=0.13u
X49 a_14235_949# a_14025_949# VSS.t69 VSS.t104 sg13_lv_nmos ad=0.1406p pd=1.12u as=0.1665p ps=1.19u w=0.74u l=0.13u
X50 VSS.t21 a_3747_952.t7 a_12791_913# VSS.t20 sg13_lv_nmos ad=0.2516p pd=2.16u as=0.2516p ps=2.16u w=0.74u l=0.13u
X51 a_3747_216.t1 a_3449_236# VDD.t78 VDD.t0 sg13_lv_pmos ad=0.2128p pd=1.5u as=0.1918p ps=1.5u w=1.12u l=0.13u
X52 a_12715_949# a_12505_949# VDD.t113 VDD.t0 sg13_lv_pmos ad=0.2128p pd=1.5u as=0.252p ps=1.57u w=1.12u l=0.13u
X53 a_11848_949# DELAY_OUT_TAP10 VSS.t117 VSS.t273 sg13_lv_nmos ad=0.1406p pd=1.12u as=0.2516p ps=2.16u w=0.74u l=0.13u
X54 a_17275_949# a_17065_949# VDD.t112 VDD.t0 sg13_lv_pmos ad=0.2128p pd=1.5u as=0.252p ps=1.57u w=1.12u l=0.13u
X55 VDD.t105 VSS.t183 VDD.t104 VDD.t0 sg13_lv_pmos ad=0.19p pd=1.38u as=0 ps=0 w=1u l=1u
X56 VDD.t11 VSS.t185 VDD.t10 VDD.t0 sg13_lv_pmos ad=0.34p pd=2.68u as=0 ps=0 w=1u l=1u
X57 a_10430_949# a_12791_913# a_12715_949# VDD.t0 sg13_lv_pmos ad=0.3808p pd=2.92u as=0.2128p ps=1.5u w=1.12u l=0.13u
X58 VSS.t64 DELAY_OUT_TAP21 a_20105_949# VSS.t322 sg13_lv_nmos ad=0.1665p pd=1.19u as=0.2516p ps=2.16u w=0.74u l=0.13u
X59 a_16510_949# a_17351_913# a_17275_949# VDD.t0 sg13_lv_pmos ad=0.3808p pd=2.92u as=0.2128p ps=1.5u w=1.12u l=0.13u
X60 VSS.t268 a_1721_1300# a_2019_952.t0 VSS.t267 sg13_lv_nmos ad=0.2812p pd=2.24u as=0.1406p ps=1.12u w=0.74u l=0.13u
X61 a_5731_194# a_14825_424# a_13470_949# VDD.t0 sg13_lv_pmos ad=0.3808p pd=2.92u as=0.3808p ps=2.92u w=1.12u l=0.13u
X62 a_16510_949# a_2595_952.t5 a_17275_949# VSS.t13 sg13_lv_nmos ad=0.2516p pd=2.16u as=0.1406p ps=1.12u w=0.74u l=0.13u
X63 a_8155_949# a_7945_949# VDD.t158 VDD.t0 sg13_lv_pmos ad=0.2128p pd=1.5u as=0.252p ps=1.57u w=1.12u l=0.13u
X64 VDD.t61 VSS.t250 VDD.t160 VDD.t0 sg13_lv_pmos ad=0.34p pd=2.68u as=0 ps=0 w=1u l=1u
X65 VSS.t114 a_3747_952.t2 a_27991_913# VSS.t113 sg13_lv_nmos ad=0.2516p pd=2.16u as=0.2516p ps=2.16u w=0.74u l=0.13u
X66 VSS.t120 a_3747_952.t9 a_6711_913# VSS.t119 sg13_lv_nmos ad=0.2516p pd=2.16u as=0.2516p ps=2.16u w=0.74u l=0.13u
X67 a_16108_194# a_2595_216.t2 a_19550_949# VSS.t40 sg13_lv_nmos ad=0.2516p pd=2.16u as=0.2516p ps=2.16u w=0.74u l=0.13u
X68 VSS.t241 VDD.t194 VSS.t240 VSS.t239 sg13_lv_nmos ad=0.1428p pd=1.52u as=0 ps=0 w=0.42u l=1u
X69 a_7390_949# a_8231_913# a_8155_949# VDD.t0 sg13_lv_pmos ad=0.3808p pd=2.92u as=0.2128p ps=1.5u w=1.12u l=0.13u
X70 VSS.t206 VDD.t201 VSS.t205 VSS.t204 sg13_lv_nmos ad=0.1428p pd=1.52u as=0 ps=0 w=0.42u l=1u
X71 a_3171_216.t0 a_2873_236# VSS.t100 VSS.t306 sg13_lv_nmos ad=0.1406p pd=1.12u as=0.1331p ps=1.12u w=0.74u l=0.13u
X72 a_5731_194# a_5705_424# a_4350_949# VDD.t0 sg13_lv_pmos ad=0.3808p pd=2.92u as=0.3808p ps=2.92u w=1.12u l=0.13u
X73 VDD.t171 a_2873_236# a_3171_216.t1 VDD.t0 sg13_lv_pmos ad=0.4256p pd=3u as=0.2128p ps=1.5u w=1.12u l=0.13u
X74 a_3747_216.t0 a_3449_236# VSS.t106 VSS.t105 sg13_lv_nmos ad=0.1406p pd=1.12u as=0.1331p ps=1.12u w=0.74u l=0.13u
X75 VDD.t79 a_3449_236# a_3747_216.t1 VDD.t0 sg13_lv_pmos ad=0.4256p pd=3u as=0.2128p ps=1.5u w=1.12u l=0.13u
X76 a_7390_949# a_2019_952.t8 a_7288_949# VSS.t313 sg13_lv_nmos ad=0.2516p pd=2.16u as=0.1406p ps=1.12u w=0.74u l=0.13u
X77 VDD.t102 DELAY_OUT_TAP21 a_20105_949# VDD.t0 sg13_lv_pmos ad=0.252p pd=1.57u as=0.3808p ps=2.92u w=1.12u l=0.13u
X78 a_19550_949# a_21044_913# a_20968_949# VDD.t0 sg13_lv_pmos ad=0.3808p pd=2.92u as=0.2128p ps=1.5u w=1.12u l=0.13u
X79 VDD.t30 VSS.t243 VDD.t29 VDD.t0 sg13_lv_pmos ad=0.19p pd=1.38u as=0 ps=0 w=1u l=1u
X80 VDD.t36 VSS.t208 VDD.t40 VDD.t0 sg13_lv_pmos ad=0.19p pd=1.38u as=0 ps=0 w=1u l=1u
X81 VDD.t15 a_3171_952.t7 a_11924_913# VDD.t0 sg13_lv_pmos ad=0.3808p pd=2.92u as=0.3808p ps=2.92u w=1.12u l=0.13u
X82 VSS.t64 a_2019_952.t4 a_19524_913# VSS.t63 sg13_lv_nmos ad=0.2516p pd=2.16u as=0.2516p ps=2.16u w=0.74u l=0.13u
X83 a_15755_949# a_15545_949# VSS.t91 VSS.t90 sg13_lv_nmos ad=0.1406p pd=1.12u as=0.1665p ps=1.19u w=0.74u l=0.13u
X84 VSS.t80 a_2595_952.t6 a_14311_913# VSS.t79 sg13_lv_nmos ad=0.2516p pd=2.16u as=0.2516p ps=2.16u w=0.74u l=0.13u
X85 a_5115_949# a_4905_949# VSS.t111 VSS.t146 sg13_lv_nmos ad=0.1406p pd=1.12u as=0.1665p ps=1.19u w=0.74u l=0.13u
X86 a_27915_949# a_27705_949# VDD.t115 VDD.t0 sg13_lv_pmos ad=0.2128p pd=1.5u as=0.252p ps=1.57u w=1.12u l=0.13u
X87 VSS.t198 VDD.t203 VSS.t196 VSS.t197 sg13_lv_nmos ad=79.8f pd=0.8u as=0 ps=0 w=0.42u l=1u
X88 a_23355_949# a_23145_949# VDD.t69 VDD.t0 sg13_lv_pmos ad=0.2128p pd=1.5u as=0.252p ps=1.57u w=1.12u l=0.13u
X89 VDD.t175 a_2019_952.t8 a_7364_913# VDD.t0 sg13_lv_pmos ad=0.3808p pd=2.92u as=0.3808p ps=2.92u w=1.12u l=0.13u
X90 VSS.t308 a_2873_236# a_3171_216.t0 VSS.t307 sg13_lv_nmos ad=0.2812p pd=2.24u as=0.1406p ps=1.12u w=0.74u l=0.13u
X91 VDD.t177 VSS.t180 VDD.t105 VDD.t0 sg13_lv_pmos ad=0.34p pd=2.68u as=0 ps=0 w=1u l=1u
X92 a_25630_949# a_27991_913# a_27915_949# VDD.t0 sg13_lv_pmos ad=0.3808p pd=2.92u as=0.2128p ps=1.5u w=1.12u l=0.13u
X93 VSS.t108 a_3449_236# a_3747_216.t0 VSS.t107 sg13_lv_nmos ad=0.2812p pd=2.24u as=0.1406p ps=1.12u w=0.74u l=0.13u
X94 VSS.t39 DELAY_OUT_TAP23 a_21625_949# VSS.t38 sg13_lv_nmos ad=0.1665p pd=1.19u as=0.2516p ps=2.16u w=0.74u l=0.13u
X95 a_22590_949# a_23431_913# a_23355_949# VDD.t0 sg13_lv_pmos ad=0.3808p pd=2.92u as=0.2128p ps=1.5u w=1.12u l=0.13u
X96 a_16108_194# a_20905_424# a_19550_949# VDD.t0 sg13_lv_pmos ad=0.3808p pd=2.92u as=0.3808p ps=2.92u w=1.12u l=0.13u
X97 VDD.t60 a_2595_952.t6 a_14311_913# VDD.t0 sg13_lv_pmos ad=0.3808p pd=2.92u as=0.3808p ps=2.92u w=1.12u l=0.13u
X98 VSS.t111 a_2019_952.t9 a_4324_913# VSS.t110 sg13_lv_nmos ad=0.2516p pd=2.16u as=0.2516p ps=2.16u w=0.74u l=0.13u
X99 a_16510_949# a_3747_952.t5 a_18795_949# VSS.t51 sg13_lv_nmos ad=0.2516p pd=2.16u as=0.1406p ps=1.12u w=0.74u l=0.13u
X100 VDD.t45 a_3747_952.t5 a_18871_913# VDD.t0 sg13_lv_pmos ad=0.3808p pd=2.92u as=0.3808p ps=2.92u w=1.12u l=0.13u
X101 VSS.t83 a_3171_216.t3 a_11785_424# VSS.t82 sg13_lv_nmos ad=0.2516p pd=2.16u as=0.2516p ps=2.16u w=0.74u l=0.13u
X102 VDD.t17 a_3747_952.t8 a_9751_913# VDD.t0 sg13_lv_pmos ad=0.3808p pd=2.92u as=0.3808p ps=2.92u w=1.12u l=0.13u
X103 VDD.t14 a_2595_952.t9 a_5191_913# VDD.t0 sg13_lv_pmos ad=0.3808p pd=2.92u as=0.3808p ps=2.92u w=1.12u l=0.13u
X104 a_10430_949# a_2019_952.t7 a_10328_949# VSS.t0 sg13_lv_nmos ad=0.2516p pd=2.16u as=0.1406p ps=1.12u w=0.74u l=0.13u
X105 a_4157_1218# DELAY_OUT_TAP0 VSS.t77 VSS.t76 sg13_lv_nmos ad=0.2516p pd=2.16u as=0.2553p ps=2.17u w=0.74u l=0.13u
X106 a_7390_949# a_3171_952.t8 a_8808_949# VSS.t32 sg13_lv_nmos ad=0.2516p pd=2.16u as=0.1406p ps=1.12u w=0.74u l=0.13u
X107 VSS.t91 DELAY_OUT_TAP15 a_15545_949# VSS.t285 sg13_lv_nmos ad=0.1665p pd=1.19u as=0.2516p ps=2.16u w=0.74u l=0.13u
X108 VDD.t56 a_2019_952.t3 a_22564_913# VDD.t0 sg13_lv_pmos ad=0.3808p pd=2.92u as=0.3808p ps=2.92u w=1.12u l=0.13u
X109 a_14888_949# DELAY_OUT_TAP14 VDD.t184 VDD.t0 sg13_lv_pmos ad=0.2128p pd=1.5u as=0.3808p ps=2.92u w=1.12u l=0.13u
X110 VSS.t31 a_3171_952.t7 a_11924_913# VSS.t30 sg13_lv_nmos ad=0.2516p pd=2.16u as=0.2516p ps=2.16u w=0.74u l=0.13u
X111 VDD.t33 VSS.t240 VDD.t30 VDD.t0 sg13_lv_pmos ad=0.34p pd=2.68u as=0 ps=0 w=1u l=1u
X112 VDD.t13 a_3171_952.t2 a_27124_913# VDD.t0 sg13_lv_pmos ad=0.3808p pd=2.92u as=0.3808p ps=2.92u w=1.12u l=0.13u
X113 a_10328_949# DELAY_OUT_TAP8 VDD.t183 VDD.t0 sg13_lv_pmos ad=0.2128p pd=1.5u as=0.3808p ps=2.92u w=1.12u l=0.13u
X114 a_19448_949# DELAY_OUT_TAP20 VDD.t147 VDD.t0 sg13_lv_pmos ad=0.2128p pd=1.5u as=0.3808p ps=2.92u w=1.12u l=0.13u
X115 VDD.t36 VSS.t205 VDD.t35 VDD.t0 sg13_lv_pmos ad=0.34p pd=2.68u as=0 ps=0 w=1u l=1u
X116 a_3171_952.t0 a_2873_1300# VSS.t280 VSS.t286 sg13_lv_nmos ad=0.1406p pd=1.12u as=0.1331p ps=1.12u w=0.74u l=0.13u
X117 a_25630_949# a_2019_952.t2 a_25528_949# VSS.t57 sg13_lv_nmos ad=0.2516p pd=2.16u as=0.1406p ps=1.12u w=0.74u l=0.13u
X118 VSS.t317 a_2297_1300# a_2595_952.t0 VSS.t316 sg13_lv_nmos ad=0.2812p pd=2.24u as=0.1406p ps=1.12u w=0.74u l=0.13u
X119 a_16108_194# a_2019_216.t2 a_16510_949# VSS.t157 sg13_lv_nmos ad=0.2516p pd=2.16u as=0.2516p ps=2.16u w=0.74u l=0.13u
X120 a_2391_1300# MUX_SEL0 a_2297_1300# VSS.t165 sg13_lv_nmos ad=0.1216p pd=1.02u as=0.2176p ps=1.96u w=0.64u l=0.13u
X121 VSS.t258 VDD.t191 VSS.t256 VSS.t257 sg13_lv_nmos ad=79.8f pd=0.8u as=0 ps=0 w=0.42u l=1u
X122 VSS.t266 a_1544_949# a_1815_1300# VSS.t269 sg13_lv_nmos ad=0.1331p pd=1.12u as=0.1216p ps=1.02u w=0.64u l=0.13u
X123 a_5768_949# DELAY_OUT_TAP2 VDD.t130 VDD.t0 sg13_lv_pmos ad=0.2128p pd=1.5u as=0.3808p ps=2.92u w=1.12u l=0.13u
X124 VSS.t261 VDD.t190 VSS.t260 VSS.t259 sg13_lv_nmos ad=0.1428p pd=1.52u as=0 ps=0 w=0.42u l=1u
X125 a_16510_949# a_2019_952.t5 a_16408_949# VSS.t133 sg13_lv_nmos ad=0.2516p pd=2.16u as=0.1406p ps=1.12u w=0.74u l=0.13u
X126 VDD.t92 a_2595_952.t4 a_20391_913# VDD.t0 sg13_lv_pmos ad=0.3808p pd=2.92u as=0.3808p ps=2.92u w=1.12u l=0.13u
X127 VSS.t24 a_3171_952.t2 a_27124_913# VSS.t23 sg13_lv_nmos ad=0.2516p pd=2.16u as=0.2516p ps=2.16u w=0.74u l=0.13u
X128 a_5731_194# a_2595_216.t3 a_7390_949# VSS.t125 sg13_lv_nmos ad=0.2516p pd=2.16u as=0.2516p ps=2.16u w=0.74u l=0.13u
X129 VDD.t63 a_3171_216.t3 a_11785_424# VDD.t0 sg13_lv_pmos ad=0.3808p pd=2.92u as=0.3808p ps=2.92u w=1.12u l=0.13u
X130 a_10430_949# a_2595_952.t7 a_11195_949# VSS.t115 sg13_lv_nmos ad=0.2516p pd=2.16u as=0.1406p ps=1.12u w=0.74u l=0.13u
X131 a_23355_949# a_23145_949# VSS.t75 VSS.t92 sg13_lv_nmos ad=0.1406p pd=1.12u as=0.1665p ps=1.19u w=0.74u l=0.13u
X132 VSS.t178 VDD.t207 VSS.t176 VSS.t177 sg13_lv_nmos ad=79.8f pd=0.8u as=0 ps=0 w=0.42u l=1u
X133 VSS.t86 a_3747_952.t4 a_21911_913# VSS.t85 sg13_lv_nmos ad=0.2516p pd=2.16u as=0.2516p ps=2.16u w=0.74u l=0.13u
X134 VSS.t276 a_3747_216.t2 a_26985_424# VSS.t275 sg13_lv_nmos ad=0.2516p pd=2.16u as=0.2516p ps=2.16u w=0.74u l=0.13u
X135 a_20968_949# DELAY_OUT_TAP22 VSS.t94 VSS.t93 sg13_lv_nmos ad=0.1406p pd=1.12u as=0.2516p ps=2.16u w=0.74u l=0.13u
X136 VDD.t20 VSS.t198 VDD.t19 VDD.t0 sg13_lv_pmos ad=0.19p pd=1.38u as=0 ps=0 w=1u l=1u
X137 a_13470_949# a_14964_913# a_14888_949# VDD.t0 sg13_lv_pmos ad=0.3808p pd=2.92u as=0.2128p ps=1.5u w=1.12u l=0.13u
X138 VDD.t75 DELAY_OUT_TAP19 a_18585_949# VDD.t0 sg13_lv_pmos ad=0.252p pd=1.57u as=0.3808p ps=2.92u w=1.12u l=0.13u
X139 a_10430_949# a_10404_913# a_10328_949# VDD.t0 sg13_lv_pmos ad=0.3808p pd=2.92u as=0.2128p ps=1.5u w=1.12u l=0.13u
X140 a_19550_949# a_19524_913# a_19448_949# VDD.t0 sg13_lv_pmos ad=0.3808p pd=2.92u as=0.2128p ps=1.5u w=1.12u l=0.13u
X141 a_2595_216.t1 a_2297_236# VDD.t4 VDD.t0 sg13_lv_pmos ad=0.2128p pd=1.5u as=0.1918p ps=1.5u w=1.12u l=0.13u
X142 a_19448_949# DELAY_OUT_TAP20 VSS.t53 VSS.t283 sg13_lv_nmos ad=0.1406p pd=1.12u as=0.2516p ps=2.16u w=0.74u l=0.13u
X143 a_10430_949# a_3171_952.t7 a_11848_949# VSS.t29 sg13_lv_nmos ad=0.2516p pd=2.16u as=0.1406p ps=1.12u w=0.74u l=0.13u
X144 a_11195_949# a_10985_949# VDD.t101 VDD.t0 sg13_lv_pmos ad=0.2128p pd=1.5u as=0.252p ps=1.57u w=1.12u l=0.13u
X145 a_25630_949# a_2595_952.t2 a_26395_949# VSS.t16 sg13_lv_nmos ad=0.2516p pd=2.16u as=0.1406p ps=1.12u w=0.74u l=0.13u
X146 VDD.t72 a_1721_236# a_2019_216.t1 VDD.t0 sg13_lv_pmos ad=0.4256p pd=3u as=0.2128p ps=1.5u w=1.12u l=0.13u
X147 VDD.t108 DELAY_OUT_TAP1 a_4905_949# VDD.t0 sg13_lv_pmos ad=0.252p pd=1.57u as=0.3808p ps=2.92u w=1.12u l=0.13u
X148 VSS.t218 VDD.t199 VSS.t216 VSS.t217 sg13_lv_nmos ad=79.8f pd=0.8u as=0 ps=0 w=0.42u l=1u
X149 VDD.t51 a_2297_236# a_2595_216.t1 VDD.t0 sg13_lv_pmos ad=0.4256p pd=3u as=0.2128p ps=1.5u w=1.12u l=0.13u
X150 a_4350_949# a_5844_913# a_5768_949# VDD.t0 sg13_lv_pmos ad=0.3808p pd=2.92u as=0.2128p ps=1.5u w=1.12u l=0.13u
X151 a_3449_1300# MUX_SEL0 VDD.t123 VDD.t0 sg13_lv_pmos ad=0.1596p pd=1.22u as=0.2856p ps=2.36u w=0.84u l=0.13u
X152 VDD.t146 DELAY_OUT_TAP7 a_9465_949# VDD.t0 sg13_lv_pmos ad=0.252p pd=1.57u as=0.3808p ps=2.92u w=1.12u l=0.13u
X153 VSS.t56 DELAY_OUT_TAP3 a_6425_949# VSS.t167 sg13_lv_nmos ad=0.1665p pd=1.19u as=0.2516p ps=2.16u w=0.74u l=0.13u
X154 a_10430_949# a_11271_913# a_11195_949# VDD.t0 sg13_lv_pmos ad=0.3808p pd=2.92u as=0.2128p ps=1.5u w=1.12u l=0.13u
X155 a_20968_949# DELAY_OUT_TAP22 VDD.t70 VDD.t0 sg13_lv_pmos ad=0.2128p pd=1.5u as=0.3808p ps=2.92u w=1.12u l=0.13u
X156 VSS.t69 a_2019_952.t6 a_13444_913# VSS.t68 sg13_lv_nmos ad=0.2516p pd=2.16u as=0.2516p ps=2.16u w=0.74u l=0.13u
X157 a_16108_194# a_17865_424# a_16510_949# VDD.t0 sg13_lv_pmos ad=0.3808p pd=2.92u as=0.3808p ps=2.92u w=1.12u l=0.13u
X158 VSS.t143 a_15964_194# a_16851_214# VSS.t160 sg13_lv_nmos ad=0.1371p pd=1.12u as=0.2176p ps=1.96u w=0.64u l=0.13u
X159 a_25528_949# DELAY_OUT_TAP28 VDD.t153 VDD.t0 sg13_lv_pmos ad=0.2128p pd=1.5u as=0.3808p ps=2.92u w=1.12u l=0.13u
X160 VDD.t144 a_1256_949# a_2873_1300# VDD.t0 sg13_lv_pmos ad=0.1918p pd=1.5u as=0.1596p ps=1.22u w=0.84u l=0.13u
X161 a_4248_949# a_4157_1218# VSS.t138 VSS.t137 sg13_lv_nmos ad=0.1406p pd=1.12u as=0.2516p ps=2.16u w=0.74u l=0.13u
X162 a_16108_194# a_3171_216.t2 a_22590_949# VSS.t87 sg13_lv_nmos ad=0.2516p pd=2.16u as=0.2516p ps=2.16u w=0.74u l=0.13u
X163 VSS.t238 VDD.t195 VSS.t236 VSS.t237 sg13_lv_nmos ad=79.8f pd=0.8u as=0 ps=0 w=0.42u l=1u
X164 a_19550_949# a_3747_952.t4 a_21835_949# VSS.t84 sg13_lv_nmos ad=0.2516p pd=2.16u as=0.1406p ps=1.12u w=0.74u l=0.13u
X165 VSS.t75 DELAY_OUT_TAP25 a_23145_949# VSS.t130 sg13_lv_nmos ad=0.1665p pd=1.19u as=0.2516p ps=2.16u w=0.74u l=0.13u
X166 a_5731_194# a_8745_424# a_7390_949# VDD.t0 sg13_lv_pmos ad=0.3808p pd=2.92u as=0.3808p ps=2.92u w=1.12u l=0.13u
X167 a_2595_216.t0 a_2297_236# VSS.t9 VSS.t59 sg13_lv_nmos ad=0.1406p pd=1.12u as=0.1331p ps=1.12u w=0.74u l=0.13u
X168 VDD.t141 a_3747_216.t2 a_26985_424# VDD.t0 sg13_lv_pmos ad=0.3808p pd=2.92u as=0.3808p ps=2.92u w=1.12u l=0.13u
X169 a_10430_949# a_3747_952.t7 a_12715_949# VSS.t19 sg13_lv_nmos ad=0.2516p pd=2.16u as=0.1406p ps=1.12u w=0.74u l=0.13u
X170 VSS.t97 a_1721_236# a_2019_216.t0 VSS.t96 sg13_lv_nmos ad=0.2812p pd=2.24u as=0.1406p ps=1.12u w=0.74u l=0.13u
X171 a_24875_949# a_24665_949# VSS.t44 VSS.t43 sg13_lv_nmos ad=0.1406p pd=1.12u as=0.1665p ps=1.19u w=0.74u l=0.13u
X172 VSS.t61 a_2297_236# a_2595_216.t0 VSS.t60 sg13_lv_nmos ad=0.2812p pd=2.24u as=0.1406p ps=1.12u w=0.74u l=0.13u
X173 VSS.t47 a_2595_952.t3 a_23431_913# VSS.t46 sg13_lv_nmos ad=0.2516p pd=2.16u as=0.2516p ps=2.16u w=0.74u l=0.13u
X174 VDD.t109 MUX_SEL1 a_3449_1300# VDD.t0 sg13_lv_pmos ad=0.1918p pd=1.5u as=0.1596p ps=1.22u w=0.84u l=0.13u
X175 VSS.t176 VDD.t207 VSS.t175 VSS.t174 sg13_lv_nmos ad=0.1428p pd=1.52u as=0 ps=0 w=0.42u l=1u
X176 VSS.t69 DELAY_OUT_TAP13 a_14025_949# VSS.t281 sg13_lv_nmos ad=0.1665p pd=1.19u as=0.2516p ps=2.16u w=0.74u l=0.13u
X177 a_22590_949# a_24084_913# a_24008_949# VDD.t0 sg13_lv_pmos ad=0.3808p pd=2.92u as=0.2128p ps=1.5u w=1.12u l=0.13u
X178 VDD.t180 VSS.t258 VDD.t133 VDD.t0 sg13_lv_pmos ad=0.19p pd=1.38u as=0 ps=0 w=1u l=1u
X179 VDD.t26 DELAY_OUT_TAP27 a_24665_949# VDD.t0 sg13_lv_pmos ad=0.252p pd=1.57u as=0.3808p ps=2.92u w=1.12u l=0.13u
X180 VDD.t86 a_3171_952.t6 a_14964_913# VDD.t0 sg13_lv_pmos ad=0.3808p pd=2.92u as=0.3808p ps=2.92u w=1.12u l=0.13u
X181 a_25630_949# a_25604_913# a_25528_949# VDD.t0 sg13_lv_pmos ad=0.3808p pd=2.92u as=0.2128p ps=1.5u w=1.12u l=0.13u
X182 a_3171_952.t1 a_2873_1300# VDD.t144 VDD.t0 sg13_lv_pmos ad=0.2128p pd=1.5u as=0.1918p ps=1.5u w=1.12u l=0.13u
X183 a_3747_952.t1 a_3449_1300# VDD.t109 VDD.t0 sg13_lv_pmos ad=0.2128p pd=1.5u as=0.1918p ps=1.5u w=1.12u l=0.13u
X184 VDD.t155 VSS.t261 VDD.t154 VDD.t0 sg13_lv_pmos ad=0.34p pd=2.68u as=0 ps=0 w=1u l=1u
X185 VDD.t97 a_2019_952.t5 a_16484_913# VDD.t0 sg13_lv_pmos ad=0.3808p pd=2.92u as=0.3808p ps=2.92u w=1.12u l=0.13u
X186 a_22590_949# a_3171_952.t3 a_24008_949# VSS.t65 sg13_lv_nmos ad=0.2516p pd=2.16u as=0.1406p ps=1.12u w=0.74u l=0.13u
X187 VDD.t106 a_15964_194# a_16851_214# VDD.t0 sg13_lv_pmos ad=0.2086p pd=1.5u as=0.34p ps=2.68u w=1u l=0.13u
X188 a_26395_949# a_26185_949# VDD.t76 VDD.t0 sg13_lv_pmos ad=0.2128p pd=1.5u as=0.252p ps=1.57u w=1.12u l=0.13u
X189 a_3747_952.t0 a_3449_1300# VSS.t148 VSS.t147 sg13_lv_nmos ad=0.1406p pd=1.12u as=0.1331p ps=1.12u w=0.74u l=0.13u
X190 a_25630_949# a_3747_952.t2 a_27915_949# VSS.t112 sg13_lv_nmos ad=0.2516p pd=2.16u as=0.1406p ps=1.12u w=0.74u l=0.13u
X191 VSS.t233 VDD.t196 VSS.t231 VSS.t232 sg13_lv_nmos ad=79.8f pd=0.8u as=0 ps=0 w=0.42u l=1u
X192 VDD.t23 VSS.t178 VDD.t83 VDD.t0 sg13_lv_pmos ad=0.19p pd=1.38u as=0 ps=0 w=1u l=1u
X193 a_2967_1300# MUX_SEL1 a_2873_1300# VSS.t170 sg13_lv_nmos ad=0.1216p pd=1.02u as=0.2176p ps=1.96u w=0.64u l=0.13u
X194 VDD.t46 a_3171_952.t9 a_5844_913# VDD.t0 sg13_lv_pmos ad=0.3808p pd=2.92u as=0.3808p ps=2.92u w=1.12u l=0.13u
X195 VSS.t228 VDD.t197 VSS.t226 VSS.t227 sg13_lv_nmos ad=79.8f pd=0.8u as=0 ps=0 w=0.42u l=1u
X196 VSS.t201 VDD.t202 VSS.t200 VSS.t199 sg13_lv_nmos ad=0.1428p pd=1.52u as=0 ps=0 w=0.42u l=1u
X197 a_25630_949# a_26471_913# a_26395_949# VDD.t0 sg13_lv_pmos ad=0.3808p pd=2.92u as=0.2128p ps=1.5u w=1.12u l=0.13u
X198 a_3543_236# MUX_SEL2 a_3449_236# VSS.t299 sg13_lv_nmos ad=0.1216p pd=1.02u as=0.2176p ps=1.96u w=0.64u l=0.13u
X199 a_16108_194# a_23945_424# a_22590_949# VDD.t0 sg13_lv_pmos ad=0.3808p pd=2.92u as=0.3808p ps=2.92u w=1.12u l=0.13u
X200 VDD.t8 a_2595_952.t5 a_17351_913# VDD.t0 sg13_lv_pmos ad=0.3808p pd=2.92u as=0.3808p ps=2.92u w=1.12u l=0.13u
X201 VDD.t12 a_3747_952.t7 a_12791_913# VDD.t0 sg13_lv_pmos ad=0.3808p pd=2.92u as=0.3808p ps=2.92u w=1.12u l=0.13u
X202 a_8155_949# a_7945_949# VSS.t294 VSS.t293 sg13_lv_nmos ad=0.1406p pd=1.12u as=0.1665p ps=1.19u w=0.74u l=0.13u
X203 a_27048_949# DELAY_OUT_TAP30 VSS.t18 VSS.t162 sg13_lv_nmos ad=0.1406p pd=1.12u as=0.2516p ps=2.16u w=0.74u l=0.13u
X204 a_5768_949# DELAY_OUT_TAP2 VSS.t27 VSS.t172 sg13_lv_nmos ad=0.1406p pd=1.12u as=0.2516p ps=2.16u w=0.74u l=0.13u
X205 VSS.t155 a_3747_216.t3 a_14825_424# VSS.t154 sg13_lv_nmos ad=0.2516p pd=2.16u as=0.2516p ps=2.16u w=0.74u l=0.13u
X206 VSS.t100 a_1256_194# a_2967_236# VSS.t99 sg13_lv_nmos ad=0.1331p pd=1.12u as=0.1216p ps=1.02u w=0.64u l=0.13u
X207 VSS.t236 VDD.t195 VSS.t235 VSS.t234 sg13_lv_nmos ad=0.1428p pd=1.52u as=0 ps=0 w=0.42u l=1u
X208 VDD.t41 VSS.t218 VDD.t122 VDD.t0 sg13_lv_pmos ad=0.19p pd=1.38u as=0 ps=0 w=1u l=1u
X209 VDD.t151 a_2873_1300# a_3171_952.t1 VDD.t0 sg13_lv_pmos ad=0.4256p pd=3u as=0.2128p ps=1.5u w=1.12u l=0.13u
X210 VSS.t44 DELAY_OUT_TAP27 a_24665_949# VSS.t291 sg13_lv_nmos ad=0.1665p pd=1.19u as=0.2516p ps=2.16u w=0.74u l=0.13u
X211 VDD.t39 a_2595_952.t8 a_8231_913# VDD.t0 sg13_lv_pmos ad=0.3808p pd=2.92u as=0.3808p ps=2.92u w=1.12u l=0.13u
X212 a_16510_949# a_3171_952.t5 a_17928_949# VSS.t128 sg13_lv_nmos ad=0.2516p pd=2.16u as=0.1406p ps=1.12u w=0.74u l=0.13u
X213 VDD.t110 a_3449_1300# a_3747_952.t1 VDD.t0 sg13_lv_pmos ad=0.4256p pd=3u as=0.2128p ps=1.5u w=1.12u l=0.13u
X214 VSS.t39 a_3171_952.t4 a_21044_913# VSS.t132 sg13_lv_nmos ad=0.2516p pd=2.16u as=0.2516p ps=2.16u w=0.74u l=0.13u
X215 VDD.t28 VSS.t238 VDD.t27 VDD.t0 sg13_lv_pmos ad=0.19p pd=1.38u as=0 ps=0 w=1u l=1u
X216 VSS.t106 MUX_SEL3 a_3543_236# VSS.t303 sg13_lv_nmos ad=0.1331p pd=1.12u as=0.1216p ps=1.02u w=0.64u l=0.13u
X217 VDD.t96 a_3171_952.t4 a_21044_913# VDD.t0 sg13_lv_pmos ad=0.3808p pd=2.92u as=0.3808p ps=2.92u w=1.12u l=0.13u
X218 a_13368_949# DELAY_OUT_TAP12 VDD.t139 VDD.t0 sg13_lv_pmos ad=0.2128p pd=1.5u as=0.3808p ps=2.92u w=1.12u l=0.13u
X219 VSS.t288 a_2873_1300# a_3171_952.t0 VSS.t287 sg13_lv_nmos ad=0.2812p pd=2.24u as=0.1406p ps=1.12u w=0.74u l=0.13u
X220 a_13368_949# DELAY_OUT_TAP12 VSS.t21 VSS.t272 sg13_lv_nmos ad=0.1406p pd=1.12u as=0.2516p ps=2.16u w=0.74u l=0.13u
X221 a_5731_194# a_3171_216.t3 a_10430_949# VSS.t81 sg13_lv_nmos ad=0.2516p pd=2.16u as=0.2516p ps=2.16u w=0.74u l=0.13u
X222 VSS.t271 a_1544_949# a_2391_1300# VSS.t270 sg13_lv_nmos ad=0.1331p pd=1.12u as=0.1216p ps=1.02u w=0.64u l=0.13u
X223 a_2019_952.t0 a_1721_1300# VSS.t266 VSS.t265 sg13_lv_nmos ad=0.1406p pd=1.12u as=0.1331p ps=1.12u w=0.74u l=0.13u
X224 a_4350_949# a_3747_952.t9 a_6635_949# VSS.t118 sg13_lv_nmos ad=0.2516p pd=2.16u as=0.1406p ps=1.12u w=0.74u l=0.13u
X225 a_19550_949# a_2595_952.t4 a_20315_949# VSS.t123 sg13_lv_nmos ad=0.2516p pd=2.16u as=0.1406p ps=1.12u w=0.74u l=0.13u
X226 a_8808_949# DELAY_OUT_TAP6 VDD.t185 VDD.t0 sg13_lv_pmos ad=0.2128p pd=1.5u as=0.3808p ps=2.92u w=1.12u l=0.13u
X227 VSS.t294 DELAY_OUT_TAP5 a_7945_949# VSS.t323 sg13_lv_nmos ad=0.1665p pd=1.19u as=0.2516p ps=2.16u w=0.74u l=0.13u
X228 a_2019_216.t1 a_1721_236# VDD.t3 VDD.t0 sg13_lv_pmos ad=0.2128p pd=1.5u as=0.1918p ps=1.5u w=1.12u l=0.13u
X229 VSS.t231 VDD.t196 VSS.t230 VSS.t229 sg13_lv_nmos ad=0.1428p pd=1.52u as=0 ps=0 w=0.42u l=1u
X230 a_4248_949# a_4157_1218# VDD.t100 VDD.t0 sg13_lv_pmos ad=0.2128p pd=1.5u as=0.3808p ps=2.92u w=1.12u l=0.13u
X231 VDD.t23 VSS.t175 VDD.t22 VDD.t0 sg13_lv_pmos ad=0.34p pd=2.68u as=0 ps=0 w=1u l=1u
X232 VSS.t196 VDD.t203 VSS.t195 VSS.t194 sg13_lv_nmos ad=0.1428p pd=1.52u as=0 ps=0 w=0.42u l=1u
X233 VSS.t226 VDD.t197 VSS.t225 VSS.t224 sg13_lv_nmos ad=0.1428p pd=1.52u as=0 ps=0 w=0.42u l=1u
X234 VDD.t31 a_2595_952.t3 a_23431_913# VDD.t0 sg13_lv_pmos ad=0.3808p pd=2.92u as=0.3808p ps=2.92u w=1.12u l=0.13u
X235 VDD.t114 a_3747_216.t3 a_14825_424# VDD.t0 sg13_lv_pmos ad=0.3808p pd=2.92u as=0.3808p ps=2.92u w=1.12u l=0.13u
X236 VDD.t82 a_3747_952.t2 a_27991_913# VDD.t0 sg13_lv_pmos ad=0.3808p pd=2.92u as=0.3808p ps=2.92u w=1.12u l=0.13u
X237 a_2297_1300# MUX_SEL0 VDD.t125 VDD.t0 sg13_lv_pmos ad=0.1596p pd=1.22u as=0.2856p ps=2.36u w=0.84u l=0.13u
X238 a_9675_949# a_9465_949# VSS.t34 VSS.t292 sg13_lv_nmos ad=0.1406p pd=1.12u as=0.1665p ps=1.19u w=0.74u l=0.13u
X239 VSS.t193 VDD.t204 VSS.t191 VSS.t192 sg13_lv_nmos ad=79.8f pd=0.8u as=0 ps=0 w=0.42u l=1u
X240 a_2873_1300# MUX_SEL1 VDD.t129 VDD.t0 sg13_lv_pmos ad=0.1596p pd=1.22u as=0.2856p ps=2.36u w=0.84u l=0.13u
X241 VSS.t50 a_2595_952.t8 a_8231_913# VSS.t49 sg13_lv_nmos ad=0.2516p pd=2.16u as=0.2516p ps=2.16u w=0.74u l=0.13u
X242 VSS.t42 a_2595_216.t2 a_20905_424# VSS.t41 sg13_lv_nmos ad=0.2516p pd=2.16u as=0.2516p ps=2.16u w=0.74u l=0.13u
X243 a_3449_236# MUX_SEL2 VDD.t163 VDD.t0 sg13_lv_pmos ad=0.1596p pd=1.22u as=0.2856p ps=2.36u w=0.84u l=0.13u
X244 VDD.t113 DELAY_OUT_TAP11 a_12505_949# VDD.t0 sg13_lv_pmos ad=0.252p pd=1.57u as=0.3808p ps=2.92u w=1.12u l=0.13u
X245 VDD.t7 VSS.t233 VDD.t6 VDD.t0 sg13_lv_pmos ad=0.19p pd=1.38u as=0 ps=0 w=1u l=1u
X246 a_13470_949# a_13444_913# a_13368_949# VDD.t0 sg13_lv_pmos ad=0.3808p pd=2.92u as=0.2128p ps=1.5u w=1.12u l=0.13u
X247 VDD.t112 DELAY_OUT_TAP17 a_17065_949# VDD.t0 sg13_lv_pmos ad=0.252p pd=1.57u as=0.3808p ps=2.92u w=1.12u l=0.13u
X248 a_16510_949# a_18004_913# a_17928_949# VDD.t0 sg13_lv_pmos ad=0.3808p pd=2.92u as=0.2128p ps=1.5u w=1.12u l=0.13u
X249 a_19550_949# a_2019_952.t4 a_19448_949# VSS.t62 sg13_lv_nmos ad=0.2516p pd=2.16u as=0.1406p ps=1.12u w=0.74u l=0.13u
X250 VDD.t38 VSS.t228 VDD.t37 VDD.t0 sg13_lv_pmos ad=0.19p pd=1.38u as=0 ps=0 w=1u l=1u
X251 VDD.t44 VSS.t200 VDD.t43 VDD.t0 sg13_lv_pmos ad=0.34p pd=2.68u as=0 ps=0 w=1u l=1u
X252 VDD.t74 a_1256_194# a_2873_236# VDD.t0 sg13_lv_pmos ad=0.1918p pd=1.5u as=0.1596p ps=1.22u w=0.84u l=0.13u
X253 a_13470_949# a_2595_952.t6 a_14235_949# VSS.t78 sg13_lv_nmos ad=0.2516p pd=2.16u as=0.1406p ps=1.12u w=0.74u l=0.13u
X254 VSS.t75 a_2019_952.t3 a_22564_913# VSS.t74 sg13_lv_nmos ad=0.2516p pd=2.16u as=0.2516p ps=2.16u w=0.74u l=0.13u
X255 a_15755_949# a_15545_949# VDD.t68 VDD.t0 sg13_lv_pmos ad=0.2128p pd=1.5u as=0.252p ps=1.57u w=1.12u l=0.13u
X256 a_7390_949# a_8884_913# a_8808_949# VDD.t0 sg13_lv_pmos ad=0.3808p pd=2.92u as=0.2128p ps=1.5u w=1.12u l=0.13u
X257 a_2019_216.t0 a_1721_236# VSS.t7 VSS.t95 sg13_lv_nmos ad=0.1406p pd=1.12u as=0.1331p ps=1.12u w=0.74u l=0.13u
X258 a_4350_949# a_4324_913# a_4248_949# VDD.t0 sg13_lv_pmos ad=0.3808p pd=2.92u as=0.2128p ps=1.5u w=1.12u l=0.13u
X259 VDD.t158 DELAY_OUT_TAP5 a_7945_949# VDD.t0 sg13_lv_pmos ad=0.252p pd=1.57u as=0.3808p ps=2.92u w=1.12u l=0.13u
X260 a_24008_949# DELAY_OUT_TAP26 VDD.t172 VDD.t0 sg13_lv_pmos ad=0.2128p pd=1.5u as=0.3808p ps=2.92u w=1.12u l=0.13u
X261 a_5731_194# a_11785_424# a_10430_949# VDD.t0 sg13_lv_pmos ad=0.3808p pd=2.92u as=0.3808p ps=2.92u w=1.12u l=0.13u
X262 a_5115_949# a_4905_949# VDD.t108 VDD.t0 sg13_lv_pmos ad=0.2128p pd=1.5u as=0.252p ps=1.57u w=1.12u l=0.13u
X263 VDD.t28 VSS.t235 VDD.t34 VDD.t0 sg13_lv_pmos ad=0.34p pd=2.68u as=0 ps=0 w=1u l=1u
X264 a_13470_949# a_15831_913# a_15755_949# VDD.t0 sg13_lv_pmos ad=0.3808p pd=2.92u as=0.2128p ps=1.5u w=1.12u l=0.13u
X265 a_17275_949# a_17065_949# VSS.t135 VSS.t151 sg13_lv_nmos ad=0.1406p pd=1.12u as=0.1665p ps=1.19u w=0.74u l=0.13u
X266 VDD.t138 a_1544_949# a_2297_1300# VDD.t0 sg13_lv_pmos ad=0.1918p pd=1.5u as=0.1596p ps=1.22u w=0.84u l=0.13u
X267 VSS.t12 a_3747_952.t6 a_15831_913# VSS.t11 sg13_lv_nmos ad=0.2516p pd=2.16u as=0.2516p ps=2.16u w=0.74u l=0.13u
X268 a_4350_949# a_2019_952.t9 a_4248_949# VSS.t109 sg13_lv_nmos ad=0.2516p pd=2.16u as=0.1406p ps=1.12u w=0.74u l=0.13u
X269 VSS.t188 VDD.t205 VSS.t186 VSS.t187 sg13_lv_nmos ad=79.8f pd=0.8u as=0 ps=0 w=0.42u l=1u
X270 a_6635_949# a_6425_949# VDD.t99 VDD.t0 sg13_lv_pmos ad=0.2128p pd=1.5u as=0.252p ps=1.57u w=1.12u l=0.13u
X271 a_14888_949# DELAY_OUT_TAP14 VSS.t80 VSS.t319 sg13_lv_nmos ad=0.1406p pd=1.12u as=0.2516p ps=2.16u w=0.74u l=0.13u
X272 a_16108_194# a_3747_216.t2 a_25630_949# VSS.t274 sg13_lv_nmos ad=0.2516p pd=2.16u as=0.2516p ps=2.16u w=0.74u l=0.13u
X273 VSS.t253 VDD.t192 VSS.t251 VSS.t252 sg13_lv_nmos ad=79.8f pd=0.8u as=0 ps=0 w=0.42u l=1u
X274 a_4350_949# a_5191_913# a_5115_949# VDD.t0 sg13_lv_pmos ad=0.3808p pd=2.92u as=0.2128p ps=1.5u w=1.12u l=0.13u
X275 VDD.t78 MUX_SEL3 a_3449_236# VDD.t0 sg13_lv_pmos ad=0.1918p pd=1.5u as=0.1596p ps=1.22u w=0.84u l=0.13u
X276 VSS.t34 DELAY_OUT_TAP7 a_9465_949# VSS.t282 sg13_lv_nmos ad=0.1665p pd=1.19u as=0.2516p ps=2.16u w=0.74u l=0.13u
X277 a_4350_949# a_6711_913# a_6635_949# VDD.t0 sg13_lv_pmos ad=0.3808p pd=2.92u as=0.2128p ps=1.5u w=1.12u l=0.13u
X278 VSS.t256 VDD.t191 VSS.t255 VSS.t254 sg13_lv_nmos ad=0.1428p pd=1.52u as=0 ps=0 w=0.42u l=1u
X279 VSS.t135 a_2019_952.t5 a_16484_913# VSS.t134 sg13_lv_nmos ad=0.2516p pd=2.16u as=0.2516p ps=2.16u w=0.74u l=0.13u
X280 VSS.t56 a_3171_952.t9 a_5844_913# VSS.t55 sg13_lv_nmos ad=0.2516p pd=2.16u as=0.2516p ps=2.16u w=0.74u l=0.13u
X281 VDD.t21 a_2595_216.t2 a_20905_424# VDD.t0 sg13_lv_pmos ad=0.3808p pd=2.92u as=0.3808p ps=2.92u w=1.12u l=0.13u
X282 VSS.t117 a_2595_952.t7 a_11271_913# VSS.t116 sg13_lv_nmos ad=0.2516p pd=2.16u as=0.2516p ps=2.16u w=0.74u l=0.13u
X283 VSS.t37 a_3747_952.t8 a_9751_913# VSS.t36 sg13_lv_nmos ad=0.2516p pd=2.16u as=0.2516p ps=2.16u w=0.74u l=0.13u
X284 a_1256_949# MUX_SEL0 VDD.t124 VDD.t0 sg13_lv_pmos ad=0.3808p pd=2.92u as=0.3808p ps=2.92u w=1.12u l=0.13u
X285 a_2391_236# MUX_SEL2 a_2297_236# VSS.t298 sg13_lv_nmos ad=0.1216p pd=1.02u as=0.2176p ps=1.96u w=0.64u l=0.13u
X286 a_2967_236# MUX_SEL3 a_2873_236# VSS.t302 sg13_lv_nmos ad=0.1216p pd=1.02u as=0.2176p ps=1.96u w=0.64u l=0.13u
X287 VDD.t115 DELAY_OUT_TAP31 a_27705_949# VDD.t0 sg13_lv_pmos ad=0.252p pd=1.57u as=0.3808p ps=2.92u w=1.12u l=0.13u
X288 VDD.t69 DELAY_OUT_TAP25 a_23145_949# VDD.t0 sg13_lv_pmos ad=0.252p pd=1.57u as=0.3808p ps=2.92u w=1.12u l=0.13u
X289 a_2595_952.t1 a_2297_1300# VDD.t138 VDD.t0 sg13_lv_pmos ad=0.2128p pd=1.5u as=0.1918p ps=1.5u w=1.12u l=0.13u
X290 VDD.t25 VSS.t230 VDD.t7 VDD.t0 sg13_lv_pmos ad=0.34p pd=2.68u as=0 ps=0 w=1u l=1u
X291 VDD.t1 a_2019_952.t7 a_10404_913# VDD.t0 sg13_lv_pmos ad=0.3808p pd=2.92u as=0.3808p ps=2.92u w=1.12u l=0.13u
X292 VDD.t52 a_2019_952.t4 a_19524_913# VDD.t0 sg13_lv_pmos ad=0.3808p pd=2.92u as=0.3808p ps=2.92u w=1.12u l=0.13u
X293 VDD.t88 VSS.t195 VDD.t20 VDD.t0 sg13_lv_pmos ad=0.34p pd=2.68u as=0 ps=0 w=1u l=1u
X294 a_20315_949# a_20105_949# VDD.t102 VDD.t0 sg13_lv_pmos ad=0.2128p pd=1.5u as=0.252p ps=1.57u w=1.12u l=0.13u
X295 a_1544_949# MUX_SEL1 VSS.t169 VSS.t168 sg13_lv_nmos ad=0.2516p pd=2.16u as=0.2516p ps=2.16u w=0.74u l=0.13u
X296 VDD.t49 VSS.t225 VDD.t38 VDD.t0 sg13_lv_pmos ad=0.34p pd=2.68u as=0 ps=0 w=1u l=1u
X297 a_13470_949# a_3747_952.t6 a_15755_949# VSS.t10 sg13_lv_nmos ad=0.2516p pd=2.16u as=0.1406p ps=1.12u w=0.74u l=0.13u
X298 VSS.t148 a_3449_1300# a_3747_952.t0 VSS.t149 sg13_lv_nmos ad=0.2812p pd=2.24u as=0.1406p ps=1.12u w=0.74u l=0.13u
X299 a_4350_949# a_2595_952.t9 a_5115_949# VSS.t25 sg13_lv_nmos ad=0.2516p pd=2.16u as=0.1406p ps=1.12u w=0.74u l=0.13u
X300 VDD.t136 a_1721_1300# a_2019_952.t1 VDD.t0 sg13_lv_pmos ad=0.4256p pd=3u as=0.2128p ps=1.5u w=1.12u l=0.13u
X301 VSS.t18 a_2595_952.t2 a_26471_913# VSS.t17 sg13_lv_nmos ad=0.2516p pd=2.16u as=0.2516p ps=2.16u w=0.74u l=0.13u
X302 VSS.t248 VDD.t193 VSS.t246 VSS.t247 sg13_lv_nmos ad=79.8f pd=0.8u as=0 ps=0 w=0.42u l=1u
X303 a_21835_949# a_21625_949# VDD.t18 VDD.t0 sg13_lv_pmos ad=0.2128p pd=1.5u as=0.252p ps=1.57u w=1.12u l=0.13u
X304 a_3543_1300# MUX_SEL0 a_3449_1300# VSS.t166 sg13_lv_nmos ad=0.1216p pd=1.02u as=0.2176p ps=1.96u w=0.64u l=0.13u
X305 VDD.t182 a_2297_1300# a_2595_952.t1 VDD.t0 sg13_lv_pmos ad=0.4256p pd=3u as=0.2128p ps=1.5u w=1.12u l=0.13u
X306 VSS.t135 DELAY_OUT_TAP17 a_17065_949# VSS.t289 sg13_lv_nmos ad=0.1665p pd=1.19u as=0.2516p ps=2.16u w=0.74u l=0.13u
X307 VDD.t90 VSS.t193 VDD.t89 VDD.t0 sg13_lv_pmos ad=0.19p pd=1.38u as=0 ps=0 w=1u l=1u
X308 VSS.t213 VDD.t200 VSS.t211 VSS.t212 sg13_lv_nmos ad=79.8f pd=0.8u as=0 ps=0 w=0.42u l=1u
X309 a_19550_949# a_20391_913# a_20315_949# VDD.t0 sg13_lv_pmos ad=0.3808p pd=2.92u as=0.2128p ps=1.5u w=1.12u l=0.13u
X310 VSS.t216 VDD.t199 VSS.t215 VSS.t214 sg13_lv_nmos ad=0.1428p pd=1.52u as=0 ps=0 w=0.42u l=1u
X311 a_1544_949# MUX_SEL1 VDD.t128 VDD.t0 sg13_lv_pmos ad=0.3808p pd=2.92u as=0.3808p ps=2.92u w=1.12u l=0.13u
X312 a_16108_194# a_26985_424# a_25630_949# VDD.t0 sg13_lv_pmos ad=0.3808p pd=2.92u as=0.3808p ps=2.92u w=1.12u l=0.13u
X313 a_19550_949# a_21911_913# a_21835_949# VDD.t0 sg13_lv_pmos ad=0.3808p pd=2.92u as=0.2128p ps=1.5u w=1.12u l=0.13u
X314 VDD.t5 a_3747_952.t6 a_15831_913# VDD.t0 sg13_lv_pmos ad=0.3808p pd=2.92u as=0.3808p ps=2.92u w=1.12u l=0.13u
X315 a_18795_949# a_18585_949# VSS.t102 VSS.t101 sg13_lv_nmos ad=0.1406p pd=1.12u as=0.1665p ps=1.19u w=0.74u l=0.13u
X316 a_25630_949# a_3171_952.t2 a_27048_949# VSS.t22 sg13_lv_nmos ad=0.2516p pd=2.16u as=0.1406p ps=1.12u w=0.74u l=0.13u
X317 VSS.t15 a_2595_952.t5 a_17351_913# VSS.t14 sg13_lv_nmos ad=0.2516p pd=2.16u as=0.2516p ps=2.16u w=0.74u l=0.13u
X318 a_4350_949# a_3171_952.t9 a_5768_949# VSS.t54 sg13_lv_nmos ad=0.2516p pd=2.16u as=0.1406p ps=1.12u w=0.74u l=0.13u
X319 VSS.t159 a_2019_216.t2 a_17865_424# VSS.t158 sg13_lv_nmos ad=0.2516p pd=2.16u as=0.2516p ps=2.16u w=0.74u l=0.13u
X320 VSS.t9 a_1544_194# a_2391_236# VSS.t8 sg13_lv_nmos ad=0.1331p pd=1.12u as=0.1216p ps=1.02u w=0.64u l=0.13u
X321 VSS.t294 a_2019_952.t8 a_7364_913# VSS.t314 sg13_lv_nmos ad=0.2516p pd=2.16u as=0.2516p ps=2.16u w=0.74u l=0.13u
X322 VSS.t5 a_2019_216.t3 a_5705_424# VSS.t4 sg13_lv_nmos ad=0.2516p pd=2.16u as=0.2516p ps=2.16u w=0.74u l=0.13u
X323 MUX_OUT a_16851_214# VDD.t106 VDD.t0 sg13_lv_pmos ad=0.2128p pd=1.5u as=0.2086p ps=1.5u w=1.12u l=0.13u
X324 a_22488_949# DELAY_OUT_TAP24 VSS.t86 VSS.t304 sg13_lv_nmos ad=0.1406p pd=1.12u as=0.2516p ps=2.16u w=0.74u l=0.13u
X325 VDD.t10 VSS.t188 VDD.t98 VDD.t0 sg13_lv_pmos ad=0.19p pd=1.38u as=0 ps=0 w=1u l=1u
X326 VDD.t62 VSS.t253 VDD.t61 VDD.t0 sg13_lv_pmos ad=0.19p pd=1.38u as=0 ps=0 w=1u l=1u
X327 a_16408_949# DELAY_OUT_TAP16 VDD.t148 VDD.t0 sg13_lv_pmos ad=0.2128p pd=1.5u as=0.3808p ps=2.92u w=1.12u l=0.13u
X328 a_13470_949# a_2019_952.t6 a_13368_949# VSS.t67 sg13_lv_nmos ad=0.2516p pd=2.16u as=0.1406p ps=1.12u w=0.74u l=0.13u
X329 a_15964_194# a_15765_368# a_5731_194# VSS.t28 sg13_lv_nmos ad=0.2183p pd=1.33u as=0.2516p ps=2.16u w=0.74u l=0.13u
X330 VDD.t47 a_2019_952.t2 a_25604_913# VDD.t0 sg13_lv_pmos ad=0.3808p pd=2.92u as=0.3808p ps=2.92u w=1.12u l=0.13u
X331 a_2595_952.t0 a_2297_1300# VSS.t271 VSS.t315 sg13_lv_nmos ad=0.1406p pd=1.12u as=0.1331p ps=1.12u w=0.74u l=0.13u
X332 a_17928_949# DELAY_OUT_TAP18 VDD.t159 VDD.t0 sg13_lv_pmos ad=0.2128p pd=1.5u as=0.3808p ps=2.92u w=1.12u l=0.13u
X333 VSS.t44 a_3171_952.t3 a_24084_913# VSS.t66 sg13_lv_nmos ad=0.2516p pd=2.16u as=0.2516p ps=2.16u w=0.74u l=0.13u
X334 VDD.t133 VSS.t255 VDD.t132 VDD.t0 sg13_lv_pmos ad=0.34p pd=2.68u as=0 ps=0 w=1u l=1u
X335 a_2297_236# MUX_SEL2 VDD.t161 VDD.t0 sg13_lv_pmos ad=0.1596p pd=1.22u as=0.2856p ps=2.36u w=0.84u l=0.13u
X336 a_1815_1300# a_1256_949# a_1721_1300# VSS.t278 sg13_lv_nmos ad=0.1216p pd=1.02u as=0.2176p ps=1.96u w=0.64u l=0.13u
X337 a_2873_236# MUX_SEL3 VDD.t165 VDD.t0 sg13_lv_pmos ad=0.1596p pd=1.22u as=0.2856p ps=2.36u w=0.84u l=0.13u
X338 VSS.t102 DELAY_OUT_TAP19 a_18585_949# VSS.t321 sg13_lv_nmos ad=0.1665p pd=1.19u as=0.2516p ps=2.16u w=0.74u l=0.13u
X339 VSS.t246 VDD.t193 VSS.t245 VSS.t244 sg13_lv_nmos ad=0.1428p pd=1.52u as=0 ps=0 w=0.42u l=1u
X340 a_7288_949# DELAY_OUT_TAP4 VDD.t118 VDD.t0 sg13_lv_pmos ad=0.2128p pd=1.5u as=0.3808p ps=2.92u w=1.12u l=0.13u
X341 VSS.t211 VDD.t200 VSS.t210 VSS.t209 sg13_lv_nmos ad=0.1428p pd=1.52u as=0 ps=0 w=0.42u l=1u
X342 VSS.t223 VDD.t198 VSS.t221 VSS.t222 sg13_lv_nmos ad=79.8f pd=0.8u as=0 ps=0 w=0.42u l=1u
X343 VSS.t91 a_3171_952.t6 a_14964_913# VSS.t122 sg13_lv_nmos ad=0.2516p pd=2.16u as=0.2516p ps=2.16u w=0.74u l=0.13u
X344 VDD.t116 a_2019_216.t2 a_17865_424# VDD.t0 sg13_lv_pmos ad=0.3808p pd=2.92u as=0.3808p ps=2.92u w=1.12u l=0.13u
X345 VDD.t64 a_3747_952.t4 a_21911_913# VDD.t0 sg13_lv_pmos ad=0.3808p pd=2.92u as=0.3808p ps=2.92u w=1.12u l=0.13u
X346 a_11195_949# a_10985_949# VSS.t2 VSS.t139 sg13_lv_nmos ad=0.1406p pd=1.12u as=0.1665p ps=1.19u w=0.74u l=0.13u
X347 a_1721_1300# a_1256_949# VDD.t143 VDD.t0 sg13_lv_pmos ad=0.1596p pd=1.22u as=0.2856p ps=2.36u w=0.84u l=0.13u
X348 VDD.t107 a_16851_214# MUX_OUT VDD.t0 sg13_lv_pmos ad=0.7336p pd=3.55u as=0.2128p ps=1.5u w=1.12u l=0.13u
X349 VSS.t89 a_3171_216.t2 a_23945_424# VSS.t88 sg13_lv_nmos ad=0.2516p pd=2.16u as=0.2516p ps=2.16u w=0.74u l=0.13u
X350 a_22590_949# a_2595_952.t3 a_23355_949# VSS.t45 sg13_lv_nmos ad=0.2516p pd=2.16u as=0.1406p ps=1.12u w=0.74u l=0.13u
X351 VSS.t312 MUX_SEL4 a_15765_368# VSS.t311 sg13_lv_nmos ad=0.2516p pd=2.16u as=0.2516p ps=2.16u w=0.74u l=0.13u
X352 a_16510_949# a_16484_913# a_16408_949# VDD.t0 sg13_lv_pmos ad=0.3808p pd=2.92u as=0.2128p ps=1.5u w=1.12u l=0.13u
X353 VDD.t57 VSS.t248 VDD.t81 VDD.t0 sg13_lv_pmos ad=0.19p pd=1.38u as=0 ps=0 w=1u l=1u
X354 VDD.t101 DELAY_OUT_TAP9 a_10985_949# VDD.t0 sg13_lv_pmos ad=0.252p pd=1.57u as=0.3808p ps=2.92u w=1.12u l=0.13u
X355 VDD.t135 a_1544_949# a_1721_1300# VDD.t0 sg13_lv_pmos ad=0.1918p pd=1.5u as=0.1596p ps=1.22u w=0.84u l=0.13u
X356 VDD.t66 VSS.t213 VDD.t167 VDD.t0 sg13_lv_pmos ad=0.19p pd=1.38u as=0 ps=0 w=1u l=1u
X357 VDD.t2 a_2019_216.t3 a_5705_424# VDD.t0 sg13_lv_pmos ad=0.3808p pd=2.92u as=0.3808p ps=2.92u w=1.12u l=0.13u
X358 VDD.t42 VSS.t215 VDD.t41 VDD.t0 sg13_lv_pmos ad=0.34p pd=2.68u as=0 ps=0 w=1u l=1u
X359 VSS.t2 a_2019_952.t7 a_10404_913# VSS.t1 sg13_lv_nmos ad=0.2516p pd=2.16u as=0.2516p ps=2.16u w=0.74u l=0.13u
X360 VDD.t4 a_1544_194# a_2297_236# VDD.t0 sg13_lv_pmos ad=0.1918p pd=1.5u as=0.1596p ps=1.22u w=0.84u l=0.13u
X361 a_26395_949# a_26185_949# VSS.t18 VSS.t141 sg13_lv_nmos ad=0.1406p pd=1.12u as=0.1665p ps=1.19u w=0.74u l=0.13u
X362 VSS.t203 VDD.t202 VSS.t201 VSS.t202 sg13_lv_nmos ad=79.8f pd=0.8u as=0 ps=0 w=0.42u l=1u
X363 VSS.t72 a_3747_952.t3 a_24951_913# VSS.t71 sg13_lv_nmos ad=0.2516p pd=2.16u as=0.2516p ps=2.16u w=0.74u l=0.13u
X364 a_18795_949# a_18585_949# VDD.t75 VDD.t0 sg13_lv_pmos ad=0.2128p pd=1.5u as=0.252p ps=1.57u w=1.12u l=0.13u
X365 a_14235_949# a_14025_949# VDD.t77 VDD.t0 sg13_lv_pmos ad=0.2128p pd=1.5u as=0.252p ps=1.57u w=1.12u l=0.13u
X366 VDD.t99 DELAY_OUT_TAP3 a_6425_949# VDD.t0 sg13_lv_pmos ad=0.252p pd=1.57u as=0.3808p ps=2.92u w=1.12u l=0.13u
X367 a_7390_949# a_7364_913# a_7288_949# VDD.t0 sg13_lv_pmos ad=0.3808p pd=2.92u as=0.2128p ps=1.5u w=1.12u l=0.13u
X368 a_24008_949# DELAY_OUT_TAP26 VSS.t47 VSS.t309 sg13_lv_nmos ad=0.1406p pd=1.12u as=0.2516p ps=2.16u w=0.74u l=0.13u
X369 a_15964_194# MUX_SEL4 a_5731_194# VDD.t0 sg13_lv_pmos ad=0.3304p pd=1.71u as=0.3808p ps=2.92u w=1.12u l=0.13u
X370 a_1256_949# MUX_SEL0 VSS.t164 VSS.t163 sg13_lv_nmos ad=0.2516p pd=2.16u as=0.2516p ps=2.16u w=0.74u l=0.13u
X371 a_22488_949# DELAY_OUT_TAP24 VDD.t168 VDD.t0 sg13_lv_pmos ad=0.2128p pd=1.5u as=0.3808p ps=2.92u w=1.12u l=0.13u
X372 a_16510_949# a_18871_913# a_18795_949# VDD.t0 sg13_lv_pmos ad=0.3808p pd=2.92u as=0.2128p ps=1.5u w=1.12u l=0.13u
X373 a_27048_949# DELAY_OUT_TAP30 VDD.t119 VDD.t0 sg13_lv_pmos ad=0.2128p pd=1.5u as=0.3808p ps=2.92u w=1.12u l=0.13u
X374 a_13470_949# a_14311_913# a_14235_949# VDD.t0 sg13_lv_pmos ad=0.3808p pd=2.92u as=0.2128p ps=1.5u w=1.12u l=0.13u
X375 a_13470_949# a_3171_952.t6 a_14888_949# VSS.t121 sg13_lv_nmos ad=0.2516p pd=2.16u as=0.1406p ps=1.12u w=0.74u l=0.13u
X376 a_1256_194# MUX_SEL2 VSS.t297 VSS.t296 sg13_lv_nmos ad=0.2516p pd=2.16u as=0.2516p ps=2.16u w=0.74u l=0.13u
X377 a_9675_949# a_9465_949# VDD.t146 VDD.t0 sg13_lv_pmos ad=0.2128p pd=1.5u as=0.252p ps=1.57u w=1.12u l=0.13u
X378 VSS.t18 a_2019_952.t2 a_25604_913# VSS.t58 sg13_lv_nmos ad=0.2516p pd=2.16u as=0.2516p ps=2.16u w=0.74u l=0.13u
X379 a_16108_194# MUX_SEL4 a_15964_194# VSS.t310 sg13_lv_nmos ad=0.2516p pd=2.16u as=0.2183p ps=1.33u w=0.74u l=0.13u
X380 a_21835_949# a_21625_949# VSS.t39 VSS.t150 sg13_lv_nmos ad=0.1406p pd=1.12u as=0.1665p ps=1.19u w=0.74u l=0.13u
X381 VSS.t94 a_2595_952.t4 a_20391_913# VSS.t124 sg13_lv_nmos ad=0.2516p pd=2.16u as=0.2516p ps=2.16u w=0.74u l=0.13u
X382 a_2019_952.t1 a_1721_1300# VDD.t135 VDD.t0 sg13_lv_pmos ad=0.2128p pd=1.5u as=0.1918p ps=1.5u w=1.12u l=0.13u
X383 VSS.t2 DELAY_OUT_TAP9 a_10985_949# VSS.t277 sg13_lv_nmos ad=0.1665p pd=1.19u as=0.2516p ps=2.16u w=0.74u l=0.13u
X384 a_7390_949# a_9751_913# a_9675_949# VDD.t0 sg13_lv_pmos ad=0.3808p pd=2.92u as=0.2128p ps=1.5u w=1.12u l=0.13u
X385 VSS.t221 VDD.t198 VSS.t220 VSS.t219 sg13_lv_nmos ad=0.1428p pd=1.52u as=0 ps=0 w=0.42u l=1u
X386 VDD.t65 a_3171_216.t2 a_23945_424# VDD.t0 sg13_lv_pmos ad=0.3808p pd=2.92u as=0.3808p ps=2.92u w=1.12u l=0.13u
X387 VSS.t53 a_3747_952.t5 a_18871_913# VSS.t52 sg13_lv_nmos ad=0.2516p pd=2.16u as=0.2516p ps=2.16u w=0.74u l=0.13u
X388 a_12715_949# a_12505_949# VSS.t31 VSS.t152 sg13_lv_nmos ad=0.1406p pd=1.12u as=0.1665p ps=1.19u w=0.74u l=0.13u
X389 a_17928_949# DELAY_OUT_TAP18 VSS.t15 VSS.t295 sg13_lv_nmos ad=0.1406p pd=1.12u as=0.2516p ps=2.16u w=0.74u l=0.13u
X390 VDD.t173 MUX_SEL4 a_15765_368# VDD.t0 sg13_lv_pmos ad=0.3808p pd=2.92u as=0.3808p ps=2.92u w=1.12u l=0.13u
X391 a_19550_949# a_3171_952.t4 a_20968_949# VSS.t131 sg13_lv_nmos ad=0.2516p pd=2.16u as=0.1406p ps=1.12u w=0.74u l=0.13u
X392 a_7288_949# DELAY_OUT_TAP4 VSS.t120 VSS.t161 sg13_lv_nmos ad=0.1406p pd=1.12u as=0.2516p ps=2.16u w=0.74u l=0.13u
X393 a_1815_236# a_1256_194# a_1721_236# VSS.t98 sg13_lv_nmos ad=0.1216p pd=1.02u as=0.2176p ps=1.96u w=0.64u l=0.13u
X394 a_1544_194# MUX_SEL3 VSS.t301 VSS.t300 sg13_lv_nmos ad=0.2516p pd=2.16u as=0.2516p ps=2.16u w=0.74u l=0.13u
X395 a_22590_949# a_3747_952.t3 a_24875_949# VSS.t70 sg13_lv_nmos ad=0.2516p pd=2.16u as=0.1406p ps=1.12u w=0.74u l=0.13u
X396 VDD.t18 DELAY_OUT_TAP23 a_21625_949# VDD.t0 sg13_lv_pmos ad=0.252p pd=1.57u as=0.3808p ps=2.92u w=1.12u l=0.13u
X397 a_22590_949# a_22564_913# a_22488_949# VDD.t0 sg13_lv_pmos ad=0.3808p pd=2.92u as=0.2128p ps=1.5u w=1.12u l=0.13u
X398 VSS.t18 DELAY_OUT_TAP29 a_26185_949# VSS.t103 sg13_lv_nmos ad=0.1665p pd=1.19u as=0.2516p ps=2.16u w=0.74u l=0.13u
X399 VSS.t191 VDD.t204 VSS.t190 VSS.t189 sg13_lv_nmos ad=0.1428p pd=1.52u as=0 ps=0 w=0.42u l=1u
X400 VDD.t76 DELAY_OUT_TAP29 a_26185_949# VDD.t0 sg13_lv_pmos ad=0.252p pd=1.57u as=0.3808p ps=2.92u w=1.12u l=0.13u
X401 VSS.t111 DELAY_OUT_TAP1 a_4905_949# VSS.t173 sg13_lv_nmos ad=0.1665p pd=1.19u as=0.2516p ps=2.16u w=0.74u l=0.13u
X402 a_25630_949# a_27124_913# a_27048_949# VDD.t0 sg13_lv_pmos ad=0.3808p pd=2.92u as=0.2128p ps=1.5u w=1.12u l=0.13u
X403 VDD.t58 VSS.t245 VDD.t57 VDD.t0 sg13_lv_pmos ad=0.34p pd=2.68u as=0 ps=0 w=1u l=1u
X404 VDD.t54 a_2019_952.t6 a_13444_913# VDD.t0 sg13_lv_pmos ad=0.3808p pd=2.92u as=0.3808p ps=2.92u w=1.12u l=0.13u
X405 VSS.t34 a_3171_952.t8 a_8884_913# VSS.t33 sg13_lv_nmos ad=0.2516p pd=2.16u as=0.2516p ps=2.16u w=0.74u l=0.13u
X406 VDD.t67 VSS.t210 VDD.t66 VDD.t0 sg13_lv_pmos ad=0.34p pd=2.68u as=0 ps=0 w=1u l=1u
X407 VDD.t121 VSS.t223 VDD.t120 VDD.t0 sg13_lv_pmos ad=0.19p pd=1.38u as=0 ps=0 w=1u l=1u
X408 VSS.t7 a_1544_194# a_1815_236# VSS.t6 sg13_lv_nmos ad=0.1331p pd=1.12u as=0.1216p ps=1.02u w=0.64u l=0.13u
X409 VDD.t94 a_3171_952.t5 a_18004_913# VDD.t0 sg13_lv_pmos ad=0.3808p pd=2.92u as=0.3808p ps=2.92u w=1.12u l=0.13u
X410 VSS.t148 MUX_SEL1 a_3543_1300# VSS.t171 sg13_lv_nmos ad=0.1331p pd=1.12u as=0.1216p ps=1.02u w=0.64u l=0.13u
X411 a_27915_949# a_27705_949# VSS.t24 VSS.t156 sg13_lv_nmos ad=0.1406p pd=1.12u as=0.1665p ps=1.19u w=0.74u l=0.13u
X412 VSS.t260 VDD.t190 VSS.t263 VSS.t262 sg13_lv_nmos ad=79.8f pd=0.8u as=0 ps=0 w=0.42u l=1u
X413 a_24875_949# a_24665_949# VDD.t26 VDD.t0 sg13_lv_pmos ad=0.2128p pd=1.5u as=0.252p ps=1.57u w=1.12u l=0.13u
C0 a_11195_949# VDD 0.15466f
C1 a_18585_949# a_16510_949# 0.03208f
C2 a_15545_949# DELAY_OUT_TAP15 0.2079f
C3 a_15964_194# a_16851_214# 0.16757f
C4 a_15831_913# VDD 0.29168f
C5 a_13470_949# DELAY_OUT_TAP14 0.07996f
C6 a_13444_913# DELAY_OUT_TAP13 0.0501f
C7 DELAY_OUT_TAP23 DELAY_OUT_TAP24 0.0331f
C8 a_9675_949# VDD 0.15484f
C9 a_23431_913# DELAY_OUT_TAP26 0.02334f
C10 DELAY_OUT_TAP24 VDD 0.17577f
C11 a_17065_949# a_17275_949# 0.09424f
C12 a_4350_949# a_4324_913# 0.277f
C13 a_4350_949# DELAY_OUT_TAP4 0.02437f
C14 a_5768_949# VDD 0.17577f
C15 a_27124_913# DELAY_OUT_TAP31 0.02053f
C16 a_5731_194# MUX_SEL4 4.60702f
C17 a_5731_194# a_13470_949# 0.40967f
C18 a_22590_949# DELAY_OUT_TAP28 0.02437f
C19 a_27991_913# a_27705_949# 0.01885f
C20 a_25630_949# DELAY_OUT_TAP30 0.07996f
C21 a_25604_913# DELAY_OUT_TAP29 0.0501f
C22 a_19550_949# DELAY_OUT_TAP23 0.05189f
C23 a_27991_913# VDD 0.29221f
C24 a_19550_949# VDD 2.02235f
C25 VDD a_11785_424# 0.29891f
C26 a_4324_913# DELAY_OUT_TAP1 0.0501f
C27 a_15964_194# MUX_SEL4 0.5544f
C28 a_4248_949# a_4157_1218# 0.11511f
C29 DELAY_OUT_TAP10 a_10430_949# 0.07996f
C30 a_27915_949# a_27991_913# 0.01194f
C31 DELAY_OUT_TAP9 a_10404_913# 0.0501f
C32 DELAY_OUT_TAP2 DELAY_OUT_TAP3 0.03717f
C33 a_19448_949# a_19550_949# 0.37183f
C34 DELAY_OUT_TAP14 DELAY_OUT_TAP15 0.03717f
C35 a_12505_949# a_12715_949# 0.09424f
C36 a_15765_368# MUX_SEL4 0.65508f
C37 a_20391_913# DELAY_OUT_TAP22 0.02334f
C38 a_6711_913# DELAY_OUT_TAP4 0.02339f
C39 DELAY_OUT_TAP9 VDD 0.13712f
C40 a_25630_949# a_26185_949# 0.03209f
C41 DELAY_OUT_TAP16 a_16484_913# 0.02011f
C42 DELAY_OUT_TAP17 a_16510_949# 0.10838f
C43 a_25528_949# VDD 0.18232f
C44 a_18871_913# a_16510_949# 0.26208f
C45 a_20105_949# VDD 0.30466f
C46 a_14025_949# a_13470_949# 0.03209f
C47 a_20905_424# a_19550_949# 0.018f
C48 a_7288_949# a_7390_949# 0.37183f
C49 a_27124_913# a_25630_949# 0.28279f
C50 a_5731_194# a_7390_949# 0.41141f
C51 MUX_SEL2 MUX_OUT 0.08497f
C52 MUX_SEL3 MUX_SEL4 0.75489f
C53 a_17275_949# a_17351_913# 0.01194f
C54 a_16510_949# a_18004_913# 0.28279f
C55 a_5731_194# a_8745_424# 0.28635f
C56 a_18795_949# a_16510_949# 0.39036f
C57 a_10430_949# a_10985_949# 0.03209f
C58 a_22590_949# a_23355_949# 0.39037f
C59 a_1544_194# MUX_OUT 0.69943f
C60 a_3449_236# MUX_SEL2 0.10741f
C61 a_2873_236# MUX_SEL3 0.12606f
C62 a_1721_236# MUX_SEL4 0.05813f
C63 a_10430_949# a_11195_949# 0.39037f
C64 a_23431_913# a_23145_949# 0.01885f
C65 a_4350_949# MUX_SEL4 0.09136f
C66 a_17865_424# a_16510_949# 0.018f
C67 a_16108_194# a_5731_194# 0.01334f
C68 a_14311_913# VDD 0.28469f
C69 a_2873_1300# MUX_SEL1 0.13092f
C70 a_16108_194# a_22590_949# 0.43108f
C71 DELAY_OUT_TAP8 DELAY_OUT_TAP9 0.06596f
C72 a_6425_949# DELAY_OUT_TAP3 0.2079f
C73 a_10404_913# VDD 0.28964f
C74 a_1256_194# MUX_OUT 0.1134f
C75 a_15964_194# a_16108_194# 0.42202f
C76 a_15755_949# VDD 0.15466f
C77 DELAY_OUT_TAP11 a_11924_913# 0.02053f
C78 a_13470_949# DELAY_OUT_TAP13 0.10838f
C79 a_16408_949# DELAY_OUT_TAP16 0.10864f
C80 a_8884_913# VDD 0.28358f
C81 a_15765_368# a_16108_194# 0.42004f
C82 a_10430_949# a_11785_424# 0.01782f
C83 a_27705_949# VDD 0.29975f
C84 DELAY_OUT_TAP23 VDD 0.12821f
C85 a_4248_949# a_4324_913# 0.01176f
C86 a_8884_913# DELAY_OUT_TAP6 0.02312f
C87 a_4350_949# DELAY_OUT_TAP3 0.05189f
C88 a_5191_913# VDD 0.28698f
C89 DELAY_OUT_TAP6 VDD 0.13935f
C90 a_22590_949# DELAY_OUT_TAP27 0.05189f
C91 a_27915_949# a_27705_949# 0.09424f
C92 a_2297_1300# VDD 0.47641f
C93 DELAY_OUT_TAP18 VDD 0.13935f
C94 a_25604_913# DELAY_OUT_TAP28 0.02011f
C95 a_25630_949# DELAY_OUT_TAP29 0.10838f
C96 a_27915_949# VDD 0.15466f
C97 a_19550_949# DELAY_OUT_TAP22 0.07996f
C98 a_19524_913# DELAY_OUT_TAP21 0.0501f
C99 DELAY_OUT_TAP12 a_13368_949# 0.10864f
C100 a_19448_949# VDD 0.18236f
C101 DELAY_OUT_TAP27 a_24665_949# 0.2079f
C102 a_24084_913# VDD 0.28358f
C103 DELAY_OUT_TAP9 a_10430_949# 0.10838f
C104 DELAY_OUT_TAP8 a_10404_913# 0.02011f
C105 a_22488_949# DELAY_OUT_TAP24 0.10864f
C106 a_20905_424# VDD 0.30044f
C107 DELAY_OUT_TAP8 VDD 0.17577f
C108 a_24951_913# VDD 0.29225f
C109 DELAY_OUT_TAP26 DELAY_OUT_TAP27 0.03717f
C110 a_14235_949# a_14311_913# 0.01194f
C111 DELAY_OUT_TAP7 a_8884_913# 0.02053f
C112 a_18585_949# VDD 0.29779f
C113 a_2873_1300# a_1256_949# 0.28892f
C114 a_12791_913# VDD 0.29225f
C115 DELAY_OUT_TAP7 VDD 0.12821f
C116 a_27048_949# a_25630_949# 0.38994f
C117 MUX_SEL2 MUX_SEL4 0.01978f
C118 DELAY_OUT_TAP7 DELAY_OUT_TAP6 0.03717f
C119 a_16510_949# a_17928_949# 0.38994f
C120 a_22590_949# a_22564_913# 0.277f
C121 a_2873_236# MUX_SEL2 0.01422f
C122 a_1544_194# MUX_SEL4 0.47529f
C123 a_2297_236# MUX_SEL3 0.01595f
C124 a_9465_949# a_9675_949# 0.09424f
C125 a_10430_949# a_10404_913# 0.277f
C126 a_26471_913# a_25630_949# 0.28268f
C127 a_23355_949# a_23145_949# 0.09424f
C128 DELAY_OUT_TAP30 VDD 0.13935f
C129 a_16851_214# a_16510_949# 0.01245f
C130 a_15964_194# a_5731_194# 0.2778f
C131 a_14235_949# VDD 0.15466f
C132 a_2873_1300# MUX_SEL0 0.01504f
C133 a_21911_913# a_21625_949# 0.01885f
C134 a_5705_424# VDD 0.30089f
C135 a_22590_949# a_24665_949# 0.03208f
C136 a_15765_368# a_5731_194# 0.23301f
C137 a_10430_949# VDD 2.01462f
C138 a_1256_194# MUX_SEL4 0.65005f
C139 a_2873_236# a_1256_194# 0.27926f
C140 a_14964_913# VDD 0.28358f
C141 MUX_SEL4 a_14825_424# 0.03307f
C142 DELAY_OUT_TAP0 DELAY_OUT_TAP1 0.04194f
C143 a_13470_949# a_14825_424# 0.01782f
C144 DELAY_OUT_TAP7 DELAY_OUT_TAP8 0.0331f
C145 DELAY_OUT_TAP10 a_11924_913# 0.02312f
C146 a_8808_949# a_8884_913# 0.01176f
C147 DELAY_OUT_TAP22 DELAY_OUT_TAP23 0.03717f
C148 a_15831_913# DELAY_OUT_TAP16 0.02339f
C149 a_8808_949# VDD 0.17577f
C150 a_15765_368# a_15964_194# 0.061f
C151 a_26185_949# VDD 0.30466f
C152 DELAY_OUT_TAP22 VDD 0.13935f
C153 a_16108_194# a_26985_424# 0.27952f
C154 a_17065_949# a_16510_949# 0.03209f
C155 a_8808_949# DELAY_OUT_TAP6 0.10863f
C156 a_4350_949# DELAY_OUT_TAP2 0.07996f
C157 a_5115_949# VDD 0.15466f
C158 DELAY_OUT_TAP5 VDD 0.13712f
C159 a_22590_949# DELAY_OUT_TAP26 0.07996f
C160 a_5115_949# a_5191_913# 0.01194f
C161 a_5844_913# DELAY_OUT_TAP3 0.02053f
C162 DELAY_OUT_TAP17 VDD 0.13881f
C163 DELAY_OUT_TAP5 DELAY_OUT_TAP6 0.02068f
C164 a_19550_949# DELAY_OUT_TAP21 0.10838f
C165 a_19524_913# DELAY_OUT_TAP20 0.02011f
C166 a_27124_913# VDD 0.28358f
C167 a_18871_913# VDD 0.29229f
C168 DELAY_OUT_TAP17 DELAY_OUT_TAP18 0.02068f
C169 a_1721_1300# VDD 0.46923f
C170 a_24008_949# VDD 0.17577f
C171 a_5731_194# a_4350_949# 0.40909f
C172 DELAY_OUT_TAP1 DELAY_OUT_TAP2 0.02068f
C173 VDD a_18004_913# 0.28358f
C174 a_4157_1218# VDD 0.57183f
C175 a_21911_913# DELAY_OUT_TAP24 0.02339f
C176 a_18795_949# VDD 0.15484f
C177 DELAY_OUT_TAP13 DELAY_OUT_TAP14 0.02068f
C178 a_22488_949# VDD 0.18236f
C179 DELAY_OUT_TAP18 a_18004_913# 0.02312f
C180 DELAY_OUT_TAP20 a_16510_949# 0.02437f
C181 a_10430_949# a_12791_913# 0.26208f
C182 a_24008_949# a_24084_913# 0.01176f
C183 a_17865_424# VDD 0.30196f
C184 a_21911_913# a_19550_949# 0.26208f
C185 DELAY_OUT_TAP19 a_16510_949# 0.05189f
C186 a_24875_949# VDD 0.15484f
C187 DELAY_OUT_TAP21 a_20105_949# 0.19203f
C188 DELAY_OUT_TAP12 DELAY_OUT_TAP13 0.06596f
C189 a_12715_949# VDD 0.15484f
C190 a_16510_949# a_17351_913# 0.28268f
C191 a_2297_236# MUX_SEL2 0.10655f
C192 a_15831_913# a_13470_949# 0.26208f
C193 a_18871_913# a_18585_949# 0.01885f
C194 a_4350_949# a_6425_949# 0.03208f
C195 a_10328_949# a_10404_913# 0.01176f
C196 a_1544_194# a_2297_236# 0.27303f
C197 a_9465_949# VDD 0.29779f
C198 a_20968_949# a_21044_913# 0.01176f
C199 DELAY_OUT_TAP29 VDD 0.13712f
C200 DELAY_OUT_TAP11 DELAY_OUT_TAP12 0.0331f
C201 a_16108_194# a_16510_949# 0.43331f
C202 MUX_OUT VDD 1.15067f
C203 a_18795_949# a_18585_949# 0.09424f
C204 a_13444_913# VDD 0.28964f
C205 a_21835_949# a_21625_949# 0.09424f
C206 a_27124_913# DELAY_OUT_TAP30 0.02312f
C207 a_3449_236# VDD 0.47436f
C208 a_9751_913# a_9675_949# 0.01194f
C209 a_22590_949# a_23145_949# 0.03209f
C210 a_16108_194# a_25630_949# 0.43108f
C211 a_10328_949# VDD 0.18236f
C212 a_14025_949# DELAY_OUT_TAP13 0.19203f
C213 a_24875_949# a_24951_913# 0.01194f
C214 a_2297_236# a_1256_194# 0.04261f
C215 MUX_SEL4 a_11785_424# 0.03255f
C216 a_14888_949# VDD 0.17577f
C217 DELAY_OUT_TAP10 a_11848_949# 0.10863f
C218 a_8231_913# VDD 0.28469f
C219 a_22564_913# DELAY_OUT_TAP25 0.0501f
C220 a_6425_949# a_6711_913# 0.01885f
C221 DELAY_OUT_TAP21 VDD 0.13712f
C222 a_16108_194# a_23945_424# 0.2906f
C223 a_8231_913# DELAY_OUT_TAP6 0.02334f
C224 a_12715_949# a_12791_913# 0.01194f
C225 a_4350_949# DELAY_OUT_TAP1 0.10838f
C226 a_4324_913# VDD 0.28929f
C227 DELAY_OUT_TAP4 VDD 0.17577f
C228 a_22590_949# DELAY_OUT_TAP25 0.10838f
C229 DELAY_OUT_TAP16 VDD 0.16873f
C230 a_5844_913# DELAY_OUT_TAP2 0.02312f
C231 a_25528_949# DELAY_OUT_TAP28 0.10864f
C232 a_27048_949# VDD 0.17577f
C233 DELAY_OUT_TAP7 a_9465_949# 0.2079f
C234 a_7390_949# a_9675_949# 0.39036f
C235 a_1544_949# VDD 0.56437f
C236 a_4350_949# a_6711_913# 0.26208f
C237 a_23431_913# VDD 0.28469f
C238 a_7364_913# VDD 0.28964f
C239 DELAY_OUT_TAP8 a_10328_949# 0.10864f
C240 a_26471_913# VDD 0.28469f
C241 VDD a_17928_949# 0.17577f
C242 a_2297_1300# a_1544_949# 0.28651f
C243 a_3449_1300# VDD 0.48157f
C244 a_21911_913# VDD 0.29229f
C245 DELAY_OUT_TAP18 a_17928_949# 0.10863f
C246 DELAY_OUT_TAP29 DELAY_OUT_TAP30 0.02068f
C247 a_10430_949# a_12715_949# 0.39036f
C248 a_16851_214# VDD 0.53195f
C249 a_5731_194# a_14825_424# 0.28056f
C250 a_18795_949# a_18871_913# 0.01194f
C251 VDD MUX_SEL1 0.67604f
C252 a_21835_949# a_19550_949# 0.39036f
C253 DELAY_OUT_TAP25 DELAY_OUT_TAP26 0.02068f
C254 a_13470_949# a_14311_913# 0.28268f
C255 a_2297_1300# MUX_SEL1 0.01995f
C256 a_16108_194# a_19550_949# 0.43108f
C257 a_11924_913# VDD 0.28358f
C258 a_15545_949# a_15831_913# 0.01885f
C259 MUX_SEL2 MUX_SEL3 3.21891f
C260 a_16510_949# a_17275_949# 0.39037f
C261 a_1721_236# MUX_SEL2 0.01315f
C262 a_1544_194# MUX_SEL3 0.15976f
C263 a_15755_949# a_13470_949# 0.39036f
C264 a_4350_949# a_4905_949# 0.03209f
C265 DELAY_OUT_TAP29 a_26185_949# 0.19203f
C266 a_1544_194# a_1721_236# 0.36963f
C267 a_10328_949# a_10430_949# 0.37183f
C268 a_7945_949# VDD 0.30466f
C269 a_17065_949# VDD 0.30275f
C270 DELAY_OUT_TAP28 VDD 0.17575f
C271 MUX_SEL4 VDD 4.25382f
C272 a_13470_949# VDD 2.0134f
C273 a_14888_949# a_14964_913# 0.01176f
C274 a_25630_949# a_26395_949# 0.39037f
C275 a_2873_236# VDD 0.47413f
C276 a_27048_949# DELAY_OUT_TAP30 0.10863f
C277 a_4905_949# DELAY_OUT_TAP1 0.19203f
C278 a_4248_949# a_4350_949# 0.37183f
C279 a_9751_913# VDD 0.29229f
C280 a_1256_194# MUX_SEL3 1.41161f
C281 a_1721_236# a_1256_194# 0.13421f
C282 a_4350_949# a_5844_913# 0.28279f
C283 a_26471_913# DELAY_OUT_TAP30 0.02334f
C284 DELAY_OUT_TAP10 a_11271_913# 0.02334f
C285 a_22590_949# a_23945_424# 0.018f
C286 DELAY_OUT_TAP21 DELAY_OUT_TAP22 0.02068f
C287 a_6425_949# a_6635_949# 0.09424f
C288 a_8155_949# VDD 0.15466f
C289 DELAY_OUT_TAP20 VDD 0.17577f
C290 DELAY_OUT_TAP3 VDD 0.12821f
C291 DELAY_OUT_TAP11 a_12505_949# 0.2079f
C292 a_5768_949# DELAY_OUT_TAP2 0.10863f
C293 DELAY_OUT_TAP15 VDD 0.12935f
C294 DELAY_OUT_TAP19 VDD 0.12821f
C295 a_16408_949# a_16484_913# 0.01176f
C296 DELAY_OUT_TAP4 DELAY_OUT_TAP5 0.06596f
C297 a_24951_913# DELAY_OUT_TAP28 0.02339f
C298 a_19448_949# DELAY_OUT_TAP20 0.10864f
C299 DELAY_OUT_TAP25 a_23145_949# 0.19203f
C300 a_22564_913# DELAY_OUT_TAP24 0.02011f
C301 DELAY_OUT_TAP16 DELAY_OUT_TAP17 0.06596f
C302 a_1256_949# VDD 0.57486f
C303 a_7390_949# a_8884_913# 0.28279f
C304 DELAY_OUT_TAP19 DELAY_OUT_TAP18 0.03717f
C305 a_4350_949# a_6635_949# 0.39036f
C306 a_23355_949# VDD 0.15466f
C307 a_26471_913# a_26185_949# 0.01885f
C308 a_7390_949# VDD 2.01762f
C309 a_27048_949# a_27124_913# 0.01176f
C310 DELAY_OUT_TAP8 a_9751_913# 0.02339f
C311 VDD a_17351_913# 0.28698f
C312 a_2297_1300# a_1256_949# 0.04619f
C313 a_8745_424# VDD 0.29602f
C314 a_7390_949# DELAY_OUT_TAP6 0.07996f
C315 a_7364_913# DELAY_OUT_TAP5 0.0501f
C316 a_4324_913# a_4157_1218# 0.02463f
C317 a_10985_949# a_11271_913# 0.01885f
C318 a_21835_949# VDD 0.15484f
C319 DELAY_OUT_TAP18 a_17351_913# 0.02334f
C320 a_1544_949# a_1721_1300# 0.38063f
C321 a_10430_949# a_11924_913# 0.28279f
C322 a_11195_949# a_11271_913# 0.01194f
C323 a_16108_194# VDD 1.94809f
C324 a_5731_194# a_11785_424# 0.28056f
C325 VDD MUX_SEL0 0.50845f
C326 a_20391_913# a_20315_949# 0.01194f
C327 a_21044_913# a_19550_949# 0.28279f
C328 a_17928_949# a_18004_913# 0.01176f
C329 a_13470_949# a_14235_949# 0.39037f
C330 a_2297_1300# MUX_SEL0 0.10655f
C331 a_5705_424# MUX_SEL4 0.03556f
C332 a_11848_949# VDD 0.17577f
C333 a_6635_949# a_6711_913# 0.01194f
C334 a_15545_949# a_15755_949# 0.09424f
C335 a_10430_949# MUX_SEL4 0.05749f
C336 a_16510_949# a_16484_913# 0.277f
C337 DELAY_OUT_TAP19 a_18585_949# 0.2079f
C338 a_1544_194# MUX_SEL2 0.07405f
C339 DELAY_OUT_TAP8 a_7390_949# 0.02437f
C340 a_14964_913# a_13470_949# 0.28279f
C341 a_15545_949# VDD 0.29975f
C342 DELAY_OUT_TAP27 VDD 0.12821f
C343 DELAY_OUT_TAP10 DELAY_OUT_TAP11 0.03717f
C344 a_7945_949# DELAY_OUT_TAP5 0.19203f
C345 DELAY_OUT_TAP7 a_7390_949# 0.05189f
C346 DELAY_OUT_TAP0 VDD 0.58017f
C347 a_17065_949# DELAY_OUT_TAP17 0.19203f
C348 a_13368_949# VDD 0.18232f
C349 a_16108_194# a_20905_424# 0.2906f
C350 a_25630_949# a_25604_913# 0.277f
C351 a_2297_236# VDD 0.47301f
C352 a_14311_913# DELAY_OUT_TAP14 0.02334f
C353 a_1256_194# MUX_SEL2 0.33134f
C354 a_24084_913# DELAY_OUT_TAP27 0.02053f
C355 a_1544_194# a_1256_194# 1.25711f
C356 a_4350_949# a_5768_949# 0.38994f
C357 a_25630_949# a_26985_424# 0.018f
C358 a_14964_913# DELAY_OUT_TAP15 0.02053f
C359 a_4157_1218# MUX_SEL4 0.08229f
C360 DELAY_OUT_TAP2 VDD 0.13935f
C361 DELAY_OUT_TAP14 VDD 0.13935f
C362 a_16851_214# MUX_OUT 0.45865f
C363 a_5191_913# DELAY_OUT_TAP2 0.02334f
C364 a_16408_949# a_16510_949# 0.37183f
C365 a_18871_913# DELAY_OUT_TAP20 0.02339f
C366 a_19550_949# a_20315_949# 0.39037f
C367 a_7390_949# a_8808_949# 0.38994f
C368 a_22564_913# VDD 0.28964f
C369 a_7288_949# VDD 0.18236f
C370 VDD a_17275_949# 0.15466f
C371 a_5731_194# VDD 0.63828f
C372 a_21044_913# DELAY_OUT_TAP23 0.02053f
C373 a_7364_913# DELAY_OUT_TAP4 0.02011f
C374 a_7390_949# DELAY_OUT_TAP5 0.10838f
C375 a_25630_949# DELAY_OUT_TAP31 0.05211f
C376 a_21044_913# VDD 0.28358f
C377 DELAY_OUT_TAP12 VDD 0.17575f
C378 a_22590_949# VDD 2.01498f
C379 DELAY_OUT_TAP19 a_18004_913# 0.02053f
C380 a_1256_949# a_1721_1300# 0.13421f
C381 DELAY_OUT_TAP28 DELAY_OUT_TAP29 0.06596f
C382 a_10430_949# a_11848_949# 0.38994f
C383 a_26395_949# VDD 0.15466f
C384 a_15964_194# VDD 0.48723f
C385 a_24665_949# VDD 0.29779f
C386 a_14025_949# a_14311_913# 0.01885f
C387 a_20968_949# a_19550_949# 0.38994f
C388 MUX_SEL4 MUX_OUT 0.91933f
C389 a_13470_949# a_13444_913# 0.277f
C390 a_9751_913# a_9465_949# 0.01885f
C391 a_22590_949# a_24084_913# 0.28279f
C392 a_3449_236# MUX_SEL4 0.05166f
C393 a_15765_368# VDD 0.35641f
C394 a_20315_949# a_20105_949# 0.09424f
C395 a_11271_913# VDD 0.28469f
C396 a_1544_949# MUX_SEL1 0.1672f
C397 a_1721_1300# MUX_SEL0 0.01315f
C398 a_14888_949# a_13470_949# 0.38994f
C399 a_7945_949# a_8231_913# 0.01885f
C400 a_3449_1300# MUX_SEL1 0.29404f
C401 DELAY_OUT_TAP25 DELAY_OUT_TAP24 0.06596f
C402 a_6425_949# VDD 0.29779f
C403 DELAY_OUT_TAP26 VDD 0.13935f
C404 a_14025_949# VDD 0.30466f
C405 MUX_SEL3 VDD 0.40997f
C406 a_24951_913# a_22590_949# 0.26208f
C407 a_16108_194# a_17865_424# 0.29564f
C408 a_25528_949# a_25604_913# 0.01176f
C409 a_1721_236# VDD 0.45834f
C410 DELAY_OUT_TAP12 a_12791_913# 0.02339f
C411 a_24951_913# a_24665_949# 0.01885f
C412 a_13470_949# DELAY_OUT_TAP16 0.02437f
C413 a_24084_913# DELAY_OUT_TAP26 0.02312f
C414 a_9465_949# a_7390_949# 0.03208f
C415 a_4350_949# VDD 2.01728f
C416 a_4350_949# a_5191_913# 0.28268f
C417 a_8155_949# a_8231_913# 0.01194f
C418 DELAY_OUT_TAP20 DELAY_OUT_TAP21 0.06596f
C419 a_14964_913# DELAY_OUT_TAP14 0.02312f
C420 a_4157_1218# DELAY_OUT_TAP0 0.45374f
C421 a_5768_949# a_5844_913# 0.01176f
C422 a_5705_424# a_5731_194# 0.28954f
C423 a_20315_949# VDD 0.15466f
C424 a_5731_194# a_10430_949# 0.40957f
C425 DELAY_OUT_TAP1 VDD 0.14002f
C426 DELAY_OUT_TAP13 VDD 0.13712f
C427 a_16108_194# MUX_OUT 0.24265f
C428 DELAY_OUT_TAP12 a_10430_949# 0.02437f
C429 DELAY_OUT_TAP3 DELAY_OUT_TAP4 0.0331f
C430 DELAY_OUT_TAP15 DELAY_OUT_TAP16 0.0331f
C431 a_19550_949# a_19524_913# 0.277f
C432 a_7390_949# a_8231_913# 0.28268f
C433 a_6711_913# VDD 0.29229f
C434 VDD a_16484_913# 0.28929f
C435 a_2873_1300# VDD 0.47934f
C436 a_21044_913# DELAY_OUT_TAP22 0.02312f
C437 a_20968_949# VDD 0.17577f
C438 a_26395_949# a_26185_949# 0.09424f
C439 DELAY_OUT_TAP11 VDD 0.12821f
C440 a_1256_949# a_1544_949# 1.26509f
C441 a_25604_913# VDD 0.28964f
C442 a_10430_949# a_11271_913# 0.28268f
C443 a_23355_949# a_23431_913# 0.01194f
C444 a_23145_949# VDD 0.30466f
C445 a_14025_949# a_14235_949# 0.09424f
C446 a_20391_913# a_19550_949# 0.28268f
C447 a_7390_949# a_7364_913# 0.277f
C448 a_27991_913# a_25630_949# 0.26208f
C449 a_13470_949# MUX_SEL4 0.05779f
C450 a_22488_949# a_22564_913# 0.01176f
C451 a_13368_949# a_13444_913# 0.01176f
C452 a_11195_949# a_10985_949# 0.09424f
C453 a_22590_949# a_24008_949# 0.38994f
C454 a_3449_236# DELAY_OUT_TAP0 0.01018f
C455 a_2297_236# MUX_OUT 0.01179f
C456 a_2873_236# MUX_SEL4 0.04916f
C457 a_19550_949# a_21625_949# 0.03208f
C458 a_26985_424# VDD 0.30089f
C459 a_1544_949# MUX_SEL0 0.07603f
C460 a_1256_949# MUX_SEL1 1.44243f
C461 a_21835_949# a_21911_913# 0.01194f
C462 a_22488_949# a_22590_949# 0.37183f
C463 a_7945_949# a_8155_949# 0.09424f
C464 a_5705_424# a_4350_949# 0.01764f
C465 a_3449_1300# MUX_SEL0 0.10753f
C466 a_4905_949# VDD 0.30183f
C467 DELAY_OUT_TAP25 VDD 0.13712f
C468 a_12505_949# VDD 0.29779f
C469 DELAY_OUT_TAP9 DELAY_OUT_TAP10 0.02068f
C470 a_4905_949# a_5191_913# 0.01885f
C471 a_24875_949# a_22590_949# 0.39036f
C472 MUX_SEL2 VDD 0.49863f
C473 a_16108_194# a_16851_214# 0.06181f
C474 a_25528_949# a_25630_949# 0.37183f
C475 a_20391_913# a_20105_949# 0.01885f
C476 a_16408_949# VDD 0.18093f
C477 a_1544_194# VDD 0.39668f
C478 MUX_SEL0 MUX_SEL1 3.14917f
C479 a_27705_949# DELAY_OUT_TAP31 0.2079f
C480 a_24875_949# a_24665_949# 0.09424f
C481 a_13470_949# DELAY_OUT_TAP15 0.05189f
C482 DELAY_OUT_TAP31 VDD 0.12941f
C483 a_24008_949# DELAY_OUT_TAP26 0.10863f
C484 a_7945_949# a_7390_949# 0.03209f
C485 a_4248_949# VDD 0.18405f
C486 a_17065_949# a_17351_913# 0.01885f
C487 a_4350_949# a_5115_949# 0.39037f
C488 a_7390_949# MUX_SEL4 0.11061f
C489 a_5844_913# VDD 0.28358f
C490 a_8745_424# MUX_SEL4 0.04472f
C491 a_5731_194# MUX_OUT 1.04829f
C492 a_14888_949# DELAY_OUT_TAP14 0.10863f
C493 a_3449_1300# DELAY_OUT_TAP0 0.01067f
C494 a_19550_949# DELAY_OUT_TAP24 0.02437f
C495 a_1256_194# VDD 0.41094f
C496 DELAY_OUT_TAP12 a_13444_913# 0.02011f
C497 a_11848_949# a_11924_913# 0.01176f
C498 a_19524_913# VDD 0.28964f
C499 a_9751_913# a_7390_949# 0.26208f
C500 VDD a_14825_424# 0.29891f
C501 DELAY_OUT_TAP19 DELAY_OUT_TAP20 0.0331f
C502 DELAY_OUT_TAP9 a_10985_949# 0.19203f
C503 a_4350_949# a_4157_1218# 0.04456f
C504 a_15964_194# MUX_OUT 0.01307f
C505 a_16108_194# MUX_SEL4 0.1283f
C506 DELAY_OUT_TAP11 a_10430_949# 0.05189f
C507 DELAY_OUT_TAP0 MUX_SEL1 0.01815f
C508 a_7390_949# a_8155_949# 0.39037f
C509 a_19448_949# a_19524_913# 0.01176f
C510 a_12505_949# a_12791_913# 0.01885f
C511 a_6635_949# VDD 0.15484f
C512 VDD a_16510_949# 2.0153f
C513 a_20968_949# DELAY_OUT_TAP22 0.10863f
C514 a_7288_949# DELAY_OUT_TAP4 0.10864f
C515 a_20391_913# VDD 0.28469f
C516 a_4157_1218# DELAY_OUT_TAP1 0.01771f
C517 DELAY_OUT_TAP10 VDD 0.13935f
C518 a_25630_949# a_27705_949# 0.03208f
C519 DELAY_OUT_TAP17 a_16484_913# 0.0501f
C520 DELAY_OUT_TAP18 a_16510_949# 0.07996f
C521 a_25630_949# VDD 2.01433f
C522 DELAY_OUT_TAP27 DELAY_OUT_TAP28 0.0331f
C523 DELAY_OUT_TAP23 a_21625_949# 0.2079f
C524 a_21625_949# VDD 0.29779f
C525 a_15545_949# a_13470_949# 0.03208f
C526 a_7288_949# a_7364_913# 0.01176f
C527 a_27915_949# a_25630_949# 0.39036f
C528 a_8745_424# a_7390_949# 0.01627f
C529 MUX_SEL3 MUX_OUT 0.79533f
C530 DELAY_OUT_TAP0 MUX_SEL4 0.06224f
C531 a_13368_949# a_13470_949# 0.37183f
C532 a_22590_949# a_23431_913# 0.28268f
C533 a_10430_949# a_12505_949# 0.03208f
C534 a_3449_236# MUX_SEL3 0.28429f
C535 a_2297_236# MUX_SEL4 0.04338f
C536 DELAY_OUT_TAP30 DELAY_OUT_TAP31 0.03717f
C537 a_19550_949# a_20105_949# 0.03209f
C538 a_23945_424# VDD 0.30044f
C539 a_1256_949# MUX_SEL0 0.3314f
C540 a_26471_913# a_26395_949# 0.01194f
C541 a_15755_949# a_15831_913# 0.01194f
C542 a_10985_949# VDD 0.30466f
C543 a_4905_949# a_5115_949# 0.09424f
R0 VDD.n3 VDD.t106 17.2438
R1 VDD.n394 VDD.n393 9.0005
R2 VDD.n395 VDD.n104 9.0005
R3 VDD.n396 VDD 9.0005
R4 VDD VDD.n8 9.0005
R5 VDD.n223 VDD.n222 9.0005
R6 VDD.n225 VDD.n224 9.0005
R7 VDD.n226 VDD.n221 9.0005
R8 VDD.n228 VDD.n227 9.0005
R9 VDD.n229 VDD.n220 9.0005
R10 VDD.n231 VDD.n230 9.0005
R11 VDD.n232 VDD.n219 9.0005
R12 VDD.n234 VDD.n233 9.0005
R13 VDD.n235 VDD.n218 9.0005
R14 VDD.n237 VDD.n236 9.0005
R15 VDD.n238 VDD.n217 9.0005
R16 VDD.n240 VDD.n239 9.0005
R17 VDD.n241 VDD.n216 9.0005
R18 VDD.n243 VDD.n242 9.0005
R19 VDD.n244 VDD.n215 9.0005
R20 VDD.n246 VDD.n245 9.0005
R21 VDD.n248 VDD.n214 9.0005
R22 VDD.n250 VDD.n249 9.0005
R23 VDD.n251 VDD.n213 9.0005
R24 VDD.n253 VDD.n252 9.0005
R25 VDD.n254 VDD.n212 9.0005
R26 VDD.n256 VDD.n255 9.0005
R27 VDD.n257 VDD.n211 9.0005
R28 VDD.n258 VDD.n38 9.11485
R29 VDD.n259 VDD.n210 9.0005
R30 VDD.n261 VDD.n260 9.0005
R31 VDD.n262 VDD.n209 9.0005
R32 VDD.n264 VDD.n263 9.0005
R33 VDD.n265 VDD.n208 9.0005
R34 VDD.n267 VDD.n266 9.0005
R35 VDD.n268 VDD.n207 9.0005
R36 VDD.n269 VDD.n206 9.0005
R37 VDD.n271 VDD.n270 9.0005
R38 VDD.n272 VDD.n95 9.0005
R39 VDD.n274 VDD.n273 9.0005
R40 VDD.n275 VDD.n205 9.0005
R41 VDD.n277 VDD.n276 9.0005
R42 VDD.n278 VDD.n81 9.0005
R43 VDD.n280 VDD.n279 9.0005
R44 VDD.n281 VDD.n204 9.0005
R45 VDD.n283 VDD.n282 9.0005
R46 VDD.n284 VDD.n74 9.0005
R47 VDD.n286 VDD.n285 9.0005
R48 VDD.n203 VDD.n197 9.0005
R49 VDD.n202 VDD.n196 9.0005
R50 VDD.n201 VDD.n195 9.0005
R51 VDD.n200 VDD.n194 9.0005
R52 VDD.n199 VDD.n193 9.0005
R53 VDD.n198 VDD.n83 9.0005
R54 VDD.n287 VDD.n192 9.0005
R55 VDD.n288 VDD.n191 9.0005
R56 VDD.n290 VDD.n289 9.0005
R57 VDD.n291 VDD.n94 9.0005
R58 VDD.n293 VDD.n292 9.0005
R59 VDD.n294 VDD.n190 9.0005
R60 VDD.n296 VDD.n295 9.0005
R61 VDD.n297 VDD.n80 9.0005
R62 VDD.n299 VDD.n298 9.0005
R63 VDD.n300 VDD.n189 9.0005
R64 VDD.n302 VDD.n301 9.0005
R65 VDD.n303 VDD.n75 9.0005
R66 VDD.n305 VDD.n304 9.0005
R67 VDD.n188 VDD.n182 9.0005
R68 VDD.n187 VDD.n181 9.0005
R69 VDD.n186 VDD.n180 9.0005
R70 VDD.n185 VDD.n179 9.0005
R71 VDD.n184 VDD.n178 9.0005
R72 VDD.n183 VDD.n85 9.0005
R73 VDD.n306 VDD.n177 9.0005
R74 VDD.n307 VDD.n176 9.0005
R75 VDD.n309 VDD.n308 9.0005
R76 VDD.n310 VDD.n93 9.0005
R77 VDD.n312 VDD.n311 9.0005
R78 VDD.n313 VDD.n175 9.0005
R79 VDD.n315 VDD.n314 9.0005
R80 VDD.n316 VDD.n79 9.0005
R81 VDD.n318 VDD.n317 9.0005
R82 VDD.n319 VDD.n174 9.0005
R83 VDD.n321 VDD.n320 9.0005
R84 VDD.n322 VDD.n76 9.0005
R85 VDD.n324 VDD.n323 9.0005
R86 VDD.n173 VDD.n149 9.0005
R87 VDD.n172 VDD.n148 9.0005
R88 VDD.n171 VDD.n147 9.0005
R89 VDD.n170 VDD.n146 9.0005
R90 VDD.n169 VDD.n145 9.0005
R91 VDD.n168 VDD.n144 9.0005
R92 VDD.n167 VDD.n143 9.0005
R93 VDD.n166 VDD.n142 9.0005
R94 VDD.n165 VDD.n30 9.11485
R95 VDD.n164 VDD.n141 9.0005
R96 VDD.n163 VDD.n140 9.0005
R97 VDD.n162 VDD.n139 9.0005
R98 VDD.n161 VDD.n138 9.0005
R99 VDD.n160 VDD.n137 9.0005
R100 VDD.n159 VDD.n136 9.0005
R101 VDD.n158 VDD.n135 9.0005
R102 VDD.n157 VDD.n134 9.0005
R103 VDD.n156 VDD.n31 9.11485
R104 VDD.n155 VDD.n133 9.0005
R105 VDD.n154 VDD.n132 9.0005
R106 VDD.n153 VDD.n131 9.0005
R107 VDD.n152 VDD.n130 9.0005
R108 VDD.n151 VDD.n129 9.0005
R109 VDD.n150 VDD.n87 9.0005
R110 VDD.n325 VDD.n128 9.0005
R111 VDD.n326 VDD.n127 9.0005
R112 VDD.n328 VDD.n327 9.0005
R113 VDD.n329 VDD.n92 9.0005
R114 VDD.n331 VDD.n330 9.0005
R115 VDD.n332 VDD.n126 9.0005
R116 VDD.n334 VDD.n333 9.0005
R117 VDD.n335 VDD.n78 9.0005
R118 VDD.n337 VDD.n336 9.0005
R119 VDD.n338 VDD.n125 9.0005
R120 VDD.n340 VDD.n339 9.0005
R121 VDD.n341 VDD.n77 9.0005
R122 VDD.n343 VDD.n342 9.0005
R123 VDD.n123 VDD.n119 9.0005
R124 VDD.n122 VDD.n118 9.0005
R125 VDD.n121 VDD.n117 9.0005
R126 VDD.n120 VDD.n116 9.0005
R127 VDD.n89 VDD.n115 9.0005
R128 VDD.n345 VDD.n344 9.0005
R129 VDD.n346 VDD.n62 9.0005
R130 VDD.n348 VDD.n347 9.0005
R131 VDD.n349 VDD.n114 9.0005
R132 VDD.n351 VDD.n350 9.0005
R133 VDD.n352 VDD.n98 9.0005
R134 VDD.n354 VDD.n353 9.0005
R135 VDD.n355 VDD.n113 9.0005
R136 VDD.n357 VDD.n356 9.0005
R137 VDD.n358 VDD.n112 9.0005
R138 VDD.n360 VDD.n359 9.0005
R139 VDD.n361 VDD.n111 9.0005
R140 VDD.n363 VDD.n362 9.0005
R141 VDD.n365 VDD.n364 9.0005
R142 VDD.n366 VDD.n110 9.0005
R143 VDD.n368 VDD.n367 9.0005
R144 VDD.n369 VDD.n70 9.0005
R145 VDD.n371 VDD.n370 9.0005
R146 VDD.n372 VDD.n109 9.0005
R147 VDD.n374 VDD.n373 9.0005
R148 VDD.n375 VDD.n69 9.0005
R149 VDD.n377 VDD.n376 9.0005
R150 VDD.n378 VDD.n108 9.0005
R151 VDD.n380 VDD.n379 9.0005
R152 VDD.n381 VDD.n96 9.0005
R153 VDD.n383 VDD.n382 9.0005
R154 VDD.n384 VDD.n107 9.0005
R155 VDD.n386 VDD.n385 9.0005
R156 VDD.n387 VDD.n106 9.0005
R157 VDD.n389 VDD.n388 9.0005
R158 VDD.n390 VDD.n105 9.0005
R159 VDD.n392 VDD.n391 9.0005
R160 VDD.n365 VDD.t0 9.0005
R161 VDD.n366 VDD.n48 0.116823
R162 VDD.n48 VDD.t0 4.44309
R163 VDD.n55 VDD.n70 0.116823
R164 VDD.n55 VDD.t0 4.44309
R165 VDD.n91 VDD.t0 4.44309
R166 VDD.n373 VDD.n91 0.116823
R167 VDD.n68 VDD.n69 0.116823
R168 VDD.n68 VDD.t0 4.44309
R169 VDD.n378 VDD.t0 9.0005
R170 VDD.n379 VDD.n97 0.116823
R171 VDD.t0 VDD.n97 4.44309
R172 VDD.n13 VDD.t0 4.44309
R173 VDD.n384 VDD.n13 0.116823
R174 VDD.n73 VDD.t0 4.44309
R175 VDD.n106 VDD.n73 0.116823
R176 VDD.n389 VDD.n61 0.116823
R177 VDD.n61 VDD.t0 4.44309
R178 VDD.n391 VDD.t0 9.0005
R179 VDD.n393 VDD.t0 9.0005
R180 VDD.n104 VDD.n0 0.114852
R181 VDD.n0 VDD.t0 4.44407
R182 VDD.n10 VDD.n9 1.39172
R183 VDD.n9 VDD.n72 4.44407
R184 VDD.n222 VDD.n72 0.114852
R185 VDD.n14 VDD.n5 4.44407
R186 VDD.n226 VDD.n14 0.114852
R187 VDD.n33 VDD.n5 4.44407
R188 VDD.n220 VDD.n33 0.114852
R189 VDD.n32 VDD.n5 4.44407
R190 VDD.n232 VDD.n32 0.114852
R191 VDD.n71 VDD.n5 4.44407
R192 VDD.n218 VDD.n71 0.114852
R193 VDD.n237 VDD.n5 9.0005
R194 VDD.n12 VDD.n5 4.44407
R195 VDD.n239 VDD.n12 0.114852
R196 VDD.n216 VDD.n5 9.0005
R197 VDD.n37 VDD.n5 4.44407
R198 VDD.n244 VDD.n37 0.114852
R199 VDD.n245 VDD.n5 9.0005
R200 VDD.n16 VDD.t0 4.44407
R201 VDD.n214 VDD.n16 0.114852
R202 VDD.n35 VDD.t0 4.44407
R203 VDD.n251 VDD.n35 0.114852
R204 VDD.n252 VDD.t0 9.0005
R205 VDD.n36 VDD.t0 4.44407
R206 VDD.n256 VDD.n36 0.114852
R207 VDD.n38 VDD.t0 4.44407
R208 VDD.n210 VDD.t0 9.0005
R209 VDD.n39 VDD.t0 4.44407
R210 VDD.n262 VDD.n39 0.114852
R211 VDD.n45 VDD.n11 4.44407
R212 VDD.n208 VDD.n45 0.114852
R213 VDD.n82 VDD.n11 4.44407
R214 VDD.n268 VDD.n82 0.114852
R215 VDD.n50 VDD.n11 4.44407
R216 VDD.n270 VDD.n50 0.114852
R217 VDD.n11 VDD.n95 9.0005
R218 VDD.n274 VDD.n103 0.114852
R219 VDD.n103 VDD.t0 4.44407
R220 VDD.n276 VDD.n26 0.114852
R221 VDD.t0 VDD.n26 4.44407
R222 VDD.n67 VDD.t0 4.44407
R223 VDD.n281 VDD.n67 0.114852
R224 VDD.n282 VDD.n56 0.114852
R225 VDD.t0 VDD.n56 4.44407
R226 VDD.t0 VDD.n286 9.0005
R227 VDD.t0 VDD.n197 9.0005
R228 VDD.n17 VDD.n40 4.44407
R229 VDD.n40 VDD.n195 0.114852
R230 VDD.n17 VDD.n18 4.44407
R231 VDD.n18 VDD.n193 0.114852
R232 VDD.n17 VDD.n84 4.44407
R233 VDD.n287 VDD.n84 0.114852
R234 VDD.n51 VDD.n17 4.44407
R235 VDD.n289 VDD.n51 0.114852
R236 VDD.n17 VDD.n94 9.0005
R237 VDD.n293 VDD.n102 0.114852
R238 VDD.n102 VDD.n17 4.44407
R239 VDD.n295 VDD.n27 0.114852
R240 VDD.n17 VDD.n27 4.44407
R241 VDD.n66 VDD.n17 4.44407
R242 VDD.n300 VDD.n66 0.114852
R243 VDD.n301 VDD.n57 0.114852
R244 VDD.n17 VDD.n57 4.44407
R245 VDD.n17 VDD.n305 9.0005
R246 VDD.n17 VDD.n182 9.0005
R247 VDD.t0 VDD.n41 4.44309
R248 VDD.n41 VDD.n180 0.116823
R249 VDD.t0 VDD.n19 4.44309
R250 VDD.n19 VDD.n178 0.116823
R251 VDD.t0 VDD.n86 4.44309
R252 VDD.n306 VDD.n86 0.116823
R253 VDD.n307 VDD.n52 0.116823
R254 VDD.n52 VDD.t0 4.44309
R255 VDD.t0 VDD.n93 9.0005
R256 VDD.n312 VDD.n101 0.116823
R257 VDD.n101 VDD.t0 4.44309
R258 VDD.n314 VDD.n22 0.116823
R259 VDD.t0 VDD.n22 4.44309
R260 VDD.n65 VDD.t0 4.44309
R261 VDD.n319 VDD.n65 0.116823
R262 VDD.n320 VDD.n58 0.116823
R263 VDD.t0 VDD.n58 4.44309
R264 VDD.n4 VDD.n324 9.0005
R265 VDD.n4 VDD.n149 9.0005
R266 VDD.n4 VDD.n42 4.44407
R267 VDD.n42 VDD.n147 0.114852
R268 VDD.n4 VDD.n23 4.44407
R269 VDD.n23 VDD.n145 0.114852
R270 VDD.n4 VDD.n34 4.44407
R271 VDD.n34 VDD.n143 0.114852
R272 VDD.n30 VDD.n142 0.114852
R273 VDD.n4 VDD.n30 4.44407
R274 VDD.n4 VDD.n141 9.0005
R275 VDD.n43 VDD.n140 0.114852
R276 VDD.n4 VDD.n43 4.44407
R277 VDD.n3 VDD.n49 4.44407
R278 VDD.n49 VDD.n137 0.114852
R279 VDD.n28 VDD.n136 0.114852
R280 VDD.n3 VDD.n28 4.44407
R281 VDD.n31 VDD.n134 0.114852
R282 VDD.n3 VDD.n31 4.44407
R283 VDD.n3 VDD.n133 9.0005
R284 VDD.n44 VDD.n132 0.114852
R285 VDD.n3 VDD.n44 4.44407
R286 VDD.n3 VDD.n46 4.44407
R287 VDD.n46 VDD.n129 0.114852
R288 VDD.n3 VDD.n88 4.44407
R289 VDD.n325 VDD.n88 0.114852
R290 VDD.n53 VDD.n3 4.44407
R291 VDD.n327 VDD.n53 0.114852
R292 VDD.n7 VDD.n92 9.0005
R293 VDD.n331 VDD.n100 0.114852
R294 VDD.n100 VDD.n7 4.44407
R295 VDD.n333 VDD.n24 0.114852
R296 VDD.n7 VDD.n24 4.44407
R297 VDD.n64 VDD.n7 4.44407
R298 VDD.n338 VDD.n64 0.114852
R299 VDD.n339 VDD.n59 0.114852
R300 VDD.n7 VDD.n59 4.44407
R301 VDD.n7 VDD.n343 9.0005
R302 VDD.n7 VDD.n47 4.44407
R303 VDD.n47 VDD.n119 0.114852
R304 VDD.n7 VDD.n29 4.44407
R305 VDD.n29 VDD.n117 0.114852
R306 VDD.t0 VDD.n116 9.0005
R307 VDD.t0 VDD.n90 4.44407
R308 VDD.n344 VDD.n90 0.114852
R309 VDD.t0 VDD.n54 4.44407
R310 VDD.n348 VDD.n54 0.114852
R311 VDD.n349 VDD.t0 9.0005
R312 VDD.n350 VDD.n99 0.114852
R313 VDD.t0 VDD.n99 4.44407
R314 VDD.n354 VDD.n25 0.114852
R315 VDD.n25 VDD.t0 4.44407
R316 VDD.n63 VDD.t0 4.44407
R317 VDD.n63 VDD.n112 0.114852
R318 VDD.n360 VDD.n60 0.114852
R319 VDD.n60 VDD.t0 4.44407
R320 VDD.n362 VDD.t0 9.0005
R321 VDD.n5 VDD.t73 8.76054
R322 VDD.n5 VDD.t143 8.76054
R323 VDD.n5 VDD.t3 8.76054
R324 VDD.n5 VDD.t135 8.76054
R325 VDD.n5 VDD.t161 8.76054
R326 VDD.n5 VDD.t125 8.76054
R327 VDD.n5 VDD.t4 8.76054
R328 VDD.n5 VDD.t138 8.76054
R329 VDD.n5 VDD.t165 8.76054
R330 VDD.n5 VDD.t129 8.76054
R331 VDD.n5 VDD.t74 8.76054
R332 VDD.n5 VDD.t144 8.76054
R333 VDD.n5 VDD.t163 8.76054
R334 VDD.n5 VDD.t123 8.76054
R335 VDD.n5 VDD.t78 8.76054
R336 VDD.n5 VDD.t109 8.76054
R337 VDD.n3 VDD.t107 8.76054
R338 VDD.t0 VDD.n6 0.710902
R339 VDD.t0 VDD.t190 7.62594
R340 VDD.n11 VDD.t207 7.62594
R341 VDD.n17 VDD.t204 7.62594
R342 VDD.t0 VDD.t201 7.62594
R343 VDD.n3 VDD.t198 7.62594
R344 VDD.t0 VDD.t195 7.62594
R345 VDD.t0 VDD.t192 7.62594
R346 VDD.t0 VDD.t191 7.62594
R347 VDD.n21 VDD.t193 7.62594
R348 VDD.t0 VDD.t194 7.62594
R349 VDD.n7 VDD.t196 7.62594
R350 VDD.n7 VDD.t197 7.62594
R351 VDD.t0 VDD.t199 7.62594
R352 VDD.t0 VDD.t200 7.62594
R353 VDD.n20 VDD.t202 7.62594
R354 VDD.n17 VDD.t203 7.62594
R355 VDD.n15 VDD.t205 7.62594
R356 VDD.t0 VDD.t206 7.62594
R357 VDD.t0 VDD.t76 5.99122
R358 VDD.t0 VDD.t69 5.99122
R359 VDD.n7 VDD.t102 5.99122
R360 VDD.t0 VDD.t77 5.99122
R361 VDD.n17 VDD.t101 5.99122
R362 VDD.t0 VDD.t158 5.99122
R363 VDD.n5 VDD.t59 5.98839
R364 VDD.n5 VDD.t136 5.97169
R365 VDD.n5 VDD.t182 5.97169
R366 VDD.n5 VDD.t151 5.97169
R367 VDD.n5 VDD.t110 5.97169
R368 VDD.n5 VDD.t72 5.97146
R369 VDD.n5 VDD.t51 5.97146
R370 VDD.n5 VDD.t171 5.97146
R371 VDD.n5 VDD.t79 5.97146
R372 VDD.t0 VDD.t189 5.96935
R373 VDD.n11 VDD.t22 5.96935
R374 VDD.n17 VDD.t174 5.96935
R375 VDD.t0 VDD.t98 5.96935
R376 VDD.t0 VDD.t35 5.96935
R377 VDD.n17 VDD.t91 5.96935
R378 VDD.n3 VDD.t178 5.96935
R379 VDD.t0 VDD.t122 5.96935
R380 VDD.t0 VDD.t34 5.96935
R381 VDD.n7 VDD.t6 5.96935
R382 VDD.t0 VDD.t160 5.96935
R383 VDD.t0 VDD.t81 5.96935
R384 VDD.t0 VDD.t132 5.96935
R385 VDD.t0 VDD.t62 5.96935
R386 VDD.t0 VDD.t154 5.96935
R387 VDD.t0 VDD.t180 5.96935
R388 VDD.t0 VDD.t58 5.96935
R389 VDD.t0 VDD.t29 5.96935
R390 VDD.t0 VDD.t33 5.96935
R391 VDD.t0 VDD.t27 5.96935
R392 VDD.n7 VDD.t25 5.96935
R393 VDD.n7 VDD.t37 5.96935
R394 VDD.n7 VDD.t49 5.96935
R395 VDD.n3 VDD.t120 5.96935
R396 VDD.t0 VDD.t42 5.96935
R397 VDD.t0 VDD.t167 5.96935
R398 VDD.t0 VDD.t67 5.96935
R399 VDD.t0 VDD.t40 5.96935
R400 VDD.n17 VDD.t44 5.96935
R401 VDD.n17 VDD.t19 5.96935
R402 VDD.n17 VDD.t88 5.96935
R403 VDD.n17 VDD.t89 5.96935
R404 VDD.t0 VDD.t11 5.96935
R405 VDD.t0 VDD.t104 5.96935
R406 VDD.n11 VDD.t177 5.96935
R407 VDD.n11 VDD.t83 5.96935
R408 VDD.n9 VDD.t124 5.96578
R409 VDD.t0 VDD.t9 5.96534
R410 VDD.t0 VDD.t119 5.96534
R411 VDD.t0 VDD.t13 5.96534
R412 VDD.n2 VDD.t115 5.96534
R413 VDD.n2 VDD.t82 5.96534
R414 VDD.n9 VDD.t128 5.96534
R415 VDD.n5 VDD.t100 5.96534
R416 VDD.t0 VDD.t80 5.96534
R417 VDD.t0 VDD.t108 5.96534
R418 VDD.t0 VDD.t14 5.96534
R419 VDD.t0 VDD.t130 5.96534
R420 VDD.t0 VDD.t46 5.96534
R421 VDD.n11 VDD.t99 5.96534
R422 VDD.t0 VDD.t39 5.96534
R423 VDD.t0 VDD.t185 5.96534
R424 VDD.n17 VDD.t16 5.96534
R425 VDD.n17 VDD.t146 5.96534
R426 VDD.n17 VDD.t84 5.96534
R427 VDD.n17 VDD.t140 5.96534
R428 VDD.t0 VDD.t15 5.96534
R429 VDD.t0 VDD.t113 5.96534
R430 VDD.n4 VDD.t60 5.96534
R431 VDD.n4 VDD.t184 5.96534
R432 VDD.n4 VDD.t86 5.96534
R433 VDD.n4 VDD.t68 5.96534
R434 VDD.n4 VDD.t5 5.96534
R435 VDD.n4 VDD.t148 5.96534
R436 VDD.n4 VDD.t97 5.96534
R437 VDD.n3 VDD.t112 5.96534
R438 VDD.n3 VDD.t8 5.96534
R439 VDD.n3 VDD.t159 5.96534
R440 VDD.n3 VDD.t94 5.96534
R441 VDD.n3 VDD.t75 5.96534
R442 VDD.n7 VDD.t92 5.96534
R443 VDD.n7 VDD.t70 5.96534
R444 VDD.n7 VDD.t96 5.96534
R445 VDD.t0 VDD.t18 5.96534
R446 VDD.t0 VDD.t31 5.96534
R447 VDD.t0 VDD.t172 5.96534
R448 VDD.t0 VDD.t53 5.96534
R449 VDD.t0 VDD.t26 5.96534
R450 VDD.t0 VDD.t55 5.96534
R451 VDD.t0 VDD.t153 5.96534
R452 VDD.t0 VDD.t47 5.96534
R453 VDD.t0 VDD.t56 5.96534
R454 VDD.t0 VDD.t64 5.96534
R455 VDD.t0 VDD.t168 5.96534
R456 VDD.n7 VDD.t52 5.96534
R457 VDD.n3 VDD.t45 5.96534
R458 VDD.n7 VDD.t147 5.96534
R459 VDD.t0 VDD.t54 5.96534
R460 VDD.t0 VDD.t12 5.96534
R461 VDD.t0 VDD.t139 5.96534
R462 VDD.n17 VDD.t1 5.96534
R463 VDD.n17 VDD.t17 5.96534
R464 VDD.n17 VDD.t183 5.96534
R465 VDD.t0 VDD.t175 5.96534
R466 VDD.n11 VDD.t85 5.96534
R467 VDD.n11 VDD.t118 5.96534
R468 VDD.t0 VDD.t141 5.96512
R469 VDD.t0 VDD.t2 5.96512
R470 VDD.n9 VDD.t162 5.96512
R471 VDD.n9 VDD.t164 5.96512
R472 VDD.n17 VDD.t93 5.96512
R473 VDD.t0 VDD.t63 5.96512
R474 VDD.n3 VDD.t116 5.96512
R475 VDD.n4 VDD.t173 5.96512
R476 VDD.n4 VDD.t114 5.96512
R477 VDD.n7 VDD.t21 5.96512
R478 VDD.t0 VDD.t65 5.96512
R479 VDD.t0 VDD.t155 5.65005
R480 VDD.n11 VDD.t23 5.65005
R481 VDD.n17 VDD.t90 5.65005
R482 VDD.t0 VDD.t36 5.65005
R483 VDD.n3 VDD.t121 5.65005
R484 VDD.t0 VDD.t28 5.65005
R485 VDD.t0 VDD.t61 5.65005
R486 VDD.t0 VDD.t133 5.65005
R487 VDD.n21 VDD.t57 5.65005
R488 VDD.t0 VDD.t30 5.65005
R489 VDD.n7 VDD.t7 5.65005
R490 VDD.n7 VDD.t38 5.65005
R491 VDD.t0 VDD.t41 5.65005
R492 VDD.t0 VDD.t66 5.65005
R493 VDD.n20 VDD.t43 5.65005
R494 VDD.n17 VDD.t20 5.65005
R495 VDD.n15 VDD.t10 5.65005
R496 VDD.t0 VDD.t105 5.65005
R497 VDD.n247 VDD.n246 0.692362
R498 VDD.n259 VDD.n258 0.461741
R499 VDD.n285 VDD.n203 0.461741
R500 VDD.n304 VDD.n188 0.461741
R501 VDD.n323 VDD.n173 0.461741
R502 VDD.n165 VDD.n164 0.461741
R503 VDD.n156 VDD.n155 0.461741
R504 VDD.n342 VDD.n124 0.461741
R505 VDD.n364 VDD.n363 0.461741
R506 VDD.n394 VDD.n392 0.461741
R507 VDD.n366 VDD.n365 0.235167
R508 VDD.n367 VDD.n48 0.116823
R509 VDD.n367 VDD.n70 0.235167
R510 VDD.n371 VDD.n55 0.116823
R511 VDD.n372 VDD.n371 0.235167
R512 VDD.n91 VDD.n372 0.116823
R513 VDD.n373 VDD.n69 0.235167
R514 VDD.n377 VDD.n68 0.116823
R515 VDD.n378 VDD.n377 0.235167
R516 VDD.n379 VDD.n378 0.235167
R517 VDD.n97 VDD.n96 0.116823
R518 VDD.n383 VDD.n96 0.235167
R519 VDD.n13 VDD.n383 0.116823
R520 VDD.n385 VDD.n384 0.235167
R521 VDD.n385 VDD.n73 0.116823
R522 VDD.n389 VDD.n106 0.235167
R523 VDD.n390 VDD.n61 0.116823
R524 VDD.n391 VDD.n390 0.235167
R525 VDD.n182 VDD.n181 0.235167
R526 VDD.n181 VDD.n41 0.116823
R527 VDD.n180 VDD.n179 0.235167
R528 VDD.n179 VDD.n19 0.116823
R529 VDD.n178 VDD.n85 0.235167
R530 VDD.n86 VDD.n85 0.116823
R531 VDD.n307 VDD.n306 0.235167
R532 VDD.n308 VDD.n52 0.116823
R533 VDD.n308 VDD.n93 0.235167
R534 VDD.n312 VDD.n93 0.235167
R535 VDD.n313 VDD.n101 0.116823
R536 VDD.n314 VDD.n313 0.235167
R537 VDD.n22 VDD.n79 0.116823
R538 VDD.n318 VDD.n79 0.235167
R539 VDD.n65 VDD.n318 0.116823
R540 VDD.n320 VDD.n319 0.235167
R541 VDD.n58 VDD.n76 0.116823
R542 VDD.n324 VDD.n76 0.235167
R543 VDD.n224 VDD.n223 0.231121
R544 VDD.n224 VDD.n221 0.231121
R545 VDD.n228 VDD.n221 0.231121
R546 VDD.n229 VDD.n228 0.231121
R547 VDD.n230 VDD.n229 0.231121
R548 VDD.n230 VDD.n219 0.231121
R549 VDD.n234 VDD.n219 0.231121
R550 VDD.n235 VDD.n234 0.231121
R551 VDD.n236 VDD.n235 0.231121
R552 VDD.n236 VDD.n217 0.231121
R553 VDD.n240 VDD.n217 0.231121
R554 VDD.n241 VDD.n240 0.231121
R555 VDD.n242 VDD.n241 0.231121
R556 VDD.n242 VDD.n215 0.231121
R557 VDD.n246 VDD.n215 0.231121
R558 VDD.n248 VDD.n247 0.231121
R559 VDD.n249 VDD.n248 0.231121
R560 VDD.n249 VDD.n213 0.231121
R561 VDD.n253 VDD.n213 0.231121
R562 VDD.n254 VDD.n253 0.231121
R563 VDD.n255 VDD.n254 0.231121
R564 VDD.n255 VDD.n211 0.231121
R565 VDD.n258 VDD.n211 0.231121
R566 VDD.n260 VDD.n259 0.231121
R567 VDD.n260 VDD.n209 0.231121
R568 VDD.n264 VDD.n209 0.231121
R569 VDD.n265 VDD.n264 0.231121
R570 VDD.n266 VDD.n265 0.231121
R571 VDD.n266 VDD.n207 0.231121
R572 VDD.n207 VDD.n206 0.231121
R573 VDD.n271 VDD.n206 0.231121
R574 VDD.n272 VDD.n271 0.231121
R575 VDD.n273 VDD.n272 0.231121
R576 VDD.n273 VDD.n205 0.231121
R577 VDD.n277 VDD.n205 0.231121
R578 VDD.n278 VDD.n277 0.231121
R579 VDD.n279 VDD.n278 0.231121
R580 VDD.n279 VDD.n204 0.231121
R581 VDD.n283 VDD.n204 0.231121
R582 VDD.n284 VDD.n283 0.231121
R583 VDD.n285 VDD.n284 0.231121
R584 VDD.n203 VDD.n202 0.231121
R585 VDD.n202 VDD.n201 0.231121
R586 VDD.n201 VDD.n200 0.231121
R587 VDD.n200 VDD.n199 0.231121
R588 VDD.n199 VDD.n198 0.231121
R589 VDD.n198 VDD.n192 0.231121
R590 VDD.n192 VDD.n191 0.231121
R591 VDD.n290 VDD.n191 0.231121
R592 VDD.n291 VDD.n290 0.231121
R593 VDD.n292 VDD.n291 0.231121
R594 VDD.n292 VDD.n190 0.231121
R595 VDD.n296 VDD.n190 0.231121
R596 VDD.n297 VDD.n296 0.231121
R597 VDD.n298 VDD.n297 0.231121
R598 VDD.n298 VDD.n189 0.231121
R599 VDD.n302 VDD.n189 0.231121
R600 VDD.n303 VDD.n302 0.231121
R601 VDD.n304 VDD.n303 0.231121
R602 VDD.n188 VDD.n187 0.231121
R603 VDD.n187 VDD.n186 0.231121
R604 VDD.n186 VDD.n185 0.231121
R605 VDD.n185 VDD.n184 0.231121
R606 VDD.n184 VDD.n183 0.231121
R607 VDD.n183 VDD.n177 0.231121
R608 VDD.n177 VDD.n176 0.231121
R609 VDD.n309 VDD.n176 0.231121
R610 VDD.n310 VDD.n309 0.231121
R611 VDD.n311 VDD.n310 0.231121
R612 VDD.n311 VDD.n175 0.231121
R613 VDD.n315 VDD.n175 0.231121
R614 VDD.n316 VDD.n315 0.231121
R615 VDD.n317 VDD.n316 0.231121
R616 VDD.n317 VDD.n174 0.231121
R617 VDD.n321 VDD.n174 0.231121
R618 VDD.n322 VDD.n321 0.231121
R619 VDD.n323 VDD.n322 0.231121
R620 VDD.n173 VDD.n172 0.231121
R621 VDD.n172 VDD.n171 0.231121
R622 VDD.n171 VDD.n170 0.231121
R623 VDD.n170 VDD.n169 0.231121
R624 VDD.n169 VDD.n168 0.231121
R625 VDD.n168 VDD.n167 0.231121
R626 VDD.n167 VDD.n166 0.231121
R627 VDD.n166 VDD.n165 0.231121
R628 VDD.n164 VDD.n163 0.231121
R629 VDD.n163 VDD.n162 0.231121
R630 VDD.n162 VDD.n161 0.231121
R631 VDD.n161 VDD.n160 0.231121
R632 VDD.n160 VDD.n159 0.231121
R633 VDD.n159 VDD.n158 0.231121
R634 VDD.n158 VDD.n157 0.231121
R635 VDD.n157 VDD.n156 0.231121
R636 VDD.n155 VDD.n154 0.231121
R637 VDD.n154 VDD.n153 0.231121
R638 VDD.n153 VDD.n152 0.231121
R639 VDD.n152 VDD.n151 0.231121
R640 VDD.n151 VDD.n150 0.231121
R641 VDD.n150 VDD.n128 0.231121
R642 VDD.n128 VDD.n127 0.231121
R643 VDD.n328 VDD.n127 0.231121
R644 VDD.n329 VDD.n328 0.231121
R645 VDD.n330 VDD.n329 0.231121
R646 VDD.n330 VDD.n126 0.231121
R647 VDD.n334 VDD.n126 0.231121
R648 VDD.n335 VDD.n334 0.231121
R649 VDD.n336 VDD.n335 0.231121
R650 VDD.n336 VDD.n125 0.231121
R651 VDD.n340 VDD.n125 0.231121
R652 VDD.n341 VDD.n340 0.231121
R653 VDD.n342 VDD.n341 0.231121
R654 VDD.n124 VDD.n123 0.231121
R655 VDD.n123 VDD.n122 0.231121
R656 VDD.n122 VDD.n121 0.231121
R657 VDD.n121 VDD.n120 0.231121
R658 VDD.n120 VDD.n115 0.231121
R659 VDD.n345 VDD.n115 0.231121
R660 VDD.n346 VDD.n345 0.231121
R661 VDD.n347 VDD.n346 0.231121
R662 VDD.n347 VDD.n114 0.231121
R663 VDD.n351 VDD.n114 0.231121
R664 VDD.n352 VDD.n351 0.231121
R665 VDD.n353 VDD.n352 0.231121
R666 VDD.n353 VDD.n113 0.231121
R667 VDD.n357 VDD.n113 0.231121
R668 VDD.n358 VDD.n357 0.231121
R669 VDD.n359 VDD.n358 0.231121
R670 VDD.n359 VDD.n111 0.231121
R671 VDD.n363 VDD.n111 0.231121
R672 VDD.n364 VDD.n110 0.231121
R673 VDD.n368 VDD.n110 0.231121
R674 VDD.n369 VDD.n368 0.231121
R675 VDD.n370 VDD.n369 0.231121
R676 VDD.n370 VDD.n109 0.231121
R677 VDD.n374 VDD.n109 0.231121
R678 VDD.n375 VDD.n374 0.231121
R679 VDD.n376 VDD.n375 0.231121
R680 VDD.n376 VDD.n108 0.231121
R681 VDD.n380 VDD.n108 0.231121
R682 VDD.n381 VDD.n380 0.231121
R683 VDD.n382 VDD.n381 0.231121
R684 VDD.n382 VDD.n107 0.231121
R685 VDD.n386 VDD.n107 0.231121
R686 VDD.n387 VDD.n386 0.231121
R687 VDD.n388 VDD.n387 0.231121
R688 VDD.n388 VDD.n105 0.231121
R689 VDD.n392 VDD.n105 0.231121
R690 VDD.n395 VDD.n394 0.231121
R691 VDD.n1 VDD.n395 1.81983
R692 VDD.n261 VDD.n210 0.231121
R693 VDD.n39 VDD.n261 0.114852
R694 VDD.n263 VDD.n262 0.231121
R695 VDD.n263 VDD.n45 0.114852
R696 VDD.n267 VDD.n208 0.231121
R697 VDD.n82 VDD.n267 0.114852
R698 VDD.n269 VDD.n268 0.231121
R699 VDD.n50 VDD.n269 0.114852
R700 VDD.n270 VDD.n95 0.231121
R701 VDD.n274 VDD.n95 0.231121
R702 VDD.n275 VDD.n103 0.114852
R703 VDD.n276 VDD.n275 0.231121
R704 VDD.n26 VDD.n81 0.114852
R705 VDD.n280 VDD.n81 0.231121
R706 VDD.n67 VDD.n280 0.114852
R707 VDD.n282 VDD.n281 0.231121
R708 VDD.n56 VDD.n74 0.114852
R709 VDD.n286 VDD.n74 0.231121
R710 VDD.n197 VDD.n196 0.231121
R711 VDD.n196 VDD.n40 0.114852
R712 VDD.n195 VDD.n194 0.231121
R713 VDD.n194 VDD.n18 0.114852
R714 VDD.n193 VDD.n83 0.231121
R715 VDD.n84 VDD.n83 0.114852
R716 VDD.n288 VDD.n287 0.231121
R717 VDD.n51 VDD.n288 0.114852
R718 VDD.n289 VDD.n94 0.231121
R719 VDD.n293 VDD.n94 0.231121
R720 VDD.n294 VDD.n102 0.114852
R721 VDD.n295 VDD.n294 0.231121
R722 VDD.n27 VDD.n80 0.114852
R723 VDD.n299 VDD.n80 0.231121
R724 VDD.n66 VDD.n299 0.114852
R725 VDD.n301 VDD.n300 0.231121
R726 VDD.n57 VDD.n75 0.114852
R727 VDD.n305 VDD.n75 0.231121
R728 VDD.n133 VDD.n132 0.231121
R729 VDD.n44 VDD.n131 0.114852
R730 VDD.n131 VDD.n130 0.231121
R731 VDD.n130 VDD.n46 0.114852
R732 VDD.n129 VDD.n87 0.231121
R733 VDD.n88 VDD.n87 0.114852
R734 VDD.n326 VDD.n325 0.231121
R735 VDD.n53 VDD.n326 0.114852
R736 VDD.n327 VDD.n92 0.231121
R737 VDD.n331 VDD.n92 0.231121
R738 VDD.n332 VDD.n100 0.114852
R739 VDD.n333 VDD.n332 0.231121
R740 VDD.n24 VDD.n78 0.114852
R741 VDD.n337 VDD.n78 0.231121
R742 VDD.n64 VDD.n337 0.114852
R743 VDD.n339 VDD.n338 0.231121
R744 VDD.n59 VDD.n77 0.114852
R745 VDD.n343 VDD.n77 0.231121
R746 VDD.n124 VDD.n47 9.11485
R747 VDD.n119 VDD.n118 0.231121
R748 VDD.n118 VDD.n29 0.114852
R749 VDD.n117 VDD.n116 0.231121
R750 VDD.n116 VDD.n89 0.231121
R751 VDD.n90 VDD.n89 0.114852
R752 VDD.n344 VDD.n62 0.231121
R753 VDD.n54 VDD.n62 0.114852
R754 VDD.n349 VDD.n348 0.231121
R755 VDD.n350 VDD.n349 0.231121
R756 VDD.n99 VDD.n98 0.114852
R757 VDD.n354 VDD.n98 0.231121
R758 VDD.n355 VDD.n25 0.114852
R759 VDD.n356 VDD.n355 0.231121
R760 VDD.n356 VDD.n63 0.114852
R761 VDD.n360 VDD.n112 0.231121
R762 VDD.n361 VDD.n60 0.114852
R763 VDD.n362 VDD.n361 0.231121
R764 VDD.n141 VDD.n140 0.231121
R765 VDD.n43 VDD.n139 0.114852
R766 VDD.n139 VDD.n138 0.231121
R767 VDD.n138 VDD.n49 0.114852
R768 VDD.n137 VDD.n136 0.231121
R769 VDD.n28 VDD.n135 0.114852
R770 VDD.n135 VDD.n134 0.231121
R771 VDD.n149 VDD.n148 0.231121
R772 VDD.n148 VDD.n42 0.114852
R773 VDD.n147 VDD.n146 0.231121
R774 VDD.n146 VDD.n23 0.114852
R775 VDD.n145 VDD.n144 0.231121
R776 VDD.n144 VDD.n34 0.114852
R777 VDD.n143 VDD.n142 0.231121
R778 VDD.n247 VDD.n16 9.11485
R779 VDD.n250 VDD.n214 0.231121
R780 VDD.n35 VDD.n250 0.114852
R781 VDD.n252 VDD.n251 0.231121
R782 VDD.n252 VDD.n212 0.231121
R783 VDD.n36 VDD.n212 0.114852
R784 VDD.n257 VDD.n256 0.231121
R785 VDD.n38 VDD.n257 0.114852
R786 VDD.n10 VDD.n396 2.16764
R787 VDD.n396 VDD.n8 0.231121
R788 VDD.n72 VDD.n8 0.114852
R789 VDD.n225 VDD.n222 0.231121
R790 VDD.n14 VDD.n225 0.114852
R791 VDD.n227 VDD.n226 0.231121
R792 VDD.n227 VDD.n33 0.114852
R793 VDD.n231 VDD.n220 0.231121
R794 VDD.n32 VDD.n231 0.114852
R795 VDD.n233 VDD.n232 0.231121
R796 VDD.n233 VDD.n71 0.114852
R797 VDD.n237 VDD.n218 0.231121
R798 VDD.n238 VDD.n237 0.231121
R799 VDD.n12 VDD.n238 0.114852
R800 VDD.n239 VDD.n216 0.231121
R801 VDD.n243 VDD.n216 0.231121
R802 VDD.n37 VDD.n243 0.114852
R803 VDD.n245 VDD.n244 0.231121
R804 VDD.n393 VDD.n104 0.231121
R805 VDD.n1 VDD.n0 0.519326
R806 VDD.n2 VDD.n1 1.6161
R807 VDD VDD.n10 2.85354
R808 VDD.n3 VDD.t0 1.44533
R809 VDD.t0 VDD.n7 1.15234
R810 VDD.n6 VDD.n5 0.454189
R811 VDD.n9 VDD.n6 0.633129
R812 VDD.n17 VDD.t0 1.11775
R813 VDD.n2 VDD.t0 1.10113
R814 VDD.n4 VDD.n3 0.466096
R815 VDD.t0 VDD.n11 1.06213
R816 VDD.n223 VDD 1.05468
R817 VDD.t0 VDD.n15 1.0422
R818 VDD.t0 VDD.n21 1.02291
R819 VDD.n17 VDD.n20 1.02291
R820 VSS.n22 VSS.n0 16832
R821 VSS.n49 VSS.n51 4683.65
R822 VSS.n91 VSS.n123 567.691
R823 VSS.n86 VSS.n133 567.691
R824 VSS.n96 VSS.n143 567.691
R825 VSS.n81 VSS.n150 567.691
R826 VSS.n76 VSS.n160 567.691
R827 VSS.n112 VSS.n94 0.00197011
R828 VSS.n113 VSS.n90 0.00197011
R829 VSS.n74 VSS.n72 0.00247012
R830 VSS.t302 VSS.n53 551.689
R831 VSS.n779 VSS.n778 551.689
R832 VSS.n740 VSS.n739 551.689
R833 VSS.n701 VSS.n700 551.689
R834 VSS.n623 VSS.n622 551.689
R835 VSS.n584 VSS.n583 551.689
R836 VSS.n545 VSS.n544 551.689
R837 VSS.n778 VSS.n242 551.688
R838 VSS.n739 VSS.n267 551.688
R839 VSS.n700 VSS.n293 551.688
R840 VSS.n622 VSS.n356 551.688
R841 VSS.n583 VSS.n382 551.688
R842 VSS.n544 VSS.n408 551.688
R843 VSS.t310 VSS.n98 65.7889
R844 VSS.t307 VSS.n55 537.605
R845 VSS.n102 VSS.t28 21.867
R846 VSS.t160 VSS.n97 52.2183
R847 VSS.n196 VSS.t303 492.959
R848 VSS.t310 VSS.n102 501.704
R849 VSS.n201 VSS.t59 478.873
R850 VSS.t170 VSS.n4 15.3031
R851 VSS.n779 VSS.t179 471.832
R852 VSS.n740 VSS.t194 471.832
R853 VSS.n701 VSS.t209 471.832
R854 VSS.n623 VSS.t224 471.832
R855 VSS.n584 VSS.t239 471.832
R856 VSS.n545 VSS.t254 471.832
R857 VSS.n63 VSS.t98 467.195
R858 VSS.t95 VSS.n68 267.416
R859 VSS.t287 VSS.n20 26.3107
R860 VSS.t6 VSS.n175 436.62
R861 VSS.n24 VSS.t171 430.062
R862 VSS.n25 VSS.t315 418.382
R863 VSS.n31 VSS.t137 68.5978
R864 VSS.n30 VSS.n22 0.382621
R865 VSS.n29 VSS.n22 0.382621
R866 VSS.n32 VSS.n22 0.382621
R867 VSS.t284 VSS.n28 68.5978
R868 VSS.t93 VSS.n27 68.5978
R869 VSS.t309 VSS.n1 68.5978
R870 VSS.n33 VSS.n22 0.382621
R871 VSS.t8 VSS.n67 417.714
R872 VSS.n95 VSS.t187 116.822
R873 VSS.t199 VSS.n88 502.404
R874 VSS.t214 VSS.n99 502.404
R875 VSS.t229 VSS.n82 502.404
R876 VSS.n79 VSS.t247 116.822
R877 VSS.n104 VSS.t262 403.817
R878 VSS.t300 VSS.n63 116.822
R879 VSS.n21 VSS.t278 72.4354
R880 VSS.t265 VSS.n64 231.506
R881 VSS.t142 VSS.n117 404.05
R882 VSS.t269 VSS.n471 375
R883 VSS.n242 VSS.t177 373.24
R884 VSS.n267 VSS.t192 373.24
R885 VSS.n293 VSS.t207 373.24
R886 VSS.n356 VSS.t222 373.24
R887 VSS.n382 VSS.t237 373.24
R888 VSS.n408 VSS.t252 373.24
R889 VSS.n198 VSS.t306 366.197
R890 VSS.n60 VSS.n61 0.00565914
R891 VSS.n112 VSS.t189 375.647
R892 VSS.n113 VSS.t204 375.647
R893 VSS.n74 VSS.n75 0.00200118
R894 VSS.n115 VSS.t234 375.647
R895 VSS.n116 VSS.t249 375.647
R896 VSS.n18 VSS.t173 98.6395
R897 VSS.n22 VSS.n108 0.423468
R898 VSS.n22 VSS.n70 0.423468
R899 VSS.n22 VSS.n109 0.423468
R900 VSS.n22 VSS.n69 0.423468
R901 VSS.n14 VSS.t264 98.6395
R902 VSS.n13 VSS.t281 98.6395
R903 VSS.n22 VSS.n110 0.423468
R904 VSS.n22 VSS.n66 0.423468
R905 VSS.n11 VSS.t321 98.6395
R906 VSS.n9 VSS.t322 98.6395
R907 VSS.n8 VSS.t38 98.6395
R908 VSS.n6 VSS.t130 98.6395
R909 VSS.n22 VSS.n111 0.423468
R910 VSS.n22 VSS.n50 0.423468
R911 VSS.n5 VSS.t305 98.6395
R912 VSS.t157 VSS.n114 133.322
R913 VSS.n198 VSS.t99 352.113
R914 VSS.t270 VSS.n65 359.983
R915 VSS.n22 VSS.t110 101.647
R916 VSS.n22 VSS.t314 101.647
R917 VSS.n22 VSS.t33 101.647
R918 VSS.n22 VSS.t1 101.647
R919 VSS.n22 VSS.t68 101.647
R920 VSS.n22 VSS.t134 101.647
R921 VSS.n22 VSS.t132 101.647
R922 VSS.n22 VSS.t23 101.647
R923 VSS.t168 VSS.n22 101.656
R924 VSS.t147 VSS.n107 348.303
R925 VSS.t136 VSS.n43 348.303
R926 VSS.t293 VSS.n42 348.303
R927 VSS.t292 VSS.n35 348.303
R928 VSS.t152 VSS.n37 348.303
R929 VSS.t104 VSS.n44 348.303
R930 VSS.t90 VSS.n38 348.303
R931 VSS.t156 VSS.n474 338.711
R932 VSS.t25 VSS.n34 111.644
R933 VSS.n22 VSS.t119 108.561
R934 VSS.n22 VSS.t49 108.561
R935 VSS.n35 VSS.n22 6.82258
R936 VSS.t115 VSS.n36 111.644
R937 VSS.n37 VSS.n22 6.82258
R938 VSS.n22 VSS.t79 108.561
R939 VSS.n38 VSS.n22 6.82258
R940 VSS.n22 VSS.t14 108.561
R941 VSS.t51 VSS.n39 111.644
R942 VSS.n22 VSS.t124 108.561
R943 VSS.n22 VSS.t85 108.561
R944 VSS.n22 VSS.t46 108.561
R945 VSS.t70 VSS.n40 111.644
R946 VSS.t16 VSS.n41 111.644
R947 VSS.n23 VSS.t113 108.505
R948 VSS.t299 VSS.n55 326.337
R949 VSS.n71 VSS.t105 404.05
R950 VSS.t144 VSS.n117 129.738
R951 VSS.n478 VSS.t286 314.517
R952 VSS.n60 VSS.n62 0.00443131
R953 VSS.n101 VSS.n72 0.00443117
R954 VSS.t158 VSS.n114 140.65
R955 VSS.n105 VSS.t275 140.645
R956 VSS.t60 VSS.n53 312.252
R957 VSS.n478 VSS.t279 302.42
R958 VSS.t182 VSS.n121 291.142
R959 VSS.t197 VSS.n131 291.142
R960 VSS.t212 VSS.n141 291.142
R961 VSS.t227 VSS.n148 291.142
R962 VSS.t242 VSS.n158 291.142
R963 VSS.t257 VSS.n106 141.963
R964 VSS.n51 VSS.t296 141.702
R965 VSS.t166 VSS.n24 110.901
R966 VSS.t95 VSS.n175 281.69
R967 VSS.t149 VSS.n107 111.647
R968 VSS.n34 VSS.t146 348.303
R969 VSS.t118 VSS.n43 111.644
R970 VSS.t48 VSS.n42 111.644
R971 VSS.t35 VSS.n35 111.644
R972 VSS.n36 VSS.t139 348.303
R973 VSS.t19 VSS.n37 111.644
R974 VSS.t78 VSS.n44 111.644
R975 VSS.t10 VSS.n38 111.644
R976 VSS.n46 VSS.t151 348.303
R977 VSS.n39 VSS.t101 348.303
R978 VSS.n45 VSS.t140 348.303
R979 VSS.n48 VSS.t150 348.303
R980 VSS.n47 VSS.t92 348.303
R981 VSS.n40 VSS.t43 348.303
R982 VSS.n41 VSS.t141 348.303
R983 VSS.t112 VSS.n474 278.226
R984 VSS.n123 VSS.t182 277.055
R985 VSS.n133 VSS.t197 277.055
R986 VSS.n143 VSS.t212 277.055
R987 VSS.n150 VSS.t227 277.055
R988 VSS.n160 VSS.t242 277.055
R989 VSS.n25 VSS.n22 9.3247
R990 VSS.t4 VSS.n62 140.651
R991 VSS.n92 VSS.t126 140.651
R992 VSS.n87 VSS.t82 140.651
R993 VSS.n101 VSS.t154 140.651
R994 VSS.n85 VSS.t41 140.651
R995 VSS.n80 VSS.t88 140.651
R996 VSS.n105 VSS.t274 354.514
R997 VSS.n22 VSS.n49 0.301145
R998 VSS.t265 VSS.n471 241.935
R999 VSS.t298 VSS.n67 131.77
R1000 VSS.t163 VSS.n49 122.754
R1001 VSS.n201 VSS.t60 239.438
R1002 VSS.t76 VSS.n60 137.774
R1003 VSS.n72 VSS.n117 6.80932
R1004 VSS.n71 VSS.t107 129.738
R1005 VSS.n196 VSS.t299 225.352
R1006 VSS.n72 VSS.n114 0.00451796
R1007 VSS.t125 VSS.n92 133.321
R1008 VSS.t81 VSS.n87 133.321
R1009 VSS.t153 VSS.n101 133.321
R1010 VSS.n85 VSS.n84 0.00443117
R1011 VSS.n80 VSS.n78 0.00443117
R1012 VSS.t274 VSS.n103 213.679
R1013 VSS.t165 VSS.n65 113.322
R1014 VSS.n25 VSS.t316 112.787
R1015 VSS.t99 VSS.n54 199.084
R1016 VSS.n22 VSS.n107 6.82269
R1017 VSS.t174 VSS.n61 127.297
R1018 VSS.t189 VSS.n127 192.548
R1019 VSS.t204 VSS.n137 192.548
R1020 VSS.t219 VSS.n75 127.299
R1021 VSS.t234 VSS.n154 192.548
R1022 VSS.t249 VSS.n164 192.548
R1023 VSS.t306 VSS.n57 185
R1024 VSS.t192 VSS.n127 178.466
R1025 VSS.t207 VSS.n137 178.466
R1026 VSS.t237 VSS.n154 178.466
R1027 VSS.t252 VSS.n164 178.466
R1028 VSS.n60 VSS.n63 0.00553973
R1029 VSS.t262 VSS.n103 164.381
R1030 VSS.n95 VSS.n94 0.00553969
R1031 VSS.t202 VSS.n88 116.822
R1032 VSS.t217 VSS.n99 116.822
R1033 VSS.t232 VSS.n82 116.822
R1034 VSS.n79 VSS.n78 0.00553969
R1035 VSS.t26 VSS.n22 108.561
R1036 VSS.t36 VSS.n22 108.561
R1037 VSS.t116 VSS.n22 108.561
R1038 VSS.t20 VSS.n22 108.561
R1039 VSS.t11 VSS.n22 108.561
R1040 VSS.t52 VSS.n22 108.561
R1041 VSS.t71 VSS.n22 108.561
R1042 VSS.t17 VSS.n22 108.561
R1043 VSS.n23 VSS.n22 0.0786776
R1044 VSS.t286 VSS.n20 161.025
R1045 VSS.n56 VSS.t105 156.831
R1046 VSS.n22 VSS.n31 0.382621
R1047 VSS.t55 VSS.n22 101.647
R1048 VSS.n16 VSS.t313 83.4525
R1049 VSS.n30 VSS.t32 83.4525
R1050 VSS.n15 VSS.t0 83.4525
R1051 VSS.t30 VSS.n22 101.647
R1052 VSS.n29 VSS.t67 83.4525
R1053 VSS.t122 VSS.n22 101.647
R1054 VSS.n22 VSS.n28 0.382621
R1055 VSS.t129 VSS.n22 101.647
R1056 VSS.t63 VSS.n22 101.647
R1057 VSS.n22 VSS.n27 0.382621
R1058 VSS.t74 VSS.n22 101.647
R1059 VSS.t66 VSS.n22 101.647
R1060 VSS.t58 VSS.n22 101.647
R1061 VSS.n22 VSS.n26 0.382621
R1062 VSS.n52 VSS.t8 142.746
R1063 VSS.n19 VSS.t147 136.798
R1064 VSS.n18 VSS.t146 136.962
R1065 VSS.t167 VSS.n108 98.6395
R1066 VSS.t323 VSS.n70 98.6395
R1067 VSS.t282 VSS.n109 98.6395
R1068 VSS.t277 VSS.n69 98.6395
R1069 VSS.n14 VSS.t152 136.962
R1070 VSS.n13 VSS.t104 136.962
R1071 VSS.t285 VSS.n110 98.6395
R1072 VSS.t289 VSS.n66 98.6395
R1073 VSS.n11 VSS.t101 136.962
R1074 VSS.n9 VSS.t140 136.962
R1075 VSS.n8 VSS.t150 136.962
R1076 VSS.n6 VSS.t92 136.962
R1077 VSS.t291 VSS.n111 98.6395
R1078 VSS.t103 VSS.n50 98.6395
R1079 VSS.n5 VSS.t156 136.962
R1080 VSS.n3 VSS.t270 124.701
R1081 VSS.n58 VSS.t6 114.578
R1082 VSS.t98 VSS.n58 100.493
R1083 VSS.n21 VSS.t269 100.614
R1084 VSS.t96 VSS.n68 71.0343
R1085 VSS.n31 VSS.t109 83.4525
R1086 VSS.n17 VSS.t172 68.5978
R1087 VSS.n16 VSS.t161 68.5978
R1088 VSS.n30 VSS.t320 68.5978
R1089 VSS.n15 VSS.t318 68.5978
R1090 VSS.n2 VSS.t273 68.5978
R1091 VSS.n29 VSS.t272 68.5978
R1092 VSS.n32 VSS.t319 68.5978
R1093 VSS.t133 VSS.n28 83.4525
R1094 VSS.n12 VSS.t295 68.5978
R1095 VSS.n10 VSS.t283 68.5978
R1096 VSS.t131 VSS.n27 83.4525
R1097 VSS.n7 VSS.t304 68.5978
R1098 VSS.t65 VSS.n1 83.4525
R1099 VSS.n33 VSS.t290 68.5978
R1100 VSS.n26 VSS.t162 68.5978
R1101 VSS.t179 VSS.n121 79.8726
R1102 VSS.t194 VSS.n131 79.8726
R1103 VSS.t209 VSS.n141 79.8726
R1104 VSS.t224 VSS.n148 79.8726
R1105 VSS.t239 VSS.n158 79.8726
R1106 VSS.t267 VSS.n64 62.2552
R1107 VSS.t59 VSS.n52 72.3236
R1108 VSS.t184 VSS.n91 65.2813
R1109 VSS.t199 VSS.n86 65.2813
R1110 VSS.t214 VSS.n96 65.2813
R1111 VSS.t229 VSS.n81 65.2813
R1112 VSS.t244 VSS.n76 65.2813
R1113 VSS.n104 VSS.t259 58.1708
R1114 VSS.t315 VSS.n3 64.2173
R1115 VSS.t303 VSS.n56 58.2391
R1116 VSS.t142 VSS.n97 156.883
R1117 VSS.t171 VSS.n19 52.1205
R1118 VSS.n57 VSS.t307 30.0701
R1119 VSS.n102 VSS.n72 0.704795
R1120 VSS.t311 VSS.n98 22.5601
R1121 VSS.n22 VSS.t169 17.0005
R1122 VSS.n22 VSS.n471 17.0005
R1123 VSS.n22 VSS.t266 17.0005
R1124 VSS.n22 VSS.n64 2.65215
R1125 VSS.n22 VSS.n65 7.23977
R1126 VSS.n22 VSS.n472 17.0005
R1127 VSS.n22 VSS.n478 17.0005
R1128 VSS.n22 VSS.t288 17.0005
R1129 VSS.n22 VSS.n24 9.74178
R1130 VSS.n22 VSS.n34 6.82258
R1131 VSS.n22 VSS.n36 6.82258
R1132 VSS.n22 VSS.n46 6.82258
R1133 VSS.n22 VSS.n39 6.82258
R1134 VSS.n22 VSS.n45 6.82258
R1135 VSS.n22 VSS.n48 6.82258
R1136 VSS.n22 VSS.n47 6.82258
R1137 VSS.n22 VSS.n40 6.82258
R1138 VSS.n22 VSS.n41 6.82258
R1139 VSS.n22 VSS.n474 17.0005
R1140 VSS.n0 VSS.n431 17.0005
R1141 VSS.n60 VSS.t301 17.0005
R1142 VSS.n60 VSS.n175 17.0005
R1143 VSS.n60 VSS.t7 17.0005
R1144 VSS.n60 VSS.n68 2.5991
R1145 VSS.n60 VSS.n67 7.23037
R1146 VSS.n60 VSS.n176 17.0005
R1147 VSS.n60 VSS.n201 17.0005
R1148 VSS.n60 VSS.n198 17.0005
R1149 VSS.n60 VSS.t308 17.0005
R1150 VSS.n60 VSS.n196 17.0005
R1151 VSS.n60 VSS.n71 6.80932
R1152 VSS.n60 VSS.n178 17.0005
R1153 VSS.n60 VSS.n179 17.0005
R1154 VSS.n60 VSS.n242 17.0005
R1155 VSS.n243 VSS.n120 0.0467092
R1156 VSS.n93 VSS.n779 17.0005
R1157 VSS.n93 VSS.t181 17.0005
R1158 VSS.n93 VSS.n124 5.64823
R1159 VSS.n94 VSS.n260 17.0005
R1160 VSS.n128 VSS.n267 17.0005
R1161 VSS.n268 VSS.n130 0.0467092
R1162 VSS.n89 VSS.n740 17.0005
R1163 VSS.n89 VSS.t196 17.0005
R1164 VSS.n90 VSS.n286 17.0005
R1165 VSS.n138 VSS.n293 17.0005
R1166 VSS.n294 VSS.n140 0.0467092
R1167 VSS.n100 VSS.n701 17.0005
R1168 VSS.n100 VSS.t211 17.0005
R1169 VSS.n100 VSS.n144 5.64823
R1170 VSS.n72 VSS.n330 17.0005
R1171 VSS.n72 VSS.t312 17.0005
R1172 VSS.n72 VSS.t143 17.0005
R1173 VSS.n72 VSS.n328 17.0005
R1174 VSS.n74 VSS.n356 17.0005
R1175 VSS.n357 VSS.n147 0.0467092
R1176 VSS.n83 VSS.n623 17.0005
R1177 VSS.n83 VSS.t226 17.0005
R1178 VSS.n83 VSS.n151 5.64823
R1179 VSS.n84 VSS.n375 17.0005
R1180 VSS.n155 VSS.n115 0.00102989
R1181 VSS.n155 VSS.n382 17.0005
R1182 VSS.n383 VSS.n157 0.0467092
R1183 VSS.n77 VSS.n584 17.0005
R1184 VSS.n77 VSS.t241 17.0005
R1185 VSS.n77 VSS.n161 5.64823
R1186 VSS.n78 VSS.n401 17.0005
R1187 VSS.n165 VSS.n116 0.00102989
R1188 VSS.n165 VSS.n408 17.0005
R1189 VSS.n409 VSS.n167 0.0467092
R1190 VSS.n0 VSS.n545 17.0005
R1191 VSS.n0 VSS.t256 17.0005
R1192 VSS.n54 VSS.t302 15.9856
R1193 VSS.t279 VSS.n4 173.107
R1194 VSS.n503 VSS.t148 9.11631
R1195 VSS.n468 VSS.n467 9.11631
R1196 VSS.n532 VSS.n487 9.0005
R1197 VSS.n531 VSS.n530 9.0005
R1198 VSS.n529 VSS.n488 9.0005
R1199 VSS.n527 VSS.n526 9.0005
R1200 VSS.n525 VSS.n490 9.0005
R1201 VSS.n524 VSS.n523 9.0005
R1202 VSS.n521 VSS.n492 9.0005
R1203 VSS.n519 VSS.n518 9.0005
R1204 VSS.n517 VSS.n494 9.0005
R1205 VSS.n516 VSS.n515 9.0005
R1206 VSS.n514 VSS.n495 9.0005
R1207 VSS.n512 VSS.n511 9.0005
R1208 VSS.n510 VSS.n497 9.0005
R1209 VSS.n509 VSS.n508 9.0005
R1210 VSS.n507 VSS.n499 9.0005
R1211 VSS.n505 VSS.n504 9.0005
R1212 VSS.n486 VSS.n487 9.0005
R1213 VSS.n529 VSS.n528 9.0005
R1214 VSS.n490 VSS.n489 9.0005
R1215 VSS.n521 VSS.n520 9.0005
R1216 VSS.n494 VSS.n493 9.0005
R1217 VSS.n514 VSS.n513 9.0005
R1218 VSS.n497 VSS.n496 9.0005
R1219 VSS.n507 VSS.n506 9.0005
R1220 VSS.n501 VSS.n500 9.0005
R1221 VSS.n505 VSS.n502 9.0005
R1222 VSS.n508 VSS.t280 9.0005
R1223 VSS.n512 VSS.n498 9.0005
R1224 VSS.n515 VSS.t271 9.0005
R1225 VSS.n519 VSS.t268 9.0005
R1226 VSS.n523 VSS.n522 9.0005
R1227 VSS.n527 VSS.n491 9.0005
R1228 VSS.n530 VSS.n470 9.0005
R1229 VSS.n433 VSS.n432 9.0005
R1230 VSS.n465 VSS.n464 9.0005
R1231 VSS.n463 VSS.n462 9.0005
R1232 VSS.n461 VSS.n460 9.0005
R1233 VSS.n459 VSS.n458 9.0005
R1234 VSS.n457 VSS.n456 9.0005
R1235 VSS.n455 VSS.t276 9.0005
R1236 VSS.n454 VSS.n453 9.0005
R1237 VSS.n452 VSS.n451 9.0005
R1238 VSS.n450 VSS.n449 9.0005
R1239 VSS.n448 VSS.t263 9.0005
R1240 VSS.n447 VSS.n446 9.0005
R1241 VSS.n445 VSS.t260 9.0005
R1242 VSS.n536 VSS.n417 9.0005
R1243 VSS.n537 VSS.t261 9.0005
R1244 VSS.n852 VSS.n851 9.0005
R1245 VSS.n172 VSS.n171 9.0005
R1246 VSS.n849 VSS.n848 9.0005
R1247 VSS.n847 VSS.n209 9.0005
R1248 VSS.n846 VSS.n845 9.0005
R1249 VSS.n843 VSS.n210 9.0005
R1250 VSS.n841 VSS.n840 9.0005
R1251 VSS.n839 VSS.n211 9.0005
R1252 VSS.n838 VSS.n837 9.0005
R1253 VSS.n835 VSS.n213 9.0005
R1254 VSS.n834 VSS.n833 9.0005
R1255 VSS.n832 VSS.n215 9.0005
R1256 VSS.n831 VSS.n830 9.0005
R1257 VSS.n828 VSS.n217 9.0005
R1258 VSS.n827 VSS.n826 9.0005
R1259 VSS.n825 VSS.n219 9.0005
R1260 VSS.n824 VSS.n823 9.0005
R1261 VSS.n821 VSS.n221 9.0005
R1262 VSS.n820 VSS.n819 9.0005
R1263 VSS.n818 VSS.n223 9.0005
R1264 VSS.n817 VSS.n816 9.0005
R1265 VSS.n815 VSS.n224 9.0005
R1266 VSS.n813 VSS.n812 9.0005
R1267 VSS.n811 VSS.n226 9.0005
R1268 VSS.n810 VSS.n809 9.0005
R1269 VSS.n807 VSS.n228 9.0005
R1270 VSS.n805 VSS.n804 9.0005
R1271 VSS.n803 VSS.n230 9.0005
R1272 VSS.n802 VSS.n801 9.0005
R1273 VSS.n799 VSS.n232 9.0005
R1274 VSS.n797 VSS.n796 9.0005
R1275 VSS.n795 VSS.n234 9.0005
R1276 VSS.n794 VSS.n793 9.0005
R1277 VSS.n792 VSS.n236 9.0005
R1278 VSS.n790 VSS.n789 9.0005
R1279 VSS.n788 VSS.n237 9.0005
R1280 VSS.n787 VSS.n786 9.0005
R1281 VSS.n240 VSS.n239 9.0005
R1282 VSS.n784 VSS.n783 9.0005
R1283 VSS.n782 VSS.n244 9.0005
R1284 VSS.n781 VSS.n780 9.0005
R1285 VSS.n246 VSS.n245 9.0005
R1286 VSS.n775 VSS.n774 9.0005
R1287 VSS.n773 VSS.n248 9.0005
R1288 VSS.n772 VSS.n771 9.0005
R1289 VSS.n250 VSS.n249 9.0005
R1290 VSS.n760 VSS.n759 9.0005
R1291 VSS.n761 VSS.n758 9.0005
R1292 VSS.n763 VSS.n762 9.0005
R1293 VSS.n764 VSS.n754 9.0005
R1294 VSS.n766 VSS.n765 9.0005
R1295 VSS.n767 VSS.n263 9.0005
R1296 VSS.n769 VSS.n768 9.0005
R1297 VSS.n753 VSS.n261 9.0005
R1298 VSS.n752 VSS.n751 9.0005
R1299 VSS.n749 VSS.n264 9.0005
R1300 VSS.n744 VSS.n265 9.0005
R1301 VSS.n745 VSS.n270 9.0005
R1302 VSS.n747 VSS.n746 9.0005
R1303 VSS.n743 VSS.n269 9.0005
R1304 VSS.n742 VSS.n741 9.0005
R1305 VSS.n272 VSS.n271 9.0005
R1306 VSS.n736 VSS.n735 9.0005
R1307 VSS.n734 VSS.n274 9.0005
R1308 VSS.n733 VSS.n732 9.0005
R1309 VSS.n276 VSS.n275 9.0005
R1310 VSS.n721 VSS.n720 9.0005
R1311 VSS.n722 VSS.n719 9.0005
R1312 VSS.n724 VSS.n723 9.0005
R1313 VSS.n725 VSS.n715 9.0005
R1314 VSS.n727 VSS.n726 9.0005
R1315 VSS.n728 VSS.n289 9.0005
R1316 VSS.n730 VSS.n729 9.0005
R1317 VSS.n714 VSS.n287 9.0005
R1318 VSS.n713 VSS.n712 9.0005
R1319 VSS.n710 VSS.n290 9.0005
R1320 VSS.n705 VSS.n291 9.0005
R1321 VSS.n706 VSS.n296 9.0005
R1322 VSS.n708 VSS.n707 9.0005
R1323 VSS.n704 VSS.n295 9.0005
R1324 VSS.n703 VSS.n702 9.0005
R1325 VSS.n298 VSS.n297 9.0005
R1326 VSS.n697 VSS.n696 9.0005
R1327 VSS.n695 VSS.n300 9.0005
R1328 VSS.n694 VSS.n693 9.0005
R1329 VSS.n302 VSS.n301 9.0005
R1330 VSS.n682 VSS.n681 9.0005
R1331 VSS.n683 VSS.n680 9.0005
R1332 VSS.n685 VSS.n684 9.0005
R1333 VSS.n686 VSS.n676 9.0005
R1334 VSS.n688 VSS.n687 9.0005
R1335 VSS.n689 VSS.n333 9.0005
R1336 VSS.n691 VSS.n690 9.0005
R1337 VSS.n675 VSS.n331 9.0005
R1338 VSS.n674 VSS.n673 9.0005
R1339 VSS.n671 VSS.n334 9.0005
R1340 VSS.n669 VSS.n668 9.0005
R1341 VSS.n667 VSS.n336 9.0005
R1342 VSS.n666 VSS.n665 9.0005
R1343 VSS.n663 VSS.n338 9.0005
R1344 VSS.n661 VSS.n660 9.0005
R1345 VSS.n659 VSS.n340 9.0005
R1346 VSS.n658 VSS.n657 9.0005
R1347 VSS.n655 VSS.n342 9.0005
R1348 VSS.n653 VSS.n652 9.0005
R1349 VSS.n651 VSS.n344 9.0005
R1350 VSS.n650 VSS.n649 9.0005
R1351 VSS.n648 VSS.n346 9.0005
R1352 VSS.n646 VSS.n645 9.0005
R1353 VSS.n644 VSS.n348 9.0005
R1354 VSS.n643 VSS.n642 9.0005
R1355 VSS.n640 VSS.n350 9.0005
R1356 VSS.n638 VSS.n637 9.0005
R1357 VSS.n636 VSS.n352 9.0005
R1358 VSS.n635 VSS.n634 9.0005
R1359 VSS.n632 VSS.n353 9.0005
R1360 VSS.n627 VSS.n354 9.0005
R1361 VSS.n628 VSS.n359 9.0005
R1362 VSS.n630 VSS.n629 9.0005
R1363 VSS.n626 VSS.n358 9.0005
R1364 VSS.n625 VSS.n624 9.0005
R1365 VSS.n361 VSS.n360 9.0005
R1366 VSS.n619 VSS.n618 9.0005
R1367 VSS.n617 VSS.n363 9.0005
R1368 VSS.n616 VSS.n615 9.0005
R1369 VSS.n365 VSS.n364 9.0005
R1370 VSS.n604 VSS.n603 9.0005
R1371 VSS.n605 VSS.n602 9.0005
R1372 VSS.n607 VSS.n606 9.0005
R1373 VSS.n608 VSS.n598 9.0005
R1374 VSS.n610 VSS.n609 9.0005
R1375 VSS.n611 VSS.n378 9.0005
R1376 VSS.n613 VSS.n612 9.0005
R1377 VSS.n597 VSS.n376 9.0005
R1378 VSS.n596 VSS.n595 9.0005
R1379 VSS.n593 VSS.n379 9.0005
R1380 VSS.n588 VSS.n380 9.0005
R1381 VSS.n589 VSS.n385 9.0005
R1382 VSS.n591 VSS.n590 9.0005
R1383 VSS.n587 VSS.n384 9.0005
R1384 VSS.n586 VSS.n585 9.0005
R1385 VSS.n387 VSS.n386 9.0005
R1386 VSS.n580 VSS.n579 9.0005
R1387 VSS.n578 VSS.n389 9.0005
R1388 VSS.n577 VSS.n576 9.0005
R1389 VSS.n391 VSS.n390 9.0005
R1390 VSS.n565 VSS.n564 9.0005
R1391 VSS.n566 VSS.n563 9.0005
R1392 VSS.n568 VSS.n567 9.0005
R1393 VSS.n569 VSS.n559 9.0005
R1394 VSS.n571 VSS.n570 9.0005
R1395 VSS.n572 VSS.n404 9.0005
R1396 VSS.n574 VSS.n573 9.0005
R1397 VSS.n558 VSS.n402 9.0005
R1398 VSS.n557 VSS.n556 9.0005
R1399 VSS.n554 VSS.n405 9.0005
R1400 VSS.n549 VSS.n406 9.0005
R1401 VSS.n550 VSS.n411 9.0005
R1402 VSS.n552 VSS.n551 9.0005
R1403 VSS.n548 VSS.n410 9.0005
R1404 VSS.n547 VSS.n546 9.0005
R1405 VSS.n413 VSS.n412 9.0005
R1406 VSS.n541 VSS.n540 9.0005
R1407 VSS.n539 VSS.n415 9.0005
R1408 VSS.n538 VSS.n537 9.0005
R1409 VSS.n417 VSS.n416 9.0005
R1410 VSS.n445 VSS.n444 9.0005
R1411 VSS.n447 VSS.n443 9.0005
R1412 VSS.n448 VSS.n442 9.0005
R1413 VSS.n450 VSS.n441 9.0005
R1414 VSS.n452 VSS.n440 9.0005
R1415 VSS.n454 VSS.n439 9.0005
R1416 VSS.n455 VSS.n438 9.0005
R1417 VSS.n457 VSS.n437 9.0005
R1418 VSS.n459 VSS.n436 9.0005
R1419 VSS.n461 VSS.n435 9.0005
R1420 VSS.n463 VSS.n434 9.0005
R1421 VSS.n466 VSS.n465 9.0005
R1422 VSS.n415 VSS.t258 9.0005
R1423 VSS.n542 VSS.n541 9.0005
R1424 VSS.n414 VSS.n413 9.0005
R1425 VSS.n546 VSS.t255 9.0005
R1426 VSS.n410 VSS.n409 9.0005
R1427 VSS.t253 VSS.n552 9.0005
R1428 VSS.n411 VSS.t251 9.0005
R1429 VSS.n553 VSS.n406 9.0005
R1430 VSS.n554 VSS.t250 9.0005
R1431 VSS.n556 VSS.n555 9.0005
R1432 VSS.n402 VSS.n400 9.0005
R1433 VSS.t89 VSS.n574 9.0005
R1434 VSS.n404 VSS.n403 9.0005
R1435 VSS.n570 VSS.n560 9.0005
R1436 VSS.n569 VSS.n561 9.0005
R1437 VSS.n568 VSS.t248 9.0005
R1438 VSS.n563 VSS.n562 9.0005
R1439 VSS.n564 VSS.t246 9.0005
R1440 VSS.n575 VSS.n391 9.0005
R1441 VSS.n576 VSS.t245 9.0005
R1442 VSS.n389 VSS.t243 9.0005
R1443 VSS.n581 VSS.n580 9.0005
R1444 VSS.n388 VSS.n387 9.0005
R1445 VSS.n585 VSS.t240 9.0005
R1446 VSS.n384 VSS.n383 9.0005
R1447 VSS.t238 VSS.n591 9.0005
R1448 VSS.n385 VSS.t236 9.0005
R1449 VSS.n592 VSS.n380 9.0005
R1450 VSS.n593 VSS.t235 9.0005
R1451 VSS.n595 VSS.n594 9.0005
R1452 VSS.n376 VSS.n374 9.0005
R1453 VSS.t42 VSS.n613 9.0005
R1454 VSS.n378 VSS.n377 9.0005
R1455 VSS.n609 VSS.n599 9.0005
R1456 VSS.n608 VSS.n600 9.0005
R1457 VSS.n607 VSS.t233 9.0005
R1458 VSS.n602 VSS.n601 9.0005
R1459 VSS.n603 VSS.t231 9.0005
R1460 VSS.n614 VSS.n365 9.0005
R1461 VSS.n615 VSS.t230 9.0005
R1462 VSS.n363 VSS.t228 9.0005
R1463 VSS.n620 VSS.n619 9.0005
R1464 VSS.n362 VSS.n361 9.0005
R1465 VSS.n624 VSS.t225 9.0005
R1466 VSS.n358 VSS.n357 9.0005
R1467 VSS.t223 VSS.n630 9.0005
R1468 VSS.n359 VSS.t221 9.0005
R1469 VSS.n631 VSS.n354 9.0005
R1470 VSS.n632 VSS.t220 9.0005
R1471 VSS.n634 VSS.n633 9.0005
R1472 VSS.n352 VSS.n351 9.0005
R1473 VSS.n638 VSS.t159 9.0005
R1474 VSS.n640 VSS.n639 9.0005
R1475 VSS.n642 VSS.n641 9.0005
R1476 VSS.n348 VSS.n347 9.0005
R1477 VSS.n646 VSS.n349 9.0005
R1478 VSS.n648 VSS.n647 9.0005
R1479 VSS.n649 VSS.t145 9.0005
R1480 VSS.n344 VSS.n343 9.0005
R1481 VSS.n653 VSS.n345 9.0005
R1482 VSS.n655 VSS.n654 9.0005
R1483 VSS.n657 VSS.n656 9.0005
R1484 VSS.n340 VSS.n339 9.0005
R1485 VSS.n661 VSS.n341 9.0005
R1486 VSS.n663 VSS.n662 9.0005
R1487 VSS.n665 VSS.n664 9.0005
R1488 VSS.n336 VSS.n335 9.0005
R1489 VSS.n669 VSS.n337 9.0005
R1490 VSS.n671 VSS.n670 9.0005
R1491 VSS.n673 VSS.n672 9.0005
R1492 VSS.n331 VSS.n329 9.0005
R1493 VSS.t155 VSS.n691 9.0005
R1494 VSS.n333 VSS.n332 9.0005
R1495 VSS.n687 VSS.n677 9.0005
R1496 VSS.n686 VSS.n678 9.0005
R1497 VSS.n685 VSS.t218 9.0005
R1498 VSS.n680 VSS.n679 9.0005
R1499 VSS.n681 VSS.t216 9.0005
R1500 VSS.n692 VSS.n302 9.0005
R1501 VSS.n693 VSS.t215 9.0005
R1502 VSS.n300 VSS.t213 9.0005
R1503 VSS.n698 VSS.n697 9.0005
R1504 VSS.n299 VSS.n298 9.0005
R1505 VSS.n702 VSS.t210 9.0005
R1506 VSS.n295 VSS.n294 9.0005
R1507 VSS.t208 VSS.n708 9.0005
R1508 VSS.n296 VSS.t206 9.0005
R1509 VSS.n709 VSS.n291 9.0005
R1510 VSS.n710 VSS.t205 9.0005
R1511 VSS.n712 VSS.n711 9.0005
R1512 VSS.n287 VSS.n285 9.0005
R1513 VSS.t83 VSS.n730 9.0005
R1514 VSS.n289 VSS.n288 9.0005
R1515 VSS.n726 VSS.n716 9.0005
R1516 VSS.n725 VSS.n717 9.0005
R1517 VSS.n724 VSS.t203 9.0005
R1518 VSS.n719 VSS.n718 9.0005
R1519 VSS.n720 VSS.t201 9.0005
R1520 VSS.n731 VSS.n276 9.0005
R1521 VSS.n732 VSS.t200 9.0005
R1522 VSS.n274 VSS.t198 9.0005
R1523 VSS.n737 VSS.n736 9.0005
R1524 VSS.n273 VSS.n272 9.0005
R1525 VSS.n741 VSS.t195 9.0005
R1526 VSS.n269 VSS.n268 9.0005
R1527 VSS.t193 VSS.n747 9.0005
R1528 VSS.n270 VSS.t191 9.0005
R1529 VSS.n748 VSS.n265 9.0005
R1530 VSS.n749 VSS.t190 9.0005
R1531 VSS.n751 VSS.n750 9.0005
R1532 VSS.n261 VSS.n259 9.0005
R1533 VSS.t127 VSS.n769 9.0005
R1534 VSS.n263 VSS.n262 9.0005
R1535 VSS.n765 VSS.n755 9.0005
R1536 VSS.n764 VSS.n756 9.0005
R1537 VSS.n763 VSS.t188 9.0005
R1538 VSS.n758 VSS.n757 9.0005
R1539 VSS.n759 VSS.t186 9.0005
R1540 VSS.n770 VSS.n250 9.0005
R1541 VSS.n771 VSS.t185 9.0005
R1542 VSS.n248 VSS.t183 9.0005
R1543 VSS.n776 VSS.n775 9.0005
R1544 VSS.n247 VSS.n246 9.0005
R1545 VSS.n780 VSS.t180 9.0005
R1546 VSS.n244 VSS.n243 9.0005
R1547 VSS.t178 VSS.n784 9.0005
R1548 VSS.t176 VSS.n240 9.0005
R1549 VSS.n786 VSS.n785 9.0005
R1550 VSS.t175 VSS.n237 9.0005
R1551 VSS.n790 VSS.n238 9.0005
R1552 VSS.n792 VSS.n791 9.0005
R1553 VSS.n793 VSS.t5 9.0005
R1554 VSS.n234 VSS.n233 9.0005
R1555 VSS.n797 VSS.n235 9.0005
R1556 VSS.n799 VSS.n798 9.0005
R1557 VSS.n801 VSS.n800 9.0005
R1558 VSS.n230 VSS.n229 9.0005
R1559 VSS.n805 VSS.n231 9.0005
R1560 VSS.n807 VSS.n806 9.0005
R1561 VSS.n809 VSS.n808 9.0005
R1562 VSS.n226 VSS.n225 9.0005
R1563 VSS.n813 VSS.n227 9.0005
R1564 VSS.n815 VSS.n814 9.0005
R1565 VSS.n816 VSS.t77 9.0005
R1566 VSS.n223 VSS.n222 9.0005
R1567 VSS.n820 VSS.t108 9.0005
R1568 VSS.n821 VSS.t106 9.0005
R1569 VSS.n823 VSS.n822 9.0005
R1570 VSS.n219 VSS.n218 9.0005
R1571 VSS.n827 VSS.n220 9.0005
R1572 VSS.n828 VSS.t100 9.0005
R1573 VSS.n830 VSS.n829 9.0005
R1574 VSS.n215 VSS.n214 9.0005
R1575 VSS.n834 VSS.n216 9.0005
R1576 VSS.n835 VSS.t9 9.0005
R1577 VSS.n837 VSS.n836 9.0005
R1578 VSS.n211 VSS.t97 9.0005
R1579 VSS.n841 VSS.n212 9.0005
R1580 VSS.n843 VSS.n842 9.0005
R1581 VSS.n845 VSS.n844 9.0005
R1582 VSS.n209 VSS.n208 9.0005
R1583 VSS.n207 VSS.n849 9.0005
R1584 VSS.n173 VSS.n172 9.0005
R1585 VSS.n851 VSS.n174 9.0005
R1586 VSS.t175 VSS.n118 0.0491025
R1587 VSS.n60 VSS.n119 4.21329
R1588 VSS.n120 VSS.n59 5.65265
R1589 VSS.t185 VSS.n124 0.0304819
R1590 VSS.t190 VSS.n125 0.0491025
R1591 VSS.n128 VSS.n129 4.21329
R1592 VSS.n130 VSS.n126 5.65265
R1593 VSS.n134 VSS.n89 5.64823
R1594 VSS.n135 VSS.n90 4.2213
R1595 VSS.n138 VSS.n139 4.21329
R1596 VSS.n140 VSS.n136 5.65265
R1597 VSS.t215 VSS.n144 0.0304819
R1598 VSS.t220 VSS.n145 0.0491025
R1599 VSS.n74 VSS.n146 4.21329
R1600 VSS.n147 VSS.n73 5.65265
R1601 VSS.t230 VSS.n151 0.0304819
R1602 VSS.n152 VSS.n84 4.2213
R1603 VSS.n155 VSS.n156 4.21329
R1604 VSS.n157 VSS.n153 5.65265
R1605 VSS.t245 VSS.n161 0.0304819
R1606 VSS.n162 VSS.n78 4.2213
R1607 VSS.n165 VSS.n166 4.21329
R1608 VSS.n167 VSS.n163 5.65265
R1609 VSS.n169 VSS.n0 5.64823
R1610 VSS.n0 VSS.n421 8.49444
R1611 VSS.n94 VSS.n253 8.49444
R1612 VSS.n90 VSS.n279 8.49444
R1613 VSS.n72 VSS.n305 8.49444
R1614 VSS.n84 VSS.n368 8.49444
R1615 VSS.n78 VSS.n394 8.49444
R1616 VSS.n22 VSS.t164 8.47732
R1617 VSS.n22 VSS.n485 8.47732
R1618 VSS.n22 VSS.n483 8.47732
R1619 VSS.n22 VSS.n482 8.47732
R1620 VSS.n22 VSS.t317 8.47732
R1621 VSS.n22 VSS.n480 8.47732
R1622 VSS.n22 VSS.n473 8.47732
R1623 VSS.n22 VSS.n477 8.47732
R1624 VSS.n22 VSS.n476 8.47732
R1625 VSS.n0 VSS.n535 8.47732
R1626 VSS.n0 VSS.n420 8.47732
R1627 VSS.n0 VSS.n423 8.47732
R1628 VSS.n0 VSS.n424 8.47732
R1629 VSS.n0 VSS.n425 8.47732
R1630 VSS.n0 VSS.n426 8.47732
R1631 VSS.n0 VSS.n427 8.47732
R1632 VSS.n0 VSS.n428 8.47732
R1633 VSS.n0 VSS.n429 8.47732
R1634 VSS.n0 VSS.n430 8.47732
R1635 VSS.n60 VSS.t297 8.47732
R1636 VSS.n60 VSS.n206 8.47732
R1637 VSS.n60 VSS.n204 8.47732
R1638 VSS.n60 VSS.n203 8.47732
R1639 VSS.n60 VSS.t61 8.47732
R1640 VSS.n60 VSS.n200 8.47732
R1641 VSS.n60 VSS.n177 8.47732
R1642 VSS.n60 VSS.n197 8.47732
R1643 VSS.n60 VSS.n195 8.47732
R1644 VSS.n60 VSS.n193 8.47732
R1645 VSS.n60 VSS.n192 8.47732
R1646 VSS.n60 VSS.n191 8.47732
R1647 VSS.n60 VSS.n190 8.47732
R1648 VSS.n60 VSS.n189 8.47732
R1649 VSS.n60 VSS.n188 8.47732
R1650 VSS.n60 VSS.n187 8.47732
R1651 VSS.n60 VSS.n186 8.47732
R1652 VSS.n60 VSS.n185 8.47732
R1653 VSS.n60 VSS.n184 8.47732
R1654 VSS.n60 VSS.n183 8.47732
R1655 VSS.n60 VSS.n182 8.47732
R1656 VSS.n60 VSS.n180 8.47732
R1657 VSS.n60 VSS.n118 4.2213
R1658 VSS.n241 VSS.n60 8.47732
R1659 VSS.n119 VSS.t176 0.11285
R1660 VSS.n93 VSS.n122 8.47732
R1661 VSS.n252 VSS.n94 8.47732
R1662 VSS.n94 VSS.n251 8.47732
R1663 VSS.n94 VSS.n254 8.47732
R1664 VSS.n94 VSS.n255 8.47732
R1665 VSS.n94 VSS.n256 8.47732
R1666 VSS.n94 VSS.n258 8.47732
R1667 VSS.n94 VSS.n125 4.2213
R1668 VSS.n266 VSS.n128 8.47732
R1669 VSS.n129 VSS.t191 0.11285
R1670 VSS.n89 VSS.n132 8.47732
R1671 VSS.n278 VSS.n90 8.47732
R1672 VSS.n90 VSS.n277 8.47732
R1673 VSS.n90 VSS.n280 8.47732
R1674 VSS.n90 VSS.n281 8.47732
R1675 VSS.n90 VSS.n282 8.47732
R1676 VSS.n90 VSS.n284 8.47732
R1677 VSS.n135 VSS.n711 0.0968361
R1678 VSS.n292 VSS.n138 8.47732
R1679 VSS.n139 VSS.t206 0.11285
R1680 VSS.n100 VSS.n142 8.47732
R1681 VSS.n304 VSS.n72 8.47732
R1682 VSS.n72 VSS.n303 8.47732
R1683 VSS.n72 VSS.n306 8.47732
R1684 VSS.n72 VSS.n307 8.47732
R1685 VSS.n72 VSS.n308 8.47732
R1686 VSS.n72 VSS.n310 8.47732
R1687 VSS.n72 VSS.n311 8.47732
R1688 VSS.n72 VSS.n312 8.47732
R1689 VSS.n72 VSS.n313 8.47732
R1690 VSS.n72 VSS.n314 8.47732
R1691 VSS.n72 VSS.n315 8.47732
R1692 VSS.n72 VSS.n317 8.47732
R1693 VSS.n72 VSS.n318 8.47732
R1694 VSS.n72 VSS.n320 8.47732
R1695 VSS.n72 VSS.n321 8.47732
R1696 VSS.n72 VSS.n322 8.47732
R1697 VSS.n72 VSS.n323 8.47732
R1698 VSS.n72 VSS.n324 8.47732
R1699 VSS.n72 VSS.n325 8.47732
R1700 VSS.n72 VSS.n327 8.47732
R1701 VSS.n72 VSS.n145 4.2213
R1702 VSS.n355 VSS.n74 8.47732
R1703 VSS.n146 VSS.t221 0.11285
R1704 VSS.n83 VSS.n149 8.47732
R1705 VSS.n367 VSS.n84 8.47732
R1706 VSS.n84 VSS.n366 8.47732
R1707 VSS.n84 VSS.n369 8.47732
R1708 VSS.n84 VSS.n370 8.47732
R1709 VSS.n84 VSS.n371 8.47732
R1710 VSS.n84 VSS.n373 8.47732
R1711 VSS.n152 VSS.n594 0.0968361
R1712 VSS.n381 VSS.n155 8.47732
R1713 VSS.n156 VSS.t236 0.11285
R1714 VSS.n77 VSS.n159 8.47732
R1715 VSS.n393 VSS.n78 8.47732
R1716 VSS.n78 VSS.n392 8.47732
R1717 VSS.n78 VSS.n395 8.47732
R1718 VSS.n78 VSS.n396 8.47732
R1719 VSS.n78 VSS.n397 8.47732
R1720 VSS.n78 VSS.n399 8.47732
R1721 VSS.n162 VSS.n555 0.0968361
R1722 VSS.n407 VSS.n165 8.47732
R1723 VSS.n166 VSS.t251 0.11285
R1724 VSS.n0 VSS.n168 8.47732
R1725 VSS.n419 VSS.n0 8.47732
R1726 VSS.n0 VSS.n418 8.47732
R1727 VSS.n93 VSS.n777 5.64536
R1728 VSS.n89 VSS.n738 5.64536
R1729 VSS.n100 VSS.n699 5.64536
R1730 VSS.n83 VSS.n621 5.64536
R1731 VSS.n77 VSS.n582 5.64536
R1732 VSS.n0 VSS.n543 5.64536
R1733 VSS.n22 VSS.n469 5.62581
R1734 VSS.n22 VSS.n484 5.62581
R1735 VSS.n22 VSS.n481 5.62581
R1736 VSS.n22 VSS.n479 5.62581
R1737 VSS.n0 VSS.n422 5.62581
R1738 VSS.n60 VSS.n850 5.62581
R1739 VSS.n60 VSS.n205 5.62581
R1740 VSS.n60 VSS.n202 5.62581
R1741 VSS.n60 VSS.n199 5.62581
R1742 VSS.n60 VSS.n194 5.62581
R1743 VSS.n60 VSS.n181 5.62581
R1744 VSS.n94 VSS.n257 5.62581
R1745 VSS.n90 VSS.n283 5.62581
R1746 VSS.n72 VSS.n309 5.62581
R1747 VSS.n72 VSS.n316 5.62581
R1748 VSS.n72 VSS.n319 5.62581
R1749 VSS.n72 VSS.n326 5.62581
R1750 VSS.n84 VSS.n372 5.62581
R1751 VSS.n78 VSS.n398 5.62581
R1752 VSS.n504 VSS.n503 4.73162
R1753 VSS.n467 VSS.n466 4.73162
R1754 VSS.n486 VSS.n534 3.84369
R1755 VSS.n174 VSS.n170 3.84291
R1756 VSS.n534 VSS.n533 2.93359
R1757 VSS.n853 VSS.n170 2.93359
R1758 VSS.n535 VSS.t114 2.78199
R1759 VSS.n22 VSS.n475 1.24465
R1760 VSS.n853 VSS.n852 1.09146
R1761 VSS.n533 VSS.n532 1.09112
R1762 VSS.t138 VSS.t111 1.05088
R1763 VSS.t27 VSS.t56 1.05088
R1764 VSS.t120 VSS.t294 1.05088
R1765 VSS.t50 VSS.t34 1.05088
R1766 VSS.t37 VSS.t2 1.05088
R1767 VSS.t117 VSS.t31 1.05088
R1768 VSS.t21 VSS.t69 1.05088
R1769 VSS.t80 VSS.t91 1.05088
R1770 VSS.t12 VSS.t135 1.05088
R1771 VSS.t15 VSS.t102 1.05088
R1772 VSS.t53 VSS.t64 1.05088
R1773 VSS.t94 VSS.t39 1.05088
R1774 VSS.t86 VSS.t75 1.05088
R1775 VSS.t47 VSS.t44 1.05088
R1776 VSS.t72 VSS.t18 1.05088
R1777 VSS.t24 VSS.t114 0.999957
R1778 VSS.n22 VSS.t111 0.60071
R1779 VSS.n22 VSS.t56 0.60071
R1780 VSS.n22 VSS.t294 0.60071
R1781 VSS.n22 VSS.t34 0.60071
R1782 VSS.n22 VSS.t2 0.60071
R1783 VSS.n22 VSS.t31 0.60071
R1784 VSS.n22 VSS.t69 0.60071
R1785 VSS.n22 VSS.t91 0.60071
R1786 VSS.n22 VSS.t135 0.60071
R1787 VSS.n22 VSS.t102 0.60071
R1788 VSS.n22 VSS.t64 0.60071
R1789 VSS.n22 VSS.t39 0.60071
R1790 VSS.n22 VSS.t75 0.60071
R1791 VSS.n22 VSS.t44 0.60071
R1792 VSS.n22 VSS.n21 0.481029
R1793 VSS.n22 VSS.n3 0.586403
R1794 VSS.n22 VSS.n4 0.567373
R1795 VSS.n22 VSS.n20 0.552982
R1796 VSS.n22 VSS.n19 0.586403
R1797 VSS.n22 VSS.n18 0.423468
R1798 VSS.n22 VSS.n17 0.382621
R1799 VSS.n108 VSS.t136 136.962
R1800 VSS.n22 VSS.n16 0.382621
R1801 VSS.n70 VSS.t293 136.962
R1802 VSS.n109 VSS.t292 136.962
R1803 VSS.n22 VSS.n15 0.382621
R1804 VSS.n69 VSS.t139 136.962
R1805 VSS.n2 VSS.t29 83.4525
R1806 VSS.n22 VSS.n14 0.423468
R1807 VSS.n22 VSS.n13 0.423468
R1808 VSS.n110 VSS.t90 136.962
R1809 VSS.n66 VSS.t151 136.962
R1810 VSS.n22 VSS.n12 0.382621
R1811 VSS.n22 VSS.n11 0.423468
R1812 VSS.n22 VSS.n10 0.382621
R1813 VSS.n22 VSS.n9 0.423468
R1814 VSS.n22 VSS.n8 0.423468
R1815 VSS.n22 VSS.n7 0.382621
R1816 VSS.n22 VSS.n6 0.423468
R1817 VSS.n111 VSS.t43 136.962
R1818 VSS.n50 VSS.t141 136.962
R1819 VSS.n26 VSS.t22 83.4525
R1820 VSS.n22 VSS.n5 0.423468
R1821 VSS.t111 VSS.t27 0.575991
R1822 VSS.t56 VSS.t120 0.575991
R1823 VSS.t294 VSS.t50 0.575991
R1824 VSS.t34 VSS.t37 0.575991
R1825 VSS.t2 VSS.t117 0.575991
R1826 VSS.t31 VSS.t21 0.575991
R1827 VSS.t69 VSS.t80 0.575991
R1828 VSS.t91 VSS.t12 0.575991
R1829 VSS.t135 VSS.t15 0.575991
R1830 VSS.t102 VSS.t53 0.575991
R1831 VSS.t64 VSS.t94 0.575991
R1832 VSS.t39 VSS.t86 0.575991
R1833 VSS.t75 VSS.t47 0.575991
R1834 VSS.t44 VSS.t72 0.575991
R1835 VSS.n60 VSS.n51 0.261408
R1836 VSS.n60 VSS.n58 0.50872
R1837 VSS.n60 VSS.n52 0.50872
R1838 VSS.n60 VSS.n54 0.50872
R1839 VSS.n60 VSS.n57 0.50872
R1840 VSS.n60 VSS.n56 0.50872
R1841 VSS.n94 VSS.n91 0.50872
R1842 VSS.n90 VSS.n86 0.50872
R1843 VSS.n72 VSS.n96 0.50872
R1844 VSS.n72 VSS.n97 0.456675
R1845 VSS.n84 VSS.n81 0.50872
R1846 VSS.n78 VSS.n76 0.50872
R1847 VSS.t148 VSS.n475 0.492503
R1848 VSS.n534 VSS.n170 0.44402
R1849 VSS.n475 VSS.t138 0.303282
R1850 VSS.t24 VSS.t18 0.282363
R1851 VSS.n532 VSS.n531 0.231121
R1852 VSS.n531 VSS.n488 0.231121
R1853 VSS.n526 VSS.n488 0.231121
R1854 VSS.n526 VSS.n525 0.231121
R1855 VSS.n525 VSS.n524 0.231121
R1856 VSS.n524 VSS.n492 0.231121
R1857 VSS.n518 VSS.n492 0.231121
R1858 VSS.n518 VSS.n517 0.231121
R1859 VSS.n517 VSS.n516 0.231121
R1860 VSS.n516 VSS.n495 0.231121
R1861 VSS.n511 VSS.n495 0.231121
R1862 VSS.n511 VSS.n510 0.231121
R1863 VSS.n510 VSS.n509 0.231121
R1864 VSS.n509 VSS.n499 0.231121
R1865 VSS.n504 VSS.n499 0.231121
R1866 VSS.n851 VSS.n172 0.231121
R1867 VSS.n849 VSS.n172 0.231121
R1868 VSS.n849 VSS.n209 0.231121
R1869 VSS.n845 VSS.n209 0.231121
R1870 VSS.n845 VSS.n843 0.231121
R1871 VSS.n843 VSS.n841 0.231121
R1872 VSS.n841 VSS.n211 0.231121
R1873 VSS.n837 VSS.n211 0.231121
R1874 VSS.n837 VSS.n835 0.231121
R1875 VSS.n835 VSS.n834 0.231121
R1876 VSS.n834 VSS.n215 0.231121
R1877 VSS.n830 VSS.n215 0.231121
R1878 VSS.n830 VSS.n828 0.231121
R1879 VSS.n828 VSS.n827 0.231121
R1880 VSS.n827 VSS.n219 0.231121
R1881 VSS.n823 VSS.n219 0.231121
R1882 VSS.n823 VSS.n821 0.231121
R1883 VSS.n821 VSS.n820 0.231121
R1884 VSS.n820 VSS.n223 0.231121
R1885 VSS.n816 VSS.n223 0.231121
R1886 VSS.n816 VSS.n815 0.231121
R1887 VSS.n815 VSS.n813 0.231121
R1888 VSS.n813 VSS.n226 0.231121
R1889 VSS.n809 VSS.n226 0.231121
R1890 VSS.n809 VSS.n807 0.231121
R1891 VSS.n807 VSS.n805 0.231121
R1892 VSS.n805 VSS.n230 0.231121
R1893 VSS.n801 VSS.n230 0.231121
R1894 VSS.n801 VSS.n799 0.231121
R1895 VSS.n799 VSS.n797 0.231121
R1896 VSS.n797 VSS.n234 0.231121
R1897 VSS.n793 VSS.n234 0.231121
R1898 VSS.n793 VSS.n792 0.231121
R1899 VSS.n792 VSS.n790 0.231121
R1900 VSS.n790 VSS.n237 0.231121
R1901 VSS.n786 VSS.n237 0.231121
R1902 VSS.n786 VSS.n240 0.231121
R1903 VSS.n784 VSS.n240 0.231121
R1904 VSS.n784 VSS.n244 0.231121
R1905 VSS.n780 VSS.n244 0.231121
R1906 VSS.n780 VSS.n246 0.231121
R1907 VSS.n775 VSS.n246 0.231121
R1908 VSS.n775 VSS.n248 0.231121
R1909 VSS.n771 VSS.n248 0.231121
R1910 VSS.n771 VSS.n250 0.231121
R1911 VSS.n759 VSS.n250 0.231121
R1912 VSS.n759 VSS.n758 0.231121
R1913 VSS.n763 VSS.n758 0.231121
R1914 VSS.n764 VSS.n763 0.231121
R1915 VSS.n765 VSS.n764 0.231121
R1916 VSS.n765 VSS.n263 0.231121
R1917 VSS.n769 VSS.n263 0.231121
R1918 VSS.n769 VSS.n261 0.231121
R1919 VSS.n751 VSS.n261 0.231121
R1920 VSS.n751 VSS.n749 0.231121
R1921 VSS.n749 VSS.n265 0.231121
R1922 VSS.n270 VSS.n265 0.231121
R1923 VSS.n747 VSS.n270 0.231121
R1924 VSS.n747 VSS.n269 0.231121
R1925 VSS.n741 VSS.n269 0.231121
R1926 VSS.n741 VSS.n272 0.231121
R1927 VSS.n736 VSS.n272 0.231121
R1928 VSS.n736 VSS.n274 0.231121
R1929 VSS.n732 VSS.n274 0.231121
R1930 VSS.n732 VSS.n276 0.231121
R1931 VSS.n720 VSS.n276 0.231121
R1932 VSS.n720 VSS.n719 0.231121
R1933 VSS.n724 VSS.n719 0.231121
R1934 VSS.n725 VSS.n724 0.231121
R1935 VSS.n726 VSS.n725 0.231121
R1936 VSS.n726 VSS.n289 0.231121
R1937 VSS.n730 VSS.n289 0.231121
R1938 VSS.n730 VSS.n287 0.231121
R1939 VSS.n712 VSS.n287 0.231121
R1940 VSS.n712 VSS.n710 0.231121
R1941 VSS.n710 VSS.n291 0.231121
R1942 VSS.n296 VSS.n291 0.231121
R1943 VSS.n708 VSS.n296 0.231121
R1944 VSS.n708 VSS.n295 0.231121
R1945 VSS.n702 VSS.n295 0.231121
R1946 VSS.n702 VSS.n298 0.231121
R1947 VSS.n697 VSS.n298 0.231121
R1948 VSS.n697 VSS.n300 0.231121
R1949 VSS.n693 VSS.n300 0.231121
R1950 VSS.n693 VSS.n302 0.231121
R1951 VSS.n681 VSS.n302 0.231121
R1952 VSS.n681 VSS.n680 0.231121
R1953 VSS.n685 VSS.n680 0.231121
R1954 VSS.n686 VSS.n685 0.231121
R1955 VSS.n687 VSS.n686 0.231121
R1956 VSS.n687 VSS.n333 0.231121
R1957 VSS.n691 VSS.n333 0.231121
R1958 VSS.n691 VSS.n331 0.231121
R1959 VSS.n673 VSS.n331 0.231121
R1960 VSS.n673 VSS.n671 0.231121
R1961 VSS.n671 VSS.n669 0.231121
R1962 VSS.n669 VSS.n336 0.231121
R1963 VSS.n665 VSS.n336 0.231121
R1964 VSS.n665 VSS.n663 0.231121
R1965 VSS.n663 VSS.n661 0.231121
R1966 VSS.n661 VSS.n340 0.231121
R1967 VSS.n657 VSS.n340 0.231121
R1968 VSS.n657 VSS.n655 0.231121
R1969 VSS.n655 VSS.n653 0.231121
R1970 VSS.n653 VSS.n344 0.231121
R1971 VSS.n649 VSS.n344 0.231121
R1972 VSS.n649 VSS.n648 0.231121
R1973 VSS.n648 VSS.n646 0.231121
R1974 VSS.n646 VSS.n348 0.231121
R1975 VSS.n642 VSS.n348 0.231121
R1976 VSS.n642 VSS.n640 0.231121
R1977 VSS.n640 VSS.n638 0.231121
R1978 VSS.n638 VSS.n352 0.231121
R1979 VSS.n634 VSS.n352 0.231121
R1980 VSS.n634 VSS.n632 0.231121
R1981 VSS.n632 VSS.n354 0.231121
R1982 VSS.n359 VSS.n354 0.231121
R1983 VSS.n630 VSS.n359 0.231121
R1984 VSS.n630 VSS.n358 0.231121
R1985 VSS.n624 VSS.n358 0.231121
R1986 VSS.n624 VSS.n361 0.231121
R1987 VSS.n619 VSS.n361 0.231121
R1988 VSS.n619 VSS.n363 0.231121
R1989 VSS.n615 VSS.n363 0.231121
R1990 VSS.n615 VSS.n365 0.231121
R1991 VSS.n603 VSS.n365 0.231121
R1992 VSS.n603 VSS.n602 0.231121
R1993 VSS.n607 VSS.n602 0.231121
R1994 VSS.n608 VSS.n607 0.231121
R1995 VSS.n609 VSS.n608 0.231121
R1996 VSS.n609 VSS.n378 0.231121
R1997 VSS.n613 VSS.n378 0.231121
R1998 VSS.n613 VSS.n376 0.231121
R1999 VSS.n595 VSS.n376 0.231121
R2000 VSS.n595 VSS.n593 0.231121
R2001 VSS.n593 VSS.n380 0.231121
R2002 VSS.n385 VSS.n380 0.231121
R2003 VSS.n591 VSS.n385 0.231121
R2004 VSS.n591 VSS.n384 0.231121
R2005 VSS.n585 VSS.n384 0.231121
R2006 VSS.n585 VSS.n387 0.231121
R2007 VSS.n580 VSS.n387 0.231121
R2008 VSS.n580 VSS.n389 0.231121
R2009 VSS.n576 VSS.n389 0.231121
R2010 VSS.n576 VSS.n391 0.231121
R2011 VSS.n564 VSS.n391 0.231121
R2012 VSS.n564 VSS.n563 0.231121
R2013 VSS.n568 VSS.n563 0.231121
R2014 VSS.n569 VSS.n568 0.231121
R2015 VSS.n570 VSS.n569 0.231121
R2016 VSS.n570 VSS.n404 0.231121
R2017 VSS.n574 VSS.n404 0.231121
R2018 VSS.n574 VSS.n402 0.231121
R2019 VSS.n556 VSS.n402 0.231121
R2020 VSS.n556 VSS.n554 0.231121
R2021 VSS.n554 VSS.n406 0.231121
R2022 VSS.n411 VSS.n406 0.231121
R2023 VSS.n552 VSS.n411 0.231121
R2024 VSS.n552 VSS.n410 0.231121
R2025 VSS.n546 VSS.n410 0.231121
R2026 VSS.n546 VSS.n413 0.231121
R2027 VSS.n541 VSS.n413 0.231121
R2028 VSS.n541 VSS.n415 0.231121
R2029 VSS.n537 VSS.n415 0.231121
R2030 VSS.n537 VSS.n417 0.231121
R2031 VSS.n445 VSS.n417 0.231121
R2032 VSS.n447 VSS.n445 0.231121
R2033 VSS.n448 VSS.n447 0.231121
R2034 VSS.n450 VSS.n448 0.231121
R2035 VSS.n452 VSS.n450 0.231121
R2036 VSS.n454 VSS.n452 0.231121
R2037 VSS.n455 VSS.n454 0.231121
R2038 VSS.n457 VSS.n455 0.231121
R2039 VSS.n459 VSS.n457 0.231121
R2040 VSS.n461 VSS.n459 0.231121
R2041 VSS.n463 VSS.n461 0.231121
R2042 VSS.n465 VSS.n463 0.231121
R2043 VSS.n465 VSS.n433 0.231121
R2044 VSS.n852 VSS.n171 0.231121
R2045 VSS.n848 VSS.n171 0.231121
R2046 VSS.n848 VSS.n847 0.231121
R2047 VSS.n847 VSS.n846 0.231121
R2048 VSS.n846 VSS.n210 0.231121
R2049 VSS.n840 VSS.n210 0.231121
R2050 VSS.n840 VSS.n839 0.231121
R2051 VSS.n839 VSS.n838 0.231121
R2052 VSS.n838 VSS.n213 0.231121
R2053 VSS.n833 VSS.n213 0.231121
R2054 VSS.n833 VSS.n832 0.231121
R2055 VSS.n832 VSS.n831 0.231121
R2056 VSS.n831 VSS.n217 0.231121
R2057 VSS.n826 VSS.n217 0.231121
R2058 VSS.n826 VSS.n825 0.231121
R2059 VSS.n825 VSS.n824 0.231121
R2060 VSS.n824 VSS.n221 0.231121
R2061 VSS.n819 VSS.n221 0.231121
R2062 VSS.n819 VSS.n818 0.231121
R2063 VSS.n818 VSS.n817 0.231121
R2064 VSS.n817 VSS.n224 0.231121
R2065 VSS.n812 VSS.n224 0.231121
R2066 VSS.n812 VSS.n811 0.231121
R2067 VSS.n811 VSS.n810 0.231121
R2068 VSS.n810 VSS.n228 0.231121
R2069 VSS.n804 VSS.n228 0.231121
R2070 VSS.n804 VSS.n803 0.231121
R2071 VSS.n803 VSS.n802 0.231121
R2072 VSS.n802 VSS.n232 0.231121
R2073 VSS.n796 VSS.n232 0.231121
R2074 VSS.n796 VSS.n795 0.231121
R2075 VSS.n795 VSS.n794 0.231121
R2076 VSS.n794 VSS.n236 0.231121
R2077 VSS.n789 VSS.n236 0.231121
R2078 VSS.n789 VSS.n788 0.231121
R2079 VSS.n788 VSS.n787 0.231121
R2080 VSS.n787 VSS.n239 0.231121
R2081 VSS.n783 VSS.n239 0.231121
R2082 VSS.n783 VSS.n782 0.231121
R2083 VSS.n782 VSS.n781 0.231121
R2084 VSS.n781 VSS.n245 0.231121
R2085 VSS.n774 VSS.n245 0.231121
R2086 VSS.n774 VSS.n773 0.231121
R2087 VSS.n773 VSS.n772 0.231121
R2088 VSS.n772 VSS.n249 0.231121
R2089 VSS.n760 VSS.n249 0.231121
R2090 VSS.n761 VSS.n760 0.231121
R2091 VSS.n762 VSS.n761 0.231121
R2092 VSS.n762 VSS.n754 0.231121
R2093 VSS.n766 VSS.n754 0.231121
R2094 VSS.n767 VSS.n766 0.231121
R2095 VSS.n768 VSS.n767 0.231121
R2096 VSS.n768 VSS.n753 0.231121
R2097 VSS.n753 VSS.n752 0.231121
R2098 VSS.n752 VSS.n264 0.231121
R2099 VSS.n744 VSS.n264 0.231121
R2100 VSS.n745 VSS.n744 0.231121
R2101 VSS.n746 VSS.n745 0.231121
R2102 VSS.n746 VSS.n743 0.231121
R2103 VSS.n743 VSS.n742 0.231121
R2104 VSS.n742 VSS.n271 0.231121
R2105 VSS.n735 VSS.n271 0.231121
R2106 VSS.n735 VSS.n734 0.231121
R2107 VSS.n734 VSS.n733 0.231121
R2108 VSS.n733 VSS.n275 0.231121
R2109 VSS.n721 VSS.n275 0.231121
R2110 VSS.n722 VSS.n721 0.231121
R2111 VSS.n723 VSS.n722 0.231121
R2112 VSS.n723 VSS.n715 0.231121
R2113 VSS.n727 VSS.n715 0.231121
R2114 VSS.n728 VSS.n727 0.231121
R2115 VSS.n729 VSS.n728 0.231121
R2116 VSS.n729 VSS.n714 0.231121
R2117 VSS.n714 VSS.n713 0.231121
R2118 VSS.n713 VSS.n290 0.231121
R2119 VSS.n705 VSS.n290 0.231121
R2120 VSS.n706 VSS.n705 0.231121
R2121 VSS.n707 VSS.n706 0.231121
R2122 VSS.n707 VSS.n704 0.231121
R2123 VSS.n704 VSS.n703 0.231121
R2124 VSS.n703 VSS.n297 0.231121
R2125 VSS.n696 VSS.n297 0.231121
R2126 VSS.n696 VSS.n695 0.231121
R2127 VSS.n695 VSS.n694 0.231121
R2128 VSS.n694 VSS.n301 0.231121
R2129 VSS.n682 VSS.n301 0.231121
R2130 VSS.n683 VSS.n682 0.231121
R2131 VSS.n684 VSS.n683 0.231121
R2132 VSS.n684 VSS.n676 0.231121
R2133 VSS.n688 VSS.n676 0.231121
R2134 VSS.n689 VSS.n688 0.231121
R2135 VSS.n690 VSS.n689 0.231121
R2136 VSS.n690 VSS.n675 0.231121
R2137 VSS.n675 VSS.n674 0.231121
R2138 VSS.n674 VSS.n334 0.231121
R2139 VSS.n668 VSS.n334 0.231121
R2140 VSS.n668 VSS.n667 0.231121
R2141 VSS.n667 VSS.n666 0.231121
R2142 VSS.n666 VSS.n338 0.231121
R2143 VSS.n660 VSS.n338 0.231121
R2144 VSS.n660 VSS.n659 0.231121
R2145 VSS.n659 VSS.n658 0.231121
R2146 VSS.n658 VSS.n342 0.231121
R2147 VSS.n652 VSS.n342 0.231121
R2148 VSS.n652 VSS.n651 0.231121
R2149 VSS.n651 VSS.n650 0.231121
R2150 VSS.n650 VSS.n346 0.231121
R2151 VSS.n645 VSS.n346 0.231121
R2152 VSS.n645 VSS.n644 0.231121
R2153 VSS.n644 VSS.n643 0.231121
R2154 VSS.n643 VSS.n350 0.231121
R2155 VSS.n637 VSS.n350 0.231121
R2156 VSS.n637 VSS.n636 0.231121
R2157 VSS.n636 VSS.n635 0.231121
R2158 VSS.n635 VSS.n353 0.231121
R2159 VSS.n627 VSS.n353 0.231121
R2160 VSS.n628 VSS.n627 0.231121
R2161 VSS.n629 VSS.n628 0.231121
R2162 VSS.n629 VSS.n626 0.231121
R2163 VSS.n626 VSS.n625 0.231121
R2164 VSS.n625 VSS.n360 0.231121
R2165 VSS.n618 VSS.n360 0.231121
R2166 VSS.n618 VSS.n617 0.231121
R2167 VSS.n617 VSS.n616 0.231121
R2168 VSS.n616 VSS.n364 0.231121
R2169 VSS.n604 VSS.n364 0.231121
R2170 VSS.n605 VSS.n604 0.231121
R2171 VSS.n606 VSS.n605 0.231121
R2172 VSS.n606 VSS.n598 0.231121
R2173 VSS.n610 VSS.n598 0.231121
R2174 VSS.n611 VSS.n610 0.231121
R2175 VSS.n612 VSS.n611 0.231121
R2176 VSS.n612 VSS.n597 0.231121
R2177 VSS.n597 VSS.n596 0.231121
R2178 VSS.n596 VSS.n379 0.231121
R2179 VSS.n588 VSS.n379 0.231121
R2180 VSS.n589 VSS.n588 0.231121
R2181 VSS.n590 VSS.n589 0.231121
R2182 VSS.n590 VSS.n587 0.231121
R2183 VSS.n587 VSS.n586 0.231121
R2184 VSS.n586 VSS.n386 0.231121
R2185 VSS.n579 VSS.n386 0.231121
R2186 VSS.n579 VSS.n578 0.231121
R2187 VSS.n578 VSS.n577 0.231121
R2188 VSS.n577 VSS.n390 0.231121
R2189 VSS.n565 VSS.n390 0.231121
R2190 VSS.n566 VSS.n565 0.231121
R2191 VSS.n567 VSS.n566 0.231121
R2192 VSS.n567 VSS.n559 0.231121
R2193 VSS.n571 VSS.n559 0.231121
R2194 VSS.n572 VSS.n571 0.231121
R2195 VSS.n573 VSS.n572 0.231121
R2196 VSS.n573 VSS.n558 0.231121
R2197 VSS.n558 VSS.n557 0.231121
R2198 VSS.n557 VSS.n405 0.231121
R2199 VSS.n549 VSS.n405 0.231121
R2200 VSS.n550 VSS.n549 0.231121
R2201 VSS.n551 VSS.n550 0.231121
R2202 VSS.n551 VSS.n548 0.231121
R2203 VSS.n548 VSS.n547 0.231121
R2204 VSS.n547 VSS.n412 0.231121
R2205 VSS.n540 VSS.n412 0.231121
R2206 VSS.n540 VSS.n539 0.231121
R2207 VSS.n539 VSS.n538 0.231121
R2208 VSS.n538 VSS.n416 0.231121
R2209 VSS.n444 VSS.n416 0.231121
R2210 VSS.n444 VSS.n443 0.231121
R2211 VSS.n443 VSS.n442 0.231121
R2212 VSS.n442 VSS.n441 0.231121
R2213 VSS.n441 VSS.n440 0.231121
R2214 VSS.n440 VSS.n439 0.231121
R2215 VSS.n439 VSS.n438 0.231121
R2216 VSS.n438 VSS.n437 0.231121
R2217 VSS.n437 VSS.n436 0.231121
R2218 VSS.n436 VSS.n435 0.231121
R2219 VSS.n435 VSS.n434 0.231121
R2220 VSS.n466 VSS.n434 0.231121
R2221 VSS.n530 VSS.n487 0.231121
R2222 VSS.n530 VSS.n529 0.231121
R2223 VSS.n529 VSS.n527 0.231121
R2224 VSS.n527 VSS.n490 0.231121
R2225 VSS.n523 VSS.n490 0.231121
R2226 VSS.n523 VSS.n521 0.231121
R2227 VSS.n521 VSS.n519 0.231121
R2228 VSS.n519 VSS.n494 0.231121
R2229 VSS.n515 VSS.n494 0.231121
R2230 VSS.n515 VSS.n514 0.231121
R2231 VSS.n514 VSS.n512 0.231121
R2232 VSS.n512 VSS.n497 0.231121
R2233 VSS.n508 VSS.n497 0.231121
R2234 VSS.n508 VSS.n507 0.231121
R2235 VSS.n507 VSS.n505 0.231121
R2236 VSS.n505 VSS.n501 0.231121
R2237 VSS.n533 VSS 0.226636
R2238 VSS VSS.n853 0.226288
R2239 VSS.n489 VSS.n485 0.143368
R2240 VSS.n493 VSS.n482 0.143368
R2241 VSS.n496 VSS.n480 0.143368
R2242 VSS.n500 VSS.n477 0.143368
R2243 VSS.n449 VSS.n420 0.143368
R2244 VSS.n451 VSS.n423 0.143368
R2245 VSS.n453 VSS.n424 0.143368
R2246 VSS.n456 VSS.n426 0.143368
R2247 VSS.n458 VSS.n427 0.143368
R2248 VSS.n460 VSS.n428 0.143368
R2249 VSS.n462 VSS.n429 0.143368
R2250 VSS.n464 VSS.n430 0.143368
R2251 VSS.n446 VSS.n418 0.143368
R2252 VSS.n844 VSS.n206 0.143368
R2253 VSS.n836 VSS.n203 0.143368
R2254 VSS.n829 VSS.n200 0.143368
R2255 VSS.n822 VSS.n197 0.143368
R2256 VSS.n814 VSS.n192 0.143368
R2257 VSS.n227 VSS.n191 0.143368
R2258 VSS.n225 VSS.n190 0.143368
R2259 VSS.n808 VSS.n189 0.143368
R2260 VSS.n806 VSS.n188 0.143368
R2261 VSS.n231 VSS.n187 0.143368
R2262 VSS.n229 VSS.n186 0.143368
R2263 VSS.n800 VSS.n185 0.143368
R2264 VSS.n798 VSS.n184 0.143368
R2265 VSS.n235 VSS.n183 0.143368
R2266 VSS.n233 VSS.n182 0.143368
R2267 VSS.n238 VSS.n180 0.143368
R2268 VSS.n757 VSS.n251 0.143368
R2269 VSS.n756 VSS.n254 0.143368
R2270 VSS.n755 VSS.n255 0.143368
R2271 VSS.n262 VSS.n256 0.143368
R2272 VSS.n750 VSS.n258 0.143368
R2273 VSS.n718 VSS.n277 0.143368
R2274 VSS.n717 VSS.n280 0.143368
R2275 VSS.n716 VSS.n281 0.143368
R2276 VSS.n288 VSS.n282 0.143368
R2277 VSS.n711 VSS.n284 0.143368
R2278 VSS.n679 VSS.n303 0.143368
R2279 VSS.n678 VSS.n306 0.143368
R2280 VSS.n677 VSS.n307 0.143368
R2281 VSS.n332 VSS.n308 0.143368
R2282 VSS.n672 VSS.n310 0.143368
R2283 VSS.n670 VSS.n311 0.143368
R2284 VSS.n337 VSS.n312 0.143368
R2285 VSS.n335 VSS.n313 0.143368
R2286 VSS.n664 VSS.n314 0.143368
R2287 VSS.n662 VSS.n315 0.143368
R2288 VSS.n656 VSS.n317 0.143368
R2289 VSS.n654 VSS.n318 0.143368
R2290 VSS.n647 VSS.n321 0.143368
R2291 VSS.n349 VSS.n322 0.143368
R2292 VSS.n347 VSS.n323 0.143368
R2293 VSS.n641 VSS.n324 0.143368
R2294 VSS.n639 VSS.n325 0.143368
R2295 VSS.n633 VSS.n327 0.143368
R2296 VSS.n601 VSS.n366 0.143368
R2297 VSS.n600 VSS.n369 0.143368
R2298 VSS.n599 VSS.n370 0.143368
R2299 VSS.n377 VSS.n371 0.143368
R2300 VSS.n594 VSS.n373 0.143368
R2301 VSS.n562 VSS.n392 0.143368
R2302 VSS.n561 VSS.n395 0.143368
R2303 VSS.n560 VSS.n396 0.143368
R2304 VSS.n403 VSS.n397 0.143368
R2305 VSS.n555 VSS.n399 0.143368
R2306 VSS.t100 VSS.n177 0.143368
R2307 VSS.t106 VSS.n195 0.143368
R2308 VSS.t77 VSS.n193 0.143368
R2309 VSS.t145 VSS.n320 0.143368
R2310 VSS.t280 VSS.n473 0.143368
R2311 VSS.t148 VSS.n476 0.143368
R2312 VSS.n498 VSS.t317 0.143368
R2313 VSS.t268 VSS.n483 0.143368
R2314 VSS.n470 VSS.t164 0.143368
R2315 VSS.t276 VSS.n425 0.143368
R2316 VSS.t260 VSS.n419 0.143368
R2317 VSS.t251 VSS.n407 0.143368
R2318 VSS.t246 VSS.n393 0.143368
R2319 VSS.t236 VSS.n381 0.143368
R2320 VSS.t231 VSS.n367 0.143368
R2321 VSS.t221 VSS.n355 0.143368
R2322 VSS.t216 VSS.n304 0.143368
R2323 VSS.t206 VSS.n292 0.143368
R2324 VSS.t201 VSS.n278 0.143368
R2325 VSS.t191 VSS.n266 0.143368
R2326 VSS.t186 VSS.n252 0.143368
R2327 VSS.t176 VSS.n241 0.143368
R2328 VSS.n214 VSS.t61 0.143368
R2329 VSS.t97 VSS.n204 0.143368
R2330 VSS.n173 VSS.t297 0.143368
R2331 VSS.t178 VSS.n119 0.0651609
R2332 VSS.t193 VSS.n129 0.0651609
R2333 VSS.t208 VSS.n139 0.0651609
R2334 VSS.t223 VSS.n146 0.0651609
R2335 VSS.t238 VSS.n156 0.0651609
R2336 VSS.t253 VSS.n166 0.0651609
R2337 VSS.n503 VSS.n501 0.113429
R2338 VSS.n467 VSS.n433 0.113429
R2339 VSS.t180 VSS.n122 0.105868
R2340 VSS.t195 VSS.n132 0.105868
R2341 VSS.t210 VSS.n142 0.105868
R2342 VSS.t225 VSS.n149 0.105868
R2343 VSS.t240 VSS.n159 0.105868
R2344 VSS.t255 VSS.n168 0.105868
R2345 VSS.n118 VSS.n238 0.0968361
R2346 VSS.n125 VSS.n750 0.0968361
R2347 VSS.t205 VSS.n135 0.0491025
R2348 VSS.n145 VSS.n633 0.0968361
R2349 VSS.t235 VSS.n152 0.0491025
R2350 VSS.t250 VSS.n162 0.0491025
R2351 VSS.n528 VSS.n469 0.0961384
R2352 VSS.n522 VSS.n484 0.0961384
R2353 VSS.t271 VSS.n481 0.0961384
R2354 VSS.t280 VSS.n479 0.0961384
R2355 VSS.n451 VSS.n422 0.0961384
R2356 VSS.n850 VSS.n207 0.0961384
R2357 VSS.n842 VSS.n205 0.0961384
R2358 VSS.t9 VSS.n202 0.0961384
R2359 VSS.t100 VSS.n199 0.0961384
R2360 VSS.t108 VSS.n194 0.0961384
R2361 VSS.t5 VSS.n181 0.0961384
R2362 VSS.t127 VSS.n257 0.0961384
R2363 VSS.t83 VSS.n283 0.0961384
R2364 VSS.t155 VSS.n309 0.0961384
R2365 VSS.n341 VSS.n316 0.0961384
R2366 VSS.n345 VSS.n319 0.0961384
R2367 VSS.t159 VSS.n326 0.0961384
R2368 VSS.t42 VSS.n372 0.0961384
R2369 VSS.t89 VSS.n398 0.0961384
R2370 VSS.n470 VSS.n469 0.0958002
R2371 VSS.n489 VSS.n484 0.0958002
R2372 VSS.n493 VSS.n481 0.0958002
R2373 VSS.n496 VSS.n479 0.0958002
R2374 VSS.n449 VSS.n422 0.0958002
R2375 VSS.n850 VSS.n173 0.0958002
R2376 VSS.n844 VSS.n205 0.0958002
R2377 VSS.n836 VSS.n202 0.0958002
R2378 VSS.n829 VSS.n199 0.0958002
R2379 VSS.t106 VSS.n194 0.0958002
R2380 VSS.n233 VSS.n181 0.0958002
R2381 VSS.n262 VSS.n257 0.0958002
R2382 VSS.n288 VSS.n283 0.0958002
R2383 VSS.n332 VSS.n309 0.0958002
R2384 VSS.n662 VSS.n316 0.0958002
R2385 VSS.n654 VSS.n319 0.0958002
R2386 VSS.n639 VSS.n326 0.0958002
R2387 VSS.n377 VSS.n372 0.0958002
R2388 VSS.n403 VSS.n398 0.0958002
R2389 VSS.n491 VSS.t169 0.0955
R2390 VSS.n520 VSS.t266 0.0955
R2391 VSS.n513 VSS.n472 0.0955
R2392 VSS.n502 VSS.t288 0.0955
R2393 VSS.n432 VSS.n431 0.0955
R2394 VSS.n468 VSS.n431 0.0955
R2395 VSS.n208 VSS.t301 0.0955
R2396 VSS.n212 VSS.t7 0.0955
R2397 VSS.n216 VSS.n176 0.0955
R2398 VSS.n218 VSS.t308 0.0955
R2399 VSS.n222 VSS.n178 0.0955
R2400 VSS.n791 VSS.n179 0.0955
R2401 VSS.n776 VSS.t181 0.0955
R2402 VSS.n260 VSS.n259 0.0955
R2403 VSS.n737 VSS.t196 0.0955
R2404 VSS.n286 VSS.n285 0.0955
R2405 VSS.n698 VSS.t211 0.0955
R2406 VSS.n330 VSS.n329 0.0955
R2407 VSS.n339 VSS.t312 0.0955
R2408 VSS.n343 VSS.t143 0.0955
R2409 VSS.n351 VSS.n328 0.0955
R2410 VSS.n620 VSS.t226 0.0955
R2411 VSS.n375 VSS.n374 0.0955
R2412 VSS.n581 VSS.t241 0.0955
R2413 VSS.n401 VSS.n400 0.0955
R2414 VSS.n542 VSS.t256 0.0955
R2415 VSS.n842 VSS.t7 0.0955
R2416 VSS.t9 VSS.n176 0.0955
R2417 VSS.t5 VSS.n179 0.0955
R2418 VSS.n260 VSS.t127 0.0955
R2419 VSS.n286 VSS.t83 0.0955
R2420 VSS.n330 VSS.t155 0.0955
R2421 VSS.n375 VSS.t42 0.0955
R2422 VSS.n401 VSS.t89 0.0955
R2423 VSS.n528 VSS.t169 0.0955
R2424 VSS.n522 VSS.t266 0.0955
R2425 VSS.t271 VSS.n472 0.0955
R2426 VSS.n506 VSS.t288 0.0955
R2427 VSS.t256 VSS.n414 0.0955
R2428 VSS.t241 VSS.n388 0.0955
R2429 VSS.t226 VSS.n362 0.0955
R2430 VSS.t159 VSS.n328 0.0955
R2431 VSS.n345 VSS.t143 0.0955
R2432 VSS.n341 VSS.t312 0.0955
R2433 VSS.t211 VSS.n299 0.0955
R2434 VSS.t196 VSS.n273 0.0955
R2435 VSS.t181 VSS.n247 0.0955
R2436 VSS.t108 VSS.n178 0.0955
R2437 VSS.n220 VSS.t308 0.0955
R2438 VSS.n207 VSS.t301 0.0955
R2439 VSS.n124 VSS.t183 0.0912103
R2440 VSS.t200 VSS.n134 0.0304819
R2441 VSS.n144 VSS.t213 0.0912103
R2442 VSS.n151 VSS.t228 0.0912103
R2443 VSS.n161 VSS.t243 0.0912103
R2444 VSS.t261 VSS.n169 0.0304819
R2445 VSS.n785 VSS.t175 0.078
R2446 VSS.t190 VSS.n748 0.078
R2447 VSS.t205 VSS.n709 0.078
R2448 VSS.t220 VSS.n631 0.078
R2449 VSS.t235 VSS.n592 0.078
R2450 VSS.t250 VSS.n553 0.078
R2451 VSS.t180 VSS.n120 0.0238559
R2452 VSS.t195 VSS.n130 0.0238559
R2453 VSS.t210 VSS.n140 0.0238559
R2454 VSS.t225 VSS.n147 0.0238559
R2455 VSS.t240 VSS.n157 0.0238559
R2456 VSS.t255 VSS.n167 0.0238559
R2457 VSS.n777 VSS.n776 0.066499
R2458 VSS.n738 VSS.n737 0.066499
R2459 VSS.n699 VSS.n698 0.066499
R2460 VSS.n621 VSS.n620 0.066499
R2461 VSS.n582 VSS.n581 0.066499
R2462 VSS.n543 VSS.n542 0.066499
R2463 VSS.t178 VSS.n243 0.05175
R2464 VSS.t193 VSS.n268 0.05175
R2465 VSS.t208 VSS.n294 0.05175
R2466 VSS.t223 VSS.n357 0.05175
R2467 VSS.t238 VSS.n383 0.05175
R2468 VSS.t253 VSS.n409 0.05175
R2469 VSS.t164 VSS.n486 0.0483676
R2470 VSS.n506 VSS.n473 0.0483676
R2471 VSS.n491 VSS.n485 0.0483676
R2472 VSS.n520 VSS.n483 0.0483676
R2473 VSS.t268 VSS.n482 0.0483676
R2474 VSS.n513 VSS.t317 0.0483676
R2475 VSS.n498 VSS.n480 0.0483676
R2476 VSS.n502 VSS.n477 0.0483676
R2477 VSS.n500 VSS.n476 0.0483676
R2478 VSS.n453 VSS.n423 0.0483676
R2479 VSS.t276 VSS.n424 0.0483676
R2480 VSS.n458 VSS.n426 0.0483676
R2481 VSS.n460 VSS.n427 0.0483676
R2482 VSS.n464 VSS.n429 0.0483676
R2483 VSS.n432 VSS.n430 0.0483676
R2484 VSS.n535 VSS.n468 0.0483676
R2485 VSS.t263 VSS.n420 0.0483676
R2486 VSS.n456 VSS.n425 0.0483676
R2487 VSS.n462 VSS.n428 0.0483676
R2488 VSS.n174 VSS.t297 0.0483676
R2489 VSS.n220 VSS.n177 0.0483676
R2490 VSS.n247 VSS.n122 0.0483676
R2491 VSS.n273 VSS.n132 0.0483676
R2492 VSS.n299 VSS.n142 0.0483676
R2493 VSS.n362 VSS.n149 0.0483676
R2494 VSS.n388 VSS.n159 0.0483676
R2495 VSS.n414 VSS.n168 0.0483676
R2496 VSS.n536 VSS.n419 0.0483676
R2497 VSS.t260 VSS.n418 0.0483676
R2498 VSS.n208 VSS.n206 0.0483676
R2499 VSS.n212 VSS.n204 0.0483676
R2500 VSS.t97 VSS.n203 0.0483676
R2501 VSS.n216 VSS.t61 0.0483676
R2502 VSS.n214 VSS.n200 0.0483676
R2503 VSS.n218 VSS.n197 0.0483676
R2504 VSS.n822 VSS.n195 0.0483676
R2505 VSS.n222 VSS.n193 0.0483676
R2506 VSS.t77 VSS.n192 0.0483676
R2507 VSS.n814 VSS.n191 0.0483676
R2508 VSS.n227 VSS.n190 0.0483676
R2509 VSS.n225 VSS.n189 0.0483676
R2510 VSS.n808 VSS.n188 0.0483676
R2511 VSS.n806 VSS.n187 0.0483676
R2512 VSS.n231 VSS.n186 0.0483676
R2513 VSS.n229 VSS.n185 0.0483676
R2514 VSS.n800 VSS.n184 0.0483676
R2515 VSS.n798 VSS.n183 0.0483676
R2516 VSS.n235 VSS.n182 0.0483676
R2517 VSS.n791 VSS.n180 0.0483676
R2518 VSS.n785 VSS.n241 0.0483676
R2519 VSS.n770 VSS.n252 0.0483676
R2520 VSS.t186 VSS.n251 0.0483676
R2521 VSS.t188 VSS.n254 0.0483676
R2522 VSS.n756 VSS.n255 0.0483676
R2523 VSS.n755 VSS.n256 0.0483676
R2524 VSS.n259 VSS.n258 0.0483676
R2525 VSS.n748 VSS.n266 0.0483676
R2526 VSS.n731 VSS.n278 0.0483676
R2527 VSS.t201 VSS.n277 0.0483676
R2528 VSS.t203 VSS.n280 0.0483676
R2529 VSS.n717 VSS.n281 0.0483676
R2530 VSS.n716 VSS.n282 0.0483676
R2531 VSS.n285 VSS.n284 0.0483676
R2532 VSS.n709 VSS.n292 0.0483676
R2533 VSS.n692 VSS.n304 0.0483676
R2534 VSS.t216 VSS.n303 0.0483676
R2535 VSS.t218 VSS.n306 0.0483676
R2536 VSS.n678 VSS.n307 0.0483676
R2537 VSS.n677 VSS.n308 0.0483676
R2538 VSS.n329 VSS.n310 0.0483676
R2539 VSS.n672 VSS.n311 0.0483676
R2540 VSS.n670 VSS.n312 0.0483676
R2541 VSS.n337 VSS.n313 0.0483676
R2542 VSS.n335 VSS.n314 0.0483676
R2543 VSS.n664 VSS.n315 0.0483676
R2544 VSS.n339 VSS.n317 0.0483676
R2545 VSS.n656 VSS.n318 0.0483676
R2546 VSS.n343 VSS.n320 0.0483676
R2547 VSS.t145 VSS.n321 0.0483676
R2548 VSS.n647 VSS.n322 0.0483676
R2549 VSS.n349 VSS.n323 0.0483676
R2550 VSS.n347 VSS.n324 0.0483676
R2551 VSS.n641 VSS.n325 0.0483676
R2552 VSS.n351 VSS.n327 0.0483676
R2553 VSS.n631 VSS.n355 0.0483676
R2554 VSS.n614 VSS.n367 0.0483676
R2555 VSS.t231 VSS.n366 0.0483676
R2556 VSS.t233 VSS.n369 0.0483676
R2557 VSS.n600 VSS.n370 0.0483676
R2558 VSS.n599 VSS.n371 0.0483676
R2559 VSS.n374 VSS.n373 0.0483676
R2560 VSS.n592 VSS.n381 0.0483676
R2561 VSS.n575 VSS.n393 0.0483676
R2562 VSS.t246 VSS.n392 0.0483676
R2563 VSS.t248 VSS.n395 0.0483676
R2564 VSS.n561 VSS.n396 0.0483676
R2565 VSS.n560 VSS.n397 0.0483676
R2566 VSS.n400 VSS.n399 0.0483676
R2567 VSS.n553 VSS.n407 0.0483676
R2568 VSS.t261 VSS.n536 0.038
R2569 VSS.t185 VSS.n770 0.038
R2570 VSS.t200 VSS.n731 0.038
R2571 VSS.t215 VSS.n692 0.038
R2572 VSS.t230 VSS.n614 0.038
R2573 VSS.t245 VSS.n575 0.038
R2574 VSS.n777 VSS.t183 0.0373698
R2575 VSS.n738 VSS.t198 0.0373698
R2576 VSS.n699 VSS.t213 0.0373698
R2577 VSS.n621 VSS.t228 0.0373698
R2578 VSS.n582 VSS.t243 0.0373698
R2579 VSS.n543 VSS.t258 0.0373698
R2580 VSS.t198 VSS.n134 0.0912103
R2581 VSS.t258 VSS.n169 0.0912103
R2582 VSS.t188 VSS.n253 0.0253649
R2583 VSS.t203 VSS.n279 0.0253649
R2584 VSS.t218 VSS.n305 0.0253649
R2585 VSS.t233 VSS.n368 0.0253649
R2586 VSS.t248 VSS.n394 0.0253649
R2587 VSS.t263 VSS.n421 0.0253649
R2588 VSS.n17 VSS.t54 83.4525
R2589 VSS.n22 VSS.n43 6.82258
R2590 VSS.n22 VSS.n42 6.82258
R2591 VSS.n22 VSS.n2 0.382621
R2592 VSS.n22 VSS.n44 6.82258
R2593 VSS.n32 VSS.t121 83.4525
R2594 VSS.n46 VSS.t13 111.644
R2595 VSS.n12 VSS.t128 83.4525
R2596 VSS.n10 VSS.t62 83.4525
R2597 VSS.n45 VSS.t123 111.644
R2598 VSS.n48 VSS.t84 111.644
R2599 VSS.n7 VSS.t73 83.4525
R2600 VSS.n47 VSS.t45 111.644
R2601 VSS.n22 VSS.n1 0.382621
R2602 VSS.n33 VSS.t57 83.4525
R2603 VSS.n0 VSS.n105 0.00962391
R2604 VSS.n60 VSS.n53 0.016192
R2605 VSS.n60 VSS.n55 0.016192
R2606 VSS.n778 VSS.n59 0.016192
R2607 VSS.n95 VSS.t184 502.404
R2608 VSS.n94 VSS.n92 0.00443117
R2609 VSS.n739 VSS.n126 0.016192
R2610 VSS.n90 VSS.n88 0.00553969
R2611 VSS.n90 VSS.n87 0.00443117
R2612 VSS.n700 VSS.n136 0.016192
R2613 VSS.n72 VSS.n99 0.00553969
R2614 VSS.n622 VSS.n73 0.016192
R2615 VSS.n84 VSS.n82 0.00553969
R2616 VSS.n85 VSS.t40 133.321
R2617 VSS.n583 VSS.n153 0.016192
R2618 VSS.n79 VSS.t244 502.404
R2619 VSS.n80 VSS.t87 133.321
R2620 VSS.n544 VSS.n163 0.016192
R2621 VSS.n0 VSS.n104 0.0028169
R2622 VSS.n446 VSS.n421 0.0141149
R2623 VSS.n757 VSS.n253 0.0141149
R2624 VSS.n718 VSS.n279 0.0141149
R2625 VSS.n679 VSS.n305 0.0141149
R2626 VSS.n601 VSS.n368 0.0141149
R2627 VSS.n562 VSS.n394 0.0141149
R2628 VSS.n62 VSS.t3 133.326
R2629 VSS.n0 VSS.n103 0.00150047
R2630 VSS.n163 VSS.n0 0.0015
R2631 VSS.n165 VSS.n163 0.0015
R2632 VSS.n116 VSS.n78 0.00197011
R2633 VSS.n153 VSS.n77 0.0015
R2634 VSS.n155 VSS.n153 0.0015
R2635 VSS.n115 VSS.n84 0.00197011
R2636 VSS.n73 VSS.n83 0.0015
R2637 VSS.n74 VSS.n73 0.0015
R2638 VSS.n136 VSS.n100 0.0015
R2639 VSS.n138 VSS.n136 0.0015
R2640 VSS.n138 VSS.n113 0.00102989
R2641 VSS.n126 VSS.n89 0.0015
R2642 VSS.n128 VSS.n126 0.0015
R2643 VSS.n128 VSS.n112 0.00102989
R2644 VSS.n59 VSS.n93 0.0015
R2645 VSS.n60 VSS.n59 0.0015
R2646 VSS.n93 VSS.n121 0.00146907
R2647 VSS.n93 VSS.n123 0.00146907
R2648 VSS.n128 VSS.n127 0.00146907
R2649 VSS.n89 VSS.n131 0.00146907
R2650 VSS.n89 VSS.n133 0.00146907
R2651 VSS.n138 VSS.n137 0.00146907
R2652 VSS.n100 VSS.n141 0.00146907
R2653 VSS.n100 VSS.n143 0.00146907
R2654 VSS.n83 VSS.n148 0.00146907
R2655 VSS.n83 VSS.n150 0.00146907
R2656 VSS.n155 VSS.n154 0.00146907
R2657 VSS.n77 VSS.n158 0.00146907
R2658 VSS.n77 VSS.n160 0.00146907
R2659 VSS.n165 VSS.n164 0.00146907
R2660 VSS.n0 VSS.n106 0.00196806
R2661 VSS.n106 VSS.t254 79.8742
R2662 VSS.n72 VSS.n98 0.00268078
R2663 VSS.n94 VSS.n93 0.00253084
R2664 VSS.n90 VSS.n89 0.00253084
R2665 VSS.n84 VSS.n83 0.00253084
R2666 VSS.n78 VSS.n77 0.00253084
R2667 VSS.n72 VSS.n100 0.00253081
R2668 VSS.n75 VSS.t222 178.468
R2669 VSS.n61 VSS.t177 178.47
R2670 VSS.n22 VSS.t24 0.436007
R2671 VSS.n23 VSS.t112 198.006
R2672 a_3747_216.n0 a_3747_216.t2 52.0388
R2673 a_3747_216.t0 a_3747_216.n0 35.4491
R2674 a_3747_216.n0 a_3747_216.t3 33.5891
R2675 a_3747_216.t1 a_3747_216.t0 5.61942
R2676 a_3171_216.n0 a_3171_216.t2 51.8377
R2677 a_3171_216.n0 a_3171_216.t3 33.3881
R2678 a_3171_216.t0 a_3171_216.n0 31.8923
R2679 a_3171_216.t1 a_3171_216.t0 5.61777
R2680 a_2595_216.n0 a_2595_216.t2 51.6367
R2681 a_2595_216.n0 a_2595_216.t3 33.187
R2682 a_2595_216.t0 a_2595_216.n0 27.993
R2683 a_2595_216.t1 a_2595_216.t0 5.73018
R2684 a_2019_216.t3 a_2019_216.t2 51.6139
R2685 a_2019_216.t0 a_2019_216.t3 24.5351
R2686 a_2019_216.t1 a_2019_216.t0 5.62052
R2687 a_3747_952.n0 a_3747_952.t2 38.0081
R2688 a_3747_952.n0 a_3747_952.t3 33.3957
R2689 a_3747_952.n1 a_3747_952.t4 33.3957
R2690 a_3747_952.n2 a_3747_952.t5 33.3957
R2691 a_3747_952.n3 a_3747_952.t6 33.3957
R2692 a_3747_952.n4 a_3747_952.t7 33.3957
R2693 a_3747_952.n5 a_3747_952.t8 33.3957
R2694 a_3747_952.n6 a_3747_952.t9 33.3957
R2695 a_3747_952.t0 a_3747_952.n6 23.2419
R2696 a_3747_952.t1 a_3747_952.t0 5.61942
R2697 a_3747_952.n6 a_3747_952.n5 4.61291
R2698 a_3747_952.n5 a_3747_952.n4 4.61291
R2699 a_3747_952.n4 a_3747_952.n3 4.61291
R2700 a_3747_952.n3 a_3747_952.n2 4.61291
R2701 a_3747_952.n2 a_3747_952.n1 4.61291
R2702 a_3747_952.n1 a_3747_952.n0 4.61291
R2703 a_3171_952.n0 a_3171_952.t2 37.8054
R2704 a_3171_952.n0 a_3171_952.t3 33.193
R2705 a_3171_952.n1 a_3171_952.t4 33.193
R2706 a_3171_952.n2 a_3171_952.t5 33.193
R2707 a_3171_952.n3 a_3171_952.t6 33.193
R2708 a_3171_952.n4 a_3171_952.t7 33.193
R2709 a_3171_952.n5 a_3171_952.t8 33.193
R2710 a_3171_952.n6 a_3171_952.t9 33.193
R2711 a_3171_952.t0 a_3171_952.n6 23.0313
R2712 a_3171_952.t1 a_3171_952.t0 5.61777
R2713 a_3171_952.n6 a_3171_952.n5 4.61291
R2714 a_3171_952.n5 a_3171_952.n4 4.61291
R2715 a_3171_952.n4 a_3171_952.n3 4.61291
R2716 a_3171_952.n3 a_3171_952.n2 4.61291
R2717 a_3171_952.n2 a_3171_952.n1 4.61291
R2718 a_3171_952.n1 a_3171_952.n0 4.61291
R2719 a_2595_952.n0 a_2595_952.t2 37.7691
R2720 a_2595_952.n0 a_2595_952.t3 33.1567
R2721 a_2595_952.n1 a_2595_952.t4 33.1567
R2722 a_2595_952.n2 a_2595_952.t5 33.1567
R2723 a_2595_952.n3 a_2595_952.t6 33.1567
R2724 a_2595_952.n4 a_2595_952.t7 33.1567
R2725 a_2595_952.n5 a_2595_952.t8 33.1567
R2726 a_2595_952.n6 a_2595_952.t9 33.1567
R2727 a_2595_952.t0 a_2595_952.n6 22.7941
R2728 a_2595_952.t1 a_2595_952.t0 5.65522
R2729 a_2595_952.n6 a_2595_952.n5 4.61291
R2730 a_2595_952.n5 a_2595_952.n4 4.61291
R2731 a_2595_952.n4 a_2595_952.n3 4.61291
R2732 a_2595_952.n3 a_2595_952.n2 4.61291
R2733 a_2595_952.n2 a_2595_952.n1 4.61291
R2734 a_2595_952.n1 a_2595_952.n0 4.61291
R2735 a_2019_952.n0 a_2019_952.t2 37.9701
R2736 a_2019_952.n0 a_2019_952.t3 33.3577
R2737 a_2019_952.n1 a_2019_952.t4 33.3577
R2738 a_2019_952.n2 a_2019_952.t5 33.3577
R2739 a_2019_952.n3 a_2019_952.t6 33.3577
R2740 a_2019_952.n4 a_2019_952.t7 33.3577
R2741 a_2019_952.t0 a_2019_952.t9 22.5945
R2742 a_2019_952.t1 a_2019_952.t0 5.62052
R2743 a_2019_952.t9 a_2019_952.t8 4.61291
R2744 a_2019_952.t8 a_2019_952.n4 4.61291
R2745 a_2019_952.n4 a_2019_952.n3 4.61291
R2746 a_2019_952.n3 a_2019_952.n2 4.61291
R2747 a_2019_952.n2 a_2019_952.n1 4.61291
R2748 a_2019_952.n1 a_2019_952.n0 4.61291
C544 MUX_OUT VSS 7.79401f
C545 MUX_SEL4 VSS 1.57386f
C546 DELAY_OUT_TAP0 VSS 0.44781f
C547 MUX_SEL3 VSS 1.0035f
C548 MUX_SEL2 VSS 4.18782f
C549 DELAY_OUT_TAP31 VSS 0.41949f
C550 DELAY_OUT_TAP30 VSS 0.43238f
C551 DELAY_OUT_TAP29 VSS 0.30856f
C552 DELAY_OUT_TAP28 VSS 0.43233f
C553 DELAY_OUT_TAP27 VSS 0.38455f
C554 DELAY_OUT_TAP26 VSS 0.43238f
C555 DELAY_OUT_TAP25 VSS 0.30856f
C556 DELAY_OUT_TAP24 VSS 0.43233f
C557 DELAY_OUT_TAP23 VSS 0.38455f
C558 DELAY_OUT_TAP22 VSS 0.43238f
C559 DELAY_OUT_TAP21 VSS 0.30856f
C560 DELAY_OUT_TAP20 VSS 0.43233f
C561 DELAY_OUT_TAP19 VSS 0.38455f
C562 DELAY_OUT_TAP18 VSS 0.43238f
C563 DELAY_OUT_TAP17 VSS 0.30374f
C564 DELAY_OUT_TAP16 VSS 0.42869f
C565 DELAY_OUT_TAP15 VSS 0.38342f
C566 DELAY_OUT_TAP14 VSS 0.43238f
C567 DELAY_OUT_TAP13 VSS 0.30856f
C568 DELAY_OUT_TAP12 VSS 0.43233f
C569 DELAY_OUT_TAP11 VSS 0.38455f
C570 DELAY_OUT_TAP10 VSS 0.43238f
C571 DELAY_OUT_TAP9 VSS 0.30856f
C572 DELAY_OUT_TAP8 VSS 0.43233f
C573 DELAY_OUT_TAP7 VSS 0.38455f
C574 DELAY_OUT_TAP6 VSS 0.43238f
C575 DELAY_OUT_TAP5 VSS 0.30856f
C576 DELAY_OUT_TAP4 VSS 0.43233f
C577 DELAY_OUT_TAP3 VSS 0.38455f
C578 DELAY_OUT_TAP2 VSS 0.43243f
C579 DELAY_OUT_TAP1 VSS 0.30956f
C580 MUX_SEL1 VSS 1.04474f
C581 MUX_SEL0 VSS 4.19516f
C582 VDD VSS 27.44818f
C583 a_26985_424# VSS 0.19097f ; **FLOATING
C584 a_23945_424# VSS 0.18682f ; **FLOATING
C585 a_20905_424# VSS 0.18533f ; **FLOATING
C586 a_17865_424# VSS 0.1805f ; **FLOATING
C587 a_16851_214# VSS 0.39062f ; **FLOATING
C588 a_16108_194# VSS 5.09478f ; **FLOATING
C589 a_15964_194# VSS 0.18389f ; **FLOATING
C590 a_15765_368# VSS 0.37143f ; **FLOATING
C591 a_14825_424# VSS 0.18268f ; **FLOATING
C592 a_11785_424# VSS 0.18268f ; **FLOATING
C593 a_8745_424# VSS 0.18268f ; **FLOATING
C594 a_5731_194# VSS 4.48871f ; **FLOATING
C595 a_5705_424# VSS 0.17977f ; **FLOATING
C596 a_3449_236# VSS 0.18976f ; **FLOATING
C597 a_2873_236# VSS 0.18555f ; **FLOATING
C598 a_2297_236# VSS 0.18559f ; **FLOATING
C599 a_1721_236# VSS 0.1759f ; **FLOATING
C600 a_1544_194# VSS 0.31269f ; **FLOATING
C601 a_1256_194# VSS 0.9846f ; **FLOATING
C602 a_27991_913# VSS 0.18706f ; **FLOATING
C603 a_27915_949# VSS 0.10926f ; **FLOATING
C604 a_27124_913# VSS 0.17878f ; **FLOATING
C605 a_27048_949# VSS 0.12122f ; **FLOATING
C606 a_26471_913# VSS 0.18175f ; **FLOATING
C607 a_26395_949# VSS 0.11073f ; **FLOATING
C608 a_25604_913# VSS 0.18087f ; **FLOATING
C609 a_25630_949# VSS 0.36789f ; **FLOATING
C610 a_25528_949# VSS 0.12433f ; **FLOATING
C611 a_24951_913# VSS 0.18335f ; **FLOATING
C612 a_24875_949# VSS 0.11016f ; **FLOATING
C613 a_24084_913# VSS 0.17878f ; **FLOATING
C614 a_24008_949# VSS 0.12122f ; **FLOATING
C615 a_23431_913# VSS 0.18175f ; **FLOATING
C616 a_23355_949# VSS 0.11073f ; **FLOATING
C617 a_22564_913# VSS 0.18087f ; **FLOATING
C618 a_22590_949# VSS 0.35849f ; **FLOATING
C619 a_22488_949# VSS 0.12433f ; **FLOATING
C620 a_21911_913# VSS 0.18335f ; **FLOATING
C621 a_21835_949# VSS 0.11016f ; **FLOATING
C622 a_21044_913# VSS 0.17878f ; **FLOATING
C623 a_20968_949# VSS 0.12122f ; **FLOATING
C624 a_20391_913# VSS 0.18175f ; **FLOATING
C625 a_20315_949# VSS 0.11073f ; **FLOATING
C626 a_19524_913# VSS 0.18087f ; **FLOATING
C627 a_19550_949# VSS 0.36002f ; **FLOATING
C628 a_19448_949# VSS 0.12433f ; **FLOATING
C629 a_18871_913# VSS 0.18335f ; **FLOATING
C630 a_18795_949# VSS 0.11016f ; **FLOATING
C631 a_18004_913# VSS 0.17878f ; **FLOATING
C632 a_17928_949# VSS 0.12122f ; **FLOATING
C633 a_17351_913# VSS 0.18022f ; **FLOATING
C634 a_17275_949# VSS 0.10926f ; **FLOATING
C635 a_16484_913# VSS 0.18023f ; **FLOATING
C636 a_16510_949# VSS 0.33744f ; **FLOATING
C637 a_16408_949# VSS 0.1229f ; **FLOATING
C638 a_15831_913# VSS 0.17846f ; **FLOATING
C639 a_15755_949# VSS 0.10926f ; **FLOATING
C640 a_14964_913# VSS 0.17878f ; **FLOATING
C641 a_14888_949# VSS 0.12122f ; **FLOATING
C642 a_14311_913# VSS 0.18175f ; **FLOATING
C643 a_14235_949# VSS 0.11073f ; **FLOATING
C644 a_13444_913# VSS 0.18087f ; **FLOATING
C645 a_13470_949# VSS 0.34828f ; **FLOATING
C646 a_13368_949# VSS 0.12433f ; **FLOATING
C647 a_12791_913# VSS 0.18335f ; **FLOATING
C648 a_12715_949# VSS 0.11016f ; **FLOATING
C649 a_11924_913# VSS 0.17878f ; **FLOATING
C650 a_11848_949# VSS 0.12122f ; **FLOATING
C651 a_11271_913# VSS 0.18175f ; **FLOATING
C652 a_11195_949# VSS 0.11073f ; **FLOATING
C653 a_10404_913# VSS 0.18087f ; **FLOATING
C654 a_10430_949# VSS 0.35462f ; **FLOATING
C655 a_10328_949# VSS 0.12433f ; **FLOATING
C656 a_9751_913# VSS 0.18335f ; **FLOATING
C657 a_9675_949# VSS 0.11016f ; **FLOATING
C658 a_8884_913# VSS 0.17878f ; **FLOATING
C659 a_8808_949# VSS 0.12122f ; **FLOATING
C660 a_8231_913# VSS 0.18175f ; **FLOATING
C661 a_8155_949# VSS 0.11073f ; **FLOATING
C662 a_7364_913# VSS 0.18087f ; **FLOATING
C663 a_7390_949# VSS 0.3543f ; **FLOATING
C664 a_7288_949# VSS 0.12433f ; **FLOATING
C665 a_6711_913# VSS 0.18335f ; **FLOATING
C666 a_6635_949# VSS 0.11016f ; **FLOATING
C667 a_5844_913# VSS 0.17878f ; **FLOATING
C668 a_5768_949# VSS 0.12122f ; **FLOATING
C669 a_5191_913# VSS 0.18022f ; **FLOATING
C670 a_5115_949# VSS 0.10926f ; **FLOATING
C671 a_4324_913# VSS 0.18023f ; **FLOATING
C672 a_4350_949# VSS 0.3288f ; **FLOATING
C673 a_4248_949# VSS 0.12443f ; **FLOATING
C674 a_27705_949# VSS 0.2535f ; **FLOATING
C675 a_26185_949# VSS 0.23529f ; **FLOATING
C676 a_24665_949# VSS 0.25486f ; **FLOATING
C677 a_23145_949# VSS 0.23529f ; **FLOATING
C678 a_21625_949# VSS 0.25486f ; **FLOATING
C679 a_20105_949# VSS 0.23529f ; **FLOATING
C680 a_18585_949# VSS 0.25486f ; **FLOATING
C681 a_17065_949# VSS 0.23439f ; **FLOATING
C682 a_15545_949# VSS 0.2535f ; **FLOATING
C683 a_14025_949# VSS 0.23529f ; **FLOATING
C684 a_12505_949# VSS 0.25486f ; **FLOATING
C685 a_10985_949# VSS 0.23529f ; **FLOATING
C686 a_9465_949# VSS 0.25486f ; **FLOATING
C687 a_7945_949# VSS 0.23529f ; **FLOATING
C688 a_6425_949# VSS 0.25486f ; **FLOATING
C689 a_4905_949# VSS 0.23602f ; **FLOATING
C690 a_4157_1218# VSS 0.34693f ; **FLOATING
C691 a_3449_1300# VSS 0.19203f ; **FLOATING
C692 a_2873_1300# VSS 0.18591f ; **FLOATING
C693 a_2297_1300# VSS 0.18559f ; **FLOATING
C694 a_1721_1300# VSS 0.1774f ; **FLOATING
C695 a_1544_949# VSS 0.31311f ; **FLOATING
C696 a_1256_949# VSS 0.98158f ; **FLOATING
C697 a_2019_952.t2 VSS 0.82935f ; **FLOATING
C698 a_2019_952.t3 VSS 0.62962f ; **FLOATING
C699 a_2019_952.n0 VSS 4.46549f ; **FLOATING
C700 a_2019_952.t4 VSS 0.62962f ; **FLOATING
C701 a_2019_952.n1 VSS 3.02103f ; **FLOATING
C702 a_2019_952.t5 VSS 0.62962f ; **FLOATING
C703 a_2019_952.n2 VSS 3.02103f ; **FLOATING
C704 a_2019_952.t6 VSS 0.62962f ; **FLOATING
C705 a_2019_952.n3 VSS 3.02103f ; **FLOATING
C706 a_2019_952.t7 VSS 0.62962f ; **FLOATING
C707 a_2019_952.n4 VSS 3.02103f ; **FLOATING
C708 a_2019_952.t8 VSS 3.65065f ; **FLOATING
C709 a_2019_952.t9 VSS 4.86312f ; **FLOATING
C710 a_2019_952.t0 VSS 0.95622f ; **FLOATING
C711 a_2019_952.t1 VSS 0.27179f ; **FLOATING
C712 a_2595_952.t2 VSS 1.36255f ; **FLOATING
C713 a_2595_952.t3 VSS 1.0176f ; **FLOATING
C714 a_2595_952.n0 VSS 7.73581f ; **FLOATING
C715 a_2595_952.t4 VSS 1.0176f ; **FLOATING
C716 a_2595_952.n1 VSS 5.25612f ; **FLOATING
C717 a_2595_952.t5 VSS 1.0176f ; **FLOATING
C718 a_2595_952.n2 VSS 5.25612f ; **FLOATING
C719 a_2595_952.t6 VSS 1.0176f ; **FLOATING
C720 a_2595_952.n3 VSS 5.25612f ; **FLOATING
C721 a_2595_952.t7 VSS 1.0176f ; **FLOATING
C722 a_2595_952.n4 VSS 5.25612f ; **FLOATING
C723 a_2595_952.t8 VSS 1.0176f ; **FLOATING
C724 a_2595_952.n5 VSS 5.25612f ; **FLOATING
C725 a_2595_952.t9 VSS 1.0176f ; **FLOATING
C726 a_2595_952.n6 VSS 7.56062f ; **FLOATING
C727 a_2595_952.t0 VSS 1.74545f ; **FLOATING
C728 a_2595_952.t1 VSS 0.48069f ; **FLOATING
C729 a_3171_952.t2 VSS 1.38836f ; **FLOATING
C730 a_3171_952.t3 VSS 1.04029f ; **FLOATING
C731 a_3171_952.n0 VSS 7.80069f ; **FLOATING
C732 a_3171_952.t4 VSS 1.04029f ; **FLOATING
C733 a_3171_952.n1 VSS 5.29585f ; **FLOATING
C734 a_3171_952.t5 VSS 1.04029f ; **FLOATING
C735 a_3171_952.n2 VSS 5.29585f ; **FLOATING
C736 a_3171_952.t6 VSS 1.04029f ; **FLOATING
C737 a_3171_952.n3 VSS 5.29585f ; **FLOATING
C738 a_3171_952.t7 VSS 1.04029f ; **FLOATING
C739 a_3171_952.n4 VSS 5.29585f ; **FLOATING
C740 a_3171_952.t8 VSS 1.04029f ; **FLOATING
C741 a_3171_952.n5 VSS 5.29585f ; **FLOATING
C742 a_3171_952.t9 VSS 1.04029f ; **FLOATING
C743 a_3171_952.n6 VSS 7.70533f ; **FLOATING
C744 a_3171_952.t0 VSS 1.7753f ; **FLOATING
C745 a_3171_952.t1 VSS 0.48221f ; **FLOATING
C746 a_3747_952.t2 VSS 1.01208f ; **FLOATING
C747 a_3747_952.t3 VSS 0.77051f ; **FLOATING
C748 a_3747_952.n0 VSS 5.39805f ; **FLOATING
C749 a_3747_952.t4 VSS 0.77051f ; **FLOATING
C750 a_3747_952.n1 VSS 3.64901f ; **FLOATING
C751 a_3747_952.t5 VSS 0.77051f ; **FLOATING
C752 a_3747_952.n2 VSS 3.64901f ; **FLOATING
C753 a_3747_952.t6 VSS 0.77051f ; **FLOATING
C754 a_3747_952.n3 VSS 3.64901f ; **FLOATING
C755 a_3747_952.t7 VSS 0.77051f ; **FLOATING
C756 a_3747_952.n4 VSS 3.64901f ; **FLOATING
C757 a_3747_952.t8 VSS 0.77051f ; **FLOATING
C758 a_3747_952.n5 VSS 3.64901f ; **FLOATING
C759 a_3747_952.t9 VSS 0.77051f ; **FLOATING
C760 a_3747_952.n6 VSS 5.41835f ; **FLOATING
C761 a_3747_952.t0 VSS 1.23825f ; **FLOATING
C762 a_3747_952.t1 VSS 0.32736f ; **FLOATING
C763 a_2019_216.t2 VSS 4.07031f ; **FLOATING
C764 a_2019_216.t3 VSS 21.905f ; **FLOATING
C765 a_2019_216.t0 VSS 1.98975f ; **FLOATING
C766 a_2019_216.t1 VSS 0.44677f ; **FLOATING
C767 a_2595_216.t0 VSS 3.28181f ; **FLOATING
C768 a_2595_216.t2 VSS 5.05908f ; **FLOATING
C769 a_2595_216.t3 VSS 1.21054f ; **FLOATING
C770 a_2595_216.n0 VSS 26.9608f ; **FLOATING
C771 a_2595_216.t1 VSS 0.49745f ; **FLOATING
C772 a_3171_216.t2 VSS 5.10959f ; **FLOATING
C773 a_3171_216.t3 VSS 1.22577f ; **FLOATING
C774 a_3171_216.n0 VSS 30.2016f ; **FLOATING
C775 a_3171_216.t0 VSS 4.66587f ; **FLOATING
C776 a_3171_216.t1 VSS 0.50316f ; **FLOATING
C777 a_3747_216.t2 VSS 3.8862f ; **FLOATING
C778 a_3747_216.t3 VSS 0.93537f ; **FLOATING
C779 a_3747_216.n0 VSS 24.9968f ; **FLOATING
C780 a_3747_216.t0 VSS 4.63641f ; **FLOATING
C781 a_3747_216.t1 VSS 0.3838f ; **FLOATING
C782 VDD.t0 VSS 69.4929f ; **FLOATING
C783 VDD.n0 VSS 0.03631f ; **FLOATING
C784 VDD.n1 VSS 0.16003f ; **FLOATING
C785 VDD.n2 VSS 0.30692f ; **FLOATING
C786 VDD.n3 VSS 1.11892f ; **FLOATING
C787 VDD.n4 VSS 0.84056f ; **FLOATING
C788 VDD.n5 VSS 1.37838f ; **FLOATING
C789 VDD.n7 VSS 1.33505f ; **FLOATING
C790 VDD.n8 VSS 0.02314f ; **FLOATING
C791 VDD.n9 VSS 0.96385f ; **FLOATING
C792 VDD.n11 VSS 0.65409f ; **FLOATING
C793 VDD.n15 VSS 0.16804f ; **FLOATING
C794 VDD.n16 VSS 0.01985f ; **FLOATING
C795 VDD.n17 VSS 1.6704f ; **FLOATING
C796 VDD.n20 VSS 0.16804f ; **FLOATING
C797 VDD.n21 VSS 0.16804f ; **FLOATING
C798 VDD.n30 VSS 0.02857f ; **FLOATING
C799 VDD.n31 VSS 0.01895f ; **FLOATING
C800 VDD.n38 VSS 0.01895f ; **FLOATING
C801 VDD.n47 VSS 0.02586f ; **FLOATING
C802 VDD.n62 VSS 0.02314f ; **FLOATING
C803 VDD.n69 VSS 0.02275f ; **FLOATING
C804 VDD.n70 VSS 0.02275f ; **FLOATING
C805 VDD.n74 VSS 0.02314f ; **FLOATING
C806 VDD.n75 VSS 0.02314f ; **FLOATING
C807 VDD.n76 VSS 0.02275f ; **FLOATING
C808 VDD.n77 VSS 0.02314f ; **FLOATING
C809 VDD.n78 VSS 0.02314f ; **FLOATING
C810 VDD.n79 VSS 0.02275f ; **FLOATING
C811 VDD.n80 VSS 0.02314f ; **FLOATING
C812 VDD.n81 VSS 0.02314f ; **FLOATING
C813 VDD.n83 VSS 0.02314f ; **FLOATING
C814 VDD.n85 VSS 0.02275f ; **FLOATING
C815 VDD.n87 VSS 0.02314f ; **FLOATING
C816 VDD.n89 VSS 0.02314f ; **FLOATING
C817 VDD.n92 VSS 0.02314f ; **FLOATING
C818 VDD.n93 VSS 0.02275f ; **FLOATING
C819 VDD.n94 VSS 0.02314f ; **FLOATING
C820 VDD.n95 VSS 0.02314f ; **FLOATING
C821 VDD.n96 VSS 0.02275f ; **FLOATING
C822 VDD.n98 VSS 0.02314f ; **FLOATING
C823 VDD.t124 VSS 0.0414f ; **FLOATING
C824 VDD.t162 VSS 0.0414f ; **FLOATING
C825 VDD.t130 VSS 0.0414f ; **FLOATING
C826 VDD.t100 VSS 0.0414f ; **FLOATING
C827 VDD.t128 VSS 0.0414f ; **FLOATING
C828 VDD.t164 VSS 0.0414f ; **FLOATING
C829 VDD.t59 VSS 0.04154f ; **FLOATING
C830 VDD.t99 VSS 0.05434f ; **FLOATING
C831 VDD.t180 VSS 0.03717f ; **FLOATING
C832 VDD.t47 VSS 0.0414f ; **FLOATING
C833 VDD.t119 VSS 0.0414f ; **FLOATING
C834 VDD.t115 VSS 0.05434f ; **FLOATING
C835 VDD.t13 VSS 0.0414f ; **FLOATING
C836 VDD.t141 VSS 0.0414f ; **FLOATING
C837 VDD.n104 VSS 0.02314f ; **FLOATING
C838 VDD.n105 VSS 0.02314f ; **FLOATING
C839 VDD.t9 VSS 0.0414f ; **FLOATING
C840 VDD.t189 VSS 0.03717f ; **FLOATING
C841 VDD.t76 VSS 0.05453f ; **FLOATING
C842 VDD.t155 VSS 0.03991f ; **FLOATING
C843 VDD.t190 VSS 0.1373f ; **FLOATING
C844 VDD.n106 VSS 0.02275f ; **FLOATING
C845 VDD.n107 VSS 0.02314f ; **FLOATING
C846 VDD.t154 VSS 0.03717f ; **FLOATING
C847 VDD.n108 VSS 0.02314f ; **FLOATING
C848 VDD.t133 VSS 0.03991f ; **FLOATING
C849 VDD.t191 VSS 0.1373f ; **FLOATING
C850 VDD.t153 VSS 0.0414f ; **FLOATING
C851 VDD.t132 VSS 0.03717f ; **FLOATING
C852 VDD.n109 VSS 0.02314f ; **FLOATING
C853 VDD.t62 VSS 0.03717f ; **FLOATING
C854 VDD.t55 VSS 0.0414f ; **FLOATING
C855 VDD.t61 VSS 0.03991f ; **FLOATING
C856 VDD.t192 VSS 0.1373f ; **FLOATING
C857 VDD.t26 VSS 0.05434f ; **FLOATING
C858 VDD.n110 VSS 0.02314f ; **FLOATING
C859 VDD.t160 VSS 0.03717f ; **FLOATING
C860 VDD.t65 VSS 0.0414f ; **FLOATING
C861 VDD.t53 VSS 0.0414f ; **FLOATING
C862 VDD.n111 VSS 0.02314f ; **FLOATING
C863 VDD.t172 VSS 0.0414f ; **FLOATING
C864 VDD.t31 VSS 0.0414f ; **FLOATING
C865 VDD.t81 VSS 0.03717f ; **FLOATING
C866 VDD.n112 VSS 0.02314f ; **FLOATING
C867 VDD.n113 VSS 0.02314f ; **FLOATING
C868 VDD.t69 VSS 0.05453f ; **FLOATING
C869 VDD.t57 VSS 0.03991f ; **FLOATING
C870 VDD.t193 VSS 0.1373f ; **FLOATING
C871 VDD.t58 VSS 0.03717f ; **FLOATING
C872 VDD.t29 VSS 0.03717f ; **FLOATING
C873 VDD.n114 VSS 0.02314f ; **FLOATING
C874 VDD.t30 VSS 0.03991f ; **FLOATING
C875 VDD.t194 VSS 0.1373f ; **FLOATING
C876 VDD.t56 VSS 0.0414f ; **FLOATING
C877 VDD.t168 VSS 0.0414f ; **FLOATING
C878 VDD.t33 VSS 0.03717f ; **FLOATING
C879 VDD.n115 VSS 0.02314f ; **FLOATING
C880 VDD.t27 VSS 0.03717f ; **FLOATING
C881 VDD.t64 VSS 0.0414f ; **FLOATING
C882 VDD.t28 VSS 0.03991f ; **FLOATING
C883 VDD.t195 VSS 0.1373f ; **FLOATING
C884 VDD.t18 VSS 0.05434f ; **FLOATING
C885 VDD.n116 VSS 0.02314f ; **FLOATING
C886 VDD.t34 VSS 0.03717f ; **FLOATING
C887 VDD.n117 VSS 0.02314f ; **FLOATING
C888 VDD.n118 VSS 0.02314f ; **FLOATING
C889 VDD.t96 VSS 0.0414f ; **FLOATING
C890 VDD.t21 VSS 0.0414f ; **FLOATING
C891 VDD.n119 VSS 0.02314f ; **FLOATING
C892 VDD.t70 VSS 0.0414f ; **FLOATING
C893 VDD.t92 VSS 0.0414f ; **FLOATING
C894 VDD.n120 VSS 0.02314f ; **FLOATING
C895 VDD.n121 VSS 0.02314f ; **FLOATING
C896 VDD.n122 VSS 0.02314f ; **FLOATING
C897 VDD.n123 VSS 0.02314f ; **FLOATING
C898 VDD.n124 VSS 0.03505f ; **FLOATING
C899 VDD.n125 VSS 0.02314f ; **FLOATING
C900 VDD.t6 VSS 0.03717f ; **FLOATING
C901 VDD.t102 VSS 0.05453f ; **FLOATING
C902 VDD.t7 VSS 0.03991f ; **FLOATING
C903 VDD.t196 VSS 0.1373f ; **FLOATING
C904 VDD.n126 VSS 0.02314f ; **FLOATING
C905 VDD.t37 VSS 0.03717f ; **FLOATING
C906 VDD.t25 VSS 0.03717f ; **FLOATING
C907 VDD.t52 VSS 0.0414f ; **FLOATING
C908 VDD.t38 VSS 0.03991f ; **FLOATING
C909 VDD.t197 VSS 0.1373f ; **FLOATING
C910 VDD.n127 VSS 0.02314f ; **FLOATING
C911 VDD.t49 VSS 0.03717f ; **FLOATING
C912 VDD.t147 VSS 0.0414f ; **FLOATING
C913 VDD.t120 VSS 0.03717f ; **FLOATING
C914 VDD.t45 VSS 0.0414f ; **FLOATING
C915 VDD.n128 VSS 0.02314f ; **FLOATING
C916 VDD.t121 VSS 0.03991f ; **FLOATING
C917 VDD.t198 VSS 0.1373f ; **FLOATING
C918 VDD.t75 VSS 0.05434f ; **FLOATING
C919 VDD.n129 VSS 0.02314f ; **FLOATING
C920 VDD.t178 VSS 0.03717f ; **FLOATING
C921 VDD.n130 VSS 0.02314f ; **FLOATING
C922 VDD.n131 VSS 0.02314f ; **FLOATING
C923 VDD.t94 VSS 0.0414f ; **FLOATING
C924 VDD.t116 VSS 0.0414f ; **FLOATING
C925 VDD.n132 VSS 0.02314f ; **FLOATING
C926 VDD.n133 VSS 0.02619f ; **FLOATING
C927 VDD.t159 VSS 0.0414f ; **FLOATING
C928 VDD.t8 VSS 0.0414f ; **FLOATING
C929 VDD.n134 VSS 0.02314f ; **FLOATING
C930 VDD.n135 VSS 0.02314f ; **FLOATING
C931 VDD.t107 VSS 0.07762f ; **FLOATING
C932 VDD.n136 VSS 0.02314f ; **FLOATING
C933 VDD.t112 VSS 0.05434f ; **FLOATING
C934 VDD.n137 VSS 0.02314f ; **FLOATING
C935 VDD.t106 VSS 0.04396f ; **FLOATING
C936 VDD.n138 VSS 0.02314f ; **FLOATING
C937 VDD.n139 VSS 0.02314f ; **FLOATING
C938 VDD.t97 VSS 0.0414f ; **FLOATING
C939 VDD.n140 VSS 0.02314f ; **FLOATING
C940 VDD.n141 VSS 0.0201f ; **FLOATING
C941 VDD.t173 VSS 0.0414f ; **FLOATING
C942 VDD.t148 VSS 0.0414f ; **FLOATING
C943 VDD.t5 VSS 0.0414f ; **FLOATING
C944 VDD.n142 VSS 0.02314f ; **FLOATING
C945 VDD.n143 VSS 0.02314f ; **FLOATING
C946 VDD.n144 VSS 0.02314f ; **FLOATING
C947 VDD.t68 VSS 0.05434f ; **FLOATING
C948 VDD.n145 VSS 0.02314f ; **FLOATING
C949 VDD.n146 VSS 0.02314f ; **FLOATING
C950 VDD.n147 VSS 0.02314f ; **FLOATING
C951 VDD.t86 VSS 0.0414f ; **FLOATING
C952 VDD.t114 VSS 0.0414f ; **FLOATING
C953 VDD.n148 VSS 0.02314f ; **FLOATING
C954 VDD.n149 VSS 0.02619f ; **FLOATING
C955 VDD.t184 VSS 0.0414f ; **FLOATING
C956 VDD.t60 VSS 0.0414f ; **FLOATING
C957 VDD.n150 VSS 0.02314f ; **FLOATING
C958 VDD.n151 VSS 0.02314f ; **FLOATING
C959 VDD.n152 VSS 0.02314f ; **FLOATING
C960 VDD.n153 VSS 0.02314f ; **FLOATING
C961 VDD.n154 VSS 0.02314f ; **FLOATING
C962 VDD.n155 VSS 0.03472f ; **FLOATING
C963 VDD.n156 VSS 0.03496f ; **FLOATING
C964 VDD.n157 VSS 0.02314f ; **FLOATING
C965 VDD.n158 VSS 0.02314f ; **FLOATING
C966 VDD.n159 VSS 0.02314f ; **FLOATING
C967 VDD.n160 VSS 0.02314f ; **FLOATING
C968 VDD.n161 VSS 0.02314f ; **FLOATING
C969 VDD.n162 VSS 0.02314f ; **FLOATING
C970 VDD.n163 VSS 0.02314f ; **FLOATING
C971 VDD.n164 VSS 0.03472f ; **FLOATING
C972 VDD.n165 VSS 0.03508f ; **FLOATING
C973 VDD.n166 VSS 0.02314f ; **FLOATING
C974 VDD.n167 VSS 0.02314f ; **FLOATING
C975 VDD.n168 VSS 0.02314f ; **FLOATING
C976 VDD.n169 VSS 0.02314f ; **FLOATING
C977 VDD.n170 VSS 0.02314f ; **FLOATING
C978 VDD.n171 VSS 0.02314f ; **FLOATING
C979 VDD.n172 VSS 0.02314f ; **FLOATING
C980 VDD.n173 VSS 0.03472f ; **FLOATING
C981 VDD.n174 VSS 0.02314f ; **FLOATING
C982 VDD.t122 VSS 0.03717f ; **FLOATING
C983 VDD.t77 VSS 0.05453f ; **FLOATING
C984 VDD.t41 VSS 0.03991f ; **FLOATING
C985 VDD.t199 VSS 0.1373f ; **FLOATING
C986 VDD.n175 VSS 0.02314f ; **FLOATING
C987 VDD.t167 VSS 0.03717f ; **FLOATING
C988 VDD.t42 VSS 0.03717f ; **FLOATING
C989 VDD.t54 VSS 0.0414f ; **FLOATING
C990 VDD.t66 VSS 0.03991f ; **FLOATING
C991 VDD.t200 VSS 0.1373f ; **FLOATING
C992 VDD.n176 VSS 0.02314f ; **FLOATING
C993 VDD.t67 VSS 0.03717f ; **FLOATING
C994 VDD.t139 VSS 0.0414f ; **FLOATING
C995 VDD.t40 VSS 0.03717f ; **FLOATING
C996 VDD.t12 VSS 0.0414f ; **FLOATING
C997 VDD.n177 VSS 0.02314f ; **FLOATING
C998 VDD.t36 VSS 0.03991f ; **FLOATING
C999 VDD.t201 VSS 0.1373f ; **FLOATING
C1000 VDD.t113 VSS 0.05434f ; **FLOATING
C1001 VDD.n178 VSS 0.02275f ; **FLOATING
C1002 VDD.t35 VSS 0.03717f ; **FLOATING
C1003 VDD.n179 VSS 0.02275f ; **FLOATING
C1004 VDD.n180 VSS 0.02275f ; **FLOATING
C1005 VDD.t15 VSS 0.0414f ; **FLOATING
C1006 VDD.t63 VSS 0.0414f ; **FLOATING
C1007 VDD.n181 VSS 0.02275f ; **FLOATING
C1008 VDD.n182 VSS 0.02574f ; **FLOATING
C1009 VDD.t140 VSS 0.0414f ; **FLOATING
C1010 VDD.t84 VSS 0.0414f ; **FLOATING
C1011 VDD.n183 VSS 0.02314f ; **FLOATING
C1012 VDD.n184 VSS 0.02314f ; **FLOATING
C1013 VDD.n185 VSS 0.02314f ; **FLOATING
C1014 VDD.n186 VSS 0.02314f ; **FLOATING
C1015 VDD.n187 VSS 0.02314f ; **FLOATING
C1016 VDD.n188 VSS 0.03472f ; **FLOATING
C1017 VDD.n189 VSS 0.02314f ; **FLOATING
C1018 VDD.t91 VSS 0.03717f ; **FLOATING
C1019 VDD.t101 VSS 0.05453f ; **FLOATING
C1020 VDD.t43 VSS 0.03991f ; **FLOATING
C1021 VDD.t202 VSS 0.1373f ; **FLOATING
C1022 VDD.n190 VSS 0.02314f ; **FLOATING
C1023 VDD.t19 VSS 0.03717f ; **FLOATING
C1024 VDD.t44 VSS 0.03717f ; **FLOATING
C1025 VDD.t1 VSS 0.0414f ; **FLOATING
C1026 VDD.t20 VSS 0.03991f ; **FLOATING
C1027 VDD.t203 VSS 0.1373f ; **FLOATING
C1028 VDD.n191 VSS 0.02314f ; **FLOATING
C1029 VDD.t88 VSS 0.03717f ; **FLOATING
C1030 VDD.t183 VSS 0.0414f ; **FLOATING
C1031 VDD.t89 VSS 0.03717f ; **FLOATING
C1032 VDD.t17 VSS 0.0414f ; **FLOATING
C1033 VDD.n192 VSS 0.02314f ; **FLOATING
C1034 VDD.t90 VSS 0.03991f ; **FLOATING
C1035 VDD.t204 VSS 0.1373f ; **FLOATING
C1036 VDD.t146 VSS 0.05434f ; **FLOATING
C1037 VDD.n193 VSS 0.02314f ; **FLOATING
C1038 VDD.t174 VSS 0.03717f ; **FLOATING
C1039 VDD.n194 VSS 0.02314f ; **FLOATING
C1040 VDD.n195 VSS 0.02314f ; **FLOATING
C1041 VDD.t16 VSS 0.0414f ; **FLOATING
C1042 VDD.t93 VSS 0.0414f ; **FLOATING
C1043 VDD.n196 VSS 0.02314f ; **FLOATING
C1044 VDD.n197 VSS 0.02619f ; **FLOATING
C1045 VDD.t185 VSS 0.0414f ; **FLOATING
C1046 VDD.t39 VSS 0.0414f ; **FLOATING
C1047 VDD.n198 VSS 0.02314f ; **FLOATING
C1048 VDD.n199 VSS 0.02314f ; **FLOATING
C1049 VDD.n200 VSS 0.02314f ; **FLOATING
C1050 VDD.n201 VSS 0.02314f ; **FLOATING
C1051 VDD.n202 VSS 0.02314f ; **FLOATING
C1052 VDD.n203 VSS 0.03472f ; **FLOATING
C1053 VDD.n204 VSS 0.02314f ; **FLOATING
C1054 VDD.t98 VSS 0.03717f ; **FLOATING
C1055 VDD.t158 VSS 0.05453f ; **FLOATING
C1056 VDD.t10 VSS 0.03991f ; **FLOATING
C1057 VDD.t205 VSS 0.1373f ; **FLOATING
C1058 VDD.n205 VSS 0.02314f ; **FLOATING
C1059 VDD.t104 VSS 0.03717f ; **FLOATING
C1060 VDD.t11 VSS 0.03717f ; **FLOATING
C1061 VDD.t175 VSS 0.0414f ; **FLOATING
C1062 VDD.t105 VSS 0.03991f ; **FLOATING
C1063 VDD.t206 VSS 0.1373f ; **FLOATING
C1064 VDD.n206 VSS 0.02314f ; **FLOATING
C1065 VDD.t177 VSS 0.03717f ; **FLOATING
C1066 VDD.t118 VSS 0.0414f ; **FLOATING
C1067 VDD.t83 VSS 0.03717f ; **FLOATING
C1068 VDD.t85 VSS 0.0414f ; **FLOATING
C1069 VDD.n207 VSS 0.02314f ; **FLOATING
C1070 VDD.t22 VSS 0.03717f ; **FLOATING
C1071 VDD.n208 VSS 0.02314f ; **FLOATING
C1072 VDD.n209 VSS 0.02314f ; **FLOATING
C1073 VDD.t46 VSS 0.0414f ; **FLOATING
C1074 VDD.t2 VSS 0.0414f ; **FLOATING
C1075 VDD.n210 VSS 0.02619f ; **FLOATING
C1076 VDD.n211 VSS 0.02314f ; **FLOATING
C1077 VDD.t108 VSS 0.05434f ; **FLOATING
C1078 VDD.n212 VSS 0.02314f ; **FLOATING
C1079 VDD.n213 VSS 0.02314f ; **FLOATING
C1080 VDD.t80 VSS 0.0414f ; **FLOATING
C1081 VDD.n214 VSS 0.02314f ; **FLOATING
C1082 VDD.n215 VSS 0.02314f ; **FLOATING
C1083 VDD.t109 VSS 0.04086f ; **FLOATING
C1084 VDD.t78 VSS 0.04086f ; **FLOATING
C1085 VDD.t123 VSS 0.03057f ; **FLOATING
C1086 VDD.t163 VSS 0.03057f ; **FLOATING
C1087 VDD.n216 VSS 0.02314f ; **FLOATING
C1088 VDD.n217 VSS 0.02314f ; **FLOATING
C1089 VDD.t151 VSS 0.04614f ; **FLOATING
C1090 VDD.t171 VSS 0.04614f ; **FLOATING
C1091 VDD.t144 VSS 0.04086f ; **FLOATING
C1092 VDD.t74 VSS 0.04086f ; **FLOATING
C1093 VDD.t129 VSS 0.03057f ; **FLOATING
C1094 VDD.t165 VSS 0.03057f ; **FLOATING
C1095 VDD.t182 VSS 0.04614f ; **FLOATING
C1096 VDD.t51 VSS 0.04614f ; **FLOATING
C1097 VDD.n218 VSS 0.02314f ; **FLOATING
C1098 VDD.n219 VSS 0.02314f ; **FLOATING
C1099 VDD.t138 VSS 0.04086f ; **FLOATING
C1100 VDD.t4 VSS 0.04086f ; **FLOATING
C1101 VDD.t125 VSS 0.03057f ; **FLOATING
C1102 VDD.t161 VSS 0.03057f ; **FLOATING
C1103 VDD.t136 VSS 0.04614f ; **FLOATING
C1104 VDD.t72 VSS 0.04614f ; **FLOATING
C1105 VDD.n220 VSS 0.02314f ; **FLOATING
C1106 VDD.n221 VSS 0.02314f ; **FLOATING
C1107 VDD.t135 VSS 0.04086f ; **FLOATING
C1108 VDD.t3 VSS 0.04086f ; **FLOATING
C1109 VDD.t143 VSS 0.03057f ; **FLOATING
C1110 VDD.t73 VSS 0.03057f ; **FLOATING
C1111 VDD.n222 VSS 0.02314f ; **FLOATING
C1112 VDD.n223 VSS 0.02314f ; **FLOATING
C1113 VDD.n224 VSS 0.02314f ; **FLOATING
C1114 VDD.n225 VSS 0.02314f ; **FLOATING
C1115 VDD.n226 VSS 0.02314f ; **FLOATING
C1116 VDD.n227 VSS 0.02314f ; **FLOATING
C1117 VDD.n228 VSS 0.02314f ; **FLOATING
C1118 VDD.n229 VSS 0.02314f ; **FLOATING
C1119 VDD.n230 VSS 0.02314f ; **FLOATING
C1120 VDD.n231 VSS 0.02314f ; **FLOATING
C1121 VDD.n232 VSS 0.02314f ; **FLOATING
C1122 VDD.n233 VSS 0.02314f ; **FLOATING
C1123 VDD.n234 VSS 0.02314f ; **FLOATING
C1124 VDD.n235 VSS 0.02314f ; **FLOATING
C1125 VDD.n236 VSS 0.02314f ; **FLOATING
C1126 VDD.n237 VSS 0.02314f ; **FLOATING
C1127 VDD.n238 VSS 0.02314f ; **FLOATING
C1128 VDD.n239 VSS 0.02314f ; **FLOATING
C1129 VDD.n240 VSS 0.02314f ; **FLOATING
C1130 VDD.n241 VSS 0.02314f ; **FLOATING
C1131 VDD.n242 VSS 0.02314f ; **FLOATING
C1132 VDD.n243 VSS 0.02314f ; **FLOATING
C1133 VDD.n244 VSS 0.02314f ; **FLOATING
C1134 VDD.t110 VSS 0.04614f ; **FLOATING
C1135 VDD.t79 VSS 0.04614f ; **FLOATING
C1136 VDD.n245 VSS 0.03015f ; **FLOATING
C1137 VDD.n246 VSS 0.04629f ; **FLOATING
C1138 VDD.n247 VSS 0.04654f ; **FLOATING
C1139 VDD.n248 VSS 0.02314f ; **FLOATING
C1140 VDD.n249 VSS 0.02314f ; **FLOATING
C1141 VDD.n250 VSS 0.02314f ; **FLOATING
C1142 VDD.n251 VSS 0.02314f ; **FLOATING
C1143 VDD.n252 VSS 0.02314f ; **FLOATING
C1144 VDD.n253 VSS 0.02314f ; **FLOATING
C1145 VDD.n254 VSS 0.02314f ; **FLOATING
C1146 VDD.n255 VSS 0.02314f ; **FLOATING
C1147 VDD.n256 VSS 0.02314f ; **FLOATING
C1148 VDD.n257 VSS 0.02314f ; **FLOATING
C1149 VDD.t14 VSS 0.0414f ; **FLOATING
C1150 VDD.n258 VSS 0.03496f ; **FLOATING
C1151 VDD.n259 VSS 0.03472f ; **FLOATING
C1152 VDD.n260 VSS 0.02314f ; **FLOATING
C1153 VDD.n261 VSS 0.02314f ; **FLOATING
C1154 VDD.n262 VSS 0.02314f ; **FLOATING
C1155 VDD.n263 VSS 0.02314f ; **FLOATING
C1156 VDD.n264 VSS 0.02314f ; **FLOATING
C1157 VDD.n265 VSS 0.02314f ; **FLOATING
C1158 VDD.n266 VSS 0.02314f ; **FLOATING
C1159 VDD.n267 VSS 0.02314f ; **FLOATING
C1160 VDD.t23 VSS 0.03991f ; **FLOATING
C1161 VDD.t207 VSS 0.1373f ; **FLOATING
C1162 VDD.n268 VSS 0.02314f ; **FLOATING
C1163 VDD.n269 VSS 0.02314f ; **FLOATING
C1164 VDD.n270 VSS 0.02314f ; **FLOATING
C1165 VDD.n271 VSS 0.02314f ; **FLOATING
C1166 VDD.n272 VSS 0.02314f ; **FLOATING
C1167 VDD.n273 VSS 0.02314f ; **FLOATING
C1168 VDD.n274 VSS 0.02314f ; **FLOATING
C1169 VDD.n275 VSS 0.02314f ; **FLOATING
C1170 VDD.n276 VSS 0.02314f ; **FLOATING
C1171 VDD.n277 VSS 0.02314f ; **FLOATING
C1172 VDD.n278 VSS 0.02314f ; **FLOATING
C1173 VDD.n279 VSS 0.02314f ; **FLOATING
C1174 VDD.n280 VSS 0.02314f ; **FLOATING
C1175 VDD.n281 VSS 0.02314f ; **FLOATING
C1176 VDD.n282 VSS 0.02314f ; **FLOATING
C1177 VDD.n283 VSS 0.02314f ; **FLOATING
C1178 VDD.n284 VSS 0.02314f ; **FLOATING
C1179 VDD.n285 VSS 0.03472f ; **FLOATING
C1180 VDD.n286 VSS 0.01919f ; **FLOATING
C1181 VDD.n287 VSS 0.02314f ; **FLOATING
C1182 VDD.n288 VSS 0.02314f ; **FLOATING
C1183 VDD.n289 VSS 0.02314f ; **FLOATING
C1184 VDD.n290 VSS 0.02314f ; **FLOATING
C1185 VDD.n291 VSS 0.02314f ; **FLOATING
C1186 VDD.n292 VSS 0.02314f ; **FLOATING
C1187 VDD.n293 VSS 0.02314f ; **FLOATING
C1188 VDD.n294 VSS 0.02314f ; **FLOATING
C1189 VDD.n295 VSS 0.02314f ; **FLOATING
C1190 VDD.n296 VSS 0.02314f ; **FLOATING
C1191 VDD.n297 VSS 0.02314f ; **FLOATING
C1192 VDD.n298 VSS 0.02314f ; **FLOATING
C1193 VDD.n299 VSS 0.02314f ; **FLOATING
C1194 VDD.n300 VSS 0.02314f ; **FLOATING
C1195 VDD.n301 VSS 0.02314f ; **FLOATING
C1196 VDD.n302 VSS 0.02314f ; **FLOATING
C1197 VDD.n303 VSS 0.02314f ; **FLOATING
C1198 VDD.n304 VSS 0.03472f ; **FLOATING
C1199 VDD.n305 VSS 0.01919f ; **FLOATING
C1200 VDD.n306 VSS 0.02275f ; **FLOATING
C1201 VDD.n307 VSS 0.02275f ; **FLOATING
C1202 VDD.n308 VSS 0.02275f ; **FLOATING
C1203 VDD.n309 VSS 0.02314f ; **FLOATING
C1204 VDD.n310 VSS 0.02314f ; **FLOATING
C1205 VDD.n311 VSS 0.02314f ; **FLOATING
C1206 VDD.n312 VSS 0.02275f ; **FLOATING
C1207 VDD.n313 VSS 0.02275f ; **FLOATING
C1208 VDD.n314 VSS 0.02275f ; **FLOATING
C1209 VDD.n315 VSS 0.02314f ; **FLOATING
C1210 VDD.n316 VSS 0.02314f ; **FLOATING
C1211 VDD.n317 VSS 0.02314f ; **FLOATING
C1212 VDD.n318 VSS 0.02275f ; **FLOATING
C1213 VDD.n319 VSS 0.02275f ; **FLOATING
C1214 VDD.n320 VSS 0.02275f ; **FLOATING
C1215 VDD.n321 VSS 0.02314f ; **FLOATING
C1216 VDD.n322 VSS 0.02314f ; **FLOATING
C1217 VDD.n323 VSS 0.03472f ; **FLOATING
C1218 VDD.n324 VSS 0.01886f ; **FLOATING
C1219 VDD.n325 VSS 0.02314f ; **FLOATING
C1220 VDD.n326 VSS 0.02314f ; **FLOATING
C1221 VDD.n327 VSS 0.02314f ; **FLOATING
C1222 VDD.n328 VSS 0.02314f ; **FLOATING
C1223 VDD.n329 VSS 0.02314f ; **FLOATING
C1224 VDD.n330 VSS 0.02314f ; **FLOATING
C1225 VDD.n331 VSS 0.02314f ; **FLOATING
C1226 VDD.n332 VSS 0.02314f ; **FLOATING
C1227 VDD.n333 VSS 0.02314f ; **FLOATING
C1228 VDD.n334 VSS 0.02314f ; **FLOATING
C1229 VDD.n335 VSS 0.02314f ; **FLOATING
C1230 VDD.n336 VSS 0.02314f ; **FLOATING
C1231 VDD.n337 VSS 0.02314f ; **FLOATING
C1232 VDD.n338 VSS 0.02314f ; **FLOATING
C1233 VDD.n339 VSS 0.02314f ; **FLOATING
C1234 VDD.n340 VSS 0.02314f ; **FLOATING
C1235 VDD.n341 VSS 0.02314f ; **FLOATING
C1236 VDD.n342 VSS 0.03472f ; **FLOATING
C1237 VDD.n343 VSS 0.01919f ; **FLOATING
C1238 VDD.n344 VSS 0.02314f ; **FLOATING
C1239 VDD.n345 VSS 0.02314f ; **FLOATING
C1240 VDD.n346 VSS 0.02314f ; **FLOATING
C1241 VDD.n347 VSS 0.02314f ; **FLOATING
C1242 VDD.n348 VSS 0.02314f ; **FLOATING
C1243 VDD.n349 VSS 0.02314f ; **FLOATING
C1244 VDD.n350 VSS 0.02314f ; **FLOATING
C1245 VDD.n351 VSS 0.02314f ; **FLOATING
C1246 VDD.n352 VSS 0.02314f ; **FLOATING
C1247 VDD.n353 VSS 0.02314f ; **FLOATING
C1248 VDD.n354 VSS 0.02314f ; **FLOATING
C1249 VDD.n355 VSS 0.02314f ; **FLOATING
C1250 VDD.n356 VSS 0.02314f ; **FLOATING
C1251 VDD.n357 VSS 0.02314f ; **FLOATING
C1252 VDD.n358 VSS 0.02314f ; **FLOATING
C1253 VDD.n359 VSS 0.02314f ; **FLOATING
C1254 VDD.n360 VSS 0.02314f ; **FLOATING
C1255 VDD.n361 VSS 0.02314f ; **FLOATING
C1256 VDD.n362 VSS 0.01919f ; **FLOATING
C1257 VDD.n363 VSS 0.03472f ; **FLOATING
C1258 VDD.n364 VSS 0.03472f ; **FLOATING
C1259 VDD.n365 VSS 0.02574f ; **FLOATING
C1260 VDD.n366 VSS 0.02275f ; **FLOATING
C1261 VDD.n367 VSS 0.02275f ; **FLOATING
C1262 VDD.n368 VSS 0.02314f ; **FLOATING
C1263 VDD.n369 VSS 0.02314f ; **FLOATING
C1264 VDD.n370 VSS 0.02314f ; **FLOATING
C1265 VDD.n371 VSS 0.02275f ; **FLOATING
C1266 VDD.n372 VSS 0.02275f ; **FLOATING
C1267 VDD.n373 VSS 0.02275f ; **FLOATING
C1268 VDD.n374 VSS 0.02314f ; **FLOATING
C1269 VDD.n375 VSS 0.02314f ; **FLOATING
C1270 VDD.n376 VSS 0.02314f ; **FLOATING
C1271 VDD.n377 VSS 0.02275f ; **FLOATING
C1272 VDD.n378 VSS 0.02275f ; **FLOATING
C1273 VDD.n379 VSS 0.02275f ; **FLOATING
C1274 VDD.n380 VSS 0.02314f ; **FLOATING
C1275 VDD.n381 VSS 0.02314f ; **FLOATING
C1276 VDD.n382 VSS 0.02314f ; **FLOATING
C1277 VDD.n383 VSS 0.02275f ; **FLOATING
C1278 VDD.n384 VSS 0.02275f ; **FLOATING
C1279 VDD.n385 VSS 0.02275f ; **FLOATING
C1280 VDD.n386 VSS 0.02314f ; **FLOATING
C1281 VDD.n387 VSS 0.02314f ; **FLOATING
C1282 VDD.n388 VSS 0.02314f ; **FLOATING
C1283 VDD.n389 VSS 0.02275f ; **FLOATING
C1284 VDD.n390 VSS 0.02275f ; **FLOATING
C1285 VDD.n391 VSS 0.01886f ; **FLOATING
C1286 VDD.n392 VSS 0.03472f ; **FLOATING
C1287 VDD.n393 VSS 0.02619f ; **FLOATING
C1288 VDD.n394 VSS 0.03472f ; **FLOATING
C1289 VDD.n395 VSS 0.1415f ; **FLOATING
C1290 VDD.t82 VSS 0.0414f ; **FLOATING
C1291 VDD.n396 VSS 0.03824f ; **FLOATING
.ends
