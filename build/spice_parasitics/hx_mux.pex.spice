* NGSPICE file created from hx_mux.ext - technology: ihp-sg13g2

.subckt hx_mux DELAY_OUT_TAP0 DELAY_OUT_TAP1 DELAY_OUT_TAP2 DELAY_OUT_TAP3 DELAY_OUT_TAP4
+ DELAY_OUT_TAP5 DELAY_OUT_TAP6 DELAY_OUT_TAP7 DELAY_OUT_TAP8 DELAY_OUT_TAP9 DELAY_OUT_TAP10
+ DELAY_OUT_TAP11 DELAY_OUT_TAP12 DELAY_OUT_TAP13 DELAY_OUT_TAP14 DELAY_OUT_TAP15
+ DELAY_OUT_TAP16 DELAY_OUT_TAP17 DELAY_OUT_TAP18 DELAY_OUT_TAP19 DELAY_OUT_TAP20
+ DELAY_OUT_TAP21 DELAY_OUT_TAP22 DELAY_OUT_TAP23 DELAY_OUT_TAP24 DELAY_OUT_TAP25
+ DELAY_OUT_TAP26 DELAY_OUT_TAP27 DELAY_OUT_TAP28 DELAY_OUT_TAP29 DELAY_OUT_TAP30
+ DELAY_OUT_TAP31 VSS VDD MUX_SEL0 MUX_SEL1 MUX_OUT MUX_SEL4 MUX_SEL2 MUX_SEL3
X0 VDD.t75 a_2019_952.t9 a_4324_913# VDD.t0 sg13_lv_pmos ad=0.3808p pd=2.92u as=0.3808p ps=2.92u w=1.12u l=0.13u
X1 a_1256_194# MUX_SEL2 VDD.t170 VDD.t0 sg13_lv_pmos ad=0.3808p pd=2.92u as=0.3808p ps=2.92u w=1.12u l=0.13u
X2 VDD.t108 a_3171_952.t8 a_8884_913# VDD.t0 sg13_lv_pmos ad=0.3808p pd=2.92u as=0.3808p ps=2.92u w=1.12u l=0.13u
X3 a_16108_194# a_15765_368# a_15964_194# VDD.t0 sg13_lv_pmos ad=0.3808p pd=2.92u as=0.3304p ps=1.71u w=1.12u l=0.13u
X4 a_22590_949# a_24951_913# a_24875_949# VDD.t0 sg13_lv_pmos ad=0.3808p pd=2.92u as=0.2128p ps=1.5u w=1.12u l=0.13u
X5 VDD.t98 a_2595_952.t7 a_11271_913# VDD.t0 sg13_lv_pmos ad=0.3808p pd=2.92u as=0.3808p ps=2.92u w=1.12u l=0.13u
X6 VSS.t174 VDD.t205 VSS.t172 VSS.t173 sg13_lv_nmos ad=79.8f pd=0.8u as=0 ps=0 w=0.42u l=1u
X7 a_7390_949# a_2595_952.t8 a_8155_949# VSS.t55 sg13_lv_nmos ad=0.2516p pd=2.16u as=0.1406p ps=1.12u w=0.74u l=0.13u
X8 VSS.t177 VDD.t204 VSS.t176 VSS.t175 sg13_lv_nmos ad=0.1428p pd=1.52u as=0 ps=0 w=0.42u l=1u
X9 VDD.t96 VSS.t194 VDD.t95 VDD.t0 sg13_lv_pmos ad=0.19p pd=1.38u as=0 ps=0 w=1u l=1u
X10 VSS.t85 DELAY_OUT_TAP11 a_12505_949# VSS.t255 sg13_lv_nmos ad=0.1665p pd=1.19u as=0.2516p ps=2.16u w=0.74u l=0.13u
X11 MUX_OUT a_16851_214# VSS.t24 VSS.t23 sg13_lv_nmos ad=0.1406p pd=1.12u as=0.1371p ps=1.12u w=0.74u l=0.13u
X12 VDD.t55 a_3747_952.t9 a_6711_913# VDD.t0 sg13_lv_pmos ad=0.3808p pd=2.92u as=0.3808p ps=2.92u w=1.12u l=0.13u
X13 VSS.t242 VDD.t191 VSS.t241 VSS.t240 sg13_lv_nmos ad=0.1428p pd=1.52u as=0 ps=0 w=0.42u l=1u
X14 a_1544_194# MUX_SEL3 VDD.t57 VDD.t0 sg13_lv_pmos ad=0.3808p pd=2.92u as=0.3808p ps=2.92u w=1.12u l=0.13u
X15 VSS.t43 a_2595_216.t3 a_8745_424# VSS.t42 sg13_lv_nmos ad=0.2516p pd=2.16u as=0.2516p ps=2.16u w=0.74u l=0.13u
X16 a_10328_949# DELAY_OUT_TAP8 VSS.t123 VSS.t265 sg13_lv_nmos ad=0.1406p pd=1.12u as=0.2516p ps=2.16u w=0.74u l=0.13u
X17 a_22590_949# a_2019_952.t3 a_22488_949# VSS.t310 sg13_lv_nmos ad=0.2516p pd=2.16u as=0.1406p ps=1.12u w=0.74u l=0.13u
X18 a_8808_949# DELAY_OUT_TAP6 VSS.t57 VSS.t287 sg13_lv_nmos ad=0.1406p pd=1.12u as=0.2516p ps=2.16u w=0.74u l=0.13u
X19 VSS.t136 DELAY_OUT_TAP31 a_27705_949# VSS.t306 sg13_lv_nmos ad=0.1665p pd=1.19u as=0.2516p ps=2.16u w=0.74u l=0.13u
X20 a_11848_949# DELAY_OUT_TAP10 VDD.t137 VDD.t0 sg13_lv_pmos ad=0.2128p pd=1.5u as=0.3808p ps=2.92u w=1.12u l=0.13u
X21 VDD.t23 a_3171_952.t3 a_24084_913# VDD.t0 sg13_lv_pmos ad=0.3808p pd=2.92u as=0.3808p ps=2.92u w=1.12u l=0.13u
X22 a_1721_236# a_1256_194# VDD.t82 VDD.t0 sg13_lv_pmos ad=0.1596p pd=1.22u as=0.2856p ps=2.36u w=0.84u l=0.13u
X23 a_6635_949# a_6425_949# VSS.t150 VSS.t292 sg13_lv_nmos ad=0.1406p pd=1.12u as=0.1665p ps=1.19u w=0.74u l=0.13u
X24 VDD.t61 VSS.t211 VDD.t60 VDD.t0 sg13_lv_pmos ad=0.34p pd=2.68u as=0 ps=0 w=1u l=1u
X25 VSS.t2 a_2595_952.t9 a_5191_913# VSS.t1 sg13_lv_nmos ad=0.2516p pd=2.16u as=0.2516p ps=2.16u w=0.74u l=0.13u
X26 VSS.t261 a_1256_949# a_2967_1300# VSS.t273 sg13_lv_nmos ad=0.1331p pd=1.12u as=0.1216p ps=1.02u w=0.64u l=0.13u
X27 a_4157_1218# DELAY_OUT_TAP0 VDD.t46 VDD.t0 sg13_lv_pmos ad=0.3808p pd=2.92u as=0.3808p ps=2.92u w=1.12u l=0.13u
X28 a_25528_949# DELAY_OUT_TAP28 VSS.t297 VSS.t318 sg13_lv_nmos ad=0.1406p pd=1.12u as=0.2516p ps=2.16u w=0.74u l=0.13u
X29 a_20315_949# a_20105_949# VSS.t12 VSS.t97 sg13_lv_nmos ad=0.1406p pd=1.12u as=0.1665p ps=1.19u w=0.74u l=0.13u
X30 a_5731_194# a_3747_216.t3 a_13470_949# VSS.t257 sg13_lv_nmos ad=0.2516p pd=2.16u as=0.2516p ps=2.16u w=0.74u l=0.13u
X31 VSS.t234 VDD.t193 VSS.t232 VSS.t233 sg13_lv_nmos ad=79.8f pd=0.8u as=0 ps=0 w=0.42u l=1u
X32 VSS.t199 VDD.t200 VSS.t197 VSS.t198 sg13_lv_nmos ad=79.8f pd=0.8u as=0 ps=0 w=0.42u l=1u
X33 VSS.t26 a_16851_214# MUX_OUT VSS.t25 sg13_lv_nmos ad=0.2516p pd=2.16u as=0.1406p ps=1.12u w=0.74u l=0.13u
X34 VDD.t72 a_1544_194# a_1721_236# VDD.t0 sg13_lv_pmos ad=0.1918p pd=1.5u as=0.1596p ps=1.22u w=0.84u l=0.13u
X35 VDD.t167 a_3747_952.t3 a_24951_913# VDD.t0 sg13_lv_pmos ad=0.3808p pd=2.92u as=0.3808p ps=2.92u w=1.12u l=0.13u
X36 VDD.t35 VSS.t181 VDD.t34 VDD.t0 sg13_lv_pmos ad=0.34p pd=2.68u as=0 ps=0 w=1u l=1u
X37 a_16408_949# DELAY_OUT_TAP16 VSS.t49 VSS.t271 sg13_lv_nmos ad=0.1406p pd=1.12u as=0.2516p ps=2.16u w=0.74u l=0.13u
X38 a_5731_194# a_2019_216.t3 a_4350_949# VSS.t73 sg13_lv_nmos ad=0.2516p pd=2.16u as=0.2516p ps=2.16u w=0.74u l=0.13u
X39 VDD.t91 a_2595_952.t2 a_26471_913# VDD.t0 sg13_lv_pmos ad=0.3808p pd=2.92u as=0.3808p ps=2.92u w=1.12u l=0.13u
X40 a_7390_949# a_3747_952.t8 a_9675_949# VSS.t121 sg13_lv_nmos ad=0.2516p pd=2.16u as=0.1406p ps=1.12u w=0.74u l=0.13u
X41 VSS.t172 VDD.t205 VSS.t171 VSS.t170 sg13_lv_nmos ad=0.1428p pd=1.52u as=0 ps=0 w=0.42u l=1u
X42 VDD.t54 VSS.t254 VDD.t53 VDD.t0 sg13_lv_pmos ad=0.19p pd=1.38u as=0 ps=0 w=1u l=1u
X43 VDD.t90 DELAY_OUT_TAP13 a_14025_949# VDD.t0 sg13_lv_pmos ad=0.252p pd=1.57u as=0.3808p ps=2.92u w=1.12u l=0.13u
X44 a_10430_949# a_11924_913# a_11848_949# VDD.t0 sg13_lv_pmos ad=0.3808p pd=2.92u as=0.2128p ps=1.5u w=1.12u l=0.13u
X45 VDD.t41 a_2595_216.t3 a_8745_424# VDD.t0 sg13_lv_pmos ad=0.3808p pd=2.92u as=0.3808p ps=2.92u w=1.12u l=0.13u
X46 VSS.t46 a_3171_952.t5 a_18004_913# VSS.t45 sg13_lv_nmos ad=0.2516p pd=2.16u as=0.2516p ps=2.16u w=0.74u l=0.13u
X47 VDD.t118 DELAY_OUT_TAP15 a_15545_949# VDD.t0 sg13_lv_pmos ad=0.252p pd=1.57u as=0.3808p ps=2.92u w=1.12u l=0.13u
X48 a_3171_216.t1 a_2873_236# VDD.t81 VDD.t0 sg13_lv_pmos ad=0.2128p pd=1.5u as=0.1918p ps=1.5u w=1.12u l=0.13u
X49 a_14235_949# a_14025_949# VSS.t70 VSS.t116 sg13_lv_nmos ad=0.1406p pd=1.12u as=0.1665p ps=1.19u w=0.74u l=0.13u
X50 VSS.t6 a_3747_952.t7 a_12791_913# VSS.t5 sg13_lv_nmos ad=0.2516p pd=2.16u as=0.2516p ps=2.16u w=0.74u l=0.13u
X51 a_3747_216.t1 a_3449_236# VDD.t17 VDD.t0 sg13_lv_pmos ad=0.2128p pd=1.5u as=0.1918p ps=1.5u w=1.12u l=0.13u
X52 a_12715_949# a_12505_949# VDD.t80 VDD.t0 sg13_lv_pmos ad=0.2128p pd=1.5u as=0.252p ps=1.57u w=1.12u l=0.13u
X53 a_11848_949# DELAY_OUT_TAP10 VSS.t126 VSS.t256 sg13_lv_nmos ad=0.1406p pd=1.12u as=0.2516p ps=2.16u w=0.74u l=0.13u
X54 a_17275_949# a_17065_949# VDD.t117 VDD.t0 sg13_lv_pmos ad=0.2128p pd=1.5u as=0.252p ps=1.57u w=1.12u l=0.13u
X55 VDD.t47 VSS.t174 VDD.t74 VDD.t0 sg13_lv_pmos ad=0.19p pd=1.38u as=0 ps=0 w=1u l=1u
X56 VDD.t186 VSS.t176 VDD.t33 VDD.t0 sg13_lv_pmos ad=0.34p pd=2.68u as=0 ps=0 w=1u l=1u
X57 a_10430_949# a_12791_913# a_12715_949# VDD.t0 sg13_lv_pmos ad=0.3808p pd=2.92u as=0.2128p ps=1.5u w=1.12u l=0.13u
X58 VSS.t12 DELAY_OUT_TAP21 a_20105_949# VSS.t291 sg13_lv_nmos ad=0.1665p pd=1.19u as=0.2516p ps=2.16u w=0.74u l=0.13u
X59 a_16510_949# a_17351_913# a_17275_949# VDD.t0 sg13_lv_pmos ad=0.3808p pd=2.92u as=0.2128p ps=1.5u w=1.12u l=0.13u
X60 VSS.t282 a_1721_1300# a_2019_952.t0 VSS.t281 sg13_lv_nmos ad=0.2812p pd=2.24u as=0.1406p ps=1.12u w=0.74u l=0.13u
X61 a_5731_194# a_14825_424# a_13470_949# VDD.t0 sg13_lv_pmos ad=0.3808p pd=2.92u as=0.3808p ps=2.92u w=1.12u l=0.13u
X62 a_16510_949# a_2595_952.t5 a_17275_949# VSS.t16 sg13_lv_nmos ad=0.2516p pd=2.16u as=0.1406p ps=1.12u w=0.74u l=0.13u
X63 a_8155_949# a_7945_949# VDD.t132 VDD.t0 sg13_lv_pmos ad=0.2128p pd=1.5u as=0.252p ps=1.57u w=1.12u l=0.13u
X64 VDD.t36 VSS.t241 VDD.t38 VDD.t0 sg13_lv_pmos ad=0.34p pd=2.68u as=0 ps=0 w=1u l=1u
X65 VSS.t37 a_3747_952.t2 a_27991_913# VSS.t36 sg13_lv_nmos ad=0.2516p pd=2.16u as=0.2516p ps=2.16u w=0.74u l=0.13u
X66 VSS.t60 a_3747_952.t9 a_6711_913# VSS.t59 sg13_lv_nmos ad=0.2516p pd=2.16u as=0.2516p ps=2.16u w=0.74u l=0.13u
X67 a_16108_194# a_2595_216.t2 a_19550_949# VSS.t302 sg13_lv_nmos ad=0.2516p pd=2.16u as=0.2516p ps=2.16u w=0.74u l=0.13u
X68 VSS.t232 VDD.t193 VSS.t231 VSS.t230 sg13_lv_nmos ad=0.1428p pd=1.52u as=0 ps=0 w=0.42u l=1u
X69 a_7390_949# a_8231_913# a_8155_949# VDD.t0 sg13_lv_pmos ad=0.3808p pd=2.92u as=0.2128p ps=1.5u w=1.12u l=0.13u
X70 VSS.t197 VDD.t200 VSS.t196 VSS.t195 sg13_lv_nmos ad=0.1428p pd=1.52u as=0 ps=0 w=0.42u l=1u
X71 a_3171_216.t0 a_2873_236# VSS.t104 VSS.t105 sg13_lv_nmos ad=0.1406p pd=1.12u as=0.1331p ps=1.12u w=0.74u l=0.13u
X72 a_5731_194# a_5705_424# a_4350_949# VDD.t0 sg13_lv_pmos ad=0.3808p pd=2.92u as=0.3808p ps=2.92u w=1.12u l=0.13u
X73 VDD.t84 a_2873_236# a_3171_216.t1 VDD.t0 sg13_lv_pmos ad=0.4256p pd=3u as=0.2128p ps=1.5u w=1.12u l=0.13u
X74 a_3747_216.t0 a_3449_236# VSS.t20 VSS.t19 sg13_lv_nmos ad=0.1406p pd=1.12u as=0.1331p ps=1.12u w=0.74u l=0.13u
X75 VDD.t18 a_3449_236# a_3747_216.t1 VDD.t0 sg13_lv_pmos ad=0.4256p pd=3u as=0.2128p ps=1.5u w=1.12u l=0.13u
X76 a_7390_949# a_2019_952.t8 a_7288_949# VSS.t86 sg13_lv_nmos ad=0.2516p pd=2.16u as=0.1406p ps=1.12u w=0.74u l=0.13u
X77 VDD.t77 DELAY_OUT_TAP21 a_20105_949# VDD.t0 sg13_lv_pmos ad=0.252p pd=1.57u as=0.3808p ps=2.92u w=1.12u l=0.13u
X78 a_19550_949# a_21044_913# a_20968_949# VDD.t0 sg13_lv_pmos ad=0.3808p pd=2.92u as=0.2128p ps=1.5u w=1.12u l=0.13u
X79 VDD.t30 VSS.t234 VDD.t29 VDD.t0 sg13_lv_pmos ad=0.19p pd=1.38u as=0 ps=0 w=1u l=1u
X80 VDD.t2 VSS.t199 VDD.t1 VDD.t0 sg13_lv_pmos ad=0.19p pd=1.38u as=0 ps=0 w=1u l=1u
X81 VDD.t70 a_3171_952.t7 a_11924_913# VDD.t0 sg13_lv_pmos ad=0.3808p pd=2.92u as=0.3808p ps=2.92u w=1.12u l=0.13u
X82 VSS.t12 a_2019_952.t4 a_19524_913# VSS.t11 sg13_lv_nmos ad=0.2516p pd=2.16u as=0.2516p ps=2.16u w=0.74u l=0.13u
X83 a_15755_949# a_15545_949# VSS.t15 VSS.t146 sg13_lv_nmos ad=0.1406p pd=1.12u as=0.1665p ps=1.19u w=0.74u l=0.13u
X84 VSS.t54 a_2595_952.t6 a_14311_913# VSS.t53 sg13_lv_nmos ad=0.2516p pd=2.16u as=0.2516p ps=2.16u w=0.74u l=0.13u
X85 a_5115_949# a_4905_949# VSS.t94 VSS.t140 sg13_lv_nmos ad=0.1406p pd=1.12u as=0.1665p ps=1.19u w=0.74u l=0.13u
X86 a_27915_949# a_27705_949# VDD.t110 VDD.t0 sg13_lv_pmos ad=0.2128p pd=1.5u as=0.252p ps=1.57u w=1.12u l=0.13u
X87 VSS.t189 VDD.t202 VSS.t187 VSS.t188 sg13_lv_nmos ad=79.8f pd=0.8u as=0 ps=0 w=0.42u l=1u
X88 a_23355_949# a_23145_949# VDD.t107 VDD.t0 sg13_lv_pmos ad=0.2128p pd=1.5u as=0.252p ps=1.57u w=1.12u l=0.13u
X89 VDD.t71 a_2019_952.t8 a_7364_913# VDD.t0 sg13_lv_pmos ad=0.3808p pd=2.92u as=0.3808p ps=2.92u w=1.12u l=0.13u
X90 VSS.t107 a_2873_236# a_3171_216.t0 VSS.t106 sg13_lv_nmos ad=0.2812p pd=2.24u as=0.1406p ps=1.12u w=0.74u l=0.13u
X91 VDD.t48 VSS.t171 VDD.t47 VDD.t0 sg13_lv_pmos ad=0.34p pd=2.68u as=0 ps=0 w=1u l=1u
X92 a_25630_949# a_27991_913# a_27915_949# VDD.t0 sg13_lv_pmos ad=0.3808p pd=2.92u as=0.2128p ps=1.5u w=1.12u l=0.13u
X93 VSS.t22 a_3449_236# a_3747_216.t0 VSS.t21 sg13_lv_nmos ad=0.2812p pd=2.24u as=0.1406p ps=1.12u w=0.74u l=0.13u
X94 VSS.t28 DELAY_OUT_TAP23 a_21625_949# VSS.t27 sg13_lv_nmos ad=0.1665p pd=1.19u as=0.2516p ps=2.16u w=0.74u l=0.13u
X95 a_22590_949# a_23431_913# a_23355_949# VDD.t0 sg13_lv_pmos ad=0.3808p pd=2.92u as=0.2128p ps=1.5u w=1.12u l=0.13u
X96 a_16108_194# a_20905_424# a_19550_949# VDD.t0 sg13_lv_pmos ad=0.3808p pd=2.92u as=0.3808p ps=2.92u w=1.12u l=0.13u
X97 VDD.t51 a_2595_952.t6 a_14311_913# VDD.t0 sg13_lv_pmos ad=0.3808p pd=2.92u as=0.3808p ps=2.92u w=1.12u l=0.13u
X98 VSS.t94 a_2019_952.t9 a_4324_913# VSS.t93 sg13_lv_nmos ad=0.2516p pd=2.16u as=0.2516p ps=2.16u w=0.74u l=0.13u
X99 a_16510_949# a_3747_952.t5 a_18795_949# VSS.t127 sg13_lv_nmos ad=0.2516p pd=2.16u as=0.1406p ps=1.12u w=0.74u l=0.13u
X100 VDD.t106 a_3747_952.t5 a_18871_913# VDD.t0 sg13_lv_pmos ad=0.3808p pd=2.92u as=0.3808p ps=2.92u w=1.12u l=0.13u
X101 VSS.t139 a_3171_216.t3 a_11785_424# VSS.t138 sg13_lv_nmos ad=0.2516p pd=2.16u as=0.2516p ps=2.16u w=0.74u l=0.13u
X102 VDD.t97 a_3747_952.t8 a_9751_913# VDD.t0 sg13_lv_pmos ad=0.3808p pd=2.92u as=0.3808p ps=2.92u w=1.12u l=0.13u
X103 VDD.t3 a_2595_952.t9 a_5191_913# VDD.t0 sg13_lv_pmos ad=0.3808p pd=2.92u as=0.3808p ps=2.92u w=1.12u l=0.13u
X104 a_10430_949# a_2019_952.t7 a_10328_949# VSS.t312 sg13_lv_nmos ad=0.2516p pd=2.16u as=0.1406p ps=1.12u w=0.74u l=0.13u
X105 a_4157_1218# DELAY_OUT_TAP0 VSS.t51 VSS.t50 sg13_lv_nmos ad=0.2516p pd=2.16u as=0.2553p ps=2.17u w=0.74u l=0.13u
X106 a_7390_949# a_3171_952.t8 a_8808_949# VSS.t132 sg13_lv_nmos ad=0.2516p pd=2.16u as=0.1406p ps=1.12u w=0.74u l=0.13u
X107 VSS.t15 DELAY_OUT_TAP15 a_15545_949# VSS.t294 sg13_lv_nmos ad=0.1665p pd=1.19u as=0.2516p ps=2.16u w=0.74u l=0.13u
X108 VDD.t175 a_2019_952.t3 a_22564_913# VDD.t0 sg13_lv_pmos ad=0.3808p pd=2.92u as=0.3808p ps=2.92u w=1.12u l=0.13u
X109 a_14888_949# DELAY_OUT_TAP14 VDD.t162 VDD.t0 sg13_lv_pmos ad=0.2128p pd=1.5u as=0.3808p ps=2.92u w=1.12u l=0.13u
X110 VSS.t85 a_3171_952.t7 a_11924_913# VSS.t84 sg13_lv_nmos ad=0.2516p pd=2.16u as=0.2516p ps=2.16u w=0.74u l=0.13u
X111 VDD.t103 VSS.t231 VDD.t30 VDD.t0 sg13_lv_pmos ad=0.34p pd=2.68u as=0 ps=0 w=1u l=1u
X112 VDD.t179 a_3171_952.t2 a_27124_913# VDD.t0 sg13_lv_pmos ad=0.3808p pd=2.92u as=0.3808p ps=2.92u w=1.12u l=0.13u
X113 a_10328_949# DELAY_OUT_TAP8 VDD.t142 VDD.t0 sg13_lv_pmos ad=0.2128p pd=1.5u as=0.3808p ps=2.92u w=1.12u l=0.13u
X114 a_19448_949# DELAY_OUT_TAP20 VDD.t160 VDD.t0 sg13_lv_pmos ad=0.2128p pd=1.5u as=0.3808p ps=2.92u w=1.12u l=0.13u
X115 VDD.t2 VSS.t196 VDD.t99 VDD.t0 sg13_lv_pmos ad=0.34p pd=2.68u as=0 ps=0 w=1u l=1u
X116 a_3171_952.t0 a_2873_1300# VSS.t261 VSS.t260 sg13_lv_nmos ad=0.1406p pd=1.12u as=0.1331p ps=1.12u w=0.74u l=0.13u
X117 a_25630_949# a_2019_952.t2 a_25528_949# VSS.t38 sg13_lv_nmos ad=0.2516p pd=2.16u as=0.1406p ps=1.12u w=0.74u l=0.13u
X118 VSS.t276 a_2297_1300# a_2595_952.t0 VSS.t275 sg13_lv_nmos ad=0.2812p pd=2.24u as=0.1406p ps=1.12u w=0.74u l=0.13u
X119 a_16108_194# a_2019_216.t2 a_16510_949# VSS.t112 sg13_lv_nmos ad=0.2516p pd=2.16u as=0.2516p ps=2.16u w=0.74u l=0.13u
X120 a_2391_1300# MUX_SEL0 a_2297_1300# VSS.t163 sg13_lv_nmos ad=0.1216p pd=1.02u as=0.2176p ps=1.96u w=0.64u l=0.13u
X121 VSS.t249 VDD.t190 VSS.t247 VSS.t248 sg13_lv_nmos ad=79.8f pd=0.8u as=0 ps=0 w=0.42u l=1u
X122 VSS.t267 a_1544_949# a_1815_1300# VSS.t266 sg13_lv_nmos ad=0.1331p pd=1.12u as=0.1216p ps=1.02u w=0.64u l=0.13u
X123 a_5768_949# DELAY_OUT_TAP2 VDD.t127 VDD.t0 sg13_lv_pmos ad=0.2128p pd=1.5u as=0.3808p ps=2.92u w=1.12u l=0.13u
X124 VSS.t252 VDD.t189 VSS.t251 VSS.t250 sg13_lv_nmos ad=0.1428p pd=1.52u as=0 ps=0 w=0.42u l=1u
X125 a_16510_949# a_2019_952.t5 a_16408_949# VSS.t61 sg13_lv_nmos ad=0.2516p pd=2.16u as=0.1406p ps=1.12u w=0.74u l=0.13u
X126 VDD.t9 a_2595_952.t4 a_20391_913# VDD.t0 sg13_lv_pmos ad=0.3808p pd=2.92u as=0.3808p ps=2.92u w=1.12u l=0.13u
X127 VSS.t136 a_3171_952.t2 a_27124_913# VSS.t315 sg13_lv_nmos ad=0.2516p pd=2.16u as=0.2516p ps=2.16u w=0.74u l=0.13u
X128 a_5731_194# a_2595_216.t3 a_7390_949# VSS.t41 sg13_lv_nmos ad=0.2516p pd=2.16u as=0.2516p ps=2.16u w=0.74u l=0.13u
X129 VDD.t112 a_3171_216.t3 a_11785_424# VDD.t0 sg13_lv_pmos ad=0.3808p pd=2.92u as=0.3808p ps=2.92u w=1.12u l=0.13u
X130 a_10430_949# a_2595_952.t7 a_11195_949# VSS.t124 sg13_lv_nmos ad=0.2516p pd=2.16u as=0.1406p ps=1.12u w=0.74u l=0.13u
X131 a_23355_949# a_23145_949# VSS.t131 VSS.t147 sg13_lv_nmos ad=0.1406p pd=1.12u as=0.1665p ps=1.19u w=0.74u l=0.13u
X132 VSS.t169 VDD.t206 VSS.t167 VSS.t168 sg13_lv_nmos ad=79.8f pd=0.8u as=0 ps=0 w=0.42u l=1u
X133 VSS.t34 a_3747_952.t4 a_21911_913# VSS.t33 sg13_lv_nmos ad=0.2516p pd=2.16u as=0.2516p ps=2.16u w=0.74u l=0.13u
X134 VSS.t286 a_3747_216.t2 a_26985_424# VSS.t285 sg13_lv_nmos ad=0.2516p pd=2.16u as=0.2516p ps=2.16u w=0.74u l=0.13u
X135 a_20968_949# DELAY_OUT_TAP22 VSS.t9 VSS.t100 sg13_lv_nmos ad=0.1406p pd=1.12u as=0.2516p ps=2.16u w=0.74u l=0.13u
X136 VDD.t44 VSS.t189 VDD.t43 VDD.t0 sg13_lv_pmos ad=0.19p pd=1.38u as=0 ps=0 w=1u l=1u
X137 a_13470_949# a_14964_913# a_14888_949# VDD.t0 sg13_lv_pmos ad=0.3808p pd=2.92u as=0.2128p ps=1.5u w=1.12u l=0.13u
X138 VDD.t89 DELAY_OUT_TAP19 a_18585_949# VDD.t0 sg13_lv_pmos ad=0.252p pd=1.57u as=0.3808p ps=2.92u w=1.12u l=0.13u
X139 a_10430_949# a_10404_913# a_10328_949# VDD.t0 sg13_lv_pmos ad=0.3808p pd=2.92u as=0.2128p ps=1.5u w=1.12u l=0.13u
X140 a_19550_949# a_19524_913# a_19448_949# VDD.t0 sg13_lv_pmos ad=0.3808p pd=2.92u as=0.2128p ps=1.5u w=1.12u l=0.13u
X141 a_2595_216.t1 a_2297_236# VDD.t65 VDD.t0 sg13_lv_pmos ad=0.2128p pd=1.5u as=0.1918p ps=1.5u w=1.12u l=0.13u
X142 a_19448_949# DELAY_OUT_TAP20 VSS.t129 VSS.t288 sg13_lv_nmos ad=0.1406p pd=1.12u as=0.2516p ps=2.16u w=0.74u l=0.13u
X143 a_10430_949# a_3171_952.t7 a_11848_949# VSS.t83 sg13_lv_nmos ad=0.2516p pd=2.16u as=0.1406p ps=1.12u w=0.74u l=0.13u
X144 a_11195_949# a_10985_949# VDD.t78 VDD.t0 sg13_lv_pmos ad=0.2128p pd=1.5u as=0.252p ps=1.57u w=1.12u l=0.13u
X145 a_25630_949# a_2595_952.t2 a_26395_949# VSS.t117 sg13_lv_nmos ad=0.2516p pd=2.16u as=0.1406p ps=1.12u w=0.74u l=0.13u
X146 VDD.t86 a_1721_236# a_2019_216.t1 VDD.t0 sg13_lv_pmos ad=0.4256p pd=3u as=0.2128p ps=1.5u w=1.12u l=0.13u
X147 VDD.t113 DELAY_OUT_TAP1 a_4905_949# VDD.t0 sg13_lv_pmos ad=0.252p pd=1.57u as=0.3808p ps=2.92u w=1.12u l=0.13u
X148 VSS.t209 VDD.t198 VSS.t207 VSS.t208 sg13_lv_nmos ad=79.8f pd=0.8u as=0 ps=0 w=0.42u l=1u
X149 VDD.t66 a_2297_236# a_2595_216.t1 VDD.t0 sg13_lv_pmos ad=0.4256p pd=3u as=0.2128p ps=1.5u w=1.12u l=0.13u
X150 a_4350_949# a_5844_913# a_5768_949# VDD.t0 sg13_lv_pmos ad=0.3808p pd=2.92u as=0.2128p ps=1.5u w=1.12u l=0.13u
X151 a_3449_1300# MUX_SEL0 VDD.t133 VDD.t0 sg13_lv_pmos ad=0.1596p pd=1.22u as=0.2856p ps=2.36u w=0.84u l=0.13u
X152 VDD.t157 DELAY_OUT_TAP7 a_9465_949# VDD.t0 sg13_lv_pmos ad=0.252p pd=1.57u as=0.3808p ps=2.92u w=1.12u l=0.13u
X153 VSS.t150 DELAY_OUT_TAP3 a_6425_949# VSS.t149 sg13_lv_nmos ad=0.1665p pd=1.19u as=0.2516p ps=2.16u w=0.74u l=0.13u
X154 a_10430_949# a_11271_913# a_11195_949# VDD.t0 sg13_lv_pmos ad=0.3808p pd=2.92u as=0.2128p ps=1.5u w=1.12u l=0.13u
X155 a_20968_949# DELAY_OUT_TAP22 VDD.t79 VDD.t0 sg13_lv_pmos ad=0.2128p pd=1.5u as=0.3808p ps=2.92u w=1.12u l=0.13u
X156 VSS.t70 a_2019_952.t6 a_13444_913# VSS.t69 sg13_lv_nmos ad=0.2516p pd=2.16u as=0.2516p ps=2.16u w=0.74u l=0.13u
X157 a_16108_194# a_17865_424# a_16510_949# VDD.t0 sg13_lv_pmos ad=0.3808p pd=2.92u as=0.3808p ps=2.92u w=1.12u l=0.13u
X158 VSS.t24 a_15964_194# a_16851_214# VSS.t152 sg13_lv_nmos ad=0.1371p pd=1.12u as=0.2176p ps=1.96u w=0.64u l=0.13u
X159 a_25528_949# DELAY_OUT_TAP28 VDD.t181 VDD.t0 sg13_lv_pmos ad=0.2128p pd=1.5u as=0.3808p ps=2.92u w=1.12u l=0.13u
X160 VDD.t139 a_1256_949# a_2873_1300# VDD.t0 sg13_lv_pmos ad=0.1918p pd=1.5u as=0.1596p ps=1.22u w=0.84u l=0.13u
X161 a_4248_949# a_4157_1218# VSS.t96 VSS.t95 sg13_lv_nmos ad=0.1406p pd=1.12u as=0.2516p ps=2.16u w=0.74u l=0.13u
X162 a_16108_194# a_3171_216.t2 a_22590_949# VSS.t80 sg13_lv_nmos ad=0.2516p pd=2.16u as=0.2516p ps=2.16u w=0.74u l=0.13u
X163 VSS.t229 VDD.t194 VSS.t227 VSS.t228 sg13_lv_nmos ad=79.8f pd=0.8u as=0 ps=0 w=0.42u l=1u
X164 a_19550_949# a_3747_952.t4 a_21835_949# VSS.t32 sg13_lv_nmos ad=0.2516p pd=2.16u as=0.1406p ps=1.12u w=0.74u l=0.13u
X165 VSS.t131 DELAY_OUT_TAP25 a_23145_949# VSS.t130 sg13_lv_nmos ad=0.1665p pd=1.19u as=0.2516p ps=2.16u w=0.74u l=0.13u
X166 a_5731_194# a_8745_424# a_7390_949# VDD.t0 sg13_lv_pmos ad=0.3808p pd=2.92u as=0.3808p ps=2.92u w=1.12u l=0.13u
X167 a_2595_216.t0 a_2297_236# VSS.t77 VSS.t76 sg13_lv_nmos ad=0.1406p pd=1.12u as=0.1331p ps=1.12u w=0.74u l=0.13u
X168 VDD.t158 a_3747_216.t2 a_26985_424# VDD.t0 sg13_lv_pmos ad=0.3808p pd=2.92u as=0.3808p ps=2.92u w=1.12u l=0.13u
X169 a_10430_949# a_3747_952.t7 a_12715_949# VSS.t4 sg13_lv_nmos ad=0.2516p pd=2.16u as=0.1406p ps=1.12u w=0.74u l=0.13u
X170 VSS.t110 a_1721_236# a_2019_216.t0 VSS.t109 sg13_lv_nmos ad=0.2812p pd=2.24u as=0.1406p ps=1.12u w=0.74u l=0.13u
X171 a_24875_949# a_24665_949# VSS.t31 VSS.t323 sg13_lv_nmos ad=0.1406p pd=1.12u as=0.1665p ps=1.19u w=0.74u l=0.13u
X172 VSS.t79 a_2297_236# a_2595_216.t0 VSS.t78 sg13_lv_nmos ad=0.2812p pd=2.24u as=0.1406p ps=1.12u w=0.74u l=0.13u
X173 VSS.t72 a_2595_952.t3 a_23431_913# VSS.t317 sg13_lv_nmos ad=0.2516p pd=2.16u as=0.2516p ps=2.16u w=0.74u l=0.13u
X174 VDD.t114 MUX_SEL1 a_3449_1300# VDD.t0 sg13_lv_pmos ad=0.1918p pd=1.5u as=0.1596p ps=1.22u w=0.84u l=0.13u
X175 VSS.t167 VDD.t206 VSS.t166 VSS.t165 sg13_lv_nmos ad=0.1428p pd=1.52u as=0 ps=0 w=0.42u l=1u
X176 VSS.t70 DELAY_OUT_TAP13 a_14025_949# VSS.t270 sg13_lv_nmos ad=0.1665p pd=1.19u as=0.2516p ps=2.16u w=0.74u l=0.13u
X177 a_22590_949# a_24084_913# a_24008_949# VDD.t0 sg13_lv_pmos ad=0.3808p pd=2.92u as=0.2128p ps=1.5u w=1.12u l=0.13u
X178 VDD.t27 VSS.t249 VDD.t26 VDD.t0 sg13_lv_pmos ad=0.19p pd=1.38u as=0 ps=0 w=1u l=1u
X179 VDD.t165 DELAY_OUT_TAP27 a_24665_949# VDD.t0 sg13_lv_pmos ad=0.252p pd=1.57u as=0.3808p ps=2.92u w=1.12u l=0.13u
X180 VDD.t11 a_3171_952.t6 a_14964_913# VDD.t0 sg13_lv_pmos ad=0.3808p pd=2.92u as=0.3808p ps=2.92u w=1.12u l=0.13u
X181 a_25630_949# a_25604_913# a_25528_949# VDD.t0 sg13_lv_pmos ad=0.3808p pd=2.92u as=0.2128p ps=1.5u w=1.12u l=0.13u
X182 a_3171_952.t1 a_2873_1300# VDD.t139 VDD.t0 sg13_lv_pmos ad=0.2128p pd=1.5u as=0.1918p ps=1.5u w=1.12u l=0.13u
X183 a_3747_952.t1 a_3449_1300# VDD.t114 VDD.t0 sg13_lv_pmos ad=0.2128p pd=1.5u as=0.1918p ps=1.5u w=1.12u l=0.13u
X184 VDD.t54 VSS.t252 VDD.t177 VDD.t0 sg13_lv_pmos ad=0.34p pd=2.68u as=0 ps=0 w=1u l=1u
X185 VDD.t56 a_2019_952.t5 a_16484_913# VDD.t0 sg13_lv_pmos ad=0.3808p pd=2.92u as=0.3808p ps=2.92u w=1.12u l=0.13u
X186 a_22590_949# a_3171_952.t3 a_24008_949# VSS.t29 sg13_lv_nmos ad=0.2516p pd=2.16u as=0.1406p ps=1.12u w=0.74u l=0.13u
X187 VDD.t19 a_15964_194# a_16851_214# VDD.t0 sg13_lv_pmos ad=0.2086p pd=1.5u as=0.34p ps=2.68u w=1u l=0.13u
X188 a_26395_949# a_26185_949# VDD.t87 VDD.t0 sg13_lv_pmos ad=0.2128p pd=1.5u as=0.252p ps=1.57u w=1.12u l=0.13u
X189 a_3747_952.t0 a_3449_1300# VSS.t142 VSS.t141 sg13_lv_nmos ad=0.1406p pd=1.12u as=0.1331p ps=1.12u w=0.74u l=0.13u
X190 a_25630_949# a_3747_952.t2 a_27915_949# VSS.t35 sg13_lv_nmos ad=0.2516p pd=2.16u as=0.1406p ps=1.12u w=0.74u l=0.13u
X191 VSS.t224 VDD.t195 VSS.t222 VSS.t223 sg13_lv_nmos ad=79.8f pd=0.8u as=0 ps=0 w=0.42u l=1u
X192 VDD.t5 VSS.t169 VDD.t4 VDD.t0 sg13_lv_pmos ad=0.19p pd=1.38u as=0 ps=0 w=1u l=1u
X193 a_2967_1300# MUX_SEL1 a_2873_1300# VSS.t157 sg13_lv_nmos ad=0.1216p pd=1.02u as=0.2176p ps=1.96u w=0.64u l=0.13u
X194 VDD.t184 a_3171_952.t9 a_5844_913# VDD.t0 sg13_lv_pmos ad=0.3808p pd=2.92u as=0.3808p ps=2.92u w=1.12u l=0.13u
X195 VSS.t219 VDD.t196 VSS.t217 VSS.t218 sg13_lv_nmos ad=79.8f pd=0.8u as=0 ps=0 w=0.42u l=1u
X196 VSS.t192 VDD.t201 VSS.t191 VSS.t190 sg13_lv_nmos ad=0.1428p pd=1.52u as=0 ps=0 w=0.42u l=1u
X197 a_25630_949# a_26471_913# a_26395_949# VDD.t0 sg13_lv_pmos ad=0.3808p pd=2.92u as=0.2128p ps=1.5u w=1.12u l=0.13u
X198 a_3543_236# MUX_SEL2 a_3449_236# VSS.t301 sg13_lv_nmos ad=0.1216p pd=1.02u as=0.2176p ps=1.96u w=0.64u l=0.13u
X199 a_16108_194# a_23945_424# a_22590_949# VDD.t0 sg13_lv_pmos ad=0.3808p pd=2.92u as=0.3808p ps=2.92u w=1.12u l=0.13u
X200 VDD.t12 a_2595_952.t5 a_17351_913# VDD.t0 sg13_lv_pmos ad=0.3808p pd=2.92u as=0.3808p ps=2.92u w=1.12u l=0.13u
X201 VDD.t8 a_3747_952.t7 a_12791_913# VDD.t0 sg13_lv_pmos ad=0.3808p pd=2.92u as=0.3808p ps=2.92u w=1.12u l=0.13u
X202 a_8155_949# a_7945_949# VSS.t88 VSS.t279 sg13_lv_nmos ad=0.1406p pd=1.12u as=0.1665p ps=1.19u w=0.74u l=0.13u
X203 a_27048_949# DELAY_OUT_TAP30 VSS.t40 VSS.t153 sg13_lv_nmos ad=0.1406p pd=1.12u as=0.2516p ps=2.16u w=0.74u l=0.13u
X204 a_5768_949# DELAY_OUT_TAP2 VSS.t2 VSS.t154 sg13_lv_nmos ad=0.1406p pd=1.12u as=0.2516p ps=2.16u w=0.74u l=0.13u
X205 VSS.t259 a_3747_216.t3 a_14825_424# VSS.t258 sg13_lv_nmos ad=0.2516p pd=2.16u as=0.2516p ps=2.16u w=0.74u l=0.13u
X206 VSS.t104 a_1256_194# a_2967_236# VSS.t103 sg13_lv_nmos ad=0.1331p pd=1.12u as=0.1216p ps=1.02u w=0.64u l=0.13u
X207 VSS.t227 VDD.t194 VSS.t226 VSS.t225 sg13_lv_nmos ad=0.1428p pd=1.52u as=0 ps=0 w=0.42u l=1u
X208 VDD.t7 VSS.t209 VDD.t6 VDD.t0 sg13_lv_pmos ad=0.19p pd=1.38u as=0 ps=0 w=1u l=1u
X209 VDD.t140 a_2873_1300# a_3171_952.t1 VDD.t0 sg13_lv_pmos ad=0.4256p pd=3u as=0.2128p ps=1.5u w=1.12u l=0.13u
X210 VSS.t31 DELAY_OUT_TAP27 a_24665_949# VSS.t293 sg13_lv_nmos ad=0.1665p pd=1.19u as=0.2516p ps=2.16u w=0.74u l=0.13u
X211 VDD.t52 a_2595_952.t8 a_8231_913# VDD.t0 sg13_lv_pmos ad=0.3808p pd=2.92u as=0.3808p ps=2.92u w=1.12u l=0.13u
X212 a_16510_949# a_3171_952.t5 a_17928_949# VSS.t44 sg13_lv_nmos ad=0.2516p pd=2.16u as=0.1406p ps=1.12u w=0.74u l=0.13u
X213 VDD.t115 a_3449_1300# a_3747_952.t1 VDD.t0 sg13_lv_pmos ad=0.4256p pd=3u as=0.2128p ps=1.5u w=1.12u l=0.13u
X214 VSS.t28 a_3171_952.t4 a_21044_913# VSS.t120 sg13_lv_nmos ad=0.2516p pd=2.16u as=0.2516p ps=2.16u w=0.74u l=0.13u
X215 VDD.t14 VSS.t229 VDD.t21 VDD.t0 sg13_lv_pmos ad=0.19p pd=1.38u as=0 ps=0 w=1u l=1u
X216 VSS.t20 MUX_SEL3 a_3543_236# VSS.t67 sg13_lv_nmos ad=0.1331p pd=1.12u as=0.1216p ps=1.02u w=0.64u l=0.13u
X217 VDD.t94 a_3171_952.t4 a_21044_913# VDD.t0 sg13_lv_pmos ad=0.3808p pd=2.92u as=0.3808p ps=2.92u w=1.12u l=0.13u
X218 a_13368_949# DELAY_OUT_TAP12 VDD.t141 VDD.t0 sg13_lv_pmos ad=0.2128p pd=1.5u as=0.3808p ps=2.92u w=1.12u l=0.13u
X219 VSS.t263 a_2873_1300# a_3171_952.t0 VSS.t262 sg13_lv_nmos ad=0.2812p pd=2.24u as=0.1406p ps=1.12u w=0.74u l=0.13u
X220 a_13368_949# DELAY_OUT_TAP12 VSS.t6 VSS.t264 sg13_lv_nmos ad=0.1406p pd=1.12u as=0.2516p ps=2.16u w=0.74u l=0.13u
X221 a_5731_194# a_3171_216.t3 a_10430_949# VSS.t137 sg13_lv_nmos ad=0.2516p pd=2.16u as=0.2516p ps=2.16u w=0.74u l=0.13u
X222 VSS.t269 a_1544_949# a_2391_1300# VSS.t268 sg13_lv_nmos ad=0.1331p pd=1.12u as=0.1216p ps=1.02u w=0.64u l=0.13u
X223 a_2019_952.t0 a_1721_1300# VSS.t267 VSS.t280 sg13_lv_nmos ad=0.1406p pd=1.12u as=0.1331p ps=1.12u w=0.74u l=0.13u
X224 a_4350_949# a_3747_952.t9 a_6635_949# VSS.t58 sg13_lv_nmos ad=0.2516p pd=2.16u as=0.1406p ps=1.12u w=0.74u l=0.13u
X225 a_19550_949# a_2595_952.t4 a_20315_949# VSS.t7 sg13_lv_nmos ad=0.2516p pd=2.16u as=0.1406p ps=1.12u w=0.74u l=0.13u
X226 a_8808_949# DELAY_OUT_TAP6 VDD.t159 VDD.t0 sg13_lv_pmos ad=0.2128p pd=1.5u as=0.3808p ps=2.92u w=1.12u l=0.13u
X227 VSS.t88 DELAY_OUT_TAP5 a_7945_949# VSS.t160 sg13_lv_nmos ad=0.1665p pd=1.19u as=0.2516p ps=2.16u w=0.74u l=0.13u
X228 a_2019_216.t1 a_1721_236# VDD.t72 VDD.t0 sg13_lv_pmos ad=0.2128p pd=1.5u as=0.1918p ps=1.5u w=1.12u l=0.13u
X229 VSS.t222 VDD.t195 VSS.t221 VSS.t220 sg13_lv_nmos ad=0.1428p pd=1.52u as=0 ps=0 w=0.42u l=1u
X230 a_4248_949# a_4157_1218# VDD.t76 VDD.t0 sg13_lv_pmos ad=0.2128p pd=1.5u as=0.3808p ps=2.92u w=1.12u l=0.13u
X231 VDD.t5 VSS.t166 VDD.t176 VDD.t0 sg13_lv_pmos ad=0.34p pd=2.68u as=0 ps=0 w=1u l=1u
X232 VSS.t187 VDD.t202 VSS.t186 VSS.t185 sg13_lv_nmos ad=0.1428p pd=1.52u as=0 ps=0 w=0.42u l=1u
X233 VSS.t217 VDD.t196 VSS.t216 VSS.t215 sg13_lv_nmos ad=0.1428p pd=1.52u as=0 ps=0 w=0.42u l=1u
X234 VDD.t180 a_2595_952.t3 a_23431_913# VDD.t0 sg13_lv_pmos ad=0.3808p pd=2.92u as=0.3808p ps=2.92u w=1.12u l=0.13u
X235 VDD.t138 a_3747_216.t3 a_14825_424# VDD.t0 sg13_lv_pmos ad=0.3808p pd=2.92u as=0.3808p ps=2.92u w=1.12u l=0.13u
X236 VDD.t39 a_3747_952.t2 a_27991_913# VDD.t0 sg13_lv_pmos ad=0.3808p pd=2.92u as=0.3808p ps=2.92u w=1.12u l=0.13u
X237 a_2297_1300# MUX_SEL0 VDD.t135 VDD.t0 sg13_lv_pmos ad=0.1596p pd=1.22u as=0.2856p ps=2.36u w=0.84u l=0.13u
X238 a_9675_949# a_9465_949# VSS.t134 VSS.t283 sg13_lv_nmos ad=0.1406p pd=1.12u as=0.1665p ps=1.19u w=0.74u l=0.13u
X239 VSS.t184 VDD.t203 VSS.t182 VSS.t183 sg13_lv_nmos ad=79.8f pd=0.8u as=0 ps=0 w=0.42u l=1u
X240 a_2873_1300# MUX_SEL1 VDD.t129 VDD.t0 sg13_lv_pmos ad=0.1596p pd=1.22u as=0.2856p ps=2.36u w=0.84u l=0.13u
X241 VSS.t57 a_2595_952.t8 a_8231_913# VSS.t56 sg13_lv_nmos ad=0.2516p pd=2.16u as=0.2516p ps=2.16u w=0.74u l=0.13u
X242 VSS.t304 a_2595_216.t2 a_20905_424# VSS.t303 sg13_lv_nmos ad=0.2516p pd=2.16u as=0.2516p ps=2.16u w=0.74u l=0.13u
X243 a_3449_236# MUX_SEL2 VDD.t168 VDD.t0 sg13_lv_pmos ad=0.1596p pd=1.22u as=0.2856p ps=2.36u w=0.84u l=0.13u
X244 VDD.t80 DELAY_OUT_TAP11 a_12505_949# VDD.t0 sg13_lv_pmos ad=0.252p pd=1.57u as=0.3808p ps=2.92u w=1.12u l=0.13u
X245 VDD.t15 VSS.t224 VDD.t125 VDD.t0 sg13_lv_pmos ad=0.19p pd=1.38u as=0 ps=0 w=1u l=1u
X246 a_13470_949# a_13444_913# a_13368_949# VDD.t0 sg13_lv_pmos ad=0.3808p pd=2.92u as=0.2128p ps=1.5u w=1.12u l=0.13u
X247 VDD.t117 DELAY_OUT_TAP17 a_17065_949# VDD.t0 sg13_lv_pmos ad=0.252p pd=1.57u as=0.3808p ps=2.92u w=1.12u l=0.13u
X248 a_16510_949# a_18004_913# a_17928_949# VDD.t0 sg13_lv_pmos ad=0.3808p pd=2.92u as=0.2128p ps=1.5u w=1.12u l=0.13u
X249 a_19550_949# a_2019_952.t4 a_19448_949# VSS.t10 sg13_lv_nmos ad=0.2516p pd=2.16u as=0.1406p ps=1.12u w=0.74u l=0.13u
X250 VDD.t92 VSS.t219 VDD.t153 VDD.t0 sg13_lv_pmos ad=0.19p pd=1.38u as=0 ps=0 w=1u l=1u
X251 VDD.t101 VSS.t191 VDD.t96 VDD.t0 sg13_lv_pmos ad=0.34p pd=2.68u as=0 ps=0 w=1u l=1u
X252 VDD.t81 a_1256_194# a_2873_236# VDD.t0 sg13_lv_pmos ad=0.1918p pd=1.5u as=0.1596p ps=1.22u w=0.84u l=0.13u
X253 a_13470_949# a_2595_952.t6 a_14235_949# VSS.t52 sg13_lv_nmos ad=0.2516p pd=2.16u as=0.1406p ps=1.12u w=0.74u l=0.13u
X254 VSS.t131 a_2019_952.t3 a_22564_913# VSS.t311 sg13_lv_nmos ad=0.2516p pd=2.16u as=0.2516p ps=2.16u w=0.74u l=0.13u
X255 a_15755_949# a_15545_949# VDD.t118 VDD.t0 sg13_lv_pmos ad=0.2128p pd=1.5u as=0.252p ps=1.57u w=1.12u l=0.13u
X256 a_7390_949# a_8884_913# a_8808_949# VDD.t0 sg13_lv_pmos ad=0.3808p pd=2.92u as=0.2128p ps=1.5u w=1.12u l=0.13u
X257 a_2019_216.t0 a_1721_236# VSS.t90 VSS.t108 sg13_lv_nmos ad=0.1406p pd=1.12u as=0.1331p ps=1.12u w=0.74u l=0.13u
X258 a_4350_949# a_4324_913# a_4248_949# VDD.t0 sg13_lv_pmos ad=0.3808p pd=2.92u as=0.2128p ps=1.5u w=1.12u l=0.13u
X259 VDD.t132 DELAY_OUT_TAP5 a_7945_949# VDD.t0 sg13_lv_pmos ad=0.252p pd=1.57u as=0.3808p ps=2.92u w=1.12u l=0.13u
X260 a_24008_949# DELAY_OUT_TAP26 VDD.t63 VDD.t0 sg13_lv_pmos ad=0.2128p pd=1.5u as=0.3808p ps=2.92u w=1.12u l=0.13u
X261 a_5731_194# a_11785_424# a_10430_949# VDD.t0 sg13_lv_pmos ad=0.3808p pd=2.92u as=0.3808p ps=2.92u w=1.12u l=0.13u
X262 a_5115_949# a_4905_949# VDD.t113 VDD.t0 sg13_lv_pmos ad=0.2128p pd=1.5u as=0.252p ps=1.57u w=1.12u l=0.13u
X263 VDD.t14 VSS.t226 VDD.t13 VDD.t0 sg13_lv_pmos ad=0.34p pd=2.68u as=0 ps=0 w=1u l=1u
X264 a_13470_949# a_15831_913# a_15755_949# VDD.t0 sg13_lv_pmos ad=0.3808p pd=2.92u as=0.2128p ps=1.5u w=1.12u l=0.13u
X265 a_17275_949# a_17065_949# VSS.t63 VSS.t145 sg13_lv_nmos ad=0.1406p pd=1.12u as=0.1665p ps=1.19u w=0.74u l=0.13u
X266 VDD.t143 a_1544_949# a_2297_1300# VDD.t0 sg13_lv_pmos ad=0.1918p pd=1.5u as=0.1596p ps=1.22u w=0.84u l=0.13u
X267 VSS.t49 a_3747_952.t6 a_15831_913# VSS.t48 sg13_lv_nmos ad=0.2516p pd=2.16u as=0.2516p ps=2.16u w=0.74u l=0.13u
X268 a_4350_949# a_2019_952.t9 a_4248_949# VSS.t92 sg13_lv_nmos ad=0.2516p pd=2.16u as=0.1406p ps=1.12u w=0.74u l=0.13u
X269 VSS.t179 VDD.t204 VSS.t177 VSS.t178 sg13_lv_nmos ad=79.8f pd=0.8u as=0 ps=0 w=0.42u l=1u
X270 a_6635_949# a_6425_949# VDD.t122 VDD.t0 sg13_lv_pmos ad=0.2128p pd=1.5u as=0.252p ps=1.57u w=1.12u l=0.13u
X271 a_14888_949# DELAY_OUT_TAP14 VSS.t54 VSS.t290 sg13_lv_nmos ad=0.1406p pd=1.12u as=0.2516p ps=2.16u w=0.74u l=0.13u
X272 a_16108_194# a_3747_216.t2 a_25630_949# VSS.t284 sg13_lv_nmos ad=0.2516p pd=2.16u as=0.2516p ps=2.16u w=0.74u l=0.13u
X273 VSS.t244 VDD.t191 VSS.t242 VSS.t243 sg13_lv_nmos ad=79.8f pd=0.8u as=0 ps=0 w=0.42u l=1u
X274 a_4350_949# a_5191_913# a_5115_949# VDD.t0 sg13_lv_pmos ad=0.3808p pd=2.92u as=0.2128p ps=1.5u w=1.12u l=0.13u
X275 VDD.t17 MUX_SEL3 a_3449_236# VDD.t0 sg13_lv_pmos ad=0.1918p pd=1.5u as=0.1596p ps=1.22u w=0.84u l=0.13u
X276 VSS.t134 DELAY_OUT_TAP7 a_9465_949# VSS.t319 sg13_lv_nmos ad=0.1665p pd=1.19u as=0.2516p ps=2.16u w=0.74u l=0.13u
X277 a_4350_949# a_6711_913# a_6635_949# VDD.t0 sg13_lv_pmos ad=0.3808p pd=2.92u as=0.2128p ps=1.5u w=1.12u l=0.13u
X278 VSS.t247 VDD.t190 VSS.t246 VSS.t245 sg13_lv_nmos ad=0.1428p pd=1.52u as=0 ps=0 w=0.42u l=1u
X279 VSS.t63 a_2019_952.t5 a_16484_913# VSS.t62 sg13_lv_nmos ad=0.2516p pd=2.16u as=0.2516p ps=2.16u w=0.74u l=0.13u
X280 VSS.t150 a_3171_952.t9 a_5844_913# VSS.t322 sg13_lv_nmos ad=0.2516p pd=2.16u as=0.2516p ps=2.16u w=0.74u l=0.13u
X281 VDD.t171 a_2595_216.t2 a_20905_424# VDD.t0 sg13_lv_pmos ad=0.3808p pd=2.92u as=0.3808p ps=2.92u w=1.12u l=0.13u
X282 VSS.t126 a_2595_952.t7 a_11271_913# VSS.t125 sg13_lv_nmos ad=0.2516p pd=2.16u as=0.2516p ps=2.16u w=0.74u l=0.13u
X283 VSS.t123 a_3747_952.t8 a_9751_913# VSS.t122 sg13_lv_nmos ad=0.2516p pd=2.16u as=0.2516p ps=2.16u w=0.74u l=0.13u
X284 a_1256_949# MUX_SEL0 VDD.t134 VDD.t0 sg13_lv_pmos ad=0.3808p pd=2.92u as=0.3808p ps=2.92u w=1.12u l=0.13u
X285 a_2391_236# MUX_SEL2 a_2297_236# VSS.t300 sg13_lv_nmos ad=0.1216p pd=1.02u as=0.2176p ps=1.96u w=0.64u l=0.13u
X286 a_2967_236# MUX_SEL3 a_2873_236# VSS.t66 sg13_lv_nmos ad=0.1216p pd=1.02u as=0.2176p ps=1.96u w=0.64u l=0.13u
X287 VDD.t110 DELAY_OUT_TAP31 a_27705_949# VDD.t0 sg13_lv_pmos ad=0.252p pd=1.57u as=0.3808p ps=2.92u w=1.12u l=0.13u
X288 VDD.t107 DELAY_OUT_TAP25 a_23145_949# VDD.t0 sg13_lv_pmos ad=0.252p pd=1.57u as=0.3808p ps=2.92u w=1.12u l=0.13u
X289 a_2595_952.t1 a_2297_1300# VDD.t143 VDD.t0 sg13_lv_pmos ad=0.2128p pd=1.5u as=0.1918p ps=1.5u w=1.12u l=0.13u
X290 VDD.t16 VSS.t221 VDD.t15 VDD.t0 sg13_lv_pmos ad=0.34p pd=2.68u as=0 ps=0 w=1u l=1u
X291 VDD.t178 a_2019_952.t7 a_10404_913# VDD.t0 sg13_lv_pmos ad=0.3808p pd=2.92u as=0.3808p ps=2.92u w=1.12u l=0.13u
X292 VDD.t10 a_2019_952.t4 a_19524_913# VDD.t0 sg13_lv_pmos ad=0.3808p pd=2.92u as=0.3808p ps=2.92u w=1.12u l=0.13u
X293 VDD.t69 VSS.t186 VDD.t44 VDD.t0 sg13_lv_pmos ad=0.34p pd=2.68u as=0 ps=0 w=1u l=1u
X294 a_20315_949# a_20105_949# VDD.t77 VDD.t0 sg13_lv_pmos ad=0.2128p pd=1.5u as=0.252p ps=1.57u w=1.12u l=0.13u
X295 a_1544_949# MUX_SEL1 VSS.t156 VSS.t155 sg13_lv_nmos ad=0.2516p pd=2.16u as=0.2516p ps=2.16u w=0.74u l=0.13u
X296 VDD.t93 VSS.t216 VDD.t92 VDD.t0 sg13_lv_pmos ad=0.34p pd=2.68u as=0 ps=0 w=1u l=1u
X297 a_13470_949# a_3747_952.t6 a_15755_949# VSS.t47 sg13_lv_nmos ad=0.2516p pd=2.16u as=0.1406p ps=1.12u w=0.74u l=0.13u
X298 VSS.t142 a_3449_1300# a_3747_952.t0 VSS.t143 sg13_lv_nmos ad=0.2812p pd=2.24u as=0.1406p ps=1.12u w=0.74u l=0.13u
X299 a_4350_949# a_2595_952.t9 a_5115_949# VSS.t0 sg13_lv_nmos ad=0.2516p pd=2.16u as=0.1406p ps=1.12u w=0.74u l=0.13u
X300 VDD.t156 a_1721_1300# a_2019_952.t1 VDD.t0 sg13_lv_pmos ad=0.4256p pd=3u as=0.2128p ps=1.5u w=1.12u l=0.13u
X301 VSS.t40 a_2595_952.t2 a_26471_913# VSS.t118 sg13_lv_nmos ad=0.2516p pd=2.16u as=0.2516p ps=2.16u w=0.74u l=0.13u
X302 VSS.t239 VDD.t192 VSS.t237 VSS.t238 sg13_lv_nmos ad=79.8f pd=0.8u as=0 ps=0 w=0.42u l=1u
X303 a_21835_949# a_21625_949# VDD.t22 VDD.t0 sg13_lv_pmos ad=0.2128p pd=1.5u as=0.252p ps=1.57u w=1.12u l=0.13u
X304 a_3543_1300# MUX_SEL0 a_3449_1300# VSS.t164 sg13_lv_nmos ad=0.1216p pd=1.02u as=0.2176p ps=1.96u w=0.64u l=0.13u
X305 VDD.t150 a_2297_1300# a_2595_952.t1 VDD.t0 sg13_lv_pmos ad=0.4256p pd=3u as=0.2128p ps=1.5u w=1.12u l=0.13u
X306 VSS.t63 DELAY_OUT_TAP17 a_17065_949# VSS.t277 sg13_lv_nmos ad=0.1665p pd=1.19u as=0.2516p ps=2.16u w=0.74u l=0.13u
X307 VDD.t35 VSS.t184 VDD.t188 VDD.t0 sg13_lv_pmos ad=0.19p pd=1.38u as=0 ps=0 w=1u l=1u
X308 VSS.t204 VDD.t199 VSS.t202 VSS.t203 sg13_lv_nmos ad=79.8f pd=0.8u as=0 ps=0 w=0.42u l=1u
X309 a_19550_949# a_20391_913# a_20315_949# VDD.t0 sg13_lv_pmos ad=0.3808p pd=2.92u as=0.2128p ps=1.5u w=1.12u l=0.13u
X310 VSS.t207 VDD.t198 VSS.t206 VSS.t205 sg13_lv_nmos ad=0.1428p pd=1.52u as=0 ps=0 w=0.42u l=1u
X311 a_1544_949# MUX_SEL1 VDD.t130 VDD.t0 sg13_lv_pmos ad=0.3808p pd=2.92u as=0.3808p ps=2.92u w=1.12u l=0.13u
X312 a_16108_194# a_26985_424# a_25630_949# VDD.t0 sg13_lv_pmos ad=0.3808p pd=2.92u as=0.3808p ps=2.92u w=1.12u l=0.13u
X313 a_19550_949# a_21911_913# a_21835_949# VDD.t0 sg13_lv_pmos ad=0.3808p pd=2.92u as=0.2128p ps=1.5u w=1.12u l=0.13u
X314 VDD.t45 a_3747_952.t6 a_15831_913# VDD.t0 sg13_lv_pmos ad=0.3808p pd=2.92u as=0.3808p ps=2.92u w=1.12u l=0.13u
X315 a_18795_949# a_18585_949# VSS.t46 VSS.t115 sg13_lv_nmos ad=0.1406p pd=1.12u as=0.1665p ps=1.19u w=0.74u l=0.13u
X316 a_25630_949# a_3171_952.t2 a_27048_949# VSS.t314 sg13_lv_nmos ad=0.2516p pd=2.16u as=0.1406p ps=1.12u w=0.74u l=0.13u
X317 VSS.t18 a_2595_952.t5 a_17351_913# VSS.t17 sg13_lv_nmos ad=0.2516p pd=2.16u as=0.2516p ps=2.16u w=0.74u l=0.13u
X318 a_4350_949# a_3171_952.t9 a_5768_949# VSS.t321 sg13_lv_nmos ad=0.2516p pd=2.16u as=0.1406p ps=1.12u w=0.74u l=0.13u
X319 VSS.t114 a_2019_216.t2 a_17865_424# VSS.t113 sg13_lv_nmos ad=0.2516p pd=2.16u as=0.2516p ps=2.16u w=0.74u l=0.13u
X320 VSS.t77 a_1544_194# a_2391_236# VSS.t91 sg13_lv_nmos ad=0.1331p pd=1.12u as=0.1216p ps=1.02u w=0.64u l=0.13u
X321 VSS.t88 a_2019_952.t8 a_7364_913# VSS.t87 sg13_lv_nmos ad=0.2516p pd=2.16u as=0.2516p ps=2.16u w=0.74u l=0.13u
X322 VSS.t75 a_2019_216.t3 a_5705_424# VSS.t74 sg13_lv_nmos ad=0.2516p pd=2.16u as=0.2516p ps=2.16u w=0.74u l=0.13u
X323 MUX_OUT a_16851_214# VDD.t19 VDD.t0 sg13_lv_pmos ad=0.2128p pd=1.5u as=0.2086p ps=1.5u w=1.12u l=0.13u
X324 a_22488_949# DELAY_OUT_TAP24 VSS.t34 VSS.t305 sg13_lv_nmos ad=0.1406p pd=1.12u as=0.2516p ps=2.16u w=0.74u l=0.13u
X325 VDD.t33 VSS.t179 VDD.t32 VDD.t0 sg13_lv_pmos ad=0.19p pd=1.38u as=0 ps=0 w=1u l=1u
X326 VDD.t37 VSS.t244 VDD.t36 VDD.t0 sg13_lv_pmos ad=0.19p pd=1.38u as=0 ps=0 w=1u l=1u
X327 a_16408_949# DELAY_OUT_TAP16 VDD.t146 VDD.t0 sg13_lv_pmos ad=0.2128p pd=1.5u as=0.3808p ps=2.92u w=1.12u l=0.13u
X328 a_13470_949# a_2019_952.t6 a_13368_949# VSS.t68 sg13_lv_nmos ad=0.2516p pd=2.16u as=0.1406p ps=1.12u w=0.74u l=0.13u
X329 a_15964_194# a_15765_368# a_5731_194# VSS.t3 sg13_lv_nmos ad=0.2183p pd=1.33u as=0.2516p ps=2.16u w=0.74u l=0.13u
X330 VDD.t40 a_2019_952.t2 a_25604_913# VDD.t0 sg13_lv_pmos ad=0.3808p pd=2.92u as=0.3808p ps=2.92u w=1.12u l=0.13u
X331 a_2595_952.t0 a_2297_1300# VSS.t269 VSS.t274 sg13_lv_nmos ad=0.1406p pd=1.12u as=0.1331p ps=1.12u w=0.74u l=0.13u
X332 a_17928_949# DELAY_OUT_TAP18 VDD.t161 VDD.t0 sg13_lv_pmos ad=0.2128p pd=1.5u as=0.3808p ps=2.92u w=1.12u l=0.13u
X333 VSS.t31 a_3171_952.t3 a_24084_913# VSS.t30 sg13_lv_nmos ad=0.2516p pd=2.16u as=0.2516p ps=2.16u w=0.74u l=0.13u
X334 VDD.t26 VSS.t246 VDD.t31 VDD.t0 sg13_lv_pmos ad=0.34p pd=2.68u as=0 ps=0 w=1u l=1u
X335 a_2297_236# MUX_SEL2 VDD.t169 VDD.t0 sg13_lv_pmos ad=0.1596p pd=1.22u as=0.2856p ps=2.36u w=0.84u l=0.13u
X336 a_1815_1300# a_1256_949# a_1721_1300# VSS.t272 sg13_lv_nmos ad=0.1216p pd=1.02u as=0.2176p ps=1.96u w=0.64u l=0.13u
X337 a_2873_236# MUX_SEL3 VDD.t58 VDD.t0 sg13_lv_pmos ad=0.1596p pd=1.22u as=0.2856p ps=2.36u w=0.84u l=0.13u
X338 VSS.t46 DELAY_OUT_TAP19 a_18585_949# VSS.t278 sg13_lv_nmos ad=0.1665p pd=1.19u as=0.2516p ps=2.16u w=0.74u l=0.13u
X339 VSS.t237 VDD.t192 VSS.t236 VSS.t235 sg13_lv_nmos ad=0.1428p pd=1.52u as=0 ps=0 w=0.42u l=1u
X340 a_7288_949# DELAY_OUT_TAP4 VDD.t123 VDD.t0 sg13_lv_pmos ad=0.2128p pd=1.5u as=0.3808p ps=2.92u w=1.12u l=0.13u
X341 VSS.t202 VDD.t199 VSS.t201 VSS.t200 sg13_lv_nmos ad=0.1428p pd=1.52u as=0 ps=0 w=0.42u l=1u
X342 VSS.t214 VDD.t197 VSS.t212 VSS.t213 sg13_lv_nmos ad=79.8f pd=0.8u as=0 ps=0 w=0.42u l=1u
X343 VSS.t15 a_3171_952.t6 a_14964_913# VSS.t14 sg13_lv_nmos ad=0.2516p pd=2.16u as=0.2516p ps=2.16u w=0.74u l=0.13u
X344 VDD.t88 a_2019_216.t2 a_17865_424# VDD.t0 sg13_lv_pmos ad=0.3808p pd=2.92u as=0.3808p ps=2.92u w=1.12u l=0.13u
X345 VDD.t28 a_3747_952.t4 a_21911_913# VDD.t0 sg13_lv_pmos ad=0.3808p pd=2.92u as=0.3808p ps=2.92u w=1.12u l=0.13u
X346 a_11195_949# a_10985_949# VSS.t99 VSS.t98 sg13_lv_nmos ad=0.1406p pd=1.12u as=0.1665p ps=1.19u w=0.74u l=0.13u
X347 a_1721_1300# a_1256_949# VDD.t148 VDD.t0 sg13_lv_pmos ad=0.1596p pd=1.22u as=0.2856p ps=2.36u w=0.84u l=0.13u
X348 VDD.t20 a_16851_214# MUX_OUT VDD.t0 sg13_lv_pmos ad=0.7336p pd=3.55u as=0.2128p ps=1.5u w=1.12u l=0.13u
X349 VSS.t82 a_3171_216.t2 a_23945_424# VSS.t81 sg13_lv_nmos ad=0.2516p pd=2.16u as=0.2516p ps=2.16u w=0.74u l=0.13u
X350 a_22590_949# a_2595_952.t3 a_23355_949# VSS.t316 sg13_lv_nmos ad=0.2516p pd=2.16u as=0.1406p ps=1.12u w=0.74u l=0.13u
X351 VSS.t309 MUX_SEL4 a_15765_368# VSS.t308 sg13_lv_nmos ad=0.2516p pd=2.16u as=0.2516p ps=2.16u w=0.74u l=0.13u
X352 a_16510_949# a_16484_913# a_16408_949# VDD.t0 sg13_lv_pmos ad=0.3808p pd=2.92u as=0.2128p ps=1.5u w=1.12u l=0.13u
X353 VDD.t24 VSS.t239 VDD.t109 VDD.t0 sg13_lv_pmos ad=0.19p pd=1.38u as=0 ps=0 w=1u l=1u
X354 VDD.t78 DELAY_OUT_TAP9 a_10985_949# VDD.t0 sg13_lv_pmos ad=0.252p pd=1.57u as=0.3808p ps=2.92u w=1.12u l=0.13u
X355 VDD.t144 a_1544_949# a_1721_1300# VDD.t0 sg13_lv_pmos ad=0.1918p pd=1.5u as=0.1596p ps=1.22u w=0.84u l=0.13u
X356 VDD.t104 VSS.t204 VDD.t121 VDD.t0 sg13_lv_pmos ad=0.19p pd=1.38u as=0 ps=0 w=1u l=1u
X357 VDD.t64 a_2019_216.t3 a_5705_424# VDD.t0 sg13_lv_pmos ad=0.3808p pd=2.92u as=0.3808p ps=2.92u w=1.12u l=0.13u
X358 VDD.t50 VSS.t206 VDD.t7 VDD.t0 sg13_lv_pmos ad=0.34p pd=2.68u as=0 ps=0 w=1u l=1u
X359 VSS.t99 a_2019_952.t7 a_10404_913# VSS.t313 sg13_lv_nmos ad=0.2516p pd=2.16u as=0.2516p ps=2.16u w=0.74u l=0.13u
X360 VDD.t65 a_1544_194# a_2297_236# VDD.t0 sg13_lv_pmos ad=0.1918p pd=1.5u as=0.1596p ps=1.22u w=0.84u l=0.13u
X361 a_26395_949# a_26185_949# VSS.t40 VSS.t148 sg13_lv_nmos ad=0.1406p pd=1.12u as=0.1665p ps=1.19u w=0.74u l=0.13u
X362 VSS.t194 VDD.t201 VSS.t192 VSS.t193 sg13_lv_nmos ad=79.8f pd=0.8u as=0 ps=0 w=0.42u l=1u
X363 VSS.t297 a_3747_952.t3 a_24951_913# VSS.t296 sg13_lv_nmos ad=0.2516p pd=2.16u as=0.2516p ps=2.16u w=0.74u l=0.13u
X364 a_18795_949# a_18585_949# VDD.t89 VDD.t0 sg13_lv_pmos ad=0.2128p pd=1.5u as=0.252p ps=1.57u w=1.12u l=0.13u
X365 a_14235_949# a_14025_949# VDD.t90 VDD.t0 sg13_lv_pmos ad=0.2128p pd=1.5u as=0.252p ps=1.57u w=1.12u l=0.13u
X366 VDD.t122 DELAY_OUT_TAP3 a_6425_949# VDD.t0 sg13_lv_pmos ad=0.252p pd=1.57u as=0.3808p ps=2.92u w=1.12u l=0.13u
X367 a_7390_949# a_7364_913# a_7288_949# VDD.t0 sg13_lv_pmos ad=0.3808p pd=2.92u as=0.2128p ps=1.5u w=1.12u l=0.13u
X368 a_24008_949# DELAY_OUT_TAP26 VSS.t72 VSS.t71 sg13_lv_nmos ad=0.1406p pd=1.12u as=0.2516p ps=2.16u w=0.74u l=0.13u
X369 a_15964_194# MUX_SEL4 a_5731_194# VDD.t0 sg13_lv_pmos ad=0.3304p pd=1.71u as=0.3808p ps=2.92u w=1.12u l=0.13u
X370 a_1256_949# MUX_SEL0 VSS.t162 VSS.t161 sg13_lv_nmos ad=0.2516p pd=2.16u as=0.2516p ps=2.16u w=0.74u l=0.13u
X371 a_22488_949# DELAY_OUT_TAP24 VDD.t172 VDD.t0 sg13_lv_pmos ad=0.2128p pd=1.5u as=0.3808p ps=2.92u w=1.12u l=0.13u
X372 a_16510_949# a_18871_913# a_18795_949# VDD.t0 sg13_lv_pmos ad=0.3808p pd=2.92u as=0.2128p ps=1.5u w=1.12u l=0.13u
X373 a_27048_949# DELAY_OUT_TAP30 VDD.t126 VDD.t0 sg13_lv_pmos ad=0.2128p pd=1.5u as=0.3808p ps=2.92u w=1.12u l=0.13u
X374 a_13470_949# a_14311_913# a_14235_949# VDD.t0 sg13_lv_pmos ad=0.3808p pd=2.92u as=0.2128p ps=1.5u w=1.12u l=0.13u
X375 a_13470_949# a_3171_952.t6 a_14888_949# VSS.t13 sg13_lv_nmos ad=0.2516p pd=2.16u as=0.1406p ps=1.12u w=0.74u l=0.13u
X376 a_1256_194# MUX_SEL2 VSS.t299 VSS.t298 sg13_lv_nmos ad=0.2516p pd=2.16u as=0.2516p ps=2.16u w=0.74u l=0.13u
X377 a_9675_949# a_9465_949# VDD.t157 VDD.t0 sg13_lv_pmos ad=0.2128p pd=1.5u as=0.252p ps=1.57u w=1.12u l=0.13u
X378 VSS.t40 a_2019_952.t2 a_25604_913# VSS.t39 sg13_lv_nmos ad=0.2516p pd=2.16u as=0.2516p ps=2.16u w=0.74u l=0.13u
X379 a_16108_194# MUX_SEL4 a_15964_194# VSS.t307 sg13_lv_nmos ad=0.2516p pd=2.16u as=0.2183p ps=1.33u w=0.74u l=0.13u
X380 a_21835_949# a_21625_949# VSS.t28 VSS.t144 sg13_lv_nmos ad=0.1406p pd=1.12u as=0.1665p ps=1.19u w=0.74u l=0.13u
X381 VSS.t9 a_2595_952.t4 a_20391_913# VSS.t8 sg13_lv_nmos ad=0.2516p pd=2.16u as=0.2516p ps=2.16u w=0.74u l=0.13u
X382 a_2019_952.t1 a_1721_1300# VDD.t144 VDD.t0 sg13_lv_pmos ad=0.2128p pd=1.5u as=0.1918p ps=1.5u w=1.12u l=0.13u
X383 VSS.t99 DELAY_OUT_TAP9 a_10985_949# VSS.t320 sg13_lv_nmos ad=0.1665p pd=1.19u as=0.2516p ps=2.16u w=0.74u l=0.13u
X384 a_7390_949# a_9751_913# a_9675_949# VDD.t0 sg13_lv_pmos ad=0.3808p pd=2.92u as=0.2128p ps=1.5u w=1.12u l=0.13u
X385 VSS.t212 VDD.t197 VSS.t211 VSS.t210 sg13_lv_nmos ad=0.1428p pd=1.52u as=0 ps=0 w=0.42u l=1u
X386 VDD.t67 a_3171_216.t2 a_23945_424# VDD.t0 sg13_lv_pmos ad=0.3808p pd=2.92u as=0.3808p ps=2.92u w=1.12u l=0.13u
X387 VSS.t129 a_3747_952.t5 a_18871_913# VSS.t128 sg13_lv_nmos ad=0.2516p pd=2.16u as=0.2516p ps=2.16u w=0.74u l=0.13u
X388 a_12715_949# a_12505_949# VSS.t85 VSS.t101 sg13_lv_nmos ad=0.1406p pd=1.12u as=0.1665p ps=1.19u w=0.74u l=0.13u
X389 a_17928_949# DELAY_OUT_TAP18 VSS.t18 VSS.t289 sg13_lv_nmos ad=0.1406p pd=1.12u as=0.2516p ps=2.16u w=0.74u l=0.13u
X390 VDD.t174 MUX_SEL4 a_15765_368# VDD.t0 sg13_lv_pmos ad=0.3808p pd=2.92u as=0.3808p ps=2.92u w=1.12u l=0.13u
X391 a_19550_949# a_3171_952.t4 a_20968_949# VSS.t119 sg13_lv_nmos ad=0.2516p pd=2.16u as=0.1406p ps=1.12u w=0.74u l=0.13u
X392 a_7288_949# DELAY_OUT_TAP4 VSS.t60 VSS.t151 sg13_lv_nmos ad=0.1406p pd=1.12u as=0.2516p ps=2.16u w=0.74u l=0.13u
X393 a_1815_236# a_1256_194# a_1721_236# VSS.t102 sg13_lv_nmos ad=0.1216p pd=1.02u as=0.2176p ps=1.96u w=0.64u l=0.13u
X394 a_1544_194# MUX_SEL3 VSS.t65 VSS.t64 sg13_lv_nmos ad=0.2516p pd=2.16u as=0.2516p ps=2.16u w=0.74u l=0.13u
X395 a_22590_949# a_3747_952.t3 a_24875_949# VSS.t295 sg13_lv_nmos ad=0.2516p pd=2.16u as=0.1406p ps=1.12u w=0.74u l=0.13u
X396 VDD.t22 DELAY_OUT_TAP23 a_21625_949# VDD.t0 sg13_lv_pmos ad=0.252p pd=1.57u as=0.3808p ps=2.92u w=1.12u l=0.13u
X397 a_22590_949# a_22564_913# a_22488_949# VDD.t0 sg13_lv_pmos ad=0.3808p pd=2.92u as=0.2128p ps=1.5u w=1.12u l=0.13u
X398 VSS.t40 DELAY_OUT_TAP29 a_26185_949# VSS.t111 sg13_lv_nmos ad=0.1665p pd=1.19u as=0.2516p ps=2.16u w=0.74u l=0.13u
X399 VSS.t182 VDD.t203 VSS.t181 VSS.t180 sg13_lv_nmos ad=0.1428p pd=1.52u as=0 ps=0 w=0.42u l=1u
X400 VDD.t87 DELAY_OUT_TAP29 a_26185_949# VDD.t0 sg13_lv_pmos ad=0.252p pd=1.57u as=0.3808p ps=2.92u w=1.12u l=0.13u
X401 VSS.t94 DELAY_OUT_TAP1 a_4905_949# VSS.t159 sg13_lv_nmos ad=0.1665p pd=1.19u as=0.2516p ps=2.16u w=0.74u l=0.13u
X402 a_25630_949# a_27124_913# a_27048_949# VDD.t0 sg13_lv_pmos ad=0.3808p pd=2.92u as=0.2128p ps=1.5u w=1.12u l=0.13u
X403 VDD.t25 VSS.t236 VDD.t24 VDD.t0 sg13_lv_pmos ad=0.34p pd=2.68u as=0 ps=0 w=1u l=1u
X404 VDD.t62 a_2019_952.t6 a_13444_913# VDD.t0 sg13_lv_pmos ad=0.3808p pd=2.92u as=0.3808p ps=2.92u w=1.12u l=0.13u
X405 VSS.t134 a_3171_952.t8 a_8884_913# VSS.t133 sg13_lv_nmos ad=0.2516p pd=2.16u as=0.2516p ps=2.16u w=0.74u l=0.13u
X406 VDD.t105 VSS.t201 VDD.t104 VDD.t0 sg13_lv_pmos ad=0.34p pd=2.68u as=0 ps=0 w=1u l=1u
X407 VDD.t61 VSS.t214 VDD.t111 VDD.t0 sg13_lv_pmos ad=0.19p pd=1.38u as=0 ps=0 w=1u l=1u
X408 VSS.t90 a_1544_194# a_1815_236# VSS.t89 sg13_lv_nmos ad=0.1331p pd=1.12u as=0.1216p ps=1.02u w=0.64u l=0.13u
X409 VDD.t42 a_3171_952.t5 a_18004_913# VDD.t0 sg13_lv_pmos ad=0.3808p pd=2.92u as=0.3808p ps=2.92u w=1.12u l=0.13u
X410 VSS.t142 MUX_SEL1 a_3543_1300# VSS.t158 sg13_lv_nmos ad=0.1331p pd=1.12u as=0.1216p ps=1.02u w=0.64u l=0.13u
X411 a_27915_949# a_27705_949# VSS.t136 VSS.t135 sg13_lv_nmos ad=0.1406p pd=1.12u as=0.1665p ps=1.19u w=0.74u l=0.13u
X412 VSS.t251 VDD.t189 VSS.t254 VSS.t253 sg13_lv_nmos ad=79.8f pd=0.8u as=0 ps=0 w=0.42u l=1u
X413 a_24875_949# a_24665_949# VDD.t165 VDD.t0 sg13_lv_pmos ad=0.2128p pd=1.5u as=0.252p ps=1.57u w=1.12u l=0.13u
C0 a_5844_913# DELAY_OUT_TAP3 0.02053f
C1 a_4248_949# a_4350_949# 0.37183f
C2 VDD a_14025_949# 0.30466f
C3 DELAY_OUT_TAP11 a_12505_949# 0.2079f
C4 a_23431_913# DELAY_OUT_TAP26 0.02334f
C5 VDD DELAY_OUT_TAP3 0.12821f
C6 DELAY_OUT_TAP7 VDD 0.12821f
C7 DELAY_OUT_TAP31 a_27124_913# 0.02053f
C8 a_16510_949# DELAY_OUT_TAP20 0.02437f
C9 a_22590_949# VDD 2.01498f
C10 a_4350_949# DELAY_OUT_TAP3 0.05189f
C11 a_20968_949# DELAY_OUT_TAP22 0.10863f
C12 VDD a_1544_194# 0.39668f
C13 MUX_SEL0 a_2297_1300# 0.10655f
C14 a_19448_949# VDD 0.18236f
C15 DELAY_OUT_TAP30 a_27124_913# 0.02312f
C16 VDD a_27705_949# 0.29975f
C17 a_16510_949# DELAY_OUT_TAP19 0.05189f
C18 a_22488_949# VDD 0.18236f
C19 VDD a_13470_949# 2.0134f
C20 DELAY_OUT_TAP3 DELAY_OUT_TAP4 0.0331f
C21 MUX_SEL4 a_11785_424# 0.03255f
C22 a_15755_949# a_15831_913# 0.01194f
C23 DELAY_OUT_TAP6 DELAY_OUT_TAP5 0.02068f
C24 DELAY_OUT_TAP7 DELAY_OUT_TAP8 0.0331f
C25 a_17351_913# VDD 0.28698f
C26 a_14311_913# a_14025_949# 0.01885f
C27 a_6711_913# a_6425_949# 0.01885f
C28 a_18795_949# a_18585_949# 0.09424f
C29 a_22590_949# a_22564_913# 0.277f
C30 a_16510_949# DELAY_OUT_TAP18 0.07996f
C31 a_15545_949# a_13470_949# 0.03208f
C32 a_14235_949# a_14025_949# 0.09424f
C33 a_5731_194# a_16108_194# 0.01334f
C34 a_17275_949# a_17065_949# 0.09424f
C35 a_1544_194# a_1721_236# 0.36963f
C36 a_1256_194# a_2297_236# 0.04261f
C37 a_22488_949# a_22564_913# 0.01176f
C38 DELAY_OUT_TAP12 DELAY_OUT_TAP13 0.06596f
C39 a_14311_913# a_13470_949# 0.28268f
C40 a_19448_949# a_19550_949# 0.37183f
C41 a_10430_949# a_11785_424# 0.01782f
C42 VDD a_7364_913# 0.28964f
C43 a_2297_1300# a_1544_949# 0.28651f
C44 MUX_SEL2 MUX_OUT 0.08497f
C45 DELAY_OUT_TAP19 DELAY_OUT_TAP20 0.0331f
C46 a_13470_949# a_13444_913# 0.277f
C47 DELAY_OUT_TAP16 VDD 0.16873f
C48 a_20905_424# a_16108_194# 0.2906f
C49 a_14235_949# a_13470_949# 0.39037f
C50 a_7945_949# a_7390_949# 0.03209f
C51 VDD DELAY_OUT_TAP23 0.12821f
C52 a_25528_949# a_25604_913# 0.01176f
C53 MUX_SEL4 a_10430_949# 0.05749f
C54 DELAY_OUT_TAP30 DELAY_OUT_TAP31 0.03717f
C55 DELAY_OUT_TAP0 VDD 0.58017f
C56 a_27048_949# a_27124_913# 0.01176f
C57 a_7390_949# DELAY_OUT_TAP5 0.10838f
C58 a_7364_913# DELAY_OUT_TAP4 0.02011f
C59 DELAY_OUT_TAP6 a_8231_913# 0.02334f
C60 VDD a_8884_913# 0.28358f
C61 a_21835_949# a_21625_949# 0.09424f
C62 a_25528_949# VDD 0.18232f
C63 DELAY_OUT_TAP18 DELAY_OUT_TAP19 0.03717f
C64 a_16408_949# a_16510_949# 0.37183f
C65 a_14964_913# DELAY_OUT_TAP14 0.02312f
C66 VDD a_5191_913# 0.28698f
C67 DELAY_OUT_TAP12 DELAY_OUT_TAP11 0.0331f
C68 VDD DELAY_OUT_TAP27 0.12821f
C69 MUX_SEL0 a_3449_1300# 0.10753f
C70 a_5191_913# a_4350_949# 0.28268f
C71 a_19550_949# DELAY_OUT_TAP23 0.05189f
C72 MUX_SEL2 a_2873_236# 0.01422f
C73 MUX_SEL4 a_1544_194# 0.47529f
C74 MUX_SEL3 a_2297_236# 0.01595f
C75 VDD a_16108_194# 1.94809f
C76 a_2297_1300# MUX_SEL1 0.01995f
C77 a_24084_913# a_24008_949# 0.01176f
C78 MUX_SEL4 a_13470_949# 0.05779f
C79 a_16108_194# a_17865_424# 0.29564f
C80 a_5731_194# a_7390_949# 0.41141f
C81 a_5844_913# DELAY_OUT_TAP2 0.02312f
C82 a_22590_949# DELAY_OUT_TAP28 0.02437f
C83 a_25630_949# a_27705_949# 0.03208f
C84 VDD DELAY_OUT_TAP2 0.13935f
C85 DELAY_OUT_TAP6 VDD 0.13935f
C86 a_7390_949# a_8231_913# 0.28268f
C87 a_4350_949# DELAY_OUT_TAP2 0.07996f
C88 a_4324_913# DELAY_OUT_TAP1 0.0501f
C89 a_20391_913# DELAY_OUT_TAP22 0.02334f
C90 VDD a_1256_194# 0.41094f
C91 a_26185_949# DELAY_OUT_TAP29 0.19203f
C92 a_18871_913# VDD 0.29229f
C93 a_11848_949# a_11924_913# 0.01176f
C94 DELAY_OUT_TAP16 DELAY_OUT_TAP17 0.06596f
C95 DELAY_OUT_TAP30 a_27048_949# 0.10863f
C96 VDD a_26185_949# 0.30466f
C97 a_27991_913# VDD 0.29221f
C98 VDD a_13368_949# 0.18232f
C99 a_19550_949# a_16108_194# 0.43108f
C100 a_17275_949# VDD 0.15466f
C101 a_6635_949# a_6425_949# 0.09424f
C102 a_7390_949# a_9751_913# 0.26208f
C103 a_14025_949# a_13470_949# 0.03209f
C104 DELAY_OUT_TAP0 MUX_SEL4 0.06224f
C105 DELAY_OUT_TAP11 a_11924_913# 0.02053f
C106 a_16510_949# a_18585_949# 0.03208f
C107 a_5731_194# a_15964_194# 0.2778f
C108 a_23431_913# a_23145_949# 0.01885f
C109 a_1256_194# a_1721_236# 0.13421f
C110 a_5115_949# a_4905_949# 0.09424f
C111 a_22488_949# a_22590_949# 0.37183f
C112 VDD a_7390_949# 2.01762f
C113 a_2297_1300# a_1256_949# 0.04619f
C114 a_13368_949# a_13444_913# 0.01176f
C115 DELAY_OUT_TAP15 VDD 0.12935f
C116 VDD DELAY_OUT_TAP22 0.13935f
C117 a_25528_949# a_25630_949# 0.37183f
C118 VDD a_1721_1300# 0.46923f
C119 MUX_SEL3 VDD 0.40997f
C120 VDD a_2873_1300# 0.47934f
C121 a_3449_1300# MUX_SEL1 0.29404f
C122 DELAY_OUT_TAP15 a_15545_949# 0.2079f
C123 MUX_SEL4 a_16108_194# 0.1283f
C124 DELAY_OUT_TAP8 a_7390_949# 0.02437f
C125 a_25528_949# DELAY_OUT_TAP28 0.10864f
C126 VDD a_8808_949# 0.17577f
C127 a_24951_913# VDD 0.29225f
C128 a_14888_949# DELAY_OUT_TAP14 0.10863f
C129 a_25630_949# a_16108_194# 0.43108f
C130 DELAY_OUT_TAP27 DELAY_OUT_TAP28 0.0331f
C131 a_10985_949# a_11271_913# 0.01885f
C132 a_18585_949# DELAY_OUT_TAP19 0.2079f
C133 VDD DELAY_OUT_TAP26 0.13935f
C134 DELAY_OUT_TAP16 a_13470_949# 0.02437f
C135 a_19550_949# DELAY_OUT_TAP22 0.07996f
C136 a_19524_913# DELAY_OUT_TAP21 0.0501f
C137 MUX_SEL2 a_2297_236# 0.10655f
C138 MUX_SEL4 a_1256_194# 0.65005f
C139 DELAY_OUT_TAP7 a_8884_913# 0.02053f
C140 VDD a_15964_194# 0.48723f
C141 DELAY_OUT_TAP10 a_11848_949# 0.10863f
C142 a_5705_424# a_5731_194# 0.28954f
C143 a_16108_194# a_16851_214# 0.06181f
C144 a_5768_949# DELAY_OUT_TAP2 0.10863f
C145 a_25630_949# a_26185_949# 0.03209f
C146 a_22590_949# DELAY_OUT_TAP27 0.05189f
C147 VDD DELAY_OUT_TAP1 0.14002f
C148 a_25630_949# a_27991_913# 0.26208f
C149 a_7390_949# a_8155_949# 0.39037f
C150 a_4350_949# DELAY_OUT_TAP1 0.10838f
C151 a_22590_949# a_16108_194# 0.43108f
C152 DELAY_OUT_TAP10 DELAY_OUT_TAP11 0.03717f
C153 a_18795_949# VDD 0.15484f
C154 VDD a_24665_949# 0.29779f
C155 DELAY_OUT_TAP30 a_26471_913# 0.02334f
C156 VDD a_12791_913# 0.29225f
C157 a_27915_949# VDD 0.15466f
C158 DELAY_OUT_TAP2 DELAY_OUT_TAP3 0.03717f
C159 MUX_SEL4 a_7390_949# 0.11061f
C160 a_16484_913# VDD 0.28929f
C161 VDD MUX_SEL0 0.50845f
C162 DELAY_OUT_TAP6 DELAY_OUT_TAP7 0.03717f
C163 a_18004_913# VDD 0.28358f
C164 a_21911_913# VDD 0.29229f
C165 a_7390_949# a_9675_949# 0.39036f
C166 VDD a_6425_949# 0.29779f
C167 MUX_SEL3 MUX_SEL4 0.75489f
C168 a_16510_949# a_17065_949# 0.03209f
C169 DELAY_OUT_TAP10 a_11924_913# 0.02312f
C170 a_5731_194# a_15765_368# 0.23301f
C171 a_23355_949# a_23145_949# 0.09424f
C172 a_4350_949# a_6425_949# 0.03208f
C173 a_1256_194# a_1544_194# 1.25711f
C174 a_5705_424# VDD 0.30089f
C175 VDD a_7288_949# 0.18236f
C176 a_5731_194# a_14825_424# 0.28056f
C177 a_27991_913# a_27705_949# 0.01885f
C178 a_5705_424# a_4350_949# 0.01764f
C179 a_13368_949# a_13470_949# 0.37183f
C180 DELAY_OUT_TAP14 VDD 0.13935f
C181 a_21911_913# a_19550_949# 0.26208f
C182 VDD DELAY_OUT_TAP21 0.13712f
C183 MUX_SEL2 VDD 0.49863f
C184 a_17275_949# a_17351_913# 0.01194f
C185 VDD a_1544_949# 0.56437f
C186 a_17928_949# a_18004_913# 0.01176f
C187 a_7288_949# DELAY_OUT_TAP4 0.10864f
C188 DELAY_OUT_TAP7 a_7390_949# 0.05189f
C189 MUX_SEL4 a_15964_194# 0.5544f
C190 a_24951_913# DELAY_OUT_TAP28 0.02339f
C191 a_24875_949# VDD 0.15484f
C192 a_14311_913# DELAY_OUT_TAP14 0.02334f
C193 a_10985_949# a_11195_949# 0.09424f
C194 VDD a_12505_949# 0.29779f
C195 a_20968_949# a_21044_913# 0.01176f
C196 VDD DELAY_OUT_TAP25 0.13712f
C197 DELAY_OUT_TAP15 a_13470_949# 0.05189f
C198 a_19550_949# DELAY_OUT_TAP21 0.10838f
C199 a_19524_913# DELAY_OUT_TAP20 0.02011f
C200 MUX_SEL3 a_1544_194# 0.15976f
C201 MUX_SEL2 a_1721_236# 0.01315f
C202 DELAY_OUT_TAP6 a_8884_913# 0.02312f
C203 a_16484_913# DELAY_OUT_TAP17 0.0501f
C204 VDD a_15765_368# 0.35641f
C205 DELAY_OUT_TAP10 a_11271_913# 0.02334f
C206 a_15964_194# a_16851_214# 0.16757f
C207 a_24951_913# a_22590_949# 0.26208f
C208 a_5191_913# DELAY_OUT_TAP2 0.02334f
C209 a_15831_913# VDD 0.29168f
C210 VDD a_14825_424# 0.29891f
C211 DELAY_OUT_TAP9 a_10985_949# 0.19203f
C212 a_22564_913# DELAY_OUT_TAP25 0.0501f
C213 a_22590_949# DELAY_OUT_TAP26 0.07996f
C214 VDD MUX_SEL1 0.67604f
C215 a_25630_949# a_27915_949# 0.39036f
C216 a_7390_949# a_7364_913# 0.277f
C217 a_15831_913# a_15545_949# 0.01885f
C218 a_10430_949# a_12791_913# 0.26208f
C219 VDD a_23145_949# 0.30466f
C220 DELAY_OUT_TAP15 DELAY_OUT_TAP16 0.0331f
C221 a_27124_913# VDD 0.28358f
C222 VDD a_12715_949# 0.15484f
C223 MUX_SEL4 a_5705_424# 0.03556f
C224 a_16510_949# VDD 2.0153f
C225 a_16510_949# a_17865_424# 0.018f
C226 DELAY_OUT_TAP22 DELAY_OUT_TAP23 0.03717f
C227 a_21835_949# VDD 0.15484f
C228 a_7390_949# a_8884_913# 0.28279f
C229 VDD a_4905_949# 0.30183f
C230 MUX_SEL2 MUX_SEL4 0.01978f
C231 a_22590_949# a_24665_949# 0.03208f
C232 a_4350_949# a_4905_949# 0.03209f
C233 a_4324_913# a_4157_1218# 0.02463f
C234 a_20391_913# a_20105_949# 0.01885f
C235 a_27915_949# a_27705_949# 0.09424f
C236 a_6425_949# DELAY_OUT_TAP3 0.2079f
C237 DELAY_OUT_TAP13 VDD 0.13712f
C238 a_8808_949# a_8884_913# 0.01176f
C239 a_21835_949# a_19550_949# 0.39036f
C240 VDD DELAY_OUT_TAP20 0.17577f
C241 a_6635_949# a_6711_913# 0.01194f
C242 VDD a_1256_949# 0.57486f
C243 a_16510_949# a_17928_949# 0.38994f
C244 DELAY_OUT_TAP31 VDD 0.12941f
C245 DELAY_OUT_TAP12 VDD 0.17575f
C246 DELAY_OUT_TAP6 a_7390_949# 0.07996f
C247 MUX_SEL4 a_15765_368# 0.65508f
C248 VDD DELAY_OUT_TAP19 0.12821f
C249 DELAY_OUT_TAP30 DELAY_OUT_TAP29 0.02068f
C250 a_11195_949# a_11271_913# 0.01194f
C251 VDD a_11848_949# 0.17577f
C252 a_24084_913# VDD 0.28358f
C253 DELAY_OUT_TAP30 VDD 0.13935f
C254 a_26395_949# a_26471_913# 0.01194f
C255 MUX_SEL4 a_14825_424# 0.03307f
C256 DELAY_OUT_TAP26 DELAY_OUT_TAP27 0.03717f
C257 a_12505_949# a_10430_949# 0.03208f
C258 DELAY_OUT_TAP0 DELAY_OUT_TAP1 0.04194f
C259 VDD DELAY_OUT_TAP18 0.13935f
C260 VDD DELAY_OUT_TAP24 0.17577f
C261 VDD a_10985_949# 0.30466f
C262 DELAY_OUT_TAP13 a_13444_913# 0.0501f
C263 DELAY_OUT_TAP14 a_13470_949# 0.07996f
C264 MUX_SEL3 a_1256_194# 1.41161f
C265 MUX_SEL2 a_1544_194# 0.07405f
C266 DELAY_OUT_TAP6 a_8808_949# 0.10863f
C267 VDD a_20105_949# 0.30466f
C268 MUX_OUT a_2297_236# 0.01179f
C269 a_16484_913# DELAY_OUT_TAP16 0.02011f
C270 a_16510_949# DELAY_OUT_TAP17 0.10838f
C271 a_24875_949# a_22590_949# 0.39036f
C272 DELAY_OUT_TAP11 VDD 0.12821f
C273 a_15964_194# a_16108_194# 0.42202f
C274 a_5731_194# a_8745_424# 0.28635f
C275 DELAY_OUT_TAP12 a_13444_913# 0.02011f
C276 a_24008_949# VDD 0.17577f
C277 a_15755_949# VDD 0.15466f
C278 VDD a_3449_236# 0.47436f
C279 a_22590_949# DELAY_OUT_TAP25 0.10838f
C280 a_22564_913# DELAY_OUT_TAP24 0.02011f
C281 a_25630_949# a_27124_913# 0.28279f
C282 a_7288_949# a_7364_913# 0.01176f
C283 MUX_OUT a_5731_194# 1.04829f
C284 a_19550_949# DELAY_OUT_TAP24 0.02437f
C285 a_15755_949# a_15545_949# 0.09424f
C286 DELAY_OUT_TAP9 DELAY_OUT_TAP10 0.02068f
C287 a_24665_949# DELAY_OUT_TAP27 0.2079f
C288 VDD a_21625_949# 0.29779f
C289 a_10430_949# a_12715_949# 0.39036f
C290 a_23355_949# a_23431_913# 0.01194f
C291 a_19550_949# a_20105_949# 0.03209f
C292 a_17928_949# DELAY_OUT_TAP18 0.10863f
C293 VDD a_11924_913# 0.28358f
C294 a_27048_949# VDD 0.17577f
C295 DELAY_OUT_TAP1 DELAY_OUT_TAP2 0.02068f
C296 a_14888_949# a_14964_913# 0.01176f
C297 a_16408_949# VDD 0.18093f
C298 a_21044_913# VDD 0.28358f
C299 a_16510_949# a_16851_214# 0.01245f
C300 a_15831_913# a_13470_949# 0.26208f
C301 a_7390_949# a_8808_949# 0.38994f
C302 VDD a_4157_1218# 0.57183f
C303 a_14825_424# a_13470_949# 0.01782f
C304 a_26985_424# VDD 0.30089f
C305 a_22590_949# a_23145_949# 0.03209f
C306 a_4350_949# a_4157_1218# 0.04456f
C307 a_20315_949# a_20105_949# 0.09424f
C308 a_18795_949# a_18871_913# 0.01194f
C309 a_19550_949# a_21625_949# 0.03208f
C310 DELAY_OUT_TAP17 DELAY_OUT_TAP18 0.02068f
C311 VDD a_8745_424# 0.29602f
C312 DELAY_OUT_TAP31 a_25630_949# 0.05211f
C313 a_27915_949# a_27991_913# 0.01194f
C314 a_21044_913# a_19550_949# 0.28279f
C315 DELAY_OUT_TAP30 a_25630_949# 0.07996f
C316 DELAY_OUT_TAP12 a_10430_949# 0.02437f
C317 a_16510_949# a_17351_913# 0.28268f
C318 VDD a_2297_1300# 0.47641f
C319 MUX_OUT VDD 1.15067f
C320 a_15831_913# DELAY_OUT_TAP16 0.02339f
C321 DELAY_OUT_TAP13 a_14025_949# 0.19203f
C322 a_9465_949# a_9751_913# 0.01885f
C323 VDD a_6711_913# 0.29229f
C324 a_10430_949# a_11848_949# 0.38994f
C325 VDD a_11271_913# 0.28469f
C326 a_6711_913# a_4350_949# 0.26208f
C327 MUX_SEL4 a_3449_236# 0.05166f
C328 a_10985_949# a_10430_949# 0.03209f
C329 DELAY_OUT_TAP0 MUX_SEL1 0.01815f
C330 VDD a_5115_949# 0.15466f
C331 VDD a_9465_949# 0.29779f
C332 a_6711_913# DELAY_OUT_TAP4 0.02339f
C333 DELAY_OUT_TAP13 a_13470_949# 0.10838f
C334 a_4350_949# a_5115_949# 0.39037f
C335 a_19448_949# DELAY_OUT_TAP20 0.10864f
C336 MUX_SEL2 a_1256_194# 0.33134f
C337 VDD a_18585_949# 0.29779f
C338 DELAY_OUT_TAP11 a_10430_949# 0.05189f
C339 DELAY_OUT_TAP31 a_27705_949# 0.2079f
C340 a_24084_913# a_22590_949# 0.28279f
C341 DELAY_OUT_TAP10 VDD 0.13935f
C342 a_15765_368# a_16108_194# 0.42004f
C343 a_23431_913# VDD 0.28469f
C344 a_14964_913# VDD 0.28358f
C345 MUX_SEL0 a_1721_1300# 0.01315f
C346 a_7945_949# DELAY_OUT_TAP5 0.19203f
C347 MUX_SEL0 a_2873_1300# 0.01504f
C348 VDD a_2873_236# 0.47413f
C349 a_24951_913# a_24665_949# 0.01885f
C350 a_25630_949# a_27048_949# 0.38994f
C351 a_7288_949# a_7390_949# 0.37183f
C352 MUX_SEL4 a_4157_1218# 0.08229f
C353 a_22488_949# DELAY_OUT_TAP24 0.10864f
C354 a_10430_949# a_11924_913# 0.28279f
C355 a_22590_949# a_24008_949# 0.38994f
C356 DELAY_OUT_TAP14 DELAY_OUT_TAP15 0.03717f
C357 a_17351_913# DELAY_OUT_TAP18 0.02334f
C358 a_26471_913# VDD 0.28469f
C359 a_25630_949# a_26985_424# 0.018f
C360 MUX_SEL4 a_8745_424# 0.04472f
C361 a_5191_913# a_4905_949# 0.01885f
C362 a_20968_949# VDD 0.17577f
C363 a_16510_949# a_16108_194# 0.43331f
C364 DELAY_OUT_TAP21 DELAY_OUT_TAP22 0.02068f
C365 a_26395_949# VDD 0.15466f
C366 a_15755_949# a_13470_949# 0.39036f
C367 VDD a_3449_1300# 0.48157f
C368 a_23945_424# VDD 0.30044f
C369 a_1544_949# a_1721_1300# 0.38063f
C370 MUX_SEL2 MUX_SEL3 3.21891f
C371 MUX_SEL4 MUX_OUT 0.91933f
C372 a_4248_949# a_4157_1218# 0.11511f
C373 a_7945_949# a_8231_913# 0.01885f
C374 a_16510_949# a_18871_913# 0.26208f
C375 DELAY_OUT_TAP24 DELAY_OUT_TAP23 0.0331f
C376 a_10404_913# a_10328_949# 0.01176f
C377 a_20968_949# a_19550_949# 0.38994f
C378 VDD a_10328_949# 0.18236f
C379 a_24875_949# a_24951_913# 0.01194f
C380 a_16510_949# a_17275_949# 0.39037f
C381 a_9465_949# a_9675_949# 0.09424f
C382 MUX_OUT a_16851_214# 0.45865f
C383 VDD a_6635_949# 0.15484f
C384 a_24084_913# DELAY_OUT_TAP27 0.02053f
C385 a_10430_949# a_11271_913# 0.28268f
C386 a_6635_949# a_4350_949# 0.39036f
C387 VDD a_11195_949# 0.15466f
C388 MUX_SEL4 a_2873_236# 0.04916f
C389 DELAY_OUT_TAP0 a_3449_236# 0.01018f
C390 DELAY_OUT_TAP8 a_10328_949# 0.10864f
C391 DELAY_OUT_TAP25 DELAY_OUT_TAP26 0.02068f
C392 a_2873_1300# MUX_SEL1 0.13092f
C393 VDD a_4324_913# 0.28929f
C394 VDD a_7945_949# 0.30466f
C395 a_18871_913# DELAY_OUT_TAP20 0.02339f
C396 a_4350_949# a_4324_913# 0.277f
C397 a_21625_949# DELAY_OUT_TAP23 0.2079f
C398 VDD a_17065_949# 0.30275f
C399 MUX_OUT a_1544_194# 0.69943f
C400 a_16408_949# DELAY_OUT_TAP16 0.10864f
C401 DELAY_OUT_TAP10 a_10430_949# 0.07996f
C402 DELAY_OUT_TAP9 a_10404_913# 0.0501f
C403 VDD DELAY_OUT_TAP5 0.13712f
C404 DELAY_OUT_TAP9 VDD 0.13712f
C405 a_15765_368# a_15964_194# 0.061f
C406 DELAY_OUT_TAP12 a_13368_949# 0.10864f
C407 a_23355_949# VDD 0.15466f
C408 a_14888_949# VDD 0.17577f
C409 a_21044_913# DELAY_OUT_TAP23 0.02053f
C410 MUX_SEL0 a_1544_949# 0.07603f
C411 DELAY_OUT_TAP7 a_9465_949# 0.2079f
C412 VDD a_2297_236# 0.47301f
C413 a_19524_913# VDD 0.28964f
C414 a_24875_949# a_24665_949# 0.09424f
C415 a_25630_949# a_26471_913# 0.28268f
C416 DELAY_OUT_TAP0 a_4157_1218# 0.45374f
C417 DELAY_OUT_TAP4 DELAY_OUT_TAP5 0.06596f
C418 DELAY_OUT_TAP8 DELAY_OUT_TAP9 0.06596f
C419 a_12505_949# a_12791_913# 0.01885f
C420 a_22590_949# a_23431_913# 0.28268f
C421 a_25630_949# a_26395_949# 0.39037f
C422 a_5731_194# VDD 0.63828f
C423 a_5731_194# a_4350_949# 0.40909f
C424 a_20391_913# VDD 0.28469f
C425 a_14964_913# a_13470_949# 0.28279f
C426 a_19550_949# a_19524_913# 0.277f
C427 a_20905_424# VDD 0.30044f
C428 VDD a_8231_913# 0.28469f
C429 a_1256_949# a_1721_1300# 0.13421f
C430 a_2873_1300# a_1256_949# 0.28892f
C431 a_26985_424# a_16108_194# 0.27952f
C432 a_7945_949# a_8155_949# 0.09424f
C433 MUX_SEL0 MUX_SEL1 3.14917f
C434 a_12715_949# a_12791_913# 0.01194f
C435 a_4905_949# DELAY_OUT_TAP1 0.19203f
C436 a_16510_949# a_18795_949# 0.39036f
C437 DELAY_OUT_TAP17 a_17065_949# 0.19203f
C438 a_10430_949# a_10328_949# 0.37183f
C439 a_22590_949# a_23945_424# 0.018f
C440 a_20391_913# a_19550_949# 0.28268f
C441 VDD a_9751_913# 0.29229f
C442 a_25604_913# DELAY_OUT_TAP29 0.0501f
C443 a_25604_913# VDD 0.28964f
C444 a_16510_949# a_16484_913# 0.277f
C445 a_16510_949# a_18004_913# 0.28279f
C446 a_19550_949# a_20905_424# 0.018f
C447 VDD a_5844_913# 0.28358f
C448 MUX_OUT a_16108_194# 0.24265f
C449 a_24084_913# DELAY_OUT_TAP26 0.02312f
C450 a_10430_949# a_11195_949# 0.39037f
C451 a_21835_949# a_21911_913# 0.01194f
C452 VDD DELAY_OUT_TAP29 0.13712f
C453 VDD a_10404_913# 0.28964f
C454 a_5844_913# a_4350_949# 0.28279f
C455 a_5191_913# a_5115_949# 0.01194f
C456 MUX_SEL3 a_3449_236# 0.28429f
C457 MUX_SEL4 a_2297_236# 0.04338f
C458 DELAY_OUT_TAP8 a_9751_913# 0.02339f
C459 VDD a_17865_424# 0.30196f
C460 a_1544_949# MUX_SEL1 0.1672f
C461 VDD a_4350_949# 2.01728f
C462 a_5731_194# a_11785_424# 0.28056f
C463 a_20315_949# a_20391_913# 0.01194f
C464 a_4248_949# a_4324_913# 0.01176f
C465 VDD a_15545_949# 0.29975f
C466 MUX_OUT a_1256_194# 0.1134f
C467 a_24008_949# DELAY_OUT_TAP26 0.10863f
C468 DELAY_OUT_TAP9 a_10430_949# 0.10838f
C469 DELAY_OUT_TAP8 a_10404_913# 0.02011f
C470 VDD DELAY_OUT_TAP4 0.17577f
C471 DELAY_OUT_TAP8 VDD 0.17577f
C472 a_22564_913# VDD 0.28964f
C473 DELAY_OUT_TAP12 a_12791_913# 0.02339f
C474 MUX_SEL4 a_5731_194# 4.60702f
C475 a_8155_949# a_8231_913# 0.01194f
C476 a_4350_949# DELAY_OUT_TAP4 0.02437f
C477 a_14311_913# VDD 0.28469f
C478 a_21044_913# DELAY_OUT_TAP22 0.02312f
C479 MUX_SEL0 a_1256_949# 0.3314f
C480 VDD a_1721_236# 0.45834f
C481 a_19550_949# VDD 2.02235f
C482 VDD a_13444_913# 0.28964f
C483 a_7390_949# a_8745_424# 0.01627f
C484 a_18004_913# DELAY_OUT_TAP19 0.02053f
C485 DELAY_OUT_TAP0 a_3449_1300# 0.01067f
C486 a_14235_949# VDD 0.15466f
C487 a_17928_949# VDD 0.17577f
C488 a_23145_949# DELAY_OUT_TAP25 0.19203f
C489 a_12505_949# a_12715_949# 0.09424f
C490 a_18871_913# a_18585_949# 0.01885f
C491 DELAY_OUT_TAP13 DELAY_OUT_TAP14 0.02068f
C492 a_22590_949# a_23355_949# 0.39037f
C493 a_18004_913# DELAY_OUT_TAP18 0.02312f
C494 a_5731_194# a_10430_949# 0.40957f
C495 a_21911_913# DELAY_OUT_TAP24 0.02339f
C496 a_17351_913# a_17065_949# 0.01885f
C497 a_1544_194# a_2297_236# 0.27303f
C498 a_1256_194# a_2873_236# 0.27926f
C499 a_20315_949# VDD 0.15466f
C500 DELAY_OUT_TAP20 DELAY_OUT_TAP21 0.06596f
C501 a_14888_949# a_13470_949# 0.38994f
C502 a_19448_949# a_19524_913# 0.01176f
C503 a_14235_949# a_14311_913# 0.01194f
C504 VDD a_11785_424# 0.29891f
C505 a_1256_949# a_1544_949# 1.26509f
C506 VDD a_8155_949# 0.15466f
C507 MUX_SEL3 MUX_OUT 0.79533f
C508 a_23945_424# a_16108_194# 0.2906f
C509 DELAY_OUT_TAP17 VDD 0.13881f
C510 a_9675_949# a_9751_913# 0.01194f
C511 a_9465_949# a_7390_949# 0.03208f
C512 a_25630_949# a_25604_913# 0.277f
C513 a_26471_913# a_26185_949# 0.01885f
C514 MUX_SEL4 VDD 4.25382f
C515 a_4157_1218# DELAY_OUT_TAP1 0.01771f
C516 a_7364_913# DELAY_OUT_TAP5 0.0501f
C517 a_5731_194# a_13470_949# 0.40967f
C518 MUX_SEL4 a_4350_949# 0.09136f
C519 a_20315_949# a_19550_949# 0.39037f
C520 a_25604_913# DELAY_OUT_TAP28 0.02011f
C521 a_25630_949# DELAY_OUT_TAP29 0.10838f
C522 VDD a_9675_949# 0.15484f
C523 a_5768_949# a_5844_913# 0.01176f
C524 a_20105_949# DELAY_OUT_TAP21 0.19203f
C525 a_21911_913# a_21625_949# 0.01885f
C526 a_25630_949# VDD 2.01433f
C527 a_26395_949# a_26185_949# 0.09424f
C528 a_16408_949# a_16484_913# 0.01176f
C529 a_14964_913# DELAY_OUT_TAP15 0.02053f
C530 VDD a_5768_949# 0.17577f
C531 DELAY_OUT_TAP28 DELAY_OUT_TAP29 0.06596f
C532 MUX_OUT a_15964_194# 0.01307f
C533 a_10430_949# a_10404_913# 0.277f
C534 VDD DELAY_OUT_TAP28 0.17575f
C535 a_5768_949# a_4350_949# 0.38994f
C536 VDD a_10430_949# 2.01462f
C537 MUX_SEL3 a_2873_236# 0.12606f
C538 MUX_SEL4 a_1721_236# 0.05813f
C539 MUX_SEL2 a_3449_236# 0.10741f
C540 DELAY_OUT_TAP24 DELAY_OUT_TAP25 0.06596f
C541 VDD a_16851_214# 0.53195f
C542 a_1256_949# MUX_SEL1 1.44243f
C543 VDD a_4248_949# 0.18405f
R0 VDD.t0 VDD.t19 17.2438
R1 VDD.n1 VDD.t0 0.121072
R2 VDD.n9 VDD.n28 0.494986
R3 VDD.t0 VDD.n70 0.64182
R4 VDD.n401 VDD.n400 9.0005
R5 VDD.n402 VDD.n111 9.0005
R6 VDD.n403 VDD.n110 9.0005
R7 VDD.n228 VDD.n73 9.0005
R8 VDD.n229 VDD.n227 9.0005
R9 VDD.n231 VDD.n230 9.0005
R10 VDD.n232 VDD.n226 9.0005
R11 VDD.n234 VDD.n233 9.0005
R12 VDD.n235 VDD.n225 9.0005
R13 VDD.n237 VDD.n236 9.0005
R14 VDD.n238 VDD.n224 9.0005
R15 VDD.n240 VDD.n239 9.0005
R16 VDD.n241 VDD.n223 9.0005
R17 VDD.n243 VDD.n242 9.0005
R18 VDD.n244 VDD.n222 9.0005
R19 VDD.n246 VDD.n245 9.0005
R20 VDD.n247 VDD.n221 9.0005
R21 VDD.n249 VDD.n248 9.0005
R22 VDD.n250 VDD.n220 9.0005
R23 VDD.n252 VDD.n251 9.0005
R24 VDD.n254 VDD.n253 9.0005
R25 VDD.n255 VDD.n219 9.0005
R26 VDD.n257 VDD.n256 9.0005
R27 VDD.n258 VDD.n218 9.0005
R28 VDD.n260 VDD.n259 9.0005
R29 VDD.n261 VDD.n217 9.0005
R30 VDD.n263 VDD.n262 9.0005
R31 VDD.n264 VDD.n216 9.0005
R32 VDD.n265 VDD.n47 9.11485
R33 VDD.n266 VDD.n215 9.0005
R34 VDD.n268 VDD.n267 9.0005
R35 VDD.n269 VDD.n214 9.0005
R36 VDD.n271 VDD.n270 9.0005
R37 VDD.n272 VDD.n213 9.0005
R38 VDD.n274 VDD.n273 9.0005
R39 VDD.n275 VDD.n212 9.0005
R40 VDD.n276 VDD.n211 9.0005
R41 VDD.n278 VDD.n277 9.0005
R42 VDD.n279 VDD.n100 9.0005
R43 VDD.n281 VDD.n280 9.0005
R44 VDD.n282 VDD.n210 9.0005
R45 VDD.n284 VDD.n283 9.0005
R46 VDD.n285 VDD.n86 9.0005
R47 VDD.n287 VDD.n286 9.0005
R48 VDD.n288 VDD.n209 9.0005
R49 VDD.n290 VDD.n289 9.0005
R50 VDD.n291 VDD.n79 9.0005
R51 VDD.n293 VDD.n292 9.0005
R52 VDD.n207 VDD.n202 9.0005
R53 VDD.n206 VDD.n201 9.0005
R54 VDD.n205 VDD.n200 9.0005
R55 VDD.n204 VDD.n199 9.0005
R56 VDD.n203 VDD.n88 9.0005
R57 VDD.n294 VDD.n198 9.0005
R58 VDD.n295 VDD.n197 9.0005
R59 VDD.n297 VDD.n296 9.0005
R60 VDD.n298 VDD.n99 9.0005
R61 VDD.n300 VDD.n299 9.0005
R62 VDD.n301 VDD.n196 9.0005
R63 VDD.n303 VDD.n302 9.0005
R64 VDD.n304 VDD.n85 9.0005
R65 VDD.n306 VDD.n305 9.0005
R66 VDD.n307 VDD.n195 9.0005
R67 VDD.n309 VDD.n308 9.0005
R68 VDD.n310 VDD.n80 9.0005
R69 VDD.n312 VDD.n311 9.0005
R70 VDD.n194 VDD.n188 9.0005
R71 VDD.n193 VDD.n187 9.0005
R72 VDD.n192 VDD.n186 9.0005
R73 VDD.n191 VDD.n185 9.0005
R74 VDD.n190 VDD.n184 9.0005
R75 VDD.n189 VDD.n90 9.0005
R76 VDD.n313 VDD.n183 9.0005
R77 VDD.n314 VDD.n182 9.0005
R78 VDD.n316 VDD.n315 9.0005
R79 VDD.n317 VDD.n98 9.0005
R80 VDD.n319 VDD.n318 9.0005
R81 VDD.n320 VDD.n181 9.0005
R82 VDD.n322 VDD.n321 9.0005
R83 VDD.n323 VDD.n84 9.0005
R84 VDD.n325 VDD.n324 9.0005
R85 VDD.n326 VDD.n180 9.0005
R86 VDD.n328 VDD.n327 9.0005
R87 VDD.n329 VDD.n81 9.0005
R88 VDD.n331 VDD.n330 9.0005
R89 VDD.n179 VDD.n155 9.0005
R90 VDD.n178 VDD.n154 9.0005
R91 VDD.n177 VDD.n153 9.0005
R92 VDD.n176 VDD.n152 9.0005
R93 VDD.n175 VDD.n151 9.0005
R94 VDD.n174 VDD.n150 9.0005
R95 VDD.n173 VDD.n149 9.0005
R96 VDD.n172 VDD.n148 9.0005
R97 VDD.n171 VDD.n48 9.11485
R98 VDD.n170 VDD.n147 9.0005
R99 VDD.n169 VDD.n146 9.0005
R100 VDD.n168 VDD.n145 9.0005
R101 VDD.n167 VDD.n144 9.0005
R102 VDD.n166 VDD.n143 9.0005
R103 VDD.n165 VDD.n142 9.0005
R104 VDD.n164 VDD.n141 9.0005
R105 VDD.n163 VDD.n140 9.0005
R106 VDD.n162 VDD.n49 9.11485
R107 VDD.n160 VDD.n139 9.0005
R108 VDD.n159 VDD.n138 9.0005
R109 VDD.n158 VDD.n137 9.0005
R110 VDD.n157 VDD.n136 9.0005
R111 VDD.n156 VDD.n92 9.0005
R112 VDD.n332 VDD.n135 9.0005
R113 VDD.n333 VDD.n134 9.0005
R114 VDD.n335 VDD.n334 9.0005
R115 VDD.n336 VDD.n97 9.0005
R116 VDD.n338 VDD.n337 9.0005
R117 VDD.n339 VDD.n133 9.0005
R118 VDD.n341 VDD.n340 9.0005
R119 VDD.n342 VDD.n83 9.0005
R120 VDD.n344 VDD.n343 9.0005
R121 VDD.n345 VDD.n132 9.0005
R122 VDD.n347 VDD.n346 9.0005
R123 VDD.n348 VDD.n82 9.0005
R124 VDD.n350 VDD.n349 9.0005
R125 VDD.n130 VDD.n126 9.0005
R126 VDD.n129 VDD.n125 9.0005
R127 VDD.n128 VDD.n124 9.0005
R128 VDD.n127 VDD.n123 9.0005
R129 VDD.n94 VDD.n122 9.0005
R130 VDD.n352 VDD.n351 9.0005
R131 VDD.n353 VDD.n60 9.0005
R132 VDD.n355 VDD.n354 9.0005
R133 VDD.n356 VDD.n121 9.0005
R134 VDD.n358 VDD.n357 9.0005
R135 VDD.n359 VDD.n103 9.0005
R136 VDD.n361 VDD.n360 9.0005
R137 VDD.n362 VDD.n120 9.0005
R138 VDD.n364 VDD.n363 9.0005
R139 VDD.n365 VDD.n119 9.0005
R140 VDD.n367 VDD.n366 9.0005
R141 VDD.n368 VDD.n118 9.0005
R142 VDD.n370 VDD.n369 9.0005
R143 VDD.n372 VDD.n371 9.0005
R144 VDD.n373 VDD.n117 9.0005
R145 VDD.n375 VDD.n374 9.0005
R146 VDD.n376 VDD.n68 9.0005
R147 VDD.n378 VDD.n377 9.0005
R148 VDD.n379 VDD.n116 9.0005
R149 VDD.n381 VDD.n380 9.0005
R150 VDD.n382 VDD.n67 9.0005
R151 VDD.n384 VDD.n383 9.0005
R152 VDD.n385 VDD.n115 9.0005
R153 VDD.n387 VDD.n386 9.0005
R154 VDD.n388 VDD.n101 9.0005
R155 VDD.n390 VDD.n389 9.0005
R156 VDD.n391 VDD.n114 9.0005
R157 VDD.n393 VDD.n392 9.0005
R158 VDD.n394 VDD.n113 9.0005
R159 VDD.n396 VDD.n395 9.0005
R160 VDD.n397 VDD.n112 9.0005
R161 VDD.n399 VDD.n398 9.0005
R162 VDD.n372 VDD.n13 9.0005
R163 VDD.n373 VDD.n77 0.116823
R164 VDD.n77 VDD.n13 4.44309
R165 VDD.n50 VDD.n68 0.116823
R166 VDD.n50 VDD.n12 4.44309
R167 VDD.n96 VDD.n12 4.44309
R168 VDD.n380 VDD.n96 0.116823
R169 VDD.n66 VDD.n67 0.116823
R170 VDD.n66 VDD.n12 4.44309
R171 VDD.n385 VDD.n12 9.0005
R172 VDD.n386 VDD.n102 0.116823
R173 VDD.n12 VDD.n102 4.44309
R174 VDD.n25 VDD.n12 4.44309
R175 VDD.n391 VDD.n25 0.116823
R176 VDD.n78 VDD.n11 4.44309
R177 VDD.n113 VDD.n78 0.116823
R178 VDD.n396 VDD.n57 0.116823
R179 VDD.n57 VDD.n11 4.44309
R180 VDD.n398 VDD.n11 9.0005
R181 VDD.n400 VDD.n11 9.0005
R182 VDD.n111 VDD.n76 0.114852
R183 VDD.n76 VDD.n11 4.44407
R184 VDD.n59 VDD.n58 4.44407
R185 VDD.n403 VDD.n59 0.114852
R186 VDD.t0 VDD.n72 4.44407
R187 VDD.n227 VDD.n72 0.114852
R188 VDD.n231 VDD.t0 9.0005
R189 VDD.n232 VDD.n33 0.114852
R190 VDD.n33 VDD.t0 4.44407
R191 VDD.n225 VDD.n30 0.114852
R192 VDD.n30 VDD.t0 4.44407
R193 VDD.n238 VDD.n27 9.0005
R194 VDD.n71 VDD.n27 4.44407
R195 VDD.n223 VDD.n71 0.114852
R196 VDD.n43 VDD.n27 4.44407
R197 VDD.n244 VDD.n43 0.114852
R198 VDD.n245 VDD.n27 9.0005
R199 VDD.n221 VDD.n17 9.0005
R200 VDD.n46 VDD.n17 4.44407
R201 VDD.n250 VDD.n46 0.114852
R202 VDD.n251 VDD.n17 9.0005
R203 VDD.n253 VDD.t0 9.0005
R204 VDD.n219 VDD.n75 0.114852
R205 VDD.n75 VDD.t0 4.44407
R206 VDD.n258 VDD.n21 0.114852
R207 VDD.n21 VDD.t0 4.44407
R208 VDD.n44 VDD.t0 4.44407
R209 VDD.n263 VDD.n44 0.114852
R210 VDD.n47 VDD.t0 4.44407
R211 VDD.n215 VDD.n70 9.0005
R212 VDD.n268 VDD.n69 9.0005
R213 VDD.n269 VDD.n45 0.114852
R214 VDD.n45 VDD.n20 4.44407
R215 VDD.n213 VDD.n20 9.0005
R216 VDD.n87 VDD.n20 4.44407
R217 VDD.n275 VDD.n87 0.114852
R218 VDD.n38 VDD.n20 4.44407
R219 VDD.n277 VDD.n38 0.114852
R220 VDD.n20 VDD.n100 9.0005
R221 VDD.n281 VDD.n108 0.114852
R222 VDD.n108 VDD.n20 4.44407
R223 VDD.n283 VDD.n20 9.0005
R224 VDD.n18 VDD.n86 9.0005
R225 VDD.n65 VDD.n18 4.44407
R226 VDD.n288 VDD.n65 0.114852
R227 VDD.n289 VDD.n52 0.114852
R228 VDD.n18 VDD.n52 4.44407
R229 VDD.n18 VDD.n293 9.0005
R230 VDD.n18 VDD.n23 4.44407
R231 VDD.n23 VDD.n202 0.114852
R232 VDD.n18 VDD.n37 4.44407
R233 VDD.n37 VDD.n200 0.114852
R234 VDD.n18 VDD.n199 9.0005
R235 VDD.n18 VDD.n89 4.44407
R236 VDD.n294 VDD.n89 0.114852
R237 VDD.n39 VDD.n18 4.44407
R238 VDD.n296 VDD.n39 0.114852
R239 VDD.n9 VDD.n99 9.0005
R240 VDD.n300 VDD.n107 0.114852
R241 VDD.n107 VDD.n9 4.44407
R242 VDD.n302 VDD.n10 0.114852
R243 VDD.n9 VDD.n10 4.44407
R244 VDD.n64 VDD.n9 4.44407
R245 VDD.n307 VDD.n64 0.114852
R246 VDD.n308 VDD.n53 0.114852
R247 VDD.n9 VDD.n53 4.44407
R248 VDD.n9 VDD.n312 9.0005
R249 VDD.n9 VDD.n188 9.0005
R250 VDD.n7 VDD.n187 9.0005
R251 VDD.n7 VDD.n36 4.44309
R252 VDD.n36 VDD.n185 0.116823
R253 VDD.n7 VDD.n184 9.0005
R254 VDD.n7 VDD.n91 4.44309
R255 VDD.n313 VDD.n91 0.116823
R256 VDD.n40 VDD.n7 4.44309
R257 VDD.n315 VDD.n40 0.116823
R258 VDD.n7 VDD.n98 9.0005
R259 VDD.n319 VDD.n106 0.116823
R260 VDD.n106 VDD.n7 4.44309
R261 VDD.n321 VDD.n8 0.116823
R262 VDD.n7 VDD.n8 4.44309
R263 VDD.n63 VDD.n7 4.44309
R264 VDD.n326 VDD.n63 0.116823
R265 VDD.n327 VDD.n54 0.116823
R266 VDD.n7 VDD.n54 4.44309
R267 VDD.n7 VDD.n331 9.0005
R268 VDD.n7 VDD.n155 9.0005
R269 VDD.n14 VDD.n154 9.0005
R270 VDD.n14 VDD.n31 4.44407
R271 VDD.n31 VDD.n152 0.114852
R272 VDD.n14 VDD.n151 9.0005
R273 VDD.n14 VDD.n32 4.44407
R274 VDD.n32 VDD.n149 0.114852
R275 VDD.n14 VDD.n48 4.44407
R276 VDD.n14 VDD.n147 9.0005
R277 VDD.n74 VDD.n146 0.114852
R278 VDD.t0 VDD.n74 4.44407
R279 VDD.n51 VDD.n144 0.114852
R280 VDD.t0 VDD.n51 4.44407
R281 VDD.n29 VDD.n142 0.114852
R282 VDD.t0 VDD.n29 4.44407
R283 VDD.t0 VDD.n49 4.44407
R284 VDD.n4 VDD.n161 9.11485
R285 VDD.t0 VDD.n4 4.44407
R286 VDD.n0 VDD.n34 4.44407
R287 VDD.n34 VDD.n137 0.114852
R288 VDD.n0 VDD.n136 9.0005
R289 VDD.n0 VDD.n93 4.44407
R290 VDD.n332 VDD.n93 0.114852
R291 VDD.n333 VDD.n41 0.114852
R292 VDD.n41 VDD.n0 4.44407
R293 VDD.n0 VDD.n97 9.0005
R294 VDD.n338 VDD.n105 0.114852
R295 VDD.n105 VDD.n0 4.44407
R296 VDD.n24 VDD.n0 4.44407
R297 VDD.n24 VDD.n83 0.114852
R298 VDD.n62 VDD.n0 4.44407
R299 VDD.n345 VDD.n62 0.114852
R300 VDD.n346 VDD.n55 0.114852
R301 VDD.n0 VDD.n55 4.44407
R302 VDD.n0 VDD.n350 9.0005
R303 VDD.n0 VDD.n19 4.44407
R304 VDD.n19 VDD.n126 0.114852
R305 VDD.n0 VDD.n35 4.44407
R306 VDD.n35 VDD.n124 0.114852
R307 VDD.n0 VDD.n123 9.0005
R308 VDD.n0 VDD.n95 4.44407
R309 VDD.n351 VDD.n95 0.114852
R310 VDD.n42 VDD.n60 0.114852
R311 VDD.n42 VDD.n0 4.44407
R312 VDD.n356 VDD.n13 9.0005
R313 VDD.n357 VDD.n104 0.114852
R314 VDD.n13 VDD.n104 4.44407
R315 VDD.n361 VDD.n26 0.114852
R316 VDD.n26 VDD.n13 4.44407
R317 VDD.n61 VDD.n13 4.44407
R318 VDD.n61 VDD.n119 0.114852
R319 VDD.n367 VDD.n56 0.114852
R320 VDD.n56 VDD.n13 4.44407
R321 VDD.n369 VDD.n13 9.0005
R322 VDD.t0 VDD.t82 8.76054
R323 VDD.t0 VDD.t148 8.76054
R324 VDD.t0 VDD.t72 8.76054
R325 VDD.t0 VDD.t144 8.76054
R326 VDD.t0 VDD.t169 8.76054
R327 VDD.t0 VDD.t135 8.76054
R328 VDD.n27 VDD.t65 8.76054
R329 VDD.n27 VDD.t143 8.76054
R330 VDD.n27 VDD.t58 8.76054
R331 VDD.n27 VDD.t129 8.76054
R332 VDD.n27 VDD.t81 8.76054
R333 VDD.n27 VDD.t139 8.76054
R334 VDD.n17 VDD.t168 8.76054
R335 VDD.n17 VDD.t133 8.76054
R336 VDD.n17 VDD.t17 8.76054
R337 VDD.n17 VDD.t114 8.76054
R338 VDD.t0 VDD.t20 8.76054
R339 VDD.n3 VDD.n15 0.361071
R340 VDD.n28 VDD.t0 0.546946
R341 VDD.n22 VDD.t0 0.206569
R342 VDD.t0 VDD.n58 0.545865
R343 VDD.n11 VDD.t189 7.62594
R344 VDD.n20 VDD.t206 7.62594
R345 VDD.n18 VDD.t203 7.62594
R346 VDD.n7 VDD.t200 7.62594
R347 VDD.n0 VDD.t197 7.62594
R348 VDD.n0 VDD.t194 7.62594
R349 VDD.n12 VDD.t191 7.62594
R350 VDD.n12 VDD.t190 7.62594
R351 VDD.n13 VDD.t192 7.62594
R352 VDD.n13 VDD.t193 7.62594
R353 VDD.n0 VDD.t195 7.62594
R354 VDD.n0 VDD.t196 7.62594
R355 VDD.n7 VDD.t198 7.62594
R356 VDD.n7 VDD.t199 7.62594
R357 VDD.n9 VDD.t201 7.62594
R358 VDD.n9 VDD.t202 7.62594
R359 VDD.n18 VDD.t204 7.62594
R360 VDD.n20 VDD.t205 7.62594
R361 VDD.n11 VDD.t87 5.99122
R362 VDD.n13 VDD.t107 5.99122
R363 VDD.n0 VDD.t77 5.99122
R364 VDD.n7 VDD.t90 5.99122
R365 VDD.n9 VDD.t78 5.99122
R366 VDD.n18 VDD.t132 5.99122
R367 VDD.n17 VDD.t46 5.98839
R368 VDD.t0 VDD.t156 5.97169
R369 VDD.n27 VDD.t150 5.97169
R370 VDD.n27 VDD.t140 5.97169
R371 VDD.n17 VDD.t115 5.97169
R372 VDD.t0 VDD.t86 5.97146
R373 VDD.n27 VDD.t66 5.97146
R374 VDD.n27 VDD.t84 5.97146
R375 VDD.n17 VDD.t18 5.97146
R376 VDD.n11 VDD.t53 5.96935
R377 VDD.n20 VDD.t176 5.96935
R378 VDD.n18 VDD.t34 5.96935
R379 VDD.n18 VDD.t32 5.96935
R380 VDD.n7 VDD.t99 5.96935
R381 VDD.n9 VDD.t95 5.96935
R382 VDD.n0 VDD.t60 5.96935
R383 VDD.n7 VDD.t6 5.96935
R384 VDD.n0 VDD.t13 5.96935
R385 VDD.n0 VDD.t125 5.96935
R386 VDD.n12 VDD.t38 5.96935
R387 VDD.n13 VDD.t109 5.96935
R388 VDD.n12 VDD.t31 5.96935
R389 VDD.n12 VDD.t37 5.96935
R390 VDD.n12 VDD.t177 5.96935
R391 VDD.n12 VDD.t27 5.96935
R392 VDD.n13 VDD.t25 5.96935
R393 VDD.n13 VDD.t29 5.96935
R394 VDD.n13 VDD.t103 5.96935
R395 VDD.n0 VDD.t21 5.96935
R396 VDD.n0 VDD.t16 5.96935
R397 VDD.n0 VDD.t153 5.96935
R398 VDD.n0 VDD.t93 5.96935
R399 VDD.n0 VDD.t111 5.96935
R400 VDD.n7 VDD.t50 5.96935
R401 VDD.n7 VDD.t121 5.96935
R402 VDD.n7 VDD.t105 5.96935
R403 VDD.n7 VDD.t1 5.96935
R404 VDD.n9 VDD.t101 5.96935
R405 VDD.n9 VDD.t43 5.96935
R406 VDD.n9 VDD.t69 5.96935
R407 VDD.n18 VDD.t188 5.96935
R408 VDD.n18 VDD.t186 5.96935
R409 VDD.n20 VDD.t74 5.96935
R410 VDD.n20 VDD.t48 5.96935
R411 VDD.n20 VDD.t4 5.96935
R412 VDD.n58 VDD.t134 5.96578
R413 VDD.n11 VDD.t91 5.96534
R414 VDD.n11 VDD.t126 5.96534
R415 VDD.n11 VDD.t179 5.96534
R416 VDD.n15 VDD.t110 5.96534
R417 VDD.n15 VDD.t39 5.96534
R418 VDD.t0 VDD.t130 5.96534
R419 VDD.n17 VDD.t76 5.96534
R420 VDD.t0 VDD.t75 5.96534
R421 VDD.t0 VDD.t113 5.96534
R422 VDD.t0 VDD.t3 5.96534
R423 VDD.n70 VDD.t127 5.96534
R424 VDD.n20 VDD.t184 5.96534
R425 VDD.n20 VDD.t122 5.96534
R426 VDD.n18 VDD.t52 5.96534
R427 VDD.n18 VDD.t159 5.96534
R428 VDD.n18 VDD.t108 5.96534
R429 VDD.n18 VDD.t157 5.96534
R430 VDD.n9 VDD.t98 5.96534
R431 VDD.n9 VDD.t137 5.96534
R432 VDD.n7 VDD.t70 5.96534
R433 VDD.n7 VDD.t80 5.96534
R434 VDD.n7 VDD.t51 5.96534
R435 VDD.n7 VDD.t162 5.96534
R436 VDD.n14 VDD.t11 5.96534
R437 VDD.n14 VDD.t118 5.96534
R438 VDD.n14 VDD.t45 5.96534
R439 VDD.n14 VDD.t146 5.96534
R440 VDD.t0 VDD.t56 5.96534
R441 VDD.t0 VDD.t117 5.96534
R442 VDD.t0 VDD.t12 5.96534
R443 VDD.t0 VDD.t161 5.96534
R444 VDD.n0 VDD.t42 5.96534
R445 VDD.n0 VDD.t89 5.96534
R446 VDD.n0 VDD.t9 5.96534
R447 VDD.n0 VDD.t79 5.96534
R448 VDD.n0 VDD.t94 5.96534
R449 VDD.n0 VDD.t22 5.96534
R450 VDD.n13 VDD.t180 5.96534
R451 VDD.n13 VDD.t63 5.96534
R452 VDD.n13 VDD.t23 5.96534
R453 VDD.n12 VDD.t165 5.96534
R454 VDD.n12 VDD.t167 5.96534
R455 VDD.n12 VDD.t181 5.96534
R456 VDD.n12 VDD.t40 5.96534
R457 VDD.n13 VDD.t175 5.96534
R458 VDD.n0 VDD.t28 5.96534
R459 VDD.n13 VDD.t172 5.96534
R460 VDD.n0 VDD.t10 5.96534
R461 VDD.n0 VDD.t106 5.96534
R462 VDD.n0 VDD.t160 5.96534
R463 VDD.n7 VDD.t62 5.96534
R464 VDD.n7 VDD.t8 5.96534
R465 VDD.n7 VDD.t141 5.96534
R466 VDD.n9 VDD.t178 5.96534
R467 VDD.n18 VDD.t97 5.96534
R468 VDD.n9 VDD.t142 5.96534
R469 VDD.n20 VDD.t71 5.96534
R470 VDD.n20 VDD.t55 5.96534
R471 VDD.n20 VDD.t123 5.96534
R472 VDD.n11 VDD.t158 5.96512
R473 VDD.n69 VDD.t64 5.96512
R474 VDD.n58 VDD.t170 5.96512
R475 VDD.t0 VDD.t57 5.96512
R476 VDD.n18 VDD.t41 5.96512
R477 VDD.n7 VDD.t112 5.96512
R478 VDD.t0 VDD.t88 5.96512
R479 VDD.n14 VDD.t174 5.96512
R480 VDD.n14 VDD.t138 5.96512
R481 VDD.n0 VDD.t171 5.96512
R482 VDD.n13 VDD.t67 5.96512
R483 VDD.n11 VDD.t54 5.65005
R484 VDD.n20 VDD.t5 5.65005
R485 VDD.n18 VDD.t35 5.65005
R486 VDD.n7 VDD.t2 5.65005
R487 VDD.n0 VDD.t61 5.65005
R488 VDD.n0 VDD.t14 5.65005
R489 VDD.n12 VDD.t36 5.65005
R490 VDD.n12 VDD.t26 5.65005
R491 VDD.n13 VDD.t24 5.65005
R492 VDD.n13 VDD.t30 5.65005
R493 VDD.n0 VDD.t15 5.65005
R494 VDD.n0 VDD.t92 5.65005
R495 VDD.n7 VDD.t7 5.65005
R496 VDD.n7 VDD.t104 5.65005
R497 VDD.n9 VDD.t96 5.65005
R498 VDD.n9 VDD.t44 5.65005
R499 VDD.n18 VDD.t33 5.65005
R500 VDD.n20 VDD.t47 5.65005
R501 VDD.n254 VDD.n252 0.692362
R502 VDD.n266 VDD.n265 0.461741
R503 VDD.n292 VDD.n208 0.461741
R504 VDD.n311 VDD.n194 0.461741
R505 VDD.n330 VDD.n179 0.461741
R506 VDD.n171 VDD.n170 0.461741
R507 VDD.n162 VDD.n161 0.461741
R508 VDD.n349 VDD.n131 0.461741
R509 VDD.n371 VDD.n370 0.461741
R510 VDD.n401 VDD.n399 0.461741
R511 VDD.n373 VDD.n372 0.235167
R512 VDD.n374 VDD.n77 0.116823
R513 VDD.n374 VDD.n68 0.235167
R514 VDD.n378 VDD.n50 0.116823
R515 VDD.n379 VDD.n378 0.235167
R516 VDD.n96 VDD.n379 0.116823
R517 VDD.n380 VDD.n67 0.235167
R518 VDD.n384 VDD.n66 0.116823
R519 VDD.n385 VDD.n384 0.235167
R520 VDD.n386 VDD.n385 0.235167
R521 VDD.n102 VDD.n101 0.116823
R522 VDD.n390 VDD.n101 0.235167
R523 VDD.n25 VDD.n390 0.116823
R524 VDD.n392 VDD.n391 0.235167
R525 VDD.n392 VDD.n78 0.116823
R526 VDD.n396 VDD.n113 0.235167
R527 VDD.n397 VDD.n57 0.116823
R528 VDD.n398 VDD.n397 0.235167
R529 VDD.n188 VDD.n187 0.235167
R530 VDD.n187 VDD.n186 0.235167
R531 VDD.n186 VDD.n36 0.116823
R532 VDD.n185 VDD.n184 0.235167
R533 VDD.n184 VDD.n90 0.235167
R534 VDD.n91 VDD.n90 0.116823
R535 VDD.n314 VDD.n313 0.235167
R536 VDD.n40 VDD.n314 0.116823
R537 VDD.n315 VDD.n98 0.235167
R538 VDD.n319 VDD.n98 0.235167
R539 VDD.n320 VDD.n106 0.116823
R540 VDD.n321 VDD.n320 0.235167
R541 VDD.n8 VDD.n84 0.116823
R542 VDD.n325 VDD.n84 0.235167
R543 VDD.n63 VDD.n325 0.116823
R544 VDD.n327 VDD.n326 0.235167
R545 VDD.n54 VDD.n81 0.116823
R546 VDD.n331 VDD.n81 0.235167
R547 VDD.n404 VDD.n110 0.231121
R548 VDD.n228 VDD.n110 0.231121
R549 VDD.n229 VDD.n228 0.231121
R550 VDD.n230 VDD.n229 0.231121
R551 VDD.n230 VDD.n226 0.231121
R552 VDD.n234 VDD.n226 0.231121
R553 VDD.n235 VDD.n234 0.231121
R554 VDD.n236 VDD.n235 0.231121
R555 VDD.n236 VDD.n224 0.231121
R556 VDD.n240 VDD.n224 0.231121
R557 VDD.n241 VDD.n240 0.231121
R558 VDD.n242 VDD.n241 0.231121
R559 VDD.n242 VDD.n222 0.231121
R560 VDD.n246 VDD.n222 0.231121
R561 VDD.n247 VDD.n246 0.231121
R562 VDD.n248 VDD.n247 0.231121
R563 VDD.n248 VDD.n220 0.231121
R564 VDD.n252 VDD.n220 0.231121
R565 VDD.n255 VDD.n254 0.231121
R566 VDD.n256 VDD.n255 0.231121
R567 VDD.n256 VDD.n218 0.231121
R568 VDD.n260 VDD.n218 0.231121
R569 VDD.n261 VDD.n260 0.231121
R570 VDD.n262 VDD.n261 0.231121
R571 VDD.n262 VDD.n216 0.231121
R572 VDD.n265 VDD.n216 0.231121
R573 VDD.n267 VDD.n266 0.231121
R574 VDD.n267 VDD.n214 0.231121
R575 VDD.n271 VDD.n214 0.231121
R576 VDD.n272 VDD.n271 0.231121
R577 VDD.n273 VDD.n272 0.231121
R578 VDD.n273 VDD.n212 0.231121
R579 VDD.n212 VDD.n211 0.231121
R580 VDD.n278 VDD.n211 0.231121
R581 VDD.n279 VDD.n278 0.231121
R582 VDD.n280 VDD.n279 0.231121
R583 VDD.n280 VDD.n210 0.231121
R584 VDD.n284 VDD.n210 0.231121
R585 VDD.n285 VDD.n284 0.231121
R586 VDD.n286 VDD.n285 0.231121
R587 VDD.n286 VDD.n209 0.231121
R588 VDD.n290 VDD.n209 0.231121
R589 VDD.n291 VDD.n290 0.231121
R590 VDD.n292 VDD.n291 0.231121
R591 VDD.n208 VDD.n207 0.231121
R592 VDD.n207 VDD.n206 0.231121
R593 VDD.n206 VDD.n205 0.231121
R594 VDD.n205 VDD.n204 0.231121
R595 VDD.n204 VDD.n203 0.231121
R596 VDD.n203 VDD.n198 0.231121
R597 VDD.n198 VDD.n197 0.231121
R598 VDD.n297 VDD.n197 0.231121
R599 VDD.n298 VDD.n297 0.231121
R600 VDD.n299 VDD.n298 0.231121
R601 VDD.n299 VDD.n196 0.231121
R602 VDD.n303 VDD.n196 0.231121
R603 VDD.n304 VDD.n303 0.231121
R604 VDD.n305 VDD.n304 0.231121
R605 VDD.n305 VDD.n195 0.231121
R606 VDD.n309 VDD.n195 0.231121
R607 VDD.n310 VDD.n309 0.231121
R608 VDD.n311 VDD.n310 0.231121
R609 VDD.n194 VDD.n193 0.231121
R610 VDD.n193 VDD.n192 0.231121
R611 VDD.n192 VDD.n191 0.231121
R612 VDD.n191 VDD.n190 0.231121
R613 VDD.n190 VDD.n189 0.231121
R614 VDD.n189 VDD.n183 0.231121
R615 VDD.n183 VDD.n182 0.231121
R616 VDD.n316 VDD.n182 0.231121
R617 VDD.n317 VDD.n316 0.231121
R618 VDD.n318 VDD.n317 0.231121
R619 VDD.n318 VDD.n181 0.231121
R620 VDD.n322 VDD.n181 0.231121
R621 VDD.n323 VDD.n322 0.231121
R622 VDD.n324 VDD.n323 0.231121
R623 VDD.n324 VDD.n180 0.231121
R624 VDD.n328 VDD.n180 0.231121
R625 VDD.n329 VDD.n328 0.231121
R626 VDD.n330 VDD.n329 0.231121
R627 VDD.n179 VDD.n178 0.231121
R628 VDD.n178 VDD.n177 0.231121
R629 VDD.n177 VDD.n176 0.231121
R630 VDD.n176 VDD.n175 0.231121
R631 VDD.n175 VDD.n174 0.231121
R632 VDD.n174 VDD.n173 0.231121
R633 VDD.n173 VDD.n172 0.231121
R634 VDD.n172 VDD.n171 0.231121
R635 VDD.n170 VDD.n169 0.231121
R636 VDD.n169 VDD.n168 0.231121
R637 VDD.n168 VDD.n167 0.231121
R638 VDD.n167 VDD.n166 0.231121
R639 VDD.n166 VDD.n165 0.231121
R640 VDD.n165 VDD.n164 0.231121
R641 VDD.n164 VDD.n163 0.231121
R642 VDD.n163 VDD.n162 0.231121
R643 VDD.n161 VDD.n160 0.231121
R644 VDD.n160 VDD.n159 0.231121
R645 VDD.n159 VDD.n158 0.231121
R646 VDD.n158 VDD.n157 0.231121
R647 VDD.n157 VDD.n156 0.231121
R648 VDD.n156 VDD.n135 0.231121
R649 VDD.n135 VDD.n134 0.231121
R650 VDD.n335 VDD.n134 0.231121
R651 VDD.n336 VDD.n335 0.231121
R652 VDD.n337 VDD.n336 0.231121
R653 VDD.n337 VDD.n133 0.231121
R654 VDD.n341 VDD.n133 0.231121
R655 VDD.n342 VDD.n341 0.231121
R656 VDD.n343 VDD.n342 0.231121
R657 VDD.n343 VDD.n132 0.231121
R658 VDD.n347 VDD.n132 0.231121
R659 VDD.n348 VDD.n347 0.231121
R660 VDD.n349 VDD.n348 0.231121
R661 VDD.n131 VDD.n130 0.231121
R662 VDD.n130 VDD.n129 0.231121
R663 VDD.n129 VDD.n128 0.231121
R664 VDD.n128 VDD.n127 0.231121
R665 VDD.n127 VDD.n122 0.231121
R666 VDD.n352 VDD.n122 0.231121
R667 VDD.n353 VDD.n352 0.231121
R668 VDD.n354 VDD.n353 0.231121
R669 VDD.n354 VDD.n121 0.231121
R670 VDD.n358 VDD.n121 0.231121
R671 VDD.n359 VDD.n358 0.231121
R672 VDD.n360 VDD.n359 0.231121
R673 VDD.n360 VDD.n120 0.231121
R674 VDD.n364 VDD.n120 0.231121
R675 VDD.n365 VDD.n364 0.231121
R676 VDD.n366 VDD.n365 0.231121
R677 VDD.n366 VDD.n118 0.231121
R678 VDD.n370 VDD.n118 0.231121
R679 VDD.n371 VDD.n117 0.231121
R680 VDD.n375 VDD.n117 0.231121
R681 VDD.n376 VDD.n375 0.231121
R682 VDD.n377 VDD.n376 0.231121
R683 VDD.n377 VDD.n116 0.231121
R684 VDD.n381 VDD.n116 0.231121
R685 VDD.n382 VDD.n381 0.231121
R686 VDD.n383 VDD.n382 0.231121
R687 VDD.n383 VDD.n115 0.231121
R688 VDD.n387 VDD.n115 0.231121
R689 VDD.n388 VDD.n387 0.231121
R690 VDD.n389 VDD.n388 0.231121
R691 VDD.n389 VDD.n114 0.231121
R692 VDD.n393 VDD.n114 0.231121
R693 VDD.n394 VDD.n393 0.231121
R694 VDD.n395 VDD.n394 0.231121
R695 VDD.n395 VDD.n112 0.231121
R696 VDD.n399 VDD.n112 0.231121
R697 VDD.n402 VDD.n401 0.231121
R698 VDD.n16 VDD.n402 1.81983
R699 VDD.n16 VDD.n15 1.6161
R700 VDD.n268 VDD.n215 0.231121
R701 VDD.n269 VDD.n268 0.231121
R702 VDD.n270 VDD.n45 0.114852
R703 VDD.n270 VDD.n213 0.231121
R704 VDD.n274 VDD.n213 0.231121
R705 VDD.n87 VDD.n274 0.114852
R706 VDD.n276 VDD.n275 0.231121
R707 VDD.n38 VDD.n276 0.114852
R708 VDD.n277 VDD.n100 0.231121
R709 VDD.n281 VDD.n100 0.231121
R710 VDD.n282 VDD.n108 0.114852
R711 VDD.n283 VDD.n282 0.231121
R712 VDD.n283 VDD.n86 0.231121
R713 VDD.n287 VDD.n86 0.231121
R714 VDD.n65 VDD.n287 0.114852
R715 VDD.n289 VDD.n288 0.231121
R716 VDD.n52 VDD.n79 0.114852
R717 VDD.n293 VDD.n79 0.231121
R718 VDD.n208 VDD.n23 9.11485
R719 VDD.n202 VDD.n201 0.231121
R720 VDD.n201 VDD.n37 0.114852
R721 VDD.n200 VDD.n199 0.231121
R722 VDD.n199 VDD.n88 0.231121
R723 VDD.n89 VDD.n88 0.114852
R724 VDD.n295 VDD.n294 0.231121
R725 VDD.n39 VDD.n295 0.114852
R726 VDD.n296 VDD.n99 0.231121
R727 VDD.n300 VDD.n99 0.231121
R728 VDD.n301 VDD.n107 0.114852
R729 VDD.n302 VDD.n301 0.231121
R730 VDD.n10 VDD.n85 0.114852
R731 VDD.n306 VDD.n85 0.231121
R732 VDD.n64 VDD.n306 0.114852
R733 VDD.n308 VDD.n307 0.231121
R734 VDD.n53 VDD.n80 0.114852
R735 VDD.n312 VDD.n80 0.231121
R736 VDD.n4 VDD.n139 0.114852
R737 VDD.n139 VDD.n138 0.231121
R738 VDD.n138 VDD.n34 0.114852
R739 VDD.n137 VDD.n136 0.231121
R740 VDD.n136 VDD.n92 0.231121
R741 VDD.n93 VDD.n92 0.114852
R742 VDD.n333 VDD.n332 0.231121
R743 VDD.n334 VDD.n41 0.114852
R744 VDD.n334 VDD.n97 0.231121
R745 VDD.n338 VDD.n97 0.231121
R746 VDD.n339 VDD.n105 0.114852
R747 VDD.n340 VDD.n339 0.231121
R748 VDD.n340 VDD.n24 0.114852
R749 VDD.n344 VDD.n83 0.231121
R750 VDD.n62 VDD.n344 0.114852
R751 VDD.n346 VDD.n345 0.231121
R752 VDD.n55 VDD.n82 0.114852
R753 VDD.n350 VDD.n82 0.231121
R754 VDD.n131 VDD.n19 9.11485
R755 VDD.n126 VDD.n125 0.231121
R756 VDD.n125 VDD.n35 0.114852
R757 VDD.n124 VDD.n123 0.231121
R758 VDD.n123 VDD.n94 0.231121
R759 VDD.n95 VDD.n94 0.114852
R760 VDD.n351 VDD.n60 0.231121
R761 VDD.n355 VDD.n42 0.114852
R762 VDD.n356 VDD.n355 0.231121
R763 VDD.n357 VDD.n356 0.231121
R764 VDD.n104 VDD.n103 0.114852
R765 VDD.n361 VDD.n103 0.231121
R766 VDD.n362 VDD.n26 0.114852
R767 VDD.n363 VDD.n362 0.231121
R768 VDD.n363 VDD.n61 0.114852
R769 VDD.n367 VDD.n119 0.231121
R770 VDD.n368 VDD.n56 0.114852
R771 VDD.n369 VDD.n368 0.231121
R772 VDD.n147 VDD.n146 0.231121
R773 VDD.n74 VDD.n145 0.114852
R774 VDD.n145 VDD.n144 0.231121
R775 VDD.n51 VDD.n143 0.114852
R776 VDD.n143 VDD.n142 0.231121
R777 VDD.n29 VDD.n141 0.114852
R778 VDD.n141 VDD.n140 0.231121
R779 VDD.n140 VDD.n49 0.114852
R780 VDD.n155 VDD.n154 0.231121
R781 VDD.n154 VDD.n153 0.231121
R782 VDD.n153 VDD.n31 0.114852
R783 VDD.n152 VDD.n151 0.231121
R784 VDD.n151 VDD.n150 0.231121
R785 VDD.n150 VDD.n32 0.114852
R786 VDD.n149 VDD.n148 0.231121
R787 VDD.n148 VDD.n48 0.114852
R788 VDD.n253 VDD.n219 0.231121
R789 VDD.n257 VDD.n75 0.114852
R790 VDD.n258 VDD.n257 0.231121
R791 VDD.n259 VDD.n21 0.114852
R792 VDD.n259 VDD.n217 0.231121
R793 VDD.n44 VDD.n217 0.114852
R794 VDD.n264 VDD.n263 0.231121
R795 VDD.n47 VDD.n264 0.114852
R796 VDD.n404 VDD.n59 9.11485
R797 VDD.n403 VDD.n73 0.231121
R798 VDD.n72 VDD.n73 0.114852
R799 VDD.n231 VDD.n227 0.231121
R800 VDD.n232 VDD.n231 0.231121
R801 VDD.n233 VDD.n33 0.114852
R802 VDD.n233 VDD.n225 0.231121
R803 VDD.n237 VDD.n30 0.114852
R804 VDD.n238 VDD.n237 0.231121
R805 VDD.n239 VDD.n238 0.231121
R806 VDD.n239 VDD.n71 0.114852
R807 VDD.n243 VDD.n223 0.231121
R808 VDD.n43 VDD.n243 0.114852
R809 VDD.n245 VDD.n244 0.231121
R810 VDD.n245 VDD.n221 0.231121
R811 VDD.n249 VDD.n221 0.231121
R812 VDD.n46 VDD.n249 0.114852
R813 VDD.n251 VDD.n250 0.231121
R814 VDD.n400 VDD.n111 0.231121
R815 VDD.n16 VDD.n76 0.519326
R816 VDD.n109 VDD.n404 0.362819
R817 VDD.n109 VDD.n58 6.17677
R818 VDD.n14 VDD.n1 0.743392
R819 VDD.n20 VDD.n69 0.428307
R820 VDD VDD.n109 0.22666
R821 VDD.n70 VDD.n69 0.143368
R822 VDD.n27 VDD.n5 0.520041
R823 VDD.n13 VDD.n2 0.555407
R824 VDD.t0 VDD.n3 0.476135
R825 VDD.n18 VDD.n22 1.41362
R826 VDD.n7 VDD.n1 1.34495
R827 VDD.t0 VDD.n0 1.32804
R828 VDD.n7 VDD.n6 1.22132
R829 VDD.n9 VDD.n6 1.13863
R830 VDD.n2 VDD.t0 1.10581
R831 VDD.n3 VDD.n11 0.414521
R832 VDD.n6 VDD.t0 0.371834
R833 VDD.n2 VDD.n12 0.131911
R834 VDD.n5 VDD.t0 1.06318
R835 VDD.n17 VDD.n5 0.228039
R836 VDD.n20 VDD.n22 1.04809
R837 VDD.n18 VDD.n28 1.00823
R838 VSS.n45 VSS.n4 16832
R839 VSS.n12 VSS.n4 4683.36
R840 VSS.t205 VSS.n4 58.173
R841 VSS.n7 VSS.n4 0.494467
R842 VSS.t307 VSS.n4 58.0906
R843 VSS.t106 VSS.n3 28.4523
R844 VSS.n4 VSS.t3 22.4894
R845 VSS.t152 VSS.n0 52.2183
R846 VSS.n4 VSS.t175 58.173
R847 VSS.n4 VSS.t220 58.1918
R848 VSS.n4 VSS.t235 58.1982
R849 VSS.n8 VSS.t67 499.695
R850 VSS.n6 VSS.t76 486.031
R851 VSS.t157 VSS.n15 476.074
R852 VSS.n4 VSS.t185 68.6463
R853 VSS.n4 VSS.t200 68.6463
R854 VSS.n4 VSS.t215 68.6433
R855 VSS.n4 VSS.t230 68.642
R856 VSS.n4 VSS.t245 68.6463
R857 VSS.n4 VSS.t102 82.63
R858 VSS.n10 VSS.t109 71.0343
R859 VSS.t262 VSS.n17 463.976
R860 VSS.n458 VSS.t158 423.387
R861 VSS.n463 VSS.t274 411.291
R862 VSS.n99 VSS.t95 68.4917
R863 VSS.t154 VSS.n19 409.562
R864 VSS.t151 VSS.n20 409.562
R865 VSS.t287 VSS.n22 409.562
R866 VSS.t265 VSS.n24 409.562
R867 VSS.t256 VSS.n26 409.562
R868 VSS.t264 VSS.n27 409.562
R869 VSS.t290 VSS.n29 409.562
R870 VSS.t271 VSS.n30 409.562
R871 VSS.t289 VSS.n32 409.562
R872 VSS.t288 VSS.n34 409.562
R873 VSS.t100 VSS.n36 409.562
R874 VSS.t305 VSS.n37 409.562
R875 VSS.t71 VSS.n39 409.562
R876 VSS.t318 VSS.n41 409.562
R877 VSS.t153 VSS.n43 409.562
R878 VSS.t91 VSS.n11 417.714
R879 VSS.n4 VSS.t193 116.825
R880 VSS.n4 VSS.t208 116.825
R881 VSS.n4 VSS.t253 116.826
R882 VSS.n103 VSS.t272 403.493
R883 VSS.n467 VSS.t281 399.195
R884 VSS.t19 VSS.n9 404.05
R885 VSS.t23 VSS.n113 404.05
R886 VSS.t92 VSS.n18 385.346
R887 VSS.t86 VSS.n21 385.346
R888 VSS.t312 VSS.n25 385.346
R889 VSS.t68 VSS.n28 385.346
R890 VSS.t61 VSS.n31 385.346
R891 VSS.t10 VSS.n35 385.346
R892 VSS.t310 VSS.n38 385.346
R893 VSS.t38 VSS.n42 385.346
R894 VSS.t266 VSS.n436 375
R895 VSS.n4 VSS.t168 122.416
R896 VSS.n4 VSS.t183 122.416
R897 VSS.n4 VSS.t198 122.416
R898 VSS.n4 VSS.t213 122.438
R899 VSS.n4 VSS.t228 122.428
R900 VSS.n4 VSS.t243 122.433
R901 VSS.n170 VSS.t105 366.197
R902 VSS.n4 VSS.t165 127.299
R903 VSS.n4 VSS.t180 127.299
R904 VSS.n4 VSS.t195 127.299
R905 VSS.n4 VSS.t210 127.299
R906 VSS.n4 VSS.t225 127.299
R907 VSS.n4 VSS.t240 127.299
R908 VSS.n98 VSS.t159 355.127
R909 VSS.n94 VSS.t149 98.6395
R910 VSS.n91 VSS.t160 355.127
R911 VSS.n105 VSS.n108 0.423468
R912 VSS.n85 VSS.t320 355.127
R913 VSS.n81 VSS.t255 98.6395
R914 VSS.n78 VSS.t270 355.127
R915 VSS.n105 VSS.n111 0.423468
R916 VSS.n72 VSS.t277 355.127
R917 VSS.n68 VSS.t278 98.6395
R918 VSS.n65 VSS.t291 355.127
R919 VSS.n61 VSS.t27 98.6395
R920 VSS.n58 VSS.t130 355.127
R921 VSS.n54 VSS.t293 98.6395
R922 VSS.n51 VSS.t111 355.127
R923 VSS.n47 VSS.t306 98.6395
R924 VSS.n170 VSS.t103 352.113
R925 VSS.t268 VSS.n437 350.807
R926 VSS.n98 VSS.t93 349.077
R927 VSS.n105 VSS.n107 0.0156714
R928 VSS.n91 VSS.t87 349.077
R929 VSS.n23 VSS.t133 101.647
R930 VSS.n85 VSS.t313 349.077
R931 VSS.n105 VSS.n109 0.0156714
R932 VSS.n78 VSS.t69 349.077
R933 VSS.n105 VSS.n110 0.0156714
R934 VSS.n72 VSS.t62 349.077
R935 VSS.n33 VSS.t45 101.647
R936 VSS.n65 VSS.t11 349.077
R937 VSS.n105 VSS.n112 0.0156714
R938 VSS.n58 VSS.t311 349.077
R939 VSS.n40 VSS.t30 101.647
R940 VSS.n51 VSS.t39 349.077
R941 VSS.n44 VSS.t315 101.647
R942 VSS.t155 VSS.n103 349.057
R943 VSS.t140 VSS.n440 338.711
R944 VSS.t292 VSS.n441 338.711
R945 VSS.t279 VSS.n442 338.711
R946 VSS.t283 VSS.n443 338.711
R947 VSS.t98 VSS.n444 338.711
R948 VSS.t101 VSS.n445 338.711
R949 VSS.t116 VSS.n446 338.711
R950 VSS.t146 VSS.n447 338.711
R951 VSS.t145 VSS.n448 338.711
R952 VSS.t115 VSS.n449 338.711
R953 VSS.t97 VSS.n450 338.711
R954 VSS.t144 VSS.n451 338.711
R955 VSS.t147 VSS.n452 338.711
R956 VSS.t323 VSS.n453 338.711
R957 VSS.t148 VSS.n454 338.711
R958 VSS.t135 VSS.n455 338.711
R959 VSS.n4 VSS.t50 137.773
R960 VSS.n96 VSS.t1 330.911
R961 VSS.n93 VSS.t59 330.911
R962 VSS.n89 VSS.t56 330.911
R963 VSS.n87 VSS.t122 330.911
R964 VSS.n83 VSS.t125 330.911
R965 VSS.n80 VSS.t5 330.911
R966 VSS.n76 VSS.t53 330.911
R967 VSS.n74 VSS.t48 330.911
R968 VSS.n70 VSS.t17 330.911
R969 VSS.n67 VSS.t128 330.911
R970 VSS.n63 VSS.t8 330.911
R971 VSS.n60 VSS.t33 330.911
R972 VSS.n56 VSS.t317 330.911
R973 VSS.n53 VSS.t296 330.911
R974 VSS.n49 VSS.t118 330.911
R975 VSS.n46 VSS.t36 330.911
R976 VSS.t301 VSS.n8 129.317
R977 VSS.t21 VSS.n9 129.738
R978 VSS.t25 VSS.n113 129.738
R979 VSS.n460 VSS.t260 314.517
R980 VSS.t113 VSS.n4 140.65
R981 VSS.n6 VSS.n4 9.33525
R982 VSS.n460 VSS.t273 302.42
R983 VSS.t173 VSS.n4 141.964
R984 VSS.t188 VSS.n4 141.964
R985 VSS.t203 VSS.n4 141.964
R986 VSS.t218 VSS.n4 141.966
R987 VSS.t233 VSS.n4 141.969
R988 VSS.t248 VSS.n4 141.964
R989 VSS.t164 VSS.n17 282.524
R990 VSS.t108 VSS.n5 294.752
R991 VSS.n106 VSS.t141 348.303
R992 VSS.t0 VSS.n440 278.226
R993 VSS.t58 VSS.n441 278.226
R994 VSS.t55 VSS.n442 278.226
R995 VSS.t121 VSS.n443 278.226
R996 VSS.t124 VSS.n444 278.226
R997 VSS.t4 VSS.n445 278.226
R998 VSS.t52 VSS.n446 278.226
R999 VSS.t47 VSS.n447 278.226
R1000 VSS.t16 VSS.n448 278.226
R1001 VSS.t127 VSS.n449 278.226
R1002 VSS.t7 VSS.n450 278.226
R1003 VSS.t32 VSS.n451 278.226
R1004 VSS.t316 VSS.n452 278.226
R1005 VSS.t295 VSS.n453 278.226
R1006 VSS.t117 VSS.n454 278.226
R1007 VSS.t35 VSS.n455 278.226
R1008 VSS.t250 VSS.n4 58.1729
R1009 VSS.t298 VSS.n4 141.702
R1010 VSS.t275 VSS.n15 270.426
R1011 VSS.n437 VSS.t163 266.13
R1012 VSS.t74 VSS.n4 140.651
R1013 VSS.n4 VSS.t42 140.651
R1014 VSS.n4 VSS.t138 140.651
R1015 VSS.n4 VSS.t258 140.651
R1016 VSS.t112 VSS.n4 133.322
R1017 VSS.n4 VSS.t303 140.651
R1018 VSS.n4 VSS.t81 140.651
R1019 VSS.t285 VSS.n4 140.651
R1020 VSS.n10 VSS.t108 267.416
R1021 VSS.n104 VSS.t161 252.302
R1022 VSS.t280 VSS.n436 241.935
R1023 VSS.t300 VSS.n11 131.77
R1024 VSS.t161 VSS.n12 239.62
R1025 VSS.n6 VSS.t78 131.47
R1026 VSS.n4 VSS.n113 6.80932
R1027 VSS.n467 VSS.t280 217.743
R1028 VSS.t73 VSS.n4 133.326
R1029 VSS.t41 VSS.n4 133.321
R1030 VSS.t137 VSS.n4 133.321
R1031 VSS.t257 VSS.n4 133.321
R1032 VSS.t80 VSS.n4 133.321
R1033 VSS.t284 VSS.n4 133.321
R1034 VSS.t163 VSS.n13 209.964
R1035 VSS.n463 VSS.t275 205.645
R1036 VSS.n106 VSS.t143 111.647
R1037 VSS.n96 VSS.t0 197.846
R1038 VSS.n93 VSS.t58 197.846
R1039 VSS.n89 VSS.t55 197.846
R1040 VSS.n87 VSS.t121 197.846
R1041 VSS.n83 VSS.t124 197.846
R1042 VSS.n80 VSS.t4 197.846
R1043 VSS.n76 VSS.t52 197.846
R1044 VSS.n74 VSS.t47 197.846
R1045 VSS.n70 VSS.t16 197.846
R1046 VSS.n67 VSS.t127 197.846
R1047 VSS.n63 VSS.t7 197.846
R1048 VSS.n60 VSS.t32 197.846
R1049 VSS.n56 VSS.t316 197.846
R1050 VSS.n53 VSS.t295 197.846
R1051 VSS.n49 VSS.t117 197.846
R1052 VSS.n46 VSS.t35 197.846
R1053 VSS.n458 VSS.t164 193.548
R1054 VSS.t105 VSS.n3 185.028
R1055 VSS.t273 VSS.n16 173.089
R1056 VSS.n4 VSS.t64 116.822
R1057 VSS.t178 VSS.n4 116.825
R1058 VSS.t223 VSS.n4 116.82
R1059 VSS.t238 VSS.n4 116.817
R1060 VSS.t1 VSS.n19 161.576
R1061 VSS.t59 VSS.n20 161.576
R1062 VSS.t56 VSS.n22 161.576
R1063 VSS.t122 VSS.n24 161.576
R1064 VSS.t125 VSS.n26 161.576
R1065 VSS.t5 VSS.n27 161.576
R1066 VSS.t53 VSS.n29 161.576
R1067 VSS.t48 VSS.n30 161.576
R1068 VSS.t17 VSS.n32 161.576
R1069 VSS.t128 VSS.n34 161.576
R1070 VSS.t8 VSS.n36 161.576
R1071 VSS.t33 VSS.n37 161.576
R1072 VSS.t317 VSS.n39 161.576
R1073 VSS.t296 VSS.n41 161.576
R1074 VSS.t118 VSS.n43 161.576
R1075 VSS.t36 VSS.n45 161.555
R1076 VSS.t260 VSS.n101 160.992
R1077 VSS.n2 VSS.t19 156.831
R1078 VSS.n104 VSS.t155 143.433
R1079 VSS.t93 VSS.n18 143.411
R1080 VSS.t322 VSS.n107 101.647
R1081 VSS.t87 VSS.n21 143.411
R1082 VSS.n23 VSS.t132 385.353
R1083 VSS.t313 VSS.n25 143.411
R1084 VSS.t84 VSS.n109 101.647
R1085 VSS.t69 VSS.n28 143.411
R1086 VSS.t14 VSS.n110 101.647
R1087 VSS.t62 VSS.n31 143.411
R1088 VSS.n33 VSS.t44 385.353
R1089 VSS.t11 VSS.n35 143.411
R1090 VSS.t120 VSS.n112 101.647
R1091 VSS.t311 VSS.n38 143.411
R1092 VSS.n40 VSS.t29 385.353
R1093 VSS.t39 VSS.n42 143.411
R1094 VSS.n44 VSS.t314 385.353
R1095 VSS.n1 VSS.t91 142.746
R1096 VSS.n100 VSS.t141 136.798
R1097 VSS.t159 VSS.n97 136.798
R1098 VSS.n97 VSS.t140 136.798
R1099 VSS.n94 VSS.t292 136.962
R1100 VSS.t160 VSS.n90 136.798
R1101 VSS.n90 VSS.t279 136.798
R1102 VSS.t319 VSS.n108 98.6395
R1103 VSS.t320 VSS.n84 136.798
R1104 VSS.n84 VSS.t98 136.798
R1105 VSS.n81 VSS.t101 136.962
R1106 VSS.t270 VSS.n77 136.798
R1107 VSS.n77 VSS.t116 136.798
R1108 VSS.t294 VSS.n111 98.6395
R1109 VSS.t277 VSS.n71 136.798
R1110 VSS.n71 VSS.t145 136.798
R1111 VSS.n68 VSS.t115 136.962
R1112 VSS.t291 VSS.n64 136.798
R1113 VSS.n64 VSS.t97 136.798
R1114 VSS.n61 VSS.t144 136.962
R1115 VSS.t130 VSS.n57 136.798
R1116 VSS.n57 VSS.t147 136.798
R1117 VSS.n54 VSS.t323 136.962
R1118 VSS.t111 VSS.n50 136.798
R1119 VSS.n50 VSS.t148 136.798
R1120 VSS.n47 VSS.t135 136.962
R1121 VSS.n14 VSS.t268 124.701
R1122 VSS.n95 VSS.t321 106.555
R1123 VSS.n92 VSS.t86 106.555
R1124 VSS.n88 VSS.t132 106.555
R1125 VSS.n86 VSS.t312 106.555
R1126 VSS.n82 VSS.t83 106.555
R1127 VSS.n79 VSS.t68 106.555
R1128 VSS.n75 VSS.t13 106.555
R1129 VSS.n73 VSS.t61 106.555
R1130 VSS.n69 VSS.t44 106.555
R1131 VSS.n66 VSS.t10 106.555
R1132 VSS.n62 VSS.t119 106.555
R1133 VSS.n59 VSS.t310 106.555
R1134 VSS.n55 VSS.t29 106.555
R1135 VSS.n52 VSS.t38 106.555
R1136 VSS.n48 VSS.t314 106.555
R1137 VSS.n102 VSS.t266 100.507
R1138 VSS.n5 VSS.t89 88.1007
R1139 VSS.t272 VSS.n102 88.4108
R1140 VSS.n10 VSS.n4 2.5991
R1141 VSS.n99 VSS.t92 106.654
R1142 VSS.n95 VSS.t154 82.3625
R1143 VSS.n92 VSS.t151 82.3625
R1144 VSS.n88 VSS.t287 82.3625
R1145 VSS.n86 VSS.t265 82.3625
R1146 VSS.n82 VSS.t256 82.3625
R1147 VSS.n79 VSS.t264 82.3625
R1148 VSS.n75 VSS.t290 82.3625
R1149 VSS.n73 VSS.t271 82.3625
R1150 VSS.n69 VSS.t289 82.3625
R1151 VSS.n66 VSS.t288 82.3625
R1152 VSS.n62 VSS.t100 82.3625
R1153 VSS.n59 VSS.t305 82.3625
R1154 VSS.n55 VSS.t71 82.3625
R1155 VSS.n52 VSS.t318 82.3625
R1156 VSS.n48 VSS.t153 82.3625
R1157 VSS.t281 VSS.n13 76.8981
R1158 VSS.t76 VSS.n1 72.3236
R1159 VSS.t274 VSS.n14 64.2173
R1160 VSS.t67 VSS.n2 58.2391
R1161 VSS.t23 VSS.n0 156.883
R1162 VSS.t158 VSS.n100 52.1205
R1163 VSS.n101 VSS.t262 27.927
R1164 VSS.t308 VSS.n4 22.5601
R1165 VSS.n105 VSS.t156 17.0005
R1166 VSS.n105 VSS.n436 17.0005
R1167 VSS.n105 VSS.t267 17.0005
R1168 VSS.n105 VSS.n467 17.0005
R1169 VSS.n105 VSS.n437 17.0005
R1170 VSS.n105 VSS.n438 17.0005
R1171 VSS.n105 VSS.n463 17.0005
R1172 VSS.n105 VSS.n460 17.0005
R1173 VSS.n105 VSS.t263 17.0005
R1174 VSS.n105 VSS.n458 17.0005
R1175 VSS.n105 VSS.n106 6.82269
R1176 VSS.n105 VSS.n440 17.0005
R1177 VSS.n105 VSS.n441 17.0005
R1178 VSS.n105 VSS.n442 17.0005
R1179 VSS.n105 VSS.n443 17.0005
R1180 VSS.n105 VSS.n444 17.0005
R1181 VSS.n105 VSS.n445 17.0005
R1182 VSS.n105 VSS.n446 17.0005
R1183 VSS.n105 VSS.n447 17.0005
R1184 VSS.n105 VSS.n448 17.0005
R1185 VSS.n105 VSS.n449 17.0005
R1186 VSS.n105 VSS.n450 17.0005
R1187 VSS.n105 VSS.n451 17.0005
R1188 VSS.n105 VSS.n452 17.0005
R1189 VSS.n105 VSS.n453 17.0005
R1190 VSS.n105 VSS.n454 17.0005
R1191 VSS.n105 VSS.n455 17.0005
R1192 VSS.n4 VSS.n390 17.0005
R1193 VSS.n4 VSS.n396 17.0005
R1194 VSS.n4 VSS.t65 17.0005
R1195 VSS.n4 VSS.n5 3.4312
R1196 VSS.n4 VSS.t90 17.0005
R1197 VSS.n4 VSS.n11 7.23037
R1198 VSS.n4 VSS.n149 17.0005
R1199 VSS.n4 VSS.n170 17.0005
R1200 VSS.n4 VSS.t107 17.0005
R1201 VSS.n4 VSS.n8 9.7563
R1202 VSS.n4 VSS.n151 17.0005
R1203 VSS.n4 VSS.n152 17.0005
R1204 VSS.n213 VSS.n116 0.0467092
R1205 VSS.n4 VSS.t172 17.0005
R1206 VSS.n4 VSS.n118 5.64823
R1207 VSS.n4 VSS.n230 17.0005
R1208 VSS.n237 VSS.n121 0.0467092
R1209 VSS.n4 VSS.t187 17.0005
R1210 VSS.n4 VSS.n123 5.64823
R1211 VSS.n4 VSS.n255 17.0005
R1212 VSS.n262 VSS.n126 0.0467092
R1213 VSS.n4 VSS.t202 17.0005
R1214 VSS.n4 VSS.n128 5.64823
R1215 VSS.n4 VSS.n298 17.0005
R1216 VSS.n4 VSS.t309 17.0005
R1217 VSS.n4 VSS.t24 17.0005
R1218 VSS.n4 VSS.n296 17.0005
R1219 VSS.n324 VSS.n131 0.0467092
R1220 VSS.n4 VSS.t217 17.0005
R1221 VSS.n4 VSS.n133 5.64823
R1222 VSS.n4 VSS.n342 17.0005
R1223 VSS.n349 VSS.n136 0.0467092
R1224 VSS.n4 VSS.t232 17.0005
R1225 VSS.n4 VSS.n138 5.64823
R1226 VSS.n4 VSS.n367 17.0005
R1227 VSS.n374 VSS.n141 0.0467092
R1228 VSS.n4 VSS.t247 17.0005
R1229 VSS.n4 VSS.n143 5.64823
R1230 VSS.n7 VSS.t66 15.522
R1231 VSS.n16 VSS.t157 15.8302
R1232 VSS.n487 VSS.t142 9.11631
R1233 VSS.n433 VSS.n432 9.11631
R1234 VSS.n516 VSS.n471 9.0005
R1235 VSS.n515 VSS.n514 9.0005
R1236 VSS.n513 VSS.n472 9.0005
R1237 VSS.n511 VSS.n510 9.0005
R1238 VSS.n509 VSS.n474 9.0005
R1239 VSS.n508 VSS.n507 9.0005
R1240 VSS.n505 VSS.n476 9.0005
R1241 VSS.n503 VSS.n502 9.0005
R1242 VSS.n501 VSS.n478 9.0005
R1243 VSS.n500 VSS.n499 9.0005
R1244 VSS.n498 VSS.n479 9.0005
R1245 VSS.n496 VSS.n495 9.0005
R1246 VSS.n494 VSS.n481 9.0005
R1247 VSS.n493 VSS.n492 9.0005
R1248 VSS.n491 VSS.n483 9.0005
R1249 VSS.n489 VSS.n488 9.0005
R1250 VSS.n470 VSS.n471 9.0005
R1251 VSS.n513 VSS.n512 9.0005
R1252 VSS.n474 VSS.n473 9.0005
R1253 VSS.n505 VSS.n504 9.0005
R1254 VSS.n478 VSS.n477 9.0005
R1255 VSS.n498 VSS.n497 9.0005
R1256 VSS.n481 VSS.n480 9.0005
R1257 VSS.n491 VSS.n490 9.0005
R1258 VSS.n485 VSS.n484 9.0005
R1259 VSS.n489 VSS.n486 9.0005
R1260 VSS.n492 VSS.t261 9.0005
R1261 VSS.n496 VSS.n482 9.0005
R1262 VSS.n499 VSS.t269 9.0005
R1263 VSS.n503 VSS.t282 9.0005
R1264 VSS.n507 VSS.n506 9.0005
R1265 VSS.n511 VSS.n475 9.0005
R1266 VSS.n514 VSS.n435 9.0005
R1267 VSS.n398 VSS.n397 9.0005
R1268 VSS.n430 VSS.n429 9.0005
R1269 VSS.n428 VSS.n427 9.0005
R1270 VSS.n426 VSS.n425 9.0005
R1271 VSS.n424 VSS.n423 9.0005
R1272 VSS.n422 VSS.n421 9.0005
R1273 VSS.n420 VSS.t286 9.0005
R1274 VSS.n419 VSS.n418 9.0005
R1275 VSS.n417 VSS.n416 9.0005
R1276 VSS.n415 VSS.n414 9.0005
R1277 VSS.n413 VSS.t254 9.0005
R1278 VSS.n412 VSS.n411 9.0005
R1279 VSS.n410 VSS.t251 9.0005
R1280 VSS.n520 VSS.n382 9.0005
R1281 VSS.n521 VSS.t252 9.0005
R1282 VSS.n824 VSS.n823 9.0005
R1283 VSS.n146 VSS.n145 9.0005
R1284 VSS.n821 VSS.n820 9.0005
R1285 VSS.n819 VSS.n180 9.0005
R1286 VSS.n818 VSS.n817 9.0005
R1287 VSS.n815 VSS.n181 9.0005
R1288 VSS.n813 VSS.n812 9.0005
R1289 VSS.n811 VSS.n182 9.0005
R1290 VSS.n810 VSS.n809 9.0005
R1291 VSS.n807 VSS.n184 9.0005
R1292 VSS.n806 VSS.n805 9.0005
R1293 VSS.n804 VSS.n186 9.0005
R1294 VSS.n803 VSS.n802 9.0005
R1295 VSS.n800 VSS.n188 9.0005
R1296 VSS.n799 VSS.n798 9.0005
R1297 VSS.n797 VSS.n190 9.0005
R1298 VSS.n796 VSS.n795 9.0005
R1299 VSS.n793 VSS.n192 9.0005
R1300 VSS.n792 VSS.n791 9.0005
R1301 VSS.n790 VSS.n194 9.0005
R1302 VSS.n789 VSS.n788 9.0005
R1303 VSS.n787 VSS.n195 9.0005
R1304 VSS.n785 VSS.n784 9.0005
R1305 VSS.n783 VSS.n197 9.0005
R1306 VSS.n782 VSS.n781 9.0005
R1307 VSS.n779 VSS.n199 9.0005
R1308 VSS.n777 VSS.n776 9.0005
R1309 VSS.n775 VSS.n201 9.0005
R1310 VSS.n774 VSS.n773 9.0005
R1311 VSS.n771 VSS.n203 9.0005
R1312 VSS.n769 VSS.n768 9.0005
R1313 VSS.n767 VSS.n205 9.0005
R1314 VSS.n766 VSS.n765 9.0005
R1315 VSS.n764 VSS.n207 9.0005
R1316 VSS.n762 VSS.n761 9.0005
R1317 VSS.n760 VSS.n208 9.0005
R1318 VSS.n759 VSS.n758 9.0005
R1319 VSS.n211 VSS.n210 9.0005
R1320 VSS.n756 VSS.n755 9.0005
R1321 VSS.n754 VSS.n214 9.0005
R1322 VSS.n753 VSS.n752 9.0005
R1323 VSS.n216 VSS.n215 9.0005
R1324 VSS.n749 VSS.n748 9.0005
R1325 VSS.n747 VSS.n218 9.0005
R1326 VSS.n746 VSS.n745 9.0005
R1327 VSS.n220 VSS.n219 9.0005
R1328 VSS.n734 VSS.n733 9.0005
R1329 VSS.n735 VSS.n732 9.0005
R1330 VSS.n737 VSS.n736 9.0005
R1331 VSS.n738 VSS.n728 9.0005
R1332 VSS.n740 VSS.n739 9.0005
R1333 VSS.n741 VSS.n233 9.0005
R1334 VSS.n743 VSS.n742 9.0005
R1335 VSS.n727 VSS.n231 9.0005
R1336 VSS.n726 VSS.n725 9.0005
R1337 VSS.n723 VSS.n234 9.0005
R1338 VSS.n718 VSS.n235 9.0005
R1339 VSS.n719 VSS.n239 9.0005
R1340 VSS.n721 VSS.n720 9.0005
R1341 VSS.n717 VSS.n238 9.0005
R1342 VSS.n716 VSS.n715 9.0005
R1343 VSS.n241 VSS.n240 9.0005
R1344 VSS.n712 VSS.n711 9.0005
R1345 VSS.n710 VSS.n243 9.0005
R1346 VSS.n709 VSS.n708 9.0005
R1347 VSS.n245 VSS.n244 9.0005
R1348 VSS.n697 VSS.n696 9.0005
R1349 VSS.n698 VSS.n695 9.0005
R1350 VSS.n700 VSS.n699 9.0005
R1351 VSS.n701 VSS.n691 9.0005
R1352 VSS.n703 VSS.n702 9.0005
R1353 VSS.n704 VSS.n258 9.0005
R1354 VSS.n706 VSS.n705 9.0005
R1355 VSS.n690 VSS.n256 9.0005
R1356 VSS.n689 VSS.n688 9.0005
R1357 VSS.n686 VSS.n259 9.0005
R1358 VSS.n681 VSS.n260 9.0005
R1359 VSS.n682 VSS.n264 9.0005
R1360 VSS.n684 VSS.n683 9.0005
R1361 VSS.n680 VSS.n263 9.0005
R1362 VSS.n679 VSS.n678 9.0005
R1363 VSS.n266 VSS.n265 9.0005
R1364 VSS.n675 VSS.n674 9.0005
R1365 VSS.n673 VSS.n268 9.0005
R1366 VSS.n672 VSS.n671 9.0005
R1367 VSS.n270 VSS.n269 9.0005
R1368 VSS.n660 VSS.n659 9.0005
R1369 VSS.n661 VSS.n658 9.0005
R1370 VSS.n663 VSS.n662 9.0005
R1371 VSS.n664 VSS.n654 9.0005
R1372 VSS.n666 VSS.n665 9.0005
R1373 VSS.n667 VSS.n301 9.0005
R1374 VSS.n669 VSS.n668 9.0005
R1375 VSS.n653 VSS.n299 9.0005
R1376 VSS.n652 VSS.n651 9.0005
R1377 VSS.n649 VSS.n302 9.0005
R1378 VSS.n647 VSS.n646 9.0005
R1379 VSS.n645 VSS.n304 9.0005
R1380 VSS.n644 VSS.n643 9.0005
R1381 VSS.n641 VSS.n306 9.0005
R1382 VSS.n639 VSS.n638 9.0005
R1383 VSS.n637 VSS.n308 9.0005
R1384 VSS.n636 VSS.n635 9.0005
R1385 VSS.n633 VSS.n310 9.0005
R1386 VSS.n631 VSS.n630 9.0005
R1387 VSS.n629 VSS.n312 9.0005
R1388 VSS.n628 VSS.n627 9.0005
R1389 VSS.n626 VSS.n314 9.0005
R1390 VSS.n624 VSS.n623 9.0005
R1391 VSS.n622 VSS.n316 9.0005
R1392 VSS.n621 VSS.n620 9.0005
R1393 VSS.n618 VSS.n318 9.0005
R1394 VSS.n616 VSS.n615 9.0005
R1395 VSS.n614 VSS.n320 9.0005
R1396 VSS.n613 VSS.n612 9.0005
R1397 VSS.n610 VSS.n321 9.0005
R1398 VSS.n605 VSS.n322 9.0005
R1399 VSS.n606 VSS.n326 9.0005
R1400 VSS.n608 VSS.n607 9.0005
R1401 VSS.n604 VSS.n325 9.0005
R1402 VSS.n603 VSS.n602 9.0005
R1403 VSS.n328 VSS.n327 9.0005
R1404 VSS.n599 VSS.n598 9.0005
R1405 VSS.n597 VSS.n330 9.0005
R1406 VSS.n596 VSS.n595 9.0005
R1407 VSS.n332 VSS.n331 9.0005
R1408 VSS.n584 VSS.n583 9.0005
R1409 VSS.n585 VSS.n582 9.0005
R1410 VSS.n587 VSS.n586 9.0005
R1411 VSS.n588 VSS.n578 9.0005
R1412 VSS.n590 VSS.n589 9.0005
R1413 VSS.n591 VSS.n345 9.0005
R1414 VSS.n593 VSS.n592 9.0005
R1415 VSS.n577 VSS.n343 9.0005
R1416 VSS.n576 VSS.n575 9.0005
R1417 VSS.n573 VSS.n346 9.0005
R1418 VSS.n568 VSS.n347 9.0005
R1419 VSS.n569 VSS.n351 9.0005
R1420 VSS.n571 VSS.n570 9.0005
R1421 VSS.n567 VSS.n350 9.0005
R1422 VSS.n566 VSS.n565 9.0005
R1423 VSS.n353 VSS.n352 9.0005
R1424 VSS.n562 VSS.n561 9.0005
R1425 VSS.n560 VSS.n355 9.0005
R1426 VSS.n559 VSS.n558 9.0005
R1427 VSS.n357 VSS.n356 9.0005
R1428 VSS.n547 VSS.n546 9.0005
R1429 VSS.n548 VSS.n545 9.0005
R1430 VSS.n550 VSS.n549 9.0005
R1431 VSS.n551 VSS.n541 9.0005
R1432 VSS.n553 VSS.n552 9.0005
R1433 VSS.n554 VSS.n370 9.0005
R1434 VSS.n556 VSS.n555 9.0005
R1435 VSS.n540 VSS.n368 9.0005
R1436 VSS.n539 VSS.n538 9.0005
R1437 VSS.n536 VSS.n371 9.0005
R1438 VSS.n531 VSS.n372 9.0005
R1439 VSS.n532 VSS.n376 9.0005
R1440 VSS.n534 VSS.n533 9.0005
R1441 VSS.n530 VSS.n375 9.0005
R1442 VSS.n529 VSS.n528 9.0005
R1443 VSS.n378 VSS.n377 9.0005
R1444 VSS.n525 VSS.n524 9.0005
R1445 VSS.n523 VSS.n380 9.0005
R1446 VSS.n522 VSS.n521 9.0005
R1447 VSS.n382 VSS.n381 9.0005
R1448 VSS.n410 VSS.n409 9.0005
R1449 VSS.n412 VSS.n408 9.0005
R1450 VSS.n413 VSS.n407 9.0005
R1451 VSS.n415 VSS.n406 9.0005
R1452 VSS.n417 VSS.n405 9.0005
R1453 VSS.n419 VSS.n404 9.0005
R1454 VSS.n420 VSS.n403 9.0005
R1455 VSS.n422 VSS.n402 9.0005
R1456 VSS.n424 VSS.n401 9.0005
R1457 VSS.n426 VSS.n400 9.0005
R1458 VSS.n428 VSS.n399 9.0005
R1459 VSS.n431 VSS.n430 9.0005
R1460 VSS.n380 VSS.t249 9.0005
R1461 VSS.n526 VSS.n525 9.0005
R1462 VSS.n379 VSS.n378 9.0005
R1463 VSS.n528 VSS.t246 9.0005
R1464 VSS.n375 VSS.n374 9.0005
R1465 VSS.t244 VSS.n534 9.0005
R1466 VSS.n376 VSS.t242 9.0005
R1467 VSS.n535 VSS.n372 9.0005
R1468 VSS.n536 VSS.t241 9.0005
R1469 VSS.n538 VSS.n537 9.0005
R1470 VSS.n368 VSS.n366 9.0005
R1471 VSS.t82 VSS.n556 9.0005
R1472 VSS.n370 VSS.n369 9.0005
R1473 VSS.n552 VSS.n542 9.0005
R1474 VSS.n551 VSS.n543 9.0005
R1475 VSS.n550 VSS.t239 9.0005
R1476 VSS.n545 VSS.n544 9.0005
R1477 VSS.n546 VSS.t237 9.0005
R1478 VSS.n557 VSS.n357 9.0005
R1479 VSS.n558 VSS.t236 9.0005
R1480 VSS.n355 VSS.t234 9.0005
R1481 VSS.n563 VSS.n562 9.0005
R1482 VSS.n354 VSS.n353 9.0005
R1483 VSS.n565 VSS.t231 9.0005
R1484 VSS.n350 VSS.n349 9.0005
R1485 VSS.t229 VSS.n571 9.0005
R1486 VSS.n351 VSS.t227 9.0005
R1487 VSS.n572 VSS.n347 9.0005
R1488 VSS.n573 VSS.t226 9.0005
R1489 VSS.n575 VSS.n574 9.0005
R1490 VSS.n343 VSS.n341 9.0005
R1491 VSS.t304 VSS.n593 9.0005
R1492 VSS.n345 VSS.n344 9.0005
R1493 VSS.n589 VSS.n579 9.0005
R1494 VSS.n588 VSS.n580 9.0005
R1495 VSS.n587 VSS.t224 9.0005
R1496 VSS.n582 VSS.n581 9.0005
R1497 VSS.n583 VSS.t222 9.0005
R1498 VSS.n594 VSS.n332 9.0005
R1499 VSS.n595 VSS.t221 9.0005
R1500 VSS.n330 VSS.t219 9.0005
R1501 VSS.n600 VSS.n599 9.0005
R1502 VSS.n329 VSS.n328 9.0005
R1503 VSS.n602 VSS.t216 9.0005
R1504 VSS.n325 VSS.n324 9.0005
R1505 VSS.t214 VSS.n608 9.0005
R1506 VSS.n326 VSS.t212 9.0005
R1507 VSS.n609 VSS.n322 9.0005
R1508 VSS.n610 VSS.t211 9.0005
R1509 VSS.n612 VSS.n611 9.0005
R1510 VSS.n320 VSS.n319 9.0005
R1511 VSS.n616 VSS.t114 9.0005
R1512 VSS.n618 VSS.n617 9.0005
R1513 VSS.n620 VSS.n619 9.0005
R1514 VSS.n316 VSS.n315 9.0005
R1515 VSS.n624 VSS.n317 9.0005
R1516 VSS.n626 VSS.n625 9.0005
R1517 VSS.n627 VSS.t26 9.0005
R1518 VSS.n312 VSS.n311 9.0005
R1519 VSS.n631 VSS.n313 9.0005
R1520 VSS.n633 VSS.n632 9.0005
R1521 VSS.n635 VSS.n634 9.0005
R1522 VSS.n308 VSS.n307 9.0005
R1523 VSS.n639 VSS.n309 9.0005
R1524 VSS.n641 VSS.n640 9.0005
R1525 VSS.n643 VSS.n642 9.0005
R1526 VSS.n304 VSS.n303 9.0005
R1527 VSS.n647 VSS.n305 9.0005
R1528 VSS.n649 VSS.n648 9.0005
R1529 VSS.n651 VSS.n650 9.0005
R1530 VSS.n299 VSS.n297 9.0005
R1531 VSS.t259 VSS.n669 9.0005
R1532 VSS.n301 VSS.n300 9.0005
R1533 VSS.n665 VSS.n655 9.0005
R1534 VSS.n664 VSS.n656 9.0005
R1535 VSS.n663 VSS.t209 9.0005
R1536 VSS.n658 VSS.n657 9.0005
R1537 VSS.n659 VSS.t207 9.0005
R1538 VSS.n670 VSS.n270 9.0005
R1539 VSS.n671 VSS.t206 9.0005
R1540 VSS.n268 VSS.t204 9.0005
R1541 VSS.n676 VSS.n675 9.0005
R1542 VSS.n267 VSS.n266 9.0005
R1543 VSS.n678 VSS.t201 9.0005
R1544 VSS.n263 VSS.n262 9.0005
R1545 VSS.t199 VSS.n684 9.0005
R1546 VSS.n264 VSS.t197 9.0005
R1547 VSS.n685 VSS.n260 9.0005
R1548 VSS.n686 VSS.t196 9.0005
R1549 VSS.n688 VSS.n687 9.0005
R1550 VSS.n256 VSS.n254 9.0005
R1551 VSS.t139 VSS.n706 9.0005
R1552 VSS.n258 VSS.n257 9.0005
R1553 VSS.n702 VSS.n692 9.0005
R1554 VSS.n701 VSS.n693 9.0005
R1555 VSS.n700 VSS.t194 9.0005
R1556 VSS.n695 VSS.n694 9.0005
R1557 VSS.n696 VSS.t192 9.0005
R1558 VSS.n707 VSS.n245 9.0005
R1559 VSS.n708 VSS.t191 9.0005
R1560 VSS.n243 VSS.t189 9.0005
R1561 VSS.n713 VSS.n712 9.0005
R1562 VSS.n242 VSS.n241 9.0005
R1563 VSS.n715 VSS.t186 9.0005
R1564 VSS.n238 VSS.n237 9.0005
R1565 VSS.t184 VSS.n721 9.0005
R1566 VSS.n239 VSS.t182 9.0005
R1567 VSS.n722 VSS.n235 9.0005
R1568 VSS.n723 VSS.t181 9.0005
R1569 VSS.n725 VSS.n724 9.0005
R1570 VSS.n231 VSS.n229 9.0005
R1571 VSS.t43 VSS.n743 9.0005
R1572 VSS.n233 VSS.n232 9.0005
R1573 VSS.n739 VSS.n729 9.0005
R1574 VSS.n738 VSS.n730 9.0005
R1575 VSS.n737 VSS.t179 9.0005
R1576 VSS.n732 VSS.n731 9.0005
R1577 VSS.n733 VSS.t177 9.0005
R1578 VSS.n744 VSS.n220 9.0005
R1579 VSS.n745 VSS.t176 9.0005
R1580 VSS.n218 VSS.t174 9.0005
R1581 VSS.n750 VSS.n749 9.0005
R1582 VSS.n217 VSS.n216 9.0005
R1583 VSS.n752 VSS.t171 9.0005
R1584 VSS.n214 VSS.n213 9.0005
R1585 VSS.t169 VSS.n756 9.0005
R1586 VSS.t167 VSS.n211 9.0005
R1587 VSS.n758 VSS.n757 9.0005
R1588 VSS.t166 VSS.n208 9.0005
R1589 VSS.n762 VSS.n209 9.0005
R1590 VSS.n764 VSS.n763 9.0005
R1591 VSS.n765 VSS.t75 9.0005
R1592 VSS.n205 VSS.n204 9.0005
R1593 VSS.n769 VSS.n206 9.0005
R1594 VSS.n771 VSS.n770 9.0005
R1595 VSS.n773 VSS.n772 9.0005
R1596 VSS.n201 VSS.n200 9.0005
R1597 VSS.n777 VSS.n202 9.0005
R1598 VSS.n779 VSS.n778 9.0005
R1599 VSS.n781 VSS.n780 9.0005
R1600 VSS.n197 VSS.n196 9.0005
R1601 VSS.n785 VSS.n198 9.0005
R1602 VSS.n787 VSS.n786 9.0005
R1603 VSS.n788 VSS.t51 9.0005
R1604 VSS.n194 VSS.n193 9.0005
R1605 VSS.n792 VSS.t22 9.0005
R1606 VSS.n793 VSS.t20 9.0005
R1607 VSS.n795 VSS.n794 9.0005
R1608 VSS.n190 VSS.n189 9.0005
R1609 VSS.n799 VSS.n191 9.0005
R1610 VSS.n800 VSS.t104 9.0005
R1611 VSS.n802 VSS.n801 9.0005
R1612 VSS.n186 VSS.n185 9.0005
R1613 VSS.n806 VSS.n187 9.0005
R1614 VSS.n807 VSS.t77 9.0005
R1615 VSS.n809 VSS.n808 9.0005
R1616 VSS.n182 VSS.t110 9.0005
R1617 VSS.n813 VSS.n183 9.0005
R1618 VSS.n815 VSS.n814 9.0005
R1619 VSS.n817 VSS.n816 9.0005
R1620 VSS.n180 VSS.n179 9.0005
R1621 VSS.n178 VSS.n821 9.0005
R1622 VSS.n147 VSS.n146 9.0005
R1623 VSS.n823 VSS.n148 9.0005
R1624 VSS.t166 VSS.n114 0.0491025
R1625 VSS.n4 VSS.n115 4.21329
R1626 VSS.n116 VSS.n4 5.65265
R1627 VSS.t176 VSS.n118 0.0304819
R1628 VSS.t181 VSS.n119 0.0491025
R1629 VSS.n4 VSS.n120 4.21329
R1630 VSS.n121 VSS.n4 5.65265
R1631 VSS.t191 VSS.n123 0.0304819
R1632 VSS.t196 VSS.n124 0.0491025
R1633 VSS.n4 VSS.n125 4.21329
R1634 VSS.n126 VSS.n4 5.65265
R1635 VSS.t206 VSS.n128 0.0304819
R1636 VSS.t211 VSS.n129 0.0491025
R1637 VSS.n4 VSS.n130 4.21329
R1638 VSS.n131 VSS.n4 5.65265
R1639 VSS.t221 VSS.n133 0.0304819
R1640 VSS.t226 VSS.n134 0.0491025
R1641 VSS.n4 VSS.n135 4.21329
R1642 VSS.n136 VSS.n4 5.65265
R1643 VSS.t236 VSS.n138 0.0304819
R1644 VSS.t241 VSS.n139 0.0491025
R1645 VSS.n4 VSS.n140 4.21329
R1646 VSS.n141 VSS.n4 5.65265
R1647 VSS.t252 VSS.n143 0.0304819
R1648 VSS.n4 VSS.n386 8.49444
R1649 VSS.n4 VSS.n223 8.49444
R1650 VSS.n4 VSS.n248 8.49444
R1651 VSS.n4 VSS.n273 8.49444
R1652 VSS.n4 VSS.n335 8.49444
R1653 VSS.n4 VSS.n360 8.49444
R1654 VSS.n105 VSS.t162 8.47732
R1655 VSS.n105 VSS.n469 8.47732
R1656 VSS.n105 VSS.n466 8.47732
R1657 VSS.n105 VSS.n465 8.47732
R1658 VSS.n105 VSS.t276 8.47732
R1659 VSS.n105 VSS.n462 8.47732
R1660 VSS.n105 VSS.n439 8.47732
R1661 VSS.n105 VSS.n459 8.47732
R1662 VSS.n105 VSS.n457 8.47732
R1663 VSS.n4 VSS.n519 8.47732
R1664 VSS.n4 VSS.n385 8.47732
R1665 VSS.n4 VSS.n387 8.47732
R1666 VSS.n4 VSS.n389 8.47732
R1667 VSS.n4 VSS.n392 8.47732
R1668 VSS.n4 VSS.n393 8.47732
R1669 VSS.n4 VSS.n394 8.47732
R1670 VSS.n4 VSS.n395 8.47732
R1671 VSS.n4 VSS.t299 8.47732
R1672 VSS.n4 VSS.n177 8.47732
R1673 VSS.n4 VSS.n175 8.47732
R1674 VSS.n4 VSS.n174 8.47732
R1675 VSS.n4 VSS.t79 8.47732
R1676 VSS.n4 VSS.n172 8.47732
R1677 VSS.n4 VSS.n150 8.47732
R1678 VSS.n4 VSS.n169 8.47732
R1679 VSS.n4 VSS.n168 8.47732
R1680 VSS.n4 VSS.n166 8.47732
R1681 VSS.n4 VSS.n165 8.47732
R1682 VSS.n4 VSS.n164 8.47732
R1683 VSS.n4 VSS.n163 8.47732
R1684 VSS.n4 VSS.n162 8.47732
R1685 VSS.n4 VSS.n161 8.47732
R1686 VSS.n4 VSS.n160 8.47732
R1687 VSS.n4 VSS.n159 8.47732
R1688 VSS.n4 VSS.n158 8.47732
R1689 VSS.n4 VSS.n157 8.47732
R1690 VSS.n4 VSS.n156 8.47732
R1691 VSS.n4 VSS.n155 8.47732
R1692 VSS.n4 VSS.n153 8.47732
R1693 VSS.n4 VSS.n114 4.2213
R1694 VSS.n212 VSS.n4 8.47732
R1695 VSS.n115 VSS.t167 0.11285
R1696 VSS.n4 VSS.n117 8.47732
R1697 VSS.n222 VSS.n4 8.47732
R1698 VSS.n4 VSS.n221 8.47732
R1699 VSS.n4 VSS.n224 8.47732
R1700 VSS.n4 VSS.n225 8.47732
R1701 VSS.n4 VSS.n226 8.47732
R1702 VSS.n4 VSS.n228 8.47732
R1703 VSS.n4 VSS.n119 4.2213
R1704 VSS.n236 VSS.n4 8.47732
R1705 VSS.n120 VSS.t182 0.11285
R1706 VSS.n4 VSS.n122 8.47732
R1707 VSS.n247 VSS.n4 8.47732
R1708 VSS.n4 VSS.n246 8.47732
R1709 VSS.n4 VSS.n249 8.47732
R1710 VSS.n4 VSS.n250 8.47732
R1711 VSS.n4 VSS.n251 8.47732
R1712 VSS.n4 VSS.n253 8.47732
R1713 VSS.n4 VSS.n124 4.2213
R1714 VSS.n261 VSS.n4 8.47732
R1715 VSS.n125 VSS.t197 0.11285
R1716 VSS.n4 VSS.n127 8.47732
R1717 VSS.n272 VSS.n4 8.47732
R1718 VSS.n4 VSS.n271 8.47732
R1719 VSS.n4 VSS.n274 8.47732
R1720 VSS.n4 VSS.n275 8.47732
R1721 VSS.n4 VSS.n276 8.47732
R1722 VSS.n4 VSS.n278 8.47732
R1723 VSS.n4 VSS.n279 8.47732
R1724 VSS.n4 VSS.n280 8.47732
R1725 VSS.n4 VSS.n281 8.47732
R1726 VSS.n4 VSS.n282 8.47732
R1727 VSS.n4 VSS.n283 8.47732
R1728 VSS.n4 VSS.n285 8.47732
R1729 VSS.n4 VSS.n286 8.47732
R1730 VSS.n4 VSS.n288 8.47732
R1731 VSS.n4 VSS.n289 8.47732
R1732 VSS.n4 VSS.n290 8.47732
R1733 VSS.n4 VSS.n291 8.47732
R1734 VSS.n4 VSS.n292 8.47732
R1735 VSS.n4 VSS.n293 8.47732
R1736 VSS.n4 VSS.n295 8.47732
R1737 VSS.n4 VSS.n129 4.2213
R1738 VSS.n323 VSS.n4 8.47732
R1739 VSS.n130 VSS.t212 0.11285
R1740 VSS.n4 VSS.n132 8.47732
R1741 VSS.n334 VSS.n4 8.47732
R1742 VSS.n4 VSS.n333 8.47732
R1743 VSS.n4 VSS.n336 8.47732
R1744 VSS.n4 VSS.n337 8.47732
R1745 VSS.n4 VSS.n338 8.47732
R1746 VSS.n4 VSS.n340 8.47732
R1747 VSS.n4 VSS.n134 4.2213
R1748 VSS.n348 VSS.n4 8.47732
R1749 VSS.n135 VSS.t227 0.11285
R1750 VSS.n4 VSS.n137 8.47732
R1751 VSS.n359 VSS.n4 8.47732
R1752 VSS.n4 VSS.n358 8.47732
R1753 VSS.n4 VSS.n361 8.47732
R1754 VSS.n4 VSS.n362 8.47732
R1755 VSS.n4 VSS.n363 8.47732
R1756 VSS.n4 VSS.n365 8.47732
R1757 VSS.n4 VSS.n139 4.2213
R1758 VSS.n373 VSS.n4 8.47732
R1759 VSS.n140 VSS.t242 0.11285
R1760 VSS.n4 VSS.n142 8.47732
R1761 VSS.n384 VSS.n4 8.47732
R1762 VSS.n4 VSS.n383 8.47732
R1763 VSS.n4 VSS.n751 5.64536
R1764 VSS.n4 VSS.n714 5.64536
R1765 VSS.n4 VSS.n677 5.64536
R1766 VSS.n4 VSS.n601 5.64536
R1767 VSS.n4 VSS.n564 5.64536
R1768 VSS.n4 VSS.n527 5.64536
R1769 VSS.n105 VSS.n434 5.62581
R1770 VSS.n105 VSS.n468 5.62581
R1771 VSS.n105 VSS.n464 5.62581
R1772 VSS.n105 VSS.n461 5.62581
R1773 VSS.n4 VSS.n388 5.62581
R1774 VSS.n4 VSS.n391 5.62581
R1775 VSS.n4 VSS.n822 5.62581
R1776 VSS.n4 VSS.n176 5.62581
R1777 VSS.n4 VSS.n173 5.62581
R1778 VSS.n4 VSS.n171 5.62581
R1779 VSS.n4 VSS.n167 5.62581
R1780 VSS.n4 VSS.n154 5.62581
R1781 VSS.n4 VSS.n227 5.62581
R1782 VSS.n4 VSS.n252 5.62581
R1783 VSS.n4 VSS.n277 5.62581
R1784 VSS.n4 VSS.n284 5.62581
R1785 VSS.n4 VSS.n287 5.62581
R1786 VSS.n4 VSS.n294 5.62581
R1787 VSS.n4 VSS.n339 5.62581
R1788 VSS.n4 VSS.n364 5.62581
R1789 VSS.n488 VSS.n487 4.73162
R1790 VSS.n432 VSS.n431 4.73162
R1791 VSS.n470 VSS.n518 3.84369
R1792 VSS.n148 VSS.n144 3.84291
R1793 VSS.n518 VSS.n517 2.93359
R1794 VSS.n825 VSS.n144 2.93359
R1795 VSS.n519 VSS.t37 2.78199
R1796 VSS.n105 VSS.n456 1.24465
R1797 VSS.n825 VSS.n824 1.09146
R1798 VSS.n517 VSS.n516 1.09112
R1799 VSS.t96 VSS.t94 1.05088
R1800 VSS.t2 VSS.t150 1.05088
R1801 VSS.t60 VSS.t88 1.05088
R1802 VSS.t57 VSS.t134 1.05088
R1803 VSS.t123 VSS.t99 1.05088
R1804 VSS.t126 VSS.t85 1.05088
R1805 VSS.t6 VSS.t70 1.05088
R1806 VSS.t54 VSS.t15 1.05088
R1807 VSS.t49 VSS.t63 1.05088
R1808 VSS.t18 VSS.t46 1.05088
R1809 VSS.t129 VSS.t12 1.05088
R1810 VSS.t9 VSS.t28 1.05088
R1811 VSS.t34 VSS.t131 1.05088
R1812 VSS.t72 VSS.t31 1.05088
R1813 VSS.t297 VSS.t40 1.05088
R1814 VSS.t136 VSS.t37 0.999957
R1815 VSS.n105 VSS.t94 0.60071
R1816 VSS.n105 VSS.t150 0.60071
R1817 VSS.n105 VSS.t88 0.60071
R1818 VSS.n105 VSS.t134 0.60071
R1819 VSS.n105 VSS.t99 0.60071
R1820 VSS.n105 VSS.t85 0.60071
R1821 VSS.n105 VSS.t70 0.60071
R1822 VSS.n105 VSS.t15 0.60071
R1823 VSS.n105 VSS.t63 0.60071
R1824 VSS.n105 VSS.t46 0.60071
R1825 VSS.n105 VSS.t12 0.60071
R1826 VSS.n105 VSS.t28 0.60071
R1827 VSS.n105 VSS.t131 0.60071
R1828 VSS.n105 VSS.t31 0.60071
R1829 VSS.n105 VSS.n12 0.586403
R1830 VSS.n105 VSS.n102 0.586403
R1831 VSS.n105 VSS.n14 0.586403
R1832 VSS.n105 VSS.n16 0.586403
R1833 VSS.n105 VSS.n101 0.586403
R1834 VSS.n105 VSS.n100 0.586403
R1835 VSS.n105 VSS.n99 0.488226
R1836 VSS.n105 VSS.n97 0.586403
R1837 VSS.n105 VSS.n95 0.586403
R1838 VSS.n105 VSS.n94 0.423468
R1839 VSS.n105 VSS.n92 0.586403
R1840 VSS.n105 VSS.n90 0.586403
R1841 VSS.n105 VSS.n88 0.586403
R1842 VSS.n108 VSS.t283 136.962
R1843 VSS.n105 VSS.n86 0.586403
R1844 VSS.n105 VSS.n84 0.586403
R1845 VSS.n105 VSS.n82 0.586403
R1846 VSS.n105 VSS.n81 0.423468
R1847 VSS.n105 VSS.n79 0.586403
R1848 VSS.n105 VSS.n77 0.586403
R1849 VSS.n105 VSS.n75 0.586403
R1850 VSS.n111 VSS.t146 136.962
R1851 VSS.n105 VSS.n73 0.586403
R1852 VSS.n105 VSS.n71 0.586403
R1853 VSS.n105 VSS.n69 0.586403
R1854 VSS.n105 VSS.n68 0.423468
R1855 VSS.n105 VSS.n66 0.586403
R1856 VSS.n105 VSS.n64 0.586403
R1857 VSS.n105 VSS.n62 0.586403
R1858 VSS.n105 VSS.n61 0.423468
R1859 VSS.n105 VSS.n59 0.586403
R1860 VSS.n105 VSS.n57 0.586403
R1861 VSS.n105 VSS.n55 0.586403
R1862 VSS.n105 VSS.n54 0.423468
R1863 VSS.n105 VSS.n52 0.586403
R1864 VSS.n105 VSS.n50 0.586403
R1865 VSS.n105 VSS.n48 0.586403
R1866 VSS.n105 VSS.n47 0.423468
R1867 VSS.t94 VSS.t2 0.575991
R1868 VSS.t150 VSS.t60 0.575991
R1869 VSS.t88 VSS.t57 0.575991
R1870 VSS.t134 VSS.t123 0.575991
R1871 VSS.t99 VSS.t126 0.575991
R1872 VSS.t85 VSS.t6 0.575991
R1873 VSS.t70 VSS.t54 0.575991
R1874 VSS.t15 VSS.t49 0.575991
R1875 VSS.t63 VSS.t18 0.575991
R1876 VSS.t46 VSS.t129 0.575991
R1877 VSS.t12 VSS.t9 0.575991
R1878 VSS.t28 VSS.t34 0.575991
R1879 VSS.t131 VSS.t72 0.575991
R1880 VSS.t31 VSS.t297 0.575991
R1881 VSS.n4 VSS.n1 0.50872
R1882 VSS.n7 VSS.t103 199.099
R1883 VSS.n4 VSS.n3 0.481869
R1884 VSS.n4 VSS.n2 0.50872
R1885 VSS.n4 VSS.t190 58.173
R1886 VSS.t142 VSS.n456 0.492503
R1887 VSS.n518 VSS.n144 0.44402
R1888 VSS.n456 VSS.t96 0.303282
R1889 VSS.t136 VSS.t40 0.282363
R1890 VSS.n516 VSS.n515 0.231121
R1891 VSS.n515 VSS.n472 0.231121
R1892 VSS.n510 VSS.n472 0.231121
R1893 VSS.n510 VSS.n509 0.231121
R1894 VSS.n509 VSS.n508 0.231121
R1895 VSS.n508 VSS.n476 0.231121
R1896 VSS.n502 VSS.n476 0.231121
R1897 VSS.n502 VSS.n501 0.231121
R1898 VSS.n501 VSS.n500 0.231121
R1899 VSS.n500 VSS.n479 0.231121
R1900 VSS.n495 VSS.n479 0.231121
R1901 VSS.n495 VSS.n494 0.231121
R1902 VSS.n494 VSS.n493 0.231121
R1903 VSS.n493 VSS.n483 0.231121
R1904 VSS.n488 VSS.n483 0.231121
R1905 VSS.n823 VSS.n146 0.231121
R1906 VSS.n821 VSS.n146 0.231121
R1907 VSS.n821 VSS.n180 0.231121
R1908 VSS.n817 VSS.n180 0.231121
R1909 VSS.n817 VSS.n815 0.231121
R1910 VSS.n815 VSS.n813 0.231121
R1911 VSS.n813 VSS.n182 0.231121
R1912 VSS.n809 VSS.n182 0.231121
R1913 VSS.n809 VSS.n807 0.231121
R1914 VSS.n807 VSS.n806 0.231121
R1915 VSS.n806 VSS.n186 0.231121
R1916 VSS.n802 VSS.n186 0.231121
R1917 VSS.n802 VSS.n800 0.231121
R1918 VSS.n800 VSS.n799 0.231121
R1919 VSS.n799 VSS.n190 0.231121
R1920 VSS.n795 VSS.n190 0.231121
R1921 VSS.n795 VSS.n793 0.231121
R1922 VSS.n793 VSS.n792 0.231121
R1923 VSS.n792 VSS.n194 0.231121
R1924 VSS.n788 VSS.n194 0.231121
R1925 VSS.n788 VSS.n787 0.231121
R1926 VSS.n787 VSS.n785 0.231121
R1927 VSS.n785 VSS.n197 0.231121
R1928 VSS.n781 VSS.n197 0.231121
R1929 VSS.n781 VSS.n779 0.231121
R1930 VSS.n779 VSS.n777 0.231121
R1931 VSS.n777 VSS.n201 0.231121
R1932 VSS.n773 VSS.n201 0.231121
R1933 VSS.n773 VSS.n771 0.231121
R1934 VSS.n771 VSS.n769 0.231121
R1935 VSS.n769 VSS.n205 0.231121
R1936 VSS.n765 VSS.n205 0.231121
R1937 VSS.n765 VSS.n764 0.231121
R1938 VSS.n764 VSS.n762 0.231121
R1939 VSS.n762 VSS.n208 0.231121
R1940 VSS.n758 VSS.n208 0.231121
R1941 VSS.n758 VSS.n211 0.231121
R1942 VSS.n756 VSS.n211 0.231121
R1943 VSS.n756 VSS.n214 0.231121
R1944 VSS.n752 VSS.n214 0.231121
R1945 VSS.n752 VSS.n216 0.231121
R1946 VSS.n749 VSS.n216 0.231121
R1947 VSS.n749 VSS.n218 0.231121
R1948 VSS.n745 VSS.n218 0.231121
R1949 VSS.n745 VSS.n220 0.231121
R1950 VSS.n733 VSS.n220 0.231121
R1951 VSS.n733 VSS.n732 0.231121
R1952 VSS.n737 VSS.n732 0.231121
R1953 VSS.n738 VSS.n737 0.231121
R1954 VSS.n739 VSS.n738 0.231121
R1955 VSS.n739 VSS.n233 0.231121
R1956 VSS.n743 VSS.n233 0.231121
R1957 VSS.n743 VSS.n231 0.231121
R1958 VSS.n725 VSS.n231 0.231121
R1959 VSS.n725 VSS.n723 0.231121
R1960 VSS.n723 VSS.n235 0.231121
R1961 VSS.n239 VSS.n235 0.231121
R1962 VSS.n721 VSS.n239 0.231121
R1963 VSS.n721 VSS.n238 0.231121
R1964 VSS.n715 VSS.n238 0.231121
R1965 VSS.n715 VSS.n241 0.231121
R1966 VSS.n712 VSS.n241 0.231121
R1967 VSS.n712 VSS.n243 0.231121
R1968 VSS.n708 VSS.n243 0.231121
R1969 VSS.n708 VSS.n245 0.231121
R1970 VSS.n696 VSS.n245 0.231121
R1971 VSS.n696 VSS.n695 0.231121
R1972 VSS.n700 VSS.n695 0.231121
R1973 VSS.n701 VSS.n700 0.231121
R1974 VSS.n702 VSS.n701 0.231121
R1975 VSS.n702 VSS.n258 0.231121
R1976 VSS.n706 VSS.n258 0.231121
R1977 VSS.n706 VSS.n256 0.231121
R1978 VSS.n688 VSS.n256 0.231121
R1979 VSS.n688 VSS.n686 0.231121
R1980 VSS.n686 VSS.n260 0.231121
R1981 VSS.n264 VSS.n260 0.231121
R1982 VSS.n684 VSS.n264 0.231121
R1983 VSS.n684 VSS.n263 0.231121
R1984 VSS.n678 VSS.n263 0.231121
R1985 VSS.n678 VSS.n266 0.231121
R1986 VSS.n675 VSS.n266 0.231121
R1987 VSS.n675 VSS.n268 0.231121
R1988 VSS.n671 VSS.n268 0.231121
R1989 VSS.n671 VSS.n270 0.231121
R1990 VSS.n659 VSS.n270 0.231121
R1991 VSS.n659 VSS.n658 0.231121
R1992 VSS.n663 VSS.n658 0.231121
R1993 VSS.n664 VSS.n663 0.231121
R1994 VSS.n665 VSS.n664 0.231121
R1995 VSS.n665 VSS.n301 0.231121
R1996 VSS.n669 VSS.n301 0.231121
R1997 VSS.n669 VSS.n299 0.231121
R1998 VSS.n651 VSS.n299 0.231121
R1999 VSS.n651 VSS.n649 0.231121
R2000 VSS.n649 VSS.n647 0.231121
R2001 VSS.n647 VSS.n304 0.231121
R2002 VSS.n643 VSS.n304 0.231121
R2003 VSS.n643 VSS.n641 0.231121
R2004 VSS.n641 VSS.n639 0.231121
R2005 VSS.n639 VSS.n308 0.231121
R2006 VSS.n635 VSS.n308 0.231121
R2007 VSS.n635 VSS.n633 0.231121
R2008 VSS.n633 VSS.n631 0.231121
R2009 VSS.n631 VSS.n312 0.231121
R2010 VSS.n627 VSS.n312 0.231121
R2011 VSS.n627 VSS.n626 0.231121
R2012 VSS.n626 VSS.n624 0.231121
R2013 VSS.n624 VSS.n316 0.231121
R2014 VSS.n620 VSS.n316 0.231121
R2015 VSS.n620 VSS.n618 0.231121
R2016 VSS.n618 VSS.n616 0.231121
R2017 VSS.n616 VSS.n320 0.231121
R2018 VSS.n612 VSS.n320 0.231121
R2019 VSS.n612 VSS.n610 0.231121
R2020 VSS.n610 VSS.n322 0.231121
R2021 VSS.n326 VSS.n322 0.231121
R2022 VSS.n608 VSS.n326 0.231121
R2023 VSS.n608 VSS.n325 0.231121
R2024 VSS.n602 VSS.n325 0.231121
R2025 VSS.n602 VSS.n328 0.231121
R2026 VSS.n599 VSS.n328 0.231121
R2027 VSS.n599 VSS.n330 0.231121
R2028 VSS.n595 VSS.n330 0.231121
R2029 VSS.n595 VSS.n332 0.231121
R2030 VSS.n583 VSS.n332 0.231121
R2031 VSS.n583 VSS.n582 0.231121
R2032 VSS.n587 VSS.n582 0.231121
R2033 VSS.n588 VSS.n587 0.231121
R2034 VSS.n589 VSS.n588 0.231121
R2035 VSS.n589 VSS.n345 0.231121
R2036 VSS.n593 VSS.n345 0.231121
R2037 VSS.n593 VSS.n343 0.231121
R2038 VSS.n575 VSS.n343 0.231121
R2039 VSS.n575 VSS.n573 0.231121
R2040 VSS.n573 VSS.n347 0.231121
R2041 VSS.n351 VSS.n347 0.231121
R2042 VSS.n571 VSS.n351 0.231121
R2043 VSS.n571 VSS.n350 0.231121
R2044 VSS.n565 VSS.n350 0.231121
R2045 VSS.n565 VSS.n353 0.231121
R2046 VSS.n562 VSS.n353 0.231121
R2047 VSS.n562 VSS.n355 0.231121
R2048 VSS.n558 VSS.n355 0.231121
R2049 VSS.n558 VSS.n357 0.231121
R2050 VSS.n546 VSS.n357 0.231121
R2051 VSS.n546 VSS.n545 0.231121
R2052 VSS.n550 VSS.n545 0.231121
R2053 VSS.n551 VSS.n550 0.231121
R2054 VSS.n552 VSS.n551 0.231121
R2055 VSS.n552 VSS.n370 0.231121
R2056 VSS.n556 VSS.n370 0.231121
R2057 VSS.n556 VSS.n368 0.231121
R2058 VSS.n538 VSS.n368 0.231121
R2059 VSS.n538 VSS.n536 0.231121
R2060 VSS.n536 VSS.n372 0.231121
R2061 VSS.n376 VSS.n372 0.231121
R2062 VSS.n534 VSS.n376 0.231121
R2063 VSS.n534 VSS.n375 0.231121
R2064 VSS.n528 VSS.n375 0.231121
R2065 VSS.n528 VSS.n378 0.231121
R2066 VSS.n525 VSS.n378 0.231121
R2067 VSS.n525 VSS.n380 0.231121
R2068 VSS.n521 VSS.n380 0.231121
R2069 VSS.n521 VSS.n382 0.231121
R2070 VSS.n410 VSS.n382 0.231121
R2071 VSS.n412 VSS.n410 0.231121
R2072 VSS.n413 VSS.n412 0.231121
R2073 VSS.n415 VSS.n413 0.231121
R2074 VSS.n417 VSS.n415 0.231121
R2075 VSS.n419 VSS.n417 0.231121
R2076 VSS.n420 VSS.n419 0.231121
R2077 VSS.n422 VSS.n420 0.231121
R2078 VSS.n424 VSS.n422 0.231121
R2079 VSS.n426 VSS.n424 0.231121
R2080 VSS.n428 VSS.n426 0.231121
R2081 VSS.n430 VSS.n428 0.231121
R2082 VSS.n430 VSS.n398 0.231121
R2083 VSS.n824 VSS.n145 0.231121
R2084 VSS.n820 VSS.n145 0.231121
R2085 VSS.n820 VSS.n819 0.231121
R2086 VSS.n819 VSS.n818 0.231121
R2087 VSS.n818 VSS.n181 0.231121
R2088 VSS.n812 VSS.n181 0.231121
R2089 VSS.n812 VSS.n811 0.231121
R2090 VSS.n811 VSS.n810 0.231121
R2091 VSS.n810 VSS.n184 0.231121
R2092 VSS.n805 VSS.n184 0.231121
R2093 VSS.n805 VSS.n804 0.231121
R2094 VSS.n804 VSS.n803 0.231121
R2095 VSS.n803 VSS.n188 0.231121
R2096 VSS.n798 VSS.n188 0.231121
R2097 VSS.n798 VSS.n797 0.231121
R2098 VSS.n797 VSS.n796 0.231121
R2099 VSS.n796 VSS.n192 0.231121
R2100 VSS.n791 VSS.n192 0.231121
R2101 VSS.n791 VSS.n790 0.231121
R2102 VSS.n790 VSS.n789 0.231121
R2103 VSS.n789 VSS.n195 0.231121
R2104 VSS.n784 VSS.n195 0.231121
R2105 VSS.n784 VSS.n783 0.231121
R2106 VSS.n783 VSS.n782 0.231121
R2107 VSS.n782 VSS.n199 0.231121
R2108 VSS.n776 VSS.n199 0.231121
R2109 VSS.n776 VSS.n775 0.231121
R2110 VSS.n775 VSS.n774 0.231121
R2111 VSS.n774 VSS.n203 0.231121
R2112 VSS.n768 VSS.n203 0.231121
R2113 VSS.n768 VSS.n767 0.231121
R2114 VSS.n767 VSS.n766 0.231121
R2115 VSS.n766 VSS.n207 0.231121
R2116 VSS.n761 VSS.n207 0.231121
R2117 VSS.n761 VSS.n760 0.231121
R2118 VSS.n760 VSS.n759 0.231121
R2119 VSS.n759 VSS.n210 0.231121
R2120 VSS.n755 VSS.n210 0.231121
R2121 VSS.n755 VSS.n754 0.231121
R2122 VSS.n754 VSS.n753 0.231121
R2123 VSS.n753 VSS.n215 0.231121
R2124 VSS.n748 VSS.n215 0.231121
R2125 VSS.n748 VSS.n747 0.231121
R2126 VSS.n747 VSS.n746 0.231121
R2127 VSS.n746 VSS.n219 0.231121
R2128 VSS.n734 VSS.n219 0.231121
R2129 VSS.n735 VSS.n734 0.231121
R2130 VSS.n736 VSS.n735 0.231121
R2131 VSS.n736 VSS.n728 0.231121
R2132 VSS.n740 VSS.n728 0.231121
R2133 VSS.n741 VSS.n740 0.231121
R2134 VSS.n742 VSS.n741 0.231121
R2135 VSS.n742 VSS.n727 0.231121
R2136 VSS.n727 VSS.n726 0.231121
R2137 VSS.n726 VSS.n234 0.231121
R2138 VSS.n718 VSS.n234 0.231121
R2139 VSS.n719 VSS.n718 0.231121
R2140 VSS.n720 VSS.n719 0.231121
R2141 VSS.n720 VSS.n717 0.231121
R2142 VSS.n717 VSS.n716 0.231121
R2143 VSS.n716 VSS.n240 0.231121
R2144 VSS.n711 VSS.n240 0.231121
R2145 VSS.n711 VSS.n710 0.231121
R2146 VSS.n710 VSS.n709 0.231121
R2147 VSS.n709 VSS.n244 0.231121
R2148 VSS.n697 VSS.n244 0.231121
R2149 VSS.n698 VSS.n697 0.231121
R2150 VSS.n699 VSS.n698 0.231121
R2151 VSS.n699 VSS.n691 0.231121
R2152 VSS.n703 VSS.n691 0.231121
R2153 VSS.n704 VSS.n703 0.231121
R2154 VSS.n705 VSS.n704 0.231121
R2155 VSS.n705 VSS.n690 0.231121
R2156 VSS.n690 VSS.n689 0.231121
R2157 VSS.n689 VSS.n259 0.231121
R2158 VSS.n681 VSS.n259 0.231121
R2159 VSS.n682 VSS.n681 0.231121
R2160 VSS.n683 VSS.n682 0.231121
R2161 VSS.n683 VSS.n680 0.231121
R2162 VSS.n680 VSS.n679 0.231121
R2163 VSS.n679 VSS.n265 0.231121
R2164 VSS.n674 VSS.n265 0.231121
R2165 VSS.n674 VSS.n673 0.231121
R2166 VSS.n673 VSS.n672 0.231121
R2167 VSS.n672 VSS.n269 0.231121
R2168 VSS.n660 VSS.n269 0.231121
R2169 VSS.n661 VSS.n660 0.231121
R2170 VSS.n662 VSS.n661 0.231121
R2171 VSS.n662 VSS.n654 0.231121
R2172 VSS.n666 VSS.n654 0.231121
R2173 VSS.n667 VSS.n666 0.231121
R2174 VSS.n668 VSS.n667 0.231121
R2175 VSS.n668 VSS.n653 0.231121
R2176 VSS.n653 VSS.n652 0.231121
R2177 VSS.n652 VSS.n302 0.231121
R2178 VSS.n646 VSS.n302 0.231121
R2179 VSS.n646 VSS.n645 0.231121
R2180 VSS.n645 VSS.n644 0.231121
R2181 VSS.n644 VSS.n306 0.231121
R2182 VSS.n638 VSS.n306 0.231121
R2183 VSS.n638 VSS.n637 0.231121
R2184 VSS.n637 VSS.n636 0.231121
R2185 VSS.n636 VSS.n310 0.231121
R2186 VSS.n630 VSS.n310 0.231121
R2187 VSS.n630 VSS.n629 0.231121
R2188 VSS.n629 VSS.n628 0.231121
R2189 VSS.n628 VSS.n314 0.231121
R2190 VSS.n623 VSS.n314 0.231121
R2191 VSS.n623 VSS.n622 0.231121
R2192 VSS.n622 VSS.n621 0.231121
R2193 VSS.n621 VSS.n318 0.231121
R2194 VSS.n615 VSS.n318 0.231121
R2195 VSS.n615 VSS.n614 0.231121
R2196 VSS.n614 VSS.n613 0.231121
R2197 VSS.n613 VSS.n321 0.231121
R2198 VSS.n605 VSS.n321 0.231121
R2199 VSS.n606 VSS.n605 0.231121
R2200 VSS.n607 VSS.n606 0.231121
R2201 VSS.n607 VSS.n604 0.231121
R2202 VSS.n604 VSS.n603 0.231121
R2203 VSS.n603 VSS.n327 0.231121
R2204 VSS.n598 VSS.n327 0.231121
R2205 VSS.n598 VSS.n597 0.231121
R2206 VSS.n597 VSS.n596 0.231121
R2207 VSS.n596 VSS.n331 0.231121
R2208 VSS.n584 VSS.n331 0.231121
R2209 VSS.n585 VSS.n584 0.231121
R2210 VSS.n586 VSS.n585 0.231121
R2211 VSS.n586 VSS.n578 0.231121
R2212 VSS.n590 VSS.n578 0.231121
R2213 VSS.n591 VSS.n590 0.231121
R2214 VSS.n592 VSS.n591 0.231121
R2215 VSS.n592 VSS.n577 0.231121
R2216 VSS.n577 VSS.n576 0.231121
R2217 VSS.n576 VSS.n346 0.231121
R2218 VSS.n568 VSS.n346 0.231121
R2219 VSS.n569 VSS.n568 0.231121
R2220 VSS.n570 VSS.n569 0.231121
R2221 VSS.n570 VSS.n567 0.231121
R2222 VSS.n567 VSS.n566 0.231121
R2223 VSS.n566 VSS.n352 0.231121
R2224 VSS.n561 VSS.n352 0.231121
R2225 VSS.n561 VSS.n560 0.231121
R2226 VSS.n560 VSS.n559 0.231121
R2227 VSS.n559 VSS.n356 0.231121
R2228 VSS.n547 VSS.n356 0.231121
R2229 VSS.n548 VSS.n547 0.231121
R2230 VSS.n549 VSS.n548 0.231121
R2231 VSS.n549 VSS.n541 0.231121
R2232 VSS.n553 VSS.n541 0.231121
R2233 VSS.n554 VSS.n553 0.231121
R2234 VSS.n555 VSS.n554 0.231121
R2235 VSS.n555 VSS.n540 0.231121
R2236 VSS.n540 VSS.n539 0.231121
R2237 VSS.n539 VSS.n371 0.231121
R2238 VSS.n531 VSS.n371 0.231121
R2239 VSS.n532 VSS.n531 0.231121
R2240 VSS.n533 VSS.n532 0.231121
R2241 VSS.n533 VSS.n530 0.231121
R2242 VSS.n530 VSS.n529 0.231121
R2243 VSS.n529 VSS.n377 0.231121
R2244 VSS.n524 VSS.n377 0.231121
R2245 VSS.n524 VSS.n523 0.231121
R2246 VSS.n523 VSS.n522 0.231121
R2247 VSS.n522 VSS.n381 0.231121
R2248 VSS.n409 VSS.n381 0.231121
R2249 VSS.n409 VSS.n408 0.231121
R2250 VSS.n408 VSS.n407 0.231121
R2251 VSS.n407 VSS.n406 0.231121
R2252 VSS.n406 VSS.n405 0.231121
R2253 VSS.n405 VSS.n404 0.231121
R2254 VSS.n404 VSS.n403 0.231121
R2255 VSS.n403 VSS.n402 0.231121
R2256 VSS.n402 VSS.n401 0.231121
R2257 VSS.n401 VSS.n400 0.231121
R2258 VSS.n400 VSS.n399 0.231121
R2259 VSS.n431 VSS.n399 0.231121
R2260 VSS.n514 VSS.n471 0.231121
R2261 VSS.n514 VSS.n513 0.231121
R2262 VSS.n513 VSS.n511 0.231121
R2263 VSS.n511 VSS.n474 0.231121
R2264 VSS.n507 VSS.n474 0.231121
R2265 VSS.n507 VSS.n505 0.231121
R2266 VSS.n505 VSS.n503 0.231121
R2267 VSS.n503 VSS.n478 0.231121
R2268 VSS.n499 VSS.n478 0.231121
R2269 VSS.n499 VSS.n498 0.231121
R2270 VSS.n498 VSS.n496 0.231121
R2271 VSS.n496 VSS.n481 0.231121
R2272 VSS.n492 VSS.n481 0.231121
R2273 VSS.n492 VSS.n491 0.231121
R2274 VSS.n491 VSS.n489 0.231121
R2275 VSS.n489 VSS.n485 0.231121
R2276 VSS.n517 VSS 0.226636
R2277 VSS VSS.n825 0.226288
R2278 VSS.n105 VSS.t136 0.201628
R2279 VSS.n473 VSS.n469 0.143368
R2280 VSS.n477 VSS.n465 0.143368
R2281 VSS.n480 VSS.n462 0.143368
R2282 VSS.n484 VSS.n459 0.143368
R2283 VSS.n414 VSS.n385 0.143368
R2284 VSS.n416 VSS.n387 0.143368
R2285 VSS.n418 VSS.n389 0.143368
R2286 VSS.n423 VSS.n392 0.143368
R2287 VSS.n425 VSS.n393 0.143368
R2288 VSS.n427 VSS.n394 0.143368
R2289 VSS.n429 VSS.n395 0.143368
R2290 VSS.n411 VSS.n383 0.143368
R2291 VSS.n816 VSS.n177 0.143368
R2292 VSS.n808 VSS.n174 0.143368
R2293 VSS.n801 VSS.n172 0.143368
R2294 VSS.n794 VSS.n169 0.143368
R2295 VSS.n786 VSS.n165 0.143368
R2296 VSS.n198 VSS.n164 0.143368
R2297 VSS.n196 VSS.n163 0.143368
R2298 VSS.n780 VSS.n162 0.143368
R2299 VSS.n778 VSS.n161 0.143368
R2300 VSS.n202 VSS.n160 0.143368
R2301 VSS.n200 VSS.n159 0.143368
R2302 VSS.n772 VSS.n158 0.143368
R2303 VSS.n770 VSS.n157 0.143368
R2304 VSS.n206 VSS.n156 0.143368
R2305 VSS.n204 VSS.n155 0.143368
R2306 VSS.n209 VSS.n153 0.143368
R2307 VSS.n731 VSS.n221 0.143368
R2308 VSS.n730 VSS.n224 0.143368
R2309 VSS.n729 VSS.n225 0.143368
R2310 VSS.n232 VSS.n226 0.143368
R2311 VSS.n724 VSS.n228 0.143368
R2312 VSS.n694 VSS.n246 0.143368
R2313 VSS.n693 VSS.n249 0.143368
R2314 VSS.n692 VSS.n250 0.143368
R2315 VSS.n257 VSS.n251 0.143368
R2316 VSS.n687 VSS.n253 0.143368
R2317 VSS.n657 VSS.n271 0.143368
R2318 VSS.n656 VSS.n274 0.143368
R2319 VSS.n655 VSS.n275 0.143368
R2320 VSS.n300 VSS.n276 0.143368
R2321 VSS.n650 VSS.n278 0.143368
R2322 VSS.n648 VSS.n279 0.143368
R2323 VSS.n305 VSS.n280 0.143368
R2324 VSS.n303 VSS.n281 0.143368
R2325 VSS.n642 VSS.n282 0.143368
R2326 VSS.n640 VSS.n283 0.143368
R2327 VSS.n634 VSS.n285 0.143368
R2328 VSS.n632 VSS.n286 0.143368
R2329 VSS.n625 VSS.n289 0.143368
R2330 VSS.n317 VSS.n290 0.143368
R2331 VSS.n315 VSS.n291 0.143368
R2332 VSS.n619 VSS.n292 0.143368
R2333 VSS.n617 VSS.n293 0.143368
R2334 VSS.n611 VSS.n295 0.143368
R2335 VSS.n581 VSS.n333 0.143368
R2336 VSS.n580 VSS.n336 0.143368
R2337 VSS.n579 VSS.n337 0.143368
R2338 VSS.n344 VSS.n338 0.143368
R2339 VSS.n574 VSS.n340 0.143368
R2340 VSS.n544 VSS.n358 0.143368
R2341 VSS.n543 VSS.n361 0.143368
R2342 VSS.n542 VSS.n362 0.143368
R2343 VSS.n369 VSS.n363 0.143368
R2344 VSS.n537 VSS.n365 0.143368
R2345 VSS.t104 VSS.n150 0.143368
R2346 VSS.t20 VSS.n168 0.143368
R2347 VSS.t51 VSS.n166 0.143368
R2348 VSS.t26 VSS.n288 0.143368
R2349 VSS.t261 VSS.n439 0.143368
R2350 VSS.t142 VSS.n457 0.143368
R2351 VSS.n482 VSS.t276 0.143368
R2352 VSS.t282 VSS.n466 0.143368
R2353 VSS.n435 VSS.t162 0.143368
R2354 VSS.t251 VSS.n384 0.143368
R2355 VSS.t242 VSS.n373 0.143368
R2356 VSS.t237 VSS.n359 0.143368
R2357 VSS.t227 VSS.n348 0.143368
R2358 VSS.t222 VSS.n334 0.143368
R2359 VSS.t212 VSS.n323 0.143368
R2360 VSS.t207 VSS.n272 0.143368
R2361 VSS.t197 VSS.n261 0.143368
R2362 VSS.t192 VSS.n247 0.143368
R2363 VSS.t182 VSS.n236 0.143368
R2364 VSS.t177 VSS.n222 0.143368
R2365 VSS.t167 VSS.n212 0.143368
R2366 VSS.n185 VSS.t79 0.143368
R2367 VSS.t110 VSS.n175 0.143368
R2368 VSS.n147 VSS.t299 0.143368
R2369 VSS.t169 VSS.n115 0.0651609
R2370 VSS.t184 VSS.n120 0.0651609
R2371 VSS.t199 VSS.n125 0.0651609
R2372 VSS.t214 VSS.n130 0.0651609
R2373 VSS.t229 VSS.n135 0.0651609
R2374 VSS.t244 VSS.n140 0.0651609
R2375 VSS.n487 VSS.n485 0.113429
R2376 VSS.n432 VSS.n398 0.113429
R2377 VSS.t171 VSS.n117 0.105868
R2378 VSS.t186 VSS.n122 0.105868
R2379 VSS.t201 VSS.n127 0.105868
R2380 VSS.t216 VSS.n132 0.105868
R2381 VSS.t231 VSS.n137 0.105868
R2382 VSS.t246 VSS.n142 0.105868
R2383 VSS.n114 VSS.n209 0.0968361
R2384 VSS.n119 VSS.n724 0.0968361
R2385 VSS.n124 VSS.n687 0.0968361
R2386 VSS.n129 VSS.n611 0.0968361
R2387 VSS.n134 VSS.n574 0.0968361
R2388 VSS.n139 VSS.n537 0.0968361
R2389 VSS.n512 VSS.n434 0.0961384
R2390 VSS.n506 VSS.n468 0.0961384
R2391 VSS.t269 VSS.n464 0.0961384
R2392 VSS.t261 VSS.n461 0.0961384
R2393 VSS.n416 VSS.n388 0.0961384
R2394 VSS.n421 VSS.n391 0.0961384
R2395 VSS.n822 VSS.n178 0.0961384
R2396 VSS.n814 VSS.n176 0.0961384
R2397 VSS.t77 VSS.n173 0.0961384
R2398 VSS.t104 VSS.n171 0.0961384
R2399 VSS.t22 VSS.n167 0.0961384
R2400 VSS.t75 VSS.n154 0.0961384
R2401 VSS.t43 VSS.n227 0.0961384
R2402 VSS.t139 VSS.n252 0.0961384
R2403 VSS.t259 VSS.n277 0.0961384
R2404 VSS.n309 VSS.n284 0.0961384
R2405 VSS.n313 VSS.n287 0.0961384
R2406 VSS.t114 VSS.n294 0.0961384
R2407 VSS.t304 VSS.n339 0.0961384
R2408 VSS.t82 VSS.n364 0.0961384
R2409 VSS.n435 VSS.n434 0.0958002
R2410 VSS.n473 VSS.n468 0.0958002
R2411 VSS.n477 VSS.n464 0.0958002
R2412 VSS.n480 VSS.n461 0.0958002
R2413 VSS.n418 VSS.n388 0.0958002
R2414 VSS.n423 VSS.n391 0.0958002
R2415 VSS.n822 VSS.n147 0.0958002
R2416 VSS.n816 VSS.n176 0.0958002
R2417 VSS.n808 VSS.n173 0.0958002
R2418 VSS.n801 VSS.n171 0.0958002
R2419 VSS.t20 VSS.n167 0.0958002
R2420 VSS.n204 VSS.n154 0.0958002
R2421 VSS.n232 VSS.n227 0.0958002
R2422 VSS.n257 VSS.n252 0.0958002
R2423 VSS.n300 VSS.n277 0.0958002
R2424 VSS.n640 VSS.n284 0.0958002
R2425 VSS.n632 VSS.n287 0.0958002
R2426 VSS.n617 VSS.n294 0.0958002
R2427 VSS.n344 VSS.n339 0.0958002
R2428 VSS.n369 VSS.n364 0.0958002
R2429 VSS.n475 VSS.t156 0.0955
R2430 VSS.n504 VSS.t267 0.0955
R2431 VSS.n497 VSS.n438 0.0955
R2432 VSS.n486 VSS.t263 0.0955
R2433 VSS.n421 VSS.n390 0.0955
R2434 VSS.n397 VSS.n396 0.0955
R2435 VSS.n433 VSS.n396 0.0955
R2436 VSS.n179 VSS.t65 0.0955
R2437 VSS.n183 VSS.t90 0.0955
R2438 VSS.n187 VSS.n149 0.0955
R2439 VSS.n189 VSS.t107 0.0955
R2440 VSS.n193 VSS.n151 0.0955
R2441 VSS.n763 VSS.n152 0.0955
R2442 VSS.n750 VSS.t172 0.0955
R2443 VSS.n230 VSS.n229 0.0955
R2444 VSS.n713 VSS.t187 0.0955
R2445 VSS.n255 VSS.n254 0.0955
R2446 VSS.n676 VSS.t202 0.0955
R2447 VSS.n298 VSS.n297 0.0955
R2448 VSS.n307 VSS.t309 0.0955
R2449 VSS.n311 VSS.t24 0.0955
R2450 VSS.n319 VSS.n296 0.0955
R2451 VSS.n600 VSS.t217 0.0955
R2452 VSS.n342 VSS.n341 0.0955
R2453 VSS.n563 VSS.t232 0.0955
R2454 VSS.n367 VSS.n366 0.0955
R2455 VSS.n526 VSS.t247 0.0955
R2456 VSS.n814 VSS.t90 0.0955
R2457 VSS.t77 VSS.n149 0.0955
R2458 VSS.t75 VSS.n152 0.0955
R2459 VSS.n230 VSS.t43 0.0955
R2460 VSS.n255 VSS.t139 0.0955
R2461 VSS.n298 VSS.t259 0.0955
R2462 VSS.n342 VSS.t304 0.0955
R2463 VSS.n367 VSS.t82 0.0955
R2464 VSS.n512 VSS.t156 0.0955
R2465 VSS.n506 VSS.t267 0.0955
R2466 VSS.t269 VSS.n438 0.0955
R2467 VSS.n490 VSS.t263 0.0955
R2468 VSS.t286 VSS.n390 0.0955
R2469 VSS.t247 VSS.n379 0.0955
R2470 VSS.t232 VSS.n354 0.0955
R2471 VSS.t217 VSS.n329 0.0955
R2472 VSS.t114 VSS.n296 0.0955
R2473 VSS.n313 VSS.t24 0.0955
R2474 VSS.n309 VSS.t309 0.0955
R2475 VSS.t202 VSS.n267 0.0955
R2476 VSS.t187 VSS.n242 0.0955
R2477 VSS.t172 VSS.n217 0.0955
R2478 VSS.t22 VSS.n151 0.0955
R2479 VSS.n191 VSS.t107 0.0955
R2480 VSS.n178 VSS.t65 0.0955
R2481 VSS.n118 VSS.t174 0.0912103
R2482 VSS.n123 VSS.t189 0.0912103
R2483 VSS.n128 VSS.t204 0.0912103
R2484 VSS.n133 VSS.t219 0.0912103
R2485 VSS.n138 VSS.t234 0.0912103
R2486 VSS.n143 VSS.t249 0.0912103
R2487 VSS.n757 VSS.t166 0.078
R2488 VSS.t181 VSS.n722 0.078
R2489 VSS.t196 VSS.n685 0.078
R2490 VSS.t211 VSS.n609 0.078
R2491 VSS.t226 VSS.n572 0.078
R2492 VSS.t241 VSS.n535 0.078
R2493 VSS.t171 VSS.n116 0.0238559
R2494 VSS.t186 VSS.n121 0.0238559
R2495 VSS.t201 VSS.n126 0.0238559
R2496 VSS.t216 VSS.n131 0.0238559
R2497 VSS.t231 VSS.n136 0.0238559
R2498 VSS.t246 VSS.n141 0.0238559
R2499 VSS.n751 VSS.n750 0.066499
R2500 VSS.n714 VSS.n713 0.066499
R2501 VSS.n677 VSS.n676 0.066499
R2502 VSS.n601 VSS.n600 0.066499
R2503 VSS.n564 VSS.n563 0.066499
R2504 VSS.n527 VSS.n526 0.066499
R2505 VSS.t169 VSS.n213 0.05175
R2506 VSS.t184 VSS.n237 0.05175
R2507 VSS.t199 VSS.n262 0.05175
R2508 VSS.t214 VSS.n324 0.05175
R2509 VSS.t229 VSS.n349 0.05175
R2510 VSS.t244 VSS.n374 0.05175
R2511 VSS.t162 VSS.n470 0.0483676
R2512 VSS.n490 VSS.n439 0.0483676
R2513 VSS.n475 VSS.n469 0.0483676
R2514 VSS.n504 VSS.n466 0.0483676
R2515 VSS.t282 VSS.n465 0.0483676
R2516 VSS.n497 VSS.t276 0.0483676
R2517 VSS.n482 VSS.n462 0.0483676
R2518 VSS.n486 VSS.n459 0.0483676
R2519 VSS.n484 VSS.n457 0.0483676
R2520 VSS.t286 VSS.n389 0.0483676
R2521 VSS.n425 VSS.n392 0.0483676
R2522 VSS.n429 VSS.n394 0.0483676
R2523 VSS.n397 VSS.n395 0.0483676
R2524 VSS.n519 VSS.n433 0.0483676
R2525 VSS.t254 VSS.n385 0.0483676
R2526 VSS.n414 VSS.n387 0.0483676
R2527 VSS.n427 VSS.n393 0.0483676
R2528 VSS.n148 VSS.t299 0.0483676
R2529 VSS.n191 VSS.n150 0.0483676
R2530 VSS.n217 VSS.n117 0.0483676
R2531 VSS.n242 VSS.n122 0.0483676
R2532 VSS.n267 VSS.n127 0.0483676
R2533 VSS.n329 VSS.n132 0.0483676
R2534 VSS.n354 VSS.n137 0.0483676
R2535 VSS.n379 VSS.n142 0.0483676
R2536 VSS.n520 VSS.n384 0.0483676
R2537 VSS.t251 VSS.n383 0.0483676
R2538 VSS.n179 VSS.n177 0.0483676
R2539 VSS.n183 VSS.n175 0.0483676
R2540 VSS.t110 VSS.n174 0.0483676
R2541 VSS.n187 VSS.t79 0.0483676
R2542 VSS.n185 VSS.n172 0.0483676
R2543 VSS.n189 VSS.n169 0.0483676
R2544 VSS.n794 VSS.n168 0.0483676
R2545 VSS.n193 VSS.n166 0.0483676
R2546 VSS.t51 VSS.n165 0.0483676
R2547 VSS.n786 VSS.n164 0.0483676
R2548 VSS.n198 VSS.n163 0.0483676
R2549 VSS.n196 VSS.n162 0.0483676
R2550 VSS.n780 VSS.n161 0.0483676
R2551 VSS.n778 VSS.n160 0.0483676
R2552 VSS.n202 VSS.n159 0.0483676
R2553 VSS.n200 VSS.n158 0.0483676
R2554 VSS.n772 VSS.n157 0.0483676
R2555 VSS.n770 VSS.n156 0.0483676
R2556 VSS.n206 VSS.n155 0.0483676
R2557 VSS.n763 VSS.n153 0.0483676
R2558 VSS.n757 VSS.n212 0.0483676
R2559 VSS.n744 VSS.n222 0.0483676
R2560 VSS.t177 VSS.n221 0.0483676
R2561 VSS.t179 VSS.n224 0.0483676
R2562 VSS.n730 VSS.n225 0.0483676
R2563 VSS.n729 VSS.n226 0.0483676
R2564 VSS.n229 VSS.n228 0.0483676
R2565 VSS.n722 VSS.n236 0.0483676
R2566 VSS.n707 VSS.n247 0.0483676
R2567 VSS.t192 VSS.n246 0.0483676
R2568 VSS.t194 VSS.n249 0.0483676
R2569 VSS.n693 VSS.n250 0.0483676
R2570 VSS.n692 VSS.n251 0.0483676
R2571 VSS.n254 VSS.n253 0.0483676
R2572 VSS.n685 VSS.n261 0.0483676
R2573 VSS.n670 VSS.n272 0.0483676
R2574 VSS.t207 VSS.n271 0.0483676
R2575 VSS.t209 VSS.n274 0.0483676
R2576 VSS.n656 VSS.n275 0.0483676
R2577 VSS.n655 VSS.n276 0.0483676
R2578 VSS.n297 VSS.n278 0.0483676
R2579 VSS.n650 VSS.n279 0.0483676
R2580 VSS.n648 VSS.n280 0.0483676
R2581 VSS.n305 VSS.n281 0.0483676
R2582 VSS.n303 VSS.n282 0.0483676
R2583 VSS.n642 VSS.n283 0.0483676
R2584 VSS.n307 VSS.n285 0.0483676
R2585 VSS.n634 VSS.n286 0.0483676
R2586 VSS.n311 VSS.n288 0.0483676
R2587 VSS.t26 VSS.n289 0.0483676
R2588 VSS.n625 VSS.n290 0.0483676
R2589 VSS.n317 VSS.n291 0.0483676
R2590 VSS.n315 VSS.n292 0.0483676
R2591 VSS.n619 VSS.n293 0.0483676
R2592 VSS.n319 VSS.n295 0.0483676
R2593 VSS.n609 VSS.n323 0.0483676
R2594 VSS.n594 VSS.n334 0.0483676
R2595 VSS.t222 VSS.n333 0.0483676
R2596 VSS.t224 VSS.n336 0.0483676
R2597 VSS.n580 VSS.n337 0.0483676
R2598 VSS.n579 VSS.n338 0.0483676
R2599 VSS.n341 VSS.n340 0.0483676
R2600 VSS.n572 VSS.n348 0.0483676
R2601 VSS.n557 VSS.n359 0.0483676
R2602 VSS.t237 VSS.n358 0.0483676
R2603 VSS.t239 VSS.n361 0.0483676
R2604 VSS.n543 VSS.n362 0.0483676
R2605 VSS.n542 VSS.n363 0.0483676
R2606 VSS.n366 VSS.n365 0.0483676
R2607 VSS.n535 VSS.n373 0.0483676
R2608 VSS.t252 VSS.n520 0.038
R2609 VSS.t176 VSS.n744 0.038
R2610 VSS.t191 VSS.n707 0.038
R2611 VSS.t206 VSS.n670 0.038
R2612 VSS.t221 VSS.n594 0.038
R2613 VSS.t236 VSS.n557 0.038
R2614 VSS.n751 VSS.t174 0.0373698
R2615 VSS.n714 VSS.t189 0.0373698
R2616 VSS.n677 VSS.t204 0.0373698
R2617 VSS.n601 VSS.t219 0.0373698
R2618 VSS.n564 VSS.t234 0.0373698
R2619 VSS.n527 VSS.t249 0.0373698
R2620 VSS.t179 VSS.n223 0.0253649
R2621 VSS.t194 VSS.n248 0.0253649
R2622 VSS.t209 VSS.n273 0.0253649
R2623 VSS.t224 VSS.n335 0.0253649
R2624 VSS.t239 VSS.n360 0.0253649
R2625 VSS.t254 VSS.n386 0.0253649
R2626 VSS.n105 VSS.n103 0.0211997
R2627 VSS.n105 VSS.n15 0.0211997
R2628 VSS.n105 VSS.n17 0.0211997
R2629 VSS.n105 VSS.n18 0.0211997
R2630 VSS.n105 VSS.n96 0.0211997
R2631 VSS.n107 VSS.t321 385.353
R2632 VSS.n105 VSS.n93 0.0211997
R2633 VSS.n105 VSS.n21 0.0211997
R2634 VSS.n105 VSS.n89 0.0211997
R2635 VSS.n105 VSS.n23 0.0156714
R2636 VSS.n105 VSS.n87 0.0211997
R2637 VSS.n105 VSS.n25 0.0211997
R2638 VSS.n105 VSS.n83 0.0211997
R2639 VSS.n109 VSS.t83 385.353
R2640 VSS.n105 VSS.n80 0.0211997
R2641 VSS.n105 VSS.n28 0.0211997
R2642 VSS.n105 VSS.n76 0.0211997
R2643 VSS.n110 VSS.t13 385.353
R2644 VSS.n105 VSS.n74 0.0211997
R2645 VSS.n105 VSS.n31 0.0211997
R2646 VSS.n105 VSS.n70 0.0211997
R2647 VSS.n105 VSS.n33 0.0156714
R2648 VSS.n105 VSS.n67 0.0211997
R2649 VSS.n105 VSS.n35 0.0211997
R2650 VSS.n105 VSS.n63 0.0211997
R2651 VSS.n112 VSS.t119 385.353
R2652 VSS.n105 VSS.n60 0.0211997
R2653 VSS.n105 VSS.n38 0.0211997
R2654 VSS.n105 VSS.n56 0.0211997
R2655 VSS.n105 VSS.n40 0.0156714
R2656 VSS.n105 VSS.n53 0.0211997
R2657 VSS.n105 VSS.n42 0.0211997
R2658 VSS.n105 VSS.n49 0.0211997
R2659 VSS.n105 VSS.n44 0.0156714
R2660 VSS.n105 VSS.n46 0.0211997
R2661 VSS.n105 VSS.n45 0.0211997
R2662 VSS.n4 VSS.t302 133.321
R2663 VSS.n411 VSS.n386 0.0141149
R2664 VSS.n731 VSS.n223 0.0141149
R2665 VSS.n694 VSS.n248 0.0141149
R2666 VSS.n657 VSS.n273 0.0141149
R2667 VSS.n581 VSS.n335 0.0141149
R2668 VSS.n544 VSS.n360 0.0141149
R2669 VSS.n105 VSS.n51 0.00212553
R2670 VSS.n105 VSS.n104 0.00171365
R2671 VSS.n105 VSS.n13 0.00171365
R2672 VSS.n105 VSS.n19 0.00171365
R2673 VSS.n105 VSS.n20 0.00171365
R2674 VSS.n105 VSS.n22 0.00171365
R2675 VSS.n105 VSS.n24 0.00171365
R2676 VSS.n105 VSS.n26 0.00171365
R2677 VSS.n105 VSS.n27 0.00171365
R2678 VSS.n105 VSS.n29 0.00171365
R2679 VSS.n105 VSS.n30 0.00171365
R2680 VSS.n105 VSS.n32 0.00171365
R2681 VSS.n105 VSS.n34 0.00171365
R2682 VSS.n105 VSS.n36 0.00171365
R2683 VSS.n105 VSS.n37 0.00171365
R2684 VSS.n105 VSS.n39 0.00171365
R2685 VSS.n105 VSS.n41 0.00171365
R2686 VSS.n105 VSS.n43 0.00171365
R2687 VSS.n105 VSS.n58 0.00158368
R2688 VSS.n105 VSS.n65 0.00158368
R2689 VSS.n105 VSS.n72 0.00158368
R2690 VSS.n105 VSS.n78 0.00158368
R2691 VSS.n105 VSS.n85 0.00158368
R2692 VSS.n105 VSS.n91 0.00158368
R2693 VSS.n105 VSS.n98 0.00158368
R2694 VSS.n4 VSS.t170 68.6463
R2695 VSS.n4 VSS.n9 6.80938
R2696 VSS.n4 VSS.n0 1.24918
R2697 a_3747_216.n0 a_3747_216.t2 52.0388
R2698 a_3747_216.t0 a_3747_216.n0 35.4491
R2699 a_3747_216.n0 a_3747_216.t3 33.5891
R2700 a_3747_216.t1 a_3747_216.t0 5.61942
R2701 a_3171_216.n0 a_3171_216.t2 51.8377
R2702 a_3171_216.n0 a_3171_216.t3 33.3881
R2703 a_3171_216.t0 a_3171_216.n0 31.8923
R2704 a_3171_216.t1 a_3171_216.t0 5.61777
R2705 a_2595_216.n0 a_2595_216.t2 51.6367
R2706 a_2595_216.n0 a_2595_216.t3 33.187
R2707 a_2595_216.t0 a_2595_216.n0 27.993
R2708 a_2595_216.t1 a_2595_216.t0 5.73018
R2709 a_2019_216.t3 a_2019_216.t2 51.6139
R2710 a_2019_216.t0 a_2019_216.t3 24.5351
R2711 a_2019_216.t1 a_2019_216.t0 5.62052
R2712 a_3747_952.n0 a_3747_952.t2 38.0081
R2713 a_3747_952.n0 a_3747_952.t3 33.3957
R2714 a_3747_952.n1 a_3747_952.t4 33.3957
R2715 a_3747_952.n2 a_3747_952.t5 33.3957
R2716 a_3747_952.n3 a_3747_952.t6 33.3957
R2717 a_3747_952.n4 a_3747_952.t7 33.3957
R2718 a_3747_952.n5 a_3747_952.t8 33.3957
R2719 a_3747_952.n6 a_3747_952.t9 33.3957
R2720 a_3747_952.t0 a_3747_952.n6 23.2419
R2721 a_3747_952.t1 a_3747_952.t0 5.61942
R2722 a_3747_952.n6 a_3747_952.n5 4.61291
R2723 a_3747_952.n5 a_3747_952.n4 4.61291
R2724 a_3747_952.n4 a_3747_952.n3 4.61291
R2725 a_3747_952.n3 a_3747_952.n2 4.61291
R2726 a_3747_952.n2 a_3747_952.n1 4.61291
R2727 a_3747_952.n1 a_3747_952.n0 4.61291
R2728 a_3171_952.n0 a_3171_952.t2 37.8054
R2729 a_3171_952.n0 a_3171_952.t3 33.193
R2730 a_3171_952.n1 a_3171_952.t4 33.193
R2731 a_3171_952.n2 a_3171_952.t5 33.193
R2732 a_3171_952.n3 a_3171_952.t6 33.193
R2733 a_3171_952.n4 a_3171_952.t7 33.193
R2734 a_3171_952.n5 a_3171_952.t8 33.193
R2735 a_3171_952.n6 a_3171_952.t9 33.193
R2736 a_3171_952.t0 a_3171_952.n6 23.0313
R2737 a_3171_952.t1 a_3171_952.t0 5.61777
R2738 a_3171_952.n6 a_3171_952.n5 4.61291
R2739 a_3171_952.n5 a_3171_952.n4 4.61291
R2740 a_3171_952.n4 a_3171_952.n3 4.61291
R2741 a_3171_952.n3 a_3171_952.n2 4.61291
R2742 a_3171_952.n2 a_3171_952.n1 4.61291
R2743 a_3171_952.n1 a_3171_952.n0 4.61291
R2744 a_2595_952.n0 a_2595_952.t2 37.7691
R2745 a_2595_952.n0 a_2595_952.t3 33.1567
R2746 a_2595_952.n1 a_2595_952.t4 33.1567
R2747 a_2595_952.n2 a_2595_952.t5 33.1567
R2748 a_2595_952.n3 a_2595_952.t6 33.1567
R2749 a_2595_952.n4 a_2595_952.t7 33.1567
R2750 a_2595_952.n5 a_2595_952.t8 33.1567
R2751 a_2595_952.n6 a_2595_952.t9 33.1567
R2752 a_2595_952.t0 a_2595_952.n6 22.7941
R2753 a_2595_952.t1 a_2595_952.t0 5.65522
R2754 a_2595_952.n6 a_2595_952.n5 4.61291
R2755 a_2595_952.n5 a_2595_952.n4 4.61291
R2756 a_2595_952.n4 a_2595_952.n3 4.61291
R2757 a_2595_952.n3 a_2595_952.n2 4.61291
R2758 a_2595_952.n2 a_2595_952.n1 4.61291
R2759 a_2595_952.n1 a_2595_952.n0 4.61291
R2760 a_2019_952.n0 a_2019_952.t2 37.9701
R2761 a_2019_952.n0 a_2019_952.t3 33.3577
R2762 a_2019_952.n1 a_2019_952.t4 33.3577
R2763 a_2019_952.n2 a_2019_952.t5 33.3577
R2764 a_2019_952.n3 a_2019_952.t6 33.3577
R2765 a_2019_952.n4 a_2019_952.t7 33.3577
R2766 a_2019_952.t0 a_2019_952.t9 22.5945
R2767 a_2019_952.t1 a_2019_952.t0 5.62052
R2768 a_2019_952.t9 a_2019_952.t8 4.61291
R2769 a_2019_952.t8 a_2019_952.n4 4.61291
R2770 a_2019_952.n4 a_2019_952.n3 4.61291
R2771 a_2019_952.n3 a_2019_952.n2 4.61291
R2772 a_2019_952.n2 a_2019_952.n1 4.61291
R2773 a_2019_952.n1 a_2019_952.n0 4.61291
C544 MUX_OUT VSS 7.79401f
C545 MUX_SEL4 VSS 1.57386f
C546 DELAY_OUT_TAP0 VSS 0.44781f
C547 MUX_SEL3 VSS 1.0035f
C548 MUX_SEL2 VSS 4.18782f
C549 DELAY_OUT_TAP31 VSS 0.41949f
C550 DELAY_OUT_TAP30 VSS 0.43238f
C551 DELAY_OUT_TAP29 VSS 0.30856f
C552 DELAY_OUT_TAP28 VSS 0.43233f
C553 DELAY_OUT_TAP27 VSS 0.38455f
C554 DELAY_OUT_TAP26 VSS 0.43238f
C555 DELAY_OUT_TAP25 VSS 0.30856f
C556 DELAY_OUT_TAP24 VSS 0.43233f
C557 DELAY_OUT_TAP23 VSS 0.38455f
C558 DELAY_OUT_TAP22 VSS 0.43238f
C559 DELAY_OUT_TAP21 VSS 0.30856f
C560 DELAY_OUT_TAP20 VSS 0.43233f
C561 DELAY_OUT_TAP19 VSS 0.38455f
C562 DELAY_OUT_TAP18 VSS 0.43238f
C563 DELAY_OUT_TAP17 VSS 0.30374f
C564 DELAY_OUT_TAP16 VSS 0.42869f
C565 DELAY_OUT_TAP15 VSS 0.38342f
C566 DELAY_OUT_TAP14 VSS 0.43238f
C567 DELAY_OUT_TAP13 VSS 0.30856f
C568 DELAY_OUT_TAP12 VSS 0.43233f
C569 DELAY_OUT_TAP11 VSS 0.38455f
C570 DELAY_OUT_TAP10 VSS 0.43238f
C571 DELAY_OUT_TAP9 VSS 0.30856f
C572 DELAY_OUT_TAP8 VSS 0.43233f
C573 DELAY_OUT_TAP7 VSS 0.38455f
C574 DELAY_OUT_TAP6 VSS 0.43238f
C575 DELAY_OUT_TAP5 VSS 0.30856f
C576 DELAY_OUT_TAP4 VSS 0.43233f
C577 DELAY_OUT_TAP3 VSS 0.38455f
C578 DELAY_OUT_TAP2 VSS 0.43243f
C579 DELAY_OUT_TAP1 VSS 0.30956f
C580 MUX_SEL1 VSS 1.04474f
C581 MUX_SEL0 VSS 4.19516f
C582 VDD VSS 26.66029f
C583 a_26985_424# VSS 0.19097f ; **FLOATING
C584 a_23945_424# VSS 0.18682f ; **FLOATING
C585 a_20905_424# VSS 0.18533f ; **FLOATING
C586 a_17865_424# VSS 0.1805f ; **FLOATING
C587 a_16851_214# VSS 0.39062f ; **FLOATING
C588 a_16108_194# VSS 5.09478f ; **FLOATING
C589 a_15964_194# VSS 0.18389f ; **FLOATING
C590 a_15765_368# VSS 0.37143f ; **FLOATING
C591 a_14825_424# VSS 0.18268f ; **FLOATING
C592 a_11785_424# VSS 0.18268f ; **FLOATING
C593 a_8745_424# VSS 0.18268f ; **FLOATING
C594 a_5731_194# VSS 4.48871f ; **FLOATING
C595 a_5705_424# VSS 0.17977f ; **FLOATING
C596 a_3449_236# VSS 0.18976f ; **FLOATING
C597 a_2873_236# VSS 0.18555f ; **FLOATING
C598 a_2297_236# VSS 0.18559f ; **FLOATING
C599 a_1721_236# VSS 0.1759f ; **FLOATING
C600 a_1544_194# VSS 0.31269f ; **FLOATING
C601 a_1256_194# VSS 0.9846f ; **FLOATING
C602 a_27991_913# VSS 0.18706f ; **FLOATING
C603 a_27915_949# VSS 0.10926f ; **FLOATING
C604 a_27124_913# VSS 0.17878f ; **FLOATING
C605 a_27048_949# VSS 0.12122f ; **FLOATING
C606 a_26471_913# VSS 0.18175f ; **FLOATING
C607 a_26395_949# VSS 0.11073f ; **FLOATING
C608 a_25604_913# VSS 0.18087f ; **FLOATING
C609 a_25630_949# VSS 0.36789f ; **FLOATING
C610 a_25528_949# VSS 0.12433f ; **FLOATING
C611 a_24951_913# VSS 0.18335f ; **FLOATING
C612 a_24875_949# VSS 0.11016f ; **FLOATING
C613 a_24084_913# VSS 0.17878f ; **FLOATING
C614 a_24008_949# VSS 0.12122f ; **FLOATING
C615 a_23431_913# VSS 0.18175f ; **FLOATING
C616 a_23355_949# VSS 0.11073f ; **FLOATING
C617 a_22564_913# VSS 0.18087f ; **FLOATING
C618 a_22590_949# VSS 0.35849f ; **FLOATING
C619 a_22488_949# VSS 0.12433f ; **FLOATING
C620 a_21911_913# VSS 0.18335f ; **FLOATING
C621 a_21835_949# VSS 0.11016f ; **FLOATING
C622 a_21044_913# VSS 0.17878f ; **FLOATING
C623 a_20968_949# VSS 0.12122f ; **FLOATING
C624 a_20391_913# VSS 0.18175f ; **FLOATING
C625 a_20315_949# VSS 0.11073f ; **FLOATING
C626 a_19524_913# VSS 0.18087f ; **FLOATING
C627 a_19550_949# VSS 0.36002f ; **FLOATING
C628 a_19448_949# VSS 0.12433f ; **FLOATING
C629 a_18871_913# VSS 0.18335f ; **FLOATING
C630 a_18795_949# VSS 0.11016f ; **FLOATING
C631 a_18004_913# VSS 0.17878f ; **FLOATING
C632 a_17928_949# VSS 0.12122f ; **FLOATING
C633 a_17351_913# VSS 0.18022f ; **FLOATING
C634 a_17275_949# VSS 0.10926f ; **FLOATING
C635 a_16484_913# VSS 0.18023f ; **FLOATING
C636 a_16510_949# VSS 0.33744f ; **FLOATING
C637 a_16408_949# VSS 0.1229f ; **FLOATING
C638 a_15831_913# VSS 0.17846f ; **FLOATING
C639 a_15755_949# VSS 0.10926f ; **FLOATING
C640 a_14964_913# VSS 0.17878f ; **FLOATING
C641 a_14888_949# VSS 0.12122f ; **FLOATING
C642 a_14311_913# VSS 0.18175f ; **FLOATING
C643 a_14235_949# VSS 0.11073f ; **FLOATING
C644 a_13444_913# VSS 0.18087f ; **FLOATING
C645 a_13470_949# VSS 0.34828f ; **FLOATING
C646 a_13368_949# VSS 0.12433f ; **FLOATING
C647 a_12791_913# VSS 0.18335f ; **FLOATING
C648 a_12715_949# VSS 0.11016f ; **FLOATING
C649 a_11924_913# VSS 0.17878f ; **FLOATING
C650 a_11848_949# VSS 0.12122f ; **FLOATING
C651 a_11271_913# VSS 0.18175f ; **FLOATING
C652 a_11195_949# VSS 0.11073f ; **FLOATING
C653 a_10404_913# VSS 0.18087f ; **FLOATING
C654 a_10430_949# VSS 0.35462f ; **FLOATING
C655 a_10328_949# VSS 0.12433f ; **FLOATING
C656 a_9751_913# VSS 0.18335f ; **FLOATING
C657 a_9675_949# VSS 0.11016f ; **FLOATING
C658 a_8884_913# VSS 0.17878f ; **FLOATING
C659 a_8808_949# VSS 0.12122f ; **FLOATING
C660 a_8231_913# VSS 0.18175f ; **FLOATING
C661 a_8155_949# VSS 0.11073f ; **FLOATING
C662 a_7364_913# VSS 0.18087f ; **FLOATING
C663 a_7390_949# VSS 0.3543f ; **FLOATING
C664 a_7288_949# VSS 0.12433f ; **FLOATING
C665 a_6711_913# VSS 0.18335f ; **FLOATING
C666 a_6635_949# VSS 0.11016f ; **FLOATING
C667 a_5844_913# VSS 0.17878f ; **FLOATING
C668 a_5768_949# VSS 0.12122f ; **FLOATING
C669 a_5191_913# VSS 0.18022f ; **FLOATING
C670 a_5115_949# VSS 0.10926f ; **FLOATING
C671 a_4324_913# VSS 0.18023f ; **FLOATING
C672 a_4350_949# VSS 0.3288f ; **FLOATING
C673 a_4248_949# VSS 0.12443f ; **FLOATING
C674 a_27705_949# VSS 0.2535f ; **FLOATING
C675 a_26185_949# VSS 0.23529f ; **FLOATING
C676 a_24665_949# VSS 0.25486f ; **FLOATING
C677 a_23145_949# VSS 0.23529f ; **FLOATING
C678 a_21625_949# VSS 0.25486f ; **FLOATING
C679 a_20105_949# VSS 0.23529f ; **FLOATING
C680 a_18585_949# VSS 0.25486f ; **FLOATING
C681 a_17065_949# VSS 0.23439f ; **FLOATING
C682 a_15545_949# VSS 0.2535f ; **FLOATING
C683 a_14025_949# VSS 0.23529f ; **FLOATING
C684 a_12505_949# VSS 0.25486f ; **FLOATING
C685 a_10985_949# VSS 0.23529f ; **FLOATING
C686 a_9465_949# VSS 0.25486f ; **FLOATING
C687 a_7945_949# VSS 0.23529f ; **FLOATING
C688 a_6425_949# VSS 0.25486f ; **FLOATING
C689 a_4905_949# VSS 0.23602f ; **FLOATING
C690 a_4157_1218# VSS 0.34693f ; **FLOATING
C691 a_3449_1300# VSS 0.19203f ; **FLOATING
C692 a_2873_1300# VSS 0.18591f ; **FLOATING
C693 a_2297_1300# VSS 0.18559f ; **FLOATING
C694 a_1721_1300# VSS 0.1774f ; **FLOATING
C695 a_1544_949# VSS 0.31311f ; **FLOATING
C696 a_1256_949# VSS 0.98158f ; **FLOATING
C697 a_2019_952.t2 VSS 0.82935f ; **FLOATING
C698 a_2019_952.t3 VSS 0.62962f ; **FLOATING
C699 a_2019_952.n0 VSS 4.46549f ; **FLOATING
C700 a_2019_952.t4 VSS 0.62962f ; **FLOATING
C701 a_2019_952.n1 VSS 3.02103f ; **FLOATING
C702 a_2019_952.t5 VSS 0.62962f ; **FLOATING
C703 a_2019_952.n2 VSS 3.02103f ; **FLOATING
C704 a_2019_952.t6 VSS 0.62962f ; **FLOATING
C705 a_2019_952.n3 VSS 3.02103f ; **FLOATING
C706 a_2019_952.t7 VSS 0.62962f ; **FLOATING
C707 a_2019_952.n4 VSS 3.02103f ; **FLOATING
C708 a_2019_952.t8 VSS 3.65065f ; **FLOATING
C709 a_2019_952.t9 VSS 4.86312f ; **FLOATING
C710 a_2019_952.t0 VSS 0.95622f ; **FLOATING
C711 a_2019_952.t1 VSS 0.27179f ; **FLOATING
C712 a_2595_952.t2 VSS 1.36255f ; **FLOATING
C713 a_2595_952.t3 VSS 1.0176f ; **FLOATING
C714 a_2595_952.n0 VSS 7.73581f ; **FLOATING
C715 a_2595_952.t4 VSS 1.0176f ; **FLOATING
C716 a_2595_952.n1 VSS 5.25612f ; **FLOATING
C717 a_2595_952.t5 VSS 1.0176f ; **FLOATING
C718 a_2595_952.n2 VSS 5.25612f ; **FLOATING
C719 a_2595_952.t6 VSS 1.0176f ; **FLOATING
C720 a_2595_952.n3 VSS 5.25612f ; **FLOATING
C721 a_2595_952.t7 VSS 1.0176f ; **FLOATING
C722 a_2595_952.n4 VSS 5.25612f ; **FLOATING
C723 a_2595_952.t8 VSS 1.0176f ; **FLOATING
C724 a_2595_952.n5 VSS 5.25612f ; **FLOATING
C725 a_2595_952.t9 VSS 1.0176f ; **FLOATING
C726 a_2595_952.n6 VSS 7.56062f ; **FLOATING
C727 a_2595_952.t0 VSS 1.74545f ; **FLOATING
C728 a_2595_952.t1 VSS 0.48069f ; **FLOATING
C729 a_3171_952.t2 VSS 1.38836f ; **FLOATING
C730 a_3171_952.t3 VSS 1.04029f ; **FLOATING
C731 a_3171_952.n0 VSS 7.80069f ; **FLOATING
C732 a_3171_952.t4 VSS 1.04029f ; **FLOATING
C733 a_3171_952.n1 VSS 5.29585f ; **FLOATING
C734 a_3171_952.t5 VSS 1.04029f ; **FLOATING
C735 a_3171_952.n2 VSS 5.29585f ; **FLOATING
C736 a_3171_952.t6 VSS 1.04029f ; **FLOATING
C737 a_3171_952.n3 VSS 5.29585f ; **FLOATING
C738 a_3171_952.t7 VSS 1.04029f ; **FLOATING
C739 a_3171_952.n4 VSS 5.29585f ; **FLOATING
C740 a_3171_952.t8 VSS 1.04029f ; **FLOATING
C741 a_3171_952.n5 VSS 5.29585f ; **FLOATING
C742 a_3171_952.t9 VSS 1.04029f ; **FLOATING
C743 a_3171_952.n6 VSS 7.70533f ; **FLOATING
C744 a_3171_952.t0 VSS 1.7753f ; **FLOATING
C745 a_3171_952.t1 VSS 0.48221f ; **FLOATING
C746 a_3747_952.t2 VSS 1.01208f ; **FLOATING
C747 a_3747_952.t3 VSS 0.77051f ; **FLOATING
C748 a_3747_952.n0 VSS 5.39805f ; **FLOATING
C749 a_3747_952.t4 VSS 0.77051f ; **FLOATING
C750 a_3747_952.n1 VSS 3.64901f ; **FLOATING
C751 a_3747_952.t5 VSS 0.77051f ; **FLOATING
C752 a_3747_952.n2 VSS 3.64901f ; **FLOATING
C753 a_3747_952.t6 VSS 0.77051f ; **FLOATING
C754 a_3747_952.n3 VSS 3.64901f ; **FLOATING
C755 a_3747_952.t7 VSS 0.77051f ; **FLOATING
C756 a_3747_952.n4 VSS 3.64901f ; **FLOATING
C757 a_3747_952.t8 VSS 0.77051f ; **FLOATING
C758 a_3747_952.n5 VSS 3.64901f ; **FLOATING
C759 a_3747_952.t9 VSS 0.77051f ; **FLOATING
C760 a_3747_952.n6 VSS 5.41835f ; **FLOATING
C761 a_3747_952.t0 VSS 1.23824f ; **FLOATING
C762 a_3747_952.t1 VSS 0.32736f ; **FLOATING
C763 a_2019_216.t2 VSS 4.0703f ; **FLOATING
C764 a_2019_216.t3 VSS 21.905f ; **FLOATING
C765 a_2019_216.t0 VSS 1.98975f ; **FLOATING
C766 a_2019_216.t1 VSS 0.44677f ; **FLOATING
C767 a_2595_216.t0 VSS 3.28181f ; **FLOATING
C768 a_2595_216.t2 VSS 5.05908f ; **FLOATING
C769 a_2595_216.t3 VSS 1.21054f ; **FLOATING
C770 a_2595_216.n0 VSS 26.9608f ; **FLOATING
C771 a_2595_216.t1 VSS 0.49745f ; **FLOATING
C772 a_3171_216.t2 VSS 5.10959f ; **FLOATING
C773 a_3171_216.t3 VSS 1.22577f ; **FLOATING
C774 a_3171_216.n0 VSS 30.2016f ; **FLOATING
C775 a_3171_216.t0 VSS 4.66587f ; **FLOATING
C776 a_3171_216.t1 VSS 0.50316f ; **FLOATING
C777 a_3747_216.t2 VSS 3.8862f ; **FLOATING
C778 a_3747_216.t3 VSS 0.93537f ; **FLOATING
C779 a_3747_216.n0 VSS 24.9968f ; **FLOATING
C780 a_3747_216.t0 VSS 4.63641f ; **FLOATING
C781 a_3747_216.t1 VSS 0.3838f ; **FLOATING
C782 VDD.n0 VSS 2.46252f ; **FLOATING
C783 VDD.t0 VSS 64.3911f ; **FLOATING
C784 VDD.n4 VSS 0.02586f ; **FLOATING
C785 VDD.n7 VSS 1.83844f ; **FLOATING
C786 VDD.n9 VSS 1.14923f ; **FLOATING
C787 VDD.n11 VSS 0.7307f ; **FLOATING
C788 VDD.n12 VSS 1.10721f ; **FLOATING
C789 VDD.n13 VSS 1.29479f ; **FLOATING
C790 VDD.n14 VSS 0.566f ; **FLOATING
C791 VDD.n15 VSS 0.30692f ; **FLOATING
C792 VDD.n16 VSS 0.16003f ; **FLOATING
C793 VDD.n17 VSS 0.4532f ; **FLOATING
C794 VDD.n18 VSS 1.34498f ; **FLOATING
C795 VDD.n19 VSS 0.02586f ; **FLOATING
C796 VDD.n20 VSS 1.11746f ; **FLOATING
C797 VDD.n23 VSS 0.02586f ; **FLOATING
C798 VDD.n27 VSS 0.51318f ; **FLOATING
C799 VDD.n47 VSS 0.01895f ; **FLOATING
C800 VDD.n48 VSS 0.02857f ; **FLOATING
C801 VDD.n49 VSS 0.01895f ; **FLOATING
C802 VDD.n58 VSS 0.82409f ; **FLOATING
C803 VDD.n59 VSS 0.01594f ; **FLOATING
C804 VDD.n60 VSS 0.02314f ; **FLOATING
C805 VDD.n67 VSS 0.02275f ; **FLOATING
C806 VDD.n68 VSS 0.02275f ; **FLOATING
C807 VDD.n69 VSS 0.06504f ; **FLOATING
C808 VDD.n70 VSS 0.10012f ; **FLOATING
C809 VDD.n73 VSS 0.02314f ; **FLOATING
C810 VDD.n76 VSS 0.03631f ; **FLOATING
C811 VDD.n79 VSS 0.02314f ; **FLOATING
C812 VDD.n80 VSS 0.02314f ; **FLOATING
C813 VDD.n81 VSS 0.02275f ; **FLOATING
C814 VDD.n82 VSS 0.02314f ; **FLOATING
C815 VDD.n83 VSS 0.02314f ; **FLOATING
C816 VDD.n84 VSS 0.02275f ; **FLOATING
C817 VDD.n85 VSS 0.02314f ; **FLOATING
C818 VDD.n86 VSS 0.02314f ; **FLOATING
C819 VDD.n88 VSS 0.02314f ; **FLOATING
C820 VDD.n90 VSS 0.02275f ; **FLOATING
C821 VDD.n92 VSS 0.02314f ; **FLOATING
C822 VDD.n94 VSS 0.02314f ; **FLOATING
C823 VDD.n97 VSS 0.02314f ; **FLOATING
C824 VDD.n98 VSS 0.02275f ; **FLOATING
C825 VDD.n99 VSS 0.02314f ; **FLOATING
C826 VDD.n100 VSS 0.02314f ; **FLOATING
C827 VDD.n101 VSS 0.02275f ; **FLOATING
C828 VDD.n103 VSS 0.02314f ; **FLOATING
C829 VDD.n109 VSS 0.7093f ; **FLOATING
C830 VDD.n110 VSS 0.02314f ; **FLOATING
C831 VDD.t134 VSS 0.0414f ; **FLOATING
C832 VDD.t170 VSS 0.0414f ; **FLOATING
C833 VDD.t127 VSS 0.0414f ; **FLOATING
C834 VDD.t76 VSS 0.0414f ; **FLOATING
C835 VDD.t130 VSS 0.0414f ; **FLOATING
C836 VDD.t57 VSS 0.0414f ; **FLOATING
C837 VDD.t46 VSS 0.04154f ; **FLOATING
C838 VDD.t122 VSS 0.05434f ; **FLOATING
C839 VDD.t27 VSS 0.03717f ; **FLOATING
C840 VDD.t40 VSS 0.0414f ; **FLOATING
C841 VDD.t126 VSS 0.0414f ; **FLOATING
C842 VDD.t110 VSS 0.05434f ; **FLOATING
C843 VDD.t179 VSS 0.0414f ; **FLOATING
C844 VDD.t158 VSS 0.0414f ; **FLOATING
C845 VDD.n111 VSS 0.02314f ; **FLOATING
C846 VDD.n112 VSS 0.02314f ; **FLOATING
C847 VDD.t91 VSS 0.0414f ; **FLOATING
C848 VDD.t53 VSS 0.03717f ; **FLOATING
C849 VDD.t87 VSS 0.05453f ; **FLOATING
C850 VDD.t54 VSS 0.03991f ; **FLOATING
C851 VDD.t189 VSS 0.1373f ; **FLOATING
C852 VDD.n113 VSS 0.02275f ; **FLOATING
C853 VDD.n114 VSS 0.02314f ; **FLOATING
C854 VDD.t177 VSS 0.03717f ; **FLOATING
C855 VDD.n115 VSS 0.02314f ; **FLOATING
C856 VDD.t26 VSS 0.03991f ; **FLOATING
C857 VDD.t190 VSS 0.1373f ; **FLOATING
C858 VDD.t181 VSS 0.0414f ; **FLOATING
C859 VDD.t31 VSS 0.03717f ; **FLOATING
C860 VDD.n116 VSS 0.02314f ; **FLOATING
C861 VDD.t37 VSS 0.03717f ; **FLOATING
C862 VDD.t167 VSS 0.0414f ; **FLOATING
C863 VDD.t36 VSS 0.03991f ; **FLOATING
C864 VDD.t191 VSS 0.1373f ; **FLOATING
C865 VDD.t165 VSS 0.05434f ; **FLOATING
C866 VDD.n117 VSS 0.02314f ; **FLOATING
C867 VDD.t38 VSS 0.03717f ; **FLOATING
C868 VDD.t67 VSS 0.0414f ; **FLOATING
C869 VDD.t23 VSS 0.0414f ; **FLOATING
C870 VDD.n118 VSS 0.02314f ; **FLOATING
C871 VDD.t63 VSS 0.0414f ; **FLOATING
C872 VDD.t180 VSS 0.0414f ; **FLOATING
C873 VDD.t109 VSS 0.03717f ; **FLOATING
C874 VDD.n119 VSS 0.02314f ; **FLOATING
C875 VDD.n120 VSS 0.02314f ; **FLOATING
C876 VDD.t107 VSS 0.05453f ; **FLOATING
C877 VDD.t24 VSS 0.03991f ; **FLOATING
C878 VDD.t192 VSS 0.1373f ; **FLOATING
C879 VDD.t25 VSS 0.03717f ; **FLOATING
C880 VDD.t29 VSS 0.03717f ; **FLOATING
C881 VDD.n121 VSS 0.02314f ; **FLOATING
C882 VDD.t30 VSS 0.03991f ; **FLOATING
C883 VDD.t193 VSS 0.1373f ; **FLOATING
C884 VDD.t175 VSS 0.0414f ; **FLOATING
C885 VDD.t172 VSS 0.0414f ; **FLOATING
C886 VDD.t103 VSS 0.03717f ; **FLOATING
C887 VDD.n122 VSS 0.02314f ; **FLOATING
C888 VDD.t21 VSS 0.03717f ; **FLOATING
C889 VDD.t28 VSS 0.0414f ; **FLOATING
C890 VDD.t14 VSS 0.03991f ; **FLOATING
C891 VDD.t194 VSS 0.1373f ; **FLOATING
C892 VDD.t22 VSS 0.05434f ; **FLOATING
C893 VDD.n123 VSS 0.02314f ; **FLOATING
C894 VDD.t13 VSS 0.03717f ; **FLOATING
C895 VDD.n124 VSS 0.02314f ; **FLOATING
C896 VDD.n125 VSS 0.02314f ; **FLOATING
C897 VDD.t94 VSS 0.0414f ; **FLOATING
C898 VDD.t171 VSS 0.0414f ; **FLOATING
C899 VDD.n126 VSS 0.02314f ; **FLOATING
C900 VDD.t79 VSS 0.0414f ; **FLOATING
C901 VDD.t9 VSS 0.0414f ; **FLOATING
C902 VDD.n127 VSS 0.02314f ; **FLOATING
C903 VDD.n128 VSS 0.02314f ; **FLOATING
C904 VDD.n129 VSS 0.02314f ; **FLOATING
C905 VDD.n130 VSS 0.02314f ; **FLOATING
C906 VDD.n131 VSS 0.03505f ; **FLOATING
C907 VDD.n132 VSS 0.02314f ; **FLOATING
C908 VDD.t125 VSS 0.03717f ; **FLOATING
C909 VDD.t77 VSS 0.05453f ; **FLOATING
C910 VDD.t15 VSS 0.03991f ; **FLOATING
C911 VDD.t195 VSS 0.1373f ; **FLOATING
C912 VDD.n133 VSS 0.02314f ; **FLOATING
C913 VDD.t153 VSS 0.03717f ; **FLOATING
C914 VDD.t16 VSS 0.03717f ; **FLOATING
C915 VDD.t10 VSS 0.0414f ; **FLOATING
C916 VDD.t92 VSS 0.03991f ; **FLOATING
C917 VDD.t196 VSS 0.1373f ; **FLOATING
C918 VDD.n134 VSS 0.02314f ; **FLOATING
C919 VDD.t93 VSS 0.03717f ; **FLOATING
C920 VDD.t160 VSS 0.0414f ; **FLOATING
C921 VDD.t111 VSS 0.03717f ; **FLOATING
C922 VDD.t106 VSS 0.0414f ; **FLOATING
C923 VDD.n135 VSS 0.02314f ; **FLOATING
C924 VDD.t61 VSS 0.03991f ; **FLOATING
C925 VDD.t197 VSS 0.1373f ; **FLOATING
C926 VDD.t89 VSS 0.05434f ; **FLOATING
C927 VDD.n136 VSS 0.02314f ; **FLOATING
C928 VDD.t60 VSS 0.03717f ; **FLOATING
C929 VDD.n137 VSS 0.02314f ; **FLOATING
C930 VDD.n138 VSS 0.02314f ; **FLOATING
C931 VDD.t42 VSS 0.0414f ; **FLOATING
C932 VDD.t88 VSS 0.0414f ; **FLOATING
C933 VDD.n139 VSS 0.02314f ; **FLOATING
C934 VDD.t161 VSS 0.0414f ; **FLOATING
C935 VDD.t12 VSS 0.0414f ; **FLOATING
C936 VDD.n140 VSS 0.02314f ; **FLOATING
C937 VDD.n141 VSS 0.02314f ; **FLOATING
C938 VDD.t20 VSS 0.07762f ; **FLOATING
C939 VDD.n142 VSS 0.02314f ; **FLOATING
C940 VDD.t117 VSS 0.05434f ; **FLOATING
C941 VDD.n143 VSS 0.02314f ; **FLOATING
C942 VDD.t19 VSS 0.04396f ; **FLOATING
C943 VDD.n144 VSS 0.02314f ; **FLOATING
C944 VDD.n145 VSS 0.02314f ; **FLOATING
C945 VDD.t56 VSS 0.0414f ; **FLOATING
C946 VDD.n146 VSS 0.02314f ; **FLOATING
C947 VDD.n147 VSS 0.0201f ; **FLOATING
C948 VDD.t174 VSS 0.0414f ; **FLOATING
C949 VDD.t146 VSS 0.0414f ; **FLOATING
C950 VDD.t45 VSS 0.0414f ; **FLOATING
C951 VDD.n148 VSS 0.02314f ; **FLOATING
C952 VDD.n149 VSS 0.02314f ; **FLOATING
C953 VDD.n150 VSS 0.02314f ; **FLOATING
C954 VDD.t118 VSS 0.05434f ; **FLOATING
C955 VDD.n151 VSS 0.02314f ; **FLOATING
C956 VDD.n152 VSS 0.02314f ; **FLOATING
C957 VDD.n153 VSS 0.02314f ; **FLOATING
C958 VDD.t11 VSS 0.0414f ; **FLOATING
C959 VDD.t138 VSS 0.0414f ; **FLOATING
C960 VDD.n154 VSS 0.02314f ; **FLOATING
C961 VDD.n155 VSS 0.02619f ; **FLOATING
C962 VDD.t162 VSS 0.0414f ; **FLOATING
C963 VDD.t51 VSS 0.0414f ; **FLOATING
C964 VDD.n156 VSS 0.02314f ; **FLOATING
C965 VDD.n157 VSS 0.02314f ; **FLOATING
C966 VDD.n158 VSS 0.02314f ; **FLOATING
C967 VDD.n159 VSS 0.02314f ; **FLOATING
C968 VDD.n160 VSS 0.02314f ; **FLOATING
C969 VDD.n161 VSS 0.03505f ; **FLOATING
C970 VDD.n162 VSS 0.03496f ; **FLOATING
C971 VDD.n163 VSS 0.02314f ; **FLOATING
C972 VDD.n164 VSS 0.02314f ; **FLOATING
C973 VDD.n165 VSS 0.02314f ; **FLOATING
C974 VDD.n166 VSS 0.02314f ; **FLOATING
C975 VDD.n167 VSS 0.02314f ; **FLOATING
C976 VDD.n168 VSS 0.02314f ; **FLOATING
C977 VDD.n169 VSS 0.02314f ; **FLOATING
C978 VDD.n170 VSS 0.03472f ; **FLOATING
C979 VDD.n171 VSS 0.03508f ; **FLOATING
C980 VDD.n172 VSS 0.02314f ; **FLOATING
C981 VDD.n173 VSS 0.02314f ; **FLOATING
C982 VDD.n174 VSS 0.02314f ; **FLOATING
C983 VDD.n175 VSS 0.02314f ; **FLOATING
C984 VDD.n176 VSS 0.02314f ; **FLOATING
C985 VDD.n177 VSS 0.02314f ; **FLOATING
C986 VDD.n178 VSS 0.02314f ; **FLOATING
C987 VDD.n179 VSS 0.03472f ; **FLOATING
C988 VDD.n180 VSS 0.02314f ; **FLOATING
C989 VDD.t6 VSS 0.03717f ; **FLOATING
C990 VDD.t90 VSS 0.05453f ; **FLOATING
C991 VDD.t7 VSS 0.03991f ; **FLOATING
C992 VDD.t198 VSS 0.1373f ; **FLOATING
C993 VDD.n181 VSS 0.02314f ; **FLOATING
C994 VDD.t121 VSS 0.03717f ; **FLOATING
C995 VDD.t50 VSS 0.03717f ; **FLOATING
C996 VDD.t62 VSS 0.0414f ; **FLOATING
C997 VDD.t104 VSS 0.03991f ; **FLOATING
C998 VDD.t199 VSS 0.1373f ; **FLOATING
C999 VDD.n182 VSS 0.02314f ; **FLOATING
C1000 VDD.t105 VSS 0.03717f ; **FLOATING
C1001 VDD.t141 VSS 0.0414f ; **FLOATING
C1002 VDD.t1 VSS 0.03717f ; **FLOATING
C1003 VDD.t8 VSS 0.0414f ; **FLOATING
C1004 VDD.n183 VSS 0.02314f ; **FLOATING
C1005 VDD.t2 VSS 0.03991f ; **FLOATING
C1006 VDD.t200 VSS 0.1373f ; **FLOATING
C1007 VDD.t80 VSS 0.05434f ; **FLOATING
C1008 VDD.n184 VSS 0.02275f ; **FLOATING
C1009 VDD.t99 VSS 0.03717f ; **FLOATING
C1010 VDD.n185 VSS 0.02275f ; **FLOATING
C1011 VDD.n186 VSS 0.02275f ; **FLOATING
C1012 VDD.t70 VSS 0.0414f ; **FLOATING
C1013 VDD.t112 VSS 0.0414f ; **FLOATING
C1014 VDD.n187 VSS 0.02275f ; **FLOATING
C1015 VDD.n188 VSS 0.02574f ; **FLOATING
C1016 VDD.t137 VSS 0.0414f ; **FLOATING
C1017 VDD.t98 VSS 0.0414f ; **FLOATING
C1018 VDD.n189 VSS 0.02314f ; **FLOATING
C1019 VDD.n190 VSS 0.02314f ; **FLOATING
C1020 VDD.n191 VSS 0.02314f ; **FLOATING
C1021 VDD.n192 VSS 0.02314f ; **FLOATING
C1022 VDD.n193 VSS 0.02314f ; **FLOATING
C1023 VDD.n194 VSS 0.03472f ; **FLOATING
C1024 VDD.n195 VSS 0.02314f ; **FLOATING
C1025 VDD.t95 VSS 0.03717f ; **FLOATING
C1026 VDD.t78 VSS 0.05453f ; **FLOATING
C1027 VDD.t96 VSS 0.03991f ; **FLOATING
C1028 VDD.t201 VSS 0.1373f ; **FLOATING
C1029 VDD.n196 VSS 0.02314f ; **FLOATING
C1030 VDD.t43 VSS 0.03717f ; **FLOATING
C1031 VDD.t101 VSS 0.03717f ; **FLOATING
C1032 VDD.t178 VSS 0.0414f ; **FLOATING
C1033 VDD.t44 VSS 0.03991f ; **FLOATING
C1034 VDD.t202 VSS 0.1373f ; **FLOATING
C1035 VDD.n197 VSS 0.02314f ; **FLOATING
C1036 VDD.t69 VSS 0.03717f ; **FLOATING
C1037 VDD.t142 VSS 0.0414f ; **FLOATING
C1038 VDD.t188 VSS 0.03717f ; **FLOATING
C1039 VDD.t97 VSS 0.0414f ; **FLOATING
C1040 VDD.n198 VSS 0.02314f ; **FLOATING
C1041 VDD.t35 VSS 0.03991f ; **FLOATING
C1042 VDD.t203 VSS 0.1373f ; **FLOATING
C1043 VDD.t157 VSS 0.05434f ; **FLOATING
C1044 VDD.n199 VSS 0.02314f ; **FLOATING
C1045 VDD.t34 VSS 0.03717f ; **FLOATING
C1046 VDD.n200 VSS 0.02314f ; **FLOATING
C1047 VDD.n201 VSS 0.02314f ; **FLOATING
C1048 VDD.t108 VSS 0.0414f ; **FLOATING
C1049 VDD.t41 VSS 0.0414f ; **FLOATING
C1050 VDD.n202 VSS 0.02314f ; **FLOATING
C1051 VDD.t159 VSS 0.0414f ; **FLOATING
C1052 VDD.t52 VSS 0.0414f ; **FLOATING
C1053 VDD.n203 VSS 0.02314f ; **FLOATING
C1054 VDD.n204 VSS 0.02314f ; **FLOATING
C1055 VDD.n205 VSS 0.02314f ; **FLOATING
C1056 VDD.n206 VSS 0.02314f ; **FLOATING
C1057 VDD.n207 VSS 0.02314f ; **FLOATING
C1058 VDD.n208 VSS 0.03505f ; **FLOATING
C1059 VDD.n209 VSS 0.02314f ; **FLOATING
C1060 VDD.t32 VSS 0.03717f ; **FLOATING
C1061 VDD.t132 VSS 0.05453f ; **FLOATING
C1062 VDD.t33 VSS 0.03991f ; **FLOATING
C1063 VDD.t204 VSS 0.1373f ; **FLOATING
C1064 VDD.n210 VSS 0.02314f ; **FLOATING
C1065 VDD.t74 VSS 0.03717f ; **FLOATING
C1066 VDD.t186 VSS 0.03717f ; **FLOATING
C1067 VDD.t71 VSS 0.0414f ; **FLOATING
C1068 VDD.t47 VSS 0.03991f ; **FLOATING
C1069 VDD.t205 VSS 0.1373f ; **FLOATING
C1070 VDD.n211 VSS 0.02314f ; **FLOATING
C1071 VDD.t48 VSS 0.03717f ; **FLOATING
C1072 VDD.t123 VSS 0.0414f ; **FLOATING
C1073 VDD.t4 VSS 0.03717f ; **FLOATING
C1074 VDD.t55 VSS 0.0414f ; **FLOATING
C1075 VDD.n212 VSS 0.02314f ; **FLOATING
C1076 VDD.t176 VSS 0.03717f ; **FLOATING
C1077 VDD.n213 VSS 0.02314f ; **FLOATING
C1078 VDD.n214 VSS 0.02314f ; **FLOATING
C1079 VDD.t184 VSS 0.0414f ; **FLOATING
C1080 VDD.t64 VSS 0.0414f ; **FLOATING
C1081 VDD.n215 VSS 0.02619f ; **FLOATING
C1082 VDD.n216 VSS 0.02314f ; **FLOATING
C1083 VDD.t113 VSS 0.05434f ; **FLOATING
C1084 VDD.n217 VSS 0.02314f ; **FLOATING
C1085 VDD.n218 VSS 0.02314f ; **FLOATING
C1086 VDD.t75 VSS 0.0414f ; **FLOATING
C1087 VDD.n219 VSS 0.02314f ; **FLOATING
C1088 VDD.n220 VSS 0.02314f ; **FLOATING
C1089 VDD.t114 VSS 0.04086f ; **FLOATING
C1090 VDD.t17 VSS 0.04086f ; **FLOATING
C1091 VDD.t133 VSS 0.03057f ; **FLOATING
C1092 VDD.t168 VSS 0.03057f ; **FLOATING
C1093 VDD.n221 VSS 0.02314f ; **FLOATING
C1094 VDD.n222 VSS 0.02314f ; **FLOATING
C1095 VDD.t140 VSS 0.04614f ; **FLOATING
C1096 VDD.t84 VSS 0.04614f ; **FLOATING
C1097 VDD.t139 VSS 0.04086f ; **FLOATING
C1098 VDD.t81 VSS 0.04086f ; **FLOATING
C1099 VDD.t129 VSS 0.03057f ; **FLOATING
C1100 VDD.t58 VSS 0.03057f ; **FLOATING
C1101 VDD.t150 VSS 0.04614f ; **FLOATING
C1102 VDD.t66 VSS 0.04614f ; **FLOATING
C1103 VDD.n223 VSS 0.02314f ; **FLOATING
C1104 VDD.n224 VSS 0.02314f ; **FLOATING
C1105 VDD.t143 VSS 0.04086f ; **FLOATING
C1106 VDD.t65 VSS 0.04086f ; **FLOATING
C1107 VDD.t135 VSS 0.03057f ; **FLOATING
C1108 VDD.t169 VSS 0.03057f ; **FLOATING
C1109 VDD.t156 VSS 0.04614f ; **FLOATING
C1110 VDD.t86 VSS 0.04614f ; **FLOATING
C1111 VDD.n225 VSS 0.02314f ; **FLOATING
C1112 VDD.n226 VSS 0.02314f ; **FLOATING
C1113 VDD.t144 VSS 0.04086f ; **FLOATING
C1114 VDD.t72 VSS 0.04086f ; **FLOATING
C1115 VDD.t148 VSS 0.03057f ; **FLOATING
C1116 VDD.t82 VSS 0.03057f ; **FLOATING
C1117 VDD.n227 VSS 0.02314f ; **FLOATING
C1118 VDD.n228 VSS 0.02314f ; **FLOATING
C1119 VDD.n229 VSS 0.02314f ; **FLOATING
C1120 VDD.n230 VSS 0.02314f ; **FLOATING
C1121 VDD.n231 VSS 0.02314f ; **FLOATING
C1122 VDD.n232 VSS 0.02314f ; **FLOATING
C1123 VDD.n233 VSS 0.02314f ; **FLOATING
C1124 VDD.n234 VSS 0.02314f ; **FLOATING
C1125 VDD.n235 VSS 0.02314f ; **FLOATING
C1126 VDD.n236 VSS 0.02314f ; **FLOATING
C1127 VDD.n237 VSS 0.02314f ; **FLOATING
C1128 VDD.n238 VSS 0.02314f ; **FLOATING
C1129 VDD.n239 VSS 0.02314f ; **FLOATING
C1130 VDD.n240 VSS 0.02314f ; **FLOATING
C1131 VDD.n241 VSS 0.02314f ; **FLOATING
C1132 VDD.n242 VSS 0.02314f ; **FLOATING
C1133 VDD.n243 VSS 0.02314f ; **FLOATING
C1134 VDD.n244 VSS 0.02314f ; **FLOATING
C1135 VDD.n245 VSS 0.02314f ; **FLOATING
C1136 VDD.n246 VSS 0.02314f ; **FLOATING
C1137 VDD.n247 VSS 0.02314f ; **FLOATING
C1138 VDD.n248 VSS 0.02314f ; **FLOATING
C1139 VDD.n249 VSS 0.02314f ; **FLOATING
C1140 VDD.n250 VSS 0.02314f ; **FLOATING
C1141 VDD.t115 VSS 0.04614f ; **FLOATING
C1142 VDD.t18 VSS 0.04614f ; **FLOATING
C1143 VDD.n251 VSS 0.03015f ; **FLOATING
C1144 VDD.n252 VSS 0.04629f ; **FLOATING
C1145 VDD.n253 VSS 0.0201f ; **FLOATING
C1146 VDD.n254 VSS 0.04629f ; **FLOATING
C1147 VDD.n255 VSS 0.02314f ; **FLOATING
C1148 VDD.n256 VSS 0.02314f ; **FLOATING
C1149 VDD.n257 VSS 0.02314f ; **FLOATING
C1150 VDD.n258 VSS 0.02314f ; **FLOATING
C1151 VDD.n259 VSS 0.02314f ; **FLOATING
C1152 VDD.n260 VSS 0.02314f ; **FLOATING
C1153 VDD.n261 VSS 0.02314f ; **FLOATING
C1154 VDD.n262 VSS 0.02314f ; **FLOATING
C1155 VDD.n263 VSS 0.02314f ; **FLOATING
C1156 VDD.n264 VSS 0.02314f ; **FLOATING
C1157 VDD.t3 VSS 0.0414f ; **FLOATING
C1158 VDD.n265 VSS 0.03496f ; **FLOATING
C1159 VDD.n266 VSS 0.03472f ; **FLOATING
C1160 VDD.n267 VSS 0.02314f ; **FLOATING
C1161 VDD.n268 VSS 0.02314f ; **FLOATING
C1162 VDD.n269 VSS 0.02314f ; **FLOATING
C1163 VDD.n270 VSS 0.02314f ; **FLOATING
C1164 VDD.n271 VSS 0.02314f ; **FLOATING
C1165 VDD.n272 VSS 0.02314f ; **FLOATING
C1166 VDD.n273 VSS 0.02314f ; **FLOATING
C1167 VDD.n274 VSS 0.02314f ; **FLOATING
C1168 VDD.t5 VSS 0.03991f ; **FLOATING
C1169 VDD.t206 VSS 0.1373f ; **FLOATING
C1170 VDD.n275 VSS 0.02314f ; **FLOATING
C1171 VDD.n276 VSS 0.02314f ; **FLOATING
C1172 VDD.n277 VSS 0.02314f ; **FLOATING
C1173 VDD.n278 VSS 0.02314f ; **FLOATING
C1174 VDD.n279 VSS 0.02314f ; **FLOATING
C1175 VDD.n280 VSS 0.02314f ; **FLOATING
C1176 VDD.n281 VSS 0.02314f ; **FLOATING
C1177 VDD.n282 VSS 0.02314f ; **FLOATING
C1178 VDD.n283 VSS 0.02314f ; **FLOATING
C1179 VDD.n284 VSS 0.02314f ; **FLOATING
C1180 VDD.n285 VSS 0.02314f ; **FLOATING
C1181 VDD.n286 VSS 0.02314f ; **FLOATING
C1182 VDD.n287 VSS 0.02314f ; **FLOATING
C1183 VDD.n288 VSS 0.02314f ; **FLOATING
C1184 VDD.n289 VSS 0.02314f ; **FLOATING
C1185 VDD.n290 VSS 0.02314f ; **FLOATING
C1186 VDD.n291 VSS 0.02314f ; **FLOATING
C1187 VDD.n292 VSS 0.03472f ; **FLOATING
C1188 VDD.n293 VSS 0.01919f ; **FLOATING
C1189 VDD.n294 VSS 0.02314f ; **FLOATING
C1190 VDD.n295 VSS 0.02314f ; **FLOATING
C1191 VDD.n296 VSS 0.02314f ; **FLOATING
C1192 VDD.n297 VSS 0.02314f ; **FLOATING
C1193 VDD.n298 VSS 0.02314f ; **FLOATING
C1194 VDD.n299 VSS 0.02314f ; **FLOATING
C1195 VDD.n300 VSS 0.02314f ; **FLOATING
C1196 VDD.n301 VSS 0.02314f ; **FLOATING
C1197 VDD.n302 VSS 0.02314f ; **FLOATING
C1198 VDD.n303 VSS 0.02314f ; **FLOATING
C1199 VDD.n304 VSS 0.02314f ; **FLOATING
C1200 VDD.n305 VSS 0.02314f ; **FLOATING
C1201 VDD.n306 VSS 0.02314f ; **FLOATING
C1202 VDD.n307 VSS 0.02314f ; **FLOATING
C1203 VDD.n308 VSS 0.02314f ; **FLOATING
C1204 VDD.n309 VSS 0.02314f ; **FLOATING
C1205 VDD.n310 VSS 0.02314f ; **FLOATING
C1206 VDD.n311 VSS 0.03472f ; **FLOATING
C1207 VDD.n312 VSS 0.01919f ; **FLOATING
C1208 VDD.n313 VSS 0.02275f ; **FLOATING
C1209 VDD.n314 VSS 0.02275f ; **FLOATING
C1210 VDD.n315 VSS 0.02275f ; **FLOATING
C1211 VDD.n316 VSS 0.02314f ; **FLOATING
C1212 VDD.n317 VSS 0.02314f ; **FLOATING
C1213 VDD.n318 VSS 0.02314f ; **FLOATING
C1214 VDD.n319 VSS 0.02275f ; **FLOATING
C1215 VDD.n320 VSS 0.02275f ; **FLOATING
C1216 VDD.n321 VSS 0.02275f ; **FLOATING
C1217 VDD.n322 VSS 0.02314f ; **FLOATING
C1218 VDD.n323 VSS 0.02314f ; **FLOATING
C1219 VDD.n324 VSS 0.02314f ; **FLOATING
C1220 VDD.n325 VSS 0.02275f ; **FLOATING
C1221 VDD.n326 VSS 0.02275f ; **FLOATING
C1222 VDD.n327 VSS 0.02275f ; **FLOATING
C1223 VDD.n328 VSS 0.02314f ; **FLOATING
C1224 VDD.n329 VSS 0.02314f ; **FLOATING
C1225 VDD.n330 VSS 0.03472f ; **FLOATING
C1226 VDD.n331 VSS 0.01886f ; **FLOATING
C1227 VDD.n332 VSS 0.02314f ; **FLOATING
C1228 VDD.n333 VSS 0.02314f ; **FLOATING
C1229 VDD.n334 VSS 0.02314f ; **FLOATING
C1230 VDD.n335 VSS 0.02314f ; **FLOATING
C1231 VDD.n336 VSS 0.02314f ; **FLOATING
C1232 VDD.n337 VSS 0.02314f ; **FLOATING
C1233 VDD.n338 VSS 0.02314f ; **FLOATING
C1234 VDD.n339 VSS 0.02314f ; **FLOATING
C1235 VDD.n340 VSS 0.02314f ; **FLOATING
C1236 VDD.n341 VSS 0.02314f ; **FLOATING
C1237 VDD.n342 VSS 0.02314f ; **FLOATING
C1238 VDD.n343 VSS 0.02314f ; **FLOATING
C1239 VDD.n344 VSS 0.02314f ; **FLOATING
C1240 VDD.n345 VSS 0.02314f ; **FLOATING
C1241 VDD.n346 VSS 0.02314f ; **FLOATING
C1242 VDD.n347 VSS 0.02314f ; **FLOATING
C1243 VDD.n348 VSS 0.02314f ; **FLOATING
C1244 VDD.n349 VSS 0.03472f ; **FLOATING
C1245 VDD.n350 VSS 0.01919f ; **FLOATING
C1246 VDD.n351 VSS 0.02314f ; **FLOATING
C1247 VDD.n352 VSS 0.02314f ; **FLOATING
C1248 VDD.n353 VSS 0.02314f ; **FLOATING
C1249 VDD.n354 VSS 0.02314f ; **FLOATING
C1250 VDD.n355 VSS 0.02314f ; **FLOATING
C1251 VDD.n356 VSS 0.02314f ; **FLOATING
C1252 VDD.n357 VSS 0.02314f ; **FLOATING
C1253 VDD.n358 VSS 0.02314f ; **FLOATING
C1254 VDD.n359 VSS 0.02314f ; **FLOATING
C1255 VDD.n360 VSS 0.02314f ; **FLOATING
C1256 VDD.n361 VSS 0.02314f ; **FLOATING
C1257 VDD.n362 VSS 0.02314f ; **FLOATING
C1258 VDD.n363 VSS 0.02314f ; **FLOATING
C1259 VDD.n364 VSS 0.02314f ; **FLOATING
C1260 VDD.n365 VSS 0.02314f ; **FLOATING
C1261 VDD.n366 VSS 0.02314f ; **FLOATING
C1262 VDD.n367 VSS 0.02314f ; **FLOATING
C1263 VDD.n368 VSS 0.02314f ; **FLOATING
C1264 VDD.n369 VSS 0.01919f ; **FLOATING
C1265 VDD.n370 VSS 0.03472f ; **FLOATING
C1266 VDD.n371 VSS 0.03472f ; **FLOATING
C1267 VDD.n372 VSS 0.02574f ; **FLOATING
C1268 VDD.n373 VSS 0.02275f ; **FLOATING
C1269 VDD.n374 VSS 0.02275f ; **FLOATING
C1270 VDD.n375 VSS 0.02314f ; **FLOATING
C1271 VDD.n376 VSS 0.02314f ; **FLOATING
C1272 VDD.n377 VSS 0.02314f ; **FLOATING
C1273 VDD.n378 VSS 0.02275f ; **FLOATING
C1274 VDD.n379 VSS 0.02275f ; **FLOATING
C1275 VDD.n380 VSS 0.02275f ; **FLOATING
C1276 VDD.n381 VSS 0.02314f ; **FLOATING
C1277 VDD.n382 VSS 0.02314f ; **FLOATING
C1278 VDD.n383 VSS 0.02314f ; **FLOATING
C1279 VDD.n384 VSS 0.02275f ; **FLOATING
C1280 VDD.n385 VSS 0.02275f ; **FLOATING
C1281 VDD.n386 VSS 0.02275f ; **FLOATING
C1282 VDD.n387 VSS 0.02314f ; **FLOATING
C1283 VDD.n388 VSS 0.02314f ; **FLOATING
C1284 VDD.n389 VSS 0.02314f ; **FLOATING
C1285 VDD.n390 VSS 0.02275f ; **FLOATING
C1286 VDD.n391 VSS 0.02275f ; **FLOATING
C1287 VDD.n392 VSS 0.02275f ; **FLOATING
C1288 VDD.n393 VSS 0.02314f ; **FLOATING
C1289 VDD.n394 VSS 0.02314f ; **FLOATING
C1290 VDD.n395 VSS 0.02314f ; **FLOATING
C1291 VDD.n396 VSS 0.02275f ; **FLOATING
C1292 VDD.n397 VSS 0.02275f ; **FLOATING
C1293 VDD.n398 VSS 0.01886f ; **FLOATING
C1294 VDD.n399 VSS 0.03472f ; **FLOATING
C1295 VDD.n400 VSS 0.02619f ; **FLOATING
C1296 VDD.n401 VSS 0.03472f ; **FLOATING
C1297 VDD.n402 VSS 0.1415f ; **FLOATING
C1298 VDD.t39 VSS 0.0414f ; **FLOATING
C1299 VDD.n403 VSS 0.02314f ; **FLOATING
C1300 VDD.n404 VSS 0.0323f ; **FLOATING
.ends
