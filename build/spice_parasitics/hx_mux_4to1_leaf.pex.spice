* NGSPICE file created from hx_mux_4to1_leaf.ext - technology: ihp-sg13g2

.subckt hx_mux_4to1_leaf VSS MUX_ONEHOT_SEL2 MUX_ONEHOT_SEL3 MUX_ONEHOT_SEL0 MUX_ONEHOT_SEL1
+ MUX_IN1 MUX_IN2 MUX_IN3 MUX_IN0 VDD MUX_OUT
X0 MUX_OUT MUX_ONEHOT_SEL3 a_2551_195# VSS.t2 sg13_lv_nmos ad=0.2516p pd=2.16u as=0.1406p ps=1.12u w=0.74u l=0.13u
X1 a_1684_195# MUX_IN2 VDD VDD sg13_lv_pmos ad=0.2128p pd=1.5u as=0.3808p ps=2.92u w=1.12u l=0.13u
X2 MUX_OUT a_1760_159# a_1684_195# VDD sg13_lv_pmos ad=0.3808p pd=2.92u as=0.2128p ps=1.5u w=1.12u l=0.13u
X3 VSS.t14 MUX_ONEHOT_SEL2 a_1760_159# VSS.t13 sg13_lv_nmos ad=0.2516p pd=2.16u as=0.2516p ps=2.16u w=0.74u l=0.13u
X4 a_1031_195# a_821_195# VSS.t7 VSS.t6 sg13_lv_nmos ad=0.1406p pd=1.12u as=0.1665p ps=1.19u w=0.74u l=0.13u
X5 MUX_OUT MUX_ONEHOT_SEL1 a_1031_195# VSS.t15 sg13_lv_nmos ad=0.2516p pd=2.16u as=0.1406p ps=1.12u w=0.74u l=0.13u
X6 VDD MUX_ONEHOT_SEL0 a_240_159# VDD sg13_lv_pmos ad=0.3808p pd=2.92u as=0.3808p ps=2.92u w=1.12u l=0.13u
X7 a_2551_195# a_2341_195# VDD VDD sg13_lv_pmos ad=0.2128p pd=1.5u as=0.252p ps=1.57u w=1.12u l=0.13u
X8 VSS.t4 MUX_ONEHOT_SEL3 a_2627_159# VSS.t3 sg13_lv_nmos ad=0.2516p pd=2.16u as=0.2516p ps=2.16u w=0.74u l=0.13u
X9 VDD MUX_ONEHOT_SEL2 a_1760_159# VDD sg13_lv_pmos ad=0.3808p pd=2.92u as=0.3808p ps=2.92u w=1.12u l=0.13u
X10 MUX_OUT a_2627_159# a_2551_195# VDD sg13_lv_pmos ad=0.3808p pd=2.92u as=0.2128p ps=1.5u w=1.12u l=0.13u
X11 VSS.t7 MUX_IN1 a_821_195# VSS.t21 sg13_lv_nmos ad=0.1665p pd=1.19u as=0.2516p ps=2.16u w=0.74u l=0.13u
X12 VSS.t1 MUX_IN3 a_2341_195# VSS.t0 sg13_lv_nmos ad=0.1665p pd=1.19u as=0.2516p ps=2.16u w=0.74u l=0.13u
X13 a_1031_195# a_821_195# VDD VDD sg13_lv_pmos ad=0.2128p pd=1.5u as=0.252p ps=1.57u w=1.12u l=0.13u
X14 VSS.t17 MUX_ONEHOT_SEL1 a_1107_159# VSS.t16 sg13_lv_nmos ad=0.2516p pd=2.16u as=0.2516p ps=2.16u w=0.74u l=0.13u
X15 a_164_195# MUX_IN0 VSS.t9 VSS.t8 sg13_lv_nmos ad=0.1406p pd=1.12u as=0.2516p ps=2.16u w=0.74u l=0.13u
X16 MUX_OUT MUX_ONEHOT_SEL0 a_164_195# VSS.t18 sg13_lv_nmos ad=0.2516p pd=2.16u as=0.1406p ps=1.12u w=0.74u l=0.13u
X17 MUX_OUT a_1107_159# a_1031_195# VDD sg13_lv_pmos ad=0.3808p pd=2.92u as=0.2128p ps=1.5u w=1.12u l=0.13u
X18 a_1684_195# MUX_IN2 VSS.t11 VSS.t10 sg13_lv_nmos ad=0.1406p pd=1.12u as=0.2516p ps=2.16u w=0.74u l=0.13u
X19 VDD MUX_ONEHOT_SEL3 a_2627_159# VDD sg13_lv_pmos ad=0.3808p pd=2.92u as=0.3808p ps=2.92u w=1.12u l=0.13u
X20 MUX_OUT MUX_ONEHOT_SEL2 a_1684_195# VSS.t12 sg13_lv_nmos ad=0.2516p pd=2.16u as=0.1406p ps=1.12u w=0.74u l=0.13u
X21 VDD MUX_IN1 a_821_195# VDD sg13_lv_pmos ad=0.252p pd=1.57u as=0.3808p ps=2.92u w=1.12u l=0.13u
X22 VDD MUX_IN3 a_2341_195# VDD sg13_lv_pmos ad=0.252p pd=1.57u as=0.3808p ps=2.92u w=1.12u l=0.13u
X23 a_164_195# MUX_IN0 VDD VDD sg13_lv_pmos ad=0.2128p pd=1.5u as=0.3808p ps=2.92u w=1.12u l=0.13u
X24 VDD MUX_ONEHOT_SEL1 a_1107_159# VDD sg13_lv_pmos ad=0.3808p pd=2.92u as=0.3808p ps=2.92u w=1.12u l=0.13u
X25 VSS.t20 MUX_ONEHOT_SEL0 a_240_159# VSS.t19 sg13_lv_nmos ad=0.2516p pd=2.16u as=0.2516p ps=2.16u w=0.74u l=0.13u
X26 MUX_OUT a_240_159# a_164_195# VDD sg13_lv_pmos ad=0.3808p pd=2.92u as=0.2128p ps=1.5u w=1.12u l=0.13u
X27 a_2551_195# a_2341_195# VSS.t1 VSS.t5 sg13_lv_nmos ad=0.1406p pd=1.12u as=0.1665p ps=1.19u w=0.74u l=0.13u
C0 MUX_ONEHOT_SEL1 VDD 0.13044f
C1 MUX_IN0 VDD 0.11377f
C2 a_1107_159# VDD 0.28192f
C3 a_1684_195# a_1760_159# 0.01176f
C4 a_2341_195# MUX_OUT 0.03203f
C5 MUX_IN3 MUX_ONEHOT_SEL2 0.05737f
C6 VDD MUX_OUT 0.59121f
C7 a_2551_195# MUX_OUT 0.39036f
C8 MUX_OUT a_1760_159# 0.2827f
C9 a_1684_195# MUX_IN2 0.09549f
C10 MUX_ONEHOT_SEL0 a_240_159# 0.11443f
C11 MUX_ONEHOT_SEL2 MUX_OUT 0.02426f
C12 a_2627_159# MUX_OUT 0.26205f
C13 a_1031_195# a_1107_159# 0.01194f
C14 MUX_ONEHOT_SEL1 MUX_IN2 0.05562f
C15 a_1031_195# MUX_OUT 0.39036f
C16 MUX_ONEHOT_SEL1 a_821_195# 0.01264f
C17 a_2341_195# VDD 0.29625f
C18 a_1107_159# a_821_195# 0.01885f
C19 a_240_159# a_164_195# 0.01176f
C20 MUX_ONEHOT_SEL0 MUX_IN0 0.01264f
C21 MUX_ONEHOT_SEL3 MUX_OUT 0.01363f
C22 a_821_195# MUX_OUT 0.03198f
C23 a_2551_195# a_2341_195# 0.09424f
C24 a_2551_195# VDD 0.15389f
C25 MUX_ONEHOT_SEL0 MUX_OUT 0.02253f
C26 VDD a_1760_159# 0.27856f
C27 MUX_ONEHOT_SEL2 VDD 0.1437f
C28 a_2627_159# a_2341_195# 0.01885f
C29 MUX_IN1 VDD 0.11517f
C30 MUX_IN0 a_164_195# 0.0955f
C31 a_2627_159# VDD 0.27828f
C32 a_1031_195# VDD 0.15389f
C33 MUX_OUT a_164_195# 0.37183f
C34 a_2551_195# a_2627_159# 0.01194f
C35 MUX_ONEHOT_SEL2 a_1760_159# 0.12062f
C36 VDD MUX_IN2 0.12021f
C37 MUX_ONEHOT_SEL3 a_2341_195# 0.01264f
C38 MUX_ONEHOT_SEL3 VDD 0.25173f
C39 VDD a_821_195# 0.29832f
C40 a_240_159# MUX_IN0 0.01885f
C41 MUX_ONEHOT_SEL0 VDD 0.13122f
C42 a_240_159# MUX_OUT 0.28012f
C43 MUX_IN2 a_1760_159# 0.01885f
C44 MUX_ONEHOT_SEL2 MUX_IN2 0.01264f
C45 MUX_IN1 a_821_195# 0.18267f
C46 a_1684_195# MUX_OUT 0.38992f
C47 a_2627_159# MUX_ONEHOT_SEL3 0.12084f
C48 VDD a_164_195# 0.1729f
C49 MUX_ONEHOT_SEL1 a_1107_159# 0.11443f
C50 MUX_IN1 MUX_ONEHOT_SEL0 0.05074f
C51 a_1031_195# a_821_195# 0.09424f
C52 MUX_ONEHOT_SEL1 MUX_OUT 0.02262f
C53 a_1107_159# MUX_OUT 0.2827f
C54 a_240_159# VDD 0.28224f
C55 MUX_ONEHOT_SEL0 a_821_195# 0.02879f
C56 MUX_IN3 a_2341_195# 0.18569f
C57 a_1684_195# VDD 0.17499f
C58 MUX_IN3 VDD 0.1137f
R0 VSS.n1 VSS.t13 122.106
R1 VSS.t6 VSS.n4 423.505
R2 VSS.n4 VSS.n1 6.80531
R3 VSS.t15 VSS.n4 136.048
R4 VSS.n5 VSS.t5 423.505
R5 VSS.n5 VSS.t2 136.048
R6 VSS.t16 VSS.n1 130.65
R7 VSS.t19 VSS.n1 122.106
R8 VSS.t12 VSS.n1 99.7583
R9 VSS.t21 VSS.n6 118.55
R10 VSS.n0 VSS.t0 118.55
R11 VSS.n1 VSS.t3 130.651
R12 VSS.n1 VSS.t18 99.7582
R13 VSS.n1 VSS.t10 81.3941
R14 VSS.n1 VSS.n5 6.8053
R15 VSS.n1 VSS.t1 8.77423
R16 VSS.n1 VSS.t14 8.77423
R17 VSS.n3 VSS.t11 8.77423
R18 VSS.n3 VSS.t17 8.77423
R19 VSS.n3 VSS.t7 8.77423
R20 VSS.n3 VSS.t20 8.77423
R21 VSS VSS.t9 8.77423
R22 VSS.n1 VSS.t4 9.16223
R23 VSS.n2 VSS 0.746538
R24 VSS.n6 VSS.t6 163.948
R25 VSS.t5 VSS.n0 163.948
R26 VSS.n1 VSS.t8 81.4072
R27 VSS.n1 VSS.n0 1.22896
R28 VSS.n2 VSS.n3 0.42976
R29 VSS.n1 VSS.n2 0.216881
R30 VSS.n1 VSS.n6 1.02585
C59 MUX_OUT VSS 0.73868f
C60 MUX_ONEHOT_SEL3 VSS 0.36494f
C61 MUX_IN3 VSS 0.13589f
C62 MUX_ONEHOT_SEL2 VSS 0.31141f
C63 MUX_IN2 VSS 0.14828f
C64 MUX_ONEHOT_SEL1 VSS 0.32525f
C65 MUX_IN1 VSS 0.13529f
C66 MUX_ONEHOT_SEL0 VSS 0.44913f
C67 MUX_IN0 VSS 0.18429f
C68 VDD VSS 0.62349f
C69 a_2627_159# VSS 0.19081f ; **FLOATING
C70 a_2551_195# VSS 0.10926f ; **FLOATING
C71 a_1760_159# VSS 0.18643f ; **FLOATING
C72 a_1684_195# VSS 0.12122f ; **FLOATING
C73 a_1107_159# VSS 0.18382f ; **FLOATING
C74 a_1031_195# VSS 0.10926f ; **FLOATING
C75 a_240_159# VSS 0.18383f ; **FLOATING
C76 a_164_195# VSS 0.13334f ; **FLOATING
C77 a_2341_195# VSS 0.25561f ; **FLOATING
C78 a_821_195# VSS 0.23813f ; **FLOATING
.ends
