* NGSPICE file created from hx_mux_4to1_leaf.ext - technology: ihp-sg13g2

.subckt hx_mux_4to1_leaf VSS MUX_ONEHOT_SEL2 MUX_ONEHOT_SEL3 MUX_ONEHOT_SEL0 MUX_ONEHOT_SEL1
+ MUX_IN1 MUX_IN2 MUX_IN3 MUX_IN0 VDD MUX_OUT
X0 MUX_OUT MUX_ONEHOT_SEL3 a_2551_195# VSS.t2 sg13_lv_nmos ad=0.2516p pd=2.16u as=0.1406p ps=1.12u w=0.74u l=0.13u
X1 a_1684_195# MUX_IN2 VDD VDD sg13_lv_pmos ad=0.2128p pd=1.5u as=0.3808p ps=2.92u w=1.12u l=0.13u
X2 MUX_OUT a_1760_159# a_1684_195# VDD sg13_lv_pmos ad=0.3808p pd=2.92u as=0.2128p ps=1.5u w=1.12u l=0.13u
X3 VSS.t14 MUX_ONEHOT_SEL2 a_1760_159# VSS.t13 sg13_lv_nmos ad=0.2516p pd=2.16u as=0.2516p ps=2.16u w=0.74u l=0.13u
X4 a_1031_195# a_821_195# VSS.t7 VSS.t6 sg13_lv_nmos ad=0.1406p pd=1.12u as=0.1665p ps=1.19u w=0.74u l=0.13u
X5 MUX_OUT MUX_ONEHOT_SEL1 a_1031_195# VSS.t15 sg13_lv_nmos ad=0.2516p pd=2.16u as=0.1406p ps=1.12u w=0.74u l=0.13u
X6 VDD MUX_ONEHOT_SEL0 a_240_159# VDD sg13_lv_pmos ad=0.3808p pd=2.92u as=0.3808p ps=2.92u w=1.12u l=0.13u
X7 a_2551_195# a_2341_195# VDD VDD sg13_lv_pmos ad=0.2128p pd=1.5u as=0.252p ps=1.57u w=1.12u l=0.13u
X8 VSS.t4 MUX_ONEHOT_SEL3 a_2627_159# VSS.t3 sg13_lv_nmos ad=0.2516p pd=2.16u as=0.2516p ps=2.16u w=0.74u l=0.13u
X9 VDD MUX_ONEHOT_SEL2 a_1760_159# VDD sg13_lv_pmos ad=0.3808p pd=2.92u as=0.3808p ps=2.92u w=1.12u l=0.13u
X10 MUX_OUT a_2627_159# a_2551_195# VDD sg13_lv_pmos ad=0.3808p pd=2.92u as=0.2128p ps=1.5u w=1.12u l=0.13u
X11 VSS.t7 MUX_IN1 a_821_195# VSS.t21 sg13_lv_nmos ad=0.1665p pd=1.19u as=0.2516p ps=2.16u w=0.74u l=0.13u
X12 VSS.t1 MUX_IN3 a_2341_195# VSS.t0 sg13_lv_nmos ad=0.1665p pd=1.19u as=0.2516p ps=2.16u w=0.74u l=0.13u
X13 a_1031_195# a_821_195# VDD VDD sg13_lv_pmos ad=0.2128p pd=1.5u as=0.252p ps=1.57u w=1.12u l=0.13u
X14 VSS.t17 MUX_ONEHOT_SEL1 a_1107_159# VSS.t16 sg13_lv_nmos ad=0.2516p pd=2.16u as=0.2516p ps=2.16u w=0.74u l=0.13u
X15 a_164_195# MUX_IN0 VSS.t9 VSS.t8 sg13_lv_nmos ad=0.1406p pd=1.12u as=0.2516p ps=2.16u w=0.74u l=0.13u
X16 MUX_OUT MUX_ONEHOT_SEL0 a_164_195# VSS.t18 sg13_lv_nmos ad=0.2516p pd=2.16u as=0.1406p ps=1.12u w=0.74u l=0.13u
X17 MUX_OUT a_1107_159# a_1031_195# VDD sg13_lv_pmos ad=0.3808p pd=2.92u as=0.2128p ps=1.5u w=1.12u l=0.13u
X18 a_1684_195# MUX_IN2 VSS.t11 VSS.t10 sg13_lv_nmos ad=0.1406p pd=1.12u as=0.2516p ps=2.16u w=0.74u l=0.13u
X19 VDD MUX_ONEHOT_SEL3 a_2627_159# VDD sg13_lv_pmos ad=0.3808p pd=2.92u as=0.3808p ps=2.92u w=1.12u l=0.13u
X20 MUX_OUT MUX_ONEHOT_SEL2 a_1684_195# VSS.t12 sg13_lv_nmos ad=0.2516p pd=2.16u as=0.1406p ps=1.12u w=0.74u l=0.13u
X21 VDD MUX_IN1 a_821_195# VDD sg13_lv_pmos ad=0.252p pd=1.57u as=0.3808p ps=2.92u w=1.12u l=0.13u
X22 VDD MUX_IN3 a_2341_195# VDD sg13_lv_pmos ad=0.252p pd=1.57u as=0.3808p ps=2.92u w=1.12u l=0.13u
X23 a_164_195# MUX_IN0 VDD VDD sg13_lv_pmos ad=0.2128p pd=1.5u as=0.3808p ps=2.92u w=1.12u l=0.13u
X24 VDD MUX_ONEHOT_SEL1 a_1107_159# VDD sg13_lv_pmos ad=0.3808p pd=2.92u as=0.3808p ps=2.92u w=1.12u l=0.13u
X25 VSS.t20 MUX_ONEHOT_SEL0 a_240_159# VSS.t19 sg13_lv_nmos ad=0.2516p pd=2.16u as=0.2516p ps=2.16u w=0.74u l=0.13u
X26 MUX_OUT a_240_159# a_164_195# VDD sg13_lv_pmos ad=0.3808p pd=2.92u as=0.2128p ps=1.5u w=1.12u l=0.13u
X27 a_2551_195# a_2341_195# VSS.t1 VSS.t5 sg13_lv_nmos ad=0.1406p pd=1.12u as=0.1665p ps=1.19u w=0.74u l=0.13u
C0 MUX_OUT a_164_195# 0.37183f
C1 VDD a_240_159# 0.28224f
C2 MUX_ONEHOT_SEL0 MUX_IN1 0.05074f
C3 a_1760_159# MUX_OUT 0.2827f
C4 a_1107_159# MUX_ONEHOT_SEL1 0.11443f
C5 VDD MUX_IN2 0.12021f
C6 a_1107_159# VDD 0.28192f
C7 MUX_IN2 MUX_ONEHOT_SEL2 0.01264f
C8 VDD MUX_ONEHOT_SEL1 0.13044f
C9 MUX_IN0 a_240_159# 0.01885f
C10 a_821_195# a_1107_159# 0.01885f
C11 a_240_159# a_164_195# 0.01176f
C12 a_821_195# MUX_ONEHOT_SEL1 0.01264f
C13 VDD MUX_ONEHOT_SEL3 0.25173f
C14 MUX_OUT MUX_ONEHOT_SEL0 0.02253f
C15 a_1031_195# a_1107_159# 0.01194f
C16 a_1684_195# MUX_OUT 0.38992f
C17 a_1760_159# MUX_IN2 0.01885f
C18 a_821_195# VDD 0.29832f
C19 VDD MUX_ONEHOT_SEL2 0.1437f
C20 a_2341_195# MUX_IN3 0.18569f
C21 a_1031_195# VDD 0.15389f
C22 a_2627_159# MUX_OUT 0.26205f
C23 VDD MUX_IN0 0.11377f
C24 VDD a_164_195# 0.1729f
C25 a_821_195# a_1031_195# 0.09424f
C26 MUX_ONEHOT_SEL0 a_240_159# 0.11443f
C27 MUX_OUT a_2551_195# 0.39036f
C28 a_1760_159# VDD 0.27856f
C29 a_2341_195# MUX_OUT 0.03203f
C30 a_2627_159# a_2551_195# 0.01194f
C31 a_1684_195# MUX_IN2 0.09549f
C32 a_2341_195# a_2627_159# 0.01885f
C33 a_1760_159# MUX_ONEHOT_SEL2 0.12062f
C34 VDD MUX_IN1 0.11517f
C35 MUX_OUT a_240_159# 0.28012f
C36 a_2341_195# a_2551_195# 0.09424f
C37 MUX_IN0 a_164_195# 0.0955f
C38 a_821_195# MUX_IN1 0.18267f
C39 VDD MUX_IN3 0.1137f
C40 a_1107_159# MUX_OUT 0.2827f
C41 VDD MUX_ONEHOT_SEL0 0.13122f
C42 VDD a_1684_195# 0.17499f
C43 MUX_OUT MUX_ONEHOT_SEL1 0.02262f
C44 a_821_195# MUX_ONEHOT_SEL0 0.02879f
C45 MUX_IN3 MUX_ONEHOT_SEL2 0.05737f
C46 MUX_OUT MUX_ONEHOT_SEL3 0.01363f
C47 a_2627_159# MUX_ONEHOT_SEL3 0.12084f
C48 VDD MUX_OUT 0.59121f
C49 VDD a_2627_159# 0.27828f
C50 a_821_195# MUX_OUT 0.03198f
C51 MUX_IN0 MUX_ONEHOT_SEL0 0.01264f
C52 a_2341_195# MUX_ONEHOT_SEL3 0.01264f
C53 VDD a_2551_195# 0.15389f
C54 MUX_ONEHOT_SEL2 MUX_OUT 0.02426f
C55 a_1760_159# a_1684_195# 0.01176f
C56 VDD a_2341_195# 0.29625f
C57 a_1031_195# MUX_OUT 0.39036f
C58 MUX_IN2 MUX_ONEHOT_SEL1 0.05562f
R0 VSS.t10 VSS.n2 81.3941
R1 VSS.n2 VSS.n1 0.352526
R2 VSS.n2 VSS.t16 130.65
R3 VSS.n3 VSS.t6 423.505
R4 VSS.n4 VSS.t5 423.505
R5 VSS.n4 VSS.t2 136.048
R6 VSS.t19 VSS.n2 122.106
R7 VSS.n2 VSS.t13 122.106
R8 VSS.t21 VSS.n5 118.55
R9 VSS.n1 VSS.t0 118.55
R10 VSS.n2 VSS.t3 130.651
R11 VSS.t8 VSS.n2 81.4072
R12 VSS.t12 VSS.n2 99.7583
R13 VSS.n2 VSS.n15 17.0005
R14 VSS.n2 VSS.n6 3.32638
R15 VSS.n2 VSS.n3 6.80531
R16 VSS.n2 VSS.n4 6.8053
R17 VSS.n0 VSS.t4 8.97483
R18 VSS.n0 VSS.t1 8.77423
R19 VSS.n0 VSS.t14 8.77423
R20 VSS.n7 VSS.t11 8.77423
R21 VSS.n9 VSS.t17 8.77423
R22 VSS.n11 VSS.t7 8.77423
R23 VSS.n12 VSS.t20 8.77423
R24 VSS.n14 VSS.t9 8.77423
R25 VSS.n2 VSS.n8 5.62581
R26 VSS.n6 VSS.n14 0.26736
R27 VSS.n2 VSS.n13 2.74446
R28 VSS.n2 VSS.n0 0.74101
R29 VSS.n2 VSS.n10 2.74394
R30 VSS.n5 VSS.t6 163.948
R31 VSS.t5 VSS.n1 163.948
R32 VSS.n13 VSS.n11 0.284268
R33 VSS.n11 VSS.n10 0.283226
R34 VSS.n10 VSS.n9 0.269814
R35 VSS.n13 VSS.n12 0.240049
R36 VSS.n9 VSS.n8 0.15705
R37 VSS.n8 VSS.n7 0.113638
R38 VSS.n12 VSS.n6 0.279847
R39 VSS.n15 VSS 0.048
R40 VSS.n15 VSS.n14 0.018
R41 VSS.n2 VSS.t18 99.7582
R42 VSS.n3 VSS.t15 136.048
R43 VSS.n0 VSS.n7 1.328
R44 VSS.n2 VSS.n5 1.02585
C59 MUX_OUT VSS 0.73868f
C60 MUX_ONEHOT_SEL3 VSS 0.36494f
C61 MUX_IN3 VSS 0.13589f
C62 MUX_ONEHOT_SEL2 VSS 0.31141f
C63 MUX_IN2 VSS 0.14828f
C64 MUX_ONEHOT_SEL1 VSS 0.32525f
C65 MUX_IN1 VSS 0.13529f
C66 MUX_ONEHOT_SEL0 VSS 0.44913f
C67 MUX_IN0 VSS 0.18429f
C68 VDD VSS 0.62349f
C69 a_2627_159# VSS 0.19081f ; **FLOATING
C70 a_2551_195# VSS 0.10926f ; **FLOATING
C71 a_1760_159# VSS 0.18643f ; **FLOATING
C72 a_1684_195# VSS 0.12122f ; **FLOATING
C73 a_1107_159# VSS 0.18382f ; **FLOATING
C74 a_1031_195# VSS 0.10926f ; **FLOATING
C75 a_240_159# VSS 0.18383f ; **FLOATING
C76 a_164_195# VSS 0.13334f ; **FLOATING
C77 a_2341_195# VSS 0.25561f ; **FLOATING
C78 a_821_195# VSS 0.23813f ; **FLOATING
.ends
