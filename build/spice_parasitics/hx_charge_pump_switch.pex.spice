* NGSPICE file created from hx_charge_pump_switch.ext - technology: ihp-sg13g2

.subckt hx_charge_pump_switch VSS VDD UP_INV DOWN DOWN_INV UP DELAY_VBIASP DELAY_VBIASN
+ CURRENT_SOURCE CURRENT_SINK DLL_RESETN
X0 VDD VDD VDD VDD sg13_lv_pmos ad=0.2128p pd=1.5u as=15.142p ps=78.71999u w=1.12u l=0.13u
X1 VDD DELAY_VBIASP DELAY_VBIASP VDD sg13_lv_pmos ad=0.3808p pd=2.92u as=1.0304p ps=4.08u w=1.12u l=0.6u
X2 VDD DOWN_INV CURRENT_SINK VSS.t14 sg13_lv_nmos ad=0.232p pd=2.08u as=0.136p ps=1.14u w=0.4u l=0.2u
X3 VDD VDD VDD VDD sg13_lv_pmos ad=0.3808p pd=2.92u as=0 ps=0 w=1.12u l=0.13u
X4 VSS.t6 VSS.t4 VSS.t4 VSS.t5 sg13_lv_nmos ad=0.2516p pd=2.16u as=0 ps=0 w=0.74u l=0.13u
X5 VSS.t6 VSS.t6 VSS.t8 VSS.t7 sg13_lv_nmos ad=0.1406p pd=1.12u as=0 ps=0 w=0.74u l=0.13u
X6 CURRENT_SINK DOWN DELAY_VBIASN VSS.t0 sg13_lv_nmos ad=0.136p pd=1.14u as=0.232p ps=2.08u w=0.4u l=0.2u
X7 VSS.t1 UP CURRENT_SOURCE VDD sg13_lv_pmos ad=0.232p pd=2.08u as=0.136p ps=1.14u w=0.4u l=0.2u
X8 VDD VDD VDD VDD sg13_lv_pmos ad=0.2128p pd=1.5u as=0 ps=0 w=1.12u l=0.13u
X9 VSS.t3 DELAY_VBIASN DELAY_VBIASP VSS.t2 sg13_lv_nmos ad=0.2516p pd=2.16u as=0.6808p ps=3.32u w=0.74u l=0.6u
X10 VDD VDD VDD VDD sg13_lv_pmos ad=0.3808p pd=2.92u as=0 ps=0 w=1.12u l=0.13u
X11 VSS.t11 VSS.t9 VSS.t9 VSS.t10 sg13_lv_nmos ad=0.2516p pd=2.16u as=0 ps=0 w=0.74u l=0.13u
X12 VSS.t11 VSS.t11 VSS.t13 VSS.t12 sg13_lv_nmos ad=0.1406p pd=1.12u as=0 ps=0 w=0.74u l=0.13u
X13 DELAY_VBIASN DLL_RESETN VDD VDD sg13_lv_pmos ad=0.158p pd=1.245u as=0.272p ps=2.28u w=0.8u l=0.2u
X14 CURRENT_SOURCE UP_INV DELAY_VBIASN VDD sg13_lv_pmos ad=0.136p pd=1.14u as=0.158p ps=1.245u w=0.4u l=0.2u
C0 DLL_RESETN UP_INV 0.03128f
C1 DOWN CURRENT_SINK 0.03275f
C2 VDD CURRENT_SINK 0.20022f
C3 DOWN DELAY_VBIASN 0.18643f
C4 UP VDD 0.31295f
C5 DLL_RESETN CURRENT_SINK 0.20441f
C6 VDD DELAY_VBIASN 0.2313f
C7 CURRENT_SOURCE VDD 0.21247f
C8 DOWN_INV CURRENT_SINK 0.01237f
C9 DLL_RESETN DELAY_VBIASN 0.12834f
C10 DELAY_VBIASP VDD 0.7492f
C11 UP DOWN_INV 0.06731f
C12 CURRENT_SOURCE DLL_RESETN 0.11791f
C13 UP UP_INV 0.07166f
C14 DLL_RESETN DELAY_VBIASP 0.06495f
C15 UP_INV DELAY_VBIASN 0.07797f
C16 CURRENT_SOURCE DOWN_INV 0.0141f
C17 CURRENT_SOURCE UP_INV 0.04919f
C18 CURRENT_SINK DELAY_VBIASN 0.21568f
C19 CURRENT_SOURCE CURRENT_SINK 0.01554f
C20 DELAY_VBIASP CURRENT_SINK 0.05036f
C21 UP CURRENT_SOURCE 0.05588f
C22 DOWN DOWN_INV 0.54597f
C23 DLL_RESETN VDD 0.54671f
C24 CURRENT_SOURCE DELAY_VBIASN 0.14824f
C25 VDD DOWN_INV 0.36499f
C26 DELAY_VBIASP DELAY_VBIASN 0.37605f
C27 UP_INV VDD 0.34717f
C28 CURRENT_SOURCE DELAY_VBIASP 0.01665f
R0 VSS.n28 VSS.n3 8.50098
R1 VSS.n27 VSS.t14 256.409
R2 VSS.n21 VSS.t5 226.278
R3 VSS.n24 VSS.t10 226.278
R4 VSS.n26 VSS.t0 212.389
R5 VSS.t2 VSS.n22 179.79
R6 VSS.t7 VSS.n21 145.986
R7 VSS.t12 VSS.n24 145.986
R8 VSS.n22 VSS.t7 139.644
R9 VSS.n25 VSS.t12 139.643
R10 VSS.n23 VSS.t2 114.097
R11 VSS.t0 VSS.n25 81.2496
R12 VSS.t10 VSS.n23 59.3506
R13 VSS.t14 VSS.n26 37.2081
R14 VSS.n15 VSS.n1 17.0005
R15 VSS.n5 VSS.n1 17.0005
R16 VSS.n33 VSS.n1 17.0005
R17 VSS.n13 VSS.n1 17.0005
R18 VSS.n29 VSS.n1 17.0005
R19 VSS.n1 VSS.n0 17.0005
R20 VSS.n28 VSS.n27 15.54
R21 VSS.t1 VSS.n40 9.08698
R22 VSS.n41 VSS.t1 9.0445
R23 VSS.n3 VSS.n1 0.00100009
R24 VSS.n24 VSS.n1 8.5005
R25 VSS.n21 VSS.n1 8.5005
R26 VSS.n20 VSS.n1 8.47732
R27 VSS.n17 VSS.n1 8.47732
R28 VSS.n12 VSS.n1 8.47732
R29 VSS.n7 VSS.n1 8.47732
R30 VSS.n35 VSS.n1 8.47732
R31 VSS.n31 VSS.n1 8.47732
R32 VSS.n19 VSS.n1 4.19225
R33 VSS.n39 VSS.n1 4.18908
R34 VSS.n9 VSS.n1 3.32633
R35 VSS.n10 VSS.n1 2.74397
R36 VSS.n42 VSS.n1 2.00992
R37 VSS.n37 VSS.n1 1.75507
R38 VSS.n14 VSS.t9 0.806855
R39 VSS.n4 VSS.t4 0.806855
R40 VSS.n11 VSS.t3 0.802775
R41 VSS.t13 VSS.n18 0.595317
R42 VSS.t11 VSS.n16 0.595317
R43 VSS.t8 VSS.n8 0.595317
R44 VSS.t6 VSS.n6 0.595317
R45 VSS.n38 VSS.n37 0.52186
R46 VSS.n37 VSS.n36 0.447348
R47 VSS.n42 VSS.t4 0.338368
R48 VSS.n43 VSS.n42 0.326302
R49 VSS.n10 VSS.n32 0.312321
R50 VSS.n39 VSS.n38 0.293144
R51 VSS.n9 VSS.t3 0.275797
R52 VSS.n8 VSS.n9 0.266415
R53 VSS.n26 VSS.n1 0.246805
R54 VSS.n40 VSS.n39 0.244511
R55 VSS.n11 VSS.n10 0.238218
R56 VSS.n19 VSS.n41 0.225674
R57 VSS.n18 VSS.n19 0.219424
R58 VSS.t6 VSS.t8 0.1875
R59 VSS.t11 VSS.t13 0.1875
R60 VSS.n12 VSS.t9 0.0971176
R61 VSS VSS.n43 0.093
R62 VSS.n13 VSS.n11 0.093
R63 VSS.n30 VSS.t6 0.0851154
R64 VSS.n32 VSS.t8 0.0851154
R65 VSS.n34 VSS.t11 0.0851154
R66 VSS.n36 VSS.t13 0.0851154
R67 VSS.n5 VSS.n6 0.08175
R68 VSS.n15 VSS.n16 0.08175
R69 VSS.n30 VSS.n29 0.08175
R70 VSS.n34 VSS.n33 0.08175
R71 VSS.n7 VSS.n8 0.0671176
R72 VSS.n17 VSS.n18 0.0671176
R73 VSS.n32 VSS.n31 0.0671176
R74 VSS.n36 VSS.n35 0.0671176
R75 VSS.n6 VSS.n7 0.0621177
R76 VSS.n16 VSS.n17 0.0621177
R77 VSS.n31 VSS.n30 0.0621177
R78 VSS.n35 VSS.n34 0.0621177
R79 VSS.n41 VSS.n20 0.0608676
R80 VSS.t3 VSS.n12 0.0571176
R81 VSS.n43 VSS.n0 0.04925
R82 VSS.n4 VSS.n0 0.04925
R83 VSS.n14 VSS.n13 0.04925
R84 VSS.n40 VSS.n20 0.0483676
R85 VSS.t4 VSS.n5 0.04675
R86 VSS.t9 VSS.n15 0.04675
R87 VSS.n29 VSS.n4 0.04675
R88 VSS.n33 VSS.n14 0.04675
R89 VSS.n43 VSS 0.0375787
R90 VSS.n27 VSS.n1 0.0220901
R91 VSS.t5 VSS.n3 59.352
R92 VSS.n38 VSS.n2 8.47807
R93 VSS.n23 VSS.n1 0.0014632
R94 VSS.n22 VSS.n1 0.0010135
R95 VSS.n25 VSS.n1 0.0010066
R96 VSS.n2 VSS.n1 0.00125
R97 VSS.n2 VSS.n28 8.50163
C29 DOWN_INV VSS 0.58961f
C30 CURRENT_SINK VSS 0.52216f
C31 DOWN VSS 0.86043f
C32 CURRENT_SOURCE VSS 0.57675f
C33 UP VSS 0.15039f
C34 DELAY_VBIASN VSS 1.10897f
C35 DLL_RESETN VSS 0.07404f
C36 UP_INV VSS 0.07259f
C37 DELAY_VBIASP VSS 0.51225f
C38 VDD VSS 2.0041f
.ends
