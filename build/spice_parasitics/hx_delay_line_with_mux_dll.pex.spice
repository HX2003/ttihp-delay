* NGSPICE file created from hx_delay_line_with_mux_dll.ext - technology: ihp-sg13g2

.subckt hx_delay_line_with_mux_dll VDD DELAY_OUT_LAST VSS DELAY_VBIASN DELAY_VBIASP
+ DLL_RESETN REF_CLK MUX_SEL0 MUX_SEL1 MUX_OUT MUX_SEL4 MUX_SEL2 MUX_SEL3
X0 a_14009_5878# REF_CLK VSS.t199 VSS.t198 sg13_lv_nmos ad=0.2516p pd=2.16u as=1.9998p ps=12.915u w=0.74u l=0.13u
X1 VDD.t113 a_4003_1842# a_4437_1842# VDD.t25 sg13_lv_pmos ad=0.2128p pd=1.5u as=0.3808p ps=2.92u w=1.12u l=0.13u
X2 VSS.t143 DLL_RESETN a_10040_6305# VSS.t142 sg13_lv_nmos ad=0.1626p pd=1.415u as=60.89999f ps=0.71u w=0.42u l=0.13u
X3 VSS.t150 a_15077_1842# a_15545_1044# VSS.t602 sg13_lv_nmos ad=0.1665p pd=1.19u as=0.2516p ps=2.16u w=0.74u l=0.13u
X4 a_27915_1044# a_27705_1044# VDD.t168 VDD.t36 sg13_lv_pmos ad=0.2128p pd=1.5u as=0.252p ps=1.57u w=1.12u l=0.13u
X5 VSS.t8 VDD.t406 VSS.t6 VSS.t7 sg13_lv_nmos ad=79.8f pd=0.8u as=0 ps=0 w=0.42u l=1u
X6 a_10951_2470# a_10713_1842# a_10843_1842# VDD.t25 sg13_lv_pmos ad=0.2128p pd=1.5u as=0.3808p ps=2.92u w=1.12u l=0.2u
X7 VSS.t334 a_3171_1047.t7 a_11924_1008# VSS.t333 sg13_lv_nmos ad=0.2516p pd=2.16u as=0.2516p ps=2.16u w=0.74u l=0.13u
X8 VDD.t68 VSS.t50 VDD.t103 VDD.t36 sg13_lv_pmos ad=0.34p pd=2.68u as=0 ps=0 w=1u l=1u
X9 VSS.t208 a_1256_1044# a_2967_1395# VSS.t207 sg13_lv_nmos ad=0.1331p pd=1.12u as=0.1216p ps=1.02u w=0.64u l=0.13u
X10 VSS.t8 VDD.t405 VSS.t8 VSS.t9 sg13_lv_nmos ad=0.1428p pd=1.52u as=0 ps=0 w=0.42u l=1u
X11 a_25153_1842# a_24957_1842# VSS.t315 VSS.t400 sg13_lv_nmos ad=0.2516p pd=2.16u as=0.1406p ps=1.12u w=0.74u l=0.13u
X12 VDD.t183 VSS.t23 VDD.t388 VDD.t36 sg13_lv_pmos ad=0.34p pd=2.68u as=0 ps=0 w=1u l=1u
X13 a_15108_6109# a_14851_6228# a_15270_6305# VSS.t94 sg13_lv_nmos ad=0.1428p pd=1.52u as=37.8f ps=0.6u w=0.42u l=0.13u
X14 VSS.t166 a_14851_6228# a_15688_5867# VSS.t451 sg13_lv_nmos ad=0.1406p pd=1.12u as=0.2516p ps=2.16u w=0.74u l=0.13u
X15 VSS.t357 VSS.t355 VSS.t355 VSS.t356 sg13_lv_nmos ad=0.68p pd=4.68u as=0 ps=0 w=2u l=1u
X16 a_15108_5325# a_12849_5867# VDD.t58 VDD.t1 sg13_lv_pmos ad=79.8f pd=0.8u as=1.03698p ps=6.245u w=0.42u l=0.13u
X17 a_25630_1044# a_2019_1047.t2 a_25528_1044# VSS.t577 sg13_lv_nmos ad=0.2516p pd=2.16u as=0.1406p ps=1.12u w=0.74u l=0.13u
X18 VDD.t258 DELAY_VBIASP a_19311_2470# VDD.t25 sg13_lv_pmos ad=0.3808p pd=2.92u as=0.2128p ps=1.5u w=1.12u l=0.6u
X19 a_16108_289# a_2019_311# a_16510_1044# VSS.t447 sg13_lv_nmos ad=0.2516p pd=2.16u as=0.2516p ps=2.16u w=0.74u l=0.13u
X20 VDD.t269 DELAY_VBIASP a_9431_2470# VDD.t25 sg13_lv_pmos ad=0.3808p pd=2.92u as=0.2128p ps=1.5u w=1.12u l=0.6u
X21 VSS.t57 VDD.t392 VSS.t56 VSS.t55 sg13_lv_nmos ad=0.1428p pd=1.52u as=0 ps=0 w=0.42u l=1u
X22 VSS.t352 VSS.t352 VSS.t354 VSS.t353 sg13_lv_nmos ad=0.68p pd=4.68u as=0 ps=0 w=2u l=1u
X23 VDD.t277 DELAY_VBIASP a_23111_2470# VDD.t25 sg13_lv_pmos ad=0.3808p pd=2.92u as=0.2128p ps=1.5u w=1.12u l=0.6u
X24 a_7390_1044# a_8231_1008# a_8155_1044# VDD.t36 sg13_lv_pmos ad=0.3808p pd=2.92u as=0.2128p ps=1.5u w=1.12u l=0.13u
X25 a_14009_5878# REF_CLK VDD.t58 VDD.t1 sg13_lv_pmos ad=0.4088p pd=2.97u as=1.03698p ps=6.245u w=1.12u l=0.13u
X26 VSS.t12 a_2595_311.t3 a_8745_519# VSS.t181 sg13_lv_nmos ad=0.2516p pd=2.16u as=0.2516p ps=2.16u w=0.74u l=0.13u
X27 a_11748_6109# DLL_RESETN VDD.t58 VDD.t1 sg13_lv_pmos ad=79.8f pd=0.8u as=1.10612p ps=6.66u w=0.42u l=0.13u
X28 VDD.t66 a_11491_6228# a_12158_5867# VDD.t1 sg13_lv_pmos ad=0.2128p pd=1.5u as=0.3864p ps=2.93u w=1.12u l=0.13u
X29 VDD.t263 DELAY_VBIASP DELAY_VBIASP VDD.t14 sg13_lv_pmos ad=0.3808p pd=2.92u as=1.0304p ps=4.08u w=1.12u l=0.6u
X30 a_17791_1842# a_17553_1842# a_17683_1842# VSS.t271 sg13_lv_nmos ad=0.1406p pd=1.12u as=0.2516p ps=2.16u w=0.74u l=0.2u
X31 VSS.t87 a_11748_6109# a_11397_6228# VSS.t110 sg13_lv_nmos ad=79.8f pd=0.8u as=0.1428p ps=1.52u w=0.42u l=0.13u
X32 VDD.t224 a_12037_1842# a_12505_1044# VDD.t36 sg13_lv_pmos ad=0.252p pd=1.57u as=0.3808p ps=2.92u w=1.12u l=0.13u
X33 a_16510_1044# a_2019_1047.t5 a_16408_1044# VSS.t607 sg13_lv_nmos ad=0.2516p pd=2.16u as=0.1406p ps=1.12u w=0.74u l=0.13u
X34 a_21591_1842# a_21353_1842# a_21483_1842# VSS.t317 sg13_lv_nmos ad=0.1406p pd=1.12u as=0.2516p ps=2.16u w=0.74u l=0.2u
X35 a_6153_1842# a_5957_1842# VSS.t311 VSS.t310 sg13_lv_nmos ad=0.2516p pd=2.16u as=0.1406p ps=1.12u w=0.74u l=0.13u
X36 VSS.t117 a_16163_1842# a_16597_1842# VSS.t116 sg13_lv_nmos ad=0.1406p pd=1.12u as=0.2516p ps=2.16u w=0.74u l=0.13u
X37 VSS.t291 a_3171_1047.t2 a_27124_1008# VSS.t290 sg13_lv_nmos ad=0.2516p pd=2.16u as=0.2516p ps=2.16u w=0.74u l=0.13u
X38 VDD.t231 a_11603_1842# a_12037_1842# VDD.t25 sg13_lv_pmos ad=0.2128p pd=1.5u as=0.3808p ps=2.92u w=1.12u l=0.13u
X39 VDD.t180 a_3171_311.t3 a_11785_519# VDD.t36 sg13_lv_pmos ad=0.3808p pd=2.92u as=0.3808p ps=2.92u w=1.12u l=0.13u
X40 a_6126_3816# a_6326_4590# VDD.t313 VDD.t1 sg13_lv_pmos ad=0.38p pd=2.38u as=0.38p ps=2.38u w=2u l=1u
X41 a_24393_1842# a_24197_1842# VDD.t163 VDD.t25 sg13_lv_pmos ad=0.3808p pd=2.92u as=0.2128p ps=1.5u w=1.12u l=0.13u
X42 a_5731_289# a_2595_311.t3 a_7390_1044# VSS.t180 sg13_lv_nmos ad=0.2516p pd=2.16u as=0.2516p ps=2.16u w=0.74u l=0.13u
X43 a_10430_1044# a_2595_1047.t7 a_11195_1044# VSS.t73 sg13_lv_nmos ad=0.2516p pd=2.16u as=0.1406p ps=1.12u w=0.74u l=0.13u
X44 a_13306_6305# a_12355_5867# VDD.t235 VDD.t1 sg13_lv_pmos ad=79.8f pd=0.8u as=0.1428p ps=1.52u w=0.42u l=0.13u
X45 a_23355_1044# a_23145_1044# VSS.t115 VSS.t114 sg13_lv_nmos ad=0.1406p pd=1.12u as=0.1665p ps=1.19u w=0.74u l=0.13u
X46 VDD.t267 DELAY_VBIASP a_14751_2470# VDD.t25 sg13_lv_pmos ad=0.3808p pd=2.92u as=0.2128p ps=1.5u w=1.12u l=0.6u
X47 VSS.t343 DELAY_VBIASN a_10191_1842# VSS.t534 sg13_lv_nmos ad=0.2516p pd=2.16u as=0.1406p ps=1.12u w=0.74u l=0.6u
X48 VSS.t129 a_3747_1047.t4 a_21911_1008# VSS.t128 sg13_lv_nmos ad=0.2516p pd=2.16u as=0.2516p ps=2.16u w=0.74u l=0.13u
X49 VSS.t159 a_19963_1842# a_20397_1842# VSS.t423 sg13_lv_nmos ad=0.1406p pd=1.12u as=0.2516p ps=2.16u w=0.74u l=0.13u
X50 a_6126_3816# a_6326_4590# VDD.t318 VDD.t1 sg13_lv_pmos ad=0.38p pd=2.38u as=0.38p ps=2.38u w=2u l=1u
X51 VDD.t5 a_6326_4590# a_6854_5454# VDD.t1 sg13_lv_pmos ad=0.38p pd=2.38u as=0.38p ps=2.38u w=2u l=1u
X52 VDD.t261 DELAY_VBIASP a_4111_2470# VDD.t25 sg13_lv_pmos ad=0.3808p pd=2.92u as=0.2128p ps=1.5u w=1.12u l=0.6u
X53 a_10328_1044# a_9757_1842# VDD.t176 VDD.t36 sg13_lv_pmos ad=0.2128p pd=1.5u as=0.3808p ps=2.92u w=1.12u l=0.13u
X54 a_20968_1044# a_20397_1842# VSS.t161 VSS.t160 sg13_lv_nmos ad=0.1406p pd=1.12u as=0.2516p ps=2.16u w=0.74u l=0.13u
X55 a_22590_1044# a_22564_1008# a_22488_1044# VDD.t36 sg13_lv_pmos ad=0.3808p pd=2.92u as=0.2128p ps=1.5u w=1.12u l=0.13u
X56 VDD.t144 VSS.t19 VDD.t143 VDD.t36 sg13_lv_pmos ad=0.19p pd=1.38u as=0 ps=0 w=1u l=1u
X57 a_8808_1044# a_8237_1842# VDD.t38 VDD.t36 sg13_lv_pmos ad=0.2128p pd=1.5u as=0.3808p ps=2.92u w=1.12u l=0.13u
X58 VDD.t322 a_6326_4590# a_6326_4590# VDD.t1 sg13_lv_pmos ad=0.38p pd=2.38u as=0.38p ps=2.38u w=2u l=1u
X59 a_4157_1313# REF_CLK VDD.t117 VDD.t36 sg13_lv_pmos ad=0.3808p pd=2.92u as=0.3808p ps=2.92u w=1.12u l=0.13u
X60 a_17031_2470# a_16793_1842# a_16923_1842# VDD.t25 sg13_lv_pmos ad=0.2128p pd=1.5u as=0.3808p ps=2.92u w=1.12u l=0.2u
X61 a_11473_1842# a_11277_1842# VSS.t164 VSS.t163 sg13_lv_nmos ad=0.2516p pd=2.16u as=0.1406p ps=1.12u w=0.74u l=0.13u
X62 VSS.t52 VDD.t394 VSS.t50 VSS.t51 sg13_lv_nmos ad=79.8f pd=0.8u as=0 ps=0 w=0.42u l=1u
X63 a_13306_5105# a_13132_5420# VDD.t308 VDD.t1 sg13_lv_pmos ad=79.8f pd=0.8u as=0.1428p ps=1.52u w=0.42u l=0.13u
X64 a_19448_1044# a_18877_1842# VSS.t72 VSS.t172 sg13_lv_nmos ad=0.1406p pd=1.12u as=0.2516p ps=2.16u w=0.74u l=0.13u
X65 a_10430_1044# a_3171_1047.t7 a_11848_1044# VSS.t332 sg13_lv_nmos ad=0.2516p pd=2.16u as=0.1406p ps=1.12u w=0.74u l=0.13u
X66 a_20831_2470# a_20593_1842# a_20723_1842# VDD.t25 sg13_lv_pmos ad=0.2128p pd=1.5u as=0.3808p ps=2.92u w=1.12u l=0.2u
X67 VSS.t26 VDD.t401 VSS.t24 VSS.t25 sg13_lv_nmos ad=79.8f pd=0.8u as=0 ps=0 w=0.42u l=1u
X68 VDD.t168 a_27237_1842# a_27705_1044# VDD.t36 sg13_lv_pmos ad=0.252p pd=1.57u as=0.3808p ps=2.92u w=1.12u l=0.13u
X69 a_5393_1842# a_5197_1842# VDD.t150 VDD.t25 sg13_lv_pmos ad=0.3808p pd=2.92u as=0.2128p ps=1.5u w=1.12u l=0.13u
X70 VDD.t251 DELAY_VBIASP a_17031_2470# VDD.t25 sg13_lv_pmos ad=0.3808p pd=2.92u as=0.2128p ps=1.5u w=1.12u l=0.6u
X71 VDD.t58 a_15108_6109# a_15053_5990# VDD.t1 sg13_lv_pmos ad=1.10612p pd=6.66u as=93.45f ps=0.865u w=0.42u l=0.13u
X72 VDD.t318 a_6326_4590# a_6854_5454# VDD.t1 sg13_lv_pmos ad=0.38p pd=2.38u as=0.38p ps=2.38u w=2u l=1u
X73 a_13818_6292# a_12849_5867# VSS.t595 VSS.t615 sg13_lv_nmos ad=37.8f pd=0.6u as=0.1701p ps=1.65u w=0.42u l=0.13u
X74 VDD.t191 a_26803_1842# a_27237_1842# VDD.t25 sg13_lv_pmos ad=0.2128p pd=1.5u as=0.3808p ps=2.92u w=1.12u l=0.13u
X75 VDD.t226 MUX_SEL1 a_3449_1395# VDD.t36 sg13_lv_pmos ad=0.1918p pd=1.5u as=0.1596p ps=1.22u w=0.84u l=0.13u
X76 a_14851_6228# a_14009_5878# a_13592_5871# VDD.t1 sg13_lv_pmos ad=0.2048p pd=1.63u as=0.34p ps=2.68u w=1u l=0.13u
X77 a_25630_1044# a_2595_1047.t2 a_26395_1044# VSS.t575 sg13_lv_nmos ad=0.2516p pd=2.16u as=0.1406p ps=1.12u w=0.74u l=0.13u
X78 VSS.t119 DELAY_VBIASN a_25391_1842# VSS.t546 sg13_lv_nmos ad=0.2516p pd=2.16u as=0.1406p ps=1.12u w=0.74u l=0.6u
X79 VSS.t519 DELAY_VBIASN VSS.t518 VSS.t510 sg13_lv_nmos ad=1.33p pd=7.38u as=0 ps=0 w=7u l=7u
X80 a_6635_1044# a_6425_1044# VDD.t194 VDD.t36 sg13_lv_pmos ad=0.2128p pd=1.5u as=0.252p ps=1.57u w=1.12u l=0.13u
X81 VDD.t86 DLL_RESETN a_9946_6305# VDD.t1 sg13_lv_pmos ad=0.36237p pd=2.605u as=79.8f ps=0.8u w=0.42u l=0.13u
X82 a_20315_1044# a_20105_1044# VDD.t85 VDD.t36 sg13_lv_pmos ad=0.2128p pd=1.5u as=0.252p ps=1.57u w=1.12u l=0.13u
X83 VDD.t248 a_2595_1047.t9 a_5191_1008# VDD.t36 sg13_lv_pmos ad=0.3808p pd=2.92u as=0.3808p ps=2.92u w=1.12u l=0.13u
X84 a_19311_2470# a_19073_1842# a_19203_1842# VDD.t25 sg13_lv_pmos ad=0.2128p pd=1.5u as=0.3808p ps=2.92u w=1.12u l=0.2u
X85 VSS.t121 a_1721_1395# a_2019_1047.t1 VSS.t122 sg13_lv_nmos ad=0.2812p pd=2.24u as=0.1406p ps=1.12u w=0.74u l=0.13u
X86 a_25528_1044# a_24957_1842# VDD.t234 VDD.t36 sg13_lv_pmos ad=0.2128p pd=1.5u as=0.3808p ps=2.92u w=1.12u l=0.13u
X87 VSS.t313 a_5957_1842# a_6425_1044# VSS.t312 sg13_lv_nmos ad=0.1665p pd=1.19u as=0.2516p ps=2.16u w=0.74u l=0.13u
X88 VSS.t408 a_2019_1047.t6 a_13444_1008# VSS.t407 sg13_lv_nmos ad=0.2516p pd=2.16u as=0.2516p ps=2.16u w=0.74u l=0.13u
X89 a_23111_2470# a_22873_1842# a_23003_1842# VDD.t25 sg13_lv_pmos ad=0.2128p pd=1.5u as=0.3808p ps=2.92u w=1.12u l=0.2u
X90 VSS.t6 VDD.t406 VSS.t6 VSS.t5 sg13_lv_nmos ad=0.1428p pd=1.52u as=0 ps=0 w=0.42u l=1u
X91 VSS.t296 a_15964_289# a_16851_309# VSS.t462 sg13_lv_nmos ad=0.1371p pd=1.12u as=0.2176p ps=1.96u w=0.64u l=0.13u
X92 a_10713_1842# a_10517_1842# VDD.t220 VDD.t25 sg13_lv_pmos ad=0.3808p pd=2.92u as=0.2128p ps=1.5u w=1.12u l=0.13u
X93 VDD.t63 a_17683_1842# a_18117_1842# VDD.t25 sg13_lv_pmos ad=0.2128p pd=1.5u as=0.3808p ps=2.92u w=1.12u l=0.13u
X94 a_16108_289# a_17865_519# a_16510_1044# VDD.t36 sg13_lv_pmos ad=0.3808p pd=2.92u as=0.3808p ps=2.92u w=1.12u l=0.13u
X95 a_26673_1842# a_26477_1842# VSS.t131 VSS.t130 sg13_lv_nmos ad=0.2516p pd=2.16u as=0.1406p ps=1.12u w=0.74u l=0.13u
X96 VDD.t37 a_7803_1842# a_8237_1842# VDD.t25 sg13_lv_pmos ad=0.2128p pd=1.5u as=0.3808p ps=2.92u w=1.12u l=0.13u
X97 a_4248_1044# a_4157_1313# VSS.t234 VSS.t233 sg13_lv_nmos ad=0.1406p pd=1.12u as=0.2516p ps=2.16u w=0.74u l=0.13u
X98 a_16108_289# a_3171_311.t2 a_22590_1044# VSS.t285 sg13_lv_nmos ad=0.2516p pd=2.16u as=0.2516p ps=2.16u w=0.74u l=0.13u
X99 VSS.t241 DELAY_VBIASN a_6391_1842# VSS.t485 sg13_lv_nmos ad=0.2516p pd=2.16u as=0.1406p ps=1.12u w=0.74u l=0.6u
X100 a_16408_1044# a_15837_1842# VDD.t369 VDD.t36 sg13_lv_pmos ad=0.2128p pd=1.5u as=0.3808p ps=2.92u w=1.12u l=0.13u
X101 a_10232_5871# a_10206_5835# VSS.t143 VSS.t142 sg13_lv_nmos ad=0.2516p pd=2.16u as=0.1626p ps=1.415u w=0.74u l=0.13u
X102 a_19550_1044# a_3747_1047.t4 a_21835_1044# VSS.t127 sg13_lv_nmos ad=0.2516p pd=2.16u as=0.1406p ps=1.12u w=0.74u l=0.13u
X103 VSS.t82 DELAY_VBIASN a_20831_1842# VSS.t491 sg13_lv_nmos ad=0.2516p pd=2.16u as=0.1406p ps=1.12u w=0.74u l=0.6u
X104 a_3171_311.t0 a_2873_331# VDD.t346 VDD.t36 sg13_lv_pmos ad=0.2128p pd=1.5u as=0.1918p ps=1.5u w=1.12u l=0.13u
X105 a_15304_4605# a_14851_6228# VDD.t297 VDD.t1 sg13_lv_pmos ad=0.4312p pd=3.01u as=0.2639p ps=1.81u w=1.12u l=0.13u
X106 a_13106_5357# a_12907_5420# VSS.t168 VSS.t585 sg13_lv_nmos ad=0.27427p pd=2.28u as=1.45407p ps=9.445u w=0.795u l=0.13u
X107 a_3747_311.t0 a_3449_331# VDD.t361 VDD.t36 sg13_lv_pmos ad=0.2128p pd=1.5u as=0.1918p ps=1.5u w=1.12u l=0.13u
X108 a_13132_5420# a_13106_5357# VDD.t58 VDD.t1 sg13_lv_pmos ad=0.3927p pd=2.99u as=1.10612p ps=6.66u w=1.155u l=0.13u
X109 a_7390_1044# a_9751_1008# a_9675_1044# VDD.t36 sg13_lv_pmos ad=0.3808p pd=2.92u as=0.2128p ps=1.5u w=1.12u l=0.13u
X110 VSS.t527 DELAY_VBIASN VSS.t525 VSS.t506 sg13_lv_nmos ad=1.33p pd=7.38u as=0 ps=0 w=7u l=7u
X111 a_10191_1842# a_9953_1842# a_10083_1842# VSS.t103 sg13_lv_nmos ad=0.1406p pd=1.12u as=0.2516p ps=2.16u w=0.74u l=0.2u
X112 VSS.t115 a_22677_1842# a_23145_1044# VSS.t184 sg13_lv_nmos ad=0.1665p pd=1.19u as=0.2516p ps=2.16u w=0.74u l=0.13u
X113 a_14751_2470# a_14513_1842# a_14643_1842# VDD.t25 sg13_lv_pmos ad=0.2128p pd=1.5u as=0.3808p ps=2.92u w=1.12u l=0.2u
X114 a_5731_289# a_8745_519# a_7390_1044# VDD.t36 sg13_lv_pmos ad=0.3808p pd=2.92u as=0.3808p ps=2.92u w=1.12u l=0.13u
X115 VDD.t27 VDD.t28 VDD.t29 VDD.t25 sg13_lv_pmos ad=0.2128p pd=1.5u as=0 ps=0 w=1.12u l=0.13u
X116 a_4111_2470# REF_CLK a_4003_1842# VDD.t25 sg13_lv_pmos ad=0.2128p pd=1.5u as=0.3808p ps=2.92u w=1.12u l=0.2u
X117 a_13566_5835# a_14009_5878# a_13306_6305# VSS.t428 sg13_lv_nmos ad=79.8f pd=0.8u as=0.1296p ps=1.52u w=0.42u l=0.13u
X118 a_13306_6305# a_14111_5878# a_13566_5835# VDD.t1 sg13_lv_pmos ad=0.1428p pd=1.52u as=79.8f ps=0.8u w=0.42u l=0.13u
X119 a_13592_5423# a_14111_5227# a_14851_5182# VSS.t260 sg13_lv_nmos ad=0.3473p pd=2.71u as=0.12665p ps=1.145u w=0.74u l=0.13u
X120 a_7673_1842# a_7477_1842# VSS.t148 VSS.t147 sg13_lv_nmos ad=0.2516p pd=2.16u as=0.1406p ps=1.12u w=0.74u l=0.13u
X121 VDD.t92 a_3171_1047.t5 a_18004_1008# VDD.t36 sg13_lv_pmos ad=0.3808p pd=2.92u as=0.3808p ps=2.92u w=1.12u l=0.13u
X122 VDD.t121 a_13123_1842# a_13557_1842# VDD.t25 sg13_lv_pmos ad=0.2128p pd=1.5u as=0.3808p ps=2.92u w=1.12u l=0.13u
X123 VDD.t126 a_3747_311.t2 a_26985_519# VDD.t36 sg13_lv_pmos ad=0.3808p pd=2.92u as=0.3808p ps=2.92u w=1.12u l=0.13u
X124 a_25913_1842# a_25717_1842# VDD.t76 VDD.t25 sg13_lv_pmos ad=0.3808p pd=2.92u as=0.2128p ps=1.5u w=1.12u l=0.13u
X125 a_10430_1044# a_3747_1047.t7 a_12715_1044# VSS.t125 sg13_lv_nmos ad=0.2516p pd=2.16u as=0.1406p ps=1.12u w=0.74u l=0.13u
X126 a_6326_4590# a_5974_5723# a_6126_3816# VSS.t209 sg13_lv_nmos ad=0.38p pd=2.38u as=0.68p ps=4.68u w=2u l=1u
X127 a_14235_1044# a_14025_1044# VDD.t232 VDD.t36 sg13_lv_pmos ad=0.2128p pd=1.5u as=0.252p ps=1.57u w=1.12u l=0.13u
X128 a_24875_1044# a_24665_1044# VSS.t395 VSS.t592 sg13_lv_nmos ad=0.1406p pd=1.12u as=0.1665p ps=1.19u w=0.74u l=0.13u
X129 VSS.t397 DELAY_VBIASN a_11711_1842# VSS.t484 sg13_lv_nmos ad=0.2516p pd=2.16u as=0.1406p ps=1.12u w=0.74u l=0.6u
X130 VDD.t80 a_3747_1047.t7 a_12791_1008# VDD.t36 sg13_lv_pmos ad=0.3808p pd=2.92u as=0.3808p ps=2.92u w=1.12u l=0.13u
X131 VSS.t322 a_2595_1047.t3 a_23431_1008# VSS.t619 sg13_lv_nmos ad=0.2516p pd=2.16u as=0.2516p ps=2.16u w=0.74u l=0.13u
X132 VSS.t113 a_21483_1842# a_21917_1842# VSS.t112 sg13_lv_nmos ad=0.1406p pd=1.12u as=0.2516p ps=2.16u w=0.74u l=0.13u
X133 VSS.t399 a_13557_1842# a_14025_1044# VSS.t581 sg13_lv_nmos ad=0.1665p pd=1.19u as=0.2516p ps=2.16u w=0.74u l=0.13u
X134 a_11848_1044# a_11277_1842# VDD.t95 VDD.t36 sg13_lv_pmos ad=0.2128p pd=1.5u as=0.3808p ps=2.92u w=1.12u l=0.13u
X135 VDD.t210 VSS.t63 VDD.t209 VDD.t36 sg13_lv_pmos ad=0.19p pd=1.38u as=0 ps=0 w=1u l=1u
X136 VDD.t58 a_12907_5186# a_12907_5420# VDD.t1 sg13_lv_pmos ad=1.10612p pd=6.66u as=0.2442p ps=2.06u w=0.66u l=0.13u
X137 a_25391_1842# a_25153_1842# a_25283_1842# VSS.t83 sg13_lv_nmos ad=0.1406p pd=1.12u as=0.2516p ps=2.16u w=0.74u l=0.2u
X138 a_12993_1842# a_12797_1842# VSS.t100 VSS.t99 sg13_lv_nmos ad=0.2516p pd=2.16u as=0.1406p ps=1.12u w=0.74u l=0.13u
X139 DELAY_OUT_LAST a_27997_1842# VDD.t127 VDD.t25 sg13_lv_pmos ad=0.3808p pd=2.92u as=0.2128p ps=1.5u w=1.12u l=0.13u
X140 VDD.t212 VSS.t63 VDD.t211 VDD.t36 sg13_lv_pmos ad=0.34p pd=2.68u as=0 ps=0 w=1u l=1u
X141 VDD.t85 a_19637_1842# a_20105_1044# VDD.t36 sg13_lv_pmos ad=0.252p pd=1.57u as=0.3808p ps=2.92u w=1.12u l=0.13u
X142 a_6854_5454# a_6326_4590# VDD.t315 VDD.t1 sg13_lv_pmos ad=0.38p pd=2.38u as=0.38p ps=2.38u w=2u l=1u
X143 VSS.t78 DELAY_VBIASN a_13991_1842# VSS.t537 sg13_lv_nmos ad=0.2516p pd=2.16u as=0.1406p ps=1.12u w=0.74u l=0.6u
X144 VSS.t50 VDD.t394 VSS.t50 VSS.t49 sg13_lv_nmos ad=0.1428p pd=1.52u as=0 ps=0 w=0.42u l=1u
X145 a_22590_1044# a_3171_1047.t3 a_24008_1044# VSS.t418 sg13_lv_nmos ad=0.2516p pd=2.16u as=0.1406p ps=1.12u w=0.74u l=0.13u
X146 a_6913_1842# a_6717_1842# VDD.t162 VDD.t25 sg13_lv_pmos ad=0.3808p pd=2.92u as=0.2128p ps=1.5u w=1.12u l=0.13u
X147 VDD.t273 DELAY_VBIASP a_18551_2470# VDD.t25 sg13_lv_pmos ad=0.3808p pd=2.92u as=0.2128p ps=1.5u w=1.12u l=0.6u
X148 VSS.t243 a_23763_1842# a_24197_1842# VSS.t242 sg13_lv_nmos ad=0.1406p pd=1.12u as=0.2516p ps=2.16u w=0.74u l=0.13u
X149 VSS.t24 VDD.t401 VSS.t23 VSS.t22 sg13_lv_nmos ad=0.1428p pd=1.52u as=0 ps=0 w=0.42u l=1u
X150 VDD.t123 a_1256_1044# a_2873_1395# VDD.t36 sg13_lv_pmos ad=0.1918p pd=1.5u as=0.1596p ps=1.22u w=0.84u l=0.13u
X151 a_3171_311.t1 a_2873_331# VSS.t153 VSS.t553 sg13_lv_nmos ad=0.1406p pd=1.12u as=0.1331p ps=1.12u w=0.74u l=0.13u
X152 VDD.t347 a_2873_331# a_3171_311.t0 VDD.t36 sg13_lv_pmos ad=0.4256p pd=3u as=0.2128p ps=1.5u w=1.12u l=0.13u
X153 a_16510_1044# a_17351_1008# a_17275_1044# VDD.t36 sg13_lv_pmos ad=0.3808p pd=2.92u as=0.2128p ps=1.5u w=1.12u l=0.13u
X154 a_25630_1044# a_3747_1047.t2 a_27915_1044# VSS.t570 sg13_lv_nmos ad=0.2516p pd=2.16u as=0.1406p ps=1.12u w=0.74u l=0.13u
X155 VSS.t308 DELAY_VBIASN a_26911_1842# VSS.t548 sg13_lv_nmos ad=0.2516p pd=2.16u as=0.1406p ps=1.12u w=0.74u l=0.6u
X156 a_3747_311.t1 a_3449_331# VSS.t589 VSS.t605 sg13_lv_nmos ad=0.1406p pd=1.12u as=0.1331p ps=1.12u w=0.74u l=0.13u
X157 VDD.t374 a_3449_331# a_3747_311.t0 VDD.t36 sg13_lv_pmos ad=0.4256p pd=3u as=0.2128p ps=1.5u w=1.12u l=0.13u
X158 VDD.t254 DELAY_VBIASP a_22351_2470# VDD.t25 sg13_lv_pmos ad=0.3808p pd=2.92u as=0.2128p ps=1.5u w=1.12u l=0.6u
X159 VDD.t350 a_3747_1047.t2 a_27991_1008# VDD.t36 sg13_lv_pmos ad=0.3808p pd=2.92u as=0.3808p ps=2.92u w=1.12u l=0.13u
X160 VDD.t159 VSS.t4 VDD.t158 VDD.t36 sg13_lv_pmos ad=0.19p pd=1.38u as=0 ps=0 w=1u l=1u
X161 a_13019_5831# a_15688_5403# VSS.t203 VSS.t424 sg13_lv_nmos ad=0.2516p pd=2.16u as=0.1406p ps=1.12u w=0.74u l=0.13u
X162 VDD.t349 a_3747_1047.t9 a_6711_1008# VDD.t36 sg13_lv_pmos ad=0.3808p pd=2.92u as=0.3808p ps=2.92u w=1.12u l=0.13u
X163 a_6854_5454# a_6326_4590# VDD.t8 VDD.t1 sg13_lv_pmos ad=0.38p pd=2.38u as=0.38p ps=2.38u w=2u l=1u
X164 a_9772_5843# a_9746_5805# VDD.t58 VDD.t1 sg13_lv_pmos ad=0.3927p pd=2.99u as=1.10612p ps=6.66u w=1.155u l=0.13u
X165 a_6391_1842# a_6153_1842# a_6283_1842# VSS.t335 sg13_lv_nmos ad=0.1406p pd=1.12u as=0.2516p ps=2.16u w=0.74u l=0.2u
X166 a_15273_1842# a_15077_1842# VSS.t494 VSS.t603 sg13_lv_nmos ad=0.2516p pd=2.16u as=0.1406p ps=1.12u w=0.74u l=0.13u
X167 a_19833_1842# a_19637_1842# VDD.t84 VDD.t25 sg13_lv_pmos ad=0.3808p pd=2.92u as=0.2128p ps=1.5u w=1.12u l=0.13u
X168 a_16108_289# a_23945_519# a_22590_1044# VDD.t36 sg13_lv_pmos ad=0.3808p pd=2.92u as=0.3808p ps=2.92u w=1.12u l=0.13u
X169 VDD.t320 a_6326_4590# a_6126_3816# VDD.t1 sg13_lv_pmos ad=0.38p pd=2.38u as=0.38p ps=2.38u w=2u l=1u
X170 a_9193_1842# a_8997_1842# VDD.t240 VDD.t25 sg13_lv_pmos ad=0.3808p pd=2.92u as=0.2128p ps=1.5u w=1.12u l=0.13u
X171 a_24631_2470# a_24393_1842# a_24523_1842# VDD.t25 sg13_lv_pmos ad=0.2128p pd=1.5u as=0.3808p ps=2.92u w=1.12u l=0.2u
X172 VSS.t442 a_15403_1842# a_15837_1842# VSS.t441 sg13_lv_nmos ad=0.1406p pd=1.12u as=0.2516p ps=2.16u w=0.74u l=0.13u
X173 a_8155_1044# a_7945_1044# VSS.t146 VSS.t464 sg13_lv_nmos ad=0.1406p pd=1.12u as=0.1665p ps=1.19u w=0.74u l=0.13u
X174 a_23633_1842# a_23437_1842# VDD.t125 VDD.t25 sg13_lv_pmos ad=0.3808p pd=2.92u as=0.2128p ps=1.5u w=1.12u l=0.13u
X175 VSS.t232 a_4763_1842# a_5197_1842# VSS.t231 sg13_lv_nmos ad=0.1406p pd=1.12u as=0.2516p ps=2.16u w=0.74u l=0.13u
X176 a_27048_1044# a_26477_1842# VSS.t133 VSS.t132 sg13_lv_nmos ad=0.1406p pd=1.12u as=0.2516p ps=2.16u w=0.74u l=0.13u
X177 VDD.t56 a_9323_1842# a_9757_1842# VDD.t25 sg13_lv_pmos ad=0.2128p pd=1.5u as=0.3808p ps=2.92u w=1.12u l=0.13u
X178 a_5768_1044# a_5197_1842# VSS.t269 VSS.t268 sg13_lv_nmos ad=0.1406p pd=1.12u as=0.2516p ps=2.16u w=0.74u l=0.13u
X179 a_6326_4590# a_6126_3816# a_5778_3367# VSS.t274 sg13_lv_nmos ad=0.38p pd=2.38u as=0.68p ps=4.68u w=2u l=1u
X180 DELAY_VBIASN DLL_RESETN VDD.t132 VDD.t14 sg13_lv_pmos ad=0.158p pd=1.245u as=0.272p ps=2.28u w=0.8u l=0.2u
X181 a_7390_1044# a_7364_1008# a_7288_1044# VDD.t36 sg13_lv_pmos ad=0.3808p pd=2.92u as=0.2128p ps=1.5u w=1.12u l=0.13u
X182 VSS.t517 DELAY_VBIASN VSS.t516 VSS.t499 sg13_lv_nmos ad=2.38p pd=14.68u as=0 ps=0 w=7u l=7u
X183 VSS.t67 DELAY_VBIASN a_7911_1842# VSS.t490 sg13_lv_nmos ad=0.2516p pd=2.16u as=0.1406p ps=1.12u w=0.74u l=0.6u
X184 VDD.t55 a_13019_5831# a_12943_5867# VDD.t1 sg13_lv_pmos ad=0.2128p pd=1.5u as=0.2128p ps=1.5u w=1.12u l=0.13u
X185 a_6854_5986# a_15304_4605# DELAY_VBIASN VDD.t14 sg13_lv_pmos ad=0.136p pd=1.14u as=0.158p ps=1.245u w=0.4u l=0.2u
X186 VDD.t50 VSS.t30 VDD.t48 VDD.t36 sg13_lv_pmos ad=0.19p pd=1.38u as=0 ps=0 w=1u l=1u
X187 a_11711_1842# a_11473_1842# a_11603_1842# VSS.t272 sg13_lv_nmos ad=0.1406p pd=1.12u as=0.2516p ps=2.16u w=0.74u l=0.2u
X188 VSS.t395 a_24197_1842# a_24665_1044# VSS.t394 sg13_lv_nmos ad=0.1665p pd=1.19u as=0.2516p ps=2.16u w=0.74u l=0.13u
X189 a_16510_1044# a_3171_1047.t5 a_17928_1044# VSS.t155 sg13_lv_nmos ad=0.2516p pd=2.16u as=0.1406p ps=1.12u w=0.74u l=0.13u
X190 a_15270_5105# a_12849_5867# VSS.t203 VSS.t617 sg13_lv_nmos ad=37.8f pd=0.6u as=79.8f ps=0.8u w=0.42u l=0.13u
X191 a_5974_5723# a_6126_3816# VSS.t278 VSS.t209 sg13_lv_nmos ad=0.38p pd=2.38u as=0.68p ps=4.68u w=2u l=1u
X192 VSS.t19 VDD.t403 VSS.t17 VSS.t18 sg13_lv_nmos ad=79.8f pd=0.8u as=0 ps=0 w=0.42u l=1u
X193 a_5631_2470# a_5393_1842# a_5523_1842# VDD.t25 sg13_lv_pmos ad=0.2128p pd=1.5u as=0.3808p ps=2.92u w=1.12u l=0.2u
X194 a_14513_1842# a_14317_1842# VDD.t41 VDD.t25 sg13_lv_pmos ad=0.3808p pd=2.92u as=0.2128p ps=1.5u w=1.12u l=0.13u
X195 a_4633_1842# a_4437_1842# VDD.t113 VDD.t25 sg13_lv_pmos ad=0.3808p pd=2.92u as=0.2128p ps=1.5u w=1.12u l=0.13u
X196 VSS.t343 a_10083_1842# a_10517_1842# VSS.t468 sg13_lv_nmos ad=0.1406p pd=1.12u as=0.2516p ps=2.16u w=0.74u l=0.13u
X197 VDD.t206 a_2019_1047.t4 a_19524_1008# VDD.t36 sg13_lv_pmos ad=0.3808p pd=2.92u as=0.3808p ps=2.92u w=1.12u l=0.13u
X198 VSS.t623 a_3171_1047.t4 a_21044_1008# VSS.t622 sg13_lv_nmos ad=0.2516p pd=2.16u as=0.2516p ps=2.16u w=0.74u l=0.13u
X199 VSS.t153 a_2873_331# a_3171_311.t1 VSS.t554 sg13_lv_nmos ad=0.2812p pd=2.24u as=0.1406p ps=1.12u w=0.74u l=0.13u
X200 a_13949_5496# a_13592_5423# VDD.t57 VDD.t1 sg13_lv_pmos ad=63f pd=0.72u as=0.1563p ps=1.22u w=0.42u l=0.13u
X201 VSS.t589 a_3449_331# a_3747_311.t1 VSS.t606 sg13_lv_nmos ad=0.2812p pd=2.24u as=0.1406p ps=1.12u w=0.74u l=0.13u
X202 a_15755_1044# a_15545_1044# VDD.t89 VDD.t36 sg13_lv_pmos ad=0.2128p pd=1.5u as=0.252p ps=1.57u w=1.12u l=0.13u
X203 VDD.t182 a_2595_1047.t6 a_14311_1008# VDD.t36 sg13_lv_pmos ad=0.3808p pd=2.92u as=0.3808p ps=2.92u w=1.12u l=0.13u
X204 VSS.t315 DELAY_VBIASN a_24631_1842# VSS.t547 sg13_lv_nmos ad=0.2516p pd=2.16u as=0.1406p ps=1.12u w=0.74u l=0.6u
X205 a_5115_1044# a_4905_1044# VDD.t114 VDD.t36 sg13_lv_pmos ad=0.2128p pd=1.5u as=0.252p ps=1.57u w=1.12u l=0.13u
X206 a_5974_5723# a_6126_3816# VSS.t281 VSS.t209 sg13_lv_nmos ad=0.38p pd=2.38u as=0.68p ps=4.68u w=2u l=1u
X207 VSS.t168 a_12907_5186# a_12907_5186# VSS.t324 sg13_lv_nmos ad=1.45407p pd=9.445u as=0.111p ps=1.34u w=0.3u l=0.13u
X208 a_18551_2470# a_18313_1842# a_18443_1842# VDD.t25 sg13_lv_pmos ad=0.2128p pd=1.5u as=0.3808p ps=2.92u w=1.12u l=0.2u
X209 VDD.t216 VSS.t48 VDD.t215 VDD.t36 sg13_lv_pmos ad=0.19p pd=1.38u as=0 ps=0 w=1u l=1u
X210 a_3171_1047.t1 a_2873_1395# VSS.t208 VSS.t236 sg13_lv_nmos ad=0.1406p pd=1.12u as=0.1331p ps=1.12u w=0.74u l=0.13u
X211 a_13121_5831# a_15688_5867# VSS.t166 VSS.t165 sg13_lv_nmos ad=0.2516p pd=2.16u as=0.1406p ps=1.12u w=0.74u l=0.13u
X212 VSS.t507 DELAY_VBIASN VSS.t509 VSS.t508 sg13_lv_nmos ad=1.33p pd=7.38u as=0 ps=0 w=7u l=7u
X213 VSS.t121 a_2297_1395# a_2595_1047.t1 VSS.t264 sg13_lv_nmos ad=0.2812p pd=2.24u as=0.1406p ps=1.12u w=0.74u l=0.13u
X214 VDD.t201 a_14851_5182# a_15108_5325# VDD.t1 sg13_lv_pmos ad=0.2639p pd=1.81u as=79.8f ps=0.8u w=0.42u l=0.13u
X215 a_22351_2470# a_22113_1842# a_22243_1842# VDD.t25 sg13_lv_pmos ad=0.2128p pd=1.5u as=0.3808p ps=2.92u w=1.12u l=0.2u
X216 VSS.t375 VSS.t375 VSS.t377 VSS.t376 sg13_lv_nmos ad=0.2516p pd=2.16u as=0 ps=0 w=0.74u l=0.13u
X217 a_26911_1842# a_26673_1842# a_26803_1842# VSS.t328 sg13_lv_nmos ad=0.1406p pd=1.12u as=0.2516p ps=2.16u w=0.74u l=0.2u
X218 VSS.t23 a_3171_311.t3 a_11785_519# VSS.t288 sg13_lv_nmos ad=0.2516p pd=2.16u as=0.2516p ps=2.16u w=0.74u l=0.13u
X219 VDD.t78 a_1721_1395# a_2019_1047.t0 VDD.t36 sg13_lv_pmos ad=0.4256p pd=3u as=0.2128p ps=1.5u w=1.12u l=0.13u
X220 a_12656_5864# DLL_RESETN VSS.t87 VSS.t222 sg13_lv_nmos ad=0.2516p pd=2.16u as=0.2516p ps=2.16u w=0.74u l=0.13u
X221 a_14851_6228# a_14009_5878# a_14757_6228# VSS.t94 sg13_lv_nmos ad=0.12665p pd=1.145u as=0.1428p ps=1.52u w=0.42u l=0.13u
X222 VDD.t172 a_16923_1842# a_17357_1842# VDD.t25 sg13_lv_pmos ad=0.2128p pd=1.5u as=0.3808p ps=2.92u w=1.12u l=0.13u
X223 a_2391_1395# MUX_SEL0 a_2297_1395# VSS.t431 sg13_lv_nmos ad=0.1216p pd=1.02u as=0.2176p ps=1.96u w=0.64u l=0.13u
X224 VSS.t121 a_1544_1044# a_1815_1395# VSS.t171 sg13_lv_nmos ad=0.1331p pd=1.12u as=0.1216p ps=1.02u w=0.64u l=0.13u
X225 a_13368_1044# a_12797_1842# VSS.t102 VSS.t101 sg13_lv_nmos ad=0.1406p pd=1.12u as=0.2516p ps=2.16u w=0.74u l=0.13u
X226 a_13400_5105# a_13132_5420# a_13306_5105# VSS.t465 sg13_lv_nmos ad=60.89999f pd=0.71u as=0.1428p ps=1.52u w=0.42u l=0.13u
X227 a_5731_289# a_3171_311.t3 a_10430_1044# VSS.t287 sg13_lv_nmos ad=0.2516p pd=2.16u as=0.2516p ps=2.16u w=0.74u l=0.13u
X228 VDD.t115 a_21157_1842# a_21625_1044# VDD.t36 sg13_lv_pmos ad=0.252p pd=1.57u as=0.3808p ps=2.92u w=1.12u l=0.13u
X229 VDD.t257 DELAY_VBIASP a_10951_2470# VDD.t25 sg13_lv_pmos ad=0.3808p pd=2.92u as=0.2128p ps=1.5u w=1.12u l=0.6u
X230 VSS.t442 DELAY_VBIASN a_15511_1842# VSS.t489 sg13_lv_nmos ad=0.2516p pd=2.16u as=0.1406p ps=1.12u w=0.74u l=0.6u
X231 a_6326_4590# a_6326_4590# VDD.t311 VDD.t1 sg13_lv_pmos ad=0.38p pd=2.38u as=0.38p ps=2.38u w=2u l=1u
X232 VSS.t523 DELAY_VBIASN VSS.t517 VSS.t502 sg13_lv_nmos ad=1.33p pd=7.38u as=0 ps=0 w=7u l=7u
X233 VDD.t53 a_20723_1842# a_21157_1842# VDD.t25 sg13_lv_pmos ad=0.2128p pd=1.5u as=0.3808p ps=2.92u w=1.12u l=0.13u
X234 VSS.t119 a_25283_1842# a_25717_1842# VSS.t118 sg13_lv_nmos ad=0.1406p pd=1.12u as=0.2516p ps=2.16u w=0.74u l=0.13u
X235 a_4350_1044# a_3747_1047.t9 a_6635_1044# VSS.t568 sg13_lv_nmos ad=0.2516p pd=2.16u as=0.1406p ps=1.12u w=0.74u l=0.13u
X236 VSS.t311 DELAY_VBIASN a_5631_1842# VSS.t498 sg13_lv_nmos ad=0.2516p pd=2.16u as=0.1406p ps=1.12u w=0.74u l=0.6u
X237 VDD.t378 a_2019_1047.t9 a_4324_1008# VDD.t36 sg13_lv_pmos ad=0.3808p pd=2.92u as=0.3808p ps=2.92u w=1.12u l=0.13u
X238 a_12849_5867# a_12656_5864# VSS.t87 VSS.t318 sg13_lv_nmos ad=0.1406p pd=1.12u as=0.2516p ps=2.16u w=0.74u l=0.13u
X239 a_16510_1044# a_18871_1008# a_18795_1044# VDD.t36 sg13_lv_pmos ad=0.3808p pd=2.92u as=0.2128p ps=1.5u w=1.12u l=0.13u
X240 a_19550_1044# a_2595_1047.t4 a_20315_1044# VSS.t297 sg13_lv_nmos ad=0.2516p pd=2.16u as=0.1406p ps=1.12u w=0.74u l=0.13u
X241 VDD.t315 a_6326_4590# a_6126_3816# VDD.t1 sg13_lv_pmos ad=0.38p pd=2.38u as=0.38p ps=2.38u w=2u l=1u
X242 VDD.t58 a_11491_6228# a_11748_6109# VDD.t1 sg13_lv_pmos ad=1.10612p pd=6.66u as=79.8f ps=0.8u w=0.42u l=0.13u
X243 a_12355_5867# a_12158_5867# VDD.t66 VDD.t1 sg13_lv_pmos ad=0.3808p pd=2.92u as=0.2128p ps=1.5u w=1.12u l=0.13u
X244 VDD.t278 DELAY_VBIASP a_23871_2470# VDD.t25 sg13_lv_pmos ad=0.3808p pd=2.92u as=0.2128p ps=1.5u w=1.12u l=0.6u
X245 VSS.t146 a_7477_1842# a_7945_1044# VSS.t145 sg13_lv_nmos ad=0.1665p pd=1.19u as=0.2516p ps=2.16u w=0.74u l=0.13u
X246 a_11910_6305# DLL_RESETN VSS.t87 VSS.t110 sg13_lv_nmos ad=37.8f pd=0.6u as=79.8f ps=0.8u w=0.42u l=0.13u
X247 VSS.t513 DELAY_VBIASN VSS.t515 VSS.t514 sg13_lv_nmos ad=1.33p pd=7.38u as=0 ps=0 w=7u l=7u
X248 a_13231_2470# a_12993_1842# a_13123_1842# VDD.t25 sg13_lv_pmos ad=0.2128p pd=1.5u as=0.3808p ps=2.92u w=1.12u l=0.2u
X249 VDD.t158 VSS.t1 VDD.t340 VDD.t36 sg13_lv_pmos ad=0.34p pd=2.68u as=0 ps=0 w=1u l=1u
X250 a_6326_4590# a_6126_3816# a_5778_3367# VSS.t274 sg13_lv_nmos ad=0.38p pd=2.38u as=0.68p ps=4.68u w=2u l=1u
X251 a_12233_1842# a_12037_1842# VDD.t231 VDD.t25 sg13_lv_pmos ad=0.3808p pd=2.92u as=0.2128p ps=1.5u w=1.12u l=0.13u
X252 a_7911_1842# a_7673_1842# a_7803_1842# VSS.t597 sg13_lv_nmos ad=0.1406p pd=1.12u as=0.2516p ps=2.16u w=0.74u l=0.2u
X253 a_16793_1842# a_16597_1842# VSS.t117 VSS.t551 sg13_lv_nmos ad=0.2516p pd=2.16u as=0.1406p ps=1.12u w=0.74u l=0.13u
X254 VDD.t106 a_3747_311.t3 a_14825_519# VDD.t36 sg13_lv_pmos ad=0.3808p pd=2.92u as=0.3808p ps=2.92u w=1.12u l=0.13u
X255 VDD.t365 a_12849_5867# a_13306_6305# VDD.t1 sg13_lv_pmos ad=0.36237p pd=2.605u as=79.8f ps=0.8u w=0.42u l=0.13u
X256 VDD.t9 VDD.t0 VDD.t8 VDD.t1 sg13_lv_pmos ad=0.68p pd=4.68u as=0 ps=0 w=2u l=1u
X257 VSS.t217 a_27563_1842# a_27997_1842# VSS.t316 sg13_lv_nmos ad=0.1406p pd=1.12u as=0.2516p ps=2.16u w=0.74u l=0.13u
X258 a_9675_1044# a_9465_1044# VSS.t85 VSS.t84 sg13_lv_nmos ad=0.1406p pd=1.12u as=0.1665p ps=1.19u w=0.74u l=0.13u
X259 VDD.t311 a_6326_4590# a_6854_5986# VDD.t1 sg13_lv_pmos ad=0.38p pd=2.38u as=0.38p ps=2.38u w=2u l=1u
X260 a_20593_1842# a_20397_1842# VSS.t159 VSS.t158 sg13_lv_nmos ad=0.2516p pd=2.16u as=0.1406p ps=1.12u w=0.74u l=0.13u
X261 VSS.t69 a_2595_1047.t8 a_8231_1008# VSS.t303 sg13_lv_nmos ad=0.2516p pd=2.16u as=0.2516p ps=2.16u w=0.74u l=0.13u
X262 VSS.t241 a_6283_1842# a_6717_1842# VSS.t240 sg13_lv_nmos ad=0.1406p pd=1.12u as=0.2516p ps=2.16u w=0.74u l=0.13u
X263 a_10430_1044# a_10404_1008# a_10328_1044# VDD.t36 sg13_lv_pmos ad=0.3808p pd=2.92u as=0.2128p ps=1.5u w=1.12u l=0.13u
X264 VDD.t280 DELAY_VBIASP a_26151_2470# VDD.t25 sg13_lv_pmos ad=0.3808p pd=2.92u as=0.2128p ps=1.5u w=1.12u l=0.6u
X265 a_7390_1044# a_8884_1008# a_8808_1044# VDD.t36 sg13_lv_pmos ad=0.3808p pd=2.92u as=0.2128p ps=1.5u w=1.12u l=0.13u
X266 a_11491_6228# a_10649_5878# a_11397_6228# VSS.t110 sg13_lv_nmos ad=0.12665p pd=1.145u as=0.1428p ps=1.52u w=0.42u l=0.13u
X267 VDD.t264 DELAY_VBIASP a_4871_2470# VDD.t25 sg13_lv_pmos ad=0.3808p pd=2.92u as=0.2128p ps=1.5u w=1.12u l=0.6u
X268 a_6126_3816# a_6126_3816# VSS.t276 VSS.t274 sg13_lv_nmos ad=0.38p pd=2.38u as=0.68p ps=4.68u w=2u l=1u
X269 a_3449_331# MUX_SEL2 VDD.t136 VDD.t36 sg13_lv_pmos ad=0.1596p pd=1.22u as=0.2856p ps=2.36u w=0.84u l=0.13u
X270 VDD.t339 VSS.t41 VDD.t337 VDD.t36 sg13_lv_pmos ad=0.19p pd=1.38u as=0 ps=0 w=1u l=1u
X271 a_19073_1842# a_18877_1842# VSS.t174 VSS.t173 sg13_lv_nmos ad=0.2516p pd=2.16u as=0.1406p ps=1.12u w=0.74u l=0.13u
X272 VDD.t89 a_15077_1842# a_15545_1044# VDD.t36 sg13_lv_pmos ad=0.252p pd=1.57u as=0.3808p ps=2.92u w=1.12u l=0.13u
X273 a_19550_1044# a_2019_1047.t4 a_19448_1044# VSS.t336 sg13_lv_nmos ad=0.2516p pd=2.16u as=0.1406p ps=1.12u w=0.74u l=0.13u
X274 VDD.t59 a_12849_5867# a_13306_5105# VDD.t1 sg13_lv_pmos ad=0.36237p pd=2.605u as=79.8f ps=0.8u w=0.42u l=0.13u
X275 VDD.t32 VDD.t30 VDD.t31 VDD.t25 sg13_lv_pmos ad=0.3808p pd=2.92u as=0 ps=0 w=1.12u l=0.6u
X276 VSS.t63 VDD.t391 VSS.t61 VSS.t62 sg13_lv_nmos ad=79.8f pd=0.8u as=0 ps=0 w=0.42u l=1u
X277 a_13592_5871# a_13566_5835# VSS.t595 VSS.t594 sg13_lv_nmos ad=0.2516p pd=2.16u as=0.1626p ps=1.415u w=0.74u l=0.13u
X278 VSS.t139 a_19203_1842# a_19637_1842# VSS.t246 sg13_lv_nmos ad=0.1406p pd=1.12u as=0.2516p ps=2.16u w=0.74u l=0.13u
X279 VDD.t335 VSS.t41 VDD.t52 VDD.t36 sg13_lv_pmos ad=0.19p pd=1.38u as=0 ps=0 w=1u l=1u
X280 a_15108_6109# a_12849_5867# VDD.t58 VDD.t1 sg13_lv_pmos ad=79.8f pd=0.8u as=1.03698p ps=6.245u w=0.42u l=0.13u
X281 VDD.t146 VSS.t19 VDD.t145 VDD.t36 sg13_lv_pmos ad=0.34p pd=2.68u as=0 ps=0 w=1u l=1u
X282 VSS.t95 a_15108_6109# a_14757_6228# VSS.t94 sg13_lv_nmos ad=79.8f pd=0.8u as=0.1428p ps=1.52u w=0.42u l=0.13u
X283 a_27433_1842# a_27237_1842# VDD.t191 VDD.t25 sg13_lv_pmos ad=0.3808p pd=2.92u as=0.2128p ps=1.5u w=1.12u l=0.13u
X284 VDD.t346 a_1256_289# a_2873_331# VDD.t36 sg13_lv_pmos ad=0.1918p pd=1.5u as=0.1596p ps=1.22u w=0.84u l=0.13u
X285 a_13470_1044# a_2595_1047.t6 a_14235_1044# VSS.t292 sg13_lv_nmos ad=0.2516p pd=2.16u as=0.1406p ps=1.12u w=0.74u l=0.13u
X286 VSS.t567 a_9444_4590# a_9444_4590# VSS.t558 sg13_lv_nmos ad=0.68p pd=4.68u as=0.38p ps=2.38u w=2u l=1u
X287 VSS.t411 a_8563_1842# a_8997_1842# VSS.t480 sg13_lv_nmos ad=0.1406p pd=1.12u as=0.2516p ps=2.16u w=0.74u l=0.13u
X288 VSS.t369 VSS.t369 VSS.t371 VSS.t370 sg13_lv_nmos ad=0.2516p pd=2.16u as=0 ps=0 w=0.74u l=0.13u
X289 VSS.t205 DELAY_VBIASN a_13231_1842# VSS.t538 sg13_lv_nmos ad=0.2516p pd=2.16u as=0.1406p ps=1.12u w=0.74u l=0.6u
X290 VDD.t205 a_3171_1047.t7 a_11924_1008# VDD.t36 sg13_lv_pmos ad=0.3808p pd=2.92u as=0.3808p ps=2.92u w=1.12u l=0.13u
X291 VSS.t438 a_2019_1047.t3 a_22564_1008# VSS.t437 sg13_lv_nmos ad=0.2516p pd=2.16u as=0.2516p ps=2.16u w=0.74u l=0.13u
X292 a_15053_5420# a_14111_5227# a_14851_5182# VDD.t1 sg13_lv_pmos ad=93.45f pd=0.865u as=0.2048p ps=1.63u w=0.42u l=0.13u
X293 VSS.t368 VSS.t364 VSS.t364 VSS.t366 sg13_lv_nmos ad=0.1406p pd=1.12u as=0 ps=0 w=0.74u l=0.13u
X294 VSS.t211 a_23003_1842# a_23437_1842# VSS.t210 sg13_lv_nmos ad=0.1406p pd=1.12u as=0.2516p ps=2.16u w=0.74u l=0.13u
X295 VSS.t63 VDD.t390 VSS.t63 VSS.t64 sg13_lv_nmos ad=0.1428p pd=1.52u as=0 ps=0 w=0.42u l=1u
X296 VDD.t265 DELAY_VBIASP a_7151_2470# VDD.t25 sg13_lv_pmos ad=0.3808p pd=2.92u as=0.2128p ps=1.5u w=1.12u l=0.6u
X297 a_5778_3367# VSS.t90 VSS.t89 rppd l=32u w=1u
X298 a_25630_1044# a_25604_1008# a_25528_1044# VDD.t36 sg13_lv_pmos ad=0.3808p pd=2.92u as=0.2128p ps=1.5u w=1.12u l=0.13u
X299 a_10206_5835# a_10649_5878# a_10589_5914# VDD.t1 sg13_lv_pmos ad=79.8f pd=0.8u as=63f ps=0.72u w=0.42u l=0.13u
X300 a_15511_1842# a_15273_1842# a_15403_1842# VSS.t248 sg13_lv_nmos ad=0.1406p pd=1.12u as=0.2516p ps=2.16u w=0.74u l=0.2u
X301 a_10520_6292# a_10751_5878# a_10206_5835# VSS.t144 sg13_lv_nmos ad=0.2373p pd=1.97u as=79.8f ps=0.8u w=0.42u l=0.13u
X302 a_11693_5990# a_10751_5878# a_11491_6228# VDD.t1 sg13_lv_pmos ad=93.45f pd=0.865u as=0.2048p ps=1.63u w=0.42u l=0.13u
X303 a_18313_1842# a_18117_1842# VDD.t63 VDD.t25 sg13_lv_pmos ad=0.3808p pd=2.92u as=0.2128p ps=1.5u w=1.12u l=0.13u
X304 a_5731_289# a_11785_519# a_10430_1044# VDD.t36 sg13_lv_pmos ad=0.3808p pd=2.92u as=0.3808p ps=2.92u w=1.12u l=0.13u
X305 VSS.t4 VDD.t407 VSS.t2 VSS.t3 sg13_lv_nmos ad=79.8f pd=0.8u as=0 ps=0 w=0.42u l=1u
X306 a_9431_2470# a_9193_1842# a_9323_1842# VDD.t25 sg13_lv_pmos ad=0.2128p pd=1.5u as=0.3808p ps=2.92u w=1.12u l=0.2u
X307 a_17275_1044# a_17065_1044# VSS.t347 VSS.t346 sg13_lv_nmos ad=0.1406p pd=1.12u as=0.1665p ps=1.19u w=0.74u l=0.13u
X308 VDD.t215 VSS.t45 VDD.t389 VDD.t36 sg13_lv_pmos ad=0.34p pd=2.68u as=0 ps=0 w=1u l=1u
X309 VSS.t457 a_3747_1047.t6 a_15831_1008# VSS.t456 sg13_lv_nmos ad=0.2516p pd=2.16u as=0.2516p ps=2.16u w=0.74u l=0.13u
X310 a_23871_2470# a_23633_1842# a_23763_1842# VDD.t25 sg13_lv_pmos ad=0.2128p pd=1.5u as=0.3808p ps=2.92u w=1.12u l=0.2u
X311 VSS.t78 a_13883_1842# a_14317_1842# VSS.t481 sg13_lv_nmos ad=0.1406p pd=1.12u as=0.2516p ps=2.16u w=0.74u l=0.13u
X312 VSS.t214 a_3747_311.t2 a_26985_519# VSS.t213 sg13_lv_nmos ad=0.2516p pd=2.16u as=0.2516p ps=2.16u w=0.74u l=0.13u
X313 a_8433_1842# a_8237_1842# VDD.t37 VDD.t25 sg13_lv_pmos ad=0.3808p pd=2.92u as=0.2128p ps=1.5u w=1.12u l=0.13u
X314 VDD.t102 a_18443_1842# a_18877_1842# VDD.t25 sg13_lv_pmos ad=0.2128p pd=1.5u as=0.3808p ps=2.92u w=1.12u l=0.13u
X315 a_22113_1842# a_21917_1842# VDD.t67 VDD.t25 sg13_lv_pmos ad=0.3808p pd=2.92u as=0.2128p ps=1.5u w=1.12u l=0.13u
X316 a_4350_1044# a_2019_1047.t9 a_4248_1044# VSS.t610 sg13_lv_nmos ad=0.2516p pd=2.16u as=0.1406p ps=1.12u w=0.74u l=0.13u
X317 a_14888_1044# a_14317_1842# VSS.t80 VSS.t79 sg13_lv_nmos ad=0.1406p pd=1.12u as=0.2516p ps=2.16u w=0.74u l=0.13u
X318 a_13880_5118# a_13592_5423# a_13818_5118# VSS.t93 sg13_lv_nmos ad=0.1428p pd=1.52u as=37.8f ps=0.6u w=0.42u l=0.13u
X319 a_16108_289# a_3747_311.t2 a_25630_1044# VSS.t212 sg13_lv_nmos ad=0.2516p pd=2.16u as=0.2516p ps=2.16u w=0.74u l=0.13u
X320 VDD.t272 DELAY_VBIASP a_12471_2470# VDD.t25 sg13_lv_pmos ad=0.3808p pd=2.92u as=0.2128p ps=1.5u w=1.12u l=0.6u
X321 VSS.t188 a_4003_1842# a_4437_1842# VSS.t582 sg13_lv_nmos ad=0.1406p pd=1.12u as=0.2516p ps=2.16u w=0.74u l=0.13u
X322 a_16510_1044# a_16484_1008# a_16408_1044# VDD.t36 sg13_lv_pmos ad=0.3808p pd=2.92u as=0.2128p ps=1.5u w=1.12u l=0.13u
X323 VSS.t87 a_13121_5831# a_13045_6215# VSS.t86 sg13_lv_nmos ad=0.2516p pd=2.16u as=0.1406p ps=1.12u w=0.74u l=0.13u
X324 VDD.t203 a_14851_5182# a_15688_5403# VDD.t1 sg13_lv_pmos ad=0.2128p pd=1.5u as=0.3864p ps=2.93u w=1.12u l=0.13u
X325 VDD.t112 a_22243_1842# a_22677_1842# VDD.t25 sg13_lv_pmos ad=0.2128p pd=1.5u as=0.3808p ps=2.92u w=1.12u l=0.13u
X326 VDD.t181 a_3171_1047.t2 a_27124_1008# VDD.t36 sg13_lv_pmos ad=0.3808p pd=2.92u as=0.3808p ps=2.92u w=1.12u l=0.13u
X327 VDD.t361 MUX_SEL3 a_3449_331# VDD.t36 sg13_lv_pmos ad=0.1918p pd=1.5u as=0.1596p ps=1.22u w=0.84u l=0.13u
X328 a_2595_311.t0 a_2297_331# VDD.t90 VDD.t36 sg13_lv_pmos ad=0.2128p pd=1.5u as=0.1918p ps=1.5u w=1.12u l=0.13u
X329 a_10430_1044# a_11271_1008# a_11195_1044# VDD.t36 sg13_lv_pmos ad=0.3808p pd=2.92u as=0.2128p ps=1.5u w=1.12u l=0.13u
X330 a_14009_5084# DELAY_OUT_LAST VSS.t168 VSS.t167 sg13_lv_nmos ad=0.2516p pd=2.16u as=1.45407p ps=9.445u w=0.74u l=0.13u
X331 a_23355_1044# a_23145_1044# VDD.t74 VDD.t36 sg13_lv_pmos ad=0.2128p pd=1.5u as=0.252p ps=1.57u w=1.12u l=0.13u
X332 VDD.t81 a_3747_1047.t4 a_21911_1008# VDD.t36 sg13_lv_pmos ad=0.3808p pd=2.92u as=0.3808p ps=2.92u w=1.12u l=0.13u
X333 VSS.t85 a_8997_1842# a_9465_1044# VSS.t409 sg13_lv_nmos ad=0.1665p pd=1.19u as=0.2516p ps=2.16u w=0.74u l=0.13u
X334 a_13592_5423# a_13566_5328# VDD.t59 VDD.t1 sg13_lv_pmos ad=0.34p pd=2.68u as=0.36237p ps=2.605u w=1u l=0.13u
X335 a_6126_3816# a_5974_5723# a_6326_4590# VSS.t209 sg13_lv_nmos ad=0.68p pd=4.68u as=0.38p ps=2.38u w=2u l=1u
X336 a_20968_1044# a_20397_1842# VDD.t94 VDD.t36 sg13_lv_pmos ad=0.2128p pd=1.5u as=0.3808p ps=2.92u w=1.12u l=0.13u
X337 a_10951_1842# a_10713_1842# a_10843_1842# VSS.t425 sg13_lv_nmos ad=0.1406p pd=1.12u as=0.2516p ps=2.16u w=0.74u l=0.2u
X338 VSS.t609 a_2019_1047.t5 a_16484_1008# VSS.t608 sg13_lv_nmos ad=0.2516p pd=2.16u as=0.2516p ps=2.16u w=0.74u l=0.13u
X339 a_26151_2470# a_25913_1842# a_26043_1842# VDD.t25 sg13_lv_pmos ad=0.2128p pd=1.5u as=0.3808p ps=2.92u w=1.12u l=0.2u
X340 a_9444_4590# a_6854_5454# a_6854_5454# VSS.t137 sg13_lv_nmos ad=0.68p pd=4.68u as=0.38p ps=2.38u w=2u l=1u
X341 a_13753_1842# a_13557_1842# VDD.t121 VDD.t25 sg13_lv_pmos ad=0.3808p pd=2.92u as=0.2128p ps=1.5u w=1.12u l=0.13u
X342 VDD.t157 a_1721_331# a_2019_311# VDD.t36 sg13_lv_pmos ad=0.4256p pd=3u as=0.2128p ps=1.5u w=1.12u l=0.13u
X343 a_4871_2470# a_4633_1842# a_4763_1842# VDD.t25 sg13_lv_pmos ad=0.2128p pd=1.5u as=0.3808p ps=2.92u w=1.12u l=0.2u
X344 VSS.t179 a_3171_1047.t9 a_5844_1008# VSS.t178 sg13_lv_nmos ad=0.2516p pd=2.16u as=0.2516p ps=2.16u w=0.74u l=0.13u
X345 VSS.t30 VDD.t399 VSS.t30 VSS.t32 sg13_lv_nmos ad=79.8f pd=0.8u as=0 ps=0 w=0.42u l=1u
X346 VDD.t110 a_2595_311.t2 a_20905_519# VDD.t36 sg13_lv_pmos ad=0.3808p pd=2.92u as=0.3808p ps=2.92u w=1.12u l=0.13u
X347 VDD.t91 a_2297_331# a_2595_311.t0 VDD.t36 sg13_lv_pmos ad=0.4256p pd=3u as=0.2128p ps=1.5u w=1.12u l=0.13u
X348 a_14009_5084# DELAY_OUT_LAST VDD.t58 VDD.t1 sg13_lv_pmos ad=0.4088p pd=2.97u as=1.10612p ps=6.66u w=1.12u l=0.13u
X349 VSS.t75 a_2595_1047.t7 a_11271_1008# VSS.t74 sg13_lv_nmos ad=0.2516p pd=2.16u as=0.2516p ps=2.16u w=0.74u l=0.13u
X350 VSS.t139 DELAY_VBIASN a_19311_1842# VSS.t492 sg13_lv_nmos ad=0.2516p pd=2.16u as=0.1406p ps=1.12u w=0.74u l=0.6u
X351 VSS.t559 a_9444_4590# a_9444_3912# VSS.t558 sg13_lv_nmos ad=0.68p pd=4.68u as=0.38p ps=2.38u w=2u l=1u
X352 a_13880_5118# a_14111_5227# a_13566_5328# VSS.t259 sg13_lv_nmos ad=0.2373p pd=1.97u as=79.8f ps=0.8u w=0.42u l=0.13u
X353 VDD.t195 a_24523_1842# a_24957_1842# VDD.t25 sg13_lv_pmos ad=0.2128p pd=1.5u as=0.3808p ps=2.92u w=1.12u l=0.13u
X354 VSS.t267 a_3747_1047.t8 a_9751_1008# VSS.t574 sg13_lv_nmos ad=0.2516p pd=2.16u as=0.2516p ps=2.16u w=0.74u l=0.13u
X355 VSS.t92 DELAY_VBIASN a_9431_1842# VSS.t535 sg13_lv_nmos ad=0.2516p pd=2.16u as=0.1406p ps=1.12u w=0.74u l=0.6u
X356 a_19448_1044# a_18877_1842# VDD.t101 VDD.t36 sg13_lv_pmos ad=0.2128p pd=1.5u as=0.3808p ps=2.92u w=1.12u l=0.13u
X357 VSS.t87 a_11491_6228# a_12158_5867# VSS.t111 sg13_lv_nmos ad=0.1406p pd=1.12u as=0.2516p ps=2.16u w=0.74u l=0.13u
X358 a_13566_5328# a_14009_5084# a_13949_5496# VDD.t1 sg13_lv_pmos ad=79.8f pd=0.8u as=63f ps=0.72u w=0.42u l=0.13u
X359 VSS.t211 DELAY_VBIASN a_23111_1842# VSS.t544 sg13_lv_nmos ad=0.2516p pd=2.16u as=0.1406p ps=1.12u w=0.74u l=0.6u
X360 a_10430_1044# a_11924_1008# a_11848_1044# VDD.t36 sg13_lv_pmos ad=0.3808p pd=2.92u as=0.2128p ps=1.5u w=1.12u l=0.13u
X361 VDD.t282 DELAY_VBIASP a_27671_2470# VDD.t25 sg13_lv_pmos ad=0.3808p pd=2.92u as=0.2128p ps=1.5u w=1.12u l=0.6u
X362 a_6854_5986# a_6326_4590# VDD.t2 VDD.t1 sg13_lv_pmos ad=0.38p pd=2.38u as=0.38p ps=2.38u w=2u l=1u
X363 VSS.t521 DELAY_VBIASN DELAY_VBIASP VSS.t520 sg13_lv_nmos ad=0.2516p pd=2.16u as=0.6808p ps=3.32u w=0.74u l=0.6u
X364 a_25630_1044# a_26471_1008# a_26395_1044# VDD.t36 sg13_lv_pmos ad=0.3808p pd=2.92u as=0.2128p ps=1.5u w=1.12u l=0.13u
X365 VSS.t503 DELAY_VBIASN VSS.t505 VSS.t504 sg13_lv_nmos ad=1.33p pd=7.38u as=0 ps=0 w=7u l=7u
X366 a_10040_6305# a_9772_5843# a_9946_6305# VSS.t235 sg13_lv_nmos ad=60.89999f pd=0.71u as=0.1428p ps=1.52u w=0.42u l=0.13u
X367 a_7151_2470# a_6913_1842# a_7043_1842# VDD.t25 sg13_lv_pmos ad=0.2128p pd=1.5u as=0.3808p ps=2.92u w=1.12u l=0.2u
X368 a_16033_1842# a_15837_1842# VDD.t293 VDD.t25 sg13_lv_pmos ad=0.3808p pd=2.92u as=0.2128p ps=1.5u w=1.12u l=0.13u
X369 VDD.t313 a_6326_4590# a_6326_4590# VDD.t1 sg13_lv_pmos ad=0.38p pd=2.38u as=0.38p ps=2.38u w=2u l=1u
X370 VDD.t244 a_15964_289# a_16851_309# VDD.t36 sg13_lv_pmos ad=0.2086p pd=1.5u as=0.34p ps=2.68u w=1u l=0.13u
X371 VDD.t337 VSS.t41 VDD.t336 VDD.t36 sg13_lv_pmos ad=0.34p pd=2.68u as=0 ps=0 w=1u l=1u
X372 a_15464_3684# a_14851_5182# VSS.t203 VSS.t326 sg13_lv_nmos ad=0.2849p pd=2.25u as=0.2516p ps=2.16u w=0.74u l=0.13u
X373 VSS.t397 a_11603_1842# a_12037_1842# VSS.t396 sg13_lv_nmos ad=0.1406p pd=1.12u as=0.2516p ps=2.16u w=0.74u l=0.13u
X374 VSS.t48 VDD.t395 VSS.t46 VSS.t47 sg13_lv_nmos ad=79.8f pd=0.8u as=0 ps=0 w=0.42u l=1u
X375 VDD.t143 VSS.t17 VDD.t185 VDD.t36 sg13_lv_pmos ad=0.34p pd=2.68u as=0 ps=0 w=1u l=1u
X376 VDD.t194 a_5957_1842# a_6425_1044# VDD.t36 sg13_lv_pmos ad=0.252p pd=1.57u as=0.3808p ps=2.92u w=1.12u l=0.13u
X377 a_24393_1842# a_24197_1842# VSS.t243 VSS.t393 sg13_lv_nmos ad=0.2516p pd=2.16u as=0.1406p ps=1.12u w=0.74u l=0.13u
X378 a_3747_1047.t1 a_3449_1395# VSS.t389 VSS.t388 sg13_lv_nmos ad=0.1406p pd=1.12u as=0.1331p ps=1.12u w=0.74u l=0.13u
X379 a_1544_1044# MUX_SEL1 VSS.t121 VSS.t433 sg13_lv_nmos ad=0.2516p pd=2.16u as=0.2516p ps=2.16u w=0.74u l=0.13u
X380 VDD.t52 VSS.t39 VDD.t51 VDD.t36 sg13_lv_pmos ad=0.34p pd=2.68u as=0 ps=0 w=1u l=1u
X381 a_3171_1047.t0 a_2873_1395# VDD.t123 VDD.t36 sg13_lv_pmos ad=0.2128p pd=1.5u as=0.1918p ps=1.5u w=1.12u l=0.13u
X382 a_13470_1044# a_3747_1047.t6 a_15755_1044# VSS.t455 sg13_lv_nmos ad=0.2516p pd=2.16u as=0.1406p ps=1.12u w=0.74u l=0.13u
X383 VDD.t328 a_15464_3684# a_9712_3912# VSS.t469 sg13_lv_nmos ad=0.232p pd=2.08u as=0.136p ps=1.14u w=0.4u l=0.2u
X384 VDD.t193 a_5523_1842# a_5957_1842# VDD.t25 sg13_lv_pmos ad=0.2128p pd=1.5u as=0.3808p ps=2.92u w=1.12u l=0.13u
X385 VDD.t174 a_2297_1395# a_2595_1047.t0 VDD.t36 sg13_lv_pmos ad=0.4256p pd=3u as=0.2128p ps=1.5u w=1.12u l=0.13u
X386 VSS.t494 DELAY_VBIASN a_14751_1842# VSS.t493 sg13_lv_nmos ad=0.2516p pd=2.16u as=0.1406p ps=1.12u w=0.74u l=0.6u
X387 a_2967_1395# MUX_SEL1 a_2873_1395# VSS.t434 sg13_lv_nmos ad=0.1216p pd=1.02u as=0.2176p ps=1.96u w=0.64u l=0.13u
X388 a_4350_1044# a_2595_1047.t9 a_5115_1044# VSS.t426 sg13_lv_nmos ad=0.2516p pd=2.16u as=0.1406p ps=1.12u w=0.74u l=0.13u
X389 VDD.t238 a_2019_1047.t6 a_13444_1008# VDD.t36 sg13_lv_pmos ad=0.3808p pd=2.92u as=0.3808p ps=2.92u w=1.12u l=0.13u
X390 VSS.t133 a_2595_1047.t2 a_26471_1008# VSS.t576 sg13_lv_nmos ad=0.2516p pd=2.16u as=0.2516p ps=2.16u w=0.74u l=0.13u
X391 a_2595_311.t1 a_2297_331# VSS.t153 VSS.t152 sg13_lv_nmos ad=0.1406p pd=1.12u as=0.1331p ps=1.12u w=0.74u l=0.13u
X392 VSS.t199 a_14009_5878# a_14111_5878# VSS.t429 sg13_lv_nmos ad=2.39977p pd=15.495u as=0.2516p ps=2.16u w=0.74u l=0.13u
X393 VSS.t188 DELAY_VBIASN a_4111_1842# VSS.t533 sg13_lv_nmos ad=0.2516p pd=2.16u as=0.1406p ps=1.12u w=0.74u l=0.6u
X394 a_2297_1395# MUX_SEL0 VDD.t285 VDD.t36 sg13_lv_pmos ad=0.1596p pd=1.22u as=0.2856p ps=2.36u w=0.84u l=0.13u
X395 VSS.t347 a_16597_1842# a_17065_1044# VSS.t552 sg13_lv_nmos ad=0.1665p pd=1.19u as=0.2516p ps=2.16u w=0.74u l=0.13u
X396 VDD.t268 DELAY_VBIASP a_8671_2470# VDD.t25 sg13_lv_pmos ad=0.3808p pd=2.92u as=0.2128p ps=1.5u w=1.12u l=0.6u
X397 VDD.t376 VSS.t15 VDD.t44 VDD.t36 sg13_lv_pmos ad=0.19p pd=1.38u as=0 ps=0 w=1u l=1u
X398 VDD.t77 a_1544_1044# a_1721_1395# VDD.t36 sg13_lv_pmos ad=0.1918p pd=1.5u as=0.1596p ps=1.22u w=0.84u l=0.13u
X399 a_9444_4590# a_9444_4590# VSS.t566 VSS.t556 sg13_lv_nmos ad=0.38p pd=2.38u as=0.68p ps=4.68u w=2u l=1u
X400 a_4248_1044# a_4157_1313# VDD.t152 VDD.t36 sg13_lv_pmos ad=0.2128p pd=1.5u as=0.3808p ps=2.92u w=1.12u l=0.13u
X401 a_5778_3367# a_6126_3816# a_6326_4590# VSS.t274 sg13_lv_nmos ad=0.68p pd=4.68u as=0.38p ps=2.38u w=2u l=1u
X402 a_12471_2470# a_12233_1842# a_12363_1842# VDD.t25 sg13_lv_pmos ad=0.2128p pd=1.5u as=0.3808p ps=2.92u w=1.12u l=0.2u
X403 a_17031_1842# a_16793_1842# a_16923_1842# VSS.t109 sg13_lv_nmos ad=0.1406p pd=1.12u as=0.2516p ps=2.16u w=0.74u l=0.2u
X404 VSS.t153 a_1721_331# a_2019_311# VSS.t239 sg13_lv_nmos ad=0.2812p pd=2.24u as=0.1406p ps=1.12u w=0.74u l=0.13u
X405 a_19550_1044# a_21911_1008# a_21835_1044# VDD.t36 sg13_lv_pmos ad=0.3808p pd=2.92u as=0.2128p ps=1.5u w=1.12u l=0.13u
X406 a_16108_289# a_26985_519# a_25630_1044# VDD.t36 sg13_lv_pmos ad=0.3808p pd=2.92u as=0.3808p ps=2.92u w=1.12u l=0.13u
X407 VSS.t153 a_2297_331# a_2595_311.t1 VSS.t154 sg13_lv_nmos ad=0.2812p pd=2.24u as=0.1406p ps=1.12u w=0.74u l=0.13u
X408 a_18795_1044# a_18585_1044# VSS.t105 VSS.t108 sg13_lv_nmos ad=0.1406p pd=1.12u as=0.1665p ps=1.19u w=0.74u l=0.13u
X409 a_9444_3912# a_6854_5454# a_9712_3912# VSS.t137 sg13_lv_nmos ad=0.68p pd=4.68u as=0.38p ps=2.38u w=2u l=1u
X410 a_20831_1842# a_20593_1842# a_20723_1842# VSS.t169 sg13_lv_nmos ad=0.1406p pd=1.12u as=0.2516p ps=2.16u w=0.74u l=0.2u
X411 VSS.t2 VDD.t407 VSS.t1 VSS.t0 sg13_lv_nmos ad=0.1428p pd=1.52u as=0 ps=0 w=0.42u l=1u
X412 VDD.t74 a_22677_1842# a_23145_1044# VDD.t36 sg13_lv_pmos ad=0.252p pd=1.57u as=0.3808p ps=2.92u w=1.12u l=0.13u
X413 VSS.t301 a_2595_1047.t5 a_17351_1008# VSS.t300 sg13_lv_nmos ad=0.2516p pd=2.16u as=0.2516p ps=2.16u w=0.74u l=0.13u
X414 a_5393_1842# a_5197_1842# VSS.t232 VSS.t270 sg13_lv_nmos ad=0.2516p pd=2.16u as=0.1406p ps=1.12u w=0.74u l=0.13u
X415 VSS.t262 DELAY_VBIASN a_17031_1842# VSS.t541 sg13_lv_nmos ad=0.2516p pd=2.16u as=0.1406p ps=1.12u w=0.74u l=0.6u
X416 a_25630_1044# a_3171_1047.t2 a_27048_1044# VSS.t289 sg13_lv_nmos ad=0.2516p pd=2.16u as=0.1406p ps=1.12u w=0.74u l=0.13u
X417 VDD.t16 VDD.t13 VDD.t15 VDD.t14 sg13_lv_pmos ad=0.3808p pd=2.92u as=0 ps=0 w=1.12u l=0.13u
X418 a_9953_1842# a_9757_1842# VDD.t56 VDD.t25 sg13_lv_pmos ad=0.3808p pd=2.92u as=0.2128p ps=1.5u w=1.12u l=0.13u
X419 VDD.t96 a_10843_1842# a_11277_1842# VDD.t25 sg13_lv_pmos ad=0.2128p pd=1.5u as=0.3808p ps=2.92u w=1.12u l=0.13u
X420 VSS.t308 a_26803_1842# a_27237_1842# VSS.t307 sg13_lv_nmos ad=0.1406p pd=1.12u as=0.2516p ps=2.16u w=0.74u l=0.13u
X421 a_4350_1044# a_3171_1047.t9 a_5768_1044# VSS.t177 sg13_lv_nmos ad=0.2516p pd=2.16u as=0.1406p ps=1.12u w=0.74u l=0.13u
X422 VDD.t57 a_12849_5867# a_13566_5328# VDD.t1 sg13_lv_pmos ad=0.1563p pd=1.22u as=0.147p ps=1.54u w=0.42u l=0.13u
X423 VDD.t21 VDD.t22 VDD.t23 VDD.t14 sg13_lv_pmos ad=0.2128p pd=1.5u as=0 ps=0 w=1.12u l=0.13u
X424 a_10430_1044# a_12791_1008# a_12715_1044# VDD.t36 sg13_lv_pmos ad=0.3808p pd=2.92u as=0.2128p ps=1.5u w=1.12u l=0.13u
X425 a_19311_1842# a_19073_1842# a_19203_1842# VSS.t273 sg13_lv_nmos ad=0.1406p pd=1.12u as=0.2516p ps=2.16u w=0.74u l=0.2u
X426 a_24875_1044# a_24665_1044# VDD.t230 VDD.t36 sg13_lv_pmos ad=0.2128p pd=1.5u as=0.252p ps=1.57u w=1.12u l=0.13u
X427 VDD.t385 a_2595_1047.t3 a_23431_1008# VDD.t36 sg13_lv_pmos ad=0.3808p pd=2.92u as=0.3808p ps=2.92u w=1.12u l=0.13u
X428 VDD.t58 a_14009_5878# a_14111_5878# VDD.t1 sg13_lv_pmos ad=1.10612p pd=6.66u as=0.3864p ps=2.93u w=1.12u l=0.13u
X429 a_13949_5914# a_13592_5871# VDD.t219 VDD.t1 sg13_lv_pmos ad=63f pd=0.72u as=0.1563p ps=1.22u w=0.42u l=0.13u
X430 VDD.t232 a_13557_1842# a_14025_1044# VDD.t36 sg13_lv_pmos ad=0.252p pd=1.57u as=0.3808p ps=2.92u w=1.12u l=0.13u
X431 a_23111_1842# a_22873_1842# a_23003_1842# VSS.t319 sg13_lv_nmos ad=0.1406p pd=1.12u as=0.2516p ps=2.16u w=0.74u l=0.2u
X432 VSS.t197 a_10649_5878# a_10751_5878# VSS.t258 sg13_lv_nmos ad=2.39977p pd=15.495u as=0.2516p ps=2.16u w=0.74u l=0.13u
X433 a_27671_2470# a_27433_1842# a_27563_1842# VDD.t25 sg13_lv_pmos ad=0.2128p pd=1.5u as=0.3808p ps=2.92u w=1.12u l=0.2u
X434 VSS.t107 a_17683_1842# a_18117_1842# VSS.t249 sg13_lv_nmos ad=0.1406p pd=1.12u as=0.2516p ps=2.16u w=0.74u l=0.13u
X435 VSS.t41 VDD.t396 VSS.t41 VSS.t43 sg13_lv_nmos ad=79.8f pd=0.8u as=0 ps=0 w=0.42u l=1u
X436 a_10713_1842# a_10517_1842# VSS.t343 VSS.t342 sg13_lv_nmos ad=0.2516p pd=2.16u as=0.1406p ps=1.12u w=0.74u l=0.13u
X437 VSS.t252 a_2019_1047.t8 a_7364_1008# VSS.t251 sg13_lv_nmos ad=0.2516p pd=2.16u as=0.2516p ps=2.16u w=0.74u l=0.13u
X438 VSS.t530 DELAY_VBIASN VSS.t519 VSS.t512 sg13_lv_nmos ad=1.33p pd=7.38u as=0 ps=0 w=7u l=7u
X439 VSS.t67 a_7803_1842# a_8237_1842# VSS.t478 sg13_lv_nmos ad=0.1406p pd=1.12u as=0.2516p ps=2.16u w=0.74u l=0.13u
X440 a_13592_5871# a_14111_5878# a_14851_6228# VSS.t94 sg13_lv_nmos ad=0.3473p pd=2.71u as=0.12665p ps=1.145u w=0.74u l=0.13u
X441 a_15304_4605# a_14851_6228# VSS.t450 VSS.t449 sg13_lv_nmos ad=0.2849p pd=2.25u as=0.2516p ps=2.16u w=0.74u l=0.13u
X442 VDD.t255 DELAY_VBIASP a_16271_2470# VDD.t25 sg13_lv_pmos ad=0.3808p pd=2.92u as=0.2128p ps=1.5u w=1.12u l=0.6u
X443 VSS.t41 VDD.t397 VSS.t39 VSS.t40 sg13_lv_nmos ad=79.8f pd=0.8u as=0 ps=0 w=0.42u l=1u
X444 VSS.t19 VDD.t402 VSS.t19 VSS.t20 sg13_lv_nmos ad=0.1428p pd=1.52u as=0 ps=0 w=0.42u l=1u
X445 a_6854_5454# a_6854_5454# a_9444_4590# VSS.t136 sg13_lv_nmos ad=0.38p pd=2.38u as=0.68p ps=4.68u w=2u l=1u
X446 VDD.t82 a_26043_1842# a_26477_1842# VDD.t25 sg13_lv_pmos ad=0.2128p pd=1.5u as=0.3808p ps=2.92u w=1.12u l=0.13u
X447 VDD.t128 DLL_RESETN a_10206_5835# VDD.t1 sg13_lv_pmos ad=0.1563p pd=1.22u as=0.147p ps=1.54u w=0.42u l=0.13u
X448 a_3543_331# MUX_SEL2 a_3449_331# VSS.t226 sg13_lv_nmos ad=0.1216p pd=1.02u as=0.2176p ps=1.96u w=0.64u l=0.13u
X449 a_22488_1044# a_21917_1842# VSS.t129 VSS.t256 sg13_lv_nmos ad=0.1406p pd=1.12u as=0.2516p ps=2.16u w=0.74u l=0.13u
X450 a_14851_5182# a_14009_5084# a_13592_5423# VDD.t1 sg13_lv_pmos ad=0.2048p pd=1.63u as=0.34p ps=2.68u w=1u l=0.13u
X451 VDD.t142 VSS.t8 VDD.t140 VDD.t36 sg13_lv_pmos ad=0.19p pd=1.38u as=0 ps=0 w=1u l=1u
X452 a_22590_1044# a_24084_1008# a_24008_1044# VDD.t36 sg13_lv_pmos ad=0.3808p pd=2.92u as=0.2128p ps=1.5u w=1.12u l=0.13u
X453 VDD.t256 DELAY_VBIASP a_20071_2470# VDD.t25 sg13_lv_pmos ad=0.3808p pd=2.92u as=0.2128p ps=1.5u w=1.12u l=0.6u
X454 a_9444_3912# a_9444_4590# VSS.t557 VSS.t556 sg13_lv_nmos ad=0.38p pd=2.38u as=0.68p ps=4.68u w=2u l=1u
X455 a_14751_1842# a_14513_1842# a_14643_1842# VSS.t350 sg13_lv_nmos ad=0.1406p pd=1.12u as=0.2516p ps=2.16u w=0.74u l=0.2u
X456 VSS.t208 a_2873_1395# a_3171_1047.t1 VSS.t237 sg13_lv_nmos ad=0.2812p pd=2.24u as=0.1406p ps=1.12u w=0.74u l=0.13u
X457 VDD.t208 VSS.t59 VDD.t161 VDD.t36 sg13_lv_pmos ad=0.19p pd=1.38u as=0 ps=0 w=1u l=1u
X458 a_25630_1044# a_27991_1008# a_27915_1044# VDD.t36 sg13_lv_pmos ad=0.3808p pd=2.92u as=0.2128p ps=1.5u w=1.12u l=0.13u
X459 VSS.t380 VSS.t377 VSS.t377 VSS.t378 sg13_lv_nmos ad=0.1406p pd=1.12u as=0 ps=0 w=0.74u l=0.13u
X460 a_4111_1842# REF_CLK a_4003_1842# VSS.t200 sg13_lv_nmos ad=0.1406p pd=1.12u as=0.2516p ps=2.16u w=0.74u l=0.2u
X461 a_8671_2470# a_8433_1842# a_8563_1842# VDD.t25 sg13_lv_pmos ad=0.2128p pd=1.5u as=0.3808p ps=2.92u w=1.12u l=0.2u
X462 a_17553_1842# a_17357_1842# VDD.t172 VDD.t25 sg13_lv_pmos ad=0.3808p pd=2.92u as=0.2128p ps=1.5u w=1.12u l=0.13u
X463 VSS.t121 a_1544_1044# a_2391_1395# VSS.t170 sg13_lv_nmos ad=0.1331p pd=1.12u as=0.1216p ps=1.02u w=0.64u l=0.13u
X464 VSS.t30 a_3747_311.t3 a_14825_519# VSS.t176 sg13_lv_nmos ad=0.2516p pd=2.16u as=0.2516p ps=2.16u w=0.74u l=0.13u
X465 VSS.t153 a_1256_289# a_2967_331# VSS.t599 sg13_lv_nmos ad=0.1331p pd=1.12u as=0.1216p ps=1.02u w=0.64u l=0.13u
X466 a_2019_1047.t1 a_1721_1395# VSS.t121 VSS.t120 sg13_lv_nmos ad=0.1406p pd=1.12u as=0.1331p ps=1.12u w=0.74u l=0.13u
X467 a_15964_289# a_15765_463# a_5731_289# VSS.t593 sg13_lv_nmos ad=0.2183p pd=1.33u as=0.2516p ps=2.16u w=0.74u l=0.13u
X468 a_13470_1044# a_2019_1047.t6 a_13368_1044# VSS.t406 sg13_lv_nmos ad=0.2516p pd=2.16u as=0.1406p ps=1.12u w=0.74u l=0.13u
X469 VDD.t3 VDD.t0 VDD.t2 VDD.t1 sg13_lv_pmos ad=0.68p pd=4.68u as=0 ps=0 w=2u l=1u
X470 VSS.t205 a_13123_1842# a_13557_1842# VSS.t204 sg13_lv_nmos ad=0.1406p pd=1.12u as=0.2516p ps=2.16u w=0.74u l=0.13u
X471 VDD.t209 VSS.t61 VDD.t237 VDD.t36 sg13_lv_pmos ad=0.34p pd=2.68u as=0 ps=0 w=1u l=1u
X472 VSS.t420 a_3171_1047.t3 a_24084_1008# VSS.t419 sg13_lv_nmos ad=0.2516p pd=2.16u as=0.2516p ps=2.16u w=0.74u l=0.13u
X473 a_25913_1842# a_25717_1842# VSS.t119 VSS.t454 sg13_lv_nmos ad=0.2516p pd=2.16u as=0.1406p ps=1.12u w=0.74u l=0.13u
X474 VDD.t58 a_10649_5878# a_10751_5878# VDD.t1 sg13_lv_pmos ad=1.10612p pd=6.66u as=0.3864p ps=2.93u w=1.12u l=0.13u
X475 a_21353_1842# a_21157_1842# VDD.t53 VDD.t25 sg13_lv_pmos ad=0.3808p pd=2.92u as=0.2128p ps=1.5u w=1.12u l=0.13u
X476 VSS.t46 VDD.t395 VSS.t45 VSS.t44 sg13_lv_nmos ad=0.1428p pd=1.52u as=0 ps=0 w=0.42u l=1u
X477 a_2297_331# MUX_SEL2 VDD.t135 VDD.t36 sg13_lv_pmos ad=0.1596p pd=1.22u as=0.2856p ps=2.36u w=0.84u l=0.13u
X478 VDD.t88 a_7043_1842# a_7477_1842# VDD.t25 sg13_lv_pmos ad=0.2128p pd=1.5u as=0.3808p ps=2.92u w=1.12u l=0.13u
X479 a_2873_331# MUX_SEL3 VDD.t360 VDD.t36 sg13_lv_pmos ad=0.1596p pd=1.22u as=0.2856p ps=2.36u w=0.84u l=0.13u
X480 a_10589_5914# a_10232_5871# VDD.t128 VDD.t1 sg13_lv_pmos ad=63f pd=0.72u as=0.1563p ps=1.22u w=0.42u l=0.13u
X481 a_8155_1044# a_7945_1044# VDD.t87 VDD.t36 sg13_lv_pmos ad=0.2128p pd=1.5u as=0.252p ps=1.57u w=1.12u l=0.13u
X482 a_13880_6292# a_13592_5871# a_13818_6292# VSS.t341 sg13_lv_nmos ad=0.1428p pd=1.52u as=37.8f ps=0.6u w=0.42u l=0.13u
X483 VSS.t105 a_18117_1842# a_18585_1044# VSS.t104 sg13_lv_nmos ad=0.1665p pd=1.19u as=0.2516p ps=2.16u w=0.74u l=0.13u
X484 a_27048_1044# a_26477_1842# VDD.t83 VDD.t36 sg13_lv_pmos ad=0.2128p pd=1.5u as=0.3808p ps=2.92u w=1.12u l=0.13u
X485 a_5768_1044# a_5197_1842# VDD.t177 VDD.t36 sg13_lv_pmos ad=0.2128p pd=1.5u as=0.3808p ps=2.92u w=1.12u l=0.13u
X486 a_10232_5871# a_10751_5878# a_11491_6228# VSS.t110 sg13_lv_nmos ad=0.3473p pd=2.71u as=0.12665p ps=1.145u w=0.74u l=0.13u
X487 a_12656_5864# DLL_RESETN VDD.t131 VDD.t1 sg13_lv_pmos ad=0.3808p pd=2.92u as=0.3808p ps=2.92u w=1.12u l=0.13u
X488 a_13991_2470# a_13753_1842# a_13883_1842# VDD.t25 sg13_lv_pmos ad=0.2128p pd=1.5u as=0.3808p ps=2.92u w=1.12u l=0.2u
X489 VSS.t417 a_3171_1047.t6 a_14964_1008# VSS.t416 sg13_lv_nmos ad=0.2516p pd=2.16u as=0.2516p ps=2.16u w=0.74u l=0.13u
X490 VDD.t296 a_2019_311# a_17865_519# VDD.t36 sg13_lv_pmos ad=0.3808p pd=2.92u as=0.3808p ps=2.92u w=1.12u l=0.13u
X491 DELAY_OUT_LAST a_27997_1842# VSS.t217 VSS.t216 sg13_lv_nmos ad=0.2516p pd=2.16u as=0.1406p ps=1.12u w=0.74u l=0.13u
X492 a_11195_1044# a_10985_1044# VSS.t345 VSS.t620 sg13_lv_nmos ad=0.1406p pd=1.12u as=0.1665p ps=1.19u w=0.74u l=0.13u
X493 VDD.t230 a_24197_1842# a_24665_1044# VDD.t36 sg13_lv_pmos ad=0.252p pd=1.57u as=0.3808p ps=2.92u w=1.12u l=0.13u
X494 a_6913_1842# a_6717_1842# VSS.t241 VSS.t473 sg13_lv_nmos ad=0.2516p pd=2.16u as=0.1406p ps=1.12u w=0.74u l=0.13u
X495 VSS.t174 DELAY_VBIASN a_18551_1842# VSS.t483 sg13_lv_nmos ad=0.2516p pd=2.16u as=0.1406p ps=1.12u w=0.74u l=0.6u
X496 a_16510_1044# a_18004_1008# a_17928_1044# VDD.t36 sg13_lv_pmos ad=0.3808p pd=2.92u as=0.2128p ps=1.5u w=1.12u l=0.13u
X497 a_13592_5423# a_13566_5328# VSS.t98 VSS.t97 sg13_lv_nmos ad=0.2516p pd=2.16u as=0.1626p ps=1.415u w=0.74u l=0.13u
X498 VDD.t60 a_12363_1842# a_12797_1842# VDD.t25 sg13_lv_pmos ad=0.2128p pd=1.5u as=0.3808p ps=2.92u w=1.12u l=0.13u
X499 VSS.t589 MUX_SEL3 a_3543_331# VSS.t588 sg13_lv_nmos ad=0.1331p pd=1.12u as=0.1216p ps=1.02u w=0.64u l=0.13u
X500 a_22590_1044# a_2595_1047.t3 a_23355_1044# VSS.t618 sg13_lv_nmos ad=0.2516p pd=2.16u as=0.1406p ps=1.12u w=0.74u l=0.13u
X501 a_9712_3912# a_6854_5454# a_9444_3912# VSS.t136 sg13_lv_nmos ad=0.38p pd=2.38u as=0.68p ps=4.68u w=2u l=1u
X502 VSS.t186 DELAY_VBIASN a_22351_1842# VSS.t486 sg13_lv_nmos ad=0.2516p pd=2.16u as=0.1406p ps=1.12u w=0.74u l=0.6u
X503 VDD.t387 a_3171_1047.t4 a_21044_1008# VDD.t36 sg13_lv_pmos ad=0.3808p pd=2.92u as=0.3808p ps=2.92u w=1.12u l=0.13u
X504 VDD.t73 VSS.t52 VDD.t71 VDD.t36 sg13_lv_pmos ad=0.19p pd=1.38u as=0 ps=0 w=1u l=1u
X505 a_16271_2470# a_16033_1842# a_16163_1842# VDD.t25 sg13_lv_pmos ad=0.2128p pd=1.5u as=0.3808p ps=2.92u w=1.12u l=0.2u
X506 VDD.t46 VSS.t30 VDD.t45 VDD.t36 sg13_lv_pmos ad=0.19p pd=1.38u as=0 ps=0 w=1u l=1u
X507 a_19833_1842# a_19637_1842# VSS.t139 VSS.t138 sg13_lv_nmos ad=0.2516p pd=2.16u as=0.1406p ps=1.12u w=0.74u l=0.13u
X508 VDD.t295 a_2019_311# a_5705_519# VDD.t36 sg13_lv_pmos ad=0.3808p pd=2.92u as=0.3808p ps=2.92u w=1.12u l=0.13u
X509 VDD.t297 a_14851_6228# a_15108_6109# VDD.t1 sg13_lv_pmos ad=0.2639p pd=1.81u as=79.8f ps=0.8u w=0.42u l=0.13u
X510 a_10520_6292# a_10232_5871# a_10458_6292# VSS.t218 sg13_lv_nmos ad=0.1428p pd=1.52u as=37.8f ps=0.6u w=0.42u l=0.13u
X511 a_15270_6305# a_12849_5867# VSS.t95 VSS.t94 sg13_lv_nmos ad=37.8f pd=0.6u as=79.8f ps=0.8u w=0.42u l=0.13u
X512 a_20071_2470# a_19833_1842# a_19963_1842# VDD.t25 sg13_lv_pmos ad=0.2128p pd=1.5u as=0.3808p ps=2.92u w=1.12u l=0.2u
X513 a_9193_1842# a_8997_1842# VSS.t411 VSS.t410 sg13_lv_nmos ad=0.2516p pd=2.16u as=0.1406p ps=1.12u w=0.74u l=0.13u
X514 a_24631_1842# a_24393_1842# a_24523_1842# VSS.t405 sg13_lv_nmos ad=0.1406p pd=1.12u as=0.2516p ps=2.16u w=0.74u l=0.2u
X515 VDD.t48 VSS.t30 VDD.t47 VDD.t36 sg13_lv_pmos ad=0.34p pd=2.68u as=0 ps=0 w=1u l=1u
X516 VSS.t306 a_2019_1047.t7 a_10404_1008# VSS.t305 sg13_lv_nmos ad=0.2516p pd=2.16u as=0.2516p ps=2.16u w=0.74u l=0.13u
X517 VSS.t509 DELAY_VBIASN VSS.t511 VSS.t510 sg13_lv_nmos ad=1.33p pd=7.38u as=0 ps=0 w=7u l=7u
X518 VDD.t358 a_14643_1842# a_15077_1842# VDD.t25 sg13_lv_pmos ad=0.2128p pd=1.5u as=0.3808p ps=2.92u w=1.12u l=0.13u
X519 VDD.t90 a_1544_289# a_2297_331# VDD.t36 sg13_lv_pmos ad=0.1918p pd=1.5u as=0.1596p ps=1.22u w=0.84u l=0.13u
X520 a_23633_1842# a_23437_1842# VSS.t211 VSS.t323 sg13_lv_nmos ad=0.2516p pd=2.16u as=0.1406p ps=1.12u w=0.74u l=0.13u
X521 VSS.t41 VDD.t396 VSS.t41 VSS.t42 sg13_lv_nmos ad=0.1428p pd=1.52u as=0 ps=0 w=0.42u l=1u
X522 a_2019_311# a_1721_331# VDD.t156 VDD.t36 sg13_lv_pmos ad=0.2128p pd=1.5u as=0.1918p ps=1.5u w=1.12u l=0.13u
X523 VSS.t92 a_9323_1842# a_9757_1842# VSS.t91 sg13_lv_nmos ad=0.1406p pd=1.12u as=0.2516p ps=2.16u w=0.74u l=0.13u
X524 a_26395_1044# a_26185_1044# VSS.t444 VSS.t443 sg13_lv_nmos ad=0.1406p pd=1.12u as=0.1665p ps=1.19u w=0.74u l=0.13u
X525 VDD.t274 DELAY_VBIASP a_17791_2470# VDD.t25 sg13_lv_pmos ad=0.3808p pd=2.92u as=0.2128p ps=1.5u w=1.12u l=0.6u
X526 VSS.t402 a_3747_1047.t3 a_24951_1008# VSS.t459 sg13_lv_nmos ad=0.2516p pd=2.16u as=0.2516p ps=2.16u w=0.74u l=0.13u
X527 VSS.t17 VDD.t403 VSS.t17 VSS.t16 sg13_lv_nmos ad=0.1428p pd=1.52u as=0 ps=0 w=0.42u l=1u
X528 VSS.t39 VDD.t397 VSS.t39 VSS.t38 sg13_lv_nmos ad=0.1428p pd=1.52u as=0 ps=0 w=0.42u l=1u
X529 a_3747_1047.t0 a_3449_1395# VDD.t226 VDD.t36 sg13_lv_pmos ad=0.2128p pd=1.5u as=0.1918p ps=1.5u w=1.12u l=0.13u
X530 a_13368_1044# a_12797_1842# VDD.t61 VDD.t36 sg13_lv_pmos ad=0.2128p pd=1.5u as=0.3808p ps=2.92u w=1.12u l=0.13u
X531 a_24008_1044# a_23437_1842# VSS.t322 VSS.t321 sg13_lv_nmos ad=0.1406p pd=1.12u as=0.2516p ps=2.16u w=0.74u l=0.13u
X532 VDD.t276 DELAY_VBIASP a_21591_2470# VDD.t25 sg13_lv_pmos ad=0.3808p pd=2.92u as=0.2128p ps=1.5u w=1.12u l=0.6u
X533 a_15964_289# MUX_SEL4 a_5731_289# VDD.t36 sg13_lv_pmos ad=0.3304p pd=1.71u as=0.3808p ps=2.92u w=1.12u l=0.13u
X534 a_4350_1044# a_6711_1008# a_6635_1044# VDD.t36 sg13_lv_pmos ad=0.3808p pd=2.92u as=0.2128p ps=1.5u w=1.12u l=0.13u
X535 a_2873_1395# MUX_SEL1 VDD.t288 VDD.t36 sg13_lv_pmos ad=0.1596p pd=1.22u as=0.2856p ps=2.36u w=0.84u l=0.13u
X536 VSS.t98 a_12849_5867# a_13400_5105# VSS.t614 sg13_lv_nmos ad=0.1626p pd=1.415u as=60.89999f ps=0.71u w=0.42u l=0.13u
X537 a_1256_1044# MUX_SEL0 VSS.t121 VSS.t430 sg13_lv_nmos ad=0.2516p pd=2.16u as=0.2516p ps=2.16u w=0.74u l=0.13u
X538 VSS.t15 VDD.t404 VSS.t13 VSS.t14 sg13_lv_nmos ad=79.8f pd=0.8u as=0 ps=0 w=0.42u l=1u
X539 a_19550_1044# a_20391_1008# a_20315_1044# VDD.t36 sg13_lv_pmos ad=0.3808p pd=2.92u as=0.2128p ps=1.5u w=1.12u l=0.13u
X540 VDD.t35 VDD.t33 VDD.t32 VDD.t25 sg13_lv_pmos ad=0.2128p pd=1.5u as=0 ps=0 w=1.12u l=0.2u
X541 a_5631_1842# a_5393_1842# a_5523_1842# VSS.t215 sg13_lv_nmos ad=0.1406p pd=1.12u as=0.2516p ps=2.16u w=0.74u l=0.2u
X542 a_14513_1842# a_14317_1842# VSS.t78 VSS.t77 sg13_lv_nmos ad=0.2516p pd=2.16u as=0.1406p ps=1.12u w=0.74u l=0.13u
X543 VSS.t45 a_2595_311.t2 a_20905_519# VSS.t183 sg13_lv_nmos ad=0.2516p pd=2.16u as=0.2516p ps=2.16u w=0.74u l=0.13u
X544 VDD.t87 a_7477_1842# a_7945_1044# VDD.t36 sg13_lv_pmos ad=0.252p pd=1.57u as=0.3808p ps=2.92u w=1.12u l=0.13u
X545 a_13470_1044# a_3171_1047.t6 a_14888_1044# VSS.t415 sg13_lv_nmos ad=0.2516p pd=2.16u as=0.1406p ps=1.12u w=0.74u l=0.13u
X546 a_4633_1842# a_4437_1842# VSS.t188 VSS.t187 sg13_lv_nmos ad=0.2516p pd=2.16u as=0.1406p ps=1.12u w=0.74u l=0.13u
X547 a_1256_289# MUX_SEL2 VSS.t224 VSS.t223 sg13_lv_nmos ad=0.2516p pd=2.16u as=0.2516p ps=2.16u w=0.74u l=0.13u
X548 VSS.t579 a_2019_1047.t2 a_25604_1008# VSS.t578 sg13_lv_nmos ad=0.2516p pd=2.16u as=0.2516p ps=2.16u w=0.74u l=0.13u
X549 a_13019_5831# a_15688_5403# VDD.t203 VDD.t1 sg13_lv_pmos ad=0.3808p pd=2.92u as=0.2128p ps=1.5u w=1.12u l=0.13u
X550 VSS.t505 DELAY_VBIASN VSS.t507 VSS.t506 sg13_lv_nmos ad=1.33p pd=7.38u as=0 ps=0 w=7u l=7u
X551 a_16108_289# MUX_SEL4 a_15964_289# VSS.t294 sg13_lv_nmos ad=0.2516p pd=2.16u as=0.2183p ps=1.33u w=0.74u l=0.13u
X552 a_13400_6305# a_12355_5867# a_13306_6305# VSS.t403 sg13_lv_nmos ad=60.89999f pd=0.71u as=0.1428p ps=1.52u w=0.42u l=0.13u
X553 a_22873_1842# a_22677_1842# VDD.t112 VDD.t25 sg13_lv_pmos ad=0.3808p pd=2.92u as=0.2128p ps=1.5u w=1.12u l=0.13u
X554 a_21835_1044# a_21625_1044# VSS.t192 VSS.t230 sg13_lv_nmos ad=0.1406p pd=1.12u as=0.1665p ps=1.19u w=0.74u l=0.13u
X555 VSS.t161 a_2595_1047.t4 a_20391_1008# VSS.t298 sg13_lv_nmos ad=0.2516p pd=2.16u as=0.2516p ps=2.16u w=0.74u l=0.13u
X556 a_9675_1044# a_9465_1044# VDD.t54 VDD.t36 sg13_lv_pmos ad=0.2128p pd=1.5u as=0.252p ps=1.57u w=1.12u l=0.13u
X557 VSS.t345 a_10517_1842# a_10985_1044# VSS.t344 sg13_lv_nmos ad=0.1665p pd=1.19u as=0.2516p ps=2.16u w=0.74u l=0.13u
X558 VDD.t189 a_2595_1047.t8 a_8231_1008# VDD.t36 sg13_lv_pmos ad=0.3808p pd=2.92u as=0.3808p ps=2.92u w=1.12u l=0.13u
X559 a_18551_1842# a_18313_1842# a_18443_1842# VSS.t452 sg13_lv_nmos ad=0.1406p pd=1.12u as=0.2516p ps=2.16u w=0.74u l=0.2u
X560 a_12943_5867# a_12656_5864# a_12849_5867# VDD.t1 sg13_lv_pmos ad=0.2128p pd=1.5u as=0.3808p ps=2.92u w=1.12u l=0.13u
X561 a_13566_5835# a_14009_5878# a_13949_5914# VDD.t1 sg13_lv_pmos ad=79.8f pd=0.8u as=63f ps=0.72u w=0.42u l=0.13u
X562 a_22351_1842# a_22113_1842# a_22243_1842# VSS.t76 sg13_lv_nmos ad=0.1406p pd=1.12u as=0.2516p ps=2.16u w=0.74u l=0.2u
X563 VSS.t72 a_3747_1047.t5 a_18871_1008# VSS.t71 sg13_lv_nmos ad=0.2516p pd=2.16u as=0.2516p ps=2.16u w=0.74u l=0.13u
X564 VSS.t262 a_16923_1842# a_17357_1842# VSS.t261 sg13_lv_nmos ad=0.1406p pd=1.12u as=0.2516p ps=2.16u w=0.74u l=0.13u
X565 VDD.t179 a_3171_311.t2 a_23945_519# VDD.t36 sg13_lv_pmos ad=0.3808p pd=2.92u as=0.3808p ps=2.92u w=1.12u l=0.13u
X566 a_2019_311# a_1721_331# VSS.t153 VSS.t238 sg13_lv_nmos ad=0.1406p pd=1.12u as=0.1331p ps=1.12u w=0.74u l=0.13u
X567 a_25153_1842# a_24957_1842# VDD.t195 VDD.t25 sg13_lv_pmos ad=0.3808p pd=2.92u as=0.2128p ps=1.5u w=1.12u l=0.13u
X568 a_17928_1044# a_17357_1842# VSS.t301 VSS.t440 sg13_lv_nmos ad=0.1406p pd=1.12u as=0.2516p ps=2.16u w=0.74u l=0.13u
X569 a_12715_1044# a_12505_1044# VSS.t349 VSS.t348 sg13_lv_nmos ad=0.1406p pd=1.12u as=0.1665p ps=1.19u w=0.74u l=0.13u
X570 a_13880_6292# a_14111_5878# a_13566_5835# VSS.t244 sg13_lv_nmos ad=0.2373p pd=1.97u as=79.8f ps=0.8u w=0.42u l=0.13u
X571 a_15053_5990# a_14111_5878# a_14851_6228# VDD.t1 sg13_lv_pmos ad=93.45f pd=0.865u as=0.2048p ps=1.63u w=0.42u l=0.13u
X572 VDD.t186 MUX_SEL4 a_15765_463# VDD.t36 sg13_lv_pmos ad=0.3808p pd=2.92u as=0.3808p ps=2.92u w=1.12u l=0.13u
X573 a_19550_1044# a_3171_1047.t4 a_20968_1044# VSS.t621 sg13_lv_nmos ad=0.2516p pd=2.16u as=0.1406p ps=1.12u w=0.74u l=0.13u
X574 VSS.t164 DELAY_VBIASN a_10951_1842# VSS.t536 sg13_lv_nmos ad=0.2516p pd=2.16u as=0.1406p ps=1.12u w=0.74u l=0.6u
X575 a_19550_1044# a_19524_1008# a_19448_1044# VDD.t36 sg13_lv_pmos ad=0.3808p pd=2.92u as=0.2128p ps=1.5u w=1.12u l=0.13u
X576 a_7288_1044# a_6717_1842# VSS.t472 VSS.t471 sg13_lv_nmos ad=0.1406p pd=1.12u as=0.2516p ps=2.16u w=0.74u l=0.13u
X577 a_12355_5867# a_12158_5867# VSS.t87 VSS.t555 sg13_lv_nmos ad=0.2516p pd=2.16u as=0.1406p ps=1.12u w=0.74u l=0.13u
X578 VSS.t82 a_20723_1842# a_21157_1842# VSS.t81 sg13_lv_nmos ad=0.1406p pd=1.12u as=0.2516p ps=2.16u w=0.74u l=0.13u
X579 VDD.t97 a_14851_6228# a_15688_5867# VDD.t1 sg13_lv_pmos ad=0.2128p pd=1.5u as=0.3864p ps=2.93u w=1.12u l=0.13u
X580 a_1544_289# MUX_SEL3 VSS.t224 VSS.t586 sg13_lv_nmos ad=0.2516p pd=2.16u as=0.2516p ps=2.16u w=0.74u l=0.13u
X581 a_13470_1044# a_14311_1008# a_14235_1044# VDD.t36 sg13_lv_pmos ad=0.3808p pd=2.92u as=0.2128p ps=1.5u w=1.12u l=0.13u
X582 a_22590_1044# a_3747_1047.t3 a_24875_1044# VSS.t458 sg13_lv_nmos ad=0.2516p pd=2.16u as=0.1406p ps=1.12u w=0.74u l=0.13u
X583 VSS.t243 DELAY_VBIASN a_23871_1842# VSS.t487 sg13_lv_nmos ad=0.2516p pd=2.16u as=0.1406p ps=1.12u w=0.74u l=0.6u
X584 VDD.t290 a_2019_1047.t3 a_22564_1008# VDD.t36 sg13_lv_pmos ad=0.3808p pd=2.92u as=0.3808p ps=2.92u w=1.12u l=0.13u
X585 VSS.t444 a_25717_1842# a_26185_1044# VSS.t453 sg13_lv_nmos ad=0.1665p pd=1.19u as=0.2516p ps=2.16u w=0.74u l=0.13u
X586 a_13231_1842# a_12993_1842# a_13123_1842# VSS.t229 sg13_lv_nmos ad=0.1406p pd=1.12u as=0.2516p ps=2.16u w=0.74u l=0.2u
X587 VSS.t8 VDD.t405 VSS.t8 VSS.t10 sg13_lv_nmos ad=79.8f pd=0.8u as=0 ps=0 w=0.42u l=1u
X588 a_17791_2470# a_17553_1842# a_17683_1842# VDD.t25 sg13_lv_pmos ad=0.2128p pd=1.5u as=0.3808p ps=2.92u w=1.12u l=0.2u
X589 VSS.t190 a_4437_1842# a_4905_1044# VSS.t189 sg13_lv_nmos ad=0.1665p pd=1.19u as=0.2516p ps=2.16u w=0.74u l=0.13u
X590 VDD.t71 VSS.t52 VDD.t70 VDD.t36 sg13_lv_pmos ad=0.34p pd=2.68u as=0 ps=0 w=1u l=1u
X591 a_12233_1842# a_12037_1842# VSS.t397 VSS.t591 sg13_lv_nmos ad=0.2516p pd=2.16u as=0.1406p ps=1.12u w=0.74u l=0.13u
X592 VDD.t58 a_9547_6172# a_9547_5942# VDD.t1 sg13_lv_pmos ad=1.10612p pd=6.66u as=0.2442p ps=2.06u w=0.66u l=0.13u
X593 a_15108_5325# a_14851_5182# a_15270_5105# VSS.t325 sg13_lv_nmos ad=0.1428p pd=1.52u as=37.8f ps=0.6u w=0.42u l=0.13u
X594 VSS.t391 a_3449_1395# a_3747_1047.t1 VSS.t390 sg13_lv_nmos ad=0.2812p pd=2.24u as=0.1406p ps=1.12u w=0.74u l=0.13u
X595 VDD.t45 VSS.t28 VDD.t151 VDD.t36 sg13_lv_pmos ad=0.34p pd=2.68u as=0 ps=0 w=1u l=1u
X596 VDD.t105 VSS.t37 VDD.t104 VDD.t36 sg13_lv_pmos ad=0.19p pd=1.38u as=0 ps=0 w=1u l=1u
X597 VSS.t59 VDD.t392 VSS.t57 VSS.t58 sg13_lv_nmos ad=79.8f pd=0.8u as=0 ps=0 w=0.42u l=1u
X598 VSS.t331 a_3171_1047.t8 a_8884_1008# VSS.t330 sg13_lv_nmos ad=0.2516p pd=2.16u as=0.2516p ps=2.16u w=0.74u l=0.13u
X599 a_21591_2470# a_21353_1842# a_21483_1842# VDD.t25 sg13_lv_pmos ad=0.2128p pd=1.5u as=0.3808p ps=2.92u w=1.12u l=0.2u
X600 VDD.t155 a_2873_1395# a_3171_1047.t0 VDD.t36 sg13_lv_pmos ad=0.4256p pd=3u as=0.2128p ps=1.5u w=1.12u l=0.13u
X601 a_6153_1842# a_5957_1842# VDD.t193 VDD.t25 sg13_lv_pmos ad=0.3808p pd=2.92u as=0.2128p ps=1.5u w=1.12u l=0.13u
X602 VDD.t75 a_16163_1842# a_16597_1842# VDD.t25 sg13_lv_pmos ad=0.2128p pd=1.5u as=0.3808p ps=2.92u w=1.12u l=0.13u
X603 a_3543_1395# MUX_SEL0 a_3449_1395# VSS.t432 sg13_lv_nmos ad=0.1216p pd=1.02u as=0.2176p ps=1.96u w=0.64u l=0.13u
X604 VDD.t100 a_1544_1044# a_2297_1395# VDD.t36 sg13_lv_pmos ad=0.1918p pd=1.5u as=0.1596p ps=1.22u w=0.84u l=0.13u
X605 VDD.t266 DELAY_VBIASP a_10191_2470# VDD.t25 sg13_lv_pmos ad=0.3808p pd=2.92u as=0.2128p ps=1.5u w=1.12u l=0.6u
X606 a_17275_1044# a_17065_1044# VDD.t222 VDD.t36 sg13_lv_pmos ad=0.2128p pd=1.5u as=0.252p ps=1.57u w=1.12u l=0.13u
X607 a_2019_1047.t0 a_1721_1395# VDD.t77 VDD.t36 sg13_lv_pmos ad=0.2128p pd=1.5u as=0.1918p ps=1.5u w=1.12u l=0.13u
X608 a_27915_1044# a_27705_1044# VSS.t254 VSS.t253 sg13_lv_nmos ad=0.1406p pd=1.12u as=0.1665p ps=1.19u w=0.74u l=0.13u
X609 VSS.t131 DELAY_VBIASN a_26151_1842# VSS.t545 sg13_lv_nmos ad=0.2516p pd=2.16u as=0.1406p ps=1.12u w=0.74u l=0.6u
X610 VDD.t302 a_3747_1047.t6 a_15831_1008# VDD.t36 sg13_lv_pmos ad=0.3808p pd=2.92u as=0.3808p ps=2.92u w=1.12u l=0.13u
X611 VDD.t93 a_19963_1842# a_20397_1842# VDD.t25 sg13_lv_pmos ad=0.2128p pd=1.5u as=0.3808p ps=2.92u w=1.12u l=0.13u
X612 VSS.t61 VDD.t391 VSS.t61 VSS.t60 sg13_lv_nmos ad=0.1428p pd=1.52u as=0 ps=0 w=0.42u l=1u
X613 VSS.t232 DELAY_VBIASN a_4871_1842# VSS.t495 sg13_lv_nmos ad=0.2516p pd=2.16u as=0.1406p ps=1.12u w=0.74u l=0.6u
X614 a_14888_1044# a_14317_1842# VDD.t42 VDD.t36 sg13_lv_pmos ad=0.2128p pd=1.5u as=0.3808p ps=2.92u w=1.12u l=0.13u
X615 a_4350_1044# a_4324_1008# a_4248_1044# VDD.t36 sg13_lv_pmos ad=0.3808p pd=2.92u as=0.2128p ps=1.5u w=1.12u l=0.13u
X616 a_1256_289# MUX_SEL2 VDD.t134 VDD.t36 sg13_lv_pmos ad=0.3808p pd=2.92u as=0.3808p ps=2.92u w=1.12u l=0.13u
X617 VSS.t384 VSS.t381 VSS.t383 VSS.t382 sg13_lv_nmos ad=0.2516p pd=2.16u as=0 ps=0 w=0.74u l=0.6u
X618 a_16108_289# a_15765_463# a_15964_289# VDD.t36 sg13_lv_pmos ad=0.3808p pd=2.92u as=0.3304p ps=1.71u w=1.12u l=0.13u
X619 VDD.t219 a_12849_5867# a_13566_5835# VDD.t1 sg13_lv_pmos ad=0.1563p pd=1.22u as=0.147p ps=1.54u w=0.42u l=0.13u
X620 VSS.t501 DELAY_VBIASN VSS.t500 VSS.t499 sg13_lv_nmos ad=2.38p pd=14.68u as=0 ps=0 w=7u l=7u
X621 a_11473_1842# a_11277_1842# VDD.t96 VDD.t25 sg13_lv_pmos ad=0.3808p pd=2.92u as=0.2128p ps=1.5u w=1.12u l=0.13u
X622 VDD.t54 a_8997_1842# a_9465_1044# VDD.t36 sg13_lv_pmos ad=0.252p pd=1.57u as=0.3808p ps=2.92u w=1.12u l=0.13u
X623 a_27433_1842# a_27237_1842# VSS.t308 VSS.t466 sg13_lv_nmos ad=0.2516p pd=2.16u as=0.1406p ps=1.12u w=0.74u l=0.13u
X624 a_2391_331# MUX_SEL2 a_2297_331# VSS.t225 sg13_lv_nmos ad=0.1216p pd=1.02u as=0.2176p ps=1.96u w=0.64u l=0.13u
X625 a_2967_331# MUX_SEL3 a_2873_331# VSS.t587 sg13_lv_nmos ad=0.1216p pd=1.02u as=0.2176p ps=1.96u w=0.64u l=0.13u
X626 VDD.t377 a_2019_1047.t5 a_16484_1008# VDD.t36 sg13_lv_pmos ad=0.3808p pd=2.92u as=0.3808p ps=2.92u w=1.12u l=0.13u
X627 a_7390_1044# a_2595_1047.t8 a_8155_1044# VSS.t302 sg13_lv_nmos ad=0.2516p pd=2.16u as=0.1406p ps=1.12u w=0.74u l=0.13u
X628 VSS.t280 a_6126_3816# a_5974_5723# VSS.t209 sg13_lv_nmos ad=0.68p pd=4.68u as=0.38p ps=2.38u w=2u l=1u
X629 VSS.t148 DELAY_VBIASN a_7151_1842# VSS.t496 sg13_lv_nmos ad=0.2516p pd=2.16u as=0.1406p ps=1.12u w=0.74u l=0.6u
X630 VDD.t108 a_3171_1047.t9 a_5844_1008# VDD.t36 sg13_lv_pmos ad=0.3808p pd=2.92u as=0.3808p ps=2.92u w=1.12u l=0.13u
X631 VDD.t275 DELAY_VBIASP a_25391_2470# VDD.t25 sg13_lv_pmos ad=0.3808p pd=2.92u as=0.2128p ps=1.5u w=1.12u l=0.6u
X632 VDD.t40 a_2595_1047.t7 a_11271_1008# VDD.t36 sg13_lv_pmos ad=0.3808p pd=2.92u as=0.3808p ps=2.92u w=1.12u l=0.13u
X633 VDD.t148 VSS.t19 VDD.t146 VDD.t36 sg13_lv_pmos ad=0.19p pd=1.38u as=0 ps=0 w=1u l=1u
X634 VSS.t349 a_12037_1842# a_12505_1044# VSS.t590 sg13_lv_nmos ad=0.1665p pd=1.19u as=0.2516p ps=2.16u w=0.74u l=0.13u
X635 VDD.t351 a_3747_1047.t8 a_9751_1008# VDD.t36 sg13_lv_pmos ad=0.3808p pd=2.92u as=0.3808p ps=2.92u w=1.12u l=0.13u
X636 a_12943_5867# a_13121_5831# VDD.t55 VDD.t1 sg13_lv_pmos ad=0.3808p pd=2.92u as=0.2128p ps=1.5u w=1.12u l=0.13u
X637 a_11748_6109# a_11491_6228# a_11910_6305# VSS.t110 sg13_lv_nmos ad=0.1428p pd=1.52u as=37.8f ps=0.6u w=0.42u l=0.13u
X638 a_9431_1842# a_9193_1842# a_9323_1842# VSS.t227 sg13_lv_nmos ad=0.1406p pd=1.12u as=0.2516p ps=2.16u w=0.74u l=0.2u
X639 a_18313_1842# a_18117_1842# VSS.t107 VSS.t106 sg13_lv_nmos ad=0.2516p pd=2.16u as=0.1406p ps=1.12u w=0.74u l=0.13u
X640 MUX_OUT a_16851_309# VSS.t296 VSS.t421 sg13_lv_nmos ad=0.1406p pd=1.12u as=0.1371p ps=1.12u w=0.74u l=0.13u
X641 a_10232_5871# a_10206_5835# VDD.t86 VDD.t1 sg13_lv_pmos ad=0.34p pd=2.68u as=0.36237p ps=2.605u w=1u l=0.13u
X642 a_14851_5182# a_14009_5084# a_14757_5182# VSS.t414 sg13_lv_nmos ad=0.12665p pd=1.145u as=0.1428p ps=1.52u w=0.42u l=0.13u
X643 VSS.t52 VDD.t393 VSS.t52 VSS.t54 sg13_lv_nmos ad=79.8f pd=0.8u as=0 ps=0 w=0.42u l=1u
X644 a_23871_1842# a_23633_1842# a_23763_1842# VSS.t477 sg13_lv_nmos ad=0.1406p pd=1.12u as=0.2516p ps=2.16u w=0.74u l=0.2u
X645 a_8433_1842# a_8237_1842# VSS.t67 VSS.t66 sg13_lv_nmos ad=0.2516p pd=2.16u as=0.1406p ps=1.12u w=0.74u l=0.13u
X646 VSS.t174 a_18443_1842# a_18877_1842# VSS.t474 sg13_lv_nmos ad=0.1406p pd=1.12u as=0.2516p ps=2.16u w=0.74u l=0.13u
X647 VSS.t30 VDD.t400 VSS.t28 VSS.t29 sg13_lv_nmos ad=79.8f pd=0.8u as=0 ps=0 w=0.42u l=1u
X648 VSS.t278 a_6126_3816# a_5974_5723# VSS.t209 sg13_lv_nmos ad=0.68p pd=4.68u as=0.38p ps=2.38u w=2u l=1u
X649 a_22113_1842# a_21917_1842# VSS.t113 VSS.t255 sg13_lv_nmos ad=0.2516p pd=2.16u as=0.1406p ps=1.12u w=0.74u l=0.13u
X650 a_1544_289# MUX_SEL3 VDD.t359 VDD.t36 sg13_lv_pmos ad=0.3808p pd=2.92u as=0.3808p ps=2.92u w=1.12u l=0.13u
X651 VDD.t12 VDD.t4 VDD.t11 VDD.t1 sg13_lv_pmos ad=0.38p pd=2.38u as=0 ps=0 w=2u l=1u
X652 a_26673_1842# a_26477_1842# VDD.t82 VDD.t25 sg13_lv_pmos ad=0.3808p pd=2.92u as=0.2128p ps=1.5u w=1.12u l=0.13u
X653 a_10328_1044# a_9757_1842# VSS.t267 VSS.t266 sg13_lv_nmos ad=0.1406p pd=1.12u as=0.2516p ps=2.16u w=0.74u l=0.13u
X654 VSS.t30 VDD.t399 VSS.t30 VSS.t31 sg13_lv_nmos ad=0.1428p pd=1.52u as=0 ps=0 w=0.42u l=1u
X655 a_22590_1044# a_2019_1047.t3 a_22488_1044# VSS.t436 sg13_lv_nmos ad=0.2516p pd=2.16u as=0.1406p ps=1.12u w=0.74u l=0.13u
X656 VSS.t100 DELAY_VBIASN a_12471_1842# VSS.t539 sg13_lv_nmos ad=0.2516p pd=2.16u as=0.1406p ps=1.12u w=0.74u l=0.6u
X657 a_8808_1044# a_8237_1842# VSS.t69 VSS.t68 sg13_lv_nmos ad=0.1406p pd=1.12u as=0.2516p ps=2.16u w=0.74u l=0.13u
X658 VSS.t186 a_22243_1842# a_22677_1842# VSS.t404 sg13_lv_nmos ad=0.1406p pd=1.12u as=0.2516p ps=2.16u w=0.74u l=0.13u
X659 VDD.t260 DELAY_VBIASP a_6391_2470# VDD.t25 sg13_lv_pmos ad=0.3808p pd=2.92u as=0.2128p ps=1.5u w=1.12u l=0.6u
X660 a_13470_1044# a_15831_1008# a_15755_1044# VDD.t36 sg13_lv_pmos ad=0.3808p pd=2.92u as=0.2128p ps=1.5u w=1.12u l=0.13u
X661 a_1544_1044# MUX_SEL1 VDD.t287 VDD.t36 sg13_lv_pmos ad=0.3808p pd=2.92u as=0.3808p ps=2.92u w=1.12u l=0.13u
X662 VDD.t252 DELAY_VBIASP a_20831_2470# VDD.t25 sg13_lv_pmos ad=0.3808p pd=2.92u as=0.2128p ps=1.5u w=1.12u l=0.6u
X663 VDD.t352 a_2595_1047.t2 a_26471_1008# VDD.t36 sg13_lv_pmos ad=0.3808p pd=2.92u as=0.3808p ps=2.92u w=1.12u l=0.13u
X664 a_4350_1044# a_5191_1008# a_5115_1044# VDD.t36 sg13_lv_pmos ad=0.3808p pd=2.92u as=0.2128p ps=1.5u w=1.12u l=0.13u
X665 VDD.t222 a_16597_1842# a_17065_1044# VDD.t36 sg13_lv_pmos ad=0.252p pd=1.57u as=0.3808p ps=2.92u w=1.12u l=0.13u
X666 VSS.t254 a_27237_1842# a_27705_1044# VSS.t467 sg13_lv_nmos ad=0.1665p pd=1.19u as=0.2516p ps=2.16u w=0.74u l=0.13u
X667 VSS.t500 DELAY_VBIASN VSS.t503 VSS.t502 sg13_lv_nmos ad=1.33p pd=7.38u as=0 ps=0 w=7u l=7u
X668 a_10191_2470# a_9953_1842# a_10083_1842# VDD.t25 sg13_lv_pmos ad=0.2128p pd=1.5u as=0.3808p ps=2.92u w=1.12u l=0.2u
X669 a_2595_1047.t1 a_2297_1395# VSS.t121 VSS.t263 sg13_lv_nmos ad=0.1406p pd=1.12u as=0.1331p ps=1.12u w=0.74u l=0.13u
X670 a_26151_1842# a_25913_1842# a_26043_1842# VSS.t470 sg13_lv_nmos ad=0.1406p pd=1.12u as=0.2516p ps=2.16u w=0.74u l=0.2u
X671 VSS.t34 a_2019_311# a_17865_519# VSS.t448 sg13_lv_nmos ad=0.2516p pd=2.16u as=0.2516p ps=2.16u w=0.74u l=0.13u
X672 VSS.t153 a_1544_289# a_2391_331# VSS.t340 sg13_lv_nmos ad=0.1331p pd=1.12u as=0.1216p ps=1.02u w=0.64u l=0.13u
X673 a_4871_1842# a_4633_1842# a_4763_1842# VSS.t247 sg13_lv_nmos ad=0.1406p pd=1.12u as=0.2516p ps=2.16u w=0.74u l=0.2u
X674 a_13753_1842# a_13557_1842# VSS.t205 VSS.t580 sg13_lv_nmos ad=0.2516p pd=2.16u as=0.1406p ps=1.12u w=0.74u l=0.13u
X675 a_1815_1395# a_1256_1044# a_1721_1395# VSS.t206 sg13_lv_nmos ad=0.1216p pd=1.02u as=0.2176p ps=1.96u w=0.64u l=0.13u
X676 a_7673_1842# a_7477_1842# VDD.t88 VDD.t25 sg13_lv_pmos ad=0.3808p pd=2.92u as=0.2128p ps=1.5u w=1.12u l=0.13u
X677 VDD.t104 VSS.t34 VDD.t107 VDD.t36 sg13_lv_pmos ad=0.34p pd=2.68u as=0 ps=0 w=1u l=1u
X678 a_1721_331# a_1256_289# VDD.t367 VDD.t36 sg13_lv_pmos ad=0.1596p pd=1.22u as=0.2856p ps=2.36u w=0.84u l=0.13u
X679 VSS.t315 a_24523_1842# a_24957_1842# VSS.t314 sg13_lv_nmos ad=0.1406p pd=1.12u as=0.2516p ps=2.16u w=0.74u l=0.13u
X680 a_6635_1044# a_6425_1044# VSS.t313 VSS.t463 sg13_lv_nmos ad=0.1406p pd=1.12u as=0.1665p ps=1.19u w=0.74u l=0.13u
X681 VDD.t58 a_15108_5325# a_15053_5420# VDD.t1 sg13_lv_pmos ad=1.10612p pd=6.66u as=93.45f ps=0.865u w=0.42u l=0.13u
X682 VSS.t269 a_2595_1047.t9 a_5191_1008# VSS.t427 sg13_lv_nmos ad=0.2516p pd=2.16u as=0.2516p ps=2.16u w=0.74u l=0.13u
X683 a_20315_1044# a_20105_1044# VSS.t141 VSS.t351 sg13_lv_nmos ad=0.1406p pd=1.12u as=0.1665p ps=1.19u w=0.74u l=0.13u
X684 VDD.t270 DELAY_VBIASP a_11711_2470# VDD.t25 sg13_lv_pmos ad=0.3808p pd=2.92u as=0.2128p ps=1.5u w=1.12u l=0.6u
X685 a_18795_1044# a_18585_1044# VDD.t62 VDD.t36 sg13_lv_pmos ad=0.2128p pd=1.5u as=0.252p ps=1.57u w=1.12u l=0.13u
X686 a_25528_1044# a_24957_1842# VSS.t402 VSS.t401 sg13_lv_nmos ad=0.1406p pd=1.12u as=0.2516p ps=2.16u w=0.74u l=0.13u
X687 a_5778_3367# a_6126_3816# a_6326_4590# VSS.t274 sg13_lv_nmos ad=0.68p pd=4.68u as=0.38p ps=2.38u w=2u l=1u
X688 VSS.t518 DELAY_VBIASN VSS.t527 VSS.t508 sg13_lv_nmos ad=1.33p pd=7.38u as=0 ps=0 w=7u l=7u
X689 VSS.t550 DELAY_VBIASN a_27671_1842# VSS.t549 sg13_lv_nmos ad=0.2516p pd=2.16u as=0.1406p ps=1.12u w=0.74u l=0.6u
X690 a_5731_289# a_3747_311.t3 a_13470_1044# VSS.t175 sg13_lv_nmos ad=0.2516p pd=2.16u as=0.2516p ps=2.16u w=0.74u l=0.13u
X691 a_25630_1044# a_27124_1008# a_27048_1044# VDD.t36 sg13_lv_pmos ad=0.3808p pd=2.92u as=0.2128p ps=1.5u w=1.12u l=0.13u
X692 VDD.t188 a_2595_1047.t5 a_17351_1008# VDD.t36 sg13_lv_pmos ad=0.3808p pd=2.92u as=0.3808p ps=2.92u w=1.12u l=0.13u
X693 VSS.t88 a_13121_5831# a_6854_5986# VDD.t14 sg13_lv_pmos ad=0.232p pd=2.08u as=0.136p ps=1.14u w=0.4u l=0.2u
X694 VDD.t67 a_21483_1842# a_21917_1842# VDD.t25 sg13_lv_pmos ad=0.2128p pd=1.5u as=0.3808p ps=2.92u w=1.12u l=0.13u
X695 a_4350_1044# a_5844_1008# a_5768_1044# VDD.t36 sg13_lv_pmos ad=0.3808p pd=2.92u as=0.2128p ps=1.5u w=1.12u l=0.13u
X696 VSS.t296 a_16851_309# MUX_OUT VSS.t422 sg13_lv_nmos ad=0.2516p pd=2.16u as=0.1406p ps=1.12u w=0.74u l=0.13u
X697 VSS.t1 a_2019_311# a_5705_519# VSS.t446 sg13_lv_nmos ad=0.2516p pd=2.16u as=0.2516p ps=2.16u w=0.74u l=0.13u
X698 VDD.t156 a_1544_289# a_1721_331# VDD.t36 sg13_lv_pmos ad=0.1918p pd=1.5u as=0.1596p ps=1.22u w=0.84u l=0.13u
X699 a_7151_1842# a_6913_1842# a_7043_1842# VSS.t124 sg13_lv_nmos ad=0.1406p pd=1.12u as=0.2516p ps=2.16u w=0.74u l=0.2u
X700 a_16033_1842# a_15837_1842# VSS.t442 VSS.t601 sg13_lv_nmos ad=0.2516p pd=2.16u as=0.1406p ps=1.12u w=0.74u l=0.13u
X701 a_10649_5878# REF_CLK VSS.t197 VSS.t196 sg13_lv_nmos ad=0.2516p pd=2.16u as=1.9998p ps=12.915u w=0.74u l=0.13u
X702 VDD.t58 a_11748_6109# a_11693_5990# VDD.t1 sg13_lv_pmos ad=1.10612p pd=6.66u as=93.45f ps=0.865u w=0.42u l=0.13u
X703 MUX_OUT a_16851_309# VDD.t244 VDD.t36 sg13_lv_pmos ad=0.2128p pd=1.5u as=0.2086p ps=1.5u w=1.12u l=0.13u
X704 a_25391_2470# a_25153_1842# a_25283_1842# VDD.t25 sg13_lv_pmos ad=0.2128p pd=1.5u as=0.3808p ps=2.92u w=1.12u l=0.2u
X705 VDD.t44 VSS.t12 VDD.t43 VDD.t36 sg13_lv_pmos ad=0.34p pd=2.68u as=0 ps=0 w=1u l=1u
X706 a_12993_1842# a_12797_1842# VDD.t60 VDD.t25 sg13_lv_pmos ad=0.3808p pd=2.92u as=0.2128p ps=1.5u w=1.12u l=0.13u
X707 a_16408_1044# a_15837_1842# VSS.t457 VSS.t600 sg13_lv_nmos ad=0.1406p pd=1.12u as=0.2516p ps=2.16u w=0.74u l=0.13u
X708 a_5778_3367# a_6126_3816# a_6326_4590# VSS.t274 sg13_lv_nmos ad=0.68p pd=4.68u as=0.38p ps=2.38u w=2u l=1u
X709 VSS.t311 a_5523_1842# a_5957_1842# VSS.t320 sg13_lv_nmos ad=0.1406p pd=1.12u as=0.2516p ps=2.16u w=0.74u l=0.13u
X710 VDD.t253 DELAY_VBIASP a_13991_2470# VDD.t25 sg13_lv_pmos ad=0.3808p pd=2.92u as=0.2128p ps=1.5u w=1.12u l=0.6u
X711 a_5731_289# a_2019_311# a_4350_1044# VSS.t445 sg13_lv_nmos ad=0.2516p pd=2.16u as=0.2516p ps=2.16u w=0.74u l=0.13u
X712 VSS.t476 a_9547_6172# a_9547_6172# VSS.t475 sg13_lv_nmos ad=2.39977p pd=15.495u as=0.111p ps=1.34u w=0.3u l=0.13u
X713 a_9444_3912# a_6854_5454# a_9712_3912# VSS.t135 sg13_lv_nmos ad=0.68p pd=4.68u as=0.38p ps=2.38u w=2u l=1u
X714 VSS.t532 DELAY_VBIASN VSS.t530 VSS.t514 sg13_lv_nmos ad=1.33p pd=7.38u as=0 ps=0 w=7u l=7u
X715 a_7390_1044# a_3747_1047.t8 a_9675_1044# VSS.t573 sg13_lv_nmos ad=0.2516p pd=2.16u as=0.1406p ps=1.12u w=0.74u l=0.13u
X716 VDD.t163 a_23763_1842# a_24197_1842# VDD.t25 sg13_lv_pmos ad=0.2128p pd=1.5u as=0.3808p ps=2.92u w=1.12u l=0.13u
X717 VSS.t411 DELAY_VBIASN a_8671_1842# VSS.t497 sg13_lv_nmos ad=0.2516p pd=2.16u as=0.1406p ps=1.12u w=0.74u l=0.6u
X718 VDD.t167 a_2019_1047.t8 a_7364_1008# VDD.t36 sg13_lv_pmos ad=0.3808p pd=2.92u as=0.3808p ps=2.92u w=1.12u l=0.13u
X719 VDD.t281 DELAY_VBIASP a_26911_2470# VDD.t25 sg13_lv_pmos ad=0.3808p pd=2.92u as=0.2128p ps=1.5u w=1.12u l=0.6u
X720 VSS.t168 a_14009_5084# a_14111_5227# VSS.t413 sg13_lv_nmos ad=1.45407p pd=9.445u as=0.2516p ps=2.16u w=0.74u l=0.13u
X721 VDD.t214 VSS.t63 VDD.t212 VDD.t36 sg13_lv_pmos ad=0.19p pd=1.38u as=0 ps=0 w=1u l=1u
X722 a_12471_1842# a_12233_1842# a_12363_1842# VSS.t604 sg13_lv_nmos ad=0.1406p pd=1.12u as=0.2516p ps=2.16u w=0.74u l=0.2u
X723 a_22488_1044# a_21917_1842# VDD.t170 VDD.t36 sg13_lv_pmos ad=0.2128p pd=1.5u as=0.3808p ps=2.92u w=1.12u l=0.13u
X724 VDD.t109 a_2595_311.t3 a_8745_519# VDD.t36 sg13_lv_pmos ad=0.3808p pd=2.92u as=0.3808p ps=2.92u w=1.12u l=0.13u
X725 VSS.t157 a_3171_1047.t5 a_18004_1008# VSS.t156 sg13_lv_nmos ad=0.2516p pd=2.16u as=0.2516p ps=2.16u w=0.74u l=0.13u
X726 a_6391_2470# a_6153_1842# a_6283_1842# VDD.t25 sg13_lv_pmos ad=0.2128p pd=1.5u as=0.3808p ps=2.92u w=1.12u l=0.2u
X727 a_15273_1842# a_15077_1842# VDD.t358 VDD.t25 sg13_lv_pmos ad=0.3808p pd=2.92u as=0.2128p ps=1.5u w=1.12u l=0.13u
X728 a_14235_1044# a_14025_1044# VSS.t399 VSS.t398 sg13_lv_nmos ad=0.1406p pd=1.12u as=0.1665p ps=1.19u w=0.74u l=0.13u
X729 a_6326_4590# a_6126_3816# a_5778_3367# VSS.t274 sg13_lv_nmos ad=0.42p pd=2.42u as=0.68p ps=4.68u w=2u l=1u
X730 VSS.t102 a_3747_1047.t7 a_12791_1008# VSS.t126 sg13_lv_nmos ad=0.2516p pd=2.16u as=0.2516p ps=2.16u w=0.74u l=0.13u
X731 VSS.t365 VSS.t362 VSS.t364 VSS.t363 sg13_lv_nmos ad=0.2516p pd=2.16u as=0 ps=0 w=0.74u l=0.13u
X732 a_9953_1842# a_9757_1842# VSS.t92 VSS.t265 sg13_lv_nmos ad=0.2516p pd=2.16u as=0.1406p ps=1.12u w=0.74u l=0.13u
X733 VSS.t164 a_10843_1842# a_11277_1842# VSS.t583 sg13_lv_nmos ad=0.1406p pd=1.12u as=0.2516p ps=2.16u w=0.74u l=0.13u
X734 VSS.t52 VDD.t393 VSS.t52 VSS.t53 sg13_lv_nmos ad=0.1428p pd=1.52u as=0 ps=0 w=0.42u l=1u
X735 a_10649_5878# REF_CLK VDD.t58 VDD.t1 sg13_lv_pmos ad=0.4088p pd=2.97u as=1.03698p ps=6.245u w=1.12u l=0.13u
X736 VDD.t293 a_15403_1842# a_15837_1842# VDD.t25 sg13_lv_pmos ad=0.2128p pd=1.5u as=0.3808p ps=2.92u w=1.12u l=0.13u
X737 VDD.t58 a_14009_5084# a_14111_5227# VDD.t1 sg13_lv_pmos ad=1.10612p pd=6.66u as=0.3864p ps=2.93u w=1.12u l=0.13u
X738 VSS.t28 VDD.t400 VSS.t28 VSS.t27 sg13_lv_nmos ad=0.1428p pd=1.52u as=0 ps=0 w=0.42u l=1u
X739 a_11848_1044# a_11277_1842# VSS.t75 VSS.t162 sg13_lv_nmos ad=0.1406p pd=1.12u as=0.2516p ps=2.16u w=0.74u l=0.13u
X740 a_6326_4590# a_6326_4590# VDD.t320 VDD.t1 sg13_lv_pmos ad=0.38p pd=2.38u as=0.38p ps=2.38u w=2u l=1u
X741 VDD.t150 a_4763_1842# a_5197_1842# VDD.t25 sg13_lv_pmos ad=0.2128p pd=1.5u as=0.3808p ps=2.92u w=1.12u l=0.13u
X742 VSS.t37 VDD.t398 VSS.t35 VSS.t36 sg13_lv_nmos ad=79.8f pd=0.8u as=0 ps=0 w=0.42u l=1u
X743 a_13470_1044# a_13444_1008# a_13368_1044# VDD.t36 sg13_lv_pmos ad=0.3808p pd=2.92u as=0.2128p ps=1.5u w=1.12u l=0.13u
X744 VDD.t227 a_3449_1395# a_3747_1047.t0 VDD.t36 sg13_lv_pmos ad=0.4256p pd=3u as=0.2128p ps=1.5u w=1.12u l=0.13u
X745 VSS.t374 VSS.t371 VSS.t371 VSS.t372 sg13_lv_nmos ad=0.1406p pd=1.12u as=0 ps=0 w=0.74u l=0.13u
X746 VDD.t243 a_3171_1047.t3 a_24084_1008# VDD.t36 sg13_lv_pmos ad=0.3808p pd=2.92u as=0.3808p ps=2.92u w=1.12u l=0.13u
X747 a_3449_1395# MUX_SEL0 VDD.t286 VDD.t36 sg13_lv_pmos ad=0.1596p pd=1.22u as=0.2856p ps=2.36u w=0.84u l=0.13u
X748 a_15464_3684# a_14851_5182# VDD.t201 VDD.t1 sg13_lv_pmos ad=0.4312p pd=3.01u as=0.2639p ps=1.81u w=1.12u l=0.13u
X749 a_5974_5723# a_6126_3816# VSS.t275 VSS.t209 sg13_lv_nmos ad=0.38p pd=2.38u as=0.68p ps=4.68u w=2u l=1u
X750 VDD.t259 DELAY_VBIASP a_7911_2470# VDD.t25 sg13_lv_pmos ad=0.3808p pd=2.92u as=0.2128p ps=1.5u w=1.12u l=0.6u
X751 VDD.t138 VSS.t8 VDD.t137 VDD.t36 sg13_lv_pmos ad=0.19p pd=1.38u as=0 ps=0 w=1u l=1u
X752 VDD.t12 a_6326_4590# a_6854_5986# VDD.t1 sg13_lv_pmos ad=0.38p pd=2.38u as=0.38p ps=2.38u w=2u l=1u
X753 a_10206_5835# a_10649_5878# a_9946_6305# VSS.t257 sg13_lv_nmos ad=79.8f pd=0.8u as=0.1296p ps=1.52u w=0.42u l=0.13u
X754 VDD.t140 VSS.t8 VDD.t139 VDD.t36 sg13_lv_pmos ad=0.34p pd=2.68u as=0 ps=0 w=1u l=1u
X755 a_9946_6305# a_9772_5843# VDD.t153 VDD.t1 sg13_lv_pmos ad=79.8f pd=0.8u as=0.1428p ps=1.52u w=0.42u l=0.13u
X756 a_9946_6305# a_10751_5878# a_10206_5835# VDD.t1 sg13_lv_pmos ad=0.1428p pd=1.52u as=79.8f ps=0.8u w=0.42u l=0.13u
X757 VDD.t245 a_16851_309# MUX_OUT VDD.t36 sg13_lv_pmos ad=0.7336p pd=3.55u as=0.2128p ps=1.5u w=1.12u l=0.13u
X758 VSS.t56 a_3171_311.t2 a_23945_519# VSS.t286 sg13_lv_nmos ad=0.2516p pd=2.16u as=0.2516p ps=2.16u w=0.74u l=0.13u
X759 VDD.t62 a_18117_1842# a_18585_1044# VDD.t36 sg13_lv_pmos ad=0.252p pd=1.57u as=0.3808p ps=2.92u w=1.12u l=0.13u
X760 VSS.t141 a_19637_1842# a_20105_1044# VSS.t140 sg13_lv_nmos ad=0.1665p pd=1.19u as=0.2516p ps=2.16u w=0.74u l=0.13u
X761 a_11711_2470# a_11473_1842# a_11603_1842# VDD.t25 sg13_lv_pmos ad=0.2128p pd=1.5u as=0.3808p ps=2.92u w=1.12u l=0.2u
X762 a_27671_1842# a_27433_1842# a_27563_1842# VSS.t151 sg13_lv_nmos ad=0.1406p pd=1.12u as=0.2516p ps=2.16u w=0.74u l=0.2u
X763 VSS.t296 MUX_SEL4 a_15765_463# VSS.t295 sg13_lv_nmos ad=0.2516p pd=2.16u as=0.2516p ps=2.16u w=0.74u l=0.13u
X764 a_5731_289# a_14825_519# a_13470_1044# VDD.t36 sg13_lv_pmos ad=0.3808p pd=2.92u as=0.3808p ps=2.92u w=1.12u l=0.13u
X765 a_16510_1044# a_2595_1047.t5 a_17275_1044# VSS.t299 sg13_lv_nmos ad=0.2516p pd=2.16u as=0.1406p ps=1.12u w=0.74u l=0.13u
X766 a_13045_6215# a_13019_5831# a_12849_5867# VSS.t460 sg13_lv_nmos ad=0.1406p pd=1.12u as=0.1406p ps=1.12u w=0.74u l=0.13u
X767 VSS.t117 DELAY_VBIASN a_16271_1842# VSS.t488 sg13_lv_nmos ad=0.2516p pd=2.16u as=0.1406p ps=1.12u w=0.74u l=0.6u
X768 VDD.t161 VSS.t56 VDD.t160 VDD.t36 sg13_lv_pmos ad=0.34p pd=2.68u as=0 ps=0 w=1u l=1u
X769 VDD.t242 a_3171_1047.t6 a_14964_1008# VDD.t36 sg13_lv_pmos ad=0.3808p pd=2.92u as=0.3808p ps=2.92u w=1.12u l=0.13u
X770 VDD.t220 a_10083_1842# a_10517_1842# VDD.t25 sg13_lv_pmos ad=0.2128p pd=1.5u as=0.3808p ps=2.92u w=1.12u l=0.13u
X771 VSS.t572 a_3747_1047.t2 a_27991_1008# VSS.t571 sg13_lv_nmos ad=0.2516p pd=2.16u as=0.2516p ps=2.16u w=0.74u l=0.13u
X772 a_9712_3912# a_13019_5831# DELAY_VBIASN VSS.t461 sg13_lv_nmos ad=0.136p pd=1.14u as=0.232p ps=2.08u w=0.4u l=0.2u
X773 VSS.t131 a_26043_1842# a_26477_1842# VSS.t482 sg13_lv_nmos ad=0.1406p pd=1.12u as=0.2516p ps=2.16u w=0.74u l=0.13u
X774 VSS.t284 a_6126_3816# a_5974_5723# VSS.t209 sg13_lv_nmos ad=0.68p pd=4.68u as=0.38p ps=2.38u w=2u l=1u
X775 a_11195_1044# a_10985_1044# VDD.t221 VDD.t36 sg13_lv_pmos ad=0.2128p pd=1.5u as=0.252p ps=1.57u w=1.12u l=0.13u
X776 VSS.t472 a_3747_1047.t9 a_6711_1008# VSS.t569 sg13_lv_nmos ad=0.2516p pd=2.16u as=0.2516p ps=2.16u w=0.74u l=0.13u
X777 a_9444_4590# a_6854_5454# a_6854_5454# VSS.t135 sg13_lv_nmos ad=0.68p pd=4.68u as=0.38p ps=2.38u w=2u l=1u
X778 a_16108_289# a_2595_311.t2 a_19550_1044# VSS.t182 sg13_lv_nmos ad=0.2516p pd=2.16u as=0.2516p ps=2.16u w=0.74u l=0.13u
X779 VSS.t159 DELAY_VBIASN a_20071_1842# VSS.t542 sg13_lv_nmos ad=0.2516p pd=2.16u as=0.1406p ps=1.12u w=0.74u l=0.6u
X780 VDD.t279 DELAY_VBIASP a_24631_2470# VDD.t25 sg13_lv_pmos ad=0.3808p pd=2.92u as=0.2128p ps=1.5u w=1.12u l=0.6u
X781 a_22590_1044# a_23431_1008# a_23355_1044# VDD.t36 sg13_lv_pmos ad=0.3808p pd=2.92u as=0.2128p ps=1.5u w=1.12u l=0.13u
X782 VSS.t19 VDD.t402 VSS.t19 VSS.t21 sg13_lv_nmos ad=79.8f pd=0.8u as=0 ps=0 w=0.42u l=1u
X783 a_10458_6292# DLL_RESETN VSS.t143 VSS.t219 sg13_lv_nmos ad=37.8f pd=0.6u as=0.1701p ps=1.65u w=0.42u l=0.13u
X784 a_11491_6228# a_10649_5878# a_10232_5871# VDD.t1 sg13_lv_pmos ad=0.2048p pd=1.63u as=0.34p ps=2.68u w=1u l=0.13u
X785 VSS.t282 a_6126_3816# a_5974_5723# VSS.t209 sg13_lv_nmos ad=0.76p pd=4.76u as=0.38p ps=2.38u w=2u l=1u
X786 a_8671_1842# a_8433_1842# a_8563_1842# VSS.t201 sg13_lv_nmos ad=0.1406p pd=1.12u as=0.2516p ps=2.16u w=0.74u l=0.2u
X787 a_17553_1842# a_17357_1842# VSS.t262 VSS.t439 sg13_lv_nmos ad=0.2516p pd=2.16u as=0.1406p ps=1.12u w=0.74u l=0.13u
X788 a_5731_289# a_5705_519# a_4350_1044# VDD.t36 sg13_lv_pmos ad=0.3808p pd=2.92u as=0.3808p ps=2.92u w=1.12u l=0.13u
X789 VDD.t27 VDD.t24 VDD.t26 VDD.t25 sg13_lv_pmos ad=0.3808p pd=2.92u as=0 ps=0 w=1.12u l=0.13u
X790 a_26911_2470# a_26673_1842# a_26803_1842# VDD.t25 sg13_lv_pmos ad=0.2128p pd=1.5u as=0.3808p ps=2.92u w=1.12u l=0.2u
X791 a_7390_1044# a_2019_1047.t8 a_7288_1044# VSS.t250 sg13_lv_nmos ad=0.2516p pd=2.16u as=0.1406p ps=1.12u w=0.74u l=0.13u
X792 a_13566_5328# a_14009_5084# a_13306_5105# VSS.t412 sg13_lv_nmos ad=79.8f pd=0.8u as=0.1296p ps=1.52u w=0.42u l=0.13u
X793 a_21353_1842# a_21157_1842# VSS.t82 VSS.t193 sg13_lv_nmos ad=0.2516p pd=2.16u as=0.1406p ps=1.12u w=0.74u l=0.13u
X794 VSS.t148 a_7043_1842# a_7477_1842# VSS.t596 sg13_lv_nmos ad=0.1406p pd=1.12u as=0.2516p ps=2.16u w=0.74u l=0.13u
X795 a_13121_5831# a_15688_5867# VDD.t97 VDD.t1 sg13_lv_pmos ad=0.3808p pd=2.92u as=0.2128p ps=1.5u w=1.12u l=0.13u
X796 VDD.t250 DELAY_VBIASP a_15511_2470# VDD.t25 sg13_lv_pmos ad=0.3808p pd=2.92u as=0.2128p ps=1.5u w=1.12u l=0.6u
X797 VDD.t190 a_2019_1047.t7 a_10404_1008# VDD.t36 sg13_lv_pmos ad=0.3808p pd=2.92u as=0.3808p ps=2.92u w=1.12u l=0.13u
X798 VSS.t565 a_9444_4590# a_9444_3912# VSS.t563 sg13_lv_nmos ad=0.68p pd=4.68u as=0.38p ps=2.38u w=2u l=1u
X799 VDD.t76 a_25283_1842# a_25717_1842# VDD.t25 sg13_lv_pmos ad=0.2128p pd=1.5u as=0.3808p ps=2.92u w=1.12u l=0.13u
X800 VDD.t262 DELAY_VBIASP a_5631_2470# VDD.t25 sg13_lv_pmos ad=0.3808p pd=2.92u as=0.2128p ps=1.5u w=1.12u l=0.6u
X801 a_26395_1044# a_26185_1044# VDD.t294 VDD.t36 sg13_lv_pmos ad=0.2128p pd=1.5u as=0.252p ps=1.57u w=1.12u l=0.13u
X802 a_13306_5105# a_14111_5227# a_13566_5328# VDD.t1 sg13_lv_pmos ad=0.1428p pd=1.52u as=79.8f ps=0.8u w=0.42u l=0.13u
X803 a_6326_4590# a_6126_3816# a_5778_3367# VSS.t274 sg13_lv_nmos ad=0.38p pd=2.38u as=0.68p ps=4.68u w=2u l=1u
X804 VDD.t303 a_3747_1047.t3 a_24951_1008# VDD.t36 sg13_lv_pmos ad=0.3808p pd=2.92u as=0.3808p ps=2.92u w=1.12u l=0.13u
X805 VDD.t69 VSS.t52 VDD.t68 VDD.t36 sg13_lv_pmos ad=0.19p pd=1.38u as=0 ps=0 w=1u l=1u
X806 a_13991_1842# a_13753_1842# a_13883_1842# VSS.t96 sg13_lv_nmos ad=0.1406p pd=1.12u as=0.2516p ps=2.16u w=0.74u l=0.2u
X807 a_24008_1044# a_23437_1842# VDD.t198 VDD.t36 sg13_lv_pmos ad=0.2128p pd=1.5u as=0.3808p ps=2.92u w=1.12u l=0.13u
X808 VDD.t184 VSS.t26 VDD.t183 VDD.t36 sg13_lv_pmos ad=0.19p pd=1.38u as=0 ps=0 w=1u l=1u
X809 VSS.t338 a_2019_1047.t4 a_19524_1008# VSS.t337 sg13_lv_nmos ad=0.2516p pd=2.16u as=0.2516p ps=2.16u w=0.74u l=0.13u
X810 a_9712_3912# a_6854_5454# a_9444_3912# VSS.t134 sg13_lv_nmos ad=0.38p pd=2.38u as=0.68p ps=4.68u w=2u l=1u
X811 a_7911_2470# a_7673_1842# a_7803_1842# VDD.t25 sg13_lv_pmos ad=0.2128p pd=1.5u as=0.3808p ps=2.92u w=1.12u l=0.2u
X812 a_16793_1842# a_16597_1842# VDD.t75 VDD.t25 sg13_lv_pmos ad=0.3808p pd=2.92u as=0.2128p ps=1.5u w=1.12u l=0.13u
X813 VSS.t389 MUX_SEL1 a_3543_1395# VSS.t435 sg13_lv_nmos ad=0.1331p pd=1.12u as=0.1216p ps=1.02u w=0.64u l=0.13u
X814 a_15755_1044# a_15545_1044# VSS.t150 VSS.t149 sg13_lv_nmos ad=0.1406p pd=1.12u as=0.1665p ps=1.19u w=0.74u l=0.13u
X815 a_13818_5118# a_12849_5867# VSS.t98 VSS.t612 sg13_lv_nmos ad=37.8f pd=0.6u as=0.1701p ps=1.65u w=0.42u l=0.13u
X816 a_2595_1047.t0 a_2297_1395# VDD.t100 VDD.t36 sg13_lv_pmos ad=0.2128p pd=1.5u as=0.1918p ps=1.5u w=1.12u l=0.13u
X817 VSS.t80 a_2595_1047.t6 a_14311_1008# VSS.t293 sg13_lv_nmos ad=0.2516p pd=2.16u as=0.2516p ps=2.16u w=0.74u l=0.13u
X818 VSS.t100 a_12363_1842# a_12797_1842# VSS.t309 sg13_lv_nmos ad=0.1406p pd=1.12u as=0.2516p ps=2.16u w=0.74u l=0.13u
X819 a_5115_1044# a_4905_1044# VSS.t190 VSS.t392 sg13_lv_nmos ad=0.1406p pd=1.12u as=0.1665p ps=1.19u w=0.74u l=0.13u
X820 a_1256_1044# MUX_SEL0 VDD.t284 VDD.t36 sg13_lv_pmos ad=0.3808p pd=2.92u as=0.3808p ps=2.92u w=1.12u l=0.13u
X821 a_9444_3912# a_9444_4590# VSS.t561 VSS.t560 sg13_lv_nmos ad=0.38p pd=2.38u as=0.68p ps=4.68u w=2u l=1u
X822 VSS.t525 DELAY_VBIASN VSS.t523 VSS.t504 sg13_lv_nmos ad=1.33p pd=7.38u as=0 ps=0 w=7u l=7u
X823 VDD.t127 a_27563_1842# a_27997_1842# VDD.t25 sg13_lv_pmos ad=0.2128p pd=1.5u as=0.3808p ps=2.92u w=1.12u l=0.13u
X824 a_20593_1842# a_20397_1842# VDD.t93 VDD.t25 sg13_lv_pmos ad=0.3808p pd=2.92u as=0.2128p ps=1.5u w=1.12u l=0.13u
X825 a_1721_1395# a_1256_1044# VDD.t122 VDD.t36 sg13_lv_pmos ad=0.1596p pd=1.22u as=0.2856p ps=2.36u w=0.84u l=0.13u
X826 VDD.t162 a_6283_1842# a_6717_1842# VDD.t25 sg13_lv_pmos ad=0.2128p pd=1.5u as=0.3808p ps=2.92u w=1.12u l=0.13u
X827 a_13470_1044# a_14964_1008# a_14888_1044# VDD.t36 sg13_lv_pmos ad=0.3808p pd=2.92u as=0.2128p ps=1.5u w=1.12u l=0.13u
X828 a_13592_5871# a_13566_5835# VDD.t365 VDD.t1 sg13_lv_pmos ad=0.34p pd=2.68u as=0.36237p ps=2.605u w=1u l=0.13u
X829 a_5778_3367# a_6126_3816# a_6326_4590# VSS.t274 sg13_lv_nmos ad=0.68p pd=4.68u as=0.42p ps=2.42u w=2u l=1u
X830 VSS.t35 VDD.t398 VSS.t34 VSS.t33 sg13_lv_nmos ad=0.1428p pd=1.52u as=0 ps=0 w=0.42u l=1u
X831 VDD.t353 a_2019_1047.t2 a_25604_1008# VDD.t36 sg13_lv_pmos ad=0.3808p pd=2.92u as=0.3808p ps=2.92u w=1.12u l=0.13u
X832 a_9746_5805# a_9547_5942# VSS.t476 VSS.t479 sg13_lv_nmos ad=0.27427p pd=2.28u as=2.39977p ps=15.495u w=0.795u l=0.13u
X833 a_16271_1842# a_16033_1842# a_16163_1842# VSS.t228 sg13_lv_nmos ad=0.1406p pd=1.12u as=0.2516p ps=2.16u w=0.74u l=0.2u
X834 a_21835_1044# a_21625_1044# VDD.t115 VDD.t36 sg13_lv_pmos ad=0.2128p pd=1.5u as=0.252p ps=1.57u w=1.12u l=0.13u
X835 VDD.t137 VSS.t6 VDD.t164 VDD.t36 sg13_lv_pmos ad=0.34p pd=2.68u as=0 ps=0 w=1u l=1u
X836 VDD.t187 a_2595_1047.t4 a_20391_1008# VDD.t36 sg13_lv_pmos ad=0.3808p pd=2.92u as=0.3808p ps=2.92u w=1.12u l=0.13u
X837 VSS.t203 a_14851_5182# a_15688_5403# VSS.t327 sg13_lv_nmos ad=0.1406p pd=1.12u as=0.2516p ps=2.16u w=0.74u l=0.13u
X838 a_19073_1842# a_18877_1842# VDD.t102 VDD.t25 sg13_lv_pmos ad=0.3808p pd=2.92u as=0.2128p ps=1.5u w=1.12u l=0.13u
X839 VDD.t221 a_10517_1842# a_10985_1044# VDD.t36 sg13_lv_pmos ad=0.252p pd=1.57u as=0.3808p ps=2.92u w=1.12u l=0.13u
X840 VSS.t192 a_21157_1842# a_21625_1044# VSS.t191 sg13_lv_nmos ad=0.1665p pd=1.19u as=0.2516p ps=2.16u w=0.74u l=0.13u
X841 VSS.t595 a_12849_5867# a_13400_6305# VSS.t594 sg13_lv_nmos ad=0.1626p pd=1.415u as=60.89999f ps=0.71u w=0.42u l=0.13u
X842 VSS.t277 a_6126_3816# a_6126_3816# VSS.t274 sg13_lv_nmos ad=0.68p pd=4.68u as=0.38p ps=2.38u w=2u l=1u
X843 a_20071_1842# a_19833_1842# a_19963_1842# VSS.t245 sg13_lv_nmos ad=0.1406p pd=1.12u as=0.2516p ps=2.16u w=0.74u l=0.2u
X844 VSS.t357 VSS.t355 VSS.t355 VSS.t356 sg13_lv_nmos ad=0.68p pd=4.68u as=0 ps=0 w=2u l=1u
X845 VSS.t494 a_14643_1842# a_15077_1842# VSS.t584 sg13_lv_nmos ad=0.1406p pd=1.12u as=0.2516p ps=2.16u w=0.74u l=0.13u
X846 a_1815_331# a_1256_289# a_1721_331# VSS.t598 sg13_lv_nmos ad=0.1216p pd=1.02u as=0.2176p ps=1.96u w=0.64u l=0.13u
X847 VDD.t6 VDD.t4 VDD.t5 VDD.t1 sg13_lv_pmos ad=0.38p pd=2.38u as=0 ps=0 w=2u l=1u
X848 VDD.t84 a_19203_1842# a_19637_1842# VDD.t25 sg13_lv_pmos ad=0.2128p pd=1.5u as=0.3808p ps=2.92u w=1.12u l=0.13u
X849 VSS.t234 a_2019_1047.t9 a_4324_1008# VSS.t611 sg13_lv_nmos ad=0.2516p pd=2.16u as=0.2516p ps=2.16u w=0.74u l=0.13u
X850 a_16108_289# a_20905_519# a_19550_1044# VDD.t36 sg13_lv_pmos ad=0.3808p pd=2.92u as=0.3808p ps=2.92u w=1.12u l=0.13u
X851 a_16510_1044# a_3747_1047.t5 a_18795_1044# VSS.t70 sg13_lv_nmos ad=0.2516p pd=2.16u as=0.1406p ps=1.12u w=0.74u l=0.13u
X852 VDD.t240 a_8563_1842# a_8997_1842# VDD.t25 sg13_lv_pmos ad=0.2128p pd=1.5u as=0.3808p ps=2.92u w=1.12u l=0.13u
X853 VDD.t271 DELAY_VBIASP a_13231_2470# VDD.t25 sg13_lv_pmos ad=0.3808p pd=2.92u as=0.2128p ps=1.5u w=1.12u l=0.6u
X854 VSS.t107 DELAY_VBIASN a_17791_1842# VSS.t540 sg13_lv_nmos ad=0.2516p pd=2.16u as=0.1406p ps=1.12u w=0.74u l=0.6u
X855 VSS.t13 VDD.t404 VSS.t12 VSS.t11 sg13_lv_nmos ad=0.1428p pd=1.52u as=0 ps=0 w=0.42u l=1u
X856 a_6854_5986# a_6326_4590# VDD.t322 VDD.t1 sg13_lv_pmos ad=0.38p pd=2.38u as=0.38p ps=2.38u w=2u l=1u
X857 VDD.t21 VDD.t19 VDD.t20 VDD.t14 sg13_lv_pmos ad=0.3808p pd=2.92u as=0 ps=0 w=1.12u l=0.13u
X858 VDD.t39 a_3747_1047.t5 a_18871_1008# VDD.t36 sg13_lv_pmos ad=0.3808p pd=2.92u as=0.3808p ps=2.92u w=1.12u l=0.13u
X859 VDD.t16 VDD.t17 VDD.t18 VDD.t14 sg13_lv_pmos ad=0.2128p pd=1.5u as=0 ps=0 w=1.12u l=0.13u
X860 VDD.t125 a_23003_1842# a_23437_1842# VDD.t25 sg13_lv_pmos ad=0.2128p pd=1.5u as=0.3808p ps=2.92u w=1.12u l=0.13u
X861 VSS.t564 a_9444_4590# a_9444_4590# VSS.t563 sg13_lv_nmos ad=0.68p pd=4.68u as=0.38p ps=2.38u w=2u l=1u
X862 VSS.t275 VSS.t352 VSS.t352 VSS.t353 sg13_lv_nmos ad=0.68p pd=4.68u as=0 ps=0 w=2u l=1u
X863 a_12715_1044# a_12505_1044# VDD.t224 VDD.t36 sg13_lv_pmos ad=0.2128p pd=1.5u as=0.252p ps=1.57u w=1.12u l=0.13u
X864 a_19550_1044# a_21044_1008# a_20968_1044# VDD.t36 sg13_lv_pmos ad=0.3808p pd=2.92u as=0.2128p ps=1.5u w=1.12u l=0.13u
X865 a_17928_1044# a_17357_1842# VDD.t292 VDD.t36 sg13_lv_pmos ad=0.2128p pd=1.5u as=0.3808p ps=2.92u w=1.12u l=0.13u
X866 VSS.t113 DELAY_VBIASN a_21591_1842# VSS.t543 sg13_lv_nmos ad=0.2516p pd=2.16u as=0.1406p ps=1.12u w=0.74u l=0.6u
X867 VSS.t153 a_1544_289# a_1815_331# VSS.t339 sg13_lv_nmos ad=0.1331p pd=1.12u as=0.1216p ps=1.02u w=0.64u l=0.13u
X868 a_7288_1044# a_6717_1842# VDD.t329 VDD.t36 sg13_lv_pmos ad=0.2128p pd=1.5u as=0.3808p ps=2.92u w=1.12u l=0.13u
X869 VSS.t511 DELAY_VBIASN VSS.t513 VSS.t512 sg13_lv_nmos ad=1.33p pd=7.38u as=0 ps=0 w=7u l=7u
X870 a_5974_5723# a_6126_3816# VSS.t283 VSS.t209 sg13_lv_nmos ad=0.38p pd=2.38u as=0.68p ps=4.68u w=2u l=1u
X871 a_15511_2470# a_15273_1842# a_15403_1842# VDD.t25 sg13_lv_pmos ad=0.2128p pd=1.5u as=0.3808p ps=2.92u w=1.12u l=0.2u
X872 VSS.t383 VSS.t385 VSS.t387 VSS.t386 sg13_lv_nmos ad=0.1406p pd=1.12u as=0 ps=0 w=0.74u l=0.2u
X873 a_22590_1044# a_24951_1008# a_24875_1044# VDD.t36 sg13_lv_pmos ad=0.3808p pd=2.92u as=0.2128p ps=1.5u w=1.12u l=0.13u
X874 VSS.t63 VDD.t390 VSS.t63 VSS.t65 sg13_lv_nmos ad=79.8f pd=0.8u as=0 ps=0 w=0.42u l=1u
X875 VSS.t203 a_15108_5325# a_14757_5182# VSS.t202 sg13_lv_nmos ad=79.8f pd=0.8u as=0.1428p ps=1.52u w=0.42u l=0.13u
X876 a_10430_1044# a_2019_1047.t7 a_10328_1044# VSS.t304 sg13_lv_nmos ad=0.2516p pd=2.16u as=0.1406p ps=1.12u w=0.74u l=0.13u
X877 VDD.t124 a_5974_5723# a_5974_5723# VDD.t1 sg13_lv_pmos ad=0.2448p pd=2.08u as=0.2826p ps=2.29u w=0.36u l=2u
X878 VDD.t294 a_25717_1842# a_26185_1044# VDD.t36 sg13_lv_pmos ad=0.252p pd=1.57u as=0.3808p ps=2.92u w=1.12u l=0.13u
X879 a_6854_5454# a_6854_5454# a_9444_4590# VSS.t134 sg13_lv_nmos ad=0.38p pd=2.38u as=0.68p ps=4.68u w=2u l=1u
X880 VDD.t41 a_13883_1842# a_14317_1842# VDD.t25 sg13_lv_pmos ad=0.2128p pd=1.5u as=0.3808p ps=2.92u w=1.12u l=0.13u
X881 VDD.t114 a_4437_1842# a_4905_1044# VDD.t36 sg13_lv_pmos ad=0.252p pd=1.57u as=0.3808p ps=2.92u w=1.12u l=0.13u
X882 a_4157_1313# REF_CLK VSS.t195 VSS.t194 sg13_lv_nmos ad=0.2516p pd=2.16u as=0.2553p ps=2.17u w=0.74u l=0.13u
X883 a_7390_1044# a_3171_1047.t8 a_8808_1044# VSS.t329 sg13_lv_nmos ad=0.2516p pd=2.16u as=0.1406p ps=1.12u w=0.74u l=0.13u
X884 a_22873_1842# a_22677_1842# VSS.t186 VSS.t185 sg13_lv_nmos ad=0.2516p pd=2.16u as=0.1406p ps=1.12u w=0.74u l=0.13u
X885 a_9444_4590# a_9444_4590# VSS.t562 VSS.t560 sg13_lv_nmos ad=0.38p pd=2.38u as=0.68p ps=4.68u w=2u l=1u
X886 VDD.t204 a_3171_1047.t8 a_8884_1008# VDD.t36 sg13_lv_pmos ad=0.3808p pd=2.92u as=0.3808p ps=2.92u w=1.12u l=0.13u
C0 a_12233_1842# a_12797_1842# 0.0114f
C1 a_27915_1044# a_27991_1008# 0.01194f
C2 a_6326_4590# a_6854_5454# 1.25249f
C3 a_14317_1842# a_15077_1842# 0.03319f
C4 a_24393_1842# VDD 0.49285f
C5 a_1721_1395# VDD 0.4533f
C6 a_8237_1842# a_7390_1044# 0.08038f
C7 a_18585_1044# VDD 0.29722f
C8 a_22590_1044# DELAY_VBIASN 0.02115f
C9 a_26185_1044# a_26395_1044# 0.09424f
C10 a_9547_6172# a_9746_5805# 0.02437f
C11 a_5731_289# a_8745_519# 0.28635f
C12 a_9547_5942# a_9772_5843# 0.02416f
C13 a_15837_1842# a_15964_289# 0.02f
C14 a_15108_5325# DELAY_OUT_LAST 0.01399f
C15 a_9757_1842# a_10404_1008# 0.02011f
C16 a_19203_1842# VDD 0.49737f
C17 a_6717_1842# a_6711_1008# 0.02354f
C18 a_24197_1842# a_24393_1842# 0.77122f
C19 a_11277_1842# a_12037_1842# 0.03319f
C20 a_25630_1044# a_27124_1008# 0.28279f
C21 a_26395_1044# a_26471_1008# 0.01194f
C22 a_13557_1842# a_13123_1842# 0.69698f
C23 a_20397_1842# a_20593_1842# 0.76914f
C24 a_17553_1842# DELAY_VBIASP 0.11284f
C25 a_13019_5831# DELAY_OUT_LAST 0.08017f
C26 a_1256_1044# a_1721_1395# 0.13421f
C27 a_23355_1044# VDD 0.15389f
C28 a_9751_1008# VDD 0.2822f
C29 a_5974_5723# a_6854_5454# 0.01757f
C30 a_6854_5986# a_6126_3816# 0.18536f
C31 a_13880_5118# VDD 0.02994f
C32 a_21591_1842# a_21483_1842# 0.01163f
C33 a_5197_1842# a_5844_1008# 0.02312f
C34 REF_CLK DELAY_VBIASP 2.13371f
C35 a_10517_1842# a_10083_1842# 0.69698f
C36 a_14111_5878# a_14851_6228# 0.26905f
C37 a_14964_1008# VDD 0.28225f
C38 a_9712_3912# a_9444_4590# 0.39071f
C39 a_15464_3684# a_15688_5403# 0.1999f
C40 VDD MUX_SEL1 0.50267f
C41 a_19073_1842# a_19203_1842# 0.70845f
C42 a_15837_1842# DELAY_VBIASP 0.04182f
C43 a_16033_1842# DELAY_VBIASN 0.10793f
C44 a_13306_6305# VDD 0.77573f
C45 a_15464_3684# a_13121_5831# 0.33256f
C46 a_22243_1842# a_22351_2470# 0.01697f
C47 a_15964_289# a_16108_289# 0.42202f
C48 a_20391_1008# VDD 0.28336f
C49 a_21911_1008# a_21625_1044# 0.01885f
C50 a_7288_1044# VDD 0.17274f
C51 a_14111_5227# VDD 0.33926f
C52 a_20071_1842# a_19963_1842# 0.01163f
C53 a_15304_4605# DELAY_VBIASN 0.07802f
C54 a_4437_1842# a_4350_1044# 0.1088f
C55 a_19550_1044# a_21483_1842# 0.01012f
C56 a_9193_1842# a_9757_1842# 0.0114f
C57 a_13592_5871# a_14111_5878# 0.34102f
C58 a_14009_5878# a_13880_6292# 0.01562f
C59 a_12158_5867# VDD 0.37862f
C60 a_12715_1044# VDD 0.15406f
C61 a_14757_5182# a_14009_5084# 0.01058f
C62 a_9444_3912# DLL_RESETN 0.03031f
C63 a_11603_1842# DELAY_VBIASN 0.07254f
C64 a_11473_1842# DELAY_VBIASP 0.11222f
C65 a_2019_311# VDD 1.43004f
C66 a_1256_1044# MUX_SEL1 1.44243f
C67 a_1544_1044# MUX_SEL0 0.07603f
C68 a_16163_1842# VDD 0.4973f
C69 VDD a_20831_2470# 0.01806f
C70 a_14317_1842# DELAY_VBIASN 0.09974f
C71 a_13123_1842# DELAY_VBIASP 0.06627f
C72 a_20723_1842# a_20831_2470# 0.01697f
C73 a_17928_1044# VDD 0.17499f
C74 a_19550_1044# a_20105_1044# 0.03209f
C75 a_22590_1044# a_23355_1044# 0.39037f
C76 a_4350_1044# VDD 0.87635f
C77 MUX_SEL3 MUX_OUT 0.79533f
C78 a_13106_5357# VDD 0.09228f
C79 a_18551_1842# a_18443_1842# 0.01163f
C80 a_8237_1842# a_8997_1842# 0.03319f
C81 a_12849_5867# a_12943_5867# 0.16706f
C82 a_10206_5835# VDD 0.09392f
C83 a_12797_1842# VDD 0.87771f
C84 a_9953_1842# DELAY_VBIASN 0.0961f
C85 a_9757_1842# DELAY_VBIASP 0.0414f
C86 a_27991_1008# VDD 0.28201f
C87 a_14513_1842# VDD 0.49436f
C88 VDD a_14751_2470# 0.01806f
C89 a_16597_1842# a_17065_1044# 0.19203f
C90 a_5864_3367# a_6854_5454# 0.03661f
C91 a_7477_1842# a_7043_1842# 0.69698f
C92 a_6283_1842# a_6391_2470# 0.01697f
C93 a_17683_1842# a_17553_1842# 0.70845f
C94 a_19203_1842# a_19311_2470# 0.01697f
C95 a_17351_1008# a_17065_1044# 0.01885f
C96 a_6153_1842# a_6717_1842# 0.0114f
C97 a_14111_5878# REF_CLK 0.02263f
C98 a_13470_1044# MUX_SEL4 0.256f
C99 a_16510_1044# a_17357_1842# 0.08038f
C100 a_6711_1008# a_6425_1044# 0.01885f
C101 a_25717_1842# a_25604_1008# 0.05157f
C102 a_7390_1044# a_8808_1044# 0.38994f
C103 a_23945_519# VDD 0.29292f
C104 a_13019_5831# a_13045_6215# 0.01249f
C105 a_13121_5831# a_13306_6305# 0.01008f
C106 a_6126_3816# VDD 0.84141f
C107 a_10430_1044# a_12505_1044# 0.03208f
C108 a_18795_1044# a_16510_1044# 0.39036f
C109 a_10083_1842# VDD 0.49727f
C110 a_13592_5423# a_13880_5118# 0.43707f
C111 a_7043_1842# DELAY_VBIASP 0.06627f
C112 a_8237_1842# DELAY_VBIASN 0.09974f
C113 a_25528_1044# VDD 0.17274f
C114 VDD a_8671_2470# 0.01806f
C115 a_5393_1842# DELAY_VBIASP 0.11222f
C116 a_5523_1842# DELAY_VBIASN 0.07254f
C117 a_13368_1044# a_13444_1008# 0.01176f
C118 a_17683_1842# a_17791_2470# 0.01697f
C119 a_14009_5084# a_12849_5867# 0.03463f
C120 a_19550_1044# a_20968_1044# 0.38994f
C121 a_5197_1842# a_5957_1842# 0.03319f
C122 a_15831_1008# a_15837_1842# 0.02354f
C123 a_4324_1008# a_4157_1313# 0.02463f
C124 a_4350_1044# a_4905_1044# 0.03209f
C125 a_2873_331# MUX_SEL2 0.01422f
C126 a_1721_331# MUX_SEL4 0.05813f
C127 a_1544_289# MUX_OUT 0.69943f
C128 a_2297_331# MUX_SEL3 0.01595f
C129 a_26803_1842# a_26911_2470# 0.01697f
C130 a_17357_1842# a_17553_1842# 0.76914f
C131 a_11785_519# VDD 0.29292f
C132 a_27997_1842# DELAY_VBIASN 0.04657f
C133 a_26803_1842# DELAY_VBIASP 0.06661f
C134 a_8433_1842# VDD 0.49417f
C135 a_13592_5423# a_14111_5227# 0.34114f
C136 a_16271_1842# a_16163_1842# 0.01163f
C137 a_18004_1008# a_18117_1842# 0.02055f
C138 a_6717_1842# VDD 0.87726f
C139 a_11748_6109# a_12158_5867# 0.10373f
C140 a_22677_1842# DELAY_VBIASP 0.04176f
C141 a_22873_1842# DELAY_VBIASN 0.10734f
C142 a_10430_1044# a_5731_289# 0.41176f
C143 a_27237_1842# a_26803_1842# 0.6972f
C144 a_4437_1842# a_4003_1842# 0.69698f
C145 a_12355_5867# DLL_RESETN 0.04879f
C146 a_14964_1008# a_14317_1842# 0.02312f
C147 a_3449_331# a_2019_311# 0.01176f
C148 a_16033_1842# a_16163_1842# 0.70845f
C149 a_25283_1842# a_25391_2470# 0.01697f
C150 a_16923_1842# a_17031_2470# 0.01697f
C151 a_4350_1044# a_6635_1044# 0.39036f
C152 a_22590_1044# a_23945_519# 0.02165f
C153 a_4111_2470# VDD 0.01866f
C154 a_25153_1842# DELAY_VBIASP 0.11284f
C155 a_25283_1842# DELAY_VBIASN 0.08024f
C156 a_24631_2470# VDD 0.01806f
C157 a_15304_4605# a_14111_5227# 0.01761f
C158 a_13132_5420# DLL_RESETN 0.01689f
C159 a_10649_5878# REF_CLK 0.25484f
C160 a_4003_1842# VDD 0.61559f
C161 a_10232_5871# a_10751_5878# 0.34102f
C162 a_10649_5878# a_10520_6292# 0.01562f
C163 a_10430_1044# a_11195_1044# 0.39037f
C164 a_15964_289# MUX_SEL4 0.5544f
C165 a_21157_1842# DELAY_VBIASN 0.09851f
C166 a_19963_1842# DELAY_VBIASP 0.06661f
C167 a_25913_1842# a_26477_1842# 0.0114f
C168 a_13470_1044# a_13557_1842# 0.1088f
C169 a_6854_5986# a_12849_5867# 0.06216f
C170 a_1544_289# a_2297_331# 0.27303f
C171 a_1256_289# a_2873_331# 0.27926f
C172 a_23763_1842# a_23871_2470# 0.01697f
C173 a_15403_1842# a_15511_2470# 0.01697f
C174 a_22113_1842# a_22677_1842# 0.0114f
C175 a_26477_1842# VDD 0.86909f
C176 a_23633_1842# DELAY_VBIASN 0.10349f
C177 a_9323_1842# a_7390_1044# 0.01012f
C178 a_23763_1842# a_23437_1842# 0.01427f
C179 a_9946_6305# a_10206_5835# 0.75507f
C180 a_2019_311# a_17865_519# 0.13959f
C181 a_5731_289# a_15765_463# 0.23301f
C182 a_8745_519# MUX_SEL4 0.04472f
C183 a_21353_1842# VDD 0.49285f
C184 a_18443_1842# DELAY_VBIASN 0.08024f
C185 a_18313_1842# DELAY_VBIASP 0.11284f
C186 a_24957_1842# a_25717_1842# 0.06198f
C187 a_6326_4590# a_6126_3816# 2.84014f
C188 a_14317_1842# a_14513_1842# 0.76914f
C189 a_13883_1842# a_13991_2470# 0.01697f
C190 a_21157_1842# a_21917_1842# 0.02912f
C191 a_23763_1842# VDD 0.49671f
C192 a_1544_1044# VDD 0.45079f
C193 a_17065_1044# VDD 0.30218f
C194 a_27705_1044# a_25630_1044# 0.03208f
C195 a_4157_1313# DELAY_VBIASN 0.01202f
C196 a_9547_5942# a_9746_5805# 0.14994f
C197 a_14851_5182# DELAY_OUT_LAST 0.02109f
C198 a_19637_1842# VDD 0.86707f
C199 a_24197_1842# a_23763_1842# 0.6972f
C200 a_11277_1842# a_11473_1842# 0.76914f
C201 a_10843_1842# a_10951_2470# 0.01697f
C202 a_25630_1044# a_27048_1044# 0.38994f
C203 a_12993_1842# a_13123_1842# 0.70845f
C204 a_12363_1842# a_12471_2470# 0.01697f
C205 a_18117_1842# DELAY_VBIASN 0.09851f
C206 a_20397_1842# a_19963_1842# 0.6972f
C207 a_16923_1842# DELAY_VBIASP 0.06661f
C208 a_12943_5867# VDD 0.29479f
C209 a_13019_5831# DELAY_VBIASN 1.23663f
C210 a_1256_1044# a_1544_1044# 1.26509f
C211 a_6425_1044# VDD 0.29722f
C212 a_22564_1008# VDD 0.28633f
C213 a_19550_1044# DELAY_VBIASN 0.02115f
C214 a_9675_1044# VDD 0.15406f
C215 a_5974_5723# a_6126_3816# 1.74589f
C216 a_5197_1842# a_5768_1044# 0.10863f
C217 a_22488_1044# a_21917_1842# 0.10864f
C218 DLL_RESETN DELAY_VBIASP 0.07017f
C219 a_9953_1842# a_10083_1842# 0.70845f
C220 a_14111_5878# a_15108_6109# 0.03093f
C221 a_14888_1044# VDD 0.17499f
C222 a_17275_1044# a_17065_1044# 0.09424f
C223 a_9444_3912# a_9444_4590# 2.20289f
C224 a_15464_3684# a_15108_5325# 0.12158f
C225 a_9323_1842# a_9431_2470# 0.01697f
C226 VDD MUX_SEL0 0.56365f
C227 a_15273_1842# DELAY_VBIASP 0.11297f
C228 a_15403_1842# DELAY_VBIASN 0.08418f
C229 a_19073_1842# a_19637_1842# 0.0114f
C230 a_12849_5867# VDD 2.56972f
C231 a_15464_3684# a_13019_5831# 0.59875f
C232 a_15765_463# a_16108_289# 0.42004f
C233 a_20315_1044# VDD 0.15389f
C234 a_24008_1044# a_24084_1008# 0.01176f
C235 a_21835_1044# a_21625_1044# 0.09424f
C236 a_6711_1008# VDD 0.2822f
C237 a_14009_5084# VDD 0.31815f
C238 a_19550_1044# a_21917_1842# 0.02479f
C239 a_13592_5871# a_13880_6292# 0.43707f
C240 a_11491_6228# VDD 0.16753f
C241 a_11924_1008# VDD 0.28225f
C242 a_14757_5182# a_13592_5423# 0.43239f
C243 a_7803_1842# a_7911_2470# 0.01697f
C244 a_5778_3367# DLL_RESETN 0.01215f
C245 a_12037_1842# DELAY_VBIASN 0.09156f
C246 a_10843_1842# DELAY_VBIASP 0.06627f
C247 a_5705_519# VDD 0.29556f
C248 a_1256_1044# MUX_SEL0 0.3314f
C249 a_16597_1842# VDD 0.86876f
C250 VDD a_20071_2470# 0.01806f
C251 a_18117_1842# a_18585_1044# 0.2079f
C252 a_13557_1842# DELAY_VBIASP 0.0414f
C253 a_13753_1842# DELAY_VBIASN 0.0961f
C254 a_17351_1008# VDD 0.28565f
C255 a_22590_1044# a_22564_1008# 0.277f
C256 a_4248_1044# VDD 0.17587f
C257 a_8231_1008# a_7945_1044# 0.01885f
C258 MUX_SEL2 MUX_OUT 0.08497f
C259 MUX_SEL3 MUX_SEL4 0.75489f
C260 a_26477_1842# a_27124_1008# 0.02312f
C261 a_19524_1008# a_19637_1842# 0.05157f
C262 a_8237_1842# a_8433_1842# 0.76914f
C263 a_13306_6305# a_14009_5878# 0.02432f
C264 a_13121_5831# a_12943_5867# 0.09118f
C265 a_12791_1008# a_12505_1044# 0.01885f
C266 a_14757_5182# a_15304_4605# 0.02225f
C267 a_12233_1842# VDD 0.49285f
C268 a_27915_1044# VDD 0.15389f
C269 a_9323_1842# DELAY_VBIASN 0.07254f
C270 a_9193_1842# DELAY_VBIASP 0.11222f
C271 a_13883_1842# VDD 0.49742f
C272 a_9712_3912# a_6854_5454# 0.6789f
C273 a_5864_3367# a_6126_3816# 0.23738f
C274 VDD a_13991_2470# 0.01806f
C275 a_6913_1842# a_7043_1842# 0.70845f
C276 a_7477_1842# DELAY_VBIASP 0.0414f
C277 a_13470_1044# a_15831_1008# 0.26208f
C278 a_6635_1044# a_6425_1044# 0.09424f
C279 a_25717_1842# a_25630_1044# 0.1088f
C280 a_7390_1044# a_8231_1008# 0.28268f
C281 a_20905_519# VDD 0.29292f
C282 a_13121_5831# a_12849_5867# 0.55272f
C283 a_6854_5986# VDD 1.20794f
C284 a_10430_1044# a_10985_1044# 0.03209f
C285 a_18004_1008# a_16510_1044# 0.28279f
C286 a_17351_1008# a_17275_1044# 0.01194f
C287 a_10517_1842# VDD 0.86707f
C288 a_14111_5227# a_15108_5325# 0.03012f
C289 a_13306_5105# a_13880_5118# 0.31978f
C290 a_7673_1842# DELAY_VBIASN 0.0961f
C291 a_24951_1008# VDD 0.2822f
C292 a_4157_1313# a_2019_311# 0.01018f
C293 VDD a_7911_2470# 0.01806f
C294 a_7390_1044# a_5731_289# 0.41331f
C295 a_13368_1044# a_13470_1044# 0.37183f
C296 a_5957_1842# DELAY_VBIASN 0.09156f
C297 a_4763_1842# DELAY_VBIASP 0.06627f
C298 a_13592_5423# a_12849_5867# 0.38497f
C299 a_24957_1842# a_16108_289# 0.0157f
C300 a_19550_1044# a_20391_1008# 0.28268f
C301 a_5197_1842# a_5393_1842# 0.76914f
C302 a_10430_1044# MUX_SEL4 0.24983f
C303 a_4350_1044# a_4157_1313# 0.04624f
C304 a_2297_331# MUX_SEL2 0.10655f
C305 a_1256_289# MUX_OUT 0.1134f
C306 a_1544_289# MUX_SEL4 0.47529f
C307 a_17357_1842# a_16923_1842# 0.6972f
C308 a_6635_1044# a_6711_1008# 0.01194f
C309 a_27433_1842# DELAY_VBIASN 0.10734f
C310 a_27237_1842# DELAY_VBIASP 0.06225f
C311 a_13306_5105# a_14111_5227# 0.097f
C312 a_7803_1842# VDD 0.4973f
C313 a_13592_5423# a_14009_5084# 0.3749f
C314 a_9444_4590# DLL_RESETN 0.10275f
C315 a_6153_1842# VDD 0.49285f
C316 a_9712_3912# DELAY_VBIASN 0.22281f
C317 a_11748_6109# a_11491_6228# 0.34468f
C318 a_11848_1044# a_11924_1008# 0.01176f
C319 a_15304_4605# a_12849_5867# 0.0606f
C320 a_22243_1842# DELAY_VBIASN 0.08024f
C321 a_22113_1842# DELAY_VBIASP 0.11286f
C322 a_26673_1842# a_26803_1842# 0.70845f
C323 a_18795_1044# a_18871_1008# 0.01194f
C324 a_14888_1044# a_14317_1842# 0.10863f
C325 a_16033_1842# a_16597_1842# 0.0114f
C326 a_4350_1044# a_5844_1008# 0.28279f
C327 a_5115_1044# a_5191_1008# 0.01194f
C328 a_27563_1842# VDD 0.49811f
C329 a_24523_1842# DELAY_VBIASP 0.06661f
C330 a_25717_1842# DELAY_VBIASN 0.09106f
C331 a_12907_5420# a_13132_5420# 0.02416f
C332 a_23871_2470# VDD 0.01806f
C333 a_22590_1044# a_24951_1008# 0.26208f
C334 a_12907_5420# DLL_RESETN 0.04234f
C335 a_10649_5878# DLL_RESETN 0.05713f
C336 a_10232_5871# REF_CLK 0.08086f
C337 a_4437_1842# VDD 0.86998f
C338 a_10232_5871# a_10520_6292# 0.43707f
C339 a_10430_1044# a_10404_1008# 0.277f
C340 a_15765_463# MUX_SEL4 0.65508f
C341 a_23437_1842# VDD 0.86909f
C342 a_20397_1842# DELAY_VBIASP 0.04176f
C343 a_20593_1842# DELAY_VBIASN 0.10398f
C344 a_15464_3684# a_9712_3912# 0.01237f
C345 a_1544_289# a_1721_331# 0.36963f
C346 a_1256_289# a_2297_331# 0.04261f
C347 a_6854_5986# a_13121_5831# 0.10056f
C348 a_15077_1842# a_15837_1842# 0.02912f
C349 a_21917_1842# a_22243_1842# 0.01427f
C350 a_25913_1842# VDD 0.49294f
C351 a_23003_1842# DELAY_VBIASN 0.08024f
C352 a_23111_2470# VDD 0.01806f
C353 a_9757_1842# a_7390_1044# 0.02479f
C354 a_24197_1842# a_23437_1842# 0.03319f
C355 a_13592_5423# a_6854_5986# 0.01958f
C356 a_27705_1044# a_27991_1008# 0.01885f
C357 a_2019_311# a_16851_309# 0.01299f
C358 a_5731_289# a_14825_519# 0.28056f
C359 a_10843_1842# a_10430_1044# 0.01012f
C360 a_20723_1842# VDD 0.49671f
C361 a_7477_1842# a_7364_1008# 0.05157f
C362 a_17683_1842# DELAY_VBIASP 0.06661f
C363 a_18877_1842# DELAY_VBIASN 0.10687f
C364 a_24957_1842# a_25153_1842# 0.76914f
C365 a_12037_1842# a_12797_1842# 0.02912f
C366 a_6326_4590# a_6854_5986# 1.31745f
C367 a_16510_1044# DELAY_VBIASN 0.02115f
C368 a_14751_1842# a_14643_1842# 0.01163f
C369 a_14317_1842# a_13883_1842# 0.6972f
C370 a_21157_1842# a_21353_1842# 0.77122f
C371 a_24197_1842# VDD 0.85848f
C372 a_1256_1044# VDD 0.475f
C373 a_15545_1044# VDD 0.29918f
C374 a_15304_4605# a_6854_5986# 0.08165f
C375 a_26185_1044# a_25630_1044# 0.03209f
C376 a_9547_5942# a_9547_6172# 0.1117f
C377 a_4437_1842# a_4905_1044# 0.19203f
C378 a_9757_1842# a_10328_1044# 0.10864f
C379 a_19073_1842# VDD 0.49426f
C380 a_22590_1044# a_23437_1842# 0.08038f
C381 a_23633_1842# a_23763_1842# 0.70845f
C382 a_11277_1842# a_10843_1842# 0.6972f
C383 a_11603_1842# a_11711_1842# 0.01163f
C384 a_17275_1044# VDD 0.15389f
C385 a_25630_1044# a_26471_1008# 0.28268f
C386 a_13231_1842# a_13123_1842# 0.01163f
C387 a_12993_1842# a_13557_1842# 0.0114f
C388 a_19833_1842# a_19963_1842# 0.70845f
C389 a_17357_1842# DELAY_VBIASP 0.04176f
C390 a_17553_1842# DELAY_VBIASN 0.10734f
C391 a_16108_289# a_26985_519# 0.2906f
C392 a_22590_1044# VDD 0.89557f
C393 a_4905_1044# VDD 0.30126f
C394 a_23431_1008# a_23145_1044# 0.01885f
C395 a_8884_1008# VDD 0.28225f
C396 a_5974_5723# a_6854_5986# 0.029f
C397 a_25630_1044# a_16108_289# 0.55833f
C398 a_15688_5403# VDD 0.30345f
C399 a_5197_1842# a_5191_1008# 0.02349f
C400 a_5957_1842# a_4350_1044# 0.05231f
C401 a_21911_1008# a_21917_1842# 0.02354f
C402 REF_CLK DELAY_VBIASN 0.07156f
C403 a_9953_1842# a_10517_1842# 0.0114f
C404 a_10083_1842# a_10191_1842# 0.01163f
C405 a_14311_1008# VDD 0.28336f
C406 a_16510_1044# a_18585_1044# 0.03208f
C407 a_5778_3367# a_9444_4590# 0.19787f
C408 a_15464_3684# a_14851_5182# 0.04797f
C409 a_18877_1842# a_19203_1842# 0.01427f
C410 a_14643_1842# DELAY_VBIASP 0.06668f
C411 a_15837_1842# DELAY_VBIASN 0.10875f
C412 a_13121_5831# VDD 0.99724f
C413 a_22590_1044# a_24197_1842# 0.05231f
C414 a_15765_463# a_15964_289# 0.061f
C415 a_19524_1008# VDD 0.28633f
C416 a_6635_1044# VDD 0.15406f
C417 a_13592_5423# VDD 0.11685f
C418 a_21044_1008# a_20397_1842# 0.02312f
C419 a_8997_1842# a_9757_1842# 0.02912f
C420 a_8563_1842# a_8671_1842# 0.01163f
C421 a_11748_6109# VDD 0.16819f
C422 a_11848_1044# VDD 0.17499f
C423 a_11473_1842# DELAY_VBIASN 0.0961f
C424 a_11277_1842# DELAY_VBIASP 0.0414f
C425 a_3449_331# VDD 0.46596f
C426 a_16033_1842# VDD 0.49413f
C427 VDD a_19311_2470# 0.01806f
C428 a_13123_1842# DELAY_VBIASN 0.07254f
C429 a_12993_1842# DELAY_VBIASP 0.11222f
C430 a_6326_4590# VDD 7.53039f
C431 a_22488_1044# a_22564_1008# 0.01176f
C432 a_6913_1842# a_7477_1842# 0.0114f
C433 a_8155_1044# a_7945_1044# 0.09424f
C434 MUX_SEL2 MUX_SEL4 0.01978f
C435 MUX_SEL1 MUX_OUT 0.09357f
C436 a_26477_1842# a_27048_1044# 0.10863f
C437 a_15304_4605# VDD 0.72158f
C438 a_19550_1044# a_19637_1842# 0.1088f
C439 a_8237_1842# a_7803_1842# 0.6972f
C440 a_12849_5867# a_14009_5878# 0.03525f
C441 a_7043_1842# a_7151_1842# 0.01163f
C442 a_13306_6305# a_13592_5871# 0.41329f
C443 a_13019_5831# a_12943_5867# 0.03346f
C444 a_9946_6305# VDD 0.77198f
C445 a_12715_1044# a_12505_1044# 0.09424f
C446 a_11603_1842# VDD 0.49671f
C447 a_8563_1842# DELAY_VBIASP 0.06627f
C448 a_9757_1842# DELAY_VBIASN 0.09992f
C449 a_27124_1008# VDD 0.28225f
C450 VDD a_13231_2470# 0.01806f
C451 a_14317_1842# VDD 0.87229f
C452 a_3449_1395# MUX_SEL1 0.29404f
C453 a_9444_3912# a_6854_5454# 0.8486f
C454 a_5523_1842# a_5631_1842# 0.01163f
C455 a_7390_1044# MUX_SEL4 0.34655f
C456 a_6913_1842# DELAY_VBIASP 0.11222f
C457 a_13470_1044# a_15755_1044# 0.39036f
C458 a_17683_1842# a_17357_1842# 0.01427f
C459 a_15688_5403# a_13121_5831# 0.01441f
C460 a_15108_5325# a_12849_5867# 0.10521f
C461 a_16510_1044# a_2019_311# 0.03139f
C462 a_5957_1842# a_6717_1842# 0.02912f
C463 a_16484_1008# a_16597_1842# 0.05157f
C464 a_2019_311# MUX_OUT 8.45486f
C465 a_7390_1044# a_8155_1044# 0.39037f
C466 a_17865_519# VDD 0.29444f
C467 a_13019_5831# a_12849_5867# 0.12838f
C468 a_5974_5723# VDD 0.91576f
C469 a_17928_1044# a_16510_1044# 0.38994f
C470 a_9953_1842# VDD 0.49426f
C471 a_14111_5227# a_14851_5182# 0.26905f
C472 a_7043_1842# DELAY_VBIASN 0.07254f
C473 VDD a_7151_2470# 0.01806f
C474 a_21917_1842# a_16108_289# 0.0157f
C475 DELAY_OUT_LAST DELAY_VBIASP 1.08837f
C476 a_4003_1842# a_4111_1842# 0.01163f
C477 a_5197_1842# DELAY_VBIASP 0.0414f
C478 a_5393_1842# DELAY_VBIASN 0.0961f
C479 a_13306_5105# a_12849_5867# 0.10976f
C480 REF_CLK MUX_SEL1 0.01858f
C481 a_27997_1842# a_27563_1842# 0.69646f
C482 a_13306_6305# REF_CLK 0.05059f
C483 a_5197_1842# a_4763_1842# 0.6972f
C484 a_19550_1044# a_20315_1044# 0.39037f
C485 a_2019_311# a_5731_289# 1.15781f
C486 a_4248_1044# a_4157_1313# 0.11672f
C487 a_1544_289# MUX_SEL3 0.15976f
C488 a_1721_331# MUX_SEL2 0.01315f
C489 a_1256_289# MUX_SEL4 0.65005f
C490 a_16793_1842# a_16923_1842# 0.70845f
C491 a_26803_1842# DELAY_VBIASN 0.08024f
C492 a_26673_1842# DELAY_VBIASP 0.11284f
C493 a_8237_1842# VDD 0.86909f
C494 a_13306_5105# a_14009_5084# 0.02454f
C495 VDD a_6391_2470# 0.01806f
C496 a_4350_1044# a_5731_289# 0.41099f
C497 a_12158_5867# REF_CLK 0.01309f
C498 a_5523_1842# VDD 0.49671f
C499 a_10751_5878# a_11491_6228# 0.26905f
C500 a_15304_4605# a_13121_5831# 0.40921f
C501 a_12797_1842# a_13444_1008# 0.02011f
C502 a_22677_1842# DELAY_VBIASN 0.0907f
C503 a_21483_1842# DELAY_VBIASP 0.06661f
C504 a_26673_1842# a_27237_1842# 0.0114f
C505 a_14311_1008# a_14317_1842# 0.02349f
C506 a_13470_1044# a_15077_1842# 0.05231f
C507 a_2297_331# a_2019_311# 0.04011f
C508 a_15837_1842# a_16163_1842# 0.01427f
C509 a_4350_1044# a_5768_1044# 0.38994f
C510 a_22873_1842# a_23437_1842# 0.0114f
C511 a_27997_1842# VDD 0.76025f
C512 a_24957_1842# DELAY_VBIASP 0.04176f
C513 a_25153_1842# DELAY_VBIASN 0.10332f
C514 a_15304_4605# a_13592_5423# 0.01817f
C515 a_12907_5186# DLL_RESETN 0.02177f
C516 a_9757_1842# a_9751_1008# 0.02354f
C517 a_10232_5871# DLL_RESETN 0.39088f
C518 a_5864_3367# VDD 0.13532f
C519 a_7477_1842# a_7945_1044# 0.19203f
C520 a_10328_1044# a_10404_1008# 0.01176f
C521 a_14825_519# MUX_SEL4 0.03307f
C522 a_12037_1842# a_11924_1008# 0.02055f
C523 a_22873_1842# VDD 0.49294f
C524 a_19963_1842# DELAY_VBIASN 0.08024f
C525 a_19833_1842# DELAY_VBIASP 0.11284f
C526 a_25717_1842# a_26477_1842# 0.01669f
C527 a_1256_289# a_1721_331# 0.13421f
C528 a_15077_1842# a_15273_1842# 0.77122f
C529 a_21917_1842# a_22677_1842# 0.06198f
C530 a_27671_1842# a_27563_1842# 0.01163f
C531 a_25283_1842# VDD 0.49737f
C532 a_19550_1044# a_20905_519# 0.02165f
C533 a_8237_1842# a_8884_1008# 0.02312f
C534 a_23633_1842# a_23437_1842# 0.76914f
C535 a_27705_1044# a_27915_1044# 0.09424f
C536 a_13470_1044# a_14825_519# 0.02058f
C537 a_6854_5454# DLL_RESETN 0.03626f
C538 a_5957_1842# a_6425_1044# 0.2079f
C539 a_2019_311# a_16108_289# 0.33889f
C540 a_5731_289# a_11785_519# 0.28056f
C541 a_21157_1842# VDD 0.85848f
C542 a_11277_1842# a_10430_1044# 0.08038f
C543 a_7477_1842# a_7390_1044# 0.1088f
C544 a_18313_1842# DELAY_VBIASN 0.10734f
C545 a_24957_1842# a_24523_1842# 0.6972f
C546 a_12037_1842# a_12233_1842# 0.77122f
C547 a_6326_4590# a_5974_5723# 0.33136f
C548 a_12797_1842# a_13123_1842# 0.01427f
C549 a_13753_1842# a_13883_1842# 0.70845f
C550 a_21157_1842# a_20723_1842# 0.6972f
C551 a_26151_1842# a_26043_1842# 0.01163f
C552 a_23633_1842# VDD 0.49417f
C553 a_15688_5867# VDD 0.30345f
C554 a_7390_1044# a_8745_519# 0.01756f
C555 a_14025_1044# VDD 0.30409f
C556 a_4437_1842# a_4157_1313# 0.01771f
C557 a_18443_1842# VDD 0.4973f
C558 a_23633_1842# a_24197_1842# 0.0114f
C559 a_10713_1842# a_10843_1842# 0.70845f
C560 a_16484_1008# VDD 0.28597f
C561 a_13470_1044# DELAY_VBIASN 0.02115f
C562 a_25630_1044# a_26395_1044# 0.39037f
C563 a_16923_1842# DELAY_VBIASN 0.08024f
C564 a_19833_1842# a_20397_1842# 0.0114f
C565 a_16793_1842# DELAY_VBIASP 0.11284f
C566 a_24631_1842# a_24523_1842# 0.01163f
C567 a_14009_5878# VDD 0.23872f
C568 a_16108_289# a_23945_519# 0.2906f
C569 a_4157_1313# VDD 0.48935f
C570 a_22488_1044# VDD 0.17274f
C571 a_23355_1044# a_23145_1044# 0.09424f
C572 a_8808_1044# VDD 0.17499f
C573 a_15108_5325# VDD 0.13728f
C574 a_2297_1395# MUX_SEL1 0.01995f
C575 DLL_RESETN DELAY_VBIASN 0.12907f
C576 a_9757_1842# a_10083_1842# 0.01427f
C577 a_14009_5878# a_14757_6228# 0.01058f
C578 a_13880_6292# a_14111_5878# 0.12701f
C579 a_14235_1044# VDD 0.15389f
C580 a_14757_5182# a_14851_5182# 0.28931f
C581 a_16510_1044# a_17065_1044# 0.03209f
C582 a_4003_1842# REF_CLK 0.55467f
C583 a_1544_1044# MUX_OUT 0.04258f
C584 a_18117_1842# VDD 0.85848f
C585 a_15077_1842# DELAY_VBIASP 0.04184f
C586 a_15273_1842# DELAY_VBIASN 0.10803f
C587 a_18877_1842# a_19637_1842# 0.06198f
C588 a_23111_1842# a_23003_1842# 0.01163f
C589 a_13019_5831# VDD 0.41932f
C590 a_6326_4590# a_5864_3367# 0.01889f
C591 a_19550_1044# VDD 0.89766f
C592 a_5844_1008# VDD 0.28225f
C593 a_13306_5105# VDD 0.79678f
C594 a_20968_1044# a_20397_1842# 0.10863f
C595 a_8997_1842# a_9193_1842# 0.77122f
C596 a_10751_5878# VDD 0.20377f
C597 a_13121_5831# a_15688_5867# 0.17255f
C598 a_12849_5867# a_14851_6228# 0.13392f
C599 a_11271_1008# VDD 0.28336f
C600 a_14311_1008# a_14025_1044# 0.01885f
C601 a_10843_1842# DELAY_VBIASN 0.07254f
C602 a_10713_1842# DELAY_VBIASP 0.11222f
C603 a_2873_331# VDD 0.46491f
C604 a_15403_1842# VDD 0.4973f
C605 a_25630_1044# DELAY_VBIASP 0.01522f
C606 VDD a_18551_2470# 0.01806f
C607 a_13557_1842# DELAY_VBIASN 0.08375f
C608 a_12363_1842# DELAY_VBIASP 0.06627f
C609 a_15755_1044# a_15831_1008# 0.01194f
C610 a_22488_1044# a_22590_1044# 0.37183f
C611 a_18871_1008# a_18585_1044# 0.01885f
C612 a_27705_1044# VDD 0.29918f
C613 a_7390_1044# a_9465_1044# 0.03208f
C614 a_27237_1842# a_25630_1044# 0.05253f
C615 a_26477_1842# a_26471_1008# 0.02349f
C616 MUX_SEL2 MUX_SEL3 3.21891f
C617 MUX_SEL1 MUX_SEL4 0.03574f
C618 a_8808_1044# a_8884_1008# 0.01176f
C619 a_7673_1842# a_7803_1842# 0.70845f
C620 a_13121_5831# a_14009_5878# 0.01604f
C621 a_13306_6305# a_13566_5835# 0.75507f
C622 a_9772_5843# VDD 0.24701f
C623 a_12849_5867# a_13592_5871# 0.38817f
C624 a_12037_1842# VDD 0.85848f
C625 a_9193_1842# DELAY_VBIASN 0.0961f
C626 a_8997_1842# DELAY_VBIASP 0.04141f
C627 a_27048_1044# VDD 0.17499f
C628 a_13753_1842# VDD 0.49349f
C629 a_5864_3367# a_5974_5723# 0.01697f
C630 a_5778_3367# a_6854_5454# 0.02695f
C631 a_9712_3912# a_6854_5986# 0.83268f
C632 a_9444_3912# a_6126_3816# 0.25721f
C633 VDD a_12471_2470# 0.01806f
C634 a_3449_1395# MUX_SEL0 0.10753f
C635 a_6717_1842# a_7043_1842# 0.01427f
C636 a_6283_1842# DELAY_VBIASP 0.06627f
C637 a_7477_1842# DELAY_VBIASN 0.08375f
C638 a_13470_1044# a_14964_1008# 0.28279f
C639 a_14235_1044# a_14311_1008# 0.01194f
C640 a_15304_4605# a_15688_5867# 0.19136f
C641 a_15688_5403# a_13019_5831# 0.1287f
C642 a_14851_5182# a_12849_5867# 0.13376f
C643 a_15108_5325# a_13121_5831# 0.05903f
C644 a_20968_1044# a_21044_1008# 0.01176f
C645 a_16510_1044# a_16597_1842# 0.1088f
C646 a_5957_1842# a_6153_1842# 0.77122f
C647 a_2019_311# MUX_SEL4 0.90276f
C648 a_24957_1842# a_25604_1008# 0.02011f
C649 a_7390_1044# a_7364_1008# 0.277f
C650 a_16851_309# VDD 0.51536f
C651 a_12656_5864# a_12849_5867# 0.33075f
C652 a_12355_5867# a_13306_6305# 0.26489f
C653 a_13019_5831# a_13121_5831# 0.56469f
C654 a_17351_1008# a_16510_1044# 0.28268f
C655 a_9323_1842# VDD 0.4973f
C656 a_4763_1842# a_4871_2470# 0.01697f
C657 DELAY_VBIASN DELAY_VBIASP 8.74838f
C658 a_4350_1044# MUX_SEL4 0.31434f
C659 a_4633_1842# DELAY_VBIASP 0.11222f
C660 a_4763_1842# DELAY_VBIASN 0.07254f
C661 REF_CLK MUX_SEL0 0.14089f
C662 a_13566_5328# a_12849_5867# 0.26617f
C663 a_27433_1842# a_27563_1842# 0.70845f
C664 a_12849_5867# REF_CLK 0.26382f
C665 a_19550_1044# a_19524_1008# 0.277f
C666 a_4633_1842# a_4763_1842# 0.70845f
C667 a_12158_5867# a_12355_5867# 0.12454f
C668 a_5705_519# a_5731_289# 0.28954f
C669 a_12797_1842# MUX_SEL4 0.01829f
C670 a_1256_289# MUX_SEL3 1.41161f
C671 a_1544_289# MUX_SEL2 0.07405f
C672 a_16793_1842# a_17357_1842# 0.0114f
C673 a_27237_1842# DELAY_VBIASN 0.10152f
C674 a_26043_1842# DELAY_VBIASP 0.06661f
C675 a_7673_1842# VDD 0.49294f
C676 a_13306_5105# a_13592_5423# 0.41329f
C677 a_15304_4605# a_15108_5325# 0.01986f
C678 a_13566_5328# a_14009_5084# 0.02242f
C679 a_24875_1044# a_24951_1008# 0.01194f
C680 a_18004_1008# a_17357_1842# 0.02312f
C681 a_11491_6228# REF_CLK 0.01827f
C682 a_12158_5867# DLL_RESETN 0.02442f
C683 a_5957_1842# VDD 0.85848f
C684 a_10649_5878# a_11397_6228# 0.01058f
C685 a_10751_5878# a_11748_6109# 0.03061f
C686 a_10430_1044# a_12791_1008# 0.26208f
C687 a_15304_4605# a_13019_5831# 0.07025f
C688 a_21917_1842# DELAY_VBIASP 0.04176f
C689 a_22113_1842# DELAY_VBIASN 0.10263f
C690 a_26477_1842# a_26803_1842# 0.01427f
C691 a_1721_331# a_2019_311# 0.18452f
C692 a_15837_1842# a_16597_1842# 0.06198f
C693 a_4350_1044# a_5191_1008# 0.28268f
C694 a_27433_1842# VDD 0.49285f
C695 a_24523_1842# DELAY_VBIASN 0.08024f
C696 a_24393_1842# DELAY_VBIASP 0.11284f
C697 a_12907_5186# a_12907_5420# 0.1117f
C698 a_13106_5357# a_13132_5420# 0.1657f
C699 a_8997_1842# a_9465_1044# 0.2079f
C700 a_13106_5357# DLL_RESETN 0.01263f
C701 a_9444_4590# a_6854_5454# 1.25013f
C702 a_10206_5835# DLL_RESETN 0.27343f
C703 a_9712_3912# VDD 0.23242f
C704 a_12797_1842# DLL_RESETN 0.0106f
C705 a_9946_6305# a_10751_5878# 0.097f
C706 a_10232_5871# a_10649_5878# 0.37583f
C707 a_10328_1044# a_10430_1044# 0.37183f
C708 a_11785_519# MUX_SEL4 0.03255f
C709 a_22243_1842# VDD 0.49737f
C710 a_19203_1842# DELAY_VBIASP 0.06661f
C711 a_20397_1842# DELAY_VBIASN 0.10669f
C712 a_25717_1842# a_25913_1842# 0.73897f
C713 a_1256_289# a_1544_289# 1.25711f
C714 a_15077_1842# a_14643_1842# 0.6972f
C715 a_21917_1842# a_22113_1842# 0.76914f
C716 a_25717_1842# VDD 0.86707f
C717 a_6717_1842# MUX_SEL4 0.0195f
C718 a_8237_1842# a_8808_1044# 0.10863f
C719 a_23003_1842# a_23437_1842# 0.6972f
C720 a_6126_3816# DLL_RESETN 0.06398f
C721 a_6854_5986# REF_CLK 0.05061f
C722 a_2019_311# a_15964_289# 0.02413f
C723 a_9772_5843# a_9946_6305# 0.27179f
C724 a_20593_1842# VDD 0.49417f
C725 a_17683_1842# DELAY_VBIASN 0.07847f
C726 a_24393_1842# a_24523_1842# 0.70845f
C727 a_12037_1842# a_11603_1842# 0.6972f
C728 a_10430_1044# a_12363_1842# 0.01012f
C729 a_27048_1044# a_27124_1008# 0.01176f
C730 a_12797_1842# a_13557_1842# 0.06198f
C731 a_23003_1842# a_23111_2470# 0.01697f
C732 a_13753_1842# a_14317_1842# 0.0114f
C733 a_1544_1044# a_2297_1395# 0.28651f
C734 a_20593_1842# a_20723_1842# 0.70845f
C735 a_23003_1842# VDD 0.4973f
C736 a_14851_6228# VDD 0.25326f
C737 a_24875_1044# VDD 0.15406f
C738 a_12505_1044# VDD 0.29722f
C739 a_22351_1842# a_22243_1842# 0.01163f
C740 a_18877_1842# VDD 0.87825f
C741 a_22564_1008# a_22677_1842# 0.05157f
C742 a_10713_1842# a_11277_1842# 0.0114f
C743 a_14851_6228# a_14757_6228# 0.28931f
C744 a_16510_1044# VDD 0.8795f
C745 a_25630_1044# a_25604_1008# 0.277f
C746 VDD MUX_OUT 0.35871f
C747 a_16163_1842# DELAY_VBIASP 0.06661f
C748 a_17357_1842# DELAY_VBIASN 0.10669f
C749 a_13592_5871# VDD 0.07242f
C750 a_16108_289# a_20905_519# 0.2906f
C751 a_21911_1008# VDD 0.2822f
C752 a_3449_1395# VDD 0.46731f
C753 a_8231_1008# VDD 0.28336f
C754 a_2297_1395# MUX_SEL0 0.10655f
C755 a_14851_5182# VDD 0.26676f
C756 a_20831_1842# a_20723_1842# 0.01163f
C757 a_4763_1842# a_4350_1044# 0.01012f
C758 a_9757_1842# a_10517_1842# 0.06198f
C759 a_13592_5871# a_14757_6228# 0.43239f
C760 a_13444_1008# VDD 0.28633f
C761 a_10430_1044# DELAY_VBIASN 0.02115f
C762 a_4437_1842# REF_CLK 0.05209f
C763 a_12797_1842# DELAY_VBIASP 0.0414f
C764 a_5731_289# VDD 0.6143f
C765 a_1544_1044# MUX_SEL4 0.03407f
C766 a_1256_1044# MUX_OUT 0.02466f
C767 a_17553_1842# VDD 0.49417f
C768 a_18877_1842# a_19073_1842# 0.76914f
C769 a_14643_1842# DELAY_VBIASN 0.08431f
C770 a_14513_1842# DELAY_VBIASP 0.12091f
C771 a_12656_5864# VDD 0.26066f
C772 a_22590_1044# a_23003_1842# 0.01012f
C773 a_16510_1044# a_17275_1044# 0.39037f
C774 a_6326_4590# a_9712_3912# 0.04741f
C775 a_21483_1842# a_21591_2470# 0.01697f
C776 a_19448_1044# VDD 0.17274f
C777 a_22590_1044# a_24875_1044# 0.39036f
C778 a_5768_1044# VDD 0.17499f
C779 a_9751_1008# a_9465_1044# 0.01885f
C780 a_13566_5328# VDD 0.0947f
C781 a_19311_1842# a_19203_1842# 0.01163f
C782 VDD REF_CLK 2.08015f
C783 a_20391_1008# a_20397_1842# 0.02349f
C784 a_19550_1044# a_21157_1842# 0.05231f
C785 a_8997_1842# a_8563_1842# 0.6972f
C786 a_13121_5831# a_14851_6228# 0.03404f
C787 a_12849_5867# a_15108_6109# 0.10225f
C788 a_13306_6305# a_14111_5878# 0.097f
C789 a_13019_5831# a_15688_5867# 0.0195f
C790 a_11195_1044# VDD 0.15389f
C791 a_6126_3816# DELAY_VBIASP 0.01821f
C792 a_14235_1044# a_14025_1044# 0.09424f
C793 a_10083_1842# DELAY_VBIASP 0.06627f
C794 a_11277_1842# DELAY_VBIASN 0.09974f
C795 a_2297_331# VDD 0.46496f
C796 a_15837_1842# VDD 0.87963f
C797 VDD a_17791_2470# 0.01806f
C798 a_12993_1842# DELAY_VBIASN 0.0961f
C799 a_19963_1842# a_20071_2470# 0.01697f
C800 a_18795_1044# a_18585_1044# 0.09424f
C801 a_6717_1842# a_7477_1842# 0.06198f
C802 a_26185_1044# VDD 0.30409f
C803 a_7390_1044# a_7945_1044# 0.03209f
C804 a_17791_1842# a_17683_1842# 0.01163f
C805 a_19524_1008# a_18877_1842# 0.02011f
C806 a_7673_1842# a_8237_1842# 0.0114f
C807 a_13121_5831# a_13592_5871# 0.01445f
C808 a_12849_5867# a_13566_5835# 0.27346f
C809 a_9746_5805# VDD 0.0918f
C810 a_11473_1842# VDD 0.49417f
C811 a_14851_5182# a_15688_5403# 0.08776f
C812 a_8433_1842# DELAY_VBIASP 0.11222f
C813 a_8563_1842# DELAY_VBIASN 0.07254f
C814 a_26471_1008# VDD 0.28336f
C815 a_13123_1842# VDD 0.49727f
C816 VDD a_11711_2470# 0.01806f
C817 a_9712_3912# a_5974_5723# 0.01152f
C818 a_5778_3367# a_6126_3816# 1.6143f
C819 a_6913_1842# DELAY_VBIASN 0.0961f
C820 a_6717_1842# DELAY_VBIASP 0.0414f
C821 a_13470_1044# a_14888_1044# 0.38994f
C822 a_18443_1842# a_18551_2470# 0.01697f
C823 a_15304_4605# a_14851_6228# 0.12139f
C824 a_14851_5182# a_13121_5831# 0.03337f
C825 a_5957_1842# a_5523_1842# 0.6972f
C826 a_12943_5867# DLL_RESETN 0.03616f
C827 a_5705_519# MUX_SEL4 0.03556f
C828 a_2019_311# MUX_SEL3 0.06209f
C829 a_27563_1842# a_27671_2470# 0.01697f
C830 a_7288_1044# a_7364_1008# 0.01176f
C831 a_16108_289# VDD 1.25759f
C832 a_12355_5867# a_12849_5867# 0.07687f
C833 a_9757_1842# VDD 0.87771f
C834 a_13592_5423# a_14851_5182# 0.01529f
C835 a_17031_1842# a_16923_1842# 0.01163f
C836 DELAY_VBIASN DELAY_OUT_LAST 3.19293f
C837 a_4003_1842# DELAY_VBIASP 0.05992f
C838 a_5197_1842# DELAY_VBIASN 0.09974f
C839 a_13132_5420# a_12849_5867# 0.06758f
C840 a_27433_1842# a_27997_1842# 0.0114f
C841 a_12849_5867# DLL_RESETN 0.3501f
C842 a_13121_5831# REF_CLK 1.40135f
C843 a_19448_1044# a_19524_1008# 0.01176f
C844 a_4633_1842# a_5197_1842# 0.0114f
C845 a_1256_289# MUX_SEL2 0.33134f
C846 a_26043_1842# a_26151_2470# 0.01697f
C847 a_26673_1842# DELAY_VBIASN 0.105f
C848 a_26477_1842# DELAY_VBIASP 0.04181f
C849 a_7043_1842# VDD 0.49723f
C850 a_10517_1842# a_10985_1044# 0.19203f
C851 a_15304_4605# a_14851_5182# 0.05156f
C852 a_13566_5328# a_13592_5423# 0.36952f
C853 a_27671_2470# VDD 0.01806f
C854 a_15511_1842# a_15403_1842# 0.01163f
C855 a_13592_5423# REF_CLK 0.03445f
C856 a_17928_1044# a_17357_1842# 0.10863f
C857 a_16510_1044# a_17865_519# 0.02165f
C858 a_11491_6228# DLL_RESETN 0.14622f
C859 a_11748_6109# REF_CLK 0.0148f
C860 a_5393_1842# VDD 0.49417f
C861 a_10232_5871# a_11397_6228# 0.43239f
C862 a_15464_3684# DELAY_OUT_LAST 0.02565f
C863 a_10430_1044# a_12715_1044# 0.39036f
C864 a_3449_331# REF_CLK 0.01017f
C865 a_12797_1842# a_13368_1044# 0.10864f
C866 a_21483_1842# DELAY_VBIASN 0.08024f
C867 a_21353_1842# DELAY_VBIASP 0.11284f
C868 a_26477_1842# a_27237_1842# 0.03319f
C869 a_13470_1044# a_13883_1842# 0.01012f
C870 a_1544_289# a_2019_311# 0.01747f
C871 a_24523_1842# a_24631_2470# 0.01697f
C872 a_15837_1842# a_16033_1842# 0.76914f
C873 a_16163_1842# a_16271_2470# 0.01697f
C874 a_4350_1044# a_5115_1044# 0.39037f
C875 a_22677_1842# a_23437_1842# 0.01669f
C876 a_26803_1842# VDD 0.49671f
C877 a_22590_1044# a_16108_289# 0.58202f
C878 a_24957_1842# DELAY_VBIASN 0.10687f
C879 a_23763_1842# DELAY_VBIASP 0.06661f
C880 a_13106_5357# a_12907_5420# 0.14994f
C881 a_15304_4605# REF_CLK 0.01066f
C882 a_9444_4590# a_6126_3816# 0.03029f
C883 a_9444_3912# VDD 0.0107f
C884 a_9946_6305# a_10520_6292# 0.31978f
C885 a_10206_5835# a_10649_5878# 0.02242f
C886 a_12797_1842# a_10430_1044# 0.02479f
C887 a_22677_1842# VDD 0.86707f
C888 a_19833_1842# DELAY_VBIASN 0.10734f
C889 a_19637_1842# DELAY_VBIASP 0.04176f
C890 a_25717_1842# a_25283_1842# 0.69698f
C891 a_14513_1842# a_14643_1842# 0.70845f
C892 a_14643_1842# a_14751_2470# 0.01697f
C893 a_2297_1395# VDD 0.46536f
C894 a_21917_1842# a_21483_1842# 0.6972f
C895 a_25153_1842# VDD 0.49426f
C896 a_23145_1044# VDD 0.30409f
C897 a_23003_1842# a_22873_1842# 0.70845f
C898 a_8997_1842# a_7390_1044# 0.05231f
C899 a_8237_1842# a_8231_1008# 0.02349f
C900 a_13132_5420# a_6854_5986# 0.01367f
C901 a_6854_5986# DLL_RESETN 0.50331f
C902 a_2019_311# a_15765_463# 0.05969f
C903 a_19963_1842# VDD 0.4973f
C904 a_10517_1842# a_10404_1008# 0.05157f
C905 a_6717_1842# a_7364_1008# 0.02011f
C906 a_24084_1008# a_23437_1842# 0.02312f
C907 a_24393_1842# a_24957_1842# 0.0114f
C908 a_11473_1842# a_11603_1842# 0.70845f
C909 a_11603_1842# a_11711_2470# 0.01697f
C910 a_12797_1842# a_12993_1842# 0.76914f
C911 a_13123_1842# a_13231_2470# 0.01697f
C912 a_1256_1044# a_2297_1395# 0.04619f
C913 a_20593_1842# a_21157_1842# 0.0114f
C914 a_15108_6109# VDD 0.1349f
C915 a_10985_1044# VDD 0.30409f
C916 a_24084_1008# VDD 0.28225f
C917 a_24665_1044# a_24951_1008# 0.01885f
C918 a_10430_1044# a_11785_519# 0.02058f
C919 a_7390_1044# DELAY_VBIASN 0.02115f
C920 a_25630_1044# a_26985_519# 0.02165f
C921 a_14111_5227# DELAY_OUT_LAST 0.02024f
C922 a_18313_1842# VDD 0.49285f
C923 a_5957_1842# a_5844_1008# 0.02055f
C924 a_22590_1044# a_22677_1842# 0.1088f
C925 a_14851_6228# a_15688_5867# 0.08776f
C926 a_16408_1044# VDD 0.17274f
C927 a_25528_1044# a_25604_1008# 0.01176f
C928 a_10083_1842# a_10191_2470# 0.01697f
C929 VDD MUX_SEL4 2.63176f
C930 a_16597_1842# DELAY_VBIASP 0.04176f
C931 a_19637_1842# a_20397_1842# 0.01669f
C932 a_16793_1842# DELAY_VBIASN 0.10734f
C933 a_13566_5835# VDD 0.09466f
C934 a_24084_1008# a_24197_1842# 0.02055f
C935 a_9712_3912# a_13019_5831# 0.03275f
C936 a_16108_289# a_17865_519# 0.29564f
C937 a_21835_1044# VDD 0.15406f
C938 a_22590_1044# a_23145_1044# 0.03209f
C939 a_8155_1044# VDD 0.15389f
C940 a_5197_1842# a_4350_1044# 0.08038f
C941 a_9757_1842# a_9953_1842# 0.76914f
C942 a_13470_1044# VDD 0.87936f
C943 a_8563_1842# a_8671_2470# 0.01697f
C944 a_12233_1842# DELAY_VBIASP 0.11222f
C945 a_16923_1842# VDD 0.4973f
C946 a_1256_1044# MUX_SEL4 0.04908f
C947 a_18877_1842# a_18443_1842# 0.6972f
C948 a_15077_1842# DELAY_VBIASN 0.10039f
C949 a_13883_1842# DELAY_VBIASP 0.06627f
C950 a_12355_5867# VDD 0.37639f
C951 a_16510_1044# a_18443_1842# 0.01012f
C952 a_16510_1044# a_16484_1008# 0.277f
C953 a_18871_1008# VDD 0.2822f
C954 a_23355_1044# a_23431_1008# 0.01194f
C955 a_22590_1044# a_24084_1008# 0.28279f
C956 a_20391_1008# a_20105_1044# 0.01885f
C957 a_5191_1008# VDD 0.28565f
C958 a_9675_1044# a_9465_1044# 0.09424f
C959 a_13132_5420# VDD 0.23863f
C960 VDD DLL_RESETN 2.47079f
C961 a_8433_1842# a_8563_1842# 0.70845f
C962 a_13019_5831# a_14851_6228# 0.01651f
C963 a_13306_6305# a_13880_6292# 0.31978f
C964 a_12849_5867# a_14111_5878# 0.42174f
C965 a_13121_5831# a_15108_6109# 0.03701f
C966 a_13592_5871# a_14009_5878# 0.37583f
C967 a_10404_1008# VDD 0.28633f
C968 a_13470_1044# a_15545_1044# 0.03208f
C969 a_6854_5986# DELAY_VBIASP 0.01478f
C970 a_7043_1842# a_7151_2470# 0.01697f
C971 a_10517_1842# DELAY_VBIASP 0.0414f
C972 a_10713_1842# DELAY_VBIASN 0.0961f
C973 a_1721_331# VDD 0.45259f
C974 a_25630_1044# DELAY_VBIASN 0.02756f
C975 a_15273_1842# VDD 0.49298f
C976 VDD a_17031_2470# 0.01806f
C977 a_12363_1842# DELAY_VBIASN 0.07254f
C978 a_18877_1842# a_18117_1842# 0.02912f
C979 a_6717_1842# a_6913_1842# 0.76914f
C980 a_16510_1044# a_18117_1842# 0.05231f
C981 a_24665_1044# VDD 0.29722f
C982 a_26043_1842# a_25630_1044# 0.01012f
C983 a_7390_1044# a_9751_1008# 0.26208f
C984 a_13019_5831# a_13592_5871# 0.04178f
C985 a_13121_5831# a_13566_5835# 0.01158f
C986 a_9547_6172# VDD 0.08695f
C987 a_10843_1842# VDD 0.4973f
C988 a_14851_5182# a_15108_5325# 0.29858f
C989 a_26395_1044# VDD 0.15389f
C990 a_8997_1842# DELAY_VBIASN 0.09156f
C991 a_7803_1842# DELAY_VBIASP 0.06627f
C992 a_13557_1842# VDD 0.86707f
C993 VDD a_10951_2470# 0.01806f
C994 a_2873_1395# MUX_SEL1 0.13092f
C995 a_24665_1044# a_24197_1842# 0.2079f
C996 a_13470_1044# a_14311_1008# 0.28268f
C997 a_6153_1842# DELAY_VBIASP 0.11222f
C998 a_6283_1842# DELAY_VBIASN 0.07254f
C999 a_15304_4605# a_15108_6109# 0.17528f
C1000 a_19550_1044# a_21911_1008# 0.26208f
C1001 a_16484_1008# a_15837_1842# 0.02011f
C1002 a_14009_5878# REF_CLK 0.25847f
C1003 a_5393_1842# a_5523_1842# 0.70845f
C1004 a_5191_1008# a_4905_1044# 0.01885f
C1005 a_3449_331# MUX_SEL4 0.05166f
C1006 a_17553_1842# a_18117_1842# 0.0114f
C1007 a_24957_1842# a_25528_1044# 0.10864f
C1008 a_7288_1044# a_7390_1044# 0.37183f
C1009 a_15964_289# VDD 0.31312f
C1010 a_4157_1313# REF_CLK 0.50643f
C1011 a_27563_1842# DELAY_VBIASP 0.06663f
C1012 a_12656_5864# a_13019_5831# 0.04193f
C1013 a_12355_5867# a_13121_5831# 0.05795f
C1014 a_9193_1842# VDD 0.49285f
C1015 a_12037_1842# a_12505_1044# 0.2079f
C1016 a_7477_1842# VDD 0.86707f
C1017 a_4437_1842# DELAY_VBIASP 0.0414f
C1018 a_4633_1842# DELAY_VBIASN 0.0961f
C1019 a_12715_1044# a_12791_1008# 0.01194f
C1020 a_23437_1842# DELAY_VBIASP 0.04176f
C1021 a_19448_1044# a_19550_1044# 0.37183f
C1022 a_13121_5831# DLL_RESETN 0.04337f
C1023 a_13019_5831# REF_CLK 0.35409f
C1024 a_14964_1008# a_15077_1842# 0.02055f
C1025 a_24665_1044# a_22590_1044# 0.03208f
C1026 a_16597_1842# a_17357_1842# 0.01669f
C1027 a_5768_1044# a_5844_1008# 0.01176f
C1028 a_8745_519# VDD 0.29292f
C1029 a_26043_1842# DELAY_VBIASN 0.08024f
C1030 a_25913_1842# DELAY_VBIASP 0.11284f
C1031 a_13566_5328# a_13306_5105# 0.75507f
C1032 a_26911_2470# VDD 0.01806f
C1033 a_13306_5105# REF_CLK 0.06166f
C1034 a_17351_1008# a_17357_1842# 0.02349f
C1035 VDD DELAY_VBIASP 14.6649f
C1036 a_16510_1044# a_16851_309# 0.02131f
C1037 a_11748_6109# DLL_RESETN 0.11133f
C1038 a_10751_5878# REF_CLK 0.01931f
C1039 a_4763_1842# VDD 0.4973f
C1040 a_10520_6292# a_10751_5878# 0.12701f
C1041 a_10430_1044# a_11924_1008# 0.28279f
C1042 a_11195_1044# a_11271_1008# 0.01194f
C1043 a_16851_309# MUX_OUT 0.45865f
C1044 a_12797_1842# a_12791_1008# 0.02354f
C1045 a_20723_1842# DELAY_VBIASP 0.06661f
C1046 a_21917_1842# DELAY_VBIASN 0.10687f
C1047 a_26477_1842# a_26673_1842# 0.76914f
C1048 a_17928_1044# a_18004_1008# 0.01176f
C1049 a_9444_3912# a_5864_3367# 0.02483f
C1050 a_13470_1044# a_14317_1842# 0.08038f
C1051 a_1256_289# a_2019_311# 0.02904f
C1052 a_15837_1842# a_15403_1842# 0.6972f
C1053 a_4350_1044# a_4324_1008# 0.277f
C1054 a_22677_1842# a_22873_1842# 0.73897f
C1055 a_27237_1842# VDD 0.85969f
C1056 a_24197_1842# DELAY_VBIASP 0.04177f
C1057 a_24393_1842# DELAY_VBIASN 0.10734f
C1058 a_13106_5357# a_12907_5186# 0.02437f
C1059 a_15304_4605# DLL_RESETN 0.03137f
C1060 a_9444_4590# a_6854_5986# 0.02502f
C1061 a_9946_6305# DLL_RESETN 0.09997f
C1062 a_10206_5835# a_10232_5871# 0.36952f
C1063 a_22113_1842# VDD 0.49426f
C1064 a_11277_1842# a_11924_1008# 0.02312f
C1065 a_19073_1842# DELAY_VBIASP 0.11286f
C1066 a_19203_1842# DELAY_VBIASN 0.07852f
C1067 a_25153_1842# a_25283_1842# 0.70845f
C1068 a_14513_1842# a_15077_1842# 0.0114f
C1069 a_21353_1842# a_21483_1842# 0.70845f
C1070 a_19550_1044# a_16108_289# 0.58202f
C1071 a_24523_1842# VDD 0.4973f
C1072 a_21625_1044# VDD 0.29722f
C1073 a_5974_5723# DLL_RESETN 0.02002f
C1074 a_9746_5805# a_9772_5843# 0.1657f
C1075 a_10517_1842# a_10430_1044# 0.1088f
C1076 a_20397_1842# VDD 0.86909f
C1077 a_24008_1044# a_23437_1842# 0.10863f
C1078 a_11473_1842# a_12037_1842# 0.0114f
C1079 a_12797_1842# a_12363_1842# 0.6972f
C1080 a_25630_1044# a_27991_1008# 0.26208f
C1081 a_13991_1842# a_13883_1842# 0.01163f
C1082 a_13557_1842# a_14317_1842# 0.01669f
C1083 a_20397_1842# a_20723_1842# 0.01427f
C1084 a_14111_5878# VDD 0.21331f
C1085 a_12849_5867# DELAY_OUT_LAST 0.01791f
C1086 a_9465_1044# VDD 0.29722f
C1087 a_24008_1044# VDD 0.17499f
C1088 a_6126_3816# a_6854_5454# 0.22705f
C1089 a_14009_5084# DELAY_OUT_LAST 0.25594f
C1090 a_17683_1842# VDD 0.49671f
C1091 a_6283_1842# a_4350_1044# 0.01012f
C1092 a_19637_1842# a_20105_1044# 0.19203f
C1093 a_10517_1842# a_11277_1842# 0.01669f
C1094 a_10843_1842# a_10951_1842# 0.01163f
C1095 a_15831_1008# VDD 0.2816f
C1096 a_25528_1044# a_25630_1044# 0.37183f
C1097 a_12471_1842# a_12363_1842# 0.01163f
C1098 VDD MUX_SEL3 0.4053f
C1099 a_19637_1842# a_19833_1842# 0.73897f
C1100 a_16163_1842# DELAY_VBIASN 0.08306f
C1101 a_16033_1842# DELAY_VBIASP 0.11287f
C1102 a_22590_1044# a_24523_1842# 0.01012f
C1103 a_16108_289# a_16851_309# 0.06181f
C1104 a_21044_1008# VDD 0.28225f
C1105 a_7364_1008# VDD 0.28633f
C1106 a_4350_1044# DELAY_VBIASN 0.02115f
C1107 a_9444_4590# VDD 0.01557f
C1108 a_9757_1842# a_9323_1842# 0.6972f
C1109 a_9323_1842# a_9431_1842# 0.01163f
C1110 a_13592_5871# a_14851_6228# 0.01529f
C1111 a_13368_1044# VDD 0.17274f
C1112 a_15831_1008# a_15545_1044# 0.01885f
C1113 a_5864_3367# DLL_RESETN 0.1727f
C1114 a_9712_3912# REF_CLK 0.06562f
C1115 a_12797_1842# DELAY_VBIASN 0.09992f
C1116 a_11603_1842# DELAY_VBIASP 0.06627f
C1117 a_17357_1842# VDD 0.86909f
C1118 VDD a_22351_2470# 0.01806f
C1119 a_18313_1842# a_18443_1842# 0.70845f
C1120 a_14513_1842# DELAY_VBIASN 0.102f
C1121 a_14317_1842# DELAY_VBIASP 0.04316f
C1122 a_16510_1044# a_18877_1842# 0.02479f
C1123 a_16408_1044# a_16484_1008# 0.01176f
C1124 a_6326_4590# a_5778_3367# 0.8779f
C1125 a_18795_1044# VDD 0.15406f
C1126 a_20315_1044# a_20105_1044# 0.09424f
C1127 a_22590_1044# a_24008_1044# 0.38994f
C1128 a_5115_1044# VDD 0.15389f
C1129 a_27237_1842# a_27124_1008# 0.02055f
C1130 a_12907_5420# VDD 0.07751f
C1131 a_19550_1044# a_19963_1842# 0.01012f
C1132 a_8433_1842# a_8997_1842# 0.0114f
C1133 a_7803_1842# a_7911_1842# 0.01163f
C1134 a_13566_5835# a_14009_5878# 0.02242f
C1135 a_13121_5831# a_14111_5878# 0.0235f
C1136 a_10430_1044# VDD 0.88416f
C1137 a_10649_5878# VDD 0.23431f
C1138 a_13470_1044# a_14025_1044# 0.03209f
C1139 a_6854_5986# DELAY_OUT_LAST 0.08491f
C1140 a_9953_1842# DELAY_VBIASP 0.11222f
C1141 a_10083_1842# DELAY_VBIASN 0.07254f
C1142 a_1544_289# VDD 0.39113f
C1143 a_14643_1842# VDD 0.49675f
C1144 VDD a_16271_2470# 0.01806f
C1145 a_4157_1313# MUX_SEL4 0.08229f
C1146 a_7477_1842# a_8237_1842# 0.01669f
C1147 a_6283_1842# a_6391_1842# 0.01163f
C1148 a_26185_1044# a_25717_1842# 0.19203f
C1149 a_18313_1842# a_18117_1842# 0.77122f
C1150 a_6717_1842# a_6283_1842# 0.6972f
C1151 a_5731_289# MUX_OUT 1.04829f
C1152 a_26477_1842# a_25630_1044# 0.08038f
C1153 MUX_SEL0 MUX_SEL2 0.01204f
C1154 a_7390_1044# a_9675_1044# 0.39036f
C1155 a_19448_1044# a_18877_1842# 0.10864f
C1156 a_9547_5942# VDD 0.1511f
C1157 a_11271_1008# a_10985_1044# 0.01885f
C1158 a_11277_1842# VDD 0.86909f
C1159 a_14111_5227# a_13880_5118# 0.12701f
C1160 a_8237_1842# DELAY_VBIASP 0.0414f
C1161 a_8433_1842# DELAY_VBIASN 0.0961f
C1162 a_25604_1008# VDD 0.28633f
C1163 a_12993_1842# VDD 0.49426f
C1164 VDD a_10191_2470# 0.01806f
C1165 a_5778_3367# a_5974_5723# 2.88221f
C1166 a_2873_1395# MUX_SEL0 0.01504f
C1167 a_4763_1842# a_4871_1842# 0.01163f
C1168 a_5523_1842# DELAY_VBIASP 0.06627f
C1169 a_6717_1842# DELAY_VBIASN 0.09992f
C1170 a_13470_1044# a_14235_1044# 0.39037f
C1171 a_15304_4605# a_14111_5878# 0.01811f
C1172 a_19550_1044# a_21835_1044# 0.39036f
C1173 a_5393_1842# a_5957_1842# 0.0114f
C1174 a_13592_5871# REF_CLK 0.11539f
C1175 a_5115_1044# a_4905_1044# 0.09424f
C1176 a_2297_331# MUX_OUT 0.01179f
C1177 a_3449_331# MUX_SEL3 0.28429f
C1178 a_2873_331# MUX_SEL4 0.04916f
C1179 a_24957_1842# a_24951_1008# 0.02354f
C1180 a_15765_463# VDD 0.35368f
C1181 a_3449_1395# REF_CLK 0.01058f
C1182 a_27997_1842# DELAY_VBIASP 0.04038f
C1183 a_12355_5867# a_13019_5831# 0.3846f
C1184 a_8563_1842# VDD 0.49671f
C1185 a_13557_1842# a_14025_1044# 0.19203f
C1186 a_6913_1842# VDD 0.49426f
C1187 a_11491_6228# a_11397_6228# 0.28931f
C1188 a_5864_3367# DELAY_VBIASP 0.03252f
C1189 a_4003_1842# DELAY_VBIASN 0.06486f
C1190 a_6326_4590# a_9444_4590# 0.01269f
C1191 a_22873_1842# DELAY_VBIASP 0.11284f
C1192 a_4437_1842# a_5197_1842# 0.01669f
C1193 a_12656_5864# REF_CLK 0.01215f
C1194 a_13019_5831# DLL_RESETN 0.01429f
C1195 a_13470_1044# a_15403_1842# 0.01012f
C1196 a_16597_1842# a_16793_1842# 0.73897f
C1197 a_5631_2470# VDD 0.01806f
C1198 a_25283_1842# DELAY_VBIASP 0.06661f
C1199 a_26477_1842# DELAY_VBIASN 0.1083f
C1200 a_26151_2470# VDD 0.01806f
C1201 a_13132_5420# a_13306_5105# 0.27179f
C1202 a_13566_5328# REF_CLK 0.01093f
C1203 a_18877_1842# a_16108_289# 0.0157f
C1204 VDD DELAY_OUT_LAST 0.70591f
C1205 a_4350_1044# a_2019_311# 0.02042f
C1206 a_16510_1044# a_16108_289# 0.56108f
C1207 a_10751_5878# DLL_RESETN 0.45018f
C1208 a_5197_1842# VDD 0.86909f
C1209 a_10232_5871# a_11491_6228# 0.01529f
C1210 a_10430_1044# a_11848_1044# 0.38994f
C1211 a_16108_289# MUX_OUT 0.24265f
C1212 a_21157_1842# DELAY_VBIASP 0.04177f
C1213 a_21353_1842# DELAY_VBIASN 0.10734f
C1214 a_26477_1842# a_26043_1842# 0.6972f
C1215 a_9444_3912# a_9712_3912# 0.72189f
C1216 a_5778_3367# a_5864_3367# 0.07306f
C1217 a_15273_1842# a_15403_1842# 0.70845f
C1218 a_4248_1044# a_4324_1008# 0.01176f
C1219 a_22677_1842# a_22243_1842# 0.69698f
C1220 a_26673_1842# VDD 0.49417f
C1221 a_23763_1842# DELAY_VBIASN 0.08024f
C1222 a_23633_1842# DELAY_VBIASP 0.11286f
C1223 a_9772_5843# DLL_RESETN 0.06592f
C1224 a_9946_6305# a_10649_5878# 0.02432f
C1225 a_5731_289# a_16108_289# 0.01334f
C1226 a_21483_1842# VDD 0.4973f
C1227 a_11277_1842# a_11848_1044# 0.10863f
C1228 a_19637_1842# DELAY_VBIASN 0.0907f
C1229 a_18443_1842# DELAY_VBIASP 0.06661f
C1230 a_25153_1842# a_25717_1842# 0.0114f
C1231 a_14317_1842# a_14643_1842# 0.01427f
C1232 a_21353_1842# a_21917_1842# 0.0114f
C1233 a_26911_1842# a_26803_1842# 0.01163f
C1234 a_24957_1842# VDD 0.87825f
C1235 a_7803_1842# a_7390_1044# 0.01012f
C1236 a_20105_1044# VDD 0.30409f
C1237 a_26185_1044# a_26471_1008# 0.01885f
C1238 a_15688_5403# DELAY_OUT_LAST 0.01699f
C1239 a_19833_1842# VDD 0.49294f
C1240 a_6717_1842# a_7288_1044# 0.10864f
C1241 a_23431_1008# a_23437_1842# 0.02349f
C1242 a_21157_1842# a_21625_1044# 0.2079f
C1243 a_24197_1842# a_24957_1842# 0.02912f
C1244 a_11277_1842# a_11603_1842# 0.01427f
C1245 a_25630_1044# a_27915_1044# 0.39036f
C1246 a_12233_1842# a_12363_1842# 0.70845f
C1247 a_13557_1842# a_13753_1842# 0.73897f
C1248 a_18117_1842# DELAY_VBIASP 0.04177f
C1249 a_20397_1842# a_21157_1842# 0.03319f
C1250 a_25391_1842# a_25283_1842# 0.01163f
C1251 a_13121_5831# DELAY_OUT_LAST 0.13178f
C1252 a_13019_5831# DELAY_VBIASP 0.02377f
C1253 a_1544_1044# a_1721_1395# 0.38063f
C1254 a_7945_1044# VDD 0.30409f
C1255 a_23431_1008# VDD 0.28336f
C1256 a_6854_5986# a_6854_5454# 0.30378f
C1257 a_13592_5423# DELAY_OUT_LAST 0.08062f
C1258 a_6717_1842# a_4350_1044# 0.02479f
C1259 a_22564_1008# a_21917_1842# 0.02011f
C1260 a_10517_1842# a_10713_1842# 0.73897f
C1261 a_15108_6109# a_14851_6228# 0.29858f
C1262 a_15755_1044# VDD 0.15389f
C1263 a_5864_3367# a_9444_4590# 0.06832f
C1264 VDD MUX_SEL2 0.50938f
C1265 a_19637_1842# a_19203_1842# 0.69698f
C1266 a_16597_1842# DELAY_VBIASN 0.0907f
C1267 a_15403_1842# DELAY_VBIASP 0.06668f
C1268 a_23871_1842# a_23763_1842# 0.01163f
C1269 a_22590_1044# a_24957_1842# 0.02479f
C1270 a_15964_289# a_16851_309# 0.16757f
C1271 a_2873_1395# VDD 0.46517f
C1272 a_20968_1044# VDD 0.17499f
C1273 a_7390_1044# VDD 0.8686f
C1274 a_15304_4605# DELAY_OUT_LAST 0.05582f
C1275 a_4437_1842# a_4324_1008# 0.05157f
C1276 a_21044_1008# a_21157_1842# 0.02055f
C1277 a_9193_1842# a_9323_1842# 0.70845f
C1278 a_14009_5878# a_14111_5878# 0.47795f
C1279 a_12791_1008# VDD 0.2822f
C1280 a_15755_1044# a_15545_1044# 0.09424f
C1281 a_9712_3912# DLL_RESETN 0.4243f
C1282 a_12037_1842# DELAY_VBIASP 0.04141f
C1283 a_12233_1842# DELAY_VBIASN 0.0961f
C1284 a_1544_1044# MUX_SEL1 0.1672f
C1285 a_16793_1842# VDD 0.49277f
C1286 a_1721_1395# MUX_SEL0 0.01315f
C1287 VDD a_21591_2470# 0.01806f
C1288 a_13753_1842# DELAY_VBIASP 0.11222f
C1289 a_13883_1842# DELAY_VBIASN 0.07254f
C1290 a_18313_1842# a_18877_1842# 0.0114f
C1291 a_27705_1044# a_27237_1842# 0.2079f
C1292 a_16408_1044# a_16510_1044# 0.37183f
C1293 a_1256_1044# a_2873_1395# 0.28892f
C1294 a_18004_1008# VDD 0.28225f
C1295 a_19550_1044# a_21625_1044# 0.03208f
C1296 a_22590_1044# a_23431_1008# 0.28268f
C1297 a_4324_1008# VDD 0.28597f
C1298 a_12907_5186# VDD 0.06323f
C1299 a_27563_1842# a_25630_1044# 0.01024f
C1300 MUX_SEL4 MUX_OUT 0.91933f
C1301 a_9675_1044# a_9751_1008# 0.01194f
C1302 a_19550_1044# a_20397_1842# 0.08038f
C1303 a_8237_1842# a_8563_1842# 0.01427f
C1304 a_13566_5835# a_13592_5871# 0.36952f
C1305 a_10232_5871# VDD 0.07206f
C1306 a_10328_1044# VDD 0.17274f
C1307 a_6854_5986# DELAY_VBIASN 0.15808f
C1308 a_10517_1842# DELAY_VBIASN 0.08375f
C1309 a_9323_1842# DELAY_VBIASP 0.06627f
C1310 a_1256_289# VDD 0.40292f
C1311 a_15077_1842# VDD 0.85965f
C1312 VDD a_15511_2470# 0.01806f
C1313 a_7477_1842# a_7673_1842# 0.73897f
C1314 a_14888_1044# a_14964_1008# 0.01176f
C1315 a_17683_1842# a_18117_1842# 0.6972f
C1316 a_21835_1044# a_21911_1008# 0.01194f
C1317 a_6153_1842# a_6283_1842# 0.70845f
C1318 a_16510_1044# a_16923_1842# 0.01012f
C1319 a_5731_289# MUX_SEL4 4.60702f
C1320 MUX_SEL0 MUX_SEL1 3.14917f
C1321 a_8155_1044# a_8231_1008# 0.01194f
C1322 a_7390_1044# a_8884_1008# 0.28279f
C1323 a_26985_519# VDD 0.29292f
C1324 a_18871_1008# a_18877_1842# 0.02354f
C1325 a_12849_5867# a_13306_6305# 0.12097f
C1326 a_6854_5454# VDD 1.03678f
C1327 a_11195_1044# a_10985_1044# 0.09424f
C1328 a_18871_1008# a_16510_1044# 0.26208f
C1329 a_14009_5084# a_13880_5118# 0.01562f
C1330 a_10713_1842# VDD 0.49294f
C1331 a_5523_1842# a_5631_2470# 0.01697f
C1332 a_25630_1044# VDD 0.89531f
C1333 a_7803_1842# DELAY_VBIASN 0.07254f
C1334 a_7673_1842# DELAY_VBIASP 0.11222f
C1335 a_12363_1842# VDD 0.4973f
C1336 VDD a_9431_2470# 0.01806f
C1337 a_15077_1842# a_15545_1044# 0.2079f
C1338 a_6153_1842# DELAY_VBIASN 0.0961f
C1339 a_5957_1842# DELAY_VBIASP 0.04141f
C1340 a_13470_1044# a_13444_1008# 0.277f
C1341 REF_CLK MUX_SEL4 0.0663f
C1342 a_14111_5227# a_12849_5867# 0.42064f
C1343 a_13470_1044# a_5731_289# 0.41365f
C1344 a_19550_1044# a_21044_1008# 0.28279f
C1345 a_20315_1044# a_20391_1008# 0.01194f
C1346 a_13566_5835# REF_CLK 0.01538f
C1347 a_5197_1842# a_5523_1842# 0.01427f
C1348 a_16408_1044# a_15837_1842# 0.10864f
C1349 a_4350_1044# a_6425_1044# 0.03208f
C1350 a_24665_1044# a_24875_1044# 0.09424f
C1351 a_2873_331# MUX_SEL3 0.12606f
C1352 a_2297_331# MUX_SEL4 0.04338f
C1353 a_3449_331# MUX_SEL2 0.10741f
C1354 a_17357_1842# a_18117_1842# 0.03319f
C1355 a_14825_519# VDD 0.29292f
C1356 a_27433_1842# DELAY_VBIASP 0.11284f
C1357 a_27563_1842# DELAY_VBIASN 0.08029f
C1358 a_27997_1842# DELAY_OUT_LAST 0.70957f
C1359 a_12355_5867# a_12656_5864# 0.03277f
C1360 a_14009_5084# a_14111_5227# 0.47622f
C1361 a_8997_1842# VDD 0.85848f
C1362 a_4003_1842# a_4111_2470# 0.01697f
C1363 a_6283_1842# VDD 0.4973f
C1364 a_4437_1842# DELAY_VBIASN 0.08375f
C1365 a_11491_6228# a_12158_5867# 0.0894f
C1366 a_9712_3912# DELAY_VBIASP 0.14197f
C1367 a_22243_1842# DELAY_VBIASP 0.06661f
C1368 a_23437_1842# DELAY_VBIASN 0.10669f
C1369 a_27237_1842# a_27433_1842# 0.77122f
C1370 a_12355_5867# REF_CLK 1.0042f
C1371 a_12656_5864# DLL_RESETN 0.11782f
C1372 a_13470_1044# a_15837_1842# 0.02479f
C1373 a_4437_1842# a_4633_1842# 0.73897f
C1374 a_5705_519# a_2019_311# 0.13872f
C1375 a_16597_1842# a_16163_1842# 0.69698f
C1376 a_4350_1044# a_6711_1008# 0.26208f
C1377 a_4871_2470# VDD 0.01806f
C1378 a_25717_1842# DELAY_VBIASP 0.04176f
C1379 a_25913_1842# DELAY_VBIASN 0.10734f
C1380 a_25391_2470# VDD 0.01806f
C1381 a_13132_5420# REF_CLK 0.02025f
C1382 VDD DELAY_VBIASN 1.49209f
C1383 DLL_RESETN REF_CLK 10.7961f
C1384 a_4350_1044# a_5705_519# 0.02005f
C1385 a_16510_1044# a_15964_289# 0.05416f
C1386 a_4633_1842# VDD 0.49285f
C1387 a_10649_5878# a_10751_5878# 0.47795f
C1388 a_10430_1044# a_11271_1008# 0.28268f
C1389 a_16108_289# MUX_SEL4 0.1283f
C1390 a_15964_289# MUX_OUT 0.01307f
C1391 a_20593_1842# DELAY_VBIASP 0.11287f
C1392 a_20723_1842# DELAY_VBIASN 0.07937f
C1393 a_25913_1842# a_26043_1842# 0.70845f
C1394 a_13444_1008# a_13557_1842# 0.05157f
C1395 a_9757_1842# MUX_SEL4 0.01829f
C1396 a_15273_1842# a_15837_1842# 0.0114f
C1397 a_4248_1044# a_4350_1044# 0.37183f
C1398 a_22113_1842# a_22243_1842# 0.70845f
C1399 a_26043_1842# VDD 0.4973f
C1400 a_24197_1842# DELAY_VBIASN 0.09851f
C1401 a_23003_1842# DELAY_VBIASP 0.06661f
C1402 a_8997_1842# a_8884_1008# 0.02055f
C1403 a_15464_3684# VDD 0.52511f
C1404 a_9946_6305# a_10232_5871# 0.41329f
C1405 a_5731_289# a_15964_289# 0.2778f
C1406 a_11277_1842# a_11271_1008# 0.02349f
C1407 a_12037_1842# a_10430_1044# 0.05231f
C1408 a_21917_1842# VDD 0.87825f
C1409 a_22677_1842# a_23145_1044# 0.19203f
C1410 a_18877_1842# DELAY_VBIASP 0.04176f
C1411 a_19073_1842# DELAY_VBIASN 0.10642f
C1412 a_24957_1842# a_25283_1842# 0.01427f
R0 VDD.n131 VDD.t128 17.3693
R1 VDD.n119 VDD.t57 17.3693
R2 VDD.n119 VDD.t219 17.3693
R3 VDD.n130 VDD.t153 17.3517
R4 VDD.n122 VDD.t308 17.3517
R5 VDD.n121 VDD.t235 17.3517
R6 VDD.n73 VDD.t244 17.2438
R7 VDD.n125 VDD.t55 17.2247
R8 VDD.n130 VDD.t86 17.0005
R9 VDD.n122 VDD.t59 17.0005
R10 VDD.n121 VDD.t365 17.0005
R11 VDD.t36 VDD.n100 4.19382
R12 VDD.n42 VDD.n43 0.189847
R13 VDD.n96 VDD.n95 0.149987
R14 VDD.t36 VDD.n95 2.39616
R15 VDD.n92 VDD.n53 0.149987
R16 VDD.n92 VDD.t36 2.39616
R17 VDD.n97 VDD.n89 0.149987
R18 VDD.t36 VDD.n89 2.39616
R19 VDD.n84 VDD.n50 0.149987
R20 VDD.n84 VDD.t36 2.39616
R21 VDD.n98 VDD.n81 0.149987
R22 VDD.t36 VDD.n81 2.39616
R23 VDD.n77 VDD.n47 0.149987
R24 VDD.t36 VDD.n77 2.39616
R25 VDD.t14 VDD.n37 2.05478
R26 VDD.n34 VDD.n65 0.448571
R27 VDD.n36 VDD.t30 15.1333
R28 VDD.n383 VDD.t33 15.0005
R29 VDD.n1 VDD.t28 15.0005
R30 VDD.n64 VDD.t13 15.0005
R31 VDD.n39 VDD.t19 15.0005
R32 VDD.n67 VDD.t328 17.9449
R33 VDD.n386 VDD.n135 9.51422
R34 VDD.n387 VDD.n386 9.17119
R35 VDD.n68 VDD.n67 0.341666
R36 VDD.n395 VDD.t124 9.02285
R37 VDD.n74 VDD.n75 0.0615821
R38 VDD.n116 VDD.n28 4.47071
R39 VDD.n115 VDD.t132 8.95516
R40 VDD.n143 VDD.t367 8.76154
R41 VDD.n12 VDD.t156 8.76154
R42 VDD.n12 VDD.t135 8.76154
R43 VDD.n12 VDD.t90 8.76154
R44 VDD.n11 VDD.t360 8.76154
R45 VDD.n144 VDD.t346 8.76154
R46 VDD.n44 VDD.t136 8.76154
R47 VDD.n145 VDD.t361 8.76154
R48 VDD.n73 VDD.t245 8.76154
R49 VDD.n109 VDD.t201 8.76054
R50 VDD.n109 VDD.t297 8.76054
R51 VDD.n143 VDD.t122 8.76054
R52 VDD.n12 VDD.t77 8.76054
R53 VDD.n12 VDD.t285 8.76054
R54 VDD.n12 VDD.t100 8.76054
R55 VDD.n11 VDD.t288 8.76054
R56 VDD.n144 VDD.t123 8.76054
R57 VDD.n44 VDD.t286 8.76054
R58 VDD.n145 VDD.t226 8.76054
R59 VDD.n95 VDD.n94 0.0442395
R60 VDD.n91 VDD.n92 0.0442395
R61 VDD.n89 VDD.n88 0.0442395
R62 VDD.n83 VDD.n84 0.0442395
R63 VDD.n81 VDD.n80 0.0442395
R64 VDD.n78 VDD.n77 0.0442395
R65 VDD VDD.t1 8.47732
R66 VDD.n46 VDD.n45 0.0953067
R67 VDD.t36 VDD.n46 4.19225
R68 VDD.t36 VDD.n41 3.34459
R69 VDD.n15 VDD.t36 0.282331
R70 VDD.t36 VDD.n9 0.793108
R71 VDD.t36 VDD.n18 1.13836
R72 VDD.n8 VDD.t36 0.793108
R73 VDD.n20 VDD.t36 1.13836
R74 VDD.t36 VDD.n6 0.793108
R75 VDD.t36 VDD.n21 0.315451
R76 VDD.n5 VDD.t36 0.793108
R77 VDD.n24 VDD.t36 1.13836
R78 VDD.t36 VDD.n3 0.793108
R79 VDD.t36 VDD.n26 1.13836
R80 VDD.t36 VDD.n10 0.793077
R81 VDD.t25 VDD.n56 4.20922
R82 VDD.t25 VDD.n60 4.20922
R83 VDD.t14 VDD.n57 1.61947
R84 VDD.t14 VDD.n34 0.894484
R85 VDD.t14 VDD.n74 8.47732
R86 VDD.n10 VDD.t407 7.62628
R87 VDD.n76 VDD.t406 7.62628
R88 VDD.n26 VDD.t405 7.62628
R89 VDD.n3 VDD.t404 7.62628
R90 VDD.n79 VDD.t403 7.62628
R91 VDD.n24 VDD.t402 7.62628
R92 VDD.n5 VDD.t401 7.62628
R93 VDD.n82 VDD.t400 7.62628
R94 VDD.n22 VDD.t399 7.62628
R95 VDD.n6 VDD.t398 7.62628
R96 VDD.n87 VDD.t397 7.62628
R97 VDD.n20 VDD.t396 7.62628
R98 VDD.n8 VDD.t395 7.62628
R99 VDD.n90 VDD.t394 7.62628
R100 VDD.n18 VDD.t393 7.62628
R101 VDD.n9 VDD.t392 7.62628
R102 VDD.n93 VDD.t391 7.62628
R103 VDD.n16 VDD.t390 7.62628
R104 VDD.n1 VDD.n30 3.11859
R105 VDD.n192 VDD.t113 6.09923
R106 VDD.n198 VDD.t150 6.09923
R107 VDD.n204 VDD.t193 6.09923
R108 VDD.n210 VDD.t162 6.09923
R109 VDD.n216 VDD.t88 6.09923
R110 VDD.n222 VDD.t37 6.09923
R111 VDD.n228 VDD.t240 6.09923
R112 VDD.n234 VDD.t56 6.09923
R113 VDD.n240 VDD.t220 6.09923
R114 VDD.n246 VDD.t96 6.09923
R115 VDD.n252 VDD.t231 6.09923
R116 VDD.n258 VDD.t60 6.09923
R117 VDD.n264 VDD.t121 6.09923
R118 VDD.n270 VDD.t41 6.09923
R119 VDD.n276 VDD.t358 6.09923
R120 VDD.n282 VDD.t293 6.09923
R121 VDD.n288 VDD.t75 6.09923
R122 VDD.n294 VDD.t172 6.09923
R123 VDD.n300 VDD.t63 6.09923
R124 VDD.n306 VDD.t102 6.09923
R125 VDD.n312 VDD.t84 6.09923
R126 VDD.n318 VDD.t93 6.09923
R127 VDD.n324 VDD.t53 6.09923
R128 VDD.n330 VDD.t67 6.09923
R129 VDD.n336 VDD.t112 6.09923
R130 VDD.n342 VDD.t125 6.09923
R131 VDD.n348 VDD.t163 6.09923
R132 VDD.n354 VDD.t195 6.09923
R133 VDD.n360 VDD.t76 6.09923
R134 VDD.n366 VDD.t82 6.09923
R135 VDD.n372 VDD.t191 6.09923
R136 VDD.n378 VDD.t127 6.09923
R137 VDD.n26 VDD.t87 5.99122
R138 VDD.n24 VDD.t221 5.99122
R139 VDD.n22 VDD.t232 5.99122
R140 VDD.n20 VDD.t85 5.99122
R141 VDD.n18 VDD.t74 5.99122
R142 VDD.n16 VDD.t294 5.99122
R143 VDD.n101 VDD.t117 5.98905
R144 VDD.n129 VDD.t66 5.9886
R145 VDD.n107 VDD.t203 5.97675
R146 VDD.n107 VDD.t97 5.97675
R147 VDD.n12 VDD.t157 5.97212
R148 VDD.n12 VDD.t91 5.97212
R149 VDD.n45 VDD.t347 5.97212
R150 VDD.n146 VDD.t374 5.97212
R151 VDD.n12 VDD.t78 5.97169
R152 VDD.n12 VDD.t174 5.97169
R153 VDD.n45 VDD.t155 5.97169
R154 VDD.n146 VDD.t227 5.97169
R155 VDD.n10 VDD.t340 5.97001
R156 VDD.n10 VDD.t164 5.97001
R157 VDD.n10 VDD.t159 5.97001
R158 VDD.n48 VDD.t139 5.97001
R159 VDD.n47 VDD.t138 5.97001
R160 VDD.n3 VDD.t43 5.97001
R161 VDD.n26 VDD.t142 5.97001
R162 VDD.n3 VDD.t185 5.97001
R163 VDD.n3 VDD.t376 5.97001
R164 VDD.n49 VDD.t145 5.97001
R165 VDD.n98 VDD.t144 5.97001
R166 VDD.n5 VDD.t388 5.97001
R167 VDD.n24 VDD.t148 5.97001
R168 VDD.n5 VDD.t151 5.97001
R169 VDD.n5 VDD.t184 5.97001
R170 VDD.n51 VDD.t47 5.97001
R171 VDD.n50 VDD.t46 5.97001
R172 VDD.n6 VDD.t107 5.97001
R173 VDD.n22 VDD.t50 5.97001
R174 VDD.n6 VDD.t51 5.97001
R175 VDD.n6 VDD.t105 5.97001
R176 VDD.n52 VDD.t336 5.97001
R177 VDD.n97 VDD.t335 5.97001
R178 VDD.n8 VDD.t389 5.97001
R179 VDD.n20 VDD.t339 5.97001
R180 VDD.n8 VDD.t103 5.97001
R181 VDD.n8 VDD.t216 5.97001
R182 VDD.n54 VDD.t70 5.97001
R183 VDD.n53 VDD.t69 5.97001
R184 VDD.n9 VDD.t160 5.97001
R185 VDD.n18 VDD.t73 5.97001
R186 VDD.n9 VDD.t237 5.97001
R187 VDD.n9 VDD.t208 5.97001
R188 VDD.n55 VDD.t211 5.97001
R189 VDD.n96 VDD.t210 5.97001
R190 VDD.n16 VDD.t214 5.97001
R191 VDD.n32 VDD.t295 5.96578
R192 VDD.n42 VDD.t134 5.96578
R193 VDD.n141 VDD.t359 5.96578
R194 VDD.n25 VDD.t109 5.96578
R195 VDD.n23 VDD.t180 5.96578
R196 VDD.n33 VDD.t296 5.96578
R197 VDD.n86 VDD.t186 5.96578
R198 VDD.n27 VDD.t106 5.96578
R199 VDD.n19 VDD.t110 5.96578
R200 VDD.n17 VDD.t179 5.96578
R201 VDD.n14 VDD.t126 5.96578
R202 VDD.n42 VDD.t284 5.96534
R203 VDD.n141 VDD.t287 5.96534
R204 VDD.n101 VDD.t152 5.96534
R205 VDD.n139 VDD.t378 5.96534
R206 VDD.n137 VDD.t114 5.96534
R207 VDD.n148 VDD.t248 5.96534
R208 VDD.n31 VDD.t177 5.96534
R209 VDD.n32 VDD.t108 5.96534
R210 VDD.n10 VDD.t194 5.96534
R211 VDD.n10 VDD.t349 5.96534
R212 VDD.n102 VDD.t329 5.96534
R213 VDD.n47 VDD.t167 5.96534
R214 VDD.n26 VDD.t189 5.96534
R215 VDD.n26 VDD.t38 5.96534
R216 VDD.n25 VDD.t204 5.96534
R217 VDD.n3 VDD.t54 5.96534
R218 VDD.n3 VDD.t351 5.96534
R219 VDD.n103 VDD.t176 5.96534
R220 VDD.n98 VDD.t190 5.96534
R221 VDD.n24 VDD.t40 5.96534
R222 VDD.n24 VDD.t95 5.96534
R223 VDD.n23 VDD.t205 5.96534
R224 VDD.n5 VDD.t224 5.96534
R225 VDD.n5 VDD.t80 5.96534
R226 VDD.n4 VDD.t61 5.96534
R227 VDD.n50 VDD.t238 5.96534
R228 VDD.n22 VDD.t182 5.96534
R229 VDD.n22 VDD.t42 5.96534
R230 VDD.n27 VDD.t242 5.96534
R231 VDD.n27 VDD.t89 5.96534
R232 VDD.n156 VDD.t302 5.96534
R233 VDD.n86 VDD.t369 5.96534
R234 VDD.n154 VDD.t377 5.96534
R235 VDD.n73 VDD.t222 5.96534
R236 VDD.n152 VDD.t188 5.96534
R237 VDD.n150 VDD.t292 5.96534
R238 VDD.n33 VDD.t92 5.96534
R239 VDD.n6 VDD.t62 5.96534
R240 VDD.n6 VDD.t39 5.96534
R241 VDD.n104 VDD.t101 5.96534
R242 VDD.n97 VDD.t206 5.96534
R243 VDD.n20 VDD.t187 5.96534
R244 VDD.n20 VDD.t94 5.96534
R245 VDD.n19 VDD.t387 5.96534
R246 VDD.n8 VDD.t115 5.96534
R247 VDD.n8 VDD.t81 5.96534
R248 VDD.n7 VDD.t170 5.96534
R249 VDD.n53 VDD.t290 5.96534
R250 VDD.n18 VDD.t385 5.96534
R251 VDD.n18 VDD.t198 5.96534
R252 VDD.n17 VDD.t243 5.96534
R253 VDD.n9 VDD.t230 5.96534
R254 VDD.n9 VDD.t303 5.96534
R255 VDD.n105 VDD.t234 5.96534
R256 VDD.n96 VDD.t353 5.96534
R257 VDD.n16 VDD.t352 5.96534
R258 VDD.n16 VDD.t83 5.96534
R259 VDD.n14 VDD.t181 5.96534
R260 VDD.n14 VDD.t168 5.96534
R261 VDD.n127 VDD.t131 5.96478
R262 VDD.n10 VDD.t158 5.65005
R263 VDD.n76 VDD.t137 5.65005
R264 VDD.n26 VDD.t140 5.65005
R265 VDD.n3 VDD.t44 5.65005
R266 VDD.n79 VDD.t143 5.65005
R267 VDD.n24 VDD.t146 5.65005
R268 VDD.n5 VDD.t183 5.65005
R269 VDD.n82 VDD.t45 5.65005
R270 VDD.n22 VDD.t48 5.65005
R271 VDD.n6 VDD.t104 5.65005
R272 VDD.n87 VDD.t52 5.65005
R273 VDD.n20 VDD.t337 5.65005
R274 VDD.n8 VDD.t215 5.65005
R275 VDD.n90 VDD.t68 5.65005
R276 VDD.n18 VDD.t71 5.65005
R277 VDD.n9 VDD.t161 5.65005
R278 VDD.n93 VDD.t209 5.65005
R279 VDD.n16 VDD.t212 5.65005
R280 VDD.t1 VDD.n133 5.62581
R281 VDD.t1 VDD.n396 5.62581
R282 VDD.t36 VDD.n149 5.62581
R283 VDD.t36 VDD.n147 5.62581
R284 VDD.t36 VDD.n140 5.62581
R285 VDD.n41 VDD.n144 0.160419
R286 VDD.t36 VDD.n13 1.07426
R287 VDD.n151 VDD.t36 5.62581
R288 VDD.n72 VDD.t36 1.79705
R289 VDD.n153 VDD.t36 5.62581
R290 VDD.n155 VDD.t36 5.62581
R291 VDD.t25 VDD.n191 5.62581
R292 VDD.t25 VDD.n197 5.62581
R293 VDD.t25 VDD.n203 5.62581
R294 VDD.t25 VDD.n209 5.62581
R295 VDD.t25 VDD.n215 5.62581
R296 VDD.t25 VDD.n221 5.62581
R297 VDD.t25 VDD.n227 5.62581
R298 VDD.t25 VDD.n233 5.62581
R299 VDD.t25 VDD.n239 5.62581
R300 VDD.t25 VDD.n245 5.62581
R301 VDD.t25 VDD.n251 5.62581
R302 VDD.t25 VDD.n257 5.62581
R303 VDD.t25 VDD.n263 5.62581
R304 VDD.t25 VDD.n269 5.62581
R305 VDD.t25 VDD.n275 5.62581
R306 VDD.t25 VDD.n281 5.62581
R307 VDD.t25 VDD.n287 5.62581
R308 VDD.t25 VDD.n293 5.62581
R309 VDD.t25 VDD.n299 5.62581
R310 VDD.t25 VDD.n305 5.62581
R311 VDD.t25 VDD.n311 5.62581
R312 VDD.t25 VDD.n317 5.62581
R313 VDD.t25 VDD.n323 5.62581
R314 VDD.t25 VDD.n329 5.62581
R315 VDD.t25 VDD.n335 5.62581
R316 VDD.t25 VDD.n341 5.62581
R317 VDD.t25 VDD.n347 5.62581
R318 VDD.t25 VDD.n353 5.62581
R319 VDD.t25 VDD.n359 5.62581
R320 VDD.t25 VDD.n365 5.62581
R321 VDD.t25 VDD.n371 5.62581
R322 VDD.t25 VDD.n377 5.62581
R323 VDD.t25 VDD.n379 5.62581
R324 VDD.t58 VDD.n124 5.61485
R325 VDD.t58 VDD.n128 5.61485
R326 VDD.n0 VDD.t26 5.7457
R327 VDD.n111 VDD.t15 5.60969
R328 VDD.n112 VDD.t20 5.60969
R329 VDD.n1 VDD.t29 5.71623
R330 VDD.n382 VDD.t35 5.60347
R331 VDD.n61 VDD.t32 5.60347
R332 VDD.n28 VDD.t18 5.60347
R333 VDD.n114 VDD.t23 5.60347
R334 VDD.n189 VDD.t261 5.59675
R335 VDD.n195 VDD.t264 5.59675
R336 VDD.n201 VDD.t262 5.59675
R337 VDD.n207 VDD.t260 5.59675
R338 VDD.n213 VDD.t265 5.59675
R339 VDD.n219 VDD.t259 5.59675
R340 VDD.n225 VDD.t268 5.59675
R341 VDD.n231 VDD.t269 5.59675
R342 VDD.n237 VDD.t266 5.59675
R343 VDD.n243 VDD.t257 5.59675
R344 VDD.n249 VDD.t270 5.59675
R345 VDD.n255 VDD.t272 5.59675
R346 VDD.n261 VDD.t271 5.59675
R347 VDD.n267 VDD.t253 5.59675
R348 VDD.n273 VDD.t267 5.59675
R349 VDD.n279 VDD.t250 5.59675
R350 VDD.n285 VDD.t255 5.59675
R351 VDD.n291 VDD.t251 5.59675
R352 VDD.n297 VDD.t274 5.59675
R353 VDD.n303 VDD.t273 5.59675
R354 VDD.n309 VDD.t258 5.59675
R355 VDD.n315 VDD.t256 5.59675
R356 VDD.n321 VDD.t252 5.59675
R357 VDD.n327 VDD.t276 5.59675
R358 VDD.n333 VDD.t254 5.59675
R359 VDD.n339 VDD.t277 5.59675
R360 VDD.n345 VDD.t278 5.59675
R361 VDD.n351 VDD.t279 5.59675
R362 VDD.n357 VDD.t275 5.59675
R363 VDD.n363 VDD.t280 5.59675
R364 VDD.n369 VDD.t281 5.59675
R365 VDD.n375 VDD.t282 5.59675
R366 VDD.n380 VDD.t31 5.59675
R367 VDD.n38 VDD.t263 5.59675
R368 VDD.n28 VDD.t16 5.59179
R369 VDD.n113 VDD.t21 5.59179
R370 VDD.n1 VDD.t27 5.59179
R371 VDD.n433 VDD.t4 4.9462
R372 VDD.n405 VDD.t0 4.9462
R373 VDD.n117 VDD.n116 4.90372
R374 VDD.t36 VDD.n142 4.19244
R375 VDD.t36 VDD.n43 3.32638
R376 VDD.t1 VDD.n425 4.19238
R377 VDD.t1 VDD.n389 4.19238
R378 VDD.n57 VDD.n28 0.406014
R379 VDD.n37 VDD.n75 0.379543
R380 VDD.t1 VDD.n397 4.19225
R381 VDD.t1 VDD.n394 4.19225
R382 VDD.t36 VDD.n99 3.3265
R383 VDD.n152 VDD.n72 0.341
R384 VDD.n85 VDD.t36 3.3265
R385 VDD.t58 VDD.n126 3.31208
R386 VDD.t58 VDD.n118 3.30706
R387 VDD.t58 VDD.n120 3.30706
R388 VDD.t58 VDD.n132 3.30688
R389 VDD VDD.n42 3.24041
R390 VDD.t58 VDD.n108 2.7751
R391 VDD.t36 VDD.n136 2.74446
R392 VDD.t36 VDD.n138 2.74446
R393 VDD.n15 VDD.n14 0.286734
R394 VDD.n156 VDD.n27 0.44578
R395 VDD.n27 VDD.n21 0.309939
R396 VDD.t1 VDD.n388 2.74414
R397 VDD.n2 VDD.n190 0.527937
R398 VDD.t25 VDD.n35 2.74386
R399 VDD.n1 VDD.n188 0.435597
R400 VDD.t58 VDD 1.47683
R401 VDD.n435 VDD.t6 2.69937
R402 VDD.n403 VDD.t9 2.69937
R403 VDD.n401 VDD.t3 2.69937
R404 VDD.n427 VDD.t11 2.69937
R405 VDD.n431 VDD.t12 2.6992
R406 VDD.n429 VDD.t5 2.6992
R407 VDD.n399 VDD.t8 2.6992
R408 VDD.n407 VDD.t2 2.6992
R409 VDD.n412 VDD.t311 2.6992
R410 VDD.n411 VDD.t318 2.6992
R411 VDD.n417 VDD.t313 2.6992
R412 VDD.n416 VDD.t320 2.6992
R413 VDD.n422 VDD.t315 2.6992
R414 VDD.n421 VDD.t322 2.6992
R415 VDD.t1 VDD.n70 2.33382
R416 VDD.t25 VDD.n313 2.32446
R417 VDD.t1 VDD.n392 2.32439
R418 VDD.t25 VDD.n199 2.32439
R419 VDD.t25 VDD.n223 2.32439
R420 VDD.t25 VDD.n325 2.32439
R421 VDD.t25 VDD.n367 2.32439
R422 VDD.t1 VDD.n409 2.32432
R423 VDD.t25 VDD.n247 2.32432
R424 VDD.t25 VDD.n271 2.32432
R425 VDD.t25 VDD.n295 2.32432
R426 VDD.t25 VDD.n319 2.32432
R427 VDD.t25 VDD.n193 2.32425
R428 VDD.t25 VDD.n217 2.32425
R429 VDD.t25 VDD.n289 2.32425
R430 VDD.t25 VDD.n301 2.32425
R431 VDD.t25 VDD.n205 2.3242
R432 VDD.t25 VDD.n211 2.32417
R433 VDD.t25 VDD.n277 2.32417
R434 VDD.t25 VDD.n307 2.32417
R435 VDD.t25 VDD.n349 2.32417
R436 VDD.t25 VDD.n373 2.32417
R437 VDD.t1 VDD.n393 2.32417
R438 VDD.t1 VDD.n390 2.32417
R439 VDD.t14 VDD.n68 0.570319
R440 VDD.t25 VDD.n337 2.32417
R441 VDD.t25 VDD.n343 2.32417
R442 VDD.t25 VDD.n229 2.32414
R443 VDD.t25 VDD.n259 2.32414
R444 VDD.t25 VDD.n265 2.32414
R445 VDD.t1 VDD.n419 2.32407
R446 VDD.t25 VDD.n241 2.32407
R447 VDD.t25 VDD.n331 2.32407
R448 VDD.t1 VDD.n424 2.32406
R449 VDD.t25 VDD.n235 2.32406
R450 VDD.t25 VDD.n253 2.32406
R451 VDD.t25 VDD.n283 2.32406
R452 VDD.t25 VDD.n355 2.32406
R453 VDD.t25 VDD.n361 2.32406
R454 VDD.n14 VDD.t350 6.35406
R455 VDD.t1 VDD.n391 2.0061
R456 VDD.t1 VDD.n414 2.00601
R457 VDD.t1 VDD.n437 1.75938
R458 VDD.t25 VDD.n385 1.56886
R459 VDD.t25 VDD.n157 1.55381
R460 VDD.t25 VDD.n159 1.55381
R461 VDD.t25 VDD.n161 1.55381
R462 VDD.t25 VDD.n162 1.55381
R463 VDD.t25 VDD.n163 1.55381
R464 VDD.t25 VDD.n164 1.55381
R465 VDD.t25 VDD.n165 1.55381
R466 VDD.t25 VDD.n166 1.55381
R467 VDD.t25 VDD.n167 1.55381
R468 VDD.t25 VDD.n168 1.55381
R469 VDD.t25 VDD.n170 1.55381
R470 VDD.t25 VDD.n171 1.55381
R471 VDD.t25 VDD.n172 1.55381
R472 VDD.t25 VDD.n173 1.55381
R473 VDD.t25 VDD.n175 1.55381
R474 VDD.t25 VDD.n176 1.55381
R475 VDD.t25 VDD.n177 1.55381
R476 VDD.t25 VDD.n178 1.55381
R477 VDD.t25 VDD.n179 1.55381
R478 VDD.t25 VDD.n180 1.55381
R479 VDD.t25 VDD.n181 1.55381
R480 VDD.t25 VDD.n184 1.55381
R481 VDD.t25 VDD.n185 1.55381
R482 VDD.t25 VDD.n186 1.55381
R483 VDD.t25 VDD.n187 1.55381
R484 VDD.t25 VDD.n158 1.55341
R485 VDD.t25 VDD.n160 1.55341
R486 VDD.t25 VDD.n169 1.55341
R487 VDD.t25 VDD.n174 1.55341
R488 VDD.t25 VDD.n182 1.55341
R489 VDD.t25 VDD.n183 1.55341
R490 VDD.t58 VDD.n110 1.20461
R491 VDD.n68 VDD.n115 0.779651
R492 VDD.n412 VDD.n411 1.11007
R493 VDD.n417 VDD.n416 1.11007
R494 VDD.n422 VDD.n421 1.11007
R495 VDD.t1 VDD.n134 1.01949
R496 VDD.n131 VDD.n106 0.975304
R497 VDD.n106 VDD.n129 0.817678
R498 VDD.n386 VDD.n30 0.808112
R499 VDD.n117 VDD.n110 0.671512
R500 VDD.n110 VDD.n109 0.6645
R501 VDD.n135 VDD.n134 0.633311
R502 VDD.n387 VDD.n134 0.617798
R503 VDD.n436 VDD.n435 0.570444
R504 VDD.n401 VDD.n400 0.570444
R505 VDD.n429 VDD.n428 0.570274
R506 VDD.n408 VDD.n407 0.570274
R507 VDD.n413 VDD.n412 0.570274
R508 VDD.n418 VDD.n417 0.570274
R509 VDD.n423 VDD.n422 0.570274
R510 VDD.n431 VDD.n430 0.569912
R511 VDD.n399 VDD.n398 0.569912
R512 VDD.n411 VDD.n410 0.569912
R513 VDD.n416 VDD.n415 0.569912
R514 VDD.n421 VDD.n420 0.569912
R515 VDD.n403 VDD.n402 0.569733
R516 VDD.n427 VDD.n426 0.569733
R517 VDD.n29 VDD.n28 0.183807
R518 VDD.n113 VDD.n40 0.508375
R519 VDD.t58 VDD.n106 0.49685
R520 VDD.n189 VDD.n188 0.495398
R521 VDD.n195 VDD.n194 0.495398
R522 VDD.n201 VDD.n200 0.495398
R523 VDD.n207 VDD.n206 0.495398
R524 VDD.n213 VDD.n212 0.495398
R525 VDD.n219 VDD.n218 0.495398
R526 VDD.n225 VDD.n224 0.495398
R527 VDD.n231 VDD.n230 0.495398
R528 VDD.n237 VDD.n236 0.495398
R529 VDD.n243 VDD.n242 0.495398
R530 VDD.n249 VDD.n248 0.495398
R531 VDD.n255 VDD.n254 0.495398
R532 VDD.n261 VDD.n260 0.495398
R533 VDD.n267 VDD.n266 0.495398
R534 VDD.n273 VDD.n272 0.495398
R535 VDD.n279 VDD.n278 0.495398
R536 VDD.n285 VDD.n284 0.495398
R537 VDD.n291 VDD.n290 0.495398
R538 VDD.n297 VDD.n296 0.495398
R539 VDD.n303 VDD.n302 0.495398
R540 VDD.n309 VDD.n308 0.495398
R541 VDD.n315 VDD.n314 0.495398
R542 VDD.n321 VDD.n320 0.495398
R543 VDD.n327 VDD.n326 0.495398
R544 VDD.n333 VDD.n332 0.495398
R545 VDD.n339 VDD.n338 0.495398
R546 VDD.n345 VDD.n344 0.495398
R547 VDD.n351 VDD.n350 0.495398
R548 VDD.n357 VDD.n356 0.495398
R549 VDD.n363 VDD.n362 0.495398
R550 VDD.n369 VDD.n368 0.495398
R551 VDD.n375 VDD.n374 0.495398
R552 VDD.n380 VDD.n36 0.495398
R553 VDD.n38 VDD.n58 0.495398
R554 VDD.n404 VDD.n403 0.492175
R555 VDD.n434 VDD.n427 0.492175
R556 VDD.n432 VDD.n431 0.492005
R557 VDD.n406 VDD.n399 0.492005
R558 VDD.n432 VDD.n429 0.491643
R559 VDD.n407 VDD.n406 0.491643
R560 VDD.n435 VDD.n434 0.491464
R561 VDD.n404 VDD.n401 0.491464
R562 VDD.n190 VDD.n189 0.478641
R563 VDD.n196 VDD.n195 0.478641
R564 VDD.n202 VDD.n201 0.478641
R565 VDD.n208 VDD.n207 0.478641
R566 VDD.n214 VDD.n213 0.478641
R567 VDD.n220 VDD.n219 0.478641
R568 VDD.n226 VDD.n225 0.478641
R569 VDD.n232 VDD.n231 0.478641
R570 VDD.n238 VDD.n237 0.478641
R571 VDD.n244 VDD.n243 0.478641
R572 VDD.n250 VDD.n249 0.478641
R573 VDD.n256 VDD.n255 0.478641
R574 VDD.n262 VDD.n261 0.478641
R575 VDD.n268 VDD.n267 0.478641
R576 VDD.n274 VDD.n273 0.478641
R577 VDD.n280 VDD.n279 0.478641
R578 VDD.n286 VDD.n285 0.478641
R579 VDD.n292 VDD.n291 0.478641
R580 VDD.n298 VDD.n297 0.478641
R581 VDD.n304 VDD.n303 0.478641
R582 VDD.n310 VDD.n309 0.478641
R583 VDD.n316 VDD.n315 0.478641
R584 VDD.n322 VDD.n321 0.478641
R585 VDD.n328 VDD.n327 0.478641
R586 VDD.n334 VDD.n333 0.478641
R587 VDD.n340 VDD.n339 0.478641
R588 VDD.n346 VDD.n345 0.478641
R589 VDD.n352 VDD.n351 0.478641
R590 VDD.n358 VDD.n357 0.478641
R591 VDD.n364 VDD.n363 0.478641
R592 VDD.n370 VDD.n369 0.478641
R593 VDD.n376 VDD.n375 0.478641
R594 VDD.n59 VDD.n380 0.478641
R595 VDD.n40 VDD.n38 0.478641
R596 VDD.n188 VDD.n187 0.467341
R597 VDD.n194 VDD.n186 0.467341
R598 VDD.n200 VDD.n185 0.467341
R599 VDD.n206 VDD.n184 0.467341
R600 VDD.n224 VDD.n181 0.467341
R601 VDD.n230 VDD.n180 0.467341
R602 VDD.n236 VDD.n179 0.467341
R603 VDD.n242 VDD.n178 0.467341
R604 VDD.n248 VDD.n177 0.467341
R605 VDD.n254 VDD.n176 0.467341
R606 VDD.n260 VDD.n175 0.467341
R607 VDD.n272 VDD.n173 0.467341
R608 VDD.n278 VDD.n172 0.467341
R609 VDD.n284 VDD.n171 0.467341
R610 VDD.n290 VDD.n170 0.467341
R611 VDD.n302 VDD.n168 0.467341
R612 VDD.n308 VDD.n167 0.467341
R613 VDD.n314 VDD.n166 0.467341
R614 VDD.n320 VDD.n165 0.467341
R615 VDD.n326 VDD.n164 0.467341
R616 VDD.n332 VDD.n163 0.467341
R617 VDD.n338 VDD.n162 0.467341
R618 VDD.n344 VDD.n161 0.467341
R619 VDD.n356 VDD.n159 0.467341
R620 VDD.n368 VDD.n157 0.467341
R621 VDD.n212 VDD.n183 0.466909
R622 VDD.n218 VDD.n182 0.466909
R623 VDD.n266 VDD.n174 0.466909
R624 VDD.n296 VDD.n169 0.466909
R625 VDD.n350 VDD.n160 0.466909
R626 VDD.n362 VDD.n158 0.466909
R627 VDD.n218 VDD.n183 0.451022
R628 VDD.n224 VDD.n182 0.451022
R629 VDD.n272 VDD.n174 0.451022
R630 VDD.n302 VDD.n169 0.451022
R631 VDD.n356 VDD.n160 0.451022
R632 VDD.n368 VDD.n158 0.451022
R633 VDD.n194 VDD.n187 0.450618
R634 VDD.n200 VDD.n186 0.450618
R635 VDD.n206 VDD.n185 0.450618
R636 VDD.n212 VDD.n184 0.450618
R637 VDD.n230 VDD.n181 0.450618
R638 VDD.n236 VDD.n180 0.450618
R639 VDD.n242 VDD.n179 0.450618
R640 VDD.n248 VDD.n178 0.450618
R641 VDD.n254 VDD.n177 0.450618
R642 VDD.n260 VDD.n176 0.450618
R643 VDD.n266 VDD.n175 0.450618
R644 VDD.n278 VDD.n173 0.450618
R645 VDD.n284 VDD.n172 0.450618
R646 VDD.n290 VDD.n171 0.450618
R647 VDD.n296 VDD.n170 0.450618
R648 VDD.n308 VDD.n168 0.450618
R649 VDD.n314 VDD.n167 0.450618
R650 VDD.n320 VDD.n166 0.450618
R651 VDD.n326 VDD.n165 0.450618
R652 VDD.n332 VDD.n164 0.450618
R653 VDD.n338 VDD.n163 0.450618
R654 VDD.n344 VDD.n162 0.450618
R655 VDD.n350 VDD.n161 0.450618
R656 VDD.n362 VDD.n159 0.450618
R657 VDD.n374 VDD.n157 0.450618
R658 VDD.n61 VDD.n56 0.445771
R659 VDD.n437 VDD.n436 0.43335
R660 VDD.n74 VDD.n29 0.0930507
R661 VDD.n66 VDD.n114 0.429929
R662 VDD.n385 VDD.n384 0.429766
R663 VDD.n382 VDD.n381 0.427147
R664 VDD.n62 VDD.n61 0.427147
R665 VDD.n385 VDD.n381 0.426171
R666 VDD.n111 VDD.n28 0.413465
R667 VDD.n112 VDD.n58 0.413465
R668 VDD.n437 VDD.n69 0.403558
R669 VDD.t1 VDD.t58 0.383639
R670 VDD.n415 VDD.n392 0.372952
R671 VDD.n419 VDD.n418 0.372338
R672 VDD.n313 VDD.n312 0.35553
R673 VDD.n199 VDD.n198 0.355452
R674 VDD.n223 VDD.n222 0.355452
R675 VDD.n325 VDD.n324 0.355452
R676 VDD.n367 VDD.n366 0.355452
R677 VDD.n247 VDD.n246 0.355386
R678 VDD.n271 VDD.n270 0.355386
R679 VDD.n295 VDD.n294 0.355386
R680 VDD.n319 VDD.n318 0.355386
R681 VDD.n289 VDD.n288 0.355312
R682 VDD.n301 VDD.n300 0.355312
R683 VDD.n193 VDD.n192 0.355312
R684 VDD.n217 VDD.n216 0.355312
R685 VDD.n307 VDD.n306 0.355155
R686 VDD.n211 VDD.n210 0.355155
R687 VDD.n277 VDD.n276 0.355155
R688 VDD.n373 VDD.n372 0.355155
R689 VDD.n283 VDD.n282 0.355071
R690 VDD.n355 VDD.n354 0.355071
R691 VDD.n361 VDD.n360 0.355071
R692 VDD.n229 VDD.n228 0.354936
R693 VDD.n259 VDD.n258 0.354936
R694 VDD.n265 VDD.n264 0.354936
R695 VDD.n205 VDD.n204 0.354903
R696 VDD.n241 VDD.n240 0.354838
R697 VDD.n331 VDD.n330 0.354838
R698 VDD.n235 VDD.n234 0.354771
R699 VDD.n253 VDD.n252 0.354771
R700 VDD.n337 VDD.n336 0.354697
R701 VDD.n343 VDD.n342 0.354697
R702 VDD.n410 VDD.n390 0.354692
R703 VDD.n349 VDD.n348 0.354692
R704 VDD.n413 VDD.n409 0.354483
R705 VDD.n420 VDD.n393 0.347655
R706 VDD.n424 VDD.n423 0.347271
R707 VDD.n410 VDD.n391 0.347254
R708 VDD.n414 VDD.n413 0.347105
R709 VDD.n132 VDD.n131 0.335799
R710 VDD.n120 VDD.n119 0.335496
R711 VDD.n428 VDD.n424 0.335071
R712 VDD.n430 VDD.n393 0.334692
R713 VDD.n123 VDD.n120 0.332368
R714 VDD.n132 VDD.n71 0.332058
R715 VDD.n426 VDD.n70 0.33018
R716 VDD.n418 VDD.n414 0.329068
R717 VDD.n415 VDD.n391 0.328947
R718 VDD.n409 VDD.n408 0.327886
R719 VDD.n398 VDD.n390 0.327655
R720 VDD.t24 VDD.n0 15.0851
R721 VDD.n127 VDD.n126 0.327354
R722 VDD.n64 VDD.n111 0.327154
R723 VDD.n39 VDD.n112 0.327154
R724 VDD.n402 VDD.n388 0.319294
R725 VDD.n383 VDD.n382 0.313013
R726 VDD.n352 VDD.n349 0.310155
R727 VDD.n340 VDD.n337 0.31015
R728 VDD.n346 VDD.n343 0.31015
R729 VDD.n238 VDD.n235 0.310071
R730 VDD.n256 VDD.n253 0.310071
R731 VDD.n423 VDD.n419 0.309994
R732 VDD.n244 VDD.n241 0.309994
R733 VDD.n334 VDD.n331 0.309994
R734 VDD.n208 VDD.n205 0.309933
R735 VDD.n232 VDD.n229 0.309928
R736 VDD.n262 VDD.n259 0.309928
R737 VDD.n268 VDD.n265 0.309928
R738 VDD.n286 VDD.n283 0.309771
R739 VDD.n358 VDD.n355 0.309771
R740 VDD.n364 VDD.n361 0.309771
R741 VDD.n214 VDD.n211 0.309692
R742 VDD.n376 VDD.n373 0.309692
R743 VDD.n280 VDD.n277 0.309692
R744 VDD.n310 VDD.n307 0.309692
R745 VDD.n196 VDD.n193 0.309557
R746 VDD.n220 VDD.n217 0.309557
R747 VDD.n292 VDD.n289 0.309557
R748 VDD.n304 VDD.n301 0.309557
R749 VDD.n250 VDD.n247 0.309483
R750 VDD.n274 VDD.n271 0.309483
R751 VDD.n298 VDD.n295 0.309483
R752 VDD.n322 VDD.n319 0.309483
R753 VDD.n202 VDD.n199 0.309405
R754 VDD.n226 VDD.n223 0.309405
R755 VDD.n328 VDD.n325 0.309405
R756 VDD.n370 VDD.n367 0.309405
R757 VDD.n420 VDD.n392 0.309405
R758 VDD.n316 VDD.n313 0.309333
R759 VDD.n109 VDD.n108 0.306614
R760 VDD.n118 VDD.n117 0.298721
R761 VDD.n374 VDD.n35 0.290887
R762 VDD VDD.n71 0.423614
R763 VDD.n2 VDD.t25 0.549206
R764 VDD.n137 VDD.n136 0.284268
R765 VDD.n138 VDD.n137 0.282549
R766 VDD.n126 VDD.n125 0.282297
R767 VDD.n99 VDD.n139 0.279247
R768 VDD.n85 VDD.n154 0.279247
R769 VDD.n2 VDD.n1 0.0990857
R770 VDD.n148 VDD.n136 0.268799
R771 VDD.n101 VDD.n99 0.267977
R772 VDD.n119 VDD.n118 0.260496
R773 VDD.n388 VDD.n387 0.25999
R774 VDD.n433 VDD.n432 0.253639
R775 VDD.n405 VDD.n404 0.253639
R776 VDD.n114 VDD.n58 0.25333
R777 VDD.n434 VDD.n433 0.253298
R778 VDD.n406 VDD.n405 0.253298
R779 VDD VDD.n70 0.250961
R780 VDD.n36 VDD.n35 0.243387
R781 VDD.n139 VDD.n138 0.241768
R782 VDD.n116 VDD.n75 4.71183
R783 VDD.n67 VDD.n66 0.706063
R784 VDD VDD.n69 0.521582
R785 VDD.n73 VDD.n72 0.484477
R786 VDD.n63 VDD.t22 15.0439
R787 VDD.n63 VDD.n58 0.130762
R788 VDD.n66 VDD.n40 0.291774
R789 VDD.n86 VDD.n85 0.222977
R790 VDD.n32 VDD.n31 0.251712
R791 VDD.n26 VDD.n25 0.251712
R792 VDD.n24 VDD.n23 0.251712
R793 VDD.n150 VDD.n33 0.251712
R794 VDD.n20 VDD.n19 0.251712
R795 VDD.n18 VDD.n17 0.251712
R796 VDD.n105 VDD.n9 0.272485
R797 VDD.n8 VDD.n7 0.272485
R798 VDD.n104 VDD.n6 0.272485
R799 VDD.n5 VDD.n4 0.272485
R800 VDD.n103 VDD.n3 0.272485
R801 VDD.n102 VDD.n10 0.272485
R802 VDD.n29 VDD.n65 0.109866
R803 VDD.n58 VDD.n57 0.0835447
R804 VDD.n40 VDD.n37 0.100362
R805 VDD.n129 VDD.n128 0.202075
R806 VDD.n408 VDD.n397 0.191924
R807 VDD.n398 VDD.n389 0.191793
R808 VDD.n434 VDD.n69 0.189333
R809 VDD.n428 VDD.n425 0.184552
R810 VDD.n430 VDD.n394 0.184424
R811 VDD.n142 VDD.n141 0.181058
R812 VDD.n400 VDD.n396 0.179888
R813 VDD.n128 VDD.n127 0.175486
R814 VDD.n125 VDD.n124 0.171736
R815 VDD.n395 VDD.n133 0.169888
R816 VDD.n379 VDD.n378 0.16955
R817 VDD.n146 VDD.n100 0.210474
R818 VDD.n203 VDD.n202 0.162388
R819 VDD.n227 VDD.n226 0.162388
R820 VDD.n233 VDD.n232 0.162388
R821 VDD.n275 VDD.n274 0.162388
R822 VDD.n281 VDD.n280 0.162388
R823 VDD.n311 VDD.n310 0.162388
R824 VDD.n359 VDD.n358 0.162388
R825 VDD.n191 VDD.n190 0.16205
R826 VDD.n197 VDD.n196 0.16205
R827 VDD.n209 VDD.n208 0.16205
R828 VDD.n215 VDD.n214 0.16205
R829 VDD.n221 VDD.n220 0.16205
R830 VDD.n239 VDD.n238 0.16205
R831 VDD.n245 VDD.n244 0.16205
R832 VDD.n251 VDD.n250 0.16205
R833 VDD.n257 VDD.n256 0.16205
R834 VDD.n263 VDD.n262 0.16205
R835 VDD.n269 VDD.n268 0.16205
R836 VDD.n287 VDD.n286 0.16205
R837 VDD.n293 VDD.n292 0.16205
R838 VDD.n299 VDD.n298 0.16205
R839 VDD.n305 VDD.n304 0.16205
R840 VDD.n317 VDD.n316 0.16205
R841 VDD.n323 VDD.n322 0.16205
R842 VDD.n329 VDD.n328 0.16205
R843 VDD.n335 VDD.n334 0.16205
R844 VDD.n341 VDD.n340 0.16205
R845 VDD.n347 VDD.n346 0.16205
R846 VDD.n353 VDD.n352 0.16205
R847 VDD.n365 VDD.n364 0.16205
R848 VDD.n371 VDD.n370 0.16205
R849 VDD.n377 VDD.n376 0.16205
R850 VDD.n426 VDD.n394 0.161924
R851 VDD.n436 VDD.n425 0.161793
R852 VDD.n30 VDD 0.485468
R853 VDD.n41 VDD.n11 0.0957379
R854 VDD.n143 VDD.n142 0.159043
R855 VDD.n149 VDD.n148 0.157388
R856 VDD.n156 VDD.n155 0.157388
R857 VDD.n152 VDD.n151 0.157388
R858 VDD.n402 VDD.n389 0.154552
R859 VDD.n400 VDD.n397 0.154424
R860 VDD.n71 VDD.n130 0.152808
R861 VDD.n123 VDD.n122 0.152808
R862 VDD.n123 VDD.n121 0.152808
R863 VDD.n145 VDD.n140 0.15205
R864 VDD.n153 VDD.n73 0.15205
R865 VDD.n124 VDD.n123 0.147075
R866 VDD.n46 VDD.n144 0.236924
R867 VDD.n147 VDD.n145 0.134888
R868 VDD.n45 VDD.n44 0.134618
R869 VDD.n384 VDD.n383 0.133259
R870 VDD.n65 VDD.n64 0.133259
R871 VDD.n101 VDD.n100 0.16225
R872 VDD.n78 VDD.n76 0.128884
R873 VDD.n80 VDD.n79 0.128884
R874 VDD.n83 VDD.n82 0.128884
R875 VDD.n88 VDD.n87 0.128884
R876 VDD.n91 VDD.n90 0.128884
R877 VDD.n94 VDD.n93 0.128884
R878 VDD.n108 VDD.n107 0.127628
R879 VDD.n13 VDD.n143 0.947265
R880 VDD.n60 VDD.n59 0.185493
R881 VDD.n155 VDD.n86 0.1583
R882 VDD.n94 VDD.n105 0.141235
R883 VDD.n7 VDD.n91 0.141235
R884 VDD.n88 VDD.n104 0.141235
R885 VDD.n4 VDD.n83 0.141235
R886 VDD.n80 VDD.n103 0.141235
R887 VDD.n78 VDD.n102 0.141235
R888 VDD.n62 VDD.n60 0.0613757
R889 VDD.n147 VDD.n146 0.12205
R890 VDD.n135 VDD.n133 0.11955
R891 VDD.n192 VDD.n191 0.117388
R892 VDD.n198 VDD.n197 0.117388
R893 VDD.n210 VDD.n209 0.117388
R894 VDD.n216 VDD.n215 0.117388
R895 VDD.n222 VDD.n221 0.117388
R896 VDD.n240 VDD.n239 0.117388
R897 VDD.n246 VDD.n245 0.117388
R898 VDD.n252 VDD.n251 0.117388
R899 VDD.n258 VDD.n257 0.117388
R900 VDD.n264 VDD.n263 0.117388
R901 VDD.n270 VDD.n269 0.117388
R902 VDD.n288 VDD.n287 0.117388
R903 VDD.n294 VDD.n293 0.117388
R904 VDD.n300 VDD.n299 0.117388
R905 VDD.n306 VDD.n305 0.117388
R906 VDD.n318 VDD.n317 0.117388
R907 VDD.n324 VDD.n323 0.117388
R908 VDD.n330 VDD.n329 0.117388
R909 VDD.n336 VDD.n335 0.117388
R910 VDD.n342 VDD.n341 0.117388
R911 VDD.n348 VDD.n347 0.117388
R912 VDD.n354 VDD.n353 0.117388
R913 VDD.n366 VDD.n365 0.117388
R914 VDD.n372 VDD.n371 0.117388
R915 VDD.n378 VDD.n377 0.117388
R916 VDD.n396 VDD.n395 0.11705
R917 VDD.n204 VDD.n203 0.11705
R918 VDD.n228 VDD.n227 0.11705
R919 VDD.n234 VDD.n233 0.11705
R920 VDD.n276 VDD.n275 0.11705
R921 VDD.n282 VDD.n281 0.11705
R922 VDD.n312 VDD.n311 0.11705
R923 VDD.n360 VDD.n359 0.11705
R924 VDD.n59 VDD.n379 0.114888
R925 VDD.n31 VDD.n149 0.1133
R926 VDD.n151 VDD.n150 0.1133
R927 VDD.n44 VDD.n140 0.104888
R928 VDD.n154 VDD.n153 0.101138
R929 VDD.n63 VDD.n113 0.340529
R930 VDD.n56 VDD.n36 0.257619
R931 VDD.n40 VDD.n39 0.251665
R932 VDD.n141 VDD.n43 0.24736
R933 VDD.n115 VDD.n58 0.205524
R934 VDD.n381 VDD.n62 0.146235
R935 VDD.n384 VDD.n56 0.146235
R936 VDD.n96 VDD.n55 0.224985
R937 VDD.n54 VDD.n53 0.224985
R938 VDD.n97 VDD.n52 0.224985
R939 VDD.n51 VDD.n50 0.224985
R940 VDD.n98 VDD.n49 0.224985
R941 VDD.n48 VDD.n47 0.224985
R942 VDD.n12 VDD.n11 0.211235
R943 VDD.n28 VDD.t17 15.0336
R944 VDD.n17 VDD.n9 1.20647
R945 VDD.n8 VDD.n19 1.20647
R946 VDD.n33 VDD.n6 1.20647
R947 VDD.n5 VDD.n23 1.20647
R948 VDD.n25 VDD.n3 1.20647
R949 VDD.n10 VDD.n32 1.20646
R950 VDD.n34 VDD.n28 1.17026
R951 VDD.n1 VDD.n0 1.10275
R952 VDD.n13 VDD.n12 0.134613
R953 VDD.n16 VDD.n15 0.43259
R954 VDD.n22 VDD.n21 0.409065
R955 VDD.n48 VDD.n26 1.01698
R956 VDD.n49 VDD.n24 1.01698
R957 VDD.n51 VDD.n22 1.01698
R958 VDD.n52 VDD.n20 1.01698
R959 VDD.n54 VDD.n18 1.01698
R960 VDD.n55 VDD.n16 1.01698
R961 VSS.t353 VSS.n527 119321
R962 VSS.n588 VSS.n587 22369.4
R963 VSS.n434 VSS.n305 7907.02
R964 VSS.n524 VSS.n202 4670.31
R965 VSS.n838 VSS.n837 3068.57
R966 VSS.t142 VSS.n68 310.202
R967 VSS.t594 VSS.n73 310.202
R968 VSS.t326 VSS.n580 849.322
R969 VSS.n639 VSS.n638 572.005
R970 VSS.t274 VSS.t209 571.348
R971 VSS.n654 VSS.t222 566.691
R972 VSS.n653 VSS.t318 560.899
R973 VSS.n643 VSS.t449 550.193
R974 VSS.n670 VSS.t260 539.653
R975 VSS.t460 VSS.n651 532.819
R976 VSS.n673 VSS.t413 522.508
R977 VSS.n664 VSS.t479 521.236
R978 VSS.t86 VSS.n650 514.091
R979 VSS.n660 VSS.t258 504.839
R980 VSS.n646 VSS.t429 504.839
R981 VSS.n671 VSS.t414 491.87
R982 VSS.n655 VSS.t555 474.904
R983 VSS.t202 VSS.n591 470.019
R984 VSS.n228 VSS.n227 469.783
R985 VSS.n241 VSS.n240 469.783
R986 VSS.n263 VSS.n262 469.783
R987 VSS.n282 VSS.n281 469.783
R988 VSS.n296 VSS.n295 469.783
R989 VSS.n310 VSS.n309 469.783
R990 VSS.n656 VSS.t111 456.175
R991 VSS.n215 VSS.n212 454.007
R992 VSS.n892 VSS.n891 454.007
R993 VSS.n246 VSS.n243 454.007
R994 VSS.n877 VSS.n876 454.007
R995 VSS.n868 VSS.n867 454.007
R996 VSS.n859 VSS.n858 454.007
R997 VSS.n218 VSS.n217 453.986
R998 VSS.n889 VSS.n888 453.986
R999 VSS.n249 VSS.n248 453.986
R1000 VSS.n874 VSS.n873 453.986
R1001 VSS.n865 VSS.n864 453.986
R1002 VSS.n856 VSS.n855 453.986
R1003 VSS.n225 VSS.n218 453.986
R1004 VSS.n888 VSS.n232 453.986
R1005 VSS.n260 VSS.n249 453.986
R1006 VSS.n873 VSS.n272 453.986
R1007 VSS.n864 VSS.n286 453.986
R1008 VSS.n855 VSS.n300 453.986
R1009 VSS.t295 VSS.n257 448.228
R1010 VSS.t554 VSS.n194 442.469
R1011 VSS.t587 VSS.n196 437.62
R1012 VSS.n266 VSS.t593 431.863
R1013 VSS.t235 VSS.n66 427.695
R1014 VSS.n650 VSS.t403 427.219
R1015 VSS.t462 VSS.n267 419.459
R1016 VSS.t64 VSS.n307 413.68
R1017 VSS.t53 VSS.n293 413.68
R1018 VSS.t42 VSS.n279 413.68
R1019 VSS.t31 VSS.n259 413.68
R1020 VSS.t20 VSS.n238 413.68
R1021 VSS.t9 VSS.n224 413.68
R1022 VSS.n658 VSS.n657 412.791
R1023 VSS.n644 VSS.n74 412.791
R1024 VSS.n818 VSS.n817 412.522
R1025 VSS.n209 VSS.t588 403.072
R1026 VSS.t167 VSS.n671 401.591
R1027 VSS.n266 VSS.t294 397.313
R1028 VSS.n207 VSS.t152 391.555
R1029 VSS.t326 VSS.n819 388.781
R1030 VSS.t5 VSS.n225 385.798
R1031 VSS.t16 VSS.n232 385.798
R1032 VSS.t27 VSS.n260 385.798
R1033 VSS.t38 VSS.n272 385.798
R1034 VSS.t49 VSS.n286 385.798
R1035 VSS.t60 VSS.n300 385.798
R1036 VSS.n204 VSS.t598 384.887
R1037 VSS.n205 VSS.t239 380.038
R1038 VSS.t475 VSS.n67 375.276
R1039 VSS.t196 VSS.n658 372.094
R1040 VSS.t198 VSS.n644 372.094
R1041 VSS.t142 VSS.n663 363.339
R1042 VSS.t594 VSS.n649 363.339
R1043 VSS.t617 VSS.t325 359.769
R1044 VSS.t339 VSS.n200 357.007
R1045 VSS.n640 VSS.t165 347.49
R1046 VSS.t340 VSS.n198 333.974
R1047 VSS.n204 VSS.t586 333.065
R1048 VSS.t10 VSS.n224 333.063
R1049 VSS.t21 VSS.n238 333.063
R1050 VSS.t32 VSS.n259 333.063
R1051 VSS.t43 VSS.n279 333.063
R1052 VSS.t54 VSS.n293 333.063
R1053 VSS.n307 VSS.t65 333.063
R1054 VSS.t451 VSS.n595 329.238
R1055 VSS.n781 VSS.t274 327.81
R1056 VSS.t605 VSS.n192 322.457
R1057 VSS.n269 VSS.t421 322.457
R1058 VSS.t353 VSS.n836 314.327
R1059 VSS.n674 VSS.t412 313.659
R1060 VSS.n217 VSS.t3 305.183
R1061 VSS.n889 VSS.t14 305.183
R1062 VSS.n248 VSS.t25 305.183
R1063 VSS.n874 VSS.t36 305.183
R1064 VSS.n865 VSS.t47 305.183
R1065 VSS.n856 VSS.t58 305.183
R1066 VSS.t219 VSS.t218 304.42
R1067 VSS.t257 VSS.n661 304.42
R1068 VSS.t615 VSS.t341 304.42
R1069 VSS.t428 VSS.n647 304.42
R1070 VSS.t259 VSS.n673 299.735
R1071 VSS.n208 VSS.t553 299.425
R1072 VSS.t0 VSS.n215 293.666
R1073 VSS.n891 VSS.t11 293.666
R1074 VSS.t22 VSS.n246 293.666
R1075 VSS.n876 VSS.t33 293.666
R1076 VSS.n867 VSS.t44 293.666
R1077 VSS.n858 VSS.t55 293.666
R1078 VSS.n311 VSS.t212 292.757
R1079 VSS.t285 VSS.n292 292.757
R1080 VSS.t182 VSS.n278 292.757
R1081 VSS.t447 VSS.n255 292.757
R1082 VSS.t175 VSS.n258 292.757
R1083 VSS.t287 VSS.n237 292.757
R1084 VSS.t180 VSS.n223 292.757
R1085 VSS.t445 VSS.n190 292.757
R1086 VSS.t144 VSS.n660 291.37
R1087 VSS.t244 VSS.n646 291.37
R1088 VSS.n208 VSS.t599 287.909
R1089 VSS.n211 VSS.t194 275.505
R1090 VSS.t226 VSS.n194 269.724
R1091 VSS.t606 VSS.n192 264.875
R1092 VSS.n269 VSS.t422 264.875
R1093 VSS.t213 VSS.n305 258.238
R1094 VSS.n265 VSS.t176 258.236
R1095 VSS.n859 VSS.t286 258.233
R1096 VSS.n868 VSS.t183 258.233
R1097 VSS.n877 VSS.t448 258.233
R1098 VSS.n892 VSS.t181 258.233
R1099 VSS.n212 VSS.t446 258.233
R1100 VSS.n243 VSS.t288 258.233
R1101 VSS.t154 VSS.n197 258.231
R1102 VSS.t225 VSS.n198 253.359
R1103 VSS.t151 VSS.n98 252.375
R1104 VSS.t319 VSS.n104 252.375
R1105 VSS.t227 VSS.n123 252.375
R1106 VSS.t200 VSS.n129 252.375
R1107 VSS.t247 VSS.n132 252.375
R1108 VSS.t335 VSS.n127 252.375
R1109 VSS.t597 VSS.n126 252.375
R1110 VSS.t425 VSS.n119 252.375
R1111 VSS.t604 VSS.n118 252.375
R1112 VSS.t452 VSS.n111 252.375
R1113 VSS.t245 VSS.n110 252.375
R1114 VSS.n107 VSS.t317 252.375
R1115 VSS.n102 VSS.t470 252.375
R1116 VSS.n176 VSS.t96 252.374
R1117 VSS.n175 VSS.t248 252.374
R1118 VSS.n173 VSS.t109 252.374
R1119 VSS.n167 VSS.t405 252.374
R1120 VSS.t215 VSS.n134 252.117
R1121 VSS.t124 VSS.n136 252.117
R1122 VSS.n125 VSS.t201 252.117
R1123 VSS.n122 VSS.t103 252.117
R1124 VSS.t272 VSS.n141 252.117
R1125 VSS.t229 VSS.n117 252.117
R1126 VSS.t350 VSS.n146 252.117
R1127 VSS.n149 VSS.t228 252.117
R1128 VSS.n114 VSS.t271 252.117
R1129 VSS.t273 VSS.n152 252.117
R1130 VSS.t169 VSS.n109 252.117
R1131 VSS.t477 VSS.n156 252.117
R1132 VSS.n170 VSS.t76 252.115
R1133 VSS.n166 VSS.t83 252.115
R1134 VSS.n163 VSS.t328 252.115
R1135 VSS.t533 VSS.n353 250.837
R1136 VSS.t495 VSS.n354 250.837
R1137 VSS.t498 VSS.n358 250.837
R1138 VSS.t485 VSS.n359 250.837
R1139 VSS.t496 VSS.n363 250.837
R1140 VSS.t490 VSS.n364 250.837
R1141 VSS.t497 VSS.n368 250.837
R1142 VSS.t535 VSS.n369 250.837
R1143 VSS.t534 VSS.n373 250.837
R1144 VSS.t536 VSS.n374 250.837
R1145 VSS.t484 VSS.n378 250.837
R1146 VSS.t539 VSS.n379 250.837
R1147 VSS.t538 VSS.n383 250.837
R1148 VSS.t537 VSS.n384 250.837
R1149 VSS.t493 VSS.n388 250.837
R1150 VSS.t489 VSS.n389 250.837
R1151 VSS.t488 VSS.n393 250.837
R1152 VSS.t541 VSS.n394 250.837
R1153 VSS.t540 VSS.n398 250.837
R1154 VSS.t483 VSS.n399 250.837
R1155 VSS.t492 VSS.n403 250.837
R1156 VSS.t542 VSS.n404 250.837
R1157 VSS.t491 VSS.n408 250.837
R1158 VSS.t543 VSS.n409 250.837
R1159 VSS.t486 VSS.n413 250.837
R1160 VSS.t544 VSS.n414 250.837
R1161 VSS.t487 VSS.n418 250.837
R1162 VSS.t547 VSS.n419 250.837
R1163 VSS.t546 VSS.n423 250.837
R1164 VSS.t545 VSS.n424 250.837
R1165 VSS.t548 VSS.n428 250.837
R1166 VSS.t549 VSS.n429 250.837
R1167 VSS.t235 VSS.n68 148.06
R1168 VSS.t403 VSS.n73 148.06
R1169 VSS.n640 VSS.t451 243.244
R1170 VSS.n203 VSS.t223 240.956
R1171 VSS.t7 VSS.n226 240.956
R1172 VSS.t18 VSS.n239 240.956
R1173 VSS.t29 VSS.n261 240.956
R1174 VSS.t40 VSS.n280 240.956
R1175 VSS.t51 VSS.n294 240.956
R1176 VSS.t62 VSS.n308 240.956
R1177 VSS.n512 VSS.t270 234.114
R1178 VSS.n507 VSS.t473 234.114
R1179 VSS.n502 VSS.t66 234.114
R1180 VSS.n497 VSS.t265 234.114
R1181 VSS.n492 VSS.t163 234.114
R1182 VSS.n487 VSS.t99 234.114
R1183 VSS.n482 VSS.t77 234.114
R1184 VSS.n477 VSS.t601 234.114
R1185 VSS.n472 VSS.t439 234.114
R1186 VSS.n467 VSS.t173 234.114
R1187 VSS.n462 VSS.t158 234.114
R1188 VSS.n457 VSS.t255 234.114
R1189 VSS.n452 VSS.t323 234.114
R1190 VSS.n447 VSS.t400 234.114
R1191 VSS.n442 VSS.t130 234.114
R1192 VSS.n437 VSS.t216 234.114
R1193 VSS.t238 VSS.n200 230.327
R1194 VSS.n227 VSS.t7 229.44
R1195 VSS.n240 VSS.t18 229.44
R1196 VSS.n262 VSS.t29 229.44
R1197 VSS.n281 VSS.t40 229.44
R1198 VSS.n295 VSS.t51 229.44
R1199 VSS.n309 VSS.t62 229.44
R1200 VSS.t223 VSS.n202 228.827
R1201 VSS.t233 VSS.n131 225.361
R1202 VSS.t471 VSS.n137 225.361
R1203 VSS.t68 VSS.n124 225.361
R1204 VSS.t266 VSS.n121 225.361
R1205 VSS.t101 VSS.n144 225.361
R1206 VSS.t79 VSS.n147 225.361
R1207 VSS.t600 VSS.n115 225.361
R1208 VSS.t440 VSS.n113 225.361
R1209 VSS.t172 VSS.n153 225.361
R1210 VSS.t160 VSS.n155 225.361
R1211 VSS.t256 VSS.n105 225.361
R1212 VSS.t321 VSS.n157 225.361
R1213 VSS.t132 VSS.n100 225.361
R1214 VSS.n181 VSS.t268 225.359
R1215 VSS.n177 VSS.t162 225.359
R1216 VSS.n165 VSS.t401 225.359
R1217 VSS.t165 VSS.n639 224.516
R1218 VSS.t446 VSS.n190 212.143
R1219 VSS.t181 VSS.n223 212.143
R1220 VSS.t288 VSS.n237 212.143
R1221 VSS.t176 VSS.n258 212.143
R1222 VSS.t448 VSS.n255 212.143
R1223 VSS.t183 VSS.n278 212.143
R1224 VSS.t286 VSS.n292 212.143
R1225 VSS.n311 VSS.t213 212.143
R1226 VSS.n180 VSS.t177 211.982
R1227 VSS.n169 VSS.t436 211.982
R1228 VSS.n164 VSS.t577 211.982
R1229 VSS.t610 VSS.n128 211.982
R1230 VSS.n138 VSS.t250 211.982
R1231 VSS.n140 VSS.t329 211.982
R1232 VSS.t304 VSS.n120 211.982
R1233 VSS.n142 VSS.t332 211.982
R1234 VSS.t406 VSS.n116 211.982
R1235 VSS.n148 VSS.t415 211.982
R1236 VSS.n150 VSS.t607 211.982
R1237 VSS.t155 VSS.n112 211.982
R1238 VSS.n154 VSS.t336 211.982
R1239 VSS.t621 VSS.n108 211.982
R1240 VSS.t418 VSS.n103 211.982
R1241 VSS.t289 VSS.n99 211.982
R1242 VSS.n672 VSS.t167 208.828
R1243 VSS.n205 VSS.t238 207.294
R1244 VSS.n674 VSS.t259 202.362
R1245 VSS.n659 VSS.t196 202.071
R1246 VSS.n645 VSS.t198 202.071
R1247 VSS.n199 VSS.t225 200.649
R1248 VSS.n588 VSS.n0 197.518
R1249 VSS.n664 VSS.t475 196.911
R1250 VSS.n661 VSS.t144 196.399
R1251 VSS.n647 VSS.t244 196.399
R1252 VSS.n207 VSS.t154 195.778
R1253 VSS.t189 VSS.n133 195.26
R1254 VSS.t312 VSS.n135 195.26
R1255 VSS.t145 VSS.n139 195.26
R1256 VSS.t590 VSS.n143 195.26
R1257 VSS.t581 VSS.n145 195.26
R1258 VSS.t552 VSS.n151 195.26
R1259 VSS.t191 VSS.n106 195.26
R1260 VSS.t394 VSS.n158 195.26
R1261 VSS.t453 VSS.n101 195.26
R1262 VSS.t467 VSS.n159 195.26
R1263 VSS.n179 VSS.t409 195.26
R1264 VSS.n178 VSS.t344 195.26
R1265 VSS.n174 VSS.t602 195.26
R1266 VSS.n172 VSS.t104 195.26
R1267 VSS.n171 VSS.t140 195.26
R1268 VSS.n168 VSS.t184 195.26
R1269 VSS.t194 VSS.n191 194.899
R1270 VSS.n820 VSS.t326 194.514
R1271 VSS.t422 VSS.n256 189.137
R1272 VSS.n211 VSS.t606 189.135
R1273 VSS.t412 VSS.n589 187.895
R1274 VSS.n513 VSS.t392 187.292
R1275 VSS.n508 VSS.t463 187.292
R1276 VSS.n503 VSS.t464 187.292
R1277 VSS.n498 VSS.t84 187.292
R1278 VSS.n493 VSS.t620 187.292
R1279 VSS.n488 VSS.t348 187.292
R1280 VSS.n483 VSS.t398 187.292
R1281 VSS.n478 VSS.t149 187.292
R1282 VSS.n473 VSS.t346 187.292
R1283 VSS.n468 VSS.t108 187.292
R1284 VSS.n463 VSS.t351 187.292
R1285 VSS.n458 VSS.t230 187.292
R1286 VSS.n453 VSS.t114 187.292
R1287 VSS.n448 VSS.t592 187.292
R1288 VSS.n443 VSS.t443 187.292
R1289 VSS.n438 VSS.t253 187.292
R1290 VSS.n209 VSS.t226 184.262
R1291 VSS.t110 VSS.n656 183.975
R1292 VSS.n662 VSS.t257 182.797
R1293 VSS.n648 VSS.t428 182.797
R1294 VSS.n6 VSS.t469 177.713
R1295 VSS.n191 VSS.t445 177.617
R1296 VSS.n256 VSS.t447 177.617
R1297 VSS.n229 VSS.t180 177.615
R1298 VSS.n242 VSS.t287 177.615
R1299 VSS.n264 VSS.t175 177.615
R1300 VSS.n283 VSS.t182 177.615
R1301 VSS.n297 VSS.t285 177.615
R1302 VSS.t212 VSS.n306 177.615
R1303 VSS.t427 VSS.n357 173.913
R1304 VSS.t569 VSS.n362 173.913
R1305 VSS.n367 VSS.t303 173.913
R1306 VSS.n372 VSS.t574 173.913
R1307 VSS.t74 VSS.n377 173.913
R1308 VSS.n382 VSS.t126 173.913
R1309 VSS.t293 VSS.n387 173.913
R1310 VSS.t456 VSS.n392 173.913
R1311 VSS.n397 VSS.t300 173.913
R1312 VSS.t71 VSS.n402 173.913
R1313 VSS.n407 VSS.t298 173.913
R1314 VSS.t128 VSS.n412 173.913
R1315 VSS.t619 VSS.n417 173.913
R1316 VSS.t459 VSS.n422 173.913
R1317 VSS.t576 VSS.n427 173.913
R1318 VSS.t571 VSS.n432 173.913
R1319 VSS.n435 VSS.n434 173.913
R1320 VSS.t94 VSS.n643 167.954
R1321 VSS.t611 VSS.t187 163.881
R1322 VSS.t178 VSS.t310 163.881
R1323 VSS.t251 VSS.t147 163.881
R1324 VSS.t330 VSS.t410 163.881
R1325 VSS.t305 VSS.t342 163.881
R1326 VSS.t333 VSS.t591 163.881
R1327 VSS.t407 VSS.t580 163.881
R1328 VSS.t416 VSS.t603 163.881
R1329 VSS.t608 VSS.t551 163.881
R1330 VSS.t156 VSS.t106 163.881
R1331 VSS.t337 VSS.t138 163.881
R1332 VSS.t622 VSS.t193 163.881
R1333 VSS.t437 VSS.t185 163.881
R1334 VSS.t419 VSS.t393 163.881
R1335 VSS.t578 VSS.t454 163.881
R1336 VSS.t290 VSS.t466 163.881
R1337 VSS.n216 VSS.t0 160.341
R1338 VSS.n230 VSS.t11 160.341
R1339 VSS.n247 VSS.t22 160.341
R1340 VSS.n270 VSS.t33 160.341
R1341 VSS.n284 VSS.t44 160.341
R1342 VSS.n298 VSS.t55 160.341
R1343 VSS.t434 VSS.n185 157.601
R1344 VSS.n186 VSS.t432 156.464
R1345 VSS.t582 VSS.n128 155.126
R1346 VSS.t596 VSS.n138 155.126
R1347 VSS.t480 VSS.n140 155.126
R1348 VSS.t468 VSS.n120 155.126
R1349 VSS.t396 VSS.n142 155.126
R1350 VSS.t204 VSS.n116 155.126
R1351 VSS.t584 VSS.n148 155.126
R1352 VSS.t116 VSS.n150 155.126
R1353 VSS.t249 VSS.n112 155.126
R1354 VSS.t246 VSS.n154 155.126
R1355 VSS.t81 VSS.n108 155.126
R1356 VSS.t242 VSS.n103 155.126
R1357 VSS.t307 VSS.n99 155.126
R1358 VSS.n180 VSS.t320 155.125
R1359 VSS.n169 VSS.t404 155.125
R1360 VSS.n164 VSS.t118 155.125
R1361 VSS.n561 VSS.t363 154.613
R1362 VSS.n572 VSS.t370 154.613
R1363 VSS.t553 VSS.n195 153.971
R1364 VSS.n186 VSS.t237 153.851
R1365 VSS.n522 VSS.t390 153.846
R1366 VSS.n513 VSS.t426 153.846
R1367 VSS.n508 VSS.t568 153.846
R1368 VSS.n503 VSS.t302 153.846
R1369 VSS.n498 VSS.t573 153.846
R1370 VSS.n493 VSS.t73 153.846
R1371 VSS.n488 VSS.t125 153.846
R1372 VSS.n483 VSS.t292 153.846
R1373 VSS.n478 VSS.t455 153.846
R1374 VSS.n473 VSS.t299 153.846
R1375 VSS.n468 VSS.t70 153.846
R1376 VSS.n463 VSS.t297 153.846
R1377 VSS.n458 VSS.t127 153.846
R1378 VSS.n453 VSS.t618 153.846
R1379 VSS.n448 VSS.t458 153.846
R1380 VSS.n443 VSS.t575 153.846
R1381 VSS.n438 VSS.t570 153.846
R1382 VSS.t435 VSS.n97 153.236
R1383 VSS.t599 VSS.n196 149.713
R1384 VSS.t3 VSS.n216 148.826
R1385 VSS.t14 VSS.n230 148.826
R1386 VSS.t25 VSS.n247 148.826
R1387 VSS.t36 VSS.n270 148.826
R1388 VSS.t47 VSS.n284 148.826
R1389 VSS.t58 VSS.n298 148.826
R1390 VSS.n5 VSS.t461 147.453
R1391 VSS.t231 VSS.n356 147.157
R1392 VSS.t240 VSS.n361 147.157
R1393 VSS.t478 VSS.n366 147.157
R1394 VSS.t91 VSS.n371 147.157
R1395 VSS.t583 VSS.n376 147.157
R1396 VSS.t309 VSS.n381 147.157
R1397 VSS.t481 VSS.n386 147.157
R1398 VSS.t441 VSS.n391 147.157
R1399 VSS.t261 VSS.n396 147.157
R1400 VSS.t474 VSS.n401 147.157
R1401 VSS.t423 VSS.n406 147.157
R1402 VSS.t112 VSS.n411 147.157
R1403 VSS.t210 VSS.n416 147.157
R1404 VSS.t314 VSS.n421 147.157
R1405 VSS.t482 VSS.n426 147.157
R1406 VSS.t316 VSS.n431 147.157
R1407 VSS.n161 VSS.t386 145.091
R1408 VSS.t218 VSS.n662 138.607
R1409 VSS.t341 VSS.n648 138.607
R1410 VSS.t382 VSS.n161 138.403
R1411 VSS.t65 VSS.n306 137.311
R1412 VSS.n297 VSS.t54 137.311
R1413 VSS.n283 VSS.t43 137.311
R1414 VSS.n264 VSS.t32 137.311
R1415 VSS.n242 VSS.t21 137.311
R1416 VSS.n229 VSS.t10 137.311
R1417 VSS.t586 VSS.n203 137.309
R1418 VSS.n638 VSS.n597 132.891
R1419 VSS.n162 VSS.t382 131.971
R1420 VSS.n193 VSS.t605 130.939
R1421 VSS.t421 VSS.n268 130.939
R1422 VSS.n845 VSS.t263 127.421
R1423 VSS.t520 VSS.n1 125.359
R1424 VSS.t122 VSS.n841 123.674
R1425 VSS.n589 VSS.n588 122.129
R1426 VSS.n591 VSS.t617 121.858
R1427 VSS.t432 VSS.n97 120.691
R1428 VSS.n206 VSS.t340 119.422
R1429 VSS.n183 VSS.t433 118.249
R1430 VSS.t386 VSS.n435 117.058
R1431 VSS.n840 VSS.t171 116.177
R1432 VSS.t111 VSS.n655 115.831
R1433 VSS.t585 VSS.n581 112.174
R1434 VSS.t170 VSS.n843 108.683
R1435 VSS.n638 VSS.n637 107.177
R1436 VSS.n515 VSS.t582 107.023
R1437 VSS.n512 VSS.t231 107.023
R1438 VSS.t320 VSS.n510 107.023
R1439 VSS.n507 VSS.t240 107.023
R1440 VSS.n505 VSS.t596 107.023
R1441 VSS.n502 VSS.t478 107.023
R1442 VSS.n500 VSS.t480 107.023
R1443 VSS.n497 VSS.t91 107.023
R1444 VSS.n495 VSS.t468 107.023
R1445 VSS.n492 VSS.t583 107.023
R1446 VSS.n490 VSS.t396 107.023
R1447 VSS.n487 VSS.t309 107.023
R1448 VSS.n485 VSS.t204 107.023
R1449 VSS.n482 VSS.t481 107.023
R1450 VSS.n480 VSS.t584 107.023
R1451 VSS.n477 VSS.t441 107.023
R1452 VSS.n475 VSS.t116 107.023
R1453 VSS.n472 VSS.t261 107.023
R1454 VSS.n470 VSS.t249 107.023
R1455 VSS.n467 VSS.t474 107.023
R1456 VSS.n465 VSS.t246 107.023
R1457 VSS.n462 VSS.t423 107.023
R1458 VSS.n460 VSS.t81 107.023
R1459 VSS.n457 VSS.t112 107.023
R1460 VSS.t404 VSS.n455 107.023
R1461 VSS.n452 VSS.t210 107.023
R1462 VSS.n450 VSS.t242 107.023
R1463 VSS.n447 VSS.t314 107.023
R1464 VSS.t118 VSS.n445 107.023
R1465 VSS.n442 VSS.t482 107.023
R1466 VSS.n440 VSS.t307 107.023
R1467 VSS.n437 VSS.t316 107.023
R1468 VSS.t206 VSS.n838 106.808
R1469 VSS.n669 VSS.t202 103.538
R1470 VSS.n676 VSS.t465 103.379
R1471 VSS.n522 VSS.t376 100.335
R1472 VSS.t426 VSS.n356 100.335
R1473 VSS.t568 VSS.n361 100.335
R1474 VSS.t302 VSS.n366 100.335
R1475 VSS.t573 VSS.n371 100.335
R1476 VSS.t73 VSS.n376 100.335
R1477 VSS.t125 VSS.n381 100.335
R1478 VSS.t292 VSS.n386 100.335
R1479 VSS.t455 VSS.n391 100.335
R1480 VSS.t299 VSS.n396 100.335
R1481 VSS.t70 VSS.n401 100.335
R1482 VSS.t297 VSS.n406 100.335
R1483 VSS.t127 VSS.n411 100.335
R1484 VSS.t618 VSS.n416 100.335
R1485 VSS.t458 VSS.n421 100.335
R1486 VSS.t575 VSS.n426 100.335
R1487 VSS.t570 VSS.n431 100.335
R1488 VSS.n561 VSS.t366 99.7511
R1489 VSS.t372 VSS.n572 99.7511
R1490 VSS.n675 VSS.t97 98.4633
R1491 VSS.t366 VSS.n1 97.9284
R1492 VSS.n4 VSS.t372 97.9276
R1493 VSS.t555 VSS.n654 97.5777
R1494 VSS.t236 VSS.n847 97.4396
R1495 VSS.n201 VSS.t339 96.3896
R1496 VSS.n185 VSS.t264 93.8889
R1497 VSS.n847 VSS.t207 93.6919
R1498 VSS.n162 VSS.t571 88.495
R1499 VSS.n182 VSS.t430 88.4111
R1500 VSS.t413 VSS.n672 88.3462
R1501 VSS.n170 VSS.t128 88.2366
R1502 VSS.n166 VSS.t459 88.2366
R1503 VSS.n163 VSS.t576 88.2366
R1504 VSS.n134 VSS.t427 88.2359
R1505 VSS.n136 VSS.t569 88.2359
R1506 VSS.t303 VSS.n125 88.2359
R1507 VSS.t574 VSS.n122 88.2359
R1508 VSS.n141 VSS.t74 88.2359
R1509 VSS.t126 VSS.n117 88.2359
R1510 VSS.n146 VSS.t293 88.2359
R1511 VSS.n149 VSS.t456 88.2359
R1512 VSS.t300 VSS.n114 88.2359
R1513 VSS.n152 VSS.t71 88.2359
R1514 VSS.t298 VSS.n109 88.2359
R1515 VSS.n156 VSS.t619 88.2359
R1516 VSS.t376 VSS.t388 86.957
R1517 VSS.t390 VSS.t378 86.957
R1518 VSS.t258 VSS.n659 85.7923
R1519 VSS.t429 VSS.n645 85.7923
R1520 VSS.t598 VSS.n201 84.8733
R1521 VSS.t430 VSS.n524 83.0562
R1522 VSS.n843 VSS.t431 82.449
R1523 VSS.t414 VSS.n670 81.2384
R1524 VSS.n3 VSS.t520 80.4704
R1525 VSS.t134 VSS.n688 77.8798
R1526 VSS.n818 VSS.t324 77.2751
R1527 VSS.t93 VSS.t612 77.2751
R1528 VSS.n819 VSS.t325 75.4357
R1529 VSS.t431 VSS.n184 75.2962
R1530 VSS.t120 VSS.n840 74.9537
R1531 VSS.t388 VSS.n130 74.8587
R1532 VSS.n605 VSS.t424 74.7824
R1533 VSS.t239 VSS.n199 73.9692
R1534 VSS.t614 VSS.n582 73.536
R1535 VSS.n587 VSS.n583 73.536
R1536 VSS.n515 VSS.t611 70.2346
R1537 VSS.n510 VSS.t178 70.2346
R1538 VSS.n505 VSS.t251 70.2346
R1539 VSS.n500 VSS.t330 70.2346
R1540 VSS.n495 VSS.t305 70.2346
R1541 VSS.n490 VSS.t333 70.2346
R1542 VSS.n485 VSS.t407 70.2346
R1543 VSS.n480 VSS.t416 70.2346
R1544 VSS.n475 VSS.t608 70.2346
R1545 VSS.n470 VSS.t156 70.2346
R1546 VSS.n465 VSS.t337 70.2346
R1547 VSS.n460 VSS.t622 70.2346
R1548 VSS.n455 VSS.t437 70.2346
R1549 VSS.n450 VSS.t419 70.2346
R1550 VSS.n445 VSS.t578 70.2346
R1551 VSS.n440 VSS.t290 70.2346
R1552 VSS.n44 VSS.n10 12.4712
R1553 VSS.t558 VSS.n734 69.1047
R1554 VSS.n226 VSS.t5 68.211
R1555 VSS.n239 VSS.t16 68.211
R1556 VSS.n261 VSS.t27 68.211
R1557 VSS.n280 VSS.t38 68.211
R1558 VSS.n294 VSS.t49 68.211
R1559 VSS.n308 VSS.t60 68.211
R1560 VSS.n841 VSS.t120 67.4583
R1561 VSS.n762 VSS.t136 66.9109
R1562 VSS.n514 VSS.t189 66.8901
R1563 VSS.t392 VSS.n354 66.8901
R1564 VSS.n509 VSS.t312 66.8901
R1565 VSS.t463 VSS.n359 66.8901
R1566 VSS.n504 VSS.t145 66.8901
R1567 VSS.t464 VSS.n364 66.8901
R1568 VSS.t409 VSS.n499 66.8901
R1569 VSS.t84 VSS.n369 66.8901
R1570 VSS.t344 VSS.n494 66.8901
R1571 VSS.t620 VSS.n374 66.8901
R1572 VSS.n489 VSS.t590 66.8901
R1573 VSS.t348 VSS.n379 66.8901
R1574 VSS.n484 VSS.t581 66.8901
R1575 VSS.t398 VSS.n384 66.8901
R1576 VSS.t602 VSS.n479 66.8901
R1577 VSS.t149 VSS.n389 66.8901
R1578 VSS.n474 VSS.t552 66.8901
R1579 VSS.t346 VSS.n394 66.8901
R1580 VSS.t104 VSS.n469 66.8901
R1581 VSS.t108 VSS.n399 66.8901
R1582 VSS.t140 VSS.n464 66.8901
R1583 VSS.t351 VSS.n404 66.8901
R1584 VSS.n459 VSS.t191 66.8901
R1585 VSS.t230 VSS.n409 66.8901
R1586 VSS.t184 VSS.n454 66.8901
R1587 VSS.t114 VSS.n414 66.8901
R1588 VSS.n449 VSS.t394 66.8901
R1589 VSS.t592 VSS.n419 66.8901
R1590 VSS.n444 VSS.t453 66.8901
R1591 VSS.t443 VSS.n424 66.8901
R1592 VSS.n439 VSS.t467 66.8901
R1593 VSS.t253 VSS.n429 66.8901
R1594 VSS.t510 VSS.n631 65.3709
R1595 VSS.n637 VSS.t499 65.365
R1596 VSS.t264 VSS.n845 63.7107
R1597 VSS.t207 VSS.n846 62.4441
R1598 VSS.n630 VSS.t514 62.1578
R1599 VSS.t152 VSS.n206 61.8407
R1600 VSS.n587 VSS.n586 59.3547
R1601 VSS.n848 VSS.t236 58.6964
R1602 VSS.n754 VSS.t563 58.1358
R1603 VSS.t424 VSS.n597 58.1084
R1604 VSS.t461 VSS.n4 58.0274
R1605 VSS.n651 VSS.t86 57.9156
R1606 VSS.t294 VSS.n257 56.6734
R1607 VSS.n228 VSS.t9 56.0825
R1608 VSS.n241 VSS.t20 56.0825
R1609 VSS.n263 VSS.t31 56.0825
R1610 VSS.n282 VSS.t42 56.0825
R1611 VSS.n296 VSS.t53 56.0825
R1612 VSS.n310 VSS.t64 56.0825
R1613 VSS.t560 VSS.n703 55.942
R1614 VSS.t506 VSS.n633 55.7378
R1615 VSS.n635 VSS.t504 55.7312
R1616 VSS.t433 VSS.n182 54.6841
R1617 VSS.t353 VSS.n9 53.7482
R1618 VSS.n605 VSS.t327 52.3478
R1619 VSS.t479 VSS.n66 51.2456
R1620 VSS.t588 VSS.n193 50.3244
R1621 VSS.n268 VSS.t462 50.3244
R1622 VSS.n353 VSS.t610 50.1677
R1623 VSS.t177 VSS.n358 50.1677
R1624 VSS.t250 VSS.n363 50.1677
R1625 VSS.t329 VSS.n368 50.1677
R1626 VSS.n373 VSS.t304 50.1677
R1627 VSS.t332 VSS.n378 50.1677
R1628 VSS.n383 VSS.t406 50.1677
R1629 VSS.t415 VSS.n388 50.1677
R1630 VSS.t607 VSS.n393 50.1677
R1631 VSS.n398 VSS.t155 50.1677
R1632 VSS.t336 VSS.n403 50.1677
R1633 VSS.n408 VSS.t621 50.1677
R1634 VSS.t436 VSS.n413 50.1677
R1635 VSS.n418 VSS.t418 50.1677
R1636 VSS.t577 VSS.n423 50.1677
R1637 VSS.n428 VSS.t289 50.1677
R1638 VSS.n712 VSS.t356 49.3606
R1639 VSS.n844 VSS.t170 47.4535
R1640 VSS.t135 VSS.n770 47.1669
R1641 VSS.t137 VSS.n695 47.1669
R1642 VSS.n675 VSS.t614 46.116
R1643 VSS.t502 VSS.n635 46.1019
R1644 VSS.n633 VSS.t508 46.0991
R1645 VSS.n742 VSS.t556 44.9731
R1646 VSS.n663 VSS.t219 44.1903
R1647 VSS.n649 VSS.t615 44.1903
R1648 VSS.t370 VSS.n3 43.0642
R1649 VSS.t363 VSS.n0 43.0619
R1650 VSS.t324 VSS.n581 42.3769
R1651 VSS.t171 VSS.n839 39.9582
R1652 VSS.t512 VSS.n630 39.6795
R1653 VSS.n652 VSS.t460 39.1873
R1654 VSS.t556 VSS.n741 38.3917
R1655 VSS.n517 VSS.t233 36.7898
R1656 VSS.t268 VSS.n511 36.7898
R1657 VSS.n506 VSS.t471 36.7898
R1658 VSS.n501 VSS.t68 36.7898
R1659 VSS.n496 VSS.t266 36.7898
R1660 VSS.t162 VSS.n491 36.7898
R1661 VSS.n486 VSS.t101 36.7898
R1662 VSS.n481 VSS.t79 36.7898
R1663 VSS.n476 VSS.t600 36.7898
R1664 VSS.n471 VSS.t440 36.7898
R1665 VSS.n466 VSS.t172 36.7898
R1666 VSS.n461 VSS.t160 36.7898
R1667 VSS.n456 VSS.t256 36.7898
R1668 VSS.n451 VSS.t321 36.7898
R1669 VSS.t401 VSS.n446 36.7898
R1670 VSS.n441 VSS.t132 36.7898
R1671 VSS.n837 VSS.t353 36.5305
R1672 VSS.n631 VSS.t512 36.466
R1673 VSS.n839 VSS.t206 36.2105
R1674 VSS.n771 VSS.t135 36.1979
R1675 VSS.n755 VSS.t137 36.1979
R1676 VSS.n184 VSS.t122 34.07
R1677 VSS.t356 VSS.n711 34.0042
R1678 VSS.t260 VSS.n669 33.9067
R1679 VSS.t465 VSS.n582 31.1596
R1680 VSS.n636 VSS.t502 30.0455
R1681 VSS.t508 VSS.n632 30.0445
R1682 VSS.t263 VSS.n844 28.7152
R1683 VSS.n838 VSS.n183 28.3058
R1684 VSS.t187 VSS.n132 28.2938
R1685 VSS.t310 VSS.n127 28.2938
R1686 VSS.t342 VSS.n119 28.2938
R1687 VSS.t106 VSS.n111 28.2938
R1688 VSS.t193 VSS.n107 28.2938
R1689 VSS.t147 VSS.n126 28.2938
R1690 VSS.t410 VSS.n123 28.2938
R1691 VSS.t591 VSS.n118 28.2938
R1692 VSS.t138 VSS.n110 28.2938
R1693 VSS.t185 VSS.n104 28.2938
R1694 VSS.t454 VSS.n102 28.2938
R1695 VSS.t466 VSS.n98 28.2938
R1696 VSS.t580 VSS.n176 28.2936
R1697 VSS.t603 VSS.n175 28.2936
R1698 VSS.t551 VSS.n173 28.2936
R1699 VSS.t393 VSS.n167 28.2936
R1700 VSS.n130 VSS.t435 28.0352
R1701 VSS.t469 VSS.n5 27.7516
R1702 VSS.t318 VSS.n652 27.6043
R1703 VSS.n704 VSS.t560 27.4228
R1704 VSS.n195 VSS.t554 27.2918
R1705 VSS.t563 VSS.n753 25.229
R1706 VSS.t612 VSS.n586 24.4565
R1707 VSS.n676 VSS.t585 22.3643
R1708 VSS.t222 VSS.n653 22.2881
R1709 VSS.n595 VSS.t449 22.2881
R1710 VSS.n267 VSS.t295 22.1486
R1711 VSS.t593 VSS.n265 22.1466
R1712 VSS.t378 VSS.n129 21.6048
R1713 VSS.t97 VSS.n583 21.1887
R1714 VSS.n634 VSS.t506 20.4133
R1715 VSS.t504 VSS.n634 20.4107
R1716 VSS.t270 VSS.n357 20.0674
R1717 VSS.t473 VSS.n362 20.0674
R1718 VSS.t66 VSS.n367 20.0674
R1719 VSS.t265 VSS.n372 20.0674
R1720 VSS.t163 VSS.n377 20.0674
R1721 VSS.t99 VSS.n382 20.0674
R1722 VSS.t77 VSS.n387 20.0674
R1723 VSS.t601 VSS.n392 20.0674
R1724 VSS.t439 VSS.n397 20.0674
R1725 VSS.t173 VSS.n402 20.0674
R1726 VSS.t158 VSS.n407 20.0674
R1727 VSS.t255 VSS.n412 20.0674
R1728 VSS.t323 VSS.n417 20.0674
R1729 VSS.t400 VSS.n422 20.0674
R1730 VSS.t130 VSS.n427 20.0674
R1731 VSS.t216 VSS.n432 20.0674
R1732 VSS.t326 VSS.t327 19.9423
R1733 VSS.n181 VSS.t215 18.0025
R1734 VSS.n179 VSS.t227 18.0025
R1735 VSS.n178 VSS.t425 18.0025
R1736 VSS.n177 VSS.t272 18.0025
R1737 VSS.t248 VSS.n174 18.0025
R1738 VSS.n172 VSS.t452 18.0025
R1739 VSS.n171 VSS.t245 18.0025
R1740 VSS.n168 VSS.t319 18.0025
R1741 VSS.t83 VSS.n165 18.0025
R1742 VSS.n131 VSS.t200 18.0017
R1743 VSS.n133 VSS.t247 18.0017
R1744 VSS.n135 VSS.t335 18.0017
R1745 VSS.n137 VSS.t124 18.0017
R1746 VSS.n139 VSS.t597 18.0017
R1747 VSS.t201 VSS.n124 18.0017
R1748 VSS.t103 VSS.n121 18.0017
R1749 VSS.n143 VSS.t604 18.0017
R1750 VSS.n144 VSS.t229 18.0017
R1751 VSS.t96 VSS.n145 18.0017
R1752 VSS.n147 VSS.t350 18.0017
R1753 VSS.t228 VSS.n115 18.0017
R1754 VSS.t109 VSS.n151 18.0017
R1755 VSS.t271 VSS.n113 18.0017
R1756 VSS.n153 VSS.t273 18.0017
R1757 VSS.n155 VSS.t169 18.0017
R1758 VSS.t317 VSS.n106 18.0017
R1759 VSS.t76 VSS.n105 18.0017
R1760 VSS.n157 VSS.t477 18.0017
R1761 VSS.t405 VSS.n158 18.0017
R1762 VSS.t470 VSS.n101 18.0017
R1763 VSS.t328 VSS.n100 18.0017
R1764 VSS.n159 VSS.t151 18.0017
R1765 VSS.t237 VSS.n848 17.4722
R1766 VSS.n96 VSS.n525 17.0005
R1767 VSS.n96 VSS.n840 17.0005
R1768 VSS.n96 VSS.n841 17.0005
R1769 VSS.n96 VSS.n843 17.0005
R1770 VSS.n96 VSS.n845 17.0005
R1771 VSS.n96 VSS.n847 17.0005
R1772 VSS.n96 VSS.n523 17.0005
R1773 VSS.n96 VSS.t391 17.0005
R1774 VSS.n849 VSS.n96 17.0005
R1775 VSS.n96 VSS.n160 17.0005
R1776 VSS.n302 VSS.n300 17.0005
R1777 VSS.n854 VSS.n301 17.0005
R1778 VSS.n857 VSS.n856 17.0005
R1779 VSS.n858 VSS.n857 17.0005
R1780 VSS.n288 VSS.n286 17.0005
R1781 VSS.n863 VSS.n287 17.0005
R1782 VSS.n866 VSS.n865 17.0005
R1783 VSS.n867 VSS.n866 17.0005
R1784 VSS.n274 VSS.n272 17.0005
R1785 VSS.n872 VSS.n273 17.0005
R1786 VSS.n875 VSS.n874 17.0005
R1787 VSS.n876 VSS.n875 17.0005
R1788 VSS.n878 VSS.n269 17.0005
R1789 VSS.n878 VSS.n266 17.0005
R1790 VSS.n260 VSS.n250 17.0005
R1791 VSS.n881 VSS.n245 17.0005
R1792 VSS.n248 VSS.n244 17.0005
R1793 VSS.n246 VSS.n244 17.0005
R1794 VSS.n234 VSS.n232 17.0005
R1795 VSS.n887 VSS.n233 17.0005
R1796 VSS.n890 VSS.n889 17.0005
R1797 VSS.n891 VSS.n890 17.0005
R1798 VSS.n225 VSS.n219 17.0005
R1799 VSS.n896 VSS.n214 17.0005
R1800 VSS.n217 VSS.n213 17.0005
R1801 VSS.n215 VSS.n213 17.0005
R1802 VSS.n899 VSS.n192 17.0005
R1803 VSS.n899 VSS.n209 17.0005
R1804 VSS.n899 VSS.n208 17.0005
R1805 VSS.n899 VSS.n196 17.0005
R1806 VSS.n899 VSS.n207 17.0005
R1807 VSS.n899 VSS.n198 17.0005
R1808 VSS.n899 VSS.n205 17.0005
R1809 VSS.n899 VSS.n200 17.0005
R1810 VSS.n96 VSS.n348 17.0005
R1811 VSS.n96 VSS.n350 17.0005
R1812 VSS.t476 VSS.n664 17.0005
R1813 VSS.t476 VSS.n68 13.5064
R1814 VSS.n663 VSS.t197 17.0005
R1815 VSS.n661 VSS.t197 17.0005
R1816 VSS.n658 VSS.t197 17.0005
R1817 VSS.n655 VSS.n71 17.0005
R1818 VSS.n651 VSS.n71 17.0005
R1819 VSS.n73 VSS.n71 13.5064
R1820 VSS.n649 VSS.t199 17.0005
R1821 VSS.n647 VSS.t199 17.0005
R1822 VSS.n644 VSS.t199 17.0005
R1823 VSS.n643 VSS.n642 17.0005
R1824 VSS.n642 VSS.n640 17.0005
R1825 VSS.t168 VSS.n818 17.0005
R1826 VSS.t168 VSS.n581 17.0005
R1827 VSS.t168 VSS.n582 17.0005
R1828 VSS.t168 VSS.n675 17.0005
R1829 VSS.t168 VSS.n583 17.0005
R1830 VSS.t168 VSS.n674 17.0005
R1831 VSS.n606 VSS.n605 17.0005
R1832 VSS.n819 VSS.t168 17.0005
R1833 VSS.t168 VSS.n591 17.0005
R1834 VSS.t168 VSS.n670 17.0005
R1835 VSS.n7 VSS.n549 17.0005
R1836 VSS.n7 VSS.n553 17.0005
R1837 VSS.n7 VSS.n556 17.0005
R1838 VSS.n7 VSS.n571 17.0005
R1839 VSS.n7 VSS.n569 17.0005
R1840 VSS.n7 VSS.n2 17.0005
R1841 VSS.n44 VSS.n28 1.51099
R1842 VSS.n714 VSS.n28 17.0005
R1843 VSS.n712 VSS.n28 17.0005
R1844 VSS.n711 VSS.n28 17.0005
R1845 VSS.n719 VSS.n28 17.0005
R1846 VSS.n730 VSS.n28 17.0005
R1847 VSS.n732 VSS.n28 17.0005
R1848 VSS.n734 VSS.n28 17.0005
R1849 VSS.n735 VSS.n28 17.0005
R1850 VSS.n737 VSS.n28 17.0005
R1851 VSS.n739 VSS.n28 17.0005
R1852 VSS.n741 VSS.n28 17.0005
R1853 VSS.n742 VSS.n28 17.0005
R1854 VSS.n747 VSS.n28 17.0005
R1855 VSS.n749 VSS.n28 17.0005
R1856 VSS.n751 VSS.n28 17.0005
R1857 VSS.n754 VSS.n28 17.0005
R1858 VSS.n753 VSS.n28 17.0005
R1859 VSS.n708 VSS.n28 17.0005
R1860 VSS.n706 VSS.n28 17.0005
R1861 VSS.n704 VSS.n28 17.0005
R1862 VSS.n703 VSS.n28 17.0005
R1863 VSS.n701 VSS.n28 17.0005
R1864 VSS.n699 VSS.n28 17.0005
R1865 VSS.n697 VSS.n28 17.0005
R1866 VSS.n695 VSS.n28 17.0005
R1867 VSS.n755 VSS.n28 17.0005
R1868 VSS.n757 VSS.n28 17.0005
R1869 VSS.n759 VSS.n28 17.0005
R1870 VSS.n761 VSS.n28 17.0005
R1871 VSS.n762 VSS.n28 17.0005
R1872 VSS.n764 VSS.n28 17.0005
R1873 VSS.n766 VSS.n28 17.0005
R1874 VSS.n768 VSS.n28 17.0005
R1875 VSS.n771 VSS.n28 17.0005
R1876 VSS.n770 VSS.n28 17.0005
R1877 VSS.n693 VSS.n28 17.0005
R1878 VSS.n691 VSS.n28 17.0005
R1879 VSS.n689 VSS.n28 17.0005
R1880 VSS.n688 VSS.n28 17.0005
R1881 VSS.n686 VSS.n28 17.0005
R1882 VSS.n9 VSS.n28 17.0005
R1883 VSS.n688 VSS.n13 17.0005
R1884 VSS.n689 VSS.n13 17.0005
R1885 VSS.n770 VSS.n13 17.0005
R1886 VSS.n762 VSS.n13 17.0005
R1887 VSS.n761 VSS.n13 17.0005
R1888 VSS.n755 VSS.n13 17.0005
R1889 VSS.n703 VSS.n13 17.0005
R1890 VSS.n704 VSS.n13 17.0005
R1891 VSS.n753 VSS.n13 17.0005
R1892 VSS.n808 VSS.n13 17.0005
R1893 VSS.n742 VSS.n13 17.0005
R1894 VSS.n741 VSS.n13 17.0005
R1895 VSS.n735 VSS.n13 17.0005
R1896 VSS.n734 VSS.n13 17.0005
R1897 VSS.n12 VSS.n9 17.0005
R1898 VSS.n12 VSS.n771 17.0005
R1899 VSS.n12 VSS.n695 17.0005
R1900 VSS.n12 VSS.n754 17.0005
R1901 VSS.n12 VSS.n746 17.0005
R1902 VSS.n12 VSS.n711 17.0005
R1903 VSS.n12 VSS.n10 17.0005
R1904 VSS.n727 VSS.n30 17.0005
R1905 VSS.n30 VSS.n31 4.19244
R1906 VSS.n712 VSS.n13 17.0005
R1907 VSS.n812 VSS.n13 17.0005
R1908 VSS.n541 VSS.n28 17.0005
R1909 VSS.t136 VSS.n761 16.4539
R1910 VSS.n197 VSS.t587 16.3876
R1911 VSS.n67 VSS.n527 16.2018
R1912 VSS.n735 VSS.t558 14.2601
R1913 VSS.t514 VSS.n629 13.9907
R1914 VSS.n846 VSS.t434 13.7246
R1915 VSS.t353 VSS.t209 13.4836
R1916 VSS.n686 VSS.n685 12.0761
R1917 VSS.n692 VSS.n691 12.0761
R1918 VSS.n771 VSS.n769 12.0761
R1919 VSS.n765 VSS.n764 12.0761
R1920 VSS.n759 VSS.n758 12.0761
R1921 VSS.n697 VSS.n696 12.0761
R1922 VSS.n700 VSS.n699 12.0761
R1923 VSS.n708 VSS.n707 12.0761
R1924 VSS.n752 VSS.n751 12.0761
R1925 VSS.n748 VSS.n747 12.0761
R1926 VSS.n738 VSS.n737 12.0761
R1927 VSS.n731 VSS.n730 12.0761
R1928 VSS.n687 VSS.n686 12.0761
R1929 VSS.n690 VSS.n689 12.0761
R1930 VSS.n694 VSS.n693 12.0761
R1931 VSS.n768 VSS.n767 12.0761
R1932 VSS.n764 VSS.n763 12.0761
R1933 VSS.n761 VSS.n760 12.0761
R1934 VSS.n757 VSS.n756 12.0761
R1935 VSS.n698 VSS.n697 12.0761
R1936 VSS.n702 VSS.n701 12.0761
R1937 VSS.n705 VSS.n704 12.0761
R1938 VSS.n709 VSS.n708 12.0761
R1939 VSS.n751 VSS.n750 12.0761
R1940 VSS.n747 VSS.n743 12.0761
R1941 VSS.n741 VSS.n740 12.0761
R1942 VSS.n737 VSS.n736 12.0761
R1943 VSS.n734 VSS.n733 12.0761
R1944 VSS.n730 VSS.n720 12.0761
R1945 VSS.n715 VSS.n712 12.0761
R1946 VSS.n718 VSS.n711 12.0761
R1947 VSS.n713 VSS.n10 12.0761
R1948 VSS.n685 VSS.n9 12.0761
R1949 VSS.n688 VSS.n687 12.0761
R1950 VSS.n691 VSS.n690 12.0761
R1951 VSS.n693 VSS.n692 12.0761
R1952 VSS.n770 VSS.n694 12.0761
R1953 VSS.n769 VSS.n768 12.0761
R1954 VSS.n767 VSS.n766 12.0761
R1955 VSS.n766 VSS.n765 12.0761
R1956 VSS.n763 VSS.n762 12.0761
R1957 VSS.n760 VSS.n759 12.0761
R1958 VSS.n758 VSS.n757 12.0761
R1959 VSS.n756 VSS.n755 12.0761
R1960 VSS.n696 VSS.n695 12.0761
R1961 VSS.n699 VSS.n698 12.0761
R1962 VSS.n701 VSS.n700 12.0761
R1963 VSS.n703 VSS.n702 12.0761
R1964 VSS.n706 VSS.n705 12.0761
R1965 VSS.n707 VSS.n706 12.0761
R1966 VSS.n753 VSS.n709 12.0761
R1967 VSS.n754 VSS.n752 12.0761
R1968 VSS.n750 VSS.n749 12.0761
R1969 VSS.n749 VSS.n748 12.0761
R1970 VSS.n743 VSS.n742 12.0761
R1971 VSS.n740 VSS.n739 12.0761
R1972 VSS.n739 VSS.n738 12.0761
R1973 VSS.n736 VSS.n735 12.0761
R1974 VSS.n733 VSS.n732 12.0761
R1975 VSS.n732 VSS.n731 12.0761
R1976 VSS.n720 VSS.n719 12.0761
R1977 VSS.n719 VSS.n718 12.0761
R1978 VSS.n715 VSS.n714 12.0761
R1979 VSS.n714 VSS.n713 12.0761
R1980 VSS.t499 VSS.n636 10.7787
R1981 VSS.n632 VSS.t510 10.7767
R1982 VSS.n787 VSS.n540 9.81803
R1983 VSS.n831 VSS.n540 9.39094
R1984 VSS.n829 VSS.n828 9.38916
R1985 VSS.n558 VSS.t88 9.08698
R1986 VSS.t88 VSS.n557 9.0445
R1987 VSS.n822 VSS.n821 9.0005
R1988 VSS.n822 VSS.n544 9.0005
R1989 VSS.n548 VSS.n543 9.0005
R1990 VSS.n677 VSS.n543 9.0005
R1991 VSS.n629 VSS.n628 8.92967
R1992 VSS.t63 VSS.n852 8.501
R1993 VSS.n853 VSS.t61 8.501
R1994 VSS.t59 VSS.n299 8.501
R1995 VSS.t56 VSS.n291 8.501
R1996 VSS.t52 VSS.n861 8.501
R1997 VSS.n862 VSS.t50 8.501
R1998 VSS.t48 VSS.n285 8.501
R1999 VSS.t45 VSS.n277 8.501
R2000 VSS.t41 VSS.n870 8.501
R2001 VSS.n871 VSS.t39 8.501
R2002 VSS.t37 VSS.n271 8.501
R2003 VSS.t34 VSS.n254 8.501
R2004 VSS.t30 VSS.n879 8.501
R2005 VSS.n880 VSS.t28 8.501
R2006 VSS.t26 VSS.n882 8.501
R2007 VSS.n883 VSS.t23 8.501
R2008 VSS.t19 VSS.n885 8.501
R2009 VSS.n886 VSS.t17 8.501
R2010 VSS.t15 VSS.n231 8.501
R2011 VSS.t12 VSS.n222 8.501
R2012 VSS.t8 VSS.n894 8.501
R2013 VSS.n895 VSS.t6 8.501
R2014 VSS.t4 VSS.n897 8.501
R2015 VSS.n898 VSS.t1 8.501
R2016 VSS.n434 VSS.n94 88.4708
R2017 VSS.n781 VSS.n46 1.88989
R2018 VSS.n781 VSS.n53 2.4296
R2019 VSS.n781 VSS.n56 1.70064
R2020 VSS.n56 VSS.n55 0.00169968
R2021 VSS.n55 VSS.n57 0.00166651
R2022 VSS.n57 VSS.n59 0.00158329
R2023 VSS.n781 VSS.n62 2.12578
R2024 VSS.n62 VSS.n61 0.00166651
R2025 VSS.n61 VSS.n64 0.00158329
R2026 VSS.n29 VSS.n28 1.68931
R2027 VSS.n836 VSS.n25 3.40102
R2028 VSS.n836 VSS.n23 2.42956
R2029 VSS.n836 VSS.n38 2.42956
R2030 VSS.n836 VSS.n20 3.40102
R2031 VSS.n836 VSS.n42 2.83417
R2032 VSS.n42 VSS.n41 0.00166658
R2033 VSS.n41 VSS.n43 0.00149997
R2034 VSS.n836 VSS.n16 3.40102
R2035 VSS.n657 VSS.n70 406.622
R2036 VSS.n75 VSS.n74 406.622
R2037 VSS.n77 VSS.n75 0.00235708
R2038 VSS.n628 VSS.n79 2.12594
R2039 VSS.n78 VSS.n80 0.00149997
R2040 VSS.n628 VSS.n81 3.40102
R2041 VSS.n84 VSS.n83 0.00216499
R2042 VSS.n83 VSS.n85 0.00173273
R2043 VSS.n85 VSS.n86 0.00172462
R2044 VSS.n86 VSS.n87 0.00170812
R2045 VSS.n87 VSS.n88 0.00166658
R2046 VSS.n88 VSS.n89 0.00149997
R2047 VSS.n628 VSS.n90 2.4296
R2048 VSS.n820 VSS.n6 5.41263
R2049 VSS.n817 VSS.n32 2.42956
R2050 VSS.n817 VSS.n34 2.42956
R2051 VSS.n817 VSS.n44 6.23647
R2052 VSS.t90 VSS.n813 8.501
R2053 VSS.n15 VSS.n14 0.00199975
R2054 VSS.n96 VSS.n522 8.5005
R2055 VSS.n96 VSS.n517 8.5005
R2056 VSS.n96 VSS.n353 8.5005
R2057 VSS.n96 VSS.n515 8.5005
R2058 VSS.n96 VSS.n514 8.5005
R2059 VSS.n96 VSS.n354 8.5005
R2060 VSS.n96 VSS.n513 8.5005
R2061 VSS.n96 VSS.n356 8.5005
R2062 VSS.n96 VSS.n512 8.5005
R2063 VSS.n96 VSS.n357 8.5005
R2064 VSS.n96 VSS.n511 8.5005
R2065 VSS.n96 VSS.n358 8.5005
R2066 VSS.n96 VSS.n510 8.5005
R2067 VSS.n96 VSS.n509 8.5005
R2068 VSS.n96 VSS.n359 8.5005
R2069 VSS.n96 VSS.n508 8.5005
R2070 VSS.n96 VSS.n361 8.5005
R2071 VSS.n96 VSS.n507 8.5005
R2072 VSS.n96 VSS.n362 8.5005
R2073 VSS.n96 VSS.n506 8.5005
R2074 VSS.n96 VSS.n363 8.5005
R2075 VSS.n96 VSS.n505 8.5005
R2076 VSS.n96 VSS.n504 8.5005
R2077 VSS.n96 VSS.n364 8.5005
R2078 VSS.n96 VSS.n503 8.5005
R2079 VSS.n96 VSS.n366 8.5005
R2080 VSS.n96 VSS.n502 8.5005
R2081 VSS.n96 VSS.n367 8.5005
R2082 VSS.n96 VSS.n501 8.5005
R2083 VSS.n96 VSS.n368 8.5005
R2084 VSS.n96 VSS.n500 8.5005
R2085 VSS.n96 VSS.n499 8.5005
R2086 VSS.n96 VSS.n369 8.5005
R2087 VSS.n96 VSS.n498 8.5005
R2088 VSS.n96 VSS.n371 8.5005
R2089 VSS.n96 VSS.n497 8.5005
R2090 VSS.n96 VSS.n372 8.5005
R2091 VSS.n96 VSS.n496 8.5005
R2092 VSS.n96 VSS.n373 8.5005
R2093 VSS.n96 VSS.n495 8.5005
R2094 VSS.n96 VSS.n494 8.5005
R2095 VSS.n96 VSS.n374 8.5005
R2096 VSS.n96 VSS.n493 8.5005
R2097 VSS.n96 VSS.n376 8.5005
R2098 VSS.n96 VSS.n492 8.5005
R2099 VSS.n96 VSS.n377 8.5005
R2100 VSS.n96 VSS.n491 8.5005
R2101 VSS.n96 VSS.n378 8.5005
R2102 VSS.n96 VSS.n490 8.5005
R2103 VSS.n96 VSS.n489 8.5005
R2104 VSS.n96 VSS.n379 8.5005
R2105 VSS.n96 VSS.n488 8.5005
R2106 VSS.n96 VSS.n381 8.5005
R2107 VSS.n96 VSS.n487 8.5005
R2108 VSS.n96 VSS.n382 8.5005
R2109 VSS.n96 VSS.n486 8.5005
R2110 VSS.n96 VSS.n383 8.5005
R2111 VSS.n96 VSS.n485 8.5005
R2112 VSS.n96 VSS.n484 8.5005
R2113 VSS.n96 VSS.n384 8.5005
R2114 VSS.n96 VSS.n483 8.5005
R2115 VSS.n96 VSS.n386 8.5005
R2116 VSS.n96 VSS.n482 8.5005
R2117 VSS.n96 VSS.n387 8.5005
R2118 VSS.n96 VSS.n481 8.5005
R2119 VSS.n96 VSS.n388 8.5005
R2120 VSS.n96 VSS.n480 8.5005
R2121 VSS.n96 VSS.n479 8.5005
R2122 VSS.n96 VSS.n389 8.5005
R2123 VSS.n96 VSS.n478 8.5005
R2124 VSS.n96 VSS.n391 8.5005
R2125 VSS.n96 VSS.n477 8.5005
R2126 VSS.n96 VSS.n392 8.5005
R2127 VSS.n96 VSS.n476 8.5005
R2128 VSS.n96 VSS.n393 8.5005
R2129 VSS.n96 VSS.n475 8.5005
R2130 VSS.n96 VSS.n474 8.5005
R2131 VSS.n96 VSS.n394 8.5005
R2132 VSS.n96 VSS.n473 8.5005
R2133 VSS.n96 VSS.n396 8.5005
R2134 VSS.n96 VSS.n472 8.5005
R2135 VSS.n96 VSS.n397 8.5005
R2136 VSS.n96 VSS.n471 8.5005
R2137 VSS.n96 VSS.n398 8.5005
R2138 VSS.n96 VSS.n470 8.5005
R2139 VSS.n96 VSS.n469 8.5005
R2140 VSS.n96 VSS.n399 8.5005
R2141 VSS.n96 VSS.n468 8.5005
R2142 VSS.n96 VSS.n401 8.5005
R2143 VSS.n96 VSS.n467 8.5005
R2144 VSS.n96 VSS.n402 8.5005
R2145 VSS.n96 VSS.n466 8.5005
R2146 VSS.n96 VSS.n403 8.5005
R2147 VSS.n96 VSS.n465 8.5005
R2148 VSS.n96 VSS.n464 8.5005
R2149 VSS.n96 VSS.n404 8.5005
R2150 VSS.n96 VSS.n463 8.5005
R2151 VSS.n96 VSS.n406 8.5005
R2152 VSS.n96 VSS.n462 8.5005
R2153 VSS.n96 VSS.n407 8.5005
R2154 VSS.n96 VSS.n461 8.5005
R2155 VSS.n96 VSS.n408 8.5005
R2156 VSS.n96 VSS.n460 8.5005
R2157 VSS.n96 VSS.n459 8.5005
R2158 VSS.n96 VSS.n409 8.5005
R2159 VSS.n96 VSS.n458 8.5005
R2160 VSS.n96 VSS.n411 8.5005
R2161 VSS.n96 VSS.n457 8.5005
R2162 VSS.n96 VSS.n412 8.5005
R2163 VSS.n96 VSS.n456 8.5005
R2164 VSS.n96 VSS.n413 8.5005
R2165 VSS.n96 VSS.n455 8.5005
R2166 VSS.n96 VSS.n454 8.5005
R2167 VSS.n96 VSS.n414 8.5005
R2168 VSS.n96 VSS.n453 8.5005
R2169 VSS.n96 VSS.n416 8.5005
R2170 VSS.n96 VSS.n452 8.5005
R2171 VSS.n96 VSS.n417 8.5005
R2172 VSS.n96 VSS.n451 8.5005
R2173 VSS.n96 VSS.n418 8.5005
R2174 VSS.n96 VSS.n450 8.5005
R2175 VSS.n96 VSS.n449 8.5005
R2176 VSS.n96 VSS.n419 8.5005
R2177 VSS.n96 VSS.n448 8.5005
R2178 VSS.n96 VSS.n421 8.5005
R2179 VSS.n96 VSS.n447 8.5005
R2180 VSS.n96 VSS.n422 8.5005
R2181 VSS.n96 VSS.n446 8.5005
R2182 VSS.n96 VSS.n423 8.5005
R2183 VSS.n96 VSS.n445 8.5005
R2184 VSS.n96 VSS.n444 8.5005
R2185 VSS.n96 VSS.n424 8.5005
R2186 VSS.n96 VSS.n443 8.5005
R2187 VSS.n96 VSS.n426 8.5005
R2188 VSS.n96 VSS.n442 8.5005
R2189 VSS.n96 VSS.n427 8.5005
R2190 VSS.n96 VSS.n441 8.5005
R2191 VSS.n96 VSS.n428 8.5005
R2192 VSS.n96 VSS.n440 8.5005
R2193 VSS.n96 VSS.n439 8.5005
R2194 VSS.n96 VSS.n429 8.5005
R2195 VSS.n96 VSS.n438 8.5005
R2196 VSS.n96 VSS.n431 8.5005
R2197 VSS.n96 VSS.n437 8.5005
R2198 VSS.n96 VSS.n432 8.5005
R2199 VSS.n96 VSS.n435 8.5005
R2200 VSS.n7 VSS.n572 8.5005
R2201 VSS.n7 VSS.n561 8.5005
R2202 VSS.n722 VSS.n12 8.50038
R2203 VSS.n7 VSS.n545 8.48883
R2204 VSS.n546 VSS.n7 8.48883
R2205 VSS.n814 VSS.n13 8.48385
R2206 VSS.n96 VSS.n436 8.48012
R2207 VSS.t532 VSS.n80 8.47784
R2208 VSS.n617 VSS.n82 8.47784
R2209 VSS.n619 VSS.n83 8.47784
R2210 VSS.n620 VSS.n85 8.47784
R2211 VSS.n621 VSS.n86 8.47784
R2212 VSS.n622 VSS.n87 8.47784
R2213 VSS.n623 VSS.n88 8.47784
R2214 VSS.n624 VSS.n89 8.47784
R2215 VSS.n627 VSS.n91 8.47784
R2216 VSS.n600 VSS.n93 8.47784
R2217 VSS.n96 VSS.n352 8.47732
R2218 VSS.n96 VSS.t381 8.47732
R2219 VSS.n96 VSS.n314 8.47732
R2220 VSS.n96 VSS.n315 8.47732
R2221 VSS.n96 VSS.n349 8.47732
R2222 VSS.n784 VSS.n28 8.47732
R2223 VSS.n537 VSS.n28 8.47732
R2224 VSS.t354 VSS.n47 8.47732
R2225 VSS.n788 VSS.n49 8.47732
R2226 VSS.n789 VSS.n48 8.47732
R2227 VSS.n791 VSS.n52 8.47732
R2228 VSS.n792 VSS.n51 8.47732
R2229 VSS.t276 VSS.n793 8.47732
R2230 VSS.n794 VSS.n55 8.47732
R2231 VSS.n795 VSS.n57 8.47732
R2232 VSS.n773 VSS.n59 8.47732
R2233 VSS.t277 VSS.n58 8.47732
R2234 VSS.n797 VSS.n772 8.47732
R2235 VSS.n798 VSS.n61 8.47732
R2236 VSS.n799 VSS.n64 8.47732
R2237 VSS.n800 VSS.n63 8.47732
R2238 VSS.n801 VSS.n65 8.47732
R2239 VSS.t275 VSS.n36 8.47732
R2240 VSS.n27 VSS.n26 3.32615
R2241 VSS.t278 VSS.n24 8.47732
R2242 VSS.n832 VSS.n37 8.47732
R2243 VSS.t280 VSS.n39 8.47732
R2244 VSS.t281 VSS.n40 8.47732
R2245 VSS.n833 VSS.n22 0.333813
R2246 VSS.n22 VSS.n21 4.19225
R2247 VSS.t283 VSS.n41 8.47732
R2248 VSS.n834 VSS.n43 8.47732
R2249 VSS.n19 VSS.n18 3.32623
R2250 VSS.n529 VSS.n528 8.47732
R2251 VSS.n614 VSS.n78 8.47732
R2252 VSS.n608 VSS.n78 8.47732
R2253 VSS.n7 VSS.n550 8.47732
R2254 VSS.n7 VSS.n552 8.47732
R2255 VSS.n7 VSS.n554 8.47732
R2256 VSS.n7 VSS.n560 8.47732
R2257 VSS.n7 VSS.n573 8.47732
R2258 VSS.n7 VSS.n562 8.47732
R2259 VSS.n683 VSS.n13 8.47732
R2260 VSS.n12 VSS.n729 8.47732
R2261 VSS.n726 VSS.n33 8.47732
R2262 VSS.n723 VSS.n35 8.47732
R2263 VSS.n666 VSS.n69 8.47111
R2264 VSS.t87 VSS.n72 8.47111
R2265 VSS.n641 VSS.n76 8.47111
R2266 VSS.t95 VSS.n77 8.47111
R2267 VSS.n12 VSS.n716 8.46924
R2268 VSS.t89 VSS.n29 3.24682
R2269 VSS.n836 VSS.n29 1.68649
R2270 VSS.n827 VSS.n826 6.85916
R2271 VSS.n665 VSS.n527 5.66985
R2272 VSS.n28 VSS.n46 0.00261098
R2273 VSS.n53 VSS.n50 0.0024999
R2274 VSS.n781 VSS.n779 5.66778
R2275 VSS.n781 VSS.n776 5.66778
R2276 VSS.n781 VSS.n778 5.66778
R2277 VSS.n25 VSS.n534 0.00229996
R2278 VSS.n23 VSS.n26 0.00349991
R2279 VSS.n38 VSS.n533 0.00249991
R2280 VSS.n20 VSS.n531 0.00229996
R2281 VSS.n16 VSS.n530 0.00229996
R2282 VSS.n836 VSS.n17 5.66778
R2283 VSS.n628 VSS.n599 5.66778
R2284 VSS.n81 VSS.n612 0.00229996
R2285 VSS.n628 VSS.n84 1.13339
R2286 VSS.n628 VSS.n598 5.66778
R2287 VSS.n90 VSS.n609 0.0024999
R2288 VSS.n817 VSS.n15 2.42928
R2289 VSS.n32 VSS.n724 0.00249991
R2290 VSS.n70 VSS.n72 0.00137142
R2291 VSS.n725 VSS.n724 5.64509
R2292 VSS.n96 VSS.n313 5.63915
R2293 VSS.n615 VSS.n613 5.62674
R2294 VSS.n616 VSS.n612 5.62674
R2295 VSS.n618 VSS.n611 5.62674
R2296 VSS.n625 VSS.n610 5.62674
R2297 VSS.n626 VSS.n609 5.62674
R2298 VSS.n92 VSS.t515 5.62674
R2299 VSS.n782 VSS.n28 5.62581
R2300 VSS.n536 VSS.n28 5.62581
R2301 VSS.n790 VSS.n50 5.62581
R2302 VSS.n774 VSS.n54 5.62581
R2303 VSS.n775 VSS.n777 5.62581
R2304 VSS.n796 VSS.n60 5.62581
R2305 VSS.n535 VSS.n534 5.62581
R2306 VSS.n532 VSS.n533 5.62581
R2307 VSS.n833 VSS.n531 5.62581
R2308 VSS.n835 VSS.n530 5.62581
R2309 VSS.n7 VSS.n559 5.62581
R2310 VSS.n14 VSS.n816 5.62581
R2311 VSS.n689 VSS.t134 5.48496
R2312 VSS.n668 VSS.n667 5.13648
R2313 VSS.n588 VSS.t93 4.98596
R2314 VSS.n823 VSS.n822 4.63796
R2315 VSS.n657 VSS.t110 4.49152
R2316 VSS.n74 VSS.t94 4.49152
R2317 VSS.t98 VSS.n668 4.4712
R2318 VSS.n79 VSS.n92 0.00331236
R2319 VSS.n781 VSS.n780 4.251
R2320 VSS.n836 VSS.n45 4.251
R2321 VSS.n12 VSS.n717 4.19244
R2322 VSS.n7 VSS.n555 4.19238
R2323 VSS.n857 VSS.t57 4.19225
R2324 VSS.n866 VSS.t46 4.19225
R2325 VSS.n875 VSS.t35 4.19225
R2326 VSS.t24 VSS.n244 4.19225
R2327 VSS.n890 VSS.t13 4.19225
R2328 VSS.t2 VSS.n213 4.19225
R2329 VSS.n679 VSS.n13 4.19225
R2330 VSS.t203 VSS.n606 4.177
R2331 VSS.n525 VSS.n187 3.84219
R2332 VSS.n900 VSS.t224 3.84041
R2333 VSS.n517 VSS.t533 3.34498
R2334 VSS.n514 VSS.t495 3.34498
R2335 VSS.n511 VSS.t498 3.34498
R2336 VSS.n509 VSS.t485 3.34498
R2337 VSS.n506 VSS.t496 3.34498
R2338 VSS.n504 VSS.t490 3.34498
R2339 VSS.n501 VSS.t497 3.34498
R2340 VSS.n499 VSS.t535 3.34498
R2341 VSS.n496 VSS.t534 3.34498
R2342 VSS.n494 VSS.t536 3.34498
R2343 VSS.n491 VSS.t484 3.34498
R2344 VSS.n489 VSS.t539 3.34498
R2345 VSS.n486 VSS.t538 3.34498
R2346 VSS.n484 VSS.t537 3.34498
R2347 VSS.n481 VSS.t493 3.34498
R2348 VSS.n479 VSS.t489 3.34498
R2349 VSS.n476 VSS.t488 3.34498
R2350 VSS.n474 VSS.t541 3.34498
R2351 VSS.n471 VSS.t540 3.34498
R2352 VSS.n469 VSS.t483 3.34498
R2353 VSS.n466 VSS.t492 3.34498
R2354 VSS.n464 VSS.t542 3.34498
R2355 VSS.n461 VSS.t491 3.34498
R2356 VSS.n459 VSS.t543 3.34498
R2357 VSS.n456 VSS.t486 3.34498
R2358 VSS.n454 VSS.t544 3.34498
R2359 VSS.n451 VSS.t487 3.34498
R2360 VSS.n449 VSS.t547 3.34498
R2361 VSS.n446 VSS.t546 3.34498
R2362 VSS.n444 VSS.t545 3.34498
R2363 VSS.n441 VSS.t548 3.34498
R2364 VSS.n439 VSS.t549 3.34498
R2365 VSS.n7 VSS.n547 3.32697
R2366 VSS.n830 VSS.n28 3.3265
R2367 VSS.n7 VSS.n551 3.32615
R2368 VSS.t595 VSS.t199 3.30696
R2369 VSS.n850 VSS.t214 3.28366
R2370 VSS.n823 VSS.n542 2.7456
R2371 VSS.n96 VSS.n351 2.74463
R2372 VSS.n96 VSS.n433 2.7443
R2373 VSS.n96 VSS.t217 2.74402
R2374 VSS.n96 VSS.n516 2.74397
R2375 VSS.n96 VSS.n347 2.74397
R2376 VSS.n7 VSS.n567 2.74397
R2377 VSS.n685 VSS.n13 2.46343
R2378 VSS.n692 VSS.n13 2.46343
R2379 VSS.n769 VSS.n13 2.46343
R2380 VSS.n765 VSS.n13 2.46343
R2381 VSS.n758 VSS.n13 2.46343
R2382 VSS.n696 VSS.n13 2.46343
R2383 VSS.n700 VSS.n13 2.46343
R2384 VSS.n707 VSS.n13 2.46343
R2385 VSS.n752 VSS.n13 2.46343
R2386 VSS.n748 VSS.n13 2.46343
R2387 VSS.n738 VSS.n13 2.46343
R2388 VSS.n731 VSS.n13 2.46343
R2389 VSS.n12 VSS.n687 2.46343
R2390 VSS.n12 VSS.n690 2.46343
R2391 VSS.n12 VSS.n694 2.46343
R2392 VSS.n12 VSS.n767 2.46343
R2393 VSS.n12 VSS.n763 2.46343
R2394 VSS.n12 VSS.n760 2.46343
R2395 VSS.n12 VSS.n756 2.46343
R2396 VSS.n12 VSS.n698 2.46343
R2397 VSS.n12 VSS.n702 2.46343
R2398 VSS.n12 VSS.n705 2.46343
R2399 VSS.n12 VSS.n709 2.46343
R2400 VSS.n12 VSS.n750 2.46343
R2401 VSS.n12 VSS.n743 2.46343
R2402 VSS.n12 VSS.n740 2.46343
R2403 VSS.n12 VSS.n736 2.46343
R2404 VSS.n12 VSS.n733 2.46343
R2405 VSS.n12 VSS.n720 2.46343
R2406 VSS.n12 VSS.n715 2.46343
R2407 VSS.n718 VSS.n13 2.46343
R2408 VSS.n713 VSS.n13 2.46343
R2409 VSS.n303 VSS.n302 2.34876
R2410 VSS.n289 VSS.n288 2.34876
R2411 VSS.n275 VSS.n274 2.34876
R2412 VSS.n251 VSS.n250 2.34876
R2413 VSS.n235 VSS.n234 2.34876
R2414 VSS.n220 VSS.n219 2.34876
R2415 VSS.n810 VSS.n13 2.32483
R2416 VSS.n12 VSS.n710 2.32483
R2417 VSS.n806 VSS.n13 2.00687
R2418 VSS.n12 VSS.n11 2.00687
R2419 VSS.t199 VSS.n592 1.97699
R2420 VSS.t168 VSS.n586 1.88189
R2421 VSS.n606 VSS.n597 1.88189
R2422 VSS.n824 VSS.n823 1.83435
R2423 VSS.t143 VSS.n665 1.80539
R2424 VSS.n786 VSS.n28 1.75689
R2425 VSS.n539 VSS.n28 1.75689
R2426 VSS.n7 VSS.n578 1.75507
R2427 VSS.n642 VSS.t450 1.72297
R2428 VSS.n678 VSS.n677 1.66925
R2429 VSS.n96 VSS.n524 1.63922
R2430 VSS.n96 VSS.n839 1.63922
R2431 VSS.n96 VSS.n844 1.63922
R2432 VSS.n96 VSS.n846 1.63922
R2433 VSS.n96 VSS.n848 1.63922
R2434 VSS.n96 VSS.n355 1.55386
R2435 VSS.n96 VSS.n360 1.55386
R2436 VSS.n96 VSS.n365 1.55386
R2437 VSS.n96 VSS.n370 1.55386
R2438 VSS.n96 VSS.n375 1.55386
R2439 VSS.n96 VSS.n380 1.55386
R2440 VSS.n96 VSS.n385 1.55386
R2441 VSS.n96 VSS.n390 1.55386
R2442 VSS.n96 VSS.n395 1.55386
R2443 VSS.n96 VSS.n400 1.55386
R2444 VSS.n96 VSS.n405 1.55386
R2445 VSS.n96 VSS.n410 1.55386
R2446 VSS.n96 VSS.n415 1.55386
R2447 VSS.n96 VSS.n420 1.55386
R2448 VSS.n96 VSS.n425 1.55386
R2449 VSS.n96 VSS.n430 1.55386
R2450 VSS.n96 VSS.t269 1.55345
R2451 VSS.n96 VSS.t472 1.55345
R2452 VSS.n96 VSS.t69 1.55345
R2453 VSS.n96 VSS.t267 1.55345
R2454 VSS.n96 VSS.t75 1.55345
R2455 VSS.n96 VSS.t102 1.55345
R2456 VSS.n96 VSS.t80 1.55345
R2457 VSS.n96 VSS.t457 1.55345
R2458 VSS.n96 VSS.t301 1.55345
R2459 VSS.n96 VSS.t72 1.55345
R2460 VSS.n96 VSS.t161 1.55345
R2461 VSS.n96 VSS.t129 1.55345
R2462 VSS.n96 VSS.t322 1.55345
R2463 VSS.n96 VSS.t402 1.55345
R2464 VSS.n96 VSS.t133 1.55345
R2465 VSS.n96 VSS.n316 1.55338
R2466 VSS.n96 VSS.n317 1.55338
R2467 VSS.n96 VSS.n318 1.55338
R2468 VSS.n96 VSS.n319 1.55338
R2469 VSS.n96 VSS.n320 1.55338
R2470 VSS.n96 VSS.n321 1.55338
R2471 VSS.n96 VSS.n322 1.55338
R2472 VSS.n96 VSS.n323 1.55338
R2473 VSS.n96 VSS.n324 1.55338
R2474 VSS.n96 VSS.n325 1.55338
R2475 VSS.n96 VSS.n326 1.55338
R2476 VSS.n96 VSS.n327 1.55338
R2477 VSS.n96 VSS.n328 1.55338
R2478 VSS.n96 VSS.n329 1.55338
R2479 VSS.n96 VSS.n330 1.55338
R2480 VSS.n96 VSS.n331 1.55338
R2481 VSS.n96 VSS.n332 1.55338
R2482 VSS.n96 VSS.n333 1.55338
R2483 VSS.n96 VSS.n334 1.55338
R2484 VSS.n96 VSS.n335 1.55338
R2485 VSS.n96 VSS.n336 1.55338
R2486 VSS.n96 VSS.n337 1.55338
R2487 VSS.n96 VSS.n338 1.55338
R2488 VSS.n96 VSS.n339 1.55338
R2489 VSS.n96 VSS.n340 1.55338
R2490 VSS.n96 VSS.n341 1.55338
R2491 VSS.n96 VSS.n342 1.55338
R2492 VSS.n96 VSS.n343 1.55338
R2493 VSS.n96 VSS.n344 1.55338
R2494 VSS.n96 VSS.n345 1.55338
R2495 VSS.n96 VSS.n346 1.55338
R2496 VSS.n601 VSS.n78 1.55041
R2497 VSS.n721 VSS.t355 1.43372
R2498 VSS.t357 VSS.n681 1.43372
R2499 VSS.n684 VSS.t355 1.42949
R2500 VSS.n680 VSS.t357 1.42949
R2501 VSS.t559 VSS.t567 1.41892
R2502 VSS.t557 VSS.t566 1.41892
R2503 VSS.t564 VSS.t565 1.41892
R2504 VSS.t561 VSS.t562 1.41892
R2505 VSS.n899 VSS.n210 1.38589
R2506 VSS.n538 VSS.t352 1.37661
R2507 VSS.t352 VSS.n783 1.37661
R2508 VSS.n825 VSS.n824 1.30942
R2509 VSS.t515 VSS.t513 1.29565
R2510 VSS.t296 VSS.n252 1.28795
R2511 VSS.n829 VSS.n825 1.26857
R2512 VSS.t532 VSS.t530 1.26451
R2513 VSS.n604 VSS.n78 1.24506
R2514 VSS.t153 VSS.t589 1.23805
R2515 VSS.t595 VSS.n593 1.21874
R2516 VSS.t523 VSS.t525 1.18357
R2517 VSS.t505 VSS.t503 1.1832
R2518 VSS.t527 VSS.t525 1.17915
R2519 VSS.t507 VSS.t505 1.17908
R2520 VSS.t500 VSS.t501 1.17816
R2521 VSS.t517 VSS.t516 1.1778
R2522 VSS.t511 VSS.t509 1.17371
R2523 VSS.t519 VSS.t518 1.17364
R2524 VSS.t530 VSS.t519 1.16725
R2525 VSS.t513 VSS.t511 1.15299
R2526 VSS.n590 VSS.t203 1.12148
R2527 VSS.t507 VSS.t509 1.11346
R2528 VSS.t518 VSS.t527 1.11316
R2529 VSS.t523 VSS.t517 1.10881
R2530 VSS.t503 VSS.t500 1.10864
R2531 VSS.t168 VSS.n584 1.09664
R2532 VSS.n594 VSS.t197 1.08287
R2533 VSS.t30 VSS.n252 1.06717
R2534 VSS.n593 VSS.t87 1.0392
R2535 VSS.n189 VSS.t1 1.03359
R2536 VSS.n584 VSS.n585 1.02454
R2537 VSS.n526 VSS.t121 1.02108
R2538 VSS.n842 VSS.t208 1.00712
R2539 VSS.n189 VSS.t195 1.0064
R2540 VSS.n188 VSS.t224 0.971887
R2541 VSS.n804 VSS.n529 0.959044
R2542 VSS.n802 VSS.n801 0.959044
R2543 VSS.t63 VSS.n304 0.950816
R2544 VSS.n805 VSS.n804 0.908953
R2545 VSS.n803 VSS.n802 0.908953
R2546 VSS.n590 VSS.t98 0.884808
R2547 VSS.t34 VSS.n253 0.841394
R2548 VSS.n666 VSS.n594 0.839803
R2549 VSS.t166 VSS.n596 0.832423
R2550 VSS.t362 VSS.t365 0.806856
R2551 VSS.n570 VSS.t369 0.806855
R2552 VSS.t389 VSS.t375 0.806855
R2553 VSS.n568 VSS.t521 0.802775
R2554 VSS.t234 VSS.t188 0.802775
R2555 VSS.t190 VSS.t232 0.802775
R2556 VSS.t179 VSS.t311 0.802775
R2557 VSS.t313 VSS.t241 0.802775
R2558 VSS.t252 VSS.t148 0.802775
R2559 VSS.t146 VSS.t67 0.802775
R2560 VSS.t331 VSS.t411 0.802775
R2561 VSS.t85 VSS.t92 0.802775
R2562 VSS.t306 VSS.t343 0.802775
R2563 VSS.t345 VSS.t164 0.802775
R2564 VSS.t334 VSS.t397 0.802775
R2565 VSS.t349 VSS.t100 0.802775
R2566 VSS.t408 VSS.t205 0.802775
R2567 VSS.t399 VSS.t78 0.802775
R2568 VSS.t417 VSS.t494 0.802775
R2569 VSS.t150 VSS.t442 0.802775
R2570 VSS.t609 VSS.t117 0.802775
R2571 VSS.t347 VSS.t262 0.802775
R2572 VSS.t157 VSS.t107 0.802775
R2573 VSS.t105 VSS.t174 0.802775
R2574 VSS.t338 VSS.t139 0.802775
R2575 VSS.t141 VSS.t159 0.802775
R2576 VSS.t623 VSS.t82 0.802775
R2577 VSS.t192 VSS.t113 0.802775
R2578 VSS.t438 VSS.t186 0.802775
R2579 VSS.t115 VSS.t211 0.802775
R2580 VSS.t420 VSS.t243 0.802775
R2581 VSS.t395 VSS.t315 0.802775
R2582 VSS.t579 VSS.t119 0.802775
R2583 VSS.t444 VSS.t131 0.802775
R2584 VSS.t291 VSS.t308 0.802775
R2585 VSS.t254 VSS.t550 0.802775
R2586 VSS.t572 VSS.t384 0.802775
R2587 VSS.t56 VSS.n290 0.78864
R2588 VSS.t45 VSS.n276 0.78864
R2589 VSS.t23 VSS.n236 0.78864
R2590 VSS.t12 VSS.n221 0.78864
R2591 VSS.n594 VSS.t143 0.756052
R2592 VSS.t166 VSS.t450 0.745166
R2593 VSS.t168 VSS.n590 0.728098
R2594 VSS.t52 VSS.n290 0.724795
R2595 VSS.t41 VSS.n276 0.724795
R2596 VSS.t19 VSS.n236 0.724795
R2597 VSS.t8 VSS.n221 0.724795
R2598 VSS.t385 VSS.t387 0.723599
R2599 VSS.t383 VSS.n312 0.723599
R2600 VSS.n728 VSS.t559 0.722582
R2601 VSS.n744 VSS.t557 0.722582
R2602 VSS.n745 VSS.t564 0.722582
R2603 VSS.t562 VSS.n803 0.722582
R2604 VSS.n811 VSS.t567 0.72222
R2605 VSS.n809 VSS.t566 0.72222
R2606 VSS.n807 VSS.t565 0.72222
R2607 VSS.n805 VSS.t561 0.72222
R2608 VSS.n596 VSS.n607 0.711165
R2609 VSS.t98 VSS.n584 0.699997
R2610 VSS.n253 VSS.t296 0.699882
R2611 VSS.n603 VSS.n602 0.6955
R2612 VSS.n593 VSS.n71 0.662806
R2613 VSS.t95 VSS.t450 0.640524
R2614 VSS.n860 VSS.n290 0.62049
R2615 VSS.n869 VSS.n276 0.62049
R2616 VSS.n884 VSS.n236 0.62049
R2617 VSS.n893 VSS.n221 0.62049
R2618 VSS.n851 VSS.n310 0.613782
R2619 VSS.n860 VSS.n296 0.613782
R2620 VSS.n869 VSS.n282 0.613782
R2621 VSS.n878 VSS.n268 0.613782
R2622 VSS.n878 VSS.n263 0.613782
R2623 VSS.n884 VSS.n241 0.613782
R2624 VSS.n893 VSS.n228 0.613782
R2625 VSS.n899 VSS.n193 0.613782
R2626 VSS.n899 VSS.n195 0.613782
R2627 VSS.n899 VSS.n206 0.613782
R2628 VSS.n899 VSS.n201 0.613782
R2629 VSS.n899 VSS.n202 0.613782
R2630 VSS.n596 VSS.n78 0.599773
R2631 VSS.t374 VSS.n574 0.595317
R2632 VSS.t371 VSS.n575 0.595317
R2633 VSS.t368 VSS.n563 0.595317
R2634 VSS.t364 VSS.n564 0.595317
R2635 VSS.t380 VSS.n518 0.595317
R2636 VSS.t377 VSS.n519 0.595317
R2637 VSS.n641 VSS.n592 0.588545
R2638 VSS.n662 VSS.t197 0.572871
R2639 VSS.n648 VSS.t199 0.572871
R2640 VSS.n96 VSS.n94 0.00105218
R2641 VSS.n607 VSS.n604 0.56503
R2642 VSS.t168 VSS.n589 0.557126
R2643 VSS.n96 VSS.n97 0.556705
R2644 VSS.n878 VSS.n253 0.554008
R2645 VSS.t195 VSS.n210 0.539958
R2646 VSS.n579 VSS.n578 0.52186
R2647 VSS.n802 VSS.n12 0.51356
R2648 VSS.n804 VSS.n13 0.51356
R2649 VSS.t355 VSS.t357 0.492336
R2650 VSS.n656 VSS.n71 0.490843
R2651 VSS.n652 VSS.n71 0.490843
R2652 VSS.n650 VSS.n71 0.490843
R2653 VSS.n642 VSS.n639 0.490843
R2654 VSS.n659 VSS.t197 0.489061
R2655 VSS.n645 VSS.t199 0.489061
R2656 VSS.t188 VSS.n346 0.477689
R2657 VSS.t232 VSS.n345 0.477689
R2658 VSS.t311 VSS.n344 0.477689
R2659 VSS.t241 VSS.n343 0.477689
R2660 VSS.t148 VSS.n342 0.477689
R2661 VSS.t67 VSS.n341 0.477689
R2662 VSS.t411 VSS.n340 0.477689
R2663 VSS.t92 VSS.n339 0.477689
R2664 VSS.t343 VSS.n338 0.477689
R2665 VSS.t164 VSS.n337 0.477689
R2666 VSS.t397 VSS.n336 0.477689
R2667 VSS.t100 VSS.n335 0.477689
R2668 VSS.t205 VSS.n334 0.477689
R2669 VSS.t78 VSS.n333 0.477689
R2670 VSS.t494 VSS.n332 0.477689
R2671 VSS.t442 VSS.n331 0.477689
R2672 VSS.t117 VSS.n330 0.477689
R2673 VSS.t262 VSS.n329 0.477689
R2674 VSS.t107 VSS.n328 0.477689
R2675 VSS.t174 VSS.n327 0.477689
R2676 VSS.t139 VSS.n326 0.477689
R2677 VSS.t159 VSS.n325 0.477689
R2678 VSS.t82 VSS.n324 0.477689
R2679 VSS.t113 VSS.n323 0.477689
R2680 VSS.t186 VSS.n322 0.477689
R2681 VSS.t211 VSS.n321 0.477689
R2682 VSS.t243 VSS.n320 0.477689
R2683 VSS.t315 VSS.n319 0.477689
R2684 VSS.t119 VSS.n318 0.477689
R2685 VSS.t131 VSS.n317 0.477689
R2686 VSS.t308 VSS.n316 0.477689
R2687 VSS.n601 VSS.n542 0.47741
R2688 VSS.t168 VSS.n671 0.477286
R2689 VSS.t168 VSS.n672 0.472981
R2690 VSS.t133 VSS.t444 0.466542
R2691 VSS.t402 VSS.t395 0.466542
R2692 VSS.t322 VSS.t115 0.466542
R2693 VSS.t129 VSS.t192 0.466542
R2694 VSS.t161 VSS.t141 0.466542
R2695 VSS.t72 VSS.t105 0.466542
R2696 VSS.t301 VSS.t347 0.466542
R2697 VSS.t457 VSS.t150 0.466542
R2698 VSS.t80 VSS.t399 0.466542
R2699 VSS.t102 VSS.t349 0.466542
R2700 VSS.t75 VSS.t345 0.466542
R2701 VSS.t267 VSS.t85 0.466542
R2702 VSS.t69 VSS.t146 0.466542
R2703 VSS.t472 VSS.t313 0.466542
R2704 VSS.t269 VSS.t190 0.466542
R2705 VSS.n355 VSS.t234 0.466192
R2706 VSS.n360 VSS.t179 0.466192
R2707 VSS.n365 VSS.t252 0.466192
R2708 VSS.n370 VSS.t331 0.466192
R2709 VSS.n375 VSS.t306 0.466192
R2710 VSS.n380 VSS.t334 0.466192
R2711 VSS.n385 VSS.t408 0.466192
R2712 VSS.n390 VSS.t417 0.466192
R2713 VSS.n395 VSS.t609 0.466192
R2714 VSS.n400 VSS.t157 0.466192
R2715 VSS.n405 VSS.t338 0.466192
R2716 VSS.n410 VSS.t623 0.466192
R2717 VSS.n415 VSS.t438 0.466192
R2718 VSS.n420 VSS.t420 0.466192
R2719 VSS.n425 VSS.t579 0.466192
R2720 VSS.n430 VSS.t291 0.466192
R2721 VSS.n667 VSS.n592 0.465582
R2722 VSS.n607 VSS.t203 0.464894
R2723 VSS.n603 VSS.n601 0.460744
R2724 VSS.n604 VSS.n603 0.455207
R2725 VSS.t254 VSS.n430 0.451785
R2726 VSS.t444 VSS.n425 0.451785
R2727 VSS.t395 VSS.n420 0.451785
R2728 VSS.t115 VSS.n415 0.451785
R2729 VSS.t192 VSS.n410 0.451785
R2730 VSS.t141 VSS.n405 0.451785
R2731 VSS.t105 VSS.n400 0.451785
R2732 VSS.t347 VSS.n395 0.451785
R2733 VSS.t150 VSS.n390 0.451785
R2734 VSS.t399 VSS.n385 0.451785
R2735 VSS.t349 VSS.n380 0.451785
R2736 VSS.t345 VSS.n375 0.451785
R2737 VSS.t85 VSS.n370 0.451785
R2738 VSS.t146 VSS.n365 0.451785
R2739 VSS.t313 VSS.n360 0.451785
R2740 VSS.t190 VSS.n355 0.451785
R2741 VSS.t269 VSS.t179 0.451337
R2742 VSS.t472 VSS.t252 0.451337
R2743 VSS.t69 VSS.t331 0.451337
R2744 VSS.t267 VSS.t306 0.451337
R2745 VSS.t75 VSS.t334 0.451337
R2746 VSS.t102 VSS.t408 0.451337
R2747 VSS.t80 VSS.t417 0.451337
R2748 VSS.t457 VSS.t609 0.451337
R2749 VSS.t301 VSS.t157 0.451337
R2750 VSS.t72 VSS.t338 0.451337
R2751 VSS.t161 VSS.t623 0.451337
R2752 VSS.t129 VSS.t438 0.451337
R2753 VSS.t322 VSS.t420 0.451337
R2754 VSS.t402 VSS.t579 0.451337
R2755 VSS.t133 VSS.t291 0.451337
R2756 VSS.n578 VSS.n577 0.447348
R2757 VSS.n900 VSS.n187 0.44402
R2758 VSS.t232 VSS.n346 0.440228
R2759 VSS.t311 VSS.n345 0.440228
R2760 VSS.t241 VSS.n344 0.440228
R2761 VSS.t411 VSS.n341 0.440228
R2762 VSS.t92 VSS.n340 0.440228
R2763 VSS.t343 VSS.n339 0.440228
R2764 VSS.t164 VSS.n338 0.440228
R2765 VSS.t205 VSS.n335 0.440228
R2766 VSS.t78 VSS.n334 0.440228
R2767 VSS.t442 VSS.n332 0.440228
R2768 VSS.t117 VSS.n331 0.440228
R2769 VSS.t262 VSS.n330 0.440228
R2770 VSS.t107 VSS.n329 0.440228
R2771 VSS.t159 VSS.n326 0.440228
R2772 VSS.t113 VSS.n324 0.440228
R2773 VSS.t186 VSS.n323 0.440228
R2774 VSS.t243 VSS.n321 0.440228
R2775 VSS.t131 VSS.n318 0.440228
R2776 VSS.n316 VSS.t550 0.440228
R2777 VSS.n317 VSS.t308 0.440228
R2778 VSS.n319 VSS.t119 0.440228
R2779 VSS.n320 VSS.t315 0.440228
R2780 VSS.n322 VSS.t211 0.440228
R2781 VSS.n325 VSS.t82 0.440228
R2782 VSS.n327 VSS.t139 0.440228
R2783 VSS.n328 VSS.t174 0.440228
R2784 VSS.n333 VSS.t494 0.440228
R2785 VSS.n336 VSS.t100 0.440228
R2786 VSS.n337 VSS.t397 0.440228
R2787 VSS.n342 VSS.t67 0.440228
R2788 VSS.n343 VSS.t148 0.440228
R2789 VSS.n831 VSS.n539 0.418268
R2790 VSS.n786 VSS.n785 0.418268
R2791 VSS.n785 VSS.n539 0.414988
R2792 VSS.n787 VSS.n786 0.414988
R2793 VSS.n668 VSS.n543 0.41014
R2794 VSS.t476 VSS.n67 0.400619
R2795 VSS.n811 VSS.n810 0.376066
R2796 VSS.n728 VSS.n710 0.376066
R2797 VSS.n7 VSS.n5 0.351198
R2798 VSS.n807 VSS.n806 0.338265
R2799 VSS.n745 VSS.n11 0.338265
R2800 VSS.n806 VSS.n805 0.338019
R2801 VSS.n803 VSS.n11 0.338019
R2802 VSS.n826 VSS.n351 0.329994
R2803 VSS.n567 VSS.n566 0.312321
R2804 VSS.n828 VSS.n827 0.31114
R2805 VSS.t6 VSS.n220 0.306378
R2806 VSS.t17 VSS.n235 0.306378
R2807 VSS.t28 VSS.n251 0.306378
R2808 VSS.t39 VSS.n275 0.306378
R2809 VSS.t50 VSS.n289 0.306378
R2810 VSS.t61 VSS.n303 0.306378
R2811 VSS.n810 VSS.n809 0.306341
R2812 VSS.n744 VSS.n710 0.306341
R2813 VSS.t550 VSS.t217 0.302153
R2814 VSS.n667 VSS.t595 0.298621
R2815 VSS.n188 VSS.n899 0.295237
R2816 VSS.n547 VSS.n544 0.291601
R2817 VSS.n433 VSS.t254 0.290734
R2818 VSS.n677 VSS.n547 0.287886
R2819 VSS.n775 VSS.n774 0.286439
R2820 VSS.n851 VSS.n304 0.282782
R2821 VSS.n616 VSS.n615 0.280152
R2822 VSS.n626 VSS.n625 0.280152
R2823 VSS.t521 VSS.n551 0.276107
R2824 VSS.n516 VSS.t234 0.275961
R2825 VSS.n899 VSS.n189 0.275933
R2826 VSS.n518 VSS.n347 0.272321
R2827 VSS.n521 VSS.n516 0.272065
R2828 VSS.n96 VSS.n130 0.267794
R2829 VSS.n96 VSS.n131 0.267794
R2830 VSS.n96 VSS.n133 0.267794
R2831 VSS.n96 VSS.n134 0.267794
R2832 VSS.n96 VSS.n181 0.267794
R2833 VSS.n96 VSS.n180 0.267794
R2834 VSS.n96 VSS.n135 0.267794
R2835 VSS.n96 VSS.n136 0.267794
R2836 VSS.n96 VSS.n137 0.267794
R2837 VSS.n96 VSS.n138 0.267794
R2838 VSS.n96 VSS.n139 0.267794
R2839 VSS.n96 VSS.n140 0.267794
R2840 VSS.n96 VSS.n179 0.267794
R2841 VSS.n96 VSS.n178 0.267794
R2842 VSS.n96 VSS.n141 0.267794
R2843 VSS.n96 VSS.n177 0.267794
R2844 VSS.n96 VSS.n142 0.267794
R2845 VSS.n96 VSS.n143 0.267794
R2846 VSS.n96 VSS.n144 0.267794
R2847 VSS.n96 VSS.n145 0.267794
R2848 VSS.n96 VSS.n146 0.267794
R2849 VSS.n96 VSS.n147 0.267794
R2850 VSS.n96 VSS.n148 0.267794
R2851 VSS.n96 VSS.n174 0.267794
R2852 VSS.n96 VSS.n149 0.267794
R2853 VSS.n96 VSS.n150 0.267794
R2854 VSS.n96 VSS.n151 0.267794
R2855 VSS.n96 VSS.n172 0.267794
R2856 VSS.n96 VSS.n152 0.267794
R2857 VSS.n96 VSS.n153 0.267794
R2858 VSS.n96 VSS.n154 0.267794
R2859 VSS.n96 VSS.n171 0.267794
R2860 VSS.n96 VSS.n155 0.267794
R2861 VSS.n96 VSS.n170 0.267794
R2862 VSS.n96 VSS.n169 0.267794
R2863 VSS.n96 VSS.n168 0.267794
R2864 VSS.n96 VSS.n156 0.267794
R2865 VSS.n96 VSS.n157 0.267794
R2866 VSS.n96 VSS.n158 0.267794
R2867 VSS.n96 VSS.n166 0.267794
R2868 VSS.n96 VSS.n165 0.267794
R2869 VSS.n96 VSS.n164 0.267794
R2870 VSS.n96 VSS.n163 0.267794
R2871 VSS.n96 VSS.n159 0.267794
R2872 VSS.n96 VSS.n99 0.267794
R2873 VSS.n96 VSS.n100 0.267794
R2874 VSS.n96 VSS.n101 0.267794
R2875 VSS.n96 VSS.n103 0.267794
R2876 VSS.n96 VSS.n105 0.267794
R2877 VSS.n96 VSS.n106 0.267794
R2878 VSS.n96 VSS.n108 0.267794
R2879 VSS.n96 VSS.n109 0.267794
R2880 VSS.n96 VSS.n112 0.267794
R2881 VSS.n96 VSS.n113 0.267794
R2882 VSS.n96 VSS.n114 0.267794
R2883 VSS.n96 VSS.n115 0.267794
R2884 VSS.n96 VSS.n116 0.267794
R2885 VSS.n96 VSS.n117 0.267794
R2886 VSS.n96 VSS.n120 0.267794
R2887 VSS.n96 VSS.n121 0.267794
R2888 VSS.n96 VSS.n122 0.267794
R2889 VSS.n96 VSS.n124 0.267794
R2890 VSS.n96 VSS.n125 0.267794
R2891 VSS.n96 VSS.n128 0.267794
R2892 VSS.n96 VSS.n161 0.267428
R2893 VSS.n563 VSS.n551 0.2661
R2894 VSS.n831 VSS.n830 0.265497
R2895 VSS.t188 VSS.n347 0.264468
R2896 VSS.n830 VSS.n829 0.264227
R2897 VSS.n210 VSS.t589 0.263148
R2898 VSS.n220 VSS.t8 0.255324
R2899 VSS.n235 VSS.t19 0.255324
R2900 VSS.n251 VSS.t30 0.255324
R2901 VSS.n275 VSS.t41 0.255324
R2902 VSS.n289 VSS.t52 0.255324
R2903 VSS.n303 VSS.t63 0.255324
R2904 VSS.t384 VSS.t217 0.254653
R2905 VSS.n96 VSS.n526 0.253529
R2906 VSS.t572 VSS.n433 0.24355
R2907 VSS.t87 VSS.n666 0.241078
R2908 VSS.t95 VSS.n641 0.241078
R2909 VSS.n842 VSS.n351 0.24011
R2910 VSS.n27 VSS.n535 0.380488
R2911 VSS.t280 VSS.n532 0.239006
R2912 VSS.t284 VSS.n835 0.239006
R2913 VSS.n19 VSS.n529 0.332933
R2914 VSS.n791 VSS.n790 0.239006
R2915 VSS.n797 VSS.n796 0.239006
R2916 VSS.n31 VSS.n723 0.286426
R2917 VSS.t275 VSS.n536 0.239006
R2918 VSS.t354 VSS.n782 0.239006
R2919 VSS.t276 VSS.n775 0.239006
R2920 VSS.n532 VSS.n832 0.238668
R2921 VSS.n833 VSS.t281 0.238668
R2922 VSS.n835 VSS.n834 0.238668
R2923 VSS.n790 VSS.n789 0.238668
R2924 VSS.n774 VSS.n792 0.238668
R2925 VSS.n796 VSS.t277 0.238668
R2926 VSS.n19 VSS.t284 0.141785
R2927 VSS.n535 VSS.t275 0.238668
R2928 VSS.t278 VSS.n27 0.332725
R2929 VSS.n568 VSS.n567 0.238218
R2930 VSS.n617 VSS.n616 0.233757
R2931 VSS.n619 VSS.n618 0.233757
R2932 VSS.n627 VSS.n626 0.233757
R2933 VSS.n615 VSS.t532 0.233419
R2934 VSS.n618 VSS.n617 0.233419
R2935 VSS.n625 VSS.n624 0.233419
R2936 VSS.t515 VSS.n600 0.233419
R2937 VSS.n557 VSS.n555 0.225543
R2938 VSS.t2 VSS.t4 0.224424
R2939 VSS.t24 VSS.t26 0.224424
R2940 VSS.t57 VSS.t59 0.224424
R2941 VSS.t46 VSS.t48 0.224424
R2942 VSS.t35 VSS.t37 0.224424
R2943 VSS.t13 VSS.t15 0.224424
R2944 VSS.t1 VSS.t2 0.220674
R2945 VSS.t23 VSS.t24 0.220674
R2946 VSS.t57 VSS.t56 0.220674
R2947 VSS.t46 VSS.t45 0.220674
R2948 VSS.t35 VSS.t34 0.220674
R2949 VSS.t13 VSS.t12 0.220674
R2950 VSS.n574 VSS.n555 0.219552
R2951 VSS.t168 VSS.n676 0.211735
R2952 VSS.n726 VSS.n725 0.210118
R2953 VSS.n822 VSS.n543 0.20686
R2954 VSS.n95 VSS.n313 0.297117
R2955 VSS.n579 VSS.n560 0.191235
R2956 VSS.n832 VSS.t278 0.191235
R2957 VSS.t282 VSS.n22 0.0953067
R2958 VSS.n834 VSS.t283 0.191235
R2959 VSS.n788 VSS.t354 0.191235
R2960 VSS.n789 VSS.n788 0.191235
R2961 VSS.n792 VSS.n791 0.191235
R2962 VSS.n794 VSS.t276 0.191235
R2963 VSS.n795 VSS.n794 0.191235
R2964 VSS.n773 VSS.n795 0.191235
R2965 VSS.n798 VSS.n797 0.191235
R2966 VSS.n799 VSS.n798 0.191235
R2967 VSS.n800 VSS.n799 0.191235
R2968 VSS.n801 VSS.n800 0.191235
R2969 VSS.n436 VSS.n95 0.23732
R2970 VSS.t277 VSS.n773 0.191235
R2971 VSS.t281 VSS.t280 0.191235
R2972 VSS.t283 VSS.t282 0.191235
R2973 VSS.n682 VSS.n31 0.191543
R2974 VSS.t374 VSS.t371 0.1875
R2975 VSS.t368 VSS.t364 0.1875
R2976 VSS.t380 VSS.t377 0.1875
R2977 VSS.n620 VSS.n619 0.187025
R2978 VSS.n621 VSS.n620 0.187025
R2979 VSS.n622 VSS.n621 0.187025
R2980 VSS.n623 VSS.n622 0.187025
R2981 VSS.n624 VSS.n623 0.187025
R2982 VSS.n600 VSS.n627 0.187025
R2983 VSS.n679 VSS.n684 0.181924
R2984 VSS.n721 VSS.n717 0.181543
R2985 VSS.n816 VSS.n678 0.168638
R2986 VSS.n785 VSS.t352 0.167615
R2987 VSS.n681 VSS.n717 0.164808
R2988 VSS.n680 VSS.n679 0.164424
R2989 VSS.n96 VSS.n183 0.160396
R2990 VSS.n96 VSS.n185 0.160396
R2991 VSS.n96 VSS.n186 0.160396
R2992 VSS.n536 VSS.n538 0.15955
R2993 VSS.n782 VSS.n783 0.15955
R2994 VSS.n602 VSS.n559 0.156138
R2995 VSS.n828 VSS.n540 0.150687
R2996 VSS.t525 VSS.n78 0.14953
R2997 VSS.t505 VSS.n78 0.149502
R2998 VSS.n723 VSS.n722 0.145118
R2999 VSS.n878 VSS.n252 0.144066
R3000 VSS.n727 VSS.n726 0.143368
R3001 VSS.n816 VSS.n815 0.1433
R3002 VSS.n585 VSS.n716 0.142012
R3003 VSS.t387 VSS.n313 0.139294
R3004 VSS.t500 VSS.n78 0.138788
R3005 VSS.t509 VSS.n78 0.138776
R3006 VSS.t518 VSS.n78 0.13875
R3007 VSS.t517 VSS.n78 0.138705
R3008 VSS.n681 VSS.n716 0.138262
R3009 VSS.n827 VSS.n187 0.138073
R3010 VSS.t381 VSS.t572 0.135868
R3011 VSS.t384 VSS.n315 0.124618
R3012 VSS.t381 VSS.n312 0.122118
R3013 VSS.n315 VSS.t383 0.122118
R3014 VSS.t357 VSS.n682 0.1171
R3015 VSS.n815 VSS.n814 0.111556
R3016 VSS.t513 VSS.n78 0.11127
R3017 VSS.t214 VSS.n304 0.109701
R3018 VSS.n436 VSS.t385 0.109642
R3019 VSS.n684 VSS.n683 0.104618
R3020 VSS.n729 VSS.n721 0.104618
R3021 VSS.t369 VSS.n552 0.0971176
R3022 VSS.n602 VSS.n560 0.0971176
R3023 VSS.t530 VSS.n78 0.0960932
R3024 VSS.n559 VSS.n558 0.0958002
R3025 VSS.n558 VSS.n556 0.0955
R3026 VSS.n569 VSS.n568 0.093
R3027 VSS.t375 VSS.n350 0.08925
R3028 VSS.n523 VSS.t389 0.08925
R3029 VSS.t371 VSS.n576 0.0851154
R3030 VSS.n577 VSS.t374 0.0851154
R3031 VSS.t364 VSS.n565 0.0851154
R3032 VSS.n566 VSS.t368 0.0851154
R3033 VSS.t377 VSS.n520 0.0851154
R3034 VSS.n521 VSS.t380 0.0851154
R3035 VSS.n608 VSS.t166 0.0846176
R3036 VSS.n614 VSS.n542 0.0846176
R3037 VSS.n808 VSS.n807 0.08425
R3038 VSS.n746 VSS.n745 0.08425
R3039 VSS.n565 VSS.n2 0.08175
R3040 VSS.n576 VSS.n571 0.08175
R3041 VSS.n564 VSS.n549 0.08175
R3042 VSS.n575 VSS.n553 0.08175
R3043 VSS.n850 VSS.n849 0.0805
R3044 VSS.n815 VSS.n812 0.0805
R3045 VSS.n538 VSS.n537 0.0796176
R3046 VSS.n783 VSS.n784 0.0796176
R3047 VSS.t121 VSS.n525 0.078
R3048 VSS.t387 VSS.n314 0.0771176
R3049 VSS.n537 VSS.n831 0.0758676
R3050 VSS.n784 VSS.n787 0.0758676
R3051 VSS.n520 VSS.n352 0.0746176
R3052 VSS.n519 VSS.n349 0.0746176
R3053 VSS.n824 VSS.n541 0.07425
R3054 VSS.n812 VSS.n680 0.07425
R3055 VSS.t365 VSS.n546 0.0740901
R3056 VSS.t362 VSS.n545 0.0740901
R3057 VSS.t90 VSS.n541 0.07175
R3058 VSS.t208 VSS.n526 0.0715186
R3059 VSS.t501 VSS.n608 0.0708676
R3060 VSS.t516 VSS.n614 0.0708676
R3061 VSS.t383 VSS.n314 0.0696176
R3062 VSS.n520 VSS.t391 0.06925
R3063 VSS.t6 VSS.n214 0.06925
R3064 VSS.t17 VSS.n233 0.06925
R3065 VSS.t28 VSS.n245 0.06925
R3066 VSS.t39 VSS.n273 0.06925
R3067 VSS.t50 VSS.n287 0.06925
R3068 VSS.t61 VSS.n301 0.06925
R3069 VSS.n809 VSS.n808 0.06925
R3070 VSS.n746 VSS.n744 0.06925
R3071 VSS.n519 VSS.n348 0.06925
R3072 VSS.n566 VSS.n562 0.0671176
R3073 VSS.n577 VSS.n573 0.0671176
R3074 VSS.n563 VSS.n550 0.0671176
R3075 VSS.n574 VSS.n554 0.0671176
R3076 VSS.n565 VSS.n562 0.0621177
R3077 VSS.n576 VSS.n573 0.0621177
R3078 VSS.n564 VSS.n550 0.0621177
R3079 VSS.n575 VSS.n554 0.0621177
R3080 VSS.n518 VSS.n348 0.05925
R3081 VSS.n521 VSS.t391 0.05925
R3082 VSS.t521 VSS.n552 0.0571176
R3083 VSS.t389 VSS.n352 0.0546176
R3084 VSS.t375 VSS.n349 0.0546176
R3085 VSS.t4 VSS.n214 0.05175
R3086 VSS.n233 VSS.t15 0.05175
R3087 VSS.t26 VSS.n245 0.05175
R3088 VSS.n273 VSS.t37 0.05175
R3089 VSS.n287 VSS.t48 0.05175
R3090 VSS.n301 VSS.t59 0.05175
R3091 VSS.n683 VSS.n811 0.0496177
R3092 VSS.n729 VSS.n728 0.0496177
R3093 VSS.n570 VSS.n569 0.04925
R3094 VSS.n571 VSS.n570 0.04675
R3095 VSS.t369 VSS.n553 0.04675
R3096 VSS.n682 VSS.n727 0.04675
R3097 VSS.n7 VSS.n6 0.0161289
R3098 VSS.n725 VSS.n678 0.0378652
R3099 VSS.n814 VSS.t90 0.0353056
R3100 VSS.n821 VSS.n2 0.0305
R3101 VSS.n549 VSS.n548 0.0305
R3102 VSS.t385 VSS.n160 0.02925
R3103 VSS.n546 VSS.n544 0.0253401
R3104 VSS.n677 VSS.n545 0.0253401
R3105 VSS.n851 VSS.n311 0.023135
R3106 VSS.n851 VSS.n307 0.023135
R3107 VSS.n855 VSS.n854 0.023135
R3108 VSS.n860 VSS.n292 0.023135
R3109 VSS.n860 VSS.n293 0.023135
R3110 VSS.n864 VSS.n863 0.023135
R3111 VSS.n869 VSS.n278 0.023135
R3112 VSS.n869 VSS.n279 0.023135
R3113 VSS.n873 VSS.n872 0.023135
R3114 VSS.n878 VSS.n255 0.023135
R3115 VSS.n878 VSS.n257 0.023135
R3116 VSS.n878 VSS.n258 0.023135
R3117 VSS.n878 VSS.n259 0.023135
R3118 VSS.n881 VSS.n249 0.023135
R3119 VSS.n884 VSS.n237 0.023135
R3120 VSS.n884 VSS.n238 0.023135
R3121 VSS.n888 VSS.n887 0.023135
R3122 VSS.n893 VSS.n223 0.023135
R3123 VSS.n893 VSS.n224 0.023135
R3124 VSS.n896 VSS.n218 0.023135
R3125 VSS.n899 VSS.n190 0.023135
R3126 VSS.n899 VSS.n194 0.023135
R3127 VSS.n899 VSS.n204 0.023135
R3128 VSS.n849 VSS.n312 0.02175
R3129 VSS.n188 VSS.t153 0.0191553
R3130 VSS.n660 VSS.t197 0.0184075
R3131 VSS.n646 VSS.t199 0.0184075
R3132 VSS.t168 VSS.n673 0.0173993
R3133 VSS.n821 VSS.t365 0.01675
R3134 VSS.n548 VSS.t362 0.01675
R3135 VSS.n96 VSS.n182 0.0165542
R3136 VSS.n96 VSS.n184 0.0165542
R3137 VSS.n850 VSS.n160 0.0155
R3138 VSS.t476 VSS.n66 0.0151406
R3139 VSS.n654 VSS.n71 0.0151406
R3140 VSS.n653 VSS.n71 0.0151406
R3141 VSS.n642 VSS.n595 0.0151406
R3142 VSS.t168 VSS.n669 0.0150892
R3143 VSS VSS.n900 0.0134067
R3144 VSS.n557 VSS.n556 0.013
R3145 VSS.n96 VSS.n176 0.00962826
R3146 VSS.n96 VSS.n175 0.00962826
R3147 VSS.n96 VSS.n173 0.00962826
R3148 VSS.n96 VSS.n167 0.00962826
R3149 VSS.n96 VSS.n162 0.00938635
R3150 VSS.n96 VSS.n98 0.00937856
R3151 VSS.n96 VSS.n104 0.00937856
R3152 VSS.n96 VSS.n123 0.00937856
R3153 VSS.n96 VSS.n132 0.00937856
R3154 VSS.n96 VSS.n102 0.00937856
R3155 VSS.n96 VSS.n107 0.00937856
R3156 VSS.n96 VSS.n110 0.00937856
R3157 VSS.n96 VSS.n111 0.00937856
R3158 VSS.n96 VSS.n118 0.00937856
R3159 VSS.n96 VSS.n119 0.00937856
R3160 VSS.n96 VSS.n126 0.00937856
R3161 VSS.n96 VSS.n127 0.00937856
R3162 VSS.n96 VSS.n129 0.00937856
R3163 VSS.n842 VSS.n523 0.00675
R3164 VSS.n826 VSS.n350 0.00675
R3165 VSS.n825 VSS.n28 0.00459701
R3166 VSS.n7 VSS.n0 0.00296307
R3167 VSS.n722 VSS.n585 0.00224991
R3168 VSS.n95 VSS.n94 4.19564
R3169 VSS.n84 VSS.n611 0.00649396
R3170 VSS.n793 VSS.n56 0.0042985
R3171 VSS.n47 VSS.n49 0.00374975
R3172 VSS.n28 VSS.n36 0.00349994
R3173 VSS.n772 VSS.n62 0.00349933
R3174 VSS.n39 VSS.n40 0.00299994
R3175 VSS.n35 VSS.n12 0.00299994
R3176 VSS.n33 VSS.n30 0.00299994
R3177 VSS.n24 VSS.n37 0.00299994
R3178 VSS.n34 VSS.n30 0.00299991
R3179 VSS.n93 VSS.n91 0.00249999
R3180 VSS.n52 VSS.n51 0.00249999
R3181 VSS.n630 VSS.n78 0.00249998
R3182 VSS.n42 VSS.n21 0.00283308
R3183 VSS.n21 VSS.n20 0.00269993
R3184 VSS.n18 VSS.n17 0.00233332
R3185 VSS.n72 VSS.n71 0.0022
R3186 VSS.n837 VSS.n28 0.00193134
R3187 VSS.n79 VSS.n78 0.00168735
R3188 VSS.n309 VSS.n302 0.00179957
R3189 VSS.n308 VSS.n302 0.00179957
R3190 VSS.n857 VSS.n298 0.00179957
R3191 VSS.n295 VSS.n288 0.00179957
R3192 VSS.n294 VSS.n288 0.00179957
R3193 VSS.n866 VSS.n284 0.00179957
R3194 VSS.n281 VSS.n274 0.00179957
R3195 VSS.n280 VSS.n274 0.00179957
R3196 VSS.n875 VSS.n270 0.00179957
R3197 VSS.n262 VSS.n250 0.00179957
R3198 VSS.n261 VSS.n250 0.00179957
R3199 VSS.n247 VSS.n244 0.00179957
R3200 VSS.n240 VSS.n234 0.00179957
R3201 VSS.n239 VSS.n234 0.00179957
R3202 VSS.n890 VSS.n230 0.00179957
R3203 VSS.n227 VSS.n219 0.00179957
R3204 VSS.n226 VSS.n219 0.00179957
R3205 VSS.n216 VSS.n213 0.00179957
R3206 VSS.n899 VSS.n197 0.00179957
R3207 VSS.n899 VSS.n199 0.00179957
R3208 VSS.n899 VSS.n203 0.00179957
R3209 VSS.n528 VSS.n45 0.00175
R3210 VSS.n780 VSS.n65 0.00175
R3211 VSS.n47 VSS.n46 0.00138885
R3212 VSS.n724 VSS.n15 0.00349966
R3213 VSS.n33 VSS.n32 0.00149995
R3214 VSS.n35 VSS.n34 0.00149995
R3215 VSS.n26 VSS.n25 0.00169993
R3216 VSS.n24 VSS.n23 0.00149995
R3217 VSS.n39 VSS.n38 0.00149995
R3218 VSS.n18 VSS.n16 0.00169993
R3219 VSS.n528 VSS.n17 0.00166667
R3220 VSS.n53 VSS.n52 0.00149995
R3221 VSS.n779 VSS.n777 0.00166667
R3222 VSS.n793 VSS.n776 0.00166667
R3223 VSS.n778 VSS.n772 0.00166667
R3224 VSS.n612 VSS.n599 0.00166667
R3225 VSS.n82 VSS.n81 0.00169993
R3226 VSS.n609 VSS.n598 0.00166667
R3227 VSS.n91 VSS.n90 0.00149995
R3228 VSS.n7 VSS.n3 0.00161188
R3229 VSS.n813 VSS.n28 0.0015
R3230 VSS.n813 VSS.n13 0.0015
R3231 VSS.n93 VSS.n92 0.0015
R3232 VSS.n611 VSS.n82 0.0015
R3233 VSS.n76 VSS.n75 0.00214264
R3234 VSS.n76 VSS.t199 0.0015
R3235 VSS.n71 VSS.t199 0.0015
R3236 VSS.n665 VSS.t476 0.00136832
R3237 VSS.n779 VSS.n54 0.00133332
R3238 VSS.n777 VSS.n776 0.00133332
R3239 VSS.n778 VSS.n60 0.00133332
R3240 VSS.n613 VSS.n599 0.00133332
R3241 VSS.n610 VSS.n598 0.00133332
R3242 VSS.n7 VSS.n1 0.00128573
R3243 VSS.n635 VSS.n78 0.00128363
R3244 VSS.n13 VSS.n45 0.00124998
R3245 VSS.n629 VSS.n78 0.00113179
R3246 VSS.n899 VSS.n211 0.00104691
R3247 VSS.n7 VSS.n4 0.00102591
R3248 VSS.n851 VSS.n306 0.00101811
R3249 VSS.n860 VSS.n859 0.00101811
R3250 VSS.n860 VSS.n297 0.00101811
R3251 VSS.n869 VSS.n868 0.00101811
R3252 VSS.n869 VSS.n283 0.00101811
R3253 VSS.n878 VSS.n877 0.00101811
R3254 VSS.n878 VSS.n264 0.00101811
R3255 VSS.n884 VSS.n243 0.00101811
R3256 VSS.n884 VSS.n242 0.00101811
R3257 VSS.n893 VSS.n892 0.00101811
R3258 VSS.n893 VSS.n229 0.00101811
R3259 VSS.n899 VSS.n212 0.00101811
R3260 VSS.n637 VSS.n78 0.00100072
R3261 VSS.n878 VSS.n267 0.00100065
R3262 VSS.n851 VSS.n305 0.00100065
R3263 VSS.n878 VSS.n256 0.00100065
R3264 VSS.n878 VSS.n265 0.00100065
R3265 VSS.n899 VSS.n191 0.00100065
R3266 VSS.n633 VSS.n78 0.00100039
R3267 VSS.n634 VSS.n78 0.00100038
R3268 VSS.n631 VSS.n78 0.00100002
R3269 VSS.n632 VSS.n78 0.00100001
R3270 VSS.n636 VSS.n78 0.00100001
R3271 VSS.n852 VSS.n302 0.001
R3272 VSS.n854 VSS.n853 0.001
R3273 VSS.n857 VSS.n299 0.001
R3274 VSS.n860 VSS.n291 0.001
R3275 VSS.n861 VSS.n288 0.001
R3276 VSS.n863 VSS.n862 0.001
R3277 VSS.n866 VSS.n285 0.001
R3278 VSS.n869 VSS.n277 0.001
R3279 VSS.n870 VSS.n274 0.001
R3280 VSS.n872 VSS.n871 0.001
R3281 VSS.n875 VSS.n271 0.001
R3282 VSS.n878 VSS.n254 0.001
R3283 VSS.n879 VSS.n250 0.001
R3284 VSS.n881 VSS.n880 0.001
R3285 VSS.n882 VSS.n244 0.001
R3286 VSS.n884 VSS.n883 0.001
R3287 VSS.n885 VSS.n234 0.001
R3288 VSS.n887 VSS.n886 0.001
R3289 VSS.n890 VSS.n231 0.001
R3290 VSS.n893 VSS.n222 0.001
R3291 VSS.n894 VSS.n219 0.001
R3292 VSS.n896 VSS.n895 0.001
R3293 VSS.n897 VSS.n213 0.001
R3294 VSS.n899 VSS.n898 0.001
R3295 VSS.n898 VSS.n213 0.001
R3296 VSS.n897 VSS.n896 0.001
R3297 VSS.n895 VSS.n219 0.001
R3298 VSS.n894 VSS.n893 0.001
R3299 VSS.n890 VSS.n222 0.001
R3300 VSS.n887 VSS.n231 0.001
R3301 VSS.n886 VSS.n234 0.001
R3302 VSS.n885 VSS.n884 0.001
R3303 VSS.n883 VSS.n244 0.001
R3304 VSS.n882 VSS.n881 0.001
R3305 VSS.n880 VSS.n250 0.001
R3306 VSS.n879 VSS.n878 0.001
R3307 VSS.n875 VSS.n254 0.001
R3308 VSS.n872 VSS.n271 0.001
R3309 VSS.n871 VSS.n274 0.001
R3310 VSS.n870 VSS.n869 0.001
R3311 VSS.n866 VSS.n277 0.001
R3312 VSS.n863 VSS.n285 0.001
R3313 VSS.n862 VSS.n288 0.001
R3314 VSS.n861 VSS.n860 0.001
R3315 VSS.n857 VSS.n291 0.001
R3316 VSS.n854 VSS.n299 0.001
R3317 VSS.n853 VSS.n302 0.001
R3318 VSS.n852 VSS.n851 0.001
R3319 VSS.n49 VSS.n48 0.00124999
R3320 VSS.n59 VSS.n58 0.00124999
R3321 VSS.n64 VSS.n63 0.00124999
R3322 VSS.n534 VSS.n36 0.001
R3323 VSS.n533 VSS.n37 0.001
R3324 VSS.n531 VSS.n40 0.001
R3325 VSS.n530 VSS.n43 0.001
R3326 VSS.n70 VSS.n69 0.00192843
R3327 VSS.n780 VSS.n12 0.00174999
R3328 VSS.n69 VSS.t197 0.0015
R3329 VSS.t476 VSS.t197 0.0015
R3330 VSS.n63 VSS.n65 0.0015
R3331 VSS.n58 VSS.n60 0.0015
R3332 VSS.n51 VSS.n54 0.0015
R3333 VSS.n48 VSS.n50 0.0015
R3334 VSS.n8 VSS.n820 8.50175
R3335 VSS.n14 VSS.n13 0.00149997
R3336 VSS.n642 VSS.n77 0.001
R3337 VSS.n613 VSS.n80 0.001
R3338 VSS.n610 VSS.n89 0.001
R3339 VSS.n606 VSS.n580 0.001
R3340 VSS.t168 VSS.n580 0.001
R3341 VSS.n8 VSS.n7 0.00125
R3342 VSS.n8 VSS.n579 8.47794
R3343 a_3747_311.n0 a_3747_311.t2 52.0388
R3344 a_3747_311.t1 a_3747_311.n0 35.4491
R3345 a_3747_311.n0 a_3747_311.t3 33.5891
R3346 a_3747_311.t0 a_3747_311.t1 5.61942
R3347 a_3171_311.n0 a_3171_311.t2 51.8377
R3348 a_3171_311.n0 a_3171_311.t3 33.3881
R3349 a_3171_311.t1 a_3171_311.n0 31.8923
R3350 a_3171_311.t0 a_3171_311.t1 5.61777
R3351 a_2595_311.n0 a_2595_311.t2 51.6367
R3352 a_2595_311.n0 a_2595_311.t3 33.187
R3353 a_2595_311.t1 a_2595_311.n0 27.993
R3354 a_2595_311.t0 a_2595_311.t1 5.73018
R3355 a_3747_1047.n0 a_3747_1047.t2 38.0081
R3356 a_3747_1047.n0 a_3747_1047.t3 33.3957
R3357 a_3747_1047.n1 a_3747_1047.t4 33.3957
R3358 a_3747_1047.n2 a_3747_1047.t5 33.3957
R3359 a_3747_1047.n3 a_3747_1047.t6 33.3957
R3360 a_3747_1047.n4 a_3747_1047.t7 33.3957
R3361 a_3747_1047.n5 a_3747_1047.t8 33.3957
R3362 a_3747_1047.n6 a_3747_1047.t9 33.3957
R3363 a_3747_1047.t1 a_3747_1047.n6 23.2419
R3364 a_3747_1047.t0 a_3747_1047.t1 5.61942
R3365 a_3747_1047.n6 a_3747_1047.n5 4.61291
R3366 a_3747_1047.n5 a_3747_1047.n4 4.61291
R3367 a_3747_1047.n4 a_3747_1047.n3 4.61291
R3368 a_3747_1047.n3 a_3747_1047.n2 4.61291
R3369 a_3747_1047.n2 a_3747_1047.n1 4.61291
R3370 a_3747_1047.n1 a_3747_1047.n0 4.61291
R3371 a_3171_1047.n0 a_3171_1047.t2 37.8054
R3372 a_3171_1047.n0 a_3171_1047.t3 33.193
R3373 a_3171_1047.n1 a_3171_1047.t4 33.193
R3374 a_3171_1047.n2 a_3171_1047.t5 33.193
R3375 a_3171_1047.n3 a_3171_1047.t6 33.193
R3376 a_3171_1047.n4 a_3171_1047.t7 33.193
R3377 a_3171_1047.n5 a_3171_1047.t8 33.193
R3378 a_3171_1047.n6 a_3171_1047.t9 33.193
R3379 a_3171_1047.t1 a_3171_1047.n6 23.0313
R3380 a_3171_1047.t0 a_3171_1047.t1 5.61777
R3381 a_3171_1047.n6 a_3171_1047.n5 4.61291
R3382 a_3171_1047.n5 a_3171_1047.n4 4.61291
R3383 a_3171_1047.n4 a_3171_1047.n3 4.61291
R3384 a_3171_1047.n3 a_3171_1047.n2 4.61291
R3385 a_3171_1047.n2 a_3171_1047.n1 4.61291
R3386 a_3171_1047.n1 a_3171_1047.n0 4.61291
R3387 a_2595_1047.n0 a_2595_1047.t2 37.7691
R3388 a_2595_1047.n0 a_2595_1047.t3 33.1567
R3389 a_2595_1047.n1 a_2595_1047.t4 33.1567
R3390 a_2595_1047.n2 a_2595_1047.t5 33.1567
R3391 a_2595_1047.n3 a_2595_1047.t6 33.1567
R3392 a_2595_1047.n4 a_2595_1047.t7 33.1567
R3393 a_2595_1047.n5 a_2595_1047.t8 33.1567
R3394 a_2595_1047.n6 a_2595_1047.t9 33.1567
R3395 a_2595_1047.t1 a_2595_1047.n6 22.7941
R3396 a_2595_1047.t0 a_2595_1047.t1 5.65522
R3397 a_2595_1047.n6 a_2595_1047.n5 4.61291
R3398 a_2595_1047.n5 a_2595_1047.n4 4.61291
R3399 a_2595_1047.n4 a_2595_1047.n3 4.61291
R3400 a_2595_1047.n3 a_2595_1047.n2 4.61291
R3401 a_2595_1047.n2 a_2595_1047.n1 4.61291
R3402 a_2595_1047.n1 a_2595_1047.n0 4.61291
R3403 a_2019_1047.n0 a_2019_1047.t2 37.9701
R3404 a_2019_1047.n0 a_2019_1047.t3 33.3577
R3405 a_2019_1047.n1 a_2019_1047.t4 33.3577
R3406 a_2019_1047.n2 a_2019_1047.t5 33.3577
R3407 a_2019_1047.n3 a_2019_1047.t6 33.3577
R3408 a_2019_1047.n4 a_2019_1047.t7 33.3577
R3409 a_2019_1047.n5 a_2019_1047.t8 33.3577
R3410 a_2019_1047.t1 a_2019_1047.t9 22.5945
R3411 a_2019_1047.t0 a_2019_1047.t1 5.62052
R3412 a_2019_1047.t9 a_2019_1047.n5 4.61291
R3413 a_2019_1047.n5 a_2019_1047.n4 4.61291
R3414 a_2019_1047.n4 a_2019_1047.n3 4.61291
R3415 a_2019_1047.n3 a_2019_1047.n2 4.61291
R3416 a_2019_1047.n2 a_2019_1047.n1 4.61291
R3417 a_2019_1047.n1 a_2019_1047.n0 4.61291
C1413 MUX_OUT VSS 3.24058f
C1414 MUX_SEL4 VSS 1.60778f
C1415 MUX_SEL3 VSS 0.90686f
C1416 MUX_SEL2 VSS 1.81137f
C1417 MUX_SEL1 VSS 0.95075f
C1418 MUX_SEL0 VSS 1.5515f
C1419 DELAY_VBIASP VSS 5.14023f
C1420 DELAY_OUT_LAST VSS 2.97841f
C1421 DELAY_VBIASN VSS 0.11242p
C1422 REF_CLK VSS 3.19236f
C1423 DLL_RESETN VSS 4.2198f
C1424 VDD VSS 61.876f
C1425 a_26985_519# VSS 0.17928f ; **FLOATING
C1426 a_23945_519# VSS 0.17928f ; **FLOATING
C1427 a_20905_519# VSS 0.17928f ; **FLOATING
C1428 a_17865_519# VSS 0.17593f ; **FLOATING
C1429 a_16851_309# VSS 0.38699f ; **FLOATING
C1430 a_16108_289# VSS 3.85084f ; **FLOATING
C1431 a_15964_289# VSS 0.17613f ; **FLOATING
C1432 a_15765_463# VSS 0.36132f ; **FLOATING
C1433 a_14825_519# VSS 0.17928f ; **FLOATING
C1434 a_11785_519# VSS 0.17928f ; **FLOATING
C1435 a_8745_519# VSS 0.17928f ; **FLOATING
C1436 a_5731_289# VSS 3.39133f ; **FLOATING
C1437 a_2019_311# VSS 1.61601f ; **FLOATING
C1438 a_5705_519# VSS 0.17638f ; **FLOATING
C1439 a_3449_331# VSS 0.18478f ; **FLOATING
C1440 a_2873_331# VSS 0.18321f ; **FLOATING
C1441 a_2297_331# VSS 0.18321f ; **FLOATING
C1442 a_1721_331# VSS 0.17001f ; **FLOATING
C1443 a_1544_289# VSS 0.30014f ; **FLOATING
C1444 a_1256_289# VSS 0.84266f ; **FLOATING
C1445 a_27991_1008# VSS 0.18706f ; **FLOATING
C1446 a_27915_1044# VSS 0.10926f ; **FLOATING
C1447 a_27124_1008# VSS 0.17878f ; **FLOATING
C1448 a_27048_1044# VSS 0.12122f ; **FLOATING
C1449 a_26471_1008# VSS 0.18175f ; **FLOATING
C1450 a_26395_1044# VSS 0.11073f ; **FLOATING
C1451 a_25604_1008# VSS 0.18087f ; **FLOATING
C1452 a_25630_1044# VSS 0.34158f ; **FLOATING
C1453 a_25528_1044# VSS 0.12433f ; **FLOATING
C1454 a_24951_1008# VSS 0.18335f ; **FLOATING
C1455 a_24875_1044# VSS 0.11016f ; **FLOATING
C1456 a_24084_1008# VSS 0.17878f ; **FLOATING
C1457 a_24008_1044# VSS 0.12122f ; **FLOATING
C1458 a_23431_1008# VSS 0.18175f ; **FLOATING
C1459 a_23355_1044# VSS 0.11073f ; **FLOATING
C1460 a_22564_1008# VSS 0.18087f ; **FLOATING
C1461 a_22590_1044# VSS 0.33314f ; **FLOATING
C1462 a_22488_1044# VSS 0.12433f ; **FLOATING
C1463 a_21911_1008# VSS 0.18335f ; **FLOATING
C1464 a_21835_1044# VSS 0.11016f ; **FLOATING
C1465 a_21044_1008# VSS 0.17878f ; **FLOATING
C1466 a_20968_1044# VSS 0.12122f ; **FLOATING
C1467 a_20391_1008# VSS 0.18175f ; **FLOATING
C1468 a_20315_1044# VSS 0.11073f ; **FLOATING
C1469 a_19524_1008# VSS 0.18087f ; **FLOATING
C1470 a_19550_1044# VSS 0.33563f ; **FLOATING
C1471 a_19448_1044# VSS 0.12433f ; **FLOATING
C1472 a_18871_1008# VSS 0.18335f ; **FLOATING
C1473 a_18795_1044# VSS 0.11016f ; **FLOATING
C1474 a_18004_1008# VSS 0.17878f ; **FLOATING
C1475 a_17928_1044# VSS 0.12122f ; **FLOATING
C1476 a_17351_1008# VSS 0.18022f ; **FLOATING
C1477 a_17275_1044# VSS 0.10926f ; **FLOATING
C1478 a_16484_1008# VSS 0.18023f ; **FLOATING
C1479 a_16510_1044# VSS 0.28935f ; **FLOATING
C1480 a_16408_1044# VSS 0.1229f ; **FLOATING
C1481 a_15831_1008# VSS 0.17846f ; **FLOATING
C1482 a_15755_1044# VSS 0.10926f ; **FLOATING
C1483 a_14964_1008# VSS 0.17878f ; **FLOATING
C1484 a_14888_1044# VSS 0.12122f ; **FLOATING
C1485 a_14311_1008# VSS 0.18175f ; **FLOATING
C1486 a_14235_1044# VSS 0.11073f ; **FLOATING
C1487 a_13444_1008# VSS 0.18087f ; **FLOATING
C1488 a_13470_1044# VSS 0.30333f ; **FLOATING
C1489 a_13368_1044# VSS 0.12433f ; **FLOATING
C1490 a_12791_1008# VSS 0.18335f ; **FLOATING
C1491 a_12715_1044# VSS 0.11016f ; **FLOATING
C1492 a_11924_1008# VSS 0.17878f ; **FLOATING
C1493 a_11848_1044# VSS 0.12122f ; **FLOATING
C1494 a_11271_1008# VSS 0.18175f ; **FLOATING
C1495 a_11195_1044# VSS 0.11073f ; **FLOATING
C1496 a_10404_1008# VSS 0.18087f ; **FLOATING
C1497 a_10430_1044# VSS 0.31665f ; **FLOATING
C1498 a_10328_1044# VSS 0.12433f ; **FLOATING
C1499 a_9751_1008# VSS 0.18335f ; **FLOATING
C1500 a_9675_1044# VSS 0.11016f ; **FLOATING
C1501 a_8884_1008# VSS 0.17878f ; **FLOATING
C1502 a_8808_1044# VSS 0.12122f ; **FLOATING
C1503 a_8231_1008# VSS 0.18175f ; **FLOATING
C1504 a_8155_1044# VSS 0.11073f ; **FLOATING
C1505 a_7364_1008# VSS 0.18087f ; **FLOATING
C1506 a_7390_1044# VSS 0.31357f ; **FLOATING
C1507 a_7288_1044# VSS 0.12433f ; **FLOATING
C1508 a_6711_1008# VSS 0.18335f ; **FLOATING
C1509 a_6635_1044# VSS 0.11016f ; **FLOATING
C1510 a_5844_1008# VSS 0.17878f ; **FLOATING
C1511 a_5768_1044# VSS 0.12122f ; **FLOATING
C1512 a_5191_1008# VSS 0.18022f ; **FLOATING
C1513 a_5115_1044# VSS 0.10926f ; **FLOATING
C1514 a_4324_1008# VSS 0.18023f ; **FLOATING
C1515 a_4350_1044# VSS 0.26655f ; **FLOATING
C1516 a_4248_1044# VSS 0.12443f ; **FLOATING
C1517 a_27705_1044# VSS 0.25297f ; **FLOATING
C1518 a_26185_1044# VSS 0.23475f ; **FLOATING
C1519 a_24665_1044# VSS 0.25433f ; **FLOATING
C1520 a_23145_1044# VSS 0.23475f ; **FLOATING
C1521 a_21625_1044# VSS 0.25433f ; **FLOATING
C1522 a_20105_1044# VSS 0.23475f ; **FLOATING
C1523 a_18585_1044# VSS 0.25433f ; **FLOATING
C1524 a_17065_1044# VSS 0.23386f ; **FLOATING
C1525 a_15545_1044# VSS 0.25297f ; **FLOATING
C1526 a_14025_1044# VSS 0.23475f ; **FLOATING
C1527 a_12505_1044# VSS 0.25433f ; **FLOATING
C1528 a_10985_1044# VSS 0.23475f ; **FLOATING
C1529 a_9465_1044# VSS 0.25433f ; **FLOATING
C1530 a_7945_1044# VSS 0.23475f ; **FLOATING
C1531 a_6425_1044# VSS 0.25433f ; **FLOATING
C1532 a_4905_1044# VSS 0.23549f ; **FLOATING
C1533 a_4157_1313# VSS 0.32875f ; **FLOATING
C1534 a_3449_1395# VSS 0.18629f ; **FLOATING
C1535 a_2873_1395# VSS 0.18349f ; **FLOATING
C1536 a_2297_1395# VSS 0.18349f ; **FLOATING
C1537 a_1721_1395# VSS 0.17029f ; **FLOATING
C1538 a_1544_1044# VSS 0.29829f ; **FLOATING
C1539 a_1256_1044# VSS 0.82974f ; **FLOATING
C1540 a_27671_1842# VSS 0.01336f ; **FLOATING
C1541 a_26911_1842# VSS 0.01336f ; **FLOATING
C1542 a_26151_1842# VSS 0.01336f ; **FLOATING
C1543 a_25391_1842# VSS 0.01336f ; **FLOATING
C1544 a_24631_1842# VSS 0.01336f ; **FLOATING
C1545 a_23871_1842# VSS 0.01336f ; **FLOATING
C1546 a_23111_1842# VSS 0.01336f ; **FLOATING
C1547 a_22351_1842# VSS 0.01336f ; **FLOATING
C1548 a_21591_1842# VSS 0.01336f ; **FLOATING
C1549 a_20831_1842# VSS 0.01336f ; **FLOATING
C1550 a_20071_1842# VSS 0.01336f ; **FLOATING
C1551 a_19311_1842# VSS 0.01336f ; **FLOATING
C1552 a_18551_1842# VSS 0.01336f ; **FLOATING
C1553 a_17791_1842# VSS 0.01336f ; **FLOATING
C1554 a_17031_1842# VSS 0.01336f ; **FLOATING
C1555 a_16271_1842# VSS 0.01336f ; **FLOATING
C1556 a_15511_1842# VSS 0.01336f ; **FLOATING
C1557 a_14751_1842# VSS 0.01336f ; **FLOATING
C1558 a_13991_1842# VSS 0.01336f ; **FLOATING
C1559 a_13231_1842# VSS 0.01336f ; **FLOATING
C1560 a_12471_1842# VSS 0.01336f ; **FLOATING
C1561 a_11711_1842# VSS 0.01336f ; **FLOATING
C1562 a_10951_1842# VSS 0.01336f ; **FLOATING
C1563 a_10191_1842# VSS 0.01336f ; **FLOATING
C1564 a_9431_1842# VSS 0.01336f ; **FLOATING
C1565 a_8671_1842# VSS 0.01336f ; **FLOATING
C1566 a_7911_1842# VSS 0.01336f ; **FLOATING
C1567 a_7151_1842# VSS 0.01336f ; **FLOATING
C1568 a_6391_1842# VSS 0.01336f ; **FLOATING
C1569 a_5631_1842# VSS 0.01336f ; **FLOATING
C1570 a_4871_1842# VSS 0.01336f ; **FLOATING
C1571 a_4111_1842# VSS 0.0139f ; **FLOATING
C1572 a_27563_1842# VSS 0.50316f ; **FLOATING
C1573 a_27997_1842# VSS 0.6484f ; **FLOATING
C1574 a_27433_1842# VSS 0.4463f ; **FLOATING
C1575 a_26803_1842# VSS 0.49934f ; **FLOATING
C1576 a_27237_1842# VSS 0.92967f ; **FLOATING
C1577 a_26673_1842# VSS 0.4492f ; **FLOATING
C1578 a_26043_1842# VSS 0.50169f ; **FLOATING
C1579 a_26477_1842# VSS 0.95928f ; **FLOATING
C1580 a_25913_1842# VSS 0.4508f ; **FLOATING
C1581 a_25283_1842# VSS 0.49938f ; **FLOATING
C1582 a_25717_1842# VSS 0.86841f ; **FLOATING
C1583 a_25153_1842# VSS 0.45035f ; **FLOATING
C1584 a_24523_1842# VSS 0.50075f ; **FLOATING
C1585 a_24957_1842# VSS 0.96341f ; **FLOATING
C1586 a_24393_1842# VSS 0.4463f ; **FLOATING
C1587 a_23763_1842# VSS 0.49934f ; **FLOATING
C1588 a_24197_1842# VSS 0.92543f ; **FLOATING
C1589 a_23633_1842# VSS 0.45062f ; **FLOATING
C1590 a_23003_1842# VSS 0.50169f ; **FLOATING
C1591 a_23437_1842# VSS 0.95769f ; **FLOATING
C1592 a_22873_1842# VSS 0.4508f ; **FLOATING
C1593 a_22243_1842# VSS 0.49938f ; **FLOATING
C1594 a_22677_1842# VSS 0.86841f ; **FLOATING
C1595 a_22113_1842# VSS 0.45249f ; **FLOATING
C1596 a_21483_1842# VSS 0.50075f ; **FLOATING
C1597 a_21917_1842# VSS 0.96341f ; **FLOATING
C1598 a_21353_1842# VSS 0.4463f ; **FLOATING
C1599 a_20723_1842# VSS 0.49992f ; **FLOATING
C1600 a_21157_1842# VSS 0.92543f ; **FLOATING
C1601 a_20593_1842# VSS 0.45196f ; **FLOATING
C1602 a_19963_1842# VSS 0.50169f ; **FLOATING
C1603 a_20397_1842# VSS 0.95769f ; **FLOATING
C1604 a_19833_1842# VSS 0.4508f ; **FLOATING
C1605 a_19203_1842# VSS 0.5005f ; **FLOATING
C1606 a_19637_1842# VSS 0.86841f ; **FLOATING
C1607 a_19073_1842# VSS 0.44947f ; **FLOATING
C1608 a_18443_1842# VSS 0.50075f ; **FLOATING
C1609 a_18877_1842# VSS 0.96341f ; **FLOATING
C1610 a_18313_1842# VSS 0.4463f ; **FLOATING
C1611 a_17683_1842# VSS 0.50046f ; **FLOATING
C1612 a_18117_1842# VSS 0.92543f ; **FLOATING
C1613 a_17553_1842# VSS 0.44782f ; **FLOATING
C1614 a_16923_1842# VSS 0.50165f ; **FLOATING
C1615 a_17357_1842# VSS 0.95769f ; **FLOATING
C1616 a_16793_1842# VSS 0.45049f ; **FLOATING
C1617 a_16163_1842# VSS 0.4946f ; **FLOATING
C1618 a_16597_1842# VSS 0.86359f ; **FLOATING
C1619 a_16033_1842# VSS 0.44618f ; **FLOATING
C1620 a_15403_1842# VSS 0.49465f ; **FLOATING
C1621 a_15837_1842# VSS 0.95171f ; **FLOATING
C1622 a_15273_1842# VSS 0.44439f ; **FLOATING
C1623 a_14643_1842# VSS 0.49305f ; **FLOATING
C1624 a_15077_1842# VSS 0.92116f ; **FLOATING
C1625 a_14513_1842# VSS 0.44501f ; **FLOATING
C1626 a_13883_1842# VSS 0.50862f ; **FLOATING
C1627 a_14317_1842# VSS 0.96009f ; **FLOATING
C1628 a_13753_1842# VSS 0.46427f ; **FLOATING
C1629 a_13123_1842# VSS 0.50173f ; **FLOATING
C1630 a_13557_1842# VSS 0.87587f ; **FLOATING
C1631 a_12993_1842# VSS 0.45643f ; **FLOATING
C1632 a_12363_1842# VSS 0.50854f ; **FLOATING
C1633 a_12797_1842# VSS 0.96142f ; **FLOATING
C1634 a_12233_1842# VSS 0.45757f ; **FLOATING
C1635 a_11603_1842# VSS 0.50267f ; **FLOATING
C1636 a_12037_1842# VSS 0.92866f ; **FLOATING
C1637 a_11473_1842# VSS 0.45177f ; **FLOATING
C1638 a_10843_1842# VSS 0.50491f ; **FLOATING
C1639 a_11277_1842# VSS 0.96053f ; **FLOATING
C1640 a_10713_1842# VSS 0.44901f ; **FLOATING
C1641 a_10083_1842# VSS 0.50223f ; **FLOATING
C1642 a_10517_1842# VSS 0.87053f ; **FLOATING
C1643 a_9953_1842# VSS 0.44673f ; **FLOATING
C1644 a_9323_1842# VSS 0.5026f ; **FLOATING
C1645 a_9757_1842# VSS 0.96312f ; **FLOATING
C1646 a_9193_1842# VSS 0.44361f ; **FLOATING
C1647 a_8563_1842# VSS 0.49203f ; **FLOATING
C1648 a_8997_1842# VSS 0.92196f ; **FLOATING
C1649 a_8433_1842# VSS 0.44439f ; **FLOATING
C1650 a_7803_1842# VSS 0.49435f ; **FLOATING
C1651 a_8237_1842# VSS 0.95422f ; **FLOATING
C1652 a_7673_1842# VSS 0.44737f ; **FLOATING
C1653 a_7043_1842# VSS 0.49204f ; **FLOATING
C1654 a_7477_1842# VSS 0.86493f ; **FLOATING
C1655 a_6913_1842# VSS 0.44442f ; **FLOATING
C1656 a_6283_1842# VSS 0.49343f ; **FLOATING
C1657 a_6717_1842# VSS 0.95763f ; **FLOATING
C1658 a_6153_1842# VSS 0.44292f ; **FLOATING
C1659 a_5523_1842# VSS 0.50322f ; **FLOATING
C1660 a_5957_1842# VSS 0.92646f ; **FLOATING
C1661 a_5393_1842# VSS 0.4596f ; **FLOATING
C1662 a_4763_1842# VSS 0.51043f ; **FLOATING
C1663 a_5197_1842# VSS 0.96509f ; **FLOATING
C1664 a_4633_1842# VSS 0.46282f ; **FLOATING
C1665 a_4003_1842# VSS 0.58808f ; **FLOATING
C1666 a_4437_1842# VSS 0.87628f ; **FLOATING
C1667 a_9712_3912# VSS 1.52086f ; **FLOATING
C1668 a_9444_3912# VSS 2.12877f ; **FLOATING
C1669 a_5778_3367# VSS 5.22809f ; **FLOATING
C1670 a_15464_3684# VSS 0.75391f ; **FLOATING
C1671 a_14757_5182# VSS 0.09495f ; **FLOATING
C1672 a_13880_5118# VSS 0.06985f ; **FLOATING
C1673 a_15688_5403# VSS 0.26291f ; **FLOATING
C1674 a_15108_5325# VSS 0.24458f ; **FLOATING
C1675 a_14851_5182# VSS 0.38123f ; **FLOATING
C1676 a_9444_4590# VSS 6.08222f ; **FLOATING
C1677 a_14111_5227# VSS 0.19866f ; **FLOATING
C1678 a_14009_5084# VSS 0.44622f ; **FLOATING
C1679 a_13592_5423# VSS 1.57456f ; **FLOATING
C1680 a_13306_5105# VSS 0.30095f ; **FLOATING
C1681 a_13566_5328# VSS 0.15441f ; **FLOATING
C1682 a_13132_5420# VSS 0.13036f ; **FLOATING
C1683 a_12907_5420# VSS 0.14377f ; **FLOATING
C1684 a_12907_5186# VSS 0.14861f ; **FLOATING
C1685 a_13106_5357# VSS 0.06343f ; **FLOATING
C1686 a_15304_4605# VSS 0.37009f ; **FLOATING
C1687 a_14757_6228# VSS 0.09586f ; **FLOATING
C1688 a_15688_5867# VSS 0.26405f ; **FLOATING
C1689 a_14851_6228# VSS 0.39588f ; **FLOATING
C1690 a_15108_6109# VSS 0.24582f ; **FLOATING
C1691 a_14111_5878# VSS 0.21915f ; **FLOATING
C1692 a_13880_6292# VSS 0.07345f ; **FLOATING
C1693 a_14009_5878# VSS 0.48187f ; **FLOATING
C1694 a_13592_5871# VSS 1.58208f ; **FLOATING
C1695 a_13566_5835# VSS 0.15442f ; **FLOATING
C1696 a_13045_6215# VSS 0.01124f ; **FLOATING
C1697 a_13306_6305# VSS 0.31701f ; **FLOATING
C1698 a_12849_5867# VSS 1.40248f ; **FLOATING
C1699 a_13121_5831# VSS 0.80439f ; **FLOATING
C1700 a_13019_5831# VSS 2.18715f ; **FLOATING
C1701 a_12656_5864# VSS 0.28393f ; **FLOATING
C1702 a_12355_5867# VSS 0.62262f ; **FLOATING
C1703 a_11397_6228# VSS 0.09495f ; **FLOATING
C1704 a_12158_5867# VSS 0.25874f ; **FLOATING
C1705 a_11491_6228# VSS 0.30073f ; **FLOATING
C1706 a_11748_6109# VSS 0.17021f ; **FLOATING
C1707 a_10751_5878# VSS 0.19918f ; **FLOATING
C1708 a_10520_6292# VSS 0.03671f ; **FLOATING
C1709 a_10649_5878# VSS 0.47308f ; **FLOATING
C1710 a_10232_5871# VSS 1.52123f ; **FLOATING
C1711 a_10206_5835# VSS 0.08466f ; **FLOATING
C1712 a_9946_6305# VSS 0.18126f ; **FLOATING
C1713 a_9772_5843# VSS 0.12435f ; **FLOATING
C1714 a_9746_5805# VSS 0.06613f ; **FLOATING
C1715 a_9547_6172# VSS 0.16037f ; **FLOATING
C1716 a_9547_5942# VSS 0.11966f ; **FLOATING
C1717 a_6854_5454# VSS 3.66026f ; **FLOATING
C1718 a_6126_3816# VSS 13.6177f ; **FLOATING
C1719 a_6854_5986# VSS 1.21519f ; **FLOATING
C1720 a_5974_5723# VSS 2.40124f ; **FLOATING
C1721 a_6326_4590# VSS 1.03474f ; **FLOATING
C1722 a_2019_1047.t2 VSS 0.93027f ; **FLOATING
C1723 a_2019_1047.t3 VSS 0.70623f ; **FLOATING
C1724 a_2019_1047.n0 VSS 5.00884f ; **FLOATING
C1725 a_2019_1047.t4 VSS 0.70623f ; **FLOATING
C1726 a_2019_1047.n1 VSS 3.38862f ; **FLOATING
C1727 a_2019_1047.t5 VSS 0.70623f ; **FLOATING
C1728 a_2019_1047.n2 VSS 3.38862f ; **FLOATING
C1729 a_2019_1047.t6 VSS 0.70623f ; **FLOATING
C1730 a_2019_1047.n3 VSS 3.38862f ; **FLOATING
C1731 a_2019_1047.t7 VSS 0.70623f ; **FLOATING
C1732 a_2019_1047.n4 VSS 3.38862f ; **FLOATING
C1733 a_2019_1047.t8 VSS 0.70623f ; **FLOATING
C1734 a_2019_1047.n5 VSS 3.38862f ; **FLOATING
C1735 a_2019_1047.t9 VSS 5.45485f ; **FLOATING
C1736 a_2019_1047.t1 VSS 1.07257f ; **FLOATING
C1737 a_2019_1047.t0 VSS 0.30486f ; **FLOATING
C1738 a_2595_1047.t2 VSS 1.36703f ; **FLOATING
C1739 a_2595_1047.t3 VSS 1.02094f ; **FLOATING
C1740 a_2595_1047.n0 VSS 7.76124f ; **FLOATING
C1741 a_2595_1047.t4 VSS 1.02094f ; **FLOATING
C1742 a_2595_1047.n1 VSS 5.2734f ; **FLOATING
C1743 a_2595_1047.t5 VSS 1.02094f ; **FLOATING
C1744 a_2595_1047.n2 VSS 5.2734f ; **FLOATING
C1745 a_2595_1047.t6 VSS 1.02094f ; **FLOATING
C1746 a_2595_1047.n3 VSS 5.2734f ; **FLOATING
C1747 a_2595_1047.t7 VSS 1.02094f ; **FLOATING
C1748 a_2595_1047.n4 VSS 5.2734f ; **FLOATING
C1749 a_2595_1047.t8 VSS 1.02094f ; **FLOATING
C1750 a_2595_1047.n5 VSS 5.2734f ; **FLOATING
C1751 a_2595_1047.t9 VSS 1.02094f ; **FLOATING
C1752 a_2595_1047.n6 VSS 7.58547f ; **FLOATING
C1753 a_2595_1047.t1 VSS 1.75119f ; **FLOATING
C1754 a_2595_1047.t0 VSS 0.48227f ; **FLOATING
C1755 a_3171_1047.t2 VSS 1.38443f ; **FLOATING
C1756 a_3171_1047.t3 VSS 1.03734f ; **FLOATING
C1757 a_3171_1047.n0 VSS 7.7786f ; **FLOATING
C1758 a_3171_1047.t4 VSS 1.03734f ; **FLOATING
C1759 a_3171_1047.n1 VSS 5.28085f ; **FLOATING
C1760 a_3171_1047.t5 VSS 1.03734f ; **FLOATING
C1761 a_3171_1047.n2 VSS 5.28085f ; **FLOATING
C1762 a_3171_1047.t6 VSS 1.03734f ; **FLOATING
C1763 a_3171_1047.n3 VSS 5.28085f ; **FLOATING
C1764 a_3171_1047.t7 VSS 1.03734f ; **FLOATING
C1765 a_3171_1047.n4 VSS 5.28085f ; **FLOATING
C1766 a_3171_1047.t8 VSS 1.03734f ; **FLOATING
C1767 a_3171_1047.n5 VSS 5.28085f ; **FLOATING
C1768 a_3171_1047.t9 VSS 1.03734f ; **FLOATING
C1769 a_3171_1047.n6 VSS 7.68351f ; **FLOATING
C1770 a_3171_1047.t1 VSS 1.77027f ; **FLOATING
C1771 a_3171_1047.t0 VSS 0.48084f ; **FLOATING
C1772 a_3747_1047.t2 VSS 0.96887f ; **FLOATING
C1773 a_3747_1047.t3 VSS 0.73761f ; **FLOATING
C1774 a_3747_1047.n0 VSS 5.16757f ; **FLOATING
C1775 a_3747_1047.t4 VSS 0.73761f ; **FLOATING
C1776 a_3747_1047.n1 VSS 3.49321f ; **FLOATING
C1777 a_3747_1047.t5 VSS 0.73761f ; **FLOATING
C1778 a_3747_1047.n2 VSS 3.49321f ; **FLOATING
C1779 a_3747_1047.t6 VSS 0.73761f ; **FLOATING
C1780 a_3747_1047.n3 VSS 3.49321f ; **FLOATING
C1781 a_3747_1047.t7 VSS 0.73761f ; **FLOATING
C1782 a_3747_1047.n4 VSS 3.49321f ; **FLOATING
C1783 a_3747_1047.t8 VSS 0.73761f ; **FLOATING
C1784 a_3747_1047.n5 VSS 3.49321f ; **FLOATING
C1785 a_3747_1047.t9 VSS 0.73761f ; **FLOATING
C1786 a_3747_1047.n6 VSS 5.18701f ; **FLOATING
C1787 a_3747_1047.t1 VSS 1.18538f ; **FLOATING
C1788 a_3747_1047.t0 VSS 0.31338f ; **FLOATING
C1789 a_2595_311.t1 VSS 3.27037f ; **FLOATING
C1790 a_2595_311.t2 VSS 5.04145f ; **FLOATING
C1791 a_2595_311.t3 VSS 1.20632f ; **FLOATING
C1792 a_2595_311.n0 VSS 26.8668f ; **FLOATING
C1793 a_2595_311.t0 VSS 0.49572f ; **FLOATING
C1794 a_3171_311.t2 VSS 5.05009f ; **FLOATING
C1795 a_3171_311.t3 VSS 1.21149f ; **FLOATING
C1796 a_3171_311.n0 VSS 29.8499f ; **FLOATING
C1797 a_3171_311.t1 VSS 4.61154f ; **FLOATING
C1798 a_3171_311.t0 VSS 0.4973f ; **FLOATING
C1799 a_3747_311.t2 VSS 3.09202f ; **FLOATING
C1800 a_3747_311.t3 VSS 0.74422f ; **FLOATING
C1801 a_3747_311.n0 VSS 19.8885f ; **FLOATING
C1802 a_3747_311.t1 VSS 3.68892f ; **FLOATING
C1803 a_3747_311.t0 VSS 0.30537f ; **FLOATING
C1804 VSS.t90 VSS 3.22049f ; **FLOATING
C1805 VDD.n0 VSS 0.03677f ; **FLOATING
C1806 VDD.n1 VSS 1.12845f ; **FLOATING
C1807 VDD.n2 VSS 0.03006f ; **FLOATING
C1808 VDD.n3 VSS 0.46891f ; **FLOATING
C1809 VDD.n4 VSS 0.04223f ; **FLOATING
C1810 VDD.t36 VSS 49.9272f ; **FLOATING
C1811 VDD.n5 VSS 0.46891f ; **FLOATING
C1812 VDD.n6 VSS 0.46891f ; **FLOATING
C1813 VDD.n7 VSS 0.04223f ; **FLOATING
C1814 VDD.n8 VSS 0.46891f ; **FLOATING
C1815 VDD.n9 VSS 0.46891f ; **FLOATING
C1816 VDD.n10 VSS 0.46891f ; **FLOATING
C1817 VDD.n11 VSS 0.07686f ; **FLOATING
C1818 VDD.n12 VSS 0.40404f ; **FLOATING
C1819 VDD.n14 VSS 0.36478f ; **FLOATING
C1820 VDD.n16 VSS 0.44734f ; **FLOATING
C1821 VDD.n17 VSS 0.13601f ; **FLOATING
C1822 VDD.n18 VSS 0.44734f ; **FLOATING
C1823 VDD.n19 VSS 0.13601f ; **FLOATING
C1824 VDD.n20 VSS 0.44734f ; **FLOATING
C1825 VDD.n22 VSS 0.44734f ; **FLOATING
C1826 VDD.n23 VSS 0.13601f ; **FLOATING
C1827 VDD.n24 VSS 0.44734f ; **FLOATING
C1828 VDD.n25 VSS 0.13601f ; **FLOATING
C1829 VDD.n26 VSS 0.44734f ; **FLOATING
C1830 VDD.n27 VSS 0.26258f ; **FLOATING
C1831 VDD.n28 VSS 0.22975f ; **FLOATING
C1832 VDD.n30 VSS 1.61338f ; **FLOATING
C1833 VDD.t25 VSS 43.7538f ; **FLOATING
C1834 VDD.n31 VSS 0.06199f ; **FLOATING
C1835 VDD.n32 VSS 0.13601f ; **FLOATING
C1836 VDD.n33 VSS 0.13601f ; **FLOATING
C1837 VDD.n34 VSS 0.03109f ; **FLOATING
C1838 VDD.t17 VSS 0.0187f ; **FLOATING
C1839 VDD.n35 VSS 0.02521f ; **FLOATING
C1840 VDD.n36 VSS 0.07728f ; **FLOATING
C1841 VDD.n37 VSS 0.0214f ; **FLOATING
C1842 VDD.n38 VSS 0.02357f ; **FLOATING
C1843 VDD.n39 VSS 0.01579f ; **FLOATING
C1844 VDD.n40 VSS 0.1023f ; **FLOATING
C1845 VDD.n42 VSS 0.15084f ; **FLOATING
C1846 VDD.n43 VSS 0.01387f ; **FLOATING
C1847 VDD.n44 VSS 0.06543f ; **FLOATING
C1848 VDD.n45 VSS 0.08545f ; **FLOATING
C1849 VDD.n47 VSS 0.08436f ; **FLOATING
C1850 VDD.n48 VSS 0.05911f ; **FLOATING
C1851 VDD.n49 VSS 0.05911f ; **FLOATING
C1852 VDD.n50 VSS 0.08436f ; **FLOATING
C1853 VDD.n51 VSS 0.05911f ; **FLOATING
C1854 VDD.n52 VSS 0.05911f ; **FLOATING
C1855 VDD.n53 VSS 0.08436f ; **FLOATING
C1856 VDD.n54 VSS 0.05911f ; **FLOATING
C1857 VDD.n55 VSS 0.05911f ; **FLOATING
C1858 VDD.n56 VSS 0.0401f ; **FLOATING
C1859 VDD.n57 VSS 0.02073f ; **FLOATING
C1860 VDD.n58 VSS 0.14214f ; **FLOATING
C1861 VDD.n59 VSS 0.0409f ; **FLOATING
C1862 VDD.n60 VSS 0.01023f ; **FLOATING
C1863 VDD.n61 VSS 0.02577f ; **FLOATING
C1864 VDD.n62 VSS 0.03847f ; **FLOATING
C1865 VDD.n63 VSS 0.02115f ; **FLOATING
C1866 VDD.n64 VSS 0.01579f ; **FLOATING
C1867 VDD.n65 VSS 0.10657f ; **FLOATING
C1868 VDD.n66 VSS 0.05152f ; **FLOATING
C1869 VDD.n67 VSS 0.20413f ; **FLOATING
C1870 VDD.n68 VSS 0.05911f ; **FLOATING
C1871 VDD.n69 VSS 0.05622f ; **FLOATING
C1872 VDD.n70 VSS 0.03174f ; **FLOATING
C1873 VDD.n71 VSS 0.07372f ; **FLOATING
C1874 VDD.n72 VSS 0.01697f ; **FLOATING
C1875 VDD.n73 VSS 0.15122f ; **FLOATING
C1876 VDD.n74 VSS 0.03162f ; **FLOATING
C1877 VDD.n75 VSS 0.03568f ; **FLOATING
C1878 VDD.n76 VSS 0.13358f ; **FLOATING
C1879 VDD.n78 VSS 0.08629f ; **FLOATING
C1880 VDD.n79 VSS 0.13358f ; **FLOATING
C1881 VDD.n80 VSS 0.08629f ; **FLOATING
C1882 VDD.n82 VSS 0.13358f ; **FLOATING
C1883 VDD.n83 VSS 0.08629f ; **FLOATING
C1884 VDD.n85 VSS 0.02633f ; **FLOATING
C1885 VDD.n86 VSS 0.09631f ; **FLOATING
C1886 VDD.n87 VSS 0.13358f ; **FLOATING
C1887 VDD.n88 VSS 0.08629f ; **FLOATING
C1888 VDD.n90 VSS 0.13358f ; **FLOATING
C1889 VDD.n91 VSS 0.08629f ; **FLOATING
C1890 VDD.n93 VSS 0.13358f ; **FLOATING
C1891 VDD.n94 VSS 0.08629f ; **FLOATING
C1892 VDD.n96 VSS 0.08436f ; **FLOATING
C1893 VDD.n97 VSS 0.08436f ; **FLOATING
C1894 VDD.n98 VSS 0.08436f ; **FLOATING
C1895 VDD.n99 VSS 0.03062f ; **FLOATING
C1896 VDD.n100 VSS 0.01587f ; **FLOATING
C1897 VDD.n101 VSS 0.1004f ; **FLOATING
C1898 VDD.n102 VSS 0.04223f ; **FLOATING
C1899 VDD.n103 VSS 0.04223f ; **FLOATING
C1900 VDD.n104 VSS 0.04223f ; **FLOATING
C1901 VDD.n105 VSS 0.04223f ; **FLOATING
C1902 VDD.n106 VSS 0.13178f ; **FLOATING
C1903 VDD.t58 VSS 8.2706f ; **FLOATING
C1904 VDD.t97 VSS 0.03686f ; **FLOATING
C1905 VDD.t203 VSS 0.03686f ; **FLOATING
C1906 VDD.n107 VSS 0.12588f ; **FLOATING
C1907 VDD.n108 VSS 0.01583f ; **FLOATING
C1908 VDD.t297 VSS 0.04458f ; **FLOATING
C1909 VDD.t201 VSS 0.04458f ; **FLOATING
C1910 VDD.n109 VSS 0.14195f ; **FLOATING
C1911 VDD.n110 VSS 0.07513f ; **FLOATING
C1912 VDD.t15 VSS 0.03178f ; **FLOATING
C1913 VDD.n111 VSS 0.02157f ; **FLOATING
C1914 VDD.t13 VSS 0.02294f ; **FLOATING
C1915 VDD.t16 VSS 0.03552f ; **FLOATING
C1916 VDD.t18 VSS 0.03178f ; **FLOATING
C1917 VDD.t263 VSS 0.03178f ; **FLOATING
C1918 VDD.t20 VSS 0.03178f ; **FLOATING
C1919 VDD.n112 VSS 0.02157f ; **FLOATING
C1920 VDD.t19 VSS 0.02294f ; **FLOATING
C1921 VDD.t21 VSS 0.03552f ; **FLOATING
C1922 VDD.n113 VSS 0.01805f ; **FLOATING
C1923 VDD.t22 VSS 0.01871f ; **FLOATING
C1924 VDD.t23 VSS 0.03178f ; **FLOATING
C1925 VDD.n114 VSS 0.01895f ; **FLOATING
C1926 VDD.t328 VSS 0.03489f ; **FLOATING
C1927 VDD.t132 VSS 0.02373f ; **FLOATING
C1928 VDD.n115 VSS 0.11939f ; **FLOATING
C1929 VDD.t14 VSS 3.33549f ; **FLOATING
C1930 VDD.n116 VSS 0.64947f ; **FLOATING
C1931 VDD.n117 VSS 0.11552f ; **FLOATING
C1932 VDD.n118 VSS 0.02729f ; **FLOATING
C1933 VDD.t219 VSS 0.02621f ; **FLOATING
C1934 VDD.t57 VSS 0.02621f ; **FLOATING
C1935 VDD.n119 VSS 0.07782f ; **FLOATING
C1936 VDD.n120 VSS 0.03693f ; **FLOATING
C1937 VDD.t235 VSS 0.01216f ; **FLOATING
C1938 VDD.t365 VSS 0.06048f ; **FLOATING
C1939 VDD.n121 VSS 0.0245f ; **FLOATING
C1940 VDD.t308 VSS 0.01216f ; **FLOATING
C1941 VDD.t59 VSS 0.06048f ; **FLOATING
C1942 VDD.n122 VSS 0.0245f ; **FLOATING
C1943 VDD.n123 VSS 0.05408f ; **FLOATING
C1944 VDD.n124 VSS 0.01438f ; **FLOATING
C1945 VDD.t55 VSS 0.03563f ; **FLOATING
C1946 VDD.n125 VSS 0.06406f ; **FLOATING
C1947 VDD.n126 VSS 0.03523f ; **FLOATING
C1948 VDD.t131 VSS 0.0329f ; **FLOATING
C1949 VDD.n127 VSS 0.07634f ; **FLOATING
C1950 VDD.n128 VSS 0.02009f ; **FLOATING
C1951 VDD.t66 VSS 0.03686f ; **FLOATING
C1952 VDD.n129 VSS 0.16471f ; **FLOATING
C1953 VDD.t153 VSS 0.01216f ; **FLOATING
C1954 VDD.t86 VSS 0.06048f ; **FLOATING
C1955 VDD.n130 VSS 0.0245f ; **FLOATING
C1956 VDD.t128 VSS 0.02621f ; **FLOATING
C1957 VDD.n131 VSS 0.14752f ; **FLOATING
C1958 VDD.n132 VSS 0.03695f ; **FLOATING
C1959 VDD.n133 VSS 0.01473f ; **FLOATING
C1960 VDD.n134 VSS 0.07152f ; **FLOATING
C1961 VDD.n135 VSS 0.71808f ; **FLOATING
C1962 VDD.t284 VSS 0.0329f ; **FLOATING
C1963 VDD.t134 VSS 0.0329f ; **FLOATING
C1964 VDD.t340 VSS 0.02954f ; **FLOATING
C1965 VDD.t108 VSS 0.0329f ; **FLOATING
C1966 VDD.n136 VSS 0.02717f ; **FLOATING
C1967 VDD.t114 VSS 0.04318f ; **FLOATING
C1968 VDD.n137 VSS 0.08282f ; **FLOATING
C1969 VDD.n138 VSS 0.02423f ; **FLOATING
C1970 VDD.t378 VSS 0.0329f ; **FLOATING
C1971 VDD.n139 VSS 0.07852f ; **FLOATING
C1972 VDD.n140 VSS 0.01153f ; **FLOATING
C1973 VDD.t174 VSS 0.03667f ; **FLOATING
C1974 VDD.t91 VSS 0.03667f ; **FLOATING
C1975 VDD.t78 VSS 0.03667f ; **FLOATING
C1976 VDD.t157 VSS 0.03667f ; **FLOATING
C1977 VDD.t287 VSS 0.0329f ; **FLOATING
C1978 VDD.t359 VSS 0.0329f ; **FLOATING
C1979 VDD.n141 VSS 0.09517f ; **FLOATING
C1980 VDD.n142 VSS 0.01506f ; **FLOATING
C1981 VDD.t122 VSS 0.0243f ; **FLOATING
C1982 VDD.t367 VSS 0.0243f ; **FLOATING
C1983 VDD.n143 VSS 0.08391f ; **FLOATING
C1984 VDD.t77 VSS 0.03248f ; **FLOATING
C1985 VDD.t156 VSS 0.03248f ; **FLOATING
C1986 VDD.t285 VSS 0.0243f ; **FLOATING
C1987 VDD.t135 VSS 0.0243f ; **FLOATING
C1988 VDD.t100 VSS 0.03248f ; **FLOATING
C1989 VDD.t90 VSS 0.03248f ; **FLOATING
C1990 VDD.t288 VSS 0.0243f ; **FLOATING
C1991 VDD.t360 VSS 0.0243f ; **FLOATING
C1992 VDD.t123 VSS 0.03248f ; **FLOATING
C1993 VDD.t346 VSS 0.03248f ; **FLOATING
C1994 VDD.n144 VSS 0.07665f ; **FLOATING
C1995 VDD.t155 VSS 0.03667f ; **FLOATING
C1996 VDD.t347 VSS 0.03667f ; **FLOATING
C1997 VDD.t286 VSS 0.0243f ; **FLOATING
C1998 VDD.t136 VSS 0.0243f ; **FLOATING
C1999 VDD.t226 VSS 0.03248f ; **FLOATING
C2000 VDD.t361 VSS 0.03248f ; **FLOATING
C2001 VDD.n145 VSS 0.06967f ; **FLOATING
C2002 VDD.t227 VSS 0.03667f ; **FLOATING
C2003 VDD.t374 VSS 0.03667f ; **FLOATING
C2004 VDD.n146 VSS 0.08757f ; **FLOATING
C2005 VDD.n147 VSS 0.01175f ; **FLOATING
C2006 VDD.t152 VSS 0.0329f ; **FLOATING
C2007 VDD.t117 VSS 0.03301f ; **FLOATING
C2008 VDD.t248 VSS 0.0329f ; **FLOATING
C2009 VDD.n148 VSS 0.06893f ; **FLOATING
C2010 VDD.n149 VSS 0.01294f ; **FLOATING
C2011 VDD.t177 VSS 0.0329f ; **FLOATING
C2012 VDD.t295 VSS 0.0329f ; **FLOATING
C2013 VDD.t349 VSS 0.0329f ; **FLOATING
C2014 VDD.t159 VSS 0.02954f ; **FLOATING
C2015 VDD.t164 VSS 0.02954f ; **FLOATING
C2016 VDD.t329 VSS 0.0329f ; **FLOATING
C2017 VDD.t407 VSS 0.10912f ; **FLOATING
C2018 VDD.t158 VSS 0.03171f ; **FLOATING
C2019 VDD.t194 VSS 0.04318f ; **FLOATING
C2020 VDD.t406 VSS 0.10912f ; **FLOATING
C2021 VDD.t137 VSS 0.03171f ; **FLOATING
C2022 VDD.t167 VSS 0.0329f ; **FLOATING
C2023 VDD.t138 VSS 0.02954f ; **FLOATING
C2024 VDD.t139 VSS 0.02954f ; **FLOATING
C2025 VDD.t142 VSS 0.02954f ; **FLOATING
C2026 VDD.t189 VSS 0.0329f ; **FLOATING
C2027 VDD.t38 VSS 0.0329f ; **FLOATING
C2028 VDD.t109 VSS 0.0329f ; **FLOATING
C2029 VDD.t204 VSS 0.0329f ; **FLOATING
C2030 VDD.t43 VSS 0.02954f ; **FLOATING
C2031 VDD.t54 VSS 0.04318f ; **FLOATING
C2032 VDD.t351 VSS 0.0329f ; **FLOATING
C2033 VDD.t376 VSS 0.02954f ; **FLOATING
C2034 VDD.t176 VSS 0.0329f ; **FLOATING
C2035 VDD.t185 VSS 0.02954f ; **FLOATING
C2036 VDD.t190 VSS 0.0329f ; **FLOATING
C2037 VDD.t144 VSS 0.02954f ; **FLOATING
C2038 VDD.t145 VSS 0.02954f ; **FLOATING
C2039 VDD.t221 VSS 0.04334f ; **FLOATING
C2040 VDD.t95 VSS 0.0329f ; **FLOATING
C2041 VDD.t148 VSS 0.02954f ; **FLOATING
C2042 VDD.t40 VSS 0.0329f ; **FLOATING
C2043 VDD.t180 VSS 0.0329f ; **FLOATING
C2044 VDD.t205 VSS 0.0329f ; **FLOATING
C2045 VDD.t388 VSS 0.02954f ; **FLOATING
C2046 VDD.t224 VSS 0.04318f ; **FLOATING
C2047 VDD.t184 VSS 0.02954f ; **FLOATING
C2048 VDD.t80 VSS 0.0329f ; **FLOATING
C2049 VDD.t151 VSS 0.02954f ; **FLOATING
C2050 VDD.t61 VSS 0.0329f ; **FLOATING
C2051 VDD.t238 VSS 0.0329f ; **FLOATING
C2052 VDD.t46 VSS 0.02954f ; **FLOATING
C2053 VDD.t47 VSS 0.02954f ; **FLOATING
C2054 VDD.t50 VSS 0.02954f ; **FLOATING
C2055 VDD.t182 VSS 0.0329f ; **FLOATING
C2056 VDD.t42 VSS 0.0329f ; **FLOATING
C2057 VDD.t106 VSS 0.0329f ; **FLOATING
C2058 VDD.t242 VSS 0.0329f ; **FLOATING
C2059 VDD.t89 VSS 0.04318f ; **FLOATING
C2060 VDD.t302 VSS 0.0329f ; **FLOATING
C2061 VDD.t369 VSS 0.0329f ; **FLOATING
C2062 VDD.t186 VSS 0.0329f ; **FLOATING
C2063 VDD.t377 VSS 0.0329f ; **FLOATING
C2064 VDD.t244 VSS 0.03493f ; **FLOATING
C2065 VDD.t222 VSS 0.04318f ; **FLOATING
C2066 VDD.t245 VSS 0.06169f ; **FLOATING
C2067 VDD.t188 VSS 0.0329f ; **FLOATING
C2068 VDD.t292 VSS 0.0329f ; **FLOATING
C2069 VDD.t296 VSS 0.0329f ; **FLOATING
C2070 VDD.t92 VSS 0.0329f ; **FLOATING
C2071 VDD.t107 VSS 0.02954f ; **FLOATING
C2072 VDD.t62 VSS 0.04318f ; **FLOATING
C2073 VDD.t39 VSS 0.0329f ; **FLOATING
C2074 VDD.t105 VSS 0.02954f ; **FLOATING
C2075 VDD.t101 VSS 0.0329f ; **FLOATING
C2076 VDD.t51 VSS 0.02954f ; **FLOATING
C2077 VDD.t206 VSS 0.0329f ; **FLOATING
C2078 VDD.t335 VSS 0.02954f ; **FLOATING
C2079 VDD.t336 VSS 0.02954f ; **FLOATING
C2080 VDD.t85 VSS 0.04334f ; **FLOATING
C2081 VDD.t94 VSS 0.0329f ; **FLOATING
C2082 VDD.t339 VSS 0.02954f ; **FLOATING
C2083 VDD.t187 VSS 0.0329f ; **FLOATING
C2084 VDD.t110 VSS 0.0329f ; **FLOATING
C2085 VDD.t387 VSS 0.0329f ; **FLOATING
C2086 VDD.t389 VSS 0.02954f ; **FLOATING
C2087 VDD.t115 VSS 0.04318f ; **FLOATING
C2088 VDD.t216 VSS 0.02954f ; **FLOATING
C2089 VDD.t81 VSS 0.0329f ; **FLOATING
C2090 VDD.t103 VSS 0.02954f ; **FLOATING
C2091 VDD.t170 VSS 0.0329f ; **FLOATING
C2092 VDD.t290 VSS 0.0329f ; **FLOATING
C2093 VDD.t69 VSS 0.02954f ; **FLOATING
C2094 VDD.t70 VSS 0.02954f ; **FLOATING
C2095 VDD.t73 VSS 0.02954f ; **FLOATING
C2096 VDD.t385 VSS 0.0329f ; **FLOATING
C2097 VDD.t198 VSS 0.0329f ; **FLOATING
C2098 VDD.t179 VSS 0.0329f ; **FLOATING
C2099 VDD.t243 VSS 0.0329f ; **FLOATING
C2100 VDD.t160 VSS 0.02954f ; **FLOATING
C2101 VDD.t230 VSS 0.04318f ; **FLOATING
C2102 VDD.t303 VSS 0.0329f ; **FLOATING
C2103 VDD.t208 VSS 0.02954f ; **FLOATING
C2104 VDD.t234 VSS 0.0329f ; **FLOATING
C2105 VDD.t237 VSS 0.02954f ; **FLOATING
C2106 VDD.t353 VSS 0.0329f ; **FLOATING
C2107 VDD.t210 VSS 0.02954f ; **FLOATING
C2108 VDD.t211 VSS 0.02954f ; **FLOATING
C2109 VDD.t294 VSS 0.04334f ; **FLOATING
C2110 VDD.t83 VSS 0.0329f ; **FLOATING
C2111 VDD.t214 VSS 0.02954f ; **FLOATING
C2112 VDD.t352 VSS 0.0329f ; **FLOATING
C2113 VDD.t126 VSS 0.0329f ; **FLOATING
C2114 VDD.t181 VSS 0.0329f ; **FLOATING
C2115 VDD.t168 VSS 0.04318f ; **FLOATING
C2116 VDD.t350 VSS 0.03956f ; **FLOATING
C2117 VDD.t390 VSS 0.10912f ; **FLOATING
C2118 VDD.t212 VSS 0.03171f ; **FLOATING
C2119 VDD.t391 VSS 0.10912f ; **FLOATING
C2120 VDD.t209 VSS 0.03171f ; **FLOATING
C2121 VDD.t392 VSS 0.10912f ; **FLOATING
C2122 VDD.t161 VSS 0.03171f ; **FLOATING
C2123 VDD.t74 VSS 0.04334f ; **FLOATING
C2124 VDD.t393 VSS 0.10912f ; **FLOATING
C2125 VDD.t71 VSS 0.03171f ; **FLOATING
C2126 VDD.t394 VSS 0.10912f ; **FLOATING
C2127 VDD.t68 VSS 0.03171f ; **FLOATING
C2128 VDD.t395 VSS 0.10912f ; **FLOATING
C2129 VDD.t215 VSS 0.03171f ; **FLOATING
C2130 VDD.t396 VSS 0.10912f ; **FLOATING
C2131 VDD.t337 VSS 0.03171f ; **FLOATING
C2132 VDD.t397 VSS 0.10912f ; **FLOATING
C2133 VDD.t52 VSS 0.03171f ; **FLOATING
C2134 VDD.t398 VSS 0.10912f ; **FLOATING
C2135 VDD.t104 VSS 0.03171f ; **FLOATING
C2136 VDD.n150 VSS 0.06199f ; **FLOATING
C2137 VDD.n151 VSS 0.01294f ; **FLOATING
C2138 VDD.n152 VSS 0.07329f ; **FLOATING
C2139 VDD.n153 VSS 0.0111f ; **FLOATING
C2140 VDD.n154 VSS 0.06465f ; **FLOATING
C2141 VDD.n155 VSS 0.01294f ; **FLOATING
C2142 VDD.n156 VSS 0.07973f ; **FLOATING
C2143 VDD.t232 VSS 0.04334f ; **FLOATING
C2144 VDD.t399 VSS 0.10912f ; **FLOATING
C2145 VDD.t48 VSS 0.03171f ; **FLOATING
C2146 VDD.t400 VSS 0.10912f ; **FLOATING
C2147 VDD.t45 VSS 0.03171f ; **FLOATING
C2148 VDD.t401 VSS 0.10912f ; **FLOATING
C2149 VDD.t183 VSS 0.03171f ; **FLOATING
C2150 VDD.t402 VSS 0.10912f ; **FLOATING
C2151 VDD.t146 VSS 0.03171f ; **FLOATING
C2152 VDD.t403 VSS 0.10912f ; **FLOATING
C2153 VDD.t143 VSS 0.03171f ; **FLOATING
C2154 VDD.t404 VSS 0.10912f ; **FLOATING
C2155 VDD.t44 VSS 0.03171f ; **FLOATING
C2156 VDD.t87 VSS 0.04334f ; **FLOATING
C2157 VDD.t405 VSS 0.10912f ; **FLOATING
C2158 VDD.t140 VSS 0.03171f ; **FLOATING
C2159 VDD.t30 VSS 0.06667f ; **FLOATING
C2160 VDD.n157 VSS 0.04824f ; **FLOATING
C2161 VDD.n158 VSS 0.04832f ; **FLOATING
C2162 VDD.n159 VSS 0.04824f ; **FLOATING
C2163 VDD.n160 VSS 0.04832f ; **FLOATING
C2164 VDD.n161 VSS 0.04824f ; **FLOATING
C2165 VDD.n162 VSS 0.04824f ; **FLOATING
C2166 VDD.n163 VSS 0.04824f ; **FLOATING
C2167 VDD.n164 VSS 0.04824f ; **FLOATING
C2168 VDD.n165 VSS 0.04824f ; **FLOATING
C2169 VDD.n166 VSS 0.04824f ; **FLOATING
C2170 VDD.n167 VSS 0.04824f ; **FLOATING
C2171 VDD.n168 VSS 0.04824f ; **FLOATING
C2172 VDD.n169 VSS 0.04832f ; **FLOATING
C2173 VDD.n170 VSS 0.04824f ; **FLOATING
C2174 VDD.n171 VSS 0.04824f ; **FLOATING
C2175 VDD.n172 VSS 0.04824f ; **FLOATING
C2176 VDD.n173 VSS 0.04824f ; **FLOATING
C2177 VDD.n174 VSS 0.04832f ; **FLOATING
C2178 VDD.n175 VSS 0.04824f ; **FLOATING
C2179 VDD.n176 VSS 0.04824f ; **FLOATING
C2180 VDD.n177 VSS 0.04824f ; **FLOATING
C2181 VDD.n178 VSS 0.04824f ; **FLOATING
C2182 VDD.n179 VSS 0.04824f ; **FLOATING
C2183 VDD.n180 VSS 0.04824f ; **FLOATING
C2184 VDD.n181 VSS 0.04824f ; **FLOATING
C2185 VDD.n182 VSS 0.04832f ; **FLOATING
C2186 VDD.n183 VSS 0.04832f ; **FLOATING
C2187 VDD.n184 VSS 0.04824f ; **FLOATING
C2188 VDD.n185 VSS 0.04824f ; **FLOATING
C2189 VDD.n186 VSS 0.04824f ; **FLOATING
C2190 VDD.n187 VSS 0.04824f ; **FLOATING
C2191 VDD.t26 VSS 0.03229f ; **FLOATING
C2192 VDD.t24 VSS 0.02303f ; **FLOATING
C2193 VDD.t29 VSS 0.03215f ; **FLOATING
C2194 VDD.t27 VSS 0.03552f ; **FLOATING
C2195 VDD.t28 VSS 0.01869f ; **FLOATING
C2196 VDD.t261 VSS 0.03178f ; **FLOATING
C2197 VDD.n188 VSS 0.09619f ; **FLOATING
C2198 VDD.n189 VSS 0.02357f ; **FLOATING
C2199 VDD.n190 VSS 0.07478f ; **FLOATING
C2200 VDD.n191 VSS 0.01381f ; **FLOATING
C2201 VDD.t113 VSS 0.03727f ; **FLOATING
C2202 VDD.n192 VSS 0.07758f ; **FLOATING
C2203 VDD.n193 VSS 0.03405f ; **FLOATING
C2204 VDD.t264 VSS 0.03178f ; **FLOATING
C2205 VDD.n194 VSS 0.1045f ; **FLOATING
C2206 VDD.n195 VSS 0.02357f ; **FLOATING
C2207 VDD.n196 VSS 0.05908f ; **FLOATING
C2208 VDD.n197 VSS 0.01381f ; **FLOATING
C2209 VDD.t150 VSS 0.03727f ; **FLOATING
C2210 VDD.n198 VSS 0.07761f ; **FLOATING
C2211 VDD.n199 VSS 0.03397f ; **FLOATING
C2212 VDD.t262 VSS 0.03178f ; **FLOATING
C2213 VDD.n200 VSS 0.1045f ; **FLOATING
C2214 VDD.n201 VSS 0.02357f ; **FLOATING
C2215 VDD.n202 VSS 0.05911f ; **FLOATING
C2216 VDD.n203 VSS 0.0138f ; **FLOATING
C2217 VDD.t193 VSS 0.03727f ; **FLOATING
C2218 VDD.n204 VSS 0.07765f ; **FLOATING
C2219 VDD.n205 VSS 0.03398f ; **FLOATING
C2220 VDD.t260 VSS 0.03178f ; **FLOATING
C2221 VDD.n206 VSS 0.1045f ; **FLOATING
C2222 VDD.n207 VSS 0.02357f ; **FLOATING
C2223 VDD.n208 VSS 0.0591f ; **FLOATING
C2224 VDD.n209 VSS 0.01381f ; **FLOATING
C2225 VDD.t162 VSS 0.03727f ; **FLOATING
C2226 VDD.n210 VSS 0.0776f ; **FLOATING
C2227 VDD.n211 VSS 0.03401f ; **FLOATING
C2228 VDD.t265 VSS 0.03178f ; **FLOATING
C2229 VDD.n212 VSS 0.10447f ; **FLOATING
C2230 VDD.n213 VSS 0.02357f ; **FLOATING
C2231 VDD.n214 VSS 0.05909f ; **FLOATING
C2232 VDD.n215 VSS 0.01381f ; **FLOATING
C2233 VDD.t88 VSS 0.03727f ; **FLOATING
C2234 VDD.n216 VSS 0.07758f ; **FLOATING
C2235 VDD.n217 VSS 0.03405f ; **FLOATING
C2236 VDD.t259 VSS 0.03178f ; **FLOATING
C2237 VDD.n218 VSS 0.10441f ; **FLOATING
C2238 VDD.n219 VSS 0.02357f ; **FLOATING
C2239 VDD.n220 VSS 0.05908f ; **FLOATING
C2240 VDD.n221 VSS 0.01381f ; **FLOATING
C2241 VDD.t37 VSS 0.03727f ; **FLOATING
C2242 VDD.n222 VSS 0.07761f ; **FLOATING
C2243 VDD.n223 VSS 0.03397f ; **FLOATING
C2244 VDD.t268 VSS 0.03178f ; **FLOATING
C2245 VDD.n224 VSS 0.10444f ; **FLOATING
C2246 VDD.n225 VSS 0.02357f ; **FLOATING
C2247 VDD.n226 VSS 0.05911f ; **FLOATING
C2248 VDD.n227 VSS 0.0138f ; **FLOATING
C2249 VDD.t240 VSS 0.03727f ; **FLOATING
C2250 VDD.n228 VSS 0.07761f ; **FLOATING
C2251 VDD.n229 VSS 0.03408f ; **FLOATING
C2252 VDD.t269 VSS 0.03178f ; **FLOATING
C2253 VDD.n230 VSS 0.1045f ; **FLOATING
C2254 VDD.n231 VSS 0.02357f ; **FLOATING
C2255 VDD.n232 VSS 0.05904f ; **FLOATING
C2256 VDD.n233 VSS 0.0138f ; **FLOATING
C2257 VDD.t56 VSS 0.03727f ; **FLOATING
C2258 VDD.n234 VSS 0.07763f ; **FLOATING
C2259 VDD.n235 VSS 0.03404f ; **FLOATING
C2260 VDD.t266 VSS 0.03178f ; **FLOATING
C2261 VDD.n236 VSS 0.1045f ; **FLOATING
C2262 VDD.n237 VSS 0.02357f ; **FLOATING
C2263 VDD.n238 VSS 0.05906f ; **FLOATING
C2264 VDD.n239 VSS 0.01381f ; **FLOATING
C2265 VDD.t220 VSS 0.03727f ; **FLOATING
C2266 VDD.n240 VSS 0.07762f ; **FLOATING
C2267 VDD.n241 VSS 0.034f ; **FLOATING
C2268 VDD.t257 VSS 0.03178f ; **FLOATING
C2269 VDD.n242 VSS 0.1045f ; **FLOATING
C2270 VDD.n243 VSS 0.02357f ; **FLOATING
C2271 VDD.n244 VSS 0.05908f ; **FLOATING
C2272 VDD.n245 VSS 0.01381f ; **FLOATING
C2273 VDD.t96 VSS 0.03727f ; **FLOATING
C2274 VDD.n246 VSS 0.07759f ; **FLOATING
C2275 VDD.n247 VSS 0.03403f ; **FLOATING
C2276 VDD.t270 VSS 0.03178f ; **FLOATING
C2277 VDD.n248 VSS 0.1045f ; **FLOATING
C2278 VDD.n249 VSS 0.02357f ; **FLOATING
C2279 VDD.n250 VSS 0.05909f ; **FLOATING
C2280 VDD.n251 VSS 0.01381f ; **FLOATING
C2281 VDD.t231 VSS 0.03727f ; **FLOATING
C2282 VDD.n252 VSS 0.07761f ; **FLOATING
C2283 VDD.n253 VSS 0.03404f ; **FLOATING
C2284 VDD.t272 VSS 0.03178f ; **FLOATING
C2285 VDD.n254 VSS 0.1045f ; **FLOATING
C2286 VDD.n255 VSS 0.02357f ; **FLOATING
C2287 VDD.n256 VSS 0.05906f ; **FLOATING
C2288 VDD.n257 VSS 0.01381f ; **FLOATING
C2289 VDD.t60 VSS 0.03727f ; **FLOATING
C2290 VDD.n258 VSS 0.07758f ; **FLOATING
C2291 VDD.n259 VSS 0.03408f ; **FLOATING
C2292 VDD.t271 VSS 0.03178f ; **FLOATING
C2293 VDD.n260 VSS 0.1045f ; **FLOATING
C2294 VDD.n261 VSS 0.02357f ; **FLOATING
C2295 VDD.n262 VSS 0.05905f ; **FLOATING
C2296 VDD.n263 VSS 0.01381f ; **FLOATING
C2297 VDD.t121 VSS 0.03727f ; **FLOATING
C2298 VDD.n264 VSS 0.07758f ; **FLOATING
C2299 VDD.n265 VSS 0.03408f ; **FLOATING
C2300 VDD.t253 VSS 0.03178f ; **FLOATING
C2301 VDD.n266 VSS 0.10447f ; **FLOATING
C2302 VDD.n267 VSS 0.02357f ; **FLOATING
C2303 VDD.n268 VSS 0.05905f ; **FLOATING
C2304 VDD.n269 VSS 0.01381f ; **FLOATING
C2305 VDD.t41 VSS 0.03727f ; **FLOATING
C2306 VDD.n270 VSS 0.07759f ; **FLOATING
C2307 VDD.n271 VSS 0.03403f ; **FLOATING
C2308 VDD.t267 VSS 0.03178f ; **FLOATING
C2309 VDD.n272 VSS 0.10444f ; **FLOATING
C2310 VDD.n273 VSS 0.02357f ; **FLOATING
C2311 VDD.n274 VSS 0.05908f ; **FLOATING
C2312 VDD.n275 VSS 0.0138f ; **FLOATING
C2313 VDD.t358 VSS 0.03727f ; **FLOATING
C2314 VDD.n276 VSS 0.07763f ; **FLOATING
C2315 VDD.n277 VSS 0.03401f ; **FLOATING
C2316 VDD.t250 VSS 0.03178f ; **FLOATING
C2317 VDD.n278 VSS 0.1045f ; **FLOATING
C2318 VDD.n279 VSS 0.02357f ; **FLOATING
C2319 VDD.n280 VSS 0.05908f ; **FLOATING
C2320 VDD.n281 VSS 0.0138f ; **FLOATING
C2321 VDD.t293 VSS 0.03727f ; **FLOATING
C2322 VDD.n282 VSS 0.07762f ; **FLOATING
C2323 VDD.n283 VSS 0.03403f ; **FLOATING
C2324 VDD.t255 VSS 0.03178f ; **FLOATING
C2325 VDD.n284 VSS 0.1045f ; **FLOATING
C2326 VDD.n285 VSS 0.02357f ; **FLOATING
C2327 VDD.n286 VSS 0.05908f ; **FLOATING
C2328 VDD.n287 VSS 0.01381f ; **FLOATING
C2329 VDD.t75 VSS 0.03727f ; **FLOATING
C2330 VDD.n288 VSS 0.07758f ; **FLOATING
C2331 VDD.n289 VSS 0.03405f ; **FLOATING
C2332 VDD.t251 VSS 0.03178f ; **FLOATING
C2333 VDD.n290 VSS 0.1045f ; **FLOATING
C2334 VDD.n291 VSS 0.02357f ; **FLOATING
C2335 VDD.n292 VSS 0.05908f ; **FLOATING
C2336 VDD.n293 VSS 0.01381f ; **FLOATING
C2337 VDD.t172 VSS 0.03727f ; **FLOATING
C2338 VDD.n294 VSS 0.07759f ; **FLOATING
C2339 VDD.n295 VSS 0.03403f ; **FLOATING
C2340 VDD.t274 VSS 0.03178f ; **FLOATING
C2341 VDD.n296 VSS 0.10447f ; **FLOATING
C2342 VDD.n297 VSS 0.02357f ; **FLOATING
C2343 VDD.n298 VSS 0.05909f ; **FLOATING
C2344 VDD.n299 VSS 0.01381f ; **FLOATING
C2345 VDD.t63 VSS 0.03727f ; **FLOATING
C2346 VDD.n300 VSS 0.07758f ; **FLOATING
C2347 VDD.n301 VSS 0.03405f ; **FLOATING
C2348 VDD.t273 VSS 0.03178f ; **FLOATING
C2349 VDD.n302 VSS 0.10444f ; **FLOATING
C2350 VDD.n303 VSS 0.02357f ; **FLOATING
C2351 VDD.n304 VSS 0.05908f ; **FLOATING
C2352 VDD.n305 VSS 0.01381f ; **FLOATING
C2353 VDD.t102 VSS 0.03727f ; **FLOATING
C2354 VDD.n306 VSS 0.0776f ; **FLOATING
C2355 VDD.n307 VSS 0.03401f ; **FLOATING
C2356 VDD.t258 VSS 0.03178f ; **FLOATING
C2357 VDD.n308 VSS 0.1045f ; **FLOATING
C2358 VDD.n309 VSS 0.02357f ; **FLOATING
C2359 VDD.n310 VSS 0.05908f ; **FLOATING
C2360 VDD.n311 VSS 0.0138f ; **FLOATING
C2361 VDD.t84 VSS 0.03727f ; **FLOATING
C2362 VDD.n312 VSS 0.07764f ; **FLOATING
C2363 VDD.n313 VSS 0.03397f ; **FLOATING
C2364 VDD.t256 VSS 0.03178f ; **FLOATING
C2365 VDD.n314 VSS 0.1045f ; **FLOATING
C2366 VDD.n315 VSS 0.02357f ; **FLOATING
C2367 VDD.n316 VSS 0.05913f ; **FLOATING
C2368 VDD.n317 VSS 0.01381f ; **FLOATING
C2369 VDD.t93 VSS 0.03727f ; **FLOATING
C2370 VDD.n318 VSS 0.07759f ; **FLOATING
C2371 VDD.n319 VSS 0.03403f ; **FLOATING
C2372 VDD.t252 VSS 0.03178f ; **FLOATING
C2373 VDD.n320 VSS 0.1045f ; **FLOATING
C2374 VDD.n321 VSS 0.02357f ; **FLOATING
C2375 VDD.n322 VSS 0.05909f ; **FLOATING
C2376 VDD.n323 VSS 0.01381f ; **FLOATING
C2377 VDD.t53 VSS 0.03727f ; **FLOATING
C2378 VDD.n324 VSS 0.07761f ; **FLOATING
C2379 VDD.n325 VSS 0.03397f ; **FLOATING
C2380 VDD.t276 VSS 0.03178f ; **FLOATING
C2381 VDD.n326 VSS 0.1045f ; **FLOATING
C2382 VDD.n327 VSS 0.02357f ; **FLOATING
C2383 VDD.n328 VSS 0.05912f ; **FLOATING
C2384 VDD.n329 VSS 0.01381f ; **FLOATING
C2385 VDD.t67 VSS 0.03727f ; **FLOATING
C2386 VDD.n330 VSS 0.07762f ; **FLOATING
C2387 VDD.n331 VSS 0.034f ; **FLOATING
C2388 VDD.t254 VSS 0.03178f ; **FLOATING
C2389 VDD.n332 VSS 0.1045f ; **FLOATING
C2390 VDD.n333 VSS 0.02357f ; **FLOATING
C2391 VDD.n334 VSS 0.05908f ; **FLOATING
C2392 VDD.n335 VSS 0.01381f ; **FLOATING
C2393 VDD.t112 VSS 0.03727f ; **FLOATING
C2394 VDD.n336 VSS 0.07762f ; **FLOATING
C2395 VDD.n337 VSS 0.03402f ; **FLOATING
C2396 VDD.t277 VSS 0.03178f ; **FLOATING
C2397 VDD.n338 VSS 0.1045f ; **FLOATING
C2398 VDD.n339 VSS 0.02357f ; **FLOATING
C2399 VDD.n340 VSS 0.05907f ; **FLOATING
C2400 VDD.n341 VSS 0.01381f ; **FLOATING
C2401 VDD.t125 VSS 0.03727f ; **FLOATING
C2402 VDD.n342 VSS 0.07762f ; **FLOATING
C2403 VDD.n343 VSS 0.03402f ; **FLOATING
C2404 VDD.t278 VSS 0.03178f ; **FLOATING
C2405 VDD.n344 VSS 0.1045f ; **FLOATING
C2406 VDD.n345 VSS 0.02357f ; **FLOATING
C2407 VDD.n346 VSS 0.05907f ; **FLOATING
C2408 VDD.n347 VSS 0.01381f ; **FLOATING
C2409 VDD.t163 VSS 0.03727f ; **FLOATING
C2410 VDD.n348 VSS 0.07762f ; **FLOATING
C2411 VDD.n349 VSS 0.03402f ; **FLOATING
C2412 VDD.t279 VSS 0.03178f ; **FLOATING
C2413 VDD.n350 VSS 0.10447f ; **FLOATING
C2414 VDD.n351 VSS 0.02357f ; **FLOATING
C2415 VDD.n352 VSS 0.05907f ; **FLOATING
C2416 VDD.n353 VSS 0.01381f ; **FLOATING
C2417 VDD.t195 VSS 0.03727f ; **FLOATING
C2418 VDD.n354 VSS 0.0776f ; **FLOATING
C2419 VDD.n355 VSS 0.03403f ; **FLOATING
C2420 VDD.t275 VSS 0.03178f ; **FLOATING
C2421 VDD.n356 VSS 0.10444f ; **FLOATING
C2422 VDD.n357 VSS 0.02357f ; **FLOATING
C2423 VDD.n358 VSS 0.05907f ; **FLOATING
C2424 VDD.n359 VSS 0.0138f ; **FLOATING
C2425 VDD.t76 VSS 0.03727f ; **FLOATING
C2426 VDD.n360 VSS 0.07762f ; **FLOATING
C2427 VDD.n361 VSS 0.03403f ; **FLOATING
C2428 VDD.t280 VSS 0.03178f ; **FLOATING
C2429 VDD.n362 VSS 0.10447f ; **FLOATING
C2430 VDD.n363 VSS 0.02357f ; **FLOATING
C2431 VDD.n364 VSS 0.05908f ; **FLOATING
C2432 VDD.n365 VSS 0.01381f ; **FLOATING
C2433 VDD.t82 VSS 0.03727f ; **FLOATING
C2434 VDD.n366 VSS 0.07761f ; **FLOATING
C2435 VDD.n367 VSS 0.03397f ; **FLOATING
C2436 VDD.t281 VSS 0.03178f ; **FLOATING
C2437 VDD.n368 VSS 0.10444f ; **FLOATING
C2438 VDD.n369 VSS 0.02357f ; **FLOATING
C2439 VDD.n370 VSS 0.05912f ; **FLOATING
C2440 VDD.n371 VSS 0.01381f ; **FLOATING
C2441 VDD.t191 VSS 0.03727f ; **FLOATING
C2442 VDD.n372 VSS 0.0776f ; **FLOATING
C2443 VDD.n373 VSS 0.03401f ; **FLOATING
C2444 VDD.t282 VSS 0.03178f ; **FLOATING
C2445 VDD.n374 VSS 0.08649f ; **FLOATING
C2446 VDD.n375 VSS 0.02357f ; **FLOATING
C2447 VDD.n376 VSS 0.05909f ; **FLOATING
C2448 VDD.n377 VSS 0.01381f ; **FLOATING
C2449 VDD.t127 VSS 0.03727f ; **FLOATING
C2450 VDD.n378 VSS 0.05916f ; **FLOATING
C2451 VDD.n379 VSS 0.01422f ; **FLOATING
C2452 VDD.t31 VSS 0.03178f ; **FLOATING
C2453 VDD.n380 VSS 0.02357f ; **FLOATING
C2454 VDD.t32 VSS 0.03552f ; **FLOATING
C2455 VDD.n381 VSS 0.06979f ; **FLOATING
C2456 VDD.t35 VSS 0.03178f ; **FLOATING
C2457 VDD.n382 VSS 0.0211f ; **FLOATING
C2458 VDD.t33 VSS 0.03071f ; **FLOATING
C2459 VDD.n383 VSS 0.01566f ; **FLOATING
C2460 VDD.n384 VSS 0.05923f ; **FLOATING
C2461 VDD.n385 VSS 0.05088f ; **FLOATING
C2462 VDD.n386 VSS 2.34984f ; **FLOATING
C2463 VDD.n387 VSS 0.70246f ; **FLOATING
C2464 VDD.n388 VSS 0.02958f ; **FLOATING
C2465 VDD.n389 VSS 0.0156f ; **FLOATING
C2466 VDD.n390 VSS 0.03576f ; **FLOATING
C2467 VDD.n391 VSS 0.03118f ; **FLOATING
C2468 VDD.n392 VSS 0.03561f ; **FLOATING
C2469 VDD.n393 VSS 0.03578f ; **FLOATING
C2470 VDD.n394 VSS 0.01573f ; **FLOATING
C2471 VDD.t124 VSS 0.02171f ; **FLOATING
C2472 VDD.n395 VSS 0.06127f ; **FLOATING
C2473 VDD.n396 VSS 0.01535f ; **FLOATING
C2474 VDD.n397 VSS 0.01566f ; **FLOATING
C2475 VDD.n398 VSS 0.06781f ; **FLOATING
C2476 VDD.t8 VSS 0.06343f ; **FLOATING
C2477 VDD.n399 VSS 0.02215f ; **FLOATING
C2478 VDD.n400 VSS 0.04961f ; **FLOATING
C2479 VDD.t3 VSS 0.05675f ; **FLOATING
C2480 VDD.n401 VSS 0.02212f ; **FLOATING
C2481 VDD.t9 VSS 0.05675f ; **FLOATING
C2482 VDD.n402 VSS 0.06353f ; **FLOATING
C2483 VDD.n403 VSS 0.02213f ; **FLOATING
C2484 VDD.n404 VSS 0.04482f ; **FLOATING
C2485 VDD.t0 VSS 0.35887f ; **FLOATING
C2486 VDD.n405 VSS 0.01448f ; **FLOATING
C2487 VDD.n406 VSS 0.04479f ; **FLOATING
C2488 VDD.t2 VSS 0.06343f ; **FLOATING
C2489 VDD.n407 VSS 0.02214f ; **FLOATING
C2490 VDD.n408 VSS 0.06776f ; **FLOATING
C2491 VDD.n409 VSS 0.03578f ; **FLOATING
C2492 VDD.n410 VSS 0.08627f ; **FLOATING
C2493 VDD.t318 VSS 0.06343f ; **FLOATING
C2494 VDD.n411 VSS 0.04115f ; **FLOATING
C2495 VDD.t311 VSS 0.06343f ; **FLOATING
C2496 VDD.n412 VSS 0.04116f ; **FLOATING
C2497 VDD.n413 VSS 0.08629f ; **FLOATING
C2498 VDD.n414 VSS 0.03114f ; **FLOATING
C2499 VDD.n415 VSS 0.08649f ; **FLOATING
C2500 VDD.t320 VSS 0.06343f ; **FLOATING
C2501 VDD.n416 VSS 0.04115f ; **FLOATING
C2502 VDD.t313 VSS 0.06343f ; **FLOATING
C2503 VDD.n417 VSS 0.04116f ; **FLOATING
C2504 VDD.n418 VSS 0.0865f ; **FLOATING
C2505 VDD.n419 VSS 0.03564f ; **FLOATING
C2506 VDD.n420 VSS 0.08174f ; **FLOATING
C2507 VDD.t322 VSS 0.06343f ; **FLOATING
C2508 VDD.n421 VSS 0.04115f ; **FLOATING
C2509 VDD.t315 VSS 0.06343f ; **FLOATING
C2510 VDD.n422 VSS 0.04116f ; **FLOATING
C2511 VDD.n423 VSS 0.0817f ; **FLOATING
C2512 VDD.n424 VSS 0.0358f ; **FLOATING
C2513 VDD.n425 VSS 0.01566f ; **FLOATING
C2514 VDD.t6 VSS 0.05675f ; **FLOATING
C2515 VDD.t11 VSS 0.05675f ; **FLOATING
C2516 VDD.n426 VSS 0.0691f ; **FLOATING
C2517 VDD.n427 VSS 0.02213f ; **FLOATING
C2518 VDD.t5 VSS 0.06343f ; **FLOATING
C2519 VDD.n428 VSS 0.06779f ; **FLOATING
C2520 VDD.n429 VSS 0.02214f ; **FLOATING
C2521 VDD.n430 VSS 0.06779f ; **FLOATING
C2522 VDD.t12 VSS 0.06343f ; **FLOATING
C2523 VDD.n431 VSS 0.02215f ; **FLOATING
C2524 VDD.n432 VSS 0.04479f ; **FLOATING
C2525 VDD.t4 VSS 0.35887f ; **FLOATING
C2526 VDD.n433 VSS 0.01448f ; **FLOATING
C2527 VDD.n434 VSS 0.04801f ; **FLOATING
C2528 VDD.n435 VSS 0.02212f ; **FLOATING
C2529 VDD.n436 VSS 0.08081f ; **FLOATING
C2530 VDD.n437 VSS 0.04703f ; **FLOATING
C2531 VDD.t1 VSS 12.4932f ; **FLOATING
.ends
