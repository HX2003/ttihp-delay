* NGSPICE file created from hx_delay_line_with_mux_dll.ext - technology: ihp-sg13g2

.subckt hx_delay_line_with_mux_dll VDD DELAY_OUT_LAST VSS DELAY_VBIASN DELAY_VBIASP
+ DLL_RESETN REF_CLK MUX_SEL0 MUX_SEL1 MUX_OUT MUX_SEL4 MUX_SEL2 MUX_SEL3
X0 a_14009_5878# REF_CLK VSS.t452 VSS.t505 sg13_lv_nmos ad=0.2516p pd=2.16u as=1.9998p ps=12.915u w=0.74u l=0.13u
X1 VDD.t160 a_4003_1842# a_4437_1842# VDD.t7 sg13_lv_pmos ad=0.2128p pd=1.5u as=0.3808p ps=2.92u w=1.12u l=0.13u
X2 VSS.t286 DLL_RESETN a_10040_6305# VSS.t285 sg13_lv_nmos ad=0.1626p pd=1.415u as=60.89999f ps=0.71u w=0.42u l=0.13u
X3 VSS.t551 a_15077_1842# a_15545_1044# VSS.t565 sg13_lv_nmos ad=0.1665p pd=1.19u as=0.2516p ps=2.16u w=0.74u l=0.13u
X4 a_27915_1044# a_27705_1044# VDD.t42 VDD.t0 sg13_lv_pmos ad=0.2128p pd=1.5u as=0.252p ps=1.57u w=1.12u l=0.13u
X5 VSS.t125 VDD.t413 VSS.t123 VSS.t124 sg13_lv_nmos ad=79.8f pd=0.8u as=0 ps=0 w=0.42u l=1u
X6 a_10951_2470# a_10713_1842# a_10843_1842# VDD.t7 sg13_lv_pmos ad=0.2128p pd=1.5u as=0.3808p ps=2.92u w=1.12u l=0.2u
X7 VSS.t249 a_3171_1047.t7 a_11924_1008# VSS.t248 sg13_lv_nmos ad=0.2516p pd=2.16u as=0.2516p ps=2.16u w=0.74u l=0.13u
X8 VDD.t213 VSS.t165 VDD.t212 VDD.t0 sg13_lv_pmos ad=0.34p pd=2.68u as=0 ps=0 w=1u l=1u
X9 VSS.t205 a_1256_1044# a_2967_1395# VSS.t502 sg13_lv_nmos ad=0.1331p pd=1.12u as=0.1216p ps=1.02u w=0.64u l=0.13u
X10 VSS.t125 VDD.t412 VSS.t125 VSS.t126 sg13_lv_nmos ad=0.1428p pd=1.52u as=0 ps=0 w=0.42u l=1u
X11 a_25153_1842# a_24957_1842# VSS.t294 VSS.t588 sg13_lv_nmos ad=0.2516p pd=2.16u as=0.1406p ps=1.12u w=0.74u l=0.13u
X12 VDD.t27 VSS.t139 VDD.t26 VDD.t0 sg13_lv_pmos ad=0.34p pd=2.68u as=0 ps=0 w=1u l=1u
X13 a_15108_6109# a_14851_6228# a_15270_6305# VSS.t10 sg13_lv_nmos ad=0.1428p pd=1.52u as=37.8f ps=0.6u w=0.42u l=0.13u
X14 VSS.t512 a_14851_6228# a_15688_5867# VSS.t511 sg13_lv_nmos ad=0.1406p pd=1.12u as=0.2516p ps=2.16u w=0.74u l=0.13u
X15 VSS.t464 VSS.t462 VSS.t462 VSS.t463 sg13_lv_nmos ad=0.68p pd=4.68u as=0 ps=0 w=2u l=1u
X16 a_15108_5325# a_12849_5867# VDD.t14 VDD.t10 sg13_lv_pmos ad=79.8f pd=0.8u as=1.03698p ps=6.245u w=0.42u l=0.13u
X17 a_25630_1044# a_2019_1047.t2 a_25528_1044# VSS.t190 sg13_lv_nmos ad=0.2516p pd=2.16u as=0.1406p ps=1.12u w=0.74u l=0.13u
X18 VDD.t279 DELAY_VBIASP a_19311_2470# VDD.t7 sg13_lv_pmos ad=0.3808p pd=2.92u as=0.2128p ps=1.5u w=1.12u l=0.6u
X19 a_16108_289# a_2019_311# a_16510_1044# VSS.t609 sg13_lv_nmos ad=0.2516p pd=2.16u as=0.2516p ps=2.16u w=0.74u l=0.13u
X20 VDD.t281 DELAY_VBIASP a_9431_2470# VDD.t7 sg13_lv_pmos ad=0.3808p pd=2.92u as=0.2128p ps=1.5u w=1.12u l=0.6u
X21 VSS.t172 VDD.t399 VSS.t171 VSS.t170 sg13_lv_nmos ad=0.1428p pd=1.52u as=0 ps=0 w=0.42u l=1u
X22 VSS.t459 VSS.t459 VSS.t461 VSS.t460 sg13_lv_nmos ad=0.68p pd=4.68u as=0 ps=0 w=2u l=1u
X23 VDD.t266 DELAY_VBIASP a_23111_2470# VDD.t7 sg13_lv_pmos ad=0.3808p pd=2.92u as=0.2128p ps=1.5u w=1.12u l=0.6u
X24 a_7390_1044# a_8231_1008# a_8155_1044# VDD.t0 sg13_lv_pmos ad=0.3808p pd=2.92u as=0.2128p ps=1.5u w=1.12u l=0.13u
X25 a_14009_5878# REF_CLK VDD.t14 VDD.t10 sg13_lv_pmos ad=0.4088p pd=2.97u as=1.03698p ps=6.245u w=1.12u l=0.13u
X26 VSS.t62 a_2595_311.t3 a_8745_519# VSS.t61 sg13_lv_nmos ad=0.2516p pd=2.16u as=0.2516p ps=2.16u w=0.74u l=0.13u
X27 a_11748_6109# DLL_RESETN VDD.t14 VDD.t10 sg13_lv_pmos ad=79.8f pd=0.8u as=1.10612p ps=6.66u w=0.42u l=0.13u
X28 VDD.t158 a_11491_6228# a_12158_5867# VDD.t10 sg13_lv_pmos ad=0.2128p pd=1.5u as=0.3864p ps=2.93u w=1.12u l=0.13u
X29 VDD.t273 DELAY_VBIASP DELAY_VBIASP VDD.t101 sg13_lv_pmos ad=0.3808p pd=2.92u as=1.0304p ps=4.08u w=1.12u l=0.6u
X30 a_17791_1842# a_17553_1842# a_17683_1842# VSS.t66 sg13_lv_nmos ad=0.1406p pd=1.12u as=0.2516p ps=2.16u w=0.74u l=0.2u
X31 VSS.t252 a_11748_6109# a_11397_6228# VSS.t250 sg13_lv_nmos ad=79.8f pd=0.8u as=0.1428p ps=1.52u w=0.42u l=0.13u
X32 VDD.t244 a_12037_1842# a_12505_1044# VDD.t0 sg13_lv_pmos ad=0.252p pd=1.57u as=0.3808p ps=2.92u w=1.12u l=0.13u
X33 a_16510_1044# a_2019_1047.t5 a_16408_1044# VSS.t617 sg13_lv_nmos ad=0.2516p pd=2.16u as=0.1406p ps=1.12u w=0.74u l=0.13u
X34 a_21591_1842# a_21353_1842# a_21483_1842# VSS.t579 sg13_lv_nmos ad=0.1406p pd=1.12u as=0.2516p ps=2.16u w=0.74u l=0.2u
X35 a_6153_1842# a_5957_1842# VSS.t260 VSS.t287 sg13_lv_nmos ad=0.2516p pd=2.16u as=0.1406p ps=1.12u w=0.74u l=0.13u
X36 VSS.t38 a_16163_1842# a_16597_1842# VSS.t283 sg13_lv_nmos ad=0.1406p pd=1.12u as=0.2516p ps=2.16u w=0.74u l=0.13u
X37 VSS.t303 a_3171_1047.t2 a_27124_1008# VSS.t302 sg13_lv_nmos ad=0.2516p pd=2.16u as=0.2516p ps=2.16u w=0.74u l=0.13u
X38 VDD.t209 a_11603_1842# a_12037_1842# VDD.t7 sg13_lv_pmos ad=0.2128p pd=1.5u as=0.3808p ps=2.92u w=1.12u l=0.13u
X39 VDD.t130 a_3171_311.t3 a_11785_519# VDD.t0 sg13_lv_pmos ad=0.3808p pd=2.92u as=0.3808p ps=2.92u w=1.12u l=0.13u
X40 a_6126_3816# a_6326_4590# VDD.t322 VDD.t10 sg13_lv_pmos ad=0.38p pd=2.38u as=0.38p ps=2.38u w=2u l=1u
X41 a_24393_1842# a_24197_1842# VDD.t174 VDD.t7 sg13_lv_pmos ad=0.3808p pd=2.92u as=0.2128p ps=1.5u w=1.12u l=0.13u
X42 a_5731_289# a_2595_311.t3 a_7390_1044# VSS.t60 sg13_lv_nmos ad=0.2516p pd=2.16u as=0.2516p ps=2.16u w=0.74u l=0.13u
X43 a_10430_1044# a_2595_1047.t7 a_11195_1044# VSS.t317 sg13_lv_nmos ad=0.2516p pd=2.16u as=0.1406p ps=1.12u w=0.74u l=0.13u
X44 a_13306_6305# a_12355_5867# VDD.t250 VDD.t10 sg13_lv_pmos ad=79.8f pd=0.8u as=0.1428p ps=1.52u w=0.42u l=0.13u
X45 a_23355_1044# a_23145_1044# VSS.t24 VSS.t47 sg13_lv_nmos ad=0.1406p pd=1.12u as=0.1665p ps=1.19u w=0.74u l=0.13u
X46 VDD.t285 DELAY_VBIASP a_14751_2470# VDD.t7 sg13_lv_pmos ad=0.3808p pd=2.92u as=0.2128p ps=1.5u w=1.12u l=0.6u
X47 VSS.t332 DELAY_VBIASN a_10191_1842# VSS.t392 sg13_lv_nmos ad=0.2516p pd=2.16u as=0.1406p ps=1.12u w=0.74u l=0.6u
X48 VSS.t31 a_3747_1047.t4 a_21911_1008# VSS.t30 sg13_lv_nmos ad=0.2516p pd=2.16u as=0.2516p ps=2.16u w=0.74u l=0.13u
X49 VSS.t213 a_19963_1842# a_20397_1842# VSS.t212 sg13_lv_nmos ad=0.1406p pd=1.12u as=0.2516p ps=2.16u w=0.74u l=0.13u
X50 a_6126_3816# a_6326_4590# VDD.t327 VDD.t10 sg13_lv_pmos ad=0.38p pd=2.38u as=0.38p ps=2.38u w=2u l=1u
X51 VDD.t92 a_6326_4590# a_6854_5454# VDD.t10 sg13_lv_pmos ad=0.38p pd=2.38u as=0.38p ps=2.38u w=2u l=1u
X52 VDD.t270 DELAY_VBIASP a_4111_2470# VDD.t7 sg13_lv_pmos ad=0.3808p pd=2.92u as=0.2128p ps=1.5u w=1.12u l=0.6u
X53 a_10328_1044# a_9757_1842# VDD.t366 VDD.t0 sg13_lv_pmos ad=0.2128p pd=1.5u as=0.3808p ps=2.92u w=1.12u l=0.13u
X54 a_20968_1044# a_20397_1842# VSS.t313 VSS.t603 sg13_lv_nmos ad=0.1406p pd=1.12u as=0.2516p ps=2.16u w=0.74u l=0.13u
X55 a_22590_1044# a_22564_1008# a_22488_1044# VDD.t0 sg13_lv_pmos ad=0.3808p pd=2.92u as=0.2128p ps=1.5u w=1.12u l=0.13u
X56 VDD.t2 VSS.t135 VDD.t1 VDD.t0 sg13_lv_pmos ad=0.19p pd=1.38u as=0 ps=0 w=1u l=1u
X57 a_8808_1044# a_8237_1842# VDD.t367 VDD.t0 sg13_lv_pmos ad=0.2128p pd=1.5u as=0.3808p ps=2.92u w=1.12u l=0.13u
X58 VDD.t331 a_6326_4590# a_6326_4590# VDD.t10 sg13_lv_pmos ad=0.38p pd=2.38u as=0.38p ps=2.38u w=2u l=1u
X59 a_4157_1313# REF_CLK VDD.t253 VDD.t0 sg13_lv_pmos ad=0.3808p pd=2.92u as=0.3808p ps=2.92u w=1.12u l=0.13u
X60 a_17031_2470# a_16793_1842# a_16923_1842# VDD.t7 sg13_lv_pmos ad=0.2128p pd=1.5u as=0.3808p ps=2.92u w=1.12u l=0.2u
X61 a_11473_1842# a_11277_1842# VSS.t3 VSS.t270 sg13_lv_nmos ad=0.2516p pd=2.16u as=0.1406p ps=1.12u w=0.74u l=0.13u
X62 VSS.t167 VDD.t401 VSS.t165 VSS.t166 sg13_lv_nmos ad=79.8f pd=0.8u as=0 ps=0 w=0.42u l=1u
X63 a_13306_5105# a_13132_5420# VDD.t152 VDD.t10 sg13_lv_pmos ad=79.8f pd=0.8u as=0.1428p ps=1.52u w=0.42u l=0.13u
X64 a_19448_1044# a_18877_1842# VSS.t78 VSS.t540 sg13_lv_nmos ad=0.1406p pd=1.12u as=0.2516p ps=2.16u w=0.74u l=0.13u
X65 a_10430_1044# a_3171_1047.t7 a_11848_1044# VSS.t247 sg13_lv_nmos ad=0.2516p pd=2.16u as=0.1406p ps=1.12u w=0.74u l=0.13u
X66 a_20831_2470# a_20593_1842# a_20723_1842# VDD.t7 sg13_lv_pmos ad=0.2128p pd=1.5u as=0.3808p ps=2.92u w=1.12u l=0.2u
X67 VSS.t142 VDD.t408 VSS.t140 VSS.t141 sg13_lv_nmos ad=79.8f pd=0.8u as=0 ps=0 w=0.42u l=1u
X68 VDD.t42 a_27237_1842# a_27705_1044# VDD.t0 sg13_lv_pmos ad=0.252p pd=1.57u as=0.3808p ps=2.92u w=1.12u l=0.13u
X69 a_5393_1842# a_5197_1842# VDD.t35 VDD.t7 sg13_lv_pmos ad=0.3808p pd=2.92u as=0.2128p ps=1.5u w=1.12u l=0.13u
X70 VDD.t262 DELAY_VBIASP a_17031_2470# VDD.t7 sg13_lv_pmos ad=0.3808p pd=2.92u as=0.2128p ps=1.5u w=1.12u l=0.6u
X71 VDD.t14 a_15108_6109# a_15053_5990# VDD.t10 sg13_lv_pmos ad=1.10612p pd=6.66u as=93.45f ps=0.865u w=0.42u l=0.13u
X72 VDD.t327 a_6326_4590# a_6854_5454# VDD.t10 sg13_lv_pmos ad=0.38p pd=2.38u as=0.38p ps=2.38u w=2u l=1u
X73 a_13818_6292# a_12849_5867# VSS.t7 VSS.t9 sg13_lv_nmos ad=37.8f pd=0.6u as=0.1701p ps=1.65u w=0.42u l=0.13u
X74 VDD.t155 a_26803_1842# a_27237_1842# VDD.t7 sg13_lv_pmos ad=0.2128p pd=1.5u as=0.3808p ps=2.92u w=1.12u l=0.13u
X75 VDD.t73 MUX_SEL1 a_3449_1395# VDD.t0 sg13_lv_pmos ad=0.1918p pd=1.5u as=0.1596p ps=1.22u w=0.84u l=0.13u
X76 a_14851_6228# a_14009_5878# a_13592_5871# VDD.t10 sg13_lv_pmos ad=0.2048p pd=1.63u as=0.34p ps=2.68u w=1u l=0.13u
X77 a_25630_1044# a_2595_1047.t2 a_26395_1044# VSS.t353 sg13_lv_nmos ad=0.2516p pd=2.16u as=0.1406p ps=1.12u w=0.74u l=0.13u
X78 VSS.t203 DELAY_VBIASN a_25391_1842# VSS.t386 sg13_lv_nmos ad=0.2516p pd=2.16u as=0.1406p ps=1.12u w=0.74u l=0.6u
X79 VSS.t414 DELAY_VBIASN VSS.t413 VSS.t405 sg13_lv_nmos ad=1.33p pd=7.38u as=0 ps=0 w=7u l=7u
X80 a_6635_1044# a_6425_1044# VDD.t161 VDD.t0 sg13_lv_pmos ad=0.2128p pd=1.5u as=0.252p ps=1.57u w=1.12u l=0.13u
X81 VDD.t179 DLL_RESETN a_9946_6305# VDD.t10 sg13_lv_pmos ad=0.36237p pd=2.605u as=79.8f ps=0.8u w=0.42u l=0.13u
X82 a_20315_1044# a_20105_1044# VDD.t137 VDD.t0 sg13_lv_pmos ad=0.2128p pd=1.5u as=0.252p ps=1.57u w=1.12u l=0.13u
X83 VDD.t259 a_2595_1047.t9 a_5191_1008# VDD.t0 sg13_lv_pmos ad=0.3808p pd=2.92u as=0.3808p ps=2.92u w=1.12u l=0.13u
X84 a_19311_2470# a_19073_1842# a_19203_1842# VDD.t7 sg13_lv_pmos ad=0.2128p pd=1.5u as=0.3808p ps=2.92u w=1.12u l=0.2u
X85 VSS.t17 a_1721_1395# a_2019_1047.t1 VSS.t44 sg13_lv_nmos ad=0.2812p pd=2.24u as=0.1406p ps=1.12u w=0.74u l=0.13u
X86 a_25528_1044# a_24957_1842# VDD.t359 VDD.t0 sg13_lv_pmos ad=0.2128p pd=1.5u as=0.3808p ps=2.92u w=1.12u l=0.13u
X87 VSS.t256 a_5957_1842# a_6425_1044# VSS.t288 sg13_lv_nmos ad=0.1665p pd=1.19u as=0.2516p ps=2.16u w=0.74u l=0.13u
X88 VSS.t364 a_2019_1047.t6 a_13444_1008# VSS.t363 sg13_lv_nmos ad=0.2516p pd=2.16u as=0.2516p ps=2.16u w=0.74u l=0.13u
X89 a_23111_2470# a_22873_1842# a_23003_1842# VDD.t7 sg13_lv_pmos ad=0.2128p pd=1.5u as=0.3808p ps=2.92u w=1.12u l=0.2u
X90 VSS.t123 VDD.t413 VSS.t123 VSS.t122 sg13_lv_nmos ad=0.1428p pd=1.52u as=0 ps=0 w=0.42u l=1u
X91 VSS.t109 a_15964_289# a_16851_309# VSS.t108 sg13_lv_nmos ad=0.1371p pd=1.12u as=0.2176p ps=1.96u w=0.64u l=0.13u
X92 a_10713_1842# a_10517_1842# VDD.t204 VDD.t7 sg13_lv_pmos ad=0.3808p pd=2.92u as=0.2128p ps=1.5u w=1.12u l=0.13u
X93 VDD.t171 a_17683_1842# a_18117_1842# VDD.t7 sg13_lv_pmos ad=0.2128p pd=1.5u as=0.3808p ps=2.92u w=1.12u l=0.13u
X94 a_16108_289# a_17865_519# a_16510_1044# VDD.t0 sg13_lv_pmos ad=0.3808p pd=2.92u as=0.3808p ps=2.92u w=1.12u l=0.13u
X95 a_26673_1842# a_26477_1842# VSS.t22 VSS.t21 sg13_lv_nmos ad=0.2516p pd=2.16u as=0.1406p ps=1.12u w=0.74u l=0.13u
X96 VDD.t338 a_7803_1842# a_8237_1842# VDD.t7 sg13_lv_pmos ad=0.2128p pd=1.5u as=0.3808p ps=2.92u w=1.12u l=0.13u
X97 a_4248_1044# a_4157_1313# VSS.t321 VSS.t558 sg13_lv_nmos ad=0.1406p pd=1.12u as=0.2516p ps=2.16u w=0.74u l=0.13u
X98 a_16108_289# a_3171_311.t2 a_22590_1044# VSS.t304 sg13_lv_nmos ad=0.2516p pd=2.16u as=0.2516p ps=2.16u w=0.74u l=0.13u
X99 VSS.t377 DELAY_VBIASN a_6391_1842# VSS.t430 sg13_lv_nmos ad=0.2516p pd=2.16u as=0.1406p ps=1.12u w=0.74u l=0.6u
X100 a_16408_1044# a_15837_1842# VDD.t395 VDD.t0 sg13_lv_pmos ad=0.2128p pd=1.5u as=0.3808p ps=2.92u w=1.12u l=0.13u
X101 a_10232_5871# a_10206_5835# VSS.t286 VSS.t285 sg13_lv_nmos ad=0.2516p pd=2.16u as=0.1626p ps=1.415u w=0.74u l=0.13u
X102 a_19550_1044# a_3747_1047.t4 a_21835_1044# VSS.t29 sg13_lv_nmos ad=0.2516p pd=2.16u as=0.1406p ps=1.12u w=0.74u l=0.13u
X103 VSS.t107 DELAY_VBIASN a_20831_1842# VSS.t436 sg13_lv_nmos ad=0.2516p pd=2.16u as=0.1406p ps=1.12u w=0.74u l=0.6u
X104 a_3171_311.t0 a_2873_331# VDD.t387 VDD.t0 sg13_lv_pmos ad=0.2128p pd=1.5u as=0.1918p ps=1.5u w=1.12u l=0.13u
X105 a_15304_4605# a_14851_6228# VDD.t255 VDD.t10 sg13_lv_pmos ad=0.4312p pd=3.01u as=0.2639p ps=1.81u w=1.12u l=0.13u
X106 a_13106_5357# a_12907_5420# VSS.t57 VSS.t258 sg13_lv_nmos ad=0.27427p pd=2.28u as=1.45407p ps=9.445u w=0.795u l=0.13u
X107 a_3747_311.t0 a_3449_331# VDD.t61 VDD.t0 sg13_lv_pmos ad=0.2128p pd=1.5u as=0.1918p ps=1.5u w=1.12u l=0.13u
X108 a_13132_5420# a_13106_5357# VDD.t14 VDD.t10 sg13_lv_pmos ad=0.3927p pd=2.99u as=1.10612p ps=6.66u w=1.155u l=0.13u
X109 a_7390_1044# a_9751_1008# a_9675_1044# VDD.t0 sg13_lv_pmos ad=0.3808p pd=2.92u as=0.2128p ps=1.5u w=1.12u l=0.13u
X110 VSS.t422 DELAY_VBIASN VSS.t420 VSS.t401 sg13_lv_nmos ad=1.33p pd=7.38u as=0 ps=0 w=7u l=7u
X111 a_10191_1842# a_9953_1842# a_10083_1842# VSS.t267 sg13_lv_nmos ad=0.1406p pd=1.12u as=0.2516p ps=2.16u w=0.74u l=0.2u
X112 VSS.t24 a_22677_1842# a_23145_1044# VSS.t23 sg13_lv_nmos ad=0.1665p pd=1.19u as=0.2516p ps=2.16u w=0.74u l=0.13u
X113 a_14751_2470# a_14513_1842# a_14643_1842# VDD.t7 sg13_lv_pmos ad=0.2128p pd=1.5u as=0.3808p ps=2.92u w=1.12u l=0.2u
X114 a_5731_289# a_8745_519# a_7390_1044# VDD.t0 sg13_lv_pmos ad=0.3808p pd=2.92u as=0.3808p ps=2.92u w=1.12u l=0.13u
X115 VDD.t113 VDD.t114 VDD.t115 VDD.t7 sg13_lv_pmos ad=0.2128p pd=1.5u as=0 ps=0 w=1.12u l=0.13u
X116 a_4111_2470# REF_CLK a_4003_1842# VDD.t7 sg13_lv_pmos ad=0.2128p pd=1.5u as=0.3808p ps=2.92u w=1.12u l=0.2u
X117 a_13566_5835# a_14009_5878# a_13306_6305# VSS.t450 sg13_lv_nmos ad=79.8f pd=0.8u as=0.1296p ps=1.52u w=0.42u l=0.13u
X118 a_13306_6305# a_14111_5878# a_13566_5835# VDD.t10 sg13_lv_pmos ad=0.1428p pd=1.52u as=79.8f ps=0.8u w=0.42u l=0.13u
X119 a_13592_5423# a_14111_5227# a_14851_5182# VSS.t574 sg13_lv_nmos ad=0.3473p pd=2.71u as=0.12665p ps=1.145u w=0.74u l=0.13u
X120 a_7673_1842# a_7477_1842# VSS.t380 VSS.t553 sg13_lv_nmos ad=0.2516p pd=2.16u as=0.1406p ps=1.12u w=0.74u l=0.13u
X121 VDD.t358 a_3171_1047.t5 a_18004_1008# VDD.t0 sg13_lv_pmos ad=0.3808p pd=2.92u as=0.3808p ps=2.92u w=1.12u l=0.13u
X122 VDD.t72 a_13123_1842# a_13557_1842# VDD.t7 sg13_lv_pmos ad=0.2128p pd=1.5u as=0.3808p ps=2.92u w=1.12u l=0.13u
X123 VDD.t125 a_3747_311.t2 a_26985_519# VDD.t0 sg13_lv_pmos ad=0.3808p pd=2.92u as=0.3808p ps=2.92u w=1.12u l=0.13u
X124 a_25913_1842# a_25717_1842# VDD.t133 VDD.t7 sg13_lv_pmos ad=0.3808p pd=2.92u as=0.2128p ps=1.5u w=1.12u l=0.13u
X125 a_10430_1044# a_3747_1047.t7 a_12715_1044# VSS.t298 sg13_lv_nmos ad=0.2516p pd=2.16u as=0.1406p ps=1.12u w=0.74u l=0.13u
X126 a_6326_4590# a_5974_5723# a_6126_3816# VSS.t41 sg13_lv_nmos ad=0.38p pd=2.38u as=0.68p ps=4.68u w=2u l=1u
X127 a_14235_1044# a_14025_1044# VDD.t153 VDD.t0 sg13_lv_pmos ad=0.2128p pd=1.5u as=0.252p ps=1.57u w=1.12u l=0.13u
X128 a_24875_1044# a_24665_1044# VSS.t538 VSS.t559 sg13_lv_nmos ad=0.1406p pd=1.12u as=0.1665p ps=1.19u w=0.74u l=0.13u
X129 VSS.t350 DELAY_VBIASN a_11711_1842# VSS.t391 sg13_lv_nmos ad=0.2516p pd=2.16u as=0.1406p ps=1.12u w=0.74u l=0.6u
X130 VDD.t187 a_3747_1047.t7 a_12791_1008# VDD.t0 sg13_lv_pmos ad=0.3808p pd=2.92u as=0.3808p ps=2.92u w=1.12u l=0.13u
X131 VSS.t215 a_2595_1047.t3 a_23431_1008# VSS.t230 sg13_lv_nmos ad=0.2516p pd=2.16u as=0.2516p ps=2.16u w=0.74u l=0.13u
X132 VSS.t1 a_21483_1842# a_21917_1842# VSS.t0 sg13_lv_nmos ad=0.1406p pd=1.12u as=0.2516p ps=2.16u w=0.74u l=0.13u
X133 VSS.t240 a_13557_1842# a_14025_1044# VSS.t239 sg13_lv_nmos ad=0.1665p pd=1.19u as=0.2516p ps=2.16u w=0.74u l=0.13u
X134 a_11848_1044# a_11277_1842# VDD.t170 VDD.t0 sg13_lv_pmos ad=0.2128p pd=1.5u as=0.3808p ps=2.92u w=1.12u l=0.13u
X135 VDD.t353 VSS.t178 VDD.t176 VDD.t0 sg13_lv_pmos ad=0.19p pd=1.38u as=0 ps=0 w=1u l=1u
X136 VDD.t14 a_12907_5186# a_12907_5420# VDD.t10 sg13_lv_pmos ad=1.10612p pd=6.66u as=0.2442p ps=2.06u w=0.66u l=0.13u
X137 a_25391_1842# a_25153_1842# a_25283_1842# VSS.t612 sg13_lv_nmos ad=0.1406p pd=1.12u as=0.2516p ps=2.16u w=0.74u l=0.2u
X138 a_12993_1842# a_12797_1842# VSS.t75 VSS.t74 sg13_lv_nmos ad=0.2516p pd=2.16u as=0.1406p ps=1.12u w=0.74u l=0.13u
X139 DELAY_OUT_LAST a_27997_1842# VDD.t261 VDD.t7 sg13_lv_pmos ad=0.3808p pd=2.92u as=0.2128p ps=1.5u w=1.12u l=0.13u
X140 VDD.t355 VSS.t178 VDD.t354 VDD.t0 sg13_lv_pmos ad=0.34p pd=2.68u as=0 ps=0 w=1u l=1u
X141 VDD.t137 a_19637_1842# a_20105_1044# VDD.t0 sg13_lv_pmos ad=0.252p pd=1.57u as=0.3808p ps=2.92u w=1.12u l=0.13u
X142 a_6854_5454# a_6326_4590# VDD.t324 VDD.t10 sg13_lv_pmos ad=0.38p pd=2.38u as=0.38p ps=2.38u w=2u l=1u
X143 VSS.t223 DELAY_VBIASN a_13991_1842# VSS.t388 sg13_lv_nmos ad=0.2516p pd=2.16u as=0.1406p ps=1.12u w=0.74u l=0.6u
X144 VSS.t165 VDD.t401 VSS.t165 VSS.t164 sg13_lv_nmos ad=0.1428p pd=1.52u as=0 ps=0 w=0.42u l=1u
X145 a_22590_1044# a_3171_1047.t3 a_24008_1044# VSS.t68 sg13_lv_nmos ad=0.2516p pd=2.16u as=0.1406p ps=1.12u w=0.74u l=0.13u
X146 a_6913_1842# a_6717_1842# VDD.t230 VDD.t7 sg13_lv_pmos ad=0.3808p pd=2.92u as=0.2128p ps=1.5u w=1.12u l=0.13u
X147 VDD.t289 DELAY_VBIASP a_18551_2470# VDD.t7 sg13_lv_pmos ad=0.3808p pd=2.92u as=0.2128p ps=1.5u w=1.12u l=0.6u
X148 VSS.t281 a_23763_1842# a_24197_1842# VSS.t280 sg13_lv_nmos ad=0.1406p pd=1.12u as=0.2516p ps=2.16u w=0.74u l=0.13u
X149 VSS.t140 VDD.t408 VSS.t139 VSS.t138 sg13_lv_nmos ad=0.1428p pd=1.52u as=0 ps=0 w=0.42u l=1u
X150 VDD.t134 a_1256_1044# a_2873_1395# VDD.t0 sg13_lv_pmos ad=0.1918p pd=1.5u as=0.1596p ps=1.22u w=0.84u l=0.13u
X151 a_3171_311.t1 a_2873_331# VSS.t262 VSS.t613 sg13_lv_nmos ad=0.1406p pd=1.12u as=0.1331p ps=1.12u w=0.74u l=0.13u
X152 VDD.t388 a_2873_331# a_3171_311.t0 VDD.t0 sg13_lv_pmos ad=0.4256p pd=3u as=0.2128p ps=1.5u w=1.12u l=0.13u
X153 a_16510_1044# a_17351_1008# a_17275_1044# VDD.t0 sg13_lv_pmos ad=0.3808p pd=2.92u as=0.2128p ps=1.5u w=1.12u l=0.13u
X154 a_25630_1044# a_3747_1047.t2 a_27915_1044# VSS.t295 sg13_lv_nmos ad=0.2516p pd=2.16u as=0.1406p ps=1.12u w=0.74u l=0.13u
X155 VSS.t243 DELAY_VBIASN a_26911_1842# VSS.t447 sg13_lv_nmos ad=0.2516p pd=2.16u as=0.1406p ps=1.12u w=0.74u l=0.6u
X156 a_3747_311.t1 a_3449_331# VSS.t80 VSS.t79 sg13_lv_nmos ad=0.1406p pd=1.12u as=0.1331p ps=1.12u w=0.74u l=0.13u
X157 VDD.t62 a_3449_331# a_3747_311.t0 VDD.t0 sg13_lv_pmos ad=0.4256p pd=3u as=0.2128p ps=1.5u w=1.12u l=0.13u
X158 VDD.t268 DELAY_VBIASP a_22351_2470# VDD.t7 sg13_lv_pmos ad=0.3808p pd=2.92u as=0.2128p ps=1.5u w=1.12u l=0.6u
X159 VDD.t186 a_3747_1047.t2 a_27991_1008# VDD.t0 sg13_lv_pmos ad=0.3808p pd=2.92u as=0.3808p ps=2.92u w=1.12u l=0.13u
X160 VDD.t128 VSS.t121 VDD.t29 VDD.t0 sg13_lv_pmos ad=0.19p pd=1.38u as=0 ps=0 w=1u l=1u
X161 a_13019_5831# a_15688_5403# VSS.t13 VSS.t42 sg13_lv_nmos ad=0.2516p pd=2.16u as=0.1406p ps=1.12u w=0.74u l=0.13u
X162 VDD.t228 a_3747_1047.t9 a_6711_1008# VDD.t0 sg13_lv_pmos ad=0.3808p pd=2.92u as=0.3808p ps=2.92u w=1.12u l=0.13u
X163 a_6854_5454# a_6326_4590# VDD.t95 VDD.t10 sg13_lv_pmos ad=0.38p pd=2.38u as=0.38p ps=2.38u w=2u l=1u
X164 a_9772_5843# a_9746_5805# VDD.t14 VDD.t10 sg13_lv_pmos ad=0.3927p pd=2.99u as=1.10612p ps=6.66u w=1.155u l=0.13u
X165 a_6391_1842# a_6153_1842# a_6283_1842# VSS.t237 sg13_lv_nmos ad=0.1406p pd=1.12u as=0.2516p ps=2.16u w=0.74u l=0.2u
X166 a_15273_1842# a_15077_1842# VSS.t356 VSS.t564 sg13_lv_nmos ad=0.2516p pd=2.16u as=0.1406p ps=1.12u w=0.74u l=0.13u
X167 a_19833_1842# a_19637_1842# VDD.t183 VDD.t7 sg13_lv_pmos ad=0.3808p pd=2.92u as=0.2128p ps=1.5u w=1.12u l=0.13u
X168 a_16108_289# a_23945_519# a_22590_1044# VDD.t0 sg13_lv_pmos ad=0.3808p pd=2.92u as=0.3808p ps=2.92u w=1.12u l=0.13u
X169 VDD.t329 a_6326_4590# a_6126_3816# VDD.t10 sg13_lv_pmos ad=0.38p pd=2.38u as=0.38p ps=2.38u w=2u l=1u
X170 a_9193_1842# a_8997_1842# VDD.t46 VDD.t7 sg13_lv_pmos ad=0.3808p pd=2.92u as=0.2128p ps=1.5u w=1.12u l=0.13u
X171 a_24631_2470# a_24393_1842# a_24523_1842# VDD.t7 sg13_lv_pmos ad=0.2128p pd=1.5u as=0.3808p ps=2.92u w=1.12u l=0.2u
X172 VSS.t89 a_15403_1842# a_15837_1842# VSS.t88 sg13_lv_nmos ad=0.1406p pd=1.12u as=0.2516p ps=2.16u w=0.74u l=0.13u
X173 a_8155_1044# a_7945_1044# VSS.t182 VSS.t181 sg13_lv_nmos ad=0.1406p pd=1.12u as=0.1665p ps=1.19u w=0.74u l=0.13u
X174 a_23633_1842# a_23437_1842# VDD.t17 VDD.t7 sg13_lv_pmos ad=0.3808p pd=2.92u as=0.2128p ps=1.5u w=1.12u l=0.13u
X175 VSS.t36 a_4763_1842# a_5197_1842# VSS.t264 sg13_lv_nmos ad=0.1406p pd=1.12u as=0.2516p ps=2.16u w=0.74u l=0.13u
X176 a_27048_1044# a_26477_1842# VSS.t20 VSS.t19 sg13_lv_nmos ad=0.1406p pd=1.12u as=0.2516p ps=2.16u w=0.74u l=0.13u
X177 VDD.t136 a_9323_1842# a_9757_1842# VDD.t7 sg13_lv_pmos ad=0.2128p pd=1.5u as=0.3808p ps=2.92u w=1.12u l=0.13u
X178 a_5768_1044# a_5197_1842# VSS.t34 VSS.t33 sg13_lv_nmos ad=0.1406p pd=1.12u as=0.2516p ps=2.16u w=0.74u l=0.13u
X179 a_6326_4590# a_6126_3816# a_5778_3367# VSS.t334 sg13_lv_nmos ad=0.38p pd=2.38u as=0.68p ps=4.68u w=2u l=1u
X180 DELAY_VBIASN DLL_RESETN VDD.t221 VDD.t101 sg13_lv_pmos ad=0.158p pd=1.245u as=0.272p ps=2.28u w=0.8u l=0.2u
X181 a_7390_1044# a_7364_1008# a_7288_1044# VDD.t0 sg13_lv_pmos ad=0.3808p pd=2.92u as=0.2128p ps=1.5u w=1.12u l=0.13u
X182 VSS.t412 DELAY_VBIASN VSS.t411 VSS.t394 sg13_lv_nmos ad=2.38p pd=14.68u as=0 ps=0 w=7u l=7u
X183 VSS.t383 DELAY_VBIASN a_7911_1842# VSS.t382 sg13_lv_nmos ad=0.2516p pd=2.16u as=0.1406p ps=1.12u w=0.74u l=0.6u
X184 VDD.t24 a_13019_5831# a_12943_5867# VDD.t10 sg13_lv_pmos ad=0.2128p pd=1.5u as=0.2128p ps=1.5u w=1.12u l=0.13u
X185 a_6854_5986# a_15304_4605# DELAY_VBIASN VDD.t101 sg13_lv_pmos ad=0.136p pd=1.14u as=0.158p ps=1.245u w=0.4u l=0.2u
X186 VDD.t60 VSS.t146 VDD.t58 VDD.t0 sg13_lv_pmos ad=0.19p pd=1.38u as=0 ps=0 w=1u l=1u
X187 a_11711_1842# a_11473_1842# a_11603_1842# VSS.t59 sg13_lv_nmos ad=0.1406p pd=1.12u as=0.2516p ps=2.16u w=0.74u l=0.2u
X188 VSS.t538 a_24197_1842# a_24665_1044# VSS.t537 sg13_lv_nmos ad=0.1665p pd=1.19u as=0.2516p ps=2.16u w=0.74u l=0.13u
X189 a_16510_1044# a_3171_1047.t5 a_17928_1044# VSS.t583 sg13_lv_nmos ad=0.2516p pd=2.16u as=0.1406p ps=1.12u w=0.74u l=0.13u
X190 a_15270_5105# a_12849_5867# VSS.t13 VSS.t12 sg13_lv_nmos ad=37.8f pd=0.6u as=79.8f ps=0.8u w=0.42u l=0.13u
X191 a_5974_5723# a_6126_3816# VSS.t338 VSS.t41 sg13_lv_nmos ad=0.38p pd=2.38u as=0.68p ps=4.68u w=2u l=1u
X192 VSS.t135 VDD.t410 VSS.t133 VSS.t134 sg13_lv_nmos ad=79.8f pd=0.8u as=0 ps=0 w=0.42u l=1u
X193 a_5631_2470# a_5393_1842# a_5523_1842# VDD.t7 sg13_lv_pmos ad=0.2128p pd=1.5u as=0.3808p ps=2.92u w=1.12u l=0.2u
X194 a_14513_1842# a_14317_1842# VDD.t146 VDD.t7 sg13_lv_pmos ad=0.3808p pd=2.92u as=0.2128p ps=1.5u w=1.12u l=0.13u
X195 a_4633_1842# a_4437_1842# VDD.t160 VDD.t7 sg13_lv_pmos ad=0.3808p pd=2.92u as=0.2128p ps=1.5u w=1.12u l=0.13u
X196 VSS.t332 a_10083_1842# a_10517_1842# VSS.t331 sg13_lv_nmos ad=0.1406p pd=1.12u as=0.2516p ps=2.16u w=0.74u l=0.13u
X197 VDD.t198 a_2019_1047.t4 a_19524_1008# VDD.t0 sg13_lv_pmos ad=0.3808p pd=2.92u as=0.3808p ps=2.92u w=1.12u l=0.13u
X198 VSS.t577 a_3171_1047.t4 a_21044_1008# VSS.t576 sg13_lv_nmos ad=0.2516p pd=2.16u as=0.2516p ps=2.16u w=0.74u l=0.13u
X199 VSS.t262 a_2873_331# a_3171_311.t1 VSS.t614 sg13_lv_nmos ad=0.2812p pd=2.24u as=0.1406p ps=1.12u w=0.74u l=0.13u
X200 a_13949_5496# a_13592_5423# VDD.t15 VDD.t10 sg13_lv_pmos ad=63f pd=0.72u as=0.1563p ps=1.22u w=0.42u l=0.13u
X201 VSS.t80 a_3449_331# a_3747_311.t1 VSS.t81 sg13_lv_nmos ad=0.2812p pd=2.24u as=0.1406p ps=1.12u w=0.74u l=0.13u
X202 a_15755_1044# a_15545_1044# VDD.t310 VDD.t0 sg13_lv_pmos ad=0.2128p pd=1.5u as=0.252p ps=1.57u w=1.12u l=0.13u
X203 VDD.t192 a_2595_1047.t6 a_14311_1008# VDD.t0 sg13_lv_pmos ad=0.3808p pd=2.92u as=0.3808p ps=2.92u w=1.12u l=0.13u
X204 VSS.t294 DELAY_VBIASN a_24631_1842# VSS.t381 sg13_lv_nmos ad=0.2516p pd=2.16u as=0.1406p ps=1.12u w=0.74u l=0.6u
X205 a_5115_1044# a_4905_1044# VDD.t87 VDD.t0 sg13_lv_pmos ad=0.2128p pd=1.5u as=0.252p ps=1.57u w=1.12u l=0.13u
X206 a_5974_5723# a_6126_3816# VSS.t340 VSS.t41 sg13_lv_nmos ad=0.38p pd=2.38u as=0.68p ps=4.68u w=2u l=1u
X207 VSS.t57 a_12907_5186# a_12907_5186# VSS.t357 sg13_lv_nmos ad=1.45407p pd=9.445u as=0.111p ps=1.34u w=0.3u l=0.13u
X208 a_18551_2470# a_18313_1842# a_18443_1842# VDD.t7 sg13_lv_pmos ad=0.2128p pd=1.5u as=0.3808p ps=2.92u w=1.12u l=0.2u
X209 VDD.t351 VSS.t163 VDD.t69 VDD.t0 sg13_lv_pmos ad=0.19p pd=1.38u as=0 ps=0 w=1u l=1u
X210 a_3171_1047.t1 a_2873_1395# VSS.t205 VSS.t204 sg13_lv_nmos ad=0.1406p pd=1.12u as=0.1331p ps=1.12u w=0.74u l=0.13u
X211 a_13121_5831# a_15688_5867# VSS.t512 VSS.t582 sg13_lv_nmos ad=0.2516p pd=2.16u as=0.1406p ps=1.12u w=0.74u l=0.13u
X212 VSS.t402 DELAY_VBIASN VSS.t404 VSS.t403 sg13_lv_nmos ad=1.33p pd=7.38u as=0 ps=0 w=7u l=7u
X213 VSS.t17 a_2297_1395# a_2595_1047.t1 VSS.t18 sg13_lv_nmos ad=0.2812p pd=2.24u as=0.1406p ps=1.12u w=0.74u l=0.13u
X214 VDD.t142 a_14851_5182# a_15108_5325# VDD.t10 sg13_lv_pmos ad=0.2639p pd=1.81u as=79.8f ps=0.8u w=0.42u l=0.13u
X215 a_22351_2470# a_22113_1842# a_22243_1842# VDD.t7 sg13_lv_pmos ad=0.2128p pd=1.5u as=0.3808p ps=2.92u w=1.12u l=0.2u
X216 VSS.t483 VSS.t483 VSS.t485 VSS.t484 sg13_lv_nmos ad=0.2516p pd=2.16u as=0 ps=0 w=0.74u l=0.13u
X217 a_26911_1842# a_26673_1842# a_26803_1842# VSS.t594 sg13_lv_nmos ad=0.1406p pd=1.12u as=0.2516p ps=2.16u w=0.74u l=0.2u
X218 VSS.t139 a_3171_311.t3 a_11785_519# VSS.t198 sg13_lv_nmos ad=0.2516p pd=2.16u as=0.2516p ps=2.16u w=0.74u l=0.13u
X219 VDD.t41 a_1721_1395# a_2019_1047.t0 VDD.t0 sg13_lv_pmos ad=0.4256p pd=3u as=0.2128p ps=1.5u w=1.12u l=0.13u
X220 a_12656_5864# DLL_RESETN VSS.t252 VSS.t360 sg13_lv_nmos ad=0.2516p pd=2.16u as=0.2516p ps=2.16u w=0.74u l=0.13u
X221 a_14851_6228# a_14009_5878# a_14757_6228# VSS.t10 sg13_lv_nmos ad=0.12665p pd=1.145u as=0.1428p ps=1.52u w=0.42u l=0.13u
X222 VDD.t44 a_16923_1842# a_17357_1842# VDD.t7 sg13_lv_pmos ad=0.2128p pd=1.5u as=0.3808p ps=2.92u w=1.12u l=0.13u
X223 a_2391_1395# MUX_SEL0 a_2297_1395# VSS.t545 sg13_lv_nmos ad=0.1216p pd=1.02u as=0.2176p ps=1.96u w=0.64u l=0.13u
X224 VSS.t17 a_1544_1044# a_1815_1395# VSS.t266 sg13_lv_nmos ad=0.1331p pd=1.12u as=0.1216p ps=1.02u w=0.64u l=0.13u
X225 a_13368_1044# a_12797_1842# VSS.t73 VSS.t72 sg13_lv_nmos ad=0.1406p pd=1.12u as=0.2516p ps=2.16u w=0.74u l=0.13u
X226 a_13400_5105# a_13132_5420# a_13306_5105# VSS.t238 sg13_lv_nmos ad=60.89999f pd=0.71u as=0.1428p ps=1.52u w=0.42u l=0.13u
X227 a_5731_289# a_3171_311.t3 a_10430_1044# VSS.t197 sg13_lv_nmos ad=0.2516p pd=2.16u as=0.2516p ps=2.16u w=0.74u l=0.13u
X228 VDD.t65 a_21157_1842# a_21625_1044# VDD.t0 sg13_lv_pmos ad=0.252p pd=1.57u as=0.3808p ps=2.92u w=1.12u l=0.13u
X229 VDD.t282 DELAY_VBIASP a_10951_2470# VDD.t7 sg13_lv_pmos ad=0.3808p pd=2.92u as=0.2128p ps=1.5u w=1.12u l=0.6u
X230 VSS.t89 DELAY_VBIASN a_15511_1842# VSS.t437 sg13_lv_nmos ad=0.2516p pd=2.16u as=0.1406p ps=1.12u w=0.74u l=0.6u
X231 a_6326_4590# a_6326_4590# VDD.t320 VDD.t10 sg13_lv_pmos ad=0.38p pd=2.38u as=0.38p ps=2.38u w=2u l=1u
X232 VSS.t418 DELAY_VBIASN VSS.t412 VSS.t397 sg13_lv_nmos ad=1.33p pd=7.38u as=0 ps=0 w=7u l=7u
X233 VDD.t80 a_20723_1842# a_21157_1842# VDD.t7 sg13_lv_pmos ad=0.2128p pd=1.5u as=0.3808p ps=2.92u w=1.12u l=0.13u
X234 VSS.t203 a_25283_1842# a_25717_1842# VSS.t345 sg13_lv_nmos ad=0.1406p pd=1.12u as=0.2516p ps=2.16u w=0.74u l=0.13u
X235 a_4350_1044# a_3747_1047.t9 a_6635_1044# VSS.t371 sg13_lv_nmos ad=0.2516p pd=2.16u as=0.1406p ps=1.12u w=0.74u l=0.13u
X236 VSS.t260 DELAY_VBIASN a_5631_1842# VSS.t387 sg13_lv_nmos ad=0.2516p pd=2.16u as=0.1406p ps=1.12u w=0.74u l=0.6u
X237 VDD.t197 a_2019_1047.t9 a_4324_1008# VDD.t0 sg13_lv_pmos ad=0.3808p pd=2.92u as=0.3808p ps=2.92u w=1.12u l=0.13u
X238 a_12849_5867# a_12656_5864# VSS.t252 VSS.t374 sg13_lv_nmos ad=0.1406p pd=1.12u as=0.2516p ps=2.16u w=0.74u l=0.13u
X239 a_16510_1044# a_18871_1008# a_18795_1044# VDD.t0 sg13_lv_pmos ad=0.3808p pd=2.92u as=0.2128p ps=1.5u w=1.12u l=0.13u
X240 a_19550_1044# a_2595_1047.t4 a_20315_1044# VSS.t311 sg13_lv_nmos ad=0.2516p pd=2.16u as=0.1406p ps=1.12u w=0.74u l=0.13u
X241 VDD.t324 a_6326_4590# a_6126_3816# VDD.t10 sg13_lv_pmos ad=0.38p pd=2.38u as=0.38p ps=2.38u w=2u l=1u
X242 VDD.t14 a_11491_6228# a_11748_6109# VDD.t10 sg13_lv_pmos ad=1.10612p pd=6.66u as=79.8f ps=0.8u w=0.42u l=0.13u
X243 a_12355_5867# a_12158_5867# VDD.t158 VDD.t10 sg13_lv_pmos ad=0.3808p pd=2.92u as=0.2128p ps=1.5u w=1.12u l=0.13u
X244 VDD.t290 DELAY_VBIASP a_23871_2470# VDD.t7 sg13_lv_pmos ad=0.3808p pd=2.92u as=0.2128p ps=1.5u w=1.12u l=0.6u
X245 VSS.t182 a_7477_1842# a_7945_1044# VSS.t554 sg13_lv_nmos ad=0.1665p pd=1.19u as=0.2516p ps=2.16u w=0.74u l=0.13u
X246 a_11910_6305# DLL_RESETN VSS.t252 VSS.t250 sg13_lv_nmos ad=37.8f pd=0.6u as=79.8f ps=0.8u w=0.42u l=0.13u
X247 VSS.t408 DELAY_VBIASN VSS.t410 VSS.t409 sg13_lv_nmos ad=1.33p pd=7.38u as=0 ps=0 w=7u l=7u
X248 a_13231_2470# a_12993_1842# a_13123_1842# VDD.t7 sg13_lv_pmos ad=0.2128p pd=1.5u as=0.3808p ps=2.92u w=1.12u l=0.2u
X249 VDD.t29 VSS.t118 VDD.t28 VDD.t0 sg13_lv_pmos ad=0.34p pd=2.68u as=0 ps=0 w=1u l=1u
X250 a_6326_4590# a_6126_3816# a_5778_3367# VSS.t334 sg13_lv_nmos ad=0.38p pd=2.38u as=0.68p ps=4.68u w=2u l=1u
X251 a_12233_1842# a_12037_1842# VDD.t209 VDD.t7 sg13_lv_pmos ad=0.3808p pd=2.92u as=0.2128p ps=1.5u w=1.12u l=0.13u
X252 a_7911_1842# a_7673_1842# a_7803_1842# VSS.t48 sg13_lv_nmos ad=0.1406p pd=1.12u as=0.2516p ps=2.16u w=0.74u l=0.2u
X253 a_16793_1842# a_16597_1842# VSS.t38 VSS.t37 sg13_lv_nmos ad=0.2516p pd=2.16u as=0.1406p ps=1.12u w=0.74u l=0.13u
X254 VDD.t129 a_3747_311.t3 a_14825_519# VDD.t0 sg13_lv_pmos ad=0.3808p pd=2.92u as=0.3808p ps=2.92u w=1.12u l=0.13u
X255 VDD.t11 a_12849_5867# a_13306_6305# VDD.t10 sg13_lv_pmos ad=0.36237p pd=2.605u as=79.8f ps=0.8u w=0.42u l=0.13u
X256 VDD.t96 VDD.t88 VDD.t95 VDD.t10 sg13_lv_pmos ad=0.68p pd=4.68u as=0 ps=0 w=2u l=1u
X257 VSS.t532 a_27563_1842# a_27997_1842# VSS.t531 sg13_lv_nmos ad=0.1406p pd=1.12u as=0.2516p ps=2.16u w=0.74u l=0.13u
X258 a_9675_1044# a_9465_1044# VSS.t52 VSS.t99 sg13_lv_nmos ad=0.1406p pd=1.12u as=0.1665p ps=1.19u w=0.74u l=0.13u
X259 VDD.t320 a_6326_4590# a_6854_5986# VDD.t10 sg13_lv_pmos ad=0.38p pd=2.38u as=0.38p ps=2.38u w=2u l=1u
X260 a_20593_1842# a_20397_1842# VSS.t213 VSS.t602 sg13_lv_nmos ad=0.2516p pd=2.16u as=0.1406p ps=1.12u w=0.74u l=0.13u
X261 VSS.t236 a_2595_1047.t8 a_8231_1008# VSS.t235 sg13_lv_nmos ad=0.2516p pd=2.16u as=0.2516p ps=2.16u w=0.74u l=0.13u
X262 VSS.t377 a_6283_1842# a_6717_1842# VSS.t622 sg13_lv_nmos ad=0.1406p pd=1.12u as=0.2516p ps=2.16u w=0.74u l=0.13u
X263 a_10430_1044# a_10404_1008# a_10328_1044# VDD.t0 sg13_lv_pmos ad=0.3808p pd=2.92u as=0.2128p ps=1.5u w=1.12u l=0.13u
X264 VDD.t292 DELAY_VBIASP a_26151_2470# VDD.t7 sg13_lv_pmos ad=0.3808p pd=2.92u as=0.2128p ps=1.5u w=1.12u l=0.6u
X265 a_7390_1044# a_8884_1008# a_8808_1044# VDD.t0 sg13_lv_pmos ad=0.3808p pd=2.92u as=0.2128p ps=1.5u w=1.12u l=0.13u
X266 a_11491_6228# a_10649_5878# a_11397_6228# VSS.t250 sg13_lv_nmos ad=0.12665p pd=1.145u as=0.1428p ps=1.52u w=0.42u l=0.13u
X267 VDD.t269 DELAY_VBIASP a_4871_2470# VDD.t7 sg13_lv_pmos ad=0.3808p pd=2.92u as=0.2128p ps=1.5u w=1.12u l=0.6u
X268 a_6126_3816# a_6126_3816# VSS.t336 VSS.t334 sg13_lv_nmos ad=0.38p pd=2.38u as=0.68p ps=4.68u w=2u l=1u
X269 a_3449_331# MUX_SEL2 VDD.t77 VDD.t0 sg13_lv_pmos ad=0.1596p pd=1.22u as=0.2856p ps=2.36u w=0.84u l=0.13u
X270 VDD.t376 VSS.t157 VDD.t374 VDD.t0 sg13_lv_pmos ad=0.19p pd=1.38u as=0 ps=0 w=1u l=1u
X271 a_19073_1842# a_18877_1842# VSS.t442 VSS.t539 sg13_lv_nmos ad=0.2516p pd=2.16u as=0.1406p ps=1.12u w=0.74u l=0.13u
X272 VDD.t310 a_15077_1842# a_15545_1044# VDD.t0 sg13_lv_pmos ad=0.252p pd=1.57u as=0.3808p ps=2.92u w=1.12u l=0.13u
X273 a_19550_1044# a_2019_1047.t4 a_19448_1044# VSS.t322 sg13_lv_nmos ad=0.2516p pd=2.16u as=0.1406p ps=1.12u w=0.74u l=0.13u
X274 VDD.t12 a_12849_5867# a_13306_5105# VDD.t10 sg13_lv_pmos ad=0.36237p pd=2.605u as=79.8f ps=0.8u w=0.42u l=0.13u
X275 VDD.t118 VDD.t116 VDD.t117 VDD.t7 sg13_lv_pmos ad=0.3808p pd=2.92u as=0 ps=0 w=1.12u l=0.6u
X276 VSS.t178 VDD.t398 VSS.t176 VSS.t177 sg13_lv_nmos ad=79.8f pd=0.8u as=0 ps=0 w=0.42u l=1u
X277 a_13592_5871# a_13566_5835# VSS.t7 VSS.t6 sg13_lv_nmos ad=0.2516p pd=2.16u as=0.1626p ps=1.415u w=0.74u l=0.13u
X278 VSS.t291 a_19203_1842# a_19637_1842# VSS.t552 sg13_lv_nmos ad=0.1406p pd=1.12u as=0.2516p ps=2.16u w=0.74u l=0.13u
X279 VDD.t372 VSS.t157 VDD.t226 VDD.t0 sg13_lv_pmos ad=0.19p pd=1.38u as=0 ps=0 w=1u l=1u
X280 a_15108_6109# a_12849_5867# VDD.t14 VDD.t10 sg13_lv_pmos ad=79.8f pd=0.8u as=1.03698p ps=6.245u w=0.42u l=0.13u
X281 VDD.t4 VSS.t135 VDD.t3 VDD.t0 sg13_lv_pmos ad=0.34p pd=2.68u as=0 ps=0 w=1u l=1u
X282 VSS.t11 a_15108_6109# a_14757_6228# VSS.t10 sg13_lv_nmos ad=79.8f pd=0.8u as=0.1428p ps=1.52u w=0.42u l=0.13u
X283 a_27433_1842# a_27237_1842# VDD.t155 VDD.t7 sg13_lv_pmos ad=0.3808p pd=2.92u as=0.2128p ps=1.5u w=1.12u l=0.13u
X284 VDD.t387 a_1256_289# a_2873_331# VDD.t0 sg13_lv_pmos ad=0.1918p pd=1.5u as=0.1596p ps=1.22u w=0.84u l=0.13u
X285 a_13470_1044# a_2595_1047.t6 a_14235_1044# VSS.t306 sg13_lv_nmos ad=0.2516p pd=2.16u as=0.1406p ps=1.12u w=0.74u l=0.13u
X286 VSS.t529 a_9444_4590# a_9444_4590# VSS.t520 sg13_lv_nmos ad=0.68p pd=4.68u as=0.38p ps=2.38u w=2u l=1u
X287 VSS.t54 a_8563_1842# a_8997_1842# VSS.t282 sg13_lv_nmos ad=0.1406p pd=1.12u as=0.2516p ps=2.16u w=0.74u l=0.13u
X288 VSS.t477 VSS.t477 VSS.t479 VSS.t478 sg13_lv_nmos ad=0.2516p pd=2.16u as=0 ps=0 w=0.74u l=0.13u
X289 VSS.t94 DELAY_VBIASN a_13231_1842# VSS.t434 sg13_lv_nmos ad=0.2516p pd=2.16u as=0.1406p ps=1.12u w=0.74u l=0.6u
X290 VDD.t157 a_3171_1047.t7 a_11924_1008# VDD.t0 sg13_lv_pmos ad=0.3808p pd=2.92u as=0.3808p ps=2.92u w=1.12u l=0.13u
X291 VSS.t368 a_2019_1047.t3 a_22564_1008# VSS.t367 sg13_lv_nmos ad=0.2516p pd=2.16u as=0.2516p ps=2.16u w=0.74u l=0.13u
X292 a_15053_5420# a_14111_5227# a_14851_5182# VDD.t10 sg13_lv_pmos ad=93.45f pd=0.865u as=0.2048p ps=1.63u w=0.42u l=0.13u
X293 VSS.t476 VSS.t472 VSS.t472 VSS.t474 sg13_lv_nmos ad=0.1406p pd=1.12u as=0 ps=0 w=0.74u l=0.13u
X294 VSS.t15 a_23003_1842# a_23437_1842# VSS.t14 sg13_lv_nmos ad=0.1406p pd=1.12u as=0.2516p ps=2.16u w=0.74u l=0.13u
X295 VSS.t178 VDD.t397 VSS.t178 VSS.t179 sg13_lv_nmos ad=0.1428p pd=1.52u as=0 ps=0 w=0.42u l=1u
X296 VDD.t277 DELAY_VBIASP a_7151_2470# VDD.t7 sg13_lv_pmos ad=0.3808p pd=2.92u as=0.2128p ps=1.5u w=1.12u l=0.6u
X297 a_5778_3367# VSS.t570 VSS.t569 rppd l=32u w=1u
X298 a_25630_1044# a_25604_1008# a_25528_1044# VDD.t0 sg13_lv_pmos ad=0.3808p pd=2.92u as=0.2128p ps=1.5u w=1.12u l=0.13u
X299 a_10206_5835# a_10649_5878# a_10589_5914# VDD.t10 sg13_lv_pmos ad=79.8f pd=0.8u as=63f ps=0.72u w=0.42u l=0.13u
X300 a_15511_1842# a_15273_1842# a_15403_1842# VSS.t454 sg13_lv_nmos ad=0.1406p pd=1.12u as=0.2516p ps=2.16u w=0.74u l=0.2u
X301 a_10520_6292# a_10751_5878# a_10206_5835# VSS.t611 sg13_lv_nmos ad=0.2373p pd=1.97u as=79.8f ps=0.8u w=0.42u l=0.13u
X302 a_11693_5990# a_10751_5878# a_11491_6228# VDD.t10 sg13_lv_pmos ad=93.45f pd=0.865u as=0.2048p ps=1.63u w=0.42u l=0.13u
X303 a_18313_1842# a_18117_1842# VDD.t171 VDD.t7 sg13_lv_pmos ad=0.3808p pd=2.92u as=0.2128p ps=1.5u w=1.12u l=0.13u
X304 a_5731_289# a_11785_519# a_10430_1044# VDD.t0 sg13_lv_pmos ad=0.3808p pd=2.92u as=0.3808p ps=2.92u w=1.12u l=0.13u
X305 VSS.t121 VDD.t414 VSS.t119 VSS.t120 sg13_lv_nmos ad=79.8f pd=0.8u as=0 ps=0 w=0.42u l=1u
X306 a_9431_2470# a_9193_1842# a_9323_1842# VDD.t7 sg13_lv_pmos ad=0.2128p pd=1.5u as=0.3808p ps=2.92u w=1.12u l=0.2u
X307 a_17275_1044# a_17065_1044# VSS.t40 VSS.t568 sg13_lv_nmos ad=0.1406p pd=1.12u as=0.1665p ps=1.19u w=0.74u l=0.13u
X308 VDD.t69 VSS.t65 VDD.t68 VDD.t0 sg13_lv_pmos ad=0.34p pd=2.68u as=0 ps=0 w=1u l=1u
X309 VSS.t591 a_3747_1047.t6 a_15831_1008# VSS.t590 sg13_lv_nmos ad=0.2516p pd=2.16u as=0.2516p ps=2.16u w=0.74u l=0.13u
X310 a_23871_2470# a_23633_1842# a_23763_1842# VDD.t7 sg13_lv_pmos ad=0.2128p pd=1.5u as=0.3808p ps=2.92u w=1.12u l=0.2u
X311 VSS.t223 a_13883_1842# a_14317_1842# VSS.t370 sg13_lv_nmos ad=0.1406p pd=1.12u as=0.2516p ps=2.16u w=0.74u l=0.13u
X312 VSS.t189 a_3747_311.t2 a_26985_519# VSS.t188 sg13_lv_nmos ad=0.2516p pd=2.16u as=0.2516p ps=2.16u w=0.74u l=0.13u
X313 a_8433_1842# a_8237_1842# VDD.t338 VDD.t7 sg13_lv_pmos ad=0.3808p pd=2.92u as=0.2128p ps=1.5u w=1.12u l=0.13u
X314 VDD.t299 a_18443_1842# a_18877_1842# VDD.t7 sg13_lv_pmos ad=0.2128p pd=1.5u as=0.3808p ps=2.92u w=1.12u l=0.13u
X315 a_22113_1842# a_21917_1842# VDD.t8 VDD.t7 sg13_lv_pmos ad=0.3808p pd=2.92u as=0.2128p ps=1.5u w=1.12u l=0.13u
X316 a_4350_1044# a_2019_1047.t9 a_4248_1044# VSS.t319 sg13_lv_nmos ad=0.2516p pd=2.16u as=0.1406p ps=1.12u w=0.74u l=0.13u
X317 a_14888_1044# a_14317_1842# VSS.t221 VSS.t220 sg13_lv_nmos ad=0.1406p pd=1.12u as=0.2516p ps=2.16u w=0.74u l=0.13u
X318 a_13880_5118# a_13592_5423# a_13818_5118# VSS.t543 sg13_lv_nmos ad=0.1428p pd=1.52u as=37.8f ps=0.6u w=0.42u l=0.13u
X319 a_16108_289# a_3747_311.t2 a_25630_1044# VSS.t187 sg13_lv_nmos ad=0.2516p pd=2.16u as=0.2516p ps=2.16u w=0.74u l=0.13u
X320 VDD.t284 DELAY_VBIASP a_12471_2470# VDD.t7 sg13_lv_pmos ad=0.3808p pd=2.92u as=0.2128p ps=1.5u w=1.12u l=0.6u
X321 VSS.t254 a_4003_1842# a_4437_1842# VSS.t253 sg13_lv_nmos ad=0.1406p pd=1.12u as=0.2516p ps=2.16u w=0.74u l=0.13u
X322 a_16510_1044# a_16484_1008# a_16408_1044# VDD.t0 sg13_lv_pmos ad=0.3808p pd=2.92u as=0.2128p ps=1.5u w=1.12u l=0.13u
X323 VSS.t252 a_13121_5831# a_13045_6215# VSS.t498 sg13_lv_nmos ad=0.2516p pd=2.16u as=0.1406p ps=1.12u w=0.74u l=0.13u
X324 VDD.t39 a_14851_5182# a_15688_5403# VDD.t10 sg13_lv_pmos ad=0.2128p pd=1.5u as=0.3864p ps=2.93u w=1.12u l=0.13u
X325 VDD.t23 a_22243_1842# a_22677_1842# VDD.t7 sg13_lv_pmos ad=0.2128p pd=1.5u as=0.3808p ps=2.92u w=1.12u l=0.13u
X326 VDD.t188 a_3171_1047.t2 a_27124_1008# VDD.t0 sg13_lv_pmos ad=0.3808p pd=2.92u as=0.3808p ps=2.92u w=1.12u l=0.13u
X327 VDD.t61 MUX_SEL3 a_3449_331# VDD.t0 sg13_lv_pmos ad=0.1918p pd=1.5u as=0.1596p ps=1.22u w=0.84u l=0.13u
X328 a_2595_311.t0 a_2297_331# VDD.t163 VDD.t0 sg13_lv_pmos ad=0.2128p pd=1.5u as=0.1918p ps=1.5u w=1.12u l=0.13u
X329 a_10430_1044# a_11271_1008# a_11195_1044# VDD.t0 sg13_lv_pmos ad=0.3808p pd=2.92u as=0.2128p ps=1.5u w=1.12u l=0.13u
X330 a_14009_5084# DELAY_OUT_LAST VSS.t57 VSS.t581 sg13_lv_nmos ad=0.2516p pd=2.16u as=1.45407p ps=9.445u w=0.74u l=0.13u
X331 a_23355_1044# a_23145_1044# VDD.t22 VDD.t0 sg13_lv_pmos ad=0.2128p pd=1.5u as=0.252p ps=1.57u w=1.12u l=0.13u
X332 VDD.t25 a_3747_1047.t4 a_21911_1008# VDD.t0 sg13_lv_pmos ad=0.3808p pd=2.92u as=0.3808p ps=2.92u w=1.12u l=0.13u
X333 VSS.t52 a_8997_1842# a_9465_1044# VSS.t51 sg13_lv_nmos ad=0.1665p pd=1.19u as=0.2516p ps=2.16u w=0.74u l=0.13u
X334 a_13592_5423# a_13566_5328# VDD.t12 VDD.t10 sg13_lv_pmos ad=0.34p pd=2.68u as=0.36237p ps=2.605u w=1u l=0.13u
X335 a_6126_3816# a_5974_5723# a_6326_4590# VSS.t41 sg13_lv_nmos ad=0.68p pd=4.68u as=0.38p ps=2.38u w=2u l=1u
X336 a_20968_1044# a_20397_1842# VDD.t370 VDD.t0 sg13_lv_pmos ad=0.2128p pd=1.5u as=0.3808p ps=2.92u w=1.12u l=0.13u
X337 a_10951_1842# a_10713_1842# a_10843_1842# VSS.t601 sg13_lv_nmos ad=0.1406p pd=1.12u as=0.2516p ps=2.16u w=0.74u l=0.2u
X338 VSS.t619 a_2019_1047.t5 a_16484_1008# VSS.t618 sg13_lv_nmos ad=0.2516p pd=2.16u as=0.2516p ps=2.16u w=0.74u l=0.13u
X339 a_26151_2470# a_25913_1842# a_26043_1842# VDD.t7 sg13_lv_pmos ad=0.2128p pd=1.5u as=0.3808p ps=2.92u w=1.12u l=0.2u
X340 a_9444_4590# a_6854_5454# a_6854_5454# VSS.t228 sg13_lv_nmos ad=0.68p pd=4.68u as=0.38p ps=2.38u w=2u l=1u
X341 a_13753_1842# a_13557_1842# VDD.t72 VDD.t7 sg13_lv_pmos ad=0.3808p pd=2.92u as=0.2128p ps=1.5u w=1.12u l=0.13u
X342 VDD.t208 a_1721_331# a_2019_311# VDD.t0 sg13_lv_pmos ad=0.4256p pd=3u as=0.2128p ps=1.5u w=1.12u l=0.13u
X343 a_4871_2470# a_4633_1842# a_4763_1842# VDD.t7 sg13_lv_pmos ad=0.2128p pd=1.5u as=0.3808p ps=2.92u w=1.12u l=0.2u
X344 VSS.t310 a_3171_1047.t9 a_5844_1008# VSS.t309 sg13_lv_nmos ad=0.2516p pd=2.16u as=0.2516p ps=2.16u w=0.74u l=0.13u
X345 VSS.t146 VDD.t406 VSS.t146 VSS.t148 sg13_lv_nmos ad=79.8f pd=0.8u as=0 ps=0 w=0.42u l=1u
X346 VDD.t49 a_2595_311.t2 a_20905_519# VDD.t0 sg13_lv_pmos ad=0.3808p pd=2.92u as=0.3808p ps=2.92u w=1.12u l=0.13u
X347 VDD.t164 a_2297_331# a_2595_311.t0 VDD.t0 sg13_lv_pmos ad=0.4256p pd=3u as=0.2128p ps=1.5u w=1.12u l=0.13u
X348 a_14009_5084# DELAY_OUT_LAST VDD.t14 VDD.t10 sg13_lv_pmos ad=0.4088p pd=2.97u as=1.10612p ps=6.66u w=1.12u l=0.13u
X349 VSS.t272 a_2595_1047.t7 a_11271_1008# VSS.t318 sg13_lv_nmos ad=0.2516p pd=2.16u as=0.2516p ps=2.16u w=0.74u l=0.13u
X350 VSS.t291 DELAY_VBIASN a_19311_1842# VSS.t443 sg13_lv_nmos ad=0.2516p pd=2.16u as=0.1406p ps=1.12u w=0.74u l=0.6u
X351 VSS.t521 a_9444_4590# a_9444_3912# VSS.t520 sg13_lv_nmos ad=0.68p pd=4.68u as=0.38p ps=2.38u w=2u l=1u
X352 a_13880_5118# a_14111_5227# a_13566_5328# VSS.t573 sg13_lv_nmos ad=0.2373p pd=1.97u as=79.8f ps=0.8u w=0.42u l=0.13u
X353 VDD.t185 a_24523_1842# a_24957_1842# VDD.t7 sg13_lv_pmos ad=0.2128p pd=1.5u as=0.3808p ps=2.92u w=1.12u l=0.13u
X354 VSS.t92 a_3747_1047.t8 a_9751_1008# VSS.t91 sg13_lv_nmos ad=0.2516p pd=2.16u as=0.2516p ps=2.16u w=0.74u l=0.13u
X355 VSS.t208 DELAY_VBIASN a_9431_1842# VSS.t431 sg13_lv_nmos ad=0.2516p pd=2.16u as=0.1406p ps=1.12u w=0.74u l=0.6u
X356 a_19448_1044# a_18877_1842# VDD.t300 VDD.t0 sg13_lv_pmos ad=0.2128p pd=1.5u as=0.3808p ps=2.92u w=1.12u l=0.13u
X357 VSS.t252 a_11491_6228# a_12158_5867# VSS.t251 sg13_lv_nmos ad=0.1406p pd=1.12u as=0.2516p ps=2.16u w=0.74u l=0.13u
X358 a_13566_5328# a_14009_5084# a_13949_5496# VDD.t10 sg13_lv_pmos ad=79.8f pd=0.8u as=63f ps=0.72u w=0.42u l=0.13u
X359 VSS.t15 DELAY_VBIASN a_23111_1842# VSS.t445 sg13_lv_nmos ad=0.2516p pd=2.16u as=0.1406p ps=1.12u w=0.74u l=0.6u
X360 a_10430_1044# a_11924_1008# a_11848_1044# VDD.t0 sg13_lv_pmos ad=0.3808p pd=2.92u as=0.2128p ps=1.5u w=1.12u l=0.13u
X361 VDD.t294 DELAY_VBIASP a_27671_2470# VDD.t7 sg13_lv_pmos ad=0.3808p pd=2.92u as=0.2128p ps=1.5u w=1.12u l=0.6u
X362 a_6854_5986# a_6326_4590# VDD.t89 VDD.t10 sg13_lv_pmos ad=0.38p pd=2.38u as=0.38p ps=2.38u w=2u l=1u
X363 VSS.t416 DELAY_VBIASN DELAY_VBIASP VSS.t415 sg13_lv_nmos ad=0.2516p pd=2.16u as=0.6808p ps=3.32u w=0.74u l=0.6u
X364 a_25630_1044# a_26471_1008# a_26395_1044# VDD.t0 sg13_lv_pmos ad=0.3808p pd=2.92u as=0.2128p ps=1.5u w=1.12u l=0.13u
X365 VSS.t398 DELAY_VBIASN VSS.t400 VSS.t399 sg13_lv_nmos ad=1.33p pd=7.38u as=0 ps=0 w=7u l=7u
X366 a_10040_6305# a_9772_5843# a_9946_6305# VSS.t578 sg13_lv_nmos ad=60.89999f pd=0.71u as=0.1428p ps=1.52u w=0.42u l=0.13u
X367 a_7151_2470# a_6913_1842# a_7043_1842# VDD.t7 sg13_lv_pmos ad=0.2128p pd=1.5u as=0.3808p ps=2.92u w=1.12u l=0.2u
X368 a_16033_1842# a_15837_1842# VDD.t67 VDD.t7 sg13_lv_pmos ad=0.3808p pd=2.92u as=0.2128p ps=1.5u w=1.12u l=0.13u
X369 VDD.t322 a_6326_4590# a_6326_4590# VDD.t10 sg13_lv_pmos ad=0.38p pd=2.38u as=0.38p ps=2.38u w=2u l=1u
X370 VDD.t81 a_15964_289# a_16851_309# VDD.t0 sg13_lv_pmos ad=0.2086p pd=1.5u as=0.34p ps=2.68u w=1u l=0.13u
X371 VDD.t374 VSS.t157 VDD.t373 VDD.t0 sg13_lv_pmos ad=0.34p pd=2.68u as=0 ps=0 w=1u l=1u
X372 a_15464_3684# a_14851_5182# VSS.t13 VSS.t218 sg13_lv_nmos ad=0.2849p pd=2.25u as=0.2516p ps=2.16u w=0.74u l=0.13u
X373 VSS.t350 a_11603_1842# a_12037_1842# VSS.t349 sg13_lv_nmos ad=0.1406p pd=1.12u as=0.2516p ps=2.16u w=0.74u l=0.13u
X374 VSS.t163 VDD.t402 VSS.t161 VSS.t162 sg13_lv_nmos ad=79.8f pd=0.8u as=0 ps=0 w=0.42u l=1u
X375 VDD.t1 VSS.t133 VDD.t215 VDD.t0 sg13_lv_pmos ad=0.34p pd=2.68u as=0 ps=0 w=1u l=1u
X376 VDD.t161 a_5957_1842# a_6425_1044# VDD.t0 sg13_lv_pmos ad=0.252p pd=1.57u as=0.3808p ps=2.92u w=1.12u l=0.13u
X377 a_24393_1842# a_24197_1842# VSS.t281 VSS.t536 sg13_lv_nmos ad=0.2516p pd=2.16u as=0.1406p ps=1.12u w=0.74u l=0.13u
X378 a_3747_1047.t1 a_3449_1395# VSS.t96 VSS.t95 sg13_lv_nmos ad=0.1406p pd=1.12u as=0.1331p ps=1.12u w=0.74u l=0.13u
X379 a_1544_1044# MUX_SEL1 VSS.t17 VSS.t547 sg13_lv_nmos ad=0.2516p pd=2.16u as=0.2516p ps=2.16u w=0.74u l=0.13u
X380 VDD.t226 VSS.t155 VDD.t225 VDD.t0 sg13_lv_pmos ad=0.34p pd=2.68u as=0 ps=0 w=1u l=1u
X381 a_3171_1047.t0 a_2873_1395# VDD.t134 VDD.t0 sg13_lv_pmos ad=0.2128p pd=1.5u as=0.1918p ps=1.5u w=1.12u l=0.13u
X382 a_13470_1044# a_3747_1047.t6 a_15755_1044# VSS.t589 sg13_lv_nmos ad=0.2516p pd=2.16u as=0.1406p ps=1.12u w=0.74u l=0.13u
X383 VDD.t260 a_15464_3684# a_9712_3912# VSS.t530 sg13_lv_nmos ad=0.232p pd=2.08u as=0.136p ps=1.14u w=0.4u l=0.2u
X384 VDD.t162 a_5523_1842# a_5957_1842# VDD.t7 sg13_lv_pmos ad=0.2128p pd=1.5u as=0.3808p ps=2.92u w=1.12u l=0.13u
X385 VDD.t19 a_2297_1395# a_2595_1047.t0 VDD.t0 sg13_lv_pmos ad=0.4256p pd=3u as=0.2128p ps=1.5u w=1.12u l=0.13u
X386 VSS.t356 DELAY_VBIASN a_14751_1842# VSS.t390 sg13_lv_nmos ad=0.2516p pd=2.16u as=0.1406p ps=1.12u w=0.74u l=0.6u
X387 a_2967_1395# MUX_SEL1 a_2873_1395# VSS.t548 sg13_lv_nmos ad=0.1216p pd=1.02u as=0.2176p ps=1.96u w=0.64u l=0.13u
X388 a_4350_1044# a_2595_1047.t9 a_5115_1044# VSS.t516 sg13_lv_nmos ad=0.2516p pd=2.16u as=0.1406p ps=1.12u w=0.74u l=0.13u
X389 VDD.t223 a_2019_1047.t6 a_13444_1008# VDD.t0 sg13_lv_pmos ad=0.3808p pd=2.92u as=0.3808p ps=2.92u w=1.12u l=0.13u
X390 VSS.t20 a_2595_1047.t2 a_26471_1008# VSS.t354 sg13_lv_nmos ad=0.2516p pd=2.16u as=0.2516p ps=2.16u w=0.74u l=0.13u
X391 a_2595_311.t1 a_2297_331# VSS.t262 VSS.t261 sg13_lv_nmos ad=0.1406p pd=1.12u as=0.1331p ps=1.12u w=0.74u l=0.13u
X392 VSS.t452 a_14009_5878# a_14111_5878# VSS.t451 sg13_lv_nmos ad=2.39977p pd=15.495u as=0.2516p ps=2.16u w=0.74u l=0.13u
X393 VSS.t254 DELAY_VBIASN a_4111_1842# VSS.t428 sg13_lv_nmos ad=0.2516p pd=2.16u as=0.1406p ps=1.12u w=0.74u l=0.6u
X394 a_2297_1395# MUX_SEL0 VDD.t304 VDD.t0 sg13_lv_pmos ad=0.1596p pd=1.22u as=0.2856p ps=2.36u w=0.84u l=0.13u
X395 VSS.t40 a_16597_1842# a_17065_1044# VSS.t39 sg13_lv_nmos ad=0.1665p pd=1.19u as=0.2516p ps=2.16u w=0.74u l=0.13u
X396 VDD.t280 DELAY_VBIASP a_8671_2470# VDD.t7 sg13_lv_pmos ad=0.3808p pd=2.92u as=0.2128p ps=1.5u w=1.12u l=0.6u
X397 VDD.t151 VSS.t131 VDD.t86 VDD.t0 sg13_lv_pmos ad=0.19p pd=1.38u as=0 ps=0 w=1u l=1u
X398 VDD.t40 a_1544_1044# a_1721_1395# VDD.t0 sg13_lv_pmos ad=0.1918p pd=1.5u as=0.1596p ps=1.22u w=0.84u l=0.13u
X399 a_9444_4590# a_9444_4590# VSS.t528 VSS.t518 sg13_lv_nmos ad=0.38p pd=2.38u as=0.68p ps=4.68u w=2u l=1u
X400 a_4248_1044# a_4157_1313# VDD.t334 VDD.t0 sg13_lv_pmos ad=0.2128p pd=1.5u as=0.3808p ps=2.92u w=1.12u l=0.13u
X401 a_5778_3367# a_6126_3816# a_6326_4590# VSS.t334 sg13_lv_nmos ad=0.68p pd=4.68u as=0.38p ps=2.38u w=2u l=1u
X402 a_12471_2470# a_12233_1842# a_12363_1842# VDD.t7 sg13_lv_pmos ad=0.2128p pd=1.5u as=0.3808p ps=2.92u w=1.12u l=0.2u
X403 a_17031_1842# a_16793_1842# a_16923_1842# VSS.t533 sg13_lv_nmos ad=0.1406p pd=1.12u as=0.2516p ps=2.16u w=0.74u l=0.2u
X404 VSS.t262 a_1721_331# a_2019_311# VSS.t348 sg13_lv_nmos ad=0.2812p pd=2.24u as=0.1406p ps=1.12u w=0.74u l=0.13u
X405 a_19550_1044# a_21911_1008# a_21835_1044# VDD.t0 sg13_lv_pmos ad=0.3808p pd=2.92u as=0.2128p ps=1.5u w=1.12u l=0.13u
X406 a_16108_289# a_26985_519# a_25630_1044# VDD.t0 sg13_lv_pmos ad=0.3808p pd=2.92u as=0.3808p ps=2.92u w=1.12u l=0.13u
X407 VSS.t262 a_2297_331# a_2595_311.t1 VSS.t263 sg13_lv_nmos ad=0.2812p pd=2.24u as=0.1406p ps=1.12u w=0.74u l=0.13u
X408 a_18795_1044# a_18585_1044# VSS.t269 VSS.t268 sg13_lv_nmos ad=0.1406p pd=1.12u as=0.1665p ps=1.19u w=0.74u l=0.13u
X409 a_9444_3912# a_6854_5454# a_9712_3912# VSS.t228 sg13_lv_nmos ad=0.68p pd=4.68u as=0.38p ps=2.38u w=2u l=1u
X410 a_20831_1842# a_20593_1842# a_20723_1842# VSS.t115 sg13_lv_nmos ad=0.1406p pd=1.12u as=0.2516p ps=2.16u w=0.74u l=0.2u
X411 VSS.t119 VDD.t414 VSS.t118 VSS.t117 sg13_lv_nmos ad=0.1428p pd=1.52u as=0 ps=0 w=0.42u l=1u
X412 VDD.t22 a_22677_1842# a_23145_1044# VDD.t0 sg13_lv_pmos ad=0.252p pd=1.57u as=0.3808p ps=2.92u w=1.12u l=0.13u
X413 VSS.t233 a_2595_1047.t5 a_17351_1008# VSS.t232 sg13_lv_nmos ad=0.2516p pd=2.16u as=0.2516p ps=2.16u w=0.74u l=0.13u
X414 a_5393_1842# a_5197_1842# VSS.t36 VSS.t35 sg13_lv_nmos ad=0.2516p pd=2.16u as=0.1406p ps=1.12u w=0.74u l=0.13u
X415 VSS.t50 DELAY_VBIASN a_17031_1842# VSS.t439 sg13_lv_nmos ad=0.2516p pd=2.16u as=0.1406p ps=1.12u w=0.74u l=0.6u
X416 a_25630_1044# a_3171_1047.t2 a_27048_1044# VSS.t301 sg13_lv_nmos ad=0.2516p pd=2.16u as=0.1406p ps=1.12u w=0.74u l=0.13u
X417 VDD.t103 VDD.t100 VDD.t102 VDD.t101 sg13_lv_pmos ad=0.3808p pd=2.92u as=0 ps=0 w=1.12u l=0.13u
X418 a_9953_1842# a_9757_1842# VDD.t136 VDD.t7 sg13_lv_pmos ad=0.3808p pd=2.92u as=0.2128p ps=1.5u w=1.12u l=0.13u
X419 VDD.t9 a_10843_1842# a_11277_1842# VDD.t7 sg13_lv_pmos ad=0.2128p pd=1.5u as=0.3808p ps=2.92u w=1.12u l=0.13u
X420 VSS.t243 a_26803_1842# a_27237_1842# VSS.t242 sg13_lv_nmos ad=0.1406p pd=1.12u as=0.2516p ps=2.16u w=0.74u l=0.13u
X421 a_4350_1044# a_3171_1047.t9 a_5768_1044# VSS.t308 sg13_lv_nmos ad=0.2516p pd=2.16u as=0.1406p ps=1.12u w=0.74u l=0.13u
X422 VDD.t15 a_12849_5867# a_13566_5328# VDD.t10 sg13_lv_pmos ad=0.1563p pd=1.22u as=0.147p ps=1.54u w=0.42u l=0.13u
X423 VDD.t108 VDD.t109 VDD.t110 VDD.t101 sg13_lv_pmos ad=0.2128p pd=1.5u as=0 ps=0 w=1.12u l=0.13u
X424 a_10430_1044# a_12791_1008# a_12715_1044# VDD.t0 sg13_lv_pmos ad=0.3808p pd=2.92u as=0.2128p ps=1.5u w=1.12u l=0.13u
X425 a_19311_1842# a_19073_1842# a_19203_1842# VSS.t32 sg13_lv_nmos ad=0.1406p pd=1.12u as=0.2516p ps=2.16u w=0.74u l=0.2u
X426 a_24875_1044# a_24665_1044# VDD.t298 VDD.t0 sg13_lv_pmos ad=0.2128p pd=1.5u as=0.252p ps=1.57u w=1.12u l=0.13u
X427 VDD.t147 a_2595_1047.t3 a_23431_1008# VDD.t0 sg13_lv_pmos ad=0.3808p pd=2.92u as=0.3808p ps=2.92u w=1.12u l=0.13u
X428 VDD.t14 a_14009_5878# a_14111_5878# VDD.t10 sg13_lv_pmos ad=1.10612p pd=6.66u as=0.3864p ps=2.93u w=1.12u l=0.13u
X429 a_13949_5914# a_13592_5871# VDD.t13 VDD.t10 sg13_lv_pmos ad=63f pd=0.72u as=0.1563p ps=1.22u w=0.42u l=0.13u
X430 VDD.t153 a_13557_1842# a_14025_1044# VDD.t0 sg13_lv_pmos ad=0.252p pd=1.57u as=0.3808p ps=2.92u w=1.12u l=0.13u
X431 a_23111_1842# a_22873_1842# a_23003_1842# VSS.t453 sg13_lv_nmos ad=0.1406p pd=1.12u as=0.2516p ps=2.16u w=0.74u l=0.2u
X432 VSS.t278 a_10649_5878# a_10751_5878# VSS.t277 sg13_lv_nmos ad=2.39977p pd=15.495u as=0.2516p ps=2.16u w=0.74u l=0.13u
X433 a_27671_2470# a_27433_1842# a_27563_1842# VDD.t7 sg13_lv_pmos ad=0.2128p pd=1.5u as=0.3808p ps=2.92u w=1.12u l=0.2u
X434 VSS.t275 a_17683_1842# a_18117_1842# VSS.t274 sg13_lv_nmos ad=0.1406p pd=1.12u as=0.2516p ps=2.16u w=0.74u l=0.13u
X435 VSS.t157 VDD.t403 VSS.t157 VSS.t159 sg13_lv_nmos ad=79.8f pd=0.8u as=0 ps=0 w=0.42u l=1u
X436 a_10713_1842# a_10517_1842# VSS.t332 VSS.t535 sg13_lv_nmos ad=0.2516p pd=2.16u as=0.1406p ps=1.12u w=0.74u l=0.13u
X437 VSS.t185 a_2019_1047.t8 a_7364_1008# VSS.t184 sg13_lv_nmos ad=0.2516p pd=2.16u as=0.2516p ps=2.16u w=0.74u l=0.13u
X438 VSS.t425 DELAY_VBIASN VSS.t414 VSS.t407 sg13_lv_nmos ad=1.33p pd=7.38u as=0 ps=0 w=7u l=7u
X439 VSS.t383 a_7803_1842# a_8237_1842# VSS.t563 sg13_lv_nmos ad=0.1406p pd=1.12u as=0.2516p ps=2.16u w=0.74u l=0.13u
X440 a_13592_5871# a_14111_5878# a_14851_6228# VSS.t10 sg13_lv_nmos ad=0.3473p pd=2.71u as=0.12665p ps=1.145u w=0.74u l=0.13u
X441 a_15304_4605# a_14851_6228# VSS.t510 VSS.t509 sg13_lv_nmos ad=0.2849p pd=2.25u as=0.2516p ps=2.16u w=0.74u l=0.13u
X442 VDD.t265 DELAY_VBIASP a_16271_2470# VDD.t7 sg13_lv_pmos ad=0.3808p pd=2.92u as=0.2128p ps=1.5u w=1.12u l=0.6u
X443 VSS.t157 VDD.t404 VSS.t155 VSS.t156 sg13_lv_nmos ad=79.8f pd=0.8u as=0 ps=0 w=0.42u l=1u
X444 VSS.t135 VDD.t409 VSS.t135 VSS.t136 sg13_lv_nmos ad=0.1428p pd=1.52u as=0 ps=0 w=0.42u l=1u
X445 a_6854_5454# a_6854_5454# a_9444_4590# VSS.t227 sg13_lv_nmos ad=0.38p pd=2.38u as=0.68p ps=4.68u w=2u l=1u
X446 VDD.t21 a_26043_1842# a_26477_1842# VDD.t7 sg13_lv_pmos ad=0.2128p pd=1.5u as=0.3808p ps=2.92u w=1.12u l=0.13u
X447 VDD.t201 DLL_RESETN a_10206_5835# VDD.t10 sg13_lv_pmos ad=0.1563p pd=1.22u as=0.147p ps=1.54u w=0.42u l=0.13u
X448 a_3543_331# MUX_SEL2 a_3449_331# VSS.t104 sg13_lv_nmos ad=0.1216p pd=1.02u as=0.2176p ps=1.96u w=0.64u l=0.13u
X449 a_22488_1044# a_21917_1842# VSS.t31 VSS.t560 sg13_lv_nmos ad=0.1406p pd=1.12u as=0.2516p ps=2.16u w=0.74u l=0.13u
X450 a_14851_5182# a_14009_5084# a_13592_5423# VDD.t10 sg13_lv_pmos ad=0.2048p pd=1.63u as=0.34p ps=2.68u w=1u l=0.13u
X451 VDD.t382 VSS.t125 VDD.t380 VDD.t0 sg13_lv_pmos ad=0.19p pd=1.38u as=0 ps=0 w=1u l=1u
X452 a_22590_1044# a_24084_1008# a_24008_1044# VDD.t0 sg13_lv_pmos ad=0.3808p pd=2.92u as=0.2128p ps=1.5u w=1.12u l=0.13u
X453 VDD.t264 DELAY_VBIASP a_20071_2470# VDD.t7 sg13_lv_pmos ad=0.3808p pd=2.92u as=0.2128p ps=1.5u w=1.12u l=0.6u
X454 a_9444_3912# a_9444_4590# VSS.t519 VSS.t518 sg13_lv_nmos ad=0.38p pd=2.38u as=0.68p ps=4.68u w=2u l=1u
X455 a_14751_1842# a_14513_1842# a_14643_1842# VSS.t365 sg13_lv_nmos ad=0.1406p pd=1.12u as=0.2516p ps=2.16u w=0.74u l=0.2u
X456 VSS.t205 a_2873_1395# a_3171_1047.t1 VSS.t206 sg13_lv_nmos ad=0.2812p pd=2.24u as=0.1406p ps=1.12u w=0.74u l=0.13u
X457 VDD.t33 VSS.t174 VDD.t32 VDD.t0 sg13_lv_pmos ad=0.19p pd=1.38u as=0 ps=0 w=1u l=1u
X458 a_25630_1044# a_27991_1008# a_27915_1044# VDD.t0 sg13_lv_pmos ad=0.3808p pd=2.92u as=0.2128p ps=1.5u w=1.12u l=0.13u
X459 VSS.t488 VSS.t485 VSS.t485 VSS.t486 sg13_lv_nmos ad=0.1406p pd=1.12u as=0 ps=0 w=0.74u l=0.13u
X460 a_4111_1842# REF_CLK a_4003_1842# VSS.t506 sg13_lv_nmos ad=0.1406p pd=1.12u as=0.2516p ps=2.16u w=0.74u l=0.2u
X461 a_8671_2470# a_8433_1842# a_8563_1842# VDD.t7 sg13_lv_pmos ad=0.2128p pd=1.5u as=0.3808p ps=2.92u w=1.12u l=0.2u
X462 a_17553_1842# a_17357_1842# VDD.t44 VDD.t7 sg13_lv_pmos ad=0.3808p pd=2.92u as=0.2128p ps=1.5u w=1.12u l=0.13u
X463 VSS.t17 a_1544_1044# a_2391_1395# VSS.t265 sg13_lv_nmos ad=0.1331p pd=1.12u as=0.1216p ps=1.02u w=0.64u l=0.13u
X464 VSS.t146 a_3747_311.t3 a_14825_519# VSS.t196 sg13_lv_nmos ad=0.2516p pd=2.16u as=0.2516p ps=2.16u w=0.74u l=0.13u
X465 VSS.t262 a_1256_289# a_2967_331# VSS.t616 sg13_lv_nmos ad=0.1331p pd=1.12u as=0.1216p ps=1.02u w=0.64u l=0.13u
X466 a_2019_1047.t1 a_1721_1395# VSS.t17 VSS.t43 sg13_lv_nmos ad=0.1406p pd=1.12u as=0.1331p ps=1.12u w=0.74u l=0.13u
X467 a_15964_289# a_15765_463# a_5731_289# VSS.t224 sg13_lv_nmos ad=0.2183p pd=1.33u as=0.2516p ps=2.16u w=0.74u l=0.13u
X468 a_13470_1044# a_2019_1047.t6 a_13368_1044# VSS.t362 sg13_lv_nmos ad=0.2516p pd=2.16u as=0.1406p ps=1.12u w=0.74u l=0.13u
X469 VDD.t90 VDD.t88 VDD.t89 VDD.t10 sg13_lv_pmos ad=0.68p pd=4.68u as=0 ps=0 w=2u l=1u
X470 VSS.t94 a_13123_1842# a_13557_1842# VSS.t93 sg13_lv_nmos ad=0.1406p pd=1.12u as=0.2516p ps=2.16u w=0.74u l=0.13u
X471 VDD.t176 VSS.t176 VDD.t175 VDD.t0 sg13_lv_pmos ad=0.34p pd=2.68u as=0 ps=0 w=1u l=1u
X472 VSS.t70 a_3171_1047.t3 a_24084_1008# VSS.t69 sg13_lv_nmos ad=0.2516p pd=2.16u as=0.2516p ps=2.16u w=0.74u l=0.13u
X473 a_25913_1842# a_25717_1842# VSS.t203 VSS.t202 sg13_lv_nmos ad=0.2516p pd=2.16u as=0.1406p ps=1.12u w=0.74u l=0.13u
X474 VDD.t14 a_10649_5878# a_10751_5878# VDD.t10 sg13_lv_pmos ad=1.10612p pd=6.66u as=0.3864p ps=2.93u w=1.12u l=0.13u
X475 a_21353_1842# a_21157_1842# VDD.t80 VDD.t7 sg13_lv_pmos ad=0.3808p pd=2.92u as=0.2128p ps=1.5u w=1.12u l=0.13u
X476 VSS.t161 VDD.t402 VSS.t65 VSS.t160 sg13_lv_nmos ad=0.1428p pd=1.52u as=0 ps=0 w=0.42u l=1u
X477 a_2297_331# MUX_SEL2 VDD.t78 VDD.t0 sg13_lv_pmos ad=0.1596p pd=1.22u as=0.2856p ps=2.36u w=0.84u l=0.13u
X478 VDD.t241 a_7043_1842# a_7477_1842# VDD.t7 sg13_lv_pmos ad=0.2128p pd=1.5u as=0.3808p ps=2.92u w=1.12u l=0.13u
X479 a_2873_331# MUX_SEL3 VDD.t84 VDD.t0 sg13_lv_pmos ad=0.1596p pd=1.22u as=0.2856p ps=2.36u w=0.84u l=0.13u
X480 a_10589_5914# a_10232_5871# VDD.t201 VDD.t10 sg13_lv_pmos ad=63f pd=0.72u as=0.1563p ps=1.22u w=0.42u l=0.13u
X481 a_8155_1044# a_7945_1044# VDD.t122 VDD.t0 sg13_lv_pmos ad=0.2128p pd=1.5u as=0.252p ps=1.57u w=1.12u l=0.13u
X482 a_13880_6292# a_13592_5871# a_13818_6292# VSS.t211 sg13_lv_nmos ad=0.1428p pd=1.52u as=37.8f ps=0.6u w=0.42u l=0.13u
X483 VSS.t269 a_18117_1842# a_18585_1044# VSS.t326 sg13_lv_nmos ad=0.1665p pd=1.19u as=0.2516p ps=2.16u w=0.74u l=0.13u
X484 a_27048_1044# a_26477_1842# VDD.t20 VDD.t0 sg13_lv_pmos ad=0.2128p pd=1.5u as=0.3808p ps=2.92u w=1.12u l=0.13u
X485 a_5768_1044# a_5197_1842# VDD.t34 VDD.t0 sg13_lv_pmos ad=0.2128p pd=1.5u as=0.3808p ps=2.92u w=1.12u l=0.13u
X486 a_10232_5871# a_10751_5878# a_11491_6228# VSS.t250 sg13_lv_nmos ad=0.3473p pd=2.71u as=0.12665p ps=1.145u w=0.74u l=0.13u
X487 a_12656_5864# DLL_RESETN VDD.t220 VDD.t10 sg13_lv_pmos ad=0.3808p pd=2.92u as=0.3808p ps=2.92u w=1.12u l=0.13u
X488 a_13991_2470# a_13753_1842# a_13883_1842# VDD.t7 sg13_lv_pmos ad=0.2128p pd=1.5u as=0.3808p ps=2.92u w=1.12u l=0.2u
X489 VSS.t515 a_3171_1047.t6 a_14964_1008# VSS.t514 sg13_lv_nmos ad=0.2516p pd=2.16u as=0.2516p ps=2.16u w=0.74u l=0.13u
X490 VDD.t385 a_2019_311# a_17865_519# VDD.t0 sg13_lv_pmos ad=0.3808p pd=2.92u as=0.3808p ps=2.92u w=1.12u l=0.13u
X491 DELAY_OUT_LAST a_27997_1842# VSS.t532 VSS.t556 sg13_lv_nmos ad=0.2516p pd=2.16u as=0.1406p ps=1.12u w=0.74u l=0.13u
X492 a_11195_1044# a_10985_1044# VSS.t85 VSS.t84 sg13_lv_nmos ad=0.1406p pd=1.12u as=0.1665p ps=1.19u w=0.74u l=0.13u
X493 VDD.t298 a_24197_1842# a_24665_1044# VDD.t0 sg13_lv_pmos ad=0.252p pd=1.57u as=0.3808p ps=2.92u w=1.12u l=0.13u
X494 a_6913_1842# a_6717_1842# VSS.t377 VSS.t376 sg13_lv_nmos ad=0.2516p pd=2.16u as=0.1406p ps=1.12u w=0.74u l=0.13u
X495 VSS.t442 DELAY_VBIASN a_18551_1842# VSS.t441 sg13_lv_nmos ad=0.2516p pd=2.16u as=0.1406p ps=1.12u w=0.74u l=0.6u
X496 a_16510_1044# a_18004_1008# a_17928_1044# VDD.t0 sg13_lv_pmos ad=0.3808p pd=2.92u as=0.2128p ps=1.5u w=1.12u l=0.13u
X497 a_13592_5423# a_13566_5328# VSS.t5 VSS.t330 sg13_lv_nmos ad=0.2516p pd=2.16u as=0.1626p ps=1.415u w=0.74u l=0.13u
X498 VDD.t53 a_12363_1842# a_12797_1842# VDD.t7 sg13_lv_pmos ad=0.2128p pd=1.5u as=0.3808p ps=2.92u w=1.12u l=0.13u
X499 VSS.t80 MUX_SEL3 a_3543_331# VSS.t112 sg13_lv_nmos ad=0.1331p pd=1.12u as=0.1216p ps=1.02u w=0.64u l=0.13u
X500 a_22590_1044# a_2595_1047.t3 a_23355_1044# VSS.t229 sg13_lv_nmos ad=0.2516p pd=2.16u as=0.1406p ps=1.12u w=0.74u l=0.13u
X501 a_9712_3912# a_6854_5454# a_9444_3912# VSS.t227 sg13_lv_nmos ad=0.38p pd=2.38u as=0.68p ps=4.68u w=2u l=1u
X502 VSS.t26 DELAY_VBIASN a_22351_1842# VSS.t385 sg13_lv_nmos ad=0.2516p pd=2.16u as=0.1406p ps=1.12u w=0.74u l=0.6u
X503 VDD.t345 a_3171_1047.t4 a_21044_1008# VDD.t0 sg13_lv_pmos ad=0.3808p pd=2.92u as=0.3808p ps=2.92u w=1.12u l=0.13u
X504 VDD.t238 VSS.t167 VDD.t236 VDD.t0 sg13_lv_pmos ad=0.19p pd=1.38u as=0 ps=0 w=1u l=1u
X505 a_16271_2470# a_16033_1842# a_16163_1842# VDD.t7 sg13_lv_pmos ad=0.2128p pd=1.5u as=0.3808p ps=2.92u w=1.12u l=0.2u
X506 VDD.t56 VSS.t146 VDD.t31 VDD.t0 sg13_lv_pmos ad=0.19p pd=1.38u as=0 ps=0 w=1u l=1u
X507 a_19833_1842# a_19637_1842# VSS.t291 VSS.t290 sg13_lv_nmos ad=0.2516p pd=2.16u as=0.1406p ps=1.12u w=0.74u l=0.13u
X508 VDD.t386 a_2019_311# a_5705_519# VDD.t0 sg13_lv_pmos ad=0.3808p pd=2.92u as=0.3808p ps=2.92u w=1.12u l=0.13u
X509 VDD.t255 a_14851_6228# a_15108_6109# VDD.t10 sg13_lv_pmos ad=0.2639p pd=1.81u as=79.8f ps=0.8u w=0.42u l=0.13u
X510 a_10520_6292# a_10232_5871# a_10458_6292# VSS.t327 sg13_lv_nmos ad=0.1428p pd=1.52u as=37.8f ps=0.6u w=0.42u l=0.13u
X511 a_15270_6305# a_12849_5867# VSS.t11 VSS.t10 sg13_lv_nmos ad=37.8f pd=0.6u as=79.8f ps=0.8u w=0.42u l=0.13u
X512 a_20071_2470# a_19833_1842# a_19963_1842# VDD.t7 sg13_lv_pmos ad=0.2128p pd=1.5u as=0.3808p ps=2.92u w=1.12u l=0.2u
X513 a_9193_1842# a_8997_1842# VSS.t54 VSS.t53 sg13_lv_nmos ad=0.2516p pd=2.16u as=0.1406p ps=1.12u w=0.74u l=0.13u
X514 a_24631_1842# a_24393_1842# a_24523_1842# VSS.t333 sg13_lv_nmos ad=0.1406p pd=1.12u as=0.2516p ps=2.16u w=0.74u l=0.2u
X515 VDD.t58 VSS.t146 VDD.t57 VDD.t0 sg13_lv_pmos ad=0.34p pd=2.68u as=0 ps=0 w=1u l=1u
X516 VSS.t316 a_2019_1047.t7 a_10404_1008# VSS.t315 sg13_lv_nmos ad=0.2516p pd=2.16u as=0.2516p ps=2.16u w=0.74u l=0.13u
X517 VSS.t404 DELAY_VBIASN VSS.t406 VSS.t405 sg13_lv_nmos ad=1.33p pd=7.38u as=0 ps=0 w=7u l=7u
X518 VDD.t216 a_14643_1842# a_15077_1842# VDD.t7 sg13_lv_pmos ad=0.2128p pd=1.5u as=0.3808p ps=2.92u w=1.12u l=0.13u
X519 VDD.t163 a_1544_289# a_2297_331# VDD.t0 sg13_lv_pmos ad=0.1918p pd=1.5u as=0.1596p ps=1.22u w=0.84u l=0.13u
X520 a_23633_1842# a_23437_1842# VSS.t15 VSS.t216 sg13_lv_nmos ad=0.2516p pd=2.16u as=0.1406p ps=1.12u w=0.74u l=0.13u
X521 VSS.t157 VDD.t403 VSS.t157 VSS.t158 sg13_lv_nmos ad=0.1428p pd=1.52u as=0 ps=0 w=0.42u l=1u
X522 a_2019_311# a_1721_331# VDD.t207 VDD.t0 sg13_lv_pmos ad=0.2128p pd=1.5u as=0.1918p ps=1.5u w=1.12u l=0.13u
X523 VSS.t208 a_9323_1842# a_9757_1842# VSS.t207 sg13_lv_nmos ad=0.1406p pd=1.12u as=0.2516p ps=2.16u w=0.74u l=0.13u
X524 a_26395_1044# a_26185_1044# VSS.t200 VSS.t199 sg13_lv_nmos ad=0.1406p pd=1.12u as=0.1665p ps=1.19u w=0.74u l=0.13u
X525 VDD.t288 DELAY_VBIASP a_17791_2470# VDD.t7 sg13_lv_pmos ad=0.3808p pd=2.92u as=0.2128p ps=1.5u w=1.12u l=0.6u
X526 VSS.t587 a_3747_1047.t3 a_24951_1008# VSS.t593 sg13_lv_nmos ad=0.2516p pd=2.16u as=0.2516p ps=2.16u w=0.74u l=0.13u
X527 VSS.t133 VDD.t410 VSS.t133 VSS.t132 sg13_lv_nmos ad=0.1428p pd=1.52u as=0 ps=0 w=0.42u l=1u
X528 VSS.t155 VDD.t404 VSS.t155 VSS.t154 sg13_lv_nmos ad=0.1428p pd=1.52u as=0 ps=0 w=0.42u l=1u
X529 a_3747_1047.t0 a_3449_1395# VDD.t73 VDD.t0 sg13_lv_pmos ad=0.2128p pd=1.5u as=0.1918p ps=1.5u w=1.12u l=0.13u
X530 a_13368_1044# a_12797_1842# VDD.t52 VDD.t0 sg13_lv_pmos ad=0.2128p pd=1.5u as=0.3808p ps=2.92u w=1.12u l=0.13u
X531 a_24008_1044# a_23437_1842# VSS.t215 VSS.t214 sg13_lv_nmos ad=0.1406p pd=1.12u as=0.2516p ps=2.16u w=0.74u l=0.13u
X532 VDD.t272 DELAY_VBIASP a_21591_2470# VDD.t7 sg13_lv_pmos ad=0.3808p pd=2.92u as=0.2128p ps=1.5u w=1.12u l=0.6u
X533 a_15964_289# MUX_SEL4 a_5731_289# VDD.t0 sg13_lv_pmos ad=0.3304p pd=1.71u as=0.3808p ps=2.92u w=1.12u l=0.13u
X534 a_4350_1044# a_6711_1008# a_6635_1044# VDD.t0 sg13_lv_pmos ad=0.3808p pd=2.92u as=0.2128p ps=1.5u w=1.12u l=0.13u
X535 a_2873_1395# MUX_SEL1 VDD.t308 VDD.t0 sg13_lv_pmos ad=0.1596p pd=1.22u as=0.2856p ps=2.36u w=0.84u l=0.13u
X536 VSS.t5 a_12849_5867# a_13400_5105# VSS.t8 sg13_lv_nmos ad=0.1626p pd=1.415u as=60.89999f ps=0.71u w=0.42u l=0.13u
X537 a_1256_1044# MUX_SEL0 VSS.t17 VSS.t544 sg13_lv_nmos ad=0.2516p pd=2.16u as=0.2516p ps=2.16u w=0.74u l=0.13u
X538 VSS.t131 VDD.t411 VSS.t129 VSS.t130 sg13_lv_nmos ad=79.8f pd=0.8u as=0 ps=0 w=0.42u l=1u
X539 a_19550_1044# a_20391_1008# a_20315_1044# VDD.t0 sg13_lv_pmos ad=0.3808p pd=2.92u as=0.2128p ps=1.5u w=1.12u l=0.13u
X540 VDD.t121 VDD.t119 VDD.t118 VDD.t7 sg13_lv_pmos ad=0.2128p pd=1.5u as=0 ps=0 w=1.12u l=0.2u
X541 a_5631_1842# a_5393_1842# a_5523_1842# VSS.t455 sg13_lv_nmos ad=0.1406p pd=1.12u as=0.2516p ps=2.16u w=0.74u l=0.2u
X542 a_14513_1842# a_14317_1842# VSS.t223 VSS.t222 sg13_lv_nmos ad=0.2516p pd=2.16u as=0.1406p ps=1.12u w=0.74u l=0.13u
X543 VSS.t65 a_2595_311.t2 a_20905_519# VSS.t64 sg13_lv_nmos ad=0.2516p pd=2.16u as=0.2516p ps=2.16u w=0.74u l=0.13u
X544 VDD.t122 a_7477_1842# a_7945_1044# VDD.t0 sg13_lv_pmos ad=0.252p pd=1.57u as=0.3808p ps=2.92u w=1.12u l=0.13u
X545 a_13470_1044# a_3171_1047.t6 a_14888_1044# VSS.t513 sg13_lv_nmos ad=0.2516p pd=2.16u as=0.1406p ps=1.12u w=0.74u l=0.13u
X546 a_4633_1842# a_4437_1842# VSS.t254 VSS.t621 sg13_lv_nmos ad=0.2516p pd=2.16u as=0.1406p ps=1.12u w=0.74u l=0.13u
X547 a_1256_289# MUX_SEL2 VSS.t102 VSS.t101 sg13_lv_nmos ad=0.2516p pd=2.16u as=0.2516p ps=2.16u w=0.74u l=0.13u
X548 VSS.t192 a_2019_1047.t2 a_25604_1008# VSS.t191 sg13_lv_nmos ad=0.2516p pd=2.16u as=0.2516p ps=2.16u w=0.74u l=0.13u
X549 a_13019_5831# a_15688_5403# VDD.t39 VDD.t10 sg13_lv_pmos ad=0.3808p pd=2.92u as=0.2128p ps=1.5u w=1.12u l=0.13u
X550 VSS.t400 DELAY_VBIASN VSS.t402 VSS.t401 sg13_lv_nmos ad=1.33p pd=7.38u as=0 ps=0 w=7u l=7u
X551 a_16108_289# MUX_SEL4 a_15964_289# VSS.t566 sg13_lv_nmos ad=0.2516p pd=2.16u as=0.2183p ps=1.33u w=0.74u l=0.13u
X552 a_13400_6305# a_12355_5867# a_13306_6305# VSS.t503 sg13_lv_nmos ad=60.89999f pd=0.71u as=0.1428p ps=1.52u w=0.42u l=0.13u
X553 a_22873_1842# a_22677_1842# VDD.t23 VDD.t7 sg13_lv_pmos ad=0.3808p pd=2.92u as=0.2128p ps=1.5u w=1.12u l=0.13u
X554 a_21835_1044# a_21625_1044# VSS.t87 VSS.t86 sg13_lv_nmos ad=0.1406p pd=1.12u as=0.1665p ps=1.19u w=0.74u l=0.13u
X555 VSS.t313 a_2595_1047.t4 a_20391_1008# VSS.t312 sg13_lv_nmos ad=0.2516p pd=2.16u as=0.2516p ps=2.16u w=0.74u l=0.13u
X556 a_9675_1044# a_9465_1044# VDD.t45 VDD.t0 sg13_lv_pmos ad=0.2128p pd=1.5u as=0.252p ps=1.57u w=1.12u l=0.13u
X557 VSS.t85 a_10517_1842# a_10985_1044# VSS.t534 sg13_lv_nmos ad=0.1665p pd=1.19u as=0.2516p ps=2.16u w=0.74u l=0.13u
X558 VDD.t149 a_2595_1047.t8 a_8231_1008# VDD.t0 sg13_lv_pmos ad=0.3808p pd=2.92u as=0.3808p ps=2.92u w=1.12u l=0.13u
X559 a_18551_1842# a_18313_1842# a_18443_1842# VSS.t116 sg13_lv_nmos ad=0.1406p pd=1.12u as=0.2516p ps=2.16u w=0.74u l=0.2u
X560 a_12943_5867# a_12656_5864# a_12849_5867# VDD.t10 sg13_lv_pmos ad=0.2128p pd=1.5u as=0.3808p ps=2.92u w=1.12u l=0.13u
X561 a_13566_5835# a_14009_5878# a_13949_5914# VDD.t10 sg13_lv_pmos ad=79.8f pd=0.8u as=63f ps=0.72u w=0.42u l=0.13u
X562 a_22351_1842# a_22113_1842# a_22243_1842# VSS.t604 sg13_lv_nmos ad=0.1406p pd=1.12u as=0.2516p ps=2.16u w=0.74u l=0.2u
X563 VSS.t78 a_3747_1047.t5 a_18871_1008# VSS.t77 sg13_lv_nmos ad=0.2516p pd=2.16u as=0.2516p ps=2.16u w=0.74u l=0.13u
X564 VSS.t50 a_16923_1842# a_17357_1842# VSS.t49 sg13_lv_nmos ad=0.1406p pd=1.12u as=0.2516p ps=2.16u w=0.74u l=0.13u
X565 VDD.t191 a_3171_311.t2 a_23945_519# VDD.t0 sg13_lv_pmos ad=0.3808p pd=2.92u as=0.3808p ps=2.92u w=1.12u l=0.13u
X566 a_2019_311# a_1721_331# VSS.t262 VSS.t347 sg13_lv_nmos ad=0.1406p pd=1.12u as=0.1331p ps=1.12u w=0.74u l=0.13u
X567 a_25153_1842# a_24957_1842# VDD.t185 VDD.t7 sg13_lv_pmos ad=0.3808p pd=2.92u as=0.2128p ps=1.5u w=1.12u l=0.13u
X568 a_17928_1044# a_17357_1842# VSS.t233 VSS.t596 sg13_lv_nmos ad=0.1406p pd=1.12u as=0.2516p ps=2.16u w=0.74u l=0.13u
X569 a_12715_1044# a_12505_1044# VSS.t458 VSS.t457 sg13_lv_nmos ad=0.1406p pd=1.12u as=0.1665p ps=1.19u w=0.74u l=0.13u
X570 a_13880_6292# a_14111_5878# a_13566_5835# VSS.t193 sg13_lv_nmos ad=0.2373p pd=1.97u as=79.8f ps=0.8u w=0.42u l=0.13u
X571 a_15053_5990# a_14111_5878# a_14851_6228# VDD.t10 sg13_lv_pmos ad=93.45f pd=0.865u as=0.2048p ps=1.63u w=0.42u l=0.13u
X572 VDD.t341 MUX_SEL4 a_15765_463# VDD.t0 sg13_lv_pmos ad=0.3808p pd=2.92u as=0.3808p ps=2.92u w=1.12u l=0.13u
X573 a_19550_1044# a_3171_1047.t4 a_20968_1044# VSS.t575 sg13_lv_nmos ad=0.2516p pd=2.16u as=0.1406p ps=1.12u w=0.74u l=0.13u
X574 VSS.t3 DELAY_VBIASN a_10951_1842# VSS.t432 sg13_lv_nmos ad=0.2516p pd=2.16u as=0.1406p ps=1.12u w=0.74u l=0.6u
X575 a_19550_1044# a_19524_1008# a_19448_1044# VDD.t0 sg13_lv_pmos ad=0.3808p pd=2.92u as=0.2128p ps=1.5u w=1.12u l=0.13u
X576 a_7288_1044# a_6717_1842# VSS.t373 VSS.t375 sg13_lv_nmos ad=0.1406p pd=1.12u as=0.2516p ps=2.16u w=0.74u l=0.13u
X577 a_12355_5867# a_12158_5867# VSS.t252 VSS.t346 sg13_lv_nmos ad=0.2516p pd=2.16u as=0.1406p ps=1.12u w=0.74u l=0.13u
X578 VSS.t107 a_20723_1842# a_21157_1842# VSS.t555 sg13_lv_nmos ad=0.1406p pd=1.12u as=0.2516p ps=2.16u w=0.74u l=0.13u
X579 VDD.t257 a_14851_6228# a_15688_5867# VDD.t10 sg13_lv_pmos ad=0.2128p pd=1.5u as=0.3864p ps=2.93u w=1.12u l=0.13u
X580 a_1544_289# MUX_SEL3 VSS.t102 VSS.t110 sg13_lv_nmos ad=0.2516p pd=2.16u as=0.2516p ps=2.16u w=0.74u l=0.13u
X581 a_13470_1044# a_14311_1008# a_14235_1044# VDD.t0 sg13_lv_pmos ad=0.3808p pd=2.92u as=0.2128p ps=1.5u w=1.12u l=0.13u
X582 a_22590_1044# a_3747_1047.t3 a_24875_1044# VSS.t592 sg13_lv_nmos ad=0.2516p pd=2.16u as=0.1406p ps=1.12u w=0.74u l=0.13u
X583 VSS.t281 DELAY_VBIASN a_23871_1842# VSS.t389 sg13_lv_nmos ad=0.2516p pd=2.16u as=0.1406p ps=1.12u w=0.74u l=0.6u
X584 VDD.t224 a_2019_1047.t3 a_22564_1008# VDD.t0 sg13_lv_pmos ad=0.3808p pd=2.92u as=0.3808p ps=2.92u w=1.12u l=0.13u
X585 VSS.t200 a_25717_1842# a_26185_1044# VSS.t201 sg13_lv_nmos ad=0.1665p pd=1.19u as=0.2516p ps=2.16u w=0.74u l=0.13u
X586 a_13231_1842# a_12993_1842# a_13123_1842# VSS.t500 sg13_lv_nmos ad=0.1406p pd=1.12u as=0.2516p ps=2.16u w=0.74u l=0.2u
X587 VSS.t125 VDD.t412 VSS.t125 VSS.t127 sg13_lv_nmos ad=79.8f pd=0.8u as=0 ps=0 w=0.42u l=1u
X588 a_17791_2470# a_17553_1842# a_17683_1842# VDD.t7 sg13_lv_pmos ad=0.2128p pd=1.5u as=0.3808p ps=2.92u w=1.12u l=0.2u
X589 VSS.t114 a_4437_1842# a_4905_1044# VSS.t620 sg13_lv_nmos ad=0.1665p pd=1.19u as=0.2516p ps=2.16u w=0.74u l=0.13u
X590 VDD.t236 VSS.t167 VDD.t235 VDD.t0 sg13_lv_pmos ad=0.34p pd=2.68u as=0 ps=0 w=1u l=1u
X591 a_12233_1842# a_12037_1842# VSS.t350 VSS.t605 sg13_lv_nmos ad=0.2516p pd=2.16u as=0.1406p ps=1.12u w=0.74u l=0.13u
X592 VDD.t14 a_9547_6172# a_9547_5942# VDD.t10 sg13_lv_pmos ad=1.10612p pd=6.66u as=0.2442p ps=2.06u w=0.66u l=0.13u
X593 a_15108_5325# a_14851_5182# a_15270_5105# VSS.t217 sg13_lv_nmos ad=0.1428p pd=1.52u as=37.8f ps=0.6u w=0.42u l=0.13u
X594 VSS.t98 a_3449_1395# a_3747_1047.t1 VSS.t97 sg13_lv_nmos ad=0.2812p pd=2.24u as=0.1406p ps=1.12u w=0.74u l=0.13u
X595 VDD.t31 VSS.t144 VDD.t30 VDD.t0 sg13_lv_pmos ad=0.34p pd=2.68u as=0 ps=0 w=1u l=1u
X596 VDD.t240 VSS.t153 VDD.t232 VDD.t0 sg13_lv_pmos ad=0.19p pd=1.38u as=0 ps=0 w=1u l=1u
X597 VSS.t174 VDD.t399 VSS.t172 VSS.t173 sg13_lv_nmos ad=79.8f pd=0.8u as=0 ps=0 w=0.42u l=1u
X598 VSS.t246 a_3171_1047.t8 a_8884_1008# VSS.t245 sg13_lv_nmos ad=0.2516p pd=2.16u as=0.2516p ps=2.16u w=0.74u l=0.13u
X599 a_21591_2470# a_21353_1842# a_21483_1842# VDD.t7 sg13_lv_pmos ad=0.2128p pd=1.5u as=0.3808p ps=2.92u w=1.12u l=0.2u
X600 VDD.t135 a_2873_1395# a_3171_1047.t0 VDD.t0 sg13_lv_pmos ad=0.4256p pd=3u as=0.2128p ps=1.5u w=1.12u l=0.13u
X601 a_6153_1842# a_5957_1842# VDD.t162 VDD.t7 sg13_lv_pmos ad=0.3808p pd=2.92u as=0.2128p ps=1.5u w=1.12u l=0.13u
X602 VDD.t36 a_16163_1842# a_16597_1842# VDD.t7 sg13_lv_pmos ad=0.2128p pd=1.5u as=0.3808p ps=2.92u w=1.12u l=0.13u
X603 a_3543_1395# MUX_SEL0 a_3449_1395# VSS.t546 sg13_lv_nmos ad=0.1216p pd=1.02u as=0.2176p ps=1.96u w=0.64u l=0.13u
X604 VDD.t18 a_1544_1044# a_2297_1395# VDD.t0 sg13_lv_pmos ad=0.1918p pd=1.5u as=0.1596p ps=1.22u w=0.84u l=0.13u
X605 VDD.t263 DELAY_VBIASP a_10191_2470# VDD.t7 sg13_lv_pmos ad=0.3808p pd=2.92u as=0.2128p ps=1.5u w=1.12u l=0.6u
X606 a_17275_1044# a_17065_1044# VDD.t37 VDD.t0 sg13_lv_pmos ad=0.2128p pd=1.5u as=0.252p ps=1.57u w=1.12u l=0.13u
X607 a_2019_1047.t0 a_1721_1395# VDD.t40 VDD.t0 sg13_lv_pmos ad=0.2128p pd=1.5u as=0.1918p ps=1.5u w=1.12u l=0.13u
X608 a_27915_1044# a_27705_1044# VSS.t46 VSS.t45 sg13_lv_nmos ad=0.1406p pd=1.12u as=0.1665p ps=1.19u w=0.74u l=0.13u
X609 VSS.t22 DELAY_VBIASN a_26151_1842# VSS.t446 sg13_lv_nmos ad=0.2516p pd=2.16u as=0.1406p ps=1.12u w=0.74u l=0.6u
X610 VDD.t361 a_3747_1047.t6 a_15831_1008# VDD.t0 sg13_lv_pmos ad=0.3808p pd=2.92u as=0.3808p ps=2.92u w=1.12u l=0.13u
X611 VDD.t139 a_19963_1842# a_20397_1842# VDD.t7 sg13_lv_pmos ad=0.2128p pd=1.5u as=0.3808p ps=2.92u w=1.12u l=0.13u
X612 VSS.t176 VDD.t398 VSS.t176 VSS.t175 sg13_lv_nmos ad=0.1428p pd=1.52u as=0 ps=0 w=0.42u l=1u
X613 VSS.t36 DELAY_VBIASN a_4871_1842# VSS.t384 sg13_lv_nmos ad=0.2516p pd=2.16u as=0.1406p ps=1.12u w=0.74u l=0.6u
X614 a_14888_1044# a_14317_1842# VDD.t145 VDD.t0 sg13_lv_pmos ad=0.2128p pd=1.5u as=0.3808p ps=2.92u w=1.12u l=0.13u
X615 a_4350_1044# a_4324_1008# a_4248_1044# VDD.t0 sg13_lv_pmos ad=0.3808p pd=2.92u as=0.2128p ps=1.5u w=1.12u l=0.13u
X616 a_1256_289# MUX_SEL2 VDD.t76 VDD.t0 sg13_lv_pmos ad=0.3808p pd=2.92u as=0.3808p ps=2.92u w=1.12u l=0.13u
X617 VSS.t492 VSS.t489 VSS.t491 VSS.t490 sg13_lv_nmos ad=0.2516p pd=2.16u as=0 ps=0 w=0.74u l=0.6u
X618 a_16108_289# a_15765_463# a_15964_289# VDD.t0 sg13_lv_pmos ad=0.3808p pd=2.92u as=0.3304p ps=1.71u w=1.12u l=0.13u
X619 VDD.t13 a_12849_5867# a_13566_5835# VDD.t10 sg13_lv_pmos ad=0.1563p pd=1.22u as=0.147p ps=1.54u w=0.42u l=0.13u
X620 VSS.t396 DELAY_VBIASN VSS.t395 VSS.t394 sg13_lv_nmos ad=2.38p pd=14.68u as=0 ps=0 w=7u l=7u
X621 a_11473_1842# a_11277_1842# VDD.t9 VDD.t7 sg13_lv_pmos ad=0.3808p pd=2.92u as=0.2128p ps=1.5u w=1.12u l=0.13u
X622 VDD.t45 a_8997_1842# a_9465_1044# VDD.t0 sg13_lv_pmos ad=0.252p pd=1.57u as=0.3808p ps=2.92u w=1.12u l=0.13u
X623 a_27433_1842# a_27237_1842# VSS.t243 VSS.t542 sg13_lv_nmos ad=0.2516p pd=2.16u as=0.1406p ps=1.12u w=0.74u l=0.13u
X624 a_2391_331# MUX_SEL2 a_2297_331# VSS.t103 sg13_lv_nmos ad=0.1216p pd=1.02u as=0.2176p ps=1.96u w=0.64u l=0.13u
X625 a_2967_331# MUX_SEL3 a_2873_331# VSS.t111 sg13_lv_nmos ad=0.1216p pd=1.02u as=0.2176p ps=1.96u w=0.64u l=0.13u
X626 VDD.t391 a_2019_1047.t5 a_16484_1008# VDD.t0 sg13_lv_pmos ad=0.3808p pd=2.92u as=0.3808p ps=2.92u w=1.12u l=0.13u
X627 a_7390_1044# a_2595_1047.t8 a_8155_1044# VSS.t234 sg13_lv_nmos ad=0.2516p pd=2.16u as=0.1406p ps=1.12u w=0.74u l=0.13u
X628 VSS.t340 a_6126_3816# a_5974_5723# VSS.t41 sg13_lv_nmos ad=0.68p pd=4.68u as=0.38p ps=2.38u w=2u l=1u
X629 VSS.t380 DELAY_VBIASN a_7151_1842# VSS.t429 sg13_lv_nmos ad=0.2516p pd=2.16u as=0.1406p ps=1.12u w=0.74u l=0.6u
X630 VDD.t193 a_3171_1047.t9 a_5844_1008# VDD.t0 sg13_lv_pmos ad=0.3808p pd=2.92u as=0.3808p ps=2.92u w=1.12u l=0.13u
X631 VDD.t271 DELAY_VBIASP a_25391_2470# VDD.t7 sg13_lv_pmos ad=0.3808p pd=2.92u as=0.2128p ps=1.5u w=1.12u l=0.6u
X632 VDD.t196 a_2595_1047.t7 a_11271_1008# VDD.t0 sg13_lv_pmos ad=0.3808p pd=2.92u as=0.3808p ps=2.92u w=1.12u l=0.13u
X633 VDD.t6 VSS.t135 VDD.t4 VDD.t0 sg13_lv_pmos ad=0.19p pd=1.38u as=0 ps=0 w=1u l=1u
X634 VSS.t458 a_12037_1842# a_12505_1044# VSS.t606 sg13_lv_nmos ad=0.1665p pd=1.19u as=0.2516p ps=2.16u w=0.74u l=0.13u
X635 VDD.t70 a_3747_1047.t8 a_9751_1008# VDD.t0 sg13_lv_pmos ad=0.3808p pd=2.92u as=0.3808p ps=2.92u w=1.12u l=0.13u
X636 a_12943_5867# a_13121_5831# VDD.t24 VDD.t10 sg13_lv_pmos ad=0.3808p pd=2.92u as=0.2128p ps=1.5u w=1.12u l=0.13u
X637 a_11748_6109# a_11491_6228# a_11910_6305# VSS.t250 sg13_lv_nmos ad=0.1428p pd=1.52u as=37.8f ps=0.6u w=0.42u l=0.13u
X638 a_9431_1842# a_9193_1842# a_9323_1842# VSS.t194 sg13_lv_nmos ad=0.1406p pd=1.12u as=0.2516p ps=2.16u w=0.74u l=0.2u
X639 a_18313_1842# a_18117_1842# VSS.t275 VSS.t325 sg13_lv_nmos ad=0.2516p pd=2.16u as=0.1406p ps=1.12u w=0.74u l=0.13u
X640 MUX_OUT a_16851_309# VSS.t109 VSS.t571 sg13_lv_nmos ad=0.1406p pd=1.12u as=0.1371p ps=1.12u w=0.74u l=0.13u
X641 a_10232_5871# a_10206_5835# VDD.t179 VDD.t10 sg13_lv_pmos ad=0.34p pd=2.68u as=0.36237p ps=2.605u w=1u l=0.13u
X642 a_14851_5182# a_14009_5084# a_14757_5182# VSS.t58 sg13_lv_nmos ad=0.12665p pd=1.145u as=0.1428p ps=1.52u w=0.42u l=0.13u
X643 VSS.t167 VDD.t400 VSS.t167 VSS.t169 sg13_lv_nmos ad=79.8f pd=0.8u as=0 ps=0 w=0.42u l=1u
X644 a_23871_1842# a_23633_1842# a_23763_1842# VSS.t100 sg13_lv_nmos ad=0.1406p pd=1.12u as=0.2516p ps=2.16u w=0.74u l=0.2u
X645 a_8433_1842# a_8237_1842# VSS.t383 VSS.t600 sg13_lv_nmos ad=0.2516p pd=2.16u as=0.1406p ps=1.12u w=0.74u l=0.13u
X646 VSS.t442 a_18443_1842# a_18877_1842# VSS.t580 sg13_lv_nmos ad=0.1406p pd=1.12u as=0.2516p ps=2.16u w=0.74u l=0.13u
X647 VSS.t146 VDD.t407 VSS.t144 VSS.t145 sg13_lv_nmos ad=79.8f pd=0.8u as=0 ps=0 w=0.42u l=1u
X648 VSS.t338 a_6126_3816# a_5974_5723# VSS.t41 sg13_lv_nmos ad=0.68p pd=4.68u as=0.38p ps=2.38u w=2u l=1u
X649 a_22113_1842# a_21917_1842# VSS.t1 VSS.t561 sg13_lv_nmos ad=0.2516p pd=2.16u as=0.1406p ps=1.12u w=0.74u l=0.13u
X650 a_1544_289# MUX_SEL3 VDD.t83 VDD.t0 sg13_lv_pmos ad=0.3808p pd=2.92u as=0.3808p ps=2.92u w=1.12u l=0.13u
X651 VDD.t99 VDD.t91 VDD.t98 VDD.t10 sg13_lv_pmos ad=0.38p pd=2.38u as=0 ps=0 w=2u l=1u
X652 a_26673_1842# a_26477_1842# VDD.t21 VDD.t7 sg13_lv_pmos ad=0.3808p pd=2.92u as=0.2128p ps=1.5u w=1.12u l=0.13u
X653 a_10328_1044# a_9757_1842# VSS.t92 VSS.t598 sg13_lv_nmos ad=0.1406p pd=1.12u as=0.2516p ps=2.16u w=0.74u l=0.13u
X654 VSS.t146 VDD.t406 VSS.t146 VSS.t147 sg13_lv_nmos ad=0.1428p pd=1.52u as=0 ps=0 w=0.42u l=1u
X655 a_22590_1044# a_2019_1047.t3 a_22488_1044# VSS.t366 sg13_lv_nmos ad=0.2516p pd=2.16u as=0.1406p ps=1.12u w=0.74u l=0.13u
X656 VSS.t75 DELAY_VBIASN a_12471_1842# VSS.t433 sg13_lv_nmos ad=0.2516p pd=2.16u as=0.1406p ps=1.12u w=0.74u l=0.6u
X657 a_8808_1044# a_8237_1842# VSS.t236 VSS.t599 sg13_lv_nmos ad=0.1406p pd=1.12u as=0.2516p ps=2.16u w=0.74u l=0.13u
X658 VSS.t26 a_22243_1842# a_22677_1842# VSS.t496 sg13_lv_nmos ad=0.1406p pd=1.12u as=0.2516p ps=2.16u w=0.74u l=0.13u
X659 VDD.t267 DELAY_VBIASP a_6391_2470# VDD.t7 sg13_lv_pmos ad=0.3808p pd=2.92u as=0.2128p ps=1.5u w=1.12u l=0.6u
X660 a_13470_1044# a_15831_1008# a_15755_1044# VDD.t0 sg13_lv_pmos ad=0.3808p pd=2.92u as=0.2128p ps=1.5u w=1.12u l=0.13u
X661 a_1544_1044# MUX_SEL1 VDD.t309 VDD.t0 sg13_lv_pmos ad=0.3808p pd=2.92u as=0.3808p ps=2.92u w=1.12u l=0.13u
X662 VDD.t275 DELAY_VBIASP a_20831_2470# VDD.t7 sg13_lv_pmos ad=0.3808p pd=2.92u as=0.2128p ps=1.5u w=1.12u l=0.6u
X663 VDD.t214 a_2595_1047.t2 a_26471_1008# VDD.t0 sg13_lv_pmos ad=0.3808p pd=2.92u as=0.3808p ps=2.92u w=1.12u l=0.13u
X664 a_4350_1044# a_5191_1008# a_5115_1044# VDD.t0 sg13_lv_pmos ad=0.3808p pd=2.92u as=0.2128p ps=1.5u w=1.12u l=0.13u
X665 VDD.t37 a_16597_1842# a_17065_1044# VDD.t0 sg13_lv_pmos ad=0.252p pd=1.57u as=0.3808p ps=2.92u w=1.12u l=0.13u
X666 VSS.t46 a_27237_1842# a_27705_1044# VSS.t541 sg13_lv_nmos ad=0.1665p pd=1.19u as=0.2516p ps=2.16u w=0.74u l=0.13u
X667 VSS.t395 DELAY_VBIASN VSS.t398 VSS.t397 sg13_lv_nmos ad=1.33p pd=7.38u as=0 ps=0 w=7u l=7u
X668 a_10191_2470# a_9953_1842# a_10083_1842# VDD.t7 sg13_lv_pmos ad=0.2128p pd=1.5u as=0.3808p ps=2.92u w=1.12u l=0.2u
X669 a_2595_1047.t1 a_2297_1395# VSS.t17 VSS.t16 sg13_lv_nmos ad=0.1406p pd=1.12u as=0.1331p ps=1.12u w=0.74u l=0.13u
X670 a_26151_1842# a_25913_1842# a_26043_1842# VSS.t273 sg13_lv_nmos ad=0.1406p pd=1.12u as=0.2516p ps=2.16u w=0.74u l=0.2u
X671 VSS.t150 a_2019_311# a_17865_519# VSS.t610 sg13_lv_nmos ad=0.2516p pd=2.16u as=0.2516p ps=2.16u w=0.74u l=0.13u
X672 VSS.t262 a_1544_289# a_2391_331# VSS.t352 sg13_lv_nmos ad=0.1331p pd=1.12u as=0.1216p ps=1.02u w=0.64u l=0.13u
X673 a_4871_1842# a_4633_1842# a_4763_1842# VSS.t562 sg13_lv_nmos ad=0.1406p pd=1.12u as=0.2516p ps=2.16u w=0.74u l=0.2u
X674 a_13753_1842# a_13557_1842# VSS.t94 VSS.t241 sg13_lv_nmos ad=0.2516p pd=2.16u as=0.1406p ps=1.12u w=0.74u l=0.13u
X675 a_1815_1395# a_1256_1044# a_1721_1395# VSS.t501 sg13_lv_nmos ad=0.1216p pd=1.02u as=0.2176p ps=1.96u w=0.64u l=0.13u
X676 a_7673_1842# a_7477_1842# VDD.t241 VDD.t7 sg13_lv_pmos ad=0.3808p pd=2.92u as=0.2128p ps=1.5u w=1.12u l=0.13u
X677 VDD.t232 VSS.t150 VDD.t231 VDD.t0 sg13_lv_pmos ad=0.34p pd=2.68u as=0 ps=0 w=1u l=1u
X678 a_1721_331# a_1256_289# VDD.t389 VDD.t0 sg13_lv_pmos ad=0.1596p pd=1.22u as=0.2856p ps=2.36u w=0.84u l=0.13u
X679 VSS.t294 a_24523_1842# a_24957_1842# VSS.t293 sg13_lv_nmos ad=0.1406p pd=1.12u as=0.2516p ps=2.16u w=0.74u l=0.13u
X680 a_6635_1044# a_6425_1044# VSS.t256 VSS.t255 sg13_lv_nmos ad=0.1406p pd=1.12u as=0.1665p ps=1.19u w=0.74u l=0.13u
X681 VDD.t14 a_15108_5325# a_15053_5420# VDD.t10 sg13_lv_pmos ad=1.10612p pd=6.66u as=93.45f ps=0.865u w=0.42u l=0.13u
X682 VSS.t34 a_2595_1047.t9 a_5191_1008# VSS.t517 sg13_lv_nmos ad=0.2516p pd=2.16u as=0.2516p ps=2.16u w=0.74u l=0.13u
X683 a_20315_1044# a_20105_1044# VSS.t210 VSS.t209 sg13_lv_nmos ad=0.1406p pd=1.12u as=0.1665p ps=1.19u w=0.74u l=0.13u
X684 VDD.t283 DELAY_VBIASP a_11711_2470# VDD.t7 sg13_lv_pmos ad=0.3808p pd=2.92u as=0.2128p ps=1.5u w=1.12u l=0.6u
X685 a_18795_1044# a_18585_1044# VDD.t168 VDD.t0 sg13_lv_pmos ad=0.2128p pd=1.5u as=0.252p ps=1.57u w=1.12u l=0.13u
X686 a_25528_1044# a_24957_1842# VSS.t587 VSS.t586 sg13_lv_nmos ad=0.1406p pd=1.12u as=0.2516p ps=2.16u w=0.74u l=0.13u
X687 a_5778_3367# a_6126_3816# a_6326_4590# VSS.t334 sg13_lv_nmos ad=0.68p pd=4.68u as=0.38p ps=2.38u w=2u l=1u
X688 VSS.t413 DELAY_VBIASN VSS.t422 VSS.t403 sg13_lv_nmos ad=1.33p pd=7.38u as=0 ps=0 w=7u l=7u
X689 VSS.t449 DELAY_VBIASN a_27671_1842# VSS.t448 sg13_lv_nmos ad=0.2516p pd=2.16u as=0.1406p ps=1.12u w=0.74u l=0.6u
X690 a_5731_289# a_3747_311.t3 a_13470_1044# VSS.t195 sg13_lv_nmos ad=0.2516p pd=2.16u as=0.2516p ps=2.16u w=0.74u l=0.13u
X691 a_25630_1044# a_27124_1008# a_27048_1044# VDD.t0 sg13_lv_pmos ad=0.3808p pd=2.92u as=0.2128p ps=1.5u w=1.12u l=0.13u
X692 VDD.t148 a_2595_1047.t5 a_17351_1008# VDD.t0 sg13_lv_pmos ad=0.3808p pd=2.92u as=0.3808p ps=2.92u w=1.12u l=0.13u
X693 VSS.t499 a_13121_5831# a_6854_5986# VDD.t101 sg13_lv_pmos ad=0.232p pd=2.08u as=0.136p ps=1.14u w=0.4u l=0.2u
X694 VDD.t8 a_21483_1842# a_21917_1842# VDD.t7 sg13_lv_pmos ad=0.2128p pd=1.5u as=0.3808p ps=2.92u w=1.12u l=0.13u
X695 a_4350_1044# a_5844_1008# a_5768_1044# VDD.t0 sg13_lv_pmos ad=0.3808p pd=2.92u as=0.2128p ps=1.5u w=1.12u l=0.13u
X696 VSS.t109 a_16851_309# MUX_OUT VSS.t572 sg13_lv_nmos ad=0.2516p pd=2.16u as=0.1406p ps=1.12u w=0.74u l=0.13u
X697 VSS.t118 a_2019_311# a_5705_519# VSS.t608 sg13_lv_nmos ad=0.2516p pd=2.16u as=0.2516p ps=2.16u w=0.74u l=0.13u
X698 VDD.t207 a_1544_289# a_1721_331# VDD.t0 sg13_lv_pmos ad=0.1918p pd=1.5u as=0.1596p ps=1.22u w=0.84u l=0.13u
X699 a_7151_1842# a_6913_1842# a_7043_1842# VSS.t369 sg13_lv_nmos ad=0.1406p pd=1.12u as=0.2516p ps=2.16u w=0.74u l=0.2u
X700 a_16033_1842# a_15837_1842# VSS.t89 VSS.t624 sg13_lv_nmos ad=0.2516p pd=2.16u as=0.1406p ps=1.12u w=0.74u l=0.13u
X701 a_10649_5878# REF_CLK VSS.t278 VSS.t504 sg13_lv_nmos ad=0.2516p pd=2.16u as=1.9998p ps=12.915u w=0.74u l=0.13u
X702 VDD.t14 a_11748_6109# a_11693_5990# VDD.t10 sg13_lv_pmos ad=1.10612p pd=6.66u as=93.45f ps=0.865u w=0.42u l=0.13u
X703 MUX_OUT a_16851_309# VDD.t81 VDD.t0 sg13_lv_pmos ad=0.2128p pd=1.5u as=0.2086p ps=1.5u w=1.12u l=0.13u
X704 a_25391_2470# a_25153_1842# a_25283_1842# VDD.t7 sg13_lv_pmos ad=0.2128p pd=1.5u as=0.3808p ps=2.92u w=1.12u l=0.2u
X705 VDD.t86 VSS.t62 VDD.t85 VDD.t0 sg13_lv_pmos ad=0.34p pd=2.68u as=0 ps=0 w=1u l=1u
X706 a_12993_1842# a_12797_1842# VDD.t53 VDD.t7 sg13_lv_pmos ad=0.3808p pd=2.92u as=0.2128p ps=1.5u w=1.12u l=0.13u
X707 a_16408_1044# a_15837_1842# VSS.t591 VSS.t623 sg13_lv_nmos ad=0.1406p pd=1.12u as=0.2516p ps=2.16u w=0.74u l=0.13u
X708 a_5778_3367# a_6126_3816# a_6326_4590# VSS.t334 sg13_lv_nmos ad=0.68p pd=4.68u as=0.38p ps=2.38u w=2u l=1u
X709 VSS.t260 a_5523_1842# a_5957_1842# VSS.t259 sg13_lv_nmos ad=0.1406p pd=1.12u as=0.2516p ps=2.16u w=0.74u l=0.13u
X710 VDD.t286 DELAY_VBIASP a_13991_2470# VDD.t7 sg13_lv_pmos ad=0.3808p pd=2.92u as=0.2128p ps=1.5u w=1.12u l=0.6u
X711 a_5731_289# a_2019_311# a_4350_1044# VSS.t607 sg13_lv_nmos ad=0.2516p pd=2.16u as=0.2516p ps=2.16u w=0.74u l=0.13u
X712 VSS.t83 a_9547_6172# a_9547_6172# VSS.t82 sg13_lv_nmos ad=2.39977p pd=15.495u as=0.111p ps=1.34u w=0.3u l=0.13u
X713 a_9444_3912# a_6854_5454# a_9712_3912# VSS.t226 sg13_lv_nmos ad=0.68p pd=4.68u as=0.38p ps=2.38u w=2u l=1u
X714 VSS.t427 DELAY_VBIASN VSS.t425 VSS.t409 sg13_lv_nmos ad=1.33p pd=7.38u as=0 ps=0 w=7u l=7u
X715 a_7390_1044# a_3747_1047.t8 a_9675_1044# VSS.t90 sg13_lv_nmos ad=0.2516p pd=2.16u as=0.1406p ps=1.12u w=0.74u l=0.13u
X716 VDD.t174 a_23763_1842# a_24197_1842# VDD.t7 sg13_lv_pmos ad=0.2128p pd=1.5u as=0.3808p ps=2.92u w=1.12u l=0.13u
X717 VSS.t54 DELAY_VBIASN a_8671_1842# VSS.t393 sg13_lv_nmos ad=0.2516p pd=2.16u as=0.1406p ps=1.12u w=0.74u l=0.6u
X718 VDD.t123 a_2019_1047.t8 a_7364_1008# VDD.t0 sg13_lv_pmos ad=0.3808p pd=2.92u as=0.3808p ps=2.92u w=1.12u l=0.13u
X719 VDD.t293 DELAY_VBIASP a_26911_2470# VDD.t7 sg13_lv_pmos ad=0.3808p pd=2.92u as=0.2128p ps=1.5u w=1.12u l=0.6u
X720 VSS.t57 a_14009_5084# a_14111_5227# VSS.t56 sg13_lv_nmos ad=1.45407p pd=9.445u as=0.2516p ps=2.16u w=0.74u l=0.13u
X721 VDD.t357 VSS.t178 VDD.t355 VDD.t0 sg13_lv_pmos ad=0.19p pd=1.38u as=0 ps=0 w=1u l=1u
X722 a_12471_1842# a_12233_1842# a_12363_1842# VSS.t284 sg13_lv_nmos ad=0.1406p pd=1.12u as=0.2516p ps=2.16u w=0.74u l=0.2u
X723 a_22488_1044# a_21917_1842# VDD.t336 VDD.t0 sg13_lv_pmos ad=0.2128p pd=1.5u as=0.3808p ps=2.92u w=1.12u l=0.13u
X724 VDD.t48 a_2595_311.t3 a_8745_519# VDD.t0 sg13_lv_pmos ad=0.3808p pd=2.92u as=0.3808p ps=2.92u w=1.12u l=0.13u
X725 VSS.t585 a_3171_1047.t5 a_18004_1008# VSS.t584 sg13_lv_nmos ad=0.2516p pd=2.16u as=0.2516p ps=2.16u w=0.74u l=0.13u
X726 a_6391_2470# a_6153_1842# a_6283_1842# VDD.t7 sg13_lv_pmos ad=0.2128p pd=1.5u as=0.3808p ps=2.92u w=1.12u l=0.2u
X727 a_15273_1842# a_15077_1842# VDD.t216 VDD.t7 sg13_lv_pmos ad=0.3808p pd=2.92u as=0.2128p ps=1.5u w=1.12u l=0.13u
X728 a_14235_1044# a_14025_1044# VSS.t240 VSS.t292 sg13_lv_nmos ad=0.1406p pd=1.12u as=0.1665p ps=1.19u w=0.74u l=0.13u
X729 a_6326_4590# a_6126_3816# a_5778_3367# VSS.t334 sg13_lv_nmos ad=0.42p pd=2.42u as=0.68p ps=4.68u w=2u l=1u
X730 VSS.t73 a_3747_1047.t7 a_12791_1008# VSS.t299 sg13_lv_nmos ad=0.2516p pd=2.16u as=0.2516p ps=2.16u w=0.74u l=0.13u
X731 VSS.t473 VSS.t470 VSS.t472 VSS.t471 sg13_lv_nmos ad=0.2516p pd=2.16u as=0 ps=0 w=0.74u l=0.13u
X732 a_9953_1842# a_9757_1842# VSS.t208 VSS.t597 sg13_lv_nmos ad=0.2516p pd=2.16u as=0.1406p ps=1.12u w=0.74u l=0.13u
X733 VSS.t3 a_10843_1842# a_11277_1842# VSS.t2 sg13_lv_nmos ad=0.1406p pd=1.12u as=0.2516p ps=2.16u w=0.74u l=0.13u
X734 VSS.t167 VDD.t400 VSS.t167 VSS.t168 sg13_lv_nmos ad=0.1428p pd=1.52u as=0 ps=0 w=0.42u l=1u
X735 a_10649_5878# REF_CLK VDD.t14 VDD.t10 sg13_lv_pmos ad=0.4088p pd=2.97u as=1.03698p ps=6.245u w=1.12u l=0.13u
X736 VDD.t67 a_15403_1842# a_15837_1842# VDD.t7 sg13_lv_pmos ad=0.2128p pd=1.5u as=0.3808p ps=2.92u w=1.12u l=0.13u
X737 VDD.t14 a_14009_5084# a_14111_5227# VDD.t10 sg13_lv_pmos ad=1.10612p pd=6.66u as=0.3864p ps=2.93u w=1.12u l=0.13u
X738 VSS.t144 VDD.t407 VSS.t144 VSS.t143 sg13_lv_nmos ad=0.1428p pd=1.52u as=0 ps=0 w=0.42u l=1u
X739 a_11848_1044# a_11277_1842# VSS.t272 VSS.t271 sg13_lv_nmos ad=0.1406p pd=1.12u as=0.2516p ps=2.16u w=0.74u l=0.13u
X740 a_6326_4590# a_6326_4590# VDD.t329 VDD.t10 sg13_lv_pmos ad=0.38p pd=2.38u as=0.38p ps=2.38u w=2u l=1u
X741 VDD.t35 a_4763_1842# a_5197_1842# VDD.t7 sg13_lv_pmos ad=0.2128p pd=1.5u as=0.3808p ps=2.92u w=1.12u l=0.13u
X742 VSS.t153 VDD.t405 VSS.t151 VSS.t152 sg13_lv_nmos ad=79.8f pd=0.8u as=0 ps=0 w=0.42u l=1u
X743 a_13470_1044# a_13444_1008# a_13368_1044# VDD.t0 sg13_lv_pmos ad=0.3808p pd=2.92u as=0.2128p ps=1.5u w=1.12u l=0.13u
X744 VDD.t74 a_3449_1395# a_3747_1047.t0 VDD.t0 sg13_lv_pmos ad=0.4256p pd=3u as=0.2128p ps=1.5u w=1.12u l=0.13u
X745 VSS.t482 VSS.t479 VSS.t479 VSS.t480 sg13_lv_nmos ad=0.1406p pd=1.12u as=0 ps=0 w=0.74u l=0.13u
X746 VDD.t51 a_3171_1047.t3 a_24084_1008# VDD.t0 sg13_lv_pmos ad=0.3808p pd=2.92u as=0.3808p ps=2.92u w=1.12u l=0.13u
X747 a_3449_1395# MUX_SEL0 VDD.t305 VDD.t0 sg13_lv_pmos ad=0.1596p pd=1.22u as=0.2856p ps=2.36u w=0.84u l=0.13u
X748 a_15464_3684# a_14851_5182# VDD.t142 VDD.t10 sg13_lv_pmos ad=0.4312p pd=3.01u as=0.2639p ps=1.81u w=1.12u l=0.13u
X749 a_5974_5723# a_6126_3816# VSS.t335 VSS.t41 sg13_lv_nmos ad=0.38p pd=2.38u as=0.68p ps=4.68u w=2u l=1u
X750 VDD.t278 DELAY_VBIASP a_7911_2470# VDD.t7 sg13_lv_pmos ad=0.3808p pd=2.92u as=0.2128p ps=1.5u w=1.12u l=0.6u
X751 VDD.t378 VSS.t125 VDD.t190 VDD.t0 sg13_lv_pmos ad=0.19p pd=1.38u as=0 ps=0 w=1u l=1u
X752 VDD.t99 a_6326_4590# a_6854_5986# VDD.t10 sg13_lv_pmos ad=0.38p pd=2.38u as=0.38p ps=2.38u w=2u l=1u
X753 a_10206_5835# a_10649_5878# a_9946_6305# VSS.t276 sg13_lv_nmos ad=79.8f pd=0.8u as=0.1296p ps=1.52u w=0.42u l=0.13u
X754 VDD.t380 VSS.t125 VDD.t379 VDD.t0 sg13_lv_pmos ad=0.34p pd=2.68u as=0 ps=0 w=1u l=1u
X755 a_9946_6305# a_9772_5843# VDD.t346 VDD.t10 sg13_lv_pmos ad=79.8f pd=0.8u as=0.1428p ps=1.52u w=0.42u l=0.13u
X756 a_9946_6305# a_10751_5878# a_10206_5835# VDD.t10 sg13_lv_pmos ad=0.1428p pd=1.52u as=79.8f ps=0.8u w=0.42u l=0.13u
X757 VDD.t344 a_16851_309# MUX_OUT VDD.t0 sg13_lv_pmos ad=0.7336p pd=3.55u as=0.2128p ps=1.5u w=1.12u l=0.13u
X758 VSS.t171 a_3171_311.t2 a_23945_519# VSS.t305 sg13_lv_nmos ad=0.2516p pd=2.16u as=0.2516p ps=2.16u w=0.74u l=0.13u
X759 VDD.t168 a_18117_1842# a_18585_1044# VDD.t0 sg13_lv_pmos ad=0.252p pd=1.57u as=0.3808p ps=2.92u w=1.12u l=0.13u
X760 VSS.t210 a_19637_1842# a_20105_1044# VSS.t289 sg13_lv_nmos ad=0.1665p pd=1.19u as=0.2516p ps=2.16u w=0.74u l=0.13u
X761 a_11711_2470# a_11473_1842# a_11603_1842# VDD.t7 sg13_lv_pmos ad=0.2128p pd=1.5u as=0.3808p ps=2.92u w=1.12u l=0.2u
X762 a_27671_1842# a_27433_1842# a_27563_1842# VSS.t257 sg13_lv_nmos ad=0.1406p pd=1.12u as=0.2516p ps=2.16u w=0.74u l=0.2u
X763 VSS.t109 MUX_SEL4 a_15765_463# VSS.t567 sg13_lv_nmos ad=0.2516p pd=2.16u as=0.2516p ps=2.16u w=0.74u l=0.13u
X764 a_5731_289# a_14825_519# a_13470_1044# VDD.t0 sg13_lv_pmos ad=0.3808p pd=2.92u as=0.3808p ps=2.92u w=1.12u l=0.13u
X765 a_16510_1044# a_2595_1047.t5 a_17275_1044# VSS.t231 sg13_lv_nmos ad=0.2516p pd=2.16u as=0.1406p ps=1.12u w=0.74u l=0.13u
X766 a_13045_6215# a_13019_5831# a_12849_5867# VSS.t27 sg13_lv_nmos ad=0.1406p pd=1.12u as=0.1406p ps=1.12u w=0.74u l=0.13u
X767 VSS.t38 DELAY_VBIASN a_16271_1842# VSS.t438 sg13_lv_nmos ad=0.2516p pd=2.16u as=0.1406p ps=1.12u w=0.74u l=0.6u
X768 VDD.t32 VSS.t171 VDD.t254 VDD.t0 sg13_lv_pmos ad=0.34p pd=2.68u as=0 ps=0 w=1u l=1u
X769 VDD.t258 a_3171_1047.t6 a_14964_1008# VDD.t0 sg13_lv_pmos ad=0.3808p pd=2.92u as=0.3808p ps=2.92u w=1.12u l=0.13u
X770 VDD.t204 a_10083_1842# a_10517_1842# VDD.t7 sg13_lv_pmos ad=0.2128p pd=1.5u as=0.3808p ps=2.92u w=1.12u l=0.13u
X771 VSS.t297 a_3747_1047.t2 a_27991_1008# VSS.t296 sg13_lv_nmos ad=0.2516p pd=2.16u as=0.2516p ps=2.16u w=0.74u l=0.13u
X772 a_9712_3912# a_13019_5831# DELAY_VBIASN VSS.t28 sg13_lv_nmos ad=0.136p pd=1.14u as=0.232p ps=2.08u w=0.4u l=0.2u
X773 VSS.t22 a_26043_1842# a_26477_1842# VSS.t67 sg13_lv_nmos ad=0.1406p pd=1.12u as=0.2516p ps=2.16u w=0.74u l=0.13u
X774 VSS.t344 a_6126_3816# a_5974_5723# VSS.t41 sg13_lv_nmos ad=0.68p pd=4.68u as=0.38p ps=2.38u w=2u l=1u
X775 a_11195_1044# a_10985_1044# VDD.t64 VDD.t0 sg13_lv_pmos ad=0.2128p pd=1.5u as=0.252p ps=1.57u w=1.12u l=0.13u
X776 VSS.t373 a_3747_1047.t9 a_6711_1008# VSS.t372 sg13_lv_nmos ad=0.2516p pd=2.16u as=0.2516p ps=2.16u w=0.74u l=0.13u
X777 a_9444_4590# a_6854_5454# a_6854_5454# VSS.t226 sg13_lv_nmos ad=0.68p pd=4.68u as=0.38p ps=2.38u w=2u l=1u
X778 a_16108_289# a_2595_311.t2 a_19550_1044# VSS.t63 sg13_lv_nmos ad=0.2516p pd=2.16u as=0.2516p ps=2.16u w=0.74u l=0.13u
X779 VSS.t213 DELAY_VBIASN a_20071_1842# VSS.t440 sg13_lv_nmos ad=0.2516p pd=2.16u as=0.1406p ps=1.12u w=0.74u l=0.6u
X780 VDD.t291 DELAY_VBIASP a_24631_2470# VDD.t7 sg13_lv_pmos ad=0.3808p pd=2.92u as=0.2128p ps=1.5u w=1.12u l=0.6u
X781 a_22590_1044# a_23431_1008# a_23355_1044# VDD.t0 sg13_lv_pmos ad=0.3808p pd=2.92u as=0.2128p ps=1.5u w=1.12u l=0.13u
X782 VSS.t135 VDD.t409 VSS.t135 VSS.t137 sg13_lv_nmos ad=79.8f pd=0.8u as=0 ps=0 w=0.42u l=1u
X783 a_10458_6292# DLL_RESETN VSS.t286 VSS.t361 sg13_lv_nmos ad=37.8f pd=0.6u as=0.1701p ps=1.65u w=0.42u l=0.13u
X784 a_11491_6228# a_10649_5878# a_10232_5871# VDD.t10 sg13_lv_pmos ad=0.2048p pd=1.63u as=0.34p ps=2.68u w=1u l=0.13u
X785 VSS.t342 a_6126_3816# a_5974_5723# VSS.t41 sg13_lv_nmos ad=0.76p pd=4.76u as=0.38p ps=2.38u w=2u l=1u
X786 a_8671_1842# a_8433_1842# a_8563_1842# VSS.t71 sg13_lv_nmos ad=0.1406p pd=1.12u as=0.2516p ps=2.16u w=0.74u l=0.2u
X787 a_17553_1842# a_17357_1842# VSS.t50 VSS.t595 sg13_lv_nmos ad=0.2516p pd=2.16u as=0.1406p ps=1.12u w=0.74u l=0.13u
X788 a_5731_289# a_5705_519# a_4350_1044# VDD.t0 sg13_lv_pmos ad=0.3808p pd=2.92u as=0.3808p ps=2.92u w=1.12u l=0.13u
X789 VDD.t113 VDD.t111 VDD.t112 VDD.t7 sg13_lv_pmos ad=0.3808p pd=2.92u as=0 ps=0 w=1.12u l=0.13u
X790 a_26911_2470# a_26673_1842# a_26803_1842# VDD.t7 sg13_lv_pmos ad=0.2128p pd=1.5u as=0.3808p ps=2.92u w=1.12u l=0.2u
X791 a_7390_1044# a_2019_1047.t8 a_7288_1044# VSS.t183 sg13_lv_nmos ad=0.2516p pd=2.16u as=0.1406p ps=1.12u w=0.74u l=0.13u
X792 a_13566_5328# a_14009_5084# a_13306_5105# VSS.t55 sg13_lv_nmos ad=79.8f pd=0.8u as=0.1296p ps=1.52u w=0.42u l=0.13u
X793 a_21353_1842# a_21157_1842# VSS.t107 VSS.t106 sg13_lv_nmos ad=0.2516p pd=2.16u as=0.1406p ps=1.12u w=0.74u l=0.13u
X794 VSS.t380 a_7043_1842# a_7477_1842# VSS.t379 sg13_lv_nmos ad=0.1406p pd=1.12u as=0.2516p ps=2.16u w=0.74u l=0.13u
X795 a_13121_5831# a_15688_5867# VDD.t257 VDD.t10 sg13_lv_pmos ad=0.3808p pd=2.92u as=0.2128p ps=1.5u w=1.12u l=0.13u
X796 VDD.t287 DELAY_VBIASP a_15511_2470# VDD.t7 sg13_lv_pmos ad=0.3808p pd=2.92u as=0.2128p ps=1.5u w=1.12u l=0.6u
X797 VDD.t195 a_2019_1047.t7 a_10404_1008# VDD.t0 sg13_lv_pmos ad=0.3808p pd=2.92u as=0.3808p ps=2.92u w=1.12u l=0.13u
X798 VSS.t527 a_9444_4590# a_9444_3912# VSS.t525 sg13_lv_nmos ad=0.68p pd=4.68u as=0.38p ps=2.38u w=2u l=1u
X799 VDD.t133 a_25283_1842# a_25717_1842# VDD.t7 sg13_lv_pmos ad=0.2128p pd=1.5u as=0.3808p ps=2.92u w=1.12u l=0.13u
X800 VDD.t274 DELAY_VBIASP a_5631_2470# VDD.t7 sg13_lv_pmos ad=0.3808p pd=2.92u as=0.2128p ps=1.5u w=1.12u l=0.6u
X801 a_26395_1044# a_26185_1044# VDD.t131 VDD.t0 sg13_lv_pmos ad=0.2128p pd=1.5u as=0.252p ps=1.57u w=1.12u l=0.13u
X802 a_13306_5105# a_14111_5227# a_13566_5328# VDD.t10 sg13_lv_pmos ad=0.1428p pd=1.52u as=79.8f ps=0.8u w=0.42u l=0.13u
X803 a_6326_4590# a_6126_3816# a_5778_3367# VSS.t334 sg13_lv_nmos ad=0.38p pd=2.38u as=0.68p ps=4.68u w=2u l=1u
X804 VDD.t362 a_3747_1047.t3 a_24951_1008# VDD.t0 sg13_lv_pmos ad=0.3808p pd=2.92u as=0.3808p ps=2.92u w=1.12u l=0.13u
X805 VDD.t234 VSS.t167 VDD.t213 VDD.t0 sg13_lv_pmos ad=0.19p pd=1.38u as=0 ps=0 w=1u l=1u
X806 a_13991_1842# a_13753_1842# a_13883_1842# VSS.t557 sg13_lv_nmos ad=0.1406p pd=1.12u as=0.2516p ps=2.16u w=0.74u l=0.2u
X807 a_24008_1044# a_23437_1842# VDD.t140 VDD.t0 sg13_lv_pmos ad=0.2128p pd=1.5u as=0.3808p ps=2.92u w=1.12u l=0.13u
X808 VDD.t317 VSS.t142 VDD.t27 VDD.t0 sg13_lv_pmos ad=0.19p pd=1.38u as=0 ps=0 w=1u l=1u
X809 VSS.t324 a_2019_1047.t4 a_19524_1008# VSS.t323 sg13_lv_nmos ad=0.2516p pd=2.16u as=0.2516p ps=2.16u w=0.74u l=0.13u
X810 a_9712_3912# a_6854_5454# a_9444_3912# VSS.t225 sg13_lv_nmos ad=0.38p pd=2.38u as=0.68p ps=4.68u w=2u l=1u
X811 a_7911_2470# a_7673_1842# a_7803_1842# VDD.t7 sg13_lv_pmos ad=0.2128p pd=1.5u as=0.3808p ps=2.92u w=1.12u l=0.2u
X812 a_16793_1842# a_16597_1842# VDD.t36 VDD.t7 sg13_lv_pmos ad=0.3808p pd=2.92u as=0.2128p ps=1.5u w=1.12u l=0.13u
X813 VSS.t96 MUX_SEL1 a_3543_1395# VSS.t549 sg13_lv_nmos ad=0.1331p pd=1.12u as=0.1216p ps=1.02u w=0.64u l=0.13u
X814 a_15755_1044# a_15545_1044# VSS.t551 VSS.t550 sg13_lv_nmos ad=0.1406p pd=1.12u as=0.1665p ps=1.19u w=0.74u l=0.13u
X815 a_13818_5118# a_12849_5867# VSS.t5 VSS.t4 sg13_lv_nmos ad=37.8f pd=0.6u as=0.1701p ps=1.65u w=0.42u l=0.13u
X816 a_2595_1047.t0 a_2297_1395# VDD.t18 VDD.t0 sg13_lv_pmos ad=0.2128p pd=1.5u as=0.1918p ps=1.5u w=1.12u l=0.13u
X817 VSS.t221 a_2595_1047.t6 a_14311_1008# VSS.t307 sg13_lv_nmos ad=0.2516p pd=2.16u as=0.2516p ps=2.16u w=0.74u l=0.13u
X818 VSS.t75 a_12363_1842# a_12797_1842# VSS.t186 sg13_lv_nmos ad=0.1406p pd=1.12u as=0.2516p ps=2.16u w=0.74u l=0.13u
X819 a_5115_1044# a_4905_1044# VSS.t114 VSS.t113 sg13_lv_nmos ad=0.1406p pd=1.12u as=0.1665p ps=1.19u w=0.74u l=0.13u
X820 a_1256_1044# MUX_SEL0 VDD.t306 VDD.t0 sg13_lv_pmos ad=0.3808p pd=2.92u as=0.3808p ps=2.92u w=1.12u l=0.13u
X821 a_9444_3912# a_9444_4590# VSS.t523 VSS.t522 sg13_lv_nmos ad=0.38p pd=2.38u as=0.68p ps=4.68u w=2u l=1u
X822 VSS.t420 DELAY_VBIASN VSS.t418 VSS.t399 sg13_lv_nmos ad=1.33p pd=7.38u as=0 ps=0 w=7u l=7u
X823 VDD.t261 a_27563_1842# a_27997_1842# VDD.t7 sg13_lv_pmos ad=0.2128p pd=1.5u as=0.3808p ps=2.92u w=1.12u l=0.13u
X824 a_20593_1842# a_20397_1842# VDD.t139 VDD.t7 sg13_lv_pmos ad=0.3808p pd=2.92u as=0.2128p ps=1.5u w=1.12u l=0.13u
X825 a_1721_1395# a_1256_1044# VDD.t248 VDD.t0 sg13_lv_pmos ad=0.1596p pd=1.22u as=0.2856p ps=2.36u w=0.84u l=0.13u
X826 VDD.t230 a_6283_1842# a_6717_1842# VDD.t7 sg13_lv_pmos ad=0.2128p pd=1.5u as=0.3808p ps=2.92u w=1.12u l=0.13u
X827 a_13470_1044# a_14964_1008# a_14888_1044# VDD.t0 sg13_lv_pmos ad=0.3808p pd=2.92u as=0.2128p ps=1.5u w=1.12u l=0.13u
X828 a_13592_5871# a_13566_5835# VDD.t11 VDD.t10 sg13_lv_pmos ad=0.34p pd=2.68u as=0.36237p ps=2.605u w=1u l=0.13u
X829 a_5778_3367# a_6126_3816# a_6326_4590# VSS.t334 sg13_lv_nmos ad=0.68p pd=4.68u as=0.42p ps=2.42u w=2u l=1u
X830 VSS.t151 VDD.t405 VSS.t150 VSS.t149 sg13_lv_nmos ad=0.1428p pd=1.52u as=0 ps=0 w=0.42u l=1u
X831 VDD.t126 a_2019_1047.t2 a_25604_1008# VDD.t0 sg13_lv_pmos ad=0.3808p pd=2.92u as=0.3808p ps=2.92u w=1.12u l=0.13u
X832 a_9746_5805# a_9547_5942# VSS.t83 VSS.t329 sg13_lv_nmos ad=0.27427p pd=2.28u as=2.39977p ps=15.495u w=0.795u l=0.13u
X833 a_16271_1842# a_16033_1842# a_16163_1842# VSS.t378 sg13_lv_nmos ad=0.1406p pd=1.12u as=0.2516p ps=2.16u w=0.74u l=0.2u
X834 a_21835_1044# a_21625_1044# VDD.t65 VDD.t0 sg13_lv_pmos ad=0.2128p pd=1.5u as=0.252p ps=1.57u w=1.12u l=0.13u
X835 VDD.t190 VSS.t123 VDD.t189 VDD.t0 sg13_lv_pmos ad=0.34p pd=2.68u as=0 ps=0 w=1u l=1u
X836 VDD.t194 a_2595_1047.t4 a_20391_1008# VDD.t0 sg13_lv_pmos ad=0.3808p pd=2.92u as=0.3808p ps=2.92u w=1.12u l=0.13u
X837 VSS.t13 a_14851_5182# a_15688_5403# VSS.t219 sg13_lv_nmos ad=0.1406p pd=1.12u as=0.2516p ps=2.16u w=0.74u l=0.13u
X838 a_19073_1842# a_18877_1842# VDD.t299 VDD.t7 sg13_lv_pmos ad=0.3808p pd=2.92u as=0.2128p ps=1.5u w=1.12u l=0.13u
X839 VDD.t64 a_10517_1842# a_10985_1044# VDD.t0 sg13_lv_pmos ad=0.252p pd=1.57u as=0.3808p ps=2.92u w=1.12u l=0.13u
X840 VSS.t87 a_21157_1842# a_21625_1044# VSS.t105 sg13_lv_nmos ad=0.1665p pd=1.19u as=0.2516p ps=2.16u w=0.74u l=0.13u
X841 VSS.t7 a_12849_5867# a_13400_6305# VSS.t6 sg13_lv_nmos ad=0.1626p pd=1.415u as=60.89999f ps=0.71u w=0.42u l=0.13u
X842 VSS.t337 a_6126_3816# a_6126_3816# VSS.t334 sg13_lv_nmos ad=0.68p pd=4.68u as=0.38p ps=2.38u w=2u l=1u
X843 a_20071_1842# a_19833_1842# a_19963_1842# VSS.t300 sg13_lv_nmos ad=0.1406p pd=1.12u as=0.2516p ps=2.16u w=0.74u l=0.2u
X844 VSS.t464 VSS.t462 VSS.t462 VSS.t463 sg13_lv_nmos ad=0.68p pd=4.68u as=0 ps=0 w=2u l=1u
X845 VSS.t356 a_14643_1842# a_15077_1842# VSS.t355 sg13_lv_nmos ad=0.1406p pd=1.12u as=0.2516p ps=2.16u w=0.74u l=0.13u
X846 a_1815_331# a_1256_289# a_1721_331# VSS.t615 sg13_lv_nmos ad=0.1216p pd=1.02u as=0.2176p ps=1.96u w=0.64u l=0.13u
X847 VDD.t93 VDD.t91 VDD.t92 VDD.t10 sg13_lv_pmos ad=0.38p pd=2.38u as=0 ps=0 w=2u l=1u
X848 VDD.t183 a_19203_1842# a_19637_1842# VDD.t7 sg13_lv_pmos ad=0.2128p pd=1.5u as=0.3808p ps=2.92u w=1.12u l=0.13u
X849 VSS.t321 a_2019_1047.t9 a_4324_1008# VSS.t320 sg13_lv_nmos ad=0.2516p pd=2.16u as=0.2516p ps=2.16u w=0.74u l=0.13u
X850 a_16108_289# a_20905_519# a_19550_1044# VDD.t0 sg13_lv_pmos ad=0.3808p pd=2.92u as=0.3808p ps=2.92u w=1.12u l=0.13u
X851 a_16510_1044# a_3747_1047.t5 a_18795_1044# VSS.t76 sg13_lv_nmos ad=0.2516p pd=2.16u as=0.1406p ps=1.12u w=0.74u l=0.13u
X852 VDD.t46 a_8563_1842# a_8997_1842# VDD.t7 sg13_lv_pmos ad=0.2128p pd=1.5u as=0.3808p ps=2.92u w=1.12u l=0.13u
X853 VDD.t276 DELAY_VBIASP a_13231_2470# VDD.t7 sg13_lv_pmos ad=0.3808p pd=2.92u as=0.2128p ps=1.5u w=1.12u l=0.6u
X854 VSS.t275 DELAY_VBIASN a_17791_1842# VSS.t435 sg13_lv_nmos ad=0.2516p pd=2.16u as=0.1406p ps=1.12u w=0.74u l=0.6u
X855 VSS.t129 VDD.t411 VSS.t62 VSS.t128 sg13_lv_nmos ad=0.1428p pd=1.52u as=0 ps=0 w=0.42u l=1u
X856 a_6854_5986# a_6326_4590# VDD.t331 VDD.t10 sg13_lv_pmos ad=0.38p pd=2.38u as=0.38p ps=2.38u w=2u l=1u
X857 VDD.t108 VDD.t106 VDD.t107 VDD.t101 sg13_lv_pmos ad=0.3808p pd=2.92u as=0 ps=0 w=1.12u l=0.13u
X858 VDD.t54 a_3747_1047.t5 a_18871_1008# VDD.t0 sg13_lv_pmos ad=0.3808p pd=2.92u as=0.3808p ps=2.92u w=1.12u l=0.13u
X859 VDD.t103 VDD.t104 VDD.t105 VDD.t101 sg13_lv_pmos ad=0.2128p pd=1.5u as=0 ps=0 w=1.12u l=0.13u
X860 VDD.t17 a_23003_1842# a_23437_1842# VDD.t7 sg13_lv_pmos ad=0.2128p pd=1.5u as=0.3808p ps=2.92u w=1.12u l=0.13u
X861 VSS.t526 a_9444_4590# a_9444_4590# VSS.t525 sg13_lv_nmos ad=0.68p pd=4.68u as=0.38p ps=2.38u w=2u l=1u
X862 VSS.t467 VSS.t459 VSS.t459 VSS.t460 sg13_lv_nmos ad=0.68p pd=4.68u as=0 ps=0 w=2u l=1u
X863 a_12715_1044# a_12505_1044# VDD.t244 VDD.t0 sg13_lv_pmos ad=0.2128p pd=1.5u as=0.252p ps=1.57u w=1.12u l=0.13u
X864 a_19550_1044# a_21044_1008# a_20968_1044# VDD.t0 sg13_lv_pmos ad=0.3808p pd=2.92u as=0.2128p ps=1.5u w=1.12u l=0.13u
X865 a_17928_1044# a_17357_1842# VDD.t364 VDD.t0 sg13_lv_pmos ad=0.2128p pd=1.5u as=0.3808p ps=2.92u w=1.12u l=0.13u
X866 VSS.t1 DELAY_VBIASN a_21591_1842# VSS.t444 sg13_lv_nmos ad=0.2516p pd=2.16u as=0.1406p ps=1.12u w=0.74u l=0.6u
X867 VSS.t262 a_1544_289# a_1815_331# VSS.t351 sg13_lv_nmos ad=0.1331p pd=1.12u as=0.1216p ps=1.02u w=0.64u l=0.13u
X868 a_7288_1044# a_6717_1842# VDD.t229 VDD.t0 sg13_lv_pmos ad=0.2128p pd=1.5u as=0.3808p ps=2.92u w=1.12u l=0.13u
X869 VSS.t406 DELAY_VBIASN VSS.t408 VSS.t407 sg13_lv_nmos ad=1.33p pd=7.38u as=0 ps=0 w=7u l=7u
X870 a_5974_5723# a_6126_3816# VSS.t342 VSS.t41 sg13_lv_nmos ad=0.38p pd=2.38u as=0.68p ps=4.68u w=2u l=1u
X871 a_15511_2470# a_15273_1842# a_15403_1842# VDD.t7 sg13_lv_pmos ad=0.2128p pd=1.5u as=0.3808p ps=2.92u w=1.12u l=0.2u
X872 VSS.t491 VSS.t493 VSS.t495 VSS.t494 sg13_lv_nmos ad=0.1406p pd=1.12u as=0 ps=0 w=0.74u l=0.2u
X873 a_22590_1044# a_24951_1008# a_24875_1044# VDD.t0 sg13_lv_pmos ad=0.3808p pd=2.92u as=0.2128p ps=1.5u w=1.12u l=0.13u
X874 VSS.t178 VDD.t397 VSS.t178 VSS.t180 sg13_lv_nmos ad=79.8f pd=0.8u as=0 ps=0 w=0.42u l=1u
X875 VSS.t13 a_15108_5325# a_14757_5182# VSS.t497 sg13_lv_nmos ad=79.8f pd=0.8u as=0.1428p ps=1.52u w=0.42u l=0.13u
X876 a_10430_1044# a_2019_1047.t7 a_10328_1044# VSS.t314 sg13_lv_nmos ad=0.2516p pd=2.16u as=0.1406p ps=1.12u w=0.74u l=0.13u
X877 VDD.t38 a_5974_5723# a_5974_5723# VDD.t10 sg13_lv_pmos ad=0.2448p pd=2.08u as=0.2826p ps=2.29u w=0.36u l=2u
X878 VDD.t131 a_25717_1842# a_26185_1044# VDD.t0 sg13_lv_pmos ad=0.252p pd=1.57u as=0.3808p ps=2.92u w=1.12u l=0.13u
X879 a_6854_5454# a_6854_5454# a_9444_4590# VSS.t225 sg13_lv_nmos ad=0.38p pd=2.38u as=0.68p ps=4.68u w=2u l=1u
X880 VDD.t146 a_13883_1842# a_14317_1842# VDD.t7 sg13_lv_pmos ad=0.2128p pd=1.5u as=0.3808p ps=2.92u w=1.12u l=0.13u
X881 VDD.t87 a_4437_1842# a_4905_1044# VDD.t0 sg13_lv_pmos ad=0.252p pd=1.57u as=0.3808p ps=2.92u w=1.12u l=0.13u
X882 a_4157_1313# REF_CLK VSS.t508 VSS.t507 sg13_lv_nmos ad=0.2516p pd=2.16u as=0.2553p ps=2.17u w=0.74u l=0.13u
X883 a_7390_1044# a_3171_1047.t8 a_8808_1044# VSS.t244 sg13_lv_nmos ad=0.2516p pd=2.16u as=0.1406p ps=1.12u w=0.74u l=0.13u
X884 a_22873_1842# a_22677_1842# VSS.t26 VSS.t25 sg13_lv_nmos ad=0.2516p pd=2.16u as=0.1406p ps=1.12u w=0.74u l=0.13u
X885 a_9444_4590# a_9444_4590# VSS.t524 VSS.t522 sg13_lv_nmos ad=0.38p pd=2.38u as=0.68p ps=4.68u w=2u l=1u
X886 VDD.t156 a_3171_1047.t8 a_8884_1008# VDD.t0 sg13_lv_pmos ad=0.3808p pd=2.92u as=0.3808p ps=2.92u w=1.12u l=0.13u
C0 VDD a_24665_1044# 0.29722f
C1 a_7390_1044# a_8745_519# 0.01756f
C2 a_6913_1842# a_7477_1842# 0.0114f
C3 VDD a_1721_1395# 0.4533f
C4 a_2019_311# a_15765_463# 0.05969f
C5 a_21917_1842# a_22564_1008# 0.02011f
C6 a_1256_1044# a_2297_1395# 0.04619f
C7 a_22677_1842# a_22873_1842# 0.73897f
C8 a_5523_1842# VDD 0.49671f
C9 a_4763_1842# DELAY_VBIASN 0.07254f
C10 a_15688_5867# a_15304_4605# 0.19136f
C11 a_8997_1842# a_9465_1044# 0.2079f
C12 a_21911_1008# a_19550_1044# 0.26208f
C13 a_13121_5831# a_14009_5878# 0.01604f
C14 a_13306_6305# a_13566_5835# 0.75507f
C15 a_12849_5867# a_13592_5871# 0.38817f
C16 a_11603_1842# a_11711_1842# 0.01163f
C17 a_6326_4590# a_6854_5986# 1.31745f
C18 a_18877_1842# a_19073_1842# 0.76914f
C19 VDD a_12505_1044# 0.29722f
C20 a_5957_1842# a_6717_1842# 0.02912f
C21 a_19203_1842# a_19311_2470# 0.01697f
C22 a_19550_1044# a_20315_1044# 0.39037f
C23 a_2019_311# a_5731_289# 1.15781f
C24 a_14111_5227# a_14851_5182# 0.26905f
C25 REF_CLK MUX_SEL4 0.0663f
C26 a_15765_463# MUX_SEL4 0.65508f
C27 a_21353_1842# a_21483_1842# 0.70845f
C28 a_14111_5878# a_14851_6228# 0.26905f
C29 a_20905_519# a_19550_1044# 0.02165f
C30 a_12656_5864# a_12849_5867# 0.33075f
C31 a_12355_5867# a_13306_6305# 0.26489f
C32 a_13019_5831# a_13121_5831# 0.56469f
C33 a_25913_1842# DELAY_VBIASN 0.10734f
C34 a_25717_1842# DELAY_VBIASP 0.04176f
C35 a_20723_1842# a_20397_1842# 0.01427f
C36 a_17553_1842# a_17683_1842# 0.70845f
C37 a_14111_5227# a_12849_5867# 0.42064f
C38 a_16108_289# a_23945_519# 0.2906f
C39 a_6425_1044# a_4350_1044# 0.03208f
C40 VDD a_10191_2470# 0.01806f
C41 a_15077_1842# a_15273_1842# 0.77122f
C42 a_17683_1842# a_17791_2470# 0.01697f
C43 DELAY_VBIASP a_26803_1842# 0.06661f
C44 DELAY_VBIASN a_27997_1842# 0.04657f
C45 a_2019_311# a_16108_289# 0.33889f
C46 a_8563_1842# a_8671_1842# 0.01163f
C47 a_2297_331# a_2019_311# 0.04011f
C48 a_11924_1008# VDD 0.28225f
C49 VDD a_26471_1008# 0.28336f
C50 a_26185_1044# a_26471_1008# 0.01885f
C51 DLL_RESETN DELAY_VBIASN 0.12907f
C52 a_5731_289# MUX_SEL4 4.60702f
C53 REF_CLK a_4157_1313# 0.50643f
C54 a_23003_1842# DELAY_VBIASP 0.06661f
C55 a_24197_1842# DELAY_VBIASN 0.09851f
C56 a_2019_311# a_16510_1044# 0.03139f
C57 a_7390_1044# a_9323_1842# 0.01012f
C58 DELAY_VBIASN a_20397_1842# 0.10669f
C59 DELAY_VBIASP a_19203_1842# 0.06661f
C60 a_16923_1842# a_16510_1044# 0.01012f
C61 a_13753_1842# a_13883_1842# 0.70845f
C62 a_16163_1842# a_16271_2470# 0.01697f
C63 VDD a_4111_2470# 0.01866f
C64 a_7043_1842# a_7151_1842# 0.01163f
C65 a_1256_289# a_1721_331# 0.13421f
C66 a_16510_1044# a_17928_1044# 0.38994f
C67 a_13592_5423# a_14851_5182# 0.01529f
C68 a_9675_1044# VDD 0.15406f
C69 a_12715_1044# a_12505_1044# 0.09424f
C70 VDD a_24008_1044# 0.17499f
C71 a_16108_289# MUX_SEL4 0.1283f
C72 a_6326_4590# a_9712_3912# 0.04737f
C73 a_15964_289# VDD 0.31312f
C74 a_2297_331# MUX_SEL4 0.04338f
C75 a_3449_331# MUX_SEL2 0.10741f
C76 a_2873_331# MUX_SEL3 0.12606f
C77 a_13132_5420# VDD 0.23863f
C78 a_24393_1842# VDD 0.49285f
C79 a_11748_6109# a_11491_6228# 0.34468f
C80 a_21483_1842# DELAY_VBIASN 0.08024f
C81 a_21353_1842# DELAY_VBIASP 0.11284f
C82 a_13566_5835# REF_CLK 0.01538f
C83 a_9772_5843# VDD 0.24701f
C84 VDD a_20593_1842# 0.49417f
C85 DELAY_VBIASN a_17683_1842# 0.07847f
C86 DELAY_VBIASP a_17553_1842# 0.11284f
C87 a_15077_1842# DELAY_VBIASP 0.04184f
C88 a_15273_1842# DELAY_VBIASN 0.10803f
C89 a_13592_5423# a_12849_5867# 0.38497f
C90 VDD a_26911_2470# 0.01806f
C91 a_12797_1842# a_13123_1842# 0.01427f
C92 a_15077_1842# a_13470_1044# 0.05231f
C93 a_14317_1842# a_14311_1008# 0.02349f
C94 a_15304_4605# a_14851_5182# 0.05156f
C95 a_6711_1008# VDD 0.2822f
C96 VDD a_21044_1008# 0.28225f
C97 a_8745_519# VDD 0.29292f
C98 a_22677_1842# VDD 0.86707f
C99 a_20723_1842# DELAY_VBIASP 0.06661f
C100 a_12355_5867# REF_CLK 1.0042f
C101 a_12656_5864# DLL_RESETN 0.11782f
C102 a_6326_4590# VDD 7.53039f
C103 VDD a_18877_1842# 0.87825f
C104 DELAY_VBIASN a_16033_1842# 0.10793f
C105 a_12363_1842# DELAY_VBIASP 0.06627f
C106 a_13557_1842# DELAY_VBIASN 0.08375f
C107 a_26477_1842# a_27124_1008# 0.02312f
C108 a_14851_6228# a_13592_5871# 0.01529f
C109 a_15304_4605# a_12849_5867# 0.0606f
C110 a_4437_1842# a_4633_1842# 0.73897f
C111 VDD a_19550_1044# 0.89766f
C112 VDD a_20831_2470# 0.01806f
C113 a_12037_1842# a_12233_1842# 0.77122f
C114 a_10232_5871# a_11491_6228# 0.01529f
C115 a_12797_1842# a_13444_1008# 0.02011f
C116 a_13470_1044# a_15755_1044# 0.39036f
C117 a_9757_1842# MUX_SEL4 0.01829f
C118 a_8155_1044# a_7945_1044# 0.09424f
C119 a_4437_1842# DELAY_VBIASP 0.0414f
C120 a_4633_1842# DELAY_VBIASN 0.0961f
C121 a_16851_309# VDD 0.51536f
C122 a_2873_331# VDD 0.46491f
C123 a_4763_1842# a_4871_1842# 0.01163f
C124 a_10430_1044# a_11271_1008# 0.28268f
C125 a_25528_1044# a_25630_1044# 0.37183f
C126 a_10751_5878# DLL_RESETN 0.45018f
C127 a_20397_1842# a_20391_1008# 0.02349f
C128 DELAY_VBIASN DELAY_VBIASP 8.74838f
C129 a_18585_1044# a_18117_1842# 0.2079f
C130 VDD a_16163_1842# 0.4973f
C131 DELAY_VBIASN a_15403_1842# 0.08418f
C132 MUX_SEL1 a_3449_1395# 0.29404f
C133 a_13753_1842# VDD 0.49349f
C134 a_10843_1842# DELAY_VBIASN 0.07254f
C135 a_10713_1842# DELAY_VBIASP 0.11222f
C136 a_25717_1842# a_25630_1044# 0.1088f
C137 a_14111_5878# a_13121_5831# 0.0235f
C138 VDD a_16484_1008# 0.28597f
C139 a_18585_1044# a_18795_1044# 0.09424f
C140 DELAY_VBIASN a_13470_1044# 0.02115f
C141 a_10713_1842# a_10843_1842# 0.70845f
C142 a_25717_1842# a_25283_1842# 0.69698f
C143 a_9193_1842# DELAY_VBIASN 0.0961f
C144 a_8997_1842# DELAY_VBIASP 0.04141f
C145 a_4437_1842# a_4350_1044# 0.1088f
C146 a_9675_1044# a_9751_1008# 0.01194f
C147 a_10232_5871# a_10649_5878# 0.37583f
C148 a_26477_1842# a_26673_1842# 0.76914f
C149 a_24008_1044# a_24084_1008# 0.01176f
C150 DELAY_VBIASN a_4350_1044# 0.02115f
C151 a_8997_1842# a_9193_1842# 0.77122f
C152 VDD MUX_SEL1 0.50267f
C153 a_4350_1044# a_4905_1044# 0.03209f
C154 a_4324_1008# a_4157_1313# 0.02463f
C155 MUX_SEL4 a_1256_1044# 0.04908f
C156 a_12037_1842# VDD 0.85848f
C157 a_10083_1842# DELAY_VBIASP 0.06627f
C158 VDD a_14235_1044# 0.15389f
C159 a_13306_5105# REF_CLK 0.06166f
C160 a_10206_5835# DLL_RESETN 0.27343f
C161 a_20723_1842# a_20831_1842# 0.01163f
C162 a_9323_1842# VDD 0.4973f
C163 a_24393_1842# a_24957_1842# 0.0114f
C164 a_7477_1842# DELAY_VBIASN 0.08375f
C165 a_6283_1842# DELAY_VBIASP 0.06627f
C166 a_20593_1842# a_21157_1842# 0.0114f
C167 a_9772_5843# a_9946_6305# 0.27179f
C168 a_8155_1044# a_8231_1008# 0.01194f
C169 a_7390_1044# a_8884_1008# 0.28279f
C170 a_26477_1842# a_26043_1842# 0.6972f
C171 a_22590_1044# a_22564_1008# 0.277f
C172 a_26985_519# a_25630_1044# 0.02195f
C173 VDD a_5115_1044# 0.15389f
C174 a_7673_1842# a_7803_1842# 0.70845f
C175 a_15304_4605# DLL_RESETN 0.03137f
C176 a_14025_1044# a_14235_1044# 0.09424f
C177 a_13019_5831# DELAY_OUT_LAST 0.08017f
C178 a_21157_1842# a_21044_1008# 0.02055f
C179 a_6854_5986# REF_CLK 0.05061f
C180 a_6126_3816# DLL_RESETN 0.06398f
C181 a_23437_1842# a_24197_1842# 0.03319f
C182 a_10517_1842# a_10985_1044# 0.19203f
C183 a_7673_1842# VDD 0.49294f
C184 a_6283_1842# a_4350_1044# 0.01012f
C185 a_15108_5325# VDD 0.13728f
C186 a_19637_1842# a_20397_1842# 0.01669f
C187 VDD a_23145_1044# 0.30409f
C188 a_21157_1842# a_19550_1044# 0.05231f
C189 a_7390_1044# a_5731_289# 0.41331f
C190 a_6717_1842# a_7043_1842# 0.01427f
C191 VDD a_1544_1044# 0.45079f
C192 a_26151_2470# a_26043_1842# 0.01697f
C193 a_13306_6305# VDD 0.77573f
C194 a_14851_6228# a_15304_4605# 0.12139f
C195 a_5957_1842# VDD 0.85848f
C196 a_22677_1842# a_22243_1842# 0.69698f
C197 a_21835_1044# a_19550_1044# 0.39036f
C198 a_13121_5831# a_13592_5871# 0.01445f
C199 a_12849_5867# a_13566_5835# 0.27346f
C200 a_18877_1842# a_18443_1842# 0.6972f
C201 a_6326_4590# a_5974_5723# 0.33136f
C202 VDD a_10985_1044# 0.30409f
C203 a_18877_1842# a_19524_1008# 0.02011f
C204 a_5957_1842# a_6153_1842# 0.77122f
C205 a_19550_1044# a_19524_1008# 0.277f
C206 a_5705_519# a_5731_289# 0.28954f
C207 DELAY_VBIASN a_25630_1044# 0.02756f
C208 a_14825_519# MUX_SEL4 0.03307f
C209 a_10430_1044# a_10843_1842# 0.01012f
C210 a_14111_5878# a_15108_6109# 0.03093f
C211 a_21353_1842# a_21917_1842# 0.0114f
C212 a_12797_1842# DLL_RESETN 0.0106f
C213 a_12355_5867# a_12849_5867# 0.07687f
C214 a_14009_5084# DELAY_OUT_LAST 0.25594f
C215 a_25283_1842# DELAY_VBIASN 0.08024f
C216 a_25153_1842# DELAY_VBIASP 0.11284f
C217 a_10328_1044# a_9757_1842# 0.10864f
C218 a_17553_1842# a_18117_1842# 0.0114f
C219 a_20105_1044# a_20391_1008# 0.01885f
C220 a_16108_289# a_20905_519# 0.2906f
C221 a_5864_3367# DLL_RESETN 0.1727f
C222 a_9712_3912# REF_CLK 0.06514f
C223 a_18117_1842# a_18004_1008# 0.02055f
C224 a_15077_1842# a_14643_1842# 0.6972f
C225 VDD a_9431_2470# 0.01806f
C226 DELAY_VBIASP a_27237_1842# 0.06225f
C227 DELAY_VBIASN a_27433_1842# 0.10734f
C228 a_1721_331# a_2019_311# 0.18452f
C229 a_14009_5084# a_14757_5182# 0.01058f
C230 a_11848_1044# VDD 0.17499f
C231 VDD a_26395_1044# 0.15389f
C232 a_26185_1044# a_26395_1044# 0.09424f
C233 REF_CLK a_3449_1395# 0.01058f
C234 a_26477_1842# VDD 0.86909f
C235 a_12158_5867# a_12355_5867# 0.12454f
C236 a_23633_1842# DELAY_VBIASN 0.10349f
C237 a_23437_1842# DELAY_VBIASP 0.04176f
C238 DELAY_VBIASP a_19637_1842# 0.04176f
C239 a_6126_3816# DELAY_VBIASP 0.01821f
C240 DELAY_VBIASN a_19833_1842# 0.10734f
C241 a_7390_1044# a_9757_1842# 0.02479f
C242 a_16597_1842# a_17357_1842# 0.01669f
C243 VDD a_27563_1842# 0.49811f
C244 a_17357_1842# a_16510_1044# 0.08038f
C245 a_13753_1842# a_14317_1842# 0.0114f
C246 a_16510_1044# a_17351_1008# 0.28268f
C247 a_1256_289# a_1544_289# 1.25711f
C248 a_8884_1008# VDD 0.28225f
C249 VDD a_23431_1008# 0.28336f
C250 VDD REF_CLK 2.08015f
C251 a_5974_5723# a_5778_3367# 2.88221f
C252 a_15765_463# VDD 0.35368f
C253 a_1544_289# MUX_OUT 0.69943f
C254 a_2297_331# MUX_SEL3 0.01595f
C255 a_2873_331# MUX_SEL2 0.01422f
C256 a_1721_331# MUX_SEL4 0.05813f
C257 a_23763_1842# VDD 0.49671f
C258 a_12907_5420# VDD 0.07751f
C259 a_10751_5878# a_11491_6228# 0.26905f
C260 a_21917_1842# DELAY_VBIASN 0.10687f
C261 a_9746_5805# VDD 0.0918f
C262 VDD a_19963_1842# 0.4973f
C263 DELAY_VBIASP a_16923_1842# 0.06661f
C264 a_7364_1008# a_7477_1842# 0.05157f
C265 DELAY_VBIASN a_18117_1842# 0.09851f
C266 a_14513_1842# DELAY_VBIASP 0.12091f
C267 a_13306_5105# a_12849_5867# 0.10976f
C268 a_14643_1842# DELAY_VBIASN 0.08431f
C269 VDD a_26151_2470# 0.01806f
C270 a_12797_1842# a_13557_1842# 0.06198f
C271 a_15755_1044# a_15831_1008# 0.01194f
C272 a_26911_1842# a_26803_1842# 0.01163f
C273 a_6635_1044# VDD 0.15406f
C274 VDD a_20968_1044# 0.17499f
C275 a_21625_1044# a_21911_1008# 0.01885f
C276 a_6854_5454# a_9444_4590# 1.24134f
C277 a_5731_289# VDD 0.6143f
C278 a_2019_311# a_4350_1044# 0.02042f
C279 a_22113_1842# VDD 0.49426f
C280 a_15688_5867# VDD 0.30345f
C281 a_25630_1044# a_27915_1044# 0.39036f
C282 a_12355_5867# DLL_RESETN 0.04879f
C283 VDD a_18313_1842# 0.49285f
C284 a_20105_1044# a_19637_1842# 0.19203f
C285 a_15837_1842# VDD 0.87963f
C286 a_12797_1842# DELAY_VBIASP 0.0414f
C287 a_12993_1842# DELAY_VBIASN 0.0961f
C288 a_14111_5878# a_14009_5878# 0.47795f
C289 a_26477_1842# a_27048_1044# 0.10863f
C290 a_15304_4605# a_13121_5831# 0.40921f
C291 a_4437_1842# a_4003_1842# 0.69698f
C292 VDD a_19448_1044# 0.17274f
C293 VDD a_20071_2470# 0.01806f
C294 MUX_SEL4 a_13470_1044# 0.256f
C295 a_12037_1842# a_11603_1842# 0.6972f
C296 a_6854_5986# a_12849_5867# 0.06216f
C297 a_10649_5878# a_10751_5878# 0.47795f
C298 a_13470_1044# a_14964_1008# 0.28279f
C299 a_14235_1044# a_14311_1008# 0.01194f
C300 a_7390_1044# a_9465_1044# 0.03208f
C301 a_16108_289# VDD 1.22378f
C302 a_5864_3367# DELAY_VBIASP 0.03252f
C303 a_4003_1842# DELAY_VBIASN 0.06486f
C304 a_2297_331# VDD 0.46496f
C305 a_10430_1044# a_11195_1044# 0.39037f
C306 a_9757_1842# a_10517_1842# 0.06198f
C307 MUX_SEL4 a_4350_1044# 0.31434f
C308 DELAY_VBIASN DELAY_OUT_LAST 3.19293f
C309 VDD a_16597_1842# 0.86876f
C310 MUX_SEL0 a_3449_1395# 0.10753f
C311 a_13123_1842# VDD 0.49727f
C312 a_11277_1842# DELAY_VBIASN 0.09974f
C313 VDD a_16510_1044# 0.8795f
C314 a_10713_1842# a_11277_1842# 0.0114f
C315 a_12797_1842# a_13368_1044# 0.10864f
C316 a_25153_1842# a_25283_1842# 0.70845f
C317 a_8433_1842# DELAY_VBIASP 0.11222f
C318 a_8563_1842# DELAY_VBIASN 0.07254f
C319 a_5197_1842# VDD 0.86909f
C320 a_27237_1842# a_25630_1044# 0.05253f
C321 a_10206_5835# a_10649_5878# 0.02242f
C322 a_5115_1044# a_5191_1008# 0.01194f
C323 VDD MUX_SEL0 0.56365f
C324 a_10430_1044# a_11785_519# 0.02058f
C325 a_8997_1842# a_8563_1842# 0.6972f
C326 a_4350_1044# a_4157_1313# 0.04624f
C327 a_11473_1842# VDD 0.49417f
C328 VDD a_13444_1008# 0.28633f
C329 a_13566_5328# REF_CLK 0.01093f
C330 a_27671_2470# a_27563_1842# 0.01697f
C331 a_27237_1842# a_27433_1842# 0.77122f
C332 a_9757_1842# VDD 0.87771f
C333 a_6717_1842# DELAY_VBIASP 0.0414f
C334 a_6913_1842# DELAY_VBIASN 0.0961f
C335 a_7390_1044# a_8808_1044# 0.38994f
C336 a_25913_1842# a_26043_1842# 0.70845f
C337 a_22488_1044# a_22564_1008# 0.01176f
C338 VDD a_4324_1008# 0.28597f
C339 a_7673_1842# a_8237_1842# 0.0114f
C340 VDD a_2873_1395# 0.46517f
C341 a_12037_1842# a_12505_1044# 0.2079f
C342 a_23003_1842# a_22590_1044# 0.01012f
C343 a_15545_1044# a_13470_1044# 0.03208f
C344 a_13019_5831# DELAY_VBIASN 1.23663f
C345 a_6854_5986# DLL_RESETN 0.50331f
C346 a_23437_1842# a_23633_1842# 0.76914f
C347 a_7043_1842# VDD 0.49723f
C348 a_6717_1842# a_4350_1044# 0.02479f
C349 a_13592_5871# a_14009_5878# 0.37583f
C350 a_14111_5227# DELAY_OUT_LAST 0.02024f
C351 a_14851_5182# VDD 0.26676f
C352 a_19637_1842# a_19833_1842# 0.73897f
C353 VDD a_21625_1044# 0.29722f
C354 a_6717_1842# a_7477_1842# 0.06198f
C355 a_27991_1008# a_25630_1044# 0.26208f
C356 a_15964_289# a_16851_309# 0.16757f
C357 a_3449_331# REF_CLK 0.01017f
C358 VDD a_1256_1044# 0.475f
C359 a_21917_1842# a_22488_1044# 0.10864f
C360 a_24957_1842# a_16108_289# 0.0157f
C361 a_1544_1044# a_1721_1395# 0.38063f
C362 a_12849_5867# VDD 2.56972f
C363 a_11924_1008# a_12037_1842# 0.02055f
C364 a_15108_6109# a_15304_4605# 0.17528f
C365 a_22113_1842# a_22243_1842# 0.70845f
C366 a_5393_1842# VDD 0.49417f
C367 a_21044_1008# a_19550_1044# 0.28279f
C368 a_13121_5831# a_13566_5835# 0.01158f
C369 a_13019_5831# a_13592_5871# 0.04178f
C370 a_18313_1842# a_18443_1842# 0.70845f
C371 VDD a_9465_1044# 0.29722f
C372 a_5957_1842# a_5523_1842# 0.6972f
C373 a_19448_1044# a_19524_1008# 0.01176f
C374 a_12158_5867# VDD 0.37862f
C375 a_10430_1044# a_11277_1842# 0.08038f
C376 a_11785_519# MUX_SEL4 0.03255f
C377 a_4763_1842# VDD 0.4973f
C378 a_24523_1842# DELAY_VBIASP 0.06661f
C379 a_25717_1842# DELAY_VBIASN 0.09106f
C380 a_12355_5867# a_13121_5831# 0.05795f
C381 a_13592_5423# DELAY_OUT_LAST 0.08062f
C382 a_12656_5864# a_13019_5831# 0.04193f
C383 a_9751_1008# a_9757_1842# 0.02354f
C384 a_17357_1842# a_17683_1842# 0.01427f
C385 a_9712_3912# DLL_RESETN 0.43103f
C386 a_16108_289# a_17865_519# 0.29564f
C387 a_18443_1842# a_16510_1044# 0.01012f
C388 a_14513_1842# a_14643_1842# 0.70845f
C389 VDD a_8671_2470# 0.01806f
C390 DELAY_VBIASN a_26803_1842# 0.08024f
C391 DELAY_VBIASP a_26673_1842# 0.11284f
C392 a_1544_289# a_2019_311# 0.01747f
C393 a_13592_5423# a_14757_5182# 0.43239f
C394 a_11271_1008# VDD 0.28336f
C395 VDD a_25604_1008# 0.28633f
C396 a_27705_1044# a_25630_1044# 0.03208f
C397 DELAY_VBIASN a_22590_1044# 0.02115f
C398 a_17865_519# a_16510_1044# 0.02165f
C399 a_25913_1842# VDD 0.49294f
C400 a_23003_1842# DELAY_VBIASN 0.08024f
C401 a_22873_1842# DELAY_VBIASP 0.11284f
C402 a_15304_4605# DELAY_OUT_LAST 0.05582f
C403 a_8884_1008# a_8237_1842# 0.02312f
C404 DELAY_VBIASN a_19203_1842# 0.07852f
C405 a_6854_5986# DELAY_VBIASP 0.01478f
C406 DELAY_VBIASP a_19073_1842# 0.11286f
C407 a_16597_1842# a_16793_1842# 0.73897f
C408 DELAY_VBIASP a_26043_1842# 0.06661f
C409 VDD a_27997_1842# 0.76025f
C410 a_16510_1044# a_17275_1044# 0.39037f
C411 a_15304_4605# a_14757_5182# 0.02225f
C412 a_8808_1044# VDD 0.17499f
C413 VDD a_23355_1044# 0.15389f
C414 VDD DLL_RESETN 2.47079f
C415 a_6326_4590# a_5778_3367# 0.8779f
C416 a_14825_519# VDD 0.29292f
C417 a_1256_289# MUX_OUT 0.1134f
C418 a_1544_289# MUX_SEL4 0.47529f
C419 a_2297_331# MUX_SEL2 0.10655f
C420 a_24197_1842# VDD 0.85848f
C421 a_12907_5186# VDD 0.06323f
C422 a_21353_1842# DELAY_VBIASN 0.10734f
C423 a_10751_5878# a_11748_6109# 0.03061f
C424 a_25283_1842# a_25391_1842# 0.01163f
C425 a_9547_6172# VDD 0.08695f
C426 VDD a_20397_1842# 0.86909f
C427 a_21625_1044# a_21157_1842# 0.2079f
C428 a_7390_1044# a_7477_1842# 0.1088f
C429 DELAY_VBIASN a_17553_1842# 0.10734f
C430 DELAY_VBIASP a_17357_1842# 0.04176f
C431 a_13883_1842# DELAY_VBIASP 0.06627f
C432 a_15077_1842# DELAY_VBIASN 0.10039f
C433 a_13566_5328# a_12849_5867# 0.26617f
C434 VDD a_25391_2470# 0.01806f
C435 a_12797_1842# a_12993_1842# 0.76914f
C436 a_13883_1842# a_13470_1044# 0.01012f
C437 a_14009_5084# a_14111_5227# 0.47622f
C438 a_5844_1008# VDD 0.28225f
C439 a_9751_1008# a_9465_1044# 0.01885f
C440 a_21625_1044# a_21835_1044# 0.09424f
C441 a_6126_3816# a_9444_4590# 0.03029f
C442 a_5705_519# a_4350_1044# 0.02005f
C443 a_4763_1842# a_4871_2470# 0.01697f
C444 a_11848_1044# a_11924_1008# 0.01176f
C445 a_14851_6228# VDD 0.25326f
C446 a_20723_1842# DELAY_VBIASN 0.07937f
C447 a_21483_1842# VDD 0.4973f
C448 a_22677_1842# a_23145_1044# 0.19203f
C449 a_25630_1044# a_27124_1008# 0.28279f
C450 a_26395_1044# a_26471_1008# 0.01194f
C451 a_23763_1842# a_23871_1842# 0.01163f
C452 MUX_SEL0 MUX_SEL2 0.01204f
C453 VDD a_17683_1842# 0.49671f
C454 a_15273_1842# VDD 0.49298f
C455 a_12363_1842# DELAY_VBIASN 0.07254f
C456 a_12233_1842# DELAY_VBIASP 0.11222f
C457 a_13880_6292# a_14009_5878# 0.01562f
C458 a_15304_4605# a_13019_5831# 0.07025f
C459 a_14111_5878# a_13592_5871# 0.34102f
C460 a_26477_1842# a_26471_1008# 0.02349f
C461 VDD a_18871_1008# 0.2822f
C462 a_20105_1044# a_20315_1044# 0.09424f
C463 VDD a_19311_2470# 0.01806f
C464 a_11473_1842# a_11603_1842# 0.70845f
C465 a_6854_5986# a_13121_5831# 0.10056f
C466 a_10232_5871# a_10751_5878# 0.34102f
C467 a_10649_5878# a_10520_6292# 0.01562f
C468 a_13470_1044# a_14888_1044# 0.38994f
C469 a_10517_1842# DELAY_VBIASP 0.0414f
C470 a_7390_1044# a_7945_1044# 0.03209f
C471 a_5197_1842# a_5191_1008# 0.02349f
C472 a_9712_3912# DELAY_VBIASP 0.14197f
C473 a_4437_1842# DELAY_VBIASN 0.08375f
C474 a_19203_1842# a_19311_1842# 0.01163f
C475 a_1721_331# VDD 0.45259f
C476 a_4437_1842# a_4905_1044# 0.19203f
C477 a_10430_1044# a_10404_1008# 0.277f
C478 a_9757_1842# a_9953_1842# 0.76914f
C479 a_22243_1842# a_22351_1842# 0.01163f
C480 VDD a_16033_1842# 0.49413f
C481 a_13557_1842# VDD 0.86707f
C482 a_10713_1842# DELAY_VBIASN 0.0961f
C483 a_24957_1842# a_25604_1008# 0.02011f
C484 a_12943_5867# a_12849_5867# 0.16706f
C485 a_15464_3684# a_9712_3912# 0.01237f
C486 VDD a_16408_1044# 0.17274f
C487 a_13592_5423# a_14009_5084# 0.3749f
C488 a_25153_1842# a_25717_1842# 0.0114f
C489 a_8997_1842# DELAY_VBIASN 0.09156f
C490 a_7803_1842# DELAY_VBIASP 0.06627f
C491 a_4633_1842# VDD 0.49285f
C492 a_17683_1842# a_17791_1842# 0.01163f
C493 a_10206_5835# a_10232_5871# 0.36952f
C494 a_22590_1044# a_24951_1008# 0.26208f
C495 a_8433_1842# a_8563_1842# 0.70845f
C496 VDD DELAY_VBIASP 14.6649f
C497 VDD a_15403_1842# 0.4973f
C498 a_5197_1842# a_5523_1842# 0.01427f
C499 a_4248_1044# a_4157_1313# 0.11672f
C500 MUX_SEL0 a_1721_1395# 0.01315f
C501 MUX_SEL1 a_1544_1044# 0.1672f
C502 a_13557_1842# a_14025_1044# 0.19203f
C503 a_10083_1842# DELAY_VBIASN 0.07254f
C504 a_10843_1842# VDD 0.4973f
C505 a_15765_463# a_15964_289# 0.061f
C506 a_13883_1842# a_13991_2470# 0.01697f
C507 a_24197_1842# a_24084_1008# 0.02055f
C508 a_9444_4590# a_5864_3367# 0.06832f
C509 VDD a_13470_1044# 0.87936f
C510 a_15545_1044# a_15831_1008# 0.01885f
C511 a_13132_5420# REF_CLK 0.02025f
C512 a_27237_1842# a_26803_1842# 0.6972f
C513 a_9946_6305# DLL_RESETN 0.09997f
C514 a_12907_5420# a_13132_5420# 0.02416f
C515 a_24197_1842# a_24957_1842# 0.02912f
C516 a_9193_1842# VDD 0.49285f
C517 a_6153_1842# DELAY_VBIASP 0.11222f
C518 a_6283_1842# DELAY_VBIASN 0.07254f
C519 a_15464_3684# VDD 0.52511f
C520 a_26043_1842# a_25630_1044# 0.01012f
C521 a_16163_1842# a_16271_1842# 0.01163f
C522 a_20397_1842# a_21157_1842# 0.03319f
C523 a_24523_1842# a_24631_2470# 0.01697f
C524 a_9746_5805# a_9772_5843# 0.1657f
C525 a_7390_1044# a_8231_1008# 0.28268f
C526 a_22488_1044# a_22590_1044# 0.37183f
C527 VDD a_4350_1044# 0.87635f
C528 a_5731_289# a_15964_289# 0.2778f
C529 a_12363_1842# a_12471_2470# 0.01697f
C530 VDD a_13368_1044# 0.17274f
C531 a_23437_1842# a_22590_1044# 0.08038f
C532 a_14851_5182# a_15688_5403# 0.08776f
C533 a_14025_1044# a_13470_1044# 0.03209f
C534 a_5974_5723# DLL_RESETN 0.02002f
C535 a_23437_1842# a_23003_1842# 0.6972f
C536 a_7477_1842# VDD 0.86707f
C537 a_13566_5835# a_14009_5878# 0.02242f
C538 a_15837_1842# a_15964_289# 0.02f
C539 a_19637_1842# a_19203_1842# 0.69698f
C540 a_23003_1842# a_23111_2470# 0.01697f
C541 a_6635_1044# a_6711_1008# 0.01194f
C542 a_6126_3816# a_6854_5454# 0.22705f
C543 a_23945_519# a_22590_1044# 0.02165f
C544 a_20968_1044# a_21044_1008# 0.01176f
C545 VDD a_20105_1044# 0.30409f
C546 a_19963_1842# a_19550_1044# 0.01012f
C547 a_6717_1842# a_6913_1842# 0.76914f
C548 a_15964_289# a_16108_289# 0.42202f
C549 a_5731_289# a_8745_519# 0.28635f
C550 a_10843_1842# a_10951_2470# 0.01697f
C551 a_21917_1842# a_21911_1008# 0.02354f
C552 a_12943_5867# DLL_RESETN 0.03616f
C553 a_1256_1044# a_1721_1395# 0.13421f
C554 a_13121_5831# VDD 0.99724f
C555 a_10430_1044# a_12363_1842# 0.01012f
C556 a_14111_5878# a_15304_4605# 0.01811f
C557 a_22113_1842# a_22677_1842# 0.0114f
C558 a_9323_1842# a_9431_2470# 0.01697f
C559 a_20968_1044# a_19550_1044# 0.38994f
C560 a_15964_289# a_16510_1044# 0.05416f
C561 a_18313_1842# a_18877_1842# 0.0114f
C562 a_21483_1842# a_21591_2470# 0.01697f
C563 VDD a_7945_1044# 0.30409f
C564 a_18877_1842# a_19448_1044# 0.10864f
C565 VDD a_13991_2470# 0.01806f
C566 a_5393_1842# a_5523_1842# 0.70845f
C567 a_19448_1044# a_19550_1044# 0.37183f
C568 a_11491_6228# VDD 0.16753f
C569 a_10430_1044# DELAY_VBIASN 0.02115f
C570 REF_CLK MUX_SEL1 0.01858f
C571 a_16108_289# a_18877_1842# 0.0157f
C572 a_13880_6292# a_14111_5878# 0.12701f
C573 a_7803_1842# a_7911_2470# 0.01697f
C574 a_4003_1842# a_4111_1842# 0.01163f
C575 a_16108_289# a_19550_1044# 0.58202f
C576 a_12355_5867# a_13019_5831# 0.3846f
C577 a_24957_1842# DELAY_VBIASP 0.04176f
C578 a_25153_1842# DELAY_VBIASN 0.10332f
C579 DELAY_VBIASP a_21157_1842# 0.04177f
C580 a_17357_1842# a_18117_1842# 0.03319f
C581 a_15837_1842# a_16163_1842# 0.01427f
C582 a_16108_289# a_16851_309# 0.06181f
C583 a_9444_3912# DLL_RESETN 0.03031f
C584 a_18877_1842# a_16510_1044# 0.02479f
C585 a_14513_1842# a_15077_1842# 0.0114f
C586 VDD a_7911_2470# 0.01806f
C587 DELAY_VBIASN a_27237_1842# 0.10152f
C588 a_15837_1842# a_16484_1008# 0.02011f
C589 a_17928_1044# a_18004_1008# 0.01176f
C590 a_1256_289# a_2019_311# 0.02904f
C591 a_14009_5084# a_13880_5118# 0.01562f
C592 a_11195_1044# VDD 0.15389f
C593 a_26185_1044# a_25630_1044# 0.03209f
C594 VDD a_25630_1044# 0.89531f
C595 a_6854_5454# a_5864_3367# 0.03661f
C596 a_2019_311# MUX_OUT 8.45486f
C597 a_6283_1842# a_6391_2470# 0.01697f
C598 a_16851_309# a_16510_1044# 0.02131f
C599 a_25283_1842# VDD 0.49737f
C600 a_22243_1842# DELAY_VBIASP 0.06661f
C601 a_15304_4605# DELAY_VBIASN 0.07802f
C602 a_23437_1842# DELAY_VBIASN 0.10669f
C603 a_10649_5878# VDD 0.23431f
C604 a_8808_1044# a_8237_1842# 0.10863f
C605 DELAY_VBIASP a_18443_1842# 0.06661f
C606 a_6854_5986# DELAY_OUT_LAST 0.08491f
C607 DELAY_VBIASN a_19637_1842# 0.0907f
C608 a_16597_1842# a_16163_1842# 0.69698f
C609 VDD a_27433_1842# 0.49285f
C610 a_16597_1842# a_16484_1008# 0.05157f
C611 a_13557_1842# a_14317_1842# 0.01669f
C612 a_15077_1842# a_14964_1008# 0.02055f
C613 a_16510_1044# a_16484_1008# 0.277f
C614 a_8231_1008# VDD 0.28336f
C615 a_23145_1044# a_23431_1008# 0.01885f
C616 VDD a_22564_1008# 0.28633f
C617 a_11785_519# VDD 0.29292f
C618 a_1721_331# MUX_SEL2 0.01315f
C619 a_1256_289# MUX_SEL4 0.65005f
C620 a_1544_289# MUX_SEL3 0.15976f
C621 a_23633_1842# VDD 0.49417f
C622 a_13106_5357# VDD 0.09228f
C623 a_24197_1842# a_24665_1044# 0.2079f
C624 a_13306_6305# REF_CLK 0.05059f
C625 MUX_SEL4 MUX_OUT 0.91933f
C626 a_9547_5942# VDD 0.1511f
C627 VDD a_19833_1842# 0.49294f
C628 DELAY_VBIASP a_16793_1842# 0.11284f
C629 DELAY_VBIASN a_16923_1842# 0.08024f
C630 a_14317_1842# DELAY_VBIASP 0.04316f
C631 a_14513_1842# DELAY_VBIASN 0.102f
C632 a_13132_5420# a_12849_5867# 0.06758f
C633 VDD a_24631_2470# 0.01806f
C634 a_15403_1842# a_15511_2470# 0.01697f
C635 a_12797_1842# a_12363_1842# 0.6972f
C636 a_14317_1842# a_13470_1044# 0.08038f
C637 a_13592_5423# a_14111_5227# 0.34114f
C638 a_5768_1044# VDD 0.17499f
C639 a_9675_1044# a_9465_1044# 0.09424f
C640 a_6854_5986# a_9444_4590# 0.05054f
C641 a_21917_1842# VDD 0.87825f
C642 a_15108_6109# VDD 0.1349f
C643 a_25630_1044# a_27048_1044# 0.38994f
C644 MUX_SEL0 MUX_SEL1 3.14917f
C645 VDD a_18117_1842# 0.85848f
C646 a_14643_1842# VDD 0.49675f
C647 a_11603_1842# DELAY_VBIASP 0.06627f
C648 a_12797_1842# DELAY_VBIASN 0.09992f
C649 a_13880_6292# a_13592_5871# 0.43707f
C650 VDD a_18795_1044# 0.15406f
C651 a_21625_1044# a_19550_1044# 0.03208f
C652 VDD a_18551_2470# 0.01806f
C653 a_11473_1842# a_12037_1842# 0.0114f
C654 a_10232_5871# a_10520_6292# 0.43707f
C655 a_15304_4605# a_14111_5227# 0.01761f
C656 a_13470_1044# a_14311_1008# 0.28268f
C657 a_9953_1842# DELAY_VBIASP 0.11222f
C658 a_10517_1842# a_11277_1842# 0.01669f
C659 a_4437_1842# a_4157_1313# 0.01771f
C660 a_1544_289# VDD 0.39113f
C661 a_10328_1044# a_10404_1008# 0.01176f
C662 a_9757_1842# a_9323_1842# 0.6972f
C663 DELAY_VBIASN a_4157_1313# 0.01202f
C664 MUX_SEL1 a_2873_1395# 0.13092f
C665 a_12993_1842# VDD 0.49426f
C666 a_15077_1842# a_15545_1044# 0.2079f
C667 a_12943_5867# a_13121_5831# 0.09118f
C668 VDD a_15831_1008# 0.2816f
C669 a_13306_5105# a_14009_5084# 0.02454f
C670 a_24957_1842# a_25283_1842# 0.01427f
C671 a_8237_1842# DELAY_VBIASP 0.0414f
C672 a_8433_1842# DELAY_VBIASN 0.0961f
C673 a_4003_1842# VDD 0.61559f
C674 a_9946_6305# a_10649_5878# 0.02432f
C675 a_22590_1044# a_24875_1044# 0.39036f
C676 a_4350_1044# a_5191_1008# 0.28268f
C677 a_8433_1842# a_8997_1842# 0.0114f
C678 VDD DELAY_OUT_LAST 0.70591f
C679 a_5197_1842# a_5957_1842# 0.03319f
C680 MUX_SEL1 a_1256_1044# 1.44243f
C681 MUX_SEL0 a_1544_1044# 0.07603f
C682 a_11277_1842# VDD 0.86909f
C683 a_24523_1842# a_22590_1044# 0.01012f
C684 a_15688_5403# a_15464_3684# 0.1999f
C685 a_9444_4590# a_9712_3912# 0.68929f
C686 a_15545_1044# a_15755_1044# 0.09424f
C687 a_13132_5420# DLL_RESETN 0.01689f
C688 a_26673_1842# a_26803_1842# 0.70845f
C689 a_9772_5843# DLL_RESETN 0.06592f
C690 a_24197_1842# a_24393_1842# 0.77122f
C691 a_15304_4605# a_13592_5423# 0.01817f
C692 a_8563_1842# VDD 0.49671f
C693 a_6717_1842# DELAY_VBIASN 0.09992f
C694 a_5523_1842# DELAY_VBIASP 0.06627f
C695 a_13883_1842# a_13991_1842# 0.01163f
C696 a_20397_1842# a_20593_1842# 0.76914f
C697 a_7390_1044# a_8155_1044# 0.39037f
C698 a_9712_3912# a_13019_5831# 0.03275f
C699 VDD a_4248_1044# 0.17587f
C700 a_7477_1842# a_8237_1842# 0.01669f
C701 a_27991_1008# a_27915_1044# 0.01194f
C702 a_5731_289# a_15765_463# 0.23301f
C703 a_14851_5182# a_15108_5325# 0.29858f
C704 a_14009_5878# VDD 0.23872f
C705 a_20397_1842# a_21044_1008# 0.02312f
C706 a_22873_1842# a_23003_1842# 0.70845f
C707 a_6913_1842# VDD 0.49426f
C708 a_13566_5835# a_13592_5871# 0.36952f
C709 a_9444_4590# VDD 0.01557f
C710 a_21917_1842# a_21157_1842# 0.02912f
C711 a_12363_1842# a_12471_1842# 0.01163f
C712 a_19073_1842# a_19203_1842# 0.70845f
C713 a_6854_5986# a_6854_5454# 0.30877f
C714 a_15688_5403# a_13121_5831# 0.01441f
C715 a_15108_5325# a_12849_5867# 0.10521f
C716 a_20397_1842# a_19550_1044# 0.08038f
C717 VDD a_18585_1044# 0.29722f
C718 a_6717_1842# a_6283_1842# 0.6972f
C719 a_19963_1842# a_20071_2470# 0.01697f
C720 a_15765_463# a_16108_289# 0.42004f
C721 a_14111_5227# a_13880_5118# 0.12701f
C722 a_1256_1044# a_1544_1044# 1.26509f
C723 a_10430_1044# MUX_SEL4 0.24983f
C724 a_13019_5831# VDD 0.41932f
C725 a_10430_1044# a_12797_1842# 0.02479f
C726 a_14851_6228# a_14757_6228# 0.28931f
C727 a_21917_1842# a_22243_1842# 0.01427f
C728 a_12849_5867# a_13306_6305# 0.12097f
C729 a_10404_1008# a_10517_1842# 0.05157f
C730 a_10843_1842# a_10951_1842# 0.01163f
C731 a_21483_1842# a_19550_1044# 0.01012f
C732 a_18877_1842# a_18871_1008# 0.02354f
C733 a_5393_1842# a_5957_1842# 0.0114f
C734 VDD a_13231_2470# 0.01806f
C735 a_18443_1842# a_18551_2470# 0.01697f
C736 a_5731_289# a_16108_289# 0.01334f
C737 a_9323_1842# a_9431_1842# 0.01163f
C738 a_11748_6109# VDD 0.16819f
C739 a_27705_1044# a_27915_1044# 0.09424f
C740 REF_CLK MUX_SEL0 0.14089f
C741 a_12355_5867# a_12656_5864# 0.03277f
C742 a_24523_1842# DELAY_VBIASN 0.08024f
C743 a_24393_1842# DELAY_VBIASP 0.11284f
C744 DELAY_VBIASP a_20593_1842# 0.11287f
C745 a_17357_1842# a_17553_1842# 0.76914f
C746 a_15837_1842# a_16597_1842# 0.06198f
C747 VDD a_6425_1044# 0.29722f
C748 a_5778_3367# DLL_RESETN 0.01215f
C749 a_17357_1842# a_18004_1008# 0.02312f
C750 VDD a_7151_2470# 0.01806f
C751 a_14317_1842# a_14643_1842# 0.01427f
C752 a_16923_1842# a_17031_2470# 0.01697f
C753 DELAY_VBIASN a_26673_1842# 0.105f
C754 a_7803_1842# a_7911_1842# 0.01163f
C755 a_13592_5423# a_13880_5118# 0.43707f
C756 a_10404_1008# VDD 0.28633f
C757 VDD a_25528_1044# 0.17274f
C758 a_7390_1044# DELAY_VBIASN 0.02115f
C759 a_6854_5454# a_9712_3912# 0.67835f
C760 a_6126_3816# a_5864_3367# 0.23738f
C761 a_2019_311# MUX_SEL4 0.90276f
C762 a_16108_289# a_16510_1044# 0.56108f
C763 a_25717_1842# VDD 0.86707f
C764 a_14009_5084# VDD 0.31815f
C765 a_25717_1842# a_26185_1044# 0.19203f
C766 a_22677_1842# DELAY_VBIASP 0.04176f
C767 a_22873_1842# DELAY_VBIASN 0.10734f
C768 a_10232_5871# VDD 0.07206f
C769 a_7390_1044# a_8997_1842# 0.05231f
C770 a_8231_1008# a_8237_1842# 0.02349f
C771 DELAY_VBIASP a_18877_1842# 0.04176f
C772 DELAY_VBIASN a_19073_1842# 0.10642f
C773 a_6854_5986# DELAY_VBIASN 0.15808f
C774 a_16033_1842# a_16163_1842# 0.70845f
C775 a_16597_1842# a_16510_1044# 0.1088f
C776 a_13557_1842# a_13753_1842# 0.73897f
C777 DELAY_VBIASN a_26043_1842# 0.08024f
C778 VDD a_26803_1842# 0.49671f
C779 a_27705_1044# a_27237_1842# 0.2079f
C780 a_14643_1842# a_14751_2470# 0.01697f
C781 a_6283_1842# a_6391_1842# 0.01163f
C782 a_16408_1044# a_16484_1008# 0.01176f
C783 a_8155_1044# VDD 0.15389f
C784 a_11271_1008# a_10985_1044# 0.01885f
C785 a_6711_1008# a_4350_1044# 0.26208f
C786 VDD a_22590_1044# 0.89557f
C787 a_23145_1044# a_23355_1044# 0.09424f
C788 a_1544_289# MUX_SEL2 0.07405f
C789 a_1256_289# MUX_SEL3 1.41161f
C790 a_2019_311# a_4157_1313# 0.01018f
C791 a_23003_1842# VDD 0.4973f
C792 a_10520_6292# a_10751_5878# 0.12701f
C793 a_12849_5867# REF_CLK 0.26382f
C794 MUX_SEL3 MUX_OUT 0.79533f
C795 VDD a_19203_1842# 0.49737f
C796 a_6854_5454# VDD 1.03678f
C797 a_7364_1008# a_6717_1842# 0.02011f
C798 DELAY_VBIASP a_16163_1842# 0.06661f
C799 DELAY_VBIASN a_17357_1842# 0.10669f
C800 a_12797_1842# MUX_SEL4 0.01829f
C801 a_13753_1842# DELAY_VBIASP 0.11222f
C802 a_13883_1842# DELAY_VBIASN 0.07254f
C803 VDD a_23871_2470# 0.01806f
C804 a_12233_1842# a_12363_1842# 0.70845f
C805 a_13306_5105# a_14111_5227# 0.097f
C806 a_26985_519# VDD 0.29292f
C807 a_10430_1044# a_12791_1008# 0.26208f
C808 a_21353_1842# VDD 0.49285f
C809 a_14111_5878# VDD 0.21331f
C810 a_25630_1044# a_26471_1008# 0.28268f
C811 a_12158_5867# REF_CLK 0.01309f
C812 VDD a_17553_1842# 0.49417f
C813 a_5844_1008# a_5957_1842# 0.02055f
C814 MUX_SEL4 a_4157_1313# 0.08229f
C815 a_15077_1842# VDD 0.85965f
C816 a_12233_1842# DELAY_VBIASN 0.0961f
C817 a_12037_1842# DELAY_VBIASP 0.04141f
C818 VDD a_18004_1008# 0.28225f
C819 VDD a_17791_2470# 0.01806f
C820 a_20105_1044# a_19550_1044# 0.03209f
C821 a_11277_1842# a_11603_1842# 0.01427f
C822 a_26151_1842# a_26043_1842# 0.01163f
C823 a_13470_1044# a_14235_1044# 0.39037f
C824 a_25913_1842# a_26477_1842# 0.0114f
C825 a_9323_1842# DELAY_VBIASP 0.06627f
C826 a_10517_1842# DELAY_VBIASN 0.08375f
C827 a_9712_3912# DELAY_VBIASN 0.22281f
C828 a_27237_1842# a_27124_1008# 0.02055f
C829 a_10517_1842# a_10713_1842# 0.73897f
C830 a_1256_289# VDD 0.40292f
C831 a_27991_1008# a_27705_1044# 0.01885f
C832 a_10328_1044# a_10430_1044# 0.37183f
C833 a_20723_1842# VDD 0.49671f
C834 a_24875_1044# a_24951_1008# 0.01194f
C835 VDD MUX_OUT 0.35871f
C836 a_9193_1842# a_9323_1842# 0.70845f
C837 MUX_SEL0 a_2873_1395# 0.01504f
C838 a_12363_1842# VDD 0.4973f
C839 a_20391_1008# a_20315_1044# 0.01194f
C840 a_24957_1842# a_25528_1044# 0.10864f
C841 a_12943_5867# a_13019_5831# 0.03346f
C842 VDD a_15755_1044# 0.15389f
C843 a_17065_1044# a_17351_1008# 0.01885f
C844 a_27997_1842# a_27563_1842# 0.69646f
C845 a_24957_1842# a_25717_1842# 0.06198f
C846 a_13306_5105# a_13592_5423# 0.41329f
C847 a_13566_5328# a_14009_5084# 0.02242f
C848 a_7673_1842# DELAY_VBIASP 0.11222f
C849 a_7803_1842# DELAY_VBIASN 0.07254f
C850 a_6717_1842# MUX_SEL4 0.0195f
C851 a_4437_1842# VDD 0.86998f
C852 a_15688_5403# DELAY_OUT_LAST 0.01699f
C853 a_10517_1842# a_10083_1842# 0.69698f
C854 a_9946_6305# a_10232_5871# 0.41329f
C855 a_8808_1044# a_8884_1008# 0.01176f
C856 a_22590_1044# a_24084_1008# 0.28279f
C857 a_23355_1044# a_23431_1008# 0.01194f
C858 a_4350_1044# a_5115_1044# 0.39037f
C859 VDD DELAY_VBIASN 1.49209f
C860 DLL_RESETN REF_CLK 10.7961f
C861 a_8237_1842# a_8563_1842# 0.01427f
C862 a_5197_1842# a_5393_1842# 0.76914f
C863 VDD a_4905_1044# 0.30126f
C864 MUX_SEL0 a_1256_1044# 0.3314f
C865 a_10713_1842# VDD 0.49294f
C866 a_24957_1842# a_22590_1044# 0.02479f
C867 a_9444_4590# a_9444_3912# 2.19249f
C868 a_15108_5325# a_15464_3684# 0.12158f
C869 a_12907_5420# DLL_RESETN 0.04234f
C870 a_26673_1842# a_27237_1842# 0.0114f
C871 a_24197_1842# a_23763_1842# 0.6972f
C872 a_8997_1842# VDD 0.85848f
C873 a_13106_5357# a_13132_5420# 0.1657f
C874 a_12907_5186# a_12907_5420# 0.1117f
C875 a_6153_1842# DELAY_VBIASN 0.0961f
C876 a_5957_1842# DELAY_VBIASP 0.04141f
C877 a_6854_5986# a_13592_5423# 0.01958f
C878 a_20397_1842# a_19963_1842# 0.6972f
C879 a_9547_5942# a_9772_5843# 0.02416f
C880 a_9547_6172# a_9746_5805# 0.02437f
C881 a_7390_1044# a_7364_1008# 0.277f
C882 a_7477_1842# a_7673_1842# 0.73897f
C883 a_5197_1842# a_4763_1842# 0.6972f
C884 VDD a_2297_1395# 0.46536f
C885 a_10083_1842# VDD 0.49727f
C886 a_5731_289# a_14825_519# 0.28056f
C887 a_22677_1842# a_22564_1008# 0.05157f
C888 a_1256_1044# a_2873_1395# 0.28892f
C889 a_13592_5871# VDD 0.07242f
C890 a_20397_1842# a_20968_1044# 0.10863f
C891 a_12791_1008# a_12797_1842# 0.02354f
C892 a_6283_1842# VDD 0.4973f
C893 a_5957_1842# a_4350_1044# 0.05231f
C894 a_22873_1842# a_23437_1842# 0.0114f
C895 a_6854_5986# a_15304_4605# 0.08165f
C896 a_21353_1842# a_21157_1842# 0.77122f
C897 a_19073_1842# a_19637_1842# 0.0114f
C898 a_6854_5986# a_6126_3816# 0.18536f
C899 a_5974_5723# a_6854_5454# 0.01757f
C900 a_15688_5403# a_13019_5831# 0.1287f
C901 a_14851_5182# a_12849_5867# 0.13376f
C902 a_15108_5325# a_13121_5831# 0.05903f
C903 VDD a_17065_1044# 0.30218f
C904 a_6153_1842# a_6283_1842# 0.70845f
C905 a_12656_5864# VDD 0.26066f
C906 a_11924_1008# a_11277_1842# 0.02312f
C907 a_14851_6228# a_15688_5867# 0.08776f
C908 a_21917_1842# a_22677_1842# 0.06198f
C909 a_14111_5227# VDD 0.33926f
C910 a_13019_5831# a_13045_6215# 0.01249f
C911 a_13121_5831# a_13306_6305# 0.01008f
C912 a_26477_1842# DELAY_VBIASP 0.04181f
C913 a_4003_1842# a_4111_2470# 0.01697f
C914 a_20723_1842# a_21157_1842# 0.6972f
C915 a_10430_1044# a_10517_1842# 0.1088f
C916 a_21917_1842# a_19550_1044# 0.02479f
C917 a_18117_1842# a_18877_1842# 0.02912f
C918 VDD a_20391_1008# 0.28336f
C919 a_15273_1842# a_15837_1842# 0.0114f
C920 VDD a_12471_2470# 0.01806f
C921 DELAY_VBIASP a_27563_1842# 0.06663f
C922 a_5705_519# a_2019_311# 0.13872f
C923 a_7390_1044# MUX_SEL4 0.34655f
C924 a_10751_5878# VDD 0.20377f
C925 VDD a_27915_1044# 0.15389f
C926 REF_CLK DELAY_VBIASP 2.13371f
C927 a_24957_1842# DELAY_VBIASN 0.10687f
C928 a_23763_1842# DELAY_VBIASP 0.06661f
C929 DELAY_VBIASN a_21157_1842# 0.09851f
C930 DELAY_VBIASP a_19963_1842# 0.06661f
C931 a_17357_1842# a_16923_1842# 0.6972f
C932 a_5844_1008# a_5197_1842# 0.02312f
C933 a_15837_1842# a_16033_1842# 0.76914f
C934 VDD a_6391_2470# 0.01806f
C935 a_17357_1842# a_17928_1044# 0.10863f
C936 a_14317_1842# a_15077_1842# 0.03319f
C937 a_15837_1842# a_16408_1044# 0.10864f
C938 a_16510_1044# a_18871_1008# 0.26208f
C939 a_13306_5105# a_13880_5118# 0.31978f
C940 a_10430_1044# VDD 0.88416f
C941 VDD a_24951_1008# 0.2822f
C942 a_6854_5454# a_9444_3912# 0.8486f
C943 a_5705_519# MUX_SEL4 0.03556f
C944 a_2019_311# MUX_SEL3 0.06209f
C945 a_13592_5423# VDD 0.11685f
C946 a_25153_1842# VDD 0.49426f
C947 a_11491_6228# a_11397_6228# 0.28931f
C948 a_22243_1842# DELAY_VBIASN 0.08024f
C949 a_22113_1842# DELAY_VBIASP 0.11286f
C950 a_5731_289# a_13470_1044# 0.41365f
C951 a_10206_5835# VDD 0.09392f
C952 DELAY_VBIASN a_18443_1842# 0.08024f
C953 DELAY_VBIASP a_18313_1842# 0.11284f
C954 a_16033_1842# a_16597_1842# 0.0114f
C955 a_15837_1842# DELAY_VBIASP 0.04182f
C956 a_15837_1842# a_15403_1842# 0.6972f
C957 VDD a_27237_1842# 0.85969f
C958 a_13557_1842# a_13123_1842# 0.69698f
C959 a_15837_1842# a_13470_1044# 0.02479f
C960 a_16408_1044# a_16510_1044# 0.37183f
C961 a_27671_1842# a_27563_1842# 0.01163f
C962 a_7364_1008# VDD 0.28633f
C963 a_11195_1044# a_10985_1044# 0.09424f
C964 a_6635_1044# a_4350_1044# 0.39036f
C965 VDD a_22488_1044# 0.17274f
C966 a_24665_1044# a_22590_1044# 0.03208f
C967 a_5731_289# a_4350_1044# 0.41099f
C968 a_1256_289# MUX_SEL2 0.33134f
C969 a_5523_1842# a_5631_1842# 0.01163f
C970 a_15304_4605# VDD 0.72158f
C971 a_23437_1842# VDD 0.86909f
C972 a_13121_5831# REF_CLK 1.40135f
C973 a_12849_5867# DLL_RESETN 0.3501f
C974 MUX_SEL2 MUX_OUT 0.08497f
C975 MUX_SEL3 MUX_SEL4 0.75489f
C976 a_6126_3816# VDD 0.84141f
C977 VDD a_19637_1842# 0.86707f
C978 DELAY_VBIASN a_16793_1842# 0.10734f
C979 DELAY_VBIASP a_16597_1842# 0.04176f
C980 a_13123_1842# DELAY_VBIASP 0.06627f
C981 a_14317_1842# DELAY_VBIASN 0.09974f
C982 a_14757_6228# a_14009_5878# 0.01058f
C983 a_4633_1842# a_5197_1842# 0.0114f
C984 VDD a_23111_2470# 0.01806f
C985 a_12233_1842# a_12797_1842# 0.0114f
C986 a_10649_5878# a_11397_6228# 0.01058f
C987 a_13557_1842# a_13444_1008# 0.05157f
C988 a_14888_1044# a_14964_1008# 0.01176f
C989 a_23945_519# VDD 0.29292f
C990 a_5197_1842# DELAY_VBIASP 0.0414f
C991 a_6326_4590# a_9444_4590# 0.01269f
C992 a_2019_311# VDD 1.43004f
C993 a_10430_1044# a_12715_1044# 0.39036f
C994 a_25630_1044# a_26395_1044# 0.39037f
C995 a_12158_5867# DLL_RESETN 0.02442f
C996 a_11491_6228# REF_CLK 0.01827f
C997 VDD a_16923_1842# 0.4973f
C998 a_14513_1842# VDD 0.49436f
C999 a_11473_1842# DELAY_VBIASP 0.11222f
C1000 a_11603_1842# DELAY_VBIASN 0.07254f
C1001 a_26477_1842# a_25630_1044# 0.08038f
C1002 a_15688_5867# a_13121_5831# 0.17255f
C1003 a_14851_6228# a_12849_5867# 0.13392f
C1004 VDD a_17928_1044# 0.17499f
C1005 VDD a_17031_2470# 0.01806f
C1006 a_11277_1842# a_12037_1842# 0.03319f
C1007 a_9946_6305# a_10751_5878# 0.097f
C1008 a_13470_1044# a_13444_1008# 0.277f
C1009 a_21483_1842# a_21591_1842# 0.01163f
C1010 a_9757_1842# DELAY_VBIASP 0.0414f
C1011 a_9953_1842# DELAY_VBIASN 0.0961f
C1012 a_5197_1842# a_4350_1044# 0.08038f
C1013 a_27563_1842# a_25630_1044# 0.01024f
C1014 a_27991_1008# VDD 0.28201f
C1015 VDD MUX_SEL4 2.63176f
C1016 a_9193_1842# a_9757_1842# 0.0114f
C1017 a_5191_1008# a_4905_1044# 0.01885f
C1018 a_12797_1842# VDD 0.87771f
C1019 a_24957_1842# a_24951_1008# 0.02354f
C1020 VDD a_14964_1008# 0.28225f
C1021 a_17065_1044# a_17275_1044# 0.09424f
C1022 a_27433_1842# a_27563_1842# 0.70845f
C1023 a_10649_5878# REF_CLK 0.25484f
C1024 a_13368_1044# a_13444_1008# 0.01176f
C1025 a_24957_1842# a_25153_1842# 0.76914f
C1026 a_13566_5328# a_13592_5423# 0.36952f
C1027 a_7043_1842# DELAY_VBIASP 0.06627f
C1028 a_8237_1842# DELAY_VBIASN 0.09974f
C1029 a_6711_1008# a_6425_1044# 0.01885f
C1030 a_5864_3367# VDD 0.13532f
C1031 a_15108_5325# DELAY_OUT_LAST 0.01399f
C1032 a_9953_1842# a_10083_1842# 0.70845f
C1033 a_9946_6305# a_10206_5835# 0.75507f
C1034 a_22590_1044# a_24008_1044# 0.38994f
C1035 a_4350_1044# a_4324_1008# 0.277f
C1036 a_8237_1842# a_8997_1842# 0.03319f
C1037 VDD a_4157_1313# 0.48935f
C1038 a_23437_1842# a_24084_1008# 0.02312f
C1039 a_9444_4590# a_5778_3367# 0.19787f
C1040 a_14851_5182# a_15464_3684# 0.04797f
C1041 a_12907_5186# DLL_RESETN 0.02177f
C1042 a_26911_2470# a_26803_1842# 0.01697f
C1043 a_13106_5357# a_12907_5420# 0.14994f
C1044 a_23633_1842# a_23763_1842# 0.70845f
C1045 a_8433_1842# VDD 0.49417f
C1046 a_5393_1842# DELAY_VBIASP 0.11222f
C1047 a_5523_1842# DELAY_VBIASN 0.07254f
C1048 a_13880_5118# VDD 0.02994f
C1049 a_7288_1044# a_7364_1008# 0.01176f
C1050 a_19833_1842# a_19963_1842# 0.70845f
C1051 a_9547_5942# a_9746_5805# 0.14994f
C1052 a_16108_289# a_25630_1044# 0.52614f
C1053 VDD a_27705_1044# 0.29918f
C1054 a_7477_1842# a_7043_1842# 0.69698f
C1055 a_4633_1842# a_4763_1842# 0.70845f
C1056 a_5731_289# a_11785_519# 0.28056f
C1057 a_22677_1842# a_22590_1044# 0.1088f
C1058 a_13566_5835# VDD 0.09466f
C1059 a_6717_1842# VDD 0.87726f
C1060 a_4763_1842# DELAY_VBIASP 0.06627f
C1061 a_13306_6305# a_14009_5878# 0.02432f
C1062 a_15403_1842# a_15511_1842# 0.01163f
C1063 a_6326_4590# a_6854_5454# 1.25249f
C1064 a_5974_5723# a_6126_3816# 1.74589f
C1065 a_18877_1842# a_19203_1842# 0.01427f
C1066 a_14851_5182# a_13121_5831# 0.03337f
C1067 a_19637_1842# a_19524_1008# 0.05157f
C1068 VDD a_15545_1044# 0.29918f
C1069 a_6153_1842# a_6717_1842# 0.0114f
C1070 a_12355_5867# VDD 0.37639f
C1071 a_11848_1044# a_11277_1842# 0.10863f
C1072 a_15964_289# MUX_OUT 0.01307f
C1073 a_4763_1842# a_4350_1044# 0.01012f
C1074 a_21917_1842# a_22113_1842# 0.76914f
C1075 a_13121_5831# a_12849_5867# 0.55272f
C1076 a_25913_1842# DELAY_VBIASP 0.11284f
C1077 a_20723_1842# a_20593_1842# 0.70845f
C1078 a_18117_1842# a_18313_1842# 0.77122f
C1079 a_4003_1842# REF_CLK 0.55467f
C1080 VDD a_11711_2470# 0.01806f
C1081 DELAY_VBIASP a_27997_1842# 0.04038f
C1082 a_2019_311# a_17865_519# 0.13959f
C1083 a_10083_1842# a_10191_2470# 0.01697f
C1084 a_3449_331# a_2019_311# 0.01176f
C1085 a_21917_1842# a_16108_289# 0.0157f
C1086 a_12791_1008# VDD 0.2822f
C1087 VDD a_27124_1008# 0.28225f
C1088 DLL_RESETN DELAY_VBIASP 0.07017f
C1089 a_24197_1842# DELAY_VBIASP 0.04177f
C1090 a_24393_1842# DELAY_VBIASN 0.10734f
C1091 a_14825_519# a_13470_1044# 0.02058f
C1092 DELAY_VBIASN a_20593_1842# 0.10398f
C1093 DELAY_VBIASP a_20397_1842# 0.04176f
C1094 a_20723_1842# a_20831_2470# 0.01697f
C1095 a_16793_1842# a_16923_1842# 0.70845f
C1096 a_5768_1044# a_5197_1842# 0.10863f
C1097 a_18117_1842# a_16510_1044# 0.05231f
C1098 a_17357_1842# a_17351_1008# 0.02349f
C1099 a_14317_1842# a_14513_1842# 0.76914f
C1100 VDD a_5631_2470# 0.01806f
C1101 a_15837_1842# a_15831_1008# 0.02354f
C1102 a_1544_289# a_2297_331# 0.27303f
C1103 a_1256_289# a_2873_331# 0.27926f
C1104 a_16510_1044# a_18795_1044# 0.39036f
C1105 a_10328_1044# VDD 0.17274f
C1106 VDD a_24875_1044# 0.15406f
C1107 a_24665_1044# a_24951_1008# 0.01885f
C1108 a_16851_309# MUX_OUT 0.45865f
C1109 a_5974_5723# a_5864_3367# 0.01697f
C1110 a_6854_5454# a_5778_3367# 0.02695f
C1111 a_6854_5986# a_9712_3912# 0.13962f
C1112 a_6126_3816# a_9444_3912# 0.25721f
C1113 a_3449_331# MUX_SEL4 0.05166f
C1114 a_5957_1842# a_6425_1044# 0.2079f
C1115 a_24523_1842# VDD 0.4973f
C1116 a_13306_5105# VDD 0.79678f
C1117 a_21483_1842# DELAY_VBIASP 0.06661f
C1118 a_11491_6228# a_12158_5867# 0.0894f
C1119 a_22677_1842# DELAY_VBIASN 0.0907f
C1120 a_14009_5878# REF_CLK 0.25847f
C1121 a_7390_1044# a_7803_1842# 0.01012f
C1122 DELAY_VBIASP a_17683_1842# 0.06661f
C1123 DELAY_VBIASN a_18877_1842# 0.10687f
C1124 a_15273_1842# DELAY_VBIASP 0.11297f
C1125 a_15273_1842# a_15403_1842# 0.70845f
C1126 DELAY_VBIASN a_19550_1044# 0.02115f
C1127 VDD a_26673_1842# 0.49417f
C1128 a_12993_1842# a_13123_1842# 0.70845f
C1129 a_14317_1842# a_14964_1008# 0.02312f
C1130 a_7390_1044# VDD 0.8686f
C1131 a_10430_1044# a_12505_1044# 0.03208f
C1132 a_5844_1008# a_4350_1044# 0.28279f
C1133 VDD a_21911_1008# 0.2822f
C1134 a_23145_1044# a_22590_1044# 0.03209f
C1135 a_12715_1044# a_12791_1008# 0.01194f
C1136 a_22873_1842# VDD 0.49294f
C1137 a_27048_1044# a_27124_1008# 0.01176f
C1138 a_13121_5831# DLL_RESETN 0.04337f
C1139 a_13019_5831# REF_CLK 0.35409f
C1140 MUX_SEL1 MUX_OUT 0.09357f
C1141 a_24523_1842# a_24631_1842# 0.01163f
C1142 MUX_SEL2 MUX_SEL4 0.01978f
C1143 a_6854_5986# VDD 1.20794f
C1144 VDD a_19073_1842# 0.49426f
C1145 a_7288_1044# a_6717_1842# 0.10864f
C1146 DELAY_VBIASN a_16163_1842# 0.08306f
C1147 DELAY_VBIASP a_16033_1842# 0.11287f
C1148 a_13557_1842# DELAY_VBIASP 0.0414f
C1149 a_13753_1842# DELAY_VBIASN 0.0961f
C1150 a_14757_6228# a_13592_5871# 0.43239f
C1151 VDD a_20315_1044# 0.15389f
C1152 VDD a_22351_2470# 0.01806f
C1153 VDD a_26043_1842# 0.4973f
C1154 a_10232_5871# a_11397_6228# 0.43239f
C1155 a_13557_1842# a_13470_1044# 0.1088f
C1156 a_20905_519# VDD 0.29292f
C1157 a_4633_1842# DELAY_VBIASP 0.11222f
C1158 a_19963_1842# a_20071_1842# 0.01163f
C1159 a_5705_519# VDD 0.29556f
C1160 a_11195_1044# a_11271_1008# 0.01194f
C1161 a_10430_1044# a_11924_1008# 0.28279f
C1162 a_25630_1044# a_25604_1008# 0.277f
C1163 a_11491_6228# DLL_RESETN 0.14622f
C1164 a_11748_6109# REF_CLK 0.0148f
C1165 a_23003_1842# a_23111_1842# 0.01163f
C1166 DELAY_VBIASP a_15403_1842# 0.06668f
C1167 VDD a_17357_1842# 0.86909f
C1168 a_13883_1842# VDD 0.49742f
C1169 a_12037_1842# DELAY_VBIASN 0.09156f
C1170 a_10843_1842# DELAY_VBIASP 0.06627f
C1171 a_15108_6109# a_12849_5867# 0.10225f
C1172 a_14111_5878# a_13306_6305# 0.097f
C1173 a_15688_5867# a_13019_5831# 0.0195f
C1174 a_14851_6228# a_13121_5831# 0.03404f
C1175 VDD a_17351_1008# 0.28565f
C1176 a_9444_3912# a_5864_3367# 0.02483f
C1177 VDD a_16271_2470# 0.01806f
C1178 a_15403_1842# a_13470_1044# 0.01012f
C1179 a_11277_1842# a_11473_1842# 0.76914f
C1180 a_9946_6305# a_10520_6292# 0.31978f
C1181 a_25717_1842# a_26477_1842# 0.01669f
C1182 a_9323_1842# DELAY_VBIASN 0.07254f
C1183 a_9193_1842# DELAY_VBIASP 0.11222f
C1184 a_18443_1842# a_18551_1842# 0.01163f
C1185 a_26477_1842# a_26803_1842# 0.01427f
C1186 VDD MUX_SEL3 0.4053f
C1187 a_5115_1044# a_4905_1044# 0.09424f
C1188 MUX_SEL1 a_2297_1395# 0.01995f
C1189 MUX_OUT a_1544_1044# 0.04258f
C1190 a_12233_1842# VDD 0.49285f
C1191 a_20391_1008# a_19550_1044# 0.28268f
C1192 VDD a_14888_1044# 0.17499f
C1193 a_18585_1044# a_16510_1044# 0.03208f
C1194 a_27433_1842# a_27997_1842# 0.0114f
C1195 a_10649_5878# DLL_RESETN 0.05713f
C1196 a_10232_5871# REF_CLK 0.08086f
C1197 a_13368_1044# a_13470_1044# 0.37183f
C1198 a_13566_5328# a_13306_5105# 0.75507f
C1199 a_24957_1842# a_24523_1842# 0.6972f
C1200 a_10517_1842# VDD 0.86707f
C1201 a_7673_1842# DELAY_VBIASN 0.0961f
C1202 a_7477_1842# DELAY_VBIASP 0.0414f
C1203 a_6635_1044# a_6425_1044# 0.09424f
C1204 a_9712_3912# VDD 0.21864f
C1205 a_14851_5182# DELAY_OUT_LAST 0.02109f
C1206 a_16923_1842# a_17031_1842# 0.01163f
C1207 a_25283_1842# a_25391_2470# 0.01697f
C1208 a_7390_1044# a_9751_1008# 0.26208f
C1209 a_22590_1044# a_23431_1008# 0.28268f
C1210 a_4248_1044# a_4324_1008# 0.01176f
C1211 a_8237_1842# a_8433_1842# 0.76914f
C1212 VDD a_3449_1395# 0.46731f
C1213 a_13123_1842# a_13231_2470# 0.01697f
C1214 a_23437_1842# a_24008_1044# 0.10863f
C1215 a_14851_5182# a_14757_5182# 0.28931f
C1216 a_13106_5357# DLL_RESETN 0.01263f
C1217 a_12849_5867# DELAY_OUT_LAST 0.01791f
C1218 a_7803_1842# VDD 0.4973f
C1219 a_13106_5357# a_12907_5186# 0.02437f
C1220 a_23633_1842# a_24197_1842# 0.0114f
C1221 a_5957_1842# DELAY_VBIASN 0.09156f
C1222 a_19833_1842# a_20397_1842# 0.0114f
C1223 a_7288_1044# a_7390_1044# 0.37183f
C1224 a_9547_5942# a_9547_6172# 0.1117f
C1225 a_23763_1842# a_23871_2470# 0.01697f
C1226 a_15464_3684# a_13121_5831# 0.33256f
C1227 a_21835_1044# a_21911_1008# 0.01194f
C1228 VDD a_26185_1044# 0.30409f
C1229 a_6913_1842# a_7043_1842# 0.70845f
C1230 a_2019_311# a_15964_289# 0.02413f
C1231 a_11603_1842# a_11711_2470# 0.01697f
C1232 a_14111_5878# REF_CLK 0.02263f
C1233 a_1544_1044# a_2297_1395# 0.28651f
C1234 a_22677_1842# a_23437_1842# 0.01669f
C1235 a_6153_1842# VDD 0.49285f
C1236 a_13306_6305# a_13592_5871# 0.41329f
C1237 a_12849_5867# a_14009_5878# 0.03525f
C1238 a_18877_1842# a_19637_1842# 0.06198f
C1239 a_5974_5723# a_6854_5986# 0.029f
C1240 a_22243_1842# a_22351_2470# 0.01697f
C1241 a_6326_4590# a_6126_3816# 2.84014f
C1242 a_5768_1044# a_5844_1008# 0.01176f
C1243 a_16108_289# a_22590_1044# 0.58202f
C1244 VDD a_14025_1044# 0.30409f
C1245 a_19637_1842# a_19550_1044# 0.1088f
C1246 a_14111_5227# a_15108_5325# 0.03012f
C1247 DELAY_VBIASP a_25630_1044# 0.01522f
C1248 a_10430_1044# a_12037_1842# 0.05231f
C1249 a_15964_289# MUX_SEL4 0.5544f
C1250 a_11271_1008# a_11277_1842# 0.02349f
C1251 a_15108_6109# a_14851_6228# 0.29858f
C1252 a_7477_1842# a_7945_1044# 0.19203f
C1253 a_21917_1842# a_21483_1842# 0.6972f
C1254 a_8563_1842# a_8671_2470# 0.01697f
C1255 a_13019_5831# a_12849_5867# 0.12838f
C1256 a_26477_1842# DELAY_VBIASN 0.1083f
C1257 a_25283_1842# DELAY_VBIASP 0.06661f
C1258 a_10404_1008# a_9757_1842# 0.02011f
C1259 a_18117_1842# a_17683_1842# 0.6972f
C1260 a_16108_289# a_26985_519# 0.27952f
C1261 a_4437_1842# REF_CLK 0.05209f
C1262 a_15077_1842# a_15837_1842# 0.02912f
C1263 VDD a_10951_2470# 0.01806f
C1264 a_2019_311# a_16851_309# 0.01299f
C1265 DELAY_VBIASP a_27433_1842# 0.11284f
C1266 DELAY_VBIASN a_27563_1842# 0.08029f
C1267 DELAY_OUT_LAST a_27997_1842# 0.70957f
C1268 a_18795_1044# a_18871_1008# 0.01194f
C1269 a_12715_1044# VDD 0.15406f
C1270 VDD a_27048_1044# 0.17499f
C1271 REF_CLK DELAY_VBIASN 0.07156f
C1272 a_8745_519# MUX_SEL4 0.04472f
C1273 a_5731_289# MUX_OUT 1.04829f
C1274 a_7043_1842# a_7151_2470# 0.01697f
C1275 a_23763_1842# DELAY_VBIASN 0.08024f
C1276 a_23633_1842# DELAY_VBIASP 0.11286f
C1277 a_10083_1842# a_10191_1842# 0.01163f
C1278 a_8884_1008# a_8997_1842# 0.02055f
C1279 DELAY_VBIASP a_19833_1842# 0.11284f
C1280 DELAY_VBIASN a_19963_1842# 0.08024f
C1281 a_16793_1842# a_17357_1842# 0.0114f
C1282 VDD a_4871_2470# 0.01806f
C1283 a_14317_1842# a_13883_1842# 0.6972f
C1284 a_16510_1044# a_18004_1008# 0.28279f
C1285 a_17275_1044# a_17351_1008# 0.01194f
C1286 a_1256_289# a_2297_331# 0.04261f
C1287 a_1544_289# a_1721_331# 0.36963f
C1288 a_9751_1008# VDD 0.2822f
C1289 a_12791_1008# a_12505_1044# 0.01885f
C1290 a_24665_1044# a_24875_1044# 0.09424f
C1291 VDD a_24084_1008# 0.28225f
C1292 a_16108_289# MUX_OUT 0.24265f
C1293 a_6126_3816# a_5778_3367# 1.6143f
C1294 a_6854_5986# a_9444_3912# 0.01142f
C1295 a_6326_4590# a_5864_3367# 0.01889f
C1296 a_5974_5723# a_9712_3912# 0.01152f
C1297 a_3449_331# MUX_SEL3 0.28429f
C1298 a_2873_331# MUX_SEL4 0.04916f
C1299 a_2297_331# MUX_OUT 0.01179f
C1300 a_5523_1842# a_5631_2470# 0.01697f
C1301 a_13566_5328# VDD 0.0947f
C1302 a_24957_1842# VDD 0.87825f
C1303 a_11748_6109# a_12158_5867# 0.10373f
C1304 a_22113_1842# DELAY_VBIASN 0.10263f
C1305 a_21917_1842# DELAY_VBIASP 0.04176f
C1306 a_13592_5871# REF_CLK 0.11539f
C1307 a_9946_6305# VDD 0.77198f
C1308 VDD a_21157_1842# 0.85848f
C1309 a_7390_1044# a_8237_1842# 0.08038f
C1310 DELAY_VBIASP a_18117_1842# 0.04177f
C1311 DELAY_VBIASN a_18313_1842# 0.10734f
C1312 a_15837_1842# DELAY_VBIASN 0.10875f
C1313 a_14643_1842# DELAY_VBIASP 0.06668f
C1314 a_14009_5084# a_12849_5867# 0.03463f
C1315 VDD a_27671_2470# 0.01806f
C1316 a_9444_4590# DLL_RESETN 0.10269f
C1317 a_12993_1842# a_13557_1842# 0.0114f
C1318 a_14317_1842# a_14888_1044# 0.10863f
C1319 a_15304_4605# a_15108_5325# 0.01986f
C1320 a_7288_1044# VDD 0.17274f
C1321 a_5768_1044# a_4350_1044# 0.38994f
C1322 a_10430_1044# a_10985_1044# 0.03209f
C1323 VDD a_21835_1044# 0.15406f
C1324 a_22243_1842# VDD 0.49737f
C1325 a_12656_5864# REF_CLK 0.01215f
C1326 a_13019_5831# DLL_RESETN 0.01429f
C1327 MUX_SEL2 MUX_SEL3 3.21891f
C1328 MUX_SEL1 MUX_SEL4 0.03574f
C1329 a_5974_5723# VDD 0.91576f
C1330 VDD a_18443_1842# 0.4973f
C1331 DELAY_VBIASN a_16597_1842# 0.0907f
C1332 a_6711_1008# a_6717_1842# 0.02354f
C1333 a_12993_1842# DELAY_VBIASP 0.11222f
C1334 a_13123_1842# DELAY_VBIASN 0.07254f
C1335 a_4437_1842# a_5197_1842# 0.01669f
C1336 VDD a_19524_1008# 0.28633f
C1337 VDD a_21591_2470# 0.01806f
C1338 DELAY_VBIASN a_16510_1044# 0.02115f
C1339 a_12037_1842# a_12797_1842# 0.02912f
C1340 a_13470_1044# a_15831_1008# 0.26208f
C1341 a_8231_1008# a_7945_1044# 0.01885f
C1342 a_17865_519# VDD 0.29444f
C1343 a_5197_1842# DELAY_VBIASN 0.09974f
C1344 a_4003_1842# DELAY_VBIASP 0.05992f
C1345 a_3449_331# VDD 0.46596f
C1346 a_10430_1044# a_11848_1044# 0.38994f
C1347 a_12943_5867# VDD 0.29479f
C1348 a_25528_1044# a_25604_1008# 0.01176f
C1349 a_10751_5878# REF_CLK 0.01931f
C1350 a_11748_6109# DLL_RESETN 0.11133f
C1351 a_9953_1842# a_10517_1842# 0.0114f
C1352 DELAY_OUT_LAST DELAY_VBIASP 1.08837f
C1353 VDD a_16793_1842# 0.49277f
C1354 a_14317_1842# VDD 0.87229f
C1355 a_11473_1842# DELAY_VBIASN 0.0961f
C1356 a_11277_1842# DELAY_VBIASP 0.0414f
C1357 a_14111_5878# a_12849_5867# 0.42174f
C1358 a_13880_6292# a_13306_6305# 0.31978f
C1359 a_15108_6109# a_13121_5831# 0.03701f
C1360 a_25717_1842# a_25604_1008# 0.05157f
C1361 a_14851_6228# a_13019_5831# 0.01651f
C1362 a_9444_3912# a_9712_3912# 0.81869f
C1363 a_5778_3367# a_5864_3367# 0.07306f
C1364 VDD a_17275_1044# 0.15389f
C1365 a_18585_1044# a_18871_1008# 0.01885f
C1366 VDD a_15511_2470# 0.01806f
C1367 a_11277_1842# a_10843_1842# 0.6972f
C1368 a_25717_1842# a_25913_1842# 0.73897f
C1369 a_9757_1842# DELAY_VBIASN 0.09992f
C1370 a_8563_1842# DELAY_VBIASP 0.06627f
C1371 a_4437_1842# a_4324_1008# 0.05157f
C1372 a_15464_3684# DELAY_OUT_LAST 0.02565f
C1373 a_26477_1842# a_27237_1842# 0.03319f
C1374 VDD MUX_SEL2 0.50938f
C1375 a_8997_1842# a_9757_1842# 0.02912f
C1376 a_17065_1044# a_16597_1842# 0.19203f
C1377 a_11603_1842# VDD 0.49671f
C1378 MUX_SEL0 a_2297_1395# 0.10655f
C1379 MUX_SEL4 a_1544_1044# 0.03407f
C1380 MUX_OUT a_1256_1044# 0.02466f
C1381 VDD a_14751_2470# 0.01806f
C1382 VDD a_14311_1008# 0.28336f
C1383 a_17065_1044# a_16510_1044# 0.03209f
C1384 a_13592_5423# REF_CLK 0.03445f
C1385 a_10232_5871# DLL_RESETN 0.39088f
C1386 a_24393_1842# a_24523_1842# 0.70845f
C1387 a_13132_5420# a_13306_5105# 0.27179f
C1388 a_9953_1842# VDD 0.49426f
C1389 a_6913_1842# DELAY_VBIASP 0.11222f
C1390 a_7043_1842# DELAY_VBIASN 0.07254f
C1391 a_9444_3912# VDD 0.0107f
C1392 a_9757_1842# a_10083_1842# 0.01427f
C1393 a_14643_1842# a_14751_1842# 0.01163f
C1394 a_7390_1044# a_9675_1044# 0.39036f
C1395 a_22590_1044# a_23355_1044# 0.39037f
C1396 a_4248_1044# a_4350_1044# 0.37183f
C1397 VDD a_5191_1008# 0.28565f
C1398 a_8237_1842# a_7803_1842# 0.6972f
C1399 a_10430_1044# a_5731_289# 0.41176f
C1400 a_24197_1842# a_22590_1044# 0.05231f
C1401 a_23437_1842# a_23431_1008# 0.02349f
C1402 a_14025_1044# a_14311_1008# 0.01885f
C1403 a_15304_4605# REF_CLK 0.01066f
C1404 a_13121_5831# DELAY_OUT_LAST 0.13178f
C1405 a_13019_5831# DELAY_VBIASP 0.02377f
C1406 a_6854_5454# DLL_RESETN 0.03626f
C1407 a_8237_1842# VDD 0.86909f
C1408 a_23437_1842# a_23763_1842# 0.01427f
C1409 a_5393_1842# DELAY_VBIASN 0.0961f
C1410 a_15688_5403# VDD 0.30345f
C1411 a_6854_5986# a_13132_5420# 0.01367f
C1412 a_13123_1842# a_13231_1842# 0.01163f
C1413 a_15464_3684# a_13019_5831# 0.59875f
R0 VDD.n103 VDD.t201 17.3693
R1 VDD.n92 VDD.t15 17.3693
R2 VDD.n92 VDD.t13 17.3693
R3 VDD.n104 VDD.t346 17.3517
R4 VDD.n95 VDD.t152 17.3517
R5 VDD.n94 VDD.t250 17.3517
R6 VDD.n60 VDD.t81 17.2438
R7 VDD.n98 VDD.t24 17.2247
R8 VDD.n104 VDD.t179 17.0005
R9 VDD.n95 VDD.t12 17.0005
R10 VDD.n94 VDD.t11 17.0005
R11 VDD.t0 VDD.n77 4.19382
R12 VDD.n38 VDD.n39 0.189847
R13 VDD.n73 VDD.n24 0.180969
R14 VDD.t0 VDD.n24 0.696641
R15 VDD.n74 VDD.n71 0.149987
R16 VDD.t0 VDD.n71 2.39616
R17 VDD.n25 VDD.n44 0.180969
R18 VDD.n25 VDD.t0 0.696641
R19 VDD.n75 VDD.n65 0.149987
R20 VDD.t0 VDD.n65 2.39616
R21 VDD.t0 VDD.n13 0.796887
R22 VDD.t101 VDD.n33 2.05485
R23 VDD.n32 VDD.n52 0.448571
R24 VDD.n31 VDD.t116 15.1333
R25 VDD.n31 VDD.t119 15.0005
R26 VDD.n3 VDD.t114 15.0005
R27 VDD.n51 VDD.t100 15.0005
R28 VDD.n35 VDD.t106 15.0005
R29 VDD.n54 VDD.t260 17.9449
R30 VDD.n350 VDD.n349 9.51422
R31 VDD.n349 VDD.n348 9.17119
R32 VDD.n55 VDD.n54 0.341666
R33 VDD.n352 VDD.t38 9.02285
R34 VDD.n61 VDD.n62 0.0615821
R35 VDD.n89 VDD.n26 4.47071
R36 VDD.n88 VDD.t221 8.95516
R37 VDD.n121 VDD.t389 8.76154
R38 VDD.n15 VDD.t207 8.76154
R39 VDD.n15 VDD.t78 8.76154
R40 VDD.n15 VDD.t163 8.76154
R41 VDD.n14 VDD.t84 8.76154
R42 VDD.n122 VDD.t387 8.76154
R43 VDD.n40 VDD.t77 8.76154
R44 VDD.n123 VDD.t61 8.76154
R45 VDD.n60 VDD.t344 8.76154
R46 VDD.n82 VDD.t142 8.76054
R47 VDD.n82 VDD.t255 8.76054
R48 VDD.n121 VDD.t248 8.76054
R49 VDD.n15 VDD.t40 8.76054
R50 VDD.n15 VDD.t304 8.76054
R51 VDD.n15 VDD.t18 8.76054
R52 VDD.n14 VDD.t308 8.76054
R53 VDD.n122 VDD.t134 8.76054
R54 VDD.n40 VDD.t305 8.76054
R55 VDD.n123 VDD.t73 8.76054
R56 VDD.n71 VDD.n70 0.0442395
R57 VDD VDD.t10 8.47732
R58 VDD.n42 VDD.n41 0.0953067
R59 VDD.t0 VDD.n42 4.19225
R60 VDD.t0 VDD.n37 3.34459
R61 VDD.t0 VDD.n16 1.07426
R62 VDD.t0 VDD.n6 0.578625
R63 VDD.t101 VDD.n48 1.61947
R64 VDD.t101 VDD.n32 0.894484
R65 VDD.t101 VDD.n61 8.47732
R66 VDD.n6 VDD.t414 7.62628
R67 VDD.n63 VDD.t413 7.62628
R68 VDD.n1 VDD.t412 7.62628
R69 VDD.n1 VDD.t411 7.62628
R70 VDD.n0 VDD.t410 7.62628
R71 VDD.n22 VDD.t409 7.62628
R72 VDD.t0 VDD.t408 7.62628
R73 VDD.n66 VDD.t407 7.62628
R74 VDD.n21 VDD.t406 7.62628
R75 VDD.n7 VDD.t405 7.62628
R76 VDD.n69 VDD.t404 7.62628
R77 VDD.t0 VDD.t403 7.62628
R78 VDD.t0 VDD.t402 7.62628
R79 VDD.t0 VDD.t401 7.62628
R80 VDD.t0 VDD.t400 7.62628
R81 VDD.t0 VDD.t399 7.62628
R82 VDD.n72 VDD.t398 7.62628
R83 VDD.n19 VDD.t397 7.62628
R84 VDD.n3 VDD.n28 3.11859
R85 VDD.n166 VDD.t160 6.09923
R86 VDD.n172 VDD.t35 6.09923
R87 VDD.n178 VDD.t162 6.09923
R88 VDD.n184 VDD.t230 6.09923
R89 VDD.n190 VDD.t241 6.09923
R90 VDD.n196 VDD.t338 6.09923
R91 VDD.n202 VDD.t46 6.09923
R92 VDD.n208 VDD.t136 6.09923
R93 VDD.n214 VDD.t204 6.09923
R94 VDD.n220 VDD.t9 6.09923
R95 VDD.n226 VDD.t209 6.09923
R96 VDD.n232 VDD.t53 6.09923
R97 VDD.n238 VDD.t72 6.09923
R98 VDD.n244 VDD.t146 6.09923
R99 VDD.n250 VDD.t216 6.09923
R100 VDD.n256 VDD.t67 6.09923
R101 VDD.n262 VDD.t36 6.09923
R102 VDD.n268 VDD.t44 6.09923
R103 VDD.n274 VDD.t171 6.09923
R104 VDD.n280 VDD.t299 6.09923
R105 VDD.n286 VDD.t183 6.09923
R106 VDD.n292 VDD.t139 6.09923
R107 VDD.n298 VDD.t80 6.09923
R108 VDD.n304 VDD.t8 6.09923
R109 VDD.n310 VDD.t23 6.09923
R110 VDD.n316 VDD.t17 6.09923
R111 VDD.n322 VDD.t174 6.09923
R112 VDD.n328 VDD.t185 6.09923
R113 VDD.n334 VDD.t133 6.09923
R114 VDD.n340 VDD.t21 6.09923
R115 VDD.n346 VDD.t155 6.09923
R116 VDD.n12 VDD.t261 6.09923
R117 VDD.n1 VDD.t122 5.99122
R118 VDD.n22 VDD.t64 5.99122
R119 VDD.n21 VDD.t153 5.99122
R120 VDD.t0 VDD.t137 5.99122
R121 VDD.t0 VDD.t22 5.99122
R122 VDD.n19 VDD.t131 5.99122
R123 VDD.n78 VDD.t253 5.98905
R124 VDD.n102 VDD.t158 5.9886
R125 VDD.n80 VDD.t39 5.97675
R126 VDD.n80 VDD.t257 5.97675
R127 VDD.n15 VDD.t208 5.97212
R128 VDD.n15 VDD.t164 5.97212
R129 VDD.n41 VDD.t388 5.97212
R130 VDD.n124 VDD.t62 5.97212
R131 VDD.n15 VDD.t41 5.97169
R132 VDD.n15 VDD.t19 5.97169
R133 VDD.n41 VDD.t135 5.97169
R134 VDD.n124 VDD.t74 5.97169
R135 VDD.n6 VDD.t28 5.97001
R136 VDD.n6 VDD.t189 5.97001
R137 VDD.n6 VDD.t128 5.97001
R138 VDD.n1 VDD.t379 5.97001
R139 VDD.n1 VDD.t378 5.97001
R140 VDD.n1 VDD.t85 5.97001
R141 VDD.n1 VDD.t382 5.97001
R142 VDD.n1 VDD.t215 5.97001
R143 VDD.n1 VDD.t151 5.97001
R144 VDD.n43 VDD.t3 5.97001
R145 VDD.n75 VDD.t2 5.97001
R146 VDD.t0 VDD.t26 5.97001
R147 VDD.n22 VDD.t6 5.97001
R148 VDD.t0 VDD.t30 5.97001
R149 VDD.t0 VDD.t317 5.97001
R150 VDD.n45 VDD.t57 5.97001
R151 VDD.n44 VDD.t56 5.97001
R152 VDD.n7 VDD.t231 5.97001
R153 VDD.n21 VDD.t60 5.97001
R154 VDD.n7 VDD.t225 5.97001
R155 VDD.n7 VDD.t240 5.97001
R156 VDD.n46 VDD.t373 5.97001
R157 VDD.n74 VDD.t372 5.97001
R158 VDD.t0 VDD.t68 5.97001
R159 VDD.t0 VDD.t376 5.97001
R160 VDD.t0 VDD.t212 5.97001
R161 VDD.t0 VDD.t351 5.97001
R162 VDD.t0 VDD.t235 6.13103
R163 VDD.t0 VDD.t234 5.97001
R164 VDD.t0 VDD.t254 5.97001
R165 VDD.t0 VDD.t238 5.97001
R166 VDD.t0 VDD.t175 5.97001
R167 VDD.t0 VDD.t33 5.97001
R168 VDD.n47 VDD.t354 5.97001
R169 VDD.n73 VDD.t353 5.97001
R170 VDD.n19 VDD.t357 5.97001
R171 VDD.n6 VDD.t386 5.96578
R172 VDD.n38 VDD.t76 5.96578
R173 VDD.n119 VDD.t83 5.96578
R174 VDD.n1 VDD.t48 5.96578
R175 VDD.t0 VDD.t130 5.96578
R176 VDD.n7 VDD.t385 5.96578
R177 VDD.n68 VDD.t341 5.96578
R178 VDD.n23 VDD.t129 5.96578
R179 VDD.t0 VDD.t49 5.96578
R180 VDD.t0 VDD.t191 5.96578
R181 VDD.n17 VDD.t125 5.96578
R182 VDD.n38 VDD.t306 5.96534
R183 VDD.n119 VDD.t309 5.96534
R184 VDD.n78 VDD.t334 5.96534
R185 VDD.n117 VDD.t197 5.96534
R186 VDD.n115 VDD.t87 5.96534
R187 VDD.n5 VDD.t259 5.96534
R188 VDD.n6 VDD.t34 5.96534
R189 VDD.n6 VDD.t193 5.96534
R190 VDD.n6 VDD.t161 5.96534
R191 VDD.n6 VDD.t228 5.96534
R192 VDD.n6 VDD.t229 5.96534
R193 VDD.n1 VDD.t123 5.96534
R194 VDD.n1 VDD.t149 5.96534
R195 VDD.n1 VDD.t367 5.96534
R196 VDD.n1 VDD.t156 5.96534
R197 VDD.n1 VDD.t45 5.96534
R198 VDD.n1 VDD.t70 5.96534
R199 VDD.n1 VDD.t366 5.96534
R200 VDD.n75 VDD.t195 5.96534
R201 VDD.n22 VDD.t196 5.96534
R202 VDD.n22 VDD.t170 5.96534
R203 VDD.t0 VDD.t157 5.96534
R204 VDD.t0 VDD.t244 5.96534
R205 VDD.t0 VDD.t187 5.96534
R206 VDD.t0 VDD.t52 5.96534
R207 VDD.n44 VDD.t223 5.96534
R208 VDD.n21 VDD.t192 5.96534
R209 VDD.n21 VDD.t145 5.96534
R210 VDD.n23 VDD.t258 5.96534
R211 VDD.n23 VDD.t310 5.96534
R212 VDD.n130 VDD.t361 5.96534
R213 VDD.n68 VDD.t395 5.96534
R214 VDD.n128 VDD.t391 5.96534
R215 VDD.n60 VDD.t37 5.96534
R216 VDD.n126 VDD.t148 5.96534
R217 VDD.n7 VDD.t364 5.96534
R218 VDD.n7 VDD.t358 5.96534
R219 VDD.n7 VDD.t168 5.96534
R220 VDD.n7 VDD.t54 5.96534
R221 VDD.n7 VDD.t300 5.96534
R222 VDD.n74 VDD.t198 5.96534
R223 VDD.t0 VDD.t194 5.96534
R224 VDD.t0 VDD.t370 5.96534
R225 VDD.t0 VDD.t345 5.96534
R226 VDD.t0 VDD.t65 5.96534
R227 VDD.t0 VDD.t25 5.96534
R228 VDD.t0 VDD.t336 5.96534
R229 VDD.t0 VDD.t224 5.96534
R230 VDD.t0 VDD.t147 5.96534
R231 VDD.t0 VDD.t140 5.96534
R232 VDD.t0 VDD.t51 5.96534
R233 VDD.t0 VDD.t298 5.96534
R234 VDD.t0 VDD.t362 5.96534
R235 VDD.t0 VDD.t359 5.96534
R236 VDD.n73 VDD.t126 5.96534
R237 VDD.n19 VDD.t214 5.96534
R238 VDD.n19 VDD.t20 5.96534
R239 VDD.n17 VDD.t188 5.96534
R240 VDD.n17 VDD.t42 5.96534
R241 VDD.n100 VDD.t220 5.96478
R242 VDD.n6 VDD.t29 5.65005
R243 VDD.n63 VDD.t190 5.65005
R244 VDD.n1 VDD.t380 5.65005
R245 VDD.n1 VDD.t86 5.65005
R246 VDD.n0 VDD.t1 5.65005
R247 VDD.n22 VDD.t4 5.65005
R248 VDD.t0 VDD.t27 5.65005
R249 VDD.n66 VDD.t31 5.65005
R250 VDD.n21 VDD.t58 5.65005
R251 VDD.n7 VDD.t232 5.65005
R252 VDD.n69 VDD.t226 5.65005
R253 VDD.t0 VDD.t374 5.65005
R254 VDD.t0 VDD.t69 5.65005
R255 VDD.t0 VDD.t213 5.65005
R256 VDD.t0 VDD.t236 5.65005
R257 VDD.t0 VDD.t32 5.65005
R258 VDD.n72 VDD.t176 5.65005
R259 VDD.n19 VDD.t355 5.65005
R260 VDD.t10 VDD.n351 5.62581
R261 VDD.t10 VDD.n353 5.62581
R262 VDD.t0 VDD.n125 5.62581
R263 VDD.t0 VDD.n118 5.62581
R264 VDD.n37 VDD.n122 0.160419
R265 VDD.n16 VDD.n15 0.134613
R266 VDD.n7 VDD.t0 0.578619
R267 VDD.n59 VDD.t0 1.79705
R268 VDD.n127 VDD.t0 5.62581
R269 VDD.n129 VDD.t0 5.62581
R270 VDD.t7 VDD.n165 5.62581
R271 VDD.t7 VDD.n171 5.62581
R272 VDD.t7 VDD.n177 5.62581
R273 VDD.t7 VDD.n183 5.62581
R274 VDD.t7 VDD.n189 5.62581
R275 VDD.t7 VDD.n195 5.62581
R276 VDD.t7 VDD.n201 5.62581
R277 VDD.t7 VDD.n207 5.62581
R278 VDD.t7 VDD.n213 5.62581
R279 VDD.t7 VDD.n219 5.62581
R280 VDD.t7 VDD.n225 5.62581
R281 VDD.t7 VDD.n231 5.62581
R282 VDD.t7 VDD.n237 5.62581
R283 VDD.t7 VDD.n243 5.62581
R284 VDD.t7 VDD.n249 5.62581
R285 VDD.t7 VDD.n255 5.62581
R286 VDD.t7 VDD.n261 5.62581
R287 VDD.t7 VDD.n267 5.62581
R288 VDD.t7 VDD.n273 5.62581
R289 VDD.t7 VDD.n279 5.62581
R290 VDD.t7 VDD.n285 5.62581
R291 VDD.t7 VDD.n291 5.62581
R292 VDD.t7 VDD.n297 5.62581
R293 VDD.t7 VDD.n303 5.62581
R294 VDD.t7 VDD.n309 5.62581
R295 VDD.t7 VDD.n315 5.62581
R296 VDD.t7 VDD.n321 5.62581
R297 VDD.t7 VDD.n327 5.62581
R298 VDD.t7 VDD.n333 5.62581
R299 VDD.t7 VDD.n339 5.62581
R300 VDD.t7 VDD.n345 5.62581
R301 VDD.t7 VDD.n29 0.400696
R302 VDD.n29 VDD.n12 0.344299
R303 VDD.t14 VDD.n97 5.61485
R304 VDD.t14 VDD.n101 5.61485
R305 VDD.n2 VDD.t112 5.7457
R306 VDD.n84 VDD.t102 5.60969
R307 VDD.n85 VDD.t107 5.60969
R308 VDD.n3 VDD.t115 5.71623
R309 VDD.n30 VDD.t121 5.60347
R310 VDD.n8 VDD.t118 5.60347
R311 VDD.n26 VDD.t105 5.60347
R312 VDD.n87 VDD.t110 5.60347
R313 VDD.n163 VDD.t270 5.59675
R314 VDD.n169 VDD.t269 5.59675
R315 VDD.n175 VDD.t274 5.59675
R316 VDD.n181 VDD.t267 5.59675
R317 VDD.n187 VDD.t277 5.59675
R318 VDD.n193 VDD.t278 5.59675
R319 VDD.n199 VDD.t280 5.59675
R320 VDD.n205 VDD.t281 5.59675
R321 VDD.n211 VDD.t263 5.59675
R322 VDD.n217 VDD.t282 5.59675
R323 VDD.n223 VDD.t283 5.59675
R324 VDD.n229 VDD.t284 5.59675
R325 VDD.n235 VDD.t276 5.59675
R326 VDD.n241 VDD.t286 5.59675
R327 VDD.n247 VDD.t285 5.59675
R328 VDD.n253 VDD.t287 5.59675
R329 VDD.n259 VDD.t265 5.59675
R330 VDD.n265 VDD.t262 5.59675
R331 VDD.n271 VDD.t288 5.59675
R332 VDD.n277 VDD.t289 5.59675
R333 VDD.n283 VDD.t279 5.59675
R334 VDD.n289 VDD.t264 5.59675
R335 VDD.n295 VDD.t275 5.59675
R336 VDD.n301 VDD.t272 5.59675
R337 VDD.n307 VDD.t268 5.59675
R338 VDD.n313 VDD.t266 5.59675
R339 VDD.n319 VDD.t290 5.59675
R340 VDD.n325 VDD.t291 5.59675
R341 VDD.n331 VDD.t271 5.59675
R342 VDD.n337 VDD.t292 5.59675
R343 VDD.n343 VDD.t293 5.59675
R344 VDD.n10 VDD.t294 5.59675
R345 VDD.n9 VDD.t117 5.59675
R346 VDD.n34 VDD.t273 5.59675
R347 VDD.n26 VDD.t103 5.59179
R348 VDD.n86 VDD.t108 5.59179
R349 VDD.n3 VDD.t113 5.59179
R350 VDD.n390 VDD.t91 4.9462
R351 VDD.n362 VDD.t88 4.9462
R352 VDD.n90 VDD.n89 4.90372
R353 VDD.t0 VDD.n120 4.19244
R354 VDD.t0 VDD.n39 3.32638
R355 VDD.t10 VDD.n108 4.19238
R356 VDD.n48 VDD.n26 0.406014
R357 VDD.n33 VDD.n62 0.379679
R358 VDD.t10 VDD.n354 4.19225
R359 VDD.t10 VDD.n382 4.19225
R360 VDD.t10 VDD.n113 4.19225
R361 VDD.t0 VDD.n76 3.3265
R362 VDD.n126 VDD.n59 0.341
R363 VDD.n67 VDD.t0 3.3265
R364 VDD.t14 VDD.n99 3.31208
R365 VDD.t14 VDD.n91 3.30706
R366 VDD.t14 VDD.n93 3.30706
R367 VDD.t14 VDD.n105 3.30688
R368 VDD VDD.n38 3.24041
R369 VDD.t14 VDD.n81 2.7751
R370 VDD.t0 VDD.n114 2.74446
R371 VDD.t0 VDD.n116 2.74446
R372 VDD.n18 VDD.n17 0.286701
R373 VDD.n130 VDD.n23 0.44578
R374 VDD.n23 VDD.n20 0.309939
R375 VDD.t10 VDD.n107 2.74414
R376 VDD.n29 VDD.n31 0.341922
R377 VDD.t14 VDD 1.47683
R378 VDD.n392 VDD.t93 2.69937
R379 VDD.n360 VDD.t96 2.69937
R380 VDD.n358 VDD.t90 2.69937
R381 VDD.n384 VDD.t98 2.69937
R382 VDD.n388 VDD.t99 2.6992
R383 VDD.n386 VDD.t92 2.6992
R384 VDD.n356 VDD.t95 2.6992
R385 VDD.n364 VDD.t89 2.6992
R386 VDD.n369 VDD.t320 2.6992
R387 VDD.n368 VDD.t327 2.6992
R388 VDD.n374 VDD.t322 2.6992
R389 VDD.n373 VDD.t329 2.6992
R390 VDD.n379 VDD.t324 2.6992
R391 VDD.n378 VDD.t331 2.6992
R392 VDD.t10 VDD.n57 2.33382
R393 VDD.t7 VDD.n323 2.32439
R394 VDD.t7 VDD.n335 2.32439
R395 VDD.t10 VDD.n381 2.32432
R396 VDD.t7 VDD.n209 2.32425
R397 VDD.t7 VDD.n233 2.32425
R398 VDD.t7 VDD.n275 2.32425
R399 VDD.t7 VDD.n167 2.32417
R400 VDD.t7 VDD.n173 2.32417
R401 VDD.t7 VDD.n179 2.32417
R402 VDD.t7 VDD.n185 2.32417
R403 VDD.t7 VDD.n227 2.32417
R404 VDD.t7 VDD.n269 2.32417
R405 VDD.t7 VDD.n305 2.32417
R406 VDD.t7 VDD.n317 2.32417
R407 VDD.t7 VDD.n341 2.32417
R408 VDD.t10 VDD.n112 2.32417
R409 VDD.t10 VDD.n109 2.32417
R410 VDD.t101 VDD.n55 0.570319
R411 VDD.t7 VDD.n197 2.32417
R412 VDD.t7 VDD.n215 2.32417
R413 VDD.t7 VDD.n239 2.32417
R414 VDD.t7 VDD.n251 2.32417
R415 VDD.t10 VDD.n376 2.32414
R416 VDD.t7 VDD.n191 2.32414
R417 VDD.t7 VDD.n221 2.32414
R418 VDD.t7 VDD.n293 2.32414
R419 VDD.t10 VDD.n366 2.32406
R420 VDD.t10 VDD.n111 2.32406
R421 VDD.t7 VDD.n203 2.32406
R422 VDD.t7 VDD.n245 2.32406
R423 VDD.t7 VDD.n257 2.32406
R424 VDD.t7 VDD.n263 2.32406
R425 VDD.t7 VDD.n281 2.32406
R426 VDD.t7 VDD.n287 2.32406
R427 VDD.t7 VDD.n299 2.32406
R428 VDD.t7 VDD.n311 2.32406
R429 VDD.t7 VDD.n329 2.32406
R430 VDD.t7 VDD.n11 2.32406
R431 VDD.n17 VDD.t186 6.35403
R432 VDD.t10 VDD.n371 2.0061
R433 VDD.t10 VDD.n110 2.0061
R434 VDD.t10 VDD.n394 1.75938
R435 VDD.t7 VDD.n134 1.55381
R436 VDD.t7 VDD.n135 1.55381
R437 VDD.t7 VDD.n136 1.55381
R438 VDD.t7 VDD.n137 1.55381
R439 VDD.t7 VDD.n138 1.55381
R440 VDD.t7 VDD.n139 1.55381
R441 VDD.t7 VDD.n140 1.55381
R442 VDD.t7 VDD.n141 1.55381
R443 VDD.t7 VDD.n142 1.55381
R444 VDD.t7 VDD.n143 1.55381
R445 VDD.t7 VDD.n145 1.55381
R446 VDD.t7 VDD.n147 1.55381
R447 VDD.t7 VDD.n148 1.55381
R448 VDD.t7 VDD.n150 1.55381
R449 VDD.t7 VDD.n152 1.55381
R450 VDD.t7 VDD.n153 1.55381
R451 VDD.t7 VDD.n154 1.55381
R452 VDD.t7 VDD.n155 1.55381
R453 VDD.t7 VDD.n156 1.55381
R454 VDD.t7 VDD.n158 1.55381
R455 VDD.t7 VDD.n160 1.55381
R456 VDD.t7 VDD.n131 1.55341
R457 VDD.t7 VDD.n132 1.55341
R458 VDD.t7 VDD.n133 1.55341
R459 VDD.t7 VDD.n144 1.55341
R460 VDD.t7 VDD.n146 1.55341
R461 VDD.t7 VDD.n149 1.55341
R462 VDD.t7 VDD.n151 1.55341
R463 VDD.t7 VDD.n157 1.55341
R464 VDD.t7 VDD.n159 1.55341
R465 VDD.t7 VDD.n161 1.55341
R466 VDD.t14 VDD.n83 1.20461
R467 VDD.n55 VDD.n88 0.779651
R468 VDD.n369 VDD.n368 1.11007
R469 VDD.n374 VDD.n373 1.11007
R470 VDD.n379 VDD.n378 1.11007
R471 VDD.t10 VDD.n106 1.01993
R472 VDD.n103 VDD.n79 0.975304
R473 VDD.n79 VDD.n102 0.817678
R474 VDD.n349 VDD.n28 0.808112
R475 VDD.n90 VDD.n83 0.671512
R476 VDD.n83 VDD.n82 0.6645
R477 VDD.n350 VDD.n106 0.632886
R478 VDD.n348 VDD.n106 0.618267
R479 VDD.n393 VDD.n392 0.570444
R480 VDD.n358 VDD.n357 0.570444
R481 VDD.n386 VDD.n385 0.570274
R482 VDD.n365 VDD.n364 0.570274
R483 VDD.n370 VDD.n369 0.570274
R484 VDD.n375 VDD.n374 0.570274
R485 VDD.n380 VDD.n379 0.570274
R486 VDD.n388 VDD.n387 0.569912
R487 VDD.n356 VDD.n355 0.569912
R488 VDD.n368 VDD.n367 0.569912
R489 VDD.n373 VDD.n372 0.569912
R490 VDD.n378 VDD.n377 0.569912
R491 VDD.n360 VDD.n359 0.569733
R492 VDD.n384 VDD.n383 0.569733
R493 VDD.n27 VDD.n26 0.183807
R494 VDD.n86 VDD.n36 0.508375
R495 VDD.t14 VDD.n79 0.49685
R496 VDD.n163 VDD.n162 0.495398
R497 VDD.n169 VDD.n168 0.495398
R498 VDD.n175 VDD.n174 0.495398
R499 VDD.n181 VDD.n180 0.495398
R500 VDD.n187 VDD.n186 0.495398
R501 VDD.n193 VDD.n192 0.495398
R502 VDD.n199 VDD.n198 0.495398
R503 VDD.n205 VDD.n204 0.495398
R504 VDD.n211 VDD.n210 0.495398
R505 VDD.n217 VDD.n216 0.495398
R506 VDD.n223 VDD.n222 0.495398
R507 VDD.n229 VDD.n228 0.495398
R508 VDD.n235 VDD.n234 0.495398
R509 VDD.n241 VDD.n240 0.495398
R510 VDD.n247 VDD.n246 0.495398
R511 VDD.n253 VDD.n252 0.495398
R512 VDD.n259 VDD.n258 0.495398
R513 VDD.n265 VDD.n264 0.495398
R514 VDD.n271 VDD.n270 0.495398
R515 VDD.n277 VDD.n276 0.495398
R516 VDD.n283 VDD.n282 0.495398
R517 VDD.n289 VDD.n288 0.495398
R518 VDD.n295 VDD.n294 0.495398
R519 VDD.n301 VDD.n300 0.495398
R520 VDD.n307 VDD.n306 0.495398
R521 VDD.n313 VDD.n312 0.495398
R522 VDD.n319 VDD.n318 0.495398
R523 VDD.n325 VDD.n324 0.495398
R524 VDD.n331 VDD.n330 0.495398
R525 VDD.n337 VDD.n336 0.495398
R526 VDD.n343 VDD.n342 0.495398
R527 VDD.n10 VDD.n347 0.495398
R528 VDD.n9 VDD.n31 0.495398
R529 VDD.n34 VDD.n49 0.495398
R530 VDD.n361 VDD.n360 0.492175
R531 VDD.n391 VDD.n384 0.492175
R532 VDD.n389 VDD.n388 0.492005
R533 VDD.n363 VDD.n356 0.492005
R534 VDD.n389 VDD.n386 0.491643
R535 VDD.n364 VDD.n363 0.491643
R536 VDD.n392 VDD.n391 0.491464
R537 VDD.n361 VDD.n358 0.491464
R538 VDD.n164 VDD.n163 0.478641
R539 VDD.n170 VDD.n169 0.478641
R540 VDD.n176 VDD.n175 0.478641
R541 VDD.n182 VDD.n181 0.478641
R542 VDD.n188 VDD.n187 0.478641
R543 VDD.n194 VDD.n193 0.478641
R544 VDD.n200 VDD.n199 0.478641
R545 VDD.n206 VDD.n205 0.478641
R546 VDD.n212 VDD.n211 0.478641
R547 VDD.n218 VDD.n217 0.478641
R548 VDD.n224 VDD.n223 0.478641
R549 VDD.n230 VDD.n229 0.478641
R550 VDD.n236 VDD.n235 0.478641
R551 VDD.n242 VDD.n241 0.478641
R552 VDD.n248 VDD.n247 0.478641
R553 VDD.n254 VDD.n253 0.478641
R554 VDD.n260 VDD.n259 0.478641
R555 VDD.n266 VDD.n265 0.478641
R556 VDD.n272 VDD.n271 0.478641
R557 VDD.n278 VDD.n277 0.478641
R558 VDD.n284 VDD.n283 0.478641
R559 VDD.n290 VDD.n289 0.478641
R560 VDD.n296 VDD.n295 0.478641
R561 VDD.n302 VDD.n301 0.478641
R562 VDD.n308 VDD.n307 0.478641
R563 VDD.n314 VDD.n313 0.478641
R564 VDD.n320 VDD.n319 0.478641
R565 VDD.n326 VDD.n325 0.478641
R566 VDD.n332 VDD.n331 0.478641
R567 VDD.n338 VDD.n337 0.478641
R568 VDD.n344 VDD.n343 0.478641
R569 VDD.n12 VDD.n10 0.478641
R570 VDD.n12 VDD.n9 0.478641
R571 VDD.n36 VDD.n34 0.478641
R572 VDD.n168 VDD.n160 0.467341
R573 VDD.n180 VDD.n158 0.467341
R574 VDD.n192 VDD.n156 0.467341
R575 VDD.n198 VDD.n155 0.467341
R576 VDD.n204 VDD.n154 0.467341
R577 VDD.n210 VDD.n153 0.467341
R578 VDD.n216 VDD.n152 0.467341
R579 VDD.n228 VDD.n150 0.467341
R580 VDD.n240 VDD.n148 0.467341
R581 VDD.n246 VDD.n147 0.467341
R582 VDD.n258 VDD.n145 0.467341
R583 VDD.n270 VDD.n143 0.467341
R584 VDD.n276 VDD.n142 0.467341
R585 VDD.n282 VDD.n141 0.467341
R586 VDD.n288 VDD.n140 0.467341
R587 VDD.n294 VDD.n139 0.467341
R588 VDD.n300 VDD.n138 0.467341
R589 VDD.n306 VDD.n137 0.467341
R590 VDD.n312 VDD.n136 0.467341
R591 VDD.n318 VDD.n135 0.467341
R592 VDD.n324 VDD.n134 0.467341
R593 VDD.n162 VDD.n161 0.466909
R594 VDD.n174 VDD.n159 0.466909
R595 VDD.n186 VDD.n157 0.466909
R596 VDD.n222 VDD.n151 0.466909
R597 VDD.n234 VDD.n149 0.466909
R598 VDD.n252 VDD.n146 0.466909
R599 VDD.n264 VDD.n144 0.466909
R600 VDD.n330 VDD.n133 0.466909
R601 VDD.n336 VDD.n132 0.466909
R602 VDD.n342 VDD.n131 0.466909
R603 VDD.n168 VDD.n161 0.451022
R604 VDD.n180 VDD.n159 0.451022
R605 VDD.n192 VDD.n157 0.451022
R606 VDD.n228 VDD.n151 0.451022
R607 VDD.n240 VDD.n149 0.451022
R608 VDD.n258 VDD.n146 0.451022
R609 VDD.n270 VDD.n144 0.451022
R610 VDD.n336 VDD.n133 0.451022
R611 VDD.n342 VDD.n132 0.451022
R612 VDD.n347 VDD.n131 0.451022
R613 VDD.n174 VDD.n160 0.450618
R614 VDD.n186 VDD.n158 0.450618
R615 VDD.n198 VDD.n156 0.450618
R616 VDD.n204 VDD.n155 0.450618
R617 VDD.n210 VDD.n154 0.450618
R618 VDD.n216 VDD.n153 0.450618
R619 VDD.n222 VDD.n152 0.450618
R620 VDD.n234 VDD.n150 0.450618
R621 VDD.n246 VDD.n148 0.450618
R622 VDD.n252 VDD.n147 0.450618
R623 VDD.n264 VDD.n145 0.450618
R624 VDD.n276 VDD.n143 0.450618
R625 VDD.n282 VDD.n142 0.450618
R626 VDD.n288 VDD.n141 0.450618
R627 VDD.n294 VDD.n140 0.450618
R628 VDD.n300 VDD.n139 0.450618
R629 VDD.n306 VDD.n138 0.450618
R630 VDD.n312 VDD.n137 0.450618
R631 VDD.n318 VDD.n136 0.450618
R632 VDD.n324 VDD.n135 0.450618
R633 VDD.n330 VDD.n134 0.450618
R634 VDD.n8 VDD.n31 0.445771
R635 VDD.n394 VDD.n393 0.43335
R636 VDD.n61 VDD.n27 0.0930507
R637 VDD.n53 VDD.n87 0.429929
R638 VDD.n30 VDD.n12 0.427147
R639 VDD.n12 VDD.n8 0.427147
R640 VDD.n84 VDD.n26 0.413465
R641 VDD.n85 VDD.n49 0.413465
R642 VDD.n394 VDD.n56 0.403558
R643 VDD.t10 VDD.t14 0.383639
R644 VDD.n372 VDD.n111 0.372571
R645 VDD.n376 VDD.n375 0.372436
R646 VDD.n323 VDD.n322 0.355452
R647 VDD.n335 VDD.n334 0.355452
R648 VDD.n209 VDD.n208 0.355312
R649 VDD.n233 VDD.n232 0.355312
R650 VDD.n275 VDD.n274 0.355312
R651 VDD.n317 VDD.n316 0.355155
R652 VDD.n341 VDD.n340 0.355155
R653 VDD.n167 VDD.n166 0.355155
R654 VDD.n173 VDD.n172 0.355155
R655 VDD.n179 VDD.n178 0.355155
R656 VDD.n185 VDD.n184 0.355155
R657 VDD.n227 VDD.n226 0.355155
R658 VDD.n269 VDD.n268 0.355155
R659 VDD.n305 VDD.n304 0.355155
R660 VDD.n370 VDD.n366 0.355071
R661 VDD.n257 VDD.n256 0.355071
R662 VDD.n263 VDD.n262 0.355071
R663 VDD.n287 VDD.n286 0.355071
R664 VDD.n311 VDD.n310 0.355071
R665 VDD.n197 VDD.n196 0.35501
R666 VDD.n251 VDD.n250 0.35501
R667 VDD.n191 VDD.n190 0.354936
R668 VDD.n221 VDD.n220 0.354936
R669 VDD.n293 VDD.n292 0.354936
R670 VDD.n239 VDD.n238 0.354837
R671 VDD.n203 VDD.n202 0.354771
R672 VDD.n245 VDD.n244 0.354771
R673 VDD.n281 VDD.n280 0.354771
R674 VDD.n299 VDD.n298 0.354771
R675 VDD.n329 VDD.n328 0.354771
R676 VDD.n11 VDD.n346 0.354771
R677 VDD.n215 VDD.n214 0.354697
R678 VDD.n367 VDD.n109 0.354692
R679 VDD.n381 VDD.n380 0.347886
R680 VDD.n377 VDD.n112 0.347655
R681 VDD.n371 VDD.n370 0.347254
R682 VDD.n367 VDD.n110 0.347254
R683 VDD.n105 VDD.n103 0.335799
R684 VDD.n93 VDD.n92 0.335496
R685 VDD.n387 VDD.n112 0.334692
R686 VDD.n385 VDD.n381 0.334483
R687 VDD.n96 VDD.n93 0.332368
R688 VDD.n105 VDD.n58 0.332058
R689 VDD.n383 VDD.n57 0.33018
R690 VDD.n375 VDD.n371 0.328947
R691 VDD.n372 VDD.n110 0.328947
R692 VDD.n355 VDD.n109 0.327655
R693 VDD.t111 VDD.n2 15.0851
R694 VDD.n100 VDD.n99 0.327354
R695 VDD.n366 VDD.n365 0.327271
R696 VDD.n51 VDD.n84 0.327154
R697 VDD.n35 VDD.n85 0.327154
R698 VDD.n359 VDD.n107 0.319294
R699 VDD.n31 VDD.n30 0.313013
R700 VDD.n218 VDD.n215 0.31015
R701 VDD.n206 VDD.n203 0.310071
R702 VDD.n248 VDD.n245 0.310071
R703 VDD.n284 VDD.n281 0.310071
R704 VDD.n302 VDD.n299 0.310071
R705 VDD.n332 VDD.n329 0.310071
R706 VDD.n242 VDD.n239 0.31001
R707 VDD.n380 VDD.n376 0.309928
R708 VDD.n194 VDD.n191 0.309928
R709 VDD.n224 VDD.n221 0.309928
R710 VDD.n296 VDD.n293 0.309928
R711 VDD.n254 VDD.n251 0.309837
R712 VDD.n200 VDD.n197 0.309837
R713 VDD.n377 VDD.n111 0.309771
R714 VDD.n260 VDD.n257 0.309771
R715 VDD.n266 VDD.n263 0.309771
R716 VDD.n290 VDD.n287 0.309771
R717 VDD.n314 VDD.n311 0.309771
R718 VDD.n170 VDD.n167 0.309692
R719 VDD.n176 VDD.n173 0.309692
R720 VDD.n182 VDD.n179 0.309692
R721 VDD.n188 VDD.n185 0.309692
R722 VDD.n230 VDD.n227 0.309692
R723 VDD.n272 VDD.n269 0.309692
R724 VDD.n308 VDD.n305 0.309692
R725 VDD.n320 VDD.n317 0.309692
R726 VDD.n344 VDD.n341 0.309692
R727 VDD.n212 VDD.n209 0.309557
R728 VDD.n236 VDD.n233 0.309557
R729 VDD.n278 VDD.n275 0.309557
R730 VDD.n326 VDD.n323 0.309405
R731 VDD.n338 VDD.n335 0.309405
R732 VDD.n82 VDD.n81 0.306614
R733 VDD.n91 VDD.n90 0.298721
R734 VDD VDD.n58 0.423614
R735 VDD.n4 VDD.t7 0.549201
R736 VDD.n115 VDD.n114 0.284268
R737 VDD.n116 VDD.n115 0.282549
R738 VDD.n99 VDD.n98 0.282297
R739 VDD.n76 VDD.n117 0.279247
R740 VDD.n67 VDD.n128 0.279247
R741 VDD.n162 VDD.n3 0.435454
R742 VDD.n4 VDD.n3 0.0990691
R743 VDD.n5 VDD.n114 0.268799
R744 VDD.n78 VDD.n76 0.267977
R745 VDD.n164 VDD.n4 0.527966
R746 VDD.n92 VDD.n91 0.260496
R747 VDD.n348 VDD.n107 0.25999
R748 VDD.n390 VDD.n389 0.253639
R749 VDD.n362 VDD.n361 0.253639
R750 VDD.n87 VDD.n49 0.25333
R751 VDD.n391 VDD.n390 0.253298
R752 VDD.n363 VDD.n362 0.253298
R753 VDD VDD.n57 0.250961
R754 VDD.n117 VDD.n116 0.241768
R755 VDD.n89 VDD.n62 4.71183
R756 VDD.n54 VDD.n53 0.706063
R757 VDD VDD.n56 0.521582
R758 VDD.n60 VDD.n59 0.484477
R759 VDD.n50 VDD.t109 15.0439
R760 VDD.n50 VDD.n49 0.130762
R761 VDD.n53 VDD.n36 0.291774
R762 VDD.n68 VDD.n67 0.222977
R763 VDD.n27 VDD.n52 0.109866
R764 VDD.n49 VDD.n48 0.0835447
R765 VDD.n36 VDD.n33 0.100238
R766 VDD.n102 VDD.n101 0.202075
R767 VDD.n365 VDD.n354 0.191924
R768 VDD.n355 VDD.n108 0.191793
R769 VDD.n391 VDD.n56 0.189333
R770 VDD.n385 VDD.n382 0.184424
R771 VDD.n387 VDD.n113 0.184424
R772 VDD.n120 VDD.n119 0.181058
R773 VDD.n357 VDD.n353 0.179888
R774 VDD.n101 VDD.n100 0.175486
R775 VDD.n98 VDD.n97 0.171736
R776 VDD.n352 VDD.n351 0.169888
R777 VDD.n124 VDD.n77 0.210474
R778 VDD.n177 VDD.n176 0.162388
R779 VDD.n183 VDD.n182 0.162388
R780 VDD.n207 VDD.n206 0.162388
R781 VDD.n231 VDD.n230 0.162388
R782 VDD.n237 VDD.n236 0.162388
R783 VDD.n261 VDD.n260 0.162388
R784 VDD.n267 VDD.n266 0.162388
R785 VDD.n285 VDD.n284 0.162388
R786 VDD.n327 VDD.n326 0.162388
R787 VDD.n165 VDD.n164 0.16205
R788 VDD.n171 VDD.n170 0.16205
R789 VDD.n189 VDD.n188 0.16205
R790 VDD.n195 VDD.n194 0.16205
R791 VDD.n201 VDD.n200 0.16205
R792 VDD.n213 VDD.n212 0.16205
R793 VDD.n219 VDD.n218 0.16205
R794 VDD.n225 VDD.n224 0.16205
R795 VDD.n243 VDD.n242 0.16205
R796 VDD.n249 VDD.n248 0.16205
R797 VDD.n255 VDD.n254 0.16205
R798 VDD.n273 VDD.n272 0.16205
R799 VDD.n279 VDD.n278 0.16205
R800 VDD.n291 VDD.n290 0.16205
R801 VDD.n297 VDD.n296 0.16205
R802 VDD.n303 VDD.n302 0.16205
R803 VDD.n309 VDD.n308 0.16205
R804 VDD.n315 VDD.n314 0.16205
R805 VDD.n321 VDD.n320 0.16205
R806 VDD.n333 VDD.n332 0.16205
R807 VDD.n339 VDD.n338 0.16205
R808 VDD.n345 VDD.n344 0.16205
R809 VDD.n393 VDD.n382 0.161924
R810 VDD.n383 VDD.n113 0.161924
R811 VDD.n28 VDD 0.485468
R812 VDD.n37 VDD.n14 0.0957379
R813 VDD.n121 VDD.n120 0.159043
R814 VDD.n6 VDD.n5 0.892484
R815 VDD.n130 VDD.n129 0.157388
R816 VDD.n126 VDD.n7 0.892484
R817 VDD.n359 VDD.n108 0.154552
R818 VDD.n357 VDD.n354 0.154424
R819 VDD.n58 VDD.n104 0.152808
R820 VDD.n96 VDD.n95 0.152808
R821 VDD.n96 VDD.n94 0.152808
R822 VDD.n123 VDD.n118 0.15205
R823 VDD.n127 VDD.n60 0.15205
R824 VDD.n97 VDD.n96 0.147075
R825 VDD.n42 VDD.n122 0.236924
R826 VDD.n125 VDD.n123 0.134888
R827 VDD.n41 VDD.n40 0.134618
R828 VDD.n52 VDD.n51 0.133259
R829 VDD.n78 VDD.n77 0.16225
R830 VDD.n64 VDD.n63 0.128884
R831 VDD.n1 VDD.n0 0.128884
R832 VDD.n25 VDD.n66 0.142085
R833 VDD.n70 VDD.n69 0.128884
R834 VDD.n24 VDD.n72 0.142085
R835 VDD.n81 VDD.n80 0.127628
R836 VDD.n16 VDD.n121 0.947265
R837 VDD.n129 VDD.n68 0.1583
R838 VDD.n125 VDD.n124 0.12205
R839 VDD.n351 VDD.n350 0.11955
R840 VDD.n166 VDD.n165 0.117388
R841 VDD.n172 VDD.n171 0.117388
R842 VDD.n190 VDD.n189 0.117388
R843 VDD.n196 VDD.n195 0.117388
R844 VDD.n202 VDD.n201 0.117388
R845 VDD.n214 VDD.n213 0.117388
R846 VDD.n220 VDD.n219 0.117388
R847 VDD.n226 VDD.n225 0.117388
R848 VDD.n244 VDD.n243 0.117388
R849 VDD.n250 VDD.n249 0.117388
R850 VDD.n256 VDD.n255 0.117388
R851 VDD.n274 VDD.n273 0.117388
R852 VDD.n280 VDD.n279 0.117388
R853 VDD.n292 VDD.n291 0.117388
R854 VDD.n298 VDD.n297 0.117388
R855 VDD.n304 VDD.n303 0.117388
R856 VDD.n310 VDD.n309 0.117388
R857 VDD.n316 VDD.n315 0.117388
R858 VDD.n322 VDD.n321 0.117388
R859 VDD.n334 VDD.n333 0.117388
R860 VDD.n340 VDD.n339 0.117388
R861 VDD.n346 VDD.n345 0.117388
R862 VDD.n353 VDD.n352 0.11705
R863 VDD.n178 VDD.n177 0.11705
R864 VDD.n184 VDD.n183 0.11705
R865 VDD.n208 VDD.n207 0.11705
R866 VDD.n232 VDD.n231 0.11705
R867 VDD.n238 VDD.n237 0.11705
R868 VDD.n262 VDD.n261 0.11705
R869 VDD.n268 VDD.n267 0.11705
R870 VDD.n286 VDD.n285 0.11705
R871 VDD.n328 VDD.n327 0.11705
R872 VDD.n40 VDD.n118 0.104888
R873 VDD.n128 VDD.n127 0.101138
R874 VDD.n50 VDD.n86 0.340529
R875 VDD.n36 VDD.n35 0.251665
R876 VDD.n119 VDD.n39 0.24736
R877 VDD.n73 VDD.n47 0.224985
R878 VDD.n74 VDD.n46 0.224985
R879 VDD.n45 VDD.n44 0.224985
R880 VDD.n75 VDD.n43 0.224985
R881 VDD.n15 VDD.n14 0.211235
R882 VDD.n88 VDD.n49 0.205524
R883 VDD.n26 VDD.t104 15.0336
R884 VDD.n22 VDD.t0 1.35979
R885 VDD.n12 VDD.n11 1.26355
R886 VDD.n13 VDD.n1 0.366115
R887 VDD.t0 VDD.n20 1.2395
R888 VDD.n18 VDD.t0 1.20634
R889 VDD.n32 VDD.n26 1.17026
R890 VDD.n3 VDD.n2 1.10286
R891 VDD.n64 VDD.n6 1.09758
R892 VDD.n70 VDD.n7 1.09757
R893 VDD.n64 VDD.n13 0.547841
R894 VDD.n19 VDD.n18 0.432615
R895 VDD.n21 VDD.n20 0.409065
R896 VDD.n347 VDD.n31 1.0694
R897 VDD.n65 VDD.n1 1.04243
R898 VDD.n45 VDD.n21 1.01698
R899 VDD.n47 VDD.n19 1.01698
R900 VDD.n43 VDD.n22 1.01673
R901 VDD.n46 VDD.t0 1.01673
R902 VSS.t460 VSS.n520 119321
R903 VSS.n591 VSS.n590 22369.4
R904 VSS.n426 VSS.n294 7907.02
R905 VSS.n516 VSS.n189 4670.31
R906 VSS.n852 VSS.n851 3068.57
R907 VSS.t285 VSS.n55 310.202
R908 VSS.t6 VSS.n60 310.202
R909 VSS.t218 VSS.n583 849.322
R910 VSS.n644 VSS.n643 572.005
R911 VSS.t334 VSS.t41 571.348
R912 VSS.n659 VSS.t360 566.691
R913 VSS.n658 VSS.t374 560.899
R914 VSS.n648 VSS.t509 550.193
R915 VSS.n675 VSS.t574 539.653
R916 VSS.t27 VSS.n656 532.819
R917 VSS.n678 VSS.t56 522.508
R918 VSS.n669 VSS.t329 521.236
R919 VSS.t498 VSS.n655 514.091
R920 VSS.n665 VSS.t277 504.839
R921 VSS.n651 VSS.t451 504.839
R922 VSS.n676 VSS.t58 491.87
R923 VSS.n660 VSS.t346 474.904
R924 VSS.t497 VSS.n594 470.019
R925 VSS.n215 VSS.n214 469.783
R926 VSS.n229 VSS.n228 469.783
R927 VSS.n247 VSS.n246 469.783
R928 VSS.n265 VSS.n264 469.783
R929 VSS.n282 VSS.n281 469.783
R930 VSS.n300 VSS.n299 469.783
R931 VSS.n661 VSS.t251 456.175
R932 VSS.n202 VSS.n199 454.007
R933 VSS.n903 VSS.n902 454.007
R934 VSS.n894 VSS.n893 454.007
R935 VSS.n885 VSS.n884 454.007
R936 VSS.n270 VSS.n267 454.007
R937 VSS.n287 VSS.n284 454.007
R938 VSS.n205 VSS.n204 453.986
R939 VSS.n900 VSS.n899 453.986
R940 VSS.n891 VSS.n890 453.986
R941 VSS.n882 VSS.n881 453.986
R942 VSS.n273 VSS.n272 453.986
R943 VSS.n290 VSS.n289 453.986
R944 VSS.n212 VSS.n205 453.986
R945 VSS.n899 VSS.n219 453.986
R946 VSS.n890 VSS.n233 453.986
R947 VSS.n881 VSS.n256 453.986
R948 VSS.n279 VSS.n273 453.986
R949 VSS.n297 VSS.n290 453.986
R950 VSS.t567 VSS.n242 448.228
R951 VSS.t614 VSS.n181 442.469
R952 VSS.t111 VSS.n183 437.62
R953 VSS.n250 VSS.t224 431.863
R954 VSS.t578 VSS.n53 427.695
R955 VSS.n655 VSS.t503 427.219
R956 VSS.t108 VSS.n251 419.459
R957 VSS.t179 VSS.n296 413.68
R958 VSS.t168 VSS.n278 413.68
R959 VSS.t158 VSS.n262 413.68
R960 VSS.t147 VSS.n244 413.68
R961 VSS.t136 VSS.n226 413.68
R962 VSS.t126 VSS.n211 413.68
R963 VSS.n663 VSS.n662 412.791
R964 VSS.n649 VSS.n61 412.791
R965 VSS.n828 VSS.n827 412.522
R966 VSS.n196 VSS.t112 403.072
R967 VSS.t581 VSS.n676 401.591
R968 VSS.n250 VSS.t566 397.313
R969 VSS.n194 VSS.t261 391.555
R970 VSS.t218 VSS.n829 388.781
R971 VSS.t122 VSS.n212 385.798
R972 VSS.t132 VSS.n219 385.798
R973 VSS.t143 VSS.n233 385.798
R974 VSS.t154 VSS.n256 385.798
R975 VSS.t164 VSS.n279 385.798
R976 VSS.t175 VSS.n297 385.798
R977 VSS.n191 VSS.t615 384.887
R978 VSS.n192 VSS.t348 380.038
R979 VSS.t82 VSS.n54 375.276
R980 VSS.t504 VSS.n663 372.094
R981 VSS.t505 VSS.n649 372.094
R982 VSS.t285 VSS.n668 363.339
R983 VSS.t6 VSS.n654 363.339
R984 VSS.t12 VSS.t217 359.769
R985 VSS.t351 VSS.n187 357.007
R986 VSS.n645 VSS.t582 347.49
R987 VSS.t352 VSS.n185 333.974
R988 VSS.n191 VSS.t110 333.065
R989 VSS.t127 VSS.n211 333.063
R990 VSS.t137 VSS.n226 333.063
R991 VSS.t148 VSS.n244 333.063
R992 VSS.t159 VSS.n262 333.063
R993 VSS.t169 VSS.n278 333.063
R994 VSS.n296 VSS.t180 333.063
R995 VSS.t511 VSS.n598 329.238
R996 VSS.n808 VSS.t334 327.81
R997 VSS.t79 VSS.n179 322.457
R998 VSS.n253 VSS.t571 322.457
R999 VSS.t460 VSS.n850 314.327
R1000 VSS.n679 VSS.t55 313.659
R1001 VSS.n204 VSS.t120 305.183
R1002 VSS.n900 VSS.t130 305.183
R1003 VSS.n891 VSS.t141 305.183
R1004 VSS.n882 VSS.t152 305.183
R1005 VSS.n272 VSS.t162 305.183
R1006 VSS.n289 VSS.t173 305.183
R1007 VSS.t361 VSS.t327 304.42
R1008 VSS.t276 VSS.n666 304.42
R1009 VSS.t9 VSS.t211 304.42
R1010 VSS.t450 VSS.n652 304.42
R1011 VSS.t573 VSS.n678 299.735
R1012 VSS.n195 VSS.t613 299.425
R1013 VSS.t117 VSS.n202 293.666
R1014 VSS.n902 VSS.t128 293.666
R1015 VSS.n893 VSS.t138 293.666
R1016 VSS.n884 VSS.t149 293.666
R1017 VSS.t160 VSS.n270 293.666
R1018 VSS.t170 VSS.n287 293.666
R1019 VSS.n301 VSS.t187 292.757
R1020 VSS.t304 VSS.n277 292.757
R1021 VSS.t63 VSS.n261 292.757
R1022 VSS.t609 VSS.n240 292.757
R1023 VSS.t195 VSS.n243 292.757
R1024 VSS.t197 VSS.n225 292.757
R1025 VSS.t60 VSS.n210 292.757
R1026 VSS.t607 VSS.n177 292.757
R1027 VSS.t611 VSS.n665 291.37
R1028 VSS.t193 VSS.n651 291.37
R1029 VSS.n195 VSS.t616 287.909
R1030 VSS.n198 VSS.t507 275.505
R1031 VSS.t104 VSS.n181 269.724
R1032 VSS.t81 VSS.n179 264.875
R1033 VSS.n253 VSS.t572 264.875
R1034 VSS.t188 VSS.n294 258.238
R1035 VSS.n249 VSS.t196 258.236
R1036 VSS.n885 VSS.t610 258.233
R1037 VSS.n894 VSS.t198 258.233
R1038 VSS.n903 VSS.t61 258.233
R1039 VSS.n199 VSS.t608 258.233
R1040 VSS.n267 VSS.t64 258.233
R1041 VSS.n284 VSS.t305 258.233
R1042 VSS.t263 VSS.n184 258.231
R1043 VSS.t103 VSS.n185 253.359
R1044 VSS.n85 VSS.t257 252.375
R1045 VSS.n91 VSS.t453 252.375
R1046 VSS.t300 VSS.n94 252.375
R1047 VSS.t506 VSS.n111 252.375
R1048 VSS.t562 VSS.n114 252.375
R1049 VSS.t237 VSS.n110 252.375
R1050 VSS.t48 VSS.n109 252.375
R1051 VSS.n108 VSS.t194 252.375
R1052 VSS.t601 VSS.n105 252.375
R1053 VSS.t284 VSS.n104 252.375
R1054 VSS.t454 VSS.n100 252.375
R1055 VSS.t533 VSS.n134 252.375
R1056 VSS.t273 VSS.n146 252.375
R1057 VSS.n162 VSS.t557 252.374
R1058 VSS.n159 VSS.t116 252.374
R1059 VSS.n155 VSS.t579 252.374
R1060 VSS.n154 VSS.t333 252.374
R1061 VSS.t455 VSS.n116 252.117
R1062 VSS.t71 VSS.n121 252.117
R1063 VSS.n123 VSS.t267 252.117
R1064 VSS.t59 VSS.n126 252.117
R1065 VSS.t500 VSS.n103 252.117
R1066 VSS.n133 VSS.t378 252.117
R1067 VSS.n136 VSS.t66 252.117
R1068 VSS.t115 VSS.n138 252.117
R1069 VSS.t604 VSS.n140 252.117
R1070 VSS.n142 VSS.t100 252.117
R1071 VSS.t612 VSS.n145 252.117
R1072 VSS.n87 VSS.t594 252.117
R1073 VSS.n165 VSS.t369 252.115
R1074 VSS.n161 VSS.t365 252.115
R1075 VSS.n158 VSS.t32 252.115
R1076 VSS.t428 VSS.n343 250.837
R1077 VSS.t384 VSS.n344 250.837
R1078 VSS.t387 VSS.n348 250.837
R1079 VSS.t430 VSS.n349 250.837
R1080 VSS.t429 VSS.n353 250.837
R1081 VSS.t382 VSS.n354 250.837
R1082 VSS.t393 VSS.n358 250.837
R1083 VSS.t431 VSS.n359 250.837
R1084 VSS.t392 VSS.n363 250.837
R1085 VSS.t432 VSS.n364 250.837
R1086 VSS.t391 VSS.n368 250.837
R1087 VSS.t433 VSS.n369 250.837
R1088 VSS.t434 VSS.n373 250.837
R1089 VSS.t388 VSS.n374 250.837
R1090 VSS.t390 VSS.n378 250.837
R1091 VSS.t437 VSS.n379 250.837
R1092 VSS.t438 VSS.n383 250.837
R1093 VSS.t439 VSS.n384 250.837
R1094 VSS.t435 VSS.n388 250.837
R1095 VSS.t441 VSS.n389 250.837
R1096 VSS.t443 VSS.n393 250.837
R1097 VSS.t440 VSS.n394 250.837
R1098 VSS.t436 VSS.n398 250.837
R1099 VSS.t444 VSS.n399 250.837
R1100 VSS.t385 VSS.n403 250.837
R1101 VSS.t445 VSS.n404 250.837
R1102 VSS.t389 VSS.n408 250.837
R1103 VSS.t381 VSS.n409 250.837
R1104 VSS.t386 VSS.n413 250.837
R1105 VSS.t446 VSS.n414 250.837
R1106 VSS.t447 VSS.n418 250.837
R1107 VSS.t448 VSS.n419 250.837
R1108 VSS.t578 VSS.n55 148.06
R1109 VSS.t503 VSS.n60 148.06
R1110 VSS.n645 VSS.t511 243.244
R1111 VSS.n190 VSS.t101 240.956
R1112 VSS.t124 VSS.n213 240.956
R1113 VSS.t134 VSS.n227 240.956
R1114 VSS.t145 VSS.n245 240.956
R1115 VSS.t156 VSS.n263 240.956
R1116 VSS.t166 VSS.n280 240.956
R1117 VSS.t177 VSS.n298 240.956
R1118 VSS.n504 VSS.t35 234.114
R1119 VSS.n499 VSS.t376 234.114
R1120 VSS.n494 VSS.t600 234.114
R1121 VSS.n489 VSS.t597 234.114
R1122 VSS.n484 VSS.t270 234.114
R1123 VSS.n479 VSS.t74 234.114
R1124 VSS.n474 VSS.t222 234.114
R1125 VSS.n469 VSS.t624 234.114
R1126 VSS.n464 VSS.t595 234.114
R1127 VSS.n459 VSS.t539 234.114
R1128 VSS.n454 VSS.t602 234.114
R1129 VSS.n449 VSS.t561 234.114
R1130 VSS.n444 VSS.t216 234.114
R1131 VSS.n439 VSS.t588 234.114
R1132 VSS.n434 VSS.t21 234.114
R1133 VSS.n429 VSS.t556 234.114
R1134 VSS.t347 VSS.n187 230.327
R1135 VSS.n214 VSS.t124 229.44
R1136 VSS.n228 VSS.t134 229.44
R1137 VSS.n246 VSS.t145 229.44
R1138 VSS.n264 VSS.t156 229.44
R1139 VSS.n281 VSS.t166 229.44
R1140 VSS.n299 VSS.t177 229.44
R1141 VSS.t101 VSS.n189 228.827
R1142 VSS.t558 VSS.n113 225.361
R1143 VSS.t375 VSS.n118 225.361
R1144 VSS.t598 VSS.n106 225.361
R1145 VSS.t72 VSS.n129 225.361
R1146 VSS.t220 VSS.n131 225.361
R1147 VSS.t623 VSS.n99 225.361
R1148 VSS.t596 VSS.n98 225.361
R1149 VSS.t540 VSS.n96 225.361
R1150 VSS.t560 VSS.n141 225.361
R1151 VSS.t214 VSS.n89 225.361
R1152 VSS.t19 VSS.n86 225.361
R1153 VSS.n167 VSS.t33 225.359
R1154 VSS.n164 VSS.t599 225.359
R1155 VSS.n163 VSS.t271 225.359
R1156 VSS.n156 VSS.t603 225.359
R1157 VSS.n153 VSS.t586 225.359
R1158 VSS.t582 VSS.n644 224.516
R1159 VSS.t569 VSS.n34 216.093
R1160 VSS.n850 VSS.t569 215.731
R1161 VSS.t608 VSS.n177 212.143
R1162 VSS.t61 VSS.n210 212.143
R1163 VSS.t198 VSS.n225 212.143
R1164 VSS.t196 VSS.n243 212.143
R1165 VSS.t610 VSS.n240 212.143
R1166 VSS.t64 VSS.n261 212.143
R1167 VSS.t305 VSS.n277 212.143
R1168 VSS.n301 VSS.t188 212.143
R1169 VSS.n168 VSS.t319 211.982
R1170 VSS.n166 VSS.t308 211.982
R1171 VSS.n160 VSS.t617 211.982
R1172 VSS.n152 VSS.t301 211.982
R1173 VSS.n119 VSS.t183 211.982
R1174 VSS.n122 VSS.t244 211.982
R1175 VSS.n124 VSS.t314 211.982
R1176 VSS.n127 VSS.t247 211.982
R1177 VSS.t362 VSS.n102 211.982
R1178 VSS.t513 VSS.n101 211.982
R1179 VSS.t583 VSS.n97 211.982
R1180 VSS.t322 VSS.n95 211.982
R1181 VSS.t575 VSS.n93 211.982
R1182 VSS.t366 VSS.n92 211.982
R1183 VSS.n143 VSS.t68 211.982
R1184 VSS.t190 VSS.n88 211.982
R1185 VSS.n677 VSS.t581 208.828
R1186 VSS.n192 VSS.t347 207.294
R1187 VSS.n679 VSS.t573 202.362
R1188 VSS.n664 VSS.t504 202.071
R1189 VSS.n650 VSS.t505 202.071
R1190 VSS.n186 VSS.t103 200.649
R1191 VSS.n591 VSS.n0 197.518
R1192 VSS.n669 VSS.t82 196.911
R1193 VSS.n666 VSS.t611 196.399
R1194 VSS.n652 VSS.t193 196.399
R1195 VSS.n194 VSS.t263 195.778
R1196 VSS.t620 VSS.n115 195.26
R1197 VSS.t288 VSS.n117 195.26
R1198 VSS.t554 VSS.n120 195.26
R1199 VSS.t51 VSS.n107 195.26
R1200 VSS.t534 VSS.n125 195.26
R1201 VSS.t606 VSS.n128 195.26
R1202 VSS.t239 VSS.n130 195.26
R1203 VSS.t565 VSS.n132 195.26
R1204 VSS.t39 VSS.n135 195.26
R1205 VSS.t326 VSS.n137 195.26
R1206 VSS.t105 VSS.n139 195.26
R1207 VSS.t23 VSS.n90 195.26
R1208 VSS.t537 VSS.n144 195.26
R1209 VSS.t201 VSS.n147 195.26
R1210 VSS.t541 VSS.n84 195.26
R1211 VSS.n157 VSS.t289 195.26
R1212 VSS.t507 VSS.n178 194.899
R1213 VSS.n830 VSS.t218 194.514
R1214 VSS.t572 VSS.n241 189.137
R1215 VSS.n198 VSS.t81 189.135
R1216 VSS.t55 VSS.n592 187.895
R1217 VSS.n505 VSS.t113 187.292
R1218 VSS.n500 VSS.t255 187.292
R1219 VSS.n495 VSS.t181 187.292
R1220 VSS.n490 VSS.t99 187.292
R1221 VSS.n485 VSS.t84 187.292
R1222 VSS.n480 VSS.t457 187.292
R1223 VSS.n475 VSS.t292 187.292
R1224 VSS.n470 VSS.t550 187.292
R1225 VSS.n465 VSS.t568 187.292
R1226 VSS.n460 VSS.t268 187.292
R1227 VSS.n455 VSS.t209 187.292
R1228 VSS.n450 VSS.t86 187.292
R1229 VSS.n445 VSS.t47 187.292
R1230 VSS.n440 VSS.t559 187.292
R1231 VSS.n435 VSS.t199 187.292
R1232 VSS.n430 VSS.t45 187.292
R1233 VSS.n196 VSS.t104 184.262
R1234 VSS.t250 VSS.n661 183.975
R1235 VSS.n667 VSS.t276 182.797
R1236 VSS.n653 VSS.t450 182.797
R1237 VSS.t530 VSS.n4 177.685
R1238 VSS.n178 VSS.t607 177.617
R1239 VSS.n241 VSS.t609 177.617
R1240 VSS.n216 VSS.t60 177.615
R1241 VSS.n230 VSS.t197 177.615
R1242 VSS.n248 VSS.t195 177.615
R1243 VSS.n266 VSS.t63 177.615
R1244 VSS.n283 VSS.t304 177.615
R1245 VSS.t187 VSS.n295 177.615
R1246 VSS.t517 VSS.n347 173.913
R1247 VSS.t372 VSS.n352 173.913
R1248 VSS.t235 VSS.n357 173.913
R1249 VSS.t91 VSS.n362 173.913
R1250 VSS.t318 VSS.n367 173.913
R1251 VSS.n372 VSS.t299 173.913
R1252 VSS.t307 VSS.n377 173.913
R1253 VSS.t590 VSS.n382 173.913
R1254 VSS.t232 VSS.n387 173.913
R1255 VSS.t77 VSS.n392 173.913
R1256 VSS.t312 VSS.n397 173.913
R1257 VSS.t30 VSS.n402 173.913
R1258 VSS.t230 VSS.n407 173.913
R1259 VSS.t593 VSS.n412 173.913
R1260 VSS.n417 VSS.t354 173.913
R1261 VSS.t296 VSS.n422 173.913
R1262 VSS.n426 VSS.n424 173.913
R1263 VSS.t10 VSS.n648 167.954
R1264 VSS.t320 VSS.t621 163.881
R1265 VSS.t309 VSS.t287 163.881
R1266 VSS.t184 VSS.t553 163.881
R1267 VSS.t245 VSS.t53 163.881
R1268 VSS.t315 VSS.t535 163.881
R1269 VSS.t248 VSS.t605 163.881
R1270 VSS.t363 VSS.t241 163.881
R1271 VSS.t514 VSS.t564 163.881
R1272 VSS.t618 VSS.t37 163.881
R1273 VSS.t584 VSS.t325 163.881
R1274 VSS.t323 VSS.t290 163.881
R1275 VSS.t576 VSS.t106 163.881
R1276 VSS.t367 VSS.t25 163.881
R1277 VSS.t69 VSS.t536 163.881
R1278 VSS.t191 VSS.t202 163.881
R1279 VSS.t302 VSS.t542 163.881
R1280 VSS.n203 VSS.t117 160.341
R1281 VSS.n217 VSS.t128 160.341
R1282 VSS.n231 VSS.t138 160.341
R1283 VSS.n254 VSS.t149 160.341
R1284 VSS.n271 VSS.t160 160.341
R1285 VSS.n288 VSS.t170 160.341
R1286 VSS.t548 VSS.n172 157.601
R1287 VSS.n173 VSS.t546 156.464
R1288 VSS.t379 VSS.n119 155.126
R1289 VSS.t282 VSS.n122 155.126
R1290 VSS.t331 VSS.n124 155.126
R1291 VSS.t349 VSS.n127 155.126
R1292 VSS.t93 VSS.n102 155.126
R1293 VSS.t355 VSS.n101 155.126
R1294 VSS.t274 VSS.n97 155.126
R1295 VSS.t552 VSS.n95 155.126
R1296 VSS.t555 VSS.n93 155.126
R1297 VSS.t496 VSS.n92 155.126
R1298 VSS.t280 VSS.n143 155.126
R1299 VSS.t345 VSS.n88 155.126
R1300 VSS.n168 VSS.t253 155.125
R1301 VSS.n166 VSS.t259 155.125
R1302 VSS.n160 VSS.t283 155.125
R1303 VSS.n152 VSS.t242 155.125
R1304 VSS.n564 VSS.t471 154.613
R1305 VSS.n575 VSS.t478 154.613
R1306 VSS.t613 VSS.n182 153.971
R1307 VSS.n173 VSS.t206 153.851
R1308 VSS.n514 VSS.t97 153.846
R1309 VSS.n505 VSS.t516 153.846
R1310 VSS.n500 VSS.t371 153.846
R1311 VSS.n495 VSS.t234 153.846
R1312 VSS.n490 VSS.t90 153.846
R1313 VSS.n485 VSS.t317 153.846
R1314 VSS.n480 VSS.t298 153.846
R1315 VSS.n475 VSS.t306 153.846
R1316 VSS.n470 VSS.t589 153.846
R1317 VSS.n465 VSS.t231 153.846
R1318 VSS.n460 VSS.t76 153.846
R1319 VSS.n455 VSS.t311 153.846
R1320 VSS.n450 VSS.t29 153.846
R1321 VSS.n445 VSS.t229 153.846
R1322 VSS.n440 VSS.t592 153.846
R1323 VSS.n435 VSS.t353 153.846
R1324 VSS.n430 VSS.t295 153.846
R1325 VSS.t549 VSS.n83 153.236
R1326 VSS.t616 VSS.n183 149.713
R1327 VSS.t120 VSS.n203 148.826
R1328 VSS.t130 VSS.n217 148.826
R1329 VSS.t141 VSS.n231 148.826
R1330 VSS.t152 VSS.n254 148.826
R1331 VSS.t162 VSS.n271 148.826
R1332 VSS.t173 VSS.n288 148.826
R1333 VSS.n6 VSS.t28 147.453
R1334 VSS.t264 VSS.n346 147.157
R1335 VSS.t622 VSS.n351 147.157
R1336 VSS.t563 VSS.n356 147.157
R1337 VSS.t207 VSS.n361 147.157
R1338 VSS.t2 VSS.n366 147.157
R1339 VSS.t186 VSS.n371 147.157
R1340 VSS.t370 VSS.n376 147.157
R1341 VSS.t88 VSS.n381 147.157
R1342 VSS.t49 VSS.n386 147.157
R1343 VSS.t580 VSS.n391 147.157
R1344 VSS.t212 VSS.n396 147.157
R1345 VSS.t0 VSS.n401 147.157
R1346 VSS.t14 VSS.n406 147.157
R1347 VSS.t293 VSS.n411 147.157
R1348 VSS.t67 VSS.n416 147.157
R1349 VSS.t531 VSS.n421 147.157
R1350 VSS.t494 VSS.n148 145.091
R1351 VSS.t327 VSS.n667 138.607
R1352 VSS.t211 VSS.n653 138.607
R1353 VSS.t490 VSS.n148 138.403
R1354 VSS.t180 VSS.n295 137.311
R1355 VSS.n283 VSS.t169 137.311
R1356 VSS.n266 VSS.t159 137.311
R1357 VSS.n248 VSS.t148 137.311
R1358 VSS.n230 VSS.t137 137.311
R1359 VSS.n216 VSS.t127 137.311
R1360 VSS.t110 VSS.n190 137.309
R1361 VSS.n643 VSS.n600 132.891
R1362 VSS.n151 VSS.t490 131.971
R1363 VSS.n180 VSS.t79 130.939
R1364 VSS.t571 VSS.n252 130.939
R1365 VSS.n859 VSS.t16 127.421
R1366 VSS.t415 VSS.n1 125.359
R1367 VSS.t44 VSS.n855 123.674
R1368 VSS.n592 VSS.n591 122.129
R1369 VSS.n594 VSS.t12 121.858
R1370 VSS.t546 VSS.n83 120.691
R1371 VSS.n193 VSS.t352 119.422
R1372 VSS.n170 VSS.t547 118.249
R1373 VSS.n424 VSS.t494 117.058
R1374 VSS.n854 VSS.t266 116.177
R1375 VSS.t251 VSS.n660 115.831
R1376 VSS.t258 VSS.n584 112.174
R1377 VSS.t265 VSS.n857 108.683
R1378 VSS.n643 VSS.n642 107.178
R1379 VSS.t253 VSS.n507 107.023
R1380 VSS.n504 VSS.t264 107.023
R1381 VSS.t259 VSS.n502 107.023
R1382 VSS.n499 VSS.t622 107.023
R1383 VSS.n497 VSS.t379 107.023
R1384 VSS.n494 VSS.t563 107.023
R1385 VSS.n492 VSS.t282 107.023
R1386 VSS.n489 VSS.t207 107.023
R1387 VSS.n487 VSS.t331 107.023
R1388 VSS.n484 VSS.t2 107.023
R1389 VSS.n482 VSS.t349 107.023
R1390 VSS.n479 VSS.t186 107.023
R1391 VSS.n477 VSS.t93 107.023
R1392 VSS.n474 VSS.t370 107.023
R1393 VSS.n472 VSS.t355 107.023
R1394 VSS.n469 VSS.t88 107.023
R1395 VSS.t283 VSS.n467 107.023
R1396 VSS.n464 VSS.t49 107.023
R1397 VSS.n462 VSS.t274 107.023
R1398 VSS.n459 VSS.t580 107.023
R1399 VSS.n457 VSS.t552 107.023
R1400 VSS.n454 VSS.t212 107.023
R1401 VSS.n452 VSS.t555 107.023
R1402 VSS.n449 VSS.t0 107.023
R1403 VSS.n447 VSS.t496 107.023
R1404 VSS.n444 VSS.t14 107.023
R1405 VSS.n442 VSS.t280 107.023
R1406 VSS.n439 VSS.t293 107.023
R1407 VSS.n437 VSS.t345 107.023
R1408 VSS.n434 VSS.t67 107.023
R1409 VSS.t242 VSS.n432 107.023
R1410 VSS.n429 VSS.t531 107.023
R1411 VSS.t501 VSS.n852 106.808
R1412 VSS.n674 VSS.t497 103.538
R1413 VSS.n681 VSS.t238 103.379
R1414 VSS.n514 VSS.t484 100.335
R1415 VSS.t516 VSS.n346 100.335
R1416 VSS.t371 VSS.n351 100.335
R1417 VSS.t234 VSS.n356 100.335
R1418 VSS.t90 VSS.n361 100.335
R1419 VSS.t317 VSS.n366 100.335
R1420 VSS.t298 VSS.n371 100.335
R1421 VSS.t306 VSS.n376 100.335
R1422 VSS.t589 VSS.n381 100.335
R1423 VSS.t231 VSS.n386 100.335
R1424 VSS.t76 VSS.n391 100.335
R1425 VSS.t311 VSS.n396 100.335
R1426 VSS.t29 VSS.n401 100.335
R1427 VSS.t229 VSS.n406 100.335
R1428 VSS.t592 VSS.n411 100.335
R1429 VSS.t353 VSS.n416 100.335
R1430 VSS.t295 VSS.n421 100.335
R1431 VSS.n564 VSS.t474 99.7511
R1432 VSS.n575 VSS.t480 99.7511
R1433 VSS.n680 VSS.t330 98.4633
R1434 VSS.t474 VSS.n1 97.9276
R1435 VSS.t480 VSS.n3 97.9273
R1436 VSS.t346 VSS.n659 97.5777
R1437 VSS.t204 VSS.n861 97.4396
R1438 VSS.n188 VSS.t351 96.3896
R1439 VSS.n172 VSS.t18 93.8889
R1440 VSS.n861 VSS.t502 93.6919
R1441 VSS.n151 VSS.t296 88.495
R1442 VSS.n169 VSS.t544 88.4111
R1443 VSS.t56 VSS.n677 88.3462
R1444 VSS.n165 VSS.t372 88.2366
R1445 VSS.n161 VSS.t307 88.2366
R1446 VSS.n158 VSS.t77 88.2366
R1447 VSS.n116 VSS.t517 88.2359
R1448 VSS.n121 VSS.t235 88.2359
R1449 VSS.n123 VSS.t91 88.2359
R1450 VSS.n126 VSS.t318 88.2359
R1451 VSS.t299 VSS.n103 88.2359
R1452 VSS.n133 VSS.t590 88.2359
R1453 VSS.n136 VSS.t232 88.2359
R1454 VSS.n138 VSS.t312 88.2359
R1455 VSS.n140 VSS.t30 88.2359
R1456 VSS.n142 VSS.t230 88.2359
R1457 VSS.n145 VSS.t593 88.2359
R1458 VSS.t354 VSS.n87 88.2359
R1459 VSS.n150 VSS.n426 88.2779
R1460 VSS.t484 VSS.t95 86.957
R1461 VSS.t97 VSS.t486 86.957
R1462 VSS.t277 VSS.n664 85.7923
R1463 VSS.t451 VSS.n650 85.7923
R1464 VSS.t615 VSS.n188 84.8733
R1465 VSS.t544 VSS.n516 83.0562
R1466 VSS.n857 VSS.t545 82.449
R1467 VSS.t58 VSS.n675 81.2384
R1468 VSS.n2 VSS.t415 80.4707
R1469 VSS.t225 VSS.n694 77.8798
R1470 VSS.n828 VSS.t357 77.2751
R1471 VSS.t543 VSS.t4 77.2751
R1472 VSS.n829 VSS.t217 75.4357
R1473 VSS.t545 VSS.n171 75.2962
R1474 VSS.t43 VSS.n854 74.9537
R1475 VSS.t95 VSS.n112 74.8587
R1476 VSS.n608 VSS.t42 74.7824
R1477 VSS.t348 VSS.n186 73.9692
R1478 VSS.t8 VSS.n585 73.536
R1479 VSS.n590 VSS.n586 73.536
R1480 VSS.n507 VSS.t320 70.2346
R1481 VSS.n502 VSS.t309 70.2346
R1482 VSS.n497 VSS.t184 70.2346
R1483 VSS.n492 VSS.t245 70.2346
R1484 VSS.n487 VSS.t315 70.2346
R1485 VSS.n482 VSS.t248 70.2346
R1486 VSS.n477 VSS.t363 70.2346
R1487 VSS.n472 VSS.t514 70.2346
R1488 VSS.n467 VSS.t618 70.2346
R1489 VSS.n462 VSS.t584 70.2346
R1490 VSS.n457 VSS.t323 70.2346
R1491 VSS.n452 VSS.t576 70.2346
R1492 VSS.n447 VSS.t367 70.2346
R1493 VSS.n442 VSS.t69 70.2346
R1494 VSS.n437 VSS.t191 70.2346
R1495 VSS.n432 VSS.t302 70.2346
R1496 VSS.n752 VSS.t520 69.1047
R1497 VSS.n213 VSS.t122 68.211
R1498 VSS.n227 VSS.t132 68.211
R1499 VSS.n245 VSS.t143 68.211
R1500 VSS.n263 VSS.t154 68.211
R1501 VSS.n280 VSS.t164 68.211
R1502 VSS.n298 VSS.t175 68.211
R1503 VSS.n855 VSS.t43 67.4583
R1504 VSS.t227 VSS.n710 66.9109
R1505 VSS.n506 VSS.t620 66.8901
R1506 VSS.t113 VSS.n344 66.8901
R1507 VSS.n501 VSS.t288 66.8901
R1508 VSS.t255 VSS.n349 66.8901
R1509 VSS.n496 VSS.t554 66.8901
R1510 VSS.t181 VSS.n354 66.8901
R1511 VSS.n491 VSS.t51 66.8901
R1512 VSS.t99 VSS.n359 66.8901
R1513 VSS.n486 VSS.t534 66.8901
R1514 VSS.t84 VSS.n364 66.8901
R1515 VSS.n481 VSS.t606 66.8901
R1516 VSS.t457 VSS.n369 66.8901
R1517 VSS.n476 VSS.t239 66.8901
R1518 VSS.t292 VSS.n374 66.8901
R1519 VSS.n471 VSS.t565 66.8901
R1520 VSS.t550 VSS.n379 66.8901
R1521 VSS.n466 VSS.t39 66.8901
R1522 VSS.t568 VSS.n384 66.8901
R1523 VSS.n461 VSS.t326 66.8901
R1524 VSS.t268 VSS.n389 66.8901
R1525 VSS.t289 VSS.n456 66.8901
R1526 VSS.t209 VSS.n394 66.8901
R1527 VSS.n451 VSS.t105 66.8901
R1528 VSS.t86 VSS.n399 66.8901
R1529 VSS.n446 VSS.t23 66.8901
R1530 VSS.t47 VSS.n404 66.8901
R1531 VSS.n441 VSS.t537 66.8901
R1532 VSS.t559 VSS.n409 66.8901
R1533 VSS.n436 VSS.t201 66.8901
R1534 VSS.t199 VSS.n414 66.8901
R1535 VSS.n431 VSS.t541 66.8901
R1536 VSS.t45 VSS.n419 66.8901
R1537 VSS.t405 VSS.n636 65.3749
R1538 VSS.n642 VSS.t394 65.3649
R1539 VSS.t18 VSS.n859 63.7107
R1540 VSS.t502 VSS.n860 62.4441
R1541 VSS.n635 VSS.t409 62.1558
R1542 VSS.t261 VSS.n193 61.8407
R1543 VSS.n590 VSS.n589 59.3547
R1544 VSS.n862 VSS.t204 58.6964
R1545 VSS.n734 VSS.t525 58.1358
R1546 VSS.t42 VSS.n600 58.1084
R1547 VSS.t28 VSS.n3 58.0281
R1548 VSS.n656 VSS.t498 57.9156
R1549 VSS.t566 VSS.n242 56.6734
R1550 VSS.n215 VSS.t126 56.0825
R1551 VSS.n229 VSS.t136 56.0825
R1552 VSS.n247 VSS.t147 56.0825
R1553 VSS.n265 VSS.t158 56.0825
R1554 VSS.n282 VSS.t168 56.0825
R1555 VSS.n300 VSS.t179 56.0825
R1556 VSS.t522 VSS.n726 55.942
R1557 VSS.t401 VSS.n638 55.7348
R1558 VSS.n640 VSS.t399 55.7328
R1559 VSS.t547 VSS.n169 54.6841
R1560 VSS.t460 VSS.n519 53.7482
R1561 VSS.n608 VSS.t219 52.3478
R1562 VSS.t329 VSS.n53 51.2456
R1563 VSS.t112 VSS.n180 50.3244
R1564 VSS.n252 VSS.t108 50.3244
R1565 VSS.t319 VSS.n343 50.1677
R1566 VSS.t308 VSS.n348 50.1677
R1567 VSS.t183 VSS.n353 50.1677
R1568 VSS.t244 VSS.n358 50.1677
R1569 VSS.t314 VSS.n363 50.1677
R1570 VSS.t247 VSS.n368 50.1677
R1571 VSS.n373 VSS.t362 50.1677
R1572 VSS.n378 VSS.t513 50.1677
R1573 VSS.t617 VSS.n383 50.1677
R1574 VSS.n388 VSS.t583 50.1677
R1575 VSS.n393 VSS.t322 50.1677
R1576 VSS.n398 VSS.t575 50.1677
R1577 VSS.n403 VSS.t366 50.1677
R1578 VSS.t68 VSS.n408 50.1677
R1579 VSS.n413 VSS.t190 50.1677
R1580 VSS.t301 VSS.n418 50.1677
R1581 VSS.n768 VSS.t463 49.3606
R1582 VSS.n858 VSS.t265 47.4535
R1583 VSS.t226 VSS.n701 47.1669
R1584 VSS.n718 VSS.t228 47.1669
R1585 VSS.n680 VSS.t8 46.116
R1586 VSS.t397 VSS.n640 46.1011
R1587 VSS.n638 VSS.t403 46.1002
R1588 VSS.t518 VSS.n744 44.9731
R1589 VSS.n668 VSS.t361 44.1903
R1590 VSS.n654 VSS.t9 44.1903
R1591 VSS.t478 VSS.n2 43.0639
R1592 VSS.t471 VSS.n0 43.0619
R1593 VSS.t357 VSS.n584 42.3769
R1594 VSS.t266 VSS.n853 39.9582
R1595 VSS.t407 VSS.n635 39.6785
R1596 VSS.n657 VSS.t27 39.1873
R1597 VSS.n745 VSS.t518 38.3917
R1598 VSS.n509 VSS.t558 36.7898
R1599 VSS.t33 VSS.n503 36.7898
R1600 VSS.n498 VSS.t375 36.7898
R1601 VSS.t599 VSS.n493 36.7898
R1602 VSS.n488 VSS.t598 36.7898
R1603 VSS.t271 VSS.n483 36.7898
R1604 VSS.n478 VSS.t72 36.7898
R1605 VSS.n473 VSS.t220 36.7898
R1606 VSS.n468 VSS.t623 36.7898
R1607 VSS.n463 VSS.t596 36.7898
R1608 VSS.n458 VSS.t540 36.7898
R1609 VSS.t603 VSS.n453 36.7898
R1610 VSS.n448 VSS.t560 36.7898
R1611 VSS.n443 VSS.t214 36.7898
R1612 VSS.t586 VSS.n438 36.7898
R1613 VSS.n433 VSS.t19 36.7898
R1614 VSS.n851 VSS.t460 36.5305
R1615 VSS.n636 VSS.t407 36.465
R1616 VSS.n853 VSS.t501 36.2105
R1617 VSS.n702 VSS.t226 36.1979
R1618 VSS.t228 VSS.n717 36.1979
R1619 VSS.n171 VSS.t44 34.07
R1620 VSS.t463 VSS.n764 34.0042
R1621 VSS.t574 VSS.n674 33.9067
R1622 VSS.t238 VSS.n585 31.1596
R1623 VSS.t403 VSS.n637 30.0465
R1624 VSS.n641 VSS.t397 30.0435
R1625 VSS.t16 VSS.n858 28.7152
R1626 VSS.n852 VSS.n170 28.3058
R1627 VSS.t621 VSS.n114 28.2938
R1628 VSS.t287 VSS.n110 28.2938
R1629 VSS.t53 VSS.n108 28.2938
R1630 VSS.t535 VSS.n105 28.2938
R1631 VSS.t564 VSS.n100 28.2938
R1632 VSS.t553 VSS.n109 28.2938
R1633 VSS.t605 VSS.n104 28.2938
R1634 VSS.t37 VSS.n134 28.2938
R1635 VSS.t290 VSS.n94 28.2938
R1636 VSS.t25 VSS.n91 28.2938
R1637 VSS.t202 VSS.n146 28.2938
R1638 VSS.t542 VSS.n85 28.2938
R1639 VSS.t241 VSS.n162 28.2936
R1640 VSS.t325 VSS.n159 28.2936
R1641 VSS.t106 VSS.n155 28.2936
R1642 VSS.t536 VSS.n154 28.2936
R1643 VSS.n112 VSS.t549 28.0352
R1644 VSS.n6 VSS.t530 27.7516
R1645 VSS.t374 VSS.n657 27.6043
R1646 VSS.n727 VSS.t522 27.4228
R1647 VSS.n182 VSS.t614 27.2918
R1648 VSS.t525 VSS.n733 25.229
R1649 VSS.t4 VSS.n589 24.4565
R1650 VSS.n681 VSS.t258 22.3643
R1651 VSS.t360 VSS.n658 22.2881
R1652 VSS.n598 VSS.t509 22.2881
R1653 VSS.n251 VSS.t567 22.1486
R1654 VSS.t224 VSS.n249 22.1466
R1655 VSS.t486 VSS.n111 21.6048
R1656 VSS.t330 VSS.n586 21.1887
R1657 VSS.n639 VSS.t401 20.4143
R1658 VSS.t399 VSS.n639 20.4117
R1659 VSS.t35 VSS.n347 20.0674
R1660 VSS.t376 VSS.n352 20.0674
R1661 VSS.t600 VSS.n357 20.0674
R1662 VSS.t597 VSS.n362 20.0674
R1663 VSS.t270 VSS.n367 20.0674
R1664 VSS.t74 VSS.n372 20.0674
R1665 VSS.t222 VSS.n377 20.0674
R1666 VSS.t624 VSS.n382 20.0674
R1667 VSS.t595 VSS.n387 20.0674
R1668 VSS.t539 VSS.n392 20.0674
R1669 VSS.t602 VSS.n397 20.0674
R1670 VSS.t561 VSS.n402 20.0674
R1671 VSS.t216 VSS.n407 20.0674
R1672 VSS.t588 VSS.n412 20.0674
R1673 VSS.t21 VSS.n417 20.0674
R1674 VSS.t556 VSS.n422 20.0674
R1675 VSS.t218 VSS.t219 19.9423
R1676 VSS.n167 VSS.t455 18.0025
R1677 VSS.n164 VSS.t71 18.0025
R1678 VSS.n163 VSS.t59 18.0025
R1679 VSS.n157 VSS.t300 18.0025
R1680 VSS.n156 VSS.t115 18.0025
R1681 VSS.n153 VSS.t612 18.0025
R1682 VSS.n113 VSS.t506 18.0017
R1683 VSS.n115 VSS.t562 18.0017
R1684 VSS.n117 VSS.t237 18.0017
R1685 VSS.t369 VSS.n118 18.0017
R1686 VSS.n120 VSS.t48 18.0017
R1687 VSS.t194 VSS.n107 18.0017
R1688 VSS.t267 VSS.n106 18.0017
R1689 VSS.n125 VSS.t601 18.0017
R1690 VSS.n128 VSS.t284 18.0017
R1691 VSS.n129 VSS.t500 18.0017
R1692 VSS.t557 VSS.n130 18.0017
R1693 VSS.t365 VSS.n131 18.0017
R1694 VSS.n132 VSS.t454 18.0017
R1695 VSS.t378 VSS.n99 18.0017
R1696 VSS.n135 VSS.t533 18.0017
R1697 VSS.t66 VSS.n98 18.0017
R1698 VSS.t116 VSS.n137 18.0017
R1699 VSS.t32 VSS.n96 18.0017
R1700 VSS.t579 VSS.n139 18.0017
R1701 VSS.n141 VSS.t604 18.0017
R1702 VSS.t453 VSS.n90 18.0017
R1703 VSS.t100 VSS.n89 18.0017
R1704 VSS.t333 VSS.n144 18.0017
R1705 VSS.n147 VSS.t273 18.0017
R1706 VSS.t594 VSS.n86 18.0017
R1707 VSS.t257 VSS.n84 18.0017
R1708 VSS.t206 VSS.n862 17.4722
R1709 VSS.n81 VSS.n517 17.0005
R1710 VSS.n81 VSS.n854 17.0005
R1711 VSS.n81 VSS.n855 17.0005
R1712 VSS.n81 VSS.n857 17.0005
R1713 VSS.n81 VSS.n859 17.0005
R1714 VSS.n81 VSS.n861 17.0005
R1715 VSS.n81 VSS.n515 17.0005
R1716 VSS.n81 VSS.t98 17.0005
R1717 VSS.n863 VSS.n81 17.0005
R1718 VSS.n81 VSS.n149 17.0005
R1719 VSS.n297 VSS.n291 17.0005
R1720 VSS.n868 VSS.n286 17.0005
R1721 VSS.n289 VSS.n285 17.0005
R1722 VSS.n287 VSS.n285 17.0005
R1723 VSS.n279 VSS.n274 17.0005
R1724 VSS.n874 VSS.n269 17.0005
R1725 VSS.n272 VSS.n268 17.0005
R1726 VSS.n270 VSS.n268 17.0005
R1727 VSS.n258 VSS.n256 17.0005
R1728 VSS.n880 VSS.n257 17.0005
R1729 VSS.n883 VSS.n882 17.0005
R1730 VSS.n884 VSS.n883 17.0005
R1731 VSS.n886 VSS.n253 17.0005
R1732 VSS.n886 VSS.n250 17.0005
R1733 VSS.n235 VSS.n233 17.0005
R1734 VSS.n889 VSS.n234 17.0005
R1735 VSS.n892 VSS.n891 17.0005
R1736 VSS.n893 VSS.n892 17.0005
R1737 VSS.n221 VSS.n219 17.0005
R1738 VSS.n898 VSS.n220 17.0005
R1739 VSS.n901 VSS.n900 17.0005
R1740 VSS.n902 VSS.n901 17.0005
R1741 VSS.n212 VSS.n206 17.0005
R1742 VSS.n907 VSS.n201 17.0005
R1743 VSS.n204 VSS.n200 17.0005
R1744 VSS.n202 VSS.n200 17.0005
R1745 VSS.n910 VSS.n179 17.0005
R1746 VSS.n910 VSS.n196 17.0005
R1747 VSS.n910 VSS.n195 17.0005
R1748 VSS.n910 VSS.n183 17.0005
R1749 VSS.n910 VSS.n194 17.0005
R1750 VSS.n910 VSS.n185 17.0005
R1751 VSS.n910 VSS.n192 17.0005
R1752 VSS.n910 VSS.n187 17.0005
R1753 VSS.n81 VSS.n338 17.0005
R1754 VSS.n81 VSS.n340 17.0005
R1755 VSS.t83 VSS.n669 17.0005
R1756 VSS.t83 VSS.n55 13.5064
R1757 VSS.n668 VSS.t278 17.0005
R1758 VSS.n666 VSS.t278 17.0005
R1759 VSS.n663 VSS.t278 17.0005
R1760 VSS.n660 VSS.n58 17.0005
R1761 VSS.n656 VSS.n58 17.0005
R1762 VSS.n60 VSS.n58 13.5064
R1763 VSS.n654 VSS.t452 17.0005
R1764 VSS.n652 VSS.t452 17.0005
R1765 VSS.n649 VSS.t452 17.0005
R1766 VSS.n648 VSS.n647 17.0005
R1767 VSS.n647 VSS.n645 17.0005
R1768 VSS.t57 VSS.n828 17.0005
R1769 VSS.t57 VSS.n584 17.0005
R1770 VSS.t57 VSS.n585 17.0005
R1771 VSS.t57 VSS.n680 17.0005
R1772 VSS.t57 VSS.n586 17.0005
R1773 VSS.t57 VSS.n679 17.0005
R1774 VSS.n609 VSS.n608 17.0005
R1775 VSS.n829 VSS.t57 17.0005
R1776 VSS.t57 VSS.n594 17.0005
R1777 VSS.t57 VSS.n675 17.0005
R1778 VSS.n7 VSS.n552 17.0005
R1779 VSS.n7 VSS.n556 17.0005
R1780 VSS.n7 VSS.n559 17.0005
R1781 VSS.n7 VSS.n574 17.0005
R1782 VSS.n7 VSS.n572 17.0005
R1783 VSS.n7 VSS.n5 17.0005
R1784 VSS.n765 VSS.n34 17.0005
R1785 VSS.n767 VSS.n34 17.0005
R1786 VSS.n768 VSS.n34 17.0005
R1787 VSS.n764 VSS.n34 17.0005
R1788 VSS.n762 VSS.n34 17.0005
R1789 VSS.n760 VSS.n34 17.0005
R1790 VSS.n758 VSS.n34 17.0005
R1791 VSS.n752 VSS.n34 17.0005
R1792 VSS.n751 VSS.n34 17.0005
R1793 VSS.n749 VSS.n34 17.0005
R1794 VSS.n747 VSS.n34 17.0005
R1795 VSS.n745 VSS.n34 17.0005
R1796 VSS.n744 VSS.n34 17.0005
R1797 VSS.n742 VSS.n34 17.0005
R1798 VSS.n740 VSS.n34 17.0005
R1799 VSS.n736 VSS.n34 17.0005
R1800 VSS.n734 VSS.n34 17.0005
R1801 VSS.n733 VSS.n34 17.0005
R1802 VSS.n731 VSS.n34 17.0005
R1803 VSS.n729 VSS.n34 17.0005
R1804 VSS.n727 VSS.n34 17.0005
R1805 VSS.n726 VSS.n34 17.0005
R1806 VSS.n724 VSS.n34 17.0005
R1807 VSS.n722 VSS.n34 17.0005
R1808 VSS.n720 VSS.n34 17.0005
R1809 VSS.n718 VSS.n34 17.0005
R1810 VSS.n717 VSS.n34 17.0005
R1811 VSS.n715 VSS.n34 17.0005
R1812 VSS.n713 VSS.n34 17.0005
R1813 VSS.n711 VSS.n34 17.0005
R1814 VSS.n710 VSS.n34 17.0005
R1815 VSS.n708 VSS.n34 17.0005
R1816 VSS.n706 VSS.n34 17.0005
R1817 VSS.n704 VSS.n34 17.0005
R1818 VSS.n702 VSS.n34 17.0005
R1819 VSS.n701 VSS.n34 17.0005
R1820 VSS.n699 VSS.n34 17.0005
R1821 VSS.n697 VSS.n34 17.0005
R1822 VSS.n695 VSS.n34 17.0005
R1823 VSS.n694 VSS.n34 17.0005
R1824 VSS.n692 VSS.n34 17.0005
R1825 VSS.n519 VSS.n34 17.0005
R1826 VSS.n694 VSS.n14 17.0005
R1827 VSS.n695 VSS.n14 17.0005
R1828 VSS.n701 VSS.n14 17.0005
R1829 VSS.n710 VSS.n14 17.0005
R1830 VSS.n711 VSS.n14 17.0005
R1831 VSS.n717 VSS.n14 17.0005
R1832 VSS.n726 VSS.n14 17.0005
R1833 VSS.n727 VSS.n14 17.0005
R1834 VSS.n733 VSS.n14 17.0005
R1835 VSS.n819 VSS.n14 17.0005
R1836 VSS.n744 VSS.n14 17.0005
R1837 VSS.n745 VSS.n14 17.0005
R1838 VSS.n751 VSS.n14 17.0005
R1839 VSS.n752 VSS.n14 17.0005
R1840 VSS.n780 VSS.n519 17.0005
R1841 VSS.n780 VSS.n702 17.0005
R1842 VSS.n780 VSS.n718 17.0005
R1843 VSS.n780 VSS.n734 17.0005
R1844 VSS.n780 VSS.n739 17.0005
R1845 VSS.n780 VSS.n764 17.0005
R1846 VSS.n683 VSS.n14 17.0005
R1847 VSS.n768 VSS.n14 17.0005
R1848 VSS.n823 VSS.n14 17.0005
R1849 VSS.n544 VSS.n34 17.0005
R1850 VSS.n825 VSS.n14 17.0005
R1851 VSS.n711 VSS.t227 16.4539
R1852 VSS.n184 VSS.t111 16.3876
R1853 VSS.n54 VSS.n520 16.2018
R1854 VSS.n830 VSS.n4 14.9664
R1855 VSS.t520 VSS.n751 14.2601
R1856 VSS.t409 VSS.n66 13.9906
R1857 VSS.n860 VSS.t548 13.7246
R1858 VSS.t460 VSS.t41 13.4836
R1859 VSS.n692 VSS.n691 12.0761
R1860 VSS.n698 VSS.n697 12.0761
R1861 VSS.n704 VSS.n703 12.0761
R1862 VSS.n708 VSS.n707 12.0761
R1863 VSS.n715 VSS.n714 12.0761
R1864 VSS.n719 VSS.n718 12.0761
R1865 VSS.n724 VSS.n723 12.0761
R1866 VSS.n730 VSS.n729 12.0761
R1867 VSS.n736 VSS.n735 12.0761
R1868 VSS.n742 VSS.n741 12.0761
R1869 VSS.n749 VSS.n748 12.0761
R1870 VSS.n760 VSS.n759 12.0761
R1871 VSS.n694 VSS.n693 12.0761
R1872 VSS.n697 VSS.n696 12.0761
R1873 VSS.n701 VSS.n700 12.0761
R1874 VSS.n706 VSS.n705 12.0761
R1875 VSS.n710 VSS.n709 12.0761
R1876 VSS.n713 VSS.n712 12.0761
R1877 VSS.n717 VSS.n716 12.0761
R1878 VSS.n722 VSS.n721 12.0761
R1879 VSS.n726 VSS.n725 12.0761
R1880 VSS.n729 VSS.n728 12.0761
R1881 VSS.n733 VSS.n732 12.0761
R1882 VSS.n740 VSS.n737 12.0761
R1883 VSS.n744 VSS.n743 12.0761
R1884 VSS.n747 VSS.n746 12.0761
R1885 VSS.n751 VSS.n750 12.0761
R1886 VSS.n758 VSS.n753 12.0761
R1887 VSS.n762 VSS.n761 12.0761
R1888 VSS.n769 VSS.n767 12.0761
R1889 VSS.n764 VSS.n763 12.0761
R1890 VSS.n766 VSS.n765 12.0761
R1891 VSS.n691 VSS.n519 12.0761
R1892 VSS.n693 VSS.n692 12.0761
R1893 VSS.n696 VSS.n695 12.0761
R1894 VSS.n699 VSS.n698 12.0761
R1895 VSS.n700 VSS.n699 12.0761
R1896 VSS.n703 VSS.n702 12.0761
R1897 VSS.n705 VSS.n704 12.0761
R1898 VSS.n707 VSS.n706 12.0761
R1899 VSS.n709 VSS.n708 12.0761
R1900 VSS.n712 VSS.n711 12.0761
R1901 VSS.n714 VSS.n713 12.0761
R1902 VSS.n716 VSS.n715 12.0761
R1903 VSS.n720 VSS.n719 12.0761
R1904 VSS.n721 VSS.n720 12.0761
R1905 VSS.n723 VSS.n722 12.0761
R1906 VSS.n725 VSS.n724 12.0761
R1907 VSS.n728 VSS.n727 12.0761
R1908 VSS.n731 VSS.n730 12.0761
R1909 VSS.n732 VSS.n731 12.0761
R1910 VSS.n735 VSS.n734 12.0761
R1911 VSS.n737 VSS.n736 12.0761
R1912 VSS.n741 VSS.n740 12.0761
R1913 VSS.n743 VSS.n742 12.0761
R1914 VSS.n746 VSS.n745 12.0761
R1915 VSS.n748 VSS.n747 12.0761
R1916 VSS.n750 VSS.n749 12.0761
R1917 VSS.n753 VSS.n752 12.0761
R1918 VSS.n759 VSS.n758 12.0761
R1919 VSS.n761 VSS.n760 12.0761
R1920 VSS.n763 VSS.n762 12.0761
R1921 VSS.n769 VSS.n768 12.0761
R1922 VSS.n767 VSS.n766 12.0761
R1923 VSS.n765 VSS.n682 11.454
R1924 VSS.n827 VSS.n682 11.454
R1925 VSS.t394 VSS.n641 10.7797
R1926 VSS.n637 VSS.t405 10.7767
R1927 VSS.n798 VSS.n543 9.81803
R1928 VSS.n841 VSS.n543 9.39094
R1929 VSS.n839 VSS.n838 9.38916
R1930 VSS.n561 VSS.t499 9.08698
R1931 VSS.t499 VSS.n560 9.0445
R1932 VSS.n832 VSS.n831 9.0005
R1933 VSS.n832 VSS.n547 9.0005
R1934 VSS.n551 VSS.n546 9.0005
R1935 VSS.n773 VSS.n546 9.0005
R1936 VSS.n66 VSS.n634 4.35584
R1937 VSS.t178 VSS.n866 8.501
R1938 VSS.n867 VSS.t176 8.501
R1939 VSS.t174 VSS.n869 8.501
R1940 VSS.n870 VSS.t171 8.501
R1941 VSS.t167 VSS.n872 8.501
R1942 VSS.n873 VSS.t165 8.501
R1943 VSS.t163 VSS.n875 8.501
R1944 VSS.n876 VSS.t65 8.501
R1945 VSS.t157 VSS.n878 8.501
R1946 VSS.n879 VSS.t155 8.501
R1947 VSS.t153 VSS.n255 8.501
R1948 VSS.t150 VSS.n239 8.501
R1949 VSS.t146 VSS.n887 8.501
R1950 VSS.n888 VSS.t144 8.501
R1951 VSS.t142 VSS.n232 8.501
R1952 VSS.t139 VSS.n224 8.501
R1953 VSS.t135 VSS.n896 8.501
R1954 VSS.n897 VSS.t133 8.501
R1955 VSS.t131 VSS.n218 8.501
R1956 VSS.t62 VSS.n209 8.501
R1957 VSS.t125 VSS.n905 8.501
R1958 VSS.n906 VSS.t123 8.501
R1959 VSS.t121 VSS.n908 8.501
R1960 VSS.n909 VSS.t118 8.501
R1961 VSS.n80 VSS.n79 0.00174993
R1962 VSS.n80 VSS.n150 9.59049
R1963 VSS.n808 VSS.n34 4.251
R1964 VSS.n808 VSS.n37 4.251
R1965 VSS.n37 VSS.n36 0.00149997
R1966 VSS.n808 VSS.n39 4.251
R1967 VSS.n39 VSS.n38 0.00149997
R1968 VSS.n808 VSS.n40 3.40102
R1969 VSS.n808 VSS.n43 2.12569
R1970 VSS.n43 VSS.n42 0.00170812
R1971 VSS.n45 VSS.n42 0.00166658
R1972 VSS.n45 VSS.n44 0.00149997
R1973 VSS.n808 VSS.n49 3.40102
R1974 VSS.n808 VSS.n52 4.25113
R1975 VSS.n850 VSS.n523 8.501
R1976 VSS.n850 VSS.n19 4.251
R1977 VSS.n19 VSS.n18 0.00149997
R1978 VSS.n850 VSS.n20 3.40102
R1979 VSS.n23 VSS.n22 0.00216959
R1980 VSS.n22 VSS.n24 0.00170812
R1981 VSS.n24 VSS.n25 0.00166658
R1982 VSS.n25 VSS.n26 0.00149997
R1983 VSS.n850 VSS.n27 1.88985
R1984 VSS.n29 VSS.n30 0.00149997
R1985 VSS.n850 VSS.n32 2.83417
R1986 VSS.n32 VSS.n31 0.00166658
R1987 VSS.n31 VSS.n33 0.00149997
R1988 VSS.n662 VSS.n57 406.622
R1989 VSS.n62 VSS.n61 406.622
R1990 VSS.n64 VSS.n62 0.00235708
R1991 VSS.n66 VSS.n65 0.0012566
R1992 VSS.n634 VSS.n67 2.42956
R1993 VSS.n634 VSS.n70 3.40102
R1994 VSS.n634 VSS.n72 2.42956
R1995 VSS.n634 VSS.n75 3.40102
R1996 VSS.n634 VSS.n77 3.40102
R1997 VSS.n8 VSS.n830 4.252
R1998 VSS.n8 VSS.n7 0.00116666
R1999 VSS.n15 VSS.n14 0.00149995
R2000 VSS.n827 VSS.n16 2.42956
R2001 VSS.n827 VSS.n34 8.501
R2002 VSS.n81 VSS.n514 8.5005
R2003 VSS.n81 VSS.n509 8.5005
R2004 VSS.n81 VSS.n343 8.5005
R2005 VSS.n81 VSS.n507 8.5005
R2006 VSS.n81 VSS.n506 8.5005
R2007 VSS.n81 VSS.n344 8.5005
R2008 VSS.n81 VSS.n505 8.5005
R2009 VSS.n81 VSS.n346 8.5005
R2010 VSS.n81 VSS.n504 8.5005
R2011 VSS.n81 VSS.n347 8.5005
R2012 VSS.n81 VSS.n503 8.5005
R2013 VSS.n81 VSS.n348 8.5005
R2014 VSS.n81 VSS.n502 8.5005
R2015 VSS.n81 VSS.n501 8.5005
R2016 VSS.n81 VSS.n349 8.5005
R2017 VSS.n81 VSS.n500 8.5005
R2018 VSS.n81 VSS.n351 8.5005
R2019 VSS.n81 VSS.n499 8.5005
R2020 VSS.n81 VSS.n352 8.5005
R2021 VSS.n81 VSS.n498 8.5005
R2022 VSS.n81 VSS.n353 8.5005
R2023 VSS.n81 VSS.n497 8.5005
R2024 VSS.n81 VSS.n496 8.5005
R2025 VSS.n81 VSS.n354 8.5005
R2026 VSS.n81 VSS.n495 8.5005
R2027 VSS.n81 VSS.n356 8.5005
R2028 VSS.n81 VSS.n494 8.5005
R2029 VSS.n81 VSS.n357 8.5005
R2030 VSS.n81 VSS.n493 8.5005
R2031 VSS.n81 VSS.n358 8.5005
R2032 VSS.n81 VSS.n492 8.5005
R2033 VSS.n81 VSS.n491 8.5005
R2034 VSS.n81 VSS.n359 8.5005
R2035 VSS.n81 VSS.n490 8.5005
R2036 VSS.n81 VSS.n361 8.5005
R2037 VSS.n81 VSS.n489 8.5005
R2038 VSS.n81 VSS.n362 8.5005
R2039 VSS.n81 VSS.n488 8.5005
R2040 VSS.n81 VSS.n363 8.5005
R2041 VSS.n81 VSS.n487 8.5005
R2042 VSS.n81 VSS.n486 8.5005
R2043 VSS.n81 VSS.n364 8.5005
R2044 VSS.n81 VSS.n485 8.5005
R2045 VSS.n81 VSS.n366 8.5005
R2046 VSS.n81 VSS.n484 8.5005
R2047 VSS.n81 VSS.n367 8.5005
R2048 VSS.n81 VSS.n483 8.5005
R2049 VSS.n81 VSS.n368 8.5005
R2050 VSS.n81 VSS.n482 8.5005
R2051 VSS.n81 VSS.n481 8.5005
R2052 VSS.n81 VSS.n369 8.5005
R2053 VSS.n81 VSS.n480 8.5005
R2054 VSS.n81 VSS.n371 8.5005
R2055 VSS.n81 VSS.n479 8.5005
R2056 VSS.n81 VSS.n372 8.5005
R2057 VSS.n81 VSS.n478 8.5005
R2058 VSS.n81 VSS.n373 8.5005
R2059 VSS.n81 VSS.n477 8.5005
R2060 VSS.n81 VSS.n476 8.5005
R2061 VSS.n81 VSS.n374 8.5005
R2062 VSS.n81 VSS.n475 8.5005
R2063 VSS.n81 VSS.n376 8.5005
R2064 VSS.n81 VSS.n474 8.5005
R2065 VSS.n81 VSS.n377 8.5005
R2066 VSS.n81 VSS.n473 8.5005
R2067 VSS.n81 VSS.n378 8.5005
R2068 VSS.n81 VSS.n472 8.5005
R2069 VSS.n81 VSS.n471 8.5005
R2070 VSS.n81 VSS.n379 8.5005
R2071 VSS.n81 VSS.n470 8.5005
R2072 VSS.n81 VSS.n381 8.5005
R2073 VSS.n81 VSS.n469 8.5005
R2074 VSS.n81 VSS.n382 8.5005
R2075 VSS.n81 VSS.n468 8.5005
R2076 VSS.n81 VSS.n383 8.5005
R2077 VSS.n81 VSS.n467 8.5005
R2078 VSS.n81 VSS.n466 8.5005
R2079 VSS.n81 VSS.n384 8.5005
R2080 VSS.n81 VSS.n465 8.5005
R2081 VSS.n81 VSS.n386 8.5005
R2082 VSS.n81 VSS.n464 8.5005
R2083 VSS.n81 VSS.n387 8.5005
R2084 VSS.n81 VSS.n463 8.5005
R2085 VSS.n81 VSS.n388 8.5005
R2086 VSS.n81 VSS.n462 8.5005
R2087 VSS.n81 VSS.n461 8.5005
R2088 VSS.n81 VSS.n389 8.5005
R2089 VSS.n81 VSS.n460 8.5005
R2090 VSS.n81 VSS.n391 8.5005
R2091 VSS.n81 VSS.n459 8.5005
R2092 VSS.n81 VSS.n392 8.5005
R2093 VSS.n81 VSS.n458 8.5005
R2094 VSS.n81 VSS.n393 8.5005
R2095 VSS.n81 VSS.n457 8.5005
R2096 VSS.n81 VSS.n456 8.5005
R2097 VSS.n81 VSS.n394 8.5005
R2098 VSS.n81 VSS.n455 8.5005
R2099 VSS.n81 VSS.n396 8.5005
R2100 VSS.n81 VSS.n454 8.5005
R2101 VSS.n81 VSS.n397 8.5005
R2102 VSS.n81 VSS.n453 8.5005
R2103 VSS.n81 VSS.n398 8.5005
R2104 VSS.n81 VSS.n452 8.5005
R2105 VSS.n81 VSS.n451 8.5005
R2106 VSS.n81 VSS.n399 8.5005
R2107 VSS.n81 VSS.n450 8.5005
R2108 VSS.n81 VSS.n401 8.5005
R2109 VSS.n81 VSS.n449 8.5005
R2110 VSS.n81 VSS.n402 8.5005
R2111 VSS.n81 VSS.n448 8.5005
R2112 VSS.n81 VSS.n403 8.5005
R2113 VSS.n81 VSS.n447 8.5005
R2114 VSS.n81 VSS.n446 8.5005
R2115 VSS.n81 VSS.n404 8.5005
R2116 VSS.n81 VSS.n445 8.5005
R2117 VSS.n81 VSS.n406 8.5005
R2118 VSS.n81 VSS.n444 8.5005
R2119 VSS.n81 VSS.n407 8.5005
R2120 VSS.n81 VSS.n443 8.5005
R2121 VSS.n81 VSS.n408 8.5005
R2122 VSS.n81 VSS.n442 8.5005
R2123 VSS.n81 VSS.n441 8.5005
R2124 VSS.n81 VSS.n409 8.5005
R2125 VSS.n81 VSS.n440 8.5005
R2126 VSS.n81 VSS.n411 8.5005
R2127 VSS.n81 VSS.n439 8.5005
R2128 VSS.n81 VSS.n412 8.5005
R2129 VSS.n81 VSS.n438 8.5005
R2130 VSS.n81 VSS.n413 8.5005
R2131 VSS.n81 VSS.n437 8.5005
R2132 VSS.n81 VSS.n436 8.5005
R2133 VSS.n81 VSS.n414 8.5005
R2134 VSS.n81 VSS.n435 8.5005
R2135 VSS.n81 VSS.n416 8.5005
R2136 VSS.n81 VSS.n434 8.5005
R2137 VSS.n81 VSS.n417 8.5005
R2138 VSS.n81 VSS.n433 8.5005
R2139 VSS.n81 VSS.n418 8.5005
R2140 VSS.n81 VSS.n432 8.5005
R2141 VSS.n81 VSS.n431 8.5005
R2142 VSS.n81 VSS.n419 8.5005
R2143 VSS.n81 VSS.n430 8.5005
R2144 VSS.n81 VSS.n421 8.5005
R2145 VSS.n81 VSS.n429 8.5005
R2146 VSS.n81 VSS.n422 8.5005
R2147 VSS.n81 VSS.n424 8.5005
R2148 VSS.n7 VSS.n575 8.5005
R2149 VSS.n7 VSS.n564 8.5005
R2150 VSS.n7 VSS.n548 8.48883
R2151 VSS.n549 VSS.n7 8.48883
R2152 VSS.n81 VSS.n425 8.48012
R2153 VSS.n620 VSS.n68 8.47784
R2154 VSS.n621 VSS.n69 8.47784
R2155 VSS.n623 VSS.n71 8.47784
R2156 VSS.n625 VSS.n73 8.47784
R2157 VSS.n626 VSS.n74 8.47784
R2158 VSS.n629 VSS.n76 8.47784
R2159 VSS.n603 VSS.n78 8.47784
R2160 VSS.n81 VSS.n342 8.47732
R2161 VSS.n81 VSS.t489 8.47732
R2162 VSS.n79 VSS.n428 8.47732
R2163 VSS.n427 VSS.n82 8.47732
R2164 VSS.n81 VSS.n304 8.47732
R2165 VSS.n81 VSS.n305 8.47732
R2166 VSS.n81 VSS.n339 8.47732
R2167 VSS.n795 VSS.n34 8.47732
R2168 VSS.n793 VSS.n34 8.47732
R2169 VSS.n540 VSS.n34 8.47732
R2170 VSS.n539 VSS.n34 8.47732
R2171 VSS.t461 VSS.n35 8.47732
R2172 VSS.n799 VSS.n790 8.47732
R2173 VSS.n800 VSS.n36 8.47732
R2174 VSS.n801 VSS.n789 8.47732
R2175 VSS.n802 VSS.n38 8.47732
R2176 VSS.t336 VSS.n41 8.47732
R2177 VSS.n805 VSS.n786 8.47732
R2178 VSS.n785 VSS.n42 8.47732
R2179 VSS.n784 VSS.n45 8.47732
R2180 VSS.t337 VSS.n44 8.47732
R2181 VSS.n809 VSS.n48 8.47732
R2182 VSS.n811 VSS.n50 8.47732
R2183 VSS.n812 VSS.n52 8.47732
R2184 VSS.t467 VSS.n842 8.47732
R2185 VSS.t335 VSS.n18 8.47732
R2186 VSS.n843 VSS.n21 8.47732
R2187 VSS.n535 VSS.n22 8.47732
R2188 VSS.n844 VSS.n24 8.47732
R2189 VSS.n534 VSS.n25 8.47732
R2190 VSS.t340 VSS.n26 8.47732
R2191 VSS.n530 VSS.n28 8.47732
R2192 VSS.t342 VSS.n29 8.47732
R2193 VSS.n529 VSS.n30 8.47732
R2194 VSS.n846 VSS.n528 8.47732
R2195 VSS.n527 VSS.n31 8.47732
R2196 VSS.t344 VSS.n33 8.47732
R2197 VSS.n619 VSS.n65 8.47732
R2198 VSS.n611 VSS.n65 8.47732
R2199 VSS.n7 VSS.n553 8.47732
R2200 VSS.n7 VSS.n555 8.47732
R2201 VSS.n7 VSS.n557 8.47732
R2202 VSS.n7 VSS.n563 8.47732
R2203 VSS.n7 VSS.n576 8.47732
R2204 VSS.n7 VSS.n565 8.47732
R2205 VSS.n687 VSS.n14 8.47732
R2206 VSS.n780 VSS.n757 8.47732
R2207 VSS.n772 VSS.n10 8.47732
R2208 VSS.n778 VSS.n17 8.47732
R2209 VSS.n13 VSS.n12 3.32623
R2210 VSS.n671 VSS.n56 8.47111
R2211 VSS.t252 VSS.n59 8.47111
R2212 VSS.n646 VSS.n63 8.47111
R2213 VSS.t11 VSS.n64 8.47111
R2214 VSS.n837 VSS.n836 6.85916
R2215 VSS.n670 VSS.n520 5.66985
R2216 VSS.n808 VSS.n782 5.66778
R2217 VSS.n808 VSS.n783 5.66778
R2218 VSS.n40 VSS.n787 0.00229996
R2219 VSS.n49 VSS.n46 0.00229996
R2220 VSS.n808 VSS.n806 5.66778
R2221 VSS.n20 VSS.n537 0.00229996
R2222 VSS.n850 VSS.n23 1.54575
R2223 VSS.n850 VSS.n522 5.66778
R2224 VSS.n27 VSS.n531 0.00261099
R2225 VSS.n850 VSS.n521 5.66778
R2226 VSS.n67 VSS.n618 0.00249991
R2227 VSS.n70 VSS.n617 0.00229996
R2228 VSS.n72 VSS.n616 0.00249991
R2229 VSS.n634 VSS.n601 5.66778
R2230 VSS.n75 VSS.n614 0.00229996
R2231 VSS.n634 VSS.n602 5.66778
R2232 VSS.n77 VSS.n612 0.00229996
R2233 VSS.n827 VSS.n9 5.66778
R2234 VSS.n16 VSS.n771 0.00249991
R2235 VSS.n827 VSS.n11 5.66778
R2236 VSS.n826 VSS.t570 5.66778
R2237 VSS.n827 VSS.n15 2.42956
R2238 VSS.n57 VSS.n59 0.00137142
R2239 VSS.n775 VSS.n10 5.64509
R2240 VSS.n81 VSS.n303 5.63915
R2241 VSS.t427 VSS.n618 5.62674
R2242 VSS.n622 VSS.n617 5.62674
R2243 VSS.n624 VSS.n616 5.62674
R2244 VSS.n627 VSS.n615 5.62674
R2245 VSS.n628 VSS.n614 5.62674
R2246 VSS.n630 VSS.n613 5.62674
R2247 VSS.n631 VSS.n612 5.62674
R2248 VSS.n632 VSS.t410 5.62674
R2249 VSS.n792 VSS.n791 5.62581
R2250 VSS.n803 VSS.n788 5.62581
R2251 VSS.n804 VSS.n787 5.62581
R2252 VSS.n781 VSS.n46 5.62581
R2253 VSS.n810 VSS.n47 5.62581
R2254 VSS.n813 VSS.n51 5.62581
R2255 VSS.n538 VSS.n537 5.62581
R2256 VSS.t338 VSS.n536 5.62581
R2257 VSS.n533 VSS.n532 5.62581
R2258 VSS.n845 VSS.n531 5.62581
R2259 VSS.n526 VSS.n525 5.62581
R2260 VSS.n848 VSS.n847 5.62581
R2261 VSS.n7 VSS.n562 5.62581
R2262 VSS.n776 VSS.n771 5.62581
R2263 VSS.n780 VSS.n779 5.62252
R2264 VSS.n695 VSS.t225 5.48496
R2265 VSS.n673 VSS.n672 5.13648
R2266 VSS.n591 VSS.t543 4.98596
R2267 VSS.n833 VSS.n832 4.63796
R2268 VSS.n662 VSS.t250 4.49152
R2269 VSS.n61 VSS.t10 4.49152
R2270 VSS.t5 VSS.n673 4.4712
R2271 VSS.n808 VSS.n807 4.25119
R2272 VSS.n850 VSS.n849 4.25119
R2273 VSS.n634 VSS.n633 4.25112
R2274 VSS.n7 VSS.n558 4.19238
R2275 VSS.n780 VSS.n770 4.19238
R2276 VSS.t172 VSS.n285 4.19225
R2277 VSS.t161 VSS.n268 4.19225
R2278 VSS.n883 VSS.t151 4.19225
R2279 VSS.n892 VSS.t140 4.19225
R2280 VSS.n901 VSS.t129 4.19225
R2281 VSS.t119 VSS.n200 4.19225
R2282 VSS.n684 VSS.n14 4.19225
R2283 VSS.t13 VSS.n609 4.177
R2284 VSS.n517 VSS.n174 3.84219
R2285 VSS.n911 VSS.t102 3.84041
R2286 VSS.n509 VSS.t428 3.34498
R2287 VSS.n506 VSS.t384 3.34498
R2288 VSS.n503 VSS.t387 3.34498
R2289 VSS.n501 VSS.t430 3.34498
R2290 VSS.n498 VSS.t429 3.34498
R2291 VSS.n496 VSS.t382 3.34498
R2292 VSS.n493 VSS.t393 3.34498
R2293 VSS.n491 VSS.t431 3.34498
R2294 VSS.n488 VSS.t392 3.34498
R2295 VSS.n486 VSS.t432 3.34498
R2296 VSS.n483 VSS.t391 3.34498
R2297 VSS.n481 VSS.t433 3.34498
R2298 VSS.n478 VSS.t434 3.34498
R2299 VSS.n476 VSS.t388 3.34498
R2300 VSS.n473 VSS.t390 3.34498
R2301 VSS.n471 VSS.t437 3.34498
R2302 VSS.n468 VSS.t438 3.34498
R2303 VSS.n466 VSS.t439 3.34498
R2304 VSS.n463 VSS.t435 3.34498
R2305 VSS.n461 VSS.t441 3.34498
R2306 VSS.n458 VSS.t443 3.34498
R2307 VSS.n456 VSS.t440 3.34498
R2308 VSS.n453 VSS.t436 3.34498
R2309 VSS.n451 VSS.t444 3.34498
R2310 VSS.n448 VSS.t385 3.34498
R2311 VSS.n446 VSS.t445 3.34498
R2312 VSS.n443 VSS.t389 3.34498
R2313 VSS.n441 VSS.t381 3.34498
R2314 VSS.n438 VSS.t386 3.34498
R2315 VSS.n436 VSS.t446 3.34498
R2316 VSS.n433 VSS.t447 3.34498
R2317 VSS.n431 VSS.t448 3.34498
R2318 VSS.n7 VSS.n550 3.32697
R2319 VSS.n840 VSS.n34 3.3265
R2320 VSS.n7 VSS.n554 3.32633
R2321 VSS.t7 VSS.t452 3.30696
R2322 VSS.n864 VSS.t189 3.28366
R2323 VSS.n780 VSS.n682 2.77448
R2324 VSS.n833 VSS.n545 2.7456
R2325 VSS.n81 VSS.n341 2.74463
R2326 VSS.n81 VSS.n423 2.7443
R2327 VSS.n81 VSS.t532 2.74402
R2328 VSS.n81 VSS.n508 2.74397
R2329 VSS.n81 VSS.n337 2.74397
R2330 VSS.n7 VSS.n570 2.74397
R2331 VSS.n691 VSS.n14 2.46343
R2332 VSS.n698 VSS.n14 2.46343
R2333 VSS.n703 VSS.n14 2.46343
R2334 VSS.n707 VSS.n14 2.46343
R2335 VSS.n714 VSS.n14 2.46343
R2336 VSS.n719 VSS.n14 2.46343
R2337 VSS.n723 VSS.n14 2.46343
R2338 VSS.n730 VSS.n14 2.46343
R2339 VSS.n735 VSS.n14 2.46343
R2340 VSS.n741 VSS.n14 2.46343
R2341 VSS.n748 VSS.n14 2.46343
R2342 VSS.n759 VSS.n14 2.46343
R2343 VSS.n780 VSS.n693 2.46343
R2344 VSS.n780 VSS.n696 2.46343
R2345 VSS.n780 VSS.n700 2.46343
R2346 VSS.n780 VSS.n705 2.46343
R2347 VSS.n780 VSS.n709 2.46343
R2348 VSS.n780 VSS.n712 2.46343
R2349 VSS.n780 VSS.n716 2.46343
R2350 VSS.n780 VSS.n721 2.46343
R2351 VSS.n780 VSS.n725 2.46343
R2352 VSS.n780 VSS.n728 2.46343
R2353 VSS.n780 VSS.n732 2.46343
R2354 VSS.n780 VSS.n737 2.46343
R2355 VSS.n780 VSS.n743 2.46343
R2356 VSS.n780 VSS.n746 2.46343
R2357 VSS.n780 VSS.n750 2.46343
R2358 VSS.n780 VSS.n753 2.46343
R2359 VSS.n780 VSS.n761 2.46343
R2360 VSS.n780 VSS.n769 2.46343
R2361 VSS.n763 VSS.n14 2.46343
R2362 VSS.n766 VSS.n14 2.46343
R2363 VSS.n292 VSS.n291 2.34876
R2364 VSS.n275 VSS.n274 2.34876
R2365 VSS.n259 VSS.n258 2.34876
R2366 VSS.n236 VSS.n235 2.34876
R2367 VSS.n222 VSS.n221 2.34876
R2368 VSS.n207 VSS.n206 2.34876
R2369 VSS.n821 VSS.n14 2.32483
R2370 VSS.n780 VSS.n755 2.32406
R2371 VSS.n817 VSS.n14 2.00687
R2372 VSS.n780 VSS.n690 2.00604
R2373 VSS.t452 VSS.n595 1.97699
R2374 VSS.t57 VSS.n589 1.88189
R2375 VSS.n609 VSS.n600 1.88189
R2376 VSS.n834 VSS.n833 1.83435
R2377 VSS.t286 VSS.n670 1.80539
R2378 VSS.n797 VSS.n34 1.75689
R2379 VSS.n542 VSS.n34 1.75689
R2380 VSS.n7 VSS.n581 1.75507
R2381 VSS.n647 VSS.t510 1.72297
R2382 VSS.n774 VSS.n773 1.66925
R2383 VSS.n81 VSS.n516 1.63922
R2384 VSS.n81 VSS.n853 1.63922
R2385 VSS.n81 VSS.n858 1.63922
R2386 VSS.n81 VSS.n860 1.63922
R2387 VSS.n81 VSS.n862 1.63922
R2388 VSS.n81 VSS.n345 1.55386
R2389 VSS.n81 VSS.n350 1.55386
R2390 VSS.n81 VSS.n355 1.55386
R2391 VSS.n81 VSS.n360 1.55386
R2392 VSS.n81 VSS.n365 1.55386
R2393 VSS.n81 VSS.n370 1.55386
R2394 VSS.n81 VSS.n375 1.55386
R2395 VSS.n81 VSS.n380 1.55386
R2396 VSS.n81 VSS.n385 1.55386
R2397 VSS.n81 VSS.n390 1.55386
R2398 VSS.n81 VSS.n395 1.55386
R2399 VSS.n81 VSS.n400 1.55386
R2400 VSS.n81 VSS.n405 1.55386
R2401 VSS.n81 VSS.n410 1.55386
R2402 VSS.n81 VSS.n415 1.55386
R2403 VSS.n81 VSS.n420 1.55386
R2404 VSS.n81 VSS.t34 1.55345
R2405 VSS.n81 VSS.t373 1.55345
R2406 VSS.n81 VSS.t236 1.55345
R2407 VSS.n81 VSS.t92 1.55345
R2408 VSS.n81 VSS.t272 1.55345
R2409 VSS.n81 VSS.t73 1.55345
R2410 VSS.n81 VSS.t221 1.55345
R2411 VSS.n81 VSS.t591 1.55345
R2412 VSS.n81 VSS.t233 1.55345
R2413 VSS.n81 VSS.t78 1.55345
R2414 VSS.n81 VSS.t313 1.55345
R2415 VSS.n81 VSS.t31 1.55345
R2416 VSS.n81 VSS.t215 1.55345
R2417 VSS.n81 VSS.t587 1.55345
R2418 VSS.n81 VSS.t20 1.55345
R2419 VSS.n81 VSS.n306 1.55338
R2420 VSS.n81 VSS.n307 1.55338
R2421 VSS.n81 VSS.n308 1.55338
R2422 VSS.n81 VSS.n309 1.55338
R2423 VSS.n81 VSS.n310 1.55338
R2424 VSS.n81 VSS.n311 1.55338
R2425 VSS.n81 VSS.n312 1.55338
R2426 VSS.n81 VSS.n313 1.55338
R2427 VSS.n81 VSS.n314 1.55338
R2428 VSS.n81 VSS.n315 1.55338
R2429 VSS.n81 VSS.n316 1.55338
R2430 VSS.n81 VSS.n317 1.55338
R2431 VSS.n81 VSS.n318 1.55338
R2432 VSS.n81 VSS.n319 1.55338
R2433 VSS.n81 VSS.n320 1.55338
R2434 VSS.n81 VSS.n321 1.55338
R2435 VSS.n81 VSS.n322 1.55338
R2436 VSS.n81 VSS.n323 1.55338
R2437 VSS.n81 VSS.n324 1.55338
R2438 VSS.n81 VSS.n325 1.55338
R2439 VSS.n81 VSS.n326 1.55338
R2440 VSS.n81 VSS.n327 1.55338
R2441 VSS.n81 VSS.n328 1.55338
R2442 VSS.n81 VSS.n329 1.55338
R2443 VSS.n81 VSS.n330 1.55338
R2444 VSS.n81 VSS.n331 1.55338
R2445 VSS.n81 VSS.n332 1.55338
R2446 VSS.n81 VSS.n333 1.55338
R2447 VSS.n81 VSS.n334 1.55338
R2448 VSS.n81 VSS.n335 1.55338
R2449 VSS.n81 VSS.n336 1.55338
R2450 VSS.n604 VSS.n65 1.55041
R2451 VSS.t464 VSS.n686 1.43372
R2452 VSS.t462 VSS.n689 1.43372
R2453 VSS.n688 VSS.t462 1.42949
R2454 VSS.n685 VSS.t464 1.42949
R2455 VSS.t521 VSS.t529 1.41892
R2456 VSS.t519 VSS.t528 1.41892
R2457 VSS.t526 VSS.t527 1.41892
R2458 VSS.t523 VSS.t524 1.41892
R2459 VSS.n910 VSS.n197 1.38589
R2460 VSS.n541 VSS.t459 1.37661
R2461 VSS.t459 VSS.n794 1.37661
R2462 VSS.n835 VSS.n834 1.30942
R2463 VSS.t410 VSS.t408 1.3038
R2464 VSS.t427 VSS.t425 1.30338
R2465 VSS.t109 VSS.n237 1.28795
R2466 VSS.n839 VSS.n835 1.26857
R2467 VSS.n607 VSS.n65 1.24506
R2468 VSS.t262 VSS.t80 1.23805
R2469 VSS.t7 VSS.n596 1.21874
R2470 VSS.t418 VSS.t420 1.18357
R2471 VSS.t400 VSS.t398 1.1832
R2472 VSS.t422 VSS.t420 1.17915
R2473 VSS.t402 VSS.t400 1.17908
R2474 VSS.t412 VSS.t411 1.1778
R2475 VSS.t395 VSS.t396 1.17752
R2476 VSS.t406 VSS.t404 1.17381
R2477 VSS.t414 VSS.t413 1.17364
R2478 VSS.t425 VSS.t414 1.16051
R2479 VSS.t408 VSS.t406 1.16021
R2480 VSS.n593 VSS.t13 1.12148
R2481 VSS.t413 VSS.t422 1.11316
R2482 VSS.t402 VSS.t404 1.1128
R2483 VSS.t418 VSS.t412 1.10881
R2484 VSS.t398 VSS.t395 1.10873
R2485 VSS.t57 VSS.n587 1.09664
R2486 VSS.n597 VSS.t278 1.08287
R2487 VSS.t146 VSS.n237 1.06717
R2488 VSS.n596 VSS.t252 1.0392
R2489 VSS.n176 VSS.t118 1.03359
R2490 VSS.n587 VSS.n588 1.02454
R2491 VSS.n518 VSS.t17 1.02116
R2492 VSS.n856 VSS.t205 1.00727
R2493 VSS.n176 VSS.t508 1.0064
R2494 VSS.n814 VSS.n813 0.986192
R2495 VSS.n847 VSS.n524 0.980375
R2496 VSS.n175 VSS.t102 0.971887
R2497 VSS.t178 VSS.n293 0.950816
R2498 VSS.n593 VSS.t5 0.884808
R2499 VSS.n816 VSS.n524 0.881792
R2500 VSS.n815 VSS.n814 0.873936
R2501 VSS.t150 VSS.n238 0.841394
R2502 VSS.n671 VSS.n597 0.839803
R2503 VSS.t512 VSS.n599 0.832423
R2504 VSS.t470 VSS.t473 0.806856
R2505 VSS.n573 VSS.t477 0.806855
R2506 VSS.t96 VSS.t483 0.806855
R2507 VSS.n571 VSS.t416 0.802775
R2508 VSS.t321 VSS.t254 0.802775
R2509 VSS.t114 VSS.t36 0.802775
R2510 VSS.t310 VSS.t260 0.802775
R2511 VSS.t256 VSS.t377 0.802775
R2512 VSS.t185 VSS.t380 0.802775
R2513 VSS.t182 VSS.t383 0.802775
R2514 VSS.t246 VSS.t54 0.802775
R2515 VSS.t52 VSS.t208 0.802775
R2516 VSS.t316 VSS.t332 0.802775
R2517 VSS.t85 VSS.t3 0.802775
R2518 VSS.t249 VSS.t350 0.802775
R2519 VSS.t458 VSS.t75 0.802775
R2520 VSS.t364 VSS.t94 0.802775
R2521 VSS.t240 VSS.t223 0.802775
R2522 VSS.t515 VSS.t356 0.802775
R2523 VSS.t551 VSS.t89 0.802775
R2524 VSS.t619 VSS.t38 0.802775
R2525 VSS.t40 VSS.t50 0.802775
R2526 VSS.t585 VSS.t275 0.802775
R2527 VSS.t269 VSS.t442 0.802775
R2528 VSS.t324 VSS.t291 0.802775
R2529 VSS.t210 VSS.t213 0.802775
R2530 VSS.t577 VSS.t107 0.802775
R2531 VSS.t87 VSS.t1 0.802775
R2532 VSS.t368 VSS.t26 0.802775
R2533 VSS.t24 VSS.t15 0.802775
R2534 VSS.t70 VSS.t281 0.802775
R2535 VSS.t538 VSS.t294 0.802775
R2536 VSS.t192 VSS.t203 0.802775
R2537 VSS.t200 VSS.t22 0.802775
R2538 VSS.t303 VSS.t243 0.802775
R2539 VSS.t46 VSS.t449 0.802775
R2540 VSS.t297 VSS.t492 0.802775
R2541 VSS.t171 VSS.n276 0.78864
R2542 VSS.t65 VSS.n260 0.78864
R2543 VSS.t139 VSS.n223 0.78864
R2544 VSS.t62 VSS.n208 0.78864
R2545 VSS.n597 VSS.t286 0.756052
R2546 VSS.t512 VSS.t510 0.745166
R2547 VSS.t57 VSS.n593 0.728098
R2548 VSS.t167 VSS.n276 0.724795
R2549 VSS.t157 VSS.n260 0.724795
R2550 VSS.t135 VSS.n223 0.724795
R2551 VSS.t125 VSS.n208 0.724795
R2552 VSS.t493 VSS.t495 0.723599
R2553 VSS.t491 VSS.n302 0.723599
R2554 VSS.n756 VSS.t521 0.722582
R2555 VSS.n754 VSS.t519 0.722582
R2556 VSS.n738 VSS.t526 0.722582
R2557 VSS.t524 VSS.n815 0.722582
R2558 VSS.n822 VSS.t529 0.72222
R2559 VSS.n820 VSS.t528 0.72222
R2560 VSS.n818 VSS.t527 0.72222
R2561 VSS.n816 VSS.t523 0.72222
R2562 VSS.n599 VSS.n610 0.711165
R2563 VSS.t5 VSS.n587 0.699997
R2564 VSS.n238 VSS.t109 0.699882
R2565 VSS.n606 VSS.n605 0.6955
R2566 VSS.n596 VSS.n58 0.662806
R2567 VSS.t11 VSS.t510 0.640524
R2568 VSS.n871 VSS.n276 0.62049
R2569 VSS.n877 VSS.n260 0.62049
R2570 VSS.n895 VSS.n223 0.62049
R2571 VSS.n904 VSS.n208 0.62049
R2572 VSS.n865 VSS.n300 0.613782
R2573 VSS.n871 VSS.n282 0.613782
R2574 VSS.n877 VSS.n265 0.613782
R2575 VSS.n886 VSS.n252 0.613782
R2576 VSS.n886 VSS.n247 0.613782
R2577 VSS.n895 VSS.n229 0.613782
R2578 VSS.n904 VSS.n215 0.613782
R2579 VSS.n910 VSS.n180 0.613782
R2580 VSS.n910 VSS.n182 0.613782
R2581 VSS.n910 VSS.n193 0.613782
R2582 VSS.n910 VSS.n188 0.613782
R2583 VSS.n910 VSS.n189 0.613782
R2584 VSS.n599 VSS.n65 0.599773
R2585 VSS.t482 VSS.n577 0.595317
R2586 VSS.t479 VSS.n578 0.595317
R2587 VSS.t476 VSS.n566 0.595317
R2588 VSS.t472 VSS.n567 0.595317
R2589 VSS.t488 VSS.n510 0.595317
R2590 VSS.t485 VSS.n511 0.595317
R2591 VSS.n646 VSS.n595 0.588545
R2592 VSS.n667 VSS.t278 0.572871
R2593 VSS.n653 VSS.t452 0.572871
R2594 VSS.n81 VSS.n150 0.1979
R2595 VSS.n610 VSS.n607 0.56503
R2596 VSS.t57 VSS.n592 0.557126
R2597 VSS.n81 VSS.n83 0.556705
R2598 VSS.n524 VSS.n14 0.556483
R2599 VSS.n814 VSS.n780 0.55447
R2600 VSS.n886 VSS.n238 0.554008
R2601 VSS.t508 VSS.n197 0.539958
R2602 VSS.n582 VSS.n581 0.52186
R2603 VSS.t464 VSS.t462 0.492336
R2604 VSS.n661 VSS.n58 0.490843
R2605 VSS.n657 VSS.n58 0.490843
R2606 VSS.n655 VSS.n58 0.490843
R2607 VSS.n647 VSS.n644 0.490843
R2608 VSS.n664 VSS.t278 0.489061
R2609 VSS.n650 VSS.t452 0.489061
R2610 VSS.t254 VSS.n336 0.477689
R2611 VSS.t36 VSS.n335 0.477689
R2612 VSS.t260 VSS.n334 0.477689
R2613 VSS.t377 VSS.n333 0.477689
R2614 VSS.t380 VSS.n332 0.477689
R2615 VSS.t383 VSS.n331 0.477689
R2616 VSS.t54 VSS.n330 0.477689
R2617 VSS.t208 VSS.n329 0.477689
R2618 VSS.t332 VSS.n328 0.477689
R2619 VSS.t3 VSS.n327 0.477689
R2620 VSS.t350 VSS.n326 0.477689
R2621 VSS.t75 VSS.n325 0.477689
R2622 VSS.t94 VSS.n324 0.477689
R2623 VSS.t223 VSS.n323 0.477689
R2624 VSS.t356 VSS.n322 0.477689
R2625 VSS.t89 VSS.n321 0.477689
R2626 VSS.t38 VSS.n320 0.477689
R2627 VSS.t50 VSS.n319 0.477689
R2628 VSS.t275 VSS.n318 0.477689
R2629 VSS.t442 VSS.n317 0.477689
R2630 VSS.t291 VSS.n316 0.477689
R2631 VSS.t213 VSS.n315 0.477689
R2632 VSS.t107 VSS.n314 0.477689
R2633 VSS.t1 VSS.n313 0.477689
R2634 VSS.t26 VSS.n312 0.477689
R2635 VSS.t15 VSS.n311 0.477689
R2636 VSS.t281 VSS.n310 0.477689
R2637 VSS.t294 VSS.n309 0.477689
R2638 VSS.t203 VSS.n308 0.477689
R2639 VSS.t22 VSS.n307 0.477689
R2640 VSS.t243 VSS.n306 0.477689
R2641 VSS.n604 VSS.n545 0.47741
R2642 VSS.t57 VSS.n676 0.477286
R2643 VSS.t57 VSS.n677 0.472981
R2644 VSS.t20 VSS.t200 0.466542
R2645 VSS.t587 VSS.t538 0.466542
R2646 VSS.t215 VSS.t24 0.466542
R2647 VSS.t31 VSS.t87 0.466542
R2648 VSS.t313 VSS.t210 0.466542
R2649 VSS.t78 VSS.t269 0.466542
R2650 VSS.t233 VSS.t40 0.466542
R2651 VSS.t591 VSS.t551 0.466542
R2652 VSS.t221 VSS.t240 0.466542
R2653 VSS.t73 VSS.t458 0.466542
R2654 VSS.t272 VSS.t85 0.466542
R2655 VSS.t92 VSS.t52 0.466542
R2656 VSS.t236 VSS.t182 0.466542
R2657 VSS.t373 VSS.t256 0.466542
R2658 VSS.t34 VSS.t114 0.466542
R2659 VSS.n345 VSS.t321 0.466192
R2660 VSS.n350 VSS.t310 0.466192
R2661 VSS.n355 VSS.t185 0.466192
R2662 VSS.n360 VSS.t246 0.466192
R2663 VSS.n365 VSS.t316 0.466192
R2664 VSS.n370 VSS.t249 0.466192
R2665 VSS.n375 VSS.t364 0.466192
R2666 VSS.n380 VSS.t515 0.466192
R2667 VSS.n385 VSS.t619 0.466192
R2668 VSS.n390 VSS.t585 0.466192
R2669 VSS.n395 VSS.t324 0.466192
R2670 VSS.n400 VSS.t577 0.466192
R2671 VSS.n405 VSS.t368 0.466192
R2672 VSS.n410 VSS.t70 0.466192
R2673 VSS.n415 VSS.t192 0.466192
R2674 VSS.n420 VSS.t303 0.466192
R2675 VSS.n672 VSS.n595 0.465582
R2676 VSS.n610 VSS.t13 0.464894
R2677 VSS.n606 VSS.n604 0.460744
R2678 VSS.n607 VSS.n606 0.455207
R2679 VSS.t46 VSS.n420 0.451785
R2680 VSS.t200 VSS.n415 0.451785
R2681 VSS.t538 VSS.n410 0.451785
R2682 VSS.t24 VSS.n405 0.451785
R2683 VSS.t87 VSS.n400 0.451785
R2684 VSS.t210 VSS.n395 0.451785
R2685 VSS.t269 VSS.n390 0.451785
R2686 VSS.t40 VSS.n385 0.451785
R2687 VSS.t551 VSS.n380 0.451785
R2688 VSS.t240 VSS.n375 0.451785
R2689 VSS.t458 VSS.n370 0.451785
R2690 VSS.t85 VSS.n365 0.451785
R2691 VSS.t52 VSS.n360 0.451785
R2692 VSS.t182 VSS.n355 0.451785
R2693 VSS.t256 VSS.n350 0.451785
R2694 VSS.t114 VSS.n345 0.451785
R2695 VSS.t34 VSS.t310 0.451337
R2696 VSS.t373 VSS.t185 0.451337
R2697 VSS.t236 VSS.t246 0.451337
R2698 VSS.t92 VSS.t316 0.451337
R2699 VSS.t272 VSS.t249 0.451337
R2700 VSS.t73 VSS.t364 0.451337
R2701 VSS.t221 VSS.t515 0.451337
R2702 VSS.t591 VSS.t619 0.451337
R2703 VSS.t233 VSS.t585 0.451337
R2704 VSS.t78 VSS.t324 0.451337
R2705 VSS.t313 VSS.t577 0.451337
R2706 VSS.t31 VSS.t368 0.451337
R2707 VSS.t215 VSS.t70 0.451337
R2708 VSS.t587 VSS.t192 0.451337
R2709 VSS.t20 VSS.t303 0.451337
R2710 VSS.n581 VSS.n580 0.447348
R2711 VSS.n911 VSS.n174 0.44402
R2712 VSS.t260 VSS.n335 0.440228
R2713 VSS.t380 VSS.n333 0.440228
R2714 VSS.t54 VSS.n331 0.440228
R2715 VSS.t208 VSS.n330 0.440228
R2716 VSS.t332 VSS.n329 0.440228
R2717 VSS.t94 VSS.n325 0.440228
R2718 VSS.t223 VSS.n324 0.440228
R2719 VSS.t356 VSS.n323 0.440228
R2720 VSS.t50 VSS.n320 0.440228
R2721 VSS.t442 VSS.n318 0.440228
R2722 VSS.t291 VSS.n317 0.440228
R2723 VSS.t213 VSS.n316 0.440228
R2724 VSS.t107 VSS.n315 0.440228
R2725 VSS.t1 VSS.n314 0.440228
R2726 VSS.t281 VSS.n311 0.440228
R2727 VSS.t294 VSS.n310 0.440228
R2728 VSS.t203 VSS.n309 0.440228
R2729 VSS.n306 VSS.t449 0.440228
R2730 VSS.n307 VSS.t243 0.440228
R2731 VSS.n308 VSS.t22 0.440228
R2732 VSS.n312 VSS.t15 0.440228
R2733 VSS.n313 VSS.t26 0.440228
R2734 VSS.n319 VSS.t275 0.440228
R2735 VSS.n321 VSS.t38 0.440228
R2736 VSS.n322 VSS.t89 0.440228
R2737 VSS.n326 VSS.t75 0.440228
R2738 VSS.n327 VSS.t350 0.440228
R2739 VSS.n328 VSS.t3 0.440228
R2740 VSS.n332 VSS.t383 0.440228
R2741 VSS.n334 VSS.t377 0.440228
R2742 VSS.n336 VSS.t36 0.440228
R2743 VSS.n841 VSS.n542 0.418268
R2744 VSS.n797 VSS.n796 0.418268
R2745 VSS.n796 VSS.n542 0.414988
R2746 VSS.n798 VSS.n797 0.414988
R2747 VSS.n673 VSS.n546 0.41014
R2748 VSS.t83 VSS.n54 0.400619
R2749 VSS.n822 VSS.n821 0.376066
R2750 VSS.n756 VSS.n755 0.374771
R2751 VSS.n7 VSS.n6 0.351198
R2752 VSS.n815 VSS.n690 0.339481
R2753 VSS.n818 VSS.n817 0.338265
R2754 VSS.n817 VSS.n816 0.338019
R2755 VSS.n738 VSS.n690 0.336696
R2756 VSS.n836 VSS.n341 0.329994
R2757 VSS.n570 VSS.n569 0.312321
R2758 VSS.n838 VSS.n837 0.31114
R2759 VSS.n755 VSS.n754 0.307571
R2760 VSS.t123 VSS.n207 0.306378
R2761 VSS.t133 VSS.n222 0.306378
R2762 VSS.t144 VSS.n236 0.306378
R2763 VSS.t155 VSS.n259 0.306378
R2764 VSS.t165 VSS.n275 0.306378
R2765 VSS.t176 VSS.n292 0.306378
R2766 VSS.n821 VSS.n820 0.306341
R2767 VSS.t449 VSS.t532 0.302153
R2768 VSS.n672 VSS.t7 0.298621
R2769 VSS.n175 VSS.n910 0.295237
R2770 VSS.n550 VSS.n547 0.291601
R2771 VSS.n423 VSS.t46 0.290734
R2772 VSS.n773 VSS.n550 0.287886
R2773 VSS.n845 VSS.n533 0.286439
R2774 VSS.n847 VSS.n526 0.286439
R2775 VSS.n804 VSS.n803 0.286439
R2776 VSS.n865 VSS.n293 0.282782
R2777 VSS.n628 VSS.n627 0.280152
R2778 VSS.n631 VSS.n630 0.280152
R2779 VSS.n508 VSS.t321 0.275961
R2780 VSS.n910 VSS.n176 0.275933
R2781 VSS.t416 VSS.n554 0.275797
R2782 VSS.n510 VSS.n337 0.272321
R2783 VSS.n513 VSS.n508 0.272065
R2784 VSS.n81 VSS.n112 0.267794
R2785 VSS.n81 VSS.n113 0.267794
R2786 VSS.n81 VSS.n168 0.267794
R2787 VSS.n81 VSS.n115 0.267794
R2788 VSS.n81 VSS.n116 0.267794
R2789 VSS.n81 VSS.n167 0.267794
R2790 VSS.n81 VSS.n166 0.267794
R2791 VSS.n81 VSS.n117 0.267794
R2792 VSS.n81 VSS.n165 0.267794
R2793 VSS.n81 VSS.n118 0.267794
R2794 VSS.n81 VSS.n119 0.267794
R2795 VSS.n81 VSS.n120 0.267794
R2796 VSS.n81 VSS.n121 0.267794
R2797 VSS.n81 VSS.n164 0.267794
R2798 VSS.n81 VSS.n122 0.267794
R2799 VSS.n81 VSS.n123 0.267794
R2800 VSS.n81 VSS.n124 0.267794
R2801 VSS.n81 VSS.n125 0.267794
R2802 VSS.n81 VSS.n126 0.267794
R2803 VSS.n81 VSS.n163 0.267794
R2804 VSS.n81 VSS.n127 0.267794
R2805 VSS.n81 VSS.n128 0.267794
R2806 VSS.n81 VSS.n129 0.267794
R2807 VSS.n81 VSS.n130 0.267794
R2808 VSS.n81 VSS.n161 0.267794
R2809 VSS.n81 VSS.n131 0.267794
R2810 VSS.n81 VSS.n132 0.267794
R2811 VSS.n81 VSS.n133 0.267794
R2812 VSS.n81 VSS.n160 0.267794
R2813 VSS.n81 VSS.n135 0.267794
R2814 VSS.n81 VSS.n136 0.267794
R2815 VSS.n81 VSS.n137 0.267794
R2816 VSS.n81 VSS.n158 0.267794
R2817 VSS.n81 VSS.n157 0.267794
R2818 VSS.n81 VSS.n138 0.267794
R2819 VSS.n81 VSS.n156 0.267794
R2820 VSS.n81 VSS.n139 0.267794
R2821 VSS.n81 VSS.n140 0.267794
R2822 VSS.n81 VSS.n141 0.267794
R2823 VSS.n81 VSS.n142 0.267794
R2824 VSS.n81 VSS.n143 0.267794
R2825 VSS.n81 VSS.n144 0.267794
R2826 VSS.n81 VSS.n145 0.267794
R2827 VSS.n81 VSS.n153 0.267794
R2828 VSS.n81 VSS.n147 0.267794
R2829 VSS.n81 VSS.n152 0.267794
R2830 VSS.n81 VSS.n84 0.267794
R2831 VSS.n81 VSS.n86 0.267794
R2832 VSS.n81 VSS.n87 0.267794
R2833 VSS.n81 VSS.n88 0.267794
R2834 VSS.n81 VSS.n89 0.267794
R2835 VSS.n81 VSS.n90 0.267794
R2836 VSS.n81 VSS.n92 0.267794
R2837 VSS.n81 VSS.n93 0.267794
R2838 VSS.n81 VSS.n95 0.267794
R2839 VSS.n81 VSS.n96 0.267794
R2840 VSS.n81 VSS.n97 0.267794
R2841 VSS.n81 VSS.n98 0.267794
R2842 VSS.n81 VSS.n99 0.267794
R2843 VSS.n81 VSS.n101 0.267794
R2844 VSS.n81 VSS.n102 0.267794
R2845 VSS.n81 VSS.n103 0.267794
R2846 VSS.n81 VSS.n106 0.267794
R2847 VSS.n81 VSS.n107 0.267794
R2848 VSS.n81 VSS.n148 0.267428
R2849 VSS.n566 VSS.n554 0.266415
R2850 VSS.n841 VSS.n840 0.265497
R2851 VSS.t254 VSS.n337 0.264468
R2852 VSS.n840 VSS.n839 0.264227
R2853 VSS.n197 VSS.t80 0.263148
R2854 VSS.n776 VSS.n775 0.25755
R2855 VSS.n207 VSS.t125 0.255324
R2856 VSS.n222 VSS.t135 0.255324
R2857 VSS.n236 VSS.t146 0.255324
R2858 VSS.n259 VSS.t157 0.255324
R2859 VSS.n275 VSS.t167 0.255324
R2860 VSS.n292 VSS.t178 0.255324
R2861 VSS.t532 VSS.t492 0.254653
R2862 VSS.n81 VSS.n518 0.253558
R2863 VSS.t297 VSS.n423 0.24355
R2864 VSS.t252 VSS.n671 0.241078
R2865 VSS.t11 VSS.n646 0.241078
R2866 VSS.n856 VSS.n341 0.24011
R2867 VSS.n843 VSS.n538 0.239006
R2868 VSS.n530 VSS.n845 0.239006
R2869 VSS.n799 VSS.n792 0.239006
R2870 VSS.t336 VSS.n804 0.239006
R2871 VSS.n809 VSS.n781 0.239006
R2872 VSS.n811 VSS.n810 0.239006
R2873 VSS.n535 VSS.t338 0.239006
R2874 VSS.n803 VSS.n802 0.238668
R2875 VSS.n810 VSS.n809 0.238668
R2876 VSS.n813 VSS.n812 0.238668
R2877 VSS.n13 VSS.n778 0.332521
R2878 VSS.t338 VSS.n843 0.238668
R2879 VSS.n792 VSS.t461 0.238668
R2880 VSS.n781 VSS.t337 0.238668
R2881 VSS.n538 VSS.t335 0.238668
R2882 VSS.n533 VSS.t340 0.238668
R2883 VSS.n526 VSS.t344 0.238668
R2884 VSS.n571 VSS.n570 0.238218
R2885 VSS.n620 VSS.t427 0.233757
R2886 VSS.n623 VSS.n622 0.233757
R2887 VSS.n625 VSS.n624 0.233757
R2888 VSS.n629 VSS.n628 0.233757
R2889 VSS.n603 VSS.n631 0.233757
R2890 VSS.n622 VSS.n621 0.233419
R2891 VSS.n624 VSS.n623 0.233419
R2892 VSS.n627 VSS.n626 0.233419
R2893 VSS.n630 VSS.n629 0.233419
R2894 VSS.t410 VSS.n603 0.233419
R2895 VSS.n560 VSS.n558 0.225543
R2896 VSS.t119 VSS.t121 0.224424
R2897 VSS.t161 VSS.t163 0.224424
R2898 VSS.t172 VSS.t174 0.224424
R2899 VSS.t151 VSS.t153 0.224424
R2900 VSS.t140 VSS.t142 0.224424
R2901 VSS.t129 VSS.t131 0.224424
R2902 VSS.t118 VSS.t119 0.220674
R2903 VSS.t65 VSS.t161 0.220674
R2904 VSS.t171 VSS.t172 0.220674
R2905 VSS.t151 VSS.t150 0.220674
R2906 VSS.t140 VSS.t139 0.220674
R2907 VSS.t129 VSS.t62 0.220674
R2908 VSS.n577 VSS.n558 0.219552
R2909 VSS.t57 VSS.n681 0.211735
R2910 VSS.n832 VSS.n546 0.20686
R2911 VSS.n427 VSS.n303 0.20231
R2912 VSS.n582 VSS.n563 0.191235
R2913 VSS.t467 VSS.n539 0.191235
R2914 VSS.n844 VSS.n535 0.191235
R2915 VSS.n534 VSS.n844 0.191235
R2916 VSS.t340 VSS.n534 0.191235
R2917 VSS.n846 VSS.n529 0.191235
R2918 VSS.n527 VSS.n846 0.191235
R2919 VSS.t344 VSS.n527 0.191235
R2920 VSS.t461 VSS.n793 0.191235
R2921 VSS.n800 VSS.n799 0.191235
R2922 VSS.n801 VSS.n800 0.191235
R2923 VSS.n802 VSS.n801 0.191235
R2924 VSS.n786 VSS.n785 0.191235
R2925 VSS.n785 VSS.n784 0.191235
R2926 VSS.n784 VSS.t337 0.191235
R2927 VSS.n812 VSS.n811 0.191235
R2928 VSS.n428 VSS.n427 0.191235
R2929 VSS.n529 VSS.t342 0.191235
R2930 VSS.t342 VSS.n530 0.191235
R2931 VSS.n786 VSS.t336 0.191235
R2932 VSS.t335 VSS.t467 0.191235
R2933 VSS.t482 VSS.t479 0.1875
R2934 VSS.t476 VSS.t472 0.1875
R2935 VSS.t488 VSS.t485 0.1875
R2936 VSS.n621 VSS.n620 0.187025
R2937 VSS.n626 VSS.n625 0.187025
R2938 VSS.n779 VSS.n686 0.185557
R2939 VSS.n689 VSS.n770 0.182052
R2940 VSS.n684 VSS.n688 0.181924
R2941 VSS.n796 VSS.t459 0.167615
R2942 VSS.n685 VSS.n684 0.164424
R2943 VSS.n686 VSS.n770 0.164293
R2944 VSS.n81 VSS.n170 0.160396
R2945 VSS.n81 VSS.n172 0.160396
R2946 VSS.n81 VSS.n173 0.160396
R2947 VSS.n605 VSS.n562 0.156138
R2948 VSS.n838 VSS.n543 0.150687
R2949 VSS.t420 VSS.n65 0.14953
R2950 VSS.t400 VSS.n65 0.149502
R2951 VSS.n886 VSS.n237 0.144066
R2952 VSS.n772 VSS.n683 0.143368
R2953 VSS.n428 VSS.n425 0.142513
R2954 VSS.n777 VSS.n776 0.142388
R2955 VSS.t495 VSS.n303 0.139294
R2956 VSS.t413 VSS.n65 0.13875
R2957 VSS.t412 VSS.n65 0.138705
R2958 VSS.t395 VSS.n65 0.138693
R2959 VSS.t404 VSS.n65 0.138673
R2960 VSS.n837 VSS.n174 0.138073
R2961 VSS.t489 VSS.t297 0.135868
R2962 VSS.t492 VSS.n305 0.124618
R2963 VSS.t489 VSS.n302 0.122118
R2964 VSS.n305 VSS.t491 0.122118
R2965 VSS.n774 VSS.n772 0.120868
R2966 VSS.n777 VSS.t464 0.1171
R2967 VSS.n539 VSS.n541 0.112118
R2968 VSS.n793 VSS.n794 0.112118
R2969 VSS.t189 VSS.n293 0.109701
R2970 VSS.n425 VSS.t493 0.109642
R2971 VSS.n688 VSS.n687 0.104618
R2972 VSS.n689 VSS.n757 0.104618
R2973 VSS.t425 VSS.n65 0.103408
R2974 VSS.t408 VSS.n65 0.10335
R2975 VSS.n588 VSS.n13 0.192565
R2976 VSS.t477 VSS.n555 0.0971176
R2977 VSS.n605 VSS.n563 0.0971176
R2978 VSS.n778 VSS.n777 0.0971176
R2979 VSS.n562 VSS.n561 0.0958002
R2980 VSS.n561 VSS.n559 0.0955
R2981 VSS.n779 VSS.n588 0.0949351
R2982 VSS.n572 VSS.n571 0.093
R2983 VSS.t483 VSS.n340 0.08925
R2984 VSS.n515 VSS.t96 0.08925
R2985 VSS.t479 VSS.n579 0.0851154
R2986 VSS.n580 VSS.t482 0.0851154
R2987 VSS.t472 VSS.n568 0.0851154
R2988 VSS.n569 VSS.t476 0.0851154
R2989 VSS.t485 VSS.n512 0.0851154
R2990 VSS.n513 VSS.t488 0.0851154
R2991 VSS.n611 VSS.t512 0.0846176
R2992 VSS.n619 VSS.n545 0.0846176
R2993 VSS.n819 VSS.n818 0.08425
R2994 VSS.n739 VSS.n738 0.08425
R2995 VSS.n568 VSS.n5 0.08175
R2996 VSS.n579 VSS.n574 0.08175
R2997 VSS.n567 VSS.n552 0.08175
R2998 VSS.n578 VSS.n556 0.08175
R2999 VSS.n864 VSS.n863 0.0805
R3000 VSS.n824 VSS.n823 0.0805
R3001 VSS.n541 VSS.n540 0.0796176
R3002 VSS.n794 VSS.n795 0.0796176
R3003 VSS.t17 VSS.n517 0.078
R3004 VSS.t495 VSS.n304 0.0771176
R3005 VSS.n825 VSS.n824 0.07675
R3006 VSS.n540 VSS.n841 0.0758676
R3007 VSS.n795 VSS.n798 0.0758676
R3008 VSS.n512 VSS.n342 0.0746176
R3009 VSS.n511 VSS.n339 0.0746176
R3010 VSS.n834 VSS.n544 0.07425
R3011 VSS.n823 VSS.n685 0.07425
R3012 VSS.t473 VSS.n549 0.0740901
R3013 VSS.t470 VSS.n548 0.0740901
R3014 VSS.t570 VSS.n544 0.07175
R3015 VSS.t205 VSS.n518 0.0715199
R3016 VSS.t396 VSS.n611 0.0708676
R3017 VSS.t411 VSS.n619 0.0708676
R3018 VSS.t491 VSS.n304 0.0696176
R3019 VSS.n512 VSS.t98 0.06925
R3020 VSS.t123 VSS.n201 0.06925
R3021 VSS.t133 VSS.n220 0.06925
R3022 VSS.t144 VSS.n234 0.06925
R3023 VSS.t155 VSS.n257 0.06925
R3024 VSS.t165 VSS.n269 0.06925
R3025 VSS.t176 VSS.n286 0.06925
R3026 VSS.n820 VSS.n819 0.06925
R3027 VSS.n754 VSS.n739 0.06925
R3028 VSS.t570 VSS.n825 0.06925
R3029 VSS.n511 VSS.n338 0.06925
R3030 VSS.n569 VSS.n565 0.0671176
R3031 VSS.n580 VSS.n576 0.0671176
R3032 VSS.n566 VSS.n553 0.0671176
R3033 VSS.n577 VSS.n557 0.0671176
R3034 VSS.n568 VSS.n565 0.0621177
R3035 VSS.n579 VSS.n576 0.0621177
R3036 VSS.n567 VSS.n553 0.0621177
R3037 VSS.n578 VSS.n557 0.0621177
R3038 VSS.n510 VSS.n338 0.05925
R3039 VSS.n513 VSS.t98 0.05925
R3040 VSS.t416 VSS.n555 0.0571176
R3041 VSS.t96 VSS.n342 0.0546176
R3042 VSS.t483 VSS.n339 0.0546176
R3043 VSS.t121 VSS.n201 0.05175
R3044 VSS.n220 VSS.t131 0.05175
R3045 VSS.n234 VSS.t142 0.05175
R3046 VSS.n257 VSS.t153 0.05175
R3047 VSS.t163 VSS.n269 0.05175
R3048 VSS.t174 VSS.n286 0.05175
R3049 VSS.n687 VSS.n822 0.0496177
R3050 VSS.n757 VSS.n756 0.0496177
R3051 VSS.n573 VSS.n572 0.04925
R3052 VSS.n824 VSS.n683 0.048
R3053 VSS.n574 VSS.n573 0.04675
R3054 VSS.t477 VSS.n556 0.04675
R3055 VSS.n7 VSS.n4 0.0423393
R3056 VSS.n775 VSS.n774 0.0378652
R3057 VSS.n831 VSS.n5 0.0305
R3058 VSS.n552 VSS.n551 0.0305
R3059 VSS.t493 VSS.n149 0.02925
R3060 VSS.n549 VSS.n547 0.0253401
R3061 VSS.n773 VSS.n548 0.0253401
R3062 VSS.n865 VSS.n301 0.023135
R3063 VSS.n865 VSS.n296 0.023135
R3064 VSS.n868 VSS.n290 0.023135
R3065 VSS.n871 VSS.n277 0.023135
R3066 VSS.n871 VSS.n278 0.023135
R3067 VSS.n874 VSS.n273 0.023135
R3068 VSS.n877 VSS.n261 0.023135
R3069 VSS.n877 VSS.n262 0.023135
R3070 VSS.n881 VSS.n880 0.023135
R3071 VSS.n886 VSS.n240 0.023135
R3072 VSS.n886 VSS.n242 0.023135
R3073 VSS.n886 VSS.n243 0.023135
R3074 VSS.n886 VSS.n244 0.023135
R3075 VSS.n890 VSS.n889 0.023135
R3076 VSS.n895 VSS.n225 0.023135
R3077 VSS.n895 VSS.n226 0.023135
R3078 VSS.n899 VSS.n898 0.023135
R3079 VSS.n904 VSS.n210 0.023135
R3080 VSS.n904 VSS.n211 0.023135
R3081 VSS.n907 VSS.n205 0.023135
R3082 VSS.n910 VSS.n177 0.023135
R3083 VSS.n910 VSS.n181 0.023135
R3084 VSS.n910 VSS.n191 0.023135
R3085 VSS.n863 VSS.n302 0.02175
R3086 VSS.n175 VSS.t262 0.0191553
R3087 VSS.n665 VSS.t278 0.0184075
R3088 VSS.n651 VSS.t452 0.0184075
R3089 VSS.t57 VSS.n678 0.0173993
R3090 VSS.n831 VSS.t473 0.01675
R3091 VSS.n551 VSS.t470 0.01675
R3092 VSS.n81 VSS.n169 0.0165542
R3093 VSS.n81 VSS.n171 0.0165542
R3094 VSS.n864 VSS.n149 0.0155
R3095 VSS.t83 VSS.n53 0.0151406
R3096 VSS.n659 VSS.n58 0.0151406
R3097 VSS.n658 VSS.n58 0.0151406
R3098 VSS.n647 VSS.n598 0.0151406
R3099 VSS.t57 VSS.n674 0.0150892
R3100 VSS VSS.n911 0.0134067
R3101 VSS.n560 VSS.n559 0.013
R3102 VSS.n81 VSS.n162 0.00962826
R3103 VSS.n81 VSS.n159 0.00962826
R3104 VSS.n81 VSS.n155 0.00962826
R3105 VSS.n81 VSS.n154 0.00962826
R3106 VSS.n81 VSS.n151 0.00938635
R3107 VSS.n81 VSS.n134 0.00937856
R3108 VSS.n81 VSS.n146 0.00937856
R3109 VSS.n81 VSS.n85 0.00937856
R3110 VSS.n81 VSS.n91 0.00937856
R3111 VSS.n81 VSS.n94 0.00937856
R3112 VSS.n81 VSS.n114 0.00937856
R3113 VSS.n81 VSS.n100 0.00937856
R3114 VSS.n81 VSS.n104 0.00937856
R3115 VSS.n81 VSS.n105 0.00937856
R3116 VSS.n81 VSS.n108 0.00937856
R3117 VSS.n81 VSS.n109 0.00937856
R3118 VSS.n81 VSS.n110 0.00937856
R3119 VSS.n81 VSS.n111 0.00937856
R3120 VSS.n856 VSS.n515 0.00675
R3121 VSS.n836 VSS.n340 0.00675
R3122 VSS.n23 VSS.n536 0.00495229
R3123 VSS.n835 VSS.n34 0.00459701
R3124 VSS.n28 VSS.n29 0.00399966
R3125 VSS.n805 VSS.n43 0.00362425
R3126 VSS.n73 VSS.n74 0.00299994
R3127 VSS.n68 VSS.n69 0.00299994
R3128 VSS.n17 VSS.n12 0.00299994
R3129 VSS.n14 VSS.n10 0.00299994
R3130 VSS.n7 VSS.n0 0.00296307
R3131 VSS.n523 VSS.n34 0.00249997
R3132 VSS.n32 VSS.n528 0.00283308
R3133 VSS.n52 VSS.n51 0.00224999
R3134 VSS.n59 VSS.n58 0.0022
R3135 VSS.n826 VSS.n34 0.00216667
R3136 VSS.n633 VSS.n632 0.002125
R3137 VSS.n82 VSS.n80 0.00174993
R3138 VSS.n851 VSS.n34 0.00193134
R3139 VSS.n633 VSS.n65 0.00187493
R3140 VSS.n299 VSS.n291 0.00179957
R3141 VSS.n298 VSS.n291 0.00179957
R3142 VSS.n288 VSS.n285 0.00179957
R3143 VSS.n281 VSS.n274 0.00179957
R3144 VSS.n280 VSS.n274 0.00179957
R3145 VSS.n271 VSS.n268 0.00179957
R3146 VSS.n264 VSS.n258 0.00179957
R3147 VSS.n263 VSS.n258 0.00179957
R3148 VSS.n883 VSS.n254 0.00179957
R3149 VSS.n246 VSS.n235 0.00179957
R3150 VSS.n245 VSS.n235 0.00179957
R3151 VSS.n892 VSS.n231 0.00179957
R3152 VSS.n228 VSS.n221 0.00179957
R3153 VSS.n227 VSS.n221 0.00179957
R3154 VSS.n901 VSS.n217 0.00179957
R3155 VSS.n214 VSS.n206 0.00179957
R3156 VSS.n213 VSS.n206 0.00179957
R3157 VSS.n203 VSS.n200 0.00179957
R3158 VSS.n910 VSS.n184 0.00179957
R3159 VSS.n910 VSS.n186 0.00179957
R3160 VSS.n910 VSS.n190 0.00179957
R3161 VSS.n771 VSS.n9 0.00166667
R3162 VSS.n17 VSS.n16 0.00149995
R3163 VSS.n780 VSS.n11 0.00166667
R3164 VSS.n21 VSS.n20 0.00169993
R3165 VSS.n531 VSS.n522 0.00166667
R3166 VSS.n28 VSS.n27 0.00138884
R3167 VSS.n848 VSS.n521 0.00166667
R3168 VSS.n826 VSS.n15 0.00333323
R3169 VSS.n790 VSS.n782 0.00166667
R3170 VSS.n787 VSS.n783 0.00166667
R3171 VSS.n41 VSS.n40 0.00169993
R3172 VSS.n49 VSS.n48 0.00169993
R3173 VSS.n806 VSS.n50 0.00166667
R3174 VSS.n68 VSS.n67 0.00149995
R3175 VSS.n71 VSS.n70 0.00169993
R3176 VSS.n73 VSS.n72 0.00149995
R3177 VSS.n614 VSS.n601 0.00166667
R3178 VSS.n76 VSS.n75 0.00169993
R3179 VSS.n612 VSS.n602 0.00166667
R3180 VSS.n78 VSS.n77 0.00169993
R3181 VSS.n849 VSS.n14 0.00162501
R3182 VSS.n807 VSS.n780 0.00162501
R3183 VSS.n7 VSS.n2 0.00161188
R3184 VSS.n81 VSS.n79 0.0015
R3185 VSS.n632 VSS.n78 0.0015
R3186 VSS.n613 VSS.n76 0.0015
R3187 VSS.n616 VSS.n71 0.0015
R3188 VSS.n618 VSS.n65 0.0015
R3189 VSS.n63 VSS.n62 0.00214264
R3190 VSS.n63 VSS.t452 0.0015
R3191 VSS.n58 VSS.t452 0.0015
R3192 VSS.n807 VSS.n51 0.00137498
R3193 VSS.n849 VSS.n848 0.00137498
R3194 VSS.n670 VSS.t83 0.00136832
R3195 VSS.n791 VSS.n782 0.00133332
R3196 VSS.n788 VSS.n783 0.00133332
R3197 VSS.n806 VSS.n47 0.00133332
R3198 VSS.n532 VSS.n522 0.00133332
R3199 VSS.n525 VSS.n521 0.00133332
R3200 VSS.n615 VSS.n601 0.00133332
R3201 VSS.n613 VSS.n602 0.00133332
R3202 VSS.n910 VSS.n198 0.00104691
R3203 VSS.n7 VSS.n3 0.00103555
R3204 VSS.n636 VSS.n65 0.00103404
R3205 VSS.n642 VSS.n65 0.00103133
R3206 VSS.n7 VSS.n1 0.00102569
R3207 VSS.n865 VSS.n295 0.00101811
R3208 VSS.n871 VSS.n284 0.00101811
R3209 VSS.n871 VSS.n283 0.00101811
R3210 VSS.n877 VSS.n267 0.00101811
R3211 VSS.n877 VSS.n266 0.00101811
R3212 VSS.n886 VSS.n885 0.00101811
R3213 VSS.n886 VSS.n248 0.00101811
R3214 VSS.n895 VSS.n894 0.00101811
R3215 VSS.n895 VSS.n230 0.00101811
R3216 VSS.n904 VSS.n903 0.00101811
R3217 VSS.n904 VSS.n216 0.00101811
R3218 VSS.n910 VSS.n199 0.00101811
R3219 VSS.n886 VSS.n251 0.00100065
R3220 VSS.n865 VSS.n294 0.00100065
R3221 VSS.n886 VSS.n241 0.00100065
R3222 VSS.n886 VSS.n249 0.00100065
R3223 VSS.n910 VSS.n178 0.00100065
R3224 VSS.n639 VSS.n65 0.00100005
R3225 VSS.n635 VSS.n65 0.00100005
R3226 VSS.n640 VSS.n65 0.00100001
R3227 VSS.n637 VSS.n65 0.00100001
R3228 VSS.n641 VSS.n65 0.001
R3229 VSS.n638 VSS.n65 0.001
R3230 VSS.n866 VSS.n291 0.001
R3231 VSS.n868 VSS.n867 0.001
R3232 VSS.n869 VSS.n285 0.001
R3233 VSS.n871 VSS.n870 0.001
R3234 VSS.n872 VSS.n274 0.001
R3235 VSS.n874 VSS.n873 0.001
R3236 VSS.n875 VSS.n268 0.001
R3237 VSS.n877 VSS.n876 0.001
R3238 VSS.n878 VSS.n258 0.001
R3239 VSS.n880 VSS.n879 0.001
R3240 VSS.n883 VSS.n255 0.001
R3241 VSS.n886 VSS.n239 0.001
R3242 VSS.n887 VSS.n235 0.001
R3243 VSS.n889 VSS.n888 0.001
R3244 VSS.n892 VSS.n232 0.001
R3245 VSS.n895 VSS.n224 0.001
R3246 VSS.n896 VSS.n221 0.001
R3247 VSS.n898 VSS.n897 0.001
R3248 VSS.n901 VSS.n218 0.001
R3249 VSS.n904 VSS.n209 0.001
R3250 VSS.n905 VSS.n206 0.001
R3251 VSS.n907 VSS.n906 0.001
R3252 VSS.n908 VSS.n200 0.001
R3253 VSS.n910 VSS.n909 0.001
R3254 VSS.n909 VSS.n200 0.001
R3255 VSS.n908 VSS.n907 0.001
R3256 VSS.n906 VSS.n206 0.001
R3257 VSS.n905 VSS.n904 0.001
R3258 VSS.n901 VSS.n209 0.001
R3259 VSS.n898 VSS.n218 0.001
R3260 VSS.n897 VSS.n221 0.001
R3261 VSS.n896 VSS.n895 0.001
R3262 VSS.n892 VSS.n224 0.001
R3263 VSS.n889 VSS.n232 0.001
R3264 VSS.n888 VSS.n235 0.001
R3265 VSS.n887 VSS.n886 0.001
R3266 VSS.n883 VSS.n239 0.001
R3267 VSS.n880 VSS.n255 0.001
R3268 VSS.n879 VSS.n258 0.001
R3269 VSS.n878 VSS.n877 0.001
R3270 VSS.n876 VSS.n268 0.001
R3271 VSS.n875 VSS.n874 0.001
R3272 VSS.n873 VSS.n274 0.001
R3273 VSS.n872 VSS.n871 0.001
R3274 VSS.n870 VSS.n285 0.001
R3275 VSS.n869 VSS.n868 0.001
R3276 VSS.n867 VSS.n291 0.001
R3277 VSS.n866 VSS.n865 0.001
R3278 VSS.n82 VSS.n81 0.001
R3279 VSS.n791 VSS.n35 0.001
R3280 VSS.n789 VSS.n36 0.001
R3281 VSS.n788 VSS.n38 0.001
R3282 VSS.n44 VSS.n46 0.001
R3283 VSS.n52 VSS.n50 0.00174999
R3284 VSS.n842 VSS.n523 0.001
R3285 VSS.n537 VSS.n18 0.001
R3286 VSS.n532 VSS.n26 0.001
R3287 VSS.n528 VSS.n30 0.001
R3288 VSS.n525 VSS.n33 0.001
R3289 VSS.n57 VSS.n56 0.00192843
R3290 VSS.n56 VSS.t278 0.0015
R3291 VSS.t83 VSS.t278 0.0015
R3292 VSS.n48 VSS.n47 0.0015
R3293 VSS.n805 VSS.n41 0.0015
R3294 VSS.n39 VSS.n789 0.00199997
R3295 VSS.n37 VSS.n790 0.00199997
R3296 VSS.n34 VSS.n35 0.00199997
R3297 VSS.n536 VSS.n21 0.0015
R3298 VSS.n19 VSS.n842 0.00199997
R3299 VSS.n12 VSS.n11 0.00183332
R3300 VSS.n10 VSS.n9 0.00183332
R3301 VSS.n647 VSS.n64 0.001
R3302 VSS.n617 VSS.n69 0.001
R3303 VSS.n615 VSS.n74 0.001
R3304 VSS.n609 VSS.n583 0.001
R3305 VSS.t57 VSS.n583 0.001
R3306 VSS.n582 VSS.n8 8.47807
R3307 a_3747_311.n0 a_3747_311.t2 52.0388
R3308 a_3747_311.t1 a_3747_311.n0 35.4491
R3309 a_3747_311.n0 a_3747_311.t3 33.5891
R3310 a_3747_311.t0 a_3747_311.t1 5.61942
R3311 a_3171_311.n0 a_3171_311.t2 51.8377
R3312 a_3171_311.n0 a_3171_311.t3 33.3881
R3313 a_3171_311.t1 a_3171_311.n0 31.8923
R3314 a_3171_311.t0 a_3171_311.t1 5.61777
R3315 a_2595_311.n0 a_2595_311.t2 51.6367
R3316 a_2595_311.n0 a_2595_311.t3 33.187
R3317 a_2595_311.t1 a_2595_311.n0 27.993
R3318 a_2595_311.t0 a_2595_311.t1 5.73018
R3319 a_3747_1047.n0 a_3747_1047.t2 38.0081
R3320 a_3747_1047.n0 a_3747_1047.t3 33.3957
R3321 a_3747_1047.n1 a_3747_1047.t4 33.3957
R3322 a_3747_1047.n2 a_3747_1047.t5 33.3957
R3323 a_3747_1047.n3 a_3747_1047.t6 33.3957
R3324 a_3747_1047.n4 a_3747_1047.t7 33.3957
R3325 a_3747_1047.n5 a_3747_1047.t8 33.3957
R3326 a_3747_1047.n6 a_3747_1047.t9 33.3957
R3327 a_3747_1047.t1 a_3747_1047.n6 23.2419
R3328 a_3747_1047.t0 a_3747_1047.t1 5.61942
R3329 a_3747_1047.n6 a_3747_1047.n5 4.61291
R3330 a_3747_1047.n5 a_3747_1047.n4 4.61291
R3331 a_3747_1047.n4 a_3747_1047.n3 4.61291
R3332 a_3747_1047.n3 a_3747_1047.n2 4.61291
R3333 a_3747_1047.n2 a_3747_1047.n1 4.61291
R3334 a_3747_1047.n1 a_3747_1047.n0 4.61291
R3335 a_3171_1047.n0 a_3171_1047.t2 37.8054
R3336 a_3171_1047.n0 a_3171_1047.t3 33.193
R3337 a_3171_1047.n1 a_3171_1047.t4 33.193
R3338 a_3171_1047.n2 a_3171_1047.t5 33.193
R3339 a_3171_1047.n3 a_3171_1047.t6 33.193
R3340 a_3171_1047.n4 a_3171_1047.t7 33.193
R3341 a_3171_1047.n5 a_3171_1047.t8 33.193
R3342 a_3171_1047.n6 a_3171_1047.t9 33.193
R3343 a_3171_1047.t1 a_3171_1047.n6 23.0313
R3344 a_3171_1047.t0 a_3171_1047.t1 5.61777
R3345 a_3171_1047.n6 a_3171_1047.n5 4.61291
R3346 a_3171_1047.n5 a_3171_1047.n4 4.61291
R3347 a_3171_1047.n4 a_3171_1047.n3 4.61291
R3348 a_3171_1047.n3 a_3171_1047.n2 4.61291
R3349 a_3171_1047.n2 a_3171_1047.n1 4.61291
R3350 a_3171_1047.n1 a_3171_1047.n0 4.61291
R3351 a_2595_1047.n0 a_2595_1047.t2 37.7691
R3352 a_2595_1047.n0 a_2595_1047.t3 33.1567
R3353 a_2595_1047.n1 a_2595_1047.t4 33.1567
R3354 a_2595_1047.n2 a_2595_1047.t5 33.1567
R3355 a_2595_1047.n3 a_2595_1047.t6 33.1567
R3356 a_2595_1047.n4 a_2595_1047.t7 33.1567
R3357 a_2595_1047.n5 a_2595_1047.t8 33.1567
R3358 a_2595_1047.n6 a_2595_1047.t9 33.1567
R3359 a_2595_1047.t1 a_2595_1047.n6 22.7941
R3360 a_2595_1047.t0 a_2595_1047.t1 5.65522
R3361 a_2595_1047.n6 a_2595_1047.n5 4.61291
R3362 a_2595_1047.n5 a_2595_1047.n4 4.61291
R3363 a_2595_1047.n4 a_2595_1047.n3 4.61291
R3364 a_2595_1047.n3 a_2595_1047.n2 4.61291
R3365 a_2595_1047.n2 a_2595_1047.n1 4.61291
R3366 a_2595_1047.n1 a_2595_1047.n0 4.61291
R3367 a_2019_1047.n0 a_2019_1047.t2 37.9701
R3368 a_2019_1047.n0 a_2019_1047.t3 33.3577
R3369 a_2019_1047.n1 a_2019_1047.t4 33.3577
R3370 a_2019_1047.n2 a_2019_1047.t5 33.3577
R3371 a_2019_1047.n3 a_2019_1047.t6 33.3577
R3372 a_2019_1047.n4 a_2019_1047.t7 33.3577
R3373 a_2019_1047.n5 a_2019_1047.t8 33.3577
R3374 a_2019_1047.t1 a_2019_1047.t9 22.5945
R3375 a_2019_1047.t0 a_2019_1047.t1 5.62052
R3376 a_2019_1047.t9 a_2019_1047.n5 4.61291
R3377 a_2019_1047.n5 a_2019_1047.n4 4.61291
R3378 a_2019_1047.n4 a_2019_1047.n3 4.61291
R3379 a_2019_1047.n3 a_2019_1047.n2 4.61291
R3380 a_2019_1047.n2 a_2019_1047.n1 4.61291
R3381 a_2019_1047.n1 a_2019_1047.n0 4.61291
C1414 MUX_OUT VSS 3.24058f
C1415 MUX_SEL4 VSS 1.60778f
C1416 MUX_SEL3 VSS 0.90686f
C1417 MUX_SEL2 VSS 1.81137f
C1418 MUX_SEL1 VSS 0.95075f
C1419 MUX_SEL0 VSS 1.5515f
C1420 DELAY_VBIASP VSS 5.14139f
C1421 DELAY_OUT_LAST VSS 2.97841f
C1422 DELAY_VBIASN VSS 0.11242p
C1423 REF_CLK VSS 3.19236f
C1424 DLL_RESETN VSS 4.18452f
C1425 VDD VSS 61.87563f
C1426 a_26985_519# VSS 0.17928f ; **FLOATING
C1427 a_23945_519# VSS 0.17928f ; **FLOATING
C1428 a_20905_519# VSS 0.17928f ; **FLOATING
C1429 a_17865_519# VSS 0.17593f ; **FLOATING
C1430 a_16851_309# VSS 0.38699f ; **FLOATING
C1431 a_16108_289# VSS 3.70428f ; **FLOATING
C1432 a_15964_289# VSS 0.17613f ; **FLOATING
C1433 a_15765_463# VSS 0.36132f ; **FLOATING
C1434 a_14825_519# VSS 0.17928f ; **FLOATING
C1435 a_11785_519# VSS 0.17928f ; **FLOATING
C1436 a_8745_519# VSS 0.17928f ; **FLOATING
C1437 a_5731_289# VSS 3.39133f ; **FLOATING
C1438 a_2019_311# VSS 1.61601f ; **FLOATING
C1439 a_5705_519# VSS 0.17638f ; **FLOATING
C1440 a_3449_331# VSS 0.18478f ; **FLOATING
C1441 a_2873_331# VSS 0.18321f ; **FLOATING
C1442 a_2297_331# VSS 0.18321f ; **FLOATING
C1443 a_1721_331# VSS 0.17001f ; **FLOATING
C1444 a_1544_289# VSS 0.30014f ; **FLOATING
C1445 a_1256_289# VSS 0.84266f ; **FLOATING
C1446 a_27991_1008# VSS 0.18706f ; **FLOATING
C1447 a_27915_1044# VSS 0.10926f ; **FLOATING
C1448 a_27124_1008# VSS 0.17878f ; **FLOATING
C1449 a_27048_1044# VSS 0.12122f ; **FLOATING
C1450 a_26471_1008# VSS 0.18175f ; **FLOATING
C1451 a_26395_1044# VSS 0.11073f ; **FLOATING
C1452 a_25604_1008# VSS 0.18087f ; **FLOATING
C1453 a_25630_1044# VSS 0.37805f ; **FLOATING
C1454 a_25528_1044# VSS 0.12433f ; **FLOATING
C1455 a_24951_1008# VSS 0.18335f ; **FLOATING
C1456 a_24875_1044# VSS 0.11016f ; **FLOATING
C1457 a_24084_1008# VSS 0.17878f ; **FLOATING
C1458 a_24008_1044# VSS 0.12122f ; **FLOATING
C1459 a_23431_1008# VSS 0.18175f ; **FLOATING
C1460 a_23355_1044# VSS 0.11073f ; **FLOATING
C1461 a_22564_1008# VSS 0.18087f ; **FLOATING
C1462 a_22590_1044# VSS 0.33314f ; **FLOATING
C1463 a_22488_1044# VSS 0.12433f ; **FLOATING
C1464 a_21911_1008# VSS 0.18335f ; **FLOATING
C1465 a_21835_1044# VSS 0.11016f ; **FLOATING
C1466 a_21044_1008# VSS 0.17878f ; **FLOATING
C1467 a_20968_1044# VSS 0.12122f ; **FLOATING
C1468 a_20391_1008# VSS 0.18175f ; **FLOATING
C1469 a_20315_1044# VSS 0.11073f ; **FLOATING
C1470 a_19524_1008# VSS 0.18087f ; **FLOATING
C1471 a_19550_1044# VSS 0.33563f ; **FLOATING
C1472 a_19448_1044# VSS 0.12433f ; **FLOATING
C1473 a_18871_1008# VSS 0.18335f ; **FLOATING
C1474 a_18795_1044# VSS 0.11016f ; **FLOATING
C1475 a_18004_1008# VSS 0.17878f ; **FLOATING
C1476 a_17928_1044# VSS 0.12122f ; **FLOATING
C1477 a_17351_1008# VSS 0.18022f ; **FLOATING
C1478 a_17275_1044# VSS 0.10926f ; **FLOATING
C1479 a_16484_1008# VSS 0.18023f ; **FLOATING
C1480 a_16510_1044# VSS 0.28935f ; **FLOATING
C1481 a_16408_1044# VSS 0.1229f ; **FLOATING
C1482 a_15831_1008# VSS 0.17846f ; **FLOATING
C1483 a_15755_1044# VSS 0.10926f ; **FLOATING
C1484 a_14964_1008# VSS 0.17878f ; **FLOATING
C1485 a_14888_1044# VSS 0.12122f ; **FLOATING
C1486 a_14311_1008# VSS 0.18175f ; **FLOATING
C1487 a_14235_1044# VSS 0.11073f ; **FLOATING
C1488 a_13444_1008# VSS 0.18087f ; **FLOATING
C1489 a_13470_1044# VSS 0.30333f ; **FLOATING
C1490 a_13368_1044# VSS 0.12433f ; **FLOATING
C1491 a_12791_1008# VSS 0.18335f ; **FLOATING
C1492 a_12715_1044# VSS 0.11016f ; **FLOATING
C1493 a_11924_1008# VSS 0.17878f ; **FLOATING
C1494 a_11848_1044# VSS 0.12122f ; **FLOATING
C1495 a_11271_1008# VSS 0.18175f ; **FLOATING
C1496 a_11195_1044# VSS 0.11073f ; **FLOATING
C1497 a_10404_1008# VSS 0.18087f ; **FLOATING
C1498 a_10430_1044# VSS 0.31665f ; **FLOATING
C1499 a_10328_1044# VSS 0.12433f ; **FLOATING
C1500 a_9751_1008# VSS 0.18335f ; **FLOATING
C1501 a_9675_1044# VSS 0.11016f ; **FLOATING
C1502 a_8884_1008# VSS 0.17878f ; **FLOATING
C1503 a_8808_1044# VSS 0.12122f ; **FLOATING
C1504 a_8231_1008# VSS 0.18175f ; **FLOATING
C1505 a_8155_1044# VSS 0.11073f ; **FLOATING
C1506 a_7364_1008# VSS 0.18087f ; **FLOATING
C1507 a_7390_1044# VSS 0.31357f ; **FLOATING
C1508 a_7288_1044# VSS 0.12433f ; **FLOATING
C1509 a_6711_1008# VSS 0.18335f ; **FLOATING
C1510 a_6635_1044# VSS 0.11016f ; **FLOATING
C1511 a_5844_1008# VSS 0.17878f ; **FLOATING
C1512 a_5768_1044# VSS 0.12122f ; **FLOATING
C1513 a_5191_1008# VSS 0.18022f ; **FLOATING
C1514 a_5115_1044# VSS 0.10926f ; **FLOATING
C1515 a_4324_1008# VSS 0.18023f ; **FLOATING
C1516 a_4350_1044# VSS 0.26655f ; **FLOATING
C1517 a_4248_1044# VSS 0.12443f ; **FLOATING
C1518 a_27705_1044# VSS 0.25297f ; **FLOATING
C1519 a_26185_1044# VSS 0.23475f ; **FLOATING
C1520 a_24665_1044# VSS 0.25433f ; **FLOATING
C1521 a_23145_1044# VSS 0.23475f ; **FLOATING
C1522 a_21625_1044# VSS 0.25433f ; **FLOATING
C1523 a_20105_1044# VSS 0.23475f ; **FLOATING
C1524 a_18585_1044# VSS 0.25433f ; **FLOATING
C1525 a_17065_1044# VSS 0.23386f ; **FLOATING
C1526 a_15545_1044# VSS 0.25297f ; **FLOATING
C1527 a_14025_1044# VSS 0.23475f ; **FLOATING
C1528 a_12505_1044# VSS 0.25433f ; **FLOATING
C1529 a_10985_1044# VSS 0.23475f ; **FLOATING
C1530 a_9465_1044# VSS 0.25433f ; **FLOATING
C1531 a_7945_1044# VSS 0.23475f ; **FLOATING
C1532 a_6425_1044# VSS 0.25433f ; **FLOATING
C1533 a_4905_1044# VSS 0.23549f ; **FLOATING
C1534 a_4157_1313# VSS 0.32875f ; **FLOATING
C1535 a_3449_1395# VSS 0.18629f ; **FLOATING
C1536 a_2873_1395# VSS 0.18349f ; **FLOATING
C1537 a_2297_1395# VSS 0.18349f ; **FLOATING
C1538 a_1721_1395# VSS 0.17029f ; **FLOATING
C1539 a_1544_1044# VSS 0.29829f ; **FLOATING
C1540 a_1256_1044# VSS 0.82974f ; **FLOATING
C1541 a_27671_1842# VSS 0.01336f ; **FLOATING
C1542 a_26911_1842# VSS 0.01336f ; **FLOATING
C1543 a_26151_1842# VSS 0.01336f ; **FLOATING
C1544 a_25391_1842# VSS 0.01336f ; **FLOATING
C1545 a_24631_1842# VSS 0.01336f ; **FLOATING
C1546 a_23871_1842# VSS 0.01336f ; **FLOATING
C1547 a_23111_1842# VSS 0.01336f ; **FLOATING
C1548 a_22351_1842# VSS 0.01336f ; **FLOATING
C1549 a_21591_1842# VSS 0.01336f ; **FLOATING
C1550 a_20831_1842# VSS 0.01336f ; **FLOATING
C1551 a_20071_1842# VSS 0.01336f ; **FLOATING
C1552 a_19311_1842# VSS 0.01336f ; **FLOATING
C1553 a_18551_1842# VSS 0.01336f ; **FLOATING
C1554 a_17791_1842# VSS 0.01336f ; **FLOATING
C1555 a_17031_1842# VSS 0.01336f ; **FLOATING
C1556 a_16271_1842# VSS 0.01336f ; **FLOATING
C1557 a_15511_1842# VSS 0.01336f ; **FLOATING
C1558 a_14751_1842# VSS 0.01336f ; **FLOATING
C1559 a_13991_1842# VSS 0.01336f ; **FLOATING
C1560 a_13231_1842# VSS 0.01336f ; **FLOATING
C1561 a_12471_1842# VSS 0.01336f ; **FLOATING
C1562 a_11711_1842# VSS 0.01336f ; **FLOATING
C1563 a_10951_1842# VSS 0.01336f ; **FLOATING
C1564 a_10191_1842# VSS 0.01336f ; **FLOATING
C1565 a_9431_1842# VSS 0.01336f ; **FLOATING
C1566 a_8671_1842# VSS 0.01336f ; **FLOATING
C1567 a_7911_1842# VSS 0.01336f ; **FLOATING
C1568 a_7151_1842# VSS 0.01336f ; **FLOATING
C1569 a_6391_1842# VSS 0.01336f ; **FLOATING
C1570 a_5631_1842# VSS 0.01336f ; **FLOATING
C1571 a_4871_1842# VSS 0.01336f ; **FLOATING
C1572 a_4111_1842# VSS 0.0139f ; **FLOATING
C1573 a_27563_1842# VSS 0.50316f ; **FLOATING
C1574 a_27997_1842# VSS 0.6484f ; **FLOATING
C1575 a_27433_1842# VSS 0.4463f ; **FLOATING
C1576 a_26803_1842# VSS 0.49934f ; **FLOATING
C1577 a_27237_1842# VSS 0.92967f ; **FLOATING
C1578 a_26673_1842# VSS 0.4492f ; **FLOATING
C1579 a_26043_1842# VSS 0.50169f ; **FLOATING
C1580 a_26477_1842# VSS 0.95928f ; **FLOATING
C1581 a_25913_1842# VSS 0.4508f ; **FLOATING
C1582 a_25283_1842# VSS 0.49938f ; **FLOATING
C1583 a_25717_1842# VSS 0.86841f ; **FLOATING
C1584 a_25153_1842# VSS 0.45035f ; **FLOATING
C1585 a_24523_1842# VSS 0.50075f ; **FLOATING
C1586 a_24957_1842# VSS 0.96341f ; **FLOATING
C1587 a_24393_1842# VSS 0.4463f ; **FLOATING
C1588 a_23763_1842# VSS 0.49934f ; **FLOATING
C1589 a_24197_1842# VSS 0.92543f ; **FLOATING
C1590 a_23633_1842# VSS 0.45062f ; **FLOATING
C1591 a_23003_1842# VSS 0.50169f ; **FLOATING
C1592 a_23437_1842# VSS 0.95769f ; **FLOATING
C1593 a_22873_1842# VSS 0.4508f ; **FLOATING
C1594 a_22243_1842# VSS 0.49938f ; **FLOATING
C1595 a_22677_1842# VSS 0.86841f ; **FLOATING
C1596 a_22113_1842# VSS 0.45249f ; **FLOATING
C1597 a_21483_1842# VSS 0.50075f ; **FLOATING
C1598 a_21917_1842# VSS 0.96341f ; **FLOATING
C1599 a_21353_1842# VSS 0.4463f ; **FLOATING
C1600 a_20723_1842# VSS 0.49992f ; **FLOATING
C1601 a_21157_1842# VSS 0.92543f ; **FLOATING
C1602 a_20593_1842# VSS 0.45196f ; **FLOATING
C1603 a_19963_1842# VSS 0.50169f ; **FLOATING
C1604 a_20397_1842# VSS 0.95769f ; **FLOATING
C1605 a_19833_1842# VSS 0.4508f ; **FLOATING
C1606 a_19203_1842# VSS 0.5005f ; **FLOATING
C1607 a_19637_1842# VSS 0.86841f ; **FLOATING
C1608 a_19073_1842# VSS 0.44947f ; **FLOATING
C1609 a_18443_1842# VSS 0.50075f ; **FLOATING
C1610 a_18877_1842# VSS 0.96341f ; **FLOATING
C1611 a_18313_1842# VSS 0.4463f ; **FLOATING
C1612 a_17683_1842# VSS 0.50046f ; **FLOATING
C1613 a_18117_1842# VSS 0.92543f ; **FLOATING
C1614 a_17553_1842# VSS 0.44782f ; **FLOATING
C1615 a_16923_1842# VSS 0.50165f ; **FLOATING
C1616 a_17357_1842# VSS 0.95769f ; **FLOATING
C1617 a_16793_1842# VSS 0.45049f ; **FLOATING
C1618 a_16163_1842# VSS 0.4946f ; **FLOATING
C1619 a_16597_1842# VSS 0.86359f ; **FLOATING
C1620 a_16033_1842# VSS 0.44618f ; **FLOATING
C1621 a_15403_1842# VSS 0.49465f ; **FLOATING
C1622 a_15837_1842# VSS 0.95171f ; **FLOATING
C1623 a_15273_1842# VSS 0.44439f ; **FLOATING
C1624 a_14643_1842# VSS 0.49305f ; **FLOATING
C1625 a_15077_1842# VSS 0.92116f ; **FLOATING
C1626 a_14513_1842# VSS 0.44501f ; **FLOATING
C1627 a_13883_1842# VSS 0.50862f ; **FLOATING
C1628 a_14317_1842# VSS 0.96009f ; **FLOATING
C1629 a_13753_1842# VSS 0.46427f ; **FLOATING
C1630 a_13123_1842# VSS 0.50173f ; **FLOATING
C1631 a_13557_1842# VSS 0.87587f ; **FLOATING
C1632 a_12993_1842# VSS 0.45643f ; **FLOATING
C1633 a_12363_1842# VSS 0.50854f ; **FLOATING
C1634 a_12797_1842# VSS 0.96142f ; **FLOATING
C1635 a_12233_1842# VSS 0.45757f ; **FLOATING
C1636 a_11603_1842# VSS 0.50267f ; **FLOATING
C1637 a_12037_1842# VSS 0.92866f ; **FLOATING
C1638 a_11473_1842# VSS 0.45177f ; **FLOATING
C1639 a_10843_1842# VSS 0.50491f ; **FLOATING
C1640 a_11277_1842# VSS 0.96053f ; **FLOATING
C1641 a_10713_1842# VSS 0.44901f ; **FLOATING
C1642 a_10083_1842# VSS 0.50223f ; **FLOATING
C1643 a_10517_1842# VSS 0.87053f ; **FLOATING
C1644 a_9953_1842# VSS 0.44673f ; **FLOATING
C1645 a_9323_1842# VSS 0.5026f ; **FLOATING
C1646 a_9757_1842# VSS 0.96312f ; **FLOATING
C1647 a_9193_1842# VSS 0.44361f ; **FLOATING
C1648 a_8563_1842# VSS 0.49203f ; **FLOATING
C1649 a_8997_1842# VSS 0.92196f ; **FLOATING
C1650 a_8433_1842# VSS 0.44439f ; **FLOATING
C1651 a_7803_1842# VSS 0.49435f ; **FLOATING
C1652 a_8237_1842# VSS 0.95422f ; **FLOATING
C1653 a_7673_1842# VSS 0.44737f ; **FLOATING
C1654 a_7043_1842# VSS 0.49204f ; **FLOATING
C1655 a_7477_1842# VSS 0.86493f ; **FLOATING
C1656 a_6913_1842# VSS 0.44442f ; **FLOATING
C1657 a_6283_1842# VSS 0.49343f ; **FLOATING
C1658 a_6717_1842# VSS 0.95763f ; **FLOATING
C1659 a_6153_1842# VSS 0.44292f ; **FLOATING
C1660 a_5523_1842# VSS 0.50322f ; **FLOATING
C1661 a_5957_1842# VSS 0.92646f ; **FLOATING
C1662 a_5393_1842# VSS 0.4596f ; **FLOATING
C1663 a_4763_1842# VSS 0.51043f ; **FLOATING
C1664 a_5197_1842# VSS 0.96509f ; **FLOATING
C1665 a_4633_1842# VSS 0.46282f ; **FLOATING
C1666 a_4003_1842# VSS 0.58808f ; **FLOATING
C1667 a_4437_1842# VSS 0.87628f ; **FLOATING
C1668 a_9712_3912# VSS 1.25906f ; **FLOATING
C1669 a_9444_3912# VSS 2.12877f ; **FLOATING
C1670 a_5778_3367# VSS 5.22809f ; **FLOATING
C1671 a_15464_3684# VSS 0.75391f ; **FLOATING
C1672 a_14757_5182# VSS 0.09495f ; **FLOATING
C1673 a_13880_5118# VSS 0.06985f ; **FLOATING
C1674 a_15688_5403# VSS 0.26291f ; **FLOATING
C1675 a_15108_5325# VSS 0.24458f ; **FLOATING
C1676 a_14851_5182# VSS 0.38123f ; **FLOATING
C1677 a_9444_4590# VSS 6.03808f ; **FLOATING
C1678 a_14111_5227# VSS 0.19866f ; **FLOATING
C1679 a_14009_5084# VSS 0.44622f ; **FLOATING
C1680 a_13592_5423# VSS 1.57456f ; **FLOATING
C1681 a_13306_5105# VSS 0.30095f ; **FLOATING
C1682 a_13566_5328# VSS 0.15441f ; **FLOATING
C1683 a_13132_5420# VSS 0.13036f ; **FLOATING
C1684 a_12907_5420# VSS 0.14377f ; **FLOATING
C1685 a_12907_5186# VSS 0.14861f ; **FLOATING
C1686 a_13106_5357# VSS 0.06343f ; **FLOATING
C1687 a_15304_4605# VSS 0.37009f ; **FLOATING
C1688 a_14757_6228# VSS 0.09586f ; **FLOATING
C1689 a_15688_5867# VSS 0.26405f ; **FLOATING
C1690 a_14851_6228# VSS 0.39588f ; **FLOATING
C1691 a_15108_6109# VSS 0.24582f ; **FLOATING
C1692 a_14111_5878# VSS 0.21915f ; **FLOATING
C1693 a_13880_6292# VSS 0.07345f ; **FLOATING
C1694 a_14009_5878# VSS 0.48187f ; **FLOATING
C1695 a_13592_5871# VSS 1.58208f ; **FLOATING
C1696 a_13566_5835# VSS 0.15442f ; **FLOATING
C1697 a_13045_6215# VSS 0.01124f ; **FLOATING
C1698 a_13306_6305# VSS 0.31701f ; **FLOATING
C1699 a_12849_5867# VSS 1.40248f ; **FLOATING
C1700 a_13121_5831# VSS 0.80439f ; **FLOATING
C1701 a_13019_5831# VSS 2.18715f ; **FLOATING
C1702 a_12656_5864# VSS 0.28393f ; **FLOATING
C1703 a_12355_5867# VSS 0.62262f ; **FLOATING
C1704 a_11397_6228# VSS 0.09495f ; **FLOATING
C1705 a_12158_5867# VSS 0.25874f ; **FLOATING
C1706 a_11491_6228# VSS 0.30073f ; **FLOATING
C1707 a_11748_6109# VSS 0.17021f ; **FLOATING
C1708 a_10751_5878# VSS 0.19918f ; **FLOATING
C1709 a_10520_6292# VSS 0.03671f ; **FLOATING
C1710 a_10649_5878# VSS 0.47308f ; **FLOATING
C1711 a_10232_5871# VSS 1.52123f ; **FLOATING
C1712 a_10206_5835# VSS 0.08466f ; **FLOATING
C1713 a_9946_6305# VSS 0.18126f ; **FLOATING
C1714 a_9772_5843# VSS 0.12435f ; **FLOATING
C1715 a_9746_5805# VSS 0.06613f ; **FLOATING
C1716 a_9547_6172# VSS 0.16037f ; **FLOATING
C1717 a_9547_5942# VSS 0.11966f ; **FLOATING
C1718 a_6854_5454# VSS 3.66026f ; **FLOATING
C1719 a_6126_3816# VSS 13.6177f ; **FLOATING
C1720 a_6854_5986# VSS 1.41376f ; **FLOATING
C1721 a_5974_5723# VSS 2.40124f ; **FLOATING
C1722 a_6326_4590# VSS 1.03474f ; **FLOATING
C1723 a_2019_1047.t2 VSS 0.93027f ; **FLOATING
C1724 a_2019_1047.t3 VSS 0.70623f ; **FLOATING
C1725 a_2019_1047.n0 VSS 5.00884f ; **FLOATING
C1726 a_2019_1047.t4 VSS 0.70623f ; **FLOATING
C1727 a_2019_1047.n1 VSS 3.38862f ; **FLOATING
C1728 a_2019_1047.t5 VSS 0.70623f ; **FLOATING
C1729 a_2019_1047.n2 VSS 3.38862f ; **FLOATING
C1730 a_2019_1047.t6 VSS 0.70623f ; **FLOATING
C1731 a_2019_1047.n3 VSS 3.38862f ; **FLOATING
C1732 a_2019_1047.t7 VSS 0.70623f ; **FLOATING
C1733 a_2019_1047.n4 VSS 3.38862f ; **FLOATING
C1734 a_2019_1047.t8 VSS 0.70623f ; **FLOATING
C1735 a_2019_1047.n5 VSS 3.38862f ; **FLOATING
C1736 a_2019_1047.t9 VSS 5.45485f ; **FLOATING
C1737 a_2019_1047.t1 VSS 1.07257f ; **FLOATING
C1738 a_2019_1047.t0 VSS 0.30486f ; **FLOATING
C1739 a_2595_1047.t2 VSS 1.36703f ; **FLOATING
C1740 a_2595_1047.t3 VSS 1.02094f ; **FLOATING
C1741 a_2595_1047.n0 VSS 7.76123f ; **FLOATING
C1742 a_2595_1047.t4 VSS 1.02094f ; **FLOATING
C1743 a_2595_1047.n1 VSS 5.2734f ; **FLOATING
C1744 a_2595_1047.t5 VSS 1.02094f ; **FLOATING
C1745 a_2595_1047.n2 VSS 5.2734f ; **FLOATING
C1746 a_2595_1047.t6 VSS 1.02094f ; **FLOATING
C1747 a_2595_1047.n3 VSS 5.2734f ; **FLOATING
C1748 a_2595_1047.t7 VSS 1.02094f ; **FLOATING
C1749 a_2595_1047.n4 VSS 5.2734f ; **FLOATING
C1750 a_2595_1047.t8 VSS 1.02094f ; **FLOATING
C1751 a_2595_1047.n5 VSS 5.2734f ; **FLOATING
C1752 a_2595_1047.t9 VSS 1.02094f ; **FLOATING
C1753 a_2595_1047.n6 VSS 7.58547f ; **FLOATING
C1754 a_2595_1047.t1 VSS 1.75119f ; **FLOATING
C1755 a_2595_1047.t0 VSS 0.48227f ; **FLOATING
C1756 a_3171_1047.t2 VSS 1.38442f ; **FLOATING
C1757 a_3171_1047.t3 VSS 1.03734f ; **FLOATING
C1758 a_3171_1047.n0 VSS 7.77858f ; **FLOATING
C1759 a_3171_1047.t4 VSS 1.03734f ; **FLOATING
C1760 a_3171_1047.n1 VSS 5.28084f ; **FLOATING
C1761 a_3171_1047.t5 VSS 1.03734f ; **FLOATING
C1762 a_3171_1047.n2 VSS 5.28084f ; **FLOATING
C1763 a_3171_1047.t6 VSS 1.03734f ; **FLOATING
C1764 a_3171_1047.n3 VSS 5.28084f ; **FLOATING
C1765 a_3171_1047.t7 VSS 1.03734f ; **FLOATING
C1766 a_3171_1047.n4 VSS 5.28084f ; **FLOATING
C1767 a_3171_1047.t8 VSS 1.03734f ; **FLOATING
C1768 a_3171_1047.n5 VSS 5.28084f ; **FLOATING
C1769 a_3171_1047.t9 VSS 1.03734f ; **FLOATING
C1770 a_3171_1047.n6 VSS 7.68349f ; **FLOATING
C1771 a_3171_1047.t1 VSS 1.77027f ; **FLOATING
C1772 a_3171_1047.t0 VSS 0.48084f ; **FLOATING
C1773 a_3747_1047.t2 VSS 0.96885f ; **FLOATING
C1774 a_3747_1047.t3 VSS 0.7376f ; **FLOATING
C1775 a_3747_1047.n0 VSS 5.16746f ; **FLOATING
C1776 a_3747_1047.t4 VSS 0.7376f ; **FLOATING
C1777 a_3747_1047.n1 VSS 3.49313f ; **FLOATING
C1778 a_3747_1047.t5 VSS 0.7376f ; **FLOATING
C1779 a_3747_1047.n2 VSS 3.49313f ; **FLOATING
C1780 a_3747_1047.t6 VSS 0.7376f ; **FLOATING
C1781 a_3747_1047.n3 VSS 3.49313f ; **FLOATING
C1782 a_3747_1047.t7 VSS 0.7376f ; **FLOATING
C1783 a_3747_1047.n4 VSS 3.49313f ; **FLOATING
C1784 a_3747_1047.t8 VSS 0.7376f ; **FLOATING
C1785 a_3747_1047.n5 VSS 3.49313f ; **FLOATING
C1786 a_3747_1047.t9 VSS 0.7376f ; **FLOATING
C1787 a_3747_1047.n6 VSS 5.1869f ; **FLOATING
C1788 a_3747_1047.t1 VSS 1.18535f ; **FLOATING
C1789 a_3747_1047.t0 VSS 0.31338f ; **FLOATING
C1790 a_2595_311.t1 VSS 3.27037f ; **FLOATING
C1791 a_2595_311.t2 VSS 5.04145f ; **FLOATING
C1792 a_2595_311.t3 VSS 1.20632f ; **FLOATING
C1793 a_2595_311.n0 VSS 26.8668f ; **FLOATING
C1794 a_2595_311.t0 VSS 0.49572f ; **FLOATING
C1795 a_3171_311.t2 VSS 5.05009f ; **FLOATING
C1796 a_3171_311.t3 VSS 1.21149f ; **FLOATING
C1797 a_3171_311.n0 VSS 29.8499f ; **FLOATING
C1798 a_3171_311.t1 VSS 4.61154f ; **FLOATING
C1799 a_3171_311.t0 VSS 0.4973f ; **FLOATING
C1800 a_3747_311.t2 VSS 3.08793f ; **FLOATING
C1801 a_3747_311.t3 VSS 0.74323f ; **FLOATING
C1802 a_3747_311.n0 VSS 19.8622f ; **FLOATING
C1803 a_3747_311.t1 VSS 3.68404f ; **FLOATING
C1804 a_3747_311.t0 VSS 0.30496f ; **FLOATING
C1805 VSS.t570 VSS 3.22049f ; **FLOATING
C1806 VDD.n0 VSS 0.13354f ; **FLOATING
C1807 VDD.n1 VSS 1.32388f ; **FLOATING
C1808 VDD.t0 VSS 53.1133f ; **FLOATING
C1809 VDD.n2 VSS 0.03676f ; **FLOATING
C1810 VDD.n3 VSS 1.12809f ; **FLOATING
C1811 VDD.n4 VSS 0.03006f ; **FLOATING
C1812 VDD.n5 VSS 0.07957f ; **FLOATING
C1813 VDD.n6 VSS 0.71122f ; **FLOATING
C1814 VDD.n7 VSS 0.71122f ; **FLOATING
C1815 VDD.n8 VSS 0.02576f ; **FLOATING
C1816 VDD.n9 VSS 0.02356f ; **FLOATING
C1817 VDD.n10 VSS 0.02356f ; **FLOATING
C1818 VDD.n11 VSS 0.03403f ; **FLOATING
C1819 VDD.n12 VSS 0.32096f ; **FLOATING
C1820 VDD.n14 VSS 0.07683f ; **FLOATING
C1821 VDD.n15 VSS 0.40392f ; **FLOATING
C1822 VDD.n17 VSS 0.36467f ; **FLOATING
C1823 VDD.n19 VSS 0.44721f ; **FLOATING
C1824 VDD.n21 VSS 0.44721f ; **FLOATING
C1825 VDD.n22 VSS 0.44721f ; **FLOATING
C1826 VDD.n23 VSS 0.26251f ; **FLOATING
C1827 VDD.n24 VSS 0.08091f ; **FLOATING
C1828 VDD.n25 VSS 0.08091f ; **FLOATING
C1829 VDD.n26 VSS 0.22968f ; **FLOATING
C1830 VDD.n28 VSS 1.61292f ; **FLOATING
C1831 VDD.n29 VSS 0.02027f ; **FLOATING
C1832 VDD.n30 VSS 0.02109f ; **FLOATING
C1833 VDD.n31 VSS 0.2326f ; **FLOATING
C1834 VDD.t7 VSS 43.7414f ; **FLOATING
C1835 VDD.n32 VSS 0.03108f ; **FLOATING
C1836 VDD.t104 VSS 0.0187f ; **FLOATING
C1837 VDD.n33 VSS 0.0214f ; **FLOATING
C1838 VDD.n34 VSS 0.02356f ; **FLOATING
C1839 VDD.n35 VSS 0.01579f ; **FLOATING
C1840 VDD.n36 VSS 0.10228f ; **FLOATING
C1841 VDD.n38 VSS 0.1508f ; **FLOATING
C1842 VDD.n39 VSS 0.01387f ; **FLOATING
C1843 VDD.n40 VSS 0.06541f ; **FLOATING
C1844 VDD.n41 VSS 0.08542f ; **FLOATING
C1845 VDD.n43 VSS 0.05909f ; **FLOATING
C1846 VDD.n44 VSS 0.0849f ; **FLOATING
C1847 VDD.n45 VSS 0.05909f ; **FLOATING
C1848 VDD.n46 VSS 0.05909f ; **FLOATING
C1849 VDD.n47 VSS 0.05909f ; **FLOATING
C1850 VDD.n48 VSS 0.02073f ; **FLOATING
C1851 VDD.n49 VSS 0.1421f ; **FLOATING
C1852 VDD.n50 VSS 0.02115f ; **FLOATING
C1853 VDD.n51 VSS 0.01579f ; **FLOATING
C1854 VDD.n52 VSS 0.10654f ; **FLOATING
C1855 VDD.n53 VSS 0.0515f ; **FLOATING
C1856 VDD.n54 VSS 0.20407f ; **FLOATING
C1857 VDD.n55 VSS 0.05909f ; **FLOATING
C1858 VDD.n56 VSS 0.0562f ; **FLOATING
C1859 VDD.n57 VSS 0.03173f ; **FLOATING
C1860 VDD.n58 VSS 0.0737f ; **FLOATING
C1861 VDD.n59 VSS 0.01696f ; **FLOATING
C1862 VDD.n60 VSS 0.15117f ; **FLOATING
C1863 VDD.n61 VSS 0.03161f ; **FLOATING
C1864 VDD.n62 VSS 0.03565f ; **FLOATING
C1865 VDD.n63 VSS 0.13354f ; **FLOATING
C1866 VDD.n64 VSS 0.08925f ; **FLOATING
C1867 VDD.n66 VSS 0.14158f ; **FLOATING
C1868 VDD.n67 VSS 0.02632f ; **FLOATING
C1869 VDD.n68 VSS 0.09628f ; **FLOATING
C1870 VDD.n69 VSS 0.13354f ; **FLOATING
C1871 VDD.n70 VSS 0.08627f ; **FLOATING
C1872 VDD.n72 VSS 0.14158f ; **FLOATING
C1873 VDD.n73 VSS 0.0849f ; **FLOATING
C1874 VDD.n74 VSS 0.08434f ; **FLOATING
C1875 VDD.n75 VSS 0.08434f ; **FLOATING
C1876 VDD.n76 VSS 0.03061f ; **FLOATING
C1877 VDD.n77 VSS 0.01586f ; **FLOATING
C1878 VDD.n78 VSS 0.10037f ; **FLOATING
C1879 VDD.n79 VSS 0.13174f ; **FLOATING
C1880 VDD.t14 VSS 8.26825f ; **FLOATING
C1881 VDD.t257 VSS 0.03685f ; **FLOATING
C1882 VDD.t39 VSS 0.03685f ; **FLOATING
C1883 VDD.n80 VSS 0.12584f ; **FLOATING
C1884 VDD.n81 VSS 0.01583f ; **FLOATING
C1885 VDD.t255 VSS 0.04457f ; **FLOATING
C1886 VDD.t142 VSS 0.04457f ; **FLOATING
C1887 VDD.n82 VSS 0.14191f ; **FLOATING
C1888 VDD.n83 VSS 0.07511f ; **FLOATING
C1889 VDD.t102 VSS 0.03177f ; **FLOATING
C1890 VDD.n84 VSS 0.02157f ; **FLOATING
C1891 VDD.t100 VSS 0.02294f ; **FLOATING
C1892 VDD.t103 VSS 0.03551f ; **FLOATING
C1893 VDD.t105 VSS 0.03177f ; **FLOATING
C1894 VDD.t273 VSS 0.03177f ; **FLOATING
C1895 VDD.t107 VSS 0.03177f ; **FLOATING
C1896 VDD.n85 VSS 0.02157f ; **FLOATING
C1897 VDD.t106 VSS 0.02294f ; **FLOATING
C1898 VDD.t108 VSS 0.03551f ; **FLOATING
C1899 VDD.n86 VSS 0.01804f ; **FLOATING
C1900 VDD.t109 VSS 0.0187f ; **FLOATING
C1901 VDD.t110 VSS 0.03177f ; **FLOATING
C1902 VDD.n87 VSS 0.01894f ; **FLOATING
C1903 VDD.t260 VSS 0.03488f ; **FLOATING
C1904 VDD.t221 VSS 0.02373f ; **FLOATING
C1905 VDD.n88 VSS 0.11936f ; **FLOATING
C1906 VDD.t101 VSS 3.33454f ; **FLOATING
C1907 VDD.n89 VSS 0.64929f ; **FLOATING
C1908 VDD.n90 VSS 0.11549f ; **FLOATING
C1909 VDD.n91 VSS 0.02728f ; **FLOATING
C1910 VDD.t13 VSS 0.02621f ; **FLOATING
C1911 VDD.t15 VSS 0.02621f ; **FLOATING
C1912 VDD.n92 VSS 0.0778f ; **FLOATING
C1913 VDD.n93 VSS 0.03692f ; **FLOATING
C1914 VDD.t250 VSS 0.01215f ; **FLOATING
C1915 VDD.t11 VSS 0.06047f ; **FLOATING
C1916 VDD.n94 VSS 0.02449f ; **FLOATING
C1917 VDD.t152 VSS 0.01215f ; **FLOATING
C1918 VDD.t12 VSS 0.06047f ; **FLOATING
C1919 VDD.n95 VSS 0.02449f ; **FLOATING
C1920 VDD.n96 VSS 0.05407f ; **FLOATING
C1921 VDD.n97 VSS 0.01437f ; **FLOATING
C1922 VDD.t24 VSS 0.03562f ; **FLOATING
C1923 VDD.n98 VSS 0.06404f ; **FLOATING
C1924 VDD.n99 VSS 0.03522f ; **FLOATING
C1925 VDD.t220 VSS 0.03289f ; **FLOATING
C1926 VDD.n100 VSS 0.07632f ; **FLOATING
C1927 VDD.n101 VSS 0.02008f ; **FLOATING
C1928 VDD.t158 VSS 0.03685f ; **FLOATING
C1929 VDD.n102 VSS 0.16466f ; **FLOATING
C1930 VDD.t201 VSS 0.02621f ; **FLOATING
C1931 VDD.n103 VSS 0.14748f ; **FLOATING
C1932 VDD.t346 VSS 0.01215f ; **FLOATING
C1933 VDD.t179 VSS 0.06047f ; **FLOATING
C1934 VDD.n104 VSS 0.02449f ; **FLOATING
C1935 VDD.n105 VSS 0.03694f ; **FLOATING
C1936 VDD.n106 VSS 0.0714f ; **FLOATING
C1937 VDD.n107 VSS 0.02957f ; **FLOATING
C1938 VDD.n108 VSS 0.01559f ; **FLOATING
C1939 VDD.n109 VSS 0.03575f ; **FLOATING
C1940 VDD.n110 VSS 0.03117f ; **FLOATING
C1941 VDD.n111 VSS 0.03566f ; **FLOATING
C1942 VDD.n112 VSS 0.03577f ; **FLOATING
C1943 VDD.n113 VSS 0.01573f ; **FLOATING
C1944 VDD.t306 VSS 0.03289f ; **FLOATING
C1945 VDD.t76 VSS 0.03289f ; **FLOATING
C1946 VDD.t28 VSS 0.02953f ; **FLOATING
C1947 VDD.t193 VSS 0.03289f ; **FLOATING
C1948 VDD.n114 VSS 0.02716f ; **FLOATING
C1949 VDD.t87 VSS 0.04317f ; **FLOATING
C1950 VDD.n115 VSS 0.0828f ; **FLOATING
C1951 VDD.n116 VSS 0.02422f ; **FLOATING
C1952 VDD.t197 VSS 0.03289f ; **FLOATING
C1953 VDD.n117 VSS 0.07849f ; **FLOATING
C1954 VDD.n118 VSS 0.01153f ; **FLOATING
C1955 VDD.t19 VSS 0.03666f ; **FLOATING
C1956 VDD.t164 VSS 0.03666f ; **FLOATING
C1957 VDD.t41 VSS 0.03666f ; **FLOATING
C1958 VDD.t208 VSS 0.03666f ; **FLOATING
C1959 VDD.t309 VSS 0.03289f ; **FLOATING
C1960 VDD.t83 VSS 0.03289f ; **FLOATING
C1961 VDD.n119 VSS 0.09515f ; **FLOATING
C1962 VDD.n120 VSS 0.01506f ; **FLOATING
C1963 VDD.t248 VSS 0.02429f ; **FLOATING
C1964 VDD.t389 VSS 0.02429f ; **FLOATING
C1965 VDD.n121 VSS 0.08389f ; **FLOATING
C1966 VDD.t40 VSS 0.03247f ; **FLOATING
C1967 VDD.t207 VSS 0.03247f ; **FLOATING
C1968 VDD.t304 VSS 0.02429f ; **FLOATING
C1969 VDD.t78 VSS 0.02429f ; **FLOATING
C1970 VDD.t18 VSS 0.03247f ; **FLOATING
C1971 VDD.t163 VSS 0.03247f ; **FLOATING
C1972 VDD.t308 VSS 0.02429f ; **FLOATING
C1973 VDD.t84 VSS 0.02429f ; **FLOATING
C1974 VDD.t134 VSS 0.03247f ; **FLOATING
C1975 VDD.t387 VSS 0.03247f ; **FLOATING
C1976 VDD.n122 VSS 0.07663f ; **FLOATING
C1977 VDD.t135 VSS 0.03666f ; **FLOATING
C1978 VDD.t388 VSS 0.03666f ; **FLOATING
C1979 VDD.t305 VSS 0.02429f ; **FLOATING
C1980 VDD.t77 VSS 0.02429f ; **FLOATING
C1981 VDD.t73 VSS 0.03247f ; **FLOATING
C1982 VDD.t61 VSS 0.03247f ; **FLOATING
C1983 VDD.n123 VSS 0.06965f ; **FLOATING
C1984 VDD.t74 VSS 0.03666f ; **FLOATING
C1985 VDD.t62 VSS 0.03666f ; **FLOATING
C1986 VDD.n124 VSS 0.08755f ; **FLOATING
C1987 VDD.n125 VSS 0.01174f ; **FLOATING
C1988 VDD.t334 VSS 0.03289f ; **FLOATING
C1989 VDD.t253 VSS 0.033f ; **FLOATING
C1990 VDD.t259 VSS 0.03289f ; **FLOATING
C1991 VDD.t34 VSS 0.03289f ; **FLOATING
C1992 VDD.t386 VSS 0.03289f ; **FLOATING
C1993 VDD.t228 VSS 0.03289f ; **FLOATING
C1994 VDD.t128 VSS 0.02953f ; **FLOATING
C1995 VDD.t189 VSS 0.02953f ; **FLOATING
C1996 VDD.t229 VSS 0.03289f ; **FLOATING
C1997 VDD.t414 VSS 0.10909f ; **FLOATING
C1998 VDD.t29 VSS 0.03171f ; **FLOATING
C1999 VDD.t161 VSS 0.04317f ; **FLOATING
C2000 VDD.t413 VSS 0.10909f ; **FLOATING
C2001 VDD.t190 VSS 0.03171f ; **FLOATING
C2002 VDD.t123 VSS 0.03289f ; **FLOATING
C2003 VDD.t378 VSS 0.02953f ; **FLOATING
C2004 VDD.t379 VSS 0.02953f ; **FLOATING
C2005 VDD.t382 VSS 0.02953f ; **FLOATING
C2006 VDD.t149 VSS 0.03289f ; **FLOATING
C2007 VDD.t367 VSS 0.03289f ; **FLOATING
C2008 VDD.t48 VSS 0.03289f ; **FLOATING
C2009 VDD.t156 VSS 0.03289f ; **FLOATING
C2010 VDD.t85 VSS 0.02953f ; **FLOATING
C2011 VDD.t45 VSS 0.04317f ; **FLOATING
C2012 VDD.t70 VSS 0.03289f ; **FLOATING
C2013 VDD.t151 VSS 0.02953f ; **FLOATING
C2014 VDD.t366 VSS 0.03289f ; **FLOATING
C2015 VDD.t215 VSS 0.02953f ; **FLOATING
C2016 VDD.t195 VSS 0.03289f ; **FLOATING
C2017 VDD.t2 VSS 0.02953f ; **FLOATING
C2018 VDD.t3 VSS 0.02953f ; **FLOATING
C2019 VDD.t64 VSS 0.04333f ; **FLOATING
C2020 VDD.t170 VSS 0.03289f ; **FLOATING
C2021 VDD.t6 VSS 0.02953f ; **FLOATING
C2022 VDD.t196 VSS 0.03289f ; **FLOATING
C2023 VDD.t130 VSS 0.03289f ; **FLOATING
C2024 VDD.t157 VSS 0.03289f ; **FLOATING
C2025 VDD.t26 VSS 0.02953f ; **FLOATING
C2026 VDD.t244 VSS 0.04317f ; **FLOATING
C2027 VDD.t317 VSS 0.02953f ; **FLOATING
C2028 VDD.t187 VSS 0.03289f ; **FLOATING
C2029 VDD.t30 VSS 0.02953f ; **FLOATING
C2030 VDD.t52 VSS 0.03289f ; **FLOATING
C2031 VDD.t223 VSS 0.03289f ; **FLOATING
C2032 VDD.t56 VSS 0.02953f ; **FLOATING
C2033 VDD.t57 VSS 0.02953f ; **FLOATING
C2034 VDD.t60 VSS 0.02953f ; **FLOATING
C2035 VDD.t192 VSS 0.03289f ; **FLOATING
C2036 VDD.t145 VSS 0.03289f ; **FLOATING
C2037 VDD.t129 VSS 0.03289f ; **FLOATING
C2038 VDD.t258 VSS 0.03289f ; **FLOATING
C2039 VDD.t310 VSS 0.04317f ; **FLOATING
C2040 VDD.t361 VSS 0.03289f ; **FLOATING
C2041 VDD.t395 VSS 0.03289f ; **FLOATING
C2042 VDD.t341 VSS 0.03289f ; **FLOATING
C2043 VDD.t391 VSS 0.03289f ; **FLOATING
C2044 VDD.t81 VSS 0.03492f ; **FLOATING
C2045 VDD.t37 VSS 0.04317f ; **FLOATING
C2046 VDD.t344 VSS 0.06167f ; **FLOATING
C2047 VDD.t148 VSS 0.03289f ; **FLOATING
C2048 VDD.t364 VSS 0.03289f ; **FLOATING
C2049 VDD.t385 VSS 0.03289f ; **FLOATING
C2050 VDD.t358 VSS 0.03289f ; **FLOATING
C2051 VDD.t231 VSS 0.02953f ; **FLOATING
C2052 VDD.t168 VSS 0.04317f ; **FLOATING
C2053 VDD.t54 VSS 0.03289f ; **FLOATING
C2054 VDD.t240 VSS 0.02953f ; **FLOATING
C2055 VDD.t300 VSS 0.03289f ; **FLOATING
C2056 VDD.t225 VSS 0.02953f ; **FLOATING
C2057 VDD.t198 VSS 0.03289f ; **FLOATING
C2058 VDD.t372 VSS 0.02953f ; **FLOATING
C2059 VDD.t373 VSS 0.02953f ; **FLOATING
C2060 VDD.t137 VSS 0.04333f ; **FLOATING
C2061 VDD.t370 VSS 0.03289f ; **FLOATING
C2062 VDD.t376 VSS 0.02953f ; **FLOATING
C2063 VDD.t194 VSS 0.03289f ; **FLOATING
C2064 VDD.t49 VSS 0.03289f ; **FLOATING
C2065 VDD.t345 VSS 0.03289f ; **FLOATING
C2066 VDD.t68 VSS 0.02953f ; **FLOATING
C2067 VDD.t65 VSS 0.04317f ; **FLOATING
C2068 VDD.t351 VSS 0.02953f ; **FLOATING
C2069 VDD.t25 VSS 0.03289f ; **FLOATING
C2070 VDD.t212 VSS 0.02953f ; **FLOATING
C2071 VDD.t336 VSS 0.03289f ; **FLOATING
C2072 VDD.t224 VSS 0.03289f ; **FLOATING
C2073 VDD.t234 VSS 0.02953f ; **FLOATING
C2074 VDD.t235 VSS 0.03109f ; **FLOATING
C2075 VDD.t238 VSS 0.02953f ; **FLOATING
C2076 VDD.t147 VSS 0.03289f ; **FLOATING
C2077 VDD.t140 VSS 0.03289f ; **FLOATING
C2078 VDD.t191 VSS 0.03289f ; **FLOATING
C2079 VDD.t51 VSS 0.03289f ; **FLOATING
C2080 VDD.t254 VSS 0.02953f ; **FLOATING
C2081 VDD.t298 VSS 0.04317f ; **FLOATING
C2082 VDD.t362 VSS 0.03289f ; **FLOATING
C2083 VDD.t33 VSS 0.02953f ; **FLOATING
C2084 VDD.t359 VSS 0.03289f ; **FLOATING
C2085 VDD.t175 VSS 0.02953f ; **FLOATING
C2086 VDD.t126 VSS 0.03289f ; **FLOATING
C2087 VDD.t353 VSS 0.02953f ; **FLOATING
C2088 VDD.t354 VSS 0.02953f ; **FLOATING
C2089 VDD.t131 VSS 0.04333f ; **FLOATING
C2090 VDD.t20 VSS 0.03289f ; **FLOATING
C2091 VDD.t357 VSS 0.02953f ; **FLOATING
C2092 VDD.t214 VSS 0.03289f ; **FLOATING
C2093 VDD.t125 VSS 0.03289f ; **FLOATING
C2094 VDD.t188 VSS 0.03289f ; **FLOATING
C2095 VDD.t42 VSS 0.04317f ; **FLOATING
C2096 VDD.t186 VSS 0.03955f ; **FLOATING
C2097 VDD.t397 VSS 0.10909f ; **FLOATING
C2098 VDD.t355 VSS 0.03171f ; **FLOATING
C2099 VDD.t398 VSS 0.10909f ; **FLOATING
C2100 VDD.t176 VSS 0.03171f ; **FLOATING
C2101 VDD.t399 VSS 0.10909f ; **FLOATING
C2102 VDD.t32 VSS 0.03171f ; **FLOATING
C2103 VDD.t22 VSS 0.04333f ; **FLOATING
C2104 VDD.t400 VSS 0.10909f ; **FLOATING
C2105 VDD.t236 VSS 0.03171f ; **FLOATING
C2106 VDD.t401 VSS 0.10909f ; **FLOATING
C2107 VDD.t213 VSS 0.03171f ; **FLOATING
C2108 VDD.t402 VSS 0.10909f ; **FLOATING
C2109 VDD.t69 VSS 0.03171f ; **FLOATING
C2110 VDD.t403 VSS 0.10909f ; **FLOATING
C2111 VDD.t374 VSS 0.03171f ; **FLOATING
C2112 VDD.t404 VSS 0.10909f ; **FLOATING
C2113 VDD.t226 VSS 0.03171f ; **FLOATING
C2114 VDD.t405 VSS 0.10909f ; **FLOATING
C2115 VDD.t232 VSS 0.03171f ; **FLOATING
C2116 VDD.n126 VSS 0.08393f ; **FLOATING
C2117 VDD.n127 VSS 0.01109f ; **FLOATING
C2118 VDD.n128 VSS 0.06463f ; **FLOATING
C2119 VDD.n129 VSS 0.01294f ; **FLOATING
C2120 VDD.n130 VSS 0.0797f ; **FLOATING
C2121 VDD.t153 VSS 0.04333f ; **FLOATING
C2122 VDD.t406 VSS 0.10909f ; **FLOATING
C2123 VDD.t58 VSS 0.03171f ; **FLOATING
C2124 VDD.t407 VSS 0.10909f ; **FLOATING
C2125 VDD.t31 VSS 0.03171f ; **FLOATING
C2126 VDD.t408 VSS 0.10909f ; **FLOATING
C2127 VDD.t27 VSS 0.03171f ; **FLOATING
C2128 VDD.t409 VSS 0.10909f ; **FLOATING
C2129 VDD.t4 VSS 0.03171f ; **FLOATING
C2130 VDD.t410 VSS 0.10909f ; **FLOATING
C2131 VDD.t1 VSS 0.03171f ; **FLOATING
C2132 VDD.t411 VSS 0.10909f ; **FLOATING
C2133 VDD.t86 VSS 0.03171f ; **FLOATING
C2134 VDD.t122 VSS 0.04333f ; **FLOATING
C2135 VDD.t412 VSS 0.10909f ; **FLOATING
C2136 VDD.t380 VSS 0.03171f ; **FLOATING
C2137 VDD.t116 VSS 0.06665f ; **FLOATING
C2138 VDD.n131 VSS 0.04831f ; **FLOATING
C2139 VDD.n132 VSS 0.04831f ; **FLOATING
C2140 VDD.n133 VSS 0.04831f ; **FLOATING
C2141 VDD.n134 VSS 0.04822f ; **FLOATING
C2142 VDD.n135 VSS 0.04822f ; **FLOATING
C2143 VDD.n136 VSS 0.04822f ; **FLOATING
C2144 VDD.n137 VSS 0.04822f ; **FLOATING
C2145 VDD.n138 VSS 0.04822f ; **FLOATING
C2146 VDD.n139 VSS 0.04822f ; **FLOATING
C2147 VDD.n140 VSS 0.04822f ; **FLOATING
C2148 VDD.n141 VSS 0.04822f ; **FLOATING
C2149 VDD.n142 VSS 0.04822f ; **FLOATING
C2150 VDD.n143 VSS 0.04822f ; **FLOATING
C2151 VDD.n144 VSS 0.04831f ; **FLOATING
C2152 VDD.n145 VSS 0.04822f ; **FLOATING
C2153 VDD.n146 VSS 0.04831f ; **FLOATING
C2154 VDD.n147 VSS 0.04822f ; **FLOATING
C2155 VDD.n148 VSS 0.04822f ; **FLOATING
C2156 VDD.n149 VSS 0.04831f ; **FLOATING
C2157 VDD.n150 VSS 0.04822f ; **FLOATING
C2158 VDD.n151 VSS 0.04831f ; **FLOATING
C2159 VDD.n152 VSS 0.04822f ; **FLOATING
C2160 VDD.n153 VSS 0.04822f ; **FLOATING
C2161 VDD.n154 VSS 0.04822f ; **FLOATING
C2162 VDD.n155 VSS 0.04822f ; **FLOATING
C2163 VDD.n156 VSS 0.04822f ; **FLOATING
C2164 VDD.n157 VSS 0.04831f ; **FLOATING
C2165 VDD.n158 VSS 0.04822f ; **FLOATING
C2166 VDD.n159 VSS 0.04831f ; **FLOATING
C2167 VDD.n160 VSS 0.04822f ; **FLOATING
C2168 VDD.n161 VSS 0.04831f ; **FLOATING
C2169 VDD.t112 VSS 0.03228f ; **FLOATING
C2170 VDD.t111 VSS 0.02302f ; **FLOATING
C2171 VDD.t115 VSS 0.03215f ; **FLOATING
C2172 VDD.t113 VSS 0.03551f ; **FLOATING
C2173 VDD.t114 VSS 0.01868f ; **FLOATING
C2174 VDD.t270 VSS 0.03177f ; **FLOATING
C2175 VDD.n162 VSS 0.09618f ; **FLOATING
C2176 VDD.n163 VSS 0.02356f ; **FLOATING
C2177 VDD.n164 VSS 0.07475f ; **FLOATING
C2178 VDD.n165 VSS 0.01381f ; **FLOATING
C2179 VDD.t160 VSS 0.03726f ; **FLOATING
C2180 VDD.n166 VSS 0.07758f ; **FLOATING
C2181 VDD.n167 VSS 0.034f ; **FLOATING
C2182 VDD.t269 VSS 0.03177f ; **FLOATING
C2183 VDD.n168 VSS 0.10441f ; **FLOATING
C2184 VDD.n169 VSS 0.02356f ; **FLOATING
C2185 VDD.n170 VSS 0.05907f ; **FLOATING
C2186 VDD.n171 VSS 0.01381f ; **FLOATING
C2187 VDD.t35 VSS 0.03726f ; **FLOATING
C2188 VDD.n172 VSS 0.07758f ; **FLOATING
C2189 VDD.n173 VSS 0.034f ; **FLOATING
C2190 VDD.t274 VSS 0.03177f ; **FLOATING
C2191 VDD.n174 VSS 0.10444f ; **FLOATING
C2192 VDD.n175 VSS 0.02356f ; **FLOATING
C2193 VDD.n176 VSS 0.05906f ; **FLOATING
C2194 VDD.n177 VSS 0.01379f ; **FLOATING
C2195 VDD.t162 VSS 0.03726f ; **FLOATING
C2196 VDD.n178 VSS 0.07761f ; **FLOATING
C2197 VDD.n179 VSS 0.034f ; **FLOATING
C2198 VDD.t267 VSS 0.03177f ; **FLOATING
C2199 VDD.n180 VSS 0.10441f ; **FLOATING
C2200 VDD.n181 VSS 0.02356f ; **FLOATING
C2201 VDD.n182 VSS 0.05906f ; **FLOATING
C2202 VDD.n183 VSS 0.01379f ; **FLOATING
C2203 VDD.t230 VSS 0.03726f ; **FLOATING
C2204 VDD.n184 VSS 0.07761f ; **FLOATING
C2205 VDD.n185 VSS 0.034f ; **FLOATING
C2206 VDD.t277 VSS 0.03177f ; **FLOATING
C2207 VDD.n186 VSS 0.10444f ; **FLOATING
C2208 VDD.n187 VSS 0.02356f ; **FLOATING
C2209 VDD.n188 VSS 0.05907f ; **FLOATING
C2210 VDD.n189 VSS 0.01381f ; **FLOATING
C2211 VDD.t241 VSS 0.03726f ; **FLOATING
C2212 VDD.n190 VSS 0.07756f ; **FLOATING
C2213 VDD.n191 VSS 0.03407f ; **FLOATING
C2214 VDD.t278 VSS 0.03177f ; **FLOATING
C2215 VDD.n192 VSS 0.10441f ; **FLOATING
C2216 VDD.n193 VSS 0.02356f ; **FLOATING
C2217 VDD.n194 VSS 0.05903f ; **FLOATING
C2218 VDD.n195 VSS 0.01381f ; **FLOATING
C2219 VDD.t338 VSS 0.03726f ; **FLOATING
C2220 VDD.n196 VSS 0.07759f ; **FLOATING
C2221 VDD.n197 VSS 0.03401f ; **FLOATING
C2222 VDD.t280 VSS 0.03177f ; **FLOATING
C2223 VDD.n198 VSS 0.10447f ; **FLOATING
C2224 VDD.n199 VSS 0.02356f ; **FLOATING
C2225 VDD.n200 VSS 0.05906f ; **FLOATING
C2226 VDD.n201 VSS 0.01381f ; **FLOATING
C2227 VDD.t46 VSS 0.03726f ; **FLOATING
C2228 VDD.n202 VSS 0.07758f ; **FLOATING
C2229 VDD.n203 VSS 0.03403f ; **FLOATING
C2230 VDD.t281 VSS 0.03177f ; **FLOATING
C2231 VDD.n204 VSS 0.10447f ; **FLOATING
C2232 VDD.n205 VSS 0.02356f ; **FLOATING
C2233 VDD.n206 VSS 0.05903f ; **FLOATING
C2234 VDD.n207 VSS 0.01379f ; **FLOATING
C2235 VDD.t136 VSS 0.03726f ; **FLOATING
C2236 VDD.n208 VSS 0.07758f ; **FLOATING
C2237 VDD.n209 VSS 0.03404f ; **FLOATING
C2238 VDD.t263 VSS 0.03177f ; **FLOATING
C2239 VDD.n210 VSS 0.10447f ; **FLOATING
C2240 VDD.n211 VSS 0.02356f ; **FLOATING
C2241 VDD.n212 VSS 0.05906f ; **FLOATING
C2242 VDD.n213 VSS 0.01381f ; **FLOATING
C2243 VDD.t204 VSS 0.03726f ; **FLOATING
C2244 VDD.n214 VSS 0.07759f ; **FLOATING
C2245 VDD.n215 VSS 0.03401f ; **FLOATING
C2246 VDD.t282 VSS 0.03177f ; **FLOATING
C2247 VDD.n216 VSS 0.10447f ; **FLOATING
C2248 VDD.n217 VSS 0.02356f ; **FLOATING
C2249 VDD.n218 VSS 0.05905f ; **FLOATING
C2250 VDD.n219 VSS 0.01381f ; **FLOATING
C2251 VDD.t9 VSS 0.03726f ; **FLOATING
C2252 VDD.n220 VSS 0.07756f ; **FLOATING
C2253 VDD.n221 VSS 0.03407f ; **FLOATING
C2254 VDD.t283 VSS 0.03177f ; **FLOATING
C2255 VDD.n222 VSS 0.10444f ; **FLOATING
C2256 VDD.n223 VSS 0.02356f ; **FLOATING
C2257 VDD.n224 VSS 0.05903f ; **FLOATING
C2258 VDD.n225 VSS 0.01381f ; **FLOATING
C2259 VDD.t209 VSS 0.03726f ; **FLOATING
C2260 VDD.n226 VSS 0.07758f ; **FLOATING
C2261 VDD.n227 VSS 0.034f ; **FLOATING
C2262 VDD.t284 VSS 0.03177f ; **FLOATING
C2263 VDD.n228 VSS 0.10441f ; **FLOATING
C2264 VDD.n229 VSS 0.02356f ; **FLOATING
C2265 VDD.n230 VSS 0.05906f ; **FLOATING
C2266 VDD.n231 VSS 0.01379f ; **FLOATING
C2267 VDD.t53 VSS 0.03726f ; **FLOATING
C2268 VDD.n232 VSS 0.07758f ; **FLOATING
C2269 VDD.n233 VSS 0.03404f ; **FLOATING
C2270 VDD.t276 VSS 0.03177f ; **FLOATING
C2271 VDD.n234 VSS 0.10444f ; **FLOATING
C2272 VDD.n235 VSS 0.02356f ; **FLOATING
C2273 VDD.n236 VSS 0.05905f ; **FLOATING
C2274 VDD.n237 VSS 0.01379f ; **FLOATING
C2275 VDD.t72 VSS 0.03726f ; **FLOATING
C2276 VDD.n238 VSS 0.07762f ; **FLOATING
C2277 VDD.n239 VSS 0.03401f ; **FLOATING
C2278 VDD.t286 VSS 0.03177f ; **FLOATING
C2279 VDD.n240 VSS 0.10441f ; **FLOATING
C2280 VDD.n241 VSS 0.02356f ; **FLOATING
C2281 VDD.n242 VSS 0.05906f ; **FLOATING
C2282 VDD.n243 VSS 0.01381f ; **FLOATING
C2283 VDD.t146 VSS 0.03726f ; **FLOATING
C2284 VDD.n244 VSS 0.07758f ; **FLOATING
C2285 VDD.n245 VSS 0.03403f ; **FLOATING
C2286 VDD.t285 VSS 0.03177f ; **FLOATING
C2287 VDD.n246 VSS 0.10447f ; **FLOATING
C2288 VDD.n247 VSS 0.02356f ; **FLOATING
C2289 VDD.n248 VSS 0.05904f ; **FLOATING
C2290 VDD.n249 VSS 0.01381f ; **FLOATING
C2291 VDD.t216 VSS 0.03726f ; **FLOATING
C2292 VDD.n250 VSS 0.07759f ; **FLOATING
C2293 VDD.n251 VSS 0.03401f ; **FLOATING
C2294 VDD.t287 VSS 0.03177f ; **FLOATING
C2295 VDD.n252 VSS 0.10444f ; **FLOATING
C2296 VDD.n253 VSS 0.02356f ; **FLOATING
C2297 VDD.n254 VSS 0.05906f ; **FLOATING
C2298 VDD.n255 VSS 0.01381f ; **FLOATING
C2299 VDD.t67 VSS 0.03726f ; **FLOATING
C2300 VDD.n256 VSS 0.07757f ; **FLOATING
C2301 VDD.n257 VSS 0.03402f ; **FLOATING
C2302 VDD.t265 VSS 0.03177f ; **FLOATING
C2303 VDD.n258 VSS 0.10441f ; **FLOATING
C2304 VDD.n259 VSS 0.02356f ; **FLOATING
C2305 VDD.n260 VSS 0.05905f ; **FLOATING
C2306 VDD.n261 VSS 0.01379f ; **FLOATING
C2307 VDD.t36 VSS 0.03726f ; **FLOATING
C2308 VDD.n262 VSS 0.0776f ; **FLOATING
C2309 VDD.n263 VSS 0.03402f ; **FLOATING
C2310 VDD.t262 VSS 0.03177f ; **FLOATING
C2311 VDD.n264 VSS 0.10444f ; **FLOATING
C2312 VDD.n265 VSS 0.02356f ; **FLOATING
C2313 VDD.n266 VSS 0.05905f ; **FLOATING
C2314 VDD.n267 VSS 0.01379f ; **FLOATING
C2315 VDD.t44 VSS 0.03726f ; **FLOATING
C2316 VDD.n268 VSS 0.07761f ; **FLOATING
C2317 VDD.n269 VSS 0.034f ; **FLOATING
C2318 VDD.t288 VSS 0.03177f ; **FLOATING
C2319 VDD.n270 VSS 0.10441f ; **FLOATING
C2320 VDD.n271 VSS 0.02356f ; **FLOATING
C2321 VDD.n272 VSS 0.05907f ; **FLOATING
C2322 VDD.n273 VSS 0.01381f ; **FLOATING
C2323 VDD.t171 VSS 0.03726f ; **FLOATING
C2324 VDD.n274 VSS 0.07756f ; **FLOATING
C2325 VDD.n275 VSS 0.03404f ; **FLOATING
C2326 VDD.t289 VSS 0.03177f ; **FLOATING
C2327 VDD.n276 VSS 0.10447f ; **FLOATING
C2328 VDD.n277 VSS 0.02356f ; **FLOATING
C2329 VDD.n278 VSS 0.05906f ; **FLOATING
C2330 VDD.n279 VSS 0.01381f ; **FLOATING
C2331 VDD.t299 VSS 0.03726f ; **FLOATING
C2332 VDD.n280 VSS 0.07758f ; **FLOATING
C2333 VDD.n281 VSS 0.03403f ; **FLOATING
C2334 VDD.t279 VSS 0.03177f ; **FLOATING
C2335 VDD.n282 VSS 0.10447f ; **FLOATING
C2336 VDD.n283 VSS 0.02356f ; **FLOATING
C2337 VDD.n284 VSS 0.05903f ; **FLOATING
C2338 VDD.n285 VSS 0.01379f ; **FLOATING
C2339 VDD.t183 VSS 0.03726f ; **FLOATING
C2340 VDD.n286 VSS 0.0776f ; **FLOATING
C2341 VDD.n287 VSS 0.03402f ; **FLOATING
C2342 VDD.t264 VSS 0.03177f ; **FLOATING
C2343 VDD.n288 VSS 0.10447f ; **FLOATING
C2344 VDD.n289 VSS 0.02356f ; **FLOATING
C2345 VDD.n290 VSS 0.05906f ; **FLOATING
C2346 VDD.n291 VSS 0.01381f ; **FLOATING
C2347 VDD.t139 VSS 0.03726f ; **FLOATING
C2348 VDD.n292 VSS 0.07756f ; **FLOATING
C2349 VDD.n293 VSS 0.03407f ; **FLOATING
C2350 VDD.t275 VSS 0.03177f ; **FLOATING
C2351 VDD.n294 VSS 0.10447f ; **FLOATING
C2352 VDD.n295 VSS 0.02356f ; **FLOATING
C2353 VDD.n296 VSS 0.05903f ; **FLOATING
C2354 VDD.n297 VSS 0.01381f ; **FLOATING
C2355 VDD.t80 VSS 0.03726f ; **FLOATING
C2356 VDD.n298 VSS 0.07758f ; **FLOATING
C2357 VDD.n299 VSS 0.03403f ; **FLOATING
C2358 VDD.t272 VSS 0.03177f ; **FLOATING
C2359 VDD.n300 VSS 0.10447f ; **FLOATING
C2360 VDD.n301 VSS 0.02356f ; **FLOATING
C2361 VDD.n302 VSS 0.05904f ; **FLOATING
C2362 VDD.n303 VSS 0.01381f ; **FLOATING
C2363 VDD.t8 VSS 0.03726f ; **FLOATING
C2364 VDD.n304 VSS 0.07758f ; **FLOATING
C2365 VDD.n305 VSS 0.034f ; **FLOATING
C2366 VDD.t268 VSS 0.03177f ; **FLOATING
C2367 VDD.n306 VSS 0.10447f ; **FLOATING
C2368 VDD.n307 VSS 0.02356f ; **FLOATING
C2369 VDD.n308 VSS 0.05907f ; **FLOATING
C2370 VDD.n309 VSS 0.01381f ; **FLOATING
C2371 VDD.t23 VSS 0.03726f ; **FLOATING
C2372 VDD.n310 VSS 0.07757f ; **FLOATING
C2373 VDD.n311 VSS 0.03402f ; **FLOATING
C2374 VDD.t266 VSS 0.03177f ; **FLOATING
C2375 VDD.n312 VSS 0.10447f ; **FLOATING
C2376 VDD.n313 VSS 0.02356f ; **FLOATING
C2377 VDD.n314 VSS 0.05906f ; **FLOATING
C2378 VDD.n315 VSS 0.01381f ; **FLOATING
C2379 VDD.t17 VSS 0.03726f ; **FLOATING
C2380 VDD.n316 VSS 0.07758f ; **FLOATING
C2381 VDD.n317 VSS 0.034f ; **FLOATING
C2382 VDD.t290 VSS 0.03177f ; **FLOATING
C2383 VDD.n318 VSS 0.10447f ; **FLOATING
C2384 VDD.n319 VSS 0.02356f ; **FLOATING
C2385 VDD.n320 VSS 0.05907f ; **FLOATING
C2386 VDD.n321 VSS 0.01381f ; **FLOATING
C2387 VDD.t174 VSS 0.03726f ; **FLOATING
C2388 VDD.n322 VSS 0.07759f ; **FLOATING
C2389 VDD.n323 VSS 0.03396f ; **FLOATING
C2390 VDD.t291 VSS 0.03177f ; **FLOATING
C2391 VDD.n324 VSS 0.10447f ; **FLOATING
C2392 VDD.n325 VSS 0.02356f ; **FLOATING
C2393 VDD.n326 VSS 0.0591f ; **FLOATING
C2394 VDD.n327 VSS 0.01379f ; **FLOATING
C2395 VDD.t185 VSS 0.03726f ; **FLOATING
C2396 VDD.n328 VSS 0.07761f ; **FLOATING
C2397 VDD.n329 VSS 0.03403f ; **FLOATING
C2398 VDD.t271 VSS 0.03177f ; **FLOATING
C2399 VDD.n330 VSS 0.10444f ; **FLOATING
C2400 VDD.n331 VSS 0.02356f ; **FLOATING
C2401 VDD.n332 VSS 0.05904f ; **FLOATING
C2402 VDD.n333 VSS 0.01381f ; **FLOATING
C2403 VDD.t133 VSS 0.03726f ; **FLOATING
C2404 VDD.n334 VSS 0.07759f ; **FLOATING
C2405 VDD.n335 VSS 0.03396f ; **FLOATING
C2406 VDD.t292 VSS 0.03177f ; **FLOATING
C2407 VDD.n336 VSS 0.10438f ; **FLOATING
C2408 VDD.n337 VSS 0.02356f ; **FLOATING
C2409 VDD.n338 VSS 0.05911f ; **FLOATING
C2410 VDD.n339 VSS 0.01381f ; **FLOATING
C2411 VDD.t21 VSS 0.03726f ; **FLOATING
C2412 VDD.n340 VSS 0.07758f ; **FLOATING
C2413 VDD.n341 VSS 0.034f ; **FLOATING
C2414 VDD.t293 VSS 0.03177f ; **FLOATING
C2415 VDD.n342 VSS 0.10438f ; **FLOATING
C2416 VDD.n343 VSS 0.02356f ; **FLOATING
C2417 VDD.n344 VSS 0.05907f ; **FLOATING
C2418 VDD.n345 VSS 0.01381f ; **FLOATING
C2419 VDD.t155 VSS 0.03726f ; **FLOATING
C2420 VDD.n346 VSS 0.07758f ; **FLOATING
C2421 VDD.t294 VSS 0.03177f ; **FLOATING
C2422 VDD.n347 VSS 0.08641f ; **FLOATING
C2423 VDD.t261 VSS 0.03726f ; **FLOATING
C2424 VDD.t117 VSS 0.03177f ; **FLOATING
C2425 VDD.t118 VSS 0.03551f ; **FLOATING
C2426 VDD.t121 VSS 0.03177f ; **FLOATING
C2427 VDD.t119 VSS 0.0307f ; **FLOATING
C2428 VDD.n348 VSS 0.70229f ; **FLOATING
C2429 VDD.n349 VSS 2.34917f ; **FLOATING
C2430 VDD.n350 VSS 0.71794f ; **FLOATING
C2431 VDD.n351 VSS 0.01473f ; **FLOATING
C2432 VDD.t38 VSS 0.0217f ; **FLOATING
C2433 VDD.n352 VSS 0.06126f ; **FLOATING
C2434 VDD.n353 VSS 0.01534f ; **FLOATING
C2435 VDD.n354 VSS 0.01566f ; **FLOATING
C2436 VDD.n355 VSS 0.06779f ; **FLOATING
C2437 VDD.t95 VSS 0.06341f ; **FLOATING
C2438 VDD.n356 VSS 0.02214f ; **FLOATING
C2439 VDD.n357 VSS 0.0496f ; **FLOATING
C2440 VDD.t90 VSS 0.05674f ; **FLOATING
C2441 VDD.n358 VSS 0.02212f ; **FLOATING
C2442 VDD.t96 VSS 0.05674f ; **FLOATING
C2443 VDD.n359 VSS 0.06351f ; **FLOATING
C2444 VDD.n360 VSS 0.02212f ; **FLOATING
C2445 VDD.n361 VSS 0.0448f ; **FLOATING
C2446 VDD.t88 VSS 0.35877f ; **FLOATING
C2447 VDD.n362 VSS 0.01448f ; **FLOATING
C2448 VDD.n363 VSS 0.04478f ; **FLOATING
C2449 VDD.t89 VSS 0.06341f ; **FLOATING
C2450 VDD.n364 VSS 0.02214f ; **FLOATING
C2451 VDD.n365 VSS 0.06776f ; **FLOATING
C2452 VDD.n366 VSS 0.03577f ; **FLOATING
C2453 VDD.n367 VSS 0.08624f ; **FLOATING
C2454 VDD.t327 VSS 0.06341f ; **FLOATING
C2455 VDD.n368 VSS 0.04114f ; **FLOATING
C2456 VDD.t320 VSS 0.06341f ; **FLOATING
C2457 VDD.n369 VSS 0.04115f ; **FLOATING
C2458 VDD.n370 VSS 0.08622f ; **FLOATING
C2459 VDD.n371 VSS 0.03117f ; **FLOATING
C2460 VDD.n372 VSS 0.08645f ; **FLOATING
C2461 VDD.t329 VSS 0.06341f ; **FLOATING
C2462 VDD.n373 VSS 0.04114f ; **FLOATING
C2463 VDD.t322 VSS 0.06341f ; **FLOATING
C2464 VDD.n374 VSS 0.04115f ; **FLOATING
C2465 VDD.n375 VSS 0.08643f ; **FLOATING
C2466 VDD.n376 VSS 0.0357f ; **FLOATING
C2467 VDD.n377 VSS 0.08167f ; **FLOATING
C2468 VDD.t331 VSS 0.06341f ; **FLOATING
C2469 VDD.n378 VSS 0.04114f ; **FLOATING
C2470 VDD.t324 VSS 0.06341f ; **FLOATING
C2471 VDD.n379 VSS 0.04115f ; **FLOATING
C2472 VDD.n380 VSS 0.08162f ; **FLOATING
C2473 VDD.n381 VSS 0.03579f ; **FLOATING
C2474 VDD.n382 VSS 0.01573f ; **FLOATING
C2475 VDD.t10 VSS 12.4896f ; **FLOATING
C2476 VDD.t93 VSS 0.05674f ; **FLOATING
C2477 VDD.t98 VSS 0.05674f ; **FLOATING
C2478 VDD.n383 VSS 0.06908f ; **FLOATING
C2479 VDD.n384 VSS 0.02212f ; **FLOATING
C2480 VDD.t92 VSS 0.06341f ; **FLOATING
C2481 VDD.n385 VSS 0.06777f ; **FLOATING
C2482 VDD.n386 VSS 0.02214f ; **FLOATING
C2483 VDD.n387 VSS 0.06777f ; **FLOATING
C2484 VDD.t99 VSS 0.06341f ; **FLOATING
C2485 VDD.n388 VSS 0.02214f ; **FLOATING
C2486 VDD.n389 VSS 0.04478f ; **FLOATING
C2487 VDD.t91 VSS 0.35877f ; **FLOATING
C2488 VDD.n390 VSS 0.01448f ; **FLOATING
C2489 VDD.n391 VSS 0.048f ; **FLOATING
C2490 VDD.n392 VSS 0.02212f ; **FLOATING
C2491 VDD.n393 VSS 0.08074f ; **FLOATING
C2492 VDD.n394 VSS 0.04702f ; **FLOATING
.ends
