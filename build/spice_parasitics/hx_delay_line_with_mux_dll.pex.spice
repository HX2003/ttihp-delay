* NGSPICE file created from hx_delay_line_with_mux_dll.ext - technology: ihp-sg13g2

.subckt hx_delay_line_with_mux_dll VDD DELAY_OUT_LAST VSS DELAY_VBIASN DELAY_VBIASP
+ DLL_RESETN REF_CLK MUX_SEL0 MUX_SEL1 MUX_OUT MUX_SEL4 MUX_SEL2 MUX_SEL3
X0 a_14009_5878# REF_CLK VSS.t379 VSS.t378 sg13_lv_nmos ad=0.2516p pd=2.16u as=1.9998p ps=12.915u w=0.74u l=0.13u
X1 VDD.t136 a_4003_1842# a_4437_1842# VDD.t3 sg13_lv_pmos ad=0.2128p pd=1.5u as=0.3808p ps=2.92u w=1.12u l=0.13u
X2 VSS.t461 DLL_RESETN a_10040_6305# VSS.t460 sg13_lv_nmos ad=0.1626p pd=1.415u as=60.89999f ps=0.71u w=0.42u l=0.13u
X3 VSS.t507 a_15077_1842# a_15545_1044# VSS.t506 sg13_lv_nmos ad=0.1665p pd=1.19u as=0.2516p ps=2.16u w=0.74u l=0.13u
X4 a_27915_1044# a_27705_1044# VDD.t9 VDD.t0 sg13_lv_pmos ad=0.2128p pd=1.5u as=0.252p ps=1.57u w=1.12u l=0.13u
X5 VSS.t55 VDD.t409 VSS.t53 VSS.t54 sg13_lv_nmos ad=79.8f pd=0.8u as=0 ps=0 w=0.42u l=1u
X6 a_10951_2470# a_10713_1842# a_10843_1842# VDD.t3 sg13_lv_pmos ad=0.2128p pd=1.5u as=0.3808p ps=2.92u w=1.12u l=0.2u
X7 VSS.t37 a_3171_1047.t7 a_11924_1008# VSS.t36 sg13_lv_nmos ad=0.2516p pd=2.16u as=0.2516p ps=2.16u w=0.74u l=0.13u
X8 VDD.t178 VSS.t97 VDD.t270 VDD.t0 sg13_lv_pmos ad=0.34p pd=2.68u as=0 ps=0 w=1u l=1u
X9 VSS.t28 a_1256_1044# a_2967_1395# VSS.t253 sg13_lv_nmos ad=0.1331p pd=1.12u as=0.1216p ps=1.02u w=0.64u l=0.13u
X10 VSS.t55 VDD.t408 VSS.t55 VSS.t56 sg13_lv_nmos ad=0.1428p pd=1.52u as=0 ps=0 w=0.42u l=1u
X11 a_25153_1842# a_24957_1842# VSS.t225 VSS.t345 sg13_lv_nmos ad=0.2516p pd=2.16u as=0.1406p ps=1.12u w=0.74u l=0.13u
X12 VDD.t13 VSS.t70 VDD.t241 VDD.t0 sg13_lv_pmos ad=0.34p pd=2.68u as=0 ps=0 w=1u l=1u
X13 a_15108_6109# a_14851_6228# a_15270_6305# VSS.t19 sg13_lv_nmos ad=0.1428p pd=1.52u as=37.8f ps=0.6u w=0.42u l=0.13u
X14 VSS.t21 a_14851_6228# a_15688_5867# VSS.t20 sg13_lv_nmos ad=0.1406p pd=1.12u as=0.2516p ps=2.16u w=0.74u l=0.13u
X15 VSS.t308 VSS.t306 VSS.t306 VSS.t307 sg13_lv_nmos ad=0.68p pd=4.68u as=0 ps=0 w=2u l=1u
X16 a_15108_5325# a_12849_5867# VDD.t8 VDD.t7 sg13_lv_pmos ad=79.8f pd=0.8u as=1.03698p ps=6.245u w=0.42u l=0.13u
X17 a_25630_1044# a_2019_1047.t2 a_25528_1044# VSS.t13 sg13_lv_nmos ad=0.2516p pd=2.16u as=0.1406p ps=1.12u w=0.74u l=0.13u
X18 VDD.t299 DELAY_VBIASP a_19311_2470# VDD.t3 sg13_lv_pmos ad=0.3808p pd=2.92u as=0.2128p ps=1.5u w=1.12u l=0.6u
X19 a_16108_289# a_2019_311# a_16510_1044# VSS.t595 sg13_lv_nmos ad=0.2516p pd=2.16u as=0.2516p ps=2.16u w=0.74u l=0.13u
X20 VDD.t294 DELAY_VBIASP a_9431_2470# VDD.t3 sg13_lv_pmos ad=0.3808p pd=2.92u as=0.2128p ps=1.5u w=1.12u l=0.6u
X21 VSS.t104 VDD.t395 VSS.t103 VSS.t102 sg13_lv_nmos ad=0.1428p pd=1.52u as=0 ps=0 w=0.42u l=1u
X22 VSS.t303 VSS.t303 VSS.t305 VSS.t304 sg13_lv_nmos ad=0.68p pd=4.68u as=0 ps=0 w=2u l=1u
X23 VDD.t308 DELAY_VBIASP a_23111_2470# VDD.t3 sg13_lv_pmos ad=0.3808p pd=2.92u as=0.2128p ps=1.5u w=1.12u l=0.6u
X24 a_7390_1044# a_8231_1008# a_8155_1044# VDD.t0 sg13_lv_pmos ad=0.3808p pd=2.92u as=0.2128p ps=1.5u w=1.12u l=0.13u
X25 a_14009_5878# REF_CLK VDD.t8 VDD.t7 sg13_lv_pmos ad=0.4088p pd=2.97u as=1.03698p ps=6.245u w=1.12u l=0.13u
X26 VSS.t59 a_2595_311.t3 a_8745_519# VSS.t463 sg13_lv_nmos ad=0.2516p pd=2.16u as=0.2516p ps=2.16u w=0.74u l=0.13u
X27 a_11748_6109# DLL_RESETN VDD.t8 VDD.t7 sg13_lv_pmos ad=79.8f pd=0.8u as=1.10612p ps=6.66u w=0.42u l=0.13u
X28 VDD.t318 a_11491_6228# a_12158_5867# VDD.t7 sg13_lv_pmos ad=0.2128p pd=1.5u as=0.3864p ps=2.93u w=1.12u l=0.13u
X29 VDD.t291 DELAY_VBIASP DELAY_VBIASP VDD.t42 sg13_lv_pmos ad=0.3808p pd=2.92u as=1.0304p ps=4.08u w=1.12u l=0.6u
X30 a_17791_1842# a_17553_1842# a_17683_1842# VSS.t499 sg13_lv_nmos ad=0.1406p pd=1.12u as=0.2516p ps=2.16u w=0.74u l=0.2u
X31 VSS.t248 a_11748_6109# a_11397_6228# VSS.t401 sg13_lv_nmos ad=79.8f pd=0.8u as=0.1428p ps=1.52u w=0.42u l=0.13u
X32 VDD.t93 a_12037_1842# a_12505_1044# VDD.t0 sg13_lv_pmos ad=0.252p pd=1.57u as=0.3808p ps=2.92u w=1.12u l=0.13u
X33 a_16510_1044# a_2019_1047.t5 a_16408_1044# VSS.t404 sg13_lv_nmos ad=0.2516p pd=2.16u as=0.1406p ps=1.12u w=0.74u l=0.13u
X34 a_21591_1842# a_21353_1842# a_21483_1842# VSS.t113 sg13_lv_nmos ad=0.1406p pd=1.12u as=0.2516p ps=2.16u w=0.74u l=0.2u
X35 a_6153_1842# a_5957_1842# VSS.t120 VSS.t119 sg13_lv_nmos ad=0.2516p pd=2.16u as=0.1406p ps=1.12u w=0.74u l=0.13u
X36 VSS.t146 a_16163_1842# a_16597_1842# VSS.t505 sg13_lv_nmos ad=0.1406p pd=1.12u as=0.2516p ps=2.16u w=0.74u l=0.13u
X37 VSS.t443 a_3171_1047.t2 a_27124_1008# VSS.t442 sg13_lv_nmos ad=0.2516p pd=2.16u as=0.2516p ps=2.16u w=0.74u l=0.13u
X38 VDD.t94 a_11603_1842# a_12037_1842# VDD.t3 sg13_lv_pmos ad=0.2128p pd=1.5u as=0.3808p ps=2.92u w=1.12u l=0.13u
X39 VDD.t72 a_3171_311.t3 a_11785_519# VDD.t0 sg13_lv_pmos ad=0.3808p pd=2.92u as=0.3808p ps=2.92u w=1.12u l=0.13u
X40 a_6126_3816# a_6326_4590# VDD.t99 VDD.t7 sg13_lv_pmos ad=0.38p pd=2.38u as=0.38p ps=2.38u w=2u l=1u
X41 a_24393_1842# a_24197_1842# VDD.t91 VDD.t3 sg13_lv_pmos ad=0.3808p pd=2.92u as=0.2128p ps=1.5u w=1.12u l=0.13u
X42 a_5731_289# a_2595_311.t3 a_7390_1044# VSS.t462 sg13_lv_nmos ad=0.2516p pd=2.16u as=0.2516p ps=2.16u w=0.74u l=0.13u
X43 a_10430_1044# a_2595_1047.t7 a_11195_1044# VSS.t257 sg13_lv_nmos ad=0.2516p pd=2.16u as=0.1406p ps=1.12u w=0.74u l=0.13u
X44 a_13306_6305# a_12355_5867# VDD.t95 VDD.t7 sg13_lv_pmos ad=79.8f pd=0.8u as=0.1428p ps=1.52u w=0.42u l=0.13u
X45 a_23355_1044# a_23145_1044# VSS.t516 VSS.t552 sg13_lv_nmos ad=0.1406p pd=1.12u as=0.1665p ps=1.19u w=0.74u l=0.13u
X46 VDD.t301 DELAY_VBIASP a_14751_2470# VDD.t3 sg13_lv_pmos ad=0.3808p pd=2.92u as=0.2128p ps=1.5u w=1.12u l=0.6u
X47 VSS.t132 DELAY_VBIASN a_10191_1842# VSS.t205 sg13_lv_nmos ad=0.2516p pd=2.16u as=0.1406p ps=1.12u w=0.74u l=0.6u
X48 VSS.t31 a_3747_1047.t4 a_21911_1008# VSS.t278 sg13_lv_nmos ad=0.2516p pd=2.16u as=0.2516p ps=2.16u w=0.74u l=0.13u
X49 VSS.t148 a_19963_1842# a_20397_1842# VSS.t502 sg13_lv_nmos ad=0.1406p pd=1.12u as=0.2516p ps=2.16u w=0.74u l=0.13u
X50 a_6126_3816# a_6326_4590# VDD.t105 VDD.t7 sg13_lv_pmos ad=0.38p pd=2.38u as=0.38p ps=2.38u w=2u l=1u
X51 VDD.t33 a_6326_4590# a_6854_5454# VDD.t7 sg13_lv_pmos ad=0.38p pd=2.38u as=0.38p ps=2.38u w=2u l=1u
X52 VDD.t284 DELAY_VBIASP a_4111_2470# VDD.t3 sg13_lv_pmos ad=0.3808p pd=2.92u as=0.2128p ps=1.5u w=1.12u l=0.6u
X53 a_10328_1044# a_9757_1842# VDD.t28 VDD.t0 sg13_lv_pmos ad=0.2128p pd=1.5u as=0.3808p ps=2.92u w=1.12u l=0.13u
X54 a_20968_1044# a_20397_1842# VSS.t424 VSS.t539 sg13_lv_nmos ad=0.1406p pd=1.12u as=0.2516p ps=2.16u w=0.74u l=0.13u
X55 a_22590_1044# a_22564_1008# a_22488_1044# VDD.t0 sg13_lv_pmos ad=0.3808p pd=2.92u as=0.2128p ps=1.5u w=1.12u l=0.13u
X56 VDD.t351 VSS.t66 VDD.t162 VDD.t0 sg13_lv_pmos ad=0.19p pd=1.38u as=0 ps=0 w=1u l=1u
X57 a_8808_1044# a_8237_1842# VDD.t343 VDD.t0 sg13_lv_pmos ad=0.2128p pd=1.5u as=0.3808p ps=2.92u w=1.12u l=0.13u
X58 VDD.t109 a_6326_4590# a_6326_4590# VDD.t7 sg13_lv_pmos ad=0.38p pd=2.38u as=0.38p ps=2.38u w=2u l=1u
X59 a_4157_1313# REF_CLK VDD.t164 VDD.t0 sg13_lv_pmos ad=0.3808p pd=2.92u as=0.3808p ps=2.92u w=1.12u l=0.13u
X60 a_17031_2470# a_16793_1842# a_16923_1842# VDD.t3 sg13_lv_pmos ad=0.2128p pd=1.5u as=0.3808p ps=2.92u w=1.12u l=0.2u
X61 a_11473_1842# a_11277_1842# VSS.t202 VSS.t384 sg13_lv_nmos ad=0.2516p pd=2.16u as=0.1406p ps=1.12u w=0.74u l=0.13u
X62 VSS.t99 VDD.t397 VSS.t97 VSS.t98 sg13_lv_nmos ad=79.8f pd=0.8u as=0 ps=0 w=0.42u l=1u
X63 a_13306_5105# a_13132_5420# VDD.t156 VDD.t7 sg13_lv_pmos ad=79.8f pd=0.8u as=0.1428p ps=1.52u w=0.42u l=0.13u
X64 a_19448_1044# a_18877_1842# VSS.t272 VSS.t271 sg13_lv_nmos ad=0.1406p pd=1.12u as=0.2516p ps=2.16u w=0.74u l=0.13u
X65 a_10430_1044# a_3171_1047.t7 a_11848_1044# VSS.t35 sg13_lv_nmos ad=0.2516p pd=2.16u as=0.1406p ps=1.12u w=0.74u l=0.13u
X66 a_20831_2470# a_20593_1842# a_20723_1842# VDD.t3 sg13_lv_pmos ad=0.2128p pd=1.5u as=0.3808p ps=2.92u w=1.12u l=0.2u
X67 VSS.t73 VDD.t404 VSS.t71 VSS.t72 sg13_lv_nmos ad=79.8f pd=0.8u as=0 ps=0 w=0.42u l=1u
X68 VDD.t9 a_27237_1842# a_27705_1044# VDD.t0 sg13_lv_pmos ad=0.252p pd=1.57u as=0.3808p ps=2.92u w=1.12u l=0.13u
X69 a_5393_1842# a_5197_1842# VDD.t313 VDD.t3 sg13_lv_pmos ad=0.3808p pd=2.92u as=0.2128p ps=1.5u w=1.12u l=0.13u
X70 VDD.t286 DELAY_VBIASP a_17031_2470# VDD.t3 sg13_lv_pmos ad=0.3808p pd=2.92u as=0.2128p ps=1.5u w=1.12u l=0.6u
X71 VDD.t8 a_15108_6109# a_15053_5990# VDD.t7 sg13_lv_pmos ad=1.10612p pd=6.66u as=93.45f ps=0.865u w=0.42u l=0.13u
X72 VDD.t105 a_6326_4590# a_6854_5454# VDD.t7 sg13_lv_pmos ad=0.38p pd=2.38u as=0.38p ps=2.38u w=2u l=1u
X73 a_13818_6292# a_12849_5867# VSS.t299 VSS.t362 sg13_lv_nmos ad=37.8f pd=0.6u as=0.1701p ps=1.65u w=0.42u l=0.13u
X74 VDD.t10 a_26803_1842# a_27237_1842# VDD.t3 sg13_lv_pmos ad=0.2128p pd=1.5u as=0.3808p ps=2.92u w=1.12u l=0.13u
X75 VDD.t325 MUX_SEL1 a_3449_1395# VDD.t0 sg13_lv_pmos ad=0.1918p pd=1.5u as=0.1596p ps=1.22u w=0.84u l=0.13u
X76 a_14851_6228# a_14009_5878# a_13592_5871# VDD.t7 sg13_lv_pmos ad=0.2048p pd=1.63u as=0.34p ps=2.68u w=1u l=0.13u
X77 a_25630_1044# a_2595_1047.t2 a_26395_1044# VSS.t484 sg13_lv_nmos ad=0.2516p pd=2.16u as=0.1406p ps=1.12u w=0.74u l=0.13u
X78 VSS.t223 DELAY_VBIASN a_25391_1842# VSS.t222 sg13_lv_nmos ad=0.2516p pd=2.16u as=0.1406p ps=1.12u w=0.74u l=0.6u
X79 VSS.t182 DELAY_VBIASN VSS.t181 VSS.t173 sg13_lv_nmos ad=1.33p pd=7.38u as=0 ps=0 w=7u l=7u
X80 a_6635_1044# a_6425_1044# VDD.t6 VDD.t0 sg13_lv_pmos ad=0.2128p pd=1.5u as=0.252p ps=1.57u w=1.12u l=0.13u
X81 VDD.t220 DLL_RESETN a_9946_6305# VDD.t7 sg13_lv_pmos ad=0.36237p pd=2.605u as=79.8f ps=0.8u w=0.42u l=0.13u
X82 a_20315_1044# a_20105_1044# VDD.t334 VDD.t0 sg13_lv_pmos ad=0.2128p pd=1.5u as=0.252p ps=1.57u w=1.12u l=0.13u
X83 VDD.t239 a_2595_1047.t9 a_5191_1008# VDD.t0 sg13_lv_pmos ad=0.3808p pd=2.92u as=0.3808p ps=2.92u w=1.12u l=0.13u
X84 a_19311_2470# a_19073_1842# a_19203_1842# VDD.t3 sg13_lv_pmos ad=0.2128p pd=1.5u as=0.3808p ps=2.92u w=1.12u l=0.2u
X85 VSS.t296 a_1721_1395# a_2019_1047.t1 VSS.t591 sg13_lv_nmos ad=0.2812p pd=2.24u as=0.1406p ps=1.12u w=0.74u l=0.13u
X86 a_25528_1044# a_24957_1842# VDD.t139 VDD.t0 sg13_lv_pmos ad=0.2128p pd=1.5u as=0.3808p ps=2.92u w=1.12u l=0.13u
X87 VSS.t6 a_5957_1842# a_6425_1044# VSS.t118 sg13_lv_nmos ad=0.1665p pd=1.19u as=0.2516p ps=2.16u w=0.74u l=0.13u
X88 VSS.t433 a_2019_1047.t6 a_13444_1008# VSS.t432 sg13_lv_nmos ad=0.2516p pd=2.16u as=0.2516p ps=2.16u w=0.74u l=0.13u
X89 a_23111_2470# a_22873_1842# a_23003_1842# VDD.t3 sg13_lv_pmos ad=0.2128p pd=1.5u as=0.3808p ps=2.92u w=1.12u l=0.2u
X90 VSS.t53 VDD.t409 VSS.t53 VSS.t52 sg13_lv_nmos ad=0.1428p pd=1.52u as=0 ps=0 w=0.42u l=1u
X91 VSS.t136 a_15964_289# a_16851_309# VSS.t264 sg13_lv_nmos ad=0.1371p pd=1.12u as=0.2176p ps=1.96u w=0.64u l=0.13u
X92 a_10713_1842# a_10517_1842# VDD.t74 VDD.t3 sg13_lv_pmos ad=0.3808p pd=2.92u as=0.2128p ps=1.5u w=1.12u l=0.13u
X93 VDD.t129 a_17683_1842# a_18117_1842# VDD.t3 sg13_lv_pmos ad=0.2128p pd=1.5u as=0.3808p ps=2.92u w=1.12u l=0.13u
X94 a_16108_289# a_17865_519# a_16510_1044# VDD.t0 sg13_lv_pmos ad=0.3808p pd=2.92u as=0.3808p ps=2.92u w=1.12u l=0.13u
X95 a_26673_1842# a_26477_1842# VSS.t1 VSS.t504 sg13_lv_nmos ad=0.2516p pd=2.16u as=0.1406p ps=1.12u w=0.74u l=0.13u
X96 VDD.t19 a_7803_1842# a_8237_1842# VDD.t3 sg13_lv_pmos ad=0.2128p pd=1.5u as=0.3808p ps=2.92u w=1.12u l=0.13u
X97 a_4248_1044# a_4157_1313# VSS.t395 VSS.t394 sg13_lv_nmos ad=0.1406p pd=1.12u as=0.2516p ps=2.16u w=0.74u l=0.13u
X98 a_16108_289# a_3171_311.t2 a_22590_1044# VSS.t556 sg13_lv_nmos ad=0.2516p pd=2.16u as=0.2516p ps=2.16u w=0.74u l=0.13u
X99 VSS.t199 DELAY_VBIASN a_6391_1842# VSS.t198 sg13_lv_nmos ad=0.2516p pd=2.16u as=0.1406p ps=1.12u w=0.74u l=0.6u
X100 a_16408_1044# a_15837_1842# VDD.t157 VDD.t0 sg13_lv_pmos ad=0.2128p pd=1.5u as=0.3808p ps=2.92u w=1.12u l=0.13u
X101 a_10232_5871# a_10206_5835# VSS.t461 VSS.t460 sg13_lv_nmos ad=0.2516p pd=2.16u as=0.1626p ps=1.415u w=0.74u l=0.13u
X102 a_19550_1044# a_3747_1047.t4 a_21835_1044# VSS.t277 sg13_lv_nmos ad=0.2516p pd=2.16u as=0.1406p ps=1.12u w=0.74u l=0.13u
X103 VSS.t217 DELAY_VBIASN a_20831_1842# VSS.t216 sg13_lv_nmos ad=0.2516p pd=2.16u as=0.1406p ps=1.12u w=0.74u l=0.6u
X104 a_3171_311.t0 a_2873_331# VDD.t328 VDD.t0 sg13_lv_pmos ad=0.2128p pd=1.5u as=0.1918p ps=1.5u w=1.12u l=0.13u
X105 a_15304_4605# a_14851_6228# VDD.t16 VDD.t7 sg13_lv_pmos ad=0.4312p pd=3.01u as=0.2639p ps=1.81u w=1.12u l=0.13u
X106 a_13106_5357# a_12907_5420# VSS.t8 VSS.t530 sg13_lv_nmos ad=0.27427p pd=2.28u as=1.45407p ps=9.445u w=0.795u l=0.13u
X107 a_3747_311.t0 a_3449_331# VDD.t171 VDD.t0 sg13_lv_pmos ad=0.2128p pd=1.5u as=0.1918p ps=1.5u w=1.12u l=0.13u
X108 a_13132_5420# a_13106_5357# VDD.t8 VDD.t7 sg13_lv_pmos ad=0.3927p pd=2.99u as=1.10612p ps=6.66u w=1.155u l=0.13u
X109 a_7390_1044# a_9751_1008# a_9675_1044# VDD.t0 sg13_lv_pmos ad=0.3808p pd=2.92u as=0.2128p ps=1.5u w=1.12u l=0.13u
X110 VSS.t190 DELAY_VBIASN VSS.t188 VSS.t169 sg13_lv_nmos ad=1.33p pd=7.38u as=0 ps=0 w=7u l=7u
X111 a_10191_1842# a_9953_1842# a_10083_1842# VSS.t341 sg13_lv_nmos ad=0.1406p pd=1.12u as=0.2516p ps=2.16u w=0.74u l=0.2u
X112 VSS.t516 a_22677_1842# a_23145_1044# VSS.t515 sg13_lv_nmos ad=0.1665p pd=1.19u as=0.2516p ps=2.16u w=0.74u l=0.13u
X113 a_14751_2470# a_14513_1842# a_14643_1842# VDD.t3 sg13_lv_pmos ad=0.2128p pd=1.5u as=0.3808p ps=2.92u w=1.12u l=0.2u
X114 a_5731_289# a_8745_519# a_7390_1044# VDD.t0 sg13_lv_pmos ad=0.3808p pd=2.92u as=0.3808p ps=2.92u w=1.12u l=0.13u
X115 VDD.t54 VDD.t55 VDD.t56 VDD.t3 sg13_lv_pmos ad=0.2128p pd=1.5u as=0 ps=0 w=1.12u l=0.13u
X116 a_4111_2470# REF_CLK a_4003_1842# VDD.t3 sg13_lv_pmos ad=0.2128p pd=1.5u as=0.3808p ps=2.92u w=1.12u l=0.2u
X117 a_13566_5835# a_14009_5878# a_13306_6305# VSS.t468 sg13_lv_nmos ad=79.8f pd=0.8u as=0.1296p ps=1.52u w=0.42u l=0.13u
X118 a_13306_6305# a_14111_5878# a_13566_5835# VDD.t7 sg13_lv_pmos ad=0.1428p pd=1.52u as=79.8f ps=0.8u w=0.42u l=0.13u
X119 a_13592_5423# a_14111_5227# a_14851_5182# VSS.t546 sg13_lv_nmos ad=0.3473p pd=2.71u as=0.12665p ps=1.145u w=0.74u l=0.13u
X120 a_7673_1842# a_7477_1842# VSS.t140 VSS.t409 sg13_lv_nmos ad=0.2516p pd=2.16u as=0.1406p ps=1.12u w=0.74u l=0.13u
X121 VDD.t196 a_3171_1047.t5 a_18004_1008# VDD.t0 sg13_lv_pmos ad=0.3808p pd=2.92u as=0.3808p ps=2.92u w=1.12u l=0.13u
X122 VDD.t15 a_13123_1842# a_13557_1842# VDD.t3 sg13_lv_pmos ad=0.2128p pd=1.5u as=0.3808p ps=2.92u w=1.12u l=0.13u
X123 VDD.t213 a_3747_311.t2 a_26985_519# VDD.t0 sg13_lv_pmos ad=0.3808p pd=2.92u as=0.3808p ps=2.92u w=1.12u l=0.13u
X124 a_25913_1842# a_25717_1842# VDD.t255 VDD.t3 sg13_lv_pmos ad=0.3808p pd=2.92u as=0.2128p ps=1.5u w=1.12u l=0.13u
X125 a_10430_1044# a_3747_1047.t7 a_12715_1044# VSS.t274 sg13_lv_nmos ad=0.2516p pd=2.16u as=0.1406p ps=1.12u w=0.74u l=0.13u
X126 a_6326_4590# a_5974_5723# a_6126_3816# VSS.t570 sg13_lv_nmos ad=0.38p pd=2.38u as=0.68p ps=4.68u w=2u l=1u
X127 a_14235_1044# a_14025_1044# VDD.t263 VDD.t0 sg13_lv_pmos ad=0.2128p pd=1.5u as=0.252p ps=1.57u w=1.12u l=0.13u
X128 a_24875_1044# a_24665_1044# VSS.t353 VSS.t527 sg13_lv_nmos ad=0.1406p pd=1.12u as=0.1665p ps=1.19u w=0.74u l=0.13u
X129 VSS.t204 DELAY_VBIASN a_11711_1842# VSS.t203 sg13_lv_nmos ad=0.2516p pd=2.16u as=0.1406p ps=1.12u w=0.74u l=0.6u
X130 VDD.t114 a_3747_1047.t7 a_12791_1008# VDD.t0 sg13_lv_pmos ad=0.3808p pd=2.92u as=0.3808p ps=2.92u w=1.12u l=0.13u
X131 VSS.t430 a_2595_1047.t3 a_23431_1008# VSS.t429 sg13_lv_nmos ad=0.2516p pd=2.16u as=0.2516p ps=2.16u w=0.74u l=0.13u
X132 VSS.t33 a_21483_1842# a_21917_1842# VSS.t285 sg13_lv_nmos ad=0.1406p pd=1.12u as=0.2516p ps=2.16u w=0.74u l=0.13u
X133 VSS.t511 a_13557_1842# a_14025_1044# VSS.t510 sg13_lv_nmos ad=0.1665p pd=1.19u as=0.2516p ps=2.16u w=0.74u l=0.13u
X134 a_11848_1044# a_11277_1842# VDD.t168 VDD.t0 sg13_lv_pmos ad=0.2128p pd=1.5u as=0.3808p ps=2.92u w=1.12u l=0.13u
X135 VDD.t357 VSS.t110 VDD.t79 VDD.t0 sg13_lv_pmos ad=0.19p pd=1.38u as=0 ps=0 w=1u l=1u
X136 VDD.t8 a_12907_5186# a_12907_5420# VDD.t7 sg13_lv_pmos ad=1.10612p pd=6.66u as=0.2442p ps=2.06u w=0.66u l=0.13u
X137 a_25391_1842# a_25153_1842# a_25283_1842# VSS.t34 sg13_lv_nmos ad=0.1406p pd=1.12u as=0.2516p ps=2.16u w=0.74u l=0.2u
X138 a_12993_1842# a_12797_1842# VSS.t207 VSS.t512 sg13_lv_nmos ad=0.2516p pd=2.16u as=0.1406p ps=1.12u w=0.74u l=0.13u
X139 DELAY_OUT_LAST a_27997_1842# VDD.t68 VDD.t3 sg13_lv_pmos ad=0.3808p pd=2.92u as=0.2128p ps=1.5u w=1.12u l=0.13u
X140 VDD.t359 VSS.t110 VDD.t358 VDD.t0 sg13_lv_pmos ad=0.34p pd=2.68u as=0 ps=0 w=1u l=1u
X141 VDD.t334 a_19637_1842# a_20105_1044# VDD.t0 sg13_lv_pmos ad=0.252p pd=1.57u as=0.3808p ps=2.92u w=1.12u l=0.13u
X142 a_6854_5454# a_6326_4590# VDD.t101 VDD.t7 sg13_lv_pmos ad=0.38p pd=2.38u as=0.38p ps=2.38u w=2u l=1u
X143 VSS.t209 DELAY_VBIASN a_13991_1842# VSS.t208 sg13_lv_nmos ad=0.2516p pd=2.16u as=0.1406p ps=1.12u w=0.74u l=0.6u
X144 VSS.t97 VDD.t397 VSS.t97 VSS.t96 sg13_lv_nmos ad=0.1428p pd=1.52u as=0 ps=0 w=0.42u l=1u
X145 a_22590_1044# a_3171_1047.t3 a_24008_1044# VSS.t475 sg13_lv_nmos ad=0.2516p pd=2.16u as=0.1406p ps=1.12u w=0.74u l=0.13u
X146 a_6913_1842# a_6717_1842# VDD.t277 VDD.t3 sg13_lv_pmos ad=0.3808p pd=2.92u as=0.2128p ps=1.5u w=1.12u l=0.13u
X147 VDD.t285 DELAY_VBIASP a_18551_2470# VDD.t3 sg13_lv_pmos ad=0.3808p pd=2.92u as=0.2128p ps=1.5u w=1.12u l=0.6u
X148 VSS.t155 a_23763_1842# a_24197_1842# VSS.t262 sg13_lv_nmos ad=0.1406p pd=1.12u as=0.2516p ps=2.16u w=0.74u l=0.13u
X149 VSS.t71 VDD.t404 VSS.t70 VSS.t69 sg13_lv_nmos ad=0.1428p pd=1.52u as=0 ps=0 w=0.42u l=1u
X150 VDD.t20 a_1256_1044# a_2873_1395# VDD.t0 sg13_lv_pmos ad=0.1918p pd=1.5u as=0.1596p ps=1.22u w=0.84u l=0.13u
X151 a_3171_311.t1 a_2873_331# VSS.t398 VSS.t541 sg13_lv_nmos ad=0.1406p pd=1.12u as=0.1331p ps=1.12u w=0.74u l=0.13u
X152 VDD.t329 a_2873_331# a_3171_311.t0 VDD.t0 sg13_lv_pmos ad=0.4256p pd=3u as=0.2128p ps=1.5u w=1.12u l=0.13u
X153 a_16510_1044# a_17351_1008# a_17275_1044# VDD.t0 sg13_lv_pmos ad=0.3808p pd=2.92u as=0.2128p ps=1.5u w=1.12u l=0.13u
X154 a_25630_1044# a_3747_1047.t2 a_27915_1044# VSS.t600 sg13_lv_nmos ad=0.2516p pd=2.16u as=0.1406p ps=1.12u w=0.74u l=0.13u
X155 VSS.t12 DELAY_VBIASN a_26911_1842# VSS.t149 sg13_lv_nmos ad=0.2516p pd=2.16u as=0.1406p ps=1.12u w=0.74u l=0.6u
X156 a_3747_311.t1 a_3449_331# VSS.t389 VSS.t580 sg13_lv_nmos ad=0.1406p pd=1.12u as=0.1331p ps=1.12u w=0.74u l=0.13u
X157 VDD.t347 a_3449_331# a_3747_311.t0 VDD.t0 sg13_lv_pmos ad=0.4256p pd=3u as=0.2128p ps=1.5u w=1.12u l=0.13u
X158 VDD.t282 DELAY_VBIASP a_22351_2470# VDD.t3 sg13_lv_pmos ad=0.3808p pd=2.92u as=0.2128p ps=1.5u w=1.12u l=0.6u
X159 VDD.t377 a_3747_1047.t2 a_27991_1008# VDD.t0 sg13_lv_pmos ad=0.3808p pd=2.92u as=0.3808p ps=2.92u w=1.12u l=0.13u
X160 VDD.t269 VSS.t51 VDD.t228 VDD.t0 sg13_lv_pmos ad=0.19p pd=1.38u as=0 ps=0 w=1u l=1u
X161 a_13019_5831# a_15688_5403# VSS.t116 VSS.t618 sg13_lv_nmos ad=0.2516p pd=2.16u as=0.1406p ps=1.12u w=0.74u l=0.13u
X162 VDD.t376 a_3747_1047.t9 a_6711_1008# VDD.t0 sg13_lv_pmos ad=0.3808p pd=2.92u as=0.3808p ps=2.92u w=1.12u l=0.13u
X163 a_6854_5454# a_6326_4590# VDD.t36 VDD.t7 sg13_lv_pmos ad=0.38p pd=2.38u as=0.38p ps=2.38u w=2u l=1u
X164 a_9772_5843# a_9746_5805# VDD.t8 VDD.t7 sg13_lv_pmos ad=0.3927p pd=2.99u as=1.10612p ps=6.66u w=1.155u l=0.13u
X165 a_6391_1842# a_6153_1842# a_6283_1842# VSS.t373 sg13_lv_nmos ad=0.1406p pd=1.12u as=0.2516p ps=2.16u w=0.74u l=0.2u
X166 a_15273_1842# a_15077_1842# VSS.t161 VSS.t508 sg13_lv_nmos ad=0.2516p pd=2.16u as=0.1406p ps=1.12u w=0.74u l=0.13u
X167 a_19833_1842# a_19637_1842# VDD.t333 VDD.t3 sg13_lv_pmos ad=0.3808p pd=2.92u as=0.2128p ps=1.5u w=1.12u l=0.13u
X168 a_16108_289# a_23945_519# a_22590_1044# VDD.t0 sg13_lv_pmos ad=0.3808p pd=2.92u as=0.3808p ps=2.92u w=1.12u l=0.13u
X169 VDD.t107 a_6326_4590# a_6126_3816# VDD.t7 sg13_lv_pmos ad=0.38p pd=2.38u as=0.38p ps=2.38u w=2u l=1u
X170 a_9193_1842# a_8997_1842# VDD.t81 VDD.t3 sg13_lv_pmos ad=0.3808p pd=2.92u as=0.2128p ps=1.5u w=1.12u l=0.13u
X171 a_24631_2470# a_24393_1842# a_24523_1842# VDD.t3 sg13_lv_pmos ad=0.2128p pd=1.5u as=0.3808p ps=2.92u w=1.12u l=0.2u
X172 VSS.t157 a_15403_1842# a_15837_1842# VSS.t490 sg13_lv_nmos ad=0.1406p pd=1.12u as=0.2516p ps=2.16u w=0.74u l=0.13u
X173 a_8155_1044# a_7945_1044# VSS.t411 VSS.t521 sg13_lv_nmos ad=0.1406p pd=1.12u as=0.1665p ps=1.19u w=0.74u l=0.13u
X174 a_23633_1842# a_23437_1842# VDD.t244 VDD.t3 sg13_lv_pmos ad=0.3808p pd=2.92u as=0.2128p ps=1.5u w=1.12u l=0.13u
X175 VSS.t197 a_4763_1842# a_5197_1842# VSS.t525 sg13_lv_nmos ad=0.1406p pd=1.12u as=0.2516p ps=2.16u w=0.74u l=0.13u
X176 a_27048_1044# a_26477_1842# VSS.t486 VSS.t503 sg13_lv_nmos ad=0.1406p pd=1.12u as=0.2516p ps=2.16u w=0.74u l=0.13u
X177 VDD.t27 a_9323_1842# a_9757_1842# VDD.t3 sg13_lv_pmos ad=0.2128p pd=1.5u as=0.3808p ps=2.92u w=1.12u l=0.13u
X178 a_5768_1044# a_5197_1842# VSS.t483 VSS.t622 sg13_lv_nmos ad=0.1406p pd=1.12u as=0.2516p ps=2.16u w=0.74u l=0.13u
X179 a_6326_4590# a_6126_3816# a_5778_3367# VSS.t567 sg13_lv_nmos ad=0.38p pd=2.38u as=0.68p ps=4.68u w=2u l=1u
X180 DELAY_VBIASN DLL_RESETN VDD.t271 VDD.t42 sg13_lv_pmos ad=0.158p pd=1.245u as=0.272p ps=2.28u w=0.8u l=0.2u
X181 a_7390_1044# a_7364_1008# a_7288_1044# VDD.t0 sg13_lv_pmos ad=0.3808p pd=2.92u as=0.2128p ps=1.5u w=1.12u l=0.13u
X182 VSS.t180 DELAY_VBIASN VSS.t179 VSS.t162 sg13_lv_nmos ad=2.38p pd=14.68u as=0 ps=0 w=7u l=7u
X183 VSS.t26 DELAY_VBIASN a_7911_1842# VSS.t138 sg13_lv_nmos ad=0.2516p pd=2.16u as=0.1406p ps=1.12u w=0.74u l=0.6u
X184 VDD.t137 a_13019_5831# a_12943_5867# VDD.t7 sg13_lv_pmos ad=0.2128p pd=1.5u as=0.2128p ps=1.5u w=1.12u l=0.13u
X185 a_6854_5986# a_15304_4605# DELAY_VBIASN VDD.t42 sg13_lv_pmos ad=0.136p pd=1.14u as=0.158p ps=1.245u w=0.4u l=0.2u
X186 VDD.t236 VSS.t77 VDD.t234 VDD.t0 sg13_lv_pmos ad=0.19p pd=1.38u as=0 ps=0 w=1u l=1u
X187 a_11711_1842# a_11473_1842# a_11603_1842# VSS.t393 sg13_lv_nmos ad=0.1406p pd=1.12u as=0.2516p ps=2.16u w=0.74u l=0.2u
X188 VSS.t353 a_24197_1842# a_24665_1044# VSS.t352 sg13_lv_nmos ad=0.1665p pd=1.19u as=0.2516p ps=2.16u w=0.74u l=0.13u
X189 a_16510_1044# a_3171_1047.t5 a_17928_1044# VSS.t416 sg13_lv_nmos ad=0.2516p pd=2.16u as=0.1406p ps=1.12u w=0.74u l=0.13u
X190 a_15270_5105# a_12849_5867# VSS.t116 VSS.t360 sg13_lv_nmos ad=37.8f pd=0.6u as=79.8f ps=0.8u w=0.42u l=0.13u
X191 a_5974_5723# a_6126_3816# VSS.t572 VSS.t570 sg13_lv_nmos ad=0.38p pd=2.38u as=0.68p ps=4.68u w=2u l=1u
X192 VSS.t66 VDD.t406 VSS.t64 VSS.t65 sg13_lv_nmos ad=79.8f pd=0.8u as=0 ps=0 w=0.42u l=1u
X193 a_5631_2470# a_5393_1842# a_5523_1842# VDD.t3 sg13_lv_pmos ad=0.2128p pd=1.5u as=0.3808p ps=2.92u w=1.12u l=0.2u
X194 a_14513_1842# a_14317_1842# VDD.t195 VDD.t3 sg13_lv_pmos ad=0.3808p pd=2.92u as=0.2128p ps=1.5u w=1.12u l=0.13u
X195 a_4633_1842# a_4437_1842# VDD.t136 VDD.t3 sg13_lv_pmos ad=0.3808p pd=2.92u as=0.2128p ps=1.5u w=1.12u l=0.13u
X196 VSS.t132 a_10083_1842# a_10517_1842# VSS.t458 sg13_lv_nmos ad=0.1406p pd=1.12u as=0.2516p ps=2.16u w=0.74u l=0.13u
X197 VDD.t209 a_2019_1047.t4 a_19524_1008# VDD.t0 sg13_lv_pmos ad=0.3808p pd=2.92u as=0.3808p ps=2.92u w=1.12u l=0.13u
X198 VSS.t587 a_3171_1047.t4 a_21044_1008# VSS.t586 sg13_lv_nmos ad=0.2516p pd=2.16u as=0.2516p ps=2.16u w=0.74u l=0.13u
X199 VSS.t398 a_2873_331# a_3171_311.t1 VSS.t542 sg13_lv_nmos ad=0.2812p pd=2.24u as=0.1406p ps=1.12u w=0.74u l=0.13u
X200 a_13949_5496# a_13592_5423# VDD.t155 VDD.t7 sg13_lv_pmos ad=63f pd=0.72u as=0.1563p ps=1.22u w=0.42u l=0.13u
X201 VSS.t389 a_3449_331# a_3747_311.t1 VSS.t581 sg13_lv_nmos ad=0.2812p pd=2.24u as=0.1406p ps=1.12u w=0.74u l=0.13u
X202 a_15755_1044# a_15545_1044# VDD.t260 VDD.t0 sg13_lv_pmos ad=0.2128p pd=1.5u as=0.252p ps=1.57u w=1.12u l=0.13u
X203 VDD.t117 a_2595_1047.t6 a_14311_1008# VDD.t0 sg13_lv_pmos ad=0.3808p pd=2.92u as=0.3808p ps=2.92u w=1.12u l=0.13u
X204 VSS.t225 DELAY_VBIASN a_24631_1842# VSS.t224 sg13_lv_nmos ad=0.2516p pd=2.16u as=0.1406p ps=1.12u w=0.74u l=0.6u
X205 a_5115_1044# a_4905_1044# VDD.t173 VDD.t0 sg13_lv_pmos ad=0.2128p pd=1.5u as=0.252p ps=1.57u w=1.12u l=0.13u
X206 a_5974_5723# a_6126_3816# VSS.t574 VSS.t570 sg13_lv_nmos ad=0.38p pd=2.38u as=0.68p ps=4.68u w=2u l=1u
X207 VSS.t8 a_12907_5186# a_12907_5186# VSS.t528 sg13_lv_nmos ad=1.45407p pd=9.445u as=0.111p ps=1.34u w=0.3u l=0.13u
X208 a_18551_2470# a_18313_1842# a_18443_1842# VDD.t3 sg13_lv_pmos ad=0.2128p pd=1.5u as=0.3808p ps=2.92u w=1.12u l=0.2u
X209 VDD.t71 VSS.t95 VDD.t70 VDD.t0 sg13_lv_pmos ad=0.19p pd=1.38u as=0 ps=0 w=1u l=1u
X210 a_3171_1047.t1 a_2873_1395# VSS.t28 VSS.t27 sg13_lv_nmos ad=0.1406p pd=1.12u as=0.1331p ps=1.12u w=0.74u l=0.13u
X211 a_13121_5831# a_15688_5867# VSS.t21 VSS.t493 sg13_lv_nmos ad=0.2516p pd=2.16u as=0.1406p ps=1.12u w=0.74u l=0.13u
X212 VSS.t170 DELAY_VBIASN VSS.t172 VSS.t171 sg13_lv_nmos ad=1.33p pd=7.38u as=0 ps=0 w=7u l=7u
X213 VSS.t296 a_2297_1395# a_2595_1047.t1 VSS.t297 sg13_lv_nmos ad=0.2812p pd=2.24u as=0.1406p ps=1.12u w=0.74u l=0.13u
X214 VDD.t63 a_14851_5182# a_15108_5325# VDD.t7 sg13_lv_pmos ad=0.2639p pd=1.81u as=79.8f ps=0.8u w=0.42u l=0.13u
X215 a_22351_2470# a_22113_1842# a_22243_1842# VDD.t3 sg13_lv_pmos ad=0.2128p pd=1.5u as=0.3808p ps=2.92u w=1.12u l=0.2u
X216 VSS.t327 VSS.t327 VSS.t329 VSS.t328 sg13_lv_nmos ad=0.2516p pd=2.16u as=0 ps=0 w=0.74u l=0.13u
X217 a_26911_1842# a_26673_1842# a_26803_1842# VSS.t412 sg13_lv_nmos ad=0.1406p pd=1.12u as=0.2516p ps=2.16u w=0.74u l=0.2u
X218 VSS.t70 a_3171_311.t3 a_11785_519# VSS.t127 sg13_lv_nmos ad=0.2516p pd=2.16u as=0.2516p ps=2.16u w=0.74u l=0.13u
X219 VDD.t366 a_1721_1395# a_2019_1047.t0 VDD.t0 sg13_lv_pmos ad=0.4256p pd=3u as=0.2128p ps=1.5u w=1.12u l=0.13u
X220 a_12656_5864# DLL_RESETN VSS.t248 VSS.t519 sg13_lv_nmos ad=0.2516p pd=2.16u as=0.2516p ps=2.16u w=0.74u l=0.13u
X221 a_14851_6228# a_14009_5878# a_14757_6228# VSS.t19 sg13_lv_nmos ad=0.12665p pd=1.145u as=0.1428p ps=1.52u w=0.42u l=0.13u
X222 VDD.t141 a_16923_1842# a_17357_1842# VDD.t3 sg13_lv_pmos ad=0.2128p pd=1.5u as=0.3808p ps=2.92u w=1.12u l=0.13u
X223 a_2391_1395# MUX_SEL0 a_2297_1395# VSS.t533 sg13_lv_nmos ad=0.1216p pd=1.02u as=0.2176p ps=1.96u w=0.64u l=0.13u
X224 VSS.t296 a_1544_1044# a_1815_1395# VSS.t370 sg13_lv_nmos ad=0.1331p pd=1.12u as=0.1216p ps=1.02u w=0.64u l=0.13u
X225 a_13368_1044# a_12797_1842# VSS.t276 VSS.t513 sg13_lv_nmos ad=0.1406p pd=1.12u as=0.2516p ps=2.16u w=0.74u l=0.13u
X226 a_13400_5105# a_13132_5420# a_13306_5105# VSS.t366 sg13_lv_nmos ad=60.89999f pd=0.71u as=0.1428p ps=1.52u w=0.42u l=0.13u
X227 a_5731_289# a_3171_311.t3 a_10430_1044# VSS.t126 sg13_lv_nmos ad=0.2516p pd=2.16u as=0.2516p ps=2.16u w=0.74u l=0.13u
X228 VDD.t122 a_21157_1842# a_21625_1044# VDD.t0 sg13_lv_pmos ad=0.252p pd=1.57u as=0.3808p ps=2.92u w=1.12u l=0.13u
X229 VDD.t298 DELAY_VBIASP a_10951_2470# VDD.t3 sg13_lv_pmos ad=0.3808p pd=2.92u as=0.2128p ps=1.5u w=1.12u l=0.6u
X230 VSS.t157 DELAY_VBIASN a_15511_1842# VSS.t156 sg13_lv_nmos ad=0.2516p pd=2.16u as=0.1406p ps=1.12u w=0.74u l=0.6u
X231 a_6326_4590# a_6326_4590# VDD.t97 VDD.t7 sg13_lv_pmos ad=0.38p pd=2.38u as=0.38p ps=2.38u w=2u l=1u
X232 VSS.t186 DELAY_VBIASN VSS.t180 VSS.t165 sg13_lv_nmos ad=1.33p pd=7.38u as=0 ps=0 w=7u l=7u
X233 VDD.t121 a_20723_1842# a_21157_1842# VDD.t3 sg13_lv_pmos ad=0.2128p pd=1.5u as=0.3808p ps=2.92u w=1.12u l=0.13u
X234 VSS.t223 a_25283_1842# a_25717_1842# VSS.t584 sg13_lv_nmos ad=0.1406p pd=1.12u as=0.2516p ps=2.16u w=0.74u l=0.13u
X235 a_4350_1044# a_3747_1047.t9 a_6635_1044# VSS.t597 sg13_lv_nmos ad=0.2516p pd=2.16u as=0.1406p ps=1.12u w=0.74u l=0.13u
X236 VSS.t120 DELAY_VBIASN a_5631_1842# VSS.t150 sg13_lv_nmos ad=0.2516p pd=2.16u as=0.1406p ps=1.12u w=0.74u l=0.6u
X237 VDD.t206 a_2019_1047.t9 a_4324_1008# VDD.t0 sg13_lv_pmos ad=0.3808p pd=2.92u as=0.3808p ps=2.92u w=1.12u l=0.13u
X238 a_12849_5867# a_12656_5864# VSS.t248 VSS.t247 sg13_lv_nmos ad=0.1406p pd=1.12u as=0.2516p ps=2.16u w=0.74u l=0.13u
X239 a_16510_1044# a_18871_1008# a_18795_1044# VDD.t0 sg13_lv_pmos ad=0.3808p pd=2.92u as=0.2128p ps=1.5u w=1.12u l=0.13u
X240 a_19550_1044# a_2595_1047.t4 a_20315_1044# VSS.t422 sg13_lv_nmos ad=0.2516p pd=2.16u as=0.1406p ps=1.12u w=0.74u l=0.13u
X241 VDD.t101 a_6326_4590# a_6126_3816# VDD.t7 sg13_lv_pmos ad=0.38p pd=2.38u as=0.38p ps=2.38u w=2u l=1u
X242 VDD.t8 a_11491_6228# a_11748_6109# VDD.t7 sg13_lv_pmos ad=1.10612p pd=6.66u as=79.8f ps=0.8u w=0.42u l=0.13u
X243 a_12355_5867# a_12158_5867# VDD.t318 VDD.t7 sg13_lv_pmos ad=0.3808p pd=2.92u as=0.2128p ps=1.5u w=1.12u l=0.13u
X244 VDD.t307 DELAY_VBIASP a_23871_2470# VDD.t3 sg13_lv_pmos ad=0.3808p pd=2.92u as=0.2128p ps=1.5u w=1.12u l=0.6u
X245 VSS.t411 a_7477_1842# a_7945_1044# VSS.t410 sg13_lv_nmos ad=0.1665p pd=1.19u as=0.2516p ps=2.16u w=0.74u l=0.13u
X246 a_11910_6305# DLL_RESETN VSS.t248 VSS.t401 sg13_lv_nmos ad=37.8f pd=0.6u as=79.8f ps=0.8u w=0.42u l=0.13u
X247 VSS.t176 DELAY_VBIASN VSS.t178 VSS.t177 sg13_lv_nmos ad=1.33p pd=7.38u as=0 ps=0 w=7u l=7u
X248 a_13231_2470# a_12993_1842# a_13123_1842# VDD.t3 sg13_lv_pmos ad=0.2128p pd=1.5u as=0.3808p ps=2.92u w=1.12u l=0.2u
X249 VDD.t228 VSS.t48 VDD.t227 VDD.t0 sg13_lv_pmos ad=0.34p pd=2.68u as=0 ps=0 w=1u l=1u
X250 a_6326_4590# a_6126_3816# a_5778_3367# VSS.t567 sg13_lv_nmos ad=0.38p pd=2.38u as=0.68p ps=4.68u w=2u l=1u
X251 a_12233_1842# a_12037_1842# VDD.t94 VDD.t3 sg13_lv_pmos ad=0.3808p pd=2.92u as=0.2128p ps=1.5u w=1.12u l=0.13u
X252 a_7911_1842# a_7673_1842# a_7803_1842# VSS.t125 sg13_lv_nmos ad=0.1406p pd=1.12u as=0.2516p ps=2.16u w=0.74u l=0.2u
X253 a_16793_1842# a_16597_1842# VSS.t146 VSS.t302 sg13_lv_nmos ad=0.2516p pd=2.16u as=0.1406p ps=1.12u w=0.74u l=0.13u
X254 VDD.t123 a_3747_311.t3 a_14825_519# VDD.t0 sg13_lv_pmos ad=0.3808p pd=2.92u as=0.3808p ps=2.92u w=1.12u l=0.13u
X255 VDD.t132 a_12849_5867# a_13306_6305# VDD.t7 sg13_lv_pmos ad=0.36237p pd=2.605u as=79.8f ps=0.8u w=0.42u l=0.13u
X256 VDD.t37 VDD.t29 VDD.t36 VDD.t7 sg13_lv_pmos ad=0.68p pd=4.68u as=0 ps=0 w=2u l=1u
X257 VSS.t122 a_27563_1842# a_27997_1842# VSS.t121 sg13_lv_nmos ad=0.1406p pd=1.12u as=0.2516p ps=2.16u w=0.74u l=0.13u
X258 a_9675_1044# a_9465_1044# VSS.t39 VSS.t38 sg13_lv_nmos ad=0.1406p pd=1.12u as=0.1665p ps=1.19u w=0.74u l=0.13u
X259 VDD.t97 a_6326_4590# a_6854_5986# VDD.t7 sg13_lv_pmos ad=0.38p pd=2.38u as=0.38p ps=2.38u w=2u l=1u
X260 a_20593_1842# a_20397_1842# VSS.t148 VSS.t540 sg13_lv_nmos ad=0.2516p pd=2.16u as=0.1406p ps=1.12u w=0.74u l=0.13u
X261 VSS.t256 a_2595_1047.t8 a_8231_1008# VSS.t255 sg13_lv_nmos ad=0.2516p pd=2.16u as=0.2516p ps=2.16u w=0.74u l=0.13u
X262 VSS.t199 a_6283_1842# a_6717_1842# VSS.t522 sg13_lv_nmos ad=0.1406p pd=1.12u as=0.2516p ps=2.16u w=0.74u l=0.13u
X263 a_10430_1044# a_10404_1008# a_10328_1044# VDD.t0 sg13_lv_pmos ad=0.3808p pd=2.92u as=0.2128p ps=1.5u w=1.12u l=0.13u
X264 VDD.t310 DELAY_VBIASP a_26151_2470# VDD.t3 sg13_lv_pmos ad=0.3808p pd=2.92u as=0.2128p ps=1.5u w=1.12u l=0.6u
X265 a_7390_1044# a_8884_1008# a_8808_1044# VDD.t0 sg13_lv_pmos ad=0.3808p pd=2.92u as=0.2128p ps=1.5u w=1.12u l=0.13u
X266 a_11491_6228# a_10649_5878# a_11397_6228# VSS.t401 sg13_lv_nmos ad=0.12665p pd=1.145u as=0.1428p ps=1.52u w=0.42u l=0.13u
X267 VDD.t292 DELAY_VBIASP a_4871_2470# VDD.t3 sg13_lv_pmos ad=0.3808p pd=2.92u as=0.2128p ps=1.5u w=1.12u l=0.6u
X268 a_6126_3816# a_6126_3816# VSS.t568 VSS.t567 sg13_lv_nmos ad=0.38p pd=2.38u as=0.68p ps=4.68u w=2u l=1u
X269 a_3449_331# MUX_SEL2 VDD.t147 VDD.t0 sg13_lv_pmos ad=0.1596p pd=1.22u as=0.2856p ps=2.36u w=0.84u l=0.13u
X270 VDD.t375 VSS.t88 VDD.t373 VDD.t0 sg13_lv_pmos ad=0.19p pd=1.38u as=0 ps=0 w=1u l=1u
X271 a_19073_1842# a_18877_1842# VSS.t215 VSS.t273 sg13_lv_nmos ad=0.2516p pd=2.16u as=0.1406p ps=1.12u w=0.74u l=0.13u
X272 VDD.t260 a_15077_1842# a_15545_1044# VDD.t0 sg13_lv_pmos ad=0.252p pd=1.57u as=0.3808p ps=2.92u w=1.12u l=0.13u
X273 a_19550_1044# a_2019_1047.t4 a_19448_1044# VSS.t444 sg13_lv_nmos ad=0.2516p pd=2.16u as=0.1406p ps=1.12u w=0.74u l=0.13u
X274 VDD.t90 a_12849_5867# a_13306_5105# VDD.t7 sg13_lv_pmos ad=0.36237p pd=2.605u as=79.8f ps=0.8u w=0.42u l=0.13u
X275 VDD.t59 VDD.t57 VDD.t58 VDD.t3 sg13_lv_pmos ad=0.3808p pd=2.92u as=0 ps=0 w=1.12u l=0.6u
X276 VSS.t110 VDD.t394 VSS.t108 VSS.t109 sg13_lv_nmos ad=79.8f pd=0.8u as=0 ps=0 w=0.42u l=1u
X277 a_13592_5871# a_13566_5835# VSS.t299 VSS.t298 sg13_lv_nmos ad=0.2516p pd=2.16u as=0.1626p ps=1.415u w=0.74u l=0.13u
X278 VSS.t219 a_19203_1842# a_19637_1842# VSS.t623 sg13_lv_nmos ad=0.1406p pd=1.12u as=0.2516p ps=2.16u w=0.74u l=0.13u
X279 VDD.t371 VSS.t88 VDD.t84 VDD.t0 sg13_lv_pmos ad=0.19p pd=1.38u as=0 ps=0 w=1u l=1u
X280 a_15108_6109# a_12849_5867# VDD.t8 VDD.t7 sg13_lv_pmos ad=79.8f pd=0.8u as=1.03698p ps=6.245u w=0.42u l=0.13u
X281 VDD.t353 VSS.t66 VDD.t352 VDD.t0 sg13_lv_pmos ad=0.34p pd=2.68u as=0 ps=0 w=1u l=1u
X282 VSS.t365 a_15108_6109# a_14757_6228# VSS.t19 sg13_lv_nmos ad=79.8f pd=0.8u as=0.1428p ps=1.52u w=0.42u l=0.13u
X283 a_27433_1842# a_27237_1842# VDD.t10 VDD.t3 sg13_lv_pmos ad=0.3808p pd=2.92u as=0.2128p ps=1.5u w=1.12u l=0.13u
X284 VDD.t328 a_1256_289# a_2873_331# VDD.t0 sg13_lv_pmos ad=0.1918p pd=1.5u as=0.1596p ps=1.22u w=0.84u l=0.13u
X285 a_13470_1044# a_2595_1047.t6 a_14235_1044# VSS.t282 sg13_lv_nmos ad=0.2516p pd=2.16u as=0.1406p ps=1.12u w=0.74u l=0.13u
X286 VSS.t243 a_9444_4590# a_9444_4590# VSS.t234 sg13_lv_nmos ad=0.68p pd=4.68u as=0.38p ps=2.38u w=2u l=1u
X287 VSS.t142 a_8563_1842# a_8997_1842# VSS.t231 sg13_lv_nmos ad=0.1406p pd=1.12u as=0.2516p ps=2.16u w=0.74u l=0.13u
X288 VSS.t321 VSS.t321 VSS.t323 VSS.t322 sg13_lv_nmos ad=0.2516p pd=2.16u as=0 ps=0 w=0.74u l=0.13u
X289 VSS.t18 DELAY_VBIASN a_13231_1842# VSS.t210 sg13_lv_nmos ad=0.2516p pd=2.16u as=0.1406p ps=1.12u w=0.74u l=0.6u
X290 VDD.t24 a_3171_1047.t7 a_11924_1008# VDD.t0 sg13_lv_pmos ad=0.3808p pd=2.92u as=0.3808p ps=2.92u w=1.12u l=0.13u
X291 VSS.t436 a_2019_1047.t3 a_22564_1008# VSS.t435 sg13_lv_nmos ad=0.2516p pd=2.16u as=0.2516p ps=2.16u w=0.74u l=0.13u
X292 a_15053_5420# a_14111_5227# a_14851_5182# VDD.t7 sg13_lv_pmos ad=93.45f pd=0.865u as=0.2048p ps=1.63u w=0.42u l=0.13u
X293 VSS.t320 VSS.t316 VSS.t316 VSS.t318 sg13_lv_nmos ad=0.1406p pd=1.12u as=0 ps=0 w=0.74u l=0.13u
X294 VSS.t144 a_23003_1842# a_23437_1842# VSS.t524 sg13_lv_nmos ad=0.1406p pd=1.12u as=0.2516p ps=2.16u w=0.74u l=0.13u
X295 VSS.t110 VDD.t393 VSS.t110 VSS.t111 sg13_lv_nmos ad=0.1428p pd=1.52u as=0 ps=0 w=0.42u l=1u
X296 VDD.t280 DELAY_VBIASP a_7151_2470# VDD.t3 sg13_lv_pmos ad=0.3808p pd=2.92u as=0.2128p ps=1.5u w=1.12u l=0.6u
X297 a_5778_3367# VSS.t610 VSS.t609 rppd l=32u w=1u
X298 a_25630_1044# a_25604_1008# a_25528_1044# VDD.t0 sg13_lv_pmos ad=0.3808p pd=2.92u as=0.2128p ps=1.5u w=1.12u l=0.13u
X299 a_10206_5835# a_10649_5878# a_10589_5914# VDD.t7 sg13_lv_pmos ad=79.8f pd=0.8u as=63f ps=0.72u w=0.42u l=0.13u
X300 a_15511_1842# a_15273_1842# a_15403_1842# VSS.t617 sg13_lv_nmos ad=0.1406p pd=1.12u as=0.2516p ps=2.16u w=0.74u l=0.2u
X301 a_10520_6292# a_10751_5878# a_10206_5835# VSS.t400 sg13_lv_nmos ad=0.2373p pd=1.97u as=79.8f ps=0.8u w=0.42u l=0.13u
X302 a_11693_5990# a_10751_5878# a_11491_6228# VDD.t7 sg13_lv_pmos ad=93.45f pd=0.865u as=0.2048p ps=1.63u w=0.42u l=0.13u
X303 a_18313_1842# a_18117_1842# VDD.t129 VDD.t3 sg13_lv_pmos ad=0.3808p pd=2.92u as=0.2128p ps=1.5u w=1.12u l=0.13u
X304 a_5731_289# a_11785_519# a_10430_1044# VDD.t0 sg13_lv_pmos ad=0.3808p pd=2.92u as=0.3808p ps=2.92u w=1.12u l=0.13u
X305 VSS.t51 VDD.t410 VSS.t49 VSS.t50 sg13_lv_nmos ad=79.8f pd=0.8u as=0 ps=0 w=0.42u l=1u
X306 a_9431_2470# a_9193_1842# a_9323_1842# VDD.t3 sg13_lv_pmos ad=0.2128p pd=1.5u as=0.3808p ps=2.92u w=1.12u l=0.2u
X307 a_17275_1044# a_17065_1044# VSS.t301 VSS.t489 sg13_lv_nmos ad=0.1406p pd=1.12u as=0.1665p ps=1.19u w=0.74u l=0.13u
X308 VDD.t70 VSS.t92 VDD.t242 VDD.t0 sg13_lv_pmos ad=0.34p pd=2.68u as=0 ps=0 w=1u l=1u
X309 VSS.t130 a_3747_1047.t6 a_15831_1008# VSS.t129 sg13_lv_nmos ad=0.2516p pd=2.16u as=0.2516p ps=2.16u w=0.74u l=0.13u
X310 a_23871_2470# a_23633_1842# a_23763_1842# VDD.t3 sg13_lv_pmos ad=0.2128p pd=1.5u as=0.3808p ps=2.92u w=1.12u l=0.2u
X311 VSS.t209 a_13883_1842# a_14317_1842# VSS.t414 sg13_lv_nmos ad=0.1406p pd=1.12u as=0.2516p ps=2.16u w=0.74u l=0.13u
X312 VSS.t452 a_3747_311.t2 a_26985_519# VSS.t451 sg13_lv_nmos ad=0.2516p pd=2.16u as=0.2516p ps=2.16u w=0.74u l=0.13u
X313 a_8433_1842# a_8237_1842# VDD.t19 VDD.t3 sg13_lv_pmos ad=0.3808p pd=2.92u as=0.2128p ps=1.5u w=1.12u l=0.13u
X314 VDD.t113 a_18443_1842# a_18877_1842# VDD.t3 sg13_lv_pmos ad=0.2128p pd=1.5u as=0.3808p ps=2.92u w=1.12u l=0.13u
X315 a_22113_1842# a_21917_1842# VDD.t23 VDD.t3 sg13_lv_pmos ad=0.3808p pd=2.92u as=0.2128p ps=1.5u w=1.12u l=0.13u
X316 a_4350_1044# a_2019_1047.t9 a_4248_1044# VSS.t437 sg13_lv_nmos ad=0.2516p pd=2.16u as=0.1406p ps=1.12u w=0.74u l=0.13u
X317 a_14888_1044# a_14317_1842# VSS.t284 VSS.t608 sg13_lv_nmos ad=0.1406p pd=1.12u as=0.2516p ps=2.16u w=0.74u l=0.13u
X318 a_13880_5118# a_13592_5423# a_13818_5118# VSS.t547 sg13_lv_nmos ad=0.1428p pd=1.52u as=37.8f ps=0.6u w=0.42u l=0.13u
X319 a_16108_289# a_3747_311.t2 a_25630_1044# VSS.t450 sg13_lv_nmos ad=0.2516p pd=2.16u as=0.2516p ps=2.16u w=0.74u l=0.13u
X320 VDD.t295 DELAY_VBIASP a_12471_2470# VDD.t3 sg13_lv_pmos ad=0.3808p pd=2.92u as=0.2128p ps=1.5u w=1.12u l=0.6u
X321 VSS.t159 a_4003_1842# a_4437_1842# VSS.t342 sg13_lv_nmos ad=0.1406p pd=1.12u as=0.2516p ps=2.16u w=0.74u l=0.13u
X322 a_16510_1044# a_16484_1008# a_16408_1044# VDD.t0 sg13_lv_pmos ad=0.3808p pd=2.92u as=0.2128p ps=1.5u w=1.12u l=0.13u
X323 VSS.t248 a_13121_5831# a_13045_6215# VSS.t455 sg13_lv_nmos ad=0.2516p pd=2.16u as=0.1406p ps=1.12u w=0.74u l=0.13u
X324 VDD.t65 a_14851_5182# a_15688_5403# VDD.t7 sg13_lv_pmos ad=0.2128p pd=1.5u as=0.3864p ps=2.93u w=1.12u l=0.13u
X325 VDD.t119 a_22243_1842# a_22677_1842# VDD.t3 sg13_lv_pmos ad=0.2128p pd=1.5u as=0.3808p ps=2.92u w=1.12u l=0.13u
X326 VDD.t208 a_3171_1047.t2 a_27124_1008# VDD.t0 sg13_lv_pmos ad=0.3808p pd=2.92u as=0.3808p ps=2.92u w=1.12u l=0.13u
X327 VDD.t171 MUX_SEL3 a_3449_331# VDD.t0 sg13_lv_pmos ad=0.1918p pd=1.5u as=0.1596p ps=1.22u w=0.84u l=0.13u
X328 a_2595_311.t0 a_2297_331# VDD.t176 VDD.t0 sg13_lv_pmos ad=0.2128p pd=1.5u as=0.1918p ps=1.5u w=1.12u l=0.13u
X329 a_10430_1044# a_11271_1008# a_11195_1044# VDD.t0 sg13_lv_pmos ad=0.3808p pd=2.92u as=0.2128p ps=1.5u w=1.12u l=0.13u
X330 a_14009_5084# DELAY_OUT_LAST VSS.t8 VSS.t7 sg13_lv_nmos ad=0.2516p pd=2.16u as=1.45407p ps=9.445u w=0.74u l=0.13u
X331 a_23355_1044# a_23145_1044# VDD.t267 VDD.t0 sg13_lv_pmos ad=0.2128p pd=1.5u as=0.252p ps=1.57u w=1.12u l=0.13u
X332 VDD.t115 a_3747_1047.t4 a_21911_1008# VDD.t0 sg13_lv_pmos ad=0.3808p pd=2.92u as=0.3808p ps=2.92u w=1.12u l=0.13u
X333 VSS.t39 a_8997_1842# a_9465_1044# VSS.t619 sg13_lv_nmos ad=0.1665p pd=1.19u as=0.2516p ps=2.16u w=0.74u l=0.13u
X334 a_13592_5423# a_13566_5328# VDD.t90 VDD.t7 sg13_lv_pmos ad=0.34p pd=2.68u as=0.36237p ps=2.605u w=1u l=0.13u
X335 a_6126_3816# a_5974_5723# a_6326_4590# VSS.t570 sg13_lv_nmos ad=0.68p pd=4.68u as=0.38p ps=2.38u w=2u l=1u
X336 a_20968_1044# a_20397_1842# VDD.t326 VDD.t0 sg13_lv_pmos ad=0.2128p pd=1.5u as=0.3808p ps=2.92u w=1.12u l=0.13u
X337 a_10951_1842# a_10713_1842# a_10843_1842# VSS.t244 sg13_lv_nmos ad=0.1406p pd=1.12u as=0.2516p ps=2.16u w=0.74u l=0.2u
X338 VSS.t406 a_2019_1047.t5 a_16484_1008# VSS.t405 sg13_lv_nmos ad=0.2516p pd=2.16u as=0.2516p ps=2.16u w=0.74u l=0.13u
X339 a_26151_2470# a_25913_1842# a_26043_1842# VDD.t3 sg13_lv_pmos ad=0.2128p pd=1.5u as=0.3808p ps=2.92u w=1.12u l=0.2u
X340 a_9444_4590# a_6854_5454# a_6854_5454# VSS.t614 sg13_lv_nmos ad=0.68p pd=4.68u as=0.38p ps=2.38u w=2u l=1u
X341 a_13753_1842# a_13557_1842# VDD.t15 VDD.t3 sg13_lv_pmos ad=0.3808p pd=2.92u as=0.2128p ps=1.5u w=1.12u l=0.13u
X342 VDD.t186 a_1721_331# a_2019_311# VDD.t0 sg13_lv_pmos ad=0.4256p pd=3u as=0.2128p ps=1.5u w=1.12u l=0.13u
X343 a_4871_2470# a_4633_1842# a_4763_1842# VDD.t3 sg13_lv_pmos ad=0.2128p pd=1.5u as=0.3808p ps=2.92u w=1.12u l=0.2u
X344 VSS.t427 a_3171_1047.t9 a_5844_1008# VSS.t426 sg13_lv_nmos ad=0.2516p pd=2.16u as=0.2516p ps=2.16u w=0.74u l=0.13u
X345 VSS.t77 VDD.t402 VSS.t77 VSS.t79 sg13_lv_nmos ad=79.8f pd=0.8u as=0 ps=0 w=0.42u l=1u
X346 VDD.t69 a_2595_311.t2 a_20905_519# VDD.t0 sg13_lv_pmos ad=0.3808p pd=2.92u as=0.3808p ps=2.92u w=1.12u l=0.13u
X347 VDD.t223 a_2297_331# a_2595_311.t0 VDD.t0 sg13_lv_pmos ad=0.4256p pd=3u as=0.2128p ps=1.5u w=1.12u l=0.13u
X348 a_14009_5084# DELAY_OUT_LAST VDD.t8 VDD.t7 sg13_lv_pmos ad=0.4088p pd=2.97u as=1.10612p ps=6.66u w=1.12u l=0.13u
X349 VSS.t259 a_2595_1047.t7 a_11271_1008# VSS.t258 sg13_lv_nmos ad=0.2516p pd=2.16u as=0.2516p ps=2.16u w=0.74u l=0.13u
X350 VSS.t219 DELAY_VBIASN a_19311_1842# VSS.t218 sg13_lv_nmos ad=0.2516p pd=2.16u as=0.1406p ps=1.12u w=0.74u l=0.6u
X351 VSS.t235 a_9444_4590# a_9444_3912# VSS.t234 sg13_lv_nmos ad=0.68p pd=4.68u as=0.38p ps=2.38u w=2u l=1u
X352 a_13880_5118# a_14111_5227# a_13566_5328# VSS.t545 sg13_lv_nmos ad=0.2373p pd=1.97u as=79.8f ps=0.8u w=0.42u l=0.13u
X353 VDD.t120 a_24523_1842# a_24957_1842# VDD.t3 sg13_lv_pmos ad=0.2128p pd=1.5u as=0.3808p ps=2.92u w=1.12u l=0.13u
X354 VSS.t45 a_3747_1047.t8 a_9751_1008# VSS.t440 sg13_lv_nmos ad=0.2516p pd=2.16u as=0.2516p ps=2.16u w=0.74u l=0.13u
X355 VSS.t43 DELAY_VBIASN a_9431_1842# VSS.t200 sg13_lv_nmos ad=0.2516p pd=2.16u as=0.1406p ps=1.12u w=0.74u l=0.6u
X356 a_19448_1044# a_18877_1842# VDD.t112 VDD.t0 sg13_lv_pmos ad=0.2128p pd=1.5u as=0.3808p ps=2.92u w=1.12u l=0.13u
X357 VSS.t248 a_11491_6228# a_12158_5867# VSS.t529 sg13_lv_nmos ad=0.1406p pd=1.12u as=0.2516p ps=2.16u w=0.74u l=0.13u
X358 a_13566_5328# a_14009_5084# a_13949_5496# VDD.t7 sg13_lv_pmos ad=79.8f pd=0.8u as=63f ps=0.72u w=0.42u l=0.13u
X359 VSS.t144 DELAY_VBIASN a_23111_1842# VSS.t143 sg13_lv_nmos ad=0.2516p pd=2.16u as=0.1406p ps=1.12u w=0.74u l=0.6u
X360 a_10430_1044# a_11924_1008# a_11848_1044# VDD.t0 sg13_lv_pmos ad=0.3808p pd=2.92u as=0.2128p ps=1.5u w=1.12u l=0.13u
X361 VDD.t312 DELAY_VBIASP a_27671_2470# VDD.t3 sg13_lv_pmos ad=0.3808p pd=2.92u as=0.2128p ps=1.5u w=1.12u l=0.6u
X362 a_6854_5986# a_6326_4590# VDD.t30 VDD.t7 sg13_lv_pmos ad=0.38p pd=2.38u as=0.38p ps=2.38u w=2u l=1u
X363 VSS.t184 DELAY_VBIASN DELAY_VBIASP VSS.t183 sg13_lv_nmos ad=0.2516p pd=2.16u as=0.6808p ps=3.32u w=0.74u l=0.6u
X364 a_25630_1044# a_26471_1008# a_26395_1044# VDD.t0 sg13_lv_pmos ad=0.3808p pd=2.92u as=0.2128p ps=1.5u w=1.12u l=0.13u
X365 VSS.t166 DELAY_VBIASN VSS.t168 VSS.t167 sg13_lv_nmos ad=1.33p pd=7.38u as=0 ps=0 w=7u l=7u
X366 a_10040_6305# a_9772_5843# a_9946_6305# VSS.t374 sg13_lv_nmos ad=60.89999f pd=0.71u as=0.1428p ps=1.52u w=0.42u l=0.13u
X367 a_7151_2470# a_6913_1842# a_7043_1842# VDD.t3 sg13_lv_pmos ad=0.2128p pd=1.5u as=0.3808p ps=2.92u w=1.12u l=0.2u
X368 a_16033_1842# a_15837_1842# VDD.t158 VDD.t3 sg13_lv_pmos ad=0.3808p pd=2.92u as=0.2128p ps=1.5u w=1.12u l=0.13u
X369 VDD.t99 a_6326_4590# a_6326_4590# VDD.t7 sg13_lv_pmos ad=0.38p pd=2.38u as=0.38p ps=2.38u w=2u l=1u
X370 VDD.t76 a_15964_289# a_16851_309# VDD.t0 sg13_lv_pmos ad=0.2086p pd=1.5u as=0.34p ps=2.68u w=1u l=0.13u
X371 VDD.t373 VSS.t88 VDD.t372 VDD.t0 sg13_lv_pmos ad=0.34p pd=2.68u as=0 ps=0 w=1u l=1u
X372 a_15464_3684# a_14851_5182# VSS.t116 VSS.t115 sg13_lv_nmos ad=0.2849p pd=2.25u as=0.2516p ps=2.16u w=0.74u l=0.13u
X373 VSS.t204 a_11603_1842# a_12037_1842# VSS.t340 sg13_lv_nmos ad=0.1406p pd=1.12u as=0.2516p ps=2.16u w=0.74u l=0.13u
X374 VSS.t95 VDD.t398 VSS.t93 VSS.t94 sg13_lv_nmos ad=79.8f pd=0.8u as=0 ps=0 w=0.42u l=1u
X375 VDD.t162 VSS.t64 VDD.t161 VDD.t0 sg13_lv_pmos ad=0.34p pd=2.68u as=0 ps=0 w=1u l=1u
X376 VDD.t6 a_5957_1842# a_6425_1044# VDD.t0 sg13_lv_pmos ad=0.252p pd=1.57u as=0.3808p ps=2.92u w=1.12u l=0.13u
X377 a_24393_1842# a_24197_1842# VSS.t155 VSS.t351 sg13_lv_nmos ad=0.2516p pd=2.16u as=0.1406p ps=1.12u w=0.74u l=0.13u
X378 a_3747_1047.t1 a_3449_1395# VSS.t538 VSS.t558 sg13_lv_nmos ad=0.1406p pd=1.12u as=0.1331p ps=1.12u w=0.74u l=0.13u
X379 a_1544_1044# MUX_SEL1 VSS.t296 VSS.t535 sg13_lv_nmos ad=0.2516p pd=2.16u as=0.2516p ps=2.16u w=0.74u l=0.13u
X380 VDD.t84 VSS.t86 VDD.t83 VDD.t0 sg13_lv_pmos ad=0.34p pd=2.68u as=0 ps=0 w=1u l=1u
X381 a_3171_1047.t0 a_2873_1395# VDD.t20 VDD.t0 sg13_lv_pmos ad=0.2128p pd=1.5u as=0.1918p ps=1.5u w=1.12u l=0.13u
X382 a_13470_1044# a_3747_1047.t6 a_15755_1044# VSS.t128 sg13_lv_nmos ad=0.2516p pd=2.16u as=0.1406p ps=1.12u w=0.74u l=0.13u
X383 VDD.t12 a_15464_3684# a_9712_3912# VSS.t16 sg13_lv_nmos ad=0.232p pd=2.08u as=0.136p ps=1.14u w=0.4u l=0.2u
X384 VDD.t67 a_5523_1842# a_5957_1842# VDD.t3 sg13_lv_pmos ad=0.2128p pd=1.5u as=0.3808p ps=2.92u w=1.12u l=0.13u
X385 VDD.t131 a_2297_1395# a_2595_1047.t0 VDD.t0 sg13_lv_pmos ad=0.4256p pd=3u as=0.2128p ps=1.5u w=1.12u l=0.13u
X386 VSS.t161 DELAY_VBIASN a_14751_1842# VSS.t160 sg13_lv_nmos ad=0.2516p pd=2.16u as=0.1406p ps=1.12u w=0.74u l=0.6u
X387 a_2967_1395# MUX_SEL1 a_2873_1395# VSS.t536 sg13_lv_nmos ad=0.1216p pd=1.02u as=0.2176p ps=1.96u w=0.64u l=0.13u
X388 a_4350_1044# a_2595_1047.t9 a_5115_1044# VSS.t481 sg13_lv_nmos ad=0.2516p pd=2.16u as=0.1406p ps=1.12u w=0.74u l=0.13u
X389 VDD.t201 a_2019_1047.t6 a_13444_1008# VDD.t0 sg13_lv_pmos ad=0.3808p pd=2.92u as=0.3808p ps=2.92u w=1.12u l=0.13u
X390 VSS.t486 a_2595_1047.t2 a_26471_1008# VSS.t485 sg13_lv_nmos ad=0.2516p pd=2.16u as=0.2516p ps=2.16u w=0.74u l=0.13u
X391 a_2595_311.t1 a_2297_331# VSS.t398 VSS.t464 sg13_lv_nmos ad=0.1406p pd=1.12u as=0.1331p ps=1.12u w=0.74u l=0.13u
X392 VSS.t379 a_14009_5878# a_14111_5878# VSS.t469 sg13_lv_nmos ad=2.39977p pd=15.495u as=0.2516p ps=2.16u w=0.74u l=0.13u
X393 VSS.t159 DELAY_VBIASN a_4111_1842# VSS.t158 sg13_lv_nmos ad=0.2516p pd=2.16u as=0.1406p ps=1.12u w=0.74u l=0.6u
X394 a_2297_1395# MUX_SEL0 VDD.t321 VDD.t0 sg13_lv_pmos ad=0.1596p pd=1.22u as=0.2856p ps=2.36u w=0.84u l=0.13u
X395 VSS.t301 a_16597_1842# a_17065_1044# VSS.t300 sg13_lv_nmos ad=0.1665p pd=1.19u as=0.2516p ps=2.16u w=0.74u l=0.13u
X396 VDD.t293 DELAY_VBIASP a_8671_2470# VDD.t3 sg13_lv_pmos ad=0.3808p pd=2.92u as=0.2128p ps=1.5u w=1.12u l=0.6u
X397 VDD.t125 VSS.t62 VDD.t124 VDD.t0 sg13_lv_pmos ad=0.19p pd=1.38u as=0 ps=0 w=1u l=1u
X398 VDD.t160 a_1544_1044# a_1721_1395# VDD.t0 sg13_lv_pmos ad=0.1918p pd=1.5u as=0.1596p ps=1.22u w=0.84u l=0.13u
X399 a_9444_4590# a_9444_4590# VSS.t242 VSS.t232 sg13_lv_nmos ad=0.38p pd=2.38u as=0.68p ps=4.68u w=2u l=1u
X400 a_4248_1044# a_4157_1313# VDD.t174 VDD.t0 sg13_lv_pmos ad=0.2128p pd=1.5u as=0.3808p ps=2.92u w=1.12u l=0.13u
X401 a_5778_3367# a_6126_3816# a_6326_4590# VSS.t567 sg13_lv_nmos ad=0.68p pd=4.68u as=0.38p ps=2.38u w=2u l=1u
X402 a_12471_2470# a_12233_1842# a_12363_1842# VDD.t3 sg13_lv_pmos ad=0.2128p pd=1.5u as=0.3808p ps=2.92u w=1.12u l=0.2u
X403 a_17031_1842# a_16793_1842# a_16923_1842# VSS.t588 sg13_lv_nmos ad=0.1406p pd=1.12u as=0.2516p ps=2.16u w=0.74u l=0.2u
X404 VSS.t398 a_1721_331# a_2019_311# VSS.t408 sg13_lv_nmos ad=0.2812p pd=2.24u as=0.1406p ps=1.12u w=0.74u l=0.13u
X405 a_19550_1044# a_21911_1008# a_21835_1044# VDD.t0 sg13_lv_pmos ad=0.3808p pd=2.92u as=0.2128p ps=1.5u w=1.12u l=0.13u
X406 a_16108_289# a_26985_519# a_25630_1044# VDD.t0 sg13_lv_pmos ad=0.3808p pd=2.92u as=0.3808p ps=2.92u w=1.12u l=0.13u
X407 VSS.t398 a_2297_331# a_2595_311.t1 VSS.t465 sg13_lv_nmos ad=0.2812p pd=2.24u as=0.1406p ps=1.12u w=0.74u l=0.13u
X408 a_18795_1044# a_18585_1044# VSS.t246 VSS.t245 sg13_lv_nmos ad=0.1406p pd=1.12u as=0.1665p ps=1.19u w=0.74u l=0.13u
X409 a_9444_3912# a_6854_5454# a_9712_3912# VSS.t614 sg13_lv_nmos ad=0.68p pd=4.68u as=0.38p ps=2.38u w=2u l=1u
X410 a_20831_1842# a_20593_1842# a_20723_1842# VSS.t396 sg13_lv_nmos ad=0.1406p pd=1.12u as=0.2516p ps=2.16u w=0.74u l=0.2u
X411 VSS.t49 VDD.t410 VSS.t48 VSS.t47 sg13_lv_nmos ad=0.1428p pd=1.52u as=0 ps=0 w=0.42u l=1u
X412 VDD.t267 a_22677_1842# a_23145_1044# VDD.t0 sg13_lv_pmos ad=0.252p pd=1.57u as=0.3808p ps=2.92u w=1.12u l=0.13u
X413 VSS.t230 a_2595_1047.t5 a_17351_1008# VSS.t229 sg13_lv_nmos ad=0.2516p pd=2.16u as=0.2516p ps=2.16u w=0.74u l=0.13u
X414 a_5393_1842# a_5197_1842# VSS.t197 VSS.t621 sg13_lv_nmos ad=0.2516p pd=2.16u as=0.1406p ps=1.12u w=0.74u l=0.13u
X415 VSS.t212 DELAY_VBIASN a_17031_1842# VSS.t211 sg13_lv_nmos ad=0.2516p pd=2.16u as=0.1406p ps=1.12u w=0.74u l=0.6u
X416 a_25630_1044# a_3171_1047.t2 a_27048_1044# VSS.t441 sg13_lv_nmos ad=0.2516p pd=2.16u as=0.1406p ps=1.12u w=0.74u l=0.13u
X417 VDD.t44 VDD.t41 VDD.t43 VDD.t42 sg13_lv_pmos ad=0.3808p pd=2.92u as=0 ps=0 w=1.12u l=0.13u
X418 a_9953_1842# a_9757_1842# VDD.t27 VDD.t3 sg13_lv_pmos ad=0.3808p pd=2.92u as=0.2128p ps=1.5u w=1.12u l=0.13u
X419 VDD.t167 a_10843_1842# a_11277_1842# VDD.t3 sg13_lv_pmos ad=0.2128p pd=1.5u as=0.3808p ps=2.92u w=1.12u l=0.13u
X420 VSS.t12 a_26803_1842# a_27237_1842# VSS.t359 sg13_lv_nmos ad=0.1406p pd=1.12u as=0.2516p ps=2.16u w=0.74u l=0.13u
X421 a_4350_1044# a_3171_1047.t9 a_5768_1044# VSS.t425 sg13_lv_nmos ad=0.2516p pd=2.16u as=0.1406p ps=1.12u w=0.74u l=0.13u
X422 VDD.t155 a_12849_5867# a_13566_5328# VDD.t7 sg13_lv_pmos ad=0.1563p pd=1.22u as=0.147p ps=1.54u w=0.42u l=0.13u
X423 VDD.t49 VDD.t50 VDD.t51 VDD.t42 sg13_lv_pmos ad=0.2128p pd=1.5u as=0 ps=0 w=1.12u l=0.13u
X424 a_10430_1044# a_12791_1008# a_12715_1044# VDD.t0 sg13_lv_pmos ad=0.3808p pd=2.92u as=0.2128p ps=1.5u w=1.12u l=0.13u
X425 a_19311_1842# a_19073_1842# a_19203_1842# VSS.t478 sg13_lv_nmos ad=0.1406p pd=1.12u as=0.2516p ps=2.16u w=0.74u l=0.2u
X426 a_24875_1044# a_24665_1044# VDD.t144 VDD.t0 sg13_lv_pmos ad=0.2128p pd=1.5u as=0.252p ps=1.57u w=1.12u l=0.13u
X427 VDD.t200 a_2595_1047.t3 a_23431_1008# VDD.t0 sg13_lv_pmos ad=0.3808p pd=2.92u as=0.3808p ps=2.92u w=1.12u l=0.13u
X428 VDD.t8 a_14009_5878# a_14111_5878# VDD.t7 sg13_lv_pmos ad=1.10612p pd=6.66u as=0.3864p ps=2.93u w=1.12u l=0.13u
X429 a_13949_5914# a_13592_5871# VDD.t26 VDD.t7 sg13_lv_pmos ad=63f pd=0.72u as=0.1563p ps=1.22u w=0.42u l=0.13u
X430 VDD.t263 a_13557_1842# a_14025_1044# VDD.t0 sg13_lv_pmos ad=0.252p pd=1.57u as=0.3808p ps=2.92u w=1.12u l=0.13u
X431 a_23111_1842# a_22873_1842# a_23003_1842# VSS.t413 sg13_lv_nmos ad=0.1406p pd=1.12u as=0.2516p ps=2.16u w=0.74u l=0.2u
X432 VSS.t381 a_10649_5878# a_10751_5878# VSS.t480 sg13_lv_nmos ad=2.39977p pd=15.495u as=0.2516p ps=2.16u w=0.74u l=0.13u
X433 a_27671_2470# a_27433_1842# a_27563_1842# VDD.t3 sg13_lv_pmos ad=0.2128p pd=1.5u as=0.3808p ps=2.92u w=1.12u l=0.2u
X434 VSS.t221 a_17683_1842# a_18117_1842# VSS.t523 sg13_lv_nmos ad=0.1406p pd=1.12u as=0.2516p ps=2.16u w=0.74u l=0.13u
X435 VSS.t88 VDD.t399 VSS.t88 VSS.t90 sg13_lv_nmos ad=79.8f pd=0.8u as=0 ps=0 w=0.42u l=1u
X436 a_10713_1842# a_10517_1842# VSS.t132 VSS.t131 sg13_lv_nmos ad=0.2516p pd=2.16u as=0.1406p ps=1.12u w=0.74u l=0.13u
X437 VSS.t281 a_2019_1047.t8 a_7364_1008# VSS.t280 sg13_lv_nmos ad=0.2516p pd=2.16u as=0.2516p ps=2.16u w=0.74u l=0.13u
X438 VSS.t193 DELAY_VBIASN VSS.t182 VSS.t175 sg13_lv_nmos ad=1.33p pd=7.38u as=0 ps=0 w=7u l=7u
X439 VSS.t26 a_7803_1842# a_8237_1842# VSS.t25 sg13_lv_nmos ad=0.1406p pd=1.12u as=0.2516p ps=2.16u w=0.74u l=0.13u
X440 a_13592_5871# a_14111_5878# a_14851_6228# VSS.t19 sg13_lv_nmos ad=0.3473p pd=2.71u as=0.12665p ps=1.145u w=0.74u l=0.13u
X441 a_15304_4605# a_14851_6228# VSS.t23 VSS.t22 sg13_lv_nmos ad=0.2849p pd=2.25u as=0.2516p ps=2.16u w=0.74u l=0.13u
X442 VDD.t304 DELAY_VBIASP a_16271_2470# VDD.t3 sg13_lv_pmos ad=0.3808p pd=2.92u as=0.2128p ps=1.5u w=1.12u l=0.6u
X443 VSS.t88 VDD.t400 VSS.t86 VSS.t87 sg13_lv_nmos ad=79.8f pd=0.8u as=0 ps=0 w=0.42u l=1u
X444 VSS.t66 VDD.t405 VSS.t66 VSS.t67 sg13_lv_nmos ad=0.1428p pd=1.52u as=0 ps=0 w=0.42u l=1u
X445 a_6854_5454# a_6854_5454# a_9444_4590# VSS.t613 sg13_lv_nmos ad=0.38p pd=2.38u as=0.68p ps=4.68u w=2u l=1u
X446 VDD.t4 a_26043_1842# a_26477_1842# VDD.t3 sg13_lv_pmos ad=0.2128p pd=1.5u as=0.3808p ps=2.92u w=1.12u l=0.13u
X447 VDD.t229 DLL_RESETN a_10206_5835# VDD.t7 sg13_lv_pmos ad=0.1563p pd=1.22u as=0.147p ps=1.54u w=0.42u l=0.13u
X448 a_3543_331# MUX_SEL2 a_3449_331# VSS.t357 sg13_lv_nmos ad=0.1216p pd=1.02u as=0.2176p ps=1.96u w=0.64u l=0.13u
X449 a_22488_1044# a_21917_1842# VSS.t31 VSS.t30 sg13_lv_nmos ad=0.1406p pd=1.12u as=0.2516p ps=2.16u w=0.74u l=0.13u
X450 a_14851_5182# a_14009_5084# a_13592_5423# VDD.t7 sg13_lv_pmos ad=0.2048p pd=1.63u as=0.34p ps=2.68u w=1u l=0.13u
X451 VDD.t194 VSS.t55 VDD.t192 VDD.t0 sg13_lv_pmos ad=0.19p pd=1.38u as=0 ps=0 w=1u l=1u
X452 a_22590_1044# a_24084_1008# a_24008_1044# VDD.t0 sg13_lv_pmos ad=0.3808p pd=2.92u as=0.2128p ps=1.5u w=1.12u l=0.13u
X453 VDD.t283 DELAY_VBIASP a_20071_2470# VDD.t3 sg13_lv_pmos ad=0.3808p pd=2.92u as=0.2128p ps=1.5u w=1.12u l=0.6u
X454 a_9444_3912# a_9444_4590# VSS.t233 VSS.t232 sg13_lv_nmos ad=0.38p pd=2.38u as=0.68p ps=4.68u w=2u l=1u
X455 a_14751_1842# a_14513_1842# a_14643_1842# VSS.t415 sg13_lv_nmos ad=0.1406p pd=1.12u as=0.2516p ps=2.16u w=0.74u l=0.2u
X456 VSS.t28 a_2873_1395# a_3171_1047.t1 VSS.t29 sg13_lv_nmos ad=0.2812p pd=2.24u as=0.1406p ps=1.12u w=0.74u l=0.13u
X457 VDD.t127 VSS.t106 VDD.t126 VDD.t0 sg13_lv_pmos ad=0.19p pd=1.38u as=0 ps=0 w=1u l=1u
X458 a_25630_1044# a_27991_1008# a_27915_1044# VDD.t0 sg13_lv_pmos ad=0.3808p pd=2.92u as=0.2128p ps=1.5u w=1.12u l=0.13u
X459 VSS.t332 VSS.t329 VSS.t329 VSS.t330 sg13_lv_nmos ad=0.1406p pd=1.12u as=0 ps=0 w=0.74u l=0.13u
X460 a_4111_1842# REF_CLK a_4003_1842# VSS.t382 sg13_lv_nmos ad=0.1406p pd=1.12u as=0.2516p ps=2.16u w=0.74u l=0.2u
X461 a_8671_2470# a_8433_1842# a_8563_1842# VDD.t3 sg13_lv_pmos ad=0.2128p pd=1.5u as=0.3808p ps=2.92u w=1.12u l=0.2u
X462 a_17553_1842# a_17357_1842# VDD.t141 VDD.t3 sg13_lv_pmos ad=0.3808p pd=2.92u as=0.2128p ps=1.5u w=1.12u l=0.13u
X463 VSS.t296 a_1544_1044# a_2391_1395# VSS.t371 sg13_lv_nmos ad=0.1331p pd=1.12u as=0.1216p ps=1.02u w=0.64u l=0.13u
X464 VSS.t77 a_3747_311.t3 a_14825_519# VSS.t292 sg13_lv_nmos ad=0.2516p pd=2.16u as=0.2516p ps=2.16u w=0.74u l=0.13u
X465 VSS.t398 a_1256_289# a_2967_331# VSS.t616 sg13_lv_nmos ad=0.1331p pd=1.12u as=0.1216p ps=1.02u w=0.64u l=0.13u
X466 a_2019_1047.t1 a_1721_1395# VSS.t296 VSS.t590 sg13_lv_nmos ad=0.1406p pd=1.12u as=0.1331p ps=1.12u w=0.74u l=0.13u
X467 a_15964_289# a_15765_463# a_5731_289# VSS.t24 sg13_lv_nmos ad=0.2183p pd=1.33u as=0.2516p ps=2.16u w=0.74u l=0.13u
X468 a_13470_1044# a_2019_1047.t6 a_13368_1044# VSS.t431 sg13_lv_nmos ad=0.2516p pd=2.16u as=0.1406p ps=1.12u w=0.74u l=0.13u
X469 VDD.t31 VDD.t29 VDD.t30 VDD.t7 sg13_lv_pmos ad=0.68p pd=4.68u as=0 ps=0 w=2u l=1u
X470 VSS.t18 a_13123_1842# a_13557_1842# VSS.t17 sg13_lv_nmos ad=0.1406p pd=1.12u as=0.2516p ps=2.16u w=0.74u l=0.13u
X471 VDD.t79 VSS.t108 VDD.t78 VDD.t0 sg13_lv_pmos ad=0.34p pd=2.68u as=0 ps=0 w=1u l=1u
X472 VSS.t477 a_3171_1047.t3 a_24084_1008# VSS.t476 sg13_lv_nmos ad=0.2516p pd=2.16u as=0.2516p ps=2.16u w=0.74u l=0.13u
X473 a_25913_1842# a_25717_1842# VSS.t223 VSS.t501 sg13_lv_nmos ad=0.2516p pd=2.16u as=0.1406p ps=1.12u w=0.74u l=0.13u
X474 VDD.t8 a_10649_5878# a_10751_5878# VDD.t7 sg13_lv_pmos ad=1.10612p pd=6.66u as=0.3864p ps=2.93u w=1.12u l=0.13u
X475 a_21353_1842# a_21157_1842# VDD.t121 VDD.t3 sg13_lv_pmos ad=0.3808p pd=2.92u as=0.2128p ps=1.5u w=1.12u l=0.13u
X476 VSS.t93 VDD.t398 VSS.t92 VSS.t91 sg13_lv_nmos ad=0.1428p pd=1.52u as=0 ps=0 w=0.42u l=1u
X477 a_2297_331# MUX_SEL2 VDD.t146 VDD.t0 sg13_lv_pmos ad=0.1596p pd=1.22u as=0.2856p ps=2.36u w=0.84u l=0.13u
X478 VDD.t187 a_7043_1842# a_7477_1842# VDD.t3 sg13_lv_pmos ad=0.2128p pd=1.5u as=0.3808p ps=2.92u w=1.12u l=0.13u
X479 a_2873_331# MUX_SEL3 VDD.t170 VDD.t0 sg13_lv_pmos ad=0.1596p pd=1.22u as=0.2856p ps=2.36u w=0.84u l=0.13u
X480 a_10589_5914# a_10232_5871# VDD.t229 VDD.t7 sg13_lv_pmos ad=63f pd=0.72u as=0.1563p ps=1.22u w=0.42u l=0.13u
X481 a_8155_1044# a_7945_1044# VDD.t188 VDD.t0 sg13_lv_pmos ad=0.2128p pd=1.5u as=0.252p ps=1.57u w=1.12u l=0.13u
X482 a_13880_6292# a_13592_5871# a_13818_6292# VSS.t40 sg13_lv_nmos ad=0.1428p pd=1.52u as=37.8f ps=0.6u w=0.42u l=0.13u
X483 VSS.t246 a_18117_1842# a_18585_1044# VSS.t293 sg13_lv_nmos ad=0.1665p pd=1.19u as=0.2516p ps=2.16u w=0.74u l=0.13u
X484 a_27048_1044# a_26477_1842# VDD.t257 VDD.t0 sg13_lv_pmos ad=0.2128p pd=1.5u as=0.3808p ps=2.92u w=1.12u l=0.13u
X485 a_5768_1044# a_5197_1842# VDD.t390 VDD.t0 sg13_lv_pmos ad=0.2128p pd=1.5u as=0.3808p ps=2.92u w=1.12u l=0.13u
X486 a_10232_5871# a_10751_5878# a_11491_6228# VSS.t401 sg13_lv_nmos ad=0.3473p pd=2.71u as=0.12665p ps=1.145u w=0.74u l=0.13u
X487 a_12656_5864# DLL_RESETN VDD.t272 VDD.t7 sg13_lv_pmos ad=0.3808p pd=2.92u as=0.3808p ps=2.92u w=1.12u l=0.13u
X488 a_13991_2470# a_13753_1842# a_13883_1842# VDD.t3 sg13_lv_pmos ad=0.2128p pd=1.5u as=0.3808p ps=2.92u w=1.12u l=0.2u
X489 VSS.t555 a_3171_1047.t6 a_14964_1008# VSS.t554 sg13_lv_nmos ad=0.2516p pd=2.16u as=0.2516p ps=2.16u w=0.74u l=0.13u
X490 VDD.t369 a_2019_311# a_17865_519# VDD.t0 sg13_lv_pmos ad=0.3808p pd=2.92u as=0.3808p ps=2.92u w=1.12u l=0.13u
X491 DELAY_OUT_LAST a_27997_1842# VSS.t122 VSS.t456 sg13_lv_nmos ad=0.2516p pd=2.16u as=0.1406p ps=1.12u w=0.74u l=0.13u
X492 a_11195_1044# a_10985_1044# VSS.t134 VSS.t492 sg13_lv_nmos ad=0.1406p pd=1.12u as=0.1665p ps=1.19u w=0.74u l=0.13u
X493 VDD.t144 a_24197_1842# a_24665_1044# VDD.t0 sg13_lv_pmos ad=0.252p pd=1.57u as=0.3808p ps=2.92u w=1.12u l=0.13u
X494 a_6913_1842# a_6717_1842# VSS.t199 VSS.t603 sg13_lv_nmos ad=0.2516p pd=2.16u as=0.1406p ps=1.12u w=0.74u l=0.13u
X495 VSS.t215 DELAY_VBIASN a_18551_1842# VSS.t214 sg13_lv_nmos ad=0.2516p pd=2.16u as=0.1406p ps=1.12u w=0.74u l=0.6u
X496 a_16510_1044# a_18004_1008# a_17928_1044# VDD.t0 sg13_lv_pmos ad=0.3808p pd=2.92u as=0.2128p ps=1.5u w=1.12u l=0.13u
X497 a_13592_5423# a_13566_5328# VSS.t261 VSS.t260 sg13_lv_nmos ad=0.2516p pd=2.16u as=0.1626p ps=1.415u w=0.74u l=0.13u
X498 VDD.t264 a_12363_1842# a_12797_1842# VDD.t3 sg13_lv_pmos ad=0.2128p pd=1.5u as=0.3808p ps=2.92u w=1.12u l=0.13u
X499 VSS.t389 MUX_SEL3 a_3543_331# VSS.t388 sg13_lv_nmos ad=0.1331p pd=1.12u as=0.1216p ps=1.02u w=0.64u l=0.13u
X500 a_22590_1044# a_2595_1047.t3 a_23355_1044# VSS.t428 sg13_lv_nmos ad=0.2516p pd=2.16u as=0.1406p ps=1.12u w=0.74u l=0.13u
X501 a_9712_3912# a_6854_5454# a_9444_3912# VSS.t613 sg13_lv_nmos ad=0.38p pd=2.38u as=0.68p ps=4.68u w=2u l=1u
X502 VSS.t152 DELAY_VBIASN a_22351_1842# VSS.t151 sg13_lv_nmos ad=0.2516p pd=2.16u as=0.1406p ps=1.12u w=0.74u l=0.6u
X503 VDD.t362 a_3171_1047.t4 a_21044_1008# VDD.t0 sg13_lv_pmos ad=0.3808p pd=2.92u as=0.3808p ps=2.92u w=1.12u l=0.13u
X504 VDD.t183 VSS.t99 VDD.t181 VDD.t0 sg13_lv_pmos ad=0.19p pd=1.38u as=0 ps=0 w=1u l=1u
X505 a_16271_2470# a_16033_1842# a_16163_1842# VDD.t3 sg13_lv_pmos ad=0.2128p pd=1.5u as=0.3808p ps=2.92u w=1.12u l=0.2u
X506 VDD.t232 VSS.t77 VDD.t2 VDD.t0 sg13_lv_pmos ad=0.19p pd=1.38u as=0 ps=0 w=1u l=1u
X507 a_19833_1842# a_19637_1842# VSS.t219 VSS.t548 sg13_lv_nmos ad=0.2516p pd=2.16u as=0.1406p ps=1.12u w=0.74u l=0.13u
X508 VDD.t368 a_2019_311# a_5705_519# VDD.t0 sg13_lv_pmos ad=0.3808p pd=2.92u as=0.3808p ps=2.92u w=1.12u l=0.13u
X509 VDD.t16 a_14851_6228# a_15108_6109# VDD.t7 sg13_lv_pmos ad=0.2639p pd=1.81u as=79.8f ps=0.8u w=0.42u l=0.13u
X510 a_10520_6292# a_10232_5871# a_10458_6292# VSS.t473 sg13_lv_nmos ad=0.1428p pd=1.52u as=37.8f ps=0.6u w=0.42u l=0.13u
X511 a_15270_6305# a_12849_5867# VSS.t365 VSS.t19 sg13_lv_nmos ad=37.8f pd=0.6u as=79.8f ps=0.8u w=0.42u l=0.13u
X512 a_20071_2470# a_19833_1842# a_19963_1842# VDD.t3 sg13_lv_pmos ad=0.2128p pd=1.5u as=0.3808p ps=2.92u w=1.12u l=0.2u
X513 a_9193_1842# a_8997_1842# VSS.t142 VSS.t620 sg13_lv_nmos ad=0.2516p pd=2.16u as=0.1406p ps=1.12u w=0.74u l=0.13u
X514 a_24631_1842# a_24393_1842# a_24523_1842# VSS.t369 sg13_lv_nmos ad=0.1406p pd=1.12u as=0.2516p ps=2.16u w=0.74u l=0.2u
X515 VDD.t234 VSS.t77 VDD.t233 VDD.t0 sg13_lv_pmos ad=0.34p pd=2.68u as=0 ps=0 w=1u l=1u
X516 VSS.t449 a_2019_1047.t7 a_10404_1008# VSS.t448 sg13_lv_nmos ad=0.2516p pd=2.16u as=0.2516p ps=2.16u w=0.74u l=0.13u
X517 VSS.t172 DELAY_VBIASN VSS.t174 VSS.t173 sg13_lv_nmos ad=1.33p pd=7.38u as=0 ps=0 w=7u l=7u
X518 VDD.t217 a_14643_1842# a_15077_1842# VDD.t3 sg13_lv_pmos ad=0.2128p pd=1.5u as=0.3808p ps=2.92u w=1.12u l=0.13u
X519 VDD.t176 a_1544_289# a_2297_331# VDD.t0 sg13_lv_pmos ad=0.1918p pd=1.5u as=0.1596p ps=1.22u w=0.84u l=0.13u
X520 a_23633_1842# a_23437_1842# VSS.t144 VSS.t487 sg13_lv_nmos ad=0.2516p pd=2.16u as=0.1406p ps=1.12u w=0.74u l=0.13u
X521 VSS.t88 VDD.t399 VSS.t88 VSS.t89 sg13_lv_nmos ad=0.1428p pd=1.52u as=0 ps=0 w=0.42u l=1u
X522 a_2019_311# a_1721_331# VDD.t175 VDD.t0 sg13_lv_pmos ad=0.2128p pd=1.5u as=0.1918p ps=1.5u w=1.12u l=0.13u
X523 VSS.t43 a_9323_1842# a_9757_1842# VSS.t592 sg13_lv_nmos ad=0.1406p pd=1.12u as=0.2516p ps=2.16u w=0.74u l=0.13u
X524 a_26395_1044# a_26185_1044# VSS.t251 VSS.t250 sg13_lv_nmos ad=0.1406p pd=1.12u as=0.1665p ps=1.19u w=0.74u l=0.13u
X525 VDD.t303 DELAY_VBIASP a_17791_2470# VDD.t3 sg13_lv_pmos ad=0.3808p pd=2.92u as=0.2128p ps=1.5u w=1.12u l=0.6u
X526 VSS.t4 a_3747_1047.t3 a_24951_1008# VSS.t3 sg13_lv_nmos ad=0.2516p pd=2.16u as=0.2516p ps=2.16u w=0.74u l=0.13u
X527 VSS.t64 VDD.t406 VSS.t64 VSS.t63 sg13_lv_nmos ad=0.1428p pd=1.52u as=0 ps=0 w=0.42u l=1u
X528 VSS.t86 VDD.t400 VSS.t86 VSS.t85 sg13_lv_nmos ad=0.1428p pd=1.52u as=0 ps=0 w=0.42u l=1u
X529 a_3747_1047.t0 a_3449_1395# VDD.t325 VDD.t0 sg13_lv_pmos ad=0.2128p pd=1.5u as=0.1918p ps=1.5u w=1.12u l=0.13u
X530 a_13368_1044# a_12797_1842# VDD.t265 VDD.t0 sg13_lv_pmos ad=0.2128p pd=1.5u as=0.3808p ps=2.92u w=1.12u l=0.13u
X531 a_24008_1044# a_23437_1842# VSS.t430 VSS.t488 sg13_lv_nmos ad=0.1406p pd=1.12u as=0.2516p ps=2.16u w=0.74u l=0.13u
X532 VDD.t306 DELAY_VBIASP a_21591_2470# VDD.t3 sg13_lv_pmos ad=0.3808p pd=2.92u as=0.2128p ps=1.5u w=1.12u l=0.6u
X533 a_15964_289# MUX_SEL4 a_5731_289# VDD.t0 sg13_lv_pmos ad=0.3304p pd=1.71u as=0.3808p ps=2.92u w=1.12u l=0.13u
X534 a_4350_1044# a_6711_1008# a_6635_1044# VDD.t0 sg13_lv_pmos ad=0.3808p pd=2.92u as=0.2128p ps=1.5u w=1.12u l=0.13u
X535 a_2873_1395# MUX_SEL1 VDD.t323 VDD.t0 sg13_lv_pmos ad=0.1596p pd=1.22u as=0.2856p ps=2.36u w=0.84u l=0.13u
X536 VSS.t261 a_12849_5867# a_13400_5105# VSS.t364 sg13_lv_nmos ad=0.1626p pd=1.415u as=60.89999f ps=0.71u w=0.42u l=0.13u
X537 a_1256_1044# MUX_SEL0 VSS.t296 VSS.t532 sg13_lv_nmos ad=0.2516p pd=2.16u as=0.2516p ps=2.16u w=0.74u l=0.13u
X538 VSS.t62 VDD.t407 VSS.t60 VSS.t61 sg13_lv_nmos ad=79.8f pd=0.8u as=0 ps=0 w=0.42u l=1u
X539 a_19550_1044# a_20391_1008# a_20315_1044# VDD.t0 sg13_lv_pmos ad=0.3808p pd=2.92u as=0.2128p ps=1.5u w=1.12u l=0.13u
X540 VDD.t62 VDD.t60 VDD.t59 VDD.t3 sg13_lv_pmos ad=0.2128p pd=1.5u as=0 ps=0 w=1.12u l=0.2u
X541 a_5631_1842# a_5393_1842# a_5523_1842# VSS.t472 sg13_lv_nmos ad=0.1406p pd=1.12u as=0.2516p ps=2.16u w=0.74u l=0.2u
X542 a_14513_1842# a_14317_1842# VSS.t209 VSS.t607 sg13_lv_nmos ad=0.2516p pd=2.16u as=0.1406p ps=1.12u w=0.74u l=0.13u
X543 VSS.t92 a_2595_311.t2 a_20905_519# VSS.t124 sg13_lv_nmos ad=0.2516p pd=2.16u as=0.2516p ps=2.16u w=0.74u l=0.13u
X544 VDD.t188 a_7477_1842# a_7945_1044# VDD.t0 sg13_lv_pmos ad=0.252p pd=1.57u as=0.3808p ps=2.92u w=1.12u l=0.13u
X545 a_13470_1044# a_3171_1047.t6 a_14888_1044# VSS.t553 sg13_lv_nmos ad=0.2516p pd=2.16u as=0.1406p ps=1.12u w=0.74u l=0.13u
X546 a_4633_1842# a_4437_1842# VSS.t159 VSS.t390 sg13_lv_nmos ad=0.2516p pd=2.16u as=0.1406p ps=1.12u w=0.74u l=0.13u
X547 a_1256_289# MUX_SEL2 VSS.t355 VSS.t354 sg13_lv_nmos ad=0.2516p pd=2.16u as=0.2516p ps=2.16u w=0.74u l=0.13u
X548 VSS.t15 a_2019_1047.t2 a_25604_1008# VSS.t14 sg13_lv_nmos ad=0.2516p pd=2.16u as=0.2516p ps=2.16u w=0.74u l=0.13u
X549 a_13019_5831# a_15688_5403# VDD.t65 VDD.t7 sg13_lv_pmos ad=0.3808p pd=2.92u as=0.2128p ps=1.5u w=1.12u l=0.13u
X550 VSS.t168 DELAY_VBIASN VSS.t170 VSS.t169 sg13_lv_nmos ad=1.33p pd=7.38u as=0 ps=0 w=7u l=7u
X551 a_16108_289# MUX_SEL4 a_15964_289# VSS.t466 sg13_lv_nmos ad=0.2516p pd=2.16u as=0.2183p ps=1.33u w=0.74u l=0.13u
X552 a_13400_6305# a_12355_5867# a_13306_6305# VSS.t269 sg13_lv_nmos ad=60.89999f pd=0.71u as=0.1428p ps=1.52u w=0.42u l=0.13u
X553 a_22873_1842# a_22677_1842# VDD.t119 VDD.t3 sg13_lv_pmos ad=0.3808p pd=2.92u as=0.2128p ps=1.5u w=1.12u l=0.13u
X554 a_21835_1044# a_21625_1044# VSS.t290 VSS.t491 sg13_lv_nmos ad=0.1406p pd=1.12u as=0.1665p ps=1.19u w=0.74u l=0.13u
X555 VSS.t424 a_2595_1047.t4 a_20391_1008# VSS.t423 sg13_lv_nmos ad=0.2516p pd=2.16u as=0.2516p ps=2.16u w=0.74u l=0.13u
X556 a_9675_1044# a_9465_1044# VDD.t25 VDD.t0 sg13_lv_pmos ad=0.2128p pd=1.5u as=0.252p ps=1.57u w=1.12u l=0.13u
X557 VSS.t134 a_10517_1842# a_10985_1044# VSS.t133 sg13_lv_nmos ad=0.1665p pd=1.19u as=0.2516p ps=2.16u w=0.74u l=0.13u
X558 VDD.t88 a_2595_1047.t8 a_8231_1008# VDD.t0 sg13_lv_pmos ad=0.3808p pd=2.92u as=0.3808p ps=2.92u w=1.12u l=0.13u
X559 a_18551_1842# a_18313_1842# a_18443_1842# VSS.t583 sg13_lv_nmos ad=0.1406p pd=1.12u as=0.2516p ps=2.16u w=0.74u l=0.2u
X560 a_12943_5867# a_12656_5864# a_12849_5867# VDD.t7 sg13_lv_pmos ad=0.2128p pd=1.5u as=0.3808p ps=2.92u w=1.12u l=0.13u
X561 a_13566_5835# a_14009_5878# a_13949_5914# VDD.t7 sg13_lv_pmos ad=79.8f pd=0.8u as=63f ps=0.72u w=0.42u l=0.13u
X562 a_22351_1842# a_22113_1842# a_22243_1842# VSS.t605 sg13_lv_nmos ad=0.1406p pd=1.12u as=0.2516p ps=2.16u w=0.74u l=0.2u
X563 VSS.t272 a_3747_1047.t5 a_18871_1008# VSS.t403 sg13_lv_nmos ad=0.2516p pd=2.16u as=0.2516p ps=2.16u w=0.74u l=0.13u
X564 VSS.t212 a_16923_1842# a_17357_1842# VSS.t471 sg13_lv_nmos ad=0.1406p pd=1.12u as=0.2516p ps=2.16u w=0.74u l=0.13u
X565 VDD.t338 a_3171_311.t2 a_23945_519# VDD.t0 sg13_lv_pmos ad=0.3808p pd=2.92u as=0.3808p ps=2.92u w=1.12u l=0.13u
X566 a_2019_311# a_1721_331# VSS.t398 VSS.t407 sg13_lv_nmos ad=0.1406p pd=1.12u as=0.1331p ps=1.12u w=0.74u l=0.13u
X567 a_25153_1842# a_24957_1842# VDD.t120 VDD.t3 sg13_lv_pmos ad=0.3808p pd=2.92u as=0.2128p ps=1.5u w=1.12u l=0.13u
X568 a_17928_1044# a_17357_1842# VSS.t230 VSS.t350 sg13_lv_nmos ad=0.1406p pd=1.12u as=0.2516p ps=2.16u w=0.74u l=0.13u
X569 a_12715_1044# a_12505_1044# VSS.t267 VSS.t358 sg13_lv_nmos ad=0.1406p pd=1.12u as=0.1665p ps=1.19u w=0.74u l=0.13u
X570 a_13880_6292# a_14111_5878# a_13566_5835# VSS.t470 sg13_lv_nmos ad=0.2373p pd=1.97u as=79.8f ps=0.8u w=0.42u l=0.13u
X571 a_15053_5990# a_14111_5878# a_14851_6228# VDD.t7 sg13_lv_pmos ad=93.45f pd=0.865u as=0.2048p ps=1.63u w=0.42u l=0.13u
X572 VDD.t224 MUX_SEL4 a_15765_463# VDD.t0 sg13_lv_pmos ad=0.3808p pd=2.92u as=0.3808p ps=2.92u w=1.12u l=0.13u
X573 a_19550_1044# a_3171_1047.t4 a_20968_1044# VSS.t585 sg13_lv_nmos ad=0.2516p pd=2.16u as=0.1406p ps=1.12u w=0.74u l=0.13u
X574 VSS.t202 DELAY_VBIASN a_10951_1842# VSS.t201 sg13_lv_nmos ad=0.2516p pd=2.16u as=0.1406p ps=1.12u w=0.74u l=0.6u
X575 a_19550_1044# a_19524_1008# a_19448_1044# VDD.t0 sg13_lv_pmos ad=0.3808p pd=2.92u as=0.2128p ps=1.5u w=1.12u l=0.13u
X576 a_7288_1044# a_6717_1842# VSS.t599 VSS.t604 sg13_lv_nmos ad=0.1406p pd=1.12u as=0.2516p ps=2.16u w=0.74u l=0.13u
X577 a_12355_5867# a_12158_5867# VSS.t248 VSS.t564 sg13_lv_nmos ad=0.2516p pd=2.16u as=0.1406p ps=1.12u w=0.74u l=0.13u
X578 VSS.t217 a_20723_1842# a_21157_1842# VSS.t579 sg13_lv_nmos ad=0.1406p pd=1.12u as=0.2516p ps=2.16u w=0.74u l=0.13u
X579 VDD.t18 a_14851_6228# a_15688_5867# VDD.t7 sg13_lv_pmos ad=0.2128p pd=1.5u as=0.3864p ps=2.93u w=1.12u l=0.13u
X580 a_1544_289# MUX_SEL3 VSS.t355 VSS.t386 sg13_lv_nmos ad=0.2516p pd=2.16u as=0.2516p ps=2.16u w=0.74u l=0.13u
X581 a_13470_1044# a_14311_1008# a_14235_1044# VDD.t0 sg13_lv_pmos ad=0.3808p pd=2.92u as=0.2128p ps=1.5u w=1.12u l=0.13u
X582 a_22590_1044# a_3747_1047.t3 a_24875_1044# VSS.t2 sg13_lv_nmos ad=0.2516p pd=2.16u as=0.1406p ps=1.12u w=0.74u l=0.13u
X583 VSS.t155 DELAY_VBIASN a_23871_1842# VSS.t154 sg13_lv_nmos ad=0.2516p pd=2.16u as=0.1406p ps=1.12u w=0.74u l=0.6u
X584 VDD.t202 a_2019_1047.t3 a_22564_1008# VDD.t0 sg13_lv_pmos ad=0.3808p pd=2.92u as=0.3808p ps=2.92u w=1.12u l=0.13u
X585 VSS.t251 a_25717_1842# a_26185_1044# VSS.t500 sg13_lv_nmos ad=0.1665p pd=1.19u as=0.2516p ps=2.16u w=0.74u l=0.13u
X586 a_13231_1842# a_12993_1842# a_13123_1842# VSS.t265 sg13_lv_nmos ad=0.1406p pd=1.12u as=0.2516p ps=2.16u w=0.74u l=0.2u
X587 VSS.t55 VDD.t408 VSS.t55 VSS.t57 sg13_lv_nmos ad=79.8f pd=0.8u as=0 ps=0 w=0.42u l=1u
X588 a_17791_2470# a_17553_1842# a_17683_1842# VDD.t3 sg13_lv_pmos ad=0.2128p pd=1.5u as=0.3808p ps=2.92u w=1.12u l=0.2u
X589 VSS.t392 a_4437_1842# a_4905_1044# VSS.t391 sg13_lv_nmos ad=0.1665p pd=1.19u as=0.2516p ps=2.16u w=0.74u l=0.13u
X590 VDD.t181 VSS.t99 VDD.t180 VDD.t0 sg13_lv_pmos ad=0.34p pd=2.68u as=0 ps=0 w=1u l=1u
X591 a_12233_1842# a_12037_1842# VSS.t204 VSS.t268 sg13_lv_nmos ad=0.2516p pd=2.16u as=0.1406p ps=1.12u w=0.74u l=0.13u
X592 VDD.t8 a_9547_6172# a_9547_5942# VDD.t7 sg13_lv_pmos ad=1.10612p pd=6.66u as=0.2442p ps=2.06u w=0.66u l=0.13u
X593 a_15108_5325# a_14851_5182# a_15270_5105# VSS.t114 sg13_lv_nmos ad=0.1428p pd=1.52u as=37.8f ps=0.6u w=0.42u l=0.13u
X594 VSS.t560 a_3449_1395# a_3747_1047.t1 VSS.t559 sg13_lv_nmos ad=0.2812p pd=2.24u as=0.1406p ps=1.12u w=0.74u l=0.13u
X595 VDD.t2 VSS.t75 VDD.t1 VDD.t0 sg13_lv_pmos ad=0.34p pd=2.68u as=0 ps=0 w=1u l=1u
X596 VDD.t212 VSS.t84 VDD.t205 VDD.t0 sg13_lv_pmos ad=0.19p pd=1.38u as=0 ps=0 w=1u l=1u
X597 VSS.t106 VDD.t395 VSS.t104 VSS.t105 sg13_lv_nmos ad=79.8f pd=0.8u as=0 ps=0 w=0.42u l=1u
X598 VSS.t421 a_3171_1047.t8 a_8884_1008# VSS.t420 sg13_lv_nmos ad=0.2516p pd=2.16u as=0.2516p ps=2.16u w=0.74u l=0.13u
X599 a_21591_2470# a_21353_1842# a_21483_1842# VDD.t3 sg13_lv_pmos ad=0.2128p pd=1.5u as=0.3808p ps=2.92u w=1.12u l=0.2u
X600 VDD.t21 a_2873_1395# a_3171_1047.t0 VDD.t0 sg13_lv_pmos ad=0.4256p pd=3u as=0.2128p ps=1.5u w=1.12u l=0.13u
X601 a_6153_1842# a_5957_1842# VDD.t67 VDD.t3 sg13_lv_pmos ad=0.3808p pd=2.92u as=0.2128p ps=1.5u w=1.12u l=0.13u
X602 VDD.t134 a_16163_1842# a_16597_1842# VDD.t3 sg13_lv_pmos ad=0.2128p pd=1.5u as=0.3808p ps=2.92u w=1.12u l=0.13u
X603 a_3543_1395# MUX_SEL0 a_3449_1395# VSS.t534 sg13_lv_nmos ad=0.1216p pd=1.02u as=0.2176p ps=1.96u w=0.64u l=0.13u
X604 VDD.t130 a_1544_1044# a_2297_1395# VDD.t0 sg13_lv_pmos ad=0.1918p pd=1.5u as=0.1596p ps=1.22u w=0.84u l=0.13u
X605 VDD.t300 DELAY_VBIASP a_10191_2470# VDD.t3 sg13_lv_pmos ad=0.3808p pd=2.92u as=0.2128p ps=1.5u w=1.12u l=0.6u
X606 a_17275_1044# a_17065_1044# VDD.t133 VDD.t0 sg13_lv_pmos ad=0.2128p pd=1.5u as=0.252p ps=1.57u w=1.12u l=0.13u
X607 a_2019_1047.t0 a_1721_1395# VDD.t160 VDD.t0 sg13_lv_pmos ad=0.2128p pd=1.5u as=0.1918p ps=1.5u w=1.12u l=0.13u
X608 a_27915_1044# a_27705_1044# VSS.t10 VSS.t551 sg13_lv_nmos ad=0.1406p pd=1.12u as=0.1665p ps=1.19u w=0.74u l=0.13u
X609 VSS.t1 DELAY_VBIASN a_26151_1842# VSS.t153 sg13_lv_nmos ad=0.2516p pd=2.16u as=0.1406p ps=1.12u w=0.74u l=0.6u
X610 VDD.t73 a_3747_1047.t6 a_15831_1008# VDD.t0 sg13_lv_pmos ad=0.3808p pd=2.92u as=0.3808p ps=2.92u w=1.12u l=0.13u
X611 VDD.t256 a_19963_1842# a_20397_1842# VDD.t3 sg13_lv_pmos ad=0.2128p pd=1.5u as=0.3808p ps=2.92u w=1.12u l=0.13u
X612 VSS.t108 VDD.t394 VSS.t108 VSS.t107 sg13_lv_nmos ad=0.1428p pd=1.52u as=0 ps=0 w=0.42u l=1u
X613 VSS.t197 DELAY_VBIASN a_4871_1842# VSS.t196 sg13_lv_nmos ad=0.2516p pd=2.16u as=0.1406p ps=1.12u w=0.74u l=0.6u
X614 a_14888_1044# a_14317_1842# VDD.t383 VDD.t0 sg13_lv_pmos ad=0.2128p pd=1.5u as=0.3808p ps=2.92u w=1.12u l=0.13u
X615 a_4350_1044# a_4324_1008# a_4248_1044# VDD.t0 sg13_lv_pmos ad=0.3808p pd=2.92u as=0.2128p ps=1.5u w=1.12u l=0.13u
X616 a_1256_289# MUX_SEL2 VDD.t145 VDD.t0 sg13_lv_pmos ad=0.3808p pd=2.92u as=0.3808p ps=2.92u w=1.12u l=0.13u
X617 VSS.t336 VSS.t333 VSS.t335 VSS.t334 sg13_lv_nmos ad=0.2516p pd=2.16u as=0 ps=0 w=0.74u l=0.6u
X618 a_16108_289# a_15765_463# a_15964_289# VDD.t0 sg13_lv_pmos ad=0.3808p pd=2.92u as=0.3304p ps=1.71u w=1.12u l=0.13u
X619 VDD.t26 a_12849_5867# a_13566_5835# VDD.t7 sg13_lv_pmos ad=0.1563p pd=1.22u as=0.147p ps=1.54u w=0.42u l=0.13u
X620 VSS.t164 DELAY_VBIASN VSS.t163 VSS.t162 sg13_lv_nmos ad=2.38p pd=14.68u as=0 ps=0 w=7u l=7u
X621 a_11473_1842# a_11277_1842# VDD.t167 VDD.t3 sg13_lv_pmos ad=0.3808p pd=2.92u as=0.2128p ps=1.5u w=1.12u l=0.13u
X622 VDD.t25 a_8997_1842# a_9465_1044# VDD.t0 sg13_lv_pmos ad=0.252p pd=1.57u as=0.3808p ps=2.92u w=1.12u l=0.13u
X623 a_27433_1842# a_27237_1842# VSS.t12 VSS.t11 sg13_lv_nmos ad=0.2516p pd=2.16u as=0.1406p ps=1.12u w=0.74u l=0.13u
X624 a_2391_331# MUX_SEL2 a_2297_331# VSS.t356 sg13_lv_nmos ad=0.1216p pd=1.02u as=0.2176p ps=1.96u w=0.64u l=0.13u
X625 a_2967_331# MUX_SEL3 a_2873_331# VSS.t387 sg13_lv_nmos ad=0.1216p pd=1.02u as=0.2176p ps=1.96u w=0.64u l=0.13u
X626 VDD.t184 a_2019_1047.t5 a_16484_1008# VDD.t0 sg13_lv_pmos ad=0.3808p pd=2.92u as=0.3808p ps=2.92u w=1.12u l=0.13u
X627 a_7390_1044# a_2595_1047.t8 a_8155_1044# VSS.t254 sg13_lv_nmos ad=0.2516p pd=2.16u as=0.1406p ps=1.12u w=0.74u l=0.13u
X628 VSS.t574 a_6126_3816# a_5974_5723# VSS.t570 sg13_lv_nmos ad=0.68p pd=4.68u as=0.38p ps=2.38u w=2u l=1u
X629 VSS.t140 DELAY_VBIASN a_7151_1842# VSS.t139 sg13_lv_nmos ad=0.2516p pd=2.16u as=0.1406p ps=1.12u w=0.74u l=0.6u
X630 VDD.t199 a_3171_1047.t9 a_5844_1008# VDD.t0 sg13_lv_pmos ad=0.3808p pd=2.92u as=0.3808p ps=2.92u w=1.12u l=0.13u
X631 VDD.t296 DELAY_VBIASP a_25391_2470# VDD.t3 sg13_lv_pmos ad=0.3808p pd=2.92u as=0.2128p ps=1.5u w=1.12u l=0.6u
X632 VDD.t89 a_2595_1047.t7 a_11271_1008# VDD.t0 sg13_lv_pmos ad=0.3808p pd=2.92u as=0.3808p ps=2.92u w=1.12u l=0.13u
X633 VDD.t355 VSS.t66 VDD.t353 VDD.t0 sg13_lv_pmos ad=0.19p pd=1.38u as=0 ps=0 w=1u l=1u
X634 VSS.t267 a_12037_1842# a_12505_1044# VSS.t266 sg13_lv_nmos ad=0.1665p pd=1.19u as=0.2516p ps=2.16u w=0.74u l=0.13u
X635 VDD.t207 a_3747_1047.t8 a_9751_1008# VDD.t0 sg13_lv_pmos ad=0.3808p pd=2.92u as=0.3808p ps=2.92u w=1.12u l=0.13u
X636 a_12943_5867# a_13121_5831# VDD.t137 VDD.t7 sg13_lv_pmos ad=0.3808p pd=2.92u as=0.2128p ps=1.5u w=1.12u l=0.13u
X637 a_11748_6109# a_11491_6228# a_11910_6305# VSS.t401 sg13_lv_nmos ad=0.1428p pd=1.52u as=37.8f ps=0.6u w=0.42u l=0.13u
X638 a_9431_1842# a_9193_1842# a_9323_1842# VSS.t263 sg13_lv_nmos ad=0.1406p pd=1.12u as=0.2516p ps=2.16u w=0.74u l=0.2u
X639 a_18313_1842# a_18117_1842# VSS.t221 VSS.t294 sg13_lv_nmos ad=0.2516p pd=2.16u as=0.1406p ps=1.12u w=0.74u l=0.13u
X640 MUX_OUT a_16851_309# VSS.t136 VSS.t135 sg13_lv_nmos ad=0.1406p pd=1.12u as=0.1371p ps=1.12u w=0.74u l=0.13u
X641 a_10232_5871# a_10206_5835# VDD.t220 VDD.t7 sg13_lv_pmos ad=0.34p pd=2.68u as=0.36237p ps=2.605u w=1u l=0.13u
X642 a_14851_5182# a_14009_5084# a_14757_5182# VSS.t498 sg13_lv_nmos ad=0.12665p pd=1.145u as=0.1428p ps=1.52u w=0.42u l=0.13u
X643 VSS.t99 VDD.t396 VSS.t99 VSS.t101 sg13_lv_nmos ad=79.8f pd=0.8u as=0 ps=0 w=0.42u l=1u
X644 a_23871_1842# a_23633_1842# a_23763_1842# VSS.t375 sg13_lv_nmos ad=0.1406p pd=1.12u as=0.2516p ps=2.16u w=0.74u l=0.2u
X645 a_8433_1842# a_8237_1842# VSS.t26 VSS.t562 sg13_lv_nmos ad=0.2516p pd=2.16u as=0.1406p ps=1.12u w=0.74u l=0.13u
X646 VSS.t215 a_18443_1842# a_18877_1842# VSS.t544 sg13_lv_nmos ad=0.1406p pd=1.12u as=0.2516p ps=2.16u w=0.74u l=0.13u
X647 VSS.t77 VDD.t403 VSS.t75 VSS.t76 sg13_lv_nmos ad=79.8f pd=0.8u as=0 ps=0 w=0.42u l=1u
X648 VSS.t572 a_6126_3816# a_5974_5723# VSS.t570 sg13_lv_nmos ad=0.68p pd=4.68u as=0.38p ps=2.38u w=2u l=1u
X649 a_22113_1842# a_21917_1842# VSS.t33 VSS.t32 sg13_lv_nmos ad=0.2516p pd=2.16u as=0.1406p ps=1.12u w=0.74u l=0.13u
X650 a_1544_289# MUX_SEL3 VDD.t169 VDD.t0 sg13_lv_pmos ad=0.3808p pd=2.92u as=0.3808p ps=2.92u w=1.12u l=0.13u
X651 VDD.t40 VDD.t32 VDD.t39 VDD.t7 sg13_lv_pmos ad=0.38p pd=2.38u as=0 ps=0 w=2u l=1u
X652 a_26673_1842# a_26477_1842# VDD.t4 VDD.t3 sg13_lv_pmos ad=0.3808p pd=2.92u as=0.2128p ps=1.5u w=1.12u l=0.13u
X653 a_10328_1044# a_9757_1842# VSS.t45 VSS.t44 sg13_lv_nmos ad=0.1406p pd=1.12u as=0.2516p ps=2.16u w=0.74u l=0.13u
X654 VSS.t77 VDD.t402 VSS.t77 VSS.t78 sg13_lv_nmos ad=0.1428p pd=1.52u as=0 ps=0 w=0.42u l=1u
X655 a_22590_1044# a_2019_1047.t3 a_22488_1044# VSS.t434 sg13_lv_nmos ad=0.2516p pd=2.16u as=0.1406p ps=1.12u w=0.74u l=0.13u
X656 VSS.t207 DELAY_VBIASN a_12471_1842# VSS.t206 sg13_lv_nmos ad=0.2516p pd=2.16u as=0.1406p ps=1.12u w=0.74u l=0.6u
X657 a_8808_1044# a_8237_1842# VSS.t256 VSS.t563 sg13_lv_nmos ad=0.1406p pd=1.12u as=0.2516p ps=2.16u w=0.74u l=0.13u
X658 VSS.t152 a_22243_1842# a_22677_1842# VSS.t286 sg13_lv_nmos ad=0.1406p pd=1.12u as=0.2516p ps=2.16u w=0.74u l=0.13u
X659 VDD.t281 DELAY_VBIASP a_6391_2470# VDD.t3 sg13_lv_pmos ad=0.3808p pd=2.92u as=0.2128p ps=1.5u w=1.12u l=0.6u
X660 a_13470_1044# a_15831_1008# a_15755_1044# VDD.t0 sg13_lv_pmos ad=0.3808p pd=2.92u as=0.2128p ps=1.5u w=1.12u l=0.13u
X661 a_1544_1044# MUX_SEL1 VDD.t324 VDD.t0 sg13_lv_pmos ad=0.3808p pd=2.92u as=0.3808p ps=2.92u w=1.12u l=0.13u
X662 VDD.t287 DELAY_VBIASP a_20831_2470# VDD.t3 sg13_lv_pmos ad=0.3808p pd=2.92u as=0.2128p ps=1.5u w=1.12u l=0.6u
X663 VDD.t240 a_2595_1047.t2 a_26471_1008# VDD.t0 sg13_lv_pmos ad=0.3808p pd=2.92u as=0.3808p ps=2.92u w=1.12u l=0.13u
X664 a_4350_1044# a_5191_1008# a_5115_1044# VDD.t0 sg13_lv_pmos ad=0.3808p pd=2.92u as=0.2128p ps=1.5u w=1.12u l=0.13u
X665 VDD.t133 a_16597_1842# a_17065_1044# VDD.t0 sg13_lv_pmos ad=0.252p pd=1.57u as=0.3808p ps=2.92u w=1.12u l=0.13u
X666 VSS.t10 a_27237_1842# a_27705_1044# VSS.t9 sg13_lv_nmos ad=0.1665p pd=1.19u as=0.2516p ps=2.16u w=0.74u l=0.13u
X667 VSS.t163 DELAY_VBIASN VSS.t166 VSS.t165 sg13_lv_nmos ad=1.33p pd=7.38u as=0 ps=0 w=7u l=7u
X668 a_10191_2470# a_9953_1842# a_10083_1842# VDD.t3 sg13_lv_pmos ad=0.2128p pd=1.5u as=0.3808p ps=2.92u w=1.12u l=0.2u
X669 a_2595_1047.t1 a_2297_1395# VSS.t296 VSS.t295 sg13_lv_nmos ad=0.1406p pd=1.12u as=0.1331p ps=1.12u w=0.74u l=0.13u
X670 a_26151_1842# a_25913_1842# a_26043_1842# VSS.t372 sg13_lv_nmos ad=0.1406p pd=1.12u as=0.2516p ps=2.16u w=0.74u l=0.2u
X671 VSS.t81 a_2019_311# a_17865_519# VSS.t596 sg13_lv_nmos ad=0.2516p pd=2.16u as=0.2516p ps=2.16u w=0.74u l=0.13u
X672 VSS.t398 a_1544_289# a_2391_331# VSS.t399 sg13_lv_nmos ad=0.1331p pd=1.12u as=0.1216p ps=1.02u w=0.64u l=0.13u
X673 a_4871_1842# a_4633_1842# a_4763_1842# VSS.t270 sg13_lv_nmos ad=0.1406p pd=1.12u as=0.2516p ps=2.16u w=0.74u l=0.2u
X674 a_13753_1842# a_13557_1842# VSS.t18 VSS.t509 sg13_lv_nmos ad=0.2516p pd=2.16u as=0.1406p ps=1.12u w=0.74u l=0.13u
X675 a_1815_1395# a_1256_1044# a_1721_1395# VSS.t252 sg13_lv_nmos ad=0.1216p pd=1.02u as=0.2176p ps=1.96u w=0.64u l=0.13u
X676 a_7673_1842# a_7477_1842# VDD.t187 VDD.t3 sg13_lv_pmos ad=0.3808p pd=2.92u as=0.2128p ps=1.5u w=1.12u l=0.13u
X677 VDD.t205 VSS.t81 VDD.t204 VDD.t0 sg13_lv_pmos ad=0.34p pd=2.68u as=0 ps=0 w=1u l=1u
X678 a_1721_331# a_1256_289# VDD.t384 VDD.t0 sg13_lv_pmos ad=0.1596p pd=1.22u as=0.2856p ps=2.36u w=0.84u l=0.13u
X679 VSS.t225 a_24523_1842# a_24957_1842# VSS.t287 sg13_lv_nmos ad=0.1406p pd=1.12u as=0.2516p ps=2.16u w=0.74u l=0.13u
X680 a_6635_1044# a_6425_1044# VSS.t6 VSS.t5 sg13_lv_nmos ad=0.1406p pd=1.12u as=0.1665p ps=1.19u w=0.74u l=0.13u
X681 VDD.t8 a_15108_5325# a_15053_5420# VDD.t7 sg13_lv_pmos ad=1.10612p pd=6.66u as=93.45f ps=0.865u w=0.42u l=0.13u
X682 VSS.t483 a_2595_1047.t9 a_5191_1008# VSS.t482 sg13_lv_nmos ad=0.2516p pd=2.16u as=0.2516p ps=2.16u w=0.74u l=0.13u
X683 a_20315_1044# a_20105_1044# VSS.t550 VSS.t589 sg13_lv_nmos ad=0.1406p pd=1.12u as=0.1665p ps=1.19u w=0.74u l=0.13u
X684 VDD.t297 DELAY_VBIASP a_11711_2470# VDD.t3 sg13_lv_pmos ad=0.3808p pd=2.92u as=0.2128p ps=1.5u w=1.12u l=0.6u
X685 a_18795_1044# a_18585_1044# VDD.t82 VDD.t0 sg13_lv_pmos ad=0.2128p pd=1.5u as=0.252p ps=1.57u w=1.12u l=0.13u
X686 a_25528_1044# a_24957_1842# VSS.t4 VSS.t346 sg13_lv_nmos ad=0.1406p pd=1.12u as=0.2516p ps=2.16u w=0.74u l=0.13u
X687 a_5778_3367# a_6126_3816# a_6326_4590# VSS.t567 sg13_lv_nmos ad=0.68p pd=4.68u as=0.38p ps=2.38u w=2u l=1u
X688 VSS.t181 DELAY_VBIASN VSS.t190 VSS.t171 sg13_lv_nmos ad=1.33p pd=7.38u as=0 ps=0 w=7u l=7u
X689 VSS.t227 DELAY_VBIASN a_27671_1842# VSS.t226 sg13_lv_nmos ad=0.2516p pd=2.16u as=0.1406p ps=1.12u w=0.74u l=0.6u
X690 a_5731_289# a_3747_311.t3 a_13470_1044# VSS.t291 sg13_lv_nmos ad=0.2516p pd=2.16u as=0.2516p ps=2.16u w=0.74u l=0.13u
X691 a_25630_1044# a_27124_1008# a_27048_1044# VDD.t0 sg13_lv_pmos ad=0.3808p pd=2.92u as=0.2128p ps=1.5u w=1.12u l=0.13u
X692 VDD.t80 a_2595_1047.t5 a_17351_1008# VDD.t0 sg13_lv_pmos ad=0.3808p pd=2.92u as=0.3808p ps=2.92u w=1.12u l=0.13u
X693 VSS.t454 a_13121_5831# a_6854_5986# VDD.t42 sg13_lv_pmos ad=0.232p pd=2.08u as=0.136p ps=1.14u w=0.4u l=0.2u
X694 VDD.t23 a_21483_1842# a_21917_1842# VDD.t3 sg13_lv_pmos ad=0.2128p pd=1.5u as=0.3808p ps=2.92u w=1.12u l=0.13u
X695 a_4350_1044# a_5844_1008# a_5768_1044# VDD.t0 sg13_lv_pmos ad=0.3808p pd=2.92u as=0.2128p ps=1.5u w=1.12u l=0.13u
X696 VSS.t136 a_16851_309# MUX_OUT VSS.t137 sg13_lv_nmos ad=0.2516p pd=2.16u as=0.1406p ps=1.12u w=0.74u l=0.13u
X697 VSS.t48 a_2019_311# a_5705_519# VSS.t594 sg13_lv_nmos ad=0.2516p pd=2.16u as=0.2516p ps=2.16u w=0.74u l=0.13u
X698 VDD.t175 a_1544_289# a_1721_331# VDD.t0 sg13_lv_pmos ad=0.1918p pd=1.5u as=0.1596p ps=1.22u w=0.84u l=0.13u
X699 a_7151_1842# a_6913_1842# a_7043_1842# VSS.t383 sg13_lv_nmos ad=0.1406p pd=1.12u as=0.2516p ps=2.16u w=0.74u l=0.2u
X700 a_16033_1842# a_15837_1842# VSS.t157 VSS.t368 sg13_lv_nmos ad=0.2516p pd=2.16u as=0.1406p ps=1.12u w=0.74u l=0.13u
X701 a_10649_5878# REF_CLK VSS.t381 VSS.t380 sg13_lv_nmos ad=0.2516p pd=2.16u as=1.9998p ps=12.915u w=0.74u l=0.13u
X702 VDD.t8 a_11748_6109# a_11693_5990# VDD.t7 sg13_lv_pmos ad=1.10612p pd=6.66u as=93.45f ps=0.865u w=0.42u l=0.13u
X703 MUX_OUT a_16851_309# VDD.t76 VDD.t0 sg13_lv_pmos ad=0.2128p pd=1.5u as=0.2086p ps=1.5u w=1.12u l=0.13u
X704 a_25391_2470# a_25153_1842# a_25283_1842# VDD.t3 sg13_lv_pmos ad=0.2128p pd=1.5u as=0.3808p ps=2.92u w=1.12u l=0.2u
X705 VDD.t124 VSS.t59 VDD.t243 VDD.t0 sg13_lv_pmos ad=0.34p pd=2.68u as=0 ps=0 w=1u l=1u
X706 a_12993_1842# a_12797_1842# VDD.t264 VDD.t3 sg13_lv_pmos ad=0.3808p pd=2.92u as=0.2128p ps=1.5u w=1.12u l=0.13u
X707 a_16408_1044# a_15837_1842# VSS.t130 VSS.t367 sg13_lv_nmos ad=0.1406p pd=1.12u as=0.2516p ps=2.16u w=0.74u l=0.13u
X708 a_5778_3367# a_6126_3816# a_6326_4590# VSS.t567 sg13_lv_nmos ad=0.68p pd=4.68u as=0.38p ps=2.38u w=2u l=1u
X709 VSS.t120 a_5523_1842# a_5957_1842# VSS.t474 sg13_lv_nmos ad=0.1406p pd=1.12u as=0.2516p ps=2.16u w=0.74u l=0.13u
X710 VDD.t302 DELAY_VBIASP a_13991_2470# VDD.t3 sg13_lv_pmos ad=0.3808p pd=2.92u as=0.2128p ps=1.5u w=1.12u l=0.6u
X711 a_5731_289# a_2019_311# a_4350_1044# VSS.t593 sg13_lv_nmos ad=0.2516p pd=2.16u as=0.2516p ps=2.16u w=0.74u l=0.13u
X712 VSS.t348 a_9547_6172# a_9547_6172# VSS.t347 sg13_lv_nmos ad=2.39977p pd=15.495u as=0.111p ps=1.34u w=0.3u l=0.13u
X713 a_9444_3912# a_6854_5454# a_9712_3912# VSS.t612 sg13_lv_nmos ad=0.68p pd=4.68u as=0.38p ps=2.38u w=2u l=1u
X714 VSS.t195 DELAY_VBIASN VSS.t193 VSS.t177 sg13_lv_nmos ad=1.33p pd=7.38u as=0 ps=0 w=7u l=7u
X715 a_7390_1044# a_3747_1047.t8 a_9675_1044# VSS.t439 sg13_lv_nmos ad=0.2516p pd=2.16u as=0.1406p ps=1.12u w=0.74u l=0.13u
X716 VDD.t91 a_23763_1842# a_24197_1842# VDD.t3 sg13_lv_pmos ad=0.2128p pd=1.5u as=0.3808p ps=2.92u w=1.12u l=0.13u
X717 VSS.t142 DELAY_VBIASN a_8671_1842# VSS.t141 sg13_lv_nmos ad=0.2516p pd=2.16u as=0.1406p ps=1.12u w=0.74u l=0.6u
X718 VDD.t116 a_2019_1047.t8 a_7364_1008# VDD.t0 sg13_lv_pmos ad=0.3808p pd=2.92u as=0.3808p ps=2.92u w=1.12u l=0.13u
X719 VDD.t311 DELAY_VBIASP a_26911_2470# VDD.t3 sg13_lv_pmos ad=0.3808p pd=2.92u as=0.2128p ps=1.5u w=1.12u l=0.6u
X720 VSS.t8 a_14009_5084# a_14111_5227# VSS.t497 sg13_lv_nmos ad=1.45407p pd=9.445u as=0.2516p ps=2.16u w=0.74u l=0.13u
X721 VDD.t361 VSS.t110 VDD.t359 VDD.t0 sg13_lv_pmos ad=0.19p pd=1.38u as=0 ps=0 w=1u l=1u
X722 a_12471_1842# a_12233_1842# a_12363_1842# VSS.t606 sg13_lv_nmos ad=0.1406p pd=1.12u as=0.2516p ps=2.16u w=0.74u l=0.2u
X723 a_22488_1044# a_21917_1842# VDD.t22 VDD.t0 sg13_lv_pmos ad=0.2128p pd=1.5u as=0.3808p ps=2.92u w=1.12u l=0.13u
X724 VDD.t221 a_2595_311.t3 a_8745_519# VDD.t0 sg13_lv_pmos ad=0.3808p pd=2.92u as=0.3808p ps=2.92u w=1.12u l=0.13u
X725 VSS.t418 a_3171_1047.t5 a_18004_1008# VSS.t417 sg13_lv_nmos ad=0.2516p pd=2.16u as=0.2516p ps=2.16u w=0.74u l=0.13u
X726 a_6391_2470# a_6153_1842# a_6283_1842# VDD.t3 sg13_lv_pmos ad=0.2128p pd=1.5u as=0.3808p ps=2.92u w=1.12u l=0.2u
X727 a_15273_1842# a_15077_1842# VDD.t217 VDD.t3 sg13_lv_pmos ad=0.3808p pd=2.92u as=0.2128p ps=1.5u w=1.12u l=0.13u
X728 a_14235_1044# a_14025_1044# VSS.t511 VSS.t561 sg13_lv_nmos ad=0.1406p pd=1.12u as=0.1665p ps=1.19u w=0.74u l=0.13u
X729 a_6326_4590# a_6126_3816# a_5778_3367# VSS.t567 sg13_lv_nmos ad=0.42p pd=2.42u as=0.68p ps=4.68u w=2u l=1u
X730 VSS.t276 a_3747_1047.t7 a_12791_1008# VSS.t275 sg13_lv_nmos ad=0.2516p pd=2.16u as=0.2516p ps=2.16u w=0.74u l=0.13u
X731 VSS.t317 VSS.t314 VSS.t316 VSS.t315 sg13_lv_nmos ad=0.2516p pd=2.16u as=0 ps=0 w=0.74u l=0.13u
X732 a_9953_1842# a_9757_1842# VSS.t43 VSS.t42 sg13_lv_nmos ad=0.2516p pd=2.16u as=0.1406p ps=1.12u w=0.74u l=0.13u
X733 VSS.t202 a_10843_1842# a_11277_1842# VSS.t494 sg13_lv_nmos ad=0.1406p pd=1.12u as=0.2516p ps=2.16u w=0.74u l=0.13u
X734 VSS.t99 VDD.t396 VSS.t99 VSS.t100 sg13_lv_nmos ad=0.1428p pd=1.52u as=0 ps=0 w=0.42u l=1u
X735 a_10649_5878# REF_CLK VDD.t8 VDD.t7 sg13_lv_pmos ad=0.4088p pd=2.97u as=1.03698p ps=6.245u w=1.12u l=0.13u
X736 VDD.t158 a_15403_1842# a_15837_1842# VDD.t3 sg13_lv_pmos ad=0.2128p pd=1.5u as=0.3808p ps=2.92u w=1.12u l=0.13u
X737 VDD.t8 a_14009_5084# a_14111_5227# VDD.t7 sg13_lv_pmos ad=1.10612p pd=6.66u as=0.3864p ps=2.93u w=1.12u l=0.13u
X738 VSS.t75 VDD.t403 VSS.t75 VSS.t74 sg13_lv_nmos ad=0.1428p pd=1.52u as=0 ps=0 w=0.42u l=1u
X739 a_11848_1044# a_11277_1842# VSS.t259 VSS.t385 sg13_lv_nmos ad=0.1406p pd=1.12u as=0.2516p ps=2.16u w=0.74u l=0.13u
X740 a_6326_4590# a_6326_4590# VDD.t107 VDD.t7 sg13_lv_pmos ad=0.38p pd=2.38u as=0.38p ps=2.38u w=2u l=1u
X741 VDD.t313 a_4763_1842# a_5197_1842# VDD.t3 sg13_lv_pmos ad=0.2128p pd=1.5u as=0.3808p ps=2.92u w=1.12u l=0.13u
X742 VSS.t84 VDD.t401 VSS.t82 VSS.t83 sg13_lv_nmos ad=79.8f pd=0.8u as=0 ps=0 w=0.42u l=1u
X743 a_13470_1044# a_13444_1008# a_13368_1044# VDD.t0 sg13_lv_pmos ad=0.3808p pd=2.92u as=0.2128p ps=1.5u w=1.12u l=0.13u
X744 VDD.t340 a_3449_1395# a_3747_1047.t0 VDD.t0 sg13_lv_pmos ad=0.4256p pd=3u as=0.2128p ps=1.5u w=1.12u l=0.13u
X745 VSS.t326 VSS.t323 VSS.t323 VSS.t324 sg13_lv_nmos ad=0.1406p pd=1.12u as=0 ps=0 w=0.74u l=0.13u
X746 VDD.t237 a_3171_1047.t3 a_24084_1008# VDD.t0 sg13_lv_pmos ad=0.3808p pd=2.92u as=0.3808p ps=2.92u w=1.12u l=0.13u
X747 a_3449_1395# MUX_SEL0 VDD.t322 VDD.t0 sg13_lv_pmos ad=0.1596p pd=1.22u as=0.2856p ps=2.36u w=0.84u l=0.13u
X748 a_15464_3684# a_14851_5182# VDD.t63 VDD.t7 sg13_lv_pmos ad=0.4312p pd=3.01u as=0.2639p ps=1.81u w=1.12u l=0.13u
X749 a_5974_5723# a_6126_3816# VSS.t571 VSS.t570 sg13_lv_nmos ad=0.38p pd=2.38u as=0.68p ps=4.68u w=2u l=1u
X750 VDD.t289 DELAY_VBIASP a_7911_2470# VDD.t3 sg13_lv_pmos ad=0.3808p pd=2.92u as=0.2128p ps=1.5u w=1.12u l=0.6u
X751 VDD.t190 VSS.t55 VDD.t189 VDD.t0 sg13_lv_pmos ad=0.19p pd=1.38u as=0 ps=0 w=1u l=1u
X752 VDD.t40 a_6326_4590# a_6854_5986# VDD.t7 sg13_lv_pmos ad=0.38p pd=2.38u as=0.38p ps=2.38u w=2u l=1u
X753 a_10206_5835# a_10649_5878# a_9946_6305# VSS.t479 sg13_lv_nmos ad=79.8f pd=0.8u as=0.1296p ps=1.52u w=0.42u l=0.13u
X754 VDD.t192 VSS.t55 VDD.t191 VDD.t0 sg13_lv_pmos ad=0.34p pd=2.68u as=0 ps=0 w=1u l=1u
X755 a_9946_6305# a_9772_5843# VDD.t163 VDD.t7 sg13_lv_pmos ad=79.8f pd=0.8u as=0.1428p ps=1.52u w=0.42u l=0.13u
X756 a_9946_6305# a_10751_5878# a_10206_5835# VDD.t7 sg13_lv_pmos ad=0.1428p pd=1.52u as=79.8f ps=0.8u w=0.42u l=0.13u
X757 VDD.t77 a_16851_309# MUX_OUT VDD.t0 sg13_lv_pmos ad=0.7336p pd=3.55u as=0.2128p ps=1.5u w=1.12u l=0.13u
X758 VSS.t103 a_3171_311.t2 a_23945_519# VSS.t557 sg13_lv_nmos ad=0.2516p pd=2.16u as=0.2516p ps=2.16u w=0.74u l=0.13u
X759 VDD.t82 a_18117_1842# a_18585_1044# VDD.t0 sg13_lv_pmos ad=0.252p pd=1.57u as=0.3808p ps=2.92u w=1.12u l=0.13u
X760 VSS.t550 a_19637_1842# a_20105_1044# VSS.t549 sg13_lv_nmos ad=0.1665p pd=1.19u as=0.2516p ps=2.16u w=0.74u l=0.13u
X761 a_11711_2470# a_11473_1842# a_11603_1842# VDD.t3 sg13_lv_pmos ad=0.2128p pd=1.5u as=0.3808p ps=2.92u w=1.12u l=0.2u
X762 a_27671_1842# a_27433_1842# a_27563_1842# VSS.t566 sg13_lv_nmos ad=0.1406p pd=1.12u as=0.2516p ps=2.16u w=0.74u l=0.2u
X763 VSS.t136 MUX_SEL4 a_15765_463# VSS.t467 sg13_lv_nmos ad=0.2516p pd=2.16u as=0.2516p ps=2.16u w=0.74u l=0.13u
X764 a_5731_289# a_14825_519# a_13470_1044# VDD.t0 sg13_lv_pmos ad=0.3808p pd=2.92u as=0.3808p ps=2.92u w=1.12u l=0.13u
X765 a_16510_1044# a_2595_1047.t5 a_17275_1044# VSS.t228 sg13_lv_nmos ad=0.2516p pd=2.16u as=0.1406p ps=1.12u w=0.74u l=0.13u
X766 a_13045_6215# a_13019_5831# a_12849_5867# VSS.t343 sg13_lv_nmos ad=0.1406p pd=1.12u as=0.1406p ps=1.12u w=0.74u l=0.13u
X767 VSS.t146 DELAY_VBIASN a_16271_1842# VSS.t145 sg13_lv_nmos ad=0.2516p pd=2.16u as=0.1406p ps=1.12u w=0.74u l=0.6u
X768 VDD.t126 VSS.t103 VDD.t203 VDD.t0 sg13_lv_pmos ad=0.34p pd=2.68u as=0 ps=0 w=1u l=1u
X769 VDD.t337 a_3171_1047.t6 a_14964_1008# VDD.t0 sg13_lv_pmos ad=0.3808p pd=2.92u as=0.3808p ps=2.92u w=1.12u l=0.13u
X770 VDD.t74 a_10083_1842# a_10517_1842# VDD.t3 sg13_lv_pmos ad=0.2128p pd=1.5u as=0.3808p ps=2.92u w=1.12u l=0.13u
X771 VSS.t602 a_3747_1047.t2 a_27991_1008# VSS.t601 sg13_lv_nmos ad=0.2516p pd=2.16u as=0.2516p ps=2.16u w=0.74u l=0.13u
X772 a_9712_3912# a_13019_5831# DELAY_VBIASN VSS.t344 sg13_lv_nmos ad=0.136p pd=1.14u as=0.232p ps=2.08u w=0.4u l=0.2u
X773 VSS.t1 a_26043_1842# a_26477_1842# VSS.t0 sg13_lv_nmos ad=0.1406p pd=1.12u as=0.2516p ps=2.16u w=0.74u l=0.13u
X774 VSS.t578 a_6126_3816# a_5974_5723# VSS.t570 sg13_lv_nmos ad=0.68p pd=4.68u as=0.38p ps=2.38u w=2u l=1u
X775 a_11195_1044# a_10985_1044# VDD.t75 VDD.t0 sg13_lv_pmos ad=0.2128p pd=1.5u as=0.252p ps=1.57u w=1.12u l=0.13u
X776 VSS.t599 a_3747_1047.t9 a_6711_1008# VSS.t598 sg13_lv_nmos ad=0.2516p pd=2.16u as=0.2516p ps=2.16u w=0.74u l=0.13u
X777 a_9444_4590# a_6854_5454# a_6854_5454# VSS.t612 sg13_lv_nmos ad=0.68p pd=4.68u as=0.38p ps=2.38u w=2u l=1u
X778 a_16108_289# a_2595_311.t2 a_19550_1044# VSS.t123 sg13_lv_nmos ad=0.2516p pd=2.16u as=0.2516p ps=2.16u w=0.74u l=0.13u
X779 VSS.t148 DELAY_VBIASN a_20071_1842# VSS.t147 sg13_lv_nmos ad=0.2516p pd=2.16u as=0.1406p ps=1.12u w=0.74u l=0.6u
X780 VDD.t309 DELAY_VBIASP a_24631_2470# VDD.t3 sg13_lv_pmos ad=0.3808p pd=2.92u as=0.2128p ps=1.5u w=1.12u l=0.6u
X781 a_22590_1044# a_23431_1008# a_23355_1044# VDD.t0 sg13_lv_pmos ad=0.3808p pd=2.92u as=0.2128p ps=1.5u w=1.12u l=0.13u
X782 VSS.t66 VDD.t405 VSS.t66 VSS.t68 sg13_lv_nmos ad=79.8f pd=0.8u as=0 ps=0 w=0.42u l=1u
X783 a_10458_6292# DLL_RESETN VSS.t461 VSS.t518 sg13_lv_nmos ad=37.8f pd=0.6u as=0.1701p ps=1.65u w=0.42u l=0.13u
X784 a_11491_6228# a_10649_5878# a_10232_5871# VDD.t7 sg13_lv_pmos ad=0.2048p pd=1.63u as=0.34p ps=2.68u w=1u l=0.13u
X785 VSS.t576 a_6126_3816# a_5974_5723# VSS.t570 sg13_lv_nmos ad=0.76p pd=4.76u as=0.38p ps=2.38u w=2u l=1u
X786 a_8671_1842# a_8433_1842# a_8563_1842# VSS.t41 sg13_lv_nmos ad=0.1406p pd=1.12u as=0.2516p ps=2.16u w=0.74u l=0.2u
X787 a_17553_1842# a_17357_1842# VSS.t212 VSS.t349 sg13_lv_nmos ad=0.2516p pd=2.16u as=0.1406p ps=1.12u w=0.74u l=0.13u
X788 a_5731_289# a_5705_519# a_4350_1044# VDD.t0 sg13_lv_pmos ad=0.3808p pd=2.92u as=0.3808p ps=2.92u w=1.12u l=0.13u
X789 VDD.t54 VDD.t52 VDD.t53 VDD.t3 sg13_lv_pmos ad=0.3808p pd=2.92u as=0 ps=0 w=1.12u l=0.13u
X790 a_26911_2470# a_26673_1842# a_26803_1842# VDD.t3 sg13_lv_pmos ad=0.2128p pd=1.5u as=0.3808p ps=2.92u w=1.12u l=0.2u
X791 a_7390_1044# a_2019_1047.t8 a_7288_1044# VSS.t279 sg13_lv_nmos ad=0.2516p pd=2.16u as=0.1406p ps=1.12u w=0.74u l=0.13u
X792 a_13566_5328# a_14009_5084# a_13306_5105# VSS.t496 sg13_lv_nmos ad=79.8f pd=0.8u as=0.1296p ps=1.52u w=0.42u l=0.13u
X793 a_21353_1842# a_21157_1842# VSS.t217 VSS.t288 sg13_lv_nmos ad=0.2516p pd=2.16u as=0.1406p ps=1.12u w=0.74u l=0.13u
X794 VSS.t140 a_7043_1842# a_7477_1842# VSS.t531 sg13_lv_nmos ad=0.1406p pd=1.12u as=0.2516p ps=2.16u w=0.74u l=0.13u
X795 a_13121_5831# a_15688_5867# VDD.t18 VDD.t7 sg13_lv_pmos ad=0.3808p pd=2.92u as=0.2128p ps=1.5u w=1.12u l=0.13u
X796 VDD.t305 DELAY_VBIASP a_15511_2470# VDD.t3 sg13_lv_pmos ad=0.3808p pd=2.92u as=0.2128p ps=1.5u w=1.12u l=0.6u
X797 VDD.t210 a_2019_1047.t7 a_10404_1008# VDD.t0 sg13_lv_pmos ad=0.3808p pd=2.92u as=0.3808p ps=2.92u w=1.12u l=0.13u
X798 VSS.t241 a_9444_4590# a_9444_3912# VSS.t239 sg13_lv_nmos ad=0.68p pd=4.68u as=0.38p ps=2.38u w=2u l=1u
X799 VDD.t255 a_25283_1842# a_25717_1842# VDD.t3 sg13_lv_pmos ad=0.2128p pd=1.5u as=0.3808p ps=2.92u w=1.12u l=0.13u
X800 VDD.t290 DELAY_VBIASP a_5631_2470# VDD.t3 sg13_lv_pmos ad=0.3808p pd=2.92u as=0.2128p ps=1.5u w=1.12u l=0.6u
X801 a_26395_1044# a_26185_1044# VDD.t85 VDD.t0 sg13_lv_pmos ad=0.2128p pd=1.5u as=0.252p ps=1.57u w=1.12u l=0.13u
X802 a_13306_5105# a_14111_5227# a_13566_5328# VDD.t7 sg13_lv_pmos ad=0.1428p pd=1.52u as=79.8f ps=0.8u w=0.42u l=0.13u
X803 a_6326_4590# a_6126_3816# a_5778_3367# VSS.t567 sg13_lv_nmos ad=0.38p pd=2.38u as=0.68p ps=4.68u w=2u l=1u
X804 VDD.t5 a_3747_1047.t3 a_24951_1008# VDD.t0 sg13_lv_pmos ad=0.3808p pd=2.92u as=0.3808p ps=2.92u w=1.12u l=0.13u
X805 VDD.t179 VSS.t99 VDD.t178 VDD.t0 sg13_lv_pmos ad=0.19p pd=1.38u as=0 ps=0 w=1u l=1u
X806 a_13991_1842# a_13753_1842# a_13883_1842# VSS.t249 sg13_lv_nmos ad=0.1406p pd=1.12u as=0.2516p ps=2.16u w=0.74u l=0.2u
X807 a_24008_1044# a_23437_1842# VDD.t245 VDD.t0 sg13_lv_pmos ad=0.2128p pd=1.5u as=0.3808p ps=2.92u w=1.12u l=0.13u
X808 VDD.t14 VSS.t73 VDD.t13 VDD.t0 sg13_lv_pmos ad=0.19p pd=1.38u as=0 ps=0 w=1u l=1u
X809 VSS.t446 a_2019_1047.t4 a_19524_1008# VSS.t445 sg13_lv_nmos ad=0.2516p pd=2.16u as=0.2516p ps=2.16u w=0.74u l=0.13u
X810 a_9712_3912# a_6854_5454# a_9444_3912# VSS.t611 sg13_lv_nmos ad=0.38p pd=2.38u as=0.68p ps=4.68u w=2u l=1u
X811 a_7911_2470# a_7673_1842# a_7803_1842# VDD.t3 sg13_lv_pmos ad=0.2128p pd=1.5u as=0.3808p ps=2.92u w=1.12u l=0.2u
X812 a_16793_1842# a_16597_1842# VDD.t134 VDD.t3 sg13_lv_pmos ad=0.3808p pd=2.92u as=0.2128p ps=1.5u w=1.12u l=0.13u
X813 VSS.t538 MUX_SEL1 a_3543_1395# VSS.t537 sg13_lv_nmos ad=0.1331p pd=1.12u as=0.1216p ps=1.02u w=0.64u l=0.13u
X814 a_15755_1044# a_15545_1044# VSS.t507 VSS.t543 sg13_lv_nmos ad=0.1406p pd=1.12u as=0.1665p ps=1.19u w=0.74u l=0.13u
X815 a_13818_5118# a_12849_5867# VSS.t261 VSS.t363 sg13_lv_nmos ad=37.8f pd=0.6u as=0.1701p ps=1.65u w=0.42u l=0.13u
X816 a_2595_1047.t0 a_2297_1395# VDD.t130 VDD.t0 sg13_lv_pmos ad=0.2128p pd=1.5u as=0.1918p ps=1.5u w=1.12u l=0.13u
X817 VSS.t284 a_2595_1047.t6 a_14311_1008# VSS.t283 sg13_lv_nmos ad=0.2516p pd=2.16u as=0.2516p ps=2.16u w=0.74u l=0.13u
X818 VSS.t207 a_12363_1842# a_12797_1842# VSS.t582 sg13_lv_nmos ad=0.1406p pd=1.12u as=0.2516p ps=2.16u w=0.74u l=0.13u
X819 a_5115_1044# a_4905_1044# VSS.t392 VSS.t624 sg13_lv_nmos ad=0.1406p pd=1.12u as=0.1665p ps=1.19u w=0.74u l=0.13u
X820 a_1256_1044# MUX_SEL0 VDD.t320 VDD.t0 sg13_lv_pmos ad=0.3808p pd=2.92u as=0.3808p ps=2.92u w=1.12u l=0.13u
X821 a_9444_3912# a_9444_4590# VSS.t237 VSS.t236 sg13_lv_nmos ad=0.38p pd=2.38u as=0.68p ps=4.68u w=2u l=1u
X822 VSS.t188 DELAY_VBIASN VSS.t186 VSS.t167 sg13_lv_nmos ad=1.33p pd=7.38u as=0 ps=0 w=7u l=7u
X823 VDD.t68 a_27563_1842# a_27997_1842# VDD.t3 sg13_lv_pmos ad=0.2128p pd=1.5u as=0.3808p ps=2.92u w=1.12u l=0.13u
X824 a_20593_1842# a_20397_1842# VDD.t256 VDD.t3 sg13_lv_pmos ad=0.3808p pd=2.92u as=0.2128p ps=1.5u w=1.12u l=0.13u
X825 a_1721_1395# a_1256_1044# VDD.t87 VDD.t0 sg13_lv_pmos ad=0.1596p pd=1.22u as=0.2856p ps=2.36u w=0.84u l=0.13u
X826 VDD.t277 a_6283_1842# a_6717_1842# VDD.t3 sg13_lv_pmos ad=0.2128p pd=1.5u as=0.3808p ps=2.92u w=1.12u l=0.13u
X827 a_13470_1044# a_14964_1008# a_14888_1044# VDD.t0 sg13_lv_pmos ad=0.3808p pd=2.92u as=0.2128p ps=1.5u w=1.12u l=0.13u
X828 a_13592_5871# a_13566_5835# VDD.t132 VDD.t7 sg13_lv_pmos ad=0.34p pd=2.68u as=0.36237p ps=2.605u w=1u l=0.13u
X829 a_5778_3367# a_6126_3816# a_6326_4590# VSS.t567 sg13_lv_nmos ad=0.68p pd=4.68u as=0.42p ps=2.42u w=2u l=1u
X830 VSS.t82 VDD.t401 VSS.t81 VSS.t80 sg13_lv_nmos ad=0.1428p pd=1.52u as=0 ps=0 w=0.42u l=1u
X831 VDD.t11 a_2019_1047.t2 a_25604_1008# VDD.t0 sg13_lv_pmos ad=0.3808p pd=2.92u as=0.3808p ps=2.92u w=1.12u l=0.13u
X832 a_9746_5805# a_9547_5942# VSS.t348 VSS.t565 sg13_lv_nmos ad=0.27427p pd=2.28u as=2.39977p ps=15.495u w=0.795u l=0.13u
X833 a_16271_1842# a_16033_1842# a_16163_1842# VSS.t459 sg13_lv_nmos ad=0.1406p pd=1.12u as=0.2516p ps=2.16u w=0.74u l=0.2u
X834 a_21835_1044# a_21625_1044# VDD.t122 VDD.t0 sg13_lv_pmos ad=0.2128p pd=1.5u as=0.252p ps=1.57u w=1.12u l=0.13u
X835 VDD.t189 VSS.t53 VDD.t380 VDD.t0 sg13_lv_pmos ad=0.34p pd=2.68u as=0 ps=0 w=1u l=1u
X836 VDD.t198 a_2595_1047.t4 a_20391_1008# VDD.t0 sg13_lv_pmos ad=0.3808p pd=2.92u as=0.3808p ps=2.92u w=1.12u l=0.13u
X837 VSS.t116 a_14851_5182# a_15688_5403# VSS.t117 sg13_lv_nmos ad=0.1406p pd=1.12u as=0.2516p ps=2.16u w=0.74u l=0.13u
X838 a_19073_1842# a_18877_1842# VDD.t113 VDD.t3 sg13_lv_pmos ad=0.3808p pd=2.92u as=0.2128p ps=1.5u w=1.12u l=0.13u
X839 VDD.t75 a_10517_1842# a_10985_1044# VDD.t0 sg13_lv_pmos ad=0.252p pd=1.57u as=0.3808p ps=2.92u w=1.12u l=0.13u
X840 VSS.t290 a_21157_1842# a_21625_1044# VSS.t289 sg13_lv_nmos ad=0.1665p pd=1.19u as=0.2516p ps=2.16u w=0.74u l=0.13u
X841 VSS.t299 a_12849_5867# a_13400_6305# VSS.t298 sg13_lv_nmos ad=0.1626p pd=1.415u as=60.89999f ps=0.71u w=0.42u l=0.13u
X842 VSS.t569 a_6126_3816# a_6126_3816# VSS.t567 sg13_lv_nmos ad=0.68p pd=4.68u as=0.38p ps=2.38u w=2u l=1u
X843 a_20071_1842# a_19833_1842# a_19963_1842# VSS.t46 sg13_lv_nmos ad=0.1406p pd=1.12u as=0.2516p ps=2.16u w=0.74u l=0.2u
X844 VSS.t308 VSS.t306 VSS.t306 VSS.t307 sg13_lv_nmos ad=0.68p pd=4.68u as=0 ps=0 w=2u l=1u
X845 VSS.t161 a_14643_1842# a_15077_1842# VSS.t457 sg13_lv_nmos ad=0.1406p pd=1.12u as=0.2516p ps=2.16u w=0.74u l=0.13u
X846 a_1815_331# a_1256_289# a_1721_331# VSS.t615 sg13_lv_nmos ad=0.1216p pd=1.02u as=0.2176p ps=1.96u w=0.64u l=0.13u
X847 VDD.t34 VDD.t32 VDD.t33 VDD.t7 sg13_lv_pmos ad=0.38p pd=2.38u as=0 ps=0 w=2u l=1u
X848 VDD.t333 a_19203_1842# a_19637_1842# VDD.t3 sg13_lv_pmos ad=0.2128p pd=1.5u as=0.3808p ps=2.92u w=1.12u l=0.13u
X849 VSS.t395 a_2019_1047.t9 a_4324_1008# VSS.t438 sg13_lv_nmos ad=0.2516p pd=2.16u as=0.2516p ps=2.16u w=0.74u l=0.13u
X850 a_16108_289# a_20905_519# a_19550_1044# VDD.t0 sg13_lv_pmos ad=0.3808p pd=2.92u as=0.3808p ps=2.92u w=1.12u l=0.13u
X851 a_16510_1044# a_3747_1047.t5 a_18795_1044# VSS.t402 sg13_lv_nmos ad=0.2516p pd=2.16u as=0.1406p ps=1.12u w=0.74u l=0.13u
X852 VDD.t81 a_8563_1842# a_8997_1842# VDD.t3 sg13_lv_pmos ad=0.2128p pd=1.5u as=0.3808p ps=2.92u w=1.12u l=0.13u
X853 VDD.t288 DELAY_VBIASP a_13231_2470# VDD.t3 sg13_lv_pmos ad=0.3808p pd=2.92u as=0.2128p ps=1.5u w=1.12u l=0.6u
X854 VSS.t221 DELAY_VBIASN a_17791_1842# VSS.t220 sg13_lv_nmos ad=0.2516p pd=2.16u as=0.1406p ps=1.12u w=0.74u l=0.6u
X855 VSS.t60 VDD.t407 VSS.t59 VSS.t58 sg13_lv_nmos ad=0.1428p pd=1.52u as=0 ps=0 w=0.42u l=1u
X856 a_6854_5986# a_6326_4590# VDD.t109 VDD.t7 sg13_lv_pmos ad=0.38p pd=2.38u as=0.38p ps=2.38u w=2u l=1u
X857 VDD.t49 VDD.t47 VDD.t48 VDD.t42 sg13_lv_pmos ad=0.3808p pd=2.92u as=0 ps=0 w=1.12u l=0.13u
X858 VDD.t177 a_3747_1047.t5 a_18871_1008# VDD.t0 sg13_lv_pmos ad=0.3808p pd=2.92u as=0.3808p ps=2.92u w=1.12u l=0.13u
X859 VDD.t44 VDD.t45 VDD.t46 VDD.t42 sg13_lv_pmos ad=0.2128p pd=1.5u as=0 ps=0 w=1.12u l=0.13u
X860 VDD.t244 a_23003_1842# a_23437_1842# VDD.t3 sg13_lv_pmos ad=0.2128p pd=1.5u as=0.3808p ps=2.92u w=1.12u l=0.13u
X861 VSS.t240 a_9444_4590# a_9444_4590# VSS.t239 sg13_lv_nmos ad=0.68p pd=4.68u as=0.38p ps=2.38u w=2u l=1u
X862 VSS.t311 VSS.t303 VSS.t303 VSS.t304 sg13_lv_nmos ad=0.68p pd=4.68u as=0 ps=0 w=2u l=1u
X863 a_12715_1044# a_12505_1044# VDD.t93 VDD.t0 sg13_lv_pmos ad=0.2128p pd=1.5u as=0.252p ps=1.57u w=1.12u l=0.13u
X864 a_19550_1044# a_21044_1008# a_20968_1044# VDD.t0 sg13_lv_pmos ad=0.3808p pd=2.92u as=0.2128p ps=1.5u w=1.12u l=0.13u
X865 a_17928_1044# a_17357_1842# VDD.t142 VDD.t0 sg13_lv_pmos ad=0.2128p pd=1.5u as=0.3808p ps=2.92u w=1.12u l=0.13u
X866 VSS.t33 DELAY_VBIASN a_21591_1842# VSS.t213 sg13_lv_nmos ad=0.2516p pd=2.16u as=0.1406p ps=1.12u w=0.74u l=0.6u
X867 VSS.t398 a_1544_289# a_1815_331# VSS.t397 sg13_lv_nmos ad=0.1331p pd=1.12u as=0.1216p ps=1.02u w=0.64u l=0.13u
X868 a_7288_1044# a_6717_1842# VDD.t379 VDD.t0 sg13_lv_pmos ad=0.2128p pd=1.5u as=0.3808p ps=2.92u w=1.12u l=0.13u
X869 VSS.t174 DELAY_VBIASN VSS.t176 VSS.t175 sg13_lv_nmos ad=1.33p pd=7.38u as=0 ps=0 w=7u l=7u
X870 a_5974_5723# a_6126_3816# VSS.t577 VSS.t570 sg13_lv_nmos ad=0.38p pd=2.38u as=0.68p ps=4.68u w=2u l=1u
X871 a_15511_2470# a_15273_1842# a_15403_1842# VDD.t3 sg13_lv_pmos ad=0.2128p pd=1.5u as=0.3808p ps=2.92u w=1.12u l=0.2u
X872 VSS.t335 VSS.t337 VSS.t339 VSS.t338 sg13_lv_nmos ad=0.1406p pd=1.12u as=0 ps=0 w=0.74u l=0.2u
X873 a_22590_1044# a_24951_1008# a_24875_1044# VDD.t0 sg13_lv_pmos ad=0.3808p pd=2.92u as=0.2128p ps=1.5u w=1.12u l=0.13u
X874 VSS.t110 VDD.t393 VSS.t110 VSS.t112 sg13_lv_nmos ad=79.8f pd=0.8u as=0 ps=0 w=0.42u l=1u
X875 VSS.t116 a_15108_5325# a_14757_5182# VSS.t495 sg13_lv_nmos ad=79.8f pd=0.8u as=0.1428p ps=1.52u w=0.42u l=0.13u
X876 a_10430_1044# a_2019_1047.t7 a_10328_1044# VSS.t447 sg13_lv_nmos ad=0.2516p pd=2.16u as=0.1406p ps=1.12u w=0.74u l=0.13u
X877 VDD.t381 a_5974_5723# a_5974_5723# VDD.t7 sg13_lv_pmos ad=0.2448p pd=2.08u as=0.2826p ps=2.29u w=0.36u l=2u
X878 VDD.t85 a_25717_1842# a_26185_1044# VDD.t0 sg13_lv_pmos ad=0.252p pd=1.57u as=0.3808p ps=2.92u w=1.12u l=0.13u
X879 a_6854_5454# a_6854_5454# a_9444_4590# VSS.t611 sg13_lv_nmos ad=0.38p pd=2.38u as=0.68p ps=4.68u w=2u l=1u
X880 VDD.t195 a_13883_1842# a_14317_1842# VDD.t3 sg13_lv_pmos ad=0.2128p pd=1.5u as=0.3808p ps=2.92u w=1.12u l=0.13u
X881 VDD.t173 a_4437_1842# a_4905_1044# VDD.t0 sg13_lv_pmos ad=0.252p pd=1.57u as=0.3808p ps=2.92u w=1.12u l=0.13u
X882 a_4157_1313# REF_CLK VSS.t377 VSS.t376 sg13_lv_nmos ad=0.2516p pd=2.16u as=0.2553p ps=2.17u w=0.74u l=0.13u
X883 a_7390_1044# a_3171_1047.t8 a_8808_1044# VSS.t419 sg13_lv_nmos ad=0.2516p pd=2.16u as=0.1406p ps=1.12u w=0.74u l=0.13u
X884 a_22873_1842# a_22677_1842# VSS.t152 VSS.t514 sg13_lv_nmos ad=0.2516p pd=2.16u as=0.1406p ps=1.12u w=0.74u l=0.13u
X885 a_9444_4590# a_9444_4590# VSS.t238 VSS.t236 sg13_lv_nmos ad=0.38p pd=2.38u as=0.68p ps=4.68u w=2u l=1u
X886 VDD.t197 a_3171_1047.t8 a_8884_1008# VDD.t0 sg13_lv_pmos ad=0.3808p pd=2.92u as=0.3808p ps=2.92u w=1.12u l=0.13u
C0 a_5731_289# a_16108_289# 0.01334f
C1 a_13592_5423# a_13880_5118# 0.43707f
C2 a_13231_2470# VDD 0.01806f
C3 a_26477_1842# a_27048_1044# 0.10863f
C4 a_10328_1044# VDD 0.17274f
C5 a_15304_4605# a_15108_5325# 0.01986f
C6 a_8997_1842# a_9757_1842# 0.02912f
C7 a_13121_5831# REF_CLK 1.40135f
C8 a_16923_1842# a_17031_1842# 0.01163f
C9 a_12158_5867# VDD 0.37862f
C10 a_5974_5723# VDD 0.91576f
C11 a_13470_1044# a_15755_1044# 0.39036f
C12 a_15837_1842# a_16033_1842# 0.76914f
C13 MUX_SEL4 a_5731_289# 4.60702f
C14 a_24084_1008# VDD 0.28225f
C15 a_15304_4605# DELAY_OUT_LAST 0.05582f
C16 a_14825_519# VDD 0.29292f
C17 a_17683_1842# VDD 0.49671f
C18 a_14643_1842# DELAY_VBIASP 0.06668f
C19 a_15837_1842# DELAY_VBIASN 0.10875f
C20 a_13470_1044# a_15837_1842# 0.02479f
C21 a_19550_1044# a_20315_1044# 0.39037f
C22 a_12797_1842# a_10430_1044# 0.02479f
C23 a_13592_5423# a_14111_5227# 0.34114f
C24 a_7390_1044# VDD 0.8686f
C25 a_4248_1044# a_4324_1008# 0.01176f
C26 a_16408_1044# VDD 0.17274f
C27 a_15688_5867# a_15304_4605# 0.19136f
C28 a_15403_1842# a_15511_1842# 0.01163f
C29 a_10206_5835# VDD 0.09392f
C30 a_14513_1842# a_14643_1842# 0.70845f
C31 a_23437_1842# a_24197_1842# 0.03319f
C32 MUX_SEL4 a_2297_331# 0.04338f
C33 a_21835_1044# VDD 0.15406f
C34 a_14851_5182# VDD 0.26676f
C35 a_9547_5942# a_9547_6172# 0.1117f
C36 a_16033_1842# VDD 0.49413f
C37 a_24875_1044# a_24665_1044# 0.09424f
C38 a_25630_1044# a_26395_1044# 0.39037f
C39 a_10517_1842# a_10404_1008# 0.05157f
C40 VDD DELAY_VBIASN 1.49209f
C41 DLL_RESETN REF_CLK 10.7961f
C42 a_4324_1008# VDD 0.28597f
C43 a_26477_1842# a_26043_1842# 0.6972f
C44 a_13470_1044# VDD 0.87936f
C45 a_14111_5878# a_14851_6228# 0.26905f
C46 a_7673_1842# a_8237_1842# 0.0114f
C47 a_13883_1842# a_13991_1842# 0.01163f
C48 a_1256_289# MUX_SEL3 1.41161f
C49 a_1544_289# MUX_SEL2 0.07405f
C50 a_22677_1842# a_22243_1842# 0.69698f
C51 a_10430_1044# a_12505_1044# 0.03208f
C52 a_4350_1044# a_2019_311# 0.02042f
C53 a_18871_1008# VDD 0.2822f
C54 a_13566_5328# VDD 0.0947f
C55 a_14851_6228# VDD 0.25326f
C56 a_27563_1842# a_27671_1842# 0.01163f
C57 a_14317_1842# VDD 0.87229f
C58 a_27563_1842# a_25630_1044# 0.01024f
C59 a_12233_1842# DELAY_VBIASP 0.11222f
C60 a_12363_1842# DELAY_VBIASN 0.07254f
C61 a_12849_5867# a_14009_5084# 0.03463f
C62 a_12797_1842# a_13444_1008# 0.02011f
C63 a_25153_1842# a_25717_1842# 0.0114f
C64 a_13592_5871# a_14111_5878# 0.34102f
C65 a_14009_5878# a_13880_6292# 0.01562f
C66 a_6717_1842# a_7477_1842# 0.06198f
C67 a_21353_1842# a_21917_1842# 0.0114f
C68 a_15831_1008# a_15545_1044# 0.01885f
C69 a_13592_5871# VDD 0.07242f
C70 a_26043_1842# a_26151_1842# 0.01163f
C71 a_13753_1842# VDD 0.49349f
C72 a_6854_5454# DLL_RESETN 0.03626f
C73 a_20315_1044# a_20105_1044# 0.09424f
C74 a_13557_1842# VDD 0.86707f
C75 a_9431_2470# a_9323_1842# 0.01697f
C76 a_10517_1842# DELAY_VBIASP 0.0414f
C77 a_10713_1842# DELAY_VBIASN 0.0961f
C78 a_8997_1842# a_7390_1044# 0.05231f
C79 a_12037_1842# a_11924_1008# 0.02055f
C80 a_5864_3367# DLL_RESETN 0.1727f
C81 a_9712_3912# REF_CLK 0.06562f
C82 a_12849_5867# a_12943_5867# 0.16706f
C83 a_1544_1044# a_1721_1395# 0.38063f
C84 a_5957_1842# a_5523_1842# 0.6972f
C85 a_1256_289# VDD 0.40292f
C86 a_20397_1842# a_21157_1842# 0.03319f
C87 a_6711_1008# a_6425_1044# 0.01885f
C88 a_22590_1044# a_23003_1842# 0.01012f
C89 a_13470_1044# a_14025_1044# 0.03209f
C90 a_24523_1842# a_24631_1842# 0.01163f
C91 a_10649_5878# REF_CLK 0.25484f
C92 a_12797_1842# a_13123_1842# 0.01427f
C93 a_10843_1842# VDD 0.4973f
C94 a_8997_1842# DELAY_VBIASN 0.09156f
C95 a_23763_1842# DELAY_VBIASN 0.08024f
C96 a_23633_1842# DELAY_VBIASP 0.11286f
C97 a_13121_5831# a_12943_5867# 0.09118f
C98 a_4633_1842# a_5197_1842# 0.0114f
C99 a_6126_3816# a_6854_5454# 0.22705f
C100 a_17065_1044# VDD 0.30218f
C101 a_19637_1842# a_19203_1842# 0.69698f
C102 a_4157_1313# DELAY_VBIASN 0.01202f
C103 a_4324_1008# a_4157_1313# 0.02463f
C104 REF_CLK DELAY_VBIASP 2.13371f
C105 a_4350_1044# a_4905_1044# 0.03209f
C106 a_7911_2470# VDD 0.01806f
C107 a_27237_1842# DELAY_VBIASN 0.10152f
C108 a_26043_1842# DELAY_VBIASP 0.06661f
C109 a_8237_1842# DELAY_VBIASP 0.0414f
C110 a_11271_1008# a_10985_1044# 0.01885f
C111 a_13019_5831# a_15464_3684# 0.59875f
C112 a_22488_1044# a_21917_1842# 0.10864f
C113 a_27705_1044# a_27991_1008# 0.01885f
C114 a_19203_1842# a_18877_1842# 0.01427f
C115 a_6126_3816# a_5864_3367# 0.23738f
C116 a_9675_1044# a_9751_1008# 0.01194f
C117 a_6854_5454# a_9712_3912# 0.6789f
C118 a_12037_1842# a_12233_1842# 0.77122f
C119 a_13592_5423# REF_CLK 0.03445f
C120 a_9193_1842# VDD 0.49285f
C121 a_8433_1842# DELAY_VBIASN 0.0961f
C122 a_2297_1395# MUX_SEL0 0.10655f
C123 a_15964_289# a_16108_289# 0.42202f
C124 a_18877_1842# a_16108_289# 0.0157f
C125 a_18877_1842# a_18443_1842# 0.6972f
C126 a_22113_1842# DELAY_VBIASN 0.10263f
C127 a_21917_1842# DELAY_VBIASP 0.04176f
C128 a_13121_5831# a_12849_5867# 0.55272f
C129 a_13557_1842# a_14025_1044# 0.19203f
C130 a_11748_6109# a_11491_6228# 0.34468f
C131 a_6425_1044# VDD 0.29722f
C132 MUX_SEL4 a_15964_289# 0.5544f
C133 a_27433_1842# VDD 0.49285f
C134 a_24393_1842# DELAY_VBIASP 0.11284f
C135 a_24523_1842# DELAY_VBIASN 0.08024f
C136 a_5523_1842# DELAY_VBIASP 0.06627f
C137 a_6717_1842# DELAY_VBIASN 0.09992f
C138 a_16510_1044# a_16851_309# 0.02131f
C139 a_19550_1044# a_21917_1842# 0.02479f
C140 a_4350_1044# a_6283_1842# 0.01012f
C141 a_18004_1008# a_18117_1842# 0.02055f
C142 a_22590_1044# a_24951_1008# 0.26208f
C143 a_24631_2470# VDD 0.01806f
C144 a_8155_1044# a_8231_1008# 0.01194f
C145 a_7390_1044# a_8884_1008# 0.28279f
C146 a_10713_1842# a_10843_1842# 0.70845f
C147 a_12943_5867# DLL_RESETN 0.03616f
C148 a_16510_1044# a_17351_1008# 0.28268f
C149 a_17553_1842# a_18117_1842# 0.0114f
C150 a_22243_1842# VDD 0.49737f
C151 a_20397_1842# DELAY_VBIASN 0.10669f
C152 a_19203_1842# DELAY_VBIASP 0.06661f
C153 a_10232_5871# a_10520_6292# 0.43707f
C154 a_18443_1842# DELAY_VBIASP 0.06661f
C155 a_25717_1842# VDD 0.86707f
C156 a_6913_1842# VDD 0.49426f
C157 a_5864_3367# DELAY_VBIASP 0.03252f
C158 a_4003_1842# DELAY_VBIASN 0.06486f
C159 a_19524_1008# a_19637_1842# 0.05157f
C160 a_6326_4590# a_9444_4590# 0.01269f
C161 a_16510_1044# a_17357_1842# 0.08038f
C162 a_22488_1044# a_22590_1044# 0.37183f
C163 a_18551_2470# VDD 0.01806f
C164 a_19550_1044# a_16108_289# 0.58202f
C165 a_19524_1008# a_18877_1842# 0.02011f
C166 a_9757_1842# a_10083_1842# 0.01427f
C167 a_11924_1008# a_10430_1044# 0.28279f
C168 a_11271_1008# a_11195_1044# 0.01194f
C169 a_12849_5867# DLL_RESETN 0.3501f
C170 a_1721_1395# VDD 0.4533f
C171 a_15755_1044# a_15831_1008# 0.01194f
C172 a_20593_1842# VDD 0.49417f
C173 a_16597_1842# a_17357_1842# 0.01669f
C174 a_7043_1842# a_7151_1842# 0.01163f
C175 a_23945_519# VDD 0.29292f
C176 a_16923_1842# DELAY_VBIASN 0.08024f
C177 a_16793_1842# DELAY_VBIASP 0.11284f
C178 a_5197_1842# VDD 0.86909f
C179 a_15831_1008# a_15837_1842# 0.02354f
C180 a_20968_1044# a_21044_1008# 0.01176f
C181 a_5731_289# a_15964_289# 0.2778f
C182 a_14111_5227# a_15108_5325# 0.03012f
C183 a_13306_5105# a_13880_5118# 0.31978f
C184 a_26477_1842# a_26471_1008# 0.02349f
C185 a_25717_1842# a_26185_1044# 0.19203f
C186 a_12471_2470# VDD 0.01806f
C187 a_9751_1008# VDD 0.2822f
C188 a_15304_4605# a_14851_5182# 0.05156f
C189 a_4350_1044# a_6711_1008# 0.26208f
C190 a_18795_1044# VDD 0.15406f
C191 a_8997_1842# a_9193_1842# 0.77122f
C192 a_13121_5831# DLL_RESETN 0.04337f
C193 a_13470_1044# a_14964_1008# 0.28279f
C194 a_6326_4590# VDD 7.53039f
C195 a_14235_1044# a_14311_1008# 0.01194f
C196 a_11491_6228# VDD 0.16753f
C197 a_15837_1842# a_15403_1842# 0.6972f
C198 a_5523_1842# a_5631_1842# 0.01163f
C199 a_24008_1044# VDD 0.17499f
C200 a_15464_3684# VDD 0.52511f
C201 a_14111_5227# DELAY_OUT_LAST 0.02024f
C202 a_15304_4605# DELAY_VBIASN 0.07802f
C203 a_11785_519# VDD 0.29292f
C204 a_18117_1842# VDD 0.85848f
C205 a_15077_1842# DELAY_VBIASP 0.04184f
C206 a_15273_1842# DELAY_VBIASN 0.10803f
C207 a_14964_1008# a_14317_1842# 0.02312f
C208 a_19550_1044# a_19524_1008# 0.277f
C209 a_12471_2470# a_12363_1842# 0.01697f
C210 a_13306_5105# a_14111_5227# 0.097f
C211 a_13592_5423# a_14009_5084# 0.3749f
C212 a_7288_1044# VDD 0.17274f
C213 a_27237_1842# a_27433_1842# 0.77122f
C214 a_4248_1044# a_4350_1044# 0.37183f
C215 a_14851_6228# a_15304_4605# 0.12139f
C216 a_15831_1008# VDD 0.2816f
C217 a_14513_1842# a_15077_1842# 0.0114f
C218 a_23437_1842# a_23633_1842# 0.76914f
C219 a_2019_311# MUX_SEL3 0.06209f
C220 MUX_SEL4 a_1721_331# 0.05813f
C221 MUX_OUT a_1544_289# 0.69943f
C222 a_4003_1842# a_4111_1842# 0.01163f
C223 a_21044_1008# VDD 0.28225f
C224 a_15403_1842# VDD 0.4973f
C225 a_10951_2470# a_10843_1842# 0.01697f
C226 a_10517_1842# a_10430_1044# 0.1088f
C227 a_12907_5420# a_13132_5420# 0.02416f
C228 a_4350_1044# VDD 0.87635f
C229 a_25913_1842# a_26043_1842# 0.70845f
C230 a_13368_1044# VDD 0.17274f
C231 a_14111_5878# a_15108_6109# 0.03093f
C232 a_22113_1842# a_22243_1842# 0.70845f
C233 a_10430_1044# a_10985_1044# 0.03209f
C234 a_1256_289# MUX_SEL2 0.33134f
C235 a_4350_1044# a_5705_519# 0.02005f
C236 a_24631_2470# a_24523_1842# 0.01697f
C237 a_13132_5420# VDD 0.23863f
C238 a_15108_6109# VDD 0.1349f
C239 a_12797_1842# DELAY_VBIASN 0.09992f
C240 a_11603_1842# DELAY_VBIASP 0.06627f
C241 a_13121_5831# a_15688_5403# 0.01441f
C242 a_24957_1842# a_25283_1842# 0.01427f
C243 a_12849_5867# a_13592_5423# 0.38497f
C244 a_13592_5871# a_13880_6292# 0.43707f
C245 a_6717_1842# a_6913_1842# 0.76914f
C246 a_23871_1842# a_23763_1842# 0.01163f
C247 a_2019_311# VDD 1.43004f
C248 a_8231_1008# a_7945_1044# 0.01885f
C249 a_24084_1008# a_24197_1842# 0.02055f
C250 a_15755_1044# a_15545_1044# 0.09424f
C251 a_13123_1842# a_13231_1842# 0.01163f
C252 a_13566_5835# VDD 0.09466f
C253 a_5705_519# a_2019_311# 0.13872f
C254 a_6126_3816# DLL_RESETN 0.06398f
C255 a_6854_5986# REF_CLK 0.05061f
C256 a_19550_1044# a_21625_1044# 0.03208f
C257 a_25717_1842# a_25604_1008# 0.05157f
C258 a_12993_1842# VDD 0.49426f
C259 a_9953_1842# DELAY_VBIASP 0.11222f
C260 a_10083_1842# DELAY_VBIASN 0.07254f
C261 a_9712_3912# DLL_RESETN 0.4243f
C262 a_13306_6305# a_14009_5878# 0.02432f
C263 a_1256_1044# a_1721_1395# 0.13421f
C264 a_5393_1842# a_5523_1842# 0.70845f
C265 a_22351_1842# a_22243_1842# 0.01163f
C266 a_27705_1044# VDD 0.29918f
C267 a_27991_1008# VDD 0.28201f
C268 a_20397_1842# a_20593_1842# 0.76914f
C269 a_6635_1044# a_6425_1044# 0.09424f
C270 a_7390_1044# a_7803_1842# 0.01012f
C271 a_22590_1044# a_23437_1842# 0.08038f
C272 a_11603_1842# a_11711_1842# 0.01163f
C273 VDD a_27671_2470# 0.01806f
C274 a_10649_5878# DLL_RESETN 0.05713f
C275 a_10232_5871# REF_CLK 0.08086f
C276 a_10430_1044# a_11195_1044# 0.39037f
C277 a_25630_1044# a_26985_519# 0.02165f
C278 a_12797_1842# a_13557_1842# 0.06198f
C279 a_11277_1842# VDD 0.86909f
C280 a_23003_1842# DELAY_VBIASP 0.06661f
C281 a_24197_1842# DELAY_VBIASN 0.09851f
C282 a_20831_1842# a_20723_1842# 0.01163f
C283 a_6854_5986# a_6854_5454# 0.30378f
C284 a_15545_1044# VDD 0.29918f
C285 a_12158_5867# a_12355_5867# 0.12454f
C286 a_19073_1842# a_19203_1842# 0.70845f
C287 a_7151_2470# VDD 0.01806f
C288 a_4350_1044# a_4157_1313# 0.04624f
C289 DLL_RESETN DELAY_VBIASP 0.07017f
C290 a_26673_1842# DELAY_VBIASN 0.105f
C291 a_26477_1842# DELAY_VBIASP 0.04181f
C292 a_7803_1842# DELAY_VBIASN 0.07254f
C293 a_7673_1842# DELAY_VBIASP 0.11222f
C294 a_21911_1008# a_21917_1842# 0.02354f
C295 a_7288_1044# a_6717_1842# 0.10864f
C296 a_10083_1842# a_10191_1842# 0.01163f
C297 a_27705_1044# a_27915_1044# 0.09424f
C298 a_27915_1044# a_27991_1008# 0.01194f
C299 a_19637_1842# a_18877_1842# 0.06198f
C300 a_6854_5454# a_9444_3912# 0.8486f
C301 MUX_SEL4 a_10430_1044# 0.24983f
C302 a_12037_1842# a_11603_1842# 0.6972f
C303 a_13306_5105# REF_CLK 0.06166f
C304 a_8563_1842# VDD 0.49671f
C305 a_15765_463# a_16108_289# 0.42004f
C306 a_18313_1842# a_18443_1842# 0.70845f
C307 a_21353_1842# DELAY_VBIASP 0.11284f
C308 a_21483_1842# DELAY_VBIASN 0.08024f
C309 a_9444_3912# a_5864_3367# 0.02483f
C310 a_19311_1842# a_19203_1842# 0.01163f
C311 a_4905_1044# VDD 0.30126f
C312 a_10751_5878# a_11491_6228# 0.26905f
C313 MUX_SEL4 a_15765_463# 0.65508f
C314 a_26803_1842# VDD 0.49671f
C315 a_24957_1842# DELAY_VBIASN 0.10687f
C316 a_5957_1842# DELAY_VBIASP 0.04141f
C317 a_6153_1842# DELAY_VBIASN 0.0961f
C318 a_16510_1044# a_16108_289# 0.56108f
C319 a_21044_1008# a_20397_1842# 0.02312f
C320 a_4350_1044# a_6717_1842# 0.02479f
C321 a_16510_1044# a_18443_1842# 0.01012f
C322 a_8563_1842# a_8671_1842# 0.01163f
C323 a_22590_1044# a_24875_1044# 0.39036f
C324 a_4157_1313# a_2019_311# 0.01018f
C325 a_26395_1044# a_26471_1008# 0.01194f
C326 a_23871_2470# VDD 0.01806f
C327 a_6854_5454# a_5778_3367# 0.02695f
C328 a_7390_1044# a_8808_1044# 0.38994f
C329 a_10713_1842# a_11277_1842# 0.0114f
C330 a_14009_5878# REF_CLK 0.25847f
C331 a_16510_1044# a_17275_1044# 0.39037f
C332 a_22677_1842# VDD 0.86707f
C333 a_6126_3816# DELAY_VBIASP 0.01821f
C334 a_17357_1842# a_17683_1842# 0.01427f
C335 a_19833_1842# DELAY_VBIASN 0.10734f
C336 a_19637_1842# DELAY_VBIASP 0.04176f
C337 a_25630_1044# DELAY_VBIASN 0.02756f
C338 a_5778_3367# a_5864_3367# 0.07306f
C339 a_18877_1842# DELAY_VBIASP 0.04176f
C340 a_25153_1842# VDD 0.49426f
C341 a_6283_1842# VDD 0.4973f
C342 a_9712_3912# DELAY_VBIASP 0.14197f
C343 a_19550_1044# a_19637_1842# 0.1088f
C344 a_4437_1842# DELAY_VBIASN 0.08375f
C345 a_4324_1008# a_4437_1842# 0.05157f
C346 a_27237_1842# a_27705_1044# 0.2079f
C347 a_17791_2470# VDD 0.01806f
C348 a_9757_1842# a_10517_1842# 0.06198f
C349 a_11848_1044# a_10430_1044# 0.38994f
C350 a_1544_1044# VDD 0.45079f
C351 a_13019_5831# VDD 0.41932f
C352 a_26803_1842# a_26911_2470# 0.01697f
C353 a_19963_1842# VDD 0.4973f
C354 a_16597_1842# a_16793_1842# 0.73897f
C355 a_10430_1044# a_5731_289# 0.41176f
C356 a_20905_519# VDD 0.29292f
C357 a_16163_1842# DELAY_VBIASP 0.06661f
C358 a_17357_1842# DELAY_VBIASN 0.10669f
C359 a_4633_1842# VDD 0.49285f
C360 a_14111_5227# a_14851_5182# 0.26905f
C361 a_5731_289# a_15765_463# 0.23301f
C362 a_2019_311# a_17865_519# 0.13959f
C363 a_9675_1044# VDD 0.15406f
C364 a_11711_2470# VDD 0.01806f
C365 a_4350_1044# a_6635_1044# 0.39036f
C366 a_7911_2470# a_7803_1842# 0.01697f
C367 a_18004_1008# VDD 0.28225f
C368 a_8997_1842# a_8563_1842# 0.6972f
C369 a_11748_6109# VDD 0.16819f
C370 a_13470_1044# a_14888_1044# 0.38994f
C371 a_15273_1842# a_15403_1842# 0.70845f
C372 a_7390_1044# a_8745_519# 0.01756f
C373 a_23431_1008# VDD 0.28336f
C374 a_14009_5084# DELAY_OUT_LAST 0.25594f
C375 a_17553_1842# VDD 0.49417f
C376 a_14513_1842# DELAY_VBIASP 0.12091f
C377 a_14643_1842# DELAY_VBIASN 0.08431f
C378 a_14888_1044# a_14317_1842# 0.10863f
C379 a_6854_5986# a_12849_5867# 0.06216f
C380 a_19448_1044# a_19524_1008# 0.01176f
C381 a_13306_5105# a_14009_5084# 0.02454f
C382 a_23871_2470# a_23763_1842# 0.01697f
C383 VDD MUX_SEL3 0.4053f
C384 a_6711_1008# VDD 0.2822f
C385 a_27237_1842# a_26803_1842# 0.6972f
C386 a_6391_2470# a_6283_1842# 0.01697f
C387 a_8433_1842# a_8563_1842# 0.70845f
C388 a_15755_1044# VDD 0.15389f
C389 a_15108_6109# a_15304_4605# 0.17528f
C390 a_9946_6305# VDD 0.77198f
C391 a_23437_1842# a_23003_1842# 0.6972f
C392 a_14317_1842# a_14643_1842# 0.01427f
C393 MUX_OUT a_1256_289# 0.1134f
C394 MUX_SEL4 a_1544_289# 0.47529f
C395 a_20968_1044# VDD 0.17499f
C396 a_9444_4590# VDD 0.01557f
C397 a_19637_1842# a_20105_1044# 0.19203f
C398 a_15837_1842# VDD 0.87963f
C399 a_6854_5986# a_13121_5831# 0.10056f
C400 a_4248_1044# VDD 0.17587f
C401 a_22351_2470# a_22243_1842# 0.01697f
C402 a_12849_5867# a_15108_5325# 0.10521f
C403 a_25913_1842# a_26477_1842# 0.0114f
C404 a_4871_2470# a_4763_1842# 0.01697f
C405 a_12791_1008# VDD 0.2822f
C406 a_7477_1842# a_8237_1842# 0.01669f
C407 a_22113_1842# a_22677_1842# 0.0114f
C408 a_17351_1008# a_17065_1044# 0.01885f
C409 a_12907_5420# VDD 0.07751f
C410 a_14111_5878# VDD 0.21331f
C411 a_12849_5867# DELAY_OUT_LAST 0.01791f
C412 a_21911_1008# a_21625_1044# 0.01885f
C413 a_12233_1842# DELAY_VBIASN 0.0961f
C414 a_12037_1842# DELAY_VBIASP 0.04141f
C415 a_13106_5357# a_13132_5420# 0.1657f
C416 MUX_SEL4 a_9757_1842# 0.01829f
C417 a_13121_5831# a_15108_5325# 0.05903f
C418 a_20831_2470# a_20723_1842# 0.01697f
C419 a_12849_5867# a_13306_5105# 0.10976f
C420 a_24957_1842# a_25717_1842# 0.06198f
C421 a_12797_1842# a_13368_1044# 0.10864f
C422 a_6717_1842# a_6283_1842# 0.6972f
C423 a_5705_519# VDD 0.29556f
C424 a_21157_1842# a_21917_1842# 0.02912f
C425 a_8155_1044# a_7945_1044# 0.09424f
C426 a_13121_5831# DELAY_OUT_LAST 0.13178f
C427 a_3449_331# a_2019_311# 0.01176f
C428 a_12158_5867# REF_CLK 0.01309f
C429 a_6854_5986# DLL_RESETN 0.50331f
C430 a_19550_1044# a_20105_1044# 0.03209f
C431 a_25717_1842# a_25630_1044# 0.1088f
C432 a_12363_1842# VDD 0.4973f
C433 a_9323_1842# DELAY_VBIASP 0.06627f
C434 a_10517_1842# DELAY_VBIASN 0.08375f
C435 a_19311_2470# a_19203_1842# 0.01697f
C436 a_9444_3912# DLL_RESETN 0.03031f
C437 a_13121_5831# a_15688_5867# 0.17255f
C438 a_13306_6305# a_13592_5871# 0.41329f
C439 a_1256_1044# a_1544_1044# 1.26509f
C440 a_12849_5867# a_14009_5878# 0.03525f
C441 a_5393_1842# a_5957_1842# 0.0114f
C442 a_12656_5864# a_13019_5831# 0.04193f
C443 a_26185_1044# VDD 0.30409f
C444 a_27915_1044# VDD 0.15389f
C445 a_20397_1842# a_19963_1842# 0.6972f
C446 a_27563_1842# DELAY_VBIASP 0.06663f
C447 a_7390_1044# a_8237_1842# 0.08038f
C448 VDD a_26911_2470# 0.01806f
C449 a_1544_289# a_2297_331# 0.27303f
C450 a_1256_289# a_2873_331# 0.27926f
C451 a_10232_5871# DLL_RESETN 0.39088f
C452 a_10430_1044# a_10404_1008# 0.277f
C453 a_12797_1842# a_12993_1842# 0.76914f
C454 a_10713_1842# VDD 0.49294f
C455 a_16108_289# a_26985_519# 0.2906f
C456 a_23437_1842# DELAY_VBIASP 0.04176f
C457 a_23633_1842# DELAY_VBIASN 0.10349f
C458 a_5778_3367# DLL_RESETN 0.01215f
C459 a_13121_5831# a_14009_5878# 0.01604f
C460 a_4437_1842# a_5197_1842# 0.01669f
C461 a_5974_5723# a_6854_5454# 0.01757f
C462 a_6854_5986# a_6126_3816# 0.18536f
C463 a_14025_1044# VDD 0.30409f
C464 a_19073_1842# a_19637_1842# 0.0114f
C465 a_4248_1044# a_4157_1313# 0.11672f
C466 REF_CLK DELAY_VBIASN 0.07156f
C467 a_6391_2470# VDD 0.01806f
C468 a_25913_1842# DELAY_VBIASP 0.11284f
C469 a_26043_1842# DELAY_VBIASN 0.08024f
C470 a_7043_1842# DELAY_VBIASP 0.06627f
C471 a_8237_1842# DELAY_VBIASN 0.09974f
C472 a_6711_1008# a_6717_1842# 0.02354f
C473 a_24875_1044# a_24951_1008# 0.01194f
C474 a_19073_1842# a_18877_1842# 0.76914f
C475 a_6854_5986# a_9712_3912# 0.83268f
C476 a_6126_3816# a_9444_3912# 0.25721f
C477 a_5974_5723# a_5864_3367# 0.01697f
C478 a_11473_1842# a_11603_1842# 0.70845f
C479 a_13566_5328# REF_CLK 0.01093f
C480 a_8997_1842# VDD 0.85848f
C481 a_15765_463# a_15964_289# 0.061f
C482 a_17928_1044# a_18004_1008# 0.01176f
C483 a_23763_1842# VDD 0.49671f
C484 a_18313_1842# a_18877_1842# 0.0114f
C485 a_20723_1842# DELAY_VBIASP 0.06661f
C486 a_21917_1842# DELAY_VBIASN 0.10687f
C487 a_9444_3912# a_9712_3912# 0.72189f
C488 a_10649_5878# a_11397_6228# 0.01058f
C489 a_10751_5878# a_11748_6109# 0.03061f
C490 a_4157_1313# VDD 0.48935f
C491 a_27237_1842# VDD 0.85969f
C492 MUX_SEL4 a_14825_519# 0.03307f
C493 a_24393_1842# DELAY_VBIASN 0.10734f
C494 a_5393_1842# DELAY_VBIASP 0.11222f
C495 a_5523_1842# DELAY_VBIASN 0.07254f
C496 a_16510_1044# a_15964_289# 0.05416f
C497 a_20968_1044# a_20397_1842# 0.10863f
C498 a_5844_1008# a_5197_1842# 0.02312f
C499 a_16510_1044# a_18877_1842# 0.02479f
C500 a_15304_4605# a_13019_5831# 0.07025f
C501 a_23355_1044# a_23431_1008# 0.01194f
C502 a_22590_1044# a_24084_1008# 0.28279f
C503 a_23111_2470# VDD 0.01806f
C504 a_6126_3816# a_5778_3367# 1.6143f
C505 a_7390_1044# a_8231_1008# 0.28268f
C506 MUX_SEL4 a_7390_1044# 0.34655f
C507 a_8433_1842# VDD 0.49417f
C508 a_2873_1395# VDD 0.46517f
C509 a_13592_5871# REF_CLK 0.11539f
C510 a_16510_1044# a_16484_1008# 0.277f
C511 a_17357_1842# a_18117_1842# 0.03319f
C512 a_22113_1842# VDD 0.49426f
C513 a_6854_5986# DELAY_VBIASP 0.01478f
C514 a_19073_1842# DELAY_VBIASP 0.11286f
C515 a_19203_1842# DELAY_VBIASN 0.07852f
C516 a_10232_5871# a_10649_5878# 0.37583f
C517 a_9946_6305# a_10751_5878# 0.097f
C518 a_18313_1842# DELAY_VBIASP 0.11284f
C519 a_18443_1842# DELAY_VBIASN 0.08024f
C520 a_24523_1842# VDD 0.4973f
C521 a_6717_1842# VDD 0.87726f
C522 a_4350_1044# a_4437_1842# 0.1088f
C523 a_6854_5986# a_13592_5423# 0.01958f
C524 a_16484_1008# a_16597_1842# 0.05157f
C525 a_17031_2470# VDD 0.01806f
C526 MUX_SEL2 MUX_SEL3 3.21891f
C527 a_15304_4605# a_14757_5182# 0.02225f
C528 a_6635_1044# a_6711_1008# 0.01194f
C529 a_19448_1044# a_18877_1842# 0.10864f
C530 a_9757_1842# a_9953_1842# 0.76914f
C531 a_11271_1008# a_10430_1044# 0.28268f
C532 MUX_SEL4 a_13470_1044# 0.256f
C533 a_1256_1044# VDD 0.475f
C534 a_12656_5864# VDD 0.26066f
C535 a_16597_1842# a_16163_1842# 0.69698f
C536 a_20397_1842# VDD 0.86909f
C537 a_25604_1008# VDD 0.28633f
C538 a_22590_1044# DELAY_VBIASN 0.02115f
C539 a_15688_5403# DELAY_OUT_LAST 0.01699f
C540 a_9772_5843# a_9946_6305# 0.27179f
C541 a_17865_519# VDD 0.29444f
C542 a_16793_1842# DELAY_VBIASN 0.10734f
C543 a_16597_1842# DELAY_VBIASP 0.04176f
C544 a_4003_1842# VDD 0.61559f
C545 a_13045_6215# a_13019_5831# 0.01249f
C546 a_19550_1044# a_21911_1008# 0.26208f
C547 a_2019_311# a_16851_309# 0.01299f
C548 a_5731_289# a_14825_519# 0.28056f
C549 a_10951_2470# VDD 0.01806f
C550 a_8884_1008# VDD 0.28225f
C551 DELAY_OUT_LAST DELAY_VBIASP 1.08837f
C552 a_4350_1044# a_5844_1008# 0.28279f
C553 a_5115_1044# a_5191_1008# 0.01194f
C554 a_17928_1044# VDD 0.17499f
C555 a_13470_1044# a_14311_1008# 0.28268f
C556 a_10751_5878# VDD 0.20377f
C557 a_15273_1842# a_15837_1842# 0.0114f
C558 MUX_OUT a_2019_311# 8.45486f
C559 a_7390_1044# a_5731_289# 0.41331f
C560 a_23355_1044# VDD 0.15389f
C561 a_13592_5423# DELAY_OUT_LAST 0.08062f
C562 a_21157_1842# a_21625_1044# 0.2079f
C563 a_16923_1842# VDD 0.4973f
C564 a_13883_1842# DELAY_VBIASP 0.06627f
C565 a_15077_1842# DELAY_VBIASN 0.10039f
C566 a_25630_1044# a_27705_1044# 0.03208f
C567 a_25630_1044# a_27991_1008# 0.26208f
C568 a_14311_1008# a_14317_1842# 0.02349f
C569 a_13470_1044# a_15077_1842# 0.05231f
C570 a_19448_1044# a_19550_1044# 0.37183f
C571 a_12037_1842# a_10430_1044# 0.05231f
C572 a_13306_5105# a_13592_5423# 0.41329f
C573 a_13566_5328# a_14009_5084# 0.02242f
C574 VDD MUX_SEL2 0.50938f
C575 a_6635_1044# VDD 0.15406f
C576 a_26673_1842# a_26803_1842# 0.70845f
C577 a_8433_1842# a_8997_1842# 0.0114f
C578 a_14111_5878# a_15304_4605# 0.01811f
C579 a_14964_1008# VDD 0.28225f
C580 a_9772_5843# VDD 0.24701f
C581 a_12715_1044# a_12791_1008# 0.01194f
C582 a_22873_1842# a_23003_1842# 0.70845f
C583 a_14317_1842# a_15077_1842# 0.03319f
C584 a_3449_331# MUX_SEL3 0.28429f
C585 MUX_SEL4 a_1256_289# 0.65005f
C586 a_20391_1008# VDD 0.28336f
C587 a_13470_1044# a_5731_289# 0.41365f
C588 a_15304_4605# VDD 0.72158f
C589 a_15273_1842# VDD 0.49298f
C590 a_13123_1842# DELAY_VBIASP 0.06627f
C591 a_9757_1842# a_10404_1008# 0.02011f
C592 a_12907_5186# a_12907_5420# 0.1117f
C593 a_12849_5867# a_14851_5182# 0.13376f
C594 a_12715_1044# VDD 0.15406f
C595 a_14009_5878# a_14757_6228# 0.01058f
C596 a_13880_6292# a_14111_5878# 0.12701f
C597 a_7477_1842# a_7673_1842# 0.73897f
C598 a_21917_1842# a_22243_1842# 0.01427f
C599 a_17275_1044# a_17065_1044# 0.09424f
C600 a_12907_5186# VDD 0.06323f
C601 a_21835_1044# a_21625_1044# 0.09424f
C602 a_13106_5357# a_12907_5420# 0.14994f
C603 a_11473_1842# DELAY_VBIASP 0.11222f
C604 a_11603_1842# DELAY_VBIASN 0.07254f
C605 a_8997_1842# a_8884_1008# 0.02055f
C606 a_13121_5831# a_14851_5182# 0.03337f
C607 a_24957_1842# a_25153_1842# 0.76914f
C608 a_12797_1842# a_12791_1008# 0.02354f
C609 a_4437_1842# a_4905_1044# 0.19203f
C610 a_12849_5867# a_13566_5328# 0.26617f
C611 a_12849_5867# a_14851_6228# 0.13392f
C612 a_1256_1044# a_2873_1395# 0.28892f
C613 a_6153_1842# a_6283_1842# 0.70845f
C614 a_3449_331# VDD 0.46596f
C615 a_21157_1842# a_21353_1842# 0.77122f
C616 a_7390_1044# a_9465_1044# 0.03208f
C617 a_13106_5357# VDD 0.09228f
C618 a_5974_5723# DLL_RESETN 0.02002f
C619 a_11491_6228# REF_CLK 0.01827f
C620 a_12158_5867# DLL_RESETN 0.02442f
C621 a_12797_1842# VDD 0.87771f
C622 a_9953_1842# DELAY_VBIASN 0.0961f
C623 a_9757_1842# DELAY_VBIASP 0.0414f
C624 a_11277_1842# a_11924_1008# 0.02312f
C625 a_13121_5831# a_14851_6228# 0.03404f
C626 a_13306_6305# a_13566_5835# 0.75507f
C627 a_12849_5867# a_13592_5871# 0.38817f
C628 a_5197_1842# a_5523_1842# 0.01427f
C629 a_24665_1044# VDD 0.29722f
C630 a_12355_5867# a_13019_5831# 0.3846f
C631 a_27124_1008# VDD 0.28225f
C632 a_19833_1842# a_19963_1842# 0.70845f
C633 a_18551_2470# a_18443_1842# 0.01697f
C634 a_27997_1842# DELAY_VBIASP 0.04038f
C635 a_22564_1008# a_22677_1842# 0.05157f
C636 a_12791_1008# a_12505_1044# 0.01885f
C637 VDD a_26151_2470# 0.01806f
C638 a_10206_5835# DLL_RESETN 0.27343f
C639 a_1544_289# a_1721_331# 0.36963f
C640 a_1256_289# a_2297_331# 0.04261f
C641 a_10328_1044# a_10404_1008# 0.01176f
C642 a_12797_1842# a_12363_1842# 0.6972f
C643 a_10083_1842# VDD 0.49727f
C644 a_16108_289# a_23945_519# 0.2906f
C645 MUX_OUT a_1544_1044# 0.04258f
C646 a_22873_1842# DELAY_VBIASP 0.11284f
C647 a_23003_1842# DELAY_VBIASN 0.08024f
C648 a_13121_5831# a_13592_5871# 0.01445f
C649 a_4437_1842# a_4633_1842# 0.73897f
C650 a_6326_4590# a_6854_5454# 1.25249f
C651 a_5974_5723# a_6126_3816# 1.74589f
C652 a_12505_1044# VDD 0.29722f
C653 a_17031_2470# a_16923_1842# 0.01697f
C654 a_5631_2470# VDD 0.01806f
C655 DLL_RESETN DELAY_VBIASN 0.12907f
C656 a_26477_1842# DELAY_VBIASN 0.1083f
C657 a_25283_1842# DELAY_VBIASP 0.06661f
C658 a_7673_1842# DELAY_VBIASN 0.0961f
C659 a_7477_1842# DELAY_VBIASP 0.0414f
C660 a_6326_4590# a_5864_3367# 0.01889f
C661 a_5974_5723# a_9712_3912# 0.01152f
C662 a_22590_1044# a_23945_519# 0.02165f
C663 a_11473_1842# a_12037_1842# 0.0114f
C664 a_13132_5420# REF_CLK 0.02025f
C665 a_1544_1044# MUX_SEL1 0.1672f
C666 a_1721_1395# MUX_SEL0 0.01315f
C667 a_24197_1842# VDD 0.85848f
C668 a_21353_1842# DELAY_VBIASN 0.10734f
C669 a_21157_1842# DELAY_VBIASP 0.04177f
C670 a_10232_5871# a_11397_6228# 0.43239f
C671 a_3449_1395# VDD 0.46731f
C672 a_15511_2470# a_15403_1842# 0.01697f
C673 MUX_SEL4 a_11785_519# 0.03255f
C674 a_26673_1842# VDD 0.49417f
C675 a_7803_1842# VDD 0.4973f
C676 a_5957_1842# DELAY_VBIASN 0.09156f
C677 a_4763_1842# DELAY_VBIASP 0.06627f
C678 a_20391_1008# a_20397_1842# 0.02349f
C679 a_19550_1044# a_21157_1842# 0.05231f
C680 a_5768_1044# a_5197_1842# 0.10863f
C681 a_18004_1008# a_17357_1842# 0.02312f
C682 a_22590_1044# a_24008_1044# 0.38994f
C683 a_22351_2470# VDD 0.01806f
C684 a_7390_1044# a_8155_1044# 0.39037f
C685 MUX_OUT MUX_SEL3 0.79533f
C686 a_10517_1842# a_11277_1842# 0.01669f
C687 a_13566_5835# REF_CLK 0.01538f
C688 a_16408_1044# a_16484_1008# 0.01176f
C689 a_21483_1842# VDD 0.4973f
C690 a_17357_1842# a_17553_1842# 0.76914f
C691 a_6854_5986# DELAY_OUT_LAST 0.08491f
C692 a_19637_1842# DELAY_VBIASN 0.0907f
C693 a_10206_5835# a_10649_5878# 0.02242f
C694 a_9946_6305# a_10520_6292# 0.31978f
C695 a_18877_1842# DELAY_VBIASN 0.10687f
C696 a_24957_1842# VDD 0.87825f
C697 a_13991_2470# a_13883_1842# 0.01697f
C698 a_17683_1842# DELAY_VBIASP 0.06661f
C699 a_6153_1842# VDD 0.49285f
C700 a_9712_3912# DELAY_VBIASN 0.22281f
C701 a_16510_1044# a_16597_1842# 0.1088f
C702 a_14851_5182# a_15688_5403# 0.08776f
C703 a_27237_1842# a_27124_1008# 0.02055f
C704 a_16271_2470# VDD 0.01806f
C705 MUX_SEL4 a_4350_1044# 0.31434f
C706 a_18871_1008# a_18877_1842# 0.02354f
C707 a_9757_1842# a_9323_1842# 0.6972f
C708 a_17683_1842# a_17791_1842# 0.01163f
C709 a_12355_5867# VDD 0.37639f
C710 a_19833_1842# VDD 0.49294f
C711 a_16033_1842# a_16163_1842# 0.70845f
C712 a_25630_1044# VDD 0.89531f
C713 a_15108_5325# DELAY_OUT_LAST 0.01399f
C714 a_16851_309# VDD 0.51536f
C715 a_22677_1842# a_23145_1044# 0.19203f
C716 a_16033_1842# DELAY_VBIASP 0.11287f
C717 a_16163_1842# DELAY_VBIASN 0.08306f
C718 a_4437_1842# VDD 0.86998f
C719 a_19550_1044# a_21835_1044# 0.39036f
C720 a_2019_311# a_16108_289# 0.33889f
C721 a_13592_5423# a_14851_5182# 0.01529f
C722 a_5731_289# a_11785_519# 0.28056f
C723 a_8808_1044# VDD 0.17499f
C724 a_10191_2470# VDD 0.01806f
C725 MUX_OUT VDD 0.35871f
C726 a_27997_1842# a_27563_1842# 0.69646f
C727 DELAY_VBIASN DELAY_VBIASP 8.74838f
C728 a_4350_1044# a_5768_1044# 0.38994f
C729 a_17351_1008# VDD 0.28565f
C730 a_16163_1842# a_16271_1842# 0.01163f
C731 a_13470_1044# a_14235_1044# 0.39037f
C732 a_24197_1842# a_23763_1842# 0.6972f
C733 MUX_SEL4 a_2019_311# 0.90276f
C734 a_22564_1008# VDD 0.28633f
C735 a_13880_5118# VDD 0.02994f
C736 a_19550_1044# DELAY_VBIASN 0.02115f
C737 a_17357_1842# VDD 0.86909f
C738 a_8563_1842# a_8237_1842# 0.01427f
C739 a_14317_1842# DELAY_VBIASP 0.04316f
C740 a_14513_1842# DELAY_VBIASN 0.102f
C741 a_25630_1044# a_26185_1044# 0.03209f
C742 a_25630_1044# a_27915_1044# 0.39036f
C743 a_13566_5328# a_13592_5423# 0.36952f
C744 a_9431_2470# VDD 0.01806f
C745 VDD MUX_SEL1 0.50267f
C746 a_5844_1008# VDD 0.28225f
C747 a_26673_1842# a_27237_1842# 0.0114f
C748 a_7477_1842# a_7945_1044# 0.19203f
C749 a_14888_1044# VDD 0.17499f
C750 a_14851_6228# a_14757_6228# 0.28931f
C751 a_14643_1842# a_14751_1842# 0.01163f
C752 a_9746_5805# VDD 0.0918f
C753 a_22873_1842# a_23437_1842# 0.0114f
C754 a_3449_331# MUX_SEL2 0.10741f
C755 a_14317_1842# a_14513_1842# 0.76914f
C756 a_2873_331# MUX_SEL3 0.12606f
C757 a_4350_1044# a_5731_289# 0.41099f
C758 a_20315_1044# VDD 0.15389f
C759 a_14111_5227# VDD 0.33926f
C760 a_13753_1842# DELAY_VBIASP 0.11222f
C761 a_14643_1842# VDD 0.49675f
C762 a_23431_1008# a_23145_1044# 0.01885f
C763 a_13557_1842# DELAY_VBIASP 0.0414f
C764 a_13121_5831# a_15464_3684# 0.33256f
C765 a_25717_1842# a_26477_1842# 0.01669f
C766 a_5957_1842# a_6425_1044# 0.2079f
C767 a_11924_1008# VDD 0.28225f
C768 a_13592_5871# a_14757_6228# 0.43239f
C769 a_7477_1842# a_7043_1842# 0.69698f
C770 a_8745_519# VDD 0.29292f
C771 a_21917_1842# a_22677_1842# 0.06198f
C772 a_9751_1008# a_9465_1044# 0.01885f
C773 a_16510_1044# a_18585_1044# 0.03208f
C774 a_26803_1842# a_26911_1842# 0.01163f
C775 a_2019_311# a_5731_289# 1.15781f
C776 a_13019_5831# REF_CLK 0.35409f
C777 a_27237_1842# a_25630_1044# 0.05253f
C778 a_12037_1842# DELAY_VBIASN 0.09156f
C779 a_10843_1842# DELAY_VBIASP 0.06627f
C780 a_9323_1842# a_7390_1044# 0.01012f
C781 a_13106_5357# a_12907_5186# 0.02437f
C782 a_24957_1842# a_24523_1842# 0.6972f
C783 a_12849_5867# a_13132_5420# 0.06758f
C784 a_4437_1842# a_4157_1313# 0.01771f
C785 a_12849_5867# a_15108_6109# 0.10225f
C786 a_13306_6305# a_14111_5878# 0.097f
C787 a_6153_1842# a_6717_1842# 0.0114f
C788 a_2873_331# VDD 0.46491f
C789 a_21157_1842# a_20723_1842# 0.6972f
C790 a_7390_1044# a_7945_1044# 0.03209f
C791 a_24084_1008# a_23437_1842# 0.02312f
C792 a_13306_6305# VDD 0.77573f
C793 a_25283_1842# a_25391_1842# 0.01163f
C794 a_2297_331# a_2019_311# 0.04011f
C795 a_11491_6228# DLL_RESETN 0.14622f
C796 a_11748_6109# REF_CLK 0.0148f
C797 a_24957_1842# a_25604_1008# 0.02011f
C798 a_12233_1842# VDD 0.49285f
C799 a_9323_1842# DELAY_VBIASN 0.07254f
C800 a_9193_1842# DELAY_VBIASP 0.11222f
C801 a_15077_1842# a_15545_1044# 0.2079f
C802 a_11277_1842# a_11848_1044# 0.10863f
C803 a_13121_5831# a_15108_6109# 0.03701f
C804 a_12849_5867# a_13566_5835# 0.27346f
C805 a_5197_1842# a_5957_1842# 0.03319f
C806 a_12355_5867# a_12656_5864# 0.03277f
C807 a_23145_1044# VDD 0.30409f
C808 a_27048_1044# VDD 0.17499f
C809 a_19833_1842# a_20397_1842# 0.0114f
C810 a_27433_1842# DELAY_VBIASP 0.11284f
C811 a_27563_1842# DELAY_VBIASN 0.08029f
C812 a_27997_1842# DELAY_OUT_LAST 0.70957f
C813 a_12715_1044# a_12505_1044# 0.09424f
C814 a_7364_1008# a_7477_1842# 0.05157f
C815 a_22590_1044# a_22677_1842# 0.1088f
C816 a_25630_1044# a_25604_1008# 0.277f
C817 a_1256_289# a_1721_331# 0.13421f
C818 a_10328_1044# a_10430_1044# 0.37183f
C819 a_12233_1842# a_12363_1842# 0.70845f
C820 a_10517_1842# VDD 0.86707f
C821 a_16108_289# a_20905_519# 0.2906f
C822 a_2873_1395# MUX_SEL1 0.13092f
C823 MUX_SEL4 a_1544_1044# 0.03407f
C824 MUX_OUT a_1256_1044# 0.02466f
C825 a_22243_1842# DELAY_VBIASP 0.06661f
C826 a_23437_1842# DELAY_VBIASN 0.10669f
C827 a_13121_5831# a_13566_5835# 0.01158f
C828 a_4437_1842# a_4003_1842# 0.69698f
C829 a_5974_5723# a_6854_5986# 0.029f
C830 a_6326_4590# a_6126_3816# 2.84014f
C831 a_10985_1044# VDD 0.30409f
C832 a_4871_2470# VDD 0.01806f
C833 a_25913_1842# DELAY_VBIASN 0.10734f
C834 a_25717_1842# DELAY_VBIASP 0.04176f
C835 a_6913_1842# DELAY_VBIASP 0.11222f
C836 a_7043_1842# DELAY_VBIASN 0.07254f
C837 a_6326_4590# a_9712_3912# 0.04741f
C838 a_8808_1044# a_8884_1008# 0.01176f
C839 a_11277_1842# a_11603_1842# 0.01427f
C840 a_13132_5420# DLL_RESETN 0.01689f
C841 a_15464_3684# a_9712_3912# 0.01237f
C842 a_14111_5878# REF_CLK 0.02263f
C843 a_1256_1044# MUX_SEL1 1.44243f
C844 a_1544_1044# MUX_SEL0 0.07603f
C845 a_23633_1842# VDD 0.49417f
C846 a_18117_1842# a_18877_1842# 0.02912f
C847 a_20593_1842# DELAY_VBIASP 0.11287f
C848 a_20723_1842# DELAY_VBIASN 0.07937f
C849 a_10520_6292# a_10751_5878# 0.12701f
C850 VDD REF_CLK 2.08015f
C851 a_26043_1842# VDD 0.4973f
C852 a_8237_1842# VDD 0.86909f
C853 a_5393_1842# DELAY_VBIASN 0.0961f
C854 a_5197_1842# DELAY_VBIASP 0.0414f
C855 a_6854_5454# a_9444_4590# 1.25013f
C856 a_5191_1008# a_5197_1842# 0.02349f
C857 a_4350_1044# a_5957_1842# 0.05231f
C858 a_17928_1044# a_17357_1842# 0.10863f
C859 a_22590_1044# a_23431_1008# 0.28268f
C860 a_15688_5403# a_15464_3684# 0.1999f
C861 a_21591_2470# VDD 0.01806f
C862 a_5974_5723# a_5778_3367# 2.88221f
C863 a_10430_1044# DELAY_VBIASN 0.02115f
C864 MUX_SEL4 MUX_SEL3 0.75489f
C865 MUX_OUT MUX_SEL2 0.08497f
C866 a_7390_1044# a_7364_1008# 0.277f
C867 a_10517_1842# a_10713_1842# 0.73897f
C868 a_9444_4590# a_5864_3367# 0.06832f
C869 a_16408_1044# a_16510_1044# 0.37183f
C870 a_21917_1842# VDD 0.87825f
C871 a_17357_1842# a_16923_1842# 0.6972f
C872 a_6854_5986# DELAY_VBIASN 0.15808f
C873 a_19073_1842# DELAY_VBIASN 0.10642f
C874 a_7803_1842# a_7911_1842# 0.01163f
C875 a_10206_5835# a_10232_5871# 0.36952f
C876 a_24197_1842# a_24665_1044# 0.2079f
C877 a_18117_1842# DELAY_VBIASP 0.04177f
C878 a_18313_1842# DELAY_VBIASN 0.10734f
C879 a_24393_1842# VDD 0.49285f
C880 a_5523_1842# VDD 0.49671f
C881 a_12943_5867# a_13019_5831# 0.03346f
C882 a_21835_1044# a_21911_1008# 0.01194f
C883 a_14009_5084# a_14757_5182# 0.01058f
C884 a_14851_5182# a_15108_5325# 0.29858f
C885 a_15511_2470# VDD 0.01806f
C886 a_11195_1044# VDD 0.15389f
C887 a_9193_1842# a_9323_1842# 0.70845f
C888 a_16510_1044# DELAY_VBIASN 0.02115f
C889 a_6854_5454# VDD 1.03678f
C890 a_14888_1044# a_14964_1008# 0.01176f
C891 a_16033_1842# a_16597_1842# 0.0114f
C892 a_19203_1842# VDD 0.49737f
C893 a_6283_1842# a_6391_1842# 0.01163f
C894 a_25528_1044# VDD 0.17274f
C895 a_14851_5182# DELAY_OUT_LAST 0.02109f
C896 a_16510_1044# a_18871_1008# 0.26208f
C897 a_9746_5805# a_9772_5843# 0.1657f
C898 a_16108_289# VDD 1.25759f
C899 a_18443_1842# VDD 0.4973f
C900 a_16597_1842# DELAY_VBIASN 0.0907f
C901 a_15403_1842# DELAY_VBIASP 0.06668f
C902 a_5864_3367# VDD 0.13532f
C903 a_12849_5867# a_13019_5831# 0.12838f
C904 a_20315_1044# a_20391_1008# 0.01194f
C905 a_13231_2470# a_13123_1842# 0.01697f
C906 a_19550_1044# a_21044_1008# 0.28279f
C907 a_2019_311# a_15964_289# 0.02413f
C908 MUX_SEL4 VDD 2.63176f
C909 a_8231_1008# VDD 0.28336f
C910 DELAY_VBIASN DELAY_OUT_LAST 3.19293f
C911 a_15304_4605# a_14111_5227# 0.01761f
C912 a_27433_1842# a_27563_1842# 0.70845f
C913 a_4350_1044# a_5191_1008# 0.28268f
C914 a_17275_1044# VDD 0.15389f
C915 a_13470_1044# a_13444_1008# 0.277f
C916 a_23633_1842# a_23763_1842# 0.70845f
C917 a_15077_1842# a_15837_1842# 0.02912f
C918 MUX_SEL4 a_5705_519# 0.03556f
C919 a_4763_1842# a_4871_1842# 0.01163f
C920 a_22590_1044# VDD 0.89557f
C921 a_16793_1842# VDD 0.49277f
C922 a_8997_1842# a_8237_1842# 0.03319f
C923 a_13883_1842# DELAY_VBIASN 0.07254f
C924 a_25630_1044# a_27124_1008# 0.28279f
C925 a_13470_1044# a_13883_1842# 0.01012f
C926 a_13121_5831# a_13019_5831# 0.56469f
C927 a_11711_2470# a_11603_1842# 0.01697f
C928 a_10843_1842# a_10430_1044# 0.01012f
C929 a_13566_5328# a_13306_5105# 0.75507f
C930 a_4157_1313# REF_CLK 0.50643f
C931 VDD MUX_SEL0 0.56365f
C932 a_5768_1044# VDD 0.17499f
C933 a_26477_1842# a_26803_1842# 0.01427f
C934 a_14311_1008# VDD 0.28336f
C935 a_14851_6228# a_15688_5867# 0.08776f
C936 a_9547_6172# VDD 0.08695f
C937 a_14317_1842# a_13883_1842# 0.6972f
C938 a_2873_331# MUX_SEL2 0.01422f
C939 a_2297_331# MUX_SEL3 0.01595f
C940 a_25391_2470# a_25283_1842# 0.01697f
C941 a_19524_1008# VDD 0.28633f
C942 a_14009_5084# VDD 0.31815f
C943 a_8433_1842# a_8237_1842# 0.76914f
C944 a_15077_1842# VDD 0.85965f
C945 a_24957_1842# a_24197_1842# 0.02912f
C946 a_23355_1044# a_23145_1044# 0.09424f
C947 a_13123_1842# DELAY_VBIASN 0.07254f
C948 a_10191_2470# a_10083_1842# 0.01697f
C949 a_12993_1842# DELAY_VBIASP 0.11222f
C950 a_9757_1842# a_10328_1044# 0.10864f
C951 a_13557_1842# a_13444_1008# 0.05157f
C952 a_25717_1842# a_25913_1842# 0.73897f
C953 a_11848_1044# VDD 0.17499f
C954 a_6913_1842# a_7043_1842# 0.70845f
C955 a_9547_5942# VDD 0.1511f
C956 a_13753_1842# a_13883_1842# 0.70845f
C957 a_5731_289# VDD 0.6143f
C958 a_21917_1842# a_22113_1842# 0.76914f
C959 a_9675_1044# a_9465_1044# 0.09424f
C960 a_16510_1044# a_17065_1044# 0.03209f
C961 a_12943_5867# VDD 0.29479f
C962 a_5705_519# a_5731_289# 0.28954f
C963 a_12656_5864# REF_CLK 0.01215f
C964 a_13019_5831# DLL_RESETN 0.01429f
C965 a_11277_1842# DELAY_VBIASP 0.0414f
C966 a_11473_1842# DELAY_VBIASN 0.0961f
C967 a_9757_1842# a_7390_1044# 0.02479f
C968 a_16597_1842# a_17065_1044# 0.19203f
C969 a_24393_1842# a_24523_1842# 0.70845f
C970 a_4003_1842# REF_CLK 0.55467f
C971 a_13306_6305# a_13880_6292# 0.31978f
C972 a_12849_5867# a_14111_5878# 0.42174f
C973 a_13592_5871# a_14009_5878# 0.37583f
C974 a_1544_1044# a_2297_1395# 0.28651f
C975 a_18551_1842# a_18443_1842# 0.01163f
C976 a_23111_1842# a_23003_1842# 0.01163f
C977 a_2297_331# VDD 0.46496f
C978 a_20593_1842# a_20723_1842# 0.70845f
C979 MUX_SEL4 a_4157_1313# 0.08229f
C980 a_24008_1044# a_23437_1842# 0.10863f
C981 a_8884_1008# a_8237_1842# 0.02312f
C982 a_14311_1008# a_14025_1044# 0.01885f
C983 a_12363_1842# a_12471_1842# 0.01163f
C984 a_12849_5867# VDD 2.56972f
C985 a_10751_5878# REF_CLK 0.01931f
C986 a_11748_6109# DLL_RESETN 0.11133f
C987 a_1721_331# a_2019_311# 0.18452f
C988 a_18871_1008# a_18585_1044# 0.01885f
C989 a_13557_1842# a_13123_1842# 0.69698f
C990 a_11603_1842# VDD 0.49671f
C991 a_8563_1842# DELAY_VBIASP 0.06627f
C992 a_9757_1842# DELAY_VBIASN 0.09992f
C993 a_11277_1842# a_11271_1008# 0.02349f
C994 a_13121_5831# a_14111_5878# 0.0235f
C995 a_5197_1842# a_5393_1842# 0.76914f
C996 a_21591_1842# a_21483_1842# 0.01163f
C997 a_21625_1044# VDD 0.29722f
C998 a_26471_1008# VDD 0.28336f
C999 a_3449_1395# MUX_SEL1 0.29404f
C1000 a_5191_1008# a_4905_1044# 0.01885f
C1001 a_26803_1842# DELAY_VBIASP 0.06661f
C1002 a_27997_1842# DELAY_VBIASN 0.04657f
C1003 MUX_SEL4 a_6717_1842# 0.0195f
C1004 a_7390_1044# a_7477_1842# 0.1088f
C1005 a_10843_1842# a_10951_1842# 0.01163f
C1006 a_13121_5831# VDD 0.99724f
C1007 a_25528_1044# a_25604_1008# 0.01176f
C1008 a_9946_6305# DLL_RESETN 0.09997f
C1009 a_1256_289# a_1544_289# 1.25711f
C1010 a_13019_5831# a_9712_3912# 0.03275f
C1011 a_12233_1842# a_12797_1842# 0.0114f
C1012 a_24523_1842# a_22590_1044# 0.01012f
C1013 a_9444_4590# DLL_RESETN 0.10275f
C1014 a_9953_1842# VDD 0.49426f
C1015 a_15304_4605# REF_CLK 0.01066f
C1016 a_2873_1395# MUX_SEL0 0.01504f
C1017 a_16108_289# a_17865_519# 0.29564f
C1018 MUX_SEL4 a_1256_1044# 0.04908f
C1019 a_22677_1842# DELAY_VBIASP 0.04176f
C1020 a_22873_1842# DELAY_VBIASN 0.10734f
C1021 a_20071_1842# a_19963_1842# 0.01163f
C1022 a_6326_4590# a_6854_5986# 1.31745f
C1023 a_9465_1044# VDD 0.29722f
C1024 a_11491_6228# a_11397_6228# 0.28931f
C1025 a_4111_2470# VDD 0.01866f
C1026 MUX_OUT a_16851_309# 0.45865f
C1027 a_10430_1044# a_11785_519# 0.02058f
C1028 a_25153_1842# DELAY_VBIASP 0.11284f
C1029 a_25283_1842# DELAY_VBIASN 0.08024f
C1030 a_6283_1842# DELAY_VBIASP 0.06627f
C1031 a_7477_1842# DELAY_VBIASN 0.08375f
C1032 a_13019_5831# a_15688_5403# 0.1287f
C1033 a_9323_1842# a_9431_1842# 0.01163f
C1034 a_26185_1044# a_26471_1008# 0.01885f
C1035 a_27048_1044# a_27124_1008# 0.01176f
C1036 a_12907_5420# DLL_RESETN 0.04234f
C1037 a_11277_1842# a_12037_1842# 0.03319f
C1038 a_1256_1044# MUX_SEL0 0.3314f
C1039 a_16510_1044# a_18795_1044# 0.39036f
C1040 a_23003_1842# VDD 0.4973f
C1041 a_18117_1842# a_18313_1842# 0.77122f
C1042 a_13019_5831# DELAY_VBIASP 0.02377f
C1043 a_21157_1842# DELAY_VBIASN 0.09851f
C1044 a_19963_1842# DELAY_VBIASP 0.06661f
C1045 a_10232_5871# a_11491_6228# 0.01529f
C1046 VDD DLL_RESETN 2.47079f
C1047 a_26477_1842# VDD 0.86909f
C1048 a_7673_1842# VDD 0.49294f
C1049 a_4633_1842# DELAY_VBIASP 0.11222f
C1050 a_4763_1842# DELAY_VBIASN 0.07254f
C1051 a_6126_3816# a_9444_4590# 0.03029f
C1052 a_19550_1044# a_19963_1842# 0.01012f
C1053 a_16510_1044# a_18117_1842# 0.05231f
C1054 a_17351_1008# a_17357_1842# 0.02349f
C1055 a_22590_1044# a_23355_1044# 0.39037f
C1056 a_15108_5325# a_15464_3684# 0.12158f
C1057 a_3449_331# REF_CLK 0.01017f
C1058 a_20831_2470# VDD 0.01806f
C1059 a_6326_4590# a_5778_3367# 0.8779f
C1060 MUX_SEL4 MUX_SEL2 0.01978f
C1061 MUX_OUT MUX_SEL1 0.09357f
C1062 a_7288_1044# a_7364_1008# 0.01176f
C1063 a_19550_1044# a_20905_519# 0.02165f
C1064 a_10517_1842# a_10083_1842# 0.69698f
C1065 a_9444_4590# a_9712_3912# 0.39071f
C1066 a_2297_1395# VDD 0.46536f
C1067 a_15837_1842# a_15964_289# 0.02f
C1068 a_21353_1842# VDD 0.49285f
C1069 a_27563_1842# a_27671_2470# 0.01697f
C1070 a_16793_1842# a_16923_1842# 0.70845f
C1071 a_15464_3684# DELAY_OUT_LAST 0.02565f
C1072 a_9946_6305# a_10649_5878# 0.02432f
C1073 a_17553_1842# DELAY_VBIASP 0.11284f
C1074 a_17683_1842# DELAY_VBIASN 0.07847f
C1075 a_5957_1842# VDD 0.85848f
C1076 a_13470_1044# a_14825_519# 0.02058f
C1077 a_6854_5986# a_13132_5420# 0.01367f
C1078 a_16484_1008# a_15837_1842# 0.02011f
C1079 a_14111_5227# a_13880_5118# 0.12701f
C1080 a_13592_5423# a_14757_5182# 0.43239f
C1081 a_10404_1008# VDD 0.28633f
C1082 a_14751_2470# VDD 0.01806f
C1083 a_7390_1044# DELAY_VBIASN 0.02115f
C1084 MUX_SEL0 MUX_SEL2 0.01204f
C1085 a_9193_1842# a_9757_1842# 0.0114f
C1086 a_6126_3816# VDD 0.84141f
C1087 a_26043_1842# a_26151_2470# 0.01697f
C1088 a_19637_1842# VDD 0.86707f
C1089 a_15837_1842# a_16163_1842# 0.01427f
C1090 a_24951_1008# VDD 0.2822f
C1091 a_8997_1842# a_9465_1044# 0.2079f
C1092 a_15964_289# VDD 0.31312f
C1093 a_18877_1842# VDD 0.87825f
C1094 a_15837_1842# DELAY_VBIASP 0.04182f
C1095 a_16033_1842# DELAY_VBIASN 0.10793f
C1096 a_9712_3912# VDD 0.23242f
C1097 a_14964_1008# a_15077_1842# 0.02055f
C1098 a_12849_5867# a_12656_5864# 0.33075f
C1099 a_13306_6305# a_12355_5867# 0.26489f
C1100 a_19550_1044# a_20968_1044# 0.38994f
C1101 a_2019_311# a_15765_463# 0.05969f
C1102 a_8155_1044# VDD 0.15389f
C1103 a_27433_1842# a_27997_1842# 0.0114f
C1104 a_4350_1044# a_5115_1044# 0.39037f
C1105 a_7151_2470# a_7043_1842# 0.01697f
C1106 a_16484_1008# VDD 0.28597f
C1107 a_13470_1044# DELAY_VBIASN 0.02115f
C1108 a_10649_5878# VDD 0.23431f
C1109 a_13368_1044# a_13444_1008# 0.01176f
C1110 a_15077_1842# a_15273_1842# 0.77122f
C1111 a_23633_1842# a_24197_1842# 0.0114f
C1112 MUX_SEL4 a_3449_331# 0.05166f
C1113 a_22488_1044# VDD 0.17274f
C1114 a_16510_1044# a_2019_311# 0.03139f
C1115 a_15688_5403# VDD 0.30345f
C1116 a_9547_5942# a_9772_5843# 0.02416f
C1117 a_16163_1842# VDD 0.4973f
C1118 a_14317_1842# DELAY_VBIASN 0.09974f
C1119 a_25630_1044# a_27048_1044# 0.38994f
C1120 a_13470_1044# a_14317_1842# 0.08038f
C1121 a_11277_1842# a_10430_1044# 0.08038f
C1122 MUX_SEL4 a_12797_1842# 0.01829f
C1123 a_13132_5420# a_13306_5105# 0.27179f
C1124 a_3449_1395# REF_CLK 0.01058f
C1125 a_23111_2470# a_23003_1842# 0.01697f
C1126 VDD DELAY_VBIASP 14.6649f
C1127 a_5191_1008# VDD 0.28565f
C1128 a_26477_1842# a_27237_1842# 0.03319f
C1129 a_5631_2470# a_5523_1842# 0.01697f
C1130 a_14235_1044# VDD 0.15389f
C1131 a_8237_1842# a_7803_1842# 0.6972f
C1132 a_22677_1842# a_23437_1842# 0.01669f
C1133 a_2297_331# MUX_SEL2 0.10655f
C1134 a_19550_1044# VDD 0.89766f
C1135 a_13592_5423# VDD 0.11685f
C1136 a_18795_1044# a_18585_1044# 0.09424f
C1137 a_13753_1842# DELAY_VBIASN 0.0961f
C1138 a_14513_1842# VDD 0.49436f
C1139 a_24393_1842# a_24197_1842# 0.77122f
C1140 a_22590_1044# a_24665_1044# 0.03208f
C1141 a_13557_1842# DELAY_VBIASN 0.08375f
C1142 a_12363_1842# DELAY_VBIASP 0.06627f
C1143 a_9757_1842# a_9751_1008# 0.02354f
C1144 a_18117_1842# a_18585_1044# 0.2079f
C1145 a_21591_2470# a_21483_1842# 0.01697f
C1146 a_25717_1842# a_25283_1842# 0.69698f
C1147 a_13557_1842# a_13470_1044# 0.1088f
C1148 a_4111_2470# a_4003_1842# 0.01697f
C1149 a_11271_1008# VDD 0.28336f
C1150 a_13592_5871# a_14851_6228# 0.01529f
C1151 a_12849_5867# a_15304_4605# 0.0606f
C1152 a_6913_1842# a_7477_1842# 0.0114f
C1153 a_13753_1842# a_14317_1842# 0.0114f
C1154 a_21917_1842# a_21483_1842# 0.6972f
C1155 a_13557_1842# a_14317_1842# 0.01669f
C1156 a_12355_5867# REF_CLK 1.0042f
C1157 a_12656_5864# DLL_RESETN 0.11782f
C1158 a_26043_1842# a_25630_1044# 0.01012f
C1159 a_10843_1842# DELAY_VBIASN 0.07254f
C1160 a_10713_1842# DELAY_VBIASP 0.11222f
C1161 a_20071_2470# a_19963_1842# 0.01697f
C1162 a_24393_1842# a_24957_1842# 0.0114f
C1163 a_4437_1842# REF_CLK 0.05209f
C1164 a_13121_5831# a_15304_4605# 0.40921f
C1165 a_1256_1044# a_2297_1395# 0.04619f
C1166 a_13566_5835# a_14009_5878# 0.02242f
C1167 a_5957_1842# a_6717_1842# 0.02912f
C1168 a_1721_331# VDD 0.45259f
C1169 a_20593_1842# a_21157_1842# 0.0114f
C1170 a_14235_1044# a_14025_1044# 0.09424f
C1171 a_8808_1044# a_8237_1842# 0.10863f
C1172 a_22590_1044# a_24197_1842# 0.05231f
C1173 a_23431_1008# a_23437_1842# 0.02349f
C1174 a_13557_1842# a_13753_1842# 0.73897f
C1175 a_1544_289# a_2019_311# 0.01747f
C1176 a_10751_5878# DLL_RESETN 0.45018f
C1177 a_12993_1842# a_13123_1842# 0.70845f
C1178 a_24957_1842# a_25528_1044# 0.10864f
C1179 a_12037_1842# VDD 0.85848f
C1180 a_9193_1842# DELAY_VBIASN 0.0961f
C1181 a_8997_1842# DELAY_VBIASP 0.04141f
C1182 a_24957_1842# a_16108_289# 0.0157f
C1183 a_23763_1842# DELAY_VBIASP 0.06661f
C1184 a_5197_1842# a_4763_1842# 0.6972f
C1185 a_20105_1044# VDD 0.30409f
C1186 a_26395_1044# VDD 0.15389f
C1187 a_19637_1842# a_20397_1842# 0.01669f
C1188 a_3449_1395# MUX_SEL0 0.10753f
C1189 a_5115_1044# a_4905_1044# 0.09424f
C1190 REF_CLK MUX_SEL1 0.01858f
C1191 a_27237_1842# DELAY_VBIASP 0.06225f
C1192 a_27433_1842# DELAY_VBIASN 0.10734f
C1193 a_22564_1008# a_21917_1842# 0.02011f
C1194 a_25528_1044# a_25630_1044# 0.37183f
C1195 a_9772_5843# DLL_RESETN 0.06592f
C1196 a_25630_1044# a_16108_289# 0.55833f
C1197 a_24957_1842# a_22590_1044# 0.02479f
C1198 a_9323_1842# VDD 0.4973f
C1199 a_8433_1842# DELAY_VBIASP 0.11222f
C1200 a_15304_4605# DLL_RESETN 0.03137f
C1201 a_16108_289# a_16851_309# 0.06181f
C1202 a_22113_1842# DELAY_VBIASP 0.11286f
C1203 a_22243_1842# DELAY_VBIASN 0.08024f
C1204 a_11491_6228# a_12158_5867# 0.0894f
C1205 a_6326_4590# a_5974_5723# 0.33136f
C1206 a_7945_1044# VDD 0.30409f
C1207 MUX_OUT a_16108_289# 0.24265f
C1208 a_27563_1842# VDD 0.49811f
C1209 a_24523_1842# DELAY_VBIASP 0.06661f
C1210 a_25717_1842# DELAY_VBIASN 0.09106f
C1211 a_6913_1842# DELAY_VBIASN 0.0961f
C1212 a_6717_1842# DELAY_VBIASP 0.0414f
C1213 a_21044_1008# a_21157_1842# 0.02055f
C1214 a_24008_1044# a_24084_1008# 0.01176f
C1215 a_26185_1044# a_26395_1044# 0.09424f
C1216 a_7390_1044# a_9751_1008# 0.26208f
C1217 MUX_SEL4 MUX_OUT 0.91933f
C1218 a_11277_1842# a_11473_1842# 0.76914f
C1219 a_12907_5186# DLL_RESETN 0.02177f
C1220 a_16510_1044# a_18004_1008# 0.28279f
C1221 a_17275_1044# a_17351_1008# 0.01194f
C1222 a_18117_1842# a_17683_1842# 0.6972f
C1223 a_23437_1842# VDD 0.86909f
C1224 a_13019_5831# DELAY_OUT_LAST 0.08017f
C1225 a_20397_1842# DELAY_VBIASP 0.04176f
C1226 a_20593_1842# DELAY_VBIASN 0.10398f
C1227 a_10649_5878# a_10751_5878# 0.47795f
C1228 a_25913_1842# VDD 0.49294f
C1229 a_7043_1842# VDD 0.49723f
C1230 a_4003_1842# DELAY_VBIASP 0.05992f
C1231 a_5197_1842# DELAY_VBIASN 0.09974f
C1232 a_6854_5986# a_9444_4590# 0.02502f
C1233 a_4350_1044# a_4763_1842# 0.01012f
C1234 a_19550_1044# a_20397_1842# 0.08038f
C1235 a_15688_5867# a_13019_5831# 0.0195f
C1236 a_22590_1044# a_22564_1008# 0.277f
C1237 a_14851_5182# a_15464_3684# 0.04797f
C1238 a_20071_2470# VDD 0.01806f
C1239 a_7288_1044# a_7390_1044# 0.37183f
C1240 MUX_SEL4 MUX_SEL1 0.03574f
C1241 a_13106_5357# DLL_RESETN 0.01263f
C1242 a_9953_1842# a_10083_1842# 0.70845f
C1243 a_12791_1008# a_10430_1044# 0.26208f
C1244 a_9444_4590# a_9444_3912# 2.20289f
C1245 a_13306_6305# REF_CLK 0.05059f
C1246 a_16793_1842# a_17357_1842# 0.0114f
C1247 a_20723_1842# VDD 0.49671f
C1248 a_10517_1842# a_10985_1044# 0.19203f
C1249 a_12797_1842# DLL_RESETN 0.0106f
C1250 a_18795_1044# a_18871_1008# 0.01194f
C1251 a_8563_1842# a_8671_2470# 0.01697f
C1252 a_9946_6305# a_10232_5871# 0.41329f
C1253 a_16923_1842# DELAY_VBIASP 0.06661f
C1254 a_18117_1842# DELAY_VBIASN 0.09851f
C1255 a_5393_1842# VDD 0.49417f
C1256 a_14009_5084# a_13880_5118# 0.01562f
C1257 a_13991_2470# VDD 0.01806f
C1258 a_10430_1044# VDD 0.88416f
C1259 a_26477_1842# a_27124_1008# 0.02312f
C1260 MUX_SEL0 MUX_SEL1 3.14917f
C1261 a_5768_1044# a_5844_1008# 0.01176f
C1262 a_9444_4590# a_5778_3367# 0.19787f
C1263 a_6854_5986# VDD 1.20794f
C1264 a_13470_1044# a_15831_1008# 0.26208f
C1265 a_15837_1842# a_16597_1842# 0.06198f
C1266 a_19073_1842# VDD 0.49426f
C1267 MUX_OUT a_5731_289# 1.04829f
C1268 MUX_SEL4 a_8745_519# 0.04472f
C1269 a_24875_1044# VDD 0.15406f
C1270 a_9547_6172# a_9746_5805# 0.02437f
C1271 a_15765_463# VDD 0.35368f
C1272 a_18313_1842# VDD 0.49285f
C1273 a_15273_1842# DELAY_VBIASP 0.11297f
C1274 a_15403_1842# DELAY_VBIASN 0.08418f
C1275 a_9444_3912# VDD 0.0107f
C1276 a_13470_1044# a_15403_1842# 0.01012f
C1277 a_12849_5867# a_12355_5867# 0.07687f
C1278 a_19550_1044# a_20391_1008# 0.28268f
C1279 a_12363_1842# a_10430_1044# 0.01012f
C1280 a_14009_5084# a_14111_5227# 0.47622f
C1281 a_7364_1008# VDD 0.28633f
C1282 a_4350_1044# DELAY_VBIASN 0.02115f
C1283 a_15304_4605# a_13592_5423# 0.01817f
C1284 a_4350_1044# a_4324_1008# 0.277f
C1285 a_16510_1044# VDD 0.8795f
C1286 a_10232_5871# VDD 0.07206f
C1287 a_13368_1044# a_13470_1044# 0.37183f
C1288 a_23437_1842# a_23763_1842# 0.01427f
C1289 a_15077_1842# a_14643_1842# 0.6972f
C1290 MUX_OUT a_2297_331# 0.01179f
C1291 MUX_SEL4 a_2873_331# 0.04916f
C1292 a_21911_1008# VDD 0.2822f
C1293 a_15108_5325# VDD 0.13728f
C1294 a_9547_5942# a_9746_5805# 0.14994f
C1295 a_16597_1842# VDD 0.86876f
C1296 a_24951_1008# a_24665_1044# 0.01885f
C1297 a_25630_1044# a_26471_1008# 0.28268f
C1298 a_13121_5831# a_12355_5867# 0.05795f
C1299 VDD DELAY_OUT_LAST 0.70591f
C1300 a_5115_1044# VDD 0.15389f
C1301 a_26477_1842# a_26673_1842# 0.76914f
C1302 a_15108_6109# a_14851_6228# 0.29858f
C1303 a_13444_1008# VDD 0.28633f
C1304 a_7673_1842# a_7803_1842# 0.70845f
C1305 a_11848_1044# a_11924_1008# 0.01176f
C1306 a_22677_1842# a_22873_1842# 0.73897f
C1307 a_1544_289# MUX_SEL3 0.15976f
C1308 a_11195_1044# a_10985_1044# 0.09424f
C1309 a_1721_331# MUX_SEL2 0.01315f
C1310 a_19448_1044# VDD 0.17274f
C1311 a_13306_5105# VDD 0.79678f
C1312 a_15688_5867# VDD 0.30345f
C1313 a_5731_289# a_8745_519# 0.28635f
C1314 a_13883_1842# VDD 0.49742f
C1315 a_22590_1044# a_23145_1044# 0.03209f
C1316 a_12993_1842# DELAY_VBIASN 0.0961f
C1317 a_12797_1842# DELAY_VBIASP 0.0414f
C1318 a_12849_5867# a_14111_5227# 0.42064f
C1319 a_25153_1842# a_25283_1842# 0.70845f
C1320 a_14009_5878# a_14111_5878# 0.47795f
C1321 a_6717_1842# a_7043_1842# 0.01427f
C1322 a_21353_1842# a_21483_1842# 0.70845f
C1323 a_14009_5878# VDD 0.23872f
C1324 a_12355_5867# DLL_RESETN 0.04879f
C1325 a_20391_1008# a_20105_1044# 0.01885f
C1326 a_26477_1842# a_25630_1044# 0.08038f
C1327 a_13123_1842# VDD 0.49727f
C1328 a_10083_1842# DELAY_VBIASP 0.06627f
C1329 a_11277_1842# DELAY_VBIASN 0.09974f
C1330 a_13566_5835# a_13592_5871# 0.36952f
C1331 a_5957_1842# a_6153_1842# 0.77122f
C1332 a_1544_289# VDD 0.39113f
C1333 a_20397_1842# a_20723_1842# 0.01427f
C1334 MUX_SEL4 REF_CLK 0.0663f
C1335 a_13470_1044# a_15545_1044# 0.03208f
C1336 a_8231_1008# a_8237_1842# 0.02349f
C1337 a_21917_1842# a_16108_289# 0.0157f
C1338 a_1256_289# a_2019_311# 0.02904f
C1339 a_12993_1842# a_13557_1842# 0.0114f
C1340 a_24957_1842# a_24951_1008# 0.02354f
C1341 a_11473_1842# VDD 0.49417f
C1342 a_8563_1842# DELAY_VBIASN 0.07254f
C1343 a_24197_1842# DELAY_VBIASP 0.04177f
C1344 a_12849_5867# a_13306_6305# 0.12097f
C1345 a_4633_1842# a_4763_1842# 0.70845f
C1346 a_18585_1044# VDD 0.29722f
C1347 a_19637_1842# a_19833_1842# 0.73897f
C1348 a_8671_2470# VDD 0.01806f
C1349 a_4350_1044# a_6425_1044# 0.03208f
C1350 a_17791_2470# a_17683_1842# 0.01697f
C1351 REF_CLK MUX_SEL0 0.14089f
C1352 a_26673_1842# DELAY_VBIASP 0.11284f
C1353 a_26803_1842# DELAY_VBIASN 0.08024f
C1354 a_7803_1842# DELAY_VBIASP 0.06627f
C1355 a_7364_1008# a_6717_1842# 0.02011f
C1356 a_6854_5454# a_5864_3367# 0.03661f
C1357 a_12037_1842# a_12797_1842# 0.02912f
C1358 a_9757_1842# VDD 0.87771f
C1359 a_2297_1395# MUX_SEL1 0.01995f
C1360 a_15964_289# a_16851_309# 0.16757f
C1361 a_22677_1842# DELAY_VBIASN 0.0907f
C1362 a_21483_1842# DELAY_VBIASP 0.06661f
C1363 a_13121_5831# a_13306_6305# 0.01008f
C1364 a_11748_6109# a_12158_5867# 0.10373f
C1365 a_16271_2470# a_16163_1842# 0.01697f
C1366 MUX_SEL4 a_16108_289# 0.1283f
C1367 MUX_OUT a_15964_289# 0.01307f
C1368 a_27997_1842# VDD 0.76025f
C1369 a_24957_1842# DELAY_VBIASP 0.04176f
C1370 a_25153_1842# DELAY_VBIASN 0.10332f
C1371 a_16510_1044# a_17865_519# 0.02165f
C1372 a_6153_1842# DELAY_VBIASP 0.11222f
C1373 a_6283_1842# DELAY_VBIASN 0.07254f
C1374 a_5844_1008# a_5957_1842# 0.02055f
C1375 a_19550_1044# a_21483_1842# 0.01012f
C1376 a_25391_2470# VDD 0.01806f
C1377 a_7390_1044# a_9675_1044# 0.39036f
C1378 a_22590_1044# a_16108_289# 0.58202f
C1379 a_11277_1842# a_10843_1842# 0.6972f
C1380 a_16510_1044# a_17928_1044# 0.38994f
C1381 a_22873_1842# VDD 0.49294f
C1382 a_13019_5831# DELAY_VBIASN 1.23663f
C1383 a_17553_1842# a_17683_1842# 0.70845f
C1384 a_19963_1842# DELAY_VBIASN 0.08024f
C1385 a_19833_1842# DELAY_VBIASP 0.11284f
C1386 a_25630_1044# DELAY_VBIASP 0.01522f
C1387 a_12037_1842# a_12505_1044# 0.2079f
C1388 a_10649_5878# a_10520_6292# 0.01562f
C1389 a_10232_5871# a_10751_5878# 0.34102f
C1390 a_25283_1842# VDD 0.49737f
C1391 a_14751_2470# a_14643_1842# 0.01697f
C1392 a_7477_1842# VDD 0.86707f
C1393 a_4437_1842# DELAY_VBIASP 0.0414f
C1394 a_4633_1842# DELAY_VBIASN 0.0961f
C1395 a_4350_1044# a_5197_1842# 0.08038f
C1396 a_16510_1044# a_16923_1842# 0.01012f
C1397 a_14851_6228# a_13019_5831# 0.01651f
C1398 a_6854_5986# a_15304_4605# 0.08165f
C1399 a_22488_1044# a_22564_1008# 0.01176f
C1400 a_14851_5182# a_14757_5182# 0.28931f
C1401 a_19311_2470# VDD 0.01806f
C1402 a_9953_1842# a_10517_1842# 0.0114f
C1403 a_12715_1044# a_10430_1044# 0.39036f
C1404 a_12849_5867# REF_CLK 0.26382f
C1405 a_21157_1842# VDD 0.85848f
C1406 a_9946_6305# a_10206_5835# 0.75507f
C1407 a_26985_519# VDD 0.29292f
C1408 a_17357_1842# DELAY_VBIASP 0.04176f
C1409 a_17553_1842# DELAY_VBIASN 0.10734f
C1410 a_4763_1842# VDD 0.4973f
C1411 a_16408_1044# a_15837_1842# 0.10864f
C1412 a_13592_5871# a_13019_5831# 0.04178f
R0 VDD.n129 VDD.t229 17.3693
R1 VDD.n118 VDD.t155 17.3693
R2 VDD.n118 VDD.t26 17.3693
R3 VDD.n130 VDD.t163 17.3517
R4 VDD.n121 VDD.t156 17.3517
R5 VDD.n120 VDD.t95 17.3517
R6 VDD.n72 VDD.t76 17.2438
R7 VDD.n124 VDD.t137 17.2247
R8 VDD.n130 VDD.t220 17.0005
R9 VDD.n121 VDD.t90 17.0005
R10 VDD.n120 VDD.t132 17.0005
R11 VDD.t0 VDD.n99 4.19382
R12 VDD.n42 VDD.n43 0.189847
R13 VDD.n95 VDD.n94 0.149987
R14 VDD.t0 VDD.n94 2.39616
R15 VDD.n91 VDD.n53 0.149987
R16 VDD.n91 VDD.t0 2.39616
R17 VDD.n96 VDD.n88 0.149987
R18 VDD.t0 VDD.n88 2.39616
R19 VDD.n83 VDD.n50 0.149987
R20 VDD.n83 VDD.t0 2.39616
R21 VDD.n97 VDD.n80 0.149987
R22 VDD.t0 VDD.n80 2.39616
R23 VDD.n76 VDD.n47 0.149987
R24 VDD.t0 VDD.n76 2.39616
R25 VDD.t42 VDD.n37 2.05485
R26 VDD.n34 VDD.n65 0.448571
R27 VDD.n36 VDD.t57 15.1333
R28 VDD.n388 VDD.t60 15.0005
R29 VDD.n1 VDD.t55 15.0005
R30 VDD.n64 VDD.t41 15.0005
R31 VDD.n39 VDD.t47 15.0005
R32 VDD.n67 VDD.t12 17.9449
R33 VDD.n393 VDD.n392 9.51422
R34 VDD.n392 VDD.n391 9.17119
R35 VDD.n68 VDD.n67 0.341666
R36 VDD.n395 VDD.t381 9.02285
R37 VDD.n73 VDD.n74 0.0615821
R38 VDD.n115 VDD.n28 4.47071
R39 VDD.n114 VDD.t271 8.95516
R40 VDD.n148 VDD.t384 8.76154
R41 VDD.n12 VDD.t175 8.76154
R42 VDD.n12 VDD.t146 8.76154
R43 VDD.n12 VDD.t176 8.76154
R44 VDD.n11 VDD.t170 8.76154
R45 VDD.n149 VDD.t328 8.76154
R46 VDD.n44 VDD.t147 8.76154
R47 VDD.n150 VDD.t171 8.76154
R48 VDD.n72 VDD.t77 8.76154
R49 VDD.n108 VDD.t63 8.76054
R50 VDD.n108 VDD.t16 8.76054
R51 VDD.n148 VDD.t87 8.76054
R52 VDD.n12 VDD.t160 8.76054
R53 VDD.n12 VDD.t321 8.76054
R54 VDD.n12 VDD.t130 8.76054
R55 VDD.n11 VDD.t323 8.76054
R56 VDD.n149 VDD.t20 8.76054
R57 VDD.n44 VDD.t322 8.76054
R58 VDD.n150 VDD.t325 8.76054
R59 VDD.n94 VDD.n93 0.0442395
R60 VDD.n90 VDD.n91 0.0442395
R61 VDD.n88 VDD.n87 0.0442395
R62 VDD.n82 VDD.n83 0.0442395
R63 VDD.n80 VDD.n79 0.0442395
R64 VDD.n77 VDD.n76 0.0442395
R65 VDD VDD.t7 8.47732
R66 VDD.n46 VDD.n45 0.0953067
R67 VDD.t0 VDD.n46 4.19225
R68 VDD.t0 VDD.n41 3.34459
R69 VDD.n15 VDD.t0 0.282297
R70 VDD.t0 VDD.n9 0.793108
R71 VDD.t0 VDD.n18 1.13836
R72 VDD.n8 VDD.t0 0.793108
R73 VDD.n20 VDD.t0 1.13836
R74 VDD.t0 VDD.n6 0.793108
R75 VDD.t0 VDD.n21 0.315451
R76 VDD.n5 VDD.t0 0.793108
R77 VDD.n24 VDD.t0 1.13836
R78 VDD.t0 VDD.n3 0.793108
R79 VDD.t0 VDD.n26 1.13836
R80 VDD.t0 VDD.n10 0.793077
R81 VDD.t3 VDD.n56 4.20922
R82 VDD.t3 VDD.n60 4.20922
R83 VDD.t42 VDD.n57 1.61947
R84 VDD.t42 VDD.n34 0.894484
R85 VDD.t42 VDD.n73 8.47732
R86 VDD.n10 VDD.t410 7.62628
R87 VDD.n75 VDD.t409 7.62628
R88 VDD.n26 VDD.t408 7.62628
R89 VDD.n3 VDD.t407 7.62628
R90 VDD.n78 VDD.t406 7.62628
R91 VDD.n24 VDD.t405 7.62628
R92 VDD.n5 VDD.t404 7.62628
R93 VDD.n81 VDD.t403 7.62628
R94 VDD.n22 VDD.t402 7.62628
R95 VDD.n6 VDD.t401 7.62628
R96 VDD.n86 VDD.t400 7.62628
R97 VDD.n20 VDD.t399 7.62628
R98 VDD.n8 VDD.t398 7.62628
R99 VDD.n89 VDD.t397 7.62628
R100 VDD.n18 VDD.t396 7.62628
R101 VDD.n9 VDD.t395 7.62628
R102 VDD.n92 VDD.t394 7.62628
R103 VDD.n16 VDD.t393 7.62628
R104 VDD.n1 VDD.n30 3.11859
R105 VDD.n197 VDD.t136 6.09923
R106 VDD.n203 VDD.t313 6.09923
R107 VDD.n209 VDD.t67 6.09923
R108 VDD.n215 VDD.t277 6.09923
R109 VDD.n221 VDD.t187 6.09923
R110 VDD.n227 VDD.t19 6.09923
R111 VDD.n233 VDD.t81 6.09923
R112 VDD.n239 VDD.t27 6.09923
R113 VDD.n245 VDD.t74 6.09923
R114 VDD.n251 VDD.t167 6.09923
R115 VDD.n257 VDD.t94 6.09923
R116 VDD.n263 VDD.t264 6.09923
R117 VDD.n269 VDD.t15 6.09923
R118 VDD.n275 VDD.t195 6.09923
R119 VDD.n281 VDD.t217 6.09923
R120 VDD.n287 VDD.t158 6.09923
R121 VDD.n293 VDD.t134 6.09923
R122 VDD.n299 VDD.t141 6.09923
R123 VDD.n305 VDD.t129 6.09923
R124 VDD.n311 VDD.t113 6.09923
R125 VDD.n317 VDD.t333 6.09923
R126 VDD.n323 VDD.t256 6.09923
R127 VDD.n329 VDD.t121 6.09923
R128 VDD.n335 VDD.t23 6.09923
R129 VDD.n341 VDD.t119 6.09923
R130 VDD.n347 VDD.t244 6.09923
R131 VDD.n353 VDD.t91 6.09923
R132 VDD.n359 VDD.t120 6.09923
R133 VDD.n365 VDD.t255 6.09923
R134 VDD.n371 VDD.t4 6.09923
R135 VDD.n377 VDD.t10 6.09923
R136 VDD.n383 VDD.t68 6.09923
R137 VDD.n26 VDD.t188 5.99122
R138 VDD.n24 VDD.t75 5.99122
R139 VDD.n22 VDD.t263 5.99122
R140 VDD.n20 VDD.t334 5.99122
R141 VDD.n18 VDD.t267 5.99122
R142 VDD.n16 VDD.t85 5.99122
R143 VDD.n100 VDD.t164 5.98905
R144 VDD.n128 VDD.t318 5.9886
R145 VDD.n106 VDD.t65 5.97675
R146 VDD.n106 VDD.t18 5.97675
R147 VDD.n12 VDD.t186 5.97212
R148 VDD.n12 VDD.t223 5.97212
R149 VDD.n45 VDD.t329 5.97212
R150 VDD.n151 VDD.t347 5.97212
R151 VDD.n12 VDD.t366 5.97169
R152 VDD.n12 VDD.t131 5.97169
R153 VDD.n45 VDD.t21 5.97169
R154 VDD.n151 VDD.t340 5.97169
R155 VDD.n10 VDD.t227 5.97001
R156 VDD.n10 VDD.t380 5.97001
R157 VDD.n10 VDD.t269 5.97001
R158 VDD.n48 VDD.t191 5.97001
R159 VDD.n47 VDD.t190 5.97001
R160 VDD.n3 VDD.t243 5.97001
R161 VDD.n26 VDD.t194 5.97001
R162 VDD.n3 VDD.t161 5.97001
R163 VDD.n3 VDD.t125 5.97001
R164 VDD.n49 VDD.t352 5.97001
R165 VDD.n97 VDD.t351 5.97001
R166 VDD.n5 VDD.t241 5.97001
R167 VDD.n24 VDD.t355 5.97001
R168 VDD.n5 VDD.t1 5.97001
R169 VDD.n5 VDD.t14 5.97001
R170 VDD.n51 VDD.t233 5.97001
R171 VDD.n50 VDD.t232 5.97001
R172 VDD.n6 VDD.t204 5.97001
R173 VDD.n22 VDD.t236 5.97001
R174 VDD.n6 VDD.t83 5.97001
R175 VDD.n6 VDD.t212 5.97001
R176 VDD.n52 VDD.t372 5.97001
R177 VDD.n96 VDD.t371 5.97001
R178 VDD.n8 VDD.t242 5.97001
R179 VDD.n20 VDD.t375 5.97001
R180 VDD.n8 VDD.t270 5.97001
R181 VDD.n8 VDD.t71 5.97001
R182 VDD.n54 VDD.t180 5.97001
R183 VDD.n53 VDD.t179 5.97001
R184 VDD.n9 VDD.t203 5.97001
R185 VDD.n18 VDD.t183 5.97001
R186 VDD.n9 VDD.t78 5.97001
R187 VDD.n9 VDD.t127 5.97001
R188 VDD.n55 VDD.t358 5.97001
R189 VDD.n95 VDD.t357 5.97001
R190 VDD.n16 VDD.t361 5.97001
R191 VDD.n32 VDD.t368 5.96578
R192 VDD.n42 VDD.t145 5.96578
R193 VDD.n146 VDD.t169 5.96578
R194 VDD.n25 VDD.t221 5.96578
R195 VDD.n23 VDD.t72 5.96578
R196 VDD.n33 VDD.t369 5.96578
R197 VDD.n85 VDD.t224 5.96578
R198 VDD.n27 VDD.t123 5.96578
R199 VDD.n19 VDD.t69 5.96578
R200 VDD.n17 VDD.t338 5.96578
R201 VDD.n14 VDD.t213 5.96578
R202 VDD.n42 VDD.t320 5.96534
R203 VDD.n146 VDD.t324 5.96534
R204 VDD.n100 VDD.t174 5.96534
R205 VDD.n144 VDD.t206 5.96534
R206 VDD.n142 VDD.t173 5.96534
R207 VDD.n153 VDD.t239 5.96534
R208 VDD.n31 VDD.t390 5.96534
R209 VDD.n32 VDD.t199 5.96534
R210 VDD.n10 VDD.t6 5.96534
R211 VDD.n10 VDD.t376 5.96534
R212 VDD.n101 VDD.t379 5.96534
R213 VDD.n47 VDD.t116 5.96534
R214 VDD.n26 VDD.t88 5.96534
R215 VDD.n26 VDD.t343 5.96534
R216 VDD.n25 VDD.t197 5.96534
R217 VDD.n3 VDD.t25 5.96534
R218 VDD.n3 VDD.t207 5.96534
R219 VDD.n102 VDD.t28 5.96534
R220 VDD.n97 VDD.t210 5.96534
R221 VDD.n24 VDD.t89 5.96534
R222 VDD.n24 VDD.t168 5.96534
R223 VDD.n23 VDD.t24 5.96534
R224 VDD.n5 VDD.t93 5.96534
R225 VDD.n5 VDD.t114 5.96534
R226 VDD.n4 VDD.t265 5.96534
R227 VDD.n50 VDD.t201 5.96534
R228 VDD.n22 VDD.t117 5.96534
R229 VDD.n22 VDD.t383 5.96534
R230 VDD.n27 VDD.t337 5.96534
R231 VDD.n27 VDD.t260 5.96534
R232 VDD.n161 VDD.t73 5.96534
R233 VDD.n85 VDD.t157 5.96534
R234 VDD.n159 VDD.t184 5.96534
R235 VDD.n72 VDD.t133 5.96534
R236 VDD.n157 VDD.t80 5.96534
R237 VDD.n155 VDD.t142 5.96534
R238 VDD.n33 VDD.t196 5.96534
R239 VDD.n6 VDD.t82 5.96534
R240 VDD.n6 VDD.t177 5.96534
R241 VDD.n103 VDD.t112 5.96534
R242 VDD.n96 VDD.t209 5.96534
R243 VDD.n20 VDD.t198 5.96534
R244 VDD.n20 VDD.t326 5.96534
R245 VDD.n19 VDD.t362 5.96534
R246 VDD.n8 VDD.t122 5.96534
R247 VDD.n8 VDD.t115 5.96534
R248 VDD.n7 VDD.t22 5.96534
R249 VDD.n53 VDD.t202 5.96534
R250 VDD.n18 VDD.t200 5.96534
R251 VDD.n18 VDD.t245 5.96534
R252 VDD.n17 VDD.t237 5.96534
R253 VDD.n9 VDD.t144 5.96534
R254 VDD.n9 VDD.t5 5.96534
R255 VDD.n104 VDD.t139 5.96534
R256 VDD.n95 VDD.t11 5.96534
R257 VDD.n16 VDD.t240 5.96534
R258 VDD.n16 VDD.t257 5.96534
R259 VDD.n14 VDD.t208 5.96534
R260 VDD.n14 VDD.t9 5.96534
R261 VDD.n126 VDD.t272 5.96478
R262 VDD.n10 VDD.t228 5.65005
R263 VDD.n75 VDD.t189 5.65005
R264 VDD.n26 VDD.t192 5.65005
R265 VDD.n3 VDD.t124 5.65005
R266 VDD.n78 VDD.t162 5.65005
R267 VDD.n24 VDD.t353 5.65005
R268 VDD.n5 VDD.t13 5.65005
R269 VDD.n81 VDD.t2 5.65005
R270 VDD.n22 VDD.t234 5.65005
R271 VDD.n6 VDD.t205 5.65005
R272 VDD.n86 VDD.t84 5.65005
R273 VDD.n20 VDD.t373 5.65005
R274 VDD.n8 VDD.t70 5.65005
R275 VDD.n89 VDD.t178 5.65005
R276 VDD.n18 VDD.t181 5.65005
R277 VDD.n9 VDD.t126 5.65005
R278 VDD.n92 VDD.t79 5.65005
R279 VDD.n16 VDD.t359 5.65005
R280 VDD.t7 VDD.n394 5.62581
R281 VDD.t7 VDD.n396 5.62581
R282 VDD.t0 VDD.n154 5.62581
R283 VDD.t0 VDD.n152 5.62581
R284 VDD.t0 VDD.n145 5.62581
R285 VDD.n41 VDD.n149 0.160419
R286 VDD.t0 VDD.n13 1.07426
R287 VDD.n156 VDD.t0 5.62581
R288 VDD.n71 VDD.t0 1.79705
R289 VDD.n158 VDD.t0 5.62581
R290 VDD.n160 VDD.t0 5.62581
R291 VDD.t3 VDD.n196 5.62581
R292 VDD.t3 VDD.n202 5.62581
R293 VDD.t3 VDD.n208 5.62581
R294 VDD.t3 VDD.n214 5.62581
R295 VDD.t3 VDD.n220 5.62581
R296 VDD.t3 VDD.n226 5.62581
R297 VDD.t3 VDD.n232 5.62581
R298 VDD.t3 VDD.n238 5.62581
R299 VDD.t3 VDD.n244 5.62581
R300 VDD.t3 VDD.n250 5.62581
R301 VDD.t3 VDD.n256 5.62581
R302 VDD.t3 VDD.n262 5.62581
R303 VDD.t3 VDD.n268 5.62581
R304 VDD.t3 VDD.n274 5.62581
R305 VDD.t3 VDD.n280 5.62581
R306 VDD.t3 VDD.n286 5.62581
R307 VDD.t3 VDD.n292 5.62581
R308 VDD.t3 VDD.n298 5.62581
R309 VDD.t3 VDD.n304 5.62581
R310 VDD.t3 VDD.n310 5.62581
R311 VDD.t3 VDD.n316 5.62581
R312 VDD.t3 VDD.n322 5.62581
R313 VDD.t3 VDD.n328 5.62581
R314 VDD.t3 VDD.n334 5.62581
R315 VDD.t3 VDD.n340 5.62581
R316 VDD.t3 VDD.n346 5.62581
R317 VDD.t3 VDD.n352 5.62581
R318 VDD.t3 VDD.n358 5.62581
R319 VDD.t3 VDD.n364 5.62581
R320 VDD.t3 VDD.n370 5.62581
R321 VDD.t3 VDD.n376 5.62581
R322 VDD.t3 VDD.n382 5.62581
R323 VDD.t3 VDD.n384 5.62581
R324 VDD.t8 VDD.n123 5.61485
R325 VDD.t8 VDD.n127 5.61485
R326 VDD.n0 VDD.t53 5.7457
R327 VDD.n110 VDD.t43 5.60969
R328 VDD.n111 VDD.t48 5.60969
R329 VDD.n1 VDD.t56 5.71623
R330 VDD.n387 VDD.t62 5.60347
R331 VDD.n61 VDD.t59 5.60347
R332 VDD.n28 VDD.t46 5.60347
R333 VDD.n113 VDD.t51 5.60347
R334 VDD.n194 VDD.t284 5.59675
R335 VDD.n200 VDD.t292 5.59675
R336 VDD.n206 VDD.t290 5.59675
R337 VDD.n212 VDD.t281 5.59675
R338 VDD.n218 VDD.t280 5.59675
R339 VDD.n224 VDD.t289 5.59675
R340 VDD.n230 VDD.t293 5.59675
R341 VDD.n236 VDD.t294 5.59675
R342 VDD.n242 VDD.t300 5.59675
R343 VDD.n248 VDD.t298 5.59675
R344 VDD.n254 VDD.t297 5.59675
R345 VDD.n260 VDD.t295 5.59675
R346 VDD.n266 VDD.t288 5.59675
R347 VDD.n272 VDD.t302 5.59675
R348 VDD.n278 VDD.t301 5.59675
R349 VDD.n284 VDD.t305 5.59675
R350 VDD.n290 VDD.t304 5.59675
R351 VDD.n296 VDD.t286 5.59675
R352 VDD.n302 VDD.t303 5.59675
R353 VDD.n308 VDD.t285 5.59675
R354 VDD.n314 VDD.t299 5.59675
R355 VDD.n320 VDD.t283 5.59675
R356 VDD.n326 VDD.t287 5.59675
R357 VDD.n332 VDD.t306 5.59675
R358 VDD.n338 VDD.t282 5.59675
R359 VDD.n344 VDD.t308 5.59675
R360 VDD.n350 VDD.t307 5.59675
R361 VDD.n356 VDD.t309 5.59675
R362 VDD.n362 VDD.t296 5.59675
R363 VDD.n368 VDD.t310 5.59675
R364 VDD.n374 VDD.t311 5.59675
R365 VDD.n380 VDD.t312 5.59675
R366 VDD.n385 VDD.t58 5.59675
R367 VDD.n38 VDD.t291 5.59675
R368 VDD.n28 VDD.t44 5.59179
R369 VDD.n112 VDD.t49 5.59179
R370 VDD.n1 VDD.t54 5.59179
R371 VDD.n433 VDD.t32 4.9462
R372 VDD.n405 VDD.t29 4.9462
R373 VDD.n116 VDD.n115 4.90372
R374 VDD.t0 VDD.n147 4.19244
R375 VDD.t0 VDD.n43 3.32638
R376 VDD.t7 VDD.n397 4.19238
R377 VDD.t7 VDD.n425 4.19238
R378 VDD.t7 VDD.n135 4.19238
R379 VDD.n57 VDD.n28 0.406014
R380 VDD.n37 VDD.n74 0.379679
R381 VDD.t7 VDD.n140 4.19225
R382 VDD VDD.t8 1.47683
R383 VDD.t0 VDD.n98 3.3265
R384 VDD.n157 VDD.n71 0.341
R385 VDD.n84 VDD.t0 3.3265
R386 VDD.t8 VDD.n125 3.31226
R387 VDD.t8 VDD.n117 3.30706
R388 VDD.t8 VDD.n119 3.30706
R389 VDD.t8 VDD.n132 3.30688
R390 VDD VDD.n42 3.24041
R391 VDD.t8 VDD.n107 2.77509
R392 VDD.t0 VDD.n141 2.74446
R393 VDD.t0 VDD.n143 2.74446
R394 VDD.n15 VDD.n14 0.286705
R395 VDD.n161 VDD.n27 0.44578
R396 VDD.n27 VDD.n21 0.309939
R397 VDD.t3 VDD.n35 2.74414
R398 VDD.n2 VDD.n195 0.527937
R399 VDD.t7 VDD.n134 2.74386
R400 VDD.n1 VDD.n193 0.435597
R401 VDD.n435 VDD.t34 2.69937
R402 VDD.n403 VDD.t37 2.69937
R403 VDD.n401 VDD.t31 2.69937
R404 VDD.n427 VDD.t39 2.69937
R405 VDD.n431 VDD.t40 2.6992
R406 VDD.n429 VDD.t33 2.6992
R407 VDD.n399 VDD.t36 2.6992
R408 VDD.n407 VDD.t30 2.6992
R409 VDD.n412 VDD.t97 2.6992
R410 VDD.n411 VDD.t105 2.6992
R411 VDD.n417 VDD.t99 2.6992
R412 VDD.n416 VDD.t107 2.6992
R413 VDD.n422 VDD.t101 2.6992
R414 VDD.n421 VDD.t109 2.6992
R415 VDD.t7 VDD.n70 2.33382
R416 VDD.t7 VDD.n419 2.32432
R417 VDD.t3 VDD.n336 2.32432
R418 VDD.t3 VDD.n348 2.32432
R419 VDD.t3 VDD.n198 2.32425
R420 VDD.t3 VDD.n216 2.32425
R421 VDD.t3 VDD.n234 2.32425
R422 VDD.t3 VDD.n270 2.32425
R423 VDD.t7 VDD.n424 2.3242
R424 VDD.t3 VDD.n312 2.3242
R425 VDD.t3 VDD.n204 2.32417
R426 VDD.t3 VDD.n222 2.32417
R427 VDD.t3 VDD.n240 2.32417
R428 VDD.t3 VDD.n282 2.32417
R429 VDD.t3 VDD.n318 2.32417
R430 VDD.t3 VDD.n360 2.32417
R431 VDD.t3 VDD.n378 2.32417
R432 VDD.t7 VDD.n139 2.32417
R433 VDD.t7 VDD.n136 2.32417
R434 VDD.t42 VDD.n68 0.570319
R435 VDD.t3 VDD.n276 2.32417
R436 VDD.t3 VDD.n294 2.32417
R437 VDD.t3 VDD.n300 2.32417
R438 VDD.t3 VDD.n306 2.32417
R439 VDD.t3 VDD.n372 2.32417
R440 VDD.t3 VDD.n228 2.32414
R441 VDD.t3 VDD.n252 2.32414
R442 VDD.t3 VDD.n258 2.32414
R443 VDD.t3 VDD.n264 2.32414
R444 VDD.t3 VDD.n288 2.32414
R445 VDD.t3 VDD.n366 2.32414
R446 VDD.t7 VDD.n409 2.32406
R447 VDD.t7 VDD.n138 2.32406
R448 VDD.t3 VDD.n210 2.32406
R449 VDD.t3 VDD.n246 2.32406
R450 VDD.t3 VDD.n324 2.32406
R451 VDD.t3 VDD.n330 2.32406
R452 VDD.t3 VDD.n342 2.32406
R453 VDD.t3 VDD.n354 2.32406
R454 VDD.n14 VDD.t377 6.35403
R455 VDD.t7 VDD.n137 2.0061
R456 VDD.t7 VDD.n414 2.00592
R457 VDD.t7 VDD.n437 1.75938
R458 VDD.t3 VDD.n390 1.56886
R459 VDD.t3 VDD.n162 1.55381
R460 VDD.t3 VDD.n164 1.55381
R461 VDD.t3 VDD.n166 1.55381
R462 VDD.t3 VDD.n168 1.55381
R463 VDD.t3 VDD.n169 1.55381
R464 VDD.t3 VDD.n170 1.55381
R465 VDD.t3 VDD.n171 1.55381
R466 VDD.t3 VDD.n172 1.55381
R467 VDD.t3 VDD.n173 1.55381
R468 VDD.t3 VDD.n179 1.55381
R469 VDD.t3 VDD.n180 1.55381
R470 VDD.t3 VDD.n182 1.55381
R471 VDD.t3 VDD.n184 1.55381
R472 VDD.t3 VDD.n185 1.55381
R473 VDD.t3 VDD.n188 1.55381
R474 VDD.t3 VDD.n189 1.55381
R475 VDD.t3 VDD.n190 1.55381
R476 VDD.t3 VDD.n192 1.55381
R477 VDD.t3 VDD.n163 1.55341
R478 VDD.t3 VDD.n165 1.55341
R479 VDD.t3 VDD.n167 1.55341
R480 VDD.t3 VDD.n174 1.55341
R481 VDD.t3 VDD.n175 1.55341
R482 VDD.t3 VDD.n176 1.55341
R483 VDD.t3 VDD.n177 1.55341
R484 VDD.t3 VDD.n178 1.55341
R485 VDD.t3 VDD.n181 1.55341
R486 VDD.t3 VDD.n183 1.55341
R487 VDD.t3 VDD.n186 1.55341
R488 VDD.t3 VDD.n187 1.55341
R489 VDD.t3 VDD.n191 1.55341
R490 VDD.t8 VDD.n109 1.20461
R491 VDD.n68 VDD.n114 0.779651
R492 VDD.n412 VDD.n411 1.11007
R493 VDD.n417 VDD.n416 1.11007
R494 VDD.n422 VDD.n421 1.11007
R495 VDD.t7 VDD.n133 1.01993
R496 VDD.n129 VDD.n105 0.975304
R497 VDD.n105 VDD.n128 0.817678
R498 VDD.n392 VDD.n30 0.808112
R499 VDD.n116 VDD.n109 0.671512
R500 VDD.n109 VDD.n108 0.6645
R501 VDD.n393 VDD.n133 0.632886
R502 VDD.n391 VDD.n133 0.618267
R503 VDD.n436 VDD.n435 0.570444
R504 VDD.n401 VDD.n400 0.570444
R505 VDD.n429 VDD.n428 0.570274
R506 VDD.n408 VDD.n407 0.570274
R507 VDD.n413 VDD.n412 0.570274
R508 VDD.n418 VDD.n417 0.570274
R509 VDD.n423 VDD.n422 0.570274
R510 VDD.n431 VDD.n430 0.569912
R511 VDD.n399 VDD.n398 0.569912
R512 VDD.n411 VDD.n410 0.569912
R513 VDD.n416 VDD.n415 0.569912
R514 VDD.n421 VDD.n420 0.569912
R515 VDD.n403 VDD.n402 0.569733
R516 VDD.n427 VDD.n426 0.569733
R517 VDD.n29 VDD.n28 0.183807
R518 VDD.n112 VDD.n40 0.508375
R519 VDD.t8 VDD.n105 0.49685
R520 VDD.n194 VDD.n193 0.495398
R521 VDD.n200 VDD.n199 0.495398
R522 VDD.n206 VDD.n205 0.495398
R523 VDD.n212 VDD.n211 0.495398
R524 VDD.n218 VDD.n217 0.495398
R525 VDD.n224 VDD.n223 0.495398
R526 VDD.n230 VDD.n229 0.495398
R527 VDD.n236 VDD.n235 0.495398
R528 VDD.n242 VDD.n241 0.495398
R529 VDD.n248 VDD.n247 0.495398
R530 VDD.n254 VDD.n253 0.495398
R531 VDD.n260 VDD.n259 0.495398
R532 VDD.n266 VDD.n265 0.495398
R533 VDD.n272 VDD.n271 0.495398
R534 VDD.n278 VDD.n277 0.495398
R535 VDD.n284 VDD.n283 0.495398
R536 VDD.n290 VDD.n289 0.495398
R537 VDD.n296 VDD.n295 0.495398
R538 VDD.n302 VDD.n301 0.495398
R539 VDD.n308 VDD.n307 0.495398
R540 VDD.n314 VDD.n313 0.495398
R541 VDD.n320 VDD.n319 0.495398
R542 VDD.n326 VDD.n325 0.495398
R543 VDD.n332 VDD.n331 0.495398
R544 VDD.n338 VDD.n337 0.495398
R545 VDD.n344 VDD.n343 0.495398
R546 VDD.n350 VDD.n349 0.495398
R547 VDD.n356 VDD.n355 0.495398
R548 VDD.n362 VDD.n361 0.495398
R549 VDD.n368 VDD.n367 0.495398
R550 VDD.n374 VDD.n373 0.495398
R551 VDD.n380 VDD.n379 0.495398
R552 VDD.n385 VDD.n36 0.495398
R553 VDD.n38 VDD.n58 0.495398
R554 VDD.n404 VDD.n403 0.492175
R555 VDD.n434 VDD.n427 0.492175
R556 VDD.n432 VDD.n431 0.492005
R557 VDD.n406 VDD.n399 0.492005
R558 VDD.n432 VDD.n429 0.491643
R559 VDD.n407 VDD.n406 0.491643
R560 VDD.n435 VDD.n434 0.491464
R561 VDD.n404 VDD.n401 0.491464
R562 VDD.n195 VDD.n194 0.478641
R563 VDD.n201 VDD.n200 0.478641
R564 VDD.n207 VDD.n206 0.478641
R565 VDD.n213 VDD.n212 0.478641
R566 VDD.n219 VDD.n218 0.478641
R567 VDD.n225 VDD.n224 0.478641
R568 VDD.n231 VDD.n230 0.478641
R569 VDD.n237 VDD.n236 0.478641
R570 VDD.n243 VDD.n242 0.478641
R571 VDD.n249 VDD.n248 0.478641
R572 VDD.n255 VDD.n254 0.478641
R573 VDD.n261 VDD.n260 0.478641
R574 VDD.n267 VDD.n266 0.478641
R575 VDD.n273 VDD.n272 0.478641
R576 VDD.n279 VDD.n278 0.478641
R577 VDD.n285 VDD.n284 0.478641
R578 VDD.n291 VDD.n290 0.478641
R579 VDD.n297 VDD.n296 0.478641
R580 VDD.n303 VDD.n302 0.478641
R581 VDD.n309 VDD.n308 0.478641
R582 VDD.n315 VDD.n314 0.478641
R583 VDD.n321 VDD.n320 0.478641
R584 VDD.n327 VDD.n326 0.478641
R585 VDD.n333 VDD.n332 0.478641
R586 VDD.n339 VDD.n338 0.478641
R587 VDD.n345 VDD.n344 0.478641
R588 VDD.n351 VDD.n350 0.478641
R589 VDD.n357 VDD.n356 0.478641
R590 VDD.n363 VDD.n362 0.478641
R591 VDD.n369 VDD.n368 0.478641
R592 VDD.n375 VDD.n374 0.478641
R593 VDD.n381 VDD.n380 0.478641
R594 VDD.n59 VDD.n385 0.478641
R595 VDD.n40 VDD.n38 0.478641
R596 VDD.n193 VDD.n192 0.467341
R597 VDD.n205 VDD.n190 0.467341
R598 VDD.n211 VDD.n189 0.467341
R599 VDD.n217 VDD.n188 0.467341
R600 VDD.n235 VDD.n185 0.467341
R601 VDD.n241 VDD.n184 0.467341
R602 VDD.n253 VDD.n182 0.467341
R603 VDD.n265 VDD.n180 0.467341
R604 VDD.n271 VDD.n179 0.467341
R605 VDD.n307 VDD.n173 0.467341
R606 VDD.n313 VDD.n172 0.467341
R607 VDD.n319 VDD.n171 0.467341
R608 VDD.n325 VDD.n170 0.467341
R609 VDD.n331 VDD.n169 0.467341
R610 VDD.n337 VDD.n168 0.467341
R611 VDD.n349 VDD.n166 0.467341
R612 VDD.n361 VDD.n164 0.467341
R613 VDD.n373 VDD.n162 0.467341
R614 VDD.n199 VDD.n191 0.466909
R615 VDD.n223 VDD.n187 0.466909
R616 VDD.n229 VDD.n186 0.466909
R617 VDD.n247 VDD.n183 0.466909
R618 VDD.n259 VDD.n181 0.466909
R619 VDD.n277 VDD.n178 0.466909
R620 VDD.n283 VDD.n177 0.466909
R621 VDD.n289 VDD.n176 0.466909
R622 VDD.n295 VDD.n175 0.466909
R623 VDD.n301 VDD.n174 0.466909
R624 VDD.n343 VDD.n167 0.466909
R625 VDD.n355 VDD.n165 0.466909
R626 VDD.n367 VDD.n163 0.466909
R627 VDD.n205 VDD.n191 0.451022
R628 VDD.n229 VDD.n187 0.451022
R629 VDD.n235 VDD.n186 0.451022
R630 VDD.n253 VDD.n183 0.451022
R631 VDD.n265 VDD.n181 0.451022
R632 VDD.n283 VDD.n178 0.451022
R633 VDD.n289 VDD.n177 0.451022
R634 VDD.n295 VDD.n176 0.451022
R635 VDD.n301 VDD.n175 0.451022
R636 VDD.n307 VDD.n174 0.451022
R637 VDD.n349 VDD.n167 0.451022
R638 VDD.n361 VDD.n165 0.451022
R639 VDD.n373 VDD.n163 0.451022
R640 VDD.n199 VDD.n192 0.450618
R641 VDD.n211 VDD.n190 0.450618
R642 VDD.n217 VDD.n189 0.450618
R643 VDD.n223 VDD.n188 0.450618
R644 VDD.n241 VDD.n185 0.450618
R645 VDD.n247 VDD.n184 0.450618
R646 VDD.n259 VDD.n182 0.450618
R647 VDD.n271 VDD.n180 0.450618
R648 VDD.n277 VDD.n179 0.450618
R649 VDD.n313 VDD.n173 0.450618
R650 VDD.n319 VDD.n172 0.450618
R651 VDD.n325 VDD.n171 0.450618
R652 VDD.n331 VDD.n170 0.450618
R653 VDD.n337 VDD.n169 0.450618
R654 VDD.n343 VDD.n168 0.450618
R655 VDD.n355 VDD.n166 0.450618
R656 VDD.n367 VDD.n164 0.450618
R657 VDD.n379 VDD.n162 0.450618
R658 VDD.n61 VDD.n56 0.445771
R659 VDD.n437 VDD.n436 0.43335
R660 VDD.n73 VDD.n29 0.0930507
R661 VDD.n66 VDD.n113 0.429929
R662 VDD.n390 VDD.n389 0.429766
R663 VDD.n387 VDD.n386 0.427147
R664 VDD.n62 VDD.n61 0.427147
R665 VDD.n390 VDD.n386 0.426171
R666 VDD.n110 VDD.n28 0.413465
R667 VDD.n111 VDD.n58 0.413465
R668 VDD.n437 VDD.n69 0.403558
R669 VDD.t7 VDD.t8 0.383639
R670 VDD.n419 VDD.n418 0.372886
R671 VDD.n415 VDD.n138 0.372571
R672 VDD.n336 VDD.n335 0.355386
R673 VDD.n348 VDD.n347 0.355386
R674 VDD.n198 VDD.n197 0.355312
R675 VDD.n216 VDD.n215 0.355312
R676 VDD.n234 VDD.n233 0.355312
R677 VDD.n270 VDD.n269 0.355312
R678 VDD.n204 VDD.n203 0.355155
R679 VDD.n222 VDD.n221 0.355155
R680 VDD.n240 VDD.n239 0.355155
R681 VDD.n282 VDD.n281 0.355155
R682 VDD.n318 VDD.n317 0.355155
R683 VDD.n360 VDD.n359 0.355155
R684 VDD.n378 VDD.n377 0.355155
R685 VDD.n276 VDD.n275 0.35515
R686 VDD.n413 VDD.n409 0.355071
R687 VDD.n246 VDD.n245 0.355071
R688 VDD.n324 VDD.n323 0.355071
R689 VDD.n330 VDD.n329 0.355071
R690 VDD.n300 VDD.n299 0.35501
R691 VDD.n228 VDD.n227 0.354936
R692 VDD.n252 VDD.n251 0.354936
R693 VDD.n258 VDD.n257 0.354936
R694 VDD.n264 VDD.n263 0.354936
R695 VDD.n288 VDD.n287 0.354936
R696 VDD.n366 VDD.n365 0.354936
R697 VDD.n312 VDD.n311 0.354903
R698 VDD.n294 VDD.n293 0.354837
R699 VDD.n306 VDD.n305 0.354837
R700 VDD.n372 VDD.n371 0.354837
R701 VDD.n210 VDD.n209 0.354771
R702 VDD.n342 VDD.n341 0.354771
R703 VDD.n354 VDD.n353 0.354771
R704 VDD.n410 VDD.n136 0.354692
R705 VDD.n420 VDD.n139 0.347655
R706 VDD.n424 VDD.n423 0.347403
R707 VDD.n410 VDD.n137 0.347254
R708 VDD.n414 VDD.n413 0.346901
R709 VDD.n132 VDD.n129 0.335799
R710 VDD.n119 VDD.n118 0.335496
R711 VDD.n428 VDD.n424 0.334933
R712 VDD.n430 VDD.n139 0.334692
R713 VDD.n122 VDD.n119 0.332368
R714 VDD.n132 VDD.n131 0.332058
R715 VDD.n426 VDD.n70 0.33018
R716 VDD.n418 VDD.n414 0.329276
R717 VDD.n415 VDD.n137 0.328947
R718 VDD.n398 VDD.n136 0.327655
R719 VDD.t52 VDD.n0 15.0851
R720 VDD.n409 VDD.n408 0.327271
R721 VDD.n64 VDD.n110 0.327154
R722 VDD.n39 VDD.n111 0.327154
R723 VDD.n126 VDD.n125 0.32704
R724 VDD.n402 VDD.n134 0.319637
R725 VDD.n388 VDD.n387 0.313013
R726 VDD.n213 VDD.n210 0.310071
R727 VDD.n345 VDD.n342 0.310071
R728 VDD.n357 VDD.n354 0.310071
R729 VDD.n375 VDD.n372 0.31001
R730 VDD.n297 VDD.n294 0.31001
R731 VDD.n309 VDD.n306 0.31001
R732 VDD.n315 VDD.n312 0.309933
R733 VDD.n231 VDD.n228 0.309928
R734 VDD.n255 VDD.n252 0.309928
R735 VDD.n261 VDD.n258 0.309928
R736 VDD.n267 VDD.n264 0.309928
R737 VDD.n291 VDD.n288 0.309928
R738 VDD.n369 VDD.n366 0.309928
R739 VDD.n303 VDD.n300 0.309837
R740 VDD.n420 VDD.n138 0.309771
R741 VDD.n249 VDD.n246 0.309771
R742 VDD.n327 VDD.n324 0.309771
R743 VDD.n333 VDD.n330 0.309771
R744 VDD.n279 VDD.n276 0.309697
R745 VDD.n207 VDD.n204 0.309692
R746 VDD.n243 VDD.n240 0.309692
R747 VDD.n363 VDD.n360 0.309692
R748 VDD.n225 VDD.n222 0.309692
R749 VDD.n285 VDD.n282 0.309692
R750 VDD.n321 VDD.n318 0.309692
R751 VDD.n381 VDD.n378 0.309692
R752 VDD.n201 VDD.n198 0.309557
R753 VDD.n219 VDD.n216 0.309557
R754 VDD.n237 VDD.n234 0.309557
R755 VDD.n273 VDD.n270 0.309557
R756 VDD.n423 VDD.n419 0.309483
R757 VDD.n339 VDD.n336 0.309483
R758 VDD.n351 VDD.n348 0.309483
R759 VDD.n108 VDD.n107 0.306263
R760 VDD.n131 VDD 0.423614
R761 VDD.n117 VDD.n116 0.298721
R762 VDD.n379 VDD.n35 0.29124
R763 VDD.n2 VDD.t3 0.549206
R764 VDD.n142 VDD.n141 0.284268
R765 VDD.n125 VDD.n124 0.282613
R766 VDD.n143 VDD.n142 0.282549
R767 VDD.n98 VDD.n144 0.279247
R768 VDD.n84 VDD.n159 0.279247
R769 VDD.n2 VDD.n1 0.0990857
R770 VDD.n153 VDD.n141 0.268799
R771 VDD.n100 VDD.n98 0.267977
R772 VDD.n118 VDD.n117 0.260496
R773 VDD.n391 VDD.n134 0.259637
R774 VDD.n433 VDD.n432 0.253639
R775 VDD.n405 VDD.n404 0.253639
R776 VDD.n113 VDD.n58 0.25333
R777 VDD.n434 VDD.n433 0.253298
R778 VDD.n406 VDD.n405 0.253298
R779 VDD VDD.n70 0.250961
R780 VDD.n36 VDD.n35 0.243044
R781 VDD.n144 VDD.n143 0.241768
R782 VDD.n115 VDD.n74 4.71183
R783 VDD.n67 VDD.n66 0.706063
R784 VDD VDD.n69 0.521582
R785 VDD.n72 VDD.n71 0.484477
R786 VDD.n63 VDD.t50 15.0439
R787 VDD.n63 VDD.n58 0.130762
R788 VDD.n66 VDD.n40 0.291774
R789 VDD.n85 VDD.n84 0.222977
R790 VDD.n32 VDD.n31 0.251712
R791 VDD.n26 VDD.n25 0.251712
R792 VDD.n24 VDD.n23 0.251712
R793 VDD.n155 VDD.n33 0.251712
R794 VDD.n20 VDD.n19 0.251712
R795 VDD.n18 VDD.n17 0.251712
R796 VDD.n104 VDD.n9 0.272485
R797 VDD.n8 VDD.n7 0.272485
R798 VDD.n103 VDD.n6 0.272485
R799 VDD.n5 VDD.n4 0.272485
R800 VDD.n102 VDD.n3 0.272485
R801 VDD.n101 VDD.n10 0.272485
R802 VDD.n29 VDD.n65 0.109866
R803 VDD.n58 VDD.n57 0.0835447
R804 VDD.n40 VDD.n37 0.100238
R805 VDD.n128 VDD.n127 0.202075
R806 VDD.n408 VDD.n397 0.191793
R807 VDD.n398 VDD.n135 0.191793
R808 VDD.n434 VDD.n69 0.189333
R809 VDD.n428 VDD.n425 0.184552
R810 VDD.n430 VDD.n140 0.184424
R811 VDD.n147 VDD.n146 0.181058
R812 VDD.n400 VDD.n396 0.179888
R813 VDD.n127 VDD.n126 0.175486
R814 VDD.n124 VDD.n123 0.171736
R815 VDD.n395 VDD.n394 0.16955
R816 VDD.n384 VDD.n383 0.16955
R817 VDD.n151 VDD.n99 0.210474
R818 VDD.n196 VDD.n195 0.162388
R819 VDD.n226 VDD.n225 0.162388
R820 VDD.n238 VDD.n237 0.162388
R821 VDD.n244 VDD.n243 0.162388
R822 VDD.n262 VDD.n261 0.162388
R823 VDD.n292 VDD.n291 0.162388
R824 VDD.n310 VDD.n309 0.162388
R825 VDD.n322 VDD.n321 0.162388
R826 VDD.n328 VDD.n327 0.162388
R827 VDD.n346 VDD.n345 0.162388
R828 VDD.n382 VDD.n381 0.162388
R829 VDD.n202 VDD.n201 0.16205
R830 VDD.n208 VDD.n207 0.16205
R831 VDD.n214 VDD.n213 0.16205
R832 VDD.n220 VDD.n219 0.16205
R833 VDD.n232 VDD.n231 0.16205
R834 VDD.n250 VDD.n249 0.16205
R835 VDD.n256 VDD.n255 0.16205
R836 VDD.n268 VDD.n267 0.16205
R837 VDD.n274 VDD.n273 0.16205
R838 VDD.n280 VDD.n279 0.16205
R839 VDD.n286 VDD.n285 0.16205
R840 VDD.n298 VDD.n297 0.16205
R841 VDD.n304 VDD.n303 0.16205
R842 VDD.n316 VDD.n315 0.16205
R843 VDD.n334 VDD.n333 0.16205
R844 VDD.n340 VDD.n339 0.16205
R845 VDD.n352 VDD.n351 0.16205
R846 VDD.n358 VDD.n357 0.16205
R847 VDD.n364 VDD.n363 0.16205
R848 VDD.n370 VDD.n369 0.16205
R849 VDD.n376 VDD.n375 0.16205
R850 VDD.n426 VDD.n140 0.161924
R851 VDD.n436 VDD.n425 0.161793
R852 VDD.n30 VDD 0.485468
R853 VDD.n41 VDD.n11 0.0957379
R854 VDD.n148 VDD.n147 0.159043
R855 VDD.n154 VDD.n153 0.157388
R856 VDD.n161 VDD.n160 0.157388
R857 VDD.n157 VDD.n156 0.157388
R858 VDD.n400 VDD.n397 0.154552
R859 VDD.n402 VDD.n135 0.154552
R860 VDD.n131 VDD.n130 0.152808
R861 VDD.n122 VDD.n121 0.152808
R862 VDD.n122 VDD.n120 0.152808
R863 VDD.n150 VDD.n145 0.15205
R864 VDD.n158 VDD.n72 0.15205
R865 VDD.n123 VDD.n122 0.147075
R866 VDD.n46 VDD.n149 0.236924
R867 VDD.n152 VDD.n150 0.134888
R868 VDD.n45 VDD.n44 0.134618
R869 VDD.n389 VDD.n388 0.133259
R870 VDD.n65 VDD.n64 0.133259
R871 VDD.n100 VDD.n99 0.16225
R872 VDD.n77 VDD.n75 0.128884
R873 VDD.n79 VDD.n78 0.128884
R874 VDD.n82 VDD.n81 0.128884
R875 VDD.n87 VDD.n86 0.128884
R876 VDD.n90 VDD.n89 0.128884
R877 VDD.n93 VDD.n92 0.128884
R878 VDD.n107 VDD.n106 0.127973
R879 VDD.n13 VDD.n148 0.947265
R880 VDD.n60 VDD.n59 0.185493
R881 VDD.n160 VDD.n85 0.1583
R882 VDD.n93 VDD.n104 0.141235
R883 VDD.n7 VDD.n90 0.141235
R884 VDD.n87 VDD.n103 0.141235
R885 VDD.n4 VDD.n82 0.141235
R886 VDD.n79 VDD.n102 0.141235
R887 VDD.n77 VDD.n101 0.141235
R888 VDD.n62 VDD.n60 0.0613757
R889 VDD.n152 VDD.n151 0.12205
R890 VDD.n394 VDD.n393 0.119888
R891 VDD.n203 VDD.n202 0.117388
R892 VDD.n209 VDD.n208 0.117388
R893 VDD.n215 VDD.n214 0.117388
R894 VDD.n221 VDD.n220 0.117388
R895 VDD.n233 VDD.n232 0.117388
R896 VDD.n251 VDD.n250 0.117388
R897 VDD.n257 VDD.n256 0.117388
R898 VDD.n269 VDD.n268 0.117388
R899 VDD.n275 VDD.n274 0.117388
R900 VDD.n281 VDD.n280 0.117388
R901 VDD.n287 VDD.n286 0.117388
R902 VDD.n299 VDD.n298 0.117388
R903 VDD.n305 VDD.n304 0.117388
R904 VDD.n317 VDD.n316 0.117388
R905 VDD.n335 VDD.n334 0.117388
R906 VDD.n341 VDD.n340 0.117388
R907 VDD.n353 VDD.n352 0.117388
R908 VDD.n359 VDD.n358 0.117388
R909 VDD.n365 VDD.n364 0.117388
R910 VDD.n371 VDD.n370 0.117388
R911 VDD.n377 VDD.n376 0.117388
R912 VDD.n396 VDD.n395 0.11705
R913 VDD.n197 VDD.n196 0.11705
R914 VDD.n227 VDD.n226 0.11705
R915 VDD.n239 VDD.n238 0.11705
R916 VDD.n245 VDD.n244 0.11705
R917 VDD.n263 VDD.n262 0.11705
R918 VDD.n293 VDD.n292 0.11705
R919 VDD.n311 VDD.n310 0.11705
R920 VDD.n323 VDD.n322 0.11705
R921 VDD.n329 VDD.n328 0.11705
R922 VDD.n347 VDD.n346 0.11705
R923 VDD.n383 VDD.n382 0.11705
R924 VDD.n59 VDD.n384 0.114888
R925 VDD.n31 VDD.n154 0.1133
R926 VDD.n156 VDD.n155 0.1133
R927 VDD.n44 VDD.n145 0.104888
R928 VDD.n159 VDD.n158 0.101138
R929 VDD.n63 VDD.n112 0.340529
R930 VDD.n56 VDD.n36 0.257619
R931 VDD.n40 VDD.n39 0.251665
R932 VDD.n146 VDD.n43 0.24736
R933 VDD.n114 VDD.n58 0.205524
R934 VDD.n386 VDD.n62 0.146235
R935 VDD.n389 VDD.n56 0.146235
R936 VDD.n95 VDD.n55 0.224985
R937 VDD.n54 VDD.n53 0.224985
R938 VDD.n96 VDD.n52 0.224985
R939 VDD.n51 VDD.n50 0.224985
R940 VDD.n97 VDD.n49 0.224985
R941 VDD.n48 VDD.n47 0.224985
R942 VDD.n12 VDD.n11 0.211235
R943 VDD.n28 VDD.t45 15.0336
R944 VDD.n17 VDD.n9 1.20647
R945 VDD.n8 VDD.n19 1.20647
R946 VDD.n33 VDD.n6 1.20647
R947 VDD.n5 VDD.n23 1.20647
R948 VDD.n25 VDD.n3 1.20647
R949 VDD.n10 VDD.n32 1.20646
R950 VDD.n34 VDD.n28 1.17026
R951 VDD.n1 VDD.n0 1.10275
R952 VDD.n13 VDD.n12 0.134613
R953 VDD.n16 VDD.n15 0.432612
R954 VDD.n22 VDD.n21 0.409065
R955 VDD.n48 VDD.n26 1.01698
R956 VDD.n49 VDD.n24 1.01698
R957 VDD.n51 VDD.n22 1.01698
R958 VDD.n52 VDD.n20 1.01698
R959 VDD.n54 VDD.n18 1.01698
R960 VDD.n55 VDD.n16 1.01698
R961 VSS.t304 VSS.n522 119321
R962 VSS.n624 VSS.n623 22369.4
R963 VSS.n429 VSS.n300 7907.02
R964 VSS.n519 VSS.n201 4670.31
R965 VSS.n836 VSS.n835 3068.57
R966 VSS.t460 VSS.n64 310.202
R967 VSS.n69 VSS.n67 13.5064
R968 VSS.t115 VSS.n616 849.322
R969 VSS.n674 VSS.n673 572.005
R970 VSS.t567 VSS.t570 571.348
R971 VSS.n689 VSS.t519 566.691
R972 VSS.n688 VSS.t247 560.899
R973 VSS.n678 VSS.t22 550.193
R974 VSS.n705 VSS.t546 539.653
R975 VSS.t343 VSS.n686 532.819
R976 VSS.n708 VSS.t497 522.508
R977 VSS.n699 VSS.t565 521.236
R978 VSS.t455 VSS.n685 514.091
R979 VSS.n695 VSS.t480 504.839
R980 VSS.n681 VSS.t469 504.839
R981 VSS.n706 VSS.t498 491.87
R982 VSS.n690 VSS.t564 474.904
R983 VSS.t495 VSS.n627 470.019
R984 VSS.n222 VSS.n221 469.783
R985 VSS.n240 VSS.n239 469.783
R986 VSS.n258 VSS.n257 469.783
R987 VSS.n277 VSS.n276 469.783
R988 VSS.n291 VSS.n290 469.783
R989 VSS.n305 VSS.n304 469.783
R990 VSS.n691 VSS.t529 456.175
R991 VSS.n899 VSS.n898 454.007
R992 VSS.n227 VSS.n224 454.007
R993 VSS.n884 VSS.n883 454.007
R994 VSS.n875 VSS.n874 454.007
R995 VSS.n866 VSS.n865 454.007
R996 VSS.n857 VSS.n856 454.007
R997 VSS.n896 VSS.n895 453.986
R998 VSS.n230 VSS.n229 453.986
R999 VSS.n881 VSS.n880 453.986
R1000 VSS.n872 VSS.n871 453.986
R1001 VSS.n863 VSS.n862 453.986
R1002 VSS.n854 VSS.n853 453.986
R1003 VSS.n895 VSS.n213 453.986
R1004 VSS.n237 VSS.n230 453.986
R1005 VSS.n880 VSS.n244 453.986
R1006 VSS.n871 VSS.n267 453.986
R1007 VSS.n862 VSS.n281 453.986
R1008 VSS.n853 VSS.n295 453.986
R1009 VSS.t467 VSS.n253 448.228
R1010 VSS.t542 VSS.n193 442.469
R1011 VSS.t387 VSS.n195 437.62
R1012 VSS.n261 VSS.t24 431.863
R1013 VSS.t374 VSS.n62 427.695
R1014 VSS.n685 VSS.t269 427.219
R1015 VSS.t264 VSS.n262 419.459
R1016 VSS.t111 VSS.n302 413.68
R1017 VSS.t100 VSS.n288 413.68
R1018 VSS.t89 VSS.n274 413.68
R1019 VSS.t78 VSS.n255 413.68
R1020 VSS.t67 VSS.n236 413.68
R1021 VSS.t56 VSS.n219 413.68
R1022 VSS.n693 VSS.n692 412.791
R1023 VSS.n679 VSS.n70 412.791
R1024 VSS.n814 VSS.n813 412.522
R1025 VSS.n208 VSS.t388 403.072
R1026 VSS.t7 VSS.n706 401.591
R1027 VSS.n261 VSS.t466 397.313
R1028 VSS.n206 VSS.t464 391.555
R1029 VSS.t115 VSS.n815 388.781
R1030 VSS.t52 VSS.n213 385.798
R1031 VSS.t63 VSS.n237 385.798
R1032 VSS.t74 VSS.n244 385.798
R1033 VSS.t85 VSS.n267 385.798
R1034 VSS.t96 VSS.n281 385.798
R1035 VSS.t107 VSS.n295 385.798
R1036 VSS.n203 VSS.t615 384.887
R1037 VSS.n204 VSS.t408 380.038
R1038 VSS.t347 VSS.n63 375.276
R1039 VSS.t380 VSS.n693 372.094
R1040 VSS.t378 VSS.n679 372.094
R1041 VSS.t460 VSS.n698 363.339
R1042 VSS.t298 VSS.n684 363.339
R1043 VSS.t360 VSS.t114 359.769
R1044 VSS.t397 VSS.n199 357.007
R1045 VSS.n675 VSS.t493 347.49
R1046 VSS.t399 VSS.n197 333.974
R1047 VSS.n203 VSS.t386 333.065
R1048 VSS.t57 VSS.n219 333.063
R1049 VSS.t68 VSS.n236 333.063
R1050 VSS.t79 VSS.n255 333.063
R1051 VSS.t90 VSS.n274 333.063
R1052 VSS.t101 VSS.n288 333.063
R1053 VSS.n302 VSS.t112 333.063
R1054 VSS.t20 VSS.n631 329.238
R1055 VSS.n805 VSS.t567 327.81
R1056 VSS.t580 VSS.n191 322.457
R1057 VSS.n264 VSS.t135 322.457
R1058 VSS.t304 VSS.n834 314.327
R1059 VSS.n709 VSS.t496 313.659
R1060 VSS.n896 VSS.t50 305.183
R1061 VSS.n229 VSS.t61 305.183
R1062 VSS.n881 VSS.t72 305.183
R1063 VSS.n872 VSS.t83 305.183
R1064 VSS.n863 VSS.t94 305.183
R1065 VSS.n854 VSS.t105 305.183
R1066 VSS.t518 VSS.t473 304.42
R1067 VSS.t479 VSS.n696 304.42
R1068 VSS.t362 VSS.t40 304.42
R1069 VSS.t468 VSS.n682 304.42
R1070 VSS.t545 VSS.n708 299.735
R1071 VSS.n207 VSS.t541 299.425
R1072 VSS.n898 VSS.t47 293.666
R1073 VSS.t58 VSS.n227 293.666
R1074 VSS.n883 VSS.t69 293.666
R1075 VSS.n874 VSS.t80 293.666
R1076 VSS.n865 VSS.t91 293.666
R1077 VSS.n856 VSS.t102 293.666
R1078 VSS.n306 VSS.t450 292.757
R1079 VSS.t556 VSS.n287 292.757
R1080 VSS.t123 VSS.n273 292.757
R1081 VSS.t595 VSS.n251 292.757
R1082 VSS.t291 VSS.n254 292.757
R1083 VSS.t126 VSS.n235 292.757
R1084 VSS.t462 VSS.n218 292.757
R1085 VSS.t593 VSS.n189 292.757
R1086 VSS.t400 VSS.n695 291.37
R1087 VSS.t470 VSS.n681 291.37
R1088 VSS.n207 VSS.t616 287.909
R1089 VSS.n210 VSS.t376 275.505
R1090 VSS.t357 VSS.n193 269.724
R1091 VSS.t581 VSS.n191 264.875
R1092 VSS.n264 VSS.t137 264.875
R1093 VSS.t451 VSS.n300 258.238
R1094 VSS.n260 VSS.t292 258.236
R1095 VSS.n857 VSS.t557 258.233
R1096 VSS.n866 VSS.t124 258.233
R1097 VSS.n875 VSS.t596 258.233
R1098 VSS.n884 VSS.t127 258.233
R1099 VSS.n899 VSS.t594 258.233
R1100 VSS.n224 VSS.t463 258.233
R1101 VSS.t465 VSS.n196 258.231
R1102 VSS.t356 VSS.n197 253.359
R1103 VSS.t372 VSS.n98 252.375
R1104 VSS.t617 VSS.n110 252.375
R1105 VSS.t263 VSS.n119 252.375
R1106 VSS.t382 VSS.n125 252.375
R1107 VSS.n129 VSS.t270 252.375
R1108 VSS.t373 VSS.n131 252.375
R1109 VSS.n123 VSS.t125 252.375
R1110 VSS.t244 VSS.n139 252.375
R1111 VSS.n116 VSS.t606 252.375
R1112 VSS.n113 VSS.t249 252.375
R1113 VSS.t583 VSS.n150 252.375
R1114 VSS.t46 VSS.n105 252.375
R1115 VSS.t113 VSS.n104 252.375
R1116 VSS.n103 VSS.t413 252.375
R1117 VSS.n157 VSS.t369 252.375
R1118 VSS.n174 VSS.t588 252.374
R1119 VSS.n164 VSS.t566 252.374
R1120 VSS.t472 VSS.n130 252.117
R1121 VSS.t383 VSS.n133 252.117
R1122 VSS.n121 VSS.t41 252.117
R1123 VSS.t341 VSS.n138 252.117
R1124 VSS.t393 VSS.n140 252.117
R1125 VSS.t265 VSS.n114 252.117
R1126 VSS.t415 VSS.n111 252.117
R1127 VSS.t459 VSS.n109 252.117
R1128 VSS.n148 VSS.t499 252.117
R1129 VSS.t478 VSS.n106 252.117
R1130 VSS.n156 VSS.t375 252.117
R1131 VSS.n159 VSS.t412 252.117
R1132 VSS.n170 VSS.t396 252.115
R1133 VSS.n168 VSS.t605 252.115
R1134 VSS.n166 VSS.t34 252.115
R1135 VSS.t158 VSS.n348 250.837
R1136 VSS.t196 VSS.n349 250.837
R1137 VSS.t150 VSS.n353 250.837
R1138 VSS.t198 VSS.n354 250.837
R1139 VSS.t139 VSS.n358 250.837
R1140 VSS.t138 VSS.n359 250.837
R1141 VSS.t141 VSS.n363 250.837
R1142 VSS.t200 VSS.n364 250.837
R1143 VSS.t205 VSS.n368 250.837
R1144 VSS.t201 VSS.n369 250.837
R1145 VSS.t203 VSS.n373 250.837
R1146 VSS.t206 VSS.n374 250.837
R1147 VSS.t210 VSS.n378 250.837
R1148 VSS.t208 VSS.n379 250.837
R1149 VSS.t160 VSS.n383 250.837
R1150 VSS.t156 VSS.n384 250.837
R1151 VSS.t145 VSS.n388 250.837
R1152 VSS.t211 VSS.n389 250.837
R1153 VSS.t220 VSS.n393 250.837
R1154 VSS.t214 VSS.n394 250.837
R1155 VSS.t218 VSS.n398 250.837
R1156 VSS.t147 VSS.n399 250.837
R1157 VSS.t216 VSS.n403 250.837
R1158 VSS.t213 VSS.n404 250.837
R1159 VSS.t151 VSS.n408 250.837
R1160 VSS.t143 VSS.n409 250.837
R1161 VSS.t154 VSS.n413 250.837
R1162 VSS.t224 VSS.n414 250.837
R1163 VSS.t222 VSS.n418 250.837
R1164 VSS.t153 VSS.n419 250.837
R1165 VSS.t149 VSS.n423 250.837
R1166 VSS.t226 VSS.n424 250.837
R1167 VSS.t374 VSS.n64 148.06
R1168 VSS.n675 VSS.t20 243.244
R1169 VSS.n202 VSS.t354 240.956
R1170 VSS.t54 VSS.n220 240.956
R1171 VSS.t65 VSS.n238 240.956
R1172 VSS.t76 VSS.n256 240.956
R1173 VSS.t87 VSS.n275 240.956
R1174 VSS.t98 VSS.n289 240.956
R1175 VSS.t109 VSS.n303 240.956
R1176 VSS.n507 VSS.t621 234.114
R1177 VSS.n502 VSS.t603 234.114
R1178 VSS.n497 VSS.t562 234.114
R1179 VSS.n492 VSS.t42 234.114
R1180 VSS.n487 VSS.t384 234.114
R1181 VSS.n482 VSS.t512 234.114
R1182 VSS.n477 VSS.t607 234.114
R1183 VSS.n472 VSS.t368 234.114
R1184 VSS.n467 VSS.t349 234.114
R1185 VSS.n462 VSS.t273 234.114
R1186 VSS.n457 VSS.t540 234.114
R1187 VSS.n452 VSS.t32 234.114
R1188 VSS.n447 VSS.t487 234.114
R1189 VSS.n442 VSS.t345 234.114
R1190 VSS.n437 VSS.t504 234.114
R1191 VSS.n432 VSS.t456 234.114
R1192 VSS.t407 VSS.n199 230.327
R1193 VSS.n221 VSS.t54 229.44
R1194 VSS.n239 VSS.t65 229.44
R1195 VSS.n257 VSS.t76 229.44
R1196 VSS.n276 VSS.t87 229.44
R1197 VSS.n290 VSS.t98 229.44
R1198 VSS.n304 VSS.t109 229.44
R1199 VSS.t354 VSS.n201 228.827
R1200 VSS.t394 VSS.n127 225.361
R1201 VSS.t604 VSS.n134 225.361
R1202 VSS.t563 VSS.n120 225.361
R1203 VSS.t385 VSS.n141 225.361
R1204 VSS.t513 VSS.n142 225.361
R1205 VSS.t608 VSS.n144 225.361
R1206 VSS.t350 VSS.n107 225.361
R1207 VSS.t539 VSS.n152 225.361
R1208 VSS.t30 VSS.n154 225.361
R1209 VSS.t488 VSS.n101 225.361
R1210 VSS.t503 VSS.n97 225.361
R1211 VSS.n179 VSS.t622 225.359
R1212 VSS.n177 VSS.t44 225.359
R1213 VSS.n175 VSS.t367 225.359
R1214 VSS.n173 VSS.t271 225.359
R1215 VSS.n165 VSS.t346 225.359
R1216 VSS.t493 VSS.n674 224.516
R1217 VSS.t594 VSS.n189 212.143
R1218 VSS.t463 VSS.n218 212.143
R1219 VSS.t127 VSS.n235 212.143
R1220 VSS.t292 VSS.n254 212.143
R1221 VSS.t596 VSS.n251 212.143
R1222 VSS.t124 VSS.n273 212.143
R1223 VSS.t557 VSS.n287 212.143
R1224 VSS.n306 VSS.t451 212.143
R1225 VSS.n178 VSS.t425 211.982
R1226 VSS.n172 VSS.t444 211.982
R1227 VSS.n167 VSS.t475 211.982
R1228 VSS.n128 VSS.t437 211.982
R1229 VSS.n135 VSS.t279 211.982
R1230 VSS.n136 VSS.t419 211.982
R1231 VSS.t447 VSS.n118 211.982
R1232 VSS.t35 VSS.n117 211.982
R1233 VSS.n143 VSS.t431 211.982
R1234 VSS.n145 VSS.t553 211.982
R1235 VSS.t404 VSS.n108 211.982
R1236 VSS.n149 VSS.t416 211.982
R1237 VSS.n153 VSS.t585 211.982
R1238 VSS.n155 VSS.t434 211.982
R1239 VSS.t13 VSS.n99 211.982
R1240 VSS.n160 VSS.t441 211.982
R1241 VSS.n707 VSS.t7 208.828
R1242 VSS.n204 VSS.t407 207.294
R1243 VSS.n709 VSS.t545 202.362
R1244 VSS.n694 VSS.t380 202.071
R1245 VSS.n680 VSS.t378 202.071
R1246 VSS.n198 VSS.t356 200.649
R1247 VSS.n624 VSS.n0 197.518
R1248 VSS.n699 VSS.t347 196.911
R1249 VSS.n696 VSS.t400 196.399
R1250 VSS.n682 VSS.t470 196.399
R1251 VSS.n206 VSS.t465 195.778
R1252 VSS.t391 VSS.n124 195.26
R1253 VSS.t118 VSS.n132 195.26
R1254 VSS.t410 VSS.n122 195.26
R1255 VSS.t619 VSS.n137 195.26
R1256 VSS.t266 VSS.n115 195.26
R1257 VSS.t510 VSS.n112 195.26
R1258 VSS.t506 VSS.n146 195.26
R1259 VSS.t300 VSS.n147 195.26
R1260 VSS.t293 VSS.n151 195.26
R1261 VSS.t515 VSS.n102 195.26
R1262 VSS.t352 VSS.n100 195.26
R1263 VSS.t500 VSS.n158 195.26
R1264 VSS.t9 VSS.n96 195.26
R1265 VSS.n176 VSS.t133 195.26
R1266 VSS.n171 VSS.t549 195.26
R1267 VSS.n169 VSS.t289 195.26
R1268 VSS.t376 VSS.n190 194.899
R1269 VSS.n816 VSS.t115 194.514
R1270 VSS.t137 VSS.n252 189.137
R1271 VSS.n210 VSS.t581 189.135
R1272 VSS.t496 VSS.n625 187.895
R1273 VSS.n508 VSS.t624 187.292
R1274 VSS.n503 VSS.t5 187.292
R1275 VSS.n498 VSS.t521 187.292
R1276 VSS.n493 VSS.t38 187.292
R1277 VSS.n488 VSS.t492 187.292
R1278 VSS.n483 VSS.t358 187.292
R1279 VSS.n478 VSS.t561 187.292
R1280 VSS.n473 VSS.t543 187.292
R1281 VSS.n468 VSS.t489 187.292
R1282 VSS.n463 VSS.t245 187.292
R1283 VSS.n458 VSS.t589 187.292
R1284 VSS.n453 VSS.t491 187.292
R1285 VSS.n448 VSS.t552 187.292
R1286 VSS.n443 VSS.t527 187.292
R1287 VSS.n438 VSS.t250 187.292
R1288 VSS.n433 VSS.t551 187.292
R1289 VSS.n208 VSS.t357 184.262
R1290 VSS.t401 VSS.n691 183.975
R1291 VSS.n697 VSS.t479 182.797
R1292 VSS.n683 VSS.t468 182.797
R1293 VSS.n6 VSS.t16 177.713
R1294 VSS.n190 VSS.t593 177.617
R1295 VSS.n252 VSS.t595 177.617
R1296 VSS.n223 VSS.t462 177.615
R1297 VSS.n241 VSS.t126 177.615
R1298 VSS.n259 VSS.t291 177.615
R1299 VSS.n278 VSS.t123 177.615
R1300 VSS.n292 VSS.t556 177.615
R1301 VSS.t450 VSS.n301 177.615
R1302 VSS.t482 VSS.n352 173.913
R1303 VSS.t598 VSS.n357 173.913
R1304 VSS.n362 VSS.t255 173.913
R1305 VSS.t440 VSS.n367 173.913
R1306 VSS.t258 VSS.n372 173.913
R1307 VSS.n377 VSS.t275 173.913
R1308 VSS.n382 VSS.t283 173.913
R1309 VSS.n387 VSS.t129 173.913
R1310 VSS.t229 VSS.n392 173.913
R1311 VSS.n397 VSS.t403 173.913
R1312 VSS.t423 VSS.n402 173.913
R1313 VSS.t278 VSS.n407 173.913
R1314 VSS.t429 VSS.n412 173.913
R1315 VSS.t3 VSS.n417 173.913
R1316 VSS.t485 VSS.n422 173.913
R1317 VSS.t601 VSS.n427 173.913
R1318 VSS.n430 VSS.n429 173.913
R1319 VSS.t19 VSS.n678 167.954
R1320 VSS.t438 VSS.t390 163.881
R1321 VSS.t426 VSS.t119 163.881
R1322 VSS.t280 VSS.t409 163.881
R1323 VSS.t420 VSS.t620 163.881
R1324 VSS.t448 VSS.t131 163.881
R1325 VSS.t36 VSS.t268 163.881
R1326 VSS.t432 VSS.t509 163.881
R1327 VSS.t554 VSS.t508 163.881
R1328 VSS.t405 VSS.t302 163.881
R1329 VSS.t417 VSS.t294 163.881
R1330 VSS.t445 VSS.t548 163.881
R1331 VSS.t586 VSS.t288 163.881
R1332 VSS.t435 VSS.t514 163.881
R1333 VSS.t476 VSS.t351 163.881
R1334 VSS.t14 VSS.t501 163.881
R1335 VSS.t442 VSS.t11 163.881
R1336 VSS.n211 VSS.t47 160.341
R1337 VSS.n228 VSS.t58 160.341
R1338 VSS.n242 VSS.t69 160.341
R1339 VSS.n265 VSS.t80 160.341
R1340 VSS.n279 VSS.t91 160.341
R1341 VSS.n293 VSS.t102 160.341
R1342 VSS.t536 VSS.n183 157.601
R1343 VSS.n184 VSS.t534 156.464
R1344 VSS.t342 VSS.n128 155.126
R1345 VSS.t531 VSS.n135 155.126
R1346 VSS.t231 VSS.n136 155.126
R1347 VSS.t458 VSS.n118 155.126
R1348 VSS.t340 VSS.n117 155.126
R1349 VSS.t17 VSS.n143 155.126
R1350 VSS.t457 VSS.n145 155.126
R1351 VSS.t505 VSS.n108 155.126
R1352 VSS.t523 VSS.n149 155.126
R1353 VSS.t579 VSS.n153 155.126
R1354 VSS.t286 VSS.n155 155.126
R1355 VSS.t584 VSS.n99 155.126
R1356 VSS.t359 VSS.n160 155.126
R1357 VSS.n178 VSS.t474 155.125
R1358 VSS.n172 VSS.t623 155.125
R1359 VSS.n167 VSS.t262 155.125
R1360 VSS.n597 VSS.t315 154.613
R1361 VSS.n608 VSS.t322 154.613
R1362 VSS.t541 VSS.n194 153.971
R1363 VSS.n184 VSS.t29 153.851
R1364 VSS.n517 VSS.t559 153.846
R1365 VSS.n508 VSS.t481 153.846
R1366 VSS.n503 VSS.t597 153.846
R1367 VSS.n498 VSS.t254 153.846
R1368 VSS.n493 VSS.t439 153.846
R1369 VSS.n488 VSS.t257 153.846
R1370 VSS.n483 VSS.t274 153.846
R1371 VSS.n478 VSS.t282 153.846
R1372 VSS.n473 VSS.t128 153.846
R1373 VSS.n468 VSS.t228 153.846
R1374 VSS.n463 VSS.t402 153.846
R1375 VSS.n458 VSS.t422 153.846
R1376 VSS.n453 VSS.t277 153.846
R1377 VSS.n448 VSS.t428 153.846
R1378 VSS.n443 VSS.t2 153.846
R1379 VSS.n438 VSS.t484 153.846
R1380 VSS.n433 VSS.t600 153.846
R1381 VSS.t537 VSS.n95 153.236
R1382 VSS.t616 VSS.n195 149.713
R1383 VSS.t50 VSS.n211 148.826
R1384 VSS.t61 VSS.n228 148.826
R1385 VSS.t72 VSS.n242 148.826
R1386 VSS.t83 VSS.n265 148.826
R1387 VSS.t94 VSS.n279 148.826
R1388 VSS.t105 VSS.n293 148.826
R1389 VSS.t344 VSS.n3 147.452
R1390 VSS.t525 VSS.n351 147.157
R1391 VSS.t522 VSS.n356 147.157
R1392 VSS.t25 VSS.n361 147.157
R1393 VSS.t592 VSS.n366 147.157
R1394 VSS.t494 VSS.n371 147.157
R1395 VSS.t582 VSS.n376 147.157
R1396 VSS.t414 VSS.n381 147.157
R1397 VSS.t490 VSS.n386 147.157
R1398 VSS.t471 VSS.n391 147.157
R1399 VSS.t544 VSS.n396 147.157
R1400 VSS.t502 VSS.n401 147.157
R1401 VSS.t285 VSS.n406 147.157
R1402 VSS.t524 VSS.n411 147.157
R1403 VSS.t287 VSS.n416 147.157
R1404 VSS.t0 VSS.n421 147.157
R1405 VSS.t121 VSS.n426 147.157
R1406 VSS.t338 VSS.n161 145.091
R1407 VSS.t269 VSS.n69 148.06
R1408 VSS.t473 VSS.n697 138.607
R1409 VSS.t40 VSS.n683 138.607
R1410 VSS.t334 VSS.n161 138.403
R1411 VSS.t112 VSS.n301 137.311
R1412 VSS.n292 VSS.t101 137.311
R1413 VSS.n278 VSS.t90 137.311
R1414 VSS.n259 VSS.t79 137.311
R1415 VSS.n241 VSS.t68 137.311
R1416 VSS.n223 VSS.t57 137.311
R1417 VSS.t386 VSS.n202 137.309
R1418 VSS.n673 VSS.n633 132.891
R1419 VSS.n163 VSS.t334 131.972
R1420 VSS.n192 VSS.t580 130.939
R1421 VSS.t135 VSS.n263 130.939
R1422 VSS.n843 VSS.t295 127.421
R1423 VSS.t183 VSS.n1 125.359
R1424 VSS.t591 VSS.n839 123.674
R1425 VSS.n625 VSS.n624 122.129
R1426 VSS.n627 VSS.t360 121.858
R1427 VSS.t534 VSS.n95 120.691
R1428 VSS.n205 VSS.t399 119.422
R1429 VSS.n181 VSS.t535 118.249
R1430 VSS.n430 VSS.t338 117.058
R1431 VSS.n838 VSS.t370 116.177
R1432 VSS.t529 VSS.n690 115.831
R1433 VSS.n69 VSS.t298 310.202
R1434 VSS.t530 VSS.n617 112.174
R1435 VSS.t371 VSS.n841 108.683
R1436 VSS.n673 VSS.n672 107.177
R1437 VSS.n510 VSS.t342 107.023
R1438 VSS.n507 VSS.t525 107.023
R1439 VSS.t474 VSS.n505 107.023
R1440 VSS.n502 VSS.t522 107.023
R1441 VSS.n500 VSS.t531 107.023
R1442 VSS.n497 VSS.t25 107.023
R1443 VSS.n495 VSS.t231 107.023
R1444 VSS.n492 VSS.t592 107.023
R1445 VSS.n490 VSS.t458 107.023
R1446 VSS.n487 VSS.t494 107.023
R1447 VSS.n485 VSS.t340 107.023
R1448 VSS.n482 VSS.t582 107.023
R1449 VSS.n480 VSS.t17 107.023
R1450 VSS.n477 VSS.t414 107.023
R1451 VSS.n475 VSS.t457 107.023
R1452 VSS.n472 VSS.t490 107.023
R1453 VSS.n470 VSS.t505 107.023
R1454 VSS.n467 VSS.t471 107.023
R1455 VSS.n465 VSS.t523 107.023
R1456 VSS.n462 VSS.t544 107.023
R1457 VSS.t623 VSS.n460 107.023
R1458 VSS.n457 VSS.t502 107.023
R1459 VSS.n455 VSS.t579 107.023
R1460 VSS.n452 VSS.t285 107.023
R1461 VSS.n450 VSS.t286 107.023
R1462 VSS.n447 VSS.t524 107.023
R1463 VSS.t262 VSS.n445 107.023
R1464 VSS.n442 VSS.t287 107.023
R1465 VSS.n440 VSS.t584 107.023
R1466 VSS.n437 VSS.t0 107.023
R1467 VSS.n435 VSS.t359 107.023
R1468 VSS.n432 VSS.t121 107.023
R1469 VSS.t252 VSS.n836 106.808
R1470 VSS.n704 VSS.t495 103.538
R1471 VSS.n711 VSS.t366 103.379
R1472 VSS.n517 VSS.t328 100.335
R1473 VSS.t481 VSS.n351 100.335
R1474 VSS.t597 VSS.n356 100.335
R1475 VSS.t254 VSS.n361 100.335
R1476 VSS.t439 VSS.n366 100.335
R1477 VSS.t257 VSS.n371 100.335
R1478 VSS.t274 VSS.n376 100.335
R1479 VSS.t282 VSS.n381 100.335
R1480 VSS.t128 VSS.n386 100.335
R1481 VSS.t228 VSS.n391 100.335
R1482 VSS.t402 VSS.n396 100.335
R1483 VSS.t422 VSS.n401 100.335
R1484 VSS.t277 VSS.n406 100.335
R1485 VSS.t428 VSS.n411 100.335
R1486 VSS.t2 VSS.n416 100.335
R1487 VSS.t484 VSS.n421 100.335
R1488 VSS.t600 VSS.n426 100.335
R1489 VSS.n597 VSS.t318 99.7511
R1490 VSS.t324 VSS.n608 99.7511
R1491 VSS.n710 VSS.t260 98.4633
R1492 VSS.t318 VSS.n1 97.9276
R1493 VSS.n5 VSS.t324 97.9273
R1494 VSS.t564 VSS.n689 97.5777
R1495 VSS.t27 VSS.n845 97.4396
R1496 VSS.n200 VSS.t397 96.3896
R1497 VSS.n183 VSS.t297 93.8889
R1498 VSS.n845 VSS.t253 93.6919
R1499 VSS.n163 VSS.t601 88.4947
R1500 VSS.n180 VSS.t532 88.4111
R1501 VSS.t497 VSS.n707 88.3462
R1502 VSS.n170 VSS.t423 88.2366
R1503 VSS.n168 VSS.t278 88.2366
R1504 VSS.n166 VSS.t3 88.2366
R1505 VSS.n130 VSS.t482 88.2359
R1506 VSS.n133 VSS.t598 88.2359
R1507 VSS.t255 VSS.n121 88.2359
R1508 VSS.n138 VSS.t440 88.2359
R1509 VSS.n140 VSS.t258 88.2359
R1510 VSS.t275 VSS.n114 88.2359
R1511 VSS.t283 VSS.n111 88.2359
R1512 VSS.t129 VSS.n109 88.2359
R1513 VSS.n148 VSS.t229 88.2359
R1514 VSS.t403 VSS.n106 88.2359
R1515 VSS.n156 VSS.t429 88.2359
R1516 VSS.n159 VSS.t485 88.2359
R1517 VSS.n429 VSS.n92 88.4708
R1518 VSS.t328 VSS.t558 86.957
R1519 VSS.t559 VSS.t330 86.957
R1520 VSS.t480 VSS.n694 85.7923
R1521 VSS.t469 VSS.n680 85.7923
R1522 VSS.t615 VSS.n200 84.8733
R1523 VSS.t532 VSS.n519 83.0562
R1524 VSS.n841 VSS.t533 82.449
R1525 VSS.t498 VSS.n705 81.2384
R1526 VSS.n2 VSS.t183 80.4712
R1527 VSS.n559 VSS.t611 77.8798
R1528 VSS.n814 VSS.t528 77.2751
R1529 VSS.t547 VSS.t363 77.2751
R1530 VSS.n815 VSS.t114 75.4357
R1531 VSS.t533 VSS.n182 75.2962
R1532 VSS.t590 VSS.n838 74.9537
R1533 VSS.t558 VSS.n126 74.8587
R1534 VSS.n640 VSS.t618 74.7824
R1535 VSS.t408 VSS.n198 73.9692
R1536 VSS.t364 VSS.n618 73.536
R1537 VSS.n623 VSS.n619 73.536
R1538 VSS.n510 VSS.t438 70.2346
R1539 VSS.n505 VSS.t426 70.2346
R1540 VSS.n500 VSS.t280 70.2346
R1541 VSS.n495 VSS.t420 70.2346
R1542 VSS.n490 VSS.t448 70.2346
R1543 VSS.n485 VSS.t36 70.2346
R1544 VSS.n480 VSS.t432 70.2346
R1545 VSS.n475 VSS.t554 70.2346
R1546 VSS.n470 VSS.t405 70.2346
R1547 VSS.n465 VSS.t417 70.2346
R1548 VSS.n460 VSS.t445 70.2346
R1549 VSS.n455 VSS.t586 70.2346
R1550 VSS.n450 VSS.t435 70.2346
R1551 VSS.n445 VSS.t476 70.2346
R1552 VSS.n440 VSS.t14 70.2346
R1553 VSS.n435 VSS.t442 70.2346
R1554 VSS.n548 VSS.t234 69.1047
R1555 VSS.n220 VSS.t52 68.211
R1556 VSS.n238 VSS.t63 68.211
R1557 VSS.n256 VSS.t74 68.211
R1558 VSS.n275 VSS.t85 68.211
R1559 VSS.n289 VSS.t96 68.211
R1560 VSS.n303 VSS.t107 68.211
R1561 VSS.n839 VSS.t590 67.4583
R1562 VSS.t613 VSS.n529 66.9109
R1563 VSS.n509 VSS.t391 66.8901
R1564 VSS.t624 VSS.n349 66.8901
R1565 VSS.n504 VSS.t118 66.8901
R1566 VSS.t5 VSS.n354 66.8901
R1567 VSS.n499 VSS.t410 66.8901
R1568 VSS.t521 VSS.n359 66.8901
R1569 VSS.n494 VSS.t619 66.8901
R1570 VSS.t38 VSS.n364 66.8901
R1571 VSS.t133 VSS.n489 66.8901
R1572 VSS.t492 VSS.n369 66.8901
R1573 VSS.n484 VSS.t266 66.8901
R1574 VSS.t358 VSS.n374 66.8901
R1575 VSS.n479 VSS.t510 66.8901
R1576 VSS.t561 VSS.n379 66.8901
R1577 VSS.n474 VSS.t506 66.8901
R1578 VSS.t543 VSS.n384 66.8901
R1579 VSS.n469 VSS.t300 66.8901
R1580 VSS.t489 VSS.n389 66.8901
R1581 VSS.n464 VSS.t293 66.8901
R1582 VSS.t245 VSS.n394 66.8901
R1583 VSS.t549 VSS.n459 66.8901
R1584 VSS.t589 VSS.n399 66.8901
R1585 VSS.t289 VSS.n454 66.8901
R1586 VSS.t491 VSS.n404 66.8901
R1587 VSS.n449 VSS.t515 66.8901
R1588 VSS.t552 VSS.n409 66.8901
R1589 VSS.n444 VSS.t352 66.8901
R1590 VSS.t527 VSS.n414 66.8901
R1591 VSS.n439 VSS.t500 66.8901
R1592 VSS.t250 VSS.n419 66.8901
R1593 VSS.n434 VSS.t9 66.8901
R1594 VSS.t551 VSS.n424 66.8901
R1595 VSS.t173 VSS.n666 65.3689
R1596 VSS.n672 VSS.t162 65.3649
R1597 VSS.t297 VSS.n843 63.7107
R1598 VSS.t253 VSS.n844 62.4441
R1599 VSS.n665 VSS.t177 62.1539
R1600 VSS.t464 VSS.n205 61.8407
R1601 VSS.n623 VSS.n622 59.3547
R1602 VSS.n846 VSS.t27 58.6964
R1603 VSS.n739 VSS.t239 58.1358
R1604 VSS.t618 VSS.n633 58.1084
R1605 VSS.n5 VSS.t344 58.0284
R1606 VSS.n686 VSS.t455 57.9156
R1607 VSS.t466 VSS.n253 56.6734
R1608 VSS.n222 VSS.t56 56.0825
R1609 VSS.n240 VSS.t67 56.0825
R1610 VSS.n258 VSS.t78 56.0825
R1611 VSS.n277 VSS.t89 56.0825
R1612 VSS.n291 VSS.t100 56.0825
R1613 VSS.n305 VSS.t111 56.0825
R1614 VSS.n553 VSS.t236 55.942
R1615 VSS.t169 VSS.n668 55.7361
R1616 VSS.n670 VSS.t167 55.7328
R1617 VSS.t535 VSS.n180 54.6841
R1618 VSS.t304 VSS.n23 53.7482
R1619 VSS.n640 VSS.t117 52.3478
R1620 VSS.t565 VSS.n62 51.2456
R1621 VSS.t388 VSS.n192 50.3244
R1622 VSS.n263 VSS.t264 50.3244
R1623 VSS.t437 VSS.n348 50.1677
R1624 VSS.t425 VSS.n353 50.1677
R1625 VSS.t279 VSS.n358 50.1677
R1626 VSS.t419 VSS.n363 50.1677
R1627 VSS.n368 VSS.t447 50.1677
R1628 VSS.n373 VSS.t35 50.1677
R1629 VSS.t431 VSS.n378 50.1677
R1630 VSS.t553 VSS.n383 50.1677
R1631 VSS.n388 VSS.t404 50.1677
R1632 VSS.t416 VSS.n393 50.1677
R1633 VSS.t444 VSS.n398 50.1677
R1634 VSS.t585 VSS.n403 50.1677
R1635 VSS.t434 VSS.n408 50.1677
R1636 VSS.t475 VSS.n413 50.1677
R1637 VSS.n418 VSS.t13 50.1677
R1638 VSS.t441 VSS.n423 50.1677
R1639 VSS.t307 VSS.n545 49.3606
R1640 VSS.n842 VSS.t371 47.4535
R1641 VSS.t612 VSS.n558 47.1669
R1642 VSS.n729 VSS.t614 47.1669
R1643 VSS.n710 VSS.t364 46.116
R1644 VSS.t165 VSS.n670 46.1011
R1645 VSS.n668 VSS.t171 46.1002
R1646 VSS.t232 VSS.n537 44.9731
R1647 VSS.n698 VSS.t518 44.1903
R1648 VSS.n684 VSS.t362 44.1903
R1649 VSS.t322 VSS.n2 43.0632
R1650 VSS.t315 VSS.n0 43.0619
R1651 VSS.t528 VSS.n617 42.3769
R1652 VSS.t370 VSS.n837 39.9582
R1653 VSS.t175 VSS.n665 39.6781
R1654 VSS.n687 VSS.t343 39.1873
R1655 VSS.n549 VSS.t232 38.3917
R1656 VSS.n512 VSS.t394 36.7898
R1657 VSS.t622 VSS.n506 36.7898
R1658 VSS.n501 VSS.t604 36.7898
R1659 VSS.n496 VSS.t563 36.7898
R1660 VSS.t44 VSS.n491 36.7898
R1661 VSS.n486 VSS.t385 36.7898
R1662 VSS.n481 VSS.t513 36.7898
R1663 VSS.n476 VSS.t608 36.7898
R1664 VSS.t367 VSS.n471 36.7898
R1665 VSS.n466 VSS.t350 36.7898
R1666 VSS.t271 VSS.n461 36.7898
R1667 VSS.n456 VSS.t539 36.7898
R1668 VSS.n451 VSS.t30 36.7898
R1669 VSS.n446 VSS.t488 36.7898
R1670 VSS.t346 VSS.n441 36.7898
R1671 VSS.n436 VSS.t503 36.7898
R1672 VSS.n835 VSS.t304 36.5305
R1673 VSS.n666 VSS.t175 36.467
R1674 VSS.n837 VSS.t252 36.2105
R1675 VSS.n719 VSS.t612 36.1979
R1676 VSS.t614 VSS.n531 36.1979
R1677 VSS.n182 VSS.t591 34.07
R1678 VSS.n764 VSS.t307 34.0042
R1679 VSS.t546 VSS.n704 33.9067
R1680 VSS.t366 VSS.n618 31.1596
R1681 VSS.n671 VSS.t165 30.0475
R1682 VSS.t171 VSS.n667 30.0435
R1683 VSS.t295 VSS.n842 28.7152
R1684 VSS.n836 VSS.n181 28.3058
R1685 VSS.t390 VSS.n129 28.2938
R1686 VSS.t119 VSS.n131 28.2938
R1687 VSS.t131 VSS.n139 28.2938
R1688 VSS.t509 VSS.n113 28.2938
R1689 VSS.t294 VSS.n150 28.2938
R1690 VSS.t288 VSS.n104 28.2938
R1691 VSS.t514 VSS.n103 28.2938
R1692 VSS.t409 VSS.n123 28.2938
R1693 VSS.t620 VSS.n119 28.2938
R1694 VSS.t268 VSS.n116 28.2938
R1695 VSS.t508 VSS.n110 28.2938
R1696 VSS.t548 VSS.n105 28.2938
R1697 VSS.t351 VSS.n157 28.2938
R1698 VSS.t501 VSS.n98 28.2938
R1699 VSS.t302 VSS.n174 28.2936
R1700 VSS.t11 VSS.n164 28.2936
R1701 VSS.n126 VSS.t537 28.0352
R1702 VSS.t16 VSS.n3 27.7523
R1703 VSS.t247 VSS.n687 27.6043
R1704 VSS.t236 VSS.n533 27.4228
R1705 VSS.n194 VSS.t542 27.2918
R1706 VSS.t239 VSS.n552 25.229
R1707 VSS.t363 VSS.n622 24.4565
R1708 VSS.n711 VSS.t530 22.3643
R1709 VSS.t519 VSS.n688 22.2881
R1710 VSS.n631 VSS.t22 22.2881
R1711 VSS.n262 VSS.t467 22.1486
R1712 VSS.t24 VSS.n260 22.1466
R1713 VSS.t330 VSS.n125 21.6048
R1714 VSS.t260 VSS.n619 21.1887
R1715 VSS.t167 VSS.n669 20.4143
R1716 VSS.n669 VSS.t169 20.4093
R1717 VSS.t621 VSS.n352 20.0674
R1718 VSS.t603 VSS.n357 20.0674
R1719 VSS.t562 VSS.n362 20.0674
R1720 VSS.t42 VSS.n367 20.0674
R1721 VSS.t384 VSS.n372 20.0674
R1722 VSS.t512 VSS.n377 20.0674
R1723 VSS.t607 VSS.n382 20.0674
R1724 VSS.t368 VSS.n387 20.0674
R1725 VSS.t349 VSS.n392 20.0674
R1726 VSS.t273 VSS.n397 20.0674
R1727 VSS.t540 VSS.n402 20.0674
R1728 VSS.t32 VSS.n407 20.0674
R1729 VSS.t487 VSS.n412 20.0674
R1730 VSS.t345 VSS.n417 20.0674
R1731 VSS.t504 VSS.n422 20.0674
R1732 VSS.t456 VSS.n427 20.0674
R1733 VSS.t115 VSS.t117 19.9423
R1734 VSS.n179 VSS.t472 18.0025
R1735 VSS.n177 VSS.t341 18.0025
R1736 VSS.n176 VSS.t244 18.0025
R1737 VSS.n175 VSS.t459 18.0025
R1738 VSS.n173 VSS.t478 18.0025
R1739 VSS.n171 VSS.t46 18.0025
R1740 VSS.n169 VSS.t113 18.0025
R1741 VSS.t34 VSS.n165 18.0025
R1742 VSS.n127 VSS.t382 18.0017
R1743 VSS.t270 VSS.n124 18.0017
R1744 VSS.n132 VSS.t373 18.0017
R1745 VSS.n134 VSS.t383 18.0017
R1746 VSS.t125 VSS.n122 18.0017
R1747 VSS.t41 VSS.n120 18.0017
R1748 VSS.n137 VSS.t263 18.0017
R1749 VSS.n141 VSS.t393 18.0017
R1750 VSS.t606 VSS.n115 18.0017
R1751 VSS.n142 VSS.t265 18.0017
R1752 VSS.t249 VSS.n112 18.0017
R1753 VSS.n144 VSS.t415 18.0017
R1754 VSS.n146 VSS.t617 18.0017
R1755 VSS.t588 VSS.n147 18.0017
R1756 VSS.t499 VSS.n107 18.0017
R1757 VSS.n151 VSS.t583 18.0017
R1758 VSS.t396 VSS.n152 18.0017
R1759 VSS.t605 VSS.n154 18.0017
R1760 VSS.t413 VSS.n102 18.0017
R1761 VSS.t375 VSS.n101 18.0017
R1762 VSS.t369 VSS.n100 18.0017
R1763 VSS.n158 VSS.t372 18.0017
R1764 VSS.t412 VSS.n97 18.0017
R1765 VSS.t566 VSS.n96 18.0017
R1766 VSS.t29 VSS.n846 17.4722
R1767 VSS.n94 VSS.n520 17.0005
R1768 VSS.n94 VSS.n838 17.0005
R1769 VSS.n94 VSS.n839 17.0005
R1770 VSS.n94 VSS.n841 17.0005
R1771 VSS.n94 VSS.n843 17.0005
R1772 VSS.n94 VSS.n845 17.0005
R1773 VSS.n94 VSS.n518 17.0005
R1774 VSS.n94 VSS.t560 17.0005
R1775 VSS.n847 VSS.n94 17.0005
R1776 VSS.n94 VSS.n162 17.0005
R1777 VSS.n297 VSS.n295 17.0005
R1778 VSS.n852 VSS.n296 17.0005
R1779 VSS.n855 VSS.n854 17.0005
R1780 VSS.n856 VSS.n855 17.0005
R1781 VSS.n283 VSS.n281 17.0005
R1782 VSS.n861 VSS.n282 17.0005
R1783 VSS.n864 VSS.n863 17.0005
R1784 VSS.n865 VSS.n864 17.0005
R1785 VSS.n269 VSS.n267 17.0005
R1786 VSS.n870 VSS.n268 17.0005
R1787 VSS.n873 VSS.n872 17.0005
R1788 VSS.n874 VSS.n873 17.0005
R1789 VSS.n876 VSS.n264 17.0005
R1790 VSS.n876 VSS.n261 17.0005
R1791 VSS.n246 VSS.n244 17.0005
R1792 VSS.n879 VSS.n245 17.0005
R1793 VSS.n882 VSS.n881 17.0005
R1794 VSS.n883 VSS.n882 17.0005
R1795 VSS.n237 VSS.n231 17.0005
R1796 VSS.n888 VSS.n226 17.0005
R1797 VSS.n229 VSS.n225 17.0005
R1798 VSS.n227 VSS.n225 17.0005
R1799 VSS.n215 VSS.n213 17.0005
R1800 VSS.n894 VSS.n214 17.0005
R1801 VSS.n897 VSS.n896 17.0005
R1802 VSS.n898 VSS.n897 17.0005
R1803 VSS.n900 VSS.n191 17.0005
R1804 VSS.n900 VSS.n208 17.0005
R1805 VSS.n900 VSS.n207 17.0005
R1806 VSS.n900 VSS.n195 17.0005
R1807 VSS.n900 VSS.n206 17.0005
R1808 VSS.n900 VSS.n197 17.0005
R1809 VSS.n900 VSS.n204 17.0005
R1810 VSS.n900 VSS.n199 17.0005
R1811 VSS.n94 VSS.n343 17.0005
R1812 VSS.n94 VSS.n345 17.0005
R1813 VSS.t348 VSS.n699 17.0005
R1814 VSS.t348 VSS.n64 13.5064
R1815 VSS.n698 VSS.t381 17.0005
R1816 VSS.n696 VSS.t381 17.0005
R1817 VSS.n693 VSS.t381 17.0005
R1818 VSS.n690 VSS.n67 17.0005
R1819 VSS.n686 VSS.n67 17.0005
R1820 VSS.n684 VSS.t379 17.0005
R1821 VSS.n682 VSS.t379 17.0005
R1822 VSS.n679 VSS.t379 17.0005
R1823 VSS.n678 VSS.n677 17.0005
R1824 VSS.n677 VSS.n675 17.0005
R1825 VSS.t8 VSS.n814 17.0005
R1826 VSS.t8 VSS.n617 17.0005
R1827 VSS.t8 VSS.n618 17.0005
R1828 VSS.t8 VSS.n710 17.0005
R1829 VSS.t8 VSS.n619 17.0005
R1830 VSS.t8 VSS.n709 17.0005
R1831 VSS.n641 VSS.n640 17.0005
R1832 VSS.n815 VSS.t8 17.0005
R1833 VSS.t8 VSS.n627 17.0005
R1834 VSS.t8 VSS.n705 17.0005
R1835 VSS.n7 VSS.n584 17.0005
R1836 VSS.n7 VSS.n588 17.0005
R1837 VSS.n7 VSS.n591 17.0005
R1838 VSS.n7 VSS.n607 17.0005
R1839 VSS.n7 VSS.n605 17.0005
R1840 VSS.n7 VSS.n4 17.0005
R1841 VSS.n582 VSS.n7 17.0005
R1842 VSS.n712 VSS.n12 17.0005
R1843 VSS.n765 VSS.n12 17.0005
R1844 VSS.n545 VSS.n12 17.0005
R1845 VSS.n764 VSS.n12 17.0005
R1846 VSS.n761 VSS.n12 17.0005
R1847 VSS.n762 VSS.n12 17.0005
R1848 VSS.n753 VSS.n12 17.0005
R1849 VSS.n548 VSS.n12 17.0005
R1850 VSS.n539 VSS.n12 17.0005
R1851 VSS.n751 VSS.n12 17.0005
R1852 VSS.n749 VSS.n12 17.0005
R1853 VSS.n549 VSS.n12 17.0005
R1854 VSS.n537 VSS.n12 17.0005
R1855 VSS.n747 VSS.n12 17.0005
R1856 VSS.n741 VSS.n12 17.0005
R1857 VSS.n742 VSS.n12 17.0005
R1858 VSS.n739 VSS.n12 17.0005
R1859 VSS.n552 VSS.n12 17.0005
R1860 VSS.n737 VSS.n12 17.0005
R1861 VSS.n735 VSS.n12 17.0005
R1862 VSS.n533 VSS.n12 17.0005
R1863 VSS.n553 VSS.n12 17.0005
R1864 VSS.n733 VSS.n12 17.0005
R1865 VSS.n730 VSS.n12 17.0005
R1866 VSS.n731 VSS.n12 17.0005
R1867 VSS.n729 VSS.n12 17.0005
R1868 VSS.n531 VSS.n12 17.0005
R1869 VSS.n727 VSS.n12 17.0005
R1870 VSS.n725 VSS.n12 17.0005
R1871 VSS.n556 VSS.n12 17.0005
R1872 VSS.n529 VSS.n12 17.0005
R1873 VSS.n723 VSS.n12 17.0005
R1874 VSS.n720 VSS.n12 17.0005
R1875 VSS.n721 VSS.n12 17.0005
R1876 VSS.n719 VSS.n12 17.0005
R1877 VSS.n558 VSS.n12 17.0005
R1878 VSS.n717 VSS.n12 17.0005
R1879 VSS.n715 VSS.n12 17.0005
R1880 VSS.n526 VSS.n12 17.0005
R1881 VSS.n559 VSS.n12 17.0005
R1882 VSS.n713 VSS.n12 17.0005
R1883 VSS.n23 VSS.n12 17.0005
R1884 VSS.n9 VSS.n559 17.0005
R1885 VSS.n9 VSS.n526 17.0005
R1886 VSS.n9 VSS.n558 17.0005
R1887 VSS.n9 VSS.n529 17.0005
R1888 VSS.n9 VSS.n556 17.0005
R1889 VSS.n9 VSS.n531 17.0005
R1890 VSS.n9 VSS.n553 17.0005
R1891 VSS.n9 VSS.n533 17.0005
R1892 VSS.n9 VSS.n552 17.0005
R1893 VSS.n9 VSS.n536 17.0005
R1894 VSS.n9 VSS.n537 17.0005
R1895 VSS.n9 VSS.n549 17.0005
R1896 VSS.n9 VSS.n539 17.0005
R1897 VSS.n9 VSS.n548 17.0005
R1898 VSS.n25 VSS.n23 17.0005
R1899 VSS.n25 VSS.n719 17.0005
R1900 VSS.n25 VSS.n729 17.0005
R1901 VSS.n25 VSS.n739 17.0005
R1902 VSS.n25 VSS.n746 17.0005
R1903 VSS.n25 VSS.n764 17.0005
R1904 VSS.n9 VSS.n545 17.0005
R1905 VSS.n9 VSS.n543 17.0005
R1906 VSS.n577 VSS.n12 17.0005
R1907 VSS.n556 VSS.t613 16.4539
R1908 VSS.n196 VSS.t387 16.3876
R1909 VSS.n63 VSS.n522 16.2018
R1910 VSS.t234 VSS.n539 14.2601
R1911 VSS.t177 VSS.n664 13.9927
R1912 VSS.n844 VSS.t536 13.7246
R1913 VSS.t304 VSS.t570 13.4836
R1914 VSS.n713 VSS.n560 12.0761
R1915 VSS.n715 VSS.n527 12.0761
R1916 VSS.n719 VSS.n557 12.0761
R1917 VSS.n723 VSS.n528 12.0761
R1918 VSS.n727 VSS.n530 12.0761
R1919 VSS.n731 VSS.n555 12.0761
R1920 VSS.n733 VSS.n554 12.0761
R1921 VSS.n735 VSS.n534 12.0761
R1922 VSS.n742 VSS.n535 12.0761
R1923 VSS.n741 VSS.n551 12.0761
R1924 VSS.n751 VSS.n538 12.0761
R1925 VSS.n762 VSS.n540 12.0761
R1926 VSS.n714 VSS.n559 12.0761
R1927 VSS.n716 VSS.n715 12.0761
R1928 VSS.n718 VSS.n558 12.0761
R1929 VSS.n722 VSS.n720 12.0761
R1930 VSS.n724 VSS.n529 12.0761
R1931 VSS.n726 VSS.n725 12.0761
R1932 VSS.n728 VSS.n531 12.0761
R1933 VSS.n732 VSS.n730 12.0761
R1934 VSS.n734 VSS.n553 12.0761
R1935 VSS.n736 VSS.n735 12.0761
R1936 VSS.n738 VSS.n552 12.0761
R1937 VSS.n743 VSS.n741 12.0761
R1938 VSS.n748 VSS.n537 12.0761
R1939 VSS.n750 VSS.n749 12.0761
R1940 VSS.n752 VSS.n539 12.0761
R1941 VSS.n754 VSS.n753 12.0761
R1942 VSS.n763 VSS.n761 12.0761
R1943 VSS.n766 VSS.n765 12.0761
R1944 VSS.n764 VSS.n547 12.0761
R1945 VSS.n712 VSS.n544 12.0761
R1946 VSS.n560 VSS.n23 12.0761
R1947 VSS.n714 VSS.n713 12.0761
R1948 VSS.n716 VSS.n526 12.0761
R1949 VSS.n717 VSS.n527 12.0761
R1950 VSS.n718 VSS.n717 12.0761
R1951 VSS.n721 VSS.n557 12.0761
R1952 VSS.n722 VSS.n721 12.0761
R1953 VSS.n720 VSS.n528 12.0761
R1954 VSS.n724 VSS.n723 12.0761
R1955 VSS.n726 VSS.n556 12.0761
R1956 VSS.n725 VSS.n530 12.0761
R1957 VSS.n728 VSS.n727 12.0761
R1958 VSS.n729 VSS.n555 12.0761
R1959 VSS.n732 VSS.n731 12.0761
R1960 VSS.n730 VSS.n554 12.0761
R1961 VSS.n734 VSS.n733 12.0761
R1962 VSS.n736 VSS.n533 12.0761
R1963 VSS.n737 VSS.n534 12.0761
R1964 VSS.n738 VSS.n737 12.0761
R1965 VSS.n739 VSS.n535 12.0761
R1966 VSS.n743 VSS.n742 12.0761
R1967 VSS.n747 VSS.n551 12.0761
R1968 VSS.n748 VSS.n747 12.0761
R1969 VSS.n750 VSS.n549 12.0761
R1970 VSS.n749 VSS.n538 12.0761
R1971 VSS.n752 VSS.n751 12.0761
R1972 VSS.n754 VSS.n548 12.0761
R1973 VSS.n753 VSS.n540 12.0761
R1974 VSS.n763 VSS.n762 12.0761
R1975 VSS.n761 VSS.n547 12.0761
R1976 VSS.n766 VSS.n545 12.0761
R1977 VSS.n765 VSS.n544 12.0761
R1978 VSS.n812 VSS.n712 11.454
R1979 VSS.n813 VSS.n812 11.454
R1980 VSS.t162 VSS.n671 10.7797
R1981 VSS.n667 VSS.t173 10.7777
R1982 VSS.n797 VSS.n576 9.81803
R1983 VSS.n827 VSS.n576 9.39094
R1984 VSS.n825 VSS.n824 9.38916
R1985 VSS.n593 VSS.t454 9.08698
R1986 VSS.t454 VSS.n592 9.0445
R1987 VSS.n818 VSS.n817 9.0005
R1988 VSS.n818 VSS.n580 9.0005
R1989 VSS.n583 VSS.n579 9.0005
R1990 VSS.n770 VSS.n579 9.0005
R1991 VSS.n664 VSS.n663 8.9296
R1992 VSS.t110 VSS.n850 8.501
R1993 VSS.n851 VSS.t108 8.501
R1994 VSS.t106 VSS.n294 8.501
R1995 VSS.t103 VSS.n286 8.501
R1996 VSS.t99 VSS.n859 8.501
R1997 VSS.n860 VSS.t97 8.501
R1998 VSS.t95 VSS.n280 8.501
R1999 VSS.t92 VSS.n272 8.501
R2000 VSS.t88 VSS.n868 8.501
R2001 VSS.n869 VSS.t86 8.501
R2002 VSS.t84 VSS.n266 8.501
R2003 VSS.t81 VSS.n250 8.501
R2004 VSS.t77 VSS.n877 8.501
R2005 VSS.n878 VSS.t75 8.501
R2006 VSS.t73 VSS.n243 8.501
R2007 VSS.t70 VSS.n234 8.501
R2008 VSS.t66 VSS.n886 8.501
R2009 VSS.n887 VSS.t64 8.501
R2010 VSS.t62 VSS.n889 8.501
R2011 VSS.n890 VSS.t59 8.501
R2012 VSS.t55 VSS.n892 8.501
R2013 VSS.n893 VSS.t53 8.501
R2014 VSS.t51 VSS.n212 8.501
R2015 VSS.t48 VSS.n188 8.501
R2016 VSS.n805 VSS.n12 8.501
R2017 VSS.n805 VSS.n40 1.88985
R2018 VSS.n42 VSS.n43 0.00149997
R2019 VSS.n805 VSS.n44 2.4296
R2020 VSS.n805 VSS.n50 2.83417
R2021 VSS.n49 VSS.n50 0.00166658
R2022 VSS.n49 VSS.n48 0.00149997
R2023 VSS.n805 VSS.n54 4.251
R2024 VSS.n54 VSS.n53 0.00149997
R2025 VSS.n805 VSS.n57 2.4296
R2026 VSS.n805 VSS.n61 3.40102
R2027 VSS.n834 VSS.n13 1.20762
R2028 VSS.n12 VSS.n19 0.00166658
R2029 VSS.n19 VSS.n29 0.00149997
R2030 VSS.n834 VSS.n31 2.83417
R2031 VSS.n31 VSS.n30 0.00166658
R2032 VSS.n30 VSS.n32 0.00149997
R2033 VSS.n834 VSS.n14 3.40102
R2034 VSS.n17 VSS.n15 0.00287442
R2035 VSS.n834 VSS.n17 2.12581
R2036 VSS.n17 VSS.n33 0.00362479
R2037 VSS.n834 VSS.n34 1.41762
R2038 VSS.n36 VSS.n37 0.00159992
R2039 VSS.n692 VSS.n66 406.622
R2040 VSS.n71 VSS.n70 406.622
R2041 VSS.n73 VSS.n71 0.00235708
R2042 VSS.n663 VSS.n74 2.42951
R2043 VSS.n663 VSS.n76 3.40102
R2044 VSS.n79 VSS.n78 0.00216499
R2045 VSS.n78 VSS.n80 0.00173273
R2046 VSS.n80 VSS.n81 0.00172462
R2047 VSS.n81 VSS.n82 0.00170812
R2048 VSS.n82 VSS.n83 0.00166658
R2049 VSS.n83 VSS.n84 0.00149997
R2050 VSS.n86 VSS.n85 0.00216959
R2051 VSS.n85 VSS.n87 0.00170812
R2052 VSS.n87 VSS.n88 0.00166658
R2053 VSS.n88 VSS.n89 0.00149997
R2054 VSS.n74 VSS.n91 0.00257133
R2055 VSS.n816 VSS.n6 5.41263
R2056 VSS.n813 VSS.n10 1.41754
R2057 VSS.n27 VSS.n28 0.00166658
R2058 VSS.n813 VSS.n21 3.40102
R2059 VSS.n813 VSS.n12 8.501
R2060 VSS.n11 VSS.t610 8.501
R2061 VSS.n94 VSS.n517 8.5005
R2062 VSS.n94 VSS.n512 8.5005
R2063 VSS.n94 VSS.n348 8.5005
R2064 VSS.n94 VSS.n510 8.5005
R2065 VSS.n94 VSS.n509 8.5005
R2066 VSS.n94 VSS.n349 8.5005
R2067 VSS.n94 VSS.n508 8.5005
R2068 VSS.n94 VSS.n351 8.5005
R2069 VSS.n94 VSS.n507 8.5005
R2070 VSS.n94 VSS.n352 8.5005
R2071 VSS.n94 VSS.n506 8.5005
R2072 VSS.n94 VSS.n353 8.5005
R2073 VSS.n94 VSS.n505 8.5005
R2074 VSS.n94 VSS.n504 8.5005
R2075 VSS.n94 VSS.n354 8.5005
R2076 VSS.n94 VSS.n503 8.5005
R2077 VSS.n94 VSS.n356 8.5005
R2078 VSS.n94 VSS.n502 8.5005
R2079 VSS.n94 VSS.n357 8.5005
R2080 VSS.n94 VSS.n501 8.5005
R2081 VSS.n94 VSS.n358 8.5005
R2082 VSS.n94 VSS.n500 8.5005
R2083 VSS.n94 VSS.n499 8.5005
R2084 VSS.n94 VSS.n359 8.5005
R2085 VSS.n94 VSS.n498 8.5005
R2086 VSS.n94 VSS.n361 8.5005
R2087 VSS.n94 VSS.n497 8.5005
R2088 VSS.n94 VSS.n362 8.5005
R2089 VSS.n94 VSS.n496 8.5005
R2090 VSS.n94 VSS.n363 8.5005
R2091 VSS.n94 VSS.n495 8.5005
R2092 VSS.n94 VSS.n494 8.5005
R2093 VSS.n94 VSS.n364 8.5005
R2094 VSS.n94 VSS.n493 8.5005
R2095 VSS.n94 VSS.n366 8.5005
R2096 VSS.n94 VSS.n492 8.5005
R2097 VSS.n94 VSS.n367 8.5005
R2098 VSS.n94 VSS.n491 8.5005
R2099 VSS.n94 VSS.n368 8.5005
R2100 VSS.n94 VSS.n490 8.5005
R2101 VSS.n94 VSS.n489 8.5005
R2102 VSS.n94 VSS.n369 8.5005
R2103 VSS.n94 VSS.n488 8.5005
R2104 VSS.n94 VSS.n371 8.5005
R2105 VSS.n94 VSS.n487 8.5005
R2106 VSS.n94 VSS.n372 8.5005
R2107 VSS.n94 VSS.n486 8.5005
R2108 VSS.n94 VSS.n373 8.5005
R2109 VSS.n94 VSS.n485 8.5005
R2110 VSS.n94 VSS.n484 8.5005
R2111 VSS.n94 VSS.n374 8.5005
R2112 VSS.n94 VSS.n483 8.5005
R2113 VSS.n94 VSS.n376 8.5005
R2114 VSS.n94 VSS.n482 8.5005
R2115 VSS.n94 VSS.n377 8.5005
R2116 VSS.n94 VSS.n481 8.5005
R2117 VSS.n94 VSS.n378 8.5005
R2118 VSS.n94 VSS.n480 8.5005
R2119 VSS.n94 VSS.n479 8.5005
R2120 VSS.n94 VSS.n379 8.5005
R2121 VSS.n94 VSS.n478 8.5005
R2122 VSS.n94 VSS.n381 8.5005
R2123 VSS.n94 VSS.n477 8.5005
R2124 VSS.n94 VSS.n382 8.5005
R2125 VSS.n94 VSS.n476 8.5005
R2126 VSS.n94 VSS.n383 8.5005
R2127 VSS.n94 VSS.n475 8.5005
R2128 VSS.n94 VSS.n474 8.5005
R2129 VSS.n94 VSS.n384 8.5005
R2130 VSS.n94 VSS.n473 8.5005
R2131 VSS.n94 VSS.n386 8.5005
R2132 VSS.n94 VSS.n472 8.5005
R2133 VSS.n94 VSS.n387 8.5005
R2134 VSS.n94 VSS.n471 8.5005
R2135 VSS.n94 VSS.n388 8.5005
R2136 VSS.n94 VSS.n470 8.5005
R2137 VSS.n94 VSS.n469 8.5005
R2138 VSS.n94 VSS.n389 8.5005
R2139 VSS.n94 VSS.n468 8.5005
R2140 VSS.n94 VSS.n391 8.5005
R2141 VSS.n94 VSS.n467 8.5005
R2142 VSS.n94 VSS.n392 8.5005
R2143 VSS.n94 VSS.n466 8.5005
R2144 VSS.n94 VSS.n393 8.5005
R2145 VSS.n94 VSS.n465 8.5005
R2146 VSS.n94 VSS.n464 8.5005
R2147 VSS.n94 VSS.n394 8.5005
R2148 VSS.n94 VSS.n463 8.5005
R2149 VSS.n94 VSS.n396 8.5005
R2150 VSS.n94 VSS.n462 8.5005
R2151 VSS.n94 VSS.n397 8.5005
R2152 VSS.n94 VSS.n461 8.5005
R2153 VSS.n94 VSS.n398 8.5005
R2154 VSS.n94 VSS.n460 8.5005
R2155 VSS.n94 VSS.n459 8.5005
R2156 VSS.n94 VSS.n399 8.5005
R2157 VSS.n94 VSS.n458 8.5005
R2158 VSS.n94 VSS.n401 8.5005
R2159 VSS.n94 VSS.n457 8.5005
R2160 VSS.n94 VSS.n402 8.5005
R2161 VSS.n94 VSS.n456 8.5005
R2162 VSS.n94 VSS.n403 8.5005
R2163 VSS.n94 VSS.n455 8.5005
R2164 VSS.n94 VSS.n454 8.5005
R2165 VSS.n94 VSS.n404 8.5005
R2166 VSS.n94 VSS.n453 8.5005
R2167 VSS.n94 VSS.n406 8.5005
R2168 VSS.n94 VSS.n452 8.5005
R2169 VSS.n94 VSS.n407 8.5005
R2170 VSS.n94 VSS.n451 8.5005
R2171 VSS.n94 VSS.n408 8.5005
R2172 VSS.n94 VSS.n450 8.5005
R2173 VSS.n94 VSS.n449 8.5005
R2174 VSS.n94 VSS.n409 8.5005
R2175 VSS.n94 VSS.n448 8.5005
R2176 VSS.n94 VSS.n411 8.5005
R2177 VSS.n94 VSS.n447 8.5005
R2178 VSS.n94 VSS.n412 8.5005
R2179 VSS.n94 VSS.n446 8.5005
R2180 VSS.n94 VSS.n413 8.5005
R2181 VSS.n94 VSS.n445 8.5005
R2182 VSS.n94 VSS.n444 8.5005
R2183 VSS.n94 VSS.n414 8.5005
R2184 VSS.n94 VSS.n443 8.5005
R2185 VSS.n94 VSS.n416 8.5005
R2186 VSS.n94 VSS.n442 8.5005
R2187 VSS.n94 VSS.n417 8.5005
R2188 VSS.n94 VSS.n441 8.5005
R2189 VSS.n94 VSS.n418 8.5005
R2190 VSS.n94 VSS.n440 8.5005
R2191 VSS.n94 VSS.n439 8.5005
R2192 VSS.n94 VSS.n419 8.5005
R2193 VSS.n94 VSS.n438 8.5005
R2194 VSS.n94 VSS.n421 8.5005
R2195 VSS.n94 VSS.n437 8.5005
R2196 VSS.n94 VSS.n422 8.5005
R2197 VSS.n94 VSS.n436 8.5005
R2198 VSS.n94 VSS.n423 8.5005
R2199 VSS.n94 VSS.n435 8.5005
R2200 VSS.n94 VSS.n434 8.5005
R2201 VSS.n94 VSS.n424 8.5005
R2202 VSS.n94 VSS.n433 8.5005
R2203 VSS.n94 VSS.n426 8.5005
R2204 VSS.n94 VSS.n432 8.5005
R2205 VSS.n94 VSS.n427 8.5005
R2206 VSS.n94 VSS.n430 8.5005
R2207 VSS.n7 VSS.n608 8.5005
R2208 VSS.n7 VSS.n597 8.5005
R2209 VSS.n7 VSS.n581 8.48883
R2210 VSS.n9 VSS.n542 8.48385
R2211 VSS.n773 VSS.n27 8.48291
R2212 VSS.n94 VSS.n431 8.48012
R2213 VSS.t195 VSS.n75 8.47784
R2214 VSS.n650 VSS.n77 8.47784
R2215 VSS.n653 VSS.n78 8.47784
R2216 VSS.n654 VSS.n80 8.47784
R2217 VSS.n655 VSS.n81 8.47784
R2218 VSS.n656 VSS.n82 8.47784
R2219 VSS.n657 VSS.n83 8.47784
R2220 VSS.n658 VSS.n84 8.47784
R2221 VSS.n660 VSS.n85 8.47784
R2222 VSS.n661 VSS.n87 8.47784
R2223 VSS.n662 VSS.n88 8.47784
R2224 VSS.n635 VSS.n89 8.47784
R2225 VSS.n90 VSS.t178 8.47784
R2226 VSS.n94 VSS.n347 8.47732
R2227 VSS.n94 VSS.t333 8.47732
R2228 VSS.n93 VSS.n92 4.19564
R2229 VSS.n94 VSS.n309 8.47732
R2230 VSS.n94 VSS.n310 8.47732
R2231 VSS.n94 VSS.n344 8.47732
R2232 VSS.n794 VSS.n12 8.47732
R2233 VSS.n798 VSS.n12 8.47732
R2234 VSS.n573 VSS.n12 8.47732
R2235 VSS.n792 VSS.n41 8.47732
R2236 VSS.n799 VSS.n42 8.47732
R2237 VSS.n800 VSS.n43 8.47732
R2238 VSS.n802 VSS.n45 8.47732
R2239 VSS.n803 VSS.n47 8.47732
R2240 VSS.n46 VSS.n804 8.47732
R2241 VSS.n788 VSS.n49 8.47732
R2242 VSS.t568 VSS.n48 8.47732
R2243 VSS.n786 VSS.n787 8.47732
R2244 VSS.t569 VSS.n53 8.47732
R2245 VSS.n807 VSS.n56 8.47732
R2246 VSS.n808 VSS.n55 8.47732
R2247 VSS.n810 VSS.n60 8.47732
R2248 VSS.t311 VSS.n19 8.47732
R2249 VSS.t571 VSS.n29 8.47732
R2250 VSS.n830 VSS.n568 8.47732
R2251 VSS.n567 VSS.n30 8.47732
R2252 VSS.t574 VSS.n32 8.47732
R2253 VSS.n18 VSS.n15 4.19225
R2254 VSS.n16 VSS.n15 4.19225
R2255 VSS.t577 VSS.n16 0.0953067
R2256 VSS.n831 VSS.n33 8.47732
R2257 VSS.t578 VSS.n35 8.47732
R2258 VSS.n562 VSS.n36 8.47732
R2259 VSS.n832 VSS.n37 8.47732
R2260 VSS.n833 VSS.n38 8.47732
R2261 VSS.n648 VSS.n91 8.47732
R2262 VSS.n643 VSS.n91 8.47732
R2263 VSS.n7 VSS.n585 8.47732
R2264 VSS.n7 VSS.n587 8.47732
R2265 VSS.n7 VSS.n589 8.47732
R2266 VSS.n7 VSS.n595 8.47732
R2267 VSS.n7 VSS.n609 8.47732
R2268 VSS.n7 VSS.n598 8.47732
R2269 VSS.n9 VSS.n541 8.47732
R2270 VSS.n25 VSS.n760 8.47732
R2271 VSS.n772 VSS.n10 8.47732
R2272 VSS.n775 VSS.n28 8.47732
R2273 VSS.n26 VSS.n20 5.62581
R2274 VSS.n780 VSS.n20 8.47732
R2275 VSS.n782 VSS.n25 8.47732
R2276 VSS.n701 VSS.n65 8.47111
R2277 VSS.t248 VSS.n68 8.47111
R2278 VSS.n676 VSS.n72 8.47111
R2279 VSS.t365 VSS.n73 8.47111
R2280 VSS.n13 VSS.n12 1.20964
R2281 VSS.n13 VSS.t609 3.48646
R2282 VSS.n823 VSS.n822 6.85916
R2283 VSS.n700 VSS.n522 5.66985
R2284 VSS.n40 VSS.n791 0.00261099
R2285 VSS.n44 VSS.n790 0.0024999
R2286 VSS.n805 VSS.n789 5.66778
R2287 VSS.n57 VSS.n52 0.0024999
R2288 VSS.n61 VSS.n58 0.00229996
R2289 VSS.n834 VSS.n524 5.66778
R2290 VSS.n834 VSS.n523 5.66778
R2291 VSS.n834 VSS.n525 5.66778
R2292 VSS.n14 VSS.n565 0.00229996
R2293 VSS.n34 VSS.n564 0.00270818
R2294 VSS.n76 VSS.n647 0.00229996
R2295 VSS.n663 VSS.n634 5.66778
R2296 VSS.n663 VSS.n79 1.13339
R2297 VSS.n663 VSS.n86 1.54575
R2298 VSS.n813 VSS.n20 5.66778
R2299 VSS.n21 VSS.n769 0.00229996
R2300 VSS.n37 VSS.n38 0.00139998
R2301 VSS.n66 VSS.n68 0.00137142
R2302 VSS.n94 VSS.n308 5.63915
R2303 VSS.n649 VSS.n647 5.62674
R2304 VSS.n651 VSS.n646 5.62674
R2305 VSS.n652 VSS.n645 5.62674
R2306 VSS.n659 VSS.n644 5.62674
R2307 VSS.n572 VSS.n12 5.62581
R2308 VSS.t305 VSS.n791 5.62581
R2309 VSS.n801 VSS.n790 5.62581
R2310 VSS.n806 VSS.n51 5.62581
R2311 VSS.n785 VSS.n52 5.62581
R2312 VSS.n809 VSS.n58 5.62581
R2313 VSS.n811 VSS.n59 5.62581
R2314 VSS.n828 VSS.n571 5.62581
R2315 VSS.t572 VSS.n829 5.62581
R2316 VSS.n570 VSS.n569 5.62581
R2317 VSS.n566 VSS.n565 5.62581
R2318 VSS.n563 VSS.n564 5.62581
R2319 VSS.n7 VSS.n594 5.62581
R2320 VSS.n781 VSS.n769 5.62581
R2321 VSS.n25 VSS.n783 5.62252
R2322 VSS.t611 VSS.n526 5.48496
R2323 VSS.n703 VSS.n702 5.13648
R2324 VSS.n624 VSS.t547 4.98596
R2325 VSS.n819 VSS.n818 4.63796
R2326 VSS.n692 VSS.t401 4.49152
R2327 VSS.n70 VSS.t19 4.49152
R2328 VSS.t261 VSS.n703 4.4712
R2329 VSS.n805 VSS.n22 4.25119
R2330 VSS.n7 VSS.n590 4.19238
R2331 VSS.n855 VSS.t104 4.19225
R2332 VSS.n864 VSS.t93 4.19225
R2333 VSS.n873 VSS.t82 4.19225
R2334 VSS.n882 VSS.t71 4.19225
R2335 VSS.t60 VSS.n225 4.19225
R2336 VSS.n897 VSS.t49 4.19225
R2337 VSS.n25 VSS.n767 4.19225
R2338 VSS.n9 VSS.n546 4.19225
R2339 VSS.t116 VSS.n641 4.177
R2340 VSS.n520 VSS.n185 3.84219
R2341 VSS.n901 VSS.t355 3.84041
R2342 VSS.n512 VSS.t158 3.34498
R2343 VSS.n509 VSS.t196 3.34498
R2344 VSS.n506 VSS.t150 3.34498
R2345 VSS.n504 VSS.t198 3.34498
R2346 VSS.n501 VSS.t139 3.34498
R2347 VSS.n499 VSS.t138 3.34498
R2348 VSS.n496 VSS.t141 3.34498
R2349 VSS.n494 VSS.t200 3.34498
R2350 VSS.n491 VSS.t205 3.34498
R2351 VSS.n489 VSS.t201 3.34498
R2352 VSS.n486 VSS.t203 3.34498
R2353 VSS.n484 VSS.t206 3.34498
R2354 VSS.n481 VSS.t210 3.34498
R2355 VSS.n479 VSS.t208 3.34498
R2356 VSS.n476 VSS.t160 3.34498
R2357 VSS.n474 VSS.t156 3.34498
R2358 VSS.n471 VSS.t145 3.34498
R2359 VSS.n469 VSS.t211 3.34498
R2360 VSS.n466 VSS.t220 3.34498
R2361 VSS.n464 VSS.t214 3.34498
R2362 VSS.n461 VSS.t218 3.34498
R2363 VSS.n459 VSS.t147 3.34498
R2364 VSS.n456 VSS.t216 3.34498
R2365 VSS.n454 VSS.t213 3.34498
R2366 VSS.n451 VSS.t151 3.34498
R2367 VSS.n449 VSS.t143 3.34498
R2368 VSS.n446 VSS.t154 3.34498
R2369 VSS.n444 VSS.t224 3.34498
R2370 VSS.n441 VSS.t222 3.34498
R2371 VSS.n439 VSS.t153 3.34498
R2372 VSS.n436 VSS.t149 3.34498
R2373 VSS.n434 VSS.t226 3.34498
R2374 VSS.n826 VSS.n12 3.3265
R2375 VSS.n7 VSS.n586 3.32615
R2376 VSS.t299 VSS.t379 3.30696
R2377 VSS.n848 VSS.t452 3.28366
R2378 VSS.n812 VSS.n25 2.77448
R2379 VSS.n819 VSS.n578 2.7456
R2380 VSS.n94 VSS.n346 2.74463
R2381 VSS.n94 VSS.n428 2.7443
R2382 VSS.n94 VSS.t122 2.74402
R2383 VSS.n94 VSS.n511 2.74397
R2384 VSS.n94 VSS.n342 2.74397
R2385 VSS.n7 VSS.n603 2.74397
R2386 VSS.n7 VSS.n596 2.74364
R2387 VSS.n9 VSS.n560 2.46343
R2388 VSS.n9 VSS.n527 2.46343
R2389 VSS.n9 VSS.n557 2.46343
R2390 VSS.n9 VSS.n528 2.46343
R2391 VSS.n9 VSS.n530 2.46343
R2392 VSS.n9 VSS.n555 2.46343
R2393 VSS.n9 VSS.n554 2.46343
R2394 VSS.n9 VSS.n534 2.46343
R2395 VSS.n9 VSS.n535 2.46343
R2396 VSS.n9 VSS.n551 2.46343
R2397 VSS.n9 VSS.n538 2.46343
R2398 VSS.n9 VSS.n540 2.46343
R2399 VSS.n25 VSS.n714 2.46343
R2400 VSS.n25 VSS.n716 2.46343
R2401 VSS.n25 VSS.n718 2.46343
R2402 VSS.n25 VSS.n722 2.46343
R2403 VSS.n25 VSS.n724 2.46343
R2404 VSS.n25 VSS.n726 2.46343
R2405 VSS.n25 VSS.n728 2.46343
R2406 VSS.n25 VSS.n732 2.46343
R2407 VSS.n25 VSS.n734 2.46343
R2408 VSS.n25 VSS.n736 2.46343
R2409 VSS.n25 VSS.n738 2.46343
R2410 VSS.n25 VSS.n743 2.46343
R2411 VSS.n25 VSS.n748 2.46343
R2412 VSS.n25 VSS.n750 2.46343
R2413 VSS.n25 VSS.n752 2.46343
R2414 VSS.n25 VSS.n754 2.46343
R2415 VSS.n25 VSS.n763 2.46343
R2416 VSS.n25 VSS.n766 2.46343
R2417 VSS.n9 VSS.n547 2.46343
R2418 VSS.n9 VSS.n544 2.46343
R2419 VSS.n298 VSS.n297 2.34876
R2420 VSS.n284 VSS.n283 2.34876
R2421 VSS.n270 VSS.n269 2.34876
R2422 VSS.n247 VSS.n246 2.34876
R2423 VSS.n232 VSS.n231 2.34876
R2424 VSS.n216 VSS.n215 2.34876
R2425 VSS.n9 VSS.n550 2.32483
R2426 VSS.n25 VSS.n757 2.32406
R2427 VSS.n9 VSS.n532 2.00687
R2428 VSS.n25 VSS.n740 2.0061
R2429 VSS.t379 VSS.n628 1.97699
R2430 VSS.t8 VSS.n622 1.88189
R2431 VSS.n641 VSS.n633 1.88189
R2432 VSS.n820 VSS.n819 1.83435
R2433 VSS.t461 VSS.n700 1.80539
R2434 VSS.n796 VSS.n12 1.75689
R2435 VSS.n575 VSS.n12 1.75689
R2436 VSS.n7 VSS.n614 1.75507
R2437 VSS.n677 VSS.t23 1.72297
R2438 VSS.n774 VSS.n770 1.66925
R2439 VSS.n94 VSS.n519 1.63922
R2440 VSS.n94 VSS.n837 1.63922
R2441 VSS.n94 VSS.n842 1.63922
R2442 VSS.n94 VSS.n844 1.63922
R2443 VSS.n94 VSS.n846 1.63922
R2444 VSS.n94 VSS.n350 1.55386
R2445 VSS.n94 VSS.n355 1.55386
R2446 VSS.n94 VSS.n360 1.55386
R2447 VSS.n94 VSS.n365 1.55386
R2448 VSS.n94 VSS.n370 1.55386
R2449 VSS.n94 VSS.n375 1.55386
R2450 VSS.n94 VSS.n380 1.55386
R2451 VSS.n94 VSS.n385 1.55386
R2452 VSS.n94 VSS.n390 1.55386
R2453 VSS.n94 VSS.n395 1.55386
R2454 VSS.n94 VSS.n400 1.55386
R2455 VSS.n94 VSS.n405 1.55386
R2456 VSS.n94 VSS.n410 1.55386
R2457 VSS.n94 VSS.n415 1.55386
R2458 VSS.n94 VSS.n420 1.55386
R2459 VSS.n94 VSS.n425 1.55386
R2460 VSS.n94 VSS.t483 1.55345
R2461 VSS.n94 VSS.t599 1.55345
R2462 VSS.n94 VSS.t256 1.55345
R2463 VSS.n94 VSS.t45 1.55345
R2464 VSS.n94 VSS.t259 1.55345
R2465 VSS.n94 VSS.t276 1.55345
R2466 VSS.n94 VSS.t284 1.55345
R2467 VSS.n94 VSS.t130 1.55345
R2468 VSS.n94 VSS.t230 1.55345
R2469 VSS.n94 VSS.t272 1.55345
R2470 VSS.n94 VSS.t424 1.55345
R2471 VSS.n94 VSS.t31 1.55345
R2472 VSS.n94 VSS.t430 1.55345
R2473 VSS.n94 VSS.t4 1.55345
R2474 VSS.n94 VSS.t486 1.55345
R2475 VSS.n94 VSS.n311 1.55338
R2476 VSS.n94 VSS.n312 1.55338
R2477 VSS.n94 VSS.n313 1.55338
R2478 VSS.n94 VSS.n314 1.55338
R2479 VSS.n94 VSS.n315 1.55338
R2480 VSS.n94 VSS.n316 1.55338
R2481 VSS.n94 VSS.n317 1.55338
R2482 VSS.n94 VSS.n318 1.55338
R2483 VSS.n94 VSS.n319 1.55338
R2484 VSS.n94 VSS.n320 1.55338
R2485 VSS.n94 VSS.n321 1.55338
R2486 VSS.n94 VSS.n322 1.55338
R2487 VSS.n94 VSS.n323 1.55338
R2488 VSS.n94 VSS.n324 1.55338
R2489 VSS.n94 VSS.n325 1.55338
R2490 VSS.n94 VSS.n326 1.55338
R2491 VSS.n94 VSS.n327 1.55338
R2492 VSS.n94 VSS.n328 1.55338
R2493 VSS.n94 VSS.n329 1.55338
R2494 VSS.n94 VSS.n330 1.55338
R2495 VSS.n94 VSS.n331 1.55338
R2496 VSS.n94 VSS.n332 1.55338
R2497 VSS.n94 VSS.n333 1.55338
R2498 VSS.n94 VSS.n334 1.55338
R2499 VSS.n94 VSS.n335 1.55338
R2500 VSS.n94 VSS.n336 1.55338
R2501 VSS.n94 VSS.n337 1.55338
R2502 VSS.n94 VSS.n338 1.55338
R2503 VSS.n94 VSS.n339 1.55338
R2504 VSS.n94 VSS.n340 1.55338
R2505 VSS.n94 VSS.n341 1.55338
R2506 VSS.n636 VSS.n91 1.55041
R2507 VSS.t308 VSS.n768 1.43372
R2508 VSS.t306 VSS.n776 1.43372
R2509 VSS.t308 VSS.n778 1.42949
R2510 VSS.t306 VSS.n777 1.42949
R2511 VSS.t235 VSS.t243 1.41892
R2512 VSS.t233 VSS.t242 1.41892
R2513 VSS.t240 VSS.t241 1.41892
R2514 VSS.t238 VSS.t237 1.41892
R2515 VSS.n900 VSS.n209 1.38589
R2516 VSS.n574 VSS.t303 1.37661
R2517 VSS.t303 VSS.n793 1.37661
R2518 VSS.n821 VSS.n820 1.30942
R2519 VSS.t136 VSS.n248 1.28795
R2520 VSS.n825 VSS.n821 1.26857
R2521 VSS.t195 VSS.t193 1.26458
R2522 VSS.t178 VSS.t176 1.24892
R2523 VSS.n639 VSS.n91 1.24506
R2524 VSS.t398 VSS.t389 1.23805
R2525 VSS.t299 VSS.n629 1.21874
R2526 VSS.t168 VSS.t166 1.1832
R2527 VSS.t186 VSS.t188 1.18293
R2528 VSS.t190 VSS.t188 1.17925
R2529 VSS.t170 VSS.t168 1.17908
R2530 VSS.t163 VSS.t164 1.17817
R2531 VSS.t180 VSS.t179 1.1778
R2532 VSS.t174 VSS.t172 1.17371
R2533 VSS.t182 VSS.t181 1.17364
R2534 VSS.t193 VSS.t182 1.16657
R2535 VSS.t176 VSS.t174 1.15299
R2536 VSS.n626 VSS.t116 1.12123
R2537 VSS.t170 VSS.t172 1.11346
R2538 VSS.t181 VSS.t190 1.11316
R2539 VSS.t166 VSS.t163 1.10882
R2540 VSS.t186 VSS.t180 1.10881
R2541 VSS.t8 VSS.n620 1.09664
R2542 VSS.n630 VSS.t381 1.08287
R2543 VSS.t77 VSS.n248 1.06717
R2544 VSS.n629 VSS.t248 1.0392
R2545 VSS.n187 VSS.t48 1.03359
R2546 VSS.n620 VSS.n621 1.02454
R2547 VSS.n521 VSS.t296 1.02126
R2548 VSS.n840 VSS.t28 1.0071
R2549 VSS.n187 VSS.t377 1.0064
R2550 VSS.n24 VSS.n811 0.986192
R2551 VSS.n186 VSS.t355 0.971887
R2552 VSS.t110 VSS.n299 0.950816
R2553 VSS.n39 VSS.n833 0.932604
R2554 VSS.n626 VSS.t261 0.885254
R2555 VSS.n39 VSS.n561 0.881792
R2556 VSS.n24 VSS.n784 0.873936
R2557 VSS.t81 VSS.n249 0.841394
R2558 VSS.n701 VSS.n630 0.839803
R2559 VSS.t21 VSS.n632 0.832423
R2560 VSS.t314 VSS.t317 0.806856
R2561 VSS.n606 VSS.t321 0.806855
R2562 VSS.t538 VSS.t327 0.806855
R2563 VSS.n604 VSS.t184 0.802775
R2564 VSS.t395 VSS.t159 0.802775
R2565 VSS.t392 VSS.t197 0.802775
R2566 VSS.t427 VSS.t120 0.802775
R2567 VSS.t6 VSS.t199 0.802775
R2568 VSS.t281 VSS.t140 0.802775
R2569 VSS.t411 VSS.t26 0.802775
R2570 VSS.t421 VSS.t142 0.802775
R2571 VSS.t39 VSS.t43 0.802775
R2572 VSS.t449 VSS.t132 0.802775
R2573 VSS.t134 VSS.t202 0.802775
R2574 VSS.t37 VSS.t204 0.802775
R2575 VSS.t267 VSS.t207 0.802775
R2576 VSS.t433 VSS.t18 0.802775
R2577 VSS.t511 VSS.t209 0.802775
R2578 VSS.t555 VSS.t161 0.802775
R2579 VSS.t507 VSS.t157 0.802775
R2580 VSS.t406 VSS.t146 0.802775
R2581 VSS.t301 VSS.t212 0.802775
R2582 VSS.t418 VSS.t221 0.802775
R2583 VSS.t246 VSS.t215 0.802775
R2584 VSS.t446 VSS.t219 0.802775
R2585 VSS.t550 VSS.t148 0.802775
R2586 VSS.t587 VSS.t217 0.802775
R2587 VSS.t290 VSS.t33 0.802775
R2588 VSS.t436 VSS.t152 0.802775
R2589 VSS.t516 VSS.t144 0.802775
R2590 VSS.t477 VSS.t155 0.802775
R2591 VSS.t353 VSS.t225 0.802775
R2592 VSS.t15 VSS.t223 0.802775
R2593 VSS.t251 VSS.t1 0.802775
R2594 VSS.t443 VSS.t12 0.802775
R2595 VSS.t10 VSS.t227 0.802775
R2596 VSS.t602 VSS.t336 0.802775
R2597 VSS.t103 VSS.n285 0.78864
R2598 VSS.t92 VSS.n271 0.78864
R2599 VSS.t70 VSS.n233 0.78864
R2600 VSS.t59 VSS.n217 0.78864
R2601 VSS.n630 VSS.t461 0.756052
R2602 VSS.t21 VSS.t23 0.745166
R2603 VSS.t8 VSS.n626 0.728354
R2604 VSS.t99 VSS.n285 0.724795
R2605 VSS.t88 VSS.n271 0.724795
R2606 VSS.t66 VSS.n233 0.724795
R2607 VSS.t55 VSS.n217 0.724795
R2608 VSS.t337 VSS.t339 0.723599
R2609 VSS.t335 VSS.n307 0.723599
R2610 VSS.n759 VSS.t235 0.722582
R2611 VSS.n756 VSS.t233 0.722582
R2612 VSS.n745 VSS.t240 0.722582
R2613 VSS.n784 VSS.t238 0.722582
R2614 VSS.t243 VSS.n758 0.72222
R2615 VSS.t242 VSS.n755 0.72222
R2616 VSS.t241 VSS.n744 0.72222
R2617 VSS.t237 VSS.n561 0.72222
R2618 VSS.n632 VSS.n642 0.711165
R2619 VSS.t261 VSS.n620 0.699997
R2620 VSS.n249 VSS.t136 0.699882
R2621 VSS.n638 VSS.n637 0.6955
R2622 VSS.n629 VSS.n67 0.662806
R2623 VSS.t365 VSS.t23 0.640524
R2624 VSS.n858 VSS.n285 0.62049
R2625 VSS.n867 VSS.n271 0.62049
R2626 VSS.n885 VSS.n233 0.62049
R2627 VSS.n891 VSS.n217 0.62049
R2628 VSS.n849 VSS.n305 0.613782
R2629 VSS.n858 VSS.n291 0.613782
R2630 VSS.n867 VSS.n277 0.613782
R2631 VSS.n876 VSS.n263 0.613782
R2632 VSS.n876 VSS.n258 0.613782
R2633 VSS.n885 VSS.n240 0.613782
R2634 VSS.n891 VSS.n222 0.613782
R2635 VSS.n900 VSS.n192 0.613782
R2636 VSS.n900 VSS.n194 0.613782
R2637 VSS.n900 VSS.n205 0.613782
R2638 VSS.n900 VSS.n200 0.613782
R2639 VSS.n900 VSS.n201 0.613782
R2640 VSS.n632 VSS.n91 0.599773
R2641 VSS.t326 VSS.n610 0.595317
R2642 VSS.t323 VSS.n611 0.595317
R2643 VSS.t320 VSS.n599 0.595317
R2644 VSS.t316 VSS.n600 0.595317
R2645 VSS.t332 VSS.n513 0.595317
R2646 VSS.t329 VSS.n514 0.595317
R2647 VSS.n676 VSS.n628 0.588545
R2648 VSS.n697 VSS.t381 0.572871
R2649 VSS.n683 VSS.t379 0.572871
R2650 VSS.n642 VSS.n639 0.56503
R2651 VSS.t8 VSS.n625 0.557126
R2652 VSS.n94 VSS.n95 0.556705
R2653 VSS.n9 VSS.n39 0.556483
R2654 VSS.n25 VSS.n24 0.55447
R2655 VSS.n876 VSS.n249 0.554008
R2656 VSS.t377 VSS.n209 0.539958
R2657 VSS.n615 VSS.n614 0.52186
R2658 VSS.t308 VSS.t306 0.492336
R2659 VSS.n691 VSS.n67 0.490843
R2660 VSS.n687 VSS.n67 0.490843
R2661 VSS.n685 VSS.n67 0.490843
R2662 VSS.n677 VSS.n674 0.490843
R2663 VSS.n694 VSS.t381 0.489061
R2664 VSS.n680 VSS.t379 0.489061
R2665 VSS.t159 VSS.n341 0.477689
R2666 VSS.t197 VSS.n340 0.477689
R2667 VSS.t120 VSS.n339 0.477689
R2668 VSS.t199 VSS.n338 0.477689
R2669 VSS.t140 VSS.n337 0.477689
R2670 VSS.t26 VSS.n336 0.477689
R2671 VSS.t142 VSS.n335 0.477689
R2672 VSS.t43 VSS.n334 0.477689
R2673 VSS.t132 VSS.n333 0.477689
R2674 VSS.t202 VSS.n332 0.477689
R2675 VSS.t204 VSS.n331 0.477689
R2676 VSS.t207 VSS.n330 0.477689
R2677 VSS.t18 VSS.n329 0.477689
R2678 VSS.t209 VSS.n328 0.477689
R2679 VSS.t161 VSS.n327 0.477689
R2680 VSS.t157 VSS.n326 0.477689
R2681 VSS.t146 VSS.n325 0.477689
R2682 VSS.t212 VSS.n324 0.477689
R2683 VSS.t221 VSS.n323 0.477689
R2684 VSS.t215 VSS.n322 0.477689
R2685 VSS.t219 VSS.n321 0.477689
R2686 VSS.t148 VSS.n320 0.477689
R2687 VSS.t217 VSS.n319 0.477689
R2688 VSS.t33 VSS.n318 0.477689
R2689 VSS.t152 VSS.n317 0.477689
R2690 VSS.t144 VSS.n316 0.477689
R2691 VSS.t155 VSS.n315 0.477689
R2692 VSS.t225 VSS.n314 0.477689
R2693 VSS.t223 VSS.n313 0.477689
R2694 VSS.t1 VSS.n312 0.477689
R2695 VSS.t12 VSS.n311 0.477689
R2696 VSS.n636 VSS.n578 0.47741
R2697 VSS.t8 VSS.n706 0.477286
R2698 VSS.t8 VSS.n707 0.472981
R2699 VSS.t486 VSS.t251 0.466542
R2700 VSS.t4 VSS.t353 0.466542
R2701 VSS.t430 VSS.t516 0.466542
R2702 VSS.t31 VSS.t290 0.466542
R2703 VSS.t424 VSS.t550 0.466542
R2704 VSS.t272 VSS.t246 0.466542
R2705 VSS.t230 VSS.t301 0.466542
R2706 VSS.t130 VSS.t507 0.466542
R2707 VSS.t284 VSS.t511 0.466542
R2708 VSS.t276 VSS.t267 0.466542
R2709 VSS.t259 VSS.t134 0.466542
R2710 VSS.t45 VSS.t39 0.466542
R2711 VSS.t256 VSS.t411 0.466542
R2712 VSS.t599 VSS.t6 0.466542
R2713 VSS.t483 VSS.t392 0.466542
R2714 VSS.n350 VSS.t395 0.466192
R2715 VSS.n355 VSS.t427 0.466192
R2716 VSS.n360 VSS.t281 0.466192
R2717 VSS.n365 VSS.t421 0.466192
R2718 VSS.n370 VSS.t449 0.466192
R2719 VSS.n375 VSS.t37 0.466192
R2720 VSS.n380 VSS.t433 0.466192
R2721 VSS.n385 VSS.t555 0.466192
R2722 VSS.n390 VSS.t406 0.466192
R2723 VSS.n395 VSS.t418 0.466192
R2724 VSS.n400 VSS.t446 0.466192
R2725 VSS.n405 VSS.t587 0.466192
R2726 VSS.n410 VSS.t436 0.466192
R2727 VSS.n415 VSS.t477 0.466192
R2728 VSS.n420 VSS.t15 0.466192
R2729 VSS.n425 VSS.t443 0.466192
R2730 VSS.n702 VSS.n628 0.465582
R2731 VSS.n642 VSS.t116 0.464894
R2732 VSS.n638 VSS.n636 0.460744
R2733 VSS.n639 VSS.n638 0.455207
R2734 VSS.t10 VSS.n425 0.451785
R2735 VSS.t251 VSS.n420 0.451785
R2736 VSS.t353 VSS.n415 0.451785
R2737 VSS.t516 VSS.n410 0.451785
R2738 VSS.t290 VSS.n405 0.451785
R2739 VSS.t550 VSS.n400 0.451785
R2740 VSS.t246 VSS.n395 0.451785
R2741 VSS.t301 VSS.n390 0.451785
R2742 VSS.t507 VSS.n385 0.451785
R2743 VSS.t511 VSS.n380 0.451785
R2744 VSS.t267 VSS.n375 0.451785
R2745 VSS.t134 VSS.n370 0.451785
R2746 VSS.t39 VSS.n365 0.451785
R2747 VSS.t411 VSS.n360 0.451785
R2748 VSS.t6 VSS.n355 0.451785
R2749 VSS.t392 VSS.n350 0.451785
R2750 VSS.t483 VSS.t427 0.451337
R2751 VSS.t599 VSS.t281 0.451337
R2752 VSS.t256 VSS.t421 0.451337
R2753 VSS.t45 VSS.t449 0.451337
R2754 VSS.t259 VSS.t37 0.451337
R2755 VSS.t276 VSS.t433 0.451337
R2756 VSS.t284 VSS.t555 0.451337
R2757 VSS.t130 VSS.t406 0.451337
R2758 VSS.t230 VSS.t418 0.451337
R2759 VSS.t272 VSS.t446 0.451337
R2760 VSS.t424 VSS.t587 0.451337
R2761 VSS.t31 VSS.t436 0.451337
R2762 VSS.t430 VSS.t477 0.451337
R2763 VSS.t4 VSS.t15 0.451337
R2764 VSS.t486 VSS.t443 0.451337
R2765 VSS.n614 VSS.n613 0.447348
R2766 VSS.n901 VSS.n185 0.44402
R2767 VSS.t199 VSS.n339 0.440228
R2768 VSS.t26 VSS.n337 0.440228
R2769 VSS.t43 VSS.n335 0.440228
R2770 VSS.t202 VSS.n333 0.440228
R2771 VSS.t18 VSS.n330 0.440228
R2772 VSS.t161 VSS.n328 0.440228
R2773 VSS.t146 VSS.n326 0.440228
R2774 VSS.t212 VSS.n325 0.440228
R2775 VSS.t215 VSS.n323 0.440228
R2776 VSS.t148 VSS.n321 0.440228
R2777 VSS.t152 VSS.n318 0.440228
R2778 VSS.t155 VSS.n316 0.440228
R2779 VSS.t225 VSS.n315 0.440228
R2780 VSS.t223 VSS.n314 0.440228
R2781 VSS.t12 VSS.n312 0.440228
R2782 VSS.t227 VSS.n311 0.440228
R2783 VSS.n313 VSS.t1 0.440228
R2784 VSS.n317 VSS.t144 0.440228
R2785 VSS.n319 VSS.t33 0.440228
R2786 VSS.n320 VSS.t217 0.440228
R2787 VSS.n322 VSS.t219 0.440228
R2788 VSS.n324 VSS.t221 0.440228
R2789 VSS.n327 VSS.t157 0.440228
R2790 VSS.n329 VSS.t209 0.440228
R2791 VSS.n331 VSS.t207 0.440228
R2792 VSS.n332 VSS.t204 0.440228
R2793 VSS.n334 VSS.t132 0.440228
R2794 VSS.n336 VSS.t142 0.440228
R2795 VSS.n338 VSS.t140 0.440228
R2796 VSS.n340 VSS.t120 0.440228
R2797 VSS.n341 VSS.t197 0.440228
R2798 VSS.n827 VSS.n575 0.418268
R2799 VSS.n796 VSS.n795 0.418268
R2800 VSS.n795 VSS.n575 0.414988
R2801 VSS.n797 VSS.n796 0.414988
R2802 VSS.n703 VSS.n579 0.41014
R2803 VSS.t348 VSS.n63 0.400619
R2804 VSS.n758 VSS.n550 0.376066
R2805 VSS.n759 VSS.n757 0.374771
R2806 VSS.n7 VSS.n3 0.351198
R2807 VSS.n784 VSS.n740 0.339754
R2808 VSS.n744 VSS.n532 0.338265
R2809 VSS.n561 VSS.n532 0.338019
R2810 VSS.n745 VSS.n740 0.336447
R2811 VSS.n770 VSS.n596 0.33508
R2812 VSS.n822 VSS.n346 0.329994
R2813 VSS.n603 VSS.n602 0.312321
R2814 VSS.n824 VSS.n823 0.31114
R2815 VSS.n757 VSS.n756 0.307571
R2816 VSS.t53 VSS.n216 0.306378
R2817 VSS.t64 VSS.n232 0.306378
R2818 VSS.t75 VSS.n247 0.306378
R2819 VSS.t86 VSS.n270 0.306378
R2820 VSS.t97 VSS.n284 0.306378
R2821 VSS.t108 VSS.n298 0.306378
R2822 VSS.n755 VSS.n550 0.306341
R2823 VSS.t227 VSS.t122 0.302153
R2824 VSS.n702 VSS.t299 0.298621
R2825 VSS.n186 VSS.n900 0.295237
R2826 VSS.n428 VSS.t10 0.290734
R2827 VSS.t572 VSS.n828 0.286777
R2828 VSS.n570 VSS.t572 0.2861
R2829 VSS.n849 VSS.n299 0.282782
R2830 VSS.n652 VSS.n651 0.280152
R2831 VSS.t184 VSS.n586 0.276107
R2832 VSS.n511 VSS.t395 0.275961
R2833 VSS.n900 VSS.n187 0.275933
R2834 VSS.n513 VSS.n342 0.272321
R2835 VSS.n516 VSS.n511 0.272065
R2836 VSS.n94 VSS.n126 0.267794
R2837 VSS.n94 VSS.n127 0.267794
R2838 VSS.n94 VSS.n128 0.267794
R2839 VSS.n94 VSS.n130 0.267794
R2840 VSS.n94 VSS.n179 0.267794
R2841 VSS.n94 VSS.n178 0.267794
R2842 VSS.n94 VSS.n132 0.267794
R2843 VSS.n94 VSS.n133 0.267794
R2844 VSS.n94 VSS.n134 0.267794
R2845 VSS.n94 VSS.n135 0.267794
R2846 VSS.n94 VSS.n136 0.267794
R2847 VSS.n94 VSS.n137 0.267794
R2848 VSS.n94 VSS.n138 0.267794
R2849 VSS.n94 VSS.n177 0.267794
R2850 VSS.n94 VSS.n176 0.267794
R2851 VSS.n94 VSS.n140 0.267794
R2852 VSS.n94 VSS.n141 0.267794
R2853 VSS.n94 VSS.n142 0.267794
R2854 VSS.n94 VSS.n143 0.267794
R2855 VSS.n94 VSS.n144 0.267794
R2856 VSS.n94 VSS.n145 0.267794
R2857 VSS.n94 VSS.n146 0.267794
R2858 VSS.n94 VSS.n175 0.267794
R2859 VSS.n94 VSS.n147 0.267794
R2860 VSS.n94 VSS.n148 0.267794
R2861 VSS.n94 VSS.n149 0.267794
R2862 VSS.n94 VSS.n151 0.267794
R2863 VSS.n94 VSS.n173 0.267794
R2864 VSS.n94 VSS.n172 0.267794
R2865 VSS.n94 VSS.n171 0.267794
R2866 VSS.n94 VSS.n170 0.267794
R2867 VSS.n94 VSS.n152 0.267794
R2868 VSS.n94 VSS.n153 0.267794
R2869 VSS.n94 VSS.n169 0.267794
R2870 VSS.n94 VSS.n168 0.267794
R2871 VSS.n94 VSS.n154 0.267794
R2872 VSS.n94 VSS.n155 0.267794
R2873 VSS.n94 VSS.n156 0.267794
R2874 VSS.n94 VSS.n167 0.267794
R2875 VSS.n94 VSS.n166 0.267794
R2876 VSS.n94 VSS.n165 0.267794
R2877 VSS.n94 VSS.n158 0.267794
R2878 VSS.n94 VSS.n159 0.267794
R2879 VSS.n94 VSS.n160 0.267794
R2880 VSS.n94 VSS.n96 0.267794
R2881 VSS.n94 VSS.n97 0.267794
R2882 VSS.n94 VSS.n99 0.267794
R2883 VSS.n94 VSS.n100 0.267794
R2884 VSS.n94 VSS.n101 0.267794
R2885 VSS.n94 VSS.n102 0.267794
R2886 VSS.n94 VSS.n106 0.267794
R2887 VSS.n94 VSS.n107 0.267794
R2888 VSS.n94 VSS.n108 0.267794
R2889 VSS.n94 VSS.n109 0.267794
R2890 VSS.n94 VSS.n111 0.267794
R2891 VSS.n94 VSS.n112 0.267794
R2892 VSS.n94 VSS.n114 0.267794
R2893 VSS.n94 VSS.n115 0.267794
R2894 VSS.n94 VSS.n117 0.267794
R2895 VSS.n94 VSS.n118 0.267794
R2896 VSS.n94 VSS.n120 0.267794
R2897 VSS.n94 VSS.n121 0.267794
R2898 VSS.n94 VSS.n122 0.267794
R2899 VSS.n94 VSS.n124 0.267794
R2900 VSS.n94 VSS.n161 0.267428
R2901 VSS.n599 VSS.n586 0.2661
R2902 VSS.n827 VSS.n826 0.265497
R2903 VSS.t159 VSS.n342 0.264468
R2904 VSS.n826 VSS.n825 0.264227
R2905 VSS.n209 VSS.t389 0.263148
R2906 VSS.n216 VSS.t55 0.255324
R2907 VSS.n232 VSS.t66 0.255324
R2908 VSS.n247 VSS.t77 0.255324
R2909 VSS.n270 VSS.t88 0.255324
R2910 VSS.n284 VSS.t99 0.255324
R2911 VSS.n298 VSS.t110 0.255324
R2912 VSS.t122 VSS.t336 0.254653
R2913 VSS.n94 VSS.n521 0.253551
R2914 VSS.t602 VSS.n428 0.24355
R2915 VSS.n596 VSS.n580 0.241289
R2916 VSS.t248 VSS.n701 0.241078
R2917 VSS.t365 VSS.n676 0.241078
R2918 VSS.n840 VSS.n346 0.24011
R2919 VSS.n830 VSS.n570 0.239006
R2920 VSS.t578 VSS.n563 0.239006
R2921 VSS.n802 VSS.n801 0.239006
R2922 VSS.n786 VSS.n806 0.239006
R2923 VSS.n807 VSS.n785 0.239006
R2924 VSS.n810 VSS.n809 0.239006
R2925 VSS.n782 VSS.n781 0.239006
R2926 VSS.t311 VSS.n572 0.239006
R2927 VSS.n792 VSS.t305 0.239006
R2928 VSS.n828 VSS.t571 0.238668
R2929 VSS.n563 VSS.n831 0.238668
R2930 VSS.n801 VSS.n800 0.238668
R2931 VSS.n806 VSS.t568 0.238668
R2932 VSS.n809 VSS.n808 0.238668
R2933 VSS.n811 VSS.n810 0.238668
R2934 VSS.n781 VSS.n780 0.238668
R2935 VSS.t305 VSS.n798 0.238668
R2936 VSS.n785 VSS.t569 0.238668
R2937 VSS.n566 VSS.t574 0.238668
R2938 VSS.n604 VSS.n603 0.238218
R2939 VSS.n650 VSS.n649 0.233757
R2940 VSS.n653 VSS.n652 0.233757
R2941 VSS.n660 VSS.n659 0.233757
R2942 VSS.n649 VSS.t195 0.233419
R2943 VSS.n651 VSS.n650 0.233419
R2944 VSS.n659 VSS.n658 0.233419
R2945 VSS.n592 VSS.n590 0.225543
R2946 VSS.t60 VSS.t62 0.224424
R2947 VSS.t104 VSS.t106 0.224424
R2948 VSS.t93 VSS.t95 0.224424
R2949 VSS.t82 VSS.t84 0.224424
R2950 VSS.t71 VSS.t73 0.224424
R2951 VSS.t49 VSS.t51 0.224424
R2952 VSS.t59 VSS.t60 0.220674
R2953 VSS.t104 VSS.t103 0.220674
R2954 VSS.t93 VSS.t92 0.220674
R2955 VSS.t82 VSS.t81 0.220674
R2956 VSS.t71 VSS.t70 0.220674
R2957 VSS.t49 VSS.t48 0.220674
R2958 VSS.n610 VSS.n590 0.219552
R2959 VSS.t8 VSS.n711 0.211735
R2960 VSS.n818 VSS.n579 0.20686
R2961 VSS.n93 VSS.n308 0.297117
R2962 VSS.n615 VSS.n595 0.191235
R2963 VSS.n567 VSS.n830 0.191235
R2964 VSS.t574 VSS.n567 0.191235
R2965 VSS.n18 VSS.n566 0.333813
R2966 VSS.t576 VSS.n18 0.286042
R2967 VSS.n831 VSS.t577 0.191235
R2968 VSS.n832 VSS.n562 0.191235
R2969 VSS.n833 VSS.n832 0.191235
R2970 VSS.n799 VSS.n792 0.191235
R2971 VSS.n800 VSS.n799 0.191235
R2972 VSS.n803 VSS.n802 0.191235
R2973 VSS.n804 VSS.n803 0.191235
R2974 VSS.n804 VSS.n788 0.191235
R2975 VSS.t569 VSS.n786 0.191235
R2976 VSS.n808 VSS.n807 0.191235
R2977 VSS.n431 VSS.n93 0.23732
R2978 VSS.t571 VSS.t311 0.191235
R2979 VSS.n788 VSS.t568 0.191235
R2980 VSS.n16 VSS.t576 0.0953067
R2981 VSS.n562 VSS.t578 0.191235
R2982 VSS.t326 VSS.t323 0.1875
R2983 VSS.t320 VSS.t316 0.1875
R2984 VSS.t332 VSS.t329 0.1875
R2985 VSS.n654 VSS.n653 0.187025
R2986 VSS.n655 VSS.n654 0.187025
R2987 VSS.n656 VSS.n655 0.187025
R2988 VSS.n657 VSS.n656 0.187025
R2989 VSS.n658 VSS.n657 0.187025
R2990 VSS.n661 VSS.n660 0.187025
R2991 VSS.n662 VSS.n661 0.187025
R2992 VSS.n635 VSS.n662 0.187025
R2993 VSS.t178 VSS.n635 0.187025
R2994 VSS.n783 VSS.n768 0.185557
R2995 VSS.n776 VSS.n767 0.181924
R2996 VSS.n777 VSS.n546 0.181924
R2997 VSS.n773 VSS.n772 0.180041
R2998 VSS.n795 VSS.t303 0.167615
R2999 VSS.n768 VSS.n767 0.164424
R3000 VSS.n778 VSS.n546 0.164424
R3001 VSS.n94 VSS.n181 0.160396
R3002 VSS.n94 VSS.n183 0.160396
R3003 VSS.n94 VSS.n184 0.160396
R3004 VSS.n572 VSS.n574 0.15955
R3005 VSS.n637 VSS.n594 0.156138
R3006 VSS.n824 VSS.n576 0.150687
R3007 VSS.t168 VSS.n91 0.149502
R3008 VSS.t188 VSS.n91 0.149428
R3009 VSS.n876 VSS.n248 0.144066
R3010 VSS.n26 VSS.n775 0.239006
R3011 VSS.t339 VSS.n308 0.139294
R3012 VSS.t172 VSS.n91 0.138776
R3013 VSS.t181 VSS.n91 0.13875
R3014 VSS.t163 VSS.n91 0.138729
R3015 VSS.t180 VSS.n91 0.138705
R3016 VSS.n823 VSS.n185 0.138073
R3017 VSS.t333 VSS.t602 0.135868
R3018 VSS.t336 VSS.n310 0.124618
R3019 VSS.t333 VSS.n307 0.122118
R3020 VSS.n310 VSS.t335 0.122118
R3021 VSS.n779 VSS.t308 0.1171
R3022 VSS.n798 VSS.n793 0.112118
R3023 VSS.n771 VSS.n542 0.111556
R3024 VSS.t176 VSS.n91 0.11127
R3025 VSS.t452 VSS.n299 0.109701
R3026 VSS.n431 VSS.t337 0.109642
R3027 VSS.n777 VSS.n541 0.104618
R3028 VSS.n776 VSS.n760 0.104618
R3029 VSS.t321 VSS.n587 0.0971176
R3030 VSS.n637 VSS.n595 0.0971176
R3031 VSS.n780 VSS.n779 0.0971176
R3032 VSS.t193 VSS.n91 0.0960217
R3033 VSS.n772 VSS.n771 0.0958676
R3034 VSS.n594 VSS.n593 0.0958002
R3035 VSS.n593 VSS.n591 0.0955
R3036 VSS.n783 VSS.n621 0.0949351
R3037 VSS.n605 VSS.n604 0.093
R3038 VSS.t327 VSS.n345 0.08925
R3039 VSS.n518 VSS.t538 0.08925
R3040 VSS.t323 VSS.n612 0.0851154
R3041 VSS.n613 VSS.t326 0.0851154
R3042 VSS.t316 VSS.n601 0.0851154
R3043 VSS.n602 VSS.t320 0.0851154
R3044 VSS.t329 VSS.n515 0.0851154
R3045 VSS.n516 VSS.t332 0.0851154
R3046 VSS.n643 VSS.t21 0.0846176
R3047 VSS.n648 VSS.n578 0.0846176
R3048 VSS.n744 VSS.n536 0.08425
R3049 VSS.n746 VSS.n745 0.08425
R3050 VSS.n601 VSS.n4 0.08175
R3051 VSS.n612 VSS.n607 0.08175
R3052 VSS.n600 VSS.n584 0.08175
R3053 VSS.n611 VSS.n588 0.08175
R3054 VSS.n848 VSS.n847 0.0805
R3055 VSS.n771 VSS.n543 0.0805
R3056 VSS.n574 VSS.n573 0.0796176
R3057 VSS.n793 VSS.n794 0.0796176
R3058 VSS.t296 VSS.n520 0.078
R3059 VSS.t339 VSS.n309 0.0771176
R3060 VSS.n573 VSS.n827 0.0758676
R3061 VSS.n794 VSS.n797 0.0758676
R3062 VSS.n515 VSS.n347 0.0746176
R3063 VSS.n514 VSS.n344 0.0746176
R3064 VSS.n820 VSS.n577 0.07425
R3065 VSS.n778 VSS.n543 0.07425
R3066 VSS.t314 VSS.n581 0.0740901
R3067 VSS.t610 VSS.n577 0.07175
R3068 VSS.t28 VSS.n521 0.0715288
R3069 VSS.t164 VSS.n643 0.0708676
R3070 VSS.t179 VSS.n648 0.0708676
R3071 VSS.t335 VSS.n309 0.0696176
R3072 VSS.n515 VSS.t560 0.06925
R3073 VSS.t53 VSS.n214 0.06925
R3074 VSS.t64 VSS.n226 0.06925
R3075 VSS.t75 VSS.n245 0.06925
R3076 VSS.t86 VSS.n268 0.06925
R3077 VSS.t97 VSS.n282 0.06925
R3078 VSS.t108 VSS.n296 0.06925
R3079 VSS.n755 VSS.n536 0.06925
R3080 VSS.n756 VSS.n746 0.06925
R3081 VSS.n514 VSS.n343 0.06925
R3082 VSS.n602 VSS.n598 0.0671176
R3083 VSS.n613 VSS.n609 0.0671176
R3084 VSS.n599 VSS.n585 0.0671176
R3085 VSS.n610 VSS.n589 0.0671176
R3086 VSS.n601 VSS.n598 0.0621177
R3087 VSS.n612 VSS.n609 0.0621177
R3088 VSS.n600 VSS.n585 0.0621177
R3089 VSS.n611 VSS.n589 0.0621177
R3090 VSS.n513 VSS.n343 0.05925
R3091 VSS.n516 VSS.t560 0.05925
R3092 VSS.t184 VSS.n587 0.0571176
R3093 VSS.n775 VSS.n774 0.0558676
R3094 VSS.t538 VSS.n347 0.0546176
R3095 VSS.t327 VSS.n344 0.0546176
R3096 VSS.n214 VSS.t51 0.05175
R3097 VSS.t62 VSS.n226 0.05175
R3098 VSS.n245 VSS.t73 0.05175
R3099 VSS.n268 VSS.t84 0.05175
R3100 VSS.n282 VSS.t95 0.05175
R3101 VSS.n296 VSS.t106 0.05175
R3102 VSS.n621 VSS.n782 0.0508676
R3103 VSS.n758 VSS.n541 0.0496177
R3104 VSS.n760 VSS.n759 0.0496177
R3105 VSS.n582 VSS.n580 0.04925
R3106 VSS.t317 VSS.n582 0.04925
R3107 VSS.n606 VSS.n605 0.04925
R3108 VSS.n607 VSS.n606 0.04675
R3109 VSS.t321 VSS.n588 0.04675
R3110 VSS.n779 VSS.n26 0.14205
R3111 VSS.n7 VSS.n6 0.0161289
R3112 VSS.n774 VSS.n773 0.0371729
R3113 VSS.t610 VSS.n542 0.0353056
R3114 VSS.n817 VSS.n4 0.0305
R3115 VSS.n584 VSS.n583 0.0305
R3116 VSS.t337 VSS.n162 0.02925
R3117 VSS.n770 VSS.n581 0.0253401
R3118 VSS.n849 VSS.n306 0.023135
R3119 VSS.n849 VSS.n302 0.023135
R3120 VSS.n853 VSS.n852 0.023135
R3121 VSS.n858 VSS.n287 0.023135
R3122 VSS.n858 VSS.n288 0.023135
R3123 VSS.n862 VSS.n861 0.023135
R3124 VSS.n867 VSS.n273 0.023135
R3125 VSS.n867 VSS.n274 0.023135
R3126 VSS.n871 VSS.n870 0.023135
R3127 VSS.n876 VSS.n251 0.023135
R3128 VSS.n876 VSS.n253 0.023135
R3129 VSS.n876 VSS.n254 0.023135
R3130 VSS.n876 VSS.n255 0.023135
R3131 VSS.n880 VSS.n879 0.023135
R3132 VSS.n885 VSS.n235 0.023135
R3133 VSS.n885 VSS.n236 0.023135
R3134 VSS.n888 VSS.n230 0.023135
R3135 VSS.n891 VSS.n218 0.023135
R3136 VSS.n891 VSS.n219 0.023135
R3137 VSS.n895 VSS.n894 0.023135
R3138 VSS.n900 VSS.n189 0.023135
R3139 VSS.n900 VSS.n193 0.023135
R3140 VSS.n900 VSS.n203 0.023135
R3141 VSS.n847 VSS.n307 0.02175
R3142 VSS.n186 VSS.t398 0.0191553
R3143 VSS.n695 VSS.t381 0.0184075
R3144 VSS.n681 VSS.t379 0.0184075
R3145 VSS.t8 VSS.n708 0.0173993
R3146 VSS.n817 VSS.t317 0.01675
R3147 VSS.n583 VSS.t314 0.01675
R3148 VSS.n94 VSS.n180 0.0165542
R3149 VSS.n94 VSS.n182 0.0165542
R3150 VSS.n848 VSS.n162 0.0155
R3151 VSS.t348 VSS.n62 0.0151406
R3152 VSS.n689 VSS.n67 0.0151406
R3153 VSS.n688 VSS.n67 0.0151406
R3154 VSS.n677 VSS.n631 0.0151406
R3155 VSS.t8 VSS.n704 0.0150892
R3156 VSS VSS.n901 0.0134067
R3157 VSS.n592 VSS.n591 0.013
R3158 VSS.n94 VSS.n174 0.00962826
R3159 VSS.n94 VSS.n164 0.00962826
R3160 VSS.n94 VSS.n163 0.00937856
R3161 VSS.n94 VSS.n98 0.00937856
R3162 VSS.n94 VSS.n110 0.00937856
R3163 VSS.n94 VSS.n119 0.00937856
R3164 VSS.n94 VSS.n129 0.00937856
R3165 VSS.n94 VSS.n131 0.00937856
R3166 VSS.n94 VSS.n139 0.00937856
R3167 VSS.n94 VSS.n150 0.00937856
R3168 VSS.n94 VSS.n157 0.00937856
R3169 VSS.n94 VSS.n103 0.00937856
R3170 VSS.n94 VSS.n104 0.00937856
R3171 VSS.n94 VSS.n105 0.00937856
R3172 VSS.n94 VSS.n113 0.00937856
R3173 VSS.n94 VSS.n116 0.00937856
R3174 VSS.n94 VSS.n123 0.00937856
R3175 VSS.n94 VSS.n125 0.00937856
R3176 VSS.n840 VSS.n518 0.00675
R3177 VSS.n822 VSS.n345 0.00675
R3178 VSS.n79 VSS.n645 0.00649396
R3179 VSS.n35 VSS.n36 0.00499884
R3180 VSS.n86 VSS.n644 0.00495229
R3181 VSS.n10 VSS.n27 0.00483237
R3182 VSS.n821 VSS.n12 0.00459701
R3183 VSS.n12 VSS.n11 0.00433308
R3184 VSS.n41 VSS.n42 0.00399966
R3185 VSS.n15 VSS.n14 0.00369993
R3186 VSS.n10 VSS.n9 0.00349974
R3187 VSS.n7 VSS.n0 0.00296307
R3188 VSS.n28 VSS.n20 0.00283329
R3189 VSS.n56 VSS.n55 0.00249999
R3190 VSS.n46 VSS.n50 0.00283308
R3191 VSS.n47 VSS.n45 0.00249999
R3192 VSS.n31 VSS.n568 0.00283308
R3193 VSS.n25 VSS.n22 0.00262501
R3194 VSS.n92 VSS.n94 0.00105218
R3195 VSS.n835 VSS.n12 0.00193134
R3196 VSS.n7 VSS.n2 0.00186142
R3197 VSS.n304 VSS.n297 0.00179957
R3198 VSS.n303 VSS.n297 0.00179957
R3199 VSS.n855 VSS.n293 0.00179957
R3200 VSS.n290 VSS.n283 0.00179957
R3201 VSS.n289 VSS.n283 0.00179957
R3202 VSS.n864 VSS.n279 0.00179957
R3203 VSS.n276 VSS.n269 0.00179957
R3204 VSS.n275 VSS.n269 0.00179957
R3205 VSS.n873 VSS.n265 0.00179957
R3206 VSS.n257 VSS.n246 0.00179957
R3207 VSS.n256 VSS.n246 0.00179957
R3208 VSS.n882 VSS.n242 0.00179957
R3209 VSS.n239 VSS.n231 0.00179957
R3210 VSS.n238 VSS.n231 0.00179957
R3211 VSS.n228 VSS.n225 0.00179957
R3212 VSS.n221 VSS.n215 0.00179957
R3213 VSS.n220 VSS.n215 0.00179957
R3214 VSS.n897 VSS.n211 0.00179957
R3215 VSS.n900 VSS.n196 0.00179957
R3216 VSS.n900 VSS.n198 0.00179957
R3217 VSS.n900 VSS.n202 0.00179957
R3218 VSS.n75 VSS.n74 0.00242827
R3219 VSS.n68 VSS.n67 0.0022
R3220 VSS.n769 VSS.n20 0.00166667
R3221 VSS.n25 VSS.n21 0.00169993
R3222 VSS.n829 VSS.n524 0.00166667
R3223 VSS.n569 VSS.n523 0.00166667
R3224 VSS.n568 VSS.n525 0.00166667
R3225 VSS.n35 VSS.n34 0.00129163
R3226 VSS.n41 VSS.n40 0.00138884
R3227 VSS.n45 VSS.n44 0.00149995
R3228 VSS.n789 VSS.n787 0.00166667
R3229 VSS.n57 VSS.n56 0.00149995
R3230 VSS.n61 VSS.n60 0.00169993
R3231 VSS.n77 VSS.n76 0.00169993
R3232 VSS.n645 VSS.n634 0.00166667
R3233 VSS.n11 VSS.n9 0.0015
R3234 VSS.n91 VSS.n90 0.0015
R3235 VSS.n646 VSS.n77 0.0015
R3236 VSS.n647 VSS.n75 0.0015
R3237 VSS.n72 VSS.n71 0.00214264
R3238 VSS.n72 VSS.t379 0.0015
R3239 VSS.n67 VSS.t379 0.0015
R3240 VSS.n59 VSS.n22 0.00137498
R3241 VSS.n700 VSS.t348 0.00136832
R3242 VSS.n789 VSS.n51 0.00133332
R3243 VSS.n571 VSS.n524 0.00133332
R3244 VSS.n829 VSS.n523 0.00133332
R3245 VSS.n569 VSS.n525 0.00133332
R3246 VSS.n646 VSS.n634 0.00133332
R3247 VSS.n664 VSS.n91 0.00113181
R3248 VSS.n900 VSS.n210 0.00104691
R3249 VSS.n7 VSS.n5 0.00103597
R3250 VSS.n672 VSS.n91 0.00103133
R3251 VSS.n669 VSS.n91 0.00103066
R3252 VSS.n7 VSS.n1 0.00102591
R3253 VSS.n849 VSS.n301 0.00101811
R3254 VSS.n858 VSS.n857 0.00101811
R3255 VSS.n858 VSS.n292 0.00101811
R3256 VSS.n867 VSS.n866 0.00101811
R3257 VSS.n867 VSS.n278 0.00101811
R3258 VSS.n876 VSS.n875 0.00101811
R3259 VSS.n876 VSS.n259 0.00101811
R3260 VSS.n885 VSS.n884 0.00101811
R3261 VSS.n885 VSS.n241 0.00101811
R3262 VSS.n891 VSS.n224 0.00101811
R3263 VSS.n891 VSS.n223 0.00101811
R3264 VSS.n900 VSS.n899 0.00101811
R3265 VSS.n665 VSS.n91 0.00100072
R3266 VSS.n876 VSS.n262 0.00100065
R3267 VSS.n849 VSS.n300 0.00100065
R3268 VSS.n876 VSS.n252 0.00100065
R3269 VSS.n876 VSS.n260 0.00100065
R3270 VSS.n900 VSS.n190 0.00100065
R3271 VSS.n667 VSS.n91 0.00100038
R3272 VSS.n666 VSS.n91 0.00100001
R3273 VSS.n668 VSS.n91 0.00100001
R3274 VSS.n670 VSS.n91 0.001
R3275 VSS.n671 VSS.n91 0.001
R3276 VSS.n850 VSS.n297 0.001
R3277 VSS.n852 VSS.n851 0.001
R3278 VSS.n855 VSS.n294 0.001
R3279 VSS.n858 VSS.n286 0.001
R3280 VSS.n859 VSS.n283 0.001
R3281 VSS.n861 VSS.n860 0.001
R3282 VSS.n864 VSS.n280 0.001
R3283 VSS.n867 VSS.n272 0.001
R3284 VSS.n868 VSS.n269 0.001
R3285 VSS.n870 VSS.n869 0.001
R3286 VSS.n873 VSS.n266 0.001
R3287 VSS.n876 VSS.n250 0.001
R3288 VSS.n877 VSS.n246 0.001
R3289 VSS.n879 VSS.n878 0.001
R3290 VSS.n882 VSS.n243 0.001
R3291 VSS.n885 VSS.n234 0.001
R3292 VSS.n886 VSS.n231 0.001
R3293 VSS.n888 VSS.n887 0.001
R3294 VSS.n889 VSS.n225 0.001
R3295 VSS.n891 VSS.n890 0.001
R3296 VSS.n892 VSS.n215 0.001
R3297 VSS.n894 VSS.n893 0.001
R3298 VSS.n897 VSS.n212 0.001
R3299 VSS.n900 VSS.n188 0.001
R3300 VSS.n897 VSS.n188 0.001
R3301 VSS.n894 VSS.n212 0.001
R3302 VSS.n893 VSS.n215 0.001
R3303 VSS.n892 VSS.n891 0.001
R3304 VSS.n890 VSS.n225 0.001
R3305 VSS.n889 VSS.n888 0.001
R3306 VSS.n887 VSS.n231 0.001
R3307 VSS.n886 VSS.n885 0.001
R3308 VSS.n882 VSS.n234 0.001
R3309 VSS.n879 VSS.n243 0.001
R3310 VSS.n878 VSS.n246 0.001
R3311 VSS.n877 VSS.n876 0.001
R3312 VSS.n873 VSS.n250 0.001
R3313 VSS.n870 VSS.n266 0.001
R3314 VSS.n869 VSS.n269 0.001
R3315 VSS.n868 VSS.n867 0.001
R3316 VSS.n864 VSS.n272 0.001
R3317 VSS.n861 VSS.n280 0.001
R3318 VSS.n860 VSS.n283 0.001
R3319 VSS.n859 VSS.n858 0.001
R3320 VSS.n855 VSS.n286 0.001
R3321 VSS.n852 VSS.n294 0.001
R3322 VSS.n851 VSS.n297 0.001
R3323 VSS.n850 VSS.n849 0.001
R3324 VSS.n790 VSS.n43 0.001
R3325 VSS.n48 VSS.n51 0.001
R3326 VSS.n53 VSS.n52 0.001
R3327 VSS.n571 VSS.n29 0.001
R3328 VSS.n565 VSS.n32 0.001
R3329 VSS.n564 VSS.n33 0.001
R3330 VSS.n66 VSS.n65 0.00192843
R3331 VSS.n65 VSS.t381 0.0015
R3332 VSS.t348 VSS.t381 0.0015
R3333 VSS.n60 VSS.n59 0.0015
R3334 VSS.n55 VSS.n58 0.0015
R3335 VSS.n54 VSS.n787 0.00199997
R3336 VSS.n47 VSS.n46 0.0015
R3337 VSS.n791 VSS.n12 0.0015
R3338 VSS.n38 VSS.n9 0.0015
R3339 VSS.n8 VSS.n816 8.50175
R3340 VSS.n677 VSS.n73 0.001
R3341 VSS.n644 VSS.n84 0.001
R3342 VSS.n90 VSS.n89 0.001
R3343 VSS.n641 VSS.n616 0.001
R3344 VSS.t8 VSS.n616 0.001
R3345 VSS.n8 VSS.n7 0.00125
R3346 VSS.n8 VSS.n615 8.47794
R3347 a_3747_311.n0 a_3747_311.t2 52.0388
R3348 a_3747_311.t1 a_3747_311.n0 35.4491
R3349 a_3747_311.n0 a_3747_311.t3 33.5891
R3350 a_3747_311.t0 a_3747_311.t1 5.61942
R3351 a_3171_311.n0 a_3171_311.t2 51.8377
R3352 a_3171_311.n0 a_3171_311.t3 33.3881
R3353 a_3171_311.t1 a_3171_311.n0 31.8923
R3354 a_3171_311.t0 a_3171_311.t1 5.61777
R3355 a_2595_311.n0 a_2595_311.t2 51.6367
R3356 a_2595_311.n0 a_2595_311.t3 33.187
R3357 a_2595_311.t1 a_2595_311.n0 27.993
R3358 a_2595_311.t0 a_2595_311.t1 5.73018
R3359 a_3747_1047.n0 a_3747_1047.t2 38.0081
R3360 a_3747_1047.n0 a_3747_1047.t3 33.3957
R3361 a_3747_1047.n1 a_3747_1047.t4 33.3957
R3362 a_3747_1047.n2 a_3747_1047.t5 33.3957
R3363 a_3747_1047.n3 a_3747_1047.t6 33.3957
R3364 a_3747_1047.n4 a_3747_1047.t7 33.3957
R3365 a_3747_1047.n5 a_3747_1047.t8 33.3957
R3366 a_3747_1047.n6 a_3747_1047.t9 33.3957
R3367 a_3747_1047.t1 a_3747_1047.n6 23.2419
R3368 a_3747_1047.t0 a_3747_1047.t1 5.61942
R3369 a_3747_1047.n6 a_3747_1047.n5 4.61291
R3370 a_3747_1047.n5 a_3747_1047.n4 4.61291
R3371 a_3747_1047.n4 a_3747_1047.n3 4.61291
R3372 a_3747_1047.n3 a_3747_1047.n2 4.61291
R3373 a_3747_1047.n2 a_3747_1047.n1 4.61291
R3374 a_3747_1047.n1 a_3747_1047.n0 4.61291
R3375 a_3171_1047.n0 a_3171_1047.t2 37.8054
R3376 a_3171_1047.n0 a_3171_1047.t3 33.193
R3377 a_3171_1047.n1 a_3171_1047.t4 33.193
R3378 a_3171_1047.n2 a_3171_1047.t5 33.193
R3379 a_3171_1047.n3 a_3171_1047.t6 33.193
R3380 a_3171_1047.n4 a_3171_1047.t7 33.193
R3381 a_3171_1047.n5 a_3171_1047.t8 33.193
R3382 a_3171_1047.n6 a_3171_1047.t9 33.193
R3383 a_3171_1047.t1 a_3171_1047.n6 23.0313
R3384 a_3171_1047.t0 a_3171_1047.t1 5.61777
R3385 a_3171_1047.n6 a_3171_1047.n5 4.61291
R3386 a_3171_1047.n5 a_3171_1047.n4 4.61291
R3387 a_3171_1047.n4 a_3171_1047.n3 4.61291
R3388 a_3171_1047.n3 a_3171_1047.n2 4.61291
R3389 a_3171_1047.n2 a_3171_1047.n1 4.61291
R3390 a_3171_1047.n1 a_3171_1047.n0 4.61291
R3391 a_2595_1047.n0 a_2595_1047.t2 37.7691
R3392 a_2595_1047.n0 a_2595_1047.t3 33.1567
R3393 a_2595_1047.n1 a_2595_1047.t4 33.1567
R3394 a_2595_1047.n2 a_2595_1047.t5 33.1567
R3395 a_2595_1047.n3 a_2595_1047.t6 33.1567
R3396 a_2595_1047.n4 a_2595_1047.t7 33.1567
R3397 a_2595_1047.n5 a_2595_1047.t8 33.1567
R3398 a_2595_1047.n6 a_2595_1047.t9 33.1567
R3399 a_2595_1047.t1 a_2595_1047.n6 22.7941
R3400 a_2595_1047.t0 a_2595_1047.t1 5.65522
R3401 a_2595_1047.n6 a_2595_1047.n5 4.61291
R3402 a_2595_1047.n5 a_2595_1047.n4 4.61291
R3403 a_2595_1047.n4 a_2595_1047.n3 4.61291
R3404 a_2595_1047.n3 a_2595_1047.n2 4.61291
R3405 a_2595_1047.n2 a_2595_1047.n1 4.61291
R3406 a_2595_1047.n1 a_2595_1047.n0 4.61291
R3407 a_2019_1047.n0 a_2019_1047.t2 37.9701
R3408 a_2019_1047.n0 a_2019_1047.t3 33.3577
R3409 a_2019_1047.n1 a_2019_1047.t4 33.3577
R3410 a_2019_1047.n2 a_2019_1047.t5 33.3577
R3411 a_2019_1047.n3 a_2019_1047.t6 33.3577
R3412 a_2019_1047.n4 a_2019_1047.t7 33.3577
R3413 a_2019_1047.n5 a_2019_1047.t8 33.3577
R3414 a_2019_1047.t1 a_2019_1047.t9 22.5945
R3415 a_2019_1047.t0 a_2019_1047.t1 5.62052
R3416 a_2019_1047.t9 a_2019_1047.n5 4.61291
R3417 a_2019_1047.n5 a_2019_1047.n4 4.61291
R3418 a_2019_1047.n4 a_2019_1047.n3 4.61291
R3419 a_2019_1047.n3 a_2019_1047.n2 4.61291
R3420 a_2019_1047.n2 a_2019_1047.n1 4.61291
R3421 a_2019_1047.n1 a_2019_1047.n0 4.61291
C1413 MUX_OUT VSS 3.24058f
C1414 MUX_SEL4 VSS 1.60778f
C1415 MUX_SEL3 VSS 0.90686f
C1416 MUX_SEL2 VSS 1.81137f
C1417 MUX_SEL1 VSS 0.95075f
C1418 MUX_SEL0 VSS 1.5515f
C1419 DELAY_VBIASP VSS 5.14023f
C1420 DELAY_OUT_LAST VSS 2.97841f
C1421 DELAY_VBIASN VSS 0.11242p
C1422 REF_CLK VSS 3.19236f
C1423 DLL_RESETN VSS 4.2198f
C1424 VDD VSS 61.876f
C1425 a_26985_519# VSS 0.17928f ; **FLOATING
C1426 a_23945_519# VSS 0.17928f ; **FLOATING
C1427 a_20905_519# VSS 0.17928f ; **FLOATING
C1428 a_17865_519# VSS 0.17593f ; **FLOATING
C1429 a_16851_309# VSS 0.38699f ; **FLOATING
C1430 a_16108_289# VSS 3.85084f ; **FLOATING
C1431 a_15964_289# VSS 0.17613f ; **FLOATING
C1432 a_15765_463# VSS 0.36132f ; **FLOATING
C1433 a_14825_519# VSS 0.17928f ; **FLOATING
C1434 a_11785_519# VSS 0.17928f ; **FLOATING
C1435 a_8745_519# VSS 0.17928f ; **FLOATING
C1436 a_5731_289# VSS 3.39133f ; **FLOATING
C1437 a_2019_311# VSS 1.61601f ; **FLOATING
C1438 a_5705_519# VSS 0.17638f ; **FLOATING
C1439 a_3449_331# VSS 0.18478f ; **FLOATING
C1440 a_2873_331# VSS 0.18321f ; **FLOATING
C1441 a_2297_331# VSS 0.18321f ; **FLOATING
C1442 a_1721_331# VSS 0.17001f ; **FLOATING
C1443 a_1544_289# VSS 0.30014f ; **FLOATING
C1444 a_1256_289# VSS 0.84266f ; **FLOATING
C1445 a_27991_1008# VSS 0.18706f ; **FLOATING
C1446 a_27915_1044# VSS 0.10926f ; **FLOATING
C1447 a_27124_1008# VSS 0.17878f ; **FLOATING
C1448 a_27048_1044# VSS 0.12122f ; **FLOATING
C1449 a_26471_1008# VSS 0.18175f ; **FLOATING
C1450 a_26395_1044# VSS 0.11073f ; **FLOATING
C1451 a_25604_1008# VSS 0.18087f ; **FLOATING
C1452 a_25630_1044# VSS 0.34158f ; **FLOATING
C1453 a_25528_1044# VSS 0.12433f ; **FLOATING
C1454 a_24951_1008# VSS 0.18335f ; **FLOATING
C1455 a_24875_1044# VSS 0.11016f ; **FLOATING
C1456 a_24084_1008# VSS 0.17878f ; **FLOATING
C1457 a_24008_1044# VSS 0.12122f ; **FLOATING
C1458 a_23431_1008# VSS 0.18175f ; **FLOATING
C1459 a_23355_1044# VSS 0.11073f ; **FLOATING
C1460 a_22564_1008# VSS 0.18087f ; **FLOATING
C1461 a_22590_1044# VSS 0.33314f ; **FLOATING
C1462 a_22488_1044# VSS 0.12433f ; **FLOATING
C1463 a_21911_1008# VSS 0.18335f ; **FLOATING
C1464 a_21835_1044# VSS 0.11016f ; **FLOATING
C1465 a_21044_1008# VSS 0.17878f ; **FLOATING
C1466 a_20968_1044# VSS 0.12122f ; **FLOATING
C1467 a_20391_1008# VSS 0.18175f ; **FLOATING
C1468 a_20315_1044# VSS 0.11073f ; **FLOATING
C1469 a_19524_1008# VSS 0.18087f ; **FLOATING
C1470 a_19550_1044# VSS 0.33563f ; **FLOATING
C1471 a_19448_1044# VSS 0.12433f ; **FLOATING
C1472 a_18871_1008# VSS 0.18335f ; **FLOATING
C1473 a_18795_1044# VSS 0.11016f ; **FLOATING
C1474 a_18004_1008# VSS 0.17878f ; **FLOATING
C1475 a_17928_1044# VSS 0.12122f ; **FLOATING
C1476 a_17351_1008# VSS 0.18022f ; **FLOATING
C1477 a_17275_1044# VSS 0.10926f ; **FLOATING
C1478 a_16484_1008# VSS 0.18023f ; **FLOATING
C1479 a_16510_1044# VSS 0.28935f ; **FLOATING
C1480 a_16408_1044# VSS 0.1229f ; **FLOATING
C1481 a_15831_1008# VSS 0.17846f ; **FLOATING
C1482 a_15755_1044# VSS 0.10926f ; **FLOATING
C1483 a_14964_1008# VSS 0.17878f ; **FLOATING
C1484 a_14888_1044# VSS 0.12122f ; **FLOATING
C1485 a_14311_1008# VSS 0.18175f ; **FLOATING
C1486 a_14235_1044# VSS 0.11073f ; **FLOATING
C1487 a_13444_1008# VSS 0.18087f ; **FLOATING
C1488 a_13470_1044# VSS 0.30333f ; **FLOATING
C1489 a_13368_1044# VSS 0.12433f ; **FLOATING
C1490 a_12791_1008# VSS 0.18335f ; **FLOATING
C1491 a_12715_1044# VSS 0.11016f ; **FLOATING
C1492 a_11924_1008# VSS 0.17878f ; **FLOATING
C1493 a_11848_1044# VSS 0.12122f ; **FLOATING
C1494 a_11271_1008# VSS 0.18175f ; **FLOATING
C1495 a_11195_1044# VSS 0.11073f ; **FLOATING
C1496 a_10404_1008# VSS 0.18087f ; **FLOATING
C1497 a_10430_1044# VSS 0.31665f ; **FLOATING
C1498 a_10328_1044# VSS 0.12433f ; **FLOATING
C1499 a_9751_1008# VSS 0.18335f ; **FLOATING
C1500 a_9675_1044# VSS 0.11016f ; **FLOATING
C1501 a_8884_1008# VSS 0.17878f ; **FLOATING
C1502 a_8808_1044# VSS 0.12122f ; **FLOATING
C1503 a_8231_1008# VSS 0.18175f ; **FLOATING
C1504 a_8155_1044# VSS 0.11073f ; **FLOATING
C1505 a_7364_1008# VSS 0.18087f ; **FLOATING
C1506 a_7390_1044# VSS 0.31357f ; **FLOATING
C1507 a_7288_1044# VSS 0.12433f ; **FLOATING
C1508 a_6711_1008# VSS 0.18335f ; **FLOATING
C1509 a_6635_1044# VSS 0.11016f ; **FLOATING
C1510 a_5844_1008# VSS 0.17878f ; **FLOATING
C1511 a_5768_1044# VSS 0.12122f ; **FLOATING
C1512 a_5191_1008# VSS 0.18022f ; **FLOATING
C1513 a_5115_1044# VSS 0.10926f ; **FLOATING
C1514 a_4324_1008# VSS 0.18023f ; **FLOATING
C1515 a_4350_1044# VSS 0.26655f ; **FLOATING
C1516 a_4248_1044# VSS 0.12443f ; **FLOATING
C1517 a_27705_1044# VSS 0.25297f ; **FLOATING
C1518 a_26185_1044# VSS 0.23475f ; **FLOATING
C1519 a_24665_1044# VSS 0.25433f ; **FLOATING
C1520 a_23145_1044# VSS 0.23475f ; **FLOATING
C1521 a_21625_1044# VSS 0.25433f ; **FLOATING
C1522 a_20105_1044# VSS 0.23475f ; **FLOATING
C1523 a_18585_1044# VSS 0.25433f ; **FLOATING
C1524 a_17065_1044# VSS 0.23386f ; **FLOATING
C1525 a_15545_1044# VSS 0.25297f ; **FLOATING
C1526 a_14025_1044# VSS 0.23475f ; **FLOATING
C1527 a_12505_1044# VSS 0.25433f ; **FLOATING
C1528 a_10985_1044# VSS 0.23475f ; **FLOATING
C1529 a_9465_1044# VSS 0.25433f ; **FLOATING
C1530 a_7945_1044# VSS 0.23475f ; **FLOATING
C1531 a_6425_1044# VSS 0.25433f ; **FLOATING
C1532 a_4905_1044# VSS 0.23549f ; **FLOATING
C1533 a_4157_1313# VSS 0.32875f ; **FLOATING
C1534 a_3449_1395# VSS 0.18629f ; **FLOATING
C1535 a_2873_1395# VSS 0.18349f ; **FLOATING
C1536 a_2297_1395# VSS 0.18349f ; **FLOATING
C1537 a_1721_1395# VSS 0.17029f ; **FLOATING
C1538 a_1544_1044# VSS 0.29829f ; **FLOATING
C1539 a_1256_1044# VSS 0.82974f ; **FLOATING
C1540 a_27671_1842# VSS 0.01336f ; **FLOATING
C1541 a_26911_1842# VSS 0.01336f ; **FLOATING
C1542 a_26151_1842# VSS 0.01336f ; **FLOATING
C1543 a_25391_1842# VSS 0.01336f ; **FLOATING
C1544 a_24631_1842# VSS 0.01336f ; **FLOATING
C1545 a_23871_1842# VSS 0.01336f ; **FLOATING
C1546 a_23111_1842# VSS 0.01336f ; **FLOATING
C1547 a_22351_1842# VSS 0.01336f ; **FLOATING
C1548 a_21591_1842# VSS 0.01336f ; **FLOATING
C1549 a_20831_1842# VSS 0.01336f ; **FLOATING
C1550 a_20071_1842# VSS 0.01336f ; **FLOATING
C1551 a_19311_1842# VSS 0.01336f ; **FLOATING
C1552 a_18551_1842# VSS 0.01336f ; **FLOATING
C1553 a_17791_1842# VSS 0.01336f ; **FLOATING
C1554 a_17031_1842# VSS 0.01336f ; **FLOATING
C1555 a_16271_1842# VSS 0.01336f ; **FLOATING
C1556 a_15511_1842# VSS 0.01336f ; **FLOATING
C1557 a_14751_1842# VSS 0.01336f ; **FLOATING
C1558 a_13991_1842# VSS 0.01336f ; **FLOATING
C1559 a_13231_1842# VSS 0.01336f ; **FLOATING
C1560 a_12471_1842# VSS 0.01336f ; **FLOATING
C1561 a_11711_1842# VSS 0.01336f ; **FLOATING
C1562 a_10951_1842# VSS 0.01336f ; **FLOATING
C1563 a_10191_1842# VSS 0.01336f ; **FLOATING
C1564 a_9431_1842# VSS 0.01336f ; **FLOATING
C1565 a_8671_1842# VSS 0.01336f ; **FLOATING
C1566 a_7911_1842# VSS 0.01336f ; **FLOATING
C1567 a_7151_1842# VSS 0.01336f ; **FLOATING
C1568 a_6391_1842# VSS 0.01336f ; **FLOATING
C1569 a_5631_1842# VSS 0.01336f ; **FLOATING
C1570 a_4871_1842# VSS 0.01336f ; **FLOATING
C1571 a_4111_1842# VSS 0.0139f ; **FLOATING
C1572 a_27563_1842# VSS 0.50316f ; **FLOATING
C1573 a_27997_1842# VSS 0.6484f ; **FLOATING
C1574 a_27433_1842# VSS 0.4463f ; **FLOATING
C1575 a_26803_1842# VSS 0.49934f ; **FLOATING
C1576 a_27237_1842# VSS 0.92967f ; **FLOATING
C1577 a_26673_1842# VSS 0.4492f ; **FLOATING
C1578 a_26043_1842# VSS 0.50169f ; **FLOATING
C1579 a_26477_1842# VSS 0.95928f ; **FLOATING
C1580 a_25913_1842# VSS 0.4508f ; **FLOATING
C1581 a_25283_1842# VSS 0.49938f ; **FLOATING
C1582 a_25717_1842# VSS 0.86841f ; **FLOATING
C1583 a_25153_1842# VSS 0.45035f ; **FLOATING
C1584 a_24523_1842# VSS 0.50075f ; **FLOATING
C1585 a_24957_1842# VSS 0.96341f ; **FLOATING
C1586 a_24393_1842# VSS 0.4463f ; **FLOATING
C1587 a_23763_1842# VSS 0.49934f ; **FLOATING
C1588 a_24197_1842# VSS 0.92543f ; **FLOATING
C1589 a_23633_1842# VSS 0.45062f ; **FLOATING
C1590 a_23003_1842# VSS 0.50169f ; **FLOATING
C1591 a_23437_1842# VSS 0.95769f ; **FLOATING
C1592 a_22873_1842# VSS 0.4508f ; **FLOATING
C1593 a_22243_1842# VSS 0.49938f ; **FLOATING
C1594 a_22677_1842# VSS 0.86841f ; **FLOATING
C1595 a_22113_1842# VSS 0.45249f ; **FLOATING
C1596 a_21483_1842# VSS 0.50075f ; **FLOATING
C1597 a_21917_1842# VSS 0.96341f ; **FLOATING
C1598 a_21353_1842# VSS 0.4463f ; **FLOATING
C1599 a_20723_1842# VSS 0.49992f ; **FLOATING
C1600 a_21157_1842# VSS 0.92543f ; **FLOATING
C1601 a_20593_1842# VSS 0.45196f ; **FLOATING
C1602 a_19963_1842# VSS 0.50169f ; **FLOATING
C1603 a_20397_1842# VSS 0.95769f ; **FLOATING
C1604 a_19833_1842# VSS 0.4508f ; **FLOATING
C1605 a_19203_1842# VSS 0.5005f ; **FLOATING
C1606 a_19637_1842# VSS 0.86841f ; **FLOATING
C1607 a_19073_1842# VSS 0.44947f ; **FLOATING
C1608 a_18443_1842# VSS 0.50075f ; **FLOATING
C1609 a_18877_1842# VSS 0.96341f ; **FLOATING
C1610 a_18313_1842# VSS 0.4463f ; **FLOATING
C1611 a_17683_1842# VSS 0.50046f ; **FLOATING
C1612 a_18117_1842# VSS 0.92543f ; **FLOATING
C1613 a_17553_1842# VSS 0.44782f ; **FLOATING
C1614 a_16923_1842# VSS 0.50165f ; **FLOATING
C1615 a_17357_1842# VSS 0.95769f ; **FLOATING
C1616 a_16793_1842# VSS 0.45049f ; **FLOATING
C1617 a_16163_1842# VSS 0.4946f ; **FLOATING
C1618 a_16597_1842# VSS 0.86359f ; **FLOATING
C1619 a_16033_1842# VSS 0.44618f ; **FLOATING
C1620 a_15403_1842# VSS 0.49465f ; **FLOATING
C1621 a_15837_1842# VSS 0.95171f ; **FLOATING
C1622 a_15273_1842# VSS 0.44439f ; **FLOATING
C1623 a_14643_1842# VSS 0.49305f ; **FLOATING
C1624 a_15077_1842# VSS 0.92116f ; **FLOATING
C1625 a_14513_1842# VSS 0.44501f ; **FLOATING
C1626 a_13883_1842# VSS 0.50862f ; **FLOATING
C1627 a_14317_1842# VSS 0.96009f ; **FLOATING
C1628 a_13753_1842# VSS 0.46427f ; **FLOATING
C1629 a_13123_1842# VSS 0.50173f ; **FLOATING
C1630 a_13557_1842# VSS 0.87587f ; **FLOATING
C1631 a_12993_1842# VSS 0.45643f ; **FLOATING
C1632 a_12363_1842# VSS 0.50854f ; **FLOATING
C1633 a_12797_1842# VSS 0.96142f ; **FLOATING
C1634 a_12233_1842# VSS 0.45757f ; **FLOATING
C1635 a_11603_1842# VSS 0.50267f ; **FLOATING
C1636 a_12037_1842# VSS 0.92866f ; **FLOATING
C1637 a_11473_1842# VSS 0.45177f ; **FLOATING
C1638 a_10843_1842# VSS 0.50491f ; **FLOATING
C1639 a_11277_1842# VSS 0.96053f ; **FLOATING
C1640 a_10713_1842# VSS 0.44901f ; **FLOATING
C1641 a_10083_1842# VSS 0.50223f ; **FLOATING
C1642 a_10517_1842# VSS 0.87053f ; **FLOATING
C1643 a_9953_1842# VSS 0.44673f ; **FLOATING
C1644 a_9323_1842# VSS 0.5026f ; **FLOATING
C1645 a_9757_1842# VSS 0.96312f ; **FLOATING
C1646 a_9193_1842# VSS 0.44361f ; **FLOATING
C1647 a_8563_1842# VSS 0.49203f ; **FLOATING
C1648 a_8997_1842# VSS 0.92196f ; **FLOATING
C1649 a_8433_1842# VSS 0.44439f ; **FLOATING
C1650 a_7803_1842# VSS 0.49435f ; **FLOATING
C1651 a_8237_1842# VSS 0.95422f ; **FLOATING
C1652 a_7673_1842# VSS 0.44737f ; **FLOATING
C1653 a_7043_1842# VSS 0.49204f ; **FLOATING
C1654 a_7477_1842# VSS 0.86493f ; **FLOATING
C1655 a_6913_1842# VSS 0.44442f ; **FLOATING
C1656 a_6283_1842# VSS 0.49343f ; **FLOATING
C1657 a_6717_1842# VSS 0.95763f ; **FLOATING
C1658 a_6153_1842# VSS 0.44292f ; **FLOATING
C1659 a_5523_1842# VSS 0.50322f ; **FLOATING
C1660 a_5957_1842# VSS 0.92646f ; **FLOATING
C1661 a_5393_1842# VSS 0.4596f ; **FLOATING
C1662 a_4763_1842# VSS 0.51043f ; **FLOATING
C1663 a_5197_1842# VSS 0.96509f ; **FLOATING
C1664 a_4633_1842# VSS 0.46282f ; **FLOATING
C1665 a_4003_1842# VSS 0.58808f ; **FLOATING
C1666 a_4437_1842# VSS 0.87628f ; **FLOATING
C1667 a_9712_3912# VSS 1.52086f ; **FLOATING
C1668 a_9444_3912# VSS 2.12877f ; **FLOATING
C1669 a_5778_3367# VSS 5.22809f ; **FLOATING
C1670 a_15464_3684# VSS 0.75391f ; **FLOATING
C1671 a_14757_5182# VSS 0.09495f ; **FLOATING
C1672 a_13880_5118# VSS 0.06985f ; **FLOATING
C1673 a_15688_5403# VSS 0.26291f ; **FLOATING
C1674 a_15108_5325# VSS 0.24458f ; **FLOATING
C1675 a_14851_5182# VSS 0.38123f ; **FLOATING
C1676 a_9444_4590# VSS 6.08222f ; **FLOATING
C1677 a_14111_5227# VSS 0.19866f ; **FLOATING
C1678 a_14009_5084# VSS 0.44622f ; **FLOATING
C1679 a_13592_5423# VSS 1.57456f ; **FLOATING
C1680 a_13306_5105# VSS 0.30095f ; **FLOATING
C1681 a_13566_5328# VSS 0.15441f ; **FLOATING
C1682 a_13132_5420# VSS 0.13036f ; **FLOATING
C1683 a_12907_5420# VSS 0.14377f ; **FLOATING
C1684 a_12907_5186# VSS 0.14861f ; **FLOATING
C1685 a_13106_5357# VSS 0.06343f ; **FLOATING
C1686 a_15304_4605# VSS 0.37009f ; **FLOATING
C1687 a_14757_6228# VSS 0.09586f ; **FLOATING
C1688 a_15688_5867# VSS 0.26405f ; **FLOATING
C1689 a_14851_6228# VSS 0.39588f ; **FLOATING
C1690 a_15108_6109# VSS 0.24582f ; **FLOATING
C1691 a_14111_5878# VSS 0.21915f ; **FLOATING
C1692 a_13880_6292# VSS 0.07345f ; **FLOATING
C1693 a_14009_5878# VSS 0.48187f ; **FLOATING
C1694 a_13592_5871# VSS 1.58208f ; **FLOATING
C1695 a_13566_5835# VSS 0.15442f ; **FLOATING
C1696 a_13045_6215# VSS 0.01124f ; **FLOATING
C1697 a_13306_6305# VSS 0.31701f ; **FLOATING
C1698 a_12849_5867# VSS 1.40248f ; **FLOATING
C1699 a_13121_5831# VSS 0.80439f ; **FLOATING
C1700 a_13019_5831# VSS 2.18715f ; **FLOATING
C1701 a_12656_5864# VSS 0.28393f ; **FLOATING
C1702 a_12355_5867# VSS 0.62262f ; **FLOATING
C1703 a_11397_6228# VSS 0.09495f ; **FLOATING
C1704 a_12158_5867# VSS 0.25874f ; **FLOATING
C1705 a_11491_6228# VSS 0.30073f ; **FLOATING
C1706 a_11748_6109# VSS 0.17021f ; **FLOATING
C1707 a_10751_5878# VSS 0.19918f ; **FLOATING
C1708 a_10520_6292# VSS 0.03671f ; **FLOATING
C1709 a_10649_5878# VSS 0.47308f ; **FLOATING
C1710 a_10232_5871# VSS 1.52123f ; **FLOATING
C1711 a_10206_5835# VSS 0.08466f ; **FLOATING
C1712 a_9946_6305# VSS 0.18126f ; **FLOATING
C1713 a_9772_5843# VSS 0.12435f ; **FLOATING
C1714 a_9746_5805# VSS 0.06613f ; **FLOATING
C1715 a_9547_6172# VSS 0.16037f ; **FLOATING
C1716 a_9547_5942# VSS 0.11966f ; **FLOATING
C1717 a_6854_5454# VSS 3.66026f ; **FLOATING
C1718 a_6126_3816# VSS 13.6177f ; **FLOATING
C1719 a_6854_5986# VSS 1.21519f ; **FLOATING
C1720 a_5974_5723# VSS 2.40124f ; **FLOATING
C1721 a_6326_4590# VSS 1.03474f ; **FLOATING
C1722 a_2019_1047.t2 VSS 0.93027f ; **FLOATING
C1723 a_2019_1047.t3 VSS 0.70623f ; **FLOATING
C1724 a_2019_1047.n0 VSS 5.00884f ; **FLOATING
C1725 a_2019_1047.t4 VSS 0.70623f ; **FLOATING
C1726 a_2019_1047.n1 VSS 3.38862f ; **FLOATING
C1727 a_2019_1047.t5 VSS 0.70623f ; **FLOATING
C1728 a_2019_1047.n2 VSS 3.38862f ; **FLOATING
C1729 a_2019_1047.t6 VSS 0.70623f ; **FLOATING
C1730 a_2019_1047.n3 VSS 3.38862f ; **FLOATING
C1731 a_2019_1047.t7 VSS 0.70623f ; **FLOATING
C1732 a_2019_1047.n4 VSS 3.38862f ; **FLOATING
C1733 a_2019_1047.t8 VSS 0.70623f ; **FLOATING
C1734 a_2019_1047.n5 VSS 3.38862f ; **FLOATING
C1735 a_2019_1047.t9 VSS 5.45485f ; **FLOATING
C1736 a_2019_1047.t1 VSS 1.07257f ; **FLOATING
C1737 a_2019_1047.t0 VSS 0.30486f ; **FLOATING
C1738 a_2595_1047.t2 VSS 1.36703f ; **FLOATING
C1739 a_2595_1047.t3 VSS 1.02094f ; **FLOATING
C1740 a_2595_1047.n0 VSS 7.76123f ; **FLOATING
C1741 a_2595_1047.t4 VSS 1.02094f ; **FLOATING
C1742 a_2595_1047.n1 VSS 5.2734f ; **FLOATING
C1743 a_2595_1047.t5 VSS 1.02094f ; **FLOATING
C1744 a_2595_1047.n2 VSS 5.2734f ; **FLOATING
C1745 a_2595_1047.t6 VSS 1.02094f ; **FLOATING
C1746 a_2595_1047.n3 VSS 5.2734f ; **FLOATING
C1747 a_2595_1047.t7 VSS 1.02094f ; **FLOATING
C1748 a_2595_1047.n4 VSS 5.2734f ; **FLOATING
C1749 a_2595_1047.t8 VSS 1.02094f ; **FLOATING
C1750 a_2595_1047.n5 VSS 5.2734f ; **FLOATING
C1751 a_2595_1047.t9 VSS 1.02094f ; **FLOATING
C1752 a_2595_1047.n6 VSS 7.58547f ; **FLOATING
C1753 a_2595_1047.t1 VSS 1.75119f ; **FLOATING
C1754 a_2595_1047.t0 VSS 0.48227f ; **FLOATING
C1755 a_3171_1047.t2 VSS 1.38443f ; **FLOATING
C1756 a_3171_1047.t3 VSS 1.03734f ; **FLOATING
C1757 a_3171_1047.n0 VSS 7.7786f ; **FLOATING
C1758 a_3171_1047.t4 VSS 1.03734f ; **FLOATING
C1759 a_3171_1047.n1 VSS 5.28086f ; **FLOATING
C1760 a_3171_1047.t5 VSS 1.03734f ; **FLOATING
C1761 a_3171_1047.n2 VSS 5.28086f ; **FLOATING
C1762 a_3171_1047.t6 VSS 1.03734f ; **FLOATING
C1763 a_3171_1047.n3 VSS 5.28086f ; **FLOATING
C1764 a_3171_1047.t7 VSS 1.03734f ; **FLOATING
C1765 a_3171_1047.n4 VSS 5.28086f ; **FLOATING
C1766 a_3171_1047.t8 VSS 1.03734f ; **FLOATING
C1767 a_3171_1047.n5 VSS 5.28086f ; **FLOATING
C1768 a_3171_1047.t9 VSS 1.03734f ; **FLOATING
C1769 a_3171_1047.n6 VSS 7.68351f ; **FLOATING
C1770 a_3171_1047.t1 VSS 1.77027f ; **FLOATING
C1771 a_3171_1047.t0 VSS 0.48084f ; **FLOATING
C1772 a_3747_1047.t2 VSS 0.96887f ; **FLOATING
C1773 a_3747_1047.t3 VSS 0.73761f ; **FLOATING
C1774 a_3747_1047.n0 VSS 5.16757f ; **FLOATING
C1775 a_3747_1047.t4 VSS 0.73761f ; **FLOATING
C1776 a_3747_1047.n1 VSS 3.49321f ; **FLOATING
C1777 a_3747_1047.t5 VSS 0.73761f ; **FLOATING
C1778 a_3747_1047.n2 VSS 3.49321f ; **FLOATING
C1779 a_3747_1047.t6 VSS 0.73761f ; **FLOATING
C1780 a_3747_1047.n3 VSS 3.49321f ; **FLOATING
C1781 a_3747_1047.t7 VSS 0.73761f ; **FLOATING
C1782 a_3747_1047.n4 VSS 3.49321f ; **FLOATING
C1783 a_3747_1047.t8 VSS 0.73761f ; **FLOATING
C1784 a_3747_1047.n5 VSS 3.49321f ; **FLOATING
C1785 a_3747_1047.t9 VSS 0.73761f ; **FLOATING
C1786 a_3747_1047.n6 VSS 5.18701f ; **FLOATING
C1787 a_3747_1047.t1 VSS 1.18538f ; **FLOATING
C1788 a_3747_1047.t0 VSS 0.31338f ; **FLOATING
C1789 a_2595_311.t1 VSS 3.27037f ; **FLOATING
C1790 a_2595_311.t2 VSS 5.04145f ; **FLOATING
C1791 a_2595_311.t3 VSS 1.20632f ; **FLOATING
C1792 a_2595_311.n0 VSS 26.8668f ; **FLOATING
C1793 a_2595_311.t0 VSS 0.49572f ; **FLOATING
C1794 a_3171_311.t2 VSS 5.05009f ; **FLOATING
C1795 a_3171_311.t3 VSS 1.21149f ; **FLOATING
C1796 a_3171_311.n0 VSS 29.8499f ; **FLOATING
C1797 a_3171_311.t1 VSS 4.61154f ; **FLOATING
C1798 a_3171_311.t0 VSS 0.4973f ; **FLOATING
C1799 a_3747_311.t2 VSS 3.09203f ; **FLOATING
C1800 a_3747_311.t3 VSS 0.74422f ; **FLOATING
C1801 a_3747_311.n0 VSS 19.8885f ; **FLOATING
C1802 a_3747_311.t1 VSS 3.68893f ; **FLOATING
C1803 a_3747_311.t0 VSS 0.30537f ; **FLOATING
C1804 VSS.t610 VSS 3.22049f ; **FLOATING
C1805 VDD.n0 VSS 0.03677f ; **FLOATING
C1806 VDD.n1 VSS 1.12845f ; **FLOATING
C1807 VDD.n2 VSS 0.03006f ; **FLOATING
C1808 VDD.n3 VSS 0.46891f ; **FLOATING
C1809 VDD.n4 VSS 0.04223f ; **FLOATING
C1810 VDD.t0 VSS 49.9272f ; **FLOATING
C1811 VDD.n5 VSS 0.46891f ; **FLOATING
C1812 VDD.n6 VSS 0.46891f ; **FLOATING
C1813 VDD.n7 VSS 0.04223f ; **FLOATING
C1814 VDD.n8 VSS 0.46891f ; **FLOATING
C1815 VDD.n9 VSS 0.46891f ; **FLOATING
C1816 VDD.n10 VSS 0.46891f ; **FLOATING
C1817 VDD.n11 VSS 0.07686f ; **FLOATING
C1818 VDD.n12 VSS 0.40404f ; **FLOATING
C1819 VDD.n14 VSS 0.36478f ; **FLOATING
C1820 VDD.n16 VSS 0.44734f ; **FLOATING
C1821 VDD.n17 VSS 0.13601f ; **FLOATING
C1822 VDD.n18 VSS 0.44734f ; **FLOATING
C1823 VDD.n19 VSS 0.13601f ; **FLOATING
C1824 VDD.n20 VSS 0.44734f ; **FLOATING
C1825 VDD.n22 VSS 0.44734f ; **FLOATING
C1826 VDD.n23 VSS 0.13601f ; **FLOATING
C1827 VDD.n24 VSS 0.44734f ; **FLOATING
C1828 VDD.n25 VSS 0.13601f ; **FLOATING
C1829 VDD.n26 VSS 0.44734f ; **FLOATING
C1830 VDD.n27 VSS 0.26258f ; **FLOATING
C1831 VDD.n28 VSS 0.22975f ; **FLOATING
C1832 VDD.n30 VSS 1.61338f ; **FLOATING
C1833 VDD.t3 VSS 43.7538f ; **FLOATING
C1834 VDD.n31 VSS 0.06199f ; **FLOATING
C1835 VDD.n32 VSS 0.13601f ; **FLOATING
C1836 VDD.n33 VSS 0.13601f ; **FLOATING
C1837 VDD.n34 VSS 0.03109f ; **FLOATING
C1838 VDD.t45 VSS 0.0187f ; **FLOATING
C1839 VDD.n35 VSS 0.02516f ; **FLOATING
C1840 VDD.n36 VSS 0.07733f ; **FLOATING
C1841 VDD.n37 VSS 0.0214f ; **FLOATING
C1842 VDD.n38 VSS 0.02357f ; **FLOATING
C1843 VDD.n39 VSS 0.01579f ; **FLOATING
C1844 VDD.n40 VSS 0.10231f ; **FLOATING
C1845 VDD.n42 VSS 0.15084f ; **FLOATING
C1846 VDD.n43 VSS 0.01387f ; **FLOATING
C1847 VDD.n44 VSS 0.06543f ; **FLOATING
C1848 VDD.n45 VSS 0.08545f ; **FLOATING
C1849 VDD.n47 VSS 0.08436f ; **FLOATING
C1850 VDD.n48 VSS 0.05911f ; **FLOATING
C1851 VDD.n49 VSS 0.05911f ; **FLOATING
C1852 VDD.n50 VSS 0.08436f ; **FLOATING
C1853 VDD.n51 VSS 0.05911f ; **FLOATING
C1854 VDD.n52 VSS 0.05911f ; **FLOATING
C1855 VDD.n53 VSS 0.08436f ; **FLOATING
C1856 VDD.n54 VSS 0.05911f ; **FLOATING
C1857 VDD.n55 VSS 0.05911f ; **FLOATING
C1858 VDD.n56 VSS 0.0401f ; **FLOATING
C1859 VDD.n57 VSS 0.02073f ; **FLOATING
C1860 VDD.n58 VSS 0.14214f ; **FLOATING
C1861 VDD.n59 VSS 0.0409f ; **FLOATING
C1862 VDD.n60 VSS 0.01023f ; **FLOATING
C1863 VDD.n61 VSS 0.02577f ; **FLOATING
C1864 VDD.n62 VSS 0.03847f ; **FLOATING
C1865 VDD.n63 VSS 0.02115f ; **FLOATING
C1866 VDD.n64 VSS 0.01579f ; **FLOATING
C1867 VDD.n65 VSS 0.10657f ; **FLOATING
C1868 VDD.n66 VSS 0.05152f ; **FLOATING
C1869 VDD.n67 VSS 0.20413f ; **FLOATING
C1870 VDD.n68 VSS 0.05911f ; **FLOATING
C1871 VDD.n69 VSS 0.05622f ; **FLOATING
C1872 VDD.n70 VSS 0.03174f ; **FLOATING
C1873 VDD.n71 VSS 0.01697f ; **FLOATING
C1874 VDD.n72 VSS 0.15122f ; **FLOATING
C1875 VDD.n73 VSS 0.03162f ; **FLOATING
C1876 VDD.n74 VSS 0.03566f ; **FLOATING
C1877 VDD.n75 VSS 0.13358f ; **FLOATING
C1878 VDD.n77 VSS 0.08629f ; **FLOATING
C1879 VDD.n78 VSS 0.13358f ; **FLOATING
C1880 VDD.n79 VSS 0.08629f ; **FLOATING
C1881 VDD.n81 VSS 0.13358f ; **FLOATING
C1882 VDD.n82 VSS 0.08629f ; **FLOATING
C1883 VDD.n84 VSS 0.02633f ; **FLOATING
C1884 VDD.n85 VSS 0.09631f ; **FLOATING
C1885 VDD.n86 VSS 0.13358f ; **FLOATING
C1886 VDD.n87 VSS 0.08629f ; **FLOATING
C1887 VDD.n89 VSS 0.13358f ; **FLOATING
C1888 VDD.n90 VSS 0.08629f ; **FLOATING
C1889 VDD.n92 VSS 0.13358f ; **FLOATING
C1890 VDD.n93 VSS 0.08629f ; **FLOATING
C1891 VDD.n95 VSS 0.08436f ; **FLOATING
C1892 VDD.n96 VSS 0.08436f ; **FLOATING
C1893 VDD.n97 VSS 0.08436f ; **FLOATING
C1894 VDD.n98 VSS 0.03062f ; **FLOATING
C1895 VDD.n99 VSS 0.01587f ; **FLOATING
C1896 VDD.n100 VSS 0.1004f ; **FLOATING
C1897 VDD.n101 VSS 0.04223f ; **FLOATING
C1898 VDD.n102 VSS 0.04223f ; **FLOATING
C1899 VDD.n103 VSS 0.04223f ; **FLOATING
C1900 VDD.n104 VSS 0.04223f ; **FLOATING
C1901 VDD.n105 VSS 0.13178f ; **FLOATING
C1902 VDD.t8 VSS 8.2706f ; **FLOATING
C1903 VDD.t18 VSS 0.03686f ; **FLOATING
C1904 VDD.t65 VSS 0.03686f ; **FLOATING
C1905 VDD.n106 VSS 0.12582f ; **FLOATING
C1906 VDD.n107 VSS 0.01589f ; **FLOATING
C1907 VDD.t16 VSS 0.04458f ; **FLOATING
C1908 VDD.t63 VSS 0.04458f ; **FLOATING
C1909 VDD.n108 VSS 0.14195f ; **FLOATING
C1910 VDD.n109 VSS 0.07513f ; **FLOATING
C1911 VDD.t43 VSS 0.03178f ; **FLOATING
C1912 VDD.n110 VSS 0.02157f ; **FLOATING
C1913 VDD.t41 VSS 0.02294f ; **FLOATING
C1914 VDD.t44 VSS 0.03552f ; **FLOATING
C1915 VDD.t46 VSS 0.03178f ; **FLOATING
C1916 VDD.t291 VSS 0.03178f ; **FLOATING
C1917 VDD.t48 VSS 0.03178f ; **FLOATING
C1918 VDD.n111 VSS 0.02157f ; **FLOATING
C1919 VDD.t47 VSS 0.02294f ; **FLOATING
C1920 VDD.t49 VSS 0.03552f ; **FLOATING
C1921 VDD.n112 VSS 0.01805f ; **FLOATING
C1922 VDD.t50 VSS 0.01871f ; **FLOATING
C1923 VDD.t51 VSS 0.03178f ; **FLOATING
C1924 VDD.n113 VSS 0.01895f ; **FLOATING
C1925 VDD.t12 VSS 0.03489f ; **FLOATING
C1926 VDD.t271 VSS 0.02373f ; **FLOATING
C1927 VDD.n114 VSS 0.11939f ; **FLOATING
C1928 VDD.t42 VSS 3.33549f ; **FLOATING
C1929 VDD.n115 VSS 0.64947f ; **FLOATING
C1930 VDD.n116 VSS 0.11552f ; **FLOATING
C1931 VDD.n117 VSS 0.02729f ; **FLOATING
C1932 VDD.t26 VSS 0.02621f ; **FLOATING
C1933 VDD.t155 VSS 0.02621f ; **FLOATING
C1934 VDD.n118 VSS 0.07782f ; **FLOATING
C1935 VDD.n119 VSS 0.03693f ; **FLOATING
C1936 VDD.t95 VSS 0.01216f ; **FLOATING
C1937 VDD.t132 VSS 0.06048f ; **FLOATING
C1938 VDD.n120 VSS 0.0245f ; **FLOATING
C1939 VDD.t156 VSS 0.01216f ; **FLOATING
C1940 VDD.t90 VSS 0.06048f ; **FLOATING
C1941 VDD.n121 VSS 0.0245f ; **FLOATING
C1942 VDD.n122 VSS 0.05408f ; **FLOATING
C1943 VDD.n123 VSS 0.01438f ; **FLOATING
C1944 VDD.t137 VSS 0.03563f ; **FLOATING
C1945 VDD.n124 VSS 0.06407f ; **FLOATING
C1946 VDD.n125 VSS 0.03521f ; **FLOATING
C1947 VDD.t272 VSS 0.0329f ; **FLOATING
C1948 VDD.n126 VSS 0.07635f ; **FLOATING
C1949 VDD.n127 VSS 0.02009f ; **FLOATING
C1950 VDD.t318 VSS 0.03686f ; **FLOATING
C1951 VDD.n128 VSS 0.16471f ; **FLOATING
C1952 VDD.t229 VSS 0.02621f ; **FLOATING
C1953 VDD.n129 VSS 0.14752f ; **FLOATING
C1954 VDD.t163 VSS 0.01216f ; **FLOATING
C1955 VDD.t220 VSS 0.06048f ; **FLOATING
C1956 VDD.n130 VSS 0.0245f ; **FLOATING
C1957 VDD.n131 VSS 0.07372f ; **FLOATING
C1958 VDD.n132 VSS 0.03695f ; **FLOATING
C1959 VDD.n133 VSS 0.07142f ; **FLOATING
C1960 VDD.n134 VSS 0.02961f ; **FLOATING
C1961 VDD.n135 VSS 0.0156f ; **FLOATING
C1962 VDD.n136 VSS 0.03576f ; **FLOATING
C1963 VDD.n137 VSS 0.03118f ; **FLOATING
C1964 VDD.n138 VSS 0.03567f ; **FLOATING
C1965 VDD.n139 VSS 0.03578f ; **FLOATING
C1966 VDD.n140 VSS 0.01573f ; **FLOATING
C1967 VDD.t320 VSS 0.0329f ; **FLOATING
C1968 VDD.t145 VSS 0.0329f ; **FLOATING
C1969 VDD.t227 VSS 0.02954f ; **FLOATING
C1970 VDD.t199 VSS 0.0329f ; **FLOATING
C1971 VDD.n141 VSS 0.02717f ; **FLOATING
C1972 VDD.t173 VSS 0.04318f ; **FLOATING
C1973 VDD.n142 VSS 0.08282f ; **FLOATING
C1974 VDD.n143 VSS 0.02423f ; **FLOATING
C1975 VDD.t206 VSS 0.0329f ; **FLOATING
C1976 VDD.n144 VSS 0.07852f ; **FLOATING
C1977 VDD.n145 VSS 0.01153f ; **FLOATING
C1978 VDD.t131 VSS 0.03667f ; **FLOATING
C1979 VDD.t223 VSS 0.03667f ; **FLOATING
C1980 VDD.t366 VSS 0.03667f ; **FLOATING
C1981 VDD.t186 VSS 0.03667f ; **FLOATING
C1982 VDD.t324 VSS 0.0329f ; **FLOATING
C1983 VDD.t169 VSS 0.0329f ; **FLOATING
C1984 VDD.n146 VSS 0.09517f ; **FLOATING
C1985 VDD.n147 VSS 0.01506f ; **FLOATING
C1986 VDD.t87 VSS 0.0243f ; **FLOATING
C1987 VDD.t384 VSS 0.0243f ; **FLOATING
C1988 VDD.n148 VSS 0.08391f ; **FLOATING
C1989 VDD.t160 VSS 0.03248f ; **FLOATING
C1990 VDD.t175 VSS 0.03248f ; **FLOATING
C1991 VDD.t321 VSS 0.0243f ; **FLOATING
C1992 VDD.t146 VSS 0.0243f ; **FLOATING
C1993 VDD.t130 VSS 0.03248f ; **FLOATING
C1994 VDD.t176 VSS 0.03248f ; **FLOATING
C1995 VDD.t323 VSS 0.0243f ; **FLOATING
C1996 VDD.t170 VSS 0.0243f ; **FLOATING
C1997 VDD.t20 VSS 0.03248f ; **FLOATING
C1998 VDD.t328 VSS 0.03248f ; **FLOATING
C1999 VDD.n149 VSS 0.07665f ; **FLOATING
C2000 VDD.t21 VSS 0.03667f ; **FLOATING
C2001 VDD.t329 VSS 0.03667f ; **FLOATING
C2002 VDD.t322 VSS 0.0243f ; **FLOATING
C2003 VDD.t147 VSS 0.0243f ; **FLOATING
C2004 VDD.t325 VSS 0.03248f ; **FLOATING
C2005 VDD.t171 VSS 0.03248f ; **FLOATING
C2006 VDD.n150 VSS 0.06967f ; **FLOATING
C2007 VDD.t340 VSS 0.03667f ; **FLOATING
C2008 VDD.t347 VSS 0.03667f ; **FLOATING
C2009 VDD.n151 VSS 0.08757f ; **FLOATING
C2010 VDD.n152 VSS 0.01175f ; **FLOATING
C2011 VDD.t174 VSS 0.0329f ; **FLOATING
C2012 VDD.t164 VSS 0.03301f ; **FLOATING
C2013 VDD.t239 VSS 0.0329f ; **FLOATING
C2014 VDD.n153 VSS 0.06893f ; **FLOATING
C2015 VDD.n154 VSS 0.01294f ; **FLOATING
C2016 VDD.t390 VSS 0.0329f ; **FLOATING
C2017 VDD.t368 VSS 0.0329f ; **FLOATING
C2018 VDD.t376 VSS 0.0329f ; **FLOATING
C2019 VDD.t269 VSS 0.02954f ; **FLOATING
C2020 VDD.t380 VSS 0.02954f ; **FLOATING
C2021 VDD.t379 VSS 0.0329f ; **FLOATING
C2022 VDD.t410 VSS 0.10912f ; **FLOATING
C2023 VDD.t228 VSS 0.03171f ; **FLOATING
C2024 VDD.t6 VSS 0.04318f ; **FLOATING
C2025 VDD.t409 VSS 0.10912f ; **FLOATING
C2026 VDD.t189 VSS 0.03171f ; **FLOATING
C2027 VDD.t116 VSS 0.0329f ; **FLOATING
C2028 VDD.t190 VSS 0.02954f ; **FLOATING
C2029 VDD.t191 VSS 0.02954f ; **FLOATING
C2030 VDD.t194 VSS 0.02954f ; **FLOATING
C2031 VDD.t88 VSS 0.0329f ; **FLOATING
C2032 VDD.t343 VSS 0.0329f ; **FLOATING
C2033 VDD.t221 VSS 0.0329f ; **FLOATING
C2034 VDD.t197 VSS 0.0329f ; **FLOATING
C2035 VDD.t243 VSS 0.02954f ; **FLOATING
C2036 VDD.t25 VSS 0.04318f ; **FLOATING
C2037 VDD.t207 VSS 0.0329f ; **FLOATING
C2038 VDD.t125 VSS 0.02954f ; **FLOATING
C2039 VDD.t28 VSS 0.0329f ; **FLOATING
C2040 VDD.t161 VSS 0.02954f ; **FLOATING
C2041 VDD.t210 VSS 0.0329f ; **FLOATING
C2042 VDD.t351 VSS 0.02954f ; **FLOATING
C2043 VDD.t352 VSS 0.02954f ; **FLOATING
C2044 VDD.t75 VSS 0.04334f ; **FLOATING
C2045 VDD.t168 VSS 0.0329f ; **FLOATING
C2046 VDD.t355 VSS 0.02954f ; **FLOATING
C2047 VDD.t89 VSS 0.0329f ; **FLOATING
C2048 VDD.t72 VSS 0.0329f ; **FLOATING
C2049 VDD.t24 VSS 0.0329f ; **FLOATING
C2050 VDD.t241 VSS 0.02954f ; **FLOATING
C2051 VDD.t93 VSS 0.04318f ; **FLOATING
C2052 VDD.t14 VSS 0.02954f ; **FLOATING
C2053 VDD.t114 VSS 0.0329f ; **FLOATING
C2054 VDD.t1 VSS 0.02954f ; **FLOATING
C2055 VDD.t265 VSS 0.0329f ; **FLOATING
C2056 VDD.t201 VSS 0.0329f ; **FLOATING
C2057 VDD.t232 VSS 0.02954f ; **FLOATING
C2058 VDD.t233 VSS 0.02954f ; **FLOATING
C2059 VDD.t236 VSS 0.02954f ; **FLOATING
C2060 VDD.t117 VSS 0.0329f ; **FLOATING
C2061 VDD.t383 VSS 0.0329f ; **FLOATING
C2062 VDD.t123 VSS 0.0329f ; **FLOATING
C2063 VDD.t337 VSS 0.0329f ; **FLOATING
C2064 VDD.t260 VSS 0.04318f ; **FLOATING
C2065 VDD.t73 VSS 0.0329f ; **FLOATING
C2066 VDD.t157 VSS 0.0329f ; **FLOATING
C2067 VDD.t224 VSS 0.0329f ; **FLOATING
C2068 VDD.t184 VSS 0.0329f ; **FLOATING
C2069 VDD.t76 VSS 0.03493f ; **FLOATING
C2070 VDD.t133 VSS 0.04318f ; **FLOATING
C2071 VDD.t77 VSS 0.06169f ; **FLOATING
C2072 VDD.t80 VSS 0.0329f ; **FLOATING
C2073 VDD.t142 VSS 0.0329f ; **FLOATING
C2074 VDD.t369 VSS 0.0329f ; **FLOATING
C2075 VDD.t196 VSS 0.0329f ; **FLOATING
C2076 VDD.t204 VSS 0.02954f ; **FLOATING
C2077 VDD.t82 VSS 0.04318f ; **FLOATING
C2078 VDD.t177 VSS 0.0329f ; **FLOATING
C2079 VDD.t212 VSS 0.02954f ; **FLOATING
C2080 VDD.t112 VSS 0.0329f ; **FLOATING
C2081 VDD.t83 VSS 0.02954f ; **FLOATING
C2082 VDD.t209 VSS 0.0329f ; **FLOATING
C2083 VDD.t371 VSS 0.02954f ; **FLOATING
C2084 VDD.t372 VSS 0.02954f ; **FLOATING
C2085 VDD.t334 VSS 0.04334f ; **FLOATING
C2086 VDD.t326 VSS 0.0329f ; **FLOATING
C2087 VDD.t375 VSS 0.02954f ; **FLOATING
C2088 VDD.t198 VSS 0.0329f ; **FLOATING
C2089 VDD.t69 VSS 0.0329f ; **FLOATING
C2090 VDD.t362 VSS 0.0329f ; **FLOATING
C2091 VDD.t242 VSS 0.02954f ; **FLOATING
C2092 VDD.t122 VSS 0.04318f ; **FLOATING
C2093 VDD.t71 VSS 0.02954f ; **FLOATING
C2094 VDD.t115 VSS 0.0329f ; **FLOATING
C2095 VDD.t270 VSS 0.02954f ; **FLOATING
C2096 VDD.t22 VSS 0.0329f ; **FLOATING
C2097 VDD.t202 VSS 0.0329f ; **FLOATING
C2098 VDD.t179 VSS 0.02954f ; **FLOATING
C2099 VDD.t180 VSS 0.02954f ; **FLOATING
C2100 VDD.t183 VSS 0.02954f ; **FLOATING
C2101 VDD.t200 VSS 0.0329f ; **FLOATING
C2102 VDD.t245 VSS 0.0329f ; **FLOATING
C2103 VDD.t338 VSS 0.0329f ; **FLOATING
C2104 VDD.t237 VSS 0.0329f ; **FLOATING
C2105 VDD.t203 VSS 0.02954f ; **FLOATING
C2106 VDD.t144 VSS 0.04318f ; **FLOATING
C2107 VDD.t5 VSS 0.0329f ; **FLOATING
C2108 VDD.t127 VSS 0.02954f ; **FLOATING
C2109 VDD.t139 VSS 0.0329f ; **FLOATING
C2110 VDD.t78 VSS 0.02954f ; **FLOATING
C2111 VDD.t11 VSS 0.0329f ; **FLOATING
C2112 VDD.t357 VSS 0.02954f ; **FLOATING
C2113 VDD.t358 VSS 0.02954f ; **FLOATING
C2114 VDD.t85 VSS 0.04334f ; **FLOATING
C2115 VDD.t257 VSS 0.0329f ; **FLOATING
C2116 VDD.t361 VSS 0.02954f ; **FLOATING
C2117 VDD.t240 VSS 0.0329f ; **FLOATING
C2118 VDD.t213 VSS 0.0329f ; **FLOATING
C2119 VDD.t208 VSS 0.0329f ; **FLOATING
C2120 VDD.t9 VSS 0.04318f ; **FLOATING
C2121 VDD.t377 VSS 0.03956f ; **FLOATING
C2122 VDD.t393 VSS 0.10912f ; **FLOATING
C2123 VDD.t359 VSS 0.03171f ; **FLOATING
C2124 VDD.t394 VSS 0.10912f ; **FLOATING
C2125 VDD.t79 VSS 0.03171f ; **FLOATING
C2126 VDD.t395 VSS 0.10912f ; **FLOATING
C2127 VDD.t126 VSS 0.03171f ; **FLOATING
C2128 VDD.t267 VSS 0.04334f ; **FLOATING
C2129 VDD.t396 VSS 0.10912f ; **FLOATING
C2130 VDD.t181 VSS 0.03171f ; **FLOATING
C2131 VDD.t397 VSS 0.10912f ; **FLOATING
C2132 VDD.t178 VSS 0.03171f ; **FLOATING
C2133 VDD.t398 VSS 0.10912f ; **FLOATING
C2134 VDD.t70 VSS 0.03171f ; **FLOATING
C2135 VDD.t399 VSS 0.10912f ; **FLOATING
C2136 VDD.t373 VSS 0.03171f ; **FLOATING
C2137 VDD.t400 VSS 0.10912f ; **FLOATING
C2138 VDD.t84 VSS 0.03171f ; **FLOATING
C2139 VDD.t401 VSS 0.10912f ; **FLOATING
C2140 VDD.t205 VSS 0.03171f ; **FLOATING
C2141 VDD.n155 VSS 0.06199f ; **FLOATING
C2142 VDD.n156 VSS 0.01294f ; **FLOATING
C2143 VDD.n157 VSS 0.07329f ; **FLOATING
C2144 VDD.n158 VSS 0.0111f ; **FLOATING
C2145 VDD.n159 VSS 0.06465f ; **FLOATING
C2146 VDD.n160 VSS 0.01294f ; **FLOATING
C2147 VDD.n161 VSS 0.07973f ; **FLOATING
C2148 VDD.t263 VSS 0.04334f ; **FLOATING
C2149 VDD.t402 VSS 0.10912f ; **FLOATING
C2150 VDD.t234 VSS 0.03171f ; **FLOATING
C2151 VDD.t403 VSS 0.10912f ; **FLOATING
C2152 VDD.t2 VSS 0.03171f ; **FLOATING
C2153 VDD.t404 VSS 0.10912f ; **FLOATING
C2154 VDD.t13 VSS 0.03171f ; **FLOATING
C2155 VDD.t405 VSS 0.10912f ; **FLOATING
C2156 VDD.t353 VSS 0.03171f ; **FLOATING
C2157 VDD.t406 VSS 0.10912f ; **FLOATING
C2158 VDD.t162 VSS 0.03171f ; **FLOATING
C2159 VDD.t407 VSS 0.10912f ; **FLOATING
C2160 VDD.t124 VSS 0.03171f ; **FLOATING
C2161 VDD.t188 VSS 0.04334f ; **FLOATING
C2162 VDD.t408 VSS 0.10912f ; **FLOATING
C2163 VDD.t192 VSS 0.03171f ; **FLOATING
C2164 VDD.t57 VSS 0.06667f ; **FLOATING
C2165 VDD.n162 VSS 0.04824f ; **FLOATING
C2166 VDD.n163 VSS 0.04832f ; **FLOATING
C2167 VDD.n164 VSS 0.04824f ; **FLOATING
C2168 VDD.n165 VSS 0.04832f ; **FLOATING
C2169 VDD.n166 VSS 0.04824f ; **FLOATING
C2170 VDD.n167 VSS 0.04832f ; **FLOATING
C2171 VDD.n168 VSS 0.04824f ; **FLOATING
C2172 VDD.n169 VSS 0.04824f ; **FLOATING
C2173 VDD.n170 VSS 0.04824f ; **FLOATING
C2174 VDD.n171 VSS 0.04824f ; **FLOATING
C2175 VDD.n172 VSS 0.04824f ; **FLOATING
C2176 VDD.n173 VSS 0.04824f ; **FLOATING
C2177 VDD.n174 VSS 0.04832f ; **FLOATING
C2178 VDD.n175 VSS 0.04832f ; **FLOATING
C2179 VDD.n176 VSS 0.04832f ; **FLOATING
C2180 VDD.n177 VSS 0.04832f ; **FLOATING
C2181 VDD.n178 VSS 0.04832f ; **FLOATING
C2182 VDD.n179 VSS 0.04824f ; **FLOATING
C2183 VDD.n180 VSS 0.04824f ; **FLOATING
C2184 VDD.n181 VSS 0.04832f ; **FLOATING
C2185 VDD.n182 VSS 0.04824f ; **FLOATING
C2186 VDD.n183 VSS 0.04832f ; **FLOATING
C2187 VDD.n184 VSS 0.04824f ; **FLOATING
C2188 VDD.n185 VSS 0.04824f ; **FLOATING
C2189 VDD.n186 VSS 0.04832f ; **FLOATING
C2190 VDD.n187 VSS 0.04832f ; **FLOATING
C2191 VDD.n188 VSS 0.04824f ; **FLOATING
C2192 VDD.n189 VSS 0.04824f ; **FLOATING
C2193 VDD.n190 VSS 0.04824f ; **FLOATING
C2194 VDD.n191 VSS 0.04832f ; **FLOATING
C2195 VDD.n192 VSS 0.04824f ; **FLOATING
C2196 VDD.t53 VSS 0.03229f ; **FLOATING
C2197 VDD.t52 VSS 0.02303f ; **FLOATING
C2198 VDD.t56 VSS 0.03215f ; **FLOATING
C2199 VDD.t54 VSS 0.03552f ; **FLOATING
C2200 VDD.t55 VSS 0.01869f ; **FLOATING
C2201 VDD.t284 VSS 0.03178f ; **FLOATING
C2202 VDD.n193 VSS 0.09619f ; **FLOATING
C2203 VDD.n194 VSS 0.02357f ; **FLOATING
C2204 VDD.n195 VSS 0.07477f ; **FLOATING
C2205 VDD.n196 VSS 0.0138f ; **FLOATING
C2206 VDD.t136 VSS 0.03727f ; **FLOATING
C2207 VDD.n197 VSS 0.07761f ; **FLOATING
C2208 VDD.n198 VSS 0.03405f ; **FLOATING
C2209 VDD.t292 VSS 0.03178f ; **FLOATING
C2210 VDD.n199 VSS 0.10447f ; **FLOATING
C2211 VDD.n200 VSS 0.02357f ; **FLOATING
C2212 VDD.n201 VSS 0.05908f ; **FLOATING
C2213 VDD.n202 VSS 0.01381f ; **FLOATING
C2214 VDD.t313 VSS 0.03727f ; **FLOATING
C2215 VDD.n203 VSS 0.0776f ; **FLOATING
C2216 VDD.n204 VSS 0.03401f ; **FLOATING
C2217 VDD.t290 VSS 0.03178f ; **FLOATING
C2218 VDD.n205 VSS 0.10444f ; **FLOATING
C2219 VDD.n206 VSS 0.02357f ; **FLOATING
C2220 VDD.n207 VSS 0.05909f ; **FLOATING
C2221 VDD.n208 VSS 0.01381f ; **FLOATING
C2222 VDD.t67 VSS 0.03727f ; **FLOATING
C2223 VDD.n209 VSS 0.07761f ; **FLOATING
C2224 VDD.n210 VSS 0.03404f ; **FLOATING
C2225 VDD.t281 VSS 0.03178f ; **FLOATING
C2226 VDD.n211 VSS 0.1045f ; **FLOATING
C2227 VDD.n212 VSS 0.02357f ; **FLOATING
C2228 VDD.n213 VSS 0.05906f ; **FLOATING
C2229 VDD.n214 VSS 0.01381f ; **FLOATING
C2230 VDD.t277 VSS 0.03727f ; **FLOATING
C2231 VDD.n215 VSS 0.07758f ; **FLOATING
C2232 VDD.n216 VSS 0.03405f ; **FLOATING
C2233 VDD.t280 VSS 0.03178f ; **FLOATING
C2234 VDD.n217 VSS 0.1045f ; **FLOATING
C2235 VDD.n218 VSS 0.02357f ; **FLOATING
C2236 VDD.n219 VSS 0.05908f ; **FLOATING
C2237 VDD.n220 VSS 0.01381f ; **FLOATING
C2238 VDD.t187 VSS 0.03727f ; **FLOATING
C2239 VDD.n221 VSS 0.0776f ; **FLOATING
C2240 VDD.n222 VSS 0.03401f ; **FLOATING
C2241 VDD.t289 VSS 0.03178f ; **FLOATING
C2242 VDD.n223 VSS 0.10447f ; **FLOATING
C2243 VDD.n224 VSS 0.02357f ; **FLOATING
C2244 VDD.n225 VSS 0.05908f ; **FLOATING
C2245 VDD.n226 VSS 0.0138f ; **FLOATING
C2246 VDD.t19 VSS 0.03727f ; **FLOATING
C2247 VDD.n227 VSS 0.07761f ; **FLOATING
C2248 VDD.n228 VSS 0.03408f ; **FLOATING
C2249 VDD.t293 VSS 0.03178f ; **FLOATING
C2250 VDD.n229 VSS 0.10441f ; **FLOATING
C2251 VDD.n230 VSS 0.02357f ; **FLOATING
C2252 VDD.n231 VSS 0.05905f ; **FLOATING
C2253 VDD.n232 VSS 0.01381f ; **FLOATING
C2254 VDD.t81 VSS 0.03727f ; **FLOATING
C2255 VDD.n233 VSS 0.07758f ; **FLOATING
C2256 VDD.n234 VSS 0.03405f ; **FLOATING
C2257 VDD.t294 VSS 0.03178f ; **FLOATING
C2258 VDD.n235 VSS 0.10444f ; **FLOATING
C2259 VDD.n236 VSS 0.02357f ; **FLOATING
C2260 VDD.n237 VSS 0.05907f ; **FLOATING
C2261 VDD.n238 VSS 0.0138f ; **FLOATING
C2262 VDD.t27 VSS 0.03727f ; **FLOATING
C2263 VDD.n239 VSS 0.07763f ; **FLOATING
C2264 VDD.n240 VSS 0.03401f ; **FLOATING
C2265 VDD.t300 VSS 0.03178f ; **FLOATING
C2266 VDD.n241 VSS 0.1045f ; **FLOATING
C2267 VDD.n242 VSS 0.02357f ; **FLOATING
C2268 VDD.n243 VSS 0.05908f ; **FLOATING
C2269 VDD.n244 VSS 0.0138f ; **FLOATING
C2270 VDD.t74 VSS 0.03727f ; **FLOATING
C2271 VDD.n245 VSS 0.07762f ; **FLOATING
C2272 VDD.n246 VSS 0.03403f ; **FLOATING
C2273 VDD.t298 VSS 0.03178f ; **FLOATING
C2274 VDD.n247 VSS 0.10447f ; **FLOATING
C2275 VDD.n248 VSS 0.02357f ; **FLOATING
C2276 VDD.n249 VSS 0.05908f ; **FLOATING
C2277 VDD.n250 VSS 0.01381f ; **FLOATING
C2278 VDD.t167 VSS 0.03727f ; **FLOATING
C2279 VDD.n251 VSS 0.07758f ; **FLOATING
C2280 VDD.n252 VSS 0.03408f ; **FLOATING
C2281 VDD.t297 VSS 0.03178f ; **FLOATING
C2282 VDD.n253 VSS 0.10444f ; **FLOATING
C2283 VDD.n254 VSS 0.02357f ; **FLOATING
C2284 VDD.n255 VSS 0.05905f ; **FLOATING
C2285 VDD.n256 VSS 0.01381f ; **FLOATING
C2286 VDD.t94 VSS 0.03727f ; **FLOATING
C2287 VDD.n257 VSS 0.07758f ; **FLOATING
C2288 VDD.n258 VSS 0.03408f ; **FLOATING
C2289 VDD.t295 VSS 0.03178f ; **FLOATING
C2290 VDD.n259 VSS 0.10447f ; **FLOATING
C2291 VDD.n260 VSS 0.02357f ; **FLOATING
C2292 VDD.n261 VSS 0.05904f ; **FLOATING
C2293 VDD.n262 VSS 0.0138f ; **FLOATING
C2294 VDD.t264 VSS 0.03727f ; **FLOATING
C2295 VDD.n263 VSS 0.07761f ; **FLOATING
C2296 VDD.n264 VSS 0.03408f ; **FLOATING
C2297 VDD.t288 VSS 0.03178f ; **FLOATING
C2298 VDD.n265 VSS 0.10444f ; **FLOATING
C2299 VDD.n266 VSS 0.02357f ; **FLOATING
C2300 VDD.n267 VSS 0.05905f ; **FLOATING
C2301 VDD.n268 VSS 0.01381f ; **FLOATING
C2302 VDD.t15 VSS 0.03727f ; **FLOATING
C2303 VDD.n269 VSS 0.07758f ; **FLOATING
C2304 VDD.n270 VSS 0.03405f ; **FLOATING
C2305 VDD.t302 VSS 0.03178f ; **FLOATING
C2306 VDD.n271 VSS 0.1045f ; **FLOATING
C2307 VDD.n272 VSS 0.02357f ; **FLOATING
C2308 VDD.n273 VSS 0.05908f ; **FLOATING
C2309 VDD.n274 VSS 0.01381f ; **FLOATING
C2310 VDD.t195 VSS 0.03727f ; **FLOATING
C2311 VDD.n275 VSS 0.0776f ; **FLOATING
C2312 VDD.n276 VSS 0.03401f ; **FLOATING
C2313 VDD.t301 VSS 0.03178f ; **FLOATING
C2314 VDD.n277 VSS 0.10447f ; **FLOATING
C2315 VDD.n278 VSS 0.02357f ; **FLOATING
C2316 VDD.n279 VSS 0.05909f ; **FLOATING
C2317 VDD.n280 VSS 0.01381f ; **FLOATING
C2318 VDD.t217 VSS 0.03727f ; **FLOATING
C2319 VDD.n281 VSS 0.0776f ; **FLOATING
C2320 VDD.n282 VSS 0.03401f ; **FLOATING
C2321 VDD.t305 VSS 0.03178f ; **FLOATING
C2322 VDD.n283 VSS 0.10441f ; **FLOATING
C2323 VDD.n284 VSS 0.02357f ; **FLOATING
C2324 VDD.n285 VSS 0.05909f ; **FLOATING
C2325 VDD.n286 VSS 0.01381f ; **FLOATING
C2326 VDD.t158 VSS 0.03727f ; **FLOATING
C2327 VDD.n287 VSS 0.07758f ; **FLOATING
C2328 VDD.n288 VSS 0.03408f ; **FLOATING
C2329 VDD.t304 VSS 0.03178f ; **FLOATING
C2330 VDD.n289 VSS 0.10441f ; **FLOATING
C2331 VDD.n290 VSS 0.02357f ; **FLOATING
C2332 VDD.n291 VSS 0.05904f ; **FLOATING
C2333 VDD.n292 VSS 0.0138f ; **FLOATING
C2334 VDD.t134 VSS 0.03727f ; **FLOATING
C2335 VDD.n293 VSS 0.07764f ; **FLOATING
C2336 VDD.n294 VSS 0.03402f ; **FLOATING
C2337 VDD.t286 VSS 0.03178f ; **FLOATING
C2338 VDD.n295 VSS 0.10441f ; **FLOATING
C2339 VDD.n296 VSS 0.02357f ; **FLOATING
C2340 VDD.n297 VSS 0.05907f ; **FLOATING
C2341 VDD.n298 VSS 0.01381f ; **FLOATING
C2342 VDD.t141 VSS 0.03727f ; **FLOATING
C2343 VDD.n299 VSS 0.07761f ; **FLOATING
C2344 VDD.n300 VSS 0.03402f ; **FLOATING
C2345 VDD.t303 VSS 0.03178f ; **FLOATING
C2346 VDD.n301 VSS 0.10441f ; **FLOATING
C2347 VDD.n302 VSS 0.02357f ; **FLOATING
C2348 VDD.n303 VSS 0.05908f ; **FLOATING
C2349 VDD.n304 VSS 0.01381f ; **FLOATING
C2350 VDD.t129 VSS 0.03727f ; **FLOATING
C2351 VDD.n305 VSS 0.07761f ; **FLOATING
C2352 VDD.n306 VSS 0.03402f ; **FLOATING
C2353 VDD.t285 VSS 0.03178f ; **FLOATING
C2354 VDD.n307 VSS 0.10444f ; **FLOATING
C2355 VDD.n308 VSS 0.02357f ; **FLOATING
C2356 VDD.n309 VSS 0.05906f ; **FLOATING
C2357 VDD.n310 VSS 0.0138f ; **FLOATING
C2358 VDD.t113 VSS 0.03727f ; **FLOATING
C2359 VDD.n311 VSS 0.07765f ; **FLOATING
C2360 VDD.n312 VSS 0.03398f ; **FLOATING
C2361 VDD.t299 VSS 0.03178f ; **FLOATING
C2362 VDD.n313 VSS 0.1045f ; **FLOATING
C2363 VDD.n314 VSS 0.02357f ; **FLOATING
C2364 VDD.n315 VSS 0.0591f ; **FLOATING
C2365 VDD.n316 VSS 0.01381f ; **FLOATING
C2366 VDD.t333 VSS 0.03727f ; **FLOATING
C2367 VDD.n317 VSS 0.0776f ; **FLOATING
C2368 VDD.n318 VSS 0.03401f ; **FLOATING
C2369 VDD.t283 VSS 0.03178f ; **FLOATING
C2370 VDD.n319 VSS 0.1045f ; **FLOATING
C2371 VDD.n320 VSS 0.02357f ; **FLOATING
C2372 VDD.n321 VSS 0.05908f ; **FLOATING
C2373 VDD.n322 VSS 0.0138f ; **FLOATING
C2374 VDD.t256 VSS 0.03727f ; **FLOATING
C2375 VDD.n323 VSS 0.07762f ; **FLOATING
C2376 VDD.n324 VSS 0.03403f ; **FLOATING
C2377 VDD.t287 VSS 0.03178f ; **FLOATING
C2378 VDD.n325 VSS 0.1045f ; **FLOATING
C2379 VDD.n326 VSS 0.02357f ; **FLOATING
C2380 VDD.n327 VSS 0.05907f ; **FLOATING
C2381 VDD.n328 VSS 0.0138f ; **FLOATING
C2382 VDD.t121 VSS 0.03727f ; **FLOATING
C2383 VDD.n329 VSS 0.07762f ; **FLOATING
C2384 VDD.n330 VSS 0.03403f ; **FLOATING
C2385 VDD.t306 VSS 0.03178f ; **FLOATING
C2386 VDD.n331 VSS 0.1045f ; **FLOATING
C2387 VDD.n332 VSS 0.02357f ; **FLOATING
C2388 VDD.n333 VSS 0.05908f ; **FLOATING
C2389 VDD.n334 VSS 0.01381f ; **FLOATING
C2390 VDD.t23 VSS 0.03727f ; **FLOATING
C2391 VDD.n335 VSS 0.07759f ; **FLOATING
C2392 VDD.n336 VSS 0.03403f ; **FLOATING
C2393 VDD.t282 VSS 0.03178f ; **FLOATING
C2394 VDD.n337 VSS 0.1045f ; **FLOATING
C2395 VDD.n338 VSS 0.02357f ; **FLOATING
C2396 VDD.n339 VSS 0.05909f ; **FLOATING
C2397 VDD.n340 VSS 0.01381f ; **FLOATING
C2398 VDD.t119 VSS 0.03727f ; **FLOATING
C2399 VDD.n341 VSS 0.07761f ; **FLOATING
C2400 VDD.n342 VSS 0.03404f ; **FLOATING
C2401 VDD.t308 VSS 0.03178f ; **FLOATING
C2402 VDD.n343 VSS 0.10447f ; **FLOATING
C2403 VDD.n344 VSS 0.02357f ; **FLOATING
C2404 VDD.n345 VSS 0.05905f ; **FLOATING
C2405 VDD.n346 VSS 0.0138f ; **FLOATING
C2406 VDD.t244 VSS 0.03727f ; **FLOATING
C2407 VDD.n347 VSS 0.07761f ; **FLOATING
C2408 VDD.n348 VSS 0.03403f ; **FLOATING
C2409 VDD.t307 VSS 0.03178f ; **FLOATING
C2410 VDD.n349 VSS 0.10444f ; **FLOATING
C2411 VDD.n350 VSS 0.02357f ; **FLOATING
C2412 VDD.n351 VSS 0.05909f ; **FLOATING
C2413 VDD.n352 VSS 0.01381f ; **FLOATING
C2414 VDD.t91 VSS 0.03727f ; **FLOATING
C2415 VDD.n353 VSS 0.07761f ; **FLOATING
C2416 VDD.n354 VSS 0.03404f ; **FLOATING
C2417 VDD.t309 VSS 0.03178f ; **FLOATING
C2418 VDD.n355 VSS 0.10447f ; **FLOATING
C2419 VDD.n356 VSS 0.02357f ; **FLOATING
C2420 VDD.n357 VSS 0.05906f ; **FLOATING
C2421 VDD.n358 VSS 0.01381f ; **FLOATING
C2422 VDD.t120 VSS 0.03727f ; **FLOATING
C2423 VDD.n359 VSS 0.0776f ; **FLOATING
C2424 VDD.n360 VSS 0.03401f ; **FLOATING
C2425 VDD.t296 VSS 0.03178f ; **FLOATING
C2426 VDD.n361 VSS 0.10444f ; **FLOATING
C2427 VDD.n362 VSS 0.02357f ; **FLOATING
C2428 VDD.n363 VSS 0.05909f ; **FLOATING
C2429 VDD.n364 VSS 0.01381f ; **FLOATING
C2430 VDD.t255 VSS 0.03727f ; **FLOATING
C2431 VDD.n365 VSS 0.07758f ; **FLOATING
C2432 VDD.n366 VSS 0.03408f ; **FLOATING
C2433 VDD.t310 VSS 0.03178f ; **FLOATING
C2434 VDD.n367 VSS 0.10447f ; **FLOATING
C2435 VDD.n368 VSS 0.02357f ; **FLOATING
C2436 VDD.n369 VSS 0.05905f ; **FLOATING
C2437 VDD.n370 VSS 0.01381f ; **FLOATING
C2438 VDD.t4 VSS 0.03727f ; **FLOATING
C2439 VDD.n371 VSS 0.07761f ; **FLOATING
C2440 VDD.n372 VSS 0.03402f ; **FLOATING
C2441 VDD.t311 VSS 0.03178f ; **FLOATING
C2442 VDD.n373 VSS 0.10444f ; **FLOATING
C2443 VDD.n374 VSS 0.02357f ; **FLOATING
C2444 VDD.n375 VSS 0.05907f ; **FLOATING
C2445 VDD.n376 VSS 0.01381f ; **FLOATING
C2446 VDD.t10 VSS 0.03727f ; **FLOATING
C2447 VDD.n377 VSS 0.0776f ; **FLOATING
C2448 VDD.n378 VSS 0.03401f ; **FLOATING
C2449 VDD.t312 VSS 0.03178f ; **FLOATING
C2450 VDD.n379 VSS 0.0865f ; **FLOATING
C2451 VDD.n380 VSS 0.02357f ; **FLOATING
C2452 VDD.n381 VSS 0.05908f ; **FLOATING
C2453 VDD.n382 VSS 0.0138f ; **FLOATING
C2454 VDD.t68 VSS 0.03727f ; **FLOATING
C2455 VDD.n383 VSS 0.05918f ; **FLOATING
C2456 VDD.n384 VSS 0.01422f ; **FLOATING
C2457 VDD.t58 VSS 0.03178f ; **FLOATING
C2458 VDD.n385 VSS 0.02357f ; **FLOATING
C2459 VDD.t59 VSS 0.03552f ; **FLOATING
C2460 VDD.n386 VSS 0.06979f ; **FLOATING
C2461 VDD.t62 VSS 0.03178f ; **FLOATING
C2462 VDD.n387 VSS 0.0211f ; **FLOATING
C2463 VDD.t60 VSS 0.03071f ; **FLOATING
C2464 VDD.n388 VSS 0.01566f ; **FLOATING
C2465 VDD.n389 VSS 0.05923f ; **FLOATING
C2466 VDD.n390 VSS 0.05088f ; **FLOATING
C2467 VDD.n391 VSS 0.70249f ; **FLOATING
C2468 VDD.n392 VSS 2.34984f ; **FLOATING
C2469 VDD.n393 VSS 0.71812f ; **FLOATING
C2470 VDD.n394 VSS 0.01475f ; **FLOATING
C2471 VDD.t381 VSS 0.02171f ; **FLOATING
C2472 VDD.n395 VSS 0.06128f ; **FLOATING
C2473 VDD.n396 VSS 0.01535f ; **FLOATING
C2474 VDD.n397 VSS 0.0156f ; **FLOATING
C2475 VDD.n398 VSS 0.06781f ; **FLOATING
C2476 VDD.t36 VSS 0.06343f ; **FLOATING
C2477 VDD.n399 VSS 0.02215f ; **FLOATING
C2478 VDD.n400 VSS 0.04964f ; **FLOATING
C2479 VDD.t31 VSS 0.05675f ; **FLOATING
C2480 VDD.n401 VSS 0.02212f ; **FLOATING
C2481 VDD.t37 VSS 0.05675f ; **FLOATING
C2482 VDD.n402 VSS 0.0635f ; **FLOATING
C2483 VDD.n403 VSS 0.02213f ; **FLOATING
C2484 VDD.n404 VSS 0.04481f ; **FLOATING
C2485 VDD.t29 VSS 0.35887f ; **FLOATING
C2486 VDD.n405 VSS 0.01448f ; **FLOATING
C2487 VDD.n406 VSS 0.04479f ; **FLOATING
C2488 VDD.t30 VSS 0.06343f ; **FLOATING
C2489 VDD.n407 VSS 0.02214f ; **FLOATING
C2490 VDD.n408 VSS 0.06782f ; **FLOATING
C2491 VDD.n409 VSS 0.03578f ; **FLOATING
C2492 VDD.n410 VSS 0.08627f ; **FLOATING
C2493 VDD.t105 VSS 0.06343f ; **FLOATING
C2494 VDD.n411 VSS 0.04115f ; **FLOATING
C2495 VDD.t97 VSS 0.06343f ; **FLOATING
C2496 VDD.n412 VSS 0.04116f ; **FLOATING
C2497 VDD.n413 VSS 0.08626f ; **FLOATING
C2498 VDD.n414 VSS 0.03118f ; **FLOATING
C2499 VDD.n415 VSS 0.08647f ; **FLOATING
C2500 VDD.t107 VSS 0.06343f ; **FLOATING
C2501 VDD.n416 VSS 0.04115f ; **FLOATING
C2502 VDD.t99 VSS 0.06343f ; **FLOATING
C2503 VDD.n417 VSS 0.04116f ; **FLOATING
C2504 VDD.n418 VSS 0.08645f ; **FLOATING
C2505 VDD.n419 VSS 0.03566f ; **FLOATING
C2506 VDD.n420 VSS 0.08169f ; **FLOATING
C2507 VDD.t109 VSS 0.06343f ; **FLOATING
C2508 VDD.n421 VSS 0.04115f ; **FLOATING
C2509 VDD.t101 VSS 0.06343f ; **FLOATING
C2510 VDD.n422 VSS 0.04116f ; **FLOATING
C2511 VDD.n423 VSS 0.08173f ; **FLOATING
C2512 VDD.n424 VSS 0.03574f ; **FLOATING
C2513 VDD.n425 VSS 0.01566f ; **FLOATING
C2514 VDD.t34 VSS 0.05675f ; **FLOATING
C2515 VDD.t39 VSS 0.05675f ; **FLOATING
C2516 VDD.n426 VSS 0.0691f ; **FLOATING
C2517 VDD.n427 VSS 0.02213f ; **FLOATING
C2518 VDD.t33 VSS 0.06343f ; **FLOATING
C2519 VDD.n428 VSS 0.06783f ; **FLOATING
C2520 VDD.n429 VSS 0.02214f ; **FLOATING
C2521 VDD.n430 VSS 0.06779f ; **FLOATING
C2522 VDD.t40 VSS 0.06343f ; **FLOATING
C2523 VDD.n431 VSS 0.02215f ; **FLOATING
C2524 VDD.n432 VSS 0.04479f ; **FLOATING
C2525 VDD.t32 VSS 0.35887f ; **FLOATING
C2526 VDD.n433 VSS 0.01448f ; **FLOATING
C2527 VDD.n434 VSS 0.04801f ; **FLOATING
C2528 VDD.n435 VSS 0.02212f ; **FLOATING
C2529 VDD.n436 VSS 0.08081f ; **FLOATING
C2530 VDD.n437 VSS 0.04703f ; **FLOATING
C2531 VDD.t7 VSS 12.4932f ; **FLOATING
.ends
