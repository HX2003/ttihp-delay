* NGSPICE file created from hx_delay_line_with_mux_dll.ext - technology: ihp-sg13g2

.subckt hx_delay_line_with_mux_dll VDD DELAY_OUT_LAST VSS DELAY_VBIASN DELAY_VBIASP
+ REF_CLK DLL_RESETN MUX_SEL0 MUX_SEL1 MUX_OUT MUX_SEL4 MUX_SEL2 MUX_SEL3
X0 a_14009_5878# REF_CLK VSS.t133 VSS.t132 sg13_lv_nmos ad=0.2516p pd=2.16u as=1.9998p ps=12.915u w=0.74u l=0.13u
X1 VDD.t49 a_4003_1842# a_4437_1842# VDD.t0 sg13_lv_pmos ad=0.2128p pd=1.5u as=0.3808p ps=2.92u w=1.12u l=0.13u
X2 VSS.t345 DLL_RESETN a_10040_6305# VSS.t344 sg13_lv_nmos ad=0.1626p pd=1.415u as=60.89999f ps=0.71u w=0.42u l=0.13u
X3 VSS.t636 a_15077_1842# a_15545_1044# VSS.t635 sg13_lv_nmos ad=0.1665p pd=1.19u as=0.2516p ps=2.16u w=0.74u l=0.13u
X4 a_27915_1044# a_27705_1044# VDD.t98 VDD.t3 sg13_lv_pmos ad=0.2128p pd=1.5u as=0.252p ps=1.57u w=1.12u l=0.13u
X5 VSS.t537 VDD.t400 VSS.t535 VSS.t536 sg13_lv_nmos ad=79.8f pd=0.8u as=0 ps=0 w=0.42u l=1u
X6 a_10951_2470# a_10713_1842# a_10843_1842# VDD.t0 sg13_lv_pmos ad=0.2128p pd=1.5u as=0.3808p ps=2.92u w=1.12u l=0.2u
X7 VSS.t445 a_3171_1047.t7 a_11924_1008# VSS.t444 sg13_lv_nmos ad=0.2516p pd=2.16u as=0.2516p ps=2.16u w=0.74u l=0.13u
X8 VDD.t251 VSS.t594 VDD.t201 VDD.t3 sg13_lv_pmos ad=0.34p pd=2.68u as=0 ps=0 w=1u l=1u
X9 VSS.t369 a_1256_1044# a_2967_1395# VSS.t368 sg13_lv_nmos ad=0.1331p pd=1.12u as=0.1216p ps=1.02u w=0.64u l=0.13u
X10 VSS.t540 VDD.t399 VSS.t539 VSS.t538 sg13_lv_nmos ad=0.1428p pd=1.52u as=0 ps=0 w=0.42u l=1u
X11 a_25153_1842# a_24957_1842# VSS.t645 VSS.t670 sg13_lv_nmos ad=0.2516p pd=2.16u as=0.1406p ps=1.12u w=0.74u l=0.13u
X12 VDD.t177 VSS.t559 VDD.t205 VDD.t3 sg13_lv_pmos ad=0.34p pd=2.68u as=0 ps=0 w=1u l=1u
X13 a_15108_6109# a_14851_6228# a_15270_6305# VSS.t17 sg13_lv_nmos ad=0.1428p pd=1.52u as=37.8f ps=0.6u w=0.42u l=0.13u
X14 VSS.t21 a_14851_6228# a_15688_5867# VSS.t20 sg13_lv_nmos ad=0.1406p pd=1.12u as=0.2516p ps=2.16u w=0.74u l=0.13u
X15 VSS.t97 VSS.t95 VSS.t95 VSS.t96 sg13_lv_nmos ad=0.68p pd=4.68u as=0 ps=0 w=2u l=1u
X16 a_15108_5325# a_12849_5867# VDD.t42 VDD.t1 sg13_lv_pmos ad=79.8f pd=0.8u as=1.03698p ps=6.245u w=0.42u l=0.13u
X17 a_25630_1044# a_2019_1047.t2 a_25528_1044# VSS.t46 sg13_lv_nmos ad=0.2516p pd=2.16u as=0.1406p ps=1.12u w=0.74u l=0.13u
X18 VDD.t294 DELAY_VBIASP.t14 a_19311_2470# VDD.t0 sg13_lv_pmos ad=0.3808p pd=2.92u as=0.2128p ps=1.5u w=1.12u l=0.6u
X19 a_16108_289# a_2019_311.t2 a_16510_1044# VSS.t31 sg13_lv_nmos ad=0.2516p pd=2.16u as=0.2516p ps=2.16u w=0.74u l=0.13u
X20 VDD.t306 DELAY_VBIASP.t27 a_9431_2470# VDD.t0 sg13_lv_pmos ad=0.3808p pd=2.92u as=0.2128p ps=1.5u w=1.12u l=0.6u
X21 VSS.t605 VDD.t386 VSS.t604 VSS.t603 sg13_lv_nmos ad=0.1428p pd=1.52u as=0 ps=0 w=0.42u l=1u
X22 VSS.t92 VSS.t92 VSS.t94 VSS.t93 sg13_lv_nmos ad=0.68p pd=4.68u as=0 ps=0 w=2u l=1u
X23 VDD.t317 DELAY_VBIASP.t9 a_23111_2470# VDD.t0 sg13_lv_pmos ad=0.3808p pd=2.92u as=0.2128p ps=1.5u w=1.12u l=0.6u
X24 a_7390_1044# a_8231_1008# a_8155_1044# VDD.t3 sg13_lv_pmos ad=0.3808p pd=2.92u as=0.2128p ps=1.5u w=1.12u l=0.13u
X25 a_14009_5878# REF_CLK VDD.t42 VDD.t1 sg13_lv_pmos ad=0.4088p pd=2.97u as=1.03698p ps=6.245u w=1.12u l=0.13u
X26 VSS.t186 a_2595_311.t3 a_8745_519# VSS.t185 sg13_lv_nmos ad=0.2516p pd=2.16u as=0.2516p ps=2.16u w=0.74u l=0.13u
X27 a_11748_6109# DLL_RESETN VDD.t42 VDD.t1 sg13_lv_pmos ad=79.8f pd=0.8u as=1.10612p ps=6.66u w=0.42u l=0.13u
X28 VDD.t72 a_11491_6228# a_12158_5867# VDD.t1 sg13_lv_pmos ad=0.2128p pd=1.5u as=0.3864p ps=2.93u w=1.12u l=0.13u
X29 VDD.t298 DELAY_VBIASP.t1 DELAY_VBIASP.t2 VDD.t58 sg13_lv_pmos ad=0.3808p pd=2.92u as=1.0304p ps=4.08u w=1.12u l=0.6u
X30 a_17791_1842# a_17553_1842# a_17683_1842# VSS.t462 sg13_lv_nmos ad=0.1406p pd=1.12u as=0.2516p ps=2.16u w=0.74u l=0.2u
X31 VSS.t346 a_11748_6109# a_11397_6228# VSS.t158 sg13_lv_nmos ad=79.8f pd=0.8u as=0.1428p ps=1.52u w=0.42u l=0.13u
X32 VDD.t329 a_12037_1842# a_12505_1044# VDD.t3 sg13_lv_pmos ad=0.252p pd=1.57u as=0.3808p ps=2.92u w=1.12u l=0.13u
X33 a_16510_1044# a_2019_1047.t5 a_16408_1044# VSS.t446 sg13_lv_nmos ad=0.2516p pd=2.16u as=0.1406p ps=1.12u w=0.74u l=0.13u
X34 a_21591_1842# a_21353_1842# a_21483_1842# VSS.t360 sg13_lv_nmos ad=0.1406p pd=1.12u as=0.2516p ps=2.16u w=0.74u l=0.2u
X35 a_6153_1842# a_5957_1842# VSS.t83 VSS.t82 sg13_lv_nmos ad=0.2516p pd=2.16u as=0.1406p ps=1.12u w=0.74u l=0.13u
X36 VSS.t45 a_16163_1842# a_16597_1842# VSS.t44 sg13_lv_nmos ad=0.1406p pd=1.12u as=0.2516p ps=2.16u w=0.74u l=0.13u
X37 VSS.t42 a_3171_1047.t2 a_27124_1008# VSS.t41 sg13_lv_nmos ad=0.2516p pd=2.16u as=0.2516p ps=2.16u w=0.74u l=0.13u
X38 VDD.t114 a_11603_1842# a_12037_1842# VDD.t0 sg13_lv_pmos ad=0.2128p pd=1.5u as=0.3808p ps=2.92u w=1.12u l=0.13u
X39 VDD.t336 a_3171_311.t3 a_11785_519# VDD.t3 sg13_lv_pmos ad=0.3808p pd=2.92u as=0.3808p ps=2.92u w=1.12u l=0.13u
X40 a_6126_3816# a_6326_4590# VDD.t12 VDD.t1 sg13_lv_pmos ad=0.38p pd=2.38u as=0.38p ps=2.38u w=2u l=1u
X41 a_24393_1842# a_24197_1842# VDD.t190 VDD.t0 sg13_lv_pmos ad=0.3808p pd=2.92u as=0.2128p ps=1.5u w=1.12u l=0.13u
X42 a_5731_289# a_2595_311.t3 a_7390_1044# VSS.t184 sg13_lv_nmos ad=0.2516p pd=2.16u as=0.2516p ps=2.16u w=0.74u l=0.13u
X43 a_10430_1044# a_2595_1047.t7 a_11195_1044# VSS.t392 sg13_lv_nmos ad=0.2516p pd=2.16u as=0.1406p ps=1.12u w=0.74u l=0.13u
X44 a_13306_6305# a_12355_5867# VDD.t153 VDD.t1 sg13_lv_pmos ad=79.8f pd=0.8u as=0.1428p ps=1.52u w=0.42u l=0.13u
X45 a_23355_1044# a_23145_1044# VSS.t198 VSS.t197 sg13_lv_nmos ad=0.1406p pd=1.12u as=0.1665p ps=1.19u w=0.74u l=0.13u
X46 VDD.t304 DELAY_VBIASP.t20 a_14751_2470# VDD.t0 sg13_lv_pmos ad=0.3808p pd=2.92u as=0.2128p ps=1.5u w=1.12u l=0.6u
X47 VSS.t293 DELAY_VBIASN a_10191_1842# VSS.t292 sg13_lv_nmos ad=0.2516p pd=2.16u as=0.1406p ps=1.12u w=0.74u l=0.6u
X48 VSS.t693 a_3747_1047.t4 a_21911_1008# VSS.t692 sg13_lv_nmos ad=0.2516p pd=2.16u as=0.2516p ps=2.16u w=0.74u l=0.13u
X49 VSS.t191 a_19963_1842# a_20397_1842# VSS.t190 sg13_lv_nmos ad=0.1406p pd=1.12u as=0.2516p ps=2.16u w=0.74u l=0.13u
X50 a_6126_3816# a_6326_4590# VDD.t18 VDD.t1 sg13_lv_pmos ad=0.38p pd=2.38u as=0.38p ps=2.38u w=2u l=1u
X51 VDD.t16 a_6326_4590# a_6854_5454# VDD.t1 sg13_lv_pmos ad=0.38p pd=2.38u as=0.38p ps=2.38u w=2u l=1u
X52 VDD.t297 DELAY_VBIASP.t34 a_4111_2470# VDD.t0 sg13_lv_pmos ad=0.3808p pd=2.92u as=0.2128p ps=1.5u w=1.12u l=0.6u
X53 a_10328_1044# a_9757_1842# VDD.t59 VDD.t3 sg13_lv_pmos ad=0.2128p pd=1.5u as=0.3808p ps=2.92u w=1.12u l=0.13u
X54 a_20968_1044# a_20397_1842# VSS.t234 VSS.t233 sg13_lv_nmos ad=0.1406p pd=1.12u as=0.2516p ps=2.16u w=0.74u l=0.13u
X55 a_22590_1044# a_22564_1008# a_22488_1044# VDD.t3 sg13_lv_pmos ad=0.3808p pd=2.92u as=0.2128p ps=1.5u w=1.12u l=0.13u
X56 VDD.t168 VSS.t552 VDD.t186 VDD.t3 sg13_lv_pmos ad=0.19p pd=1.38u as=0 ps=0 w=1u l=1u
X57 a_8808_1044# a_8237_1842# VDD.t68 VDD.t3 sg13_lv_pmos ad=0.2128p pd=1.5u as=0.3808p ps=2.92u w=1.12u l=0.13u
X58 VDD.t22 a_6326_4590# a_6326_4590# VDD.t1 sg13_lv_pmos ad=0.38p pd=2.38u as=0.38p ps=2.38u w=2u l=1u
X59 a_4157_1313# REF_CLK VDD.t63 VDD.t3 sg13_lv_pmos ad=0.3808p pd=2.92u as=0.3808p ps=2.92u w=1.12u l=0.13u
X60 a_17031_2470# a_16793_1842# a_16923_1842# VDD.t0 sg13_lv_pmos ad=0.2128p pd=1.5u as=0.3808p ps=2.92u w=1.12u l=0.2u
X61 a_11473_1842# a_11277_1842# VSS.t61 VSS.t60 sg13_lv_nmos ad=0.2516p pd=2.16u as=0.1406p ps=1.12u w=0.74u l=0.13u
X62 VSS.t597 VDD.t388 VSS.t595 VSS.t596 sg13_lv_nmos ad=79.8f pd=0.8u as=0 ps=0 w=0.42u l=1u
X63 a_13306_5105# a_13132_5420# VDD.t128 VDD.t1 sg13_lv_pmos ad=79.8f pd=0.8u as=0.1428p ps=1.52u w=0.42u l=0.13u
X64 a_19448_1044# a_18877_1842# VSS.t399 VSS.t398 sg13_lv_nmos ad=0.1406p pd=1.12u as=0.2516p ps=2.16u w=0.74u l=0.13u
X65 a_10430_1044# a_3171_1047.t7 a_11848_1044# VSS.t443 sg13_lv_nmos ad=0.2516p pd=2.16u as=0.1406p ps=1.12u w=0.74u l=0.13u
X66 a_20831_2470# a_20593_1842# a_20723_1842# VDD.t0 sg13_lv_pmos ad=0.2128p pd=1.5u as=0.3808p ps=2.92u w=1.12u l=0.2u
X67 VSS.t562 VDD.t395 VSS.t560 VSS.t561 sg13_lv_nmos ad=79.8f pd=0.8u as=0 ps=0 w=0.42u l=1u
X68 VDD.t98 a_27237_1842# a_27705_1044# VDD.t3 sg13_lv_pmos ad=0.252p pd=1.57u as=0.3808p ps=2.92u w=1.12u l=0.13u
X69 a_5393_1842# a_5197_1842# VDD.t217 VDD.t0 sg13_lv_pmos ad=0.3808p pd=2.92u as=0.2128p ps=1.5u w=1.12u l=0.13u
X70 VDD.t311 DELAY_VBIASP.t17 a_17031_2470# VDD.t0 sg13_lv_pmos ad=0.3808p pd=2.92u as=0.2128p ps=1.5u w=1.12u l=0.6u
X71 VDD.t42 a_15108_6109# a_15053_5990# VDD.t1 sg13_lv_pmos ad=1.10612p pd=6.66u as=93.45f ps=0.865u w=0.42u l=0.13u
X72 VDD.t18 a_6326_4590# a_6854_5454# VDD.t1 sg13_lv_pmos ad=0.38p pd=2.38u as=0.38p ps=2.38u w=2u l=1u
X73 a_13818_6292# a_12849_5867# VSS.t717 VSS.t716 sg13_lv_nmos ad=37.8f pd=0.6u as=0.1701p ps=1.65u w=0.42u l=0.13u
X74 VDD.t97 a_26803_1842# a_27237_1842# VDD.t0 sg13_lv_pmos ad=0.2128p pd=1.5u as=0.3808p ps=2.92u w=1.12u l=0.13u
X75 VDD.t46 MUX_SEL1 a_3449_1395# VDD.t3 sg13_lv_pmos ad=0.1918p pd=1.5u as=0.1596p ps=1.22u w=0.84u l=0.13u
X76 a_14851_6228# a_14009_5878# a_13592_5871# VDD.t1 sg13_lv_pmos ad=0.2048p pd=1.63u as=0.34p ps=2.68u w=1u l=0.13u
X77 a_25630_1044# a_2595_1047.t2 a_26395_1044# VSS.t428 sg13_lv_nmos ad=0.2516p pd=2.16u as=0.1406p ps=1.12u w=0.74u l=0.13u
X78 VSS.t325 DELAY_VBIASN a_25391_1842# VSS.t324 sg13_lv_nmos ad=0.2516p pd=2.16u as=0.1406p ps=1.12u w=0.74u l=0.6u
X79 VSS.t270 DELAY_VBIASN VSS.t269 VSS.t261 sg13_lv_nmos ad=1.33p pd=7.38u as=0 ps=0 w=7u l=7u
X80 a_6635_1044# a_6425_1044# VDD.t55 VDD.t3 sg13_lv_pmos ad=0.2128p pd=1.5u as=0.252p ps=1.57u w=1.12u l=0.13u
X81 VDD.t121 DLL_RESETN a_9946_6305# VDD.t1 sg13_lv_pmos ad=0.36237p pd=2.605u as=79.8f ps=0.8u w=0.42u l=0.13u
X82 a_20315_1044# a_20105_1044# VDD.t34 VDD.t3 sg13_lv_pmos ad=0.2128p pd=1.5u as=0.252p ps=1.57u w=1.12u l=0.13u
X83 VDD.t191 a_2595_1047.t9 a_5191_1008# VDD.t3 sg13_lv_pmos ad=0.3808p pd=2.92u as=0.3808p ps=2.92u w=1.12u l=0.13u
X84 a_19311_2470# a_19073_1842# a_19203_1842# VDD.t0 sg13_lv_pmos ad=0.2128p pd=1.5u as=0.3808p ps=2.92u w=1.12u l=0.2u
X85 VSS.t674 a_1721_1395# a_2019_1047.t0 VSS.t673 sg13_lv_nmos ad=0.2812p pd=2.24u as=0.1406p ps=1.12u w=0.74u l=0.13u
X86 a_25528_1044# a_24957_1842# VDD.t354 VDD.t3 sg13_lv_pmos ad=0.2128p pd=1.5u as=0.3808p ps=2.92u w=1.12u l=0.13u
X87 VSS.t85 a_5957_1842# a_6425_1044# VSS.t84 sg13_lv_nmos ad=0.1665p pd=1.19u as=0.2516p ps=2.16u w=0.74u l=0.13u
X88 VSS.t439 a_2019_1047.t6 a_13444_1008# VSS.t438 sg13_lv_nmos ad=0.2516p pd=2.16u as=0.2516p ps=2.16u w=0.74u l=0.13u
X89 a_23111_2470# a_22873_1842# a_23003_1842# VDD.t0 sg13_lv_pmos ad=0.2128p pd=1.5u as=0.3808p ps=2.92u w=1.12u l=0.2u
X90 VSS.t535 VDD.t400 VSS.t534 VSS.t533 sg13_lv_nmos ad=0.1428p pd=1.52u as=0 ps=0 w=0.42u l=1u
X91 VSS.t181 a_15964_289# a_16851_309# VSS.t520 sg13_lv_nmos ad=0.1371p pd=1.12u as=0.2176p ps=1.96u w=0.64u l=0.13u
X92 a_10713_1842# a_10517_1842# VDD.t218 VDD.t0 sg13_lv_pmos ad=0.3808p pd=2.92u as=0.2128p ps=1.5u w=1.12u l=0.13u
X93 VDD.t65 a_17683_1842# a_18117_1842# VDD.t0 sg13_lv_pmos ad=0.2128p pd=1.5u as=0.3808p ps=2.92u w=1.12u l=0.13u
X94 a_16108_289# a_17865_519# a_16510_1044# VDD.t3 sg13_lv_pmos ad=0.3808p pd=2.92u as=0.3808p ps=2.92u w=1.12u l=0.13u
X95 a_26673_1842# a_26477_1842# VSS.t376 VSS.t375 sg13_lv_nmos ad=0.2516p pd=2.16u as=0.1406p ps=1.12u w=0.74u l=0.13u
X96 VDD.t69 a_7803_1842# a_8237_1842# VDD.t0 sg13_lv_pmos ad=0.2128p pd=1.5u as=0.3808p ps=2.92u w=1.12u l=0.13u
X97 a_4248_1044# a_4157_1313# VSS.t373 VSS.t372 sg13_lv_nmos ad=0.1406p pd=1.12u as=0.2516p ps=2.16u w=0.74u l=0.13u
X98 a_16108_289# a_3171_311.t2 a_22590_1044# VSS.t215 sg13_lv_nmos ad=0.2516p pd=2.16u as=0.2516p ps=2.16u w=0.74u l=0.13u
X99 VSS.t305 DELAY_VBIASN a_6391_1842# VSS.t304 sg13_lv_nmos ad=0.2516p pd=2.16u as=0.1406p ps=1.12u w=0.74u l=0.6u
X100 a_16408_1044# a_15837_1842# VDD.t238 VDD.t3 sg13_lv_pmos ad=0.2128p pd=1.5u as=0.3808p ps=2.92u w=1.12u l=0.13u
X101 a_10232_5871# a_10206_5835# VSS.t345 VSS.t344 sg13_lv_nmos ad=0.2516p pd=2.16u as=0.1626p ps=1.415u w=0.74u l=0.13u
X102 a_19550_1044# a_3747_1047.t4 a_21835_1044# VSS.t691 sg13_lv_nmos ad=0.2516p pd=2.16u as=0.1406p ps=1.12u w=0.74u l=0.13u
X103 VSS.t291 DELAY_VBIASN a_20831_1842# VSS.t290 sg13_lv_nmos ad=0.2516p pd=2.16u as=0.1406p ps=1.12u w=0.74u l=0.6u
X104 a_3171_311.t1 a_2873_331# VDD.t359 VDD.t3 sg13_lv_pmos ad=0.2128p pd=1.5u as=0.1918p ps=1.5u w=1.12u l=0.13u
X105 a_15304_4605# a_14851_6228# VDD.t25 VDD.t1 sg13_lv_pmos ad=0.4312p pd=3.01u as=0.2639p ps=1.81u w=1.12u l=0.13u
X106 a_13106_5357# a_12907_5420# VSS.t58 VSS.t200 sg13_lv_nmos ad=0.27427p pd=2.28u as=1.45407p ps=9.445u w=0.795u l=0.13u
X107 a_3747_311.t1 a_3449_331# VDD.t225 VDD.t3 sg13_lv_pmos ad=0.2128p pd=1.5u as=0.1918p ps=1.5u w=1.12u l=0.13u
X108 a_13132_5420# a_13106_5357# VDD.t42 VDD.t1 sg13_lv_pmos ad=0.3927p pd=2.99u as=1.10612p ps=6.66u w=1.155u l=0.13u
X109 a_7390_1044# a_9751_1008# a_9675_1044# VDD.t3 sg13_lv_pmos ad=0.3808p pd=2.92u as=0.2128p ps=1.5u w=1.12u l=0.13u
X110 VSS.t278 DELAY_VBIASN VSS.t276 VSS.t257 sg13_lv_nmos ad=1.33p pd=7.38u as=0 ps=0 w=7u l=7u
X111 a_10191_1842# a_9953_1842# a_10083_1842# VSS.t359 sg13_lv_nmos ad=0.1406p pd=1.12u as=0.2516p ps=2.16u w=0.74u l=0.2u
X112 VSS.t198 a_22677_1842# a_23145_1044# VSS.t349 sg13_lv_nmos ad=0.1665p pd=1.19u as=0.2516p ps=2.16u w=0.74u l=0.13u
X113 a_14751_2470# a_14513_1842# a_14643_1842# VDD.t0 sg13_lv_pmos ad=0.2128p pd=1.5u as=0.3808p ps=2.92u w=1.12u l=0.2u
X114 a_5731_289# a_8745_519# a_7390_1044# VDD.t3 sg13_lv_pmos ad=0.3808p pd=2.92u as=0.3808p ps=2.92u w=1.12u l=0.13u
X115 VDD.t284 VDD.t282 VDD.t280 VDD.t0 sg13_lv_pmos ad=0.2128p pd=1.5u as=0 ps=0 w=1.12u l=0.13u
X116 a_4111_2470# REF_CLK a_4003_1842# VDD.t0 sg13_lv_pmos ad=0.2128p pd=1.5u as=0.3808p ps=2.92u w=1.12u l=0.2u
X117 a_13566_5835# a_14009_5878# a_13306_6305# VSS.t228 sg13_lv_nmos ad=79.8f pd=0.8u as=0.1296p ps=1.52u w=0.42u l=0.13u
X118 a_13306_6305# a_14111_5878# a_13566_5835# VDD.t1 sg13_lv_pmos ad=0.1428p pd=1.52u as=79.8f ps=0.8u w=0.42u l=0.13u
X119 a_13592_5423# a_14111_5227# a_14851_5182# VSS.t39 sg13_lv_nmos ad=0.3473p pd=2.71u as=0.12665p ps=1.145u w=0.74u l=0.13u
X120 a_7673_1842# a_7477_1842# VSS.t153 VSS.t193 sg13_lv_nmos ad=0.2516p pd=2.16u as=0.1406p ps=1.12u w=0.74u l=0.13u
X121 VDD.t348 a_3171_1047.t5 a_18004_1008# VDD.t3 sg13_lv_pmos ad=0.3808p pd=2.92u as=0.3808p ps=2.92u w=1.12u l=0.13u
X122 VDD.t67 a_13123_1842# a_13557_1842# VDD.t0 sg13_lv_pmos ad=0.2128p pd=1.5u as=0.3808p ps=2.92u w=1.12u l=0.13u
X123 VDD.t337 a_3747_311.t2 a_26985_519# VDD.t3 sg13_lv_pmos ad=0.3808p pd=2.92u as=0.3808p ps=2.92u w=1.12u l=0.13u
X124 a_25913_1842# a_25717_1842# VDD.t178 VDD.t0 sg13_lv_pmos ad=0.3808p pd=2.92u as=0.2128p ps=1.5u w=1.12u l=0.13u
X125 a_10430_1044# a_3747_1047.t7 a_12715_1044# VSS.t8 sg13_lv_nmos ad=0.2516p pd=2.16u as=0.1406p ps=1.12u w=0.74u l=0.13u
X126 a_6326_4590# a_5974_5723# a_6126_3816# VSS.t504 sg13_lv_nmos ad=0.38p pd=2.38u as=0.68p ps=4.68u w=2u l=1u
X127 a_14235_1044# a_14025_1044# VDD.t103 VDD.t3 sg13_lv_pmos ad=0.2128p pd=1.5u as=0.252p ps=1.57u w=1.12u l=0.13u
X128 a_24875_1044# a_24665_1044# VSS.t386 VSS.t385 sg13_lv_nmos ad=0.1406p pd=1.12u as=0.1665p ps=1.19u w=0.74u l=0.13u
X129 VSS.t297 DELAY_VBIASN a_11711_1842# VSS.t296 sg13_lv_nmos ad=0.2516p pd=2.16u as=0.1406p ps=1.12u w=0.74u l=0.6u
X130 VDD.t5 a_3747_1047.t7 a_12791_1008# VDD.t3 sg13_lv_pmos ad=0.3808p pd=2.92u as=0.3808p ps=2.92u w=1.12u l=0.13u
X131 VSS.t54 a_2595_1047.t3 a_23431_1008# VSS.t53 sg13_lv_nmos ad=0.2516p pd=2.16u as=0.2516p ps=2.16u w=0.74u l=0.13u
X132 VSS.t14 a_21483_1842# a_21917_1842# VSS.t214 sg13_lv_nmos ad=0.1406p pd=1.12u as=0.2516p ps=2.16u w=0.74u l=0.13u
X133 VSS.t213 a_13557_1842# a_14025_1044# VSS.t477 sg13_lv_nmos ad=0.1665p pd=1.19u as=0.2516p ps=2.16u w=0.74u l=0.13u
X134 a_11848_1044# a_11277_1842# VDD.t44 VDD.t3 sg13_lv_pmos ad=0.2128p pd=1.5u as=0.3808p ps=2.92u w=1.12u l=0.13u
X135 VDD.t86 VSS.t612 VDD.t253 VDD.t3 sg13_lv_pmos ad=0.19p pd=1.38u as=0 ps=0 w=1u l=1u
X136 VDD.t42 a_12907_5186# a_12907_5420# VDD.t1 sg13_lv_pmos ad=1.10612p pd=6.66u as=0.2442p ps=2.06u w=0.66u l=0.13u
X137 a_25391_1842# a_25153_1842# a_25283_1842# VSS.t379 sg13_lv_nmos ad=0.1406p pd=1.12u as=0.2516p ps=2.16u w=0.74u l=0.2u
X138 a_12993_1842# a_12797_1842# VSS.t24 VSS.t23 sg13_lv_nmos ad=0.2516p pd=2.16u as=0.1406p ps=1.12u w=0.74u l=0.13u
X139 DELAY_OUT_LAST a_27997_1842# VDD.t70 VDD.t0 sg13_lv_pmos ad=0.3808p pd=2.92u as=0.2128p ps=1.5u w=1.12u l=0.13u
X140 VDD.t84 VSS.t615 VDD.t83 VDD.t3 sg13_lv_pmos ad=0.34p pd=2.68u as=0 ps=0 w=1u l=1u
X141 VDD.t34 a_19637_1842# a_20105_1044# VDD.t3 sg13_lv_pmos ad=0.252p pd=1.57u as=0.3808p ps=2.92u w=1.12u l=0.13u
X142 a_6854_5454# a_6326_4590# VDD.t14 VDD.t1 sg13_lv_pmos ad=0.38p pd=2.38u as=0.38p ps=2.38u w=2u l=1u
X143 VSS.t285 DELAY_VBIASN a_13991_1842# VSS.t284 sg13_lv_nmos ad=0.2516p pd=2.16u as=0.1406p ps=1.12u w=0.74u l=0.6u
X144 VSS.t595 VDD.t388 VSS.t594 VSS.t593 sg13_lv_nmos ad=0.1428p pd=1.52u as=0 ps=0 w=0.42u l=1u
X145 a_22590_1044# a_3171_1047.t3 a_24008_1044# VSS.t452 sg13_lv_nmos ad=0.2516p pd=2.16u as=0.1406p ps=1.12u w=0.74u l=0.13u
X146 a_6913_1842# a_6717_1842# VDD.t212 VDD.t0 sg13_lv_pmos ad=0.3808p pd=2.92u as=0.2128p ps=1.5u w=1.12u l=0.13u
X147 VDD.t312 DELAY_VBIASP.t15 a_18551_2470# VDD.t0 sg13_lv_pmos ad=0.3808p pd=2.92u as=0.2128p ps=1.5u w=1.12u l=0.6u
X148 VSS.t419 a_23763_1842# a_24197_1842# VSS.t518 sg13_lv_nmos ad=0.1406p pd=1.12u as=0.2516p ps=2.16u w=0.74u l=0.13u
X149 VSS.t560 VDD.t395 VSS.t559 VSS.t558 sg13_lv_nmos ad=0.1428p pd=1.52u as=0 ps=0 w=0.42u l=1u
X150 VDD.t137 a_1256_1044# a_2873_1395# VDD.t3 sg13_lv_pmos ad=0.1918p pd=1.5u as=0.1596p ps=1.22u w=0.84u l=0.13u
X151 a_3171_311.t0 a_2873_331# VSS.t677 VSS.t700 sg13_lv_nmos ad=0.1406p pd=1.12u as=0.1331p ps=1.12u w=0.74u l=0.13u
X152 VDD.t372 a_2873_331# a_3171_311.t1 VDD.t3 sg13_lv_pmos ad=0.4256p pd=3u as=0.2128p ps=1.5u w=1.12u l=0.13u
X153 a_16510_1044# a_17351_1008# a_17275_1044# VDD.t3 sg13_lv_pmos ad=0.3808p pd=2.92u as=0.2128p ps=1.5u w=1.12u l=0.13u
X154 a_25630_1044# a_3747_1047.t2 a_27915_1044# VSS.t5 sg13_lv_nmos ad=0.2516p pd=2.16u as=0.1406p ps=1.12u w=0.74u l=0.13u
X155 VSS.t337 DELAY_VBIASN a_26911_1842# VSS.t336 sg13_lv_nmos ad=0.2516p pd=2.16u as=0.1406p ps=1.12u w=0.74u l=0.6u
X156 a_3747_311.t0 a_3449_331# VSS.t479 VSS.t478 sg13_lv_nmos ad=0.1406p pd=1.12u as=0.1331p ps=1.12u w=0.74u l=0.13u
X157 VDD.t226 a_3449_331# a_3747_311.t1 VDD.t3 sg13_lv_pmos ad=0.4256p pd=3u as=0.2128p ps=1.5u w=1.12u l=0.13u
X158 VDD.t319 DELAY_VBIASP.t10 a_22351_2470# VDD.t0 sg13_lv_pmos ad=0.3808p pd=2.92u as=0.2128p ps=1.5u w=1.12u l=0.6u
X159 VDD.t4 a_3747_1047.t2 a_27991_1008# VDD.t3 sg13_lv_pmos ad=0.3808p pd=2.92u as=0.3808p ps=2.92u w=1.12u l=0.13u
X160 VDD.t184 VSS.t532 VDD.t185 VDD.t3 sg13_lv_pmos ad=0.19p pd=1.38u as=0 ps=0 w=1u l=1u
X161 a_13019_5831# a_15688_5403# VSS.t685 VSS.t684 sg13_lv_nmos ad=0.2516p pd=2.16u as=0.1406p ps=1.12u w=0.74u l=0.13u
X162 VDD.t252 a_3747_1047.t9 a_6711_1008# VDD.t3 sg13_lv_pmos ad=0.3808p pd=2.92u as=0.3808p ps=2.92u w=1.12u l=0.13u
X163 a_6854_5454# a_6326_4590# VDD.t17 VDD.t1 sg13_lv_pmos ad=0.38p pd=2.38u as=0.38p ps=2.38u w=2u l=1u
X164 a_9772_5843# a_9746_5805# VDD.t42 VDD.t1 sg13_lv_pmos ad=0.3927p pd=2.99u as=1.10612p ps=6.66u w=1.155u l=0.13u
X165 a_6391_1842# a_6153_1842# a_6283_1842# VSS.t160 sg13_lv_nmos ad=0.1406p pd=1.12u as=0.2516p ps=2.16u w=0.74u l=0.2u
X166 a_15273_1842# a_15077_1842# VSS.t240 VSS.t634 sg13_lv_nmos ad=0.2516p pd=2.16u as=0.1406p ps=1.12u w=0.74u l=0.13u
X167 a_19833_1842# a_19637_1842# VDD.t33 VDD.t0 sg13_lv_pmos ad=0.3808p pd=2.92u as=0.2128p ps=1.5u w=1.12u l=0.13u
X168 a_16108_289# a_23945_519# a_22590_1044# VDD.t3 sg13_lv_pmos ad=0.3808p pd=2.92u as=0.3808p ps=2.92u w=1.12u l=0.13u
X169 VDD.t20 a_6326_4590# a_6126_3816# VDD.t1 sg13_lv_pmos ad=0.38p pd=2.38u as=0.38p ps=2.38u w=2u l=1u
X170 a_9193_1842# a_8997_1842# VDD.t82 VDD.t0 sg13_lv_pmos ad=0.3808p pd=2.92u as=0.2128p ps=1.5u w=1.12u l=0.13u
X171 a_24631_2470# a_24393_1842# a_24523_1842# VDD.t0 sg13_lv_pmos ad=0.2128p pd=1.5u as=0.3808p ps=2.92u w=1.12u l=0.2u
X172 VSS.t461 a_15403_1842# a_15837_1842# VSS.t460 sg13_lv_nmos ad=0.1406p pd=1.12u as=0.2516p ps=2.16u w=0.74u l=0.13u
X173 a_8155_1044# a_7945_1044# VSS.t66 VSS.t65 sg13_lv_nmos ad=0.1406p pd=1.12u as=0.1665p ps=1.19u w=0.74u l=0.13u
X174 a_23633_1842# a_23437_1842# VDD.t112 VDD.t0 sg13_lv_pmos ad=0.3808p pd=2.92u as=0.2128p ps=1.5u w=1.12u l=0.13u
X175 VSS.t466 a_4763_1842# a_5197_1842# VSS.t465 sg13_lv_nmos ad=0.1406p pd=1.12u as=0.2516p ps=2.16u w=0.74u l=0.13u
X176 a_27048_1044# a_26477_1842# VSS.t378 VSS.t377 sg13_lv_nmos ad=0.1406p pd=1.12u as=0.2516p ps=2.16u w=0.74u l=0.13u
X177 VDD.t60 a_9323_1842# a_9757_1842# VDD.t0 sg13_lv_pmos ad=0.2128p pd=1.5u as=0.3808p ps=2.92u w=1.12u l=0.13u
X178 a_5768_1044# a_5197_1842# VSS.t654 VSS.t653 sg13_lv_nmos ad=0.1406p pd=1.12u as=0.2516p ps=2.16u w=0.74u l=0.13u
X179 a_6326_4590# a_6126_3816# a_5778_3367# VSS.t501 sg13_lv_nmos ad=0.38p pd=2.38u as=0.68p ps=4.68u w=2u l=1u
X180 DELAY_VBIASN DLL_RESETN VDD.t120 VDD.t58 sg13_lv_pmos ad=0.158p pd=1.245u as=0.272p ps=2.28u w=0.8u l=0.2u
X181 a_7390_1044# a_7364_1008# a_7288_1044# VDD.t3 sg13_lv_pmos ad=0.3808p pd=2.92u as=0.2128p ps=1.5u w=1.12u l=0.13u
X182 VSS.t268 DELAY_VBIASN VSS.t267 VSS.t250 sg13_lv_nmos ad=2.38p pd=14.68u as=0 ps=0 w=7u l=7u
X183 VSS.t307 DELAY_VBIASN a_7911_1842# VSS.t306 sg13_lv_nmos ad=0.2516p pd=2.16u as=0.1406p ps=1.12u w=0.74u l=0.6u
X184 VDD.t57 a_13019_5831# a_12943_5867# VDD.t1 sg13_lv_pmos ad=0.2128p pd=1.5u as=0.2128p ps=1.5u w=1.12u l=0.13u
X185 a_6854_5986# a_15304_4605# DELAY_VBIASN VDD.t58 sg13_lv_pmos ad=0.136p pd=1.14u as=0.158p ps=1.245u w=0.4u l=0.2u
X186 VDD.t143 VSS.t572 VDD.t194 VDD.t3 sg13_lv_pmos ad=0.19p pd=1.38u as=0 ps=0 w=1u l=1u
X187 a_11711_1842# a_11473_1842# a_11603_1842# VSS.t64 sg13_lv_nmos ad=0.1406p pd=1.12u as=0.2516p ps=2.16u w=0.74u l=0.2u
X188 VSS.t386 a_24197_1842# a_24665_1044# VSS.t417 sg13_lv_nmos ad=0.1665p pd=1.19u as=0.2516p ps=2.16u w=0.74u l=0.13u
X189 a_16510_1044# a_3171_1047.t5 a_17928_1044# VSS.t658 sg13_lv_nmos ad=0.2516p pd=2.16u as=0.1406p ps=1.12u w=0.74u l=0.13u
X190 a_15270_5105# a_12849_5867# VSS.t388 VSS.t719 sg13_lv_nmos ad=37.8f pd=0.6u as=79.8f ps=0.8u w=0.42u l=0.13u
X191 a_5974_5723# a_6126_3816# VSS.t507 VSS.t504 sg13_lv_nmos ad=0.38p pd=2.38u as=0.68p ps=4.68u w=2u l=1u
X192 VSS.t552 VDD.t397 VSS.t550 VSS.t551 sg13_lv_nmos ad=79.8f pd=0.8u as=0 ps=0 w=0.42u l=1u
X193 a_5631_2470# a_5393_1842# a_5523_1842# VDD.t0 sg13_lv_pmos ad=0.2128p pd=1.5u as=0.3808p ps=2.92u w=1.12u l=0.2u
X194 a_14513_1842# a_14317_1842# VDD.t53 VDD.t0 sg13_lv_pmos ad=0.3808p pd=2.92u as=0.2128p ps=1.5u w=1.12u l=0.13u
X195 a_4633_1842# a_4437_1842# VDD.t49 VDD.t0 sg13_lv_pmos ad=0.3808p pd=2.92u as=0.2128p ps=1.5u w=1.12u l=0.13u
X196 VSS.t468 a_10083_1842# a_10517_1842# VSS.t467 sg13_lv_nmos ad=0.1406p pd=1.12u as=0.2516p ps=2.16u w=0.74u l=0.13u
X197 VDD.t196 a_2019_1047.t4 a_19524_1008# VDD.t3 sg13_lv_pmos ad=0.3808p pd=2.92u as=0.3808p ps=2.92u w=1.12u l=0.13u
X198 VSS.t220 a_3171_1047.t4 a_21044_1008# VSS.t219 sg13_lv_nmos ad=0.2516p pd=2.16u as=0.2516p ps=2.16u w=0.74u l=0.13u
X199 VSS.t702 a_2873_331# a_3171_311.t0 VSS.t701 sg13_lv_nmos ad=0.2812p pd=2.24u as=0.1406p ps=1.12u w=0.74u l=0.13u
X200 a_13949_5496# a_13592_5423# VDD.t85 VDD.t1 sg13_lv_pmos ad=63f pd=0.72u as=0.1563p ps=1.22u w=0.42u l=0.13u
X201 VSS.t481 a_3449_331# a_3747_311.t0 VSS.t480 sg13_lv_nmos ad=0.2812p pd=2.24u as=0.1406p ps=1.12u w=0.74u l=0.13u
X202 a_15755_1044# a_15545_1044# VDD.t334 VDD.t3 sg13_lv_pmos ad=0.2128p pd=1.5u as=0.252p ps=1.57u w=1.12u l=0.13u
X203 VDD.t38 a_2595_1047.t6 a_14311_1008# VDD.t3 sg13_lv_pmos ad=0.3808p pd=2.92u as=0.3808p ps=2.92u w=1.12u l=0.13u
X204 VSS.t333 DELAY_VBIASN a_24631_1842# VSS.t332 sg13_lv_nmos ad=0.2516p pd=2.16u as=0.1406p ps=1.12u w=0.74u l=0.6u
X205 a_5115_1044# a_4905_1044# VDD.t48 VDD.t3 sg13_lv_pmos ad=0.2128p pd=1.5u as=0.252p ps=1.57u w=1.12u l=0.13u
X206 a_5974_5723# a_6126_3816# VSS.t509 VSS.t504 sg13_lv_nmos ad=0.38p pd=2.38u as=0.68p ps=4.68u w=2u l=1u
X207 VSS.t58 a_12907_5186# a_12907_5186# VSS.t515 sg13_lv_nmos ad=1.45407p pd=9.445u as=0.111p ps=1.34u w=0.3u l=0.13u
X208 a_18551_2470# a_18313_1842# a_18443_1842# VDD.t0 sg13_lv_pmos ad=0.2128p pd=1.5u as=0.3808p ps=2.92u w=1.12u l=0.2u
X209 VDD.t94 VSS.t592 VDD.t93 VDD.t3 sg13_lv_pmos ad=0.19p pd=1.38u as=0 ps=0 w=1u l=1u
X210 a_3171_1047.t0 a_2873_1395# VSS.t369 VSS.t405 sg13_lv_nmos ad=0.1406p pd=1.12u as=0.1331p ps=1.12u w=0.74u l=0.13u
X211 a_13121_5831# a_15688_5867# VSS.t21 VSS.t694 sg13_lv_nmos ad=0.2516p pd=2.16u as=0.1406p ps=1.12u w=0.74u l=0.13u
X212 VSS.t258 DELAY_VBIASN VSS.t260 VSS.t259 sg13_lv_nmos ad=1.33p pd=7.38u as=0 ps=0 w=7u l=7u
X213 VSS.t484 a_2297_1395# a_2595_1047.t0 VSS.t483 sg13_lv_nmos ad=0.2812p pd=2.24u as=0.1406p ps=1.12u w=0.74u l=0.13u
X214 VDD.t373 a_14851_5182# a_15108_5325# VDD.t1 sg13_lv_pmos ad=0.2639p pd=1.81u as=79.8f ps=0.8u w=0.42u l=0.13u
X215 a_22351_2470# a_22113_1842# a_22243_1842# VDD.t0 sg13_lv_pmos ad=0.2128p pd=1.5u as=0.3808p ps=2.92u w=1.12u l=0.2u
X216 VSS.t117 VSS.t115 VSS.t69 VSS.t116 sg13_lv_nmos ad=0.2516p pd=2.16u as=0 ps=0 w=0.74u l=0.13u
X217 a_26911_1842# a_26673_1842# a_26803_1842# VSS.t420 sg13_lv_nmos ad=0.1406p pd=1.12u as=0.2516p ps=2.16u w=0.74u l=0.2u
X218 VSS.t640 a_3171_311.t3 a_11785_519# VSS.t639 sg13_lv_nmos ad=0.2516p pd=2.16u as=0.2516p ps=2.16u w=0.74u l=0.13u
X219 VDD.t357 a_1721_1395# a_2019_1047.t1 VDD.t3 sg13_lv_pmos ad=0.4256p pd=3u as=0.2128p ps=1.5u w=1.12u l=0.13u
X220 a_12656_5864# DLL_RESETN VSS.t348 VSS.t347 sg13_lv_nmos ad=0.2516p pd=2.16u as=0.2516p ps=2.16u w=0.74u l=0.13u
X221 a_14851_6228# a_14009_5878# a_14757_6228# VSS.t17 sg13_lv_nmos ad=0.12665p pd=1.145u as=0.1428p ps=1.52u w=0.42u l=0.13u
X222 VDD.t330 a_16923_1842# a_17357_1842# VDD.t0 sg13_lv_pmos ad=0.2128p pd=1.5u as=0.3808p ps=2.92u w=1.12u l=0.13u
X223 a_2391_1395# MUX_SEL0 a_2297_1395# VSS.t624 sg13_lv_nmos ad=0.1216p pd=1.02u as=0.2176p ps=1.96u w=0.64u l=0.13u
X224 VSS.t356 a_1544_1044# a_1815_1395# VSS.t355 sg13_lv_nmos ad=0.1331p pd=1.12u as=0.1216p ps=1.02u w=0.64u l=0.13u
X225 a_13368_1044# a_12797_1842# VSS.t26 VSS.t25 sg13_lv_nmos ad=0.1406p pd=1.12u as=0.2516p ps=2.16u w=0.74u l=0.13u
X226 a_13400_5105# a_13132_5420# a_13306_5105# VSS.t352 sg13_lv_nmos ad=60.89999f pd=0.71u as=0.1428p ps=1.52u w=0.42u l=0.13u
X227 a_5731_289# a_3171_311.t3 a_10430_1044# VSS.t638 sg13_lv_nmos ad=0.2516p pd=2.16u as=0.2516p ps=2.16u w=0.74u l=0.13u
X228 VDD.t101 a_21157_1842# a_21625_1044# VDD.t3 sg13_lv_pmos ad=0.252p pd=1.57u as=0.3808p ps=2.92u w=1.12u l=0.13u
X229 VDD.t308 DELAY_VBIASP.t25 a_10951_2470# VDD.t0 sg13_lv_pmos ad=0.3808p pd=2.92u as=0.2128p ps=1.5u w=1.12u l=0.6u
X230 VSS.t301 DELAY_VBIASN a_15511_1842# VSS.t300 sg13_lv_nmos ad=0.2516p pd=2.16u as=0.1406p ps=1.12u w=0.74u l=0.6u
X231 a_6326_4590# a_6326_4590# VDD.t10 VDD.t1 sg13_lv_pmos ad=0.38p pd=2.38u as=0.38p ps=2.38u w=2u l=1u
X232 VSS.t274 DELAY_VBIASN VSS.t268 VSS.t253 sg13_lv_nmos ad=1.33p pd=7.38u as=0 ps=0 w=7u l=7u
X233 VDD.t131 a_20723_1842# a_21157_1842# VDD.t0 sg13_lv_pmos ad=0.2128p pd=1.5u as=0.3808p ps=2.92u w=1.12u l=0.13u
X234 VSS.t403 a_25283_1842# a_25717_1842# VSS.t402 sg13_lv_nmos ad=0.1406p pd=1.12u as=0.2516p ps=2.16u w=0.74u l=0.13u
X235 a_4350_1044# a_3747_1047.t9 a_6635_1044# VSS.t524 sg13_lv_nmos ad=0.2516p pd=2.16u as=0.1406p ps=1.12u w=0.74u l=0.13u
X236 VSS.t287 DELAY_VBIASN a_5631_1842# VSS.t286 sg13_lv_nmos ad=0.2516p pd=2.16u as=0.1406p ps=1.12u w=0.74u l=0.6u
X237 VDD.t377 a_2019_1047.t9 a_4324_1008# VDD.t3 sg13_lv_pmos ad=0.3808p pd=2.92u as=0.3808p ps=2.92u w=1.12u l=0.13u
X238 a_12849_5867# a_12656_5864# VSS.t683 VSS.t682 sg13_lv_nmos ad=0.1406p pd=1.12u as=0.2516p ps=2.16u w=0.74u l=0.13u
X239 a_16510_1044# a_18871_1008# a_18795_1044# VDD.t3 sg13_lv_pmos ad=0.3808p pd=2.92u as=0.2128p ps=1.5u w=1.12u l=0.13u
X240 a_19550_1044# a_2595_1047.t4 a_20315_1044# VSS.t686 sg13_lv_nmos ad=0.2516p pd=2.16u as=0.1406p ps=1.12u w=0.74u l=0.13u
X241 VDD.t14 a_6326_4590# a_6126_3816# VDD.t1 sg13_lv_pmos ad=0.38p pd=2.38u as=0.38p ps=2.38u w=2u l=1u
X242 VDD.t42 a_11491_6228# a_11748_6109# VDD.t1 sg13_lv_pmos ad=1.10612p pd=6.66u as=79.8f ps=0.8u w=0.42u l=0.13u
X243 a_12355_5867# a_12158_5867# VDD.t72 VDD.t1 sg13_lv_pmos ad=0.3808p pd=2.92u as=0.2128p ps=1.5u w=1.12u l=0.13u
X244 VDD.t316 DELAY_VBIASP.t8 a_23871_2470# VDD.t0 sg13_lv_pmos ad=0.3808p pd=2.92u as=0.2128p ps=1.5u w=1.12u l=0.6u
X245 VSS.t66 a_7477_1842# a_7945_1044# VSS.t192 sg13_lv_nmos ad=0.1665p pd=1.19u as=0.2516p ps=2.16u w=0.74u l=0.13u
X246 a_11910_6305# DLL_RESETN VSS.t346 VSS.t158 sg13_lv_nmos ad=37.8f pd=0.6u as=79.8f ps=0.8u w=0.42u l=0.13u
X247 VSS.t264 DELAY_VBIASN VSS.t266 VSS.t265 sg13_lv_nmos ad=1.33p pd=7.38u as=0 ps=0 w=7u l=7u
X248 a_13231_2470# a_12993_1842# a_13123_1842# VDD.t0 sg13_lv_pmos ad=0.2128p pd=1.5u as=0.3808p ps=2.92u w=1.12u l=0.2u
X249 VDD.t184 VSS.t529 VDD.t183 VDD.t3 sg13_lv_pmos ad=0.34p pd=2.68u as=0 ps=0 w=1u l=1u
X250 a_6326_4590# a_6126_3816# a_5778_3367# VSS.t501 sg13_lv_nmos ad=0.38p pd=2.38u as=0.68p ps=4.68u w=2u l=1u
X251 a_12233_1842# a_12037_1842# VDD.t114 VDD.t0 sg13_lv_pmos ad=0.3808p pd=2.92u as=0.2128p ps=1.5u w=1.12u l=0.13u
X252 a_7911_1842# a_7673_1842# a_7803_1842# VSS.t232 sg13_lv_nmos ad=0.1406p pd=1.12u as=0.2516p ps=2.16u w=0.74u l=0.2u
X253 a_16793_1842# a_16597_1842# VSS.t45 VSS.t474 sg13_lv_nmos ad=0.2516p pd=2.16u as=0.1406p ps=1.12u w=0.74u l=0.13u
X254 VDD.t102 a_3747_311.t3 a_14825_519# VDD.t3 sg13_lv_pmos ad=0.3808p pd=2.92u as=0.3808p ps=2.92u w=1.12u l=0.13u
X255 VDD.t6 a_12849_5867# a_13306_6305# VDD.t1 sg13_lv_pmos ad=0.36237p pd=2.605u as=79.8f ps=0.8u w=0.42u l=0.13u
X256 VDD.t266 VDD.t258 VDD.t17 VDD.t1 sg13_lv_pmos ad=0.68p pd=4.68u as=0 ps=0 w=2u l=1u
X257 VSS.t151 a_27563_1842# a_27997_1842# VSS.t361 sg13_lv_nmos ad=0.1406p pd=1.12u as=0.2516p ps=2.16u w=0.74u l=0.13u
X258 a_9675_1044# a_9465_1044# VSS.t397 VSS.t513 sg13_lv_nmos ad=0.1406p pd=1.12u as=0.1665p ps=1.19u w=0.74u l=0.13u
X259 VDD.t10 a_6326_4590# a_6854_5986# VDD.t1 sg13_lv_pmos ad=0.38p pd=2.38u as=0.38p ps=2.38u w=2u l=1u
X260 a_20593_1842# a_20397_1842# VSS.t191 VSS.t235 sg13_lv_nmos ad=0.2516p pd=2.16u as=0.1406p ps=1.12u w=0.74u l=0.13u
X261 VSS.t391 a_2595_1047.t8 a_8231_1008# VSS.t390 sg13_lv_nmos ad=0.2516p pd=2.16u as=0.2516p ps=2.16u w=0.74u l=0.13u
X262 VSS.t458 a_6283_1842# a_6717_1842# VSS.t619 sg13_lv_nmos ad=0.1406p pd=1.12u as=0.2516p ps=2.16u w=0.74u l=0.13u
X263 a_10430_1044# a_10404_1008# a_10328_1044# VDD.t3 sg13_lv_pmos ad=0.3808p pd=2.92u as=0.2128p ps=1.5u w=1.12u l=0.13u
X264 VDD.t321 DELAY_VBIASP.t5 a_26151_2470# VDD.t0 sg13_lv_pmos ad=0.3808p pd=2.92u as=0.2128p ps=1.5u w=1.12u l=0.6u
X265 a_7390_1044# a_8884_1008# a_8808_1044# VDD.t3 sg13_lv_pmos ad=0.3808p pd=2.92u as=0.2128p ps=1.5u w=1.12u l=0.13u
X266 a_11491_6228# a_10649_5878# a_11397_6228# VSS.t158 sg13_lv_nmos ad=0.12665p pd=1.145u as=0.1428p ps=1.52u w=0.42u l=0.13u
X267 VDD.t295 DELAY_VBIASP.t33 a_4871_2470# VDD.t0 sg13_lv_pmos ad=0.3808p pd=2.92u as=0.2128p ps=1.5u w=1.12u l=0.6u
X268 a_6126_3816# a_6126_3816# VSS.t502 VSS.t501 sg13_lv_nmos ad=0.38p pd=2.38u as=0.68p ps=4.68u w=2u l=1u
X269 a_3449_331# MUX_SEL2 VDD.t135 VDD.t3 sg13_lv_pmos ad=0.1596p pd=1.22u as=0.2856p ps=2.36u w=0.84u l=0.13u
X270 VDD.t162 VSS.t587 VDD.t227 VDD.t3 sg13_lv_pmos ad=0.19p pd=1.38u as=0 ps=0 w=1u l=1u
X271 a_19073_1842# a_18877_1842# VSS.t401 VSS.t400 sg13_lv_nmos ad=0.2516p pd=2.16u as=0.1406p ps=1.12u w=0.74u l=0.13u
X272 VDD.t334 a_15077_1842# a_15545_1044# VDD.t3 sg13_lv_pmos ad=0.252p pd=1.57u as=0.3808p ps=2.92u w=1.12u l=0.13u
X273 a_19550_1044# a_2019_1047.t4 a_19448_1044# VSS.t431 sg13_lv_nmos ad=0.2516p pd=2.16u as=0.1406p ps=1.12u w=0.74u l=0.13u
X274 VDD.t2 a_12849_5867# a_13306_5105# VDD.t1 sg13_lv_pmos ad=0.36237p pd=2.605u as=79.8f ps=0.8u w=0.42u l=0.13u
X275 VDD.t287 VDD.t285 VDD.t286 VDD.t0 sg13_lv_pmos ad=0.3808p pd=2.92u as=0 ps=0 w=1.12u l=0.6u
X276 VSS.t612 VDD.t385 VSS.t610 VSS.t611 sg13_lv_nmos ad=79.8f pd=0.8u as=0 ps=0 w=0.42u l=1u
X277 a_13592_5871# a_13566_5835# VSS.t12 VSS.t11 sg13_lv_nmos ad=0.2516p pd=2.16u as=0.1626p ps=1.415u w=0.74u l=0.13u
X278 VSS.t35 a_19203_1842# a_19637_1842# VSS.t463 sg13_lv_nmos ad=0.1406p pd=1.12u as=0.2516p ps=2.16u w=0.74u l=0.13u
X279 VDD.t166 VSS.t582 VDD.t364 VDD.t3 sg13_lv_pmos ad=0.19p pd=1.38u as=0 ps=0 w=1u l=1u
X280 a_15108_6109# a_12849_5867# VDD.t42 VDD.t1 sg13_lv_pmos ad=79.8f pd=0.8u as=1.03698p ps=6.245u w=0.42u l=0.13u
X281 VDD.t208 VSS.t554 VDD.t165 VDD.t3 sg13_lv_pmos ad=0.34p pd=2.68u as=0 ps=0 w=1u l=1u
X282 VSS.t159 a_15108_6109# a_14757_6228# VSS.t17 sg13_lv_nmos ad=79.8f pd=0.8u as=0.1428p ps=1.52u w=0.42u l=0.13u
X283 a_27433_1842# a_27237_1842# VDD.t97 VDD.t0 sg13_lv_pmos ad=0.3808p pd=2.92u as=0.2128p ps=1.5u w=1.12u l=0.13u
X284 VDD.t359 a_1256_289# a_2873_331# VDD.t3 sg13_lv_pmos ad=0.1918p pd=1.5u as=0.1596p ps=1.22u w=0.84u l=0.13u
X285 a_13470_1044# a_2595_1047.t6 a_14235_1044# VSS.t49 sg13_lv_nmos ad=0.2516p pd=2.16u as=0.1406p ps=1.12u w=0.74u l=0.13u
X286 VSS.t179 a_9444_4590# a_9444_4590# VSS.t174 sg13_lv_nmos ad=0.68p pd=4.68u as=0.38p ps=2.38u w=2u l=1u
X287 VSS.t188 a_8563_1842# a_8997_1842# VSS.t187 sg13_lv_nmos ad=0.1406p pd=1.12u as=0.2516p ps=2.16u w=0.74u l=0.13u
X288 VSS.t109 VSS.t109 VSS.t111 VSS.t110 sg13_lv_nmos ad=0.2516p pd=2.16u as=0 ps=0 w=0.74u l=0.13u
X289 VSS.t317 DELAY_VBIASN a_13231_1842# VSS.t316 sg13_lv_nmos ad=0.2516p pd=2.16u as=0.1406p ps=1.12u w=0.74u l=0.6u
X290 VDD.t202 a_3171_1047.t7 a_11924_1008# VDD.t3 sg13_lv_pmos ad=0.3808p pd=2.92u as=0.3808p ps=2.92u w=1.12u l=0.13u
X291 VSS.t442 a_2019_1047.t3 a_22564_1008# VSS.t441 sg13_lv_nmos ad=0.2516p pd=2.16u as=0.2516p ps=2.16u w=0.74u l=0.13u
X292 a_15053_5420# a_14111_5227# a_14851_5182# VDD.t1 sg13_lv_pmos ad=93.45f pd=0.865u as=0.2048p ps=1.63u w=0.42u l=0.13u
X293 VSS.t108 VSS.t105 VSS.t105 VSS.t106 sg13_lv_nmos ad=0.1406p pd=1.12u as=0 ps=0 w=0.74u l=0.13u
X294 VSS.t227 a_23003_1842# a_23437_1842# VSS.t492 sg13_lv_nmos ad=0.1406p pd=1.12u as=0.2516p ps=2.16u w=0.74u l=0.13u
X295 VSS.t615 VDD.t384 VSS.t614 VSS.t613 sg13_lv_nmos ad=0.1428p pd=1.52u as=0 ps=0 w=0.42u l=1u
X296 VDD.t299 DELAY_VBIASP.t30 a_7151_2470# VDD.t0 sg13_lv_pmos ad=0.3808p pd=2.92u as=0.2128p ps=1.5u w=1.12u l=0.6u
X297 a_5778_3367# VSS.t2 VSS.t1 rppd l=32u w=1u
X298 a_25630_1044# a_25604_1008# a_25528_1044# VDD.t3 sg13_lv_pmos ad=0.3808p pd=2.92u as=0.2128p ps=1.5u w=1.12u l=0.13u
X299 a_10206_5835# a_10649_5878# a_10589_5914# VDD.t1 sg13_lv_pmos ad=79.8f pd=0.8u as=63f ps=0.72u w=0.42u l=0.13u
X300 a_15511_1842# a_15273_1842# a_15403_1842# VSS.t485 sg13_lv_nmos ad=0.1406p pd=1.12u as=0.2516p ps=2.16u w=0.74u l=0.2u
X301 a_10520_6292# a_10751_5878# a_10206_5835# VSS.t671 sg13_lv_nmos ad=0.2373p pd=1.97u as=79.8f ps=0.8u w=0.42u l=0.13u
X302 a_11693_5990# a_10751_5878# a_11491_6228# VDD.t1 sg13_lv_pmos ad=93.45f pd=0.865u as=0.2048p ps=1.63u w=0.42u l=0.13u
X303 a_18313_1842# a_18117_1842# VDD.t65 VDD.t0 sg13_lv_pmos ad=0.3808p pd=2.92u as=0.2128p ps=1.5u w=1.12u l=0.13u
X304 a_5731_289# a_11785_519# a_10430_1044# VDD.t3 sg13_lv_pmos ad=0.3808p pd=2.92u as=0.3808p ps=2.92u w=1.12u l=0.13u
X305 VSS.t532 VDD.t401 VSS.t530 VSS.t531 sg13_lv_nmos ad=79.8f pd=0.8u as=0 ps=0 w=0.42u l=1u
X306 a_9431_2470# a_9193_1842# a_9323_1842# VDD.t0 sg13_lv_pmos ad=0.2128p pd=1.5u as=0.3808p ps=2.92u w=1.12u l=0.2u
X307 a_17275_1044# a_17065_1044# VSS.t139 VSS.t138 sg13_lv_nmos ad=0.1406p pd=1.12u as=0.1665p ps=1.19u w=0.74u l=0.13u
X308 VDD.t94 VSS.t589 VDD.t140 VDD.t3 sg13_lv_pmos ad=0.34p pd=2.68u as=0 ps=0 w=1u l=1u
X309 VSS.t413 a_3747_1047.t6 a_15831_1008# VSS.t412 sg13_lv_nmos ad=0.2516p pd=2.16u as=0.2516p ps=2.16u w=0.74u l=0.13u
X310 a_23871_2470# a_23633_1842# a_23763_1842# VDD.t0 sg13_lv_pmos ad=0.2128p pd=1.5u as=0.3808p ps=2.92u w=1.12u l=0.2u
X311 VSS.t81 a_13883_1842# a_14317_1842# VSS.t80 sg13_lv_nmos ad=0.1406p pd=1.12u as=0.2516p ps=2.16u w=0.74u l=0.13u
X312 VSS.t643 a_3747_311.t2 a_26985_519# VSS.t642 sg13_lv_nmos ad=0.2516p pd=2.16u as=0.2516p ps=2.16u w=0.74u l=0.13u
X313 a_8433_1842# a_8237_1842# VDD.t69 VDD.t0 sg13_lv_pmos ad=0.3808p pd=2.92u as=0.2128p ps=1.5u w=1.12u l=0.13u
X314 VDD.t175 a_18443_1842# a_18877_1842# VDD.t0 sg13_lv_pmos ad=0.2128p pd=1.5u as=0.3808p ps=2.92u w=1.12u l=0.13u
X315 a_22113_1842# a_21917_1842# VDD.t7 VDD.t0 sg13_lv_pmos ad=0.3808p pd=2.92u as=0.2128p ps=1.5u w=1.12u l=0.13u
X316 a_4350_1044# a_2019_1047.t9 a_4248_1044# VSS.t707 sg13_lv_nmos ad=0.2516p pd=2.16u as=0.1406p ps=1.12u w=0.74u l=0.13u
X317 a_14888_1044# a_14317_1842# VSS.t426 VSS.t425 sg13_lv_nmos ad=0.1406p pd=1.12u as=0.2516p ps=2.16u w=0.74u l=0.13u
X318 a_13880_5118# a_13592_5423# a_13818_5118# VSS.t189 sg13_lv_nmos ad=0.1428p pd=1.52u as=37.8f ps=0.6u w=0.42u l=0.13u
X319 a_16108_289# a_3747_311.t2 a_25630_1044# VSS.t641 sg13_lv_nmos ad=0.2516p pd=2.16u as=0.2516p ps=2.16u w=0.74u l=0.13u
X320 VDD.t302 DELAY_VBIASP.t23 a_12471_2470# VDD.t0 sg13_lv_pmos ad=0.3808p pd=2.92u as=0.2128p ps=1.5u w=1.12u l=0.6u
X321 VSS.t75 a_4003_1842# a_4437_1842# VSS.t241 sg13_lv_nmos ad=0.1406p pd=1.12u as=0.2516p ps=2.16u w=0.74u l=0.13u
X322 a_16510_1044# a_16484_1008# a_16408_1044# VDD.t3 sg13_lv_pmos ad=0.3808p pd=2.92u as=0.2128p ps=1.5u w=1.12u l=0.13u
X323 VSS.t91 a_13121_5831# a_13045_6215# VSS.t90 sg13_lv_nmos ad=0.2516p pd=2.16u as=0.1406p ps=1.12u w=0.74u l=0.13u
X324 VDD.t360 a_14851_5182# a_15688_5403# VDD.t1 sg13_lv_pmos ad=0.2128p pd=1.5u as=0.3864p ps=2.93u w=1.12u l=0.13u
X325 VDD.t126 a_22243_1842# a_22677_1842# VDD.t0 sg13_lv_pmos ad=0.2128p pd=1.5u as=0.3808p ps=2.92u w=1.12u l=0.13u
X326 VDD.t35 a_3171_1047.t2 a_27124_1008# VDD.t3 sg13_lv_pmos ad=0.3808p pd=2.92u as=0.3808p ps=2.92u w=1.12u l=0.13u
X327 VDD.t225 MUX_SEL3 a_3449_331# VDD.t3 sg13_lv_pmos ad=0.1918p pd=1.5u as=0.1596p ps=1.22u w=0.84u l=0.13u
X328 a_2595_311.t1 a_2297_331# VDD.t30 VDD.t3 sg13_lv_pmos ad=0.2128p pd=1.5u as=0.1918p ps=1.5u w=1.12u l=0.13u
X329 a_10430_1044# a_11271_1008# a_11195_1044# VDD.t3 sg13_lv_pmos ad=0.3808p pd=2.92u as=0.2128p ps=1.5u w=1.12u l=0.13u
X330 a_14009_5084# DELAY_OUT_LAST VSS.t58 VSS.t164 sg13_lv_nmos ad=0.2516p pd=2.16u as=1.45407p ps=9.445u w=0.74u l=0.13u
X331 a_23355_1044# a_23145_1044# VDD.t96 VDD.t3 sg13_lv_pmos ad=0.2128p pd=1.5u as=0.252p ps=1.57u w=1.12u l=0.13u
X332 VDD.t365 a_3747_1047.t4 a_21911_1008# VDD.t3 sg13_lv_pmos ad=0.3808p pd=2.92u as=0.3808p ps=2.92u w=1.12u l=0.13u
X333 VSS.t397 a_8997_1842# a_9465_1044# VSS.t396 sg13_lv_nmos ad=0.1665p pd=1.19u as=0.2516p ps=2.16u w=0.74u l=0.13u
X334 a_13592_5423# a_13566_5328# VDD.t2 VDD.t1 sg13_lv_pmos ad=0.34p pd=2.68u as=0.36237p ps=2.605u w=1u l=0.13u
X335 a_6126_3816# a_5974_5723# a_6326_4590# VSS.t504 sg13_lv_nmos ad=0.68p pd=4.68u as=0.38p ps=2.38u w=2u l=1u
X336 a_20968_1044# a_20397_1842# VDD.t115 VDD.t3 sg13_lv_pmos ad=0.2128p pd=1.5u as=0.3808p ps=2.92u w=1.12u l=0.13u
X337 a_10951_1842# a_10713_1842# a_10843_1842# VSS.t696 sg13_lv_nmos ad=0.1406p pd=1.12u as=0.2516p ps=2.16u w=0.74u l=0.2u
X338 VSS.t448 a_2019_1047.t5 a_16484_1008# VSS.t447 sg13_lv_nmos ad=0.2516p pd=2.16u as=0.2516p ps=2.16u w=0.74u l=0.13u
X339 a_26151_2470# a_25913_1842# a_26043_1842# VDD.t0 sg13_lv_pmos ad=0.2128p pd=1.5u as=0.3808p ps=2.92u w=1.12u l=0.2u
X340 a_9444_4590# a_6854_5454# a_6854_5454# VSS.t681 sg13_lv_nmos ad=0.68p pd=4.68u as=0.38p ps=2.38u w=2u l=1u
X341 a_13753_1842# a_13557_1842# VDD.t67 VDD.t0 sg13_lv_pmos ad=0.3808p pd=2.92u as=0.2128p ps=1.5u w=1.12u l=0.13u
X342 VDD.t249 a_1721_331# a_2019_311.t1 VDD.t3 sg13_lv_pmos ad=0.4256p pd=3u as=0.2128p ps=1.5u w=1.12u l=0.13u
X343 a_4871_2470# a_4633_1842# a_4763_1842# VDD.t0 sg13_lv_pmos ad=0.2128p pd=1.5u as=0.3808p ps=2.92u w=1.12u l=0.2u
X344 VSS.t167 a_3171_1047.t9 a_5844_1008# VSS.t166 sg13_lv_nmos ad=0.2516p pd=2.16u as=0.2516p ps=2.16u w=0.74u l=0.13u
X345 VSS.t572 VDD.t393 VSS.t570 VSS.t571 sg13_lv_nmos ad=79.8f pd=0.8u as=0 ps=0 w=0.42u l=1u
X346 VDD.t219 a_2595_311.t2 a_20905_519# VDD.t3 sg13_lv_pmos ad=0.3808p pd=2.92u as=0.3808p ps=2.92u w=1.12u l=0.13u
X347 VDD.t155 a_2297_331# a_2595_311.t1 VDD.t3 sg13_lv_pmos ad=0.4256p pd=3u as=0.2128p ps=1.5u w=1.12u l=0.13u
X348 a_14009_5084# DELAY_OUT_LAST VDD.t42 VDD.t1 sg13_lv_pmos ad=0.4088p pd=2.97u as=1.10612p ps=6.66u w=1.12u l=0.13u
X349 VSS.t394 a_2595_1047.t7 a_11271_1008# VSS.t393 sg13_lv_nmos ad=0.2516p pd=2.16u as=0.2516p ps=2.16u w=0.74u l=0.13u
X350 VSS.t319 DELAY_VBIASN a_19311_1842# VSS.t318 sg13_lv_nmos ad=0.2516p pd=2.16u as=0.1406p ps=1.12u w=0.74u l=0.6u
X351 VSS.t175 a_9444_4590# a_9444_3912# VSS.t174 sg13_lv_nmos ad=0.68p pd=4.68u as=0.38p ps=2.38u w=2u l=1u
X352 a_13880_5118# a_14111_5227# a_13566_5328# VSS.t38 sg13_lv_nmos ad=0.2373p pd=1.97u as=79.8f ps=0.8u w=0.42u l=0.13u
X353 VDD.t338 a_24523_1842# a_24957_1842# VDD.t0 sg13_lv_pmos ad=0.2128p pd=1.5u as=0.3808p ps=2.92u w=1.12u l=0.13u
X354 VSS.t488 a_3747_1047.t8 a_9751_1008# VSS.t487 sg13_lv_nmos ad=0.2516p pd=2.16u as=0.2516p ps=2.16u w=0.74u l=0.13u
X355 VSS.t309 DELAY_VBIASN a_9431_1842# VSS.t308 sg13_lv_nmos ad=0.2516p pd=2.16u as=0.1406p ps=1.12u w=0.74u l=0.6u
X356 a_19448_1044# a_18877_1842# VDD.t174 VDD.t3 sg13_lv_pmos ad=0.2128p pd=1.5u as=0.3808p ps=2.92u w=1.12u l=0.13u
X357 VSS.t155 a_11491_6228# a_12158_5867# VSS.t384 sg13_lv_nmos ad=0.1406p pd=1.12u as=0.2516p ps=2.16u w=0.74u l=0.13u
X358 a_13566_5328# a_14009_5084# a_13949_5496# VDD.t1 sg13_lv_pmos ad=79.8f pd=0.8u as=63f ps=0.72u w=0.42u l=0.13u
X359 VSS.t331 DELAY_VBIASN a_23111_1842# VSS.t330 sg13_lv_nmos ad=0.2516p pd=2.16u as=0.1406p ps=1.12u w=0.74u l=0.6u
X360 a_10430_1044# a_11924_1008# a_11848_1044# VDD.t3 sg13_lv_pmos ad=0.3808p pd=2.92u as=0.2128p ps=1.5u w=1.12u l=0.13u
X361 VDD.t323 DELAY_VBIASP.t3 a_27671_2470# VDD.t0 sg13_lv_pmos ad=0.3808p pd=2.92u as=0.2128p ps=1.5u w=1.12u l=0.6u
X362 a_6854_5986# a_6326_4590# VDD.t9 VDD.t1 sg13_lv_pmos ad=0.38p pd=2.38u as=0.38p ps=2.38u w=2u l=1u
X363 VSS.t272 DELAY_VBIASN DELAY_VBIASP.t0 VSS.t271 sg13_lv_nmos ad=0.2516p pd=2.16u as=0.6808p ps=3.32u w=0.74u l=0.6u
X364 a_25630_1044# a_26471_1008# a_26395_1044# VDD.t3 sg13_lv_pmos ad=0.3808p pd=2.92u as=0.2128p ps=1.5u w=1.12u l=0.13u
X365 VSS.t254 DELAY_VBIASN VSS.t256 VSS.t255 sg13_lv_nmos ad=1.33p pd=7.38u as=0 ps=0 w=7u l=7u
X366 a_10040_6305# a_9772_5843# a_9946_6305# VSS.t527 sg13_lv_nmos ad=60.89999f pd=0.71u as=0.1428p ps=1.52u w=0.42u l=0.13u
X367 a_7151_2470# a_6913_1842# a_7043_1842# VDD.t0 sg13_lv_pmos ad=0.2128p pd=1.5u as=0.3808p ps=2.92u w=1.12u l=0.2u
X368 a_16033_1842# a_15837_1842# VDD.t214 VDD.t0 sg13_lv_pmos ad=0.3808p pd=2.92u as=0.2128p ps=1.5u w=1.12u l=0.13u
X369 VDD.t12 a_6326_4590# a_6326_4590# VDD.t1 sg13_lv_pmos ad=0.38p pd=2.38u as=0.38p ps=2.38u w=2u l=1u
X370 VDD.t79 a_15964_289# a_16851_309# VDD.t3 sg13_lv_pmos ad=0.2086p pd=1.5u as=0.34p ps=2.68u w=1u l=0.13u
X371 VDD.t163 VSS.t584 VDD.t162 VDD.t3 sg13_lv_pmos ad=0.34p pd=2.68u as=0 ps=0 w=1u l=1u
X372 a_15464_3684# a_14851_5182# VSS.t388 VSS.t704 sg13_lv_nmos ad=0.2849p pd=2.25u as=0.2516p ps=2.16u w=0.74u l=0.13u
X373 VSS.t231 a_11603_1842# a_12037_1842# VSS.t230 sg13_lv_nmos ad=0.1406p pd=1.12u as=0.2516p ps=2.16u w=0.74u l=0.13u
X374 VSS.t592 VDD.t389 VSS.t590 VSS.t591 sg13_lv_nmos ad=79.8f pd=0.8u as=0 ps=0 w=0.42u l=1u
X375 VDD.t169 VSS.t549 VDD.t168 VDD.t3 sg13_lv_pmos ad=0.34p pd=2.68u as=0 ps=0 w=1u l=1u
X376 VDD.t55 a_5957_1842# a_6425_1044# VDD.t3 sg13_lv_pmos ad=0.252p pd=1.57u as=0.3808p ps=2.92u w=1.12u l=0.13u
X377 a_24393_1842# a_24197_1842# VSS.t419 VSS.t418 sg13_lv_nmos ad=0.2516p pd=2.16u as=0.1406p ps=1.12u w=0.74u l=0.13u
X378 a_3747_1047.t0 a_3449_1395# VSS.t69 VSS.t68 sg13_lv_nmos ad=0.1406p pd=1.12u as=0.1331p ps=1.12u w=0.74u l=0.13u
X379 a_1544_1044# MUX_SEL1 VSS.t77 VSS.t76 sg13_lv_nmos ad=0.2516p pd=2.16u as=0.2516p ps=2.16u w=0.74u l=0.13u
X380 VDD.t167 VSS.t579 VDD.t166 VDD.t3 sg13_lv_pmos ad=0.34p pd=2.68u as=0 ps=0 w=1u l=1u
X381 a_3171_1047.t1 a_2873_1395# VDD.t137 VDD.t3 sg13_lv_pmos ad=0.2128p pd=1.5u as=0.1918p ps=1.5u w=1.12u l=0.13u
X382 a_13470_1044# a_3747_1047.t6 a_15755_1044# VSS.t411 sg13_lv_nmos ad=0.2516p pd=2.16u as=0.1406p ps=1.12u w=0.74u l=0.13u
X383 VDD.t216 a_15464_3684# a_9712_3912# VSS.t464 sg13_lv_nmos ad=0.232p pd=2.08u as=0.136p ps=1.14u w=0.4u l=0.2u
X384 VDD.t54 a_5523_1842# a_5957_1842# VDD.t0 sg13_lv_pmos ad=0.2128p pd=1.5u as=0.3808p ps=2.92u w=1.12u l=0.13u
X385 VDD.t229 a_2297_1395# a_2595_1047.t1 VDD.t3 sg13_lv_pmos ad=0.4256p pd=3u as=0.2128p ps=1.5u w=1.12u l=0.13u
X386 VSS.t311 DELAY_VBIASN a_14751_1842# VSS.t310 sg13_lv_nmos ad=0.2516p pd=2.16u as=0.1406p ps=1.12u w=0.74u l=0.6u
X387 a_2967_1395# MUX_SEL1 a_2873_1395# VSS.t78 sg13_lv_nmos ad=0.1216p pd=1.02u as=0.2176p ps=1.96u w=0.64u l=0.13u
X388 a_4350_1044# a_2595_1047.t9 a_5115_1044# VSS.t421 sg13_lv_nmos ad=0.2516p pd=2.16u as=0.1406p ps=1.12u w=0.74u l=0.13u
X389 VDD.t198 a_2019_1047.t6 a_13444_1008# VDD.t3 sg13_lv_pmos ad=0.3808p pd=2.92u as=0.3808p ps=2.92u w=1.12u l=0.13u
X390 VSS.t430 a_2595_1047.t2 a_26471_1008# VSS.t429 sg13_lv_nmos ad=0.2516p pd=2.16u as=0.2516p ps=2.16u w=0.74u l=0.13u
X391 a_2595_311.t0 a_2297_331# VSS.t30 VSS.t381 sg13_lv_nmos ad=0.1406p pd=1.12u as=0.1331p ps=1.12u w=0.74u l=0.13u
X392 VSS.t133 a_14009_5878# a_14111_5878# VSS.t229 sg13_lv_nmos ad=2.39977p pd=15.495u as=0.2516p ps=2.16u w=0.74u l=0.13u
X393 VSS.t303 DELAY_VBIASN a_4111_1842# VSS.t302 sg13_lv_nmos ad=0.2516p pd=2.16u as=0.1406p ps=1.12u w=0.74u l=0.6u
X394 a_2297_1395# MUX_SEL0 VDD.t327 VDD.t3 sg13_lv_pmos ad=0.1596p pd=1.22u as=0.2856p ps=2.36u w=0.84u l=0.13u
X395 VSS.t139 a_16597_1842# a_17065_1044# VSS.t475 sg13_lv_nmos ad=0.1665p pd=1.19u as=0.2516p ps=2.16u w=0.74u l=0.13u
X396 VDD.t300 DELAY_VBIASP.t28 a_8671_2470# VDD.t0 sg13_lv_pmos ad=0.3808p pd=2.92u as=0.2128p ps=1.5u w=1.12u l=0.6u
X397 VDD.t142 VSS.t547 VDD.t353 VDD.t3 sg13_lv_pmos ad=0.19p pd=1.38u as=0 ps=0 w=1u l=1u
X398 VDD.t130 a_1544_1044# a_1721_1395# VDD.t3 sg13_lv_pmos ad=0.1918p pd=1.5u as=0.1596p ps=1.22u w=0.84u l=0.13u
X399 a_9444_4590# a_9444_4590# VSS.t177 VSS.t172 sg13_lv_nmos ad=0.38p pd=2.38u as=0.68p ps=4.68u w=2u l=1u
X400 a_4248_1044# a_4157_1313# VDD.t146 VDD.t3 sg13_lv_pmos ad=0.2128p pd=1.5u as=0.3808p ps=2.92u w=1.12u l=0.13u
X401 a_5778_3367# a_6126_3816# a_6326_4590# VSS.t501 sg13_lv_nmos ad=0.68p pd=4.68u as=0.38p ps=2.38u w=2u l=1u
X402 a_12471_2470# a_12233_1842# a_12363_1842# VDD.t0 sg13_lv_pmos ad=0.2128p pd=1.5u as=0.3808p ps=2.92u w=1.12u l=0.2u
X403 a_17031_1842# a_16793_1842# a_16923_1842# VSS.t43 sg13_lv_nmos ad=0.1406p pd=1.12u as=0.2516p ps=2.16u w=0.74u l=0.2u
X404 VSS.t523 a_1721_331# a_2019_311.t0 VSS.t522 sg13_lv_nmos ad=0.2812p pd=2.24u as=0.1406p ps=1.12u w=0.74u l=0.13u
X405 a_19550_1044# a_21911_1008# a_21835_1044# VDD.t3 sg13_lv_pmos ad=0.3808p pd=2.92u as=0.2128p ps=1.5u w=1.12u l=0.13u
X406 a_16108_289# a_26985_519# a_25630_1044# VDD.t3 sg13_lv_pmos ad=0.3808p pd=2.92u as=0.3808p ps=2.92u w=1.12u l=0.13u
X407 VSS.t383 a_2297_331# a_2595_311.t0 VSS.t382 sg13_lv_nmos ad=0.2812p pd=2.24u as=0.1406p ps=1.12u w=0.74u l=0.13u
X408 a_18795_1044# a_18585_1044# VSS.t143 VSS.t489 sg13_lv_nmos ad=0.1406p pd=1.12u as=0.1665p ps=1.19u w=0.74u l=0.13u
X409 a_9444_3912# a_6854_5454# a_9712_3912# VSS.t681 sg13_lv_nmos ad=0.68p pd=4.68u as=0.38p ps=2.38u w=2u l=1u
X410 a_20831_1842# a_20593_1842# a_20723_1842# VSS.t695 sg13_lv_nmos ad=0.1406p pd=1.12u as=0.2516p ps=2.16u w=0.74u l=0.2u
X411 VSS.t530 VDD.t401 VSS.t529 VSS.t528 sg13_lv_nmos ad=0.1428p pd=1.52u as=0 ps=0 w=0.42u l=1u
X412 VDD.t96 a_22677_1842# a_23145_1044# VDD.t3 sg13_lv_pmos ad=0.252p pd=1.57u as=0.3808p ps=2.92u w=1.12u l=0.13u
X413 VSS.t410 a_2595_1047.t5 a_17351_1008# VSS.t409 sg13_lv_nmos ad=0.2516p pd=2.16u as=0.2516p ps=2.16u w=0.74u l=0.13u
X414 a_5393_1842# a_5197_1842# VSS.t466 VSS.t655 sg13_lv_nmos ad=0.2516p pd=2.16u as=0.1406p ps=1.12u w=0.74u l=0.13u
X415 VSS.t295 DELAY_VBIASN a_17031_1842# VSS.t294 sg13_lv_nmos ad=0.2516p pd=2.16u as=0.1406p ps=1.12u w=0.74u l=0.6u
X416 a_25630_1044# a_3171_1047.t2 a_27048_1044# VSS.t40 sg13_lv_nmos ad=0.2516p pd=2.16u as=0.1406p ps=1.12u w=0.74u l=0.13u
X417 VDD.t271 VDD.t269 VDD.t270 VDD.t58 sg13_lv_pmos ad=0.3808p pd=2.92u as=0 ps=0 w=1.12u l=0.13u
X418 a_9953_1842# a_9757_1842# VDD.t60 VDD.t0 sg13_lv_pmos ad=0.3808p pd=2.92u as=0.2128p ps=1.5u w=1.12u l=0.13u
X419 VDD.t43 a_10843_1842# a_11277_1842# VDD.t0 sg13_lv_pmos ad=0.2128p pd=1.5u as=0.3808p ps=2.92u w=1.12u l=0.13u
X420 VSS.t202 a_26803_1842# a_27237_1842# VSS.t374 sg13_lv_nmos ad=0.1406p pd=1.12u as=0.2516p ps=2.16u w=0.74u l=0.13u
X421 a_4350_1044# a_3171_1047.t9 a_5768_1044# VSS.t165 sg13_lv_nmos ad=0.2516p pd=2.16u as=0.1406p ps=1.12u w=0.74u l=0.13u
X422 VDD.t85 a_12849_5867# a_13566_5328# VDD.t1 sg13_lv_pmos ad=0.1563p pd=1.22u as=0.147p ps=1.54u w=0.42u l=0.13u
X423 VDD.t276 VDD.t277 VDD.t278 VDD.t58 sg13_lv_pmos ad=0.2128p pd=1.5u as=0 ps=0 w=1.12u l=0.13u
X424 a_10430_1044# a_12791_1008# a_12715_1044# VDD.t3 sg13_lv_pmos ad=0.3808p pd=2.92u as=0.2128p ps=1.5u w=1.12u l=0.13u
X425 a_19311_1842# a_19073_1842# a_19203_1842# VSS.t427 sg13_lv_nmos ad=0.1406p pd=1.12u as=0.2516p ps=2.16u w=0.74u l=0.2u
X426 a_24875_1044# a_24665_1044# VDD.t158 VDD.t3 sg13_lv_pmos ad=0.2128p pd=1.5u as=0.252p ps=1.57u w=1.12u l=0.13u
X427 VDD.t39 a_2595_1047.t3 a_23431_1008# VDD.t3 sg13_lv_pmos ad=0.3808p pd=2.92u as=0.3808p ps=2.92u w=1.12u l=0.13u
X428 VDD.t42 a_14009_5878# a_14111_5878# VDD.t1 sg13_lv_pmos ad=1.10612p pd=6.66u as=0.3864p ps=2.93u w=1.12u l=0.13u
X429 a_13949_5914# a_13592_5871# VDD.t324 VDD.t1 sg13_lv_pmos ad=63f pd=0.72u as=0.1563p ps=1.22u w=0.42u l=0.13u
X430 VDD.t103 a_13557_1842# a_14025_1044# VDD.t3 sg13_lv_pmos ad=0.252p pd=1.57u as=0.3808p ps=2.92u w=1.12u l=0.13u
X431 a_23111_1842# a_22873_1842# a_23003_1842# VSS.t711 sg13_lv_nmos ad=0.1406p pd=1.12u as=0.2516p ps=2.16u w=0.74u l=0.2u
X432 VSS.t131 a_10649_5878# a_10751_5878# VSS.t157 sg13_lv_nmos ad=2.39977p pd=15.495u as=0.2516p ps=2.16u w=0.74u l=0.13u
X433 a_27671_2470# a_27433_1842# a_27563_1842# VDD.t0 sg13_lv_pmos ad=0.2128p pd=1.5u as=0.3808p ps=2.92u w=1.12u l=0.2u
X434 VSS.t141 a_17683_1842# a_18117_1842# VSS.t637 sg13_lv_nmos ad=0.1406p pd=1.12u as=0.2516p ps=2.16u w=0.74u l=0.13u
X435 VSS.t587 VDD.t390 VSS.t585 VSS.t586 sg13_lv_nmos ad=79.8f pd=0.8u as=0 ps=0 w=0.42u l=1u
X436 a_10713_1842# a_10517_1842# VSS.t468 VSS.t491 sg13_lv_nmos ad=0.2516p pd=2.16u as=0.1406p ps=1.12u w=0.74u l=0.13u
X437 VSS.t196 a_2019_1047.t8 a_7364_1008# VSS.t195 sg13_lv_nmos ad=0.2516p pd=2.16u as=0.2516p ps=2.16u w=0.74u l=0.13u
X438 VSS.t281 DELAY_VBIASN VSS.t270 VSS.t263 sg13_lv_nmos ad=1.33p pd=7.38u as=0 ps=0 w=7u l=7u
X439 VSS.t149 a_7803_1842# a_8237_1842# VSS.t519 sg13_lv_nmos ad=0.1406p pd=1.12u as=0.2516p ps=2.16u w=0.74u l=0.13u
X440 a_13592_5871# a_14111_5878# a_14851_6228# VSS.t17 sg13_lv_nmos ad=0.3473p pd=2.71u as=0.12665p ps=1.145u w=0.74u l=0.13u
X441 a_15304_4605# a_14851_6228# VSS.t19 VSS.t18 sg13_lv_nmos ad=0.2849p pd=2.25u as=0.2516p ps=2.16u w=0.74u l=0.13u
X442 VDD.t301 DELAY_VBIASP.t18 a_16271_2470# VDD.t0 sg13_lv_pmos ad=0.3808p pd=2.92u as=0.2128p ps=1.5u w=1.12u l=0.6u
X443 VSS.t582 VDD.t391 VSS.t580 VSS.t581 sg13_lv_nmos ad=79.8f pd=0.8u as=0 ps=0 w=0.42u l=1u
X444 VSS.t555 VDD.t396 VSS.t554 VSS.t553 sg13_lv_nmos ad=0.1428p pd=1.52u as=0 ps=0 w=0.42u l=1u
X445 a_6854_5454# a_6854_5454# a_9444_4590# VSS.t680 sg13_lv_nmos ad=0.38p pd=2.38u as=0.68p ps=4.68u w=2u l=1u
X446 VDD.t150 a_26043_1842# a_26477_1842# VDD.t0 sg13_lv_pmos ad=0.2128p pd=1.5u as=0.3808p ps=2.92u w=1.12u l=0.13u
X447 VDD.t122 DLL_RESETN a_10206_5835# VDD.t1 sg13_lv_pmos ad=0.1563p pd=1.22u as=0.147p ps=1.54u w=0.42u l=0.13u
X448 a_3543_331# MUX_SEL2 a_3449_331# VSS.t365 sg13_lv_nmos ad=0.1216p pd=1.02u as=0.2176p ps=1.96u w=0.64u l=0.13u
X449 a_22488_1044# a_21917_1842# VSS.t16 VSS.t15 sg13_lv_nmos ad=0.1406p pd=1.12u as=0.2516p ps=2.16u w=0.74u l=0.13u
X450 a_14851_5182# a_14009_5084# a_13592_5423# VDD.t1 sg13_lv_pmos ad=0.2048p pd=1.63u as=0.34p ps=2.68u w=1u l=0.13u
X451 VDD.t171 VSS.t542 VDD.t170 VDD.t3 sg13_lv_pmos ad=0.19p pd=1.38u as=0 ps=0 w=1u l=1u
X452 a_22590_1044# a_24084_1008# a_24008_1044# VDD.t3 sg13_lv_pmos ad=0.3808p pd=2.92u as=0.2128p ps=1.5u w=1.12u l=0.13u
X453 VDD.t313 DELAY_VBIASP.t13 a_20071_2470# VDD.t0 sg13_lv_pmos ad=0.3808p pd=2.92u as=0.2128p ps=1.5u w=1.12u l=0.6u
X454 a_9444_3912# a_9444_4590# VSS.t173 VSS.t172 sg13_lv_nmos ad=0.38p pd=2.38u as=0.68p ps=4.68u w=2u l=1u
X455 a_14751_1842# a_14513_1842# a_14643_1842# VSS.t199 sg13_lv_nmos ad=0.1406p pd=1.12u as=0.2516p ps=2.16u w=0.74u l=0.2u
X456 VSS.t407 a_2873_1395# a_3171_1047.t0 VSS.t406 sg13_lv_nmos ad=0.2812p pd=2.24u as=0.1406p ps=1.12u w=0.74u l=0.13u
X457 VDD.t204 VSS.t607 VDD.t220 VDD.t3 sg13_lv_pmos ad=0.19p pd=1.38u as=0 ps=0 w=1u l=1u
X458 a_25630_1044# a_27991_1008# a_27915_1044# VDD.t3 sg13_lv_pmos ad=0.3808p pd=2.92u as=0.2128p ps=1.5u w=1.12u l=0.13u
X459 VSS.t117 VSS.t117 VSS.t119 VSS.t118 sg13_lv_nmos ad=0.1406p pd=1.12u as=0 ps=0 w=0.74u l=0.13u
X460 a_4111_1842# REF_CLK a_4003_1842# VSS.t134 sg13_lv_nmos ad=0.1406p pd=1.12u as=0.2516p ps=2.16u w=0.74u l=0.2u
X461 a_8671_2470# a_8433_1842# a_8563_1842# VDD.t0 sg13_lv_pmos ad=0.2128p pd=1.5u as=0.3808p ps=2.92u w=1.12u l=0.2u
X462 a_17553_1842# a_17357_1842# VDD.t330 VDD.t0 sg13_lv_pmos ad=0.3808p pd=2.92u as=0.2128p ps=1.5u w=1.12u l=0.13u
X463 VSS.t354 a_1544_1044# a_2391_1395# VSS.t353 sg13_lv_nmos ad=0.1331p pd=1.12u as=0.1216p ps=1.02u w=0.64u l=0.13u
X464 VSS.t211 a_3747_311.t3 a_14825_519# VSS.t210 sg13_lv_nmos ad=0.2516p pd=2.16u as=0.2516p ps=2.16u w=0.74u l=0.13u
X465 VSS.t677 a_1256_289# a_2967_331# VSS.t676 sg13_lv_nmos ad=0.1331p pd=1.12u as=0.1216p ps=1.02u w=0.64u l=0.13u
X466 a_2019_1047.t0 a_1721_1395# VSS.t356 VSS.t672 sg13_lv_nmos ad=0.1406p pd=1.12u as=0.1331p ps=1.12u w=0.74u l=0.13u
X467 a_15964_289# a_15765_463# a_5731_289# VSS.t690 sg13_lv_nmos ad=0.2183p pd=1.33u as=0.2516p ps=2.16u w=0.74u l=0.13u
X468 a_13470_1044# a_2019_1047.t6 a_13368_1044# VSS.t437 sg13_lv_nmos ad=0.2516p pd=2.16u as=0.1406p ps=1.12u w=0.74u l=0.13u
X469 VDD.t260 VDD.t258 VDD.t9 VDD.t1 sg13_lv_pmos ad=0.68p pd=4.68u as=0 ps=0 w=2u l=1u
X470 VSS.t145 a_13123_1842# a_13557_1842# VSS.t144 sg13_lv_nmos ad=0.1406p pd=1.12u as=0.2516p ps=2.16u w=0.74u l=0.13u
X471 VDD.t87 VSS.t609 VDD.t86 VDD.t3 sg13_lv_pmos ad=0.34p pd=2.68u as=0 ps=0 w=1u l=1u
X472 VSS.t454 a_3171_1047.t3 a_24084_1008# VSS.t453 sg13_lv_nmos ad=0.2516p pd=2.16u as=0.2516p ps=2.16u w=0.74u l=0.13u
X473 a_25913_1842# a_25717_1842# VSS.t403 VSS.t657 sg13_lv_nmos ad=0.2516p pd=2.16u as=0.1406p ps=1.12u w=0.74u l=0.13u
X474 VDD.t42 a_10649_5878# a_10751_5878# VDD.t1 sg13_lv_pmos ad=1.10612p pd=6.66u as=0.3864p ps=2.93u w=1.12u l=0.13u
X475 a_21353_1842# a_21157_1842# VDD.t131 VDD.t0 sg13_lv_pmos ad=0.3808p pd=2.92u as=0.2128p ps=1.5u w=1.12u l=0.13u
X476 VSS.t590 VDD.t389 VSS.t589 VSS.t588 sg13_lv_nmos ad=0.1428p pd=1.52u as=0 ps=0 w=0.42u l=1u
X477 a_2297_331# MUX_SEL2 VDD.t134 VDD.t3 sg13_lv_pmos ad=0.1596p pd=1.22u as=0.2856p ps=2.36u w=0.84u l=0.13u
X478 VDD.t71 a_7043_1842# a_7477_1842# VDD.t0 sg13_lv_pmos ad=0.2128p pd=1.5u as=0.3808p ps=2.92u w=1.12u l=0.13u
X479 a_2873_331# MUX_SEL3 VDD.t341 VDD.t3 sg13_lv_pmos ad=0.1596p pd=1.22u as=0.2856p ps=2.36u w=0.84u l=0.13u
X480 a_10589_5914# a_10232_5871# VDD.t122 VDD.t1 sg13_lv_pmos ad=63f pd=0.72u as=0.1563p ps=1.22u w=0.42u l=0.13u
X481 a_8155_1044# a_7945_1044# VDD.t45 VDD.t3 sg13_lv_pmos ad=0.2128p pd=1.5u as=0.252p ps=1.57u w=1.12u l=0.13u
X482 a_13880_6292# a_13592_5871# a_13818_6292# VSS.t621 sg13_lv_nmos ad=0.1428p pd=1.52u as=37.8f ps=0.6u w=0.42u l=0.13u
X483 VSS.t143 a_18117_1842# a_18585_1044# VSS.t142 sg13_lv_nmos ad=0.1665p pd=1.19u as=0.2516p ps=2.16u w=0.74u l=0.13u
X484 a_27048_1044# a_26477_1842# VDD.t151 VDD.t3 sg13_lv_pmos ad=0.2128p pd=1.5u as=0.3808p ps=2.92u w=1.12u l=0.13u
X485 a_5768_1044# a_5197_1842# VDD.t344 VDD.t3 sg13_lv_pmos ad=0.2128p pd=1.5u as=0.3808p ps=2.92u w=1.12u l=0.13u
X486 a_10232_5871# a_10751_5878# a_11491_6228# VSS.t158 sg13_lv_nmos ad=0.3473p pd=2.71u as=0.12665p ps=1.145u w=0.74u l=0.13u
X487 a_12656_5864# DLL_RESETN VDD.t124 VDD.t1 sg13_lv_pmos ad=0.3808p pd=2.92u as=0.3808p ps=2.92u w=1.12u l=0.13u
X488 a_13991_2470# a_13753_1842# a_13883_1842# VDD.t0 sg13_lv_pmos ad=0.2128p pd=1.5u as=0.3808p ps=2.92u w=1.12u l=0.2u
X489 VSS.t451 a_3171_1047.t6 a_14964_1008# VSS.t450 sg13_lv_nmos ad=0.2516p pd=2.16u as=0.2516p ps=2.16u w=0.74u l=0.13u
X490 VDD.t32 a_2019_311.t2 a_17865_519# VDD.t3 sg13_lv_pmos ad=0.3808p pd=2.92u as=0.3808p ps=2.92u w=1.12u l=0.13u
X491 DELAY_OUT_LAST a_27997_1842# VSS.t151 VSS.t150 sg13_lv_nmos ad=0.2516p pd=2.16u as=0.1406p ps=1.12u w=0.74u l=0.13u
X492 a_11195_1044# a_10985_1044# VSS.t371 VSS.t370 sg13_lv_nmos ad=0.1406p pd=1.12u as=0.1665p ps=1.19u w=0.74u l=0.13u
X493 VDD.t158 a_24197_1842# a_24665_1044# VDD.t3 sg13_lv_pmos ad=0.252p pd=1.57u as=0.3808p ps=2.92u w=1.12u l=0.13u
X494 a_6913_1842# a_6717_1842# VSS.t458 VSS.t457 sg13_lv_nmos ad=0.2516p pd=2.16u as=0.1406p ps=1.12u w=0.74u l=0.13u
X495 VSS.t321 DELAY_VBIASN a_18551_1842# VSS.t320 sg13_lv_nmos ad=0.2516p pd=2.16u as=0.1406p ps=1.12u w=0.74u l=0.6u
X496 a_16510_1044# a_18004_1008# a_17928_1044# VDD.t3 sg13_lv_pmos ad=0.3808p pd=2.92u as=0.2128p ps=1.5u w=1.12u l=0.13u
X497 a_13592_5423# a_13566_5328# VSS.t4 VSS.t3 sg13_lv_nmos ad=0.2516p pd=2.16u as=0.1626p ps=1.415u w=0.74u l=0.13u
X498 VDD.t28 a_12363_1842# a_12797_1842# VDD.t0 sg13_lv_pmos ad=0.2128p pd=1.5u as=0.3808p ps=2.92u w=1.12u l=0.13u
X499 VSS.t479 MUX_SEL3 a_3543_331# VSS.t649 sg13_lv_nmos ad=0.1331p pd=1.12u as=0.1216p ps=1.02u w=0.64u l=0.13u
X500 a_22590_1044# a_2595_1047.t3 a_23355_1044# VSS.t52 sg13_lv_nmos ad=0.2516p pd=2.16u as=0.1406p ps=1.12u w=0.74u l=0.13u
X501 a_9712_3912# a_6854_5454# a_9444_3912# VSS.t680 sg13_lv_nmos ad=0.38p pd=2.38u as=0.68p ps=4.68u w=2u l=1u
X502 VSS.t243 DELAY_VBIASN a_22351_1842# VSS.t242 sg13_lv_nmos ad=0.2516p pd=2.16u as=0.1406p ps=1.12u w=0.74u l=0.6u
X503 VDD.t109 a_3171_1047.t4 a_21044_1008# VDD.t3 sg13_lv_pmos ad=0.3808p pd=2.92u as=0.3808p ps=2.92u w=1.12u l=0.13u
X504 VDD.t92 VSS.t602 VDD.t91 VDD.t3 sg13_lv_pmos ad=0.19p pd=1.38u as=0 ps=0 w=1u l=1u
X505 a_16271_2470# a_16033_1842# a_16163_1842# VDD.t0 sg13_lv_pmos ad=0.2128p pd=1.5u as=0.3808p ps=2.92u w=1.12u l=0.2u
X506 VDD.t147 VSS.t567 VDD.t254 VDD.t3 sg13_lv_pmos ad=0.19p pd=1.38u as=0 ps=0 w=1u l=1u
X507 a_19833_1842# a_19637_1842# VSS.t35 VSS.t34 sg13_lv_nmos ad=0.2516p pd=2.16u as=0.1406p ps=1.12u w=0.74u l=0.13u
X508 VDD.t110 a_2019_311.t3 a_5705_519# VDD.t3 sg13_lv_pmos ad=0.3808p pd=2.92u as=0.3808p ps=2.92u w=1.12u l=0.13u
X509 VDD.t25 a_14851_6228# a_15108_6109# VDD.t1 sg13_lv_pmos ad=0.2639p pd=1.81u as=79.8f ps=0.8u w=0.42u l=0.13u
X510 a_10520_6292# a_10232_5871# a_10458_6292# VSS.t664 sg13_lv_nmos ad=0.1428p pd=1.52u as=37.8f ps=0.6u w=0.42u l=0.13u
X511 a_15270_6305# a_12849_5867# VSS.t159 VSS.t17 sg13_lv_nmos ad=37.8f pd=0.6u as=79.8f ps=0.8u w=0.42u l=0.13u
X512 a_20071_2470# a_19833_1842# a_19963_1842# VDD.t0 sg13_lv_pmos ad=0.2128p pd=1.5u as=0.3808p ps=2.92u w=1.12u l=0.2u
X513 a_9193_1842# a_8997_1842# VSS.t188 VSS.t395 sg13_lv_nmos ad=0.2516p pd=2.16u as=0.1406p ps=1.12u w=0.74u l=0.13u
X514 a_24631_1842# a_24393_1842# a_24523_1842# VSS.t652 sg13_lv_nmos ad=0.1406p pd=1.12u as=0.2516p ps=2.16u w=0.74u l=0.2u
X515 VDD.t144 VSS.t569 VDD.t143 VDD.t3 sg13_lv_pmos ad=0.34p pd=2.68u as=0 ps=0 w=1u l=1u
X516 VSS.t436 a_2019_1047.t7 a_10404_1008# VSS.t435 sg13_lv_nmos ad=0.2516p pd=2.16u as=0.2516p ps=2.16u w=0.74u l=0.13u
X517 VSS.t260 DELAY_VBIASN VSS.t262 VSS.t261 sg13_lv_nmos ad=1.33p pd=7.38u as=0 ps=0 w=7u l=7u
X518 VDD.t118 a_14643_1842# a_15077_1842# VDD.t0 sg13_lv_pmos ad=0.2128p pd=1.5u as=0.3808p ps=2.92u w=1.12u l=0.13u
X519 VDD.t30 a_1544_289# a_2297_331# VDD.t3 sg13_lv_pmos ad=0.1918p pd=1.5u as=0.1596p ps=1.22u w=0.84u l=0.13u
X520 a_23633_1842# a_23437_1842# VSS.t227 VSS.t226 sg13_lv_nmos ad=0.2516p pd=2.16u as=0.1406p ps=1.12u w=0.74u l=0.13u
X521 VSS.t585 VDD.t390 VSS.t584 VSS.t583 sg13_lv_nmos ad=0.1428p pd=1.52u as=0 ps=0 w=0.42u l=1u
X522 a_2019_311.t1 a_1721_331# VDD.t31 VDD.t3 sg13_lv_pmos ad=0.2128p pd=1.5u as=0.1918p ps=1.5u w=1.12u l=0.13u
X523 VSS.t129 a_9323_1842# a_9757_1842# VSS.t495 sg13_lv_nmos ad=0.1406p pd=1.12u as=0.2516p ps=2.16u w=0.74u l=0.13u
X524 a_26395_1044# a_26185_1044# VSS.t517 VSS.t516 sg13_lv_nmos ad=0.1406p pd=1.12u as=0.1665p ps=1.19u w=0.74u l=0.13u
X525 VDD.t293 DELAY_VBIASP.t16 a_17791_2470# VDD.t0 sg13_lv_pmos ad=0.3808p pd=2.92u as=0.2128p ps=1.5u w=1.12u l=0.6u
X526 VSS.t416 a_3747_1047.t3 a_24951_1008# VSS.t415 sg13_lv_nmos ad=0.2516p pd=2.16u as=0.2516p ps=2.16u w=0.74u l=0.13u
X527 VSS.t550 VDD.t397 VSS.t549 VSS.t548 sg13_lv_nmos ad=0.1428p pd=1.52u as=0 ps=0 w=0.42u l=1u
X528 VSS.t580 VDD.t391 VSS.t579 VSS.t578 sg13_lv_nmos ad=0.1428p pd=1.52u as=0 ps=0 w=0.42u l=1u
X529 a_3747_1047.t1 a_3449_1395# VDD.t46 VDD.t3 sg13_lv_pmos ad=0.2128p pd=1.5u as=0.1918p ps=1.5u w=1.12u l=0.13u
X530 a_13368_1044# a_12797_1842# VDD.t29 VDD.t3 sg13_lv_pmos ad=0.2128p pd=1.5u as=0.3808p ps=2.92u w=1.12u l=0.13u
X531 a_24008_1044# a_23437_1842# VSS.t225 VSS.t224 sg13_lv_nmos ad=0.1406p pd=1.12u as=0.2516p ps=2.16u w=0.74u l=0.13u
X532 VDD.t314 DELAY_VBIASP.t11 a_21591_2470# VDD.t0 sg13_lv_pmos ad=0.3808p pd=2.92u as=0.2128p ps=1.5u w=1.12u l=0.6u
X533 a_15964_289# MUX_SEL4 a_5731_289# VDD.t3 sg13_lv_pmos ad=0.3304p pd=1.71u as=0.3808p ps=2.92u w=1.12u l=0.13u
X534 a_4350_1044# a_6711_1008# a_6635_1044# VDD.t3 sg13_lv_pmos ad=0.3808p pd=2.92u as=0.2128p ps=1.5u w=1.12u l=0.13u
X535 a_2873_1395# MUX_SEL1 VDD.t52 VDD.t3 sg13_lv_pmos ad=0.1596p pd=1.22u as=0.2856p ps=2.36u w=0.84u l=0.13u
X536 VSS.t4 a_12849_5867# a_13400_5105# VSS.t714 sg13_lv_nmos ad=0.1626p pd=1.415u as=60.89999f ps=0.71u w=0.42u l=0.13u
X537 a_1256_1044# MUX_SEL0 VSS.t623 VSS.t622 sg13_lv_nmos ad=0.2516p pd=2.16u as=0.2516p ps=2.16u w=0.74u l=0.13u
X538 VSS.t547 VDD.t398 VSS.t545 VSS.t546 sg13_lv_nmos ad=79.8f pd=0.8u as=0 ps=0 w=0.42u l=1u
X539 a_19550_1044# a_20391_1008# a_20315_1044# VDD.t3 sg13_lv_pmos ad=0.3808p pd=2.92u as=0.2128p ps=1.5u w=1.12u l=0.13u
X540 VDD.t286 VDD.t288 VDD.t289 VDD.t0 sg13_lv_pmos ad=0.2128p pd=1.5u as=0 ps=0 w=1.12u l=0.2u
X541 a_5631_1842# a_5393_1842# a_5523_1842# VSS.t620 sg13_lv_nmos ad=0.1406p pd=1.12u as=0.2516p ps=2.16u w=0.74u l=0.2u
X542 a_14513_1842# a_14317_1842# VSS.t81 VSS.t424 sg13_lv_nmos ad=0.2516p pd=2.16u as=0.1406p ps=1.12u w=0.74u l=0.13u
X543 VSS.t471 a_2595_311.t2 a_20905_519# VSS.t470 sg13_lv_nmos ad=0.2516p pd=2.16u as=0.2516p ps=2.16u w=0.74u l=0.13u
X544 VDD.t45 a_7477_1842# a_7945_1044# VDD.t3 sg13_lv_pmos ad=0.252p pd=1.57u as=0.3808p ps=2.92u w=1.12u l=0.13u
X545 a_13470_1044# a_3171_1047.t6 a_14888_1044# VSS.t449 sg13_lv_nmos ad=0.2516p pd=2.16u as=0.1406p ps=1.12u w=0.74u l=0.13u
X546 a_4633_1842# a_4437_1842# VSS.t75 VSS.t74 sg13_lv_nmos ad=0.2516p pd=2.16u as=0.1406p ps=1.12u w=0.74u l=0.13u
X547 a_1256_289# MUX_SEL2 VSS.t363 VSS.t362 sg13_lv_nmos ad=0.2516p pd=2.16u as=0.2516p ps=2.16u w=0.74u l=0.13u
X548 VSS.t48 a_2019_1047.t2 a_25604_1008# VSS.t47 sg13_lv_nmos ad=0.2516p pd=2.16u as=0.2516p ps=2.16u w=0.74u l=0.13u
X549 a_13019_5831# a_15688_5403# VDD.t360 VDD.t1 sg13_lv_pmos ad=0.3808p pd=2.92u as=0.2128p ps=1.5u w=1.12u l=0.13u
X550 VSS.t256 DELAY_VBIASN VSS.t258 VSS.t257 sg13_lv_nmos ad=1.33p pd=7.38u as=0 ps=0 w=7u l=7u
X551 a_16108_289# MUX_SEL4 a_15964_289# VSS.t236 sg13_lv_nmos ad=0.2516p pd=2.16u as=0.2183p ps=1.33u w=0.74u l=0.13u
X552 a_13400_6305# a_12355_5867# a_13306_6305# VSS.t380 sg13_lv_nmos ad=60.89999f pd=0.71u as=0.1428p ps=1.52u w=0.42u l=0.13u
X553 a_22873_1842# a_22677_1842# VDD.t126 VDD.t0 sg13_lv_pmos ad=0.3808p pd=2.92u as=0.2128p ps=1.5u w=1.12u l=0.13u
X554 a_21835_1044# a_21625_1044# VSS.t208 VSS.t207 sg13_lv_nmos ad=0.1406p pd=1.12u as=0.1665p ps=1.19u w=0.74u l=0.13u
X555 VSS.t688 a_2595_1047.t4 a_20391_1008# VSS.t687 sg13_lv_nmos ad=0.2516p pd=2.16u as=0.2516p ps=2.16u w=0.74u l=0.13u
X556 a_9675_1044# a_9465_1044# VDD.t173 VDD.t3 sg13_lv_pmos ad=0.2128p pd=1.5u as=0.252p ps=1.57u w=1.12u l=0.13u
X557 VSS.t371 a_10517_1842# a_10985_1044# VSS.t490 sg13_lv_nmos ad=0.1665p pd=1.19u as=0.2516p ps=2.16u w=0.74u l=0.13u
X558 VDD.t160 a_2595_1047.t8 a_8231_1008# VDD.t3 sg13_lv_pmos ad=0.3808p pd=2.92u as=0.3808p ps=2.92u w=1.12u l=0.13u
X559 a_18551_1842# a_18313_1842# a_18443_1842# VSS.t137 sg13_lv_nmos ad=0.1406p pd=1.12u as=0.2516p ps=2.16u w=0.74u l=0.2u
X560 a_12943_5867# a_12656_5864# a_12849_5867# VDD.t1 sg13_lv_pmos ad=0.2128p pd=1.5u as=0.3808p ps=2.92u w=1.12u l=0.13u
X561 a_13566_5835# a_14009_5878# a_13949_5914# VDD.t1 sg13_lv_pmos ad=79.8f pd=0.8u as=63f ps=0.72u w=0.42u l=0.13u
X562 a_22351_1842# a_22113_1842# a_22243_1842# VSS.t0 sg13_lv_nmos ad=0.1406p pd=1.12u as=0.2516p ps=2.16u w=0.74u l=0.2u
X563 VSS.t88 a_3747_1047.t5 a_18871_1008# VSS.t87 sg13_lv_nmos ad=0.2516p pd=2.16u as=0.2516p ps=2.16u w=0.74u l=0.13u
X564 VSS.t630 a_16923_1842# a_17357_1842# VSS.t629 sg13_lv_nmos ad=0.1406p pd=1.12u as=0.2516p ps=2.16u w=0.74u l=0.13u
X565 VDD.t108 a_3171_311.t2 a_23945_519# VDD.t3 sg13_lv_pmos ad=0.3808p pd=2.92u as=0.3808p ps=2.92u w=1.12u l=0.13u
X566 a_2019_311.t0 a_1721_331# VSS.t28 VSS.t521 sg13_lv_nmos ad=0.1406p pd=1.12u as=0.1331p ps=1.12u w=0.74u l=0.13u
X567 a_25153_1842# a_24957_1842# VDD.t338 VDD.t0 sg13_lv_pmos ad=0.3808p pd=2.92u as=0.2128p ps=1.5u w=1.12u l=0.13u
X568 a_17928_1044# a_17357_1842# VSS.t633 VSS.t632 sg13_lv_nmos ad=0.1406p pd=1.12u as=0.2516p ps=2.16u w=0.74u l=0.13u
X569 a_12715_1044# a_12505_1044# VSS.t628 VSS.t627 sg13_lv_nmos ad=0.1406p pd=1.12u as=0.1665p ps=1.19u w=0.74u l=0.13u
X570 a_13880_6292# a_14111_5878# a_13566_5835# VSS.t710 sg13_lv_nmos ad=0.2373p pd=1.97u as=79.8f ps=0.8u w=0.42u l=0.13u
X571 a_15053_5990# a_14111_5878# a_14851_6228# VDD.t1 sg13_lv_pmos ad=93.45f pd=0.865u as=0.2048p ps=1.63u w=0.42u l=0.13u
X572 VDD.t117 MUX_SEL4 a_15765_463# VDD.t3 sg13_lv_pmos ad=0.3808p pd=2.92u as=0.3808p ps=2.92u w=1.12u l=0.13u
X573 a_19550_1044# a_3171_1047.t4 a_20968_1044# VSS.t218 sg13_lv_nmos ad=0.2516p pd=2.16u as=0.1406p ps=1.12u w=0.74u l=0.13u
X574 VSS.t249 DELAY_VBIASN a_10951_1842# VSS.t248 sg13_lv_nmos ad=0.2516p pd=2.16u as=0.1406p ps=1.12u w=0.74u l=0.6u
X575 a_19550_1044# a_19524_1008# a_19448_1044# VDD.t3 sg13_lv_pmos ad=0.3808p pd=2.92u as=0.2128p ps=1.5u w=1.12u l=0.13u
X576 a_7288_1044# a_6717_1842# VSS.t456 VSS.t455 sg13_lv_nmos ad=0.1406p pd=1.12u as=0.2516p ps=2.16u w=0.74u l=0.13u
X577 a_12355_5867# a_12158_5867# VSS.t155 VSS.t154 sg13_lv_nmos ad=0.2516p pd=2.16u as=0.1406p ps=1.12u w=0.74u l=0.13u
X578 VSS.t358 a_20723_1842# a_21157_1842# VSS.t357 sg13_lv_nmos ad=0.1406p pd=1.12u as=0.2516p ps=2.16u w=0.74u l=0.13u
X579 VDD.t27 a_14851_6228# a_15688_5867# VDD.t1 sg13_lv_pmos ad=0.2128p pd=1.5u as=0.3864p ps=2.93u w=1.12u l=0.13u
X580 a_1544_289# MUX_SEL3 VSS.t647 VSS.t646 sg13_lv_nmos ad=0.2516p pd=2.16u as=0.2516p ps=2.16u w=0.74u l=0.13u
X581 a_13470_1044# a_14311_1008# a_14235_1044# VDD.t3 sg13_lv_pmos ad=0.3808p pd=2.92u as=0.2128p ps=1.5u w=1.12u l=0.13u
X582 a_22590_1044# a_3747_1047.t3 a_24875_1044# VSS.t414 sg13_lv_nmos ad=0.2516p pd=2.16u as=0.1406p ps=1.12u w=0.74u l=0.13u
X583 VSS.t329 DELAY_VBIASN a_23871_1842# VSS.t328 sg13_lv_nmos ad=0.2516p pd=2.16u as=0.1406p ps=1.12u w=0.74u l=0.6u
X584 VDD.t199 a_2019_1047.t3 a_22564_1008# VDD.t3 sg13_lv_pmos ad=0.3808p pd=2.92u as=0.3808p ps=2.92u w=1.12u l=0.13u
X585 VSS.t517 a_25717_1842# a_26185_1044# VSS.t656 sg13_lv_nmos ad=0.1665p pd=1.19u as=0.2516p ps=2.16u w=0.74u l=0.13u
X586 a_13231_1842# a_12993_1842# a_13123_1842# VSS.t22 sg13_lv_nmos ad=0.1406p pd=1.12u as=0.2516p ps=2.16u w=0.74u l=0.2u
X587 VSS.t542 VDD.t399 VSS.t540 VSS.t541 sg13_lv_nmos ad=79.8f pd=0.8u as=0 ps=0 w=0.42u l=1u
X588 a_17791_2470# a_17553_1842# a_17683_1842# VDD.t0 sg13_lv_pmos ad=0.2128p pd=1.5u as=0.3808p ps=2.92u w=1.12u l=0.2u
X589 VSS.t73 a_4437_1842# a_4905_1044# VSS.t72 sg13_lv_nmos ad=0.1665p pd=1.19u as=0.2516p ps=2.16u w=0.74u l=0.13u
X590 VDD.t256 VSS.t599 VDD.t92 VDD.t3 sg13_lv_pmos ad=0.34p pd=2.68u as=0 ps=0 w=1u l=1u
X591 a_12233_1842# a_12037_1842# VSS.t231 VSS.t699 sg13_lv_nmos ad=0.2516p pd=2.16u as=0.1406p ps=1.12u w=0.74u l=0.13u
X592 VDD.t42 a_9547_6172# a_9547_5942# VDD.t1 sg13_lv_pmos ad=1.10612p pd=6.66u as=0.2442p ps=2.06u w=0.66u l=0.13u
X593 a_15108_5325# a_14851_5182# a_15270_5105# VSS.t703 sg13_lv_nmos ad=0.1428p pd=1.52u as=37.8f ps=0.6u w=0.42u l=0.13u
X594 VSS.t71 a_3449_1395# a_3747_1047.t0 VSS.t70 sg13_lv_nmos ad=0.2812p pd=2.24u as=0.1406p ps=1.12u w=0.74u l=0.13u
X595 VDD.t148 VSS.t564 VDD.t147 VDD.t3 sg13_lv_pmos ad=0.34p pd=2.68u as=0 ps=0 w=1u l=1u
X596 VDD.t41 VSS.t577 VDD.t145 VDD.t3 sg13_lv_pmos ad=0.19p pd=1.38u as=0 ps=0 w=1u l=1u
X597 VSS.t607 VDD.t386 VSS.t605 VSS.t606 sg13_lv_nmos ad=79.8f pd=0.8u as=0 ps=0 w=0.42u l=1u
X598 VSS.t663 a_3171_1047.t8 a_8884_1008# VSS.t662 sg13_lv_nmos ad=0.2516p pd=2.16u as=0.2516p ps=2.16u w=0.74u l=0.13u
X599 a_21591_2470# a_21353_1842# a_21483_1842# VDD.t0 sg13_lv_pmos ad=0.2128p pd=1.5u as=0.3808p ps=2.92u w=1.12u l=0.2u
X600 VDD.t181 a_2873_1395# a_3171_1047.t1 VDD.t3 sg13_lv_pmos ad=0.4256p pd=3u as=0.2128p ps=1.5u w=1.12u l=0.13u
X601 a_6153_1842# a_5957_1842# VDD.t54 VDD.t0 sg13_lv_pmos ad=0.3808p pd=2.92u as=0.2128p ps=1.5u w=1.12u l=0.13u
X602 VDD.t36 a_16163_1842# a_16597_1842# VDD.t0 sg13_lv_pmos ad=0.2128p pd=1.5u as=0.3808p ps=2.92u w=1.12u l=0.13u
X603 a_3543_1395# MUX_SEL0 a_3449_1395# VSS.t625 sg13_lv_nmos ad=0.1216p pd=1.02u as=0.2176p ps=1.96u w=0.64u l=0.13u
X604 VDD.t129 a_1544_1044# a_2297_1395# VDD.t3 sg13_lv_pmos ad=0.1918p pd=1.5u as=0.1596p ps=1.22u w=0.84u l=0.13u
X605 VDD.t303 DELAY_VBIASP.t26 a_10191_2470# VDD.t0 sg13_lv_pmos ad=0.3808p pd=2.92u as=0.2128p ps=1.5u w=1.12u l=0.6u
X606 a_17275_1044# a_17065_1044# VDD.t64 VDD.t3 sg13_lv_pmos ad=0.2128p pd=1.5u as=0.252p ps=1.57u w=1.12u l=0.13u
X607 a_2019_1047.t1 a_1721_1395# VDD.t130 VDD.t3 sg13_lv_pmos ad=0.2128p pd=1.5u as=0.1918p ps=1.5u w=1.12u l=0.13u
X608 a_27915_1044# a_27705_1044# VSS.t204 VSS.t626 sg13_lv_nmos ad=0.1406p pd=1.12u as=0.1665p ps=1.19u w=0.74u l=0.13u
X609 VSS.t335 DELAY_VBIASN a_26151_1842# VSS.t334 sg13_lv_nmos ad=0.2516p pd=2.16u as=0.1406p ps=1.12u w=0.74u l=0.6u
X610 VDD.t187 a_3747_1047.t6 a_15831_1008# VDD.t3 sg13_lv_pmos ad=0.3808p pd=2.92u as=0.3808p ps=2.92u w=1.12u l=0.13u
X611 VDD.t88 a_19963_1842# a_20397_1842# VDD.t0 sg13_lv_pmos ad=0.2128p pd=1.5u as=0.3808p ps=2.92u w=1.12u l=0.13u
X612 VSS.t610 VDD.t385 VSS.t609 VSS.t608 sg13_lv_nmos ad=0.1428p pd=1.52u as=0 ps=0 w=0.42u l=1u
X613 VSS.t289 DELAY_VBIASN a_4871_1842# VSS.t288 sg13_lv_nmos ad=0.2516p pd=2.16u as=0.1406p ps=1.12u w=0.74u l=0.6u
X614 a_14888_1044# a_14317_1842# VDD.t193 VDD.t3 sg13_lv_pmos ad=0.2128p pd=1.5u as=0.3808p ps=2.92u w=1.12u l=0.13u
X615 a_4350_1044# a_4324_1008# a_4248_1044# VDD.t3 sg13_lv_pmos ad=0.3808p pd=2.92u as=0.2128p ps=1.5u w=1.12u l=0.13u
X616 a_1256_289# MUX_SEL2 VDD.t133 VDD.t3 sg13_lv_pmos ad=0.3808p pd=2.92u as=0.3808p ps=2.92u w=1.12u l=0.13u
X617 VSS.t123 VSS.t120 VSS.t122 VSS.t121 sg13_lv_nmos ad=0.2516p pd=2.16u as=0 ps=0 w=0.74u l=0.6u
X618 a_16108_289# a_15765_463# a_15964_289# VDD.t3 sg13_lv_pmos ad=0.3808p pd=2.92u as=0.3304p ps=1.71u w=1.12u l=0.13u
X619 VDD.t324 a_12849_5867# a_13566_5835# VDD.t1 sg13_lv_pmos ad=0.1563p pd=1.22u as=0.147p ps=1.54u w=0.42u l=0.13u
X620 VSS.t252 DELAY_VBIASN VSS.t251 VSS.t250 sg13_lv_nmos ad=2.38p pd=14.68u as=0 ps=0 w=7u l=7u
X621 a_11473_1842# a_11277_1842# VDD.t43 VDD.t0 sg13_lv_pmos ad=0.3808p pd=2.92u as=0.2128p ps=1.5u w=1.12u l=0.13u
X622 VDD.t173 a_8997_1842# a_9465_1044# VDD.t3 sg13_lv_pmos ad=0.252p pd=1.57u as=0.3808p ps=2.92u w=1.12u l=0.13u
X623 a_27433_1842# a_27237_1842# VSS.t202 VSS.t201 sg13_lv_nmos ad=0.2516p pd=2.16u as=0.1406p ps=1.12u w=0.74u l=0.13u
X624 a_2391_331# MUX_SEL2 a_2297_331# VSS.t364 sg13_lv_nmos ad=0.1216p pd=1.02u as=0.2176p ps=1.96u w=0.64u l=0.13u
X625 a_2967_331# MUX_SEL3 a_2873_331# VSS.t648 sg13_lv_nmos ad=0.1216p pd=1.02u as=0.2176p ps=1.96u w=0.64u l=0.13u
X626 VDD.t206 a_2019_1047.t5 a_16484_1008# VDD.t3 sg13_lv_pmos ad=0.3808p pd=2.92u as=0.3808p ps=2.92u w=1.12u l=0.13u
X627 a_7390_1044# a_2595_1047.t8 a_8155_1044# VSS.t389 sg13_lv_nmos ad=0.2516p pd=2.16u as=0.1406p ps=1.12u w=0.74u l=0.13u
X628 VSS.t508 a_6126_3816# a_5974_5723# VSS.t504 sg13_lv_nmos ad=0.68p pd=4.68u as=0.38p ps=2.38u w=2u l=1u
X629 VSS.t245 DELAY_VBIASN a_7151_1842# VSS.t244 sg13_lv_nmos ad=0.2516p pd=2.16u as=0.1406p ps=1.12u w=0.74u l=0.6u
X630 VDD.t78 a_3171_1047.t9 a_5844_1008# VDD.t3 sg13_lv_pmos ad=0.3808p pd=2.92u as=0.3808p ps=2.92u w=1.12u l=0.13u
X631 VDD.t320 DELAY_VBIASP.t6 a_25391_2470# VDD.t0 sg13_lv_pmos ad=0.3808p pd=2.92u as=0.2128p ps=1.5u w=1.12u l=0.6u
X632 VDD.t161 a_2595_1047.t7 a_11271_1008# VDD.t3 sg13_lv_pmos ad=0.3808p pd=2.92u as=0.3808p ps=2.92u w=1.12u l=0.13u
X633 VDD.t165 VSS.t557 VDD.t164 VDD.t3 sg13_lv_pmos ad=0.19p pd=1.38u as=0 ps=0 w=1u l=1u
X634 VSS.t628 a_12037_1842# a_12505_1044# VSS.t698 sg13_lv_nmos ad=0.1665p pd=1.19u as=0.2516p ps=2.16u w=0.74u l=0.13u
X635 VDD.t230 a_3747_1047.t8 a_9751_1008# VDD.t3 sg13_lv_pmos ad=0.3808p pd=2.92u as=0.3808p ps=2.92u w=1.12u l=0.13u
X636 a_12943_5867# a_13121_5831# VDD.t57 VDD.t1 sg13_lv_pmos ad=0.3808p pd=2.92u as=0.2128p ps=1.5u w=1.12u l=0.13u
X637 a_11748_6109# a_11491_6228# a_11910_6305# VSS.t158 sg13_lv_nmos ad=0.1428p pd=1.52u as=37.8f ps=0.6u w=0.42u l=0.13u
X638 a_9431_1842# a_9193_1842# a_9323_1842# VSS.t67 sg13_lv_nmos ad=0.1406p pd=1.12u as=0.2516p ps=2.16u w=0.74u l=0.2u
X639 a_18313_1842# a_18117_1842# VSS.t141 VSS.t140 sg13_lv_nmos ad=0.2516p pd=2.16u as=0.1406p ps=1.12u w=0.74u l=0.13u
X640 MUX_OUT a_16851_309# VSS.t181 VSS.t180 sg13_lv_nmos ad=0.1406p pd=1.12u as=0.1371p ps=1.12u w=0.74u l=0.13u
X641 a_10232_5871# a_10206_5835# VDD.t121 VDD.t1 sg13_lv_pmos ad=0.34p pd=2.68u as=0.36237p ps=2.605u w=1u l=0.13u
X642 a_14851_5182# a_14009_5084# a_14757_5182# VSS.t59 sg13_lv_nmos ad=0.12665p pd=1.145u as=0.1428p ps=1.52u w=0.42u l=0.13u
X643 VSS.t602 VDD.t387 VSS.t600 VSS.t601 sg13_lv_nmos ad=79.8f pd=0.8u as=0 ps=0 w=0.42u l=1u
X644 a_23871_1842# a_23633_1842# a_23763_1842# VSS.t340 sg13_lv_nmos ad=0.1406p pd=1.12u as=0.2516p ps=2.16u w=0.74u l=0.2u
X645 a_8433_1842# a_8237_1842# VSS.t149 VSS.t148 sg13_lv_nmos ad=0.2516p pd=2.16u as=0.1406p ps=1.12u w=0.74u l=0.13u
X646 VSS.t401 a_18443_1842# a_18877_1842# VSS.t651 sg13_lv_nmos ad=0.1406p pd=1.12u as=0.2516p ps=2.16u w=0.74u l=0.13u
X647 VSS.t567 VDD.t394 VSS.t565 VSS.t566 sg13_lv_nmos ad=79.8f pd=0.8u as=0 ps=0 w=0.42u l=1u
X648 VSS.t506 a_6126_3816# a_5974_5723# VSS.t504 sg13_lv_nmos ad=0.68p pd=4.68u as=0.38p ps=2.38u w=2u l=1u
X649 a_22113_1842# a_21917_1842# VSS.t14 VSS.t13 sg13_lv_nmos ad=0.2516p pd=2.16u as=0.1406p ps=1.12u w=0.74u l=0.13u
X650 a_1544_289# MUX_SEL3 VDD.t339 VDD.t3 sg13_lv_pmos ad=0.3808p pd=2.92u as=0.3808p ps=2.92u w=1.12u l=0.13u
X651 VDD.t24 VDD.t261 VDD.t268 VDD.t1 sg13_lv_pmos ad=0.38p pd=2.38u as=0 ps=0 w=2u l=1u
X652 a_26673_1842# a_26477_1842# VDD.t150 VDD.t0 sg13_lv_pmos ad=0.3808p pd=2.92u as=0.2128p ps=1.5u w=1.12u l=0.13u
X653 a_10328_1044# a_9757_1842# VSS.t127 VSS.t126 sg13_lv_nmos ad=0.1406p pd=1.12u as=0.2516p ps=2.16u w=0.74u l=0.13u
X654 VSS.t570 VDD.t393 VSS.t569 VSS.t568 sg13_lv_nmos ad=0.1428p pd=1.52u as=0 ps=0 w=0.42u l=1u
X655 a_22590_1044# a_2019_1047.t3 a_22488_1044# VSS.t440 sg13_lv_nmos ad=0.2516p pd=2.16u as=0.1406p ps=1.12u w=0.74u l=0.13u
X656 VSS.t315 DELAY_VBIASN a_12471_1842# VSS.t314 sg13_lv_nmos ad=0.2516p pd=2.16u as=0.1406p ps=1.12u w=0.74u l=0.6u
X657 a_8808_1044# a_8237_1842# VSS.t147 VSS.t146 sg13_lv_nmos ad=0.1406p pd=1.12u as=0.2516p ps=2.16u w=0.74u l=0.13u
X658 VSS.t351 a_22243_1842# a_22677_1842# VSS.t706 sg13_lv_nmos ad=0.1406p pd=1.12u as=0.2516p ps=2.16u w=0.74u l=0.13u
X659 VDD.t292 DELAY_VBIASP.t31 a_6391_2470# VDD.t0 sg13_lv_pmos ad=0.3808p pd=2.92u as=0.2128p ps=1.5u w=1.12u l=0.6u
X660 a_13470_1044# a_15831_1008# a_15755_1044# VDD.t3 sg13_lv_pmos ad=0.3808p pd=2.92u as=0.2128p ps=1.5u w=1.12u l=0.13u
X661 a_1544_1044# MUX_SEL1 VDD.t51 VDD.t3 sg13_lv_pmos ad=0.3808p pd=2.92u as=0.3808p ps=2.92u w=1.12u l=0.13u
X662 VDD.t318 DELAY_VBIASP.t12 a_20831_2470# VDD.t0 sg13_lv_pmos ad=0.3808p pd=2.92u as=0.2128p ps=1.5u w=1.12u l=0.6u
X663 VDD.t195 a_2595_1047.t2 a_26471_1008# VDD.t3 sg13_lv_pmos ad=0.3808p pd=2.92u as=0.3808p ps=2.92u w=1.12u l=0.13u
X664 a_4350_1044# a_5191_1008# a_5115_1044# VDD.t3 sg13_lv_pmos ad=0.3808p pd=2.92u as=0.2128p ps=1.5u w=1.12u l=0.13u
X665 VDD.t64 a_16597_1842# a_17065_1044# VDD.t3 sg13_lv_pmos ad=0.252p pd=1.57u as=0.3808p ps=2.92u w=1.12u l=0.13u
X666 VSS.t204 a_27237_1842# a_27705_1044# VSS.t203 sg13_lv_nmos ad=0.1665p pd=1.19u as=0.2516p ps=2.16u w=0.74u l=0.13u
X667 VSS.t251 DELAY_VBIASN VSS.t254 VSS.t253 sg13_lv_nmos ad=1.33p pd=7.38u as=0 ps=0 w=7u l=7u
X668 a_10191_2470# a_9953_1842# a_10083_1842# VDD.t0 sg13_lv_pmos ad=0.2128p pd=1.5u as=0.3808p ps=2.92u w=1.12u l=0.2u
X669 a_2595_1047.t0 a_2297_1395# VSS.t354 VSS.t482 sg13_lv_nmos ad=0.1406p pd=1.12u as=0.1331p ps=1.12u w=0.74u l=0.13u
X670 a_26151_1842# a_25913_1842# a_26043_1842# VSS.t618 sg13_lv_nmos ad=0.1406p pd=1.12u as=0.2516p ps=2.16u w=0.74u l=0.2u
X671 VSS.t33 a_2019_311.t2 a_17865_519# VSS.t32 sg13_lv_nmos ad=0.2516p pd=2.16u as=0.2516p ps=2.16u w=0.74u l=0.13u
X672 VSS.t30 a_1544_289# a_2391_331# VSS.t29 sg13_lv_nmos ad=0.1331p pd=1.12u as=0.1216p ps=1.02u w=0.64u l=0.13u
X673 a_4871_1842# a_4633_1842# a_4763_1842# VSS.t499 sg13_lv_nmos ad=0.1406p pd=1.12u as=0.2516p ps=2.16u w=0.74u l=0.2u
X674 a_13753_1842# a_13557_1842# VSS.t145 VSS.t476 sg13_lv_nmos ad=0.2516p pd=2.16u as=0.1406p ps=1.12u w=0.74u l=0.13u
X675 a_1815_1395# a_1256_1044# a_1721_1395# VSS.t367 sg13_lv_nmos ad=0.1216p pd=1.02u as=0.2176p ps=1.96u w=0.64u l=0.13u
X676 a_7673_1842# a_7477_1842# VDD.t71 VDD.t0 sg13_lv_pmos ad=0.3808p pd=2.92u as=0.2128p ps=1.5u w=1.12u l=0.13u
X677 VDD.t41 VSS.t574 VDD.t40 VDD.t3 sg13_lv_pmos ad=0.34p pd=2.68u as=0 ps=0 w=1u l=1u
X678 a_1721_331# a_1256_289# VDD.t358 VDD.t3 sg13_lv_pmos ad=0.1596p pd=1.22u as=0.2856p ps=2.36u w=0.84u l=0.13u
X679 VSS.t645 a_24523_1842# a_24957_1842# VSS.t644 sg13_lv_nmos ad=0.1406p pd=1.12u as=0.2516p ps=2.16u w=0.74u l=0.13u
X680 a_6635_1044# a_6425_1044# VSS.t85 VSS.t404 sg13_lv_nmos ad=0.1406p pd=1.12u as=0.1665p ps=1.19u w=0.74u l=0.13u
X681 VDD.t42 a_15108_5325# a_15053_5420# VDD.t1 sg13_lv_pmos ad=1.10612p pd=6.66u as=93.45f ps=0.865u w=0.42u l=0.13u
X682 VSS.t423 a_2595_1047.t9 a_5191_1008# VSS.t422 sg13_lv_nmos ad=0.2516p pd=2.16u as=0.2516p ps=2.16u w=0.74u l=0.13u
X683 a_20315_1044# a_20105_1044# VSS.t37 VSS.t205 sg13_lv_nmos ad=0.1406p pd=1.12u as=0.1665p ps=1.19u w=0.74u l=0.13u
X684 VDD.t307 DELAY_VBIASP.t24 a_11711_2470# VDD.t0 sg13_lv_pmos ad=0.3808p pd=2.92u as=0.2128p ps=1.5u w=1.12u l=0.6u
X685 a_18795_1044# a_18585_1044# VDD.t66 VDD.t3 sg13_lv_pmos ad=0.2128p pd=1.5u as=0.252p ps=1.57u w=1.12u l=0.13u
X686 a_25528_1044# a_24957_1842# VSS.t669 VSS.t668 sg13_lv_nmos ad=0.1406p pd=1.12u as=0.2516p ps=2.16u w=0.74u l=0.13u
X687 a_5778_3367# a_6126_3816# a_6326_4590# VSS.t501 sg13_lv_nmos ad=0.68p pd=4.68u as=0.38p ps=2.38u w=2u l=1u
X688 VSS.t269 DELAY_VBIASN VSS.t278 VSS.t259 sg13_lv_nmos ad=1.33p pd=7.38u as=0 ps=0 w=7u l=7u
X689 VSS.t339 DELAY_VBIASN a_27671_1842# VSS.t338 sg13_lv_nmos ad=0.2516p pd=2.16u as=0.1406p ps=1.12u w=0.74u l=0.6u
X690 a_5731_289# a_3747_311.t3 a_13470_1044# VSS.t209 sg13_lv_nmos ad=0.2516p pd=2.16u as=0.2516p ps=2.16u w=0.74u l=0.13u
X691 a_25630_1044# a_27124_1008# a_27048_1044# VDD.t3 sg13_lv_pmos ad=0.3808p pd=2.92u as=0.2128p ps=1.5u w=1.12u l=0.13u
X692 VDD.t182 a_2595_1047.t5 a_17351_1008# VDD.t3 sg13_lv_pmos ad=0.3808p pd=2.92u as=0.3808p ps=2.92u w=1.12u l=0.13u
X693 VSS.t89 a_13121_5831# a_6854_5986# VDD.t58 sg13_lv_pmos ad=0.232p pd=2.08u as=0.136p ps=1.14u w=0.4u l=0.2u
X694 VDD.t7 a_21483_1842# a_21917_1842# VDD.t0 sg13_lv_pmos ad=0.2128p pd=1.5u as=0.3808p ps=2.92u w=1.12u l=0.13u
X695 a_4350_1044# a_5844_1008# a_5768_1044# VDD.t3 sg13_lv_pmos ad=0.3808p pd=2.92u as=0.2128p ps=1.5u w=1.12u l=0.13u
X696 VSS.t183 a_16851_309# MUX_OUT VSS.t182 sg13_lv_nmos ad=0.2516p pd=2.16u as=0.1406p ps=1.12u w=0.74u l=0.13u
X697 VSS.t223 a_2019_311.t3 a_5705_519# VSS.t222 sg13_lv_nmos ad=0.2516p pd=2.16u as=0.2516p ps=2.16u w=0.74u l=0.13u
X698 VDD.t31 a_1544_289# a_1721_331# VDD.t3 sg13_lv_pmos ad=0.1918p pd=1.5u as=0.1596p ps=1.22u w=0.84u l=0.13u
X699 a_7151_1842# a_6913_1842# a_7043_1842# VSS.t472 sg13_lv_nmos ad=0.1406p pd=1.12u as=0.2516p ps=2.16u w=0.74u l=0.2u
X700 a_16033_1842# a_15837_1842# VSS.t461 VSS.t498 sg13_lv_nmos ad=0.2516p pd=2.16u as=0.1406p ps=1.12u w=0.74u l=0.13u
X701 a_10649_5878# REF_CLK VSS.t131 VSS.t130 sg13_lv_nmos ad=0.2516p pd=2.16u as=1.9998p ps=12.915u w=0.74u l=0.13u
X702 VDD.t42 a_11748_6109# a_11693_5990# VDD.t1 sg13_lv_pmos ad=1.10612p pd=6.66u as=93.45f ps=0.865u w=0.42u l=0.13u
X703 MUX_OUT a_16851_309# VDD.t79 VDD.t3 sg13_lv_pmos ad=0.2128p pd=1.5u as=0.2086p ps=1.5u w=1.12u l=0.13u
X704 a_25391_2470# a_25153_1842# a_25283_1842# VDD.t0 sg13_lv_pmos ad=0.2128p pd=1.5u as=0.3808p ps=2.92u w=1.12u l=0.2u
X705 VDD.t142 VSS.t544 VDD.t141 VDD.t3 sg13_lv_pmos ad=0.34p pd=2.68u as=0 ps=0 w=1u l=1u
X706 a_12993_1842# a_12797_1842# VDD.t28 VDD.t0 sg13_lv_pmos ad=0.3808p pd=2.92u as=0.2128p ps=1.5u w=1.12u l=0.13u
X707 a_16408_1044# a_15837_1842# VSS.t497 VSS.t496 sg13_lv_nmos ad=0.1406p pd=1.12u as=0.2516p ps=2.16u w=0.74u l=0.13u
X708 a_5778_3367# a_6126_3816# a_6326_4590# VSS.t501 sg13_lv_nmos ad=0.68p pd=4.68u as=0.38p ps=2.38u w=2u l=1u
X709 VSS.t83 a_5523_1842# a_5957_1842# VSS.t366 sg13_lv_nmos ad=0.1406p pd=1.12u as=0.2516p ps=2.16u w=0.74u l=0.13u
X710 VDD.t309 DELAY_VBIASP.t21 a_13991_2470# VDD.t0 sg13_lv_pmos ad=0.3808p pd=2.92u as=0.2128p ps=1.5u w=1.12u l=0.6u
X711 a_5731_289# a_2019_311.t3 a_4350_1044# VSS.t221 sg13_lv_nmos ad=0.2516p pd=2.16u as=0.2516p ps=2.16u w=0.74u l=0.13u
X712 VSS.t163 a_9547_6172# a_9547_6172# VSS.t162 sg13_lv_nmos ad=2.39977p pd=15.495u as=0.111p ps=1.34u w=0.3u l=0.13u
X713 a_9444_3912# a_6854_5454# a_9712_3912# VSS.t679 sg13_lv_nmos ad=0.68p pd=4.68u as=0.38p ps=2.38u w=2u l=1u
X714 VSS.t283 DELAY_VBIASN VSS.t281 VSS.t265 sg13_lv_nmos ad=1.33p pd=7.38u as=0 ps=0 w=7u l=7u
X715 a_7390_1044# a_3747_1047.t8 a_9675_1044# VSS.t486 sg13_lv_nmos ad=0.2516p pd=2.16u as=0.1406p ps=1.12u w=0.74u l=0.13u
X716 VDD.t190 a_23763_1842# a_24197_1842# VDD.t0 sg13_lv_pmos ad=0.2128p pd=1.5u as=0.3808p ps=2.92u w=1.12u l=0.13u
X717 VSS.t313 DELAY_VBIASN a_8671_1842# VSS.t312 sg13_lv_nmos ad=0.2516p pd=2.16u as=0.1406p ps=1.12u w=0.74u l=0.6u
X718 VDD.t95 a_2019_1047.t8 a_7364_1008# VDD.t3 sg13_lv_pmos ad=0.3808p pd=2.92u as=0.3808p ps=2.92u w=1.12u l=0.13u
X719 VDD.t322 DELAY_VBIASP.t4 a_26911_2470# VDD.t0 sg13_lv_pmos ad=0.3808p pd=2.92u as=0.2128p ps=1.5u w=1.12u l=0.6u
X720 VSS.t58 a_14009_5084# a_14111_5227# VSS.t57 sg13_lv_nmos ad=1.45407p pd=9.445u as=0.2516p ps=2.16u w=0.74u l=0.13u
X721 VDD.t83 VSS.t617 VDD.t107 VDD.t3 sg13_lv_pmos ad=0.19p pd=1.38u as=0 ps=0 w=1u l=1u
X722 a_12471_1842# a_12233_1842# a_12363_1842# VSS.t721 sg13_lv_nmos ad=0.1406p pd=1.12u as=0.2516p ps=2.16u w=0.74u l=0.2u
X723 a_22488_1044# a_21917_1842# VDD.t8 VDD.t3 sg13_lv_pmos ad=0.2128p pd=1.5u as=0.3808p ps=2.92u w=1.12u l=0.13u
X724 VDD.t81 a_2595_311.t3 a_8745_519# VDD.t3 sg13_lv_pmos ad=0.3808p pd=2.92u as=0.3808p ps=2.92u w=1.12u l=0.13u
X725 VSS.t660 a_3171_1047.t5 a_18004_1008# VSS.t659 sg13_lv_nmos ad=0.2516p pd=2.16u as=0.2516p ps=2.16u w=0.74u l=0.13u
X726 a_6391_2470# a_6153_1842# a_6283_1842# VDD.t0 sg13_lv_pmos ad=0.2128p pd=1.5u as=0.3808p ps=2.92u w=1.12u l=0.2u
X727 a_15273_1842# a_15077_1842# VDD.t118 VDD.t0 sg13_lv_pmos ad=0.3808p pd=2.92u as=0.2128p ps=1.5u w=1.12u l=0.13u
X728 a_14235_1044# a_14025_1044# VSS.t213 VSS.t212 sg13_lv_nmos ad=0.1406p pd=1.12u as=0.1665p ps=1.19u w=0.74u l=0.13u
X729 a_6326_4590# a_6126_3816# a_5778_3367# VSS.t501 sg13_lv_nmos ad=0.42p pd=2.42u as=0.68p ps=4.68u w=2u l=1u
X730 VSS.t10 a_3747_1047.t7 a_12791_1008# VSS.t9 sg13_lv_nmos ad=0.2516p pd=2.16u as=0.2516p ps=2.16u w=0.74u l=0.13u
X731 VSS.t103 VSS.t103 VSS.t105 VSS.t104 sg13_lv_nmos ad=0.2516p pd=2.16u as=0 ps=0 w=0.74u l=0.13u
X732 a_9953_1842# a_9757_1842# VSS.t129 VSS.t128 sg13_lv_nmos ad=0.2516p pd=2.16u as=0.1406p ps=1.12u w=0.74u l=0.13u
X733 VSS.t61 a_10843_1842# a_11277_1842# VSS.t697 sg13_lv_nmos ad=0.1406p pd=1.12u as=0.2516p ps=2.16u w=0.74u l=0.13u
X734 VSS.t600 VDD.t387 VSS.t599 VSS.t598 sg13_lv_nmos ad=0.1428p pd=1.52u as=0 ps=0 w=0.42u l=1u
X735 a_10649_5878# REF_CLK VDD.t42 VDD.t1 sg13_lv_pmos ad=0.4088p pd=2.97u as=1.03698p ps=6.245u w=1.12u l=0.13u
X736 VDD.t214 a_15403_1842# a_15837_1842# VDD.t0 sg13_lv_pmos ad=0.2128p pd=1.5u as=0.3808p ps=2.92u w=1.12u l=0.13u
X737 VDD.t42 a_14009_5084# a_14111_5227# VDD.t1 sg13_lv_pmos ad=1.10612p pd=6.66u as=0.3864p ps=2.93u w=1.12u l=0.13u
X738 VSS.t565 VDD.t394 VSS.t564 VSS.t563 sg13_lv_nmos ad=0.1428p pd=1.52u as=0 ps=0 w=0.42u l=1u
X739 a_11848_1044# a_11277_1842# VSS.t63 VSS.t62 sg13_lv_nmos ad=0.1406p pd=1.12u as=0.2516p ps=2.16u w=0.74u l=0.13u
X740 a_6326_4590# a_6326_4590# VDD.t20 VDD.t1 sg13_lv_pmos ad=0.38p pd=2.38u as=0.38p ps=2.38u w=2u l=1u
X741 VDD.t217 a_4763_1842# a_5197_1842# VDD.t0 sg13_lv_pmos ad=0.2128p pd=1.5u as=0.3808p ps=2.92u w=1.12u l=0.13u
X742 VSS.t577 VDD.t392 VSS.t575 VSS.t576 sg13_lv_nmos ad=79.8f pd=0.8u as=0 ps=0 w=0.42u l=1u
X743 a_13470_1044# a_13444_1008# a_13368_1044# VDD.t3 sg13_lv_pmos ad=0.3808p pd=2.92u as=0.2128p ps=1.5u w=1.12u l=0.13u
X744 VDD.t47 a_3449_1395# a_3747_1047.t1 VDD.t3 sg13_lv_pmos ad=0.4256p pd=3u as=0.2128p ps=1.5u w=1.12u l=0.13u
X745 VSS.t114 VSS.t111 VSS.t111 VSS.t112 sg13_lv_nmos ad=0.1406p pd=1.12u as=0 ps=0 w=0.74u l=0.13u
X746 VDD.t210 a_3171_1047.t3 a_24084_1008# VDD.t3 sg13_lv_pmos ad=0.3808p pd=2.92u as=0.3808p ps=2.92u w=1.12u l=0.13u
X747 a_3449_1395# MUX_SEL0 VDD.t325 VDD.t3 sg13_lv_pmos ad=0.1596p pd=1.22u as=0.2856p ps=2.36u w=0.84u l=0.13u
X748 a_15464_3684# a_14851_5182# VDD.t373 VDD.t1 sg13_lv_pmos ad=0.4312p pd=3.01u as=0.2639p ps=1.81u w=1.12u l=0.13u
X749 a_5974_5723# a_6126_3816# VSS.t505 VSS.t504 sg13_lv_nmos ad=0.38p pd=2.38u as=0.68p ps=4.68u w=2u l=1u
X750 VDD.t296 DELAY_VBIASP.t29 a_7911_2470# VDD.t0 sg13_lv_pmos ad=0.3808p pd=2.92u as=0.2128p ps=1.5u w=1.12u l=0.6u
X751 VDD.t106 VSS.t537 VDD.t152 VDD.t3 sg13_lv_pmos ad=0.19p pd=1.38u as=0 ps=0 w=1u l=1u
X752 VDD.t24 a_6326_4590# a_6854_5986# VDD.t1 sg13_lv_pmos ad=0.38p pd=2.38u as=0.38p ps=2.38u w=2u l=1u
X753 a_10206_5835# a_10649_5878# a_9946_6305# VSS.t156 sg13_lv_nmos ad=79.8f pd=0.8u as=0.1296p ps=1.52u w=0.42u l=0.13u
X754 VDD.t363 VSS.t539 VDD.t171 VDD.t3 sg13_lv_pmos ad=0.34p pd=2.68u as=0 ps=0 w=1u l=1u
X755 a_9946_6305# a_9772_5843# VDD.t257 VDD.t1 sg13_lv_pmos ad=79.8f pd=0.8u as=0.1428p ps=1.52u w=0.42u l=0.13u
X756 a_9946_6305# a_10751_5878# a_10206_5835# VDD.t1 sg13_lv_pmos ad=0.1428p pd=1.52u as=79.8f ps=0.8u w=0.42u l=0.13u
X757 VDD.t80 a_16851_309# MUX_OUT VDD.t3 sg13_lv_pmos ad=0.7336p pd=3.55u as=0.2128p ps=1.5u w=1.12u l=0.13u
X758 VSS.t217 a_3171_311.t2 a_23945_519# VSS.t216 sg13_lv_nmos ad=0.2516p pd=2.16u as=0.2516p ps=2.16u w=0.74u l=0.13u
X759 VDD.t66 a_18117_1842# a_18585_1044# VDD.t3 sg13_lv_pmos ad=0.252p pd=1.57u as=0.3808p ps=2.92u w=1.12u l=0.13u
X760 VSS.t37 a_19637_1842# a_20105_1044# VSS.t36 sg13_lv_nmos ad=0.1665p pd=1.19u as=0.2516p ps=2.16u w=0.74u l=0.13u
X761 a_11711_2470# a_11473_1842# a_11603_1842# VDD.t0 sg13_lv_pmos ad=0.2128p pd=1.5u as=0.3808p ps=2.92u w=1.12u l=0.2u
X762 a_27671_1842# a_27433_1842# a_27563_1842# VSS.t473 sg13_lv_nmos ad=0.1406p pd=1.12u as=0.2516p ps=2.16u w=0.74u l=0.2u
X763 VSS.t238 MUX_SEL4 a_15765_463# VSS.t237 sg13_lv_nmos ad=0.2516p pd=2.16u as=0.2516p ps=2.16u w=0.74u l=0.13u
X764 a_5731_289# a_14825_519# a_13470_1044# VDD.t3 sg13_lv_pmos ad=0.3808p pd=2.92u as=0.3808p ps=2.92u w=1.12u l=0.13u
X765 a_16510_1044# a_2595_1047.t5 a_17275_1044# VSS.t408 sg13_lv_nmos ad=0.2516p pd=2.16u as=0.1406p ps=1.12u w=0.74u l=0.13u
X766 a_13045_6215# a_13019_5831# a_12849_5867# VSS.t666 sg13_lv_nmos ad=0.1406p pd=1.12u as=0.1406p ps=1.12u w=0.74u l=0.13u
X767 VSS.t299 DELAY_VBIASN a_16271_1842# VSS.t298 sg13_lv_nmos ad=0.2516p pd=2.16u as=0.1406p ps=1.12u w=0.74u l=0.6u
X768 VDD.t204 VSS.t604 VDD.t203 VDD.t3 sg13_lv_pmos ad=0.34p pd=2.68u as=0 ps=0 w=1u l=1u
X769 VDD.t209 a_3171_1047.t6 a_14964_1008# VDD.t3 sg13_lv_pmos ad=0.3808p pd=2.92u as=0.3808p ps=2.92u w=1.12u l=0.13u
X770 VDD.t218 a_10083_1842# a_10517_1842# VDD.t0 sg13_lv_pmos ad=0.2128p pd=1.5u as=0.3808p ps=2.92u w=1.12u l=0.13u
X771 VSS.t7 a_3747_1047.t2 a_27991_1008# VSS.t6 sg13_lv_nmos ad=0.2516p pd=2.16u as=0.2516p ps=2.16u w=0.74u l=0.13u
X772 a_9712_3912# a_13019_5831# DELAY_VBIASN VSS.t667 sg13_lv_nmos ad=0.136p pd=1.14u as=0.232p ps=2.08u w=0.4u l=0.2u
X773 VSS.t376 a_26043_1842# a_26477_1842# VSS.t500 sg13_lv_nmos ad=0.1406p pd=1.12u as=0.2516p ps=2.16u w=0.74u l=0.13u
X774 VSS.t512 a_6126_3816# a_5974_5723# VSS.t504 sg13_lv_nmos ad=0.68p pd=4.68u as=0.38p ps=2.38u w=2u l=1u
X775 a_11195_1044# a_10985_1044# VDD.t139 VDD.t3 sg13_lv_pmos ad=0.2128p pd=1.5u as=0.252p ps=1.57u w=1.12u l=0.13u
X776 VSS.t526 a_3747_1047.t9 a_6711_1008# VSS.t525 sg13_lv_nmos ad=0.2516p pd=2.16u as=0.2516p ps=2.16u w=0.74u l=0.13u
X777 a_9444_4590# a_6854_5454# a_6854_5454# VSS.t679 sg13_lv_nmos ad=0.68p pd=4.68u as=0.38p ps=2.38u w=2u l=1u
X778 a_16108_289# a_2595_311.t2 a_19550_1044# VSS.t469 sg13_lv_nmos ad=0.2516p pd=2.16u as=0.2516p ps=2.16u w=0.74u l=0.13u
X779 VSS.t323 DELAY_VBIASN a_20071_1842# VSS.t322 sg13_lv_nmos ad=0.2516p pd=2.16u as=0.1406p ps=1.12u w=0.74u l=0.6u
X780 VDD.t315 DELAY_VBIASP.t7 a_24631_2470# VDD.t0 sg13_lv_pmos ad=0.3808p pd=2.92u as=0.2128p ps=1.5u w=1.12u l=0.6u
X781 a_22590_1044# a_23431_1008# a_23355_1044# VDD.t3 sg13_lv_pmos ad=0.3808p pd=2.92u as=0.2128p ps=1.5u w=1.12u l=0.13u
X782 VSS.t557 VDD.t396 VSS.t555 VSS.t556 sg13_lv_nmos ad=79.8f pd=0.8u as=0 ps=0 w=0.42u l=1u
X783 a_10458_6292# DLL_RESETN VSS.t343 VSS.t342 sg13_lv_nmos ad=37.8f pd=0.6u as=0.1701p ps=1.65u w=0.42u l=0.13u
X784 a_11491_6228# a_10649_5878# a_10232_5871# VDD.t1 sg13_lv_pmos ad=0.2048p pd=1.63u as=0.34p ps=2.68u w=1u l=0.13u
X785 VSS.t510 a_6126_3816# a_5974_5723# VSS.t504 sg13_lv_nmos ad=0.76p pd=4.76u as=0.38p ps=2.38u w=2u l=1u
X786 a_8671_1842# a_8433_1842# a_8563_1842# VSS.t689 sg13_lv_nmos ad=0.1406p pd=1.12u as=0.2516p ps=2.16u w=0.74u l=0.2u
X787 a_17553_1842# a_17357_1842# VSS.t630 VSS.t631 sg13_lv_nmos ad=0.2516p pd=2.16u as=0.1406p ps=1.12u w=0.74u l=0.13u
X788 a_5731_289# a_5705_519# a_4350_1044# VDD.t3 sg13_lv_pmos ad=0.3808p pd=2.92u as=0.3808p ps=2.92u w=1.12u l=0.13u
X789 VDD.t281 VDD.t279 VDD.t280 VDD.t0 sg13_lv_pmos ad=0.3808p pd=2.92u as=0 ps=0 w=1.12u l=0.13u
X790 a_26911_2470# a_26673_1842# a_26803_1842# VDD.t0 sg13_lv_pmos ad=0.2128p pd=1.5u as=0.3808p ps=2.92u w=1.12u l=0.2u
X791 a_7390_1044# a_2019_1047.t8 a_7288_1044# VSS.t194 sg13_lv_nmos ad=0.2516p pd=2.16u as=0.1406p ps=1.12u w=0.74u l=0.13u
X792 a_13566_5328# a_14009_5084# a_13306_5105# VSS.t56 sg13_lv_nmos ad=79.8f pd=0.8u as=0.1296p ps=1.52u w=0.42u l=0.13u
X793 a_21353_1842# a_21157_1842# VSS.t358 VSS.t494 sg13_lv_nmos ad=0.2516p pd=2.16u as=0.1406p ps=1.12u w=0.74u l=0.13u
X794 VSS.t153 a_7043_1842# a_7477_1842# VSS.t152 sg13_lv_nmos ad=0.1406p pd=1.12u as=0.2516p ps=2.16u w=0.74u l=0.13u
X795 a_13121_5831# a_15688_5867# VDD.t27 VDD.t1 sg13_lv_pmos ad=0.3808p pd=2.92u as=0.2128p ps=1.5u w=1.12u l=0.13u
X796 VDD.t310 DELAY_VBIASP.t19 a_15511_2470# VDD.t0 sg13_lv_pmos ad=0.3808p pd=2.92u as=0.2128p ps=1.5u w=1.12u l=0.6u
X797 VDD.t197 a_2019_1047.t7 a_10404_1008# VDD.t3 sg13_lv_pmos ad=0.3808p pd=2.92u as=0.3808p ps=2.92u w=1.12u l=0.13u
X798 VSS.t178 a_9444_4590# a_9444_3912# VSS.t170 sg13_lv_nmos ad=0.68p pd=4.68u as=0.38p ps=2.38u w=2u l=1u
X799 VDD.t178 a_25283_1842# a_25717_1842# VDD.t0 sg13_lv_pmos ad=0.2128p pd=1.5u as=0.3808p ps=2.92u w=1.12u l=0.13u
X800 VDD.t291 DELAY_VBIASP.t32 a_5631_2470# VDD.t0 sg13_lv_pmos ad=0.3808p pd=2.92u as=0.2128p ps=1.5u w=1.12u l=0.6u
X801 a_26395_1044# a_26185_1044# VDD.t244 VDD.t3 sg13_lv_pmos ad=0.2128p pd=1.5u as=0.252p ps=1.57u w=1.12u l=0.13u
X802 a_13306_5105# a_14111_5227# a_13566_5328# VDD.t1 sg13_lv_pmos ad=0.1428p pd=1.52u as=79.8f ps=0.8u w=0.42u l=0.13u
X803 a_6326_4590# a_6126_3816# a_5778_3367# VSS.t501 sg13_lv_nmos ad=0.38p pd=2.38u as=0.68p ps=4.68u w=2u l=1u
X804 VDD.t188 a_3747_1047.t3 a_24951_1008# VDD.t3 sg13_lv_pmos ad=0.3808p pd=2.92u as=0.3808p ps=2.92u w=1.12u l=0.13u
X805 VDD.t201 VSS.t597 VDD.t200 VDD.t3 sg13_lv_pmos ad=0.19p pd=1.38u as=0 ps=0 w=1u l=1u
X806 a_13991_1842# a_13753_1842# a_13883_1842# VSS.t55 sg13_lv_nmos ad=0.1406p pd=1.12u as=0.2516p ps=2.16u w=0.74u l=0.2u
X807 a_24008_1044# a_23437_1842# VDD.t111 VDD.t3 sg13_lv_pmos ad=0.2128p pd=1.5u as=0.3808p ps=2.92u w=1.12u l=0.13u
X808 VDD.t177 VSS.t562 VDD.t176 VDD.t3 sg13_lv_pmos ad=0.19p pd=1.38u as=0 ps=0 w=1u l=1u
X809 VSS.t433 a_2019_1047.t4 a_19524_1008# VSS.t432 sg13_lv_nmos ad=0.2516p pd=2.16u as=0.2516p ps=2.16u w=0.74u l=0.13u
X810 a_9712_3912# a_6854_5454# a_9444_3912# VSS.t678 sg13_lv_nmos ad=0.38p pd=2.38u as=0.68p ps=4.68u w=2u l=1u
X811 a_7911_2470# a_7673_1842# a_7803_1842# VDD.t0 sg13_lv_pmos ad=0.2128p pd=1.5u as=0.3808p ps=2.92u w=1.12u l=0.2u
X812 a_16793_1842# a_16597_1842# VDD.t36 VDD.t0 sg13_lv_pmos ad=0.3808p pd=2.92u as=0.2128p ps=1.5u w=1.12u l=0.13u
X813 VSS.t69 MUX_SEL1 a_3543_1395# VSS.t79 sg13_lv_nmos ad=0.1331p pd=1.12u as=0.1216p ps=1.02u w=0.64u l=0.13u
X814 a_15755_1044# a_15545_1044# VSS.t636 VSS.t650 sg13_lv_nmos ad=0.1406p pd=1.12u as=0.1665p ps=1.19u w=0.74u l=0.13u
X815 a_13818_5118# a_12849_5867# VSS.t713 VSS.t712 sg13_lv_nmos ad=37.8f pd=0.6u as=0.1701p ps=1.65u w=0.42u l=0.13u
X816 a_2595_1047.t1 a_2297_1395# VDD.t129 VDD.t3 sg13_lv_pmos ad=0.2128p pd=1.5u as=0.1918p ps=1.5u w=1.12u l=0.13u
X817 VSS.t51 a_2595_1047.t6 a_14311_1008# VSS.t50 sg13_lv_nmos ad=0.2516p pd=2.16u as=0.2516p ps=2.16u w=0.74u l=0.13u
X818 VSS.t24 a_12363_1842# a_12797_1842# VSS.t206 sg13_lv_nmos ad=0.1406p pd=1.12u as=0.2516p ps=2.16u w=0.74u l=0.13u
X819 a_5115_1044# a_4905_1044# VSS.t73 VSS.t459 sg13_lv_nmos ad=0.1406p pd=1.12u as=0.1665p ps=1.19u w=0.74u l=0.13u
X820 a_1256_1044# MUX_SEL0 VDD.t326 VDD.t3 sg13_lv_pmos ad=0.3808p pd=2.92u as=0.3808p ps=2.92u w=1.12u l=0.13u
X821 a_9444_3912# a_9444_4590# VSS.t176 VSS.t168 sg13_lv_nmos ad=0.38p pd=2.38u as=0.68p ps=4.68u w=2u l=1u
X822 VSS.t276 DELAY_VBIASN VSS.t274 VSS.t255 sg13_lv_nmos ad=1.33p pd=7.38u as=0 ps=0 w=7u l=7u
X823 VDD.t70 a_27563_1842# a_27997_1842# VDD.t0 sg13_lv_pmos ad=0.2128p pd=1.5u as=0.3808p ps=2.92u w=1.12u l=0.13u
X824 a_20593_1842# a_20397_1842# VDD.t88 VDD.t0 sg13_lv_pmos ad=0.3808p pd=2.92u as=0.2128p ps=1.5u w=1.12u l=0.13u
X825 a_1721_1395# a_1256_1044# VDD.t138 VDD.t3 sg13_lv_pmos ad=0.1596p pd=1.22u as=0.2856p ps=2.36u w=0.84u l=0.13u
X826 VDD.t212 a_6283_1842# a_6717_1842# VDD.t0 sg13_lv_pmos ad=0.2128p pd=1.5u as=0.3808p ps=2.92u w=1.12u l=0.13u
X827 a_13470_1044# a_14964_1008# a_14888_1044# VDD.t3 sg13_lv_pmos ad=0.3808p pd=2.92u as=0.2128p ps=1.5u w=1.12u l=0.13u
X828 a_13592_5871# a_13566_5835# VDD.t6 VDD.t1 sg13_lv_pmos ad=0.34p pd=2.68u as=0.36237p ps=2.605u w=1u l=0.13u
X829 a_5778_3367# a_6126_3816# a_6326_4590# VSS.t501 sg13_lv_nmos ad=0.68p pd=4.68u as=0.42p ps=2.42u w=2u l=1u
X830 VSS.t575 VDD.t392 VSS.t574 VSS.t573 sg13_lv_nmos ad=0.1428p pd=1.52u as=0 ps=0 w=0.42u l=1u
X831 VDD.t37 a_2019_1047.t2 a_25604_1008# VDD.t3 sg13_lv_pmos ad=0.3808p pd=2.92u as=0.3808p ps=2.92u w=1.12u l=0.13u
X832 a_9746_5805# a_9547_5942# VSS.t163 VSS.t341 sg13_lv_nmos ad=0.27427p pd=2.28u as=2.39977p ps=15.495u w=0.795u l=0.13u
X833 a_16271_1842# a_16033_1842# a_16163_1842# VSS.t720 sg13_lv_nmos ad=0.1406p pd=1.12u as=0.2516p ps=2.16u w=0.74u l=0.2u
X834 a_21835_1044# a_21625_1044# VDD.t101 VDD.t3 sg13_lv_pmos ad=0.2128p pd=1.5u as=0.252p ps=1.57u w=1.12u l=0.13u
X835 VDD.t106 VSS.t534 VDD.t105 VDD.t3 sg13_lv_pmos ad=0.34p pd=2.68u as=0 ps=0 w=1u l=1u
X836 VDD.t361 a_2595_1047.t4 a_20391_1008# VDD.t3 sg13_lv_pmos ad=0.3808p pd=2.92u as=0.3808p ps=2.92u w=1.12u l=0.13u
X837 VSS.t685 a_14851_5182# a_15688_5403# VSS.t705 sg13_lv_nmos ad=0.1406p pd=1.12u as=0.2516p ps=2.16u w=0.74u l=0.13u
X838 a_19073_1842# a_18877_1842# VDD.t175 VDD.t0 sg13_lv_pmos ad=0.3808p pd=2.92u as=0.2128p ps=1.5u w=1.12u l=0.13u
X839 VDD.t139 a_10517_1842# a_10985_1044# VDD.t3 sg13_lv_pmos ad=0.252p pd=1.57u as=0.3808p ps=2.92u w=1.12u l=0.13u
X840 VSS.t208 a_21157_1842# a_21625_1044# VSS.t493 sg13_lv_nmos ad=0.1665p pd=1.19u as=0.2516p ps=2.16u w=0.74u l=0.13u
X841 VSS.t12 a_12849_5867# a_13400_6305# VSS.t11 sg13_lv_nmos ad=0.1626p pd=1.415u as=60.89999f ps=0.71u w=0.42u l=0.13u
X842 VSS.t503 a_6126_3816# a_6126_3816# VSS.t501 sg13_lv_nmos ad=0.68p pd=4.68u as=0.38p ps=2.38u w=2u l=1u
X843 a_20071_1842# a_19833_1842# a_19963_1842# VSS.t161 sg13_lv_nmos ad=0.1406p pd=1.12u as=0.2516p ps=2.16u w=0.74u l=0.2u
X844 VSS.t97 VSS.t95 VSS.t95 VSS.t96 sg13_lv_nmos ad=0.68p pd=4.68u as=0 ps=0 w=2u l=1u
X845 VSS.t240 a_14643_1842# a_15077_1842# VSS.t239 sg13_lv_nmos ad=0.1406p pd=1.12u as=0.2516p ps=2.16u w=0.74u l=0.13u
X846 a_1815_331# a_1256_289# a_1721_331# VSS.t675 sg13_lv_nmos ad=0.1216p pd=1.02u as=0.2176p ps=1.96u w=0.64u l=0.13u
X847 VDD.t263 VDD.t261 VDD.t16 VDD.t1 sg13_lv_pmos ad=0.38p pd=2.38u as=0 ps=0 w=2u l=1u
X848 VDD.t33 a_19203_1842# a_19637_1842# VDD.t0 sg13_lv_pmos ad=0.2128p pd=1.5u as=0.3808p ps=2.92u w=1.12u l=0.13u
X849 VSS.t709 a_2019_1047.t9 a_4324_1008# VSS.t708 sg13_lv_nmos ad=0.2516p pd=2.16u as=0.2516p ps=2.16u w=0.74u l=0.13u
X850 a_16108_289# a_20905_519# a_19550_1044# VDD.t3 sg13_lv_pmos ad=0.3808p pd=2.92u as=0.3808p ps=2.92u w=1.12u l=0.13u
X851 a_16510_1044# a_3747_1047.t5 a_18795_1044# VSS.t86 sg13_lv_nmos ad=0.2516p pd=2.16u as=0.1406p ps=1.12u w=0.74u l=0.13u
X852 VDD.t82 a_8563_1842# a_8997_1842# VDD.t0 sg13_lv_pmos ad=0.2128p pd=1.5u as=0.3808p ps=2.92u w=1.12u l=0.13u
X853 VDD.t305 DELAY_VBIASP.t22 a_13231_2470# VDD.t0 sg13_lv_pmos ad=0.3808p pd=2.92u as=0.2128p ps=1.5u w=1.12u l=0.6u
X854 VSS.t247 DELAY_VBIASN a_17791_1842# VSS.t246 sg13_lv_nmos ad=0.2516p pd=2.16u as=0.1406p ps=1.12u w=0.74u l=0.6u
X855 VSS.t545 VDD.t398 VSS.t544 VSS.t543 sg13_lv_nmos ad=0.1428p pd=1.52u as=0 ps=0 w=0.42u l=1u
X856 a_6854_5986# a_6326_4590# VDD.t22 VDD.t1 sg13_lv_pmos ad=0.38p pd=2.38u as=0.38p ps=2.38u w=2u l=1u
X857 VDD.t276 VDD.t274 VDD.t275 VDD.t58 sg13_lv_pmos ad=0.3808p pd=2.92u as=0 ps=0 w=1.12u l=0.13u
X858 VDD.t56 a_3747_1047.t5 a_18871_1008# VDD.t3 sg13_lv_pmos ad=0.3808p pd=2.92u as=0.3808p ps=2.92u w=1.12u l=0.13u
X859 VDD.t271 VDD.t272 VDD.t273 VDD.t58 sg13_lv_pmos ad=0.2128p pd=1.5u as=0 ps=0 w=1.12u l=0.13u
X860 VDD.t112 a_23003_1842# a_23437_1842# VDD.t0 sg13_lv_pmos ad=0.2128p pd=1.5u as=0.3808p ps=2.92u w=1.12u l=0.13u
X861 VSS.t171 a_9444_4590# a_9444_4590# VSS.t170 sg13_lv_nmos ad=0.68p pd=4.68u as=0.38p ps=2.38u w=2u l=1u
X862 VSS.t100 VSS.t92 VSS.t92 VSS.t93 sg13_lv_nmos ad=0.68p pd=4.68u as=0 ps=0 w=2u l=1u
X863 a_12715_1044# a_12505_1044# VDD.t329 VDD.t3 sg13_lv_pmos ad=0.2128p pd=1.5u as=0.252p ps=1.57u w=1.12u l=0.13u
X864 a_19550_1044# a_21044_1008# a_20968_1044# VDD.t3 sg13_lv_pmos ad=0.3808p pd=2.92u as=0.2128p ps=1.5u w=1.12u l=0.13u
X865 a_17928_1044# a_17357_1842# VDD.t332 VDD.t3 sg13_lv_pmos ad=0.2128p pd=1.5u as=0.3808p ps=2.92u w=1.12u l=0.13u
X866 VSS.t327 DELAY_VBIASN a_21591_1842# VSS.t326 sg13_lv_nmos ad=0.2516p pd=2.16u as=0.1406p ps=1.12u w=0.74u l=0.6u
X867 VSS.t28 a_1544_289# a_1815_331# VSS.t27 sg13_lv_nmos ad=0.1331p pd=1.12u as=0.1216p ps=1.02u w=0.64u l=0.13u
X868 a_7288_1044# a_6717_1842# VDD.t211 VDD.t3 sg13_lv_pmos ad=0.2128p pd=1.5u as=0.3808p ps=2.92u w=1.12u l=0.13u
X869 VSS.t262 DELAY_VBIASN VSS.t264 VSS.t263 sg13_lv_nmos ad=1.33p pd=7.38u as=0 ps=0 w=7u l=7u
X870 a_5974_5723# a_6126_3816# VSS.t511 VSS.t504 sg13_lv_nmos ad=0.38p pd=2.38u as=0.68p ps=4.68u w=2u l=1u
X871 a_15511_2470# a_15273_1842# a_15403_1842# VDD.t0 sg13_lv_pmos ad=0.2128p pd=1.5u as=0.3808p ps=2.92u w=1.12u l=0.2u
X872 VSS.t123 VSS.t124 VSS.t123 VSS.t125 sg13_lv_nmos ad=0.1406p pd=1.12u as=0 ps=0 w=0.74u l=0.2u
X873 a_22590_1044# a_24951_1008# a_24875_1044# VDD.t3 sg13_lv_pmos ad=0.3808p pd=2.92u as=0.2128p ps=1.5u w=1.12u l=0.13u
X874 VSS.t614 VDD.t384 VSS.t617 VSS.t616 sg13_lv_nmos ad=79.8f pd=0.8u as=0 ps=0 w=0.42u l=1u
X875 VSS.t388 a_15108_5325# a_14757_5182# VSS.t387 sg13_lv_nmos ad=79.8f pd=0.8u as=0.1428p ps=1.52u w=0.42u l=0.13u
X876 a_10430_1044# a_2019_1047.t7 a_10328_1044# VSS.t434 sg13_lv_nmos ad=0.2516p pd=2.16u as=0.1406p ps=1.12u w=0.74u l=0.13u
X877 VDD.t366 a_5974_5723# a_5974_5723# VDD.t1 sg13_lv_pmos ad=0.2448p pd=2.08u as=0.2826p ps=2.29u w=0.36u l=2u
X878 VDD.t244 a_25717_1842# a_26185_1044# VDD.t3 sg13_lv_pmos ad=0.252p pd=1.57u as=0.3808p ps=2.92u w=1.12u l=0.13u
X879 a_6854_5454# a_6854_5454# a_9444_4590# VSS.t678 sg13_lv_nmos ad=0.38p pd=2.38u as=0.68p ps=4.68u w=2u l=1u
X880 VDD.t53 a_13883_1842# a_14317_1842# VDD.t0 sg13_lv_pmos ad=0.2128p pd=1.5u as=0.3808p ps=2.92u w=1.12u l=0.13u
X881 VDD.t48 a_4437_1842# a_4905_1044# VDD.t3 sg13_lv_pmos ad=0.252p pd=1.57u as=0.3808p ps=2.92u w=1.12u l=0.13u
X882 a_4157_1313# REF_CLK VSS.t136 VSS.t135 sg13_lv_nmos ad=0.2516p pd=2.16u as=0.2553p ps=2.17u w=0.74u l=0.13u
X883 a_7390_1044# a_3171_1047.t8 a_8808_1044# VSS.t661 sg13_lv_nmos ad=0.2516p pd=2.16u as=0.1406p ps=1.12u w=0.74u l=0.13u
X884 a_22873_1842# a_22677_1842# VSS.t351 VSS.t350 sg13_lv_nmos ad=0.2516p pd=2.16u as=0.1406p ps=1.12u w=0.74u l=0.13u
X885 a_9444_4590# a_9444_4590# VSS.t169 VSS.t168 sg13_lv_nmos ad=0.38p pd=2.38u as=0.68p ps=4.68u w=2u l=1u
X886 VDD.t349 a_3171_1047.t8 a_8884_1008# VDD.t3 sg13_lv_pmos ad=0.3808p pd=2.92u as=0.3808p ps=2.92u w=1.12u l=0.13u
C0 a_7477_1842# VDD 0.93609f
C1 a_13368_1044# VDD 0.18232f
C2 a_4633_1842# DELAY_VBIASN 0.09305f
C3 a_4437_1842# DELAY_VBIASP 0.03915f
C4 a_15765_463# a_16108_289# 0.42004f
C5 a_7390_1044# MUX_SEL4 0.11061f
C6 a_14851_5182# a_15688_5403# 0.08776f
C7 a_10985_1044# a_10430_1044# 0.03209f
C8 a_4350_1044# a_5768_1044# 0.38994f
C9 a_27237_1842# a_26803_1842# 0.6972f
C10 a_10649_5878# VDD 0.24968f
C11 a_25630_1044# a_26985_519# 0.018f
C12 a_16851_309# MUX_OUT 0.45865f
C13 a_18117_1842# a_18313_1842# 0.72625f
C14 a_21917_1842# a_22564_1008# 0.02011f
C15 a_12656_5864# a_13019_5831# 0.04193f
C16 a_12355_5867# a_13121_5831# 0.05795f
C17 a_23437_1842# VDD 0.93774f
C18 a_1256_289# MUX_OUT 0.1134f
C19 a_20397_1842# DELAY_VBIASP 0.03914f
C20 a_2297_331# MUX_SEL2 0.10655f
C21 a_1544_289# MUX_SEL4 0.47529f
C22 a_20593_1842# DELAY_VBIASN 0.09436f
C23 a_27705_1044# a_27991_1008# 0.01885f
C24 a_12037_1842# a_11924_1008# 0.02055f
C25 a_15755_1044# a_15831_1008# 0.01194f
C26 a_26043_1842# a_26151_1842# 0.01163f
C27 a_8997_1842# a_9757_1842# 0.02577f
C28 a_10430_1044# VDD 2.01462f
C29 a_4763_1842# VDD 0.85902f
C30 a_7945_1044# a_8231_1008# 0.01885f
C31 a_13592_5423# a_14851_5182# 0.01529f
C32 a_25913_1842# a_26477_1842# 0.0114f
C33 a_9547_5942# VDD 0.16041f
C34 a_25630_1044# a_27048_1044# 0.38994f
C35 a_16793_1842# a_16923_1842# 0.69911f
C36 a_21157_1842# a_21044_1008# 0.02055f
C37 a_13566_5835# REF_CLK 0.01538f
C38 a_20723_1842# VDD 0.85925f
C39 a_18877_1842# DELAY_VBIASN 0.07573f
C40 a_17683_1842# DELAY_VBIASP 0.06316f
C41 MUX_SEL2 MUX_SEL4 0.01978f
C42 a_8237_1842# a_7803_1842# 0.6972f
C43 a_18117_1842# a_18585_1044# 0.2079f
C44 a_13470_1044# a_14964_1008# 0.28279f
C45 a_24523_1842# a_24631_1842# 0.01163f
C46 a_26185_1044# a_25630_1044# 0.03209f
C47 a_14235_1044# a_14311_1008# 0.01194f
C48 a_11277_1842# a_10430_1044# 0.08038f
C49 a_7364_1008# VDD 0.28964f
C50 a_15304_4605# a_14851_5182# 0.05156f
C51 a_24957_1842# a_25717_1842# 0.05863f
C52 a_6425_1044# a_6635_1044# 0.09424f
C53 a_13566_5328# a_13592_5423# 0.36952f
C54 a_20905_519# VDD 0.30044f
C55 a_20397_1842# a_19550_1044# 0.08038f
C56 a_10751_5878# a_11748_6109# 0.03061f
C57 a_10649_5878# a_11397_6228# 0.01058f
C58 a_12355_5867# REF_CLK 1.0042f
C59 a_1721_331# VDD 0.45834f
C60 a_12656_5864# DLL_RESETN 0.11782f
C61 a_19073_1842# VDD 0.71046f
C62 a_16033_1842# DELAY_VBIASP 0.11008f
C63 a_16163_1842# DELAY_VBIASN 0.06961f
C64 a_23003_1842# a_23111_1842# 0.01163f
C65 a_9757_1842# a_9751_1008# 0.02354f
C66 a_6913_1842# a_7477_1842# 0.0114f
C67 a_23145_1044# a_23431_1008# 0.01885f
C68 a_5115_1044# VDD 0.15466f
C69 a_15108_5325# VDD 0.14081f
C70 a_24197_1842# a_23763_1842# 0.6972f
C71 a_13106_5357# a_12907_5420# 0.14994f
C72 a_4157_1313# a_4350_1044# 0.04456f
C73 a_24631_2470# VDD 0.02372f
C74 a_18877_1842# a_18871_1008# 0.02354f
C75 a_15077_1842# a_15273_1842# 0.72625f
C76 a_9946_6305# a_10751_5878# 0.097f
C77 a_22590_1044# a_24875_1044# 0.39036f
C78 a_10232_5871# a_10649_5878# 0.37583f
C79 a_10751_5878# DLL_RESETN 0.45018f
C80 a_26395_1044# VDD 0.15466f
C81 a_17357_1842# VDD 0.93774f
C82 a_14317_1842# DELAY_VBIASP 0.03961f
C83 a_14513_1842# DELAY_VBIASN 0.09371f
C84 VDD MUX_SEL3 0.40997f
C85 a_8237_1842# a_8884_1008# 0.02312f
C86 a_21483_1842# a_21591_1842# 0.01163f
C87 a_27563_1842# a_27671_2470# 0.01697f
C88 a_10430_1044# a_12791_1008# 0.26208f
C89 a_5957_1842# a_6717_1842# 0.02577f
C90 a_23145_1044# VDD 0.30542f
C91 a_13306_5105# VDD 0.80534f
C92 a_22873_1842# a_23437_1842# 0.0114f
C93 a_16510_1044# a_16108_289# 0.43331f
C94 a_18551_2470# VDD 0.02372f
C95 a_9772_5843# a_9946_6305# 0.27179f
C96 a_17357_1842# a_18004_1008# 0.02312f
C97 a_13753_1842# a_13883_1842# 0.69911f
C98 a_9772_5843# DLL_RESETN 0.06592f
C99 a_23431_1008# VDD 0.28469f
C100 a_14643_1842# VDD 0.85929f
C101 a_11603_1842# DELAY_VBIASP 0.06316f
C102 a_12797_1842# DELAY_VBIASN 0.07392f
C103 a_26043_1842# a_26151_2470# 0.01697f
C104 a_5197_1842# a_4763_1842# 0.6972f
C105 a_7477_1842# a_7390_1044# 0.1088f
C106 a_19963_1842# a_20071_1842# 0.01163f
C107 a_10328_1044# a_10430_1044# 0.37183f
C108 a_10985_1044# VDD 0.30542f
C109 a_2297_1395# MUX_SEL0 0.10655f
C110 a_12849_5867# a_13592_5423# 0.38072f
C111 a_26477_1842# a_27124_1008# 0.02312f
C112 a_21917_1842# a_22677_1842# 0.05863f
C113 a_5864_3367# DLL_RESETN 0.01688f
C114 a_12471_2470# VDD 0.02372f
C115 a_9712_3912# REF_CLK 0.04752f
C116 a_27563_1842# DELAY_VBIASP 0.06318f
C117 a_16597_1842# a_16510_1044# 0.1088f
C118 a_20968_1044# VDD 0.17577f
C119 a_12993_1842# VDD 0.71046f
C120 a_9953_1842# DELAY_VBIASP 0.11005f
C121 a_10083_1842# DELAY_VBIASN 0.06808f
C122 a_18585_1044# a_16510_1044# 0.03208f
C123 a_18443_1842# a_18551_1842# 0.01163f
C124 a_24523_1842# a_24631_2470# 0.01697f
C125 a_8808_1044# a_8884_1008# 0.01176f
C126 a_13019_5831# DELAY_OUT_LAST 0.07707f
C127 a_25717_1842# a_25630_1044# 0.1088f
C128 a_13592_5871# a_14851_6228# 0.01529f
C129 a_6126_3816# a_9444_3912# 0.25721f
C130 a_6854_5986# a_9712_3912# 0.03156f
C131 a_6854_5454# a_5778_3367# 0.02497f
C132 a_21157_1842# a_20723_1842# 0.6972f
C133 a_5974_5723# a_5864_3367# 0.01697f
C134 a_12849_5867# a_15304_4605# 0.0606f
C135 a_6391_2470# VDD 0.02372f
C136 a_25913_1842# DELAY_VBIASP 0.11005f
C137 a_26043_1842# DELAY_VBIASN 0.0697f
C138 a_6326_4590# a_5974_5723# 0.32939f
C139 a_19448_1044# a_19524_1008# 0.01176f
C140 a_12037_1842# a_12233_1842# 0.72625f
C141 a_18004_1008# VDD 0.28358f
C142 a_11277_1842# VDD 0.93774f
C143 a_8433_1842# DELAY_VBIASN 0.09305f
C144 a_8237_1842# DELAY_VBIASP 0.03914f
C145 a_16923_1842# a_17031_1842# 0.01163f
C146 a_23003_1842# a_23111_2470# 0.01697f
C147 a_7390_1044# a_7364_1008# 0.277f
C148 a_1721_1395# VDD 0.46949f
C149 a_13306_6305# VDD 0.78103f
C150 a_13566_5835# a_14009_5878# 0.02242f
C151 a_19833_1842# a_20397_1842# 0.0114f
C152 a_13121_5831# a_14111_5878# 0.0235f
C153 a_27237_1842# VDD 0.92838f
C154 a_24197_1842# DELAY_VBIASP 0.03915f
C155 a_24393_1842# DELAY_VBIASN 0.09602f
C156 a_10713_1842# a_10843_1842# 0.69911f
C157 a_4350_1044# a_5731_289# 0.40909f
C158 a_6717_1842# DELAY_VBIASN 0.07392f
C159 a_5523_1842# DELAY_VBIASP 0.06316f
C160 a_8563_1842# VDD 0.85925f
C161 a_15755_1044# VDD 0.15466f
C162 a_16108_289# a_26985_519# 0.27952f
C163 a_12505_1044# a_12715_1044# 0.09424f
C164 a_9444_4590# a_9712_3912# 0.57573f
C165 a_15403_1842# a_15511_1842# 0.01163f
C166 a_21483_1842# a_21591_2470# 0.01697f
C167 a_15688_5403# a_15464_3684# 0.19544f
C168 REF_CLK DELAY_VBIASN 0.06978f
C169 a_1256_289# a_2297_331# 0.04261f
C170 a_1544_289# a_1721_331# 0.36963f
C171 a_18877_1842# a_19637_1842# 0.05863f
C172 a_21483_1842# DELAY_VBIASP 0.06316f
C173 a_13106_5357# DLL_RESETN 0.01263f
C174 a_22677_1842# DELAY_VBIASN 0.07499f
C175 a_24523_1842# VDD 0.85903f
C176 a_16510_1044# a_17275_1044# 0.39037f
C177 a_5864_3367# DELAY_VBIASP 0.02026f
C178 a_6913_1842# VDD 0.71046f
C179 a_12791_1008# VDD 0.29225f
C180 a_4003_1842# DELAY_VBIASN 0.06129f
C181 a_15765_463# a_15964_289# 0.061f
C182 a_14009_5084# a_14757_5182# 0.01058f
C183 a_26673_1842# a_26803_1842# 0.69911f
C184 a_19963_1842# a_20071_2470# 0.01697f
C185 a_13883_1842# a_13991_1842# 0.01163f
C186 a_4350_1044# a_5191_1008# 0.28268f
C187 a_14851_5182# a_15108_5325# 0.29858f
C188 a_10232_5871# VDD 0.09601f
C189 a_6854_5986# DELAY_VBIASN 0.15808f
C190 a_16108_289# MUX_OUT 0.24265f
C191 a_18117_1842# a_17683_1842# 0.6972f
C192 a_12355_5867# a_13019_5831# 0.3846f
C193 a_14111_5878# REF_CLK 0.02263f
C194 a_19833_1842# DELAY_VBIASP 0.11005f
C195 a_19963_1842# DELAY_VBIASN 0.0697f
C196 a_4157_1313# REF_CLK 0.45375f
C197 a_22873_1842# VDD 0.70915f
C198 a_1544_289# MUX_SEL3 0.15976f
C199 a_1256_289# MUX_SEL4 0.65005f
C200 a_1721_331# MUX_SEL2 0.01315f
C201 a_8997_1842# a_9193_1842# 0.72625f
C202 a_27705_1044# a_27915_1044# 0.09424f
C203 a_19637_1842# a_20105_1044# 0.19203f
C204 a_5197_1842# VDD 0.93774f
C205 a_4350_1044# MUX_SEL4 0.09136f
C206 a_10328_1044# VDD 0.18236f
C207 a_18443_1842# a_18551_2470# 0.01697f
C208 a_7945_1044# a_8155_1044# 0.09424f
C209 a_12363_1842# a_12471_1842# 0.01163f
C210 a_4437_1842# a_4905_1044# 0.19203f
C211 a_6854_5454# VDD 1.80901f
C212 a_25630_1044# a_26471_1008# 0.28268f
C213 a_16793_1842# a_17357_1842# 0.0114f
C214 a_21157_1842# VDD 0.92718f
C215 a_18117_1842# DELAY_VBIASP 0.03915f
C216 a_18313_1842# DELAY_VBIASN 0.09602f
C217 MUX_SEL2 MUX_SEL3 3.21891f
C218 a_13470_1044# a_14888_1044# 0.38994f
C219 a_7673_1842# a_7803_1842# 0.69911f
C220 a_7390_1044# VDD 2.01762f
C221 a_13566_5328# a_13306_5105# 0.75507f
C222 a_24957_1842# a_25153_1842# 0.72407f
C223 a_16923_1842# a_17031_2470# 0.01697f
C224 a_10843_1842# a_10951_1842# 0.01163f
C225 a_17865_519# VDD 0.30196f
C226 a_24875_1044# a_24951_1008# 0.01194f
C227 a_15837_1842# a_16597_1842# 0.05863f
C228 a_10232_5871# a_11397_6228# 0.43239f
C229 a_16597_1842# DELAY_VBIASN 0.07499f
C230 a_18443_1842# VDD 0.85903f
C231 a_1544_289# VDD 0.39668f
C232 a_12355_5867# DLL_RESETN 0.04879f
C233 a_15403_1842# DELAY_VBIASP 0.06323f
C234 DELAY_OUT_LAST DELAY_VBIASP 1.34214f
C235 a_23145_1044# a_23355_1044# 0.09424f
C236 a_14851_5182# VDD 0.27539f
C237 a_4324_1008# VDD 0.28929f
C238 a_13106_5357# a_12907_5186# 0.02437f
C239 a_15403_1842# a_15511_2470# 0.01697f
C240 a_4157_1313# a_4248_1044# 0.11511f
C241 a_9323_1842# a_9431_1842# 0.01163f
C242 a_13019_5831# a_9712_3912# 0.03275f
C243 a_23633_1842# a_23763_1842# 0.69911f
C244 a_23871_2470# VDD 0.02372f
C245 a_15077_1842# a_14643_1842# 0.6972f
C246 a_22590_1044# a_24084_1008# 0.28279f
C247 a_23355_1044# a_23431_1008# 0.01194f
C248 a_9946_6305# a_10520_6292# 0.31978f
C249 a_10206_5835# a_10649_5878# 0.02242f
C250 a_16793_1842# VDD 0.70898f
C251 a_13883_1842# DELAY_VBIASN 0.06808f
C252 a_13753_1842# DELAY_VBIASP 0.11005f
C253 a_25604_1008# VDD 0.28964f
C254 VDD MUX_SEL2 0.49863f
C255 a_5957_1842# a_6153_1842# 0.72625f
C256 a_10430_1044# a_12715_1044# 0.39036f
C257 a_8237_1842# a_8808_1044# 0.10863f
C258 a_21625_1044# VDD 0.29855f
C259 a_3449_1395# MUX_SEL1 0.29404f
C260 a_13566_5328# VDD 0.09979f
C261 a_13883_1842# a_13991_2470# 0.01697f
C262 a_12849_5867# a_15108_5325# 0.10521f
C263 a_7803_1842# a_7911_1842# 0.01163f
C264 a_17791_2470# VDD 0.02372f
C265 a_13753_1842# a_14317_1842# 0.0114f
C266 a_17357_1842# a_17928_1044# 0.10863f
C267 a_23355_1044# VDD 0.15466f
C268 a_15077_1842# VDD 0.92835f
C269 a_12037_1842# DELAY_VBIASP 0.03915f
C270 a_12233_1842# DELAY_VBIASN 0.09305f
C271 a_4633_1842# a_4763_1842# 0.69911f
C272 a_18585_1044# a_18871_1008# 0.01885f
C273 a_9465_1044# VDD 0.29855f
C274 a_6283_1842# a_6391_1842# 0.01163f
C275 a_12849_5867# a_13306_5105# 0.10675f
C276 a_15108_6109# a_14851_6228# 0.29858f
C277 a_26477_1842# a_27048_1044# 0.10863f
C278 a_21917_1842# a_22113_1842# 0.72407f
C279 a_12363_1842# a_12471_2470# 0.01697f
C280 a_27997_1842# DELAY_VBIASP 0.03777f
C281 a_11711_2470# VDD 0.02372f
C282 a_9712_3912# DLL_RESETN 0.39633f
C283 a_19550_1044# a_21911_1008# 0.26208f
C284 a_12797_1842# a_13557_1842# 0.05863f
C285 a_12363_1842# VDD 0.85903f
C286 a_10517_1842# DELAY_VBIASN 0.07317f
C287 a_20391_1008# VDD 0.28469f
C288 a_9323_1842# DELAY_VBIASP 0.06316f
C289 a_17065_1044# a_16510_1044# 0.03209f
C290 a_13019_5831# DELAY_VBIASN 1.23663f
C291 a_12943_5867# VDD 0.3011f
C292 a_14009_5878# a_14111_5878# 0.47795f
C293 a_6126_3816# a_5778_3367# 1.6143f
C294 a_5974_5723# a_9712_3912# 0.01152f
C295 a_20593_1842# a_20723_1842# 0.69911f
C296 a_13121_5831# a_15304_4605# 0.40633f
C297 a_10843_1842# a_10951_2470# 0.01697f
C298 a_4763_1842# a_4871_1842# 0.01163f
C299 a_26477_1842# DELAY_VBIASN 0.07484f
C300 a_5631_2470# VDD 0.02372f
C301 a_25283_1842# DELAY_VBIASP 0.06316f
C302 a_12037_1842# a_11603_1842# 0.6972f
C303 a_19448_1044# a_19550_1044# 0.37183f
C304 a_7673_1842# DELAY_VBIASP 0.11005f
C305 a_7803_1842# DELAY_VBIASN 0.06808f
C306 a_10713_1842# VDD 0.70915f
C307 a_17928_1044# VDD 0.17577f
C308 a_7288_1044# a_7364_1008# 0.01176f
C309 a_14025_1044# a_14311_1008# 0.01885f
C310 a_12849_5867# VDD 2.97867f
C311 a_1544_1044# VDD 0.56457f
C312 a_5731_289# a_16108_289# 0.01334f
C313 REF_CLK MUX_SEL4 0.06227f
C314 a_9323_1842# a_9431_2470# 0.01697f
C315 a_13566_5835# a_13592_5871# 0.36952f
C316 a_13592_5423# REF_CLK 0.03445f
C317 a_23633_1842# DELAY_VBIASP 0.11007f
C318 a_23763_1842# DELAY_VBIASN 0.0697f
C319 a_26673_1842# VDD 0.71037f
C320 a_17928_1044# a_18004_1008# 0.01176f
C321 a_10713_1842# a_11277_1842# 0.0114f
C322 a_14964_1008# VDD 0.28358f
C323 a_5957_1842# DELAY_VBIASP 0.03915f
C324 a_6153_1842# DELAY_VBIASN 0.09305f
C325 a_8997_1842# VDD 0.92718f
C326 a_16108_289# a_23945_519# 0.2906f
C327 a_7477_1842# a_7945_1044# 0.19203f
C328 a_15108_5325# a_15464_3684# 0.12158f
C329 a_27997_1842# a_27563_1842# 0.69646f
C330 a_9444_4590# a_9444_3912# 2.19613f
C331 a_12158_5867# VDD 0.39251f
C332 DLL_RESETN DELAY_VBIASN 0.12904f
C333 a_1544_1044# a_1721_1395# 0.38063f
C334 a_18877_1842# a_19073_1842# 0.72407f
C335 a_1256_289# a_1721_331# 0.13421f
C336 a_12849_5867# a_13306_6305# 0.12097f
C337 a_7803_1842# a_7911_2470# 0.01697f
C338 a_22113_1842# DELAY_VBIASN 0.0948f
C339 a_24957_1842# VDD 0.97415f
C340 a_15304_4605# REF_CLK 0.01066f
C341 a_21917_1842# DELAY_VBIASP 0.03914f
C342 a_12797_1842# a_13368_1044# 0.10864f
C343 a_16510_1044# a_16484_1008# 0.277f
C344 a_9757_1842# a_10517_1842# 0.05863f
C345 a_21157_1842# a_21625_1044# 0.2079f
C346 a_9712_3912# DELAY_VBIASP 0.1109f
C347 a_12715_1044# VDD 0.15484f
C348 a_4437_1842# DELAY_VBIASN 0.07317f
C349 a_6283_1842# VDD 0.85903f
C350 a_4350_1044# a_5115_1044# 0.39037f
C351 a_14111_5227# a_13880_5118# 0.12701f
C352 a_26673_1842# a_27237_1842# 0.0114f
C353 a_5957_1842# a_6425_1044# 0.2079f
C354 a_13592_5423# a_14757_5182# 0.43239f
C355 a_10206_5835# VDD 0.11162f
C356 a_15964_289# MUX_OUT 0.01307f
C357 a_16108_289# MUX_SEL4 0.1283f
C358 a_21917_1842# a_22488_1044# 0.10864f
C359 a_6854_5986# a_15304_4605# 0.07441f
C360 a_6283_1842# a_6391_2470# 0.01697f
C361 a_12355_5867# a_12656_5864# 0.03277f
C362 a_17553_1842# a_17683_1842# 0.69911f
C363 a_20397_1842# DELAY_VBIASN 0.07573f
C364 a_1544_289# MUX_SEL2 0.07405f
C365 a_3449_1395# REF_CLK 0.01068f
C366 a_1256_289# MUX_SEL3 1.41161f
C367 a_22243_1842# VDD 0.85925f
C368 a_19203_1842# DELAY_VBIASP 0.06316f
C369 a_8997_1842# a_8563_1842# 0.6972f
C370 a_12797_1842# a_10430_1044# 0.02479f
C371 a_9751_1008# VDD 0.29229f
C372 a_4633_1842# VDD 0.70905f
C373 a_15304_4605# a_14757_5182# 0.02225f
C374 a_4437_1842# a_4157_1313# 0.01771f
C375 a_9465_1044# a_7390_1044# 0.03208f
C376 a_25717_1842# a_26477_1842# 0.01335f
C377 a_6126_3816# VDD 0.9531f
C378 a_22590_1044# a_23945_519# 0.018f
C379 a_4763_1842# a_4871_2470# 0.01697f
C380 a_21917_1842# a_19550_1044# 0.02479f
C381 a_25630_1044# a_26395_1044# 0.39037f
C382 a_17683_1842# DELAY_VBIASN 0.06962f
C383 a_17553_1842# DELAY_VBIASP 0.11005f
C384 a_20593_1842# VDD 0.71037f
C385 a_7673_1842# a_8237_1842# 0.0114f
C386 a_13470_1044# a_14311_1008# 0.28268f
C387 a_10517_1842# a_10404_1008# 0.05118f
C388 a_15464_3684# VDD 0.5374f
C389 a_14111_5227# DELAY_OUT_LAST 0.02024f
C390 a_7288_1044# VDD 0.18236f
C391 a_13132_5420# a_13306_5105# 0.27179f
C392 a_24957_1842# a_24523_1842# 0.6972f
C393 a_16851_309# VDD 0.53195f
C394 a_10520_6292# a_10751_5878# 0.12701f
C395 a_19637_1842# a_19524_1008# 0.05118f
C396 a_15837_1842# a_16033_1842# 0.72407f
C397 a_18877_1842# VDD 0.97416f
C398 a_1256_289# VDD 0.41094f
C399 a_16033_1842# DELAY_VBIASN 0.09308f
C400 a_15837_1842# DELAY_VBIASP 0.0392f
C401 DELAY_VBIASN DELAY_VBIASP 7.515f
C402 a_6717_1842# a_7477_1842# 0.05863f
C403 a_12715_1044# a_12791_1008# 0.01194f
C404 a_24665_1044# a_22590_1044# 0.03208f
C405 a_4350_1044# VDD 2.01728f
C406 a_23633_1842# a_24197_1842# 0.0114f
C407 a_23111_2470# VDD 0.02372f
C408 a_14513_1842# a_14643_1842# 0.69911f
C409 a_10206_5835# a_10232_5871# 0.36952f
C410 a_22590_1044# a_24008_1044# 0.38994f
C411 a_13123_1842# DELAY_VBIASP 0.06316f
C412 a_25630_1044# VDD 2.01433f
C413 a_14317_1842# DELAY_VBIASN 0.07392f
C414 a_10649_5878# REF_CLK 0.25484f
C415 a_16163_1842# VDD 0.85925f
C416 VDD MUX_SEL1 0.67739f
C417 a_8997_1842# a_7390_1044# 0.05231f
C418 a_10430_1044# a_11924_1008# 0.28279f
C419 a_5957_1842# a_5523_1842# 0.6972f
C420 a_8237_1842# a_8231_1008# 0.02349f
C421 a_11195_1044# a_11271_1008# 0.01194f
C422 a_20105_1044# VDD 0.30542f
C423 a_3449_1395# MUX_SEL0 0.10753f
C424 a_13132_5420# VDD 0.25347f
C425 a_22677_1842# a_23437_1842# 0.01335f
C426 a_13121_5831# a_15108_5325# 0.05714f
C427 a_12849_5867# a_14851_5182# 0.13376f
C428 a_13019_5831# a_15688_5403# 0.12862f
C429 a_15688_5867# a_15304_4605# 0.19136f
C430 a_17031_2470# VDD 0.02372f
C431 a_18117_1842# a_16510_1044# 0.05231f
C432 a_9746_5805# a_9772_5843# 0.1657f
C433 a_17357_1842# a_17351_1008# 0.02349f
C434 a_11473_1842# DELAY_VBIASP 0.11005f
C435 a_22564_1008# VDD 0.28964f
C436 a_11603_1842# DELAY_VBIASN 0.06808f
C437 a_14513_1842# VDD 0.71057f
C438 a_6717_1842# a_7364_1008# 0.02011f
C439 a_4633_1842# a_5197_1842# 0.0114f
C440 a_18585_1044# a_18795_1044# 0.09424f
C441 a_7945_1044# VDD 0.30542f
C442 a_14111_5878# a_14851_6228# 0.26905f
C443 a_21917_1842# a_21483_1842# 0.6972f
C444 a_26477_1842# a_26471_1008# 0.02349f
C445 a_27237_1842# a_25630_1044# 0.05253f
C446 a_12849_5867# a_13566_5328# 0.26312f
C447 a_27997_1842# DELAY_OUT_LAST 0.7096f
C448 a_27563_1842# DELAY_VBIASN 0.06974f
C449 a_27433_1842# DELAY_VBIASP 0.11005f
C450 a_10951_2470# VDD 0.02372f
C451 a_9444_3912# DLL_RESETN 0.02134f
C452 a_19550_1044# a_21835_1044# 0.39036f
C453 a_6126_3816# a_6854_5454# 0.19098f
C454 a_15837_1842# a_16484_1008# 0.02011f
C455 a_12797_1842# a_12993_1842# 0.72407f
C456 a_9953_1842# DELAY_VBIASN 0.09305f
C457 a_12797_1842# VDD 0.97415f
C458 a_9757_1842# DELAY_VBIASP 0.03914f
C459 a_20315_1044# VDD 0.15466f
C460 a_7390_1044# a_9751_1008# 0.26208f
C461 a_5957_1842# a_5844_1008# 0.02055f
C462 a_2873_1395# VDD 0.4796f
C463 a_24957_1842# a_25604_1008# 0.02011f
C464 a_6326_4590# a_9712_3912# 0.04737f
C465 a_13019_5831# a_15304_4605# 0.07025f
C466 a_14009_5878# a_13880_6292# 0.01562f
C467 a_13592_5871# a_14111_5878# 0.34102f
C468 a_5705_519# a_5731_289# 0.28954f
C469 a_20593_1842# a_21157_1842# 0.0114f
C470 a_25717_1842# DELAY_VBIASP 0.03915f
C471 a_4871_2470# VDD 0.02372f
C472 a_25913_1842# DELAY_VBIASN 0.09602f
C473 a_11473_1842# a_11603_1842# 0.69911f
C474 a_15077_1842# a_14964_1008# 0.02055f
C475 a_8237_1842# DELAY_VBIASN 0.07392f
C476 a_17351_1008# VDD 0.28698f
C477 a_7043_1842# DELAY_VBIASP 0.06316f
C478 a_10083_1842# VDD 0.85925f
C479 a_7288_1044# a_7390_1044# 0.37183f
C480 a_14025_1044# a_14235_1044# 0.09424f
C481 a_5197_1842# a_4350_1044# 0.08038f
C482 a_8997_1842# a_9465_1044# 0.2079f
C483 a_5731_289# a_15964_289# 0.2778f
C484 a_13121_5831# VDD 1.4119f
C485 a_1256_1044# VDD 0.57525f
C486 a_24197_1842# a_24084_1008# 0.02055f
C487 a_19637_1842# a_20397_1842# 0.01335f
C488 a_12849_5867# a_12943_5867# 0.16706f
C489 a_13306_5105# REF_CLK 0.06166f
C490 a_23003_1842# DELAY_VBIASP 0.06316f
C491 a_26043_1842# VDD 0.85902f
C492 a_24197_1842# DELAY_VBIASN 0.07543f
C493 a_14317_1842# a_13470_1044# 0.08038f
C494 a_22677_1842# a_23145_1044# 0.19203f
C495 a_8433_1842# VDD 0.71037f
C496 a_14888_1044# VDD 0.17577f
C497 a_16108_289# a_20905_519# 0.2906f
C498 a_5523_1842# DELAY_VBIASN 0.06808f
C499 a_5393_1842# DELAY_VBIASP 0.11005f
C500 a_14851_5182# a_15464_3684# 0.04597f
C501 a_9444_4590# a_5778_3367# 0.19787f
C502 a_5768_1044# a_5844_1008# 0.01176f
C503 a_27433_1842# a_27563_1842# 0.69911f
C504 a_5731_289# a_8745_519# 0.28635f
C505 a_11491_6228# VDD 0.18135f
C506 a_13121_5831# a_13306_6305# 0.01008f
C507 a_13019_5831# a_13045_6215# 0.01249f
C508 a_23437_1842# a_22590_1044# 0.08038f
C509 a_18877_1842# a_18443_1842# 0.6972f
C510 a_1256_1044# a_1721_1395# 0.13421f
C511 a_1256_289# a_1544_289# 1.25711f
C512 a_5705_519# MUX_SEL4 0.03556f
C513 a_15304_4605# DLL_RESETN 0.03137f
C514 a_21353_1842# DELAY_VBIASP 0.11005f
C515 a_21483_1842# DELAY_VBIASN 0.0697f
C516 a_24393_1842# VDD 0.70905f
C517 a_12797_1842# a_12791_1008# 0.02354f
C518 a_16408_1044# a_16484_1008# 0.01176f
C519 a_9757_1842# a_9953_1842# 0.72407f
C520 a_6717_1842# VDD 0.97416f
C521 a_11924_1008# VDD 0.28358f
C522 a_14009_5084# a_13880_5118# 0.01562f
C523 a_9465_1044# a_9751_1008# 0.01885f
C524 a_4350_1044# a_4324_1008# 0.277f
C525 a_15964_289# MUX_SEL4 0.5544f
C526 VDD REF_CLK 10.6545f
C527 a_27048_1044# a_27124_1008# 0.01176f
C528 a_21917_1842# a_21911_1008# 0.02354f
C529 a_17553_1842# a_18117_1842# 0.0114f
C530 a_19637_1842# DELAY_VBIASP 0.03915f
C531 a_1256_289# MUX_SEL2 0.33134f
C532 a_22677_1842# VDD 0.93609f
C533 a_19833_1842# DELAY_VBIASN 0.09602f
C534 a_8433_1842# a_8563_1842# 0.69911f
C535 a_11277_1842# a_11924_1008# 0.02312f
C536 a_9675_1044# VDD 0.15484f
C537 a_4003_1842# VDD 0.97933f
C538 a_14009_5084# a_14111_5227# 0.47622f
C539 a_7945_1044# a_7390_1044# 0.03209f
C540 a_25717_1842# a_25913_1842# 0.72565f
C541 a_6854_5986# VDD 2.86504f
C542 a_8745_519# MUX_SEL4 0.04472f
C543 a_16597_1842# a_17357_1842# 0.01335f
C544 a_11491_6228# a_11397_6228# 0.28931f
C545 a_20397_1842# a_21044_1008# 0.02312f
C546 a_25630_1044# a_25604_1008# 0.277f
C547 a_16923_1842# DELAY_VBIASP 0.06316f
C548 a_13306_6305# REF_CLK 0.05059f
C549 a_19963_1842# VDD 0.85902f
C550 a_18117_1842# DELAY_VBIASN 0.07543f
C551 a_24665_1044# a_24951_1008# 0.01885f
C552 a_10517_1842# a_10430_1044# 0.1088f
C553 a_13470_1044# a_14235_1044# 0.39037f
C554 a_6711_1008# VDD 0.29229f
C555 a_14009_5084# DELAY_OUT_LAST 0.25594f
C556 a_24393_1842# a_24523_1842# 0.69911f
C557 a_16108_289# VDD 1.94809f
C558 a_15837_1842# a_15403_1842# 0.6972f
C559 a_10232_5871# a_11491_6228# 0.01529f
C560 a_19637_1842# a_19550_1044# 0.1088f
C561 a_27991_1008# VDD 0.29221f
C562 a_15403_1842# DELAY_VBIASN 0.06815f
C563 a_15273_1842# DELAY_VBIASP 0.11018f
C564 a_18313_1842# VDD 0.70905f
C565 DELAY_VBIASN DELAY_OUT_LAST 3.17532f
C566 a_6717_1842# a_6913_1842# 0.72407f
C567 a_23145_1044# a_22590_1044# 0.03209f
C568 a_9444_4590# VDD 0.01023f
C569 a_4248_1044# VDD 0.18405f
C570 a_22351_2470# VDD 0.02372f
C571 a_14513_1842# a_15077_1842# 0.0114f
C572 a_9946_6305# a_10649_5878# 0.02432f
C573 a_22590_1044# a_23431_1008# 0.28268f
C574 a_13557_1842# DELAY_VBIASP 0.03915f
C575 a_16597_1842# VDD 0.93778f
C576 a_10649_5878# DLL_RESETN 0.05713f
C577 a_10232_5871# REF_CLK 0.08086f
C578 a_25528_1044# VDD 0.18232f
C579 a_13753_1842# DELAY_VBIASN 0.09305f
C580 VDD MUX_SEL0 0.51016f
C581 a_5393_1842# a_5523_1842# 0.69911f
C582 a_20105_1044# a_20391_1008# 0.01885f
C583 a_10430_1044# a_11848_1044# 0.38994f
C584 a_12907_5420# VDD 0.08229f
C585 a_18585_1044# VDD 0.29855f
C586 a_22677_1842# a_22873_1842# 0.72565f
C587 a_13121_5831# a_14851_5182# 0.02878f
C588 a_14851_6228# a_15304_4605# 0.12139f
C589 a_16271_2470# VDD 0.02372f
C590 a_13557_1842# a_14317_1842# 0.01335f
C591 a_21835_1044# a_21911_1008# 0.01194f
C592 a_10843_1842# DELAY_VBIASP 0.06316f
C593 a_12037_1842# DELAY_VBIASN 0.07362f
C594 a_13883_1842# VDD 0.85908f
C595 a_22590_1044# VDD 2.01498f
C596 a_1544_1044# MUX_SEL1 0.1672f
C597 a_15688_5867# VDD 0.31235f
C598 a_1721_1395# MUX_SEL0 0.01315f
C599 a_21353_1842# a_21483_1842# 0.69911f
C600 a_14111_5878# a_15108_6109# 0.03093f
C601 a_12849_5867# a_13132_5420# 0.06256f
C602 a_26803_1842# DELAY_VBIASP 0.06316f
C603 a_10191_2470# VDD 0.02372f
C604 a_27997_1842# DELAY_VBIASN 0.0389f
C605 a_12797_1842# a_12363_1842# 0.6972f
C606 a_6854_5986# a_6854_5454# 0.27156f
C607 a_20315_1044# a_20391_1008# 0.01194f
C608 a_19550_1044# a_21044_1008# 0.28279f
C609 a_9193_1842# DELAY_VBIASP 0.11005f
C610 a_9323_1842# DELAY_VBIASN 0.06808f
C611 a_19524_1008# VDD 0.28964f
C612 a_12233_1842# VDD 0.70905f
C613 a_7390_1044# a_9675_1044# 0.39036f
C614 a_10517_1842# a_10985_1044# 0.19203f
C615 a_14009_5878# VDD 0.25176f
C616 a_5974_5723# a_5778_3367# 2.87939f
C617 a_13592_5871# a_13880_6292# 0.43707f
C618 a_25283_1842# DELAY_VBIASN 0.0697f
C619 a_4111_2470# VDD 0.02431f
C620 a_25153_1842# DELAY_VBIASP 0.11005f
C621 a_11473_1842# a_12037_1842# 0.0114f
C622 a_24197_1842# a_24665_1044# 0.2079f
C623 a_10517_1842# VDD 0.93609f
C624 a_7477_1842# DELAY_VBIASP 0.03915f
C625 a_7673_1842# DELAY_VBIASN 0.09305f
C626 a_17275_1044# VDD 0.15466f
C627 a_15545_1044# a_13470_1044# 0.03208f
C628 a_5731_289# a_15765_463# 0.23301f
C629 a_13019_5831# VDD 0.48914f
C630 a_13121_5831# a_12943_5867# 0.09118f
C631 a_13306_6305# a_14009_5878# 0.02432f
C632 a_6854_5454# a_9444_4590# 1.24089f
C633 a_19637_1842# a_19833_1842# 0.72565f
C634 a_26477_1842# VDD 0.93774f
C635 a_23633_1842# DELAY_VBIASN 0.09566f
C636 a_23437_1842# DELAY_VBIASP 0.03914f
C637 a_13566_5328# REF_CLK 0.01093f
C638 a_10517_1842# a_11277_1842# 0.01335f
C639 a_16510_1044# a_18871_1008# 0.26208f
C640 a_4763_1842# DELAY_VBIASP 0.06316f
C641 a_5957_1842# DELAY_VBIASN 0.07362f
C642 a_7803_1842# VDD 0.85902f
C643 a_14311_1008# VDD 0.28469f
C644 a_16108_289# a_17865_519# 0.29564f
C645 a_27433_1842# a_27997_1842# 0.0114f
C646 a_14851_5182# a_14757_5182# 0.28931f
C647 a_11748_6109# VDD 0.1754f
C648 a_18313_1842# a_18443_1842# 0.69911f
C649 a_13121_5831# a_12849_5867# 0.54766f
C650 a_1256_1044# a_1544_1044# 1.26509f
C651 a_21917_1842# DELAY_VBIASN 0.07573f
C652 a_20723_1842# DELAY_VBIASP 0.06316f
C653 a_3449_331# MUX_SEL4 0.05166f
C654 a_23763_1842# VDD 0.85925f
C655 a_16408_1044# a_16510_1044# 0.37183f
C656 a_9757_1842# a_9323_1842# 0.6972f
C657 a_26803_1842# a_26911_1842# 0.01163f
C658 a_11848_1044# VDD 0.17577f
C659 a_9712_3912# DELAY_VBIASN 0.22281f
C660 a_6153_1842# VDD 0.70905f
C661 a_13592_5423# a_13880_5118# 0.43707f
C662 a_26477_1842# a_27237_1842# 0.02984f
C663 a_9465_1044# a_9675_1044# 0.09424f
C664 a_4248_1044# a_4324_1008# 0.01176f
C665 a_9946_6305# VDD 0.81635f
C666 a_15765_463# MUX_SEL4 0.65508f
C667 VDD DLL_RESETN 5.89762f
C668 a_22113_1842# VDD 0.71046f
C669 a_19203_1842# DELAY_VBIASN 0.06966f
C670 a_19073_1842# DELAY_VBIASP 0.11007f
C671 a_8433_1842# a_8997_1842# 0.0114f
C672 a_14888_1044# a_14964_1008# 0.01176f
C673 a_25283_1842# a_25391_1842# 0.01163f
C674 a_11277_1842# a_11848_1044# 0.10863f
C675 a_8884_1008# VDD 0.28358f
C676 a_15688_5403# DELAY_OUT_LAST 0.01699f
C677 a_4437_1842# VDD 0.93901f
C678 a_13592_5423# a_14111_5227# 0.34114f
C679 a_25717_1842# a_25283_1842# 0.69698f
C680 a_5974_5723# VDD 1.03535f
C681 a_20397_1842# a_20968_1044# 0.10863f
C682 a_16597_1842# a_16793_1842# 0.72565f
C683 a_11491_6228# a_12158_5867# 0.0894f
C684 a_25528_1044# a_25604_1008# 0.01176f
C685 a_20397_1842# VDD 0.93774f
C686 a_17553_1842# DELAY_VBIASN 0.09602f
C687 a_17357_1842# DELAY_VBIASP 0.03914f
C688 a_12849_5867# REF_CLK 0.25718f
C689 a_5705_519# VDD 0.30089f
C690 a_23763_1842# a_23871_1842# 0.01163f
C691 a_13470_1044# a_13444_1008# 0.277f
C692 a_24665_1044# a_24875_1044# 0.09424f
C693 a_7477_1842# a_8237_1842# 0.01335f
C694 a_6635_1044# VDD 0.15484f
C695 a_13592_5423# DELAY_OUT_LAST 0.08062f
C696 a_24393_1842# a_24957_1842# 0.0114f
C697 a_15304_4605# a_14111_5227# 0.01761f
C698 a_4905_1044# a_5191_1008# 0.01885f
C699 a_19550_1044# a_20905_519# 0.018f
C700 a_27671_2470# VDD 0.02372f
C701 a_15964_289# VDD 0.48724f
C702 a_15273_1842# a_15403_1842# 0.69911f
C703 a_10649_5878# a_10751_5878# 0.47795f
C704 a_17683_1842# VDD 0.85925f
C705 a_12158_5867# REF_CLK 0.01309f
C706 a_15837_1842# DELAY_VBIASN 0.07399f
C707 a_14643_1842# DELAY_VBIASP 0.06323f
C708 a_27915_1044# VDD 0.15466f
C709 a_22243_1842# a_22351_1842# 0.01163f
C710 a_6717_1842# a_6283_1842# 0.6972f
C711 a_15304_4605# DELAY_OUT_LAST 0.05183f
C712 a_23437_1842# a_24197_1842# 0.02984f
C713 a_13121_5831# a_15464_3684# 0.31727f
C714 a_21591_2470# VDD 0.02372f
C715 a_8745_519# VDD 0.29602f
C716 a_9946_6305# a_10232_5871# 0.41329f
C717 a_22590_1044# a_23355_1044# 0.39037f
C718 a_12993_1842# DELAY_VBIASP 0.11005f
C719 a_13123_1842# DELAY_VBIASN 0.06808f
C720 a_10232_5871# DLL_RESETN 0.39088f
C721 a_16033_1842# VDD 0.71033f
C722 a_24951_1008# VDD 0.29225f
C723 VDD DELAY_VBIASP 37.0123f
C724 a_5393_1842# a_5957_1842# 0.0114f
C725 a_20105_1044# a_20315_1044# 0.09424f
C726 a_10430_1044# a_11271_1008# 0.28268f
C727 a_20723_1842# a_20831_1842# 0.01163f
C728 a_26803_1842# a_26911_2470# 0.01697f
C729 a_12907_5186# VDD 0.0643f
C730 a_2873_1395# MUX_SEL1 0.13092f
C731 a_17065_1044# VDD 0.30351f
C732 a_15108_6109# a_15304_4605# 0.17528f
C733 a_22677_1842# a_22243_1842# 0.69698f
C734 a_15511_2470# VDD 0.02372f
C735 a_9547_5942# a_9772_5843# 0.02416f
C736 a_13557_1842# a_13753_1842# 0.72565f
C737 a_9547_6172# a_9746_5805# 0.02437f
C738 a_22488_1044# VDD 0.18236f
C739 a_14317_1842# VDD 0.93787f
C740 a_11277_1842# DELAY_VBIASP 0.03914f
C741 a_11473_1842# DELAY_VBIASN 0.09305f
C742 a_6854_5454# DLL_RESETN 0.0112f
C743 a_19203_1842# a_19311_1842# 0.01163f
C744 a_25283_1842# a_25391_2470# 0.01697f
C745 a_12037_1842# a_12505_1044# 0.2079f
C746 a_9675_1044# a_9751_1008# 0.01194f
C747 a_4437_1842# a_5197_1842# 0.01335f
C748 a_6717_1842# a_7288_1044# 0.10864f
C749 a_1256_1044# MUX_SEL1 1.44243f
C750 a_14851_6228# VDD 0.25849f
C751 a_6425_1044# VDD 0.29855f
C752 a_1544_1044# MUX_SEL0 0.07603f
C753 a_21353_1842# a_21917_1842# 0.0114f
C754 a_13470_1044# a_14825_519# 0.01782f
C755 a_27237_1842# DELAY_VBIASP 0.05773f
C756 a_9431_2470# VDD 0.02372f
C757 a_27433_1842# DELAY_VBIASN 0.09602f
C758 a_6854_5986# a_6126_3816# 0.11771f
C759 a_19550_1044# a_20968_1044# 0.38994f
C760 a_25717_1842# a_26185_1044# 0.19203f
C761 a_5974_5723# a_6854_5454# 0.01501f
C762 a_15837_1842# a_16408_1044# 0.10864f
C763 a_12233_1842# a_12363_1842# 0.69911f
C764 a_9757_1842# DELAY_VBIASN 0.07392f
C765 a_19550_1044# VDD 2.02235f
C766 a_8563_1842# DELAY_VBIASP 0.06316f
C767 a_11603_1842# VDD 0.85925f
C768 a_6717_1842# a_4350_1044# 0.02479f
C769 a_8155_1044# a_8231_1008# 0.01194f
C770 a_23763_1842# a_23871_2470# 0.01697f
C771 a_17683_1842# a_17791_1842# 0.01163f
C772 a_15545_1044# a_15831_1008# 0.01885f
C773 a_5778_3367# a_5864_3367# 0.07051f
C774 a_9444_3912# a_9712_3912# 0.80775f
C775 a_7390_1044# a_8884_1008# 0.28279f
C776 a_13592_5871# VDD 0.07868f
C777 a_6326_4590# a_5778_3367# 0.87631f
C778 a_24957_1842# a_25528_1044# 0.10864f
C779 a_20397_1842# a_21157_1842# 0.02984f
C780 a_25717_1842# DELAY_VBIASN 0.07499f
C781 a_27563_1842# VDD 0.85987f
C782 a_24523_1842# DELAY_VBIASP 0.06316f
C783 a_15837_1842# a_13470_1044# 0.02479f
C784 a_9953_1842# VDD 0.71046f
C785 a_6913_1842# DELAY_VBIASP 0.11005f
C786 a_7043_1842# DELAY_VBIASN 0.06808f
C787 a_16484_1008# VDD 0.28929f
C788 a_14025_1044# a_13470_1044# 0.03209f
C789 a_4437_1842# a_4324_1008# 0.05118f
C790 a_22243_1842# a_22351_2470# 0.01697f
C791 a_16163_1842# a_16271_1842# 0.01163f
C792 a_5731_289# a_14825_519# 0.28056f
C793 a_12656_5864# VDD 0.27069f
C794 REF_CLK MUX_SEL1 0.01829f
C795 a_6126_3816# a_9444_4590# 0.03029f
C796 a_19637_1842# a_19203_1842# 0.69698f
C797 a_12849_5867# a_14009_5878# 0.03525f
C798 a_13019_5831# a_12943_5867# 0.03346f
C799 a_13306_6305# a_13592_5871# 0.41329f
C800 a_1256_1044# a_2873_1395# 0.28892f
C801 a_24957_1842# a_22590_1044# 0.02479f
C802 a_5731_289# MUX_OUT 1.04829f
C803 a_22873_1842# DELAY_VBIASP 0.11005f
C804 a_13132_5420# REF_CLK 0.02025f
C805 a_23003_1842# DELAY_VBIASN 0.0697f
C806 a_25913_1842# VDD 0.70915f
C807 a_10517_1842# a_10713_1842# 0.72565f
C808 a_13557_1842# a_13444_1008# 0.05118f
C809 a_16510_1044# a_18795_1044# 0.39036f
C810 a_8237_1842# VDD 0.93774f
C811 a_16108_289# a_16851_309# 0.06181f
C812 a_5393_1842# DELAY_VBIASN 0.09305f
C813 a_5197_1842# DELAY_VBIASP 0.03914f
C814 a_14235_1044# VDD 0.15466f
C815 a_20723_1842# a_20831_2470# 0.01697f
C816 a_14643_1842# a_14751_1842# 0.01163f
C817 a_10985_1044# a_11271_1008# 0.01885f
C818 a_4350_1044# a_6711_1008# 0.26208f
C819 a_10751_5878# VDD 0.23078f
C820 a_18313_1842# a_18877_1842# 0.0114f
C821 a_13019_5831# a_12849_5867# 0.12838f
C822 a_22677_1842# a_22564_1008# 0.05118f
C823 a_7390_1044# a_8745_519# 0.01627f
C824 a_24197_1842# VDD 0.92718f
C825 a_21353_1842# DELAY_VBIASN 0.09602f
C826 a_2873_331# MUX_SEL4 0.04916f
C827 a_3449_331# MUX_SEL3 0.28429f
C828 a_2297_331# MUX_OUT 0.01179f
C829 a_21157_1842# DELAY_VBIASP 0.03915f
C830 a_9193_1842# a_9323_1842# 0.69911f
C831 a_5523_1842# VDD 0.85925f
C832 a_11271_1008# VDD 0.28469f
C833 a_4248_1044# a_4350_1044# 0.37183f
C834 a_13306_5105# a_13880_5118# 0.31978f
C835 a_14111_5227# a_15108_5325# 0.03012f
C836 a_13123_1842# a_13231_1842# 0.01163f
C837 a_26477_1842# a_26673_1842# 0.72407f
C838 a_19203_1842# a_19311_2470# 0.01697f
C839 a_9772_5843# VDD 0.26362f
C840 a_25630_1044# a_16108_289# 0.43108f
C841 a_14825_519# MUX_SEL4 0.03307f
C842 a_17357_1842# a_18117_1842# 0.02984f
C843 a_25630_1044# a_27991_1008# 0.26208f
C844 a_21483_1842# VDD 0.85903f
C845 a_18443_1842# DELAY_VBIASP 0.06316f
C846 a_19637_1842# DELAY_VBIASN 0.07499f
C847 a_12943_5867# DLL_RESETN 0.03616f
C848 MUX_SEL4 MUX_OUT 0.91933f
C849 a_12037_1842# a_10430_1044# 0.05231f
C850 a_11277_1842# a_11271_1008# 0.02349f
C851 a_26185_1044# a_26471_1008# 0.01885f
C852 a_8808_1044# VDD 0.17577f
C853 a_5864_3367# VDD 0.13532f
C854 a_15108_5325# DELAY_OUT_LAST 0.01399f
C855 a_11603_1842# a_11711_1842# 0.01163f
C856 a_13306_5105# a_14111_5227# 0.097f
C857 a_13592_5423# a_14009_5084# 0.3749f
C858 a_17683_1842# a_17791_2470# 0.01697f
C859 a_25153_1842# a_25283_1842# 0.69911f
C860 a_6326_4590# VDD 8.12264f
C861 a_21157_1842# a_19550_1044# 0.05231f
C862 a_16597_1842# a_16163_1842# 0.69698f
C863 a_20397_1842# a_20391_1008# 0.02349f
C864 a_11748_6109# a_12158_5867# 0.10373f
C865 a_25528_1044# a_25630_1044# 0.37183f
C866 a_3449_331# VDD 0.47436f
C867 a_19833_1842# VDD 0.70915f
C868 a_13121_5831# REF_CLK 1.40135f
C869 a_12849_5867# DLL_RESETN 0.34367f
C870 a_16923_1842# DELAY_VBIASN 0.0697f
C871 a_16793_1842# DELAY_VBIASP 0.11005f
C872 MUX_SEL0 MUX_SEL1 3.14917f
C873 a_9757_1842# a_10404_1008# 0.02011f
C874 a_7477_1842# a_7673_1842# 0.72565f
C875 a_13368_1044# a_13444_1008# 0.01176f
C876 a_13880_5118# VDD 0.03137f
C877 a_5844_1008# VDD 0.28358f
C878 a_10083_1842# a_10191_1842# 0.01163f
C879 a_12907_5420# a_13132_5420# 0.02416f
C880 a_4905_1044# a_5115_1044# 0.09424f
C881 a_16163_1842# a_16271_2470# 0.01697f
C882 a_26911_2470# VDD 0.02372f
C883 a_15765_463# VDD 0.35641f
C884 a_15273_1842# a_15837_1842# 0.0114f
C885 a_18877_1842# a_19524_1008# 0.02011f
C886 a_10649_5878# a_10520_6292# 0.01562f
C887 a_10232_5871# a_10751_5878# 0.34102f
C888 a_24008_1044# a_24084_1008# 0.01176f
C889 a_6854_5986# a_13121_5831# 0.07016f
C890 a_27124_1008# VDD 0.28358f
C891 a_18117_1842# VDD 0.92718f
C892 a_15273_1842# DELAY_VBIASN 0.09318f
C893 a_15077_1842# DELAY_VBIASP 0.03922f
C894 a_11491_6228# REF_CLK 0.01827f
C895 a_12158_5867# DLL_RESETN 0.02442f
C896 a_6153_1842# a_6283_1842# 0.69911f
C897 a_8997_1842# a_8884_1008# 0.02055f
C898 a_14111_5227# VDD 0.35469f
C899 a_27705_1044# VDD 0.30052f
C900 a_15304_4605# DELAY_VBIASN 0.07802f
C901 a_4157_1313# MUX_SEL4 0.08229f
C902 a_13019_5831# a_15464_3684# 0.59356f
C903 a_23437_1842# a_23633_1842# 0.72407f
C904 a_8563_1842# a_8671_1842# 0.01163f
C905 a_14643_1842# a_14751_2470# 0.01697f
C906 a_20831_2470# VDD 0.02372f
C907 a_13470_1044# a_5731_289# 0.40967f
C908 a_9946_6305# a_10206_5835# 0.75507f
C909 a_14317_1842# a_15077_1842# 0.02984f
C910 a_18117_1842# a_18004_1008# 0.02055f
C911 a_22590_1044# a_22564_1008# 0.277f
C912 a_24875_1044# VDD 0.15484f
C913 a_15403_1842# VDD 0.85902f
C914 a_13557_1842# DELAY_VBIASN 0.07317f
C915 a_10206_5835# DLL_RESETN 0.27343f
C916 a_12363_1842# DELAY_VBIASP 0.06316f
C917 VDD DELAY_OUT_LAST 0.97966f
C918 a_21625_1044# a_19550_1044# 0.03208f
C919 a_13557_1842# a_14025_1044# 0.19203f
C920 a_10430_1044# a_11195_1044# 0.39037f
C921 a_8237_1842# a_7390_1044# 0.08038f
C922 a_13106_5357# VDD 0.10008f
C923 a_15545_1044# VDD 0.30052f
C924 a_2873_1395# MUX_SEL0 0.01504f
C925 a_14111_5878# a_15304_4605# 0.01811f
C926 a_22113_1842# a_22243_1842# 0.69911f
C927 a_7043_1842# a_7151_1842# 0.01163f
C928 a_27237_1842# a_27124_1008# 0.02055f
C929 a_13123_1842# a_13231_2470# 0.01697f
C930 a_14751_2470# VDD 0.02372f
C931 a_4003_1842# REF_CLK 0.5248f
C932 a_27237_1842# a_27705_1044# 0.2079f
C933 a_17357_1842# a_16510_1044# 0.08038f
C934 a_13557_1842# a_13123_1842# 0.69698f
C935 a_9547_5942# a_9746_5805# 0.14994f
C936 a_21911_1008# VDD 0.29229f
C937 a_13753_1842# VDD 0.70941f
C938 a_10713_1842# DELAY_VBIASP 0.11005f
C939 a_10843_1842# DELAY_VBIASN 0.06808f
C940 a_6854_5986# REF_CLK 0.04054f
C941 a_4437_1842# a_4633_1842# 0.72565f
C942 a_6717_1842# a_6711_1008# 0.02354f
C943 a_4905_1044# VDD 0.30259f
C944 a_15108_6109# VDD 0.13564f
C945 a_1256_1044# MUX_SEL0 0.3314f
C946 a_26477_1842# a_25630_1044# 0.08038f
C947 a_5523_1842# a_5631_1842# 0.01163f
C948 a_11603_1842# a_11711_2470# 0.01697f
C949 a_13880_6292# a_14111_5878# 0.12701f
C950 a_6854_5454# a_5864_3367# 0.03661f
C951 a_14009_5878# a_14757_6228# 0.01058f
C952 a_8671_2470# VDD 0.02372f
C953 a_26673_1842# DELAY_VBIASP 0.11005f
C954 a_26803_1842# DELAY_VBIASN 0.0697f
C955 a_5974_5723# a_6126_3816# 1.74557f
C956 a_12233_1842# a_12797_1842# 0.0114f
C957 a_6326_4590# a_6854_5454# 1.24805f
C958 a_15837_1842# a_15831_1008# 0.02354f
C959 a_19550_1044# a_20391_1008# 0.28268f
C960 a_12037_1842# VDD 0.92718f
C961 a_19448_1044# VDD 0.18236f
C962 a_8997_1842# DELAY_VBIASP 0.03915f
C963 a_9193_1842# DELAY_VBIASN 0.09305f
C964 a_13470_1044# MUX_SEL4 0.05779f
C965 a_5197_1842# a_5844_1008# 0.02312f
C966 a_15545_1044# a_15755_1044# 0.09424f
C967 a_7390_1044# a_8808_1044# 0.38994f
C968 a_13566_5835# VDD 0.09483f
C969 a_2297_1395# VDD 0.47666f
C970 a_4003_1842# a_4111_1842# 0.01163f
C971 a_12849_5867# a_14851_6228# 0.13392f
C972 a_10083_1842# a_10191_2470# 0.01697f
C973 a_13121_5831# a_15688_5867# 0.17255f
C974 a_24957_1842# a_24951_1008# 0.02354f
C975 a_20397_1842# a_20593_1842# 0.72407f
C976 a_27997_1842# VDD 0.82766f
C977 a_25153_1842# DELAY_VBIASN 0.09549f
C978 a_24957_1842# DELAY_VBIASP 0.03914f
C979 a_18795_1044# a_18871_1008# 0.01194f
C980 a_14317_1842# a_14964_1008# 0.02312f
C981 a_11277_1842# a_12037_1842# 0.02984f
C982 a_9323_1842# VDD 0.85903f
C983 a_16510_1044# VDD 2.0153f
C984 a_7477_1842# DELAY_VBIASN 0.07317f
C985 a_6283_1842# DELAY_VBIASP 0.06316f
C986 a_4437_1842# a_4350_1044# 0.1088f
C987 a_5731_289# a_11785_519# 0.28056f
C988 a_12355_5867# VDD 0.40041f
C989 a_8563_1842# a_8671_2470# 0.01697f
C990 a_12849_5867# a_13592_5871# 0.38817f
C991 a_13306_6305# a_13566_5835# 0.75507f
C992 a_13121_5831# a_14009_5878# 0.01604f
C993 a_23437_1842# a_24084_1008# 0.02312f
C994 a_19073_1842# a_19203_1842# 0.69911f
C995 a_25283_1842# VDD 0.85925f
C996 a_5731_289# MUX_SEL4 4.60702f
C997 a_22243_1842# DELAY_VBIASP 0.06316f
C998 a_13132_5420# DLL_RESETN 0.01689f
C999 a_23437_1842# DELAY_VBIASN 0.07573f
C1000 a_16510_1044# a_18004_1008# 0.28279f
C1001 a_10517_1842# a_10083_1842# 0.69698f
C1002 a_13557_1842# a_13470_1044# 0.1088f
C1003 a_4350_1044# a_5705_519# 0.01764f
C1004 a_17275_1044# a_17351_1008# 0.01194f
C1005 a_13444_1008# VDD 0.28964f
C1006 a_7673_1842# VDD 0.70915f
C1007 a_4763_1842# DELAY_VBIASN 0.06808f
C1008 a_4633_1842# DELAY_VBIASP 0.11005f
C1009 a_15964_289# a_16851_309# 0.16757f
C1010 a_4350_1044# a_6635_1044# 0.39036f
C1011 a_10985_1044# a_11195_1044# 0.09424f
C1012 a_22677_1842# a_22590_1044# 0.1088f
C1013 a_12355_5867# a_13306_6305# 0.26489f
C1014 a_12656_5864# a_12849_5867# 0.33075f
C1015 a_7043_1842# a_7151_2470# 0.01697f
C1016 a_13019_5831# a_13121_5831# 0.54957f
C1017 a_23633_1842# VDD 0.71037f
C1018 a_2297_331# MUX_SEL4 0.04338f
C1019 a_20593_1842# DELAY_VBIASP 0.11008f
C1020 a_2873_331# MUX_SEL3 0.12606f
C1021 a_20723_1842# DELAY_VBIASN 0.0697f
C1022 a_3449_331# MUX_SEL2 0.10741f
C1023 a_9193_1842# a_9757_1842# 0.0114f
C1024 a_5957_1842# VDD 0.92718f
C1025 a_11195_1044# VDD 0.15466f
C1026 a_14111_5227# a_14851_5182# 0.26905f
C1027 a_26477_1842# a_26043_1842# 0.6972f
C1028 a_9746_5805# VDD 0.0996f
C1029 a_11785_519# MUX_SEL4 0.03255f
C1030 a_5523_1842# a_5631_2470# 0.01697f
C1031 a_17357_1842# a_17553_1842# 0.72407f
C1032 a_25630_1044# a_27915_1044# 0.39036f
C1033 a_21917_1842# VDD 0.97416f
C1034 a_18877_1842# DELAY_VBIASP 0.03914f
C1035 a_14009_5878# REF_CLK 0.25847f
C1036 a_19073_1842# DELAY_VBIASN 0.0951f
C1037 MUX_SEL3 MUX_OUT 0.79533f
C1038 a_26185_1044# a_26395_1044# 0.09424f
C1039 a_8237_1842# a_8997_1842# 0.02984f
C1040 a_13470_1044# a_15831_1008# 0.26208f
C1041 a_8231_1008# VDD 0.28469f
C1042 a_9712_3912# VDD 0.2127f
C1043 a_14851_5182# DELAY_OUT_LAST 0.02109f
C1044 a_13306_5105# a_14009_5084# 0.02454f
C1045 a_25153_1842# a_25717_1842# 0.0114f
C1046 a_22590_1044# a_16108_289# 0.43108f
C1047 a_26985_519# VDD 0.30089f
C1048 a_4003_1842# a_4111_2470# 0.01697f
C1049 a_11748_6109# a_11491_6228# 0.34468f
C1050 a_16033_1842# a_16163_1842# 0.69911f
C1051 a_19203_1842# VDD 0.85925f
C1052 a_2873_331# VDD 0.47413f
C1053 a_13019_5831# REF_CLK 0.35409f
C1054 a_13121_5831# DLL_RESETN 0.04337f
C1055 a_16163_1842# DELAY_VBIASP 0.06316f
C1056 a_17357_1842# DELAY_VBIASN 0.07573f
C1057 a_25630_1044# DELAY_VBIASP 0.0137f
C1058 a_13368_1044# a_13470_1044# 0.37183f
C1059 a_7477_1842# a_7043_1842# 0.69698f
C1060 a_5768_1044# VDD 0.17577f
C1061 a_15304_4605# a_13592_5423# 0.01817f
C1062 a_6425_1044# a_4350_1044# 0.03208f
C1063 a_24197_1842# a_24957_1842# 0.02577f
C1064 a_26151_2470# VDD 0.02372f
C1065 a_14825_519# VDD 0.29891f
C1066 a_10232_5871# a_10520_6292# 0.43707f
C1067 a_17553_1842# VDD 0.71037f
C1068 a_27048_1044# VDD 0.17577f
C1069 a_11491_6228# DLL_RESETN 0.14622f
C1070 a_14513_1842# DELAY_VBIASP 0.11018f
C1071 a_14643_1842# DELAY_VBIASN 0.06828f
C1072 a_11748_6109# REF_CLK 0.0148f
C1073 VDD MUX_OUT 1.15067f
C1074 a_11848_1044# a_11924_1008# 0.01176f
C1075 a_15077_1842# a_15545_1044# 0.2079f
C1076 a_6153_1842# a_6717_1842# 0.0114f
C1077 a_21625_1044# a_21911_1008# 0.01885f
C1078 a_26185_1044# VDD 0.30542f
C1079 a_14009_5084# VDD 0.33745f
C1080 a_23437_1842# a_23003_1842# 0.6972f
C1081 a_20071_2470# VDD 0.02372f
C1082 a_16510_1044# a_17865_519# 0.018f
C1083 a_22488_1044# a_22564_1008# 0.01176f
C1084 a_14317_1842# a_14513_1842# 0.72407f
C1085 a_15837_1842# VDD 0.96712f
C1086 a_24084_1008# VDD 0.28358f
C1087 a_12797_1842# DELAY_VBIASP 0.03914f
C1088 a_12993_1842# DELAY_VBIASN 0.09305f
C1089 DLL_RESETN REF_CLK 2.74214f
C1090 VDD DELAY_VBIASN 1.03926f
C1091 a_20105_1044# a_19550_1044# 0.03209f
C1092 a_10430_1044# a_10404_1008# 0.277f
C1093 a_5197_1842# a_5957_1842# 0.02984f
C1094 a_14025_1044# VDD 0.30542f
C1095 a_22113_1842# a_22677_1842# 0.0114f
C1096 a_14851_6228# a_14757_6228# 0.28931f
C1097 a_12849_5867# a_14111_5227# 0.42064f
C1098 a_13991_2470# VDD 0.02372f
C1099 a_4437_1842# REF_CLK 0.04461f
C1100 a_10430_1044# a_5731_289# 0.40957f
C1101 a_9547_5942# a_9547_6172# 0.1117f
C1102 a_12993_1842# a_13123_1842# 0.69911f
C1103 a_21835_1044# VDD 0.15484f
C1104 a_13123_1842# VDD 0.85925f
C1105 a_10083_1842# DELAY_VBIASP 0.06316f
C1106 a_6854_5986# DLL_RESETN 0.28237f
C1107 a_11277_1842# DELAY_VBIASN 0.07392f
C1108 a_4437_1842# a_4003_1842# 0.69698f
C1109 a_17065_1044# a_17351_1008# 0.01885f
C1110 a_4157_1313# VDD 0.57212f
C1111 a_14111_5878# VDD 0.22908f
C1112 a_12849_5867# DELAY_OUT_LAST 0.01467f
C1113 a_13592_5871# a_14757_6228# 0.43239f
C1114 a_6126_3816# a_5864_3367# 0.12761f
C1115 a_6854_5454# a_9712_3912# 0.67825f
C1116 a_21157_1842# a_21917_1842# 0.02577f
C1117 a_7911_2470# VDD 0.02372f
C1118 a_26043_1842# DELAY_VBIASP 0.06316f
C1119 a_27237_1842# DELAY_VBIASN 0.07543f
C1120 a_19550_1044# a_20315_1044# 0.39037f
C1121 a_5974_5723# a_6854_5986# 0.02579f
C1122 a_6326_4590# a_6126_3816# 2.74106f
C1123 a_11473_1842# VDD 0.71037f
C1124 a_18871_1008# VDD 0.29229f
C1125 a_8433_1842# DELAY_VBIASP 0.11005f
C1126 a_8563_1842# DELAY_VBIASN 0.06808f
C1127 a_7390_1044# a_8231_1008# 0.28268f
C1128 a_5197_1842# a_5768_1044# 0.10863f
C1129 a_13306_6305# a_14111_5878# 0.097f
C1130 a_20397_1842# a_19963_1842# 0.6972f
C1131 a_12849_5867# a_15108_6109# 0.10225f
C1132 a_13121_5831# a_14851_6228# 0.03404f
C1133 a_13019_5831# a_15688_5867# 0.0195f
C1134 a_9444_4590# DLL_RESETN 0.01688f
C1135 a_27433_1842# VDD 0.70905f
C1136 a_10430_1044# a_11785_519# 0.01782f
C1137 a_24393_1842# DELAY_VBIASP 0.11005f
C1138 a_24523_1842# DELAY_VBIASN 0.0697f
C1139 a_11277_1842# a_11473_1842# 0.72407f
C1140 a_14317_1842# a_14888_1044# 0.10863f
C1141 a_9757_1842# VDD 0.97416f
C1142 a_16408_1044# VDD 0.18093f
C1143 a_6913_1842# DELAY_VBIASN 0.09305f
C1144 a_10430_1044# MUX_SEL4 0.05749f
C1145 a_6717_1842# DELAY_VBIASP 0.03914f
C1146 a_6635_1044# a_6711_1008# 0.01194f
C1147 REF_CLK DELAY_VBIASP 0.08317f
C1148 a_19073_1842# a_19637_1842# 0.0114f
C1149 a_12849_5867# a_13566_5835# 0.27346f
C1150 a_1544_1044# a_2297_1395# 0.28651f
C1151 a_23437_1842# a_24008_1044# 0.10863f
C1152 a_13121_5831# a_13592_5871# 0.01445f
C1153 a_25717_1842# VDD 0.93609f
C1154 a_12907_5420# DLL_RESETN 0.04234f
C1155 a_22677_1842# DELAY_VBIASP 0.03915f
C1156 a_22873_1842# DELAY_VBIASN 0.09602f
C1157 a_9953_1842# a_10083_1842# 0.69911f
C1158 a_16510_1044# a_17928_1044# 0.38994f
C1159 a_13470_1044# VDD 2.0134f
C1160 a_7043_1842# VDD 0.85925f
C1161 a_15964_289# a_16108_289# 0.42202f
C1162 a_5197_1842# DELAY_VBIASN 0.07392f
C1163 a_4003_1842# DELAY_VBIASP 0.05735f
C1164 a_12505_1044# a_10430_1044# 0.03208f
C1165 a_5115_1044# a_5191_1008# 0.01194f
C1166 a_4350_1044# a_5844_1008# 0.28279f
C1167 a_27237_1842# a_27433_1842# 0.72625f
C1168 a_6854_5986# DELAY_VBIASP 0.01478f
C1169 a_12355_5867# a_12849_5867# 0.07687f
C1170 a_27915_1044# a_27991_1008# 0.01194f
C1171 a_18117_1842# a_18877_1842# 0.02577f
C1172 a_23003_1842# VDD 0.85902f
C1173 a_1544_289# MUX_OUT 0.69943f
C1174 a_19963_1842# DELAY_VBIASP 0.06316f
C1175 a_21157_1842# DELAY_VBIASN 0.07543f
C1176 a_1721_331# MUX_SEL4 0.05813f
C1177 a_2873_331# MUX_SEL2 0.01422f
C1178 a_2297_331# MUX_SEL3 0.01595f
C1179 a_5393_1842# VDD 0.71037f
C1180 a_10404_1008# VDD 0.28964f
C1181 a_15464_3684# DELAY_OUT_LAST 0.01937f
C1182 a_25913_1842# a_26043_1842# 0.69911f
C1183 a_9547_6172# VDD 0.09227f
C1184 a_17357_1842# a_16923_1842# 0.6972f
C1185 a_26395_1044# a_26471_1008# 0.01194f
C1186 a_25630_1044# a_27124_1008# 0.28279f
C1187 a_12158_5867# a_12355_5867# 0.12454f
C1188 a_13592_5871# REF_CLK 0.11539f
C1189 a_5731_289# VDD 0.63828f
C1190 a_21353_1842# VDD 0.70905f
C1191 a_18313_1842# DELAY_VBIASP 0.11005f
C1192 a_18443_1842# DELAY_VBIASN 0.0697f
C1193 MUX_SEL3 MUX_SEL4 0.75489f
C1194 MUX_SEL2 MUX_OUT 0.08497f
C1195 a_13470_1044# a_15755_1044# 0.39036f
C1196 a_8237_1842# a_8433_1842# 0.72407f
C1197 a_27705_1044# a_25630_1044# 0.03208f
C1198 a_8155_1044# VDD 0.15466f
C1199 a_13566_5328# a_14009_5084# 0.02242f
C1200 a_6425_1044# a_6711_1008# 0.01885f
C1201 a_15304_4605# a_15108_5325# 0.01986f
C1202 a_13306_5105# a_13592_5423# 0.41329f
C1203 a_23945_519# VDD 0.30044f
C1204 a_10751_5878# a_11491_6228# 0.26905f
C1205 a_16033_1842# a_16597_1842# 0.0114f
C1206 a_12656_5864# REF_CLK 0.01215f
C1207 a_19637_1842# VDD 0.93609f
C1208 a_13019_5831# DLL_RESETN 0.01429f
C1209 a_2297_331# VDD 0.47301f
C1210 a_16793_1842# DELAY_VBIASN 0.09602f
C1211 a_16597_1842# DELAY_VBIASP 0.03915f
C1212 a_9757_1842# a_10328_1044# 0.10864f
C1213 a_16597_1842# a_17065_1044# 0.19203f
C1214 a_6913_1842# a_7043_1842# 0.69911f
C1215 a_15688_5403# VDD 0.31892f
C1216 a_5191_1008# VDD 0.28698f
C1217 a_4905_1044# a_4350_1044# 0.03209f
C1218 a_24197_1842# a_24393_1842# 0.72625f
C1219 a_4157_1313# a_4324_1008# 0.02463f
C1220 a_12907_5186# a_12907_5420# 0.1117f
C1221 a_13106_5357# a_13132_5420# 0.1657f
C1222 a_25391_2470# VDD 0.02372f
C1223 a_19550_1044# a_16108_289# 0.43108f
C1224 a_11785_519# VDD 0.29891f
C1225 a_22590_1044# a_24951_1008# 0.26208f
C1226 a_15077_1842# a_15837_1842# 0.02577f
C1227 a_18877_1842# a_19448_1044# 0.10864f
C1228 a_10751_5878# REF_CLK 0.01931f
C1229 a_16923_1842# VDD 0.85902f
C1230 a_26471_1008# VDD 0.28469f
C1231 a_11748_6109# DLL_RESETN 0.11133f
C1232 a_15077_1842# DELAY_VBIASN 0.0737f
C1233 a_13883_1842# DELAY_VBIASP 0.06316f
C1234 VDD MUX_SEL4 4.25383f
C1235 a_9757_1842# a_7390_1044# 0.02479f
C1236 a_21625_1044# a_21835_1044# 0.09424f
C1237 a_24665_1044# VDD 0.29855f
C1238 a_13592_5423# VDD 0.13283f
C1239 a_22873_1842# a_23003_1842# 0.69911f
C1240 a_19311_2470# VDD 0.02372f
C1241 a_16510_1044# a_16851_309# 0.01245f
C1242 a_18877_1842# a_16510_1044# 0.02479f
C1243 a_14317_1842# a_13883_1842# 0.6972f
C1244 a_22488_1044# a_22590_1044# 0.37183f
C1245 a_15273_1842# VDD 0.70918f
C1246 a_24008_1044# VDD 0.17577f
C1247 a_9946_6305# DLL_RESETN 0.09997f
C1248 a_12363_1842# DELAY_VBIASN 0.06808f
C1249 a_12233_1842# DELAY_VBIASP 0.11005f
C1250 a_10328_1044# a_10404_1008# 0.01176f
C1251 a_7477_1842# a_7364_1008# 0.05118f
C1252 a_5197_1842# a_5393_1842# 0.72407f
C1253 a_15304_4605# VDD 0.77714f
C1254 a_12505_1044# VDD 0.29855f
C1255 a_2297_1395# MUX_SEL1 0.01995f
C1256 a_12849_5867# a_14009_5084# 0.03463f
C1257 a_14851_6228# a_15688_5867# 0.08776f
C1258 a_5864_3367# REF_CLK 0.01659f
C1259 a_13231_2470# VDD 0.02372f
C1260 a_16597_1842# a_16484_1008# 0.05118f
C1261 a_20968_1044# a_21044_1008# 0.01176f
C1262 a_12993_1842# a_13557_1842# 0.0114f
C1263 a_13557_1842# VDD 0.93609f
C1264 a_21044_1008# VDD 0.28358f
C1265 a_10517_1842# DELAY_VBIASP 0.03915f
C1266 a_10713_1842# DELAY_VBIASN 0.09305f
C1267 a_17065_1044# a_17275_1044# 0.09424f
C1268 a_3449_331# REF_CLK 0.01018f
C1269 a_3449_1395# VDD 0.48234f
C1270 a_13019_5831# DELAY_VBIASP 0.02377f
C1271 a_13121_5831# DELAY_OUT_LAST 0.04358f
C1272 a_25717_1842# a_25604_1008# 0.05118f
C1273 a_21157_1842# a_21353_1842# 0.72625f
C1274 a_6854_5454# a_9444_3912# 0.84817f
C1275 a_7151_2470# VDD 0.02372f
C1276 a_26477_1842# DELAY_VBIASP 0.03919f
C1277 a_26673_1842# DELAY_VBIASN 0.09565f
C1278 a_6326_4590# a_6854_5986# 1.17368f
C1279 a_7390_1044# a_5731_289# 0.41141f
C1280 a_12037_1842# a_12797_1842# 0.02577f
C1281 a_19550_1044# a_19524_1008# 0.277f
C1282 a_18795_1044# VDD 0.15484f
C1283 a_10843_1842# VDD 0.85902f
C1284 a_7803_1842# DELAY_VBIASP 0.06316f
C1285 a_8997_1842# DELAY_VBIASN 0.07362f
C1286 a_15464_3684# a_9712_3912# 0.01237f
C1287 a_7390_1044# a_8155_1044# 0.39037f
C1288 a_5197_1842# a_5191_1008# 0.02349f
C1289 a_5957_1842# a_4350_1044# 0.05231f
C1290 a_12849_5867# a_14111_5878# 0.42174f
C1291 a_13306_6305# a_13880_6292# 0.31978f
C1292 a_13019_5831# a_14851_6228# 0.01651f
C1293 a_19833_1842# a_19963_1842# 0.69911f
C1294 a_13592_5871# a_14009_5878# 0.37583f
C1295 a_13121_5831# a_15108_6109# 0.03701f
C1296 a_26803_1842# VDD 0.85925f
C1297 a_23763_1842# DELAY_VBIASP 0.06316f
C1298 a_24957_1842# DELAY_VBIASN 0.07573f
C1299 a_11277_1842# a_10843_1842# 0.6972f
C1300 a_14317_1842# a_14311_1008# 0.02349f
C1301 a_15077_1842# a_13470_1044# 0.05231f
C1302 a_9193_1842# VDD 0.70905f
C1303 a_15831_1008# VDD 0.29168f
C1304 a_6153_1842# DELAY_VBIASP 0.11005f
C1305 a_6283_1842# DELAY_VBIASN 0.06808f
C1306 a_12505_1044# a_12791_1008# 0.01885f
C1307 a_9444_4590# a_5864_3367# 0.04218f
C1308 DLL_RESETN DELAY_VBIASP 0.05892f
C1309 a_1256_289# a_2873_331# 0.27926f
C1310 a_6326_4590# a_9444_4590# 0.01269f
C1311 a_23437_1842# a_23431_1008# 0.02349f
C1312 a_24197_1842# a_22590_1044# 0.05231f
C1313 a_1544_289# a_2297_331# 0.27303f
C1314 a_13121_5831# a_13566_5835# 0.01158f
C1315 a_1256_1044# a_2297_1395# 0.04619f
C1316 a_13019_5831# a_13592_5871# 0.04178f
C1317 a_25153_1842# VDD 0.71046f
C1318 a_12907_5186# DLL_RESETN 0.02177f
C1319 a_22113_1842# DELAY_VBIASP 0.11007f
C1320 a_22243_1842# DELAY_VBIASN 0.0697f
C1321 a_12797_1842# a_13444_1008# 0.02011f
C1322 a_27563_1842# a_27671_1842# 0.01163f
C1323 a_16510_1044# a_17351_1008# 0.28268f
C1324 a_9953_1842# a_10517_1842# 0.0114f
R0 DELAY_VBIASP.n0 DELAY_VBIASP.t34 34.3685
R1 DELAY_VBIASP.n0 DELAY_VBIASP.t33 33.0005
R2 DELAY_VBIASP.n1 DELAY_VBIASP.t32 33.0005
R3 DELAY_VBIASP.n2 DELAY_VBIASP.t31 33.0005
R4 DELAY_VBIASP.n3 DELAY_VBIASP.t30 33.0005
R5 DELAY_VBIASP.n4 DELAY_VBIASP.t29 33.0005
R6 DELAY_VBIASP.n5 DELAY_VBIASP.t28 33.0005
R7 DELAY_VBIASP.n6 DELAY_VBIASP.t27 33.0005
R8 DELAY_VBIASP.n7 DELAY_VBIASP.t26 33.0005
R9 DELAY_VBIASP.n8 DELAY_VBIASP.t25 33.0005
R10 DELAY_VBIASP.n9 DELAY_VBIASP.t24 33.0005
R11 DELAY_VBIASP.n10 DELAY_VBIASP.t23 33.0005
R12 DELAY_VBIASP.n11 DELAY_VBIASP.t22 33.0005
R13 DELAY_VBIASP.n12 DELAY_VBIASP.t21 33.0005
R14 DELAY_VBIASP.n13 DELAY_VBIASP.t20 33.0005
R15 DELAY_VBIASP.n14 DELAY_VBIASP.t19 33.0005
R16 DELAY_VBIASP.n15 DELAY_VBIASP.t18 33.0005
R17 DELAY_VBIASP.n16 DELAY_VBIASP.t17 33.0005
R18 DELAY_VBIASP.n17 DELAY_VBIASP.t16 33.0005
R19 DELAY_VBIASP.n18 DELAY_VBIASP.t15 33.0005
R20 DELAY_VBIASP.n19 DELAY_VBIASP.t14 33.0005
R21 DELAY_VBIASP.n20 DELAY_VBIASP.t0 31.7887
R22 DELAY_VBIASP.t2 DELAY_VBIASP.t1 5.66709
R23 DELAY_VBIASP.n20 DELAY_VBIASP.t3 10.3812
R24 DELAY_VBIASP DELAY_VBIASP.n20 4.16078
R25 DELAY_VBIASP.t3 DELAY_VBIASP.t4 1.36852
R26 DELAY_VBIASP.t4 DELAY_VBIASP.t5 1.36852
R27 DELAY_VBIASP.t5 DELAY_VBIASP.t6 1.36852
R28 DELAY_VBIASP.t6 DELAY_VBIASP.t7 1.36852
R29 DELAY_VBIASP.t7 DELAY_VBIASP.t8 1.36852
R30 DELAY_VBIASP.t8 DELAY_VBIASP.t9 1.36852
R31 DELAY_VBIASP.t9 DELAY_VBIASP.t10 1.36852
R32 DELAY_VBIASP.t10 DELAY_VBIASP.t11 1.36852
R33 DELAY_VBIASP.t11 DELAY_VBIASP.t12 1.36852
R34 DELAY_VBIASP.t12 DELAY_VBIASP.t13 1.36852
R35 DELAY_VBIASP.t13 DELAY_VBIASP.n19 1.36852
R36 DELAY_VBIASP.n19 DELAY_VBIASP.n18 1.36852
R37 DELAY_VBIASP.n18 DELAY_VBIASP.n17 1.36852
R38 DELAY_VBIASP.n17 DELAY_VBIASP.n16 1.36852
R39 DELAY_VBIASP.n16 DELAY_VBIASP.n15 1.36852
R40 DELAY_VBIASP.n15 DELAY_VBIASP.n14 1.36852
R41 DELAY_VBIASP.n14 DELAY_VBIASP.n13 1.36852
R42 DELAY_VBIASP.n13 DELAY_VBIASP.n12 1.36852
R43 DELAY_VBIASP.n12 DELAY_VBIASP.n11 1.36852
R44 DELAY_VBIASP.n11 DELAY_VBIASP.n10 1.36852
R45 DELAY_VBIASP.n10 DELAY_VBIASP.n9 1.36852
R46 DELAY_VBIASP.n9 DELAY_VBIASP.n8 1.36852
R47 DELAY_VBIASP.n8 DELAY_VBIASP.n7 1.36852
R48 DELAY_VBIASP.n7 DELAY_VBIASP.n6 1.36852
R49 DELAY_VBIASP.n6 DELAY_VBIASP.n5 1.36852
R50 DELAY_VBIASP.n5 DELAY_VBIASP.n4 1.36852
R51 DELAY_VBIASP.n4 DELAY_VBIASP.n3 1.36852
R52 DELAY_VBIASP.n3 DELAY_VBIASP.n2 1.36852
R53 DELAY_VBIASP.n2 DELAY_VBIASP.n1 1.36852
R54 DELAY_VBIASP.n1 DELAY_VBIASP.n0 1.36852
R55 DELAY_VBIASP.t0 DELAY_VBIASP.t1 3.94734
R56 VDD VDD.t122 17.3693
R57 VDD.n113 VDD.t85 17.3693
R58 VDD.n113 VDD.t324 17.3693
R59 VDD VDD.t257 17.3517
R60 VDD.n115 VDD.t128 17.3517
R61 VDD.n114 VDD.t153 17.3517
R62 VDD.n49 VDD.t79 17.2438
R63 VDD.n115 VDD.t57 17.2247
R64 VDD.t42 VDD.n115 1.4472
R65 VDD.n77 VDD.n76 0.322033
R66 VDD VDD.t121 17.0005
R67 VDD.n115 VDD.t2 17.0005
R68 VDD.n114 VDD.t6 17.0005
R69 VDD.n117 VDD 0.286558
R70 VDD.n64 VDD.n118 0.549968
R71 VDD.t0 VDD.n8 0.0874746
R72 VDD.t0 VDD.n4 0.377214
R73 VDD.n88 VDD.n3 0.744354
R74 VDD.t0 VDD.n88 0.714174
R75 VDD.n89 VDD.n47 0.744354
R76 VDD.t0 VDD.n89 0.714174
R77 VDD.n90 VDD.n44 0.744354
R78 VDD.t0 VDD.n90 0.714174
R79 VDD.n91 VDD.n42 0.744354
R80 VDD.t0 VDD.n91 0.714174
R81 VDD.n92 VDD.n39 0.744354
R82 VDD.t0 VDD.n92 0.714174
R83 VDD.n93 VDD.n36 0.744354
R84 VDD.t0 VDD.n93 0.714174
R85 VDD.n94 VDD.n33 0.744354
R86 VDD.t0 VDD.n94 0.714174
R87 VDD.n95 VDD.n31 0.744354
R88 VDD.t0 VDD.n95 0.714174
R89 VDD.n96 VDD.n29 0.744354
R90 VDD.t0 VDD.n96 0.714174
R91 VDD.n97 VDD.n27 0.744354
R92 VDD.t0 VDD.n97 0.714174
R93 VDD.n98 VDD.n25 0.744354
R94 VDD.t0 VDD.n98 0.714174
R95 VDD.n99 VDD.n24 0.744354
R96 VDD.t0 VDD.n99 0.714174
R97 VDD.n100 VDD.n21 0.744354
R98 VDD.t0 VDD.n100 0.714174
R99 VDD.n101 VDD.n19 0.744354
R100 VDD.t0 VDD.n101 0.714174
R101 VDD.n14 VDD.n16 0.215566
R102 VDD.n3 VDD.t285 15.1333
R103 VDD.t58 VDD.t269 15.0005
R104 VDD.t58 VDD.t274 15.0005
R105 VDD.t58 VDD.t277 15.0005
R106 VDD.n3 VDD.t288 15.0005
R107 VDD.t0 VDD.t282 15.0005
R108 VDD.t0 VDD.t279 15.0005
R109 VDD.t58 VDD.t216 17.9449
R110 VDD.n1070 VDD.n55 1.80645
R111 VDD.n1070 VDD.n402 10.0583
R112 VDD.n75 VDD.n630 6.77146
R113 VDD.n387 VDD 9.07383
R114 VDD.t1 VDD.t366 9.02285
R115 VDD VDD.n388 9.0005
R116 VDD.n323 VDD 9.0005
R117 VDD.n293 VDD 4.46488
R118 VDD.n383 VDD.n293 0.073243
R119 VDD.n382 VDD 9.0005
R120 VDD.n130 VDD 4.46488
R121 VDD.n378 VDD.n130 0.073243
R122 VDD VDD.n122 4.46488
R123 VDD.n377 VDD.n122 0.073243
R124 VDD.n295 VDD.n306 0.073243
R125 VDD.n295 VDD 4.46488
R126 VDD VDD.n137 4.46488
R127 VDD.n372 VDD.n137 0.073243
R128 VDD.n136 VDD.n139 0.073243
R129 VDD.n136 VDD 4.46488
R130 VDD.n71 VDD.n135 4.46488
R131 VDD.n367 VDD.n135 0.073243
R132 VDD.n134 VDD.n141 0.073243
R133 VDD.n134 VDD.n71 4.46488
R134 VDD.n71 VDD.n133 4.46488
R135 VDD.n362 VDD.n133 0.073243
R136 VDD.n132 VDD.n143 0.073243
R137 VDD.n132 VDD.n71 4.46488
R138 VDD.n71 VDD.n144 9.0005
R139 VDD.n357 VDD.n285 0.073243
R140 VDD.n285 VDD.n71 4.46488
R141 VDD.n292 VDD.n71 4.46488
R142 VDD.n352 VDD.n292 0.073243
R143 VDD.n351 VDD.n71 9.0005
R144 VDD.n333 VDD.n145 0.073243
R145 VDD.n145 VDD.n71 4.46488
R146 VDD.n146 VDD.n147 0.073243
R147 VDD.n146 VDD.n71 4.46488
R148 VDD.n342 VDD.n115 9.0005
R149 VDD.n341 VDD.n294 0.073243
R150 VDD.n294 VDD.n115 4.46488
R151 VDD.n125 VDD.n127 0.134609
R152 VDD.n127 VDD.n76 1.38505
R153 VDD.n76 VDD.n124 9.0005
R154 VDD.n70 VDD.n335 9.0005
R155 VDD.n386 VDD.n323 9.0005
R156 VDD.n385 VDD.n384 9.0005
R157 VDD.n383 VDD.n324 9.0005
R158 VDD.n382 VDD.n381 9.0005
R159 VDD.n380 VDD.n325 9.0005
R160 VDD.n379 VDD.n378 9.0005
R161 VDD.n131 VDD.n326 9.0005
R162 VDD.n377 VDD.n376 9.0005
R163 VDD.n375 VDD.n306 9.0005
R164 VDD.n374 VDD.n373 9.0005
R165 VDD.n138 VDD.n327 9.0005
R166 VDD.n372 VDD.n371 9.0005
R167 VDD.n370 VDD.n139 9.0005
R168 VDD.n369 VDD.n368 9.0005
R169 VDD.n140 VDD.n328 9.0005
R170 VDD.n367 VDD.n366 9.0005
R171 VDD.n365 VDD.n141 9.0005
R172 VDD.n364 VDD.n363 9.0005
R173 VDD.n142 VDD.n329 9.0005
R174 VDD.n362 VDD.n361 9.0005
R175 VDD.n360 VDD.n143 9.0005
R176 VDD.n359 VDD.n358 9.0005
R177 VDD.n144 VDD.n330 9.0005
R178 VDD.n357 VDD.n356 9.0005
R179 VDD.n355 VDD.n331 9.0005
R180 VDD.n354 VDD.n353 9.0005
R181 VDD.n352 VDD.n332 9.0005
R182 VDD.n351 VDD.n350 9.0005
R183 VDD.n349 VDD.n333 9.0005
R184 VDD.n348 VDD.n347 9.0005
R185 VDD.n147 VDD.n334 9.0005
R186 VDD.n346 VDD.n345 9.0005
R187 VDD.n344 VDD.n335 9.0005
R188 VDD.n343 VDD.n342 9.0005
R189 VDD.n341 VDD.n336 9.0005
R190 VDD.n339 VDD.n338 9.0005
R191 VDD.n124 VDD.n337 9.0005
R192 VDD.n309 VDD.n321 0.285069
R193 VDD.n1078 VDD.n79 9.0005
R194 VDD.n272 VDD.n1079 0.114852
R195 VDD.n272 VDD.n79 4.44407
R196 VDD.n397 VDD.n226 0.114852
R197 VDD.n226 VDD 4.44407
R198 VDD.n389 VDD.n284 0.114852
R199 VDD.n284 VDD 4.44407
R200 VDD.n1072 VDD.n1071 9.0005
R201 VDD.n1073 VDD.n403 9.0005
R202 VDD.n80 VDD.n79 4.38857
R203 VDD.n79 VDD.n225 4.44407
R204 VDD.n1077 VDD.n225 0.114852
R205 VDD.n227 VDD 4.44407
R206 VDD.n394 VDD.n227 0.114852
R207 VDD.n392 VDD.n389 9.0005
R208 VDD.n284 VDD.n103 0.519066
R209 VDD.n103 VDD 1.6162
R210 VDD.n103 VDD.n392 1.82017
R211 VDD.n394 VDD.n393 9.0005
R212 VDD.n1078 VDD.n401 9.0005
R213 VDD.n1079 VDD.n400 9.0005
R214 VDD.n399 VDD.n391 9.0005
R215 VDD.n398 VDD.n397 9.0005
R216 VDD.n226 VDD.n396 9.11485
R217 VDD.n1077 VDD.n1076 9.0005
R218 VDD.n1072 VDD.n402 9.0005
R219 VDD.n1074 VDD.n1073 9.0005
R220 VDD.n206 VDD.n58 4.44407
R221 VDD.n627 VDD.n206 0.114852
R222 VDD.n269 VDD.n296 0.114852
R223 VDD.n269 VDD.n58 4.44407
R224 VDD.n585 VDD.n112 0.114852
R225 VDD.n112 VDD.n58 4.44407
R226 VDD.n587 VDD.n158 0.114852
R227 VDD.n158 VDD.n58 4.44407
R228 VDD.n589 VDD.n86 9.0005
R229 VDD.n239 VDD.n86 4.44407
R230 VDD.n591 VDD.n239 0.114852
R231 VDD.n102 VDD.n86 4.44407
R232 VDD.n593 VDD.n102 0.114852
R233 VDD.n274 VDD.n86 4.44407
R234 VDD.n595 VDD.n274 0.114852
R235 VDD.n596 VDD.n283 0.114852
R236 VDD.n283 VDD.n121 4.44407
R237 VDD.n149 VDD.n121 4.44407
R238 VDD.n599 VDD.n149 9.11485
R239 VDD.n230 VDD.n51 4.44407
R240 VDD.n222 VDD.n51 4.44407
R241 VDD.n603 VDD.n222 0.114852
R242 VDD.n604 VDD.n51 9.0005
R243 VDD.n223 VDD.n51 4.44407
R244 VDD.n606 VDD.n223 0.114852
R245 VDD.n607 VDD.n224 0.114852
R246 VDD.n224 VDD.n51 4.44407
R247 VDD.n610 VDD.n51 9.0005
R248 VDD.n611 VDD.n157 0.114852
R249 VDD.n157 VDD.n51 4.44407
R250 VDD.n613 VDD.n275 0.114852
R251 VDD.n275 VDD.n51 4.44407
R252 VDD.n302 VDD.n51 4.44407
R253 VDD.n616 VDD.n302 0.114852
R254 VDD.n617 VDD.n51 9.0005
R255 VDD.n618 VDD.n105 0.114852
R256 VDD.n105 VDD.t3 4.44407
R257 VDD.n620 VDD.n320 0.114852
R258 VDD.n610 VDD.n609 9.0005
R259 VDD.n611 VDD.n560 9.0005
R260 VDD.n612 VDD.n559 9.0005
R261 VDD.n613 VDD.n558 9.0005
R262 VDD.n614 VDD.n557 9.0005
R263 VDD.n615 VDD.n556 9.0005
R264 VDD.n616 VDD.n555 9.0005
R265 VDD.n617 VDD.n554 9.0005
R266 VDD.n618 VDD.n553 9.0005
R267 VDD.n619 VDD.n552 9.0005
R268 VDD.n620 VDD.n551 9.0005
R269 VDD.n621 VDD.n550 9.0005
R270 VDD.n623 VDD.n622 9.0005
R271 VDD.n624 VDD.n412 9.0005
R272 VDD.n626 VDD.n625 9.0005
R273 VDD.n549 VDD.n411 9.0005
R274 VDD.n548 VDD.n547 9.0005
R275 VDD.n297 VDD.n413 9.0005
R276 VDD.n546 VDD.n545 9.0005
R277 VDD.n320 VDD.t3 4.44407
R278 VDD.n238 VDD.t3 4.44407
R279 VDD.n412 VDD.n238 0.114852
R280 VDD.t3 VDD.n276 4.44407
R281 VDD.n411 VDD.n276 0.114852
R282 VDD.n191 VDD.t3 4.44407
R283 VDD.n191 VDD.n297 0.114852
R284 VDD.t3 VDD.n546 9.0005
R285 VDD.n543 VDD.t3 9.0005
R286 VDD.n84 VDD.n153 4.44407
R287 VDD.n153 VDD.n415 0.114852
R288 VDD.n152 VDD.n542 0.114852
R289 VDD.n84 VDD.n152 4.44407
R290 VDD.n303 VDD.n84 4.44407
R291 VDD.n303 VDD.n417 0.114852
R292 VDD.n544 VDD.n543 9.0005
R293 VDD.n310 VDD.n414 9.0005
R294 VDD.n540 VDD.n415 9.0005
R295 VDD.n542 VDD.n541 9.0005
R296 VDD.n539 VDD.n311 9.0005
R297 VDD.n538 VDD.n537 9.0005
R298 VDD.n417 VDD.n416 9.0005
R299 VDD.n529 VDD.n528 9.0005
R300 VDD.n530 VDD.n527 9.0005
R301 VDD.n532 VDD.n531 9.0005
R302 VDD.n533 VDD.n418 9.0005
R303 VDD.n534 VDD.n419 9.0005
R304 VDD.n536 VDD.n535 9.0005
R305 VDD.n526 VDD.n301 9.0005
R306 VDD.n525 VDD.n524 9.0005
R307 VDD.n282 VDD.n420 9.0005
R308 VDD.n520 VDD.n421 9.0005
R309 VDD.n521 VDD.n422 9.0005
R310 VDD.n523 VDD.n522 9.0005
R311 VDD.n108 VDD.n84 4.44407
R312 VDD.n530 VDD.n108 0.114852
R313 VDD.n531 VDD.t3 9.0005
R314 VDD.n319 VDD.n418 0.114852
R315 VDD.t3 VDD.n319 4.44407
R316 VDD.t3 VDD.n237 4.44407
R317 VDD.n237 VDD.n301 0.114852
R318 VDD.n277 VDD.n78 4.44407
R319 VDD.n277 VDD.n282 0.114852
R320 VDD.n78 VDD.n190 4.44407
R321 VDD.n190 VDD.n422 0.114852
R322 VDD.n78 VDD.n523 9.0005
R323 VDD.n518 VDD.n78 9.0005
R324 VDD.n78 VDD.n154 4.44309
R325 VDD.n154 VDD.n424 0.116823
R326 VDD.n151 VDD.n517 0.116823
R327 VDD.n67 VDD.n151 4.44309
R328 VDD.n304 VDD.n67 4.44309
R329 VDD.n304 VDD.n426 0.116823
R330 VDD.n519 VDD.n518 9.0005
R331 VDD.n312 VDD.n423 9.0005
R332 VDD.n515 VDD.n424 9.0005
R333 VDD.n517 VDD.n516 9.0005
R334 VDD.n514 VDD.n313 9.0005
R335 VDD.n513 VDD.n512 9.0005
R336 VDD.n426 VDD.n425 9.0005
R337 VDD.n504 VDD.n503 9.0005
R338 VDD.n505 VDD.n502 9.0005
R339 VDD.n507 VDD.n506 9.0005
R340 VDD.n508 VDD.n427 9.0005
R341 VDD.n509 VDD.n428 9.0005
R342 VDD.n511 VDD.n510 9.0005
R343 VDD.n501 VDD.n300 9.0005
R344 VDD.n500 VDD.n499 9.0005
R345 VDD.n281 VDD.n429 9.0005
R346 VDD.n495 VDD.n430 9.0005
R347 VDD.n496 VDD.n431 9.0005
R348 VDD.n498 VDD.n497 9.0005
R349 VDD.n504 VDD.n109 0.116823
R350 VDD.n109 VDD.n67 4.44309
R351 VDD.n506 VDD.n67 9.0005
R352 VDD.n318 VDD.n427 0.116823
R353 VDD.n67 VDD.n318 4.44309
R354 VDD.n67 VDD.n236 4.44309
R355 VDD.n236 VDD.n300 0.116823
R356 VDD.n278 VDD.n67 4.44309
R357 VDD.n278 VDD.n281 0.116823
R358 VDD.n67 VDD.n189 4.44309
R359 VDD.n189 VDD.n431 0.116823
R360 VDD.n67 VDD.n498 9.0005
R361 VDD.n493 VDD.n104 9.0005
R362 VDD.n104 VDD.n155 4.44407
R363 VDD.n155 VDD.n433 0.114852
R364 VDD.n104 VDD.n492 9.0005
R365 VDD.n104 VDD.n273 4.44407
R366 VDD.n487 VDD.n273 0.114852
R367 VDD.n104 VDD.n220 9.0005
R368 VDD.n104 VDD.n270 4.44407
R369 VDD.n270 VDD.n484 9.11485
R370 VDD.n482 VDD.n49 9.0005
R371 VDD.n307 VDD.n436 0.114852
R372 VDD.n49 VDD.n307 4.44407
R373 VDD.n49 VDD.n221 4.44407
R374 VDD.n221 VDD.n287 0.114852
R375 VDD.n68 VDD.n49 4.44407
R376 VDD.n68 VDD.n219 0.114852
R377 VDD.n49 VDD.n271 4.44407
R378 VDD.n271 VDD.n473 9.11485
R379 VDD.n471 VDD.n61 9.0005
R380 VDD.n61 VDD.n156 4.44407
R381 VDD.n156 VDD.n440 0.114852
R382 VDD.n150 VDD.n470 0.114852
R383 VDD.n61 VDD.n150 4.44407
R384 VDD.n305 VDD.n61 4.44407
R385 VDD.n305 VDD.n442 0.114852
R386 VDD.n472 VDD.n471 9.0005
R387 VDD.n315 VDD.n439 9.0005
R388 VDD.n468 VDD.n440 9.0005
R389 VDD.n470 VDD.n469 9.0005
R390 VDD.n467 VDD.n316 9.0005
R391 VDD.n466 VDD.n465 9.0005
R392 VDD.n442 VDD.n441 9.0005
R393 VDD.n457 VDD.n456 9.0005
R394 VDD.n458 VDD.n455 9.0005
R395 VDD.n460 VDD.n459 9.0005
R396 VDD.n461 VDD.n443 9.0005
R397 VDD.n462 VDD.n444 9.0005
R398 VDD.n464 VDD.n463 9.0005
R399 VDD.n454 VDD.n299 9.0005
R400 VDD.n453 VDD.n452 9.0005
R401 VDD.n280 VDD.n445 9.0005
R402 VDD.n448 VDD.n446 9.0005
R403 VDD.n449 VDD.n447 9.0005
R404 VDD.n451 VDD.n450 9.0005
R405 VDD.n110 VDD.n61 4.44407
R406 VDD.n458 VDD.n110 0.114852
R407 VDD.n459 VDD.n61 9.0005
R408 VDD.n317 VDD.n443 0.114852
R409 VDD.n61 VDD.n317 4.44407
R410 VDD.n61 VDD.n235 4.44407
R411 VDD.n235 VDD.n299 0.114852
R412 VDD.n279 VDD.n61 4.44407
R413 VDD.n279 VDD.n280 0.114852
R414 VDD.n61 VDD.n188 4.44407
R415 VDD.n188 VDD.n447 0.114852
R416 VDD.n61 VDD.n451 9.0005
R417 VDD.n450 VDD.n0 2.26547
R418 VDD.n0 VDD.t3 0.043594
R419 VDD.n627 VDD.n410 9.0005
R420 VDD.n582 VDD.n296 9.0005
R421 VDD.n584 VDD.n583 9.0005
R422 VDD.n585 VDD.n581 9.0005
R423 VDD.n586 VDD.n580 9.0005
R424 VDD.n587 VDD.n579 9.0005
R425 VDD.n588 VDD.n578 9.0005
R426 VDD.n589 VDD.n577 9.0005
R427 VDD.n590 VDD.n576 9.0005
R428 VDD.n591 VDD.n575 9.0005
R429 VDD.n592 VDD.n574 9.0005
R430 VDD.n593 VDD.n573 9.0005
R431 VDD.n594 VDD.n572 9.0005
R432 VDD.n595 VDD.n571 9.0005
R433 VDD.n596 VDD.n570 9.0005
R434 VDD.n597 VDD.n569 9.0005
R435 VDD.n598 VDD.n568 9.0005
R436 VDD.n230 VDD.n600 9.11485
R437 VDD.n601 VDD.n567 9.0005
R438 VDD.n602 VDD.n566 9.0005
R439 VDD.n603 VDD.n565 9.0005
R440 VDD.n604 VDD.n564 9.0005
R441 VDD.n605 VDD.n563 9.0005
R442 VDD.n606 VDD.n562 9.0005
R443 VDD.n607 VDD.n561 9.0005
R444 VDD.n494 VDD.n493 9.0005
R445 VDD.n314 VDD.n432 9.0005
R446 VDD.n490 VDD.n433 9.0005
R447 VDD.n492 VDD.n491 9.0005
R448 VDD.n489 VDD.n286 9.0005
R449 VDD.n488 VDD.n487 9.0005
R450 VDD.n220 VDD.n434 9.0005
R451 VDD.n486 VDD.n485 9.0005
R452 VDD.n483 VDD.n482 9.0005
R453 VDD.n436 VDD.n435 9.0005
R454 VDD.n479 VDD.n437 9.0005
R455 VDD.n481 VDD.n480 9.0005
R456 VDD.n478 VDD.n287 9.0005
R457 VDD.n477 VDD.n476 9.0005
R458 VDD.n219 VDD.n438 9.0005
R459 VDD.n475 VDD.n474 9.0005
R460 VDD.t0 VDD.n288 9.0005
R461 VDD.n1028 VDD.n199 0.114852
R462 VDD.n199 VDD.t0 4.44407
R463 VDD.n218 VDD.t0 4.44407
R464 VDD.n669 VDD.t0 9.0005
R465 VDD.n1031 VDD.n116 9.0005
R466 VDD.n200 VDD.n1032 0.114852
R467 VDD.n200 VDD.n116 4.44407
R468 VDD.n116 VDD.n217 4.44407
R469 VDD.n1033 VDD.n217 0.114852
R470 VDD.n82 VDD.n1034 9.0005
R471 VDD.n216 VDD.n82 4.44407
R472 VDD.n216 VDD.n289 0.114852
R473 VDD.n82 VDD.n1038 9.0005
R474 VDD.n233 VDD.n82 4.44407
R475 VDD.n960 VDD.n233 0.114852
R476 VDD.n961 VDD.n82 9.0005
R477 VDD.n964 VDD.n22 9.0005
R478 VDD.n192 VDD.n22 4.44407
R479 VDD.n966 VDD.n192 9.11485
R480 VDD.n967 VDD.n22 9.0005
R481 VDD.n953 VDD.n201 0.114852
R482 VDD.n22 VDD.n201 4.44407
R483 VDD.n956 VDD.n22 9.0005
R484 VDD.n193 VDD.n118 4.44407
R485 VDD.n660 VDD.n193 9.11485
R486 VDD.n215 VDD.n123 4.44407
R487 VDD.n215 VDD.n290 0.114852
R488 VDD.n13 VDD.n1042 9.0005
R489 VDD.n13 VDD.n111 9.0005
R490 VDD.n1043 VDD.n202 0.114852
R491 VDD.n202 VDD.n13 4.44407
R492 VDD.n13 VDD.n232 4.44407
R493 VDD.n650 VDD.n232 0.114852
R494 VDD.n655 VDD.n13 9.0005
R495 VDD.n653 VDD.n13 9.0005
R496 VDD.n652 VDD.n203 0.114852
R497 VDD.n203 VDD.n13 4.44407
R498 VDD.n1046 VDD.n7 9.0005
R499 VDD.n204 VDD.n644 0.114852
R500 VDD.n7 VDD.n204 4.44407
R501 VDD.n231 VDD.n7 4.44407
R502 VDD.n647 VDD.n231 0.114852
R503 VDD.n646 VDD.n7 9.0005
R504 VDD.n1050 VDD.n7 9.0005
R505 VDD.n194 VDD.n641 0.114852
R506 VDD.n7 VDD.n194 4.44407
R507 VDD.n7 VDD.n291 9.0005
R508 VDD.n195 VDD.n7 4.44407
R509 VDD.n195 VDD.n639 9.11485
R510 VDD.n1055 VDD.n7 9.0005
R511 VDD.n7 VDD.n197 4.44407
R512 VDD.n197 VDD.n1058 9.11485
R513 VDD.n234 VDD.n11 4.44407
R514 VDD.n1060 VDD.n11 9.0005
R515 VDD.n11 VDD.n229 4.44407
R516 VDD.n635 VDD.n229 0.114852
R517 VDD.n11 VDD.n862 9.0005
R518 VDD.n859 VDD.n11 9.0005
R519 VDD.n198 VDD.n11 4.44407
R520 VDD.n857 VDD.n198 9.11485
R521 VDD.n214 VDD.n11 4.44407
R522 VDD.n854 VDD.n11 9.0005
R523 VDD.n213 VDD.n66 4.44407
R524 VDD.n850 VDD.n66 9.0005
R525 VDD.n847 VDD.n66 9.0005
R526 VDD.n846 VDD.n205 0.114852
R527 VDD.n205 VDD.n40 4.44407
R528 VDD.n212 VDD.n40 4.44407
R529 VDD.n842 VDD.n40 9.0005
R530 VDD.n211 VDD.n40 4.44407
R531 VDD.n838 VDD.n40 9.0005
R532 VDD.n60 VDD.n228 4.44407
R533 VDD.n1063 VDD.n228 0.114852
R534 VDD.n1064 VDD.n60 9.0005
R535 VDD.n210 VDD.n60 4.44407
R536 VDD.n60 VDD.n761 9.0005
R537 VDD.n209 VDD.n60 4.44407
R538 VDD.n757 VDD.n60 9.0005
R539 VDD.n208 VDD.n59 4.44407
R540 VDD.n753 VDD.n59 9.0005
R541 VDD.n62 VDD.n207 4.44407
R542 VDD.n1067 VDD.n207 0.114852
R543 VDD.n62 VDD.n1068 9.0005
R544 VDD.n63 VDD.t0 4.44407
R545 VDD.n240 VDD.n1027 0.114852
R546 VDD.n240 VDD.t0 4.44407
R547 VDD.n187 VDD.t0 4.44407
R548 VDD.n1019 VDD.n187 0.114852
R549 VDD.n1018 VDD.t0 9.0005
R550 VDD.n675 VDD.n241 0.114852
R551 VDD.n241 VDD.n16 4.44407
R552 VDD.n186 VDD.n16 4.44407
R553 VDD.n1012 VDD.n186 0.114852
R554 VDD.n677 VDD.n16 9.0005
R555 VDD.n1008 VDD.n242 0.114852
R556 VDD.n242 VDD.n16 4.44407
R557 VDD.n185 VDD.n16 4.44407
R558 VDD.n679 VDD.n185 0.114852
R559 VDD.n1002 VDD.n16 9.0005
R560 VDD.n1001 VDD.n243 0.114852
R561 VDD.n243 VDD.n19 4.44407
R562 VDD.n184 VDD.n19 4.44407
R563 VDD.n996 VDD.n184 0.114852
R564 VDD.n995 VDD.n19 9.0005
R565 VDD.n994 VDD.n244 0.114852
R566 VDD.n244 VDD.n19 4.44407
R567 VDD.n183 VDD.n19 4.44407
R568 VDD.n989 VDD.n183 0.114852
R569 VDD.n988 VDD.n19 9.0005
R570 VDD.n245 VDD.n298 0.114852
R571 VDD.n245 VDD.n21 4.44407
R572 VDD.n182 VDD.n21 4.44407
R573 VDD.n982 VDD.n182 0.114852
R574 VDD.n686 VDD.n21 9.0005
R575 VDD.n978 VDD.n246 0.114852
R576 VDD.n246 VDD.n21 4.44407
R577 VDD.n181 VDD.n21 4.44407
R578 VDD.n688 VDD.n181 0.114852
R579 VDD.n972 VDD.n21 9.0005
R580 VDD.n971 VDD.n247 0.114852
R581 VDD.n247 VDD.n24 4.44407
R582 VDD.n180 VDD.n24 4.44407
R583 VDD.n948 VDD.n180 0.114852
R584 VDD.n947 VDD.n24 9.0005
R585 VDD.n946 VDD.n248 0.114852
R586 VDD.n248 VDD.n24 4.44407
R587 VDD.n179 VDD.n24 4.44407
R588 VDD.n941 VDD.n179 0.114852
R589 VDD.n940 VDD.n24 9.0005
R590 VDD.n694 VDD.n249 0.114852
R591 VDD.n249 VDD.n25 4.44407
R592 VDD.n178 VDD.n25 4.44407
R593 VDD.n934 VDD.n178 0.114852
R594 VDD.n696 VDD.n25 9.0005
R595 VDD.n930 VDD.n250 0.114852
R596 VDD.n250 VDD.n25 4.44407
R597 VDD.n177 VDD.n25 4.44407
R598 VDD.n698 VDD.n177 0.114852
R599 VDD.n924 VDD.n25 9.0005
R600 VDD.n923 VDD.n251 0.114852
R601 VDD.n251 VDD.n27 4.44407
R602 VDD.n176 VDD.n27 4.44407
R603 VDD.n918 VDD.n176 0.114852
R604 VDD.n917 VDD.n27 9.0005
R605 VDD.n916 VDD.n252 0.114852
R606 VDD.n252 VDD.n27 4.44407
R607 VDD.n175 VDD.n27 4.44407
R608 VDD.n911 VDD.n175 0.114852
R609 VDD.n910 VDD.n27 9.0005
R610 VDD.n704 VDD.n253 0.114852
R611 VDD.n253 VDD.n29 4.44407
R612 VDD.n174 VDD.n29 4.44407
R613 VDD.n904 VDD.n174 0.114852
R614 VDD.n706 VDD.n29 9.0005
R615 VDD.n900 VDD.n254 0.114852
R616 VDD.n254 VDD.n29 4.44407
R617 VDD.n173 VDD.n29 4.44407
R618 VDD.n708 VDD.n173 0.114852
R619 VDD.n894 VDD.n29 9.0005
R620 VDD.n893 VDD.n255 0.114852
R621 VDD.n255 VDD.n31 4.44407
R622 VDD.n172 VDD.n31 4.44407
R623 VDD.n888 VDD.n172 0.114852
R624 VDD.n887 VDD.n31 9.0005
R625 VDD.n886 VDD.n256 0.114852
R626 VDD.n256 VDD.n31 4.44407
R627 VDD.n171 VDD.n31 4.44407
R628 VDD.n881 VDD.n171 0.114852
R629 VDD.n880 VDD.n31 9.0005
R630 VDD.n714 VDD.n257 0.114852
R631 VDD.n257 VDD.n33 4.44407
R632 VDD.n170 VDD.n33 4.44407
R633 VDD.n874 VDD.n170 0.114852
R634 VDD.n716 VDD.n33 9.0005
R635 VDD.n870 VDD.n258 0.114852
R636 VDD.n258 VDD.n33 4.44407
R637 VDD.n169 VDD.n33 4.44407
R638 VDD.n718 VDD.n169 0.114852
R639 VDD.n864 VDD.n33 9.0005
R640 VDD.n863 VDD.n259 0.114852
R641 VDD.n259 VDD.n36 4.44407
R642 VDD.n168 VDD.n36 4.44407
R643 VDD.n808 VDD.n168 0.114852
R644 VDD.n809 VDD.n36 9.0005
R645 VDD.n810 VDD.n260 0.114852
R646 VDD.n260 VDD.n36 4.44407
R647 VDD.n167 VDD.n36 4.44407
R648 VDD.n813 VDD.n167 0.114852
R649 VDD.n814 VDD.n36 9.0005
R650 VDD.n815 VDD.n261 0.114852
R651 VDD.n261 VDD.n39 4.44407
R652 VDD.n166 VDD.n39 4.44407
R653 VDD.n818 VDD.n166 0.114852
R654 VDD.n819 VDD.n39 9.0005
R655 VDD.n820 VDD.n262 0.114852
R656 VDD.n262 VDD.n39 4.44407
R657 VDD.n165 VDD.n39 4.44407
R658 VDD.n823 VDD.n165 0.114852
R659 VDD.n824 VDD.n39 9.0005
R660 VDD.n825 VDD.n263 0.114852
R661 VDD.n263 VDD.n42 4.44407
R662 VDD.n164 VDD.n42 4.44407
R663 VDD.n828 VDD.n164 0.114852
R664 VDD.n829 VDD.n42 9.0005
R665 VDD.n830 VDD.n264 0.114852
R666 VDD.n264 VDD.n42 4.44407
R667 VDD.n163 VDD.n42 4.44407
R668 VDD.n833 VDD.n163 0.114852
R669 VDD.n834 VDD.n42 9.0005
R670 VDD.n265 VDD.n835 0.114852
R671 VDD.n265 VDD.n44 4.44407
R672 VDD.n162 VDD.n44 4.44407
R673 VDD.n773 VDD.n162 0.114852
R674 VDD.n772 VDD.n44 9.0005
R675 VDD.n729 VDD.n266 0.114852
R676 VDD.n266 VDD.n44 4.44407
R677 VDD.n161 VDD.n44 4.44407
R678 VDD.n766 VDD.n161 0.114852
R679 VDD.n731 VDD.n44 9.0005
R680 VDD.n762 VDD.n267 0.114852
R681 VDD.n267 VDD.n47 4.44407
R682 VDD.n160 VDD.n47 4.44407
R683 VDD.n744 VDD.n160 0.114852
R684 VDD.n745 VDD.n47 9.0005
R685 VDD.n746 VDD.n268 0.114852
R686 VDD.n268 VDD.n47 4.44407
R687 VDD.n159 VDD.n47 4.44407
R688 VDD.n749 VDD.n159 0.114852
R689 VDD.n750 VDD.n47 9.0005
R690 VDD.n63 VDD.n1025 9.11485
R691 VDD.n1026 VDD.n1024 9.0005
R692 VDD.n1027 VDD.n1023 9.0005
R693 VDD.n1022 VDD.n673 9.0005
R694 VDD.n1021 VDD.n1020 9.0005
R695 VDD.n1019 VDD.n674 9.0005
R696 VDD.n1018 VDD.n1017 9.0005
R697 VDD.n1016 VDD.n675 9.0005
R698 VDD.n1015 VDD.n1014 9.0005
R699 VDD.n1013 VDD.n676 9.0005
R700 VDD.n1012 VDD.n1011 9.0005
R701 VDD.n1010 VDD.n677 9.0005
R702 VDD.n1009 VDD.n1008 9.0005
R703 VDD.n1007 VDD.n678 9.0005
R704 VDD.n1006 VDD.n1005 9.0005
R705 VDD.n1004 VDD.n679 9.0005
R706 VDD.n1003 VDD.n1002 9.0005
R707 VDD.n1001 VDD.n680 9.0005
R708 VDD.n1000 VDD.n999 9.0005
R709 VDD.n998 VDD.n681 9.0005
R710 VDD.n997 VDD.n996 9.0005
R711 VDD.n995 VDD.n682 9.0005
R712 VDD.n994 VDD.n993 9.0005
R713 VDD.n992 VDD.n683 9.0005
R714 VDD.n991 VDD.n990 9.0005
R715 VDD.n989 VDD.n684 9.0005
R716 VDD.n988 VDD.n987 9.0005
R717 VDD.n986 VDD.n298 9.0005
R718 VDD.n985 VDD.n984 9.0005
R719 VDD.n983 VDD.n685 9.0005
R720 VDD.n982 VDD.n981 9.0005
R721 VDD.n980 VDD.n686 9.0005
R722 VDD.n979 VDD.n978 9.0005
R723 VDD.n977 VDD.n687 9.0005
R724 VDD.n976 VDD.n975 9.0005
R725 VDD.n974 VDD.n688 9.0005
R726 VDD.n973 VDD.n972 9.0005
R727 VDD.n971 VDD.n689 9.0005
R728 VDD.n952 VDD.n951 9.0005
R729 VDD.n950 VDD.n690 9.0005
R730 VDD.n949 VDD.n948 9.0005
R731 VDD.n947 VDD.n691 9.0005
R732 VDD.n946 VDD.n945 9.0005
R733 VDD.n944 VDD.n692 9.0005
R734 VDD.n943 VDD.n942 9.0005
R735 VDD.n941 VDD.n693 9.0005
R736 VDD.n940 VDD.n939 9.0005
R737 VDD.n938 VDD.n694 9.0005
R738 VDD.n937 VDD.n936 9.0005
R739 VDD.n935 VDD.n695 9.0005
R740 VDD.n934 VDD.n933 9.0005
R741 VDD.n932 VDD.n696 9.0005
R742 VDD.n931 VDD.n930 9.0005
R743 VDD.n929 VDD.n697 9.0005
R744 VDD.n928 VDD.n927 9.0005
R745 VDD.n926 VDD.n698 9.0005
R746 VDD.n925 VDD.n924 9.0005
R747 VDD.n923 VDD.n699 9.0005
R748 VDD.n922 VDD.n921 9.0005
R749 VDD.n920 VDD.n700 9.0005
R750 VDD.n919 VDD.n918 9.0005
R751 VDD.n917 VDD.n701 9.0005
R752 VDD.n916 VDD.n915 9.0005
R753 VDD.n914 VDD.n702 9.0005
R754 VDD.n913 VDD.n912 9.0005
R755 VDD.n911 VDD.n703 9.0005
R756 VDD.n910 VDD.n909 9.0005
R757 VDD.n908 VDD.n704 9.0005
R758 VDD.n907 VDD.n906 9.0005
R759 VDD.n905 VDD.n705 9.0005
R760 VDD.n904 VDD.n903 9.0005
R761 VDD.n902 VDD.n706 9.0005
R762 VDD.n901 VDD.n900 9.0005
R763 VDD.n899 VDD.n707 9.0005
R764 VDD.n898 VDD.n897 9.0005
R765 VDD.n896 VDD.n708 9.0005
R766 VDD.n895 VDD.n894 9.0005
R767 VDD.n893 VDD.n709 9.0005
R768 VDD.n892 VDD.n891 9.0005
R769 VDD.n890 VDD.n710 9.0005
R770 VDD.n889 VDD.n888 9.0005
R771 VDD.n887 VDD.n711 9.0005
R772 VDD.n886 VDD.n885 9.0005
R773 VDD.n884 VDD.n712 9.0005
R774 VDD.n883 VDD.n882 9.0005
R775 VDD.n881 VDD.n713 9.0005
R776 VDD.n880 VDD.n879 9.0005
R777 VDD.n878 VDD.n714 9.0005
R778 VDD.n877 VDD.n876 9.0005
R779 VDD.n875 VDD.n715 9.0005
R780 VDD.n874 VDD.n873 9.0005
R781 VDD.n872 VDD.n716 9.0005
R782 VDD.n871 VDD.n870 9.0005
R783 VDD.n869 VDD.n717 9.0005
R784 VDD.n868 VDD.n867 9.0005
R785 VDD.n866 VDD.n718 9.0005
R786 VDD.n865 VDD.n864 9.0005
R787 VDD.n863 VDD.n719 9.0005
R788 VDD.n805 VDD.n720 9.0005
R789 VDD.n807 VDD.n806 9.0005
R790 VDD.n808 VDD.n804 9.0005
R791 VDD.n809 VDD.n803 9.0005
R792 VDD.n810 VDD.n802 9.0005
R793 VDD.n811 VDD.n801 9.0005
R794 VDD.n812 VDD.n800 9.0005
R795 VDD.n813 VDD.n799 9.0005
R796 VDD.n814 VDD.n798 9.0005
R797 VDD.n815 VDD.n797 9.0005
R798 VDD.n816 VDD.n796 9.0005
R799 VDD.n817 VDD.n795 9.0005
R800 VDD.n818 VDD.n794 9.0005
R801 VDD.n819 VDD.n793 9.0005
R802 VDD.n820 VDD.n792 9.0005
R803 VDD.n821 VDD.n791 9.0005
R804 VDD.n822 VDD.n790 9.0005
R805 VDD.n823 VDD.n789 9.0005
R806 VDD.n824 VDD.n788 9.0005
R807 VDD.n825 VDD.n787 9.0005
R808 VDD.n826 VDD.n786 9.0005
R809 VDD.n827 VDD.n785 9.0005
R810 VDD.n828 VDD.n784 9.0005
R811 VDD.n829 VDD.n783 9.0005
R812 VDD.n830 VDD.n782 9.0005
R813 VDD.n831 VDD.n781 9.0005
R814 VDD.n832 VDD.n780 9.0005
R815 VDD.n833 VDD.n779 9.0005
R816 VDD.n834 VDD.n778 9.0005
R817 VDD.n835 VDD.n777 9.0005
R818 VDD.n776 VDD.n727 9.0005
R819 VDD.n775 VDD.n774 9.0005
R820 VDD.n773 VDD.n728 9.0005
R821 VDD.n772 VDD.n771 9.0005
R822 VDD.n770 VDD.n729 9.0005
R823 VDD.n769 VDD.n768 9.0005
R824 VDD.n767 VDD.n730 9.0005
R825 VDD.n766 VDD.n765 9.0005
R826 VDD.n764 VDD.n731 9.0005
R827 VDD.n763 VDD.n762 9.0005
R828 VDD.n733 VDD.n732 9.0005
R829 VDD.n743 VDD.n742 9.0005
R830 VDD.n744 VDD.n741 9.0005
R831 VDD.n745 VDD.n740 9.0005
R832 VDD.n746 VDD.n739 9.0005
R833 VDD.n747 VDD.n738 9.0005
R834 VDD.n748 VDD.n737 9.0005
R835 VDD.n749 VDD.n736 9.0005
R836 VDD.n750 VDD.n48 0.567346
R837 VDD.n48 VDD.n3 0.914539
R838 VDD.n736 VDD.n48 1.45071
R839 VDD.n128 VDD.n288 9.0005
R840 VDD.n1028 VDD.n672 9.0005
R841 VDD.n218 VDD.n1030 9.11485
R842 VDD.n671 VDD.n668 9.0005
R843 VDD.n670 VDD.n669 9.0005
R844 VDD.n1031 VDD.n667 9.0005
R845 VDD.n1032 VDD.n666 9.0005
R846 VDD.n1033 VDD.n663 9.0005
R847 VDD.n1034 VDD.n662 9.0005
R848 VDD.n1036 VDD.n289 9.0005
R849 VDD.n1038 VDD.n1037 9.0005
R850 VDD.n960 VDD.n959 9.0005
R851 VDD.n962 VDD.n961 9.0005
R852 VDD.n964 VDD.n963 9.0005
R853 VDD.n965 VDD.n958 9.0005
R854 VDD.n968 VDD.n967 9.0005
R855 VDD.n969 VDD.n953 9.0005
R856 VDD.n957 VDD.n956 9.0005
R857 VDD.n955 VDD.n954 9.0005
R858 VDD.n1040 VDD.n290 9.0005
R859 VDD.n1042 VDD.n1041 9.0005
R860 VDD.n659 VDD.n111 9.0005
R861 VDD.n1043 VDD.n658 9.0005
R862 VDD.n657 VDD.n650 9.0005
R863 VDD.n656 VDD.n655 9.0005
R864 VDD.n654 VDD.n653 9.0005
R865 VDD.n652 VDD.n651 9.0005
R866 VDD.n1047 VDD.n1046 9.0005
R867 VDD.n1048 VDD.n644 9.0005
R868 VDD.n647 VDD.n645 9.0005
R869 VDD.n646 VDD.n643 9.0005
R870 VDD.n1051 VDD.n1050 9.0005
R871 VDD.n1052 VDD.n641 9.0005
R872 VDD.n642 VDD.n291 9.0005
R873 VDD.n1054 VDD.n640 9.0005
R874 VDD.n1056 VDD.n1055 9.0005
R875 VDD.n1057 VDD.n196 9.0005
R876 VDD.n638 VDD.n234 9.11485
R877 VDD.n1059 VDD.n637 9.0005
R878 VDD.n1061 VDD.n1060 9.0005
R879 VDD.n636 VDD.n635 9.0005
R880 VDD.n862 VDD.n861 9.0005
R881 VDD.n860 VDD.n859 9.0005
R882 VDD.n858 VDD.n721 9.0005
R883 VDD.n856 VDD.n214 9.11485
R884 VDD.n855 VDD.n722 9.0005
R885 VDD.n854 VDD.n853 9.0005
R886 VDD.n852 VDD.n213 9.11485
R887 VDD.n851 VDD.n723 9.0005
R888 VDD.n850 VDD.n849 9.0005
R889 VDD.n848 VDD.n847 9.0005
R890 VDD.n846 VDD.n724 9.0005
R891 VDD.n844 VDD.n212 9.11485
R892 VDD.n843 VDD.n725 9.0005
R893 VDD.n842 VDD.n841 9.0005
R894 VDD.n840 VDD.n211 9.11485
R895 VDD.n839 VDD.n726 9.0005
R896 VDD.n838 VDD.n837 9.0005
R897 VDD.n1063 VDD.n634 9.0005
R898 VDD.n1065 VDD.n1064 9.0005
R899 VDD.n210 VDD.n1066 9.11485
R900 VDD.n633 VDD.n632 9.0005
R901 VDD.n761 VDD.n760 9.0005
R902 VDD.n759 VDD.n209 9.11485
R903 VDD.n758 VDD.n734 9.0005
R904 VDD.n757 VDD.n756 9.0005
R905 VDD.n755 VDD.n208 9.11485
R906 VDD.n754 VDD.n735 9.0005
R907 VDD.n753 VDD.n752 9.0005
R908 VDD.n1067 VDD.n631 9.0005
R909 VDD.n1068 VDD.n630 9.0005
R910 VDD.n55 VDD.t1 4.71716
R911 VDD.t58 VDD.t120 8.95516
R912 VDD.n1071 VDD.n1070 8.81559
R913 VDD.n322 VDD.t373 8.76054
R914 VDD.n322 VDD.t25 8.76054
R915 VDD.n58 VDD.t358 8.76054
R916 VDD.n58 VDD.t138 8.76054
R917 VDD.n58 VDD.t31 8.76054
R918 VDD.n58 VDD.t130 8.76054
R919 VDD.n86 VDD.t134 8.76054
R920 VDD.n86 VDD.t327 8.76054
R921 VDD.n86 VDD.t30 8.76054
R922 VDD.n86 VDD.t129 8.76054
R923 VDD.n86 VDD.t341 8.76054
R924 VDD.n86 VDD.t52 8.76054
R925 VDD.n86 VDD.t359 8.76054
R926 VDD.n86 VDD.t137 8.76054
R927 VDD.n121 VDD.t135 8.76054
R928 VDD.n121 VDD.t325 8.76054
R929 VDD.n121 VDD.t225 8.76054
R930 VDD.n121 VDD.t46 8.76054
R931 VDD.n49 VDD.t80 8.76054
R932 VDD.t1 VDD.n117 0.510878
R933 VDD.n57 VDD.n79 1.10133
R934 VDD.n83 VDD.n86 0.202722
R935 VDD.t3 VDD.n78 0.629552
R936 VDD.n116 VDD.n50 0.234658
R937 VDD.n118 VDD.n123 0.256568
R938 VDD.n62 VDD.n106 0.528051
R939 VDD.n4 VDD.n75 0.35501
R940 VDD.n72 VDD 0.591552
R941 VDD.t42 VDD.n321 8.47111
R942 VDD.t42 VDD.n308 4.22406
R943 VDD.n51 VDD.t401 7.62594
R944 VDD.t3 VDD.t400 7.62594
R945 VDD.n84 VDD.t398 7.62594
R946 VDD.n67 VDD.t395 7.62594
R947 VDD.n61 VDD.t392 7.62594
R948 VDD.t3 VDD.t389 7.62594
R949 VDD.t3 VDD.t386 7.62594
R950 VDD.t3 VDD.t384 7.62594
R951 VDD.t3 VDD.t385 7.62594
R952 VDD.t3 VDD.t387 7.62594
R953 VDD.t3 VDD.t388 7.62594
R954 VDD.n61 VDD.t390 7.62594
R955 VDD.n61 VDD.t391 7.62594
R956 VDD.n67 VDD.t393 7.62594
R957 VDD.n67 VDD.t394 7.62594
R958 VDD.n78 VDD.t396 7.62594
R959 VDD.t3 VDD.t397 7.62594
R960 VDD.t3 VDD.t399 7.62594
R961 VDD.n148 VDD.t0 2.51424
R962 VDD.t0 VDD.n129 2.51424
R963 VDD.t0 VDD.t49 6.09901
R964 VDD.t0 VDD.t217 6.09901
R965 VDD.n116 VDD.t54 6.09901
R966 VDD.n82 VDD.t212 6.09901
R967 VDD.n82 VDD.t71 6.09901
R968 VDD.n82 VDD.t69 6.09901
R969 VDD.n22 VDD.t82 6.09901
R970 VDD.n22 VDD.t60 6.09901
R971 VDD.n123 VDD.t218 6.09901
R972 VDD.n13 VDD.t43 6.09901
R973 VDD.n13 VDD.t114 6.09901
R974 VDD.n13 VDD.t28 6.09901
R975 VDD.n13 VDD.t67 6.09901
R976 VDD.n7 VDD.t53 6.09901
R977 VDD.n7 VDD.t118 6.09901
R978 VDD.n7 VDD.t214 6.09901
R979 VDD.n7 VDD.t36 6.09901
R980 VDD.n11 VDD.t330 6.09901
R981 VDD.n11 VDD.t65 6.09901
R982 VDD.n11 VDD.t175 6.09901
R983 VDD.n11 VDD.t33 6.09901
R984 VDD.n66 VDD.t88 6.09901
R985 VDD.n66 VDD.t131 6.09901
R986 VDD.n40 VDD.t7 6.09901
R987 VDD.n40 VDD.t126 6.09901
R988 VDD.n60 VDD.t112 6.09901
R989 VDD.n60 VDD.t190 6.09901
R990 VDD.n60 VDD.t338 6.09901
R991 VDD.n59 VDD.t178 6.09901
R992 VDD.n62 VDD.t150 6.09901
R993 VDD.n62 VDD.t97 6.09901
R994 VDD.n75 VDD.t70 6.09901
R995 VDD.t3 VDD.t244 5.99122
R996 VDD.t3 VDD.t96 5.99122
R997 VDD.n61 VDD.t34 5.99122
R998 VDD.n67 VDD.t103 5.99122
R999 VDD.n78 VDD.t139 5.99122
R1000 VDD.t3 VDD.t45 5.99122
R1001 VDD.n71 VDD.t72 5.9886
R1002 VDD.n51 VDD.t63 5.98839
R1003 VDD.n308 VDD.t360 5.97675
R1004 VDD.n308 VDD.t27 5.97675
R1005 VDD.n58 VDD.t357 5.97169
R1006 VDD.n86 VDD.t229 5.97169
R1007 VDD.n121 VDD.t181 5.97169
R1008 VDD.n121 VDD.t47 5.97169
R1009 VDD.n58 VDD.t249 5.97146
R1010 VDD.n86 VDD.t155 5.97146
R1011 VDD.n121 VDD.t372 5.97146
R1012 VDD.n121 VDD.t226 5.97146
R1013 VDD.n51 VDD.t183 5.96935
R1014 VDD.t3 VDD.t105 5.96935
R1015 VDD.t3 VDD.t185 5.96935
R1016 VDD.n84 VDD.t141 5.96935
R1017 VDD.t3 VDD.t170 5.96935
R1018 VDD.n67 VDD.t205 5.96935
R1019 VDD.n78 VDD.t164 5.96935
R1020 VDD.n61 VDD.t40 5.96935
R1021 VDD.n67 VDD.t194 5.96935
R1022 VDD.t3 VDD.t140 5.96935
R1023 VDD.n61 VDD.t227 5.96935
R1024 VDD.t3 VDD.t203 5.96935
R1025 VDD.t3 VDD.t91 5.96935
R1026 VDD.t3 VDD.t107 5.96935
R1027 VDD.t3 VDD.t84 5.96935
R1028 VDD.t3 VDD.t253 5.96935
R1029 VDD.t3 VDD.t87 5.96935
R1030 VDD.t3 VDD.t220 5.96935
R1031 VDD.t3 VDD.t256 5.96935
R1032 VDD.t3 VDD.t200 5.96935
R1033 VDD.t3 VDD.t251 5.96935
R1034 VDD.t3 VDD.t93 5.96935
R1035 VDD.n61 VDD.t163 5.96935
R1036 VDD.n61 VDD.t364 5.96935
R1037 VDD.n61 VDD.t167 5.96935
R1038 VDD.n61 VDD.t145 5.96935
R1039 VDD.n67 VDD.t144 5.96935
R1040 VDD.n67 VDD.t254 5.96935
R1041 VDD.n67 VDD.t148 5.96935
R1042 VDD.n67 VDD.t176 5.96935
R1043 VDD.t3 VDD.t208 5.96935
R1044 VDD.t3 VDD.t186 5.96935
R1045 VDD.t3 VDD.t169 5.96935
R1046 VDD.n84 VDD.t353 5.96935
R1047 VDD.t3 VDD.t363 5.96935
R1048 VDD.t3 VDD.t152 5.96935
R1049 VDD.n58 VDD.t326 5.96534
R1050 VDD.n58 VDD.t51 5.96534
R1051 VDD.n51 VDD.t146 5.96534
R1052 VDD.n51 VDD.t377 5.96534
R1053 VDD.n51 VDD.t48 5.96534
R1054 VDD.n51 VDD.t191 5.96534
R1055 VDD.n51 VDD.t344 5.96534
R1056 VDD.n51 VDD.t78 5.96534
R1057 VDD.n51 VDD.t55 5.96534
R1058 VDD.t3 VDD.t252 5.96534
R1059 VDD.t3 VDD.t211 5.96534
R1060 VDD.t3 VDD.t160 5.96534
R1061 VDD.t3 VDD.t68 5.96534
R1062 VDD.n84 VDD.t349 5.96534
R1063 VDD.n84 VDD.t173 5.96534
R1064 VDD.n78 VDD.t161 5.96534
R1065 VDD.n78 VDD.t44 5.96534
R1066 VDD.n78 VDD.t202 5.96534
R1067 VDD.n67 VDD.t329 5.96534
R1068 VDD.n67 VDD.t38 5.96534
R1069 VDD.n104 VDD.t193 5.96534
R1070 VDD.n104 VDD.t209 5.96534
R1071 VDD.n104 VDD.t334 5.96534
R1072 VDD.n104 VDD.t187 5.96534
R1073 VDD.n49 VDD.t238 5.96534
R1074 VDD.n49 VDD.t206 5.96534
R1075 VDD.n49 VDD.t64 5.96534
R1076 VDD.n49 VDD.t182 5.96534
R1077 VDD.n61 VDD.t332 5.96534
R1078 VDD.n61 VDD.t348 5.96534
R1079 VDD.n61 VDD.t66 5.96534
R1080 VDD.n61 VDD.t361 5.96534
R1081 VDD.n61 VDD.t115 5.96534
R1082 VDD.t3 VDD.t109 5.96534
R1083 VDD.t3 VDD.t101 5.96534
R1084 VDD.t3 VDD.t39 5.96534
R1085 VDD.t3 VDD.t111 5.96534
R1086 VDD.t3 VDD.t210 5.96534
R1087 VDD.t3 VDD.t158 5.96534
R1088 VDD.t3 VDD.t195 5.96534
R1089 VDD.t3 VDD.t151 5.96534
R1090 VDD.t3 VDD.t35 5.96534
R1091 VDD.t3 VDD.t98 5.96534
R1092 VDD.t3 VDD.t4 5.96534
R1093 VDD.t3 VDD.t37 5.96534
R1094 VDD.t3 VDD.t188 5.96534
R1095 VDD.t3 VDD.t354 5.96534
R1096 VDD.t3 VDD.t199 5.96534
R1097 VDD.t3 VDD.t365 5.96534
R1098 VDD.t3 VDD.t8 5.96534
R1099 VDD.n61 VDD.t196 5.96534
R1100 VDD.n61 VDD.t56 5.96534
R1101 VDD.n61 VDD.t174 5.96534
R1102 VDD.n67 VDD.t198 5.96534
R1103 VDD.n67 VDD.t5 5.96534
R1104 VDD.n67 VDD.t29 5.96534
R1105 VDD.t3 VDD.t197 5.96534
R1106 VDD.n84 VDD.t230 5.96534
R1107 VDD.t3 VDD.t59 5.96534
R1108 VDD.t3 VDD.t95 5.96534
R1109 VDD.n51 VDD.t110 5.96512
R1110 VDD.n58 VDD.t133 5.96512
R1111 VDD.n58 VDD.t339 5.96512
R1112 VDD.n84 VDD.t81 5.96512
R1113 VDD.n78 VDD.t336 5.96512
R1114 VDD.n61 VDD.t32 5.96512
R1115 VDD.n49 VDD.t117 5.96512
R1116 VDD.n104 VDD.t102 5.96512
R1117 VDD.t3 VDD.t219 5.96512
R1118 VDD.t3 VDD.t108 5.96512
R1119 VDD.t3 VDD.t337 5.96512
R1120 VDD.n71 VDD.t124 5.96478
R1121 VDD.n51 VDD.t184 5.65005
R1122 VDD.t3 VDD.t106 5.65005
R1123 VDD.n84 VDD.t142 5.65005
R1124 VDD.n67 VDD.t177 5.65005
R1125 VDD.n61 VDD.t41 5.65005
R1126 VDD.t3 VDD.t94 5.65005
R1127 VDD.t3 VDD.t204 5.65005
R1128 VDD.t3 VDD.t83 5.65005
R1129 VDD.t3 VDD.t86 5.65005
R1130 VDD.t3 VDD.t92 5.65005
R1131 VDD.t3 VDD.t201 5.65005
R1132 VDD.n61 VDD.t162 5.65005
R1133 VDD.n61 VDD.t166 5.65005
R1134 VDD.n67 VDD.t143 5.65005
R1135 VDD.n67 VDD.t147 5.65005
R1136 VDD.n78 VDD.t165 5.65005
R1137 VDD.t3 VDD.t168 5.65005
R1138 VDD.t3 VDD.t171 5.65005
R1139 VDD.n121 VDD.n86 0.475103
R1140 VDD.t0 VDD.n107 0.4255
R1141 VDD.n107 VDD.n66 0.455698
R1142 VDD.n69 VDD.n40 0.509101
R1143 VDD.t0 VDD.n119 0.597621
R1144 VDD.t0 VDD.n106 0.854278
R1145 VDD.t58 VDD.t270 5.70751
R1146 VDD.t58 VDD.t278 5.60347
R1147 VDD.n3 VDD.t289 5.60347
R1148 VDD.n73 VDD.t286 5.60347
R1149 VDD.t0 VDD.t284 5.71996
R1150 VDD.n74 VDD.t287 5.59675
R1151 VDD.n1 VDD.t323 5.59675
R1152 VDD.n2 VDD.t322 5.59675
R1153 VDD.n120 VDD.t321 5.59675
R1154 VDD.n46 VDD.t320 5.59675
R1155 VDD.n45 VDD.t315 5.59675
R1156 VDD.n43 VDD.t316 5.59675
R1157 VDD.n65 VDD.t317 5.59675
R1158 VDD.n40 VDD.t319 5.59675
R1159 VDD.n38 VDD.t318 5.59675
R1160 VDD.n37 VDD.t313 5.59675
R1161 VDD.n35 VDD.t294 5.59675
R1162 VDD.n34 VDD.t312 5.59675
R1163 VDD.n32 VDD.t293 5.59675
R1164 VDD.n5 VDD.t311 5.59675
R1165 VDD.n6 VDD.t301 5.59675
R1166 VDD.n30 VDD.t310 5.59675
R1167 VDD.n7 VDD.t304 5.59675
R1168 VDD.n28 VDD.t309 5.84843
R1169 VDD.n26 VDD.t305 5.77361
R1170 VDD.n13 VDD.t302 5.59675
R1171 VDD.n13 VDD.t307 5.59675
R1172 VDD.n23 VDD.t303 5.59675
R1173 VDD.n22 VDD.t306 5.59675
R1174 VDD.n20 VDD.t300 5.59675
R1175 VDD.n81 VDD.t296 5.59675
R1176 VDD.n18 VDD.t299 5.59675
R1177 VDD.n17 VDD.t292 5.59675
R1178 VDD.n15 VDD.t291 5.59675
R1179 VDD.t58 VDD.t271 5.59179
R1180 VDD.t0 VDD.t280 5.73121
R1181 VDD VDD.t261 4.9462
R1182 VDD.n408 VDD.t258 4.9462
R1183 VDD.n1076 VDD.n1075 4.73162
R1184 VDD.n387 VDD.n386 4.64666
R1185 VDD.n126 VDD.n125 1.69009
R1186 VDD.n76 VDD.n113 0.509214
R1187 VDD VDD.n628 3.2945
R1188 VDD VDD.n58 3.24369
R1189 VDD.n55 VDD 1.35145
R1190 VDD.n87 VDD.t263 2.6992
R1191 VDD.n10 VDD.t24 2.6992
R1192 VDD.n406 VDD.t266 2.6992
R1193 VDD.n404 VDD.t17 2.6992
R1194 VDD.n85 VDD.t9 2.6992
R1195 VDD.n405 VDD.t260 2.6992
R1196 VDD.n1080 VDD.t18 2.6992
R1197 VDD.n54 VDD.t10 2.6992
R1198 VDD.n390 VDD.t20 2.6992
R1199 VDD.n53 VDD.t12 2.6992
R1200 VDD.n9 VDD.t22 2.6992
R1201 VDD.n1081 VDD.t14 2.6992
R1202 VDD VDD.t268 2.84219
R1203 VDD.t42 VDD.n77 0.726719
R1204 VDD.n54 VDD.n1080 1.11007
R1205 VDD.n53 VDD.n390 1.11007
R1206 VDD.n9 VDD.n1081 1.11007
R1207 VDD.n1070 VDD.n1069 0.72826
R1208 VDD.n600 VDD.n599 0.692362
R1209 VDD.n1030 VDD.n1029 0.692362
R1210 VDD.n670 VDD.n667 0.692362
R1211 VDD.n665 VDD.n664 0.692362
R1212 VDD.n1035 VDD.n662 0.692362
R1213 VDD.n1037 VDD.n661 0.692362
R1214 VDD.n963 VDD.n962 0.692362
R1215 VDD.n968 VDD.n966 0.692362
R1216 VDD.n970 VDD.n957 0.692362
R1217 VDD.n1039 VDD.n660 0.692362
R1218 VDD.n1041 VDD.n659 0.692362
R1219 VDD.n1045 VDD.n1044 0.692362
R1220 VDD.n656 VDD.n654 0.692362
R1221 VDD.n1047 VDD.n649 0.692362
R1222 VDD.n1049 VDD.n648 0.692362
R1223 VDD.n1051 VDD.n643 0.692362
R1224 VDD.n1053 VDD.n642 0.692362
R1225 VDD.n1056 VDD.n639 0.692362
R1226 VDD.n1058 VDD.n638 0.692362
R1227 VDD.n1062 VDD.n1061 0.692362
R1228 VDD.n861 VDD.n860 0.692362
R1229 VDD.n857 VDD.n856 0.692362
R1230 VDD.n853 VDD.n852 0.692362
R1231 VDD.n849 VDD.n848 0.692362
R1232 VDD.n845 VDD.n844 0.692362
R1233 VDD.n841 VDD.n840 0.692362
R1234 VDD.n837 VDD.n836 0.692362
R1235 VDD.n1066 VDD.n1065 0.692362
R1236 VDD.n760 VDD.n759 0.692362
R1237 VDD.n756 VDD.n755 0.692362
R1238 VDD.n752 VDD.n751 0.692362
R1239 VDD VDD.n10 0.570274
R1240 VDD.n406 VDD.n79 0.570274
R1241 VDD.n1080 VDD.n79 0.570274
R1242 VDD.n390 VDD 0.570274
R1243 VDD VDD.n9 0.570274
R1244 VDD.n87 VDD.t1 0.569912
R1245 VDD.n56 VDD.t16 2.83529
R1246 VDD.n404 VDD.n79 0.569912
R1247 VDD.t1 VDD.n54 0.569912
R1248 VDD.t1 VDD.n53 0.569912
R1249 VDD.n1081 VDD.t1 0.569912
R1250 VDD.n74 VDD.n3 0.495739
R1251 VDD.n3 VDD.n1 0.495739
R1252 VDD.n3 VDD.n2 0.495739
R1253 VDD.n120 VDD.n3 0.495739
R1254 VDD.n47 VDD.n46 0.495739
R1255 VDD.n47 VDD.n45 0.495739
R1256 VDD.n44 VDD.n43 0.495739
R1257 VDD.n65 VDD.n44 0.495739
R1258 VDD.n42 VDD.n41 0.109424
R1259 VDD.n41 VDD.t314 5.87564
R1260 VDD.n39 VDD.n38 0.495739
R1261 VDD.n39 VDD.n37 0.495739
R1262 VDD.n36 VDD.n35 0.495739
R1263 VDD.n36 VDD.n34 0.495739
R1264 VDD.n33 VDD.n32 0.495739
R1265 VDD.n33 VDD.n5 0.495739
R1266 VDD.n31 VDD.n6 0.495739
R1267 VDD.n31 VDD.n30 0.495739
R1268 VDD.n29 VDD.n28 0.123027
R1269 VDD.n27 VDD.n26 0.234238
R1270 VDD.n25 VDD.n12 0.168041
R1271 VDD.n12 VDD.t308 5.7584
R1272 VDD.n24 VDD.n23 0.495739
R1273 VDD.n24 VDD.n22 0.495739
R1274 VDD.n21 VDD.n20 0.495739
R1275 VDD.n81 VDD.n21 0.495739
R1276 VDD.n19 VDD.n18 0.495739
R1277 VDD.n19 VDD.n17 0.495739
R1278 VDD.n16 VDD.n15 0.495739
R1279 VDD.n14 VDD.t295 5.73507
R1280 VDD.t297 VDD.t0 5.79869
R1281 VDD.n409 VDD.n404 0.492005
R1282 VDD.n85 VDD.n409 0.492005
R1283 VDD.n407 VDD.n405 0.492005
R1284 VDD.n407 VDD.n406 0.491643
R1285 VDD.t58 VDD.t298 5.76434
R1286 VDD.n75 VDD.n74 0.478299
R1287 VDD.n75 VDD.n1 0.478299
R1288 VDD.n62 VDD.n2 0.478299
R1289 VDD.n59 VDD.n120 0.478299
R1290 VDD.n46 VDD.n60 0.478299
R1291 VDD.n45 VDD.n60 0.478299
R1292 VDD.n43 VDD.n60 0.478299
R1293 VDD.n38 VDD.n66 0.478299
R1294 VDD.n37 VDD.n11 0.478299
R1295 VDD.n34 VDD.n11 0.478299
R1296 VDD.n32 VDD.n11 0.478299
R1297 VDD.n7 VDD.n5 0.478299
R1298 VDD.n7 VDD.n6 0.478299
R1299 VDD.n13 VDD.n12 0.162158
R1300 VDD.n23 VDD.n118 0.478299
R1301 VDD.n20 VDD.n22 0.478299
R1302 VDD.n82 VDD.n81 0.478299
R1303 VDD.n82 VDD.n17 0.478299
R1304 VDD.n15 VDD.n116 0.478299
R1305 VDD.n14 VDD.t0 0.208009
R1306 VDD.n396 VDD.n395 0.461741
R1307 VDD.n80 VDD.n1074 9.91772
R1308 VDD.n609 VDD.n608 0.461741
R1309 VDD.n545 VDD.n544 0.461741
R1310 VDD.n522 VDD.n519 0.461741
R1311 VDD.n497 VDD.n494 0.461741
R1312 VDD.n484 VDD.n483 0.461741
R1313 VDD.n473 VDD.n472 0.461741
R1314 VDD.n344 VDD.n343 0.437466
R1315 VDD.n75 VDD.n73 0.426806
R1316 VDD.t275 VDD.t58 5.72558
R1317 VDD.t281 VDD.t0 5.70757
R1318 VDD.n77 VDD.n322 0.890716
R1319 VDD.n629 VDD 0.405593
R1320 VDD.n1025 VDD.n148 3.33242
R1321 VDD.n129 VDD.n128 3.33242
R1322 VDD.n115 VDD.n113 0.507017
R1323 VDD.t58 VDD.t276 5.67731
R1324 VDD.n409 VDD.n408 0.253639
R1325 VDD.t273 VDD.t58 5.6952
R1326 VDD.n408 VDD.n407 0.253298
R1327 VDD.n309 VDD.n308 0.0759111
R1328 VDD.n518 VDD.n312 0.235167
R1329 VDD.n154 VDD.n312 0.116823
R1330 VDD.n517 VDD.n424 0.235167
R1331 VDD.n151 VDD.n313 0.116823
R1332 VDD.n512 VDD.n313 0.235167
R1333 VDD.n512 VDD.n304 0.116823
R1334 VDD.n504 VDD.n426 0.235167
R1335 VDD.n505 VDD.n109 0.116823
R1336 VDD.n506 VDD.n505 0.235167
R1337 VDD.n506 VDD.n427 0.235167
R1338 VDD.n428 VDD.n318 0.116823
R1339 VDD.n511 VDD.n428 0.235167
R1340 VDD.n511 VDD.n236 0.116823
R1341 VDD.n499 VDD.n300 0.235167
R1342 VDD.n499 VDD.n278 0.116823
R1343 VDD.n430 VDD.n281 0.235167
R1344 VDD.n189 VDD.n430 0.116823
R1345 VDD.n498 VDD.n431 0.235167
R1346 VDD.n395 VDD.n227 9.11485
R1347 VDD.n394 VDD.n389 0.231121
R1348 VDD.n1076 VDD.n401 0.231121
R1349 VDD.n401 VDD.n400 0.231121
R1350 VDD.n400 VDD.n399 0.231121
R1351 VDD.n399 VDD.n398 0.231121
R1352 VDD.n398 VDD.n396 0.231121
R1353 VDD.n395 VDD.n393 0.231121
R1354 VDD.n393 VDD.n392 0.231121
R1355 VDD.n225 VDD.n1075 0.227781
R1356 VDD.n1078 VDD.n1077 0.231121
R1357 VDD.n1079 VDD.n1078 0.231121
R1358 VDD.n272 VDD.n391 0.114852
R1359 VDD.n397 VDD.n391 0.231121
R1360 VDD.n1074 VDD.n402 0.231121
R1361 VDD.n1073 VDD.n1072 0.231121
R1362 VDD.n611 VDD.n610 0.231121
R1363 VDD.n612 VDD.n157 0.114852
R1364 VDD.n613 VDD.n612 0.231121
R1365 VDD.n614 VDD.n275 0.114852
R1366 VDD.n615 VDD.n614 0.231121
R1367 VDD.n302 VDD.n615 0.114852
R1368 VDD.n617 VDD.n616 0.231121
R1369 VDD.n618 VDD.n617 0.231121
R1370 VDD.n619 VDD.n105 0.114852
R1371 VDD.n620 VDD.n619 0.231121
R1372 VDD.n621 VDD.n320 0.114852
R1373 VDD.n622 VDD.n621 0.231121
R1374 VDD.n622 VDD.n238 0.114852
R1375 VDD.n626 VDD.n412 0.231121
R1376 VDD.n626 VDD.n276 0.114852
R1377 VDD.n547 VDD.n411 0.231121
R1378 VDD.n547 VDD.n191 0.114852
R1379 VDD.n546 VDD.n297 0.231121
R1380 VDD.n543 VDD.n310 0.231121
R1381 VDD.n153 VDD.n310 0.114852
R1382 VDD.n542 VDD.n415 0.231121
R1383 VDD.n152 VDD.n311 0.114852
R1384 VDD.n537 VDD.n311 0.231121
R1385 VDD.n537 VDD.n303 0.114852
R1386 VDD.n529 VDD.n417 0.231121
R1387 VDD.n108 VDD.n529 0.114852
R1388 VDD.n531 VDD.n530 0.231121
R1389 VDD.n531 VDD.n418 0.231121
R1390 VDD.n419 VDD.n319 0.114852
R1391 VDD.n536 VDD.n419 0.231121
R1392 VDD.n536 VDD.n237 0.114852
R1393 VDD.n524 VDD.n301 0.231121
R1394 VDD.n524 VDD.n277 0.114852
R1395 VDD.n421 VDD.n282 0.231121
R1396 VDD.n190 VDD.n421 0.114852
R1397 VDD.n523 VDD.n422 0.231121
R1398 VDD.n471 VDD.n315 0.231121
R1399 VDD.n156 VDD.n315 0.114852
R1400 VDD.n470 VDD.n440 0.231121
R1401 VDD.n150 VDD.n316 0.114852
R1402 VDD.n465 VDD.n316 0.231121
R1403 VDD.n465 VDD.n305 0.114852
R1404 VDD.n457 VDD.n442 0.231121
R1405 VDD.n110 VDD.n457 0.114852
R1406 VDD.n459 VDD.n458 0.231121
R1407 VDD.n459 VDD.n443 0.231121
R1408 VDD.n444 VDD.n317 0.114852
R1409 VDD.n464 VDD.n444 0.231121
R1410 VDD.n464 VDD.n235 0.114852
R1411 VDD.n452 VDD.n299 0.231121
R1412 VDD.n452 VDD.n279 0.114852
R1413 VDD.n446 VDD.n280 0.231121
R1414 VDD.n188 VDD.n446 0.114852
R1415 VDD.n451 VDD.n447 0.231121
R1416 VDD.n628 VDD.n410 0.231121
R1417 VDD.n582 VDD.n410 0.231121
R1418 VDD.n583 VDD.n582 0.231121
R1419 VDD.n583 VDD.n581 0.231121
R1420 VDD.n581 VDD.n580 0.231121
R1421 VDD.n580 VDD.n579 0.231121
R1422 VDD.n579 VDD.n578 0.231121
R1423 VDD.n578 VDD.n577 0.231121
R1424 VDD.n577 VDD.n576 0.231121
R1425 VDD.n576 VDD.n575 0.231121
R1426 VDD.n575 VDD.n574 0.231121
R1427 VDD.n574 VDD.n573 0.231121
R1428 VDD.n573 VDD.n572 0.231121
R1429 VDD.n572 VDD.n571 0.231121
R1430 VDD.n571 VDD.n570 0.231121
R1431 VDD.n570 VDD.n569 0.231121
R1432 VDD.n569 VDD.n568 0.231121
R1433 VDD.n599 VDD.n568 0.231121
R1434 VDD.n600 VDD.n567 0.231121
R1435 VDD.n567 VDD.n566 0.231121
R1436 VDD.n566 VDD.n565 0.231121
R1437 VDD.n565 VDD.n564 0.231121
R1438 VDD.n564 VDD.n563 0.231121
R1439 VDD.n563 VDD.n562 0.231121
R1440 VDD.n562 VDD.n561 0.231121
R1441 VDD.n608 VDD.n561 0.231121
R1442 VDD.n609 VDD.n560 0.231121
R1443 VDD.n560 VDD.n559 0.231121
R1444 VDD.n559 VDD.n558 0.231121
R1445 VDD.n558 VDD.n557 0.231121
R1446 VDD.n557 VDD.n556 0.231121
R1447 VDD.n556 VDD.n555 0.231121
R1448 VDD.n555 VDD.n554 0.231121
R1449 VDD.n554 VDD.n553 0.231121
R1450 VDD.n553 VDD.n552 0.231121
R1451 VDD.n552 VDD.n551 0.231121
R1452 VDD.n551 VDD.n550 0.231121
R1453 VDD.n623 VDD.n550 0.231121
R1454 VDD.n624 VDD.n623 0.231121
R1455 VDD.n625 VDD.n624 0.231121
R1456 VDD.n625 VDD.n549 0.231121
R1457 VDD.n549 VDD.n548 0.231121
R1458 VDD.n548 VDD.n413 0.231121
R1459 VDD.n545 VDD.n413 0.231121
R1460 VDD.n544 VDD.n414 0.231121
R1461 VDD.n540 VDD.n414 0.231121
R1462 VDD.n541 VDD.n540 0.231121
R1463 VDD.n541 VDD.n539 0.231121
R1464 VDD.n539 VDD.n538 0.231121
R1465 VDD.n538 VDD.n416 0.231121
R1466 VDD.n528 VDD.n416 0.231121
R1467 VDD.n528 VDD.n527 0.231121
R1468 VDD.n532 VDD.n527 0.231121
R1469 VDD.n533 VDD.n532 0.231121
R1470 VDD.n534 VDD.n533 0.231121
R1471 VDD.n535 VDD.n534 0.231121
R1472 VDD.n535 VDD.n526 0.231121
R1473 VDD.n526 VDD.n525 0.231121
R1474 VDD.n525 VDD.n420 0.231121
R1475 VDD.n520 VDD.n420 0.231121
R1476 VDD.n521 VDD.n520 0.231121
R1477 VDD.n522 VDD.n521 0.231121
R1478 VDD.n519 VDD.n423 0.231121
R1479 VDD.n515 VDD.n423 0.231121
R1480 VDD.n516 VDD.n515 0.231121
R1481 VDD.n516 VDD.n514 0.231121
R1482 VDD.n514 VDD.n513 0.231121
R1483 VDD.n513 VDD.n425 0.231121
R1484 VDD.n503 VDD.n425 0.231121
R1485 VDD.n503 VDD.n502 0.231121
R1486 VDD.n507 VDD.n502 0.231121
R1487 VDD.n508 VDD.n507 0.231121
R1488 VDD.n509 VDD.n508 0.231121
R1489 VDD.n510 VDD.n509 0.231121
R1490 VDD.n510 VDD.n501 0.231121
R1491 VDD.n501 VDD.n500 0.231121
R1492 VDD.n500 VDD.n429 0.231121
R1493 VDD.n495 VDD.n429 0.231121
R1494 VDD.n496 VDD.n495 0.231121
R1495 VDD.n497 VDD.n496 0.231121
R1496 VDD.n494 VDD.n432 0.231121
R1497 VDD.n490 VDD.n432 0.231121
R1498 VDD.n491 VDD.n490 0.231121
R1499 VDD.n491 VDD.n489 0.231121
R1500 VDD.n489 VDD.n488 0.231121
R1501 VDD.n488 VDD.n434 0.231121
R1502 VDD.n485 VDD.n434 0.231121
R1503 VDD.n485 VDD.n484 0.231121
R1504 VDD.n483 VDD.n435 0.231121
R1505 VDD.n479 VDD.n435 0.231121
R1506 VDD.n480 VDD.n479 0.231121
R1507 VDD.n480 VDD.n478 0.231121
R1508 VDD.n478 VDD.n477 0.231121
R1509 VDD.n477 VDD.n438 0.231121
R1510 VDD.n474 VDD.n438 0.231121
R1511 VDD.n474 VDD.n473 0.231121
R1512 VDD.n472 VDD.n439 0.231121
R1513 VDD.n468 VDD.n439 0.231121
R1514 VDD.n469 VDD.n468 0.231121
R1515 VDD.n469 VDD.n467 0.231121
R1516 VDD.n467 VDD.n466 0.231121
R1517 VDD.n466 VDD.n441 0.231121
R1518 VDD.n456 VDD.n441 0.231121
R1519 VDD.n456 VDD.n455 0.231121
R1520 VDD.n460 VDD.n455 0.231121
R1521 VDD.n461 VDD.n460 0.231121
R1522 VDD.n462 VDD.n461 0.231121
R1523 VDD.n463 VDD.n462 0.231121
R1524 VDD.n463 VDD.n454 0.231121
R1525 VDD.n454 VDD.n453 0.231121
R1526 VDD.n453 VDD.n445 0.231121
R1527 VDD.n448 VDD.n445 0.231121
R1528 VDD.n449 VDD.n448 0.231121
R1529 VDD.n450 VDD.n449 0.231121
R1530 VDD.n482 VDD.n436 0.231121
R1531 VDD.n437 VDD.n307 0.114852
R1532 VDD.n481 VDD.n437 0.231121
R1533 VDD.n481 VDD.n221 0.114852
R1534 VDD.n476 VDD.n287 0.231121
R1535 VDD.n476 VDD.n68 0.114852
R1536 VDD.n475 VDD.n219 0.231121
R1537 VDD.n475 VDD.n271 0.114852
R1538 VDD.n493 VDD.n314 0.231121
R1539 VDD.n155 VDD.n314 0.114852
R1540 VDD.n492 VDD.n433 0.231121
R1541 VDD.n492 VDD.n286 0.231121
R1542 VDD.n273 VDD.n286 0.114852
R1543 VDD.n487 VDD.n220 0.231121
R1544 VDD.n486 VDD.n220 0.231121
R1545 VDD.n486 VDD.n270 0.114852
R1546 VDD.n601 VDD.n230 0.114852
R1547 VDD.n602 VDD.n601 0.231121
R1548 VDD.n222 VDD.n602 0.114852
R1549 VDD.n604 VDD.n603 0.231121
R1550 VDD.n605 VDD.n604 0.231121
R1551 VDD.n223 VDD.n605 0.114852
R1552 VDD.n607 VDD.n606 0.231121
R1553 VDD.n608 VDD.n224 9.11485
R1554 VDD.n628 VDD.n206 9.11485
R1555 VDD.n627 VDD.n296 0.231121
R1556 VDD.n584 VDD.n269 0.114852
R1557 VDD.n585 VDD.n584 0.231121
R1558 VDD.n586 VDD.n112 0.114852
R1559 VDD.n587 VDD.n586 0.231121
R1560 VDD.n588 VDD.n158 0.114852
R1561 VDD.n589 VDD.n588 0.231121
R1562 VDD.n590 VDD.n589 0.231121
R1563 VDD.n239 VDD.n590 0.114852
R1564 VDD.n592 VDD.n591 0.231121
R1565 VDD.n102 VDD.n592 0.114852
R1566 VDD.n594 VDD.n593 0.231121
R1567 VDD.n274 VDD.n594 0.114852
R1568 VDD.n596 VDD.n595 0.231121
R1569 VDD.n597 VDD.n283 0.114852
R1570 VDD.n598 VDD.n597 0.231121
R1571 VDD.n149 VDD.n598 0.114852
R1572 VDD.n1026 VDD.n63 0.114852
R1573 VDD.n1027 VDD.n1026 0.231121
R1574 VDD.n240 VDD.n673 0.114852
R1575 VDD.n1020 VDD.n673 0.231121
R1576 VDD.n1020 VDD.n187 0.114852
R1577 VDD.n1019 VDD.n1018 0.231121
R1578 VDD.n1018 VDD.n675 0.231121
R1579 VDD.n1014 VDD.n241 0.114852
R1580 VDD.n1014 VDD.n1013 0.231121
R1581 VDD.n1013 VDD.n186 0.114852
R1582 VDD.n1012 VDD.n677 0.231121
R1583 VDD.n1008 VDD.n677 0.231121
R1584 VDD.n242 VDD.n1007 0.114852
R1585 VDD.n1007 VDD.n1006 0.231121
R1586 VDD.n1006 VDD.n185 0.114852
R1587 VDD.n1002 VDD.n679 0.231121
R1588 VDD.n1002 VDD.n1001 0.231121
R1589 VDD.n243 VDD.n1000 0.114852
R1590 VDD.n1000 VDD.n681 0.231121
R1591 VDD.n184 VDD.n681 0.114852
R1592 VDD.n996 VDD.n995 0.231121
R1593 VDD.n995 VDD.n994 0.231121
R1594 VDD.n244 VDD.n683 0.114852
R1595 VDD.n990 VDD.n683 0.231121
R1596 VDD.n990 VDD.n183 0.114852
R1597 VDD.n989 VDD.n988 0.231121
R1598 VDD.n988 VDD.n298 0.231121
R1599 VDD.n984 VDD.n245 0.114852
R1600 VDD.n984 VDD.n983 0.231121
R1601 VDD.n983 VDD.n182 0.114852
R1602 VDD.n982 VDD.n686 0.231121
R1603 VDD.n978 VDD.n686 0.231121
R1604 VDD.n246 VDD.n977 0.114852
R1605 VDD.n977 VDD.n976 0.231121
R1606 VDD.n976 VDD.n181 0.114852
R1607 VDD.n972 VDD.n688 0.231121
R1608 VDD.n972 VDD.n971 0.231121
R1609 VDD.n247 VDD.n952 0.114852
R1610 VDD.n952 VDD.n690 0.231121
R1611 VDD.n180 VDD.n690 0.114852
R1612 VDD.n948 VDD.n947 0.231121
R1613 VDD.n947 VDD.n946 0.231121
R1614 VDD.n248 VDD.n692 0.114852
R1615 VDD.n942 VDD.n692 0.231121
R1616 VDD.n942 VDD.n179 0.114852
R1617 VDD.n941 VDD.n940 0.231121
R1618 VDD.n940 VDD.n694 0.231121
R1619 VDD.n936 VDD.n249 0.114852
R1620 VDD.n936 VDD.n935 0.231121
R1621 VDD.n935 VDD.n178 0.114852
R1622 VDD.n934 VDD.n696 0.231121
R1623 VDD.n930 VDD.n696 0.231121
R1624 VDD.n250 VDD.n929 0.114852
R1625 VDD.n929 VDD.n928 0.231121
R1626 VDD.n928 VDD.n177 0.114852
R1627 VDD.n924 VDD.n698 0.231121
R1628 VDD.n924 VDD.n923 0.231121
R1629 VDD.n251 VDD.n922 0.114852
R1630 VDD.n922 VDD.n700 0.231121
R1631 VDD.n176 VDD.n700 0.114852
R1632 VDD.n918 VDD.n917 0.231121
R1633 VDD.n917 VDD.n916 0.231121
R1634 VDD.n252 VDD.n702 0.114852
R1635 VDD.n912 VDD.n702 0.231121
R1636 VDD.n912 VDD.n175 0.114852
R1637 VDD.n911 VDD.n910 0.231121
R1638 VDD.n910 VDD.n704 0.231121
R1639 VDD.n906 VDD.n253 0.114852
R1640 VDD.n906 VDD.n905 0.231121
R1641 VDD.n905 VDD.n174 0.114852
R1642 VDD.n904 VDD.n706 0.231121
R1643 VDD.n900 VDD.n706 0.231121
R1644 VDD.n254 VDD.n899 0.114852
R1645 VDD.n899 VDD.n898 0.231121
R1646 VDD.n898 VDD.n173 0.114852
R1647 VDD.n894 VDD.n708 0.231121
R1648 VDD.n894 VDD.n893 0.231121
R1649 VDD.n255 VDD.n892 0.114852
R1650 VDD.n892 VDD.n710 0.231121
R1651 VDD.n172 VDD.n710 0.114852
R1652 VDD.n888 VDD.n887 0.231121
R1653 VDD.n887 VDD.n886 0.231121
R1654 VDD.n256 VDD.n712 0.114852
R1655 VDD.n882 VDD.n712 0.231121
R1656 VDD.n882 VDD.n171 0.114852
R1657 VDD.n881 VDD.n880 0.231121
R1658 VDD.n880 VDD.n714 0.231121
R1659 VDD.n876 VDD.n257 0.114852
R1660 VDD.n876 VDD.n875 0.231121
R1661 VDD.n875 VDD.n170 0.114852
R1662 VDD.n874 VDD.n716 0.231121
R1663 VDD.n870 VDD.n716 0.231121
R1664 VDD.n258 VDD.n869 0.114852
R1665 VDD.n869 VDD.n868 0.231121
R1666 VDD.n868 VDD.n169 0.114852
R1667 VDD.n864 VDD.n718 0.231121
R1668 VDD.n864 VDD.n863 0.231121
R1669 VDD.n259 VDD.n720 0.114852
R1670 VDD.n807 VDD.n720 0.231121
R1671 VDD.n168 VDD.n807 0.114852
R1672 VDD.n809 VDD.n808 0.231121
R1673 VDD.n810 VDD.n809 0.231121
R1674 VDD.n811 VDD.n260 0.114852
R1675 VDD.n812 VDD.n811 0.231121
R1676 VDD.n167 VDD.n812 0.114852
R1677 VDD.n814 VDD.n813 0.231121
R1678 VDD.n815 VDD.n814 0.231121
R1679 VDD.n816 VDD.n261 0.114852
R1680 VDD.n817 VDD.n816 0.231121
R1681 VDD.n166 VDD.n817 0.114852
R1682 VDD.n819 VDD.n818 0.231121
R1683 VDD.n820 VDD.n819 0.231121
R1684 VDD.n821 VDD.n262 0.114852
R1685 VDD.n822 VDD.n821 0.231121
R1686 VDD.n165 VDD.n822 0.114852
R1687 VDD.n824 VDD.n823 0.231121
R1688 VDD.n825 VDD.n824 0.231121
R1689 VDD.n826 VDD.n263 0.114852
R1690 VDD.n827 VDD.n826 0.231121
R1691 VDD.n164 VDD.n827 0.114852
R1692 VDD.n829 VDD.n828 0.231121
R1693 VDD.n830 VDD.n829 0.231121
R1694 VDD.n831 VDD.n264 0.114852
R1695 VDD.n832 VDD.n831 0.231121
R1696 VDD.n163 VDD.n832 0.114852
R1697 VDD.n834 VDD.n833 0.231121
R1698 VDD.n835 VDD.n834 0.231121
R1699 VDD.n265 VDD.n727 0.114852
R1700 VDD.n774 VDD.n727 0.231121
R1701 VDD.n774 VDD.n162 0.114852
R1702 VDD.n773 VDD.n772 0.231121
R1703 VDD.n772 VDD.n729 0.231121
R1704 VDD.n768 VDD.n266 0.114852
R1705 VDD.n768 VDD.n767 0.231121
R1706 VDD.n767 VDD.n161 0.114852
R1707 VDD.n766 VDD.n731 0.231121
R1708 VDD.n762 VDD.n731 0.231121
R1709 VDD.n267 VDD.n733 0.114852
R1710 VDD.n743 VDD.n733 0.231121
R1711 VDD.n160 VDD.n743 0.114852
R1712 VDD.n745 VDD.n744 0.231121
R1713 VDD.n746 VDD.n745 0.231121
R1714 VDD.n747 VDD.n268 0.114852
R1715 VDD.n748 VDD.n747 0.231121
R1716 VDD.n159 VDD.n748 0.114852
R1717 VDD.n750 VDD.n749 0.231121
R1718 VDD.n1069 VDD.n148 2.02793
R1719 VDD.n1025 VDD.n1024 0.231121
R1720 VDD.n1024 VDD.n1023 0.231121
R1721 VDD.n1023 VDD.n1022 0.231121
R1722 VDD.n1022 VDD.n1021 0.231121
R1723 VDD.n1021 VDD.n674 0.231121
R1724 VDD.n1017 VDD.n674 0.231121
R1725 VDD.n1017 VDD.n1016 0.231121
R1726 VDD.n1016 VDD.n1015 0.231121
R1727 VDD.n1015 VDD.n676 0.231121
R1728 VDD.n1011 VDD.n676 0.231121
R1729 VDD.n1011 VDD.n1010 0.231121
R1730 VDD.n1010 VDD.n1009 0.231121
R1731 VDD.n1009 VDD.n678 0.231121
R1732 VDD.n1005 VDD.n678 0.231121
R1733 VDD.n1005 VDD.n1004 0.231121
R1734 VDD.n1004 VDD.n1003 0.231121
R1735 VDD.n1003 VDD.n680 0.231121
R1736 VDD.n999 VDD.n680 0.231121
R1737 VDD.n999 VDD.n998 0.231121
R1738 VDD.n998 VDD.n997 0.231121
R1739 VDD.n997 VDD.n682 0.231121
R1740 VDD.n993 VDD.n682 0.231121
R1741 VDD.n993 VDD.n992 0.231121
R1742 VDD.n992 VDD.n991 0.231121
R1743 VDD.n991 VDD.n684 0.231121
R1744 VDD.n987 VDD.n684 0.231121
R1745 VDD.n987 VDD.n986 0.231121
R1746 VDD.n986 VDD.n985 0.231121
R1747 VDD.n985 VDD.n685 0.231121
R1748 VDD.n981 VDD.n685 0.231121
R1749 VDD.n981 VDD.n980 0.231121
R1750 VDD.n980 VDD.n979 0.231121
R1751 VDD.n979 VDD.n687 0.231121
R1752 VDD.n975 VDD.n687 0.231121
R1753 VDD.n975 VDD.n974 0.231121
R1754 VDD.n974 VDD.n973 0.231121
R1755 VDD.n973 VDD.n689 0.231121
R1756 VDD.n951 VDD.n689 0.231121
R1757 VDD.n951 VDD.n950 0.231121
R1758 VDD.n950 VDD.n949 0.231121
R1759 VDD.n949 VDD.n691 0.231121
R1760 VDD.n945 VDD.n691 0.231121
R1761 VDD.n945 VDD.n944 0.231121
R1762 VDD.n944 VDD.n943 0.231121
R1763 VDD.n943 VDD.n693 0.231121
R1764 VDD.n939 VDD.n693 0.231121
R1765 VDD.n939 VDD.n938 0.231121
R1766 VDD.n938 VDD.n937 0.231121
R1767 VDD.n937 VDD.n695 0.231121
R1768 VDD.n933 VDD.n695 0.231121
R1769 VDD.n933 VDD.n932 0.231121
R1770 VDD.n932 VDD.n931 0.231121
R1771 VDD.n931 VDD.n697 0.231121
R1772 VDD.n927 VDD.n697 0.231121
R1773 VDD.n927 VDD.n926 0.231121
R1774 VDD.n926 VDD.n925 0.231121
R1775 VDD.n925 VDD.n699 0.231121
R1776 VDD.n921 VDD.n699 0.231121
R1777 VDD.n921 VDD.n920 0.231121
R1778 VDD.n920 VDD.n919 0.231121
R1779 VDD.n919 VDD.n701 0.231121
R1780 VDD.n915 VDD.n701 0.231121
R1781 VDD.n915 VDD.n914 0.231121
R1782 VDD.n914 VDD.n913 0.231121
R1783 VDD.n913 VDD.n703 0.231121
R1784 VDD.n909 VDD.n703 0.231121
R1785 VDD.n909 VDD.n908 0.231121
R1786 VDD.n908 VDD.n907 0.231121
R1787 VDD.n907 VDD.n705 0.231121
R1788 VDD.n903 VDD.n705 0.231121
R1789 VDD.n903 VDD.n902 0.231121
R1790 VDD.n902 VDD.n901 0.231121
R1791 VDD.n901 VDD.n707 0.231121
R1792 VDD.n897 VDD.n707 0.231121
R1793 VDD.n897 VDD.n896 0.231121
R1794 VDD.n896 VDD.n895 0.231121
R1795 VDD.n895 VDD.n709 0.231121
R1796 VDD.n891 VDD.n709 0.231121
R1797 VDD.n891 VDD.n890 0.231121
R1798 VDD.n890 VDD.n889 0.231121
R1799 VDD.n889 VDD.n711 0.231121
R1800 VDD.n885 VDD.n711 0.231121
R1801 VDD.n885 VDD.n884 0.231121
R1802 VDD.n884 VDD.n883 0.231121
R1803 VDD.n883 VDD.n713 0.231121
R1804 VDD.n879 VDD.n713 0.231121
R1805 VDD.n879 VDD.n878 0.231121
R1806 VDD.n878 VDD.n877 0.231121
R1807 VDD.n877 VDD.n715 0.231121
R1808 VDD.n873 VDD.n715 0.231121
R1809 VDD.n873 VDD.n872 0.231121
R1810 VDD.n872 VDD.n871 0.231121
R1811 VDD.n871 VDD.n717 0.231121
R1812 VDD.n867 VDD.n717 0.231121
R1813 VDD.n867 VDD.n866 0.231121
R1814 VDD.n866 VDD.n865 0.231121
R1815 VDD.n865 VDD.n719 0.231121
R1816 VDD.n805 VDD.n719 0.231121
R1817 VDD.n806 VDD.n805 0.231121
R1818 VDD.n806 VDD.n804 0.231121
R1819 VDD.n804 VDD.n803 0.231121
R1820 VDD.n803 VDD.n802 0.231121
R1821 VDD.n802 VDD.n801 0.231121
R1822 VDD.n801 VDD.n800 0.231121
R1823 VDD.n800 VDD.n799 0.231121
R1824 VDD.n799 VDD.n798 0.231121
R1825 VDD.n798 VDD.n797 0.231121
R1826 VDD.n797 VDD.n796 0.231121
R1827 VDD.n796 VDD.n795 0.231121
R1828 VDD.n795 VDD.n794 0.231121
R1829 VDD.n794 VDD.n793 0.231121
R1830 VDD.n793 VDD.n792 0.231121
R1831 VDD.n792 VDD.n791 0.231121
R1832 VDD.n791 VDD.n790 0.231121
R1833 VDD.n790 VDD.n789 0.231121
R1834 VDD.n789 VDD.n788 0.231121
R1835 VDD.n788 VDD.n787 0.231121
R1836 VDD.n787 VDD.n786 0.231121
R1837 VDD.n786 VDD.n785 0.231121
R1838 VDD.n785 VDD.n784 0.231121
R1839 VDD.n784 VDD.n783 0.231121
R1840 VDD.n783 VDD.n782 0.231121
R1841 VDD.n782 VDD.n781 0.231121
R1842 VDD.n781 VDD.n780 0.231121
R1843 VDD.n780 VDD.n779 0.231121
R1844 VDD.n779 VDD.n778 0.231121
R1845 VDD.n778 VDD.n777 0.231121
R1846 VDD.n777 VDD.n776 0.231121
R1847 VDD.n776 VDD.n775 0.231121
R1848 VDD.n775 VDD.n728 0.231121
R1849 VDD.n771 VDD.n728 0.231121
R1850 VDD.n771 VDD.n770 0.231121
R1851 VDD.n770 VDD.n769 0.231121
R1852 VDD.n769 VDD.n730 0.231121
R1853 VDD.n765 VDD.n730 0.231121
R1854 VDD.n765 VDD.n764 0.231121
R1855 VDD.n764 VDD.n763 0.231121
R1856 VDD.n763 VDD.n732 0.231121
R1857 VDD.n742 VDD.n732 0.231121
R1858 VDD.n742 VDD.n741 0.231121
R1859 VDD.n741 VDD.n740 0.231121
R1860 VDD.n740 VDD.n739 0.231121
R1861 VDD.n739 VDD.n738 0.231121
R1862 VDD.n738 VDD.n737 0.231121
R1863 VDD.n737 VDD.n736 0.231121
R1864 VDD.n629 VDD.n129 2.02793
R1865 VDD.n128 VDD.n672 0.231121
R1866 VDD.n1029 VDD.n672 0.231121
R1867 VDD.n1030 VDD.n671 0.231121
R1868 VDD.n671 VDD.n670 0.231121
R1869 VDD.n667 VDD.n666 0.231121
R1870 VDD.n666 VDD.n665 0.231121
R1871 VDD.n664 VDD.n663 0.231121
R1872 VDD.n663 VDD.n662 0.231121
R1873 VDD.n1036 VDD.n1035 0.231121
R1874 VDD.n1037 VDD.n1036 0.231121
R1875 VDD.n959 VDD.n661 0.231121
R1876 VDD.n962 VDD.n959 0.231121
R1877 VDD.n963 VDD.n958 0.231121
R1878 VDD.n966 VDD.n958 0.231121
R1879 VDD.n969 VDD.n968 0.231121
R1880 VDD.n970 VDD.n969 0.231121
R1881 VDD.n957 VDD.n954 0.231121
R1882 VDD.n954 VDD.n660 0.231121
R1883 VDD.n1040 VDD.n1039 0.231121
R1884 VDD.n1041 VDD.n1040 0.231121
R1885 VDD.n659 VDD.n658 0.231121
R1886 VDD.n1044 VDD.n658 0.231121
R1887 VDD.n1045 VDD.n657 0.231121
R1888 VDD.n657 VDD.n656 0.231121
R1889 VDD.n654 VDD.n651 0.231121
R1890 VDD.n651 VDD.n649 0.231121
R1891 VDD.n1048 VDD.n1047 0.231121
R1892 VDD.n1049 VDD.n1048 0.231121
R1893 VDD.n648 VDD.n645 0.231121
R1894 VDD.n645 VDD.n643 0.231121
R1895 VDD.n1052 VDD.n1051 0.231121
R1896 VDD.n1053 VDD.n1052 0.231121
R1897 VDD.n642 VDD.n640 0.231121
R1898 VDD.n640 VDD.n639 0.231121
R1899 VDD.n1057 VDD.n1056 0.231121
R1900 VDD.n1058 VDD.n1057 0.231121
R1901 VDD.n638 VDD.n637 0.231121
R1902 VDD.n1061 VDD.n637 0.231121
R1903 VDD.n1062 VDD.n636 0.231121
R1904 VDD.n861 VDD.n636 0.231121
R1905 VDD.n860 VDD.n721 0.231121
R1906 VDD.n857 VDD.n721 0.231121
R1907 VDD.n856 VDD.n722 0.231121
R1908 VDD.n853 VDD.n722 0.231121
R1909 VDD.n852 VDD.n723 0.231121
R1910 VDD.n849 VDD.n723 0.231121
R1911 VDD.n848 VDD.n724 0.231121
R1912 VDD.n845 VDD.n724 0.231121
R1913 VDD.n844 VDD.n725 0.231121
R1914 VDD.n841 VDD.n725 0.231121
R1915 VDD.n840 VDD.n726 0.231121
R1916 VDD.n837 VDD.n726 0.231121
R1917 VDD.n836 VDD.n634 0.231121
R1918 VDD.n1065 VDD.n634 0.231121
R1919 VDD.n1066 VDD.n633 0.231121
R1920 VDD.n760 VDD.n633 0.231121
R1921 VDD.n759 VDD.n734 0.231121
R1922 VDD.n756 VDD.n734 0.231121
R1923 VDD.n755 VDD.n735 0.231121
R1924 VDD.n752 VDD.n735 0.231121
R1925 VDD.n751 VDD.n631 0.231121
R1926 VDD.n631 VDD.n630 0.231121
R1927 VDD.n207 VDD.n751 9.11485
R1928 VDD.n1068 VDD.n1067 0.231121
R1929 VDD.n208 VDD.n754 0.114852
R1930 VDD.n754 VDD.n753 0.231121
R1931 VDD.n209 VDD.n758 0.114852
R1932 VDD.n758 VDD.n757 0.231121
R1933 VDD.n210 VDD.n632 0.114852
R1934 VDD.n761 VDD.n632 0.231121
R1935 VDD.n228 VDD.n836 9.11485
R1936 VDD.n1064 VDD.n1063 0.231121
R1937 VDD.n211 VDD.n839 0.114852
R1938 VDD.n839 VDD.n838 0.231121
R1939 VDD.n212 VDD.n843 0.114852
R1940 VDD.n843 VDD.n842 0.231121
R1941 VDD.n847 VDD.n846 0.231121
R1942 VDD.n205 VDD.n845 9.11485
R1943 VDD.n213 VDD.n851 0.114852
R1944 VDD.n851 VDD.n850 0.231121
R1945 VDD.n214 VDD.n855 0.114852
R1946 VDD.n855 VDD.n854 0.231121
R1947 VDD.n859 VDD.n858 0.231121
R1948 VDD.n858 VDD.n198 0.114852
R1949 VDD.n1062 VDD.n229 9.11485
R1950 VDD.n862 VDD.n635 0.231121
R1951 VDD.n1059 VDD.n234 0.114852
R1952 VDD.n1060 VDD.n1059 0.231121
R1953 VDD.n1055 VDD.n196 0.231121
R1954 VDD.n197 VDD.n196 0.114852
R1955 VDD.n1054 VDD.n291 0.231121
R1956 VDD.n195 VDD.n1054 0.114852
R1957 VDD.n1050 VDD.n641 0.231121
R1958 VDD.n1053 VDD.n194 9.11485
R1959 VDD.n648 VDD.n231 9.11485
R1960 VDD.n647 VDD.n646 0.231121
R1961 VDD.n1046 VDD.n644 0.231121
R1962 VDD.n1049 VDD.n204 9.11485
R1963 VDD.n653 VDD.n652 0.231121
R1964 VDD.n203 VDD.n649 9.11485
R1965 VDD.n1045 VDD.n232 9.11485
R1966 VDD.n655 VDD.n650 0.231121
R1967 VDD.n1043 VDD.n111 0.231121
R1968 VDD.n1044 VDD.n202 9.11485
R1969 VDD.n1039 VDD.n215 9.11485
R1970 VDD.n1042 VDD.n290 0.231121
R1971 VDD.n956 VDD.n955 0.231121
R1972 VDD.n955 VDD.n193 0.114852
R1973 VDD.n967 VDD.n953 0.231121
R1974 VDD.n970 VDD.n201 9.11485
R1975 VDD.n965 VDD.n964 0.231121
R1976 VDD.n192 VDD.n965 0.114852
R1977 VDD.n233 VDD.n661 9.11485
R1978 VDD.n961 VDD.n960 0.231121
R1979 VDD.n1035 VDD.n216 9.11485
R1980 VDD.n1038 VDD.n289 0.231121
R1981 VDD.n217 VDD.n664 9.11485
R1982 VDD.n1034 VDD.n1033 0.231121
R1983 VDD.n1032 VDD.n1031 0.231121
R1984 VDD.n200 VDD.n665 9.11485
R1985 VDD.n218 VDD.n668 0.114852
R1986 VDD.n669 VDD.n668 0.231121
R1987 VDD.n1028 VDD.n288 0.231121
R1988 VDD.n1029 VDD.n199 9.11485
R1989 VDD.n340 VDD.n126 1.73963
R1990 VDD.n1071 VDD.n403 0.1905
R1991 VDD.n403 VDD.n57 0.362417
R1992 VDD.n70 VDD.n115 0.16333
R1993 VDD.n1069 VDD.n629 0.161247
R1994 VDD.n388 VDD.n323 0.146155
R1995 VDD.n384 VDD.n323 0.146155
R1996 VDD.n384 VDD.n293 0.073243
R1997 VDD.n383 VDD.n382 0.146155
R1998 VDD.n382 VDD.n325 0.146155
R1999 VDD.n130 VDD.n325 0.073243
R2000 VDD.n378 VDD.n131 0.146155
R2001 VDD.n131 VDD.n122 0.073243
R2002 VDD.n377 VDD.n306 0.146155
R2003 VDD.n373 VDD.n295 0.073243
R2004 VDD.n373 VDD.n138 0.146155
R2005 VDD.n138 VDD.n137 0.073243
R2006 VDD.n372 VDD.n139 0.146155
R2007 VDD.n368 VDD.n136 0.073243
R2008 VDD.n368 VDD.n140 0.146155
R2009 VDD.n140 VDD.n135 0.073243
R2010 VDD.n367 VDD.n141 0.146155
R2011 VDD.n363 VDD.n134 0.073243
R2012 VDD.n363 VDD.n142 0.146155
R2013 VDD.n142 VDD.n133 0.073243
R2014 VDD.n362 VDD.n143 0.146155
R2015 VDD.n358 VDD.n132 0.073243
R2016 VDD.n358 VDD.n144 0.146155
R2017 VDD.n144 VDD.n357 0.146155
R2018 VDD.n285 VDD.n331 0.073243
R2019 VDD.n353 VDD.n331 0.146155
R2020 VDD.n353 VDD.n292 0.073243
R2021 VDD.n352 VDD.n351 0.146155
R2022 VDD.n351 VDD.n333 0.146155
R2023 VDD.n347 VDD.n145 0.073243
R2024 VDD.n347 VDD.n147 0.146155
R2025 VDD.n146 VDD.n346 0.073243
R2026 VDD.n346 VDD.n335 0.146155
R2027 VDD.n386 VDD.n385 0.146155
R2028 VDD.n385 VDD.n324 0.146155
R2029 VDD.n381 VDD.n324 0.146155
R2030 VDD.n381 VDD.n380 0.146155
R2031 VDD.n380 VDD.n379 0.146155
R2032 VDD.n379 VDD.n326 0.146155
R2033 VDD.n376 VDD.n326 0.146155
R2034 VDD.n376 VDD.n375 0.146155
R2035 VDD.n375 VDD.n374 0.146155
R2036 VDD.n374 VDD.n327 0.146155
R2037 VDD.n371 VDD.n327 0.146155
R2038 VDD.n371 VDD.n370 0.146155
R2039 VDD.n370 VDD.n369 0.146155
R2040 VDD.n369 VDD.n328 0.146155
R2041 VDD.n366 VDD.n328 0.146155
R2042 VDD.n366 VDD.n365 0.146155
R2043 VDD.n365 VDD.n364 0.146155
R2044 VDD.n364 VDD.n329 0.146155
R2045 VDD.n361 VDD.n329 0.146155
R2046 VDD.n361 VDD.n360 0.146155
R2047 VDD.n360 VDD.n359 0.146155
R2048 VDD.n359 VDD.n330 0.146155
R2049 VDD.n356 VDD.n330 0.146155
R2050 VDD.n356 VDD.n355 0.146155
R2051 VDD.n355 VDD.n354 0.146155
R2052 VDD.n354 VDD.n332 0.146155
R2053 VDD.n350 VDD.n332 0.146155
R2054 VDD.n350 VDD.n349 0.146155
R2055 VDD.n349 VDD.n348 0.146155
R2056 VDD.n348 VDD.n334 0.146155
R2057 VDD.n345 VDD.n334 0.146155
R2058 VDD.n345 VDD.n344 0.146155
R2059 VDD.n343 VDD.n336 0.146155
R2060 VDD.n340 VDD.n336 0.146155
R2061 VDD.n126 VDD.n339 0.427453
R2062 VDD.n339 VDD.n337 0.146155
R2063 VDD.n338 VDD.n127 0.344925
R2064 VDD.n338 VDD.n124 0.146155
R2065 VDD.n342 VDD.n341 0.146155
R2066 VDD.n294 VDD.n340 9.07324
R2067 VDD.n322 VDD.n321 0.125789
R2068 VDD.n1075 VDD.n80 0.341669
R2069 VDD.t58 VDD.t272 15.0172
R2070 VDD.n388 VDD.n387 0.0726677
R2071 VDD.n309 VDD.n337 5.74018
R2072 VDD.n125 VDD.t58 3.0401
R2073 VDD.n49 VDD.t3 0.740739
R2074 VDD.n83 VDD.n58 1.59833
R2075 VDD.n4 VDD.n3 0.265755
R2076 VDD.t42 VDD.n72 0.455899
R2077 VDD VDD.n10 1.35281
R2078 VDD.n26 VDD.n13 0.481329
R2079 VDD.n7 VDD.n30 1.32623
R2080 VDD.n52 VDD.n51 0.402719
R2081 VDD.n41 VDD.n40 0.279392
R2082 VDD.t3 VDD.n67 0.578777
R2083 VDD.n40 VDD.n65 1.24629
R2084 VDD.n22 VDD.n82 1.2261
R2085 VDD.n11 VDD.n8 1.19381
R2086 VDD.n35 VDD.n11 1.20676
R2087 VDD.t1 VDD.n85 1.20575
R2088 VDD.t0 VDD.n13 1.19868
R2089 VDD.t1 VDD.n57 1.19865
R2090 VDD.n69 VDD.n60 1.19543
R2091 VDD VDD.n87 1.14653
R2092 VDD.n106 VDD.n75 1.07561
R2093 VDD.n405 VDD.t1 1.07224
R2094 VDD.n104 VDD.n49 1.05792
R2095 VDD.n52 VDD.n121 1.03404
R2096 VDD.n66 VDD.n40 1.04226
R2097 VDD.n104 VDD.n67 1.037
R2098 VDD.n117 VDD.n79 0.713337
R2099 VDD.n71 VDD.n72 0.428895
R2100 VDD.n71 VDD.n70 0.930126
R2101 VDD.n60 VDD.n59 0.919264
R2102 VDD.n115 VDD.n114 0.916832
R2103 VDD.n59 VDD.n119 0.836168
R2104 VDD.n50 VDD.t0 0.25873
R2105 VDD.n82 VDD.n18 1.01992
R2106 VDD.t42 VDD.t1 1.01537
R2107 VDD.t1 VDD.n56 0.277747
R2108 VDD.n50 VDD.n82 1.10208
R2109 VDD.n119 VDD.n62 0.989055
R2110 VDD.n8 VDD.n7 0.304068
R2111 VDD.t0 VDD.n69 0.985187
R2112 VDD.n61 VDD.n0 0.542545
R2113 VDD.n73 VDD.n3 1.37742
R2114 VDD.t3 VDD.n83 1.28577
R2115 VDD.n107 VDD.n11 1.24535
R2116 VDD.t3 VDD.n52 1.23859
R2117 VDD.n28 VDD.n7 1.21462
R2118 VDD.n56 VDD 1.19138
R2119 VDD.n64 VDD.n22 1.17833
R2120 VDD.n123 VDD.n13 1.16768
R2121 VDD.t3 VDD.n84 1.09537
R2122 VDD.n88 VDD.n47 1.0868
R2123 VDD.n89 VDD.n44 1.0868
R2124 VDD.n90 VDD.n42 1.0868
R2125 VDD.n91 VDD.n39 1.0868
R2126 VDD.n92 VDD.n36 1.0868
R2127 VDD.n93 VDD.n33 1.0868
R2128 VDD.n94 VDD.n31 1.0868
R2129 VDD.n95 VDD.n29 1.0868
R2130 VDD.n96 VDD.n27 1.0868
R2131 VDD.n97 VDD.n25 1.0868
R2132 VDD.n98 VDD.n24 1.0868
R2133 VDD.n99 VDD.n21 1.0868
R2134 VDD.n100 VDD.n19 1.0868
R2135 VDD.n101 VDD.n16 1.0868
R2136 VDD.t0 VDD.n64 1.0029
R2137 VSS.t93 VSS.n1276 119321
R2138 VSS.n3462 VSS.n609 22369.4
R2139 VSS.n1840 VSS.n1839 7963.84
R2140 VSS.n3204 VSS.n3203 4670.31
R2141 VSS.n3208 VSS.n3207 3068.57
R2142 VSS.n1271 VSS.n780 1028.14
R2143 VSS.n1173 VSS.n821 1028.14
R2144 VSS.n616 VSS.t704 849.322
R2145 VSS.n874 VSS.n582 572.005
R2146 VSS.t504 VSS.t501 571.348
R2147 VSS.t347 VSS.n815 566.691
R2148 VSS.n828 VSS.t682 560.899
R2149 VSS.n876 VSS.t18 550.193
R2150 VSS.n3456 VSS.t39 539.653
R2151 VSS.t666 VSS.n819 532.819
R2152 VSS.n3459 VSS.t57 522.509
R2153 VSS.n1274 VSS.t341 521.236
R2154 VSS.n820 VSS.t90 514.091
R2155 VSS.n790 VSS.t157 504.839
R2156 VSS.n855 VSS.t229 504.839
R2157 VSS.n3457 VSS.t59 491.87
R2158 VSS.n830 VSS.t154 474.904
R2159 VSS.t387 VSS.n3454 470.019
R2160 VSS.n1349 VSS.n1341 469.784
R2161 VSS.n1388 VSS.n1380 469.784
R2162 VSS.n1427 VSS.n1419 469.784
R2163 VSS.n1511 VSS.n1503 469.784
R2164 VSS.n1550 VSS.n1542 469.784
R2165 VSS.n1592 VSS.n1581 469.784
R2166 VSS.t384 VSS.n813 456.175
R2167 VSS.n3182 VSS.n3181 454.012
R2168 VSS.n3048 VSS.n1356 454.012
R2169 VSS.n3001 VSS.n1395 454.012
R2170 VSS.n2915 VSS.n1455 454.012
R2171 VSS.n2868 VSS.n1518 454.012
R2172 VSS.n2821 VSS.n1557 454.012
R2173 VSS.n3193 VSS.t648 453.986
R2174 VSS.n3085 VSS.n3084 453.986
R2175 VSS.n3037 VSS.n3036 453.986
R2176 VSS.n2990 VSS.n2989 453.986
R2177 VSS.n2904 VSS.n2903 453.986
R2178 VSS.n2857 VSS.n2856 453.986
R2179 VSS.n2810 VSS.n2809 453.986
R2180 VSS.n3085 VSS.n1282 453.986
R2181 VSS.n3036 VSS.n1370 453.986
R2182 VSS.n2989 VSS.n1409 453.986
R2183 VSS.n2903 VSS.n1493 453.986
R2184 VSS.n2856 VSS.n1532 453.986
R2185 VSS.n2809 VSS.n1571 453.986
R2186 VSS.n1463 VSS.t237 448.228
R2187 VSS.t701 VSS.n3189 442.469
R2188 VSS.n1440 VSS.t690 431.863
R2189 VSS.n1273 VSS.t527 427.695
R2190 VSS.t380 VSS.n820 427.219
R2191 VSS.t520 VSS.n1443 419.464
R2192 VSS.n3073 VSS.t538 413.678
R2193 VSS.n3026 VSS.t553 413.678
R2194 VSS.n2979 VSS.t568 413.678
R2195 VSS.n2893 VSS.t583 413.678
R2196 VSS.n2846 VSS.t598 413.678
R2197 VSS.t613 VSS.n1591 413.678
R2198 VSS.n811 VSS.n786 412.791
R2199 VSS.n868 VSS.n851 412.791
R2200 VSS.n3452 VSS.n72 413.113
R2201 VSS.n1218 VSS.n811 404.192
R2202 VSS.n1144 VSS.n868 404.192
R2203 VSS.n3188 VSS.t649 403.072
R2204 VSS.t164 VSS.n3457 401.591
R2205 VSS.t236 VSS.n1440 397.313
R2206 VSS.t381 VSS.n3194 391.555
R2207 VSS.n3453 VSS.t704 388.781
R2208 VSS.n3084 VSS.t533 385.798
R2209 VSS.n3037 VSS.t548 385.798
R2210 VSS.n2990 VSS.t563 385.798
R2211 VSS.n2904 VSS.t578 385.798
R2212 VSS.n2857 VSS.t593 385.798
R2213 VSS.n2810 VSS.t608 385.798
R2214 VSS.n3201 VSS.t675 384.889
R2215 VSS.n3198 VSS.t522 380.038
R2216 VSS.n1275 VSS.t162 375.276
R2217 VSS.t130 VSS.n786 372.094
R2218 VSS.t132 VSS.n851 372.094
R2219 VSS.t344 VSS.n1270 363.339
R2220 VSS.n1174 VSS.t11 363.339
R2221 VSS.t719 VSS.t703 359.769
R2222 VSS.t27 VSS.n3199 357.007
R2223 VSS.n875 VSS.t694 347.49
R2224 VSS.n3196 VSS.t29 333.974
R2225 VSS.n3073 VSS.t541 333.065
R2226 VSS.n3026 VSS.t556 333.065
R2227 VSS.n2979 VSS.t571 333.065
R2228 VSS.n2893 VSS.t586 333.065
R2229 VSS.n2846 VSS.t601 333.065
R2230 VSS.n1591 VSS.t616 333.065
R2231 VSS.t646 VSS.n3201 333.063
R2232 VSS.t20 VSS.n870 329.238
R2233 VSS.n3385 VSS.t501 327.81
R2234 VSS.t478 VSS.n3186 322.457
R2235 VSS.t180 VSS.n1447 322.457
R2236 VSS.n3359 VSS.t93 314.327
R2237 VSS.t56 VSS.n3460 313.659
R2238 VSS.n1282 VSS.t531 305.183
R2239 VSS.n1370 VSS.t546 305.183
R2240 VSS.n1409 VSS.t561 305.183
R2241 VSS.n1493 VSS.t576 305.183
R2242 VSS.n1532 VSS.t591 305.183
R2243 VSS.n1571 VSS.t606 305.183
R2244 VSS.t664 VSS.t342 304.42
R2245 VSS.t156 VSS.n782 304.42
R2246 VSS.t716 VSS.t621 304.42
R2247 VSS.t228 VSS.n847 304.42
R2248 VSS.t38 VSS.n3459 299.733
R2249 VSS.n3191 VSS.t700 299.425
R2250 VSS.n3181 VSS.t528 293.666
R2251 VSS.n3048 VSS.t543 293.666
R2252 VSS.n3001 VSS.t558 293.666
R2253 VSS.n2915 VSS.t573 293.666
R2254 VSS.n2868 VSS.t588 293.666
R2255 VSS.n2821 VSS.t603 293.666
R2256 VSS.t221 VSS.n3183 292.757
R2257 VSS.n3072 VSS.t184 292.757
R2258 VSS.n3025 VSS.t638 292.757
R2259 VSS.n2978 VSS.t209 292.757
R2260 VSS.t31 VSS.n1460 292.757
R2261 VSS.n2892 VSS.t469 292.757
R2262 VSS.n2845 VSS.t215 292.757
R2263 VSS.n1596 VSS.t641 292.757
R2264 VSS.n790 VSS.t671 291.37
R2265 VSS.n855 VSS.t710 291.37
R2266 VSS.t676 VSS.n3191 287.909
R2267 VSS.n3185 VSS.t135 275.507
R2268 VSS.n3189 VSS.t365 269.726
R2269 VSS.n3186 VSS.t480 264.875
R2270 VSS.t182 VSS.n1447 264.875
R2271 VSS.t222 VSS.n3182 258.231
R2272 VSS.t185 VSS.n1356 258.231
R2273 VSS.t639 VSS.n1395 258.231
R2274 VSS.t210 VSS.n1434 258.231
R2275 VSS.t32 VSS.n1455 258.231
R2276 VSS.t470 VSS.n1518 258.231
R2277 VSS.t216 VSS.n1557 258.231
R2278 VSS.n1840 VSS.t642 258.231
R2279 VSS.t382 VSS.n3193 258.207
R2280 VSS.t364 VSS.n3196 253.359
R2281 VSS.t134 VSS.n1613 252.375
R2282 VSS.t499 VSS.n1619 252.375
R2283 VSS.t160 VSS.n1633 252.375
R2284 VSS.t67 VSS.n1661 252.375
R2285 VSS.t696 VSS.n1675 252.375
R2286 VSS.t721 VSS.n1689 252.375
R2287 VSS.t55 VSS.n1703 252.375
R2288 VSS.t485 VSS.n1717 252.375
R2289 VSS.t43 VSS.n1731 252.375
R2290 VSS.t137 VSS.n1745 252.375
R2291 VSS.t161 VSS.n1759 252.375
R2292 VSS.t360 VSS.n1773 252.375
R2293 VSS.t711 VSS.n1787 252.375
R2294 VSS.t652 VSS.n1801 252.375
R2295 VSS.t618 VSS.n1815 252.375
R2296 VSS.t473 VSS.n1829 252.375
R2297 VSS.t232 VSS.n1647 252.374
R2298 VSS.t620 VSS.n1627 252.117
R2299 VSS.t472 VSS.n1641 252.117
R2300 VSS.t689 VSS.n1655 252.117
R2301 VSS.t359 VSS.n1669 252.117
R2302 VSS.t22 VSS.n1697 252.117
R2303 VSS.t199 VSS.n1711 252.117
R2304 VSS.t720 VSS.n1725 252.117
R2305 VSS.t427 VSS.n1753 252.117
R2306 VSS.t340 VSS.n1795 252.117
R2307 VSS.t420 VSS.n1823 252.117
R2308 VSS.t64 VSS.n1683 252.115
R2309 VSS.t462 VSS.n1739 252.115
R2310 VSS.t695 VSS.n1767 252.115
R2311 VSS.t0 VSS.n1781 252.115
R2312 VSS.t379 VSS.n1809 252.115
R2313 VSS.n1616 VSS.t302 250.837
R2314 VSS.n1622 VSS.t288 250.837
R2315 VSS.n1630 VSS.t286 250.837
R2316 VSS.n1636 VSS.t304 250.837
R2317 VSS.n1644 VSS.t244 250.837
R2318 VSS.n1650 VSS.t306 250.837
R2319 VSS.n1658 VSS.t312 250.837
R2320 VSS.n1664 VSS.t308 250.837
R2321 VSS.n1672 VSS.t292 250.837
R2322 VSS.n1678 VSS.t248 250.837
R2323 VSS.n1686 VSS.t296 250.837
R2324 VSS.n1692 VSS.t314 250.837
R2325 VSS.n1700 VSS.t316 250.837
R2326 VSS.n1706 VSS.t284 250.837
R2327 VSS.n1714 VSS.t310 250.837
R2328 VSS.n1720 VSS.t300 250.837
R2329 VSS.n1728 VSS.t298 250.837
R2330 VSS.n1734 VSS.t294 250.837
R2331 VSS.n1742 VSS.t246 250.837
R2332 VSS.n1748 VSS.t320 250.837
R2333 VSS.n1756 VSS.t318 250.837
R2334 VSS.n1762 VSS.t322 250.837
R2335 VSS.n1770 VSS.t290 250.837
R2336 VSS.n1776 VSS.t326 250.837
R2337 VSS.n1784 VSS.t242 250.837
R2338 VSS.n1790 VSS.t330 250.837
R2339 VSS.n1798 VSS.t328 250.837
R2340 VSS.n1804 VSS.t332 250.837
R2341 VSS.n1812 VSS.t324 250.837
R2342 VSS.n1818 VSS.t334 250.837
R2343 VSS.n1826 VSS.t336 250.837
R2344 VSS.n1832 VSS.t338 250.837
R2345 VSS.n1272 VSS.n1271 249.036
R2346 VSS.n1173 VSS.n823 249.036
R2347 VSS.n875 VSS.t20 243.244
R2348 VSS.t536 VSS.n1339 240.957
R2349 VSS.t551 VSS.n1378 240.957
R2350 VSS.t566 VSS.n1417 240.957
R2351 VSS.t581 VSS.n1501 240.957
R2352 VSS.t596 VSS.n1540 240.957
R2353 VSS.t611 VSS.n1579 240.957
R2354 VSS.t362 VSS.n3202 240.954
R2355 VSS.t655 VSS.n1625 234.114
R2356 VSS.t457 VSS.n1639 234.114
R2357 VSS.t148 VSS.n1653 234.114
R2358 VSS.t128 VSS.n1667 234.114
R2359 VSS.t60 VSS.n1681 234.114
R2360 VSS.t23 VSS.n1695 234.114
R2361 VSS.t424 VSS.n1709 234.114
R2362 VSS.t498 VSS.n1723 234.114
R2363 VSS.t631 VSS.n1737 234.114
R2364 VSS.t400 VSS.n1751 234.114
R2365 VSS.t235 VSS.n1765 234.114
R2366 VSS.t13 VSS.n1779 234.114
R2367 VSS.t226 VSS.n1793 234.114
R2368 VSS.t670 VSS.n1807 234.114
R2369 VSS.t375 VSS.n1821 234.114
R2370 VSS.t150 VSS.n1835 234.114
R2371 VSS.n3199 VSS.t521 230.327
R2372 VSS.n1341 VSS.t536 229.439
R2373 VSS.n1380 VSS.t551 229.439
R2374 VSS.n1419 VSS.t566 229.439
R2375 VSS.n1503 VSS.t581 229.439
R2376 VSS.n1542 VSS.t596 229.439
R2377 VSS.n1581 VSS.t611 229.439
R2378 VSS.n3203 VSS.t362 228.827
R2379 VSS.t372 VSS.n1614 225.361
R2380 VSS.t653 VSS.n1628 225.361
R2381 VSS.t146 VSS.n1656 225.361
R2382 VSS.t25 VSS.n1698 225.361
R2383 VSS.t632 VSS.n1740 225.361
R2384 VSS.t377 VSS.n1824 225.361
R2385 VSS.t455 VSS.n1642 225.359
R2386 VSS.t126 VSS.n1670 225.359
R2387 VSS.t62 VSS.n1684 225.359
R2388 VSS.t425 VSS.n1712 225.359
R2389 VSS.t496 VSS.n1726 225.359
R2390 VSS.t398 VSS.n1754 225.359
R2391 VSS.t233 VSS.n1768 225.359
R2392 VSS.t15 VSS.n1782 225.359
R2393 VSS.t224 VSS.n1796 225.359
R2394 VSS.t668 VSS.n1810 225.359
R2395 VSS.t694 VSS.n874 224.516
R2396 VSS.n3808 VSS.t1 215.731
R2397 VSS.n3359 VSS.t1 215.731
R2398 VSS.n3183 VSS.t222 212.143
R2399 VSS.n3072 VSS.t185 212.143
R2400 VSS.n3025 VSS.t639 212.143
R2401 VSS.n2978 VSS.t210 212.143
R2402 VSS.n1460 VSS.t32 212.143
R2403 VSS.n2892 VSS.t470 212.143
R2404 VSS.n2845 VSS.t216 212.143
R2405 VSS.t642 VSS.n1596 212.143
R2406 VSS.n1617 VSS.t707 211.982
R2407 VSS.n1785 VSS.t440 211.982
R2408 VSS.n1813 VSS.t46 211.982
R2409 VSS.n1631 VSS.t165 211.982
R2410 VSS.n1645 VSS.t194 211.982
R2411 VSS.n1659 VSS.t661 211.982
R2412 VSS.n1673 VSS.t434 211.982
R2413 VSS.n1687 VSS.t443 211.982
R2414 VSS.n1701 VSS.t437 211.982
R2415 VSS.n1715 VSS.t449 211.982
R2416 VSS.n1729 VSS.t446 211.982
R2417 VSS.n1743 VSS.t658 211.982
R2418 VSS.n1757 VSS.t431 211.982
R2419 VSS.n1771 VSS.t218 211.982
R2420 VSS.n1799 VSS.t452 211.982
R2421 VSS.n1827 VSS.t40 211.982
R2422 VSS.n3458 VSS.t164 208.828
R2423 VSS.t521 VSS.n3198 207.294
R2424 VSS.n3460 VSS.t38 202.362
R2425 VSS.n789 VSS.t130 202.071
R2426 VSS.n854 VSS.t132 202.071
R2427 VSS.n3197 VSS.t364 200.649
R2428 VSS.n3463 VSS.n3462 197.518
R2429 VSS.t162 VSS.n1274 196.911
R2430 VSS.t671 VSS.n782 196.399
R2431 VSS.t710 VSS.n847 196.399
R2432 VSS.n3194 VSS.t382 195.778
R2433 VSS.t192 VSS.n1648 195.26
R2434 VSS.t698 VSS.n1690 195.26
R2435 VSS.t477 VSS.n1704 195.26
R2436 VSS.t635 VSS.n1718 195.26
R2437 VSS.t475 VSS.n1732 195.26
R2438 VSS.t142 VSS.n1746 195.26
R2439 VSS.t36 VSS.n1760 195.26
R2440 VSS.t417 VSS.n1802 195.26
R2441 VSS.t203 VSS.n1830 195.26
R2442 VSS.t72 VSS.n1620 195.26
R2443 VSS.t84 VSS.n1634 195.26
R2444 VSS.t396 VSS.n1662 195.26
R2445 VSS.t490 VSS.n1676 195.26
R2446 VSS.t493 VSS.n1774 195.26
R2447 VSS.t349 VSS.n1788 195.26
R2448 VSS.t656 VSS.n1816 195.26
R2449 VSS.t135 VSS.n3184 194.891
R2450 VSS.n3470 VSS.t704 194.514
R2451 VSS.n1461 VSS.t182 189.132
R2452 VSS.t480 VSS.n3185 189.132
R2453 VSS.n3461 VSS.t56 187.895
R2454 VSS.n1623 VSS.t459 187.292
R2455 VSS.n1637 VSS.t404 187.292
R2456 VSS.n1651 VSS.t65 187.292
R2457 VSS.n1665 VSS.t513 187.292
R2458 VSS.n1679 VSS.t370 187.292
R2459 VSS.n1693 VSS.t627 187.292
R2460 VSS.n1707 VSS.t212 187.292
R2461 VSS.n1721 VSS.t650 187.292
R2462 VSS.n1735 VSS.t138 187.292
R2463 VSS.n1749 VSS.t489 187.292
R2464 VSS.n1763 VSS.t205 187.292
R2465 VSS.n1777 VSS.t207 187.292
R2466 VSS.n1791 VSS.t197 187.292
R2467 VSS.n1805 VSS.t385 187.292
R2468 VSS.n1819 VSS.t516 187.292
R2469 VSS.n1833 VSS.t626 187.292
R2470 VSS.t365 VSS.n3188 184.262
R2471 VSS.n813 VSS.t158 183.975
R2472 VSS.n791 VSS.t156 182.797
R2473 VSS.n856 VSS.t228 182.797
R2474 VSS.n2 VSS.t464 177.713
R2475 VSS.n3184 VSS.t221 177.633
R2476 VSS.n1461 VSS.t31 177.624
R2477 VSS.t184 VSS.n1350 177.62
R2478 VSS.t638 VSS.n1389 177.62
R2479 VSS.t209 VSS.n1428 177.62
R2480 VSS.t469 VSS.n1512 177.62
R2481 VSS.t215 VSS.n1551 177.62
R2482 VSS.t641 VSS.n1590 177.619
R2483 VSS.t422 VSS.n1626 173.913
R2484 VSS.t525 VSS.n1640 173.913
R2485 VSS.t390 VSS.n1654 173.913
R2486 VSS.t487 VSS.n1668 173.913
R2487 VSS.t393 VSS.n1682 173.913
R2488 VSS.t9 VSS.n1696 173.913
R2489 VSS.t50 VSS.n1710 173.913
R2490 VSS.t412 VSS.n1724 173.913
R2491 VSS.t409 VSS.n1738 173.913
R2492 VSS.t87 VSS.n1752 173.913
R2493 VSS.t687 VSS.n1766 173.913
R2494 VSS.t692 VSS.n1780 173.913
R2495 VSS.t53 VSS.n1794 173.913
R2496 VSS.t415 VSS.n1808 173.913
R2497 VSS.t429 VSS.n1822 173.913
R2498 VSS.t6 VSS.n1836 173.913
R2499 VSS.n876 VSS.t17 167.954
R2500 VSS.n3192 VSS.t676 165.488
R2501 VSS.t74 VSS.t708 163.881
R2502 VSS.t82 VSS.t166 163.881
R2503 VSS.t193 VSS.t195 163.881
R2504 VSS.t395 VSS.t662 163.881
R2505 VSS.t491 VSS.t435 163.881
R2506 VSS.t699 VSS.t444 163.881
R2507 VSS.t476 VSS.t438 163.881
R2508 VSS.t634 VSS.t450 163.881
R2509 VSS.t474 VSS.t447 163.881
R2510 VSS.t140 VSS.t659 163.881
R2511 VSS.t34 VSS.t432 163.881
R2512 VSS.t494 VSS.t219 163.881
R2513 VSS.t350 VSS.t441 163.881
R2514 VSS.t418 VSS.t453 163.881
R2515 VSS.t657 VSS.t47 163.881
R2516 VSS.t201 VSS.t41 163.881
R2517 VSS.n1279 VSS.t528 160.34
R2518 VSS.t543 VSS.n1369 160.34
R2519 VSS.t558 VSS.n1408 160.34
R2520 VSS.t573 VSS.n1492 160.34
R2521 VSS.t588 VSS.n1531 160.34
R2522 VSS.t603 VSS.n1570 160.34
R2523 VSS.t78 VSS.n1605 157.601
R2524 VSS.t625 VSS.n1609 156.464
R2525 VSS.t366 VSS.n1631 155.126
R2526 VSS.t152 VSS.n1645 155.126
R2527 VSS.t187 VSS.n1659 155.126
R2528 VSS.t467 VSS.n1673 155.126
R2529 VSS.t230 VSS.n1687 155.126
R2530 VSS.t144 VSS.n1701 155.126
R2531 VSS.t239 VSS.n1715 155.126
R2532 VSS.t44 VSS.n1729 155.126
R2533 VSS.t637 VSS.n1743 155.126
R2534 VSS.t463 VSS.n1757 155.126
R2535 VSS.t357 VSS.n1771 155.126
R2536 VSS.t518 VSS.n1799 155.126
R2537 VSS.t374 VSS.n1827 155.126
R2538 VSS.t241 VSS.n1617 155.125
R2539 VSS.t706 VSS.n1785 155.125
R2540 VSS.t402 VSS.n1813 155.125
R2541 VSS.n3464 VSS.t104 154.613
R2542 VSS.n3467 VSS.t110 154.613
R2543 VSS.t700 VSS.n3190 153.971
R2544 VSS.n1609 VSS.t406 153.851
R2545 VSS.t70 VSS.n1612 153.846
R2546 VSS.t421 VSS.n1623 153.846
R2547 VSS.t524 VSS.n1637 153.846
R2548 VSS.t389 VSS.n1651 153.846
R2549 VSS.t486 VSS.n1665 153.846
R2550 VSS.t392 VSS.n1679 153.846
R2551 VSS.t8 VSS.n1693 153.846
R2552 VSS.t49 VSS.n1707 153.846
R2553 VSS.t411 VSS.n1721 153.846
R2554 VSS.t408 VSS.n1735 153.846
R2555 VSS.t86 VSS.n1749 153.846
R2556 VSS.t686 VSS.n1763 153.846
R2557 VSS.t691 VSS.n1777 153.846
R2558 VSS.t52 VSS.n1791 153.846
R2559 VSS.t414 VSS.n1805 153.846
R2560 VSS.t428 VSS.n1819 153.846
R2561 VSS.t5 VSS.n1833 153.846
R2562 VSS.t79 VSS.n1610 153.236
R2563 VSS.t531 VSS.n1279 148.827
R2564 VSS.t546 VSS.n1369 148.827
R2565 VSS.t561 VSS.n1408 148.827
R2566 VSS.t576 VSS.n1492 148.827
R2567 VSS.t591 VSS.n1531 148.827
R2568 VSS.t606 VSS.n1570 148.827
R2569 VSS.n3469 VSS.t667 147.452
R2570 VSS.t465 VSS.n1624 147.157
R2571 VSS.t619 VSS.n1638 147.157
R2572 VSS.t519 VSS.n1652 147.157
R2573 VSS.t495 VSS.n1666 147.157
R2574 VSS.t697 VSS.n1680 147.157
R2575 VSS.t206 VSS.n1694 147.157
R2576 VSS.t80 VSS.n1708 147.157
R2577 VSS.t460 VSS.n1722 147.157
R2578 VSS.t629 VSS.n1736 147.157
R2579 VSS.t651 VSS.n1750 147.157
R2580 VSS.t190 VSS.n1764 147.157
R2581 VSS.t214 VSS.n1778 147.157
R2582 VSS.t492 VSS.n1792 147.157
R2583 VSS.t644 VSS.n1806 147.157
R2584 VSS.t500 VSS.n1820 147.157
R2585 VSS.t361 VSS.n1834 147.157
R2586 VSS.t125 VSS.n1838 145.093
R2587 VSS.t527 VSS.n1272 144.788
R2588 VSS.n823 VSS.t380 144.788
R2589 VSS.n791 VSS.t664 138.607
R2590 VSS.t621 VSS.n856 138.607
R2591 VSS.n1838 VSS.t121 138.404
R2592 VSS.n3202 VSS.t646 137.31
R2593 VSS.t616 VSS.n1590 137.31
R2594 VSS.t541 VSS.n1350 137.309
R2595 VSS.t556 VSS.n1389 137.309
R2596 VSS.t571 VSS.n1428 137.309
R2597 VSS.t586 VSS.n1512 137.309
R2598 VSS.t601 VSS.n1551 137.309
R2599 VSS.n637 VSS.n582 132.891
R2600 VSS.t121 VSS.n1837 131.974
R2601 VSS.n3187 VSS.t478 130.939
R2602 VSS.n1462 VSS.t180 130.939
R2603 VSS.n1604 VSS.t482 127.421
R2604 VSS.t271 VSS.n3465 125.359
R2605 VSS.t673 VSS.n1600 123.674
R2606 VSS.n1839 VSS.t125 122.516
R2607 VSS.n3462 VSS.n3461 122.129
R2608 VSS.n3454 VSS.t719 121.858
R2609 VSS.n1610 VSS.t625 120.691
R2610 VSS.t29 VSS.n3195 119.422
R2611 VSS.n3206 VSS.t76 118.249
R2612 VSS.n1599 VSS.t355 116.177
R2613 VSS.n830 VSS.t384 115.831
R2614 VSS.n1271 VSS.t344 112.361
R2615 VSS.t11 VSS.n1173 112.361
R2616 VSS.t200 VSS.n610 112.174
R2617 VSS.t353 VSS.n1602 108.683
R2618 VSS.n1618 VSS.t241 107.023
R2619 VSS.n1625 VSS.t465 107.023
R2620 VSS.n1632 VSS.t366 107.023
R2621 VSS.n1639 VSS.t619 107.023
R2622 VSS.n1646 VSS.t152 107.023
R2623 VSS.n1653 VSS.t519 107.023
R2624 VSS.n1660 VSS.t187 107.023
R2625 VSS.n1667 VSS.t495 107.023
R2626 VSS.n1674 VSS.t467 107.023
R2627 VSS.n1681 VSS.t697 107.023
R2628 VSS.n1688 VSS.t230 107.023
R2629 VSS.n1695 VSS.t206 107.023
R2630 VSS.n1702 VSS.t144 107.023
R2631 VSS.n1709 VSS.t80 107.023
R2632 VSS.n1716 VSS.t239 107.023
R2633 VSS.n1723 VSS.t460 107.023
R2634 VSS.n1730 VSS.t44 107.023
R2635 VSS.n1737 VSS.t629 107.023
R2636 VSS.n1744 VSS.t637 107.023
R2637 VSS.n1751 VSS.t651 107.023
R2638 VSS.n1758 VSS.t463 107.023
R2639 VSS.n1765 VSS.t190 107.023
R2640 VSS.n1772 VSS.t357 107.023
R2641 VSS.n1779 VSS.t214 107.023
R2642 VSS.n1786 VSS.t706 107.023
R2643 VSS.n1793 VSS.t492 107.023
R2644 VSS.n1800 VSS.t518 107.023
R2645 VSS.n1807 VSS.t644 107.023
R2646 VSS.n1814 VSS.t402 107.023
R2647 VSS.n1821 VSS.t500 107.023
R2648 VSS.n1828 VSS.t374 107.023
R2649 VSS.n1835 VSS.t361 107.023
R2650 VSS.n3207 VSS.t367 106.808
R2651 VSS.n3499 VSS.n582 106.77
R2652 VSS.n3455 VSS.t387 103.54
R2653 VSS.n625 VSS.t352 103.379
R2654 VSS.n1612 VSS.t116 100.335
R2655 VSS.n1624 VSS.t421 100.335
R2656 VSS.n1638 VSS.t524 100.335
R2657 VSS.n1652 VSS.t389 100.335
R2658 VSS.n1666 VSS.t486 100.335
R2659 VSS.n1680 VSS.t392 100.335
R2660 VSS.n1694 VSS.t8 100.335
R2661 VSS.n1708 VSS.t49 100.335
R2662 VSS.n1722 VSS.t411 100.335
R2663 VSS.n1736 VSS.t408 100.335
R2664 VSS.n1750 VSS.t86 100.335
R2665 VSS.n1764 VSS.t686 100.335
R2666 VSS.n1778 VSS.t691 100.335
R2667 VSS.n1792 VSS.t52 100.335
R2668 VSS.n1806 VSS.t414 100.335
R2669 VSS.n1820 VSS.t428 100.335
R2670 VSS.n1834 VSS.t5 100.335
R2671 VSS.t106 VSS.n3464 99.7511
R2672 VSS.t112 VSS.n3467 99.7511
R2673 VSS.n622 VSS.t3 98.4633
R2674 VSS.n3468 VSS.t112 97.9286
R2675 VSS.n3465 VSS.t106 97.9283
R2676 VSS.t154 VSS.n815 97.5777
R2677 VSS.t405 VSS.n1607 97.4396
R2678 VSS.n3200 VSS.t27 96.3896
R2679 VSS.n1605 VSS.t483 93.8889
R2680 VSS.n1607 VSS.t368 93.6919
R2681 VSS.n1837 VSS.t6 88.4947
R2682 VSS.n3205 VSS.t622 88.4111
R2683 VSS.t57 VSS.n3458 88.3462
R2684 VSS.n1683 VSS.t393 88.2366
R2685 VSS.n1739 VSS.t409 88.2366
R2686 VSS.n1767 VSS.t687 88.2366
R2687 VSS.n1781 VSS.t692 88.2366
R2688 VSS.n1809 VSS.t415 88.2366
R2689 VSS.n1627 VSS.t422 88.2359
R2690 VSS.n1641 VSS.t525 88.2359
R2691 VSS.n1655 VSS.t390 88.2359
R2692 VSS.n1669 VSS.t487 88.2359
R2693 VSS.n1697 VSS.t9 88.2359
R2694 VSS.n1711 VSS.t50 88.2359
R2695 VSS.n1725 VSS.t412 88.2359
R2696 VSS.n1753 VSS.t87 88.2359
R2697 VSS.n1795 VSS.t53 88.2359
R2698 VSS.n1823 VSS.t429 88.2359
R2699 VSS.t116 VSS.t68 86.957
R2700 VSS.t118 VSS.t70 86.957
R2701 VSS.t157 VSS.n789 85.7923
R2702 VSS.t229 VSS.n854 85.7923
R2703 VSS.t675 VSS.n3200 84.8733
R2704 VSS.t622 VSS.n3204 83.0562
R2705 VSS.n1602 VSS.t624 82.449
R2706 VSS.t59 VSS.n3456 81.2384
R2707 VSS.n3466 VSS.t271 80.4704
R2708 VSS.n185 VSS.t678 77.8798
R2709 VSS.n3452 VSS.t515 77.2751
R2710 VSS.t712 VSS.t189 77.2751
R2711 VSS.t703 VSS.n3453 75.4357
R2712 VSS.t624 VSS.n1601 75.2962
R2713 VSS.t672 VSS.n1599 74.9537
R2714 VSS.t68 VSS.n1611 74.8587
R2715 VSS.t684 VSS.n636 74.7824
R2716 VSS.t522 VSS.n3197 73.9682
R2717 VSS.t714 VSS.n611 73.536
R2718 VSS.n612 VSS.n609 73.536
R2719 VSS.t708 VSS.n1618 70.2346
R2720 VSS.t166 VSS.n1632 70.2346
R2721 VSS.t195 VSS.n1646 70.2346
R2722 VSS.t662 VSS.n1660 70.2346
R2723 VSS.t435 VSS.n1674 70.2346
R2724 VSS.t444 VSS.n1688 70.2346
R2725 VSS.t438 VSS.n1702 70.2346
R2726 VSS.t450 VSS.n1716 70.2346
R2727 VSS.t447 VSS.n1730 70.2346
R2728 VSS.t659 VSS.n1744 70.2346
R2729 VSS.t432 VSS.n1758 70.2346
R2730 VSS.t219 VSS.n1772 70.2346
R2731 VSS.t441 VSS.n1786 70.2346
R2732 VSS.t453 VSS.n1800 70.2346
R2733 VSS.t47 VSS.n1814 70.2346
R2734 VSS.t41 VSS.n1828 70.2346
R2735 VSS.t174 VSS.n157 69.1047
R2736 VSS.n1339 VSS.t533 68.21
R2737 VSS.t548 VSS.n1378 68.21
R2738 VSS.t563 VSS.n1417 68.21
R2739 VSS.t578 VSS.n1501 68.21
R2740 VSS.t593 VSS.n1540 68.21
R2741 VSS.t608 VSS.n1579 68.21
R2742 VSS.n1600 VSS.t672 67.4583
R2743 VSS.n177 VSS.t680 66.9109
R2744 VSS.n1621 VSS.t72 66.8901
R2745 VSS.t459 VSS.n1622 66.8901
R2746 VSS.n1635 VSS.t84 66.8901
R2747 VSS.t404 VSS.n1636 66.8901
R2748 VSS.n1649 VSS.t192 66.8901
R2749 VSS.t65 VSS.n1650 66.8901
R2750 VSS.n1663 VSS.t396 66.8901
R2751 VSS.t513 VSS.n1664 66.8901
R2752 VSS.n1677 VSS.t490 66.8901
R2753 VSS.t370 VSS.n1678 66.8901
R2754 VSS.n1691 VSS.t698 66.8901
R2755 VSS.t627 VSS.n1692 66.8901
R2756 VSS.n1705 VSS.t477 66.8901
R2757 VSS.t212 VSS.n1706 66.8901
R2758 VSS.n1719 VSS.t635 66.8901
R2759 VSS.t650 VSS.n1720 66.8901
R2760 VSS.n1733 VSS.t475 66.8901
R2761 VSS.t138 VSS.n1734 66.8901
R2762 VSS.n1747 VSS.t142 66.8901
R2763 VSS.t489 VSS.n1748 66.8901
R2764 VSS.n1761 VSS.t36 66.8901
R2765 VSS.t205 VSS.n1762 66.8901
R2766 VSS.n1775 VSS.t493 66.8901
R2767 VSS.t207 VSS.n1776 66.8901
R2768 VSS.n1789 VSS.t349 66.8901
R2769 VSS.t197 VSS.n1790 66.8901
R2770 VSS.n1803 VSS.t417 66.8901
R2771 VSS.t385 VSS.n1804 66.8901
R2772 VSS.n1817 VSS.t656 66.8901
R2773 VSS.t516 VSS.n1818 66.8901
R2774 VSS.n1831 VSS.t203 66.8901
R2775 VSS.t626 VSS.n1832 66.8901
R2776 VSS.t483 VSS.n1604 63.7107
R2777 VSS.t368 VSS.n1606 62.4441
R2778 VSS.n3195 VSS.t381 61.8407
R2779 VSS.n3500 VSS.n581 61.012
R2780 VSS.n561 VSS.n559 61.012
R2781 VSS.n536 VSS.n534 61.012
R2782 VSS.n315 VSS.n314 61.012
R2783 VSS.n514 VSS.n512 61.012
R2784 VSS.n325 VSS.n324 61.012
R2785 VSS.n336 VSS.n335 61.012
R2786 VSS.n490 VSS.n488 61.012
R2787 VSS.n341 VSS.n340 61.012
R2788 VSS.n463 VSS.n461 61.012
R2789 VSS.n365 VSS.n364 61.012
R2790 VSS.n451 VSS.n449 61.012
R2791 VSS.n371 VSS.n370 61.012
R2792 VSS.n430 VSS.n428 61.012
R2793 VSS.n376 VSS.n375 61.012
R2794 VSS.n614 VSS.n609 59.3547
R2795 VSS.n1608 VSS.t405 58.6964
R2796 VSS.n670 VSS.t170 58.1358
R2797 VSS.n637 VSS.t684 58.1084
R2798 VSS.t667 VSS.n3468 58.0271
R2799 VSS.t90 VSS.n819 57.9156
R2800 VSS.n565 VSS.t250 57.8009
R2801 VSS.t261 VSS.n363 57.8009
R2802 VSS.n1463 VSS.t236 56.6724
R2803 VSS.t538 VSS.n1349 56.0825
R2804 VSS.t553 VSS.n1388 56.0825
R2805 VSS.t568 VSS.n1427 56.0825
R2806 VSS.t583 VSS.n1511 56.0825
R2807 VSS.t598 VSS.n1550 56.0825
R2808 VSS.n1592 VSS.t613 56.0825
R2809 VSS.n170 VSS.t168 55.942
R2810 VSS.t76 VSS.n3205 54.6841
R2811 VSS.n417 VSS.t265 54.5897
R2812 VSS.t93 VSS.n778 53.7482
R2813 VSS.n636 VSS.t705 52.3478
R2814 VSS.t341 VSS.n1273 51.2456
R2815 VSS.t649 VSS.n3187 50.3244
R2816 VSS.n1462 VSS.t520 50.3244
R2817 VSS.t707 VSS.n1616 50.1677
R2818 VSS.t165 VSS.n1630 50.1677
R2819 VSS.t194 VSS.n1644 50.1677
R2820 VSS.t661 VSS.n1658 50.1677
R2821 VSS.t434 VSS.n1672 50.1677
R2822 VSS.t443 VSS.n1686 50.1677
R2823 VSS.t437 VSS.n1700 50.1677
R2824 VSS.t449 VSS.n1714 50.1677
R2825 VSS.t446 VSS.n1728 50.1677
R2826 VSS.t658 VSS.n1742 50.1677
R2827 VSS.t431 VSS.n1756 50.1677
R2828 VSS.t218 VSS.n1770 50.1677
R2829 VSS.t440 VSS.n1784 50.1677
R2830 VSS.t452 VSS.n1798 50.1677
R2831 VSS.t46 VSS.n1812 50.1677
R2832 VSS.t40 VSS.n1826 50.1677
R2833 VSS.t96 VSS.n154 49.3606
R2834 VSS.t255 VSS.n319 48.1675
R2835 VSS.n499 VSS.t257 48.1675
R2836 VSS.n1603 VSS.t353 47.4535
R2837 VSS.t679 VSS.n181 47.1669
R2838 VSS.n684 VSS.t681 47.1669
R2839 VSS.n622 VSS.t714 46.116
R2840 VSS.n162 VSS.t172 44.9731
R2841 VSS.n1270 VSS.t342 44.1903
R2842 VSS.n1174 VSS.t716 44.1903
R2843 VSS.t110 VSS.n3466 43.0642
R2844 VSS.t104 VSS.n3463 43.0619
R2845 VSS.t515 VSS.n610 42.3769
R2846 VSS.t355 VSS.n1598 39.9582
R2847 VSS.n826 VSS.t666 39.1873
R2848 VSS.t253 VSS.n310 38.5341
R2849 VSS.n477 VSS.t259 38.5341
R2850 VSS.t172 VSS.n161 38.3917
R2851 VSS.n1615 VSS.t372 36.7898
R2852 VSS.n1629 VSS.t653 36.7898
R2853 VSS.n1643 VSS.t455 36.7898
R2854 VSS.n1657 VSS.t146 36.7898
R2855 VSS.n1671 VSS.t126 36.7898
R2856 VSS.n1685 VSS.t62 36.7898
R2857 VSS.n1699 VSS.t25 36.7898
R2858 VSS.n1713 VSS.t425 36.7898
R2859 VSS.n1727 VSS.t496 36.7898
R2860 VSS.n1741 VSS.t632 36.7898
R2861 VSS.n1755 VSS.t398 36.7898
R2862 VSS.n1769 VSS.t233 36.7898
R2863 VSS.n1783 VSS.t15 36.7898
R2864 VSS.n1797 VSS.t224 36.7898
R2865 VSS.n1811 VSS.t668 36.7898
R2866 VSS.n1825 VSS.t377 36.7898
R2867 VSS.t93 VSS.n3208 36.5288
R2868 VSS.n1598 VSS.t367 36.2105
R2869 VSS.n665 VSS.t679 36.1979
R2870 VSS.t681 VSS.n173 36.1979
R2871 VSS.n1601 VSS.t673 34.07
R2872 VSS.n679 VSS.t96 34.0042
R2873 VSS.t39 VSS.n3455 33.9057
R2874 VSS.n438 VSS.t263 32.1118
R2875 VSS.t352 VSS.n611 31.1596
R2876 VSS.t263 VSS.n369 28.9007
R2877 VSS.t482 VSS.n1603 28.7152
R2878 VSS.n3207 VSS.n3206 28.3058
R2879 VSS.n1647 VSS.t193 28.2943
R2880 VSS.n1801 VSS.t418 28.2941
R2881 VSS.n1619 VSS.t74 28.2941
R2882 VSS.n1633 VSS.t82 28.2941
R2883 VSS.n1661 VSS.t395 28.2941
R2884 VSS.n1675 VSS.t491 28.2941
R2885 VSS.n1689 VSS.t699 28.2941
R2886 VSS.n1703 VSS.t476 28.2941
R2887 VSS.n1717 VSS.t634 28.2941
R2888 VSS.n1731 VSS.t474 28.2941
R2889 VSS.n1745 VSS.t140 28.2941
R2890 VSS.n1759 VSS.t34 28.2941
R2891 VSS.n1773 VSS.t494 28.2941
R2892 VSS.n1787 VSS.t350 28.2941
R2893 VSS.n1815 VSS.t657 28.2941
R2894 VSS.n1829 VSS.t201 28.2941
R2895 VSS.n1611 VSS.t79 28.0352
R2896 VSS.t464 VSS.n3469 27.7523
R2897 VSS.t682 VSS.n826 27.6043
R2898 VSS.t168 VSS.n168 27.4228
R2899 VSS.n3190 VSS.t701 27.2918
R2900 VSS.t170 VSS.n166 25.229
R2901 VSS.n614 VSS.t712 24.4565
R2902 VSS.n539 VSS.t253 22.4784
R2903 VSS.t259 VSS.n343 22.4784
R2904 VSS.n625 VSS.t200 22.3643
R2905 VSS.n828 VSS.t347 22.2881
R2906 VSS.t18 VSS.n870 22.2881
R2907 VSS.t690 VSS.n1434 22.1556
R2908 VSS.t237 VSS.n1443 22.1456
R2909 VSS.n389 VSS.n387 21.8346
R2910 VSS.n386 VSS.n385 21.8346
R2911 VSS.n384 VSS.n383 21.8346
R2912 VSS.n382 VSS.n381 21.8346
R2913 VSS.n380 VSS.n379 21.8346
R2914 VSS.n423 VSS.n421 21.8346
R2915 VSS.n426 VSS.n424 21.8346
R2916 VSS.n374 VSS.n373 21.8346
R2917 VSS.n437 VSS.n435 21.8346
R2918 VSS.n441 VSS.n440 21.8346
R2919 VSS.n443 VSS.n441 21.8346
R2920 VSS.n446 VSS.n444 21.8346
R2921 VSS.n368 VSS.n367 21.8346
R2922 VSS.n458 VSS.n456 21.8346
R2923 VSS.n465 VSS.n362 21.8346
R2924 VSS.n362 VSS.n361 21.8346
R2925 VSS.n360 VSS.n359 21.8346
R2926 VSS.n358 VSS.n357 21.8346
R2927 VSS.n356 VSS.n355 21.8346
R2928 VSS.n353 VSS.n352 21.8346
R2929 VSS.n351 VSS.n350 21.8346
R2930 VSS.n349 VSS.n348 21.8346
R2931 VSS.n347 VSS.n346 21.8346
R2932 VSS.n345 VSS.n344 21.8346
R2933 VSS.n483 VSS.n481 21.8346
R2934 VSS.n486 VSS.n484 21.8346
R2935 VSS.n339 VSS.n338 21.8346
R2936 VSS.n497 VSS.n495 21.8346
R2937 VSS.n334 VSS.n333 21.8346
R2938 VSS.n332 VSS.n331 21.8346
R2939 VSS.n330 VSS.n329 21.8346
R2940 VSS.n328 VSS.n327 21.8346
R2941 VSS.n509 VSS.n507 21.8346
R2942 VSS.n323 VSS.n322 21.8346
R2943 VSS.n318 VSS.n317 21.8346
R2944 VSS.n523 VSS.n521 21.8346
R2945 VSS.n525 VSS.n524 21.8346
R2946 VSS.n528 VSS.n526 21.8346
R2947 VSS.n531 VSS.n529 21.8346
R2948 VSS.n312 VSS.n311 21.8346
R2949 VSS.n542 VSS.n540 21.8346
R2950 VSS.n545 VSS.n543 21.8346
R2951 VSS.n548 VSS.n546 21.8346
R2952 VSS.n551 VSS.n549 21.8346
R2953 VSS.n553 VSS.n552 21.8346
R2954 VSS.n556 VSS.n554 21.8346
R2955 VSS.n309 VSS.n308 21.8346
R2956 VSS.n307 VSS.n306 21.8346
R2957 VSS.n568 VSS.n566 21.8346
R2958 VSS.n571 VSS.n569 21.8346
R2959 VSS.n574 VSS.n572 21.8346
R2960 VSS.n577 VSS.n575 21.8346
R2961 VSS.n578 VSS.n577 21.8346
R2962 VSS.n575 VSS.n574 21.8346
R2963 VSS.n572 VSS.n571 21.8346
R2964 VSS.n569 VSS.n568 21.8346
R2965 VSS.n308 VSS.n307 21.8346
R2966 VSS.n560 VSS.n309 21.8346
R2967 VSS.n557 VSS.n556 21.8346
R2968 VSS.n554 VSS.n553 21.8346
R2969 VSS.n552 VSS.n551 21.8346
R2970 VSS.n549 VSS.n548 21.8346
R2971 VSS.n546 VSS.n545 21.8346
R2972 VSS.n543 VSS.n542 21.8346
R2973 VSS.n535 VSS.n312 21.8346
R2974 VSS.n532 VSS.n531 21.8346
R2975 VSS.n529 VSS.n528 21.8346
R2976 VSS.n526 VSS.n525 21.8346
R2977 VSS.n524 VSS.n523 21.8346
R2978 VSS.n521 VSS.n520 21.8346
R2979 VSS.n317 VSS.n316 21.8346
R2980 VSS.n322 VSS.n321 21.8346
R2981 VSS.n513 VSS.n323 21.8346
R2982 VSS.n510 VSS.n509 21.8346
R2983 VSS.n507 VSS.n506 21.8346
R2984 VSS.n327 VSS.n326 21.8346
R2985 VSS.n329 VSS.n328 21.8346
R2986 VSS.n331 VSS.n330 21.8346
R2987 VSS.n333 VSS.n332 21.8346
R2988 VSS.n495 VSS.n494 21.8346
R2989 VSS.n338 VSS.n337 21.8346
R2990 VSS.n489 VSS.n339 21.8346
R2991 VSS.n487 VSS.n486 21.8346
R2992 VSS.n484 VSS.n483 21.8346
R2993 VSS.n481 VSS.n480 21.8346
R2994 VSS.n476 VSS.n342 21.8346
R2995 VSS.n346 VSS.n345 21.8346
R2996 VSS.n348 VSS.n347 21.8346
R2997 VSS.n350 VSS.n349 21.8346
R2998 VSS.n352 VSS.n351 21.8346
R2999 VSS.n355 VSS.n353 21.8346
R3000 VSS.n357 VSS.n356 21.8346
R3001 VSS.n359 VSS.n358 21.8346
R3002 VSS.n361 VSS.n360 21.8346
R3003 VSS.n459 VSS.n458 21.8346
R3004 VSS.n456 VSS.n455 21.8346
R3005 VSS.n367 VSS.n366 21.8346
R3006 VSS.n450 VSS.n368 21.8346
R3007 VSS.n447 VSS.n446 21.8346
R3008 VSS.n444 VSS.n443 21.8346
R3009 VSS.n435 VSS.n434 21.8346
R3010 VSS.n373 VSS.n372 21.8346
R3011 VSS.n429 VSS.n374 21.8346
R3012 VSS.n427 VSS.n426 21.8346
R3013 VSS.n424 VSS.n423 21.8346
R3014 VSS.n421 VSS.n420 21.8346
R3015 VSS.n416 VSS.n377 21.8346
R3016 VSS.n381 VSS.n380 21.8346
R3017 VSS.n383 VSS.n382 21.8346
R3018 VSS.n385 VSS.n384 21.8346
R3019 VSS.n387 VSS.n386 21.8346
R3020 VSS.n389 VSS.n388 21.8346
R3021 VSS.n1613 VSS.t118 21.6051
R3022 VSS.t3 VSS.n612 21.1887
R3023 VSS.n1626 VSS.t655 20.0674
R3024 VSS.n1640 VSS.t457 20.0674
R3025 VSS.n1654 VSS.t148 20.0674
R3026 VSS.n1668 VSS.t128 20.0674
R3027 VSS.n1682 VSS.t60 20.0674
R3028 VSS.n1696 VSS.t23 20.0674
R3029 VSS.n1710 VSS.t424 20.0674
R3030 VSS.n1724 VSS.t498 20.0674
R3031 VSS.n1738 VSS.t631 20.0674
R3032 VSS.n1752 VSS.t400 20.0674
R3033 VSS.n1766 VSS.t235 20.0674
R3034 VSS.n1780 VSS.t13 20.0674
R3035 VSS.n1794 VSS.t226 20.0674
R3036 VSS.n1808 VSS.t670 20.0674
R3037 VSS.n1822 VSS.t375 20.0674
R3038 VSS.n1836 VSS.t150 20.0674
R3039 VSS.t705 VSS.t704 19.9423
R3040 VSS.n676 VSS.n58 19.1378
R3041 VSS.n686 VSS.n69 19.1369
R3042 VSS.n667 VSS.n67 19.1369
R3043 VSS.n669 VSS.n66 19.1369
R3044 VSS.n683 VSS.n65 19.1369
R3045 VSS.n682 VSS.n64 19.1369
R3046 VSS.n680 VSS.n63 19.1369
R3047 VSS.n671 VSS.n62 19.1369
R3048 VSS.n672 VSS.n61 19.1369
R3049 VSS.n673 VSS.n60 19.1369
R3050 VSS.n676 VSS.n59 19.1369
R3051 VSS.n687 VSS.n70 19.1369
R3052 VSS.n685 VSS.n69 19.1369
R3053 VSS.n666 VSS.n68 19.1369
R3054 VSS.n666 VSS.n67 19.1369
R3055 VSS.n668 VSS.n66 19.1369
R3056 VSS.n683 VSS.n64 19.1369
R3057 VSS.n681 VSS.n63 19.1369
R3058 VSS.n671 VSS.n61 19.1369
R3059 VSS.n674 VSS.n60 19.1369
R3060 VSS.n675 VSS.n59 19.1369
R3061 VSS.n678 VSS.n152 18.5857
R3062 VSS.n2798 VSS.n2797 18.4617
R3063 VSS.n1620 VSS.t499 18.0025
R3064 VSS.n1634 VSS.t160 18.0025
R3065 VSS.n1642 VSS.t472 18.0025
R3066 VSS.n1662 VSS.t67 18.0025
R3067 VSS.n1670 VSS.t359 18.0025
R3068 VSS.n1676 VSS.t696 18.0025
R3069 VSS.n1684 VSS.t64 18.0025
R3070 VSS.n1712 VSS.t199 18.0025
R3071 VSS.n1726 VSS.t720 18.0025
R3072 VSS.n1754 VSS.t427 18.0025
R3073 VSS.n1768 VSS.t695 18.0025
R3074 VSS.n1774 VSS.t360 18.0025
R3075 VSS.n1782 VSS.t0 18.0025
R3076 VSS.n1788 VSS.t711 18.0025
R3077 VSS.n1796 VSS.t340 18.0025
R3078 VSS.n1810 VSS.t379 18.0025
R3079 VSS.n1816 VSS.t618 18.0025
R3080 VSS.n1614 VSS.t134 18.0017
R3081 VSS.n1628 VSS.t620 18.0017
R3082 VSS.n1648 VSS.t232 18.0017
R3083 VSS.n1656 VSS.t689 18.0017
R3084 VSS.n1690 VSS.t721 18.0017
R3085 VSS.n1698 VSS.t22 18.0017
R3086 VSS.n1704 VSS.t55 18.0017
R3087 VSS.n1718 VSS.t485 18.0017
R3088 VSS.n1732 VSS.t43 18.0017
R3089 VSS.n1740 VSS.t462 18.0017
R3090 VSS.n1746 VSS.t137 18.0017
R3091 VSS.n1760 VSS.t161 18.0017
R3092 VSS.n1802 VSS.t652 18.0017
R3093 VSS.n1824 VSS.t420 18.0017
R3094 VSS.n1830 VSS.t473 18.0017
R3095 VSS.n3858 VSS.n3857 18.0005
R3096 VSS.t406 VSS.n1608 17.4722
R3097 VSS.n1599 VSS.n1277 17.0005
R3098 VSS.n1600 VSS.n1277 17.0005
R3099 VSS.n2527 VSS.n1277 17.0005
R3100 VSS.n1602 VSS.n1277 17.0005
R3101 VSS.n1604 VSS.n1277 17.0005
R3102 VSS.t484 VSS.n1277 17.0005
R3103 VSS.n1607 VSS.n1277 17.0005
R3104 VSS.n2513 VSS.n1277 17.0005
R3105 VSS.n2502 VSS.n1277 17.0005
R3106 VSS.n2497 VSS.n1277 17.0005
R3107 VSS.n2509 VSS.n1277 17.0005
R3108 VSS.t71 VSS.n1277 17.0005
R3109 VSS.n2574 VSS.n1277 17.0005
R3110 VSS.n1886 VSS.n1277 17.0005
R3111 VSS.n2800 VSS.n1594 17.0005
R3112 VSS.n2800 VSS.n1845 17.0005
R3113 VSS.t647 VSS.n1278 17.0005
R3114 VSS.n3199 VSS.n1278 17.0005
R3115 VSS.t28 VSS.n1278 17.0005
R3116 VSS.n3198 VSS.n1278 17.0005
R3117 VSS.n3196 VSS.n1278 17.0005
R3118 VSS.n1318 VSS.n1278 17.0005
R3119 VSS.n3194 VSS.n1278 17.0005
R3120 VSS.n3191 VSS.n1278 17.0005
R3121 VSS.t702 VSS.n1278 17.0005
R3122 VSS.n3188 VSS.n1278 17.0005
R3123 VSS.n3186 VSS.n1278 17.0005
R3124 VSS.n1304 VSS.n1278 17.0005
R3125 VSS.n1288 VSS.n1278 17.0005
R3126 VSS.n3181 VSS.n3180 17.0005
R3127 VSS.n3180 VSS.n1282 17.0005
R3128 VSS.n3087 VSS.n3086 17.0005
R3129 VSS.n3084 VSS.n3083 17.0005
R3130 VSS.n3083 VSS.t535 17.0005
R3131 VSS.n3083 VSS.n1342 17.0005
R3132 VSS.n3074 VSS.n1361 17.0005
R3133 VSS.n3049 VSS.n3048 17.0005
R3134 VSS.n3049 VSS.n1370 17.0005
R3135 VSS.n1372 VSS.n1371 17.0005
R3136 VSS.n3038 VSS.n3037 17.0005
R3137 VSS.n3038 VSS.t550 17.0005
R3138 VSS.n3038 VSS.n1381 17.0005
R3139 VSS.n3027 VSS.n1400 17.0005
R3140 VSS.n3002 VSS.n3001 17.0005
R3141 VSS.n3002 VSS.n1409 17.0005
R3142 VSS.n1411 VSS.n1410 17.0005
R3143 VSS.n2991 VSS.n2990 17.0005
R3144 VSS.n2991 VSS.t565 17.0005
R3145 VSS.n2991 VSS.n1420 17.0005
R3146 VSS.n2980 VSS.n1465 17.0005
R3147 VSS.n2980 VSS.n1440 17.0005
R3148 VSS.n2980 VSS.t238 17.0005
R3149 VSS.n2980 VSS.t181 17.0005
R3150 VSS.n2980 VSS.n1447 17.0005
R3151 VSS.n2980 VSS.n1459 17.0005
R3152 VSS.n2916 VSS.n2915 17.0005
R3153 VSS.n2916 VSS.n1493 17.0005
R3154 VSS.n1495 VSS.n1494 17.0005
R3155 VSS.n2905 VSS.n2904 17.0005
R3156 VSS.n2905 VSS.t580 17.0005
R3157 VSS.n2905 VSS.n1504 17.0005
R3158 VSS.n2894 VSS.n1523 17.0005
R3159 VSS.n2869 VSS.n2868 17.0005
R3160 VSS.n2869 VSS.n1532 17.0005
R3161 VSS.n1534 VSS.n1533 17.0005
R3162 VSS.n2858 VSS.n2857 17.0005
R3163 VSS.n2858 VSS.t595 17.0005
R3164 VSS.n2858 VSS.n1543 17.0005
R3165 VSS.n2847 VSS.n1562 17.0005
R3166 VSS.n2822 VSS.n2821 17.0005
R3167 VSS.n2822 VSS.n1571 17.0005
R3168 VSS.n1573 VSS.n1572 17.0005
R3169 VSS.n2811 VSS.n2810 17.0005
R3170 VSS.n2811 VSS.t610 17.0005
R3171 VSS.n2811 VSS.n1582 17.0005
R3172 VSS.n3787 VSS.n199 17.0005
R3173 VSS.n3378 VSS.n739 17.0005
R3174 VSS.n3388 VSS.n53 17.0005
R3175 VSS.n3398 VSS.n724 17.0005
R3176 VSS.n3338 VSS.n3233 17.0005
R3177 VSS.n3346 VSS.n3223 17.0005
R3178 VSS.t512 VSS.n3212 17.0005
R3179 VSS.n37 VSS.n187 17.0005
R3180 VSS.n1274 VSS.t163 17.0005
R3181 VSS.n1272 VSS.t163 17.0005
R3182 VSS.n1270 VSS.t131 17.0005
R3183 VSS.t131 VSS.n792 17.0005
R3184 VSS.t131 VSS.n782 17.0005
R3185 VSS.t131 VSS.n786 17.0005
R3186 VSS.n1216 VSS.t346 17.0005
R3187 VSS.n1216 VSS.n830 17.0005
R3188 VSS.n1216 VSS.n816 17.0005
R3189 VSS.n1216 VSS.n827 17.0005
R3190 VSS.n1216 VSS.n818 17.0005
R3191 VSS.n1216 VSS.n819 17.0005
R3192 VSS.n1216 VSS.n823 17.0005
R3193 VSS.t133 VSS.n1174 17.0005
R3194 VSS.t133 VSS.n1172 17.0005
R3195 VSS.t133 VSS.n847 17.0005
R3196 VSS.t133 VSS.n851 17.0005
R3197 VSS.n1142 VSS.t159 17.0005
R3198 VSS.n1142 VSS.n876 17.0005
R3199 VSS.n1142 VSS.n875 17.0005
R3200 VSS.n92 VSS.n3500 17.0005
R3201 VSS.n92 VSS.n305 17.0005
R3202 VSS.n92 VSS.n561 17.0005
R3203 VSS.n92 VSS.t251 17.0005
R3204 VSS.n92 VSS.n310 17.0005
R3205 VSS.n92 VSS.n536 17.0005
R3206 VSS.n92 VSS.n313 17.0005
R3207 VSS.n92 VSS.n314 17.0005
R3208 VSS.n92 VSS.n514 17.0005
R3209 VSS.n92 VSS.n324 17.0005
R3210 VSS.n92 VSS.n499 17.0005
R3211 VSS.n92 VSS.n335 17.0005
R3212 VSS.n92 VSS.n490 17.0005
R3213 VSS.n92 VSS.t258 17.0005
R3214 VSS.n92 VSS.n340 17.0005
R3215 VSS.n92 VSS.n477 17.0005
R3216 VSS.n92 VSS.n343 17.0005
R3217 VSS.n92 VSS.n354 17.0005
R3218 VSS.n92 VSS.n466 17.0005
R3219 VSS.n92 VSS.n363 17.0005
R3220 VSS.n92 VSS.n463 17.0005
R3221 VSS.n92 VSS.n364 17.0005
R3222 VSS.n92 VSS.n451 17.0005
R3223 VSS.n92 VSS.n369 17.0005
R3224 VSS.n92 VSS.n438 17.0005
R3225 VSS.n92 VSS.n370 17.0005
R3226 VSS.n92 VSS.n430 17.0005
R3227 VSS.n92 VSS.n375 17.0005
R3228 VSS.n92 VSS.n417 17.0005
R3229 VSS.n92 VSS.n378 17.0005
R3230 VSS.n92 VSS.t266 17.0005
R3231 VSS.n376 VSS.n95 17.0005
R3232 VSS.n428 VSS.n95 17.0005
R3233 VSS.n371 VSS.n95 17.0005
R3234 VSS.n449 VSS.n95 17.0005
R3235 VSS.n365 VSS.n95 17.0005
R3236 VSS.n461 VSS.n95 17.0005
R3237 VSS.n272 VSS.n95 17.0005
R3238 VSS.n341 VSS.n95 17.0005
R3239 VSS.n488 VSS.n95 17.0005
R3240 VSS.t278 VSS.n95 17.0005
R3241 VSS.n336 VSS.n95 17.0005
R3242 VSS.n498 VSS.n95 17.0005
R3243 VSS.n325 VSS.n95 17.0005
R3244 VSS.n512 VSS.n95 17.0005
R3245 VSS.n320 VSS.n95 17.0005
R3246 VSS.n319 VSS.n95 17.0005
R3247 VSS.n315 VSS.n95 17.0005
R3248 VSS.n239 VSS.n95 17.0005
R3249 VSS.n534 VSS.n95 17.0005
R3250 VSS.n539 VSS.n95 17.0005
R3251 VSS.t268 VSS.n95 17.0005
R3252 VSS.n559 VSS.n95 17.0005
R3253 VSS.n565 VSS.n95 17.0005
R3254 VSS.n581 VSS.n95 17.0005
R3255 VSS.n3503 VSS.n95 17.0005
R3256 VSS.n37 VSS.n134 17.0005
R3257 VSS.n37 VSS.n141 17.0005
R3258 VSS.n37 VSS.n171 17.0005
R3259 VSS.n37 VSS.n164 17.0005
R3260 VSS.n778 VSS.n688 17.0005
R3261 VSS.n688 VSS.n665 17.0005
R3262 VSS.n688 VSS.n684 17.0005
R3263 VSS.n688 VSS.n670 17.0005
R3264 VSS.n3433 VSS.n688 17.0005
R3265 VSS.n688 VSS.n679 17.0005
R3266 VSS.n688 VSS.n677 17.0005
R3267 VSS.t58 VSS.n3452 17.0005
R3268 VSS.t58 VSS.n610 17.0005
R3269 VSS.t58 VSS.n611 17.0005
R3270 VSS.t58 VSS.n622 17.0005
R3271 VSS.t58 VSS.n612 17.0005
R3272 VSS.t58 VSS.n615 17.0005
R3273 VSS.n3460 VSS.t58 17.0005
R3274 VSS.n3456 VSS.t58 17.0005
R3275 VSS.n3454 VSS.t58 17.0005
R3276 VSS.n3453 VSS.t58 17.0005
R3277 VSS.n640 VSS.n636 17.0005
R3278 VSS.n640 VSS.t685 17.0005
R3279 VSS.n603 VSS.n1 17.0005
R3280 VSS.n593 VSS.n1 17.0005
R3281 VSS.n3489 VSS.n1 17.0005
R3282 VSS.n596 VSS.n1 17.0005
R3283 VSS.n599 VSS.n1 17.0005
R3284 VSS.n3480 VSS.n1 17.0005
R3285 VSS.n37 VSS.n151 17.0005
R3286 VSS.t680 VSS.n176 16.4539
R3287 VSS.n1276 VSS.n1275 16.2018
R3288 VSS.t648 VSS.n3192 15.7754
R3289 VSS.n388 VSS.n304 15.1414
R3290 VSS.n3470 VSS.n2 5.41263
R3291 VSS.n158 VSS.t174 14.2601
R3292 VSS.n1606 VSS.t78 13.7246
R3293 VSS.t93 VSS.t504 13.4836
R3294 VSS.n677 VSS.n152 13.0197
R3295 VSS.n320 VSS.t255 12.845
R3296 VSS.t257 VSS.n498 12.845
R3297 VSS.n686 VSS.n183 12.0761
R3298 VSS.n668 VSS.n176 12.0761
R3299 VSS.n681 VSS.n168 12.0761
R3300 VSS.n673 VSS.n161 12.0761
R3301 VSS.n675 VSS.n157 12.0761
R3302 VSS.n678 VSS.n154 12.0761
R3303 VSS.n687 VSS.n185 12.0761
R3304 VSS.n685 VSS.n181 12.0761
R3305 VSS.n667 VSS.n177 12.0761
R3306 VSS.n669 VSS.n173 12.0761
R3307 VSS.n682 VSS.n170 12.0761
R3308 VSS.n680 VSS.n166 12.0761
R3309 VSS.n672 VSS.n162 12.0761
R3310 VSS.n674 VSS.n158 12.0761
R3311 VSS.n677 VSS.n72 13.5726
R3312 VSS.n581 VSS.n578 10.9175
R3313 VSS.n559 VSS.n557 10.9175
R3314 VSS.n534 VSS.n532 10.9175
R3315 VSS.n316 VSS.n315 10.9175
R3316 VSS.n321 VSS.n320 10.9175
R3317 VSS.n512 VSS.n510 10.9175
R3318 VSS.n326 VSS.n325 10.9175
R3319 VSS.n337 VSS.n336 10.9175
R3320 VSS.n488 VSS.n487 10.9175
R3321 VSS.n342 VSS.n341 10.9175
R3322 VSS.n461 VSS.n459 10.9175
R3323 VSS.n366 VSS.n365 10.9175
R3324 VSS.n449 VSS.n447 10.9175
R3325 VSS.n372 VSS.n371 10.9175
R3326 VSS.n428 VSS.n427 10.9175
R3327 VSS.n377 VSS.n376 10.9175
R3328 VSS.n417 VSS.n416 10.9175
R3329 VSS.n420 VSS.n375 10.9175
R3330 VSS.n430 VSS.n429 10.9175
R3331 VSS.n434 VSS.n370 10.9175
R3332 VSS.n451 VSS.n450 10.9175
R3333 VSS.n455 VSS.n364 10.9175
R3334 VSS.n463 VSS.n462 10.9175
R3335 VSS.n477 VSS.n476 10.9175
R3336 VSS.n480 VSS.n340 10.9175
R3337 VSS.n490 VSS.n489 10.9175
R3338 VSS.n494 VSS.n335 10.9175
R3339 VSS.n506 VSS.n324 10.9175
R3340 VSS.n514 VSS.n513 10.9175
R3341 VSS.n520 VSS.n314 10.9175
R3342 VSS.n536 VSS.n535 10.9175
R3343 VSS.n561 VSS.n560 10.9175
R3344 VSS.n566 VSS.n565 10.9175
R3345 VSS.n306 VSS.n305 10.9175
R3346 VSS.n540 VSS.n539 10.9175
R3347 VSS.n311 VSS.n310 10.9175
R3348 VSS.n319 VSS.n318 10.9175
R3349 VSS.n498 VSS.n334 10.9175
R3350 VSS.n499 VSS.n497 10.9175
R3351 VSS.n344 VSS.n343 10.9175
R3352 VSS.n466 VSS.n465 10.9175
R3353 VSS.n462 VSS.n363 10.9175
R3354 VSS.n440 VSS.n369 10.9175
R3355 VSS.n438 VSS.n437 10.9175
R3356 VSS.n379 VSS.n378 10.9175
R3357 VSS.n776 VSS.n775 10.7899
R3358 VSS.n3853 VSS.n3852 10.7882
R3359 VSS.n774 VSS.n766 9.69236
R3360 VSS.n3856 VSS.n106 9.38994
R3361 VSS.n3854 VSS.n3853 9.38994
R3362 VSS.n3363 VSS.n776 9.38916
R3363 VSS.n1884 VSS.n1883 9.11631
R3364 VSS.n3530 VSS.n3504 9.11631
R3365 VSS.n1115 VSS.n1114 9.11631
R3366 VSS.n945 VSS.n942 9.11631
R3367 VSS.n3264 VSS.n3261 9.11631
R3368 VSS.n689 VSS.n3448 9.11631
R3369 VSS.n2214 VSS.n2212 9.11631
R3370 VSS.n3490 VSS.t89 9.08698
R3371 VSS.n1118 VSS.n1117 9.07383
R3372 VSS.n664 VSS.n663 9.07383
R3373 VSS.n638 VSS.n634 9.07383
R3374 VSS.n1260 VSS.n1259 9.07383
R3375 VSS.n3488 VSS.t89 9.0445
R3376 VSS.n2545 VSS.n2543 9.0005
R3377 VSS.n2539 VSS.n2546 9.0005
R3378 VSS.t77 VSS.n2537 9.0005
R3379 VSS.n2549 VSS.n2548 9.0005
R3380 VSS.n2551 VSS.n2550 9.0005
R3381 VSS.n2532 VSS.n2531 9.0005
R3382 VSS.n2554 VSS.n2553 9.0005
R3383 VSS.t674 VSS.n2555 9.0005
R3384 VSS.n2557 VSS.n2525 9.0005
R3385 VSS.n2558 VSS.t354 9.0005
R3386 VSS.n2560 VSS.n2559 9.0005
R3387 VSS.n2520 VSS.n2519 9.0005
R3388 VSS.n2563 VSS.n2562 9.0005
R3389 VSS.t369 VSS.n2564 9.0005
R3390 VSS.t407 VSS.n2146 9.0005
R3391 VSS.n2566 VSS.n2565 9.0005
R3392 VSS.n2512 VSS.n2143 9.0005
R3393 VSS.n2509 VSS.n2508 9.0005
R3394 VSS.n2499 VSS.n2148 9.0005
R3395 VSS.n2504 VSS.n2503 9.0005
R3396 VSS.n2495 VSS.n2150 9.0005
R3397 VSS.n2493 VSS.n2492 9.0005
R3398 VSS.n2489 VSS.n2488 9.0005
R3399 VSS.n2486 VSS.n2153 9.0005
R3400 VSS.n2484 VSS.n2483 9.0005
R3401 VSS.n2480 VSS.n2479 9.0005
R3402 VSS.n2477 VSS.n2155 9.0005
R3403 VSS.n2475 VSS.n2474 9.0005
R3404 VSS.n2471 VSS.n2470 9.0005
R3405 VSS.n2468 VSS.n2157 9.0005
R3406 VSS.n2466 VSS.n2465 9.0005
R3407 VSS.n2462 VSS.n2461 9.0005
R3408 VSS.n2459 VSS.n2159 9.0005
R3409 VSS.n2457 VSS.n2456 9.0005
R3410 VSS.n2453 VSS.n2452 9.0005
R3411 VSS.n2450 VSS.n2161 9.0005
R3412 VSS.n2448 VSS.n2447 9.0005
R3413 VSS.n2444 VSS.n2443 9.0005
R3414 VSS.n2441 VSS.n2163 9.0005
R3415 VSS.n2439 VSS.n2438 9.0005
R3416 VSS.n2435 VSS.n2434 9.0005
R3417 VSS.n2432 VSS.n2165 9.0005
R3418 VSS.n2430 VSS.n2429 9.0005
R3419 VSS.n2426 VSS.n2425 9.0005
R3420 VSS.n2423 VSS.n2167 9.0005
R3421 VSS.n2421 VSS.n2420 9.0005
R3422 VSS.n2417 VSS.n2416 9.0005
R3423 VSS.n2414 VSS.n2169 9.0005
R3424 VSS.n2412 VSS.n2411 9.0005
R3425 VSS.n2408 VSS.n2407 9.0005
R3426 VSS.n2405 VSS.n2171 9.0005
R3427 VSS.n2403 VSS.n2402 9.0005
R3428 VSS.n2399 VSS.n2398 9.0005
R3429 VSS.n2396 VSS.n2173 9.0005
R3430 VSS.n2394 VSS.n2393 9.0005
R3431 VSS.n2390 VSS.n2389 9.0005
R3432 VSS.n2387 VSS.n2175 9.0005
R3433 VSS.n2385 VSS.n2384 9.0005
R3434 VSS.n2381 VSS.n2380 9.0005
R3435 VSS.n2378 VSS.n2177 9.0005
R3436 VSS.n2376 VSS.n2375 9.0005
R3437 VSS.n2372 VSS.n2371 9.0005
R3438 VSS.n2369 VSS.n2179 9.0005
R3439 VSS.n2367 VSS.n2366 9.0005
R3440 VSS.n2363 VSS.n2362 9.0005
R3441 VSS.n2360 VSS.n2181 9.0005
R3442 VSS.n2358 VSS.n2357 9.0005
R3443 VSS.n2354 VSS.n2353 9.0005
R3444 VSS.n2351 VSS.n2183 9.0005
R3445 VSS.n2349 VSS.n2348 9.0005
R3446 VSS.n2345 VSS.n2344 9.0005
R3447 VSS.n2342 VSS.n2185 9.0005
R3448 VSS.n2340 VSS.n2339 9.0005
R3449 VSS.n2336 VSS.n2335 9.0005
R3450 VSS.n2333 VSS.n2187 9.0005
R3451 VSS.n2331 VSS.n2330 9.0005
R3452 VSS.n2327 VSS.n2326 9.0005
R3453 VSS.n2324 VSS.n2189 9.0005
R3454 VSS.n2322 VSS.n2321 9.0005
R3455 VSS.n2318 VSS.n2317 9.0005
R3456 VSS.n2315 VSS.n2191 9.0005
R3457 VSS.n2313 VSS.n2312 9.0005
R3458 VSS.n2309 VSS.n2308 9.0005
R3459 VSS.n2306 VSS.n2193 9.0005
R3460 VSS.n2304 VSS.n2303 9.0005
R3461 VSS.n2300 VSS.n2299 9.0005
R3462 VSS.n2297 VSS.n2195 9.0005
R3463 VSS.n2295 VSS.n2294 9.0005
R3464 VSS.n2291 VSS.n2290 9.0005
R3465 VSS.n2288 VSS.n2197 9.0005
R3466 VSS.n2286 VSS.n2285 9.0005
R3467 VSS.n2282 VSS.n2281 9.0005
R3468 VSS.n2279 VSS.n2199 9.0005
R3469 VSS.n2277 VSS.n2276 9.0005
R3470 VSS.n2273 VSS.n2272 9.0005
R3471 VSS.n2270 VSS.n2201 9.0005
R3472 VSS.n2268 VSS.n2267 9.0005
R3473 VSS.n2264 VSS.n2263 9.0005
R3474 VSS.n2261 VSS.n2203 9.0005
R3475 VSS.n2259 VSS.n2258 9.0005
R3476 VSS.n2255 VSS.n2254 9.0005
R3477 VSS.n2252 VSS.n2205 9.0005
R3478 VSS.n2250 VSS.n2249 9.0005
R3479 VSS.n2246 VSS.n2245 9.0005
R3480 VSS.n2243 VSS.n2207 9.0005
R3481 VSS.n2241 VSS.n2240 9.0005
R3482 VSS.n2237 VSS.n2236 9.0005
R3483 VSS.n2234 VSS.n2209 9.0005
R3484 VSS.n2232 VSS.n2231 9.0005
R3485 VSS.n2228 VSS.n2227 9.0005
R3486 VSS.n2225 VSS.n2211 9.0005
R3487 VSS.n2223 VSS.n2222 9.0005
R3488 VSS.n2219 VSS.n2218 9.0005
R3489 VSS.n2216 VSS.n2213 9.0005
R3490 VSS.n2571 VSS.n2570 9.0005
R3491 VSS.n2575 VSS.n2139 9.0005
R3492 VSS.n2576 VSS.t373 9.0005
R3493 VSS.n2577 VSS.n2138 9.0005
R3494 VSS.t709 VSS.n2580 9.0005
R3495 VSS.t73 VSS.n2585 9.0005
R3496 VSS.n2588 VSS.n2587 9.0005
R3497 VSS.n2123 VSS.n2593 9.0005
R3498 VSS.n2594 VSS.t167 9.0005
R3499 VSS.t85 VSS.n2599 9.0005
R3500 VSS.n2602 VSS.n2601 9.0005
R3501 VSS.n2107 VSS.n2607 9.0005
R3502 VSS.n2608 VSS.t196 9.0005
R3503 VSS.t66 VSS.n2613 9.0005
R3504 VSS.n2616 VSS.n2615 9.0005
R3505 VSS.n2091 VSS.n2621 9.0005
R3506 VSS.n2622 VSS.t663 9.0005
R3507 VSS.t397 VSS.n2627 9.0005
R3508 VSS.n2630 VSS.n2629 9.0005
R3509 VSS.n2075 VSS.n2635 9.0005
R3510 VSS.n2636 VSS.t436 9.0005
R3511 VSS.t371 VSS.n2641 9.0005
R3512 VSS.n2644 VSS.n2643 9.0005
R3513 VSS.n2059 VSS.n2649 9.0005
R3514 VSS.n2650 VSS.t445 9.0005
R3515 VSS.t628 VSS.n2655 9.0005
R3516 VSS.n2658 VSS.n2657 9.0005
R3517 VSS.n2043 VSS.n2663 9.0005
R3518 VSS.n2664 VSS.t439 9.0005
R3519 VSS.t213 VSS.n2669 9.0005
R3520 VSS.n2672 VSS.n2671 9.0005
R3521 VSS.n2027 VSS.n2677 9.0005
R3522 VSS.n2678 VSS.t451 9.0005
R3523 VSS.t636 VSS.n2683 9.0005
R3524 VSS.n2686 VSS.n2685 9.0005
R3525 VSS.n2011 VSS.n2691 9.0005
R3526 VSS.n2692 VSS.t448 9.0005
R3527 VSS.t139 VSS.n2697 9.0005
R3528 VSS.n2700 VSS.n2699 9.0005
R3529 VSS.n1995 VSS.n2705 9.0005
R3530 VSS.n2706 VSS.t660 9.0005
R3531 VSS.t143 VSS.n2711 9.0005
R3532 VSS.n2714 VSS.n2713 9.0005
R3533 VSS.n1979 VSS.n2719 9.0005
R3534 VSS.n2720 VSS.t433 9.0005
R3535 VSS.t37 VSS.n2725 9.0005
R3536 VSS.n2728 VSS.n2727 9.0005
R3537 VSS.n1963 VSS.n2733 9.0005
R3538 VSS.n2734 VSS.t220 9.0005
R3539 VSS.t208 VSS.n2739 9.0005
R3540 VSS.n2742 VSS.n2741 9.0005
R3541 VSS.n1947 VSS.n2747 9.0005
R3542 VSS.n2748 VSS.t442 9.0005
R3543 VSS.t198 VSS.n2753 9.0005
R3544 VSS.n2756 VSS.n2755 9.0005
R3545 VSS.n1931 VSS.n2761 9.0005
R3546 VSS.n2762 VSS.t454 9.0005
R3547 VSS.t386 VSS.n2767 9.0005
R3548 VSS.n2770 VSS.n2769 9.0005
R3549 VSS.n1915 VSS.n2775 9.0005
R3550 VSS.n2776 VSS.t48 9.0005
R3551 VSS.t517 VSS.n2781 9.0005
R3552 VSS.n2784 VSS.n2783 9.0005
R3553 VSS.n1898 VSS.n2789 9.0005
R3554 VSS.n2790 VSS.t42 9.0005
R3555 VSS.n2796 VSS.t204 9.0005
R3556 VSS.n2792 VSS.n2791 9.0005
R3557 VSS.n2794 VSS.n1892 9.0005
R3558 VSS.t430 VSS.n1902 9.0005
R3559 VSS.n2788 VSS.t378 9.0005
R3560 VSS.n1912 VSS.n1909 9.0005
R3561 VSS.n2780 VSS.n1907 9.0005
R3562 VSS.t416 VSS.n1918 9.0005
R3563 VSS.n2774 VSS.t669 9.0005
R3564 VSS.n1928 VSS.n1925 9.0005
R3565 VSS.n2766 VSS.n1923 9.0005
R3566 VSS.t54 VSS.n1934 9.0005
R3567 VSS.n2760 VSS.t225 9.0005
R3568 VSS.n1944 VSS.n1941 9.0005
R3569 VSS.n2752 VSS.n1939 9.0005
R3570 VSS.t693 VSS.n1950 9.0005
R3571 VSS.n2746 VSS.t16 9.0005
R3572 VSS.n1960 VSS.n1957 9.0005
R3573 VSS.n2738 VSS.n1955 9.0005
R3574 VSS.t688 VSS.n1966 9.0005
R3575 VSS.n2732 VSS.t234 9.0005
R3576 VSS.n1976 VSS.n1973 9.0005
R3577 VSS.n2724 VSS.n1971 9.0005
R3578 VSS.t88 VSS.n1982 9.0005
R3579 VSS.n2718 VSS.t399 9.0005
R3580 VSS.n1992 VSS.n1989 9.0005
R3581 VSS.n2710 VSS.n1987 9.0005
R3582 VSS.t410 VSS.n1998 9.0005
R3583 VSS.n2704 VSS.t633 9.0005
R3584 VSS.n2008 VSS.n2005 9.0005
R3585 VSS.n2696 VSS.n2003 9.0005
R3586 VSS.t413 VSS.n2014 9.0005
R3587 VSS.n2690 VSS.t497 9.0005
R3588 VSS.n2024 VSS.n2021 9.0005
R3589 VSS.n2682 VSS.n2019 9.0005
R3590 VSS.t51 VSS.n2030 9.0005
R3591 VSS.n2676 VSS.t426 9.0005
R3592 VSS.n2040 VSS.n2037 9.0005
R3593 VSS.n2668 VSS.n2035 9.0005
R3594 VSS.t10 VSS.n2046 9.0005
R3595 VSS.n2662 VSS.t26 9.0005
R3596 VSS.n2056 VSS.n2053 9.0005
R3597 VSS.n2654 VSS.n2051 9.0005
R3598 VSS.t394 VSS.n2062 9.0005
R3599 VSS.n2648 VSS.t63 9.0005
R3600 VSS.n2072 VSS.n2069 9.0005
R3601 VSS.n2640 VSS.n2067 9.0005
R3602 VSS.t488 VSS.n2078 9.0005
R3603 VSS.n2634 VSS.t127 9.0005
R3604 VSS.n2088 VSS.n2085 9.0005
R3605 VSS.n2626 VSS.n2083 9.0005
R3606 VSS.t391 VSS.n2094 9.0005
R3607 VSS.n2620 VSS.t147 9.0005
R3608 VSS.n2104 VSS.n2101 9.0005
R3609 VSS.n2612 VSS.n2099 9.0005
R3610 VSS.t526 VSS.n2110 9.0005
R3611 VSS.n2606 VSS.t456 9.0005
R3612 VSS.n2120 VSS.n2117 9.0005
R3613 VSS.n2598 VSS.n2115 9.0005
R3614 VSS.t423 VSS.n2126 9.0005
R3615 VSS.n2592 VSS.t654 9.0005
R3616 VSS.n2582 VSS.n2134 9.0005
R3617 VSS.n2584 VSS.n2131 9.0005
R3618 VSS.n1849 VSS.n1848 9.0005
R3619 VSS.n1881 VSS.n1880 9.0005
R3620 VSS.n1879 VSS.n1878 9.0005
R3621 VSS.n1877 VSS.n1876 9.0005
R3622 VSS.n1875 VSS.n1874 9.0005
R3623 VSS.n1873 VSS.n1872 9.0005
R3624 VSS.n1871 VSS.t643 9.0005
R3625 VSS.n1870 VSS.n1869 9.0005
R3626 VSS.n1868 VSS.n1867 9.0005
R3627 VSS.n1866 VSS.n1865 9.0005
R3628 VSS.n1864 VSS.t617 9.0005
R3629 VSS.n1863 VSS.n1862 9.0005
R3630 VSS.n1861 VSS.t614 9.0005
R3631 VSS.n2801 VSS.n1586 9.0005
R3632 VSS.n2802 VSS.t615 9.0005
R3633 VSS.n3132 VSS.n3131 9.0005
R3634 VSS.n3130 VSS.n1330 9.0005
R3635 VSS.n3129 VSS.n1329 9.0005
R3636 VSS.n3128 VSS.n1327 9.0005
R3637 VSS.n3127 VSS.n1326 9.0005
R3638 VSS.n3126 VSS.n1325 9.0005
R3639 VSS.n3125 VSS.n1323 9.0005
R3640 VSS.n3124 VSS.n1321 9.0005
R3641 VSS.n3123 VSS.n1320 9.0005
R3642 VSS.n3122 VSS.n1319 9.0005
R3643 VSS.n3121 VSS.n1317 9.0005
R3644 VSS.n3120 VSS.n1315 9.0005
R3645 VSS.n3119 VSS.n1314 9.0005
R3646 VSS.n3118 VSS.n1313 9.0005
R3647 VSS.n3117 VSS.n1311 9.0005
R3648 VSS.n3116 VSS.n1309 9.0005
R3649 VSS.n3115 VSS.n1308 9.0005
R3650 VSS.n3114 VSS.n1306 9.0005
R3651 VSS.n3113 VSS.n1305 9.0005
R3652 VSS.n3112 VSS.n1303 9.0005
R3653 VSS.n3111 VSS.n1301 9.0005
R3654 VSS.n3110 VSS.n1300 9.0005
R3655 VSS.n3109 VSS.n1299 9.0005
R3656 VSS.n3108 VSS.n1298 9.0005
R3657 VSS.n3107 VSS.n1297 9.0005
R3658 VSS.n3106 VSS.n1296 9.0005
R3659 VSS.n3105 VSS.n1295 9.0005
R3660 VSS.n3104 VSS.n1294 9.0005
R3661 VSS.n3103 VSS.n1293 9.0005
R3662 VSS.n3102 VSS.n1292 9.0005
R3663 VSS.n3101 VSS.n1291 9.0005
R3664 VSS.n3100 VSS.n1290 9.0005
R3665 VSS.n3099 VSS.n1289 9.0005
R3666 VSS.n3098 VSS.n1287 9.0005
R3667 VSS.n3097 VSS.n1286 9.0005
R3668 VSS.n3096 VSS.n1285 9.0005
R3669 VSS.n3095 VSS.n3094 9.0005
R3670 VSS.n3093 VSS.n1333 9.0005
R3671 VSS.n3092 VSS.n3091 9.0005
R3672 VSS.n3090 VSS.n1334 9.0005
R3673 VSS.n3089 VSS.n3088 9.0005
R3674 VSS.n1336 VSS.n1335 9.0005
R3675 VSS.n3080 VSS.n3079 9.0005
R3676 VSS.n3078 VSS.n1344 9.0005
R3677 VSS.n3077 VSS.n3076 9.0005
R3678 VSS.n1346 VSS.n1345 9.0005
R3679 VSS.n3062 VSS.n3061 9.0005
R3680 VSS.n3063 VSS.n3060 9.0005
R3681 VSS.n3065 VSS.n3064 9.0005
R3682 VSS.n3066 VSS.n3056 9.0005
R3683 VSS.n3068 VSS.n3067 9.0005
R3684 VSS.n3069 VSS.n1364 9.0005
R3685 VSS.n3071 VSS.n3070 9.0005
R3686 VSS.n3055 VSS.n1362 9.0005
R3687 VSS.n3054 VSS.n3053 9.0005
R3688 VSS.n3051 VSS.n1365 9.0005
R3689 VSS.n3043 VSS.n1366 9.0005
R3690 VSS.n3044 VSS.n1374 9.0005
R3691 VSS.n3046 VSS.n3045 9.0005
R3692 VSS.n3042 VSS.n1373 9.0005
R3693 VSS.n3041 VSS.n3040 9.0005
R3694 VSS.n1376 VSS.n1375 9.0005
R3695 VSS.n3033 VSS.n3032 9.0005
R3696 VSS.n3031 VSS.n1383 9.0005
R3697 VSS.n3030 VSS.n3029 9.0005
R3698 VSS.n1385 VSS.n1384 9.0005
R3699 VSS.n3015 VSS.n3014 9.0005
R3700 VSS.n3016 VSS.n3013 9.0005
R3701 VSS.n3018 VSS.n3017 9.0005
R3702 VSS.n3019 VSS.n3009 9.0005
R3703 VSS.n3021 VSS.n3020 9.0005
R3704 VSS.n3022 VSS.n1403 9.0005
R3705 VSS.n3024 VSS.n3023 9.0005
R3706 VSS.n3008 VSS.n1401 9.0005
R3707 VSS.n3007 VSS.n3006 9.0005
R3708 VSS.n3004 VSS.n1404 9.0005
R3709 VSS.n2996 VSS.n1405 9.0005
R3710 VSS.n2997 VSS.n1413 9.0005
R3711 VSS.n2999 VSS.n2998 9.0005
R3712 VSS.n2995 VSS.n1412 9.0005
R3713 VSS.n2994 VSS.n2993 9.0005
R3714 VSS.n1415 VSS.n1414 9.0005
R3715 VSS.n2986 VSS.n2985 9.0005
R3716 VSS.n2984 VSS.n1422 9.0005
R3717 VSS.n2983 VSS.n2982 9.0005
R3718 VSS.n1424 VSS.n1423 9.0005
R3719 VSS.n2968 VSS.n2967 9.0005
R3720 VSS.n2969 VSS.n2966 9.0005
R3721 VSS.n2971 VSS.n2970 9.0005
R3722 VSS.n2972 VSS.n2962 9.0005
R3723 VSS.n2974 VSS.n2973 9.0005
R3724 VSS.n2975 VSS.n1468 9.0005
R3725 VSS.n2977 VSS.n2976 9.0005
R3726 VSS.n2961 VSS.n1466 9.0005
R3727 VSS.n2960 VSS.n2959 9.0005
R3728 VSS.n2957 VSS.n1469 9.0005
R3729 VSS.n2955 VSS.n2954 9.0005
R3730 VSS.n2953 VSS.n1471 9.0005
R3731 VSS.n2952 VSS.n2951 9.0005
R3732 VSS.n2949 VSS.n1473 9.0005
R3733 VSS.n2947 VSS.n2946 9.0005
R3734 VSS.n2945 VSS.n1475 9.0005
R3735 VSS.n2944 VSS.n2943 9.0005
R3736 VSS.n2941 VSS.n1477 9.0005
R3737 VSS.n2939 VSS.n2938 9.0005
R3738 VSS.n2937 VSS.n1479 9.0005
R3739 VSS.n2936 VSS.n2935 9.0005
R3740 VSS.n2934 VSS.n1481 9.0005
R3741 VSS.n2932 VSS.n2931 9.0005
R3742 VSS.n2930 VSS.n1483 9.0005
R3743 VSS.n2929 VSS.n2928 9.0005
R3744 VSS.n2926 VSS.n1485 9.0005
R3745 VSS.n2924 VSS.n2923 9.0005
R3746 VSS.n2922 VSS.n1487 9.0005
R3747 VSS.n2921 VSS.n2920 9.0005
R3748 VSS.n2918 VSS.n1488 9.0005
R3749 VSS.n2910 VSS.n1489 9.0005
R3750 VSS.n2911 VSS.n1497 9.0005
R3751 VSS.n2913 VSS.n2912 9.0005
R3752 VSS.n2909 VSS.n1496 9.0005
R3753 VSS.n2908 VSS.n2907 9.0005
R3754 VSS.n1499 VSS.n1498 9.0005
R3755 VSS.n2900 VSS.n2899 9.0005
R3756 VSS.n2898 VSS.n1506 9.0005
R3757 VSS.n2897 VSS.n2896 9.0005
R3758 VSS.n1508 VSS.n1507 9.0005
R3759 VSS.n2882 VSS.n2881 9.0005
R3760 VSS.n2883 VSS.n2880 9.0005
R3761 VSS.n2885 VSS.n2884 9.0005
R3762 VSS.n2886 VSS.n2876 9.0005
R3763 VSS.n2888 VSS.n2887 9.0005
R3764 VSS.n2889 VSS.n1526 9.0005
R3765 VSS.n2891 VSS.n2890 9.0005
R3766 VSS.n2875 VSS.n1524 9.0005
R3767 VSS.n2874 VSS.n2873 9.0005
R3768 VSS.n2871 VSS.n1527 9.0005
R3769 VSS.n2863 VSS.n1528 9.0005
R3770 VSS.n2864 VSS.n1536 9.0005
R3771 VSS.n2866 VSS.n2865 9.0005
R3772 VSS.n2862 VSS.n1535 9.0005
R3773 VSS.n2861 VSS.n2860 9.0005
R3774 VSS.n1538 VSS.n1537 9.0005
R3775 VSS.n2853 VSS.n2852 9.0005
R3776 VSS.n2851 VSS.n1545 9.0005
R3777 VSS.n2850 VSS.n2849 9.0005
R3778 VSS.n1547 VSS.n1546 9.0005
R3779 VSS.n2835 VSS.n2834 9.0005
R3780 VSS.n2836 VSS.n2833 9.0005
R3781 VSS.n2838 VSS.n2837 9.0005
R3782 VSS.n2839 VSS.n2829 9.0005
R3783 VSS.n2841 VSS.n2840 9.0005
R3784 VSS.n2842 VSS.n1565 9.0005
R3785 VSS.n2844 VSS.n2843 9.0005
R3786 VSS.n2828 VSS.n1563 9.0005
R3787 VSS.n2827 VSS.n2826 9.0005
R3788 VSS.n2824 VSS.n1566 9.0005
R3789 VSS.n2816 VSS.n1567 9.0005
R3790 VSS.n2817 VSS.n1575 9.0005
R3791 VSS.n2819 VSS.n2818 9.0005
R3792 VSS.n2815 VSS.n1574 9.0005
R3793 VSS.n2814 VSS.n2813 9.0005
R3794 VSS.n1577 VSS.n1576 9.0005
R3795 VSS.n2806 VSS.n2805 9.0005
R3796 VSS.n2804 VSS.n1584 9.0005
R3797 VSS.n2803 VSS.n2802 9.0005
R3798 VSS.n1586 VSS.n1585 9.0005
R3799 VSS.n1861 VSS.n1860 9.0005
R3800 VSS.n1863 VSS.n1859 9.0005
R3801 VSS.n1864 VSS.n1858 9.0005
R3802 VSS.n1866 VSS.n1857 9.0005
R3803 VSS.n1868 VSS.n1856 9.0005
R3804 VSS.n1870 VSS.n1855 9.0005
R3805 VSS.n1871 VSS.n1854 9.0005
R3806 VSS.n1873 VSS.n1853 9.0005
R3807 VSS.n1875 VSS.n1852 9.0005
R3808 VSS.n1877 VSS.n1851 9.0005
R3809 VSS.n1879 VSS.n1850 9.0005
R3810 VSS.n1882 VSS.n1881 9.0005
R3811 VSS.n1584 VSS.t612 9.0005
R3812 VSS.n2807 VSS.n2806 9.0005
R3813 VSS.n1580 VSS.n1577 9.0005
R3814 VSS.n2813 VSS.t609 9.0005
R3815 VSS.n1574 VSS.n1573 9.0005
R3816 VSS.t607 VSS.n2819 9.0005
R3817 VSS.n1575 VSS.t605 9.0005
R3818 VSS.n2823 VSS.n1567 9.0005
R3819 VSS.n2824 VSS.t604 9.0005
R3820 VSS.n2826 VSS.n2825 9.0005
R3821 VSS.n1563 VSS.n1561 9.0005
R3822 VSS.t217 VSS.n2844 9.0005
R3823 VSS.n1565 VSS.n1564 9.0005
R3824 VSS.n2840 VSS.n2830 9.0005
R3825 VSS.n2839 VSS.n2831 9.0005
R3826 VSS.n2838 VSS.t602 9.0005
R3827 VSS.n2833 VSS.n2832 9.0005
R3828 VSS.n2834 VSS.t600 9.0005
R3829 VSS.n2848 VSS.n1547 9.0005
R3830 VSS.n2849 VSS.t599 9.0005
R3831 VSS.n1545 VSS.t597 9.0005
R3832 VSS.n2854 VSS.n2853 9.0005
R3833 VSS.n1541 VSS.n1538 9.0005
R3834 VSS.n2860 VSS.t594 9.0005
R3835 VSS.n1535 VSS.n1534 9.0005
R3836 VSS.t592 VSS.n2866 9.0005
R3837 VSS.n1536 VSS.t590 9.0005
R3838 VSS.n2870 VSS.n1528 9.0005
R3839 VSS.n2871 VSS.t589 9.0005
R3840 VSS.n2873 VSS.n2872 9.0005
R3841 VSS.n1524 VSS.n1522 9.0005
R3842 VSS.t471 VSS.n2891 9.0005
R3843 VSS.n1526 VSS.n1525 9.0005
R3844 VSS.n2887 VSS.n2877 9.0005
R3845 VSS.n2886 VSS.n2878 9.0005
R3846 VSS.n2885 VSS.t587 9.0005
R3847 VSS.n2880 VSS.n2879 9.0005
R3848 VSS.n2881 VSS.t585 9.0005
R3849 VSS.n2895 VSS.n1508 9.0005
R3850 VSS.n2896 VSS.t584 9.0005
R3851 VSS.n1506 VSS.t582 9.0005
R3852 VSS.n2901 VSS.n2900 9.0005
R3853 VSS.n1502 VSS.n1499 9.0005
R3854 VSS.n2907 VSS.t579 9.0005
R3855 VSS.n1496 VSS.n1495 9.0005
R3856 VSS.t577 VSS.n2913 9.0005
R3857 VSS.n1497 VSS.t575 9.0005
R3858 VSS.n2917 VSS.n1489 9.0005
R3859 VSS.n2918 VSS.t574 9.0005
R3860 VSS.n2920 VSS.n2919 9.0005
R3861 VSS.n1487 VSS.n1486 9.0005
R3862 VSS.n2924 VSS.t33 9.0005
R3863 VSS.n2926 VSS.n2925 9.0005
R3864 VSS.n2928 VSS.n2927 9.0005
R3865 VSS.n1483 VSS.n1482 9.0005
R3866 VSS.n2932 VSS.n1484 9.0005
R3867 VSS.n2934 VSS.n2933 9.0005
R3868 VSS.n2935 VSS.t183 9.0005
R3869 VSS.n1479 VSS.n1478 9.0005
R3870 VSS.n2939 VSS.n1480 9.0005
R3871 VSS.n2941 VSS.n2940 9.0005
R3872 VSS.n2943 VSS.n2942 9.0005
R3873 VSS.n1475 VSS.n1474 9.0005
R3874 VSS.n2947 VSS.n1476 9.0005
R3875 VSS.n2949 VSS.n2948 9.0005
R3876 VSS.n2951 VSS.n2950 9.0005
R3877 VSS.n1471 VSS.n1470 9.0005
R3878 VSS.n2955 VSS.n1472 9.0005
R3879 VSS.n2957 VSS.n2956 9.0005
R3880 VSS.n2959 VSS.n2958 9.0005
R3881 VSS.n1466 VSS.n1464 9.0005
R3882 VSS.t211 VSS.n2977 9.0005
R3883 VSS.n1468 VSS.n1467 9.0005
R3884 VSS.n2973 VSS.n2963 9.0005
R3885 VSS.n2972 VSS.n2964 9.0005
R3886 VSS.n2971 VSS.t572 9.0005
R3887 VSS.n2966 VSS.n2965 9.0005
R3888 VSS.n2967 VSS.t570 9.0005
R3889 VSS.n2981 VSS.n1424 9.0005
R3890 VSS.n2982 VSS.t569 9.0005
R3891 VSS.n1422 VSS.t567 9.0005
R3892 VSS.n2987 VSS.n2986 9.0005
R3893 VSS.n1418 VSS.n1415 9.0005
R3894 VSS.n2993 VSS.t564 9.0005
R3895 VSS.n1412 VSS.n1411 9.0005
R3896 VSS.t562 VSS.n2999 9.0005
R3897 VSS.n1413 VSS.t560 9.0005
R3898 VSS.n3003 VSS.n1405 9.0005
R3899 VSS.n3004 VSS.t559 9.0005
R3900 VSS.n3006 VSS.n3005 9.0005
R3901 VSS.n1401 VSS.n1399 9.0005
R3902 VSS.t640 VSS.n3024 9.0005
R3903 VSS.n1403 VSS.n1402 9.0005
R3904 VSS.n3020 VSS.n3010 9.0005
R3905 VSS.n3019 VSS.n3011 9.0005
R3906 VSS.n3018 VSS.t557 9.0005
R3907 VSS.n3013 VSS.n3012 9.0005
R3908 VSS.n3014 VSS.t555 9.0005
R3909 VSS.n3028 VSS.n1385 9.0005
R3910 VSS.n3029 VSS.t554 9.0005
R3911 VSS.n1383 VSS.t552 9.0005
R3912 VSS.n3034 VSS.n3033 9.0005
R3913 VSS.n1379 VSS.n1376 9.0005
R3914 VSS.n3040 VSS.t549 9.0005
R3915 VSS.n1373 VSS.n1372 9.0005
R3916 VSS.t547 VSS.n3046 9.0005
R3917 VSS.n1374 VSS.t545 9.0005
R3918 VSS.n3050 VSS.n1366 9.0005
R3919 VSS.n3051 VSS.t544 9.0005
R3920 VSS.n3053 VSS.n3052 9.0005
R3921 VSS.n1362 VSS.n1360 9.0005
R3922 VSS.t186 VSS.n3071 9.0005
R3923 VSS.n1364 VSS.n1363 9.0005
R3924 VSS.n3067 VSS.n3057 9.0005
R3925 VSS.n3066 VSS.n3058 9.0005
R3926 VSS.n3065 VSS.t542 9.0005
R3927 VSS.n3060 VSS.n3059 9.0005
R3928 VSS.n3061 VSS.t540 9.0005
R3929 VSS.n3075 VSS.n1346 9.0005
R3930 VSS.n3076 VSS.t539 9.0005
R3931 VSS.n1344 VSS.t537 9.0005
R3932 VSS.n3081 VSS.n3080 9.0005
R3933 VSS.n1340 VSS.n1336 9.0005
R3934 VSS.n3088 VSS.t534 9.0005
R3935 VSS.n3087 VSS.n1334 9.0005
R3936 VSS.n3092 VSS.t532 9.0005
R3937 VSS.n3093 VSS.t530 9.0005
R3938 VSS.n3094 VSS.n1284 9.0005
R3939 VSS.t529 VSS.n1285 9.0005
R3940 VSS.n3177 VSS.n1286 9.0005
R3941 VSS.n3175 VSS.n1287 9.0005
R3942 VSS.t223 VSS.n1289 9.0005
R3943 VSS.n3173 VSS.n1290 9.0005
R3944 VSS.n3171 VSS.n1291 9.0005
R3945 VSS.n3169 VSS.n1292 9.0005
R3946 VSS.n3167 VSS.n1293 9.0005
R3947 VSS.n3165 VSS.n1294 9.0005
R3948 VSS.n3163 VSS.n1295 9.0005
R3949 VSS.n3161 VSS.n1296 9.0005
R3950 VSS.n3159 VSS.n1297 9.0005
R3951 VSS.n3157 VSS.n1298 9.0005
R3952 VSS.n3155 VSS.n1299 9.0005
R3953 VSS.n3153 VSS.n1300 9.0005
R3954 VSS.t136 VSS.n1301 9.0005
R3955 VSS.n3151 VSS.n1303 9.0005
R3956 VSS.t481 VSS.n1305 9.0005
R3957 VSS.t479 VSS.n1306 9.0005
R3958 VSS.n3149 VSS.n1308 9.0005
R3959 VSS.n3147 VSS.n1309 9.0005
R3960 VSS.n1310 VSS.n1311 9.0005
R3961 VSS.t677 VSS.n1313 9.0005
R3962 VSS.n3145 VSS.n1314 9.0005
R3963 VSS.n1316 VSS.n1315 9.0005
R3964 VSS.n3143 VSS.n1317 9.0005
R3965 VSS.t30 VSS.n1319 9.0005
R3966 VSS.n3141 VSS.n1320 9.0005
R3967 VSS.t523 VSS.n1321 9.0005
R3968 VSS.n3139 VSS.n1323 9.0005
R3969 VSS.n1324 VSS.n1325 9.0005
R3970 VSS.n3137 VSS.n1326 9.0005
R3971 VSS.n3135 VSS.n1327 9.0005
R3972 VSS.n1328 VSS.n1329 9.0005
R3973 VSS.n1331 VSS.n1330 9.0005
R3974 VSS.n3133 VSS.n3132 9.0005
R3975 VSS.n217 VSS.n215 9.0005
R3976 VSS.n3694 VSS.n218 9.0005
R3977 VSS.n3695 VSS.n219 9.0005
R3978 VSS.n3696 VSS.n220 9.0005
R3979 VSS.n3697 VSS.n221 9.0005
R3980 VSS.n3698 VSS.n222 9.0005
R3981 VSS.n3699 VSS.n223 9.0005
R3982 VSS.n3700 VSS.n224 9.0005
R3983 VSS.n3701 VSS.n225 9.0005
R3984 VSS.n3702 VSS.n226 9.0005
R3985 VSS.n3704 VSS.n3703 9.0005
R3986 VSS.n3693 VSS.n228 9.0005
R3987 VSS.n3692 VSS.n3691 9.0005
R3988 VSS.n230 VSS.n229 9.0005
R3989 VSS.n3667 VSS.n233 9.0005
R3990 VSS.n3668 VSS.n234 9.0005
R3991 VSS.n3669 VSS.n235 9.0005
R3992 VSS.n3670 VSS.n236 9.0005
R3993 VSS.n3671 VSS.n237 9.0005
R3994 VSS.n3672 VSS.n238 9.0005
R3995 VSS.n3674 VSS.n3673 9.0005
R3996 VSS.n3666 VSS.n240 9.0005
R3997 VSS.n3665 VSS.n3664 9.0005
R3998 VSS.n242 VSS.n241 9.0005
R3999 VSS.n3614 VSS.n245 9.0005
R4000 VSS.n3615 VSS.n246 9.0005
R4001 VSS.n3616 VSS.n247 9.0005
R4002 VSS.n3617 VSS.n248 9.0005
R4003 VSS.n3618 VSS.n249 9.0005
R4004 VSS.n3619 VSS.n250 9.0005
R4005 VSS.n3620 VSS.n251 9.0005
R4006 VSS.n3621 VSS.n252 9.0005
R4007 VSS.n3622 VSS.n253 9.0005
R4008 VSS.n3623 VSS.n254 9.0005
R4009 VSS.n3624 VSS.n255 9.0005
R4010 VSS.n3625 VSS.n256 9.0005
R4011 VSS.n3626 VSS.n257 9.0005
R4012 VSS.n3627 VSS.n258 9.0005
R4013 VSS.n3628 VSS.n259 9.0005
R4014 VSS.n3630 VSS.n3629 9.0005
R4015 VSS.n3613 VSS.n261 9.0005
R4016 VSS.n3612 VSS.n3611 9.0005
R4017 VSS.n263 VSS.n262 9.0005
R4018 VSS.n3587 VSS.n266 9.0005
R4019 VSS.n3588 VSS.n267 9.0005
R4020 VSS.n3589 VSS.n268 9.0005
R4021 VSS.n3590 VSS.n269 9.0005
R4022 VSS.n3591 VSS.n270 9.0005
R4023 VSS.n3592 VSS.n271 9.0005
R4024 VSS.n3594 VSS.n3593 9.0005
R4025 VSS.n3586 VSS.n273 9.0005
R4026 VSS.n3585 VSS.n3584 9.0005
R4027 VSS.n275 VSS.n274 9.0005
R4028 VSS.n3505 VSS.n278 9.0005
R4029 VSS.n3506 VSS.n279 9.0005
R4030 VSS.n3507 VSS.n280 9.0005
R4031 VSS.n3508 VSS.n281 9.0005
R4032 VSS.n3509 VSS.n282 9.0005
R4033 VSS.n3510 VSS.n283 9.0005
R4034 VSS.n3511 VSS.n284 9.0005
R4035 VSS.n3512 VSS.n285 9.0005
R4036 VSS.n3513 VSS.n286 9.0005
R4037 VSS.n3514 VSS.n287 9.0005
R4038 VSS.n3515 VSS.n288 9.0005
R4039 VSS.n3516 VSS.n289 9.0005
R4040 VSS.n3517 VSS.n290 9.0005
R4041 VSS.n3518 VSS.n291 9.0005
R4042 VSS.n3519 VSS.n292 9.0005
R4043 VSS.n3520 VSS.n293 9.0005
R4044 VSS.n3521 VSS.n294 9.0005
R4045 VSS.n3522 VSS.n295 9.0005
R4046 VSS.n3523 VSS.n296 9.0005
R4047 VSS.n3524 VSS.n297 9.0005
R4048 VSS.n3525 VSS.n298 9.0005
R4049 VSS.n3526 VSS.n299 9.0005
R4050 VSS.n3527 VSS.n300 9.0005
R4051 VSS.n3528 VSS.n301 9.0005
R4052 VSS.n3529 VSS.n302 9.0005
R4053 VSS.n3723 VSS.n217 9.0005
R4054 VSS.n3722 VSS.n218 9.0005
R4055 VSS.n3720 VSS.n219 9.0005
R4056 VSS.n3718 VSS.n220 9.0005
R4057 VSS.n3716 VSS.n221 9.0005
R4058 VSS.n3714 VSS.n222 9.0005
R4059 VSS.n3712 VSS.n223 9.0005
R4060 VSS.n3710 VSS.n224 9.0005
R4061 VSS.n3708 VSS.n225 9.0005
R4062 VSS.n3706 VSS.n226 9.0005
R4063 VSS.n227 VSS.n3704 9.0005
R4064 VSS.n231 VSS.n228 9.0005
R4065 VSS.n3691 VSS.n3690 9.0005
R4066 VSS.n3688 VSS.n230 9.0005
R4067 VSS.n3686 VSS.n233 9.0005
R4068 VSS.n3684 VSS.n234 9.0005
R4069 VSS.n3682 VSS.n235 9.0005
R4070 VSS.n3680 VSS.n236 9.0005
R4071 VSS.n3678 VSS.n237 9.0005
R4072 VSS.n3676 VSS.n238 9.0005
R4073 VSS.t274 VSS.n3674 9.0005
R4074 VSS.n243 VSS.n240 9.0005
R4075 VSS.n3664 VSS.n3663 9.0005
R4076 VSS.n3661 VSS.n242 9.0005
R4077 VSS.n3659 VSS.n245 9.0005
R4078 VSS.n3657 VSS.n246 9.0005
R4079 VSS.n3655 VSS.n247 9.0005
R4080 VSS.n3653 VSS.n248 9.0005
R4081 VSS.n3651 VSS.n249 9.0005
R4082 VSS.n3649 VSS.n250 9.0005
R4083 VSS.t276 VSS.n251 9.0005
R4084 VSS.n3646 VSS.n252 9.0005
R4085 VSS.n3644 VSS.n253 9.0005
R4086 VSS.n3642 VSS.n254 9.0005
R4087 VSS.n3640 VSS.n255 9.0005
R4088 VSS.n3638 VSS.n256 9.0005
R4089 VSS.n3636 VSS.n257 9.0005
R4090 VSS.n3634 VSS.n258 9.0005
R4091 VSS.n3632 VSS.n259 9.0005
R4092 VSS.n260 VSS.n3630 9.0005
R4093 VSS.n264 VSS.n261 9.0005
R4094 VSS.n3611 VSS.n3610 9.0005
R4095 VSS.n3608 VSS.n263 9.0005
R4096 VSS.n3606 VSS.n266 9.0005
R4097 VSS.n3604 VSS.n267 9.0005
R4098 VSS.n3602 VSS.n268 9.0005
R4099 VSS.n3600 VSS.n269 9.0005
R4100 VSS.n3598 VSS.n270 9.0005
R4101 VSS.n3596 VSS.n271 9.0005
R4102 VSS.t269 VSS.n3594 9.0005
R4103 VSS.n276 VSS.n273 9.0005
R4104 VSS.n3584 VSS.n3583 9.0005
R4105 VSS.n3581 VSS.n275 9.0005
R4106 VSS.n3579 VSS.n278 9.0005
R4107 VSS.n3577 VSS.n279 9.0005
R4108 VSS.n3575 VSS.n280 9.0005
R4109 VSS.n3573 VSS.n281 9.0005
R4110 VSS.n3571 VSS.n282 9.0005
R4111 VSS.n3569 VSS.n283 9.0005
R4112 VSS.t270 VSS.n284 9.0005
R4113 VSS.n3566 VSS.n285 9.0005
R4114 VSS.n3564 VSS.n286 9.0005
R4115 VSS.n3562 VSS.n287 9.0005
R4116 VSS.n3560 VSS.n288 9.0005
R4117 VSS.n3558 VSS.n289 9.0005
R4118 VSS.n3556 VSS.n290 9.0005
R4119 VSS.n3554 VSS.n291 9.0005
R4120 VSS.n3552 VSS.n292 9.0005
R4121 VSS.n3550 VSS.n293 9.0005
R4122 VSS.n3549 VSS.n294 9.0005
R4123 VSS.n3547 VSS.n295 9.0005
R4124 VSS.n3545 VSS.n296 9.0005
R4125 VSS.n3543 VSS.n297 9.0005
R4126 VSS.n3541 VSS.n298 9.0005
R4127 VSS.n3539 VSS.n299 9.0005
R4128 VSS.n3537 VSS.n300 9.0005
R4129 VSS.n3535 VSS.n301 9.0005
R4130 VSS.n3533 VSS.n302 9.0005
R4131 VSS.t283 VSS.n3531 9.0005
R4132 VSS.n3821 VSS.n119 9.0005
R4133 VSS.n3819 VSS.n3818 9.0005
R4134 VSS.n3814 VSS.n3813 9.0005
R4135 VSS.n3788 VSS.n3785 9.0005
R4136 VSS.n3794 VSS.n195 9.0005
R4137 VSS.n3798 VSS.n193 9.0005
R4138 VSS.n3802 VSS.n191 9.0005
R4139 VSS.n3772 VSS.n3771 9.0005
R4140 VSS.n202 VSS.n201 9.0005
R4141 VSS.n3763 VSS.n3762 9.0005
R4142 VSS.n3754 VSS.n3753 9.0005
R4143 VSS.n208 VSS.n207 9.0005
R4144 VSS.n3745 VSS.n3744 9.0005
R4145 VSS.n3736 VSS.n3735 9.0005
R4146 VSS.n214 VSS.n213 9.0005
R4147 VSS.n3729 VSS.n3728 9.0005
R4148 VSS.n3734 VSS.n3733 9.0005
R4149 VSS.n3743 VSS.n3742 9.0005
R4150 VSS.n3747 VSS.n3746 9.0005
R4151 VSS.n3752 VSS.n3751 9.0005
R4152 VSS.n3761 VSS.n3760 9.0005
R4153 VSS.n3765 VSS.n3764 9.0005
R4154 VSS.n3770 VSS.n3769 9.0005
R4155 VSS.n3804 VSS.n190 9.0005
R4156 VSS.n3800 VSS.n192 9.0005
R4157 VSS.n3796 VSS.n194 9.0005
R4158 VSS.n3786 VSS.n123 9.0005
R4159 VSS.n3811 VSS.n121 9.0005
R4160 VSS.n3851 VSS.n108 9.0005
R4161 VSS.n3850 VSS.n3849 9.0005
R4162 VSS.n3846 VSS.n111 9.0005
R4163 VSS.n3844 VSS.n3843 9.0005
R4164 VSS.n3835 VSS.n113 9.0005
R4165 VSS.n3838 VSS.n3837 9.0005
R4166 VSS.n3833 VSS.n115 9.0005
R4167 VSS.n3831 VSS.n3830 9.0005
R4168 VSS.n3823 VSS.n117 9.0005
R4169 VSS.n3826 VSS.n3825 9.0005
R4170 VSS.n3790 VSS.n198 9.0005
R4171 VSS.n3792 VSS.n196 9.0005
R4172 VSS.n3806 VSS.n189 9.0005
R4173 VSS.n3773 VSS.n188 9.0005
R4174 VSS.n205 VSS.n204 9.0005
R4175 VSS.n3756 VSS.n3755 9.0005
R4176 VSS.n211 VSS.n210 9.0005
R4177 VSS.n3738 VSS.n3737 9.0005
R4178 VSS.n777 VSS.n3334 9.0005
R4179 VSS.n3333 VSS.n3332 9.0005
R4180 VSS.n3336 VSS.n3242 9.0005
R4181 VSS.n3239 VSS.n3240 9.0005
R4182 VSS.t506 VSS.n3238 9.0005
R4183 VSS.n3236 VSS.n3235 9.0005
R4184 VSS.n3339 VSS.n3234 9.0005
R4185 VSS.t510 VSS.n3221 9.0005
R4186 VSS.t511 VSS.n3219 9.0005
R4187 VSS.n3310 VSS.n3209 9.0005
R4188 VSS.n3309 VSS.n3308 9.0005
R4189 VSS.n3293 VSS.n3292 9.0005
R4190 VSS.n3291 VSS.n3290 9.0005
R4191 VSS.n3273 VSS.n3272 9.0005
R4192 VSS.n3271 VSS.n3270 9.0005
R4193 VSS.n3260 VSS.n3257 9.0005
R4194 VSS.n3269 VSS.n3268 9.0005
R4195 VSS.n3255 VSS.n3254 9.0005
R4196 VSS.n3279 VSS.n3278 9.0005
R4197 VSS.n3281 VSS.n3280 9.0005
R4198 VSS.n3283 VSS.n3282 9.0005
R4199 VSS.n3251 VSS.n3250 9.0005
R4200 VSS.n3289 VSS.n3288 9.0005
R4201 VSS.n3248 VSS.n3247 9.0005
R4202 VSS.n3298 VSS.n3297 9.0005
R4203 VSS.n3300 VSS.n3299 9.0005
R4204 VSS.n3302 VSS.n3301 9.0005
R4205 VSS.n3245 VSS.n3244 9.0005
R4206 VSS.n3307 VSS.n3306 9.0005
R4207 VSS.n3357 VSS.n3210 9.0005
R4208 VSS.n3355 VSS.n3211 9.0005
R4209 VSS.n3353 VSS.n3213 9.0005
R4210 VSS.n3214 VSS.n3215 9.0005
R4211 VSS.n3351 VSS.n3216 9.0005
R4212 VSS.n3349 VSS.n3218 9.0005
R4213 VSS.n3347 VSS.n3224 9.0005
R4214 VSS.n3345 VSS.n3225 9.0005
R4215 VSS.n3343 VSS.n3226 9.0005
R4216 VSS.t509 VSS.n3228 9.0005
R4217 VSS.t508 VSS.n3231 9.0005
R4218 VSS.n3341 VSS.n3232 9.0005
R4219 VSS.n3364 VSS.n773 9.0005
R4220 VSS.n3365 VSS.n769 9.0005
R4221 VSS.n3366 VSS.n766 9.0005
R4222 VSS.n3377 VSS.n741 9.0005
R4223 VSS.n3379 VSS.n740 9.0005
R4224 VSS.t502 VSS.n738 9.0005
R4225 VSS.n3382 VSS.n737 9.0005
R4226 VSS.n755 VSS.n754 9.0005
R4227 VSS.n3389 VSS.n730 9.0005
R4228 VSS.n3391 VSS.n729 9.0005
R4229 VSS.n3393 VSS.n728 9.0005
R4230 VSS.n3395 VSS.n727 9.0005
R4231 VSS.n3397 VSS.n726 9.0005
R4232 VSS.n3399 VSS.n725 9.0005
R4233 VSS.n3406 VSS.n3405 9.0005
R4234 VSS.n3410 VSS.n3409 9.0005
R4235 VSS.n3412 VSS.n718 9.0005
R4236 VSS.n3415 VSS.n3414 9.0005
R4237 VSS.n3422 VSS.n3421 9.0005
R4238 VSS.n3424 VSS.n3423 9.0005
R4239 VSS.n3426 VSS.n707 9.0005
R4240 VSS.n3429 VSS.n3428 9.0005
R4241 VSS.n3431 VSS.n3430 9.0005
R4242 VSS.n3435 VSS.n702 9.0005
R4243 VSS.n3442 VSS.n695 9.0005
R4244 VSS.n3446 VSS.n3445 9.0005
R4245 VSS.n696 VSS.n693 9.0005
R4246 VSS.n3369 VSS.n764 9.0005
R4247 VSS.n3371 VSS.n744 9.0005
R4248 VSS.n3373 VSS.n743 9.0005
R4249 VSS.n3375 VSS.n742 9.0005
R4250 VSS.t503 VSS.n732 9.0005
R4251 VSS.n3387 VSS.n731 9.0005
R4252 VSS.n3401 VSS.n723 9.0005
R4253 VSS.n3403 VSS.n722 9.0005
R4254 VSS.n3417 VSS.n3416 9.0005
R4255 VSS.n3419 VSS.n712 9.0005
R4256 VSS.n3438 VSS.n3437 9.0005
R4257 VSS.n3440 VSS.n3439 9.0005
R4258 VSS.t685 VSS.n635 9.0005
R4259 VSS.n642 VSS.n641 9.0005
R4260 VSS.n632 VSS.n631 9.0005
R4261 VSS.n646 VSS.n633 9.0005
R4262 VSS.n648 VSS.n647 9.0005
R4263 VSS.n650 VSS.n649 9.0005
R4264 VSS.n629 VSS.n628 9.0005
R4265 VSS.n655 VSS.n615 9.0005
R4266 VSS.n656 VSS.t713 9.0005
R4267 VSS.n657 VSS.t4 9.0005
R4268 VSS.n661 VSS.n660 9.0005
R4269 VSS.n659 VSS.n626 9.0005
R4270 VSS.n1261 VSS.n800 9.0005
R4271 VSS.n1263 VSS.n799 9.0005
R4272 VSS.n1264 VSS.n798 9.0005
R4273 VSS.n1266 VSS.n797 9.0005
R4274 VSS.n1267 VSS.n796 9.0005
R4275 VSS.t345 VSS.n795 9.0005
R4276 VSS.n794 VSS.n793 9.0005
R4277 VSS.n1251 VSS.t343 9.0005
R4278 VSS.n1250 VSS.n792 9.0005
R4279 VSS.n1249 VSS.n1248 9.0005
R4280 VSS.n1242 VSS.n802 9.0005
R4281 VSS.n1244 VSS.n1243 9.0005
R4282 VSS.n1241 VSS.n1240 9.0005
R4283 VSS.n1239 VSS.n1238 9.0005
R4284 VSS.n1232 VSS.n804 9.0005
R4285 VSS.n1234 VSS.n1233 9.0005
R4286 VSS.n1231 VSS.n1230 9.0005
R4287 VSS.n1229 VSS.n1228 9.0005
R4288 VSS.n1222 VSS.n806 9.0005
R4289 VSS.n1224 VSS.n1223 9.0005
R4290 VSS.n809 VSS.n808 9.0005
R4291 VSS.n1214 VSS.n1213 9.0005
R4292 VSS.n833 VSS.n834 9.0005
R4293 VSS.t346 VSS.n832 9.0005
R4294 VSS.n1208 VSS.n831 9.0005
R4295 VSS.n1207 VSS.n1206 9.0005
R4296 VSS.n1205 VSS.n1204 9.0005
R4297 VSS.n836 VSS.t155 9.0005
R4298 VSS.n1200 VSS.n816 9.0005
R4299 VSS.n1199 VSS.n1198 9.0005
R4300 VSS.n1197 VSS.t348 9.0005
R4301 VSS.n838 VSS.n827 9.0005
R4302 VSS.n1193 VSS.n1192 9.0005
R4303 VSS.n1191 VSS.t683 9.0005
R4304 VSS.n1190 VSS.n818 9.0005
R4305 VSS.n841 VSS.n840 9.0005
R4306 VSS.n1186 VSS.n1185 9.0005
R4307 VSS.t91 VSS.n1184 9.0005
R4308 VSS.n1183 VSS.n1182 9.0005
R4309 VSS.n1181 VSS.n843 9.0005
R4310 VSS.n1177 VSS.t12 9.0005
R4311 VSS.n1176 VSS.n845 9.0005
R4312 VSS.n1170 VSS.t717 9.0005
R4313 VSS.n1172 VSS.n1171 9.0005
R4314 VSS.n858 VSS.n857 9.0005
R4315 VSS.n1164 VSS.n1163 9.0005
R4316 VSS.n1162 VSS.n1161 9.0005
R4317 VSS.n1160 VSS.n1159 9.0005
R4318 VSS.n1158 VSS.n862 9.0005
R4319 VSS.n1154 VSS.n1153 9.0005
R4320 VSS.n1152 VSS.n1151 9.0005
R4321 VSS.n1150 VSS.n1149 9.0005
R4322 VSS.n1148 VSS.n864 9.0005
R4323 VSS.n1138 VSS.n866 9.0005
R4324 VSS.n1140 VSS.n1139 9.0005
R4325 VSS.n879 VSS.n880 9.0005
R4326 VSS.t159 VSS.n878 9.0005
R4327 VSS.n1131 VSS.n877 9.0005
R4328 VSS.n1130 VSS.t19 9.0005
R4329 VSS.n1129 VSS.n1128 9.0005
R4330 VSS.n1122 VSS.n882 9.0005
R4331 VSS.n1124 VSS.n1123 9.0005
R4332 VSS.n1121 VSS.t21 9.0005
R4333 VSS.n1120 VSS.n1119 9.0005
R4334 VSS.n885 VSS.n884 9.0005
R4335 VSS.n1110 VSS.n1109 9.0005
R4336 VSS.n888 VSS.n887 9.0005
R4337 VSS.n1101 VSS.n1100 9.0005
R4338 VSS.n891 VSS.n890 9.0005
R4339 VSS.n1092 VSS.n1091 9.0005
R4340 VSS.n894 VSS.n893 9.0005
R4341 VSS.n1083 VSS.n1082 9.0005
R4342 VSS.n897 VSS.n896 9.0005
R4343 VSS.n1074 VSS.n1073 9.0005
R4344 VSS.n900 VSS.n899 9.0005
R4345 VSS.n1066 VSS.n1065 9.0005
R4346 VSS.n903 VSS.n902 9.0005
R4347 VSS.n1057 VSS.n1056 9.0005
R4348 VSS.n906 VSS.n905 9.0005
R4349 VSS.n1049 VSS.n1048 9.0005
R4350 VSS.n909 VSS.n908 9.0005
R4351 VSS.n1040 VSS.n1039 9.0005
R4352 VSS.n912 VSS.n911 9.0005
R4353 VSS.n1031 VSS.n1030 9.0005
R4354 VSS.n915 VSS.n914 9.0005
R4355 VSS.n1022 VSS.n1021 9.0005
R4356 VSS.n918 VSS.n917 9.0005
R4357 VSS.n1013 VSS.n1012 9.0005
R4358 VSS.n920 VSS.t260 9.0005
R4359 VSS.n1004 VSS.n1003 9.0005
R4360 VSS.n923 VSS.n922 9.0005
R4361 VSS.n995 VSS.n994 9.0005
R4362 VSS.n926 VSS.n925 9.0005
R4363 VSS.n986 VSS.t262 9.0005
R4364 VSS.n929 VSS.n928 9.0005
R4365 VSS.n978 VSS.n977 9.0005
R4366 VSS.n932 VSS.n931 9.0005
R4367 VSS.n969 VSS.n968 9.0005
R4368 VSS.n935 VSS.n934 9.0005
R4369 VSS.n960 VSS.n959 9.0005
R4370 VSS.n938 VSS.n937 9.0005
R4371 VSS.n951 VSS.n950 9.0005
R4372 VSS.n941 VSS.n940 9.0005
R4373 VSS.n944 VSS.n943 9.0005
R4374 VSS.n949 VSS.n948 9.0005
R4375 VSS.n953 VSS.n952 9.0005
R4376 VSS.n958 VSS.n957 9.0005
R4377 VSS.n962 VSS.n961 9.0005
R4378 VSS.n967 VSS.n966 9.0005
R4379 VSS.n971 VSS.n970 9.0005
R4380 VSS.n976 VSS.n975 9.0005
R4381 VSS.n980 VSS.n979 9.0005
R4382 VSS.n985 VSS.n984 9.0005
R4383 VSS.n988 VSS.n987 9.0005
R4384 VSS.n993 VSS.n992 9.0005
R4385 VSS.n997 VSS.n996 9.0005
R4386 VSS.n1002 VSS.n1001 9.0005
R4387 VSS.n1006 VSS.n1005 9.0005
R4388 VSS.n1011 VSS.n1010 9.0005
R4389 VSS.n1015 VSS.n1014 9.0005
R4390 VSS.n1020 VSS.n1019 9.0005
R4391 VSS.n1024 VSS.n1023 9.0005
R4392 VSS.n1029 VSS.n1028 9.0005
R4393 VSS.n1033 VSS.n1032 9.0005
R4394 VSS.n1038 VSS.n1037 9.0005
R4395 VSS.n1042 VSS.n1041 9.0005
R4396 VSS.n1047 VSS.n1046 9.0005
R4397 VSS.n1050 VSS.t256 9.0005
R4398 VSS.n1055 VSS.n1054 9.0005
R4399 VSS.n1059 VSS.n1058 9.0005
R4400 VSS.n1064 VSS.n1063 9.0005
R4401 VSS.n1068 VSS.n1067 9.0005
R4402 VSS.n1072 VSS.t254 9.0005
R4403 VSS.n1076 VSS.n1075 9.0005
R4404 VSS.n1081 VSS.n1080 9.0005
R4405 VSS.n1085 VSS.n1084 9.0005
R4406 VSS.n1090 VSS.n1089 9.0005
R4407 VSS.n1094 VSS.n1093 9.0005
R4408 VSS.n1099 VSS.n1098 9.0005
R4409 VSS.n1103 VSS.n1102 9.0005
R4410 VSS.n1108 VSS.n1107 9.0005
R4411 VSS.n1112 VSS.n1111 9.0005
R4412 VSS.n1113 VSS.n1112 9.0005
R4413 VSS.n1110 VSS.n886 9.0005
R4414 VSS.n1108 VSS.n1106 9.0005
R4415 VSS.n1105 VSS.n888 9.0005
R4416 VSS.n1104 VSS.n1103 9.0005
R4417 VSS.n1101 VSS.n889 9.0005
R4418 VSS.n1099 VSS.n1097 9.0005
R4419 VSS.n1096 VSS.n891 9.0005
R4420 VSS.n1095 VSS.n1094 9.0005
R4421 VSS.n1092 VSS.n892 9.0005
R4422 VSS.n1090 VSS.n1088 9.0005
R4423 VSS.n1087 VSS.n894 9.0005
R4424 VSS.n1086 VSS.n1085 9.0005
R4425 VSS.n1083 VSS.n895 9.0005
R4426 VSS.n1081 VSS.n1079 9.0005
R4427 VSS.n1078 VSS.n897 9.0005
R4428 VSS.n1077 VSS.n1076 9.0005
R4429 VSS.n1074 VSS.n898 9.0005
R4430 VSS.n1072 VSS.n1071 9.0005
R4431 VSS.n1070 VSS.n900 9.0005
R4432 VSS.n1069 VSS.n1068 9.0005
R4433 VSS.n1066 VSS.n901 9.0005
R4434 VSS.n1064 VSS.n1062 9.0005
R4435 VSS.n1061 VSS.n903 9.0005
R4436 VSS.n1060 VSS.n1059 9.0005
R4437 VSS.n1057 VSS.n904 9.0005
R4438 VSS.n1055 VSS.n1053 9.0005
R4439 VSS.n1052 VSS.n906 9.0005
R4440 VSS.n1051 VSS.n1050 9.0005
R4441 VSS.n1049 VSS.n907 9.0005
R4442 VSS.n1047 VSS.n1045 9.0005
R4443 VSS.n1044 VSS.n909 9.0005
R4444 VSS.n1043 VSS.n1042 9.0005
R4445 VSS.n1040 VSS.n910 9.0005
R4446 VSS.n1038 VSS.n1036 9.0005
R4447 VSS.n1035 VSS.n912 9.0005
R4448 VSS.n1034 VSS.n1033 9.0005
R4449 VSS.n1031 VSS.n913 9.0005
R4450 VSS.n1029 VSS.n1027 9.0005
R4451 VSS.n1026 VSS.n915 9.0005
R4452 VSS.n1025 VSS.n1024 9.0005
R4453 VSS.n1022 VSS.n916 9.0005
R4454 VSS.n1020 VSS.n1018 9.0005
R4455 VSS.n1017 VSS.n918 9.0005
R4456 VSS.n1016 VSS.n1015 9.0005
R4457 VSS.n1013 VSS.n919 9.0005
R4458 VSS.n1011 VSS.n1009 9.0005
R4459 VSS.n1008 VSS.n920 9.0005
R4460 VSS.n1007 VSS.n1006 9.0005
R4461 VSS.n1004 VSS.n921 9.0005
R4462 VSS.n1002 VSS.n1000 9.0005
R4463 VSS.n999 VSS.n923 9.0005
R4464 VSS.n998 VSS.n997 9.0005
R4465 VSS.n995 VSS.n924 9.0005
R4466 VSS.n993 VSS.n991 9.0005
R4467 VSS.n990 VSS.n926 9.0005
R4468 VSS.n989 VSS.n988 9.0005
R4469 VSS.n986 VSS.n927 9.0005
R4470 VSS.n985 VSS.n983 9.0005
R4471 VSS.n982 VSS.n929 9.0005
R4472 VSS.n981 VSS.n980 9.0005
R4473 VSS.n978 VSS.n930 9.0005
R4474 VSS.n976 VSS.n974 9.0005
R4475 VSS.n973 VSS.n932 9.0005
R4476 VSS.n972 VSS.n971 9.0005
R4477 VSS.n969 VSS.n933 9.0005
R4478 VSS.n967 VSS.n965 9.0005
R4479 VSS.n964 VSS.n935 9.0005
R4480 VSS.n963 VSS.n962 9.0005
R4481 VSS.n960 VSS.n936 9.0005
R4482 VSS.n958 VSS.n956 9.0005
R4483 VSS.n955 VSS.n938 9.0005
R4484 VSS.n954 VSS.n953 9.0005
R4485 VSS.n951 VSS.n939 9.0005
R4486 VSS.n949 VSS.n947 9.0005
R4487 VSS.n946 VSS.n941 9.0005
R4488 VSS.n1165 VSS.n1164 9.0005
R4489 VSS.n1161 VSS.n861 9.0005
R4490 VSS.n1160 VSS.n1157 9.0005
R4491 VSS.n1156 VSS.n862 9.0005
R4492 VSS.n1155 VSS.n1154 9.0005
R4493 VSS.n1151 VSS.n863 9.0005
R4494 VSS.n1150 VSS.n865 9.0005
R4495 VSS.n1136 VSS.n864 9.0005
R4496 VSS.n1138 VSS.n1137 9.0005
R4497 VSS.n1139 VSS.n1135 9.0005
R4498 VSS.n1134 VSS.n880 9.0005
R4499 VSS.n1133 VSS.n878 9.0005
R4500 VSS.n1132 VSS.n1131 9.0005
R4501 VSS.n1130 VSS.n881 9.0005
R4502 VSS.n1128 VSS.n1127 9.0005
R4503 VSS.n1126 VSS.n882 9.0005
R4504 VSS.n1125 VSS.n1124 9.0005
R4505 VSS.n1121 VSS.n883 9.0005
R4506 VSS.n607 VSS.n216 9.0005
R4507 VSS.n3482 VSS.n216 9.0005
R4508 VSS.n3486 VSS.n3485 9.0005
R4509 VSS.n3485 VSS.n3484 9.0005
R4510 VSS.n3263 VSS.n3262 9.0005
R4511 VSS.n3334 VSS.n107 9.0005
R4512 VSS.n3332 VSS.n3331 9.0005
R4513 VSS.n3330 VSS.n3242 9.0005
R4514 VSS.n3329 VSS.n3240 9.0005
R4515 VSS.n3328 VSS.n3238 9.0005
R4516 VSS.n3327 VSS.n3235 9.0005
R4517 VSS.n3326 VSS.n3234 9.0005
R4518 VSS.n3319 VSS.n3221 9.0005
R4519 VSS.n3318 VSS.n3219 9.0005
R4520 VSS.n3311 VSS.n3310 9.0005
R4521 VSS.n3309 VSS.n3243 9.0005
R4522 VSS.n3294 VSS.n3293 9.0005
R4523 VSS.n3291 VSS.n3249 9.0005
R4524 VSS.n3274 VSS.n3273 9.0005
R4525 VSS.n3271 VSS.n3256 9.0005
R4526 VSS.n3269 VSS.n3266 9.0005
R4527 VSS.n3265 VSS.n3257 9.0005
R4528 VSS.n3289 VSS.n3286 9.0005
R4529 VSS.n3285 VSS.n3251 9.0005
R4530 VSS.n3284 VSS.n3283 9.0005
R4531 VSS.n3281 VSS.n3252 9.0005
R4532 VSS.n3279 VSS.n3276 9.0005
R4533 VSS.n3275 VSS.n3255 9.0005
R4534 VSS.n3307 VSS.n3305 9.0005
R4535 VSS.n3304 VSS.n3245 9.0005
R4536 VSS.n3303 VSS.n3302 9.0005
R4537 VSS.n3300 VSS.n3246 9.0005
R4538 VSS.n3298 VSS.n3296 9.0005
R4539 VSS.n3295 VSS.n3248 9.0005
R4540 VSS.n3317 VSS.n3218 9.0005
R4541 VSS.n3316 VSS.n3216 9.0005
R4542 VSS.n3315 VSS.n3215 9.0005
R4543 VSS.n3314 VSS.n3213 9.0005
R4544 VSS.n3313 VSS.n3211 9.0005
R4545 VSS.n3312 VSS.n3210 9.0005
R4546 VSS.n3325 VSS.n3232 9.0005
R4547 VSS.n3324 VSS.n3231 9.0005
R4548 VSS.n3323 VSS.n3228 9.0005
R4549 VSS.n3322 VSS.n3226 9.0005
R4550 VSS.n3321 VSS.n3225 9.0005
R4551 VSS.n3320 VSS.n3224 9.0005
R4552 VSS.n653 VSS.n629 9.0005
R4553 VSS.n655 VSS.n654 9.0005
R4554 VSS.n656 VSS.n627 9.0005
R4555 VSS.n658 VSS.n657 9.0005
R4556 VSS.n643 VSS.n642 9.0005
R4557 VSS.n644 VSS.n631 9.0005
R4558 VSS.n651 VSS.n650 9.0005
R4559 VSS.n647 VSS.n630 9.0005
R4560 VSS.n646 VSS.n645 9.0005
R4561 VSS.n662 VSS.n661 9.0005
R4562 VSS.n3818 VSS.n3817 9.0005
R4563 VSS.n3816 VSS.n121 9.0005
R4564 VSS.n3815 VSS.n3814 9.0005
R4565 VSS.n123 VSS.n122 9.0005
R4566 VSS.n3785 VSS.n3784 9.0005
R4567 VSS.n3783 VSS.n198 9.0005
R4568 VSS.n3782 VSS.n196 9.0005
R4569 VSS.n3775 VSS.n189 9.0005
R4570 VSS.n3774 VSS.n3773 9.0005
R4571 VSS.n3758 VSS.n205 9.0005
R4572 VSS.n3757 VSS.n3756 9.0005
R4573 VSS.n3740 VSS.n211 9.0005
R4574 VSS.n3739 VSS.n3738 9.0005
R4575 VSS.n3736 VSS.n212 9.0005
R4576 VSS.n3734 VSS.n3732 9.0005
R4577 VSS.n3731 VSS.n214 9.0005
R4578 VSS.n3730 VSS.n3729 9.0005
R4579 VSS.n3754 VSS.n206 9.0005
R4580 VSS.n3752 VSS.n3750 9.0005
R4581 VSS.n3749 VSS.n208 9.0005
R4582 VSS.n3748 VSS.n3747 9.0005
R4583 VSS.n3745 VSS.n209 9.0005
R4584 VSS.n3743 VSS.n3741 9.0005
R4585 VSS.n3772 VSS.n200 9.0005
R4586 VSS.n3770 VSS.n3768 9.0005
R4587 VSS.n3767 VSS.n202 9.0005
R4588 VSS.n3766 VSS.n3765 9.0005
R4589 VSS.n3763 VSS.n203 9.0005
R4590 VSS.n3761 VSS.n3759 9.0005
R4591 VSS.n3781 VSS.n195 9.0005
R4592 VSS.n3780 VSS.n194 9.0005
R4593 VSS.n3779 VSS.n193 9.0005
R4594 VSS.n3778 VSS.n192 9.0005
R4595 VSS.n3777 VSS.n191 9.0005
R4596 VSS.n3776 VSS.n190 9.0005
R4597 VSS.n3852 VSS.n3851 9.0005
R4598 VSS.n3850 VSS.n110 9.0005
R4599 VSS.n3841 VSS.n111 9.0005
R4600 VSS.n3843 VSS.n3842 9.0005
R4601 VSS.n3840 VSS.n113 9.0005
R4602 VSS.n3839 VSS.n3838 9.0005
R4603 VSS.n115 VSS.n114 9.0005
R4604 VSS.n3830 VSS.n3829 9.0005
R4605 VSS.n3828 VSS.n117 9.0005
R4606 VSS.n3827 VSS.n3826 9.0005
R4607 VSS.n119 VSS.n118 9.0005
R4608 VSS.n1258 VSS.n799 9.0005
R4609 VSS.n1257 VSS.n798 9.0005
R4610 VSS.n1256 VSS.n797 9.0005
R4611 VSS.n1255 VSS.n796 9.0005
R4612 VSS.n1254 VSS.n795 9.0005
R4613 VSS.n1253 VSS.n793 9.0005
R4614 VSS.n1252 VSS.n1251 9.0005
R4615 VSS.n1250 VSS.n801 9.0005
R4616 VSS.n1249 VSS.n1247 9.0005
R4617 VSS.n1246 VSS.n802 9.0005
R4618 VSS.n1245 VSS.n1244 9.0005
R4619 VSS.n1241 VSS.n803 9.0005
R4620 VSS.n1238 VSS.n1237 9.0005
R4621 VSS.n1236 VSS.n804 9.0005
R4622 VSS.n1235 VSS.n1234 9.0005
R4623 VSS.n1231 VSS.n805 9.0005
R4624 VSS.n1228 VSS.n1227 9.0005
R4625 VSS.n1226 VSS.n806 9.0005
R4626 VSS.n1225 VSS.n1224 9.0005
R4627 VSS.n808 VSS.n807 9.0005
R4628 VSS.n1213 VSS.n1212 9.0005
R4629 VSS.n1211 VSS.n834 9.0005
R4630 VSS.n1210 VSS.n832 9.0005
R4631 VSS.n1209 VSS.n1208 9.0005
R4632 VSS.n1207 VSS.n835 9.0005
R4633 VSS.n1204 VSS.n1203 9.0005
R4634 VSS.n1202 VSS.n836 9.0005
R4635 VSS.n1201 VSS.n1200 9.0005
R4636 VSS.n1199 VSS.n837 9.0005
R4637 VSS.n1197 VSS.n1196 9.0005
R4638 VSS.n1195 VSS.n838 9.0005
R4639 VSS.n1194 VSS.n1193 9.0005
R4640 VSS.n1191 VSS.n839 9.0005
R4641 VSS.n1190 VSS.n1189 9.0005
R4642 VSS.n1188 VSS.n841 9.0005
R4643 VSS.n1187 VSS.n1186 9.0005
R4644 VSS.n1184 VSS.n842 9.0005
R4645 VSS.n1183 VSS.n1180 9.0005
R4646 VSS.n1179 VSS.n843 9.0005
R4647 VSS.n1178 VSS.n1177 9.0005
R4648 VSS.n845 VSS.n844 9.0005
R4649 VSS.n1170 VSS.n1169 9.0005
R4650 VSS.n1171 VSS.n1168 9.0005
R4651 VSS.n1167 VSS.n858 9.0005
R4652 VSS.n3409 VSS.n3408 9.0005
R4653 VSS.n720 VSS.n718 9.0005
R4654 VSS.n3415 VSS.n717 9.0005
R4655 VSS.n3416 VSS.n716 9.0005
R4656 VSS.n715 VSS.n712 9.0005
R4657 VSS.n3438 VSS.n701 9.0005
R4658 VSS.n3439 VSS.n700 9.0005
R4659 VSS.n695 VSS.n694 9.0005
R4660 VSS.n3447 VSS.n3446 9.0005
R4661 VSS.n3422 VSS.n711 9.0005
R4662 VSS.n3423 VSS.n710 9.0005
R4663 VSS.n709 VSS.n707 9.0005
R4664 VSS.n3429 VSS.n706 9.0005
R4665 VSS.n3430 VSS.n705 9.0005
R4666 VSS.n704 VSS.n702 9.0005
R4667 VSS.n762 VSS.n743 9.0005
R4668 VSS.n761 VSS.n742 9.0005
R4669 VSS.n760 VSS.n741 9.0005
R4670 VSS.n759 VSS.n740 9.0005
R4671 VSS.n758 VSS.n738 9.0005
R4672 VSS.n757 VSS.n737 9.0005
R4673 VSS.n756 VSS.n755 9.0005
R4674 VSS.n753 VSS.n732 9.0005
R4675 VSS.n752 VSS.n731 9.0005
R4676 VSS.n745 VSS.n723 9.0005
R4677 VSS.n722 VSS.n721 9.0005
R4678 VSS.n3407 VSS.n3406 9.0005
R4679 VSS.n751 VSS.n730 9.0005
R4680 VSS.n750 VSS.n729 9.0005
R4681 VSS.n749 VSS.n728 9.0005
R4682 VSS.n748 VSS.n727 9.0005
R4683 VSS.n747 VSS.n726 9.0005
R4684 VSS.n746 VSS.n725 9.0005
R4685 VSS.n775 VSS.n773 9.0005
R4686 VSS.n774 VSS.n769 9.0005
R4687 VSS.n2580 VSS.n2579 9.0005
R4688 VSS.n2585 VSS.n2127 9.0005
R4689 VSS.n2136 VSS.n2134 9.0005
R4690 VSS.n2584 VSS.n2133 9.0005
R4691 VSS.n2545 VSS.n2542 9.0005
R4692 VSS.n2546 VSS.n2541 9.0005
R4693 VSS.n2540 VSS.n2537 9.0005
R4694 VSS.n2549 VSS.n2536 9.0005
R4695 VSS.n2550 VSS.n2535 9.0005
R4696 VSS.n2534 VSS.n2531 9.0005
R4697 VSS.n2554 VSS.n2530 9.0005
R4698 VSS.n2555 VSS.n2529 9.0005
R4699 VSS.n2528 VSS.n2525 9.0005
R4700 VSS.n2558 VSS.n2524 9.0005
R4701 VSS.n2559 VSS.n2523 9.0005
R4702 VSS.n2522 VSS.n2519 9.0005
R4703 VSS.n2563 VSS.n2518 9.0005
R4704 VSS.n2564 VSS.n2517 9.0005
R4705 VSS.n2146 VSS.n2145 9.0005
R4706 VSS.n2567 VSS.n2566 9.0005
R4707 VSS.n2568 VSS.n2143 9.0005
R4708 VSS.n2570 VSS.n2569 9.0005
R4709 VSS.n2144 VSS.n2139 9.0005
R4710 VSS.n2576 VSS.n2137 9.0005
R4711 VSS.n2578 VSS.n2577 9.0005
R4712 VSS.n2589 VSS.n2588 9.0005
R4713 VSS.n2593 VSS.n2118 9.0005
R4714 VSS.n2590 VSS.n2126 9.0005
R4715 VSS.n2592 VSS.n2591 9.0005
R4716 VSS.n2595 VSS.n2594 9.0005
R4717 VSS.n2599 VSS.n2111 9.0005
R4718 VSS.n2596 VSS.n2117 9.0005
R4719 VSS.n2598 VSS.n2597 9.0005
R4720 VSS.n2603 VSS.n2602 9.0005
R4721 VSS.n2607 VSS.n2102 9.0005
R4722 VSS.n2604 VSS.n2110 9.0005
R4723 VSS.n2606 VSS.n2605 9.0005
R4724 VSS.n2609 VSS.n2608 9.0005
R4725 VSS.n2613 VSS.n2095 9.0005
R4726 VSS.n2610 VSS.n2101 9.0005
R4727 VSS.n2612 VSS.n2611 9.0005
R4728 VSS.n2617 VSS.n2616 9.0005
R4729 VSS.n2621 VSS.n2086 9.0005
R4730 VSS.n2618 VSS.n2094 9.0005
R4731 VSS.n2620 VSS.n2619 9.0005
R4732 VSS.n2623 VSS.n2622 9.0005
R4733 VSS.n2627 VSS.n2079 9.0005
R4734 VSS.n2624 VSS.n2085 9.0005
R4735 VSS.n2626 VSS.n2625 9.0005
R4736 VSS.n2631 VSS.n2630 9.0005
R4737 VSS.n2635 VSS.n2070 9.0005
R4738 VSS.n2632 VSS.n2078 9.0005
R4739 VSS.n2634 VSS.n2633 9.0005
R4740 VSS.n2637 VSS.n2636 9.0005
R4741 VSS.n2641 VSS.n2063 9.0005
R4742 VSS.n2638 VSS.n2069 9.0005
R4743 VSS.n2640 VSS.n2639 9.0005
R4744 VSS.n2645 VSS.n2644 9.0005
R4745 VSS.n2649 VSS.n2054 9.0005
R4746 VSS.n2646 VSS.n2062 9.0005
R4747 VSS.n2648 VSS.n2647 9.0005
R4748 VSS.n2651 VSS.n2650 9.0005
R4749 VSS.n2655 VSS.n2047 9.0005
R4750 VSS.n2652 VSS.n2053 9.0005
R4751 VSS.n2654 VSS.n2653 9.0005
R4752 VSS.n2659 VSS.n2658 9.0005
R4753 VSS.n2663 VSS.n2038 9.0005
R4754 VSS.n2660 VSS.n2046 9.0005
R4755 VSS.n2662 VSS.n2661 9.0005
R4756 VSS.n2665 VSS.n2664 9.0005
R4757 VSS.n2669 VSS.n2031 9.0005
R4758 VSS.n2666 VSS.n2037 9.0005
R4759 VSS.n2668 VSS.n2667 9.0005
R4760 VSS.n2673 VSS.n2672 9.0005
R4761 VSS.n2677 VSS.n2022 9.0005
R4762 VSS.n2674 VSS.n2030 9.0005
R4763 VSS.n2676 VSS.n2675 9.0005
R4764 VSS.n2679 VSS.n2678 9.0005
R4765 VSS.n2683 VSS.n2015 9.0005
R4766 VSS.n2680 VSS.n2021 9.0005
R4767 VSS.n2682 VSS.n2681 9.0005
R4768 VSS.n2687 VSS.n2686 9.0005
R4769 VSS.n2691 VSS.n2006 9.0005
R4770 VSS.n2688 VSS.n2014 9.0005
R4771 VSS.n2690 VSS.n2689 9.0005
R4772 VSS.n2693 VSS.n2692 9.0005
R4773 VSS.n2697 VSS.n1999 9.0005
R4774 VSS.n2694 VSS.n2005 9.0005
R4775 VSS.n2696 VSS.n2695 9.0005
R4776 VSS.n2701 VSS.n2700 9.0005
R4777 VSS.n2705 VSS.n1990 9.0005
R4778 VSS.n2702 VSS.n1998 9.0005
R4779 VSS.n2704 VSS.n2703 9.0005
R4780 VSS.n2707 VSS.n2706 9.0005
R4781 VSS.n2711 VSS.n1983 9.0005
R4782 VSS.n2708 VSS.n1989 9.0005
R4783 VSS.n2710 VSS.n2709 9.0005
R4784 VSS.n2715 VSS.n2714 9.0005
R4785 VSS.n2719 VSS.n1974 9.0005
R4786 VSS.n2716 VSS.n1982 9.0005
R4787 VSS.n2718 VSS.n2717 9.0005
R4788 VSS.n2721 VSS.n2720 9.0005
R4789 VSS.n2725 VSS.n1967 9.0005
R4790 VSS.n2722 VSS.n1973 9.0005
R4791 VSS.n2724 VSS.n2723 9.0005
R4792 VSS.n2729 VSS.n2728 9.0005
R4793 VSS.n2733 VSS.n1958 9.0005
R4794 VSS.n2730 VSS.n1966 9.0005
R4795 VSS.n2732 VSS.n2731 9.0005
R4796 VSS.n2735 VSS.n2734 9.0005
R4797 VSS.n2739 VSS.n1951 9.0005
R4798 VSS.n2736 VSS.n1957 9.0005
R4799 VSS.n2738 VSS.n2737 9.0005
R4800 VSS.n2743 VSS.n2742 9.0005
R4801 VSS.n2747 VSS.n1942 9.0005
R4802 VSS.n2744 VSS.n1950 9.0005
R4803 VSS.n2746 VSS.n2745 9.0005
R4804 VSS.n2749 VSS.n2748 9.0005
R4805 VSS.n2753 VSS.n1935 9.0005
R4806 VSS.n2750 VSS.n1941 9.0005
R4807 VSS.n2752 VSS.n2751 9.0005
R4808 VSS.n2757 VSS.n2756 9.0005
R4809 VSS.n2761 VSS.n1926 9.0005
R4810 VSS.n2758 VSS.n1934 9.0005
R4811 VSS.n2760 VSS.n2759 9.0005
R4812 VSS.n2763 VSS.n2762 9.0005
R4813 VSS.n2767 VSS.n1919 9.0005
R4814 VSS.n2764 VSS.n1925 9.0005
R4815 VSS.n2766 VSS.n2765 9.0005
R4816 VSS.n2771 VSS.n2770 9.0005
R4817 VSS.n2775 VSS.n1910 9.0005
R4818 VSS.n2772 VSS.n1918 9.0005
R4819 VSS.n2774 VSS.n2773 9.0005
R4820 VSS.n2777 VSS.n2776 9.0005
R4821 VSS.n2781 VSS.n1903 9.0005
R4822 VSS.n2778 VSS.n1909 9.0005
R4823 VSS.n2780 VSS.n2779 9.0005
R4824 VSS.n2785 VSS.n2784 9.0005
R4825 VSS.n2789 VSS.n1901 9.0005
R4826 VSS.n2786 VSS.n1902 9.0005
R4827 VSS.n2788 VSS.n2787 9.0005
R4828 VSS.n2790 VSS.n1896 9.0005
R4829 VSS.n2797 VSS.n2796 9.0005
R4830 VSS.n2791 VSS.n1895 9.0005
R4831 VSS.n1892 VSS.n1891 9.0005
R4832 VSS.n2220 VSS.n2219 9.0005
R4833 VSS.n2508 VSS.n2507 9.0005
R4834 VSS.n2506 VSS.n2148 9.0005
R4835 VSS.n2505 VSS.n2504 9.0005
R4836 VSS.n2150 VSS.n2149 9.0005
R4837 VSS.n2492 VSS.n2491 9.0005
R4838 VSS.n2490 VSS.n2489 9.0005
R4839 VSS.n2153 VSS.n2152 9.0005
R4840 VSS.n2483 VSS.n2482 9.0005
R4841 VSS.n2481 VSS.n2480 9.0005
R4842 VSS.n2155 VSS.n2154 9.0005
R4843 VSS.n2474 VSS.n2473 9.0005
R4844 VSS.n2472 VSS.n2471 9.0005
R4845 VSS.n2157 VSS.n2156 9.0005
R4846 VSS.n2465 VSS.n2464 9.0005
R4847 VSS.n2463 VSS.n2462 9.0005
R4848 VSS.n2159 VSS.n2158 9.0005
R4849 VSS.n2456 VSS.n2455 9.0005
R4850 VSS.n2454 VSS.n2453 9.0005
R4851 VSS.n2161 VSS.n2160 9.0005
R4852 VSS.n2447 VSS.n2446 9.0005
R4853 VSS.n2445 VSS.n2444 9.0005
R4854 VSS.n2163 VSS.n2162 9.0005
R4855 VSS.n2438 VSS.n2437 9.0005
R4856 VSS.n2436 VSS.n2435 9.0005
R4857 VSS.n2165 VSS.n2164 9.0005
R4858 VSS.n2429 VSS.n2428 9.0005
R4859 VSS.n2427 VSS.n2426 9.0005
R4860 VSS.n2167 VSS.n2166 9.0005
R4861 VSS.n2420 VSS.n2419 9.0005
R4862 VSS.n2418 VSS.n2417 9.0005
R4863 VSS.n2169 VSS.n2168 9.0005
R4864 VSS.n2411 VSS.n2410 9.0005
R4865 VSS.n2409 VSS.n2408 9.0005
R4866 VSS.n2171 VSS.n2170 9.0005
R4867 VSS.n2402 VSS.n2401 9.0005
R4868 VSS.n2400 VSS.n2399 9.0005
R4869 VSS.n2173 VSS.n2172 9.0005
R4870 VSS.n2393 VSS.n2392 9.0005
R4871 VSS.n2391 VSS.n2390 9.0005
R4872 VSS.n2175 VSS.n2174 9.0005
R4873 VSS.n2384 VSS.n2383 9.0005
R4874 VSS.n2382 VSS.n2381 9.0005
R4875 VSS.n2177 VSS.n2176 9.0005
R4876 VSS.n2375 VSS.n2374 9.0005
R4877 VSS.n2373 VSS.n2372 9.0005
R4878 VSS.n2179 VSS.n2178 9.0005
R4879 VSS.n2366 VSS.n2365 9.0005
R4880 VSS.n2364 VSS.n2363 9.0005
R4881 VSS.n2181 VSS.n2180 9.0005
R4882 VSS.n2357 VSS.n2356 9.0005
R4883 VSS.n2355 VSS.n2354 9.0005
R4884 VSS.n2183 VSS.n2182 9.0005
R4885 VSS.n2348 VSS.n2347 9.0005
R4886 VSS.n2346 VSS.n2345 9.0005
R4887 VSS.n2185 VSS.n2184 9.0005
R4888 VSS.n2339 VSS.n2338 9.0005
R4889 VSS.n2337 VSS.n2336 9.0005
R4890 VSS.n2187 VSS.n2186 9.0005
R4891 VSS.n2330 VSS.n2329 9.0005
R4892 VSS.n2328 VSS.n2327 9.0005
R4893 VSS.n2189 VSS.n2188 9.0005
R4894 VSS.n2321 VSS.n2320 9.0005
R4895 VSS.n2319 VSS.n2318 9.0005
R4896 VSS.n2191 VSS.n2190 9.0005
R4897 VSS.n2312 VSS.n2311 9.0005
R4898 VSS.n2310 VSS.n2309 9.0005
R4899 VSS.n2193 VSS.n2192 9.0005
R4900 VSS.n2303 VSS.n2302 9.0005
R4901 VSS.n2301 VSS.n2300 9.0005
R4902 VSS.n2195 VSS.n2194 9.0005
R4903 VSS.n2294 VSS.n2293 9.0005
R4904 VSS.n2292 VSS.n2291 9.0005
R4905 VSS.n2197 VSS.n2196 9.0005
R4906 VSS.n2285 VSS.n2284 9.0005
R4907 VSS.n2283 VSS.n2282 9.0005
R4908 VSS.n2199 VSS.n2198 9.0005
R4909 VSS.n2276 VSS.n2275 9.0005
R4910 VSS.n2274 VSS.n2273 9.0005
R4911 VSS.n2201 VSS.n2200 9.0005
R4912 VSS.n2267 VSS.n2266 9.0005
R4913 VSS.n2265 VSS.n2264 9.0005
R4914 VSS.n2203 VSS.n2202 9.0005
R4915 VSS.n2258 VSS.n2257 9.0005
R4916 VSS.n2256 VSS.n2255 9.0005
R4917 VSS.n2205 VSS.n2204 9.0005
R4918 VSS.n2249 VSS.n2248 9.0005
R4919 VSS.n2247 VSS.n2246 9.0005
R4920 VSS.n2207 VSS.n2206 9.0005
R4921 VSS.n2240 VSS.n2239 9.0005
R4922 VSS.n2238 VSS.n2237 9.0005
R4923 VSS.n2209 VSS.n2208 9.0005
R4924 VSS.n2231 VSS.n2230 9.0005
R4925 VSS.n2229 VSS.n2228 9.0005
R4926 VSS.n2211 VSS.n2210 9.0005
R4927 VSS.n2222 VSS.n2221 9.0005
R4928 VSS.n3179 VSS.t529 8.501
R4929 VSS.t532 VSS.n1283 8.501
R4930 VSS.t534 VSS.n1338 8.501
R4931 VSS.t539 VSS.n1343 8.501
R4932 VSS.t544 VSS.n1359 8.501
R4933 VSS.n3047 VSS.t547 8.501
R4934 VSS.t549 VSS.n3039 8.501
R4935 VSS.t554 VSS.n1382 8.501
R4936 VSS.t559 VSS.n1398 8.501
R4937 VSS.n3000 VSS.t562 8.501
R4938 VSS.t564 VSS.n2992 8.501
R4939 VSS.t569 VSS.n1421 8.501
R4940 VSS.t574 VSS.n1458 8.501
R4941 VSS.n2914 VSS.t577 8.501
R4942 VSS.t579 VSS.n2906 8.501
R4943 VSS.t584 VSS.n1505 8.501
R4944 VSS.t589 VSS.n1521 8.501
R4945 VSS.n2867 VSS.t592 8.501
R4946 VSS.t594 VSS.n2859 8.501
R4947 VSS.t599 VSS.n1544 8.501
R4948 VSS.t604 VSS.n1560 8.501
R4949 VSS.n2820 VSS.t607 8.501
R4950 VSS.t609 VSS.n2812 8.501
R4951 VSS.t615 VSS.n1583 8.501
R4952 VSS.n3808 VSS.n26 2.4296
R4953 VSS.n3808 VSS.n31 1.00026
R4954 VSS.n31 VSS.n30 0.00172818
R4955 VSS.n30 VSS.n32 0.00172217
R4956 VSS.n32 VSS.n33 0.00171266
R4957 VSS.n33 VSS.n34 0.00169658
R4958 VSS.n34 VSS.n35 0.00166646
R4959 VSS.n35 VSS.n36 0.00159992
R4960 VSS.n3385 VSS.n39 3.40102
R4961 VSS.n42 VSS.n41 0.00216959
R4962 VSS.n41 VSS.n43 0.00170812
R4963 VSS.n43 VSS.n44 0.00166658
R4964 VSS.n44 VSS.n45 0.00149997
R4965 VSS.n3385 VSS.n46 3.40102
R4966 VSS.n50 VSS.n3385 1.88989
R4967 VSS.n3385 VSS.n56 2.4296
R4968 VSS.n7 VSS.n3359 2.12569
R4969 VSS.n7 VSS.n4 0.00170812
R4970 VSS.n4 VSS.n8 0.00166658
R4971 VSS.n8 VSS.n9 0.00149997
R4972 VSS.n3359 VSS.n10 2.42956
R4973 VSS.n3359 VSS.n13 3.40102
R4974 VSS.n3359 VSS.n15 2.42956
R4975 VSS.n3359 VSS.n18 2.42956
R4976 VSS.n3359 VSS.n21 3.40102
R4977 VSS.n3359 VSS.n23 3.40102
R4978 VSS.n1218 VSS.n788 8.501
R4979 VSS.n1219 VSS.n1218 8.501
R4980 VSS.n1144 VSS.n853 8.501
R4981 VSS.n1145 VSS.n1144 8.501
R4982 VSS.n96 VSS.n95 0.98631
R4983 VSS.n95 VSS.n97 0.00166658
R4984 VSS.n97 VSS.n98 0.00149997
R4985 VSS.n3499 VSS.n99 3.40102
R4986 VSS.n3499 VSS.n101 1.88989
R4987 VSS.n74 VSS.n3501 2.83428
R4988 VSS.n74 VSS.n73 0.00158329
R4989 VSS.n3501 VSS.n77 2.42956
R4990 VSS.n3501 VSS.n80 1.88985
R4991 VSS.n82 VSS.n83 0.00149997
R4992 VSS.n3501 VSS.n85 1.70056
R4993 VSS.n85 VSS.n84 0.00172462
R4994 VSS.n84 VSS.n86 0.00170812
R4995 VSS.n86 VSS.n87 0.00166658
R4996 VSS.n87 VSS.n88 0.00149997
R4997 VSS.n3501 VSS.n89 1.88989
R4998 VSS.n2 VSS.n1 0.0161289
R4999 VSS.n1612 VSS.n1277 8.5005
R5000 VSS.n1615 VSS.n1277 8.5005
R5001 VSS.n1616 VSS.n1277 8.5005
R5002 VSS.n1618 VSS.n1277 8.5005
R5003 VSS.n1621 VSS.n1277 8.5005
R5004 VSS.n1622 VSS.n1277 8.5005
R5005 VSS.n1623 VSS.n1277 8.5005
R5006 VSS.n1624 VSS.n1277 8.5005
R5007 VSS.n1625 VSS.n1277 8.5005
R5008 VSS.n1626 VSS.n1277 8.5005
R5009 VSS.n1629 VSS.n1277 8.5005
R5010 VSS.n1630 VSS.n1277 8.5005
R5011 VSS.n1632 VSS.n1277 8.5005
R5012 VSS.n1635 VSS.n1277 8.5005
R5013 VSS.n1636 VSS.n1277 8.5005
R5014 VSS.n1637 VSS.n1277 8.5005
R5015 VSS.n1638 VSS.n1277 8.5005
R5016 VSS.n1639 VSS.n1277 8.5005
R5017 VSS.n1640 VSS.n1277 8.5005
R5018 VSS.n1643 VSS.n1277 8.5005
R5019 VSS.n1644 VSS.n1277 8.5005
R5020 VSS.n1646 VSS.n1277 8.5005
R5021 VSS.n1649 VSS.n1277 8.5005
R5022 VSS.n1650 VSS.n1277 8.5005
R5023 VSS.n1651 VSS.n1277 8.5005
R5024 VSS.n1652 VSS.n1277 8.5005
R5025 VSS.n1653 VSS.n1277 8.5005
R5026 VSS.n1654 VSS.n1277 8.5005
R5027 VSS.n1657 VSS.n1277 8.5005
R5028 VSS.n1658 VSS.n1277 8.5005
R5029 VSS.n1660 VSS.n1277 8.5005
R5030 VSS.n1663 VSS.n1277 8.5005
R5031 VSS.n1664 VSS.n1277 8.5005
R5032 VSS.n1665 VSS.n1277 8.5005
R5033 VSS.n1666 VSS.n1277 8.5005
R5034 VSS.n1667 VSS.n1277 8.5005
R5035 VSS.n1668 VSS.n1277 8.5005
R5036 VSS.n1671 VSS.n1277 8.5005
R5037 VSS.n1672 VSS.n1277 8.5005
R5038 VSS.n1674 VSS.n1277 8.5005
R5039 VSS.n1677 VSS.n1277 8.5005
R5040 VSS.n1678 VSS.n1277 8.5005
R5041 VSS.n1679 VSS.n1277 8.5005
R5042 VSS.n1680 VSS.n1277 8.5005
R5043 VSS.n1681 VSS.n1277 8.5005
R5044 VSS.n1682 VSS.n1277 8.5005
R5045 VSS.n1685 VSS.n1277 8.5005
R5046 VSS.n1686 VSS.n1277 8.5005
R5047 VSS.n1688 VSS.n1277 8.5005
R5048 VSS.n1691 VSS.n1277 8.5005
R5049 VSS.n1692 VSS.n1277 8.5005
R5050 VSS.n1693 VSS.n1277 8.5005
R5051 VSS.n1694 VSS.n1277 8.5005
R5052 VSS.n1695 VSS.n1277 8.5005
R5053 VSS.n1696 VSS.n1277 8.5005
R5054 VSS.n1699 VSS.n1277 8.5005
R5055 VSS.n1700 VSS.n1277 8.5005
R5056 VSS.n1702 VSS.n1277 8.5005
R5057 VSS.n1705 VSS.n1277 8.5005
R5058 VSS.n1706 VSS.n1277 8.5005
R5059 VSS.n1707 VSS.n1277 8.5005
R5060 VSS.n1708 VSS.n1277 8.5005
R5061 VSS.n1709 VSS.n1277 8.5005
R5062 VSS.n1710 VSS.n1277 8.5005
R5063 VSS.n1713 VSS.n1277 8.5005
R5064 VSS.n1714 VSS.n1277 8.5005
R5065 VSS.n1716 VSS.n1277 8.5005
R5066 VSS.n1719 VSS.n1277 8.5005
R5067 VSS.n1720 VSS.n1277 8.5005
R5068 VSS.n1721 VSS.n1277 8.5005
R5069 VSS.n1722 VSS.n1277 8.5005
R5070 VSS.n1723 VSS.n1277 8.5005
R5071 VSS.n1724 VSS.n1277 8.5005
R5072 VSS.n1727 VSS.n1277 8.5005
R5073 VSS.n1728 VSS.n1277 8.5005
R5074 VSS.n1730 VSS.n1277 8.5005
R5075 VSS.n1733 VSS.n1277 8.5005
R5076 VSS.n1734 VSS.n1277 8.5005
R5077 VSS.n1735 VSS.n1277 8.5005
R5078 VSS.n1736 VSS.n1277 8.5005
R5079 VSS.n1737 VSS.n1277 8.5005
R5080 VSS.n1738 VSS.n1277 8.5005
R5081 VSS.n1741 VSS.n1277 8.5005
R5082 VSS.n1742 VSS.n1277 8.5005
R5083 VSS.n1744 VSS.n1277 8.5005
R5084 VSS.n1747 VSS.n1277 8.5005
R5085 VSS.n1748 VSS.n1277 8.5005
R5086 VSS.n1749 VSS.n1277 8.5005
R5087 VSS.n1750 VSS.n1277 8.5005
R5088 VSS.n1751 VSS.n1277 8.5005
R5089 VSS.n1752 VSS.n1277 8.5005
R5090 VSS.n1755 VSS.n1277 8.5005
R5091 VSS.n1756 VSS.n1277 8.5005
R5092 VSS.n1758 VSS.n1277 8.5005
R5093 VSS.n1761 VSS.n1277 8.5005
R5094 VSS.n1762 VSS.n1277 8.5005
R5095 VSS.n1763 VSS.n1277 8.5005
R5096 VSS.n1764 VSS.n1277 8.5005
R5097 VSS.n1765 VSS.n1277 8.5005
R5098 VSS.n1766 VSS.n1277 8.5005
R5099 VSS.n1769 VSS.n1277 8.5005
R5100 VSS.n1770 VSS.n1277 8.5005
R5101 VSS.n1772 VSS.n1277 8.5005
R5102 VSS.n1775 VSS.n1277 8.5005
R5103 VSS.n1776 VSS.n1277 8.5005
R5104 VSS.n1777 VSS.n1277 8.5005
R5105 VSS.n1778 VSS.n1277 8.5005
R5106 VSS.n1779 VSS.n1277 8.5005
R5107 VSS.n1780 VSS.n1277 8.5005
R5108 VSS.n1783 VSS.n1277 8.5005
R5109 VSS.n1784 VSS.n1277 8.5005
R5110 VSS.n1786 VSS.n1277 8.5005
R5111 VSS.n1789 VSS.n1277 8.5005
R5112 VSS.n1790 VSS.n1277 8.5005
R5113 VSS.n1791 VSS.n1277 8.5005
R5114 VSS.n1792 VSS.n1277 8.5005
R5115 VSS.n1793 VSS.n1277 8.5005
R5116 VSS.n1794 VSS.n1277 8.5005
R5117 VSS.n1797 VSS.n1277 8.5005
R5118 VSS.n1798 VSS.n1277 8.5005
R5119 VSS.n1800 VSS.n1277 8.5005
R5120 VSS.n1803 VSS.n1277 8.5005
R5121 VSS.n1804 VSS.n1277 8.5005
R5122 VSS.n1805 VSS.n1277 8.5005
R5123 VSS.n1806 VSS.n1277 8.5005
R5124 VSS.n1807 VSS.n1277 8.5005
R5125 VSS.n1808 VSS.n1277 8.5005
R5126 VSS.n1811 VSS.n1277 8.5005
R5127 VSS.n1812 VSS.n1277 8.5005
R5128 VSS.n1814 VSS.n1277 8.5005
R5129 VSS.n1817 VSS.n1277 8.5005
R5130 VSS.n1818 VSS.n1277 8.5005
R5131 VSS.n1819 VSS.n1277 8.5005
R5132 VSS.n1820 VSS.n1277 8.5005
R5133 VSS.n1821 VSS.n1277 8.5005
R5134 VSS.n1822 VSS.n1277 8.5005
R5135 VSS.n1825 VSS.n1277 8.5005
R5136 VSS.n1826 VSS.n1277 8.5005
R5137 VSS.n1828 VSS.n1277 8.5005
R5138 VSS.n1831 VSS.n1277 8.5005
R5139 VSS.n1832 VSS.n1277 8.5005
R5140 VSS.n1833 VSS.n1277 8.5005
R5141 VSS.n1834 VSS.n1277 8.5005
R5142 VSS.n1835 VSS.n1277 8.5005
R5143 VSS.n1836 VSS.n1277 8.5005
R5144 VSS.n37 VSS.n185 8.5005
R5145 VSS.n37 VSS.n183 8.5005
R5146 VSS.n37 VSS.n181 8.5005
R5147 VSS.n37 VSS.n177 8.5005
R5148 VSS.n37 VSS.n176 8.5005
R5149 VSS.n37 VSS.n173 8.5005
R5150 VSS.n37 VSS.n170 8.5005
R5151 VSS.n37 VSS.n168 8.5005
R5152 VSS.n37 VSS.n166 8.5005
R5153 VSS.n37 VSS.n162 8.5005
R5154 VSS.n37 VSS.n161 8.5005
R5155 VSS.n37 VSS.n158 8.5005
R5156 VSS.n37 VSS.n157 8.5005
R5157 VSS.n3467 VSS.n1 8.5005
R5158 VSS.n3464 VSS.n1 8.5005
R5159 VSS.n37 VSS.n154 8.5005
R5160 VSS.n2147 VSS.n1277 8.49944
R5161 VSS.n2800 VSS.n1589 8.49444
R5162 VSS.n3074 VSS.n1351 8.49444
R5163 VSS.n3027 VSS.n1390 8.49444
R5164 VSS.n2980 VSS.n1429 8.49444
R5165 VSS.n2894 VSS.n1513 8.49444
R5166 VSS.n2847 VSS.n1552 8.49444
R5167 VSS.n589 VSS.n100 8.49109
R5168 VSS.n606 VSS.n1 8.48883
R5169 VSS.n3481 VSS.n1 8.48883
R5170 VSS.n303 VSS.n95 8.48665
R5171 VSS.n3502 VSS.n73 8.47784
R5172 VSS.n76 VSS.n75 8.47784
R5173 VSS.n395 VSS.n78 8.47784
R5174 VSS.n396 VSS.n79 8.47784
R5175 VSS.n398 VSS.n81 8.47784
R5176 VSS.n399 VSS.n82 8.47784
R5177 VSS.n400 VSS.n83 8.47784
R5178 VSS.n401 VSS.n391 8.47784
R5179 VSS.n402 VSS.n84 8.47784
R5180 VSS.n403 VSS.n86 8.47784
R5181 VSS.n404 VSS.n87 8.47784
R5182 VSS.n405 VSS.n88 8.47784
R5183 VSS.n407 VSS.n90 8.47784
R5184 VSS.n408 VSS.n91 8.47784
R5185 VSS.n409 VSS.n93 8.47784
R5186 VSS.n2547 VSS.n1277 8.47732
R5187 VSS.n2538 VSS.n1277 8.47732
R5188 VSS.n2533 VSS.n1277 8.47732
R5189 VSS.n2552 VSS.n1277 8.47732
R5190 VSS.t356 VSS.n1277 8.47732
R5191 VSS.n2526 VSS.n1277 8.47732
R5192 VSS.n2521 VSS.n1277 8.47732
R5193 VSS.n2516 VSS.n1277 8.47732
R5194 VSS.n2515 VSS.n1277 8.47732
R5195 VSS.n2514 VSS.n1277 8.47732
R5196 VSS.n1889 VSS.n1277 8.47732
R5197 VSS.n2217 VSS.n1277 8.47732
R5198 VSS.n2226 VSS.n1277 8.47732
R5199 VSS.n2235 VSS.n1277 8.47732
R5200 VSS.n2244 VSS.n1277 8.47732
R5201 VSS.n2253 VSS.n1277 8.47732
R5202 VSS.n2262 VSS.n1277 8.47732
R5203 VSS.n2271 VSS.n1277 8.47732
R5204 VSS.n2280 VSS.n1277 8.47732
R5205 VSS.n2289 VSS.n1277 8.47732
R5206 VSS.n2298 VSS.n1277 8.47732
R5207 VSS.n2307 VSS.n1277 8.47732
R5208 VSS.n2316 VSS.n1277 8.47732
R5209 VSS.n2325 VSS.n1277 8.47732
R5210 VSS.n2334 VSS.n1277 8.47732
R5211 VSS.n2343 VSS.n1277 8.47732
R5212 VSS.n2352 VSS.n1277 8.47732
R5213 VSS.n2361 VSS.n1277 8.47732
R5214 VSS.n2370 VSS.n1277 8.47732
R5215 VSS.n2379 VSS.n1277 8.47732
R5216 VSS.n2388 VSS.n1277 8.47732
R5217 VSS.n2397 VSS.n1277 8.47732
R5218 VSS.n2406 VSS.n1277 8.47732
R5219 VSS.n2415 VSS.n1277 8.47732
R5220 VSS.n2424 VSS.n1277 8.47732
R5221 VSS.n2433 VSS.n1277 8.47732
R5222 VSS.n2442 VSS.n1277 8.47732
R5223 VSS.n2451 VSS.n1277 8.47732
R5224 VSS.n2460 VSS.n1277 8.47732
R5225 VSS.n2469 VSS.n1277 8.47732
R5226 VSS.n2478 VSS.n1277 8.47732
R5227 VSS.n2487 VSS.n1277 8.47732
R5228 VSS.n2496 VSS.n1277 8.47732
R5229 VSS.n2501 VSS.n1277 8.47732
R5230 VSS.n2572 VSS.n1277 8.47732
R5231 VSS.n2140 VSS.n1277 8.47732
R5232 VSS.n2581 VSS.n1277 8.47732
R5233 VSS.n2583 VSS.n1277 8.47732
R5234 VSS.n2129 VSS.n1277 8.47732
R5235 VSS.n2125 VSS.n1277 8.47732
R5236 VSS.n2121 VSS.n1277 8.47732
R5237 VSS.n2119 VSS.n1277 8.47732
R5238 VSS.n2113 VSS.n1277 8.47732
R5239 VSS.n2109 VSS.n1277 8.47732
R5240 VSS.n2105 VSS.n1277 8.47732
R5241 VSS.n2103 VSS.n1277 8.47732
R5242 VSS.n2097 VSS.n1277 8.47732
R5243 VSS.n2093 VSS.n1277 8.47732
R5244 VSS.n2089 VSS.n1277 8.47732
R5245 VSS.n2087 VSS.n1277 8.47732
R5246 VSS.n2081 VSS.n1277 8.47732
R5247 VSS.n2077 VSS.n1277 8.47732
R5248 VSS.n2073 VSS.n1277 8.47732
R5249 VSS.n2071 VSS.n1277 8.47732
R5250 VSS.n2065 VSS.n1277 8.47732
R5251 VSS.n2061 VSS.n1277 8.47732
R5252 VSS.n2057 VSS.n1277 8.47732
R5253 VSS.n2055 VSS.n1277 8.47732
R5254 VSS.n2049 VSS.n1277 8.47732
R5255 VSS.n2045 VSS.n1277 8.47732
R5256 VSS.n2041 VSS.n1277 8.47732
R5257 VSS.n2039 VSS.n1277 8.47732
R5258 VSS.n2033 VSS.n1277 8.47732
R5259 VSS.n2029 VSS.n1277 8.47732
R5260 VSS.n2025 VSS.n1277 8.47732
R5261 VSS.n2023 VSS.n1277 8.47732
R5262 VSS.n2017 VSS.n1277 8.47732
R5263 VSS.n2013 VSS.n1277 8.47732
R5264 VSS.n2009 VSS.n1277 8.47732
R5265 VSS.n2007 VSS.n1277 8.47732
R5266 VSS.n2001 VSS.n1277 8.47732
R5267 VSS.n1997 VSS.n1277 8.47732
R5268 VSS.n1993 VSS.n1277 8.47732
R5269 VSS.n1991 VSS.n1277 8.47732
R5270 VSS.n1985 VSS.n1277 8.47732
R5271 VSS.n1981 VSS.n1277 8.47732
R5272 VSS.n1977 VSS.n1277 8.47732
R5273 VSS.n1975 VSS.n1277 8.47732
R5274 VSS.n1969 VSS.n1277 8.47732
R5275 VSS.n1965 VSS.n1277 8.47732
R5276 VSS.n1961 VSS.n1277 8.47732
R5277 VSS.n1959 VSS.n1277 8.47732
R5278 VSS.n1953 VSS.n1277 8.47732
R5279 VSS.n1949 VSS.n1277 8.47732
R5280 VSS.n1945 VSS.n1277 8.47732
R5281 VSS.n1943 VSS.n1277 8.47732
R5282 VSS.n1937 VSS.n1277 8.47732
R5283 VSS.n1933 VSS.n1277 8.47732
R5284 VSS.n1929 VSS.n1277 8.47732
R5285 VSS.n1927 VSS.n1277 8.47732
R5286 VSS.n1921 VSS.n1277 8.47732
R5287 VSS.n1917 VSS.n1277 8.47732
R5288 VSS.n1913 VSS.n1277 8.47732
R5289 VSS.n1911 VSS.n1277 8.47732
R5290 VSS.n1905 VSS.n1277 8.47732
R5291 VSS.n1900 VSS.n1277 8.47732
R5292 VSS.n1894 VSS.n1277 8.47732
R5293 VSS.n2793 VSS.n1277 8.47732
R5294 VSS.t120 VSS.n1277 8.47732
R5295 VSS.n2800 VSS.n2799 8.47732
R5296 VSS.n2800 VSS.n1595 8.47732
R5297 VSS.n2800 VSS.n1841 8.47732
R5298 VSS.n2800 VSS.n1842 8.47732
R5299 VSS.n2800 VSS.n1843 8.47732
R5300 VSS.n2800 VSS.n1844 8.47732
R5301 VSS.n2800 VSS.n1846 8.47732
R5302 VSS.n2800 VSS.n1847 8.47732
R5303 VSS.t363 VSS.n1278 8.47732
R5304 VSS.n3136 VSS.n1278 8.47732
R5305 VSS.n1322 VSS.n1278 8.47732
R5306 VSS.n3140 VSS.n1278 8.47732
R5307 VSS.t383 VSS.n1278 8.47732
R5308 VSS.n3144 VSS.n1278 8.47732
R5309 VSS.n1312 VSS.n1278 8.47732
R5310 VSS.n3148 VSS.n1278 8.47732
R5311 VSS.n1307 VSS.n1278 8.47732
R5312 VSS.n1302 VSS.n1278 8.47732
R5313 VSS.n3152 VSS.n1278 8.47732
R5314 VSS.n3154 VSS.n1278 8.47732
R5315 VSS.n3156 VSS.n1278 8.47732
R5316 VSS.n3158 VSS.n1278 8.47732
R5317 VSS.n3160 VSS.n1278 8.47732
R5318 VSS.n3162 VSS.n1278 8.47732
R5319 VSS.n3164 VSS.n1278 8.47732
R5320 VSS.n3166 VSS.n1278 8.47732
R5321 VSS.n3168 VSS.n1278 8.47732
R5322 VSS.n3170 VSS.n1278 8.47732
R5323 VSS.n3172 VSS.n1278 8.47732
R5324 VSS.n3176 VSS.n1278 8.47732
R5325 VSS.n3178 VSS.n1278 8.47732
R5326 VSS.n3180 VSS.n1280 8.47732
R5327 VSS.n3180 VSS.n1281 8.47732
R5328 VSS.n3083 VSS.n1337 8.47732
R5329 VSS.n1348 VSS.n3074 8.47732
R5330 VSS.n3074 VSS.n1347 8.47732
R5331 VSS.n3074 VSS.n1352 8.47732
R5332 VSS.n3074 VSS.n1353 8.47732
R5333 VSS.n3074 VSS.n1354 8.47732
R5334 VSS.n3074 VSS.n1357 8.47732
R5335 VSS.n3074 VSS.n1358 8.47732
R5336 VSS.n1368 VSS.n3049 8.47732
R5337 VSS.n3049 VSS.n1367 8.47732
R5338 VSS.n3038 VSS.n1377 8.47732
R5339 VSS.n1387 VSS.n3027 8.47732
R5340 VSS.n3027 VSS.n1386 8.47732
R5341 VSS.n3027 VSS.n1391 8.47732
R5342 VSS.n3027 VSS.n1392 8.47732
R5343 VSS.n3027 VSS.n1393 8.47732
R5344 VSS.n3027 VSS.n1396 8.47732
R5345 VSS.n3027 VSS.n1397 8.47732
R5346 VSS.n1407 VSS.n3002 8.47732
R5347 VSS.n3002 VSS.n1406 8.47732
R5348 VSS.n2991 VSS.n1416 8.47732
R5349 VSS.n1426 VSS.n2980 8.47732
R5350 VSS.n2980 VSS.n1425 8.47732
R5351 VSS.n2980 VSS.n1430 8.47732
R5352 VSS.n2980 VSS.n1431 8.47732
R5353 VSS.n2980 VSS.n1432 8.47732
R5354 VSS.n2980 VSS.n1435 8.47732
R5355 VSS.n2980 VSS.n1436 8.47732
R5356 VSS.n2980 VSS.n1437 8.47732
R5357 VSS.n2980 VSS.n1438 8.47732
R5358 VSS.n2980 VSS.n1439 8.47732
R5359 VSS.n2980 VSS.n1441 8.47732
R5360 VSS.n2980 VSS.n1444 8.47732
R5361 VSS.n2980 VSS.n1445 8.47732
R5362 VSS.n2980 VSS.n1448 8.47732
R5363 VSS.n2980 VSS.n1449 8.47732
R5364 VSS.n2980 VSS.n1450 8.47732
R5365 VSS.n2980 VSS.n1451 8.47732
R5366 VSS.n2980 VSS.n1452 8.47732
R5367 VSS.n2980 VSS.n1453 8.47732
R5368 VSS.n2980 VSS.n1456 8.47732
R5369 VSS.n2980 VSS.n1457 8.47732
R5370 VSS.n1491 VSS.n2916 8.47732
R5371 VSS.n2916 VSS.n1490 8.47732
R5372 VSS.n2905 VSS.n1500 8.47732
R5373 VSS.n1510 VSS.n2894 8.47732
R5374 VSS.n2894 VSS.n1509 8.47732
R5375 VSS.n2894 VSS.n1514 8.47732
R5376 VSS.n2894 VSS.n1515 8.47732
R5377 VSS.n2894 VSS.n1516 8.47732
R5378 VSS.n2894 VSS.n1519 8.47732
R5379 VSS.n2894 VSS.n1520 8.47732
R5380 VSS.n1530 VSS.n2869 8.47732
R5381 VSS.n2869 VSS.n1529 8.47732
R5382 VSS.n2858 VSS.n1539 8.47732
R5383 VSS.n1549 VSS.n2847 8.47732
R5384 VSS.n2847 VSS.n1548 8.47732
R5385 VSS.n2847 VSS.n1553 8.47732
R5386 VSS.n2847 VSS.n1554 8.47732
R5387 VSS.n2847 VSS.n1555 8.47732
R5388 VSS.n2847 VSS.n1558 8.47732
R5389 VSS.n2847 VSS.n1559 8.47732
R5390 VSS.n1569 VSS.n2822 8.47732
R5391 VSS.n2822 VSS.n1568 8.47732
R5392 VSS.n2811 VSS.n1578 8.47732
R5393 VSS.n1588 VSS.n2800 8.47732
R5394 VSS.n2800 VSS.n1587 8.47732
R5395 VSS.n3848 VSS.n7 8.47732
R5396 VSS.n3847 VSS.n7 8.47732
R5397 VSS.n770 VSS.n7 8.47732
R5398 VSS.n7 VSS.n6 8.47732
R5399 VSS.n3360 VSS.n7 8.47732
R5400 VSS.n3820 VSS.n7 8.47732
R5401 VSS.n3812 VSS.n27 8.47732
R5402 VSS.n29 VSS.n28 8.47732
R5403 VSS.n3789 VSS.n199 8.47732
R5404 VSS.n3791 VSS.n197 8.47732
R5405 VSS.n3793 VSS.n30 8.47732
R5406 VSS.n3795 VSS.n32 8.47732
R5407 VSS.n3797 VSS.n33 8.47732
R5408 VSS.n3799 VSS.n34 8.47732
R5409 VSS.n3801 VSS.n35 8.47732
R5410 VSS.n3803 VSS.n36 8.47732
R5411 VSS.n3805 VSS.n38 8.47732
R5412 VSS.n3845 VSS.n7 8.47732
R5413 VSS.n112 VSS.n7 8.47732
R5414 VSS.n3836 VSS.n7 8.47732
R5415 VSS.n3834 VSS.n7 8.47732
R5416 VSS.n3832 VSS.n7 8.47732
R5417 VSS.n116 VSS.n7 8.47732
R5418 VSS.n3824 VSS.n7 8.47732
R5419 VSS.n3822 VSS.n7 8.47732
R5420 VSS.n3367 VSS.n40 8.47732
R5421 VSS.n3370 VSS.n41 8.47732
R5422 VSS.n3372 VSS.n43 8.47732
R5423 VSS.n3374 VSS.n44 8.47732
R5424 VSS.n3376 VSS.n45 8.47732
R5425 VSS.n3380 VSS.n739 8.47732
R5426 VSS.n3381 VSS.n48 8.47732
R5427 VSS.n736 VSS.n49 8.47732
R5428 VSS.n733 VSS.n52 8.47732
R5429 VSS.n3386 VSS.n51 8.47732
R5430 VSS.n3390 VSS.n53 8.47732
R5431 VSS.n3392 VSS.n55 8.47732
R5432 VSS.n3394 VSS.n54 8.47732
R5433 VSS.n3400 VSS.n724 8.47732
R5434 VSS.n3402 VSS.n688 8.47732
R5435 VSS.n4 VSS.t100 8.47732
R5436 VSS.t505 VSS.n8 8.47732
R5437 VSS.n3335 VSS.n9 8.47732
R5438 VSS.n3237 VSS.n11 8.47732
R5439 VSS.t507 VSS.n12 8.47732
R5440 VSS.n3340 VSS.n3233 8.47732
R5441 VSS.n3342 VSS.n14 8.47732
R5442 VSS.n3227 VSS.n16 8.47732
R5443 VSS.n3344 VSS.n17 8.47732
R5444 VSS.n3222 VSS.n3223 8.47732
R5445 VSS.n3220 VSS.n19 8.47732
R5446 VSS.n3348 VSS.n20 8.47732
R5447 VSS.n3352 VSS.n22 8.47732
R5448 VSS.n3354 VSS.n3212 8.47732
R5449 VSS.n3356 VSS.n25 8.47732
R5450 VSS.n92 VSS.t252 8.47732
R5451 VSS.n92 VSS.n576 8.47732
R5452 VSS.n92 VSS.n573 8.47732
R5453 VSS.n92 VSS.n570 8.47732
R5454 VSS.n92 VSS.n567 8.47732
R5455 VSS.n92 VSS.n564 8.47732
R5456 VSS.n92 VSS.n563 8.47732
R5457 VSS.n92 VSS.n562 8.47732
R5458 VSS.n92 VSS.n558 8.47732
R5459 VSS.n92 VSS.n550 8.47732
R5460 VSS.n92 VSS.n547 8.47732
R5461 VSS.n92 VSS.n544 8.47732
R5462 VSS.n92 VSS.n541 8.47732
R5463 VSS.n92 VSS.n538 8.47732
R5464 VSS.n92 VSS.n537 8.47732
R5465 VSS.n92 VSS.n533 8.47732
R5466 VSS.n92 VSS.n530 8.47732
R5467 VSS.n92 VSS.n522 8.47732
R5468 VSS.n92 VSS.n519 8.47732
R5469 VSS.n92 VSS.n518 8.47732
R5470 VSS.n92 VSS.n517 8.47732
R5471 VSS.n92 VSS.n516 8.47732
R5472 VSS.n92 VSS.n515 8.47732
R5473 VSS.n92 VSS.n511 8.47732
R5474 VSS.n92 VSS.n508 8.47732
R5475 VSS.n92 VSS.n505 8.47732
R5476 VSS.n92 VSS.n504 8.47732
R5477 VSS.n92 VSS.n503 8.47732
R5478 VSS.n92 VSS.n502 8.47732
R5479 VSS.n92 VSS.n501 8.47732
R5480 VSS.n92 VSS.n500 8.47732
R5481 VSS.n92 VSS.n496 8.47732
R5482 VSS.n92 VSS.n493 8.47732
R5483 VSS.n92 VSS.n492 8.47732
R5484 VSS.n92 VSS.n485 8.47732
R5485 VSS.n92 VSS.n482 8.47732
R5486 VSS.n92 VSS.n479 8.47732
R5487 VSS.n92 VSS.n478 8.47732
R5488 VSS.n92 VSS.n475 8.47732
R5489 VSS.n92 VSS.n474 8.47732
R5490 VSS.n92 VSS.n473 8.47732
R5491 VSS.n92 VSS.n472 8.47732
R5492 VSS.n92 VSS.n470 8.47732
R5493 VSS.n92 VSS.n469 8.47732
R5494 VSS.n92 VSS.n468 8.47732
R5495 VSS.n92 VSS.n467 8.47732
R5496 VSS.n92 VSS.n464 8.47732
R5497 VSS.n92 VSS.n460 8.47732
R5498 VSS.n92 VSS.n457 8.47732
R5499 VSS.n92 VSS.n454 8.47732
R5500 VSS.n92 VSS.n453 8.47732
R5501 VSS.n92 VSS.n452 8.47732
R5502 VSS.n92 VSS.n448 8.47732
R5503 VSS.n92 VSS.n445 8.47732
R5504 VSS.n92 VSS.n442 8.47732
R5505 VSS.n92 VSS.n439 8.47732
R5506 VSS.n92 VSS.n436 8.47732
R5507 VSS.n92 VSS.n433 8.47732
R5508 VSS.n92 VSS.n432 8.47732
R5509 VSS.n92 VSS.n431 8.47732
R5510 VSS.n92 VSS.t264 8.47732
R5511 VSS.n92 VSS.n425 8.47732
R5512 VSS.n92 VSS.n422 8.47732
R5513 VSS.n92 VSS.n419 8.47732
R5514 VSS.n92 VSS.n418 8.47732
R5515 VSS.n92 VSS.n415 8.47732
R5516 VSS.n92 VSS.n414 8.47732
R5517 VSS.n92 VSS.n413 8.47732
R5518 VSS.n92 VSS.n412 8.47732
R5519 VSS.n3534 VSS.n95 8.47732
R5520 VSS.n3536 VSS.n95 8.47732
R5521 VSS.n3538 VSS.n95 8.47732
R5522 VSS.n3540 VSS.n95 8.47732
R5523 VSS.n3542 VSS.n95 8.47732
R5524 VSS.n3544 VSS.n95 8.47732
R5525 VSS.n3546 VSS.n95 8.47732
R5526 VSS.n3548 VSS.n95 8.47732
R5527 VSS.t281 VSS.n95 8.47732
R5528 VSS.n3551 VSS.n95 8.47732
R5529 VSS.n3553 VSS.n95 8.47732
R5530 VSS.n3555 VSS.n95 8.47732
R5531 VSS.n3557 VSS.n95 8.47732
R5532 VSS.n3559 VSS.n95 8.47732
R5533 VSS.n3561 VSS.n95 8.47732
R5534 VSS.n3563 VSS.n95 8.47732
R5535 VSS.n3565 VSS.n95 8.47732
R5536 VSS.n3567 VSS.n95 8.47732
R5537 VSS.n3568 VSS.n95 8.47732
R5538 VSS.n3570 VSS.n95 8.47732
R5539 VSS.n3572 VSS.n95 8.47732
R5540 VSS.n3574 VSS.n95 8.47732
R5541 VSS.n3576 VSS.n95 8.47732
R5542 VSS.n3578 VSS.n95 8.47732
R5543 VSS.n3580 VSS.n95 8.47732
R5544 VSS.n3582 VSS.n95 8.47732
R5545 VSS.n277 VSS.n95 8.47732
R5546 VSS.n3597 VSS.n95 8.47732
R5547 VSS.n3599 VSS.n95 8.47732
R5548 VSS.n3601 VSS.n95 8.47732
R5549 VSS.n3603 VSS.n95 8.47732
R5550 VSS.n3605 VSS.n95 8.47732
R5551 VSS.n3607 VSS.n95 8.47732
R5552 VSS.n3609 VSS.n95 8.47732
R5553 VSS.n265 VSS.n95 8.47732
R5554 VSS.n3633 VSS.n95 8.47732
R5555 VSS.n3635 VSS.n95 8.47732
R5556 VSS.n3637 VSS.n95 8.47732
R5557 VSS.n3639 VSS.n95 8.47732
R5558 VSS.n3641 VSS.n95 8.47732
R5559 VSS.n3643 VSS.n95 8.47732
R5560 VSS.n3645 VSS.n95 8.47732
R5561 VSS.n3647 VSS.n95 8.47732
R5562 VSS.n3648 VSS.n95 8.47732
R5563 VSS.n3650 VSS.n95 8.47732
R5564 VSS.n3652 VSS.n95 8.47732
R5565 VSS.n3654 VSS.n95 8.47732
R5566 VSS.n3656 VSS.n95 8.47732
R5567 VSS.n3658 VSS.n95 8.47732
R5568 VSS.n3660 VSS.n95 8.47732
R5569 VSS.n3662 VSS.n95 8.47732
R5570 VSS.n244 VSS.n95 8.47732
R5571 VSS.n3677 VSS.n95 8.47732
R5572 VSS.n3679 VSS.n95 8.47732
R5573 VSS.n3681 VSS.n95 8.47732
R5574 VSS.n3683 VSS.n95 8.47732
R5575 VSS.n3685 VSS.n95 8.47732
R5576 VSS.n3687 VSS.n95 8.47732
R5577 VSS.n3689 VSS.n95 8.47732
R5578 VSS.n232 VSS.n95 8.47732
R5579 VSS.n3707 VSS.n95 8.47732
R5580 VSS.n3709 VSS.n95 8.47732
R5581 VSS.n3711 VSS.n95 8.47732
R5582 VSS.n3713 VSS.n95 8.47732
R5583 VSS.n3715 VSS.n95 8.47732
R5584 VSS.n3717 VSS.n95 8.47732
R5585 VSS.n3719 VSS.n95 8.47732
R5586 VSS.n3721 VSS.n95 8.47732
R5587 VSS.t267 VSS.n95 8.47732
R5588 VSS.n37 VSS.n125 8.47732
R5589 VSS.n37 VSS.n126 8.47732
R5590 VSS.n37 VSS.n127 8.47732
R5591 VSS.n37 VSS.n128 8.47732
R5592 VSS.n37 VSS.n129 8.47732
R5593 VSS.n37 VSS.n130 8.47732
R5594 VSS.n37 VSS.n131 8.47732
R5595 VSS.n37 VSS.n132 8.47732
R5596 VSS.n37 VSS.n133 8.47732
R5597 VSS.n37 VSS.n135 8.47732
R5598 VSS.n37 VSS.n137 8.47732
R5599 VSS.n37 VSS.n138 8.47732
R5600 VSS.n37 VSS.n139 8.47732
R5601 VSS.n37 VSS.n140 8.47732
R5602 VSS.n37 VSS.n142 8.47732
R5603 VSS.n37 VSS.n143 8.47732
R5604 VSS.n37 VSS.n144 8.47732
R5605 VSS.n37 VSS.n145 8.47732
R5606 VSS.n37 VSS.n186 8.47732
R5607 VSS.n37 VSS.n184 8.47732
R5608 VSS.n37 VSS.n182 8.47732
R5609 VSS.n37 VSS.n180 8.47732
R5610 VSS.n37 VSS.n179 8.47732
R5611 VSS.n37 VSS.n178 8.47732
R5612 VSS.n37 VSS.n175 8.47732
R5613 VSS.n37 VSS.n174 8.47732
R5614 VSS.n37 VSS.n169 8.47732
R5615 VSS.n37 VSS.n167 8.47732
R5616 VSS.n37 VSS.n163 8.47732
R5617 VSS.n37 VSS.n160 8.47732
R5618 VSS.n37 VSS.n156 8.47732
R5619 VSS.n3411 VSS.n688 8.47732
R5620 VSS.n3413 VSS.n688 8.47732
R5621 VSS.n714 VSS.n688 8.47732
R5622 VSS.n3418 VSS.n688 8.47732
R5623 VSS.n3420 VSS.n688 8.47732
R5624 VSS.n708 VSS.n688 8.47732
R5625 VSS.n3425 VSS.n688 8.47732
R5626 VSS.n3427 VSS.n688 8.47732
R5627 VSS.n703 VSS.n688 8.47732
R5628 VSS.n699 VSS.n688 8.47732
R5629 VSS.n3441 VSS.n688 8.47732
R5630 VSS.n3444 VSS.n688 8.47732
R5631 VSS.n697 VSS.n688 8.47732
R5632 VSS.n692 VSS.n688 8.47732
R5633 VSS.n600 VSS.n1 8.47732
R5634 VSS.n595 VSS.n1 8.47732
R5635 VSS.n590 VSS.n1 8.47732
R5636 VSS.n1 VSS.n0 8.47732
R5637 VSS.n3474 VSS.n1 8.47732
R5638 VSS.n3478 VSS.n1 8.47732
R5639 VSS.n37 VSS.n155 8.47732
R5640 VSS.n37 VSS.n153 8.47732
R5641 VSS.n95 VSS.n94 8.47677
R5642 VSS.n586 VSS.n97 8.47677
R5643 VSS.n587 VSS.n98 8.47677
R5644 VSS.n3495 VSS.n102 8.47677
R5645 VSS.n3496 VSS.n103 8.47677
R5646 VSS.n3497 VSS.n105 8.47677
R5647 VSS.n1265 VSS.t163 8.47111
R5648 VSS.n1268 VSS.t163 8.47111
R5649 VSS.t131 VSS.n1269 8.47111
R5650 VSS.t131 VSS.n781 8.47111
R5651 VSS.t131 VSS.n783 8.47111
R5652 VSS.t131 VSS.n784 8.47111
R5653 VSS.t131 VSS.n785 8.47111
R5654 VSS.t131 VSS.n787 8.47111
R5655 VSS.n1221 VSS.n1220 8.47111
R5656 VSS.n1215 VSS.n810 8.47111
R5657 VSS.n1216 VSS.n812 8.47111
R5658 VSS.n1216 VSS.n814 8.47111
R5659 VSS.n1216 VSS.n829 8.47111
R5660 VSS.n1216 VSS.n817 8.47111
R5661 VSS.n1216 VSS.n825 8.47111
R5662 VSS.n1216 VSS.n824 8.47111
R5663 VSS.n1216 VSS.n822 8.47111
R5664 VSS.n1175 VSS.t133 8.47111
R5665 VSS.t133 VSS.n846 8.47111
R5666 VSS.t133 VSS.n848 8.47111
R5667 VSS.t133 VSS.n849 8.47111
R5668 VSS.t133 VSS.n850 8.47111
R5669 VSS.t133 VSS.n852 8.47111
R5670 VSS.n1147 VSS.n1146 8.47111
R5671 VSS.n1141 VSS.n867 8.47111
R5672 VSS.n1142 VSS.n869 8.47111
R5673 VSS.n1142 VSS.n871 8.47111
R5674 VSS.n1142 VSS.n872 8.47111
R5675 VSS.n1142 VSS.n873 8.47111
R5676 VSS.n640 VSS.n639 8.47111
R5677 VSS.t58 VSS.n624 8.47111
R5678 VSS.t58 VSS.n613 8.47111
R5679 VSS.t58 VSS.n621 8.47111
R5680 VSS.t58 VSS.n618 8.47111
R5681 VSS.t388 VSS.n640 8.47111
R5682 VSS.n3449 VSS.n688 8.46924
R5683 VSS.n3859 VSS.n3858 7.85649
R5684 VSS.n2507 VSS.n109 7.82802
R5685 VSS.n679 VSS.n58 7.06146
R5686 VSS.n778 VSS.n70 7.06124
R5687 VSS.n665 VSS.n68 7.06124
R5688 VSS.n684 VSS.n65 7.06124
R5689 VSS.n670 VSS.n62 7.06124
R5690 VSS.n2510 VSS.n109 6.85994
R5691 VSS.n96 VSS.n3499 1.30378
R5692 VSS.t265 VSS.n378 6.42276
R5693 VSS.n92 VSS.n304 6.3893
R5694 VSS.n1276 VSS.n779 5.66923
R5695 VSS.n3810 VSS.n26 0.0024999
R5696 VSS.n3808 VSS.n124 5.66778
R5697 VSS.n3385 VSS.n735 5.66778
R5698 VSS.n39 VSS.n767 0.00229996
R5699 VSS.n3385 VSS.n42 1.54575
R5700 VSS.n46 VSS.n739 0.00229996
R5701 VSS.n50 VSS.n47 0.00261098
R5702 VSS.n56 VSS.n53 0.0024999
R5703 VSS.n3385 VSS.n734 5.66778
R5704 VSS.n10 VSS.n3241 0.00249991
R5705 VSS.n13 VSS.n3233 0.00229996
R5706 VSS.n15 VSS.n3230 0.00249991
R5707 VSS.n18 VSS.n3223 0.00249991
R5708 VSS.n21 VSS.n3217 0.00229996
R5709 VSS.n23 VSS.n3212 0.00229996
R5710 VSS.n3359 VSS.n71 5.66778
R5711 VSS.n99 VSS.n585 0.00229996
R5712 VSS.n101 VSS.n584 0.00261098
R5713 VSS.n77 VSS.n393 0.00249991
R5714 VSS.n80 VSS.n392 0.00261099
R5715 VSS.n89 VSS.n390 0.00261098
R5716 VSS.n36 VSS.n38 0.00139998
R5717 VSS.n1218 VSS.n1217 5.66767
R5718 VSS.n1144 VSS.n1143 5.66767
R5719 VSS.n1262 VSS.t163 5.66031
R5720 VSS.t58 VSS.n3451 5.65099
R5721 VSS.n3083 VSS.n3082 5.64536
R5722 VSS.n3038 VSS.n3035 5.64536
R5723 VSS.n2991 VSS.n2988 5.64536
R5724 VSS.n2905 VSS.n2902 5.64536
R5725 VSS.n2858 VSS.n2855 5.64536
R5726 VSS.n2811 VSS.n2808 5.64536
R5727 VSS.n104 VSS.n3498 5.63173
R5728 VSS.n394 VSS.n393 5.62674
R5729 VSS.n397 VSS.n392 5.62674
R5730 VSS.n406 VSS.n390 5.62674
R5731 VSS.t623 VSS.n1277 5.62581
R5732 VSS.n2556 VSS.n1277 5.62581
R5733 VSS.n2561 VSS.n1277 5.62581
R5734 VSS.n2215 VSS.n1277 5.62581
R5735 VSS.n2224 VSS.n1277 5.62581
R5736 VSS.n2233 VSS.n1277 5.62581
R5737 VSS.n2242 VSS.n1277 5.62581
R5738 VSS.n2251 VSS.n1277 5.62581
R5739 VSS.n2260 VSS.n1277 5.62581
R5740 VSS.n2269 VSS.n1277 5.62581
R5741 VSS.n2278 VSS.n1277 5.62581
R5742 VSS.n2287 VSS.n1277 5.62581
R5743 VSS.n2296 VSS.n1277 5.62581
R5744 VSS.n2305 VSS.n1277 5.62581
R5745 VSS.n2314 VSS.n1277 5.62581
R5746 VSS.n2323 VSS.n1277 5.62581
R5747 VSS.n2332 VSS.n1277 5.62581
R5748 VSS.n2341 VSS.n1277 5.62581
R5749 VSS.n2350 VSS.n1277 5.62581
R5750 VSS.n2359 VSS.n1277 5.62581
R5751 VSS.n2368 VSS.n1277 5.62581
R5752 VSS.n2377 VSS.n1277 5.62581
R5753 VSS.n2386 VSS.n1277 5.62581
R5754 VSS.n2395 VSS.n1277 5.62581
R5755 VSS.n2404 VSS.n1277 5.62581
R5756 VSS.n2413 VSS.n1277 5.62581
R5757 VSS.n2422 VSS.n1277 5.62581
R5758 VSS.n2431 VSS.n1277 5.62581
R5759 VSS.n2440 VSS.n1277 5.62581
R5760 VSS.n2449 VSS.n1277 5.62581
R5761 VSS.n2458 VSS.n1277 5.62581
R5762 VSS.n2467 VSS.n1277 5.62581
R5763 VSS.n2476 VSS.n1277 5.62581
R5764 VSS.n2485 VSS.n1277 5.62581
R5765 VSS.n2494 VSS.n1277 5.62581
R5766 VSS.n2141 VSS.n1277 5.62581
R5767 VSS.n2135 VSS.n1277 5.62581
R5768 VSS.n2132 VSS.n1277 5.62581
R5769 VSS.n2586 VSS.n1277 5.62581
R5770 VSS.n2128 VSS.n1277 5.62581
R5771 VSS.n2122 VSS.n1277 5.62581
R5772 VSS.n2116 VSS.n1277 5.62581
R5773 VSS.n2600 VSS.n1277 5.62581
R5774 VSS.n2112 VSS.n1277 5.62581
R5775 VSS.n2106 VSS.n1277 5.62581
R5776 VSS.n2100 VSS.n1277 5.62581
R5777 VSS.n2614 VSS.n1277 5.62581
R5778 VSS.n2096 VSS.n1277 5.62581
R5779 VSS.n2090 VSS.n1277 5.62581
R5780 VSS.n2084 VSS.n1277 5.62581
R5781 VSS.n2628 VSS.n1277 5.62581
R5782 VSS.n2080 VSS.n1277 5.62581
R5783 VSS.n2074 VSS.n1277 5.62581
R5784 VSS.n2068 VSS.n1277 5.62581
R5785 VSS.n2642 VSS.n1277 5.62581
R5786 VSS.n2064 VSS.n1277 5.62581
R5787 VSS.n2058 VSS.n1277 5.62581
R5788 VSS.n2052 VSS.n1277 5.62581
R5789 VSS.n2656 VSS.n1277 5.62581
R5790 VSS.n2048 VSS.n1277 5.62581
R5791 VSS.n2042 VSS.n1277 5.62581
R5792 VSS.n2036 VSS.n1277 5.62581
R5793 VSS.n2670 VSS.n1277 5.62581
R5794 VSS.n2032 VSS.n1277 5.62581
R5795 VSS.n2026 VSS.n1277 5.62581
R5796 VSS.n2020 VSS.n1277 5.62581
R5797 VSS.n2684 VSS.n1277 5.62581
R5798 VSS.n2016 VSS.n1277 5.62581
R5799 VSS.n2010 VSS.n1277 5.62581
R5800 VSS.n2004 VSS.n1277 5.62581
R5801 VSS.n2698 VSS.n1277 5.62581
R5802 VSS.n2000 VSS.n1277 5.62581
R5803 VSS.n1994 VSS.n1277 5.62581
R5804 VSS.n1988 VSS.n1277 5.62581
R5805 VSS.n2712 VSS.n1277 5.62581
R5806 VSS.n1984 VSS.n1277 5.62581
R5807 VSS.n1978 VSS.n1277 5.62581
R5808 VSS.n1972 VSS.n1277 5.62581
R5809 VSS.n2726 VSS.n1277 5.62581
R5810 VSS.n1968 VSS.n1277 5.62581
R5811 VSS.n1962 VSS.n1277 5.62581
R5812 VSS.n1956 VSS.n1277 5.62581
R5813 VSS.n2740 VSS.n1277 5.62581
R5814 VSS.n1952 VSS.n1277 5.62581
R5815 VSS.n1946 VSS.n1277 5.62581
R5816 VSS.n1940 VSS.n1277 5.62581
R5817 VSS.n2754 VSS.n1277 5.62581
R5818 VSS.n1936 VSS.n1277 5.62581
R5819 VSS.n1930 VSS.n1277 5.62581
R5820 VSS.n1924 VSS.n1277 5.62581
R5821 VSS.n2768 VSS.n1277 5.62581
R5822 VSS.n1920 VSS.n1277 5.62581
R5823 VSS.n1914 VSS.n1277 5.62581
R5824 VSS.n1908 VSS.n1277 5.62581
R5825 VSS.n2782 VSS.n1277 5.62581
R5826 VSS.n1904 VSS.n1277 5.62581
R5827 VSS.n1897 VSS.n1277 5.62581
R5828 VSS.n2795 VSS.n1277 5.62581
R5829 VSS.n1890 VSS.n1277 5.62581
R5830 VSS.n1888 VSS.n1277 5.62581
R5831 VSS.n2800 VSS.n1593 5.62581
R5832 VSS.n2800 VSS.n1597 5.62581
R5833 VSS.n3134 VSS.n1278 5.62581
R5834 VSS.n3138 VSS.n1278 5.62581
R5835 VSS.n3142 VSS.n1278 5.62581
R5836 VSS.n3146 VSS.n1278 5.62581
R5837 VSS.n3150 VSS.n1278 5.62581
R5838 VSS.n3174 VSS.n1278 5.62581
R5839 VSS.n3074 VSS.n1355 5.62581
R5840 VSS.n3027 VSS.n1394 5.62581
R5841 VSS.n2980 VSS.n1433 5.62581
R5842 VSS.n2980 VSS.n1442 5.62581
R5843 VSS.n2980 VSS.n1446 5.62581
R5844 VSS.n2980 VSS.n1454 5.62581
R5845 VSS.n2894 VSS.n1517 5.62581
R5846 VSS.n2847 VSS.n1556 5.62581
R5847 VSS.n768 VSS.n7 5.62581
R5848 VSS.n3810 VSS.n120 5.62581
R5849 VSS.n37 VSS.n3807 5.62581
R5850 VSS.t94 VSS.n767 5.62581
R5851 VSS.n3368 VSS.n765 5.62581
R5852 VSS.n47 VSS.n3383 5.62581
R5853 VSS.n3396 VSS.n57 5.62581
R5854 VSS.n3337 VSS.n3241 5.62581
R5855 VSS.n3230 VSS.n3229 5.62581
R5856 VSS.n3350 VSS.n3217 5.62581
R5857 VSS.n24 VSS.n3358 5.62581
R5858 VSS.n92 VSS.n555 5.62581
R5859 VSS.n92 VSS.n527 5.62581
R5860 VSS.n92 VSS.n491 5.62581
R5861 VSS.n92 VSS.n471 5.62581
R5862 VSS.n92 VSS.n411 5.62581
R5863 VSS.n3532 VSS.n95 5.62581
R5864 VSS.n3595 VSS.n95 5.62581
R5865 VSS.n3631 VSS.n95 5.62581
R5866 VSS.n3675 VSS.n95 5.62581
R5867 VSS.n3705 VSS.n95 5.62581
R5868 VSS.n37 VSS.n136 5.62581
R5869 VSS.n37 VSS.n172 5.62581
R5870 VSS.n37 VSS.n165 5.62581
R5871 VSS.n37 VSS.n159 5.62581
R5872 VSS.n3404 VSS.n688 5.62581
R5873 VSS.n3436 VSS.n688 5.62581
R5874 VSS.n3491 VSS.n1 5.62581
R5875 VSS.n588 VSS.n585 5.62484
R5876 VSS.n3494 VSS.n584 5.62484
R5877 VSS.n92 VSS.n410 5.62352
R5878 VSS.t58 VSS.n623 5.61485
R5879 VSS.t678 VSS.n183 5.48496
R5880 VSS.n3500 VSS.n96 9.1202
R5881 VSS.n3462 VSS.t189 4.98596
R5882 VSS.n1883 VSS.n1882 4.73162
R5883 VSS.n1114 VSS.n1113 4.73162
R5884 VSS.n946 VSS.n945 4.73162
R5885 VSS.n3265 VSS.n3264 4.73162
R5886 VSS.n3530 VSS.n3529 4.73162
R5887 VSS.n763 VSS.n762 4.73162
R5888 VSS.n3448 VSS.n3447 4.73162
R5889 VSS.n2220 VSS.n2212 4.73162
R5890 VSS.n663 VSS.n662 4.64666
R5891 VSS.n643 VSS.n634 4.64666
R5892 VSS.n1259 VSS.n1258 4.64666
R5893 VSS.n1118 VSS.n883 4.64666
R5894 VSS.t158 VSS.n811 4.49152
R5895 VSS.t17 VSS.n868 4.49152
R5896 VSS.n3726 VSS.n3725 4.4712
R5897 VSS.n620 VSS.n604 4.4712
R5898 VSS.n860 VSS.n859 4.4712
R5899 VSS.n1166 VSS.n860 4.46488
R5900 VSS.n3727 VSS.n3726 4.46488
R5901 VSS.n652 VSS.n604 4.46488
R5902 VSS.n3385 VSS.n3384 4.25119
R5903 VSS.n3501 VSS.n304 4.2244
R5904 VSS.n37 VSS.n148 4.19639
R5905 VSS.n3487 VSS.n1 4.19225
R5906 VSS.n3131 VSS.n1332 4.02278
R5907 VSS.n2544 VSS.n2542 4.02278
R5908 VSS.n2543 VSS.n2544 3.84369
R5909 VSS.n3133 VSS.n1332 3.84291
R5910 VSS.n1260 VSS.n779 3.52606
R5911 VSS.n37 VSS.t2 3.37895
R5912 VSS.n3727 VSS.n215 3.37628
R5913 VSS.t302 VSS.n1615 3.34498
R5914 VSS.t288 VSS.n1621 3.34498
R5915 VSS.t286 VSS.n1629 3.34498
R5916 VSS.t304 VSS.n1635 3.34498
R5917 VSS.t244 VSS.n1643 3.34498
R5918 VSS.t306 VSS.n1649 3.34498
R5919 VSS.t312 VSS.n1657 3.34498
R5920 VSS.t308 VSS.n1663 3.34498
R5921 VSS.t292 VSS.n1671 3.34498
R5922 VSS.t248 VSS.n1677 3.34498
R5923 VSS.t296 VSS.n1685 3.34498
R5924 VSS.t314 VSS.n1691 3.34498
R5925 VSS.t316 VSS.n1699 3.34498
R5926 VSS.t284 VSS.n1705 3.34498
R5927 VSS.t310 VSS.n1713 3.34498
R5928 VSS.t300 VSS.n1719 3.34498
R5929 VSS.t298 VSS.n1727 3.34498
R5930 VSS.t294 VSS.n1733 3.34498
R5931 VSS.t246 VSS.n1741 3.34498
R5932 VSS.t320 VSS.n1747 3.34498
R5933 VSS.t318 VSS.n1755 3.34498
R5934 VSS.t322 VSS.n1761 3.34498
R5935 VSS.t290 VSS.n1769 3.34498
R5936 VSS.t326 VSS.n1775 3.34498
R5937 VSS.t242 VSS.n1783 3.34498
R5938 VSS.t330 VSS.n1789 3.34498
R5939 VSS.t328 VSS.n1797 3.34498
R5940 VSS.t332 VSS.n1803 3.34498
R5941 VSS.t324 VSS.n1811 3.34498
R5942 VSS.t334 VSS.n1817 3.34498
R5943 VSS.t336 VSS.n1825 3.34498
R5944 VSS.t338 VSS.n1831 3.34498
R5945 VSS.n2511 VSS.n1277 3.32778
R5946 VSS.n3483 VSS.n1 3.32697
R5947 VSS.n37 VSS.n147 3.32633
R5948 VSS.n598 VSS.n1 3.32623
R5949 VSS.t202 VSS.n1277 3.32615
R5950 VSS.t376 VSS.n1277 3.32615
R5951 VSS.t403 VSS.n1277 3.32615
R5952 VSS.t645 VSS.n1277 3.32615
R5953 VSS.t419 VSS.n1277 3.32615
R5954 VSS.t227 VSS.n1277 3.32615
R5955 VSS.t351 VSS.n1277 3.32615
R5956 VSS.t14 VSS.n1277 3.32615
R5957 VSS.t358 VSS.n1277 3.32615
R5958 VSS.t191 VSS.n1277 3.32615
R5959 VSS.t35 VSS.n1277 3.32615
R5960 VSS.t401 VSS.n1277 3.32615
R5961 VSS.t141 VSS.n1277 3.32615
R5962 VSS.t630 VSS.n1277 3.32615
R5963 VSS.t45 VSS.n1277 3.32615
R5964 VSS.t461 VSS.n1277 3.32615
R5965 VSS.t240 VSS.n1277 3.32615
R5966 VSS.t81 VSS.n1277 3.32615
R5967 VSS.t145 VSS.n1277 3.32615
R5968 VSS.t24 VSS.n1277 3.32615
R5969 VSS.t231 VSS.n1277 3.32615
R5970 VSS.t61 VSS.n1277 3.32615
R5971 VSS.t468 VSS.n1277 3.32615
R5972 VSS.t129 VSS.n1277 3.32615
R5973 VSS.t188 VSS.n1277 3.32615
R5974 VSS.t149 VSS.n1277 3.32615
R5975 VSS.t153 VSS.n1277 3.32615
R5976 VSS.t458 VSS.n1277 3.32615
R5977 VSS.t83 VSS.n1277 3.32615
R5978 VSS.t466 VSS.n1277 3.32615
R5979 VSS.t75 VSS.n1277 3.32615
R5980 VSS.n3855 VSS.n7 3.32615
R5981 VSS.t250 VSS.n305 3.21163
R5982 VSS.n466 VSS.t261 3.21163
R5983 VSS.n92 VSS.n578 3.04274
R5984 VSS.n92 VSS.n575 3.04274
R5985 VSS.n92 VSS.n572 3.04274
R5986 VSS.n92 VSS.n569 3.04274
R5987 VSS.n92 VSS.n566 3.04274
R5988 VSS.n92 VSS.n307 3.04274
R5989 VSS.n92 VSS.n309 3.04274
R5990 VSS.n92 VSS.n557 3.04274
R5991 VSS.n92 VSS.n554 3.04274
R5992 VSS.n92 VSS.n552 3.04274
R5993 VSS.n92 VSS.n549 3.04274
R5994 VSS.n92 VSS.n546 3.04274
R5995 VSS.n92 VSS.n543 3.04274
R5996 VSS.n92 VSS.n540 3.04274
R5997 VSS.n92 VSS.n312 3.04274
R5998 VSS.n92 VSS.n532 3.04274
R5999 VSS.n92 VSS.n529 3.04274
R6000 VSS.n92 VSS.n526 3.04274
R6001 VSS.n92 VSS.n524 3.04274
R6002 VSS.n92 VSS.n521 3.04274
R6003 VSS.n92 VSS.n316 3.04274
R6004 VSS.n92 VSS.n318 3.04274
R6005 VSS.n92 VSS.n321 3.04274
R6006 VSS.n92 VSS.n323 3.04274
R6007 VSS.n92 VSS.n510 3.04274
R6008 VSS.n92 VSS.n507 3.04274
R6009 VSS.n92 VSS.n326 3.04274
R6010 VSS.n92 VSS.n328 3.04274
R6011 VSS.n92 VSS.n330 3.04274
R6012 VSS.n92 VSS.n332 3.04274
R6013 VSS.n92 VSS.n334 3.04274
R6014 VSS.n92 VSS.n495 3.04274
R6015 VSS.n92 VSS.n337 3.04274
R6016 VSS.n92 VSS.n339 3.04274
R6017 VSS.n92 VSS.n487 3.04274
R6018 VSS.n92 VSS.n484 3.04274
R6019 VSS.n92 VSS.n481 3.04274
R6020 VSS.n92 VSS.n342 3.04274
R6021 VSS.n92 VSS.n345 3.04274
R6022 VSS.n92 VSS.n347 3.04274
R6023 VSS.n92 VSS.n349 3.04274
R6024 VSS.n92 VSS.n351 3.04274
R6025 VSS.n92 VSS.n353 3.04274
R6026 VSS.n92 VSS.n356 3.04274
R6027 VSS.n92 VSS.n358 3.04274
R6028 VSS.n92 VSS.n360 3.04274
R6029 VSS.n92 VSS.n362 3.04274
R6030 VSS.n92 VSS.n459 3.04274
R6031 VSS.n92 VSS.n456 3.04274
R6032 VSS.n92 VSS.n366 3.04274
R6033 VSS.n92 VSS.n368 3.04274
R6034 VSS.n92 VSS.n447 3.04274
R6035 VSS.n92 VSS.n444 3.04274
R6036 VSS.n92 VSS.n441 3.04274
R6037 VSS.n92 VSS.n435 3.04274
R6038 VSS.n92 VSS.n372 3.04274
R6039 VSS.n92 VSS.n374 3.04274
R6040 VSS.n92 VSS.n427 3.04274
R6041 VSS.n92 VSS.n424 3.04274
R6042 VSS.n92 VSS.n421 3.04274
R6043 VSS.n92 VSS.n377 3.04274
R6044 VSS.n92 VSS.n380 3.04274
R6045 VSS.n92 VSS.n382 3.04274
R6046 VSS.n92 VSS.n384 3.04274
R6047 VSS.n92 VSS.n386 3.04274
R6048 VSS.n92 VSS.n389 3.04274
R6049 VSS.n388 VSS.n95 3.04274
R6050 VSS.n387 VSS.n95 3.04274
R6051 VSS.n385 VSS.n95 3.04274
R6052 VSS.n383 VSS.n95 3.04274
R6053 VSS.n381 VSS.n95 3.04274
R6054 VSS.n379 VSS.n95 3.04274
R6055 VSS.n416 VSS.n95 3.04274
R6056 VSS.n420 VSS.n95 3.04274
R6057 VSS.n423 VSS.n95 3.04274
R6058 VSS.n426 VSS.n95 3.04274
R6059 VSS.n429 VSS.n95 3.04274
R6060 VSS.n373 VSS.n95 3.04274
R6061 VSS.n434 VSS.n95 3.04274
R6062 VSS.n437 VSS.n95 3.04274
R6063 VSS.n440 VSS.n95 3.04274
R6064 VSS.n443 VSS.n95 3.04274
R6065 VSS.n446 VSS.n95 3.04274
R6066 VSS.n450 VSS.n95 3.04274
R6067 VSS.n367 VSS.n95 3.04274
R6068 VSS.n455 VSS.n95 3.04274
R6069 VSS.n458 VSS.n95 3.04274
R6070 VSS.n462 VSS.n95 3.04274
R6071 VSS.n465 VSS.n95 3.04274
R6072 VSS.n361 VSS.n95 3.04274
R6073 VSS.n359 VSS.n95 3.04274
R6074 VSS.n357 VSS.n95 3.04274
R6075 VSS.n355 VSS.n95 3.04274
R6076 VSS.n352 VSS.n95 3.04274
R6077 VSS.n350 VSS.n95 3.04274
R6078 VSS.n348 VSS.n95 3.04274
R6079 VSS.n346 VSS.n95 3.04274
R6080 VSS.n344 VSS.n95 3.04274
R6081 VSS.n476 VSS.n95 3.04274
R6082 VSS.n480 VSS.n95 3.04274
R6083 VSS.n483 VSS.n95 3.04274
R6084 VSS.n486 VSS.n95 3.04274
R6085 VSS.n489 VSS.n95 3.04274
R6086 VSS.n338 VSS.n95 3.04274
R6087 VSS.n494 VSS.n95 3.04274
R6088 VSS.n497 VSS.n95 3.04274
R6089 VSS.n333 VSS.n95 3.04274
R6090 VSS.n331 VSS.n95 3.04274
R6091 VSS.n329 VSS.n95 3.04274
R6092 VSS.n327 VSS.n95 3.04274
R6093 VSS.n506 VSS.n95 3.04274
R6094 VSS.n509 VSS.n95 3.04274
R6095 VSS.n513 VSS.n95 3.04274
R6096 VSS.n322 VSS.n95 3.04274
R6097 VSS.n317 VSS.n95 3.04274
R6098 VSS.n520 VSS.n95 3.04274
R6099 VSS.n523 VSS.n95 3.04274
R6100 VSS.n525 VSS.n95 3.04274
R6101 VSS.n528 VSS.n95 3.04274
R6102 VSS.n531 VSS.n95 3.04274
R6103 VSS.n535 VSS.n95 3.04274
R6104 VSS.n311 VSS.n95 3.04274
R6105 VSS.n542 VSS.n95 3.04274
R6106 VSS.n545 VSS.n95 3.04274
R6107 VSS.n548 VSS.n95 3.04274
R6108 VSS.n551 VSS.n95 3.04274
R6109 VSS.n553 VSS.n95 3.04274
R6110 VSS.n556 VSS.n95 3.04274
R6111 VSS.n560 VSS.n95 3.04274
R6112 VSS.n308 VSS.n95 3.04274
R6113 VSS.n306 VSS.n95 3.04274
R6114 VSS.n568 VSS.n95 3.04274
R6115 VSS.n571 VSS.n95 3.04274
R6116 VSS.n574 VSS.n95 3.04274
R6117 VSS.n577 VSS.n95 3.04274
R6118 VSS.n3859 VSS.n106 2.93359
R6119 VSS.n1839 VSS.n1277 2.77706
R6120 VSS.n3725 VSS.n3724 2.7456
R6121 VSS.n719 VSS.n688 2.74446
R6122 VSS.n3476 VSS.n1 2.74397
R6123 VSS.t151 VSS.n1277 2.74386
R6124 VSS.t58 VSS.n619 2.72142
R6125 VSS.n2799 VSS.t124 2.46412
R6126 VSS.n688 VSS.n687 2.46343
R6127 VSS.n688 VSS.n686 2.46343
R6128 VSS.n688 VSS.n685 2.46343
R6129 VSS.n688 VSS.n666 2.46343
R6130 VSS.n688 VSS.n667 2.46343
R6131 VSS.n688 VSS.n668 2.46343
R6132 VSS.n688 VSS.n669 2.46343
R6133 VSS.n688 VSS.n683 2.46343
R6134 VSS.n688 VSS.n682 2.46343
R6135 VSS.n688 VSS.n681 2.46343
R6136 VSS.n688 VSS.n680 2.46343
R6137 VSS.n688 VSS.n671 2.46343
R6138 VSS.n688 VSS.n672 2.46343
R6139 VSS.n688 VSS.n673 2.46343
R6140 VSS.n688 VSS.n674 2.46343
R6141 VSS.n688 VSS.n675 2.46343
R6142 VSS.n688 VSS.n676 2.46343
R6143 VSS.n688 VSS.n678 2.46343
R6144 VSS.n3730 VSS.n3727 2.43862
R6145 VSS.n37 VSS.n146 2.01633
R6146 VSS.t58 VSS.n617 1.97632
R6147 VSS.t58 VSS.n614 1.88189
R6148 VSS.n640 VSS.n637 1.88189
R6149 VSS.n3725 VSS.n149 1.83435
R6150 VSS.n3362 VSS.n7 1.7562
R6151 VSS.n7 VSS.n5 1.75596
R6152 VSS.n3472 VSS.n1 1.75507
R6153 VSS.n3484 VSS.n605 1.66925
R6154 VSS.n3204 VSS.n1277 1.63922
R6155 VSS.n1598 VSS.n1277 1.63922
R6156 VSS.n1603 VSS.n1277 1.63922
R6157 VSS.n1606 VSS.n1277 1.63922
R6158 VSS.n1608 VSS.n1277 1.63922
R6159 VSS.t95 VSS.n698 1.43372
R6160 VSS.n690 VSS.t97 1.43372
R6161 VSS.n3258 VSS.t97 1.42949
R6162 VSS.t95 VSS.n3259 1.42949
R6163 VSS.t179 VSS.t175 1.41892
R6164 VSS.t177 VSS.t173 1.41892
R6165 VSS.t178 VSS.t171 1.41892
R6166 VSS.t176 VSS.t169 1.41892
R6167 VSS.t92 VSS.n772 1.37661
R6168 VSS.n771 VSS.t92 1.37661
R6169 VSS.n1885 VSS.n1277 1.35577
R6170 VSS.n37 VSS.n152 1.32857
R6171 VSS.n644 VSS.n643 1.3114
R6172 VSS.n3809 VSS.n3808 0.85096
R6173 VSS.n3499 VSS.n580 0.810955
R6174 VSS.t115 VSS.t69 0.806856
R6175 VSS.n608 VSS.t103 0.806855
R6176 VSS.t109 VSS.n594 0.806855
R6177 VSS.n1116 VSS.n579 0.805602
R6178 VSS.t339 VSS.n1893 0.802775
R6179 VSS.t303 VSS.n2151 0.802775
R6180 VSS.n2130 VSS.t289 0.802775
R6181 VSS.n2124 VSS.t287 0.802775
R6182 VSS.n2114 VSS.t305 0.802775
R6183 VSS.n2108 VSS.t245 0.802775
R6184 VSS.n2098 VSS.t307 0.802775
R6185 VSS.n2092 VSS.t313 0.802775
R6186 VSS.n2082 VSS.t309 0.802775
R6187 VSS.n2076 VSS.t293 0.802775
R6188 VSS.n2066 VSS.t249 0.802775
R6189 VSS.n2060 VSS.t297 0.802775
R6190 VSS.n2050 VSS.t315 0.802775
R6191 VSS.n2044 VSS.t317 0.802775
R6192 VSS.n2034 VSS.t285 0.802775
R6193 VSS.n2028 VSS.t311 0.802775
R6194 VSS.n2018 VSS.t301 0.802775
R6195 VSS.n2012 VSS.t299 0.802775
R6196 VSS.n2002 VSS.t295 0.802775
R6197 VSS.n1996 VSS.t247 0.802775
R6198 VSS.n1986 VSS.t321 0.802775
R6199 VSS.n1980 VSS.t319 0.802775
R6200 VSS.n1970 VSS.t323 0.802775
R6201 VSS.n1964 VSS.t291 0.802775
R6202 VSS.n1954 VSS.t327 0.802775
R6203 VSS.n1948 VSS.t243 0.802775
R6204 VSS.n1938 VSS.t331 0.802775
R6205 VSS.n1932 VSS.t329 0.802775
R6206 VSS.n1922 VSS.t333 0.802775
R6207 VSS.n1916 VSS.t325 0.802775
R6208 VSS.n1906 VSS.t335 0.802775
R6209 VSS.n1899 VSS.t337 0.802775
R6210 VSS.t7 VSS.t122 0.802775
R6211 VSS.t272 VSS.n597 0.802775
R6212 VSS.n652 VSS.n651 0.801519
R6213 VSS.n72 VSS.n37 0.143988
R6214 VSS.n583 VSS.n579 0.768682
R6215 VSS.t123 VSS.n1887 0.723599
R6216 VSS.n3267 VSS.t179 0.722582
R6217 VSS.n3253 VSS.t177 0.722582
R6218 VSS.n3277 VSS.t178 0.722582
R6219 VSS.n3287 VSS.t176 0.722582
R6220 VSS.n3443 VSS.t175 0.72222
R6221 VSS.n3434 VSS.t173 0.72222
R6222 VSS.n3432 VSS.t171 0.72222
R6223 VSS.t169 VSS.n713 0.72222
R6224 VSS.n37 VSS.n58 0.721231
R6225 VSS.n37 VSS.n70 0.720881
R6226 VSS.n37 VSS.n69 0.720881
R6227 VSS.n37 VSS.n68 0.720881
R6228 VSS.n37 VSS.n67 0.720881
R6229 VSS.n37 VSS.n66 0.720881
R6230 VSS.n37 VSS.n65 0.720881
R6231 VSS.n37 VSS.n64 0.720881
R6232 VSS.n37 VSS.n63 0.720881
R6233 VSS.n37 VSS.n62 0.720881
R6234 VSS.n37 VSS.n61 0.720881
R6235 VSS.n37 VSS.n60 0.720881
R6236 VSS.n37 VSS.n59 0.720881
R6237 VSS.n3493 VSS.n3492 0.6955
R6238 VSS.n3858 VSS.n107 0.692362
R6239 VSS.n3408 VSS.n3407 0.692362
R6240 VSS.n2491 VSS.n2490 0.692362
R6241 VSS.n2482 VSS.n2481 0.692362
R6242 VSS.n2473 VSS.n2472 0.692362
R6243 VSS.n2464 VSS.n2463 0.692362
R6244 VSS.n2455 VSS.n2454 0.692362
R6245 VSS.n2446 VSS.n2445 0.692362
R6246 VSS.n2437 VSS.n2436 0.692362
R6247 VSS.n2428 VSS.n2427 0.692362
R6248 VSS.n2419 VSS.n2418 0.692362
R6249 VSS.n2410 VSS.n2409 0.692362
R6250 VSS.n2401 VSS.n2400 0.692362
R6251 VSS.n2392 VSS.n2391 0.692362
R6252 VSS.n2383 VSS.n2382 0.692362
R6253 VSS.n2374 VSS.n2373 0.692362
R6254 VSS.n2365 VSS.n2364 0.692362
R6255 VSS.n2356 VSS.n2355 0.692362
R6256 VSS.n2347 VSS.n2346 0.692362
R6257 VSS.n2338 VSS.n2337 0.692362
R6258 VSS.n2329 VSS.n2328 0.692362
R6259 VSS.n2320 VSS.n2319 0.692362
R6260 VSS.n2311 VSS.n2310 0.692362
R6261 VSS.n2302 VSS.n2301 0.692362
R6262 VSS.n2293 VSS.n2292 0.692362
R6263 VSS.n2284 VSS.n2283 0.692362
R6264 VSS.n2275 VSS.n2274 0.692362
R6265 VSS.n2266 VSS.n2265 0.692362
R6266 VSS.n2257 VSS.n2256 0.692362
R6267 VSS.n2248 VSS.n2247 0.692362
R6268 VSS.n2239 VSS.n2238 0.692362
R6269 VSS.n2230 VSS.n2229 0.692362
R6270 VSS.n2221 VSS.n2220 0.692362
R6271 VSS.n860 VSS.n604 0.66578
R6272 VSS.n92 VSS.n579 0.649291
R6273 VSS.n3203 VSS.n1278 0.613782
R6274 VSS.n3200 VSS.n1278 0.613782
R6275 VSS.n3195 VSS.n1278 0.613782
R6276 VSS.n3192 VSS.n1278 0.613782
R6277 VSS.n3190 VSS.n1278 0.613782
R6278 VSS.n3187 VSS.n1278 0.613782
R6279 VSS.n3074 VSS.n1349 0.613782
R6280 VSS.n3027 VSS.n1388 0.613782
R6281 VSS.n2980 VSS.n1427 0.613782
R6282 VSS.n2980 VSS.n1462 0.613782
R6283 VSS.n2894 VSS.n1511 0.613782
R6284 VSS.n2847 VSS.n1550 0.613782
R6285 VSS.n2800 VSS.n1592 0.613782
R6286 VSS.n2500 VSS.t117 0.595317
R6287 VSS.n2498 VSS.t119 0.595317
R6288 VSS.t105 VSS.n602 0.595317
R6289 VSS.n601 VSS.t108 0.595317
R6290 VSS.t111 VSS.n592 0.595317
R6291 VSS.n591 VSS.t114 0.595317
R6292 VSS.t388 VSS.n617 0.586866
R6293 VSS.t131 VSS.n791 0.572871
R6294 VSS.t133 VSS.n856 0.572871
R6295 VSS.n3461 VSS.t58 0.557126
R6296 VSS.n1610 VSS.n1277 0.556788
R6297 VSS.n3451 VSS.n3450 0.548518
R6298 VSS.n3472 VSS.n3471 0.52186
R6299 VSS.t97 VSS.t95 0.492336
R6300 VSS.n1216 VSS.n813 0.490843
R6301 VSS.n1216 VSS.n826 0.490843
R6302 VSS.n1216 VSS.n820 0.490843
R6303 VSS.n1142 VSS.n874 0.490843
R6304 VSS.t131 VSS.n789 0.489061
R6305 VSS.t133 VSS.n854 0.489061
R6306 VSS.n3457 VSS.t58 0.477286
R6307 VSS.n3458 VSS.t58 0.472981
R6308 VSS.n757 VSS.n756 0.461741
R6309 VSS.n766 VSS.n764 0.461741
R6310 VSS.n2569 VSS.n2144 0.461741
R6311 VSS.n2579 VSS.n2578 0.461741
R6312 VSS.n2589 VSS.n2127 0.461741
R6313 VSS.n2595 VSS.n2118 0.461741
R6314 VSS.n2603 VSS.n2111 0.461741
R6315 VSS.n2609 VSS.n2102 0.461741
R6316 VSS.n2617 VSS.n2095 0.461741
R6317 VSS.n2623 VSS.n2086 0.461741
R6318 VSS.n2631 VSS.n2079 0.461741
R6319 VSS.n2637 VSS.n2070 0.461741
R6320 VSS.n2645 VSS.n2063 0.461741
R6321 VSS.n2651 VSS.n2054 0.461741
R6322 VSS.n2659 VSS.n2047 0.461741
R6323 VSS.n2665 VSS.n2038 0.461741
R6324 VSS.n2673 VSS.n2031 0.461741
R6325 VSS.n2679 VSS.n2022 0.461741
R6326 VSS.n2687 VSS.n2015 0.461741
R6327 VSS.n2693 VSS.n2006 0.461741
R6328 VSS.n2701 VSS.n1999 0.461741
R6329 VSS.n2707 VSS.n1990 0.461741
R6330 VSS.n2715 VSS.n1983 0.461741
R6331 VSS.n2721 VSS.n1974 0.461741
R6332 VSS.n2729 VSS.n1967 0.461741
R6333 VSS.n2735 VSS.n1958 0.461741
R6334 VSS.n2743 VSS.n1951 0.461741
R6335 VSS.n2749 VSS.n1942 0.461741
R6336 VSS.n2757 VSS.n1935 0.461741
R6337 VSS.n2763 VSS.n1926 0.461741
R6338 VSS.n2771 VSS.n1919 0.461741
R6339 VSS.n2777 VSS.n1910 0.461741
R6340 VSS.n2785 VSS.n1903 0.461741
R6341 VSS.n1901 VSS.n1896 0.461741
R6342 VSS.n3473 VSS.n3472 0.447348
R6343 VSS.n2544 VSS.n1332 0.44402
R6344 VSS.n662 VSS.n658 0.437466
R6345 VSS.n776 VSS.n106 0.427593
R6346 VSS.n3362 VSS.n3361 0.417336
R6347 VSS.n3856 VSS.n5 0.417043
R6348 VSS.n3361 VSS.n5 0.416074
R6349 VSS.n3363 VSS.n3362 0.415796
R6350 VSS.n3485 VSS.n604 0.41058
R6351 VSS.n617 VSS.n632 0.407016
R6352 VSS.n1275 VSS.t163 0.400619
R6353 VSS.n691 VSS.n146 0.36227
R6354 VSS.n620 VSS.n619 0.354963
R6355 VSS.n3469 VSS.n1 0.351198
R6356 VSS.n2506 VSS.n2505 0.346431
R6357 VSS.n639 VSS.n583 0.345789
R6358 VSS.n3405 VSS.n719 0.330049
R6359 VSS.n3477 VSS.n3476 0.312321
R6360 VSS.n3853 VSS.n109 0.31114
R6361 VSS.t339 VSS.t151 0.302137
R6362 VSS.t123 VSS.n1885 0.30061
R6363 VSS.n649 VSS.n619 0.296592
R6364 VSS.n3483 VSS.n3482 0.291601
R6365 VSS.n2512 VSS.n2511 0.289639
R6366 VSS.n3484 VSS.n3483 0.287886
R6367 VSS.t94 VSS.n768 0.286439
R6368 VSS.n1117 VSS.n1116 0.2855
R6369 VSS.n2488 VSS.t75 0.28485
R6370 VSS.n2479 VSS.t466 0.28485
R6371 VSS.n2470 VSS.t83 0.28485
R6372 VSS.n2461 VSS.t458 0.28485
R6373 VSS.n2452 VSS.t153 0.28485
R6374 VSS.n2443 VSS.t149 0.28485
R6375 VSS.n2434 VSS.t188 0.28485
R6376 VSS.n2425 VSS.t129 0.28485
R6377 VSS.n2416 VSS.t468 0.28485
R6378 VSS.n2407 VSS.t61 0.28485
R6379 VSS.n2398 VSS.t231 0.28485
R6380 VSS.n2389 VSS.t24 0.28485
R6381 VSS.n2380 VSS.t145 0.28485
R6382 VSS.n2371 VSS.t81 0.28485
R6383 VSS.n2362 VSS.t240 0.28485
R6384 VSS.n2353 VSS.t461 0.28485
R6385 VSS.n2344 VSS.t45 0.28485
R6386 VSS.n2335 VSS.t630 0.28485
R6387 VSS.n2326 VSS.t141 0.28485
R6388 VSS.n2317 VSS.t401 0.28485
R6389 VSS.n2308 VSS.t35 0.28485
R6390 VSS.n2299 VSS.t191 0.28485
R6391 VSS.n2290 VSS.t358 0.28485
R6392 VSS.n2281 VSS.t14 0.28485
R6393 VSS.n2272 VSS.t351 0.28485
R6394 VSS.n2263 VSS.t227 0.28485
R6395 VSS.n2254 VSS.t419 0.28485
R6396 VSS.n2245 VSS.t645 0.28485
R6397 VSS.n2236 VSS.t403 0.28485
R6398 VSS.n2227 VSS.t376 0.28485
R6399 VSS.n2218 VSS.t202 0.28485
R6400 VSS.n2511 VSS.n2510 0.28352
R6401 VSS.t272 VSS.n598 0.275903
R6402 VSS.n1838 VSS.n1277 0.267794
R6403 VSS.n1816 VSS.n1277 0.267794
R6404 VSS.n1813 VSS.n1277 0.267794
R6405 VSS.n1810 VSS.n1277 0.267794
R6406 VSS.n1809 VSS.n1277 0.267794
R6407 VSS.n1799 VSS.n1277 0.267794
R6408 VSS.n1796 VSS.n1277 0.267794
R6409 VSS.n1795 VSS.n1277 0.267794
R6410 VSS.n1788 VSS.n1277 0.267794
R6411 VSS.n1785 VSS.n1277 0.267794
R6412 VSS.n1782 VSS.n1277 0.267794
R6413 VSS.n1781 VSS.n1277 0.267794
R6414 VSS.n1774 VSS.n1277 0.267794
R6415 VSS.n1768 VSS.n1277 0.267794
R6416 VSS.n1767 VSS.n1277 0.267794
R6417 VSS.n1754 VSS.n1277 0.267794
R6418 VSS.n1746 VSS.n1277 0.267794
R6419 VSS.n1740 VSS.n1277 0.267794
R6420 VSS.n1739 VSS.n1277 0.267794
R6421 VSS.n1726 VSS.n1277 0.267794
R6422 VSS.n1725 VSS.n1277 0.267794
R6423 VSS.n1718 VSS.n1277 0.267794
R6424 VSS.n1715 VSS.n1277 0.267794
R6425 VSS.n1712 VSS.n1277 0.267794
R6426 VSS.n1704 VSS.n1277 0.267794
R6427 VSS.n1684 VSS.n1277 0.267794
R6428 VSS.n1683 VSS.n1277 0.267794
R6429 VSS.n1676 VSS.n1277 0.267794
R6430 VSS.n1673 VSS.n1277 0.267794
R6431 VSS.n1670 VSS.n1277 0.267794
R6432 VSS.n1669 VSS.n1277 0.267794
R6433 VSS.n1662 VSS.n1277 0.267794
R6434 VSS.n1656 VSS.n1277 0.267794
R6435 VSS.n1655 VSS.n1277 0.267794
R6436 VSS.n1645 VSS.n1277 0.267794
R6437 VSS.n1642 VSS.n1277 0.267794
R6438 VSS.n1641 VSS.n1277 0.267794
R6439 VSS.n1634 VSS.n1277 0.267794
R6440 VSS.n1631 VSS.n1277 0.267794
R6441 VSS.n1628 VSS.n1277 0.267794
R6442 VSS.n1627 VSS.n1277 0.267794
R6443 VSS.n1620 VSS.n1277 0.267794
R6444 VSS.n1617 VSS.n1277 0.267794
R6445 VSS.n1611 VSS.n1277 0.267794
R6446 VSS.n1614 VSS.n1277 0.267794
R6447 VSS.n1648 VSS.n1277 0.267794
R6448 VSS.n1659 VSS.n1277 0.267794
R6449 VSS.n1687 VSS.n1277 0.267794
R6450 VSS.n1690 VSS.n1277 0.267794
R6451 VSS.n1697 VSS.n1277 0.267794
R6452 VSS.n1698 VSS.n1277 0.267794
R6453 VSS.n1701 VSS.n1277 0.267794
R6454 VSS.n1711 VSS.n1277 0.267794
R6455 VSS.n1729 VSS.n1277 0.267794
R6456 VSS.n1732 VSS.n1277 0.267794
R6457 VSS.n1743 VSS.n1277 0.267794
R6458 VSS.n1753 VSS.n1277 0.267794
R6459 VSS.n1757 VSS.n1277 0.267794
R6460 VSS.n1760 VSS.n1277 0.267794
R6461 VSS.n1771 VSS.n1277 0.267794
R6462 VSS.n1802 VSS.n1277 0.267794
R6463 VSS.n1823 VSS.n1277 0.267794
R6464 VSS.n1824 VSS.n1277 0.267794
R6465 VSS.n1827 VSS.n1277 0.267794
R6466 VSS.n1830 VSS.n1277 0.267794
R6467 VSS.n598 VSS.n601 0.266315
R6468 VSS.n3856 VSS.n3855 0.266107
R6469 VSS.n3855 VSS.n3854 0.2636
R6470 VSS.t75 VSS.t303 0.256107
R6471 VSS.t466 VSS.t289 0.256107
R6472 VSS.t83 VSS.t287 0.256107
R6473 VSS.t458 VSS.t305 0.256107
R6474 VSS.t153 VSS.t245 0.256107
R6475 VSS.t149 VSS.t307 0.256107
R6476 VSS.t188 VSS.t313 0.256107
R6477 VSS.t129 VSS.t309 0.256107
R6478 VSS.t468 VSS.t293 0.256107
R6479 VSS.t61 VSS.t249 0.256107
R6480 VSS.t231 VSS.t297 0.256107
R6481 VSS.t24 VSS.t315 0.256107
R6482 VSS.t145 VSS.t317 0.256107
R6483 VSS.t81 VSS.t285 0.256107
R6484 VSS.t240 VSS.t311 0.256107
R6485 VSS.t461 VSS.t301 0.256107
R6486 VSS.t45 VSS.t299 0.256107
R6487 VSS.t630 VSS.t295 0.256107
R6488 VSS.t141 VSS.t247 0.256107
R6489 VSS.t401 VSS.t321 0.256107
R6490 VSS.t35 VSS.t319 0.256107
R6491 VSS.t191 VSS.t323 0.256107
R6492 VSS.t358 VSS.t291 0.256107
R6493 VSS.t14 VSS.t327 0.256107
R6494 VSS.t351 VSS.t243 0.256107
R6495 VSS.t227 VSS.t331 0.256107
R6496 VSS.t419 VSS.t329 0.256107
R6497 VSS.t645 VSS.t333 0.256107
R6498 VSS.t403 VSS.t325 0.256107
R6499 VSS.t376 VSS.t335 0.256107
R6500 VSS.t202 VSS.t337 0.256107
R6501 VSS.t151 VSS.t122 0.254637
R6502 VSS.t124 VSS.n1885 0.253987
R6503 VSS.n3450 VSS.n146 0.248324
R6504 VSS.n3495 VSS.n3494 0.244498
R6505 VSS.n588 VSS.n587 0.24416
R6506 VSS.t4 VSS.n623 0.240825
R6507 VSS.n3383 VSS.n736 0.239006
R6508 VSS.n3368 VSS.n3367 0.238668
R6509 VSS.n410 VSS.n409 0.238582
R6510 VSS.n3476 VSS.n597 0.238218
R6511 VSS.n3410 VSS.n719 0.236768
R6512 VSS.n691 VSS.n147 0.235797
R6513 VSS.n3498 VSS.n3497 0.234049
R6514 VSS.n395 VSS.n394 0.233757
R6515 VSS.n398 VSS.n397 0.233757
R6516 VSS.n407 VSS.n406 0.233757
R6517 VSS.n394 VSS.n75 0.233419
R6518 VSS.n397 VSS.n396 0.233419
R6519 VSS.n406 VSS.n405 0.233419
R6520 VSS.n3132 VSS.n1330 0.231121
R6521 VSS.n1330 VSS.n1329 0.231121
R6522 VSS.n1329 VSS.n1327 0.231121
R6523 VSS.n1327 VSS.n1326 0.231121
R6524 VSS.n1326 VSS.n1325 0.231121
R6525 VSS.n1325 VSS.n1323 0.231121
R6526 VSS.n1323 VSS.n1321 0.231121
R6527 VSS.n1321 VSS.n1320 0.231121
R6528 VSS.n1320 VSS.n1319 0.231121
R6529 VSS.n1319 VSS.n1317 0.231121
R6530 VSS.n1317 VSS.n1315 0.231121
R6531 VSS.n1315 VSS.n1314 0.231121
R6532 VSS.n1314 VSS.n1313 0.231121
R6533 VSS.n1313 VSS.n1311 0.231121
R6534 VSS.n1311 VSS.n1309 0.231121
R6535 VSS.n1309 VSS.n1308 0.231121
R6536 VSS.n1308 VSS.n1306 0.231121
R6537 VSS.n1306 VSS.n1305 0.231121
R6538 VSS.n1305 VSS.n1303 0.231121
R6539 VSS.n1303 VSS.n1301 0.231121
R6540 VSS.n1301 VSS.n1300 0.231121
R6541 VSS.n1300 VSS.n1299 0.231121
R6542 VSS.n1299 VSS.n1298 0.231121
R6543 VSS.n1298 VSS.n1297 0.231121
R6544 VSS.n1297 VSS.n1296 0.231121
R6545 VSS.n1296 VSS.n1295 0.231121
R6546 VSS.n1295 VSS.n1294 0.231121
R6547 VSS.n1294 VSS.n1293 0.231121
R6548 VSS.n1293 VSS.n1292 0.231121
R6549 VSS.n1292 VSS.n1291 0.231121
R6550 VSS.n1291 VSS.n1290 0.231121
R6551 VSS.n1290 VSS.n1289 0.231121
R6552 VSS.n1289 VSS.n1287 0.231121
R6553 VSS.n1287 VSS.n1286 0.231121
R6554 VSS.n1286 VSS.n1285 0.231121
R6555 VSS.n3094 VSS.n1285 0.231121
R6556 VSS.n3094 VSS.n3093 0.231121
R6557 VSS.n3093 VSS.n3092 0.231121
R6558 VSS.n3092 VSS.n1334 0.231121
R6559 VSS.n3088 VSS.n1334 0.231121
R6560 VSS.n3088 VSS.n1336 0.231121
R6561 VSS.n3080 VSS.n1336 0.231121
R6562 VSS.n3080 VSS.n1344 0.231121
R6563 VSS.n3076 VSS.n1344 0.231121
R6564 VSS.n3076 VSS.n1346 0.231121
R6565 VSS.n3061 VSS.n1346 0.231121
R6566 VSS.n3061 VSS.n3060 0.231121
R6567 VSS.n3065 VSS.n3060 0.231121
R6568 VSS.n3066 VSS.n3065 0.231121
R6569 VSS.n3067 VSS.n3066 0.231121
R6570 VSS.n3067 VSS.n1364 0.231121
R6571 VSS.n3071 VSS.n1364 0.231121
R6572 VSS.n3071 VSS.n1362 0.231121
R6573 VSS.n3053 VSS.n1362 0.231121
R6574 VSS.n3053 VSS.n3051 0.231121
R6575 VSS.n3051 VSS.n1366 0.231121
R6576 VSS.n1374 VSS.n1366 0.231121
R6577 VSS.n3046 VSS.n1374 0.231121
R6578 VSS.n3046 VSS.n1373 0.231121
R6579 VSS.n3040 VSS.n1373 0.231121
R6580 VSS.n3040 VSS.n1376 0.231121
R6581 VSS.n3033 VSS.n1376 0.231121
R6582 VSS.n3033 VSS.n1383 0.231121
R6583 VSS.n3029 VSS.n1383 0.231121
R6584 VSS.n3029 VSS.n1385 0.231121
R6585 VSS.n3014 VSS.n1385 0.231121
R6586 VSS.n3014 VSS.n3013 0.231121
R6587 VSS.n3018 VSS.n3013 0.231121
R6588 VSS.n3019 VSS.n3018 0.231121
R6589 VSS.n3020 VSS.n3019 0.231121
R6590 VSS.n3020 VSS.n1403 0.231121
R6591 VSS.n3024 VSS.n1403 0.231121
R6592 VSS.n3024 VSS.n1401 0.231121
R6593 VSS.n3006 VSS.n1401 0.231121
R6594 VSS.n3006 VSS.n3004 0.231121
R6595 VSS.n3004 VSS.n1405 0.231121
R6596 VSS.n1413 VSS.n1405 0.231121
R6597 VSS.n2999 VSS.n1413 0.231121
R6598 VSS.n2999 VSS.n1412 0.231121
R6599 VSS.n2993 VSS.n1412 0.231121
R6600 VSS.n2993 VSS.n1415 0.231121
R6601 VSS.n2986 VSS.n1415 0.231121
R6602 VSS.n2986 VSS.n1422 0.231121
R6603 VSS.n2982 VSS.n1422 0.231121
R6604 VSS.n2982 VSS.n1424 0.231121
R6605 VSS.n2967 VSS.n1424 0.231121
R6606 VSS.n2967 VSS.n2966 0.231121
R6607 VSS.n2971 VSS.n2966 0.231121
R6608 VSS.n2972 VSS.n2971 0.231121
R6609 VSS.n2973 VSS.n2972 0.231121
R6610 VSS.n2973 VSS.n1468 0.231121
R6611 VSS.n2977 VSS.n1468 0.231121
R6612 VSS.n2977 VSS.n1466 0.231121
R6613 VSS.n2959 VSS.n1466 0.231121
R6614 VSS.n2959 VSS.n2957 0.231121
R6615 VSS.n2957 VSS.n2955 0.231121
R6616 VSS.n2955 VSS.n1471 0.231121
R6617 VSS.n2951 VSS.n1471 0.231121
R6618 VSS.n2951 VSS.n2949 0.231121
R6619 VSS.n2949 VSS.n2947 0.231121
R6620 VSS.n2947 VSS.n1475 0.231121
R6621 VSS.n2943 VSS.n1475 0.231121
R6622 VSS.n2943 VSS.n2941 0.231121
R6623 VSS.n2941 VSS.n2939 0.231121
R6624 VSS.n2939 VSS.n1479 0.231121
R6625 VSS.n2935 VSS.n1479 0.231121
R6626 VSS.n2935 VSS.n2934 0.231121
R6627 VSS.n2934 VSS.n2932 0.231121
R6628 VSS.n2932 VSS.n1483 0.231121
R6629 VSS.n2928 VSS.n1483 0.231121
R6630 VSS.n2928 VSS.n2926 0.231121
R6631 VSS.n2926 VSS.n2924 0.231121
R6632 VSS.n2924 VSS.n1487 0.231121
R6633 VSS.n2920 VSS.n1487 0.231121
R6634 VSS.n2920 VSS.n2918 0.231121
R6635 VSS.n2918 VSS.n1489 0.231121
R6636 VSS.n1497 VSS.n1489 0.231121
R6637 VSS.n2913 VSS.n1497 0.231121
R6638 VSS.n2913 VSS.n1496 0.231121
R6639 VSS.n2907 VSS.n1496 0.231121
R6640 VSS.n2907 VSS.n1499 0.231121
R6641 VSS.n2900 VSS.n1499 0.231121
R6642 VSS.n2900 VSS.n1506 0.231121
R6643 VSS.n2896 VSS.n1506 0.231121
R6644 VSS.n2896 VSS.n1508 0.231121
R6645 VSS.n2881 VSS.n1508 0.231121
R6646 VSS.n2881 VSS.n2880 0.231121
R6647 VSS.n2885 VSS.n2880 0.231121
R6648 VSS.n2886 VSS.n2885 0.231121
R6649 VSS.n2887 VSS.n2886 0.231121
R6650 VSS.n2887 VSS.n1526 0.231121
R6651 VSS.n2891 VSS.n1526 0.231121
R6652 VSS.n2891 VSS.n1524 0.231121
R6653 VSS.n2873 VSS.n1524 0.231121
R6654 VSS.n2873 VSS.n2871 0.231121
R6655 VSS.n2871 VSS.n1528 0.231121
R6656 VSS.n1536 VSS.n1528 0.231121
R6657 VSS.n2866 VSS.n1536 0.231121
R6658 VSS.n2866 VSS.n1535 0.231121
R6659 VSS.n2860 VSS.n1535 0.231121
R6660 VSS.n2860 VSS.n1538 0.231121
R6661 VSS.n2853 VSS.n1538 0.231121
R6662 VSS.n2853 VSS.n1545 0.231121
R6663 VSS.n2849 VSS.n1545 0.231121
R6664 VSS.n2849 VSS.n1547 0.231121
R6665 VSS.n2834 VSS.n1547 0.231121
R6666 VSS.n2834 VSS.n2833 0.231121
R6667 VSS.n2838 VSS.n2833 0.231121
R6668 VSS.n2839 VSS.n2838 0.231121
R6669 VSS.n2840 VSS.n2839 0.231121
R6670 VSS.n2840 VSS.n1565 0.231121
R6671 VSS.n2844 VSS.n1565 0.231121
R6672 VSS.n2844 VSS.n1563 0.231121
R6673 VSS.n2826 VSS.n1563 0.231121
R6674 VSS.n2826 VSS.n2824 0.231121
R6675 VSS.n2824 VSS.n1567 0.231121
R6676 VSS.n1575 VSS.n1567 0.231121
R6677 VSS.n2819 VSS.n1575 0.231121
R6678 VSS.n2819 VSS.n1574 0.231121
R6679 VSS.n2813 VSS.n1574 0.231121
R6680 VSS.n2813 VSS.n1577 0.231121
R6681 VSS.n2806 VSS.n1577 0.231121
R6682 VSS.n2806 VSS.n1584 0.231121
R6683 VSS.n2802 VSS.n1584 0.231121
R6684 VSS.n2802 VSS.n1586 0.231121
R6685 VSS.n1861 VSS.n1586 0.231121
R6686 VSS.n1863 VSS.n1861 0.231121
R6687 VSS.n1864 VSS.n1863 0.231121
R6688 VSS.n1866 VSS.n1864 0.231121
R6689 VSS.n1868 VSS.n1866 0.231121
R6690 VSS.n1870 VSS.n1868 0.231121
R6691 VSS.n1871 VSS.n1870 0.231121
R6692 VSS.n1873 VSS.n1871 0.231121
R6693 VSS.n1875 VSS.n1873 0.231121
R6694 VSS.n1877 VSS.n1875 0.231121
R6695 VSS.n1879 VSS.n1877 0.231121
R6696 VSS.n1881 VSS.n1879 0.231121
R6697 VSS.n1881 VSS.n1849 0.231121
R6698 VSS.n3131 VSS.n3130 0.231121
R6699 VSS.n3130 VSS.n3129 0.231121
R6700 VSS.n3129 VSS.n3128 0.231121
R6701 VSS.n3128 VSS.n3127 0.231121
R6702 VSS.n3127 VSS.n3126 0.231121
R6703 VSS.n3126 VSS.n3125 0.231121
R6704 VSS.n3125 VSS.n3124 0.231121
R6705 VSS.n3124 VSS.n3123 0.231121
R6706 VSS.n3123 VSS.n3122 0.231121
R6707 VSS.n3122 VSS.n3121 0.231121
R6708 VSS.n3121 VSS.n3120 0.231121
R6709 VSS.n3120 VSS.n3119 0.231121
R6710 VSS.n3119 VSS.n3118 0.231121
R6711 VSS.n3118 VSS.n3117 0.231121
R6712 VSS.n3117 VSS.n3116 0.231121
R6713 VSS.n3116 VSS.n3115 0.231121
R6714 VSS.n3115 VSS.n3114 0.231121
R6715 VSS.n3114 VSS.n3113 0.231121
R6716 VSS.n3113 VSS.n3112 0.231121
R6717 VSS.n3112 VSS.n3111 0.231121
R6718 VSS.n3111 VSS.n3110 0.231121
R6719 VSS.n3110 VSS.n3109 0.231121
R6720 VSS.n3109 VSS.n3108 0.231121
R6721 VSS.n3108 VSS.n3107 0.231121
R6722 VSS.n3107 VSS.n3106 0.231121
R6723 VSS.n3106 VSS.n3105 0.231121
R6724 VSS.n3105 VSS.n3104 0.231121
R6725 VSS.n3104 VSS.n3103 0.231121
R6726 VSS.n3103 VSS.n3102 0.231121
R6727 VSS.n3102 VSS.n3101 0.231121
R6728 VSS.n3101 VSS.n3100 0.231121
R6729 VSS.n3100 VSS.n3099 0.231121
R6730 VSS.n3099 VSS.n3098 0.231121
R6731 VSS.n3098 VSS.n3097 0.231121
R6732 VSS.n3097 VSS.n3096 0.231121
R6733 VSS.n3096 VSS.n3095 0.231121
R6734 VSS.n3095 VSS.n1333 0.231121
R6735 VSS.n3091 VSS.n1333 0.231121
R6736 VSS.n3091 VSS.n3090 0.231121
R6737 VSS.n3090 VSS.n3089 0.231121
R6738 VSS.n3089 VSS.n1335 0.231121
R6739 VSS.n3079 VSS.n1335 0.231121
R6740 VSS.n3079 VSS.n3078 0.231121
R6741 VSS.n3078 VSS.n3077 0.231121
R6742 VSS.n3077 VSS.n1345 0.231121
R6743 VSS.n3062 VSS.n1345 0.231121
R6744 VSS.n3063 VSS.n3062 0.231121
R6745 VSS.n3064 VSS.n3063 0.231121
R6746 VSS.n3064 VSS.n3056 0.231121
R6747 VSS.n3068 VSS.n3056 0.231121
R6748 VSS.n3069 VSS.n3068 0.231121
R6749 VSS.n3070 VSS.n3069 0.231121
R6750 VSS.n3070 VSS.n3055 0.231121
R6751 VSS.n3055 VSS.n3054 0.231121
R6752 VSS.n3054 VSS.n1365 0.231121
R6753 VSS.n3043 VSS.n1365 0.231121
R6754 VSS.n3044 VSS.n3043 0.231121
R6755 VSS.n3045 VSS.n3044 0.231121
R6756 VSS.n3045 VSS.n3042 0.231121
R6757 VSS.n3042 VSS.n3041 0.231121
R6758 VSS.n3041 VSS.n1375 0.231121
R6759 VSS.n3032 VSS.n1375 0.231121
R6760 VSS.n3032 VSS.n3031 0.231121
R6761 VSS.n3031 VSS.n3030 0.231121
R6762 VSS.n3030 VSS.n1384 0.231121
R6763 VSS.n3015 VSS.n1384 0.231121
R6764 VSS.n3016 VSS.n3015 0.231121
R6765 VSS.n3017 VSS.n3016 0.231121
R6766 VSS.n3017 VSS.n3009 0.231121
R6767 VSS.n3021 VSS.n3009 0.231121
R6768 VSS.n3022 VSS.n3021 0.231121
R6769 VSS.n3023 VSS.n3022 0.231121
R6770 VSS.n3023 VSS.n3008 0.231121
R6771 VSS.n3008 VSS.n3007 0.231121
R6772 VSS.n3007 VSS.n1404 0.231121
R6773 VSS.n2996 VSS.n1404 0.231121
R6774 VSS.n2997 VSS.n2996 0.231121
R6775 VSS.n2998 VSS.n2997 0.231121
R6776 VSS.n2998 VSS.n2995 0.231121
R6777 VSS.n2995 VSS.n2994 0.231121
R6778 VSS.n2994 VSS.n1414 0.231121
R6779 VSS.n2985 VSS.n1414 0.231121
R6780 VSS.n2985 VSS.n2984 0.231121
R6781 VSS.n2984 VSS.n2983 0.231121
R6782 VSS.n2983 VSS.n1423 0.231121
R6783 VSS.n2968 VSS.n1423 0.231121
R6784 VSS.n2969 VSS.n2968 0.231121
R6785 VSS.n2970 VSS.n2969 0.231121
R6786 VSS.n2970 VSS.n2962 0.231121
R6787 VSS.n2974 VSS.n2962 0.231121
R6788 VSS.n2975 VSS.n2974 0.231121
R6789 VSS.n2976 VSS.n2975 0.231121
R6790 VSS.n2976 VSS.n2961 0.231121
R6791 VSS.n2961 VSS.n2960 0.231121
R6792 VSS.n2960 VSS.n1469 0.231121
R6793 VSS.n2954 VSS.n1469 0.231121
R6794 VSS.n2954 VSS.n2953 0.231121
R6795 VSS.n2953 VSS.n2952 0.231121
R6796 VSS.n2952 VSS.n1473 0.231121
R6797 VSS.n2946 VSS.n1473 0.231121
R6798 VSS.n2946 VSS.n2945 0.231121
R6799 VSS.n2945 VSS.n2944 0.231121
R6800 VSS.n2944 VSS.n1477 0.231121
R6801 VSS.n2938 VSS.n1477 0.231121
R6802 VSS.n2938 VSS.n2937 0.231121
R6803 VSS.n2937 VSS.n2936 0.231121
R6804 VSS.n2936 VSS.n1481 0.231121
R6805 VSS.n2931 VSS.n1481 0.231121
R6806 VSS.n2931 VSS.n2930 0.231121
R6807 VSS.n2930 VSS.n2929 0.231121
R6808 VSS.n2929 VSS.n1485 0.231121
R6809 VSS.n2923 VSS.n1485 0.231121
R6810 VSS.n2923 VSS.n2922 0.231121
R6811 VSS.n2922 VSS.n2921 0.231121
R6812 VSS.n2921 VSS.n1488 0.231121
R6813 VSS.n2910 VSS.n1488 0.231121
R6814 VSS.n2911 VSS.n2910 0.231121
R6815 VSS.n2912 VSS.n2911 0.231121
R6816 VSS.n2912 VSS.n2909 0.231121
R6817 VSS.n2909 VSS.n2908 0.231121
R6818 VSS.n2908 VSS.n1498 0.231121
R6819 VSS.n2899 VSS.n1498 0.231121
R6820 VSS.n2899 VSS.n2898 0.231121
R6821 VSS.n2898 VSS.n2897 0.231121
R6822 VSS.n2897 VSS.n1507 0.231121
R6823 VSS.n2882 VSS.n1507 0.231121
R6824 VSS.n2883 VSS.n2882 0.231121
R6825 VSS.n2884 VSS.n2883 0.231121
R6826 VSS.n2884 VSS.n2876 0.231121
R6827 VSS.n2888 VSS.n2876 0.231121
R6828 VSS.n2889 VSS.n2888 0.231121
R6829 VSS.n2890 VSS.n2889 0.231121
R6830 VSS.n2890 VSS.n2875 0.231121
R6831 VSS.n2875 VSS.n2874 0.231121
R6832 VSS.n2874 VSS.n1527 0.231121
R6833 VSS.n2863 VSS.n1527 0.231121
R6834 VSS.n2864 VSS.n2863 0.231121
R6835 VSS.n2865 VSS.n2864 0.231121
R6836 VSS.n2865 VSS.n2862 0.231121
R6837 VSS.n2862 VSS.n2861 0.231121
R6838 VSS.n2861 VSS.n1537 0.231121
R6839 VSS.n2852 VSS.n1537 0.231121
R6840 VSS.n2852 VSS.n2851 0.231121
R6841 VSS.n2851 VSS.n2850 0.231121
R6842 VSS.n2850 VSS.n1546 0.231121
R6843 VSS.n2835 VSS.n1546 0.231121
R6844 VSS.n2836 VSS.n2835 0.231121
R6845 VSS.n2837 VSS.n2836 0.231121
R6846 VSS.n2837 VSS.n2829 0.231121
R6847 VSS.n2841 VSS.n2829 0.231121
R6848 VSS.n2842 VSS.n2841 0.231121
R6849 VSS.n2843 VSS.n2842 0.231121
R6850 VSS.n2843 VSS.n2828 0.231121
R6851 VSS.n2828 VSS.n2827 0.231121
R6852 VSS.n2827 VSS.n1566 0.231121
R6853 VSS.n2816 VSS.n1566 0.231121
R6854 VSS.n2817 VSS.n2816 0.231121
R6855 VSS.n2818 VSS.n2817 0.231121
R6856 VSS.n2818 VSS.n2815 0.231121
R6857 VSS.n2815 VSS.n2814 0.231121
R6858 VSS.n2814 VSS.n1576 0.231121
R6859 VSS.n2805 VSS.n1576 0.231121
R6860 VSS.n2805 VSS.n2804 0.231121
R6861 VSS.n2804 VSS.n2803 0.231121
R6862 VSS.n2803 VSS.n1585 0.231121
R6863 VSS.n1860 VSS.n1585 0.231121
R6864 VSS.n1860 VSS.n1859 0.231121
R6865 VSS.n1859 VSS.n1858 0.231121
R6866 VSS.n1858 VSS.n1857 0.231121
R6867 VSS.n1857 VSS.n1856 0.231121
R6868 VSS.n1856 VSS.n1855 0.231121
R6869 VSS.n1855 VSS.n1854 0.231121
R6870 VSS.n1854 VSS.n1853 0.231121
R6871 VSS.n1853 VSS.n1852 0.231121
R6872 VSS.n1852 VSS.n1851 0.231121
R6873 VSS.n1851 VSS.n1850 0.231121
R6874 VSS.n1882 VSS.n1850 0.231121
R6875 VSS.n218 VSS.n217 0.231121
R6876 VSS.n219 VSS.n218 0.231121
R6877 VSS.n220 VSS.n219 0.231121
R6878 VSS.n221 VSS.n220 0.231121
R6879 VSS.n222 VSS.n221 0.231121
R6880 VSS.n223 VSS.n222 0.231121
R6881 VSS.n224 VSS.n223 0.231121
R6882 VSS.n225 VSS.n224 0.231121
R6883 VSS.n226 VSS.n225 0.231121
R6884 VSS.n3704 VSS.n226 0.231121
R6885 VSS.n3704 VSS.n228 0.231121
R6886 VSS.n3691 VSS.n228 0.231121
R6887 VSS.n3691 VSS.n230 0.231121
R6888 VSS.n233 VSS.n230 0.231121
R6889 VSS.n234 VSS.n233 0.231121
R6890 VSS.n235 VSS.n234 0.231121
R6891 VSS.n236 VSS.n235 0.231121
R6892 VSS.n237 VSS.n236 0.231121
R6893 VSS.n238 VSS.n237 0.231121
R6894 VSS.n3674 VSS.n238 0.231121
R6895 VSS.n3674 VSS.n240 0.231121
R6896 VSS.n3664 VSS.n240 0.231121
R6897 VSS.n3664 VSS.n242 0.231121
R6898 VSS.n245 VSS.n242 0.231121
R6899 VSS.n246 VSS.n245 0.231121
R6900 VSS.n247 VSS.n246 0.231121
R6901 VSS.n248 VSS.n247 0.231121
R6902 VSS.n249 VSS.n248 0.231121
R6903 VSS.n250 VSS.n249 0.231121
R6904 VSS.n251 VSS.n250 0.231121
R6905 VSS.n252 VSS.n251 0.231121
R6906 VSS.n253 VSS.n252 0.231121
R6907 VSS.n254 VSS.n253 0.231121
R6908 VSS.n255 VSS.n254 0.231121
R6909 VSS.n256 VSS.n255 0.231121
R6910 VSS.n257 VSS.n256 0.231121
R6911 VSS.n258 VSS.n257 0.231121
R6912 VSS.n259 VSS.n258 0.231121
R6913 VSS.n3630 VSS.n259 0.231121
R6914 VSS.n3630 VSS.n261 0.231121
R6915 VSS.n3611 VSS.n261 0.231121
R6916 VSS.n3611 VSS.n263 0.231121
R6917 VSS.n266 VSS.n263 0.231121
R6918 VSS.n267 VSS.n266 0.231121
R6919 VSS.n268 VSS.n267 0.231121
R6920 VSS.n269 VSS.n268 0.231121
R6921 VSS.n270 VSS.n269 0.231121
R6922 VSS.n271 VSS.n270 0.231121
R6923 VSS.n3594 VSS.n271 0.231121
R6924 VSS.n3594 VSS.n273 0.231121
R6925 VSS.n3584 VSS.n273 0.231121
R6926 VSS.n3584 VSS.n275 0.231121
R6927 VSS.n278 VSS.n275 0.231121
R6928 VSS.n279 VSS.n278 0.231121
R6929 VSS.n280 VSS.n279 0.231121
R6930 VSS.n281 VSS.n280 0.231121
R6931 VSS.n282 VSS.n281 0.231121
R6932 VSS.n283 VSS.n282 0.231121
R6933 VSS.n284 VSS.n283 0.231121
R6934 VSS.n285 VSS.n284 0.231121
R6935 VSS.n286 VSS.n285 0.231121
R6936 VSS.n287 VSS.n286 0.231121
R6937 VSS.n288 VSS.n287 0.231121
R6938 VSS.n289 VSS.n288 0.231121
R6939 VSS.n290 VSS.n289 0.231121
R6940 VSS.n291 VSS.n290 0.231121
R6941 VSS.n292 VSS.n291 0.231121
R6942 VSS.n293 VSS.n292 0.231121
R6943 VSS.n294 VSS.n293 0.231121
R6944 VSS.n295 VSS.n294 0.231121
R6945 VSS.n296 VSS.n295 0.231121
R6946 VSS.n297 VSS.n296 0.231121
R6947 VSS.n298 VSS.n297 0.231121
R6948 VSS.n299 VSS.n298 0.231121
R6949 VSS.n300 VSS.n299 0.231121
R6950 VSS.n301 VSS.n300 0.231121
R6951 VSS.n302 VSS.n301 0.231121
R6952 VSS.n3531 VSS.n302 0.231121
R6953 VSS.n1112 VSS.n885 0.231121
R6954 VSS.n1112 VSS.n1110 0.231121
R6955 VSS.n1110 VSS.n1108 0.231121
R6956 VSS.n1108 VSS.n888 0.231121
R6957 VSS.n1103 VSS.n888 0.231121
R6958 VSS.n1103 VSS.n1101 0.231121
R6959 VSS.n1101 VSS.n1099 0.231121
R6960 VSS.n1099 VSS.n891 0.231121
R6961 VSS.n1094 VSS.n891 0.231121
R6962 VSS.n1094 VSS.n1092 0.231121
R6963 VSS.n1092 VSS.n1090 0.231121
R6964 VSS.n1090 VSS.n894 0.231121
R6965 VSS.n1085 VSS.n894 0.231121
R6966 VSS.n1085 VSS.n1083 0.231121
R6967 VSS.n1083 VSS.n1081 0.231121
R6968 VSS.n1081 VSS.n897 0.231121
R6969 VSS.n1076 VSS.n897 0.231121
R6970 VSS.n1076 VSS.n1074 0.231121
R6971 VSS.n1074 VSS.n1072 0.231121
R6972 VSS.n1072 VSS.n900 0.231121
R6973 VSS.n1068 VSS.n900 0.231121
R6974 VSS.n1068 VSS.n1066 0.231121
R6975 VSS.n1066 VSS.n1064 0.231121
R6976 VSS.n1064 VSS.n903 0.231121
R6977 VSS.n1059 VSS.n903 0.231121
R6978 VSS.n1059 VSS.n1057 0.231121
R6979 VSS.n1057 VSS.n1055 0.231121
R6980 VSS.n1055 VSS.n906 0.231121
R6981 VSS.n1050 VSS.n906 0.231121
R6982 VSS.n1050 VSS.n1049 0.231121
R6983 VSS.n1049 VSS.n1047 0.231121
R6984 VSS.n1047 VSS.n909 0.231121
R6985 VSS.n1042 VSS.n909 0.231121
R6986 VSS.n1042 VSS.n1040 0.231121
R6987 VSS.n1040 VSS.n1038 0.231121
R6988 VSS.n1038 VSS.n912 0.231121
R6989 VSS.n1033 VSS.n912 0.231121
R6990 VSS.n1033 VSS.n1031 0.231121
R6991 VSS.n1031 VSS.n1029 0.231121
R6992 VSS.n1029 VSS.n915 0.231121
R6993 VSS.n1024 VSS.n915 0.231121
R6994 VSS.n1024 VSS.n1022 0.231121
R6995 VSS.n1022 VSS.n1020 0.231121
R6996 VSS.n1020 VSS.n918 0.231121
R6997 VSS.n1015 VSS.n918 0.231121
R6998 VSS.n1015 VSS.n1013 0.231121
R6999 VSS.n1013 VSS.n1011 0.231121
R7000 VSS.n1011 VSS.n920 0.231121
R7001 VSS.n1006 VSS.n920 0.231121
R7002 VSS.n1006 VSS.n1004 0.231121
R7003 VSS.n1004 VSS.n1002 0.231121
R7004 VSS.n1002 VSS.n923 0.231121
R7005 VSS.n997 VSS.n923 0.231121
R7006 VSS.n997 VSS.n995 0.231121
R7007 VSS.n995 VSS.n993 0.231121
R7008 VSS.n993 VSS.n926 0.231121
R7009 VSS.n988 VSS.n926 0.231121
R7010 VSS.n988 VSS.n986 0.231121
R7011 VSS.n986 VSS.n985 0.231121
R7012 VSS.n985 VSS.n929 0.231121
R7013 VSS.n980 VSS.n929 0.231121
R7014 VSS.n980 VSS.n978 0.231121
R7015 VSS.n978 VSS.n976 0.231121
R7016 VSS.n976 VSS.n932 0.231121
R7017 VSS.n971 VSS.n932 0.231121
R7018 VSS.n971 VSS.n969 0.231121
R7019 VSS.n969 VSS.n967 0.231121
R7020 VSS.n967 VSS.n935 0.231121
R7021 VSS.n962 VSS.n935 0.231121
R7022 VSS.n962 VSS.n960 0.231121
R7023 VSS.n960 VSS.n958 0.231121
R7024 VSS.n958 VSS.n938 0.231121
R7025 VSS.n953 VSS.n938 0.231121
R7026 VSS.n953 VSS.n951 0.231121
R7027 VSS.n951 VSS.n949 0.231121
R7028 VSS.n949 VSS.n941 0.231121
R7029 VSS.n944 VSS.n941 0.231121
R7030 VSS.n1113 VSS.n886 0.231121
R7031 VSS.n1106 VSS.n886 0.231121
R7032 VSS.n1106 VSS.n1105 0.231121
R7033 VSS.n1105 VSS.n1104 0.231121
R7034 VSS.n1104 VSS.n889 0.231121
R7035 VSS.n1097 VSS.n889 0.231121
R7036 VSS.n1097 VSS.n1096 0.231121
R7037 VSS.n1096 VSS.n1095 0.231121
R7038 VSS.n1095 VSS.n892 0.231121
R7039 VSS.n1088 VSS.n892 0.231121
R7040 VSS.n1088 VSS.n1087 0.231121
R7041 VSS.n1087 VSS.n1086 0.231121
R7042 VSS.n1086 VSS.n895 0.231121
R7043 VSS.n1079 VSS.n895 0.231121
R7044 VSS.n1079 VSS.n1078 0.231121
R7045 VSS.n1078 VSS.n1077 0.231121
R7046 VSS.n1077 VSS.n898 0.231121
R7047 VSS.n1071 VSS.n898 0.231121
R7048 VSS.n1071 VSS.n1070 0.231121
R7049 VSS.n1070 VSS.n1069 0.231121
R7050 VSS.n1069 VSS.n901 0.231121
R7051 VSS.n1062 VSS.n901 0.231121
R7052 VSS.n1062 VSS.n1061 0.231121
R7053 VSS.n1061 VSS.n1060 0.231121
R7054 VSS.n1060 VSS.n904 0.231121
R7055 VSS.n1053 VSS.n904 0.231121
R7056 VSS.n1053 VSS.n1052 0.231121
R7057 VSS.n1052 VSS.n1051 0.231121
R7058 VSS.n1051 VSS.n907 0.231121
R7059 VSS.n1045 VSS.n907 0.231121
R7060 VSS.n1045 VSS.n1044 0.231121
R7061 VSS.n1044 VSS.n1043 0.231121
R7062 VSS.n1043 VSS.n910 0.231121
R7063 VSS.n1036 VSS.n910 0.231121
R7064 VSS.n1036 VSS.n1035 0.231121
R7065 VSS.n1035 VSS.n1034 0.231121
R7066 VSS.n1034 VSS.n913 0.231121
R7067 VSS.n1027 VSS.n913 0.231121
R7068 VSS.n1027 VSS.n1026 0.231121
R7069 VSS.n1026 VSS.n1025 0.231121
R7070 VSS.n1025 VSS.n916 0.231121
R7071 VSS.n1018 VSS.n916 0.231121
R7072 VSS.n1018 VSS.n1017 0.231121
R7073 VSS.n1017 VSS.n1016 0.231121
R7074 VSS.n1016 VSS.n919 0.231121
R7075 VSS.n1009 VSS.n919 0.231121
R7076 VSS.n1009 VSS.n1008 0.231121
R7077 VSS.n1008 VSS.n1007 0.231121
R7078 VSS.n1007 VSS.n921 0.231121
R7079 VSS.n1000 VSS.n921 0.231121
R7080 VSS.n1000 VSS.n999 0.231121
R7081 VSS.n999 VSS.n998 0.231121
R7082 VSS.n998 VSS.n924 0.231121
R7083 VSS.n991 VSS.n924 0.231121
R7084 VSS.n991 VSS.n990 0.231121
R7085 VSS.n990 VSS.n989 0.231121
R7086 VSS.n989 VSS.n927 0.231121
R7087 VSS.n983 VSS.n927 0.231121
R7088 VSS.n983 VSS.n982 0.231121
R7089 VSS.n982 VSS.n981 0.231121
R7090 VSS.n981 VSS.n930 0.231121
R7091 VSS.n974 VSS.n930 0.231121
R7092 VSS.n974 VSS.n973 0.231121
R7093 VSS.n973 VSS.n972 0.231121
R7094 VSS.n972 VSS.n933 0.231121
R7095 VSS.n965 VSS.n933 0.231121
R7096 VSS.n965 VSS.n964 0.231121
R7097 VSS.n964 VSS.n963 0.231121
R7098 VSS.n963 VSS.n936 0.231121
R7099 VSS.n956 VSS.n936 0.231121
R7100 VSS.n956 VSS.n955 0.231121
R7101 VSS.n955 VSS.n954 0.231121
R7102 VSS.n954 VSS.n939 0.231121
R7103 VSS.n947 VSS.n939 0.231121
R7104 VSS.n947 VSS.n946 0.231121
R7105 VSS.n3334 VSS.n3332 0.231121
R7106 VSS.n3332 VSS.n3242 0.231121
R7107 VSS.n3242 VSS.n3240 0.231121
R7108 VSS.n3240 VSS.n3238 0.231121
R7109 VSS.n3238 VSS.n3235 0.231121
R7110 VSS.n3235 VSS.n3234 0.231121
R7111 VSS.n3234 VSS.n3232 0.231121
R7112 VSS.n3232 VSS.n3231 0.231121
R7113 VSS.n3231 VSS.n3228 0.231121
R7114 VSS.n3228 VSS.n3226 0.231121
R7115 VSS.n3226 VSS.n3225 0.231121
R7116 VSS.n3225 VSS.n3224 0.231121
R7117 VSS.n3224 VSS.n3221 0.231121
R7118 VSS.n3221 VSS.n3219 0.231121
R7119 VSS.n3219 VSS.n3218 0.231121
R7120 VSS.n3218 VSS.n3216 0.231121
R7121 VSS.n3216 VSS.n3215 0.231121
R7122 VSS.n3215 VSS.n3213 0.231121
R7123 VSS.n3213 VSS.n3211 0.231121
R7124 VSS.n3211 VSS.n3210 0.231121
R7125 VSS.n3310 VSS.n3210 0.231121
R7126 VSS.n3310 VSS.n3309 0.231121
R7127 VSS.n3309 VSS.n3307 0.231121
R7128 VSS.n3307 VSS.n3245 0.231121
R7129 VSS.n3302 VSS.n3245 0.231121
R7130 VSS.n3302 VSS.n3300 0.231121
R7131 VSS.n3300 VSS.n3298 0.231121
R7132 VSS.n3298 VSS.n3248 0.231121
R7133 VSS.n3293 VSS.n3248 0.231121
R7134 VSS.n3293 VSS.n3291 0.231121
R7135 VSS.n3291 VSS.n3289 0.231121
R7136 VSS.n3289 VSS.n3251 0.231121
R7137 VSS.n3283 VSS.n3251 0.231121
R7138 VSS.n3283 VSS.n3281 0.231121
R7139 VSS.n3281 VSS.n3279 0.231121
R7140 VSS.n3279 VSS.n3255 0.231121
R7141 VSS.n3273 VSS.n3255 0.231121
R7142 VSS.n3273 VSS.n3271 0.231121
R7143 VSS.n3271 VSS.n3269 0.231121
R7144 VSS.n3269 VSS.n3257 0.231121
R7145 VSS.n3263 VSS.n3257 0.231121
R7146 VSS.n3331 VSS.n107 0.231121
R7147 VSS.n3331 VSS.n3330 0.231121
R7148 VSS.n3330 VSS.n3329 0.231121
R7149 VSS.n3329 VSS.n3328 0.231121
R7150 VSS.n3328 VSS.n3327 0.231121
R7151 VSS.n3327 VSS.n3326 0.231121
R7152 VSS.n3326 VSS.n3325 0.231121
R7153 VSS.n3325 VSS.n3324 0.231121
R7154 VSS.n3324 VSS.n3323 0.231121
R7155 VSS.n3323 VSS.n3322 0.231121
R7156 VSS.n3322 VSS.n3321 0.231121
R7157 VSS.n3321 VSS.n3320 0.231121
R7158 VSS.n3320 VSS.n3319 0.231121
R7159 VSS.n3319 VSS.n3318 0.231121
R7160 VSS.n3318 VSS.n3317 0.231121
R7161 VSS.n3317 VSS.n3316 0.231121
R7162 VSS.n3316 VSS.n3315 0.231121
R7163 VSS.n3315 VSS.n3314 0.231121
R7164 VSS.n3314 VSS.n3313 0.231121
R7165 VSS.n3313 VSS.n3312 0.231121
R7166 VSS.n3312 VSS.n3311 0.231121
R7167 VSS.n3311 VSS.n3243 0.231121
R7168 VSS.n3305 VSS.n3243 0.231121
R7169 VSS.n3305 VSS.n3304 0.231121
R7170 VSS.n3304 VSS.n3303 0.231121
R7171 VSS.n3303 VSS.n3246 0.231121
R7172 VSS.n3296 VSS.n3246 0.231121
R7173 VSS.n3296 VSS.n3295 0.231121
R7174 VSS.n3295 VSS.n3294 0.231121
R7175 VSS.n3294 VSS.n3249 0.231121
R7176 VSS.n3286 VSS.n3249 0.231121
R7177 VSS.n3286 VSS.n3285 0.231121
R7178 VSS.n3285 VSS.n3284 0.231121
R7179 VSS.n3284 VSS.n3252 0.231121
R7180 VSS.n3276 VSS.n3252 0.231121
R7181 VSS.n3276 VSS.n3275 0.231121
R7182 VSS.n3275 VSS.n3274 0.231121
R7183 VSS.n3274 VSS.n3256 0.231121
R7184 VSS.n3266 VSS.n3256 0.231121
R7185 VSS.n3266 VSS.n3265 0.231121
R7186 VSS.n3852 VSS.n110 0.231121
R7187 VSS.n3841 VSS.n110 0.231121
R7188 VSS.n3842 VSS.n3841 0.231121
R7189 VSS.n3842 VSS.n3840 0.231121
R7190 VSS.n3840 VSS.n3839 0.231121
R7191 VSS.n3839 VSS.n114 0.231121
R7192 VSS.n3829 VSS.n114 0.231121
R7193 VSS.n3829 VSS.n3828 0.231121
R7194 VSS.n3828 VSS.n3827 0.231121
R7195 VSS.n3827 VSS.n118 0.231121
R7196 VSS.n3817 VSS.n118 0.231121
R7197 VSS.n3817 VSS.n3816 0.231121
R7198 VSS.n3816 VSS.n3815 0.231121
R7199 VSS.n3815 VSS.n122 0.231121
R7200 VSS.n3784 VSS.n122 0.231121
R7201 VSS.n3784 VSS.n3783 0.231121
R7202 VSS.n3783 VSS.n3782 0.231121
R7203 VSS.n3782 VSS.n3781 0.231121
R7204 VSS.n3781 VSS.n3780 0.231121
R7205 VSS.n3780 VSS.n3779 0.231121
R7206 VSS.n3779 VSS.n3778 0.231121
R7207 VSS.n3778 VSS.n3777 0.231121
R7208 VSS.n3777 VSS.n3776 0.231121
R7209 VSS.n3776 VSS.n3775 0.231121
R7210 VSS.n3775 VSS.n3774 0.231121
R7211 VSS.n3774 VSS.n200 0.231121
R7212 VSS.n3768 VSS.n200 0.231121
R7213 VSS.n3768 VSS.n3767 0.231121
R7214 VSS.n3767 VSS.n3766 0.231121
R7215 VSS.n3766 VSS.n203 0.231121
R7216 VSS.n3759 VSS.n203 0.231121
R7217 VSS.n3759 VSS.n3758 0.231121
R7218 VSS.n3758 VSS.n3757 0.231121
R7219 VSS.n3757 VSS.n206 0.231121
R7220 VSS.n3750 VSS.n206 0.231121
R7221 VSS.n3750 VSS.n3749 0.231121
R7222 VSS.n3749 VSS.n3748 0.231121
R7223 VSS.n3748 VSS.n209 0.231121
R7224 VSS.n3741 VSS.n209 0.231121
R7225 VSS.n3741 VSS.n3740 0.231121
R7226 VSS.n3740 VSS.n3739 0.231121
R7227 VSS.n3739 VSS.n212 0.231121
R7228 VSS.n3732 VSS.n212 0.231121
R7229 VSS.n3732 VSS.n3731 0.231121
R7230 VSS.n3731 VSS.n3730 0.231121
R7231 VSS.n3694 VSS.n215 0.231121
R7232 VSS.n3695 VSS.n3694 0.231121
R7233 VSS.n3696 VSS.n3695 0.231121
R7234 VSS.n3697 VSS.n3696 0.231121
R7235 VSS.n3698 VSS.n3697 0.231121
R7236 VSS.n3699 VSS.n3698 0.231121
R7237 VSS.n3700 VSS.n3699 0.231121
R7238 VSS.n3701 VSS.n3700 0.231121
R7239 VSS.n3702 VSS.n3701 0.231121
R7240 VSS.n3703 VSS.n3702 0.231121
R7241 VSS.n3703 VSS.n3693 0.231121
R7242 VSS.n3693 VSS.n3692 0.231121
R7243 VSS.n3692 VSS.n229 0.231121
R7244 VSS.n3667 VSS.n229 0.231121
R7245 VSS.n3668 VSS.n3667 0.231121
R7246 VSS.n3669 VSS.n3668 0.231121
R7247 VSS.n3670 VSS.n3669 0.231121
R7248 VSS.n3671 VSS.n3670 0.231121
R7249 VSS.n3672 VSS.n3671 0.231121
R7250 VSS.n3673 VSS.n3672 0.231121
R7251 VSS.n3673 VSS.n3666 0.231121
R7252 VSS.n3666 VSS.n3665 0.231121
R7253 VSS.n3665 VSS.n241 0.231121
R7254 VSS.n3614 VSS.n241 0.231121
R7255 VSS.n3615 VSS.n3614 0.231121
R7256 VSS.n3616 VSS.n3615 0.231121
R7257 VSS.n3617 VSS.n3616 0.231121
R7258 VSS.n3618 VSS.n3617 0.231121
R7259 VSS.n3619 VSS.n3618 0.231121
R7260 VSS.n3620 VSS.n3619 0.231121
R7261 VSS.n3621 VSS.n3620 0.231121
R7262 VSS.n3622 VSS.n3621 0.231121
R7263 VSS.n3623 VSS.n3622 0.231121
R7264 VSS.n3624 VSS.n3623 0.231121
R7265 VSS.n3625 VSS.n3624 0.231121
R7266 VSS.n3626 VSS.n3625 0.231121
R7267 VSS.n3627 VSS.n3626 0.231121
R7268 VSS.n3628 VSS.n3627 0.231121
R7269 VSS.n3629 VSS.n3628 0.231121
R7270 VSS.n3629 VSS.n3613 0.231121
R7271 VSS.n3613 VSS.n3612 0.231121
R7272 VSS.n3612 VSS.n262 0.231121
R7273 VSS.n3587 VSS.n262 0.231121
R7274 VSS.n3588 VSS.n3587 0.231121
R7275 VSS.n3589 VSS.n3588 0.231121
R7276 VSS.n3590 VSS.n3589 0.231121
R7277 VSS.n3591 VSS.n3590 0.231121
R7278 VSS.n3592 VSS.n3591 0.231121
R7279 VSS.n3593 VSS.n3592 0.231121
R7280 VSS.n3593 VSS.n3586 0.231121
R7281 VSS.n3586 VSS.n3585 0.231121
R7282 VSS.n3585 VSS.n274 0.231121
R7283 VSS.n3505 VSS.n274 0.231121
R7284 VSS.n3506 VSS.n3505 0.231121
R7285 VSS.n3507 VSS.n3506 0.231121
R7286 VSS.n3508 VSS.n3507 0.231121
R7287 VSS.n3509 VSS.n3508 0.231121
R7288 VSS.n3510 VSS.n3509 0.231121
R7289 VSS.n3511 VSS.n3510 0.231121
R7290 VSS.n3512 VSS.n3511 0.231121
R7291 VSS.n3513 VSS.n3512 0.231121
R7292 VSS.n3514 VSS.n3513 0.231121
R7293 VSS.n3515 VSS.n3514 0.231121
R7294 VSS.n3516 VSS.n3515 0.231121
R7295 VSS.n3517 VSS.n3516 0.231121
R7296 VSS.n3518 VSS.n3517 0.231121
R7297 VSS.n3519 VSS.n3518 0.231121
R7298 VSS.n3520 VSS.n3519 0.231121
R7299 VSS.n3521 VSS.n3520 0.231121
R7300 VSS.n3522 VSS.n3521 0.231121
R7301 VSS.n3523 VSS.n3522 0.231121
R7302 VSS.n3524 VSS.n3523 0.231121
R7303 VSS.n3525 VSS.n3524 0.231121
R7304 VSS.n3526 VSS.n3525 0.231121
R7305 VSS.n3527 VSS.n3526 0.231121
R7306 VSS.n3528 VSS.n3527 0.231121
R7307 VSS.n3529 VSS.n3528 0.231121
R7308 VSS.n3851 VSS.n3850 0.231121
R7309 VSS.n3850 VSS.n111 0.231121
R7310 VSS.n3843 VSS.n111 0.231121
R7311 VSS.n3843 VSS.n113 0.231121
R7312 VSS.n3838 VSS.n113 0.231121
R7313 VSS.n3838 VSS.n115 0.231121
R7314 VSS.n3830 VSS.n115 0.231121
R7315 VSS.n3830 VSS.n117 0.231121
R7316 VSS.n3826 VSS.n117 0.231121
R7317 VSS.n3826 VSS.n119 0.231121
R7318 VSS.n3818 VSS.n119 0.231121
R7319 VSS.n3818 VSS.n121 0.231121
R7320 VSS.n3814 VSS.n121 0.231121
R7321 VSS.n3814 VSS.n123 0.231121
R7322 VSS.n3785 VSS.n123 0.231121
R7323 VSS.n3785 VSS.n198 0.231121
R7324 VSS.n198 VSS.n196 0.231121
R7325 VSS.n196 VSS.n195 0.231121
R7326 VSS.n195 VSS.n194 0.231121
R7327 VSS.n194 VSS.n193 0.231121
R7328 VSS.n193 VSS.n192 0.231121
R7329 VSS.n192 VSS.n191 0.231121
R7330 VSS.n191 VSS.n190 0.231121
R7331 VSS.n190 VSS.n189 0.231121
R7332 VSS.n3773 VSS.n189 0.231121
R7333 VSS.n3773 VSS.n3772 0.231121
R7334 VSS.n3772 VSS.n3770 0.231121
R7335 VSS.n3770 VSS.n202 0.231121
R7336 VSS.n3765 VSS.n202 0.231121
R7337 VSS.n3765 VSS.n3763 0.231121
R7338 VSS.n3763 VSS.n3761 0.231121
R7339 VSS.n3761 VSS.n205 0.231121
R7340 VSS.n3756 VSS.n205 0.231121
R7341 VSS.n3756 VSS.n3754 0.231121
R7342 VSS.n3754 VSS.n3752 0.231121
R7343 VSS.n3752 VSS.n208 0.231121
R7344 VSS.n3747 VSS.n208 0.231121
R7345 VSS.n3747 VSS.n3745 0.231121
R7346 VSS.n3745 VSS.n3743 0.231121
R7347 VSS.n3743 VSS.n211 0.231121
R7348 VSS.n3738 VSS.n211 0.231121
R7349 VSS.n3738 VSS.n3736 0.231121
R7350 VSS.n3736 VSS.n3734 0.231121
R7351 VSS.n3734 VSS.n214 0.231121
R7352 VSS.n3729 VSS.n214 0.231121
R7353 VSS.n3409 VSS.n718 0.231121
R7354 VSS.n3415 VSS.n718 0.231121
R7355 VSS.n3416 VSS.n3415 0.231121
R7356 VSS.n3416 VSS.n712 0.231121
R7357 VSS.n3422 VSS.n712 0.231121
R7358 VSS.n3423 VSS.n3422 0.231121
R7359 VSS.n3423 VSS.n707 0.231121
R7360 VSS.n3429 VSS.n707 0.231121
R7361 VSS.n3430 VSS.n3429 0.231121
R7362 VSS.n3430 VSS.n702 0.231121
R7363 VSS.n3438 VSS.n702 0.231121
R7364 VSS.n3439 VSS.n3438 0.231121
R7365 VSS.n3439 VSS.n695 0.231121
R7366 VSS.n3446 VSS.n695 0.231121
R7367 VSS.n3446 VSS.n693 0.231121
R7368 VSS.n762 VSS.n761 0.231121
R7369 VSS.n761 VSS.n760 0.231121
R7370 VSS.n760 VSS.n759 0.231121
R7371 VSS.n759 VSS.n758 0.231121
R7372 VSS.n758 VSS.n757 0.231121
R7373 VSS.n756 VSS.n753 0.231121
R7374 VSS.n753 VSS.n752 0.231121
R7375 VSS.n752 VSS.n751 0.231121
R7376 VSS.n751 VSS.n750 0.231121
R7377 VSS.n750 VSS.n749 0.231121
R7378 VSS.n749 VSS.n748 0.231121
R7379 VSS.n748 VSS.n747 0.231121
R7380 VSS.n747 VSS.n746 0.231121
R7381 VSS.n746 VSS.n745 0.231121
R7382 VSS.n745 VSS.n721 0.231121
R7383 VSS.n3407 VSS.n721 0.231121
R7384 VSS.n3408 VSS.n720 0.231121
R7385 VSS.n720 VSS.n717 0.231121
R7386 VSS.n717 VSS.n716 0.231121
R7387 VSS.n716 VSS.n715 0.231121
R7388 VSS.n715 VSS.n711 0.231121
R7389 VSS.n711 VSS.n710 0.231121
R7390 VSS.n710 VSS.n709 0.231121
R7391 VSS.n709 VSS.n706 0.231121
R7392 VSS.n706 VSS.n705 0.231121
R7393 VSS.n705 VSS.n704 0.231121
R7394 VSS.n704 VSS.n701 0.231121
R7395 VSS.n701 VSS.n700 0.231121
R7396 VSS.n700 VSS.n694 0.231121
R7397 VSS.n3447 VSS.n694 0.231121
R7398 VSS.n755 VSS.n732 0.231121
R7399 VSS.n732 VSS.n731 0.231121
R7400 VSS.n731 VSS.n730 0.231121
R7401 VSS.n730 VSS.n729 0.231121
R7402 VSS.n729 VSS.n728 0.231121
R7403 VSS.n728 VSS.n727 0.231121
R7404 VSS.n727 VSS.n726 0.231121
R7405 VSS.n726 VSS.n725 0.231121
R7406 VSS.n725 VSS.n723 0.231121
R7407 VSS.n723 VSS.n722 0.231121
R7408 VSS.n3406 VSS.n722 0.231121
R7409 VSS.n744 VSS.n743 0.231121
R7410 VSS.n743 VSS.n742 0.231121
R7411 VSS.n742 VSS.n741 0.231121
R7412 VSS.n741 VSS.n740 0.231121
R7413 VSS.n740 VSS.n738 0.231121
R7414 VSS.n738 VSS.n737 0.231121
R7415 VSS.n775 VSS.n774 0.231121
R7416 VSS.n773 VSS.n769 0.231121
R7417 VSS.n2580 VSS.n2134 0.231121
R7418 VSS.n2584 VSS.n2134 0.231121
R7419 VSS.n2585 VSS.n2584 0.231121
R7420 VSS.n2542 VSS.n2541 0.231121
R7421 VSS.n2541 VSS.n2540 0.231121
R7422 VSS.n2540 VSS.n2536 0.231121
R7423 VSS.n2536 VSS.n2535 0.231121
R7424 VSS.n2535 VSS.n2534 0.231121
R7425 VSS.n2534 VSS.n2530 0.231121
R7426 VSS.n2530 VSS.n2529 0.231121
R7427 VSS.n2529 VSS.n2528 0.231121
R7428 VSS.n2528 VSS.n2524 0.231121
R7429 VSS.n2524 VSS.n2523 0.231121
R7430 VSS.n2523 VSS.n2522 0.231121
R7431 VSS.n2522 VSS.n2518 0.231121
R7432 VSS.n2518 VSS.n2517 0.231121
R7433 VSS.n2517 VSS.n2145 0.231121
R7434 VSS.n2567 VSS.n2145 0.231121
R7435 VSS.n2568 VSS.n2567 0.231121
R7436 VSS.n2569 VSS.n2568 0.231121
R7437 VSS.n2144 VSS.n2137 0.231121
R7438 VSS.n2578 VSS.n2137 0.231121
R7439 VSS.n2579 VSS.n2136 0.231121
R7440 VSS.n2136 VSS.n2133 0.231121
R7441 VSS.n2133 VSS.n2127 0.231121
R7442 VSS.n2590 VSS.n2589 0.231121
R7443 VSS.n2591 VSS.n2590 0.231121
R7444 VSS.n2591 VSS.n2118 0.231121
R7445 VSS.n2596 VSS.n2595 0.231121
R7446 VSS.n2597 VSS.n2596 0.231121
R7447 VSS.n2597 VSS.n2111 0.231121
R7448 VSS.n2604 VSS.n2603 0.231121
R7449 VSS.n2605 VSS.n2604 0.231121
R7450 VSS.n2605 VSS.n2102 0.231121
R7451 VSS.n2610 VSS.n2609 0.231121
R7452 VSS.n2611 VSS.n2610 0.231121
R7453 VSS.n2611 VSS.n2095 0.231121
R7454 VSS.n2618 VSS.n2617 0.231121
R7455 VSS.n2619 VSS.n2618 0.231121
R7456 VSS.n2619 VSS.n2086 0.231121
R7457 VSS.n2624 VSS.n2623 0.231121
R7458 VSS.n2625 VSS.n2624 0.231121
R7459 VSS.n2625 VSS.n2079 0.231121
R7460 VSS.n2632 VSS.n2631 0.231121
R7461 VSS.n2633 VSS.n2632 0.231121
R7462 VSS.n2633 VSS.n2070 0.231121
R7463 VSS.n2638 VSS.n2637 0.231121
R7464 VSS.n2639 VSS.n2638 0.231121
R7465 VSS.n2639 VSS.n2063 0.231121
R7466 VSS.n2646 VSS.n2645 0.231121
R7467 VSS.n2647 VSS.n2646 0.231121
R7468 VSS.n2647 VSS.n2054 0.231121
R7469 VSS.n2652 VSS.n2651 0.231121
R7470 VSS.n2653 VSS.n2652 0.231121
R7471 VSS.n2653 VSS.n2047 0.231121
R7472 VSS.n2660 VSS.n2659 0.231121
R7473 VSS.n2661 VSS.n2660 0.231121
R7474 VSS.n2661 VSS.n2038 0.231121
R7475 VSS.n2666 VSS.n2665 0.231121
R7476 VSS.n2667 VSS.n2666 0.231121
R7477 VSS.n2667 VSS.n2031 0.231121
R7478 VSS.n2674 VSS.n2673 0.231121
R7479 VSS.n2675 VSS.n2674 0.231121
R7480 VSS.n2675 VSS.n2022 0.231121
R7481 VSS.n2680 VSS.n2679 0.231121
R7482 VSS.n2681 VSS.n2680 0.231121
R7483 VSS.n2681 VSS.n2015 0.231121
R7484 VSS.n2688 VSS.n2687 0.231121
R7485 VSS.n2689 VSS.n2688 0.231121
R7486 VSS.n2689 VSS.n2006 0.231121
R7487 VSS.n2694 VSS.n2693 0.231121
R7488 VSS.n2695 VSS.n2694 0.231121
R7489 VSS.n2695 VSS.n1999 0.231121
R7490 VSS.n2702 VSS.n2701 0.231121
R7491 VSS.n2703 VSS.n2702 0.231121
R7492 VSS.n2703 VSS.n1990 0.231121
R7493 VSS.n2708 VSS.n2707 0.231121
R7494 VSS.n2709 VSS.n2708 0.231121
R7495 VSS.n2709 VSS.n1983 0.231121
R7496 VSS.n2716 VSS.n2715 0.231121
R7497 VSS.n2717 VSS.n2716 0.231121
R7498 VSS.n2717 VSS.n1974 0.231121
R7499 VSS.n2722 VSS.n2721 0.231121
R7500 VSS.n2723 VSS.n2722 0.231121
R7501 VSS.n2723 VSS.n1967 0.231121
R7502 VSS.n2730 VSS.n2729 0.231121
R7503 VSS.n2731 VSS.n2730 0.231121
R7504 VSS.n2731 VSS.n1958 0.231121
R7505 VSS.n2736 VSS.n2735 0.231121
R7506 VSS.n2737 VSS.n2736 0.231121
R7507 VSS.n2737 VSS.n1951 0.231121
R7508 VSS.n2744 VSS.n2743 0.231121
R7509 VSS.n2745 VSS.n2744 0.231121
R7510 VSS.n2745 VSS.n1942 0.231121
R7511 VSS.n2750 VSS.n2749 0.231121
R7512 VSS.n2751 VSS.n2750 0.231121
R7513 VSS.n2751 VSS.n1935 0.231121
R7514 VSS.n2758 VSS.n2757 0.231121
R7515 VSS.n2759 VSS.n2758 0.231121
R7516 VSS.n2759 VSS.n1926 0.231121
R7517 VSS.n2764 VSS.n2763 0.231121
R7518 VSS.n2765 VSS.n2764 0.231121
R7519 VSS.n2765 VSS.n1919 0.231121
R7520 VSS.n2772 VSS.n2771 0.231121
R7521 VSS.n2773 VSS.n2772 0.231121
R7522 VSS.n2773 VSS.n1910 0.231121
R7523 VSS.n2778 VSS.n2777 0.231121
R7524 VSS.n2779 VSS.n2778 0.231121
R7525 VSS.n2779 VSS.n1903 0.231121
R7526 VSS.n2786 VSS.n2785 0.231121
R7527 VSS.n2787 VSS.n2786 0.231121
R7528 VSS.n2787 VSS.n1901 0.231121
R7529 VSS.n1896 VSS.n1895 0.231121
R7530 VSS.n1895 VSS.n1891 0.231121
R7531 VSS.n2797 VSS.n1891 0.231121
R7532 VSS.n2791 VSS.n2790 0.231121
R7533 VSS.n2791 VSS.n1892 0.231121
R7534 VSS.n2796 VSS.n1892 0.231121
R7535 VSS.n2784 VSS.n1902 0.231121
R7536 VSS.n2788 VSS.n1902 0.231121
R7537 VSS.n2789 VSS.n2788 0.231121
R7538 VSS.n2776 VSS.n1909 0.231121
R7539 VSS.n2780 VSS.n1909 0.231121
R7540 VSS.n2781 VSS.n2780 0.231121
R7541 VSS.n2770 VSS.n1918 0.231121
R7542 VSS.n2774 VSS.n1918 0.231121
R7543 VSS.n2775 VSS.n2774 0.231121
R7544 VSS.n2762 VSS.n1925 0.231121
R7545 VSS.n2766 VSS.n1925 0.231121
R7546 VSS.n2767 VSS.n2766 0.231121
R7547 VSS.n2756 VSS.n1934 0.231121
R7548 VSS.n2760 VSS.n1934 0.231121
R7549 VSS.n2761 VSS.n2760 0.231121
R7550 VSS.n2748 VSS.n1941 0.231121
R7551 VSS.n2752 VSS.n1941 0.231121
R7552 VSS.n2753 VSS.n2752 0.231121
R7553 VSS.n2742 VSS.n1950 0.231121
R7554 VSS.n2746 VSS.n1950 0.231121
R7555 VSS.n2747 VSS.n2746 0.231121
R7556 VSS.n2734 VSS.n1957 0.231121
R7557 VSS.n2738 VSS.n1957 0.231121
R7558 VSS.n2739 VSS.n2738 0.231121
R7559 VSS.n2728 VSS.n1966 0.231121
R7560 VSS.n2732 VSS.n1966 0.231121
R7561 VSS.n2733 VSS.n2732 0.231121
R7562 VSS.n2720 VSS.n1973 0.231121
R7563 VSS.n2724 VSS.n1973 0.231121
R7564 VSS.n2725 VSS.n2724 0.231121
R7565 VSS.n2714 VSS.n1982 0.231121
R7566 VSS.n2718 VSS.n1982 0.231121
R7567 VSS.n2719 VSS.n2718 0.231121
R7568 VSS.n2706 VSS.n1989 0.231121
R7569 VSS.n2710 VSS.n1989 0.231121
R7570 VSS.n2711 VSS.n2710 0.231121
R7571 VSS.n2700 VSS.n1998 0.231121
R7572 VSS.n2704 VSS.n1998 0.231121
R7573 VSS.n2705 VSS.n2704 0.231121
R7574 VSS.n2692 VSS.n2005 0.231121
R7575 VSS.n2696 VSS.n2005 0.231121
R7576 VSS.n2697 VSS.n2696 0.231121
R7577 VSS.n2686 VSS.n2014 0.231121
R7578 VSS.n2690 VSS.n2014 0.231121
R7579 VSS.n2691 VSS.n2690 0.231121
R7580 VSS.n2678 VSS.n2021 0.231121
R7581 VSS.n2682 VSS.n2021 0.231121
R7582 VSS.n2683 VSS.n2682 0.231121
R7583 VSS.n2672 VSS.n2030 0.231121
R7584 VSS.n2676 VSS.n2030 0.231121
R7585 VSS.n2677 VSS.n2676 0.231121
R7586 VSS.n2664 VSS.n2037 0.231121
R7587 VSS.n2668 VSS.n2037 0.231121
R7588 VSS.n2669 VSS.n2668 0.231121
R7589 VSS.n2658 VSS.n2046 0.231121
R7590 VSS.n2662 VSS.n2046 0.231121
R7591 VSS.n2663 VSS.n2662 0.231121
R7592 VSS.n2650 VSS.n2053 0.231121
R7593 VSS.n2654 VSS.n2053 0.231121
R7594 VSS.n2655 VSS.n2654 0.231121
R7595 VSS.n2644 VSS.n2062 0.231121
R7596 VSS.n2648 VSS.n2062 0.231121
R7597 VSS.n2649 VSS.n2648 0.231121
R7598 VSS.n2636 VSS.n2069 0.231121
R7599 VSS.n2640 VSS.n2069 0.231121
R7600 VSS.n2641 VSS.n2640 0.231121
R7601 VSS.n2630 VSS.n2078 0.231121
R7602 VSS.n2634 VSS.n2078 0.231121
R7603 VSS.n2635 VSS.n2634 0.231121
R7604 VSS.n2622 VSS.n2085 0.231121
R7605 VSS.n2626 VSS.n2085 0.231121
R7606 VSS.n2627 VSS.n2626 0.231121
R7607 VSS.n2616 VSS.n2094 0.231121
R7608 VSS.n2620 VSS.n2094 0.231121
R7609 VSS.n2621 VSS.n2620 0.231121
R7610 VSS.n2608 VSS.n2101 0.231121
R7611 VSS.n2612 VSS.n2101 0.231121
R7612 VSS.n2613 VSS.n2612 0.231121
R7613 VSS.n2602 VSS.n2110 0.231121
R7614 VSS.n2606 VSS.n2110 0.231121
R7615 VSS.n2607 VSS.n2606 0.231121
R7616 VSS.n2594 VSS.n2117 0.231121
R7617 VSS.n2598 VSS.n2117 0.231121
R7618 VSS.n2599 VSS.n2598 0.231121
R7619 VSS.n2588 VSS.n2126 0.231121
R7620 VSS.n2592 VSS.n2126 0.231121
R7621 VSS.n2593 VSS.n2592 0.231121
R7622 VSS.n2576 VSS.n2139 0.231121
R7623 VSS.n2577 VSS.n2576 0.231121
R7624 VSS.n2546 VSS.n2545 0.231121
R7625 VSS.n2546 VSS.n2537 0.231121
R7626 VSS.n2549 VSS.n2537 0.231121
R7627 VSS.n2550 VSS.n2549 0.231121
R7628 VSS.n2550 VSS.n2531 0.231121
R7629 VSS.n2554 VSS.n2531 0.231121
R7630 VSS.n2555 VSS.n2554 0.231121
R7631 VSS.n2555 VSS.n2525 0.231121
R7632 VSS.n2558 VSS.n2525 0.231121
R7633 VSS.n2559 VSS.n2558 0.231121
R7634 VSS.n2559 VSS.n2519 0.231121
R7635 VSS.n2563 VSS.n2519 0.231121
R7636 VSS.n2564 VSS.n2563 0.231121
R7637 VSS.n2564 VSS.n2146 0.231121
R7638 VSS.n2566 VSS.n2146 0.231121
R7639 VSS.n2566 VSS.n2143 0.231121
R7640 VSS.n2570 VSS.n2143 0.231121
R7641 VSS.n2219 VSS.n2213 0.231121
R7642 VSS.n2507 VSS.n2506 0.231121
R7643 VSS.n2505 VSS.n2149 0.231121
R7644 VSS.n2491 VSS.n2149 0.231121
R7645 VSS.n2490 VSS.n2152 0.231121
R7646 VSS.n2482 VSS.n2152 0.231121
R7647 VSS.n2481 VSS.n2154 0.231121
R7648 VSS.n2473 VSS.n2154 0.231121
R7649 VSS.n2472 VSS.n2156 0.231121
R7650 VSS.n2464 VSS.n2156 0.231121
R7651 VSS.n2463 VSS.n2158 0.231121
R7652 VSS.n2455 VSS.n2158 0.231121
R7653 VSS.n2454 VSS.n2160 0.231121
R7654 VSS.n2446 VSS.n2160 0.231121
R7655 VSS.n2445 VSS.n2162 0.231121
R7656 VSS.n2437 VSS.n2162 0.231121
R7657 VSS.n2436 VSS.n2164 0.231121
R7658 VSS.n2428 VSS.n2164 0.231121
R7659 VSS.n2427 VSS.n2166 0.231121
R7660 VSS.n2419 VSS.n2166 0.231121
R7661 VSS.n2418 VSS.n2168 0.231121
R7662 VSS.n2410 VSS.n2168 0.231121
R7663 VSS.n2409 VSS.n2170 0.231121
R7664 VSS.n2401 VSS.n2170 0.231121
R7665 VSS.n2400 VSS.n2172 0.231121
R7666 VSS.n2392 VSS.n2172 0.231121
R7667 VSS.n2391 VSS.n2174 0.231121
R7668 VSS.n2383 VSS.n2174 0.231121
R7669 VSS.n2382 VSS.n2176 0.231121
R7670 VSS.n2374 VSS.n2176 0.231121
R7671 VSS.n2373 VSS.n2178 0.231121
R7672 VSS.n2365 VSS.n2178 0.231121
R7673 VSS.n2364 VSS.n2180 0.231121
R7674 VSS.n2356 VSS.n2180 0.231121
R7675 VSS.n2355 VSS.n2182 0.231121
R7676 VSS.n2347 VSS.n2182 0.231121
R7677 VSS.n2346 VSS.n2184 0.231121
R7678 VSS.n2338 VSS.n2184 0.231121
R7679 VSS.n2337 VSS.n2186 0.231121
R7680 VSS.n2329 VSS.n2186 0.231121
R7681 VSS.n2328 VSS.n2188 0.231121
R7682 VSS.n2320 VSS.n2188 0.231121
R7683 VSS.n2319 VSS.n2190 0.231121
R7684 VSS.n2311 VSS.n2190 0.231121
R7685 VSS.n2310 VSS.n2192 0.231121
R7686 VSS.n2302 VSS.n2192 0.231121
R7687 VSS.n2301 VSS.n2194 0.231121
R7688 VSS.n2293 VSS.n2194 0.231121
R7689 VSS.n2292 VSS.n2196 0.231121
R7690 VSS.n2284 VSS.n2196 0.231121
R7691 VSS.n2283 VSS.n2198 0.231121
R7692 VSS.n2275 VSS.n2198 0.231121
R7693 VSS.n2274 VSS.n2200 0.231121
R7694 VSS.n2266 VSS.n2200 0.231121
R7695 VSS.n2265 VSS.n2202 0.231121
R7696 VSS.n2257 VSS.n2202 0.231121
R7697 VSS.n2256 VSS.n2204 0.231121
R7698 VSS.n2248 VSS.n2204 0.231121
R7699 VSS.n2247 VSS.n2206 0.231121
R7700 VSS.n2239 VSS.n2206 0.231121
R7701 VSS.n2238 VSS.n2208 0.231121
R7702 VSS.n2230 VSS.n2208 0.231121
R7703 VSS.n2229 VSS.n2210 0.231121
R7704 VSS.n2221 VSS.n2210 0.231121
R7705 VSS.n2228 VSS.n2211 0.231121
R7706 VSS.n2222 VSS.n2211 0.231121
R7707 VSS.n2237 VSS.n2209 0.231121
R7708 VSS.n2231 VSS.n2209 0.231121
R7709 VSS.n2246 VSS.n2207 0.231121
R7710 VSS.n2240 VSS.n2207 0.231121
R7711 VSS.n2255 VSS.n2205 0.231121
R7712 VSS.n2249 VSS.n2205 0.231121
R7713 VSS.n2264 VSS.n2203 0.231121
R7714 VSS.n2258 VSS.n2203 0.231121
R7715 VSS.n2273 VSS.n2201 0.231121
R7716 VSS.n2267 VSS.n2201 0.231121
R7717 VSS.n2282 VSS.n2199 0.231121
R7718 VSS.n2276 VSS.n2199 0.231121
R7719 VSS.n2291 VSS.n2197 0.231121
R7720 VSS.n2285 VSS.n2197 0.231121
R7721 VSS.n2300 VSS.n2195 0.231121
R7722 VSS.n2294 VSS.n2195 0.231121
R7723 VSS.n2309 VSS.n2193 0.231121
R7724 VSS.n2303 VSS.n2193 0.231121
R7725 VSS.n2318 VSS.n2191 0.231121
R7726 VSS.n2312 VSS.n2191 0.231121
R7727 VSS.n2327 VSS.n2189 0.231121
R7728 VSS.n2321 VSS.n2189 0.231121
R7729 VSS.n2336 VSS.n2187 0.231121
R7730 VSS.n2330 VSS.n2187 0.231121
R7731 VSS.n2345 VSS.n2185 0.231121
R7732 VSS.n2339 VSS.n2185 0.231121
R7733 VSS.n2354 VSS.n2183 0.231121
R7734 VSS.n2348 VSS.n2183 0.231121
R7735 VSS.n2363 VSS.n2181 0.231121
R7736 VSS.n2357 VSS.n2181 0.231121
R7737 VSS.n2372 VSS.n2179 0.231121
R7738 VSS.n2366 VSS.n2179 0.231121
R7739 VSS.n2381 VSS.n2177 0.231121
R7740 VSS.n2375 VSS.n2177 0.231121
R7741 VSS.n2390 VSS.n2175 0.231121
R7742 VSS.n2384 VSS.n2175 0.231121
R7743 VSS.n2399 VSS.n2173 0.231121
R7744 VSS.n2393 VSS.n2173 0.231121
R7745 VSS.n2408 VSS.n2171 0.231121
R7746 VSS.n2402 VSS.n2171 0.231121
R7747 VSS.n2417 VSS.n2169 0.231121
R7748 VSS.n2411 VSS.n2169 0.231121
R7749 VSS.n2426 VSS.n2167 0.231121
R7750 VSS.n2420 VSS.n2167 0.231121
R7751 VSS.n2435 VSS.n2165 0.231121
R7752 VSS.n2429 VSS.n2165 0.231121
R7753 VSS.n2444 VSS.n2163 0.231121
R7754 VSS.n2438 VSS.n2163 0.231121
R7755 VSS.n2453 VSS.n2161 0.231121
R7756 VSS.n2447 VSS.n2161 0.231121
R7757 VSS.n2462 VSS.n2159 0.231121
R7758 VSS.n2456 VSS.n2159 0.231121
R7759 VSS.n2471 VSS.n2157 0.231121
R7760 VSS.n2465 VSS.n2157 0.231121
R7761 VSS.n2480 VSS.n2155 0.231121
R7762 VSS.n2474 VSS.n2155 0.231121
R7763 VSS.n2489 VSS.n2153 0.231121
R7764 VSS.n2483 VSS.n2153 0.231121
R7765 VSS.n2504 VSS.n2150 0.231121
R7766 VSS.n2492 VSS.n2150 0.231121
R7767 VSS.n2508 VSS.n2148 0.231121
R7768 VSS VSS.n3859 0.228153
R7769 VSS.n3488 VSS.n3487 0.225674
R7770 VSS.n3487 VSS.n591 0.219424
R7771 VSS.n653 VSS.n652 0.218898
R7772 VSS.n1167 VSS.n1166 0.218898
R7773 VSS.n1166 VSS.n1165 0.218898
R7774 VSS.n589 VSS.n588 0.216472
R7775 VSS.t58 VSS.n625 0.211735
R7776 VSS.n3485 VSS.n216 0.20686
R7777 VSS.n605 VSS.n147 0.197665
R7778 VSS.n3496 VSS.n3495 0.195641
R7779 VSS.n3497 VSS.n3496 0.195641
R7780 VSS.n586 VSS.n94 0.195641
R7781 VSS.n587 VSS.n586 0.195641
R7782 VSS.n3360 VSS.t100 0.191235
R7783 VSS.n3471 VSS.n0 0.191235
R7784 VSS.n2601 VSS.n2600 0.191138
R7785 VSS.n2629 VSS.n2628 0.191138
R7786 VSS.n2671 VSS.n2670 0.191138
R7787 VSS.n2685 VSS.n2684 0.191138
R7788 VSS.n2727 VSS.n2726 0.191138
R7789 VSS.n2741 VSS.n2740 0.191138
R7790 VSS.n2769 VSS.n2768 0.191138
R7791 VSS.n3366 VSS.t94 0.191138
R7792 VSS.t42 VSS.n1897 0.191138
R7793 VSS.t48 VSS.n1914 0.191138
R7794 VSS.t454 VSS.n1930 0.191138
R7795 VSS.t442 VSS.n1946 0.191138
R7796 VSS.t220 VSS.n1962 0.191138
R7797 VSS.t433 VSS.n1978 0.191138
R7798 VSS.t448 VSS.n2010 0.191138
R7799 VSS.t451 VSS.n2026 0.191138
R7800 VSS.t439 VSS.n2042 0.191138
R7801 VSS.t445 VSS.n2058 0.191138
R7802 VSS.t436 VSS.n2074 0.191138
R7803 VSS.t709 VSS.n2135 0.191138
R7804 VSS.n2587 VSS.n2586 0.1908
R7805 VSS.n2615 VSS.n2614 0.1908
R7806 VSS.n2643 VSS.n2642 0.1908
R7807 VSS.n2657 VSS.n2656 0.1908
R7808 VSS.n2699 VSS.n2698 0.1908
R7809 VSS.n2713 VSS.n2712 0.1908
R7810 VSS.n2755 VSS.n2754 0.1908
R7811 VSS.n2783 VSS.n2782 0.1908
R7812 VSS.n2798 VSS.n1890 0.1908
R7813 VSS.t660 VSS.n1994 0.1908
R7814 VSS.t663 VSS.n2090 0.1908
R7815 VSS.t196 VSS.n2106 0.1908
R7816 VSS.t167 VSS.n2122 0.1908
R7817 VSS.t117 VSS.t119 0.1875
R7818 VSS.t114 VSS.t111 0.1875
R7819 VSS.t108 VSS.t105 0.1875
R7820 VSS.n3502 VSS.n75 0.187025
R7821 VSS.n396 VSS.n395 0.187025
R7822 VSS.n399 VSS.n398 0.187025
R7823 VSS.n400 VSS.n399 0.187025
R7824 VSS.n401 VSS.n400 0.187025
R7825 VSS.n402 VSS.n401 0.187025
R7826 VSS.n403 VSS.n402 0.187025
R7827 VSS.n404 VSS.n403 0.187025
R7828 VSS.n405 VSS.n404 0.187025
R7829 VSS.n408 VSS.n407 0.187025
R7830 VSS.n409 VSS.n408 0.187025
R7831 VSS.n150 VSS.n148 0.185168
R7832 VSS.n3361 VSS.t92 0.167615
R7833 VSS.n3726 VSS.n216 0.16726
R7834 VSS.n3206 VSS.n1277 0.160396
R7835 VSS.n1605 VSS.n1277 0.160396
R7836 VSS.n1609 VSS.n1277 0.160396
R7837 VSS.n3492 VSS.n3491 0.156138
R7838 VSS.n2586 VSS.n2130 0.151138
R7839 VSS.n2122 VSS.n2124 0.151138
R7840 VSS.n2106 VSS.n2108 0.151138
R7841 VSS.n2614 VSS.n2098 0.151138
R7842 VSS.n2090 VSS.n2092 0.151138
R7843 VSS.n2642 VSS.n2066 0.151138
R7844 VSS.n2656 VSS.n2050 0.151138
R7845 VSS.n2698 VSS.n2002 0.151138
R7846 VSS.n1994 VSS.n1996 0.151138
R7847 VSS.n2712 VSS.n1986 0.151138
R7848 VSS.n2754 VSS.n1938 0.151138
R7849 VSS.n2782 VSS.n1906 0.151138
R7850 VSS.n1893 VSS.n1890 0.151138
R7851 VSS.n2151 VSS.n2135 0.1508
R7852 VSS.n2600 VSS.n2114 0.1508
R7853 VSS.n2628 VSS.n2082 0.1508
R7854 VSS.n2074 VSS.n2076 0.1508
R7855 VSS.n2058 VSS.n2060 0.1508
R7856 VSS.n2042 VSS.n2044 0.1508
R7857 VSS.n2670 VSS.n2034 0.1508
R7858 VSS.n2026 VSS.n2028 0.1508
R7859 VSS.n2684 VSS.n2018 0.1508
R7860 VSS.n2010 VSS.n2012 0.1508
R7861 VSS.n1978 VSS.n1980 0.1508
R7862 VSS.n2726 VSS.n1970 0.1508
R7863 VSS.n1962 VSS.n1964 0.1508
R7864 VSS.n2740 VSS.n1954 0.1508
R7865 VSS.n1946 VSS.n1948 0.1508
R7866 VSS.n1930 VSS.n1932 0.1508
R7867 VSS.n2768 VSS.n1922 0.1508
R7868 VSS.n1914 VSS.n1916 0.1508
R7869 VSS.n1897 VSS.n1899 0.1508
R7870 VSS.n3853 VSS.n106 0.150687
R7871 VSS.n3451 VSS.n664 0.147398
R7872 VSS.n150 VSS.t2 0.146613
R7873 VSS.n1164 VSS.n1161 0.146155
R7874 VSS.n1161 VSS.n1160 0.146155
R7875 VSS.n1160 VSS.n862 0.146155
R7876 VSS.n1154 VSS.n862 0.146155
R7877 VSS.n1154 VSS.n1151 0.146155
R7878 VSS.n1151 VSS.n1150 0.146155
R7879 VSS.n1150 VSS.n864 0.146155
R7880 VSS.n1138 VSS.n864 0.146155
R7881 VSS.n1139 VSS.n1138 0.146155
R7882 VSS.n1139 VSS.n880 0.146155
R7883 VSS.n880 VSS.n878 0.146155
R7884 VSS.n1131 VSS.n878 0.146155
R7885 VSS.n1131 VSS.n1130 0.146155
R7886 VSS.n1130 VSS.n1128 0.146155
R7887 VSS.n1128 VSS.n882 0.146155
R7888 VSS.n1124 VSS.n882 0.146155
R7889 VSS.n1124 VSS.n1121 0.146155
R7890 VSS.n1121 VSS.n1119 0.146155
R7891 VSS.n658 VSS.n627 0.146155
R7892 VSS.n654 VSS.n627 0.146155
R7893 VSS.n654 VSS.n653 0.146155
R7894 VSS.n651 VSS.n630 0.146155
R7895 VSS.n645 VSS.n630 0.146155
R7896 VSS.n645 VSS.n644 0.146155
R7897 VSS.n661 VSS.n626 0.146155
R7898 VSS.n650 VSS.n647 0.146155
R7899 VSS.n647 VSS.n646 0.146155
R7900 VSS.n646 VSS.n631 0.146155
R7901 VSS.n642 VSS.n635 0.146155
R7902 VSS.n657 VSS.n656 0.146155
R7903 VSS.n656 VSS.n655 0.146155
R7904 VSS.n655 VSS.n629 0.146155
R7905 VSS.n1258 VSS.n1257 0.146155
R7906 VSS.n1257 VSS.n1256 0.146155
R7907 VSS.n1256 VSS.n1255 0.146155
R7908 VSS.n1255 VSS.n1254 0.146155
R7909 VSS.n1254 VSS.n1253 0.146155
R7910 VSS.n1253 VSS.n1252 0.146155
R7911 VSS.n1252 VSS.n801 0.146155
R7912 VSS.n1247 VSS.n801 0.146155
R7913 VSS.n1247 VSS.n1246 0.146155
R7914 VSS.n1246 VSS.n1245 0.146155
R7915 VSS.n1245 VSS.n803 0.146155
R7916 VSS.n1237 VSS.n803 0.146155
R7917 VSS.n1237 VSS.n1236 0.146155
R7918 VSS.n1236 VSS.n1235 0.146155
R7919 VSS.n1235 VSS.n805 0.146155
R7920 VSS.n1227 VSS.n805 0.146155
R7921 VSS.n1227 VSS.n1226 0.146155
R7922 VSS.n1226 VSS.n1225 0.146155
R7923 VSS.n1225 VSS.n807 0.146155
R7924 VSS.n1212 VSS.n807 0.146155
R7925 VSS.n1212 VSS.n1211 0.146155
R7926 VSS.n1211 VSS.n1210 0.146155
R7927 VSS.n1210 VSS.n1209 0.146155
R7928 VSS.n1209 VSS.n835 0.146155
R7929 VSS.n1203 VSS.n835 0.146155
R7930 VSS.n1203 VSS.n1202 0.146155
R7931 VSS.n1202 VSS.n1201 0.146155
R7932 VSS.n1201 VSS.n837 0.146155
R7933 VSS.n1196 VSS.n837 0.146155
R7934 VSS.n1196 VSS.n1195 0.146155
R7935 VSS.n1195 VSS.n1194 0.146155
R7936 VSS.n1194 VSS.n839 0.146155
R7937 VSS.n1189 VSS.n839 0.146155
R7938 VSS.n1189 VSS.n1188 0.146155
R7939 VSS.n1188 VSS.n1187 0.146155
R7940 VSS.n1187 VSS.n842 0.146155
R7941 VSS.n1180 VSS.n842 0.146155
R7942 VSS.n1180 VSS.n1179 0.146155
R7943 VSS.n1179 VSS.n1178 0.146155
R7944 VSS.n1178 VSS.n844 0.146155
R7945 VSS.n1169 VSS.n844 0.146155
R7946 VSS.n1169 VSS.n1168 0.146155
R7947 VSS.n1168 VSS.n1167 0.146155
R7948 VSS.n1165 VSS.n861 0.146155
R7949 VSS.n1157 VSS.n861 0.146155
R7950 VSS.n1157 VSS.n1156 0.146155
R7951 VSS.n1156 VSS.n1155 0.146155
R7952 VSS.n1155 VSS.n863 0.146155
R7953 VSS.n865 VSS.n863 0.146155
R7954 VSS.n1136 VSS.n865 0.146155
R7955 VSS.n1137 VSS.n1136 0.146155
R7956 VSS.n1137 VSS.n1135 0.146155
R7957 VSS.n1135 VSS.n1134 0.146155
R7958 VSS.n1134 VSS.n1133 0.146155
R7959 VSS.n1133 VSS.n1132 0.146155
R7960 VSS.n1132 VSS.n881 0.146155
R7961 VSS.n1127 VSS.n881 0.146155
R7962 VSS.n1127 VSS.n1126 0.146155
R7963 VSS.n1126 VSS.n1125 0.146155
R7964 VSS.n1125 VSS.n883 0.146155
R7965 VSS.n800 VSS.n799 0.146155
R7966 VSS.n799 VSS.n798 0.146155
R7967 VSS.n798 VSS.n797 0.146155
R7968 VSS.n797 VSS.n796 0.146155
R7969 VSS.n796 VSS.n795 0.146155
R7970 VSS.n795 VSS.n793 0.146155
R7971 VSS.n1251 VSS.n793 0.146155
R7972 VSS.n1251 VSS.n1250 0.146155
R7973 VSS.n1250 VSS.n1249 0.146155
R7974 VSS.n1249 VSS.n802 0.146155
R7975 VSS.n1244 VSS.n802 0.146155
R7976 VSS.n1244 VSS.n1241 0.146155
R7977 VSS.n1241 VSS.n1238 0.146155
R7978 VSS.n1238 VSS.n804 0.146155
R7979 VSS.n1234 VSS.n804 0.146155
R7980 VSS.n1234 VSS.n1231 0.146155
R7981 VSS.n1231 VSS.n1228 0.146155
R7982 VSS.n1228 VSS.n806 0.146155
R7983 VSS.n1224 VSS.n806 0.146155
R7984 VSS.n1224 VSS.n808 0.146155
R7985 VSS.n1213 VSS.n808 0.146155
R7986 VSS.n1213 VSS.n834 0.146155
R7987 VSS.n834 VSS.n832 0.146155
R7988 VSS.n1208 VSS.n832 0.146155
R7989 VSS.n1208 VSS.n1207 0.146155
R7990 VSS.n1207 VSS.n1204 0.146155
R7991 VSS.n1204 VSS.n836 0.146155
R7992 VSS.n1200 VSS.n836 0.146155
R7993 VSS.n1200 VSS.n1199 0.146155
R7994 VSS.n1199 VSS.n1197 0.146155
R7995 VSS.n1197 VSS.n838 0.146155
R7996 VSS.n1193 VSS.n838 0.146155
R7997 VSS.n1193 VSS.n1191 0.146155
R7998 VSS.n1191 VSS.n1190 0.146155
R7999 VSS.n1190 VSS.n841 0.146155
R8000 VSS.n1186 VSS.n841 0.146155
R8001 VSS.n1186 VSS.n1184 0.146155
R8002 VSS.n1184 VSS.n1183 0.146155
R8003 VSS.n1183 VSS.n843 0.146155
R8004 VSS.n1177 VSS.n843 0.146155
R8005 VSS.n1177 VSS.n845 0.146155
R8006 VSS.n1170 VSS.n845 0.146155
R8007 VSS.n1171 VSS.n1170 0.146155
R8008 VSS.n1171 VSS.n858 0.146155
R8009 VSS.t2 VSS.n149 0.145809
R8010 VSS.n2547 VSS.n2539 0.143368
R8011 VSS.n2548 VSS.n2533 0.143368
R8012 VSS.n2552 VSS.n2551 0.143368
R8013 VSS.n2526 VSS.n2557 0.143368
R8014 VSS.n2562 VSS.n2516 0.143368
R8015 VSS.n2496 VSS.n2495 0.143368
R8016 VSS.n2487 VSS.n2486 0.143368
R8017 VSS.n2478 VSS.n2477 0.143368
R8018 VSS.n2469 VSS.n2468 0.143368
R8019 VSS.n2460 VSS.n2459 0.143368
R8020 VSS.n2451 VSS.n2450 0.143368
R8021 VSS.n2442 VSS.n2441 0.143368
R8022 VSS.n2433 VSS.n2432 0.143368
R8023 VSS.n2424 VSS.n2423 0.143368
R8024 VSS.n2415 VSS.n2414 0.143368
R8025 VSS.n2406 VSS.n2405 0.143368
R8026 VSS.n2397 VSS.n2396 0.143368
R8027 VSS.n2388 VSS.n2387 0.143368
R8028 VSS.n2379 VSS.n2378 0.143368
R8029 VSS.n2370 VSS.n2369 0.143368
R8030 VSS.n2361 VSS.n2360 0.143368
R8031 VSS.n2352 VSS.n2351 0.143368
R8032 VSS.n2343 VSS.n2342 0.143368
R8033 VSS.n2334 VSS.n2333 0.143368
R8034 VSS.n2325 VSS.n2324 0.143368
R8035 VSS.n2316 VSS.n2315 0.143368
R8036 VSS.n2307 VSS.n2306 0.143368
R8037 VSS.n2298 VSS.n2297 0.143368
R8038 VSS.n2289 VSS.n2288 0.143368
R8039 VSS.n2280 VSS.n2279 0.143368
R8040 VSS.n2271 VSS.n2270 0.143368
R8041 VSS.n2262 VSS.n2261 0.143368
R8042 VSS.n2253 VSS.n2252 0.143368
R8043 VSS.n2244 VSS.n2243 0.143368
R8044 VSS.n2235 VSS.n2234 0.143368
R8045 VSS.n2226 VSS.n2225 0.143368
R8046 VSS.n2217 VSS.n2216 0.143368
R8047 VSS.n2582 VSS.n2581 0.143368
R8048 VSS.n2131 VSS.n2583 0.143368
R8049 VSS.n2121 VSS.n2120 0.143368
R8050 VSS.n2119 VSS.n2115 0.143368
R8051 VSS.n2105 VSS.n2104 0.143368
R8052 VSS.n2103 VSS.n2099 0.143368
R8053 VSS.n2089 VSS.n2088 0.143368
R8054 VSS.n2087 VSS.n2083 0.143368
R8055 VSS.n2073 VSS.n2072 0.143368
R8056 VSS.n2071 VSS.n2067 0.143368
R8057 VSS.n2057 VSS.n2056 0.143368
R8058 VSS.n2055 VSS.n2051 0.143368
R8059 VSS.n2041 VSS.n2040 0.143368
R8060 VSS.n2039 VSS.n2035 0.143368
R8061 VSS.n2025 VSS.n2024 0.143368
R8062 VSS.n2023 VSS.n2019 0.143368
R8063 VSS.n2009 VSS.n2008 0.143368
R8064 VSS.n2007 VSS.n2003 0.143368
R8065 VSS.n1993 VSS.n1992 0.143368
R8066 VSS.n1991 VSS.n1987 0.143368
R8067 VSS.n1977 VSS.n1976 0.143368
R8068 VSS.n1975 VSS.n1971 0.143368
R8069 VSS.n1961 VSS.n1960 0.143368
R8070 VSS.n1959 VSS.n1955 0.143368
R8071 VSS.n1945 VSS.n1944 0.143368
R8072 VSS.n1943 VSS.n1939 0.143368
R8073 VSS.n1929 VSS.n1928 0.143368
R8074 VSS.n1927 VSS.n1923 0.143368
R8075 VSS.n1913 VSS.n1912 0.143368
R8076 VSS.n1911 VSS.n1907 0.143368
R8077 VSS.n2792 VSS.n1894 0.143368
R8078 VSS.n2794 VSS.n2793 0.143368
R8079 VSS.n1869 VSS.n1595 0.143368
R8080 VSS.n1872 VSS.n1842 0.143368
R8081 VSS.n1874 VSS.n1843 0.143368
R8082 VSS.n1876 VSS.n1844 0.143368
R8083 VSS.n1848 VSS.n1846 0.143368
R8084 VSS.n1884 VSS.n1847 0.143368
R8085 VSS.n1862 VSS.n1587 0.143368
R8086 VSS.n3137 VSS.n3136 0.143368
R8087 VSS.n3141 VSS.n3140 0.143368
R8088 VSS.n3145 VSS.n3144 0.143368
R8089 VSS.n3149 VSS.n3148 0.143368
R8090 VSS.n3153 VSS.n3152 0.143368
R8091 VSS.n3155 VSS.n3154 0.143368
R8092 VSS.n3157 VSS.n3156 0.143368
R8093 VSS.n3159 VSS.n3158 0.143368
R8094 VSS.n3161 VSS.n3160 0.143368
R8095 VSS.n3163 VSS.n3162 0.143368
R8096 VSS.n3165 VSS.n3164 0.143368
R8097 VSS.n3167 VSS.n3166 0.143368
R8098 VSS.n3169 VSS.n3168 0.143368
R8099 VSS.n3171 VSS.n3170 0.143368
R8100 VSS.n3173 VSS.n3172 0.143368
R8101 VSS.n3177 VSS.n3176 0.143368
R8102 VSS.n3059 VSS.n1347 0.143368
R8103 VSS.n3058 VSS.n1352 0.143368
R8104 VSS.n3057 VSS.n1353 0.143368
R8105 VSS.n1363 VSS.n1354 0.143368
R8106 VSS.n3052 VSS.n1357 0.143368
R8107 VSS.n3012 VSS.n1386 0.143368
R8108 VSS.n3011 VSS.n1391 0.143368
R8109 VSS.n3010 VSS.n1392 0.143368
R8110 VSS.n1402 VSS.n1393 0.143368
R8111 VSS.n3005 VSS.n1396 0.143368
R8112 VSS.n2965 VSS.n1425 0.143368
R8113 VSS.n2964 VSS.n1430 0.143368
R8114 VSS.n2963 VSS.n1431 0.143368
R8115 VSS.n1467 VSS.n1432 0.143368
R8116 VSS.n2958 VSS.n1435 0.143368
R8117 VSS.n2956 VSS.n1436 0.143368
R8118 VSS.n1472 VSS.n1437 0.143368
R8119 VSS.n1470 VSS.n1438 0.143368
R8120 VSS.n2950 VSS.n1439 0.143368
R8121 VSS.n2948 VSS.n1441 0.143368
R8122 VSS.n2942 VSS.n1444 0.143368
R8123 VSS.n2940 VSS.n1445 0.143368
R8124 VSS.n2933 VSS.n1449 0.143368
R8125 VSS.n1484 VSS.n1450 0.143368
R8126 VSS.n1482 VSS.n1451 0.143368
R8127 VSS.n2927 VSS.n1452 0.143368
R8128 VSS.n2925 VSS.n1453 0.143368
R8129 VSS.n2919 VSS.n1456 0.143368
R8130 VSS.n2879 VSS.n1509 0.143368
R8131 VSS.n2878 VSS.n1514 0.143368
R8132 VSS.n2877 VSS.n1515 0.143368
R8133 VSS.n1525 VSS.n1516 0.143368
R8134 VSS.n2872 VSS.n1519 0.143368
R8135 VSS.n2832 VSS.n1548 0.143368
R8136 VSS.n2831 VSS.n1553 0.143368
R8137 VSS.n2830 VSS.n1554 0.143368
R8138 VSS.n1564 VSS.n1555 0.143368
R8139 VSS.n2825 VSS.n1558 0.143368
R8140 VSS.n3849 VSS.n3848 0.143368
R8141 VSS.n3847 VSS.n3846 0.143368
R8142 VSS.n3845 VSS.n3844 0.143368
R8143 VSS.n3835 VSS.n112 0.143368
R8144 VSS.n3837 VSS.n3836 0.143368
R8145 VSS.n3834 VSS.n3833 0.143368
R8146 VSS.n3832 VSS.n3831 0.143368
R8147 VSS.n3823 VSS.n116 0.143368
R8148 VSS.n3825 VSS.n3824 0.143368
R8149 VSS.n3822 VSS.n3821 0.143368
R8150 VSS.n3820 VSS.n3819 0.143368
R8151 VSS.n3812 VSS.n3811 0.143368
R8152 VSS.n3813 VSS.n28 0.143368
R8153 VSS.n3790 VSS.n3789 0.143368
R8154 VSS.n3792 VSS.n3791 0.143368
R8155 VSS.n3794 VSS.n3793 0.143368
R8156 VSS.n3796 VSS.n3795 0.143368
R8157 VSS.n3798 VSS.n3797 0.143368
R8158 VSS.n3800 VSS.n3799 0.143368
R8159 VSS.n3802 VSS.n3801 0.143368
R8160 VSS.n3804 VSS.n3803 0.143368
R8161 VSS.n3806 VSS.n3805 0.143368
R8162 VSS.n188 VSS.n125 0.143368
R8163 VSS.n3771 VSS.n126 0.143368
R8164 VSS.n3769 VSS.n127 0.143368
R8165 VSS.n201 VSS.n128 0.143368
R8166 VSS.n3764 VSS.n129 0.143368
R8167 VSS.n3762 VSS.n130 0.143368
R8168 VSS.n3760 VSS.n131 0.143368
R8169 VSS.n204 VSS.n132 0.143368
R8170 VSS.n3755 VSS.n133 0.143368
R8171 VSS.n207 VSS.n135 0.143368
R8172 VSS.n3746 VSS.n137 0.143368
R8173 VSS.n3744 VSS.n138 0.143368
R8174 VSS.n3742 VSS.n139 0.143368
R8175 VSS.n210 VSS.n140 0.143368
R8176 VSS.n3733 VSS.n142 0.143368
R8177 VSS.n213 VSS.n143 0.143368
R8178 VSS.n3728 VSS.n144 0.143368
R8179 VSS.n3721 VSS.n3720 0.143368
R8180 VSS.n3719 VSS.n3718 0.143368
R8181 VSS.n3717 VSS.n3716 0.143368
R8182 VSS.n3715 VSS.n3714 0.143368
R8183 VSS.n3713 VSS.n3712 0.143368
R8184 VSS.n3711 VSS.n3710 0.143368
R8185 VSS.n3709 VSS.n3708 0.143368
R8186 VSS.n3707 VSS.n3706 0.143368
R8187 VSS.n3690 VSS.n232 0.143368
R8188 VSS.n3689 VSS.n3688 0.143368
R8189 VSS.n3687 VSS.n3686 0.143368
R8190 VSS.n3685 VSS.n3684 0.143368
R8191 VSS.n3683 VSS.n3682 0.143368
R8192 VSS.n3681 VSS.n3680 0.143368
R8193 VSS.n3679 VSS.n3678 0.143368
R8194 VSS.n3677 VSS.n3676 0.143368
R8195 VSS.n3663 VSS.n244 0.143368
R8196 VSS.n3662 VSS.n3661 0.143368
R8197 VSS.n3660 VSS.n3659 0.143368
R8198 VSS.n3658 VSS.n3657 0.143368
R8199 VSS.n3656 VSS.n3655 0.143368
R8200 VSS.n3654 VSS.n3653 0.143368
R8201 VSS.n3652 VSS.n3651 0.143368
R8202 VSS.n3650 VSS.n3649 0.143368
R8203 VSS.n3647 VSS.n3646 0.143368
R8204 VSS.n3645 VSS.n3644 0.143368
R8205 VSS.n3643 VSS.n3642 0.143368
R8206 VSS.n3641 VSS.n3640 0.143368
R8207 VSS.n3639 VSS.n3638 0.143368
R8208 VSS.n3637 VSS.n3636 0.143368
R8209 VSS.n3635 VSS.n3634 0.143368
R8210 VSS.n3633 VSS.n3632 0.143368
R8211 VSS.n3610 VSS.n265 0.143368
R8212 VSS.n3609 VSS.n3608 0.143368
R8213 VSS.n3607 VSS.n3606 0.143368
R8214 VSS.n3605 VSS.n3604 0.143368
R8215 VSS.n3603 VSS.n3602 0.143368
R8216 VSS.n3601 VSS.n3600 0.143368
R8217 VSS.n3599 VSS.n3598 0.143368
R8218 VSS.n3597 VSS.n3596 0.143368
R8219 VSS.n3583 VSS.n277 0.143368
R8220 VSS.n3582 VSS.n3581 0.143368
R8221 VSS.n3580 VSS.n3579 0.143368
R8222 VSS.n3578 VSS.n3577 0.143368
R8223 VSS.n3576 VSS.n3575 0.143368
R8224 VSS.n3574 VSS.n3573 0.143368
R8225 VSS.n3572 VSS.n3571 0.143368
R8226 VSS.n3570 VSS.n3569 0.143368
R8227 VSS.n3567 VSS.n3566 0.143368
R8228 VSS.n3565 VSS.n3564 0.143368
R8229 VSS.n3563 VSS.n3562 0.143368
R8230 VSS.n3561 VSS.n3560 0.143368
R8231 VSS.n3559 VSS.n3558 0.143368
R8232 VSS.n3557 VSS.n3556 0.143368
R8233 VSS.n3555 VSS.n3554 0.143368
R8234 VSS.n3553 VSS.n3552 0.143368
R8235 VSS.n3551 VSS.n3550 0.143368
R8236 VSS.n3548 VSS.n3547 0.143368
R8237 VSS.n3546 VSS.n3545 0.143368
R8238 VSS.n3544 VSS.n3543 0.143368
R8239 VSS.n3542 VSS.n3541 0.143368
R8240 VSS.n3540 VSS.n3539 0.143368
R8241 VSS.n3538 VSS.n3537 0.143368
R8242 VSS.n3536 VSS.n3535 0.143368
R8243 VSS.n3534 VSS.n3533 0.143368
R8244 VSS.n3336 VSS.n3335 0.143368
R8245 VSS.n3237 VSS.n3239 0.143368
R8246 VSS.n3341 VSS.n3340 0.143368
R8247 VSS.t508 VSS.n3342 0.143368
R8248 VSS.n3344 VSS.n3343 0.143368
R8249 VSS.n3349 VSS.n3348 0.143368
R8250 VSS.n3352 VSS.n3351 0.143368
R8251 VSS.n3355 VSS.n3354 0.143368
R8252 VSS.n3357 VSS.n3356 0.143368
R8253 VSS.n3306 VSS.n186 0.143368
R8254 VSS.n3244 VSS.n184 0.143368
R8255 VSS.n3301 VSS.n182 0.143368
R8256 VSS.n3299 VSS.n180 0.143368
R8257 VSS.n3297 VSS.n179 0.143368
R8258 VSS.n3247 VSS.n178 0.143368
R8259 VSS.n3292 VSS.n175 0.143368
R8260 VSS.n3290 VSS.n174 0.143368
R8261 VSS.n3282 VSS.n169 0.143368
R8262 VSS.n3280 VSS.n167 0.143368
R8263 VSS.n3272 VSS.n163 0.143368
R8264 VSS.n3270 VSS.n160 0.143368
R8265 VSS.n3370 VSS.n3369 0.143368
R8266 VSS.n3372 VSS.n3371 0.143368
R8267 VSS.n3374 VSS.n3373 0.143368
R8268 VSS.n3376 VSS.n3375 0.143368
R8269 VSS.t502 VSS.n3380 0.143368
R8270 VSS.n3382 VSS.n3381 0.143368
R8271 VSS.n754 VSS.n733 0.143368
R8272 VSS.n3386 VSS.t503 0.143368
R8273 VSS.n3391 VSS.n3390 0.143368
R8274 VSS.n3393 VSS.n3392 0.143368
R8275 VSS.n3395 VSS.n3394 0.143368
R8276 VSS.n3401 VSS.n3400 0.143368
R8277 VSS.n3403 VSS.n3402 0.143368
R8278 VSS.n3411 VSS.n3410 0.143368
R8279 VSS.n3413 VSS.n3412 0.143368
R8280 VSS.n3414 VSS.n714 0.143368
R8281 VSS.n3418 VSS.n3417 0.143368
R8282 VSS.n3420 VSS.n3419 0.143368
R8283 VSS.n3425 VSS.n3424 0.143368
R8284 VSS.n3427 VSS.n3426 0.143368
R8285 VSS.n3428 VSS.n703 0.143368
R8286 VSS.n3437 VSS.n699 0.143368
R8287 VSS.n3441 VSS.n3440 0.143368
R8288 VSS.n696 VSS.n692 0.143368
R8289 VSS.n1111 VSS.n576 0.143368
R8290 VSS.n1109 VSS.n573 0.143368
R8291 VSS.n1107 VSS.n570 0.143368
R8292 VSS.n887 VSS.n567 0.143368
R8293 VSS.n1102 VSS.n564 0.143368
R8294 VSS.n1100 VSS.n563 0.143368
R8295 VSS.n1098 VSS.n562 0.143368
R8296 VSS.n890 VSS.n558 0.143368
R8297 VSS.n1089 VSS.n550 0.143368
R8298 VSS.n893 VSS.n547 0.143368
R8299 VSS.n1084 VSS.n544 0.143368
R8300 VSS.n1082 VSS.n541 0.143368
R8301 VSS.n1080 VSS.n538 0.143368
R8302 VSS.n896 VSS.n537 0.143368
R8303 VSS.n1075 VSS.n533 0.143368
R8304 VSS.n1073 VSS.n530 0.143368
R8305 VSS.n1067 VSS.n522 0.143368
R8306 VSS.n1065 VSS.n519 0.143368
R8307 VSS.n1063 VSS.n518 0.143368
R8308 VSS.n902 VSS.n517 0.143368
R8309 VSS.n1058 VSS.n516 0.143368
R8310 VSS.n1056 VSS.n515 0.143368
R8311 VSS.n1054 VSS.n511 0.143368
R8312 VSS.n905 VSS.n508 0.143368
R8313 VSS.n1048 VSS.n504 0.143368
R8314 VSS.n1046 VSS.n503 0.143368
R8315 VSS.n908 VSS.n502 0.143368
R8316 VSS.n1041 VSS.n501 0.143368
R8317 VSS.n1039 VSS.n500 0.143368
R8318 VSS.n1037 VSS.n496 0.143368
R8319 VSS.n911 VSS.n493 0.143368
R8320 VSS.n1032 VSS.n492 0.143368
R8321 VSS.n914 VSS.n485 0.143368
R8322 VSS.n1023 VSS.n482 0.143368
R8323 VSS.n1021 VSS.n479 0.143368
R8324 VSS.n1019 VSS.n478 0.143368
R8325 VSS.n917 VSS.n475 0.143368
R8326 VSS.n1014 VSS.n474 0.143368
R8327 VSS.n1012 VSS.n473 0.143368
R8328 VSS.n1010 VSS.n472 0.143368
R8329 VSS.n1003 VSS.n470 0.143368
R8330 VSS.n1001 VSS.n469 0.143368
R8331 VSS.n922 VSS.n468 0.143368
R8332 VSS.n996 VSS.n467 0.143368
R8333 VSS.n994 VSS.n464 0.143368
R8334 VSS.n992 VSS.n460 0.143368
R8335 VSS.n925 VSS.n457 0.143368
R8336 VSS.n987 VSS.n454 0.143368
R8337 VSS.n984 VSS.n452 0.143368
R8338 VSS.n928 VSS.n448 0.143368
R8339 VSS.n979 VSS.n445 0.143368
R8340 VSS.n977 VSS.n442 0.143368
R8341 VSS.n975 VSS.n439 0.143368
R8342 VSS.n931 VSS.n436 0.143368
R8343 VSS.n970 VSS.n433 0.143368
R8344 VSS.n968 VSS.n432 0.143368
R8345 VSS.n966 VSS.n431 0.143368
R8346 VSS.n961 VSS.n425 0.143368
R8347 VSS.n959 VSS.n422 0.143368
R8348 VSS.n957 VSS.n419 0.143368
R8349 VSS.n937 VSS.n418 0.143368
R8350 VSS.n952 VSS.n415 0.143368
R8351 VSS.n950 VSS.n414 0.143368
R8352 VSS.n948 VSS.n413 0.143368
R8353 VSS.n940 VSS.n412 0.143368
R8354 VSS.n3262 VSS.n153 0.143368
R8355 VSS.t267 VSS.n3722 0.143368
R8356 VSS.n3648 VSS.t276 0.143368
R8357 VSS.n3568 VSS.t270 0.143368
R8358 VSS.t281 VSS.n3549 0.143368
R8359 VSS.t511 VSS.n3220 0.143368
R8360 VSS.t510 VSS.n3222 0.143368
R8361 VSS.n3227 VSS.t509 0.143368
R8362 VSS.n3333 VSS.t505 0.143368
R8363 VSS.t507 VSS.t506 0.143368
R8364 VSS.t136 VSS.n1302 0.143368
R8365 VSS.t479 VSS.n1307 0.143368
R8366 VSS.n1312 VSS.t677 0.143368
R8367 VSS.n1316 VSS.t383 0.143368
R8368 VSS.t523 VSS.n1322 0.143368
R8369 VSS.t530 VSS.n1280 0.143368
R8370 VSS.t183 VSS.n1448 0.143368
R8371 VSS.n2514 VSS.t407 0.143368
R8372 VSS.n2515 VSS.t369 0.143368
R8373 VSS.t356 VSS.n2532 0.143368
R8374 VSS.n2538 VSS.t77 0.143368
R8375 VSS.t354 VSS.n2521 0.143368
R8376 VSS.t373 VSS.n2140 0.143368
R8377 VSS.n2129 VSS.t423 0.143368
R8378 VSS.t654 VSS.n2125 0.143368
R8379 VSS.n2113 VSS.t526 0.143368
R8380 VSS.t456 VSS.n2109 0.143368
R8381 VSS.n2097 VSS.t391 0.143368
R8382 VSS.t147 VSS.n2093 0.143368
R8383 VSS.n2081 VSS.t488 0.143368
R8384 VSS.t127 VSS.n2077 0.143368
R8385 VSS.n2065 VSS.t394 0.143368
R8386 VSS.t63 VSS.n2061 0.143368
R8387 VSS.n2049 VSS.t10 0.143368
R8388 VSS.t26 VSS.n2045 0.143368
R8389 VSS.n2033 VSS.t51 0.143368
R8390 VSS.t426 VSS.n2029 0.143368
R8391 VSS.n2017 VSS.t413 0.143368
R8392 VSS.t497 VSS.n2013 0.143368
R8393 VSS.n2001 VSS.t410 0.143368
R8394 VSS.t633 VSS.n1997 0.143368
R8395 VSS.n1985 VSS.t88 0.143368
R8396 VSS.t399 VSS.n1981 0.143368
R8397 VSS.n1969 VSS.t688 0.143368
R8398 VSS.t234 VSS.n1965 0.143368
R8399 VSS.n1953 VSS.t693 0.143368
R8400 VSS.t16 VSS.n1949 0.143368
R8401 VSS.n1937 VSS.t54 0.143368
R8402 VSS.t225 VSS.n1933 0.143368
R8403 VSS.n1921 VSS.t416 0.143368
R8404 VSS.t669 VSS.n1917 0.143368
R8405 VSS.n1905 VSS.t430 0.143368
R8406 VSS.t378 VSS.n1900 0.143368
R8407 VSS.t643 VSS.n1841 0.143368
R8408 VSS.t614 VSS.n1588 0.143368
R8409 VSS.t605 VSS.n1569 0.143368
R8410 VSS.t600 VSS.n1549 0.143368
R8411 VSS.t590 VSS.n1530 0.143368
R8412 VSS.t585 VSS.n1510 0.143368
R8413 VSS.t575 VSS.n1491 0.143368
R8414 VSS.t570 VSS.n1426 0.143368
R8415 VSS.t560 VSS.n1407 0.143368
R8416 VSS.t555 VSS.n1387 0.143368
R8417 VSS.t545 VSS.n1368 0.143368
R8418 VSS.t540 VSS.n1348 0.143368
R8419 VSS.n1331 VSS.t363 0.143368
R8420 VSS.t256 VSS.n505 0.143368
R8421 VSS.t262 VSS.n453 0.143368
R8422 VSS.n934 VSS.t264 0.143368
R8423 VSS.n884 VSS.t252 0.143368
R8424 VSS.n777 VSS.t100 0.143368
R8425 VSS.n3450 VSS.n3449 0.142012
R8426 VSS.n3503 VSS.n3502 0.140207
R8427 VSS.n3494 VSS.n3493 0.138915
R8428 VSS.n3449 VSS.n690 0.138262
R8429 VSS.n2544 VSS.n109 0.138073
R8430 VSS.t120 VSS.t7 0.135868
R8431 VSS.t532 VSS.n1281 0.129618
R8432 VSS.t547 VSS.n1367 0.129618
R8433 VSS.t562 VSS.n1406 0.129618
R8434 VSS.t577 VSS.n1490 0.129618
R8435 VSS.t592 VSS.n1529 0.129618
R8436 VSS.t607 VSS.n1568 0.129618
R8437 VSS.n149 VSS.n145 0.128368
R8438 VSS.n605 VSS.n148 0.126532
R8439 VSS.n303 VSS.t283 0.124701
R8440 VSS.t122 VSS.n1889 0.124618
R8441 VSS.n1889 VSS.t123 0.122118
R8442 VSS.n1887 VSS.t120 0.122118
R8443 VSS.n621 VSS.n620 0.120892
R8444 VSS.n859 VSS.n846 0.120892
R8445 VSS.n859 VSS.n848 0.120892
R8446 VSS.n660 VSS.n659 0.1205
R8447 VSS.n628 VSS.n615 0.1205
R8448 VSS.n649 VSS.n648 0.1205
R8449 VSS.n633 VSS.n632 0.1205
R8450 VSS.n641 VSS.t685 0.1205
R8451 VSS.n1261 VSS.n1260 0.1205
R8452 VSS.n1264 VSS.n1263 0.1205
R8453 VSS.n1267 VSS.n1266 0.1205
R8454 VSS.n1248 VSS.n792 0.1205
R8455 VSS.n1243 VSS.n1242 0.1205
R8456 VSS.n1240 VSS.n1239 0.1205
R8457 VSS.n1233 VSS.n1232 0.1205
R8458 VSS.n1230 VSS.n1229 0.1205
R8459 VSS.n1223 VSS.n1222 0.1205
R8460 VSS.n1214 VSS.n809 0.1205
R8461 VSS.t346 VSS.n831 0.1205
R8462 VSS.n1206 VSS.n1205 0.1205
R8463 VSS.n1198 VSS.n816 0.1205
R8464 VSS.n1192 VSS.n827 0.1205
R8465 VSS.n840 VSS.n818 0.1205
R8466 VSS.n1182 VSS.n1181 0.1205
R8467 VSS.n1172 VSS.n857 0.1205
R8468 VSS.n1163 VSS.n1162 0.1205
R8469 VSS.n1159 VSS.n1158 0.1205
R8470 VSS.n1153 VSS.n1152 0.1205
R8471 VSS.n1149 VSS.n1148 0.1205
R8472 VSS.n1140 VSS.n866 0.1205
R8473 VSS.t159 VSS.n877 0.1205
R8474 VSS.n1123 VSS.n1122 0.1205
R8475 VSS.n794 VSS.t345 0.1205
R8476 VSS.t346 VSS.n833 0.1205
R8477 VSS.t348 VSS.n827 0.1205
R8478 VSS.t683 VSS.n818 0.1205
R8479 VSS.n1185 VSS.t91 0.1205
R8480 VSS.t12 VSS.n1176 0.1205
R8481 VSS.n1172 VSS.t717 0.1205
R8482 VSS.t159 VSS.n879 0.1205
R8483 VSS.t19 VSS.n1129 0.1205
R8484 VSS.t21 VSS.n1120 0.1205
R8485 VSS.t155 VSS.n816 0.1205
R8486 VSS.t343 VSS.n792 0.1205
R8487 VSS.t713 VSS.n615 0.1205
R8488 VSS.n638 VSS.t685 0.1205
R8489 VSS.n660 VSS.n623 0.120486
R8490 VSS.t97 VSS.n691 0.1171
R8491 VSS.n764 VSS.n763 0.11631
R8492 VSS.n1883 VSS.n1849 0.113429
R8493 VSS.n3531 VSS.n3530 0.113429
R8494 VSS.n1114 VSS.n885 0.113429
R8495 VSS.n945 VSS.n944 0.113429
R8496 VSS.n3264 VSS.n3263 0.113429
R8497 VSS.n3448 VSS.n693 0.113429
R8498 VSS.n763 VSS.n744 0.113429
R8499 VSS.n2213 VSS.n2212 0.113429
R8500 VSS.n772 VSS.n3360 0.112118
R8501 VSS.n3504 VSS.n3503 0.108056
R8502 VSS.t534 VSS.n1337 0.105868
R8503 VSS.t549 VSS.n1377 0.105868
R8504 VSS.t564 VSS.n1416 0.105868
R8505 VSS.t579 VSS.n1500 0.105868
R8506 VSS.t594 VSS.n1539 0.105868
R8507 VSS.t609 VSS.n1578 0.105868
R8508 VSS.n3724 VSS.n94 0.105745
R8509 VSS.n942 VSS.n410 0.103387
R8510 VSS.t7 VSS.n1888 0.1033
R8511 VSS.t529 VSS.n3178 0.0971176
R8512 VSS.t544 VSS.n1358 0.0971176
R8513 VSS.t559 VSS.n1397 0.0971176
R8514 VSS.t574 VSS.n1457 0.0971176
R8515 VSS.t589 VSS.n1520 0.0971176
R8516 VSS.t604 VSS.n1559 0.0971176
R8517 VSS.t109 VSS.n595 0.0971176
R8518 VSS.n3492 VSS.n0 0.0971176
R8519 VSS.n2557 VSS.n2556 0.0961384
R8520 VSS.n2562 VSS.n2561 0.0961384
R8521 VSS.n2216 VSS.n2215 0.0961384
R8522 VSS.n2225 VSS.n2224 0.0961384
R8523 VSS.n2234 VSS.n2233 0.0961384
R8524 VSS.n2243 VSS.n2242 0.0961384
R8525 VSS.n2252 VSS.n2251 0.0961384
R8526 VSS.n2261 VSS.n2260 0.0961384
R8527 VSS.n2270 VSS.n2269 0.0961384
R8528 VSS.n2279 VSS.n2278 0.0961384
R8529 VSS.n2288 VSS.n2287 0.0961384
R8530 VSS.n2297 VSS.n2296 0.0961384
R8531 VSS.n2306 VSS.n2305 0.0961384
R8532 VSS.n2315 VSS.n2314 0.0961384
R8533 VSS.n2324 VSS.n2323 0.0961384
R8534 VSS.n2333 VSS.n2332 0.0961384
R8535 VSS.n2342 VSS.n2341 0.0961384
R8536 VSS.n2351 VSS.n2350 0.0961384
R8537 VSS.n2360 VSS.n2359 0.0961384
R8538 VSS.n2369 VSS.n2368 0.0961384
R8539 VSS.n2378 VSS.n2377 0.0961384
R8540 VSS.n2387 VSS.n2386 0.0961384
R8541 VSS.n2396 VSS.n2395 0.0961384
R8542 VSS.n2405 VSS.n2404 0.0961384
R8543 VSS.n2414 VSS.n2413 0.0961384
R8544 VSS.n2423 VSS.n2422 0.0961384
R8545 VSS.n2432 VSS.n2431 0.0961384
R8546 VSS.n2441 VSS.n2440 0.0961384
R8547 VSS.n2450 VSS.n2449 0.0961384
R8548 VSS.n2459 VSS.n2458 0.0961384
R8549 VSS.n2468 VSS.n2467 0.0961384
R8550 VSS.n2477 VSS.n2476 0.0961384
R8551 VSS.n2486 VSS.n2485 0.0961384
R8552 VSS.n2495 VSS.n2494 0.0961384
R8553 VSS.t373 VSS.n2141 0.0961384
R8554 VSS.n2128 VSS.t654 0.0961384
R8555 VSS.n2112 VSS.t456 0.0961384
R8556 VSS.n2096 VSS.t147 0.0961384
R8557 VSS.n2080 VSS.t127 0.0961384
R8558 VSS.n2064 VSS.t63 0.0961384
R8559 VSS.n2048 VSS.t26 0.0961384
R8560 VSS.n2032 VSS.t426 0.0961384
R8561 VSS.n2016 VSS.t497 0.0961384
R8562 VSS.n2000 VSS.t633 0.0961384
R8563 VSS.n1984 VSS.t399 0.0961384
R8564 VSS.n1968 VSS.t234 0.0961384
R8565 VSS.n1952 VSS.t16 0.0961384
R8566 VSS.n1936 VSS.t225 0.0961384
R8567 VSS.n1920 VSS.t669 0.0961384
R8568 VSS.n1904 VSS.t378 0.0961384
R8569 VSS.n1888 VSS.n2798 0.0961384
R8570 VSS.n1865 VSS.n1593 0.0961384
R8571 VSS.t643 VSS.n1597 0.0961384
R8572 VSS.n1328 VSS.n3134 0.0961384
R8573 VSS.n1324 VSS.n3138 0.0961384
R8574 VSS.t30 VSS.n3142 0.0961384
R8575 VSS.t677 VSS.n3146 0.0961384
R8576 VSS.t481 VSS.n3150 0.0961384
R8577 VSS.t223 VSS.n3174 0.0961384
R8578 VSS.t186 VSS.n1355 0.0961384
R8579 VSS.t640 VSS.n1394 0.0961384
R8580 VSS.t211 VSS.n1433 0.0961384
R8581 VSS.n1476 VSS.n1442 0.0961384
R8582 VSS.n1480 VSS.n1446 0.0961384
R8583 VSS.t33 VSS.n1454 0.0961384
R8584 VSS.t471 VSS.n1517 0.0961384
R8585 VSS.t217 VSS.n1556 0.0961384
R8586 VSS.n3811 VSS.n120 0.0961384
R8587 VSS.n3369 VSS.n3368 0.0961384
R8588 VSS.n3397 VSS.n3396 0.0961384
R8589 VSS.n3239 VSS.n3337 0.0961384
R8590 VSS.t509 VSS.n3229 0.0961384
R8591 VSS.n3351 VSS.n3350 0.0961384
R8592 VSS.n3358 VSS.n3209 0.0961384
R8593 VSS.n1093 VSS.n555 0.0961384
R8594 VSS.t254 VSS.n527 0.0961384
R8595 VSS.n1030 VSS.n491 0.0961384
R8596 VSS.t260 VSS.n471 0.0961384
R8597 VSS.n943 VSS.n411 0.0961384
R8598 VSS.n3533 VSS.n3532 0.0961384
R8599 VSS.n3596 VSS.n3595 0.0961384
R8600 VSS.n3632 VSS.n3631 0.0961384
R8601 VSS.n3676 VSS.n3675 0.0961384
R8602 VSS.n3706 VSS.n3705 0.0961384
R8603 VSS.n3807 VSS.n188 0.0961384
R8604 VSS.n3746 VSS.n136 0.0961384
R8605 VSS.n3288 VSS.n172 0.0961384
R8606 VSS.n3268 VSS.n159 0.0961384
R8607 VSS.n3280 VSS.n165 0.0961384
R8608 VSS.n3405 VSS.n3404 0.0961384
R8609 VSS.n3437 VSS.n3436 0.0961384
R8610 VSS.n1908 VSS.n1907 0.0961384
R8611 VSS.n1924 VSS.n1923 0.0961384
R8612 VSS.n1940 VSS.n1939 0.0961384
R8613 VSS.n1956 VSS.n1955 0.0961384
R8614 VSS.n1972 VSS.n1971 0.0961384
R8615 VSS.n1988 VSS.n1987 0.0961384
R8616 VSS.n2004 VSS.n2003 0.0961384
R8617 VSS.n2020 VSS.n2019 0.0961384
R8618 VSS.n2036 VSS.n2035 0.0961384
R8619 VSS.n2052 VSS.n2051 0.0961384
R8620 VSS.n2068 VSS.n2067 0.0961384
R8621 VSS.n2084 VSS.n2083 0.0961384
R8622 VSS.n2100 VSS.n2099 0.0961384
R8623 VSS.n2116 VSS.n2115 0.0961384
R8624 VSS.n2132 VSS.n2131 0.0961384
R8625 VSS.n2795 VSS.n2794 0.0961384
R8626 VSS.n2539 VSS.t623 0.0961384
R8627 VSS.n2556 VSS.t674 0.0958002
R8628 VSS.n2561 VSS.n2520 0.0958002
R8629 VSS.n2215 VSS.n2214 0.0958002
R8630 VSS.n2224 VSS.n2223 0.0958002
R8631 VSS.n2233 VSS.n2232 0.0958002
R8632 VSS.n2242 VSS.n2241 0.0958002
R8633 VSS.n2251 VSS.n2250 0.0958002
R8634 VSS.n2260 VSS.n2259 0.0958002
R8635 VSS.n2269 VSS.n2268 0.0958002
R8636 VSS.n2278 VSS.n2277 0.0958002
R8637 VSS.n2287 VSS.n2286 0.0958002
R8638 VSS.n2296 VSS.n2295 0.0958002
R8639 VSS.n2305 VSS.n2304 0.0958002
R8640 VSS.n2314 VSS.n2313 0.0958002
R8641 VSS.n2323 VSS.n2322 0.0958002
R8642 VSS.n2332 VSS.n2331 0.0958002
R8643 VSS.n2341 VSS.n2340 0.0958002
R8644 VSS.n2350 VSS.n2349 0.0958002
R8645 VSS.n2359 VSS.n2358 0.0958002
R8646 VSS.n2368 VSS.n2367 0.0958002
R8647 VSS.n2377 VSS.n2376 0.0958002
R8648 VSS.n2386 VSS.n2385 0.0958002
R8649 VSS.n2395 VSS.n2394 0.0958002
R8650 VSS.n2404 VSS.n2403 0.0958002
R8651 VSS.n2413 VSS.n2412 0.0958002
R8652 VSS.n2422 VSS.n2421 0.0958002
R8653 VSS.n2431 VSS.n2430 0.0958002
R8654 VSS.n2440 VSS.n2439 0.0958002
R8655 VSS.n2449 VSS.n2448 0.0958002
R8656 VSS.n2458 VSS.n2457 0.0958002
R8657 VSS.n2467 VSS.n2466 0.0958002
R8658 VSS.n2476 VSS.n2475 0.0958002
R8659 VSS.n2485 VSS.n2484 0.0958002
R8660 VSS.n2494 VSS.n2493 0.0958002
R8661 VSS.t73 VSS.n2132 0.0958002
R8662 VSS.t85 VSS.n2116 0.0958002
R8663 VSS.t66 VSS.n2100 0.0958002
R8664 VSS.t397 VSS.n2084 0.0958002
R8665 VSS.t371 VSS.n2068 0.0958002
R8666 VSS.t628 VSS.n2052 0.0958002
R8667 VSS.t213 VSS.n2036 0.0958002
R8668 VSS.t636 VSS.n2020 0.0958002
R8669 VSS.t139 VSS.n2004 0.0958002
R8670 VSS.t143 VSS.n1988 0.0958002
R8671 VSS.t37 VSS.n1972 0.0958002
R8672 VSS.t208 VSS.n1956 0.0958002
R8673 VSS.t198 VSS.n1940 0.0958002
R8674 VSS.t386 VSS.n1924 0.0958002
R8675 VSS.t517 VSS.n1908 0.0958002
R8676 VSS.t204 VSS.n2795 0.0958002
R8677 VSS.n2141 VSS.n2575 0.0958002
R8678 VSS.t423 VSS.n2128 0.0958002
R8679 VSS.t526 VSS.n2112 0.0958002
R8680 VSS.t391 VSS.n2096 0.0958002
R8681 VSS.t488 VSS.n2080 0.0958002
R8682 VSS.t394 VSS.n2064 0.0958002
R8683 VSS.t10 VSS.n2048 0.0958002
R8684 VSS.t51 VSS.n2032 0.0958002
R8685 VSS.t413 VSS.n2016 0.0958002
R8686 VSS.t410 VSS.n2000 0.0958002
R8687 VSS.t88 VSS.n1984 0.0958002
R8688 VSS.t688 VSS.n1968 0.0958002
R8689 VSS.t693 VSS.n1952 0.0958002
R8690 VSS.t54 VSS.n1936 0.0958002
R8691 VSS.t416 VSS.n1920 0.0958002
R8692 VSS.t430 VSS.n1904 0.0958002
R8693 VSS.t617 VSS.n1593 0.0958002
R8694 VSS.n1869 VSS.n1597 0.0958002
R8695 VSS.n3134 VSS.n1331 0.0958002
R8696 VSS.n3138 VSS.n3137 0.0958002
R8697 VSS.n3142 VSS.n3141 0.0958002
R8698 VSS.n3146 VSS.n3145 0.0958002
R8699 VSS.n3150 VSS.t479 0.0958002
R8700 VSS.n3174 VSS.n3173 0.0958002
R8701 VSS.n1363 VSS.n1355 0.0958002
R8702 VSS.n1402 VSS.n1394 0.0958002
R8703 VSS.n1467 VSS.n1433 0.0958002
R8704 VSS.n2948 VSS.n1442 0.0958002
R8705 VSS.n2940 VSS.n1446 0.0958002
R8706 VSS.n2925 VSS.n1454 0.0958002
R8707 VSS.n1525 VSS.n1517 0.0958002
R8708 VSS.n1564 VSS.n1556 0.0958002
R8709 VSS.n3595 VSS.t269 0.0958002
R8710 VSS.n3631 VSS.n260 0.0958002
R8711 VSS.n3675 VSS.t274 0.0958002
R8712 VSS.n207 VSS.n136 0.0958002
R8713 VSS.n3819 VSS.n120 0.0958002
R8714 VSS.n3807 VSS.n3806 0.0958002
R8715 VSS.n3705 VSS.n227 0.0958002
R8716 VSS.n3532 VSS.t283 0.0958002
R8717 VSS.n3278 VSS.n165 0.0958002
R8718 VSS.n3337 VSS.n3336 0.0958002
R8719 VSS.n3350 VSS.n3349 0.0958002
R8720 VSS.n3358 VSS.n3357 0.0958002
R8721 VSS.n3290 VSS.n172 0.0958002
R8722 VSS.n3270 VSS.n159 0.0958002
R8723 VSS.n768 VSS.n3365 0.0958002
R8724 VSS.n3383 VSS.n3382 0.0958002
R8725 VSS.n3396 VSS.n3395 0.0958002
R8726 VSS.n3404 VSS.n3403 0.0958002
R8727 VSS.n3436 VSS.n3435 0.0958002
R8728 VSS.n890 VSS.n555 0.0958002
R8729 VSS.n1073 VSS.n527 0.0958002
R8730 VSS.n1032 VSS.n491 0.0958002
R8731 VSS.n1010 VSS.n471 0.0958002
R8732 VSS.n940 VSS.n411 0.0958002
R8733 VSS.n3491 VSS.n3490 0.0958002
R8734 VSS.n2543 VSS.t623 0.0958002
R8735 VSS.n3229 VSS.t508 0.0958002
R8736 VSS.n2553 VSS.n2527 0.0955
R8737 VSS.t484 VSS.n2560 0.0955
R8738 VSS.n2565 VSS.n2513 0.0955
R8739 VSS.n2503 VSS.n2502 0.0955
R8740 VSS.n2575 VSS.n2574 0.0955
R8741 VSS.n1865 VSS.n1594 0.0955
R8742 VSS.n1867 VSS.n1594 0.0955
R8743 VSS.n1878 VSS.n1845 0.0955
R8744 VSS.n1880 VSS.n1845 0.0955
R8745 VSS.n3135 VSS.t647 0.0955
R8746 VSS.n3139 VSS.t28 0.0955
R8747 VSS.n3143 VSS.n1318 0.0955
R8748 VSS.n3147 VSS.t702 0.0955
R8749 VSS.n3151 VSS.n1304 0.0955
R8750 VSS.n3175 VSS.n1288 0.0955
R8751 VSS.n3081 VSS.t535 0.0955
R8752 VSS.n1361 VSS.n1360 0.0955
R8753 VSS.n3034 VSS.t550 0.0955
R8754 VSS.n1400 VSS.n1399 0.0955
R8755 VSS.n2987 VSS.t565 0.0955
R8756 VSS.n1465 VSS.n1464 0.0955
R8757 VSS.n1474 VSS.t238 0.0955
R8758 VSS.n1478 VSS.t181 0.0955
R8759 VSS.n1486 VSS.n1459 0.0955
R8760 VSS.n2901 VSS.t580 0.0955
R8761 VSS.n1523 VSS.n1522 0.0955
R8762 VSS.n2854 VSS.t595 0.0955
R8763 VSS.n1562 VSS.n1561 0.0955
R8764 VSS.n2807 VSS.t610 0.0955
R8765 VSS.n3787 VSS.n3786 0.0955
R8766 VSS.n3788 VSS.n3787 0.0955
R8767 VSS.n3753 VSS.n134 0.0955
R8768 VSS.n3751 VSS.n134 0.0955
R8769 VSS.n3737 VSS.n141 0.0955
R8770 VSS.n3735 VSS.n141 0.0955
R8771 VSS.n231 VSS.t268 0.0955
R8772 VSS.n243 VSS.n239 0.0955
R8773 VSS.n264 VSS.t278 0.0955
R8774 VSS.n276 VSS.n272 0.0955
R8775 VSS.n3338 VSS.n3236 0.0955
R8776 VSS.n3339 VSS.n3338 0.0955
R8777 VSS.n3346 VSS.n3345 0.0955
R8778 VSS.n3347 VSS.n3346 0.0955
R8779 VSS.n3353 VSS.t512 0.0955
R8780 VSS.n3209 VSS.n187 0.0955
R8781 VSS.n3308 VSS.n187 0.0955
R8782 VSS.n3250 VSS.n171 0.0955
R8783 VSS.n3378 VSS.n3377 0.0955
R8784 VSS.n3379 VSS.n3378 0.0955
R8785 VSS.n3388 VSS.n3387 0.0955
R8786 VSS.n3389 VSS.n3388 0.0955
R8787 VSS.n3398 VSS.n3397 0.0955
R8788 VSS.n3399 VSS.n3398 0.0955
R8789 VSS.n1091 VSS.t251 0.0955
R8790 VSS.n899 VSS.n313 0.0955
R8791 VSS.n1028 VSS.t258 0.0955
R8792 VSS.n1005 VSS.n354 0.0955
R8793 VSS.n3490 VSS.n3489 0.0955
R8794 VSS.t512 VSS.n3214 0.0955
R8795 VSS.n1288 VSS.t223 0.0955
R8796 VSS.n1304 VSS.t481 0.0955
R8797 VSS.t702 VSS.n1310 0.0955
R8798 VSS.n1318 VSS.t30 0.0955
R8799 VSS.t28 VSS.n1324 0.0955
R8800 VSS.t647 VSS.n1328 0.0955
R8801 VSS.n1361 VSS.t186 0.0955
R8802 VSS.n1400 VSS.t640 0.0955
R8803 VSS.n1465 VSS.t211 0.0955
R8804 VSS.n1523 VSS.t471 0.0955
R8805 VSS.n1562 VSS.t217 0.0955
R8806 VSS.n2520 VSS.t484 0.0955
R8807 VSS.t674 VSS.n2527 0.0955
R8808 VSS.t610 VSS.n1580 0.0955
R8809 VSS.t595 VSS.n1541 0.0955
R8810 VSS.t580 VSS.n1502 0.0955
R8811 VSS.t33 VSS.n1459 0.0955
R8812 VSS.n1480 VSS.t181 0.0955
R8813 VSS.n1476 VSS.t238 0.0955
R8814 VSS.t565 VSS.n1418 0.0955
R8815 VSS.t550 VSS.n1379 0.0955
R8816 VSS.t535 VSS.n1340 0.0955
R8817 VSS.n1093 VSS.t251 0.0955
R8818 VSS.t254 VSS.n313 0.0955
R8819 VSS.n1030 VSS.t258 0.0955
R8820 VSS.n943 VSS.t266 0.0955
R8821 VSS.t260 VSS.n354 0.0955
R8822 VSS.n272 VSS.t269 0.0955
R8823 VSS.t278 VSS.n260 0.0955
R8824 VSS.n239 VSS.t274 0.0955
R8825 VSS.t268 VSS.n227 0.0955
R8826 VSS.n3268 VSS.n3267 0.09425
R8827 VSS.n3443 VSS.n3442 0.09425
R8828 VSS.n597 VSS.n599 0.093
R8829 VSS.n2147 VSS.t69 0.0928744
R8830 VSS.n2509 VSS.t115 0.08925
R8831 VSS.t539 VSS.n1342 0.08925
R8832 VSS.t554 VSS.n1381 0.08925
R8833 VSS.t569 VSS.n1420 0.08925
R8834 VSS.t584 VSS.n1504 0.08925
R8835 VSS.t599 VSS.n1543 0.08925
R8836 VSS.t615 VSS.n1582 0.08925
R8837 VSS.n698 VSS.n697 0.0871176
R8838 VSS.n3259 VSS.n155 0.0871176
R8839 VSS.n3475 VSS.t111 0.0851154
R8840 VSS.n3473 VSS.t114 0.0851154
R8841 VSS.n3479 VSS.t105 0.0851154
R8842 VSS.n3477 VSS.t108 0.0851154
R8843 VSS.n2573 VSS.t117 0.0851154
R8844 VSS.n2142 VSS.t119 0.0851154
R8845 VSS.n3277 VSS.n164 0.08425
R8846 VSS.n3433 VSS.n3432 0.08425
R8847 VSS.n3288 VSS.n3287 0.08175
R8848 VSS.n3421 VSS.n713 0.08175
R8849 VSS.n3480 VSS.n3479 0.08175
R8850 VSS.n596 VSS.n3475 0.08175
R8851 VSS.n602 VSS.n603 0.08175
R8852 VSS.n592 VSS.n593 0.08175
R8853 VSS.t124 VSS.n1886 0.0805
R8854 VSS.n151 VSS.n150 0.0805
R8855 VSS.n772 VSS.n6 0.0796176
R8856 VSS.n771 VSS.n770 0.0796176
R8857 VSS.n3498 VSS.n583 0.0780484
R8858 VSS.t529 VSS.n1284 0.078
R8859 VSS.t544 VSS.n3050 0.078
R8860 VSS.t559 VSS.n3003 0.078
R8861 VSS.t574 VSS.n2917 0.078
R8862 VSS.t589 VSS.n2870 0.078
R8863 VSS.t604 VSS.n2823 0.078
R8864 VSS.n2573 VSS.n2572 0.0746176
R8865 VSS.n3258 VSS.n151 0.07425
R8866 VSS.n3481 VSS.n608 0.0740901
R8867 VSS.n606 VSS.t103 0.0740901
R8868 VSS.n1119 VSS.n1118 0.0726677
R8869 VSS.n635 VSS.n634 0.0726677
R8870 VSS.n663 VSS.n626 0.0726677
R8871 VSS.n1259 VSS.n800 0.0726677
R8872 VSS.n2513 VSS.n2512 0.07175
R8873 VSS.n2497 VSS.n2500 0.06925
R8874 VSS.t71 VSS.n2573 0.06925
R8875 VSS.t534 VSS.n3087 0.06925
R8876 VSS.t549 VSS.n1372 0.06925
R8877 VSS.t564 VSS.n1411 0.06925
R8878 VSS.t579 VSS.n1495 0.06925
R8879 VSS.t594 VSS.n1534 0.06925
R8880 VSS.t609 VSS.n1573 0.06925
R8881 VSS.n3253 VSS.n164 0.06925
R8882 VSS.n3434 VSS.n3433 0.06925
R8883 VSS.n1164 VSS.n860 0.0672586
R8884 VSS.n629 VSS.n604 0.0672586
R8885 VSS.n860 VSS.n858 0.0672586
R8886 VSS.n1263 VSS.n1262 0.0672168
R8887 VSS.n3478 VSS.n3477 0.0671176
R8888 VSS.n3474 VSS.n3473 0.0671176
R8889 VSS.n601 VSS.n600 0.0671176
R8890 VSS.n591 VSS.n590 0.0671176
R8891 VSS.n3082 VSS.n3081 0.066499
R8892 VSS.n3035 VSS.n3034 0.066499
R8893 VSS.n2988 VSS.n2987 0.066499
R8894 VSS.n2902 VSS.n2901 0.066499
R8895 VSS.n2855 VSS.n2854 0.066499
R8896 VSS.n2808 VSS.n2807 0.066499
R8897 VSS.n3365 VSS.n771 0.06425
R8898 VSS.n713 VSS.n708 0.0621177
R8899 VSS.n3479 VSS.n3478 0.0621177
R8900 VSS.n3475 VSS.n3474 0.0621177
R8901 VSS.n600 VSS.n602 0.0621177
R8902 VSS.n590 VSS.n592 0.0621177
R8903 VSS.n1266 VSS.n1265 0.060789
R8904 VSS.t345 VSS.n1268 0.060789
R8905 VSS.n1269 VSS.t343 0.060789
R8906 VSS.n1242 VSS.n781 0.060789
R8907 VSS.n1240 VSS.n783 0.060789
R8908 VSS.n1232 VSS.n784 0.060789
R8909 VSS.n1230 VSS.n785 0.060789
R8910 VSS.n1222 VSS.n787 0.060789
R8911 VSS.n1221 VSS.n809 0.060789
R8912 VSS.n833 VSS.n1215 0.060789
R8913 VSS.n1206 VSS.n812 0.060789
R8914 VSS.t155 VSS.n814 0.060789
R8915 VSS.t348 VSS.n829 0.060789
R8916 VSS.t683 VSS.n817 0.060789
R8917 VSS.n1185 VSS.n825 0.060789
R8918 VSS.n1182 VSS.n824 0.060789
R8919 VSS.t12 VSS.n822 0.060789
R8920 VSS.n1175 VSS.t717 0.060789
R8921 VSS.n1163 VSS.n848 0.060789
R8922 VSS.n1159 VSS.n849 0.060789
R8923 VSS.n1153 VSS.n850 0.060789
R8924 VSS.n1149 VSS.n852 0.060789
R8925 VSS.n1147 VSS.n866 0.060789
R8926 VSS.n879 VSS.n1141 0.060789
R8927 VSS.t19 VSS.n869 0.060789
R8928 VSS.n1122 VSS.n871 0.060789
R8929 VSS.t21 VSS.n872 0.060789
R8930 VSS.n1117 VSS.n873 0.060789
R8931 VSS.n659 VSS.n624 0.060789
R8932 VSS.t713 VSS.n613 0.060789
R8933 VSS.n633 VSS.n618 0.060789
R8934 VSS.n641 VSS.t388 0.060789
R8935 VSS.n639 VSS.n638 0.060789
R8936 VSS.n664 VSS.n624 0.060789
R8937 VSS.t4 VSS.n613 0.060789
R8938 VSS.n628 VSS.n621 0.060789
R8939 VSS.n648 VSS.n618 0.060789
R8940 VSS.n1265 VSS.n1264 0.060789
R8941 VSS.n1268 VSS.n1267 0.060789
R8942 VSS.n1269 VSS.n794 0.060789
R8943 VSS.n1248 VSS.n781 0.060789
R8944 VSS.n1243 VSS.n783 0.060789
R8945 VSS.n1239 VSS.n784 0.060789
R8946 VSS.n1233 VSS.n785 0.060789
R8947 VSS.n1229 VSS.n787 0.060789
R8948 VSS.n1223 VSS.n1221 0.060789
R8949 VSS.n1215 VSS.n1214 0.060789
R8950 VSS.n831 VSS.n812 0.060789
R8951 VSS.n1205 VSS.n814 0.060789
R8952 VSS.n1198 VSS.n829 0.060789
R8953 VSS.n1192 VSS.n817 0.060789
R8954 VSS.n840 VSS.n825 0.060789
R8955 VSS.t91 VSS.n824 0.060789
R8956 VSS.n1181 VSS.n822 0.060789
R8957 VSS.n1176 VSS.n1175 0.060789
R8958 VSS.n857 VSS.n846 0.060789
R8959 VSS.n1162 VSS.n849 0.060789
R8960 VSS.n1158 VSS.n850 0.060789
R8961 VSS.n1152 VSS.n852 0.060789
R8962 VSS.n1148 VSS.n1147 0.060789
R8963 VSS.n1141 VSS.n1140 0.060789
R8964 VSS.n877 VSS.n869 0.060789
R8965 VSS.n1129 VSS.n871 0.060789
R8966 VSS.n1123 VSS.n872 0.060789
R8967 VSS.n1120 VSS.n873 0.060789
R8968 VSS.n2498 VSS.n2497 0.05925
R8969 VSS.n2142 VSS.t71 0.05925
R8970 VSS.n942 VSS.t266 0.058
R8971 VSS.n595 VSS.t272 0.0571176
R8972 VSS.n3259 VSS.n3260 0.05675
R8973 VSS.n3445 VSS.n698 0.05675
R8974 VSS.n1262 VSS.n1261 0.0553461
R8975 VSS.n2501 VSS.t115 0.0546176
R8976 VSS.n3087 VSS.t532 0.05175
R8977 VSS.t547 VSS.n1372 0.05175
R8978 VSS.t562 VSS.n1411 0.05175
R8979 VSS.t577 VSS.n1495 0.05175
R8980 VSS.t592 VSS.n1534 0.05175
R8981 VSS.t607 VSS.n1573 0.05175
R8982 VSS.n3267 VSS.n156 0.0496177
R8983 VSS.n3444 VSS.n3443 0.0496177
R8984 VSS.n599 VSS.n594 0.04925
R8985 VSS.t77 VSS.n2547 0.0483676
R8986 VSS.n2548 VSS.n2538 0.0483676
R8987 VSS.n2551 VSS.n2533 0.0483676
R8988 VSS.n2532 VSS.n2552 0.0483676
R8989 VSS.n2553 VSS.t356 0.0483676
R8990 VSS.t354 VSS.n2526 0.0483676
R8991 VSS.n2560 VSS.n2521 0.0483676
R8992 VSS.t369 VSS.n2516 0.0483676
R8993 VSS.t407 VSS.n2515 0.0483676
R8994 VSS.n2565 VSS.n2514 0.0483676
R8995 VSS.n2218 VSS.n2217 0.0483676
R8996 VSS.n2227 VSS.n2226 0.0483676
R8997 VSS.n2236 VSS.n2235 0.0483676
R8998 VSS.n2245 VSS.n2244 0.0483676
R8999 VSS.n2254 VSS.n2253 0.0483676
R9000 VSS.n2263 VSS.n2262 0.0483676
R9001 VSS.n2272 VSS.n2271 0.0483676
R9002 VSS.n2281 VSS.n2280 0.0483676
R9003 VSS.n2290 VSS.n2289 0.0483676
R9004 VSS.n2299 VSS.n2298 0.0483676
R9005 VSS.n2308 VSS.n2307 0.0483676
R9006 VSS.n2317 VSS.n2316 0.0483676
R9007 VSS.n2326 VSS.n2325 0.0483676
R9008 VSS.n2335 VSS.n2334 0.0483676
R9009 VSS.n2344 VSS.n2343 0.0483676
R9010 VSS.n2353 VSS.n2352 0.0483676
R9011 VSS.n2362 VSS.n2361 0.0483676
R9012 VSS.n2371 VSS.n2370 0.0483676
R9013 VSS.n2380 VSS.n2379 0.0483676
R9014 VSS.n2389 VSS.n2388 0.0483676
R9015 VSS.n2398 VSS.n2397 0.0483676
R9016 VSS.n2407 VSS.n2406 0.0483676
R9017 VSS.n2416 VSS.n2415 0.0483676
R9018 VSS.n2425 VSS.n2424 0.0483676
R9019 VSS.n2434 VSS.n2433 0.0483676
R9020 VSS.n2443 VSS.n2442 0.0483676
R9021 VSS.n2452 VSS.n2451 0.0483676
R9022 VSS.n2461 VSS.n2460 0.0483676
R9023 VSS.n2470 VSS.n2469 0.0483676
R9024 VSS.n2479 VSS.n2478 0.0483676
R9025 VSS.n2488 VSS.n2487 0.0483676
R9026 VSS.n2503 VSS.n2496 0.0483676
R9027 VSS.n2499 VSS.n2501 0.0483676
R9028 VSS.n2140 VSS.n2138 0.0483676
R9029 VSS.n2123 VSS.n2125 0.0483676
R9030 VSS.n2107 VSS.n2109 0.0483676
R9031 VSS.n2091 VSS.n2093 0.0483676
R9032 VSS.n2075 VSS.n2077 0.0483676
R9033 VSS.n2059 VSS.n2061 0.0483676
R9034 VSS.n2043 VSS.n2045 0.0483676
R9035 VSS.n2027 VSS.n2029 0.0483676
R9036 VSS.n2011 VSS.n2013 0.0483676
R9037 VSS.n1995 VSS.n1997 0.0483676
R9038 VSS.n1979 VSS.n1981 0.0483676
R9039 VSS.n1963 VSS.n1965 0.0483676
R9040 VSS.n1947 VSS.n1949 0.0483676
R9041 VSS.n1931 VSS.n1933 0.0483676
R9042 VSS.n1915 VSS.n1917 0.0483676
R9043 VSS.n1898 VSS.n1900 0.0483676
R9044 VSS.n2572 VSS.n2571 0.0483676
R9045 VSS.n2581 VSS.t709 0.0483676
R9046 VSS.n2583 VSS.n2582 0.0483676
R9047 VSS.n2587 VSS.n2129 0.0483676
R9048 VSS.t167 VSS.n2121 0.0483676
R9049 VSS.n2120 VSS.n2119 0.0483676
R9050 VSS.n2601 VSS.n2113 0.0483676
R9051 VSS.t196 VSS.n2105 0.0483676
R9052 VSS.n2104 VSS.n2103 0.0483676
R9053 VSS.n2615 VSS.n2097 0.0483676
R9054 VSS.t663 VSS.n2089 0.0483676
R9055 VSS.n2088 VSS.n2087 0.0483676
R9056 VSS.n2629 VSS.n2081 0.0483676
R9057 VSS.t436 VSS.n2073 0.0483676
R9058 VSS.n2072 VSS.n2071 0.0483676
R9059 VSS.n2643 VSS.n2065 0.0483676
R9060 VSS.t445 VSS.n2057 0.0483676
R9061 VSS.n2056 VSS.n2055 0.0483676
R9062 VSS.n2657 VSS.n2049 0.0483676
R9063 VSS.t439 VSS.n2041 0.0483676
R9064 VSS.n2040 VSS.n2039 0.0483676
R9065 VSS.n2671 VSS.n2033 0.0483676
R9066 VSS.t451 VSS.n2025 0.0483676
R9067 VSS.n2024 VSS.n2023 0.0483676
R9068 VSS.n2685 VSS.n2017 0.0483676
R9069 VSS.t448 VSS.n2009 0.0483676
R9070 VSS.n2008 VSS.n2007 0.0483676
R9071 VSS.n2699 VSS.n2001 0.0483676
R9072 VSS.t660 VSS.n1993 0.0483676
R9073 VSS.n1992 VSS.n1991 0.0483676
R9074 VSS.n2713 VSS.n1985 0.0483676
R9075 VSS.t433 VSS.n1977 0.0483676
R9076 VSS.n1976 VSS.n1975 0.0483676
R9077 VSS.n2727 VSS.n1969 0.0483676
R9078 VSS.t220 VSS.n1961 0.0483676
R9079 VSS.n1960 VSS.n1959 0.0483676
R9080 VSS.n2741 VSS.n1953 0.0483676
R9081 VSS.t442 VSS.n1945 0.0483676
R9082 VSS.n1944 VSS.n1943 0.0483676
R9083 VSS.n2755 VSS.n1937 0.0483676
R9084 VSS.t454 VSS.n1929 0.0483676
R9085 VSS.n1928 VSS.n1927 0.0483676
R9086 VSS.n2769 VSS.n1921 0.0483676
R9087 VSS.t48 VSS.n1913 0.0483676
R9088 VSS.n1912 VSS.n1911 0.0483676
R9089 VSS.n2783 VSS.n1905 0.0483676
R9090 VSS.t42 VSS.n1894 0.0483676
R9091 VSS.n2793 VSS.n2792 0.0483676
R9092 VSS.n1874 VSS.n1842 0.0483676
R9093 VSS.n1876 VSS.n1843 0.0483676
R9094 VSS.n1878 VSS.n1844 0.0483676
R9095 VSS.n1880 VSS.n1846 0.0483676
R9096 VSS.n1848 VSS.n1847 0.0483676
R9097 VSS.n2799 VSS.n1884 0.0483676
R9098 VSS.n1867 VSS.n1595 0.0483676
R9099 VSS.n1872 VSS.n1841 0.0483676
R9100 VSS.n3133 VSS.t363 0.0483676
R9101 VSS.n1310 VSS.n1312 0.0483676
R9102 VSS.n1340 VSS.n1337 0.0483676
R9103 VSS.n1379 VSS.n1377 0.0483676
R9104 VSS.n1418 VSS.n1416 0.0483676
R9105 VSS.n1502 VSS.n1500 0.0483676
R9106 VSS.n1541 VSS.n1539 0.0483676
R9107 VSS.n1580 VSS.n1578 0.0483676
R9108 VSS.n2801 VSS.n1588 0.0483676
R9109 VSS.t614 VSS.n1587 0.0483676
R9110 VSS.n3136 VSS.n3135 0.0483676
R9111 VSS.n1322 VSS.n3139 0.0483676
R9112 VSS.n3140 VSS.t523 0.0483676
R9113 VSS.t383 VSS.n3143 0.0483676
R9114 VSS.n3144 VSS.n1316 0.0483676
R9115 VSS.n3148 VSS.n3147 0.0483676
R9116 VSS.n1307 VSS.n3149 0.0483676
R9117 VSS.n1302 VSS.n3151 0.0483676
R9118 VSS.n3152 VSS.t136 0.0483676
R9119 VSS.n3154 VSS.n3153 0.0483676
R9120 VSS.n3156 VSS.n3155 0.0483676
R9121 VSS.n3158 VSS.n3157 0.0483676
R9122 VSS.n3160 VSS.n3159 0.0483676
R9123 VSS.n3162 VSS.n3161 0.0483676
R9124 VSS.n3164 VSS.n3163 0.0483676
R9125 VSS.n3166 VSS.n3165 0.0483676
R9126 VSS.n3168 VSS.n3167 0.0483676
R9127 VSS.n3170 VSS.n3169 0.0483676
R9128 VSS.n3172 VSS.n3171 0.0483676
R9129 VSS.n3176 VSS.n3175 0.0483676
R9130 VSS.n3178 VSS.n3177 0.0483676
R9131 VSS.n1284 VSS.n1280 0.0483676
R9132 VSS.t530 VSS.n1281 0.0483676
R9133 VSS.n3075 VSS.n1348 0.0483676
R9134 VSS.t540 VSS.n1347 0.0483676
R9135 VSS.t542 VSS.n1352 0.0483676
R9136 VSS.n3058 VSS.n1353 0.0483676
R9137 VSS.n3057 VSS.n1354 0.0483676
R9138 VSS.n1360 VSS.n1357 0.0483676
R9139 VSS.n3052 VSS.n1358 0.0483676
R9140 VSS.n3050 VSS.n1368 0.0483676
R9141 VSS.t545 VSS.n1367 0.0483676
R9142 VSS.n3028 VSS.n1387 0.0483676
R9143 VSS.t555 VSS.n1386 0.0483676
R9144 VSS.t557 VSS.n1391 0.0483676
R9145 VSS.n3011 VSS.n1392 0.0483676
R9146 VSS.n3010 VSS.n1393 0.0483676
R9147 VSS.n1399 VSS.n1396 0.0483676
R9148 VSS.n3005 VSS.n1397 0.0483676
R9149 VSS.n3003 VSS.n1407 0.0483676
R9150 VSS.t560 VSS.n1406 0.0483676
R9151 VSS.n2981 VSS.n1426 0.0483676
R9152 VSS.t570 VSS.n1425 0.0483676
R9153 VSS.t572 VSS.n1430 0.0483676
R9154 VSS.n2964 VSS.n1431 0.0483676
R9155 VSS.n2963 VSS.n1432 0.0483676
R9156 VSS.n1464 VSS.n1435 0.0483676
R9157 VSS.n2958 VSS.n1436 0.0483676
R9158 VSS.n2956 VSS.n1437 0.0483676
R9159 VSS.n1472 VSS.n1438 0.0483676
R9160 VSS.n1470 VSS.n1439 0.0483676
R9161 VSS.n2950 VSS.n1441 0.0483676
R9162 VSS.n1474 VSS.n1444 0.0483676
R9163 VSS.n2942 VSS.n1445 0.0483676
R9164 VSS.n1478 VSS.n1448 0.0483676
R9165 VSS.t183 VSS.n1449 0.0483676
R9166 VSS.n2933 VSS.n1450 0.0483676
R9167 VSS.n1484 VSS.n1451 0.0483676
R9168 VSS.n1482 VSS.n1452 0.0483676
R9169 VSS.n2927 VSS.n1453 0.0483676
R9170 VSS.n1486 VSS.n1456 0.0483676
R9171 VSS.n2919 VSS.n1457 0.0483676
R9172 VSS.n2917 VSS.n1491 0.0483676
R9173 VSS.t575 VSS.n1490 0.0483676
R9174 VSS.n2895 VSS.n1510 0.0483676
R9175 VSS.t585 VSS.n1509 0.0483676
R9176 VSS.t587 VSS.n1514 0.0483676
R9177 VSS.n2878 VSS.n1515 0.0483676
R9178 VSS.n2877 VSS.n1516 0.0483676
R9179 VSS.n1522 VSS.n1519 0.0483676
R9180 VSS.n2872 VSS.n1520 0.0483676
R9181 VSS.n2870 VSS.n1530 0.0483676
R9182 VSS.t590 VSS.n1529 0.0483676
R9183 VSS.n2848 VSS.n1549 0.0483676
R9184 VSS.t600 VSS.n1548 0.0483676
R9185 VSS.t602 VSS.n1553 0.0483676
R9186 VSS.n2831 VSS.n1554 0.0483676
R9187 VSS.n2830 VSS.n1555 0.0483676
R9188 VSS.n1561 VSS.n1558 0.0483676
R9189 VSS.n2825 VSS.n1559 0.0483676
R9190 VSS.n2823 VSS.n1569 0.0483676
R9191 VSS.t605 VSS.n1568 0.0483676
R9192 VSS.n3813 VSS.n3812 0.0483676
R9193 VSS.n3786 VSS.n28 0.0483676
R9194 VSS.n3371 VSS.n3370 0.0483676
R9195 VSS.n3373 VSS.n3372 0.0483676
R9196 VSS.n3375 VSS.n3374 0.0483676
R9197 VSS.n3377 VSS.n3376 0.0483676
R9198 VSS.t502 VSS.n3381 0.0483676
R9199 VSS.n754 VSS.n736 0.0483676
R9200 VSS.n3387 VSS.n3386 0.0483676
R9201 VSS.t505 VSS.n777 0.0483676
R9202 VSS.n3343 VSS.n3227 0.0483676
R9203 VSS.n3345 VSS.n3344 0.0483676
R9204 VSS.n3214 VSS.n3352 0.0483676
R9205 VSS.n3535 VSS.n3534 0.0483676
R9206 VSS.n3537 VSS.n3536 0.0483676
R9207 VSS.n3539 VSS.n3538 0.0483676
R9208 VSS.n3541 VSS.n3540 0.0483676
R9209 VSS.n3543 VSS.n3542 0.0483676
R9210 VSS.n3545 VSS.n3544 0.0483676
R9211 VSS.n3547 VSS.n3546 0.0483676
R9212 VSS.n3549 VSS.n3548 0.0483676
R9213 VSS.n3550 VSS.t281 0.0483676
R9214 VSS.n3552 VSS.n3551 0.0483676
R9215 VSS.n3554 VSS.n3553 0.0483676
R9216 VSS.n3556 VSS.n3555 0.0483676
R9217 VSS.n3558 VSS.n3557 0.0483676
R9218 VSS.n3560 VSS.n3559 0.0483676
R9219 VSS.n3562 VSS.n3561 0.0483676
R9220 VSS.n3564 VSS.n3563 0.0483676
R9221 VSS.n3566 VSS.n3565 0.0483676
R9222 VSS.t270 VSS.n3567 0.0483676
R9223 VSS.n3569 VSS.n3568 0.0483676
R9224 VSS.n3571 VSS.n3570 0.0483676
R9225 VSS.n3573 VSS.n3572 0.0483676
R9226 VSS.n3575 VSS.n3574 0.0483676
R9227 VSS.n3577 VSS.n3576 0.0483676
R9228 VSS.n3579 VSS.n3578 0.0483676
R9229 VSS.n3581 VSS.n3580 0.0483676
R9230 VSS.n3583 VSS.n3582 0.0483676
R9231 VSS.n277 VSS.n276 0.0483676
R9232 VSS.n3598 VSS.n3597 0.0483676
R9233 VSS.n3600 VSS.n3599 0.0483676
R9234 VSS.n3602 VSS.n3601 0.0483676
R9235 VSS.n3604 VSS.n3603 0.0483676
R9236 VSS.n3606 VSS.n3605 0.0483676
R9237 VSS.n3608 VSS.n3607 0.0483676
R9238 VSS.n3610 VSS.n3609 0.0483676
R9239 VSS.n265 VSS.n264 0.0483676
R9240 VSS.n3634 VSS.n3633 0.0483676
R9241 VSS.n3636 VSS.n3635 0.0483676
R9242 VSS.n3638 VSS.n3637 0.0483676
R9243 VSS.n3640 VSS.n3639 0.0483676
R9244 VSS.n3642 VSS.n3641 0.0483676
R9245 VSS.n3644 VSS.n3643 0.0483676
R9246 VSS.n3646 VSS.n3645 0.0483676
R9247 VSS.t276 VSS.n3647 0.0483676
R9248 VSS.n3649 VSS.n3648 0.0483676
R9249 VSS.n3651 VSS.n3650 0.0483676
R9250 VSS.n3653 VSS.n3652 0.0483676
R9251 VSS.n3655 VSS.n3654 0.0483676
R9252 VSS.n3657 VSS.n3656 0.0483676
R9253 VSS.n3659 VSS.n3658 0.0483676
R9254 VSS.n3661 VSS.n3660 0.0483676
R9255 VSS.n3663 VSS.n3662 0.0483676
R9256 VSS.n244 VSS.n243 0.0483676
R9257 VSS.n3678 VSS.n3677 0.0483676
R9258 VSS.n3680 VSS.n3679 0.0483676
R9259 VSS.n3682 VSS.n3681 0.0483676
R9260 VSS.n3684 VSS.n3683 0.0483676
R9261 VSS.n3686 VSS.n3685 0.0483676
R9262 VSS.n3688 VSS.n3687 0.0483676
R9263 VSS.n3690 VSS.n3689 0.0483676
R9264 VSS.n232 VSS.n231 0.0483676
R9265 VSS.n3708 VSS.n3707 0.0483676
R9266 VSS.n3710 VSS.n3709 0.0483676
R9267 VSS.n3712 VSS.n3711 0.0483676
R9268 VSS.n3714 VSS.n3713 0.0483676
R9269 VSS.n3716 VSS.n3715 0.0483676
R9270 VSS.n3718 VSS.n3717 0.0483676
R9271 VSS.n3720 VSS.n3719 0.0483676
R9272 VSS.n3722 VSS.n3721 0.0483676
R9273 VSS.n3723 VSS.t267 0.0483676
R9274 VSS.n3764 VSS.n128 0.0483676
R9275 VSS.n3762 VSS.n129 0.0483676
R9276 VSS.n3760 VSS.n130 0.0483676
R9277 VSS.n204 VSS.n131 0.0483676
R9278 VSS.n3755 VSS.n132 0.0483676
R9279 VSS.n3753 VSS.n133 0.0483676
R9280 VSS.n3744 VSS.n137 0.0483676
R9281 VSS.n3742 VSS.n138 0.0483676
R9282 VSS.n210 VSS.n139 0.0483676
R9283 VSS.n3737 VSS.n140 0.0483676
R9284 VSS.n3848 VSS.n108 0.0483676
R9285 VSS.n3849 VSS.n3847 0.0483676
R9286 VSS.n3846 VSS.n3845 0.0483676
R9287 VSS.n3844 VSS.n112 0.0483676
R9288 VSS.n3836 VSS.n3835 0.0483676
R9289 VSS.n3837 VSS.n3834 0.0483676
R9290 VSS.n3833 VSS.n3832 0.0483676
R9291 VSS.n3831 VSS.n116 0.0483676
R9292 VSS.n3824 VSS.n3823 0.0483676
R9293 VSS.n3825 VSS.n3822 0.0483676
R9294 VSS.n3821 VSS.n3820 0.0483676
R9295 VSS.n3789 VSS.n3788 0.0483676
R9296 VSS.n3791 VSS.n3790 0.0483676
R9297 VSS.n3793 VSS.n3792 0.0483676
R9298 VSS.n3795 VSS.n3794 0.0483676
R9299 VSS.n3797 VSS.n3796 0.0483676
R9300 VSS.n3799 VSS.n3798 0.0483676
R9301 VSS.n3801 VSS.n3800 0.0483676
R9302 VSS.n3803 VSS.n3802 0.0483676
R9303 VSS.n3805 VSS.n3804 0.0483676
R9304 VSS.n3771 VSS.n125 0.0483676
R9305 VSS.n3769 VSS.n126 0.0483676
R9306 VSS.n201 VSS.n127 0.0483676
R9307 VSS.n3751 VSS.n135 0.0483676
R9308 VSS.n3735 VSS.n142 0.0483676
R9309 VSS.n3733 VSS.n143 0.0483676
R9310 VSS.n213 VSS.n144 0.0483676
R9311 VSS.n3728 VSS.n145 0.0483676
R9312 VSS.n3260 VSS.n156 0.0483676
R9313 VSS.n3857 VSS.n6 0.0483676
R9314 VSS.n3335 VSS.n3333 0.0483676
R9315 VSS.n3340 VSS.n3339 0.0483676
R9316 VSS.n3342 VSS.n3341 0.0483676
R9317 VSS.n3222 VSS.n3347 0.0483676
R9318 VSS.n3220 VSS.t510 0.0483676
R9319 VSS.n3348 VSS.t511 0.0483676
R9320 VSS.n3354 VSS.n3353 0.0483676
R9321 VSS.n3356 VSS.n3355 0.0483676
R9322 VSS.n3308 VSS.n186 0.0483676
R9323 VSS.n3306 VSS.n184 0.0483676
R9324 VSS.n3244 VSS.n182 0.0483676
R9325 VSS.n3301 VSS.n180 0.0483676
R9326 VSS.n3299 VSS.n179 0.0483676
R9327 VSS.n3297 VSS.n178 0.0483676
R9328 VSS.n3247 VSS.n175 0.0483676
R9329 VSS.n3292 VSS.n174 0.0483676
R9330 VSS.n3250 VSS.n169 0.0483676
R9331 VSS.n3282 VSS.n167 0.0483676
R9332 VSS.n3254 VSS.n163 0.0483676
R9333 VSS.n3272 VSS.n160 0.0483676
R9334 VSS.n3412 VSS.n3411 0.0483676
R9335 VSS.n3414 VSS.n3413 0.0483676
R9336 VSS.n3417 VSS.n714 0.0483676
R9337 VSS.n3419 VSS.n3418 0.0483676
R9338 VSS.n3421 VSS.n3420 0.0483676
R9339 VSS.n3424 VSS.n708 0.0483676
R9340 VSS.n3426 VSS.n3425 0.0483676
R9341 VSS.n3428 VSS.n3427 0.0483676
R9342 VSS.n3431 VSS.n703 0.0483676
R9343 VSS.n3440 VSS.n699 0.0483676
R9344 VSS.n3442 VSS.n3441 0.0483676
R9345 VSS.n3445 VSS.n3444 0.0483676
R9346 VSS.n697 VSS.n696 0.0483676
R9347 VSS.n689 VSS.n692 0.0483676
R9348 VSS.n770 VSS.n3364 0.0483676
R9349 VSS.n3367 VSS.n3366 0.0483676
R9350 VSS.n3380 VSS.n3379 0.0483676
R9351 VSS.n3390 VSS.n3389 0.0483676
R9352 VSS.n3392 VSS.n3391 0.0483676
R9353 VSS.n3394 VSS.n3393 0.0483676
R9354 VSS.n3400 VSS.n3399 0.0483676
R9355 VSS.n3402 VSS.n3401 0.0483676
R9356 VSS.n1115 VSS.t252 0.0483676
R9357 VSS.n884 VSS.n576 0.0483676
R9358 VSS.n1111 VSS.n573 0.0483676
R9359 VSS.n1109 VSS.n570 0.0483676
R9360 VSS.n1107 VSS.n567 0.0483676
R9361 VSS.n887 VSS.n564 0.0483676
R9362 VSS.n1102 VSS.n563 0.0483676
R9363 VSS.n1100 VSS.n562 0.0483676
R9364 VSS.n1098 VSS.n558 0.0483676
R9365 VSS.n1091 VSS.n550 0.0483676
R9366 VSS.n1089 VSS.n547 0.0483676
R9367 VSS.n893 VSS.n544 0.0483676
R9368 VSS.n1084 VSS.n541 0.0483676
R9369 VSS.n1082 VSS.n538 0.0483676
R9370 VSS.n1080 VSS.n537 0.0483676
R9371 VSS.n896 VSS.n533 0.0483676
R9372 VSS.n1075 VSS.n530 0.0483676
R9373 VSS.n899 VSS.n522 0.0483676
R9374 VSS.n1067 VSS.n519 0.0483676
R9375 VSS.n1065 VSS.n518 0.0483676
R9376 VSS.n1063 VSS.n517 0.0483676
R9377 VSS.n902 VSS.n516 0.0483676
R9378 VSS.n1058 VSS.n515 0.0483676
R9379 VSS.n1056 VSS.n511 0.0483676
R9380 VSS.n1054 VSS.n508 0.0483676
R9381 VSS.n905 VSS.n505 0.0483676
R9382 VSS.t256 VSS.n504 0.0483676
R9383 VSS.n1048 VSS.n503 0.0483676
R9384 VSS.n1046 VSS.n502 0.0483676
R9385 VSS.n908 VSS.n501 0.0483676
R9386 VSS.n1041 VSS.n500 0.0483676
R9387 VSS.n1039 VSS.n496 0.0483676
R9388 VSS.n1037 VSS.n493 0.0483676
R9389 VSS.n911 VSS.n492 0.0483676
R9390 VSS.n1028 VSS.n485 0.0483676
R9391 VSS.n914 VSS.n482 0.0483676
R9392 VSS.n1023 VSS.n479 0.0483676
R9393 VSS.n1021 VSS.n478 0.0483676
R9394 VSS.n1019 VSS.n475 0.0483676
R9395 VSS.n917 VSS.n474 0.0483676
R9396 VSS.n1014 VSS.n473 0.0483676
R9397 VSS.n1012 VSS.n472 0.0483676
R9398 VSS.n1005 VSS.n470 0.0483676
R9399 VSS.n1003 VSS.n469 0.0483676
R9400 VSS.n1001 VSS.n468 0.0483676
R9401 VSS.n922 VSS.n467 0.0483676
R9402 VSS.n996 VSS.n464 0.0483676
R9403 VSS.n994 VSS.n460 0.0483676
R9404 VSS.n992 VSS.n457 0.0483676
R9405 VSS.n925 VSS.n454 0.0483676
R9406 VSS.n987 VSS.n453 0.0483676
R9407 VSS.t262 VSS.n452 0.0483676
R9408 VSS.n984 VSS.n448 0.0483676
R9409 VSS.n928 VSS.n445 0.0483676
R9410 VSS.n979 VSS.n442 0.0483676
R9411 VSS.n977 VSS.n439 0.0483676
R9412 VSS.n975 VSS.n436 0.0483676
R9413 VSS.n931 VSS.n433 0.0483676
R9414 VSS.n970 VSS.n432 0.0483676
R9415 VSS.n968 VSS.n431 0.0483676
R9416 VSS.n966 VSS.t264 0.0483676
R9417 VSS.n934 VSS.n425 0.0483676
R9418 VSS.n961 VSS.n422 0.0483676
R9419 VSS.n959 VSS.n419 0.0483676
R9420 VSS.n957 VSS.n418 0.0483676
R9421 VSS.n937 VSS.n415 0.0483676
R9422 VSS.n952 VSS.n414 0.0483676
R9423 VSS.n950 VSS.n413 0.0483676
R9424 VSS.n948 VSS.n412 0.0483676
R9425 VSS.n3262 VSS.n155 0.0483676
R9426 VSS.n3261 VSS.n153 0.0483676
R9427 VSS.t503 VSS.n733 0.0483676
R9428 VSS.n3236 VSS.t507 0.0483676
R9429 VSS.t506 VSS.n3237 0.0483676
R9430 VSS.n594 VSS.n596 0.04675
R9431 VSS.n593 VSS.t109 0.04675
R9432 VSS.n2151 VSS.n2138 0.0405
R9433 VSS.n2130 VSS.t73 0.0405
R9434 VSS.n2124 VSS.n2123 0.0405
R9435 VSS.n2114 VSS.t85 0.0405
R9436 VSS.n2108 VSS.n2107 0.0405
R9437 VSS.n2098 VSS.t66 0.0405
R9438 VSS.n2092 VSS.n2091 0.0405
R9439 VSS.n2082 VSS.t397 0.0405
R9440 VSS.n2076 VSS.n2075 0.0405
R9441 VSS.n2066 VSS.t371 0.0405
R9442 VSS.n2060 VSS.n2059 0.0405
R9443 VSS.n2050 VSS.t628 0.0405
R9444 VSS.n2044 VSS.n2043 0.0405
R9445 VSS.n2034 VSS.t213 0.0405
R9446 VSS.n2028 VSS.n2027 0.0405
R9447 VSS.n2018 VSS.t636 0.0405
R9448 VSS.n2012 VSS.n2011 0.0405
R9449 VSS.n2002 VSS.t139 0.0405
R9450 VSS.n1996 VSS.n1995 0.0405
R9451 VSS.n1986 VSS.t143 0.0405
R9452 VSS.n1980 VSS.n1979 0.0405
R9453 VSS.n1970 VSS.t37 0.0405
R9454 VSS.n1964 VSS.n1963 0.0405
R9455 VSS.n1954 VSS.t208 0.0405
R9456 VSS.n1948 VSS.n1947 0.0405
R9457 VSS.n1938 VSS.t198 0.0405
R9458 VSS.n1932 VSS.n1931 0.0405
R9459 VSS.n1922 VSS.t386 0.0405
R9460 VSS.n1916 VSS.n1915 0.0405
R9461 VSS.n1906 VSS.t517 0.0405
R9462 VSS.n1899 VSS.n1898 0.0405
R9463 VSS.t204 VSS.n1893 0.0405
R9464 VSS.t615 VSS.n2801 0.038
R9465 VSS.t539 VSS.n3075 0.038
R9466 VSS.t554 VSS.n3028 0.038
R9467 VSS.t569 VSS.n2981 0.038
R9468 VSS.t584 VSS.n2895 0.038
R9469 VSS.t599 VSS.n2848 0.038
R9470 VSS.n3082 VSS.t537 0.0373698
R9471 VSS.n3035 VSS.t552 0.0373698
R9472 VSS.n2988 VSS.t567 0.0373698
R9473 VSS.n2902 VSS.t582 0.0373698
R9474 VSS.n2855 VSS.t597 0.0373698
R9475 VSS.n2808 VSS.t612 0.0373698
R9476 VSS.n2502 VSS.n2498 0.03675
R9477 VSS.n2574 VSS.n2142 0.03675
R9478 VSS.n3724 VSS.n3723 0.03675
R9479 VSS.n1116 VSS.n1115 0.03675
R9480 VSS.t537 VSS.n1342 0.03175
R9481 VSS.t552 VSS.n1381 0.03175
R9482 VSS.t567 VSS.n1420 0.03175
R9483 VSS.t582 VSS.n1504 0.03175
R9484 VSS.t597 VSS.n1543 0.03175
R9485 VSS.t612 VSS.n1582 0.03175
R9486 VSS.n607 VSS.n3480 0.0305
R9487 VSS.n603 VSS.n3486 0.0305
R9488 VSS.n3504 VSS.n303 0.0297015
R9489 VSS.n2493 VSS.t303 0.02925
R9490 VSS.n2484 VSS.t289 0.02925
R9491 VSS.n2475 VSS.t287 0.02925
R9492 VSS.n2466 VSS.t305 0.02925
R9493 VSS.n2457 VSS.t245 0.02925
R9494 VSS.n2448 VSS.t307 0.02925
R9495 VSS.n2439 VSS.t313 0.02925
R9496 VSS.n2430 VSS.t309 0.02925
R9497 VSS.n2421 VSS.t293 0.02925
R9498 VSS.n2412 VSS.t249 0.02925
R9499 VSS.n2403 VSS.t297 0.02925
R9500 VSS.n2394 VSS.t315 0.02925
R9501 VSS.n2385 VSS.t317 0.02925
R9502 VSS.n2376 VSS.t285 0.02925
R9503 VSS.n2367 VSS.t311 0.02925
R9504 VSS.n2358 VSS.t301 0.02925
R9505 VSS.n2349 VSS.t299 0.02925
R9506 VSS.n2340 VSS.t295 0.02925
R9507 VSS.n2331 VSS.t247 0.02925
R9508 VSS.n2322 VSS.t321 0.02925
R9509 VSS.n2313 VSS.t319 0.02925
R9510 VSS.n2304 VSS.t323 0.02925
R9511 VSS.n2295 VSS.t291 0.02925
R9512 VSS.n2286 VSS.t327 0.02925
R9513 VSS.n2277 VSS.t243 0.02925
R9514 VSS.n2268 VSS.t331 0.02925
R9515 VSS.n2259 VSS.t329 0.02925
R9516 VSS.n2250 VSS.t333 0.02925
R9517 VSS.n2241 VSS.t325 0.02925
R9518 VSS.n2232 VSS.t335 0.02925
R9519 VSS.n2223 VSS.t337 0.02925
R9520 VSS.n2214 VSS.t339 0.02925
R9521 VSS.n3854 VSS.n108 0.028
R9522 VSS.n3857 VSS.n3856 0.028
R9523 VSS.n3364 VSS.n3363 0.028
R9524 VSS.n2500 VSS.n2499 0.02675
R9525 VSS.n3254 VSS.n3253 0.02675
R9526 VSS.n3435 VSS.n3434 0.02675
R9527 VSS.t542 VSS.n1351 0.0253649
R9528 VSS.t557 VSS.n1390 0.0253649
R9529 VSS.t572 VSS.n1429 0.0253649
R9530 VSS.t587 VSS.n1513 0.0253649
R9531 VSS.t602 VSS.n1552 0.0253649
R9532 VSS.t617 VSS.n1589 0.0253649
R9533 VSS.n3482 VSS.n3481 0.0253401
R9534 VSS.n3484 VSS.n606 0.0253401
R9535 VSS.n2800 VSS.n1596 0.023135
R9536 VSS.n3201 VSS.n1278 0.023135
R9537 VSS.n3193 VSS.n1278 0.023135
R9538 VSS.n3189 VSS.n1278 0.023135
R9539 VSS.n3183 VSS.n1278 0.023135
R9540 VSS.n3086 VSS.n3085 0.023135
R9541 VSS.n3074 VSS.n3073 0.023135
R9542 VSS.n3074 VSS.n3072 0.023135
R9543 VSS.n3036 VSS.n1371 0.023135
R9544 VSS.n3027 VSS.n3026 0.023135
R9545 VSS.n3027 VSS.n3025 0.023135
R9546 VSS.n2989 VSS.n1410 0.023135
R9547 VSS.n2980 VSS.n2979 0.023135
R9548 VSS.n2980 VSS.n2978 0.023135
R9549 VSS.n2980 VSS.n1463 0.023135
R9550 VSS.n2980 VSS.n1460 0.023135
R9551 VSS.n2903 VSS.n1494 0.023135
R9552 VSS.n2894 VSS.n2893 0.023135
R9553 VSS.n2894 VSS.n2892 0.023135
R9554 VSS.n2856 VSS.n1533 0.023135
R9555 VSS.n2847 VSS.n2846 0.023135
R9556 VSS.n2847 VSS.n2845 0.023135
R9557 VSS.n2809 VSS.n1572 0.023135
R9558 VSS.n2800 VSS.n1591 0.023135
R9559 VSS.n1886 VSS.n1887 0.02175
R9560 VSS.n690 VSS.n689 0.02175
R9561 VSS.n3261 VSS.n3258 0.02175
R9562 VSS.n3493 VSS.n589 0.0214413
R9563 VSS.t131 VSS.n790 0.0184075
R9564 VSS.t133 VSS.n855 0.0184075
R9565 VSS.n3459 VSS.t58 0.0174009
R9566 VSS.n608 VSS.n607 0.01675
R9567 VSS.n3486 VSS.t103 0.01675
R9568 VSS.n3205 VSS.n1277 0.0165542
R9569 VSS.n1601 VSS.n1277 0.0165542
R9570 VSS.n1273 VSS.t163 0.0151406
R9571 VSS.n1216 VSS.n815 0.0151406
R9572 VSS.n1216 VSS.n828 0.0151406
R9573 VSS.n1142 VSS.n870 0.0151406
R9574 VSS.n3455 VSS.t58 0.0150892
R9575 VSS.n3287 VSS.n171 0.01425
R9576 VSS.n1862 VSS.n1589 0.0141149
R9577 VSS.n3059 VSS.n1351 0.0141149
R9578 VSS.n3012 VSS.n1390 0.0141149
R9579 VSS.n2965 VSS.n1429 0.0141149
R9580 VSS.n2879 VSS.n1513 0.0141149
R9581 VSS.n2832 VSS.n1552 0.0141149
R9582 VSS.n1332 VSS 0.0134067
R9583 VSS.n3489 VSS.n3488 0.013
R9584 VSS.n3278 VSS.n3277 0.01175
R9585 VSS.n3432 VSS.n3431 0.01175
R9586 VSS.n1647 VSS.n1277 0.00938635
R9587 VSS.n1837 VSS.n1277 0.00938222
R9588 VSS.n1829 VSS.n1277 0.00937856
R9589 VSS.n1815 VSS.n1277 0.00937856
R9590 VSS.n1787 VSS.n1277 0.00937856
R9591 VSS.n1759 VSS.n1277 0.00937856
R9592 VSS.n1745 VSS.n1277 0.00937856
R9593 VSS.n1731 VSS.n1277 0.00937856
R9594 VSS.n1717 VSS.n1277 0.00937856
R9595 VSS.n1703 VSS.n1277 0.00937856
R9596 VSS.n1689 VSS.n1277 0.00937856
R9597 VSS.n1661 VSS.n1277 0.00937856
R9598 VSS.n1633 VSS.n1277 0.00937856
R9599 VSS.n1619 VSS.n1277 0.00937856
R9600 VSS.n1613 VSS.n1277 0.00937856
R9601 VSS.n1801 VSS.n1277 0.00937856
R9602 VSS.n1773 VSS.n1277 0.00937856
R9603 VSS.n1675 VSS.n1277 0.00937856
R9604 VSS.n2510 VSS.n2509 0.00675
R9605 VSS.n2571 VSS.t69 0.00675
R9606 VSS.n31 VSS.n197 0.00696227
R9607 VSS.n2512 VSS.n2147 0.00412443
R9608 VSS.n85 VSS.n391 0.00439839
R9609 VSS.n81 VSS.n82 0.00399966
R9610 VSS.n102 VSS.n103 0.00374975
R9611 VSS.n90 VSS.n91 0.00374975
R9612 VSS.n74 VSS.n95 0.00499955
R9613 VSS.n42 VSS.n765 0.00495229
R9614 VSS.n3809 VSS.n7 0.00417424
R9615 VSS.n49 VSS.n52 0.00374975
R9616 VSS.n78 VSS.n79 0.00299994
R9617 VSS.n19 VSS.n20 0.00299994
R9618 VSS.n16 VSS.n17 0.00299994
R9619 VSS.n11 VSS.n12 0.00299994
R9620 VSS.n3463 VSS.n1 0.00296307
R9621 VSS.n55 VSS.n54 0.00249999
R9622 VSS.n29 VSS.n27 0.00249999
R9623 VSS.n3208 VSS.n7 0.00216164
R9624 VSS.t58 VSS.n616 0.002125
R9625 VSS.t163 VSS.n779 0.00198843
R9626 VSS.n3810 VSS.n3809 0.00194998
R9627 VSS.n640 VSS.n616 0.00187493
R9628 VSS.n3202 VSS.n1278 0.00181696
R9629 VSS.n3197 VSS.n1278 0.00181696
R9630 VSS.n3180 VSS.n1279 0.00181696
R9631 VSS.n3083 VSS.n1339 0.00181696
R9632 VSS.n3083 VSS.n1341 0.00181696
R9633 VSS.n3049 VSS.n1369 0.00181696
R9634 VSS.n3038 VSS.n1378 0.00181696
R9635 VSS.n3038 VSS.n1380 0.00181696
R9636 VSS.n3002 VSS.n1408 0.00181696
R9637 VSS.n2991 VSS.n1417 0.00181696
R9638 VSS.n2991 VSS.n1419 0.00181696
R9639 VSS.n2916 VSS.n1492 0.00181696
R9640 VSS.n2905 VSS.n1501 0.00181696
R9641 VSS.n2905 VSS.n1503 0.00181696
R9642 VSS.n2869 VSS.n1531 0.00181696
R9643 VSS.n2858 VSS.n1540 0.00181696
R9644 VSS.n2858 VSS.n1542 0.00181696
R9645 VSS.n2822 VSS.n1570 0.00181696
R9646 VSS.n2811 VSS.n1579 0.00181696
R9647 VSS.n2811 VSS.n1581 0.00181696
R9648 VSS.n767 VSS.n735 0.00166667
R9649 VSS.n11 VSS.n10 0.00149995
R9650 VSS.n14 VSS.n13 0.00169993
R9651 VSS.n16 VSS.n15 0.00149995
R9652 VSS.n19 VSS.n18 0.00149995
R9653 VSS.n22 VSS.n21 0.00169993
R9654 VSS.n25 VSS.n23 0.00169993
R9655 VSS.n37 VSS.n71 0.00166667
R9656 VSS.n27 VSS.n26 0.00149995
R9657 VSS.n197 VSS.n124 0.00166667
R9658 VSS.n40 VSS.n39 0.00169993
R9659 VSS.n48 VSS.n46 0.00169993
R9660 VSS.n50 VSS.n49 0.00138885
R9661 VSS.n56 VSS.n55 0.00149995
R9662 VSS.n734 VSS.n724 0.00166667
R9663 VSS.n78 VSS.n77 0.00149995
R9664 VSS.n81 VSS.n80 0.00138884
R9665 VSS.n90 VSS.n89 0.00138885
R9666 VSS.n100 VSS.n99 0.00169993
R9667 VSS.n102 VSS.n101 0.00138885
R9668 VSS.n3384 VSS.n688 0.00162501
R9669 VSS.n3466 VSS.n1 0.00161188
R9670 VSS.n92 VSS.n580 0.00152382
R9671 VSS.n105 VSS.n104 0.0015
R9672 VSS.n584 VSS.n100 0.0015
R9673 VSS.n93 VSS.n92 0.0015
R9674 VSS.n393 VSS.n76 0.0015
R9675 VSS.n38 VSS.n37 0.0015
R9676 VSS.n54 VSS.n57 0.0015
R9677 VSS.n51 VSS.n53 0.0015
R9678 VSS.n48 VSS.n47 0.0015
R9679 VSS.n765 VSS.n40 0.0015
R9680 VSS.n199 VSS.n29 0.0015
R9681 VSS.n25 VSS.n24 0.0015
R9682 VSS.n3212 VSS.n22 0.0015
R9683 VSS.n3230 VSS.n14 0.0015
R9684 VSS.n3 VSS.n1 0.00125
R9685 VSS.n104 VSS.n580 0.00147616
R9686 VSS.n3384 VSS.n724 0.00137498
R9687 VSS.n199 VSS.n124 0.00133332
R9688 VSS.n734 VSS.n57 0.00133332
R9689 VSS.n24 VSS.n71 0.00133332
R9690 VSS.n735 VSS.n7 0.00133332
R9691 VSS.n3185 VSS.n1278 0.00104753
R9692 VSS.n3468 VSS.n1 0.00103597
R9693 VSS.n3465 VSS.n1 0.00103555
R9694 VSS.n3182 VSS.n1278 0.00101876
R9695 VSS.n3074 VSS.n1350 0.00101876
R9696 VSS.n3074 VSS.n1356 0.00101876
R9697 VSS.n3027 VSS.n1389 0.00101876
R9698 VSS.n3027 VSS.n1395 0.00101876
R9699 VSS.n2980 VSS.n1428 0.00101876
R9700 VSS.n2980 VSS.n1455 0.00101876
R9701 VSS.n2894 VSS.n1512 0.00101876
R9702 VSS.n2894 VSS.n1518 0.00101876
R9703 VSS.n2847 VSS.n1551 0.00101876
R9704 VSS.n2847 VSS.n1557 0.00101876
R9705 VSS.n2980 VSS.n1443 0.00101872
R9706 VSS.n2800 VSS.n1840 0.00101872
R9707 VSS.n3184 VSS.n1278 0.00101872
R9708 VSS.n2980 VSS.n1434 0.00101872
R9709 VSS.n2980 VSS.n1461 0.00101872
R9710 VSS.n2800 VSS.n1590 0.00100071
R9711 VSS.n3180 VSS.n3179 0.001
R9712 VSS.n3086 VSS.n1283 0.001
R9713 VSS.n3083 VSS.n1338 0.001
R9714 VSS.n3074 VSS.n1343 0.001
R9715 VSS.n3049 VSS.n1359 0.001
R9716 VSS.n3047 VSS.n1371 0.001
R9717 VSS.n3039 VSS.n3038 0.001
R9718 VSS.n3027 VSS.n1382 0.001
R9719 VSS.n3002 VSS.n1398 0.001
R9720 VSS.n3000 VSS.n1410 0.001
R9721 VSS.n2992 VSS.n2991 0.001
R9722 VSS.n2980 VSS.n1421 0.001
R9723 VSS.n2916 VSS.n1458 0.001
R9724 VSS.n2914 VSS.n1494 0.001
R9725 VSS.n2906 VSS.n2905 0.001
R9726 VSS.n2894 VSS.n1505 0.001
R9727 VSS.n2869 VSS.n1521 0.001
R9728 VSS.n2867 VSS.n1533 0.001
R9729 VSS.n2859 VSS.n2858 0.001
R9730 VSS.n2847 VSS.n1544 0.001
R9731 VSS.n2822 VSS.n1560 0.001
R9732 VSS.n2820 VSS.n1572 0.001
R9733 VSS.n2812 VSS.n2811 0.001
R9734 VSS.n2800 VSS.n1583 0.001
R9735 VSS.n3179 VSS.n1278 0.001
R9736 VSS.n3180 VSS.n1283 0.001
R9737 VSS.n3086 VSS.n1338 0.001
R9738 VSS.n3083 VSS.n1343 0.001
R9739 VSS.n3074 VSS.n1359 0.001
R9740 VSS.n3049 VSS.n3047 0.001
R9741 VSS.n3039 VSS.n1371 0.001
R9742 VSS.n3038 VSS.n1382 0.001
R9743 VSS.n3027 VSS.n1398 0.001
R9744 VSS.n3002 VSS.n3000 0.001
R9745 VSS.n2992 VSS.n1410 0.001
R9746 VSS.n2991 VSS.n1421 0.001
R9747 VSS.n2980 VSS.n1458 0.001
R9748 VSS.n2916 VSS.n2914 0.001
R9749 VSS.n2906 VSS.n1494 0.001
R9750 VSS.n2905 VSS.n1505 0.001
R9751 VSS.n2894 VSS.n1521 0.001
R9752 VSS.n2869 VSS.n2867 0.001
R9753 VSS.n2859 VSS.n1533 0.001
R9754 VSS.n2858 VSS.n1544 0.001
R9755 VSS.n2847 VSS.n1560 0.001
R9756 VSS.n2822 VSS.n2820 0.001
R9757 VSS.n2812 VSS.n1572 0.001
R9758 VSS.n2811 VSS.n1583 0.001
R9759 VSS.n739 VSS.n45 0.001
R9760 VSS.n52 VSS.n51 0.00124999
R9761 VSS.n3241 VSS.n9 0.001
R9762 VSS.n3233 VSS.n12 0.001
R9763 VSS.n3223 VSS.n17 0.001
R9764 VSS.n3217 VSS.n20 0.001
R9765 VSS.t131 VSS.n780 0.001
R9766 VSS.t131 VSS.n788 0.001
R9767 VSS.n1220 VSS.n1219 0.001
R9768 VSS.n1217 VSS.n1216 0.001
R9769 VSS.t133 VSS.n821 0.001
R9770 VSS.t133 VSS.n853 0.001
R9771 VSS.n1146 VSS.n1145 0.001
R9772 VSS.n1143 VSS.n1142 0.001
R9773 VSS.n585 VSS.n98 0.001
R9774 VSS.n105 VSS.n103 0.00124999
R9775 VSS.n76 VSS.n73 0.00124999
R9776 VSS.n392 VSS.n79 0.001
R9777 VSS.n391 VSS.n83 0.001
R9778 VSS.n390 VSS.n88 0.001
R9779 VSS.n93 VSS.n91 0.00124999
R9780 VSS.n688 VSS.n37 0.001
R9781 VSS.n780 VSS.t163 0.001
R9782 VSS.n1220 VSS.n788 0.001
R9783 VSS.n1219 VSS.n810 0.001
R9784 VSS.n1217 VSS.n810 0.001
R9785 VSS.n1216 VSS.n821 0.001
R9786 VSS.n1146 VSS.n853 0.001
R9787 VSS.n1145 VSS.n867 0.001
R9788 VSS.n1143 VSS.n867 0.001
R9789 VSS.n3470 VSS.n3 8.50163
R9790 VSS.n3471 VSS.n3 8.47807
R9791 a_3747_311.n0 a_3747_311.t2 52.0388
R9792 a_3747_311.t0 a_3747_311.n0 35.4491
R9793 a_3747_311.n0 a_3747_311.t3 33.5891
R9794 a_3747_311.t1 a_3747_311.t0 5.61942
R9795 a_3171_311.n0 a_3171_311.t2 51.8377
R9796 a_3171_311.n0 a_3171_311.t3 33.3881
R9797 a_3171_311.t0 a_3171_311.n0 31.8923
R9798 a_3171_311.t1 a_3171_311.t0 5.61777
R9799 a_2595_311.n0 a_2595_311.t2 51.6367
R9800 a_2595_311.n0 a_2595_311.t3 33.187
R9801 a_2595_311.t0 a_2595_311.n0 27.993
R9802 a_2595_311.t1 a_2595_311.t0 5.73018
R9803 a_2019_311.t3 a_2019_311.t2 51.6139
R9804 a_2019_311.t0 a_2019_311.t3 24.5351
R9805 a_2019_311.t1 a_2019_311.t0 5.62052
R9806 a_3747_1047.n0 a_3747_1047.t2 38.0081
R9807 a_3747_1047.n0 a_3747_1047.t3 33.3957
R9808 a_3747_1047.n1 a_3747_1047.t4 33.3957
R9809 a_3747_1047.n2 a_3747_1047.t5 33.3957
R9810 a_3747_1047.n3 a_3747_1047.t6 33.3957
R9811 a_3747_1047.n4 a_3747_1047.t7 33.3957
R9812 a_3747_1047.n5 a_3747_1047.t8 33.3957
R9813 a_3747_1047.n6 a_3747_1047.t9 33.3957
R9814 a_3747_1047.t0 a_3747_1047.n6 23.2419
R9815 a_3747_1047.t1 a_3747_1047.t0 5.61942
R9816 a_3747_1047.n6 a_3747_1047.n5 4.61291
R9817 a_3747_1047.n5 a_3747_1047.n4 4.61291
R9818 a_3747_1047.n4 a_3747_1047.n3 4.61291
R9819 a_3747_1047.n3 a_3747_1047.n2 4.61291
R9820 a_3747_1047.n2 a_3747_1047.n1 4.61291
R9821 a_3747_1047.n1 a_3747_1047.n0 4.61291
R9822 a_3171_1047.n0 a_3171_1047.t2 37.8054
R9823 a_3171_1047.n0 a_3171_1047.t3 33.193
R9824 a_3171_1047.n1 a_3171_1047.t4 33.193
R9825 a_3171_1047.n2 a_3171_1047.t5 33.193
R9826 a_3171_1047.n3 a_3171_1047.t6 33.193
R9827 a_3171_1047.n4 a_3171_1047.t7 33.193
R9828 a_3171_1047.n5 a_3171_1047.t8 33.193
R9829 a_3171_1047.n6 a_3171_1047.t9 33.193
R9830 a_3171_1047.t0 a_3171_1047.n6 23.0313
R9831 a_3171_1047.t1 a_3171_1047.t0 5.61777
R9832 a_3171_1047.n6 a_3171_1047.n5 4.61291
R9833 a_3171_1047.n5 a_3171_1047.n4 4.61291
R9834 a_3171_1047.n4 a_3171_1047.n3 4.61291
R9835 a_3171_1047.n3 a_3171_1047.n2 4.61291
R9836 a_3171_1047.n2 a_3171_1047.n1 4.61291
R9837 a_3171_1047.n1 a_3171_1047.n0 4.61291
R9838 a_2595_1047.n0 a_2595_1047.t2 37.7691
R9839 a_2595_1047.n0 a_2595_1047.t3 33.1567
R9840 a_2595_1047.n1 a_2595_1047.t4 33.1567
R9841 a_2595_1047.n2 a_2595_1047.t5 33.1567
R9842 a_2595_1047.n3 a_2595_1047.t6 33.1567
R9843 a_2595_1047.n4 a_2595_1047.t7 33.1567
R9844 a_2595_1047.n5 a_2595_1047.t8 33.1567
R9845 a_2595_1047.n6 a_2595_1047.t9 33.1567
R9846 a_2595_1047.t0 a_2595_1047.n6 22.7941
R9847 a_2595_1047.t1 a_2595_1047.t0 5.65522
R9848 a_2595_1047.n6 a_2595_1047.n5 4.61291
R9849 a_2595_1047.n5 a_2595_1047.n4 4.61291
R9850 a_2595_1047.n4 a_2595_1047.n3 4.61291
R9851 a_2595_1047.n3 a_2595_1047.n2 4.61291
R9852 a_2595_1047.n2 a_2595_1047.n1 4.61291
R9853 a_2595_1047.n1 a_2595_1047.n0 4.61291
R9854 a_2019_1047.n0 a_2019_1047.t2 37.9701
R9855 a_2019_1047.n0 a_2019_1047.t3 33.3577
R9856 a_2019_1047.n1 a_2019_1047.t4 33.3577
R9857 a_2019_1047.n2 a_2019_1047.t5 33.3577
R9858 a_2019_1047.n3 a_2019_1047.t6 33.3577
R9859 a_2019_1047.n4 a_2019_1047.t7 33.3577
R9860 a_2019_1047.t0 a_2019_1047.t9 22.5945
R9861 a_2019_1047.t1 a_2019_1047.t0 5.62052
R9862 a_2019_1047.t9 a_2019_1047.t8 4.61291
R9863 a_2019_1047.t8 a_2019_1047.n4 4.61291
R9864 a_2019_1047.n4 a_2019_1047.n3 4.61291
R9865 a_2019_1047.n3 a_2019_1047.n2 4.61291
R9866 a_2019_1047.n2 a_2019_1047.n1 4.61291
R9867 a_2019_1047.n1 a_2019_1047.n0 4.61291
C1325 MUX_OUT VSS 7.79401f
C1326 MUX_SEL4 VSS 1.57276f
C1327 MUX_SEL3 VSS 1.0035f
C1328 MUX_SEL2 VSS 4.18782f
C1329 MUX_SEL1 VSS 1.04567f
C1330 MUX_SEL0 VSS 4.19577f
C1331 DELAY_VBIASP VSS 12.35601f
C1332 DELAY_OUT_LAST VSS 2.86018f
C1333 DELAY_VBIASN VSS 0.14048p
C1334 REF_CLK VSS 5.96886f
C1335 DLL_RESETN VSS 11.4579f
C1336 VDD VSS 95.87363f
C1337 a_26985_519# VSS 0.19019f ; **FLOATING
C1338 a_23945_519# VSS 0.18605f ; **FLOATING
C1339 a_20905_519# VSS 0.18456f ; **FLOATING
C1340 a_17865_519# VSS 0.17973f ; **FLOATING
C1341 a_16851_309# VSS 0.39012f ; **FLOATING
C1342 a_16108_289# VSS 5.09238f ; **FLOATING
C1343 a_15964_289# VSS 0.18287f ; **FLOATING
C1344 a_15765_463# VSS 0.3701f ; **FLOATING
C1345 a_14825_519# VSS 0.1819f ; **FLOATING
C1346 a_11785_519# VSS 0.1819f ; **FLOATING
C1347 a_8745_519# VSS 0.1819f ; **FLOATING
C1348 a_5731_289# VSS 4.48871f ; **FLOATING
C1349 a_5705_519# VSS 0.17899f ; **FLOATING
C1350 a_3449_331# VSS 0.18976f ; **FLOATING
C1351 a_2873_331# VSS 0.18555f ; **FLOATING
C1352 a_2297_331# VSS 0.18559f ; **FLOATING
C1353 a_1721_331# VSS 0.1759f ; **FLOATING
C1354 a_1544_289# VSS 0.31269f ; **FLOATING
C1355 a_1256_289# VSS 0.9846f ; **FLOATING
C1356 a_27991_1008# VSS 0.19969f ; **FLOATING
C1357 a_27915_1044# VSS 0.11737f ; **FLOATING
C1358 a_27124_1008# VSS 0.18296f ; **FLOATING
C1359 a_27048_1044# VSS 0.13154f ; **FLOATING
C1360 a_26471_1008# VSS 0.18345f ; **FLOATING
C1361 a_26395_1044# VSS 0.1168f ; **FLOATING
C1362 a_25604_1008# VSS 0.18358f ; **FLOATING
C1363 a_25630_1044# VSS 0.3469f ; **FLOATING
C1364 a_25528_1044# VSS 0.13242f ; **FLOATING
C1365 a_24951_1008# VSS 0.18359f ; **FLOATING
C1366 a_24875_1044# VSS 0.11461f ; **FLOATING
C1367 a_24084_1008# VSS 0.17994f ; **FLOATING
C1368 a_24008_1044# VSS 0.12896f ; **FLOATING
C1369 a_23431_1008# VSS 0.18198f ; **FLOATING
C1370 a_23355_1044# VSS 0.11518f ; **FLOATING
C1371 a_22564_1008# VSS 0.18358f ; **FLOATING
C1372 a_22590_1044# VSS 0.34962f ; **FLOATING
C1373 a_22488_1044# VSS 0.13242f ; **FLOATING
C1374 a_21911_1008# VSS 0.18359f ; **FLOATING
C1375 a_21835_1044# VSS 0.11461f ; **FLOATING
C1376 a_21044_1008# VSS 0.17994f ; **FLOATING
C1377 a_20968_1044# VSS 0.12896f ; **FLOATING
C1378 a_20391_1008# VSS 0.18198f ; **FLOATING
C1379 a_20315_1044# VSS 0.11518f ; **FLOATING
C1380 a_19524_1008# VSS 0.18358f ; **FLOATING
C1381 a_19550_1044# VSS 0.35115f ; **FLOATING
C1382 a_19448_1044# VSS 0.13242f ; **FLOATING
C1383 a_18871_1008# VSS 0.18359f ; **FLOATING
C1384 a_18795_1044# VSS 0.11461f ; **FLOATING
C1385 a_18004_1008# VSS 0.17994f ; **FLOATING
C1386 a_17928_1044# VSS 0.12896f ; **FLOATING
C1387 a_17351_1008# VSS 0.18046f ; **FLOATING
C1388 a_17275_1044# VSS 0.11372f ; **FLOATING
C1389 a_16484_1008# VSS 0.18294f ; **FLOATING
C1390 a_16510_1044# VSS 0.32857f ; **FLOATING
C1391 a_16408_1044# VSS 0.13098f ; **FLOATING
C1392 a_15831_1008# VSS 0.1787f ; **FLOATING
C1393 a_15755_1044# VSS 0.11372f ; **FLOATING
C1394 a_14964_1008# VSS 0.17994f ; **FLOATING
C1395 a_14888_1044# VSS 0.12896f ; **FLOATING
C1396 a_14311_1008# VSS 0.18198f ; **FLOATING
C1397 a_14235_1044# VSS 0.11518f ; **FLOATING
C1398 a_13444_1008# VSS 0.18358f ; **FLOATING
C1399 a_13470_1044# VSS 0.33941f ; **FLOATING
C1400 a_13368_1044# VSS 0.13242f ; **FLOATING
C1401 a_12791_1008# VSS 0.18359f ; **FLOATING
C1402 a_12715_1044# VSS 0.11461f ; **FLOATING
C1403 a_11924_1008# VSS 0.17994f ; **FLOATING
C1404 a_11848_1044# VSS 0.12896f ; **FLOATING
C1405 a_11271_1008# VSS 0.18198f ; **FLOATING
C1406 a_11195_1044# VSS 0.11518f ; **FLOATING
C1407 a_10404_1008# VSS 0.18358f ; **FLOATING
C1408 a_10430_1044# VSS 0.34574f ; **FLOATING
C1409 a_10328_1044# VSS 0.13242f ; **FLOATING
C1410 a_9751_1008# VSS 0.18359f ; **FLOATING
C1411 a_9675_1044# VSS 0.11461f ; **FLOATING
C1412 a_8884_1008# VSS 0.17994f ; **FLOATING
C1413 a_8808_1044# VSS 0.12896f ; **FLOATING
C1414 a_8231_1008# VSS 0.18198f ; **FLOATING
C1415 a_8155_1044# VSS 0.11518f ; **FLOATING
C1416 a_7364_1008# VSS 0.18358f ; **FLOATING
C1417 a_7390_1044# VSS 0.34543f ; **FLOATING
C1418 a_7288_1044# VSS 0.13242f ; **FLOATING
C1419 a_6711_1008# VSS 0.18359f ; **FLOATING
C1420 a_6635_1044# VSS 0.11461f ; **FLOATING
C1421 a_5844_1008# VSS 0.17994f ; **FLOATING
C1422 a_5768_1044# VSS 0.12896f ; **FLOATING
C1423 a_5191_1008# VSS 0.18046f ; **FLOATING
C1424 a_5115_1044# VSS 0.11372f ; **FLOATING
C1425 a_4324_1008# VSS 0.18294f ; **FLOATING
C1426 a_4350_1044# VSS 0.31993f ; **FLOATING
C1427 a_4248_1044# VSS 0.13252f ; **FLOATING
C1428 a_27705_1044# VSS 0.27018f ; **FLOATING
C1429 a_26185_1044# VSS 0.24814f ; **FLOATING
C1430 a_24665_1044# VSS 0.26584f ; **FLOATING
C1431 a_23145_1044# VSS 0.24624f ; **FLOATING
C1432 a_21625_1044# VSS 0.26584f ; **FLOATING
C1433 a_20105_1044# VSS 0.24624f ; **FLOATING
C1434 a_18585_1044# VSS 0.26584f ; **FLOATING
C1435 a_17065_1044# VSS 0.24534f ; **FLOATING
C1436 a_15545_1044# VSS 0.26448f ; **FLOATING
C1437 a_14025_1044# VSS 0.24624f ; **FLOATING
C1438 a_12505_1044# VSS 0.26584f ; **FLOATING
C1439 a_10985_1044# VSS 0.24624f ; **FLOATING
C1440 a_9465_1044# VSS 0.26584f ; **FLOATING
C1441 a_7945_1044# VSS 0.24624f ; **FLOATING
C1442 a_6425_1044# VSS 0.26584f ; **FLOATING
C1443 a_4905_1044# VSS 0.24698f ; **FLOATING
C1444 a_4157_1313# VSS 0.34738f ; **FLOATING
C1445 a_3449_1395# VSS 0.19228f ; **FLOATING
C1446 a_2873_1395# VSS 0.18619f ; **FLOATING
C1447 a_2297_1395# VSS 0.18587f ; **FLOATING
C1448 a_1721_1395# VSS 0.17768f ; **FLOATING
C1449 a_1544_1044# VSS 0.31333f ; **FLOATING
C1450 a_1256_1044# VSS 0.98205f ; **FLOATING
C1451 a_27671_1842# VSS 0.01732f ; **FLOATING
C1452 a_26911_1842# VSS 0.01732f ; **FLOATING
C1453 a_26151_1842# VSS 0.01732f ; **FLOATING
C1454 a_25391_1842# VSS 0.01732f ; **FLOATING
C1455 a_24631_1842# VSS 0.01732f ; **FLOATING
C1456 a_23871_1842# VSS 0.01732f ; **FLOATING
C1457 a_23111_1842# VSS 0.01732f ; **FLOATING
C1458 a_22351_1842# VSS 0.01732f ; **FLOATING
C1459 a_21591_1842# VSS 0.01732f ; **FLOATING
C1460 a_20831_1842# VSS 0.01732f ; **FLOATING
C1461 a_20071_1842# VSS 0.01732f ; **FLOATING
C1462 a_19311_1842# VSS 0.01732f ; **FLOATING
C1463 a_18551_1842# VSS 0.01732f ; **FLOATING
C1464 a_17791_1842# VSS 0.01732f ; **FLOATING
C1465 a_17031_1842# VSS 0.01732f ; **FLOATING
C1466 a_16271_1842# VSS 0.01732f ; **FLOATING
C1467 a_15511_1842# VSS 0.01732f ; **FLOATING
C1468 a_14751_1842# VSS 0.01732f ; **FLOATING
C1469 a_13991_1842# VSS 0.01732f ; **FLOATING
C1470 a_13231_1842# VSS 0.01732f ; **FLOATING
C1471 a_12471_1842# VSS 0.01732f ; **FLOATING
C1472 a_11711_1842# VSS 0.01732f ; **FLOATING
C1473 a_10951_1842# VSS 0.01732f ; **FLOATING
C1474 a_10191_1842# VSS 0.01732f ; **FLOATING
C1475 a_9431_1842# VSS 0.01732f ; **FLOATING
C1476 a_8671_1842# VSS 0.01732f ; **FLOATING
C1477 a_7911_1842# VSS 0.01732f ; **FLOATING
C1478 a_7151_1842# VSS 0.01732f ; **FLOATING
C1479 a_6391_1842# VSS 0.01732f ; **FLOATING
C1480 a_5631_1842# VSS 0.01732f ; **FLOATING
C1481 a_4871_1842# VSS 0.01732f ; **FLOATING
C1482 a_4111_1842# VSS 0.01786f ; **FLOATING
C1483 a_27563_1842# VSS 0.84296f ; **FLOATING
C1484 a_27997_1842# VSS 0.67442f ; **FLOATING
C1485 a_27433_1842# VSS 0.65329f ; **FLOATING
C1486 a_26803_1842# VSS 0.84079f ; **FLOATING
C1487 a_27237_1842# VSS 1.28291f ; **FLOATING
C1488 a_26673_1842# VSS 0.65417f ; **FLOATING
C1489 a_26043_1842# VSS 0.84057f ; **FLOATING
C1490 a_26477_1842# VSS 1.37853f ; **FLOATING
C1491 a_25913_1842# VSS 0.65331f ; **FLOATING
C1492 a_25283_1842# VSS 0.84081f ; **FLOATING
C1493 a_25717_1842# VSS 1.03862f ; **FLOATING
C1494 a_25153_1842# VSS 0.6542f ; **FLOATING
C1495 a_24523_1842# VSS 0.84055f ; **FLOATING
C1496 a_24957_1842# VSS 1.3729f ; **FLOATING
C1497 a_24393_1842# VSS 0.65329f ; **FLOATING
C1498 a_23763_1842# VSS 0.84079f ; **FLOATING
C1499 a_24197_1842# VSS 1.27457f ; **FLOATING
C1500 a_23633_1842# VSS 0.65447f ; **FLOATING
C1501 a_23003_1842# VSS 0.84057f ; **FLOATING
C1502 a_23437_1842# VSS 1.37272f ; **FLOATING
C1503 a_22873_1842# VSS 0.65331f ; **FLOATING
C1504 a_22243_1842# VSS 0.84081f ; **FLOATING
C1505 a_22677_1842# VSS 1.03822f ; **FLOATING
C1506 a_22113_1842# VSS 0.65634f ; **FLOATING
C1507 a_21483_1842# VSS 0.84055f ; **FLOATING
C1508 a_21917_1842# VSS 1.3729f ; **FLOATING
C1509 a_21353_1842# VSS 0.65329f ; **FLOATING
C1510 a_20723_1842# VSS 0.84079f ; **FLOATING
C1511 a_21157_1842# VSS 1.27457f ; **FLOATING
C1512 a_20593_1842# VSS 0.65709f ; **FLOATING
C1513 a_19963_1842# VSS 0.84057f ; **FLOATING
C1514 a_20397_1842# VSS 1.37272f ; **FLOATING
C1515 a_19833_1842# VSS 0.65331f ; **FLOATING
C1516 a_19203_1842# VSS 0.84081f ; **FLOATING
C1517 a_19637_1842# VSS 1.03822f ; **FLOATING
C1518 a_19073_1842# VSS 0.65583f ; **FLOATING
C1519 a_18443_1842# VSS 0.84055f ; **FLOATING
C1520 a_18877_1842# VSS 1.3729f ; **FLOATING
C1521 a_18313_1842# VSS 0.65329f ; **FLOATING
C1522 a_17683_1842# VSS 0.84079f ; **FLOATING
C1523 a_18117_1842# VSS 1.27457f ; **FLOATING
C1524 a_17553_1842# VSS 0.65417f ; **FLOATING
C1525 a_16923_1842# VSS 0.84053f ; **FLOATING
C1526 a_17357_1842# VSS 1.37272f ; **FLOATING
C1527 a_16793_1842# VSS 0.65301f ; **FLOATING
C1528 a_16163_1842# VSS 0.84079f ; **FLOATING
C1529 a_16597_1842# VSS 1.0334f ; **FLOATING
C1530 a_16033_1842# VSS 0.65709f ; **FLOATING
C1531 a_15403_1842# VSS 0.84254f ; **FLOATING
C1532 a_15837_1842# VSS 1.37106f ; **FLOATING
C1533 a_15273_1842# VSS 0.65574f ; **FLOATING
C1534 a_14643_1842# VSS 0.84258f ; **FLOATING
C1535 a_15077_1842# VSS 1.2744f ; **FLOATING
C1536 a_14513_1842# VSS 0.65705f ; **FLOATING
C1537 a_13883_1842# VSS 0.84262f ; **FLOATING
C1538 a_14317_1842# VSS 1.37449f ; **FLOATING
C1539 a_13753_1842# VSS 0.65718f ; **FLOATING
C1540 a_13123_1842# VSS 0.84281f ; **FLOATING
C1541 a_13557_1842# VSS 1.04002f ; **FLOATING
C1542 a_12993_1842# VSS 0.65743f ; **FLOATING
C1543 a_12363_1842# VSS 0.84255f ; **FLOATING
C1544 a_12797_1842# VSS 1.37469f ; **FLOATING
C1545 a_12233_1842# VSS 0.65737f ; **FLOATING
C1546 a_11603_1842# VSS 0.84092f ; **FLOATING
C1547 a_12037_1842# VSS 1.27472f ; **FLOATING
C1548 a_11473_1842# VSS 0.65444f ; **FLOATING
C1549 a_10843_1842# VSS 0.8407f ; **FLOATING
C1550 a_11277_1842# VSS 1.37287f ; **FLOATING
C1551 a_10713_1842# VSS 0.65358f ; **FLOATING
C1552 a_10083_1842# VSS 0.84093f ; **FLOATING
C1553 a_10517_1842# VSS 1.03837f ; **FLOATING
C1554 a_9953_1842# VSS 0.65447f ; **FLOATING
C1555 a_9323_1842# VSS 0.84068f ; **FLOATING
C1556 a_9757_1842# VSS 1.37305f ; **FLOATING
C1557 a_9193_1842# VSS 0.65356f ; **FLOATING
C1558 a_8563_1842# VSS 0.84092f ; **FLOATING
C1559 a_8997_1842# VSS 1.27472f ; **FLOATING
C1560 a_8433_1842# VSS 0.65444f ; **FLOATING
C1561 a_7803_1842# VSS 0.8407f ; **FLOATING
C1562 a_8237_1842# VSS 1.37287f ; **FLOATING
C1563 a_7673_1842# VSS 0.65358f ; **FLOATING
C1564 a_7043_1842# VSS 0.84093f ; **FLOATING
C1565 a_7477_1842# VSS 1.03837f ; **FLOATING
C1566 a_6913_1842# VSS 0.65447f ; **FLOATING
C1567 a_6283_1842# VSS 0.84068f ; **FLOATING
C1568 a_6717_1842# VSS 1.37305f ; **FLOATING
C1569 a_6153_1842# VSS 0.65356f ; **FLOATING
C1570 a_5523_1842# VSS 0.84092f ; **FLOATING
C1571 a_5957_1842# VSS 1.27472f ; **FLOATING
C1572 a_5393_1842# VSS 0.65853f ; **FLOATING
C1573 a_4763_1842# VSS 0.84257f ; **FLOATING
C1574 a_5197_1842# VSS 1.37454f ; **FLOATING
C1575 a_4633_1842# VSS 0.65656f ; **FLOATING
C1576 a_4003_1842# VSS 0.92443f ; **FLOATING
C1577 a_4437_1842# VSS 1.04148f ; **FLOATING
C1578 a_9712_3912# VSS 1.59526f ; **FLOATING
C1579 a_9444_3912# VSS 2.31588f ; **FLOATING
C1580 a_5778_3367# VSS 5.88104f ; **FLOATING
C1581 a_15464_3684# VSS 0.91028f ; **FLOATING
C1582 a_14757_5182# VSS 0.1031f ; **FLOATING
C1583 a_13880_5118# VSS 0.0742f ; **FLOATING
C1584 a_15688_5403# VSS 0.27866f ; **FLOATING
C1585 a_15108_5325# VSS 0.24688f ; **FLOATING
C1586 a_14851_5182# VSS 0.39269f ; **FLOATING
C1587 a_9444_4590# VSS 6.48112f ; **FLOATING
C1588 a_14111_5227# VSS 0.20221f ; **FLOATING
C1589 a_14009_5084# VSS 0.4602f ; **FLOATING
C1590 a_13592_5423# VSS 1.62662f ; **FLOATING
C1591 a_13306_5105# VSS 0.31101f ; **FLOATING
C1592 a_13566_5328# VSS 0.1634f ; **FLOATING
C1593 a_13132_5420# VSS 0.14211f ; **FLOATING
C1594 a_12907_5420# VSS 0.1476f ; **FLOATING
C1595 a_12907_5186# VSS 0.14887f ; **FLOATING
C1596 a_13106_5357# VSS 0.07369f ; **FLOATING
C1597 a_15304_4605# VSS 0.46629f ; **FLOATING
C1598 a_14757_6228# VSS 0.10568f ; **FLOATING
C1599 a_15688_5867# VSS 0.2737f ; **FLOATING
C1600 a_14851_6228# VSS 0.40535f ; **FLOATING
C1601 a_15108_6109# VSS 0.25077f ; **FLOATING
C1602 a_14111_5878# VSS 0.23266f ; **FLOATING
C1603 a_13880_6292# VSS 0.0799f ; **FLOATING
C1604 a_14009_5878# VSS 0.494f ; **FLOATING
C1605 a_13592_5871# VSS 1.63328f ; **FLOATING
C1606 a_13566_5835# VSS 0.1587f ; **FLOATING
C1607 a_13045_6215# VSS 0.01186f ; **FLOATING
C1608 a_13306_6305# VSS 0.32799f ; **FLOATING
C1609 a_12849_5867# VSS 1.40481f ; **FLOATING
C1610 a_13121_5831# VSS 0.83335f ; **FLOATING
C1611 a_13019_5831# VSS 3.84477f ; **FLOATING
C1612 a_12656_5864# VSS 0.29728f ; **FLOATING
C1613 a_12355_5867# VSS 0.76652f ; **FLOATING
C1614 a_11397_6228# VSS 0.10938f ; **FLOATING
C1615 a_12158_5867# VSS 0.27426f ; **FLOATING
C1616 a_11491_6228# VSS 0.32236f ; **FLOATING
C1617 a_11748_6109# VSS 0.18335f ; **FLOATING
C1618 a_10751_5878# VSS 0.21951f ; **FLOATING
C1619 a_10520_6292# VSS 0.05232f ; **FLOATING
C1620 a_10649_5878# VSS 0.49351f ; **FLOATING
C1621 a_10232_5871# VSS 1.59913f ; **FLOATING
C1622 a_10206_5835# VSS 0.09627f ; **FLOATING
C1623 a_9946_6305# VSS 0.20725f ; **FLOATING
C1624 a_9772_5843# VSS 0.13878f ; **FLOATING
C1625 a_9746_5805# VSS 0.07638f ; **FLOATING
C1626 a_9547_6172# VSS 0.16803f ; **FLOATING
C1627 a_9547_5942# VSS 0.12932f ; **FLOATING
C1628 a_6854_5454# VSS 3.65501f ; **FLOATING
C1629 a_6126_3816# VSS 17.0938f ; **FLOATING
C1630 a_6854_5986# VSS 2.92522f ; **FLOATING
C1631 a_5974_5723# VSS 2.52601f ; **FLOATING
C1632 a_6326_4590# VSS 1.17208f ; **FLOATING
C1633 a_2019_1047.t2 VSS 0.83005f ; **FLOATING
C1634 a_2019_1047.t3 VSS 0.63015f ; **FLOATING
C1635 a_2019_1047.n0 VSS 4.46922f ; **FLOATING
C1636 a_2019_1047.t4 VSS 0.63015f ; **FLOATING
C1637 a_2019_1047.n1 VSS 3.02355f ; **FLOATING
C1638 a_2019_1047.t5 VSS 0.63015f ; **FLOATING
C1639 a_2019_1047.n2 VSS 3.02355f ; **FLOATING
C1640 a_2019_1047.t6 VSS 0.63015f ; **FLOATING
C1641 a_2019_1047.n3 VSS 3.02355f ; **FLOATING
C1642 a_2019_1047.t7 VSS 0.63015f ; **FLOATING
C1643 a_2019_1047.n4 VSS 3.02355f ; **FLOATING
C1644 a_2019_1047.t8 VSS 3.6537f ; **FLOATING
C1645 a_2019_1047.t9 VSS 4.86718f ; **FLOATING
C1646 a_2019_1047.t0 VSS 0.95702f ; **FLOATING
C1647 a_2019_1047.t1 VSS 0.27201f ; **FLOATING
C1648 a_2595_1047.t2 VSS 1.36604f ; **FLOATING
C1649 a_2595_1047.t3 VSS 1.0202f ; **FLOATING
C1650 a_2595_1047.n0 VSS 7.7556f ; **FLOATING
C1651 a_2595_1047.t4 VSS 1.0202f ; **FLOATING
C1652 a_2595_1047.n1 VSS 5.26957f ; **FLOATING
C1653 a_2595_1047.t5 VSS 1.0202f ; **FLOATING
C1654 a_2595_1047.n2 VSS 5.26957f ; **FLOATING
C1655 a_2595_1047.t6 VSS 1.0202f ; **FLOATING
C1656 a_2595_1047.n3 VSS 5.26957f ; **FLOATING
C1657 a_2595_1047.t7 VSS 1.0202f ; **FLOATING
C1658 a_2595_1047.n4 VSS 5.26957f ; **FLOATING
C1659 a_2595_1047.t8 VSS 1.0202f ; **FLOATING
C1660 a_2595_1047.n5 VSS 5.26957f ; **FLOATING
C1661 a_2595_1047.t9 VSS 1.0202f ; **FLOATING
C1662 a_2595_1047.n6 VSS 7.57997f ; **FLOATING
C1663 a_2595_1047.t0 VSS 1.74992f ; **FLOATING
C1664 a_2595_1047.t1 VSS 0.48192f ; **FLOATING
C1665 a_3171_1047.t2 VSS 1.39099f ; **FLOATING
C1666 a_3171_1047.t3 VSS 1.04226f ; **FLOATING
C1667 a_3171_1047.n0 VSS 7.81546f ; **FLOATING
C1668 a_3171_1047.t4 VSS 1.04226f ; **FLOATING
C1669 a_3171_1047.n1 VSS 5.30588f ; **FLOATING
C1670 a_3171_1047.t5 VSS 1.04226f ; **FLOATING
C1671 a_3171_1047.n2 VSS 5.30588f ; **FLOATING
C1672 a_3171_1047.t6 VSS 1.04226f ; **FLOATING
C1673 a_3171_1047.n3 VSS 5.30588f ; **FLOATING
C1674 a_3171_1047.t7 VSS 1.04226f ; **FLOATING
C1675 a_3171_1047.n4 VSS 5.30588f ; **FLOATING
C1676 a_3171_1047.t8 VSS 1.04226f ; **FLOATING
C1677 a_3171_1047.n5 VSS 5.30588f ; **FLOATING
C1678 a_3171_1047.t9 VSS 1.04226f ; **FLOATING
C1679 a_3171_1047.n6 VSS 7.71992f ; **FLOATING
C1680 a_3171_1047.t0 VSS 1.77866f ; **FLOATING
C1681 a_3171_1047.t1 VSS 0.48312f ; **FLOATING
C1682 a_3747_1047.t2 VSS 1.01739f ; **FLOATING
C1683 a_3747_1047.t3 VSS 0.77455f ; **FLOATING
C1684 a_3747_1047.n0 VSS 5.42635f ; **FLOATING
C1685 a_3747_1047.t4 VSS 0.77455f ; **FLOATING
C1686 a_3747_1047.n1 VSS 3.66814f ; **FLOATING
C1687 a_3747_1047.t5 VSS 0.77455f ; **FLOATING
C1688 a_3747_1047.n2 VSS 3.66814f ; **FLOATING
C1689 a_3747_1047.t6 VSS 0.77455f ; **FLOATING
C1690 a_3747_1047.n3 VSS 3.66814f ; **FLOATING
C1691 a_3747_1047.t7 VSS 0.77455f ; **FLOATING
C1692 a_3747_1047.n4 VSS 3.66814f ; **FLOATING
C1693 a_3747_1047.t8 VSS 0.77455f ; **FLOATING
C1694 a_3747_1047.n5 VSS 3.66814f ; **FLOATING
C1695 a_3747_1047.t9 VSS 0.77455f ; **FLOATING
C1696 a_3747_1047.n6 VSS 5.44676f ; **FLOATING
C1697 a_3747_1047.t0 VSS 1.24474f ; **FLOATING
C1698 a_3747_1047.t1 VSS 0.32908f ; **FLOATING
C1699 a_2019_311.t2 VSS 4.07039f ; **FLOATING
C1700 a_2019_311.t3 VSS 21.9055f ; **FLOATING
C1701 a_2019_311.t0 VSS 1.98979f ; **FLOATING
C1702 a_2019_311.t1 VSS 0.44677f ; **FLOATING
C1703 a_2595_311.t0 VSS 3.28186f ; **FLOATING
C1704 a_2595_311.t2 VSS 5.05916f ; **FLOATING
C1705 a_2595_311.t3 VSS 1.21056f ; **FLOATING
C1706 a_2595_311.n0 VSS 26.9612f ; **FLOATING
C1707 a_2595_311.t1 VSS 0.49746f ; **FLOATING
C1708 a_3171_311.t2 VSS 5.10971f ; **FLOATING
C1709 a_3171_311.t3 VSS 1.2258f ; **FLOATING
C1710 a_3171_311.n0 VSS 30.2023f ; **FLOATING
C1711 a_3171_311.t0 VSS 4.66598f ; **FLOATING
C1712 a_3171_311.t1 VSS 0.50317f ; **FLOATING
C1713 a_3747_311.t2 VSS 3.88688f ; **FLOATING
C1714 a_3747_311.t3 VSS 0.93553f ; **FLOATING
C1715 a_3747_311.n0 VSS 25.0012f ; **FLOATING
C1716 a_3747_311.t0 VSS 4.63722f ; **FLOATING
C1717 a_3747_311.t1 VSS 0.38387f ; **FLOATING
C1718 VSS.t2 VSS 3.68888f ; **FLOATING
C1719 VDD.t3 VSS 76.038f ; **FLOATING
C1720 VDD.n0 VSS 0.33588f ; **FLOATING
C1721 VDD.t58 VSS 6.4122f ; **FLOATING
C1722 VDD.t298 VSS 0.04413f ; **FLOATING
C1723 VDD.t276 VSS 0.04861f ; **FLOATING
C1724 VDD.n1 VSS 0.03204f ; **FLOATING
C1725 VDD.n2 VSS 0.03204f ; **FLOATING
C1726 VDD.n3 VSS 1.00819f ; **FLOATING
C1727 VDD.n4 VSS 0.01724f ; **FLOATING
C1728 VDD.n5 VSS 0.03204f ; **FLOATING
C1729 VDD.n6 VSS 0.03204f ; **FLOATING
C1730 VDD.n7 VSS 1.19661f ; **FLOATING
C1731 VDD.n9 VSS 0.05594f ; **FLOATING
C1732 VDD.n10 VSS 0.0301f ; **FLOATING
C1733 VDD.n11 VSS 0.99776f ; **FLOATING
C1734 VDD.t308 VSS 0.0441f ; **FLOATING
C1735 VDD.n12 VSS 0.03114f ; **FLOATING
C1736 VDD.n13 VSS 0.97984f ; **FLOATING
C1737 VDD.t0 VSS 61.8795f ; **FLOATING
C1738 VDD.n14 VSS 0.03126f ; **FLOATING
C1739 VDD.n15 VSS 0.03204f ; **FLOATING
C1740 VDD.n16 VSS 0.41381f ; **FLOATING
C1741 VDD.n17 VSS 0.03204f ; **FLOATING
C1742 VDD.n18 VSS 0.03204f ; **FLOATING
C1743 VDD.n19 VSS 0.41381f ; **FLOATING
C1744 VDD.n20 VSS 0.03204f ; **FLOATING
C1745 VDD.n21 VSS 0.41381f ; **FLOATING
C1746 VDD.n22 VSS 0.58232f ; **FLOATING
C1747 VDD.n23 VSS 0.03204f ; **FLOATING
C1748 VDD.n24 VSS 0.41381f ; **FLOATING
C1749 VDD.n25 VSS 0.41381f ; **FLOATING
C1750 VDD.n26 VSS 0.03105f ; **FLOATING
C1751 VDD.n27 VSS 0.41381f ; **FLOATING
C1752 VDD.n28 VSS 0.03066f ; **FLOATING
C1753 VDD.n29 VSS 0.41381f ; **FLOATING
C1754 VDD.n30 VSS 0.03204f ; **FLOATING
C1755 VDD.n31 VSS 0.41381f ; **FLOATING
C1756 VDD.n32 VSS 0.03204f ; **FLOATING
C1757 VDD.n33 VSS 0.41381f ; **FLOATING
C1758 VDD.n34 VSS 0.03204f ; **FLOATING
C1759 VDD.n35 VSS 0.03204f ; **FLOATING
C1760 VDD.n36 VSS 0.41381f ; **FLOATING
C1761 VDD.n37 VSS 0.03204f ; **FLOATING
C1762 VDD.n38 VSS 0.03204f ; **FLOATING
C1763 VDD.n39 VSS 0.41381f ; **FLOATING
C1764 VDD.n40 VSS 0.63864f ; **FLOATING
C1765 VDD.t314 VSS 0.04472f ; **FLOATING
C1766 VDD.n41 VSS 0.03052f ; **FLOATING
C1767 VDD.n42 VSS 0.41381f ; **FLOATING
C1768 VDD.n43 VSS 0.03204f ; **FLOATING
C1769 VDD.n44 VSS 0.41381f ; **FLOATING
C1770 VDD.n45 VSS 0.03204f ; **FLOATING
C1771 VDD.n46 VSS 0.03204f ; **FLOATING
C1772 VDD.n47 VSS 0.41381f ; **FLOATING
C1773 VDD.n48 VSS 0.29912f ; **FLOATING
C1774 VDD.n49 VSS 0.61802f ; **FLOATING
C1775 VDD.n51 VSS 1.32848f ; **FLOATING
C1776 VDD.n53 VSS 0.05593f ; **FLOATING
C1777 VDD.n54 VSS 0.05593f ; **FLOATING
C1778 VDD.t1 VSS 20.274f ; **FLOATING
C1779 VDD.n55 VSS 0.2803f ; **FLOATING
C1780 VDD.n56 VSS 0.02866f ; **FLOATING
C1781 VDD.n57 VSS 0.08837f ; **FLOATING
C1782 VDD.n58 VSS 0.71798f ; **FLOATING
C1783 VDD.n59 VSS 0.25079f ; **FLOATING
C1784 VDD.n60 VSS 0.74474f ; **FLOATING
C1785 VDD.n61 VSS 2.09921f ; **FLOATING
C1786 VDD.n62 VSS 0.36159f ; **FLOATING
C1787 VDD.n63 VSS 0.01852f ; **FLOATING
C1788 VDD.n65 VSS 0.03204f ; **FLOATING
C1789 VDD.n66 VSS 0.39257f ; **FLOATING
C1790 VDD.n67 VSS 1.72631f ; **FLOATING
C1791 VDD.n70 VSS 0.03335f ; **FLOATING
C1792 VDD.n71 VSS 0.54861f ; **FLOATING
C1793 VDD.n73 VSS 0.03502f ; **FLOATING
C1794 VDD.n74 VSS 0.03204f ; **FLOATING
C1795 VDD.n75 VSS 0.55688f ; **FLOATING
C1796 VDD.n76 VSS 0.24045f ; **FLOATING
C1797 VDD.n77 VSS 0.02219f ; **FLOATING
C1798 VDD.n78 VSS 0.78644f ; **FLOATING
C1799 VDD.n79 VSS 0.38855f ; **FLOATING
C1800 VDD.n80 VSS 0.05924f ; **FLOATING
C1801 VDD.n81 VSS 0.03204f ; **FLOATING
C1802 VDD.n82 VSS 0.66639f ; **FLOATING
C1803 VDD.n84 VSS 0.74433f ; **FLOATING
C1804 VDD.n85 VSS 0.0301f ; **FLOATING
C1805 VDD.n86 VSS 0.55958f ; **FLOATING
C1806 VDD.n87 VSS 0.0301f ; **FLOATING
C1807 VDD.n103 VSS 0.16163f ; **FLOATING
C1808 VDD.n104 VSS 0.56095f ; **FLOATING
C1809 VDD.n111 VSS 0.01875f ; **FLOATING
C1810 VDD.n113 VSS 0.14091f ; **FLOATING
C1811 VDD.n114 VSS 0.0333f ; **FLOATING
C1812 VDD.n115 VSS 0.25548f ; **FLOATING
C1813 VDD.n116 VSS 0.32507f ; **FLOATING
C1814 VDD.n118 VSS 0.11388f ; **FLOATING
C1815 VDD.n120 VSS 0.03204f ; **FLOATING
C1816 VDD.n121 VSS 0.44872f ; **FLOATING
C1817 VDD.n123 VSS 0.17403f ; **FLOATING
C1818 VDD.t272 VSS 0.02541f ; **FLOATING
C1819 VDD.n124 VSS 0.01892f ; **FLOATING
C1820 VDD.n125 VSS 0.85818f ; **FLOATING
C1821 VDD.n126 VSS 0.11268f ; **FLOATING
C1822 VDD.n128 VSS 0.41267f ; **FLOATING
C1823 VDD.n129 VSS 0.05988f ; **FLOATING
C1824 VDD.n131 VSS 0.01579f ; **FLOATING
C1825 VDD.n138 VSS 0.01579f ; **FLOATING
C1826 VDD.n139 VSS 0.01579f ; **FLOATING
C1827 VDD.n140 VSS 0.01579f ; **FLOATING
C1828 VDD.n141 VSS 0.01579f ; **FLOATING
C1829 VDD.n142 VSS 0.01579f ; **FLOATING
C1830 VDD.n143 VSS 0.01579f ; **FLOATING
C1831 VDD.n144 VSS 0.01579f ; **FLOATING
C1832 VDD.n147 VSS 0.01579f ; **FLOATING
C1833 VDD.n148 VSS 0.05977f ; **FLOATING
C1834 VDD.n149 VSS 0.03216f ; **FLOATING
C1835 VDD.n192 VSS 0.02485f ; **FLOATING
C1836 VDD.n193 VSS 0.02485f ; **FLOATING
C1837 VDD.n194 VSS 0.02485f ; **FLOATING
C1838 VDD.n195 VSS 0.02485f ; **FLOATING
C1839 VDD.n196 VSS 0.025f ; **FLOATING
C1840 VDD.n197 VSS 0.02485f ; **FLOATING
C1841 VDD.n198 VSS 0.02485f ; **FLOATING
C1842 VDD.n199 VSS 0.02485f ; **FLOATING
C1843 VDD.n200 VSS 0.02485f ; **FLOATING
C1844 VDD.n201 VSS 0.02485f ; **FLOATING
C1845 VDD.n202 VSS 0.02485f ; **FLOATING
C1846 VDD.n203 VSS 0.02485f ; **FLOATING
C1847 VDD.n204 VSS 0.02485f ; **FLOATING
C1848 VDD.n205 VSS 0.02485f ; **FLOATING
C1849 VDD.n206 VSS 0.01722f ; **FLOATING
C1850 VDD.n207 VSS 0.01852f ; **FLOATING
C1851 VDD.n208 VSS 0.01852f ; **FLOATING
C1852 VDD.n209 VSS 0.01852f ; **FLOATING
C1853 VDD.n210 VSS 0.01852f ; **FLOATING
C1854 VDD.n211 VSS 0.01852f ; **FLOATING
C1855 VDD.n212 VSS 0.01852f ; **FLOATING
C1856 VDD.n213 VSS 0.01852f ; **FLOATING
C1857 VDD.n214 VSS 0.01852f ; **FLOATING
C1858 VDD.n215 VSS 0.01852f ; **FLOATING
C1859 VDD.n216 VSS 0.01852f ; **FLOATING
C1860 VDD.n217 VSS 0.01852f ; **FLOATING
C1861 VDD.n218 VSS 0.01852f ; **FLOATING
C1862 VDD.n219 VSS 0.025f ; **FLOATING
C1863 VDD.n220 VSS 0.025f ; **FLOATING
C1864 VDD.n224 VSS 0.02046f ; **FLOATING
C1865 VDD.n225 VSS 0.01242f ; **FLOATING
C1866 VDD.n226 VSS 0.02144f ; **FLOATING
C1867 VDD.n227 VSS 0.02111f ; **FLOATING
C1868 VDD.n228 VSS 0.01852f ; **FLOATING
C1869 VDD.n229 VSS 0.01852f ; **FLOATING
C1870 VDD.n230 VSS 0.02144f ; **FLOATING
C1871 VDD.n231 VSS 0.01852f ; **FLOATING
C1872 VDD.n232 VSS 0.01852f ; **FLOATING
C1873 VDD.n233 VSS 0.01852f ; **FLOATING
C1874 VDD.n234 VSS 0.01852f ; **FLOATING
C1875 VDD.n270 VSS 0.03086f ; **FLOATING
C1876 VDD.n271 VSS 0.02046f ; **FLOATING
C1877 VDD.n280 VSS 0.025f ; **FLOATING
C1878 VDD.n281 VSS 0.02457f ; **FLOATING
C1879 VDD.n282 VSS 0.025f ; **FLOATING
C1880 VDD.n284 VSS 0.03923f ; **FLOATING
C1881 VDD.n286 VSS 0.025f ; **FLOATING
C1882 VDD.n287 VSS 0.025f ; **FLOATING
C1883 VDD.n288 VSS 0.01875f ; **FLOATING
C1884 VDD.n289 VSS 0.025f ; **FLOATING
C1885 VDD.n290 VSS 0.025f ; **FLOATING
C1886 VDD.n291 VSS 0.01875f ; **FLOATING
C1887 VDD.n294 VSS 0.01681f ; **FLOATING
C1888 VDD.n296 VSS 0.025f ; **FLOATING
C1889 VDD.n297 VSS 0.025f ; **FLOATING
C1890 VDD.n298 VSS 0.025f ; **FLOATING
C1891 VDD.n299 VSS 0.025f ; **FLOATING
C1892 VDD.n300 VSS 0.02457f ; **FLOATING
C1893 VDD.n301 VSS 0.025f ; **FLOATING
C1894 VDD.n306 VSS 0.01579f ; **FLOATING
C1895 VDD.n308 VSS 0.1826f ; **FLOATING
C1896 VDD.n309 VSS 0.07414f ; **FLOATING
C1897 VDD.t42 VSS 11.1296f ; **FLOATING
C1898 VDD.n310 VSS 0.025f ; **FLOATING
C1899 VDD.n311 VSS 0.025f ; **FLOATING
C1900 VDD.n312 VSS 0.02457f ; **FLOATING
C1901 VDD.n313 VSS 0.02457f ; **FLOATING
C1902 VDD.n314 VSS 0.025f ; **FLOATING
C1903 VDD.n315 VSS 0.025f ; **FLOATING
C1904 VDD.n316 VSS 0.025f ; **FLOATING
C1905 VDD.n321 VSS 0.02882f ; **FLOATING
C1906 VDD.t25 VSS 0.0606f ; **FLOATING
C1907 VDD.t373 VSS 0.0606f ; **FLOATING
C1908 VDD.n322 VSS 0.15977f ; **FLOATING
C1909 VDD.t324 VSS 0.03563f ; **FLOATING
C1910 VDD.t85 VSS 0.03563f ; **FLOATING
C1911 VDD.t57 VSS 0.04843f ; **FLOATING
C1912 VDD.n323 VSS 0.01579f ; **FLOATING
C1913 VDD.n324 VSS 0.01579f ; **FLOATING
C1914 VDD.n325 VSS 0.01579f ; **FLOATING
C1915 VDD.n326 VSS 0.01579f ; **FLOATING
C1916 VDD.n327 VSS 0.01579f ; **FLOATING
C1917 VDD.n328 VSS 0.01579f ; **FLOATING
C1918 VDD.n329 VSS 0.01579f ; **FLOATING
C1919 VDD.n330 VSS 0.01579f ; **FLOATING
C1920 VDD.n331 VSS 0.01579f ; **FLOATING
C1921 VDD.n332 VSS 0.01579f ; **FLOATING
C1922 VDD.n333 VSS 0.01579f ; **FLOATING
C1923 VDD.n334 VSS 0.01579f ; **FLOATING
C1924 VDD.n335 VSS 0.01842f ; **FLOATING
C1925 VDD.n336 VSS 0.01579f ; **FLOATING
C1926 VDD.t153 VSS 0.01652f ; **FLOATING
C1927 VDD.t6 VSS 0.08221f ; **FLOATING
C1928 VDD.t128 VSS 0.01652f ; **FLOATING
C1929 VDD.t2 VSS 0.08221f ; **FLOATING
C1930 VDD.t27 VSS 0.05011f ; **FLOATING
C1931 VDD.t360 VSS 0.05011f ; **FLOATING
C1932 VDD.n337 VSS 0.20197f ; **FLOATING
C1933 VDD.n338 VSS 0.01579f ; **FLOATING
C1934 VDD.n339 VSS 0.03649f ; **FLOATING
C1935 VDD.t270 VSS 0.0437f ; **FLOATING
C1936 VDD.t269 VSS 0.03118f ; **FLOATING
C1937 VDD.t271 VSS 0.04828f ; **FLOATING
C1938 VDD.t273 VSS 0.04361f ; **FLOATING
C1939 VDD.t275 VSS 0.04379f ; **FLOATING
C1940 VDD.t274 VSS 0.03118f ; **FLOATING
C1941 VDD.t277 VSS 0.0254f ; **FLOATING
C1942 VDD.t278 VSS 0.0432f ; **FLOATING
C1943 VDD.t216 VSS 0.04742f ; **FLOATING
C1944 VDD.t120 VSS 0.03226f ; **FLOATING
C1945 VDD.n340 VSS 0.10362f ; **FLOATING
C1946 VDD.n341 VSS 0.01579f ; **FLOATING
C1947 VDD.n342 VSS 0.01382f ; **FLOATING
C1948 VDD.n343 VSS 0.03158f ; **FLOATING
C1949 VDD.n344 VSS 0.03158f ; **FLOATING
C1950 VDD.n345 VSS 0.01579f ; **FLOATING
C1951 VDD.n346 VSS 0.01579f ; **FLOATING
C1952 VDD.t124 VSS 0.04472f ; **FLOATING
C1953 VDD.n347 VSS 0.01579f ; **FLOATING
C1954 VDD.n348 VSS 0.01579f ; **FLOATING
C1955 VDD.n349 VSS 0.01579f ; **FLOATING
C1956 VDD.n350 VSS 0.01579f ; **FLOATING
C1957 VDD.n351 VSS 0.01579f ; **FLOATING
C1958 VDD.t72 VSS 0.0501f ; **FLOATING
C1959 VDD.n352 VSS 0.01579f ; **FLOATING
C1960 VDD.n353 VSS 0.01579f ; **FLOATING
C1961 VDD.n354 VSS 0.01579f ; **FLOATING
C1962 VDD.n355 VSS 0.01579f ; **FLOATING
C1963 VDD.n356 VSS 0.01579f ; **FLOATING
C1964 VDD.n357 VSS 0.01579f ; **FLOATING
C1965 VDD.n358 VSS 0.01579f ; **FLOATING
C1966 VDD.n359 VSS 0.01579f ; **FLOATING
C1967 VDD.n360 VSS 0.01579f ; **FLOATING
C1968 VDD.n361 VSS 0.01579f ; **FLOATING
C1969 VDD.n362 VSS 0.01579f ; **FLOATING
C1970 VDD.n363 VSS 0.01579f ; **FLOATING
C1971 VDD.n364 VSS 0.01579f ; **FLOATING
C1972 VDD.n365 VSS 0.01579f ; **FLOATING
C1973 VDD.n366 VSS 0.01579f ; **FLOATING
C1974 VDD.n367 VSS 0.01579f ; **FLOATING
C1975 VDD.n368 VSS 0.01579f ; **FLOATING
C1976 VDD.n369 VSS 0.01579f ; **FLOATING
C1977 VDD.n370 VSS 0.01579f ; **FLOATING
C1978 VDD.n371 VSS 0.01579f ; **FLOATING
C1979 VDD.n372 VSS 0.01579f ; **FLOATING
C1980 VDD.n373 VSS 0.01579f ; **FLOATING
C1981 VDD.n374 VSS 0.01579f ; **FLOATING
C1982 VDD.n375 VSS 0.01579f ; **FLOATING
C1983 VDD.n376 VSS 0.01579f ; **FLOATING
C1984 VDD.t122 VSS 0.03563f ; **FLOATING
C1985 VDD.n377 VSS 0.01579f ; **FLOATING
C1986 VDD.n378 VSS 0.01579f ; **FLOATING
C1987 VDD.n379 VSS 0.01579f ; **FLOATING
C1988 VDD.n380 VSS 0.01579f ; **FLOATING
C1989 VDD.n381 VSS 0.01579f ; **FLOATING
C1990 VDD.n382 VSS 0.01579f ; **FLOATING
C1991 VDD.t257 VSS 0.01652f ; **FLOATING
C1992 VDD.t121 VSS 0.08221f ; **FLOATING
C1993 VDD.n383 VSS 0.01579f ; **FLOATING
C1994 VDD.n384 VSS 0.01579f ; **FLOATING
C1995 VDD.n385 VSS 0.01579f ; **FLOATING
C1996 VDD.n386 VSS 0.04614f ; **FLOATING
C1997 VDD.n387 VSS 0.01689f ; **FLOATING
C1998 VDD.n388 VSS 0.01579f ; **FLOATING
C1999 VDD.t16 VSS 0.08766f ; **FLOATING
C2000 VDD.t24 VSS 0.08621f ; **FLOATING
C2001 VDD.n389 VSS 0.025f ; **FLOATING
C2002 VDD.t12 VSS 0.08621f ; **FLOATING
C2003 VDD.t20 VSS 0.08621f ; **FLOATING
C2004 VDD.n390 VSS 0.05594f ; **FLOATING
C2005 VDD.t10 VSS 0.08621f ; **FLOATING
C2006 VDD.t18 VSS 0.08621f ; **FLOATING
C2007 VDD.n391 VSS 0.025f ; **FLOATING
C2008 VDD.n392 VSS 0.1466f ; **FLOATING
C2009 VDD.n393 VSS 0.025f ; **FLOATING
C2010 VDD.n394 VSS 0.025f ; **FLOATING
C2011 VDD.n395 VSS 0.03777f ; **FLOATING
C2012 VDD.n396 VSS 0.03777f ; **FLOATING
C2013 VDD.n397 VSS 0.025f ; **FLOATING
C2014 VDD.n398 VSS 0.025f ; **FLOATING
C2015 VDD.n399 VSS 0.025f ; **FLOATING
C2016 VDD.n400 VSS 0.025f ; **FLOATING
C2017 VDD.n401 VSS 0.025f ; **FLOATING
C2018 VDD.n402 VSS 0.55424f ; **FLOATING
C2019 VDD.n403 VSS 0.13113f ; **FLOATING
C2020 VDD.t9 VSS 0.08621f ; **FLOATING
C2021 VDD.t17 VSS 0.08621f ; **FLOATING
C2022 VDD.n404 VSS 0.0301f ; **FLOATING
C2023 VDD.t258 VSS 0.48778f ; **FLOATING
C2024 VDD.t260 VSS 0.07714f ; **FLOATING
C2025 VDD.n405 VSS 0.0301f ; **FLOATING
C2026 VDD.t266 VSS 0.07714f ; **FLOATING
C2027 VDD.n406 VSS 0.0301f ; **FLOATING
C2028 VDD.n407 VSS 0.06088f ; **FLOATING
C2029 VDD.n408 VSS 0.01969f ; **FLOATING
C2030 VDD.n409 VSS 0.06088f ; **FLOATING
C2031 VDD.t366 VSS 0.0295f ; **FLOATING
C2032 VDD.n410 VSS 0.025f ; **FLOATING
C2033 VDD.t326 VSS 0.04472f ; **FLOATING
C2034 VDD.t133 VSS 0.04472f ; **FLOATING
C2035 VDD.t51 VSS 0.04472f ; **FLOATING
C2036 VDD.t339 VSS 0.04472f ; **FLOATING
C2037 VDD.t146 VSS 0.04472f ; **FLOATING
C2038 VDD.t63 VSS 0.04487f ; **FLOATING
C2039 VDD.t344 VSS 0.04472f ; **FLOATING
C2040 VDD.t105 VSS 0.04016f ; **FLOATING
C2041 VDD.t211 VSS 0.04472f ; **FLOATING
C2042 VDD.t55 VSS 0.0587f ; **FLOATING
C2043 VDD.t95 VSS 0.04472f ; **FLOATING
C2044 VDD.t152 VSS 0.04015f ; **FLOATING
C2045 VDD.t363 VSS 0.04016f ; **FLOATING
C2046 VDD.t45 VSS 0.05891f ; **FLOATING
C2047 VDD.t171 VSS 0.04311f ; **FLOATING
C2048 VDD.t399 VSS 0.14831f ; **FLOATING
C2049 VDD.n411 VSS 0.025f ; **FLOATING
C2050 VDD.n412 VSS 0.025f ; **FLOATING
C2051 VDD.n413 VSS 0.025f ; **FLOATING
C2052 VDD.t170 VSS 0.04015f ; **FLOATING
C2053 VDD.t160 VSS 0.04472f ; **FLOATING
C2054 VDD.n414 VSS 0.025f ; **FLOATING
C2055 VDD.t81 VSS 0.04472f ; **FLOATING
C2056 VDD.t349 VSS 0.04472f ; **FLOATING
C2057 VDD.n415 VSS 0.025f ; **FLOATING
C2058 VDD.n416 VSS 0.025f ; **FLOATING
C2059 VDD.n417 VSS 0.025f ; **FLOATING
C2060 VDD.t59 VSS 0.04472f ; **FLOATING
C2061 VDD.t169 VSS 0.04016f ; **FLOATING
C2062 VDD.n418 VSS 0.025f ; **FLOATING
C2063 VDD.t168 VSS 0.04311f ; **FLOATING
C2064 VDD.t397 VSS 0.14831f ; **FLOATING
C2065 VDD.n419 VSS 0.025f ; **FLOATING
C2066 VDD.t197 VSS 0.04472f ; **FLOATING
C2067 VDD.t186 VSS 0.04015f ; **FLOATING
C2068 VDD.n420 VSS 0.025f ; **FLOATING
C2069 VDD.t139 VSS 0.05891f ; **FLOATING
C2070 VDD.t165 VSS 0.04311f ; **FLOATING
C2071 VDD.t396 VSS 0.14831f ; **FLOATING
C2072 VDD.n421 VSS 0.025f ; **FLOATING
C2073 VDD.t164 VSS 0.04015f ; **FLOATING
C2074 VDD.n422 VSS 0.025f ; **FLOATING
C2075 VDD.t161 VSS 0.04472f ; **FLOATING
C2076 VDD.n423 VSS 0.025f ; **FLOATING
C2077 VDD.t336 VSS 0.04472f ; **FLOATING
C2078 VDD.t202 VSS 0.04472f ; **FLOATING
C2079 VDD.n424 VSS 0.02457f ; **FLOATING
C2080 VDD.n425 VSS 0.025f ; **FLOATING
C2081 VDD.n426 VSS 0.02457f ; **FLOATING
C2082 VDD.t29 VSS 0.04472f ; **FLOATING
C2083 VDD.t148 VSS 0.04016f ; **FLOATING
C2084 VDD.n427 VSS 0.02457f ; **FLOATING
C2085 VDD.t147 VSS 0.04311f ; **FLOATING
C2086 VDD.t394 VSS 0.14831f ; **FLOATING
C2087 VDD.n428 VSS 0.02457f ; **FLOATING
C2088 VDD.t198 VSS 0.04472f ; **FLOATING
C2089 VDD.t254 VSS 0.04015f ; **FLOATING
C2090 VDD.n429 VSS 0.025f ; **FLOATING
C2091 VDD.t103 VSS 0.05891f ; **FLOATING
C2092 VDD.t143 VSS 0.04311f ; **FLOATING
C2093 VDD.t393 VSS 0.14831f ; **FLOATING
C2094 VDD.n430 VSS 0.02457f ; **FLOATING
C2095 VDD.t194 VSS 0.04015f ; **FLOATING
C2096 VDD.n431 VSS 0.02457f ; **FLOATING
C2097 VDD.t38 VSS 0.04472f ; **FLOATING
C2098 VDD.n432 VSS 0.025f ; **FLOATING
C2099 VDD.t102 VSS 0.04472f ; **FLOATING
C2100 VDD.t209 VSS 0.04472f ; **FLOATING
C2101 VDD.n433 VSS 0.025f ; **FLOATING
C2102 VDD.n434 VSS 0.025f ; **FLOATING
C2103 VDD.t334 VSS 0.0587f ; **FLOATING
C2104 VDD.n435 VSS 0.025f ; **FLOATING
C2105 VDD.n436 VSS 0.025f ; **FLOATING
C2106 VDD.t206 VSS 0.04472f ; **FLOATING
C2107 VDD.n437 VSS 0.025f ; **FLOATING
C2108 VDD.t79 VSS 0.04748f ; **FLOATING
C2109 VDD.n438 VSS 0.025f ; **FLOATING
C2110 VDD.t80 VSS 0.08384f ; **FLOATING
C2111 VDD.n439 VSS 0.025f ; **FLOATING
C2112 VDD.t32 VSS 0.04472f ; **FLOATING
C2113 VDD.t348 VSS 0.04472f ; **FLOATING
C2114 VDD.n440 VSS 0.025f ; **FLOATING
C2115 VDD.n441 VSS 0.025f ; **FLOATING
C2116 VDD.n442 VSS 0.025f ; **FLOATING
C2117 VDD.t174 VSS 0.04472f ; **FLOATING
C2118 VDD.t167 VSS 0.04016f ; **FLOATING
C2119 VDD.n443 VSS 0.025f ; **FLOATING
C2120 VDD.t166 VSS 0.04311f ; **FLOATING
C2121 VDD.t391 VSS 0.14831f ; **FLOATING
C2122 VDD.n444 VSS 0.025f ; **FLOATING
C2123 VDD.t196 VSS 0.04472f ; **FLOATING
C2124 VDD.t364 VSS 0.04015f ; **FLOATING
C2125 VDD.n445 VSS 0.025f ; **FLOATING
C2126 VDD.t34 VSS 0.05891f ; **FLOATING
C2127 VDD.t162 VSS 0.04311f ; **FLOATING
C2128 VDD.t390 VSS 0.14831f ; **FLOATING
C2129 VDD.n446 VSS 0.025f ; **FLOATING
C2130 VDD.t227 VSS 0.04015f ; **FLOATING
C2131 VDD.n447 VSS 0.025f ; **FLOATING
C2132 VDD.t361 VSS 0.04472f ; **FLOATING
C2133 VDD.t219 VSS 0.04472f ; **FLOATING
C2134 VDD.t109 VSS 0.04472f ; **FLOATING
C2135 VDD.t8 VSS 0.04472f ; **FLOATING
C2136 VDD.t251 VSS 0.04016f ; **FLOATING
C2137 VDD.t201 VSS 0.04311f ; **FLOATING
C2138 VDD.t388 VSS 0.14831f ; **FLOATING
C2139 VDD.t199 VSS 0.04472f ; **FLOATING
C2140 VDD.t200 VSS 0.04015f ; **FLOATING
C2141 VDD.t96 VSS 0.05891f ; **FLOATING
C2142 VDD.t92 VSS 0.04311f ; **FLOATING
C2143 VDD.t387 VSS 0.14831f ; **FLOATING
C2144 VDD.t91 VSS 0.04015f ; **FLOATING
C2145 VDD.t39 VSS 0.04472f ; **FLOATING
C2146 VDD.t108 VSS 0.04472f ; **FLOATING
C2147 VDD.t210 VSS 0.04472f ; **FLOATING
C2148 VDD.t354 VSS 0.04472f ; **FLOATING
C2149 VDD.t87 VSS 0.04016f ; **FLOATING
C2150 VDD.t86 VSS 0.04311f ; **FLOATING
C2151 VDD.t385 VSS 0.14831f ; **FLOATING
C2152 VDD.t37 VSS 0.04472f ; **FLOATING
C2153 VDD.t253 VSS 0.04015f ; **FLOATING
C2154 VDD.t244 VSS 0.05891f ; **FLOATING
C2155 VDD.t83 VSS 0.04311f ; **FLOATING
C2156 VDD.t384 VSS 0.14831f ; **FLOATING
C2157 VDD.t107 VSS 0.04015f ; **FLOATING
C2158 VDD.t195 VSS 0.04472f ; **FLOATING
C2159 VDD.t337 VSS 0.04472f ; **FLOATING
C2160 VDD.t35 VSS 0.04472f ; **FLOATING
C2161 VDD.t98 VSS 0.0587f ; **FLOATING
C2162 VDD.t4 VSS 0.04472f ; **FLOATING
C2163 VDD.t151 VSS 0.04472f ; **FLOATING
C2164 VDD.t84 VSS 0.04016f ; **FLOATING
C2165 VDD.t188 VSS 0.04472f ; **FLOATING
C2166 VDD.t220 VSS 0.04015f ; **FLOATING
C2167 VDD.t204 VSS 0.04311f ; **FLOATING
C2168 VDD.t386 VSS 0.14831f ; **FLOATING
C2169 VDD.t158 VSS 0.0587f ; **FLOATING
C2170 VDD.t203 VSS 0.04016f ; **FLOATING
C2171 VDD.t111 VSS 0.04472f ; **FLOATING
C2172 VDD.t256 VSS 0.04016f ; **FLOATING
C2173 VDD.t365 VSS 0.04472f ; **FLOATING
C2174 VDD.t93 VSS 0.04015f ; **FLOATING
C2175 VDD.t94 VSS 0.04311f ; **FLOATING
C2176 VDD.t389 VSS 0.14831f ; **FLOATING
C2177 VDD.t101 VSS 0.0587f ; **FLOATING
C2178 VDD.t140 VSS 0.04016f ; **FLOATING
C2179 VDD.t115 VSS 0.04472f ; **FLOATING
C2180 VDD.n448 VSS 0.025f ; **FLOATING
C2181 VDD.n449 VSS 0.025f ; **FLOATING
C2182 VDD.n450 VSS 0.34089f ; **FLOATING
C2183 VDD.n451 VSS 0.02072f ; **FLOATING
C2184 VDD.t163 VSS 0.04016f ; **FLOATING
C2185 VDD.n452 VSS 0.025f ; **FLOATING
C2186 VDD.n453 VSS 0.025f ; **FLOATING
C2187 VDD.n454 VSS 0.025f ; **FLOATING
C2188 VDD.n455 VSS 0.025f ; **FLOATING
C2189 VDD.t56 VSS 0.04472f ; **FLOATING
C2190 VDD.t145 VSS 0.04015f ; **FLOATING
C2191 VDD.n456 VSS 0.025f ; **FLOATING
C2192 VDD.n457 VSS 0.025f ; **FLOATING
C2193 VDD.n458 VSS 0.025f ; **FLOATING
C2194 VDD.n459 VSS 0.025f ; **FLOATING
C2195 VDD.n460 VSS 0.025f ; **FLOATING
C2196 VDD.n461 VSS 0.025f ; **FLOATING
C2197 VDD.n462 VSS 0.025f ; **FLOATING
C2198 VDD.n463 VSS 0.025f ; **FLOATING
C2199 VDD.n464 VSS 0.025f ; **FLOATING
C2200 VDD.t41 VSS 0.04311f ; **FLOATING
C2201 VDD.t392 VSS 0.14831f ; **FLOATING
C2202 VDD.t66 VSS 0.0587f ; **FLOATING
C2203 VDD.t40 VSS 0.04016f ; **FLOATING
C2204 VDD.n465 VSS 0.025f ; **FLOATING
C2205 VDD.n466 VSS 0.025f ; **FLOATING
C2206 VDD.n467 VSS 0.025f ; **FLOATING
C2207 VDD.n468 VSS 0.025f ; **FLOATING
C2208 VDD.n469 VSS 0.025f ; **FLOATING
C2209 VDD.n470 VSS 0.025f ; **FLOATING
C2210 VDD.t332 VSS 0.04472f ; **FLOATING
C2211 VDD.t182 VSS 0.04472f ; **FLOATING
C2212 VDD.n471 VSS 0.02829f ; **FLOATING
C2213 VDD.n472 VSS 0.0375f ; **FLOATING
C2214 VDD.n473 VSS 0.03776f ; **FLOATING
C2215 VDD.n474 VSS 0.025f ; **FLOATING
C2216 VDD.n475 VSS 0.025f ; **FLOATING
C2217 VDD.t64 VSS 0.0587f ; **FLOATING
C2218 VDD.n476 VSS 0.025f ; **FLOATING
C2219 VDD.n477 VSS 0.025f ; **FLOATING
C2220 VDD.n478 VSS 0.025f ; **FLOATING
C2221 VDD.n479 VSS 0.025f ; **FLOATING
C2222 VDD.n480 VSS 0.025f ; **FLOATING
C2223 VDD.n481 VSS 0.025f ; **FLOATING
C2224 VDD.t117 VSS 0.04472f ; **FLOATING
C2225 VDD.t238 VSS 0.04472f ; **FLOATING
C2226 VDD.t187 VSS 0.04472f ; **FLOATING
C2227 VDD.n482 VSS 0.02171f ; **FLOATING
C2228 VDD.n483 VSS 0.0375f ; **FLOATING
C2229 VDD.n484 VSS 0.03789f ; **FLOATING
C2230 VDD.n485 VSS 0.025f ; **FLOATING
C2231 VDD.n486 VSS 0.025f ; **FLOATING
C2232 VDD.n487 VSS 0.025f ; **FLOATING
C2233 VDD.n488 VSS 0.025f ; **FLOATING
C2234 VDD.n489 VSS 0.025f ; **FLOATING
C2235 VDD.n490 VSS 0.025f ; **FLOATING
C2236 VDD.n491 VSS 0.025f ; **FLOATING
C2237 VDD.n492 VSS 0.025f ; **FLOATING
C2238 VDD.t193 VSS 0.04472f ; **FLOATING
C2239 VDD.n493 VSS 0.02829f ; **FLOATING
C2240 VDD.n494 VSS 0.0375f ; **FLOATING
C2241 VDD.n495 VSS 0.025f ; **FLOATING
C2242 VDD.n496 VSS 0.025f ; **FLOATING
C2243 VDD.n497 VSS 0.0375f ; **FLOATING
C2244 VDD.n498 VSS 0.02037f ; **FLOATING
C2245 VDD.t144 VSS 0.04016f ; **FLOATING
C2246 VDD.n499 VSS 0.02457f ; **FLOATING
C2247 VDD.n500 VSS 0.025f ; **FLOATING
C2248 VDD.n501 VSS 0.025f ; **FLOATING
C2249 VDD.n502 VSS 0.025f ; **FLOATING
C2250 VDD.t5 VSS 0.04472f ; **FLOATING
C2251 VDD.t176 VSS 0.04015f ; **FLOATING
C2252 VDD.n503 VSS 0.025f ; **FLOATING
C2253 VDD.n504 VSS 0.02457f ; **FLOATING
C2254 VDD.n505 VSS 0.02457f ; **FLOATING
C2255 VDD.n506 VSS 0.02457f ; **FLOATING
C2256 VDD.n507 VSS 0.025f ; **FLOATING
C2257 VDD.n508 VSS 0.025f ; **FLOATING
C2258 VDD.n509 VSS 0.025f ; **FLOATING
C2259 VDD.n510 VSS 0.025f ; **FLOATING
C2260 VDD.n511 VSS 0.02457f ; **FLOATING
C2261 VDD.t177 VSS 0.04311f ; **FLOATING
C2262 VDD.t395 VSS 0.14831f ; **FLOATING
C2263 VDD.t329 VSS 0.0587f ; **FLOATING
C2264 VDD.t205 VSS 0.04016f ; **FLOATING
C2265 VDD.n512 VSS 0.02457f ; **FLOATING
C2266 VDD.n513 VSS 0.025f ; **FLOATING
C2267 VDD.n514 VSS 0.025f ; **FLOATING
C2268 VDD.n515 VSS 0.025f ; **FLOATING
C2269 VDD.n516 VSS 0.025f ; **FLOATING
C2270 VDD.n517 VSS 0.02457f ; **FLOATING
C2271 VDD.t44 VSS 0.04472f ; **FLOATING
C2272 VDD.n518 VSS 0.0278f ; **FLOATING
C2273 VDD.n519 VSS 0.0375f ; **FLOATING
C2274 VDD.n520 VSS 0.025f ; **FLOATING
C2275 VDD.n521 VSS 0.025f ; **FLOATING
C2276 VDD.n522 VSS 0.0375f ; **FLOATING
C2277 VDD.n523 VSS 0.02072f ; **FLOATING
C2278 VDD.t208 VSS 0.04016f ; **FLOATING
C2279 VDD.n524 VSS 0.025f ; **FLOATING
C2280 VDD.n525 VSS 0.025f ; **FLOATING
C2281 VDD.n526 VSS 0.025f ; **FLOATING
C2282 VDD.n527 VSS 0.025f ; **FLOATING
C2283 VDD.t230 VSS 0.04472f ; **FLOATING
C2284 VDD.t353 VSS 0.04015f ; **FLOATING
C2285 VDD.n528 VSS 0.025f ; **FLOATING
C2286 VDD.n529 VSS 0.025f ; **FLOATING
C2287 VDD.n530 VSS 0.025f ; **FLOATING
C2288 VDD.n531 VSS 0.025f ; **FLOATING
C2289 VDD.n532 VSS 0.025f ; **FLOATING
C2290 VDD.n533 VSS 0.025f ; **FLOATING
C2291 VDD.n534 VSS 0.025f ; **FLOATING
C2292 VDD.n535 VSS 0.025f ; **FLOATING
C2293 VDD.n536 VSS 0.025f ; **FLOATING
C2294 VDD.t142 VSS 0.04311f ; **FLOATING
C2295 VDD.t398 VSS 0.14831f ; **FLOATING
C2296 VDD.t173 VSS 0.0587f ; **FLOATING
C2297 VDD.t141 VSS 0.04016f ; **FLOATING
C2298 VDD.n537 VSS 0.025f ; **FLOATING
C2299 VDD.n538 VSS 0.025f ; **FLOATING
C2300 VDD.n539 VSS 0.025f ; **FLOATING
C2301 VDD.n540 VSS 0.025f ; **FLOATING
C2302 VDD.n541 VSS 0.025f ; **FLOATING
C2303 VDD.n542 VSS 0.025f ; **FLOATING
C2304 VDD.t68 VSS 0.04472f ; **FLOATING
C2305 VDD.n543 VSS 0.02829f ; **FLOATING
C2306 VDD.n544 VSS 0.0375f ; **FLOATING
C2307 VDD.n545 VSS 0.0375f ; **FLOATING
C2308 VDD.n546 VSS 0.02072f ; **FLOATING
C2309 VDD.n547 VSS 0.025f ; **FLOATING
C2310 VDD.n548 VSS 0.025f ; **FLOATING
C2311 VDD.n549 VSS 0.025f ; **FLOATING
C2312 VDD.n550 VSS 0.025f ; **FLOATING
C2313 VDD.n551 VSS 0.025f ; **FLOATING
C2314 VDD.n552 VSS 0.025f ; **FLOATING
C2315 VDD.n553 VSS 0.025f ; **FLOATING
C2316 VDD.n554 VSS 0.025f ; **FLOATING
C2317 VDD.n555 VSS 0.025f ; **FLOATING
C2318 VDD.n556 VSS 0.025f ; **FLOATING
C2319 VDD.n557 VSS 0.025f ; **FLOATING
C2320 VDD.n558 VSS 0.025f ; **FLOATING
C2321 VDD.n559 VSS 0.025f ; **FLOATING
C2322 VDD.n560 VSS 0.025f ; **FLOATING
C2323 VDD.n561 VSS 0.025f ; **FLOATING
C2324 VDD.t191 VSS 0.04472f ; **FLOATING
C2325 VDD.n562 VSS 0.025f ; **FLOATING
C2326 VDD.n563 VSS 0.025f ; **FLOATING
C2327 VDD.n564 VSS 0.025f ; **FLOATING
C2328 VDD.n565 VSS 0.025f ; **FLOATING
C2329 VDD.n566 VSS 0.025f ; **FLOATING
C2330 VDD.n567 VSS 0.025f ; **FLOATING
C2331 VDD.n568 VSS 0.025f ; **FLOATING
C2332 VDD.t47 VSS 0.04984f ; **FLOATING
C2333 VDD.t226 VSS 0.04984f ; **FLOATING
C2334 VDD.n569 VSS 0.025f ; **FLOATING
C2335 VDD.n570 VSS 0.025f ; **FLOATING
C2336 VDD.n571 VSS 0.025f ; **FLOATING
C2337 VDD.n572 VSS 0.025f ; **FLOATING
C2338 VDD.n573 VSS 0.025f ; **FLOATING
C2339 VDD.n574 VSS 0.025f ; **FLOATING
C2340 VDD.n575 VSS 0.025f ; **FLOATING
C2341 VDD.n576 VSS 0.025f ; **FLOATING
C2342 VDD.n577 VSS 0.025f ; **FLOATING
C2343 VDD.n578 VSS 0.025f ; **FLOATING
C2344 VDD.n579 VSS 0.025f ; **FLOATING
C2345 VDD.n580 VSS 0.025f ; **FLOATING
C2346 VDD.n581 VSS 0.025f ; **FLOATING
C2347 VDD.n582 VSS 0.025f ; **FLOATING
C2348 VDD.n583 VSS 0.025f ; **FLOATING
C2349 VDD.n584 VSS 0.025f ; **FLOATING
C2350 VDD.t138 VSS 0.03302f ; **FLOATING
C2351 VDD.t358 VSS 0.03302f ; **FLOATING
C2352 VDD.n585 VSS 0.025f ; **FLOATING
C2353 VDD.t130 VSS 0.04414f ; **FLOATING
C2354 VDD.t31 VSS 0.04414f ; **FLOATING
C2355 VDD.n586 VSS 0.025f ; **FLOATING
C2356 VDD.n587 VSS 0.025f ; **FLOATING
C2357 VDD.t357 VSS 0.04984f ; **FLOATING
C2358 VDD.t249 VSS 0.04984f ; **FLOATING
C2359 VDD.n588 VSS 0.025f ; **FLOATING
C2360 VDD.t327 VSS 0.03302f ; **FLOATING
C2361 VDD.t134 VSS 0.03302f ; **FLOATING
C2362 VDD.n589 VSS 0.025f ; **FLOATING
C2363 VDD.t129 VSS 0.04414f ; **FLOATING
C2364 VDD.t30 VSS 0.04414f ; **FLOATING
C2365 VDD.n590 VSS 0.025f ; **FLOATING
C2366 VDD.n591 VSS 0.025f ; **FLOATING
C2367 VDD.t229 VSS 0.04984f ; **FLOATING
C2368 VDD.t155 VSS 0.04984f ; **FLOATING
C2369 VDD.n592 VSS 0.025f ; **FLOATING
C2370 VDD.t52 VSS 0.03302f ; **FLOATING
C2371 VDD.t341 VSS 0.03302f ; **FLOATING
C2372 VDD.n593 VSS 0.025f ; **FLOATING
C2373 VDD.t137 VSS 0.04414f ; **FLOATING
C2374 VDD.t359 VSS 0.04414f ; **FLOATING
C2375 VDD.n594 VSS 0.025f ; **FLOATING
C2376 VDD.t181 VSS 0.04984f ; **FLOATING
C2377 VDD.t372 VSS 0.04984f ; **FLOATING
C2378 VDD.n595 VSS 0.025f ; **FLOATING
C2379 VDD.t325 VSS 0.03302f ; **FLOATING
C2380 VDD.t135 VSS 0.03302f ; **FLOATING
C2381 VDD.n596 VSS 0.025f ; **FLOATING
C2382 VDD.n597 VSS 0.025f ; **FLOATING
C2383 VDD.t46 VSS 0.04414f ; **FLOATING
C2384 VDD.t225 VSS 0.04414f ; **FLOATING
C2385 VDD.n598 VSS 0.025f ; **FLOATING
C2386 VDD.n599 VSS 0.05041f ; **FLOATING
C2387 VDD.n600 VSS 0.05028f ; **FLOATING
C2388 VDD.n601 VSS 0.025f ; **FLOATING
C2389 VDD.t377 VSS 0.04472f ; **FLOATING
C2390 VDD.n602 VSS 0.025f ; **FLOATING
C2391 VDD.n603 VSS 0.025f ; **FLOATING
C2392 VDD.n604 VSS 0.025f ; **FLOATING
C2393 VDD.t48 VSS 0.0587f ; **FLOATING
C2394 VDD.n605 VSS 0.025f ; **FLOATING
C2395 VDD.n606 VSS 0.025f ; **FLOATING
C2396 VDD.n607 VSS 0.025f ; **FLOATING
C2397 VDD.n608 VSS 0.03776f ; **FLOATING
C2398 VDD.n609 VSS 0.0375f ; **FLOATING
C2399 VDD.n610 VSS 0.02829f ; **FLOATING
C2400 VDD.t110 VSS 0.04472f ; **FLOATING
C2401 VDD.n611 VSS 0.025f ; **FLOATING
C2402 VDD.t78 VSS 0.04472f ; **FLOATING
C2403 VDD.n612 VSS 0.025f ; **FLOATING
C2404 VDD.n613 VSS 0.025f ; **FLOATING
C2405 VDD.t183 VSS 0.04016f ; **FLOATING
C2406 VDD.n614 VSS 0.025f ; **FLOATING
C2407 VDD.n615 VSS 0.025f ; **FLOATING
C2408 VDD.t184 VSS 0.04311f ; **FLOATING
C2409 VDD.t401 VSS 0.14831f ; **FLOATING
C2410 VDD.n616 VSS 0.025f ; **FLOATING
C2411 VDD.n617 VSS 0.025f ; **FLOATING
C2412 VDD.t252 VSS 0.04472f ; **FLOATING
C2413 VDD.t185 VSS 0.04015f ; **FLOATING
C2414 VDD.n618 VSS 0.025f ; **FLOATING
C2415 VDD.n619 VSS 0.025f ; **FLOATING
C2416 VDD.t106 VSS 0.04311f ; **FLOATING
C2417 VDD.t400 VSS 0.14831f ; **FLOATING
C2418 VDD.n620 VSS 0.025f ; **FLOATING
C2419 VDD.n621 VSS 0.025f ; **FLOATING
C2420 VDD.n622 VSS 0.025f ; **FLOATING
C2421 VDD.n623 VSS 0.025f ; **FLOATING
C2422 VDD.n624 VSS 0.025f ; **FLOATING
C2423 VDD.n625 VSS 0.025f ; **FLOATING
C2424 VDD.n626 VSS 0.025f ; **FLOATING
C2425 VDD.n627 VSS 0.025f ; **FLOATING
C2426 VDD.n628 VSS 0.1806f ; **FLOATING
C2427 VDD.n629 VSS 1.2448f ; **FLOATING
C2428 VDD.t285 VSS 0.09062f ; **FLOATING
C2429 VDD.t288 VSS 0.04174f ; **FLOATING
C2430 VDD.t289 VSS 0.0432f ; **FLOATING
C2431 VDD.t286 VSS 0.04828f ; **FLOATING
C2432 VDD.t287 VSS 0.0432f ; **FLOATING
C2433 VDD.t70 VSS 0.05066f ; **FLOATING
C2434 VDD.t323 VSS 0.0432f ; **FLOATING
C2435 VDD.n630 VSS 0.2171f ; **FLOATING
C2436 VDD.t97 VSS 0.05066f ; **FLOATING
C2437 VDD.t322 VSS 0.0432f ; **FLOATING
C2438 VDD.n631 VSS 0.025f ; **FLOATING
C2439 VDD.t150 VSS 0.05066f ; **FLOATING
C2440 VDD.t178 VSS 0.05066f ; **FLOATING
C2441 VDD.t338 VSS 0.05066f ; **FLOATING
C2442 VDD.n632 VSS 0.025f ; **FLOATING
C2443 VDD.n633 VSS 0.025f ; **FLOATING
C2444 VDD.n634 VSS 0.025f ; **FLOATING
C2445 VDD.t112 VSS 0.05066f ; **FLOATING
C2446 VDD.t126 VSS 0.05066f ; **FLOATING
C2447 VDD.t7 VSS 0.05066f ; **FLOATING
C2448 VDD.t131 VSS 0.05066f ; **FLOATING
C2449 VDD.t88 VSS 0.05066f ; **FLOATING
C2450 VDD.t33 VSS 0.05066f ; **FLOATING
C2451 VDD.t175 VSS 0.05066f ; **FLOATING
C2452 VDD.n635 VSS 0.025f ; **FLOATING
C2453 VDD.n636 VSS 0.025f ; **FLOATING
C2454 VDD.n637 VSS 0.025f ; **FLOATING
C2455 VDD.t330 VSS 0.05066f ; **FLOATING
C2456 VDD.t311 VSS 0.0432f ; **FLOATING
C2457 VDD.n638 VSS 0.05024f ; **FLOATING
C2458 VDD.n639 VSS 0.05032f ; **FLOATING
C2459 VDD.t36 VSS 0.05066f ; **FLOATING
C2460 VDD.t301 VSS 0.0432f ; **FLOATING
C2461 VDD.n640 VSS 0.025f ; **FLOATING
C2462 VDD.t214 VSS 0.05066f ; **FLOATING
C2463 VDD.t310 VSS 0.0432f ; **FLOATING
C2464 VDD.n641 VSS 0.025f ; **FLOATING
C2465 VDD.n642 VSS 0.05f ; **FLOATING
C2466 VDD.n643 VSS 0.05f ; **FLOATING
C2467 VDD.t118 VSS 0.05066f ; **FLOATING
C2468 VDD.t53 VSS 0.05066f ; **FLOATING
C2469 VDD.t309 VSS 0.04458f ; **FLOATING
C2470 VDD.n644 VSS 0.025f ; **FLOATING
C2471 VDD.n645 VSS 0.025f ; **FLOATING
C2472 VDD.n646 VSS 0.02517f ; **FLOATING
C2473 VDD.n647 VSS 0.025f ; **FLOATING
C2474 VDD.n648 VSS 0.05024f ; **FLOATING
C2475 VDD.n649 VSS 0.05032f ; **FLOATING
C2476 VDD.t67 VSS 0.05066f ; **FLOATING
C2477 VDD.t28 VSS 0.05066f ; **FLOATING
C2478 VDD.n650 VSS 0.025f ; **FLOATING
C2479 VDD.n651 VSS 0.025f ; **FLOATING
C2480 VDD.n652 VSS 0.025f ; **FLOATING
C2481 VDD.n653 VSS 0.01875f ; **FLOATING
C2482 VDD.n654 VSS 0.05f ; **FLOATING
C2483 VDD.n655 VSS 0.02517f ; **FLOATING
C2484 VDD.n656 VSS 0.05f ; **FLOATING
C2485 VDD.n657 VSS 0.025f ; **FLOATING
C2486 VDD.n658 VSS 0.025f ; **FLOATING
C2487 VDD.t43 VSS 0.05066f ; **FLOATING
C2488 VDD.n659 VSS 0.05f ; **FLOATING
C2489 VDD.n660 VSS 0.05032f ; **FLOATING
C2490 VDD.t218 VSS 0.05066f ; **FLOATING
C2491 VDD.t60 VSS 0.05066f ; **FLOATING
C2492 VDD.t82 VSS 0.05066f ; **FLOATING
C2493 VDD.t69 VSS 0.05066f ; **FLOATING
C2494 VDD.t71 VSS 0.05066f ; **FLOATING
C2495 VDD.t299 VSS 0.0432f ; **FLOATING
C2496 VDD.n661 VSS 0.05024f ; **FLOATING
C2497 VDD.n662 VSS 0.05f ; **FLOATING
C2498 VDD.t212 VSS 0.05066f ; **FLOATING
C2499 VDD.t292 VSS 0.0432f ; **FLOATING
C2500 VDD.n663 VSS 0.025f ; **FLOATING
C2501 VDD.t54 VSS 0.05066f ; **FLOATING
C2502 VDD.n664 VSS 0.05024f ; **FLOATING
C2503 VDD.n665 VSS 0.05032f ; **FLOATING
C2504 VDD.n666 VSS 0.025f ; **FLOATING
C2505 VDD.n667 VSS 0.05f ; **FLOATING
C2506 VDD.t217 VSS 0.05066f ; **FLOATING
C2507 VDD.n668 VSS 0.025f ; **FLOATING
C2508 VDD.n669 VSS 0.02517f ; **FLOATING
C2509 VDD.n670 VSS 0.05f ; **FLOATING
C2510 VDD.n671 VSS 0.025f ; **FLOATING
C2511 VDD.n672 VSS 0.025f ; **FLOATING
C2512 VDD.t49 VSS 0.05066f ; **FLOATING
C2513 VDD.n673 VSS 0.025f ; **FLOATING
C2514 VDD.n674 VSS 0.025f ; **FLOATING
C2515 VDD.t295 VSS 0.04397f ; **FLOATING
C2516 VDD.n675 VSS 0.025f ; **FLOATING
C2517 VDD.n676 VSS 0.025f ; **FLOATING
C2518 VDD.n677 VSS 0.025f ; **FLOATING
C2519 VDD.n678 VSS 0.025f ; **FLOATING
C2520 VDD.n679 VSS 0.025f ; **FLOATING
C2521 VDD.n680 VSS 0.025f ; **FLOATING
C2522 VDD.n681 VSS 0.025f ; **FLOATING
C2523 VDD.n682 VSS 0.025f ; **FLOATING
C2524 VDD.n683 VSS 0.025f ; **FLOATING
C2525 VDD.n684 VSS 0.025f ; **FLOATING
C2526 VDD.n685 VSS 0.025f ; **FLOATING
C2527 VDD.n686 VSS 0.025f ; **FLOATING
C2528 VDD.n687 VSS 0.025f ; **FLOATING
C2529 VDD.n688 VSS 0.025f ; **FLOATING
C2530 VDD.n689 VSS 0.025f ; **FLOATING
C2531 VDD.n690 VSS 0.025f ; **FLOATING
C2532 VDD.n691 VSS 0.025f ; **FLOATING
C2533 VDD.n692 VSS 0.025f ; **FLOATING
C2534 VDD.n693 VSS 0.025f ; **FLOATING
C2535 VDD.n694 VSS 0.025f ; **FLOATING
C2536 VDD.n695 VSS 0.025f ; **FLOATING
C2537 VDD.n696 VSS 0.025f ; **FLOATING
C2538 VDD.n697 VSS 0.025f ; **FLOATING
C2539 VDD.n698 VSS 0.025f ; **FLOATING
C2540 VDD.n699 VSS 0.025f ; **FLOATING
C2541 VDD.n700 VSS 0.025f ; **FLOATING
C2542 VDD.n701 VSS 0.025f ; **FLOATING
C2543 VDD.n702 VSS 0.025f ; **FLOATING
C2544 VDD.n703 VSS 0.025f ; **FLOATING
C2545 VDD.n704 VSS 0.025f ; **FLOATING
C2546 VDD.n705 VSS 0.025f ; **FLOATING
C2547 VDD.n706 VSS 0.025f ; **FLOATING
C2548 VDD.n707 VSS 0.025f ; **FLOATING
C2549 VDD.n708 VSS 0.025f ; **FLOATING
C2550 VDD.n709 VSS 0.025f ; **FLOATING
C2551 VDD.n710 VSS 0.025f ; **FLOATING
C2552 VDD.n711 VSS 0.025f ; **FLOATING
C2553 VDD.n712 VSS 0.025f ; **FLOATING
C2554 VDD.n713 VSS 0.025f ; **FLOATING
C2555 VDD.n714 VSS 0.025f ; **FLOATING
C2556 VDD.n715 VSS 0.025f ; **FLOATING
C2557 VDD.n716 VSS 0.025f ; **FLOATING
C2558 VDD.n717 VSS 0.025f ; **FLOATING
C2559 VDD.n718 VSS 0.025f ; **FLOATING
C2560 VDD.n719 VSS 0.025f ; **FLOATING
C2561 VDD.n720 VSS 0.025f ; **FLOATING
C2562 VDD.t312 VSS 0.0432f ; **FLOATING
C2563 VDD.n721 VSS 0.025f ; **FLOATING
C2564 VDD.n722 VSS 0.025f ; **FLOATING
C2565 VDD.n723 VSS 0.025f ; **FLOATING
C2566 VDD.n724 VSS 0.025f ; **FLOATING
C2567 VDD.n725 VSS 0.025f ; **FLOATING
C2568 VDD.n726 VSS 0.025f ; **FLOATING
C2569 VDD.n727 VSS 0.025f ; **FLOATING
C2570 VDD.n728 VSS 0.025f ; **FLOATING
C2571 VDD.t316 VSS 0.0432f ; **FLOATING
C2572 VDD.t190 VSS 0.05066f ; **FLOATING
C2573 VDD.n729 VSS 0.025f ; **FLOATING
C2574 VDD.n730 VSS 0.025f ; **FLOATING
C2575 VDD.n731 VSS 0.025f ; **FLOATING
C2576 VDD.n732 VSS 0.025f ; **FLOATING
C2577 VDD.n733 VSS 0.025f ; **FLOATING
C2578 VDD.t315 VSS 0.0432f ; **FLOATING
C2579 VDD.n734 VSS 0.025f ; **FLOATING
C2580 VDD.n735 VSS 0.025f ; **FLOATING
C2581 VDD.n736 VSS 0.19145f ; **FLOATING
C2582 VDD.n737 VSS 0.025f ; **FLOATING
C2583 VDD.n738 VSS 0.025f ; **FLOATING
C2584 VDD.n739 VSS 0.025f ; **FLOATING
C2585 VDD.n740 VSS 0.025f ; **FLOATING
C2586 VDD.n741 VSS 0.025f ; **FLOATING
C2587 VDD.n742 VSS 0.025f ; **FLOATING
C2588 VDD.n743 VSS 0.025f ; **FLOATING
C2589 VDD.n744 VSS 0.025f ; **FLOATING
C2590 VDD.n745 VSS 0.025f ; **FLOATING
C2591 VDD.t320 VSS 0.0432f ; **FLOATING
C2592 VDD.n746 VSS 0.025f ; **FLOATING
C2593 VDD.n747 VSS 0.025f ; **FLOATING
C2594 VDD.n748 VSS 0.025f ; **FLOATING
C2595 VDD.n749 VSS 0.025f ; **FLOATING
C2596 VDD.n750 VSS 0.07227f ; **FLOATING
C2597 VDD.t321 VSS 0.0432f ; **FLOATING
C2598 VDD.n751 VSS 0.05024f ; **FLOATING
C2599 VDD.n752 VSS 0.05f ; **FLOATING
C2600 VDD.n753 VSS 0.02517f ; **FLOATING
C2601 VDD.n754 VSS 0.025f ; **FLOATING
C2602 VDD.n755 VSS 0.05024f ; **FLOATING
C2603 VDD.n756 VSS 0.05f ; **FLOATING
C2604 VDD.n757 VSS 0.02517f ; **FLOATING
C2605 VDD.n758 VSS 0.025f ; **FLOATING
C2606 VDD.n759 VSS 0.05024f ; **FLOATING
C2607 VDD.n760 VSS 0.05f ; **FLOATING
C2608 VDD.n761 VSS 0.02517f ; **FLOATING
C2609 VDD.n762 VSS 0.025f ; **FLOATING
C2610 VDD.n763 VSS 0.025f ; **FLOATING
C2611 VDD.n764 VSS 0.025f ; **FLOATING
C2612 VDD.n765 VSS 0.025f ; **FLOATING
C2613 VDD.n766 VSS 0.025f ; **FLOATING
C2614 VDD.n767 VSS 0.025f ; **FLOATING
C2615 VDD.n768 VSS 0.025f ; **FLOATING
C2616 VDD.n769 VSS 0.025f ; **FLOATING
C2617 VDD.n770 VSS 0.025f ; **FLOATING
C2618 VDD.n771 VSS 0.025f ; **FLOATING
C2619 VDD.n772 VSS 0.025f ; **FLOATING
C2620 VDD.n773 VSS 0.025f ; **FLOATING
C2621 VDD.n774 VSS 0.025f ; **FLOATING
C2622 VDD.n775 VSS 0.025f ; **FLOATING
C2623 VDD.n776 VSS 0.025f ; **FLOATING
C2624 VDD.n777 VSS 0.025f ; **FLOATING
C2625 VDD.n778 VSS 0.025f ; **FLOATING
C2626 VDD.n779 VSS 0.025f ; **FLOATING
C2627 VDD.n780 VSS 0.025f ; **FLOATING
C2628 VDD.n781 VSS 0.025f ; **FLOATING
C2629 VDD.n782 VSS 0.025f ; **FLOATING
C2630 VDD.n783 VSS 0.025f ; **FLOATING
C2631 VDD.n784 VSS 0.025f ; **FLOATING
C2632 VDD.n785 VSS 0.025f ; **FLOATING
C2633 VDD.n786 VSS 0.025f ; **FLOATING
C2634 VDD.n787 VSS 0.025f ; **FLOATING
C2635 VDD.n788 VSS 0.025f ; **FLOATING
C2636 VDD.n789 VSS 0.025f ; **FLOATING
C2637 VDD.n790 VSS 0.025f ; **FLOATING
C2638 VDD.n791 VSS 0.025f ; **FLOATING
C2639 VDD.n792 VSS 0.025f ; **FLOATING
C2640 VDD.n793 VSS 0.025f ; **FLOATING
C2641 VDD.n794 VSS 0.025f ; **FLOATING
C2642 VDD.n795 VSS 0.025f ; **FLOATING
C2643 VDD.n796 VSS 0.025f ; **FLOATING
C2644 VDD.n797 VSS 0.025f ; **FLOATING
C2645 VDD.n798 VSS 0.025f ; **FLOATING
C2646 VDD.n799 VSS 0.025f ; **FLOATING
C2647 VDD.n800 VSS 0.025f ; **FLOATING
C2648 VDD.n801 VSS 0.025f ; **FLOATING
C2649 VDD.n802 VSS 0.025f ; **FLOATING
C2650 VDD.n803 VSS 0.025f ; **FLOATING
C2651 VDD.n804 VSS 0.025f ; **FLOATING
C2652 VDD.n805 VSS 0.025f ; **FLOATING
C2653 VDD.n806 VSS 0.025f ; **FLOATING
C2654 VDD.n807 VSS 0.025f ; **FLOATING
C2655 VDD.n808 VSS 0.025f ; **FLOATING
C2656 VDD.n809 VSS 0.025f ; **FLOATING
C2657 VDD.t294 VSS 0.0432f ; **FLOATING
C2658 VDD.n810 VSS 0.025f ; **FLOATING
C2659 VDD.n811 VSS 0.025f ; **FLOATING
C2660 VDD.n812 VSS 0.025f ; **FLOATING
C2661 VDD.n813 VSS 0.025f ; **FLOATING
C2662 VDD.n814 VSS 0.025f ; **FLOATING
C2663 VDD.t313 VSS 0.0432f ; **FLOATING
C2664 VDD.n815 VSS 0.025f ; **FLOATING
C2665 VDD.n816 VSS 0.025f ; **FLOATING
C2666 VDD.n817 VSS 0.025f ; **FLOATING
C2667 VDD.n818 VSS 0.025f ; **FLOATING
C2668 VDD.n819 VSS 0.025f ; **FLOATING
C2669 VDD.t318 VSS 0.0432f ; **FLOATING
C2670 VDD.n820 VSS 0.025f ; **FLOATING
C2671 VDD.n821 VSS 0.025f ; **FLOATING
C2672 VDD.n822 VSS 0.025f ; **FLOATING
C2673 VDD.n823 VSS 0.025f ; **FLOATING
C2674 VDD.n824 VSS 0.025f ; **FLOATING
C2675 VDD.n825 VSS 0.025f ; **FLOATING
C2676 VDD.n826 VSS 0.025f ; **FLOATING
C2677 VDD.n827 VSS 0.025f ; **FLOATING
C2678 VDD.n828 VSS 0.025f ; **FLOATING
C2679 VDD.n829 VSS 0.025f ; **FLOATING
C2680 VDD.t319 VSS 0.0432f ; **FLOATING
C2681 VDD.n830 VSS 0.025f ; **FLOATING
C2682 VDD.n831 VSS 0.025f ; **FLOATING
C2683 VDD.n832 VSS 0.025f ; **FLOATING
C2684 VDD.n833 VSS 0.025f ; **FLOATING
C2685 VDD.n834 VSS 0.025f ; **FLOATING
C2686 VDD.n835 VSS 0.025f ; **FLOATING
C2687 VDD.t317 VSS 0.0432f ; **FLOATING
C2688 VDD.n836 VSS 0.05024f ; **FLOATING
C2689 VDD.n837 VSS 0.05f ; **FLOATING
C2690 VDD.n838 VSS 0.02517f ; **FLOATING
C2691 VDD.n839 VSS 0.025f ; **FLOATING
C2692 VDD.n840 VSS 0.05024f ; **FLOATING
C2693 VDD.n841 VSS 0.05f ; **FLOATING
C2694 VDD.n842 VSS 0.02517f ; **FLOATING
C2695 VDD.n843 VSS 0.025f ; **FLOATING
C2696 VDD.n844 VSS 0.05024f ; **FLOATING
C2697 VDD.n845 VSS 0.05032f ; **FLOATING
C2698 VDD.n846 VSS 0.025f ; **FLOATING
C2699 VDD.n847 VSS 0.01875f ; **FLOATING
C2700 VDD.n848 VSS 0.05f ; **FLOATING
C2701 VDD.n849 VSS 0.05f ; **FLOATING
C2702 VDD.n850 VSS 0.02517f ; **FLOATING
C2703 VDD.n851 VSS 0.025f ; **FLOATING
C2704 VDD.n852 VSS 0.05024f ; **FLOATING
C2705 VDD.n853 VSS 0.05f ; **FLOATING
C2706 VDD.n854 VSS 0.02517f ; **FLOATING
C2707 VDD.n855 VSS 0.025f ; **FLOATING
C2708 VDD.n856 VSS 0.05024f ; **FLOATING
C2709 VDD.n857 VSS 0.05032f ; **FLOATING
C2710 VDD.n858 VSS 0.025f ; **FLOATING
C2711 VDD.n859 VSS 0.01875f ; **FLOATING
C2712 VDD.n860 VSS 0.05f ; **FLOATING
C2713 VDD.n861 VSS 0.05f ; **FLOATING
C2714 VDD.n862 VSS 0.02517f ; **FLOATING
C2715 VDD.n863 VSS 0.025f ; **FLOATING
C2716 VDD.n864 VSS 0.025f ; **FLOATING
C2717 VDD.n865 VSS 0.025f ; **FLOATING
C2718 VDD.n866 VSS 0.025f ; **FLOATING
C2719 VDD.n867 VSS 0.025f ; **FLOATING
C2720 VDD.n868 VSS 0.025f ; **FLOATING
C2721 VDD.n869 VSS 0.025f ; **FLOATING
C2722 VDD.t293 VSS 0.0432f ; **FLOATING
C2723 VDD.t65 VSS 0.05066f ; **FLOATING
C2724 VDD.n870 VSS 0.025f ; **FLOATING
C2725 VDD.n871 VSS 0.025f ; **FLOATING
C2726 VDD.n872 VSS 0.025f ; **FLOATING
C2727 VDD.n873 VSS 0.025f ; **FLOATING
C2728 VDD.n874 VSS 0.025f ; **FLOATING
C2729 VDD.n875 VSS 0.025f ; **FLOATING
C2730 VDD.n876 VSS 0.025f ; **FLOATING
C2731 VDD.n877 VSS 0.025f ; **FLOATING
C2732 VDD.n878 VSS 0.025f ; **FLOATING
C2733 VDD.n879 VSS 0.025f ; **FLOATING
C2734 VDD.n880 VSS 0.025f ; **FLOATING
C2735 VDD.n881 VSS 0.025f ; **FLOATING
C2736 VDD.n882 VSS 0.025f ; **FLOATING
C2737 VDD.n883 VSS 0.025f ; **FLOATING
C2738 VDD.n884 VSS 0.025f ; **FLOATING
C2739 VDD.n885 VSS 0.025f ; **FLOATING
C2740 VDD.n886 VSS 0.025f ; **FLOATING
C2741 VDD.n887 VSS 0.025f ; **FLOATING
C2742 VDD.n888 VSS 0.025f ; **FLOATING
C2743 VDD.n889 VSS 0.025f ; **FLOATING
C2744 VDD.n890 VSS 0.025f ; **FLOATING
C2745 VDD.n891 VSS 0.025f ; **FLOATING
C2746 VDD.n892 VSS 0.025f ; **FLOATING
C2747 VDD.n893 VSS 0.025f ; **FLOATING
C2748 VDD.n894 VSS 0.025f ; **FLOATING
C2749 VDD.n895 VSS 0.025f ; **FLOATING
C2750 VDD.n896 VSS 0.025f ; **FLOATING
C2751 VDD.n897 VSS 0.025f ; **FLOATING
C2752 VDD.n898 VSS 0.025f ; **FLOATING
C2753 VDD.n899 VSS 0.025f ; **FLOATING
C2754 VDD.t304 VSS 0.0432f ; **FLOATING
C2755 VDD.n900 VSS 0.025f ; **FLOATING
C2756 VDD.n901 VSS 0.025f ; **FLOATING
C2757 VDD.n902 VSS 0.025f ; **FLOATING
C2758 VDD.n903 VSS 0.025f ; **FLOATING
C2759 VDD.n904 VSS 0.025f ; **FLOATING
C2760 VDD.n905 VSS 0.025f ; **FLOATING
C2761 VDD.n906 VSS 0.025f ; **FLOATING
C2762 VDD.n907 VSS 0.025f ; **FLOATING
C2763 VDD.n908 VSS 0.025f ; **FLOATING
C2764 VDD.n909 VSS 0.025f ; **FLOATING
C2765 VDD.n910 VSS 0.025f ; **FLOATING
C2766 VDD.n911 VSS 0.025f ; **FLOATING
C2767 VDD.n912 VSS 0.025f ; **FLOATING
C2768 VDD.n913 VSS 0.025f ; **FLOATING
C2769 VDD.n914 VSS 0.025f ; **FLOATING
C2770 VDD.n915 VSS 0.025f ; **FLOATING
C2771 VDD.t305 VSS 0.04418f ; **FLOATING
C2772 VDD.n916 VSS 0.025f ; **FLOATING
C2773 VDD.n917 VSS 0.025f ; **FLOATING
C2774 VDD.n918 VSS 0.025f ; **FLOATING
C2775 VDD.n919 VSS 0.025f ; **FLOATING
C2776 VDD.n920 VSS 0.025f ; **FLOATING
C2777 VDD.n921 VSS 0.025f ; **FLOATING
C2778 VDD.n922 VSS 0.025f ; **FLOATING
C2779 VDD.t302 VSS 0.0432f ; **FLOATING
C2780 VDD.n923 VSS 0.025f ; **FLOATING
C2781 VDD.n924 VSS 0.025f ; **FLOATING
C2782 VDD.n925 VSS 0.025f ; **FLOATING
C2783 VDD.n926 VSS 0.025f ; **FLOATING
C2784 VDD.n927 VSS 0.025f ; **FLOATING
C2785 VDD.n928 VSS 0.025f ; **FLOATING
C2786 VDD.n929 VSS 0.025f ; **FLOATING
C2787 VDD.t307 VSS 0.0432f ; **FLOATING
C2788 VDD.t114 VSS 0.05066f ; **FLOATING
C2789 VDD.n930 VSS 0.025f ; **FLOATING
C2790 VDD.n931 VSS 0.025f ; **FLOATING
C2791 VDD.n932 VSS 0.025f ; **FLOATING
C2792 VDD.n933 VSS 0.025f ; **FLOATING
C2793 VDD.n934 VSS 0.025f ; **FLOATING
C2794 VDD.n935 VSS 0.025f ; **FLOATING
C2795 VDD.n936 VSS 0.025f ; **FLOATING
C2796 VDD.n937 VSS 0.025f ; **FLOATING
C2797 VDD.n938 VSS 0.025f ; **FLOATING
C2798 VDD.n939 VSS 0.025f ; **FLOATING
C2799 VDD.n940 VSS 0.025f ; **FLOATING
C2800 VDD.n941 VSS 0.025f ; **FLOATING
C2801 VDD.n942 VSS 0.025f ; **FLOATING
C2802 VDD.n943 VSS 0.025f ; **FLOATING
C2803 VDD.n944 VSS 0.025f ; **FLOATING
C2804 VDD.n945 VSS 0.025f ; **FLOATING
C2805 VDD.t303 VSS 0.0432f ; **FLOATING
C2806 VDD.n946 VSS 0.025f ; **FLOATING
C2807 VDD.n947 VSS 0.025f ; **FLOATING
C2808 VDD.n948 VSS 0.025f ; **FLOATING
C2809 VDD.n949 VSS 0.025f ; **FLOATING
C2810 VDD.n950 VSS 0.025f ; **FLOATING
C2811 VDD.n951 VSS 0.025f ; **FLOATING
C2812 VDD.n952 VSS 0.025f ; **FLOATING
C2813 VDD.t306 VSS 0.0432f ; **FLOATING
C2814 VDD.n953 VSS 0.025f ; **FLOATING
C2815 VDD.n954 VSS 0.025f ; **FLOATING
C2816 VDD.n955 VSS 0.025f ; **FLOATING
C2817 VDD.n956 VSS 0.01875f ; **FLOATING
C2818 VDD.n957 VSS 0.05f ; **FLOATING
C2819 VDD.n958 VSS 0.025f ; **FLOATING
C2820 VDD.n959 VSS 0.025f ; **FLOATING
C2821 VDD.t296 VSS 0.0432f ; **FLOATING
C2822 VDD.n960 VSS 0.025f ; **FLOATING
C2823 VDD.n961 VSS 0.02517f ; **FLOATING
C2824 VDD.n962 VSS 0.05f ; **FLOATING
C2825 VDD.n963 VSS 0.05f ; **FLOATING
C2826 VDD.n964 VSS 0.01875f ; **FLOATING
C2827 VDD.n965 VSS 0.025f ; **FLOATING
C2828 VDD.n966 VSS 0.05032f ; **FLOATING
C2829 VDD.n967 VSS 0.01875f ; **FLOATING
C2830 VDD.n968 VSS 0.05f ; **FLOATING
C2831 VDD.n969 VSS 0.025f ; **FLOATING
C2832 VDD.n970 VSS 0.05032f ; **FLOATING
C2833 VDD.n971 VSS 0.025f ; **FLOATING
C2834 VDD.n972 VSS 0.025f ; **FLOATING
C2835 VDD.n973 VSS 0.025f ; **FLOATING
C2836 VDD.n974 VSS 0.025f ; **FLOATING
C2837 VDD.n975 VSS 0.025f ; **FLOATING
C2838 VDD.n976 VSS 0.025f ; **FLOATING
C2839 VDD.n977 VSS 0.025f ; **FLOATING
C2840 VDD.t300 VSS 0.0432f ; **FLOATING
C2841 VDD.n978 VSS 0.025f ; **FLOATING
C2842 VDD.n979 VSS 0.025f ; **FLOATING
C2843 VDD.n980 VSS 0.025f ; **FLOATING
C2844 VDD.n981 VSS 0.025f ; **FLOATING
C2845 VDD.n982 VSS 0.025f ; **FLOATING
C2846 VDD.n983 VSS 0.025f ; **FLOATING
C2847 VDD.n984 VSS 0.025f ; **FLOATING
C2848 VDD.n985 VSS 0.025f ; **FLOATING
C2849 VDD.n986 VSS 0.025f ; **FLOATING
C2850 VDD.n987 VSS 0.025f ; **FLOATING
C2851 VDD.n988 VSS 0.025f ; **FLOATING
C2852 VDD.n989 VSS 0.025f ; **FLOATING
C2853 VDD.n990 VSS 0.025f ; **FLOATING
C2854 VDD.n991 VSS 0.025f ; **FLOATING
C2855 VDD.n992 VSS 0.025f ; **FLOATING
C2856 VDD.n993 VSS 0.025f ; **FLOATING
C2857 VDD.n994 VSS 0.025f ; **FLOATING
C2858 VDD.n995 VSS 0.025f ; **FLOATING
C2859 VDD.n996 VSS 0.025f ; **FLOATING
C2860 VDD.n997 VSS 0.025f ; **FLOATING
C2861 VDD.n998 VSS 0.025f ; **FLOATING
C2862 VDD.n999 VSS 0.025f ; **FLOATING
C2863 VDD.n1000 VSS 0.025f ; **FLOATING
C2864 VDD.n1001 VSS 0.025f ; **FLOATING
C2865 VDD.n1002 VSS 0.025f ; **FLOATING
C2866 VDD.n1003 VSS 0.025f ; **FLOATING
C2867 VDD.n1004 VSS 0.025f ; **FLOATING
C2868 VDD.n1005 VSS 0.025f ; **FLOATING
C2869 VDD.n1006 VSS 0.025f ; **FLOATING
C2870 VDD.n1007 VSS 0.025f ; **FLOATING
C2871 VDD.t291 VSS 0.0432f ; **FLOATING
C2872 VDD.n1008 VSS 0.025f ; **FLOATING
C2873 VDD.n1009 VSS 0.025f ; **FLOATING
C2874 VDD.n1010 VSS 0.025f ; **FLOATING
C2875 VDD.n1011 VSS 0.025f ; **FLOATING
C2876 VDD.n1012 VSS 0.025f ; **FLOATING
C2877 VDD.n1013 VSS 0.025f ; **FLOATING
C2878 VDD.n1014 VSS 0.025f ; **FLOATING
C2879 VDD.n1015 VSS 0.025f ; **FLOATING
C2880 VDD.n1016 VSS 0.025f ; **FLOATING
C2881 VDD.n1017 VSS 0.025f ; **FLOATING
C2882 VDD.n1018 VSS 0.025f ; **FLOATING
C2883 VDD.n1019 VSS 0.025f ; **FLOATING
C2884 VDD.n1020 VSS 0.025f ; **FLOATING
C2885 VDD.n1021 VSS 0.025f ; **FLOATING
C2886 VDD.n1022 VSS 0.025f ; **FLOATING
C2887 VDD.n1023 VSS 0.025f ; **FLOATING
C2888 VDD.n1024 VSS 0.025f ; **FLOATING
C2889 VDD.n1025 VSS 0.41219f ; **FLOATING
C2890 VDD.n1026 VSS 0.025f ; **FLOATING
C2891 VDD.n1027 VSS 0.025f ; **FLOATING
C2892 VDD.t297 VSS 0.04431f ; **FLOATING
C2893 VDD.t284 VSS 0.04372f ; **FLOATING
C2894 VDD.t282 VSS 0.0254f ; **FLOATING
C2895 VDD.t280 VSS 0.04881f ; **FLOATING
C2896 VDD.t281 VSS 0.0437f ; **FLOATING
C2897 VDD.t279 VSS 0.03118f ; **FLOATING
C2898 VDD.n1028 VSS 0.025f ; **FLOATING
C2899 VDD.n1029 VSS 0.05032f ; **FLOATING
C2900 VDD.n1030 VSS 0.05024f ; **FLOATING
C2901 VDD.n1031 VSS 0.01875f ; **FLOATING
C2902 VDD.n1032 VSS 0.025f ; **FLOATING
C2903 VDD.n1033 VSS 0.025f ; **FLOATING
C2904 VDD.n1034 VSS 0.02517f ; **FLOATING
C2905 VDD.n1035 VSS 0.05024f ; **FLOATING
C2906 VDD.n1036 VSS 0.025f ; **FLOATING
C2907 VDD.n1037 VSS 0.05f ; **FLOATING
C2908 VDD.n1038 VSS 0.02517f ; **FLOATING
C2909 VDD.n1039 VSS 0.05024f ; **FLOATING
C2910 VDD.n1040 VSS 0.025f ; **FLOATING
C2911 VDD.n1041 VSS 0.05f ; **FLOATING
C2912 VDD.n1042 VSS 0.02517f ; **FLOATING
C2913 VDD.n1043 VSS 0.025f ; **FLOATING
C2914 VDD.n1044 VSS 0.05032f ; **FLOATING
C2915 VDD.n1045 VSS 0.05024f ; **FLOATING
C2916 VDD.n1046 VSS 0.01875f ; **FLOATING
C2917 VDD.n1047 VSS 0.05f ; **FLOATING
C2918 VDD.n1048 VSS 0.025f ; **FLOATING
C2919 VDD.n1049 VSS 0.05032f ; **FLOATING
C2920 VDD.n1050 VSS 0.01875f ; **FLOATING
C2921 VDD.n1051 VSS 0.05f ; **FLOATING
C2922 VDD.n1052 VSS 0.025f ; **FLOATING
C2923 VDD.n1053 VSS 0.05032f ; **FLOATING
C2924 VDD.n1054 VSS 0.025f ; **FLOATING
C2925 VDD.n1055 VSS 0.01875f ; **FLOATING
C2926 VDD.n1056 VSS 0.05f ; **FLOATING
C2927 VDD.n1057 VSS 0.025f ; **FLOATING
C2928 VDD.n1058 VSS 0.05032f ; **FLOATING
C2929 VDD.n1059 VSS 0.025f ; **FLOATING
C2930 VDD.n1060 VSS 0.02517f ; **FLOATING
C2931 VDD.n1061 VSS 0.05f ; **FLOATING
C2932 VDD.n1062 VSS 0.05024f ; **FLOATING
C2933 VDD.n1063 VSS 0.025f ; **FLOATING
C2934 VDD.n1064 VSS 0.02517f ; **FLOATING
C2935 VDD.n1065 VSS 0.05f ; **FLOATING
C2936 VDD.n1066 VSS 0.05024f ; **FLOATING
C2937 VDD.n1067 VSS 0.025f ; **FLOATING
C2938 VDD.n1068 VSS 0.02517f ; **FLOATING
C2939 VDD.n1069 VSS 1.71273f ; **FLOATING
C2940 VDD.n1070 VSS 3.1307f ; **FLOATING
C2941 VDD.n1071 VSS 0.81358f ; **FLOATING
C2942 VDD.n1072 VSS 0.02319f ; **FLOATING
C2943 VDD.n1073 VSS 0.02714f ; **FLOATING
C2944 VDD.n1074 VSS 0.09476f ; **FLOATING
C2945 VDD.n1075 VSS 0.03968f ; **FLOATING
C2946 VDD.n1076 VSS 0.0648f ; **FLOATING
C2947 VDD.n1077 VSS 0.025f ; **FLOATING
C2948 VDD.n1078 VSS 0.025f ; **FLOATING
C2949 VDD.n1079 VSS 0.025f ; **FLOATING
C2950 VDD.n1080 VSS 0.05594f ; **FLOATING
C2951 VDD.t14 VSS 0.08621f ; **FLOATING
C2952 VDD.n1081 VSS 0.05593f ; **FLOATING
C2953 VDD.t22 VSS 0.08621f ; **FLOATING
C2954 VDD.t268 VSS 0.07865f ; **FLOATING
C2955 VDD.t263 VSS 0.07714f ; **FLOATING
C2956 VDD.t261 VSS 0.48778f ; **FLOATING
C2957 DELAY_VBIASP.t1 VSS 0.8162f ; **FLOATING
C2958 DELAY_VBIASP.t2 VSS 0.54234f ; **FLOATING
C2959 DELAY_VBIASP.t0 VSS 6.91837f ; **FLOATING
C2960 DELAY_VBIASP.t34 VSS 0.49136f ; **FLOATING
C2961 DELAY_VBIASP.t33 VSS 0.48037f ; **FLOATING
C2962 DELAY_VBIASP.n0 VSS 0.86084f ; **FLOATING
C2963 DELAY_VBIASP.t32 VSS 0.48037f ; **FLOATING
C2964 DELAY_VBIASP.n1 VSS 0.59572f ; **FLOATING
C2965 DELAY_VBIASP.t31 VSS 0.48037f ; **FLOATING
C2966 DELAY_VBIASP.n2 VSS 0.59572f ; **FLOATING
C2967 DELAY_VBIASP.t30 VSS 0.48037f ; **FLOATING
C2968 DELAY_VBIASP.n3 VSS 0.59572f ; **FLOATING
C2969 DELAY_VBIASP.t29 VSS 0.48037f ; **FLOATING
C2970 DELAY_VBIASP.n4 VSS 0.59572f ; **FLOATING
C2971 DELAY_VBIASP.t28 VSS 0.48037f ; **FLOATING
C2972 DELAY_VBIASP.n5 VSS 0.59572f ; **FLOATING
C2973 DELAY_VBIASP.t27 VSS 0.48037f ; **FLOATING
C2974 DELAY_VBIASP.n6 VSS 0.59572f ; **FLOATING
C2975 DELAY_VBIASP.t26 VSS 0.48037f ; **FLOATING
C2976 DELAY_VBIASP.n7 VSS 0.59572f ; **FLOATING
C2977 DELAY_VBIASP.t25 VSS 0.48037f ; **FLOATING
C2978 DELAY_VBIASP.n8 VSS 0.59572f ; **FLOATING
C2979 DELAY_VBIASP.t24 VSS 0.48037f ; **FLOATING
C2980 DELAY_VBIASP.n9 VSS 0.59572f ; **FLOATING
C2981 DELAY_VBIASP.t23 VSS 0.48037f ; **FLOATING
C2982 DELAY_VBIASP.n10 VSS 0.59572f ; **FLOATING
C2983 DELAY_VBIASP.t22 VSS 0.48037f ; **FLOATING
C2984 DELAY_VBIASP.n11 VSS 0.59572f ; **FLOATING
C2985 DELAY_VBIASP.t21 VSS 0.48037f ; **FLOATING
C2986 DELAY_VBIASP.n12 VSS 0.59572f ; **FLOATING
C2987 DELAY_VBIASP.t20 VSS 0.48037f ; **FLOATING
C2988 DELAY_VBIASP.n13 VSS 0.59572f ; **FLOATING
C2989 DELAY_VBIASP.t19 VSS 0.48037f ; **FLOATING
C2990 DELAY_VBIASP.n14 VSS 0.59572f ; **FLOATING
C2991 DELAY_VBIASP.t18 VSS 0.48037f ; **FLOATING
C2992 DELAY_VBIASP.n15 VSS 0.59572f ; **FLOATING
C2993 DELAY_VBIASP.t17 VSS 0.48037f ; **FLOATING
C2994 DELAY_VBIASP.n16 VSS 0.59572f ; **FLOATING
C2995 DELAY_VBIASP.t16 VSS 0.48037f ; **FLOATING
C2996 DELAY_VBIASP.n17 VSS 0.59572f ; **FLOATING
C2997 DELAY_VBIASP.t15 VSS 0.48037f ; **FLOATING
C2998 DELAY_VBIASP.n18 VSS 0.59572f ; **FLOATING
C2999 DELAY_VBIASP.t14 VSS 0.48037f ; **FLOATING
C3000 DELAY_VBIASP.n19 VSS 0.59572f ; **FLOATING
C3001 DELAY_VBIASP.t13 VSS 1.07609f ; **FLOATING
C3002 DELAY_VBIASP.t12 VSS 1.07609f ; **FLOATING
C3003 DELAY_VBIASP.t11 VSS 1.07609f ; **FLOATING
C3004 DELAY_VBIASP.t10 VSS 1.07609f ; **FLOATING
C3005 DELAY_VBIASP.t9 VSS 1.07609f ; **FLOATING
C3006 DELAY_VBIASP.t8 VSS 1.07609f ; **FLOATING
C3007 DELAY_VBIASP.t7 VSS 1.07609f ; **FLOATING
C3008 DELAY_VBIASP.t6 VSS 1.07609f ; **FLOATING
C3009 DELAY_VBIASP.t5 VSS 1.07609f ; **FLOATING
C3010 DELAY_VBIASP.t4 VSS 1.07609f ; **FLOATING
C3011 DELAY_VBIASP.t3 VSS 1.30925f ; **FLOATING
C3012 DELAY_VBIASP.n20 VSS 9.37766f ; **FLOATING
.ends
