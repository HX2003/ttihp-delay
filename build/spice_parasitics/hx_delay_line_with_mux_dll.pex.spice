* NGSPICE file created from hx_delay_line_with_mux_dll.ext - technology: ihp-sg13g2

.subckt hx_delay_line_with_mux_dll VDD DELAY_OUT_LAST VSS DELAY_VBIASN DELAY_VBIASP
+ REF_CLK DLL_RESETN MUX_SEL0 MUX_SEL1 MUX_OUT MUX_SEL4 MUX_SEL2 MUX_SEL3
X0 a_14009_5878# REF_CLK VSS.t428 VSS.t427 sg13_lv_nmos ad=0.2516p pd=2.16u as=1.9998p ps=12.915u w=0.74u l=0.13u
X1 VDD.t28 a_4003_1842# a_4437_1842# VDD.t10 sg13_lv_pmos ad=0.2128p pd=1.5u as=0.3808p ps=2.92u w=1.12u l=0.13u
X2 VSS.t163 DLL_RESETN a_10040_6305# VSS.t162 sg13_lv_nmos ad=0.1626p pd=1.415u as=60.89999f ps=0.71u w=0.42u l=0.13u
X3 VSS.t240 a_15077_1842# a_15545_1044# VSS.t417 sg13_lv_nmos ad=0.1665p pd=1.19u as=0.2516p ps=2.16u w=0.74u l=0.13u
X4 a_27915_1044# a_27705_1044# VDD.t8 VDD.t4 sg13_lv_pmos ad=0.2128p pd=1.5u as=0.252p ps=1.57u w=1.12u l=0.13u
X5 VSS.t72 VDD.t399 VSS.t70 VSS.t71 sg13_lv_nmos ad=79.8f pd=0.8u as=0 ps=0 w=0.42u l=1u
X6 a_10951_2470# a_10713_1842# a_10843_1842# VDD.t10 sg13_lv_pmos ad=0.2128p pd=1.5u as=0.3808p ps=2.92u w=1.12u l=0.2u
X7 VSS.t212 a_3171_1047.t7 a_11924_1008# VSS.t211 sg13_lv_nmos ad=0.2516p pd=2.16u as=0.2516p ps=2.16u w=0.74u l=0.13u
X8 VDD.t249 VSS.t129 VDD.t248 VDD.t4 sg13_lv_pmos ad=0.34p pd=2.68u as=0 ps=0 w=1u l=1u
X9 VSS.t174 a_1256_1044# a_2967_1395# VSS.t173 sg13_lv_nmos ad=0.1331p pd=1.12u as=0.1216p ps=1.02u w=0.64u l=0.13u
X10 VSS.t75 VDD.t398 VSS.t74 VSS.t73 sg13_lv_nmos ad=0.1428p pd=1.52u as=0 ps=0 w=0.42u l=1u
X11 a_25153_1842# a_24957_1842# VSS.t286 VSS.t285 sg13_lv_nmos ad=0.2516p pd=2.16u as=0.1406p ps=1.12u w=0.74u l=0.13u
X12 VDD.t166 VSS.t94 VDD.t165 VDD.t4 sg13_lv_pmos ad=0.34p pd=2.68u as=0 ps=0 w=1u l=1u
X13 a_15108_6109# a_14851_6228# a_15270_6305# VSS.t1 sg13_lv_nmos ad=0.1428p pd=1.52u as=37.8f ps=0.6u w=0.42u l=0.13u
X14 VSS.t3 a_14851_6228# a_15688_5867# VSS.t2 sg13_lv_nmos ad=0.1406p pd=1.12u as=0.2516p ps=2.16u w=0.74u l=0.13u
X15 VSS.t491 VSS.t489 VSS.t489 VSS.t490 sg13_lv_nmos ad=0.68p pd=4.68u as=0 ps=0 w=2u l=1u
X16 a_15108_5325# a_12849_5867# VDD.t36 VDD.t0 sg13_lv_pmos ad=79.8f pd=0.8u as=1.03698p ps=6.245u w=0.42u l=0.13u
X17 a_25630_1044# a_2019_1047.t2 a_25528_1044# VSS.t248 sg13_lv_nmos ad=0.2516p pd=2.16u as=0.1406p ps=1.12u w=0.74u l=0.13u
X18 VDD.t297 DELAY_VBIASP.t14 a_19311_2470# VDD.t10 sg13_lv_pmos ad=0.3808p pd=2.92u as=0.2128p ps=1.5u w=1.12u l=0.6u
X19 a_16108_289# a_2019_311.t2 a_16510_1044# VSS.t524 sg13_lv_nmos ad=0.2516p pd=2.16u as=0.2516p ps=2.16u w=0.74u l=0.13u
X20 VDD.t304 DELAY_VBIASP.t27 a_9431_2470# VDD.t10 sg13_lv_pmos ad=0.3808p pd=2.92u as=0.2128p ps=1.5u w=1.12u l=0.6u
X21 VSS.t140 VDD.t385 VSS.t139 VSS.t138 sg13_lv_nmos ad=0.1428p pd=1.52u as=0 ps=0 w=0.42u l=1u
X22 VSS.t486 VSS.t486 VSS.t488 VSS.t487 sg13_lv_nmos ad=0.68p pd=4.68u as=0 ps=0 w=2u l=1u
X23 VDD.t315 DELAY_VBIASP.t9 a_23111_2470# VDD.t10 sg13_lv_pmos ad=0.3808p pd=2.92u as=0.2128p ps=1.5u w=1.12u l=0.6u
X24 a_7390_1044# a_8231_1008# a_8155_1044# VDD.t4 sg13_lv_pmos ad=0.3808p pd=2.92u as=0.2128p ps=1.5u w=1.12u l=0.13u
X25 a_14009_5878# REF_CLK VDD.t36 VDD.t0 sg13_lv_pmos ad=0.4088p pd=2.97u as=1.03698p ps=6.245u w=1.12u l=0.13u
X26 VSS.t50 a_2595_311.t3 a_8745_519# VSS.t49 sg13_lv_nmos ad=0.2516p pd=2.16u as=0.2516p ps=2.16u w=0.74u l=0.13u
X27 a_11748_6109# DLL_RESETN VDD.t36 VDD.t0 sg13_lv_pmos ad=79.8f pd=0.8u as=1.10612p ps=6.66u w=0.42u l=0.13u
X28 VDD.t214 a_11491_6228# a_12158_5867# VDD.t0 sg13_lv_pmos ad=0.2128p pd=1.5u as=0.3864p ps=2.93u w=1.12u l=0.13u
X29 VDD.t300 DELAY_VBIASP.t0 DELAY_VBIASP.t1 VDD.t55 sg13_lv_pmos ad=0.3808p pd=2.92u as=1.0304p ps=4.08u w=1.12u l=0.6u
X30 a_17791_1842# a_17553_1842# a_17683_1842# VSS.t310 sg13_lv_nmos ad=0.1406p pd=1.12u as=0.2516p ps=2.16u w=0.74u l=0.2u
X31 VSS.t159 a_11748_6109# a_11397_6228# VSS.t158 sg13_lv_nmos ad=79.8f pd=0.8u as=0.1428p ps=1.52u w=0.42u l=0.13u
X32 VDD.t41 a_12037_1842# a_12505_1044# VDD.t4 sg13_lv_pmos ad=0.252p pd=1.57u as=0.3808p ps=2.92u w=1.12u l=0.13u
X33 a_16510_1044# a_2019_1047.t5 a_16408_1044# VSS.t710 sg13_lv_nmos ad=0.2516p pd=2.16u as=0.1406p ps=1.12u w=0.74u l=0.13u
X34 a_21591_1842# a_21353_1842# a_21483_1842# VSS.t633 sg13_lv_nmos ad=0.1406p pd=1.12u as=0.2516p ps=2.16u w=0.74u l=0.2u
X35 a_6153_1842# a_5957_1842# VSS.t253 VSS.t670 sg13_lv_nmos ad=0.2516p pd=2.16u as=0.1406p ps=1.12u w=0.74u l=0.13u
X36 VSS.t385 a_16163_1842# a_16597_1842# VSS.t384 sg13_lv_nmos ad=0.1406p pd=1.12u as=0.2516p ps=2.16u w=0.74u l=0.13u
X37 VSS.t316 a_3171_1047.t2 a_27124_1008# VSS.t315 sg13_lv_nmos ad=0.2516p pd=2.16u as=0.2516p ps=2.16u w=0.74u l=0.13u
X38 VDD.t40 a_11603_1842# a_12037_1842# VDD.t10 sg13_lv_pmos ad=0.2128p pd=1.5u as=0.3808p ps=2.92u w=1.12u l=0.13u
X39 VDD.t93 a_3171_311.t3 a_11785_519# VDD.t4 sg13_lv_pmos ad=0.3808p pd=2.92u as=0.3808p ps=2.92u w=1.12u l=0.13u
X40 a_6126_3816# a_6326_4590# VDD.t185 VDD.t0 sg13_lv_pmos ad=0.38p pd=2.38u as=0.38p ps=2.38u w=2u l=1u
X41 a_24393_1842# a_24197_1842# VDD.t11 VDD.t10 sg13_lv_pmos ad=0.3808p pd=2.92u as=0.2128p ps=1.5u w=1.12u l=0.13u
X42 a_5731_289# a_2595_311.t3 a_7390_1044# VSS.t48 sg13_lv_nmos ad=0.2516p pd=2.16u as=0.2516p ps=2.16u w=0.74u l=0.13u
X43 a_10430_1044# a_2595_1047.t7 a_11195_1044# VSS.t194 sg13_lv_nmos ad=0.2516p pd=2.16u as=0.1406p ps=1.12u w=0.74u l=0.13u
X44 a_13306_6305# a_12355_5867# VDD.t360 VDD.t0 sg13_lv_pmos ad=79.8f pd=0.8u as=0.1428p ps=1.52u w=0.42u l=0.13u
X45 a_23355_1044# a_23145_1044# VSS.t247 VSS.t246 sg13_lv_nmos ad=0.1406p pd=1.12u as=0.1665p ps=1.19u w=0.74u l=0.13u
X46 VDD.t309 DELAY_VBIASP.t20 a_14751_2470# VDD.t10 sg13_lv_pmos ad=0.3808p pd=2.92u as=0.2128p ps=1.5u w=1.12u l=0.6u
X47 VSS.t612 DELAY_VBIASN a_10191_1842# VSS.t611 sg13_lv_nmos ad=0.2516p pd=2.16u as=0.1406p ps=1.12u w=0.74u l=0.6u
X48 VSS.t679 a_3747_1047.t4 a_21911_1008# VSS.t678 sg13_lv_nmos ad=0.2516p pd=2.16u as=0.2516p ps=2.16u w=0.74u l=0.13u
X49 VSS.t242 a_19963_1842# a_20397_1842# VSS.t468 sg13_lv_nmos ad=0.1406p pd=1.12u as=0.2516p ps=2.16u w=0.74u l=0.13u
X50 a_6126_3816# a_6326_4590# VDD.t190 VDD.t0 sg13_lv_pmos ad=0.38p pd=2.38u as=0.38p ps=2.38u w=2u l=1u
X51 VDD.t46 a_6326_4590# a_6854_5454# VDD.t0 sg13_lv_pmos ad=0.38p pd=2.38u as=0.38p ps=2.38u w=2u l=1u
X52 VDD.t301 DELAY_VBIASP.t34 a_4111_2470# VDD.t10 sg13_lv_pmos ad=0.3808p pd=2.92u as=0.2128p ps=1.5u w=1.12u l=0.6u
X53 a_10328_1044# a_9757_1842# VDD.t148 VDD.t4 sg13_lv_pmos ad=0.2128p pd=1.5u as=0.3808p ps=2.92u w=1.12u l=0.13u
X54 a_20968_1044# a_20397_1842# VSS.t244 VSS.t243 sg13_lv_nmos ad=0.1406p pd=1.12u as=0.2516p ps=2.16u w=0.74u l=0.13u
X55 a_22590_1044# a_22564_1008# a_22488_1044# VDD.t4 sg13_lv_pmos ad=0.3808p pd=2.92u as=0.2128p ps=1.5u w=1.12u l=0.13u
X56 VDD.t14 VSS.t87 VDD.t178 VDD.t4 sg13_lv_pmos ad=0.19p pd=1.38u as=0 ps=0 w=1u l=1u
X57 a_8808_1044# a_8237_1842# VDD.t341 VDD.t4 sg13_lv_pmos ad=0.2128p pd=1.5u as=0.3808p ps=2.92u w=1.12u l=0.13u
X58 VDD.t194 a_6326_4590# a_6326_4590# VDD.t0 sg13_lv_pmos ad=0.38p pd=2.38u as=0.38p ps=2.38u w=2u l=1u
X59 a_4157_1313# REF_CLK VDD.t261 VDD.t4 sg13_lv_pmos ad=0.3808p pd=2.92u as=0.3808p ps=2.92u w=1.12u l=0.13u
X60 a_17031_2470# a_16793_1842# a_16923_1842# VDD.t10 sg13_lv_pmos ad=0.2128p pd=1.5u as=0.3808p ps=2.92u w=1.12u l=0.2u
X61 a_11473_1842# a_11277_1842# VSS.t397 VSS.t396 sg13_lv_nmos ad=0.2516p pd=2.16u as=0.1406p ps=1.12u w=0.74u l=0.13u
X62 VSS.t132 VDD.t387 VSS.t130 VSS.t131 sg13_lv_nmos ad=79.8f pd=0.8u as=0 ps=0 w=0.42u l=1u
X63 a_13306_5105# a_13132_5420# VDD.t9 VDD.t0 sg13_lv_pmos ad=79.8f pd=0.8u as=0.1428p ps=1.52u w=0.42u l=0.13u
X64 a_19448_1044# a_18877_1842# VSS.t347 VSS.t346 sg13_lv_nmos ad=0.1406p pd=1.12u as=0.2516p ps=2.16u w=0.74u l=0.13u
X65 a_10430_1044# a_3171_1047.t7 a_11848_1044# VSS.t210 sg13_lv_nmos ad=0.2516p pd=2.16u as=0.1406p ps=1.12u w=0.74u l=0.13u
X66 a_20831_2470# a_20593_1842# a_20723_1842# VDD.t10 sg13_lv_pmos ad=0.2128p pd=1.5u as=0.3808p ps=2.92u w=1.12u l=0.2u
X67 VSS.t97 VDD.t394 VSS.t95 VSS.t96 sg13_lv_nmos ad=79.8f pd=0.8u as=0 ps=0 w=0.42u l=1u
X68 VDD.t8 a_27237_1842# a_27705_1044# VDD.t4 sg13_lv_pmos ad=0.252p pd=1.57u as=0.3808p ps=2.92u w=1.12u l=0.13u
X69 a_5393_1842# a_5197_1842# VDD.t211 VDD.t10 sg13_lv_pmos ad=0.3808p pd=2.92u as=0.2128p ps=1.5u w=1.12u l=0.13u
X70 VDD.t308 DELAY_VBIASP.t17 a_17031_2470# VDD.t10 sg13_lv_pmos ad=0.3808p pd=2.92u as=0.2128p ps=1.5u w=1.12u l=0.6u
X71 VDD.t36 a_15108_6109# a_15053_5990# VDD.t0 sg13_lv_pmos ad=1.10612p pd=6.66u as=93.45f ps=0.865u w=0.42u l=0.13u
X72 VDD.t190 a_6326_4590# a_6854_5454# VDD.t0 sg13_lv_pmos ad=0.38p pd=2.38u as=0.38p ps=2.38u w=2u l=1u
X73 a_13818_6292# a_12849_5867# VSS.t404 VSS.t403 sg13_lv_nmos ad=37.8f pd=0.6u as=0.1701p ps=1.65u w=0.42u l=0.13u
X74 VDD.t336 a_26803_1842# a_27237_1842# VDD.t10 sg13_lv_pmos ad=0.2128p pd=1.5u as=0.3808p ps=2.92u w=1.12u l=0.13u
X75 VDD.t82 MUX_SEL1 a_3449_1395# VDD.t4 sg13_lv_pmos ad=0.1918p pd=1.5u as=0.1596p ps=1.22u w=0.84u l=0.13u
X76 a_14851_6228# a_14009_5878# a_13592_5871# VDD.t0 sg13_lv_pmos ad=0.2048p pd=1.63u as=0.34p ps=2.68u w=1u l=0.13u
X77 a_25630_1044# a_2595_1047.t2 a_26395_1044# VSS.t233 sg13_lv_nmos ad=0.2516p pd=2.16u as=0.1406p ps=1.12u w=0.74u l=0.13u
X78 VSS.t561 DELAY_VBIASN a_25391_1842# VSS.t560 sg13_lv_nmos ad=0.2516p pd=2.16u as=0.1406p ps=1.12u w=0.74u l=0.6u
X79 VSS.t598 DELAY_VBIASN VSS.t596 VSS.t581 sg13_lv_nmos ad=1.33p pd=7.38u as=0 ps=0 w=7u l=7u
X80 a_6635_1044# a_6425_1044# VDD.t149 VDD.t4 sg13_lv_pmos ad=0.2128p pd=1.5u as=0.252p ps=1.57u w=1.12u l=0.13u
X81 VDD.t77 DLL_RESETN a_9946_6305# VDD.t0 sg13_lv_pmos ad=0.36237p pd=2.605u as=79.8f ps=0.8u w=0.42u l=0.13u
X82 a_20315_1044# a_20105_1044# VDD.t370 VDD.t4 sg13_lv_pmos ad=0.2128p pd=1.5u as=0.252p ps=1.57u w=1.12u l=0.13u
X83 VDD.t339 a_2595_1047.t9 a_5191_1008# VDD.t4 sg13_lv_pmos ad=0.3808p pd=2.92u as=0.3808p ps=2.92u w=1.12u l=0.13u
X84 a_19311_2470# a_19073_1842# a_19203_1842# VDD.t10 sg13_lv_pmos ad=0.2128p pd=1.5u as=0.3808p ps=2.92u w=1.12u l=0.2u
X85 VSS.t466 a_1721_1395# a_2019_1047.t1 VSS.t465 sg13_lv_nmos ad=0.2812p pd=2.24u as=0.1406p ps=1.12u w=0.74u l=0.13u
X86 a_25528_1044# a_24957_1842# VDD.t142 VDD.t4 sg13_lv_pmos ad=0.2128p pd=1.5u as=0.3808p ps=2.92u w=1.12u l=0.13u
X87 VSS.t298 a_5957_1842# a_6425_1044# VSS.t669 sg13_lv_nmos ad=0.1665p pd=1.19u as=0.2516p ps=2.16u w=0.74u l=0.13u
X88 VSS.t664 a_2019_1047.t6 a_13444_1008# VSS.t663 sg13_lv_nmos ad=0.2516p pd=2.16u as=0.2516p ps=2.16u w=0.74u l=0.13u
X89 a_23111_2470# a_22873_1842# a_23003_1842# VDD.t10 sg13_lv_pmos ad=0.2128p pd=1.5u as=0.3808p ps=2.92u w=1.12u l=0.2u
X90 VSS.t70 VDD.t399 VSS.t69 VSS.t68 sg13_lv_nmos ad=0.1428p pd=1.52u as=0 ps=0 w=0.42u l=1u
X91 VSS.t169 a_15964_289# a_16851_309# VSS.t267 sg13_lv_nmos ad=0.1371p pd=1.12u as=0.2176p ps=1.96u w=0.64u l=0.13u
X92 a_10713_1842# a_10517_1842# VDD.t109 VDD.t10 sg13_lv_pmos ad=0.3808p pd=2.92u as=0.2128p ps=1.5u w=1.12u l=0.13u
X93 VDD.t114 a_17683_1842# a_18117_1842# VDD.t10 sg13_lv_pmos ad=0.2128p pd=1.5u as=0.3808p ps=2.92u w=1.12u l=0.13u
X94 a_16108_289# a_17865_519# a_16510_1044# VDD.t4 sg13_lv_pmos ad=0.3808p pd=2.92u as=0.3808p ps=2.92u w=1.12u l=0.13u
X95 a_26673_1842# a_26477_1842# VSS.t388 VSS.t458 sg13_lv_nmos ad=0.2516p pd=2.16u as=0.1406p ps=1.12u w=0.74u l=0.13u
X96 VDD.t231 a_7803_1842# a_8237_1842# VDD.t10 sg13_lv_pmos ad=0.2128p pd=1.5u as=0.3808p ps=2.92u w=1.12u l=0.13u
X97 a_4248_1044# a_4157_1313# VSS.t33 VSS.t32 sg13_lv_nmos ad=0.1406p pd=1.12u as=0.2516p ps=2.16u w=0.74u l=0.13u
X98 a_16108_289# a_3171_311.t2 a_22590_1044# VSS.t636 sg13_lv_nmos ad=0.2516p pd=2.16u as=0.2516p ps=2.16u w=0.74u l=0.13u
X99 VSS.t547 DELAY_VBIASN a_6391_1842# VSS.t546 sg13_lv_nmos ad=0.2516p pd=2.16u as=0.1406p ps=1.12u w=0.74u l=0.6u
X100 a_16408_1044# a_15837_1842# VDD.t99 VDD.t4 sg13_lv_pmos ad=0.2128p pd=1.5u as=0.3808p ps=2.92u w=1.12u l=0.13u
X101 a_10232_5871# a_10206_5835# VSS.t163 VSS.t162 sg13_lv_nmos ad=0.2516p pd=2.16u as=0.1626p ps=1.415u w=0.74u l=0.13u
X102 a_19550_1044# a_3747_1047.t4 a_21835_1044# VSS.t677 sg13_lv_nmos ad=0.2516p pd=2.16u as=0.1406p ps=1.12u w=0.74u l=0.13u
X103 VSS.t622 DELAY_VBIASN a_20831_1842# VSS.t621 sg13_lv_nmos ad=0.2516p pd=2.16u as=0.1406p ps=1.12u w=0.74u l=0.6u
X104 a_3171_311.t0 a_2873_331# VDD.t136 VDD.t4 sg13_lv_pmos ad=0.2128p pd=1.5u as=0.1918p ps=1.5u w=1.12u l=0.13u
X105 a_15304_4605# a_14851_6228# VDD.t1 VDD.t0 sg13_lv_pmos ad=0.4312p pd=3.01u as=0.2639p ps=1.81u w=1.12u l=0.13u
X106 a_13106_5357# a_12907_5420# VSS.t55 VSS.t399 sg13_lv_nmos ad=0.27427p pd=2.28u as=1.45407p ps=9.445u w=0.795u l=0.13u
X107 a_3747_311.t0 a_3449_331# VDD.t5 VDD.t4 sg13_lv_pmos ad=0.2128p pd=1.5u as=0.1918p ps=1.5u w=1.12u l=0.13u
X108 a_13132_5420# a_13106_5357# VDD.t36 VDD.t0 sg13_lv_pmos ad=0.3927p pd=2.99u as=1.10612p ps=6.66u w=1.155u l=0.13u
X109 a_7390_1044# a_9751_1008# a_9675_1044# VDD.t4 sg13_lv_pmos ad=0.3808p pd=2.92u as=0.2128p ps=1.5u w=1.12u l=0.13u
X110 VSS.t594 DELAY_VBIASN VSS.t592 VSS.t577 sg13_lv_nmos ad=1.33p pd=7.38u as=0 ps=0 w=7u l=7u
X111 a_10191_1842# a_9953_1842# a_10083_1842# VSS.t340 sg13_lv_nmos ad=0.1406p pd=1.12u as=0.2516p ps=2.16u w=0.74u l=0.2u
X112 VSS.t247 a_22677_1842# a_23145_1044# VSS.t287 sg13_lv_nmos ad=0.1665p pd=1.19u as=0.2516p ps=2.16u w=0.74u l=0.13u
X113 a_14751_2470# a_14513_1842# a_14643_1842# VDD.t10 sg13_lv_pmos ad=0.2128p pd=1.5u as=0.3808p ps=2.92u w=1.12u l=0.2u
X114 a_5731_289# a_8745_519# a_7390_1044# VDD.t4 sg13_lv_pmos ad=0.3808p pd=2.92u as=0.3808p ps=2.92u w=1.12u l=0.13u
X115 VDD.t70 VDD.t68 VDD.t66 VDD.t10 sg13_lv_pmos ad=0.2128p pd=1.5u as=0 ps=0 w=1.12u l=0.13u
X116 a_4111_2470# REF_CLK a_4003_1842# VDD.t10 sg13_lv_pmos ad=0.2128p pd=1.5u as=0.3808p ps=2.92u w=1.12u l=0.2u
X117 a_13566_5835# a_14009_5878# a_13306_6305# VSS.t713 sg13_lv_nmos ad=79.8f pd=0.8u as=0.1296p ps=1.52u w=0.42u l=0.13u
X118 a_13306_6305# a_14111_5878# a_13566_5835# VDD.t0 sg13_lv_pmos ad=0.1428p pd=1.52u as=79.8f ps=0.8u w=0.42u l=0.13u
X119 a_13592_5423# a_14111_5227# a_14851_5182# VSS.t319 sg13_lv_nmos ad=0.3473p pd=2.71u as=0.12665p ps=1.145u w=0.74u l=0.13u
X120 a_7673_1842# a_7477_1842# VSS.t219 VSS.t218 sg13_lv_nmos ad=0.2516p pd=2.16u as=0.1406p ps=1.12u w=0.74u l=0.13u
X121 VDD.t216 a_3171_1047.t5 a_18004_1008# VDD.t4 sg13_lv_pmos ad=0.3808p pd=2.92u as=0.3808p ps=2.92u w=1.12u l=0.13u
X122 VDD.t90 a_13123_1842# a_13557_1842# VDD.t10 sg13_lv_pmos ad=0.2128p pd=1.5u as=0.3808p ps=2.92u w=1.12u l=0.13u
X123 VDD.t220 a_3747_311.t2 a_26985_519# VDD.t4 sg13_lv_pmos ad=0.3808p pd=2.92u as=0.3808p ps=2.92u w=1.12u l=0.13u
X124 a_25913_1842# a_25717_1842# VDD.t159 VDD.t10 sg13_lv_pmos ad=0.3808p pd=2.92u as=0.2128p ps=1.5u w=1.12u l=0.13u
X125 a_10430_1044# a_3747_1047.t7 a_12715_1044# VSS.t674 sg13_lv_nmos ad=0.2516p pd=2.16u as=0.1406p ps=1.12u w=0.74u l=0.13u
X126 a_6326_4590# a_5974_5723# a_6126_3816# VSS.t58 sg13_lv_nmos ad=0.38p pd=2.38u as=0.68p ps=4.68u w=2u l=1u
X127 a_14235_1044# a_14025_1044# VDD.t91 VDD.t4 sg13_lv_pmos ad=0.2128p pd=1.5u as=0.252p ps=1.57u w=1.12u l=0.13u
X128 a_24875_1044# a_24665_1044# VSS.t31 VSS.t303 sg13_lv_nmos ad=0.1406p pd=1.12u as=0.1665p ps=1.19u w=0.74u l=0.13u
X129 VSS.t610 DELAY_VBIASN a_11711_1842# VSS.t609 sg13_lv_nmos ad=0.2516p pd=2.16u as=0.1406p ps=1.12u w=0.74u l=0.6u
X130 VDD.t361 a_3747_1047.t7 a_12791_1008# VDD.t4 sg13_lv_pmos ad=0.3808p pd=2.92u as=0.3808p ps=2.92u w=1.12u l=0.13u
X131 VSS.t353 a_2595_1047.t3 a_23431_1008# VSS.t352 sg13_lv_nmos ad=0.2516p pd=2.16u as=0.2516p ps=2.16u w=0.74u l=0.13u
X132 VSS.t451 a_21483_1842# a_21917_1842# VSS.t450 sg13_lv_nmos ad=0.1406p pd=1.12u as=0.2516p ps=2.16u w=0.74u l=0.13u
X133 VSS.t183 a_13557_1842# a_14025_1044# VSS.t182 sg13_lv_nmos ad=0.1665p pd=1.19u as=0.2516p ps=2.16u w=0.74u l=0.13u
X134 a_11848_1044# a_11277_1842# VDD.t232 VDD.t4 sg13_lv_pmos ad=0.2128p pd=1.5u as=0.3808p ps=2.92u w=1.12u l=0.13u
X135 VDD.t115 VSS.t147 VDD.t169 VDD.t4 sg13_lv_pmos ad=0.19p pd=1.38u as=0 ps=0 w=1u l=1u
X136 VDD.t36 a_12907_5186# a_12907_5420# VDD.t0 sg13_lv_pmos ad=1.10612p pd=6.66u as=0.2442p ps=2.06u w=0.66u l=0.13u
X137 a_25391_1842# a_25153_1842# a_25283_1842# VSS.t655 sg13_lv_nmos ad=0.1406p pd=1.12u as=0.2516p ps=2.16u w=0.74u l=0.2u
X138 a_12993_1842# a_12797_1842# VSS.t221 VSS.t344 sg13_lv_nmos ad=0.2516p pd=2.16u as=0.1406p ps=1.12u w=0.74u l=0.13u
X139 DELAY_OUT_LAST a_27997_1842# VDD.t88 VDD.t10 sg13_lv_pmos ad=0.3808p pd=2.92u as=0.2128p ps=1.5u w=1.12u l=0.13u
X140 VDD.t177 VSS.t150 VDD.t176 VDD.t4 sg13_lv_pmos ad=0.34p pd=2.68u as=0 ps=0 w=1u l=1u
X141 VDD.t370 a_19637_1842# a_20105_1044# VDD.t4 sg13_lv_pmos ad=0.252p pd=1.57u as=0.3808p ps=2.92u w=1.12u l=0.13u
X142 a_6854_5454# a_6326_4590# VDD.t187 VDD.t0 sg13_lv_pmos ad=0.38p pd=2.38u as=0.38p ps=2.38u w=2u l=1u
X143 VSS.t614 DELAY_VBIASN a_13991_1842# VSS.t613 sg13_lv_nmos ad=0.2516p pd=2.16u as=0.1406p ps=1.12u w=0.74u l=0.6u
X144 VSS.t130 VDD.t387 VSS.t129 VSS.t128 sg13_lv_nmos ad=0.1428p pd=1.52u as=0 ps=0 w=0.42u l=1u
X145 a_22590_1044# a_3171_1047.t3 a_24008_1044# VSS.t455 sg13_lv_nmos ad=0.2516p pd=2.16u as=0.1406p ps=1.12u w=0.74u l=0.13u
X146 a_6913_1842# a_6717_1842# VDD.t19 VDD.t10 sg13_lv_pmos ad=0.3808p pd=2.92u as=0.2128p ps=1.5u w=1.12u l=0.13u
X147 VDD.t312 DELAY_VBIASP.t15 a_18551_2470# VDD.t10 sg13_lv_pmos ad=0.3808p pd=2.92u as=0.2128p ps=1.5u w=1.12u l=0.6u
X148 VSS.t15 a_23763_1842# a_24197_1842# VSS.t14 sg13_lv_nmos ad=0.1406p pd=1.12u as=0.2516p ps=2.16u w=0.74u l=0.13u
X149 VSS.t95 VDD.t394 VSS.t94 VSS.t93 sg13_lv_nmos ad=0.1428p pd=1.52u as=0 ps=0 w=0.42u l=1u
X150 VDD.t86 a_1256_1044# a_2873_1395# VDD.t4 sg13_lv_pmos ad=0.1918p pd=1.5u as=0.1596p ps=1.22u w=0.84u l=0.13u
X151 a_3171_311.t1 a_2873_331# VSS.t269 VSS.t268 sg13_lv_nmos ad=0.1406p pd=1.12u as=0.1331p ps=1.12u w=0.74u l=0.13u
X152 VDD.t137 a_2873_331# a_3171_311.t0 VDD.t4 sg13_lv_pmos ad=0.4256p pd=3u as=0.2128p ps=1.5u w=1.12u l=0.13u
X153 a_16510_1044# a_17351_1008# a_17275_1044# VDD.t4 sg13_lv_pmos ad=0.3808p pd=2.92u as=0.2128p ps=1.5u w=1.12u l=0.13u
X154 a_25630_1044# a_3747_1047.t2 a_27915_1044# VSS.t474 sg13_lv_nmos ad=0.2516p pd=2.16u as=0.1406p ps=1.12u w=0.74u l=0.13u
X155 VSS.t555 DELAY_VBIASN a_26911_1842# VSS.t554 sg13_lv_nmos ad=0.2516p pd=2.16u as=0.1406p ps=1.12u w=0.74u l=0.6u
X156 a_3747_311.t1 a_3449_331# VSS.t10 VSS.t45 sg13_lv_nmos ad=0.1406p pd=1.12u as=0.1331p ps=1.12u w=0.74u l=0.13u
X157 VDD.t33 a_3449_331# a_3747_311.t0 VDD.t4 sg13_lv_pmos ad=0.4256p pd=3u as=0.2128p ps=1.5u w=1.12u l=0.13u
X158 VDD.t288 DELAY_VBIASP.t10 a_22351_2470# VDD.t10 sg13_lv_pmos ad=0.3808p pd=2.92u as=0.2128p ps=1.5u w=1.12u l=0.6u
X159 VDD.t325 a_3747_1047.t2 a_27991_1008# VDD.t4 sg13_lv_pmos ad=0.3808p pd=2.92u as=0.3808p ps=2.92u w=1.12u l=0.13u
X160 VDD.t254 VSS.t67 VDD.t255 VDD.t4 sg13_lv_pmos ad=0.19p pd=1.38u as=0 ps=0 w=1u l=1u
X161 a_13019_5831# a_15688_5403# VSS.t228 VSS.t412 sg13_lv_nmos ad=0.2516p pd=2.16u as=0.1406p ps=1.12u w=0.74u l=0.13u
X162 VDD.t324 a_3747_1047.t9 a_6711_1008# VDD.t4 sg13_lv_pmos ad=0.3808p pd=2.92u as=0.3808p ps=2.92u w=1.12u l=0.13u
X163 a_6854_5454# a_6326_4590# VDD.t49 VDD.t0 sg13_lv_pmos ad=0.38p pd=2.38u as=0.38p ps=2.38u w=2u l=1u
X164 a_9772_5843# a_9746_5805# VDD.t36 VDD.t0 sg13_lv_pmos ad=0.3927p pd=2.99u as=1.10612p ps=6.66u w=1.155u l=0.13u
X165 a_6391_1842# a_6153_1842# a_6283_1842# VSS.t336 sg13_lv_nmos ad=0.1406p pd=1.12u as=0.2516p ps=2.16u w=0.74u l=0.2u
X166 a_15273_1842# a_15077_1842# VSS.t308 VSS.t418 sg13_lv_nmos ad=0.2516p pd=2.16u as=0.1406p ps=1.12u w=0.74u l=0.13u
X167 a_19833_1842# a_19637_1842# VDD.t37 VDD.t10 sg13_lv_pmos ad=0.3808p pd=2.92u as=0.2128p ps=1.5u w=1.12u l=0.13u
X168 a_16108_289# a_23945_519# a_22590_1044# VDD.t4 sg13_lv_pmos ad=0.3808p pd=2.92u as=0.3808p ps=2.92u w=1.12u l=0.13u
X169 VDD.t192 a_6326_4590# a_6126_3816# VDD.t0 sg13_lv_pmos ad=0.38p pd=2.38u as=0.38p ps=2.38u w=2u l=1u
X170 a_9193_1842# a_8997_1842# VDD.t27 VDD.t10 sg13_lv_pmos ad=0.3808p pd=2.92u as=0.2128p ps=1.5u w=1.12u l=0.13u
X171 a_24631_2470# a_24393_1842# a_24523_1842# VDD.t10 sg13_lv_pmos ad=0.2128p pd=1.5u as=0.3808p ps=2.92u w=1.12u l=0.2u
X172 VSS.t206 a_15403_1842# a_15837_1842# VSS.t354 sg13_lv_nmos ad=0.1406p pd=1.12u as=0.2516p ps=2.16u w=0.74u l=0.13u
X173 a_8155_1044# a_7945_1044# VSS.t217 VSS.t415 sg13_lv_nmos ad=0.1406p pd=1.12u as=0.1665p ps=1.19u w=0.74u l=0.13u
X174 a_23633_1842# a_23437_1842# VDD.t141 VDD.t10 sg13_lv_pmos ad=0.3808p pd=2.92u as=0.2128p ps=1.5u w=1.12u l=0.13u
X175 VSS.t364 a_4763_1842# a_5197_1842# VSS.t363 sg13_lv_nmos ad=0.1406p pd=1.12u as=0.2516p ps=2.16u w=0.74u l=0.13u
X176 a_27048_1044# a_26477_1842# VSS.t460 VSS.t459 sg13_lv_nmos ad=0.1406p pd=1.12u as=0.2516p ps=2.16u w=0.74u l=0.13u
X177 VDD.t147 a_9323_1842# a_9757_1842# VDD.t10 sg13_lv_pmos ad=0.2128p pd=1.5u as=0.3808p ps=2.92u w=1.12u l=0.13u
X178 a_5768_1044# a_5197_1842# VSS.t523 VSS.t522 sg13_lv_nmos ad=0.1406p pd=1.12u as=0.2516p ps=2.16u w=0.74u l=0.13u
X179 a_6326_4590# a_6126_3816# a_5778_3367# VSS.t690 sg13_lv_nmos ad=0.38p pd=2.38u as=0.68p ps=4.68u w=2u l=1u
X180 DELAY_VBIASN DLL_RESETN VDD.t81 VDD.t55 sg13_lv_pmos ad=0.158p pd=1.245u as=0.272p ps=2.28u w=0.8u l=0.2u
X181 a_7390_1044# a_7364_1008# a_7288_1044# VDD.t4 sg13_lv_pmos ad=0.3808p pd=2.92u as=0.2128p ps=1.5u w=1.12u l=0.13u
X182 VSS.t588 DELAY_VBIASN VSS.t587 VSS.t570 sg13_lv_nmos ad=2.38p pd=14.68u as=0 ps=0 w=7u l=7u
X183 VSS.t604 DELAY_VBIASN a_7911_1842# VSS.t603 sg13_lv_nmos ad=0.2516p pd=2.16u as=0.1406p ps=1.12u w=0.74u l=0.6u
X184 VDD.t140 a_13019_5831# a_12943_5867# VDD.t0 sg13_lv_pmos ad=0.2128p pd=1.5u as=0.2128p ps=1.5u w=1.12u l=0.13u
X185 a_6854_5986# a_15304_4605# DELAY_VBIASN VDD.t55 sg13_lv_pmos ad=0.136p pd=1.14u as=0.158p ps=1.245u w=0.4u l=0.2u
X186 VDD.t108 VSS.t107 VDD.t107 VDD.t4 sg13_lv_pmos ad=0.19p pd=1.38u as=0 ps=0 w=1u l=1u
X187 a_11711_1842# a_11473_1842# a_11603_1842# VSS.t335 sg13_lv_nmos ad=0.1406p pd=1.12u as=0.2516p ps=2.16u w=0.74u l=0.2u
X188 VSS.t31 a_24197_1842# a_24665_1044# VSS.t30 sg13_lv_nmos ad=0.1665p pd=1.19u as=0.2516p ps=2.16u w=0.74u l=0.13u
X189 a_16510_1044# a_3171_1047.t5 a_17928_1044# VSS.t370 sg13_lv_nmos ad=0.2516p pd=2.16u as=0.1406p ps=1.12u w=0.74u l=0.13u
X190 a_15270_5105# a_12849_5867# VSS.t226 VSS.t408 sg13_lv_nmos ad=37.8f pd=0.6u as=79.8f ps=0.8u w=0.42u l=0.13u
X191 a_5974_5723# a_6126_3816# VSS.t695 VSS.t58 sg13_lv_nmos ad=0.38p pd=2.38u as=0.68p ps=4.68u w=2u l=1u
X192 VSS.t87 VDD.t396 VSS.t85 VSS.t86 sg13_lv_nmos ad=79.8f pd=0.8u as=0 ps=0 w=0.42u l=1u
X193 a_5631_2470# a_5393_1842# a_5523_1842# VDD.t10 sg13_lv_pmos ad=0.2128p pd=1.5u as=0.3808p ps=2.92u w=1.12u l=0.2u
X194 a_14513_1842# a_14317_1842# VDD.t344 VDD.t10 sg13_lv_pmos ad=0.3808p pd=2.92u as=0.2128p ps=1.5u w=1.12u l=0.13u
X195 a_4633_1842# a_4437_1842# VDD.t28 VDD.t10 sg13_lv_pmos ad=0.3808p pd=2.92u as=0.2128p ps=1.5u w=1.12u l=0.13u
X196 VSS.t223 a_10083_1842# a_10517_1842# VSS.t222 sg13_lv_nmos ad=0.1406p pd=1.12u as=0.2516p ps=2.16u w=0.74u l=0.13u
X197 VDD.t380 a_2019_1047.t4 a_19524_1008# VDD.t4 sg13_lv_pmos ad=0.3808p pd=2.92u as=0.3808p ps=2.92u w=1.12u l=0.13u
X198 VSS.t209 a_3171_1047.t4 a_21044_1008# VSS.t208 sg13_lv_nmos ad=0.2516p pd=2.16u as=0.2516p ps=2.16u w=0.74u l=0.13u
X199 VSS.t271 a_2873_331# a_3171_311.t1 VSS.t270 sg13_lv_nmos ad=0.2812p pd=2.24u as=0.1406p ps=1.12u w=0.74u l=0.13u
X200 a_13949_5496# a_13592_5423# VDD.t241 VDD.t0 sg13_lv_pmos ad=63f pd=0.72u as=0.1563p ps=1.22u w=0.42u l=0.13u
X201 VSS.t47 a_3449_331# a_3747_311.t1 VSS.t46 sg13_lv_nmos ad=0.2812p pd=2.24u as=0.1406p ps=1.12u w=0.74u l=0.13u
X202 a_15755_1044# a_15545_1044# VDD.t127 VDD.t4 sg13_lv_pmos ad=0.2128p pd=1.5u as=0.252p ps=1.57u w=1.12u l=0.13u
X203 VDD.t226 a_2595_1047.t6 a_14311_1008# VDD.t4 sg13_lv_pmos ad=0.3808p pd=2.92u as=0.3808p ps=2.92u w=1.12u l=0.13u
X204 VSS.t541 DELAY_VBIASN a_24631_1842# VSS.t540 sg13_lv_nmos ad=0.2516p pd=2.16u as=0.1406p ps=1.12u w=0.74u l=0.6u
X205 a_5115_1044# a_4905_1044# VDD.t156 VDD.t4 sg13_lv_pmos ad=0.2128p pd=1.5u as=0.252p ps=1.57u w=1.12u l=0.13u
X206 a_5974_5723# a_6126_3816# VSS.t697 VSS.t58 sg13_lv_nmos ad=0.38p pd=2.38u as=0.68p ps=4.68u w=2u l=1u
X207 VSS.t55 a_12907_5186# a_12907_5186# VSS.t683 sg13_lv_nmos ad=1.45407p pd=9.445u as=0.111p ps=1.34u w=0.3u l=0.13u
X208 a_18551_2470# a_18313_1842# a_18443_1842# VDD.t10 sg13_lv_pmos ad=0.2128p pd=1.5u as=0.3808p ps=2.92u w=1.12u l=0.2u
X209 VDD.t120 VSS.t127 VDD.t119 VDD.t4 sg13_lv_pmos ad=0.19p pd=1.38u as=0 ps=0 w=1u l=1u
X210 a_3171_1047.t1 a_2873_1395# VSS.t174 VSS.t435 sg13_lv_nmos ad=0.1406p pd=1.12u as=0.1331p ps=1.12u w=0.74u l=0.13u
X211 a_13121_5831# a_15688_5867# VSS.t3 VSS.t632 sg13_lv_nmos ad=0.2516p pd=2.16u as=0.1406p ps=1.12u w=0.74u l=0.13u
X212 VSS.t578 DELAY_VBIASN VSS.t580 VSS.t579 sg13_lv_nmos ad=1.33p pd=7.38u as=0 ps=0 w=7u l=7u
X213 VSS.t37 a_2297_1395# a_2595_1047.t1 VSS.t36 sg13_lv_nmos ad=0.2812p pd=2.24u as=0.1406p ps=1.12u w=0.74u l=0.13u
X214 VDD.t110 a_14851_5182# a_15108_5325# VDD.t0 sg13_lv_pmos ad=0.2639p pd=1.81u as=79.8f ps=0.8u w=0.42u l=0.13u
X215 a_22351_2470# a_22113_1842# a_22243_1842# VDD.t10 sg13_lv_pmos ad=0.2128p pd=1.5u as=0.3808p ps=2.92u w=1.12u l=0.2u
X216 VSS.t512 VSS.t510 VSS.t165 VSS.t511 sg13_lv_nmos ad=0.2516p pd=2.16u as=0 ps=0 w=0.74u l=0.13u
X217 a_26911_1842# a_26673_1842# a_26803_1842# VSS.t654 sg13_lv_nmos ad=0.1406p pd=1.12u as=0.2516p ps=2.16u w=0.74u l=0.2u
X218 VSS.t190 a_3171_311.t3 a_11785_519# VSS.t189 sg13_lv_nmos ad=0.2516p pd=2.16u as=0.2516p ps=2.16u w=0.74u l=0.13u
X219 VDD.t287 a_1721_1395# a_2019_1047.t0 VDD.t4 sg13_lv_pmos ad=0.4256p pd=3u as=0.2128p ps=1.5u w=1.12u l=0.13u
X220 a_12656_5864# DLL_RESETN VSS.t161 VSS.t160 sg13_lv_nmos ad=0.2516p pd=2.16u as=0.2516p ps=2.16u w=0.74u l=0.13u
X221 a_14851_6228# a_14009_5878# a_14757_6228# VSS.t1 sg13_lv_nmos ad=0.12665p pd=1.145u as=0.1428p ps=1.52u w=0.42u l=0.13u
X222 VDD.t12 a_16923_1842# a_17357_1842# VDD.t10 sg13_lv_pmos ad=0.2128p pd=1.5u as=0.3808p ps=2.92u w=1.12u l=0.13u
X223 a_2391_1395# MUX_SEL0 a_2297_1395# VSS.t479 sg13_lv_nmos ad=0.1216p pd=1.02u as=0.2176p ps=1.96u w=0.64u l=0.13u
X224 VSS.t202 a_1544_1044# a_1815_1395# VSS.t201 sg13_lv_nmos ad=0.1331p pd=1.12u as=0.1216p ps=1.02u w=0.64u l=0.13u
X225 a_13368_1044# a_12797_1842# VSS.t343 VSS.t342 sg13_lv_nmos ad=0.1406p pd=1.12u as=0.2516p ps=2.16u w=0.74u l=0.13u
X226 a_13400_5105# a_13132_5420# a_13306_5105# VSS.t13 sg13_lv_nmos ad=60.89999f pd=0.71u as=0.1428p ps=1.52u w=0.42u l=0.13u
X227 a_5731_289# a_3171_311.t3 a_10430_1044# VSS.t188 sg13_lv_nmos ad=0.2516p pd=2.16u as=0.2516p ps=2.16u w=0.74u l=0.13u
X228 VDD.t230 a_21157_1842# a_21625_1044# VDD.t4 sg13_lv_pmos ad=0.252p pd=1.57u as=0.3808p ps=2.92u w=1.12u l=0.13u
X229 VDD.t294 DELAY_VBIASP.t25 a_10951_2470# VDD.t10 sg13_lv_pmos ad=0.3808p pd=2.92u as=0.2128p ps=1.5u w=1.12u l=0.6u
X230 VSS.t535 DELAY_VBIASN a_15511_1842# VSS.t534 sg13_lv_nmos ad=0.2516p pd=2.16u as=0.1406p ps=1.12u w=0.74u l=0.6u
X231 a_6326_4590# a_6326_4590# VDD.t183 VDD.t0 sg13_lv_pmos ad=0.38p pd=2.38u as=0.38p ps=2.38u w=2u l=1u
X232 VSS.t590 DELAY_VBIASN VSS.t588 VSS.t573 sg13_lv_nmos ad=1.33p pd=7.38u as=0 ps=0 w=7u l=7u
X233 VDD.t31 a_20723_1842# a_21157_1842# VDD.t10 sg13_lv_pmos ad=0.2128p pd=1.5u as=0.3808p ps=2.92u w=1.12u l=0.13u
X234 VSS.t321 a_25283_1842# a_25717_1842# VSS.t320 sg13_lv_nmos ad=0.1406p pd=1.12u as=0.2516p ps=2.16u w=0.74u l=0.13u
X235 a_4350_1044# a_3747_1047.t9 a_6635_1044# VSS.t471 sg13_lv_nmos ad=0.2516p pd=2.16u as=0.1406p ps=1.12u w=0.74u l=0.13u
X236 VSS.t549 DELAY_VBIASN a_5631_1842# VSS.t548 sg13_lv_nmos ad=0.2516p pd=2.16u as=0.1406p ps=1.12u w=0.74u l=0.6u
X237 VDD.t382 a_2019_1047.t9 a_4324_1008# VDD.t4 sg13_lv_pmos ad=0.3808p pd=2.92u as=0.3808p ps=2.92u w=1.12u l=0.13u
X238 a_12849_5867# a_12656_5864# VSS.t442 VSS.t441 sg13_lv_nmos ad=0.1406p pd=1.12u as=0.2516p ps=2.16u w=0.74u l=0.13u
X239 a_16510_1044# a_18871_1008# a_18795_1044# VDD.t4 sg13_lv_pmos ad=0.3808p pd=2.92u as=0.2128p ps=1.5u w=1.12u l=0.13u
X240 a_19550_1044# a_2595_1047.t4 a_20315_1044# VSS.t197 sg13_lv_nmos ad=0.2516p pd=2.16u as=0.1406p ps=1.12u w=0.74u l=0.13u
X241 VDD.t187 a_6326_4590# a_6126_3816# VDD.t0 sg13_lv_pmos ad=0.38p pd=2.38u as=0.38p ps=2.38u w=2u l=1u
X242 VDD.t36 a_11491_6228# a_11748_6109# VDD.t0 sg13_lv_pmos ad=1.10612p pd=6.66u as=79.8f ps=0.8u w=0.42u l=0.13u
X243 a_12355_5867# a_12158_5867# VDD.t214 VDD.t0 sg13_lv_pmos ad=0.3808p pd=2.92u as=0.2128p ps=1.5u w=1.12u l=0.13u
X244 VDD.t317 DELAY_VBIASP.t8 a_23871_2470# VDD.t10 sg13_lv_pmos ad=0.3808p pd=2.92u as=0.2128p ps=1.5u w=1.12u l=0.6u
X245 VSS.t217 a_7477_1842# a_7945_1044# VSS.t216 sg13_lv_nmos ad=0.1665p pd=1.19u as=0.2516p ps=2.16u w=0.74u l=0.13u
X246 a_11910_6305# DLL_RESETN VSS.t159 VSS.t158 sg13_lv_nmos ad=37.8f pd=0.6u as=79.8f ps=0.8u w=0.42u l=0.13u
X247 VSS.t584 DELAY_VBIASN VSS.t586 VSS.t585 sg13_lv_nmos ad=1.33p pd=7.38u as=0 ps=0 w=7u l=7u
X248 a_13231_2470# a_12993_1842# a_13123_1842# VDD.t10 sg13_lv_pmos ad=0.2128p pd=1.5u as=0.3808p ps=2.92u w=1.12u l=0.2u
X249 VDD.t254 VSS.t64 VDD.t253 VDD.t4 sg13_lv_pmos ad=0.34p pd=2.68u as=0 ps=0 w=1u l=1u
X250 a_6326_4590# a_6126_3816# a_5778_3367# VSS.t690 sg13_lv_nmos ad=0.38p pd=2.38u as=0.68p ps=4.68u w=2u l=1u
X251 a_12233_1842# a_12037_1842# VDD.t40 VDD.t10 sg13_lv_pmos ad=0.3808p pd=2.92u as=0.2128p ps=1.5u w=1.12u l=0.13u
X252 a_7911_1842# a_7673_1842# a_7803_1842# VSS.t665 sg13_lv_nmos ad=0.1406p pd=1.12u as=0.2516p ps=2.16u w=0.74u l=0.2u
X253 a_16793_1842# a_16597_1842# VSS.t385 VSS.t469 sg13_lv_nmos ad=0.2516p pd=2.16u as=0.1406p ps=1.12u w=0.74u l=0.13u
X254 VDD.t89 a_3747_311.t3 a_14825_519# VDD.t4 sg13_lv_pmos ad=0.3808p pd=2.92u as=0.3808p ps=2.92u w=1.12u l=0.13u
X255 VDD.t212 a_12849_5867# a_13306_6305# VDD.t0 sg13_lv_pmos ad=0.36237p pd=2.605u as=79.8f ps=0.8u w=0.42u l=0.13u
X256 VDD.t50 VDD.t42 VDD.t49 VDD.t0 sg13_lv_pmos ad=0.68p pd=4.68u as=0 ps=0 w=2u l=1u
X257 VSS.t176 a_27563_1842# a_27997_1842# VSS.t707 sg13_lv_nmos ad=0.1406p pd=1.12u as=0.2516p ps=2.16u w=0.74u l=0.13u
X258 a_9675_1044# a_9465_1044# VSS.t350 VSS.t349 sg13_lv_nmos ad=0.1406p pd=1.12u as=0.1665p ps=1.19u w=0.74u l=0.13u
X259 VDD.t183 a_6326_4590# a_6854_5986# VDD.t0 sg13_lv_pmos ad=0.38p pd=2.38u as=0.38p ps=2.38u w=2u l=1u
X260 a_20593_1842# a_20397_1842# VSS.t242 VSS.t241 sg13_lv_nmos ad=0.2516p pd=2.16u as=0.1406p ps=1.12u w=0.74u l=0.13u
X261 VSS.t193 a_2595_1047.t8 a_8231_1008# VSS.t192 sg13_lv_nmos ad=0.2516p pd=2.16u as=0.2516p ps=2.16u w=0.74u l=0.13u
X262 VSS.t26 a_6283_1842# a_6717_1842# VSS.t653 sg13_lv_nmos ad=0.1406p pd=1.12u as=0.2516p ps=2.16u w=0.74u l=0.13u
X263 a_10430_1044# a_10404_1008# a_10328_1044# VDD.t4 sg13_lv_pmos ad=0.3808p pd=2.92u as=0.2128p ps=1.5u w=1.12u l=0.13u
X264 VDD.t318 DELAY_VBIASP.t5 a_26151_2470# VDD.t10 sg13_lv_pmos ad=0.3808p pd=2.92u as=0.2128p ps=1.5u w=1.12u l=0.6u
X265 a_7390_1044# a_8884_1008# a_8808_1044# VDD.t4 sg13_lv_pmos ad=0.3808p pd=2.92u as=0.2128p ps=1.5u w=1.12u l=0.13u
X266 a_11491_6228# a_10649_5878# a_11397_6228# VSS.t158 sg13_lv_nmos ad=0.12665p pd=1.145u as=0.1428p ps=1.52u w=0.42u l=0.13u
X267 VDD.t298 DELAY_VBIASP.t33 a_4871_2470# VDD.t10 sg13_lv_pmos ad=0.3808p pd=2.92u as=0.2128p ps=1.5u w=1.12u l=0.6u
X268 a_6126_3816# a_6126_3816# VSS.t692 VSS.t690 sg13_lv_nmos ad=0.38p pd=2.38u as=0.68p ps=4.68u w=2u l=1u
X269 a_3449_331# MUX_SEL2 VDD.t17 VDD.t4 sg13_lv_pmos ad=0.1596p pd=1.22u as=0.2856p ps=2.36u w=0.84u l=0.13u
X270 VDD.t223 VSS.t122 VDD.t222 VDD.t4 sg13_lv_pmos ad=0.19p pd=1.38u as=0 ps=0 w=1u l=1u
X271 a_19073_1842# a_18877_1842# VSS.t324 VSS.t345 sg13_lv_nmos ad=0.2516p pd=2.16u as=0.1406p ps=1.12u w=0.74u l=0.13u
X272 VDD.t127 a_15077_1842# a_15545_1044# VDD.t4 sg13_lv_pmos ad=0.252p pd=1.57u as=0.3808p ps=2.92u w=1.12u l=0.13u
X273 a_19550_1044# a_2019_1047.t4 a_19448_1044# VSS.t715 sg13_lv_nmos ad=0.2516p pd=2.16u as=0.1406p ps=1.12u w=0.74u l=0.13u
X274 VDD.t167 a_12849_5867# a_13306_5105# VDD.t0 sg13_lv_pmos ad=0.36237p pd=2.605u as=79.8f ps=0.8u w=0.42u l=0.13u
X275 VDD.t73 VDD.t71 VDD.t72 VDD.t10 sg13_lv_pmos ad=0.3808p pd=2.92u as=0 ps=0 w=1.12u l=0.6u
X276 VSS.t147 VDD.t384 VSS.t145 VSS.t146 sg13_lv_nmos ad=79.8f pd=0.8u as=0 ps=0 w=0.42u l=1u
X277 a_13592_5871# a_13566_5835# VSS.t366 VSS.t365 sg13_lv_nmos ad=0.2516p pd=2.16u as=0.1626p ps=1.415u w=0.74u l=0.13u
X278 VSS.t57 a_19203_1842# a_19637_1842# VSS.t56 sg13_lv_nmos ad=0.1406p pd=1.12u as=0.2516p ps=2.16u w=0.74u l=0.13u
X279 VDD.t117 VSS.t117 VDD.t215 VDD.t4 sg13_lv_pmos ad=0.19p pd=1.38u as=0 ps=0 w=1u l=1u
X280 a_15108_6109# a_12849_5867# VDD.t36 VDD.t0 sg13_lv_pmos ad=79.8f pd=0.8u as=1.03698p ps=6.245u w=0.42u l=0.13u
X281 VDD.t180 VSS.t89 VDD.t179 VDD.t4 sg13_lv_pmos ad=0.34p pd=2.68u as=0 ps=0 w=1u l=1u
X282 VSS.t317 a_15108_6109# a_14757_6228# VSS.t1 sg13_lv_nmos ad=79.8f pd=0.8u as=0.1428p ps=1.52u w=0.42u l=0.13u
X283 a_27433_1842# a_27237_1842# VDD.t336 VDD.t10 sg13_lv_pmos ad=0.3808p pd=2.92u as=0.2128p ps=1.5u w=1.12u l=0.13u
X284 VDD.t136 a_1256_289# a_2873_331# VDD.t4 sg13_lv_pmos ad=0.1918p pd=1.5u as=0.1596p ps=1.22u w=0.84u l=0.13u
X285 a_13470_1044# a_2595_1047.t6 a_14235_1044# VSS.t379 sg13_lv_nmos ad=0.2516p pd=2.16u as=0.1406p ps=1.12u w=0.74u l=0.13u
X286 VSS.t265 a_9444_4590# a_9444_4590# VSS.t256 sg13_lv_nmos ad=0.68p pd=4.68u as=0.38p ps=2.38u w=2u l=1u
X287 VSS.t40 a_8563_1842# a_8997_1842# VSS.t39 sg13_lv_nmos ad=0.1406p pd=1.12u as=0.2516p ps=2.16u w=0.74u l=0.13u
X288 VSS.t504 VSS.t504 VSS.t506 VSS.t505 sg13_lv_nmos ad=0.2516p pd=2.16u as=0 ps=0 w=0.74u l=0.13u
X289 VSS.t553 DELAY_VBIASN a_13231_1842# VSS.t552 sg13_lv_nmos ad=0.2516p pd=2.16u as=0.1406p ps=1.12u w=0.74u l=0.6u
X290 VDD.t102 a_3171_1047.t7 a_11924_1008# VDD.t4 sg13_lv_pmos ad=0.3808p pd=2.92u as=0.3808p ps=2.92u w=1.12u l=0.13u
X291 VSS.t658 a_2019_1047.t3 a_22564_1008# VSS.t657 sg13_lv_nmos ad=0.2516p pd=2.16u as=0.2516p ps=2.16u w=0.74u l=0.13u
X292 a_15053_5420# a_14111_5227# a_14851_5182# VDD.t0 sg13_lv_pmos ad=93.45f pd=0.865u as=0.2048p ps=1.63u w=0.42u l=0.13u
X293 VSS.t503 VSS.t499 VSS.t499 VSS.t501 sg13_lv_nmos ad=0.1406p pd=1.12u as=0 ps=0 w=0.74u l=0.13u
X294 VSS.t282 a_23003_1842# a_23437_1842# VSS.t281 sg13_lv_nmos ad=0.1406p pd=1.12u as=0.2516p ps=2.16u w=0.74u l=0.13u
X295 VSS.t150 VDD.t383 VSS.t149 VSS.t148 sg13_lv_nmos ad=0.1428p pd=1.52u as=0 ps=0 w=0.42u l=1u
X296 VDD.t289 DELAY_VBIASP.t30 a_7151_2470# VDD.t10 sg13_lv_pmos ad=0.3808p pd=2.92u as=0.2128p ps=1.5u w=1.12u l=0.6u
X297 a_5778_3367# VSS.t215 VSS.t214 rppd l=32u w=1u
X298 a_25630_1044# a_25604_1008# a_25528_1044# VDD.t4 sg13_lv_pmos ad=0.3808p pd=2.92u as=0.2128p ps=1.5u w=1.12u l=0.13u
X299 a_10206_5835# a_10649_5878# a_10589_5914# VDD.t0 sg13_lv_pmos ad=79.8f pd=0.8u as=63f ps=0.72u w=0.42u l=0.13u
X300 a_15511_1842# a_15273_1842# a_15403_1842# VSS.t481 sg13_lv_nmos ad=0.1406p pd=1.12u as=0.2516p ps=2.16u w=0.74u l=0.2u
X301 a_10520_6292# a_10751_5878# a_10206_5835# VSS.t467 sg13_lv_nmos ad=0.2373p pd=1.97u as=79.8f ps=0.8u w=0.42u l=0.13u
X302 a_11693_5990# a_10751_5878# a_11491_6228# VDD.t0 sg13_lv_pmos ad=93.45f pd=0.865u as=0.2048p ps=1.63u w=0.42u l=0.13u
X303 a_18313_1842# a_18117_1842# VDD.t114 VDD.t10 sg13_lv_pmos ad=0.3808p pd=2.92u as=0.2128p ps=1.5u w=1.12u l=0.13u
X304 a_5731_289# a_11785_519# a_10430_1044# VDD.t4 sg13_lv_pmos ad=0.3808p pd=2.92u as=0.3808p ps=2.92u w=1.12u l=0.13u
X305 VSS.t67 VDD.t400 VSS.t65 VSS.t66 sg13_lv_nmos ad=79.8f pd=0.8u as=0 ps=0 w=0.42u l=1u
X306 a_9431_2470# a_9193_1842# a_9323_1842# VDD.t10 sg13_lv_pmos ad=0.2128p pd=1.5u as=0.3808p ps=2.92u w=1.12u l=0.2u
X307 a_17275_1044# a_17065_1044# VSS.t421 VSS.t420 sg13_lv_nmos ad=0.1406p pd=1.12u as=0.1665p ps=1.19u w=0.74u l=0.13u
X308 VDD.t120 VSS.t124 VDD.t351 VDD.t4 sg13_lv_pmos ad=0.34p pd=2.68u as=0 ps=0 w=1u l=1u
X309 VSS.t274 a_3747_1047.t6 a_15831_1008# VSS.t273 sg13_lv_nmos ad=0.2516p pd=2.16u as=0.2516p ps=2.16u w=0.74u l=0.13u
X310 a_23871_2470# a_23633_1842# a_23763_1842# VDD.t10 sg13_lv_pmos ad=0.2128p pd=1.5u as=0.3808p ps=2.92u w=1.12u l=0.2u
X311 VSS.t652 a_13883_1842# a_14317_1842# VSS.t688 sg13_lv_nmos ad=0.1406p pd=1.12u as=0.2516p ps=2.16u w=0.74u l=0.13u
X312 VSS.t378 a_3747_311.t2 a_26985_519# VSS.t377 sg13_lv_nmos ad=0.2516p pd=2.16u as=0.2516p ps=2.16u w=0.74u l=0.13u
X313 a_8433_1842# a_8237_1842# VDD.t231 VDD.t10 sg13_lv_pmos ad=0.3808p pd=2.92u as=0.2128p ps=1.5u w=1.12u l=0.13u
X314 VDD.t161 a_18443_1842# a_18877_1842# VDD.t10 sg13_lv_pmos ad=0.2128p pd=1.5u as=0.3808p ps=2.92u w=1.12u l=0.13u
X315 a_22113_1842# a_21917_1842# VDD.t274 VDD.t10 sg13_lv_pmos ad=0.3808p pd=2.92u as=0.2128p ps=1.5u w=1.12u l=0.13u
X316 a_4350_1044# a_2019_1047.t9 a_4248_1044# VSS.t721 sg13_lv_nmos ad=0.2516p pd=2.16u as=0.1406p ps=1.12u w=0.74u l=0.13u
X317 a_14888_1044# a_14317_1842# VSS.t650 VSS.t649 sg13_lv_nmos ad=0.1406p pd=1.12u as=0.2516p ps=2.16u w=0.74u l=0.13u
X318 a_13880_5118# a_13592_5423# a_13818_5118# VSS.t702 sg13_lv_nmos ad=0.1428p pd=1.52u as=37.8f ps=0.6u w=0.42u l=0.13u
X319 a_16108_289# a_3747_311.t2 a_25630_1044# VSS.t376 sg13_lv_nmos ad=0.2516p pd=2.16u as=0.2516p ps=2.16u w=0.74u l=0.13u
X320 VDD.t291 DELAY_VBIASP.t23 a_12471_2470# VDD.t10 sg13_lv_pmos ad=0.3808p pd=2.92u as=0.2128p ps=1.5u w=1.12u l=0.6u
X321 VSS.t42 a_4003_1842# a_4437_1842# VSS.t41 sg13_lv_nmos ad=0.1406p pd=1.12u as=0.2516p ps=2.16u w=0.74u l=0.13u
X322 a_16510_1044# a_16484_1008# a_16408_1044# VDD.t4 sg13_lv_pmos ad=0.3808p pd=2.92u as=0.2128p ps=1.5u w=1.12u l=0.13u
X323 VSS.t279 a_13121_5831# a_13045_6215# VSS.t278 sg13_lv_nmos ad=0.2516p pd=2.16u as=0.1406p ps=1.12u w=0.74u l=0.13u
X324 VDD.t112 a_14851_5182# a_15688_5403# VDD.t0 sg13_lv_pmos ad=0.2128p pd=1.5u as=0.3864p ps=2.93u w=1.12u l=0.13u
X325 VDD.t145 a_22243_1842# a_22677_1842# VDD.t10 sg13_lv_pmos ad=0.2128p pd=1.5u as=0.3808p ps=2.92u w=1.12u l=0.13u
X326 VDD.t157 a_3171_1047.t2 a_27124_1008# VDD.t4 sg13_lv_pmos ad=0.3808p pd=2.92u as=0.3808p ps=2.92u w=1.12u l=0.13u
X327 VDD.t5 MUX_SEL3 a_3449_331# VDD.t4 sg13_lv_pmos ad=0.1918p pd=1.5u as=0.1596p ps=1.22u w=0.84u l=0.13u
X328 a_2595_311.t0 a_2297_331# VDD.t264 VDD.t4 sg13_lv_pmos ad=0.2128p pd=1.5u as=0.1918p ps=1.5u w=1.12u l=0.13u
X329 a_10430_1044# a_11271_1008# a_11195_1044# VDD.t4 sg13_lv_pmos ad=0.3808p pd=2.92u as=0.2128p ps=1.5u w=1.12u l=0.13u
X330 a_14009_5084# DELAY_OUT_LAST VSS.t55 VSS.t54 sg13_lv_nmos ad=0.2516p pd=2.16u as=1.45407p ps=9.445u w=0.74u l=0.13u
X331 a_23355_1044# a_23145_1044# VDD.t131 VDD.t4 sg13_lv_pmos ad=0.2128p pd=1.5u as=0.252p ps=1.57u w=1.12u l=0.13u
X332 VDD.t362 a_3747_1047.t4 a_21911_1008# VDD.t4 sg13_lv_pmos ad=0.3808p pd=2.92u as=0.3808p ps=2.92u w=1.12u l=0.13u
X333 VSS.t350 a_8997_1842# a_9465_1044# VSS.t362 sg13_lv_nmos ad=0.1665p pd=1.19u as=0.2516p ps=2.16u w=0.74u l=0.13u
X334 a_13592_5423# a_13566_5328# VDD.t167 VDD.t0 sg13_lv_pmos ad=0.34p pd=2.68u as=0.36237p ps=2.605u w=1u l=0.13u
X335 a_6126_3816# a_5974_5723# a_6326_4590# VSS.t58 sg13_lv_nmos ad=0.68p pd=4.68u as=0.38p ps=2.38u w=2u l=1u
X336 a_20968_1044# a_20397_1842# VDD.t129 VDD.t4 sg13_lv_pmos ad=0.2128p pd=1.5u as=0.3808p ps=2.92u w=1.12u l=0.13u
X337 a_10951_1842# a_10713_1842# a_10843_1842# VSS.t684 sg13_lv_nmos ad=0.1406p pd=1.12u as=0.2516p ps=2.16u w=0.74u l=0.2u
X338 VSS.t712 a_2019_1047.t5 a_16484_1008# VSS.t711 sg13_lv_nmos ad=0.2516p pd=2.16u as=0.2516p ps=2.16u w=0.74u l=0.13u
X339 a_26151_2470# a_25913_1842# a_26043_1842# VDD.t10 sg13_lv_pmos ad=0.2128p pd=1.5u as=0.3808p ps=2.92u w=1.12u l=0.2u
X340 a_9444_4590# a_6854_5454# a_6854_5454# VSS.t531 sg13_lv_nmos ad=0.68p pd=4.68u as=0.38p ps=2.38u w=2u l=1u
X341 a_13753_1842# a_13557_1842# VDD.t90 VDD.t10 sg13_lv_pmos ad=0.3808p pd=2.92u as=0.2128p ps=1.5u w=1.12u l=0.13u
X342 VDD.t330 a_1721_331# a_2019_311.t0 VDD.t4 sg13_lv_pmos ad=0.4256p pd=3u as=0.2128p ps=1.5u w=1.12u l=0.13u
X343 a_4871_2470# a_4633_1842# a_4763_1842# VDD.t10 sg13_lv_pmos ad=0.2128p pd=1.5u as=0.3808p ps=2.92u w=1.12u l=0.2u
X344 VSS.t238 a_3171_1047.t9 a_5844_1008# VSS.t237 sg13_lv_nmos ad=0.2516p pd=2.16u as=0.2516p ps=2.16u w=0.74u l=0.13u
X345 VSS.t107 VDD.t392 VSS.t105 VSS.t106 sg13_lv_nmos ad=79.8f pd=0.8u as=0 ps=0 w=0.42u l=1u
X346 VDD.t35 a_2595_311.t2 a_20905_519# VDD.t4 sg13_lv_pmos ad=0.3808p pd=2.92u as=0.3808p ps=2.92u w=1.12u l=0.13u
X347 VDD.t265 a_2297_331# a_2595_311.t0 VDD.t4 sg13_lv_pmos ad=0.4256p pd=3u as=0.2128p ps=1.5u w=1.12u l=0.13u
X348 a_14009_5084# DELAY_OUT_LAST VDD.t36 VDD.t0 sg13_lv_pmos ad=0.4088p pd=2.97u as=1.10612p ps=6.66u w=1.12u l=0.13u
X349 VSS.t196 a_2595_1047.t7 a_11271_1008# VSS.t195 sg13_lv_nmos ad=0.2516p pd=2.16u as=0.2516p ps=2.16u w=0.74u l=0.13u
X350 VSS.t624 DELAY_VBIASN a_19311_1842# VSS.t623 sg13_lv_nmos ad=0.2516p pd=2.16u as=0.1406p ps=1.12u w=0.74u l=0.6u
X351 VSS.t257 a_9444_4590# a_9444_3912# VSS.t256 sg13_lv_nmos ad=0.68p pd=4.68u as=0.38p ps=2.38u w=2u l=1u
X352 a_13880_5118# a_14111_5227# a_13566_5328# VSS.t318 sg13_lv_nmos ad=0.2373p pd=1.97u as=79.8f ps=0.8u w=0.42u l=0.13u
X353 VDD.t143 a_24523_1842# a_24957_1842# VDD.t10 sg13_lv_pmos ad=0.2128p pd=1.5u as=0.3808p ps=2.92u w=1.12u l=0.13u
X354 VSS.t705 a_3747_1047.t8 a_9751_1008# VSS.t704 sg13_lv_nmos ad=0.2516p pd=2.16u as=0.2516p ps=2.16u w=0.74u l=0.13u
X355 VSS.t551 DELAY_VBIASN a_9431_1842# VSS.t550 sg13_lv_nmos ad=0.2516p pd=2.16u as=0.1406p ps=1.12u w=0.74u l=0.6u
X356 a_19448_1044# a_18877_1842# VDD.t198 VDD.t4 sg13_lv_pmos ad=0.2128p pd=1.5u as=0.3808p ps=2.92u w=1.12u l=0.13u
X357 VSS.t368 a_11491_6228# a_12158_5867# VSS.t367 sg13_lv_nmos ad=0.1406p pd=1.12u as=0.2516p ps=2.16u w=0.74u l=0.13u
X358 a_13566_5328# a_14009_5084# a_13949_5496# VDD.t0 sg13_lv_pmos ad=79.8f pd=0.8u as=63f ps=0.72u w=0.42u l=0.13u
X359 VSS.t626 DELAY_VBIASN a_23111_1842# VSS.t625 sg13_lv_nmos ad=0.2516p pd=2.16u as=0.1406p ps=1.12u w=0.74u l=0.6u
X360 a_10430_1044# a_11924_1008# a_11848_1044# VDD.t4 sg13_lv_pmos ad=0.3808p pd=2.92u as=0.2128p ps=1.5u w=1.12u l=0.13u
X361 VDD.t320 DELAY_VBIASP.t3 a_27671_2470# VDD.t10 sg13_lv_pmos ad=0.3808p pd=2.92u as=0.2128p ps=1.5u w=1.12u l=0.6u
X362 a_6854_5986# a_6326_4590# VDD.t43 VDD.t0 sg13_lv_pmos ad=0.38p pd=2.38u as=0.38p ps=2.38u w=2u l=1u
X363 VSS.t569 DELAY_VBIASN DELAY_VBIASP.t2 VSS.t568 sg13_lv_nmos ad=0.2516p pd=2.16u as=0.6808p ps=3.32u w=0.74u l=0.6u
X364 a_25630_1044# a_26471_1008# a_26395_1044# VDD.t4 sg13_lv_pmos ad=0.3808p pd=2.92u as=0.2128p ps=1.5u w=1.12u l=0.13u
X365 VSS.t574 DELAY_VBIASN VSS.t576 VSS.t575 sg13_lv_nmos ad=1.33p pd=7.38u as=0 ps=0 w=7u l=7u
X366 a_10040_6305# a_9772_5843# a_9946_6305# VSS.t266 sg13_lv_nmos ad=60.89999f pd=0.71u as=0.1428p ps=1.52u w=0.42u l=0.13u
X367 a_7151_2470# a_6913_1842# a_7043_1842# VDD.t10 sg13_lv_pmos ad=0.2128p pd=1.5u as=0.3808p ps=2.92u w=1.12u l=0.2u
X368 a_16033_1842# a_15837_1842# VDD.t100 VDD.t10 sg13_lv_pmos ad=0.3808p pd=2.92u as=0.2128p ps=1.5u w=1.12u l=0.13u
X369 VDD.t185 a_6326_4590# a_6326_4590# VDD.t0 sg13_lv_pmos ad=0.38p pd=2.38u as=0.38p ps=2.38u w=2u l=1u
X370 VDD.t84 a_15964_289# a_16851_309# VDD.t4 sg13_lv_pmos ad=0.2086p pd=1.5u as=0.34p ps=2.68u w=1u l=0.13u
X371 VDD.t225 VSS.t119 VDD.t223 VDD.t4 sg13_lv_pmos ad=0.34p pd=2.68u as=0 ps=0 w=1u l=1u
X372 a_15464_3684# a_14851_5182# VSS.t226 VSS.t225 sg13_lv_nmos ad=0.2849p pd=2.25u as=0.2516p ps=2.16u w=0.74u l=0.13u
X373 VSS.t60 a_11603_1842# a_12037_1842# VSS.t213 sg13_lv_nmos ad=0.1406p pd=1.12u as=0.2516p ps=2.16u w=0.74u l=0.13u
X374 VSS.t127 VDD.t388 VSS.t125 VSS.t126 sg13_lv_nmos ad=79.8f pd=0.8u as=0 ps=0 w=0.42u l=1u
X375 VDD.t15 VSS.t84 VDD.t14 VDD.t4 sg13_lv_pmos ad=0.34p pd=2.68u as=0 ps=0 w=1u l=1u
X376 VDD.t149 a_5957_1842# a_6425_1044# VDD.t4 sg13_lv_pmos ad=0.252p pd=1.57u as=0.3808p ps=2.92u w=1.12u l=0.13u
X377 a_24393_1842# a_24197_1842# VSS.t15 VSS.t29 sg13_lv_nmos ad=0.2516p pd=2.16u as=0.1406p ps=1.12u w=0.74u l=0.13u
X378 a_3747_1047.t1 a_3449_1395# VSS.t165 VSS.t164 sg13_lv_nmos ad=0.1406p pd=1.12u as=0.1331p ps=1.12u w=0.74u l=0.13u
X379 a_1544_1044# MUX_SEL1 VSS.t444 VSS.t443 sg13_lv_nmos ad=0.2516p pd=2.16u as=0.2516p ps=2.16u w=0.74u l=0.13u
X380 VDD.t118 VSS.t114 VDD.t117 VDD.t4 sg13_lv_pmos ad=0.34p pd=2.68u as=0 ps=0 w=1u l=1u
X381 a_3171_1047.t0 a_2873_1395# VDD.t86 VDD.t4 sg13_lv_pmos ad=0.2128p pd=1.5u as=0.1918p ps=1.5u w=1.12u l=0.13u
X382 a_13470_1044# a_3747_1047.t6 a_15755_1044# VSS.t272 sg13_lv_nmos ad=0.2516p pd=2.16u as=0.1406p ps=1.12u w=0.74u l=0.13u
X383 VDD.t366 a_15464_3684# a_9712_3912# VSS.t681 sg13_lv_nmos ad=0.232p pd=2.08u as=0.136p ps=1.14u w=0.4u l=0.2u
X384 VDD.t133 a_5523_1842# a_5957_1842# VDD.t10 sg13_lv_pmos ad=0.2128p pd=1.5u as=0.3808p ps=2.92u w=1.12u l=0.13u
X385 VDD.t25 a_2297_1395# a_2595_1047.t0 VDD.t4 sg13_lv_pmos ad=0.4256p pd=3u as=0.2128p ps=1.5u w=1.12u l=0.13u
X386 VSS.t606 DELAY_VBIASN a_14751_1842# VSS.t605 sg13_lv_nmos ad=0.2516p pd=2.16u as=0.1406p ps=1.12u w=0.74u l=0.6u
X387 a_2967_1395# MUX_SEL1 a_2873_1395# VSS.t445 sg13_lv_nmos ad=0.1216p pd=1.02u as=0.2176p ps=1.96u w=0.64u l=0.13u
X388 a_4350_1044# a_2595_1047.t9 a_5115_1044# VSS.t642 sg13_lv_nmos ad=0.2516p pd=2.16u as=0.1406p ps=1.12u w=0.74u l=0.13u
X389 VDD.t349 a_2019_1047.t6 a_13444_1008# VDD.t4 sg13_lv_pmos ad=0.3808p pd=2.92u as=0.3808p ps=2.92u w=1.12u l=0.13u
X390 VSS.t235 a_2595_1047.t2 a_26471_1008# VSS.t234 sg13_lv_nmos ad=0.2516p pd=2.16u as=0.2516p ps=2.16u w=0.74u l=0.13u
X391 a_2595_311.t1 a_2297_331# VSS.t431 VSS.t430 sg13_lv_nmos ad=0.1406p pd=1.12u as=0.1331p ps=1.12u w=0.74u l=0.13u
X392 VSS.t428 a_14009_5878# a_14111_5878# VSS.t714 sg13_lv_nmos ad=2.39977p pd=15.495u as=0.2516p ps=2.16u w=0.74u l=0.13u
X393 VSS.t567 DELAY_VBIASN a_4111_1842# VSS.t566 sg13_lv_nmos ad=0.2516p pd=2.16u as=0.1406p ps=1.12u w=0.74u l=0.6u
X394 a_2297_1395# MUX_SEL0 VDD.t326 VDD.t4 sg13_lv_pmos ad=0.1596p pd=1.22u as=0.2856p ps=2.36u w=0.84u l=0.13u
X395 VSS.t421 a_16597_1842# a_17065_1044# VSS.t470 sg13_lv_nmos ad=0.1665p pd=1.19u as=0.2516p ps=2.16u w=0.74u l=0.13u
X396 VDD.t303 DELAY_VBIASP.t28 a_8671_2470# VDD.t10 sg13_lv_pmos ad=0.3808p pd=2.92u as=0.2128p ps=1.5u w=1.12u l=0.6u
X397 VDD.t122 VSS.t82 VDD.t164 VDD.t4 sg13_lv_pmos ad=0.19p pd=1.38u as=0 ps=0 w=1u l=1u
X398 VDD.t98 a_1544_1044# a_1721_1395# VDD.t4 sg13_lv_pmos ad=0.1918p pd=1.5u as=0.1596p ps=1.22u w=0.84u l=0.13u
X399 a_9444_4590# a_9444_4590# VSS.t264 VSS.t254 sg13_lv_nmos ad=0.38p pd=2.38u as=0.68p ps=4.68u w=2u l=1u
X400 a_4248_1044# a_4157_1313# VDD.t23 VDD.t4 sg13_lv_pmos ad=0.2128p pd=1.5u as=0.3808p ps=2.92u w=1.12u l=0.13u
X401 a_5778_3367# a_6126_3816# a_6326_4590# VSS.t690 sg13_lv_nmos ad=0.68p pd=4.68u as=0.38p ps=2.38u w=2u l=1u
X402 a_12471_2470# a_12233_1842# a_12363_1842# VDD.t10 sg13_lv_pmos ad=0.2128p pd=1.5u as=0.3808p ps=2.92u w=1.12u l=0.2u
X403 a_17031_1842# a_16793_1842# a_16923_1842# VSS.t414 sg13_lv_nmos ad=0.1406p pd=1.12u as=0.2516p ps=2.16u w=0.74u l=0.2u
X404 VSS.t485 a_1721_331# a_2019_311.t1 VSS.t484 sg13_lv_nmos ad=0.2812p pd=2.24u as=0.1406p ps=1.12u w=0.74u l=0.13u
X405 a_19550_1044# a_21911_1008# a_21835_1044# VDD.t4 sg13_lv_pmos ad=0.3808p pd=2.92u as=0.2128p ps=1.5u w=1.12u l=0.13u
X406 a_16108_289# a_26985_519# a_25630_1044# VDD.t4 sg13_lv_pmos ad=0.3808p pd=2.92u as=0.3808p ps=2.92u w=1.12u l=0.13u
X407 VSS.t433 a_2297_331# a_2595_311.t1 VSS.t432 sg13_lv_nmos ad=0.2812p pd=2.24u as=0.1406p ps=1.12u w=0.74u l=0.13u
X408 a_18795_1044# a_18585_1044# VSS.t230 VSS.t422 sg13_lv_nmos ad=0.1406p pd=1.12u as=0.1665p ps=1.19u w=0.74u l=0.13u
X409 a_9444_3912# a_6854_5454# a_9712_3912# VSS.t531 sg13_lv_nmos ad=0.68p pd=4.68u as=0.38p ps=2.38u w=2u l=1u
X410 a_20831_1842# a_20593_1842# a_20723_1842# VSS.t309 sg13_lv_nmos ad=0.1406p pd=1.12u as=0.2516p ps=2.16u w=0.74u l=0.2u
X411 VSS.t65 VDD.t400 VSS.t64 VSS.t63 sg13_lv_nmos ad=0.1428p pd=1.52u as=0 ps=0 w=0.42u l=1u
X412 VDD.t131 a_22677_1842# a_23145_1044# VDD.t4 sg13_lv_pmos ad=0.252p pd=1.57u as=0.3808p ps=2.92u w=1.12u l=0.13u
X413 VSS.t306 a_2595_1047.t5 a_17351_1008# VSS.t305 sg13_lv_nmos ad=0.2516p pd=2.16u as=0.2516p ps=2.16u w=0.74u l=0.13u
X414 a_5393_1842# a_5197_1842# VSS.t364 VSS.t521 sg13_lv_nmos ad=0.2516p pd=2.16u as=0.1406p ps=1.12u w=0.74u l=0.13u
X415 VSS.t616 DELAY_VBIASN a_17031_1842# VSS.t615 sg13_lv_nmos ad=0.2516p pd=2.16u as=0.1406p ps=1.12u w=0.74u l=0.6u
X416 a_25630_1044# a_3171_1047.t2 a_27048_1044# VSS.t314 sg13_lv_nmos ad=0.2516p pd=2.16u as=0.1406p ps=1.12u w=0.74u l=0.13u
X417 VDD.t57 VDD.t54 VDD.t56 VDD.t55 sg13_lv_pmos ad=0.3808p pd=2.92u as=0 ps=0 w=1.12u l=0.13u
X418 a_9953_1842# a_9757_1842# VDD.t147 VDD.t10 sg13_lv_pmos ad=0.3808p pd=2.92u as=0.2128p ps=1.5u w=1.12u l=0.13u
X419 VDD.t233 a_10843_1842# a_11277_1842# VDD.t10 sg13_lv_pmos ad=0.2128p pd=1.5u as=0.3808p ps=2.92u w=1.12u l=0.13u
X420 VSS.t635 a_26803_1842# a_27237_1842# VSS.t634 sg13_lv_nmos ad=0.1406p pd=1.12u as=0.2516p ps=2.16u w=0.74u l=0.13u
X421 a_4350_1044# a_3171_1047.t9 a_5768_1044# VSS.t236 sg13_lv_nmos ad=0.2516p pd=2.16u as=0.1406p ps=1.12u w=0.74u l=0.13u
X422 VDD.t241 a_12849_5867# a_13566_5328# VDD.t0 sg13_lv_pmos ad=0.1563p pd=1.22u as=0.147p ps=1.54u w=0.42u l=0.13u
X423 VDD.t62 VDD.t63 VDD.t64 VDD.t55 sg13_lv_pmos ad=0.2128p pd=1.5u as=0 ps=0 w=1.12u l=0.13u
X424 a_10430_1044# a_12791_1008# a_12715_1044# VDD.t4 sg13_lv_pmos ad=0.3808p pd=2.92u as=0.2128p ps=1.5u w=1.12u l=0.13u
X425 a_19311_1842# a_19073_1842# a_19203_1842# VSS.t369 sg13_lv_nmos ad=0.1406p pd=1.12u as=0.2516p ps=2.16u w=0.74u l=0.2u
X426 a_24875_1044# a_24665_1044# VDD.t22 VDD.t4 sg13_lv_pmos ad=0.2128p pd=1.5u as=0.252p ps=1.57u w=1.12u l=0.13u
X427 VDD.t202 a_2595_1047.t3 a_23431_1008# VDD.t4 sg13_lv_pmos ad=0.3808p pd=2.92u as=0.3808p ps=2.92u w=1.12u l=0.13u
X428 VDD.t36 a_14009_5878# a_14111_5878# VDD.t0 sg13_lv_pmos ad=1.10612p pd=6.66u as=0.3864p ps=2.93u w=1.12u l=0.13u
X429 a_13949_5914# a_13592_5871# VDD.t239 VDD.t0 sg13_lv_pmos ad=63f pd=0.72u as=0.1563p ps=1.22u w=0.42u l=0.13u
X430 VDD.t91 a_13557_1842# a_14025_1044# VDD.t4 sg13_lv_pmos ad=0.252p pd=1.57u as=0.3808p ps=2.92u w=1.12u l=0.13u
X431 a_23111_1842# a_22873_1842# a_23003_1842# VSS.t327 sg13_lv_nmos ad=0.1406p pd=1.12u as=0.2516p ps=2.16u w=0.74u l=0.2u
X432 VSS.t426 a_10649_5878# a_10751_5878# VSS.t463 sg13_lv_nmos ad=2.39977p pd=15.495u as=0.2516p ps=2.16u w=0.74u l=0.13u
X433 a_27671_2470# a_27433_1842# a_27563_1842# VDD.t10 sg13_lv_pmos ad=0.2128p pd=1.5u as=0.3808p ps=2.92u w=1.12u l=0.2u
X434 VSS.t232 a_17683_1842# a_18117_1842# VSS.t290 sg13_lv_nmos ad=0.1406p pd=1.12u as=0.2516p ps=2.16u w=0.74u l=0.13u
X435 VSS.t122 VDD.t389 VSS.t120 VSS.t121 sg13_lv_nmos ad=79.8f pd=0.8u as=0 ps=0 w=0.42u l=1u
X436 a_10713_1842# a_10517_1842# VSS.t223 VSS.t302 sg13_lv_nmos ad=0.2516p pd=2.16u as=0.1406p ps=1.12u w=0.74u l=0.13u
X437 VSS.t187 a_2019_1047.t8 a_7364_1008# VSS.t186 sg13_lv_nmos ad=0.2516p pd=2.16u as=0.2516p ps=2.16u w=0.74u l=0.13u
X438 VSS.t600 DELAY_VBIASN VSS.t598 VSS.t583 sg13_lv_nmos ad=1.33p pd=7.38u as=0 ps=0 w=7u l=7u
X439 VSS.t393 a_7803_1842# a_8237_1842# VSS.t392 sg13_lv_nmos ad=0.1406p pd=1.12u as=0.2516p ps=2.16u w=0.74u l=0.13u
X440 a_13592_5871# a_14111_5878# a_14851_6228# VSS.t1 sg13_lv_nmos ad=0.3473p pd=2.71u as=0.12665p ps=1.145u w=0.74u l=0.13u
X441 a_15304_4605# a_14851_6228# VSS.t5 VSS.t4 sg13_lv_nmos ad=0.2849p pd=2.25u as=0.2516p ps=2.16u w=0.74u l=0.13u
X442 VDD.t311 DELAY_VBIASP.t18 a_16271_2470# VDD.t10 sg13_lv_pmos ad=0.3808p pd=2.92u as=0.2128p ps=1.5u w=1.12u l=0.6u
X443 VSS.t117 VDD.t390 VSS.t115 VSS.t116 sg13_lv_nmos ad=79.8f pd=0.8u as=0 ps=0 w=0.42u l=1u
X444 VSS.t90 VDD.t395 VSS.t89 VSS.t88 sg13_lv_nmos ad=0.1428p pd=1.52u as=0 ps=0 w=0.42u l=1u
X445 a_6854_5454# a_6854_5454# a_9444_4590# VSS.t530 sg13_lv_nmos ad=0.38p pd=2.38u as=0.68p ps=4.68u w=2u l=1u
X446 VDD.t228 a_26043_1842# a_26477_1842# VDD.t10 sg13_lv_pmos ad=0.2128p pd=1.5u as=0.3808p ps=2.92u w=1.12u l=0.13u
X447 VDD.t79 DLL_RESETN a_10206_5835# VDD.t0 sg13_lv_pmos ad=0.1563p pd=1.22u as=0.147p ps=1.54u w=0.42u l=0.13u
X448 a_3543_331# MUX_SEL2 a_3449_331# VSS.t23 sg13_lv_nmos ad=0.1216p pd=1.02u as=0.2176p ps=1.96u w=0.64u l=0.13u
X449 a_22488_1044# a_21917_1842# VSS.t660 VSS.t659 sg13_lv_nmos ad=0.1406p pd=1.12u as=0.2516p ps=2.16u w=0.74u l=0.13u
X450 a_14851_5182# a_14009_5084# a_13592_5423# VDD.t0 sg13_lv_pmos ad=0.2048p pd=1.63u as=0.34p ps=2.68u w=1u l=0.13u
X451 VDD.t123 VSS.t77 VDD.t221 VDD.t4 sg13_lv_pmos ad=0.19p pd=1.38u as=0 ps=0 w=1u l=1u
X452 a_22590_1044# a_24084_1008# a_24008_1044# VDD.t4 sg13_lv_pmos ad=0.3808p pd=2.92u as=0.2128p ps=1.5u w=1.12u l=0.13u
X453 VDD.t296 DELAY_VBIASP.t13 a_20071_2470# VDD.t10 sg13_lv_pmos ad=0.3808p pd=2.92u as=0.2128p ps=1.5u w=1.12u l=0.6u
X454 a_9444_3912# a_9444_4590# VSS.t255 VSS.t254 sg13_lv_nmos ad=0.38p pd=2.38u as=0.68p ps=4.68u w=2u l=1u
X455 a_14751_1842# a_14513_1842# a_14643_1842# VSS.t339 sg13_lv_nmos ad=0.1406p pd=1.12u as=0.2516p ps=2.16u w=0.74u l=0.2u
X456 VSS.t437 a_2873_1395# a_3171_1047.t1 VSS.t436 sg13_lv_nmos ad=0.2812p pd=2.24u as=0.1406p ps=1.12u w=0.74u l=0.13u
X457 VDD.t277 VSS.t142 VDD.t350 VDD.t4 sg13_lv_pmos ad=0.19p pd=1.38u as=0 ps=0 w=1u l=1u
X458 a_25630_1044# a_27991_1008# a_27915_1044# VDD.t4 sg13_lv_pmos ad=0.3808p pd=2.92u as=0.2128p ps=1.5u w=1.12u l=0.13u
X459 VSS.t512 VSS.t512 VSS.t514 VSS.t513 sg13_lv_nmos ad=0.1406p pd=1.12u as=0 ps=0 w=0.74u l=0.13u
X460 a_4111_1842# REF_CLK a_4003_1842# VSS.t429 sg13_lv_nmos ad=0.1406p pd=1.12u as=0.2516p ps=2.16u w=0.74u l=0.2u
X461 a_8671_2470# a_8433_1842# a_8563_1842# VDD.t10 sg13_lv_pmos ad=0.2128p pd=1.5u as=0.3808p ps=2.92u w=1.12u l=0.2u
X462 a_17553_1842# a_17357_1842# VDD.t12 VDD.t10 sg13_lv_pmos ad=0.3808p pd=2.92u as=0.2128p ps=1.5u w=1.12u l=0.13u
X463 VSS.t35 a_1544_1044# a_2391_1395# VSS.t200 sg13_lv_nmos ad=0.1331p pd=1.12u as=0.1216p ps=1.02u w=0.64u l=0.13u
X464 VSS.t179 a_3747_311.t3 a_14825_519# VSS.t178 sg13_lv_nmos ad=0.2516p pd=2.16u as=0.2516p ps=2.16u w=0.74u l=0.13u
X465 VSS.t269 a_1256_289# a_2967_331# VSS.t338 sg13_lv_nmos ad=0.1331p pd=1.12u as=0.1216p ps=1.02u w=0.64u l=0.13u
X466 a_2019_1047.t1 a_1721_1395# VSS.t202 VSS.t464 sg13_lv_nmos ad=0.1406p pd=1.12u as=0.1331p ps=1.12u w=0.74u l=0.13u
X467 a_15964_289# a_15765_463# a_5731_289# VSS.t333 sg13_lv_nmos ad=0.2183p pd=1.33u as=0.2516p ps=2.16u w=0.74u l=0.13u
X468 a_13470_1044# a_2019_1047.t6 a_13368_1044# VSS.t662 sg13_lv_nmos ad=0.2516p pd=2.16u as=0.1406p ps=1.12u w=0.74u l=0.13u
X469 VDD.t44 VDD.t42 VDD.t43 VDD.t0 sg13_lv_pmos ad=0.68p pd=4.68u as=0 ps=0 w=2u l=1u
X470 VSS.t181 a_13123_1842# a_13557_1842# VSS.t668 sg13_lv_nmos ad=0.1406p pd=1.12u as=0.2516p ps=2.16u w=0.74u l=0.13u
X471 VDD.t116 VSS.t144 VDD.t115 VDD.t4 sg13_lv_pmos ad=0.34p pd=2.68u as=0 ps=0 w=1u l=1u
X472 VSS.t457 a_3171_1047.t3 a_24084_1008# VSS.t456 sg13_lv_nmos ad=0.2516p pd=2.16u as=0.2516p ps=2.16u w=0.74u l=0.13u
X473 a_25913_1842# a_25717_1842# VSS.t321 VSS.t359 sg13_lv_nmos ad=0.2516p pd=2.16u as=0.1406p ps=1.12u w=0.74u l=0.13u
X474 VDD.t36 a_10649_5878# a_10751_5878# VDD.t0 sg13_lv_pmos ad=1.10612p pd=6.66u as=0.3864p ps=2.93u w=1.12u l=0.13u
X475 a_21353_1842# a_21157_1842# VDD.t31 VDD.t10 sg13_lv_pmos ad=0.3808p pd=2.92u as=0.2128p ps=1.5u w=1.12u l=0.13u
X476 VSS.t125 VDD.t388 VSS.t124 VSS.t123 sg13_lv_nmos ad=0.1428p pd=1.52u as=0 ps=0 w=0.42u l=1u
X477 a_2297_331# MUX_SEL2 VDD.t18 VDD.t4 sg13_lv_pmos ad=0.1596p pd=1.22u as=0.2856p ps=2.36u w=0.84u l=0.13u
X478 VDD.t105 a_7043_1842# a_7477_1842# VDD.t10 sg13_lv_pmos ad=0.2128p pd=1.5u as=0.3808p ps=2.92u w=1.12u l=0.13u
X479 a_2873_331# MUX_SEL3 VDD.t6 VDD.t4 sg13_lv_pmos ad=0.1596p pd=1.22u as=0.2856p ps=2.36u w=0.84u l=0.13u
X480 a_10589_5914# a_10232_5871# VDD.t79 VDD.t0 sg13_lv_pmos ad=63f pd=0.72u as=0.1563p ps=1.22u w=0.42u l=0.13u
X481 a_8155_1044# a_7945_1044# VDD.t104 VDD.t4 sg13_lv_pmos ad=0.2128p pd=1.5u as=0.252p ps=1.57u w=1.12u l=0.13u
X482 a_13880_6292# a_13592_5871# a_13818_6292# VSS.t709 sg13_lv_nmos ad=0.1428p pd=1.52u as=37.8f ps=0.6u w=0.42u l=0.13u
X483 VSS.t230 a_18117_1842# a_18585_1044# VSS.t229 sg13_lv_nmos ad=0.1665p pd=1.19u as=0.2516p ps=2.16u w=0.74u l=0.13u
X484 a_27048_1044# a_26477_1842# VDD.t283 VDD.t4 sg13_lv_pmos ad=0.2128p pd=1.5u as=0.3808p ps=2.92u w=1.12u l=0.13u
X485 a_5768_1044# a_5197_1842# VDD.t332 VDD.t4 sg13_lv_pmos ad=0.2128p pd=1.5u as=0.3808p ps=2.92u w=1.12u l=0.13u
X486 a_10232_5871# a_10751_5878# a_11491_6228# VSS.t158 sg13_lv_nmos ad=0.3473p pd=2.71u as=0.12665p ps=1.145u w=0.74u l=0.13u
X487 a_12656_5864# DLL_RESETN VDD.t80 VDD.t0 sg13_lv_pmos ad=0.3808p pd=2.92u as=0.3808p ps=2.92u w=1.12u l=0.13u
X488 a_13991_2470# a_13753_1842# a_13883_1842# VDD.t10 sg13_lv_pmos ad=0.2128p pd=1.5u as=0.3808p ps=2.92u w=1.12u l=0.2u
X489 VSS.t454 a_3171_1047.t6 a_14964_1008# VSS.t453 sg13_lv_nmos ad=0.2516p pd=2.16u as=0.2516p ps=2.16u w=0.74u l=0.13u
X490 VDD.t333 a_2019_311.t2 a_17865_519# VDD.t4 sg13_lv_pmos ad=0.3808p pd=2.92u as=0.3808p ps=2.92u w=1.12u l=0.13u
X491 DELAY_OUT_LAST a_27997_1842# VSS.t176 VSS.t175 sg13_lv_nmos ad=0.2516p pd=2.16u as=0.1406p ps=1.12u w=0.74u l=0.13u
X492 a_11195_1044# a_10985_1044# VSS.t301 VSS.t680 sg13_lv_nmos ad=0.1406p pd=1.12u as=0.1665p ps=1.19u w=0.74u l=0.13u
X493 VDD.t22 a_24197_1842# a_24665_1044# VDD.t4 sg13_lv_pmos ad=0.252p pd=1.57u as=0.3808p ps=2.92u w=1.12u l=0.13u
X494 a_6913_1842# a_6717_1842# VSS.t26 VSS.t25 sg13_lv_nmos ad=0.2516p pd=2.16u as=0.1406p ps=1.12u w=0.74u l=0.13u
X495 VSS.t618 DELAY_VBIASN a_18551_1842# VSS.t617 sg13_lv_nmos ad=0.2516p pd=2.16u as=0.1406p ps=1.12u w=0.74u l=0.6u
X496 a_16510_1044# a_18004_1008# a_17928_1044# VDD.t4 sg13_lv_pmos ad=0.3808p pd=2.92u as=0.2128p ps=1.5u w=1.12u l=0.13u
X497 a_13592_5423# a_13566_5328# VSS.t332 VSS.t331 sg13_lv_nmos ad=0.2516p pd=2.16u as=0.1626p ps=1.415u w=0.74u l=0.13u
X498 VDD.t106 a_12363_1842# a_12797_1842# VDD.t10 sg13_lv_pmos ad=0.2128p pd=1.5u as=0.3808p ps=2.92u w=1.12u l=0.13u
X499 VSS.t10 MUX_SEL3 a_3543_331# VSS.t9 sg13_lv_nmos ad=0.1331p pd=1.12u as=0.1216p ps=1.02u w=0.64u l=0.13u
X500 a_22590_1044# a_2595_1047.t3 a_23355_1044# VSS.t351 sg13_lv_nmos ad=0.2516p pd=2.16u as=0.1406p ps=1.12u w=0.74u l=0.13u
X501 a_9712_3912# a_6854_5454# a_9444_3912# VSS.t530 sg13_lv_nmos ad=0.38p pd=2.38u as=0.68p ps=4.68u w=2u l=1u
X502 VSS.t537 DELAY_VBIASN a_22351_1842# VSS.t536 sg13_lv_nmos ad=0.2516p pd=2.16u as=0.1406p ps=1.12u w=0.74u l=0.6u
X503 VDD.t101 a_3171_1047.t4 a_21044_1008# VDD.t4 sg13_lv_pmos ad=0.3808p pd=2.92u as=0.3808p ps=2.92u w=1.12u l=0.13u
X504 VDD.t243 VSS.t137 VDD.t275 VDD.t4 sg13_lv_pmos ad=0.19p pd=1.38u as=0 ps=0 w=1u l=1u
X505 a_16271_2470# a_16033_1842# a_16163_1842# VDD.t10 sg13_lv_pmos ad=0.2128p pd=1.5u as=0.3808p ps=2.92u w=1.12u l=0.2u
X506 VDD.t251 VSS.t102 VDD.t278 VDD.t4 sg13_lv_pmos ad=0.19p pd=1.38u as=0 ps=0 w=1u l=1u
X507 a_19833_1842# a_19637_1842# VSS.t57 VSS.t685 sg13_lv_nmos ad=0.2516p pd=2.16u as=0.1406p ps=1.12u w=0.74u l=0.13u
X508 VDD.t76 a_2019_311.t3 a_5705_519# VDD.t4 sg13_lv_pmos ad=0.3808p pd=2.92u as=0.3808p ps=2.92u w=1.12u l=0.13u
X509 VDD.t1 a_14851_6228# a_15108_6109# VDD.t0 sg13_lv_pmos ad=0.2639p pd=1.81u as=79.8f ps=0.8u w=0.42u l=0.13u
X510 a_10520_6292# a_10232_5871# a_10458_6292# VSS.t322 sg13_lv_nmos ad=0.1428p pd=1.52u as=37.8f ps=0.6u w=0.42u l=0.13u
X511 a_15270_6305# a_12849_5867# VSS.t317 VSS.t1 sg13_lv_nmos ad=37.8f pd=0.6u as=79.8f ps=0.8u w=0.42u l=0.13u
X512 a_20071_2470# a_19833_1842# a_19963_1842# VDD.t10 sg13_lv_pmos ad=0.2128p pd=1.5u as=0.3808p ps=2.92u w=1.12u l=0.2u
X513 a_9193_1842# a_8997_1842# VSS.t40 VSS.t361 sg13_lv_nmos ad=0.2516p pd=2.16u as=0.1406p ps=1.12u w=0.74u l=0.13u
X514 a_24631_1842# a_24393_1842# a_24523_1842# VSS.t24 sg13_lv_nmos ad=0.1406p pd=1.12u as=0.2516p ps=2.16u w=0.74u l=0.2u
X515 VDD.t364 VSS.t104 VDD.t108 VDD.t4 sg13_lv_pmos ad=0.34p pd=2.68u as=0 ps=0 w=1u l=1u
X516 VSS.t720 a_2019_1047.t7 a_10404_1008# VSS.t719 sg13_lv_nmos ad=0.2516p pd=2.16u as=0.2516p ps=2.16u w=0.74u l=0.13u
X517 VSS.t580 DELAY_VBIASN VSS.t582 VSS.t581 sg13_lv_nmos ad=1.33p pd=7.38u as=0 ps=0 w=7u l=7u
X518 VDD.t154 a_14643_1842# a_15077_1842# VDD.t10 sg13_lv_pmos ad=0.2128p pd=1.5u as=0.3808p ps=2.92u w=1.12u l=0.13u
X519 VDD.t264 a_1544_289# a_2297_331# VDD.t4 sg13_lv_pmos ad=0.1918p pd=1.5u as=0.1596p ps=1.22u w=0.84u l=0.13u
X520 a_23633_1842# a_23437_1842# VSS.t282 VSS.t449 sg13_lv_nmos ad=0.2516p pd=2.16u as=0.1406p ps=1.12u w=0.74u l=0.13u
X521 VSS.t120 VDD.t389 VSS.t119 VSS.t118 sg13_lv_nmos ad=0.1428p pd=1.52u as=0 ps=0 w=0.42u l=1u
X522 a_2019_311.t0 a_1721_331# VDD.t329 VDD.t4 sg13_lv_pmos ad=0.2128p pd=1.5u as=0.1918p ps=1.5u w=1.12u l=0.13u
X523 VSS.t294 a_9323_1842# a_9757_1842# VSS.t341 sg13_lv_nmos ad=0.1406p pd=1.12u as=0.2516p ps=2.16u w=0.74u l=0.13u
X524 a_26395_1044# a_26185_1044# VSS.t358 VSS.t411 sg13_lv_nmos ad=0.1406p pd=1.12u as=0.1665p ps=1.19u w=0.74u l=0.13u
X525 VDD.t306 DELAY_VBIASP.t16 a_17791_2470# VDD.t10 sg13_lv_pmos ad=0.3808p pd=2.92u as=0.2128p ps=1.5u w=1.12u l=0.6u
X526 VSS.t277 a_3747_1047.t3 a_24951_1008# VSS.t276 sg13_lv_nmos ad=0.2516p pd=2.16u as=0.2516p ps=2.16u w=0.74u l=0.13u
X527 VSS.t85 VDD.t396 VSS.t84 VSS.t83 sg13_lv_nmos ad=0.1428p pd=1.52u as=0 ps=0 w=0.42u l=1u
X528 VSS.t115 VDD.t390 VSS.t114 VSS.t113 sg13_lv_nmos ad=0.1428p pd=1.52u as=0 ps=0 w=0.42u l=1u
X529 a_3747_1047.t0 a_3449_1395# VDD.t82 VDD.t4 sg13_lv_pmos ad=0.2128p pd=1.5u as=0.1918p ps=1.5u w=1.12u l=0.13u
X530 a_13368_1044# a_12797_1842# VDD.t174 VDD.t4 sg13_lv_pmos ad=0.2128p pd=1.5u as=0.3808p ps=2.92u w=1.12u l=0.13u
X531 a_24008_1044# a_23437_1842# VSS.t448 VSS.t447 sg13_lv_nmos ad=0.1406p pd=1.12u as=0.2516p ps=2.16u w=0.74u l=0.13u
X532 VDD.t314 DELAY_VBIASP.t11 a_21591_2470# VDD.t10 sg13_lv_pmos ad=0.3808p pd=2.92u as=0.2128p ps=1.5u w=1.12u l=0.6u
X533 a_15964_289# MUX_SEL4 a_5731_289# VDD.t4 sg13_lv_pmos ad=0.3304p pd=1.71u as=0.3808p ps=2.92u w=1.12u l=0.13u
X534 a_4350_1044# a_6711_1008# a_6635_1044# VDD.t4 sg13_lv_pmos ad=0.3808p pd=2.92u as=0.2128p ps=1.5u w=1.12u l=0.13u
X535 a_2873_1395# MUX_SEL1 VDD.t271 VDD.t4 sg13_lv_pmos ad=0.1596p pd=1.22u as=0.2856p ps=2.36u w=0.84u l=0.13u
X536 VSS.t332 a_12849_5867# a_13400_5105# VSS.t401 sg13_lv_nmos ad=0.1626p pd=1.415u as=60.89999f ps=0.71u w=0.42u l=0.13u
X537 a_1256_1044# MUX_SEL0 VSS.t478 VSS.t477 sg13_lv_nmos ad=0.2516p pd=2.16u as=0.2516p ps=2.16u w=0.74u l=0.13u
X538 VSS.t82 VDD.t397 VSS.t80 VSS.t81 sg13_lv_nmos ad=79.8f pd=0.8u as=0 ps=0 w=0.42u l=1u
X539 a_19550_1044# a_20391_1008# a_20315_1044# VDD.t4 sg13_lv_pmos ad=0.3808p pd=2.92u as=0.2128p ps=1.5u w=1.12u l=0.13u
X540 VDD.t72 VDD.t74 VDD.t75 VDD.t10 sg13_lv_pmos ad=0.2128p pd=1.5u as=0 ps=0 w=1.12u l=0.2u
X541 a_5631_1842# a_5393_1842# a_5523_1842# VSS.t184 sg13_lv_nmos ad=0.1406p pd=1.12u as=0.2516p ps=2.16u w=0.74u l=0.2u
X542 a_14513_1842# a_14317_1842# VSS.t652 VSS.t651 sg13_lv_nmos ad=0.2516p pd=2.16u as=0.1406p ps=1.12u w=0.74u l=0.13u
X543 VSS.t53 a_2595_311.t2 a_20905_519# VSS.t52 sg13_lv_nmos ad=0.2516p pd=2.16u as=0.2516p ps=2.16u w=0.74u l=0.13u
X544 VDD.t104 a_7477_1842# a_7945_1044# VDD.t4 sg13_lv_pmos ad=0.252p pd=1.57u as=0.3808p ps=2.92u w=1.12u l=0.13u
X545 a_13470_1044# a_3171_1047.t6 a_14888_1044# VSS.t452 sg13_lv_nmos ad=0.2516p pd=2.16u as=0.1406p ps=1.12u w=0.74u l=0.13u
X546 a_4633_1842# a_4437_1842# VSS.t42 VSS.t311 sg13_lv_nmos ad=0.2516p pd=2.16u as=0.1406p ps=1.12u w=0.74u l=0.13u
X547 a_1256_289# MUX_SEL2 VSS.t21 VSS.t20 sg13_lv_nmos ad=0.2516p pd=2.16u as=0.2516p ps=2.16u w=0.74u l=0.13u
X548 VSS.t250 a_2019_1047.t2 a_25604_1008# VSS.t249 sg13_lv_nmos ad=0.2516p pd=2.16u as=0.2516p ps=2.16u w=0.74u l=0.13u
X549 a_13019_5831# a_15688_5403# VDD.t112 VDD.t0 sg13_lv_pmos ad=0.3808p pd=2.92u as=0.2128p ps=1.5u w=1.12u l=0.13u
X550 VSS.t576 DELAY_VBIASN VSS.t578 VSS.t577 sg13_lv_nmos ad=1.33p pd=7.38u as=0 ps=0 w=7u l=7u
X551 a_16108_289# MUX_SEL4 a_15964_289# VSS.t438 sg13_lv_nmos ad=0.2516p pd=2.16u as=0.2183p ps=1.33u w=0.74u l=0.13u
X552 a_13400_6305# a_12355_5867# a_13306_6305# VSS.t673 sg13_lv_nmos ad=60.89999f pd=0.71u as=0.1428p ps=1.52u w=0.42u l=0.13u
X553 a_22873_1842# a_22677_1842# VDD.t145 VDD.t10 sg13_lv_pmos ad=0.3808p pd=2.92u as=0.2128p ps=1.5u w=1.12u l=0.13u
X554 a_21835_1044# a_21625_1044# VSS.t391 VSS.t645 sg13_lv_nmos ad=0.1406p pd=1.12u as=0.1665p ps=1.19u w=0.74u l=0.13u
X555 VSS.t199 a_2595_1047.t4 a_20391_1008# VSS.t198 sg13_lv_nmos ad=0.2516p pd=2.16u as=0.2516p ps=2.16u w=0.74u l=0.13u
X556 a_9675_1044# a_9465_1044# VDD.t199 VDD.t4 sg13_lv_pmos ad=0.2128p pd=1.5u as=0.252p ps=1.57u w=1.12u l=0.13u
X557 VSS.t301 a_10517_1842# a_10985_1044# VSS.t300 sg13_lv_nmos ad=0.1665p pd=1.19u as=0.2516p ps=2.16u w=0.74u l=0.13u
X558 VDD.t94 a_2595_1047.t8 a_8231_1008# VDD.t4 sg13_lv_pmos ad=0.3808p pd=2.92u as=0.3808p ps=2.92u w=1.12u l=0.13u
X559 a_18551_1842# a_18313_1842# a_18443_1842# VSS.t689 sg13_lv_nmos ad=0.1406p pd=1.12u as=0.2516p ps=2.16u w=0.74u l=0.2u
X560 a_12943_5867# a_12656_5864# a_12849_5867# VDD.t0 sg13_lv_pmos ad=0.2128p pd=1.5u as=0.3808p ps=2.92u w=1.12u l=0.13u
X561 a_13566_5835# a_14009_5878# a_13949_5914# VDD.t0 sg13_lv_pmos ad=79.8f pd=0.8u as=63f ps=0.72u w=0.42u l=0.13u
X562 a_22351_1842# a_22113_1842# a_22243_1842# VSS.t527 sg13_lv_nmos ad=0.1406p pd=1.12u as=0.2516p ps=2.16u w=0.74u l=0.2u
X563 VSS.t330 a_3747_1047.t5 a_18871_1008# VSS.t329 sg13_lv_nmos ad=0.2516p pd=2.16u as=0.2516p ps=2.16u w=0.74u l=0.13u
X564 VSS.t17 a_16923_1842# a_17357_1842# VSS.t38 sg13_lv_nmos ad=0.1406p pd=1.12u as=0.2516p ps=2.16u w=0.74u l=0.13u
X565 VDD.t337 a_3171_311.t2 a_23945_519# VDD.t4 sg13_lv_pmos ad=0.3808p pd=2.92u as=0.3808p ps=2.92u w=1.12u l=0.13u
X566 a_2019_311.t1 a_1721_331# VSS.t483 VSS.t482 sg13_lv_nmos ad=0.1406p pd=1.12u as=0.1331p ps=1.12u w=0.74u l=0.13u
X567 a_25153_1842# a_24957_1842# VDD.t143 VDD.t10 sg13_lv_pmos ad=0.3808p pd=2.92u as=0.2128p ps=1.5u w=1.12u l=0.13u
X568 a_17928_1044# a_17357_1842# VSS.t19 VSS.t18 sg13_lv_nmos ad=0.1406p pd=1.12u as=0.2516p ps=2.16u w=0.74u l=0.13u
X569 a_12715_1044# a_12505_1044# VSS.t62 VSS.t398 sg13_lv_nmos ad=0.1406p pd=1.12u as=0.1665p ps=1.19u w=0.74u l=0.13u
X570 a_13880_6292# a_14111_5878# a_13566_5835# VSS.t0 sg13_lv_nmos ad=0.2373p pd=1.97u as=79.8f ps=0.8u w=0.42u l=0.13u
X571 a_15053_5990# a_14111_5878# a_14851_6228# VDD.t0 sg13_lv_pmos ad=93.45f pd=0.865u as=0.2048p ps=1.63u w=0.42u l=0.13u
X572 VDD.t268 MUX_SEL4 a_15765_463# VDD.t4 sg13_lv_pmos ad=0.3808p pd=2.92u as=0.3808p ps=2.92u w=1.12u l=0.13u
X573 a_19550_1044# a_3171_1047.t4 a_20968_1044# VSS.t207 sg13_lv_nmos ad=0.2516p pd=2.16u as=0.1406p ps=1.12u w=0.74u l=0.13u
X574 VSS.t543 DELAY_VBIASN a_10951_1842# VSS.t542 sg13_lv_nmos ad=0.2516p pd=2.16u as=0.1406p ps=1.12u w=0.74u l=0.6u
X575 a_19550_1044# a_19524_1008# a_19448_1044# VDD.t4 sg13_lv_pmos ad=0.3808p pd=2.92u as=0.2128p ps=1.5u w=1.12u l=0.13u
X576 a_7288_1044# a_6717_1842# VSS.t28 VSS.t27 sg13_lv_nmos ad=0.1406p pd=1.12u as=0.2516p ps=2.16u w=0.74u l=0.13u
X577 a_12355_5867# a_12158_5867# VSS.t368 VSS.t631 sg13_lv_nmos ad=0.2516p pd=2.16u as=0.1406p ps=1.12u w=0.74u l=0.13u
X578 VSS.t44 a_20723_1842# a_21157_1842# VSS.t43 sg13_lv_nmos ad=0.1406p pd=1.12u as=0.2516p ps=2.16u w=0.74u l=0.13u
X579 VDD.t3 a_14851_6228# a_15688_5867# VDD.t0 sg13_lv_pmos ad=0.2128p pd=1.5u as=0.3864p ps=2.93u w=1.12u l=0.13u
X580 a_1544_289# MUX_SEL3 VSS.t7 VSS.t6 sg13_lv_nmos ad=0.2516p pd=2.16u as=0.2516p ps=2.16u w=0.74u l=0.13u
X581 a_13470_1044# a_14311_1008# a_14235_1044# VDD.t4 sg13_lv_pmos ad=0.3808p pd=2.92u as=0.2128p ps=1.5u w=1.12u l=0.13u
X582 a_22590_1044# a_3747_1047.t3 a_24875_1044# VSS.t275 sg13_lv_nmos ad=0.2516p pd=2.16u as=0.1406p ps=1.12u w=0.74u l=0.13u
X583 VSS.t565 DELAY_VBIASN a_23871_1842# VSS.t564 sg13_lv_nmos ad=0.2516p pd=2.16u as=0.1406p ps=1.12u w=0.74u l=0.6u
X584 VDD.t346 a_2019_1047.t3 a_22564_1008# VDD.t4 sg13_lv_pmos ad=0.3808p pd=2.92u as=0.3808p ps=2.92u w=1.12u l=0.13u
X585 VSS.t358 a_25717_1842# a_26185_1044# VSS.t357 sg13_lv_nmos ad=0.1665p pd=1.19u as=0.2516p ps=2.16u w=0.74u l=0.13u
X586 a_13231_1842# a_12993_1842# a_13123_1842# VSS.t434 sg13_lv_nmos ad=0.1406p pd=1.12u as=0.2516p ps=2.16u w=0.74u l=0.2u
X587 VSS.t77 VDD.t398 VSS.t75 VSS.t76 sg13_lv_nmos ad=79.8f pd=0.8u as=0 ps=0 w=0.42u l=1u
X588 a_17791_2470# a_17553_1842# a_17683_1842# VDD.t10 sg13_lv_pmos ad=0.2128p pd=1.5u as=0.3808p ps=2.92u w=1.12u l=0.2u
X589 VSS.t313 a_4437_1842# a_4905_1044# VSS.t312 sg13_lv_nmos ad=0.1665p pd=1.19u as=0.2516p ps=2.16u w=0.74u l=0.13u
X590 VDD.t244 VSS.t134 VDD.t243 VDD.t4 sg13_lv_pmos ad=0.34p pd=2.68u as=0 ps=0 w=1u l=1u
X591 a_12233_1842# a_12037_1842# VSS.t60 VSS.t59 sg13_lv_nmos ad=0.2516p pd=2.16u as=0.1406p ps=1.12u w=0.74u l=0.13u
X592 VDD.t36 a_9547_6172# a_9547_5942# VDD.t0 sg13_lv_pmos ad=1.10612p pd=6.66u as=0.2442p ps=2.06u w=0.66u l=0.13u
X593 a_15108_5325# a_14851_5182# a_15270_5105# VSS.t224 sg13_lv_nmos ad=0.1428p pd=1.52u as=37.8f ps=0.6u w=0.42u l=0.13u
X594 VSS.t167 a_3449_1395# a_3747_1047.t1 VSS.t166 sg13_lv_nmos ad=0.2812p pd=2.24u as=0.1406p ps=1.12u w=0.74u l=0.13u
X595 VDD.t252 VSS.t99 VDD.t251 VDD.t4 sg13_lv_pmos ad=0.34p pd=2.68u as=0 ps=0 w=1u l=1u
X596 VDD.t201 VSS.t112 VDD.t200 VDD.t4 sg13_lv_pmos ad=0.19p pd=1.38u as=0 ps=0 w=1u l=1u
X597 VSS.t142 VDD.t385 VSS.t140 VSS.t141 sg13_lv_nmos ad=79.8f pd=0.8u as=0 ps=0 w=0.42u l=1u
X598 VSS.t375 a_3171_1047.t8 a_8884_1008# VSS.t374 sg13_lv_nmos ad=0.2516p pd=2.16u as=0.2516p ps=2.16u w=0.74u l=0.13u
X599 a_21591_2470# a_21353_1842# a_21483_1842# VDD.t10 sg13_lv_pmos ad=0.2128p pd=1.5u as=0.3808p ps=2.92u w=1.12u l=0.2u
X600 VDD.t267 a_2873_1395# a_3171_1047.t0 VDD.t4 sg13_lv_pmos ad=0.4256p pd=3u as=0.2128p ps=1.5u w=1.12u l=0.13u
X601 a_6153_1842# a_5957_1842# VDD.t133 VDD.t10 sg13_lv_pmos ad=0.3808p pd=2.92u as=0.2128p ps=1.5u w=1.12u l=0.13u
X602 VDD.t227 a_16163_1842# a_16597_1842# VDD.t10 sg13_lv_pmos ad=0.2128p pd=1.5u as=0.3808p ps=2.92u w=1.12u l=0.13u
X603 a_3543_1395# MUX_SEL0 a_3449_1395# VSS.t480 sg13_lv_nmos ad=0.1216p pd=1.02u as=0.2176p ps=1.96u w=0.64u l=0.13u
X604 VDD.t24 a_1544_1044# a_2297_1395# VDD.t4 sg13_lv_pmos ad=0.1918p pd=1.5u as=0.1596p ps=1.22u w=0.84u l=0.13u
X605 VDD.t305 DELAY_VBIASP.t26 a_10191_2470# VDD.t10 sg13_lv_pmos ad=0.3808p pd=2.92u as=0.2128p ps=1.5u w=1.12u l=0.6u
X606 a_17275_1044# a_17065_1044# VDD.t259 VDD.t4 sg13_lv_pmos ad=0.2128p pd=1.5u as=0.252p ps=1.57u w=1.12u l=0.13u
X607 a_2019_1047.t0 a_1721_1395# VDD.t98 VDD.t4 sg13_lv_pmos ad=0.2128p pd=1.5u as=0.1918p ps=1.5u w=1.12u l=0.13u
X608 a_27915_1044# a_27705_1044# VSS.t12 VSS.t11 sg13_lv_nmos ad=0.1406p pd=1.12u as=0.1665p ps=1.19u w=0.74u l=0.13u
X609 VSS.t628 DELAY_VBIASN a_26151_1842# VSS.t627 sg13_lv_nmos ad=0.2516p pd=2.16u as=0.1406p ps=1.12u w=0.74u l=0.6u
X610 VDD.t138 a_3747_1047.t6 a_15831_1008# VDD.t4 sg13_lv_pmos ad=0.3808p pd=2.92u as=0.3808p ps=2.92u w=1.12u l=0.13u
X611 VDD.t128 a_19963_1842# a_20397_1842# VDD.t10 sg13_lv_pmos ad=0.2128p pd=1.5u as=0.3808p ps=2.92u w=1.12u l=0.13u
X612 VSS.t145 VDD.t384 VSS.t144 VSS.t143 sg13_lv_nmos ad=0.1428p pd=1.52u as=0 ps=0 w=0.42u l=1u
X613 VSS.t563 DELAY_VBIASN a_4871_1842# VSS.t562 sg13_lv_nmos ad=0.2516p pd=2.16u as=0.1406p ps=1.12u w=0.74u l=0.6u
X614 a_14888_1044# a_14317_1842# VDD.t343 VDD.t4 sg13_lv_pmos ad=0.2128p pd=1.5u as=0.3808p ps=2.92u w=1.12u l=0.13u
X615 a_4350_1044# a_4324_1008# a_4248_1044# VDD.t4 sg13_lv_pmos ad=0.3808p pd=2.92u as=0.2128p ps=1.5u w=1.12u l=0.13u
X616 a_1256_289# MUX_SEL2 VDD.t16 VDD.t4 sg13_lv_pmos ad=0.3808p pd=2.92u as=0.3808p ps=2.92u w=1.12u l=0.13u
X617 VSS.t518 VSS.t515 VSS.t517 VSS.t516 sg13_lv_nmos ad=0.2516p pd=2.16u as=0 ps=0 w=0.74u l=0.6u
X618 a_16108_289# a_15765_463# a_15964_289# VDD.t4 sg13_lv_pmos ad=0.3808p pd=2.92u as=0.3304p ps=1.71u w=1.12u l=0.13u
X619 VDD.t239 a_12849_5867# a_13566_5835# VDD.t0 sg13_lv_pmos ad=0.1563p pd=1.22u as=0.147p ps=1.54u w=0.42u l=0.13u
X620 VSS.t572 DELAY_VBIASN VSS.t571 VSS.t570 sg13_lv_nmos ad=2.38p pd=14.68u as=0 ps=0 w=7u l=7u
X621 a_11473_1842# a_11277_1842# VDD.t233 VDD.t10 sg13_lv_pmos ad=0.3808p pd=2.92u as=0.2128p ps=1.5u w=1.12u l=0.13u
X622 VDD.t199 a_8997_1842# a_9465_1044# VDD.t4 sg13_lv_pmos ad=0.252p pd=1.57u as=0.3808p ps=2.92u w=1.12u l=0.13u
X623 a_27433_1842# a_27237_1842# VSS.t635 VSS.t667 sg13_lv_nmos ad=0.2516p pd=2.16u as=0.1406p ps=1.12u w=0.74u l=0.13u
X624 a_2391_331# MUX_SEL2 a_2297_331# VSS.t22 sg13_lv_nmos ad=0.1216p pd=1.02u as=0.2176p ps=1.96u w=0.64u l=0.13u
X625 a_2967_331# MUX_SEL3 a_2873_331# VSS.t8 sg13_lv_nmos ad=0.1216p pd=1.02u as=0.2176p ps=1.96u w=0.64u l=0.13u
X626 VDD.t378 a_2019_1047.t5 a_16484_1008# VDD.t4 sg13_lv_pmos ad=0.3808p pd=2.92u as=0.3808p ps=2.92u w=1.12u l=0.13u
X627 a_7390_1044# a_2595_1047.t8 a_8155_1044# VSS.t191 sg13_lv_nmos ad=0.2516p pd=2.16u as=0.1406p ps=1.12u w=0.74u l=0.13u
X628 VSS.t696 a_6126_3816# a_5974_5723# VSS.t58 sg13_lv_nmos ad=0.68p pd=4.68u as=0.38p ps=2.38u w=2u l=1u
X629 VSS.t608 DELAY_VBIASN a_7151_1842# VSS.t607 sg13_lv_nmos ad=0.2516p pd=2.16u as=0.1406p ps=1.12u w=0.74u l=0.6u
X630 VDD.t126 a_3171_1047.t9 a_5844_1008# VDD.t4 sg13_lv_pmos ad=0.3808p pd=2.92u as=0.3808p ps=2.92u w=1.12u l=0.13u
X631 VDD.t293 DELAY_VBIASP.t6 a_25391_2470# VDD.t10 sg13_lv_pmos ad=0.3808p pd=2.92u as=0.2128p ps=1.5u w=1.12u l=0.6u
X632 VDD.t95 a_2595_1047.t7 a_11271_1008# VDD.t4 sg13_lv_pmos ad=0.3808p pd=2.92u as=0.3808p ps=2.92u w=1.12u l=0.13u
X633 VDD.t179 VSS.t92 VDD.t218 VDD.t4 sg13_lv_pmos ad=0.19p pd=1.38u as=0 ps=0 w=1u l=1u
X634 VSS.t62 a_12037_1842# a_12505_1044# VSS.t61 sg13_lv_nmos ad=0.1665p pd=1.19u as=0.2516p ps=2.16u w=0.74u l=0.13u
X635 VDD.t373 a_3747_1047.t8 a_9751_1008# VDD.t4 sg13_lv_pmos ad=0.3808p pd=2.92u as=0.3808p ps=2.92u w=1.12u l=0.13u
X636 a_12943_5867# a_13121_5831# VDD.t140 VDD.t0 sg13_lv_pmos ad=0.3808p pd=2.92u as=0.2128p ps=1.5u w=1.12u l=0.13u
X637 a_11748_6109# a_11491_6228# a_11910_6305# VSS.t158 sg13_lv_nmos ad=0.1428p pd=1.52u as=37.8f ps=0.6u w=0.42u l=0.13u
X638 a_9431_1842# a_9193_1842# a_9323_1842# VSS.t251 sg13_lv_nmos ad=0.1406p pd=1.12u as=0.2516p ps=2.16u w=0.74u l=0.2u
X639 a_18313_1842# a_18117_1842# VSS.t232 VSS.t231 sg13_lv_nmos ad=0.2516p pd=2.16u as=0.1406p ps=1.12u w=0.74u l=0.13u
X640 MUX_OUT a_16851_309# VSS.t169 VSS.t168 sg13_lv_nmos ad=0.1406p pd=1.12u as=0.1371p ps=1.12u w=0.74u l=0.13u
X641 a_10232_5871# a_10206_5835# VDD.t77 VDD.t0 sg13_lv_pmos ad=0.34p pd=2.68u as=0.36237p ps=2.605u w=1u l=0.13u
X642 a_14851_5182# a_14009_5084# a_14757_5182# VSS.t641 sg13_lv_nmos ad=0.12665p pd=1.145u as=0.1428p ps=1.52u w=0.42u l=0.13u
X643 VSS.t137 VDD.t386 VSS.t135 VSS.t136 sg13_lv_nmos ad=79.8f pd=0.8u as=0 ps=0 w=0.42u l=1u
X644 a_23871_1842# a_23633_1842# a_23763_1842# VSS.t299 sg13_lv_nmos ad=0.1406p pd=1.12u as=0.2516p ps=2.16u w=0.74u l=0.2u
X645 a_8433_1842# a_8237_1842# VSS.t393 VSS.t648 sg13_lv_nmos ad=0.2516p pd=2.16u as=0.1406p ps=1.12u w=0.74u l=0.13u
X646 VSS.t324 a_18443_1842# a_18877_1842# VSS.t323 sg13_lv_nmos ad=0.1406p pd=1.12u as=0.2516p ps=2.16u w=0.74u l=0.13u
X647 VSS.t102 VDD.t393 VSS.t100 VSS.t101 sg13_lv_nmos ad=79.8f pd=0.8u as=0 ps=0 w=0.42u l=1u
X648 VSS.t694 a_6126_3816# a_5974_5723# VSS.t58 sg13_lv_nmos ad=0.68p pd=4.68u as=0.38p ps=2.38u w=2u l=1u
X649 a_22113_1842# a_21917_1842# VSS.t451 VSS.t661 sg13_lv_nmos ad=0.2516p pd=2.16u as=0.1406p ps=1.12u w=0.74u l=0.13u
X650 a_1544_289# MUX_SEL3 VDD.t7 VDD.t4 sg13_lv_pmos ad=0.3808p pd=2.92u as=0.3808p ps=2.92u w=1.12u l=0.13u
X651 VDD.t53 VDD.t45 VDD.t52 VDD.t0 sg13_lv_pmos ad=0.38p pd=2.38u as=0 ps=0 w=2u l=1u
X652 a_26673_1842# a_26477_1842# VDD.t228 VDD.t10 sg13_lv_pmos ad=0.3808p pd=2.92u as=0.2128p ps=1.5u w=1.12u l=0.13u
X653 a_10328_1044# a_9757_1842# VSS.t296 VSS.t295 sg13_lv_nmos ad=0.1406p pd=1.12u as=0.2516p ps=2.16u w=0.74u l=0.13u
X654 VSS.t105 VDD.t392 VSS.t104 VSS.t103 sg13_lv_nmos ad=0.1428p pd=1.52u as=0 ps=0 w=0.42u l=1u
X655 a_22590_1044# a_2019_1047.t3 a_22488_1044# VSS.t656 sg13_lv_nmos ad=0.2516p pd=2.16u as=0.1406p ps=1.12u w=0.74u l=0.13u
X656 VSS.t533 DELAY_VBIASN a_12471_1842# VSS.t532 sg13_lv_nmos ad=0.2516p pd=2.16u as=0.1406p ps=1.12u w=0.74u l=0.6u
X657 a_8808_1044# a_8237_1842# VSS.t647 VSS.t646 sg13_lv_nmos ad=0.1406p pd=1.12u as=0.2516p ps=2.16u w=0.74u l=0.13u
X658 VSS.t289 a_22243_1842# a_22677_1842# VSS.t356 sg13_lv_nmos ad=0.1406p pd=1.12u as=0.2516p ps=2.16u w=0.74u l=0.13u
X659 VDD.t302 DELAY_VBIASP.t31 a_6391_2470# VDD.t10 sg13_lv_pmos ad=0.3808p pd=2.92u as=0.2128p ps=1.5u w=1.12u l=0.6u
X660 a_13470_1044# a_15831_1008# a_15755_1044# VDD.t4 sg13_lv_pmos ad=0.3808p pd=2.92u as=0.2128p ps=1.5u w=1.12u l=0.13u
X661 a_1544_1044# MUX_SEL1 VDD.t270 VDD.t4 sg13_lv_pmos ad=0.3808p pd=2.92u as=0.3808p ps=2.92u w=1.12u l=0.13u
X662 VDD.t313 DELAY_VBIASP.t12 a_20831_2470# VDD.t10 sg13_lv_pmos ad=0.3808p pd=2.92u as=0.2128p ps=1.5u w=1.12u l=0.6u
X663 VDD.t125 a_2595_1047.t2 a_26471_1008# VDD.t4 sg13_lv_pmos ad=0.3808p pd=2.92u as=0.3808p ps=2.92u w=1.12u l=0.13u
X664 a_4350_1044# a_5191_1008# a_5115_1044# VDD.t4 sg13_lv_pmos ad=0.3808p pd=2.92u as=0.2128p ps=1.5u w=1.12u l=0.13u
X665 VDD.t259 a_16597_1842# a_17065_1044# VDD.t4 sg13_lv_pmos ad=0.252p pd=1.57u as=0.3808p ps=2.92u w=1.12u l=0.13u
X666 VSS.t12 a_27237_1842# a_27705_1044# VSS.t666 sg13_lv_nmos ad=0.1665p pd=1.19u as=0.2516p ps=2.16u w=0.74u l=0.13u
X667 VSS.t571 DELAY_VBIASN VSS.t574 VSS.t573 sg13_lv_nmos ad=1.33p pd=7.38u as=0 ps=0 w=7u l=7u
X668 a_10191_2470# a_9953_1842# a_10083_1842# VDD.t10 sg13_lv_pmos ad=0.2128p pd=1.5u as=0.3808p ps=2.92u w=1.12u l=0.2u
X669 a_2595_1047.t1 a_2297_1395# VSS.t35 VSS.t34 sg13_lv_nmos ad=0.1406p pd=1.12u as=0.1331p ps=1.12u w=0.74u l=0.13u
X670 a_26151_1842# a_25913_1842# a_26043_1842# VSS.t461 sg13_lv_nmos ad=0.1406p pd=1.12u as=0.2516p ps=2.16u w=0.74u l=0.2u
X671 VSS.t526 a_2019_311.t2 a_17865_519# VSS.t525 sg13_lv_nmos ad=0.2516p pd=2.16u as=0.2516p ps=2.16u w=0.74u l=0.13u
X672 VSS.t431 a_1544_289# a_2391_331# VSS.t672 sg13_lv_nmos ad=0.1331p pd=1.12u as=0.1216p ps=1.02u w=0.64u l=0.13u
X673 a_4871_1842# a_4633_1842# a_4763_1842# VSS.t382 sg13_lv_nmos ad=0.1406p pd=1.12u as=0.2516p ps=2.16u w=0.74u l=0.2u
X674 a_13753_1842# a_13557_1842# VSS.t181 VSS.t180 sg13_lv_nmos ad=0.2516p pd=2.16u as=0.1406p ps=1.12u w=0.74u l=0.13u
X675 a_1815_1395# a_1256_1044# a_1721_1395# VSS.t172 sg13_lv_nmos ad=0.1216p pd=1.02u as=0.2176p ps=1.96u w=0.64u l=0.13u
X676 a_7673_1842# a_7477_1842# VDD.t105 VDD.t10 sg13_lv_pmos ad=0.3808p pd=2.92u as=0.2128p ps=1.5u w=1.12u l=0.13u
X677 VDD.t201 VSS.t109 VDD.t250 VDD.t4 sg13_lv_pmos ad=0.34p pd=2.68u as=0 ps=0 w=1u l=1u
X678 a_1721_331# a_1256_289# VDD.t171 VDD.t4 sg13_lv_pmos ad=0.1596p pd=1.22u as=0.2856p ps=2.36u w=0.84u l=0.13u
X679 VSS.t286 a_24523_1842# a_24957_1842# VSS.t400 sg13_lv_nmos ad=0.1406p pd=1.12u as=0.2516p ps=2.16u w=0.74u l=0.13u
X680 a_6635_1044# a_6425_1044# VSS.t298 VSS.t297 sg13_lv_nmos ad=0.1406p pd=1.12u as=0.1665p ps=1.19u w=0.74u l=0.13u
X681 VDD.t36 a_15108_5325# a_15053_5420# VDD.t0 sg13_lv_pmos ad=1.10612p pd=6.66u as=93.45f ps=0.865u w=0.42u l=0.13u
X682 VSS.t644 a_2595_1047.t9 a_5191_1008# VSS.t643 sg13_lv_nmos ad=0.2516p pd=2.16u as=0.2516p ps=2.16u w=0.74u l=0.13u
X683 a_20315_1044# a_20105_1044# VSS.t687 VSS.t706 sg13_lv_nmos ad=0.1406p pd=1.12u as=0.1665p ps=1.19u w=0.74u l=0.13u
X684 VDD.t292 DELAY_VBIASP.t24 a_11711_2470# VDD.t10 sg13_lv_pmos ad=0.3808p pd=2.92u as=0.2128p ps=1.5u w=1.12u l=0.6u
X685 a_18795_1044# a_18585_1044# VDD.t113 VDD.t4 sg13_lv_pmos ad=0.2128p pd=1.5u as=0.252p ps=1.57u w=1.12u l=0.13u
X686 a_25528_1044# a_24957_1842# VSS.t284 VSS.t283 sg13_lv_nmos ad=0.1406p pd=1.12u as=0.2516p ps=2.16u w=0.74u l=0.13u
X687 a_5778_3367# a_6126_3816# a_6326_4590# VSS.t690 sg13_lv_nmos ad=0.68p pd=4.68u as=0.38p ps=2.38u w=2u l=1u
X688 VSS.t596 DELAY_VBIASN VSS.t594 VSS.t579 sg13_lv_nmos ad=1.33p pd=7.38u as=0 ps=0 w=7u l=7u
X689 VSS.t630 DELAY_VBIASN a_27671_1842# VSS.t629 sg13_lv_nmos ad=0.2516p pd=2.16u as=0.1406p ps=1.12u w=0.74u l=0.6u
X690 a_5731_289# a_3747_311.t3 a_13470_1044# VSS.t177 sg13_lv_nmos ad=0.2516p pd=2.16u as=0.2516p ps=2.16u w=0.74u l=0.13u
X691 a_25630_1044# a_27124_1008# a_27048_1044# VDD.t4 sg13_lv_pmos ad=0.3808p pd=2.92u as=0.2128p ps=1.5u w=1.12u l=0.13u
X692 VDD.t153 a_2595_1047.t5 a_17351_1008# VDD.t4 sg13_lv_pmos ad=0.3808p pd=2.92u as=0.3808p ps=2.92u w=1.12u l=0.13u
X693 VSS.t280 a_13121_5831# a_6854_5986# VDD.t55 sg13_lv_pmos ad=0.232p pd=2.08u as=0.136p ps=1.14u w=0.4u l=0.2u
X694 VDD.t274 a_21483_1842# a_21917_1842# VDD.t10 sg13_lv_pmos ad=0.2128p pd=1.5u as=0.3808p ps=2.92u w=1.12u l=0.13u
X695 a_4350_1044# a_5844_1008# a_5768_1044# VDD.t4 sg13_lv_pmos ad=0.3808p pd=2.92u as=0.2128p ps=1.5u w=1.12u l=0.13u
X696 VSS.t171 a_16851_309# MUX_OUT VSS.t170 sg13_lv_nmos ad=0.2516p pd=2.16u as=0.1406p ps=1.12u w=0.74u l=0.13u
X697 VSS.t155 a_2019_311.t3 a_5705_519# VSS.t154 sg13_lv_nmos ad=0.2516p pd=2.16u as=0.2516p ps=2.16u w=0.74u l=0.13u
X698 VDD.t329 a_1544_289# a_1721_331# VDD.t4 sg13_lv_pmos ad=0.1918p pd=1.5u as=0.1596p ps=1.22u w=0.84u l=0.13u
X699 a_7151_1842# a_6913_1842# a_7043_1842# VSS.t386 sg13_lv_nmos ad=0.1406p pd=1.12u as=0.2516p ps=2.16u w=0.74u l=0.2u
X700 a_16033_1842# a_15837_1842# VSS.t206 VSS.t205 sg13_lv_nmos ad=0.2516p pd=2.16u as=0.1406p ps=1.12u w=0.74u l=0.13u
X701 a_10649_5878# REF_CLK VSS.t426 VSS.t425 sg13_lv_nmos ad=0.2516p pd=2.16u as=1.9998p ps=12.915u w=0.74u l=0.13u
X702 VDD.t36 a_11748_6109# a_11693_5990# VDD.t0 sg13_lv_pmos ad=1.10612p pd=6.66u as=93.45f ps=0.865u w=0.42u l=0.13u
X703 MUX_OUT a_16851_309# VDD.t84 VDD.t4 sg13_lv_pmos ad=0.2128p pd=1.5u as=0.2086p ps=1.5u w=1.12u l=0.13u
X704 a_25391_2470# a_25153_1842# a_25283_1842# VDD.t10 sg13_lv_pmos ad=0.2128p pd=1.5u as=0.3808p ps=2.92u w=1.12u l=0.2u
X705 VDD.t122 VSS.t79 VDD.t121 VDD.t4 sg13_lv_pmos ad=0.34p pd=2.68u as=0 ps=0 w=1u l=1u
X706 a_12993_1842# a_12797_1842# VDD.t106 VDD.t10 sg13_lv_pmos ad=0.3808p pd=2.92u as=0.2128p ps=1.5u w=1.12u l=0.13u
X707 a_16408_1044# a_15837_1842# VSS.t204 VSS.t203 sg13_lv_nmos ad=0.1406p pd=1.12u as=0.2516p ps=2.16u w=0.74u l=0.13u
X708 a_5778_3367# a_6126_3816# a_6326_4590# VSS.t690 sg13_lv_nmos ad=0.68p pd=4.68u as=0.38p ps=2.38u w=2u l=1u
X709 VSS.t253 a_5523_1842# a_5957_1842# VSS.t252 sg13_lv_nmos ad=0.1406p pd=1.12u as=0.2516p ps=2.16u w=0.74u l=0.13u
X710 VDD.t307 DELAY_VBIASP.t21 a_13991_2470# VDD.t10 sg13_lv_pmos ad=0.3808p pd=2.92u as=0.2128p ps=1.5u w=1.12u l=0.6u
X711 a_5731_289# a_2019_311.t3 a_4350_1044# VSS.t153 sg13_lv_nmos ad=0.2516p pd=2.16u as=0.2516p ps=2.16u w=0.74u l=0.13u
X712 VSS.t292 a_9547_6172# a_9547_6172# VSS.t334 sg13_lv_nmos ad=2.39977p pd=15.495u as=0.111p ps=1.34u w=0.3u l=0.13u
X713 a_9444_3912# a_6854_5454# a_9712_3912# VSS.t529 sg13_lv_nmos ad=0.68p pd=4.68u as=0.38p ps=2.38u w=2u l=1u
X714 VSS.t602 DELAY_VBIASN VSS.t600 VSS.t585 sg13_lv_nmos ad=1.33p pd=7.38u as=0 ps=0 w=7u l=7u
X715 a_7390_1044# a_3747_1047.t8 a_9675_1044# VSS.t703 sg13_lv_nmos ad=0.2516p pd=2.16u as=0.1406p ps=1.12u w=0.74u l=0.13u
X716 VDD.t11 a_23763_1842# a_24197_1842# VDD.t10 sg13_lv_pmos ad=0.2128p pd=1.5u as=0.3808p ps=2.92u w=1.12u l=0.13u
X717 VSS.t557 DELAY_VBIASN a_8671_1842# VSS.t556 sg13_lv_nmos ad=0.2516p pd=2.16u as=0.1406p ps=1.12u w=0.74u l=0.6u
X718 VDD.t92 a_2019_1047.t8 a_7364_1008# VDD.t4 sg13_lv_pmos ad=0.3808p pd=2.92u as=0.3808p ps=2.92u w=1.12u l=0.13u
X719 VDD.t319 DELAY_VBIASP.t4 a_26911_2470# VDD.t10 sg13_lv_pmos ad=0.3808p pd=2.92u as=0.2128p ps=1.5u w=1.12u l=0.6u
X720 VSS.t55 a_14009_5084# a_14111_5227# VSS.t640 sg13_lv_nmos ad=1.45407p pd=9.445u as=0.2516p ps=2.16u w=0.74u l=0.13u
X721 VDD.t176 VSS.t152 VDD.t281 VDD.t4 sg13_lv_pmos ad=0.19p pd=1.38u as=0 ps=0 w=1u l=1u
X722 a_12471_1842# a_12233_1842# a_12363_1842# VSS.t383 sg13_lv_nmos ad=0.1406p pd=1.12u as=0.2516p ps=2.16u w=0.74u l=0.2u
X723 a_22488_1044# a_21917_1842# VDD.t347 VDD.t4 sg13_lv_pmos ad=0.2128p pd=1.5u as=0.3808p ps=2.92u w=1.12u l=0.13u
X724 VDD.t34 a_2595_311.t3 a_8745_519# VDD.t4 sg13_lv_pmos ad=0.3808p pd=2.92u as=0.3808p ps=2.92u w=1.12u l=0.13u
X725 VSS.t372 a_3171_1047.t5 a_18004_1008# VSS.t371 sg13_lv_nmos ad=0.2516p pd=2.16u as=0.2516p ps=2.16u w=0.74u l=0.13u
X726 a_6391_2470# a_6153_1842# a_6283_1842# VDD.t10 sg13_lv_pmos ad=0.2128p pd=1.5u as=0.3808p ps=2.92u w=1.12u l=0.2u
X727 a_15273_1842# a_15077_1842# VDD.t154 VDD.t10 sg13_lv_pmos ad=0.3808p pd=2.92u as=0.2128p ps=1.5u w=1.12u l=0.13u
X728 a_14235_1044# a_14025_1044# VSS.t183 VSS.t682 sg13_lv_nmos ad=0.1406p pd=1.12u as=0.1665p ps=1.19u w=0.74u l=0.13u
X729 a_6326_4590# a_6126_3816# a_5778_3367# VSS.t690 sg13_lv_nmos ad=0.42p pd=2.42u as=0.68p ps=4.68u w=2u l=1u
X730 VSS.t676 a_3747_1047.t7 a_12791_1008# VSS.t675 sg13_lv_nmos ad=0.2516p pd=2.16u as=0.2516p ps=2.16u w=0.74u l=0.13u
X731 VSS.t500 VSS.t497 VSS.t499 VSS.t498 sg13_lv_nmos ad=0.2516p pd=2.16u as=0 ps=0 w=0.74u l=0.13u
X732 a_9953_1842# a_9757_1842# VSS.t294 VSS.t293 sg13_lv_nmos ad=0.2516p pd=2.16u as=0.1406p ps=1.12u w=0.74u l=0.13u
X733 VSS.t397 a_10843_1842# a_11277_1842# VSS.t708 sg13_lv_nmos ad=0.1406p pd=1.12u as=0.2516p ps=2.16u w=0.74u l=0.13u
X734 VSS.t135 VDD.t386 VSS.t134 VSS.t133 sg13_lv_nmos ad=0.1428p pd=1.52u as=0 ps=0 w=0.42u l=1u
X735 a_10649_5878# REF_CLK VDD.t36 VDD.t0 sg13_lv_pmos ad=0.4088p pd=2.97u as=1.03698p ps=6.245u w=1.12u l=0.13u
X736 VDD.t100 a_15403_1842# a_15837_1842# VDD.t10 sg13_lv_pmos ad=0.2128p pd=1.5u as=0.3808p ps=2.92u w=1.12u l=0.13u
X737 VDD.t36 a_14009_5084# a_14111_5227# VDD.t0 sg13_lv_pmos ad=1.10612p pd=6.66u as=0.3864p ps=2.93u w=1.12u l=0.13u
X738 VSS.t100 VDD.t393 VSS.t99 VSS.t98 sg13_lv_nmos ad=0.1428p pd=1.52u as=0 ps=0 w=0.42u l=1u
X739 a_11848_1044# a_11277_1842# VSS.t395 VSS.t394 sg13_lv_nmos ad=0.1406p pd=1.12u as=0.2516p ps=2.16u w=0.74u l=0.13u
X740 a_6326_4590# a_6326_4590# VDD.t192 VDD.t0 sg13_lv_pmos ad=0.38p pd=2.38u as=0.38p ps=2.38u w=2u l=1u
X741 VDD.t211 a_4763_1842# a_5197_1842# VDD.t10 sg13_lv_pmos ad=0.2128p pd=1.5u as=0.3808p ps=2.92u w=1.12u l=0.13u
X742 VSS.t112 VDD.t391 VSS.t110 VSS.t111 sg13_lv_nmos ad=79.8f pd=0.8u as=0 ps=0 w=0.42u l=1u
X743 a_13470_1044# a_13444_1008# a_13368_1044# VDD.t4 sg13_lv_pmos ad=0.3808p pd=2.92u as=0.2128p ps=1.5u w=1.12u l=0.13u
X744 VDD.t83 a_3449_1395# a_3747_1047.t0 VDD.t4 sg13_lv_pmos ad=0.4256p pd=3u as=0.2128p ps=1.5u w=1.12u l=0.13u
X745 VSS.t509 VSS.t506 VSS.t506 VSS.t507 sg13_lv_nmos ad=0.1406p pd=1.12u as=0 ps=0 w=0.74u l=0.13u
X746 VDD.t280 a_3171_1047.t3 a_24084_1008# VDD.t4 sg13_lv_pmos ad=0.3808p pd=2.92u as=0.3808p ps=2.92u w=1.12u l=0.13u
X747 a_3449_1395# MUX_SEL0 VDD.t327 VDD.t4 sg13_lv_pmos ad=0.1596p pd=1.22u as=0.2856p ps=2.36u w=0.84u l=0.13u
X748 a_15464_3684# a_14851_5182# VDD.t110 VDD.t0 sg13_lv_pmos ad=0.4312p pd=3.01u as=0.2639p ps=1.81u w=1.12u l=0.13u
X749 a_5974_5723# a_6126_3816# VSS.t691 VSS.t58 sg13_lv_nmos ad=0.38p pd=2.38u as=0.68p ps=4.68u w=2u l=1u
X750 VDD.t299 DELAY_VBIASP.t29 a_7911_2470# VDD.t10 sg13_lv_pmos ad=0.3808p pd=2.92u as=0.2128p ps=1.5u w=1.12u l=0.6u
X751 VDD.t30 VSS.t72 VDD.t29 VDD.t4 sg13_lv_pmos ad=0.19p pd=1.38u as=0 ps=0 w=1u l=1u
X752 VDD.t53 a_6326_4590# a_6854_5986# VDD.t0 sg13_lv_pmos ad=0.38p pd=2.38u as=0.38p ps=2.38u w=2u l=1u
X753 a_10206_5835# a_10649_5878# a_9946_6305# VSS.t462 sg13_lv_nmos ad=79.8f pd=0.8u as=0.1296p ps=1.52u w=0.42u l=0.13u
X754 VDD.t124 VSS.t74 VDD.t123 VDD.t4 sg13_lv_pmos ad=0.34p pd=2.68u as=0 ps=0 w=1u l=1u
X755 a_9946_6305# a_9772_5843# VDD.t134 VDD.t0 sg13_lv_pmos ad=79.8f pd=0.8u as=0.1428p ps=1.52u w=0.42u l=0.13u
X756 a_9946_6305# a_10751_5878# a_10206_5835# VDD.t0 sg13_lv_pmos ad=0.1428p pd=1.52u as=79.8f ps=0.8u w=0.42u l=0.13u
X757 VDD.t85 a_16851_309# MUX_OUT VDD.t4 sg13_lv_pmos ad=0.7336p pd=3.55u as=0.2128p ps=1.5u w=1.12u l=0.13u
X758 VSS.t638 a_3171_311.t2 a_23945_519# VSS.t637 sg13_lv_nmos ad=0.2516p pd=2.16u as=0.2516p ps=2.16u w=0.74u l=0.13u
X759 VDD.t113 a_18117_1842# a_18585_1044# VDD.t4 sg13_lv_pmos ad=0.252p pd=1.57u as=0.3808p ps=2.92u w=1.12u l=0.13u
X760 VSS.t687 a_19637_1842# a_20105_1044# VSS.t686 sg13_lv_nmos ad=0.1665p pd=1.19u as=0.2516p ps=2.16u w=0.74u l=0.13u
X761 a_11711_2470# a_11473_1842# a_11603_1842# VDD.t10 sg13_lv_pmos ad=0.2128p pd=1.5u as=0.3808p ps=2.92u w=1.12u l=0.2u
X762 a_27671_1842# a_27433_1842# a_27563_1842# VSS.t419 sg13_lv_nmos ad=0.1406p pd=1.12u as=0.2516p ps=2.16u w=0.74u l=0.2u
X763 VSS.t440 MUX_SEL4 a_15765_463# VSS.t439 sg13_lv_nmos ad=0.2516p pd=2.16u as=0.2516p ps=2.16u w=0.74u l=0.13u
X764 a_5731_289# a_14825_519# a_13470_1044# VDD.t4 sg13_lv_pmos ad=0.3808p pd=2.92u as=0.3808p ps=2.92u w=1.12u l=0.13u
X765 a_16510_1044# a_2595_1047.t5 a_17275_1044# VSS.t304 sg13_lv_nmos ad=0.2516p pd=2.16u as=0.1406p ps=1.12u w=0.74u l=0.13u
X766 a_13045_6215# a_13019_5831# a_12849_5867# VSS.t325 sg13_lv_nmos ad=0.1406p pd=1.12u as=0.1406p ps=1.12u w=0.74u l=0.13u
X767 VSS.t539 DELAY_VBIASN a_16271_1842# VSS.t538 sg13_lv_nmos ad=0.2516p pd=2.16u as=0.1406p ps=1.12u w=0.74u l=0.6u
X768 VDD.t277 VSS.t139 VDD.t276 VDD.t4 sg13_lv_pmos ad=0.34p pd=2.68u as=0 ps=0 w=1u l=1u
X769 VDD.t279 a_3171_1047.t6 a_14964_1008# VDD.t4 sg13_lv_pmos ad=0.3808p pd=2.92u as=0.3808p ps=2.92u w=1.12u l=0.13u
X770 VDD.t109 a_10083_1842# a_10517_1842# VDD.t10 sg13_lv_pmos ad=0.2128p pd=1.5u as=0.3808p ps=2.92u w=1.12u l=0.13u
X771 VSS.t476 a_3747_1047.t2 a_27991_1008# VSS.t475 sg13_lv_nmos ad=0.2516p pd=2.16u as=0.2516p ps=2.16u w=0.74u l=0.13u
X772 a_9712_3912# a_13019_5831# DELAY_VBIASN VSS.t326 sg13_lv_nmos ad=0.136p pd=1.14u as=0.232p ps=2.08u w=0.4u l=0.2u
X773 VSS.t388 a_26043_1842# a_26477_1842# VSS.t387 sg13_lv_nmos ad=0.1406p pd=1.12u as=0.2516p ps=2.16u w=0.74u l=0.13u
X774 VSS.t700 a_6126_3816# a_5974_5723# VSS.t58 sg13_lv_nmos ad=0.68p pd=4.68u as=0.38p ps=2.38u w=2u l=1u
X775 a_11195_1044# a_10985_1044# VDD.t150 VDD.t4 sg13_lv_pmos ad=0.2128p pd=1.5u as=0.252p ps=1.57u w=1.12u l=0.13u
X776 VSS.t473 a_3747_1047.t9 a_6711_1008# VSS.t472 sg13_lv_nmos ad=0.2516p pd=2.16u as=0.2516p ps=2.16u w=0.74u l=0.13u
X777 a_9444_4590# a_6854_5454# a_6854_5454# VSS.t529 sg13_lv_nmos ad=0.68p pd=4.68u as=0.38p ps=2.38u w=2u l=1u
X778 a_16108_289# a_2595_311.t2 a_19550_1044# VSS.t51 sg13_lv_nmos ad=0.2516p pd=2.16u as=0.2516p ps=2.16u w=0.74u l=0.13u
X779 VSS.t545 DELAY_VBIASN a_20071_1842# VSS.t544 sg13_lv_nmos ad=0.2516p pd=2.16u as=0.1406p ps=1.12u w=0.74u l=0.6u
X780 VDD.t316 DELAY_VBIASP.t7 a_24631_2470# VDD.t10 sg13_lv_pmos ad=0.3808p pd=2.92u as=0.2128p ps=1.5u w=1.12u l=0.6u
X781 a_22590_1044# a_23431_1008# a_23355_1044# VDD.t4 sg13_lv_pmos ad=0.3808p pd=2.92u as=0.2128p ps=1.5u w=1.12u l=0.13u
X782 VSS.t92 VDD.t395 VSS.t90 VSS.t91 sg13_lv_nmos ad=79.8f pd=0.8u as=0 ps=0 w=0.42u l=1u
X783 a_10458_6292# DLL_RESETN VSS.t157 VSS.t156 sg13_lv_nmos ad=37.8f pd=0.6u as=0.1701p ps=1.65u w=0.42u l=0.13u
X784 a_11491_6228# a_10649_5878# a_10232_5871# VDD.t0 sg13_lv_pmos ad=0.2048p pd=1.63u as=0.34p ps=2.68u w=1u l=0.13u
X785 VSS.t698 a_6126_3816# a_5974_5723# VSS.t58 sg13_lv_nmos ad=0.76p pd=4.76u as=0.38p ps=2.38u w=2u l=1u
X786 a_8671_1842# a_8433_1842# a_8563_1842# VSS.t416 sg13_lv_nmos ad=0.1406p pd=1.12u as=0.2516p ps=2.16u w=0.74u l=0.2u
X787 a_17553_1842# a_17357_1842# VSS.t17 VSS.t16 sg13_lv_nmos ad=0.2516p pd=2.16u as=0.1406p ps=1.12u w=0.74u l=0.13u
X788 a_5731_289# a_5705_519# a_4350_1044# VDD.t4 sg13_lv_pmos ad=0.3808p pd=2.92u as=0.3808p ps=2.92u w=1.12u l=0.13u
X789 VDD.t67 VDD.t65 VDD.t66 VDD.t10 sg13_lv_pmos ad=0.3808p pd=2.92u as=0 ps=0 w=1.12u l=0.13u
X790 a_26911_2470# a_26673_1842# a_26803_1842# VDD.t10 sg13_lv_pmos ad=0.2128p pd=1.5u as=0.3808p ps=2.92u w=1.12u l=0.2u
X791 a_7390_1044# a_2019_1047.t8 a_7288_1044# VSS.t185 sg13_lv_nmos ad=0.2516p pd=2.16u as=0.1406p ps=1.12u w=0.74u l=0.13u
X792 a_13566_5328# a_14009_5084# a_13306_5105# VSS.t639 sg13_lv_nmos ad=79.8f pd=0.8u as=0.1296p ps=1.52u w=0.42u l=0.13u
X793 a_21353_1842# a_21157_1842# VSS.t44 VSS.t389 sg13_lv_nmos ad=0.2516p pd=2.16u as=0.1406p ps=1.12u w=0.74u l=0.13u
X794 VSS.t219 a_7043_1842# a_7477_1842# VSS.t409 sg13_lv_nmos ad=0.1406p pd=1.12u as=0.2516p ps=2.16u w=0.74u l=0.13u
X795 a_13121_5831# a_15688_5867# VDD.t3 VDD.t0 sg13_lv_pmos ad=0.3808p pd=2.92u as=0.2128p ps=1.5u w=1.12u l=0.13u
X796 VDD.t310 DELAY_VBIASP.t19 a_15511_2470# VDD.t10 sg13_lv_pmos ad=0.3808p pd=2.92u as=0.2128p ps=1.5u w=1.12u l=0.6u
X797 VDD.t381 a_2019_1047.t7 a_10404_1008# VDD.t4 sg13_lv_pmos ad=0.3808p pd=2.92u as=0.3808p ps=2.92u w=1.12u l=0.13u
X798 VSS.t263 a_9444_4590# a_9444_3912# VSS.t261 sg13_lv_nmos ad=0.68p pd=4.68u as=0.38p ps=2.38u w=2u l=1u
X799 VDD.t159 a_25283_1842# a_25717_1842# VDD.t10 sg13_lv_pmos ad=0.2128p pd=1.5u as=0.3808p ps=2.92u w=1.12u l=0.13u
X800 VDD.t295 DELAY_VBIASP.t32 a_5631_2470# VDD.t10 sg13_lv_pmos ad=0.3808p pd=2.92u as=0.2128p ps=1.5u w=1.12u l=0.6u
X801 a_26395_1044# a_26185_1044# VDD.t206 VDD.t4 sg13_lv_pmos ad=0.2128p pd=1.5u as=0.252p ps=1.57u w=1.12u l=0.13u
X802 a_13306_5105# a_14111_5227# a_13566_5328# VDD.t0 sg13_lv_pmos ad=0.1428p pd=1.52u as=79.8f ps=0.8u w=0.42u l=0.13u
X803 a_6326_4590# a_6126_3816# a_5778_3367# VSS.t690 sg13_lv_nmos ad=0.38p pd=2.38u as=0.68p ps=4.68u w=2u l=1u
X804 VDD.t139 a_3747_1047.t3 a_24951_1008# VDD.t4 sg13_lv_pmos ad=0.3808p pd=2.92u as=0.3808p ps=2.92u w=1.12u l=0.13u
X805 VDD.t248 VSS.t132 VDD.t352 VDD.t4 sg13_lv_pmos ad=0.19p pd=1.38u as=0 ps=0 w=1u l=1u
X806 a_13991_1842# a_13753_1842# a_13883_1842# VSS.t413 sg13_lv_nmos ad=0.1406p pd=1.12u as=0.2516p ps=2.16u w=0.74u l=0.2u
X807 a_24008_1044# a_23437_1842# VDD.t272 VDD.t4 sg13_lv_pmos ad=0.2128p pd=1.5u as=0.3808p ps=2.92u w=1.12u l=0.13u
X808 VDD.t166 VSS.t97 VDD.t173 VDD.t4 sg13_lv_pmos ad=0.19p pd=1.38u as=0 ps=0 w=1u l=1u
X809 VSS.t717 a_2019_1047.t4 a_19524_1008# VSS.t716 sg13_lv_nmos ad=0.2516p pd=2.16u as=0.2516p ps=2.16u w=0.74u l=0.13u
X810 a_9712_3912# a_6854_5454# a_9444_3912# VSS.t528 sg13_lv_nmos ad=0.38p pd=2.38u as=0.68p ps=4.68u w=2u l=1u
X811 a_7911_2470# a_7673_1842# a_7803_1842# VDD.t10 sg13_lv_pmos ad=0.2128p pd=1.5u as=0.3808p ps=2.92u w=1.12u l=0.2u
X812 a_16793_1842# a_16597_1842# VDD.t227 VDD.t10 sg13_lv_pmos ad=0.3808p pd=2.92u as=0.2128p ps=1.5u w=1.12u l=0.13u
X813 VSS.t165 MUX_SEL1 a_3543_1395# VSS.t446 sg13_lv_nmos ad=0.1331p pd=1.12u as=0.1216p ps=1.02u w=0.64u l=0.13u
X814 a_15755_1044# a_15545_1044# VSS.t240 VSS.t239 sg13_lv_nmos ad=0.1406p pd=1.12u as=0.1665p ps=1.19u w=0.74u l=0.13u
X815 a_13818_5118# a_12849_5867# VSS.t407 VSS.t406 sg13_lv_nmos ad=37.8f pd=0.6u as=0.1701p ps=1.65u w=0.42u l=0.13u
X816 a_2595_1047.t0 a_2297_1395# VDD.t24 VDD.t4 sg13_lv_pmos ad=0.2128p pd=1.5u as=0.1918p ps=1.5u w=1.12u l=0.13u
X817 VSS.t381 a_2595_1047.t6 a_14311_1008# VSS.t380 sg13_lv_nmos ad=0.2516p pd=2.16u as=0.2516p ps=2.16u w=0.74u l=0.13u
X818 VSS.t221 a_12363_1842# a_12797_1842# VSS.t220 sg13_lv_nmos ad=0.1406p pd=1.12u as=0.2516p ps=2.16u w=0.74u l=0.13u
X819 a_5115_1044# a_4905_1044# VSS.t313 VSS.t410 sg13_lv_nmos ad=0.1406p pd=1.12u as=0.1665p ps=1.19u w=0.74u l=0.13u
X820 a_1256_1044# MUX_SEL0 VDD.t328 VDD.t4 sg13_lv_pmos ad=0.3808p pd=2.92u as=0.3808p ps=2.92u w=1.12u l=0.13u
X821 a_9444_3912# a_9444_4590# VSS.t259 VSS.t258 sg13_lv_nmos ad=0.38p pd=2.38u as=0.68p ps=4.68u w=2u l=1u
X822 VSS.t592 DELAY_VBIASN VSS.t590 VSS.t575 sg13_lv_nmos ad=1.33p pd=7.38u as=0 ps=0 w=7u l=7u
X823 VDD.t88 a_27563_1842# a_27997_1842# VDD.t10 sg13_lv_pmos ad=0.2128p pd=1.5u as=0.3808p ps=2.92u w=1.12u l=0.13u
X824 a_20593_1842# a_20397_1842# VDD.t128 VDD.t10 sg13_lv_pmos ad=0.3808p pd=2.92u as=0.2128p ps=1.5u w=1.12u l=0.13u
X825 a_1721_1395# a_1256_1044# VDD.t87 VDD.t4 sg13_lv_pmos ad=0.1596p pd=1.22u as=0.2856p ps=2.36u w=0.84u l=0.13u
X826 VDD.t19 a_6283_1842# a_6717_1842# VDD.t10 sg13_lv_pmos ad=0.2128p pd=1.5u as=0.3808p ps=2.92u w=1.12u l=0.13u
X827 a_13470_1044# a_14964_1008# a_14888_1044# VDD.t4 sg13_lv_pmos ad=0.3808p pd=2.92u as=0.2128p ps=1.5u w=1.12u l=0.13u
X828 a_13592_5871# a_13566_5835# VDD.t212 VDD.t0 sg13_lv_pmos ad=0.34p pd=2.68u as=0.36237p ps=2.605u w=1u l=0.13u
X829 a_5778_3367# a_6126_3816# a_6326_4590# VSS.t690 sg13_lv_nmos ad=0.68p pd=4.68u as=0.42p ps=2.42u w=2u l=1u
X830 VSS.t110 VDD.t391 VSS.t109 VSS.t108 sg13_lv_nmos ad=0.1428p pd=1.52u as=0 ps=0 w=0.42u l=1u
X831 VDD.t132 a_2019_1047.t2 a_25604_1008# VDD.t4 sg13_lv_pmos ad=0.3808p pd=2.92u as=0.3808p ps=2.92u w=1.12u l=0.13u
X832 a_9746_5805# a_9547_5942# VSS.t292 VSS.t291 sg13_lv_nmos ad=0.27427p pd=2.28u as=2.39977p ps=15.495u w=0.795u l=0.13u
X833 a_16271_1842# a_16033_1842# a_16163_1842# VSS.t701 sg13_lv_nmos ad=0.1406p pd=1.12u as=0.2516p ps=2.16u w=0.74u l=0.2u
X834 a_21835_1044# a_21625_1044# VDD.t230 VDD.t4 sg13_lv_pmos ad=0.2128p pd=1.5u as=0.252p ps=1.57u w=1.12u l=0.13u
X835 VDD.t30 VSS.t69 VDD.t219 VDD.t4 sg13_lv_pmos ad=0.34p pd=2.68u as=0 ps=0 w=1u l=1u
X836 VDD.t96 a_2595_1047.t4 a_20391_1008# VDD.t4 sg13_lv_pmos ad=0.3808p pd=2.92u as=0.3808p ps=2.92u w=1.12u l=0.13u
X837 VSS.t228 a_14851_5182# a_15688_5403# VSS.t227 sg13_lv_nmos ad=0.1406p pd=1.12u as=0.2516p ps=2.16u w=0.74u l=0.13u
X838 a_19073_1842# a_18877_1842# VDD.t161 VDD.t10 sg13_lv_pmos ad=0.3808p pd=2.92u as=0.2128p ps=1.5u w=1.12u l=0.13u
X839 VDD.t150 a_10517_1842# a_10985_1044# VDD.t4 sg13_lv_pmos ad=0.252p pd=1.57u as=0.3808p ps=2.92u w=1.12u l=0.13u
X840 VSS.t391 a_21157_1842# a_21625_1044# VSS.t390 sg13_lv_nmos ad=0.1665p pd=1.19u as=0.2516p ps=2.16u w=0.74u l=0.13u
X841 VSS.t366 a_12849_5867# a_13400_6305# VSS.t365 sg13_lv_nmos ad=0.1626p pd=1.415u as=60.89999f ps=0.71u w=0.42u l=0.13u
X842 VSS.t693 a_6126_3816# a_6126_3816# VSS.t690 sg13_lv_nmos ad=0.68p pd=4.68u as=0.38p ps=2.38u w=2u l=1u
X843 a_20071_1842# a_19833_1842# a_19963_1842# VSS.t348 sg13_lv_nmos ad=0.1406p pd=1.12u as=0.2516p ps=2.16u w=0.74u l=0.2u
X844 VSS.t491 VSS.t489 VSS.t489 VSS.t490 sg13_lv_nmos ad=0.68p pd=4.68u as=0 ps=0 w=2u l=1u
X845 VSS.t308 a_14643_1842# a_15077_1842# VSS.t307 sg13_lv_nmos ad=0.1406p pd=1.12u as=0.2516p ps=2.16u w=0.74u l=0.13u
X846 a_1815_331# a_1256_289# a_1721_331# VSS.t337 sg13_lv_nmos ad=0.1216p pd=1.02u as=0.2176p ps=1.96u w=0.64u l=0.13u
X847 VDD.t47 VDD.t45 VDD.t46 VDD.t0 sg13_lv_pmos ad=0.38p pd=2.38u as=0 ps=0 w=2u l=1u
X848 VDD.t37 a_19203_1842# a_19637_1842# VDD.t10 sg13_lv_pmos ad=0.2128p pd=1.5u as=0.3808p ps=2.92u w=1.12u l=0.13u
X849 VSS.t723 a_2019_1047.t9 a_4324_1008# VSS.t722 sg13_lv_nmos ad=0.2516p pd=2.16u as=0.2516p ps=2.16u w=0.74u l=0.13u
X850 a_16108_289# a_20905_519# a_19550_1044# VDD.t4 sg13_lv_pmos ad=0.3808p pd=2.92u as=0.3808p ps=2.92u w=1.12u l=0.13u
X851 a_16510_1044# a_3747_1047.t5 a_18795_1044# VSS.t328 sg13_lv_nmos ad=0.2516p pd=2.16u as=0.1406p ps=1.12u w=0.74u l=0.13u
X852 VDD.t27 a_8563_1842# a_8997_1842# VDD.t10 sg13_lv_pmos ad=0.2128p pd=1.5u as=0.3808p ps=2.92u w=1.12u l=0.13u
X853 VDD.t290 DELAY_VBIASP.t22 a_13231_2470# VDD.t10 sg13_lv_pmos ad=0.3808p pd=2.92u as=0.2128p ps=1.5u w=1.12u l=0.6u
X854 VSS.t559 DELAY_VBIASN a_17791_1842# VSS.t558 sg13_lv_nmos ad=0.2516p pd=2.16u as=0.1406p ps=1.12u w=0.74u l=0.6u
X855 VSS.t80 VDD.t397 VSS.t79 VSS.t78 sg13_lv_nmos ad=0.1428p pd=1.52u as=0 ps=0 w=0.42u l=1u
X856 a_6854_5986# a_6326_4590# VDD.t194 VDD.t0 sg13_lv_pmos ad=0.38p pd=2.38u as=0.38p ps=2.38u w=2u l=1u
X857 VDD.t62 VDD.t60 VDD.t61 VDD.t55 sg13_lv_pmos ad=0.3808p pd=2.92u as=0 ps=0 w=1.12u l=0.13u
X858 VDD.t163 a_3747_1047.t5 a_18871_1008# VDD.t4 sg13_lv_pmos ad=0.3808p pd=2.92u as=0.3808p ps=2.92u w=1.12u l=0.13u
X859 VDD.t57 VDD.t58 VDD.t59 VDD.t55 sg13_lv_pmos ad=0.2128p pd=1.5u as=0 ps=0 w=1.12u l=0.13u
X860 VDD.t141 a_23003_1842# a_23437_1842# VDD.t10 sg13_lv_pmos ad=0.2128p pd=1.5u as=0.3808p ps=2.92u w=1.12u l=0.13u
X861 VSS.t262 a_9444_4590# a_9444_4590# VSS.t261 sg13_lv_nmos ad=0.68p pd=4.68u as=0.38p ps=2.38u w=2u l=1u
X862 VSS.t494 VSS.t486 VSS.t486 VSS.t487 sg13_lv_nmos ad=0.68p pd=4.68u as=0 ps=0 w=2u l=1u
X863 a_12715_1044# a_12505_1044# VDD.t41 VDD.t4 sg13_lv_pmos ad=0.2128p pd=1.5u as=0.252p ps=1.57u w=1.12u l=0.13u
X864 a_19550_1044# a_21044_1008# a_20968_1044# VDD.t4 sg13_lv_pmos ad=0.3808p pd=2.92u as=0.2128p ps=1.5u w=1.12u l=0.13u
X865 a_17928_1044# a_17357_1842# VDD.t13 VDD.t4 sg13_lv_pmos ad=0.2128p pd=1.5u as=0.3808p ps=2.92u w=1.12u l=0.13u
X866 VSS.t620 DELAY_VBIASN a_21591_1842# VSS.t619 sg13_lv_nmos ad=0.2516p pd=2.16u as=0.1406p ps=1.12u w=0.74u l=0.6u
X867 VSS.t483 a_1544_289# a_1815_331# VSS.t671 sg13_lv_nmos ad=0.1331p pd=1.12u as=0.1216p ps=1.02u w=0.64u l=0.13u
X868 a_7288_1044# a_6717_1842# VDD.t20 VDD.t4 sg13_lv_pmos ad=0.2128p pd=1.5u as=0.3808p ps=2.92u w=1.12u l=0.13u
X869 VSS.t582 DELAY_VBIASN VSS.t584 VSS.t583 sg13_lv_nmos ad=1.33p pd=7.38u as=0 ps=0 w=7u l=7u
X870 a_5974_5723# a_6126_3816# VSS.t699 VSS.t58 sg13_lv_nmos ad=0.38p pd=2.38u as=0.68p ps=4.68u w=2u l=1u
X871 a_15511_2470# a_15273_1842# a_15403_1842# VDD.t10 sg13_lv_pmos ad=0.2128p pd=1.5u as=0.3808p ps=2.92u w=1.12u l=0.2u
X872 VSS.t518 VSS.t519 VSS.t518 VSS.t520 sg13_lv_nmos ad=0.1406p pd=1.12u as=0 ps=0 w=0.74u l=0.2u
X873 a_22590_1044# a_24951_1008# a_24875_1044# VDD.t4 sg13_lv_pmos ad=0.3808p pd=2.92u as=0.2128p ps=1.5u w=1.12u l=0.13u
X874 VSS.t149 VDD.t383 VSS.t152 VSS.t151 sg13_lv_nmos ad=79.8f pd=0.8u as=0 ps=0 w=0.42u l=1u
X875 VSS.t226 a_15108_5325# a_14757_5182# VSS.t245 sg13_lv_nmos ad=79.8f pd=0.8u as=0.1428p ps=1.52u w=0.42u l=0.13u
X876 a_10430_1044# a_2019_1047.t7 a_10328_1044# VSS.t718 sg13_lv_nmos ad=0.2516p pd=2.16u as=0.1406p ps=1.12u w=0.74u l=0.13u
X877 VDD.t39 a_5974_5723# a_5974_5723# VDD.t0 sg13_lv_pmos ad=0.2448p pd=2.08u as=0.2826p ps=2.29u w=0.36u l=2u
X878 VDD.t206 a_25717_1842# a_26185_1044# VDD.t4 sg13_lv_pmos ad=0.252p pd=1.57u as=0.3808p ps=2.92u w=1.12u l=0.13u
X879 a_6854_5454# a_6854_5454# a_9444_4590# VSS.t528 sg13_lv_nmos ad=0.38p pd=2.38u as=0.68p ps=4.68u w=2u l=1u
X880 VDD.t344 a_13883_1842# a_14317_1842# VDD.t10 sg13_lv_pmos ad=0.2128p pd=1.5u as=0.3808p ps=2.92u w=1.12u l=0.13u
X881 VDD.t156 a_4437_1842# a_4905_1044# VDD.t4 sg13_lv_pmos ad=0.252p pd=1.57u as=0.3808p ps=2.92u w=1.12u l=0.13u
X882 a_4157_1313# REF_CLK VSS.t424 VSS.t423 sg13_lv_nmos ad=0.2516p pd=2.16u as=0.2553p ps=2.17u w=0.74u l=0.13u
X883 a_7390_1044# a_3171_1047.t8 a_8808_1044# VSS.t373 sg13_lv_nmos ad=0.2516p pd=2.16u as=0.1406p ps=1.12u w=0.74u l=0.13u
X884 a_22873_1842# a_22677_1842# VSS.t289 VSS.t288 sg13_lv_nmos ad=0.2516p pd=2.16u as=0.1406p ps=1.12u w=0.74u l=0.13u
X885 a_9444_4590# a_9444_4590# VSS.t260 VSS.t258 sg13_lv_nmos ad=0.38p pd=2.38u as=0.68p ps=4.68u w=2u l=1u
X886 VDD.t217 a_3171_1047.t8 a_8884_1008# VDD.t4 sg13_lv_pmos ad=0.3808p pd=2.92u as=0.3808p ps=2.92u w=1.12u l=0.13u
C0 a_21625_1044# a_19550_1044# 0.03208f
C1 a_13557_1842# a_14025_1044# 0.19203f
C2 a_10430_1044# a_11195_1044# 0.39037f
C3 a_8237_1842# a_7390_1044# 0.08038f
C4 a_10517_1842# VDD 0.93609f
C5 a_7477_1842# DELAY_VBIASP 0.03915f
C6 a_7673_1842# DELAY_VBIASN 0.09305f
C7 a_17275_1044# VDD 0.15466f
C8 a_13123_1842# a_13231_2470# 0.01697f
C9 a_5731_289# a_15765_463# 0.23301f
C10 a_14111_5878# a_15304_4605# 0.01811f
C11 a_22113_1842# a_22243_1842# 0.69911f
C12 a_7043_1842# a_7151_1842# 0.01163f
C13 a_13019_5831# VDD 0.48914f
C14 a_27237_1842# a_27124_1008# 0.02055f
C15 a_13557_1842# a_13123_1842# 0.69698f
C16 a_9547_5942# a_9746_5805# 0.14994f
C17 a_26477_1842# VDD 0.93774f
C18 a_27237_1842# a_27705_1044# 0.2079f
C19 a_17357_1842# a_16510_1044# 0.08038f
C20 a_23633_1842# DELAY_VBIASN 0.09566f
C21 a_23437_1842# DELAY_VBIASP 0.03914f
C22 a_13566_5328# REF_CLK 0.01093f
C23 a_6717_1842# a_6711_1008# 0.02354f
C24 a_7803_1842# VDD 0.85902f
C25 a_4437_1842# a_4633_1842# 0.72565f
C26 a_4763_1842# DELAY_VBIASP 0.06316f
C27 a_5957_1842# DELAY_VBIASN 0.07362f
C28 a_14311_1008# VDD 0.28469f
C29 a_11603_1842# a_11711_2470# 0.01697f
C30 a_13880_6292# a_14111_5878# 0.12701f
C31 a_6854_5454# a_5864_3367# 0.03661f
C32 a_14009_5878# a_14757_6228# 0.01058f
C33 a_26477_1842# a_25630_1044# 0.08038f
C34 a_11748_6109# VDD 0.1754f
C35 a_5523_1842# a_5631_1842# 0.01163f
C36 a_15837_1842# a_15831_1008# 0.02354f
C37 a_19550_1044# a_20391_1008# 0.28268f
C38 a_23763_1842# VDD 0.85925f
C39 a_5974_5723# a_6126_3816# 1.74557f
C40 a_12233_1842# a_12797_1842# 0.0114f
C41 a_6326_4590# a_6854_5454# 1.24805f
C42 a_16851_309# VDD 0.53195f
C43 a_21917_1842# DELAY_VBIASN 0.07573f
C44 a_20723_1842# DELAY_VBIASP 0.06316f
C45 a_3449_331# MUX_SEL4 0.05166f
C46 a_5197_1842# a_5844_1008# 0.02312f
C47 a_15545_1044# a_15755_1044# 0.09424f
C48 a_7390_1044# a_8808_1044# 0.38994f
C49 a_11848_1044# VDD 0.17577f
C50 a_6153_1842# VDD 0.70905f
C51 a_9712_3912# DELAY_VBIASN 0.22281f
C52 DELAY_VBIASN DELAY_VBIASP 7.515f
C53 a_20397_1842# a_20593_1842# 0.72407f
C54 a_4003_1842# a_4111_1842# 0.01163f
C55 a_12849_5867# a_14851_6228# 0.13392f
C56 a_10083_1842# a_10191_2470# 0.01697f
C57 a_13121_5831# a_15688_5867# 0.17255f
C58 a_24957_1842# a_24951_1008# 0.02354f
C59 a_9946_6305# VDD 0.81635f
C60 a_11277_1842# a_12037_1842# 0.02984f
C61 a_22113_1842# VDD 0.71046f
C62 a_18795_1044# a_18871_1008# 0.01194f
C63 a_14317_1842# a_14964_1008# 0.02312f
C64 a_19203_1842# DELAY_VBIASN 0.06966f
C65 a_19073_1842# DELAY_VBIASP 0.11007f
C66 a_4437_1842# VDD 0.93901f
C67 a_4437_1842# a_4350_1044# 0.1088f
C68 a_8884_1008# VDD 0.28358f
C69 VDD MUX_SEL1 0.67739f
C70 a_15688_5403# DELAY_OUT_LAST 0.01699f
C71 a_19073_1842# a_19203_1842# 0.69911f
C72 a_8563_1842# a_8671_2470# 0.01697f
C73 a_12849_5867# a_13592_5871# 0.38817f
C74 a_5974_5723# VDD 1.03535f
C75 a_13306_6305# a_13566_5835# 0.75507f
C76 a_13121_5831# a_14009_5878# 0.01604f
C77 a_23437_1842# a_24084_1008# 0.02312f
C78 a_13557_1842# a_13470_1044# 0.1088f
C79 a_4350_1044# a_5705_519# 0.01764f
C80 a_17275_1044# a_17351_1008# 0.01194f
C81 a_5705_519# VDD 0.30089f
C82 a_20397_1842# VDD 0.93774f
C83 a_16510_1044# a_18004_1008# 0.28279f
C84 a_10517_1842# a_10083_1842# 0.69698f
C85 a_12849_5867# REF_CLK 0.25718f
C86 a_17553_1842# DELAY_VBIASN 0.09602f
C87 a_17357_1842# DELAY_VBIASP 0.03914f
C88 a_4350_1044# a_6635_1044# 0.39036f
C89 a_10985_1044# a_11195_1044# 0.09424f
C90 a_6635_1044# VDD 0.15484f
C91 a_13592_5423# DELAY_OUT_LAST 0.08062f
C92 a_27671_2470# VDD 0.02372f
C93 a_13019_5831# a_13121_5831# 0.54957f
C94 a_22677_1842# a_22590_1044# 0.1088f
C95 a_19550_1044# a_20905_519# 0.018f
C96 a_12355_5867# a_13306_6305# 0.26489f
C97 a_12656_5864# a_12849_5867# 0.33075f
C98 a_7043_1842# a_7151_2470# 0.01697f
C99 a_27915_1044# VDD 0.15466f
C100 a_17683_1842# VDD 0.85925f
C101 a_9193_1842# a_9757_1842# 0.0114f
C102 a_12158_5867# REF_CLK 0.01309f
C103 a_15837_1842# DELAY_VBIASN 0.07399f
C104 a_14643_1842# DELAY_VBIASP 0.06323f
C105 a_14111_5227# a_14851_5182# 0.26905f
C106 a_26477_1842# a_26043_1842# 0.6972f
C107 a_15304_4605# DELAY_OUT_LAST 0.05183f
C108 a_25630_1044# a_27915_1044# 0.39036f
C109 a_5523_1842# a_5631_2470# 0.01697f
C110 a_21591_2470# VDD 0.02372f
C111 a_17357_1842# a_17553_1842# 0.72407f
C112 a_8237_1842# a_8997_1842# 0.02984f
C113 a_16033_1842# VDD 0.71033f
C114 a_13470_1044# a_15831_1008# 0.26208f
C115 a_24951_1008# VDD 0.29225f
C116 a_26185_1044# a_26395_1044# 0.09424f
C117 a_12993_1842# DELAY_VBIASP 0.11005f
C118 a_13123_1842# DELAY_VBIASN 0.06808f
C119 a_10232_5871# DLL_RESETN 0.39088f
C120 a_25153_1842# a_25717_1842# 0.0114f
C121 a_17065_1044# VDD 0.30351f
C122 a_13306_5105# a_14009_5084# 0.02454f
C123 a_12907_5186# VDD 0.0643f
C124 a_2873_1395# MUX_SEL1 0.13092f
C125 a_4003_1842# a_4111_2470# 0.01697f
C126 a_11748_6109# a_11491_6228# 0.34468f
C127 a_16033_1842# a_16163_1842# 0.69911f
C128 a_15511_2470# VDD 0.02372f
C129 a_13368_1044# a_13470_1044# 0.37183f
C130 a_22488_1044# VDD 0.18236f
C131 a_14317_1842# VDD 0.93787f
C132 a_7477_1842# a_7043_1842# 0.69698f
C133 a_11473_1842# DELAY_VBIASN 0.09305f
C134 a_6854_5454# DLL_RESETN 0.0112f
C135 a_11277_1842# DELAY_VBIASP 0.03914f
C136 a_6425_1044# VDD 0.29855f
C137 a_24197_1842# a_24957_1842# 0.02577f
C138 a_15304_4605# a_13592_5423# 0.01817f
C139 a_14851_6228# VDD 0.25849f
C140 a_6425_1044# a_4350_1044# 0.03208f
C141 a_16108_289# a_20905_519# 0.2906f
C142 a_1544_1044# MUX_SEL0 0.07603f
C143 a_1256_1044# MUX_SEL1 1.44243f
C144 a_10232_5871# a_10520_6292# 0.43707f
C145 a_9431_2470# VDD 0.02372f
C146 a_13470_1044# a_14825_519# 0.01782f
C147 a_27433_1842# DELAY_VBIASN 0.09602f
C148 a_27237_1842# DELAY_VBIASP 0.05773f
C149 a_11603_1842# VDD 0.85925f
C150 a_21625_1044# a_21911_1008# 0.01885f
C151 a_11848_1044# a_11924_1008# 0.01176f
C152 a_19550_1044# VDD 2.02235f
C153 a_15077_1842# a_15545_1044# 0.2079f
C154 a_6153_1842# a_6717_1842# 0.0114f
C155 a_9757_1842# DELAY_VBIASN 0.07392f
C156 a_8563_1842# DELAY_VBIASP 0.06316f
C157 a_23437_1842# a_23003_1842# 0.6972f
C158 a_13592_5871# VDD 0.07868f
C159 a_14317_1842# a_14513_1842# 0.72407f
C160 a_27563_1842# VDD 0.85987f
C161 a_22488_1044# a_22564_1008# 0.01176f
C162 a_15964_289# MUX_SEL4 0.5544f
C163 VDD REF_CLK 10.6545f
C164 a_25717_1842# DELAY_VBIASN 0.07499f
C165 a_24523_1842# DELAY_VBIASP 0.06316f
C166 a_20105_1044# a_19550_1044# 0.03209f
C167 a_10430_1044# a_10404_1008# 0.277f
C168 a_16484_1008# VDD 0.28929f
C169 a_5197_1842# a_5957_1842# 0.02984f
C170 a_9953_1842# VDD 0.71046f
C171 a_7043_1842# DELAY_VBIASN 0.06808f
C172 a_6913_1842# DELAY_VBIASP 0.11005f
C173 a_12849_5867# a_14111_5227# 0.42064f
C174 a_5731_289# a_14825_519# 0.28056f
C175 a_22113_1842# a_22677_1842# 0.0114f
C176 a_14851_6228# a_14757_6228# 0.28931f
C177 a_12656_5864# VDD 0.27069f
C178 a_12993_1842# a_13123_1842# 0.69911f
C179 a_25913_1842# VDD 0.70915f
C180 a_10430_1044# a_5731_289# 0.40957f
C181 a_9547_5942# a_9547_6172# 0.1117f
C182 a_23003_1842# DELAY_VBIASN 0.0697f
C183 a_8745_519# MUX_SEL4 0.04472f
C184 a_5731_289# MUX_OUT 1.04829f
C185 a_22873_1842# DELAY_VBIASP 0.11005f
C186 a_13132_5420# REF_CLK 0.02025f
C187 a_14235_1044# VDD 0.15466f
C188 a_17065_1044# a_17351_1008# 0.01885f
C189 a_8237_1842# VDD 0.93774f
C190 a_4437_1842# a_4003_1842# 0.69698f
C191 a_5197_1842# DELAY_VBIASP 0.03914f
C192 a_5393_1842# DELAY_VBIASN 0.09305f
C193 a_6854_5454# a_9712_3912# 0.67825f
C194 a_10751_5878# VDD 0.23078f
C195 a_21157_1842# a_21917_1842# 0.02577f
C196 a_13592_5871# a_14757_6228# 0.43239f
C197 a_6126_3816# a_5864_3367# 0.12761f
C198 a_24197_1842# VDD 0.92718f
C199 a_16108_289# VDD 1.94809f
C200 a_6326_4590# a_6126_3816# 2.74106f
C201 a_19550_1044# a_20315_1044# 0.39037f
C202 a_7390_1044# a_8745_519# 0.01627f
C203 a_5974_5723# a_6854_5986# 0.02579f
C204 a_21157_1842# DELAY_VBIASP 0.03915f
C205 a_21353_1842# DELAY_VBIASN 0.09602f
C206 a_2873_331# MUX_SEL4 0.04916f
C207 a_3449_331# MUX_SEL3 0.28429f
C208 a_2297_331# MUX_OUT 0.01179f
C209 a_5197_1842# a_5768_1044# 0.10863f
C210 a_5523_1842# VDD 0.85925f
C211 a_11271_1008# VDD 0.28469f
C212 a_7390_1044# a_8231_1008# 0.28268f
C213 DELAY_VBIASN DELAY_OUT_LAST 3.17532f
C214 a_13121_5831# a_14851_6228# 0.03404f
C215 a_13019_5831# a_15688_5867# 0.0195f
C216 a_25630_1044# a_16108_289# 0.43108f
C217 a_13306_6305# a_14111_5878# 0.097f
C218 a_9772_5843# VDD 0.26362f
C219 a_20397_1842# a_19963_1842# 0.6972f
C220 a_12849_5867# a_15108_6109# 0.10225f
C221 a_21483_1842# VDD 0.85903f
C222 a_14317_1842# a_14888_1044# 0.10863f
C223 a_11277_1842# a_11473_1842# 0.72407f
C224 a_19637_1842# DELAY_VBIASN 0.07499f
C225 a_12943_5867# DLL_RESETN 0.03616f
C226 a_18443_1842# DELAY_VBIASP 0.06316f
C227 a_5864_3367# VDD 0.13532f
C228 a_6635_1044# a_6711_1008# 0.01194f
C229 a_8808_1044# VDD 0.17577f
C230 VDD MUX_SEL0 0.51016f
C231 a_15108_5325# DELAY_OUT_LAST 0.01399f
C232 a_13121_5831# a_13592_5871# 0.01445f
C233 a_6326_4590# VDD 8.12264f
C234 a_19073_1842# a_19637_1842# 0.0114f
C235 a_12849_5867# a_13566_5835# 0.27346f
C236 a_1544_1044# a_2297_1395# 0.28651f
C237 a_23437_1842# a_24008_1044# 0.10863f
C238 a_9953_1842# a_10083_1842# 0.69911f
C239 a_3449_331# VDD 0.47436f
C240 a_16510_1044# a_17928_1044# 0.38994f
C241 a_19833_1842# VDD 0.70915f
C242 a_16793_1842# DELAY_VBIASP 0.11005f
C243 a_13121_5831# REF_CLK 1.40135f
C244 a_12849_5867# DLL_RESETN 0.34367f
C245 a_16923_1842# DELAY_VBIASN 0.0697f
C246 a_5115_1044# a_5191_1008# 0.01194f
C247 a_4350_1044# a_5844_1008# 0.28279f
C248 a_27237_1842# a_27433_1842# 0.72625f
C249 a_5844_1008# VDD 0.28358f
C250 a_13880_5118# VDD 0.03137f
C251 a_12505_1044# a_10430_1044# 0.03208f
C252 a_18117_1842# a_18877_1842# 0.02577f
C253 a_26911_2470# VDD 0.02372f
C254 a_12355_5867# a_12849_5867# 0.07687f
C255 a_27915_1044# a_27991_1008# 0.01194f
C256 a_18117_1842# VDD 0.92718f
C257 a_27124_1008# VDD 0.28358f
C258 a_12158_5867# DLL_RESETN 0.02442f
C259 a_15273_1842# DELAY_VBIASN 0.09318f
C260 a_15077_1842# DELAY_VBIASP 0.03922f
C261 a_11491_6228# REF_CLK 0.01827f
C262 a_14111_5227# VDD 0.35469f
C263 a_27705_1044# VDD 0.30052f
C264 a_25913_1842# a_26043_1842# 0.69911f
C265 a_15304_4605# DELAY_VBIASN 0.07802f
C266 a_4157_1313# MUX_SEL4 0.08229f
C267 a_12158_5867# a_12355_5867# 0.12454f
C268 a_17357_1842# a_16923_1842# 0.6972f
C269 a_26395_1044# a_26471_1008# 0.01194f
C270 a_20831_2470# VDD 0.02372f
C271 a_25630_1044# a_27124_1008# 0.28279f
C272 a_13470_1044# a_15755_1044# 0.39036f
C273 a_8237_1842# a_8433_1842# 0.72407f
C274 a_24875_1044# VDD 0.15484f
C275 a_27705_1044# a_25630_1044# 0.03208f
C276 a_15403_1842# VDD 0.85902f
C277 a_12363_1842# DELAY_VBIASP 0.06316f
C278 a_13557_1842# DELAY_VBIASN 0.07317f
C279 a_10206_5835# DLL_RESETN 0.27343f
C280 a_13106_5357# VDD 0.10008f
C281 a_15545_1044# VDD 0.30052f
C282 a_13566_5328# a_14009_5084# 0.02242f
C283 a_6425_1044# a_6711_1008# 0.01885f
C284 a_15304_4605# a_15108_5325# 0.01986f
C285 a_13306_5105# a_13592_5423# 0.41329f
C286 a_2873_1395# MUX_SEL0 0.01504f
C287 a_10751_5878# a_11491_6228# 0.26905f
C288 a_14751_2470# VDD 0.02372f
C289 a_16033_1842# a_16597_1842# 0.0114f
C290 a_4003_1842# REF_CLK 0.5248f
C291 a_9757_1842# a_10328_1044# 0.10864f
C292 a_16597_1842# a_17065_1044# 0.19203f
C293 a_6913_1842# a_7043_1842# 0.69911f
C294 a_6854_5986# REF_CLK 0.04054f
C295 a_13753_1842# VDD 0.70941f
C296 a_21911_1008# VDD 0.29229f
C297 a_10713_1842# DELAY_VBIASP 0.11005f
C298 a_10843_1842# DELAY_VBIASN 0.06808f
C299 a_13106_5357# a_13132_5420# 0.1657f
C300 a_4905_1044# a_4350_1044# 0.03209f
C301 a_24197_1842# a_24393_1842# 0.72625f
C302 a_4905_1044# VDD 0.30259f
C303 a_15108_6109# VDD 0.13564f
C304 a_4157_1313# a_4324_1008# 0.02463f
C305 a_16108_289# a_17865_519# 0.29564f
C306 a_12907_5186# a_12907_5420# 0.1117f
C307 a_1256_1044# MUX_SEL0 0.3314f
C308 a_15077_1842# a_15837_1842# 0.02577f
C309 a_18877_1842# a_19448_1044# 0.10864f
C310 a_22590_1044# a_24951_1008# 0.26208f
C311 a_8671_2470# VDD 0.02372f
C312 a_26803_1842# DELAY_VBIASN 0.0697f
C313 a_26673_1842# DELAY_VBIASP 0.11005f
C314 a_21625_1044# a_21835_1044# 0.09424f
C315 a_12037_1842# VDD 0.92718f
C316 a_9757_1842# a_7390_1044# 0.02479f
C317 a_19448_1044# VDD 0.18236f
C318 a_13470_1044# MUX_SEL4 0.05779f
C319 a_8997_1842# DELAY_VBIASP 0.03915f
C320 a_9193_1842# DELAY_VBIASN 0.09305f
C321 a_13566_5835# VDD 0.09483f
C322 a_2297_1395# VDD 0.47666f
C323 a_22873_1842# a_23003_1842# 0.69911f
C324 a_18877_1842# a_16510_1044# 0.02479f
C325 a_14317_1842# a_13883_1842# 0.6972f
C326 a_22488_1044# a_22590_1044# 0.37183f
C327 a_27997_1842# VDD 0.82766f
C328 a_25153_1842# DELAY_VBIASN 0.09549f
C329 a_24957_1842# DELAY_VBIASP 0.03914f
C330 a_15765_463# MUX_SEL4 0.65508f
C331 VDD DLL_RESETN 5.89762f
C332 a_16510_1044# VDD 2.0153f
C333 a_10328_1044# a_10404_1008# 0.01176f
C334 a_7477_1842# a_7364_1008# 0.05118f
C335 a_5197_1842# a_5393_1842# 0.72407f
C336 a_9323_1842# VDD 0.85903f
C337 a_7477_1842# DELAY_VBIASN 0.07317f
C338 a_6283_1842# DELAY_VBIASP 0.06316f
C339 a_14851_6228# a_15688_5867# 0.08776f
C340 a_5731_289# a_11785_519# 0.28056f
C341 a_12355_5867# VDD 0.40041f
C342 a_12849_5867# a_14009_5084# 0.03463f
C343 a_20968_1044# a_21044_1008# 0.01176f
C344 a_12993_1842# a_13557_1842# 0.0114f
C345 a_25283_1842# VDD 0.85925f
C346 a_13132_5420# DLL_RESETN 0.01689f
C347 a_16597_1842# a_16484_1008# 0.05118f
C348 a_23437_1842# DELAY_VBIASN 0.07573f
C349 a_5731_289# MUX_SEL4 4.60702f
C350 a_22243_1842# DELAY_VBIASP 0.06316f
C351 a_7673_1842# VDD 0.70915f
C352 a_13444_1008# VDD 0.28964f
C353 a_17065_1044# a_17275_1044# 0.09424f
C354 a_4763_1842# DELAY_VBIASN 0.06808f
C355 a_4633_1842# DELAY_VBIASP 0.11005f
C356 a_21157_1842# a_21353_1842# 0.72625f
C357 a_6854_5454# a_9444_3912# 0.84817f
C358 a_25717_1842# a_25604_1008# 0.05118f
C359 a_19550_1044# a_19524_1008# 0.277f
C360 a_6326_4590# a_6854_5986# 1.17368f
C361 a_7390_1044# a_5731_289# 0.41141f
C362 a_23633_1842# VDD 0.71037f
C363 a_12037_1842# a_12797_1842# 0.02577f
C364 a_15964_289# VDD 0.48724f
C365 a_2873_331# MUX_SEL3 0.12606f
C366 a_20723_1842# DELAY_VBIASN 0.0697f
C367 a_3449_331# MUX_SEL2 0.10741f
C368 a_2297_331# MUX_SEL4 0.04338f
C369 a_20593_1842# DELAY_VBIASP 0.11008f
C370 a_5957_1842# a_4350_1044# 0.05231f
C371 a_5957_1842# VDD 0.92718f
C372 a_11195_1044# VDD 0.15466f
C373 a_15464_3684# a_9712_3912# 0.01237f
C374 a_7390_1044# a_8155_1044# 0.39037f
C375 a_5197_1842# a_5191_1008# 0.02349f
C376 a_9746_5805# VDD 0.0996f
C377 a_19833_1842# a_19963_1842# 0.69911f
C378 a_13592_5871# a_14009_5878# 0.37583f
C379 a_13121_5831# a_15108_6109# 0.03701f
C380 a_12849_5867# a_14111_5878# 0.42174f
C381 a_13306_6305# a_13880_6292# 0.31978f
C382 a_13019_5831# a_14851_6228# 0.01651f
C383 a_15077_1842# a_13470_1044# 0.05231f
C384 a_8745_519# VDD 0.29602f
C385 a_21917_1842# VDD 0.97416f
C386 a_11277_1842# a_10843_1842# 0.6972f
C387 a_14009_5878# REF_CLK 0.25847f
C388 a_14317_1842# a_14311_1008# 0.02349f
C389 a_19073_1842# DELAY_VBIASN 0.0951f
C390 a_18877_1842# DELAY_VBIASP 0.03914f
C391 a_12505_1044# a_12791_1008# 0.01885f
C392 a_9444_4590# a_5864_3367# 0.04218f
C393 a_8231_1008# VDD 0.28469f
C394 a_9712_3912# VDD 0.2127f
C395 a_14851_5182# DELAY_OUT_LAST 0.02109f
C396 VDD DELAY_VBIASP 37.0123f
C397 a_1256_289# a_2873_331# 0.27926f
C398 a_6326_4590# a_9444_4590# 0.01269f
C399 a_23437_1842# a_23431_1008# 0.02349f
C400 a_24197_1842# a_22590_1044# 0.05231f
C401 a_1544_289# a_2297_331# 0.27303f
C402 a_13121_5831# a_13566_5835# 0.01158f
C403 a_1256_1044# a_2297_1395# 0.04619f
C404 a_22590_1044# a_16108_289# 0.43108f
C405 a_13019_5831# a_13592_5871# 0.04178f
C406 a_27563_1842# a_27671_1842# 0.01163f
C407 a_16510_1044# a_17351_1008# 0.28268f
C408 a_2873_331# VDD 0.47413f
C409 a_9953_1842# a_10517_1842# 0.0114f
C410 a_13019_5831# REF_CLK 0.35409f
C411 a_13121_5831# DLL_RESETN 0.04337f
C412 a_19203_1842# VDD 0.85925f
C413 a_12797_1842# a_13444_1008# 0.02011f
C414 a_17357_1842# DELAY_VBIASN 0.07573f
C415 a_25630_1044# DELAY_VBIASP 0.0137f
C416 a_16163_1842# DELAY_VBIASP 0.06316f
C417 a_4350_1044# a_5768_1044# 0.38994f
C418 a_27237_1842# a_26803_1842# 0.6972f
C419 a_5768_1044# VDD 0.17577f
C420 a_14851_5182# a_15688_5403# 0.08776f
C421 a_10985_1044# a_10430_1044# 0.03209f
C422 a_12656_5864# a_13019_5831# 0.04193f
C423 a_26151_2470# VDD 0.02372f
C424 a_12355_5867# a_13121_5831# 0.05795f
C425 a_18117_1842# a_18313_1842# 0.72625f
C426 a_21917_1842# a_22564_1008# 0.02011f
C427 a_26043_1842# a_26151_1842# 0.01163f
C428 a_8997_1842# a_9757_1842# 0.02577f
C429 a_27048_1044# VDD 0.17577f
C430 a_11748_6109# REF_CLK 0.0148f
C431 a_17553_1842# VDD 0.71037f
C432 a_27705_1044# a_27991_1008# 0.01885f
C433 a_12037_1842# a_11924_1008# 0.02055f
C434 a_11491_6228# DLL_RESETN 0.14622f
C435 a_15755_1044# a_15831_1008# 0.01194f
C436 a_14643_1842# DELAY_VBIASN 0.06828f
C437 a_14513_1842# DELAY_VBIASP 0.11018f
C438 a_26185_1044# VDD 0.30542f
C439 a_14009_5084# VDD 0.33745f
C440 a_25913_1842# a_26477_1842# 0.0114f
C441 a_7945_1044# a_8231_1008# 0.01885f
C442 a_13592_5423# a_14851_5182# 0.01529f
C443 a_25630_1044# a_27048_1044# 0.38994f
C444 a_20071_2470# VDD 0.02372f
C445 a_16793_1842# a_16923_1842# 0.69911f
C446 a_21157_1842# a_21044_1008# 0.02055f
C447 a_16510_1044# a_17865_519# 0.018f
C448 a_26185_1044# a_25630_1044# 0.03209f
C449 a_14235_1044# a_14311_1008# 0.01194f
C450 a_24084_1008# VDD 0.28358f
C451 a_11277_1842# a_10430_1044# 0.08038f
C452 a_8237_1842# a_7803_1842# 0.6972f
C453 a_18117_1842# a_18585_1044# 0.2079f
C454 a_13470_1044# a_14964_1008# 0.28279f
C455 a_15837_1842# VDD 0.96712f
C456 a_24523_1842# a_24631_1842# 0.01163f
C457 a_12797_1842# DELAY_VBIASP 0.03914f
C458 a_12993_1842# DELAY_VBIASN 0.09305f
C459 a_6425_1044# a_6635_1044# 0.09424f
C460 a_14025_1044# VDD 0.30542f
C461 a_13566_5328# a_13592_5423# 0.36952f
C462 a_15304_4605# a_14851_5182# 0.05156f
C463 a_24957_1842# a_25717_1842# 0.05863f
C464 a_10751_5878# a_11748_6109# 0.03061f
C465 a_10649_5878# a_11397_6228# 0.01058f
C466 a_20397_1842# a_19550_1044# 0.08038f
C467 a_13991_2470# VDD 0.02372f
C468 a_4437_1842# REF_CLK 0.04461f
C469 REF_CLK MUX_SEL1 0.01829f
C470 a_23145_1044# a_23431_1008# 0.01885f
C471 a_6854_5986# DLL_RESETN 0.28237f
C472 a_23003_1842# a_23111_1842# 0.01163f
C473 a_21835_1044# VDD 0.15484f
C474 a_9757_1842# a_9751_1008# 0.02354f
C475 a_6913_1842# a_7477_1842# 0.0114f
C476 a_13123_1842# VDD 0.85925f
C477 a_11277_1842# DELAY_VBIASN 0.07392f
C478 a_10083_1842# DELAY_VBIASP 0.06316f
C479 a_4157_1313# a_4350_1044# 0.04456f
C480 a_4157_1313# VDD 0.57212f
C481 a_16108_289# a_16851_309# 0.06181f
C482 a_24197_1842# a_23763_1842# 0.6972f
C483 a_13106_5357# a_12907_5420# 0.14994f
C484 a_14111_5878# VDD 0.22908f
C485 a_12849_5867# DELAY_OUT_LAST 0.01467f
C486 a_9946_6305# a_10751_5878# 0.097f
C487 a_22590_1044# a_24875_1044# 0.39036f
C488 a_7911_2470# VDD 0.02372f
C489 a_10232_5871# a_10649_5878# 0.37583f
C490 a_18877_1842# a_18871_1008# 0.02354f
C491 a_15077_1842# a_15273_1842# 0.72625f
C492 a_26043_1842# DELAY_VBIASP 0.06316f
C493 a_27237_1842# DELAY_VBIASN 0.07543f
C494 a_11473_1842# VDD 0.71037f
C495 a_27563_1842# a_27671_2470# 0.01697f
C496 a_10430_1044# a_12791_1008# 0.26208f
C497 a_5957_1842# a_6717_1842# 0.02577f
C498 a_18871_1008# VDD 0.29229f
C499 a_8237_1842# a_8884_1008# 0.02312f
C500 a_21483_1842# a_21591_1842# 0.01163f
C501 a_8563_1842# DELAY_VBIASN 0.06808f
C502 a_8433_1842# DELAY_VBIASP 0.11005f
C503 a_22873_1842# a_23437_1842# 0.0114f
C504 a_9444_4590# DLL_RESETN 0.01688f
C505 a_27433_1842# VDD 0.70905f
C506 a_10430_1044# a_11785_519# 0.01782f
C507 a_13753_1842# a_13883_1842# 0.69911f
C508 a_9772_5843# a_9946_6305# 0.27179f
C509 a_17357_1842# a_18004_1008# 0.02312f
C510 a_24523_1842# DELAY_VBIASN 0.0697f
C511 a_14825_519# MUX_SEL4 0.03307f
C512 a_24393_1842# DELAY_VBIASP 0.11005f
C513 a_19963_1842# a_20071_1842# 0.01163f
C514 a_10328_1044# a_10430_1044# 0.37183f
C515 a_26043_1842# a_26151_2470# 0.01697f
C516 a_5197_1842# a_4763_1842# 0.6972f
C517 a_9757_1842# VDD 0.97416f
C518 a_7477_1842# a_7390_1044# 0.1088f
C519 a_16408_1044# VDD 0.18093f
C520 a_10430_1044# MUX_SEL4 0.05749f
C521 a_6717_1842# DELAY_VBIASP 0.03914f
C522 MUX_SEL4 MUX_OUT 0.91933f
C523 a_6913_1842# DELAY_VBIASN 0.09305f
C524 a_12849_5867# a_13592_5423# 0.38072f
C525 a_26477_1842# a_27124_1008# 0.02312f
C526 a_21917_1842# a_22677_1842# 0.05863f
C527 a_16597_1842# a_16510_1044# 0.1088f
C528 a_12907_5420# DLL_RESETN 0.04234f
C529 a_25717_1842# VDD 0.93609f
C530 a_22873_1842# DELAY_VBIASN 0.09602f
C531 a_22677_1842# DELAY_VBIASP 0.03915f
C532 a_24523_1842# a_24631_2470# 0.01697f
C533 a_8808_1044# a_8884_1008# 0.01176f
C534 a_18585_1044# a_16510_1044# 0.03208f
C535 a_13470_1044# VDD 2.0134f
C536 a_18443_1842# a_18551_1842# 0.01163f
C537 a_7043_1842# VDD 0.85925f
C538 a_5197_1842# DELAY_VBIASN 0.07392f
C539 MUX_SEL0 MUX_SEL1 3.14917f
C540 a_4003_1842# DELAY_VBIASP 0.05735f
C541 a_21157_1842# a_20723_1842# 0.6972f
C542 a_5974_5723# a_5864_3367# 0.01697f
C543 a_12849_5867# a_15304_4605# 0.0606f
C544 a_25717_1842# a_25630_1044# 0.1088f
C545 a_13592_5871# a_14851_6228# 0.01529f
C546 a_6126_3816# a_9444_3912# 0.25721f
C547 a_6854_5986# a_9712_3912# 0.03156f
C548 a_6854_5454# a_5778_3367# 0.02497f
C549 a_6854_5986# DELAY_VBIASP 0.01478f
C550 a_23003_1842# VDD 0.85902f
C551 a_12037_1842# a_12233_1842# 0.72625f
C552 a_6326_4590# a_5974_5723# 0.32939f
C553 a_19448_1044# a_19524_1008# 0.01176f
C554 a_15765_463# VDD 0.35641f
C555 a_2297_331# MUX_SEL3 0.01595f
C556 a_1544_289# MUX_OUT 0.69943f
C557 a_19963_1842# DELAY_VBIASP 0.06316f
C558 a_21157_1842# DELAY_VBIASN 0.07543f
C559 a_1721_331# MUX_SEL4 0.05813f
C560 a_2873_331# MUX_SEL2 0.01422f
C561 a_16923_1842# a_17031_1842# 0.01163f
C562 a_23003_1842# a_23111_2470# 0.01697f
C563 a_5393_1842# VDD 0.71037f
C564 a_7390_1044# a_7364_1008# 0.277f
C565 a_10404_1008# VDD 0.28964f
C566 a_15464_3684# DELAY_OUT_LAST 0.01937f
C567 a_13121_5831# a_14111_5878# 0.0235f
C568 a_9547_6172# VDD 0.09227f
C569 a_13566_5835# a_14009_5878# 0.02242f
C570 a_19833_1842# a_20397_1842# 0.0114f
C571 a_4350_1044# a_5731_289# 0.40909f
C572 a_13592_5871# REF_CLK 0.11539f
C573 a_5731_289# VDD 0.63828f
C574 a_21353_1842# VDD 0.70905f
C575 a_10713_1842# a_10843_1842# 0.69911f
C576 a_18313_1842# DELAY_VBIASP 0.11005f
C577 a_18443_1842# DELAY_VBIASN 0.0697f
C578 a_21483_1842# a_21591_2470# 0.01697f
C579 a_15688_5403# a_15464_3684# 0.19544f
C580 a_12505_1044# a_12715_1044# 0.09424f
C581 a_8155_1044# VDD 0.15466f
C582 a_9444_4590# a_9712_3912# 0.57573f
C583 a_15403_1842# a_15511_1842# 0.01163f
C584 VDD DELAY_OUT_LAST 0.97966f
C585 a_18877_1842# a_19637_1842# 0.05863f
C586 a_1256_289# a_2297_331# 0.04261f
C587 a_1544_289# a_1721_331# 0.36963f
C588 a_19637_1842# VDD 0.93609f
C589 a_13019_5831# DLL_RESETN 0.01429f
C590 a_2297_331# VDD 0.47301f
C591 a_12656_5864# REF_CLK 0.01215f
C592 a_16510_1044# a_17275_1044# 0.39037f
C593 a_16597_1842# DELAY_VBIASP 0.03915f
C594 a_16793_1842# DELAY_VBIASN 0.09602f
C595 a_5191_1008# VDD 0.28698f
C596 a_14851_5182# a_15108_5325# 0.29858f
C597 a_14009_5084# a_14757_5182# 0.01058f
C598 a_15688_5403# VDD 0.31892f
C599 a_26673_1842# a_26803_1842# 0.69911f
C600 a_19963_1842# a_20071_2470# 0.01697f
C601 a_13883_1842# a_13991_1842# 0.01163f
C602 a_4350_1044# a_5191_1008# 0.28268f
C603 a_12355_5867# a_13019_5831# 0.3846f
C604 a_19550_1044# a_16108_289# 0.43108f
C605 a_25391_2470# VDD 0.02372f
C606 a_18117_1842# a_17683_1842# 0.6972f
C607 a_11748_6109# DLL_RESETN 0.11133f
C608 a_19637_1842# a_20105_1044# 0.19203f
C609 a_8997_1842# a_9193_1842# 0.72625f
C610 a_10751_5878# REF_CLK 0.01931f
C611 a_16923_1842# VDD 0.85902f
C612 a_26471_1008# VDD 0.28469f
C613 a_27705_1044# a_27915_1044# 0.09424f
C614 a_15077_1842# DELAY_VBIASN 0.0737f
C615 a_13883_1842# DELAY_VBIASP 0.06316f
C616 a_4437_1842# a_4905_1044# 0.19203f
C617 a_18443_1842# a_18551_2470# 0.01697f
C618 a_7945_1044# a_8155_1044# 0.09424f
C619 a_24665_1044# VDD 0.29855f
C620 a_13592_5423# VDD 0.13283f
C621 a_12363_1842# a_12471_1842# 0.01163f
C622 a_25630_1044# a_26471_1008# 0.28268f
C623 a_16793_1842# a_17357_1842# 0.0114f
C624 a_19311_2470# VDD 0.02372f
C625 a_16510_1044# a_16851_309# 0.01245f
C626 a_13470_1044# a_14888_1044# 0.38994f
C627 a_7673_1842# a_7803_1842# 0.69911f
C628 a_15273_1842# VDD 0.70918f
C629 a_24008_1044# VDD 0.17577f
C630 a_9946_6305# DLL_RESETN 0.09997f
C631 a_12363_1842# DELAY_VBIASN 0.06808f
C632 a_12233_1842# DELAY_VBIASP 0.11005f
C633 a_15304_4605# VDD 0.77714f
C634 a_12505_1044# VDD 0.29855f
C635 a_13566_5328# a_13306_5105# 0.75507f
C636 a_24957_1842# a_25153_1842# 0.72407f
C637 a_16923_1842# a_17031_2470# 0.01697f
C638 a_10843_1842# a_10951_1842# 0.01163f
C639 a_2297_1395# MUX_SEL1 0.01995f
C640 a_24875_1044# a_24951_1008# 0.01194f
C641 a_15837_1842# a_16597_1842# 0.05863f
C642 a_10232_5871# a_11397_6228# 0.43239f
C643 a_5864_3367# REF_CLK 0.01659f
C644 a_13231_2470# VDD 0.02372f
C645 a_21044_1008# VDD 0.28358f
C646 a_23145_1044# a_23355_1044# 0.09424f
C647 a_13557_1842# VDD 0.93609f
C648 a_10713_1842# DELAY_VBIASN 0.09305f
C649 a_10517_1842# DELAY_VBIASP 0.03915f
C650 a_3449_331# REF_CLK 0.01018f
C651 a_3449_1395# VDD 0.48234f
C652 a_15964_289# a_16851_309# 0.16757f
C653 a_23633_1842# a_23763_1842# 0.69911f
C654 a_13019_5831# DELAY_VBIASP 0.02377f
C655 a_13106_5357# a_12907_5186# 0.02437f
C656 a_13121_5831# DELAY_OUT_LAST 0.04358f
C657 a_15403_1842# a_15511_2470# 0.01697f
C658 a_4157_1313# a_4248_1044# 0.11511f
C659 a_9323_1842# a_9431_1842# 0.01163f
C660 a_13019_5831# a_9712_3912# 0.03275f
C661 a_9946_6305# a_10520_6292# 0.31978f
C662 a_10206_5835# a_10649_5878# 0.02242f
C663 a_7151_2470# VDD 0.02372f
C664 a_15077_1842# a_14643_1842# 0.6972f
C665 a_22590_1044# a_24084_1008# 0.28279f
C666 a_23355_1044# a_23431_1008# 0.01194f
C667 a_26477_1842# DELAY_VBIASP 0.03919f
C668 a_26673_1842# DELAY_VBIASN 0.09565f
C669 a_7803_1842# DELAY_VBIASP 0.06316f
C670 a_8997_1842# DELAY_VBIASN 0.07362f
C671 a_5957_1842# a_6153_1842# 0.72625f
C672 a_10430_1044# a_12715_1044# 0.39036f
C673 a_18795_1044# VDD 0.15484f
C674 a_8237_1842# a_8808_1044# 0.10863f
C675 a_10843_1842# VDD 0.85902f
C676 a_7803_1842# a_7911_1842# 0.01163f
C677 a_13883_1842# a_13991_2470# 0.01697f
C678 a_12849_5867# a_15108_5325# 0.10521f
C679 a_26803_1842# VDD 0.85925f
C680 a_13753_1842# a_14317_1842# 0.0114f
C681 a_23763_1842# DELAY_VBIASP 0.06316f
C682 a_24957_1842# DELAY_VBIASN 0.07573f
C683 a_17357_1842# a_17928_1044# 0.10863f
C684 a_11785_519# MUX_SEL4 0.03255f
C685 a_15831_1008# VDD 0.29168f
C686 a_6283_1842# DELAY_VBIASN 0.06808f
C687 a_4633_1842# a_4763_1842# 0.69911f
C688 a_6153_1842# DELAY_VBIASP 0.11005f
C689 a_18585_1044# a_18871_1008# 0.01885f
C690 a_9193_1842# VDD 0.70905f
C691 MUX_SEL3 MUX_OUT 0.79533f
C692 a_26477_1842# a_27048_1044# 0.10863f
C693 a_21917_1842# a_22113_1842# 0.72407f
C694 a_12363_1842# a_12471_2470# 0.01697f
C695 a_6283_1842# a_6391_1842# 0.01163f
C696 a_12849_5867# a_13306_5105# 0.10675f
C697 a_15108_6109# a_14851_6228# 0.29858f
C698 a_22243_1842# DELAY_VBIASN 0.0697f
C699 a_12907_5186# DLL_RESETN 0.02177f
C700 a_12797_1842# a_13557_1842# 0.05863f
C701 a_25153_1842# VDD 0.71046f
C702 a_19550_1044# a_21911_1008# 0.26208f
C703 a_26985_519# VDD 0.30089f
C704 a_22113_1842# DELAY_VBIASP 0.11007f
C705 a_7390_1044# MUX_SEL4 0.11061f
C706 a_13368_1044# VDD 0.18232f
C707 a_4633_1842# DELAY_VBIASN 0.09305f
C708 a_7477_1842# VDD 0.93609f
C709 a_4437_1842# DELAY_VBIASP 0.03915f
C710 a_17065_1044# a_16510_1044# 0.03209f
C711 a_10843_1842# a_10951_2470# 0.01697f
C712 a_4763_1842# a_4871_1842# 0.01163f
C713 a_10649_5878# VDD 0.24968f
C714 a_14009_5878# a_14111_5878# 0.47795f
C715 a_6126_3816# a_5778_3367# 1.6143f
C716 a_5974_5723# a_9712_3912# 0.01152f
C717 a_25630_1044# a_26985_519# 0.018f
C718 a_20593_1842# a_20723_1842# 0.69911f
C719 a_13121_5831# a_15304_4605# 0.40633f
C720 a_23437_1842# VDD 0.93774f
C721 a_1544_289# MUX_SEL4 0.47529f
C722 a_20593_1842# DELAY_VBIASN 0.09436f
C723 a_1256_289# MUX_OUT 0.1134f
C724 a_14825_519# VDD 0.29891f
C725 a_12037_1842# a_11603_1842# 0.6972f
C726 a_20397_1842# DELAY_VBIASP 0.03914f
C727 a_19448_1044# a_19550_1044# 0.37183f
C728 a_2297_331# MUX_SEL2 0.10655f
C729 a_7288_1044# a_7364_1008# 0.01176f
C730 a_14025_1044# a_14311_1008# 0.01885f
C731 a_10430_1044# VDD 2.01462f
C732 a_4763_1842# VDD 0.85902f
C733 VDD MUX_OUT 1.15067f
C734 a_13566_5835# a_13592_5871# 0.36952f
C735 a_9547_5942# VDD 0.16041f
C736 a_9323_1842# a_9431_2470# 0.01697f
C737 a_17683_1842# DELAY_VBIASP 0.06316f
C738 a_20723_1842# VDD 0.85925f
C739 a_17928_1044# a_18004_1008# 0.01176f
C740 a_13566_5835# REF_CLK 0.01538f
C741 a_18877_1842# DELAY_VBIASN 0.07573f
C742 a_10713_1842# a_11277_1842# 0.0114f
C743 a_7477_1842# a_7945_1044# 0.19203f
C744 a_7364_1008# VDD 0.28964f
C745 a_15108_5325# a_15464_3684# 0.12158f
C746 a_27997_1842# a_27563_1842# 0.69646f
C747 a_9444_4590# a_9444_3912# 2.19613f
C748 DLL_RESETN REF_CLK 2.74214f
C749 VDD DELAY_VBIASN 1.03926f
C750 a_12849_5867# a_13306_6305# 0.12097f
C751 a_7803_1842# a_7911_2470# 0.01697f
C752 a_1544_1044# a_1721_1395# 0.38063f
C753 a_18877_1842# a_19073_1842# 0.72407f
C754 a_1256_289# a_1721_331# 0.13421f
C755 a_16163_1842# DELAY_VBIASN 0.06961f
C756 a_12656_5864# DLL_RESETN 0.11782f
C757 a_21157_1842# a_21625_1044# 0.2079f
C758 a_19073_1842# VDD 0.71046f
C759 a_12355_5867# REF_CLK 1.0042f
C760 a_1721_331# VDD 0.45834f
C761 a_12797_1842# a_13368_1044# 0.10864f
C762 a_16510_1044# a_16484_1008# 0.277f
C763 a_16033_1842# DELAY_VBIASP 0.11008f
C764 a_9757_1842# a_10517_1842# 0.05863f
C765 a_13592_5423# a_14757_5182# 0.43239f
C766 a_15108_5325# VDD 0.14081f
C767 a_4350_1044# a_5115_1044# 0.39037f
C768 a_14111_5227# a_13880_5118# 0.12701f
C769 a_26673_1842# a_27237_1842# 0.0114f
C770 a_5115_1044# VDD 0.15466f
C771 a_5957_1842# a_6425_1044# 0.2079f
C772 a_12355_5867# a_12656_5864# 0.03277f
C773 a_17553_1842# a_17683_1842# 0.69911f
C774 a_21917_1842# a_22488_1044# 0.10864f
C775 a_6854_5986# a_15304_4605# 0.07441f
C776 a_6283_1842# a_6391_2470# 0.01697f
C777 a_24631_2470# VDD 0.02372f
C778 a_12797_1842# a_10430_1044# 0.02479f
C779 a_14513_1842# DELAY_VBIASN 0.09371f
C780 a_17357_1842# VDD 0.93774f
C781 a_10751_5878# DLL_RESETN 0.45018f
C782 a_14317_1842# DELAY_VBIASP 0.03961f
C783 a_26395_1044# VDD 0.15466f
C784 a_8997_1842# a_8563_1842# 0.6972f
C785 a_25717_1842# a_26477_1842# 0.01335f
C786 a_15304_4605# a_14757_5182# 0.02225f
C787 a_23145_1044# VDD 0.30542f
C788 a_13306_5105# VDD 0.80534f
C789 a_4437_1842# a_4157_1313# 0.01771f
C790 a_9465_1044# a_7390_1044# 0.03208f
C791 a_18551_2470# VDD 0.02372f
C792 a_4763_1842# a_4871_2470# 0.01697f
C793 a_21917_1842# a_19550_1044# 0.02479f
C794 a_25630_1044# a_26395_1044# 0.39037f
C795 a_16510_1044# a_16108_289# 0.43331f
C796 a_14643_1842# VDD 0.85929f
C797 a_10517_1842# a_10404_1008# 0.05118f
C798 a_11603_1842# DELAY_VBIASP 0.06316f
C799 a_9772_5843# DLL_RESETN 0.06592f
C800 a_7673_1842# a_8237_1842# 0.0114f
C801 a_13470_1044# a_14311_1008# 0.28268f
C802 a_12797_1842# DELAY_VBIASN 0.07392f
C803 a_23431_1008# VDD 0.28469f
C804 a_24957_1842# a_24523_1842# 0.6972f
C805 a_13132_5420# a_13306_5105# 0.27179f
C806 a_10985_1044# VDD 0.30542f
C807 a_2297_1395# MUX_SEL0 0.10655f
C808 a_15837_1842# a_16033_1842# 0.72407f
C809 a_27563_1842# DELAY_VBIASP 0.06318f
C810 a_12471_2470# VDD 0.02372f
C811 a_9712_3912# REF_CLK 0.04752f
C812 a_5864_3367# DLL_RESETN 0.01688f
C813 a_10520_6292# a_10751_5878# 0.12701f
C814 a_19637_1842# a_19524_1008# 0.05118f
C815 REF_CLK DELAY_VBIASP 0.08317f
C816 a_12715_1044# a_12791_1008# 0.01194f
C817 a_24665_1044# a_22590_1044# 0.03208f
C818 a_10083_1842# DELAY_VBIASN 0.06808f
C819 a_6717_1842# a_7477_1842# 0.05863f
C820 a_9953_1842# DELAY_VBIASP 0.11005f
C821 a_20968_1044# VDD 0.17577f
C822 a_12993_1842# VDD 0.71046f
C823 a_23633_1842# a_24197_1842# 0.0114f
C824 a_13019_5831# DELAY_OUT_LAST 0.07707f
C825 a_15964_289# a_16108_289# 0.42202f
C826 a_26043_1842# DELAY_VBIASN 0.0697f
C827 a_14513_1842# a_14643_1842# 0.69911f
C828 a_10206_5835# a_10232_5871# 0.36952f
C829 a_25913_1842# DELAY_VBIASP 0.11005f
C830 a_22590_1044# a_24008_1044# 0.38994f
C831 a_6391_2470# VDD 0.02372f
C832 a_11277_1842# VDD 0.93774f
C833 a_8237_1842# a_8231_1008# 0.02349f
C834 a_11195_1044# a_11271_1008# 0.01194f
C835 a_8997_1842# a_7390_1044# 0.05231f
C836 a_10430_1044# a_11924_1008# 0.28279f
C837 a_8433_1842# DELAY_VBIASN 0.09305f
C838 a_18004_1008# VDD 0.28358f
C839 a_5957_1842# a_5523_1842# 0.6972f
C840 a_8237_1842# DELAY_VBIASP 0.03914f
C841 a_13306_6305# VDD 0.78103f
C842 a_22677_1842# a_23437_1842# 0.01335f
C843 a_13121_5831# a_15108_5325# 0.05714f
C844 a_12849_5867# a_14851_5182# 0.13376f
C845 a_1721_1395# VDD 0.46949f
C846 a_13019_5831# a_15688_5403# 0.12862f
C847 a_15688_5867# a_15304_4605# 0.19136f
C848 a_17357_1842# a_17351_1008# 0.02349f
C849 a_24393_1842# DELAY_VBIASN 0.09602f
C850 a_18117_1842# a_16510_1044# 0.05231f
C851 a_24197_1842# DELAY_VBIASP 0.03915f
C852 a_27237_1842# VDD 0.92838f
C853 a_9746_5805# a_9772_5843# 0.1657f
C854 a_4633_1842# a_5197_1842# 0.0114f
C855 a_18585_1044# a_18795_1044# 0.09424f
C856 a_8563_1842# VDD 0.85925f
C857 a_15755_1044# VDD 0.15466f
C858 a_6717_1842# a_7364_1008# 0.02011f
C859 a_6717_1842# DELAY_VBIASN 0.07392f
C860 a_5523_1842# DELAY_VBIASP 0.06316f
C861 MUX_SEL3 MUX_SEL4 0.75489f
C862 MUX_SEL2 MUX_OUT 0.08497f
C863 a_12849_5867# a_13566_5328# 0.26312f
C864 a_14111_5878# a_14851_6228# 0.26905f
C865 a_21917_1842# a_21483_1842# 0.6972f
C866 a_26477_1842# a_26471_1008# 0.02349f
C867 a_27237_1842# a_25630_1044# 0.05253f
C868 a_15837_1842# a_16484_1008# 0.02011f
C869 a_12797_1842# a_12993_1842# 0.72407f
C870 a_19550_1044# a_21835_1044# 0.39036f
C871 a_21483_1842# DELAY_VBIASP 0.06316f
C872 a_23945_519# VDD 0.30044f
C873 a_6126_3816# a_6854_5454# 0.19098f
C874 a_13106_5357# DLL_RESETN 0.01263f
C875 a_22677_1842# DELAY_VBIASN 0.07499f
C876 a_24523_1842# VDD 0.85903f
C877 a_12791_1008# VDD 0.29225f
C878 a_4003_1842# DELAY_VBIASN 0.06129f
C879 a_5864_3367# DELAY_VBIASP 0.02026f
C880 a_7390_1044# a_9751_1008# 0.26208f
C881 a_6913_1842# VDD 0.71046f
C882 a_5957_1842# a_5844_1008# 0.02055f
C883 a_20593_1842# a_21157_1842# 0.0114f
C884 a_24957_1842# a_25604_1008# 0.02011f
C885 a_6326_4590# a_9712_3912# 0.04737f
C886 a_13019_5831# a_15304_4605# 0.07025f
C887 a_14009_5878# a_13880_6292# 0.01562f
C888 a_10232_5871# VDD 0.09601f
C889 a_6854_5986# DELAY_VBIASN 0.15808f
C890 a_13592_5871# a_14111_5878# 0.34102f
C891 a_5705_519# a_5731_289# 0.28954f
C892 a_4157_1313# REF_CLK 0.45375f
C893 a_11785_519# VDD 0.29891f
C894 a_1256_289# MUX_SEL4 0.65005f
C895 a_22873_1842# VDD 0.70915f
C896 a_1721_331# MUX_SEL2 0.01315f
C897 a_14111_5878# REF_CLK 0.02263f
C898 a_11473_1842# a_11603_1842# 0.69911f
C899 a_19833_1842# DELAY_VBIASP 0.11005f
C900 a_15077_1842# a_14964_1008# 0.02055f
C901 a_1544_289# MUX_SEL3 0.15976f
C902 a_19963_1842# DELAY_VBIASN 0.0697f
C903 a_10328_1044# VDD 0.18236f
C904 a_5197_1842# a_4350_1044# 0.08038f
C905 a_8997_1842# a_9465_1044# 0.2079f
C906 a_5197_1842# VDD 0.93774f
C907 a_7288_1044# a_7390_1044# 0.37183f
C908 a_14025_1044# a_14235_1044# 0.09424f
C909 a_4350_1044# MUX_SEL4 0.09136f
C910 VDD MUX_SEL4 4.25383f
C911 a_12849_5867# a_12943_5867# 0.16706f
C912 a_24197_1842# a_24084_1008# 0.02055f
C913 a_19637_1842# a_20397_1842# 0.01335f
C914 a_6854_5454# VDD 1.80901f
C915 a_18313_1842# DELAY_VBIASN 0.09602f
C916 a_21157_1842# VDD 0.92718f
C917 a_18117_1842# DELAY_VBIASP 0.03915f
C918 a_14317_1842# a_13470_1044# 0.08038f
C919 a_22677_1842# a_23145_1044# 0.19203f
C920 a_14851_5182# a_15464_3684# 0.04597f
C921 a_9444_4590# a_5778_3367# 0.19787f
C922 a_5768_1044# a_5844_1008# 0.01176f
C923 a_7390_1044# VDD 2.01762f
C924 a_27433_1842# a_27563_1842# 0.69911f
C925 a_13019_5831# a_13045_6215# 0.01249f
C926 a_13121_5831# a_13306_6305# 0.01008f
C927 a_18877_1842# a_18443_1842# 0.6972f
C928 a_1256_1044# a_1721_1395# 0.13421f
C929 a_1256_289# a_1544_289# 1.25711f
C930 a_23437_1842# a_22590_1044# 0.08038f
C931 a_9757_1842# a_9953_1842# 0.72407f
C932 a_12355_5867# DLL_RESETN 0.04879f
C933 a_15403_1842# DELAY_VBIASP 0.06323f
C934 a_12797_1842# a_12791_1008# 0.02354f
C935 a_16408_1044# a_16484_1008# 0.01176f
C936 a_16597_1842# DELAY_VBIASN 0.07499f
C937 a_18443_1842# VDD 0.85903f
C938 a_1544_289# VDD 0.39668f
C939 a_14009_5084# a_13880_5118# 0.01562f
C940 a_4324_1008# VDD 0.28929f
C941 a_9465_1044# a_9751_1008# 0.01885f
C942 a_14851_5182# VDD 0.27539f
C943 a_4350_1044# a_4324_1008# 0.277f
C944 a_17553_1842# a_18117_1842# 0.0114f
C945 a_23871_2470# VDD 0.02372f
C946 a_27048_1044# a_27124_1008# 0.01176f
C947 a_21917_1842# a_21911_1008# 0.02354f
C948 a_8433_1842# a_8563_1842# 0.69911f
C949 a_25604_1008# VDD 0.28964f
C950 a_11277_1842# a_11924_1008# 0.02312f
C951 a_16793_1842# VDD 0.70898f
C952 a_13883_1842# DELAY_VBIASN 0.06808f
C953 a_13753_1842# DELAY_VBIASP 0.11005f
C954 a_25717_1842# a_25913_1842# 0.72565f
C955 a_14009_5084# a_14111_5227# 0.47622f
C956 a_13566_5328# VDD 0.09979f
C957 a_21625_1044# VDD 0.29855f
C958 a_3449_1395# MUX_SEL1 0.29404f
C959 a_7945_1044# a_7390_1044# 0.03209f
C960 a_16597_1842# a_17357_1842# 0.01335f
C961 a_11491_6228# a_11397_6228# 0.28931f
C962 a_25630_1044# a_25604_1008# 0.277f
C963 a_17791_2470# VDD 0.02372f
C964 a_20397_1842# a_21044_1008# 0.02312f
C965 a_15077_1842# VDD 0.92835f
C966 a_10517_1842# a_10430_1044# 0.1088f
C967 a_12037_1842# DELAY_VBIASP 0.03915f
C968 a_13470_1044# a_14235_1044# 0.39037f
C969 a_12233_1842# DELAY_VBIASN 0.09305f
C970 a_24665_1044# a_24951_1008# 0.01885f
C971 a_23355_1044# VDD 0.15466f
C972 a_24393_1842# a_24523_1842# 0.69911f
C973 a_9465_1044# VDD 0.29855f
C974 a_10232_5871# a_11491_6228# 0.01529f
C975 a_15837_1842# a_15403_1842# 0.6972f
C976 a_9712_3912# DLL_RESETN 0.39633f
C977 a_19637_1842# a_19550_1044# 0.1088f
C978 a_27997_1842# DELAY_VBIASP 0.03777f
C979 a_11711_2470# VDD 0.02372f
C980 DLL_RESETN DELAY_VBIASP 0.05892f
C981 a_6717_1842# a_6913_1842# 0.72407f
C982 a_20391_1008# VDD 0.28469f
C983 a_23145_1044# a_22590_1044# 0.03209f
C984 a_9323_1842# DELAY_VBIASP 0.06316f
C985 a_12363_1842# VDD 0.85903f
C986 a_10517_1842# DELAY_VBIASN 0.07317f
C987 a_15765_463# a_16108_289# 0.42004f
C988 a_13019_5831# DELAY_VBIASN 1.23663f
C989 a_12943_5867# VDD 0.3011f
C990 a_9946_6305# a_10649_5878# 0.02432f
C991 a_14513_1842# a_15077_1842# 0.0114f
C992 a_5631_2470# VDD 0.02372f
C993 a_25283_1842# DELAY_VBIASP 0.06316f
C994 a_22590_1044# a_23431_1008# 0.28268f
C995 a_16851_309# MUX_OUT 0.45865f
C996 a_26477_1842# DELAY_VBIASN 0.07484f
C997 a_5393_1842# a_5523_1842# 0.69911f
C998 a_10713_1842# VDD 0.70915f
C999 a_17928_1044# VDD 0.17577f
C1000 a_20105_1044# a_20391_1008# 0.01885f
C1001 a_7673_1842# DELAY_VBIASP 0.11005f
C1002 a_7803_1842# DELAY_VBIASN 0.06808f
C1003 a_10430_1044# a_11848_1044# 0.38994f
C1004 a_13121_5831# a_14851_5182# 0.02878f
C1005 a_14851_6228# a_15304_4605# 0.12139f
C1006 a_22677_1842# a_22873_1842# 0.72565f
C1007 a_12849_5867# VDD 2.97867f
C1008 a_1544_1044# VDD 0.56457f
C1009 a_5731_289# a_16108_289# 0.01334f
C1010 a_13557_1842# a_14317_1842# 0.01335f
C1011 a_13592_5423# REF_CLK 0.03445f
C1012 a_23633_1842# DELAY_VBIASP 0.11007f
C1013 a_23763_1842# DELAY_VBIASN 0.0697f
C1014 a_26673_1842# VDD 0.71037f
C1015 a_21835_1044# a_21911_1008# 0.01194f
C1016 a_8997_1842# VDD 0.92718f
C1017 a_14964_1008# VDD 0.28358f
C1018 a_5957_1842# DELAY_VBIASP 0.03915f
C1019 a_6153_1842# DELAY_VBIASN 0.09305f
C1020 MUX_SEL2 MUX_SEL4 0.01978f
C1021 a_14111_5878# a_15108_6109# 0.03093f
C1022 a_12849_5867# a_13132_5420# 0.06256f
C1023 a_21353_1842# a_21483_1842# 0.69911f
C1024 a_12158_5867# VDD 0.39251f
C1025 a_19550_1044# a_21044_1008# 0.28279f
C1026 a_20315_1044# a_20391_1008# 0.01194f
C1027 a_12797_1842# a_12363_1842# 0.6972f
C1028 a_6854_5986# a_6854_5454# 0.27156f
C1029 a_21917_1842# DELAY_VBIASP 0.03914f
C1030 a_20905_519# VDD 0.30044f
C1031 a_22113_1842# DELAY_VBIASN 0.0948f
C1032 a_24957_1842# VDD 0.97415f
C1033 a_15304_4605# REF_CLK 0.01066f
C1034 a_7390_1044# a_9675_1044# 0.39036f
C1035 a_10517_1842# a_10985_1044# 0.19203f
C1036 a_4437_1842# DELAY_VBIASN 0.07317f
C1037 a_6283_1842# VDD 0.85903f
C1038 a_9712_3912# DELAY_VBIASP 0.1109f
C1039 a_12715_1044# VDD 0.15484f
C1040 a_13592_5871# a_13880_6292# 0.43707f
C1041 a_5974_5723# a_5778_3367# 2.87939f
C1042 a_10206_5835# VDD 0.11162f
C1043 a_24197_1842# a_24665_1044# 0.2079f
C1044 a_11473_1842# a_12037_1842# 0.0114f
C1045 a_22243_1842# VDD 0.85925f
C1046 a_19203_1842# DELAY_VBIASP 0.06316f
C1047 a_20397_1842# DELAY_VBIASN 0.07573f
C1048 a_1544_289# MUX_SEL2 0.07405f
C1049 a_3449_1395# REF_CLK 0.01068f
C1050 a_1256_289# MUX_SEL3 1.41161f
C1051 a_15545_1044# a_13470_1044# 0.03208f
C1052 a_4633_1842# VDD 0.70905f
C1053 a_9751_1008# VDD 0.29229f
C1054 VDD MUX_SEL3 0.40997f
C1055 a_22590_1044# a_23945_519# 0.018f
C1056 a_19637_1842# a_19833_1842# 0.72565f
C1057 a_13121_5831# a_12943_5867# 0.09118f
C1058 a_13306_6305# a_14009_5878# 0.02432f
C1059 a_6854_5454# a_9444_4590# 1.24089f
C1060 a_6126_3816# VDD 0.9531f
C1061 a_10517_1842# a_11277_1842# 0.01335f
C1062 a_16510_1044# a_18871_1008# 0.26208f
C1063 a_20593_1842# VDD 0.71037f
C1064 a_17683_1842# DELAY_VBIASN 0.06962f
C1065 a_17553_1842# DELAY_VBIASP 0.11005f
C1066 a_14851_5182# a_14757_5182# 0.28931f
C1067 a_27433_1842# a_27997_1842# 0.0114f
C1068 a_7288_1044# VDD 0.18236f
C1069 a_15464_3684# VDD 0.5374f
C1070 a_14111_5227# DELAY_OUT_LAST 0.02024f
C1071 a_1256_1044# a_1544_1044# 1.26509f
C1072 a_18313_1842# a_18443_1842# 0.69911f
C1073 a_13121_5831# a_12849_5867# 0.54766f
C1074 a_26803_1842# a_26911_1842# 0.01163f
C1075 a_16408_1044# a_16510_1044# 0.37183f
C1076 a_9757_1842# a_9323_1842# 0.6972f
C1077 a_16033_1842# DELAY_VBIASN 0.09308f
C1078 a_15837_1842# DELAY_VBIASP 0.0392f
C1079 a_18877_1842# VDD 0.97416f
C1080 a_1256_289# VDD 0.41094f
C1081 a_4248_1044# a_4324_1008# 0.01176f
C1082 a_13592_5423# a_13880_5118# 0.43707f
C1083 a_26477_1842# a_27237_1842# 0.02984f
C1084 a_9465_1044# a_9675_1044# 0.09424f
C1085 a_4350_1044# VDD 2.01728f
C1086 a_23111_2470# VDD 0.02372f
C1087 a_25283_1842# a_25391_1842# 0.01163f
C1088 a_11277_1842# a_11848_1044# 0.10863f
C1089 a_8433_1842# a_8997_1842# 0.0114f
C1090 a_14888_1044# a_14964_1008# 0.01176f
C1091 a_13123_1842# DELAY_VBIASP 0.06316f
C1092 a_25630_1044# VDD 2.01433f
C1093 a_14317_1842# DELAY_VBIASN 0.07392f
C1094 a_10649_5878# REF_CLK 0.25484f
C1095 a_16163_1842# VDD 0.85925f
C1096 a_25717_1842# a_25283_1842# 0.69698f
C1097 a_13592_5423# a_14111_5227# 0.34114f
C1098 a_3449_1395# MUX_SEL0 0.10753f
C1099 a_13132_5420# VDD 0.25347f
C1100 a_20105_1044# VDD 0.30542f
C1101 a_20397_1842# a_20968_1044# 0.10863f
C1102 a_16597_1842# a_16793_1842# 0.72565f
C1103 a_11491_6228# a_12158_5867# 0.0894f
C1104 a_25528_1044# a_25604_1008# 0.01176f
C1105 a_17031_2470# VDD 0.02372f
C1106 a_7477_1842# a_8237_1842# 0.01335f
C1107 a_23763_1842# a_23871_1842# 0.01163f
C1108 a_13470_1044# a_13444_1008# 0.277f
C1109 a_24665_1044# a_24875_1044# 0.09424f
C1110 a_11603_1842# DELAY_VBIASN 0.06808f
C1111 a_14513_1842# VDD 0.71057f
C1112 a_11473_1842# DELAY_VBIASP 0.11005f
C1113 a_22564_1008# VDD 0.28964f
C1114 a_15304_4605# a_14111_5227# 0.01761f
C1115 a_4905_1044# a_5191_1008# 0.01885f
C1116 a_16108_289# a_26985_519# 0.27952f
C1117 a_24393_1842# a_24957_1842# 0.0114f
C1118 a_7945_1044# VDD 0.30542f
C1119 a_15273_1842# a_15403_1842# 0.69911f
C1120 a_10649_5878# a_10751_5878# 0.47795f
C1121 a_9444_3912# DLL_RESETN 0.02134f
C1122 a_27997_1842# DELAY_OUT_LAST 0.7096f
C1123 a_27563_1842# DELAY_VBIASN 0.06974f
C1124 a_27433_1842# DELAY_VBIASP 0.11005f
C1125 a_10951_2470# VDD 0.02372f
C1126 REF_CLK DELAY_VBIASN 0.06978f
C1127 a_6717_1842# a_6283_1842# 0.6972f
C1128 a_22243_1842# a_22351_1842# 0.01163f
C1129 a_9757_1842# DELAY_VBIASP 0.03914f
C1130 a_20315_1044# VDD 0.15466f
C1131 a_9953_1842# DELAY_VBIASN 0.09305f
C1132 a_12797_1842# VDD 0.97415f
C1133 a_23437_1842# a_24197_1842# 0.02984f
C1134 a_15765_463# a_15964_289# 0.061f
C1135 a_13121_5831# a_15464_3684# 0.31727f
C1136 a_2873_1395# VDD 0.4796f
C1137 a_9946_6305# a_10232_5871# 0.41329f
C1138 a_22590_1044# a_23355_1044# 0.39037f
C1139 a_25717_1842# DELAY_VBIASP 0.03915f
C1140 a_4871_2470# VDD 0.02372f
C1141 a_25913_1842# DELAY_VBIASN 0.09602f
C1142 a_16108_289# MUX_OUT 0.24265f
C1143 a_26803_1842# a_26911_2470# 0.01697f
C1144 a_5393_1842# a_5957_1842# 0.0114f
C1145 a_20105_1044# a_20315_1044# 0.09424f
C1146 a_10430_1044# a_11271_1008# 0.28268f
C1147 a_20723_1842# a_20831_1842# 0.01163f
C1148 a_10083_1842# VDD 0.85925f
C1149 a_8237_1842# DELAY_VBIASN 0.07392f
C1150 a_17351_1008# VDD 0.28698f
C1151 a_7043_1842# DELAY_VBIASP 0.06316f
C1152 a_22677_1842# a_22243_1842# 0.69698f
C1153 a_5731_289# a_15964_289# 0.2778f
C1154 a_15108_6109# a_15304_4605# 0.17528f
C1155 a_13121_5831# VDD 1.4119f
C1156 a_1256_1044# VDD 0.57525f
C1157 a_9547_5942# a_9772_5843# 0.02416f
C1158 a_13557_1842# a_13753_1842# 0.72565f
C1159 a_9547_6172# a_9746_5805# 0.02437f
C1160 a_26043_1842# VDD 0.85902f
C1161 a_24197_1842# DELAY_VBIASN 0.07543f
C1162 a_13306_5105# REF_CLK 0.06166f
C1163 a_23003_1842# DELAY_VBIASP 0.06316f
C1164 a_6717_1842# a_7288_1044# 0.10864f
C1165 a_19203_1842# a_19311_1842# 0.01163f
C1166 a_25283_1842# a_25391_2470# 0.01697f
C1167 a_12037_1842# a_12505_1044# 0.2079f
C1168 a_9675_1044# a_9751_1008# 0.01194f
C1169 a_4437_1842# a_5197_1842# 0.01335f
C1170 a_5523_1842# DELAY_VBIASN 0.06808f
C1171 a_5393_1842# DELAY_VBIASP 0.11005f
C1172 a_8433_1842# VDD 0.71037f
C1173 a_14888_1044# VDD 0.17577f
C1174 MUX_SEL2 MUX_SEL3 3.21891f
C1175 a_21353_1842# a_21917_1842# 0.0114f
C1176 a_5731_289# a_8745_519# 0.28635f
C1177 a_11491_6228# VDD 0.18135f
C1178 a_12233_1842# a_12363_1842# 0.69911f
C1179 a_6854_5986# a_6126_3816# 0.11771f
C1180 a_19550_1044# a_20968_1044# 0.38994f
C1181 a_25717_1842# a_26185_1044# 0.19203f
C1182 a_5974_5723# a_6854_5454# 0.01501f
C1183 a_15837_1842# a_16408_1044# 0.10864f
C1184 a_21483_1842# DELAY_VBIASN 0.0697f
C1185 a_24393_1842# VDD 0.70905f
C1186 a_17865_519# VDD 0.30196f
C1187 a_5705_519# MUX_SEL4 0.03556f
C1188 a_15304_4605# DLL_RESETN 0.03137f
C1189 a_21353_1842# DELAY_VBIASP 0.11005f
C1190 a_5778_3367# a_5864_3367# 0.07051f
C1191 a_9444_3912# a_9712_3912# 0.80775f
C1192 a_7390_1044# a_8884_1008# 0.28279f
C1193 a_6717_1842# a_4350_1044# 0.02479f
C1194 a_8155_1044# a_8231_1008# 0.01194f
C1195 a_23763_1842# a_23871_2470# 0.01697f
C1196 a_17683_1842# a_17791_1842# 0.01163f
C1197 a_15545_1044# a_15831_1008# 0.01885f
C1198 a_6717_1842# VDD 0.97416f
C1199 a_11924_1008# VDD 0.28358f
C1200 DELAY_OUT_LAST DELAY_VBIASP 1.34214f
C1201 a_20397_1842# a_21157_1842# 0.02984f
C1202 a_6326_4590# a_5778_3367# 0.87631f
C1203 a_24957_1842# a_25528_1044# 0.10864f
C1204 a_15837_1842# a_13470_1044# 0.02479f
C1205 a_19637_1842# DELAY_VBIASP 0.03915f
C1206 a_1256_289# MUX_SEL2 0.33134f
C1207 a_22677_1842# VDD 0.93609f
C1208 a_19833_1842# DELAY_VBIASN 0.09602f
C1209 a_16163_1842# a_16271_1842# 0.01163f
C1210 a_14025_1044# a_13470_1044# 0.03209f
C1211 a_4437_1842# a_4324_1008# 0.05118f
C1212 a_22243_1842# a_22351_2470# 0.01697f
C1213 a_4003_1842# VDD 0.97933f
C1214 VDD MUX_SEL2 0.49863f
C1215 a_9675_1044# VDD 0.15484f
C1216 a_13019_5831# a_12943_5867# 0.03346f
C1217 a_13306_6305# a_13592_5871# 0.41329f
C1218 a_1256_1044# a_2873_1395# 0.28892f
C1219 a_24957_1842# a_22590_1044# 0.02479f
C1220 a_6126_3816# a_9444_4590# 0.03029f
C1221 a_19637_1842# a_19203_1842# 0.69698f
C1222 a_12849_5867# a_14009_5878# 0.03525f
C1223 a_6854_5986# VDD 2.86504f
C1224 a_16510_1044# a_18795_1044# 0.39036f
C1225 a_10517_1842# a_10713_1842# 0.72565f
C1226 a_13557_1842# a_13444_1008# 0.05118f
C1227 a_18117_1842# DELAY_VBIASN 0.07543f
C1228 a_16923_1842# DELAY_VBIASP 0.06316f
C1229 a_13306_6305# REF_CLK 0.05059f
C1230 a_19963_1842# VDD 0.85902f
C1231 a_4350_1044# a_6711_1008# 0.26208f
C1232 a_20723_1842# a_20831_2470# 0.01697f
C1233 a_14643_1842# a_14751_1842# 0.01163f
C1234 a_10985_1044# a_11271_1008# 0.01885f
C1235 a_6711_1008# VDD 0.29229f
C1236 a_14009_5084# DELAY_OUT_LAST 0.25594f
C1237 a_22677_1842# a_22564_1008# 0.05118f
C1238 a_18313_1842# a_18877_1842# 0.0114f
C1239 a_13019_5831# a_12849_5867# 0.12838f
C1240 a_9193_1842# a_9323_1842# 0.69911f
C1241 a_18313_1842# VDD 0.70905f
C1242 a_27991_1008# VDD 0.29221f
C1243 a_15403_1842# DELAY_VBIASN 0.06815f
C1244 a_15273_1842# DELAY_VBIASP 0.11018f
C1245 a_13123_1842# a_13231_1842# 0.01163f
C1246 a_26477_1842# a_26673_1842# 0.72407f
C1247 a_19203_1842# a_19311_2470# 0.01697f
C1248 a_4248_1044# a_4350_1044# 0.37183f
C1249 a_13306_5105# a_13880_5118# 0.31978f
C1250 a_14111_5227# a_15108_5325# 0.03012f
C1251 a_9444_4590# VDD 0.01023f
C1252 a_4248_1044# VDD 0.18405f
C1253 a_17357_1842# a_18117_1842# 0.02984f
C1254 a_25630_1044# a_27991_1008# 0.26208f
C1255 a_22351_2470# VDD 0.02372f
C1256 a_11277_1842# a_11271_1008# 0.02349f
C1257 a_26185_1044# a_26471_1008# 0.01885f
C1258 a_12037_1842# a_10430_1044# 0.05231f
C1259 a_10232_5871# REF_CLK 0.08086f
C1260 a_25528_1044# VDD 0.18232f
C1261 a_13753_1842# DELAY_VBIASN 0.09305f
C1262 a_13557_1842# DELAY_VBIASP 0.03915f
C1263 a_16597_1842# VDD 0.93778f
C1264 a_10649_5878# DLL_RESETN 0.05713f
C1265 a_13592_5423# a_14009_5084# 0.3749f
C1266 a_17683_1842# a_17791_2470# 0.01697f
C1267 a_25153_1842# a_25283_1842# 0.69911f
C1268 a_11603_1842# a_11711_1842# 0.01163f
C1269 a_13306_5105# a_14111_5227# 0.097f
C1270 a_18585_1044# VDD 0.29855f
C1271 a_12907_5420# VDD 0.08229f
C1272 a_25528_1044# a_25630_1044# 0.37183f
C1273 a_21157_1842# a_19550_1044# 0.05231f
C1274 a_16597_1842# a_16163_1842# 0.69698f
C1275 a_20397_1842# a_20391_1008# 0.02349f
C1276 a_11748_6109# a_12158_5867# 0.10373f
C1277 a_16271_2470# VDD 0.02372f
C1278 REF_CLK MUX_SEL4 0.06227f
C1279 a_13368_1044# a_13444_1008# 0.01176f
C1280 a_9757_1842# a_10404_1008# 0.02011f
C1281 a_7477_1842# a_7673_1842# 0.72565f
C1282 a_22590_1044# VDD 2.01498f
C1283 a_10843_1842# DELAY_VBIASP 0.06316f
C1284 a_12037_1842# DELAY_VBIASN 0.07362f
C1285 a_13883_1842# VDD 0.85908f
C1286 a_15688_5867# VDD 0.31235f
C1287 a_16108_289# a_23945_519# 0.2906f
C1288 a_10083_1842# a_10191_1842# 0.01163f
C1289 a_12907_5420# a_13132_5420# 0.02416f
C1290 a_4905_1044# a_5115_1044# 0.09424f
C1291 a_16163_1842# a_16271_2470# 0.01697f
C1292 a_1721_1395# MUX_SEL0 0.01315f
C1293 a_1544_1044# MUX_SEL1 0.1672f
C1294 a_10232_5871# a_10751_5878# 0.34102f
C1295 a_24008_1044# a_24084_1008# 0.01176f
C1296 a_6854_5986# a_13121_5831# 0.07016f
C1297 a_15273_1842# a_15837_1842# 0.0114f
C1298 a_18877_1842# a_19524_1008# 0.02011f
C1299 a_10649_5878# a_10520_6292# 0.01562f
C1300 a_27997_1842# DELAY_VBIASN 0.0389f
C1301 a_26803_1842# DELAY_VBIASP 0.06316f
C1302 a_10191_2470# VDD 0.02372f
C1303 DLL_RESETN DELAY_VBIASN 0.12904f
C1304 a_12233_1842# VDD 0.70905f
C1305 a_6153_1842# a_6283_1842# 0.69911f
C1306 a_8997_1842# a_8884_1008# 0.02055f
C1307 a_19524_1008# VDD 0.28964f
C1308 a_9193_1842# DELAY_VBIASP 0.11005f
C1309 a_9323_1842# DELAY_VBIASN 0.06808f
C1310 a_23437_1842# a_23633_1842# 0.72407f
C1311 a_14009_5878# VDD 0.25176f
C1312 a_8563_1842# a_8671_1842# 0.01163f
C1313 a_14643_1842# a_14751_2470# 0.01697f
C1314 a_13019_5831# a_15464_3684# 0.59356f
C1315 a_14317_1842# a_15077_1842# 0.02984f
C1316 a_18117_1842# a_18004_1008# 0.02055f
C1317 a_22590_1044# a_22564_1008# 0.277f
C1318 a_13470_1044# a_5731_289# 0.40967f
C1319 a_9946_6305# a_10206_5835# 0.75507f
C1320 a_15964_289# MUX_OUT 0.01307f
C1321 a_16108_289# MUX_SEL4 0.1283f
C1322 a_25283_1842# DELAY_VBIASN 0.0697f
C1323 a_4111_2470# VDD 0.02431f
C1324 a_25153_1842# DELAY_VBIASP 0.11005f
R0 DELAY_VBIASP.n0 DELAY_VBIASP.t34 34.3685
R1 DELAY_VBIASP.n0 DELAY_VBIASP.t33 33.0005
R2 DELAY_VBIASP.n1 DELAY_VBIASP.t32 33.0005
R3 DELAY_VBIASP.n2 DELAY_VBIASP.t31 33.0005
R4 DELAY_VBIASP.n3 DELAY_VBIASP.t30 33.0005
R5 DELAY_VBIASP.n4 DELAY_VBIASP.t29 33.0005
R6 DELAY_VBIASP.n5 DELAY_VBIASP.t28 33.0005
R7 DELAY_VBIASP.n6 DELAY_VBIASP.t27 33.0005
R8 DELAY_VBIASP.n7 DELAY_VBIASP.t26 33.0005
R9 DELAY_VBIASP.n8 DELAY_VBIASP.t25 33.0005
R10 DELAY_VBIASP.n9 DELAY_VBIASP.t24 33.0005
R11 DELAY_VBIASP.n10 DELAY_VBIASP.t23 33.0005
R12 DELAY_VBIASP.n11 DELAY_VBIASP.t22 33.0005
R13 DELAY_VBIASP.n12 DELAY_VBIASP.t21 33.0005
R14 DELAY_VBIASP.n13 DELAY_VBIASP.t20 33.0005
R15 DELAY_VBIASP.n14 DELAY_VBIASP.t19 33.0005
R16 DELAY_VBIASP.n15 DELAY_VBIASP.t18 33.0005
R17 DELAY_VBIASP.n16 DELAY_VBIASP.t17 33.0005
R18 DELAY_VBIASP.n17 DELAY_VBIASP.t16 33.0005
R19 DELAY_VBIASP.n18 DELAY_VBIASP.t15 33.0005
R20 DELAY_VBIASP.n19 DELAY_VBIASP.t14 33.0005
R21 DELAY_VBIASP.n20 DELAY_VBIASP.t2 31.7887
R22 DELAY_VBIASP.t1 DELAY_VBIASP.t0 5.66709
R23 DELAY_VBIASP.n20 DELAY_VBIASP.t3 10.3812
R24 DELAY_VBIASP DELAY_VBIASP.n20 4.16078
R25 DELAY_VBIASP.t3 DELAY_VBIASP.t4 1.36852
R26 DELAY_VBIASP.t4 DELAY_VBIASP.t5 1.36852
R27 DELAY_VBIASP.t5 DELAY_VBIASP.t6 1.36852
R28 DELAY_VBIASP.t6 DELAY_VBIASP.t7 1.36852
R29 DELAY_VBIASP.t7 DELAY_VBIASP.t8 1.36852
R30 DELAY_VBIASP.t8 DELAY_VBIASP.t9 1.36852
R31 DELAY_VBIASP.t9 DELAY_VBIASP.t10 1.36852
R32 DELAY_VBIASP.t10 DELAY_VBIASP.t11 1.36852
R33 DELAY_VBIASP.t11 DELAY_VBIASP.t12 1.36852
R34 DELAY_VBIASP.t12 DELAY_VBIASP.t13 1.36852
R35 DELAY_VBIASP.t13 DELAY_VBIASP.n19 1.36852
R36 DELAY_VBIASP.n19 DELAY_VBIASP.n18 1.36852
R37 DELAY_VBIASP.n18 DELAY_VBIASP.n17 1.36852
R38 DELAY_VBIASP.n17 DELAY_VBIASP.n16 1.36852
R39 DELAY_VBIASP.n16 DELAY_VBIASP.n15 1.36852
R40 DELAY_VBIASP.n15 DELAY_VBIASP.n14 1.36852
R41 DELAY_VBIASP.n14 DELAY_VBIASP.n13 1.36852
R42 DELAY_VBIASP.n13 DELAY_VBIASP.n12 1.36852
R43 DELAY_VBIASP.n12 DELAY_VBIASP.n11 1.36852
R44 DELAY_VBIASP.n11 DELAY_VBIASP.n10 1.36852
R45 DELAY_VBIASP.n10 DELAY_VBIASP.n9 1.36852
R46 DELAY_VBIASP.n9 DELAY_VBIASP.n8 1.36852
R47 DELAY_VBIASP.n8 DELAY_VBIASP.n7 1.36852
R48 DELAY_VBIASP.n7 DELAY_VBIASP.n6 1.36852
R49 DELAY_VBIASP.n6 DELAY_VBIASP.n5 1.36852
R50 DELAY_VBIASP.n5 DELAY_VBIASP.n4 1.36852
R51 DELAY_VBIASP.n4 DELAY_VBIASP.n3 1.36852
R52 DELAY_VBIASP.n3 DELAY_VBIASP.n2 1.36852
R53 DELAY_VBIASP.n2 DELAY_VBIASP.n1 1.36852
R54 DELAY_VBIASP.n1 DELAY_VBIASP.n0 1.36852
R55 DELAY_VBIASP.t2 DELAY_VBIASP.t0 3.94734
R56 VDD VDD.t79 17.3693
R57 VDD.n87 VDD.t241 17.3693
R58 VDD.n87 VDD.t239 17.3693
R59 VDD VDD.t134 17.3517
R60 VDD.n58 VDD.t9 17.3517
R61 VDD.n58 VDD.t360 17.3517
R62 VDD.n135 VDD.t84 17.2438
R63 VDD.n58 VDD.t140 17.2247
R64 VDD.t36 VDD.n58 1.4472
R65 VDD.n80 VDD.n79 0.322004
R66 VDD VDD.t77 17.0005
R67 VDD.n58 VDD.t167 17.0005
R68 VDD.n58 VDD.t212 17.0005
R69 VDD.n122 VDD.n12 0.351784
R70 VDD.t55 VDD.n9 0.709211
R71 VDD.t0 VDD.n86 0.17505
R72 VDD.n85 VDD 0.311063
R73 VDD.n1 VDD.n245 0.50193
R74 VDD.n321 VDD.t4 2.75676
R75 VDD.t4 VDD.n131 0.490826
R76 VDD.n180 VDD.n131 0.669282
R77 VDD.n316 VDD.t4 2.01015
R78 VDD.n135 VDD.n11 0.366389
R79 VDD.n265 VDD.n10 0.463326
R80 VDD.n99 VDD.t4 0.201247
R81 VDD.n164 VDD.n120 0.235427
R82 VDD.t10 VDD.n97 1.34626
R83 VDD.n90 VDD.n53 0.305555
R84 VDD.n105 VDD.n50 0.744354
R85 VDD.t10 VDD.n105 0.714174
R86 VDD.n106 VDD.n47 0.744354
R87 VDD.t10 VDD.n106 0.714174
R88 VDD.n107 VDD.n46 0.744354
R89 VDD.t10 VDD.n107 0.714174
R90 VDD.n108 VDD.n44 0.744354
R91 VDD.t10 VDD.n108 0.714174
R92 VDD.n109 VDD.n42 0.744354
R93 VDD.t10 VDD.n109 0.714174
R94 VDD.n110 VDD.n39 0.744354
R95 VDD.t10 VDD.n110 0.714174
R96 VDD.n111 VDD.n36 0.744354
R97 VDD.t10 VDD.n111 0.714174
R98 VDD.n112 VDD.n33 0.744354
R99 VDD.t10 VDD.n112 0.714174
R100 VDD.n113 VDD.n30 0.744354
R101 VDD.t10 VDD.n113 0.714174
R102 VDD.n114 VDD.n27 0.744354
R103 VDD.t10 VDD.n114 0.714174
R104 VDD.n115 VDD.n24 0.744354
R105 VDD.t10 VDD.n115 0.714174
R106 VDD.n116 VDD.n21 0.744354
R107 VDD.t10 VDD.n116 0.714174
R108 VDD.n0 VDD.n18 0.987221
R109 VDD.t10 VDD.n0 0.313079
R110 VDD.n53 VDD.t71 15.1333
R111 VDD.n7 VDD.t54 15.0005
R112 VDD.n8 VDD.t60 15.0005
R113 VDD.n12 VDD.t63 15.0005
R114 VDD.n53 VDD.t74 15.0005
R115 VDD.n344 VDD.t366 17.9449
R116 VDD.n531 VDD.n100 12.3334
R117 VDD.n1251 VDD.n507 10.0583
R118 VDD.n1256 VDD.n1255 9.69236
R119 VDD.n592 VDD.n341 9.23034
R120 VDD.n1285 VDD.n1284 9.11631
R121 VDD.n475 VDD 9.07383
R122 VDD.n84 VDD.t39 9.02285
R123 VDD VDD.n476 9.0005
R124 VDD.n411 VDD 9.0005
R125 VDD.n363 VDD 4.46488
R126 VDD.n471 VDD.n363 0.073243
R127 VDD.n470 VDD 9.0005
R128 VDD.n143 VDD 4.46488
R129 VDD.n466 VDD.n143 0.073243
R130 VDD VDD.n134 4.46488
R131 VDD.n465 VDD.n134 0.073243
R132 VDD.n365 VDD.n382 0.073243
R133 VDD.n365 VDD 4.46488
R134 VDD VDD.n152 4.46488
R135 VDD.n460 VDD.n152 0.073243
R136 VDD.n151 VDD.n154 0.073243
R137 VDD.n151 VDD 4.46488
R138 VDD.n123 VDD.n150 4.46488
R139 VDD.n455 VDD.n150 0.073243
R140 VDD.n149 VDD.n156 0.073243
R141 VDD.n149 VDD.n123 4.46488
R142 VDD.n123 VDD.n148 4.46488
R143 VDD.n450 VDD.n148 0.073243
R144 VDD.n147 VDD.n158 0.073243
R145 VDD.n147 VDD.n123 4.46488
R146 VDD.n58 VDD.n166 9.0005
R147 VDD.n445 VDD.n384 0.073243
R148 VDD.n384 VDD.n58 4.46488
R149 VDD.n362 VDD.n58 4.46488
R150 VDD.n440 VDD.n362 0.073243
R151 VDD.n439 VDD.n58 9.0005
R152 VDD.n421 VDD.n145 0.073243
R153 VDD.n145 VDD.n58 4.46488
R154 VDD.n146 VDD.n159 0.073243
R155 VDD.n146 VDD.n58 4.46488
R156 VDD.n430 VDD.n58 9.0005
R157 VDD.n429 VDD.n364 0.073243
R158 VDD.n364 VDD.n58 4.46488
R159 VDD.n139 VDD.n141 0.134609
R160 VDD.n141 VDD.n79 1.38505
R161 VDD.n79 VDD.n138 9.0005
R162 VDD.n58 VDD.n104 9.0005
R163 VDD.n474 VDD.n411 9.0005
R164 VDD.n473 VDD.n472 9.0005
R165 VDD.n471 VDD.n412 9.0005
R166 VDD.n470 VDD.n469 9.0005
R167 VDD.n468 VDD.n413 9.0005
R168 VDD.n467 VDD.n466 9.0005
R169 VDD.n144 VDD.n414 9.0005
R170 VDD.n465 VDD.n464 9.0005
R171 VDD.n463 VDD.n382 9.0005
R172 VDD.n462 VDD.n461 9.0005
R173 VDD.n153 VDD.n415 9.0005
R174 VDD.n460 VDD.n459 9.0005
R175 VDD.n458 VDD.n154 9.0005
R176 VDD.n457 VDD.n456 9.0005
R177 VDD.n155 VDD.n416 9.0005
R178 VDD.n455 VDD.n454 9.0005
R179 VDD.n453 VDD.n156 9.0005
R180 VDD.n452 VDD.n451 9.0005
R181 VDD.n157 VDD.n417 9.0005
R182 VDD.n450 VDD.n449 9.0005
R183 VDD.n448 VDD.n158 9.0005
R184 VDD.n447 VDD.n446 9.0005
R185 VDD.n166 VDD.n418 9.0005
R186 VDD.n445 VDD.n444 9.0005
R187 VDD.n443 VDD.n419 9.0005
R188 VDD.n442 VDD.n441 9.0005
R189 VDD.n440 VDD.n420 9.0005
R190 VDD.n439 VDD.n438 9.0005
R191 VDD.n437 VDD.n421 9.0005
R192 VDD.n436 VDD.n435 9.0005
R193 VDD.n159 VDD.n422 9.0005
R194 VDD.n434 VDD.n433 9.0005
R195 VDD.n432 VDD.n104 9.0005
R196 VDD.n431 VDD.n430 9.0005
R197 VDD.n429 VDD.n423 9.0005
R198 VDD.n426 VDD.n425 9.0005
R199 VDD.n138 VDD.n424 9.0005
R200 VDD.n388 VDD.n409 0.285069
R201 VDD.n8 VDD.n9 0.054854
R202 VDD.n528 VDD.n100 9.0005
R203 VDD.n252 VDD.n84 4.44407
R204 VDD.n522 VDD.n219 0.114852
R205 VDD.n121 VDD.n84 4.44407
R206 VDD.n124 VDD.n94 4.44407
R207 VDD.n1272 VDD.n124 0.114852
R208 VDD.n94 VDD.n385 9.0005
R209 VDD.n317 VDD.n94 4.44407
R210 VDD.n317 VDD.n1274 0.114852
R211 VDD.n118 VDD.n94 4.44407
R212 VDD.n478 VDD.n118 0.114852
R213 VDD.n345 VDD.n94 4.44407
R214 VDD.n1282 VDD.n345 0.114852
R215 VDD.n495 VDD.n121 0.114852
R216 VDD.n1264 VDD.n168 0.114852
R217 VDD.n168 VDD.n84 4.44407
R218 VDD.n1266 VDD.n273 0.114852
R219 VDD.n273 VDD.n84 4.44407
R220 VDD.n1270 VDD.n84 9.0005
R221 VDD.n219 VDD.n84 4.44407
R222 VDD.n84 VDD.n390 9.0005
R223 VDD.n527 VDD.n252 0.114852
R224 VDD.n1261 VDD.n51 9.0005
R225 VDD.n318 VDD.n1262 0.114852
R226 VDD.n318 VDD.n51 4.44407
R227 VDD.n502 VDD.n271 0.114852
R228 VDD.n271 VDD.n51 4.44407
R229 VDD.n483 VDD.n343 0.114852
R230 VDD.n343 VDD.n51 4.44407
R231 VDD.n1277 VDD.n2 9.0005
R232 VDD.n1278 VDD 9.0005
R233 VDD.n1279 VDD.n280 0.114852
R234 VDD.n280 VDD 4.44407
R235 VDD.n1253 VDD.n1252 9.0005
R236 VDD.n1254 VDD.n509 9.0005
R237 VDD.n1256 VDD.n324 9.0005
R238 VDD.n1257 VDD.n92 9.0005
R239 VDD.n92 VDD.n270 4.44407
R240 VDD.n1260 VDD.n270 0.114852
R241 VDD.n272 VDD.n51 4.44407
R242 VDD.n499 VDD.n272 0.114852
R243 VDD.n497 VDD.n483 9.0005
R244 VDD.n1276 VDD.n482 9.0005
R245 VDD.n1277 VDD.n481 9.0005
R246 VDD.n1278 VDD.n480 9.0005
R247 VDD.n1279 VDD.n479 9.0005
R248 VDD.n499 VDD.n498 9.0005
R249 VDD.n1261 VDD.n506 9.0005
R250 VDD.n1262 VDD.n505 9.0005
R251 VDD.n504 VDD.n496 9.0005
R252 VDD.n503 VDD.n502 9.0005
R253 VDD.n271 VDD.n501 9.11485
R254 VDD.n1260 VDD.n1259 9.0005
R255 VDD.n1253 VDD.n507 9.0005
R256 VDD.n1255 VDD.n1254 9.0005
R257 VDD.n246 VDD.n245 4.44407
R258 VDD.n832 VDD.n246 0.114852
R259 VDD.n313 VDD.n367 0.114852
R260 VDD.n313 VDD.n312 4.44407
R261 VDD.n790 VDD.n129 0.114852
R262 VDD.n129 VDD.t4 4.44407
R263 VDD.n792 VDD.n185 0.114852
R264 VDD.n185 VDD.t4 4.44407
R265 VDD.n794 VDD.n75 9.0005
R266 VDD.n281 VDD.n75 4.44407
R267 VDD.n796 VDD.n281 0.114852
R268 VDD.n117 VDD.n75 4.44407
R269 VDD.n798 VDD.n117 0.114852
R270 VDD.n322 VDD.n75 4.44407
R271 VDD.n800 VDD.n322 0.114852
R272 VDD.n801 VDD.n342 0.114852
R273 VDD.n342 VDD.n75 4.44407
R274 VDD.n165 VDD.n75 4.44407
R275 VDD.n804 VDD.n165 9.11485
R276 VDD.n276 VDD.n187 4.44407
R277 VDD.n267 VDD.n187 4.44407
R278 VDD.n808 VDD.n267 0.114852
R279 VDD.n809 VDD.n60 9.0005
R280 VDD.n268 VDD.n60 4.44407
R281 VDD.n811 VDD.n268 0.114852
R282 VDD.n812 VDD.n269 0.114852
R283 VDD.n269 VDD.n60 4.44407
R284 VDD.n815 VDD.n60 9.0005
R285 VDD.n816 VDD.n184 0.114852
R286 VDD.n184 VDD.n60 4.44407
R287 VDD.n818 VDD.n325 0.114852
R288 VDD.n325 VDD.n60 4.44407
R289 VDD.n376 VDD.n60 4.44407
R290 VDD.n821 VDD.n376 0.114852
R291 VDD.n822 VDD.n167 0.114852
R292 VDD.n167 VDD.n60 4.44407
R293 VDD.n824 VDD.n60 9.0005
R294 VDD.n825 VDD.n408 0.114852
R295 VDD.n815 VDD.n814 9.0005
R296 VDD.n816 VDD.n765 9.0005
R297 VDD.n817 VDD.n764 9.0005
R298 VDD.n818 VDD.n763 9.0005
R299 VDD.n819 VDD.n762 9.0005
R300 VDD.n820 VDD.n761 9.0005
R301 VDD.n821 VDD.n760 9.0005
R302 VDD.n822 VDD.n759 9.0005
R303 VDD.n823 VDD.n758 9.0005
R304 VDD.n824 VDD.n757 9.0005
R305 VDD.n825 VDD.n756 9.0005
R306 VDD.n826 VDD.n755 9.0005
R307 VDD.n828 VDD.n827 9.0005
R308 VDD.n829 VDD.n534 9.0005
R309 VDD.n831 VDD.n830 9.0005
R310 VDD.n754 VDD.n533 9.0005
R311 VDD.n753 VDD.n752 9.0005
R312 VDD.n368 VDD.n535 9.0005
R313 VDD.n751 VDD.n750 9.0005
R314 VDD.n408 VDD.n60 4.44407
R315 VDD.n241 VDD.n73 4.44407
R316 VDD.n534 VDD.n241 0.114852
R317 VDD.n73 VDD.n326 4.44407
R318 VDD.n533 VDD.n326 0.114852
R319 VDD.n225 VDD.n73 4.44407
R320 VDD.n225 VDD.n368 0.114852
R321 VDD.n73 VDD.n751 9.0005
R322 VDD.n748 VDD.n74 9.0005
R323 VDD.n74 VDD.n174 4.44407
R324 VDD.n174 VDD.n537 0.114852
R325 VDD.n173 VDD.n747 0.114852
R326 VDD.n62 VDD.n173 4.44407
R327 VDD.n377 VDD.n62 4.44407
R328 VDD.n377 VDD.n539 0.114852
R329 VDD.n749 VDD.n748 9.0005
R330 VDD.n391 VDD.n536 9.0005
R331 VDD.n745 VDD.n537 9.0005
R332 VDD.n747 VDD.n746 9.0005
R333 VDD.n744 VDD.n392 9.0005
R334 VDD.n743 VDD.n742 9.0005
R335 VDD.n539 VDD.n538 9.0005
R336 VDD.n734 VDD.n733 9.0005
R337 VDD.n735 VDD.n732 9.0005
R338 VDD.n737 VDD.n736 9.0005
R339 VDD.n738 VDD.n540 9.0005
R340 VDD.n739 VDD.n541 9.0005
R341 VDD.n741 VDD.n740 9.0005
R342 VDD.n731 VDD.n375 9.0005
R343 VDD.n730 VDD.n729 9.0005
R344 VDD.n336 VDD.n542 9.0005
R345 VDD.n725 VDD.n543 9.0005
R346 VDD.n726 VDD.n544 9.0005
R347 VDD.n728 VDD.n727 9.0005
R348 VDD.n130 VDD.n62 4.44407
R349 VDD.n735 VDD.n130 0.114852
R350 VDD.n736 VDD.n62 9.0005
R351 VDD.n407 VDD.n540 0.114852
R352 VDD.n62 VDD.n407 4.44407
R353 VDD.n242 VDD.n741 0.114852
R354 VDD.n62 VDD.n242 4.44407
R355 VDD.n327 VDD.n62 4.44407
R356 VDD.n327 VDD.n336 0.114852
R357 VDD.n62 VDD.n224 4.44407
R358 VDD.n224 VDD.n544 0.114852
R359 VDD.n62 VDD.n728 9.0005
R360 VDD.n723 VDD.n339 9.0005
R361 VDD.n175 VDD.n176 4.44309
R362 VDD.n176 VDD.n546 0.116823
R363 VDD.n172 VDD.n722 0.116823
R364 VDD.n66 VDD.n172 4.44309
R365 VDD.n378 VDD.n66 4.44309
R366 VDD.n378 VDD.n548 0.116823
R367 VDD.n724 VDD.n723 9.0005
R368 VDD.n393 VDD.n545 9.0005
R369 VDD.n720 VDD.n546 9.0005
R370 VDD.n722 VDD.n721 9.0005
R371 VDD.n719 VDD.n394 9.0005
R372 VDD.n718 VDD.n717 9.0005
R373 VDD.n548 VDD.n547 9.0005
R374 VDD.n709 VDD.n708 9.0005
R375 VDD.n710 VDD.n707 9.0005
R376 VDD.n712 VDD.n711 9.0005
R377 VDD.n713 VDD.n549 9.0005
R378 VDD.n714 VDD.n550 9.0005
R379 VDD.n716 VDD.n715 9.0005
R380 VDD.n706 VDD.n374 9.0005
R381 VDD.n705 VDD.n704 9.0005
R382 VDD.n335 VDD.n551 9.0005
R383 VDD.n700 VDD.n552 9.0005
R384 VDD.n701 VDD.n553 9.0005
R385 VDD.n703 VDD.n702 9.0005
R386 VDD.n709 VDD.n66 9.0005
R387 VDD.n710 VDD.n162 0.116823
R388 VDD.n162 VDD.n66 4.44309
R389 VDD.n406 VDD.n549 0.116823
R390 VDD.n66 VDD.n406 4.44309
R391 VDD.n66 VDD.n127 4.44309
R392 VDD.n127 VDD.n374 0.116823
R393 VDD.n328 VDD.n66 4.44309
R394 VDD.n328 VDD.n335 0.116823
R395 VDD.n66 VDD.n223 4.44309
R396 VDD.n223 VDD.n553 0.116823
R397 VDD.n66 VDD.n703 9.0005
R398 VDD.n698 VDD.n136 9.0005
R399 VDD.n136 VDD.n177 4.44407
R400 VDD.n177 VDD.n555 0.114852
R401 VDD.n265 VDD.n697 9.0005
R402 VDD.n265 VDD.n319 4.44407
R403 VDD.n692 VDD.n319 0.114852
R404 VDD.n11 VDD.n264 9.0005
R405 VDD.n11 VDD.n314 4.44407
R406 VDD.n314 VDD.n689 9.11485
R407 VDD.n687 VDD.n11 9.0005
R408 VDD.n386 VDD.n558 0.114852
R409 VDD.n11 VDD.n386 4.44407
R410 VDD.n135 VDD.n266 4.44407
R411 VDD.n266 VDD.n347 0.114852
R412 VDD.n681 VDD.n135 9.0005
R413 VDD.n263 VDD.n262 9.0005
R414 VDD.n263 VDD.n315 4.44407
R415 VDD.n315 VDD.n678 9.11485
R416 VDD.n676 VDD.n338 9.0005
R417 VDD.n178 VDD.n179 4.44407
R418 VDD.n179 VDD.n562 0.114852
R419 VDD.n171 VDD.n675 0.114852
R420 VDD.n67 VDD.n171 4.44407
R421 VDD.n379 VDD.n67 4.44407
R422 VDD.n379 VDD.n564 0.114852
R423 VDD.n677 VDD.n676 9.0005
R424 VDD.n396 VDD.n561 9.0005
R425 VDD.n673 VDD.n562 9.0005
R426 VDD.n675 VDD.n674 9.0005
R427 VDD.n672 VDD.n397 9.0005
R428 VDD.n671 VDD.n670 9.0005
R429 VDD.n564 VDD.n563 9.0005
R430 VDD.n662 VDD.n661 9.0005
R431 VDD.n663 VDD.n660 9.0005
R432 VDD.n665 VDD.n664 9.0005
R433 VDD.n666 VDD.n565 9.0005
R434 VDD.n667 VDD.n566 9.0005
R435 VDD.n669 VDD.n668 9.0005
R436 VDD.n659 VDD.n373 9.0005
R437 VDD.n658 VDD.n657 9.0005
R438 VDD.n334 VDD.n567 9.0005
R439 VDD.n653 VDD.n568 9.0005
R440 VDD.n654 VDD.n569 9.0005
R441 VDD.n656 VDD.n655 9.0005
R442 VDD.n662 VDD.n67 9.0005
R443 VDD.n663 VDD.n161 0.114852
R444 VDD.n161 VDD.n67 4.44407
R445 VDD.n405 VDD.n565 0.114852
R446 VDD.n67 VDD.n405 4.44407
R447 VDD.n126 VDD.n669 0.114852
R448 VDD.n67 VDD.n126 4.44407
R449 VDD.n329 VDD.n67 4.44407
R450 VDD.n329 VDD.n334 0.114852
R451 VDD.n67 VDD.n222 4.44407
R452 VDD.n222 VDD.n569 0.114852
R453 VDD.n67 VDD.n656 9.0005
R454 VDD.n651 VDD.n337 9.0005
R455 VDD.n180 VDD.n181 4.44407
R456 VDD.n181 VDD.n571 0.114852
R457 VDD.n170 VDD.n650 0.114852
R458 VDD.n64 VDD.n170 4.44407
R459 VDD.n380 VDD.n64 4.44407
R460 VDD.n380 VDD.n573 0.114852
R461 VDD.n652 VDD.n651 9.0005
R462 VDD.n398 VDD.n570 9.0005
R463 VDD.n648 VDD.n571 9.0005
R464 VDD.n650 VDD.n649 9.0005
R465 VDD.n647 VDD.n399 9.0005
R466 VDD.n646 VDD.n645 9.0005
R467 VDD.n573 VDD.n572 9.0005
R468 VDD.n637 VDD.n636 9.0005
R469 VDD.n638 VDD.n635 9.0005
R470 VDD.n640 VDD.n639 9.0005
R471 VDD.n641 VDD.n574 9.0005
R472 VDD.n642 VDD.n575 9.0005
R473 VDD.n644 VDD.n643 9.0005
R474 VDD.n634 VDD.n372 9.0005
R475 VDD.n633 VDD.n632 9.0005
R476 VDD.n333 VDD.n576 9.0005
R477 VDD.n628 VDD.n577 9.0005
R478 VDD.n629 VDD.n578 9.0005
R479 VDD.n631 VDD.n630 9.0005
R480 VDD.n132 VDD.n64 4.44407
R481 VDD.n638 VDD.n132 0.114852
R482 VDD.n639 VDD.n64 9.0005
R483 VDD.n404 VDD.n574 0.114852
R484 VDD.n64 VDD.n404 4.44407
R485 VDD.n64 VDD.n243 4.44407
R486 VDD.n243 VDD.n372 0.114852
R487 VDD.n330 VDD.n64 4.44407
R488 VDD.n330 VDD.n333 0.114852
R489 VDD.n64 VDD.n221 4.44407
R490 VDD.n221 VDD.n578 0.114852
R491 VDD.n64 VDD.n631 9.0005
R492 VDD.n626 VDD.n68 9.0005
R493 VDD.n68 VDD.n182 4.44309
R494 VDD.n182 VDD.n580 0.116823
R495 VDD.n169 VDD.n625 0.116823
R496 VDD.n68 VDD.n169 4.44309
R497 VDD.n381 VDD.n68 4.44309
R498 VDD.n381 VDD.n582 0.116823
R499 VDD.n627 VDD.n626 9.0005
R500 VDD.n400 VDD.n579 9.0005
R501 VDD.n623 VDD.n580 9.0005
R502 VDD.n625 VDD.n624 9.0005
R503 VDD.n622 VDD.n401 9.0005
R504 VDD.n621 VDD.n620 9.0005
R505 VDD.n582 VDD.n581 9.0005
R506 VDD.n612 VDD.n611 9.0005
R507 VDD.n613 VDD.n610 9.0005
R508 VDD.n615 VDD.n614 9.0005
R509 VDD.n616 VDD.n583 9.0005
R510 VDD.n617 VDD.n584 9.0005
R511 VDD.n619 VDD.n618 9.0005
R512 VDD.n609 VDD.n371 9.0005
R513 VDD.n608 VDD.n607 9.0005
R514 VDD.n332 VDD.n585 9.0005
R515 VDD.n603 VDD.n586 9.0005
R516 VDD.n604 VDD.n587 9.0005
R517 VDD.n606 VDD.n605 9.0005
R518 VDD.n612 VDD.n68 9.0005
R519 VDD.n613 VDD.n160 0.116823
R520 VDD.n160 VDD.n68 4.44309
R521 VDD.n403 VDD.n583 0.116823
R522 VDD.n68 VDD.n403 4.44309
R523 VDD.n125 VDD.n619 0.116823
R524 VDD.n68 VDD.n125 4.44309
R525 VDD.n331 VDD.n68 4.44309
R526 VDD.n331 VDD.n332 0.116823
R527 VDD.n68 VDD.n220 4.44309
R528 VDD.n220 VDD.n587 0.116823
R529 VDD.n68 VDD.n606 9.0005
R530 VDD.n601 VDD.n137 9.0005
R531 VDD.n137 VDD.n183 4.44407
R532 VDD.n183 VDD.n589 0.114852
R533 VDD.n261 VDD.n600 9.0005
R534 VDD.n261 VDD.n320 4.44407
R535 VDD.n595 VDD.n320 0.114852
R536 VDD.n594 VDD.n591 9.0005
R537 VDD.n340 VDD.n593 9.0005
R538 VDD.n602 VDD.n601 9.0005
R539 VDD.n402 VDD.n588 9.0005
R540 VDD.n598 VDD.n589 9.0005
R541 VDD.n600 VDD.n599 9.0005
R542 VDD.n597 VDD.n348 9.0005
R543 VDD.n596 VDD.n595 9.0005
R544 VDD.n591 VDD.n590 9.0005
R545 VDD.n832 VDD.n532 9.0005
R546 VDD.n787 VDD.n367 9.0005
R547 VDD.n789 VDD.n788 9.0005
R548 VDD.n790 VDD.n786 9.0005
R549 VDD.n791 VDD.n785 9.0005
R550 VDD.n792 VDD.n784 9.0005
R551 VDD.n793 VDD.n783 9.0005
R552 VDD.n794 VDD.n782 9.0005
R553 VDD.n795 VDD.n781 9.0005
R554 VDD.n796 VDD.n780 9.0005
R555 VDD.n797 VDD.n779 9.0005
R556 VDD.n798 VDD.n778 9.0005
R557 VDD.n799 VDD.n777 9.0005
R558 VDD.n800 VDD.n776 9.0005
R559 VDD.n801 VDD.n775 9.0005
R560 VDD.n802 VDD.n774 9.0005
R561 VDD.n803 VDD.n773 9.0005
R562 VDD.n276 VDD.n805 9.11485
R563 VDD.n806 VDD.n772 9.0005
R564 VDD.n807 VDD.n771 9.0005
R565 VDD.n808 VDD.n770 9.0005
R566 VDD.n809 VDD.n769 9.0005
R567 VDD.n810 VDD.n768 9.0005
R568 VDD.n811 VDD.n767 9.0005
R569 VDD.n812 VDD.n766 9.0005
R570 VDD.n699 VDD.n698 9.0005
R571 VDD.n395 VDD.n554 9.0005
R572 VDD.n695 VDD.n555 9.0005
R573 VDD.n697 VDD.n696 9.0005
R574 VDD.n694 VDD.n346 9.0005
R575 VDD.n693 VDD.n692 9.0005
R576 VDD.n264 VDD.n556 9.0005
R577 VDD.n691 VDD.n690 9.0005
R578 VDD.n688 VDD.n687 9.0005
R579 VDD.n558 VDD.n557 9.0005
R580 VDD.n684 VDD.n559 9.0005
R581 VDD.n686 VDD.n685 9.0005
R582 VDD.n683 VDD.n347 9.0005
R583 VDD.n682 VDD.n681 9.0005
R584 VDD.n262 VDD.n560 9.0005
R585 VDD.n680 VDD.n679 9.0005
R586 VDD.n260 VDD.t10 4.44407
R587 VDD.n260 VDD.n349 0.114852
R588 VDD.t10 VDD.n1248 9.0005
R589 VDD.n259 VDD.t10 4.44407
R590 VDD.n259 VDD.n350 0.114852
R591 VDD.t10 VDD.n1245 9.0005
R592 VDD.n1242 VDD.t10 9.0005
R593 VDD.t10 VDD.n234 4.44407
R594 VDD.n234 VDD.n1241 9.11485
R595 VDD.t10 VDD.n258 4.44407
R596 VDD.t10 VDD.n1239 9.0005
R597 VDD.n1236 VDD.t10 9.0005
R598 VDD.n236 VDD.n839 0.114852
R599 VDD.t10 VDD.n236 4.44407
R600 VDD.n279 VDD.t10 4.44407
R601 VDD.n279 VDD.n352 0.114852
R602 VDD.t10 VDD.n1233 9.0005
R603 VDD.n1230 VDD.t10 9.0005
R604 VDD.t10 VDD.n227 4.44407
R605 VDD.n227 VDD.n1229 9.11485
R606 VDD.n78 VDD.n257 4.44407
R607 VDD.n78 VDD.n1227 9.0005
R608 VDD.n278 VDD.n78 4.44407
R609 VDD.n278 VDD.n353 0.114852
R610 VDD.n78 VDD.n1224 9.0005
R611 VDD.n1221 VDD.n69 9.0005
R612 VDD.n237 VDD.n845 0.114852
R613 VDD.n69 VDD.n237 4.44407
R614 VDD.n1218 VDD.n69 9.0005
R615 VDD.n238 VDD.n847 0.114852
R616 VDD.n69 VDD.n238 4.44407
R617 VDD.n1215 VDD.n69 9.0005
R618 VDD.n69 VDD.n229 4.44407
R619 VDD.n229 VDD.n1214 9.11485
R620 VDD.n255 VDD.n69 4.44407
R621 VDD.n255 VDD.n354 0.114852
R622 VDD.n72 VDD.n1212 9.0005
R623 VDD.n254 VDD.n72 4.44407
R624 VDD.n254 VDD.n355 0.114852
R625 VDD.n72 VDD.n1209 9.0005
R626 VDD.n1206 VDD.n77 9.0005
R627 VDD.n239 VDD.n852 0.114852
R628 VDD.n77 VDD.n239 4.44407
R629 VDD.n32 VDD.n253 4.44407
R630 VDD.n32 VDD.n1203 9.0005
R631 VDD.n1200 VDD.n32 9.0005
R632 VDD.n120 VDD.n231 4.44407
R633 VDD.n231 VDD.n1199 9.11485
R634 VDD.n275 VDD.n164 4.44407
R635 VDD.n275 VDD.n357 0.114852
R636 VDD.n163 VDD.n1197 9.0005
R637 VDD.n1194 VDD.n76 9.0005
R638 VDD.n232 VDD.n857 0.114852
R639 VDD.n76 VDD.n232 4.44407
R640 VDD.n1191 VDD.n76 9.0005
R641 VDD.n235 VDD.n859 0.114852
R642 VDD.n76 VDD.n235 4.44407
R643 VDD.n251 VDD.n76 4.44407
R644 VDD.n251 VDD.n358 0.114852
R645 VDD.n76 VDD.n1188 9.0005
R646 VDD.t10 VDD.n250 4.44407
R647 VDD.t10 VDD.n1185 9.0005
R648 VDD.n248 VDD.t10 4.44407
R649 VDD.n248 VDD.n359 0.114852
R650 VDD.t10 VDD.n1182 9.0005
R651 VDD.n277 VDD.t10 4.44407
R652 VDD.n277 VDD.n360 0.114852
R653 VDD.n921 VDD.n97 9.0005
R654 VDD.n247 VDD.n97 4.44407
R655 VDD.n97 VDD.n925 9.0005
R656 VDD.n274 VDD.n97 4.44407
R657 VDD.n274 VDD.n361 0.114852
R658 VDD.n142 VDD.n929 9.0005
R659 VDD.n917 VDD.n103 9.0005
R660 VDD.n240 VDD.n871 0.114852
R661 VDD.n240 VDD.n103 4.44407
R662 VDD.n133 VDD.t10 4.44407
R663 VDD.n1064 VDD.n282 0.114852
R664 VDD.n282 VDD.t10 4.44407
R665 VDD.n218 VDD.t10 4.44407
R666 VDD.n1067 VDD.n218 0.114852
R667 VDD.n1068 VDD.t10 9.0005
R668 VDD.n1069 VDD.n283 0.114852
R669 VDD.n283 VDD.t10 4.44407
R670 VDD.n217 VDD.t10 4.44407
R671 VDD.n1072 VDD.n217 0.114852
R672 VDD.n1073 VDD.t10 9.0005
R673 VDD.n1074 VDD.n284 0.114852
R674 VDD.n284 VDD.n15 4.44407
R675 VDD.n216 VDD.n15 4.44407
R676 VDD.n1077 VDD.n216 0.114852
R677 VDD.n1078 VDD.n15 9.0005
R678 VDD.n1079 VDD.n285 0.114852
R679 VDD.n285 VDD.n15 4.44407
R680 VDD.n215 VDD.n15 4.44407
R681 VDD.n1082 VDD.n215 0.114852
R682 VDD.n1083 VDD.n15 9.0005
R683 VDD.n1084 VDD.n286 0.114852
R684 VDD.n286 VDD.n18 4.44407
R685 VDD.n214 VDD.n18 4.44407
R686 VDD.n1087 VDD.n214 0.114852
R687 VDD.n1088 VDD.n18 9.0005
R688 VDD.n1089 VDD.n287 0.114852
R689 VDD.n287 VDD.n18 4.44407
R690 VDD.n213 VDD.n18 4.44407
R691 VDD.n1092 VDD.n213 0.114852
R692 VDD.n1093 VDD.n18 9.0005
R693 VDD.n1094 VDD.n288 0.114852
R694 VDD.n288 VDD.n21 4.44407
R695 VDD.n212 VDD.n21 4.44407
R696 VDD.n1097 VDD.n212 0.114852
R697 VDD.n1098 VDD.n21 9.0005
R698 VDD.n1099 VDD.n289 0.114852
R699 VDD.n289 VDD.n21 4.44407
R700 VDD.n211 VDD.n21 4.44407
R701 VDD.n1102 VDD.n211 0.114852
R702 VDD.n1103 VDD.n21 9.0005
R703 VDD.n1104 VDD.n290 0.114852
R704 VDD.n290 VDD.n24 4.44407
R705 VDD.n210 VDD.n24 4.44407
R706 VDD.n1107 VDD.n210 0.114852
R707 VDD.n1108 VDD.n24 9.0005
R708 VDD.n1109 VDD.n291 0.114852
R709 VDD.n291 VDD.n24 4.44407
R710 VDD.n209 VDD.n24 4.44407
R711 VDD.n1112 VDD.n209 0.114852
R712 VDD.n1113 VDD.n24 9.0005
R713 VDD.n1114 VDD.n292 0.114852
R714 VDD.n292 VDD.n27 4.44407
R715 VDD.n208 VDD.n27 4.44407
R716 VDD.n1117 VDD.n208 0.114852
R717 VDD.n1118 VDD.n27 9.0005
R718 VDD.n1119 VDD.n293 0.114852
R719 VDD.n293 VDD.n27 4.44407
R720 VDD.n207 VDD.n27 4.44407
R721 VDD.n1122 VDD.n207 0.114852
R722 VDD.n1123 VDD.n27 9.0005
R723 VDD.n1124 VDD.n294 0.114852
R724 VDD.n294 VDD.n30 4.44407
R725 VDD.n206 VDD.n30 4.44407
R726 VDD.n1127 VDD.n206 0.114852
R727 VDD.n1128 VDD.n30 9.0005
R728 VDD.n1129 VDD.n295 0.114852
R729 VDD.n295 VDD.n30 4.44407
R730 VDD.n205 VDD.n30 4.44407
R731 VDD.n1132 VDD.n205 0.114852
R732 VDD.n1133 VDD.n30 9.0005
R733 VDD.n1134 VDD.n296 0.114852
R734 VDD.n296 VDD.n33 4.44407
R735 VDD.n204 VDD.n33 4.44407
R736 VDD.n1137 VDD.n204 0.114852
R737 VDD.n1138 VDD.n33 9.0005
R738 VDD.n1139 VDD.n297 0.114852
R739 VDD.n297 VDD.n33 4.44407
R740 VDD.n203 VDD.n33 4.44407
R741 VDD.n1142 VDD.n203 0.114852
R742 VDD.n1143 VDD.n33 9.0005
R743 VDD.n1144 VDD.n298 0.114852
R744 VDD.n298 VDD.n36 4.44407
R745 VDD.n202 VDD.n36 4.44407
R746 VDD.n1147 VDD.n202 0.114852
R747 VDD.n1148 VDD.n36 9.0005
R748 VDD.n1149 VDD.n299 0.114852
R749 VDD.n299 VDD.n36 4.44407
R750 VDD.n201 VDD.n36 4.44407
R751 VDD.n1152 VDD.n201 0.114852
R752 VDD.n1153 VDD.n36 9.0005
R753 VDD.n1154 VDD.n300 0.114852
R754 VDD.n300 VDD.n39 4.44407
R755 VDD.n200 VDD.n39 4.44407
R756 VDD.n1157 VDD.n200 0.114852
R757 VDD.n1158 VDD.n39 9.0005
R758 VDD.n1159 VDD.n301 0.114852
R759 VDD.n301 VDD.n39 4.44407
R760 VDD.n199 VDD.n39 4.44407
R761 VDD.n1162 VDD.n199 0.114852
R762 VDD.n1163 VDD.n39 9.0005
R763 VDD.n1164 VDD.n302 0.114852
R764 VDD.n302 VDD.n42 4.44407
R765 VDD.n198 VDD.n42 4.44407
R766 VDD.n1167 VDD.n198 0.114852
R767 VDD.n1168 VDD.n42 9.0005
R768 VDD.n1169 VDD.n303 0.114852
R769 VDD.n303 VDD.n42 4.44407
R770 VDD.n197 VDD.n42 4.44407
R771 VDD.n1172 VDD.n197 0.114852
R772 VDD.n1173 VDD.n42 9.0005
R773 VDD.n1174 VDD.n304 0.114852
R774 VDD.n304 VDD.n44 4.44407
R775 VDD.n196 VDD.n44 4.44407
R776 VDD.n1177 VDD.n196 0.114852
R777 VDD.n1178 VDD.n44 9.0005
R778 VDD.n305 VDD.n1179 0.114852
R779 VDD.n305 VDD.n44 4.44407
R780 VDD.n195 VDD.n44 4.44407
R781 VDD.n941 VDD.n195 0.114852
R782 VDD.n940 VDD.n44 9.0005
R783 VDD.n306 VDD.n369 0.114852
R784 VDD.n306 VDD.n46 4.44407
R785 VDD.n194 VDD.n46 4.44407
R786 VDD.n934 VDD.n194 0.114852
R787 VDD.n867 VDD.n46 9.0005
R788 VDD.n930 VDD.n307 0.114852
R789 VDD.n307 VDD.n46 4.44407
R790 VDD.n193 VDD.n46 4.44407
R791 VDD.n914 VDD.n193 0.114852
R792 VDD.n915 VDD.n46 9.0005
R793 VDD.n308 VDD.n916 0.114852
R794 VDD.n308 VDD.n47 4.44407
R795 VDD.n192 VDD.n47 4.44407
R796 VDD.n905 VDD.n192 0.114852
R797 VDD.n904 VDD.n47 9.0005
R798 VDD.n309 VDD.n370 0.114852
R799 VDD.n309 VDD.n47 4.44407
R800 VDD.n191 VDD.n47 4.44407
R801 VDD.n898 VDD.n191 0.114852
R802 VDD.n875 VDD.n47 9.0005
R803 VDD.n894 VDD.n310 0.114852
R804 VDD.n310 VDD.n50 4.44407
R805 VDD.n190 VDD.n50 4.44407
R806 VDD.n886 VDD.n190 0.114852
R807 VDD.n887 VDD.n50 9.0005
R808 VDD.n888 VDD.n311 0.114852
R809 VDD.n311 VDD.n50 4.44407
R810 VDD.n189 VDD.n50 4.44407
R811 VDD.n891 VDD.n189 0.114852
R812 VDD.n892 VDD.n50 9.0005
R813 VDD.n133 VDD.n1062 9.11485
R814 VDD.n1063 VDD.n1061 9.0005
R815 VDD.n1064 VDD.n1060 9.0005
R816 VDD.n1065 VDD.n1059 9.0005
R817 VDD.n1066 VDD.n1058 9.0005
R818 VDD.n1067 VDD.n1057 9.0005
R819 VDD.n1068 VDD.n1056 9.0005
R820 VDD.n1069 VDD.n1055 9.0005
R821 VDD.n1070 VDD.n1054 9.0005
R822 VDD.n1071 VDD.n1053 9.0005
R823 VDD.n1072 VDD.n1052 9.0005
R824 VDD.n1073 VDD.n1051 9.0005
R825 VDD.n1074 VDD.n1050 9.0005
R826 VDD.n1075 VDD.n1049 9.0005
R827 VDD.n1076 VDD.n1048 9.0005
R828 VDD.n1077 VDD.n1047 9.0005
R829 VDD.n1078 VDD.n1046 9.0005
R830 VDD.n1079 VDD.n1045 9.0005
R831 VDD.n1080 VDD.n1044 9.0005
R832 VDD.n1081 VDD.n1043 9.0005
R833 VDD.n1082 VDD.n1042 9.0005
R834 VDD.n1083 VDD.n1041 9.0005
R835 VDD.n1084 VDD.n1040 9.0005
R836 VDD.n1085 VDD.n1039 9.0005
R837 VDD.n1086 VDD.n1038 9.0005
R838 VDD.n1087 VDD.n1037 9.0005
R839 VDD.n1088 VDD.n1036 9.0005
R840 VDD.n1089 VDD.n1035 9.0005
R841 VDD.n1090 VDD.n1034 9.0005
R842 VDD.n1091 VDD.n1033 9.0005
R843 VDD.n1092 VDD.n1032 9.0005
R844 VDD.n1093 VDD.n1031 9.0005
R845 VDD.n1094 VDD.n1030 9.0005
R846 VDD.n1095 VDD.n1029 9.0005
R847 VDD.n1096 VDD.n1028 9.0005
R848 VDD.n1097 VDD.n1027 9.0005
R849 VDD.n1098 VDD.n1026 9.0005
R850 VDD.n1099 VDD.n1025 9.0005
R851 VDD.n1100 VDD.n1024 9.0005
R852 VDD.n1101 VDD.n1023 9.0005
R853 VDD.n1102 VDD.n1022 9.0005
R854 VDD.n1103 VDD.n1021 9.0005
R855 VDD.n1104 VDD.n1020 9.0005
R856 VDD.n1105 VDD.n1019 9.0005
R857 VDD.n1106 VDD.n1018 9.0005
R858 VDD.n1107 VDD.n1017 9.0005
R859 VDD.n1108 VDD.n1016 9.0005
R860 VDD.n1109 VDD.n1015 9.0005
R861 VDD.n1110 VDD.n1014 9.0005
R862 VDD.n1111 VDD.n1013 9.0005
R863 VDD.n1112 VDD.n1012 9.0005
R864 VDD.n1113 VDD.n1011 9.0005
R865 VDD.n1114 VDD.n1010 9.0005
R866 VDD.n1115 VDD.n1009 9.0005
R867 VDD.n1116 VDD.n1008 9.0005
R868 VDD.n1117 VDD.n1007 9.0005
R869 VDD.n1118 VDD.n1006 9.0005
R870 VDD.n1119 VDD.n1005 9.0005
R871 VDD.n1120 VDD.n1004 9.0005
R872 VDD.n1121 VDD.n1003 9.0005
R873 VDD.n1122 VDD.n1002 9.0005
R874 VDD.n1123 VDD.n1001 9.0005
R875 VDD.n1124 VDD.n1000 9.0005
R876 VDD.n1125 VDD.n999 9.0005
R877 VDD.n1126 VDD.n998 9.0005
R878 VDD.n1127 VDD.n997 9.0005
R879 VDD.n1128 VDD.n996 9.0005
R880 VDD.n1129 VDD.n995 9.0005
R881 VDD.n1130 VDD.n994 9.0005
R882 VDD.n1131 VDD.n993 9.0005
R883 VDD.n1132 VDD.n992 9.0005
R884 VDD.n1133 VDD.n991 9.0005
R885 VDD.n1134 VDD.n990 9.0005
R886 VDD.n1135 VDD.n989 9.0005
R887 VDD.n1136 VDD.n988 9.0005
R888 VDD.n1137 VDD.n987 9.0005
R889 VDD.n1138 VDD.n986 9.0005
R890 VDD.n1139 VDD.n985 9.0005
R891 VDD.n1140 VDD.n984 9.0005
R892 VDD.n1141 VDD.n983 9.0005
R893 VDD.n1142 VDD.n982 9.0005
R894 VDD.n1143 VDD.n981 9.0005
R895 VDD.n1144 VDD.n980 9.0005
R896 VDD.n1145 VDD.n979 9.0005
R897 VDD.n1146 VDD.n978 9.0005
R898 VDD.n1147 VDD.n977 9.0005
R899 VDD.n1148 VDD.n976 9.0005
R900 VDD.n1149 VDD.n975 9.0005
R901 VDD.n1150 VDD.n974 9.0005
R902 VDD.n1151 VDD.n973 9.0005
R903 VDD.n1152 VDD.n972 9.0005
R904 VDD.n1153 VDD.n971 9.0005
R905 VDD.n1154 VDD.n970 9.0005
R906 VDD.n1155 VDD.n969 9.0005
R907 VDD.n1156 VDD.n968 9.0005
R908 VDD.n1157 VDD.n967 9.0005
R909 VDD.n1158 VDD.n966 9.0005
R910 VDD.n1159 VDD.n965 9.0005
R911 VDD.n1160 VDD.n964 9.0005
R912 VDD.n1161 VDD.n963 9.0005
R913 VDD.n1162 VDD.n962 9.0005
R914 VDD.n1163 VDD.n961 9.0005
R915 VDD.n1164 VDD.n960 9.0005
R916 VDD.n1165 VDD.n959 9.0005
R917 VDD.n1166 VDD.n958 9.0005
R918 VDD.n1167 VDD.n957 9.0005
R919 VDD.n1168 VDD.n956 9.0005
R920 VDD.n1169 VDD.n955 9.0005
R921 VDD.n1170 VDD.n954 9.0005
R922 VDD.n1171 VDD.n953 9.0005
R923 VDD.n1172 VDD.n952 9.0005
R924 VDD.n1173 VDD.n951 9.0005
R925 VDD.n1174 VDD.n950 9.0005
R926 VDD.n1175 VDD.n949 9.0005
R927 VDD.n1176 VDD.n948 9.0005
R928 VDD.n1177 VDD.n947 9.0005
R929 VDD.n1178 VDD.n946 9.0005
R930 VDD.n1179 VDD.n945 9.0005
R931 VDD.n944 VDD.n864 9.0005
R932 VDD.n943 VDD.n942 9.0005
R933 VDD.n941 VDD.n865 9.0005
R934 VDD.n940 VDD.n939 9.0005
R935 VDD.n938 VDD.n369 9.0005
R936 VDD.n937 VDD.n936 9.0005
R937 VDD.n935 VDD.n866 9.0005
R938 VDD.n934 VDD.n933 9.0005
R939 VDD.n932 VDD.n867 9.0005
R940 VDD.n931 VDD.n930 9.0005
R941 VDD.n869 VDD.n868 9.0005
R942 VDD.n913 VDD.n912 9.0005
R943 VDD.n914 VDD.n911 9.0005
R944 VDD.n915 VDD.n910 9.0005
R945 VDD.n916 VDD.n909 9.0005
R946 VDD.n908 VDD.n872 9.0005
R947 VDD.n907 VDD.n906 9.0005
R948 VDD.n905 VDD.n873 9.0005
R949 VDD.n904 VDD.n903 9.0005
R950 VDD.n902 VDD.n370 9.0005
R951 VDD.n901 VDD.n900 9.0005
R952 VDD.n899 VDD.n874 9.0005
R953 VDD.n898 VDD.n897 9.0005
R954 VDD.n896 VDD.n875 9.0005
R955 VDD.n895 VDD.n894 9.0005
R956 VDD.n877 VDD.n876 9.0005
R957 VDD.n885 VDD.n884 9.0005
R958 VDD.n886 VDD.n883 9.0005
R959 VDD.n887 VDD.n882 9.0005
R960 VDD.n888 VDD.n881 9.0005
R961 VDD.n889 VDD.n880 9.0005
R962 VDD.n890 VDD.n879 9.0005
R963 VDD.n891 VDD.n878 9.0005
R964 VDD.n892 VDD.n89 0.47461
R965 VDD.n89 VDD.n53 1.26575
R966 VDD.n89 VDD.n878 1.63077
R967 VDD.n349 VDD.n834 9.0005
R968 VDD.n1248 VDD.n1247 9.0005
R969 VDD.n350 VDD.n835 9.0005
R970 VDD.n1245 VDD.n1244 9.0005
R971 VDD.n1243 VDD.n1242 9.0005
R972 VDD.n233 VDD.n836 9.0005
R973 VDD.n1240 VDD.n258 9.11485
R974 VDD.n351 VDD.n837 9.0005
R975 VDD.n1239 VDD.n1238 9.0005
R976 VDD.n1237 VDD.n1236 9.0005
R977 VDD.n839 VDD.n838 9.0005
R978 VDD.n352 VDD.n840 9.0005
R979 VDD.n1233 VDD.n1232 9.0005
R980 VDD.n1231 VDD.n1230 9.0005
R981 VDD.n226 VDD.n841 9.0005
R982 VDD.n1228 VDD.n257 9.11485
R983 VDD.n256 VDD.n842 9.0005
R984 VDD.n1227 VDD.n1226 9.0005
R985 VDD.n353 VDD.n843 9.0005
R986 VDD.n1224 VDD.n1223 9.0005
R987 VDD.n1222 VDD.n1221 9.0005
R988 VDD.n845 VDD.n844 9.0005
R989 VDD.n1219 VDD.n1218 9.0005
R990 VDD.n847 VDD.n846 9.0005
R991 VDD.n1216 VDD.n1215 9.0005
R992 VDD.n228 VDD.n848 9.0005
R993 VDD.n354 VDD.n849 9.0005
R994 VDD.n1212 VDD.n1211 9.0005
R995 VDD.n355 VDD.n850 9.0005
R996 VDD.n1209 VDD.n1208 9.0005
R997 VDD.n1207 VDD.n1206 9.0005
R998 VDD.n852 VDD.n851 9.0005
R999 VDD.n1204 VDD.n253 9.11485
R1000 VDD.n356 VDD.n853 9.0005
R1001 VDD.n1203 VDD.n1202 9.0005
R1002 VDD.n1201 VDD.n1200 9.0005
R1003 VDD.n230 VDD.n854 9.0005
R1004 VDD.n357 VDD.n855 9.0005
R1005 VDD.n1197 VDD.n1196 9.0005
R1006 VDD.n1195 VDD.n1194 9.0005
R1007 VDD.n857 VDD.n856 9.0005
R1008 VDD.n1192 VDD.n1191 9.0005
R1009 VDD.n859 VDD.n858 9.0005
R1010 VDD.n358 VDD.n860 9.0005
R1011 VDD.n1188 VDD.n1187 9.0005
R1012 VDD.n1186 VDD.n250 9.11485
R1013 VDD.n249 VDD.n861 9.0005
R1014 VDD.n1185 VDD.n1184 9.0005
R1015 VDD.n359 VDD.n862 9.0005
R1016 VDD.n1182 VDD.n1181 9.0005
R1017 VDD.n360 VDD.n863 9.0005
R1018 VDD.n922 VDD.n921 9.0005
R1019 VDD.n247 VDD.n923 9.11485
R1020 VDD.n924 VDD.n920 9.0005
R1021 VDD.n925 VDD.n919 9.0005
R1022 VDD.n927 VDD.n361 9.0005
R1023 VDD.n929 VDD.n928 9.0005
R1024 VDD.n918 VDD.n917 9.0005
R1025 VDD.n871 VDD.n870 9.0005
R1026 VDD.n57 VDD.n893 3.05626
R1027 VDD.n529 VDD.n528 9.0005
R1028 VDD.n527 VDD.n510 9.0005
R1029 VDD.n526 VDD.n525 9.0005
R1030 VDD.n524 VDD.n390 9.0005
R1031 VDD.n523 VDD.n522 9.0005
R1032 VDD.n521 VDD.n511 9.0005
R1033 VDD.n514 VDD.n513 9.0005
R1034 VDD.n1271 VDD.n490 9.0005
R1035 VDD.n1272 VDD.n489 9.0005
R1036 VDD.n1273 VDD.n488 9.0005
R1037 VDD.n1274 VDD.n487 9.0005
R1038 VDD.n486 VDD.n484 9.0005
R1039 VDD.n485 VDD.n478 9.0005
R1040 VDD.n1281 VDD.n477 9.0005
R1041 VDD.n1283 VDD.n1282 9.0005
R1042 VDD.n512 VDD.n495 9.0005
R1043 VDD.n1264 VDD.n494 9.0005
R1044 VDD.n1265 VDD.n493 9.0005
R1045 VDD.n1267 VDD.n1266 9.0005
R1046 VDD.n1268 VDD.n492 9.0005
R1047 VDD.n1270 VDD.n1269 9.0005
R1048 VDD.n12 VDD.t81 8.95516
R1049 VDD.n1252 VDD.n1251 8.81559
R1050 VDD.n410 VDD.t110 8.76054
R1051 VDD.n410 VDD.t1 8.76054
R1052 VDD.t4 VDD.t171 8.76054
R1053 VDD.t4 VDD.t87 8.76054
R1054 VDD.t4 VDD.t329 8.76054
R1055 VDD.t4 VDD.t98 8.76054
R1056 VDD.n75 VDD.t18 8.76054
R1057 VDD.n75 VDD.t326 8.76054
R1058 VDD.n75 VDD.t264 8.76054
R1059 VDD.n75 VDD.t24 8.76054
R1060 VDD.n75 VDD.t6 8.76054
R1061 VDD.n75 VDD.t271 8.76054
R1062 VDD.n75 VDD.t136 8.76054
R1063 VDD.n75 VDD.t86 8.76054
R1064 VDD.n75 VDD.t17 8.76054
R1065 VDD.n75 VDD.t327 8.76054
R1066 VDD.n75 VDD.t5 8.76054
R1067 VDD.n75 VDD.t82 8.76054
R1068 VDD.n135 VDD.t85 8.76054
R1069 VDD.n341 VDD.t4 3.34484
R1070 VDD.n86 VDD.n84 0.292859
R1071 VDD.n51 VDD.n2 0.654309
R1072 VDD.t0 VDD.n51 0.572944
R1073 VDD.n188 VDD.n92 0.210228
R1074 VDD.t0 VDD.n188 2.03946
R1075 VDD.t0 VDD.n323 2.75414
R1076 VDD.n61 VDD.n60 0.36275
R1077 VDD.t4 VDD.n75 0.276649
R1078 VDD.n340 VDD.n341 0.123015
R1079 VDD.n261 VDD.n321 0.172561
R1080 VDD.n119 VDD.t4 0.242175
R1081 VDD.n263 VDD.n316 0.266612
R1082 VDD.n10 VDD.t4 0.446203
R1083 VDD.n72 VDD.n101 0.524313
R1084 VDD.n163 VDD.n76 0.62251
R1085 VDD.n142 VDD.n59 0.737912
R1086 VDD.t36 VDD.n85 0.244488
R1087 VDD.t36 VDD 0.311673
R1088 VDD.t36 VDD.n409 8.47111
R1089 VDD.t36 VDD.n387 4.22406
R1090 VDD.n60 VDD.t400 7.62594
R1091 VDD.n60 VDD.t399 7.62594
R1092 VDD.n62 VDD.t397 7.62594
R1093 VDD.n66 VDD.t394 7.62594
R1094 VDD.n67 VDD.t391 7.62594
R1095 VDD.n64 VDD.t388 7.62594
R1096 VDD.n68 VDD.t385 7.62594
R1097 VDD.n68 VDD.t383 7.62594
R1098 VDD.n68 VDD.t384 7.62594
R1099 VDD.n64 VDD.t386 7.62594
R1100 VDD.n63 VDD.t387 7.62594
R1101 VDD.n67 VDD.t389 7.62594
R1102 VDD.n67 VDD.t390 7.62594
R1103 VDD.n66 VDD.t392 7.62594
R1104 VDD.n66 VDD.t393 7.62594
R1105 VDD.n62 VDD.t395 7.62594
R1106 VDD.n62 VDD.t396 7.62594
R1107 VDD.n73 VDD.t398 7.62594
R1108 VDD.n530 VDD.n529 7.58677
R1109 VDD.n1250 VDD.n128 2.02793
R1110 VDD.t10 VDD.n244 2.51424
R1111 VDD.t10 VDD.t28 6.09901
R1112 VDD.t10 VDD.t211 6.09901
R1113 VDD.t10 VDD.t133 6.09901
R1114 VDD.t10 VDD.t19 6.09901
R1115 VDD.t10 VDD.t105 6.09901
R1116 VDD.t10 VDD.t231 6.09901
R1117 VDD.t10 VDD.t27 6.09901
R1118 VDD.n78 VDD.t147 6.09901
R1119 VDD.n69 VDD.t109 6.09901
R1120 VDD.n69 VDD.t233 6.09901
R1121 VDD.n69 VDD.t40 6.09901
R1122 VDD.n69 VDD.t106 6.09901
R1123 VDD.n72 VDD.t90 6.09901
R1124 VDD.n72 VDD.t344 6.09901
R1125 VDD.n77 VDD.t154 6.09901
R1126 VDD.n32 VDD.t100 6.09901
R1127 VDD.n164 VDD.t227 6.09901
R1128 VDD.n76 VDD.t12 6.09901
R1129 VDD.n76 VDD.t114 6.09901
R1130 VDD.n76 VDD.t161 6.09901
R1131 VDD.n76 VDD.t37 6.09901
R1132 VDD.t10 VDD.t128 6.09901
R1133 VDD.t10 VDD.t31 6.09901
R1134 VDD.n97 VDD.t274 6.09901
R1135 VDD.n97 VDD.t145 6.09901
R1136 VDD.n142 VDD.t141 6.09901
R1137 VDD.n103 VDD.t11 6.09901
R1138 VDD.n57 VDD.t143 6.09901
R1139 VDD.n57 VDD.t159 6.09901
R1140 VDD.n57 VDD.t228 6.09901
R1141 VDD.n57 VDD.t336 6.09901
R1142 VDD.n57 VDD.t88 6.09901
R1143 VDD.n68 VDD.t206 5.99122
R1144 VDD.n64 VDD.t131 5.99122
R1145 VDD.n67 VDD.t370 5.99122
R1146 VDD.n66 VDD.t91 5.99122
R1147 VDD.n62 VDD.t150 5.99122
R1148 VDD.n73 VDD.t104 5.99122
R1149 VDD.n58 VDD.t214 5.9886
R1150 VDD.n186 VDD.t261 5.98839
R1151 VDD.n387 VDD.t112 5.97675
R1152 VDD.n387 VDD.t3 5.97675
R1153 VDD.t4 VDD.t287 5.97169
R1154 VDD.n75 VDD.t25 5.97169
R1155 VDD.n75 VDD.t267 5.97169
R1156 VDD.n75 VDD.t83 5.97169
R1157 VDD.t4 VDD.t330 5.97146
R1158 VDD.n75 VDD.t265 5.97146
R1159 VDD.n75 VDD.t137 5.97146
R1160 VDD.n75 VDD.t33 5.97146
R1161 VDD.n60 VDD.t253 5.96935
R1162 VDD.n60 VDD.t219 5.96935
R1163 VDD.n60 VDD.t255 5.96935
R1164 VDD.n62 VDD.t121 5.96935
R1165 VDD.n73 VDD.t221 5.96935
R1166 VDD.n66 VDD.t165 5.96935
R1167 VDD.n62 VDD.t218 5.96935
R1168 VDD.n67 VDD.t250 5.96935
R1169 VDD.n66 VDD.t107 5.96935
R1170 VDD.n64 VDD.t351 5.96935
R1171 VDD.n67 VDD.t222 5.96935
R1172 VDD.n68 VDD.t276 5.96935
R1173 VDD.n64 VDD.t275 5.96935
R1174 VDD.n68 VDD.t281 5.96935
R1175 VDD.n68 VDD.t177 5.96935
R1176 VDD.n68 VDD.t169 5.96935
R1177 VDD.n68 VDD.t116 5.96935
R1178 VDD.n68 VDD.t350 5.96935
R1179 VDD.n64 VDD.t244 5.96935
R1180 VDD.n64 VDD.t352 5.96935
R1181 VDD.n64 VDD.t249 5.96935
R1182 VDD.n64 VDD.t119 5.96935
R1183 VDD.n67 VDD.t225 5.96935
R1184 VDD.n67 VDD.t215 5.96935
R1185 VDD.n67 VDD.t118 5.96935
R1186 VDD.n67 VDD.t200 5.96935
R1187 VDD.n66 VDD.t364 5.96935
R1188 VDD.n66 VDD.t278 5.96935
R1189 VDD.n66 VDD.t252 5.96935
R1190 VDD.n66 VDD.t173 5.96935
R1191 VDD.n62 VDD.t180 5.96935
R1192 VDD.n62 VDD.t178 5.96935
R1193 VDD.n62 VDD.t15 5.96935
R1194 VDD.n62 VDD.t164 5.96935
R1195 VDD.n73 VDD.t124 5.96935
R1196 VDD.n73 VDD.t29 5.96935
R1197 VDD.n245 VDD.t328 5.96534
R1198 VDD.n312 VDD.t270 5.96534
R1199 VDD.n186 VDD.t23 5.96534
R1200 VDD.n187 VDD.t382 5.96534
R1201 VDD.n60 VDD.t156 5.96534
R1202 VDD.n60 VDD.t339 5.96534
R1203 VDD.n60 VDD.t332 5.96534
R1204 VDD.n60 VDD.t126 5.96534
R1205 VDD.n60 VDD.t149 5.96534
R1206 VDD.n60 VDD.t324 5.96534
R1207 VDD.n60 VDD.t20 5.96534
R1208 VDD.n73 VDD.t94 5.96534
R1209 VDD.n74 VDD.t341 5.96534
R1210 VDD.n74 VDD.t217 5.96534
R1211 VDD.n62 VDD.t199 5.96534
R1212 VDD.n62 VDD.t95 5.96534
R1213 VDD.n339 VDD.t232 5.96534
R1214 VDD.n175 VDD.t102 5.96534
R1215 VDD.n66 VDD.t41 5.96534
R1216 VDD.n66 VDD.t226 5.96534
R1217 VDD.n136 VDD.t343 5.96534
R1218 VDD.n136 VDD.t279 5.96534
R1219 VDD.n265 VDD.t127 5.96534
R1220 VDD.n11 VDD.t138 5.96534
R1221 VDD.n11 VDD.t99 5.96534
R1222 VDD.n11 VDD.t378 5.96534
R1223 VDD.n135 VDD.t259 5.96534
R1224 VDD.n263 VDD.t153 5.96534
R1225 VDD.n338 VDD.t13 5.96534
R1226 VDD.n178 VDD.t216 5.96534
R1227 VDD.n67 VDD.t113 5.96534
R1228 VDD.n67 VDD.t96 5.96534
R1229 VDD.n337 VDD.t129 5.96534
R1230 VDD.n180 VDD.t101 5.96534
R1231 VDD.n64 VDD.t230 5.96534
R1232 VDD.n64 VDD.t202 5.96534
R1233 VDD.n68 VDD.t272 5.96534
R1234 VDD.n68 VDD.t280 5.96534
R1235 VDD.n68 VDD.t22 5.96534
R1236 VDD.n68 VDD.t125 5.96534
R1237 VDD.n137 VDD.t283 5.96534
R1238 VDD.n137 VDD.t157 5.96534
R1239 VDD.n261 VDD.t8 5.96534
R1240 VDD.n340 VDD.t325 5.96534
R1241 VDD.n68 VDD.t132 5.96534
R1242 VDD.n68 VDD.t139 5.96534
R1243 VDD.n68 VDD.t142 5.96534
R1244 VDD.n64 VDD.t346 5.96534
R1245 VDD.n64 VDD.t362 5.96534
R1246 VDD.n64 VDD.t347 5.96534
R1247 VDD.n67 VDD.t380 5.96534
R1248 VDD.n67 VDD.t163 5.96534
R1249 VDD.n67 VDD.t198 5.96534
R1250 VDD.n66 VDD.t349 5.96534
R1251 VDD.n66 VDD.t361 5.96534
R1252 VDD.n66 VDD.t174 5.96534
R1253 VDD.n62 VDD.t381 5.96534
R1254 VDD.n62 VDD.t373 5.96534
R1255 VDD.n62 VDD.t148 5.96534
R1256 VDD.n73 VDD.t92 5.96534
R1257 VDD.n60 VDD.t76 5.96512
R1258 VDD.n245 VDD.t16 5.96512
R1259 VDD.n312 VDD.t7 5.96512
R1260 VDD.n74 VDD.t34 5.96512
R1261 VDD.n175 VDD.t93 5.96512
R1262 VDD.n178 VDD.t333 5.96512
R1263 VDD.n11 VDD.t268 5.96512
R1264 VDD.n136 VDD.t89 5.96512
R1265 VDD.n180 VDD.t35 5.96512
R1266 VDD.n68 VDD.t337 5.96512
R1267 VDD.n137 VDD.t220 5.96512
R1268 VDD.n58 VDD.t80 5.96478
R1269 VDD.n64 VDD.n68 0.472854
R1270 VDD.n60 VDD.t254 5.65005
R1271 VDD.n60 VDD.t30 5.65005
R1272 VDD.n62 VDD.t122 5.65005
R1273 VDD.n66 VDD.t166 5.65005
R1274 VDD.n67 VDD.t201 5.65005
R1275 VDD.n64 VDD.t120 5.65005
R1276 VDD.n68 VDD.t277 5.65005
R1277 VDD.n68 VDD.t176 5.65005
R1278 VDD.n68 VDD.t115 5.65005
R1279 VDD.n64 VDD.t243 5.65005
R1280 VDD.n63 VDD.t248 5.65005
R1281 VDD.n67 VDD.t223 5.65005
R1282 VDD.n67 VDD.t117 5.65005
R1283 VDD.n66 VDD.t108 5.65005
R1284 VDD.n66 VDD.t251 5.65005
R1285 VDD.n62 VDD.t179 5.65005
R1286 VDD.n62 VDD.t14 5.65005
R1287 VDD.n73 VDD.t123 5.65005
R1288 VDD.t0 VDD.n366 0.789031
R1289 VDD.n594 VDD.n321 0.205672
R1290 VDD.n137 VDD.n91 0.794506
R1291 VDD.n337 VDD.n119 0.857025
R1292 VDD.n136 VDD.n65 0.832678
R1293 VDD.n339 VDD.n62 0.584301
R1294 VDD.n74 VDD.n73 0.658312
R1295 VDD.n77 VDD.n71 0.477552
R1296 VDD.n59 VDD.t10 0.381002
R1297 VDD.t10 VDD.n90 0.293199
R1298 VDD.n427 VDD.t56 5.60969
R1299 VDD.n12 VDD.t64 5.60347
R1300 VDD.n52 VDD.t75 5.60347
R1301 VDD.n57 VDD.t72 5.60347
R1302 VDD.t10 VDD.t70 5.8433
R1303 VDD.n5 VDD.t300 5.59675
R1304 VDD.n55 VDD.t320 5.59675
R1305 VDD.n88 VDD.t319 5.59675
R1306 VDD.n49 VDD.t318 5.59675
R1307 VDD.n48 VDD.t293 5.59675
R1308 VDD.n56 VDD.t316 5.59675
R1309 VDD.n102 VDD.t317 5.59675
R1310 VDD.n45 VDD.t315 5.59675
R1311 VDD.n96 VDD.t288 5.59675
R1312 VDD.n95 VDD.t314 5.59675
R1313 VDD.n43 VDD.t313 5.59675
R1314 VDD.n41 VDD.t296 5.59675
R1315 VDD.n40 VDD.t297 5.59675
R1316 VDD.n38 VDD.t312 5.59675
R1317 VDD.n37 VDD.t306 5.59675
R1318 VDD.n35 VDD.t308 5.59675
R1319 VDD.n34 VDD.t311 5.59675
R1320 VDD.n32 VDD.t310 5.59675
R1321 VDD.n31 VDD.t309 5.59675
R1322 VDD.n29 VDD.t307 5.59675
R1323 VDD.n28 VDD.t290 5.59675
R1324 VDD.n26 VDD.t291 5.59675
R1325 VDD.n25 VDD.t292 5.59675
R1326 VDD.n23 VDD.t294 5.59675
R1327 VDD.n22 VDD.t305 5.59675
R1328 VDD.n20 VDD.t304 5.59675
R1329 VDD.n19 VDD.t303 5.59675
R1330 VDD.n17 VDD.t299 5.59675
R1331 VDD.n16 VDD.t289 5.59675
R1332 VDD.n14 VDD.t302 5.59675
R1333 VDD.n13 VDD.t295 5.59675
R1334 VDD.t10 VDD.t298 5.78303
R1335 VDD.t10 VDD.t301 5.59675
R1336 VDD.n98 VDD.t57 5.59179
R1337 VDD.t10 VDD.t66 5.69856
R1338 VDD VDD.t45 4.9462
R1339 VDD.n519 VDD.t42 4.9462
R1340 VDD.n1259 VDD.n1258 4.73162
R1341 VDD.n592 VDD.n590 4.73162
R1342 VDD.n1284 VDD.n1283 4.73162
R1343 VDD.n475 VDD.n474 4.64666
R1344 VDD.n140 VDD.n139 1.69009
R1345 VDD.n79 VDD.n87 0.509383
R1346 VDD VDD.n833 3.2945
R1347 VDD VDD.n245 3.24369
R1348 VDD.n531 VDD.n530 2.93359
R1349 VDD.n4 VDD.t47 2.6992
R1350 VDD.n3 VDD.t53 2.6992
R1351 VDD.n93 VDD.t46 2.6992
R1352 VDD.n517 VDD.t50 2.6992
R1353 VDD.n515 VDD.t49 2.6992
R1354 VDD.n83 VDD.t43 2.6992
R1355 VDD.n516 VDD.t44 2.6992
R1356 VDD.n1263 VDD.t190 2.6992
R1357 VDD.n82 VDD.t183 2.6992
R1358 VDD.n491 VDD.t192 2.6992
R1359 VDD.n81 VDD.t185 2.6992
R1360 VDD.n51 VDD.t194 2.6992
R1361 VDD.n1275 VDD.t187 2.6992
R1362 VDD.t55 VDD.n122 0.25754
R1363 VDD.t36 VDD.n80 0.726746
R1364 VDD VDD.n1285 0.650201
R1365 VDD.n344 VDD.n122 0.523113
R1366 VDD.n82 VDD.n1263 1.11007
R1367 VDD.n81 VDD.n491 1.11007
R1368 VDD.n51 VDD.n1275 1.11007
R1369 VDD.n366 VDD.n508 0.707356
R1370 VDD.n1251 VDD.n1250 0.72826
R1371 VDD.n805 VDD.n804 0.692362
R1372 VDD.n1247 VDD.n1246 0.692362
R1373 VDD.n1244 VDD.n1243 0.692362
R1374 VDD.n1241 VDD.n1240 0.692362
R1375 VDD.n1238 VDD.n1237 0.692362
R1376 VDD.n1235 VDD.n1234 0.692362
R1377 VDD.n1232 VDD.n1231 0.692362
R1378 VDD.n1229 VDD.n1228 0.692362
R1379 VDD.n1226 VDD.n1225 0.692362
R1380 VDD.n1223 VDD.n1222 0.692362
R1381 VDD.n1220 VDD.n1219 0.692362
R1382 VDD.n1217 VDD.n1216 0.692362
R1383 VDD.n1214 VDD.n1213 0.692362
R1384 VDD.n1211 VDD.n1210 0.692362
R1385 VDD.n1208 VDD.n1207 0.692362
R1386 VDD.n1205 VDD.n1204 0.692362
R1387 VDD.n1202 VDD.n1201 0.692362
R1388 VDD.n1199 VDD.n1198 0.692362
R1389 VDD.n1196 VDD.n1195 0.692362
R1390 VDD.n1193 VDD.n1192 0.692362
R1391 VDD.n1190 VDD.n1189 0.692362
R1392 VDD.n1187 VDD.n1186 0.692362
R1393 VDD.n1184 VDD.n1183 0.692362
R1394 VDD.n1181 VDD.n1180 0.692362
R1395 VDD.n923 VDD.n922 0.692362
R1396 VDD.n926 VDD.n919 0.692362
R1397 VDD.n928 VDD.n918 0.692362
R1398 VDD.n100 VDD.n366 0.489843
R1399 VDD VDD.n3 0.570274
R1400 VDD.n517 VDD.n324 0.570274
R1401 VDD.n491 VDD.n51 0.570274
R1402 VDD.n4 VDD.n94 0.569912
R1403 VDD.n94 VDD.n93 0.569912
R1404 VDD.n515 VDD.n92 0.569912
R1405 VDD.n84 VDD.n83 0.569912
R1406 VDD.n516 VDD.n84 0.569912
R1407 VDD.n84 VDD.n81 0.569912
R1408 VDD.n1275 VDD.n94 0.569912
R1409 VDD.t52 VDD 2.91268
R1410 VDD.t73 VDD.n54 5.76404
R1411 VDD.n55 VDD.n53 0.495739
R1412 VDD.n53 VDD.n88 0.495739
R1413 VDD.n50 VDD.n49 0.495739
R1414 VDD.n50 VDD.n48 0.495739
R1415 VDD.n56 VDD.n47 0.495739
R1416 VDD.n102 VDD.n47 0.495739
R1417 VDD.n46 VDD.n45 0.495739
R1418 VDD.n96 VDD.n46 0.495739
R1419 VDD.n95 VDD.n44 0.495739
R1420 VDD.n44 VDD.n43 0.495739
R1421 VDD.n42 VDD.n41 0.495739
R1422 VDD.n42 VDD.n40 0.495739
R1423 VDD.n39 VDD.n38 0.495739
R1424 VDD.n39 VDD.n37 0.495739
R1425 VDD.n36 VDD.n35 0.495739
R1426 VDD.n36 VDD.n34 0.495739
R1427 VDD.n33 VDD.n32 0.495739
R1428 VDD.n33 VDD.n31 0.495739
R1429 VDD.n30 VDD.n29 0.495739
R1430 VDD.n30 VDD.n28 0.495739
R1431 VDD.n27 VDD.n26 0.495739
R1432 VDD.n27 VDD.n25 0.495739
R1433 VDD.n24 VDD.n23 0.495739
R1434 VDD.n24 VDD.n22 0.495739
R1435 VDD.n21 VDD.n20 0.495739
R1436 VDD.n21 VDD.n19 0.495739
R1437 VDD.n18 VDD.n17 0.495739
R1438 VDD.n18 VDD.n16 0.495739
R1439 VDD.n15 VDD.n14 0.495739
R1440 VDD.n15 VDD.n13 0.495739
R1441 VDD.n5 VDD.n12 0.495398
R1442 VDD VDD.n4 0.492005
R1443 VDD.n93 VDD.n1280 0.492005
R1444 VDD.n520 VDD.n515 0.492005
R1445 VDD.n83 VDD.n520 0.492005
R1446 VDD.n518 VDD.n516 0.492005
R1447 VDD.n1280 VDD.n3 0.491643
R1448 VDD.n518 VDD.n517 0.491643
R1449 VDD.n8 VDD.n5 0.478641
R1450 VDD.n57 VDD.n54 0.151081
R1451 VDD.n57 VDD.n55 0.478299
R1452 VDD.n49 VDD.n57 0.478299
R1453 VDD.n57 VDD.n56 0.478299
R1454 VDD.n103 VDD.n102 0.478299
R1455 VDD.n45 VDD.n142 0.478299
R1456 VDD.n97 VDD.n96 0.478299
R1457 VDD.n97 VDD.n95 0.478299
R1458 VDD.n41 VDD.t10 0.478299
R1459 VDD.n40 VDD.n76 0.478299
R1460 VDD.n35 VDD.n163 0.478299
R1461 VDD.n34 VDD.n120 0.478299
R1462 VDD.n31 VDD.n77 0.478299
R1463 VDD.n29 VDD.n72 0.478299
R1464 VDD.n25 VDD.n69 0.478299
R1465 VDD.n23 VDD.n69 0.478299
R1466 VDD.n22 VDD.n78 0.478299
R1467 VDD.n17 VDD.t10 0.478299
R1468 VDD.n13 VDD.t10 0.478299
R1469 VDD.n501 VDD.n500 0.461741
R1470 VDD.n1257 VDD.n1256 0.461741
R1471 VDD.n814 VDD.n813 0.461741
R1472 VDD.n750 VDD.n749 0.461741
R1473 VDD.n727 VDD.n724 0.461741
R1474 VDD.n702 VDD.n699 0.461741
R1475 VDD.n689 VDD.n688 0.461741
R1476 VDD.n678 VDD.n677 0.461741
R1477 VDD.n655 VDD.n652 0.461741
R1478 VDD.n630 VDD.n627 0.461741
R1479 VDD.n605 VDD.n602 0.461741
R1480 VDD.n54 VDD.n53 0.15656
R1481 VDD.n432 VDD.n431 0.437466
R1482 VDD.n139 VDD.n8 2.53755
R1483 VDD.n98 VDD.n9 0.20102
R1484 VDD.n427 VDD.n98 0.413465
R1485 VDD.t61 VDD.n6 5.68596
R1486 VDD.t67 VDD.t10 5.73699
R1487 VDD.n80 VDD.n410 0.890665
R1488 VDD.n389 VDD 0.405593
R1489 VDD.n1062 VDD.n128 3.33242
R1490 VDD.n244 VDD.n1249 3.33242
R1491 VDD.n1251 VDD.n531 0.342527
R1492 VDD.n7 VDD.n427 0.327154
R1493 VDD.n8 VDD.n6 0.191936
R1494 VDD.t65 VDD.t10 15.1006
R1495 VDD.n8 VDD.t62 5.71506
R1496 VDD.n520 VDD.n519 0.253639
R1497 VDD.t59 VDD.n98 5.6952
R1498 VDD.n519 VDD.n518 0.253298
R1499 VDD.n388 VDD.n387 0.0759111
R1500 VDD.n324 VDD.n323 0.157104
R1501 VDD.n723 VDD.n393 0.235167
R1502 VDD.n176 VDD.n393 0.116823
R1503 VDD.n722 VDD.n546 0.235167
R1504 VDD.n172 VDD.n394 0.116823
R1505 VDD.n717 VDD.n394 0.235167
R1506 VDD.n717 VDD.n378 0.116823
R1507 VDD.n709 VDD.n548 0.235167
R1508 VDD.n710 VDD.n709 0.235167
R1509 VDD.n711 VDD.n162 0.116823
R1510 VDD.n711 VDD.n549 0.235167
R1511 VDD.n550 VDD.n406 0.116823
R1512 VDD.n716 VDD.n550 0.235167
R1513 VDD.n716 VDD.n127 0.116823
R1514 VDD.n704 VDD.n374 0.235167
R1515 VDD.n704 VDD.n328 0.116823
R1516 VDD.n552 VDD.n335 0.235167
R1517 VDD.n223 VDD.n552 0.116823
R1518 VDD.n703 VDD.n553 0.235167
R1519 VDD.n626 VDD.n400 0.235167
R1520 VDD.n182 VDD.n400 0.116823
R1521 VDD.n625 VDD.n580 0.235167
R1522 VDD.n169 VDD.n401 0.116823
R1523 VDD.n620 VDD.n401 0.235167
R1524 VDD.n620 VDD.n381 0.116823
R1525 VDD.n612 VDD.n582 0.235167
R1526 VDD.n613 VDD.n612 0.235167
R1527 VDD.n614 VDD.n160 0.116823
R1528 VDD.n614 VDD.n583 0.235167
R1529 VDD.n584 VDD.n403 0.116823
R1530 VDD.n619 VDD.n584 0.235167
R1531 VDD.n125 VDD.n371 0.116823
R1532 VDD.n607 VDD.n371 0.235167
R1533 VDD.n607 VDD.n331 0.116823
R1534 VDD.n586 VDD.n332 0.235167
R1535 VDD.n220 VDD.n586 0.116823
R1536 VDD.n606 VDD.n587 0.235167
R1537 VDD.n500 VDD.n272 9.11485
R1538 VDD.n499 VDD.n483 0.231121
R1539 VDD.n1276 VDD.n343 0.114852
R1540 VDD.n1277 VDD.n1276 0.231121
R1541 VDD.n1278 VDD.n1277 0.231121
R1542 VDD.n1279 VDD.n1278 0.231121
R1543 VDD.n383 VDD.n280 0.29879
R1544 VDD.n1259 VDD.n506 0.231121
R1545 VDD.n506 VDD.n505 0.231121
R1546 VDD.n505 VDD.n504 0.231121
R1547 VDD.n504 VDD.n503 0.231121
R1548 VDD.n503 VDD.n501 0.231121
R1549 VDD.n500 VDD.n498 0.231121
R1550 VDD.n498 VDD.n497 0.231121
R1551 VDD.n497 VDD.n482 0.231121
R1552 VDD.n482 VDD.n481 0.231121
R1553 VDD.n481 VDD.n480 0.231121
R1554 VDD.n480 VDD.n479 0.231121
R1555 VDD.n479 VDD.n383 3.29329
R1556 VDD.n270 VDD.n1258 0.227781
R1557 VDD.n1261 VDD.n1260 0.231121
R1558 VDD.n1262 VDD.n1261 0.231121
R1559 VDD.n318 VDD.n496 0.114852
R1560 VDD.n502 VDD.n496 0.231121
R1561 VDD.n1255 VDD.n507 0.231121
R1562 VDD.n1254 VDD.n1253 0.231121
R1563 VDD.n816 VDD.n815 0.231121
R1564 VDD.n817 VDD.n184 0.114852
R1565 VDD.n818 VDD.n817 0.231121
R1566 VDD.n819 VDD.n325 0.114852
R1567 VDD.n820 VDD.n819 0.231121
R1568 VDD.n376 VDD.n820 0.114852
R1569 VDD.n822 VDD.n821 0.231121
R1570 VDD.n823 VDD.n167 0.114852
R1571 VDD.n824 VDD.n823 0.231121
R1572 VDD.n825 VDD.n824 0.231121
R1573 VDD.n826 VDD.n408 0.114852
R1574 VDD.n827 VDD.n826 0.231121
R1575 VDD.n827 VDD.n241 0.114852
R1576 VDD.n831 VDD.n534 0.231121
R1577 VDD.n831 VDD.n326 0.114852
R1578 VDD.n752 VDD.n533 0.231121
R1579 VDD.n752 VDD.n225 0.114852
R1580 VDD.n751 VDD.n368 0.231121
R1581 VDD.n748 VDD.n391 0.231121
R1582 VDD.n174 VDD.n391 0.114852
R1583 VDD.n747 VDD.n537 0.231121
R1584 VDD.n173 VDD.n392 0.114852
R1585 VDD.n742 VDD.n392 0.231121
R1586 VDD.n742 VDD.n377 0.114852
R1587 VDD.n734 VDD.n539 0.231121
R1588 VDD.n130 VDD.n734 0.114852
R1589 VDD.n736 VDD.n735 0.231121
R1590 VDD.n736 VDD.n540 0.231121
R1591 VDD.n541 VDD.n407 0.114852
R1592 VDD.n741 VDD.n541 0.231121
R1593 VDD.n242 VDD.n375 0.114852
R1594 VDD.n729 VDD.n375 0.231121
R1595 VDD.n729 VDD.n327 0.114852
R1596 VDD.n543 VDD.n336 0.231121
R1597 VDD.n224 VDD.n543 0.114852
R1598 VDD.n728 VDD.n544 0.231121
R1599 VDD.n676 VDD.n396 0.231121
R1600 VDD.n179 VDD.n396 0.114852
R1601 VDD.n675 VDD.n562 0.231121
R1602 VDD.n171 VDD.n397 0.114852
R1603 VDD.n670 VDD.n397 0.231121
R1604 VDD.n670 VDD.n379 0.114852
R1605 VDD.n662 VDD.n564 0.231121
R1606 VDD.n663 VDD.n662 0.231121
R1607 VDD.n664 VDD.n161 0.114852
R1608 VDD.n664 VDD.n565 0.231121
R1609 VDD.n566 VDD.n405 0.114852
R1610 VDD.n669 VDD.n566 0.231121
R1611 VDD.n126 VDD.n373 0.114852
R1612 VDD.n657 VDD.n373 0.231121
R1613 VDD.n657 VDD.n329 0.114852
R1614 VDD.n568 VDD.n334 0.231121
R1615 VDD.n222 VDD.n568 0.114852
R1616 VDD.n656 VDD.n569 0.231121
R1617 VDD.n651 VDD.n398 0.231121
R1618 VDD.n181 VDD.n398 0.114852
R1619 VDD.n650 VDD.n571 0.231121
R1620 VDD.n170 VDD.n399 0.114852
R1621 VDD.n645 VDD.n399 0.231121
R1622 VDD.n645 VDD.n380 0.114852
R1623 VDD.n637 VDD.n573 0.231121
R1624 VDD.n132 VDD.n637 0.114852
R1625 VDD.n639 VDD.n638 0.231121
R1626 VDD.n639 VDD.n574 0.231121
R1627 VDD.n575 VDD.n404 0.114852
R1628 VDD.n644 VDD.n575 0.231121
R1629 VDD.n644 VDD.n243 0.114852
R1630 VDD.n632 VDD.n372 0.231121
R1631 VDD.n632 VDD.n330 0.114852
R1632 VDD.n577 VDD.n333 0.231121
R1633 VDD.n221 VDD.n577 0.114852
R1634 VDD.n631 VDD.n578 0.231121
R1635 VDD.n601 VDD.n402 0.231121
R1636 VDD.n183 VDD.n402 0.114852
R1637 VDD.n600 VDD.n589 0.231121
R1638 VDD.n600 VDD.n348 0.231121
R1639 VDD.n320 VDD.n348 0.114852
R1640 VDD.n595 VDD.n591 0.231121
R1641 VDD.n593 VDD.n591 0.231121
R1642 VDD.n833 VDD.n532 0.231121
R1643 VDD.n787 VDD.n532 0.231121
R1644 VDD.n788 VDD.n787 0.231121
R1645 VDD.n788 VDD.n786 0.231121
R1646 VDD.n786 VDD.n785 0.231121
R1647 VDD.n785 VDD.n784 0.231121
R1648 VDD.n784 VDD.n783 0.231121
R1649 VDD.n783 VDD.n782 0.231121
R1650 VDD.n782 VDD.n781 0.231121
R1651 VDD.n781 VDD.n780 0.231121
R1652 VDD.n780 VDD.n779 0.231121
R1653 VDD.n779 VDD.n778 0.231121
R1654 VDD.n778 VDD.n777 0.231121
R1655 VDD.n777 VDD.n776 0.231121
R1656 VDD.n776 VDD.n775 0.231121
R1657 VDD.n775 VDD.n774 0.231121
R1658 VDD.n774 VDD.n773 0.231121
R1659 VDD.n804 VDD.n773 0.231121
R1660 VDD.n805 VDD.n772 0.231121
R1661 VDD.n772 VDD.n771 0.231121
R1662 VDD.n771 VDD.n770 0.231121
R1663 VDD.n770 VDD.n769 0.231121
R1664 VDD.n769 VDD.n768 0.231121
R1665 VDD.n768 VDD.n767 0.231121
R1666 VDD.n767 VDD.n766 0.231121
R1667 VDD.n813 VDD.n766 0.231121
R1668 VDD.n814 VDD.n765 0.231121
R1669 VDD.n765 VDD.n764 0.231121
R1670 VDD.n764 VDD.n763 0.231121
R1671 VDD.n763 VDD.n762 0.231121
R1672 VDD.n762 VDD.n761 0.231121
R1673 VDD.n761 VDD.n760 0.231121
R1674 VDD.n760 VDD.n759 0.231121
R1675 VDD.n759 VDD.n758 0.231121
R1676 VDD.n758 VDD.n757 0.231121
R1677 VDD.n757 VDD.n756 0.231121
R1678 VDD.n756 VDD.n755 0.231121
R1679 VDD.n828 VDD.n755 0.231121
R1680 VDD.n829 VDD.n828 0.231121
R1681 VDD.n830 VDD.n829 0.231121
R1682 VDD.n830 VDD.n754 0.231121
R1683 VDD.n754 VDD.n753 0.231121
R1684 VDD.n753 VDD.n535 0.231121
R1685 VDD.n750 VDD.n535 0.231121
R1686 VDD.n749 VDD.n536 0.231121
R1687 VDD.n745 VDD.n536 0.231121
R1688 VDD.n746 VDD.n745 0.231121
R1689 VDD.n746 VDD.n744 0.231121
R1690 VDD.n744 VDD.n743 0.231121
R1691 VDD.n743 VDD.n538 0.231121
R1692 VDD.n733 VDD.n538 0.231121
R1693 VDD.n733 VDD.n732 0.231121
R1694 VDD.n737 VDD.n732 0.231121
R1695 VDD.n738 VDD.n737 0.231121
R1696 VDD.n739 VDD.n738 0.231121
R1697 VDD.n740 VDD.n739 0.231121
R1698 VDD.n740 VDD.n731 0.231121
R1699 VDD.n731 VDD.n730 0.231121
R1700 VDD.n730 VDD.n542 0.231121
R1701 VDD.n725 VDD.n542 0.231121
R1702 VDD.n726 VDD.n725 0.231121
R1703 VDD.n727 VDD.n726 0.231121
R1704 VDD.n724 VDD.n545 0.231121
R1705 VDD.n720 VDD.n545 0.231121
R1706 VDD.n721 VDD.n720 0.231121
R1707 VDD.n721 VDD.n719 0.231121
R1708 VDD.n719 VDD.n718 0.231121
R1709 VDD.n718 VDD.n547 0.231121
R1710 VDD.n708 VDD.n547 0.231121
R1711 VDD.n708 VDD.n707 0.231121
R1712 VDD.n712 VDD.n707 0.231121
R1713 VDD.n713 VDD.n712 0.231121
R1714 VDD.n714 VDD.n713 0.231121
R1715 VDD.n715 VDD.n714 0.231121
R1716 VDD.n715 VDD.n706 0.231121
R1717 VDD.n706 VDD.n705 0.231121
R1718 VDD.n705 VDD.n551 0.231121
R1719 VDD.n700 VDD.n551 0.231121
R1720 VDD.n701 VDD.n700 0.231121
R1721 VDD.n702 VDD.n701 0.231121
R1722 VDD.n699 VDD.n554 0.231121
R1723 VDD.n695 VDD.n554 0.231121
R1724 VDD.n696 VDD.n695 0.231121
R1725 VDD.n696 VDD.n694 0.231121
R1726 VDD.n694 VDD.n693 0.231121
R1727 VDD.n693 VDD.n556 0.231121
R1728 VDD.n690 VDD.n556 0.231121
R1729 VDD.n690 VDD.n689 0.231121
R1730 VDD.n688 VDD.n557 0.231121
R1731 VDD.n684 VDD.n557 0.231121
R1732 VDD.n685 VDD.n684 0.231121
R1733 VDD.n685 VDD.n683 0.231121
R1734 VDD.n683 VDD.n682 0.231121
R1735 VDD.n682 VDD.n560 0.231121
R1736 VDD.n679 VDD.n560 0.231121
R1737 VDD.n679 VDD.n678 0.231121
R1738 VDD.n677 VDD.n561 0.231121
R1739 VDD.n673 VDD.n561 0.231121
R1740 VDD.n674 VDD.n673 0.231121
R1741 VDD.n674 VDD.n672 0.231121
R1742 VDD.n672 VDD.n671 0.231121
R1743 VDD.n671 VDD.n563 0.231121
R1744 VDD.n661 VDD.n563 0.231121
R1745 VDD.n661 VDD.n660 0.231121
R1746 VDD.n665 VDD.n660 0.231121
R1747 VDD.n666 VDD.n665 0.231121
R1748 VDD.n667 VDD.n666 0.231121
R1749 VDD.n668 VDD.n667 0.231121
R1750 VDD.n668 VDD.n659 0.231121
R1751 VDD.n659 VDD.n658 0.231121
R1752 VDD.n658 VDD.n567 0.231121
R1753 VDD.n653 VDD.n567 0.231121
R1754 VDD.n654 VDD.n653 0.231121
R1755 VDD.n655 VDD.n654 0.231121
R1756 VDD.n652 VDD.n570 0.231121
R1757 VDD.n648 VDD.n570 0.231121
R1758 VDD.n649 VDD.n648 0.231121
R1759 VDD.n649 VDD.n647 0.231121
R1760 VDD.n647 VDD.n646 0.231121
R1761 VDD.n646 VDD.n572 0.231121
R1762 VDD.n636 VDD.n572 0.231121
R1763 VDD.n636 VDD.n635 0.231121
R1764 VDD.n640 VDD.n635 0.231121
R1765 VDD.n641 VDD.n640 0.231121
R1766 VDD.n642 VDD.n641 0.231121
R1767 VDD.n643 VDD.n642 0.231121
R1768 VDD.n643 VDD.n634 0.231121
R1769 VDD.n634 VDD.n633 0.231121
R1770 VDD.n633 VDD.n576 0.231121
R1771 VDD.n628 VDD.n576 0.231121
R1772 VDD.n629 VDD.n628 0.231121
R1773 VDD.n630 VDD.n629 0.231121
R1774 VDD.n627 VDD.n579 0.231121
R1775 VDD.n623 VDD.n579 0.231121
R1776 VDD.n624 VDD.n623 0.231121
R1777 VDD.n624 VDD.n622 0.231121
R1778 VDD.n622 VDD.n621 0.231121
R1779 VDD.n621 VDD.n581 0.231121
R1780 VDD.n611 VDD.n581 0.231121
R1781 VDD.n611 VDD.n610 0.231121
R1782 VDD.n615 VDD.n610 0.231121
R1783 VDD.n616 VDD.n615 0.231121
R1784 VDD.n617 VDD.n616 0.231121
R1785 VDD.n618 VDD.n617 0.231121
R1786 VDD.n618 VDD.n609 0.231121
R1787 VDD.n609 VDD.n608 0.231121
R1788 VDD.n608 VDD.n585 0.231121
R1789 VDD.n603 VDD.n585 0.231121
R1790 VDD.n604 VDD.n603 0.231121
R1791 VDD.n605 VDD.n604 0.231121
R1792 VDD.n602 VDD.n588 0.231121
R1793 VDD.n598 VDD.n588 0.231121
R1794 VDD.n599 VDD.n598 0.231121
R1795 VDD.n599 VDD.n597 0.231121
R1796 VDD.n597 VDD.n596 0.231121
R1797 VDD.n596 VDD.n590 0.231121
R1798 VDD.n687 VDD.n558 0.231121
R1799 VDD.n559 VDD.n386 0.114852
R1800 VDD.n686 VDD.n559 0.231121
R1801 VDD.n686 VDD.n266 0.114852
R1802 VDD.n681 VDD.n347 0.231121
R1803 VDD.n681 VDD.n262 0.231121
R1804 VDD.n680 VDD.n262 0.231121
R1805 VDD.n680 VDD.n315 0.114852
R1806 VDD.n698 VDD.n395 0.231121
R1807 VDD.n177 VDD.n395 0.114852
R1808 VDD.n697 VDD.n555 0.231121
R1809 VDD.n697 VDD.n346 0.231121
R1810 VDD.n319 VDD.n346 0.114852
R1811 VDD.n692 VDD.n264 0.231121
R1812 VDD.n691 VDD.n264 0.231121
R1813 VDD.n691 VDD.n314 0.114852
R1814 VDD.n806 VDD.n276 0.114852
R1815 VDD.n807 VDD.n806 0.231121
R1816 VDD.n267 VDD.n807 0.114852
R1817 VDD.n809 VDD.n808 0.231121
R1818 VDD.n810 VDD.n809 0.231121
R1819 VDD.n268 VDD.n810 0.114852
R1820 VDD.n812 VDD.n811 0.231121
R1821 VDD.n813 VDD.n269 9.11485
R1822 VDD.n833 VDD.n246 9.11485
R1823 VDD.n832 VDD.n367 0.231121
R1824 VDD.n789 VDD.n313 0.114852
R1825 VDD.n790 VDD.n789 0.231121
R1826 VDD.n791 VDD.n129 0.114852
R1827 VDD.n792 VDD.n791 0.231121
R1828 VDD.n793 VDD.n185 0.114852
R1829 VDD.n794 VDD.n793 0.231121
R1830 VDD.n795 VDD.n794 0.231121
R1831 VDD.n281 VDD.n795 0.114852
R1832 VDD.n797 VDD.n796 0.231121
R1833 VDD.n117 VDD.n797 0.114852
R1834 VDD.n799 VDD.n798 0.231121
R1835 VDD.n322 VDD.n799 0.114852
R1836 VDD.n801 VDD.n800 0.231121
R1837 VDD.n802 VDD.n342 0.114852
R1838 VDD.n803 VDD.n802 0.231121
R1839 VDD.n165 VDD.n803 0.114852
R1840 VDD.n1063 VDD.n133 0.114852
R1841 VDD.n1064 VDD.n1063 0.231121
R1842 VDD.n1065 VDD.n282 0.114852
R1843 VDD.n1066 VDD.n1065 0.231121
R1844 VDD.n218 VDD.n1066 0.114852
R1845 VDD.n1068 VDD.n1067 0.231121
R1846 VDD.n1069 VDD.n1068 0.231121
R1847 VDD.n1070 VDD.n283 0.114852
R1848 VDD.n1071 VDD.n1070 0.231121
R1849 VDD.n217 VDD.n1071 0.114852
R1850 VDD.n1073 VDD.n1072 0.231121
R1851 VDD.n1074 VDD.n1073 0.231121
R1852 VDD.n1075 VDD.n284 0.114852
R1853 VDD.n1076 VDD.n1075 0.231121
R1854 VDD.n216 VDD.n1076 0.114852
R1855 VDD.n1078 VDD.n1077 0.231121
R1856 VDD.n1079 VDD.n1078 0.231121
R1857 VDD.n1080 VDD.n285 0.114852
R1858 VDD.n1081 VDD.n1080 0.231121
R1859 VDD.n215 VDD.n1081 0.114852
R1860 VDD.n1083 VDD.n1082 0.231121
R1861 VDD.n1084 VDD.n1083 0.231121
R1862 VDD.n1085 VDD.n286 0.114852
R1863 VDD.n1086 VDD.n1085 0.231121
R1864 VDD.n214 VDD.n1086 0.114852
R1865 VDD.n1088 VDD.n1087 0.231121
R1866 VDD.n1089 VDD.n1088 0.231121
R1867 VDD.n1090 VDD.n287 0.114852
R1868 VDD.n1091 VDD.n1090 0.231121
R1869 VDD.n213 VDD.n1091 0.114852
R1870 VDD.n1093 VDD.n1092 0.231121
R1871 VDD.n1094 VDD.n1093 0.231121
R1872 VDD.n1095 VDD.n288 0.114852
R1873 VDD.n1096 VDD.n1095 0.231121
R1874 VDD.n212 VDD.n1096 0.114852
R1875 VDD.n1098 VDD.n1097 0.231121
R1876 VDD.n1099 VDD.n1098 0.231121
R1877 VDD.n1100 VDD.n289 0.114852
R1878 VDD.n1101 VDD.n1100 0.231121
R1879 VDD.n211 VDD.n1101 0.114852
R1880 VDD.n1103 VDD.n1102 0.231121
R1881 VDD.n1104 VDD.n1103 0.231121
R1882 VDD.n1105 VDD.n290 0.114852
R1883 VDD.n1106 VDD.n1105 0.231121
R1884 VDD.n210 VDD.n1106 0.114852
R1885 VDD.n1108 VDD.n1107 0.231121
R1886 VDD.n1109 VDD.n1108 0.231121
R1887 VDD.n1110 VDD.n291 0.114852
R1888 VDD.n1111 VDD.n1110 0.231121
R1889 VDD.n209 VDD.n1111 0.114852
R1890 VDD.n1113 VDD.n1112 0.231121
R1891 VDD.n1114 VDD.n1113 0.231121
R1892 VDD.n1115 VDD.n292 0.114852
R1893 VDD.n1116 VDD.n1115 0.231121
R1894 VDD.n208 VDD.n1116 0.114852
R1895 VDD.n1118 VDD.n1117 0.231121
R1896 VDD.n1119 VDD.n1118 0.231121
R1897 VDD.n1120 VDD.n293 0.114852
R1898 VDD.n1121 VDD.n1120 0.231121
R1899 VDD.n207 VDD.n1121 0.114852
R1900 VDD.n1123 VDD.n1122 0.231121
R1901 VDD.n1124 VDD.n1123 0.231121
R1902 VDD.n1125 VDD.n294 0.114852
R1903 VDD.n1126 VDD.n1125 0.231121
R1904 VDD.n206 VDD.n1126 0.114852
R1905 VDD.n1128 VDD.n1127 0.231121
R1906 VDD.n1129 VDD.n1128 0.231121
R1907 VDD.n1130 VDD.n295 0.114852
R1908 VDD.n1131 VDD.n1130 0.231121
R1909 VDD.n205 VDD.n1131 0.114852
R1910 VDD.n1133 VDD.n1132 0.231121
R1911 VDD.n1134 VDD.n1133 0.231121
R1912 VDD.n1135 VDD.n296 0.114852
R1913 VDD.n1136 VDD.n1135 0.231121
R1914 VDD.n204 VDD.n1136 0.114852
R1915 VDD.n1138 VDD.n1137 0.231121
R1916 VDD.n1139 VDD.n1138 0.231121
R1917 VDD.n1140 VDD.n297 0.114852
R1918 VDD.n1141 VDD.n1140 0.231121
R1919 VDD.n203 VDD.n1141 0.114852
R1920 VDD.n1143 VDD.n1142 0.231121
R1921 VDD.n1144 VDD.n1143 0.231121
R1922 VDD.n1145 VDD.n298 0.114852
R1923 VDD.n1146 VDD.n1145 0.231121
R1924 VDD.n202 VDD.n1146 0.114852
R1925 VDD.n1148 VDD.n1147 0.231121
R1926 VDD.n1149 VDD.n1148 0.231121
R1927 VDD.n1150 VDD.n299 0.114852
R1928 VDD.n1151 VDD.n1150 0.231121
R1929 VDD.n201 VDD.n1151 0.114852
R1930 VDD.n1153 VDD.n1152 0.231121
R1931 VDD.n1154 VDD.n1153 0.231121
R1932 VDD.n1155 VDD.n300 0.114852
R1933 VDD.n1156 VDD.n1155 0.231121
R1934 VDD.n200 VDD.n1156 0.114852
R1935 VDD.n1158 VDD.n1157 0.231121
R1936 VDD.n1159 VDD.n1158 0.231121
R1937 VDD.n1160 VDD.n301 0.114852
R1938 VDD.n1161 VDD.n1160 0.231121
R1939 VDD.n199 VDD.n1161 0.114852
R1940 VDD.n1163 VDD.n1162 0.231121
R1941 VDD.n1164 VDD.n1163 0.231121
R1942 VDD.n1165 VDD.n302 0.114852
R1943 VDD.n1166 VDD.n1165 0.231121
R1944 VDD.n198 VDD.n1166 0.114852
R1945 VDD.n1168 VDD.n1167 0.231121
R1946 VDD.n1169 VDD.n1168 0.231121
R1947 VDD.n1170 VDD.n303 0.114852
R1948 VDD.n1171 VDD.n1170 0.231121
R1949 VDD.n197 VDD.n1171 0.114852
R1950 VDD.n1173 VDD.n1172 0.231121
R1951 VDD.n1174 VDD.n1173 0.231121
R1952 VDD.n1175 VDD.n304 0.114852
R1953 VDD.n1176 VDD.n1175 0.231121
R1954 VDD.n196 VDD.n1176 0.114852
R1955 VDD.n1178 VDD.n1177 0.231121
R1956 VDD.n1179 VDD.n1178 0.231121
R1957 VDD.n305 VDD.n864 0.114852
R1958 VDD.n942 VDD.n864 0.231121
R1959 VDD.n942 VDD.n195 0.114852
R1960 VDD.n941 VDD.n940 0.231121
R1961 VDD.n940 VDD.n369 0.231121
R1962 VDD.n936 VDD.n306 0.114852
R1963 VDD.n936 VDD.n935 0.231121
R1964 VDD.n935 VDD.n194 0.114852
R1965 VDD.n934 VDD.n867 0.231121
R1966 VDD.n930 VDD.n867 0.231121
R1967 VDD.n307 VDD.n869 0.114852
R1968 VDD.n913 VDD.n869 0.231121
R1969 VDD.n193 VDD.n913 0.114852
R1970 VDD.n915 VDD.n914 0.231121
R1971 VDD.n916 VDD.n915 0.231121
R1972 VDD.n308 VDD.n872 0.114852
R1973 VDD.n906 VDD.n872 0.231121
R1974 VDD.n906 VDD.n192 0.114852
R1975 VDD.n905 VDD.n904 0.231121
R1976 VDD.n904 VDD.n370 0.231121
R1977 VDD.n900 VDD.n309 0.114852
R1978 VDD.n900 VDD.n899 0.231121
R1979 VDD.n899 VDD.n191 0.114852
R1980 VDD.n898 VDD.n875 0.231121
R1981 VDD.n894 VDD.n875 0.231121
R1982 VDD.n310 VDD.n877 0.114852
R1983 VDD.n885 VDD.n877 0.231121
R1984 VDD.n190 VDD.n885 0.114852
R1985 VDD.n887 VDD.n886 0.231121
R1986 VDD.n888 VDD.n887 0.231121
R1987 VDD.n889 VDD.n311 0.114852
R1988 VDD.n890 VDD.n889 0.231121
R1989 VDD.n189 VDD.n890 0.114852
R1990 VDD.n892 VDD.n891 0.231121
R1991 VDD.n1062 VDD.n1061 0.231121
R1992 VDD.n1061 VDD.n1060 0.231121
R1993 VDD.n1060 VDD.n1059 0.231121
R1994 VDD.n1059 VDD.n1058 0.231121
R1995 VDD.n1058 VDD.n1057 0.231121
R1996 VDD.n1057 VDD.n1056 0.231121
R1997 VDD.n1056 VDD.n1055 0.231121
R1998 VDD.n1055 VDD.n1054 0.231121
R1999 VDD.n1054 VDD.n1053 0.231121
R2000 VDD.n1053 VDD.n1052 0.231121
R2001 VDD.n1052 VDD.n1051 0.231121
R2002 VDD.n1051 VDD.n1050 0.231121
R2003 VDD.n1050 VDD.n1049 0.231121
R2004 VDD.n1049 VDD.n1048 0.231121
R2005 VDD.n1048 VDD.n1047 0.231121
R2006 VDD.n1047 VDD.n1046 0.231121
R2007 VDD.n1046 VDD.n1045 0.231121
R2008 VDD.n1045 VDD.n1044 0.231121
R2009 VDD.n1044 VDD.n1043 0.231121
R2010 VDD.n1043 VDD.n1042 0.231121
R2011 VDD.n1042 VDD.n1041 0.231121
R2012 VDD.n1041 VDD.n1040 0.231121
R2013 VDD.n1040 VDD.n1039 0.231121
R2014 VDD.n1039 VDD.n1038 0.231121
R2015 VDD.n1038 VDD.n1037 0.231121
R2016 VDD.n1037 VDD.n1036 0.231121
R2017 VDD.n1036 VDD.n1035 0.231121
R2018 VDD.n1035 VDD.n1034 0.231121
R2019 VDD.n1034 VDD.n1033 0.231121
R2020 VDD.n1033 VDD.n1032 0.231121
R2021 VDD.n1032 VDD.n1031 0.231121
R2022 VDD.n1031 VDD.n1030 0.231121
R2023 VDD.n1030 VDD.n1029 0.231121
R2024 VDD.n1029 VDD.n1028 0.231121
R2025 VDD.n1028 VDD.n1027 0.231121
R2026 VDD.n1027 VDD.n1026 0.231121
R2027 VDD.n1026 VDD.n1025 0.231121
R2028 VDD.n1025 VDD.n1024 0.231121
R2029 VDD.n1024 VDD.n1023 0.231121
R2030 VDD.n1023 VDD.n1022 0.231121
R2031 VDD.n1022 VDD.n1021 0.231121
R2032 VDD.n1021 VDD.n1020 0.231121
R2033 VDD.n1020 VDD.n1019 0.231121
R2034 VDD.n1019 VDD.n1018 0.231121
R2035 VDD.n1018 VDD.n1017 0.231121
R2036 VDD.n1017 VDD.n1016 0.231121
R2037 VDD.n1016 VDD.n1015 0.231121
R2038 VDD.n1015 VDD.n1014 0.231121
R2039 VDD.n1014 VDD.n1013 0.231121
R2040 VDD.n1013 VDD.n1012 0.231121
R2041 VDD.n1012 VDD.n1011 0.231121
R2042 VDD.n1011 VDD.n1010 0.231121
R2043 VDD.n1010 VDD.n1009 0.231121
R2044 VDD.n1009 VDD.n1008 0.231121
R2045 VDD.n1008 VDD.n1007 0.231121
R2046 VDD.n1007 VDD.n1006 0.231121
R2047 VDD.n1006 VDD.n1005 0.231121
R2048 VDD.n1005 VDD.n1004 0.231121
R2049 VDD.n1004 VDD.n1003 0.231121
R2050 VDD.n1003 VDD.n1002 0.231121
R2051 VDD.n1002 VDD.n1001 0.231121
R2052 VDD.n1001 VDD.n1000 0.231121
R2053 VDD.n1000 VDD.n999 0.231121
R2054 VDD.n999 VDD.n998 0.231121
R2055 VDD.n998 VDD.n997 0.231121
R2056 VDD.n997 VDD.n996 0.231121
R2057 VDD.n996 VDD.n995 0.231121
R2058 VDD.n995 VDD.n994 0.231121
R2059 VDD.n994 VDD.n993 0.231121
R2060 VDD.n993 VDD.n992 0.231121
R2061 VDD.n992 VDD.n991 0.231121
R2062 VDD.n991 VDD.n990 0.231121
R2063 VDD.n990 VDD.n989 0.231121
R2064 VDD.n989 VDD.n988 0.231121
R2065 VDD.n988 VDD.n987 0.231121
R2066 VDD.n987 VDD.n986 0.231121
R2067 VDD.n986 VDD.n985 0.231121
R2068 VDD.n985 VDD.n984 0.231121
R2069 VDD.n984 VDD.n983 0.231121
R2070 VDD.n983 VDD.n982 0.231121
R2071 VDD.n982 VDD.n981 0.231121
R2072 VDD.n981 VDD.n980 0.231121
R2073 VDD.n980 VDD.n979 0.231121
R2074 VDD.n979 VDD.n978 0.231121
R2075 VDD.n978 VDD.n977 0.231121
R2076 VDD.n977 VDD.n976 0.231121
R2077 VDD.n976 VDD.n975 0.231121
R2078 VDD.n975 VDD.n974 0.231121
R2079 VDD.n974 VDD.n973 0.231121
R2080 VDD.n973 VDD.n972 0.231121
R2081 VDD.n972 VDD.n971 0.231121
R2082 VDD.n971 VDD.n970 0.231121
R2083 VDD.n970 VDD.n969 0.231121
R2084 VDD.n969 VDD.n968 0.231121
R2085 VDD.n968 VDD.n967 0.231121
R2086 VDD.n967 VDD.n966 0.231121
R2087 VDD.n966 VDD.n965 0.231121
R2088 VDD.n965 VDD.n964 0.231121
R2089 VDD.n964 VDD.n963 0.231121
R2090 VDD.n963 VDD.n962 0.231121
R2091 VDD.n962 VDD.n961 0.231121
R2092 VDD.n961 VDD.n960 0.231121
R2093 VDD.n960 VDD.n959 0.231121
R2094 VDD.n959 VDD.n958 0.231121
R2095 VDD.n958 VDD.n957 0.231121
R2096 VDD.n957 VDD.n956 0.231121
R2097 VDD.n956 VDD.n955 0.231121
R2098 VDD.n955 VDD.n954 0.231121
R2099 VDD.n954 VDD.n953 0.231121
R2100 VDD.n953 VDD.n952 0.231121
R2101 VDD.n952 VDD.n951 0.231121
R2102 VDD.n951 VDD.n950 0.231121
R2103 VDD.n950 VDD.n949 0.231121
R2104 VDD.n949 VDD.n948 0.231121
R2105 VDD.n948 VDD.n947 0.231121
R2106 VDD.n947 VDD.n946 0.231121
R2107 VDD.n946 VDD.n945 0.231121
R2108 VDD.n945 VDD.n944 0.231121
R2109 VDD.n944 VDD.n943 0.231121
R2110 VDD.n943 VDD.n865 0.231121
R2111 VDD.n939 VDD.n865 0.231121
R2112 VDD.n939 VDD.n938 0.231121
R2113 VDD.n938 VDD.n937 0.231121
R2114 VDD.n937 VDD.n866 0.231121
R2115 VDD.n933 VDD.n866 0.231121
R2116 VDD.n933 VDD.n932 0.231121
R2117 VDD.n932 VDD.n931 0.231121
R2118 VDD.n931 VDD.n868 0.231121
R2119 VDD.n912 VDD.n868 0.231121
R2120 VDD.n912 VDD.n911 0.231121
R2121 VDD.n911 VDD.n910 0.231121
R2122 VDD.n910 VDD.n909 0.231121
R2123 VDD.n909 VDD.n908 0.231121
R2124 VDD.n908 VDD.n907 0.231121
R2125 VDD.n907 VDD.n873 0.231121
R2126 VDD.n903 VDD.n873 0.231121
R2127 VDD.n903 VDD.n902 0.231121
R2128 VDD.n902 VDD.n901 0.231121
R2129 VDD.n901 VDD.n874 0.231121
R2130 VDD.n897 VDD.n874 0.231121
R2131 VDD.n897 VDD.n896 0.231121
R2132 VDD.n896 VDD.n895 0.231121
R2133 VDD.n895 VDD.n876 0.231121
R2134 VDD.n884 VDD.n876 0.231121
R2135 VDD.n884 VDD.n883 0.231121
R2136 VDD.n883 VDD.n882 0.231121
R2137 VDD.n882 VDD.n881 0.231121
R2138 VDD.n881 VDD.n880 0.231121
R2139 VDD.n880 VDD.n879 0.231121
R2140 VDD.n879 VDD.n878 0.231121
R2141 VDD.n128 VDD.t10 2.51424
R2142 VDD.n389 VDD.n244 2.02793
R2143 VDD.n1249 VDD.n834 0.231121
R2144 VDD.n1247 VDD.n834 0.231121
R2145 VDD.n1246 VDD.n835 0.231121
R2146 VDD.n1244 VDD.n835 0.231121
R2147 VDD.n1243 VDD.n836 0.231121
R2148 VDD.n1241 VDD.n836 0.231121
R2149 VDD.n1240 VDD.n837 0.231121
R2150 VDD.n1238 VDD.n837 0.231121
R2151 VDD.n1237 VDD.n838 0.231121
R2152 VDD.n1235 VDD.n838 0.231121
R2153 VDD.n1234 VDD.n840 0.231121
R2154 VDD.n1232 VDD.n840 0.231121
R2155 VDD.n1231 VDD.n841 0.231121
R2156 VDD.n1229 VDD.n841 0.231121
R2157 VDD.n1228 VDD.n842 0.231121
R2158 VDD.n1226 VDD.n842 0.231121
R2159 VDD.n1225 VDD.n843 0.231121
R2160 VDD.n1223 VDD.n843 0.231121
R2161 VDD.n1222 VDD.n844 0.231121
R2162 VDD.n1220 VDD.n844 0.231121
R2163 VDD.n1219 VDD.n846 0.231121
R2164 VDD.n1217 VDD.n846 0.231121
R2165 VDD.n1216 VDD.n848 0.231121
R2166 VDD.n1214 VDD.n848 0.231121
R2167 VDD.n1213 VDD.n849 0.231121
R2168 VDD.n1211 VDD.n849 0.231121
R2169 VDD.n1210 VDD.n850 0.231121
R2170 VDD.n1208 VDD.n850 0.231121
R2171 VDD.n1207 VDD.n851 0.231121
R2172 VDD.n1205 VDD.n851 0.231121
R2173 VDD.n1204 VDD.n853 0.231121
R2174 VDD.n1202 VDD.n853 0.231121
R2175 VDD.n1201 VDD.n854 0.231121
R2176 VDD.n1199 VDD.n854 0.231121
R2177 VDD.n1198 VDD.n855 0.231121
R2178 VDD.n1196 VDD.n855 0.231121
R2179 VDD.n1195 VDD.n856 0.231121
R2180 VDD.n1193 VDD.n856 0.231121
R2181 VDD.n1192 VDD.n858 0.231121
R2182 VDD.n1190 VDD.n858 0.231121
R2183 VDD.n1189 VDD.n860 0.231121
R2184 VDD.n1187 VDD.n860 0.231121
R2185 VDD.n1186 VDD.n861 0.231121
R2186 VDD.n1184 VDD.n861 0.231121
R2187 VDD.n1183 VDD.n862 0.231121
R2188 VDD.n1181 VDD.n862 0.231121
R2189 VDD.n1180 VDD.n863 0.231121
R2190 VDD.n922 VDD.n863 0.231121
R2191 VDD.n923 VDD.n920 0.231121
R2192 VDD.n920 VDD.n919 0.231121
R2193 VDD.n927 VDD.n926 0.231121
R2194 VDD.n928 VDD.n927 0.231121
R2195 VDD.n918 VDD.n870 0.231121
R2196 VDD.n893 VDD.n870 0.231121
R2197 VDD.n917 VDD.n871 0.231121
R2198 VDD.n893 VDD.n240 9.11485
R2199 VDD.n926 VDD.n274 9.11485
R2200 VDD.n929 VDD.n361 0.231121
R2201 VDD.n924 VDD.n247 0.114852
R2202 VDD.n925 VDD.n924 0.231121
R2203 VDD.n1180 VDD.n277 9.11485
R2204 VDD.n921 VDD.n360 0.231121
R2205 VDD.n1183 VDD.n248 9.11485
R2206 VDD.n1182 VDD.n359 0.231121
R2207 VDD.n250 VDD.n249 0.114852
R2208 VDD.n1185 VDD.n249 0.231121
R2209 VDD.n1189 VDD.n251 9.11485
R2210 VDD.n1188 VDD.n358 0.231121
R2211 VDD.n1191 VDD.n859 0.231121
R2212 VDD.n1190 VDD.n235 9.11485
R2213 VDD.n1194 VDD.n857 0.231121
R2214 VDD.n1193 VDD.n232 9.11485
R2215 VDD.n1198 VDD.n275 9.11485
R2216 VDD.n1197 VDD.n357 0.231121
R2217 VDD.n1200 VDD.n230 0.231121
R2218 VDD.n231 VDD.n230 0.114852
R2219 VDD.n253 VDD.n356 0.114852
R2220 VDD.n1203 VDD.n356 0.231121
R2221 VDD.n1206 VDD.n852 0.231121
R2222 VDD.n1205 VDD.n239 9.11485
R2223 VDD.n1210 VDD.n254 9.11485
R2224 VDD.n1209 VDD.n355 0.231121
R2225 VDD.n1213 VDD.n255 9.11485
R2226 VDD.n1212 VDD.n354 0.231121
R2227 VDD.n1215 VDD.n228 0.231121
R2228 VDD.n229 VDD.n228 0.114852
R2229 VDD.n1218 VDD.n847 0.231121
R2230 VDD.n1217 VDD.n238 9.11485
R2231 VDD.n1221 VDD.n845 0.231121
R2232 VDD.n1220 VDD.n237 9.11485
R2233 VDD.n1225 VDD.n278 9.11485
R2234 VDD.n1224 VDD.n353 0.231121
R2235 VDD.n257 VDD.n256 0.114852
R2236 VDD.n1227 VDD.n256 0.231121
R2237 VDD.n1230 VDD.n226 0.231121
R2238 VDD.n227 VDD.n226 0.114852
R2239 VDD.n1234 VDD.n279 9.11485
R2240 VDD.n1233 VDD.n352 0.231121
R2241 VDD.n1236 VDD.n839 0.231121
R2242 VDD.n1235 VDD.n236 9.11485
R2243 VDD.n258 VDD.n351 0.114852
R2244 VDD.n1239 VDD.n351 0.231121
R2245 VDD.n1242 VDD.n233 0.231121
R2246 VDD.n234 VDD.n233 0.114852
R2247 VDD.n1246 VDD.n259 9.11485
R2248 VDD.n1245 VDD.n350 0.231121
R2249 VDD.n1249 VDD.n260 9.11485
R2250 VDD.n1248 VDD.n349 0.231121
R2251 VDD.n529 VDD.n510 0.231121
R2252 VDD.n525 VDD.n510 0.231121
R2253 VDD.n525 VDD.n524 0.231121
R2254 VDD.n524 VDD.n523 0.231121
R2255 VDD.n523 VDD.n511 0.231121
R2256 VDD.n513 VDD.n511 0.231121
R2257 VDD.n513 VDD.n512 0.231121
R2258 VDD.n512 VDD.n494 0.231121
R2259 VDD.n494 VDD.n493 0.231121
R2260 VDD.n1267 VDD.n493 0.231121
R2261 VDD.n1268 VDD.n1267 0.231121
R2262 VDD.n1269 VDD.n1268 0.231121
R2263 VDD.n1269 VDD.n490 0.231121
R2264 VDD.n490 VDD.n489 0.231121
R2265 VDD.n489 VDD.n488 0.231121
R2266 VDD.n488 VDD.n487 0.231121
R2267 VDD.n487 VDD.n486 0.231121
R2268 VDD.n486 VDD.n485 0.231121
R2269 VDD.n485 VDD.n477 0.231121
R2270 VDD.n1283 VDD.n477 0.231121
R2271 VDD.n528 VDD.n527 0.231121
R2272 VDD.n252 VDD.n526 0.114852
R2273 VDD.n526 VDD.n390 0.231121
R2274 VDD.n522 VDD.n390 0.231121
R2275 VDD.n219 VDD.n521 0.114852
R2276 VDD.n521 VDD.n514 0.231121
R2277 VDD.n514 VDD.n121 0.114852
R2278 VDD.n1264 VDD.n495 0.231121
R2279 VDD.n1265 VDD.n168 0.114852
R2280 VDD.n1266 VDD.n1265 0.231121
R2281 VDD.n273 VDD.n492 0.114852
R2282 VDD.n1270 VDD.n492 0.231121
R2283 VDD.n1271 VDD.n1270 0.231121
R2284 VDD.n124 VDD.n1271 0.114852
R2285 VDD.n1273 VDD.n1272 0.231121
R2286 VDD.n317 VDD.n1273 0.114852
R2287 VDD.n1274 VDD.n484 0.231121
R2288 VDD.n484 VDD.n118 0.114852
R2289 VDD.n1281 VDD.n478 0.231121
R2290 VDD.n345 VDD.n1281 0.114852
R2291 VDD.n1282 VDD.n385 0.231121
R2292 VDD.n530 VDD 0.229322
R2293 VDD.n428 VDD.n140 1.73963
R2294 VDD.n1252 VDD.n509 0.1905
R2295 VDD.n508 VDD.n323 0.244617
R2296 VDD.n509 VDD.n508 0.16675
R2297 VDD.n1250 VDD.n389 0.161247
R2298 VDD.n476 VDD.n411 0.146155
R2299 VDD.n472 VDD.n411 0.146155
R2300 VDD.n472 VDD.n363 0.073243
R2301 VDD.n471 VDD.n470 0.146155
R2302 VDD.n470 VDD.n413 0.146155
R2303 VDD.n143 VDD.n413 0.073243
R2304 VDD.n466 VDD.n144 0.146155
R2305 VDD.n144 VDD.n134 0.073243
R2306 VDD.n465 VDD.n382 0.146155
R2307 VDD.n461 VDD.n365 0.073243
R2308 VDD.n461 VDD.n153 0.146155
R2309 VDD.n153 VDD.n152 0.073243
R2310 VDD.n460 VDD.n154 0.146155
R2311 VDD.n456 VDD.n151 0.073243
R2312 VDD.n456 VDD.n155 0.146155
R2313 VDD.n155 VDD.n150 0.073243
R2314 VDD.n455 VDD.n156 0.146155
R2315 VDD.n451 VDD.n149 0.073243
R2316 VDD.n451 VDD.n157 0.146155
R2317 VDD.n157 VDD.n148 0.073243
R2318 VDD.n450 VDD.n158 0.146155
R2319 VDD.n446 VDD.n147 0.073243
R2320 VDD.n446 VDD.n166 0.146155
R2321 VDD.n166 VDD.n445 0.146155
R2322 VDD.n384 VDD.n419 0.073243
R2323 VDD.n441 VDD.n419 0.146155
R2324 VDD.n441 VDD.n362 0.073243
R2325 VDD.n440 VDD.n439 0.146155
R2326 VDD.n439 VDD.n421 0.146155
R2327 VDD.n435 VDD.n145 0.073243
R2328 VDD.n435 VDD.n159 0.146155
R2329 VDD.n146 VDD.n434 0.073243
R2330 VDD.n434 VDD.n104 0.146155
R2331 VDD.n474 VDD.n473 0.146155
R2332 VDD.n473 VDD.n412 0.146155
R2333 VDD.n469 VDD.n412 0.146155
R2334 VDD.n469 VDD.n468 0.146155
R2335 VDD.n468 VDD.n467 0.146155
R2336 VDD.n467 VDD.n414 0.146155
R2337 VDD.n464 VDD.n414 0.146155
R2338 VDD.n464 VDD.n463 0.146155
R2339 VDD.n463 VDD.n462 0.146155
R2340 VDD.n462 VDD.n415 0.146155
R2341 VDD.n459 VDD.n415 0.146155
R2342 VDD.n459 VDD.n458 0.146155
R2343 VDD.n458 VDD.n457 0.146155
R2344 VDD.n457 VDD.n416 0.146155
R2345 VDD.n454 VDD.n416 0.146155
R2346 VDD.n454 VDD.n453 0.146155
R2347 VDD.n453 VDD.n452 0.146155
R2348 VDD.n452 VDD.n417 0.146155
R2349 VDD.n449 VDD.n417 0.146155
R2350 VDD.n449 VDD.n448 0.146155
R2351 VDD.n448 VDD.n447 0.146155
R2352 VDD.n447 VDD.n418 0.146155
R2353 VDD.n444 VDD.n418 0.146155
R2354 VDD.n444 VDD.n443 0.146155
R2355 VDD.n443 VDD.n442 0.146155
R2356 VDD.n442 VDD.n420 0.146155
R2357 VDD.n438 VDD.n420 0.146155
R2358 VDD.n438 VDD.n437 0.146155
R2359 VDD.n437 VDD.n436 0.146155
R2360 VDD.n436 VDD.n422 0.146155
R2361 VDD.n433 VDD.n422 0.146155
R2362 VDD.n433 VDD.n432 0.146155
R2363 VDD.n431 VDD.n423 0.146155
R2364 VDD.n428 VDD.n423 0.146155
R2365 VDD.n140 VDD.n426 0.427453
R2366 VDD.n426 VDD.n424 0.146155
R2367 VDD.n425 VDD.n141 0.344925
R2368 VDD.n425 VDD.n138 0.146155
R2369 VDD.n430 VDD.n429 0.146155
R2370 VDD.n364 VDD.n428 9.07324
R2371 VDD.n339 VDD.n175 0.143368
R2372 VDD.n338 VDD.n178 0.143368
R2373 VDD.n337 VDD.n180 0.143368
R2374 VDD.n594 VDD.n340 0.143368
R2375 VDD.n410 VDD.n409 0.125789
R2376 VDD.n1258 VDD.n1257 0.11631
R2377 VDD VDD.n383 4.5998
R2378 VDD.n593 VDD.n592 0.113429
R2379 VDD.n1284 VDD.n385 0.113429
R2380 VDD.n98 VDD.t58 15.0172
R2381 VDD.n1 VDD.t4 0.194414
R2382 VDD.n476 VDD.n475 0.0726677
R2383 VDD.n388 VDD.n424 5.74018
R2384 VDD.n344 VDD.n8 0.706063
R2385 VDD.n164 VDD.n163 0.409175
R2386 VDD.n142 VDD.n97 0.409175
R2387 VDD.t0 VDD.n85 0.0924002
R2388 VDD.n187 VDD.n186 0.386906
R2389 VDD.n338 VDD.n316 0.289879
R2390 VDD.n324 VDD.n188 0.403102
R2391 VDD.n265 VDD.n136 0.334452
R2392 VDD.n261 VDD.n137 0.334452
R2393 VDD.n263 VDD.n135 0.331847
R2394 VDD.n1 VDD.n312 0.026558
R2395 VDD.t68 VDD.t10 15.0482
R2396 VDD.n123 VDD.n58 1.94158
R2397 VDD.n1263 VDD.n51 1.50145
R2398 VDD.n75 VDD.n186 1.35472
R2399 VDD.n84 VDD.n82 1.33774
R2400 VDD.n28 VDD.n72 1.30042
R2401 VDD.n38 VDD.n76 1.28261
R2402 VDD.n58 VDD.n87 1.27104
R2403 VDD.n62 VDD.n99 1.2659
R2404 VDD.n73 VDD.n61 0.38839
R2405 VDD.n60 VDD.n187 1.24351
R2406 VDD.n68 VDD.n91 1.23216
R2407 VDD.n26 VDD.n69 1.18768
R2408 VDD.n20 VDD.n78 1.14953
R2409 VDD.n88 VDD.n57 1.14777
R2410 VDD.n84 VDD.n100 1.1223
R2411 VDD.n43 VDD.t10 1.11082
R2412 VDD.n57 VDD.t10 0.453029
R2413 VDD.n103 VDD.n59 0.182543
R2414 VDD.n71 VDD.n32 0.193433
R2415 VDD.n51 VDD.n92 1.08247
R2416 VDD.n16 VDD.t10 1.07903
R2417 VDD.n52 VDD.n53 1.0773
R2418 VDD.n48 VDD.n57 1.07242
R2419 VDD.n37 VDD.n76 1.06226
R2420 VDD.n175 VDD.n66 1.05448
R2421 VDD.n178 VDD.n67 1.05448
R2422 VDD.n72 VDD.n77 1.05338
R2423 VDD.n94 VDD.n86 0.277521
R2424 VDD.n14 VDD.t10 1.01712
R2425 VDD.n91 VDD.t4 0.216158
R2426 VDD.n12 VDD.n98 1.0088
R2427 VDD.n131 VDD.n64 0.995002
R2428 VDD.n19 VDD.t10 0.993274
R2429 VDD.n76 VDD.t10 0.322641
R2430 VDD.n78 VDD.n70 0.25307
R2431 VDD.n61 VDD.t4 0.273113
R2432 VDD.n69 VDD.n101 0.392263
R2433 VDD.n1285 VDD.n94 0.939208
R2434 VDD.n15 VDD.n0 0.476025
R2435 VDD.n57 VDD.n52 1.34247
R2436 VDD.n90 VDD.n50 1.30241
R2437 VDD VDD.n123 1.24554
R2438 VDD.n69 VDD.n70 1.21272
R2439 VDD.n1280 VDD 1.17318
R2440 VDD.n64 VDD.n63 1.15565
R2441 VDD.n101 VDD.t10 1.1329
R2442 VDD.n66 VDD.n65 1.12464
R2443 VDD.n71 VDD.t10 1.12053
R2444 VDD.n70 VDD.t10 1.11975
R2445 VDD.n120 VDD.n32 1.11604
R2446 VDD.t4 VDD.n65 1.11055
R2447 VDD VDD.n2 1.09628
R2448 VDD.n105 VDD.n47 1.0868
R2449 VDD.n106 VDD.n46 1.0868
R2450 VDD.n107 VDD.n44 1.0868
R2451 VDD.n108 VDD.n42 1.0868
R2452 VDD.n109 VDD.n39 1.0868
R2453 VDD.n110 VDD.n36 1.0868
R2454 VDD.n111 VDD.n33 1.0868
R2455 VDD.n112 VDD.n30 1.0868
R2456 VDD.n113 VDD.n27 1.0868
R2457 VDD.n114 VDD.n24 1.0868
R2458 VDD.n115 VDD.n21 1.0868
R2459 VDD.n116 VDD.n18 1.0868
R2460 VDD.n8 VDD.n7 1.08357
R2461 VDD.n119 VDD.n67 1.05289
R2462 VDD.n11 VDD.n10 1.00789
R2463 VDD.n6 VDD.n12 0.242387
R2464 VDD.n74 VDD.n99 1.00653
R2465 VSS.n3042 VSS.t487 119321
R2466 VSS.n2216 VSS.n2215 22369.4
R2467 VSS.n779 VSS.n778 7963.84
R2468 VSS.n2144 VSS.n2143 4670.31
R2469 VSS.n2148 VSS.n2147 3068.57
R2470 VSS.n3037 VSS.n2996 1028.14
R2471 VSS.n3021 VSS.n3001 1028.14
R2472 VSS.t225 VSS.n2192 849.322
R2473 VSS.n3010 VSS.n3009 572.005
R2474 VSS.t690 VSS.t58 571.348
R2475 VSS.n3027 VSS.t160 566.691
R2476 VSS.n3026 VSS.t441 560.899
R2477 VSS.n3013 VSS.t4 550.193
R2478 VSS.n2194 VSS.t319 539.653
R2479 VSS.t325 VSS.n3024 532.819
R2480 VSS.t640 VSS.n2186 522.509
R2481 VSS.n3040 VSS.t291 521.236
R2482 VSS.t278 VSS.n3023 514.091
R2483 VSS.n3033 VSS.t463 504.839
R2484 VSS.n3017 VSS.t714 504.839
R2485 VSS.t641 VSS.n2188 491.87
R2486 VSS.n3028 VSS.t631 474.904
R2487 VSS.n2193 VSS.t245 470.019
R2488 VSS.n289 VSS.n281 469.784
R2489 VSS.n328 VSS.n320 469.784
R2490 VSS.n367 VSS.n359 469.784
R2491 VSS.n451 VSS.n443 469.784
R2492 VSS.n490 VSS.n482 469.784
R2493 VSS.n532 VSS.n521 469.784
R2494 VSS.n3029 VSS.t367 456.175
R2495 VSS.n2122 VSS.n2121 454.012
R2496 VSS.n1988 VSS.n296 454.012
R2497 VSS.n1941 VSS.n335 454.012
R2498 VSS.n1855 VSS.n395 454.012
R2499 VSS.n1808 VSS.n458 454.012
R2500 VSS.n1761 VSS.n497 454.012
R2501 VSS.n2133 VSS.t8 453.986
R2502 VSS.n2025 VSS.n2024 453.986
R2503 VSS.n1977 VSS.n1976 453.986
R2504 VSS.n1930 VSS.n1929 453.986
R2505 VSS.n1844 VSS.n1843 453.986
R2506 VSS.n1797 VSS.n1796 453.986
R2507 VSS.n1750 VSS.n1749 453.986
R2508 VSS.n2025 VSS.n222 453.986
R2509 VSS.n1976 VSS.n310 453.986
R2510 VSS.n1929 VSS.n349 453.986
R2511 VSS.n1843 VSS.n433 453.986
R2512 VSS.n1796 VSS.n472 453.986
R2513 VSS.n1749 VSS.n511 453.986
R2514 VSS.n403 VSS.t439 448.228
R2515 VSS.t270 VSS.n2129 442.469
R2516 VSS.n380 VSS.t333 431.863
R2517 VSS.n3039 VSS.t266 427.695
R2518 VSS.n3023 VSS.t673 427.219
R2519 VSS.t267 VSS.n383 419.464
R2520 VSS.n2013 VSS.t73 413.678
R2521 VSS.n1966 VSS.t88 413.678
R2522 VSS.n1919 VSS.t103 413.678
R2523 VSS.n1833 VSS.t118 413.678
R2524 VSS.n1786 VSS.t133 413.678
R2525 VSS.t148 VSS.n531 413.678
R2526 VSS.n3031 VSS.n3030 412.791
R2527 VSS.n3015 VSS.n3014 412.791
R2528 VSS.n3462 VSS.n84 413.113
R2529 VSS.n3030 VSS.n3000 404.192
R2530 VSS.n3014 VSS.n3005 404.192
R2531 VSS.n2128 VSS.t9 403.072
R2532 VSS.n2188 VSS.t54 401.591
R2533 VSS.t438 VSS.n380 397.313
R2534 VSS.t430 VSS.n2134 391.555
R2535 VSS.t225 VSS.n2190 388.781
R2536 VSS.n2024 VSS.t68 385.798
R2537 VSS.n1977 VSS.t83 385.798
R2538 VSS.n1930 VSS.t98 385.798
R2539 VSS.n1844 VSS.t113 385.798
R2540 VSS.n1797 VSS.t128 385.798
R2541 VSS.n1750 VSS.t143 385.798
R2542 VSS.n2141 VSS.t337 384.889
R2543 VSS.n2138 VSS.t484 380.038
R2544 VSS.n3041 VSS.t334 375.276
R2545 VSS.t425 VSS.n3031 372.094
R2546 VSS.t427 VSS.n3015 372.094
R2547 VSS.t162 VSS.n3036 363.339
R2548 VSS.t365 VSS.n3020 363.339
R2549 VSS.t408 VSS.t224 359.769
R2550 VSS.t671 VSS.n2139 357.007
R2551 VSS.n3011 VSS.t632 347.49
R2552 VSS.n2136 VSS.t672 333.974
R2553 VSS.n2013 VSS.t76 333.065
R2554 VSS.n1966 VSS.t91 333.065
R2555 VSS.n1919 VSS.t106 333.065
R2556 VSS.n1833 VSS.t121 333.065
R2557 VSS.n1786 VSS.t136 333.065
R2558 VSS.n531 VSS.t151 333.065
R2559 VSS.t6 VSS.n2141 333.063
R2560 VSS.n3012 VSS.t2 329.238
R2561 VSS.n3763 VSS.t690 327.81
R2562 VSS.t45 VSS.n2126 322.457
R2563 VSS.t168 VSS.n387 322.457
R2564 VSS.n3737 VSS.t487 314.327
R2565 VSS.n2197 VSS.t639 313.659
R2566 VSS.n222 VSS.t66 305.183
R2567 VSS.n310 VSS.t81 305.183
R2568 VSS.n349 VSS.t96 305.183
R2569 VSS.n433 VSS.t111 305.183
R2570 VSS.n472 VSS.t126 305.183
R2571 VSS.n511 VSS.t141 305.183
R2572 VSS.t156 VSS.t322 304.42
R2573 VSS.t462 VSS.n3034 304.42
R2574 VSS.t403 VSS.t709 304.42
R2575 VSS.t713 VSS.n3018 304.42
R2576 VSS.t318 VSS.n2186 299.733
R2577 VSS.n2131 VSS.t268 299.425
R2578 VSS.n2121 VSS.t63 293.666
R2579 VSS.n1988 VSS.t78 293.666
R2580 VSS.n1941 VSS.t93 293.666
R2581 VSS.n1855 VSS.t108 293.666
R2582 VSS.n1808 VSS.t123 293.666
R2583 VSS.n1761 VSS.t138 293.666
R2584 VSS.t153 VSS.n2123 292.757
R2585 VSS.n2012 VSS.t48 292.757
R2586 VSS.n1965 VSS.t188 292.757
R2587 VSS.n1918 VSS.t177 292.757
R2588 VSS.t524 VSS.n400 292.757
R2589 VSS.n1832 VSS.t51 292.757
R2590 VSS.n1785 VSS.t636 292.757
R2591 VSS.n535 VSS.t376 292.757
R2592 VSS.t467 VSS.n3033 291.37
R2593 VSS.t0 VSS.n3017 291.37
R2594 VSS.t338 VSS.n2131 287.909
R2595 VSS.n2125 VSS.t423 275.507
R2596 VSS.n2129 VSS.t23 269.726
R2597 VSS.n2126 VSS.t46 264.875
R2598 VSS.t170 VSS.n387 264.875
R2599 VSS.t154 VSS.n2122 258.231
R2600 VSS.t49 VSS.n296 258.231
R2601 VSS.t189 VSS.n335 258.231
R2602 VSS.t178 VSS.n374 258.231
R2603 VSS.t525 VSS.n395 258.231
R2604 VSS.t52 VSS.n458 258.231
R2605 VSS.t637 VSS.n497 258.231
R2606 VSS.n779 VSS.t377 258.231
R2607 VSS.t432 VSS.n2133 258.207
R2608 VSS.t22 VSS.n2136 253.359
R2609 VSS.t429 VSS.n552 252.375
R2610 VSS.t336 VSS.n572 252.375
R2611 VSS.t665 VSS.n586 252.375
R2612 VSS.t251 VSS.n600 252.375
R2613 VSS.t413 VSS.n642 252.375
R2614 VSS.t481 VSS.n656 252.375
R2615 VSS.t414 VSS.n670 252.375
R2616 VSS.t689 VSS.n684 252.375
R2617 VSS.t633 VSS.n712 252.375
R2618 VSS.t327 VSS.n726 252.375
R2619 VSS.t24 VSS.n740 252.375
R2620 VSS.t461 VSS.n754 252.375
R2621 VSS.t419 VSS.n768 252.375
R2622 VSS.t382 VSS.n558 252.374
R2623 VSS.t684 VSS.n614 252.374
R2624 VSS.t383 VSS.n628 252.374
R2625 VSS.t348 VSS.n698 252.374
R2626 VSS.t184 VSS.n566 252.117
R2627 VSS.t386 VSS.n580 252.117
R2628 VSS.t416 VSS.n594 252.117
R2629 VSS.t340 VSS.n608 252.117
R2630 VSS.t335 VSS.n622 252.117
R2631 VSS.t434 VSS.n636 252.117
R2632 VSS.t339 VSS.n650 252.117
R2633 VSS.t701 VSS.n664 252.117
R2634 VSS.t369 VSS.n692 252.117
R2635 VSS.t309 VSS.n706 252.117
R2636 VSS.t527 VSS.n720 252.117
R2637 VSS.t655 VSS.n748 252.117
R2638 VSS.t310 VSS.n678 252.115
R2639 VSS.t299 VSS.n734 252.115
R2640 VSS.t654 VSS.n762 252.115
R2641 VSS.n555 VSS.t566 250.837
R2642 VSS.n561 VSS.t562 250.837
R2643 VSS.n569 VSS.t548 250.837
R2644 VSS.n575 VSS.t546 250.837
R2645 VSS.n583 VSS.t607 250.837
R2646 VSS.n589 VSS.t603 250.837
R2647 VSS.n597 VSS.t556 250.837
R2648 VSS.n603 VSS.t550 250.837
R2649 VSS.n611 VSS.t611 250.837
R2650 VSS.n617 VSS.t542 250.837
R2651 VSS.n625 VSS.t609 250.837
R2652 VSS.n631 VSS.t532 250.837
R2653 VSS.n639 VSS.t552 250.837
R2654 VSS.n645 VSS.t613 250.837
R2655 VSS.n653 VSS.t605 250.837
R2656 VSS.n659 VSS.t534 250.837
R2657 VSS.n667 VSS.t538 250.837
R2658 VSS.n673 VSS.t615 250.837
R2659 VSS.n681 VSS.t558 250.837
R2660 VSS.n687 VSS.t617 250.837
R2661 VSS.n695 VSS.t623 250.837
R2662 VSS.n701 VSS.t544 250.837
R2663 VSS.n709 VSS.t621 250.837
R2664 VSS.n715 VSS.t619 250.837
R2665 VSS.n723 VSS.t536 250.837
R2666 VSS.n729 VSS.t625 250.837
R2667 VSS.n737 VSS.t564 250.837
R2668 VSS.n743 VSS.t540 250.837
R2669 VSS.n751 VSS.t560 250.837
R2670 VSS.n757 VSS.t627 250.837
R2671 VSS.n765 VSS.t554 250.837
R2672 VSS.n771 VSS.t629 250.837
R2673 VSS.n3038 VSS.n3037 249.036
R2674 VSS.n3022 VSS.n3021 249.036
R2675 VSS.t2 VSS.n3011 243.244
R2676 VSS.t71 VSS.n279 240.957
R2677 VSS.t86 VSS.n318 240.957
R2678 VSS.t101 VSS.n357 240.957
R2679 VSS.t116 VSS.n441 240.957
R2680 VSS.t131 VSS.n480 240.957
R2681 VSS.t146 VSS.n519 240.957
R2682 VSS.t20 VSS.n2142 240.954
R2683 VSS.t521 VSS.n564 234.114
R2684 VSS.t25 VSS.n578 234.114
R2685 VSS.t648 VSS.n592 234.114
R2686 VSS.t293 VSS.n606 234.114
R2687 VSS.t396 VSS.n620 234.114
R2688 VSS.t344 VSS.n634 234.114
R2689 VSS.t651 VSS.n648 234.114
R2690 VSS.t205 VSS.n662 234.114
R2691 VSS.t16 VSS.n676 234.114
R2692 VSS.t345 VSS.n690 234.114
R2693 VSS.t241 VSS.n704 234.114
R2694 VSS.t661 VSS.n718 234.114
R2695 VSS.t449 VSS.n732 234.114
R2696 VSS.t285 VSS.n746 234.114
R2697 VSS.t458 VSS.n760 234.114
R2698 VSS.t175 VSS.n774 234.114
R2699 VSS.n2139 VSS.t482 230.327
R2700 VSS.n281 VSS.t71 229.439
R2701 VSS.n320 VSS.t86 229.439
R2702 VSS.n359 VSS.t101 229.439
R2703 VSS.n443 VSS.t116 229.439
R2704 VSS.n482 VSS.t131 229.439
R2705 VSS.n521 VSS.t146 229.439
R2706 VSS.n2143 VSS.t20 228.827
R2707 VSS.t32 VSS.n553 225.361
R2708 VSS.t522 VSS.n567 225.361
R2709 VSS.t295 VSS.n609 225.361
R2710 VSS.t342 VSS.n637 225.361
R2711 VSS.t203 VSS.n665 225.361
R2712 VSS.t346 VSS.n693 225.361
R2713 VSS.t659 VSS.n721 225.361
R2714 VSS.t447 VSS.n735 225.361
R2715 VSS.t283 VSS.n749 225.361
R2716 VSS.t459 VSS.n763 225.361
R2717 VSS.t27 VSS.n581 225.359
R2718 VSS.t646 VSS.n595 225.359
R2719 VSS.t394 VSS.n623 225.359
R2720 VSS.t649 VSS.n651 225.359
R2721 VSS.t18 VSS.n679 225.359
R2722 VSS.t243 VSS.n707 225.359
R2723 VSS.t632 VSS.n3010 224.516
R2724 VSS.n11 VSS.t214 215.731
R2725 VSS.n3737 VSS.t214 215.731
R2726 VSS.n2123 VSS.t154 212.143
R2727 VSS.n2012 VSS.t49 212.143
R2728 VSS.n1965 VSS.t189 212.143
R2729 VSS.n1918 VSS.t178 212.143
R2730 VSS.n400 VSS.t525 212.143
R2731 VSS.n1832 VSS.t52 212.143
R2732 VSS.n1785 VSS.t637 212.143
R2733 VSS.t377 VSS.n535 212.143
R2734 VSS.n570 VSS.t236 211.982
R2735 VSS.n612 VSS.t718 211.982
R2736 VSS.n682 VSS.t370 211.982
R2737 VSS.n724 VSS.t656 211.982
R2738 VSS.n556 VSS.t721 211.982
R2739 VSS.n584 VSS.t185 211.982
R2740 VSS.n598 VSS.t373 211.982
R2741 VSS.n626 VSS.t210 211.982
R2742 VSS.n640 VSS.t662 211.982
R2743 VSS.n654 VSS.t452 211.982
R2744 VSS.n668 VSS.t710 211.982
R2745 VSS.n696 VSS.t715 211.982
R2746 VSS.n710 VSS.t207 211.982
R2747 VSS.n738 VSS.t455 211.982
R2748 VSS.n752 VSS.t248 211.982
R2749 VSS.n766 VSS.t314 211.982
R2750 VSS.t54 VSS.n2187 208.828
R2751 VSS.t482 VSS.n2138 207.294
R2752 VSS.n2197 VSS.t318 202.362
R2753 VSS.n3032 VSS.t425 202.071
R2754 VSS.n3016 VSS.t427 202.071
R2755 VSS.n2137 VSS.t22 200.649
R2756 VSS.n1 VSS.n2216 197.518
R2757 VSS.t334 VSS.n3040 196.911
R2758 VSS.n3034 VSS.t467 196.399
R2759 VSS.n3018 VSS.t0 196.399
R2760 VSS.n2134 VSS.t432 195.778
R2761 VSS.t312 VSS.n559 195.26
R2762 VSS.t669 VSS.n573 195.26
R2763 VSS.t362 VSS.n601 195.26
R2764 VSS.t300 VSS.n615 195.26
R2765 VSS.t61 VSS.n629 195.26
R2766 VSS.t470 VSS.n671 195.26
R2767 VSS.t686 VSS.n699 195.26
R2768 VSS.t666 VSS.n769 195.26
R2769 VSS.t216 VSS.n587 195.26
R2770 VSS.t182 VSS.n643 195.26
R2771 VSS.t417 VSS.n657 195.26
R2772 VSS.t229 VSS.n685 195.26
R2773 VSS.t390 VSS.n713 195.26
R2774 VSS.t287 VSS.n727 195.26
R2775 VSS.t30 VSS.n741 195.26
R2776 VSS.t357 VSS.n755 195.26
R2777 VSS.t423 VSS.n2124 194.891
R2778 VSS.n3444 VSS.t225 194.514
R2779 VSS.n401 VSS.t170 189.132
R2780 VSS.t46 VSS.n2125 189.132
R2781 VSS.t639 VSS.n2185 187.895
R2782 VSS.n562 VSS.t410 187.292
R2783 VSS.n576 VSS.t297 187.292
R2784 VSS.n590 VSS.t415 187.292
R2785 VSS.n604 VSS.t349 187.292
R2786 VSS.n618 VSS.t680 187.292
R2787 VSS.n632 VSS.t398 187.292
R2788 VSS.n646 VSS.t682 187.292
R2789 VSS.n660 VSS.t239 187.292
R2790 VSS.n674 VSS.t420 187.292
R2791 VSS.n688 VSS.t422 187.292
R2792 VSS.n702 VSS.t706 187.292
R2793 VSS.n716 VSS.t645 187.292
R2794 VSS.n730 VSS.t246 187.292
R2795 VSS.n744 VSS.t303 187.292
R2796 VSS.n758 VSS.t411 187.292
R2797 VSS.n772 VSS.t11 187.292
R2798 VSS.t23 VSS.n2128 184.262
R2799 VSS.t158 VSS.n3029 183.975
R2800 VSS.n3035 VSS.t462 182.797
R2801 VSS.n3019 VSS.t713 182.797
R2802 VSS.n7 VSS.t681 177.713
R2803 VSS.n2124 VSS.t153 177.633
R2804 VSS.n401 VSS.t524 177.624
R2805 VSS.t48 VSS.n290 177.62
R2806 VSS.t188 VSS.n329 177.62
R2807 VSS.t177 VSS.n368 177.62
R2808 VSS.t51 VSS.n452 177.62
R2809 VSS.t636 VSS.n491 177.62
R2810 VSS.t376 VSS.n530 177.619
R2811 VSS.t643 VSS.n565 173.913
R2812 VSS.t472 VSS.n579 173.913
R2813 VSS.t192 VSS.n593 173.913
R2814 VSS.t704 VSS.n607 173.913
R2815 VSS.t195 VSS.n621 173.913
R2816 VSS.t675 VSS.n635 173.913
R2817 VSS.t380 VSS.n649 173.913
R2818 VSS.t273 VSS.n663 173.913
R2819 VSS.t305 VSS.n677 173.913
R2820 VSS.t329 VSS.n691 173.913
R2821 VSS.t198 VSS.n705 173.913
R2822 VSS.t678 VSS.n719 173.913
R2823 VSS.t352 VSS.n733 173.913
R2824 VSS.t276 VSS.n747 173.913
R2825 VSS.t234 VSS.n761 173.913
R2826 VSS.t475 VSS.n775 173.913
R2827 VSS.t1 VSS.n3013 167.954
R2828 VSS.n2132 VSS.t338 165.488
R2829 VSS.t311 VSS.t722 163.881
R2830 VSS.t670 VSS.t237 163.881
R2831 VSS.t218 VSS.t186 163.881
R2832 VSS.t361 VSS.t374 163.881
R2833 VSS.t302 VSS.t719 163.881
R2834 VSS.t59 VSS.t211 163.881
R2835 VSS.t180 VSS.t663 163.881
R2836 VSS.t418 VSS.t453 163.881
R2837 VSS.t469 VSS.t711 163.881
R2838 VSS.t231 VSS.t371 163.881
R2839 VSS.t685 VSS.t716 163.881
R2840 VSS.t389 VSS.t208 163.881
R2841 VSS.t288 VSS.t657 163.881
R2842 VSS.t29 VSS.t456 163.881
R2843 VSS.t359 VSS.t249 163.881
R2844 VSS.t667 VSS.t315 163.881
R2845 VSS.n219 VSS.t63 160.34
R2846 VSS.t78 VSS.n309 160.34
R2847 VSS.t93 VSS.n348 160.34
R2848 VSS.t108 VSS.n432 160.34
R2849 VSS.t123 VSS.n471 160.34
R2850 VSS.t138 VSS.n510 160.34
R2851 VSS.t445 VSS.n544 157.601
R2852 VSS.t480 VSS.n548 156.464
R2853 VSS.t41 VSS.n556 155.126
R2854 VSS.t409 VSS.n584 155.126
R2855 VSS.t39 VSS.n598 155.126
R2856 VSS.t213 VSS.n626 155.126
R2857 VSS.t668 VSS.n640 155.126
R2858 VSS.t307 VSS.n654 155.126
R2859 VSS.t384 VSS.n668 155.126
R2860 VSS.t56 VSS.n696 155.126
R2861 VSS.t43 VSS.n710 155.126
R2862 VSS.t14 VSS.n738 155.126
R2863 VSS.t320 VSS.n752 155.126
R2864 VSS.t634 VSS.n766 155.126
R2865 VSS.t252 VSS.n570 155.125
R2866 VSS.t222 VSS.n612 155.125
R2867 VSS.t290 VSS.n682 155.125
R2868 VSS.t356 VSS.n724 155.125
R2869 VSS.n2229 VSS.t498 154.613
R2870 VSS.n2240 VSS.t505 154.613
R2871 VSS.t268 VSS.n2130 153.971
R2872 VSS.n548 VSS.t436 153.851
R2873 VSS.t166 VSS.n551 153.846
R2874 VSS.t642 VSS.n562 153.846
R2875 VSS.t471 VSS.n576 153.846
R2876 VSS.t191 VSS.n590 153.846
R2877 VSS.t703 VSS.n604 153.846
R2878 VSS.t194 VSS.n618 153.846
R2879 VSS.t674 VSS.n632 153.846
R2880 VSS.t379 VSS.n646 153.846
R2881 VSS.t272 VSS.n660 153.846
R2882 VSS.t304 VSS.n674 153.846
R2883 VSS.t328 VSS.n688 153.846
R2884 VSS.t197 VSS.n702 153.846
R2885 VSS.t677 VSS.n716 153.846
R2886 VSS.t351 VSS.n730 153.846
R2887 VSS.t275 VSS.n744 153.846
R2888 VSS.t233 VSS.n758 153.846
R2889 VSS.t474 VSS.n772 153.846
R2890 VSS.t446 VSS.n549 153.236
R2891 VSS.t66 VSS.n219 148.827
R2892 VSS.t81 VSS.n309 148.827
R2893 VSS.t96 VSS.n348 148.827
R2894 VSS.t111 VSS.n432 148.827
R2895 VSS.t126 VSS.n471 148.827
R2896 VSS.t141 VSS.n510 148.827
R2897 VSS.t326 VSS.n3 147.453
R2898 VSS.t363 VSS.n563 147.157
R2899 VSS.t653 VSS.n577 147.157
R2900 VSS.t392 VSS.n591 147.157
R2901 VSS.t341 VSS.n605 147.157
R2902 VSS.t708 VSS.n619 147.157
R2903 VSS.t220 VSS.n633 147.157
R2904 VSS.t688 VSS.n647 147.157
R2905 VSS.t354 VSS.n661 147.157
R2906 VSS.t38 VSS.n675 147.157
R2907 VSS.t323 VSS.n689 147.157
R2908 VSS.t468 VSS.n703 147.157
R2909 VSS.t450 VSS.n717 147.157
R2910 VSS.t281 VSS.n731 147.157
R2911 VSS.t400 VSS.n745 147.157
R2912 VSS.t387 VSS.n759 147.157
R2913 VSS.t707 VSS.n773 147.157
R2914 VSS.t520 VSS.n777 145.093
R2915 VSS.t266 VSS.n3038 144.788
R2916 VSS.t673 VSS.n3022 144.788
R2917 VSS.t322 VSS.n3035 138.607
R2918 VSS.t709 VSS.n3019 138.607
R2919 VSS.n777 VSS.t516 138.404
R2920 VSS.n2142 VSS.t6 137.31
R2921 VSS.t151 VSS.n530 137.31
R2922 VSS.t76 VSS.n290 137.309
R2923 VSS.t91 VSS.n329 137.309
R2924 VSS.t106 VSS.n368 137.309
R2925 VSS.t121 VSS.n452 137.309
R2926 VSS.t136 VSS.n491 137.309
R2927 VSS.n3009 VSS.n2248 132.891
R2928 VSS.t516 VSS.n776 131.972
R2929 VSS.n2127 VSS.t45 130.939
R2930 VSS.n402 VSS.t168 130.939
R2931 VSS.n543 VSS.t34 127.421
R2932 VSS.t568 VSS.n4 125.359
R2933 VSS.t465 VSS.n539 123.674
R2934 VSS.n778 VSS.t520 122.516
R2935 VSS.n2216 VSS.n2185 122.129
R2936 VSS.n2193 VSS.t408 121.858
R2937 VSS.n549 VSS.t480 120.691
R2938 VSS.t672 VSS.n2135 119.422
R2939 VSS.n2146 VSS.t443 118.249
R2940 VSS.n538 VSS.t201 116.177
R2941 VSS.t367 VSS.n3028 115.831
R2942 VSS.n3037 VSS.t162 112.361
R2943 VSS.n3021 VSS.t365 112.361
R2944 VSS.t399 VSS.n2179 112.174
R2945 VSS.t200 VSS.n541 108.683
R2946 VSS.n557 VSS.t41 107.023
R2947 VSS.n564 VSS.t363 107.023
R2948 VSS.n571 VSS.t252 107.023
R2949 VSS.n578 VSS.t653 107.023
R2950 VSS.n585 VSS.t409 107.023
R2951 VSS.n592 VSS.t392 107.023
R2952 VSS.n599 VSS.t39 107.023
R2953 VSS.n606 VSS.t341 107.023
R2954 VSS.n613 VSS.t222 107.023
R2955 VSS.n620 VSS.t708 107.023
R2956 VSS.n627 VSS.t213 107.023
R2957 VSS.n634 VSS.t220 107.023
R2958 VSS.n641 VSS.t668 107.023
R2959 VSS.n648 VSS.t688 107.023
R2960 VSS.n655 VSS.t307 107.023
R2961 VSS.n662 VSS.t354 107.023
R2962 VSS.n669 VSS.t384 107.023
R2963 VSS.n676 VSS.t38 107.023
R2964 VSS.n683 VSS.t290 107.023
R2965 VSS.n690 VSS.t323 107.023
R2966 VSS.n697 VSS.t56 107.023
R2967 VSS.n704 VSS.t468 107.023
R2968 VSS.n711 VSS.t43 107.023
R2969 VSS.n718 VSS.t450 107.023
R2970 VSS.n725 VSS.t356 107.023
R2971 VSS.n732 VSS.t281 107.023
R2972 VSS.n739 VSS.t14 107.023
R2973 VSS.n746 VSS.t400 107.023
R2974 VSS.n753 VSS.t320 107.023
R2975 VSS.n760 VSS.t387 107.023
R2976 VSS.n767 VSS.t634 107.023
R2977 VSS.n774 VSS.t707 107.023
R2978 VSS.n2147 VSS.t172 106.808
R2979 VSS.n3009 VSS.n3008 106.77
R2980 VSS.t245 VSS.n2189 103.54
R2981 VSS.n3461 VSS.t13 103.379
R2982 VSS.n551 VSS.t511 100.335
R2983 VSS.n563 VSS.t642 100.335
R2984 VSS.n577 VSS.t471 100.335
R2985 VSS.n591 VSS.t191 100.335
R2986 VSS.n605 VSS.t703 100.335
R2987 VSS.n619 VSS.t194 100.335
R2988 VSS.n633 VSS.t674 100.335
R2989 VSS.n647 VSS.t379 100.335
R2990 VSS.n661 VSS.t272 100.335
R2991 VSS.n675 VSS.t304 100.335
R2992 VSS.n689 VSS.t328 100.335
R2993 VSS.n703 VSS.t197 100.335
R2994 VSS.n717 VSS.t677 100.335
R2995 VSS.n731 VSS.t351 100.335
R2996 VSS.n745 VSS.t275 100.335
R2997 VSS.n759 VSS.t233 100.335
R2998 VSS.n773 VSS.t474 100.335
R2999 VSS.t501 VSS.n2229 99.7511
R3000 VSS.t507 VSS.n2240 99.7511
R3001 VSS.n2199 VSS.t331 98.4633
R3002 VSS.n4 VSS.t501 97.9283
R3003 VSS.n6 VSS.t507 97.9276
R3004 VSS.t631 VSS.n3027 97.5777
R3005 VSS.t435 VSS.n546 97.4396
R3006 VSS.n2140 VSS.t671 96.3896
R3007 VSS.n544 VSS.t36 93.8889
R3008 VSS.n546 VSS.t173 93.6919
R3009 VSS.n776 VSS.t475 88.4947
R3010 VSS.n2145 VSS.t477 88.4111
R3011 VSS.n2187 VSS.t640 88.3462
R3012 VSS.n678 VSS.t305 88.2366
R3013 VSS.n734 VSS.t352 88.2366
R3014 VSS.n762 VSS.t234 88.2366
R3015 VSS.n566 VSS.t643 88.2359
R3016 VSS.n580 VSS.t472 88.2359
R3017 VSS.n594 VSS.t192 88.2359
R3018 VSS.n608 VSS.t704 88.2359
R3019 VSS.n622 VSS.t195 88.2359
R3020 VSS.n636 VSS.t675 88.2359
R3021 VSS.n650 VSS.t380 88.2359
R3022 VSS.n664 VSS.t273 88.2359
R3023 VSS.n692 VSS.t329 88.2359
R3024 VSS.n706 VSS.t198 88.2359
R3025 VSS.n720 VSS.t678 88.2359
R3026 VSS.n748 VSS.t276 88.2359
R3027 VSS.t511 VSS.t164 86.957
R3028 VSS.t513 VSS.t166 86.957
R3029 VSS.t463 VSS.n3032 85.7923
R3030 VSS.t714 VSS.n3016 85.7923
R3031 VSS.t337 VSS.n2140 84.8733
R3032 VSS.t477 VSS.n2144 83.0562
R3033 VSS.n541 VSS.t479 82.449
R3034 VSS.n2194 VSS.t641 81.2384
R3035 VSS.n5 VSS.t568 80.4704
R3036 VSS.n216 VSS.t528 77.8798
R3037 VSS.n3462 VSS.t683 77.2751
R3038 VSS.t702 VSS.t406 77.2751
R3039 VSS.t224 VSS.n2190 75.4357
R3040 VSS.t479 VSS.n540 75.2962
R3041 VSS.t464 VSS.n538 74.9537
R3042 VSS.t164 VSS.n550 74.8587
R3043 VSS.n3443 VSS.t412 74.7824
R3044 VSS.t484 VSS.n2137 73.9682
R3045 VSS.t401 VSS.n2180 73.536
R3046 VSS.n2215 VSS.n2181 73.536
R3047 VSS.t722 VSS.n557 70.2346
R3048 VSS.t237 VSS.n571 70.2346
R3049 VSS.t186 VSS.n585 70.2346
R3050 VSS.t374 VSS.n599 70.2346
R3051 VSS.t719 VSS.n613 70.2346
R3052 VSS.t211 VSS.n627 70.2346
R3053 VSS.t663 VSS.n641 70.2346
R3054 VSS.t453 VSS.n655 70.2346
R3055 VSS.t711 VSS.n669 70.2346
R3056 VSS.t371 VSS.n683 70.2346
R3057 VSS.t716 VSS.n697 70.2346
R3058 VSS.t208 VSS.n711 70.2346
R3059 VSS.t657 VSS.n725 70.2346
R3060 VSS.t456 VSS.n739 70.2346
R3061 VSS.t249 VSS.n753 70.2346
R3062 VSS.t315 VSS.n767 70.2346
R3063 VSS.t256 VSS.n187 69.1047
R3064 VSS.n279 VSS.t68 68.21
R3065 VSS.t83 VSS.n318 68.21
R3066 VSS.t98 VSS.n357 68.21
R3067 VSS.t113 VSS.n441 68.21
R3068 VSS.t128 VSS.n480 68.21
R3069 VSS.t143 VSS.n519 68.21
R3070 VSS.n539 VSS.t464 67.4583
R3071 VSS.n208 VSS.t530 66.9109
R3072 VSS.n560 VSS.t312 66.8901
R3073 VSS.t410 VSS.n561 66.8901
R3074 VSS.n574 VSS.t669 66.8901
R3075 VSS.t297 VSS.n575 66.8901
R3076 VSS.n588 VSS.t216 66.8901
R3077 VSS.t415 VSS.n589 66.8901
R3078 VSS.n602 VSS.t362 66.8901
R3079 VSS.t349 VSS.n603 66.8901
R3080 VSS.n616 VSS.t300 66.8901
R3081 VSS.t680 VSS.n617 66.8901
R3082 VSS.n630 VSS.t61 66.8901
R3083 VSS.t398 VSS.n631 66.8901
R3084 VSS.n644 VSS.t182 66.8901
R3085 VSS.t682 VSS.n645 66.8901
R3086 VSS.n658 VSS.t417 66.8901
R3087 VSS.t239 VSS.n659 66.8901
R3088 VSS.n672 VSS.t470 66.8901
R3089 VSS.t420 VSS.n673 66.8901
R3090 VSS.n686 VSS.t229 66.8901
R3091 VSS.t422 VSS.n687 66.8901
R3092 VSS.n700 VSS.t686 66.8901
R3093 VSS.t706 VSS.n701 66.8901
R3094 VSS.n714 VSS.t390 66.8901
R3095 VSS.t645 VSS.n715 66.8901
R3096 VSS.n728 VSS.t287 66.8901
R3097 VSS.t246 VSS.n729 66.8901
R3098 VSS.n742 VSS.t30 66.8901
R3099 VSS.t303 VSS.n743 66.8901
R3100 VSS.n756 VSS.t357 66.8901
R3101 VSS.t411 VSS.n757 66.8901
R3102 VSS.n770 VSS.t666 66.8901
R3103 VSS.t11 VSS.n771 66.8901
R3104 VSS.t36 VSS.n543 63.7107
R3105 VSS.t173 VSS.n545 62.4441
R3106 VSS.n2135 VSS.t430 61.8407
R3107 VSS.n2593 VSS.n2591 61.012
R3108 VSS.n2392 VSS.n2391 61.012
R3109 VSS.n2404 VSS.n2403 61.012
R3110 VSS.n2423 VSS.n2422 61.012
R3111 VSS.n2558 VSS.n2556 61.012
R3112 VSS.n2428 VSS.n2427 61.012
R3113 VSS.n2541 VSS.n2539 61.012
R3114 VSS.n2439 VSS.n2438 61.012
R3115 VSS.n2531 VSS.n2529 61.012
R3116 VSS.n2519 VSS.n2517 61.012
R3117 VSS.n2447 VSS.n2446 61.012
R3118 VSS.n2510 VSS.n2508 61.012
R3119 VSS.n2453 VSS.n2452 61.012
R3120 VSS.n2494 VSS.n2492 61.012
R3121 VSS.n2462 VSS.n2461 61.012
R3122 VSS.n2470 VSS.n2468 61.012
R3123 VSS.n2215 VSS.n2183 59.3547
R3124 VSS.n547 VSS.t435 58.6964
R3125 VSS.n2163 VSS.t261 58.1358
R3126 VSS.n2248 VSS.t412 58.1084
R3127 VSS.n6 VSS.t326 58.0274
R3128 VSS.n3024 VSS.t278 57.9156
R3129 VSS.n2609 VSS.t570 57.8009
R3130 VSS.t581 VSS.n2441 57.8009
R3131 VSS.n403 VSS.t438 56.6724
R3132 VSS.t73 VSS.n289 56.0825
R3133 VSS.t88 VSS.n328 56.0825
R3134 VSS.t103 VSS.n367 56.0825
R3135 VSS.t118 VSS.n451 56.0825
R3136 VSS.t133 VSS.n490 56.0825
R3137 VSS.n532 VSS.t148 56.0825
R3138 VSS.n200 VSS.t258 55.942
R3139 VSS.t443 VSS.n2145 54.6841
R3140 VSS.n2480 VSS.t585 54.5897
R3141 VSS.n3781 VSS.t487 53.7482
R3142 VSS.t227 VSS.n3443 52.3478
R3143 VSS.t291 VSS.n3039 51.2456
R3144 VSS.t9 VSS.n2127 50.3244
R3145 VSS.n402 VSS.t267 50.3244
R3146 VSS.t721 VSS.n555 50.1677
R3147 VSS.t236 VSS.n569 50.1677
R3148 VSS.t185 VSS.n583 50.1677
R3149 VSS.t373 VSS.n597 50.1677
R3150 VSS.t718 VSS.n611 50.1677
R3151 VSS.t210 VSS.n625 50.1677
R3152 VSS.t662 VSS.n639 50.1677
R3153 VSS.t452 VSS.n653 50.1677
R3154 VSS.t710 VSS.n667 50.1677
R3155 VSS.t370 VSS.n681 50.1677
R3156 VSS.t715 VSS.n695 50.1677
R3157 VSS.t207 VSS.n709 50.1677
R3158 VSS.t656 VSS.n723 50.1677
R3159 VSS.t455 VSS.n737 50.1677
R3160 VSS.t248 VSS.n751 50.1677
R3161 VSS.t314 VSS.n765 50.1677
R3162 VSS.t490 VSS.n184 49.3606
R3163 VSS.t575 VSS.n2581 48.1675
R3164 VSS.n2569 VSS.t577 48.1675
R3165 VSS.n542 VSS.t200 47.4535
R3166 VSS.t529 VSS.n212 47.1669
R3167 VSS.n3473 VSS.t531 47.1669
R3168 VSS.n2199 VSS.t401 46.116
R3169 VSS.n193 VSS.t254 44.9731
R3170 VSS.n3036 VSS.t156 44.1903
R3171 VSS.n3020 VSS.t403 44.1903
R3172 VSS.t505 VSS.n5 43.0642
R3173 VSS.t498 VSS.n1 43.0619
R3174 VSS.t683 VSS.n2179 42.3769
R3175 VSS.t201 VSS.n537 39.9582
R3176 VSS.n3025 VSS.t325 39.1873
R3177 VSS.t573 VSS.n2386 38.5341
R3178 VSS.n2547 VSS.t579 38.5341
R3179 VSS.t254 VSS.n191 38.3917
R3180 VSS.n554 VSS.t32 36.7898
R3181 VSS.n568 VSS.t522 36.7898
R3182 VSS.n582 VSS.t27 36.7898
R3183 VSS.n596 VSS.t646 36.7898
R3184 VSS.n610 VSS.t295 36.7898
R3185 VSS.n624 VSS.t394 36.7898
R3186 VSS.n638 VSS.t342 36.7898
R3187 VSS.n652 VSS.t649 36.7898
R3188 VSS.n666 VSS.t203 36.7898
R3189 VSS.n680 VSS.t18 36.7898
R3190 VSS.n694 VSS.t346 36.7898
R3191 VSS.n708 VSS.t243 36.7898
R3192 VSS.n722 VSS.t659 36.7898
R3193 VSS.n736 VSS.t447 36.7898
R3194 VSS.n750 VSS.t283 36.7898
R3195 VSS.n764 VSS.t459 36.7898
R3196 VSS.t487 VSS.n2148 36.5298
R3197 VSS.n537 VSS.t172 36.2105
R3198 VSS.n2150 VSS.t529 36.1979
R3199 VSS.t531 VSS.n204 36.1979
R3200 VSS.n540 VSS.t465 34.07
R3201 VSS.n3467 VSS.t490 34.0042
R3202 VSS.t319 VSS.n2189 33.9057
R3203 VSS.n2500 VSS.t583 32.1118
R3204 VSS.t13 VSS.n2180 31.1596
R3205 VSS.t583 VSS.n2451 28.9007
R3206 VSS.t34 VSS.n542 28.7152
R3207 VSS.n2147 VSS.n2146 28.3058
R3208 VSS.n558 VSS.t311 28.2943
R3209 VSS.n614 VSS.t302 28.2943
R3210 VSS.n628 VSS.t59 28.2943
R3211 VSS.n698 VSS.t685 28.2943
R3212 VSS.n572 VSS.t670 28.2941
R3213 VSS.n586 VSS.t218 28.2941
R3214 VSS.n600 VSS.t361 28.2941
R3215 VSS.n642 VSS.t180 28.2941
R3216 VSS.n656 VSS.t418 28.2941
R3217 VSS.n670 VSS.t469 28.2941
R3218 VSS.n684 VSS.t231 28.2941
R3219 VSS.n712 VSS.t389 28.2941
R3220 VSS.n726 VSS.t288 28.2941
R3221 VSS.n740 VSS.t29 28.2941
R3222 VSS.n754 VSS.t359 28.2941
R3223 VSS.n768 VSS.t667 28.2941
R3224 VSS.n550 VSS.t446 28.0352
R3225 VSS.t681 VSS.n3 27.7516
R3226 VSS.t441 VSS.n3025 27.6043
R3227 VSS.t258 VSS.n199 27.4228
R3228 VSS.n2130 VSS.t270 27.2918
R3229 VSS.t261 VSS.n196 25.229
R3230 VSS.t406 VSS.n2183 24.4565
R3231 VSS.n2598 VSS.t573 22.4784
R3232 VSS.t579 VSS.n2430 22.4784
R3233 VSS.n3461 VSS.t399 22.3643
R3234 VSS.t160 VSS.n3026 22.2881
R3235 VSS.t4 VSS.n3012 22.2881
R3236 VSS.t333 VSS.n374 22.1556
R3237 VSS.t439 VSS.n383 22.1456
R3238 VSS.n2465 VSS.n2464 21.8346
R3239 VSS.n2476 VSS.n2474 21.8346
R3240 VSS.n2483 VSS.n2481 21.8346
R3241 VSS.n2486 VSS.n2484 21.8346
R3242 VSS.n2489 VSS.n2487 21.8346
R3243 VSS.n2460 VSS.n2459 21.8346
R3244 VSS.n2458 VSS.n2457 21.8346
R3245 VSS.n2456 VSS.n2455 21.8346
R3246 VSS.n2505 VSS.n2503 21.8346
R3247 VSS.n2450 VSS.n2449 21.8346
R3248 VSS.n2445 VSS.n2444 21.8346
R3249 VSS.n2443 VSS.n2442 21.8346
R3250 VSS.n2526 VSS.n2524 21.8346
R3251 VSS.n2536 VSS.n2535 21.8346
R3252 VSS.n2436 VSS.n2435 21.8346
R3253 VSS.n2434 VSS.n2433 21.8346
R3254 VSS.n2432 VSS.n2431 21.8346
R3255 VSS.n2546 VSS.n2429 21.8346
R3256 VSS.n2553 VSS.n2551 21.8346
R3257 VSS.n2426 VSS.n2425 21.8346
R3258 VSS.n2564 VSS.n2562 21.8346
R3259 VSS.n2567 VSS.n2565 21.8346
R3260 VSS.n2421 VSS.n2420 21.8346
R3261 VSS.n2419 VSS.n2418 21.8346
R3262 VSS.n2417 VSS.n2416 21.8346
R3263 VSS.n2415 VSS.n2414 21.8346
R3264 VSS.n2413 VSS.n2412 21.8346
R3265 VSS.n2411 VSS.n2410 21.8346
R3266 VSS.n2409 VSS.n2408 21.8346
R3267 VSS.n2407 VSS.n2406 21.8346
R3268 VSS.n2402 VSS.n2401 21.8346
R3269 VSS.n2400 VSS.n2399 21.8346
R3270 VSS.n2398 VSS.n2397 21.8346
R3271 VSS.n2396 VSS.n2395 21.8346
R3272 VSS.n2390 VSS.n2389 21.8346
R3273 VSS.n2388 VSS.n2387 21.8346
R3274 VSS.n2385 VSS.n2384 21.8346
R3275 VSS.n2383 VSS.n2382 21.8346
R3276 VSS.n2381 VSS.n2380 21.8346
R3277 VSS.n2379 VSS.n2378 21.8346
R3278 VSS.n2377 VSS.n2376 21.8346
R3279 VSS.n2375 VSS.n2374 21.8346
R3280 VSS.n2373 VSS.n2372 21.8346
R3281 VSS.n2371 VSS.n2370 21.8346
R3282 VSS.n2369 VSS.n2368 21.8346
R3283 VSS.n2366 VSS.n2365 21.8346
R3284 VSS.n2364 VSS.n2363 21.8346
R3285 VSS.n2362 VSS.n2361 21.8346
R3286 VSS.n2360 VSS.n2359 21.8346
R3287 VSS.n2359 VSS.n2358 21.8346
R3288 VSS.n2361 VSS.n2360 21.8346
R3289 VSS.n2363 VSS.n2362 21.8346
R3290 VSS.n2365 VSS.n2364 21.8346
R3291 VSS.n2608 VSS.n2366 21.8346
R3292 VSS.n2370 VSS.n2369 21.8346
R3293 VSS.n2372 VSS.n2371 21.8346
R3294 VSS.n2374 VSS.n2373 21.8346
R3295 VSS.n2376 VSS.n2375 21.8346
R3296 VSS.n2378 VSS.n2377 21.8346
R3297 VSS.n2380 VSS.n2379 21.8346
R3298 VSS.n2382 VSS.n2381 21.8346
R3299 VSS.n2384 VSS.n2383 21.8346
R3300 VSS.n2597 VSS.n2385 21.8346
R3301 VSS.n2389 VSS.n2388 21.8346
R3302 VSS.n2592 VSS.n2390 21.8346
R3303 VSS.n2589 VSS.n2588 21.8346
R3304 VSS.n2395 VSS.n2393 21.8346
R3305 VSS.n2397 VSS.n2396 21.8346
R3306 VSS.n2399 VSS.n2398 21.8346
R3307 VSS.n2401 VSS.n2400 21.8346
R3308 VSS.n2406 VSS.n2405 21.8346
R3309 VSS.n2408 VSS.n2407 21.8346
R3310 VSS.n2410 VSS.n2409 21.8346
R3311 VSS.n2412 VSS.n2411 21.8346
R3312 VSS.n2414 VSS.n2413 21.8346
R3313 VSS.n2416 VSS.n2415 21.8346
R3314 VSS.n2418 VSS.n2417 21.8346
R3315 VSS.n2420 VSS.n2419 21.8346
R3316 VSS.n2565 VSS.n2564 21.8346
R3317 VSS.n2562 VSS.n2561 21.8346
R3318 VSS.n2425 VSS.n2424 21.8346
R3319 VSS.n2557 VSS.n2426 21.8346
R3320 VSS.n2554 VSS.n2553 21.8346
R3321 VSS.n2551 VSS.n2550 21.8346
R3322 VSS.n2433 VSS.n2432 21.8346
R3323 VSS.n2435 VSS.n2434 21.8346
R3324 VSS.n2540 VSS.n2436 21.8346
R3325 VSS.n2537 VSS.n2536 21.8346
R3326 VSS.n2535 VSS.n2534 21.8346
R3327 VSS.n2530 VSS.n2440 21.8346
R3328 VSS.n2527 VSS.n2526 21.8346
R3329 VSS.n2444 VSS.n2443 21.8346
R3330 VSS.n2518 VSS.n2445 21.8346
R3331 VSS.n2515 VSS.n2514 21.8346
R3332 VSS.n2449 VSS.n2448 21.8346
R3333 VSS.n2509 VSS.n2450 21.8346
R3334 VSS.n2506 VSS.n2505 21.8346
R3335 VSS.n2503 VSS.n2502 21.8346
R3336 VSS.n2455 VSS.n2454 21.8346
R3337 VSS.n2457 VSS.n2456 21.8346
R3338 VSS.n2459 VSS.n2458 21.8346
R3339 VSS.n2493 VSS.n2460 21.8346
R3340 VSS.n2490 VSS.n2489 21.8346
R3341 VSS.n2487 VSS.n2486 21.8346
R3342 VSS.n2484 VSS.n2483 21.8346
R3343 VSS.n2477 VSS.n2476 21.8346
R3344 VSS.n2474 VSS.n2473 21.8346
R3345 VSS.n2469 VSS.n2463 21.8346
R3346 VSS.n2466 VSS.n2465 21.8346
R3347 VSS.n552 VSS.t513 21.6051
R3348 VSS.t331 VSS.n2181 21.1887
R3349 VSS.n565 VSS.t521 20.0674
R3350 VSS.n579 VSS.t25 20.0674
R3351 VSS.n593 VSS.t648 20.0674
R3352 VSS.n607 VSS.t293 20.0674
R3353 VSS.n621 VSS.t396 20.0674
R3354 VSS.n635 VSS.t344 20.0674
R3355 VSS.n649 VSS.t651 20.0674
R3356 VSS.n663 VSS.t205 20.0674
R3357 VSS.n677 VSS.t16 20.0674
R3358 VSS.n691 VSS.t345 20.0674
R3359 VSS.n705 VSS.t241 20.0674
R3360 VSS.n719 VSS.t661 20.0674
R3361 VSS.n733 VSS.t449 20.0674
R3362 VSS.n747 VSS.t285 20.0674
R3363 VSS.n761 VSS.t458 20.0674
R3364 VSS.n775 VSS.t175 20.0674
R3365 VSS.t225 VSS.t227 19.9423
R3366 VSS.n2174 VSS.n82 19.1378
R3367 VSS.n3474 VSS.n71 19.1369
R3368 VSS.n2153 VSS.n73 19.1369
R3369 VSS.n2157 VSS.n74 19.1369
R3370 VSS.n3472 VSS.n75 19.1369
R3371 VSS.n3471 VSS.n76 19.1369
R3372 VSS.n2165 VSS.n78 19.1369
R3373 VSS.n2170 VSS.n80 19.1369
R3374 VSS.n2174 VSS.n81 19.1369
R3375 VSS.n70 VSS.n66 19.1369
R3376 VSS.n3475 VSS.n71 19.1369
R3377 VSS.n2151 VSS.n72 19.1369
R3378 VSS.n2151 VSS.n73 19.1369
R3379 VSS.n2155 VSS.n74 19.1369
R3380 VSS.n3472 VSS.n76 19.1369
R3381 VSS.n3470 VSS.n77 19.1369
R3382 VSS.n3469 VSS.n77 19.1369
R3383 VSS.n2165 VSS.n79 19.1369
R3384 VSS.n2167 VSS.n79 19.1369
R3385 VSS.n2168 VSS.n80 19.1369
R3386 VSS.n2172 VSS.n81 19.1369
R3387 VSS.n3466 VSS.n175 18.5857
R3388 VSS.n1738 VSS.n1737 18.4617
R3389 VSS.n581 VSS.t386 18.0025
R3390 VSS.n587 VSS.t665 18.0025
R3391 VSS.n595 VSS.t416 18.0025
R3392 VSS.n623 VSS.t335 18.0025
R3393 VSS.n643 VSS.t413 18.0025
R3394 VSS.n651 VSS.t339 18.0025
R3395 VSS.n657 VSS.t481 18.0025
R3396 VSS.n679 VSS.t310 18.0025
R3397 VSS.n685 VSS.t689 18.0025
R3398 VSS.n707 VSS.t309 18.0025
R3399 VSS.n713 VSS.t633 18.0025
R3400 VSS.n727 VSS.t327 18.0025
R3401 VSS.n741 VSS.t24 18.0025
R3402 VSS.n755 VSS.t461 18.0025
R3403 VSS.n553 VSS.t429 18.0017
R3404 VSS.n559 VSS.t382 18.0017
R3405 VSS.n567 VSS.t184 18.0017
R3406 VSS.n573 VSS.t336 18.0017
R3407 VSS.n601 VSS.t251 18.0017
R3408 VSS.n609 VSS.t340 18.0017
R3409 VSS.n615 VSS.t684 18.0017
R3410 VSS.n629 VSS.t383 18.0017
R3411 VSS.n637 VSS.t434 18.0017
R3412 VSS.n665 VSS.t701 18.0017
R3413 VSS.n671 VSS.t414 18.0017
R3414 VSS.n693 VSS.t369 18.0017
R3415 VSS.n699 VSS.t348 18.0017
R3416 VSS.n721 VSS.t527 18.0017
R3417 VSS.n735 VSS.t299 18.0017
R3418 VSS.n749 VSS.t655 18.0017
R3419 VSS.n763 VSS.t654 18.0017
R3420 VSS.n769 VSS.t419 18.0017
R3421 VSS.n3860 VSS.n3859 18.0005
R3422 VSS.n3006 VSS.n2358 17.6839
R3423 VSS.t436 VSS.n547 17.4722
R3424 VSS.n538 VSS.n217 17.0005
R3425 VSS.n539 VSS.n217 17.0005
R3426 VSS.n1467 VSS.n217 17.0005
R3427 VSS.n541 VSS.n217 17.0005
R3428 VSS.n543 VSS.n217 17.0005
R3429 VSS.t37 VSS.n217 17.0005
R3430 VSS.n546 VSS.n217 17.0005
R3431 VSS.n1453 VSS.n217 17.0005
R3432 VSS.n1442 VSS.n217 17.0005
R3433 VSS.n1437 VSS.n217 17.0005
R3434 VSS.n1449 VSS.n217 17.0005
R3435 VSS.t167 VSS.n217 17.0005
R3436 VSS.n1514 VSS.n217 17.0005
R3437 VSS.n826 VSS.n217 17.0005
R3438 VSS.n1740 VSS.n783 17.0005
R3439 VSS.t7 VSS.n218 17.0005
R3440 VSS.n2139 VSS.n218 17.0005
R3441 VSS.t483 VSS.n218 17.0005
R3442 VSS.n2138 VSS.n218 17.0005
R3443 VSS.n2136 VSS.n218 17.0005
R3444 VSS.n258 VSS.n218 17.0005
R3445 VSS.n2134 VSS.n218 17.0005
R3446 VSS.n2131 VSS.n218 17.0005
R3447 VSS.t271 VSS.n218 17.0005
R3448 VSS.n2128 VSS.n218 17.0005
R3449 VSS.n2126 VSS.n218 17.0005
R3450 VSS.n244 VSS.n218 17.0005
R3451 VSS.n228 VSS.n218 17.0005
R3452 VSS.n2121 VSS.n2120 17.0005
R3453 VSS.n2120 VSS.n222 17.0005
R3454 VSS.n2027 VSS.n2026 17.0005
R3455 VSS.n2024 VSS.n2023 17.0005
R3456 VSS.n2023 VSS.t70 17.0005
R3457 VSS.n2023 VSS.n282 17.0005
R3458 VSS.n2014 VSS.n301 17.0005
R3459 VSS.n1989 VSS.n1988 17.0005
R3460 VSS.n1989 VSS.n310 17.0005
R3461 VSS.n312 VSS.n311 17.0005
R3462 VSS.n1978 VSS.n1977 17.0005
R3463 VSS.n1978 VSS.t85 17.0005
R3464 VSS.n1978 VSS.n321 17.0005
R3465 VSS.n1967 VSS.n340 17.0005
R3466 VSS.n1942 VSS.n1941 17.0005
R3467 VSS.n1942 VSS.n349 17.0005
R3468 VSS.n351 VSS.n350 17.0005
R3469 VSS.n1931 VSS.n1930 17.0005
R3470 VSS.n1931 VSS.t100 17.0005
R3471 VSS.n1931 VSS.n360 17.0005
R3472 VSS.n1920 VSS.n405 17.0005
R3473 VSS.n1920 VSS.n380 17.0005
R3474 VSS.n1920 VSS.t440 17.0005
R3475 VSS.n1920 VSS.t169 17.0005
R3476 VSS.n1920 VSS.n387 17.0005
R3477 VSS.n1920 VSS.n399 17.0005
R3478 VSS.n1856 VSS.n1855 17.0005
R3479 VSS.n1856 VSS.n433 17.0005
R3480 VSS.n435 VSS.n434 17.0005
R3481 VSS.n1845 VSS.n1844 17.0005
R3482 VSS.n1845 VSS.t115 17.0005
R3483 VSS.n1845 VSS.n444 17.0005
R3484 VSS.n1834 VSS.n463 17.0005
R3485 VSS.n1809 VSS.n1808 17.0005
R3486 VSS.n1809 VSS.n472 17.0005
R3487 VSS.n474 VSS.n473 17.0005
R3488 VSS.n1798 VSS.n1797 17.0005
R3489 VSS.n1798 VSS.t130 17.0005
R3490 VSS.n1798 VSS.n483 17.0005
R3491 VSS.n1787 VSS.n502 17.0005
R3492 VSS.n1762 VSS.n1761 17.0005
R3493 VSS.n1762 VSS.n511 17.0005
R3494 VSS.n513 VSS.n512 17.0005
R3495 VSS.n1751 VSS.n1750 17.0005
R3496 VSS.n1751 VSS.t145 17.0005
R3497 VSS.n1751 VSS.n522 17.0005
R3498 VSS.n3822 VSS.n35 17.0005
R3499 VSS.n3813 VSS.n143 17.0005
R3500 VSS.n3782 VSS.n67 17.0005
R3501 VSS.n3744 VSS.n3499 17.0005
R3502 VSS.n3766 VSS.n59 17.0005
R3503 VSS.n3726 VSS.n3525 17.0005
R3504 VSS.n3040 VSS.t292 17.0005
R3505 VSS.n3038 VSS.t292 17.0005
R3506 VSS.n3036 VSS.t426 17.0005
R3507 VSS.n2690 VSS.t426 17.0005
R3508 VSS.n3034 VSS.t426 17.0005
R3509 VSS.n3031 VSS.t426 17.0005
R3510 VSS.t159 VSS.n2650 17.0005
R3511 VSS.n3028 VSS.n2650 17.0005
R3512 VSS.n2666 VSS.n2650 17.0005
R3513 VSS.n2662 VSS.n2650 17.0005
R3514 VSS.n2658 VSS.n2650 17.0005
R3515 VSS.n3024 VSS.n2650 17.0005
R3516 VSS.n3022 VSS.n2650 17.0005
R3517 VSS.n3020 VSS.t428 17.0005
R3518 VSS.n2645 VSS.t428 17.0005
R3519 VSS.n3018 VSS.t428 17.0005
R3520 VSS.n3015 VSS.t428 17.0005
R3521 VSS.t317 VSS.n2618 17.0005
R3522 VSS.n3013 VSS.n2618 17.0005
R3523 VSS.n3011 VSS.n2618 17.0005
R3524 VSS.n119 VSS.n2609 17.0005
R3525 VSS.n119 VSS.n2367 17.0005
R3526 VSS.n119 VSS.t571 17.0005
R3527 VSS.n119 VSS.n2598 17.0005
R3528 VSS.n119 VSS.n2386 17.0005
R3529 VSS.n119 VSS.n2593 17.0005
R3530 VSS.n119 VSS.n2391 17.0005
R3531 VSS.n119 VSS.n2394 17.0005
R3532 VSS.n119 VSS.n2582 17.0005
R3533 VSS.n119 VSS.n2403 17.0005
R3534 VSS.n119 VSS.n2569 17.0005
R3535 VSS.n119 VSS.n2422 17.0005
R3536 VSS.n119 VSS.t578 17.0005
R3537 VSS.n119 VSS.n2558 17.0005
R3538 VSS.n119 VSS.n2427 17.0005
R3539 VSS.n119 VSS.n2547 17.0005
R3540 VSS.n119 VSS.n2430 17.0005
R3541 VSS.n119 VSS.n2541 17.0005
R3542 VSS.n119 VSS.n2437 17.0005
R3543 VSS.n119 VSS.n2438 17.0005
R3544 VSS.n119 VSS.n2531 17.0005
R3545 VSS.n119 VSS.n2441 17.0005
R3546 VSS.n119 VSS.n2519 17.0005
R3547 VSS.n119 VSS.n2446 17.0005
R3548 VSS.n119 VSS.n2510 17.0005
R3549 VSS.n119 VSS.n2451 17.0005
R3550 VSS.n119 VSS.n2500 17.0005
R3551 VSS.n119 VSS.n2452 17.0005
R3552 VSS.n119 VSS.n2494 17.0005
R3553 VSS.n119 VSS.n2461 17.0005
R3554 VSS.n119 VSS.n2470 17.0005
R3555 VSS.n119 VSS.t586 17.0005
R3556 VSS.n86 VSS.n85 3.93433
R3557 VSS.n2468 VSS.n85 17.0005
R3558 VSS.n2462 VSS.n85 17.0005
R3559 VSS.n2479 VSS.n85 17.0005
R3560 VSS.n2480 VSS.n85 17.0005
R3561 VSS.n2492 VSS.n85 17.0005
R3562 VSS.n2453 VSS.n85 17.0005
R3563 VSS.n2508 VSS.n85 17.0005
R3564 VSS.n2447 VSS.n85 17.0005
R3565 VSS.n2517 VSS.n85 17.0005
R3566 VSS.n2523 VSS.n85 17.0005
R3567 VSS.n2529 VSS.n85 17.0005
R3568 VSS.n2439 VSS.n85 17.0005
R3569 VSS.n2325 VSS.n85 17.0005
R3570 VSS.n2539 VSS.n85 17.0005
R3571 VSS.n2428 VSS.n85 17.0005
R3572 VSS.n2556 VSS.n85 17.0005
R3573 VSS.t594 VSS.n85 17.0005
R3574 VSS.n2423 VSS.n85 17.0005
R3575 VSS.n2568 VSS.n85 17.0005
R3576 VSS.n2404 VSS.n85 17.0005
R3577 VSS.n2581 VSS.n85 17.0005
R3578 VSS.n2292 VSS.n85 17.0005
R3579 VSS.n2392 VSS.n85 17.0005
R3580 VSS.n2591 VSS.n85 17.0005
R3581 VSS.t588 VSS.n85 17.0005
R3582 VSS.n3140 VSS.n85 17.0005
R3583 VSS.n67 VSS.n190 17.0005
R3584 VSS.n67 VSS.n182 17.0005
R3585 VSS.n67 VSS.n165 17.0005
R3586 VSS.n67 VSS.n169 17.0005
R3587 VSS.n3781 VSS.n68 17.0005
R3588 VSS.n68 VSS.n2150 17.0005
R3589 VSS.n68 VSS.n3473 17.0005
R3590 VSS.n68 VSS.n2163 17.0005
R3591 VSS.n68 VSS.n2166 17.0005
R3592 VSS.n68 VSS.n3467 17.0005
R3593 VSS.n68 VSS.n2177 17.0005
R3594 VSS.t55 VSS.n3462 17.0005
R3595 VSS.t55 VSS.n2179 17.0005
R3596 VSS.t55 VSS.n2180 17.0005
R3597 VSS.t55 VSS.n2199 17.0005
R3598 VSS.t55 VSS.n2181 17.0005
R3599 VSS.t55 VSS.n2184 17.0005
R3600 VSS.t55 VSS.n2197 17.0005
R3601 VSS.t55 VSS.n2194 17.0005
R3602 VSS.t55 VSS.n2193 17.0005
R3603 VSS.t55 VSS.n2190 17.0005
R3604 VSS.n3443 VSS.n3442 17.0005
R3605 VSS.n3442 VSS.t228 17.0005
R3606 VSS.n8 VSS.n2 17.0005
R3607 VSS.n8 VSS.n2220 17.0005
R3608 VSS.n8 VSS.n2223 17.0005
R3609 VSS.n8 VSS.n2239 17.0005
R3610 VSS.n8 VSS.n2237 17.0005
R3611 VSS.n8 VSS.n2228 17.0005
R3612 VSS.n67 VSS.n177 17.0005
R3613 VSS.t530 VSS.n206 16.4539
R3614 VSS.n3042 VSS.n3041 16.2018
R3615 VSS.t8 VSS.n2132 15.7754
R3616 VSS.n188 VSS.t256 14.2601
R3617 VSS.n545 VSS.t445 13.7246
R3618 VSS.t58 VSS.t487 13.4836
R3619 VSS.n2177 VSS.n175 13.0197
R3620 VSS.n2582 VSS.t575 12.845
R3621 VSS.t577 VSS.n2568 12.845
R3622 VSS.n3475 VSS.n214 12.0761
R3623 VSS.n2155 VSS.n206 12.0761
R3624 VSS.n3470 VSS.n199 12.0761
R3625 VSS.n2168 VSS.n191 12.0761
R3626 VSS.n2172 VSS.n187 12.0761
R3627 VSS.n3466 VSS.n184 12.0761
R3628 VSS.n66 VSS.n216 12.0761
R3629 VSS.n3474 VSS.n212 12.0761
R3630 VSS.n2153 VSS.n208 12.0761
R3631 VSS.n2157 VSS.n204 12.0761
R3632 VSS.n3471 VSS.n200 12.0761
R3633 VSS.n3469 VSS.n196 12.0761
R3634 VSS.n2167 VSS.n193 12.0761
R3635 VSS.n2170 VSS.n188 12.0761
R3636 VSS.n2177 VSS.n84 13.5726
R3637 VSS.n86 VSS.n2464 16.1185
R3638 VSS.n2591 VSS.n2589 10.9175
R3639 VSS.n2393 VSS.n2392 10.9175
R3640 VSS.n2405 VSS.n2404 10.9175
R3641 VSS.n2424 VSS.n2423 10.9175
R3642 VSS.n2556 VSS.n2554 10.9175
R3643 VSS.n2429 VSS.n2428 10.9175
R3644 VSS.n2539 VSS.n2537 10.9175
R3645 VSS.n2440 VSS.n2439 10.9175
R3646 VSS.n2529 VSS.n2527 10.9175
R3647 VSS.n2517 VSS.n2515 10.9175
R3648 VSS.n2448 VSS.n2447 10.9175
R3649 VSS.n2508 VSS.n2506 10.9175
R3650 VSS.n2454 VSS.n2453 10.9175
R3651 VSS.n2492 VSS.n2490 10.9175
R3652 VSS.n2479 VSS.n2477 10.9175
R3653 VSS.n2463 VSS.n2462 10.9175
R3654 VSS.n2468 VSS.n2466 10.9175
R3655 VSS.n2470 VSS.n2469 10.9175
R3656 VSS.n2473 VSS.n2461 10.9175
R3657 VSS.n2494 VSS.n2493 10.9175
R3658 VSS.n2499 VSS.n2452 10.9175
R3659 VSS.n2502 VSS.n2451 10.9175
R3660 VSS.n2510 VSS.n2509 10.9175
R3661 VSS.n2514 VSS.n2446 10.9175
R3662 VSS.n2519 VSS.n2518 10.9175
R3663 VSS.n2531 VSS.n2530 10.9175
R3664 VSS.n2534 VSS.n2438 10.9175
R3665 VSS.n2541 VSS.n2540 10.9175
R3666 VSS.n2550 VSS.n2427 10.9175
R3667 VSS.n2558 VSS.n2557 10.9175
R3668 VSS.n2561 VSS.n2422 10.9175
R3669 VSS.n2580 VSS.n2403 10.9175
R3670 VSS.n2588 VSS.n2391 10.9175
R3671 VSS.n2593 VSS.n2592 10.9175
R3672 VSS.n2598 VSS.n2597 10.9175
R3673 VSS.n2609 VSS.n2608 10.9175
R3674 VSS.n2368 VSS.n2367 10.9175
R3675 VSS.n2387 VSS.n2386 10.9175
R3676 VSS.n2581 VSS.n2402 10.9175
R3677 VSS.n2582 VSS.n2580 10.9175
R3678 VSS.n2568 VSS.n2421 10.9175
R3679 VSS.n2569 VSS.n2567 10.9175
R3680 VSS.n2547 VSS.n2546 10.9175
R3681 VSS.n2431 VSS.n2430 10.9175
R3682 VSS.n2524 VSS.n2523 10.9175
R3683 VSS.n2442 VSS.n2441 10.9175
R3684 VSS.n2500 VSS.n2499 10.9175
R3685 VSS.n2481 VSS.n2480 10.9175
R3686 VSS.n3509 VSS.n3508 10.7899
R3687 VSS.n3855 VSS.n3854 10.7882
R3688 VSS.n3507 VSS.n3500 9.69236
R3689 VSS.n3858 VSS.n120 9.38994
R3690 VSS.n3856 VSS.n3855 9.38994
R3691 VSS.n3741 VSS.n3509 9.38916
R3692 VSS.n824 VSS.n823 9.11631
R3693 VSS.n3167 VSS.n3141 9.11631
R3694 VSS.n2756 VSS.n2357 9.11631
R3695 VSS.n3578 VSS.n3577 9.11631
R3696 VSS.n3582 VSS.n3579 9.11631
R3697 VSS.n1154 VSS.n1152 9.11631
R3698 VSS.n2225 VSS.t280 9.08698
R3699 VSS.n3457 VSS.n2178 9.07383
R3700 VSS.n2265 VSS.n2264 9.07383
R3701 VSS.n3044 VSS.n2995 9.07383
R3702 VSS.t280 VSS.n2224 9.0445
R3703 VSS.n1485 VSS.n1483 9.0005
R3704 VSS.n1479 VSS.n1486 9.0005
R3705 VSS.t444 VSS.n1477 9.0005
R3706 VSS.n1489 VSS.n1488 9.0005
R3707 VSS.n1491 VSS.n1490 9.0005
R3708 VSS.n1472 VSS.n1471 9.0005
R3709 VSS.n1494 VSS.n1493 9.0005
R3710 VSS.t466 VSS.n1495 9.0005
R3711 VSS.n1497 VSS.n1465 9.0005
R3712 VSS.n1498 VSS.t35 9.0005
R3713 VSS.n1500 VSS.n1499 9.0005
R3714 VSS.n1460 VSS.n1459 9.0005
R3715 VSS.n1503 VSS.n1502 9.0005
R3716 VSS.t174 VSS.n1504 9.0005
R3717 VSS.t437 VSS.n1086 9.0005
R3718 VSS.n1506 VSS.n1505 9.0005
R3719 VSS.n1452 VSS.n1083 9.0005
R3720 VSS.n1449 VSS.n1448 9.0005
R3721 VSS.n1439 VSS.n1088 9.0005
R3722 VSS.n1444 VSS.n1443 9.0005
R3723 VSS.n1435 VSS.n1090 9.0005
R3724 VSS.n1433 VSS.n1432 9.0005
R3725 VSS.n1429 VSS.n1428 9.0005
R3726 VSS.n1426 VSS.n1093 9.0005
R3727 VSS.n1424 VSS.n1423 9.0005
R3728 VSS.n1420 VSS.n1419 9.0005
R3729 VSS.n1417 VSS.n1095 9.0005
R3730 VSS.n1415 VSS.n1414 9.0005
R3731 VSS.n1411 VSS.n1410 9.0005
R3732 VSS.n1408 VSS.n1097 9.0005
R3733 VSS.n1406 VSS.n1405 9.0005
R3734 VSS.n1402 VSS.n1401 9.0005
R3735 VSS.n1399 VSS.n1099 9.0005
R3736 VSS.n1397 VSS.n1396 9.0005
R3737 VSS.n1393 VSS.n1392 9.0005
R3738 VSS.n1390 VSS.n1101 9.0005
R3739 VSS.n1388 VSS.n1387 9.0005
R3740 VSS.n1384 VSS.n1383 9.0005
R3741 VSS.n1381 VSS.n1103 9.0005
R3742 VSS.n1379 VSS.n1378 9.0005
R3743 VSS.n1375 VSS.n1374 9.0005
R3744 VSS.n1372 VSS.n1105 9.0005
R3745 VSS.n1370 VSS.n1369 9.0005
R3746 VSS.n1366 VSS.n1365 9.0005
R3747 VSS.n1363 VSS.n1107 9.0005
R3748 VSS.n1361 VSS.n1360 9.0005
R3749 VSS.n1357 VSS.n1356 9.0005
R3750 VSS.n1354 VSS.n1109 9.0005
R3751 VSS.n1352 VSS.n1351 9.0005
R3752 VSS.n1348 VSS.n1347 9.0005
R3753 VSS.n1345 VSS.n1111 9.0005
R3754 VSS.n1343 VSS.n1342 9.0005
R3755 VSS.n1339 VSS.n1338 9.0005
R3756 VSS.n1336 VSS.n1113 9.0005
R3757 VSS.n1334 VSS.n1333 9.0005
R3758 VSS.n1330 VSS.n1329 9.0005
R3759 VSS.n1327 VSS.n1115 9.0005
R3760 VSS.n1325 VSS.n1324 9.0005
R3761 VSS.n1321 VSS.n1320 9.0005
R3762 VSS.n1318 VSS.n1117 9.0005
R3763 VSS.n1316 VSS.n1315 9.0005
R3764 VSS.n1312 VSS.n1311 9.0005
R3765 VSS.n1309 VSS.n1119 9.0005
R3766 VSS.n1307 VSS.n1306 9.0005
R3767 VSS.n1303 VSS.n1302 9.0005
R3768 VSS.n1300 VSS.n1121 9.0005
R3769 VSS.n1298 VSS.n1297 9.0005
R3770 VSS.n1294 VSS.n1293 9.0005
R3771 VSS.n1291 VSS.n1123 9.0005
R3772 VSS.n1289 VSS.n1288 9.0005
R3773 VSS.n1285 VSS.n1284 9.0005
R3774 VSS.n1282 VSS.n1125 9.0005
R3775 VSS.n1280 VSS.n1279 9.0005
R3776 VSS.n1276 VSS.n1275 9.0005
R3777 VSS.n1273 VSS.n1127 9.0005
R3778 VSS.n1271 VSS.n1270 9.0005
R3779 VSS.n1267 VSS.n1266 9.0005
R3780 VSS.n1264 VSS.n1129 9.0005
R3781 VSS.n1262 VSS.n1261 9.0005
R3782 VSS.n1258 VSS.n1257 9.0005
R3783 VSS.n1255 VSS.n1131 9.0005
R3784 VSS.n1253 VSS.n1252 9.0005
R3785 VSS.n1249 VSS.n1248 9.0005
R3786 VSS.n1246 VSS.n1133 9.0005
R3787 VSS.n1244 VSS.n1243 9.0005
R3788 VSS.n1240 VSS.n1239 9.0005
R3789 VSS.n1237 VSS.n1135 9.0005
R3790 VSS.n1235 VSS.n1234 9.0005
R3791 VSS.n1231 VSS.n1230 9.0005
R3792 VSS.n1228 VSS.n1137 9.0005
R3793 VSS.n1226 VSS.n1225 9.0005
R3794 VSS.n1222 VSS.n1221 9.0005
R3795 VSS.n1219 VSS.n1139 9.0005
R3796 VSS.n1217 VSS.n1216 9.0005
R3797 VSS.n1213 VSS.n1212 9.0005
R3798 VSS.n1210 VSS.n1141 9.0005
R3799 VSS.n1208 VSS.n1207 9.0005
R3800 VSS.n1204 VSS.n1203 9.0005
R3801 VSS.n1201 VSS.n1143 9.0005
R3802 VSS.n1199 VSS.n1198 9.0005
R3803 VSS.n1195 VSS.n1194 9.0005
R3804 VSS.n1192 VSS.n1145 9.0005
R3805 VSS.n1190 VSS.n1189 9.0005
R3806 VSS.n1186 VSS.n1185 9.0005
R3807 VSS.n1183 VSS.n1147 9.0005
R3808 VSS.n1181 VSS.n1180 9.0005
R3809 VSS.n1177 VSS.n1176 9.0005
R3810 VSS.n1174 VSS.n1149 9.0005
R3811 VSS.n1172 VSS.n1171 9.0005
R3812 VSS.n1168 VSS.n1167 9.0005
R3813 VSS.n1165 VSS.n1151 9.0005
R3814 VSS.n1163 VSS.n1162 9.0005
R3815 VSS.n1159 VSS.n1158 9.0005
R3816 VSS.n1156 VSS.n1153 9.0005
R3817 VSS.n1511 VSS.n1510 9.0005
R3818 VSS.n1515 VSS.n1079 9.0005
R3819 VSS.n1516 VSS.t33 9.0005
R3820 VSS.n1517 VSS.n1078 9.0005
R3821 VSS.t723 VSS.n1520 9.0005
R3822 VSS.t313 VSS.n1525 9.0005
R3823 VSS.n1528 VSS.n1527 9.0005
R3824 VSS.n1063 VSS.n1533 9.0005
R3825 VSS.n1534 VSS.t238 9.0005
R3826 VSS.t298 VSS.n1539 9.0005
R3827 VSS.n1542 VSS.n1541 9.0005
R3828 VSS.n1047 VSS.n1547 9.0005
R3829 VSS.n1548 VSS.t187 9.0005
R3830 VSS.t217 VSS.n1553 9.0005
R3831 VSS.n1556 VSS.n1555 9.0005
R3832 VSS.n1031 VSS.n1561 9.0005
R3833 VSS.n1562 VSS.t375 9.0005
R3834 VSS.t350 VSS.n1567 9.0005
R3835 VSS.n1570 VSS.n1569 9.0005
R3836 VSS.n1015 VSS.n1575 9.0005
R3837 VSS.n1576 VSS.t720 9.0005
R3838 VSS.t301 VSS.n1581 9.0005
R3839 VSS.n1584 VSS.n1583 9.0005
R3840 VSS.n999 VSS.n1589 9.0005
R3841 VSS.n1590 VSS.t212 9.0005
R3842 VSS.t62 VSS.n1595 9.0005
R3843 VSS.n1598 VSS.n1597 9.0005
R3844 VSS.n983 VSS.n1603 9.0005
R3845 VSS.n1604 VSS.t664 9.0005
R3846 VSS.t183 VSS.n1609 9.0005
R3847 VSS.n1612 VSS.n1611 9.0005
R3848 VSS.n967 VSS.n1617 9.0005
R3849 VSS.n1618 VSS.t454 9.0005
R3850 VSS.t240 VSS.n1623 9.0005
R3851 VSS.n1626 VSS.n1625 9.0005
R3852 VSS.n951 VSS.n1631 9.0005
R3853 VSS.n1632 VSS.t712 9.0005
R3854 VSS.t421 VSS.n1637 9.0005
R3855 VSS.n1640 VSS.n1639 9.0005
R3856 VSS.n935 VSS.n1645 9.0005
R3857 VSS.n1646 VSS.t372 9.0005
R3858 VSS.t230 VSS.n1651 9.0005
R3859 VSS.n1654 VSS.n1653 9.0005
R3860 VSS.n919 VSS.n1659 9.0005
R3861 VSS.n1660 VSS.t717 9.0005
R3862 VSS.t687 VSS.n1665 9.0005
R3863 VSS.n1668 VSS.n1667 9.0005
R3864 VSS.n903 VSS.n1673 9.0005
R3865 VSS.n1674 VSS.t209 9.0005
R3866 VSS.t391 VSS.n1679 9.0005
R3867 VSS.n1682 VSS.n1681 9.0005
R3868 VSS.n887 VSS.n1687 9.0005
R3869 VSS.n1688 VSS.t658 9.0005
R3870 VSS.t247 VSS.n1693 9.0005
R3871 VSS.n1696 VSS.n1695 9.0005
R3872 VSS.n871 VSS.n1701 9.0005
R3873 VSS.n1702 VSS.t457 9.0005
R3874 VSS.t31 VSS.n1707 9.0005
R3875 VSS.n1710 VSS.n1709 9.0005
R3876 VSS.n855 VSS.n1715 9.0005
R3877 VSS.n1716 VSS.t250 9.0005
R3878 VSS.t358 VSS.n1721 9.0005
R3879 VSS.n1724 VSS.n1723 9.0005
R3880 VSS.n838 VSS.n1729 9.0005
R3881 VSS.n1730 VSS.t316 9.0005
R3882 VSS.n1736 VSS.t12 9.0005
R3883 VSS.n1732 VSS.n1731 9.0005
R3884 VSS.n1734 VSS.n832 9.0005
R3885 VSS.t235 VSS.n842 9.0005
R3886 VSS.n1728 VSS.t460 9.0005
R3887 VSS.n852 VSS.n849 9.0005
R3888 VSS.n1720 VSS.n847 9.0005
R3889 VSS.t277 VSS.n858 9.0005
R3890 VSS.n1714 VSS.t284 9.0005
R3891 VSS.n868 VSS.n865 9.0005
R3892 VSS.n1706 VSS.n863 9.0005
R3893 VSS.t353 VSS.n874 9.0005
R3894 VSS.n1700 VSS.t448 9.0005
R3895 VSS.n884 VSS.n881 9.0005
R3896 VSS.n1692 VSS.n879 9.0005
R3897 VSS.t679 VSS.n890 9.0005
R3898 VSS.n1686 VSS.t660 9.0005
R3899 VSS.n900 VSS.n897 9.0005
R3900 VSS.n1678 VSS.n895 9.0005
R3901 VSS.t199 VSS.n906 9.0005
R3902 VSS.n1672 VSS.t244 9.0005
R3903 VSS.n916 VSS.n913 9.0005
R3904 VSS.n1664 VSS.n911 9.0005
R3905 VSS.t330 VSS.n922 9.0005
R3906 VSS.n1658 VSS.t347 9.0005
R3907 VSS.n932 VSS.n929 9.0005
R3908 VSS.n1650 VSS.n927 9.0005
R3909 VSS.t306 VSS.n938 9.0005
R3910 VSS.n1644 VSS.t19 9.0005
R3911 VSS.n948 VSS.n945 9.0005
R3912 VSS.n1636 VSS.n943 9.0005
R3913 VSS.t274 VSS.n954 9.0005
R3914 VSS.n1630 VSS.t204 9.0005
R3915 VSS.n964 VSS.n961 9.0005
R3916 VSS.n1622 VSS.n959 9.0005
R3917 VSS.t381 VSS.n970 9.0005
R3918 VSS.n1616 VSS.t650 9.0005
R3919 VSS.n980 VSS.n977 9.0005
R3920 VSS.n1608 VSS.n975 9.0005
R3921 VSS.t676 VSS.n986 9.0005
R3922 VSS.n1602 VSS.t343 9.0005
R3923 VSS.n996 VSS.n993 9.0005
R3924 VSS.n1594 VSS.n991 9.0005
R3925 VSS.t196 VSS.n1002 9.0005
R3926 VSS.n1588 VSS.t395 9.0005
R3927 VSS.n1012 VSS.n1009 9.0005
R3928 VSS.n1580 VSS.n1007 9.0005
R3929 VSS.t705 VSS.n1018 9.0005
R3930 VSS.n1574 VSS.t296 9.0005
R3931 VSS.n1028 VSS.n1025 9.0005
R3932 VSS.n1566 VSS.n1023 9.0005
R3933 VSS.t193 VSS.n1034 9.0005
R3934 VSS.n1560 VSS.t647 9.0005
R3935 VSS.n1044 VSS.n1041 9.0005
R3936 VSS.n1552 VSS.n1039 9.0005
R3937 VSS.t473 VSS.n1050 9.0005
R3938 VSS.n1546 VSS.t28 9.0005
R3939 VSS.n1060 VSS.n1057 9.0005
R3940 VSS.n1538 VSS.n1055 9.0005
R3941 VSS.t644 VSS.n1066 9.0005
R3942 VSS.n1532 VSS.t523 9.0005
R3943 VSS.n1522 VSS.n1074 9.0005
R3944 VSS.n1524 VSS.n1071 9.0005
R3945 VSS.n789 VSS.n788 9.0005
R3946 VSS.n821 VSS.n820 9.0005
R3947 VSS.n819 VSS.n818 9.0005
R3948 VSS.n817 VSS.n816 9.0005
R3949 VSS.n815 VSS.n814 9.0005
R3950 VSS.n813 VSS.n812 9.0005
R3951 VSS.n811 VSS.t378 9.0005
R3952 VSS.n810 VSS.n809 9.0005
R3953 VSS.n808 VSS.n807 9.0005
R3954 VSS.n806 VSS.n805 9.0005
R3955 VSS.n804 VSS.t152 9.0005
R3956 VSS.n803 VSS.n802 9.0005
R3957 VSS.n801 VSS.t149 9.0005
R3958 VSS.n1741 VSS.n526 9.0005
R3959 VSS.n1742 VSS.t150 9.0005
R3960 VSS.n2072 VSS.n2071 9.0005
R3961 VSS.n2070 VSS.n270 9.0005
R3962 VSS.n2069 VSS.n269 9.0005
R3963 VSS.n2068 VSS.n267 9.0005
R3964 VSS.n2067 VSS.n266 9.0005
R3965 VSS.n2066 VSS.n265 9.0005
R3966 VSS.n2065 VSS.n263 9.0005
R3967 VSS.n2064 VSS.n261 9.0005
R3968 VSS.n2063 VSS.n260 9.0005
R3969 VSS.n2062 VSS.n259 9.0005
R3970 VSS.n2061 VSS.n257 9.0005
R3971 VSS.n2060 VSS.n255 9.0005
R3972 VSS.n2059 VSS.n254 9.0005
R3973 VSS.n2058 VSS.n253 9.0005
R3974 VSS.n2057 VSS.n251 9.0005
R3975 VSS.n2056 VSS.n249 9.0005
R3976 VSS.n2055 VSS.n248 9.0005
R3977 VSS.n2054 VSS.n246 9.0005
R3978 VSS.n2053 VSS.n245 9.0005
R3979 VSS.n2052 VSS.n243 9.0005
R3980 VSS.n2051 VSS.n241 9.0005
R3981 VSS.n2050 VSS.n240 9.0005
R3982 VSS.n2049 VSS.n239 9.0005
R3983 VSS.n2048 VSS.n238 9.0005
R3984 VSS.n2047 VSS.n237 9.0005
R3985 VSS.n2046 VSS.n236 9.0005
R3986 VSS.n2045 VSS.n235 9.0005
R3987 VSS.n2044 VSS.n234 9.0005
R3988 VSS.n2043 VSS.n233 9.0005
R3989 VSS.n2042 VSS.n232 9.0005
R3990 VSS.n2041 VSS.n231 9.0005
R3991 VSS.n2040 VSS.n230 9.0005
R3992 VSS.n2039 VSS.n229 9.0005
R3993 VSS.n2038 VSS.n227 9.0005
R3994 VSS.n2037 VSS.n226 9.0005
R3995 VSS.n2036 VSS.n225 9.0005
R3996 VSS.n2035 VSS.n2034 9.0005
R3997 VSS.n2033 VSS.n273 9.0005
R3998 VSS.n2032 VSS.n2031 9.0005
R3999 VSS.n2030 VSS.n274 9.0005
R4000 VSS.n2029 VSS.n2028 9.0005
R4001 VSS.n276 VSS.n275 9.0005
R4002 VSS.n2020 VSS.n2019 9.0005
R4003 VSS.n2018 VSS.n284 9.0005
R4004 VSS.n2017 VSS.n2016 9.0005
R4005 VSS.n286 VSS.n285 9.0005
R4006 VSS.n2002 VSS.n2001 9.0005
R4007 VSS.n2003 VSS.n2000 9.0005
R4008 VSS.n2005 VSS.n2004 9.0005
R4009 VSS.n2006 VSS.n1996 9.0005
R4010 VSS.n2008 VSS.n2007 9.0005
R4011 VSS.n2009 VSS.n304 9.0005
R4012 VSS.n2011 VSS.n2010 9.0005
R4013 VSS.n1995 VSS.n302 9.0005
R4014 VSS.n1994 VSS.n1993 9.0005
R4015 VSS.n1991 VSS.n305 9.0005
R4016 VSS.n1983 VSS.n306 9.0005
R4017 VSS.n1984 VSS.n314 9.0005
R4018 VSS.n1986 VSS.n1985 9.0005
R4019 VSS.n1982 VSS.n313 9.0005
R4020 VSS.n1981 VSS.n1980 9.0005
R4021 VSS.n316 VSS.n315 9.0005
R4022 VSS.n1973 VSS.n1972 9.0005
R4023 VSS.n1971 VSS.n323 9.0005
R4024 VSS.n1970 VSS.n1969 9.0005
R4025 VSS.n325 VSS.n324 9.0005
R4026 VSS.n1955 VSS.n1954 9.0005
R4027 VSS.n1956 VSS.n1953 9.0005
R4028 VSS.n1958 VSS.n1957 9.0005
R4029 VSS.n1959 VSS.n1949 9.0005
R4030 VSS.n1961 VSS.n1960 9.0005
R4031 VSS.n1962 VSS.n343 9.0005
R4032 VSS.n1964 VSS.n1963 9.0005
R4033 VSS.n1948 VSS.n341 9.0005
R4034 VSS.n1947 VSS.n1946 9.0005
R4035 VSS.n1944 VSS.n344 9.0005
R4036 VSS.n1936 VSS.n345 9.0005
R4037 VSS.n1937 VSS.n353 9.0005
R4038 VSS.n1939 VSS.n1938 9.0005
R4039 VSS.n1935 VSS.n352 9.0005
R4040 VSS.n1934 VSS.n1933 9.0005
R4041 VSS.n355 VSS.n354 9.0005
R4042 VSS.n1926 VSS.n1925 9.0005
R4043 VSS.n1924 VSS.n362 9.0005
R4044 VSS.n1923 VSS.n1922 9.0005
R4045 VSS.n364 VSS.n363 9.0005
R4046 VSS.n1908 VSS.n1907 9.0005
R4047 VSS.n1909 VSS.n1906 9.0005
R4048 VSS.n1911 VSS.n1910 9.0005
R4049 VSS.n1912 VSS.n1902 9.0005
R4050 VSS.n1914 VSS.n1913 9.0005
R4051 VSS.n1915 VSS.n408 9.0005
R4052 VSS.n1917 VSS.n1916 9.0005
R4053 VSS.n1901 VSS.n406 9.0005
R4054 VSS.n1900 VSS.n1899 9.0005
R4055 VSS.n1897 VSS.n409 9.0005
R4056 VSS.n1895 VSS.n1894 9.0005
R4057 VSS.n1893 VSS.n411 9.0005
R4058 VSS.n1892 VSS.n1891 9.0005
R4059 VSS.n1889 VSS.n413 9.0005
R4060 VSS.n1887 VSS.n1886 9.0005
R4061 VSS.n1885 VSS.n415 9.0005
R4062 VSS.n1884 VSS.n1883 9.0005
R4063 VSS.n1881 VSS.n417 9.0005
R4064 VSS.n1879 VSS.n1878 9.0005
R4065 VSS.n1877 VSS.n419 9.0005
R4066 VSS.n1876 VSS.n1875 9.0005
R4067 VSS.n1874 VSS.n421 9.0005
R4068 VSS.n1872 VSS.n1871 9.0005
R4069 VSS.n1870 VSS.n423 9.0005
R4070 VSS.n1869 VSS.n1868 9.0005
R4071 VSS.n1866 VSS.n425 9.0005
R4072 VSS.n1864 VSS.n1863 9.0005
R4073 VSS.n1862 VSS.n427 9.0005
R4074 VSS.n1861 VSS.n1860 9.0005
R4075 VSS.n1858 VSS.n428 9.0005
R4076 VSS.n1850 VSS.n429 9.0005
R4077 VSS.n1851 VSS.n437 9.0005
R4078 VSS.n1853 VSS.n1852 9.0005
R4079 VSS.n1849 VSS.n436 9.0005
R4080 VSS.n1848 VSS.n1847 9.0005
R4081 VSS.n439 VSS.n438 9.0005
R4082 VSS.n1840 VSS.n1839 9.0005
R4083 VSS.n1838 VSS.n446 9.0005
R4084 VSS.n1837 VSS.n1836 9.0005
R4085 VSS.n448 VSS.n447 9.0005
R4086 VSS.n1822 VSS.n1821 9.0005
R4087 VSS.n1823 VSS.n1820 9.0005
R4088 VSS.n1825 VSS.n1824 9.0005
R4089 VSS.n1826 VSS.n1816 9.0005
R4090 VSS.n1828 VSS.n1827 9.0005
R4091 VSS.n1829 VSS.n466 9.0005
R4092 VSS.n1831 VSS.n1830 9.0005
R4093 VSS.n1815 VSS.n464 9.0005
R4094 VSS.n1814 VSS.n1813 9.0005
R4095 VSS.n1811 VSS.n467 9.0005
R4096 VSS.n1803 VSS.n468 9.0005
R4097 VSS.n1804 VSS.n476 9.0005
R4098 VSS.n1806 VSS.n1805 9.0005
R4099 VSS.n1802 VSS.n475 9.0005
R4100 VSS.n1801 VSS.n1800 9.0005
R4101 VSS.n478 VSS.n477 9.0005
R4102 VSS.n1793 VSS.n1792 9.0005
R4103 VSS.n1791 VSS.n485 9.0005
R4104 VSS.n1790 VSS.n1789 9.0005
R4105 VSS.n487 VSS.n486 9.0005
R4106 VSS.n1775 VSS.n1774 9.0005
R4107 VSS.n1776 VSS.n1773 9.0005
R4108 VSS.n1778 VSS.n1777 9.0005
R4109 VSS.n1779 VSS.n1769 9.0005
R4110 VSS.n1781 VSS.n1780 9.0005
R4111 VSS.n1782 VSS.n505 9.0005
R4112 VSS.n1784 VSS.n1783 9.0005
R4113 VSS.n1768 VSS.n503 9.0005
R4114 VSS.n1767 VSS.n1766 9.0005
R4115 VSS.n1764 VSS.n506 9.0005
R4116 VSS.n1756 VSS.n507 9.0005
R4117 VSS.n1757 VSS.n515 9.0005
R4118 VSS.n1759 VSS.n1758 9.0005
R4119 VSS.n1755 VSS.n514 9.0005
R4120 VSS.n1754 VSS.n1753 9.0005
R4121 VSS.n517 VSS.n516 9.0005
R4122 VSS.n1746 VSS.n1745 9.0005
R4123 VSS.n1744 VSS.n524 9.0005
R4124 VSS.n1743 VSS.n1742 9.0005
R4125 VSS.n526 VSS.n525 9.0005
R4126 VSS.n801 VSS.n800 9.0005
R4127 VSS.n803 VSS.n799 9.0005
R4128 VSS.n804 VSS.n798 9.0005
R4129 VSS.n806 VSS.n797 9.0005
R4130 VSS.n808 VSS.n796 9.0005
R4131 VSS.n810 VSS.n795 9.0005
R4132 VSS.n811 VSS.n794 9.0005
R4133 VSS.n813 VSS.n793 9.0005
R4134 VSS.n815 VSS.n792 9.0005
R4135 VSS.n817 VSS.n791 9.0005
R4136 VSS.n819 VSS.n790 9.0005
R4137 VSS.n822 VSS.n821 9.0005
R4138 VSS.n524 VSS.t147 9.0005
R4139 VSS.n1747 VSS.n1746 9.0005
R4140 VSS.n520 VSS.n517 9.0005
R4141 VSS.n1753 VSS.t144 9.0005
R4142 VSS.n514 VSS.n513 9.0005
R4143 VSS.t142 VSS.n1759 9.0005
R4144 VSS.n515 VSS.t140 9.0005
R4145 VSS.n1763 VSS.n507 9.0005
R4146 VSS.n1764 VSS.t139 9.0005
R4147 VSS.n1766 VSS.n1765 9.0005
R4148 VSS.n503 VSS.n501 9.0005
R4149 VSS.t638 VSS.n1784 9.0005
R4150 VSS.n505 VSS.n504 9.0005
R4151 VSS.n1780 VSS.n1770 9.0005
R4152 VSS.n1779 VSS.n1771 9.0005
R4153 VSS.n1778 VSS.t137 9.0005
R4154 VSS.n1773 VSS.n1772 9.0005
R4155 VSS.n1774 VSS.t135 9.0005
R4156 VSS.n1788 VSS.n487 9.0005
R4157 VSS.n1789 VSS.t134 9.0005
R4158 VSS.n485 VSS.t132 9.0005
R4159 VSS.n1794 VSS.n1793 9.0005
R4160 VSS.n481 VSS.n478 9.0005
R4161 VSS.n1800 VSS.t129 9.0005
R4162 VSS.n475 VSS.n474 9.0005
R4163 VSS.t127 VSS.n1806 9.0005
R4164 VSS.n476 VSS.t125 9.0005
R4165 VSS.n1810 VSS.n468 9.0005
R4166 VSS.n1811 VSS.t124 9.0005
R4167 VSS.n1813 VSS.n1812 9.0005
R4168 VSS.n464 VSS.n462 9.0005
R4169 VSS.t53 VSS.n1831 9.0005
R4170 VSS.n466 VSS.n465 9.0005
R4171 VSS.n1827 VSS.n1817 9.0005
R4172 VSS.n1826 VSS.n1818 9.0005
R4173 VSS.n1825 VSS.t122 9.0005
R4174 VSS.n1820 VSS.n1819 9.0005
R4175 VSS.n1821 VSS.t120 9.0005
R4176 VSS.n1835 VSS.n448 9.0005
R4177 VSS.n1836 VSS.t119 9.0005
R4178 VSS.n446 VSS.t117 9.0005
R4179 VSS.n1841 VSS.n1840 9.0005
R4180 VSS.n442 VSS.n439 9.0005
R4181 VSS.n1847 VSS.t114 9.0005
R4182 VSS.n436 VSS.n435 9.0005
R4183 VSS.t112 VSS.n1853 9.0005
R4184 VSS.n437 VSS.t110 9.0005
R4185 VSS.n1857 VSS.n429 9.0005
R4186 VSS.n1858 VSS.t109 9.0005
R4187 VSS.n1860 VSS.n1859 9.0005
R4188 VSS.n427 VSS.n426 9.0005
R4189 VSS.n1864 VSS.t526 9.0005
R4190 VSS.n1866 VSS.n1865 9.0005
R4191 VSS.n1868 VSS.n1867 9.0005
R4192 VSS.n423 VSS.n422 9.0005
R4193 VSS.n1872 VSS.n424 9.0005
R4194 VSS.n1874 VSS.n1873 9.0005
R4195 VSS.n1875 VSS.t171 9.0005
R4196 VSS.n419 VSS.n418 9.0005
R4197 VSS.n1879 VSS.n420 9.0005
R4198 VSS.n1881 VSS.n1880 9.0005
R4199 VSS.n1883 VSS.n1882 9.0005
R4200 VSS.n415 VSS.n414 9.0005
R4201 VSS.n1887 VSS.n416 9.0005
R4202 VSS.n1889 VSS.n1888 9.0005
R4203 VSS.n1891 VSS.n1890 9.0005
R4204 VSS.n411 VSS.n410 9.0005
R4205 VSS.n1895 VSS.n412 9.0005
R4206 VSS.n1897 VSS.n1896 9.0005
R4207 VSS.n1899 VSS.n1898 9.0005
R4208 VSS.n406 VSS.n404 9.0005
R4209 VSS.t179 VSS.n1917 9.0005
R4210 VSS.n408 VSS.n407 9.0005
R4211 VSS.n1913 VSS.n1903 9.0005
R4212 VSS.n1912 VSS.n1904 9.0005
R4213 VSS.n1911 VSS.t107 9.0005
R4214 VSS.n1906 VSS.n1905 9.0005
R4215 VSS.n1907 VSS.t105 9.0005
R4216 VSS.n1921 VSS.n364 9.0005
R4217 VSS.n1922 VSS.t104 9.0005
R4218 VSS.n362 VSS.t102 9.0005
R4219 VSS.n1927 VSS.n1926 9.0005
R4220 VSS.n358 VSS.n355 9.0005
R4221 VSS.n1933 VSS.t99 9.0005
R4222 VSS.n352 VSS.n351 9.0005
R4223 VSS.t97 VSS.n1939 9.0005
R4224 VSS.n353 VSS.t95 9.0005
R4225 VSS.n1943 VSS.n345 9.0005
R4226 VSS.n1944 VSS.t94 9.0005
R4227 VSS.n1946 VSS.n1945 9.0005
R4228 VSS.n341 VSS.n339 9.0005
R4229 VSS.t190 VSS.n1964 9.0005
R4230 VSS.n343 VSS.n342 9.0005
R4231 VSS.n1960 VSS.n1950 9.0005
R4232 VSS.n1959 VSS.n1951 9.0005
R4233 VSS.n1958 VSS.t92 9.0005
R4234 VSS.n1953 VSS.n1952 9.0005
R4235 VSS.n1954 VSS.t90 9.0005
R4236 VSS.n1968 VSS.n325 9.0005
R4237 VSS.n1969 VSS.t89 9.0005
R4238 VSS.n323 VSS.t87 9.0005
R4239 VSS.n1974 VSS.n1973 9.0005
R4240 VSS.n319 VSS.n316 9.0005
R4241 VSS.n1980 VSS.t84 9.0005
R4242 VSS.n313 VSS.n312 9.0005
R4243 VSS.t82 VSS.n1986 9.0005
R4244 VSS.n314 VSS.t80 9.0005
R4245 VSS.n1990 VSS.n306 9.0005
R4246 VSS.n1991 VSS.t79 9.0005
R4247 VSS.n1993 VSS.n1992 9.0005
R4248 VSS.n302 VSS.n300 9.0005
R4249 VSS.t50 VSS.n2011 9.0005
R4250 VSS.n304 VSS.n303 9.0005
R4251 VSS.n2007 VSS.n1997 9.0005
R4252 VSS.n2006 VSS.n1998 9.0005
R4253 VSS.n2005 VSS.t77 9.0005
R4254 VSS.n2000 VSS.n1999 9.0005
R4255 VSS.n2001 VSS.t75 9.0005
R4256 VSS.n2015 VSS.n286 9.0005
R4257 VSS.n2016 VSS.t74 9.0005
R4258 VSS.n284 VSS.t72 9.0005
R4259 VSS.n2021 VSS.n2020 9.0005
R4260 VSS.n280 VSS.n276 9.0005
R4261 VSS.n2028 VSS.t69 9.0005
R4262 VSS.n2027 VSS.n274 9.0005
R4263 VSS.n2032 VSS.t67 9.0005
R4264 VSS.n2033 VSS.t65 9.0005
R4265 VSS.n2034 VSS.n224 9.0005
R4266 VSS.t64 VSS.n225 9.0005
R4267 VSS.n2117 VSS.n226 9.0005
R4268 VSS.n2115 VSS.n227 9.0005
R4269 VSS.t155 VSS.n229 9.0005
R4270 VSS.n2113 VSS.n230 9.0005
R4271 VSS.n2111 VSS.n231 9.0005
R4272 VSS.n2109 VSS.n232 9.0005
R4273 VSS.n2107 VSS.n233 9.0005
R4274 VSS.n2105 VSS.n234 9.0005
R4275 VSS.n2103 VSS.n235 9.0005
R4276 VSS.n2101 VSS.n236 9.0005
R4277 VSS.n2099 VSS.n237 9.0005
R4278 VSS.n2097 VSS.n238 9.0005
R4279 VSS.n2095 VSS.n239 9.0005
R4280 VSS.n2093 VSS.n240 9.0005
R4281 VSS.t424 VSS.n241 9.0005
R4282 VSS.n2091 VSS.n243 9.0005
R4283 VSS.t47 VSS.n245 9.0005
R4284 VSS.t10 VSS.n246 9.0005
R4285 VSS.n2089 VSS.n248 9.0005
R4286 VSS.n2087 VSS.n249 9.0005
R4287 VSS.n250 VSS.n251 9.0005
R4288 VSS.t269 VSS.n253 9.0005
R4289 VSS.n2085 VSS.n254 9.0005
R4290 VSS.n256 VSS.n255 9.0005
R4291 VSS.n2083 VSS.n257 9.0005
R4292 VSS.t431 VSS.n259 9.0005
R4293 VSS.n2081 VSS.n260 9.0005
R4294 VSS.t485 VSS.n261 9.0005
R4295 VSS.n2079 VSS.n263 9.0005
R4296 VSS.n264 VSS.n265 9.0005
R4297 VSS.n2077 VSS.n266 9.0005
R4298 VSS.n2075 VSS.n267 9.0005
R4299 VSS.n268 VSS.n269 9.0005
R4300 VSS.n271 VSS.n270 9.0005
R4301 VSS.n2073 VSS.n2072 9.0005
R4302 VSS.n3359 VSS.n3358 9.0005
R4303 VSS.n3357 VSS.n2269 9.0005
R4304 VSS.n3331 VSS.n2270 9.0005
R4305 VSS.n3332 VSS.n2273 9.0005
R4306 VSS.n3333 VSS.n2274 9.0005
R4307 VSS.n3334 VSS.n2275 9.0005
R4308 VSS.n3335 VSS.n2276 9.0005
R4309 VSS.n3336 VSS.n2277 9.0005
R4310 VSS.n3337 VSS.n2278 9.0005
R4311 VSS.n3338 VSS.n2279 9.0005
R4312 VSS.n3340 VSS.n3339 9.0005
R4313 VSS.n3330 VSS.n2281 9.0005
R4314 VSS.n3329 VSS.n3328 9.0005
R4315 VSS.n2283 VSS.n2282 9.0005
R4316 VSS.n3304 VSS.n2286 9.0005
R4317 VSS.n3305 VSS.n2287 9.0005
R4318 VSS.n3306 VSS.n2288 9.0005
R4319 VSS.n3307 VSS.n2289 9.0005
R4320 VSS.n3308 VSS.n2290 9.0005
R4321 VSS.n3309 VSS.n2291 9.0005
R4322 VSS.n3311 VSS.n3310 9.0005
R4323 VSS.n3303 VSS.n2293 9.0005
R4324 VSS.n3302 VSS.n3301 9.0005
R4325 VSS.n2295 VSS.n2294 9.0005
R4326 VSS.n3251 VSS.n2298 9.0005
R4327 VSS.n3252 VSS.n2299 9.0005
R4328 VSS.n3253 VSS.n2300 9.0005
R4329 VSS.n3254 VSS.n2301 9.0005
R4330 VSS.n3255 VSS.n2302 9.0005
R4331 VSS.n3256 VSS.n2303 9.0005
R4332 VSS.n3257 VSS.n2304 9.0005
R4333 VSS.n3258 VSS.n2305 9.0005
R4334 VSS.n3259 VSS.n2306 9.0005
R4335 VSS.n3260 VSS.n2307 9.0005
R4336 VSS.n3261 VSS.n2308 9.0005
R4337 VSS.n3262 VSS.n2309 9.0005
R4338 VSS.n3263 VSS.n2310 9.0005
R4339 VSS.n3264 VSS.n2311 9.0005
R4340 VSS.n3265 VSS.n2312 9.0005
R4341 VSS.n3267 VSS.n3266 9.0005
R4342 VSS.n3250 VSS.n2314 9.0005
R4343 VSS.n3249 VSS.n3248 9.0005
R4344 VSS.n2316 VSS.n2315 9.0005
R4345 VSS.n3224 VSS.n2319 9.0005
R4346 VSS.n3225 VSS.n2320 9.0005
R4347 VSS.n3226 VSS.n2321 9.0005
R4348 VSS.n3227 VSS.n2322 9.0005
R4349 VSS.n3228 VSS.n2323 9.0005
R4350 VSS.n3229 VSS.n2324 9.0005
R4351 VSS.n3231 VSS.n3230 9.0005
R4352 VSS.n3223 VSS.n2326 9.0005
R4353 VSS.n3222 VSS.n3221 9.0005
R4354 VSS.n2328 VSS.n2327 9.0005
R4355 VSS.n3142 VSS.n2331 9.0005
R4356 VSS.n3143 VSS.n2332 9.0005
R4357 VSS.n3144 VSS.n2333 9.0005
R4358 VSS.n3145 VSS.n2334 9.0005
R4359 VSS.n3146 VSS.n2335 9.0005
R4360 VSS.n3147 VSS.n2336 9.0005
R4361 VSS.n3148 VSS.n2337 9.0005
R4362 VSS.n3149 VSS.n2338 9.0005
R4363 VSS.n3150 VSS.n2339 9.0005
R4364 VSS.n3151 VSS.n2340 9.0005
R4365 VSS.n3152 VSS.n2341 9.0005
R4366 VSS.n3153 VSS.n2342 9.0005
R4367 VSS.n3154 VSS.n2343 9.0005
R4368 VSS.n3155 VSS.n2344 9.0005
R4369 VSS.n3156 VSS.n2345 9.0005
R4370 VSS.n3157 VSS.n2346 9.0005
R4371 VSS.n3158 VSS.n2347 9.0005
R4372 VSS.n3159 VSS.n2348 9.0005
R4373 VSS.n3160 VSS.n2349 9.0005
R4374 VSS.n3161 VSS.n2350 9.0005
R4375 VSS.n3162 VSS.n2351 9.0005
R4376 VSS.n3163 VSS.n2352 9.0005
R4377 VSS.n3164 VSS.n2353 9.0005
R4378 VSS.n3165 VSS.n2354 9.0005
R4379 VSS.n3166 VSS.n2355 9.0005
R4380 VSS.n3358 VSS.n2267 9.0005
R4381 VSS.n3357 VSS.n2272 9.0005
R4382 VSS.n3356 VSS.n2270 9.0005
R4383 VSS.n3354 VSS.n2273 9.0005
R4384 VSS.n3352 VSS.n2274 9.0005
R4385 VSS.n3350 VSS.n2275 9.0005
R4386 VSS.n3348 VSS.n2276 9.0005
R4387 VSS.n3346 VSS.n2277 9.0005
R4388 VSS.n3344 VSS.n2278 9.0005
R4389 VSS.n3342 VSS.n2279 9.0005
R4390 VSS.n2280 VSS.n3340 9.0005
R4391 VSS.n2284 VSS.n2281 9.0005
R4392 VSS.n3328 VSS.n3327 9.0005
R4393 VSS.n3325 VSS.n2283 9.0005
R4394 VSS.n3323 VSS.n2286 9.0005
R4395 VSS.n3321 VSS.n2287 9.0005
R4396 VSS.n3319 VSS.n2288 9.0005
R4397 VSS.n3317 VSS.n2289 9.0005
R4398 VSS.n3315 VSS.n2290 9.0005
R4399 VSS.n3313 VSS.n2291 9.0005
R4400 VSS.t590 VSS.n3311 9.0005
R4401 VSS.n2296 VSS.n2293 9.0005
R4402 VSS.n3301 VSS.n3300 9.0005
R4403 VSS.n3298 VSS.n2295 9.0005
R4404 VSS.n3296 VSS.n2298 9.0005
R4405 VSS.n3294 VSS.n2299 9.0005
R4406 VSS.n3292 VSS.n2300 9.0005
R4407 VSS.n3290 VSS.n2301 9.0005
R4408 VSS.n3288 VSS.n2302 9.0005
R4409 VSS.n3286 VSS.n2303 9.0005
R4410 VSS.t592 VSS.n2304 9.0005
R4411 VSS.n3283 VSS.n2305 9.0005
R4412 VSS.n3281 VSS.n2306 9.0005
R4413 VSS.n3279 VSS.n2307 9.0005
R4414 VSS.n3277 VSS.n2308 9.0005
R4415 VSS.n3275 VSS.n2309 9.0005
R4416 VSS.n3273 VSS.n2310 9.0005
R4417 VSS.n3271 VSS.n2311 9.0005
R4418 VSS.n3269 VSS.n2312 9.0005
R4419 VSS.n2313 VSS.n3267 9.0005
R4420 VSS.n2317 VSS.n2314 9.0005
R4421 VSS.n3248 VSS.n3247 9.0005
R4422 VSS.n3245 VSS.n2316 9.0005
R4423 VSS.n3243 VSS.n2319 9.0005
R4424 VSS.n3241 VSS.n2320 9.0005
R4425 VSS.n3239 VSS.n2321 9.0005
R4426 VSS.n3237 VSS.n2322 9.0005
R4427 VSS.n3235 VSS.n2323 9.0005
R4428 VSS.n3233 VSS.n2324 9.0005
R4429 VSS.t596 VSS.n3231 9.0005
R4430 VSS.n2329 VSS.n2326 9.0005
R4431 VSS.n3221 VSS.n3220 9.0005
R4432 VSS.n3218 VSS.n2328 9.0005
R4433 VSS.n3216 VSS.n2331 9.0005
R4434 VSS.n3214 VSS.n2332 9.0005
R4435 VSS.n3212 VSS.n2333 9.0005
R4436 VSS.n3210 VSS.n2334 9.0005
R4437 VSS.n3208 VSS.n2335 9.0005
R4438 VSS.n3206 VSS.n2336 9.0005
R4439 VSS.t598 VSS.n2337 9.0005
R4440 VSS.n3203 VSS.n2338 9.0005
R4441 VSS.n3201 VSS.n2339 9.0005
R4442 VSS.n3199 VSS.n2340 9.0005
R4443 VSS.n3197 VSS.n2341 9.0005
R4444 VSS.n3195 VSS.n2342 9.0005
R4445 VSS.n3193 VSS.n2343 9.0005
R4446 VSS.n3191 VSS.n2344 9.0005
R4447 VSS.n3189 VSS.n2345 9.0005
R4448 VSS.n3187 VSS.n2346 9.0005
R4449 VSS.n3186 VSS.n2347 9.0005
R4450 VSS.n3184 VSS.n2348 9.0005
R4451 VSS.n3182 VSS.n2349 9.0005
R4452 VSS.n3180 VSS.n2350 9.0005
R4453 VSS.n3178 VSS.n2351 9.0005
R4454 VSS.n3176 VSS.n2352 9.0005
R4455 VSS.n3174 VSS.n2353 9.0005
R4456 VSS.n3172 VSS.n2354 9.0005
R4457 VSS.n3170 VSS.n2355 9.0005
R4458 VSS.t602 VSS.n3168 9.0005
R4459 VSS.n3823 VSS.n133 9.0005
R4460 VSS.n3800 VSS.n134 9.0005
R4461 VSS.n3804 VSS.n150 9.0005
R4462 VSS.n3808 VSS.n148 9.0005
R4463 VSS.n3814 VSS.n144 9.0005
R4464 VSS.n3818 VSS.n140 9.0005
R4465 VSS.n3787 VSS.n138 9.0005
R4466 VSS.n3384 VSS.n3383 9.0005
R4467 VSS.n3388 VSS.n3387 9.0005
R4468 VSS.n3392 VSS.n3391 9.0005
R4469 VSS.n3400 VSS.n3399 9.0005
R4470 VSS.n3404 VSS.n3403 9.0005
R4471 VSS.n3408 VSS.n3407 9.0005
R4472 VSS.n3416 VSS.n3415 9.0005
R4473 VSS.n3420 VSS.n3419 9.0005
R4474 VSS.n3422 VSS.n3421 9.0005
R4475 VSS.n3418 VSS.n3417 9.0005
R4476 VSS.n3410 VSS.n3409 9.0005
R4477 VSS.n3406 VSS.n3405 9.0005
R4478 VSS.n3402 VSS.n3401 9.0005
R4479 VSS.n3394 VSS.n3393 9.0005
R4480 VSS.n3390 VSS.n3389 9.0005
R4481 VSS.n3386 VSS.n3385 9.0005
R4482 VSS.n3786 VSS.n3785 9.0005
R4483 VSS.n3820 VSS.n139 9.0005
R4484 VSS.n3816 VSS.n142 9.0005
R4485 VSS.n3806 VSS.n149 9.0005
R4486 VSS.n3802 VSS.n3801 9.0005
R4487 VSS.n3853 VSS.n122 9.0005
R4488 VSS.n3852 VSS.n3851 9.0005
R4489 VSS.n3848 VSS.n125 9.0005
R4490 VSS.n3846 VSS.n3845 9.0005
R4491 VSS.n3837 VSS.n127 9.0005
R4492 VSS.n3840 VSS.n3839 9.0005
R4493 VSS.n3835 VSS.n129 9.0005
R4494 VSS.n3833 VSS.n3832 9.0005
R4495 VSS.n3825 VSS.n131 9.0005
R4496 VSS.n3828 VSS.n3827 9.0005
R4497 VSS.n3810 VSS.n146 9.0005
R4498 VSS.n3812 VSS.n145 9.0005
R4499 VSS.n153 VSS.n152 9.0005
R4500 VSS.n3382 VSS.n3381 9.0005
R4501 VSS.n3396 VSS.n3395 9.0005
R4502 VSS.n3398 VSS.n3397 9.0005
R4503 VSS.n3412 VSS.n3411 9.0005
R4504 VSS.n3414 VSS.n3413 9.0005
R4505 VSS.n3510 VSS.n3714 9.0005
R4506 VSS.n3713 VSS.n3712 9.0005
R4507 VSS.n3716 VSS.n3542 9.0005
R4508 VSS.n3718 VSS.n3541 9.0005
R4509 VSS.t694 VSS.n3539 9.0005
R4510 VSS.t695 VSS.n3537 9.0005
R4511 VSS.n3720 VSS.n3536 9.0005
R4512 VSS.t698 VSS.n3523 9.0005
R4513 VSS.t699 VSS.n3521 9.0005
R4514 VSS.n3690 VSS.n3511 9.0005
R4515 VSS.n3689 VSS.n3688 9.0005
R4516 VSS.n3673 VSS.n3672 9.0005
R4517 VSS.n3671 VSS.n3670 9.0005
R4518 VSS.n3601 VSS.n3600 9.0005
R4519 VSS.n3599 VSS.n3598 9.0005
R4520 VSS.n3571 VSS.n3564 9.0005
R4521 VSS.n3597 VSS.n3596 9.0005
R4522 VSS.n3562 VSS.n3561 9.0005
R4523 VSS.n3613 VSS.n3612 9.0005
R4524 VSS.n3611 VSS.n3610 9.0005
R4525 VSS.n3609 VSS.n3608 9.0005
R4526 VSS.n3551 VSS.n3550 9.0005
R4527 VSS.n3669 VSS.n3668 9.0005
R4528 VSS.n3548 VSS.n3547 9.0005
R4529 VSS.n3678 VSS.n3677 9.0005
R4530 VSS.n3680 VSS.n3679 9.0005
R4531 VSS.n3682 VSS.n3681 9.0005
R4532 VSS.n3545 VSS.n3544 9.0005
R4533 VSS.n3687 VSS.n3686 9.0005
R4534 VSS.n3735 VSS.n3512 9.0005
R4535 VSS.n3733 VSS.n3513 9.0005
R4536 VSS.n3515 VSS.n3514 9.0005
R4537 VSS.n3517 VSS.n3518 9.0005
R4538 VSS.n3731 VSS.n3519 9.0005
R4539 VSS.n3729 VSS.n3520 9.0005
R4540 VSS.n3727 VSS.n3526 9.0005
R4541 VSS.n3725 VSS.n3527 9.0005
R4542 VSS.n3723 VSS.n3528 9.0005
R4543 VSS.t697 VSS.n3531 9.0005
R4544 VSS.n3533 VSS.n3534 9.0005
R4545 VSS.n3722 VSS.n3535 9.0005
R4546 VSS.n3742 VSS.n3506 9.0005
R4547 VSS.n3743 VSS.n3502 9.0005
R4548 VSS.n3745 VSS.n3500 9.0005
R4549 VSS.n3756 VSS.n3493 9.0005
R4550 VSS.n3758 VSS.n3492 9.0005
R4551 VSS.t692 VSS.n3491 9.0005
R4552 VSS.n3760 VSS.n3489 9.0005
R4553 VSS.n3637 VSS.n3636 9.0005
R4554 VSS.n3767 VSS.n3484 9.0005
R4555 VSS.n3769 VSS.n3483 9.0005
R4556 VSS.n3771 VSS.n3482 9.0005
R4557 VSS.n3773 VSS.n3481 9.0005
R4558 VSS.n3775 VSS.n3480 9.0005
R4559 VSS.n3777 VSS.n3479 9.0005
R4560 VSS.n3651 VSS.n3650 9.0005
R4561 VSS.n3655 VSS.n3654 9.0005
R4562 VSS.n3657 VSS.n3656 9.0005
R4563 VSS.n3659 VSS.n3658 9.0005
R4564 VSS.n3665 VSS.n3664 9.0005
R4565 VSS.n3554 VSS.n3553 9.0005
R4566 VSS.n3621 VSS.n3620 9.0005
R4567 VSS.n3619 VSS.n3618 9.0005
R4568 VSS.n3617 VSS.n3616 9.0005
R4569 VSS.n3558 VSS.n3556 9.0005
R4570 VSS.n3593 VSS.n3592 9.0005
R4571 VSS.n3568 VSS.n3566 9.0005
R4572 VSS.n3581 VSS.n3580 9.0005
R4573 VSS.n3748 VSS.n3498 9.0005
R4574 VSS.n3750 VSS.n3496 9.0005
R4575 VSS.n3752 VSS.n3495 9.0005
R4576 VSS.n3754 VSS.n3494 9.0005
R4577 VSS.t693 VSS.n3486 9.0005
R4578 VSS.n3765 VSS.n3485 9.0005
R4579 VSS.n3779 VSS.n3478 9.0005
R4580 VSS.n3649 VSS.n3477 9.0005
R4581 VSS.n3661 VSS.n3660 9.0005
R4582 VSS.n3663 VSS.n3662 9.0005
R4583 VSS.n3589 VSS.n3588 9.0005
R4584 VSS.n3591 VSS.n3590 9.0005
R4585 VSS.n2249 VSS.t228 9.0005
R4586 VSS.n2262 VSS.n2261 9.0005
R4587 VSS.n2259 VSS.n2258 9.0005
R4588 VSS.n2257 VSS.n2256 9.0005
R4589 VSS.n2255 VSS.n2254 9.0005
R4590 VSS.n2253 VSS.n2252 9.0005
R4591 VSS.n2205 VSS.n2204 9.0005
R4592 VSS.n3452 VSS.n2184 9.0005
R4593 VSS.n3453 VSS.t407 9.0005
R4594 VSS.n3454 VSS.t332 9.0005
R4595 VSS.n2202 VSS.n2201 9.0005
R4596 VSS.n3459 VSS.n3458 9.0005
R4597 VSS.n3045 VSS.n2699 9.0005
R4598 VSS.n3047 VSS.n2698 9.0005
R4599 VSS.n3048 VSS.n2697 9.0005
R4600 VSS.n3050 VSS.n2696 9.0005
R4601 VSS.n3051 VSS.n2695 9.0005
R4602 VSS.t163 VSS.n2694 9.0005
R4603 VSS.n2693 VSS.n2692 9.0005
R4604 VSS.t157 VSS.n2691 9.0005
R4605 VSS.n2690 VSS.n2689 9.0005
R4606 VSS.n3054 VSS.n2688 9.0005
R4607 VSS.n3056 VSS.n2687 9.0005
R4608 VSS.n3057 VSS.n2686 9.0005
R4609 VSS.n3059 VSS.n2685 9.0005
R4610 VSS.n3060 VSS.n2684 9.0005
R4611 VSS.n3062 VSS.n2683 9.0005
R4612 VSS.n3063 VSS.n2682 9.0005
R4613 VSS.n3065 VSS.n2681 9.0005
R4614 VSS.n3066 VSS.n2680 9.0005
R4615 VSS.n3068 VSS.n2679 9.0005
R4616 VSS.n3069 VSS.n2678 9.0005
R4617 VSS.n3071 VSS.n2676 9.0005
R4618 VSS.n3072 VSS.n2675 9.0005
R4619 VSS.n2672 VSS.n2673 9.0005
R4620 VSS.t159 VSS.n2671 9.0005
R4621 VSS.n3074 VSS.n2670 9.0005
R4622 VSS.n3076 VSS.n2669 9.0005
R4623 VSS.n3077 VSS.n2668 9.0005
R4624 VSS.t368 VSS.n2667 9.0005
R4625 VSS.n2666 VSS.n2665 9.0005
R4626 VSS.n3079 VSS.n2664 9.0005
R4627 VSS.t161 VSS.n2663 9.0005
R4628 VSS.n2662 VSS.n2661 9.0005
R4629 VSS.n3081 VSS.n2660 9.0005
R4630 VSS.t442 VSS.n2659 9.0005
R4631 VSS.n2658 VSS.n2657 9.0005
R4632 VSS.n3083 VSS.n2656 9.0005
R4633 VSS.n2654 VSS.n2655 9.0005
R4634 VSS.t279 VSS.n2653 9.0005
R4635 VSS.n3086 VSS.n2652 9.0005
R4636 VSS.n3087 VSS.n2651 9.0005
R4637 VSS.t366 VSS.n2649 9.0005
R4638 VSS.n2648 VSS.n2647 9.0005
R4639 VSS.t404 VSS.n2646 9.0005
R4640 VSS.n2645 VSS.n2644 9.0005
R4641 VSS.n3090 VSS.n2643 9.0005
R4642 VSS.n3094 VSS.n2642 9.0005
R4643 VSS.n3095 VSS.n2641 9.0005
R4644 VSS.n3097 VSS.n2640 9.0005
R4645 VSS.n3098 VSS.n2639 9.0005
R4646 VSS.n3100 VSS.n2638 9.0005
R4647 VSS.n3101 VSS.n2637 9.0005
R4648 VSS.n3103 VSS.n2636 9.0005
R4649 VSS.n3104 VSS.n2635 9.0005
R4650 VSS.n3106 VSS.n2633 9.0005
R4651 VSS.n3107 VSS.n2632 9.0005
R4652 VSS.n2629 VSS.n2630 9.0005
R4653 VSS.t317 VSS.n2628 9.0005
R4654 VSS.n3109 VSS.n2627 9.0005
R4655 VSS.t5 VSS.n2626 9.0005
R4656 VSS.n2625 VSS.n2624 9.0005
R4657 VSS.n3112 VSS.n2623 9.0005
R4658 VSS.n3113 VSS.n2622 9.0005
R4659 VSS.t3 VSS.n2621 9.0005
R4660 VSS.n2620 VSS.n2619 9.0005
R4661 VSS.n3116 VSS.n2617 9.0005
R4662 VSS.n2615 VSS.n2616 9.0005
R4663 VSS.n2927 VSS.n2614 9.0005
R4664 VSS.n2924 VSS.n2923 9.0005
R4665 VSS.n2919 VSS.n2918 9.0005
R4666 VSS.n2915 VSS.n2914 9.0005
R4667 VSS.n2910 VSS.n2909 9.0005
R4668 VSS.n2906 VSS.n2905 9.0005
R4669 VSS.n2901 VSS.n2900 9.0005
R4670 VSS.n2897 VSS.n2896 9.0005
R4671 VSS.n2892 VSS.n2891 9.0005
R4672 VSS.n2888 VSS.n2887 9.0005
R4673 VSS.n2883 VSS.n2882 9.0005
R4674 VSS.n2879 VSS.n2878 9.0005
R4675 VSS.n2874 VSS.n2873 9.0005
R4676 VSS.n2870 VSS.n2869 9.0005
R4677 VSS.n2865 VSS.n2864 9.0005
R4678 VSS.n2862 VSS.n2861 9.0005
R4679 VSS.n2857 VSS.n2856 9.0005
R4680 VSS.n2853 VSS.n2852 9.0005
R4681 VSS.n2848 VSS.n2847 9.0005
R4682 VSS.n2844 VSS.n2843 9.0005
R4683 VSS.n2839 VSS.n2838 9.0005
R4684 VSS.n2835 VSS.n2834 9.0005
R4685 VSS.n2830 VSS.n2829 9.0005
R4686 VSS.n2826 VSS.n2825 9.0005
R4687 VSS.n2821 VSS.t580 9.0005
R4688 VSS.n2818 VSS.n2817 9.0005
R4689 VSS.n2813 VSS.n2812 9.0005
R4690 VSS.n2809 VSS.n2808 9.0005
R4691 VSS.n2804 VSS.n2803 9.0005
R4692 VSS.n2800 VSS.t582 9.0005
R4693 VSS.n2796 VSS.n2795 9.0005
R4694 VSS.n2792 VSS.n2791 9.0005
R4695 VSS.n2787 VSS.n2786 9.0005
R4696 VSS.n2783 VSS.n2782 9.0005
R4697 VSS.n2778 VSS.n2777 9.0005
R4698 VSS.n2774 VSS.n2773 9.0005
R4699 VSS.n2769 VSS.n2768 9.0005
R4700 VSS.n2765 VSS.n2764 9.0005
R4701 VSS.n2760 VSS.n2759 9.0005
R4702 VSS.n2758 VSS.n2757 9.0005
R4703 VSS.n2755 VSS.n2754 9.0005
R4704 VSS.n2767 VSS.n2766 9.0005
R4705 VSS.n2752 VSS.n2751 9.0005
R4706 VSS.n2776 VSS.n2775 9.0005
R4707 VSS.n2749 VSS.n2748 9.0005
R4708 VSS.n2785 VSS.n2784 9.0005
R4709 VSS.n2746 VSS.n2745 9.0005
R4710 VSS.n2794 VSS.n2793 9.0005
R4711 VSS.n2743 VSS.n2742 9.0005
R4712 VSS.n2802 VSS.n2801 9.0005
R4713 VSS.n2740 VSS.n2739 9.0005
R4714 VSS.n2811 VSS.n2810 9.0005
R4715 VSS.n2737 VSS.n2736 9.0005
R4716 VSS.n2820 VSS.n2819 9.0005
R4717 VSS.n2734 VSS.n2733 9.0005
R4718 VSS.n2828 VSS.n2827 9.0005
R4719 VSS.n2731 VSS.n2730 9.0005
R4720 VSS.n2837 VSS.n2836 9.0005
R4721 VSS.n2728 VSS.n2727 9.0005
R4722 VSS.n2846 VSS.n2845 9.0005
R4723 VSS.n2725 VSS.n2724 9.0005
R4724 VSS.n2855 VSS.n2854 9.0005
R4725 VSS.n2722 VSS.n2721 9.0005
R4726 VSS.n2863 VSS.t576 9.0005
R4727 VSS.n2719 VSS.n2718 9.0005
R4728 VSS.n2872 VSS.n2871 9.0005
R4729 VSS.n2716 VSS.n2715 9.0005
R4730 VSS.n2881 VSS.n2880 9.0005
R4731 VSS.n2713 VSS.t574 9.0005
R4732 VSS.n2890 VSS.n2889 9.0005
R4733 VSS.n2711 VSS.n2710 9.0005
R4734 VSS.n2899 VSS.n2898 9.0005
R4735 VSS.n2708 VSS.n2707 9.0005
R4736 VSS.n2908 VSS.n2907 9.0005
R4737 VSS.n2705 VSS.n2704 9.0005
R4738 VSS.n2917 VSS.n2916 9.0005
R4739 VSS.n2702 VSS.n2701 9.0005
R4740 VSS.n2926 VSS.n2925 9.0005
R4741 VSS.n2949 VSS.n2642 9.0005
R4742 VSS.n2948 VSS.n2641 9.0005
R4743 VSS.n2947 VSS.n2640 9.0005
R4744 VSS.n2946 VSS.n2639 9.0005
R4745 VSS.n2945 VSS.n2638 9.0005
R4746 VSS.n2944 VSS.n2637 9.0005
R4747 VSS.n2943 VSS.n2636 9.0005
R4748 VSS.n2942 VSS.n2635 9.0005
R4749 VSS.n2941 VSS.n2633 9.0005
R4750 VSS.n2940 VSS.n2632 9.0005
R4751 VSS.n2939 VSS.n2630 9.0005
R4752 VSS.n2938 VSS.n2628 9.0005
R4753 VSS.n2937 VSS.n2627 9.0005
R4754 VSS.n2936 VSS.n2626 9.0005
R4755 VSS.n2935 VSS.n2624 9.0005
R4756 VSS.n2934 VSS.n2623 9.0005
R4757 VSS.n2933 VSS.n2622 9.0005
R4758 VSS.n2932 VSS.n2621 9.0005
R4759 VSS.n2931 VSS.n2619 9.0005
R4760 VSS.n2930 VSS.n2617 9.0005
R4761 VSS.n2929 VSS.n2616 9.0005
R4762 VSS.n2928 VSS.n2927 9.0005
R4763 VSS.n2926 VSS.n2700 9.0005
R4764 VSS.n2924 VSS.n2922 9.0005
R4765 VSS.n2921 VSS.n2702 9.0005
R4766 VSS.n2920 VSS.n2919 9.0005
R4767 VSS.n2917 VSS.n2703 9.0005
R4768 VSS.n2915 VSS.n2913 9.0005
R4769 VSS.n2912 VSS.n2705 9.0005
R4770 VSS.n2911 VSS.n2910 9.0005
R4771 VSS.n2908 VSS.n2706 9.0005
R4772 VSS.n2906 VSS.n2904 9.0005
R4773 VSS.n2903 VSS.n2708 9.0005
R4774 VSS.n2902 VSS.n2901 9.0005
R4775 VSS.n2899 VSS.n2709 9.0005
R4776 VSS.n2897 VSS.n2895 9.0005
R4777 VSS.n2894 VSS.n2711 9.0005
R4778 VSS.n2893 VSS.n2892 9.0005
R4779 VSS.n2890 VSS.n2712 9.0005
R4780 VSS.n2888 VSS.n2886 9.0005
R4781 VSS.n2885 VSS.n2713 9.0005
R4782 VSS.n2884 VSS.n2883 9.0005
R4783 VSS.n2881 VSS.n2714 9.0005
R4784 VSS.n2879 VSS.n2877 9.0005
R4785 VSS.n2876 VSS.n2716 9.0005
R4786 VSS.n2875 VSS.n2874 9.0005
R4787 VSS.n2872 VSS.n2717 9.0005
R4788 VSS.n2870 VSS.n2868 9.0005
R4789 VSS.n2867 VSS.n2719 9.0005
R4790 VSS.n2866 VSS.n2865 9.0005
R4791 VSS.n2863 VSS.n2720 9.0005
R4792 VSS.n2862 VSS.n2860 9.0005
R4793 VSS.n2859 VSS.n2722 9.0005
R4794 VSS.n2858 VSS.n2857 9.0005
R4795 VSS.n2855 VSS.n2723 9.0005
R4796 VSS.n2853 VSS.n2851 9.0005
R4797 VSS.n2850 VSS.n2725 9.0005
R4798 VSS.n2849 VSS.n2848 9.0005
R4799 VSS.n2846 VSS.n2726 9.0005
R4800 VSS.n2844 VSS.n2842 9.0005
R4801 VSS.n2841 VSS.n2728 9.0005
R4802 VSS.n2840 VSS.n2839 9.0005
R4803 VSS.n2837 VSS.n2729 9.0005
R4804 VSS.n2835 VSS.n2833 9.0005
R4805 VSS.n2832 VSS.n2731 9.0005
R4806 VSS.n2831 VSS.n2830 9.0005
R4807 VSS.n2828 VSS.n2732 9.0005
R4808 VSS.n2826 VSS.n2824 9.0005
R4809 VSS.n2823 VSS.n2734 9.0005
R4810 VSS.n2822 VSS.n2821 9.0005
R4811 VSS.n2820 VSS.n2735 9.0005
R4812 VSS.n2818 VSS.n2816 9.0005
R4813 VSS.n2815 VSS.n2737 9.0005
R4814 VSS.n2814 VSS.n2813 9.0005
R4815 VSS.n2811 VSS.n2738 9.0005
R4816 VSS.n2809 VSS.n2807 9.0005
R4817 VSS.n2806 VSS.n2740 9.0005
R4818 VSS.n2805 VSS.n2804 9.0005
R4819 VSS.n2802 VSS.n2741 9.0005
R4820 VSS.n2800 VSS.n2799 9.0005
R4821 VSS.n2798 VSS.n2743 9.0005
R4822 VSS.n2797 VSS.n2796 9.0005
R4823 VSS.n2794 VSS.n2744 9.0005
R4824 VSS.n2792 VSS.n2790 9.0005
R4825 VSS.n2789 VSS.n2746 9.0005
R4826 VSS.n2788 VSS.n2787 9.0005
R4827 VSS.n2785 VSS.n2747 9.0005
R4828 VSS.n2783 VSS.n2781 9.0005
R4829 VSS.n2780 VSS.n2749 9.0005
R4830 VSS.n2779 VSS.n2778 9.0005
R4831 VSS.n2776 VSS.n2750 9.0005
R4832 VSS.n2774 VSS.n2772 9.0005
R4833 VSS.n2771 VSS.n2752 9.0005
R4834 VSS.n2770 VSS.n2769 9.0005
R4835 VSS.n2767 VSS.n2753 9.0005
R4836 VSS.n2765 VSS.n2763 9.0005
R4837 VSS.n2762 VSS.n2755 9.0005
R4838 VSS.n2761 VSS.n2760 9.0005
R4839 VSS.n2212 VSS.n2211 9.0005
R4840 VSS.n2213 VSS.n2211 9.0005
R4841 VSS.n3447 VSS.n3446 9.0005
R4842 VSS.n3447 VSS.n2210 9.0005
R4843 VSS.n3575 VSS.n3574 9.0005
R4844 VSS.n3714 VSS.n121 9.0005
R4845 VSS.n3712 VSS.n3711 9.0005
R4846 VSS.n3710 VSS.n3542 9.0005
R4847 VSS.n3709 VSS.n3541 9.0005
R4848 VSS.n3708 VSS.n3539 9.0005
R4849 VSS.n3707 VSS.n3537 9.0005
R4850 VSS.n3706 VSS.n3536 9.0005
R4851 VSS.n3699 VSS.n3523 9.0005
R4852 VSS.n3698 VSS.n3521 9.0005
R4853 VSS.n3691 VSS.n3690 9.0005
R4854 VSS.n3689 VSS.n3543 9.0005
R4855 VSS.n3674 VSS.n3673 9.0005
R4856 VSS.n3671 VSS.n3549 9.0005
R4857 VSS.n3602 VSS.n3601 9.0005
R4858 VSS.n3599 VSS.n3563 9.0005
R4859 VSS.n3597 VSS.n3565 9.0005
R4860 VSS.n3576 VSS.n3564 9.0005
R4861 VSS.n3669 VSS.n3552 9.0005
R4862 VSS.n3606 VSS.n3551 9.0005
R4863 VSS.n3609 VSS.n3607 9.0005
R4864 VSS.n3611 VSS.n3605 9.0005
R4865 VSS.n3612 VSS.n3604 9.0005
R4866 VSS.n3603 VSS.n3562 9.0005
R4867 VSS.n3687 VSS.n3685 9.0005
R4868 VSS.n3684 VSS.n3545 9.0005
R4869 VSS.n3683 VSS.n3682 9.0005
R4870 VSS.n3680 VSS.n3546 9.0005
R4871 VSS.n3678 VSS.n3676 9.0005
R4872 VSS.n3675 VSS.n3548 9.0005
R4873 VSS.n3697 VSS.n3520 9.0005
R4874 VSS.n3696 VSS.n3519 9.0005
R4875 VSS.n3695 VSS.n3518 9.0005
R4876 VSS.n3694 VSS.n3514 9.0005
R4877 VSS.n3693 VSS.n3513 9.0005
R4878 VSS.n3692 VSS.n3512 9.0005
R4879 VSS.n3705 VSS.n3535 9.0005
R4880 VSS.n3704 VSS.n3534 9.0005
R4881 VSS.n3703 VSS.n3531 9.0005
R4882 VSS.n3702 VSS.n3528 9.0005
R4883 VSS.n3701 VSS.n3527 9.0005
R4884 VSS.n3700 VSS.n3526 9.0005
R4885 VSS.n3450 VSS.n2205 9.0005
R4886 VSS.n3452 VSS.n3451 9.0005
R4887 VSS.n3453 VSS.n2203 9.0005
R4888 VSS.n3455 VSS.n3454 9.0005
R4889 VSS.n2263 VSS.n2262 9.0005
R4890 VSS.n2260 VSS.n2259 9.0005
R4891 VSS.n2252 VSS.n2206 9.0005
R4892 VSS.n2255 VSS.n2251 9.0005
R4893 VSS.n2256 VSS.n2250 9.0005
R4894 VSS.n3456 VSS.n2202 9.0005
R4895 VSS.n3800 VSS.n3799 9.0005
R4896 VSS.n3801 VSS.n3798 9.0005
R4897 VSS.n3797 VSS.n150 9.0005
R4898 VSS.n3796 VSS.n149 9.0005
R4899 VSS.n3795 VSS.n148 9.0005
R4900 VSS.n3794 VSS.n146 9.0005
R4901 VSS.n3793 VSS.n145 9.0005
R4902 VSS.n3379 VSS.n152 9.0005
R4903 VSS.n3382 VSS.n3380 9.0005
R4904 VSS.n3396 VSS.n3372 9.0005
R4905 VSS.n3398 VSS.n3371 9.0005
R4906 VSS.n3412 VSS.n3364 9.0005
R4907 VSS.n3414 VSS.n3363 9.0005
R4908 VSS.n3416 VSS.n3362 9.0005
R4909 VSS.n3418 VSS.n3361 9.0005
R4910 VSS.n3420 VSS.n3360 9.0005
R4911 VSS.n3423 VSS.n3422 9.0005
R4912 VSS.n3400 VSS.n3370 9.0005
R4913 VSS.n3402 VSS.n3369 9.0005
R4914 VSS.n3404 VSS.n3368 9.0005
R4915 VSS.n3406 VSS.n3367 9.0005
R4916 VSS.n3408 VSS.n3366 9.0005
R4917 VSS.n3410 VSS.n3365 9.0005
R4918 VSS.n3384 VSS.n3378 9.0005
R4919 VSS.n3386 VSS.n3377 9.0005
R4920 VSS.n3388 VSS.n3376 9.0005
R4921 VSS.n3390 VSS.n3375 9.0005
R4922 VSS.n3392 VSS.n3374 9.0005
R4923 VSS.n3394 VSS.n3373 9.0005
R4924 VSS.n3792 VSS.n144 9.0005
R4925 VSS.n3791 VSS.n142 9.0005
R4926 VSS.n3790 VSS.n140 9.0005
R4927 VSS.n3789 VSS.n139 9.0005
R4928 VSS.n3788 VSS.n3787 9.0005
R4929 VSS.n3786 VSS.n151 9.0005
R4930 VSS.n3854 VSS.n3853 9.0005
R4931 VSS.n3852 VSS.n124 9.0005
R4932 VSS.n3843 VSS.n125 9.0005
R4933 VSS.n3845 VSS.n3844 9.0005
R4934 VSS.n3842 VSS.n127 9.0005
R4935 VSS.n3841 VSS.n3840 9.0005
R4936 VSS.n129 VSS.n128 9.0005
R4937 VSS.n3832 VSS.n3831 9.0005
R4938 VSS.n3830 VSS.n131 9.0005
R4939 VSS.n3829 VSS.n3828 9.0005
R4940 VSS.n133 VSS.n132 9.0005
R4941 VSS.n2994 VSS.n2698 9.0005
R4942 VSS.n2993 VSS.n2697 9.0005
R4943 VSS.n2992 VSS.n2696 9.0005
R4944 VSS.n2991 VSS.n2695 9.0005
R4945 VSS.n2990 VSS.n2694 9.0005
R4946 VSS.n2989 VSS.n2692 9.0005
R4947 VSS.n2988 VSS.n2691 9.0005
R4948 VSS.n2987 VSS.n2689 9.0005
R4949 VSS.n2986 VSS.n2688 9.0005
R4950 VSS.n2985 VSS.n2687 9.0005
R4951 VSS.n2984 VSS.n2686 9.0005
R4952 VSS.n2983 VSS.n2685 9.0005
R4953 VSS.n2982 VSS.n2684 9.0005
R4954 VSS.n2981 VSS.n2683 9.0005
R4955 VSS.n2980 VSS.n2682 9.0005
R4956 VSS.n2979 VSS.n2681 9.0005
R4957 VSS.n2978 VSS.n2680 9.0005
R4958 VSS.n2977 VSS.n2679 9.0005
R4959 VSS.n2976 VSS.n2678 9.0005
R4960 VSS.n2975 VSS.n2676 9.0005
R4961 VSS.n2974 VSS.n2675 9.0005
R4962 VSS.n2973 VSS.n2673 9.0005
R4963 VSS.n2972 VSS.n2671 9.0005
R4964 VSS.n2971 VSS.n2670 9.0005
R4965 VSS.n2970 VSS.n2669 9.0005
R4966 VSS.n2969 VSS.n2668 9.0005
R4967 VSS.n2968 VSS.n2667 9.0005
R4968 VSS.n2967 VSS.n2665 9.0005
R4969 VSS.n2966 VSS.n2664 9.0005
R4970 VSS.n2965 VSS.n2663 9.0005
R4971 VSS.n2964 VSS.n2661 9.0005
R4972 VSS.n2963 VSS.n2660 9.0005
R4973 VSS.n2962 VSS.n2659 9.0005
R4974 VSS.n2961 VSS.n2657 9.0005
R4975 VSS.n2960 VSS.n2656 9.0005
R4976 VSS.n2959 VSS.n2655 9.0005
R4977 VSS.n2958 VSS.n2653 9.0005
R4978 VSS.n2957 VSS.n2652 9.0005
R4979 VSS.n2956 VSS.n2651 9.0005
R4980 VSS.n2955 VSS.n2649 9.0005
R4981 VSS.n2954 VSS.n2647 9.0005
R4982 VSS.n2953 VSS.n2646 9.0005
R4983 VSS.n2952 VSS.n2644 9.0005
R4984 VSS.n2951 VSS.n2643 9.0005
R4985 VSS.n3655 VSS.n3653 9.0005
R4986 VSS.n3657 VSS.n3628 9.0005
R4987 VSS.n3659 VSS.n3627 9.0005
R4988 VSS.n3661 VSS.n3626 9.0005
R4989 VSS.n3663 VSS.n3625 9.0005
R4990 VSS.n3589 VSS.n3587 9.0005
R4991 VSS.n3591 VSS.n3585 9.0005
R4992 VSS.n3592 VSS.n3584 9.0005
R4993 VSS.n3583 VSS.n3566 9.0005
R4994 VSS.n3664 VSS.n3624 9.0005
R4995 VSS.n3623 VSS.n3554 9.0005
R4996 VSS.n3622 VSS.n3621 9.0005
R4997 VSS.n3619 VSS.n3555 9.0005
R4998 VSS.n3617 VSS.n3557 9.0005
R4999 VSS.n3586 VSS.n3556 9.0005
R5000 VSS.n3630 VSS.n3495 9.0005
R5001 VSS.n3631 VSS.n3494 9.0005
R5002 VSS.n3632 VSS.n3493 9.0005
R5003 VSS.n3633 VSS.n3492 9.0005
R5004 VSS.n3634 VSS.n3491 9.0005
R5005 VSS.n3635 VSS.n3489 9.0005
R5006 VSS.n3638 VSS.n3637 9.0005
R5007 VSS.n3639 VSS.n3486 9.0005
R5008 VSS.n3640 VSS.n3485 9.0005
R5009 VSS.n3647 VSS.n3478 9.0005
R5010 VSS.n3649 VSS.n3648 9.0005
R5011 VSS.n3652 VSS.n3651 9.0005
R5012 VSS.n3641 VSS.n3484 9.0005
R5013 VSS.n3642 VSS.n3483 9.0005
R5014 VSS.n3643 VSS.n3482 9.0005
R5015 VSS.n3644 VSS.n3481 9.0005
R5016 VSS.n3645 VSS.n3480 9.0005
R5017 VSS.n3646 VSS.n3479 9.0005
R5018 VSS.n3508 VSS.n3506 9.0005
R5019 VSS.n3507 VSS.n3502 9.0005
R5020 VSS.n1520 VSS.n1519 9.0005
R5021 VSS.n1525 VSS.n1067 9.0005
R5022 VSS.n1076 VSS.n1074 9.0005
R5023 VSS.n1524 VSS.n1073 9.0005
R5024 VSS.n1485 VSS.n1482 9.0005
R5025 VSS.n1486 VSS.n1481 9.0005
R5026 VSS.n1480 VSS.n1477 9.0005
R5027 VSS.n1489 VSS.n1476 9.0005
R5028 VSS.n1490 VSS.n1475 9.0005
R5029 VSS.n1474 VSS.n1471 9.0005
R5030 VSS.n1494 VSS.n1470 9.0005
R5031 VSS.n1495 VSS.n1469 9.0005
R5032 VSS.n1468 VSS.n1465 9.0005
R5033 VSS.n1498 VSS.n1464 9.0005
R5034 VSS.n1499 VSS.n1463 9.0005
R5035 VSS.n1462 VSS.n1459 9.0005
R5036 VSS.n1503 VSS.n1458 9.0005
R5037 VSS.n1504 VSS.n1457 9.0005
R5038 VSS.n1086 VSS.n1085 9.0005
R5039 VSS.n1507 VSS.n1506 9.0005
R5040 VSS.n1508 VSS.n1083 9.0005
R5041 VSS.n1510 VSS.n1509 9.0005
R5042 VSS.n1084 VSS.n1079 9.0005
R5043 VSS.n1516 VSS.n1077 9.0005
R5044 VSS.n1518 VSS.n1517 9.0005
R5045 VSS.n1529 VSS.n1528 9.0005
R5046 VSS.n1533 VSS.n1058 9.0005
R5047 VSS.n1530 VSS.n1066 9.0005
R5048 VSS.n1532 VSS.n1531 9.0005
R5049 VSS.n1535 VSS.n1534 9.0005
R5050 VSS.n1539 VSS.n1051 9.0005
R5051 VSS.n1536 VSS.n1057 9.0005
R5052 VSS.n1538 VSS.n1537 9.0005
R5053 VSS.n1543 VSS.n1542 9.0005
R5054 VSS.n1547 VSS.n1042 9.0005
R5055 VSS.n1544 VSS.n1050 9.0005
R5056 VSS.n1546 VSS.n1545 9.0005
R5057 VSS.n1549 VSS.n1548 9.0005
R5058 VSS.n1553 VSS.n1035 9.0005
R5059 VSS.n1550 VSS.n1041 9.0005
R5060 VSS.n1552 VSS.n1551 9.0005
R5061 VSS.n1557 VSS.n1556 9.0005
R5062 VSS.n1561 VSS.n1026 9.0005
R5063 VSS.n1558 VSS.n1034 9.0005
R5064 VSS.n1560 VSS.n1559 9.0005
R5065 VSS.n1563 VSS.n1562 9.0005
R5066 VSS.n1567 VSS.n1019 9.0005
R5067 VSS.n1564 VSS.n1025 9.0005
R5068 VSS.n1566 VSS.n1565 9.0005
R5069 VSS.n1571 VSS.n1570 9.0005
R5070 VSS.n1575 VSS.n1010 9.0005
R5071 VSS.n1572 VSS.n1018 9.0005
R5072 VSS.n1574 VSS.n1573 9.0005
R5073 VSS.n1577 VSS.n1576 9.0005
R5074 VSS.n1581 VSS.n1003 9.0005
R5075 VSS.n1578 VSS.n1009 9.0005
R5076 VSS.n1580 VSS.n1579 9.0005
R5077 VSS.n1585 VSS.n1584 9.0005
R5078 VSS.n1589 VSS.n994 9.0005
R5079 VSS.n1586 VSS.n1002 9.0005
R5080 VSS.n1588 VSS.n1587 9.0005
R5081 VSS.n1591 VSS.n1590 9.0005
R5082 VSS.n1595 VSS.n987 9.0005
R5083 VSS.n1592 VSS.n993 9.0005
R5084 VSS.n1594 VSS.n1593 9.0005
R5085 VSS.n1599 VSS.n1598 9.0005
R5086 VSS.n1603 VSS.n978 9.0005
R5087 VSS.n1600 VSS.n986 9.0005
R5088 VSS.n1602 VSS.n1601 9.0005
R5089 VSS.n1605 VSS.n1604 9.0005
R5090 VSS.n1609 VSS.n971 9.0005
R5091 VSS.n1606 VSS.n977 9.0005
R5092 VSS.n1608 VSS.n1607 9.0005
R5093 VSS.n1613 VSS.n1612 9.0005
R5094 VSS.n1617 VSS.n962 9.0005
R5095 VSS.n1614 VSS.n970 9.0005
R5096 VSS.n1616 VSS.n1615 9.0005
R5097 VSS.n1619 VSS.n1618 9.0005
R5098 VSS.n1623 VSS.n955 9.0005
R5099 VSS.n1620 VSS.n961 9.0005
R5100 VSS.n1622 VSS.n1621 9.0005
R5101 VSS.n1627 VSS.n1626 9.0005
R5102 VSS.n1631 VSS.n946 9.0005
R5103 VSS.n1628 VSS.n954 9.0005
R5104 VSS.n1630 VSS.n1629 9.0005
R5105 VSS.n1633 VSS.n1632 9.0005
R5106 VSS.n1637 VSS.n939 9.0005
R5107 VSS.n1634 VSS.n945 9.0005
R5108 VSS.n1636 VSS.n1635 9.0005
R5109 VSS.n1641 VSS.n1640 9.0005
R5110 VSS.n1645 VSS.n930 9.0005
R5111 VSS.n1642 VSS.n938 9.0005
R5112 VSS.n1644 VSS.n1643 9.0005
R5113 VSS.n1647 VSS.n1646 9.0005
R5114 VSS.n1651 VSS.n923 9.0005
R5115 VSS.n1648 VSS.n929 9.0005
R5116 VSS.n1650 VSS.n1649 9.0005
R5117 VSS.n1655 VSS.n1654 9.0005
R5118 VSS.n1659 VSS.n914 9.0005
R5119 VSS.n1656 VSS.n922 9.0005
R5120 VSS.n1658 VSS.n1657 9.0005
R5121 VSS.n1661 VSS.n1660 9.0005
R5122 VSS.n1665 VSS.n907 9.0005
R5123 VSS.n1662 VSS.n913 9.0005
R5124 VSS.n1664 VSS.n1663 9.0005
R5125 VSS.n1669 VSS.n1668 9.0005
R5126 VSS.n1673 VSS.n898 9.0005
R5127 VSS.n1670 VSS.n906 9.0005
R5128 VSS.n1672 VSS.n1671 9.0005
R5129 VSS.n1675 VSS.n1674 9.0005
R5130 VSS.n1679 VSS.n891 9.0005
R5131 VSS.n1676 VSS.n897 9.0005
R5132 VSS.n1678 VSS.n1677 9.0005
R5133 VSS.n1683 VSS.n1682 9.0005
R5134 VSS.n1687 VSS.n882 9.0005
R5135 VSS.n1684 VSS.n890 9.0005
R5136 VSS.n1686 VSS.n1685 9.0005
R5137 VSS.n1689 VSS.n1688 9.0005
R5138 VSS.n1693 VSS.n875 9.0005
R5139 VSS.n1690 VSS.n881 9.0005
R5140 VSS.n1692 VSS.n1691 9.0005
R5141 VSS.n1697 VSS.n1696 9.0005
R5142 VSS.n1701 VSS.n866 9.0005
R5143 VSS.n1698 VSS.n874 9.0005
R5144 VSS.n1700 VSS.n1699 9.0005
R5145 VSS.n1703 VSS.n1702 9.0005
R5146 VSS.n1707 VSS.n859 9.0005
R5147 VSS.n1704 VSS.n865 9.0005
R5148 VSS.n1706 VSS.n1705 9.0005
R5149 VSS.n1711 VSS.n1710 9.0005
R5150 VSS.n1715 VSS.n850 9.0005
R5151 VSS.n1712 VSS.n858 9.0005
R5152 VSS.n1714 VSS.n1713 9.0005
R5153 VSS.n1717 VSS.n1716 9.0005
R5154 VSS.n1721 VSS.n843 9.0005
R5155 VSS.n1718 VSS.n849 9.0005
R5156 VSS.n1720 VSS.n1719 9.0005
R5157 VSS.n1725 VSS.n1724 9.0005
R5158 VSS.n1729 VSS.n841 9.0005
R5159 VSS.n1726 VSS.n842 9.0005
R5160 VSS.n1728 VSS.n1727 9.0005
R5161 VSS.n1730 VSS.n836 9.0005
R5162 VSS.n1737 VSS.n1736 9.0005
R5163 VSS.n1731 VSS.n835 9.0005
R5164 VSS.n832 VSS.n831 9.0005
R5165 VSS.n1160 VSS.n1159 9.0005
R5166 VSS.n1448 VSS.n1447 9.0005
R5167 VSS.n1446 VSS.n1088 9.0005
R5168 VSS.n1445 VSS.n1444 9.0005
R5169 VSS.n1090 VSS.n1089 9.0005
R5170 VSS.n1432 VSS.n1431 9.0005
R5171 VSS.n1430 VSS.n1429 9.0005
R5172 VSS.n1093 VSS.n1092 9.0005
R5173 VSS.n1423 VSS.n1422 9.0005
R5174 VSS.n1421 VSS.n1420 9.0005
R5175 VSS.n1095 VSS.n1094 9.0005
R5176 VSS.n1414 VSS.n1413 9.0005
R5177 VSS.n1412 VSS.n1411 9.0005
R5178 VSS.n1097 VSS.n1096 9.0005
R5179 VSS.n1405 VSS.n1404 9.0005
R5180 VSS.n1403 VSS.n1402 9.0005
R5181 VSS.n1099 VSS.n1098 9.0005
R5182 VSS.n1396 VSS.n1395 9.0005
R5183 VSS.n1394 VSS.n1393 9.0005
R5184 VSS.n1101 VSS.n1100 9.0005
R5185 VSS.n1387 VSS.n1386 9.0005
R5186 VSS.n1385 VSS.n1384 9.0005
R5187 VSS.n1103 VSS.n1102 9.0005
R5188 VSS.n1378 VSS.n1377 9.0005
R5189 VSS.n1376 VSS.n1375 9.0005
R5190 VSS.n1105 VSS.n1104 9.0005
R5191 VSS.n1369 VSS.n1368 9.0005
R5192 VSS.n1367 VSS.n1366 9.0005
R5193 VSS.n1107 VSS.n1106 9.0005
R5194 VSS.n1360 VSS.n1359 9.0005
R5195 VSS.n1358 VSS.n1357 9.0005
R5196 VSS.n1109 VSS.n1108 9.0005
R5197 VSS.n1351 VSS.n1350 9.0005
R5198 VSS.n1349 VSS.n1348 9.0005
R5199 VSS.n1111 VSS.n1110 9.0005
R5200 VSS.n1342 VSS.n1341 9.0005
R5201 VSS.n1340 VSS.n1339 9.0005
R5202 VSS.n1113 VSS.n1112 9.0005
R5203 VSS.n1333 VSS.n1332 9.0005
R5204 VSS.n1331 VSS.n1330 9.0005
R5205 VSS.n1115 VSS.n1114 9.0005
R5206 VSS.n1324 VSS.n1323 9.0005
R5207 VSS.n1322 VSS.n1321 9.0005
R5208 VSS.n1117 VSS.n1116 9.0005
R5209 VSS.n1315 VSS.n1314 9.0005
R5210 VSS.n1313 VSS.n1312 9.0005
R5211 VSS.n1119 VSS.n1118 9.0005
R5212 VSS.n1306 VSS.n1305 9.0005
R5213 VSS.n1304 VSS.n1303 9.0005
R5214 VSS.n1121 VSS.n1120 9.0005
R5215 VSS.n1297 VSS.n1296 9.0005
R5216 VSS.n1295 VSS.n1294 9.0005
R5217 VSS.n1123 VSS.n1122 9.0005
R5218 VSS.n1288 VSS.n1287 9.0005
R5219 VSS.n1286 VSS.n1285 9.0005
R5220 VSS.n1125 VSS.n1124 9.0005
R5221 VSS.n1279 VSS.n1278 9.0005
R5222 VSS.n1277 VSS.n1276 9.0005
R5223 VSS.n1127 VSS.n1126 9.0005
R5224 VSS.n1270 VSS.n1269 9.0005
R5225 VSS.n1268 VSS.n1267 9.0005
R5226 VSS.n1129 VSS.n1128 9.0005
R5227 VSS.n1261 VSS.n1260 9.0005
R5228 VSS.n1259 VSS.n1258 9.0005
R5229 VSS.n1131 VSS.n1130 9.0005
R5230 VSS.n1252 VSS.n1251 9.0005
R5231 VSS.n1250 VSS.n1249 9.0005
R5232 VSS.n1133 VSS.n1132 9.0005
R5233 VSS.n1243 VSS.n1242 9.0005
R5234 VSS.n1241 VSS.n1240 9.0005
R5235 VSS.n1135 VSS.n1134 9.0005
R5236 VSS.n1234 VSS.n1233 9.0005
R5237 VSS.n1232 VSS.n1231 9.0005
R5238 VSS.n1137 VSS.n1136 9.0005
R5239 VSS.n1225 VSS.n1224 9.0005
R5240 VSS.n1223 VSS.n1222 9.0005
R5241 VSS.n1139 VSS.n1138 9.0005
R5242 VSS.n1216 VSS.n1215 9.0005
R5243 VSS.n1214 VSS.n1213 9.0005
R5244 VSS.n1141 VSS.n1140 9.0005
R5245 VSS.n1207 VSS.n1206 9.0005
R5246 VSS.n1205 VSS.n1204 9.0005
R5247 VSS.n1143 VSS.n1142 9.0005
R5248 VSS.n1198 VSS.n1197 9.0005
R5249 VSS.n1196 VSS.n1195 9.0005
R5250 VSS.n1145 VSS.n1144 9.0005
R5251 VSS.n1189 VSS.n1188 9.0005
R5252 VSS.n1187 VSS.n1186 9.0005
R5253 VSS.n1147 VSS.n1146 9.0005
R5254 VSS.n1180 VSS.n1179 9.0005
R5255 VSS.n1178 VSS.n1177 9.0005
R5256 VSS.n1149 VSS.n1148 9.0005
R5257 VSS.n1171 VSS.n1170 9.0005
R5258 VSS.n1169 VSS.n1168 9.0005
R5259 VSS.n1151 VSS.n1150 9.0005
R5260 VSS.n1162 VSS.n1161 9.0005
R5261 VSS.n2119 VSS.t64 8.501
R5262 VSS.t67 VSS.n223 8.501
R5263 VSS.t69 VSS.n278 8.501
R5264 VSS.t74 VSS.n283 8.501
R5265 VSS.t79 VSS.n299 8.501
R5266 VSS.n1987 VSS.t82 8.501
R5267 VSS.t84 VSS.n1979 8.501
R5268 VSS.t89 VSS.n322 8.501
R5269 VSS.t94 VSS.n338 8.501
R5270 VSS.n1940 VSS.t97 8.501
R5271 VSS.t99 VSS.n1932 8.501
R5272 VSS.t104 VSS.n361 8.501
R5273 VSS.t109 VSS.n398 8.501
R5274 VSS.n1854 VSS.t112 8.501
R5275 VSS.t114 VSS.n1846 8.501
R5276 VSS.t119 VSS.n445 8.501
R5277 VSS.t124 VSS.n461 8.501
R5278 VSS.n1807 VSS.t127 8.501
R5279 VSS.t129 VSS.n1799 8.501
R5280 VSS.t134 VSS.n484 8.501
R5281 VSS.t139 VSS.n500 8.501
R5282 VSS.n1760 VSS.t142 8.501
R5283 VSS.t144 VSS.n1752 8.501
R5284 VSS.t150 VSS.n523 8.501
R5285 VSS.n11 VSS.n36 1.88985
R5286 VSS.n38 VSS.n39 0.00149997
R5287 VSS.n11 VSS.n40 3.40102
R5288 VSS.n11 VSS.n43 4.25113
R5289 VSS.n3763 VSS.n44 3.40102
R5290 VSS.n3763 VSS.n46 3.40102
R5291 VSS.n49 VSS.n48 0.00216499
R5292 VSS.n48 VSS.n50 0.00173273
R5293 VSS.n50 VSS.n51 0.00172462
R5294 VSS.n51 VSS.n52 0.00170812
R5295 VSS.n52 VSS.n53 0.00166658
R5296 VSS.n53 VSS.n54 0.00149997
R5297 VSS.n3763 VSS.n56 2.12578
R5298 VSS.n55 VSS.n56 0.00166651
R5299 VSS.n55 VSS.n58 0.00158329
R5300 VSS.n3763 VSS.n61 1.54642
R5301 VSS.n62 VSS.n64 0.00158329
R5302 VSS.n12 VSS.n3737 0.772679
R5303 VSS.n12 VSS.n10 0.00174311
R5304 VSS.n10 VSS.n13 0.00174253
R5305 VSS.n13 VSS.n14 0.00174154
R5306 VSS.n14 VSS.n15 0.0017399
R5307 VSS.n15 VSS.n16 0.00173723
R5308 VSS.n16 VSS.n17 0.00173273
R5309 VSS.n17 VSS.n18 0.00172462
R5310 VSS.n18 VSS.n19 0.00170812
R5311 VSS.n19 VSS.n20 0.00166658
R5312 VSS.n20 VSS.n21 0.00149997
R5313 VSS.n3737 VSS.n22 3.40102
R5314 VSS.n25 VSS.n24 0.00214918
R5315 VSS.n24 VSS.n26 0.00172539
R5316 VSS.n26 VSS.n27 0.00171613
R5317 VSS.n27 VSS.n28 0.00169968
R5318 VSS.n28 VSS.n29 0.00166651
R5319 VSS.n29 VSS.n30 0.00158329
R5320 VSS.n3000 VSS.n2998 8.501
R5321 VSS.n3000 VSS.n2997 8.501
R5322 VSS.n3005 VSS.n3003 8.501
R5323 VSS.n3005 VSS.n3002 8.501
R5324 VSS.n3008 VSS.n109 2.4296
R5325 VSS.n3008 VSS.n114 3.40102
R5326 VSS.n3008 VSS.n111 2.83428
R5327 VSS.n111 VSS.n116 0.00158329
R5328 VSS.n86 VSS.n3137 2.60139
R5329 VSS.n89 VSS.n88 0.00215535
R5330 VSS.n88 VSS.n90 0.00174154
R5331 VSS.n90 VSS.n91 0.0017399
R5332 VSS.n91 VSS.n92 0.00173723
R5333 VSS.n92 VSS.n93 0.00173273
R5334 VSS.n93 VSS.n94 0.00172462
R5335 VSS.n94 VSS.n95 0.00170812
R5336 VSS.n95 VSS.n96 0.00166658
R5337 VSS.n96 VSS.n97 0.00149997
R5338 VSS.n3137 VSS.n98 3.40102
R5339 VSS.n3137 VSS.n100 3.40102
R5340 VSS.n3137 VSS.n103 1.88985
R5341 VSS.n105 VSS.n106 0.00149997
R5342 VSS.n3444 VSS.n7 5.41263
R5343 VSS.n551 VSS.n217 8.5005
R5344 VSS.n554 VSS.n217 8.5005
R5345 VSS.n555 VSS.n217 8.5005
R5346 VSS.n557 VSS.n217 8.5005
R5347 VSS.n560 VSS.n217 8.5005
R5348 VSS.n561 VSS.n217 8.5005
R5349 VSS.n562 VSS.n217 8.5005
R5350 VSS.n563 VSS.n217 8.5005
R5351 VSS.n564 VSS.n217 8.5005
R5352 VSS.n565 VSS.n217 8.5005
R5353 VSS.n568 VSS.n217 8.5005
R5354 VSS.n569 VSS.n217 8.5005
R5355 VSS.n571 VSS.n217 8.5005
R5356 VSS.n574 VSS.n217 8.5005
R5357 VSS.n575 VSS.n217 8.5005
R5358 VSS.n576 VSS.n217 8.5005
R5359 VSS.n577 VSS.n217 8.5005
R5360 VSS.n578 VSS.n217 8.5005
R5361 VSS.n579 VSS.n217 8.5005
R5362 VSS.n582 VSS.n217 8.5005
R5363 VSS.n583 VSS.n217 8.5005
R5364 VSS.n585 VSS.n217 8.5005
R5365 VSS.n588 VSS.n217 8.5005
R5366 VSS.n589 VSS.n217 8.5005
R5367 VSS.n590 VSS.n217 8.5005
R5368 VSS.n591 VSS.n217 8.5005
R5369 VSS.n592 VSS.n217 8.5005
R5370 VSS.n593 VSS.n217 8.5005
R5371 VSS.n596 VSS.n217 8.5005
R5372 VSS.n597 VSS.n217 8.5005
R5373 VSS.n599 VSS.n217 8.5005
R5374 VSS.n602 VSS.n217 8.5005
R5375 VSS.n603 VSS.n217 8.5005
R5376 VSS.n604 VSS.n217 8.5005
R5377 VSS.n605 VSS.n217 8.5005
R5378 VSS.n606 VSS.n217 8.5005
R5379 VSS.n607 VSS.n217 8.5005
R5380 VSS.n610 VSS.n217 8.5005
R5381 VSS.n611 VSS.n217 8.5005
R5382 VSS.n613 VSS.n217 8.5005
R5383 VSS.n616 VSS.n217 8.5005
R5384 VSS.n617 VSS.n217 8.5005
R5385 VSS.n618 VSS.n217 8.5005
R5386 VSS.n619 VSS.n217 8.5005
R5387 VSS.n620 VSS.n217 8.5005
R5388 VSS.n621 VSS.n217 8.5005
R5389 VSS.n624 VSS.n217 8.5005
R5390 VSS.n625 VSS.n217 8.5005
R5391 VSS.n627 VSS.n217 8.5005
R5392 VSS.n630 VSS.n217 8.5005
R5393 VSS.n631 VSS.n217 8.5005
R5394 VSS.n632 VSS.n217 8.5005
R5395 VSS.n633 VSS.n217 8.5005
R5396 VSS.n634 VSS.n217 8.5005
R5397 VSS.n635 VSS.n217 8.5005
R5398 VSS.n638 VSS.n217 8.5005
R5399 VSS.n639 VSS.n217 8.5005
R5400 VSS.n641 VSS.n217 8.5005
R5401 VSS.n644 VSS.n217 8.5005
R5402 VSS.n645 VSS.n217 8.5005
R5403 VSS.n646 VSS.n217 8.5005
R5404 VSS.n647 VSS.n217 8.5005
R5405 VSS.n648 VSS.n217 8.5005
R5406 VSS.n649 VSS.n217 8.5005
R5407 VSS.n652 VSS.n217 8.5005
R5408 VSS.n653 VSS.n217 8.5005
R5409 VSS.n655 VSS.n217 8.5005
R5410 VSS.n658 VSS.n217 8.5005
R5411 VSS.n659 VSS.n217 8.5005
R5412 VSS.n660 VSS.n217 8.5005
R5413 VSS.n661 VSS.n217 8.5005
R5414 VSS.n662 VSS.n217 8.5005
R5415 VSS.n663 VSS.n217 8.5005
R5416 VSS.n666 VSS.n217 8.5005
R5417 VSS.n667 VSS.n217 8.5005
R5418 VSS.n669 VSS.n217 8.5005
R5419 VSS.n672 VSS.n217 8.5005
R5420 VSS.n673 VSS.n217 8.5005
R5421 VSS.n674 VSS.n217 8.5005
R5422 VSS.n675 VSS.n217 8.5005
R5423 VSS.n676 VSS.n217 8.5005
R5424 VSS.n677 VSS.n217 8.5005
R5425 VSS.n680 VSS.n217 8.5005
R5426 VSS.n681 VSS.n217 8.5005
R5427 VSS.n683 VSS.n217 8.5005
R5428 VSS.n686 VSS.n217 8.5005
R5429 VSS.n687 VSS.n217 8.5005
R5430 VSS.n688 VSS.n217 8.5005
R5431 VSS.n689 VSS.n217 8.5005
R5432 VSS.n690 VSS.n217 8.5005
R5433 VSS.n691 VSS.n217 8.5005
R5434 VSS.n694 VSS.n217 8.5005
R5435 VSS.n695 VSS.n217 8.5005
R5436 VSS.n697 VSS.n217 8.5005
R5437 VSS.n700 VSS.n217 8.5005
R5438 VSS.n701 VSS.n217 8.5005
R5439 VSS.n702 VSS.n217 8.5005
R5440 VSS.n703 VSS.n217 8.5005
R5441 VSS.n704 VSS.n217 8.5005
R5442 VSS.n705 VSS.n217 8.5005
R5443 VSS.n708 VSS.n217 8.5005
R5444 VSS.n709 VSS.n217 8.5005
R5445 VSS.n711 VSS.n217 8.5005
R5446 VSS.n714 VSS.n217 8.5005
R5447 VSS.n715 VSS.n217 8.5005
R5448 VSS.n716 VSS.n217 8.5005
R5449 VSS.n717 VSS.n217 8.5005
R5450 VSS.n718 VSS.n217 8.5005
R5451 VSS.n719 VSS.n217 8.5005
R5452 VSS.n722 VSS.n217 8.5005
R5453 VSS.n723 VSS.n217 8.5005
R5454 VSS.n725 VSS.n217 8.5005
R5455 VSS.n728 VSS.n217 8.5005
R5456 VSS.n729 VSS.n217 8.5005
R5457 VSS.n730 VSS.n217 8.5005
R5458 VSS.n731 VSS.n217 8.5005
R5459 VSS.n732 VSS.n217 8.5005
R5460 VSS.n733 VSS.n217 8.5005
R5461 VSS.n736 VSS.n217 8.5005
R5462 VSS.n737 VSS.n217 8.5005
R5463 VSS.n739 VSS.n217 8.5005
R5464 VSS.n742 VSS.n217 8.5005
R5465 VSS.n743 VSS.n217 8.5005
R5466 VSS.n744 VSS.n217 8.5005
R5467 VSS.n745 VSS.n217 8.5005
R5468 VSS.n746 VSS.n217 8.5005
R5469 VSS.n747 VSS.n217 8.5005
R5470 VSS.n750 VSS.n217 8.5005
R5471 VSS.n751 VSS.n217 8.5005
R5472 VSS.n753 VSS.n217 8.5005
R5473 VSS.n756 VSS.n217 8.5005
R5474 VSS.n757 VSS.n217 8.5005
R5475 VSS.n758 VSS.n217 8.5005
R5476 VSS.n759 VSS.n217 8.5005
R5477 VSS.n760 VSS.n217 8.5005
R5478 VSS.n761 VSS.n217 8.5005
R5479 VSS.n764 VSS.n217 8.5005
R5480 VSS.n765 VSS.n217 8.5005
R5481 VSS.n767 VSS.n217 8.5005
R5482 VSS.n770 VSS.n217 8.5005
R5483 VSS.n771 VSS.n217 8.5005
R5484 VSS.n772 VSS.n217 8.5005
R5485 VSS.n773 VSS.n217 8.5005
R5486 VSS.n774 VSS.n217 8.5005
R5487 VSS.n775 VSS.n217 8.5005
R5488 VSS.n67 VSS.n216 8.5005
R5489 VSS.n67 VSS.n214 8.5005
R5490 VSS.n67 VSS.n212 8.5005
R5491 VSS.n67 VSS.n208 8.5005
R5492 VSS.n67 VSS.n206 8.5005
R5493 VSS.n67 VSS.n204 8.5005
R5494 VSS.n67 VSS.n200 8.5005
R5495 VSS.n67 VSS.n199 8.5005
R5496 VSS.n67 VSS.n196 8.5005
R5497 VSS.n67 VSS.n193 8.5005
R5498 VSS.n67 VSS.n191 8.5005
R5499 VSS.n67 VSS.n188 8.5005
R5500 VSS.n67 VSS.n187 8.5005
R5501 VSS.n67 VSS.n184 8.5005
R5502 VSS.n8 VSS.n2240 8.5005
R5503 VSS.n8 VSS.n2229 8.5005
R5504 VSS.n1087 VSS.n217 8.49944
R5505 VSS.n1740 VSS.n529 8.49444
R5506 VSS.n2014 VSS.n291 8.49444
R5507 VSS.n1967 VSS.n330 8.49444
R5508 VSS.n1920 VSS.n369 8.49444
R5509 VSS.n1834 VSS.n453 8.49444
R5510 VSS.n1787 VSS.n492 8.49444
R5511 VSS.n3445 VSS.n8 8.48883
R5512 VSS.n8 VSS.n0 8.48883
R5513 VSS.n2356 VSS.n85 8.48665
R5514 VSS.n3439 VSS.n117 8.48472
R5515 VSS.n88 VSS.n87 8.47784
R5516 VSS.n3124 VSS.n90 8.47784
R5517 VSS.n3125 VSS.n91 8.47784
R5518 VSS.n3126 VSS.n92 8.47784
R5519 VSS.n3127 VSS.n93 8.47784
R5520 VSS.n3128 VSS.n94 8.47784
R5521 VSS.n3129 VSS.n95 8.47784
R5522 VSS.n3130 VSS.n96 8.47784
R5523 VSS.n3131 VSS.n97 8.47784
R5524 VSS.n3133 VSS.n99 8.47784
R5525 VSS.n3135 VSS.n102 8.47784
R5526 VSS.n3121 VSS.n104 8.47784
R5527 VSS.n3120 VSS.n105 8.47784
R5528 VSS.n3119 VSS.n106 8.47784
R5529 VSS.n1487 VSS.n217 8.47732
R5530 VSS.n1478 VSS.n217 8.47732
R5531 VSS.n1473 VSS.n217 8.47732
R5532 VSS.n1492 VSS.n217 8.47732
R5533 VSS.t202 VSS.n217 8.47732
R5534 VSS.n1466 VSS.n217 8.47732
R5535 VSS.n1461 VSS.n217 8.47732
R5536 VSS.n1456 VSS.n217 8.47732
R5537 VSS.n1455 VSS.n217 8.47732
R5538 VSS.n1454 VSS.n217 8.47732
R5539 VSS.n829 VSS.n217 8.47732
R5540 VSS.n1157 VSS.n217 8.47732
R5541 VSS.n1166 VSS.n217 8.47732
R5542 VSS.n1175 VSS.n217 8.47732
R5543 VSS.n1184 VSS.n217 8.47732
R5544 VSS.n1193 VSS.n217 8.47732
R5545 VSS.n1202 VSS.n217 8.47732
R5546 VSS.n1211 VSS.n217 8.47732
R5547 VSS.n1220 VSS.n217 8.47732
R5548 VSS.n1229 VSS.n217 8.47732
R5549 VSS.n1238 VSS.n217 8.47732
R5550 VSS.n1247 VSS.n217 8.47732
R5551 VSS.n1256 VSS.n217 8.47732
R5552 VSS.n1265 VSS.n217 8.47732
R5553 VSS.n1274 VSS.n217 8.47732
R5554 VSS.n1283 VSS.n217 8.47732
R5555 VSS.n1292 VSS.n217 8.47732
R5556 VSS.n1301 VSS.n217 8.47732
R5557 VSS.n1310 VSS.n217 8.47732
R5558 VSS.n1319 VSS.n217 8.47732
R5559 VSS.n1328 VSS.n217 8.47732
R5560 VSS.n1337 VSS.n217 8.47732
R5561 VSS.n1346 VSS.n217 8.47732
R5562 VSS.n1355 VSS.n217 8.47732
R5563 VSS.n1364 VSS.n217 8.47732
R5564 VSS.n1373 VSS.n217 8.47732
R5565 VSS.n1382 VSS.n217 8.47732
R5566 VSS.n1391 VSS.n217 8.47732
R5567 VSS.n1400 VSS.n217 8.47732
R5568 VSS.n1409 VSS.n217 8.47732
R5569 VSS.n1418 VSS.n217 8.47732
R5570 VSS.n1427 VSS.n217 8.47732
R5571 VSS.n1436 VSS.n217 8.47732
R5572 VSS.n1441 VSS.n217 8.47732
R5573 VSS.n1512 VSS.n217 8.47732
R5574 VSS.n1080 VSS.n217 8.47732
R5575 VSS.n1521 VSS.n217 8.47732
R5576 VSS.n1523 VSS.n217 8.47732
R5577 VSS.n1069 VSS.n217 8.47732
R5578 VSS.n1065 VSS.n217 8.47732
R5579 VSS.n1061 VSS.n217 8.47732
R5580 VSS.n1059 VSS.n217 8.47732
R5581 VSS.n1053 VSS.n217 8.47732
R5582 VSS.n1049 VSS.n217 8.47732
R5583 VSS.n1045 VSS.n217 8.47732
R5584 VSS.n1043 VSS.n217 8.47732
R5585 VSS.n1037 VSS.n217 8.47732
R5586 VSS.n1033 VSS.n217 8.47732
R5587 VSS.n1029 VSS.n217 8.47732
R5588 VSS.n1027 VSS.n217 8.47732
R5589 VSS.n1021 VSS.n217 8.47732
R5590 VSS.n1017 VSS.n217 8.47732
R5591 VSS.n1013 VSS.n217 8.47732
R5592 VSS.n1011 VSS.n217 8.47732
R5593 VSS.n1005 VSS.n217 8.47732
R5594 VSS.n1001 VSS.n217 8.47732
R5595 VSS.n997 VSS.n217 8.47732
R5596 VSS.n995 VSS.n217 8.47732
R5597 VSS.n989 VSS.n217 8.47732
R5598 VSS.n985 VSS.n217 8.47732
R5599 VSS.n981 VSS.n217 8.47732
R5600 VSS.n979 VSS.n217 8.47732
R5601 VSS.n973 VSS.n217 8.47732
R5602 VSS.n969 VSS.n217 8.47732
R5603 VSS.n965 VSS.n217 8.47732
R5604 VSS.n963 VSS.n217 8.47732
R5605 VSS.n957 VSS.n217 8.47732
R5606 VSS.n953 VSS.n217 8.47732
R5607 VSS.n949 VSS.n217 8.47732
R5608 VSS.n947 VSS.n217 8.47732
R5609 VSS.n941 VSS.n217 8.47732
R5610 VSS.n937 VSS.n217 8.47732
R5611 VSS.n933 VSS.n217 8.47732
R5612 VSS.n931 VSS.n217 8.47732
R5613 VSS.n925 VSS.n217 8.47732
R5614 VSS.n921 VSS.n217 8.47732
R5615 VSS.n917 VSS.n217 8.47732
R5616 VSS.n915 VSS.n217 8.47732
R5617 VSS.n909 VSS.n217 8.47732
R5618 VSS.n905 VSS.n217 8.47732
R5619 VSS.n901 VSS.n217 8.47732
R5620 VSS.n899 VSS.n217 8.47732
R5621 VSS.n893 VSS.n217 8.47732
R5622 VSS.n889 VSS.n217 8.47732
R5623 VSS.n885 VSS.n217 8.47732
R5624 VSS.n883 VSS.n217 8.47732
R5625 VSS.n877 VSS.n217 8.47732
R5626 VSS.n873 VSS.n217 8.47732
R5627 VSS.n869 VSS.n217 8.47732
R5628 VSS.n867 VSS.n217 8.47732
R5629 VSS.n861 VSS.n217 8.47732
R5630 VSS.n857 VSS.n217 8.47732
R5631 VSS.n853 VSS.n217 8.47732
R5632 VSS.n851 VSS.n217 8.47732
R5633 VSS.n845 VSS.n217 8.47732
R5634 VSS.n840 VSS.n217 8.47732
R5635 VSS.n834 VSS.n217 8.47732
R5636 VSS.n1733 VSS.n217 8.47732
R5637 VSS.t515 VSS.n217 8.47732
R5638 VSS.n1740 VSS.n1739 8.47732
R5639 VSS.n1740 VSS.n534 8.47732
R5640 VSS.n1740 VSS.n536 8.47732
R5641 VSS.n1740 VSS.n780 8.47732
R5642 VSS.n1740 VSS.n781 8.47732
R5643 VSS.n1740 VSS.n782 8.47732
R5644 VSS.n1740 VSS.n784 8.47732
R5645 VSS.n1740 VSS.n785 8.47732
R5646 VSS.n1740 VSS.n786 8.47732
R5647 VSS.n1740 VSS.n787 8.47732
R5648 VSS.t21 VSS.n218 8.47732
R5649 VSS.n2076 VSS.n218 8.47732
R5650 VSS.n262 VSS.n218 8.47732
R5651 VSS.n2080 VSS.n218 8.47732
R5652 VSS.t433 VSS.n218 8.47732
R5653 VSS.n2084 VSS.n218 8.47732
R5654 VSS.n252 VSS.n218 8.47732
R5655 VSS.n2088 VSS.n218 8.47732
R5656 VSS.n247 VSS.n218 8.47732
R5657 VSS.n242 VSS.n218 8.47732
R5658 VSS.n2092 VSS.n218 8.47732
R5659 VSS.n2094 VSS.n218 8.47732
R5660 VSS.n2096 VSS.n218 8.47732
R5661 VSS.n2098 VSS.n218 8.47732
R5662 VSS.n2100 VSS.n218 8.47732
R5663 VSS.n2102 VSS.n218 8.47732
R5664 VSS.n2104 VSS.n218 8.47732
R5665 VSS.n2106 VSS.n218 8.47732
R5666 VSS.n2108 VSS.n218 8.47732
R5667 VSS.n2110 VSS.n218 8.47732
R5668 VSS.n2112 VSS.n218 8.47732
R5669 VSS.n2116 VSS.n218 8.47732
R5670 VSS.n2118 VSS.n218 8.47732
R5671 VSS.n2120 VSS.n220 8.47732
R5672 VSS.n2120 VSS.n221 8.47732
R5673 VSS.n2023 VSS.n277 8.47732
R5674 VSS.n288 VSS.n2014 8.47732
R5675 VSS.n2014 VSS.n287 8.47732
R5676 VSS.n2014 VSS.n292 8.47732
R5677 VSS.n2014 VSS.n293 8.47732
R5678 VSS.n2014 VSS.n294 8.47732
R5679 VSS.n2014 VSS.n297 8.47732
R5680 VSS.n2014 VSS.n298 8.47732
R5681 VSS.n308 VSS.n1989 8.47732
R5682 VSS.n1989 VSS.n307 8.47732
R5683 VSS.n1978 VSS.n317 8.47732
R5684 VSS.n327 VSS.n1967 8.47732
R5685 VSS.n1967 VSS.n326 8.47732
R5686 VSS.n1967 VSS.n331 8.47732
R5687 VSS.n1967 VSS.n332 8.47732
R5688 VSS.n1967 VSS.n333 8.47732
R5689 VSS.n1967 VSS.n336 8.47732
R5690 VSS.n1967 VSS.n337 8.47732
R5691 VSS.n347 VSS.n1942 8.47732
R5692 VSS.n1942 VSS.n346 8.47732
R5693 VSS.n1931 VSS.n356 8.47732
R5694 VSS.n366 VSS.n1920 8.47732
R5695 VSS.n1920 VSS.n365 8.47732
R5696 VSS.n1920 VSS.n370 8.47732
R5697 VSS.n1920 VSS.n371 8.47732
R5698 VSS.n1920 VSS.n372 8.47732
R5699 VSS.n1920 VSS.n375 8.47732
R5700 VSS.n1920 VSS.n376 8.47732
R5701 VSS.n1920 VSS.n377 8.47732
R5702 VSS.n1920 VSS.n378 8.47732
R5703 VSS.n1920 VSS.n379 8.47732
R5704 VSS.n1920 VSS.n381 8.47732
R5705 VSS.n1920 VSS.n384 8.47732
R5706 VSS.n1920 VSS.n385 8.47732
R5707 VSS.n1920 VSS.n388 8.47732
R5708 VSS.n1920 VSS.n389 8.47732
R5709 VSS.n1920 VSS.n390 8.47732
R5710 VSS.n1920 VSS.n391 8.47732
R5711 VSS.n1920 VSS.n392 8.47732
R5712 VSS.n1920 VSS.n393 8.47732
R5713 VSS.n1920 VSS.n396 8.47732
R5714 VSS.n1920 VSS.n397 8.47732
R5715 VSS.n431 VSS.n1856 8.47732
R5716 VSS.n1856 VSS.n430 8.47732
R5717 VSS.n1845 VSS.n440 8.47732
R5718 VSS.n450 VSS.n1834 8.47732
R5719 VSS.n1834 VSS.n449 8.47732
R5720 VSS.n1834 VSS.n454 8.47732
R5721 VSS.n1834 VSS.n455 8.47732
R5722 VSS.n1834 VSS.n456 8.47732
R5723 VSS.n1834 VSS.n459 8.47732
R5724 VSS.n1834 VSS.n460 8.47732
R5725 VSS.n470 VSS.n1809 8.47732
R5726 VSS.n1809 VSS.n469 8.47732
R5727 VSS.n1798 VSS.n479 8.47732
R5728 VSS.n489 VSS.n1787 8.47732
R5729 VSS.n1787 VSS.n488 8.47732
R5730 VSS.n1787 VSS.n493 8.47732
R5731 VSS.n1787 VSS.n494 8.47732
R5732 VSS.n1787 VSS.n495 8.47732
R5733 VSS.n1787 VSS.n498 8.47732
R5734 VSS.n1787 VSS.n499 8.47732
R5735 VSS.n509 VSS.n1762 8.47732
R5736 VSS.n1762 VSS.n508 8.47732
R5737 VSS.n1751 VSS.n518 8.47732
R5738 VSS.n528 VSS.n1740 8.47732
R5739 VSS.n1740 VSS.n527 8.47732
R5740 VSS.n3850 VSS.n12 8.47732
R5741 VSS.n3849 VSS.n12 8.47732
R5742 VSS.n3503 VSS.n12 8.47732
R5743 VSS.n12 VSS.n33 8.47732
R5744 VSS.n3738 VSS.n12 8.47732
R5745 VSS.n35 VSS.n135 8.47732
R5746 VSS.n3803 VSS.n37 8.47732
R5747 VSS.n3805 VSS.n38 8.47732
R5748 VSS.n3807 VSS.n39 8.47732
R5749 VSS.n3811 VSS.n41 8.47732
R5750 VSS.n3815 VSS.n143 8.47732
R5751 VSS.n3817 VSS.n141 8.47732
R5752 VSS.n3819 VSS.n43 8.47732
R5753 VSS.n3784 VSS.n3783 8.47732
R5754 VSS.n3847 VSS.n12 8.47732
R5755 VSS.n126 VSS.n12 8.47732
R5756 VSS.n3838 VSS.n12 8.47732
R5757 VSS.n3836 VSS.n12 8.47732
R5758 VSS.n3834 VSS.n12 8.47732
R5759 VSS.n130 VSS.n12 8.47732
R5760 VSS.n3826 VSS.n12 8.47732
R5761 VSS.t488 VSS.n45 8.47732
R5762 VSS.n3746 VSS.n3499 8.47732
R5763 VSS.n3747 VSS.n47 8.47732
R5764 VSS.n3751 VSS.n48 8.47732
R5765 VSS.n3753 VSS.n50 8.47732
R5766 VSS.n3755 VSS.n51 8.47732
R5767 VSS.n3757 VSS.n52 8.47732
R5768 VSS.n3759 VSS.n53 8.47732
R5769 VSS.n3490 VSS.n54 8.47732
R5770 VSS.n3762 VSS.n3761 8.47732
R5771 VSS.n3488 VSS.n55 8.47732
R5772 VSS.n3487 VSS.n58 8.47732
R5773 VSS.n3764 VSS.n57 8.47732
R5774 VSS.n3768 VSS.n59 8.47732
R5775 VSS.n3770 VSS.n60 8.47732
R5776 VSS.n3772 VSS.n62 8.47732
R5777 VSS.n3774 VSS.n64 8.47732
R5778 VSS.n3776 VSS.n63 8.47732
R5779 VSS.n3778 VSS.n65 8.47732
R5780 VSS.n68 VSS.n3780 8.47732
R5781 VSS.n10 VSS.t494 8.47732
R5782 VSS.t691 VSS.n13 8.47732
R5783 VSS.n3715 VSS.n14 8.47732
R5784 VSS.n3717 VSS.n15 8.47732
R5785 VSS.n3540 VSS.n16 8.47732
R5786 VSS.n3538 VSS.n17 8.47732
R5787 VSS.n3719 VSS.n18 8.47732
R5788 VSS.n3721 VSS.n19 8.47732
R5789 VSS.n3532 VSS.n20 8.47732
R5790 VSS.t696 VSS.n21 8.47732
R5791 VSS.n3724 VSS.n23 8.47732
R5792 VSS.n3524 VSS.n3525 8.47732
R5793 VSS.n3522 VSS.n24 8.47732
R5794 VSS.n3728 VSS.n26 8.47732
R5795 VSS.n3730 VSS.n27 8.47732
R5796 VSS.n3516 VSS.n28 8.47732
R5797 VSS.t700 VSS.n29 8.47732
R5798 VSS.n3732 VSS.n30 8.47732
R5799 VSS.n3734 VSS.n32 8.47732
R5800 VSS.n31 VSS.n3736 8.47732
R5801 VSS.n67 VSS.n155 8.47732
R5802 VSS.n119 VSS.t572 8.47732
R5803 VSS.n119 VSS.n2613 8.47732
R5804 VSS.n119 VSS.n2612 8.47732
R5805 VSS.n119 VSS.n2611 8.47732
R5806 VSS.n119 VSS.n2610 8.47732
R5807 VSS.n119 VSS.n2607 8.47732
R5808 VSS.n119 VSS.n2606 8.47732
R5809 VSS.n119 VSS.n2605 8.47732
R5810 VSS.n119 VSS.n2604 8.47732
R5811 VSS.n119 VSS.n2602 8.47732
R5812 VSS.n119 VSS.n2601 8.47732
R5813 VSS.n119 VSS.n2600 8.47732
R5814 VSS.n119 VSS.n2599 8.47732
R5815 VSS.n119 VSS.n2596 8.47732
R5816 VSS.n119 VSS.n2595 8.47732
R5817 VSS.n119 VSS.n2594 8.47732
R5818 VSS.n119 VSS.n2590 8.47732
R5819 VSS.n119 VSS.n2586 8.47732
R5820 VSS.n119 VSS.n2585 8.47732
R5821 VSS.n119 VSS.n2584 8.47732
R5822 VSS.n119 VSS.n2583 8.47732
R5823 VSS.n119 VSS.n2579 8.47732
R5824 VSS.n119 VSS.n2578 8.47732
R5825 VSS.n119 VSS.n2577 8.47732
R5826 VSS.n119 VSS.n2576 8.47732
R5827 VSS.n119 VSS.n2575 8.47732
R5828 VSS.n119 VSS.n2574 8.47732
R5829 VSS.n119 VSS.n2573 8.47732
R5830 VSS.n119 VSS.n2572 8.47732
R5831 VSS.n119 VSS.n2571 8.47732
R5832 VSS.n119 VSS.n2570 8.47732
R5833 VSS.n119 VSS.n2566 8.47732
R5834 VSS.n119 VSS.n2563 8.47732
R5835 VSS.n119 VSS.n2560 8.47732
R5836 VSS.n119 VSS.n2555 8.47732
R5837 VSS.n119 VSS.n2552 8.47732
R5838 VSS.n119 VSS.n2549 8.47732
R5839 VSS.n119 VSS.n2548 8.47732
R5840 VSS.n119 VSS.n2545 8.47732
R5841 VSS.n119 VSS.n2544 8.47732
R5842 VSS.n119 VSS.n2543 8.47732
R5843 VSS.n119 VSS.n2542 8.47732
R5844 VSS.n119 VSS.n2533 8.47732
R5845 VSS.n119 VSS.n2532 8.47732
R5846 VSS.n119 VSS.n2528 8.47732
R5847 VSS.n119 VSS.n2525 8.47732
R5848 VSS.n119 VSS.n2522 8.47732
R5849 VSS.n119 VSS.n2521 8.47732
R5850 VSS.n119 VSS.n2520 8.47732
R5851 VSS.n119 VSS.n2516 8.47732
R5852 VSS.n119 VSS.n2513 8.47732
R5853 VSS.n119 VSS.n2512 8.47732
R5854 VSS.n119 VSS.n2511 8.47732
R5855 VSS.n119 VSS.n2507 8.47732
R5856 VSS.n119 VSS.n2504 8.47732
R5857 VSS.n119 VSS.n2501 8.47732
R5858 VSS.n119 VSS.n2498 8.47732
R5859 VSS.n119 VSS.n2497 8.47732
R5860 VSS.n119 VSS.n2496 8.47732
R5861 VSS.n119 VSS.n2495 8.47732
R5862 VSS.n119 VSS.t584 8.47732
R5863 VSS.n119 VSS.n2491 8.47732
R5864 VSS.n119 VSS.n2488 8.47732
R5865 VSS.n119 VSS.n2485 8.47732
R5866 VSS.n119 VSS.n2482 8.47732
R5867 VSS.n119 VSS.n2478 8.47732
R5868 VSS.n119 VSS.n2475 8.47732
R5869 VSS.n119 VSS.n2472 8.47732
R5870 VSS.n119 VSS.n2471 8.47732
R5871 VSS.n3171 VSS.n85 8.47732
R5872 VSS.n3173 VSS.n85 8.47732
R5873 VSS.n3175 VSS.n85 8.47732
R5874 VSS.n3177 VSS.n85 8.47732
R5875 VSS.n3179 VSS.n85 8.47732
R5876 VSS.n3181 VSS.n85 8.47732
R5877 VSS.n3183 VSS.n85 8.47732
R5878 VSS.n3185 VSS.n85 8.47732
R5879 VSS.t600 VSS.n85 8.47732
R5880 VSS.n3188 VSS.n85 8.47732
R5881 VSS.n3190 VSS.n85 8.47732
R5882 VSS.n3192 VSS.n85 8.47732
R5883 VSS.n3194 VSS.n85 8.47732
R5884 VSS.n3196 VSS.n85 8.47732
R5885 VSS.n3198 VSS.n85 8.47732
R5886 VSS.n3200 VSS.n85 8.47732
R5887 VSS.n3202 VSS.n85 8.47732
R5888 VSS.n3204 VSS.n85 8.47732
R5889 VSS.n3205 VSS.n85 8.47732
R5890 VSS.n3207 VSS.n85 8.47732
R5891 VSS.n3209 VSS.n85 8.47732
R5892 VSS.n3211 VSS.n85 8.47732
R5893 VSS.n3213 VSS.n85 8.47732
R5894 VSS.n3215 VSS.n85 8.47732
R5895 VSS.n3217 VSS.n85 8.47732
R5896 VSS.n3219 VSS.n85 8.47732
R5897 VSS.n2330 VSS.n85 8.47732
R5898 VSS.n3234 VSS.n85 8.47732
R5899 VSS.n3236 VSS.n85 8.47732
R5900 VSS.n3238 VSS.n85 8.47732
R5901 VSS.n3240 VSS.n85 8.47732
R5902 VSS.n3242 VSS.n85 8.47732
R5903 VSS.n3244 VSS.n85 8.47732
R5904 VSS.n3246 VSS.n85 8.47732
R5905 VSS.n2318 VSS.n85 8.47732
R5906 VSS.n3270 VSS.n85 8.47732
R5907 VSS.n3272 VSS.n85 8.47732
R5908 VSS.n3274 VSS.n85 8.47732
R5909 VSS.n3276 VSS.n85 8.47732
R5910 VSS.n3278 VSS.n85 8.47732
R5911 VSS.n3280 VSS.n85 8.47732
R5912 VSS.n3282 VSS.n85 8.47732
R5913 VSS.n3284 VSS.n85 8.47732
R5914 VSS.n3285 VSS.n85 8.47732
R5915 VSS.n3287 VSS.n85 8.47732
R5916 VSS.n3289 VSS.n85 8.47732
R5917 VSS.n3291 VSS.n85 8.47732
R5918 VSS.n3293 VSS.n85 8.47732
R5919 VSS.n3295 VSS.n85 8.47732
R5920 VSS.n3297 VSS.n85 8.47732
R5921 VSS.n3299 VSS.n85 8.47732
R5922 VSS.n2297 VSS.n85 8.47732
R5923 VSS.n3314 VSS.n85 8.47732
R5924 VSS.n3316 VSS.n85 8.47732
R5925 VSS.n3318 VSS.n85 8.47732
R5926 VSS.n3320 VSS.n85 8.47732
R5927 VSS.n3322 VSS.n85 8.47732
R5928 VSS.n3324 VSS.n85 8.47732
R5929 VSS.n3326 VSS.n85 8.47732
R5930 VSS.n2285 VSS.n85 8.47732
R5931 VSS.n3343 VSS.n85 8.47732
R5932 VSS.n3345 VSS.n85 8.47732
R5933 VSS.n3347 VSS.n85 8.47732
R5934 VSS.n3349 VSS.n85 8.47732
R5935 VSS.n3351 VSS.n85 8.47732
R5936 VSS.n3353 VSS.n85 8.47732
R5937 VSS.n3355 VSS.n85 8.47732
R5938 VSS.n2271 VSS.n85 8.47732
R5939 VSS.t587 VSS.n85 8.47732
R5940 VSS.n67 VSS.n215 8.47732
R5941 VSS.n67 VSS.n213 8.47732
R5942 VSS.n67 VSS.n211 8.47732
R5943 VSS.n67 VSS.n210 8.47732
R5944 VSS.n67 VSS.n209 8.47732
R5945 VSS.n67 VSS.n207 8.47732
R5946 VSS.n67 VSS.n205 8.47732
R5947 VSS.n67 VSS.n203 8.47732
R5948 VSS.n67 VSS.n202 8.47732
R5949 VSS.n67 VSS.n201 8.47732
R5950 VSS.n67 VSS.n198 8.47732
R5951 VSS.n67 VSS.n197 8.47732
R5952 VSS.n67 VSS.n195 8.47732
R5953 VSS.n67 VSS.n194 8.47732
R5954 VSS.n67 VSS.n192 8.47732
R5955 VSS.n67 VSS.n189 8.47732
R5956 VSS.n67 VSS.n185 8.47732
R5957 VSS.n67 VSS.n183 8.47732
R5958 VSS.n67 VSS.n156 8.47732
R5959 VSS.n67 VSS.n157 8.47732
R5960 VSS.n67 VSS.n158 8.47732
R5961 VSS.n67 VSS.n159 8.47732
R5962 VSS.n67 VSS.n160 8.47732
R5963 VSS.n67 VSS.n161 8.47732
R5964 VSS.n67 VSS.n162 8.47732
R5965 VSS.n67 VSS.n163 8.47732
R5966 VSS.n67 VSS.n166 8.47732
R5967 VSS.n67 VSS.n167 8.47732
R5968 VSS.n67 VSS.n170 8.47732
R5969 VSS.n67 VSS.n171 8.47732
R5970 VSS.n67 VSS.n173 8.47732
R5971 VSS.n68 VSS.n2152 8.47732
R5972 VSS.n68 VSS.n2154 8.47732
R5973 VSS.n68 VSS.n2156 8.47732
R5974 VSS.n68 VSS.n2158 8.47732
R5975 VSS.n68 VSS.n2159 8.47732
R5976 VSS.n68 VSS.n2160 8.47732
R5977 VSS.n68 VSS.n2161 8.47732
R5978 VSS.n68 VSS.n2162 8.47732
R5979 VSS.n68 VSS.n2164 8.47732
R5980 VSS.n68 VSS.n2169 8.47732
R5981 VSS.n68 VSS.n2171 8.47732
R5982 VSS.n68 VSS.n2173 8.47732
R5983 VSS.n68 VSS.n2175 8.47732
R5984 VSS.n68 VSS.n2176 8.47732
R5985 VSS.n8 VSS.n2217 8.47732
R5986 VSS.n8 VSS.n2219 8.47732
R5987 VSS.n8 VSS.n2221 8.47732
R5988 VSS.n8 VSS.n2227 8.47732
R5989 VSS.n8 VSS.n2241 8.47732
R5990 VSS.n8 VSS.n2230 8.47732
R5991 VSS.n67 VSS.n174 8.47732
R5992 VSS.n67 VSS.n176 8.47732
R5993 VSS.n3430 VSS.n108 8.47677
R5994 VSS.n3431 VSS.n107 8.47677
R5995 VSS.n3435 VSS.n113 8.47677
R5996 VSS.n3436 VSS.n112 8.47677
R5997 VSS.n3437 VSS.n116 8.47677
R5998 VSS.n3438 VSS.n115 8.47677
R5999 VSS.n3118 VSS.n119 8.4742
R6000 VSS.n3049 VSS.t292 8.47111
R6001 VSS.n3052 VSS.t292 8.47111
R6002 VSS.n3053 VSS.t426 8.47111
R6003 VSS.n3055 VSS.t426 8.47111
R6004 VSS.n3058 VSS.t426 8.47111
R6005 VSS.n3061 VSS.t426 8.47111
R6006 VSS.n3064 VSS.t426 8.47111
R6007 VSS.n3067 VSS.t426 8.47111
R6008 VSS.n3070 VSS.n2677 8.47111
R6009 VSS.n3073 VSS.n2674 8.47111
R6010 VSS.n3075 VSS.n2650 8.47111
R6011 VSS.n3078 VSS.n2650 8.47111
R6012 VSS.n3080 VSS.n2650 8.47111
R6013 VSS.n3082 VSS.n2650 8.47111
R6014 VSS.n3084 VSS.n2650 8.47111
R6015 VSS.n3085 VSS.n2650 8.47111
R6016 VSS.n3088 VSS.n2650 8.47111
R6017 VSS.n3089 VSS.t428 8.47111
R6018 VSS.n3091 VSS.t428 8.47111
R6019 VSS.n3093 VSS.t428 8.47111
R6020 VSS.n3096 VSS.t428 8.47111
R6021 VSS.n3099 VSS.t428 8.47111
R6022 VSS.n3102 VSS.t428 8.47111
R6023 VSS.n3105 VSS.n2634 8.47111
R6024 VSS.n3108 VSS.n2631 8.47111
R6025 VSS.n3110 VSS.n2618 8.47111
R6026 VSS.n3111 VSS.n2618 8.47111
R6027 VSS.n3114 VSS.n2618 8.47111
R6028 VSS.n3115 VSS.n2618 8.47111
R6029 VSS.n3442 VSS.n3441 8.47111
R6030 VSS.t55 VSS.n3460 8.47111
R6031 VSS.t55 VSS.n2182 8.47111
R6032 VSS.t55 VSS.n2198 8.47111
R6033 VSS.t55 VSS.n2195 8.47111
R6034 VSS.n3442 VSS.t226 8.47111
R6035 VSS.n68 VSS.n3465 8.46924
R6036 VSS.n3861 VSS.n3860 7.85649
R6037 VSS.n1447 VSS.n123 7.82802
R6038 VSS.n3467 VSS.n82 7.06146
R6039 VSS.n70 VSS.n3781 7.06124
R6040 VSS.n2150 VSS.n72 7.06124
R6041 VSS.n3473 VSS.n75 7.06124
R6042 VSS.n2163 VSS.n78 7.06124
R6043 VSS.n1450 VSS.n123 6.85994
R6044 VSS.n3008 VSS.n3006 6.76691
R6045 VSS.t585 VSS.n2479 6.42276
R6046 VSS.n3043 VSS.n3042 5.66923
R6047 VSS.n36 VSS.n35 0.00261099
R6048 VSS.n40 VSS.n147 0.00229996
R6049 VSS.n11 VSS.n137 5.66778
R6050 VSS.n11 VSS.n136 5.66778
R6051 VSS.n44 VSS.n12 0.00229996
R6052 VSS.n46 VSS.n3499 0.00229996
R6053 VSS.n3763 VSS.n49 1.13339
R6054 VSS.n61 VSS.n59 0.00268168
R6055 VSS.n22 VSS.n3530 0.00229996
R6056 VSS.n3737 VSS.n25 1
R6057 VSS.n3737 VSS.n83 5.66778
R6058 VSS.n3008 VSS.n3007 5.66778
R6059 VSS.n109 VSS.n2266 0.0024999
R6060 VSS.n114 VSS.n110 0.00229996
R6061 VSS.n3137 VSS.n89 0.80928
R6062 VSS.n98 VSS.n3123 0.00229996
R6063 VSS.n100 VSS.n3122 0.00229996
R6064 VSS.n103 VSS.n101 0.00261099
R6065 VSS.n3763 VSS.n68 5.66767
R6066 VSS.n3000 VSS.n2999 5.66767
R6067 VSS.n3005 VSS.n3004 5.66767
R6068 VSS.n3046 VSS.t292 5.66031
R6069 VSS.n3463 VSS.t55 5.65099
R6070 VSS.n2023 VSS.n2022 5.64536
R6071 VSS.n1978 VSS.n1975 5.64536
R6072 VSS.n1931 VSS.n1928 5.64536
R6073 VSS.n1845 VSS.n1842 5.64536
R6074 VSS.n1798 VSS.n1795 5.64536
R6075 VSS.n1751 VSS.n1748 5.64536
R6076 VSS.n3434 VSS.n110 5.63736
R6077 VSS.n3139 VSS.n3138 5.62674
R6078 VSS.n3132 VSS.n3123 5.62674
R6079 VSS.n3134 VSS.n3122 5.62674
R6080 VSS.n101 VSS.n3136 5.62674
R6081 VSS.t478 VSS.n217 5.62581
R6082 VSS.n1496 VSS.n217 5.62581
R6083 VSS.n1501 VSS.n217 5.62581
R6084 VSS.n1155 VSS.n217 5.62581
R6085 VSS.n1164 VSS.n217 5.62581
R6086 VSS.n1173 VSS.n217 5.62581
R6087 VSS.n1182 VSS.n217 5.62581
R6088 VSS.n1191 VSS.n217 5.62581
R6089 VSS.n1200 VSS.n217 5.62581
R6090 VSS.n1209 VSS.n217 5.62581
R6091 VSS.n1218 VSS.n217 5.62581
R6092 VSS.n1227 VSS.n217 5.62581
R6093 VSS.n1236 VSS.n217 5.62581
R6094 VSS.n1245 VSS.n217 5.62581
R6095 VSS.n1254 VSS.n217 5.62581
R6096 VSS.n1263 VSS.n217 5.62581
R6097 VSS.n1272 VSS.n217 5.62581
R6098 VSS.n1281 VSS.n217 5.62581
R6099 VSS.n1290 VSS.n217 5.62581
R6100 VSS.n1299 VSS.n217 5.62581
R6101 VSS.n1308 VSS.n217 5.62581
R6102 VSS.n1317 VSS.n217 5.62581
R6103 VSS.n1326 VSS.n217 5.62581
R6104 VSS.n1335 VSS.n217 5.62581
R6105 VSS.n1344 VSS.n217 5.62581
R6106 VSS.n1353 VSS.n217 5.62581
R6107 VSS.n1362 VSS.n217 5.62581
R6108 VSS.n1371 VSS.n217 5.62581
R6109 VSS.n1380 VSS.n217 5.62581
R6110 VSS.n1389 VSS.n217 5.62581
R6111 VSS.n1398 VSS.n217 5.62581
R6112 VSS.n1407 VSS.n217 5.62581
R6113 VSS.n1416 VSS.n217 5.62581
R6114 VSS.n1425 VSS.n217 5.62581
R6115 VSS.n1434 VSS.n217 5.62581
R6116 VSS.n1081 VSS.n217 5.62581
R6117 VSS.n1075 VSS.n217 5.62581
R6118 VSS.n1072 VSS.n217 5.62581
R6119 VSS.n1526 VSS.n217 5.62581
R6120 VSS.n1068 VSS.n217 5.62581
R6121 VSS.n1062 VSS.n217 5.62581
R6122 VSS.n1056 VSS.n217 5.62581
R6123 VSS.n1540 VSS.n217 5.62581
R6124 VSS.n1052 VSS.n217 5.62581
R6125 VSS.n1046 VSS.n217 5.62581
R6126 VSS.n1040 VSS.n217 5.62581
R6127 VSS.n1554 VSS.n217 5.62581
R6128 VSS.n1036 VSS.n217 5.62581
R6129 VSS.n1030 VSS.n217 5.62581
R6130 VSS.n1024 VSS.n217 5.62581
R6131 VSS.n1568 VSS.n217 5.62581
R6132 VSS.n1020 VSS.n217 5.62581
R6133 VSS.n1014 VSS.n217 5.62581
R6134 VSS.n1008 VSS.n217 5.62581
R6135 VSS.n1582 VSS.n217 5.62581
R6136 VSS.n1004 VSS.n217 5.62581
R6137 VSS.n998 VSS.n217 5.62581
R6138 VSS.n992 VSS.n217 5.62581
R6139 VSS.n1596 VSS.n217 5.62581
R6140 VSS.n988 VSS.n217 5.62581
R6141 VSS.n982 VSS.n217 5.62581
R6142 VSS.n976 VSS.n217 5.62581
R6143 VSS.n1610 VSS.n217 5.62581
R6144 VSS.n972 VSS.n217 5.62581
R6145 VSS.n966 VSS.n217 5.62581
R6146 VSS.n960 VSS.n217 5.62581
R6147 VSS.n1624 VSS.n217 5.62581
R6148 VSS.n956 VSS.n217 5.62581
R6149 VSS.n950 VSS.n217 5.62581
R6150 VSS.n944 VSS.n217 5.62581
R6151 VSS.n1638 VSS.n217 5.62581
R6152 VSS.n940 VSS.n217 5.62581
R6153 VSS.n934 VSS.n217 5.62581
R6154 VSS.n928 VSS.n217 5.62581
R6155 VSS.n1652 VSS.n217 5.62581
R6156 VSS.n924 VSS.n217 5.62581
R6157 VSS.n918 VSS.n217 5.62581
R6158 VSS.n912 VSS.n217 5.62581
R6159 VSS.n1666 VSS.n217 5.62581
R6160 VSS.n908 VSS.n217 5.62581
R6161 VSS.n902 VSS.n217 5.62581
R6162 VSS.n896 VSS.n217 5.62581
R6163 VSS.n1680 VSS.n217 5.62581
R6164 VSS.n892 VSS.n217 5.62581
R6165 VSS.n886 VSS.n217 5.62581
R6166 VSS.n880 VSS.n217 5.62581
R6167 VSS.n1694 VSS.n217 5.62581
R6168 VSS.n876 VSS.n217 5.62581
R6169 VSS.n870 VSS.n217 5.62581
R6170 VSS.n864 VSS.n217 5.62581
R6171 VSS.n1708 VSS.n217 5.62581
R6172 VSS.n860 VSS.n217 5.62581
R6173 VSS.n854 VSS.n217 5.62581
R6174 VSS.n848 VSS.n217 5.62581
R6175 VSS.n1722 VSS.n217 5.62581
R6176 VSS.n844 VSS.n217 5.62581
R6177 VSS.n837 VSS.n217 5.62581
R6178 VSS.n1735 VSS.n217 5.62581
R6179 VSS.n830 VSS.n217 5.62581
R6180 VSS.n828 VSS.n217 5.62581
R6181 VSS.n1740 VSS.n533 5.62581
R6182 VSS.n2074 VSS.n218 5.62581
R6183 VSS.n2078 VSS.n218 5.62581
R6184 VSS.n2082 VSS.n218 5.62581
R6185 VSS.n2086 VSS.n218 5.62581
R6186 VSS.n2090 VSS.n218 5.62581
R6187 VSS.n2114 VSS.n218 5.62581
R6188 VSS.n2014 VSS.n295 5.62581
R6189 VSS.n1967 VSS.n334 5.62581
R6190 VSS.n1920 VSS.n373 5.62581
R6191 VSS.n1920 VSS.n382 5.62581
R6192 VSS.n1920 VSS.n386 5.62581
R6193 VSS.n1920 VSS.n394 5.62581
R6194 VSS.n1834 VSS.n457 5.62581
R6195 VSS.n1787 VSS.n496 5.62581
R6196 VSS.n3501 VSS.n12 5.62581
R6197 VSS.n3809 VSS.n147 5.62581
R6198 VSS.n42 VSS.n3821 5.62581
R6199 VSS.n67 VSS.n154 5.62581
R6200 VSS.n3824 VSS.n12 5.62581
R6201 VSS.n3749 VSS.n3497 5.62581
R6202 VSS.n3530 VSS.n3529 5.62581
R6203 VSS.n119 VSS.n2603 5.62581
R6204 VSS.n119 VSS.n2587 5.62581
R6205 VSS.n119 VSS.n2559 5.62581
R6206 VSS.n119 VSS.n2538 5.62581
R6207 VSS.n119 VSS.n2467 5.62581
R6208 VSS.n3169 VSS.n85 5.62581
R6209 VSS.n3232 VSS.n85 5.62581
R6210 VSS.n3268 VSS.n85 5.62581
R6211 VSS.n3312 VSS.n85 5.62581
R6212 VSS.n3341 VSS.n85 5.62581
R6213 VSS.n67 VSS.n186 5.62581
R6214 VSS.n67 VSS.n164 5.62581
R6215 VSS.n67 VSS.n168 5.62581
R6216 VSS.n67 VSS.n172 5.62581
R6217 VSS.n68 VSS.n3476 5.62581
R6218 VSS.n68 VSS.n3468 5.62581
R6219 VSS.n8 VSS.n2226 5.62581
R6220 VSS.n67 VSS.n179 5.62581
R6221 VSS.n3428 VSS.n85 5.62484
R6222 VSS.n3429 VSS.n2266 5.62484
R6223 VSS.t55 VSS.n2200 5.61485
R6224 VSS.t528 VSS.n214 5.48496
R6225 VSS.n3006 VSS.n85 5.11804
R6226 VSS.n2216 VSS.t702 4.98596
R6227 VSS.n823 VSS.n822 4.73162
R6228 VSS.n3577 VSS.n3576 4.73162
R6229 VSS.n3167 VSS.n3166 4.73162
R6230 VSS.n2761 VSS.n2756 4.73162
R6231 VSS.n3630 VSS.n3629 4.73162
R6232 VSS.n3583 VSS.n3582 4.73162
R6233 VSS.n1160 VSS.n1152 4.73162
R6234 VSS.n3457 VSS.n3456 4.64666
R6235 VSS.n2264 VSS.n2263 4.64666
R6236 VSS.n2995 VSS.n2994 4.64666
R6237 VSS.n3030 VSS.t158 4.49152
R6238 VSS.n3014 VSS.t1 4.49152
R6239 VSS.n3426 VSS.n3425 4.4712
R6240 VSS.n3448 VSS.n2208 4.4712
R6241 VSS.n3092 VSS.n2207 4.4712
R6242 VSS.n2950 VSS.n2207 4.46488
R6243 VSS.n3425 VSS.n3424 4.46488
R6244 VSS.n3449 VSS.n3448 4.46488
R6245 VSS.n11 VSS.n69 4.251
R6246 VSS.n8 VSS.n2222 4.19225
R6247 VSS.n2071 VSS.n272 4.02278
R6248 VSS.n1484 VSS.n1482 4.02278
R6249 VSS.n1483 VSS.n1484 3.84369
R6250 VSS.n2073 VSS.n272 3.84291
R6251 VSS.n3044 VSS.n3043 3.52606
R6252 VSS.n67 VSS.t215 3.37895
R6253 VSS.n3424 VSS.n3359 3.37628
R6254 VSS.t566 VSS.n554 3.34498
R6255 VSS.t562 VSS.n560 3.34498
R6256 VSS.t548 VSS.n568 3.34498
R6257 VSS.t546 VSS.n574 3.34498
R6258 VSS.t607 VSS.n582 3.34498
R6259 VSS.t603 VSS.n588 3.34498
R6260 VSS.t556 VSS.n596 3.34498
R6261 VSS.t550 VSS.n602 3.34498
R6262 VSS.t611 VSS.n610 3.34498
R6263 VSS.t542 VSS.n616 3.34498
R6264 VSS.t609 VSS.n624 3.34498
R6265 VSS.t532 VSS.n630 3.34498
R6266 VSS.t552 VSS.n638 3.34498
R6267 VSS.t613 VSS.n644 3.34498
R6268 VSS.t605 VSS.n652 3.34498
R6269 VSS.t534 VSS.n658 3.34498
R6270 VSS.t538 VSS.n666 3.34498
R6271 VSS.t615 VSS.n672 3.34498
R6272 VSS.t558 VSS.n680 3.34498
R6273 VSS.t617 VSS.n686 3.34498
R6274 VSS.t623 VSS.n694 3.34498
R6275 VSS.t544 VSS.n700 3.34498
R6276 VSS.t621 VSS.n708 3.34498
R6277 VSS.t619 VSS.n714 3.34498
R6278 VSS.t536 VSS.n722 3.34498
R6279 VSS.t625 VSS.n728 3.34498
R6280 VSS.t564 VSS.n736 3.34498
R6281 VSS.t540 VSS.n742 3.34498
R6282 VSS.t560 VSS.n750 3.34498
R6283 VSS.t627 VSS.n756 3.34498
R6284 VSS.t554 VSS.n764 3.34498
R6285 VSS.t629 VSS.n770 3.34498
R6286 VSS.n1451 VSS.n217 3.32778
R6287 VSS.n8 VSS.n2214 3.32697
R6288 VSS.t635 VSS.n217 3.32615
R6289 VSS.t388 VSS.n217 3.32615
R6290 VSS.t321 VSS.n217 3.32615
R6291 VSS.t286 VSS.n217 3.32615
R6292 VSS.t15 VSS.n217 3.32615
R6293 VSS.t282 VSS.n217 3.32615
R6294 VSS.t289 VSS.n217 3.32615
R6295 VSS.t451 VSS.n217 3.32615
R6296 VSS.t44 VSS.n217 3.32615
R6297 VSS.t242 VSS.n217 3.32615
R6298 VSS.t57 VSS.n217 3.32615
R6299 VSS.t324 VSS.n217 3.32615
R6300 VSS.t232 VSS.n217 3.32615
R6301 VSS.t17 VSS.n217 3.32615
R6302 VSS.t385 VSS.n217 3.32615
R6303 VSS.t206 VSS.n217 3.32615
R6304 VSS.t308 VSS.n217 3.32615
R6305 VSS.t652 VSS.n217 3.32615
R6306 VSS.t181 VSS.n217 3.32615
R6307 VSS.t221 VSS.n217 3.32615
R6308 VSS.t60 VSS.n217 3.32615
R6309 VSS.t397 VSS.n217 3.32615
R6310 VSS.t223 VSS.n217 3.32615
R6311 VSS.t294 VSS.n217 3.32615
R6312 VSS.t40 VSS.n217 3.32615
R6313 VSS.t393 VSS.n217 3.32615
R6314 VSS.t219 VSS.n217 3.32615
R6315 VSS.t26 VSS.n217 3.32615
R6316 VSS.t253 VSS.n217 3.32615
R6317 VSS.t364 VSS.n217 3.32615
R6318 VSS.t42 VSS.n217 3.32615
R6319 VSS.n3857 VSS.n12 3.32615
R6320 VSS.n8 VSS.n2218 3.32615
R6321 VSS.t570 VSS.n2367 3.21163
R6322 VSS.n2523 VSS.t581 3.21163
R6323 VSS.n119 VSS.n2358 3.04274
R6324 VSS.n119 VSS.n2360 3.04274
R6325 VSS.n119 VSS.n2362 3.04274
R6326 VSS.n119 VSS.n2364 3.04274
R6327 VSS.n119 VSS.n2366 3.04274
R6328 VSS.n119 VSS.n2369 3.04274
R6329 VSS.n119 VSS.n2371 3.04274
R6330 VSS.n119 VSS.n2373 3.04274
R6331 VSS.n119 VSS.n2375 3.04274
R6332 VSS.n119 VSS.n2377 3.04274
R6333 VSS.n119 VSS.n2379 3.04274
R6334 VSS.n119 VSS.n2381 3.04274
R6335 VSS.n119 VSS.n2383 3.04274
R6336 VSS.n119 VSS.n2385 3.04274
R6337 VSS.n119 VSS.n2388 3.04274
R6338 VSS.n119 VSS.n2390 3.04274
R6339 VSS.n119 VSS.n2589 3.04274
R6340 VSS.n119 VSS.n2393 3.04274
R6341 VSS.n119 VSS.n2396 3.04274
R6342 VSS.n119 VSS.n2398 3.04274
R6343 VSS.n119 VSS.n2400 3.04274
R6344 VSS.n119 VSS.n2402 3.04274
R6345 VSS.n119 VSS.n2405 3.04274
R6346 VSS.n119 VSS.n2407 3.04274
R6347 VSS.n119 VSS.n2409 3.04274
R6348 VSS.n119 VSS.n2411 3.04274
R6349 VSS.n119 VSS.n2413 3.04274
R6350 VSS.n119 VSS.n2415 3.04274
R6351 VSS.n119 VSS.n2417 3.04274
R6352 VSS.n119 VSS.n2419 3.04274
R6353 VSS.n119 VSS.n2421 3.04274
R6354 VSS.n119 VSS.n2565 3.04274
R6355 VSS.n119 VSS.n2562 3.04274
R6356 VSS.n119 VSS.n2424 3.04274
R6357 VSS.n119 VSS.n2426 3.04274
R6358 VSS.n119 VSS.n2554 3.04274
R6359 VSS.n119 VSS.n2551 3.04274
R6360 VSS.n119 VSS.n2429 3.04274
R6361 VSS.n119 VSS.n2432 3.04274
R6362 VSS.n119 VSS.n2434 3.04274
R6363 VSS.n119 VSS.n2436 3.04274
R6364 VSS.n119 VSS.n2537 3.04274
R6365 VSS.n119 VSS.n2535 3.04274
R6366 VSS.n119 VSS.n2440 3.04274
R6367 VSS.n119 VSS.n2527 3.04274
R6368 VSS.n119 VSS.n2524 3.04274
R6369 VSS.n119 VSS.n2443 3.04274
R6370 VSS.n119 VSS.n2445 3.04274
R6371 VSS.n119 VSS.n2515 3.04274
R6372 VSS.n119 VSS.n2448 3.04274
R6373 VSS.n119 VSS.n2450 3.04274
R6374 VSS.n119 VSS.n2506 3.04274
R6375 VSS.n119 VSS.n2503 3.04274
R6376 VSS.n119 VSS.n2454 3.04274
R6377 VSS.n119 VSS.n2456 3.04274
R6378 VSS.n119 VSS.n2458 3.04274
R6379 VSS.n119 VSS.n2460 3.04274
R6380 VSS.n119 VSS.n2490 3.04274
R6381 VSS.n119 VSS.n2487 3.04274
R6382 VSS.n119 VSS.n2484 3.04274
R6383 VSS.n119 VSS.n2481 3.04274
R6384 VSS.n119 VSS.n2477 3.04274
R6385 VSS.n119 VSS.n2474 3.04274
R6386 VSS.n119 VSS.n2463 3.04274
R6387 VSS.n119 VSS.n2466 3.04274
R6388 VSS.n119 VSS.n2464 3.04274
R6389 VSS.n2465 VSS.n85 3.04274
R6390 VSS.n2469 VSS.n85 3.04274
R6391 VSS.n2473 VSS.n85 3.04274
R6392 VSS.n2476 VSS.n85 3.04274
R6393 VSS.n2483 VSS.n85 3.04274
R6394 VSS.n2486 VSS.n85 3.04274
R6395 VSS.n2489 VSS.n85 3.04274
R6396 VSS.n2493 VSS.n85 3.04274
R6397 VSS.n2459 VSS.n85 3.04274
R6398 VSS.n2457 VSS.n85 3.04274
R6399 VSS.n2455 VSS.n85 3.04274
R6400 VSS.n2499 VSS.n85 3.04274
R6401 VSS.n2502 VSS.n85 3.04274
R6402 VSS.n2505 VSS.n85 3.04274
R6403 VSS.n2509 VSS.n85 3.04274
R6404 VSS.n2449 VSS.n85 3.04274
R6405 VSS.n2514 VSS.n85 3.04274
R6406 VSS.n2518 VSS.n85 3.04274
R6407 VSS.n2444 VSS.n85 3.04274
R6408 VSS.n2442 VSS.n85 3.04274
R6409 VSS.n2526 VSS.n85 3.04274
R6410 VSS.n2530 VSS.n85 3.04274
R6411 VSS.n2534 VSS.n85 3.04274
R6412 VSS.n2536 VSS.n85 3.04274
R6413 VSS.n2540 VSS.n85 3.04274
R6414 VSS.n2435 VSS.n85 3.04274
R6415 VSS.n2433 VSS.n85 3.04274
R6416 VSS.n2431 VSS.n85 3.04274
R6417 VSS.n2546 VSS.n85 3.04274
R6418 VSS.n2550 VSS.n85 3.04274
R6419 VSS.n2553 VSS.n85 3.04274
R6420 VSS.n2557 VSS.n85 3.04274
R6421 VSS.n2425 VSS.n85 3.04274
R6422 VSS.n2561 VSS.n85 3.04274
R6423 VSS.n2564 VSS.n85 3.04274
R6424 VSS.n2567 VSS.n85 3.04274
R6425 VSS.n2420 VSS.n85 3.04274
R6426 VSS.n2418 VSS.n85 3.04274
R6427 VSS.n2416 VSS.n85 3.04274
R6428 VSS.n2414 VSS.n85 3.04274
R6429 VSS.n2412 VSS.n85 3.04274
R6430 VSS.n2410 VSS.n85 3.04274
R6431 VSS.n2408 VSS.n85 3.04274
R6432 VSS.n2406 VSS.n85 3.04274
R6433 VSS.n2580 VSS.n85 3.04274
R6434 VSS.n2401 VSS.n85 3.04274
R6435 VSS.n2399 VSS.n85 3.04274
R6436 VSS.n2397 VSS.n85 3.04274
R6437 VSS.n2395 VSS.n85 3.04274
R6438 VSS.n2588 VSS.n85 3.04274
R6439 VSS.n2592 VSS.n85 3.04274
R6440 VSS.n2389 VSS.n85 3.04274
R6441 VSS.n2387 VSS.n85 3.04274
R6442 VSS.n2597 VSS.n85 3.04274
R6443 VSS.n2384 VSS.n85 3.04274
R6444 VSS.n2382 VSS.n85 3.04274
R6445 VSS.n2380 VSS.n85 3.04274
R6446 VSS.n2378 VSS.n85 3.04274
R6447 VSS.n2376 VSS.n85 3.04274
R6448 VSS.n2374 VSS.n85 3.04274
R6449 VSS.n2372 VSS.n85 3.04274
R6450 VSS.n2370 VSS.n85 3.04274
R6451 VSS.n2368 VSS.n85 3.04274
R6452 VSS.n2608 VSS.n85 3.04274
R6453 VSS.n2365 VSS.n85 3.04274
R6454 VSS.n2363 VSS.n85 3.04274
R6455 VSS.n2361 VSS.n85 3.04274
R6456 VSS.n2359 VSS.n85 3.04274
R6457 VSS.n3861 VSS.n120 2.93359
R6458 VSS.n778 VSS.n217 2.77706
R6459 VSS.n67 VSS.n84 0.143988
R6460 VSS.n67 VSS.n180 2.75575
R6461 VSS.n3427 VSS.n3426 2.7456
R6462 VSS.n68 VSS.n2149 2.74446
R6463 VSS.n8 VSS.n2235 2.74397
R6464 VSS.t176 VSS.n217 2.74386
R6465 VSS.t55 VSS.n2196 2.72142
R6466 VSS.n1739 VSS.t519 2.46412
R6467 VSS.n68 VSS.n66 2.46343
R6468 VSS.n68 VSS.n3475 2.46343
R6469 VSS.n68 VSS.n3474 2.46343
R6470 VSS.n68 VSS.n2151 2.46343
R6471 VSS.n68 VSS.n2153 2.46343
R6472 VSS.n68 VSS.n2155 2.46343
R6473 VSS.n68 VSS.n2157 2.46343
R6474 VSS.n68 VSS.n3472 2.46343
R6475 VSS.n68 VSS.n3471 2.46343
R6476 VSS.n68 VSS.n3470 2.46343
R6477 VSS.n68 VSS.n3469 2.46343
R6478 VSS.n68 VSS.n2165 2.46343
R6479 VSS.n68 VSS.n2167 2.46343
R6480 VSS.n68 VSS.n2168 2.46343
R6481 VSS.n68 VSS.n2170 2.46343
R6482 VSS.n68 VSS.n2172 2.46343
R6483 VSS.n68 VSS.n2174 2.46343
R6484 VSS.n68 VSS.n3466 2.46343
R6485 VSS.n3424 VSS.n3423 2.43862
R6486 VSS.n67 VSS.n181 2.01633
R6487 VSS.t55 VSS.n2191 1.97632
R6488 VSS.t55 VSS.n2183 1.88189
R6489 VSS.n3442 VSS.n2248 1.88189
R6490 VSS.n3426 VSS.n2268 1.83435
R6491 VSS.n3740 VSS.n12 1.7562
R6492 VSS.n12 VSS.n34 1.75596
R6493 VSS.n8 VSS.n2246 1.75507
R6494 VSS.n2210 VSS.n2209 1.66925
R6495 VSS.n2144 VSS.n217 1.63922
R6496 VSS.n537 VSS.n217 1.63922
R6497 VSS.n542 VSS.n217 1.63922
R6498 VSS.n545 VSS.n217 1.63922
R6499 VSS.n547 VSS.n217 1.63922
R6500 VSS.n3567 VSS.t491 1.43372
R6501 VSS.t489 VSS.n3569 1.43372
R6502 VSS.t491 VSS.n3572 1.42949
R6503 VSS.t489 VSS.n3570 1.42949
R6504 VSS.t265 VSS.t257 1.41892
R6505 VSS.t264 VSS.t255 1.41892
R6506 VSS.t262 VSS.t263 1.41892
R6507 VSS.t259 VSS.t260 1.41892
R6508 VSS.t486 VSS.n3505 1.37661
R6509 VSS.n3504 VSS.t486 1.37661
R6510 VSS.n825 VSS.n217 1.35591
R6511 VSS.n67 VSS.n175 1.32857
R6512 VSS.n2263 VSS.n2260 1.3114
R6513 VSS.n12 VSS.n11 0.895737
R6514 VSS.n3008 VSS.n119 0.851
R6515 VSS.t497 VSS.t500 0.806856
R6516 VSS.t510 VSS.t165 0.806856
R6517 VSS.n2238 VSS.t504 0.806855
R6518 VSS.n3117 VSS.n118 0.805602
R6519 VSS.n2236 VSS.t569 0.802775
R6520 VSS.t630 VSS.n833 0.802775
R6521 VSS.t567 VSS.n1091 0.802775
R6522 VSS.n1070 VSS.t563 0.802775
R6523 VSS.n1064 VSS.t549 0.802775
R6524 VSS.n1054 VSS.t547 0.802775
R6525 VSS.n1048 VSS.t608 0.802775
R6526 VSS.n1038 VSS.t604 0.802775
R6527 VSS.n1032 VSS.t557 0.802775
R6528 VSS.n1022 VSS.t551 0.802775
R6529 VSS.n1016 VSS.t612 0.802775
R6530 VSS.n1006 VSS.t543 0.802775
R6531 VSS.n1000 VSS.t610 0.802775
R6532 VSS.n990 VSS.t533 0.802775
R6533 VSS.n984 VSS.t553 0.802775
R6534 VSS.n974 VSS.t614 0.802775
R6535 VSS.n968 VSS.t606 0.802775
R6536 VSS.n958 VSS.t535 0.802775
R6537 VSS.n952 VSS.t539 0.802775
R6538 VSS.n942 VSS.t616 0.802775
R6539 VSS.n936 VSS.t559 0.802775
R6540 VSS.n926 VSS.t618 0.802775
R6541 VSS.n920 VSS.t624 0.802775
R6542 VSS.n910 VSS.t545 0.802775
R6543 VSS.n904 VSS.t622 0.802775
R6544 VSS.n894 VSS.t620 0.802775
R6545 VSS.n888 VSS.t537 0.802775
R6546 VSS.n878 VSS.t626 0.802775
R6547 VSS.n872 VSS.t565 0.802775
R6548 VSS.n862 VSS.t541 0.802775
R6549 VSS.n856 VSS.t561 0.802775
R6550 VSS.n846 VSS.t628 0.802775
R6551 VSS.n839 VSS.t555 0.802775
R6552 VSS.t476 VSS.t517 0.802775
R6553 VSS.n3449 VSS.n2206 0.801519
R6554 VSS.n3440 VSS.n118 0.768682
R6555 VSS.t518 VSS.n827 0.723599
R6556 VSS.n3595 VSS.t265 0.722582
R6557 VSS.n3560 VSS.t264 0.722582
R6558 VSS.t263 VSS.n3614 0.722582
R6559 VSS.n3667 VSS.t259 0.722582
R6560 VSS.t257 VSS.n3594 0.72222
R6561 VSS.t255 VSS.n3559 0.72222
R6562 VSS.n3615 VSS.t262 0.72222
R6563 VSS.t260 VSS.n3666 0.72222
R6564 VSS.n67 VSS.n82 0.721231
R6565 VSS.n67 VSS.n70 0.720881
R6566 VSS.n67 VSS.n71 0.720881
R6567 VSS.n67 VSS.n72 0.720881
R6568 VSS.n67 VSS.n73 0.720881
R6569 VSS.n67 VSS.n74 0.720881
R6570 VSS.n67 VSS.n75 0.720881
R6571 VSS.n67 VSS.n76 0.720881
R6572 VSS.n67 VSS.n77 0.720881
R6573 VSS.n67 VSS.n78 0.720881
R6574 VSS.n67 VSS.n79 0.720881
R6575 VSS.n67 VSS.n80 0.720881
R6576 VSS.n67 VSS.n81 0.720881
R6577 VSS.n3433 VSS.n3432 0.6955
R6578 VSS.n3860 VSS.n121 0.692362
R6579 VSS.n3653 VSS.n3652 0.692362
R6580 VSS.n1431 VSS.n1430 0.692362
R6581 VSS.n1422 VSS.n1421 0.692362
R6582 VSS.n1413 VSS.n1412 0.692362
R6583 VSS.n1404 VSS.n1403 0.692362
R6584 VSS.n1395 VSS.n1394 0.692362
R6585 VSS.n1386 VSS.n1385 0.692362
R6586 VSS.n1377 VSS.n1376 0.692362
R6587 VSS.n1368 VSS.n1367 0.692362
R6588 VSS.n1359 VSS.n1358 0.692362
R6589 VSS.n1350 VSS.n1349 0.692362
R6590 VSS.n1341 VSS.n1340 0.692362
R6591 VSS.n1332 VSS.n1331 0.692362
R6592 VSS.n1323 VSS.n1322 0.692362
R6593 VSS.n1314 VSS.n1313 0.692362
R6594 VSS.n1305 VSS.n1304 0.692362
R6595 VSS.n1296 VSS.n1295 0.692362
R6596 VSS.n1287 VSS.n1286 0.692362
R6597 VSS.n1278 VSS.n1277 0.692362
R6598 VSS.n1269 VSS.n1268 0.692362
R6599 VSS.n1260 VSS.n1259 0.692362
R6600 VSS.n1251 VSS.n1250 0.692362
R6601 VSS.n1242 VSS.n1241 0.692362
R6602 VSS.n1233 VSS.n1232 0.692362
R6603 VSS.n1224 VSS.n1223 0.692362
R6604 VSS.n1215 VSS.n1214 0.692362
R6605 VSS.n1206 VSS.n1205 0.692362
R6606 VSS.n1197 VSS.n1196 0.692362
R6607 VSS.n1188 VSS.n1187 0.692362
R6608 VSS.n1179 VSS.n1178 0.692362
R6609 VSS.n1170 VSS.n1169 0.692362
R6610 VSS.n1161 VSS.n1160 0.692362
R6611 VSS.n3448 VSS.n2207 0.66578
R6612 VSS.n119 VSS.n118 0.649291
R6613 VSS.n2143 VSS.n218 0.613782
R6614 VSS.n2140 VSS.n218 0.613782
R6615 VSS.n2135 VSS.n218 0.613782
R6616 VSS.n2132 VSS.n218 0.613782
R6617 VSS.n2130 VSS.n218 0.613782
R6618 VSS.n2127 VSS.n218 0.613782
R6619 VSS.n2014 VSS.n289 0.613782
R6620 VSS.n1967 VSS.n328 0.613782
R6621 VSS.n1920 VSS.n367 0.613782
R6622 VSS.n1920 VSS.n402 0.613782
R6623 VSS.n1834 VSS.n451 0.613782
R6624 VSS.n1787 VSS.n490 0.613782
R6625 VSS.n1740 VSS.n532 0.613782
R6626 VSS.t509 VSS.n2242 0.595317
R6627 VSS.t506 VSS.n2243 0.595317
R6628 VSS.t503 VSS.n2231 0.595317
R6629 VSS.t499 VSS.n2232 0.595317
R6630 VSS.n1440 VSS.t512 0.595317
R6631 VSS.n1438 VSS.t514 0.595317
R6632 VSS.t226 VSS.n2191 0.586866
R6633 VSS.n3035 VSS.t426 0.572871
R6634 VSS.n3019 VSS.t428 0.572871
R6635 VSS.t55 VSS.n2185 0.557126
R6636 VSS.n549 VSS.n217 0.556788
R6637 VSS.n3464 VSS.n3463 0.548518
R6638 VSS.n2247 VSS.n2246 0.52186
R6639 VSS.t491 VSS.t489 0.492336
R6640 VSS.n3029 VSS.n2650 0.490843
R6641 VSS.n3025 VSS.n2650 0.490843
R6642 VSS.n3023 VSS.n2650 0.490843
R6643 VSS.n3010 VSS.n2618 0.490843
R6644 VSS.n3032 VSS.t426 0.489061
R6645 VSS.n3016 VSS.t428 0.489061
R6646 VSS.t55 VSS.n2188 0.477286
R6647 VSS.t55 VSS.n2187 0.472981
R6648 VSS.n3638 VSS.n3635 0.461741
R6649 VSS.n3500 VSS.n3498 0.461741
R6650 VSS.n1509 VSS.n1084 0.461741
R6651 VSS.n1519 VSS.n1518 0.461741
R6652 VSS.n1529 VSS.n1067 0.461741
R6653 VSS.n1535 VSS.n1058 0.461741
R6654 VSS.n1543 VSS.n1051 0.461741
R6655 VSS.n1549 VSS.n1042 0.461741
R6656 VSS.n1557 VSS.n1035 0.461741
R6657 VSS.n1563 VSS.n1026 0.461741
R6658 VSS.n1571 VSS.n1019 0.461741
R6659 VSS.n1577 VSS.n1010 0.461741
R6660 VSS.n1585 VSS.n1003 0.461741
R6661 VSS.n1591 VSS.n994 0.461741
R6662 VSS.n1599 VSS.n987 0.461741
R6663 VSS.n1605 VSS.n978 0.461741
R6664 VSS.n1613 VSS.n971 0.461741
R6665 VSS.n1619 VSS.n962 0.461741
R6666 VSS.n1627 VSS.n955 0.461741
R6667 VSS.n1633 VSS.n946 0.461741
R6668 VSS.n1641 VSS.n939 0.461741
R6669 VSS.n1647 VSS.n930 0.461741
R6670 VSS.n1655 VSS.n923 0.461741
R6671 VSS.n1661 VSS.n914 0.461741
R6672 VSS.n1669 VSS.n907 0.461741
R6673 VSS.n1675 VSS.n898 0.461741
R6674 VSS.n1683 VSS.n891 0.461741
R6675 VSS.n1689 VSS.n882 0.461741
R6676 VSS.n1697 VSS.n875 0.461741
R6677 VSS.n1703 VSS.n866 0.461741
R6678 VSS.n1711 VSS.n859 0.461741
R6679 VSS.n1717 VSS.n850 0.461741
R6680 VSS.n1725 VSS.n843 0.461741
R6681 VSS.n841 VSS.n836 0.461741
R6682 VSS.n2246 VSS.n2245 0.447348
R6683 VSS.n1484 VSS.n272 0.44402
R6684 VSS.n3456 VSS.n3455 0.437466
R6685 VSS.n3509 VSS.n120 0.427593
R6686 VSS.n3740 VSS.n3739 0.417336
R6687 VSS.n3858 VSS.n34 0.417043
R6688 VSS.n3739 VSS.n34 0.416074
R6689 VSS.n3741 VSS.n3740 0.415796
R6690 VSS.n3448 VSS.n3447 0.41058
R6691 VSS.n2191 VSS.n2258 0.407016
R6692 VSS.n3041 VSS.t292 0.400619
R6693 VSS.n2617 VSS.n2616 0.390431
R6694 VSS.n2930 VSS.n2929 0.390431
R6695 VSS.n3573 VSS.n181 0.36227
R6696 VSS.n2208 VSS.n2196 0.354963
R6697 VSS.n8 VSS.n3 0.351198
R6698 VSS.n1446 VSS.n1445 0.346431
R6699 VSS.n3441 VSS.n3440 0.345789
R6700 VSS.n3650 VSS.n2149 0.330049
R6701 VSS.n2235 VSS.n2234 0.312321
R6702 VSS.n3855 VSS.n123 0.31114
R6703 VSS.t630 VSS.t176 0.302137
R6704 VSS.t518 VSS.n825 0.300523
R6705 VSS.n2253 VSS.n2196 0.296592
R6706 VSS.n3429 VSS.n3428 0.293017
R6707 VSS.n2214 VSS.n2213 0.291601
R6708 VSS.n1452 VSS.n1451 0.289639
R6709 VSS.n2214 VSS.n2210 0.287886
R6710 VSS.n3117 VSS.n3116 0.2855
R6711 VSS.n1428 VSS.t42 0.28485
R6712 VSS.n1419 VSS.t364 0.28485
R6713 VSS.n1410 VSS.t253 0.28485
R6714 VSS.n1401 VSS.t26 0.28485
R6715 VSS.n1392 VSS.t219 0.28485
R6716 VSS.n1383 VSS.t393 0.28485
R6717 VSS.n1374 VSS.t40 0.28485
R6718 VSS.n1365 VSS.t294 0.28485
R6719 VSS.n1356 VSS.t223 0.28485
R6720 VSS.n1347 VSS.t397 0.28485
R6721 VSS.n1338 VSS.t60 0.28485
R6722 VSS.n1329 VSS.t221 0.28485
R6723 VSS.n1320 VSS.t181 0.28485
R6724 VSS.n1311 VSS.t652 0.28485
R6725 VSS.n1302 VSS.t308 0.28485
R6726 VSS.n1293 VSS.t206 0.28485
R6727 VSS.n1284 VSS.t385 0.28485
R6728 VSS.n1275 VSS.t17 0.28485
R6729 VSS.n1266 VSS.t232 0.28485
R6730 VSS.n1257 VSS.t324 0.28485
R6731 VSS.n1248 VSS.t57 0.28485
R6732 VSS.n1239 VSS.t242 0.28485
R6733 VSS.n1230 VSS.t44 0.28485
R6734 VSS.n1221 VSS.t451 0.28485
R6735 VSS.n1212 VSS.t289 0.28485
R6736 VSS.n1203 VSS.t282 0.28485
R6737 VSS.n1194 VSS.t15 0.28485
R6738 VSS.n1185 VSS.t286 0.28485
R6739 VSS.n1176 VSS.t321 0.28485
R6740 VSS.n1167 VSS.t388 0.28485
R6741 VSS.n1158 VSS.t635 0.28485
R6742 VSS.n1451 VSS.n1450 0.28352
R6743 VSS.t569 VSS.n2218 0.2761
R6744 VSS.n3573 VSS.n180 0.267902
R6745 VSS.n777 VSS.n217 0.267794
R6746 VSS.n769 VSS.n217 0.267794
R6747 VSS.n766 VSS.n217 0.267794
R6748 VSS.n762 VSS.n217 0.267794
R6749 VSS.n755 VSS.n217 0.267794
R6750 VSS.n752 VSS.n217 0.267794
R6751 VSS.n748 VSS.n217 0.267794
R6752 VSS.n741 VSS.n217 0.267794
R6753 VSS.n735 VSS.n217 0.267794
R6754 VSS.n734 VSS.n217 0.267794
R6755 VSS.n727 VSS.n217 0.267794
R6756 VSS.n724 VSS.n217 0.267794
R6757 VSS.n720 VSS.n217 0.267794
R6758 VSS.n713 VSS.n217 0.267794
R6759 VSS.n710 VSS.n217 0.267794
R6760 VSS.n707 VSS.n217 0.267794
R6761 VSS.n706 VSS.n217 0.267794
R6762 VSS.n699 VSS.n217 0.267794
R6763 VSS.n696 VSS.n217 0.267794
R6764 VSS.n692 VSS.n217 0.267794
R6765 VSS.n685 VSS.n217 0.267794
R6766 VSS.n682 VSS.n217 0.267794
R6767 VSS.n679 VSS.n217 0.267794
R6768 VSS.n678 VSS.n217 0.267794
R6769 VSS.n668 VSS.n217 0.267794
R6770 VSS.n665 VSS.n217 0.267794
R6771 VSS.n664 VSS.n217 0.267794
R6772 VSS.n657 VSS.n217 0.267794
R6773 VSS.n654 VSS.n217 0.267794
R6774 VSS.n651 VSS.n217 0.267794
R6775 VSS.n650 VSS.n217 0.267794
R6776 VSS.n643 VSS.n217 0.267794
R6777 VSS.n640 VSS.n217 0.267794
R6778 VSS.n629 VSS.n217 0.267794
R6779 VSS.n626 VSS.n217 0.267794
R6780 VSS.n623 VSS.n217 0.267794
R6781 VSS.n615 VSS.n217 0.267794
R6782 VSS.n612 VSS.n217 0.267794
R6783 VSS.n608 VSS.n217 0.267794
R6784 VSS.n601 VSS.n217 0.267794
R6785 VSS.n595 VSS.n217 0.267794
R6786 VSS.n594 VSS.n217 0.267794
R6787 VSS.n587 VSS.n217 0.267794
R6788 VSS.n584 VSS.n217 0.267794
R6789 VSS.n581 VSS.n217 0.267794
R6790 VSS.n570 VSS.n217 0.267794
R6791 VSS.n567 VSS.n217 0.267794
R6792 VSS.n566 VSS.n217 0.267794
R6793 VSS.n559 VSS.n217 0.267794
R6794 VSS.n553 VSS.n217 0.267794
R6795 VSS.n550 VSS.n217 0.267794
R6796 VSS.n556 VSS.n217 0.267794
R6797 VSS.n573 VSS.n217 0.267794
R6798 VSS.n580 VSS.n217 0.267794
R6799 VSS.n598 VSS.n217 0.267794
R6800 VSS.n609 VSS.n217 0.267794
R6801 VSS.n622 VSS.n217 0.267794
R6802 VSS.n636 VSS.n217 0.267794
R6803 VSS.n637 VSS.n217 0.267794
R6804 VSS.n671 VSS.n217 0.267794
R6805 VSS.n693 VSS.n217 0.267794
R6806 VSS.n721 VSS.n217 0.267794
R6807 VSS.n738 VSS.n217 0.267794
R6808 VSS.n749 VSS.n217 0.267794
R6809 VSS.n763 VSS.n217 0.267794
R6810 VSS.n3858 VSS.n3857 0.266107
R6811 VSS.n2231 VSS.n2218 0.266107
R6812 VSS.n3857 VSS.n3856 0.2636
R6813 VSS.t42 VSS.t567 0.256107
R6814 VSS.t364 VSS.t563 0.256107
R6815 VSS.t253 VSS.t549 0.256107
R6816 VSS.t26 VSS.t547 0.256107
R6817 VSS.t219 VSS.t608 0.256107
R6818 VSS.t393 VSS.t604 0.256107
R6819 VSS.t40 VSS.t557 0.256107
R6820 VSS.t294 VSS.t551 0.256107
R6821 VSS.t223 VSS.t612 0.256107
R6822 VSS.t397 VSS.t543 0.256107
R6823 VSS.t60 VSS.t610 0.256107
R6824 VSS.t221 VSS.t533 0.256107
R6825 VSS.t181 VSS.t553 0.256107
R6826 VSS.t652 VSS.t614 0.256107
R6827 VSS.t308 VSS.t606 0.256107
R6828 VSS.t206 VSS.t535 0.256107
R6829 VSS.t385 VSS.t539 0.256107
R6830 VSS.t17 VSS.t616 0.256107
R6831 VSS.t232 VSS.t559 0.256107
R6832 VSS.t324 VSS.t618 0.256107
R6833 VSS.t57 VSS.t624 0.256107
R6834 VSS.t242 VSS.t545 0.256107
R6835 VSS.t44 VSS.t622 0.256107
R6836 VSS.t451 VSS.t620 0.256107
R6837 VSS.t289 VSS.t537 0.256107
R6838 VSS.t282 VSS.t626 0.256107
R6839 VSS.t15 VSS.t565 0.256107
R6840 VSS.t286 VSS.t541 0.256107
R6841 VSS.t321 VSS.t561 0.256107
R6842 VSS.t388 VSS.t628 0.256107
R6843 VSS.t635 VSS.t555 0.256107
R6844 VSS.t176 VSS.t517 0.254637
R6845 VSS.t519 VSS.n825 0.254083
R6846 VSS.n3464 VSS.n181 0.248324
R6847 VSS.n3430 VSS.n3429 0.244498
R6848 VSS.t332 VSS.n2200 0.240825
R6849 VSS.t488 VSS.n3501 0.239006
R6850 VSS.n2236 VSS.n2235 0.238218
R6851 VSS.n3654 VSS.n2149 0.236768
R6852 VSS.n3139 VSS.n87 0.233757
R6853 VSS.n3133 VSS.n3132 0.233757
R6854 VSS.n3135 VSS.n3134 0.233757
R6855 VSS.n3136 VSS.n3121 0.233757
R6856 VSS.n3132 VSS.n3131 0.233419
R6857 VSS.n3134 VSS.n3133 0.233419
R6858 VSS.n3136 VSS.n3135 0.233419
R6859 VSS.n2072 VSS.n270 0.231121
R6860 VSS.n270 VSS.n269 0.231121
R6861 VSS.n269 VSS.n267 0.231121
R6862 VSS.n267 VSS.n266 0.231121
R6863 VSS.n266 VSS.n265 0.231121
R6864 VSS.n265 VSS.n263 0.231121
R6865 VSS.n263 VSS.n261 0.231121
R6866 VSS.n261 VSS.n260 0.231121
R6867 VSS.n260 VSS.n259 0.231121
R6868 VSS.n259 VSS.n257 0.231121
R6869 VSS.n257 VSS.n255 0.231121
R6870 VSS.n255 VSS.n254 0.231121
R6871 VSS.n254 VSS.n253 0.231121
R6872 VSS.n253 VSS.n251 0.231121
R6873 VSS.n251 VSS.n249 0.231121
R6874 VSS.n249 VSS.n248 0.231121
R6875 VSS.n248 VSS.n246 0.231121
R6876 VSS.n246 VSS.n245 0.231121
R6877 VSS.n245 VSS.n243 0.231121
R6878 VSS.n243 VSS.n241 0.231121
R6879 VSS.n241 VSS.n240 0.231121
R6880 VSS.n240 VSS.n239 0.231121
R6881 VSS.n239 VSS.n238 0.231121
R6882 VSS.n238 VSS.n237 0.231121
R6883 VSS.n237 VSS.n236 0.231121
R6884 VSS.n236 VSS.n235 0.231121
R6885 VSS.n235 VSS.n234 0.231121
R6886 VSS.n234 VSS.n233 0.231121
R6887 VSS.n233 VSS.n232 0.231121
R6888 VSS.n232 VSS.n231 0.231121
R6889 VSS.n231 VSS.n230 0.231121
R6890 VSS.n230 VSS.n229 0.231121
R6891 VSS.n229 VSS.n227 0.231121
R6892 VSS.n227 VSS.n226 0.231121
R6893 VSS.n226 VSS.n225 0.231121
R6894 VSS.n2034 VSS.n225 0.231121
R6895 VSS.n2034 VSS.n2033 0.231121
R6896 VSS.n2033 VSS.n2032 0.231121
R6897 VSS.n2032 VSS.n274 0.231121
R6898 VSS.n2028 VSS.n274 0.231121
R6899 VSS.n2028 VSS.n276 0.231121
R6900 VSS.n2020 VSS.n276 0.231121
R6901 VSS.n2020 VSS.n284 0.231121
R6902 VSS.n2016 VSS.n284 0.231121
R6903 VSS.n2016 VSS.n286 0.231121
R6904 VSS.n2001 VSS.n286 0.231121
R6905 VSS.n2001 VSS.n2000 0.231121
R6906 VSS.n2005 VSS.n2000 0.231121
R6907 VSS.n2006 VSS.n2005 0.231121
R6908 VSS.n2007 VSS.n2006 0.231121
R6909 VSS.n2007 VSS.n304 0.231121
R6910 VSS.n2011 VSS.n304 0.231121
R6911 VSS.n2011 VSS.n302 0.231121
R6912 VSS.n1993 VSS.n302 0.231121
R6913 VSS.n1993 VSS.n1991 0.231121
R6914 VSS.n1991 VSS.n306 0.231121
R6915 VSS.n314 VSS.n306 0.231121
R6916 VSS.n1986 VSS.n314 0.231121
R6917 VSS.n1986 VSS.n313 0.231121
R6918 VSS.n1980 VSS.n313 0.231121
R6919 VSS.n1980 VSS.n316 0.231121
R6920 VSS.n1973 VSS.n316 0.231121
R6921 VSS.n1973 VSS.n323 0.231121
R6922 VSS.n1969 VSS.n323 0.231121
R6923 VSS.n1969 VSS.n325 0.231121
R6924 VSS.n1954 VSS.n325 0.231121
R6925 VSS.n1954 VSS.n1953 0.231121
R6926 VSS.n1958 VSS.n1953 0.231121
R6927 VSS.n1959 VSS.n1958 0.231121
R6928 VSS.n1960 VSS.n1959 0.231121
R6929 VSS.n1960 VSS.n343 0.231121
R6930 VSS.n1964 VSS.n343 0.231121
R6931 VSS.n1964 VSS.n341 0.231121
R6932 VSS.n1946 VSS.n341 0.231121
R6933 VSS.n1946 VSS.n1944 0.231121
R6934 VSS.n1944 VSS.n345 0.231121
R6935 VSS.n353 VSS.n345 0.231121
R6936 VSS.n1939 VSS.n353 0.231121
R6937 VSS.n1939 VSS.n352 0.231121
R6938 VSS.n1933 VSS.n352 0.231121
R6939 VSS.n1933 VSS.n355 0.231121
R6940 VSS.n1926 VSS.n355 0.231121
R6941 VSS.n1926 VSS.n362 0.231121
R6942 VSS.n1922 VSS.n362 0.231121
R6943 VSS.n1922 VSS.n364 0.231121
R6944 VSS.n1907 VSS.n364 0.231121
R6945 VSS.n1907 VSS.n1906 0.231121
R6946 VSS.n1911 VSS.n1906 0.231121
R6947 VSS.n1912 VSS.n1911 0.231121
R6948 VSS.n1913 VSS.n1912 0.231121
R6949 VSS.n1913 VSS.n408 0.231121
R6950 VSS.n1917 VSS.n408 0.231121
R6951 VSS.n1917 VSS.n406 0.231121
R6952 VSS.n1899 VSS.n406 0.231121
R6953 VSS.n1899 VSS.n1897 0.231121
R6954 VSS.n1897 VSS.n1895 0.231121
R6955 VSS.n1895 VSS.n411 0.231121
R6956 VSS.n1891 VSS.n411 0.231121
R6957 VSS.n1891 VSS.n1889 0.231121
R6958 VSS.n1889 VSS.n1887 0.231121
R6959 VSS.n1887 VSS.n415 0.231121
R6960 VSS.n1883 VSS.n415 0.231121
R6961 VSS.n1883 VSS.n1881 0.231121
R6962 VSS.n1881 VSS.n1879 0.231121
R6963 VSS.n1879 VSS.n419 0.231121
R6964 VSS.n1875 VSS.n419 0.231121
R6965 VSS.n1875 VSS.n1874 0.231121
R6966 VSS.n1874 VSS.n1872 0.231121
R6967 VSS.n1872 VSS.n423 0.231121
R6968 VSS.n1868 VSS.n423 0.231121
R6969 VSS.n1868 VSS.n1866 0.231121
R6970 VSS.n1866 VSS.n1864 0.231121
R6971 VSS.n1864 VSS.n427 0.231121
R6972 VSS.n1860 VSS.n427 0.231121
R6973 VSS.n1860 VSS.n1858 0.231121
R6974 VSS.n1858 VSS.n429 0.231121
R6975 VSS.n437 VSS.n429 0.231121
R6976 VSS.n1853 VSS.n437 0.231121
R6977 VSS.n1853 VSS.n436 0.231121
R6978 VSS.n1847 VSS.n436 0.231121
R6979 VSS.n1847 VSS.n439 0.231121
R6980 VSS.n1840 VSS.n439 0.231121
R6981 VSS.n1840 VSS.n446 0.231121
R6982 VSS.n1836 VSS.n446 0.231121
R6983 VSS.n1836 VSS.n448 0.231121
R6984 VSS.n1821 VSS.n448 0.231121
R6985 VSS.n1821 VSS.n1820 0.231121
R6986 VSS.n1825 VSS.n1820 0.231121
R6987 VSS.n1826 VSS.n1825 0.231121
R6988 VSS.n1827 VSS.n1826 0.231121
R6989 VSS.n1827 VSS.n466 0.231121
R6990 VSS.n1831 VSS.n466 0.231121
R6991 VSS.n1831 VSS.n464 0.231121
R6992 VSS.n1813 VSS.n464 0.231121
R6993 VSS.n1813 VSS.n1811 0.231121
R6994 VSS.n1811 VSS.n468 0.231121
R6995 VSS.n476 VSS.n468 0.231121
R6996 VSS.n1806 VSS.n476 0.231121
R6997 VSS.n1806 VSS.n475 0.231121
R6998 VSS.n1800 VSS.n475 0.231121
R6999 VSS.n1800 VSS.n478 0.231121
R7000 VSS.n1793 VSS.n478 0.231121
R7001 VSS.n1793 VSS.n485 0.231121
R7002 VSS.n1789 VSS.n485 0.231121
R7003 VSS.n1789 VSS.n487 0.231121
R7004 VSS.n1774 VSS.n487 0.231121
R7005 VSS.n1774 VSS.n1773 0.231121
R7006 VSS.n1778 VSS.n1773 0.231121
R7007 VSS.n1779 VSS.n1778 0.231121
R7008 VSS.n1780 VSS.n1779 0.231121
R7009 VSS.n1780 VSS.n505 0.231121
R7010 VSS.n1784 VSS.n505 0.231121
R7011 VSS.n1784 VSS.n503 0.231121
R7012 VSS.n1766 VSS.n503 0.231121
R7013 VSS.n1766 VSS.n1764 0.231121
R7014 VSS.n1764 VSS.n507 0.231121
R7015 VSS.n515 VSS.n507 0.231121
R7016 VSS.n1759 VSS.n515 0.231121
R7017 VSS.n1759 VSS.n514 0.231121
R7018 VSS.n1753 VSS.n514 0.231121
R7019 VSS.n1753 VSS.n517 0.231121
R7020 VSS.n1746 VSS.n517 0.231121
R7021 VSS.n1746 VSS.n524 0.231121
R7022 VSS.n1742 VSS.n524 0.231121
R7023 VSS.n1742 VSS.n526 0.231121
R7024 VSS.n801 VSS.n526 0.231121
R7025 VSS.n803 VSS.n801 0.231121
R7026 VSS.n804 VSS.n803 0.231121
R7027 VSS.n806 VSS.n804 0.231121
R7028 VSS.n808 VSS.n806 0.231121
R7029 VSS.n810 VSS.n808 0.231121
R7030 VSS.n811 VSS.n810 0.231121
R7031 VSS.n813 VSS.n811 0.231121
R7032 VSS.n815 VSS.n813 0.231121
R7033 VSS.n817 VSS.n815 0.231121
R7034 VSS.n819 VSS.n817 0.231121
R7035 VSS.n821 VSS.n819 0.231121
R7036 VSS.n821 VSS.n789 0.231121
R7037 VSS.n2071 VSS.n2070 0.231121
R7038 VSS.n2070 VSS.n2069 0.231121
R7039 VSS.n2069 VSS.n2068 0.231121
R7040 VSS.n2068 VSS.n2067 0.231121
R7041 VSS.n2067 VSS.n2066 0.231121
R7042 VSS.n2066 VSS.n2065 0.231121
R7043 VSS.n2065 VSS.n2064 0.231121
R7044 VSS.n2064 VSS.n2063 0.231121
R7045 VSS.n2063 VSS.n2062 0.231121
R7046 VSS.n2062 VSS.n2061 0.231121
R7047 VSS.n2061 VSS.n2060 0.231121
R7048 VSS.n2060 VSS.n2059 0.231121
R7049 VSS.n2059 VSS.n2058 0.231121
R7050 VSS.n2058 VSS.n2057 0.231121
R7051 VSS.n2057 VSS.n2056 0.231121
R7052 VSS.n2056 VSS.n2055 0.231121
R7053 VSS.n2055 VSS.n2054 0.231121
R7054 VSS.n2054 VSS.n2053 0.231121
R7055 VSS.n2053 VSS.n2052 0.231121
R7056 VSS.n2052 VSS.n2051 0.231121
R7057 VSS.n2051 VSS.n2050 0.231121
R7058 VSS.n2050 VSS.n2049 0.231121
R7059 VSS.n2049 VSS.n2048 0.231121
R7060 VSS.n2048 VSS.n2047 0.231121
R7061 VSS.n2047 VSS.n2046 0.231121
R7062 VSS.n2046 VSS.n2045 0.231121
R7063 VSS.n2045 VSS.n2044 0.231121
R7064 VSS.n2044 VSS.n2043 0.231121
R7065 VSS.n2043 VSS.n2042 0.231121
R7066 VSS.n2042 VSS.n2041 0.231121
R7067 VSS.n2041 VSS.n2040 0.231121
R7068 VSS.n2040 VSS.n2039 0.231121
R7069 VSS.n2039 VSS.n2038 0.231121
R7070 VSS.n2038 VSS.n2037 0.231121
R7071 VSS.n2037 VSS.n2036 0.231121
R7072 VSS.n2036 VSS.n2035 0.231121
R7073 VSS.n2035 VSS.n273 0.231121
R7074 VSS.n2031 VSS.n273 0.231121
R7075 VSS.n2031 VSS.n2030 0.231121
R7076 VSS.n2030 VSS.n2029 0.231121
R7077 VSS.n2029 VSS.n275 0.231121
R7078 VSS.n2019 VSS.n275 0.231121
R7079 VSS.n2019 VSS.n2018 0.231121
R7080 VSS.n2018 VSS.n2017 0.231121
R7081 VSS.n2017 VSS.n285 0.231121
R7082 VSS.n2002 VSS.n285 0.231121
R7083 VSS.n2003 VSS.n2002 0.231121
R7084 VSS.n2004 VSS.n2003 0.231121
R7085 VSS.n2004 VSS.n1996 0.231121
R7086 VSS.n2008 VSS.n1996 0.231121
R7087 VSS.n2009 VSS.n2008 0.231121
R7088 VSS.n2010 VSS.n2009 0.231121
R7089 VSS.n2010 VSS.n1995 0.231121
R7090 VSS.n1995 VSS.n1994 0.231121
R7091 VSS.n1994 VSS.n305 0.231121
R7092 VSS.n1983 VSS.n305 0.231121
R7093 VSS.n1984 VSS.n1983 0.231121
R7094 VSS.n1985 VSS.n1984 0.231121
R7095 VSS.n1985 VSS.n1982 0.231121
R7096 VSS.n1982 VSS.n1981 0.231121
R7097 VSS.n1981 VSS.n315 0.231121
R7098 VSS.n1972 VSS.n315 0.231121
R7099 VSS.n1972 VSS.n1971 0.231121
R7100 VSS.n1971 VSS.n1970 0.231121
R7101 VSS.n1970 VSS.n324 0.231121
R7102 VSS.n1955 VSS.n324 0.231121
R7103 VSS.n1956 VSS.n1955 0.231121
R7104 VSS.n1957 VSS.n1956 0.231121
R7105 VSS.n1957 VSS.n1949 0.231121
R7106 VSS.n1961 VSS.n1949 0.231121
R7107 VSS.n1962 VSS.n1961 0.231121
R7108 VSS.n1963 VSS.n1962 0.231121
R7109 VSS.n1963 VSS.n1948 0.231121
R7110 VSS.n1948 VSS.n1947 0.231121
R7111 VSS.n1947 VSS.n344 0.231121
R7112 VSS.n1936 VSS.n344 0.231121
R7113 VSS.n1937 VSS.n1936 0.231121
R7114 VSS.n1938 VSS.n1937 0.231121
R7115 VSS.n1938 VSS.n1935 0.231121
R7116 VSS.n1935 VSS.n1934 0.231121
R7117 VSS.n1934 VSS.n354 0.231121
R7118 VSS.n1925 VSS.n354 0.231121
R7119 VSS.n1925 VSS.n1924 0.231121
R7120 VSS.n1924 VSS.n1923 0.231121
R7121 VSS.n1923 VSS.n363 0.231121
R7122 VSS.n1908 VSS.n363 0.231121
R7123 VSS.n1909 VSS.n1908 0.231121
R7124 VSS.n1910 VSS.n1909 0.231121
R7125 VSS.n1910 VSS.n1902 0.231121
R7126 VSS.n1914 VSS.n1902 0.231121
R7127 VSS.n1915 VSS.n1914 0.231121
R7128 VSS.n1916 VSS.n1915 0.231121
R7129 VSS.n1916 VSS.n1901 0.231121
R7130 VSS.n1901 VSS.n1900 0.231121
R7131 VSS.n1900 VSS.n409 0.231121
R7132 VSS.n1894 VSS.n409 0.231121
R7133 VSS.n1894 VSS.n1893 0.231121
R7134 VSS.n1893 VSS.n1892 0.231121
R7135 VSS.n1892 VSS.n413 0.231121
R7136 VSS.n1886 VSS.n413 0.231121
R7137 VSS.n1886 VSS.n1885 0.231121
R7138 VSS.n1885 VSS.n1884 0.231121
R7139 VSS.n1884 VSS.n417 0.231121
R7140 VSS.n1878 VSS.n417 0.231121
R7141 VSS.n1878 VSS.n1877 0.231121
R7142 VSS.n1877 VSS.n1876 0.231121
R7143 VSS.n1876 VSS.n421 0.231121
R7144 VSS.n1871 VSS.n421 0.231121
R7145 VSS.n1871 VSS.n1870 0.231121
R7146 VSS.n1870 VSS.n1869 0.231121
R7147 VSS.n1869 VSS.n425 0.231121
R7148 VSS.n1863 VSS.n425 0.231121
R7149 VSS.n1863 VSS.n1862 0.231121
R7150 VSS.n1862 VSS.n1861 0.231121
R7151 VSS.n1861 VSS.n428 0.231121
R7152 VSS.n1850 VSS.n428 0.231121
R7153 VSS.n1851 VSS.n1850 0.231121
R7154 VSS.n1852 VSS.n1851 0.231121
R7155 VSS.n1852 VSS.n1849 0.231121
R7156 VSS.n1849 VSS.n1848 0.231121
R7157 VSS.n1848 VSS.n438 0.231121
R7158 VSS.n1839 VSS.n438 0.231121
R7159 VSS.n1839 VSS.n1838 0.231121
R7160 VSS.n1838 VSS.n1837 0.231121
R7161 VSS.n1837 VSS.n447 0.231121
R7162 VSS.n1822 VSS.n447 0.231121
R7163 VSS.n1823 VSS.n1822 0.231121
R7164 VSS.n1824 VSS.n1823 0.231121
R7165 VSS.n1824 VSS.n1816 0.231121
R7166 VSS.n1828 VSS.n1816 0.231121
R7167 VSS.n1829 VSS.n1828 0.231121
R7168 VSS.n1830 VSS.n1829 0.231121
R7169 VSS.n1830 VSS.n1815 0.231121
R7170 VSS.n1815 VSS.n1814 0.231121
R7171 VSS.n1814 VSS.n467 0.231121
R7172 VSS.n1803 VSS.n467 0.231121
R7173 VSS.n1804 VSS.n1803 0.231121
R7174 VSS.n1805 VSS.n1804 0.231121
R7175 VSS.n1805 VSS.n1802 0.231121
R7176 VSS.n1802 VSS.n1801 0.231121
R7177 VSS.n1801 VSS.n477 0.231121
R7178 VSS.n1792 VSS.n477 0.231121
R7179 VSS.n1792 VSS.n1791 0.231121
R7180 VSS.n1791 VSS.n1790 0.231121
R7181 VSS.n1790 VSS.n486 0.231121
R7182 VSS.n1775 VSS.n486 0.231121
R7183 VSS.n1776 VSS.n1775 0.231121
R7184 VSS.n1777 VSS.n1776 0.231121
R7185 VSS.n1777 VSS.n1769 0.231121
R7186 VSS.n1781 VSS.n1769 0.231121
R7187 VSS.n1782 VSS.n1781 0.231121
R7188 VSS.n1783 VSS.n1782 0.231121
R7189 VSS.n1783 VSS.n1768 0.231121
R7190 VSS.n1768 VSS.n1767 0.231121
R7191 VSS.n1767 VSS.n506 0.231121
R7192 VSS.n1756 VSS.n506 0.231121
R7193 VSS.n1757 VSS.n1756 0.231121
R7194 VSS.n1758 VSS.n1757 0.231121
R7195 VSS.n1758 VSS.n1755 0.231121
R7196 VSS.n1755 VSS.n1754 0.231121
R7197 VSS.n1754 VSS.n516 0.231121
R7198 VSS.n1745 VSS.n516 0.231121
R7199 VSS.n1745 VSS.n1744 0.231121
R7200 VSS.n1744 VSS.n1743 0.231121
R7201 VSS.n1743 VSS.n525 0.231121
R7202 VSS.n800 VSS.n525 0.231121
R7203 VSS.n800 VSS.n799 0.231121
R7204 VSS.n799 VSS.n798 0.231121
R7205 VSS.n798 VSS.n797 0.231121
R7206 VSS.n797 VSS.n796 0.231121
R7207 VSS.n796 VSS.n795 0.231121
R7208 VSS.n795 VSS.n794 0.231121
R7209 VSS.n794 VSS.n793 0.231121
R7210 VSS.n793 VSS.n792 0.231121
R7211 VSS.n792 VSS.n791 0.231121
R7212 VSS.n791 VSS.n790 0.231121
R7213 VSS.n822 VSS.n790 0.231121
R7214 VSS.n3358 VSS.n3357 0.231121
R7215 VSS.n3357 VSS.n2270 0.231121
R7216 VSS.n2273 VSS.n2270 0.231121
R7217 VSS.n2274 VSS.n2273 0.231121
R7218 VSS.n2275 VSS.n2274 0.231121
R7219 VSS.n2276 VSS.n2275 0.231121
R7220 VSS.n2277 VSS.n2276 0.231121
R7221 VSS.n2278 VSS.n2277 0.231121
R7222 VSS.n2279 VSS.n2278 0.231121
R7223 VSS.n3340 VSS.n2279 0.231121
R7224 VSS.n3340 VSS.n2281 0.231121
R7225 VSS.n3328 VSS.n2281 0.231121
R7226 VSS.n3328 VSS.n2283 0.231121
R7227 VSS.n2286 VSS.n2283 0.231121
R7228 VSS.n2287 VSS.n2286 0.231121
R7229 VSS.n2288 VSS.n2287 0.231121
R7230 VSS.n2289 VSS.n2288 0.231121
R7231 VSS.n2290 VSS.n2289 0.231121
R7232 VSS.n2291 VSS.n2290 0.231121
R7233 VSS.n3311 VSS.n2291 0.231121
R7234 VSS.n3311 VSS.n2293 0.231121
R7235 VSS.n3301 VSS.n2293 0.231121
R7236 VSS.n3301 VSS.n2295 0.231121
R7237 VSS.n2298 VSS.n2295 0.231121
R7238 VSS.n2299 VSS.n2298 0.231121
R7239 VSS.n2300 VSS.n2299 0.231121
R7240 VSS.n2301 VSS.n2300 0.231121
R7241 VSS.n2302 VSS.n2301 0.231121
R7242 VSS.n2303 VSS.n2302 0.231121
R7243 VSS.n2304 VSS.n2303 0.231121
R7244 VSS.n2305 VSS.n2304 0.231121
R7245 VSS.n2306 VSS.n2305 0.231121
R7246 VSS.n2307 VSS.n2306 0.231121
R7247 VSS.n2308 VSS.n2307 0.231121
R7248 VSS.n2309 VSS.n2308 0.231121
R7249 VSS.n2310 VSS.n2309 0.231121
R7250 VSS.n2311 VSS.n2310 0.231121
R7251 VSS.n2312 VSS.n2311 0.231121
R7252 VSS.n3267 VSS.n2312 0.231121
R7253 VSS.n3267 VSS.n2314 0.231121
R7254 VSS.n3248 VSS.n2314 0.231121
R7255 VSS.n3248 VSS.n2316 0.231121
R7256 VSS.n2319 VSS.n2316 0.231121
R7257 VSS.n2320 VSS.n2319 0.231121
R7258 VSS.n2321 VSS.n2320 0.231121
R7259 VSS.n2322 VSS.n2321 0.231121
R7260 VSS.n2323 VSS.n2322 0.231121
R7261 VSS.n2324 VSS.n2323 0.231121
R7262 VSS.n3231 VSS.n2324 0.231121
R7263 VSS.n3231 VSS.n2326 0.231121
R7264 VSS.n3221 VSS.n2326 0.231121
R7265 VSS.n3221 VSS.n2328 0.231121
R7266 VSS.n2331 VSS.n2328 0.231121
R7267 VSS.n2332 VSS.n2331 0.231121
R7268 VSS.n2333 VSS.n2332 0.231121
R7269 VSS.n2334 VSS.n2333 0.231121
R7270 VSS.n2335 VSS.n2334 0.231121
R7271 VSS.n2336 VSS.n2335 0.231121
R7272 VSS.n2337 VSS.n2336 0.231121
R7273 VSS.n2338 VSS.n2337 0.231121
R7274 VSS.n2339 VSS.n2338 0.231121
R7275 VSS.n2340 VSS.n2339 0.231121
R7276 VSS.n2341 VSS.n2340 0.231121
R7277 VSS.n2342 VSS.n2341 0.231121
R7278 VSS.n2343 VSS.n2342 0.231121
R7279 VSS.n2344 VSS.n2343 0.231121
R7280 VSS.n2345 VSS.n2344 0.231121
R7281 VSS.n2346 VSS.n2345 0.231121
R7282 VSS.n2347 VSS.n2346 0.231121
R7283 VSS.n2348 VSS.n2347 0.231121
R7284 VSS.n2349 VSS.n2348 0.231121
R7285 VSS.n2350 VSS.n2349 0.231121
R7286 VSS.n2351 VSS.n2350 0.231121
R7287 VSS.n2352 VSS.n2351 0.231121
R7288 VSS.n2353 VSS.n2352 0.231121
R7289 VSS.n2354 VSS.n2353 0.231121
R7290 VSS.n2355 VSS.n2354 0.231121
R7291 VSS.n3168 VSS.n2355 0.231121
R7292 VSS.n2927 VSS.n2616 0.231121
R7293 VSS.n2927 VSS.n2926 0.231121
R7294 VSS.n2926 VSS.n2924 0.231121
R7295 VSS.n2924 VSS.n2702 0.231121
R7296 VSS.n2919 VSS.n2702 0.231121
R7297 VSS.n2919 VSS.n2917 0.231121
R7298 VSS.n2917 VSS.n2915 0.231121
R7299 VSS.n2915 VSS.n2705 0.231121
R7300 VSS.n2910 VSS.n2705 0.231121
R7301 VSS.n2910 VSS.n2908 0.231121
R7302 VSS.n2908 VSS.n2906 0.231121
R7303 VSS.n2906 VSS.n2708 0.231121
R7304 VSS.n2901 VSS.n2708 0.231121
R7305 VSS.n2901 VSS.n2899 0.231121
R7306 VSS.n2899 VSS.n2897 0.231121
R7307 VSS.n2897 VSS.n2711 0.231121
R7308 VSS.n2892 VSS.n2711 0.231121
R7309 VSS.n2892 VSS.n2890 0.231121
R7310 VSS.n2890 VSS.n2888 0.231121
R7311 VSS.n2888 VSS.n2713 0.231121
R7312 VSS.n2883 VSS.n2713 0.231121
R7313 VSS.n2883 VSS.n2881 0.231121
R7314 VSS.n2881 VSS.n2879 0.231121
R7315 VSS.n2879 VSS.n2716 0.231121
R7316 VSS.n2874 VSS.n2716 0.231121
R7317 VSS.n2874 VSS.n2872 0.231121
R7318 VSS.n2872 VSS.n2870 0.231121
R7319 VSS.n2870 VSS.n2719 0.231121
R7320 VSS.n2865 VSS.n2719 0.231121
R7321 VSS.n2865 VSS.n2863 0.231121
R7322 VSS.n2863 VSS.n2862 0.231121
R7323 VSS.n2862 VSS.n2722 0.231121
R7324 VSS.n2857 VSS.n2722 0.231121
R7325 VSS.n2857 VSS.n2855 0.231121
R7326 VSS.n2855 VSS.n2853 0.231121
R7327 VSS.n2853 VSS.n2725 0.231121
R7328 VSS.n2848 VSS.n2725 0.231121
R7329 VSS.n2848 VSS.n2846 0.231121
R7330 VSS.n2846 VSS.n2844 0.231121
R7331 VSS.n2844 VSS.n2728 0.231121
R7332 VSS.n2839 VSS.n2728 0.231121
R7333 VSS.n2839 VSS.n2837 0.231121
R7334 VSS.n2837 VSS.n2835 0.231121
R7335 VSS.n2835 VSS.n2731 0.231121
R7336 VSS.n2830 VSS.n2731 0.231121
R7337 VSS.n2830 VSS.n2828 0.231121
R7338 VSS.n2828 VSS.n2826 0.231121
R7339 VSS.n2826 VSS.n2734 0.231121
R7340 VSS.n2821 VSS.n2734 0.231121
R7341 VSS.n2821 VSS.n2820 0.231121
R7342 VSS.n2820 VSS.n2818 0.231121
R7343 VSS.n2818 VSS.n2737 0.231121
R7344 VSS.n2813 VSS.n2737 0.231121
R7345 VSS.n2813 VSS.n2811 0.231121
R7346 VSS.n2811 VSS.n2809 0.231121
R7347 VSS.n2809 VSS.n2740 0.231121
R7348 VSS.n2804 VSS.n2740 0.231121
R7349 VSS.n2804 VSS.n2802 0.231121
R7350 VSS.n2802 VSS.n2800 0.231121
R7351 VSS.n2800 VSS.n2743 0.231121
R7352 VSS.n2796 VSS.n2743 0.231121
R7353 VSS.n2796 VSS.n2794 0.231121
R7354 VSS.n2794 VSS.n2792 0.231121
R7355 VSS.n2792 VSS.n2746 0.231121
R7356 VSS.n2787 VSS.n2746 0.231121
R7357 VSS.n2787 VSS.n2785 0.231121
R7358 VSS.n2785 VSS.n2783 0.231121
R7359 VSS.n2783 VSS.n2749 0.231121
R7360 VSS.n2778 VSS.n2749 0.231121
R7361 VSS.n2778 VSS.n2776 0.231121
R7362 VSS.n2776 VSS.n2774 0.231121
R7363 VSS.n2774 VSS.n2752 0.231121
R7364 VSS.n2769 VSS.n2752 0.231121
R7365 VSS.n2769 VSS.n2767 0.231121
R7366 VSS.n2767 VSS.n2765 0.231121
R7367 VSS.n2765 VSS.n2755 0.231121
R7368 VSS.n2760 VSS.n2755 0.231121
R7369 VSS.n2760 VSS.n2758 0.231121
R7370 VSS.n3714 VSS.n3712 0.231121
R7371 VSS.n3712 VSS.n3542 0.231121
R7372 VSS.n3542 VSS.n3541 0.231121
R7373 VSS.n3541 VSS.n3539 0.231121
R7374 VSS.n3539 VSS.n3537 0.231121
R7375 VSS.n3537 VSS.n3536 0.231121
R7376 VSS.n3536 VSS.n3535 0.231121
R7377 VSS.n3535 VSS.n3534 0.231121
R7378 VSS.n3534 VSS.n3531 0.231121
R7379 VSS.n3531 VSS.n3528 0.231121
R7380 VSS.n3528 VSS.n3527 0.231121
R7381 VSS.n3527 VSS.n3526 0.231121
R7382 VSS.n3526 VSS.n3523 0.231121
R7383 VSS.n3523 VSS.n3521 0.231121
R7384 VSS.n3521 VSS.n3520 0.231121
R7385 VSS.n3520 VSS.n3519 0.231121
R7386 VSS.n3519 VSS.n3518 0.231121
R7387 VSS.n3518 VSS.n3514 0.231121
R7388 VSS.n3514 VSS.n3513 0.231121
R7389 VSS.n3513 VSS.n3512 0.231121
R7390 VSS.n3690 VSS.n3512 0.231121
R7391 VSS.n3690 VSS.n3689 0.231121
R7392 VSS.n3689 VSS.n3687 0.231121
R7393 VSS.n3687 VSS.n3545 0.231121
R7394 VSS.n3682 VSS.n3545 0.231121
R7395 VSS.n3682 VSS.n3680 0.231121
R7396 VSS.n3680 VSS.n3678 0.231121
R7397 VSS.n3678 VSS.n3548 0.231121
R7398 VSS.n3673 VSS.n3548 0.231121
R7399 VSS.n3673 VSS.n3671 0.231121
R7400 VSS.n3671 VSS.n3669 0.231121
R7401 VSS.n3669 VSS.n3551 0.231121
R7402 VSS.n3609 VSS.n3551 0.231121
R7403 VSS.n3611 VSS.n3609 0.231121
R7404 VSS.n3612 VSS.n3611 0.231121
R7405 VSS.n3612 VSS.n3562 0.231121
R7406 VSS.n3601 VSS.n3562 0.231121
R7407 VSS.n3601 VSS.n3599 0.231121
R7408 VSS.n3599 VSS.n3597 0.231121
R7409 VSS.n3597 VSS.n3564 0.231121
R7410 VSS.n3575 VSS.n3564 0.231121
R7411 VSS.n3711 VSS.n121 0.231121
R7412 VSS.n3711 VSS.n3710 0.231121
R7413 VSS.n3710 VSS.n3709 0.231121
R7414 VSS.n3709 VSS.n3708 0.231121
R7415 VSS.n3708 VSS.n3707 0.231121
R7416 VSS.n3707 VSS.n3706 0.231121
R7417 VSS.n3706 VSS.n3705 0.231121
R7418 VSS.n3705 VSS.n3704 0.231121
R7419 VSS.n3704 VSS.n3703 0.231121
R7420 VSS.n3703 VSS.n3702 0.231121
R7421 VSS.n3702 VSS.n3701 0.231121
R7422 VSS.n3701 VSS.n3700 0.231121
R7423 VSS.n3700 VSS.n3699 0.231121
R7424 VSS.n3699 VSS.n3698 0.231121
R7425 VSS.n3698 VSS.n3697 0.231121
R7426 VSS.n3697 VSS.n3696 0.231121
R7427 VSS.n3696 VSS.n3695 0.231121
R7428 VSS.n3695 VSS.n3694 0.231121
R7429 VSS.n3694 VSS.n3693 0.231121
R7430 VSS.n3693 VSS.n3692 0.231121
R7431 VSS.n3692 VSS.n3691 0.231121
R7432 VSS.n3691 VSS.n3543 0.231121
R7433 VSS.n3685 VSS.n3543 0.231121
R7434 VSS.n3685 VSS.n3684 0.231121
R7435 VSS.n3684 VSS.n3683 0.231121
R7436 VSS.n3683 VSS.n3546 0.231121
R7437 VSS.n3676 VSS.n3546 0.231121
R7438 VSS.n3676 VSS.n3675 0.231121
R7439 VSS.n3675 VSS.n3674 0.231121
R7440 VSS.n3674 VSS.n3549 0.231121
R7441 VSS.n3552 VSS.n3549 0.231121
R7442 VSS.n3606 VSS.n3552 0.231121
R7443 VSS.n3607 VSS.n3606 0.231121
R7444 VSS.n3607 VSS.n3605 0.231121
R7445 VSS.n3605 VSS.n3604 0.231121
R7446 VSS.n3604 VSS.n3603 0.231121
R7447 VSS.n3603 VSS.n3602 0.231121
R7448 VSS.n3602 VSS.n3563 0.231121
R7449 VSS.n3565 VSS.n3563 0.231121
R7450 VSS.n3576 VSS.n3565 0.231121
R7451 VSS.n3854 VSS.n124 0.231121
R7452 VSS.n3843 VSS.n124 0.231121
R7453 VSS.n3844 VSS.n3843 0.231121
R7454 VSS.n3844 VSS.n3842 0.231121
R7455 VSS.n3842 VSS.n3841 0.231121
R7456 VSS.n3841 VSS.n128 0.231121
R7457 VSS.n3831 VSS.n128 0.231121
R7458 VSS.n3831 VSS.n3830 0.231121
R7459 VSS.n3830 VSS.n3829 0.231121
R7460 VSS.n3829 VSS.n132 0.231121
R7461 VSS.n3799 VSS.n132 0.231121
R7462 VSS.n3799 VSS.n3798 0.231121
R7463 VSS.n3798 VSS.n3797 0.231121
R7464 VSS.n3797 VSS.n3796 0.231121
R7465 VSS.n3796 VSS.n3795 0.231121
R7466 VSS.n3795 VSS.n3794 0.231121
R7467 VSS.n3794 VSS.n3793 0.231121
R7468 VSS.n3793 VSS.n3792 0.231121
R7469 VSS.n3792 VSS.n3791 0.231121
R7470 VSS.n3791 VSS.n3790 0.231121
R7471 VSS.n3790 VSS.n3789 0.231121
R7472 VSS.n3789 VSS.n3788 0.231121
R7473 VSS.n3788 VSS.n151 0.231121
R7474 VSS.n3379 VSS.n151 0.231121
R7475 VSS.n3380 VSS.n3379 0.231121
R7476 VSS.n3380 VSS.n3378 0.231121
R7477 VSS.n3378 VSS.n3377 0.231121
R7478 VSS.n3377 VSS.n3376 0.231121
R7479 VSS.n3376 VSS.n3375 0.231121
R7480 VSS.n3375 VSS.n3374 0.231121
R7481 VSS.n3374 VSS.n3373 0.231121
R7482 VSS.n3373 VSS.n3372 0.231121
R7483 VSS.n3372 VSS.n3371 0.231121
R7484 VSS.n3371 VSS.n3370 0.231121
R7485 VSS.n3370 VSS.n3369 0.231121
R7486 VSS.n3369 VSS.n3368 0.231121
R7487 VSS.n3368 VSS.n3367 0.231121
R7488 VSS.n3367 VSS.n3366 0.231121
R7489 VSS.n3366 VSS.n3365 0.231121
R7490 VSS.n3365 VSS.n3364 0.231121
R7491 VSS.n3364 VSS.n3363 0.231121
R7492 VSS.n3363 VSS.n3362 0.231121
R7493 VSS.n3362 VSS.n3361 0.231121
R7494 VSS.n3361 VSS.n3360 0.231121
R7495 VSS.n3423 VSS.n3360 0.231121
R7496 VSS.n3359 VSS.n2269 0.231121
R7497 VSS.n3331 VSS.n2269 0.231121
R7498 VSS.n3332 VSS.n3331 0.231121
R7499 VSS.n3333 VSS.n3332 0.231121
R7500 VSS.n3334 VSS.n3333 0.231121
R7501 VSS.n3335 VSS.n3334 0.231121
R7502 VSS.n3336 VSS.n3335 0.231121
R7503 VSS.n3337 VSS.n3336 0.231121
R7504 VSS.n3338 VSS.n3337 0.231121
R7505 VSS.n3339 VSS.n3338 0.231121
R7506 VSS.n3339 VSS.n3330 0.231121
R7507 VSS.n3330 VSS.n3329 0.231121
R7508 VSS.n3329 VSS.n2282 0.231121
R7509 VSS.n3304 VSS.n2282 0.231121
R7510 VSS.n3305 VSS.n3304 0.231121
R7511 VSS.n3306 VSS.n3305 0.231121
R7512 VSS.n3307 VSS.n3306 0.231121
R7513 VSS.n3308 VSS.n3307 0.231121
R7514 VSS.n3309 VSS.n3308 0.231121
R7515 VSS.n3310 VSS.n3309 0.231121
R7516 VSS.n3310 VSS.n3303 0.231121
R7517 VSS.n3303 VSS.n3302 0.231121
R7518 VSS.n3302 VSS.n2294 0.231121
R7519 VSS.n3251 VSS.n2294 0.231121
R7520 VSS.n3252 VSS.n3251 0.231121
R7521 VSS.n3253 VSS.n3252 0.231121
R7522 VSS.n3254 VSS.n3253 0.231121
R7523 VSS.n3255 VSS.n3254 0.231121
R7524 VSS.n3256 VSS.n3255 0.231121
R7525 VSS.n3257 VSS.n3256 0.231121
R7526 VSS.n3258 VSS.n3257 0.231121
R7527 VSS.n3259 VSS.n3258 0.231121
R7528 VSS.n3260 VSS.n3259 0.231121
R7529 VSS.n3261 VSS.n3260 0.231121
R7530 VSS.n3262 VSS.n3261 0.231121
R7531 VSS.n3263 VSS.n3262 0.231121
R7532 VSS.n3264 VSS.n3263 0.231121
R7533 VSS.n3265 VSS.n3264 0.231121
R7534 VSS.n3266 VSS.n3265 0.231121
R7535 VSS.n3266 VSS.n3250 0.231121
R7536 VSS.n3250 VSS.n3249 0.231121
R7537 VSS.n3249 VSS.n2315 0.231121
R7538 VSS.n3224 VSS.n2315 0.231121
R7539 VSS.n3225 VSS.n3224 0.231121
R7540 VSS.n3226 VSS.n3225 0.231121
R7541 VSS.n3227 VSS.n3226 0.231121
R7542 VSS.n3228 VSS.n3227 0.231121
R7543 VSS.n3229 VSS.n3228 0.231121
R7544 VSS.n3230 VSS.n3229 0.231121
R7545 VSS.n3230 VSS.n3223 0.231121
R7546 VSS.n3223 VSS.n3222 0.231121
R7547 VSS.n3222 VSS.n2327 0.231121
R7548 VSS.n3142 VSS.n2327 0.231121
R7549 VSS.n3143 VSS.n3142 0.231121
R7550 VSS.n3144 VSS.n3143 0.231121
R7551 VSS.n3145 VSS.n3144 0.231121
R7552 VSS.n3146 VSS.n3145 0.231121
R7553 VSS.n3147 VSS.n3146 0.231121
R7554 VSS.n3148 VSS.n3147 0.231121
R7555 VSS.n3149 VSS.n3148 0.231121
R7556 VSS.n3150 VSS.n3149 0.231121
R7557 VSS.n3151 VSS.n3150 0.231121
R7558 VSS.n3152 VSS.n3151 0.231121
R7559 VSS.n3153 VSS.n3152 0.231121
R7560 VSS.n3154 VSS.n3153 0.231121
R7561 VSS.n3155 VSS.n3154 0.231121
R7562 VSS.n3156 VSS.n3155 0.231121
R7563 VSS.n3157 VSS.n3156 0.231121
R7564 VSS.n3158 VSS.n3157 0.231121
R7565 VSS.n3159 VSS.n3158 0.231121
R7566 VSS.n3160 VSS.n3159 0.231121
R7567 VSS.n3161 VSS.n3160 0.231121
R7568 VSS.n3162 VSS.n3161 0.231121
R7569 VSS.n3163 VSS.n3162 0.231121
R7570 VSS.n3164 VSS.n3163 0.231121
R7571 VSS.n3165 VSS.n3164 0.231121
R7572 VSS.n3166 VSS.n3165 0.231121
R7573 VSS.n3853 VSS.n3852 0.231121
R7574 VSS.n3852 VSS.n125 0.231121
R7575 VSS.n3845 VSS.n125 0.231121
R7576 VSS.n3845 VSS.n127 0.231121
R7577 VSS.n3840 VSS.n127 0.231121
R7578 VSS.n3840 VSS.n129 0.231121
R7579 VSS.n3832 VSS.n129 0.231121
R7580 VSS.n3832 VSS.n131 0.231121
R7581 VSS.n3828 VSS.n131 0.231121
R7582 VSS.n3828 VSS.n133 0.231121
R7583 VSS.n3800 VSS.n133 0.231121
R7584 VSS.n3801 VSS.n3800 0.231121
R7585 VSS.n3801 VSS.n150 0.231121
R7586 VSS.n150 VSS.n149 0.231121
R7587 VSS.n149 VSS.n148 0.231121
R7588 VSS.n148 VSS.n146 0.231121
R7589 VSS.n146 VSS.n145 0.231121
R7590 VSS.n145 VSS.n144 0.231121
R7591 VSS.n144 VSS.n142 0.231121
R7592 VSS.n142 VSS.n140 0.231121
R7593 VSS.n140 VSS.n139 0.231121
R7594 VSS.n3787 VSS.n139 0.231121
R7595 VSS.n3787 VSS.n3786 0.231121
R7596 VSS.n3786 VSS.n152 0.231121
R7597 VSS.n3382 VSS.n152 0.231121
R7598 VSS.n3384 VSS.n3382 0.231121
R7599 VSS.n3386 VSS.n3384 0.231121
R7600 VSS.n3388 VSS.n3386 0.231121
R7601 VSS.n3390 VSS.n3388 0.231121
R7602 VSS.n3392 VSS.n3390 0.231121
R7603 VSS.n3394 VSS.n3392 0.231121
R7604 VSS.n3396 VSS.n3394 0.231121
R7605 VSS.n3398 VSS.n3396 0.231121
R7606 VSS.n3400 VSS.n3398 0.231121
R7607 VSS.n3402 VSS.n3400 0.231121
R7608 VSS.n3404 VSS.n3402 0.231121
R7609 VSS.n3406 VSS.n3404 0.231121
R7610 VSS.n3408 VSS.n3406 0.231121
R7611 VSS.n3410 VSS.n3408 0.231121
R7612 VSS.n3412 VSS.n3410 0.231121
R7613 VSS.n3414 VSS.n3412 0.231121
R7614 VSS.n3416 VSS.n3414 0.231121
R7615 VSS.n3418 VSS.n3416 0.231121
R7616 VSS.n3420 VSS.n3418 0.231121
R7617 VSS.n3422 VSS.n3420 0.231121
R7618 VSS.n2929 VSS.n2928 0.231121
R7619 VSS.n2928 VSS.n2700 0.231121
R7620 VSS.n2922 VSS.n2700 0.231121
R7621 VSS.n2922 VSS.n2921 0.231121
R7622 VSS.n2921 VSS.n2920 0.231121
R7623 VSS.n2920 VSS.n2703 0.231121
R7624 VSS.n2913 VSS.n2703 0.231121
R7625 VSS.n2913 VSS.n2912 0.231121
R7626 VSS.n2912 VSS.n2911 0.231121
R7627 VSS.n2911 VSS.n2706 0.231121
R7628 VSS.n2904 VSS.n2706 0.231121
R7629 VSS.n2904 VSS.n2903 0.231121
R7630 VSS.n2903 VSS.n2902 0.231121
R7631 VSS.n2902 VSS.n2709 0.231121
R7632 VSS.n2895 VSS.n2709 0.231121
R7633 VSS.n2895 VSS.n2894 0.231121
R7634 VSS.n2894 VSS.n2893 0.231121
R7635 VSS.n2893 VSS.n2712 0.231121
R7636 VSS.n2886 VSS.n2712 0.231121
R7637 VSS.n2886 VSS.n2885 0.231121
R7638 VSS.n2885 VSS.n2884 0.231121
R7639 VSS.n2884 VSS.n2714 0.231121
R7640 VSS.n2877 VSS.n2714 0.231121
R7641 VSS.n2877 VSS.n2876 0.231121
R7642 VSS.n2876 VSS.n2875 0.231121
R7643 VSS.n2875 VSS.n2717 0.231121
R7644 VSS.n2868 VSS.n2717 0.231121
R7645 VSS.n2868 VSS.n2867 0.231121
R7646 VSS.n2867 VSS.n2866 0.231121
R7647 VSS.n2866 VSS.n2720 0.231121
R7648 VSS.n2860 VSS.n2720 0.231121
R7649 VSS.n2860 VSS.n2859 0.231121
R7650 VSS.n2859 VSS.n2858 0.231121
R7651 VSS.n2858 VSS.n2723 0.231121
R7652 VSS.n2851 VSS.n2723 0.231121
R7653 VSS.n2851 VSS.n2850 0.231121
R7654 VSS.n2850 VSS.n2849 0.231121
R7655 VSS.n2849 VSS.n2726 0.231121
R7656 VSS.n2842 VSS.n2726 0.231121
R7657 VSS.n2842 VSS.n2841 0.231121
R7658 VSS.n2841 VSS.n2840 0.231121
R7659 VSS.n2840 VSS.n2729 0.231121
R7660 VSS.n2833 VSS.n2729 0.231121
R7661 VSS.n2833 VSS.n2832 0.231121
R7662 VSS.n2832 VSS.n2831 0.231121
R7663 VSS.n2831 VSS.n2732 0.231121
R7664 VSS.n2824 VSS.n2732 0.231121
R7665 VSS.n2824 VSS.n2823 0.231121
R7666 VSS.n2823 VSS.n2822 0.231121
R7667 VSS.n2822 VSS.n2735 0.231121
R7668 VSS.n2816 VSS.n2735 0.231121
R7669 VSS.n2816 VSS.n2815 0.231121
R7670 VSS.n2815 VSS.n2814 0.231121
R7671 VSS.n2814 VSS.n2738 0.231121
R7672 VSS.n2807 VSS.n2738 0.231121
R7673 VSS.n2807 VSS.n2806 0.231121
R7674 VSS.n2806 VSS.n2805 0.231121
R7675 VSS.n2805 VSS.n2741 0.231121
R7676 VSS.n2799 VSS.n2741 0.231121
R7677 VSS.n2799 VSS.n2798 0.231121
R7678 VSS.n2798 VSS.n2797 0.231121
R7679 VSS.n2797 VSS.n2744 0.231121
R7680 VSS.n2790 VSS.n2744 0.231121
R7681 VSS.n2790 VSS.n2789 0.231121
R7682 VSS.n2789 VSS.n2788 0.231121
R7683 VSS.n2788 VSS.n2747 0.231121
R7684 VSS.n2781 VSS.n2747 0.231121
R7685 VSS.n2781 VSS.n2780 0.231121
R7686 VSS.n2780 VSS.n2779 0.231121
R7687 VSS.n2779 VSS.n2750 0.231121
R7688 VSS.n2772 VSS.n2750 0.231121
R7689 VSS.n2772 VSS.n2771 0.231121
R7690 VSS.n2771 VSS.n2770 0.231121
R7691 VSS.n2770 VSS.n2753 0.231121
R7692 VSS.n2763 VSS.n2753 0.231121
R7693 VSS.n2763 VSS.n2762 0.231121
R7694 VSS.n2762 VSS.n2761 0.231121
R7695 VSS.n3657 VSS.n3655 0.231121
R7696 VSS.n3659 VSS.n3657 0.231121
R7697 VSS.n3661 VSS.n3659 0.231121
R7698 VSS.n3663 VSS.n3661 0.231121
R7699 VSS.n3664 VSS.n3663 0.231121
R7700 VSS.n3664 VSS.n3554 0.231121
R7701 VSS.n3621 VSS.n3554 0.231121
R7702 VSS.n3621 VSS.n3619 0.231121
R7703 VSS.n3619 VSS.n3617 0.231121
R7704 VSS.n3617 VSS.n3556 0.231121
R7705 VSS.n3589 VSS.n3556 0.231121
R7706 VSS.n3591 VSS.n3589 0.231121
R7707 VSS.n3592 VSS.n3591 0.231121
R7708 VSS.n3592 VSS.n3566 0.231121
R7709 VSS.n3581 VSS.n3566 0.231121
R7710 VSS.n3631 VSS.n3630 0.231121
R7711 VSS.n3632 VSS.n3631 0.231121
R7712 VSS.n3633 VSS.n3632 0.231121
R7713 VSS.n3634 VSS.n3633 0.231121
R7714 VSS.n3635 VSS.n3634 0.231121
R7715 VSS.n3639 VSS.n3638 0.231121
R7716 VSS.n3640 VSS.n3639 0.231121
R7717 VSS.n3641 VSS.n3640 0.231121
R7718 VSS.n3642 VSS.n3641 0.231121
R7719 VSS.n3643 VSS.n3642 0.231121
R7720 VSS.n3644 VSS.n3643 0.231121
R7721 VSS.n3645 VSS.n3644 0.231121
R7722 VSS.n3646 VSS.n3645 0.231121
R7723 VSS.n3647 VSS.n3646 0.231121
R7724 VSS.n3648 VSS.n3647 0.231121
R7725 VSS.n3652 VSS.n3648 0.231121
R7726 VSS.n3653 VSS.n3628 0.231121
R7727 VSS.n3628 VSS.n3627 0.231121
R7728 VSS.n3627 VSS.n3626 0.231121
R7729 VSS.n3626 VSS.n3625 0.231121
R7730 VSS.n3625 VSS.n3624 0.231121
R7731 VSS.n3624 VSS.n3623 0.231121
R7732 VSS.n3623 VSS.n3622 0.231121
R7733 VSS.n3622 VSS.n3555 0.231121
R7734 VSS.n3557 VSS.n3555 0.231121
R7735 VSS.n3586 VSS.n3557 0.231121
R7736 VSS.n3587 VSS.n3586 0.231121
R7737 VSS.n3587 VSS.n3585 0.231121
R7738 VSS.n3585 VSS.n3584 0.231121
R7739 VSS.n3584 VSS.n3583 0.231121
R7740 VSS.n3637 VSS.n3486 0.231121
R7741 VSS.n3486 VSS.n3485 0.231121
R7742 VSS.n3485 VSS.n3484 0.231121
R7743 VSS.n3484 VSS.n3483 0.231121
R7744 VSS.n3483 VSS.n3482 0.231121
R7745 VSS.n3482 VSS.n3481 0.231121
R7746 VSS.n3481 VSS.n3480 0.231121
R7747 VSS.n3480 VSS.n3479 0.231121
R7748 VSS.n3479 VSS.n3478 0.231121
R7749 VSS.n3649 VSS.n3478 0.231121
R7750 VSS.n3651 VSS.n3649 0.231121
R7751 VSS.n3496 VSS.n3495 0.231121
R7752 VSS.n3495 VSS.n3494 0.231121
R7753 VSS.n3494 VSS.n3493 0.231121
R7754 VSS.n3493 VSS.n3492 0.231121
R7755 VSS.n3492 VSS.n3491 0.231121
R7756 VSS.n3491 VSS.n3489 0.231121
R7757 VSS.n3508 VSS.n3507 0.231121
R7758 VSS.n3506 VSS.n3502 0.231121
R7759 VSS.n1520 VSS.n1074 0.231121
R7760 VSS.n1524 VSS.n1074 0.231121
R7761 VSS.n1525 VSS.n1524 0.231121
R7762 VSS.n1482 VSS.n1481 0.231121
R7763 VSS.n1481 VSS.n1480 0.231121
R7764 VSS.n1480 VSS.n1476 0.231121
R7765 VSS.n1476 VSS.n1475 0.231121
R7766 VSS.n1475 VSS.n1474 0.231121
R7767 VSS.n1474 VSS.n1470 0.231121
R7768 VSS.n1470 VSS.n1469 0.231121
R7769 VSS.n1469 VSS.n1468 0.231121
R7770 VSS.n1468 VSS.n1464 0.231121
R7771 VSS.n1464 VSS.n1463 0.231121
R7772 VSS.n1463 VSS.n1462 0.231121
R7773 VSS.n1462 VSS.n1458 0.231121
R7774 VSS.n1458 VSS.n1457 0.231121
R7775 VSS.n1457 VSS.n1085 0.231121
R7776 VSS.n1507 VSS.n1085 0.231121
R7777 VSS.n1508 VSS.n1507 0.231121
R7778 VSS.n1509 VSS.n1508 0.231121
R7779 VSS.n1084 VSS.n1077 0.231121
R7780 VSS.n1518 VSS.n1077 0.231121
R7781 VSS.n1519 VSS.n1076 0.231121
R7782 VSS.n1076 VSS.n1073 0.231121
R7783 VSS.n1073 VSS.n1067 0.231121
R7784 VSS.n1530 VSS.n1529 0.231121
R7785 VSS.n1531 VSS.n1530 0.231121
R7786 VSS.n1531 VSS.n1058 0.231121
R7787 VSS.n1536 VSS.n1535 0.231121
R7788 VSS.n1537 VSS.n1536 0.231121
R7789 VSS.n1537 VSS.n1051 0.231121
R7790 VSS.n1544 VSS.n1543 0.231121
R7791 VSS.n1545 VSS.n1544 0.231121
R7792 VSS.n1545 VSS.n1042 0.231121
R7793 VSS.n1550 VSS.n1549 0.231121
R7794 VSS.n1551 VSS.n1550 0.231121
R7795 VSS.n1551 VSS.n1035 0.231121
R7796 VSS.n1558 VSS.n1557 0.231121
R7797 VSS.n1559 VSS.n1558 0.231121
R7798 VSS.n1559 VSS.n1026 0.231121
R7799 VSS.n1564 VSS.n1563 0.231121
R7800 VSS.n1565 VSS.n1564 0.231121
R7801 VSS.n1565 VSS.n1019 0.231121
R7802 VSS.n1572 VSS.n1571 0.231121
R7803 VSS.n1573 VSS.n1572 0.231121
R7804 VSS.n1573 VSS.n1010 0.231121
R7805 VSS.n1578 VSS.n1577 0.231121
R7806 VSS.n1579 VSS.n1578 0.231121
R7807 VSS.n1579 VSS.n1003 0.231121
R7808 VSS.n1586 VSS.n1585 0.231121
R7809 VSS.n1587 VSS.n1586 0.231121
R7810 VSS.n1587 VSS.n994 0.231121
R7811 VSS.n1592 VSS.n1591 0.231121
R7812 VSS.n1593 VSS.n1592 0.231121
R7813 VSS.n1593 VSS.n987 0.231121
R7814 VSS.n1600 VSS.n1599 0.231121
R7815 VSS.n1601 VSS.n1600 0.231121
R7816 VSS.n1601 VSS.n978 0.231121
R7817 VSS.n1606 VSS.n1605 0.231121
R7818 VSS.n1607 VSS.n1606 0.231121
R7819 VSS.n1607 VSS.n971 0.231121
R7820 VSS.n1614 VSS.n1613 0.231121
R7821 VSS.n1615 VSS.n1614 0.231121
R7822 VSS.n1615 VSS.n962 0.231121
R7823 VSS.n1620 VSS.n1619 0.231121
R7824 VSS.n1621 VSS.n1620 0.231121
R7825 VSS.n1621 VSS.n955 0.231121
R7826 VSS.n1628 VSS.n1627 0.231121
R7827 VSS.n1629 VSS.n1628 0.231121
R7828 VSS.n1629 VSS.n946 0.231121
R7829 VSS.n1634 VSS.n1633 0.231121
R7830 VSS.n1635 VSS.n1634 0.231121
R7831 VSS.n1635 VSS.n939 0.231121
R7832 VSS.n1642 VSS.n1641 0.231121
R7833 VSS.n1643 VSS.n1642 0.231121
R7834 VSS.n1643 VSS.n930 0.231121
R7835 VSS.n1648 VSS.n1647 0.231121
R7836 VSS.n1649 VSS.n1648 0.231121
R7837 VSS.n1649 VSS.n923 0.231121
R7838 VSS.n1656 VSS.n1655 0.231121
R7839 VSS.n1657 VSS.n1656 0.231121
R7840 VSS.n1657 VSS.n914 0.231121
R7841 VSS.n1662 VSS.n1661 0.231121
R7842 VSS.n1663 VSS.n1662 0.231121
R7843 VSS.n1663 VSS.n907 0.231121
R7844 VSS.n1670 VSS.n1669 0.231121
R7845 VSS.n1671 VSS.n1670 0.231121
R7846 VSS.n1671 VSS.n898 0.231121
R7847 VSS.n1676 VSS.n1675 0.231121
R7848 VSS.n1677 VSS.n1676 0.231121
R7849 VSS.n1677 VSS.n891 0.231121
R7850 VSS.n1684 VSS.n1683 0.231121
R7851 VSS.n1685 VSS.n1684 0.231121
R7852 VSS.n1685 VSS.n882 0.231121
R7853 VSS.n1690 VSS.n1689 0.231121
R7854 VSS.n1691 VSS.n1690 0.231121
R7855 VSS.n1691 VSS.n875 0.231121
R7856 VSS.n1698 VSS.n1697 0.231121
R7857 VSS.n1699 VSS.n1698 0.231121
R7858 VSS.n1699 VSS.n866 0.231121
R7859 VSS.n1704 VSS.n1703 0.231121
R7860 VSS.n1705 VSS.n1704 0.231121
R7861 VSS.n1705 VSS.n859 0.231121
R7862 VSS.n1712 VSS.n1711 0.231121
R7863 VSS.n1713 VSS.n1712 0.231121
R7864 VSS.n1713 VSS.n850 0.231121
R7865 VSS.n1718 VSS.n1717 0.231121
R7866 VSS.n1719 VSS.n1718 0.231121
R7867 VSS.n1719 VSS.n843 0.231121
R7868 VSS.n1726 VSS.n1725 0.231121
R7869 VSS.n1727 VSS.n1726 0.231121
R7870 VSS.n1727 VSS.n841 0.231121
R7871 VSS.n836 VSS.n835 0.231121
R7872 VSS.n835 VSS.n831 0.231121
R7873 VSS.n1737 VSS.n831 0.231121
R7874 VSS.n1731 VSS.n1730 0.231121
R7875 VSS.n1731 VSS.n832 0.231121
R7876 VSS.n1736 VSS.n832 0.231121
R7877 VSS.n1724 VSS.n842 0.231121
R7878 VSS.n1728 VSS.n842 0.231121
R7879 VSS.n1729 VSS.n1728 0.231121
R7880 VSS.n1716 VSS.n849 0.231121
R7881 VSS.n1720 VSS.n849 0.231121
R7882 VSS.n1721 VSS.n1720 0.231121
R7883 VSS.n1710 VSS.n858 0.231121
R7884 VSS.n1714 VSS.n858 0.231121
R7885 VSS.n1715 VSS.n1714 0.231121
R7886 VSS.n1702 VSS.n865 0.231121
R7887 VSS.n1706 VSS.n865 0.231121
R7888 VSS.n1707 VSS.n1706 0.231121
R7889 VSS.n1696 VSS.n874 0.231121
R7890 VSS.n1700 VSS.n874 0.231121
R7891 VSS.n1701 VSS.n1700 0.231121
R7892 VSS.n1688 VSS.n881 0.231121
R7893 VSS.n1692 VSS.n881 0.231121
R7894 VSS.n1693 VSS.n1692 0.231121
R7895 VSS.n1682 VSS.n890 0.231121
R7896 VSS.n1686 VSS.n890 0.231121
R7897 VSS.n1687 VSS.n1686 0.231121
R7898 VSS.n1674 VSS.n897 0.231121
R7899 VSS.n1678 VSS.n897 0.231121
R7900 VSS.n1679 VSS.n1678 0.231121
R7901 VSS.n1668 VSS.n906 0.231121
R7902 VSS.n1672 VSS.n906 0.231121
R7903 VSS.n1673 VSS.n1672 0.231121
R7904 VSS.n1660 VSS.n913 0.231121
R7905 VSS.n1664 VSS.n913 0.231121
R7906 VSS.n1665 VSS.n1664 0.231121
R7907 VSS.n1654 VSS.n922 0.231121
R7908 VSS.n1658 VSS.n922 0.231121
R7909 VSS.n1659 VSS.n1658 0.231121
R7910 VSS.n1646 VSS.n929 0.231121
R7911 VSS.n1650 VSS.n929 0.231121
R7912 VSS.n1651 VSS.n1650 0.231121
R7913 VSS.n1640 VSS.n938 0.231121
R7914 VSS.n1644 VSS.n938 0.231121
R7915 VSS.n1645 VSS.n1644 0.231121
R7916 VSS.n1632 VSS.n945 0.231121
R7917 VSS.n1636 VSS.n945 0.231121
R7918 VSS.n1637 VSS.n1636 0.231121
R7919 VSS.n1626 VSS.n954 0.231121
R7920 VSS.n1630 VSS.n954 0.231121
R7921 VSS.n1631 VSS.n1630 0.231121
R7922 VSS.n1618 VSS.n961 0.231121
R7923 VSS.n1622 VSS.n961 0.231121
R7924 VSS.n1623 VSS.n1622 0.231121
R7925 VSS.n1612 VSS.n970 0.231121
R7926 VSS.n1616 VSS.n970 0.231121
R7927 VSS.n1617 VSS.n1616 0.231121
R7928 VSS.n1604 VSS.n977 0.231121
R7929 VSS.n1608 VSS.n977 0.231121
R7930 VSS.n1609 VSS.n1608 0.231121
R7931 VSS.n1598 VSS.n986 0.231121
R7932 VSS.n1602 VSS.n986 0.231121
R7933 VSS.n1603 VSS.n1602 0.231121
R7934 VSS.n1590 VSS.n993 0.231121
R7935 VSS.n1594 VSS.n993 0.231121
R7936 VSS.n1595 VSS.n1594 0.231121
R7937 VSS.n1584 VSS.n1002 0.231121
R7938 VSS.n1588 VSS.n1002 0.231121
R7939 VSS.n1589 VSS.n1588 0.231121
R7940 VSS.n1576 VSS.n1009 0.231121
R7941 VSS.n1580 VSS.n1009 0.231121
R7942 VSS.n1581 VSS.n1580 0.231121
R7943 VSS.n1570 VSS.n1018 0.231121
R7944 VSS.n1574 VSS.n1018 0.231121
R7945 VSS.n1575 VSS.n1574 0.231121
R7946 VSS.n1562 VSS.n1025 0.231121
R7947 VSS.n1566 VSS.n1025 0.231121
R7948 VSS.n1567 VSS.n1566 0.231121
R7949 VSS.n1556 VSS.n1034 0.231121
R7950 VSS.n1560 VSS.n1034 0.231121
R7951 VSS.n1561 VSS.n1560 0.231121
R7952 VSS.n1548 VSS.n1041 0.231121
R7953 VSS.n1552 VSS.n1041 0.231121
R7954 VSS.n1553 VSS.n1552 0.231121
R7955 VSS.n1542 VSS.n1050 0.231121
R7956 VSS.n1546 VSS.n1050 0.231121
R7957 VSS.n1547 VSS.n1546 0.231121
R7958 VSS.n1534 VSS.n1057 0.231121
R7959 VSS.n1538 VSS.n1057 0.231121
R7960 VSS.n1539 VSS.n1538 0.231121
R7961 VSS.n1528 VSS.n1066 0.231121
R7962 VSS.n1532 VSS.n1066 0.231121
R7963 VSS.n1533 VSS.n1532 0.231121
R7964 VSS.n1516 VSS.n1079 0.231121
R7965 VSS.n1517 VSS.n1516 0.231121
R7966 VSS.n1486 VSS.n1485 0.231121
R7967 VSS.n1486 VSS.n1477 0.231121
R7968 VSS.n1489 VSS.n1477 0.231121
R7969 VSS.n1490 VSS.n1489 0.231121
R7970 VSS.n1490 VSS.n1471 0.231121
R7971 VSS.n1494 VSS.n1471 0.231121
R7972 VSS.n1495 VSS.n1494 0.231121
R7973 VSS.n1495 VSS.n1465 0.231121
R7974 VSS.n1498 VSS.n1465 0.231121
R7975 VSS.n1499 VSS.n1498 0.231121
R7976 VSS.n1499 VSS.n1459 0.231121
R7977 VSS.n1503 VSS.n1459 0.231121
R7978 VSS.n1504 VSS.n1503 0.231121
R7979 VSS.n1504 VSS.n1086 0.231121
R7980 VSS.n1506 VSS.n1086 0.231121
R7981 VSS.n1506 VSS.n1083 0.231121
R7982 VSS.n1510 VSS.n1083 0.231121
R7983 VSS.n1159 VSS.n1153 0.231121
R7984 VSS.n1447 VSS.n1446 0.231121
R7985 VSS.n1445 VSS.n1089 0.231121
R7986 VSS.n1431 VSS.n1089 0.231121
R7987 VSS.n1430 VSS.n1092 0.231121
R7988 VSS.n1422 VSS.n1092 0.231121
R7989 VSS.n1421 VSS.n1094 0.231121
R7990 VSS.n1413 VSS.n1094 0.231121
R7991 VSS.n1412 VSS.n1096 0.231121
R7992 VSS.n1404 VSS.n1096 0.231121
R7993 VSS.n1403 VSS.n1098 0.231121
R7994 VSS.n1395 VSS.n1098 0.231121
R7995 VSS.n1394 VSS.n1100 0.231121
R7996 VSS.n1386 VSS.n1100 0.231121
R7997 VSS.n1385 VSS.n1102 0.231121
R7998 VSS.n1377 VSS.n1102 0.231121
R7999 VSS.n1376 VSS.n1104 0.231121
R8000 VSS.n1368 VSS.n1104 0.231121
R8001 VSS.n1367 VSS.n1106 0.231121
R8002 VSS.n1359 VSS.n1106 0.231121
R8003 VSS.n1358 VSS.n1108 0.231121
R8004 VSS.n1350 VSS.n1108 0.231121
R8005 VSS.n1349 VSS.n1110 0.231121
R8006 VSS.n1341 VSS.n1110 0.231121
R8007 VSS.n1340 VSS.n1112 0.231121
R8008 VSS.n1332 VSS.n1112 0.231121
R8009 VSS.n1331 VSS.n1114 0.231121
R8010 VSS.n1323 VSS.n1114 0.231121
R8011 VSS.n1322 VSS.n1116 0.231121
R8012 VSS.n1314 VSS.n1116 0.231121
R8013 VSS.n1313 VSS.n1118 0.231121
R8014 VSS.n1305 VSS.n1118 0.231121
R8015 VSS.n1304 VSS.n1120 0.231121
R8016 VSS.n1296 VSS.n1120 0.231121
R8017 VSS.n1295 VSS.n1122 0.231121
R8018 VSS.n1287 VSS.n1122 0.231121
R8019 VSS.n1286 VSS.n1124 0.231121
R8020 VSS.n1278 VSS.n1124 0.231121
R8021 VSS.n1277 VSS.n1126 0.231121
R8022 VSS.n1269 VSS.n1126 0.231121
R8023 VSS.n1268 VSS.n1128 0.231121
R8024 VSS.n1260 VSS.n1128 0.231121
R8025 VSS.n1259 VSS.n1130 0.231121
R8026 VSS.n1251 VSS.n1130 0.231121
R8027 VSS.n1250 VSS.n1132 0.231121
R8028 VSS.n1242 VSS.n1132 0.231121
R8029 VSS.n1241 VSS.n1134 0.231121
R8030 VSS.n1233 VSS.n1134 0.231121
R8031 VSS.n1232 VSS.n1136 0.231121
R8032 VSS.n1224 VSS.n1136 0.231121
R8033 VSS.n1223 VSS.n1138 0.231121
R8034 VSS.n1215 VSS.n1138 0.231121
R8035 VSS.n1214 VSS.n1140 0.231121
R8036 VSS.n1206 VSS.n1140 0.231121
R8037 VSS.n1205 VSS.n1142 0.231121
R8038 VSS.n1197 VSS.n1142 0.231121
R8039 VSS.n1196 VSS.n1144 0.231121
R8040 VSS.n1188 VSS.n1144 0.231121
R8041 VSS.n1187 VSS.n1146 0.231121
R8042 VSS.n1179 VSS.n1146 0.231121
R8043 VSS.n1178 VSS.n1148 0.231121
R8044 VSS.n1170 VSS.n1148 0.231121
R8045 VSS.n1169 VSS.n1150 0.231121
R8046 VSS.n1161 VSS.n1150 0.231121
R8047 VSS.n1168 VSS.n1151 0.231121
R8048 VSS.n1162 VSS.n1151 0.231121
R8049 VSS.n1177 VSS.n1149 0.231121
R8050 VSS.n1171 VSS.n1149 0.231121
R8051 VSS.n1186 VSS.n1147 0.231121
R8052 VSS.n1180 VSS.n1147 0.231121
R8053 VSS.n1195 VSS.n1145 0.231121
R8054 VSS.n1189 VSS.n1145 0.231121
R8055 VSS.n1204 VSS.n1143 0.231121
R8056 VSS.n1198 VSS.n1143 0.231121
R8057 VSS.n1213 VSS.n1141 0.231121
R8058 VSS.n1207 VSS.n1141 0.231121
R8059 VSS.n1222 VSS.n1139 0.231121
R8060 VSS.n1216 VSS.n1139 0.231121
R8061 VSS.n1231 VSS.n1137 0.231121
R8062 VSS.n1225 VSS.n1137 0.231121
R8063 VSS.n1240 VSS.n1135 0.231121
R8064 VSS.n1234 VSS.n1135 0.231121
R8065 VSS.n1249 VSS.n1133 0.231121
R8066 VSS.n1243 VSS.n1133 0.231121
R8067 VSS.n1258 VSS.n1131 0.231121
R8068 VSS.n1252 VSS.n1131 0.231121
R8069 VSS.n1267 VSS.n1129 0.231121
R8070 VSS.n1261 VSS.n1129 0.231121
R8071 VSS.n1276 VSS.n1127 0.231121
R8072 VSS.n1270 VSS.n1127 0.231121
R8073 VSS.n1285 VSS.n1125 0.231121
R8074 VSS.n1279 VSS.n1125 0.231121
R8075 VSS.n1294 VSS.n1123 0.231121
R8076 VSS.n1288 VSS.n1123 0.231121
R8077 VSS.n1303 VSS.n1121 0.231121
R8078 VSS.n1297 VSS.n1121 0.231121
R8079 VSS.n1312 VSS.n1119 0.231121
R8080 VSS.n1306 VSS.n1119 0.231121
R8081 VSS.n1321 VSS.n1117 0.231121
R8082 VSS.n1315 VSS.n1117 0.231121
R8083 VSS.n1330 VSS.n1115 0.231121
R8084 VSS.n1324 VSS.n1115 0.231121
R8085 VSS.n1339 VSS.n1113 0.231121
R8086 VSS.n1333 VSS.n1113 0.231121
R8087 VSS.n1348 VSS.n1111 0.231121
R8088 VSS.n1342 VSS.n1111 0.231121
R8089 VSS.n1357 VSS.n1109 0.231121
R8090 VSS.n1351 VSS.n1109 0.231121
R8091 VSS.n1366 VSS.n1107 0.231121
R8092 VSS.n1360 VSS.n1107 0.231121
R8093 VSS.n1375 VSS.n1105 0.231121
R8094 VSS.n1369 VSS.n1105 0.231121
R8095 VSS.n1384 VSS.n1103 0.231121
R8096 VSS.n1378 VSS.n1103 0.231121
R8097 VSS.n1393 VSS.n1101 0.231121
R8098 VSS.n1387 VSS.n1101 0.231121
R8099 VSS.n1402 VSS.n1099 0.231121
R8100 VSS.n1396 VSS.n1099 0.231121
R8101 VSS.n1411 VSS.n1097 0.231121
R8102 VSS.n1405 VSS.n1097 0.231121
R8103 VSS.n1420 VSS.n1095 0.231121
R8104 VSS.n1414 VSS.n1095 0.231121
R8105 VSS.n1429 VSS.n1093 0.231121
R8106 VSS.n1423 VSS.n1093 0.231121
R8107 VSS.n1444 VSS.n1090 0.231121
R8108 VSS.n1432 VSS.n1090 0.231121
R8109 VSS.n1448 VSS.n1088 0.231121
R8110 VSS VSS.n3861 0.228153
R8111 VSS.n3435 VSS.n3434 0.225944
R8112 VSS.n2224 VSS.n2222 0.225674
R8113 VSS.n2242 VSS.n2222 0.219424
R8114 VSS.n3450 VSS.n3449 0.218898
R8115 VSS.n2951 VSS.n2950 0.218898
R8116 VSS.n2950 VSS.n2949 0.218898
R8117 VSS.t55 VSS.n3461 0.211735
R8118 VSS.n3447 VSS.n2211 0.20686
R8119 VSS.n3436 VSS.n3435 0.195641
R8120 VSS.n3437 VSS.n3436 0.195641
R8121 VSS.n3438 VSS.n3437 0.195641
R8122 VSS.n3431 VSS.n3430 0.195641
R8123 VSS.n3119 VSS.n3118 0.194315
R8124 VSS.n3738 VSS.t494 0.191235
R8125 VSS.n3747 VSS.n3746 0.191235
R8126 VSS.n3761 VSS.n3488 0.191235
R8127 VSS.n2247 VSS.n2227 0.191235
R8128 VSS.n1527 VSS.n1526 0.191138
R8129 VSS.n1541 VSS.n1540 0.191138
R8130 VSS.n1569 VSS.n1568 0.191138
R8131 VSS.n1583 VSS.n1582 0.191138
R8132 VSS.n1611 VSS.n1610 0.191138
R8133 VSS.n1639 VSS.n1638 0.191138
R8134 VSS.n1653 VSS.n1652 0.191138
R8135 VSS.n1667 VSS.n1666 0.191138
R8136 VSS.n1681 VSS.n1680 0.191138
R8137 VSS.n1723 VSS.n1722 0.191138
R8138 VSS.n1738 VSS.n830 0.191138
R8139 VSS.t316 VSS.n837 0.191138
R8140 VSS.t250 VSS.n854 0.191138
R8141 VSS.t457 VSS.n870 0.191138
R8142 VSS.t658 VSS.n886 0.191138
R8143 VSS.t209 VSS.n902 0.191138
R8144 VSS.t717 VSS.n918 0.191138
R8145 VSS.t372 VSS.n934 0.191138
R8146 VSS.t664 VSS.n982 0.191138
R8147 VSS.t212 VSS.n998 0.191138
R8148 VSS.t720 VSS.n1014 0.191138
R8149 VSS.t375 VSS.n1030 0.191138
R8150 VSS.t187 VSS.n1046 0.191138
R8151 VSS.t238 VSS.n1062 0.191138
R8152 VSS.n1555 VSS.n1554 0.1908
R8153 VSS.n1597 VSS.n1596 0.1908
R8154 VSS.n1625 VSS.n1624 0.1908
R8155 VSS.n1695 VSS.n1694 0.1908
R8156 VSS.n1709 VSS.n1708 0.1908
R8157 VSS.t712 VSS.n950 0.1908
R8158 VSS.t454 VSS.n966 0.1908
R8159 VSS.t723 VSS.n1075 0.1908
R8160 VSS.t509 VSS.t506 0.1875
R8161 VSS.t503 VSS.t499 0.1875
R8162 VSS.t512 VSS.t514 0.1875
R8163 VSS.n3124 VSS.n87 0.187025
R8164 VSS.n3125 VSS.n3124 0.187025
R8165 VSS.n3126 VSS.n3125 0.187025
R8166 VSS.n3127 VSS.n3126 0.187025
R8167 VSS.n3128 VSS.n3127 0.187025
R8168 VSS.n3129 VSS.n3128 0.187025
R8169 VSS.n3130 VSS.n3129 0.187025
R8170 VSS.n3131 VSS.n3130 0.187025
R8171 VSS.n3121 VSS.n3120 0.187025
R8172 VSS.n3120 VSS.n3119 0.187025
R8173 VSS.n3140 VSS.n3139 0.186601
R8174 VSS.n3439 VSS.n3438 0.180365
R8175 VSS.n2209 VSS.n179 0.168638
R8176 VSS.n3739 VSS.t486 0.167615
R8177 VSS.n3425 VSS.n2211 0.16726
R8178 VSS.n2209 VSS.n180 0.164671
R8179 VSS.n2146 VSS.n217 0.160396
R8180 VSS.n544 VSS.n217 0.160396
R8181 VSS.n548 VSS.n217 0.160396
R8182 VSS.n3432 VSS.n2226 0.156138
R8183 VSS.n3428 VSS.n3427 0.154264
R8184 VSS.n1091 VSS.n1075 0.151138
R8185 VSS.n1554 VSS.n1038 0.151138
R8186 VSS.n1596 VSS.n990 0.151138
R8187 VSS.n966 VSS.n968 0.151138
R8188 VSS.n1624 VSS.n958 0.151138
R8189 VSS.n950 VSS.n952 0.151138
R8190 VSS.n1694 VSS.n878 0.151138
R8191 VSS.n1708 VSS.n862 0.151138
R8192 VSS.n1526 VSS.n1070 0.1508
R8193 VSS.n1062 VSS.n1064 0.1508
R8194 VSS.n1540 VSS.n1054 0.1508
R8195 VSS.n1046 VSS.n1048 0.1508
R8196 VSS.n1030 VSS.n1032 0.1508
R8197 VSS.n1568 VSS.n1022 0.1508
R8198 VSS.n1014 VSS.n1016 0.1508
R8199 VSS.n1582 VSS.n1006 0.1508
R8200 VSS.n998 VSS.n1000 0.1508
R8201 VSS.n982 VSS.n984 0.1508
R8202 VSS.n1610 VSS.n974 0.1508
R8203 VSS.n1638 VSS.n942 0.1508
R8204 VSS.n934 VSS.n936 0.1508
R8205 VSS.n1652 VSS.n926 0.1508
R8206 VSS.n918 VSS.n920 0.1508
R8207 VSS.n1666 VSS.n910 0.1508
R8208 VSS.n902 VSS.n904 0.1508
R8209 VSS.n1680 VSS.n894 0.1508
R8210 VSS.n886 VSS.n888 0.1508
R8211 VSS.n870 VSS.n872 0.1508
R8212 VSS.n854 VSS.n856 0.1508
R8213 VSS.n1722 VSS.n846 0.1508
R8214 VSS.n837 VSS.n839 0.1508
R8215 VSS.n833 VSS.n830 0.1508
R8216 VSS.n3855 VSS.n120 0.150687
R8217 VSS.n3463 VSS.n2178 0.147398
R8218 VSS.n178 VSS.t215 0.146818
R8219 VSS.n2642 VSS.n2641 0.146155
R8220 VSS.n2641 VSS.n2640 0.146155
R8221 VSS.n2640 VSS.n2639 0.146155
R8222 VSS.n2639 VSS.n2638 0.146155
R8223 VSS.n2638 VSS.n2637 0.146155
R8224 VSS.n2637 VSS.n2636 0.146155
R8225 VSS.n2636 VSS.n2635 0.146155
R8226 VSS.n2635 VSS.n2633 0.146155
R8227 VSS.n2633 VSS.n2632 0.146155
R8228 VSS.n2632 VSS.n2630 0.146155
R8229 VSS.n2630 VSS.n2628 0.146155
R8230 VSS.n2628 VSS.n2627 0.146155
R8231 VSS.n2627 VSS.n2626 0.146155
R8232 VSS.n2626 VSS.n2624 0.146155
R8233 VSS.n2624 VSS.n2623 0.146155
R8234 VSS.n2623 VSS.n2622 0.146155
R8235 VSS.n2622 VSS.n2621 0.146155
R8236 VSS.n2621 VSS.n2619 0.146155
R8237 VSS.n2619 VSS.n2617 0.146155
R8238 VSS.n3455 VSS.n2203 0.146155
R8239 VSS.n3451 VSS.n2203 0.146155
R8240 VSS.n3451 VSS.n3450 0.146155
R8241 VSS.n2251 VSS.n2206 0.146155
R8242 VSS.n2251 VSS.n2250 0.146155
R8243 VSS.n2260 VSS.n2250 0.146155
R8244 VSS.n3458 VSS.n2202 0.146155
R8245 VSS.n2255 VSS.n2252 0.146155
R8246 VSS.n2256 VSS.n2255 0.146155
R8247 VSS.n2259 VSS.n2256 0.146155
R8248 VSS.n2262 VSS.n2249 0.146155
R8249 VSS.n3454 VSS.n3453 0.146155
R8250 VSS.n3453 VSS.n3452 0.146155
R8251 VSS.n3452 VSS.n2205 0.146155
R8252 VSS.n2994 VSS.n2993 0.146155
R8253 VSS.n2993 VSS.n2992 0.146155
R8254 VSS.n2992 VSS.n2991 0.146155
R8255 VSS.n2991 VSS.n2990 0.146155
R8256 VSS.n2990 VSS.n2989 0.146155
R8257 VSS.n2989 VSS.n2988 0.146155
R8258 VSS.n2988 VSS.n2987 0.146155
R8259 VSS.n2987 VSS.n2986 0.146155
R8260 VSS.n2986 VSS.n2985 0.146155
R8261 VSS.n2985 VSS.n2984 0.146155
R8262 VSS.n2984 VSS.n2983 0.146155
R8263 VSS.n2983 VSS.n2982 0.146155
R8264 VSS.n2982 VSS.n2981 0.146155
R8265 VSS.n2981 VSS.n2980 0.146155
R8266 VSS.n2980 VSS.n2979 0.146155
R8267 VSS.n2979 VSS.n2978 0.146155
R8268 VSS.n2978 VSS.n2977 0.146155
R8269 VSS.n2977 VSS.n2976 0.146155
R8270 VSS.n2976 VSS.n2975 0.146155
R8271 VSS.n2975 VSS.n2974 0.146155
R8272 VSS.n2974 VSS.n2973 0.146155
R8273 VSS.n2973 VSS.n2972 0.146155
R8274 VSS.n2972 VSS.n2971 0.146155
R8275 VSS.n2971 VSS.n2970 0.146155
R8276 VSS.n2970 VSS.n2969 0.146155
R8277 VSS.n2969 VSS.n2968 0.146155
R8278 VSS.n2968 VSS.n2967 0.146155
R8279 VSS.n2967 VSS.n2966 0.146155
R8280 VSS.n2966 VSS.n2965 0.146155
R8281 VSS.n2965 VSS.n2964 0.146155
R8282 VSS.n2964 VSS.n2963 0.146155
R8283 VSS.n2963 VSS.n2962 0.146155
R8284 VSS.n2962 VSS.n2961 0.146155
R8285 VSS.n2961 VSS.n2960 0.146155
R8286 VSS.n2960 VSS.n2959 0.146155
R8287 VSS.n2959 VSS.n2958 0.146155
R8288 VSS.n2958 VSS.n2957 0.146155
R8289 VSS.n2957 VSS.n2956 0.146155
R8290 VSS.n2956 VSS.n2955 0.146155
R8291 VSS.n2955 VSS.n2954 0.146155
R8292 VSS.n2954 VSS.n2953 0.146155
R8293 VSS.n2953 VSS.n2952 0.146155
R8294 VSS.n2952 VSS.n2951 0.146155
R8295 VSS.n2949 VSS.n2948 0.146155
R8296 VSS.n2948 VSS.n2947 0.146155
R8297 VSS.n2947 VSS.n2946 0.146155
R8298 VSS.n2946 VSS.n2945 0.146155
R8299 VSS.n2945 VSS.n2944 0.146155
R8300 VSS.n2944 VSS.n2943 0.146155
R8301 VSS.n2943 VSS.n2942 0.146155
R8302 VSS.n2942 VSS.n2941 0.146155
R8303 VSS.n2941 VSS.n2940 0.146155
R8304 VSS.n2940 VSS.n2939 0.146155
R8305 VSS.n2939 VSS.n2938 0.146155
R8306 VSS.n2938 VSS.n2937 0.146155
R8307 VSS.n2937 VSS.n2936 0.146155
R8308 VSS.n2936 VSS.n2935 0.146155
R8309 VSS.n2935 VSS.n2934 0.146155
R8310 VSS.n2934 VSS.n2933 0.146155
R8311 VSS.n2933 VSS.n2932 0.146155
R8312 VSS.n2932 VSS.n2931 0.146155
R8313 VSS.n2931 VSS.n2930 0.146155
R8314 VSS.n2699 VSS.n2698 0.146155
R8315 VSS.n2698 VSS.n2697 0.146155
R8316 VSS.n2697 VSS.n2696 0.146155
R8317 VSS.n2696 VSS.n2695 0.146155
R8318 VSS.n2695 VSS.n2694 0.146155
R8319 VSS.n2694 VSS.n2692 0.146155
R8320 VSS.n2692 VSS.n2691 0.146155
R8321 VSS.n2691 VSS.n2689 0.146155
R8322 VSS.n2689 VSS.n2688 0.146155
R8323 VSS.n2688 VSS.n2687 0.146155
R8324 VSS.n2687 VSS.n2686 0.146155
R8325 VSS.n2686 VSS.n2685 0.146155
R8326 VSS.n2685 VSS.n2684 0.146155
R8327 VSS.n2684 VSS.n2683 0.146155
R8328 VSS.n2683 VSS.n2682 0.146155
R8329 VSS.n2682 VSS.n2681 0.146155
R8330 VSS.n2681 VSS.n2680 0.146155
R8331 VSS.n2680 VSS.n2679 0.146155
R8332 VSS.n2679 VSS.n2678 0.146155
R8333 VSS.n2678 VSS.n2676 0.146155
R8334 VSS.n2676 VSS.n2675 0.146155
R8335 VSS.n2675 VSS.n2673 0.146155
R8336 VSS.n2673 VSS.n2671 0.146155
R8337 VSS.n2671 VSS.n2670 0.146155
R8338 VSS.n2670 VSS.n2669 0.146155
R8339 VSS.n2669 VSS.n2668 0.146155
R8340 VSS.n2668 VSS.n2667 0.146155
R8341 VSS.n2667 VSS.n2665 0.146155
R8342 VSS.n2665 VSS.n2664 0.146155
R8343 VSS.n2664 VSS.n2663 0.146155
R8344 VSS.n2663 VSS.n2661 0.146155
R8345 VSS.n2661 VSS.n2660 0.146155
R8346 VSS.n2660 VSS.n2659 0.146155
R8347 VSS.n2659 VSS.n2657 0.146155
R8348 VSS.n2657 VSS.n2656 0.146155
R8349 VSS.n2656 VSS.n2655 0.146155
R8350 VSS.n2655 VSS.n2653 0.146155
R8351 VSS.n2653 VSS.n2652 0.146155
R8352 VSS.n2652 VSS.n2651 0.146155
R8353 VSS.n2651 VSS.n2649 0.146155
R8354 VSS.n2649 VSS.n2647 0.146155
R8355 VSS.n2647 VSS.n2646 0.146155
R8356 VSS.n2646 VSS.n2644 0.146155
R8357 VSS.n2644 VSS.n2643 0.146155
R8358 VSS.n2268 VSS.t215 0.145603
R8359 VSS.n1487 VSS.n1479 0.143368
R8360 VSS.n1488 VSS.n1473 0.143368
R8361 VSS.n1492 VSS.n1491 0.143368
R8362 VSS.n1466 VSS.n1497 0.143368
R8363 VSS.n1502 VSS.n1456 0.143368
R8364 VSS.n1436 VSS.n1435 0.143368
R8365 VSS.n1427 VSS.n1426 0.143368
R8366 VSS.n1418 VSS.n1417 0.143368
R8367 VSS.n1409 VSS.n1408 0.143368
R8368 VSS.n1400 VSS.n1399 0.143368
R8369 VSS.n1391 VSS.n1390 0.143368
R8370 VSS.n1382 VSS.n1381 0.143368
R8371 VSS.n1373 VSS.n1372 0.143368
R8372 VSS.n1364 VSS.n1363 0.143368
R8373 VSS.n1355 VSS.n1354 0.143368
R8374 VSS.n1346 VSS.n1345 0.143368
R8375 VSS.n1337 VSS.n1336 0.143368
R8376 VSS.n1328 VSS.n1327 0.143368
R8377 VSS.n1319 VSS.n1318 0.143368
R8378 VSS.n1310 VSS.n1309 0.143368
R8379 VSS.n1301 VSS.n1300 0.143368
R8380 VSS.n1292 VSS.n1291 0.143368
R8381 VSS.n1283 VSS.n1282 0.143368
R8382 VSS.n1274 VSS.n1273 0.143368
R8383 VSS.n1265 VSS.n1264 0.143368
R8384 VSS.n1256 VSS.n1255 0.143368
R8385 VSS.n1247 VSS.n1246 0.143368
R8386 VSS.n1238 VSS.n1237 0.143368
R8387 VSS.n1229 VSS.n1228 0.143368
R8388 VSS.n1220 VSS.n1219 0.143368
R8389 VSS.n1211 VSS.n1210 0.143368
R8390 VSS.n1202 VSS.n1201 0.143368
R8391 VSS.n1193 VSS.n1192 0.143368
R8392 VSS.n1184 VSS.n1183 0.143368
R8393 VSS.n1175 VSS.n1174 0.143368
R8394 VSS.n1166 VSS.n1165 0.143368
R8395 VSS.n1157 VSS.n1156 0.143368
R8396 VSS.n1522 VSS.n1521 0.143368
R8397 VSS.n1071 VSS.n1523 0.143368
R8398 VSS.n1061 VSS.n1060 0.143368
R8399 VSS.n1059 VSS.n1055 0.143368
R8400 VSS.n1045 VSS.n1044 0.143368
R8401 VSS.n1043 VSS.n1039 0.143368
R8402 VSS.n1029 VSS.n1028 0.143368
R8403 VSS.n1027 VSS.n1023 0.143368
R8404 VSS.n1013 VSS.n1012 0.143368
R8405 VSS.n1011 VSS.n1007 0.143368
R8406 VSS.n997 VSS.n996 0.143368
R8407 VSS.n995 VSS.n991 0.143368
R8408 VSS.n981 VSS.n980 0.143368
R8409 VSS.n979 VSS.n975 0.143368
R8410 VSS.n965 VSS.n964 0.143368
R8411 VSS.n963 VSS.n959 0.143368
R8412 VSS.n949 VSS.n948 0.143368
R8413 VSS.n947 VSS.n943 0.143368
R8414 VSS.n933 VSS.n932 0.143368
R8415 VSS.n931 VSS.n927 0.143368
R8416 VSS.n917 VSS.n916 0.143368
R8417 VSS.n915 VSS.n911 0.143368
R8418 VSS.n901 VSS.n900 0.143368
R8419 VSS.n899 VSS.n895 0.143368
R8420 VSS.n885 VSS.n884 0.143368
R8421 VSS.n883 VSS.n879 0.143368
R8422 VSS.n869 VSS.n868 0.143368
R8423 VSS.n867 VSS.n863 0.143368
R8424 VSS.n853 VSS.n852 0.143368
R8425 VSS.n851 VSS.n847 0.143368
R8426 VSS.n1732 VSS.n834 0.143368
R8427 VSS.n1734 VSS.n1733 0.143368
R8428 VSS.n805 VSS.n534 0.143368
R8429 VSS.n807 VSS.n536 0.143368
R8430 VSS.n809 VSS.n780 0.143368
R8431 VSS.n812 VSS.n782 0.143368
R8432 VSS.n818 VSS.n784 0.143368
R8433 VSS.n820 VSS.n785 0.143368
R8434 VSS.n788 VSS.n786 0.143368
R8435 VSS.n824 VSS.n787 0.143368
R8436 VSS.n802 VSS.n527 0.143368
R8437 VSS.n2077 VSS.n2076 0.143368
R8438 VSS.n2081 VSS.n2080 0.143368
R8439 VSS.n2085 VSS.n2084 0.143368
R8440 VSS.n2089 VSS.n2088 0.143368
R8441 VSS.n2093 VSS.n2092 0.143368
R8442 VSS.n2095 VSS.n2094 0.143368
R8443 VSS.n2097 VSS.n2096 0.143368
R8444 VSS.n2099 VSS.n2098 0.143368
R8445 VSS.n2101 VSS.n2100 0.143368
R8446 VSS.n2103 VSS.n2102 0.143368
R8447 VSS.n2105 VSS.n2104 0.143368
R8448 VSS.n2107 VSS.n2106 0.143368
R8449 VSS.n2109 VSS.n2108 0.143368
R8450 VSS.n2111 VSS.n2110 0.143368
R8451 VSS.n2113 VSS.n2112 0.143368
R8452 VSS.n2117 VSS.n2116 0.143368
R8453 VSS.n1999 VSS.n287 0.143368
R8454 VSS.n1998 VSS.n292 0.143368
R8455 VSS.n1997 VSS.n293 0.143368
R8456 VSS.n303 VSS.n294 0.143368
R8457 VSS.n1992 VSS.n297 0.143368
R8458 VSS.n1952 VSS.n326 0.143368
R8459 VSS.n1951 VSS.n331 0.143368
R8460 VSS.n1950 VSS.n332 0.143368
R8461 VSS.n342 VSS.n333 0.143368
R8462 VSS.n1945 VSS.n336 0.143368
R8463 VSS.n1905 VSS.n365 0.143368
R8464 VSS.n1904 VSS.n370 0.143368
R8465 VSS.n1903 VSS.n371 0.143368
R8466 VSS.n407 VSS.n372 0.143368
R8467 VSS.n1898 VSS.n375 0.143368
R8468 VSS.n1896 VSS.n376 0.143368
R8469 VSS.n412 VSS.n377 0.143368
R8470 VSS.n410 VSS.n378 0.143368
R8471 VSS.n1890 VSS.n379 0.143368
R8472 VSS.n1888 VSS.n381 0.143368
R8473 VSS.n1882 VSS.n384 0.143368
R8474 VSS.n1880 VSS.n385 0.143368
R8475 VSS.n1873 VSS.n389 0.143368
R8476 VSS.n424 VSS.n390 0.143368
R8477 VSS.n422 VSS.n391 0.143368
R8478 VSS.n1867 VSS.n392 0.143368
R8479 VSS.n1865 VSS.n393 0.143368
R8480 VSS.n1859 VSS.n396 0.143368
R8481 VSS.n1819 VSS.n449 0.143368
R8482 VSS.n1818 VSS.n454 0.143368
R8483 VSS.n1817 VSS.n455 0.143368
R8484 VSS.n465 VSS.n456 0.143368
R8485 VSS.n1812 VSS.n459 0.143368
R8486 VSS.n1772 VSS.n488 0.143368
R8487 VSS.n1771 VSS.n493 0.143368
R8488 VSS.n1770 VSS.n494 0.143368
R8489 VSS.n504 VSS.n495 0.143368
R8490 VSS.n1765 VSS.n498 0.143368
R8491 VSS.n3851 VSS.n3850 0.143368
R8492 VSS.n3849 VSS.n3848 0.143368
R8493 VSS.n3847 VSS.n3846 0.143368
R8494 VSS.n3837 VSS.n126 0.143368
R8495 VSS.n3839 VSS.n3838 0.143368
R8496 VSS.n3836 VSS.n3835 0.143368
R8497 VSS.n3834 VSS.n3833 0.143368
R8498 VSS.n3825 VSS.n130 0.143368
R8499 VSS.n3827 VSS.n3826 0.143368
R8500 VSS.n3802 VSS.n135 0.143368
R8501 VSS.n3804 VSS.n3803 0.143368
R8502 VSS.n3806 VSS.n3805 0.143368
R8503 VSS.n3808 VSS.n3807 0.143368
R8504 VSS.n3811 VSS.n3810 0.143368
R8505 VSS.n3816 VSS.n3815 0.143368
R8506 VSS.n3818 VSS.n3817 0.143368
R8507 VSS.n3820 VSS.n3819 0.143368
R8508 VSS.n3784 VSS.n138 0.143368
R8509 VSS.n3381 VSS.n215 0.143368
R8510 VSS.n3383 VSS.n213 0.143368
R8511 VSS.n3385 VSS.n211 0.143368
R8512 VSS.n3387 VSS.n210 0.143368
R8513 VSS.n3389 VSS.n209 0.143368
R8514 VSS.n3391 VSS.n207 0.143368
R8515 VSS.n3393 VSS.n205 0.143368
R8516 VSS.n3395 VSS.n203 0.143368
R8517 VSS.n3397 VSS.n202 0.143368
R8518 VSS.n3399 VSS.n201 0.143368
R8519 VSS.n3401 VSS.n198 0.143368
R8520 VSS.n3403 VSS.n197 0.143368
R8521 VSS.n3405 VSS.n195 0.143368
R8522 VSS.n3407 VSS.n194 0.143368
R8523 VSS.n3409 VSS.n192 0.143368
R8524 VSS.n3415 VSS.n189 0.143368
R8525 VSS.n3417 VSS.n185 0.143368
R8526 VSS.n3419 VSS.n183 0.143368
R8527 VSS.n2271 VSS.n3356 0.143368
R8528 VSS.n3355 VSS.n3354 0.143368
R8529 VSS.n3353 VSS.n3352 0.143368
R8530 VSS.n3351 VSS.n3350 0.143368
R8531 VSS.n3349 VSS.n3348 0.143368
R8532 VSS.n3347 VSS.n3346 0.143368
R8533 VSS.n3345 VSS.n3344 0.143368
R8534 VSS.n3343 VSS.n3342 0.143368
R8535 VSS.n3327 VSS.n2285 0.143368
R8536 VSS.n3326 VSS.n3325 0.143368
R8537 VSS.n3324 VSS.n3323 0.143368
R8538 VSS.n3322 VSS.n3321 0.143368
R8539 VSS.n3320 VSS.n3319 0.143368
R8540 VSS.n3318 VSS.n3317 0.143368
R8541 VSS.n3316 VSS.n3315 0.143368
R8542 VSS.n3314 VSS.n3313 0.143368
R8543 VSS.n3300 VSS.n2297 0.143368
R8544 VSS.n3299 VSS.n3298 0.143368
R8545 VSS.n3297 VSS.n3296 0.143368
R8546 VSS.n3295 VSS.n3294 0.143368
R8547 VSS.n3293 VSS.n3292 0.143368
R8548 VSS.n3291 VSS.n3290 0.143368
R8549 VSS.n3289 VSS.n3288 0.143368
R8550 VSS.n3287 VSS.n3286 0.143368
R8551 VSS.n3284 VSS.n3283 0.143368
R8552 VSS.n3282 VSS.n3281 0.143368
R8553 VSS.n3280 VSS.n3279 0.143368
R8554 VSS.n3278 VSS.n3277 0.143368
R8555 VSS.n3276 VSS.n3275 0.143368
R8556 VSS.n3274 VSS.n3273 0.143368
R8557 VSS.n3272 VSS.n3271 0.143368
R8558 VSS.n3270 VSS.n3269 0.143368
R8559 VSS.n3247 VSS.n2318 0.143368
R8560 VSS.n3246 VSS.n3245 0.143368
R8561 VSS.n3244 VSS.n3243 0.143368
R8562 VSS.n3242 VSS.n3241 0.143368
R8563 VSS.n3240 VSS.n3239 0.143368
R8564 VSS.n3238 VSS.n3237 0.143368
R8565 VSS.n3236 VSS.n3235 0.143368
R8566 VSS.n3234 VSS.n3233 0.143368
R8567 VSS.n3220 VSS.n2330 0.143368
R8568 VSS.n3219 VSS.n3218 0.143368
R8569 VSS.n3217 VSS.n3216 0.143368
R8570 VSS.n3215 VSS.n3214 0.143368
R8571 VSS.n3213 VSS.n3212 0.143368
R8572 VSS.n3211 VSS.n3210 0.143368
R8573 VSS.n3209 VSS.n3208 0.143368
R8574 VSS.n3207 VSS.n3206 0.143368
R8575 VSS.n3204 VSS.n3203 0.143368
R8576 VSS.n3202 VSS.n3201 0.143368
R8577 VSS.n3200 VSS.n3199 0.143368
R8578 VSS.n3198 VSS.n3197 0.143368
R8579 VSS.n3196 VSS.n3195 0.143368
R8580 VSS.n3194 VSS.n3193 0.143368
R8581 VSS.n3192 VSS.n3191 0.143368
R8582 VSS.n3190 VSS.n3189 0.143368
R8583 VSS.n3188 VSS.n3187 0.143368
R8584 VSS.n3185 VSS.n3184 0.143368
R8585 VSS.n3183 VSS.n3182 0.143368
R8586 VSS.n3181 VSS.n3180 0.143368
R8587 VSS.n3179 VSS.n3178 0.143368
R8588 VSS.n3177 VSS.n3176 0.143368
R8589 VSS.n3175 VSS.n3174 0.143368
R8590 VSS.n3173 VSS.n3172 0.143368
R8591 VSS.n3171 VSS.n3170 0.143368
R8592 VSS.n3716 VSS.n3715 0.143368
R8593 VSS.n3718 VSS.n3717 0.143368
R8594 VSS.n3720 VSS.n3719 0.143368
R8595 VSS.n3722 VSS.n3721 0.143368
R8596 VSS.n3533 VSS.n3532 0.143368
R8597 VSS.n3724 VSS.n3723 0.143368
R8598 VSS.n3729 VSS.n3728 0.143368
R8599 VSS.n3731 VSS.n3730 0.143368
R8600 VSS.n3517 VSS.n3516 0.143368
R8601 VSS.n3733 VSS.n3732 0.143368
R8602 VSS.n3735 VSS.n3734 0.143368
R8603 VSS.n3736 VSS.n3511 0.143368
R8604 VSS.n3688 VSS.n155 0.143368
R8605 VSS.n3686 VSS.n156 0.143368
R8606 VSS.n3544 VSS.n157 0.143368
R8607 VSS.n3681 VSS.n158 0.143368
R8608 VSS.n3679 VSS.n159 0.143368
R8609 VSS.n3677 VSS.n160 0.143368
R8610 VSS.n3547 VSS.n161 0.143368
R8611 VSS.n3672 VSS.n162 0.143368
R8612 VSS.n3670 VSS.n163 0.143368
R8613 VSS.n3608 VSS.n166 0.143368
R8614 VSS.n3610 VSS.n167 0.143368
R8615 VSS.n3600 VSS.n170 0.143368
R8616 VSS.n3598 VSS.n171 0.143368
R8617 VSS.n3744 VSS.t488 0.143368
R8618 VSS.n3748 VSS.n3747 0.143368
R8619 VSS.n3751 VSS.n3750 0.143368
R8620 VSS.n3753 VSS.n3752 0.143368
R8621 VSS.n3755 VSS.n3754 0.143368
R8622 VSS.n3757 VSS.n3756 0.143368
R8623 VSS.n3759 VSS.n3758 0.143368
R8624 VSS.n3761 VSS.n3760 0.143368
R8625 VSS.n3636 VSS.n3487 0.143368
R8626 VSS.n3764 VSS.t693 0.143368
R8627 VSS.n3769 VSS.n3768 0.143368
R8628 VSS.n3771 VSS.n3770 0.143368
R8629 VSS.n3773 VSS.n3772 0.143368
R8630 VSS.n3775 VSS.n3774 0.143368
R8631 VSS.n3777 VSS.n3776 0.143368
R8632 VSS.n3779 VSS.n3778 0.143368
R8633 VSS.n3780 VSS.n3477 0.143368
R8634 VSS.n3654 VSS.n2152 0.143368
R8635 VSS.n3656 VSS.n2154 0.143368
R8636 VSS.n3658 VSS.n2156 0.143368
R8637 VSS.n3660 VSS.n2158 0.143368
R8638 VSS.n3662 VSS.n2159 0.143368
R8639 VSS.n3553 VSS.n2161 0.143368
R8640 VSS.n3620 VSS.n2162 0.143368
R8641 VSS.n3618 VSS.n2164 0.143368
R8642 VSS.n3588 VSS.n2169 0.143368
R8643 VSS.n3590 VSS.n2171 0.143368
R8644 VSS.n3580 VSS.n2176 0.143368
R8645 VSS.n2925 VSS.n2613 0.143368
R8646 VSS.n2923 VSS.n2612 0.143368
R8647 VSS.n2701 VSS.n2611 0.143368
R8648 VSS.n2918 VSS.n2610 0.143368
R8649 VSS.n2916 VSS.n2607 0.143368
R8650 VSS.n2914 VSS.n2606 0.143368
R8651 VSS.n2704 VSS.n2605 0.143368
R8652 VSS.n2909 VSS.n2604 0.143368
R8653 VSS.n2707 VSS.n2602 0.143368
R8654 VSS.n2900 VSS.n2601 0.143368
R8655 VSS.n2898 VSS.n2600 0.143368
R8656 VSS.n2896 VSS.n2599 0.143368
R8657 VSS.n2710 VSS.n2596 0.143368
R8658 VSS.n2891 VSS.n2595 0.143368
R8659 VSS.n2889 VSS.n2594 0.143368
R8660 VSS.n2887 VSS.n2590 0.143368
R8661 VSS.n2880 VSS.n2586 0.143368
R8662 VSS.n2878 VSS.n2585 0.143368
R8663 VSS.n2715 VSS.n2584 0.143368
R8664 VSS.n2873 VSS.n2583 0.143368
R8665 VSS.n2871 VSS.n2579 0.143368
R8666 VSS.n2869 VSS.n2578 0.143368
R8667 VSS.n2718 VSS.n2577 0.143368
R8668 VSS.n2864 VSS.n2576 0.143368
R8669 VSS.n2861 VSS.n2574 0.143368
R8670 VSS.n2721 VSS.n2573 0.143368
R8671 VSS.n2856 VSS.n2572 0.143368
R8672 VSS.n2854 VSS.n2571 0.143368
R8673 VSS.n2852 VSS.n2570 0.143368
R8674 VSS.n2724 VSS.n2566 0.143368
R8675 VSS.n2847 VSS.n2563 0.143368
R8676 VSS.n2845 VSS.n2560 0.143368
R8677 VSS.n2838 VSS.n2555 0.143368
R8678 VSS.n2836 VSS.n2552 0.143368
R8679 VSS.n2834 VSS.n2549 0.143368
R8680 VSS.n2730 VSS.n2548 0.143368
R8681 VSS.n2829 VSS.n2545 0.143368
R8682 VSS.n2827 VSS.n2544 0.143368
R8683 VSS.n2825 VSS.n2543 0.143368
R8684 VSS.n2733 VSS.n2542 0.143368
R8685 VSS.n2817 VSS.n2533 0.143368
R8686 VSS.n2736 VSS.n2532 0.143368
R8687 VSS.n2812 VSS.n2528 0.143368
R8688 VSS.n2810 VSS.n2525 0.143368
R8689 VSS.n2808 VSS.n2522 0.143368
R8690 VSS.n2739 VSS.n2521 0.143368
R8691 VSS.n2803 VSS.n2520 0.143368
R8692 VSS.n2801 VSS.n2516 0.143368
R8693 VSS.n2742 VSS.n2512 0.143368
R8694 VSS.n2795 VSS.n2511 0.143368
R8695 VSS.n2793 VSS.n2507 0.143368
R8696 VSS.n2791 VSS.n2504 0.143368
R8697 VSS.n2745 VSS.n2501 0.143368
R8698 VSS.n2786 VSS.n2498 0.143368
R8699 VSS.n2784 VSS.n2497 0.143368
R8700 VSS.n2782 VSS.n2496 0.143368
R8701 VSS.n2748 VSS.n2495 0.143368
R8702 VSS.n2775 VSS.n2491 0.143368
R8703 VSS.n2773 VSS.n2488 0.143368
R8704 VSS.n2751 VSS.n2485 0.143368
R8705 VSS.n2768 VSS.n2482 0.143368
R8706 VSS.n2766 VSS.n2478 0.143368
R8707 VSS.n2764 VSS.n2475 0.143368
R8708 VSS.n2754 VSS.n2472 0.143368
R8709 VSS.n2759 VSS.n2471 0.143368
R8710 VSS.n3574 VSS.n176 0.143368
R8711 VSS.n3490 VSS.t692 0.143368
R8712 VSS.t699 VSS.n3522 0.143368
R8713 VSS.t698 VSS.n3524 0.143368
R8714 VSS.t695 VSS.n3538 0.143368
R8715 VSS.t694 VSS.n3540 0.143368
R8716 VSS.n3713 VSS.t691 0.143368
R8717 VSS.t697 VSS.t696 0.143368
R8718 VSS.n3515 VSS.t700 0.143368
R8719 VSS.n3510 VSS.t494 0.143368
R8720 VSS.n3285 VSS.t592 0.143368
R8721 VSS.n3205 VSS.t598 0.143368
R8722 VSS.t600 VSS.n3186 0.143368
R8723 VSS.t576 VSS.n2575 0.143368
R8724 VSS.t582 VSS.n2513 0.143368
R8725 VSS.n2777 VSS.t584 0.143368
R8726 VSS.n2614 VSS.t572 0.143368
R8727 VSS.n2272 VSS.t587 0.143368
R8728 VSS.t424 VSS.n242 0.143368
R8729 VSS.t10 VSS.n247 0.143368
R8730 VSS.n252 VSS.t269 0.143368
R8731 VSS.n256 VSS.t433 0.143368
R8732 VSS.t485 VSS.n262 0.143368
R8733 VSS.t65 VSS.n220 0.143368
R8734 VSS.t171 VSS.n388 0.143368
R8735 VSS.n1454 VSS.t437 0.143368
R8736 VSS.n1455 VSS.t174 0.143368
R8737 VSS.t202 VSS.n1472 0.143368
R8738 VSS.n1478 VSS.t444 0.143368
R8739 VSS.t35 VSS.n1461 0.143368
R8740 VSS.t33 VSS.n1080 0.143368
R8741 VSS.n1069 VSS.t644 0.143368
R8742 VSS.t523 VSS.n1065 0.143368
R8743 VSS.n1053 VSS.t473 0.143368
R8744 VSS.t28 VSS.n1049 0.143368
R8745 VSS.n1037 VSS.t193 0.143368
R8746 VSS.t647 VSS.n1033 0.143368
R8747 VSS.n1021 VSS.t705 0.143368
R8748 VSS.t296 VSS.n1017 0.143368
R8749 VSS.n1005 VSS.t196 0.143368
R8750 VSS.t395 VSS.n1001 0.143368
R8751 VSS.n989 VSS.t676 0.143368
R8752 VSS.t343 VSS.n985 0.143368
R8753 VSS.n973 VSS.t381 0.143368
R8754 VSS.t650 VSS.n969 0.143368
R8755 VSS.n957 VSS.t274 0.143368
R8756 VSS.t204 VSS.n953 0.143368
R8757 VSS.n941 VSS.t306 0.143368
R8758 VSS.t19 VSS.n937 0.143368
R8759 VSS.n925 VSS.t330 0.143368
R8760 VSS.t347 VSS.n921 0.143368
R8761 VSS.n909 VSS.t199 0.143368
R8762 VSS.t244 VSS.n905 0.143368
R8763 VSS.n893 VSS.t679 0.143368
R8764 VSS.t660 VSS.n889 0.143368
R8765 VSS.n877 VSS.t353 0.143368
R8766 VSS.t448 VSS.n873 0.143368
R8767 VSS.n861 VSS.t277 0.143368
R8768 VSS.t284 VSS.n857 0.143368
R8769 VSS.n845 VSS.t235 0.143368
R8770 VSS.t460 VSS.n840 0.143368
R8771 VSS.t378 VSS.n781 0.143368
R8772 VSS.t149 VSS.n528 0.143368
R8773 VSS.t140 VSS.n509 0.143368
R8774 VSS.t135 VSS.n489 0.143368
R8775 VSS.t125 VSS.n470 0.143368
R8776 VSS.t120 VSS.n450 0.143368
R8777 VSS.t110 VSS.n431 0.143368
R8778 VSS.t105 VSS.n366 0.143368
R8779 VSS.t95 VSS.n347 0.143368
R8780 VSS.t90 VSS.n327 0.143368
R8781 VSS.t80 VSS.n308 0.143368
R8782 VSS.t75 VSS.n288 0.143368
R8783 VSS.n271 VSS.t21 0.143368
R8784 VSS.n179 VSS.n178 0.1433
R8785 VSS.n3465 VSS.n3464 0.142012
R8786 VSS.n3567 VSS.n3465 0.138262
R8787 VSS.n1484 VSS.n123 0.138073
R8788 VSS.t515 VSS.t476 0.135868
R8789 VSS.t67 VSS.n221 0.129618
R8790 VSS.t82 VSS.n307 0.129618
R8791 VSS.t97 VSS.n346 0.129618
R8792 VSS.t112 VSS.n430 0.129618
R8793 VSS.t127 VSS.n469 0.129618
R8794 VSS.t142 VSS.n508 0.129618
R8795 VSS.n2356 VSS.t602 0.124701
R8796 VSS.t517 VSS.n829 0.124618
R8797 VSS.n829 VSS.t518 0.122118
R8798 VSS.n827 VSS.t515 0.122118
R8799 VSS.n2208 VSS.n2198 0.120892
R8800 VSS.n3092 VSS.n3091 0.120892
R8801 VSS.n3093 VSS.n3092 0.120892
R8802 VSS.n3459 VSS.n2201 0.1205
R8803 VSS.n2204 VSS.n2184 0.1205
R8804 VSS.n2254 VSS.n2253 0.1205
R8805 VSS.n2258 VSS.n2257 0.1205
R8806 VSS.n2261 VSS.t228 0.1205
R8807 VSS.n3045 VSS.n3044 0.1205
R8808 VSS.n3048 VSS.n3047 0.1205
R8809 VSS.n3051 VSS.n3050 0.1205
R8810 VSS.n3054 VSS.n2690 0.1205
R8811 VSS.n3057 VSS.n3056 0.1205
R8812 VSS.n3060 VSS.n3059 0.1205
R8813 VSS.n3063 VSS.n3062 0.1205
R8814 VSS.n3066 VSS.n3065 0.1205
R8815 VSS.n3069 VSS.n3068 0.1205
R8816 VSS.n3072 VSS.n3071 0.1205
R8817 VSS.n3074 VSS.t159 0.1205
R8818 VSS.n3077 VSS.n3076 0.1205
R8819 VSS.n3079 VSS.n2666 0.1205
R8820 VSS.n3081 VSS.n2662 0.1205
R8821 VSS.n3083 VSS.n2658 0.1205
R8822 VSS.n3087 VSS.n3086 0.1205
R8823 VSS.n3090 VSS.n2645 0.1205
R8824 VSS.n3095 VSS.n3094 0.1205
R8825 VSS.n3098 VSS.n3097 0.1205
R8826 VSS.n3101 VSS.n3100 0.1205
R8827 VSS.n3104 VSS.n3103 0.1205
R8828 VSS.n3107 VSS.n3106 0.1205
R8829 VSS.n3109 VSS.t317 0.1205
R8830 VSS.n3113 VSS.n3112 0.1205
R8831 VSS.t407 VSS.n2184 0.1205
R8832 VSS.n2620 VSS.t3 0.1205
R8833 VSS.n2625 VSS.t5 0.1205
R8834 VSS.t317 VSS.n2629 0.1205
R8835 VSS.n2645 VSS.t404 0.1205
R8836 VSS.n2648 VSS.t366 0.1205
R8837 VSS.t279 VSS.n2654 0.1205
R8838 VSS.n2658 VSS.t442 0.1205
R8839 VSS.n2662 VSS.t161 0.1205
R8840 VSS.n2666 VSS.t368 0.1205
R8841 VSS.t159 VSS.n2672 0.1205
R8842 VSS.n2690 VSS.t157 0.1205
R8843 VSS.n2693 VSS.t163 0.1205
R8844 VSS.n2265 VSS.t228 0.1205
R8845 VSS.n2201 VSS.n2200 0.120486
R8846 VSS.t491 VSS.n3573 0.1171
R8847 VSS.n3629 VSS.n3498 0.11631
R8848 VSS.n823 VSS.n789 0.113429
R8849 VSS.n3168 VSS.n3167 0.113429
R8850 VSS.n2758 VSS.n2756 0.113429
R8851 VSS.n3577 VSS.n3575 0.113429
R8852 VSS.n3582 VSS.n3581 0.113429
R8853 VSS.n3629 VSS.n3496 0.113429
R8854 VSS.n1153 VSS.n1152 0.113429
R8855 VSS.n3505 VSS.n3738 0.112118
R8856 VSS.n3141 VSS.n3140 0.108056
R8857 VSS.t69 VSS.n277 0.105868
R8858 VSS.t84 VSS.n317 0.105868
R8859 VSS.t99 VSS.n356 0.105868
R8860 VSS.t114 VSS.n440 0.105868
R8861 VSS.t129 VSS.n479 0.105868
R8862 VSS.t144 VSS.n518 0.105868
R8863 VSS.t476 VSS.n828 0.1033
R8864 VSS.t64 VSS.n2118 0.0971176
R8865 VSS.t79 VSS.n298 0.0971176
R8866 VSS.t94 VSS.n337 0.0971176
R8867 VSS.t109 VSS.n397 0.0971176
R8868 VSS.t124 VSS.n460 0.0971176
R8869 VSS.t139 VSS.n499 0.0971176
R8870 VSS.t504 VSS.n2219 0.0971176
R8871 VSS.n3432 VSS.n2227 0.0971176
R8872 VSS.n1497 VSS.n1496 0.0961384
R8873 VSS.n1502 VSS.n1501 0.0961384
R8874 VSS.n1156 VSS.n1155 0.0961384
R8875 VSS.n1165 VSS.n1164 0.0961384
R8876 VSS.n1174 VSS.n1173 0.0961384
R8877 VSS.n1183 VSS.n1182 0.0961384
R8878 VSS.n1192 VSS.n1191 0.0961384
R8879 VSS.n1201 VSS.n1200 0.0961384
R8880 VSS.n1210 VSS.n1209 0.0961384
R8881 VSS.n1219 VSS.n1218 0.0961384
R8882 VSS.n1228 VSS.n1227 0.0961384
R8883 VSS.n1237 VSS.n1236 0.0961384
R8884 VSS.n1246 VSS.n1245 0.0961384
R8885 VSS.n1255 VSS.n1254 0.0961384
R8886 VSS.n1264 VSS.n1263 0.0961384
R8887 VSS.n1273 VSS.n1272 0.0961384
R8888 VSS.n1282 VSS.n1281 0.0961384
R8889 VSS.n1291 VSS.n1290 0.0961384
R8890 VSS.n1300 VSS.n1299 0.0961384
R8891 VSS.n1309 VSS.n1308 0.0961384
R8892 VSS.n1318 VSS.n1317 0.0961384
R8893 VSS.n1327 VSS.n1326 0.0961384
R8894 VSS.n1336 VSS.n1335 0.0961384
R8895 VSS.n1345 VSS.n1344 0.0961384
R8896 VSS.n1354 VSS.n1353 0.0961384
R8897 VSS.n1363 VSS.n1362 0.0961384
R8898 VSS.n1372 VSS.n1371 0.0961384
R8899 VSS.n1381 VSS.n1380 0.0961384
R8900 VSS.n1390 VSS.n1389 0.0961384
R8901 VSS.n1399 VSS.n1398 0.0961384
R8902 VSS.n1408 VSS.n1407 0.0961384
R8903 VSS.n1417 VSS.n1416 0.0961384
R8904 VSS.n1426 VSS.n1425 0.0961384
R8905 VSS.n1435 VSS.n1434 0.0961384
R8906 VSS.t33 VSS.n1081 0.0961384
R8907 VSS.n1068 VSS.t523 0.0961384
R8908 VSS.n1052 VSS.t28 0.0961384
R8909 VSS.n1036 VSS.t647 0.0961384
R8910 VSS.n1020 VSS.t296 0.0961384
R8911 VSS.n1004 VSS.t395 0.0961384
R8912 VSS.n988 VSS.t343 0.0961384
R8913 VSS.n972 VSS.t650 0.0961384
R8914 VSS.n956 VSS.t204 0.0961384
R8915 VSS.n940 VSS.t19 0.0961384
R8916 VSS.n924 VSS.t347 0.0961384
R8917 VSS.n908 VSS.t244 0.0961384
R8918 VSS.n892 VSS.t660 0.0961384
R8919 VSS.n876 VSS.t448 0.0961384
R8920 VSS.n860 VSS.t284 0.0961384
R8921 VSS.n844 VSS.t460 0.0961384
R8922 VSS.n828 VSS.n1738 0.0961384
R8923 VSS.t152 VSS.n533 0.0961384
R8924 VSS.n268 VSS.n2074 0.0961384
R8925 VSS.n264 VSS.n2078 0.0961384
R8926 VSS.t431 VSS.n2082 0.0961384
R8927 VSS.t269 VSS.n2086 0.0961384
R8928 VSS.t47 VSS.n2090 0.0961384
R8929 VSS.t155 VSS.n2114 0.0961384
R8930 VSS.t50 VSS.n295 0.0961384
R8931 VSS.t190 VSS.n334 0.0961384
R8932 VSS.t179 VSS.n373 0.0961384
R8933 VSS.n416 VSS.n382 0.0961384
R8934 VSS.n420 VSS.n386 0.0961384
R8935 VSS.t526 VSS.n394 0.0961384
R8936 VSS.t53 VSS.n457 0.0961384
R8937 VSS.t638 VSS.n496 0.0961384
R8938 VSS.n3824 VSS.n3823 0.0961384
R8939 VSS.n3810 VSS.n3809 0.0961384
R8940 VSS.n3821 VSS.n138 0.0961384
R8941 VSS.n3750 VSS.n3749 0.0961384
R8942 VSS.n3723 VSS.n3529 0.0961384
R8943 VSS.n2907 VSS.n2603 0.0961384
R8944 VSS.t574 VSS.n2587 0.0961384
R8945 VSS.n2843 VSS.n2559 0.0961384
R8946 VSS.t580 VSS.n2538 0.0961384
R8947 VSS.n2757 VSS.n2467 0.0961384
R8948 VSS.n3170 VSS.n3169 0.0961384
R8949 VSS.n3233 VSS.n3232 0.0961384
R8950 VSS.n3269 VSS.n3268 0.0961384
R8951 VSS.n3313 VSS.n3312 0.0961384
R8952 VSS.n3342 VSS.n3341 0.0961384
R8953 VSS.n3381 VSS.n154 0.0961384
R8954 VSS.n3415 VSS.n186 0.0961384
R8955 VSS.n3668 VSS.n164 0.0961384
R8956 VSS.n3596 VSS.n172 0.0961384
R8957 VSS.n3610 VSS.n168 0.0961384
R8958 VSS.n3650 VSS.n3476 0.0961384
R8959 VSS.n3588 VSS.n3468 0.0961384
R8960 VSS.n848 VSS.n847 0.0961384
R8961 VSS.n864 VSS.n863 0.0961384
R8962 VSS.n880 VSS.n879 0.0961384
R8963 VSS.n896 VSS.n895 0.0961384
R8964 VSS.n912 VSS.n911 0.0961384
R8965 VSS.n928 VSS.n927 0.0961384
R8966 VSS.n944 VSS.n943 0.0961384
R8967 VSS.n960 VSS.n959 0.0961384
R8968 VSS.n976 VSS.n975 0.0961384
R8969 VSS.n992 VSS.n991 0.0961384
R8970 VSS.n1008 VSS.n1007 0.0961384
R8971 VSS.n1024 VSS.n1023 0.0961384
R8972 VSS.n1040 VSS.n1039 0.0961384
R8973 VSS.n1056 VSS.n1055 0.0961384
R8974 VSS.n1072 VSS.n1071 0.0961384
R8975 VSS.n1735 VSS.n1734 0.0961384
R8976 VSS.n1479 VSS.t478 0.0961384
R8977 VSS.n1496 VSS.t466 0.0958002
R8978 VSS.n1501 VSS.n1460 0.0958002
R8979 VSS.n1155 VSS.n1154 0.0958002
R8980 VSS.n1164 VSS.n1163 0.0958002
R8981 VSS.n1173 VSS.n1172 0.0958002
R8982 VSS.n1182 VSS.n1181 0.0958002
R8983 VSS.n1191 VSS.n1190 0.0958002
R8984 VSS.n1200 VSS.n1199 0.0958002
R8985 VSS.n1209 VSS.n1208 0.0958002
R8986 VSS.n1218 VSS.n1217 0.0958002
R8987 VSS.n1227 VSS.n1226 0.0958002
R8988 VSS.n1236 VSS.n1235 0.0958002
R8989 VSS.n1245 VSS.n1244 0.0958002
R8990 VSS.n1254 VSS.n1253 0.0958002
R8991 VSS.n1263 VSS.n1262 0.0958002
R8992 VSS.n1272 VSS.n1271 0.0958002
R8993 VSS.n1281 VSS.n1280 0.0958002
R8994 VSS.n1290 VSS.n1289 0.0958002
R8995 VSS.n1299 VSS.n1298 0.0958002
R8996 VSS.n1308 VSS.n1307 0.0958002
R8997 VSS.n1317 VSS.n1316 0.0958002
R8998 VSS.n1326 VSS.n1325 0.0958002
R8999 VSS.n1335 VSS.n1334 0.0958002
R9000 VSS.n1344 VSS.n1343 0.0958002
R9001 VSS.n1353 VSS.n1352 0.0958002
R9002 VSS.n1362 VSS.n1361 0.0958002
R9003 VSS.n1371 VSS.n1370 0.0958002
R9004 VSS.n1380 VSS.n1379 0.0958002
R9005 VSS.n1389 VSS.n1388 0.0958002
R9006 VSS.n1398 VSS.n1397 0.0958002
R9007 VSS.n1407 VSS.n1406 0.0958002
R9008 VSS.n1416 VSS.n1415 0.0958002
R9009 VSS.n1425 VSS.n1424 0.0958002
R9010 VSS.n1434 VSS.n1433 0.0958002
R9011 VSS.t313 VSS.n1072 0.0958002
R9012 VSS.t298 VSS.n1056 0.0958002
R9013 VSS.t217 VSS.n1040 0.0958002
R9014 VSS.t350 VSS.n1024 0.0958002
R9015 VSS.t301 VSS.n1008 0.0958002
R9016 VSS.t62 VSS.n992 0.0958002
R9017 VSS.t183 VSS.n976 0.0958002
R9018 VSS.t240 VSS.n960 0.0958002
R9019 VSS.t421 VSS.n944 0.0958002
R9020 VSS.t230 VSS.n928 0.0958002
R9021 VSS.t687 VSS.n912 0.0958002
R9022 VSS.t391 VSS.n896 0.0958002
R9023 VSS.t247 VSS.n880 0.0958002
R9024 VSS.t31 VSS.n864 0.0958002
R9025 VSS.t358 VSS.n848 0.0958002
R9026 VSS.t12 VSS.n1735 0.0958002
R9027 VSS.n1081 VSS.n1515 0.0958002
R9028 VSS.t644 VSS.n1068 0.0958002
R9029 VSS.t473 VSS.n1052 0.0958002
R9030 VSS.t193 VSS.n1036 0.0958002
R9031 VSS.t705 VSS.n1020 0.0958002
R9032 VSS.t196 VSS.n1004 0.0958002
R9033 VSS.t676 VSS.n988 0.0958002
R9034 VSS.t381 VSS.n972 0.0958002
R9035 VSS.t274 VSS.n956 0.0958002
R9036 VSS.t306 VSS.n940 0.0958002
R9037 VSS.t330 VSS.n924 0.0958002
R9038 VSS.t199 VSS.n908 0.0958002
R9039 VSS.t679 VSS.n892 0.0958002
R9040 VSS.t353 VSS.n876 0.0958002
R9041 VSS.t277 VSS.n860 0.0958002
R9042 VSS.t235 VSS.n844 0.0958002
R9043 VSS.n805 VSS.n533 0.0958002
R9044 VSS.n2074 VSS.n271 0.0958002
R9045 VSS.n2078 VSS.n2077 0.0958002
R9046 VSS.n2082 VSS.n2081 0.0958002
R9047 VSS.n2086 VSS.n2085 0.0958002
R9048 VSS.n2090 VSS.t10 0.0958002
R9049 VSS.n2114 VSS.n2113 0.0958002
R9050 VSS.n303 VSS.n295 0.0958002
R9051 VSS.n342 VSS.n334 0.0958002
R9052 VSS.n407 VSS.n373 0.0958002
R9053 VSS.n1888 VSS.n382 0.0958002
R9054 VSS.n1880 VSS.n386 0.0958002
R9055 VSS.n1865 VSS.n394 0.0958002
R9056 VSS.n465 VSS.n457 0.0958002
R9057 VSS.n504 VSS.n496 0.0958002
R9058 VSS.n3169 VSS.t602 0.0958002
R9059 VSS.n3232 VSS.t596 0.0958002
R9060 VSS.n3268 VSS.n2313 0.0958002
R9061 VSS.n3341 VSS.n2280 0.0958002
R9062 VSS.n3827 VSS.n3824 0.0958002
R9063 VSS.n3809 VSS.n3808 0.0958002
R9064 VSS.n3821 VSS.n3820 0.0958002
R9065 VSS.n154 VSS.n153 0.0958002
R9066 VSS.n3417 VSS.n186 0.0958002
R9067 VSS.n3312 VSS.t590 0.0958002
R9068 VSS.n3613 VSS.n168 0.0958002
R9069 VSS.n3670 VSS.n164 0.0958002
R9070 VSS.n3598 VSS.n172 0.0958002
R9071 VSS.n3501 VSS.n3743 0.0958002
R9072 VSS.n3749 VSS.n3748 0.0958002
R9073 VSS.n3477 VSS.n3476 0.0958002
R9074 VSS.n3558 VSS.n3468 0.0958002
R9075 VSS.n2909 VSS.n2603 0.0958002
R9076 VSS.n2887 VSS.n2587 0.0958002
R9077 VSS.n2845 VSS.n2559 0.0958002
R9078 VSS.n2733 VSS.n2538 0.0958002
R9079 VSS.n2759 VSS.n2467 0.0958002
R9080 VSS.n2226 VSS.n2225 0.0958002
R9081 VSS.n1483 VSS.t478 0.0958002
R9082 VSS.n3529 VSS.t697 0.0958002
R9083 VSS.n1493 VSS.n1467 0.0955
R9084 VSS.t37 VSS.n1500 0.0955
R9085 VSS.n1505 VSS.n1453 0.0955
R9086 VSS.n1443 VSS.n1442 0.0955
R9087 VSS.n1515 VSS.n1514 0.0955
R9088 VSS.n814 VSS.n783 0.0955
R9089 VSS.n816 VSS.n783 0.0955
R9090 VSS.n2075 VSS.t7 0.0955
R9091 VSS.n2079 VSS.t483 0.0955
R9092 VSS.n2083 VSS.n258 0.0955
R9093 VSS.n2087 VSS.t271 0.0955
R9094 VSS.n2091 VSS.n244 0.0955
R9095 VSS.n2115 VSS.n228 0.0955
R9096 VSS.n2021 VSS.t70 0.0955
R9097 VSS.n301 VSS.n300 0.0955
R9098 VSS.n1974 VSS.t85 0.0955
R9099 VSS.n340 VSS.n339 0.0955
R9100 VSS.n1927 VSS.t100 0.0955
R9101 VSS.n405 VSS.n404 0.0955
R9102 VSS.n414 VSS.t440 0.0955
R9103 VSS.n418 VSS.t169 0.0955
R9104 VSS.n426 VSS.n399 0.0955
R9105 VSS.n1841 VSS.t115 0.0955
R9106 VSS.n463 VSS.n462 0.0955
R9107 VSS.n1794 VSS.t130 0.0955
R9108 VSS.n502 VSS.n501 0.0955
R9109 VSS.n1747 VSS.t145 0.0955
R9110 VSS.n3823 VSS.n3822 0.0955
R9111 VSS.n3822 VSS.n134 0.0955
R9112 VSS.n3813 VSS.n3812 0.0955
R9113 VSS.n3814 VSS.n3813 0.0955
R9114 VSS.n3785 VSS.n3782 0.0955
R9115 VSS.n3782 VSS.n153 0.0955
R9116 VSS.n3411 VSS.n190 0.0955
R9117 VSS.n3413 VSS.n190 0.0955
R9118 VSS.n3421 VSS.n182 0.0955
R9119 VSS.n2284 VSS.t588 0.0955
R9120 VSS.n2296 VSS.n2292 0.0955
R9121 VSS.n2317 VSS.t594 0.0955
R9122 VSS.n2329 VSS.n2325 0.0955
R9123 VSS.n3726 VSS.n3725 0.0955
R9124 VSS.n3727 VSS.n3726 0.0955
R9125 VSS.n3550 VSS.n165 0.0955
R9126 VSS.n3745 VSS.n3744 0.0955
R9127 VSS.n3766 VSS.n3765 0.0955
R9128 VSS.n3767 VSS.n3766 0.0955
R9129 VSS.n2905 VSS.t571 0.0955
R9130 VSS.n2882 VSS.n2394 0.0955
R9131 VSS.n2727 VSS.t578 0.0955
R9132 VSS.n2819 VSS.n2437 0.0955
R9133 VSS.n2225 VSS.n2223 0.0955
R9134 VSS.n2907 VSS.t571 0.0955
R9135 VSS.n2843 VSS.t578 0.0955
R9136 VSS.t580 VSS.n2437 0.0955
R9137 VSS.n2757 VSS.t586 0.0955
R9138 VSS.t574 VSS.n2394 0.0955
R9139 VSS.n2325 VSS.t596 0.0955
R9140 VSS.t594 VSS.n2313 0.0955
R9141 VSS.n2292 VSS.t590 0.0955
R9142 VSS.t588 VSS.n2280 0.0955
R9143 VSS.n228 VSS.t155 0.0955
R9144 VSS.n244 VSS.t47 0.0955
R9145 VSS.t271 VSS.n250 0.0955
R9146 VSS.n258 VSS.t431 0.0955
R9147 VSS.t483 VSS.n264 0.0955
R9148 VSS.t7 VSS.n268 0.0955
R9149 VSS.n301 VSS.t50 0.0955
R9150 VSS.n340 VSS.t190 0.0955
R9151 VSS.n405 VSS.t179 0.0955
R9152 VSS.n463 VSS.t53 0.0955
R9153 VSS.n502 VSS.t638 0.0955
R9154 VSS.n1460 VSS.t37 0.0955
R9155 VSS.t466 VSS.n1467 0.0955
R9156 VSS.t145 VSS.n520 0.0955
R9157 VSS.t130 VSS.n481 0.0955
R9158 VSS.t115 VSS.n442 0.0955
R9159 VSS.t526 VSS.n399 0.0955
R9160 VSS.n420 VSS.t169 0.0955
R9161 VSS.n416 VSS.t440 0.0955
R9162 VSS.t100 VSS.n358 0.0955
R9163 VSS.t85 VSS.n319 0.0955
R9164 VSS.t70 VSS.n280 0.0955
R9165 VSS.n3596 VSS.n3595 0.09425
R9166 VSS.n3594 VSS.n3593 0.09425
R9167 VSS.n2237 VSS.n2236 0.093
R9168 VSS.n1087 VSS.t165 0.0928744
R9169 VSS.n3433 VSS.n3431 0.0903963
R9170 VSS.n1449 VSS.t510 0.08925
R9171 VSS.t74 VSS.n282 0.08925
R9172 VSS.t89 VSS.n321 0.08925
R9173 VSS.t104 VSS.n360 0.08925
R9174 VSS.t119 VSS.n444 0.08925
R9175 VSS.t134 VSS.n483 0.08925
R9176 VSS.t150 VSS.n522 0.08925
R9177 VSS.n3569 VSS.n2175 0.0871176
R9178 VSS.n3570 VSS.n174 0.0871176
R9179 VSS.t506 VSS.n2244 0.0851154
R9180 VSS.n2245 VSS.t509 0.0851154
R9181 VSS.t499 VSS.n2233 0.0851154
R9182 VSS.n2234 VSS.t503 0.0851154
R9183 VSS.n1513 VSS.t512 0.0851154
R9184 VSS.n1082 VSS.t514 0.0851154
R9185 VSS.n3614 VSS.n169 0.08425
R9186 VSS.n3615 VSS.n2166 0.08425
R9187 VSS.n3668 VSS.n3667 0.08175
R9188 VSS.n3666 VSS.n3665 0.08175
R9189 VSS.n2233 VSS.n2228 0.08175
R9190 VSS.n2244 VSS.n2239 0.08175
R9191 VSS.n2232 VSS.n2 0.08175
R9192 VSS.n2243 VSS.n2220 0.08175
R9193 VSS.t519 VSS.n826 0.0805
R9194 VSS.n2268 VSS.n182 0.0805
R9195 VSS.n178 VSS.n177 0.0805
R9196 VSS.n3505 VSS.n33 0.0796176
R9197 VSS.n3504 VSS.n3503 0.0796176
R9198 VSS.t64 VSS.n224 0.078
R9199 VSS.t79 VSS.n1990 0.078
R9200 VSS.t94 VSS.n1943 0.078
R9201 VSS.t109 VSS.n1857 0.078
R9202 VSS.t124 VSS.n1810 0.078
R9203 VSS.t139 VSS.n1763 0.078
R9204 VSS.n1513 VSS.n1512 0.0746176
R9205 VSS.n3572 VSS.n177 0.07425
R9206 VSS.t500 VSS.n3445 0.0740901
R9207 VSS.t497 VSS.n0 0.0740901
R9208 VSS.n2264 VSS.n2249 0.0726677
R9209 VSS.n3458 VSS.n3457 0.0726677
R9210 VSS.n2995 VSS.n2699 0.0726677
R9211 VSS.n1453 VSS.n1452 0.07175
R9212 VSS.n1437 VSS.n1440 0.06925
R9213 VSS.t167 VSS.n1513 0.06925
R9214 VSS.t69 VSS.n2027 0.06925
R9215 VSS.t84 VSS.n312 0.06925
R9216 VSS.t99 VSS.n351 0.06925
R9217 VSS.t114 VSS.n435 0.06925
R9218 VSS.t129 VSS.n474 0.06925
R9219 VSS.t144 VSS.n513 0.06925
R9220 VSS.n3560 VSS.n169 0.06925
R9221 VSS.n3559 VSS.n2166 0.06925
R9222 VSS.n2642 VSS.n2207 0.0672586
R9223 VSS.n3448 VSS.n2205 0.0672586
R9224 VSS.n2643 VSS.n2207 0.0672586
R9225 VSS.n3047 VSS.n3046 0.0672168
R9226 VSS.n2234 VSS.n2230 0.0671176
R9227 VSS.n2245 VSS.n2241 0.0671176
R9228 VSS.n2231 VSS.n2217 0.0671176
R9229 VSS.n2242 VSS.n2221 0.0671176
R9230 VSS.n2022 VSS.n2021 0.066499
R9231 VSS.n1975 VSS.n1974 0.066499
R9232 VSS.n1928 VSS.n1927 0.066499
R9233 VSS.n1842 VSS.n1841 0.066499
R9234 VSS.n1795 VSS.n1794 0.066499
R9235 VSS.n1748 VSS.n1747 0.066499
R9236 VSS.n3743 VSS.n3504 0.06425
R9237 VSS.n3666 VSS.n2160 0.0621177
R9238 VSS.n2233 VSS.n2230 0.0621177
R9239 VSS.n2244 VSS.n2241 0.0621177
R9240 VSS.n2232 VSS.n2217 0.0621177
R9241 VSS.n2243 VSS.n2221 0.0621177
R9242 VSS.n3050 VSS.n3049 0.060789
R9243 VSS.t163 VSS.n3052 0.060789
R9244 VSS.t157 VSS.n3053 0.060789
R9245 VSS.n3056 VSS.n3055 0.060789
R9246 VSS.n3059 VSS.n3058 0.060789
R9247 VSS.n3062 VSS.n3061 0.060789
R9248 VSS.n3065 VSS.n3064 0.060789
R9249 VSS.n3068 VSS.n3067 0.060789
R9250 VSS.n3071 VSS.n3070 0.060789
R9251 VSS.n2672 VSS.n3073 0.060789
R9252 VSS.n3076 VSS.n3075 0.060789
R9253 VSS.t368 VSS.n3078 0.060789
R9254 VSS.t161 VSS.n3080 0.060789
R9255 VSS.t442 VSS.n3082 0.060789
R9256 VSS.n2654 VSS.n3084 0.060789
R9257 VSS.n3086 VSS.n3085 0.060789
R9258 VSS.t366 VSS.n3088 0.060789
R9259 VSS.t404 VSS.n3089 0.060789
R9260 VSS.n3094 VSS.n3093 0.060789
R9261 VSS.n3097 VSS.n3096 0.060789
R9262 VSS.n3100 VSS.n3099 0.060789
R9263 VSS.n3103 VSS.n3102 0.060789
R9264 VSS.n3106 VSS.n3105 0.060789
R9265 VSS.n2629 VSS.n3108 0.060789
R9266 VSS.t5 VSS.n3110 0.060789
R9267 VSS.n3112 VSS.n3111 0.060789
R9268 VSS.t3 VSS.n3114 0.060789
R9269 VSS.n3116 VSS.n3115 0.060789
R9270 VSS.n3460 VSS.n3459 0.060789
R9271 VSS.t407 VSS.n2182 0.060789
R9272 VSS.n2257 VSS.n2195 0.060789
R9273 VSS.n2261 VSS.t226 0.060789
R9274 VSS.n3441 VSS.n2265 0.060789
R9275 VSS.n3460 VSS.n2178 0.060789
R9276 VSS.t332 VSS.n2182 0.060789
R9277 VSS.n2204 VSS.n2198 0.060789
R9278 VSS.n2254 VSS.n2195 0.060789
R9279 VSS.n3049 VSS.n3048 0.060789
R9280 VSS.n3052 VSS.n3051 0.060789
R9281 VSS.n3053 VSS.n2693 0.060789
R9282 VSS.n3055 VSS.n3054 0.060789
R9283 VSS.n3058 VSS.n3057 0.060789
R9284 VSS.n3061 VSS.n3060 0.060789
R9285 VSS.n3064 VSS.n3063 0.060789
R9286 VSS.n3067 VSS.n3066 0.060789
R9287 VSS.n3070 VSS.n3069 0.060789
R9288 VSS.n3073 VSS.n3072 0.060789
R9289 VSS.n3075 VSS.n3074 0.060789
R9290 VSS.n3078 VSS.n3077 0.060789
R9291 VSS.n3080 VSS.n3079 0.060789
R9292 VSS.n3082 VSS.n3081 0.060789
R9293 VSS.n3084 VSS.n3083 0.060789
R9294 VSS.n3085 VSS.t279 0.060789
R9295 VSS.n3088 VSS.n3087 0.060789
R9296 VSS.n3089 VSS.n2648 0.060789
R9297 VSS.n3091 VSS.n3090 0.060789
R9298 VSS.n3096 VSS.n3095 0.060789
R9299 VSS.n3099 VSS.n3098 0.060789
R9300 VSS.n3102 VSS.n3101 0.060789
R9301 VSS.n3105 VSS.n3104 0.060789
R9302 VSS.n3108 VSS.n3107 0.060789
R9303 VSS.n3110 VSS.n3109 0.060789
R9304 VSS.n3111 VSS.n2625 0.060789
R9305 VSS.n3114 VSS.n3113 0.060789
R9306 VSS.n3115 VSS.n2620 0.060789
R9307 VSS.n3434 VSS.n3433 0.0607773
R9308 VSS.n1438 VSS.n1437 0.05925
R9309 VSS.n1082 VSS.t167 0.05925
R9310 VSS.t586 VSS.n2357 0.058
R9311 VSS.t569 VSS.n2219 0.0571176
R9312 VSS.n3570 VSS.n3571 0.05675
R9313 VSS.n3569 VSS.n3568 0.05675
R9314 VSS.n3046 VSS.n3045 0.0553461
R9315 VSS.n1441 VSS.t510 0.0546176
R9316 VSS.n3118 VSS.n2357 0.0546082
R9317 VSS.n2027 VSS.t67 0.05175
R9318 VSS.t82 VSS.n312 0.05175
R9319 VSS.t97 VSS.n351 0.05175
R9320 VSS.t112 VSS.n435 0.05175
R9321 VSS.t127 VSS.n474 0.05175
R9322 VSS.t142 VSS.n513 0.05175
R9323 VSS.n3595 VSS.n173 0.0496177
R9324 VSS.n3594 VSS.n2173 0.0496177
R9325 VSS.n2238 VSS.n2237 0.04925
R9326 VSS.t444 VSS.n1487 0.0483676
R9327 VSS.n1488 VSS.n1478 0.0483676
R9328 VSS.n1491 VSS.n1473 0.0483676
R9329 VSS.n1472 VSS.n1492 0.0483676
R9330 VSS.n1493 VSS.t202 0.0483676
R9331 VSS.t35 VSS.n1466 0.0483676
R9332 VSS.n1500 VSS.n1461 0.0483676
R9333 VSS.t174 VSS.n1456 0.0483676
R9334 VSS.t437 VSS.n1455 0.0483676
R9335 VSS.n1505 VSS.n1454 0.0483676
R9336 VSS.n1158 VSS.n1157 0.0483676
R9337 VSS.n1167 VSS.n1166 0.0483676
R9338 VSS.n1176 VSS.n1175 0.0483676
R9339 VSS.n1185 VSS.n1184 0.0483676
R9340 VSS.n1194 VSS.n1193 0.0483676
R9341 VSS.n1203 VSS.n1202 0.0483676
R9342 VSS.n1212 VSS.n1211 0.0483676
R9343 VSS.n1221 VSS.n1220 0.0483676
R9344 VSS.n1230 VSS.n1229 0.0483676
R9345 VSS.n1239 VSS.n1238 0.0483676
R9346 VSS.n1248 VSS.n1247 0.0483676
R9347 VSS.n1257 VSS.n1256 0.0483676
R9348 VSS.n1266 VSS.n1265 0.0483676
R9349 VSS.n1275 VSS.n1274 0.0483676
R9350 VSS.n1284 VSS.n1283 0.0483676
R9351 VSS.n1293 VSS.n1292 0.0483676
R9352 VSS.n1302 VSS.n1301 0.0483676
R9353 VSS.n1311 VSS.n1310 0.0483676
R9354 VSS.n1320 VSS.n1319 0.0483676
R9355 VSS.n1329 VSS.n1328 0.0483676
R9356 VSS.n1338 VSS.n1337 0.0483676
R9357 VSS.n1347 VSS.n1346 0.0483676
R9358 VSS.n1356 VSS.n1355 0.0483676
R9359 VSS.n1365 VSS.n1364 0.0483676
R9360 VSS.n1374 VSS.n1373 0.0483676
R9361 VSS.n1383 VSS.n1382 0.0483676
R9362 VSS.n1392 VSS.n1391 0.0483676
R9363 VSS.n1401 VSS.n1400 0.0483676
R9364 VSS.n1410 VSS.n1409 0.0483676
R9365 VSS.n1419 VSS.n1418 0.0483676
R9366 VSS.n1428 VSS.n1427 0.0483676
R9367 VSS.n1443 VSS.n1436 0.0483676
R9368 VSS.n1439 VSS.n1441 0.0483676
R9369 VSS.n1080 VSS.n1078 0.0483676
R9370 VSS.n1063 VSS.n1065 0.0483676
R9371 VSS.n1047 VSS.n1049 0.0483676
R9372 VSS.n1031 VSS.n1033 0.0483676
R9373 VSS.n1015 VSS.n1017 0.0483676
R9374 VSS.n999 VSS.n1001 0.0483676
R9375 VSS.n983 VSS.n985 0.0483676
R9376 VSS.n967 VSS.n969 0.0483676
R9377 VSS.n951 VSS.n953 0.0483676
R9378 VSS.n935 VSS.n937 0.0483676
R9379 VSS.n919 VSS.n921 0.0483676
R9380 VSS.n903 VSS.n905 0.0483676
R9381 VSS.n887 VSS.n889 0.0483676
R9382 VSS.n871 VSS.n873 0.0483676
R9383 VSS.n855 VSS.n857 0.0483676
R9384 VSS.n838 VSS.n840 0.0483676
R9385 VSS.n1512 VSS.n1511 0.0483676
R9386 VSS.n1521 VSS.t723 0.0483676
R9387 VSS.n1523 VSS.n1522 0.0483676
R9388 VSS.n1527 VSS.n1069 0.0483676
R9389 VSS.t238 VSS.n1061 0.0483676
R9390 VSS.n1060 VSS.n1059 0.0483676
R9391 VSS.n1541 VSS.n1053 0.0483676
R9392 VSS.t187 VSS.n1045 0.0483676
R9393 VSS.n1044 VSS.n1043 0.0483676
R9394 VSS.n1555 VSS.n1037 0.0483676
R9395 VSS.t375 VSS.n1029 0.0483676
R9396 VSS.n1028 VSS.n1027 0.0483676
R9397 VSS.n1569 VSS.n1021 0.0483676
R9398 VSS.t720 VSS.n1013 0.0483676
R9399 VSS.n1012 VSS.n1011 0.0483676
R9400 VSS.n1583 VSS.n1005 0.0483676
R9401 VSS.t212 VSS.n997 0.0483676
R9402 VSS.n996 VSS.n995 0.0483676
R9403 VSS.n1597 VSS.n989 0.0483676
R9404 VSS.t664 VSS.n981 0.0483676
R9405 VSS.n980 VSS.n979 0.0483676
R9406 VSS.n1611 VSS.n973 0.0483676
R9407 VSS.t454 VSS.n965 0.0483676
R9408 VSS.n964 VSS.n963 0.0483676
R9409 VSS.n1625 VSS.n957 0.0483676
R9410 VSS.t712 VSS.n949 0.0483676
R9411 VSS.n948 VSS.n947 0.0483676
R9412 VSS.n1639 VSS.n941 0.0483676
R9413 VSS.t372 VSS.n933 0.0483676
R9414 VSS.n932 VSS.n931 0.0483676
R9415 VSS.n1653 VSS.n925 0.0483676
R9416 VSS.t717 VSS.n917 0.0483676
R9417 VSS.n916 VSS.n915 0.0483676
R9418 VSS.n1667 VSS.n909 0.0483676
R9419 VSS.t209 VSS.n901 0.0483676
R9420 VSS.n900 VSS.n899 0.0483676
R9421 VSS.n1681 VSS.n893 0.0483676
R9422 VSS.t658 VSS.n885 0.0483676
R9423 VSS.n884 VSS.n883 0.0483676
R9424 VSS.n1695 VSS.n877 0.0483676
R9425 VSS.t457 VSS.n869 0.0483676
R9426 VSS.n868 VSS.n867 0.0483676
R9427 VSS.n1709 VSS.n861 0.0483676
R9428 VSS.t250 VSS.n853 0.0483676
R9429 VSS.n852 VSS.n851 0.0483676
R9430 VSS.n1723 VSS.n845 0.0483676
R9431 VSS.t316 VSS.n834 0.0483676
R9432 VSS.n1733 VSS.n1732 0.0483676
R9433 VSS.n807 VSS.n534 0.0483676
R9434 VSS.n812 VSS.n781 0.0483676
R9435 VSS.n814 VSS.n782 0.0483676
R9436 VSS.n816 VSS.n784 0.0483676
R9437 VSS.n820 VSS.n786 0.0483676
R9438 VSS.n788 VSS.n787 0.0483676
R9439 VSS.n1739 VSS.n824 0.0483676
R9440 VSS.n809 VSS.n536 0.0483676
R9441 VSS.t378 VSS.n780 0.0483676
R9442 VSS.n818 VSS.n785 0.0483676
R9443 VSS.n2073 VSS.t21 0.0483676
R9444 VSS.n250 VSS.n252 0.0483676
R9445 VSS.n280 VSS.n277 0.0483676
R9446 VSS.n319 VSS.n317 0.0483676
R9447 VSS.n358 VSS.n356 0.0483676
R9448 VSS.n442 VSS.n440 0.0483676
R9449 VSS.n481 VSS.n479 0.0483676
R9450 VSS.n520 VSS.n518 0.0483676
R9451 VSS.n1741 VSS.n528 0.0483676
R9452 VSS.t149 VSS.n527 0.0483676
R9453 VSS.n2076 VSS.n2075 0.0483676
R9454 VSS.n262 VSS.n2079 0.0483676
R9455 VSS.n2080 VSS.t485 0.0483676
R9456 VSS.t433 VSS.n2083 0.0483676
R9457 VSS.n2084 VSS.n256 0.0483676
R9458 VSS.n2088 VSS.n2087 0.0483676
R9459 VSS.n247 VSS.n2089 0.0483676
R9460 VSS.n242 VSS.n2091 0.0483676
R9461 VSS.n2092 VSS.t424 0.0483676
R9462 VSS.n2094 VSS.n2093 0.0483676
R9463 VSS.n2096 VSS.n2095 0.0483676
R9464 VSS.n2098 VSS.n2097 0.0483676
R9465 VSS.n2100 VSS.n2099 0.0483676
R9466 VSS.n2102 VSS.n2101 0.0483676
R9467 VSS.n2104 VSS.n2103 0.0483676
R9468 VSS.n2106 VSS.n2105 0.0483676
R9469 VSS.n2108 VSS.n2107 0.0483676
R9470 VSS.n2110 VSS.n2109 0.0483676
R9471 VSS.n2112 VSS.n2111 0.0483676
R9472 VSS.n2116 VSS.n2115 0.0483676
R9473 VSS.n2118 VSS.n2117 0.0483676
R9474 VSS.n224 VSS.n220 0.0483676
R9475 VSS.t65 VSS.n221 0.0483676
R9476 VSS.n2015 VSS.n288 0.0483676
R9477 VSS.t75 VSS.n287 0.0483676
R9478 VSS.t77 VSS.n292 0.0483676
R9479 VSS.n1998 VSS.n293 0.0483676
R9480 VSS.n1997 VSS.n294 0.0483676
R9481 VSS.n300 VSS.n297 0.0483676
R9482 VSS.n1992 VSS.n298 0.0483676
R9483 VSS.n1990 VSS.n308 0.0483676
R9484 VSS.t80 VSS.n307 0.0483676
R9485 VSS.n1968 VSS.n327 0.0483676
R9486 VSS.t90 VSS.n326 0.0483676
R9487 VSS.t92 VSS.n331 0.0483676
R9488 VSS.n1951 VSS.n332 0.0483676
R9489 VSS.n1950 VSS.n333 0.0483676
R9490 VSS.n339 VSS.n336 0.0483676
R9491 VSS.n1945 VSS.n337 0.0483676
R9492 VSS.n1943 VSS.n347 0.0483676
R9493 VSS.t95 VSS.n346 0.0483676
R9494 VSS.n1921 VSS.n366 0.0483676
R9495 VSS.t105 VSS.n365 0.0483676
R9496 VSS.t107 VSS.n370 0.0483676
R9497 VSS.n1904 VSS.n371 0.0483676
R9498 VSS.n1903 VSS.n372 0.0483676
R9499 VSS.n404 VSS.n375 0.0483676
R9500 VSS.n1898 VSS.n376 0.0483676
R9501 VSS.n1896 VSS.n377 0.0483676
R9502 VSS.n412 VSS.n378 0.0483676
R9503 VSS.n410 VSS.n379 0.0483676
R9504 VSS.n1890 VSS.n381 0.0483676
R9505 VSS.n414 VSS.n384 0.0483676
R9506 VSS.n1882 VSS.n385 0.0483676
R9507 VSS.n418 VSS.n388 0.0483676
R9508 VSS.t171 VSS.n389 0.0483676
R9509 VSS.n1873 VSS.n390 0.0483676
R9510 VSS.n424 VSS.n391 0.0483676
R9511 VSS.n422 VSS.n392 0.0483676
R9512 VSS.n1867 VSS.n393 0.0483676
R9513 VSS.n426 VSS.n396 0.0483676
R9514 VSS.n1859 VSS.n397 0.0483676
R9515 VSS.n1857 VSS.n431 0.0483676
R9516 VSS.t110 VSS.n430 0.0483676
R9517 VSS.n1835 VSS.n450 0.0483676
R9518 VSS.t120 VSS.n449 0.0483676
R9519 VSS.t122 VSS.n454 0.0483676
R9520 VSS.n1818 VSS.n455 0.0483676
R9521 VSS.n1817 VSS.n456 0.0483676
R9522 VSS.n462 VSS.n459 0.0483676
R9523 VSS.n1812 VSS.n460 0.0483676
R9524 VSS.n1810 VSS.n470 0.0483676
R9525 VSS.t125 VSS.n469 0.0483676
R9526 VSS.n1788 VSS.n489 0.0483676
R9527 VSS.t135 VSS.n488 0.0483676
R9528 VSS.t137 VSS.n493 0.0483676
R9529 VSS.n1771 VSS.n494 0.0483676
R9530 VSS.n1770 VSS.n495 0.0483676
R9531 VSS.n501 VSS.n498 0.0483676
R9532 VSS.n1765 VSS.n499 0.0483676
R9533 VSS.n1763 VSS.n509 0.0483676
R9534 VSS.t140 VSS.n508 0.0483676
R9535 VSS.n3812 VSS.n3811 0.0483676
R9536 VSS.n3785 VSS.n3784 0.0483676
R9537 VSS.n3752 VSS.n3751 0.0483676
R9538 VSS.n3754 VSS.n3753 0.0483676
R9539 VSS.n3756 VSS.n3755 0.0483676
R9540 VSS.n3758 VSS.n3757 0.0483676
R9541 VSS.t692 VSS.n3759 0.0483676
R9542 VSS.n3760 VSS.n3490 0.0483676
R9543 VSS.n3636 VSS.n3488 0.0483676
R9544 VSS.n3765 VSS.n3764 0.0483676
R9545 VSS.t691 VSS.n3510 0.0483676
R9546 VSS.t696 VSS.n3533 0.0483676
R9547 VSS.n3725 VSS.n3724 0.0483676
R9548 VSS.t700 VSS.n3517 0.0483676
R9549 VSS.n3172 VSS.n3171 0.0483676
R9550 VSS.n3174 VSS.n3173 0.0483676
R9551 VSS.n3176 VSS.n3175 0.0483676
R9552 VSS.n3178 VSS.n3177 0.0483676
R9553 VSS.n3180 VSS.n3179 0.0483676
R9554 VSS.n3182 VSS.n3181 0.0483676
R9555 VSS.n3184 VSS.n3183 0.0483676
R9556 VSS.n3186 VSS.n3185 0.0483676
R9557 VSS.n3187 VSS.t600 0.0483676
R9558 VSS.n3189 VSS.n3188 0.0483676
R9559 VSS.n3191 VSS.n3190 0.0483676
R9560 VSS.n3193 VSS.n3192 0.0483676
R9561 VSS.n3195 VSS.n3194 0.0483676
R9562 VSS.n3197 VSS.n3196 0.0483676
R9563 VSS.n3199 VSS.n3198 0.0483676
R9564 VSS.n3201 VSS.n3200 0.0483676
R9565 VSS.n3203 VSS.n3202 0.0483676
R9566 VSS.t598 VSS.n3204 0.0483676
R9567 VSS.n3206 VSS.n3205 0.0483676
R9568 VSS.n3208 VSS.n3207 0.0483676
R9569 VSS.n3210 VSS.n3209 0.0483676
R9570 VSS.n3212 VSS.n3211 0.0483676
R9571 VSS.n3214 VSS.n3213 0.0483676
R9572 VSS.n3216 VSS.n3215 0.0483676
R9573 VSS.n3218 VSS.n3217 0.0483676
R9574 VSS.n3220 VSS.n3219 0.0483676
R9575 VSS.n2330 VSS.n2329 0.0483676
R9576 VSS.n3235 VSS.n3234 0.0483676
R9577 VSS.n3237 VSS.n3236 0.0483676
R9578 VSS.n3239 VSS.n3238 0.0483676
R9579 VSS.n3241 VSS.n3240 0.0483676
R9580 VSS.n3243 VSS.n3242 0.0483676
R9581 VSS.n3245 VSS.n3244 0.0483676
R9582 VSS.n3247 VSS.n3246 0.0483676
R9583 VSS.n2318 VSS.n2317 0.0483676
R9584 VSS.n3271 VSS.n3270 0.0483676
R9585 VSS.n3273 VSS.n3272 0.0483676
R9586 VSS.n3275 VSS.n3274 0.0483676
R9587 VSS.n3277 VSS.n3276 0.0483676
R9588 VSS.n3279 VSS.n3278 0.0483676
R9589 VSS.n3281 VSS.n3280 0.0483676
R9590 VSS.n3283 VSS.n3282 0.0483676
R9591 VSS.t592 VSS.n3284 0.0483676
R9592 VSS.n3286 VSS.n3285 0.0483676
R9593 VSS.n3288 VSS.n3287 0.0483676
R9594 VSS.n3290 VSS.n3289 0.0483676
R9595 VSS.n3292 VSS.n3291 0.0483676
R9596 VSS.n3294 VSS.n3293 0.0483676
R9597 VSS.n3296 VSS.n3295 0.0483676
R9598 VSS.n3298 VSS.n3297 0.0483676
R9599 VSS.n3300 VSS.n3299 0.0483676
R9600 VSS.n2297 VSS.n2296 0.0483676
R9601 VSS.n3315 VSS.n3314 0.0483676
R9602 VSS.n3317 VSS.n3316 0.0483676
R9603 VSS.n3319 VSS.n3318 0.0483676
R9604 VSS.n3321 VSS.n3320 0.0483676
R9605 VSS.n3323 VSS.n3322 0.0483676
R9606 VSS.n3325 VSS.n3324 0.0483676
R9607 VSS.n3327 VSS.n3326 0.0483676
R9608 VSS.n2285 VSS.n2284 0.0483676
R9609 VSS.n3344 VSS.n3343 0.0483676
R9610 VSS.n3346 VSS.n3345 0.0483676
R9611 VSS.n3348 VSS.n3347 0.0483676
R9612 VSS.n3350 VSS.n3349 0.0483676
R9613 VSS.n3352 VSS.n3351 0.0483676
R9614 VSS.n3354 VSS.n3353 0.0483676
R9615 VSS.n3356 VSS.n3355 0.0483676
R9616 VSS.n2272 VSS.n2271 0.0483676
R9617 VSS.t587 VSS.n2267 0.0483676
R9618 VSS.n3389 VSS.n210 0.0483676
R9619 VSS.n3391 VSS.n209 0.0483676
R9620 VSS.n3393 VSS.n207 0.0483676
R9621 VSS.n3397 VSS.n203 0.0483676
R9622 VSS.n3399 VSS.n202 0.0483676
R9623 VSS.n3401 VSS.n201 0.0483676
R9624 VSS.n3405 VSS.n197 0.0483676
R9625 VSS.n3407 VSS.n195 0.0483676
R9626 VSS.n3409 VSS.n194 0.0483676
R9627 VSS.n3411 VSS.n192 0.0483676
R9628 VSS.n3419 VSS.n185 0.0483676
R9629 VSS.n3421 VSS.n183 0.0483676
R9630 VSS.n3850 VSS.n122 0.0483676
R9631 VSS.n3851 VSS.n3849 0.0483676
R9632 VSS.n3848 VSS.n3847 0.0483676
R9633 VSS.n3846 VSS.n126 0.0483676
R9634 VSS.n3838 VSS.n3837 0.0483676
R9635 VSS.n3839 VSS.n3836 0.0483676
R9636 VSS.n3835 VSS.n3834 0.0483676
R9637 VSS.n3833 VSS.n130 0.0483676
R9638 VSS.n3826 VSS.n3825 0.0483676
R9639 VSS.n135 VSS.n134 0.0483676
R9640 VSS.n3803 VSS.n3802 0.0483676
R9641 VSS.n3805 VSS.n3804 0.0483676
R9642 VSS.n3807 VSS.n3806 0.0483676
R9643 VSS.n3815 VSS.n3814 0.0483676
R9644 VSS.n3817 VSS.n3816 0.0483676
R9645 VSS.n3819 VSS.n3818 0.0483676
R9646 VSS.n3383 VSS.n215 0.0483676
R9647 VSS.n3385 VSS.n213 0.0483676
R9648 VSS.n3387 VSS.n211 0.0483676
R9649 VSS.n3395 VSS.n205 0.0483676
R9650 VSS.n3403 VSS.n198 0.0483676
R9651 VSS.n3413 VSS.n189 0.0483676
R9652 VSS.n3571 VSS.n173 0.0483676
R9653 VSS.n3859 VSS.n33 0.0483676
R9654 VSS.n3715 VSS.n3713 0.0483676
R9655 VSS.n3717 VSS.n3716 0.0483676
R9656 VSS.n3540 VSS.n3718 0.0483676
R9657 VSS.n3538 VSS.t694 0.0483676
R9658 VSS.n3719 VSS.t695 0.0483676
R9659 VSS.n3721 VSS.n3720 0.0483676
R9660 VSS.n3532 VSS.n3722 0.0483676
R9661 VSS.n3524 VSS.n3727 0.0483676
R9662 VSS.n3522 VSS.t698 0.0483676
R9663 VSS.n3728 VSS.t699 0.0483676
R9664 VSS.n3730 VSS.n3729 0.0483676
R9665 VSS.n3516 VSS.n3731 0.0483676
R9666 VSS.n3732 VSS.n3515 0.0483676
R9667 VSS.n3734 VSS.n3733 0.0483676
R9668 VSS.n3736 VSS.n3735 0.0483676
R9669 VSS.n3511 VSS.n155 0.0483676
R9670 VSS.n3688 VSS.n156 0.0483676
R9671 VSS.n3686 VSS.n157 0.0483676
R9672 VSS.n3544 VSS.n158 0.0483676
R9673 VSS.n3681 VSS.n159 0.0483676
R9674 VSS.n3679 VSS.n160 0.0483676
R9675 VSS.n3677 VSS.n161 0.0483676
R9676 VSS.n3547 VSS.n162 0.0483676
R9677 VSS.n3672 VSS.n163 0.0483676
R9678 VSS.n3550 VSS.n166 0.0483676
R9679 VSS.n3608 VSS.n167 0.0483676
R9680 VSS.n3561 VSS.n170 0.0483676
R9681 VSS.n3600 VSS.n171 0.0483676
R9682 VSS.n3656 VSS.n2152 0.0483676
R9683 VSS.n3658 VSS.n2154 0.0483676
R9684 VSS.n3660 VSS.n2156 0.0483676
R9685 VSS.n3662 VSS.n2158 0.0483676
R9686 VSS.n3665 VSS.n2159 0.0483676
R9687 VSS.n3553 VSS.n2160 0.0483676
R9688 VSS.n3620 VSS.n2161 0.0483676
R9689 VSS.n3618 VSS.n2162 0.0483676
R9690 VSS.n3616 VSS.n2164 0.0483676
R9691 VSS.n3590 VSS.n2169 0.0483676
R9692 VSS.n3593 VSS.n2171 0.0483676
R9693 VSS.n3568 VSS.n2173 0.0483676
R9694 VSS.n3580 VSS.n2175 0.0483676
R9695 VSS.n3579 VSS.n2176 0.0483676
R9696 VSS.n3503 VSS.n3742 0.0483676
R9697 VSS.n3746 VSS.n3745 0.0483676
R9698 VSS.n3768 VSS.n3767 0.0483676
R9699 VSS.n3770 VSS.n3769 0.0483676
R9700 VSS.n3772 VSS.n3771 0.0483676
R9701 VSS.n3774 VSS.n3773 0.0483676
R9702 VSS.n3776 VSS.n3775 0.0483676
R9703 VSS.n3778 VSS.n3777 0.0483676
R9704 VSS.n3780 VSS.n3779 0.0483676
R9705 VSS.t572 VSS.n2615 0.0483676
R9706 VSS.n2614 VSS.n2613 0.0483676
R9707 VSS.n2925 VSS.n2612 0.0483676
R9708 VSS.n2923 VSS.n2611 0.0483676
R9709 VSS.n2701 VSS.n2610 0.0483676
R9710 VSS.n2918 VSS.n2607 0.0483676
R9711 VSS.n2916 VSS.n2606 0.0483676
R9712 VSS.n2914 VSS.n2605 0.0483676
R9713 VSS.n2704 VSS.n2604 0.0483676
R9714 VSS.n2905 VSS.n2602 0.0483676
R9715 VSS.n2707 VSS.n2601 0.0483676
R9716 VSS.n2900 VSS.n2600 0.0483676
R9717 VSS.n2898 VSS.n2599 0.0483676
R9718 VSS.n2896 VSS.n2596 0.0483676
R9719 VSS.n2710 VSS.n2595 0.0483676
R9720 VSS.n2891 VSS.n2594 0.0483676
R9721 VSS.n2889 VSS.n2590 0.0483676
R9722 VSS.n2882 VSS.n2586 0.0483676
R9723 VSS.n2880 VSS.n2585 0.0483676
R9724 VSS.n2878 VSS.n2584 0.0483676
R9725 VSS.n2715 VSS.n2583 0.0483676
R9726 VSS.n2873 VSS.n2579 0.0483676
R9727 VSS.n2871 VSS.n2578 0.0483676
R9728 VSS.n2869 VSS.n2577 0.0483676
R9729 VSS.n2718 VSS.n2576 0.0483676
R9730 VSS.n2864 VSS.n2575 0.0483676
R9731 VSS.t576 VSS.n2574 0.0483676
R9732 VSS.n2861 VSS.n2573 0.0483676
R9733 VSS.n2721 VSS.n2572 0.0483676
R9734 VSS.n2856 VSS.n2571 0.0483676
R9735 VSS.n2854 VSS.n2570 0.0483676
R9736 VSS.n2852 VSS.n2566 0.0483676
R9737 VSS.n2724 VSS.n2563 0.0483676
R9738 VSS.n2847 VSS.n2560 0.0483676
R9739 VSS.n2727 VSS.n2555 0.0483676
R9740 VSS.n2838 VSS.n2552 0.0483676
R9741 VSS.n2836 VSS.n2549 0.0483676
R9742 VSS.n2834 VSS.n2548 0.0483676
R9743 VSS.n2730 VSS.n2545 0.0483676
R9744 VSS.n2829 VSS.n2544 0.0483676
R9745 VSS.n2827 VSS.n2543 0.0483676
R9746 VSS.n2825 VSS.n2542 0.0483676
R9747 VSS.n2819 VSS.n2533 0.0483676
R9748 VSS.n2817 VSS.n2532 0.0483676
R9749 VSS.n2736 VSS.n2528 0.0483676
R9750 VSS.n2812 VSS.n2525 0.0483676
R9751 VSS.n2810 VSS.n2522 0.0483676
R9752 VSS.n2808 VSS.n2521 0.0483676
R9753 VSS.n2739 VSS.n2520 0.0483676
R9754 VSS.n2803 VSS.n2516 0.0483676
R9755 VSS.n2801 VSS.n2513 0.0483676
R9756 VSS.t582 VSS.n2512 0.0483676
R9757 VSS.n2742 VSS.n2511 0.0483676
R9758 VSS.n2795 VSS.n2507 0.0483676
R9759 VSS.n2793 VSS.n2504 0.0483676
R9760 VSS.n2791 VSS.n2501 0.0483676
R9761 VSS.n2745 VSS.n2498 0.0483676
R9762 VSS.n2786 VSS.n2497 0.0483676
R9763 VSS.n2784 VSS.n2496 0.0483676
R9764 VSS.n2782 VSS.n2495 0.0483676
R9765 VSS.n2748 VSS.t584 0.0483676
R9766 VSS.n2777 VSS.n2491 0.0483676
R9767 VSS.n2775 VSS.n2488 0.0483676
R9768 VSS.n2773 VSS.n2485 0.0483676
R9769 VSS.n2751 VSS.n2482 0.0483676
R9770 VSS.n2768 VSS.n2478 0.0483676
R9771 VSS.n2766 VSS.n2475 0.0483676
R9772 VSS.n2764 VSS.n2472 0.0483676
R9773 VSS.n2754 VSS.n2471 0.0483676
R9774 VSS.n3574 VSS.n174 0.0483676
R9775 VSS.n3578 VSS.n176 0.0483676
R9776 VSS.t693 VSS.n3487 0.0483676
R9777 VSS.n2239 VSS.n2238 0.04675
R9778 VSS.t504 VSS.n2220 0.04675
R9779 VSS.n8 VSS.n7 0.0161289
R9780 VSS.n1091 VSS.n1078 0.0405
R9781 VSS.n1070 VSS.t313 0.0405
R9782 VSS.n1064 VSS.n1063 0.0405
R9783 VSS.n1054 VSS.t298 0.0405
R9784 VSS.n1048 VSS.n1047 0.0405
R9785 VSS.n1038 VSS.t217 0.0405
R9786 VSS.n1032 VSS.n1031 0.0405
R9787 VSS.n1022 VSS.t350 0.0405
R9788 VSS.n1016 VSS.n1015 0.0405
R9789 VSS.n1006 VSS.t301 0.0405
R9790 VSS.n1000 VSS.n999 0.0405
R9791 VSS.n990 VSS.t62 0.0405
R9792 VSS.n984 VSS.n983 0.0405
R9793 VSS.n974 VSS.t183 0.0405
R9794 VSS.n968 VSS.n967 0.0405
R9795 VSS.n958 VSS.t240 0.0405
R9796 VSS.n952 VSS.n951 0.0405
R9797 VSS.n942 VSS.t421 0.0405
R9798 VSS.n936 VSS.n935 0.0405
R9799 VSS.n926 VSS.t230 0.0405
R9800 VSS.n920 VSS.n919 0.0405
R9801 VSS.n910 VSS.t687 0.0405
R9802 VSS.n904 VSS.n903 0.0405
R9803 VSS.n894 VSS.t391 0.0405
R9804 VSS.n888 VSS.n887 0.0405
R9805 VSS.n878 VSS.t247 0.0405
R9806 VSS.n872 VSS.n871 0.0405
R9807 VSS.n862 VSS.t31 0.0405
R9808 VSS.n856 VSS.n855 0.0405
R9809 VSS.n846 VSS.t358 0.0405
R9810 VSS.n839 VSS.n838 0.0405
R9811 VSS.t12 VSS.n833 0.0405
R9812 VSS.t150 VSS.n1741 0.038
R9813 VSS.t74 VSS.n2015 0.038
R9814 VSS.t89 VSS.n1968 0.038
R9815 VSS.t104 VSS.n1921 0.038
R9816 VSS.t119 VSS.n1835 0.038
R9817 VSS.t134 VSS.n1788 0.038
R9818 VSS.n2022 VSS.t72 0.0373698
R9819 VSS.n1975 VSS.t87 0.0373698
R9820 VSS.n1928 VSS.t102 0.0373698
R9821 VSS.n1842 VSS.t117 0.0373698
R9822 VSS.n1795 VSS.t132 0.0373698
R9823 VSS.n1748 VSS.t147 0.0373698
R9824 VSS.n1442 VSS.n1438 0.03675
R9825 VSS.n1514 VSS.n1082 0.03675
R9826 VSS.n3427 VSS.n2267 0.03675
R9827 VSS.n2615 VSS.n3117 0.03675
R9828 VSS.n3440 VSS.n3439 0.0341921
R9829 VSS.t72 VSS.n282 0.03175
R9830 VSS.t87 VSS.n321 0.03175
R9831 VSS.t102 VSS.n360 0.03175
R9832 VSS.t117 VSS.n444 0.03175
R9833 VSS.t132 VSS.n483 0.03175
R9834 VSS.t147 VSS.n522 0.03175
R9835 VSS.n2228 VSS.n2212 0.0305
R9836 VSS.n3446 VSS.n2 0.0305
R9837 VSS.n3141 VSS.n2356 0.0297015
R9838 VSS.n1433 VSS.t567 0.02925
R9839 VSS.n1424 VSS.t563 0.02925
R9840 VSS.n1415 VSS.t549 0.02925
R9841 VSS.n1406 VSS.t547 0.02925
R9842 VSS.n1397 VSS.t608 0.02925
R9843 VSS.n1388 VSS.t604 0.02925
R9844 VSS.n1379 VSS.t557 0.02925
R9845 VSS.n1370 VSS.t551 0.02925
R9846 VSS.n1361 VSS.t612 0.02925
R9847 VSS.n1352 VSS.t543 0.02925
R9848 VSS.n1343 VSS.t610 0.02925
R9849 VSS.n1334 VSS.t533 0.02925
R9850 VSS.n1325 VSS.t553 0.02925
R9851 VSS.n1316 VSS.t614 0.02925
R9852 VSS.n1307 VSS.t606 0.02925
R9853 VSS.n1298 VSS.t535 0.02925
R9854 VSS.n1289 VSS.t539 0.02925
R9855 VSS.n1280 VSS.t616 0.02925
R9856 VSS.n1271 VSS.t559 0.02925
R9857 VSS.n1262 VSS.t618 0.02925
R9858 VSS.n1253 VSS.t624 0.02925
R9859 VSS.n1244 VSS.t545 0.02925
R9860 VSS.n1235 VSS.t622 0.02925
R9861 VSS.n1226 VSS.t620 0.02925
R9862 VSS.n1217 VSS.t537 0.02925
R9863 VSS.n1208 VSS.t626 0.02925
R9864 VSS.n1199 VSS.t565 0.02925
R9865 VSS.n1190 VSS.t541 0.02925
R9866 VSS.n1181 VSS.t561 0.02925
R9867 VSS.n1172 VSS.t628 0.02925
R9868 VSS.n1163 VSS.t555 0.02925
R9869 VSS.n1154 VSS.t630 0.02925
R9870 VSS.n3856 VSS.n122 0.028
R9871 VSS.n3859 VSS.n3858 0.028
R9872 VSS.n3742 VSS.n3741 0.028
R9873 VSS.n1440 VSS.n1439 0.02675
R9874 VSS.n3561 VSS.n3560 0.02675
R9875 VSS.n3559 VSS.n3558 0.02675
R9876 VSS.t77 VSS.n291 0.0253649
R9877 VSS.t92 VSS.n330 0.0253649
R9878 VSS.t107 VSS.n369 0.0253649
R9879 VSS.t122 VSS.n453 0.0253649
R9880 VSS.t137 VSS.n492 0.0253649
R9881 VSS.t152 VSS.n529 0.0253649
R9882 VSS.n0 VSS.n2210 0.0253401
R9883 VSS.n3445 VSS.n2213 0.0253401
R9884 VSS.n1740 VSS.n535 0.023135
R9885 VSS.n2141 VSS.n218 0.023135
R9886 VSS.n2133 VSS.n218 0.023135
R9887 VSS.n2129 VSS.n218 0.023135
R9888 VSS.n2123 VSS.n218 0.023135
R9889 VSS.n2026 VSS.n2025 0.023135
R9890 VSS.n2014 VSS.n2013 0.023135
R9891 VSS.n2014 VSS.n2012 0.023135
R9892 VSS.n1976 VSS.n311 0.023135
R9893 VSS.n1967 VSS.n1966 0.023135
R9894 VSS.n1967 VSS.n1965 0.023135
R9895 VSS.n1929 VSS.n350 0.023135
R9896 VSS.n1920 VSS.n1919 0.023135
R9897 VSS.n1920 VSS.n1918 0.023135
R9898 VSS.n1920 VSS.n403 0.023135
R9899 VSS.n1920 VSS.n400 0.023135
R9900 VSS.n1843 VSS.n434 0.023135
R9901 VSS.n1834 VSS.n1833 0.023135
R9902 VSS.n1834 VSS.n1832 0.023135
R9903 VSS.n1796 VSS.n473 0.023135
R9904 VSS.n1787 VSS.n1786 0.023135
R9905 VSS.n1787 VSS.n1785 0.023135
R9906 VSS.n1749 VSS.n512 0.023135
R9907 VSS.n1740 VSS.n531 0.023135
R9908 VSS.n826 VSS.n827 0.02175
R9909 VSS.n3579 VSS.n3567 0.02175
R9910 VSS.n3572 VSS.n3578 0.02175
R9911 VSS.n3033 VSS.t426 0.0184075
R9912 VSS.n3017 VSS.t428 0.0184075
R9913 VSS.t55 VSS.n2186 0.0174009
R9914 VSS.t500 VSS.n2212 0.01675
R9915 VSS.n3446 VSS.t497 0.01675
R9916 VSS.n2145 VSS.n217 0.0165542
R9917 VSS.n540 VSS.n217 0.0165542
R9918 VSS.n3039 VSS.t292 0.0151406
R9919 VSS.n3027 VSS.n2650 0.0151406
R9920 VSS.n3026 VSS.n2650 0.0151406
R9921 VSS.n3012 VSS.n2618 0.0151406
R9922 VSS.t55 VSS.n2189 0.0150892
R9923 VSS.n3667 VSS.n165 0.01425
R9924 VSS.n802 VSS.n529 0.0141149
R9925 VSS.n1999 VSS.n291 0.0141149
R9926 VSS.n1952 VSS.n330 0.0141149
R9927 VSS.n1905 VSS.n369 0.0141149
R9928 VSS.n1819 VSS.n453 0.0141149
R9929 VSS.n1772 VSS.n492 0.0141149
R9930 VSS.n272 VSS 0.0134067
R9931 VSS.n2224 VSS.n2223 0.013
R9932 VSS.n3614 VSS.n3613 0.01175
R9933 VSS.n3616 VSS.n3615 0.01175
R9934 VSS.n35 VSS.n12 0.00993548
R9935 VSS.n558 VSS.n217 0.00938635
R9936 VSS.n614 VSS.n217 0.00938635
R9937 VSS.n628 VSS.n217 0.00938635
R9938 VSS.n698 VSS.n217 0.00938635
R9939 VSS.n776 VSS.n217 0.00938222
R9940 VSS.n768 VSS.n217 0.00937856
R9941 VSS.n754 VSS.n217 0.00937856
R9942 VSS.n740 VSS.n217 0.00937856
R9943 VSS.n726 VSS.n217 0.00937856
R9944 VSS.n712 VSS.n217 0.00937856
R9945 VSS.n642 VSS.n217 0.00937856
R9946 VSS.n586 VSS.n217 0.00937856
R9947 VSS.n670 VSS.n217 0.00937856
R9948 VSS.n656 VSS.n217 0.00937856
R9949 VSS.n572 VSS.n217 0.00937856
R9950 VSS.n552 VSS.n217 0.00937856
R9951 VSS.n600 VSS.n217 0.00937856
R9952 VSS.n684 VSS.n217 0.00937856
R9953 VSS.n89 VSS.n3138 0.00876885
R9954 VSS.n25 VSS.n3525 0.0071972
R9955 VSS.n1450 VSS.n1449 0.00675
R9956 VSS.n1511 VSS.t165 0.00675
R9957 VSS.n49 VSS.n3497 0.00649396
R9958 VSS.n60 VSS.n62 0.00466584
R9959 VSS.n1452 VSS.n1087 0.00412443
R9960 VSS.n104 VSS.n105 0.00399966
R9961 VSS.n37 VSS.n38 0.00399966
R9962 VSS.n3762 VSS.n56 0.00349933
R9963 VSS.n8 VSS.n1 0.00296307
R9964 VSS.n112 VSS.n111 0.00266647
R9965 VSS.n108 VSS.n107 0.00249999
R9966 VSS.n43 VSS.n42 0.00224999
R9967 VSS.t55 VSS.n2192 0.002125
R9968 VSS.n3043 VSS.t292 0.00198843
R9969 VSS.n2148 VSS.n12 0.00196948
R9970 VSS.n3442 VSS.n2192 0.00187493
R9971 VSS.n2142 VSS.n218 0.00181696
R9972 VSS.n2137 VSS.n218 0.00181696
R9973 VSS.n2120 VSS.n219 0.00181696
R9974 VSS.n2023 VSS.n279 0.00181696
R9975 VSS.n2023 VSS.n281 0.00181696
R9976 VSS.n1989 VSS.n309 0.00181696
R9977 VSS.n1978 VSS.n318 0.00181696
R9978 VSS.n1978 VSS.n320 0.00181696
R9979 VSS.n1942 VSS.n348 0.00181696
R9980 VSS.n1931 VSS.n357 0.00181696
R9981 VSS.n1931 VSS.n359 0.00181696
R9982 VSS.n1856 VSS.n432 0.00181696
R9983 VSS.n1845 VSS.n441 0.00181696
R9984 VSS.n1845 VSS.n443 0.00181696
R9985 VSS.n1809 VSS.n471 0.00181696
R9986 VSS.n1798 VSS.n480 0.00181696
R9987 VSS.n1798 VSS.n482 0.00181696
R9988 VSS.n1762 VSS.n510 0.00181696
R9989 VSS.n1751 VSS.n519 0.00181696
R9990 VSS.n1751 VSS.n521 0.00181696
R9991 VSS.n3783 VSS.n69 0.00175
R9992 VSS.n3007 VSS.n2266 0.00166667
R9993 VSS.n23 VSS.n22 0.00169993
R9994 VSS.n31 VSS.n83 0.00166667
R9995 VSS.n37 VSS.n36 0.00138884
R9996 VSS.n41 VSS.n40 0.00169993
R9997 VSS.n141 VSS.n137 0.00166667
R9998 VSS.n3783 VSS.n136 0.00166667
R9999 VSS.n45 VSS.n44 0.00169993
R10000 VSS.n47 VSS.n46 0.00169993
R10001 VSS.n61 VSS.n60 0.00131814
R10002 VSS.n99 VSS.n98 0.00169993
R10003 VSS.n102 VSS.n100 0.00169993
R10004 VSS.n104 VSS.n103 0.00138884
R10005 VSS.n109 VSS.n108 0.00149995
R10006 VSS.n114 VSS.n113 0.00169993
R10007 VSS.n8 VSS.n5 0.00161188
R10008 VSS.n119 VSS.n106 0.0015
R10009 VSS.n115 VSS.n117 0.0015
R10010 VSS.n113 VSS.n112 0.0015
R10011 VSS.n107 VSS.n110 0.0015
R10012 VSS.n102 VSS.n101 0.0015
R10013 VSS.n3122 VSS.n99 0.0015
R10014 VSS.n3138 VSS.n85 0.0015
R10015 VSS.n68 VSS.n67 0.0015
R10016 VSS.n65 VSS.n68 0.0015
R10017 VSS.n63 VSS.n65 0.0015
R10018 VSS.n57 VSS.n59 0.0015
R10019 VSS.n3497 VSS.n47 0.0015
R10020 VSS.n3499 VSS.n45 0.0015
R10021 VSS.n143 VSS.n137 0.00133332
R10022 VSS.n42 VSS.n136 0.00133332
R10023 VSS.n67 VSS.n83 0.00133332
R10024 VSS.n3007 VSS.n85 0.00133332
R10025 VSS.n67 VSS.n69 0.00124998
R10026 VSS.n2125 VSS.n218 0.00104753
R10027 VSS.n8 VSS.n6 0.00102591
R10028 VSS.n8 VSS.n4 0.00102569
R10029 VSS.n2122 VSS.n218 0.00101876
R10030 VSS.n2014 VSS.n290 0.00101876
R10031 VSS.n2014 VSS.n296 0.00101876
R10032 VSS.n1967 VSS.n329 0.00101876
R10033 VSS.n1967 VSS.n335 0.00101876
R10034 VSS.n1920 VSS.n368 0.00101876
R10035 VSS.n1920 VSS.n395 0.00101876
R10036 VSS.n1834 VSS.n452 0.00101876
R10037 VSS.n1834 VSS.n458 0.00101876
R10038 VSS.n1787 VSS.n491 0.00101876
R10039 VSS.n1787 VSS.n497 0.00101876
R10040 VSS.n1920 VSS.n383 0.00101872
R10041 VSS.n1740 VSS.n779 0.00101872
R10042 VSS.n2124 VSS.n218 0.00101872
R10043 VSS.n1920 VSS.n374 0.00101872
R10044 VSS.n1920 VSS.n401 0.00101872
R10045 VSS.n1740 VSS.n530 0.00100071
R10046 VSS.n2120 VSS.n2119 0.001
R10047 VSS.n2026 VSS.n223 0.001
R10048 VSS.n2023 VSS.n278 0.001
R10049 VSS.n2014 VSS.n283 0.001
R10050 VSS.n1989 VSS.n299 0.001
R10051 VSS.n1987 VSS.n311 0.001
R10052 VSS.n1979 VSS.n1978 0.001
R10053 VSS.n1967 VSS.n322 0.001
R10054 VSS.n1942 VSS.n338 0.001
R10055 VSS.n1940 VSS.n350 0.001
R10056 VSS.n1932 VSS.n1931 0.001
R10057 VSS.n1920 VSS.n361 0.001
R10058 VSS.n1856 VSS.n398 0.001
R10059 VSS.n1854 VSS.n434 0.001
R10060 VSS.n1846 VSS.n1845 0.001
R10061 VSS.n1834 VSS.n445 0.001
R10062 VSS.n1809 VSS.n461 0.001
R10063 VSS.n1807 VSS.n473 0.001
R10064 VSS.n1799 VSS.n1798 0.001
R10065 VSS.n1787 VSS.n484 0.001
R10066 VSS.n1762 VSS.n500 0.001
R10067 VSS.n1760 VSS.n512 0.001
R10068 VSS.n1752 VSS.n1751 0.001
R10069 VSS.n1740 VSS.n523 0.001
R10070 VSS.n2119 VSS.n218 0.001
R10071 VSS.n2120 VSS.n223 0.001
R10072 VSS.n2026 VSS.n278 0.001
R10073 VSS.n2023 VSS.n283 0.001
R10074 VSS.n2014 VSS.n299 0.001
R10075 VSS.n1989 VSS.n1987 0.001
R10076 VSS.n1979 VSS.n311 0.001
R10077 VSS.n1978 VSS.n322 0.001
R10078 VSS.n1967 VSS.n338 0.001
R10079 VSS.n1942 VSS.n1940 0.001
R10080 VSS.n1932 VSS.n350 0.001
R10081 VSS.n1931 VSS.n361 0.001
R10082 VSS.n1920 VSS.n398 0.001
R10083 VSS.n1856 VSS.n1854 0.001
R10084 VSS.n1846 VSS.n434 0.001
R10085 VSS.n1845 VSS.n445 0.001
R10086 VSS.n1834 VSS.n461 0.001
R10087 VSS.n1809 VSS.n1807 0.001
R10088 VSS.n1799 VSS.n473 0.001
R10089 VSS.n1798 VSS.n484 0.001
R10090 VSS.n1787 VSS.n500 0.001
R10091 VSS.n1762 VSS.n1760 0.001
R10092 VSS.n1752 VSS.n512 0.001
R10093 VSS.n1751 VSS.n523 0.001
R10094 VSS.n147 VSS.n39 0.001
R10095 VSS.n141 VSS.n43 0.00174999
R10096 VSS.n143 VSS.n41 0.0015
R10097 VSS.n32 VSS.n31 0.0015
R10098 VSS.n3525 VSS.n23 0.0015
R10099 VSS.n9 VSS.n3444 8.50175
R10100 VSS.n3762 VSS.n54 0.001
R10101 VSS.n58 VSS.n57 0.00124999
R10102 VSS.n64 VSS.n63 0.00124999
R10103 VSS.n3530 VSS.n21 0.001
R10104 VSS.n32 VSS.n30 0.00124999
R10105 VSS.n2996 VSS.t426 0.001
R10106 VSS.n2998 VSS.t426 0.001
R10107 VSS.n2997 VSS.n2677 0.001
R10108 VSS.n2999 VSS.n2650 0.001
R10109 VSS.n3001 VSS.t428 0.001
R10110 VSS.n3003 VSS.t428 0.001
R10111 VSS.n3002 VSS.n2634 0.001
R10112 VSS.n3004 VSS.n2618 0.001
R10113 VSS.n116 VSS.n115 0.00124999
R10114 VSS.n119 VSS.n117 0.001
R10115 VSS.n3123 VSS.n97 0.001
R10116 VSS.n2996 VSS.t292 0.001
R10117 VSS.n2998 VSS.n2677 0.001
R10118 VSS.n2997 VSS.n2674 0.001
R10119 VSS.n2999 VSS.n2674 0.001
R10120 VSS.n3001 VSS.n2650 0.001
R10121 VSS.n3003 VSS.n2634 0.001
R10122 VSS.n3002 VSS.n2631 0.001
R10123 VSS.n3004 VSS.n2631 0.001
R10124 VSS.n9 VSS.n8 0.00125
R10125 VSS.n9 VSS.n2247 8.47794
R10126 a_3747_311.n0 a_3747_311.t2 52.0388
R10127 a_3747_311.t1 a_3747_311.n0 35.4491
R10128 a_3747_311.n0 a_3747_311.t3 33.5891
R10129 a_3747_311.t0 a_3747_311.t1 5.61942
R10130 a_3171_311.n0 a_3171_311.t2 51.8377
R10131 a_3171_311.n0 a_3171_311.t3 33.3881
R10132 a_3171_311.t1 a_3171_311.n0 31.8923
R10133 a_3171_311.t0 a_3171_311.t1 5.61777
R10134 a_2595_311.n0 a_2595_311.t2 51.6367
R10135 a_2595_311.n0 a_2595_311.t3 33.187
R10136 a_2595_311.t1 a_2595_311.n0 27.993
R10137 a_2595_311.t0 a_2595_311.t1 5.73018
R10138 a_2019_311.t3 a_2019_311.t2 51.6139
R10139 a_2019_311.t1 a_2019_311.t3 24.5351
R10140 a_2019_311.t0 a_2019_311.t1 5.62052
R10141 a_3747_1047.n0 a_3747_1047.t2 38.0081
R10142 a_3747_1047.n0 a_3747_1047.t3 33.3957
R10143 a_3747_1047.n1 a_3747_1047.t4 33.3957
R10144 a_3747_1047.n2 a_3747_1047.t5 33.3957
R10145 a_3747_1047.n3 a_3747_1047.t6 33.3957
R10146 a_3747_1047.n4 a_3747_1047.t7 33.3957
R10147 a_3747_1047.n5 a_3747_1047.t8 33.3957
R10148 a_3747_1047.n6 a_3747_1047.t9 33.3957
R10149 a_3747_1047.t1 a_3747_1047.n6 23.2419
R10150 a_3747_1047.t0 a_3747_1047.t1 5.61942
R10151 a_3747_1047.n6 a_3747_1047.n5 4.61291
R10152 a_3747_1047.n5 a_3747_1047.n4 4.61291
R10153 a_3747_1047.n4 a_3747_1047.n3 4.61291
R10154 a_3747_1047.n3 a_3747_1047.n2 4.61291
R10155 a_3747_1047.n2 a_3747_1047.n1 4.61291
R10156 a_3747_1047.n1 a_3747_1047.n0 4.61291
R10157 a_3171_1047.n0 a_3171_1047.t2 37.8054
R10158 a_3171_1047.n0 a_3171_1047.t3 33.193
R10159 a_3171_1047.n1 a_3171_1047.t4 33.193
R10160 a_3171_1047.n2 a_3171_1047.t5 33.193
R10161 a_3171_1047.n3 a_3171_1047.t6 33.193
R10162 a_3171_1047.n4 a_3171_1047.t7 33.193
R10163 a_3171_1047.n5 a_3171_1047.t8 33.193
R10164 a_3171_1047.n6 a_3171_1047.t9 33.193
R10165 a_3171_1047.t1 a_3171_1047.n6 23.0313
R10166 a_3171_1047.t0 a_3171_1047.t1 5.61777
R10167 a_3171_1047.n6 a_3171_1047.n5 4.61291
R10168 a_3171_1047.n5 a_3171_1047.n4 4.61291
R10169 a_3171_1047.n4 a_3171_1047.n3 4.61291
R10170 a_3171_1047.n3 a_3171_1047.n2 4.61291
R10171 a_3171_1047.n2 a_3171_1047.n1 4.61291
R10172 a_3171_1047.n1 a_3171_1047.n0 4.61291
R10173 a_2595_1047.n0 a_2595_1047.t2 37.7691
R10174 a_2595_1047.n0 a_2595_1047.t3 33.1567
R10175 a_2595_1047.n1 a_2595_1047.t4 33.1567
R10176 a_2595_1047.n2 a_2595_1047.t5 33.1567
R10177 a_2595_1047.n3 a_2595_1047.t6 33.1567
R10178 a_2595_1047.n4 a_2595_1047.t7 33.1567
R10179 a_2595_1047.n5 a_2595_1047.t8 33.1567
R10180 a_2595_1047.n6 a_2595_1047.t9 33.1567
R10181 a_2595_1047.t1 a_2595_1047.n6 22.7941
R10182 a_2595_1047.t0 a_2595_1047.t1 5.65522
R10183 a_2595_1047.n6 a_2595_1047.n5 4.61291
R10184 a_2595_1047.n5 a_2595_1047.n4 4.61291
R10185 a_2595_1047.n4 a_2595_1047.n3 4.61291
R10186 a_2595_1047.n3 a_2595_1047.n2 4.61291
R10187 a_2595_1047.n2 a_2595_1047.n1 4.61291
R10188 a_2595_1047.n1 a_2595_1047.n0 4.61291
R10189 a_2019_1047.n0 a_2019_1047.t2 37.9701
R10190 a_2019_1047.n0 a_2019_1047.t3 33.3577
R10191 a_2019_1047.n1 a_2019_1047.t4 33.3577
R10192 a_2019_1047.n2 a_2019_1047.t5 33.3577
R10193 a_2019_1047.n3 a_2019_1047.t6 33.3577
R10194 a_2019_1047.n4 a_2019_1047.t7 33.3577
R10195 a_2019_1047.t1 a_2019_1047.t9 22.5945
R10196 a_2019_1047.t0 a_2019_1047.t1 5.62052
R10197 a_2019_1047.t9 a_2019_1047.t8 4.61291
R10198 a_2019_1047.t8 a_2019_1047.n4 4.61291
R10199 a_2019_1047.n4 a_2019_1047.n3 4.61291
R10200 a_2019_1047.n3 a_2019_1047.n2 4.61291
R10201 a_2019_1047.n2 a_2019_1047.n1 4.61291
R10202 a_2019_1047.n1 a_2019_1047.n0 4.61291
C1325 MUX_OUT VSS 7.79401f
C1326 MUX_SEL4 VSS 1.57276f
C1327 MUX_SEL3 VSS 1.0035f
C1328 MUX_SEL2 VSS 4.18782f
C1329 MUX_SEL1 VSS 1.04567f
C1330 MUX_SEL0 VSS 4.19577f
C1331 DELAY_VBIASP VSS 12.35601f
C1332 DELAY_OUT_LAST VSS 2.85823f
C1333 DELAY_VBIASN VSS 0.14048p
C1334 REF_CLK VSS 5.96886f
C1335 DLL_RESETN VSS 11.4579f
C1336 VDD VSS 94.96463f
C1337 a_26985_519# VSS 0.19019f ; **FLOATING
C1338 a_23945_519# VSS 0.18605f ; **FLOATING
C1339 a_20905_519# VSS 0.18456f ; **FLOATING
C1340 a_17865_519# VSS 0.17973f ; **FLOATING
C1341 a_16851_309# VSS 0.39012f ; **FLOATING
C1342 a_16108_289# VSS 5.09238f ; **FLOATING
C1343 a_15964_289# VSS 0.18287f ; **FLOATING
C1344 a_15765_463# VSS 0.3701f ; **FLOATING
C1345 a_14825_519# VSS 0.1819f ; **FLOATING
C1346 a_11785_519# VSS 0.1819f ; **FLOATING
C1347 a_8745_519# VSS 0.1819f ; **FLOATING
C1348 a_5731_289# VSS 4.48871f ; **FLOATING
C1349 a_5705_519# VSS 0.17899f ; **FLOATING
C1350 a_3449_331# VSS 0.18976f ; **FLOATING
C1351 a_2873_331# VSS 0.18555f ; **FLOATING
C1352 a_2297_331# VSS 0.18559f ; **FLOATING
C1353 a_1721_331# VSS 0.1759f ; **FLOATING
C1354 a_1544_289# VSS 0.31269f ; **FLOATING
C1355 a_1256_289# VSS 0.9846f ; **FLOATING
C1356 a_27991_1008# VSS 0.19969f ; **FLOATING
C1357 a_27915_1044# VSS 0.11737f ; **FLOATING
C1358 a_27124_1008# VSS 0.18296f ; **FLOATING
C1359 a_27048_1044# VSS 0.13154f ; **FLOATING
C1360 a_26471_1008# VSS 0.18345f ; **FLOATING
C1361 a_26395_1044# VSS 0.1168f ; **FLOATING
C1362 a_25604_1008# VSS 0.18358f ; **FLOATING
C1363 a_25630_1044# VSS 0.3469f ; **FLOATING
C1364 a_25528_1044# VSS 0.13242f ; **FLOATING
C1365 a_24951_1008# VSS 0.18359f ; **FLOATING
C1366 a_24875_1044# VSS 0.11461f ; **FLOATING
C1367 a_24084_1008# VSS 0.17994f ; **FLOATING
C1368 a_24008_1044# VSS 0.12896f ; **FLOATING
C1369 a_23431_1008# VSS 0.18198f ; **FLOATING
C1370 a_23355_1044# VSS 0.11518f ; **FLOATING
C1371 a_22564_1008# VSS 0.18358f ; **FLOATING
C1372 a_22590_1044# VSS 0.34962f ; **FLOATING
C1373 a_22488_1044# VSS 0.13242f ; **FLOATING
C1374 a_21911_1008# VSS 0.18359f ; **FLOATING
C1375 a_21835_1044# VSS 0.11461f ; **FLOATING
C1376 a_21044_1008# VSS 0.17994f ; **FLOATING
C1377 a_20968_1044# VSS 0.12896f ; **FLOATING
C1378 a_20391_1008# VSS 0.18198f ; **FLOATING
C1379 a_20315_1044# VSS 0.11518f ; **FLOATING
C1380 a_19524_1008# VSS 0.18358f ; **FLOATING
C1381 a_19550_1044# VSS 0.35115f ; **FLOATING
C1382 a_19448_1044# VSS 0.13242f ; **FLOATING
C1383 a_18871_1008# VSS 0.18359f ; **FLOATING
C1384 a_18795_1044# VSS 0.11461f ; **FLOATING
C1385 a_18004_1008# VSS 0.17994f ; **FLOATING
C1386 a_17928_1044# VSS 0.12896f ; **FLOATING
C1387 a_17351_1008# VSS 0.18046f ; **FLOATING
C1388 a_17275_1044# VSS 0.11372f ; **FLOATING
C1389 a_16484_1008# VSS 0.18294f ; **FLOATING
C1390 a_16510_1044# VSS 0.32857f ; **FLOATING
C1391 a_16408_1044# VSS 0.13098f ; **FLOATING
C1392 a_15831_1008# VSS 0.1787f ; **FLOATING
C1393 a_15755_1044# VSS 0.11372f ; **FLOATING
C1394 a_14964_1008# VSS 0.17994f ; **FLOATING
C1395 a_14888_1044# VSS 0.12896f ; **FLOATING
C1396 a_14311_1008# VSS 0.18198f ; **FLOATING
C1397 a_14235_1044# VSS 0.11518f ; **FLOATING
C1398 a_13444_1008# VSS 0.18358f ; **FLOATING
C1399 a_13470_1044# VSS 0.33941f ; **FLOATING
C1400 a_13368_1044# VSS 0.13242f ; **FLOATING
C1401 a_12791_1008# VSS 0.18359f ; **FLOATING
C1402 a_12715_1044# VSS 0.11461f ; **FLOATING
C1403 a_11924_1008# VSS 0.17994f ; **FLOATING
C1404 a_11848_1044# VSS 0.12896f ; **FLOATING
C1405 a_11271_1008# VSS 0.18198f ; **FLOATING
C1406 a_11195_1044# VSS 0.11518f ; **FLOATING
C1407 a_10404_1008# VSS 0.18358f ; **FLOATING
C1408 a_10430_1044# VSS 0.34574f ; **FLOATING
C1409 a_10328_1044# VSS 0.13242f ; **FLOATING
C1410 a_9751_1008# VSS 0.18359f ; **FLOATING
C1411 a_9675_1044# VSS 0.11461f ; **FLOATING
C1412 a_8884_1008# VSS 0.17994f ; **FLOATING
C1413 a_8808_1044# VSS 0.12896f ; **FLOATING
C1414 a_8231_1008# VSS 0.18198f ; **FLOATING
C1415 a_8155_1044# VSS 0.11518f ; **FLOATING
C1416 a_7364_1008# VSS 0.18358f ; **FLOATING
C1417 a_7390_1044# VSS 0.34543f ; **FLOATING
C1418 a_7288_1044# VSS 0.13242f ; **FLOATING
C1419 a_6711_1008# VSS 0.18359f ; **FLOATING
C1420 a_6635_1044# VSS 0.11461f ; **FLOATING
C1421 a_5844_1008# VSS 0.17994f ; **FLOATING
C1422 a_5768_1044# VSS 0.12896f ; **FLOATING
C1423 a_5191_1008# VSS 0.18046f ; **FLOATING
C1424 a_5115_1044# VSS 0.11372f ; **FLOATING
C1425 a_4324_1008# VSS 0.18294f ; **FLOATING
C1426 a_4350_1044# VSS 0.31993f ; **FLOATING
C1427 a_4248_1044# VSS 0.13252f ; **FLOATING
C1428 a_27705_1044# VSS 0.27018f ; **FLOATING
C1429 a_26185_1044# VSS 0.24814f ; **FLOATING
C1430 a_24665_1044# VSS 0.26584f ; **FLOATING
C1431 a_23145_1044# VSS 0.24624f ; **FLOATING
C1432 a_21625_1044# VSS 0.26584f ; **FLOATING
C1433 a_20105_1044# VSS 0.24624f ; **FLOATING
C1434 a_18585_1044# VSS 0.26584f ; **FLOATING
C1435 a_17065_1044# VSS 0.24534f ; **FLOATING
C1436 a_15545_1044# VSS 0.26448f ; **FLOATING
C1437 a_14025_1044# VSS 0.24624f ; **FLOATING
C1438 a_12505_1044# VSS 0.26584f ; **FLOATING
C1439 a_10985_1044# VSS 0.24624f ; **FLOATING
C1440 a_9465_1044# VSS 0.26584f ; **FLOATING
C1441 a_7945_1044# VSS 0.24624f ; **FLOATING
C1442 a_6425_1044# VSS 0.26584f ; **FLOATING
C1443 a_4905_1044# VSS 0.24698f ; **FLOATING
C1444 a_4157_1313# VSS 0.34738f ; **FLOATING
C1445 a_3449_1395# VSS 0.19228f ; **FLOATING
C1446 a_2873_1395# VSS 0.18619f ; **FLOATING
C1447 a_2297_1395# VSS 0.18587f ; **FLOATING
C1448 a_1721_1395# VSS 0.17768f ; **FLOATING
C1449 a_1544_1044# VSS 0.31333f ; **FLOATING
C1450 a_1256_1044# VSS 0.98205f ; **FLOATING
C1451 a_27671_1842# VSS 0.01732f ; **FLOATING
C1452 a_26911_1842# VSS 0.01732f ; **FLOATING
C1453 a_26151_1842# VSS 0.01732f ; **FLOATING
C1454 a_25391_1842# VSS 0.01732f ; **FLOATING
C1455 a_24631_1842# VSS 0.01732f ; **FLOATING
C1456 a_23871_1842# VSS 0.01732f ; **FLOATING
C1457 a_23111_1842# VSS 0.01732f ; **FLOATING
C1458 a_22351_1842# VSS 0.01732f ; **FLOATING
C1459 a_21591_1842# VSS 0.01732f ; **FLOATING
C1460 a_20831_1842# VSS 0.01732f ; **FLOATING
C1461 a_20071_1842# VSS 0.01732f ; **FLOATING
C1462 a_19311_1842# VSS 0.01732f ; **FLOATING
C1463 a_18551_1842# VSS 0.01732f ; **FLOATING
C1464 a_17791_1842# VSS 0.01732f ; **FLOATING
C1465 a_17031_1842# VSS 0.01732f ; **FLOATING
C1466 a_16271_1842# VSS 0.01732f ; **FLOATING
C1467 a_15511_1842# VSS 0.01732f ; **FLOATING
C1468 a_14751_1842# VSS 0.01732f ; **FLOATING
C1469 a_13991_1842# VSS 0.01732f ; **FLOATING
C1470 a_13231_1842# VSS 0.01732f ; **FLOATING
C1471 a_12471_1842# VSS 0.01732f ; **FLOATING
C1472 a_11711_1842# VSS 0.01732f ; **FLOATING
C1473 a_10951_1842# VSS 0.01732f ; **FLOATING
C1474 a_10191_1842# VSS 0.01732f ; **FLOATING
C1475 a_9431_1842# VSS 0.01732f ; **FLOATING
C1476 a_8671_1842# VSS 0.01732f ; **FLOATING
C1477 a_7911_1842# VSS 0.01732f ; **FLOATING
C1478 a_7151_1842# VSS 0.01732f ; **FLOATING
C1479 a_6391_1842# VSS 0.01732f ; **FLOATING
C1480 a_5631_1842# VSS 0.01732f ; **FLOATING
C1481 a_4871_1842# VSS 0.01732f ; **FLOATING
C1482 a_4111_1842# VSS 0.01786f ; **FLOATING
C1483 a_27563_1842# VSS 0.84296f ; **FLOATING
C1484 a_27997_1842# VSS 0.67442f ; **FLOATING
C1485 a_27433_1842# VSS 0.65329f ; **FLOATING
C1486 a_26803_1842# VSS 0.84079f ; **FLOATING
C1487 a_27237_1842# VSS 1.28291f ; **FLOATING
C1488 a_26673_1842# VSS 0.65417f ; **FLOATING
C1489 a_26043_1842# VSS 0.84057f ; **FLOATING
C1490 a_26477_1842# VSS 1.37853f ; **FLOATING
C1491 a_25913_1842# VSS 0.65331f ; **FLOATING
C1492 a_25283_1842# VSS 0.84081f ; **FLOATING
C1493 a_25717_1842# VSS 1.03862f ; **FLOATING
C1494 a_25153_1842# VSS 0.6542f ; **FLOATING
C1495 a_24523_1842# VSS 0.84055f ; **FLOATING
C1496 a_24957_1842# VSS 1.3729f ; **FLOATING
C1497 a_24393_1842# VSS 0.65329f ; **FLOATING
C1498 a_23763_1842# VSS 0.84079f ; **FLOATING
C1499 a_24197_1842# VSS 1.27457f ; **FLOATING
C1500 a_23633_1842# VSS 0.65447f ; **FLOATING
C1501 a_23003_1842# VSS 0.84057f ; **FLOATING
C1502 a_23437_1842# VSS 1.37272f ; **FLOATING
C1503 a_22873_1842# VSS 0.65331f ; **FLOATING
C1504 a_22243_1842# VSS 0.84081f ; **FLOATING
C1505 a_22677_1842# VSS 1.03822f ; **FLOATING
C1506 a_22113_1842# VSS 0.65634f ; **FLOATING
C1507 a_21483_1842# VSS 0.84055f ; **FLOATING
C1508 a_21917_1842# VSS 1.3729f ; **FLOATING
C1509 a_21353_1842# VSS 0.65329f ; **FLOATING
C1510 a_20723_1842# VSS 0.84079f ; **FLOATING
C1511 a_21157_1842# VSS 1.27457f ; **FLOATING
C1512 a_20593_1842# VSS 0.65709f ; **FLOATING
C1513 a_19963_1842# VSS 0.84057f ; **FLOATING
C1514 a_20397_1842# VSS 1.37272f ; **FLOATING
C1515 a_19833_1842# VSS 0.65331f ; **FLOATING
C1516 a_19203_1842# VSS 0.84081f ; **FLOATING
C1517 a_19637_1842# VSS 1.03822f ; **FLOATING
C1518 a_19073_1842# VSS 0.65583f ; **FLOATING
C1519 a_18443_1842# VSS 0.84055f ; **FLOATING
C1520 a_18877_1842# VSS 1.3729f ; **FLOATING
C1521 a_18313_1842# VSS 0.65329f ; **FLOATING
C1522 a_17683_1842# VSS 0.84079f ; **FLOATING
C1523 a_18117_1842# VSS 1.27457f ; **FLOATING
C1524 a_17553_1842# VSS 0.65417f ; **FLOATING
C1525 a_16923_1842# VSS 0.84053f ; **FLOATING
C1526 a_17357_1842# VSS 1.37272f ; **FLOATING
C1527 a_16793_1842# VSS 0.65301f ; **FLOATING
C1528 a_16163_1842# VSS 0.84079f ; **FLOATING
C1529 a_16597_1842# VSS 1.0334f ; **FLOATING
C1530 a_16033_1842# VSS 0.65709f ; **FLOATING
C1531 a_15403_1842# VSS 0.84254f ; **FLOATING
C1532 a_15837_1842# VSS 1.37106f ; **FLOATING
C1533 a_15273_1842# VSS 0.65574f ; **FLOATING
C1534 a_14643_1842# VSS 0.84258f ; **FLOATING
C1535 a_15077_1842# VSS 1.2744f ; **FLOATING
C1536 a_14513_1842# VSS 0.65705f ; **FLOATING
C1537 a_13883_1842# VSS 0.84262f ; **FLOATING
C1538 a_14317_1842# VSS 1.37449f ; **FLOATING
C1539 a_13753_1842# VSS 0.65718f ; **FLOATING
C1540 a_13123_1842# VSS 0.84281f ; **FLOATING
C1541 a_13557_1842# VSS 1.04002f ; **FLOATING
C1542 a_12993_1842# VSS 0.65743f ; **FLOATING
C1543 a_12363_1842# VSS 0.84255f ; **FLOATING
C1544 a_12797_1842# VSS 1.37469f ; **FLOATING
C1545 a_12233_1842# VSS 0.65737f ; **FLOATING
C1546 a_11603_1842# VSS 0.84092f ; **FLOATING
C1547 a_12037_1842# VSS 1.27472f ; **FLOATING
C1548 a_11473_1842# VSS 0.65444f ; **FLOATING
C1549 a_10843_1842# VSS 0.8407f ; **FLOATING
C1550 a_11277_1842# VSS 1.37287f ; **FLOATING
C1551 a_10713_1842# VSS 0.65358f ; **FLOATING
C1552 a_10083_1842# VSS 0.84093f ; **FLOATING
C1553 a_10517_1842# VSS 1.03837f ; **FLOATING
C1554 a_9953_1842# VSS 0.65447f ; **FLOATING
C1555 a_9323_1842# VSS 0.84068f ; **FLOATING
C1556 a_9757_1842# VSS 1.37305f ; **FLOATING
C1557 a_9193_1842# VSS 0.65356f ; **FLOATING
C1558 a_8563_1842# VSS 0.84092f ; **FLOATING
C1559 a_8997_1842# VSS 1.27472f ; **FLOATING
C1560 a_8433_1842# VSS 0.65444f ; **FLOATING
C1561 a_7803_1842# VSS 0.8407f ; **FLOATING
C1562 a_8237_1842# VSS 1.37287f ; **FLOATING
C1563 a_7673_1842# VSS 0.65358f ; **FLOATING
C1564 a_7043_1842# VSS 0.84093f ; **FLOATING
C1565 a_7477_1842# VSS 1.03837f ; **FLOATING
C1566 a_6913_1842# VSS 0.65447f ; **FLOATING
C1567 a_6283_1842# VSS 0.84068f ; **FLOATING
C1568 a_6717_1842# VSS 1.37305f ; **FLOATING
C1569 a_6153_1842# VSS 0.65356f ; **FLOATING
C1570 a_5523_1842# VSS 0.84092f ; **FLOATING
C1571 a_5957_1842# VSS 1.27472f ; **FLOATING
C1572 a_5393_1842# VSS 0.65853f ; **FLOATING
C1573 a_4763_1842# VSS 0.84257f ; **FLOATING
C1574 a_5197_1842# VSS 1.37454f ; **FLOATING
C1575 a_4633_1842# VSS 0.65656f ; **FLOATING
C1576 a_4003_1842# VSS 0.92443f ; **FLOATING
C1577 a_4437_1842# VSS 1.04148f ; **FLOATING
C1578 a_9712_3912# VSS 1.59526f ; **FLOATING
C1579 a_9444_3912# VSS 2.31588f ; **FLOATING
C1580 a_5778_3367# VSS 5.88104f ; **FLOATING
C1581 a_15464_3684# VSS 0.91028f ; **FLOATING
C1582 a_14757_5182# VSS 0.1031f ; **FLOATING
C1583 a_13880_5118# VSS 0.0742f ; **FLOATING
C1584 a_15688_5403# VSS 0.27866f ; **FLOATING
C1585 a_15108_5325# VSS 0.24688f ; **FLOATING
C1586 a_14851_5182# VSS 0.39269f ; **FLOATING
C1587 a_9444_4590# VSS 6.48112f ; **FLOATING
C1588 a_14111_5227# VSS 0.20221f ; **FLOATING
C1589 a_14009_5084# VSS 0.4602f ; **FLOATING
C1590 a_13592_5423# VSS 1.62662f ; **FLOATING
C1591 a_13306_5105# VSS 0.31101f ; **FLOATING
C1592 a_13566_5328# VSS 0.1634f ; **FLOATING
C1593 a_13132_5420# VSS 0.14211f ; **FLOATING
C1594 a_12907_5420# VSS 0.1476f ; **FLOATING
C1595 a_12907_5186# VSS 0.14887f ; **FLOATING
C1596 a_13106_5357# VSS 0.07369f ; **FLOATING
C1597 a_15304_4605# VSS 0.46629f ; **FLOATING
C1598 a_14757_6228# VSS 0.10568f ; **FLOATING
C1599 a_15688_5867# VSS 0.2737f ; **FLOATING
C1600 a_14851_6228# VSS 0.40535f ; **FLOATING
C1601 a_15108_6109# VSS 0.25077f ; **FLOATING
C1602 a_14111_5878# VSS 0.23266f ; **FLOATING
C1603 a_13880_6292# VSS 0.0799f ; **FLOATING
C1604 a_14009_5878# VSS 0.494f ; **FLOATING
C1605 a_13592_5871# VSS 1.63328f ; **FLOATING
C1606 a_13566_5835# VSS 0.1587f ; **FLOATING
C1607 a_13045_6215# VSS 0.01186f ; **FLOATING
C1608 a_13306_6305# VSS 0.32799f ; **FLOATING
C1609 a_12849_5867# VSS 1.40481f ; **FLOATING
C1610 a_13121_5831# VSS 0.83335f ; **FLOATING
C1611 a_13019_5831# VSS 3.90831f ; **FLOATING
C1612 a_12656_5864# VSS 0.29728f ; **FLOATING
C1613 a_12355_5867# VSS 0.76652f ; **FLOATING
C1614 a_11397_6228# VSS 0.10938f ; **FLOATING
C1615 a_12158_5867# VSS 0.27426f ; **FLOATING
C1616 a_11491_6228# VSS 0.32236f ; **FLOATING
C1617 a_11748_6109# VSS 0.18335f ; **FLOATING
C1618 a_10751_5878# VSS 0.21951f ; **FLOATING
C1619 a_10520_6292# VSS 0.05232f ; **FLOATING
C1620 a_10649_5878# VSS 0.49351f ; **FLOATING
C1621 a_10232_5871# VSS 1.59913f ; **FLOATING
C1622 a_10206_5835# VSS 0.09627f ; **FLOATING
C1623 a_9946_6305# VSS 0.20725f ; **FLOATING
C1624 a_9772_5843# VSS 0.13878f ; **FLOATING
C1625 a_9746_5805# VSS 0.07638f ; **FLOATING
C1626 a_9547_6172# VSS 0.16803f ; **FLOATING
C1627 a_9547_5942# VSS 0.12932f ; **FLOATING
C1628 a_6854_5454# VSS 3.65501f ; **FLOATING
C1629 a_6126_3816# VSS 17.0938f ; **FLOATING
C1630 a_6854_5986# VSS 2.92522f ; **FLOATING
C1631 a_5974_5723# VSS 2.52601f ; **FLOATING
C1632 a_6326_4590# VSS 1.17208f ; **FLOATING
C1633 a_2019_1047.t2 VSS 0.83005f ; **FLOATING
C1634 a_2019_1047.t3 VSS 0.63015f ; **FLOATING
C1635 a_2019_1047.n0 VSS 4.46922f ; **FLOATING
C1636 a_2019_1047.t4 VSS 0.63015f ; **FLOATING
C1637 a_2019_1047.n1 VSS 3.02355f ; **FLOATING
C1638 a_2019_1047.t5 VSS 0.63015f ; **FLOATING
C1639 a_2019_1047.n2 VSS 3.02355f ; **FLOATING
C1640 a_2019_1047.t6 VSS 0.63015f ; **FLOATING
C1641 a_2019_1047.n3 VSS 3.02355f ; **FLOATING
C1642 a_2019_1047.t7 VSS 0.63015f ; **FLOATING
C1643 a_2019_1047.n4 VSS 3.02355f ; **FLOATING
C1644 a_2019_1047.t8 VSS 3.6537f ; **FLOATING
C1645 a_2019_1047.t9 VSS 4.86718f ; **FLOATING
C1646 a_2019_1047.t1 VSS 0.95702f ; **FLOATING
C1647 a_2019_1047.t0 VSS 0.27201f ; **FLOATING
C1648 a_2595_1047.t2 VSS 1.36604f ; **FLOATING
C1649 a_2595_1047.t3 VSS 1.0202f ; **FLOATING
C1650 a_2595_1047.n0 VSS 7.75561f ; **FLOATING
C1651 a_2595_1047.t4 VSS 1.0202f ; **FLOATING
C1652 a_2595_1047.n1 VSS 5.26957f ; **FLOATING
C1653 a_2595_1047.t5 VSS 1.0202f ; **FLOATING
C1654 a_2595_1047.n2 VSS 5.26957f ; **FLOATING
C1655 a_2595_1047.t6 VSS 1.0202f ; **FLOATING
C1656 a_2595_1047.n3 VSS 5.26957f ; **FLOATING
C1657 a_2595_1047.t7 VSS 1.0202f ; **FLOATING
C1658 a_2595_1047.n4 VSS 5.26957f ; **FLOATING
C1659 a_2595_1047.t8 VSS 1.0202f ; **FLOATING
C1660 a_2595_1047.n5 VSS 5.26957f ; **FLOATING
C1661 a_2595_1047.t9 VSS 1.0202f ; **FLOATING
C1662 a_2595_1047.n6 VSS 7.57997f ; **FLOATING
C1663 a_2595_1047.t1 VSS 1.74992f ; **FLOATING
C1664 a_2595_1047.t0 VSS 0.48192f ; **FLOATING
C1665 a_3171_1047.t2 VSS 1.39099f ; **FLOATING
C1666 a_3171_1047.t3 VSS 1.04226f ; **FLOATING
C1667 a_3171_1047.n0 VSS 7.81547f ; **FLOATING
C1668 a_3171_1047.t4 VSS 1.04226f ; **FLOATING
C1669 a_3171_1047.n1 VSS 5.30588f ; **FLOATING
C1670 a_3171_1047.t5 VSS 1.04226f ; **FLOATING
C1671 a_3171_1047.n2 VSS 5.30588f ; **FLOATING
C1672 a_3171_1047.t6 VSS 1.04226f ; **FLOATING
C1673 a_3171_1047.n3 VSS 5.30588f ; **FLOATING
C1674 a_3171_1047.t7 VSS 1.04226f ; **FLOATING
C1675 a_3171_1047.n4 VSS 5.30588f ; **FLOATING
C1676 a_3171_1047.t8 VSS 1.04226f ; **FLOATING
C1677 a_3171_1047.n5 VSS 5.30588f ; **FLOATING
C1678 a_3171_1047.t9 VSS 1.04226f ; **FLOATING
C1679 a_3171_1047.n6 VSS 7.71992f ; **FLOATING
C1680 a_3171_1047.t1 VSS 1.77866f ; **FLOATING
C1681 a_3171_1047.t0 VSS 0.48312f ; **FLOATING
C1682 a_3747_1047.t2 VSS 1.01739f ; **FLOATING
C1683 a_3747_1047.t3 VSS 0.77455f ; **FLOATING
C1684 a_3747_1047.n0 VSS 5.42635f ; **FLOATING
C1685 a_3747_1047.t4 VSS 0.77455f ; **FLOATING
C1686 a_3747_1047.n1 VSS 3.66814f ; **FLOATING
C1687 a_3747_1047.t5 VSS 0.77455f ; **FLOATING
C1688 a_3747_1047.n2 VSS 3.66814f ; **FLOATING
C1689 a_3747_1047.t6 VSS 0.77455f ; **FLOATING
C1690 a_3747_1047.n3 VSS 3.66814f ; **FLOATING
C1691 a_3747_1047.t7 VSS 0.77455f ; **FLOATING
C1692 a_3747_1047.n4 VSS 3.66814f ; **FLOATING
C1693 a_3747_1047.t8 VSS 0.77455f ; **FLOATING
C1694 a_3747_1047.n5 VSS 3.66814f ; **FLOATING
C1695 a_3747_1047.t9 VSS 0.77455f ; **FLOATING
C1696 a_3747_1047.n6 VSS 5.44676f ; **FLOATING
C1697 a_3747_1047.t1 VSS 1.24474f ; **FLOATING
C1698 a_3747_1047.t0 VSS 0.32908f ; **FLOATING
C1699 a_2019_311.t2 VSS 4.07039f ; **FLOATING
C1700 a_2019_311.t3 VSS 21.9055f ; **FLOATING
C1701 a_2019_311.t1 VSS 1.98979f ; **FLOATING
C1702 a_2019_311.t0 VSS 0.44677f ; **FLOATING
C1703 a_2595_311.t1 VSS 3.28186f ; **FLOATING
C1704 a_2595_311.t2 VSS 5.05916f ; **FLOATING
C1705 a_2595_311.t3 VSS 1.21056f ; **FLOATING
C1706 a_2595_311.n0 VSS 26.9612f ; **FLOATING
C1707 a_2595_311.t0 VSS 0.49746f ; **FLOATING
C1708 a_3171_311.t2 VSS 5.10971f ; **FLOATING
C1709 a_3171_311.t3 VSS 1.2258f ; **FLOATING
C1710 a_3171_311.n0 VSS 30.2023f ; **FLOATING
C1711 a_3171_311.t1 VSS 4.66598f ; **FLOATING
C1712 a_3171_311.t0 VSS 0.50317f ; **FLOATING
C1713 a_3747_311.t2 VSS 3.88688f ; **FLOATING
C1714 a_3747_311.t3 VSS 0.93554f ; **FLOATING
C1715 a_3747_311.n0 VSS 25.0012f ; **FLOATING
C1716 a_3747_311.t1 VSS 4.63722f ; **FLOATING
C1717 a_3747_311.t0 VSS 0.38387f ; **FLOATING
C1718 VSS.t215 VSS 3.68888f ; **FLOATING
C1719 VDD.t10 VSS 63.9646f ; **FLOATING
C1720 VDD.t4 VSS 68.2032f ; **FLOATING
C1721 VDD.n2 VSS 0.03793f ; **FLOATING
C1722 VDD.n3 VSS 0.0301f ; **FLOATING
C1723 VDD.n4 VSS 0.0301f ; **FLOATING
C1724 VDD.n5 VSS 0.03204f ; **FLOATING
C1725 VDD.n6 VSS 0.02893f ; **FLOATING
C1726 VDD.n7 VSS 0.02146f ; **FLOATING
C1727 VDD.n8 VSS 0.60782f ; **FLOATING
C1728 VDD.n9 VSS 0.03734f ; **FLOATING
C1729 VDD.n11 VSS 0.41619f ; **FLOATING
C1730 VDD.n12 VSS 0.44104f ; **FLOATING
C1731 VDD.t62 VSS 0.04875f ; **FLOATING
C1732 VDD.n13 VSS 0.03204f ; **FLOATING
C1733 VDD.n14 VSS 0.03204f ; **FLOATING
C1734 VDD.n15 VSS 0.41446f ; **FLOATING
C1735 VDD.n16 VSS 0.03204f ; **FLOATING
C1736 VDD.n17 VSS 0.03204f ; **FLOATING
C1737 VDD.n18 VSS 0.41415f ; **FLOATING
C1738 VDD.n19 VSS 0.03204f ; **FLOATING
C1739 VDD.n20 VSS 0.03204f ; **FLOATING
C1740 VDD.n21 VSS 0.41381f ; **FLOATING
C1741 VDD.n22 VSS 0.03204f ; **FLOATING
C1742 VDD.n23 VSS 0.03204f ; **FLOATING
C1743 VDD.n24 VSS 0.41381f ; **FLOATING
C1744 VDD.n25 VSS 0.03204f ; **FLOATING
C1745 VDD.n26 VSS 0.03204f ; **FLOATING
C1746 VDD.n27 VSS 0.41381f ; **FLOATING
C1747 VDD.n28 VSS 0.03204f ; **FLOATING
C1748 VDD.n29 VSS 0.03204f ; **FLOATING
C1749 VDD.n30 VSS 0.41381f ; **FLOATING
C1750 VDD.n31 VSS 0.03204f ; **FLOATING
C1751 VDD.n32 VSS 0.3261f ; **FLOATING
C1752 VDD.n33 VSS 0.41381f ; **FLOATING
C1753 VDD.n34 VSS 0.03204f ; **FLOATING
C1754 VDD.n35 VSS 0.03204f ; **FLOATING
C1755 VDD.n36 VSS 0.41381f ; **FLOATING
C1756 VDD.n37 VSS 0.03204f ; **FLOATING
C1757 VDD.n38 VSS 0.03204f ; **FLOATING
C1758 VDD.n39 VSS 0.41381f ; **FLOATING
C1759 VDD.n40 VSS 0.03204f ; **FLOATING
C1760 VDD.n41 VSS 0.03204f ; **FLOATING
C1761 VDD.n42 VSS 0.41381f ; **FLOATING
C1762 VDD.n43 VSS 0.03204f ; **FLOATING
C1763 VDD.n44 VSS 0.41381f ; **FLOATING
C1764 VDD.n45 VSS 0.03204f ; **FLOATING
C1765 VDD.n46 VSS 0.41381f ; **FLOATING
C1766 VDD.n47 VSS 0.41381f ; **FLOATING
C1767 VDD.n48 VSS 0.03204f ; **FLOATING
C1768 VDD.n49 VSS 0.03204f ; **FLOATING
C1769 VDD.n50 VSS 0.41462f ; **FLOATING
C1770 VDD.n51 VSS 0.50592f ; **FLOATING
C1771 VDD.n52 VSS 0.02868f ; **FLOATING
C1772 VDD.n53 VSS 0.65759f ; **FLOATING
C1773 VDD.n54 VSS 0.03111f ; **FLOATING
C1774 VDD.n55 VSS 0.03204f ; **FLOATING
C1775 VDD.n56 VSS 0.03204f ; **FLOATING
C1776 VDD.n57 VSS 2.21769f ; **FLOATING
C1777 VDD.n58 VSS 0.67908f ; **FLOATING
C1778 VDD.n60 VSS 1.53274f ; **FLOATING
C1779 VDD.n62 VSS 1.72336f ; **FLOATING
C1780 VDD.n63 VSS 0.18152f ; **FLOATING
C1781 VDD.n64 VSS 1.5437f ; **FLOATING
C1782 VDD.n66 VSS 1.72485f ; **FLOATING
C1783 VDD.n67 VSS 1.72351f ; **FLOATING
C1784 VDD.n68 VSS 1.98418f ; **FLOATING
C1785 VDD.n69 VSS 0.93084f ; **FLOATING
C1786 VDD.n72 VSS 0.41649f ; **FLOATING
C1787 VDD.n73 VSS 0.71757f ; **FLOATING
C1788 VDD.n74 VSS 0.26267f ; **FLOATING
C1789 VDD.n75 VSS 1.00937f ; **FLOATING
C1790 VDD.n76 VSS 0.84467f ; **FLOATING
C1791 VDD.n77 VSS 0.26094f ; **FLOATING
C1792 VDD.n78 VSS 0.40502f ; **FLOATING
C1793 VDD.n79 VSS 0.24049f ; **FLOATING
C1794 VDD.n80 VSS 0.02219f ; **FLOATING
C1795 VDD.n81 VSS 0.05593f ; **FLOATING
C1796 VDD.n82 VSS 0.05593f ; **FLOATING
C1797 VDD.n83 VSS 0.0301f ; **FLOATING
C1798 VDD.n84 VSS 0.58955f ; **FLOATING
C1799 VDD.n87 VSS 0.14087f ; **FLOATING
C1800 VDD.n88 VSS 0.03204f ; **FLOATING
C1801 VDD.n89 VSS 0.21078f ; **FLOATING
C1802 VDD.n92 VSS 0.13735f ; **FLOATING
C1803 VDD.n93 VSS 0.0301f ; **FLOATING
C1804 VDD.n94 VSS 0.41119f ; **FLOATING
C1805 VDD.n95 VSS 0.03204f ; **FLOATING
C1806 VDD.n96 VSS 0.03204f ; **FLOATING
C1807 VDD.n97 VSS 0.50158f ; **FLOATING
C1808 VDD.n98 VSS 0.32393f ; **FLOATING
C1809 VDD.n100 VSS 0.63063f ; **FLOATING
C1810 VDD.n102 VSS 0.03204f ; **FLOATING
C1811 VDD.n103 VSS 0.26275f ; **FLOATING
C1812 VDD.n104 VSS 0.01842f ; **FLOATING
C1813 VDD.n120 VSS 0.10844f ; **FLOATING
C1814 VDD.n122 VSS 0.05245f ; **FLOATING
C1815 VDD.n123 VSS 0.19166f ; **FLOATING
C1816 VDD.n128 VSS 0.05977f ; **FLOATING
C1817 VDD.n133 VSS 0.01852f ; **FLOATING
C1818 VDD.n135 VSS 0.2014f ; **FLOATING
C1819 VDD.n136 VSS 0.26153f ; **FLOATING
C1820 VDD.n137 VSS 0.26149f ; **FLOATING
C1821 VDD.t58 VSS 0.02541f ; **FLOATING
C1822 VDD.n138 VSS 0.01892f ; **FLOATING
C1823 VDD.n139 VSS 0.85313f ; **FLOATING
C1824 VDD.n140 VSS 0.11268f ; **FLOATING
C1825 VDD.n142 VSS 0.16496f ; **FLOATING
C1826 VDD.n144 VSS 0.01579f ; **FLOATING
C1827 VDD.n153 VSS 0.01579f ; **FLOATING
C1828 VDD.n154 VSS 0.01579f ; **FLOATING
C1829 VDD.n155 VSS 0.01579f ; **FLOATING
C1830 VDD.n156 VSS 0.01579f ; **FLOATING
C1831 VDD.n157 VSS 0.01579f ; **FLOATING
C1832 VDD.n158 VSS 0.01579f ; **FLOATING
C1833 VDD.n159 VSS 0.01579f ; **FLOATING
C1834 VDD.n163 VSS 0.07586f ; **FLOATING
C1835 VDD.n164 VSS 0.17403f ; **FLOATING
C1836 VDD.n165 VSS 0.03216f ; **FLOATING
C1837 VDD.n166 VSS 0.01579f ; **FLOATING
C1838 VDD.n175 VSS 0.15379f ; **FLOATING
C1839 VDD.n178 VSS 0.15379f ; **FLOATING
C1840 VDD.n180 VSS 0.15409f ; **FLOATING
C1841 VDD.n186 VSS 0.14352f ; **FLOATING
C1842 VDD.n187 VSS 0.18293f ; **FLOATING
C1843 VDD.n226 VSS 0.025f ; **FLOATING
C1844 VDD.n227 VSS 0.02485f ; **FLOATING
C1845 VDD.n228 VSS 0.025f ; **FLOATING
C1846 VDD.n229 VSS 0.02485f ; **FLOATING
C1847 VDD.n230 VSS 0.025f ; **FLOATING
C1848 VDD.n231 VSS 0.02485f ; **FLOATING
C1849 VDD.n232 VSS 0.02485f ; **FLOATING
C1850 VDD.n233 VSS 0.025f ; **FLOATING
C1851 VDD.n234 VSS 0.02485f ; **FLOATING
C1852 VDD.n235 VSS 0.02485f ; **FLOATING
C1853 VDD.n236 VSS 0.02485f ; **FLOATING
C1854 VDD.n237 VSS 0.02485f ; **FLOATING
C1855 VDD.n238 VSS 0.02485f ; **FLOATING
C1856 VDD.n239 VSS 0.02485f ; **FLOATING
C1857 VDD.n240 VSS 0.02485f ; **FLOATING
C1858 VDD.n244 VSS 0.05988f ; **FLOATING
C1859 VDD.n245 VSS 0.2237f ; **FLOATING
C1860 VDD.n246 VSS 0.01722f ; **FLOATING
C1861 VDD.n247 VSS 0.01852f ; **FLOATING
C1862 VDD.n248 VSS 0.01852f ; **FLOATING
C1863 VDD.n249 VSS 0.025f ; **FLOATING
C1864 VDD.n250 VSS 0.01852f ; **FLOATING
C1865 VDD.n251 VSS 0.01852f ; **FLOATING
C1866 VDD.n253 VSS 0.01852f ; **FLOATING
C1867 VDD.n254 VSS 0.01852f ; **FLOATING
C1868 VDD.n255 VSS 0.01852f ; **FLOATING
C1869 VDD.n256 VSS 0.025f ; **FLOATING
C1870 VDD.n257 VSS 0.01852f ; **FLOATING
C1871 VDD.n258 VSS 0.01852f ; **FLOATING
C1872 VDD.n259 VSS 0.01852f ; **FLOATING
C1873 VDD.n260 VSS 0.01852f ; **FLOATING
C1874 VDD.n261 VSS 0.14715f ; **FLOATING
C1875 VDD.n262 VSS 0.025f ; **FLOATING
C1876 VDD.n263 VSS 0.15061f ; **FLOATING
C1877 VDD.n264 VSS 0.025f ; **FLOATING
C1878 VDD.n265 VSS 0.149f ; **FLOATING
C1879 VDD.n269 VSS 0.02046f ; **FLOATING
C1880 VDD.n270 VSS 0.01242f ; **FLOATING
C1881 VDD.n271 VSS 0.02144f ; **FLOATING
C1882 VDD.n272 VSS 0.02111f ; **FLOATING
C1883 VDD.n274 VSS 0.01852f ; **FLOATING
C1884 VDD.n275 VSS 0.01852f ; **FLOATING
C1885 VDD.n276 VSS 0.02144f ; **FLOATING
C1886 VDD.n277 VSS 0.01852f ; **FLOATING
C1887 VDD.n278 VSS 0.01852f ; **FLOATING
C1888 VDD.n279 VSS 0.01852f ; **FLOATING
C1889 VDD.n280 VSS 0.01844f ; **FLOATING
C1890 VDD.n312 VSS 0.14982f ; **FLOATING
C1891 VDD.n314 VSS 0.03086f ; **FLOATING
C1892 VDD.n315 VSS 0.02046f ; **FLOATING
C1893 VDD.n323 VSS 0.01966f ; **FLOATING
C1894 VDD.n324 VSS 0.10736f ; **FLOATING
C1895 VDD.n332 VSS 0.02457f ; **FLOATING
C1896 VDD.n333 VSS 0.025f ; **FLOATING
C1897 VDD.n334 VSS 0.025f ; **FLOATING
C1898 VDD.n335 VSS 0.02457f ; **FLOATING
C1899 VDD.n336 VSS 0.025f ; **FLOATING
C1900 VDD.n337 VSS 0.10777f ; **FLOATING
C1901 VDD.n338 VSS 0.10696f ; **FLOATING
C1902 VDD.n339 VSS 0.10739f ; **FLOATING
C1903 VDD.n340 VSS 0.09147f ; **FLOATING
C1904 VDD.n341 VSS 0.03443f ; **FLOATING
C1905 VDD.n344 VSS 0.30534f ; **FLOATING
C1906 VDD.n346 VSS 0.025f ; **FLOATING
C1907 VDD.n347 VSS 0.025f ; **FLOATING
C1908 VDD.n348 VSS 0.025f ; **FLOATING
C1909 VDD.n349 VSS 0.025f ; **FLOATING
C1910 VDD.n350 VSS 0.025f ; **FLOATING
C1911 VDD.n351 VSS 0.025f ; **FLOATING
C1912 VDD.n352 VSS 0.025f ; **FLOATING
C1913 VDD.n353 VSS 0.025f ; **FLOATING
C1914 VDD.n354 VSS 0.025f ; **FLOATING
C1915 VDD.n355 VSS 0.025f ; **FLOATING
C1916 VDD.n356 VSS 0.025f ; **FLOATING
C1917 VDD.n357 VSS 0.025f ; **FLOATING
C1918 VDD.n358 VSS 0.025f ; **FLOATING
C1919 VDD.n359 VSS 0.025f ; **FLOATING
C1920 VDD.n360 VSS 0.025f ; **FLOATING
C1921 VDD.n361 VSS 0.025f ; **FLOATING
C1922 VDD.n364 VSS 0.01681f ; **FLOATING
C1923 VDD.n366 VSS 0.08484f ; **FLOATING
C1924 VDD.n367 VSS 0.025f ; **FLOATING
C1925 VDD.n368 VSS 0.025f ; **FLOATING
C1926 VDD.n369 VSS 0.025f ; **FLOATING
C1927 VDD.n370 VSS 0.025f ; **FLOATING
C1928 VDD.n371 VSS 0.02457f ; **FLOATING
C1929 VDD.n372 VSS 0.025f ; **FLOATING
C1930 VDD.n373 VSS 0.025f ; **FLOATING
C1931 VDD.n374 VSS 0.02457f ; **FLOATING
C1932 VDD.n375 VSS 0.025f ; **FLOATING
C1933 VDD.n382 VSS 0.01579f ; **FLOATING
C1934 VDD.n383 VSS 0.05905f ; **FLOATING
C1935 VDD.n385 VSS 0.025f ; **FLOATING
C1936 VDD.t36 VSS 10.9078f ; **FLOATING
C1937 VDD.n387 VSS 0.1826f ; **FLOATING
C1938 VDD.n388 VSS 0.07414f ; **FLOATING
C1939 VDD.n389 VSS 1.2448f ; **FLOATING
C1940 VDD.n390 VSS 0.025f ; **FLOATING
C1941 VDD.n391 VSS 0.025f ; **FLOATING
C1942 VDD.n392 VSS 0.025f ; **FLOATING
C1943 VDD.n393 VSS 0.02457f ; **FLOATING
C1944 VDD.n394 VSS 0.02457f ; **FLOATING
C1945 VDD.n395 VSS 0.025f ; **FLOATING
C1946 VDD.n396 VSS 0.025f ; **FLOATING
C1947 VDD.n397 VSS 0.025f ; **FLOATING
C1948 VDD.n398 VSS 0.025f ; **FLOATING
C1949 VDD.n399 VSS 0.025f ; **FLOATING
C1950 VDD.n400 VSS 0.02457f ; **FLOATING
C1951 VDD.n401 VSS 0.02457f ; **FLOATING
C1952 VDD.n402 VSS 0.025f ; **FLOATING
C1953 VDD.n409 VSS 0.02882f ; **FLOATING
C1954 VDD.t1 VSS 0.0606f ; **FLOATING
C1955 VDD.t110 VSS 0.0606f ; **FLOATING
C1956 VDD.n410 VSS 0.15976f ; **FLOATING
C1957 VDD.t239 VSS 0.03563f ; **FLOATING
C1958 VDD.t241 VSS 0.03563f ; **FLOATING
C1959 VDD.t140 VSS 0.04843f ; **FLOATING
C1960 VDD.n411 VSS 0.01579f ; **FLOATING
C1961 VDD.n412 VSS 0.01579f ; **FLOATING
C1962 VDD.n413 VSS 0.01579f ; **FLOATING
C1963 VDD.n414 VSS 0.01579f ; **FLOATING
C1964 VDD.n415 VSS 0.01579f ; **FLOATING
C1965 VDD.n416 VSS 0.01579f ; **FLOATING
C1966 VDD.n417 VSS 0.01579f ; **FLOATING
C1967 VDD.n418 VSS 0.01579f ; **FLOATING
C1968 VDD.n419 VSS 0.01579f ; **FLOATING
C1969 VDD.n420 VSS 0.01579f ; **FLOATING
C1970 VDD.n421 VSS 0.01579f ; **FLOATING
C1971 VDD.n422 VSS 0.01579f ; **FLOATING
C1972 VDD.n423 VSS 0.01579f ; **FLOATING
C1973 VDD.t360 VSS 0.01652f ; **FLOATING
C1974 VDD.t212 VSS 0.08221f ; **FLOATING
C1975 VDD.t9 VSS 0.01652f ; **FLOATING
C1976 VDD.t167 VSS 0.08221f ; **FLOATING
C1977 VDD.t3 VSS 0.05011f ; **FLOATING
C1978 VDD.t112 VSS 0.05011f ; **FLOATING
C1979 VDD.n424 VSS 0.20197f ; **FLOATING
C1980 VDD.n425 VSS 0.01579f ; **FLOATING
C1981 VDD.n426 VSS 0.03649f ; **FLOATING
C1982 VDD.t56 VSS 0.0432f ; **FLOATING
C1983 VDD.n427 VSS 0.02932f ; **FLOATING
C1984 VDD.t54 VSS 0.03118f ; **FLOATING
C1985 VDD.t57 VSS 0.04828f ; **FLOATING
C1986 VDD.t59 VSS 0.04361f ; **FLOATING
C1987 VDD.t300 VSS 0.0432f ; **FLOATING
C1988 VDD.t61 VSS 0.04359f ; **FLOATING
C1989 VDD.t60 VSS 0.03118f ; **FLOATING
C1990 VDD.t63 VSS 0.0254f ; **FLOATING
C1991 VDD.t64 VSS 0.0432f ; **FLOATING
C1992 VDD.t366 VSS 0.04742f ; **FLOATING
C1993 VDD.t81 VSS 0.03226f ; **FLOATING
C1994 VDD.t55 VSS 4.53907f ; **FLOATING
C1995 VDD.n428 VSS 0.10362f ; **FLOATING
C1996 VDD.n429 VSS 0.01579f ; **FLOATING
C1997 VDD.n430 VSS 0.01382f ; **FLOATING
C1998 VDD.n431 VSS 0.03158f ; **FLOATING
C1999 VDD.n432 VSS 0.03158f ; **FLOATING
C2000 VDD.n433 VSS 0.01579f ; **FLOATING
C2001 VDD.n434 VSS 0.01579f ; **FLOATING
C2002 VDD.t80 VSS 0.04472f ; **FLOATING
C2003 VDD.n435 VSS 0.01579f ; **FLOATING
C2004 VDD.n436 VSS 0.01579f ; **FLOATING
C2005 VDD.n437 VSS 0.01579f ; **FLOATING
C2006 VDD.n438 VSS 0.01579f ; **FLOATING
C2007 VDD.n439 VSS 0.01579f ; **FLOATING
C2008 VDD.t214 VSS 0.0501f ; **FLOATING
C2009 VDD.n440 VSS 0.01579f ; **FLOATING
C2010 VDD.n441 VSS 0.01579f ; **FLOATING
C2011 VDD.n442 VSS 0.01579f ; **FLOATING
C2012 VDD.n443 VSS 0.01579f ; **FLOATING
C2013 VDD.n444 VSS 0.01579f ; **FLOATING
C2014 VDD.n445 VSS 0.01579f ; **FLOATING
C2015 VDD.n446 VSS 0.01579f ; **FLOATING
C2016 VDD.n447 VSS 0.01579f ; **FLOATING
C2017 VDD.n448 VSS 0.01579f ; **FLOATING
C2018 VDD.n449 VSS 0.01579f ; **FLOATING
C2019 VDD.n450 VSS 0.01579f ; **FLOATING
C2020 VDD.n451 VSS 0.01579f ; **FLOATING
C2021 VDD.n452 VSS 0.01579f ; **FLOATING
C2022 VDD.n453 VSS 0.01579f ; **FLOATING
C2023 VDD.n454 VSS 0.01579f ; **FLOATING
C2024 VDD.n455 VSS 0.01579f ; **FLOATING
C2025 VDD.n456 VSS 0.01579f ; **FLOATING
C2026 VDD.n457 VSS 0.01579f ; **FLOATING
C2027 VDD.n458 VSS 0.01579f ; **FLOATING
C2028 VDD.n459 VSS 0.01579f ; **FLOATING
C2029 VDD.n460 VSS 0.01579f ; **FLOATING
C2030 VDD.n461 VSS 0.01579f ; **FLOATING
C2031 VDD.n462 VSS 0.01579f ; **FLOATING
C2032 VDD.n463 VSS 0.01579f ; **FLOATING
C2033 VDD.n464 VSS 0.01579f ; **FLOATING
C2034 VDD.t79 VSS 0.03563f ; **FLOATING
C2035 VDD.n465 VSS 0.01579f ; **FLOATING
C2036 VDD.n466 VSS 0.01579f ; **FLOATING
C2037 VDD.n467 VSS 0.01579f ; **FLOATING
C2038 VDD.n468 VSS 0.01579f ; **FLOATING
C2039 VDD.n469 VSS 0.01579f ; **FLOATING
C2040 VDD.n470 VSS 0.01579f ; **FLOATING
C2041 VDD.t134 VSS 0.01652f ; **FLOATING
C2042 VDD.t77 VSS 0.08221f ; **FLOATING
C2043 VDD.n471 VSS 0.01579f ; **FLOATING
C2044 VDD.n472 VSS 0.01579f ; **FLOATING
C2045 VDD.n473 VSS 0.01579f ; **FLOATING
C2046 VDD.n474 VSS 0.04614f ; **FLOATING
C2047 VDD.n475 VSS 0.01689f ; **FLOATING
C2048 VDD.n476 VSS 0.01579f ; **FLOATING
C2049 VDD.t0 VSS 17.3132f ; **FLOATING
C2050 VDD.n477 VSS 0.025f ; **FLOATING
C2051 VDD.n478 VSS 0.025f ; **FLOATING
C2052 VDD.t46 VSS 0.08621f ; **FLOATING
C2053 VDD.t53 VSS 0.08621f ; **FLOATING
C2054 VDD.n479 VSS 0.08908f ; **FLOATING
C2055 VDD.n480 VSS 0.025f ; **FLOATING
C2056 VDD.n481 VSS 0.025f ; **FLOATING
C2057 VDD.n482 VSS 0.025f ; **FLOATING
C2058 VDD.n483 VSS 0.025f ; **FLOATING
C2059 VDD.n484 VSS 0.025f ; **FLOATING
C2060 VDD.n485 VSS 0.025f ; **FLOATING
C2061 VDD.n486 VSS 0.025f ; **FLOATING
C2062 VDD.n487 VSS 0.025f ; **FLOATING
C2063 VDD.n488 VSS 0.025f ; **FLOATING
C2064 VDD.n489 VSS 0.025f ; **FLOATING
C2065 VDD.n490 VSS 0.025f ; **FLOATING
C2066 VDD.t185 VSS 0.08621f ; **FLOATING
C2067 VDD.t192 VSS 0.08621f ; **FLOATING
C2068 VDD.n491 VSS 0.05594f ; **FLOATING
C2069 VDD.n492 VSS 0.025f ; **FLOATING
C2070 VDD.n493 VSS 0.025f ; **FLOATING
C2071 VDD.n494 VSS 0.025f ; **FLOATING
C2072 VDD.n495 VSS 0.025f ; **FLOATING
C2073 VDD.t183 VSS 0.08621f ; **FLOATING
C2074 VDD.t190 VSS 0.08621f ; **FLOATING
C2075 VDD.n496 VSS 0.025f ; **FLOATING
C2076 VDD.n497 VSS 0.025f ; **FLOATING
C2077 VDD.n498 VSS 0.025f ; **FLOATING
C2078 VDD.n499 VSS 0.025f ; **FLOATING
C2079 VDD.n500 VSS 0.03777f ; **FLOATING
C2080 VDD.n501 VSS 0.03777f ; **FLOATING
C2081 VDD.n502 VSS 0.025f ; **FLOATING
C2082 VDD.n503 VSS 0.025f ; **FLOATING
C2083 VDD.n504 VSS 0.025f ; **FLOATING
C2084 VDD.n505 VSS 0.025f ; **FLOATING
C2085 VDD.n506 VSS 0.025f ; **FLOATING
C2086 VDD.n507 VSS 0.55424f ; **FLOATING
C2087 VDD.n508 VSS 0.14672f ; **FLOATING
C2088 VDD.n509 VSS 0.03556f ; **FLOATING
C2089 VDD.n510 VSS 0.025f ; **FLOATING
C2090 VDD.n511 VSS 0.025f ; **FLOATING
C2091 VDD.n512 VSS 0.025f ; **FLOATING
C2092 VDD.n513 VSS 0.025f ; **FLOATING
C2093 VDD.n514 VSS 0.025f ; **FLOATING
C2094 VDD.t43 VSS 0.08621f ; **FLOATING
C2095 VDD.t49 VSS 0.08621f ; **FLOATING
C2096 VDD.n515 VSS 0.0301f ; **FLOATING
C2097 VDD.t42 VSS 0.48778f ; **FLOATING
C2098 VDD.t44 VSS 0.07714f ; **FLOATING
C2099 VDD.n516 VSS 0.0301f ; **FLOATING
C2100 VDD.t50 VSS 0.07714f ; **FLOATING
C2101 VDD.n517 VSS 0.0301f ; **FLOATING
C2102 VDD.n518 VSS 0.06088f ; **FLOATING
C2103 VDD.n519 VSS 0.01969f ; **FLOATING
C2104 VDD.n520 VSS 0.06088f ; **FLOATING
C2105 VDD.n521 VSS 0.025f ; **FLOATING
C2106 VDD.n522 VSS 0.025f ; **FLOATING
C2107 VDD.n523 VSS 0.025f ; **FLOATING
C2108 VDD.n524 VSS 0.025f ; **FLOATING
C2109 VDD.n525 VSS 0.025f ; **FLOATING
C2110 VDD.n526 VSS 0.025f ; **FLOATING
C2111 VDD.t39 VSS 0.0295f ; **FLOATING
C2112 VDD.n527 VSS 0.025f ; **FLOATING
C2113 VDD.n528 VSS 0.02286f ; **FLOATING
C2114 VDD.n529 VSS 0.42382f ; **FLOATING
C2115 VDD.n530 VSS 0.42005f ; **FLOATING
C2116 VDD.n531 VSS 0.96996f ; **FLOATING
C2117 VDD.n532 VSS 0.025f ; **FLOATING
C2118 VDD.t328 VSS 0.04472f ; **FLOATING
C2119 VDD.t16 VSS 0.04472f ; **FLOATING
C2120 VDD.t270 VSS 0.04472f ; **FLOATING
C2121 VDD.t7 VSS 0.04472f ; **FLOATING
C2122 VDD.t23 VSS 0.04472f ; **FLOATING
C2123 VDD.t261 VSS 0.04487f ; **FLOATING
C2124 VDD.t332 VSS 0.04472f ; **FLOATING
C2125 VDD.t219 VSS 0.04016f ; **FLOATING
C2126 VDD.t20 VSS 0.04472f ; **FLOATING
C2127 VDD.t149 VSS 0.0587f ; **FLOATING
C2128 VDD.t92 VSS 0.04472f ; **FLOATING
C2129 VDD.t29 VSS 0.04015f ; **FLOATING
C2130 VDD.t124 VSS 0.04016f ; **FLOATING
C2131 VDD.t104 VSS 0.05891f ; **FLOATING
C2132 VDD.t123 VSS 0.04311f ; **FLOATING
C2133 VDD.t398 VSS 0.14831f ; **FLOATING
C2134 VDD.n533 VSS 0.025f ; **FLOATING
C2135 VDD.n534 VSS 0.025f ; **FLOATING
C2136 VDD.n535 VSS 0.025f ; **FLOATING
C2137 VDD.t221 VSS 0.04015f ; **FLOATING
C2138 VDD.t94 VSS 0.04472f ; **FLOATING
C2139 VDD.n536 VSS 0.025f ; **FLOATING
C2140 VDD.t34 VSS 0.04472f ; **FLOATING
C2141 VDD.t217 VSS 0.04472f ; **FLOATING
C2142 VDD.n537 VSS 0.025f ; **FLOATING
C2143 VDD.n538 VSS 0.025f ; **FLOATING
C2144 VDD.n539 VSS 0.025f ; **FLOATING
C2145 VDD.t148 VSS 0.04472f ; **FLOATING
C2146 VDD.t15 VSS 0.04016f ; **FLOATING
C2147 VDD.n540 VSS 0.025f ; **FLOATING
C2148 VDD.t14 VSS 0.04311f ; **FLOATING
C2149 VDD.t396 VSS 0.14831f ; **FLOATING
C2150 VDD.n541 VSS 0.025f ; **FLOATING
C2151 VDD.t381 VSS 0.04472f ; **FLOATING
C2152 VDD.t178 VSS 0.04015f ; **FLOATING
C2153 VDD.n542 VSS 0.025f ; **FLOATING
C2154 VDD.t150 VSS 0.05891f ; **FLOATING
C2155 VDD.t179 VSS 0.04311f ; **FLOATING
C2156 VDD.t395 VSS 0.14831f ; **FLOATING
C2157 VDD.n543 VSS 0.025f ; **FLOATING
C2158 VDD.t218 VSS 0.04015f ; **FLOATING
C2159 VDD.n544 VSS 0.025f ; **FLOATING
C2160 VDD.t95 VSS 0.04472f ; **FLOATING
C2161 VDD.n545 VSS 0.025f ; **FLOATING
C2162 VDD.t93 VSS 0.04472f ; **FLOATING
C2163 VDD.t102 VSS 0.04472f ; **FLOATING
C2164 VDD.n546 VSS 0.02457f ; **FLOATING
C2165 VDD.n547 VSS 0.025f ; **FLOATING
C2166 VDD.n548 VSS 0.02457f ; **FLOATING
C2167 VDD.t174 VSS 0.04472f ; **FLOATING
C2168 VDD.t252 VSS 0.04016f ; **FLOATING
C2169 VDD.n549 VSS 0.02457f ; **FLOATING
C2170 VDD.t251 VSS 0.04311f ; **FLOATING
C2171 VDD.t393 VSS 0.14831f ; **FLOATING
C2172 VDD.n550 VSS 0.02457f ; **FLOATING
C2173 VDD.t349 VSS 0.04472f ; **FLOATING
C2174 VDD.t278 VSS 0.04015f ; **FLOATING
C2175 VDD.n551 VSS 0.025f ; **FLOATING
C2176 VDD.t91 VSS 0.05891f ; **FLOATING
C2177 VDD.t108 VSS 0.04311f ; **FLOATING
C2178 VDD.t392 VSS 0.14831f ; **FLOATING
C2179 VDD.n552 VSS 0.02457f ; **FLOATING
C2180 VDD.t107 VSS 0.04015f ; **FLOATING
C2181 VDD.n553 VSS 0.02457f ; **FLOATING
C2182 VDD.t226 VSS 0.04472f ; **FLOATING
C2183 VDD.n554 VSS 0.025f ; **FLOATING
C2184 VDD.t89 VSS 0.04472f ; **FLOATING
C2185 VDD.t279 VSS 0.04472f ; **FLOATING
C2186 VDD.n555 VSS 0.025f ; **FLOATING
C2187 VDD.n556 VSS 0.025f ; **FLOATING
C2188 VDD.t127 VSS 0.0587f ; **FLOATING
C2189 VDD.n557 VSS 0.025f ; **FLOATING
C2190 VDD.n558 VSS 0.025f ; **FLOATING
C2191 VDD.t378 VSS 0.04472f ; **FLOATING
C2192 VDD.n559 VSS 0.025f ; **FLOATING
C2193 VDD.t84 VSS 0.04748f ; **FLOATING
C2194 VDD.n560 VSS 0.025f ; **FLOATING
C2195 VDD.t85 VSS 0.08384f ; **FLOATING
C2196 VDD.n561 VSS 0.025f ; **FLOATING
C2197 VDD.t333 VSS 0.04472f ; **FLOATING
C2198 VDD.t216 VSS 0.04472f ; **FLOATING
C2199 VDD.n562 VSS 0.025f ; **FLOATING
C2200 VDD.n563 VSS 0.025f ; **FLOATING
C2201 VDD.n564 VSS 0.025f ; **FLOATING
C2202 VDD.t198 VSS 0.04472f ; **FLOATING
C2203 VDD.t118 VSS 0.04016f ; **FLOATING
C2204 VDD.n565 VSS 0.025f ; **FLOATING
C2205 VDD.t117 VSS 0.04311f ; **FLOATING
C2206 VDD.t390 VSS 0.14831f ; **FLOATING
C2207 VDD.n566 VSS 0.025f ; **FLOATING
C2208 VDD.t380 VSS 0.04472f ; **FLOATING
C2209 VDD.t215 VSS 0.04015f ; **FLOATING
C2210 VDD.n567 VSS 0.025f ; **FLOATING
C2211 VDD.t370 VSS 0.05891f ; **FLOATING
C2212 VDD.t223 VSS 0.04311f ; **FLOATING
C2213 VDD.t389 VSS 0.14831f ; **FLOATING
C2214 VDD.n568 VSS 0.025f ; **FLOATING
C2215 VDD.t222 VSS 0.04015f ; **FLOATING
C2216 VDD.n569 VSS 0.025f ; **FLOATING
C2217 VDD.t96 VSS 0.04472f ; **FLOATING
C2218 VDD.n570 VSS 0.025f ; **FLOATING
C2219 VDD.t35 VSS 0.04472f ; **FLOATING
C2220 VDD.t101 VSS 0.04472f ; **FLOATING
C2221 VDD.n571 VSS 0.025f ; **FLOATING
C2222 VDD.n572 VSS 0.025f ; **FLOATING
C2223 VDD.n573 VSS 0.025f ; **FLOATING
C2224 VDD.t347 VSS 0.04472f ; **FLOATING
C2225 VDD.t249 VSS 0.04016f ; **FLOATING
C2226 VDD.n574 VSS 0.025f ; **FLOATING
C2227 VDD.t248 VSS 0.04311f ; **FLOATING
C2228 VDD.t387 VSS 0.14831f ; **FLOATING
C2229 VDD.n575 VSS 0.025f ; **FLOATING
C2230 VDD.t346 VSS 0.04472f ; **FLOATING
C2231 VDD.t352 VSS 0.04015f ; **FLOATING
C2232 VDD.n576 VSS 0.025f ; **FLOATING
C2233 VDD.t131 VSS 0.05891f ; **FLOATING
C2234 VDD.t243 VSS 0.04311f ; **FLOATING
C2235 VDD.t386 VSS 0.14831f ; **FLOATING
C2236 VDD.n577 VSS 0.025f ; **FLOATING
C2237 VDD.t275 VSS 0.04015f ; **FLOATING
C2238 VDD.n578 VSS 0.025f ; **FLOATING
C2239 VDD.t202 VSS 0.04472f ; **FLOATING
C2240 VDD.n579 VSS 0.025f ; **FLOATING
C2241 VDD.t337 VSS 0.04472f ; **FLOATING
C2242 VDD.t280 VSS 0.04472f ; **FLOATING
C2243 VDD.n580 VSS 0.02457f ; **FLOATING
C2244 VDD.n581 VSS 0.025f ; **FLOATING
C2245 VDD.n582 VSS 0.02457f ; **FLOATING
C2246 VDD.t142 VSS 0.04472f ; **FLOATING
C2247 VDD.t116 VSS 0.04016f ; **FLOATING
C2248 VDD.n583 VSS 0.02457f ; **FLOATING
C2249 VDD.t115 VSS 0.04311f ; **FLOATING
C2250 VDD.t384 VSS 0.14831f ; **FLOATING
C2251 VDD.n584 VSS 0.02457f ; **FLOATING
C2252 VDD.t132 VSS 0.04472f ; **FLOATING
C2253 VDD.t169 VSS 0.04015f ; **FLOATING
C2254 VDD.n585 VSS 0.025f ; **FLOATING
C2255 VDD.t206 VSS 0.05891f ; **FLOATING
C2256 VDD.t176 VSS 0.04311f ; **FLOATING
C2257 VDD.t383 VSS 0.14831f ; **FLOATING
C2258 VDD.n586 VSS 0.02457f ; **FLOATING
C2259 VDD.t281 VSS 0.04015f ; **FLOATING
C2260 VDD.n587 VSS 0.02457f ; **FLOATING
C2261 VDD.t125 VSS 0.04472f ; **FLOATING
C2262 VDD.n588 VSS 0.025f ; **FLOATING
C2263 VDD.t220 VSS 0.04472f ; **FLOATING
C2264 VDD.t157 VSS 0.04472f ; **FLOATING
C2265 VDD.n589 VSS 0.025f ; **FLOATING
C2266 VDD.n590 VSS 0.07777f ; **FLOATING
C2267 VDD.n591 VSS 0.025f ; **FLOATING
C2268 VDD.t8 VSS 0.0587f ; **FLOATING
C2269 VDD.t325 VSS 0.04472f ; **FLOATING
C2270 VDD.n592 VSS 0.03476f ; **FLOATING
C2271 VDD.n593 VSS 0.025f ; **FLOATING
C2272 VDD.n594 VSS 0.03506f ; **FLOATING
C2273 VDD.n595 VSS 0.025f ; **FLOATING
C2274 VDD.n596 VSS 0.025f ; **FLOATING
C2275 VDD.n597 VSS 0.025f ; **FLOATING
C2276 VDD.n598 VSS 0.025f ; **FLOATING
C2277 VDD.n599 VSS 0.025f ; **FLOATING
C2278 VDD.n600 VSS 0.025f ; **FLOATING
C2279 VDD.t283 VSS 0.04472f ; **FLOATING
C2280 VDD.n601 VSS 0.02829f ; **FLOATING
C2281 VDD.n602 VSS 0.0375f ; **FLOATING
C2282 VDD.n603 VSS 0.025f ; **FLOATING
C2283 VDD.n604 VSS 0.025f ; **FLOATING
C2284 VDD.n605 VSS 0.0375f ; **FLOATING
C2285 VDD.n606 VSS 0.02037f ; **FLOATING
C2286 VDD.t177 VSS 0.04016f ; **FLOATING
C2287 VDD.n607 VSS 0.02457f ; **FLOATING
C2288 VDD.n608 VSS 0.025f ; **FLOATING
C2289 VDD.n609 VSS 0.025f ; **FLOATING
C2290 VDD.n610 VSS 0.025f ; **FLOATING
C2291 VDD.t139 VSS 0.04472f ; **FLOATING
C2292 VDD.t350 VSS 0.04015f ; **FLOATING
C2293 VDD.n611 VSS 0.025f ; **FLOATING
C2294 VDD.n612 VSS 0.02457f ; **FLOATING
C2295 VDD.n613 VSS 0.02457f ; **FLOATING
C2296 VDD.n614 VSS 0.02457f ; **FLOATING
C2297 VDD.n615 VSS 0.025f ; **FLOATING
C2298 VDD.n616 VSS 0.025f ; **FLOATING
C2299 VDD.n617 VSS 0.025f ; **FLOATING
C2300 VDD.n618 VSS 0.025f ; **FLOATING
C2301 VDD.n619 VSS 0.02457f ; **FLOATING
C2302 VDD.t277 VSS 0.04311f ; **FLOATING
C2303 VDD.t385 VSS 0.14831f ; **FLOATING
C2304 VDD.t22 VSS 0.0587f ; **FLOATING
C2305 VDD.t276 VSS 0.04016f ; **FLOATING
C2306 VDD.n620 VSS 0.02457f ; **FLOATING
C2307 VDD.n621 VSS 0.025f ; **FLOATING
C2308 VDD.n622 VSS 0.025f ; **FLOATING
C2309 VDD.n623 VSS 0.025f ; **FLOATING
C2310 VDD.n624 VSS 0.025f ; **FLOATING
C2311 VDD.n625 VSS 0.02457f ; **FLOATING
C2312 VDD.t272 VSS 0.04472f ; **FLOATING
C2313 VDD.n626 VSS 0.0278f ; **FLOATING
C2314 VDD.n627 VSS 0.0375f ; **FLOATING
C2315 VDD.n628 VSS 0.025f ; **FLOATING
C2316 VDD.n629 VSS 0.025f ; **FLOATING
C2317 VDD.n630 VSS 0.0375f ; **FLOATING
C2318 VDD.n631 VSS 0.02072f ; **FLOATING
C2319 VDD.t244 VSS 0.04016f ; **FLOATING
C2320 VDD.n632 VSS 0.025f ; **FLOATING
C2321 VDD.n633 VSS 0.025f ; **FLOATING
C2322 VDD.n634 VSS 0.025f ; **FLOATING
C2323 VDD.n635 VSS 0.025f ; **FLOATING
C2324 VDD.t362 VSS 0.04472f ; **FLOATING
C2325 VDD.t119 VSS 0.04015f ; **FLOATING
C2326 VDD.n636 VSS 0.025f ; **FLOATING
C2327 VDD.n637 VSS 0.025f ; **FLOATING
C2328 VDD.n638 VSS 0.025f ; **FLOATING
C2329 VDD.n639 VSS 0.025f ; **FLOATING
C2330 VDD.n640 VSS 0.025f ; **FLOATING
C2331 VDD.n641 VSS 0.025f ; **FLOATING
C2332 VDD.n642 VSS 0.025f ; **FLOATING
C2333 VDD.n643 VSS 0.025f ; **FLOATING
C2334 VDD.n644 VSS 0.025f ; **FLOATING
C2335 VDD.t120 VSS 0.04311f ; **FLOATING
C2336 VDD.t388 VSS 0.14831f ; **FLOATING
C2337 VDD.t230 VSS 0.0587f ; **FLOATING
C2338 VDD.t351 VSS 0.04016f ; **FLOATING
C2339 VDD.n645 VSS 0.025f ; **FLOATING
C2340 VDD.n646 VSS 0.025f ; **FLOATING
C2341 VDD.n647 VSS 0.025f ; **FLOATING
C2342 VDD.n648 VSS 0.025f ; **FLOATING
C2343 VDD.n649 VSS 0.025f ; **FLOATING
C2344 VDD.n650 VSS 0.025f ; **FLOATING
C2345 VDD.t129 VSS 0.04472f ; **FLOATING
C2346 VDD.n651 VSS 0.02829f ; **FLOATING
C2347 VDD.n652 VSS 0.0375f ; **FLOATING
C2348 VDD.n653 VSS 0.025f ; **FLOATING
C2349 VDD.n654 VSS 0.025f ; **FLOATING
C2350 VDD.n655 VSS 0.0375f ; **FLOATING
C2351 VDD.n656 VSS 0.02072f ; **FLOATING
C2352 VDD.t225 VSS 0.04016f ; **FLOATING
C2353 VDD.n657 VSS 0.025f ; **FLOATING
C2354 VDD.n658 VSS 0.025f ; **FLOATING
C2355 VDD.n659 VSS 0.025f ; **FLOATING
C2356 VDD.n660 VSS 0.025f ; **FLOATING
C2357 VDD.t163 VSS 0.04472f ; **FLOATING
C2358 VDD.t200 VSS 0.04015f ; **FLOATING
C2359 VDD.n661 VSS 0.025f ; **FLOATING
C2360 VDD.n662 VSS 0.025f ; **FLOATING
C2361 VDD.n663 VSS 0.025f ; **FLOATING
C2362 VDD.n664 VSS 0.025f ; **FLOATING
C2363 VDD.n665 VSS 0.025f ; **FLOATING
C2364 VDD.n666 VSS 0.025f ; **FLOATING
C2365 VDD.n667 VSS 0.025f ; **FLOATING
C2366 VDD.n668 VSS 0.025f ; **FLOATING
C2367 VDD.n669 VSS 0.025f ; **FLOATING
C2368 VDD.t201 VSS 0.04311f ; **FLOATING
C2369 VDD.t391 VSS 0.14831f ; **FLOATING
C2370 VDD.t113 VSS 0.0587f ; **FLOATING
C2371 VDD.t250 VSS 0.04016f ; **FLOATING
C2372 VDD.n670 VSS 0.025f ; **FLOATING
C2373 VDD.n671 VSS 0.025f ; **FLOATING
C2374 VDD.n672 VSS 0.025f ; **FLOATING
C2375 VDD.n673 VSS 0.025f ; **FLOATING
C2376 VDD.n674 VSS 0.025f ; **FLOATING
C2377 VDD.n675 VSS 0.025f ; **FLOATING
C2378 VDD.t13 VSS 0.04472f ; **FLOATING
C2379 VDD.t153 VSS 0.04472f ; **FLOATING
C2380 VDD.n676 VSS 0.02829f ; **FLOATING
C2381 VDD.n677 VSS 0.0375f ; **FLOATING
C2382 VDD.n678 VSS 0.03776f ; **FLOATING
C2383 VDD.n679 VSS 0.025f ; **FLOATING
C2384 VDD.n680 VSS 0.025f ; **FLOATING
C2385 VDD.t259 VSS 0.0587f ; **FLOATING
C2386 VDD.n681 VSS 0.025f ; **FLOATING
C2387 VDD.n682 VSS 0.025f ; **FLOATING
C2388 VDD.n683 VSS 0.025f ; **FLOATING
C2389 VDD.n684 VSS 0.025f ; **FLOATING
C2390 VDD.n685 VSS 0.025f ; **FLOATING
C2391 VDD.n686 VSS 0.025f ; **FLOATING
C2392 VDD.t268 VSS 0.04472f ; **FLOATING
C2393 VDD.t99 VSS 0.04472f ; **FLOATING
C2394 VDD.t138 VSS 0.04472f ; **FLOATING
C2395 VDD.n687 VSS 0.02171f ; **FLOATING
C2396 VDD.n688 VSS 0.0375f ; **FLOATING
C2397 VDD.n689 VSS 0.03789f ; **FLOATING
C2398 VDD.n690 VSS 0.025f ; **FLOATING
C2399 VDD.n691 VSS 0.025f ; **FLOATING
C2400 VDD.n692 VSS 0.025f ; **FLOATING
C2401 VDD.n693 VSS 0.025f ; **FLOATING
C2402 VDD.n694 VSS 0.025f ; **FLOATING
C2403 VDD.n695 VSS 0.025f ; **FLOATING
C2404 VDD.n696 VSS 0.025f ; **FLOATING
C2405 VDD.n697 VSS 0.025f ; **FLOATING
C2406 VDD.t343 VSS 0.04472f ; **FLOATING
C2407 VDD.n698 VSS 0.02829f ; **FLOATING
C2408 VDD.n699 VSS 0.0375f ; **FLOATING
C2409 VDD.n700 VSS 0.025f ; **FLOATING
C2410 VDD.n701 VSS 0.025f ; **FLOATING
C2411 VDD.n702 VSS 0.0375f ; **FLOATING
C2412 VDD.n703 VSS 0.02037f ; **FLOATING
C2413 VDD.t364 VSS 0.04016f ; **FLOATING
C2414 VDD.n704 VSS 0.02457f ; **FLOATING
C2415 VDD.n705 VSS 0.025f ; **FLOATING
C2416 VDD.n706 VSS 0.025f ; **FLOATING
C2417 VDD.n707 VSS 0.025f ; **FLOATING
C2418 VDD.t361 VSS 0.04472f ; **FLOATING
C2419 VDD.t173 VSS 0.04015f ; **FLOATING
C2420 VDD.n708 VSS 0.025f ; **FLOATING
C2421 VDD.n709 VSS 0.02457f ; **FLOATING
C2422 VDD.n710 VSS 0.02457f ; **FLOATING
C2423 VDD.n711 VSS 0.02457f ; **FLOATING
C2424 VDD.n712 VSS 0.025f ; **FLOATING
C2425 VDD.n713 VSS 0.025f ; **FLOATING
C2426 VDD.n714 VSS 0.025f ; **FLOATING
C2427 VDD.n715 VSS 0.025f ; **FLOATING
C2428 VDD.n716 VSS 0.02457f ; **FLOATING
C2429 VDD.t166 VSS 0.04311f ; **FLOATING
C2430 VDD.t394 VSS 0.14831f ; **FLOATING
C2431 VDD.t41 VSS 0.0587f ; **FLOATING
C2432 VDD.t165 VSS 0.04016f ; **FLOATING
C2433 VDD.n717 VSS 0.02457f ; **FLOATING
C2434 VDD.n718 VSS 0.025f ; **FLOATING
C2435 VDD.n719 VSS 0.025f ; **FLOATING
C2436 VDD.n720 VSS 0.025f ; **FLOATING
C2437 VDD.n721 VSS 0.025f ; **FLOATING
C2438 VDD.n722 VSS 0.02457f ; **FLOATING
C2439 VDD.t232 VSS 0.04472f ; **FLOATING
C2440 VDD.n723 VSS 0.0278f ; **FLOATING
C2441 VDD.n724 VSS 0.0375f ; **FLOATING
C2442 VDD.n725 VSS 0.025f ; **FLOATING
C2443 VDD.n726 VSS 0.025f ; **FLOATING
C2444 VDD.n727 VSS 0.0375f ; **FLOATING
C2445 VDD.n728 VSS 0.02072f ; **FLOATING
C2446 VDD.t180 VSS 0.04016f ; **FLOATING
C2447 VDD.n729 VSS 0.025f ; **FLOATING
C2448 VDD.n730 VSS 0.025f ; **FLOATING
C2449 VDD.n731 VSS 0.025f ; **FLOATING
C2450 VDD.n732 VSS 0.025f ; **FLOATING
C2451 VDD.t373 VSS 0.04472f ; **FLOATING
C2452 VDD.t164 VSS 0.04015f ; **FLOATING
C2453 VDD.n733 VSS 0.025f ; **FLOATING
C2454 VDD.n734 VSS 0.025f ; **FLOATING
C2455 VDD.n735 VSS 0.025f ; **FLOATING
C2456 VDD.n736 VSS 0.025f ; **FLOATING
C2457 VDD.n737 VSS 0.025f ; **FLOATING
C2458 VDD.n738 VSS 0.025f ; **FLOATING
C2459 VDD.n739 VSS 0.025f ; **FLOATING
C2460 VDD.n740 VSS 0.025f ; **FLOATING
C2461 VDD.n741 VSS 0.025f ; **FLOATING
C2462 VDD.t122 VSS 0.04311f ; **FLOATING
C2463 VDD.t397 VSS 0.14831f ; **FLOATING
C2464 VDD.t199 VSS 0.0587f ; **FLOATING
C2465 VDD.t121 VSS 0.04016f ; **FLOATING
C2466 VDD.n742 VSS 0.025f ; **FLOATING
C2467 VDD.n743 VSS 0.025f ; **FLOATING
C2468 VDD.n744 VSS 0.025f ; **FLOATING
C2469 VDD.n745 VSS 0.025f ; **FLOATING
C2470 VDD.n746 VSS 0.025f ; **FLOATING
C2471 VDD.n747 VSS 0.025f ; **FLOATING
C2472 VDD.t341 VSS 0.04472f ; **FLOATING
C2473 VDD.n748 VSS 0.02829f ; **FLOATING
C2474 VDD.n749 VSS 0.0375f ; **FLOATING
C2475 VDD.n750 VSS 0.0375f ; **FLOATING
C2476 VDD.n751 VSS 0.02072f ; **FLOATING
C2477 VDD.n752 VSS 0.025f ; **FLOATING
C2478 VDD.n753 VSS 0.025f ; **FLOATING
C2479 VDD.n754 VSS 0.025f ; **FLOATING
C2480 VDD.n755 VSS 0.025f ; **FLOATING
C2481 VDD.n756 VSS 0.025f ; **FLOATING
C2482 VDD.n757 VSS 0.025f ; **FLOATING
C2483 VDD.n758 VSS 0.025f ; **FLOATING
C2484 VDD.n759 VSS 0.025f ; **FLOATING
C2485 VDD.n760 VSS 0.025f ; **FLOATING
C2486 VDD.n761 VSS 0.025f ; **FLOATING
C2487 VDD.n762 VSS 0.025f ; **FLOATING
C2488 VDD.n763 VSS 0.025f ; **FLOATING
C2489 VDD.n764 VSS 0.025f ; **FLOATING
C2490 VDD.n765 VSS 0.025f ; **FLOATING
C2491 VDD.n766 VSS 0.025f ; **FLOATING
C2492 VDD.t339 VSS 0.04472f ; **FLOATING
C2493 VDD.n767 VSS 0.025f ; **FLOATING
C2494 VDD.n768 VSS 0.025f ; **FLOATING
C2495 VDD.n769 VSS 0.025f ; **FLOATING
C2496 VDD.n770 VSS 0.025f ; **FLOATING
C2497 VDD.n771 VSS 0.025f ; **FLOATING
C2498 VDD.n772 VSS 0.025f ; **FLOATING
C2499 VDD.n773 VSS 0.025f ; **FLOATING
C2500 VDD.t83 VSS 0.04984f ; **FLOATING
C2501 VDD.t33 VSS 0.04984f ; **FLOATING
C2502 VDD.n774 VSS 0.025f ; **FLOATING
C2503 VDD.n775 VSS 0.025f ; **FLOATING
C2504 VDD.n776 VSS 0.025f ; **FLOATING
C2505 VDD.n777 VSS 0.025f ; **FLOATING
C2506 VDD.n778 VSS 0.025f ; **FLOATING
C2507 VDD.n779 VSS 0.025f ; **FLOATING
C2508 VDD.n780 VSS 0.025f ; **FLOATING
C2509 VDD.n781 VSS 0.025f ; **FLOATING
C2510 VDD.n782 VSS 0.025f ; **FLOATING
C2511 VDD.n783 VSS 0.025f ; **FLOATING
C2512 VDD.n784 VSS 0.025f ; **FLOATING
C2513 VDD.n785 VSS 0.025f ; **FLOATING
C2514 VDD.n786 VSS 0.025f ; **FLOATING
C2515 VDD.n787 VSS 0.025f ; **FLOATING
C2516 VDD.n788 VSS 0.025f ; **FLOATING
C2517 VDD.n789 VSS 0.025f ; **FLOATING
C2518 VDD.t87 VSS 0.03302f ; **FLOATING
C2519 VDD.t171 VSS 0.03302f ; **FLOATING
C2520 VDD.n790 VSS 0.025f ; **FLOATING
C2521 VDD.t98 VSS 0.04414f ; **FLOATING
C2522 VDD.t329 VSS 0.04414f ; **FLOATING
C2523 VDD.n791 VSS 0.025f ; **FLOATING
C2524 VDD.n792 VSS 0.025f ; **FLOATING
C2525 VDD.t287 VSS 0.04984f ; **FLOATING
C2526 VDD.t330 VSS 0.04984f ; **FLOATING
C2527 VDD.n793 VSS 0.025f ; **FLOATING
C2528 VDD.t326 VSS 0.03302f ; **FLOATING
C2529 VDD.t18 VSS 0.03302f ; **FLOATING
C2530 VDD.n794 VSS 0.025f ; **FLOATING
C2531 VDD.t24 VSS 0.04414f ; **FLOATING
C2532 VDD.t264 VSS 0.04414f ; **FLOATING
C2533 VDD.n795 VSS 0.025f ; **FLOATING
C2534 VDD.n796 VSS 0.025f ; **FLOATING
C2535 VDD.t25 VSS 0.04984f ; **FLOATING
C2536 VDD.t265 VSS 0.04984f ; **FLOATING
C2537 VDD.n797 VSS 0.025f ; **FLOATING
C2538 VDD.t271 VSS 0.03302f ; **FLOATING
C2539 VDD.t6 VSS 0.03302f ; **FLOATING
C2540 VDD.n798 VSS 0.025f ; **FLOATING
C2541 VDD.t86 VSS 0.04414f ; **FLOATING
C2542 VDD.t136 VSS 0.04414f ; **FLOATING
C2543 VDD.n799 VSS 0.025f ; **FLOATING
C2544 VDD.t267 VSS 0.04984f ; **FLOATING
C2545 VDD.t137 VSS 0.04984f ; **FLOATING
C2546 VDD.n800 VSS 0.025f ; **FLOATING
C2547 VDD.t327 VSS 0.03302f ; **FLOATING
C2548 VDD.t17 VSS 0.03302f ; **FLOATING
C2549 VDD.n801 VSS 0.025f ; **FLOATING
C2550 VDD.n802 VSS 0.025f ; **FLOATING
C2551 VDD.t82 VSS 0.04414f ; **FLOATING
C2552 VDD.t5 VSS 0.04414f ; **FLOATING
C2553 VDD.n803 VSS 0.025f ; **FLOATING
C2554 VDD.n804 VSS 0.05041f ; **FLOATING
C2555 VDD.n805 VSS 0.05028f ; **FLOATING
C2556 VDD.n806 VSS 0.025f ; **FLOATING
C2557 VDD.t382 VSS 0.04472f ; **FLOATING
C2558 VDD.n807 VSS 0.025f ; **FLOATING
C2559 VDD.n808 VSS 0.025f ; **FLOATING
C2560 VDD.n809 VSS 0.025f ; **FLOATING
C2561 VDD.t156 VSS 0.0587f ; **FLOATING
C2562 VDD.n810 VSS 0.025f ; **FLOATING
C2563 VDD.n811 VSS 0.025f ; **FLOATING
C2564 VDD.n812 VSS 0.025f ; **FLOATING
C2565 VDD.n813 VSS 0.03776f ; **FLOATING
C2566 VDD.n814 VSS 0.0375f ; **FLOATING
C2567 VDD.n815 VSS 0.02829f ; **FLOATING
C2568 VDD.t76 VSS 0.04472f ; **FLOATING
C2569 VDD.n816 VSS 0.025f ; **FLOATING
C2570 VDD.t126 VSS 0.04472f ; **FLOATING
C2571 VDD.n817 VSS 0.025f ; **FLOATING
C2572 VDD.n818 VSS 0.025f ; **FLOATING
C2573 VDD.t253 VSS 0.04016f ; **FLOATING
C2574 VDD.n819 VSS 0.025f ; **FLOATING
C2575 VDD.n820 VSS 0.025f ; **FLOATING
C2576 VDD.t254 VSS 0.04311f ; **FLOATING
C2577 VDD.t400 VSS 0.14831f ; **FLOATING
C2578 VDD.n821 VSS 0.025f ; **FLOATING
C2579 VDD.n822 VSS 0.025f ; **FLOATING
C2580 VDD.t324 VSS 0.04472f ; **FLOATING
C2581 VDD.t255 VSS 0.04015f ; **FLOATING
C2582 VDD.n823 VSS 0.025f ; **FLOATING
C2583 VDD.n824 VSS 0.025f ; **FLOATING
C2584 VDD.t30 VSS 0.04311f ; **FLOATING
C2585 VDD.t399 VSS 0.14831f ; **FLOATING
C2586 VDD.n825 VSS 0.025f ; **FLOATING
C2587 VDD.n826 VSS 0.025f ; **FLOATING
C2588 VDD.n827 VSS 0.025f ; **FLOATING
C2589 VDD.n828 VSS 0.025f ; **FLOATING
C2590 VDD.n829 VSS 0.025f ; **FLOATING
C2591 VDD.n830 VSS 0.025f ; **FLOATING
C2592 VDD.n831 VSS 0.025f ; **FLOATING
C2593 VDD.n832 VSS 0.025f ; **FLOATING
C2594 VDD.n833 VSS 0.1806f ; **FLOATING
C2595 VDD.t71 VSS 0.09062f ; **FLOATING
C2596 VDD.t67 VSS 0.04385f ; **FLOATING
C2597 VDD.t65 VSS 0.03133f ; **FLOATING
C2598 VDD.n834 VSS 0.025f ; **FLOATING
C2599 VDD.n835 VSS 0.025f ; **FLOATING
C2600 VDD.n836 VSS 0.025f ; **FLOATING
C2601 VDD.n837 VSS 0.025f ; **FLOATING
C2602 VDD.n838 VSS 0.025f ; **FLOATING
C2603 VDD.n839 VSS 0.025f ; **FLOATING
C2604 VDD.n840 VSS 0.025f ; **FLOATING
C2605 VDD.n841 VSS 0.025f ; **FLOATING
C2606 VDD.n842 VSS 0.025f ; **FLOATING
C2607 VDD.n843 VSS 0.025f ; **FLOATING
C2608 VDD.n844 VSS 0.025f ; **FLOATING
C2609 VDD.n845 VSS 0.025f ; **FLOATING
C2610 VDD.n846 VSS 0.025f ; **FLOATING
C2611 VDD.n847 VSS 0.025f ; **FLOATING
C2612 VDD.n848 VSS 0.025f ; **FLOATING
C2613 VDD.n849 VSS 0.025f ; **FLOATING
C2614 VDD.n850 VSS 0.025f ; **FLOATING
C2615 VDD.n851 VSS 0.025f ; **FLOATING
C2616 VDD.n852 VSS 0.025f ; **FLOATING
C2617 VDD.n853 VSS 0.025f ; **FLOATING
C2618 VDD.n854 VSS 0.025f ; **FLOATING
C2619 VDD.n855 VSS 0.025f ; **FLOATING
C2620 VDD.n856 VSS 0.025f ; **FLOATING
C2621 VDD.n857 VSS 0.025f ; **FLOATING
C2622 VDD.n858 VSS 0.025f ; **FLOATING
C2623 VDD.n859 VSS 0.025f ; **FLOATING
C2624 VDD.n860 VSS 0.025f ; **FLOATING
C2625 VDD.n861 VSS 0.025f ; **FLOATING
C2626 VDD.n862 VSS 0.025f ; **FLOATING
C2627 VDD.n863 VSS 0.025f ; **FLOATING
C2628 VDD.n864 VSS 0.025f ; **FLOATING
C2629 VDD.n865 VSS 0.025f ; **FLOATING
C2630 VDD.n866 VSS 0.025f ; **FLOATING
C2631 VDD.n867 VSS 0.025f ; **FLOATING
C2632 VDD.n868 VSS 0.025f ; **FLOATING
C2633 VDD.n869 VSS 0.025f ; **FLOATING
C2634 VDD.t315 VSS 0.0432f ; **FLOATING
C2635 VDD.n870 VSS 0.025f ; **FLOATING
C2636 VDD.n871 VSS 0.025f ; **FLOATING
C2637 VDD.n872 VSS 0.025f ; **FLOATING
C2638 VDD.n873 VSS 0.025f ; **FLOATING
C2639 VDD.n874 VSS 0.025f ; **FLOATING
C2640 VDD.n875 VSS 0.025f ; **FLOATING
C2641 VDD.n876 VSS 0.025f ; **FLOATING
C2642 VDD.n877 VSS 0.025f ; **FLOATING
C2643 VDD.t293 VSS 0.0432f ; **FLOATING
C2644 VDD.n878 VSS 0.16905f ; **FLOATING
C2645 VDD.n879 VSS 0.025f ; **FLOATING
C2646 VDD.n880 VSS 0.025f ; **FLOATING
C2647 VDD.n881 VSS 0.025f ; **FLOATING
C2648 VDD.n882 VSS 0.025f ; **FLOATING
C2649 VDD.n883 VSS 0.025f ; **FLOATING
C2650 VDD.n884 VSS 0.025f ; **FLOATING
C2651 VDD.n885 VSS 0.025f ; **FLOATING
C2652 VDD.n886 VSS 0.025f ; **FLOATING
C2653 VDD.n887 VSS 0.025f ; **FLOATING
C2654 VDD.t318 VSS 0.0432f ; **FLOATING
C2655 VDD.n888 VSS 0.025f ; **FLOATING
C2656 VDD.n889 VSS 0.025f ; **FLOATING
C2657 VDD.n890 VSS 0.025f ; **FLOATING
C2658 VDD.n891 VSS 0.025f ; **FLOATING
C2659 VDD.n892 VSS 0.05854f ; **FLOATING
C2660 VDD.t319 VSS 0.0432f ; **FLOATING
C2661 VDD.t320 VSS 0.0432f ; **FLOATING
C2662 VDD.t88 VSS 0.05066f ; **FLOATING
C2663 VDD.t73 VSS 0.04413f ; **FLOATING
C2664 VDD.t72 VSS 0.04828f ; **FLOATING
C2665 VDD.t74 VSS 0.04174f ; **FLOATING
C2666 VDD.t75 VSS 0.0432f ; **FLOATING
C2667 VDD.t336 VSS 0.05066f ; **FLOATING
C2668 VDD.t228 VSS 0.05066f ; **FLOATING
C2669 VDD.t159 VSS 0.05066f ; **FLOATING
C2670 VDD.t143 VSS 0.05066f ; **FLOATING
C2671 VDD.t316 VSS 0.0432f ; **FLOATING
C2672 VDD.n893 VSS 0.36222f ; **FLOATING
C2673 VDD.t11 VSS 0.05066f ; **FLOATING
C2674 VDD.n894 VSS 0.025f ; **FLOATING
C2675 VDD.n895 VSS 0.025f ; **FLOATING
C2676 VDD.n896 VSS 0.025f ; **FLOATING
C2677 VDD.n897 VSS 0.025f ; **FLOATING
C2678 VDD.n898 VSS 0.025f ; **FLOATING
C2679 VDD.n899 VSS 0.025f ; **FLOATING
C2680 VDD.n900 VSS 0.025f ; **FLOATING
C2681 VDD.n901 VSS 0.025f ; **FLOATING
C2682 VDD.n902 VSS 0.025f ; **FLOATING
C2683 VDD.n903 VSS 0.025f ; **FLOATING
C2684 VDD.n904 VSS 0.025f ; **FLOATING
C2685 VDD.n905 VSS 0.025f ; **FLOATING
C2686 VDD.n906 VSS 0.025f ; **FLOATING
C2687 VDD.n907 VSS 0.025f ; **FLOATING
C2688 VDD.n908 VSS 0.025f ; **FLOATING
C2689 VDD.n909 VSS 0.025f ; **FLOATING
C2690 VDD.n910 VSS 0.025f ; **FLOATING
C2691 VDD.n911 VSS 0.025f ; **FLOATING
C2692 VDD.n912 VSS 0.025f ; **FLOATING
C2693 VDD.n913 VSS 0.025f ; **FLOATING
C2694 VDD.n914 VSS 0.025f ; **FLOATING
C2695 VDD.n915 VSS 0.025f ; **FLOATING
C2696 VDD.n916 VSS 0.025f ; **FLOATING
C2697 VDD.t317 VSS 0.0432f ; **FLOATING
C2698 VDD.t141 VSS 0.05066f ; **FLOATING
C2699 VDD.n917 VSS 0.01875f ; **FLOATING
C2700 VDD.n918 VSS 0.05f ; **FLOATING
C2701 VDD.n919 VSS 0.05f ; **FLOATING
C2702 VDD.t145 VSS 0.05066f ; **FLOATING
C2703 VDD.t288 VSS 0.0432f ; **FLOATING
C2704 VDD.n920 VSS 0.025f ; **FLOATING
C2705 VDD.n921 VSS 0.02517f ; **FLOATING
C2706 VDD.n922 VSS 0.05f ; **FLOATING
C2707 VDD.n923 VSS 0.05024f ; **FLOATING
C2708 VDD.t274 VSS 0.05066f ; **FLOATING
C2709 VDD.n924 VSS 0.025f ; **FLOATING
C2710 VDD.n925 VSS 0.02517f ; **FLOATING
C2711 VDD.n926 VSS 0.05024f ; **FLOATING
C2712 VDD.n927 VSS 0.025f ; **FLOATING
C2713 VDD.n928 VSS 0.05f ; **FLOATING
C2714 VDD.n929 VSS 0.02517f ; **FLOATING
C2715 VDD.n930 VSS 0.025f ; **FLOATING
C2716 VDD.n931 VSS 0.025f ; **FLOATING
C2717 VDD.n932 VSS 0.025f ; **FLOATING
C2718 VDD.n933 VSS 0.025f ; **FLOATING
C2719 VDD.n934 VSS 0.025f ; **FLOATING
C2720 VDD.n935 VSS 0.025f ; **FLOATING
C2721 VDD.n936 VSS 0.025f ; **FLOATING
C2722 VDD.n937 VSS 0.025f ; **FLOATING
C2723 VDD.n938 VSS 0.025f ; **FLOATING
C2724 VDD.n939 VSS 0.025f ; **FLOATING
C2725 VDD.n940 VSS 0.025f ; **FLOATING
C2726 VDD.n941 VSS 0.025f ; **FLOATING
C2727 VDD.n942 VSS 0.025f ; **FLOATING
C2728 VDD.n943 VSS 0.025f ; **FLOATING
C2729 VDD.n944 VSS 0.025f ; **FLOATING
C2730 VDD.n945 VSS 0.025f ; **FLOATING
C2731 VDD.n946 VSS 0.025f ; **FLOATING
C2732 VDD.n947 VSS 0.025f ; **FLOATING
C2733 VDD.n948 VSS 0.025f ; **FLOATING
C2734 VDD.n949 VSS 0.025f ; **FLOATING
C2735 VDD.n950 VSS 0.025f ; **FLOATING
C2736 VDD.n951 VSS 0.025f ; **FLOATING
C2737 VDD.n952 VSS 0.025f ; **FLOATING
C2738 VDD.n953 VSS 0.025f ; **FLOATING
C2739 VDD.n954 VSS 0.025f ; **FLOATING
C2740 VDD.n955 VSS 0.025f ; **FLOATING
C2741 VDD.n956 VSS 0.025f ; **FLOATING
C2742 VDD.n957 VSS 0.025f ; **FLOATING
C2743 VDD.n958 VSS 0.025f ; **FLOATING
C2744 VDD.n959 VSS 0.025f ; **FLOATING
C2745 VDD.n960 VSS 0.025f ; **FLOATING
C2746 VDD.n961 VSS 0.025f ; **FLOATING
C2747 VDD.n962 VSS 0.025f ; **FLOATING
C2748 VDD.n963 VSS 0.025f ; **FLOATING
C2749 VDD.n964 VSS 0.025f ; **FLOATING
C2750 VDD.n965 VSS 0.025f ; **FLOATING
C2751 VDD.n966 VSS 0.025f ; **FLOATING
C2752 VDD.n967 VSS 0.025f ; **FLOATING
C2753 VDD.n968 VSS 0.025f ; **FLOATING
C2754 VDD.n969 VSS 0.025f ; **FLOATING
C2755 VDD.n970 VSS 0.025f ; **FLOATING
C2756 VDD.n971 VSS 0.025f ; **FLOATING
C2757 VDD.n972 VSS 0.025f ; **FLOATING
C2758 VDD.n973 VSS 0.025f ; **FLOATING
C2759 VDD.n974 VSS 0.025f ; **FLOATING
C2760 VDD.n975 VSS 0.025f ; **FLOATING
C2761 VDD.n976 VSS 0.025f ; **FLOATING
C2762 VDD.n977 VSS 0.025f ; **FLOATING
C2763 VDD.n978 VSS 0.025f ; **FLOATING
C2764 VDD.n979 VSS 0.025f ; **FLOATING
C2765 VDD.n980 VSS 0.025f ; **FLOATING
C2766 VDD.n981 VSS 0.025f ; **FLOATING
C2767 VDD.n982 VSS 0.025f ; **FLOATING
C2768 VDD.n983 VSS 0.025f ; **FLOATING
C2769 VDD.n984 VSS 0.025f ; **FLOATING
C2770 VDD.n985 VSS 0.025f ; **FLOATING
C2771 VDD.n986 VSS 0.025f ; **FLOATING
C2772 VDD.n987 VSS 0.025f ; **FLOATING
C2773 VDD.n988 VSS 0.025f ; **FLOATING
C2774 VDD.n989 VSS 0.025f ; **FLOATING
C2775 VDD.n990 VSS 0.025f ; **FLOATING
C2776 VDD.n991 VSS 0.025f ; **FLOATING
C2777 VDD.n992 VSS 0.025f ; **FLOATING
C2778 VDD.n993 VSS 0.025f ; **FLOATING
C2779 VDD.n994 VSS 0.025f ; **FLOATING
C2780 VDD.n995 VSS 0.025f ; **FLOATING
C2781 VDD.n996 VSS 0.025f ; **FLOATING
C2782 VDD.n997 VSS 0.025f ; **FLOATING
C2783 VDD.n998 VSS 0.025f ; **FLOATING
C2784 VDD.n999 VSS 0.025f ; **FLOATING
C2785 VDD.n1000 VSS 0.025f ; **FLOATING
C2786 VDD.n1001 VSS 0.025f ; **FLOATING
C2787 VDD.n1002 VSS 0.025f ; **FLOATING
C2788 VDD.n1003 VSS 0.025f ; **FLOATING
C2789 VDD.n1004 VSS 0.025f ; **FLOATING
C2790 VDD.n1005 VSS 0.025f ; **FLOATING
C2791 VDD.n1006 VSS 0.025f ; **FLOATING
C2792 VDD.n1007 VSS 0.025f ; **FLOATING
C2793 VDD.n1008 VSS 0.025f ; **FLOATING
C2794 VDD.n1009 VSS 0.025f ; **FLOATING
C2795 VDD.n1010 VSS 0.025f ; **FLOATING
C2796 VDD.n1011 VSS 0.025f ; **FLOATING
C2797 VDD.n1012 VSS 0.025f ; **FLOATING
C2798 VDD.n1013 VSS 0.025f ; **FLOATING
C2799 VDD.n1014 VSS 0.025f ; **FLOATING
C2800 VDD.n1015 VSS 0.025f ; **FLOATING
C2801 VDD.n1016 VSS 0.025f ; **FLOATING
C2802 VDD.n1017 VSS 0.025f ; **FLOATING
C2803 VDD.n1018 VSS 0.025f ; **FLOATING
C2804 VDD.n1019 VSS 0.025f ; **FLOATING
C2805 VDD.n1020 VSS 0.025f ; **FLOATING
C2806 VDD.n1021 VSS 0.025f ; **FLOATING
C2807 VDD.n1022 VSS 0.025f ; **FLOATING
C2808 VDD.n1023 VSS 0.025f ; **FLOATING
C2809 VDD.n1024 VSS 0.025f ; **FLOATING
C2810 VDD.n1025 VSS 0.025f ; **FLOATING
C2811 VDD.n1026 VSS 0.025f ; **FLOATING
C2812 VDD.n1027 VSS 0.025f ; **FLOATING
C2813 VDD.n1028 VSS 0.025f ; **FLOATING
C2814 VDD.n1029 VSS 0.025f ; **FLOATING
C2815 VDD.n1030 VSS 0.025f ; **FLOATING
C2816 VDD.n1031 VSS 0.025f ; **FLOATING
C2817 VDD.n1032 VSS 0.025f ; **FLOATING
C2818 VDD.n1033 VSS 0.025f ; **FLOATING
C2819 VDD.n1034 VSS 0.025f ; **FLOATING
C2820 VDD.n1035 VSS 0.025f ; **FLOATING
C2821 VDD.n1036 VSS 0.025f ; **FLOATING
C2822 VDD.n1037 VSS 0.025f ; **FLOATING
C2823 VDD.n1038 VSS 0.025f ; **FLOATING
C2824 VDD.n1039 VSS 0.025f ; **FLOATING
C2825 VDD.n1040 VSS 0.025f ; **FLOATING
C2826 VDD.n1041 VSS 0.025f ; **FLOATING
C2827 VDD.n1042 VSS 0.025f ; **FLOATING
C2828 VDD.n1043 VSS 0.025f ; **FLOATING
C2829 VDD.n1044 VSS 0.025f ; **FLOATING
C2830 VDD.n1045 VSS 0.025f ; **FLOATING
C2831 VDD.n1046 VSS 0.025f ; **FLOATING
C2832 VDD.n1047 VSS 0.025f ; **FLOATING
C2833 VDD.n1048 VSS 0.025f ; **FLOATING
C2834 VDD.n1049 VSS 0.025f ; **FLOATING
C2835 VDD.n1050 VSS 0.025f ; **FLOATING
C2836 VDD.n1051 VSS 0.025f ; **FLOATING
C2837 VDD.n1052 VSS 0.025f ; **FLOATING
C2838 VDD.n1053 VSS 0.025f ; **FLOATING
C2839 VDD.n1054 VSS 0.025f ; **FLOATING
C2840 VDD.n1055 VSS 0.025f ; **FLOATING
C2841 VDD.n1056 VSS 0.025f ; **FLOATING
C2842 VDD.n1057 VSS 0.025f ; **FLOATING
C2843 VDD.n1058 VSS 0.025f ; **FLOATING
C2844 VDD.n1059 VSS 0.025f ; **FLOATING
C2845 VDD.n1060 VSS 0.025f ; **FLOATING
C2846 VDD.n1061 VSS 0.025f ; **FLOATING
C2847 VDD.n1062 VSS 0.41219f ; **FLOATING
C2848 VDD.n1063 VSS 0.025f ; **FLOATING
C2849 VDD.t301 VSS 0.0432f ; **FLOATING
C2850 VDD.n1064 VSS 0.025f ; **FLOATING
C2851 VDD.n1065 VSS 0.025f ; **FLOATING
C2852 VDD.n1066 VSS 0.025f ; **FLOATING
C2853 VDD.n1067 VSS 0.025f ; **FLOATING
C2854 VDD.n1068 VSS 0.025f ; **FLOATING
C2855 VDD.t298 VSS 0.04423f ; **FLOATING
C2856 VDD.n1069 VSS 0.025f ; **FLOATING
C2857 VDD.n1070 VSS 0.025f ; **FLOATING
C2858 VDD.n1071 VSS 0.025f ; **FLOATING
C2859 VDD.n1072 VSS 0.025f ; **FLOATING
C2860 VDD.n1073 VSS 0.025f ; **FLOATING
C2861 VDD.t295 VSS 0.0432f ; **FLOATING
C2862 VDD.n1074 VSS 0.025f ; **FLOATING
C2863 VDD.n1075 VSS 0.025f ; **FLOATING
C2864 VDD.n1076 VSS 0.025f ; **FLOATING
C2865 VDD.n1077 VSS 0.025f ; **FLOATING
C2866 VDD.n1078 VSS 0.025f ; **FLOATING
C2867 VDD.t302 VSS 0.0432f ; **FLOATING
C2868 VDD.n1079 VSS 0.025f ; **FLOATING
C2869 VDD.n1080 VSS 0.025f ; **FLOATING
C2870 VDD.n1081 VSS 0.025f ; **FLOATING
C2871 VDD.n1082 VSS 0.025f ; **FLOATING
C2872 VDD.n1083 VSS 0.025f ; **FLOATING
C2873 VDD.t289 VSS 0.0432f ; **FLOATING
C2874 VDD.n1084 VSS 0.025f ; **FLOATING
C2875 VDD.n1085 VSS 0.025f ; **FLOATING
C2876 VDD.n1086 VSS 0.025f ; **FLOATING
C2877 VDD.n1087 VSS 0.025f ; **FLOATING
C2878 VDD.n1088 VSS 0.025f ; **FLOATING
C2879 VDD.t299 VSS 0.0432f ; **FLOATING
C2880 VDD.n1089 VSS 0.025f ; **FLOATING
C2881 VDD.n1090 VSS 0.025f ; **FLOATING
C2882 VDD.n1091 VSS 0.025f ; **FLOATING
C2883 VDD.n1092 VSS 0.025f ; **FLOATING
C2884 VDD.n1093 VSS 0.025f ; **FLOATING
C2885 VDD.t303 VSS 0.0432f ; **FLOATING
C2886 VDD.n1094 VSS 0.025f ; **FLOATING
C2887 VDD.n1095 VSS 0.025f ; **FLOATING
C2888 VDD.n1096 VSS 0.025f ; **FLOATING
C2889 VDD.n1097 VSS 0.025f ; **FLOATING
C2890 VDD.n1098 VSS 0.025f ; **FLOATING
C2891 VDD.t304 VSS 0.0432f ; **FLOATING
C2892 VDD.n1099 VSS 0.025f ; **FLOATING
C2893 VDD.n1100 VSS 0.025f ; **FLOATING
C2894 VDD.n1101 VSS 0.025f ; **FLOATING
C2895 VDD.n1102 VSS 0.025f ; **FLOATING
C2896 VDD.n1103 VSS 0.025f ; **FLOATING
C2897 VDD.t305 VSS 0.0432f ; **FLOATING
C2898 VDD.n1104 VSS 0.025f ; **FLOATING
C2899 VDD.n1105 VSS 0.025f ; **FLOATING
C2900 VDD.n1106 VSS 0.025f ; **FLOATING
C2901 VDD.n1107 VSS 0.025f ; **FLOATING
C2902 VDD.n1108 VSS 0.025f ; **FLOATING
C2903 VDD.t294 VSS 0.0432f ; **FLOATING
C2904 VDD.n1109 VSS 0.025f ; **FLOATING
C2905 VDD.n1110 VSS 0.025f ; **FLOATING
C2906 VDD.n1111 VSS 0.025f ; **FLOATING
C2907 VDD.n1112 VSS 0.025f ; **FLOATING
C2908 VDD.n1113 VSS 0.025f ; **FLOATING
C2909 VDD.t292 VSS 0.0432f ; **FLOATING
C2910 VDD.n1114 VSS 0.025f ; **FLOATING
C2911 VDD.n1115 VSS 0.025f ; **FLOATING
C2912 VDD.n1116 VSS 0.025f ; **FLOATING
C2913 VDD.n1117 VSS 0.025f ; **FLOATING
C2914 VDD.n1118 VSS 0.025f ; **FLOATING
C2915 VDD.t291 VSS 0.0432f ; **FLOATING
C2916 VDD.n1119 VSS 0.025f ; **FLOATING
C2917 VDD.n1120 VSS 0.025f ; **FLOATING
C2918 VDD.n1121 VSS 0.025f ; **FLOATING
C2919 VDD.n1122 VSS 0.025f ; **FLOATING
C2920 VDD.n1123 VSS 0.025f ; **FLOATING
C2921 VDD.t290 VSS 0.0432f ; **FLOATING
C2922 VDD.n1124 VSS 0.025f ; **FLOATING
C2923 VDD.n1125 VSS 0.025f ; **FLOATING
C2924 VDD.n1126 VSS 0.025f ; **FLOATING
C2925 VDD.n1127 VSS 0.025f ; **FLOATING
C2926 VDD.n1128 VSS 0.025f ; **FLOATING
C2927 VDD.t307 VSS 0.0432f ; **FLOATING
C2928 VDD.n1129 VSS 0.025f ; **FLOATING
C2929 VDD.n1130 VSS 0.025f ; **FLOATING
C2930 VDD.n1131 VSS 0.025f ; **FLOATING
C2931 VDD.n1132 VSS 0.025f ; **FLOATING
C2932 VDD.n1133 VSS 0.025f ; **FLOATING
C2933 VDD.t309 VSS 0.0432f ; **FLOATING
C2934 VDD.n1134 VSS 0.025f ; **FLOATING
C2935 VDD.n1135 VSS 0.025f ; **FLOATING
C2936 VDD.n1136 VSS 0.025f ; **FLOATING
C2937 VDD.n1137 VSS 0.025f ; **FLOATING
C2938 VDD.n1138 VSS 0.025f ; **FLOATING
C2939 VDD.t310 VSS 0.0432f ; **FLOATING
C2940 VDD.n1139 VSS 0.025f ; **FLOATING
C2941 VDD.n1140 VSS 0.025f ; **FLOATING
C2942 VDD.n1141 VSS 0.025f ; **FLOATING
C2943 VDD.n1142 VSS 0.025f ; **FLOATING
C2944 VDD.n1143 VSS 0.025f ; **FLOATING
C2945 VDD.t311 VSS 0.0432f ; **FLOATING
C2946 VDD.n1144 VSS 0.025f ; **FLOATING
C2947 VDD.n1145 VSS 0.025f ; **FLOATING
C2948 VDD.n1146 VSS 0.025f ; **FLOATING
C2949 VDD.n1147 VSS 0.025f ; **FLOATING
C2950 VDD.n1148 VSS 0.025f ; **FLOATING
C2951 VDD.t308 VSS 0.0432f ; **FLOATING
C2952 VDD.n1149 VSS 0.025f ; **FLOATING
C2953 VDD.n1150 VSS 0.025f ; **FLOATING
C2954 VDD.n1151 VSS 0.025f ; **FLOATING
C2955 VDD.n1152 VSS 0.025f ; **FLOATING
C2956 VDD.n1153 VSS 0.025f ; **FLOATING
C2957 VDD.t306 VSS 0.0432f ; **FLOATING
C2958 VDD.n1154 VSS 0.025f ; **FLOATING
C2959 VDD.n1155 VSS 0.025f ; **FLOATING
C2960 VDD.n1156 VSS 0.025f ; **FLOATING
C2961 VDD.n1157 VSS 0.025f ; **FLOATING
C2962 VDD.n1158 VSS 0.025f ; **FLOATING
C2963 VDD.t312 VSS 0.0432f ; **FLOATING
C2964 VDD.n1159 VSS 0.025f ; **FLOATING
C2965 VDD.n1160 VSS 0.025f ; **FLOATING
C2966 VDD.n1161 VSS 0.025f ; **FLOATING
C2967 VDD.n1162 VSS 0.025f ; **FLOATING
C2968 VDD.n1163 VSS 0.025f ; **FLOATING
C2969 VDD.t297 VSS 0.0432f ; **FLOATING
C2970 VDD.n1164 VSS 0.025f ; **FLOATING
C2971 VDD.n1165 VSS 0.025f ; **FLOATING
C2972 VDD.n1166 VSS 0.025f ; **FLOATING
C2973 VDD.n1167 VSS 0.025f ; **FLOATING
C2974 VDD.n1168 VSS 0.025f ; **FLOATING
C2975 VDD.t296 VSS 0.0432f ; **FLOATING
C2976 VDD.n1169 VSS 0.025f ; **FLOATING
C2977 VDD.n1170 VSS 0.025f ; **FLOATING
C2978 VDD.n1171 VSS 0.025f ; **FLOATING
C2979 VDD.n1172 VSS 0.025f ; **FLOATING
C2980 VDD.n1173 VSS 0.025f ; **FLOATING
C2981 VDD.t313 VSS 0.0432f ; **FLOATING
C2982 VDD.n1174 VSS 0.025f ; **FLOATING
C2983 VDD.n1175 VSS 0.025f ; **FLOATING
C2984 VDD.n1176 VSS 0.025f ; **FLOATING
C2985 VDD.n1177 VSS 0.025f ; **FLOATING
C2986 VDD.n1178 VSS 0.025f ; **FLOATING
C2987 VDD.n1179 VSS 0.025f ; **FLOATING
C2988 VDD.t314 VSS 0.0432f ; **FLOATING
C2989 VDD.t31 VSS 0.05066f ; **FLOATING
C2990 VDD.n1180 VSS 0.05024f ; **FLOATING
C2991 VDD.n1181 VSS 0.05f ; **FLOATING
C2992 VDD.n1182 VSS 0.02517f ; **FLOATING
C2993 VDD.t128 VSS 0.05066f ; **FLOATING
C2994 VDD.n1183 VSS 0.05024f ; **FLOATING
C2995 VDD.n1184 VSS 0.05f ; **FLOATING
C2996 VDD.n1185 VSS 0.02517f ; **FLOATING
C2997 VDD.t37 VSS 0.05066f ; **FLOATING
C2998 VDD.n1186 VSS 0.05024f ; **FLOATING
C2999 VDD.n1187 VSS 0.05f ; **FLOATING
C3000 VDD.n1188 VSS 0.02517f ; **FLOATING
C3001 VDD.t161 VSS 0.05066f ; **FLOATING
C3002 VDD.n1189 VSS 0.05024f ; **FLOATING
C3003 VDD.n1190 VSS 0.05032f ; **FLOATING
C3004 VDD.t114 VSS 0.05066f ; **FLOATING
C3005 VDD.n1191 VSS 0.01875f ; **FLOATING
C3006 VDD.n1192 VSS 0.05f ; **FLOATING
C3007 VDD.n1193 VSS 0.05032f ; **FLOATING
C3008 VDD.t12 VSS 0.05066f ; **FLOATING
C3009 VDD.n1194 VSS 0.01875f ; **FLOATING
C3010 VDD.n1195 VSS 0.05f ; **FLOATING
C3011 VDD.n1196 VSS 0.05f ; **FLOATING
C3012 VDD.n1197 VSS 0.02517f ; **FLOATING
C3013 VDD.t227 VSS 0.05066f ; **FLOATING
C3014 VDD.n1198 VSS 0.05024f ; **FLOATING
C3015 VDD.n1199 VSS 0.05032f ; **FLOATING
C3016 VDD.t100 VSS 0.05066f ; **FLOATING
C3017 VDD.n1200 VSS 0.01875f ; **FLOATING
C3018 VDD.n1201 VSS 0.05f ; **FLOATING
C3019 VDD.n1202 VSS 0.05f ; **FLOATING
C3020 VDD.n1203 VSS 0.02517f ; **FLOATING
C3021 VDD.t154 VSS 0.05066f ; **FLOATING
C3022 VDD.n1204 VSS 0.05024f ; **FLOATING
C3023 VDD.n1205 VSS 0.05032f ; **FLOATING
C3024 VDD.t344 VSS 0.05066f ; **FLOATING
C3025 VDD.n1206 VSS 0.01875f ; **FLOATING
C3026 VDD.n1207 VSS 0.05f ; **FLOATING
C3027 VDD.n1208 VSS 0.05f ; **FLOATING
C3028 VDD.n1209 VSS 0.02517f ; **FLOATING
C3029 VDD.t90 VSS 0.05066f ; **FLOATING
C3030 VDD.n1210 VSS 0.05024f ; **FLOATING
C3031 VDD.n1211 VSS 0.05f ; **FLOATING
C3032 VDD.n1212 VSS 0.02517f ; **FLOATING
C3033 VDD.t106 VSS 0.05066f ; **FLOATING
C3034 VDD.n1213 VSS 0.05024f ; **FLOATING
C3035 VDD.n1214 VSS 0.05032f ; **FLOATING
C3036 VDD.t40 VSS 0.05066f ; **FLOATING
C3037 VDD.n1215 VSS 0.01875f ; **FLOATING
C3038 VDD.n1216 VSS 0.05f ; **FLOATING
C3039 VDD.n1217 VSS 0.05032f ; **FLOATING
C3040 VDD.t233 VSS 0.05066f ; **FLOATING
C3041 VDD.n1218 VSS 0.01875f ; **FLOATING
C3042 VDD.n1219 VSS 0.05f ; **FLOATING
C3043 VDD.n1220 VSS 0.05032f ; **FLOATING
C3044 VDD.t109 VSS 0.05066f ; **FLOATING
C3045 VDD.n1221 VSS 0.01875f ; **FLOATING
C3046 VDD.n1222 VSS 0.05f ; **FLOATING
C3047 VDD.n1223 VSS 0.05f ; **FLOATING
C3048 VDD.n1224 VSS 0.02517f ; **FLOATING
C3049 VDD.t147 VSS 0.05066f ; **FLOATING
C3050 VDD.n1225 VSS 0.05024f ; **FLOATING
C3051 VDD.n1226 VSS 0.05f ; **FLOATING
C3052 VDD.n1227 VSS 0.02517f ; **FLOATING
C3053 VDD.t27 VSS 0.05066f ; **FLOATING
C3054 VDD.n1228 VSS 0.05024f ; **FLOATING
C3055 VDD.n1229 VSS 0.05032f ; **FLOATING
C3056 VDD.t231 VSS 0.05066f ; **FLOATING
C3057 VDD.n1230 VSS 0.01875f ; **FLOATING
C3058 VDD.n1231 VSS 0.05f ; **FLOATING
C3059 VDD.n1232 VSS 0.05f ; **FLOATING
C3060 VDD.n1233 VSS 0.02517f ; **FLOATING
C3061 VDD.t105 VSS 0.05066f ; **FLOATING
C3062 VDD.n1234 VSS 0.05024f ; **FLOATING
C3063 VDD.n1235 VSS 0.05032f ; **FLOATING
C3064 VDD.t19 VSS 0.05066f ; **FLOATING
C3065 VDD.n1236 VSS 0.01875f ; **FLOATING
C3066 VDD.n1237 VSS 0.05f ; **FLOATING
C3067 VDD.n1238 VSS 0.05f ; **FLOATING
C3068 VDD.n1239 VSS 0.02517f ; **FLOATING
C3069 VDD.t133 VSS 0.05066f ; **FLOATING
C3070 VDD.n1240 VSS 0.05024f ; **FLOATING
C3071 VDD.n1241 VSS 0.05032f ; **FLOATING
C3072 VDD.t211 VSS 0.05066f ; **FLOATING
C3073 VDD.n1242 VSS 0.01875f ; **FLOATING
C3074 VDD.n1243 VSS 0.05f ; **FLOATING
C3075 VDD.n1244 VSS 0.05f ; **FLOATING
C3076 VDD.n1245 VSS 0.02517f ; **FLOATING
C3077 VDD.t28 VSS 0.05066f ; **FLOATING
C3078 VDD.n1246 VSS 0.05024f ; **FLOATING
C3079 VDD.n1247 VSS 0.05f ; **FLOATING
C3080 VDD.n1248 VSS 0.02517f ; **FLOATING
C3081 VDD.t70 VSS 0.04425f ; **FLOATING
C3082 VDD.t68 VSS 0.02543f ; **FLOATING
C3083 VDD.t66 VSS 0.04869f ; **FLOATING
C3084 VDD.n1249 VSS 0.41291f ; **FLOATING
C3085 VDD.n1250 VSS 1.71273f ; **FLOATING
C3086 VDD.n1251 VSS 2.34444f ; **FLOATING
C3087 VDD.n1252 VSS 0.81358f ; **FLOATING
C3088 VDD.n1253 VSS 0.02319f ; **FLOATING
C3089 VDD.n1254 VSS 0.02714f ; **FLOATING
C3090 VDD.n1255 VSS 0.09369f ; **FLOATING
C3091 VDD.n1256 VSS 0.04744f ; **FLOATING
C3092 VDD.n1257 VSS 0.03793f ; **FLOATING
C3093 VDD.n1258 VSS 0.01462f ; **FLOATING
C3094 VDD.n1259 VSS 0.0648f ; **FLOATING
C3095 VDD.n1260 VSS 0.025f ; **FLOATING
C3096 VDD.n1261 VSS 0.025f ; **FLOATING
C3097 VDD.n1262 VSS 0.025f ; **FLOATING
C3098 VDD.n1263 VSS 0.05594f ; **FLOATING
C3099 VDD.n1264 VSS 0.025f ; **FLOATING
C3100 VDD.n1265 VSS 0.025f ; **FLOATING
C3101 VDD.n1266 VSS 0.025f ; **FLOATING
C3102 VDD.n1267 VSS 0.025f ; **FLOATING
C3103 VDD.n1268 VSS 0.025f ; **FLOATING
C3104 VDD.n1269 VSS 0.025f ; **FLOATING
C3105 VDD.n1270 VSS 0.025f ; **FLOATING
C3106 VDD.n1271 VSS 0.025f ; **FLOATING
C3107 VDD.n1272 VSS 0.025f ; **FLOATING
C3108 VDD.n1273 VSS 0.025f ; **FLOATING
C3109 VDD.n1274 VSS 0.025f ; **FLOATING
C3110 VDD.t187 VSS 0.08621f ; **FLOATING
C3111 VDD.n1275 VSS 0.05593f ; **FLOATING
C3112 VDD.t194 VSS 0.08621f ; **FLOATING
C3113 VDD.n1276 VSS 0.025f ; **FLOATING
C3114 VDD.n1277 VSS 0.025f ; **FLOATING
C3115 VDD.n1278 VSS 0.025f ; **FLOATING
C3116 VDD.n1279 VSS 0.025f ; **FLOATING
C3117 VDD.t52 VSS 0.07934f ; **FLOATING
C3118 VDD.t47 VSS 0.07714f ; **FLOATING
C3119 VDD.t45 VSS 0.48778f ; **FLOATING
C3120 VDD.n1280 VSS 0.06088f ; **FLOATING
C3121 VDD.n1281 VSS 0.025f ; **FLOATING
C3122 VDD.n1282 VSS 0.025f ; **FLOATING
C3123 VDD.n1283 VSS 0.06862f ; **FLOATING
C3124 VDD.n1284 VSS 0.02387f ; **FLOATING
C3125 VDD.n1285 VSS 0.10142f ; **FLOATING
C3126 DELAY_VBIASP.t0 VSS 0.8162f ; **FLOATING
C3127 DELAY_VBIASP.t1 VSS 0.54234f ; **FLOATING
C3128 DELAY_VBIASP.t2 VSS 6.91836f ; **FLOATING
C3129 DELAY_VBIASP.t34 VSS 0.49136f ; **FLOATING
C3130 DELAY_VBIASP.t33 VSS 0.48037f ; **FLOATING
C3131 DELAY_VBIASP.n0 VSS 0.86084f ; **FLOATING
C3132 DELAY_VBIASP.t32 VSS 0.48037f ; **FLOATING
C3133 DELAY_VBIASP.n1 VSS 0.59572f ; **FLOATING
C3134 DELAY_VBIASP.t31 VSS 0.48037f ; **FLOATING
C3135 DELAY_VBIASP.n2 VSS 0.59572f ; **FLOATING
C3136 DELAY_VBIASP.t30 VSS 0.48037f ; **FLOATING
C3137 DELAY_VBIASP.n3 VSS 0.59572f ; **FLOATING
C3138 DELAY_VBIASP.t29 VSS 0.48037f ; **FLOATING
C3139 DELAY_VBIASP.n4 VSS 0.59572f ; **FLOATING
C3140 DELAY_VBIASP.t28 VSS 0.48037f ; **FLOATING
C3141 DELAY_VBIASP.n5 VSS 0.59572f ; **FLOATING
C3142 DELAY_VBIASP.t27 VSS 0.48037f ; **FLOATING
C3143 DELAY_VBIASP.n6 VSS 0.59572f ; **FLOATING
C3144 DELAY_VBIASP.t26 VSS 0.48037f ; **FLOATING
C3145 DELAY_VBIASP.n7 VSS 0.59572f ; **FLOATING
C3146 DELAY_VBIASP.t25 VSS 0.48037f ; **FLOATING
C3147 DELAY_VBIASP.n8 VSS 0.59572f ; **FLOATING
C3148 DELAY_VBIASP.t24 VSS 0.48037f ; **FLOATING
C3149 DELAY_VBIASP.n9 VSS 0.59572f ; **FLOATING
C3150 DELAY_VBIASP.t23 VSS 0.48037f ; **FLOATING
C3151 DELAY_VBIASP.n10 VSS 0.59572f ; **FLOATING
C3152 DELAY_VBIASP.t22 VSS 0.48037f ; **FLOATING
C3153 DELAY_VBIASP.n11 VSS 0.59572f ; **FLOATING
C3154 DELAY_VBIASP.t21 VSS 0.48037f ; **FLOATING
C3155 DELAY_VBIASP.n12 VSS 0.59572f ; **FLOATING
C3156 DELAY_VBIASP.t20 VSS 0.48037f ; **FLOATING
C3157 DELAY_VBIASP.n13 VSS 0.59572f ; **FLOATING
C3158 DELAY_VBIASP.t19 VSS 0.48037f ; **FLOATING
C3159 DELAY_VBIASP.n14 VSS 0.59572f ; **FLOATING
C3160 DELAY_VBIASP.t18 VSS 0.48037f ; **FLOATING
C3161 DELAY_VBIASP.n15 VSS 0.59572f ; **FLOATING
C3162 DELAY_VBIASP.t17 VSS 0.48037f ; **FLOATING
C3163 DELAY_VBIASP.n16 VSS 0.59572f ; **FLOATING
C3164 DELAY_VBIASP.t16 VSS 0.48037f ; **FLOATING
C3165 DELAY_VBIASP.n17 VSS 0.59572f ; **FLOATING
C3166 DELAY_VBIASP.t15 VSS 0.48037f ; **FLOATING
C3167 DELAY_VBIASP.n18 VSS 0.59572f ; **FLOATING
C3168 DELAY_VBIASP.t14 VSS 0.48037f ; **FLOATING
C3169 DELAY_VBIASP.n19 VSS 0.59572f ; **FLOATING
C3170 DELAY_VBIASP.t13 VSS 1.07609f ; **FLOATING
C3171 DELAY_VBIASP.t12 VSS 1.07609f ; **FLOATING
C3172 DELAY_VBIASP.t11 VSS 1.07609f ; **FLOATING
C3173 DELAY_VBIASP.t10 VSS 1.07609f ; **FLOATING
C3174 DELAY_VBIASP.t9 VSS 1.07609f ; **FLOATING
C3175 DELAY_VBIASP.t8 VSS 1.07609f ; **FLOATING
C3176 DELAY_VBIASP.t7 VSS 1.07609f ; **FLOATING
C3177 DELAY_VBIASP.t6 VSS 1.07609f ; **FLOATING
C3178 DELAY_VBIASP.t5 VSS 1.07609f ; **FLOATING
C3179 DELAY_VBIASP.t4 VSS 1.07609f ; **FLOATING
C3180 DELAY_VBIASP.t3 VSS 1.30925f ; **FLOATING
C3181 DELAY_VBIASP.n20 VSS 9.37766f ; **FLOATING
.ends
