* NGSPICE file created from hx_delay_line_with_mux_dll.ext - technology: ihp-sg13g2

.subckt hx_delay_line_with_mux_dll VDD DELAY_OUT_LAST VSS DELAY_VBIASN DELAY_VBIASP
+ DLL_RESETN REF_CLK MUX_SEL0 MUX_SEL1 MUX_OUT MUX_SEL4 MUX_SEL2 MUX_SEL3
X0 a_14009_5878# REF_CLK VSS.t200 VSS.t199 sg13_lv_nmos ad=0.2516p pd=2.16u as=1.9998p ps=12.915u w=0.74u l=0.13u
X1 VDD.t41 a_4003_1842# a_4437_1842# VDD.t7 sg13_lv_pmos ad=0.2128p pd=1.5u as=0.3808p ps=2.92u w=1.12u l=0.13u
X2 VSS.t269 DLL_RESETN a_10040_6305# VSS.t268 sg13_lv_nmos ad=0.1626p pd=1.415u as=60.89999f ps=0.71u w=0.42u l=0.13u
X3 VSS.t465 a_15077_1842# a_15545_1044# VSS.t469 sg13_lv_nmos ad=0.1665p pd=1.19u as=0.2516p ps=2.16u w=0.74u l=0.13u
X4 a_27915_1044# a_27705_1044# VDD.t150 VDD.t0 sg13_lv_pmos ad=0.2128p pd=1.5u as=0.252p ps=1.57u w=1.12u l=0.13u
X5 VSS.t115 VDD.t408 VSS.t113 VSS.t114 sg13_lv_nmos ad=79.8f pd=0.8u as=0 ps=0 w=0.42u l=1u
X6 a_10951_2470# a_10713_1842# a_10843_1842# VDD.t7 sg13_lv_pmos ad=0.2128p pd=1.5u as=0.3808p ps=2.92u w=1.12u l=0.2u
X7 VSS.t324 a_3171_1047.t7 a_11924_1008# VSS.t323 sg13_lv_nmos ad=0.2516p pd=2.16u as=0.2516p ps=2.16u w=0.74u l=0.13u
X8 VDD.t116 VSS.t154 VDD.t187 VDD.t0 sg13_lv_pmos ad=0.34p pd=2.68u as=0 ps=0 w=1u l=1u
X9 VSS.t435 a_1256_1044# a_2967_1395# VSS.t434 sg13_lv_nmos ad=0.1331p pd=1.12u as=0.1216p ps=1.02u w=0.64u l=0.13u
X10 VSS.t115 VDD.t407 VSS.t115 VSS.t116 sg13_lv_nmos ad=0.1428p pd=1.52u as=0 ps=0 w=0.42u l=1u
X11 a_25153_1842# a_24957_1842# VSS.t56 VSS.t304 sg13_lv_nmos ad=0.2516p pd=2.16u as=0.1406p ps=1.12u w=0.74u l=0.13u
X12 VDD.t163 VSS.t129 VDD.t178 VDD.t0 sg13_lv_pmos ad=0.34p pd=2.68u as=0 ps=0 w=1u l=1u
X13 a_15108_6109# a_14851_6228# a_15270_6305# VSS.t34 sg13_lv_nmos ad=0.1428p pd=1.52u as=37.8f ps=0.6u w=0.42u l=0.13u
X14 VSS.t36 a_14851_6228# a_15688_5867# VSS.t35 sg13_lv_nmos ad=0.1406p pd=1.12u as=0.2516p ps=2.16u w=0.74u l=0.13u
X15 VSS.t584 VSS.t582 VSS.t582 VSS.t583 sg13_lv_nmos ad=0.68p pd=4.68u as=0 ps=0 w=2u l=1u
X16 a_15108_5325# a_12849_5867# VDD.t14 VDD.t13 sg13_lv_pmos ad=79.8f pd=0.8u as=1.03698p ps=6.245u w=0.42u l=0.13u
X17 a_25630_1044# a_2019_1047.t2 a_25528_1044# VSS.t192 sg13_lv_nmos ad=0.2516p pd=2.16u as=0.1406p ps=1.12u w=0.74u l=0.13u
X18 VDD.t295 DELAY_VBIASP a_19311_2470# VDD.t7 sg13_lv_pmos ad=0.3808p pd=2.92u as=0.2128p ps=1.5u w=1.12u l=0.6u
X19 a_16108_289# a_2019_311# a_16510_1044# VSS.t349 sg13_lv_nmos ad=0.2516p pd=2.16u as=0.2516p ps=2.16u w=0.74u l=0.13u
X20 VDD.t305 DELAY_VBIASP a_9431_2470# VDD.t7 sg13_lv_pmos ad=0.3808p pd=2.92u as=0.2128p ps=1.5u w=1.12u l=0.6u
X21 VSS.t161 VDD.t394 VSS.t160 VSS.t159 sg13_lv_nmos ad=0.1428p pd=1.52u as=0 ps=0 w=0.42u l=1u
X22 VSS.t579 VSS.t579 VSS.t581 VSS.t580 sg13_lv_nmos ad=0.68p pd=4.68u as=0 ps=0 w=2u l=1u
X23 VDD.t287 DELAY_VBIASP a_23111_2470# VDD.t7 sg13_lv_pmos ad=0.3808p pd=2.92u as=0.2128p ps=1.5u w=1.12u l=0.6u
X24 a_7390_1044# a_8231_1008# a_8155_1044# VDD.t0 sg13_lv_pmos ad=0.3808p pd=2.92u as=0.2128p ps=1.5u w=1.12u l=0.13u
X25 a_14009_5878# REF_CLK VDD.t14 VDD.t13 sg13_lv_pmos ad=0.4088p pd=2.97u as=1.03698p ps=6.245u w=1.12u l=0.13u
X26 VSS.t78 a_2595_311.t3 a_8745_519# VSS.t77 sg13_lv_nmos ad=0.2516p pd=2.16u as=0.2516p ps=2.16u w=0.74u l=0.13u
X27 a_11748_6109# DLL_RESETN VDD.t14 VDD.t13 sg13_lv_pmos ad=79.8f pd=0.8u as=1.10612p ps=6.66u w=0.42u l=0.13u
X28 VDD.t250 a_11491_6228# a_12158_5867# VDD.t13 sg13_lv_pmos ad=0.2128p pd=1.5u as=0.3864p ps=2.93u w=1.12u l=0.13u
X29 VDD.t298 DELAY_VBIASP DELAY_VBIASP VDD.t38 sg13_lv_pmos ad=0.3808p pd=2.92u as=1.0304p ps=4.08u w=1.12u l=0.6u
X30 a_17791_1842# a_17553_1842# a_17683_1842# VSS.t571 sg13_lv_nmos ad=0.1406p pd=1.12u as=0.2516p ps=2.16u w=0.74u l=0.2u
X31 VSS.t46 a_11748_6109# a_11397_6228# VSS.t236 sg13_lv_nmos ad=79.8f pd=0.8u as=0.1428p ps=1.52u w=0.42u l=0.13u
X32 VDD.t143 a_12037_1842# a_12505_1044# VDD.t0 sg13_lv_pmos ad=0.252p pd=1.57u as=0.3808p ps=2.92u w=1.12u l=0.13u
X33 a_16510_1044# a_2019_1047.t5 a_16408_1044# VSS.t15 sg13_lv_nmos ad=0.2516p pd=2.16u as=0.1406p ps=1.12u w=0.74u l=0.13u
X34 a_21591_1842# a_21353_1842# a_21483_1842# VSS.t29 sg13_lv_nmos ad=0.1406p pd=1.12u as=0.2516p ps=2.16u w=0.74u l=0.2u
X35 a_6153_1842# a_5957_1842# VSS.t1 VSS.t374 sg13_lv_nmos ad=0.2516p pd=2.16u as=0.1406p ps=1.12u w=0.74u l=0.13u
X36 VSS.t318 a_16163_1842# a_16597_1842# VSS.t430 sg13_lv_nmos ad=0.1406p pd=1.12u as=0.2516p ps=2.16u w=0.74u l=0.13u
X37 VSS.t172 a_3171_1047.t2 a_27124_1008# VSS.t171 sg13_lv_nmos ad=0.2516p pd=2.16u as=0.2516p ps=2.16u w=0.74u l=0.13u
X38 VDD.t142 a_11603_1842# a_12037_1842# VDD.t7 sg13_lv_pmos ad=0.2128p pd=1.5u as=0.3808p ps=2.92u w=1.12u l=0.13u
X39 VDD.t379 a_3171_311.t3 a_11785_519# VDD.t0 sg13_lv_pmos ad=0.3808p pd=2.92u as=0.3808p ps=2.92u w=1.12u l=0.13u
X40 a_6126_3816# a_6326_4590# VDD.t50 VDD.t13 sg13_lv_pmos ad=0.38p pd=2.38u as=0.38p ps=2.38u w=2u l=1u
X41 a_24393_1842# a_24197_1842# VDD.t80 VDD.t7 sg13_lv_pmos ad=0.3808p pd=2.92u as=0.2128p ps=1.5u w=1.12u l=0.13u
X42 a_5731_289# a_2595_311.t3 a_7390_1044# VSS.t76 sg13_lv_nmos ad=0.2516p pd=2.16u as=0.2516p ps=2.16u w=0.74u l=0.13u
X43 a_10430_1044# a_2595_1047.t7 a_11195_1044# VSS.t48 sg13_lv_nmos ad=0.2516p pd=2.16u as=0.1406p ps=1.12u w=0.74u l=0.13u
X44 a_13306_6305# a_12355_5867# VDD.t389 VDD.t13 sg13_lv_pmos ad=79.8f pd=0.8u as=0.1428p ps=1.52u w=0.42u l=0.13u
X45 a_23355_1044# a_23145_1044# VSS.t106 VSS.t105 sg13_lv_nmos ad=0.1406p pd=1.12u as=0.1665p ps=1.19u w=0.74u l=0.13u
X46 VDD.t300 DELAY_VBIASP a_14751_2470# VDD.t7 sg13_lv_pmos ad=0.3808p pd=2.92u as=0.2128p ps=1.5u w=1.12u l=0.6u
X47 VSS.t179 DELAY_VBIASN a_10191_1842# VSS.t496 sg13_lv_nmos ad=0.2516p pd=2.16u as=0.1406p ps=1.12u w=0.74u l=0.6u
X48 VSS.t71 a_3747_1047.t4 a_21911_1008# VSS.t70 sg13_lv_nmos ad=0.2516p pd=2.16u as=0.2516p ps=2.16u w=0.74u l=0.13u
X49 VSS.t333 a_19963_1842# a_20397_1842# VSS.t444 sg13_lv_nmos ad=0.1406p pd=1.12u as=0.2516p ps=2.16u w=0.74u l=0.13u
X50 a_6126_3816# a_6326_4590# VDD.t56 VDD.t13 sg13_lv_pmos ad=0.38p pd=2.38u as=0.38p ps=2.38u w=2u l=1u
X51 VDD.t54 a_6326_4590# a_6854_5454# VDD.t13 sg13_lv_pmos ad=0.38p pd=2.38u as=0.38p ps=2.38u w=2u l=1u
X52 VDD.t290 DELAY_VBIASP a_4111_2470# VDD.t7 sg13_lv_pmos ad=0.3808p pd=2.92u as=0.2128p ps=1.5u w=1.12u l=0.6u
X53 a_10328_1044# a_9757_1842# VDD.t209 VDD.t0 sg13_lv_pmos ad=0.2128p pd=1.5u as=0.3808p ps=2.92u w=1.12u l=0.13u
X54 a_20968_1044# a_20397_1842# VSS.t175 VSS.t331 sg13_lv_nmos ad=0.1406p pd=1.12u as=0.2516p ps=2.16u w=0.74u l=0.13u
X55 a_22590_1044# a_22564_1008# a_22488_1044# VDD.t0 sg13_lv_pmos ad=0.3808p pd=2.92u as=0.2128p ps=1.5u w=1.12u l=0.13u
X56 VDD.t357 VSS.t125 VDD.t268 VDD.t0 sg13_lv_pmos ad=0.19p pd=1.38u as=0 ps=0 w=1u l=1u
X57 a_8808_1044# a_8237_1842# VDD.t276 VDD.t0 sg13_lv_pmos ad=0.2128p pd=1.5u as=0.3808p ps=2.92u w=1.12u l=0.13u
X58 VDD.t60 a_6326_4590# a_6326_4590# VDD.t13 sg13_lv_pmos ad=0.38p pd=2.38u as=0.38p ps=2.38u w=2u l=1u
X59 a_4157_1313# REF_CLK VDD.t136 VDD.t0 sg13_lv_pmos ad=0.3808p pd=2.92u as=0.3808p ps=2.92u w=1.12u l=0.13u
X60 a_17031_2470# a_16793_1842# a_16923_1842# VDD.t7 sg13_lv_pmos ad=0.2128p pd=1.5u as=0.3808p ps=2.92u w=1.12u l=0.2u
X61 a_11473_1842# a_11277_1842# VSS.t352 VSS.t423 sg13_lv_nmos ad=0.2516p pd=2.16u as=0.1406p ps=1.12u w=0.74u l=0.13u
X62 VSS.t156 VDD.t396 VSS.t154 VSS.t155 sg13_lv_nmos ad=79.8f pd=0.8u as=0 ps=0 w=0.42u l=1u
X63 a_13306_5105# a_13132_5420# VDD.t248 VDD.t13 sg13_lv_pmos ad=79.8f pd=0.8u as=0.1428p ps=1.52u w=0.42u l=0.13u
X64 a_19448_1044# a_18877_1842# VSS.t412 VSS.t416 sg13_lv_nmos ad=0.1406p pd=1.12u as=0.2516p ps=2.16u w=0.74u l=0.13u
X65 a_10430_1044# a_3171_1047.t7 a_11848_1044# VSS.t322 sg13_lv_nmos ad=0.2516p pd=2.16u as=0.1406p ps=1.12u w=0.74u l=0.13u
X66 a_20831_2470# a_20593_1842# a_20723_1842# VDD.t7 sg13_lv_pmos ad=0.2128p pd=1.5u as=0.3808p ps=2.92u w=1.12u l=0.2u
X67 VSS.t132 VDD.t403 VSS.t130 VSS.t131 sg13_lv_nmos ad=79.8f pd=0.8u as=0 ps=0 w=0.42u l=1u
X68 VDD.t150 a_27237_1842# a_27705_1044# VDD.t0 sg13_lv_pmos ad=0.252p pd=1.57u as=0.3808p ps=2.92u w=1.12u l=0.13u
X69 a_5393_1842# a_5197_1842# VDD.t375 VDD.t7 sg13_lv_pmos ad=0.3808p pd=2.92u as=0.2128p ps=1.5u w=1.12u l=0.13u
X70 VDD.t288 DELAY_VBIASP a_17031_2470# VDD.t7 sg13_lv_pmos ad=0.3808p pd=2.92u as=0.2128p ps=1.5u w=1.12u l=0.6u
X71 VDD.t14 a_15108_6109# a_15053_5990# VDD.t13 sg13_lv_pmos ad=1.10612p pd=6.66u as=93.45f ps=0.865u w=0.42u l=0.13u
X72 VDD.t56 a_6326_4590# a_6854_5454# VDD.t13 sg13_lv_pmos ad=0.38p pd=2.38u as=0.38p ps=2.38u w=2u l=1u
X73 a_13818_6292# a_12849_5867# VSS.t267 VSS.t338 sg13_lv_nmos ad=37.8f pd=0.6u as=0.1701p ps=1.65u w=0.42u l=0.13u
X74 VDD.t149 a_26803_1842# a_27237_1842# VDD.t7 sg13_lv_pmos ad=0.2128p pd=1.5u as=0.3808p ps=2.92u w=1.12u l=0.13u
X75 VDD.t152 MUX_SEL1 a_3449_1395# VDD.t0 sg13_lv_pmos ad=0.1918p pd=1.5u as=0.1596p ps=1.22u w=0.84u l=0.13u
X76 a_14851_6228# a_14009_5878# a_13592_5871# VDD.t13 sg13_lv_pmos ad=0.2048p pd=1.63u as=0.34p ps=2.68u w=1u l=0.13u
X77 a_25630_1044# a_2595_1047.t2 a_26395_1044# VSS.t325 sg13_lv_nmos ad=0.2516p pd=2.16u as=0.1406p ps=1.12u w=0.74u l=0.13u
X78 VSS.t26 DELAY_VBIASN a_25391_1842# VSS.t560 sg13_lv_nmos ad=0.2516p pd=2.16u as=0.1406p ps=1.12u w=0.74u l=0.6u
X79 VSS.t543 DELAY_VBIASN VSS.t541 VSS.t526 sg13_lv_nmos ad=1.33p pd=7.38u as=0 ps=0 w=7u l=7u
X80 a_6635_1044# a_6425_1044# VDD.t272 VDD.t0 sg13_lv_pmos ad=0.2128p pd=1.5u as=0.252p ps=1.57u w=1.12u l=0.13u
X81 VDD.t174 DLL_RESETN a_9946_6305# VDD.t13 sg13_lv_pmos ad=0.36237p pd=2.605u as=79.8f ps=0.8u w=0.42u l=0.13u
X82 a_20315_1044# a_20105_1044# VDD.t25 VDD.t0 sg13_lv_pmos ad=0.2128p pd=1.5u as=0.252p ps=1.57u w=1.12u l=0.13u
X83 VDD.t235 a_2595_1047.t9 a_5191_1008# VDD.t0 sg13_lv_pmos ad=0.3808p pd=2.92u as=0.3808p ps=2.92u w=1.12u l=0.13u
X84 a_19311_2470# a_19073_1842# a_19203_1842# VDD.t7 sg13_lv_pmos ad=0.2128p pd=1.5u as=0.3808p ps=2.92u w=1.12u l=0.2u
X85 VSS.t248 a_1721_1395# a_2019_1047.t1 VSS.t273 sg13_lv_nmos ad=0.2812p pd=2.24u as=0.1406p ps=1.12u w=0.74u l=0.13u
X86 a_25528_1044# a_24957_1842# VDD.t212 VDD.t0 sg13_lv_pmos ad=0.2128p pd=1.5u as=0.3808p ps=2.92u w=1.12u l=0.13u
X87 VSS.t376 a_5957_1842# a_6425_1044# VSS.t375 sg13_lv_nmos ad=0.1665p pd=1.19u as=0.2516p ps=2.16u w=0.74u l=0.13u
X88 VSS.t367 a_2019_1047.t6 a_13444_1008# VSS.t366 sg13_lv_nmos ad=0.2516p pd=2.16u as=0.2516p ps=2.16u w=0.74u l=0.13u
X89 a_23111_2470# a_22873_1842# a_23003_1842# VDD.t7 sg13_lv_pmos ad=0.2128p pd=1.5u as=0.3808p ps=2.92u w=1.12u l=0.2u
X90 VSS.t113 VDD.t408 VSS.t113 VSS.t112 sg13_lv_nmos ad=0.1428p pd=1.52u as=0 ps=0 w=0.42u l=1u
X91 VSS.t214 a_15964_289# a_16851_309# VSS.t432 sg13_lv_nmos ad=0.1371p pd=1.12u as=0.2176p ps=1.96u w=0.64u l=0.13u
X92 a_10713_1842# a_10517_1842# VDD.t123 VDD.t7 sg13_lv_pmos ad=0.3808p pd=2.92u as=0.2128p ps=1.5u w=1.12u l=0.13u
X93 VDD.t17 a_17683_1842# a_18117_1842# VDD.t7 sg13_lv_pmos ad=0.2128p pd=1.5u as=0.3808p ps=2.92u w=1.12u l=0.13u
X94 a_16108_289# a_17865_519# a_16510_1044# VDD.t0 sg13_lv_pmos ad=0.3808p pd=2.92u as=0.3808p ps=2.92u w=1.12u l=0.13u
X95 a_26673_1842# a_26477_1842# VSS.t402 VSS.t472 sg13_lv_nmos ad=0.2516p pd=2.16u as=0.1406p ps=1.12u w=0.74u l=0.13u
X96 VDD.t188 a_7803_1842# a_8237_1842# VDD.t7 sg13_lv_pmos ad=0.2128p pd=1.5u as=0.3808p ps=2.92u w=1.12u l=0.13u
X97 a_4248_1044# a_4157_1313# VSS.t295 VSS.t313 sg13_lv_nmos ad=0.1406p pd=1.12u as=0.2516p ps=2.16u w=0.74u l=0.13u
X98 a_16108_289# a_3171_311.t2 a_22590_1044# VSS.t195 sg13_lv_nmos ad=0.2516p pd=2.16u as=0.2516p ps=2.16u w=0.74u l=0.13u
X99 VSS.t297 DELAY_VBIASN a_6391_1842# VSS.t548 sg13_lv_nmos ad=0.2516p pd=2.16u as=0.1406p ps=1.12u w=0.74u l=0.6u
X100 a_16408_1044# a_15837_1842# VDD.t215 VDD.t0 sg13_lv_pmos ad=0.2128p pd=1.5u as=0.3808p ps=2.92u w=1.12u l=0.13u
X101 a_10232_5871# a_10206_5835# VSS.t269 VSS.t268 sg13_lv_nmos ad=0.2516p pd=2.16u as=0.1626p ps=1.415u w=0.74u l=0.13u
X102 a_19550_1044# a_3747_1047.t4 a_21835_1044# VSS.t69 sg13_lv_nmos ad=0.2516p pd=2.16u as=0.1406p ps=1.12u w=0.74u l=0.13u
X103 VSS.t276 DELAY_VBIASN a_20831_1842# VSS.t554 sg13_lv_nmos ad=0.2516p pd=2.16u as=0.1406p ps=1.12u w=0.74u l=0.6u
X104 a_3171_311.t0 a_2873_331# VDD.t43 VDD.t0 sg13_lv_pmos ad=0.2128p pd=1.5u as=0.1918p ps=1.5u w=1.12u l=0.13u
X105 a_15304_4605# a_14851_6228# VDD.t28 VDD.t13 sg13_lv_pmos ad=0.4312p pd=3.01u as=0.2639p ps=1.81u w=1.12u l=0.13u
X106 a_13106_5357# a_12907_5420# VSS.t13 VSS.t75 sg13_lv_nmos ad=0.27427p pd=2.28u as=1.45407p ps=9.445u w=0.795u l=0.13u
X107 a_3747_311.t0 a_3449_331# VDD.t138 VDD.t0 sg13_lv_pmos ad=0.2128p pd=1.5u as=0.1918p ps=1.5u w=1.12u l=0.13u
X108 a_13132_5420# a_13106_5357# VDD.t14 VDD.t13 sg13_lv_pmos ad=0.3927p pd=2.99u as=1.10612p ps=6.66u w=1.155u l=0.13u
X109 a_7390_1044# a_9751_1008# a_9675_1044# VDD.t0 sg13_lv_pmos ad=0.3808p pd=2.92u as=0.2128p ps=1.5u w=1.12u l=0.13u
X110 VSS.t539 DELAY_VBIASN VSS.t537 VSS.t522 sg13_lv_nmos ad=1.33p pd=7.38u as=0 ps=0 w=7u l=7u
X111 a_10191_1842# a_9953_1842# a_10083_1842# VSS.t386 sg13_lv_nmos ad=0.1406p pd=1.12u as=0.2516p ps=2.16u w=0.74u l=0.2u
X112 VSS.t106 a_22677_1842# a_23145_1044# VSS.t180 sg13_lv_nmos ad=0.1665p pd=1.19u as=0.2516p ps=2.16u w=0.74u l=0.13u
X113 a_14751_2470# a_14513_1842# a_14643_1842# VDD.t7 sg13_lv_pmos ad=0.2128p pd=1.5u as=0.3808p ps=2.92u w=1.12u l=0.2u
X114 a_5731_289# a_8745_519# a_7390_1044# VDD.t0 sg13_lv_pmos ad=0.3808p pd=2.92u as=0.3808p ps=2.92u w=1.12u l=0.13u
X115 VDD.t105 VDD.t106 VDD.t107 VDD.t7 sg13_lv_pmos ad=0.2128p pd=1.5u as=0 ps=0 w=1.12u l=0.13u
X116 a_4111_2470# REF_CLK a_4003_1842# VDD.t7 sg13_lv_pmos ad=0.2128p pd=1.5u as=0.3808p ps=2.92u w=1.12u l=0.2u
X117 a_13566_5835# a_14009_5878# a_13306_6305# VSS.t253 sg13_lv_nmos ad=79.8f pd=0.8u as=0.1296p ps=1.52u w=0.42u l=0.13u
X118 a_13306_6305# a_14111_5878# a_13566_5835# VDD.t13 sg13_lv_pmos ad=0.1428p pd=1.52u as=79.8f ps=0.8u w=0.42u l=0.13u
X119 a_13592_5423# a_14111_5227# a_14851_5182# VSS.t343 sg13_lv_nmos ad=0.3473p pd=2.71u as=0.12665p ps=1.145u w=0.74u l=0.13u
X120 a_7673_1842# a_7477_1842# VSS.t292 VSS.t291 sg13_lv_nmos ad=0.2516p pd=2.16u as=0.1406p ps=1.12u w=0.74u l=0.13u
X121 VDD.t367 a_3171_1047.t5 a_18004_1008# VDD.t0 sg13_lv_pmos ad=0.3808p pd=2.92u as=0.3808p ps=2.92u w=1.12u l=0.13u
X122 VDD.t144 a_13123_1842# a_13557_1842# VDD.t7 sg13_lv_pmos ad=0.2128p pd=1.5u as=0.3808p ps=2.92u w=1.12u l=0.13u
X123 VDD.t79 a_3747_311.t2 a_26985_519# VDD.t0 sg13_lv_pmos ad=0.3808p pd=2.92u as=0.3808p ps=2.92u w=1.12u l=0.13u
X124 a_25913_1842# a_25717_1842# VDD.t19 VDD.t7 sg13_lv_pmos ad=0.3808p pd=2.92u as=0.2128p ps=1.5u w=1.12u l=0.13u
X125 a_10430_1044# a_3747_1047.t7 a_12715_1044# VSS.t63 sg13_lv_nmos ad=0.2516p pd=2.16u as=0.1406p ps=1.12u w=0.74u l=0.13u
X126 a_6326_4590# a_5974_5723# a_6126_3816# VSS.t274 sg13_lv_nmos ad=0.38p pd=2.38u as=0.68p ps=4.68u w=2u l=1u
X127 a_14235_1044# a_14025_1044# VDD.t63 VDD.t0 sg13_lv_pmos ad=0.2128p pd=1.5u as=0.252p ps=1.57u w=1.12u l=0.13u
X128 a_24875_1044# a_24665_1044# VSS.t380 VSS.t379 sg13_lv_nmos ad=0.1406p pd=1.12u as=0.1665p ps=1.19u w=0.74u l=0.13u
X129 VSS.t217 DELAY_VBIASN a_11711_1842# VSS.t551 sg13_lv_nmos ad=0.2516p pd=2.16u as=0.1406p ps=1.12u w=0.74u l=0.6u
X130 VDD.t46 a_3747_1047.t7 a_12791_1008# VDD.t0 sg13_lv_pmos ad=0.3808p pd=2.92u as=0.3808p ps=2.92u w=1.12u l=0.13u
X131 VSS.t259 a_2595_1047.t3 a_23431_1008# VSS.t621 sg13_lv_nmos ad=0.2516p pd=2.16u as=0.2516p ps=2.16u w=0.74u l=0.13u
X132 VSS.t224 a_21483_1842# a_21917_1842# VSS.t223 sg13_lv_nmos ad=0.1406p pd=1.12u as=0.2516p ps=2.16u w=0.74u l=0.13u
X133 VSS.t67 a_13557_1842# a_14025_1044# VSS.t314 sg13_lv_nmos ad=0.1665p pd=1.19u as=0.2516p ps=2.16u w=0.74u l=0.13u
X134 a_11848_1044# a_11277_1842# VDD.t328 VDD.t0 sg13_lv_pmos ad=0.2128p pd=1.5u as=0.3808p ps=2.92u w=1.12u l=0.13u
X135 VDD.t230 VSS.t167 VDD.t65 VDD.t0 sg13_lv_pmos ad=0.19p pd=1.38u as=0 ps=0 w=1u l=1u
X136 VDD.t14 a_12907_5186# a_12907_5420# VDD.t13 sg13_lv_pmos ad=1.10612p pd=6.66u as=0.2442p ps=2.06u w=0.66u l=0.13u
X137 a_25391_1842# a_25153_1842# a_25283_1842# VSS.t256 sg13_lv_nmos ad=0.1406p pd=1.12u as=0.2516p ps=2.16u w=0.74u l=0.2u
X138 a_12993_1842# a_12797_1842# VSS.t40 VSS.t39 sg13_lv_nmos ad=0.2516p pd=2.16u as=0.1406p ps=1.12u w=0.74u l=0.13u
X139 DELAY_OUT_LAST a_27997_1842# VDD.t154 VDD.t7 sg13_lv_pmos ad=0.3808p pd=2.92u as=0.2128p ps=1.5u w=1.12u l=0.13u
X140 VDD.t232 VSS.t167 VDD.t231 VDD.t0 sg13_lv_pmos ad=0.34p pd=2.68u as=0 ps=0 w=1u l=1u
X141 VDD.t25 a_19637_1842# a_20105_1044# VDD.t0 sg13_lv_pmos ad=0.252p pd=1.57u as=0.3808p ps=2.92u w=1.12u l=0.13u
X142 a_6854_5454# a_6326_4590# VDD.t52 VDD.t13 sg13_lv_pmos ad=0.38p pd=2.38u as=0.38p ps=2.38u w=2u l=1u
X143 VSS.t98 DELAY_VBIASN a_13991_1842# VSS.t552 sg13_lv_nmos ad=0.2516p pd=2.16u as=0.1406p ps=1.12u w=0.74u l=0.6u
X144 VSS.t154 VDD.t396 VSS.t154 VSS.t153 sg13_lv_nmos ad=0.1428p pd=1.52u as=0 ps=0 w=0.42u l=1u
X145 a_22590_1044# a_3171_1047.t3 a_24008_1044# VSS.t187 sg13_lv_nmos ad=0.2516p pd=2.16u as=0.1406p ps=1.12u w=0.74u l=0.13u
X146 a_6913_1842# a_6717_1842# VDD.t208 VDD.t7 sg13_lv_pmos ad=0.3808p pd=2.92u as=0.2128p ps=1.5u w=1.12u l=0.13u
X147 VDD.t311 DELAY_VBIASP a_18551_2470# VDD.t7 sg13_lv_pmos ad=0.3808p pd=2.92u as=0.2128p ps=1.5u w=1.12u l=0.6u
X148 VSS.t104 a_23763_1842# a_24197_1842# VSS.t103 sg13_lv_nmos ad=0.1406p pd=1.12u as=0.2516p ps=2.16u w=0.74u l=0.13u
X149 VSS.t130 VDD.t403 VSS.t129 VSS.t128 sg13_lv_nmos ad=0.1428p pd=1.52u as=0 ps=0 w=0.42u l=1u
X150 VDD.t339 a_1256_1044# a_2873_1395# VDD.t0 sg13_lv_pmos ad=0.1918p pd=1.5u as=0.1596p ps=1.22u w=0.84u l=0.13u
X151 a_3171_311.t1 a_2873_331# VSS.t59 VSS.t245 sg13_lv_nmos ad=0.1406p pd=1.12u as=0.1331p ps=1.12u w=0.74u l=0.13u
X152 VDD.t156 a_2873_331# a_3171_311.t0 VDD.t0 sg13_lv_pmos ad=0.4256p pd=3u as=0.2128p ps=1.5u w=1.12u l=0.13u
X153 a_16510_1044# a_17351_1008# a_17275_1044# VDD.t0 sg13_lv_pmos ad=0.3808p pd=2.92u as=0.2128p ps=1.5u w=1.12u l=0.13u
X154 a_25630_1044# a_3747_1047.t2 a_27915_1044# VSS.t60 sg13_lv_nmos ad=0.2516p pd=2.16u as=0.1406p ps=1.12u w=0.74u l=0.13u
X155 VSS.t231 DELAY_VBIASN a_26911_1842# VSS.t504 sg13_lv_nmos ad=0.2516p pd=2.16u as=0.1406p ps=1.12u w=0.74u l=0.6u
X156 a_3747_311.t1 a_3449_331# VSS.t208 VSS.t263 sg13_lv_nmos ad=0.1406p pd=1.12u as=0.1331p ps=1.12u w=0.74u l=0.13u
X157 VDD.t171 a_3449_331# a_3747_311.t0 VDD.t0 sg13_lv_pmos ad=0.4256p pd=3u as=0.2128p ps=1.5u w=1.12u l=0.13u
X158 VDD.t314 DELAY_VBIASP a_22351_2470# VDD.t7 sg13_lv_pmos ad=0.3808p pd=2.92u as=0.2128p ps=1.5u w=1.12u l=0.6u
X159 VDD.t45 a_3747_1047.t2 a_27991_1008# VDD.t0 sg13_lv_pmos ad=0.3808p pd=2.92u as=0.3808p ps=2.92u w=1.12u l=0.13u
X160 VDD.t168 VSS.t111 VDD.t167 VDD.t0 sg13_lv_pmos ad=0.19p pd=1.38u as=0 ps=0 w=1u l=1u
X161 a_13019_5831# a_15688_5403# VSS.t335 VSS.t460 sg13_lv_nmos ad=0.2516p pd=2.16u as=0.1406p ps=1.12u w=0.74u l=0.13u
X162 VDD.t214 a_3747_1047.t9 a_6711_1008# VDD.t0 sg13_lv_pmos ad=0.3808p pd=2.92u as=0.3808p ps=2.92u w=1.12u l=0.13u
X163 a_6854_5454# a_6326_4590# VDD.t55 VDD.t13 sg13_lv_pmos ad=0.38p pd=2.38u as=0.38p ps=2.38u w=2u l=1u
X164 a_9772_5843# a_9746_5805# VDD.t14 VDD.t13 sg13_lv_pmos ad=0.3927p pd=2.99u as=1.10612p ps=6.66u w=1.155u l=0.13u
X165 a_6391_1842# a_6153_1842# a_6283_1842# VSS.t255 sg13_lv_nmos ad=0.1406p pd=1.12u as=0.2516p ps=2.16u w=0.74u l=0.2u
X166 a_15273_1842# a_15077_1842# VSS.t468 VSS.t467 sg13_lv_nmos ad=0.2516p pd=2.16u as=0.1406p ps=1.12u w=0.74u l=0.13u
X167 a_19833_1842# a_19637_1842# VDD.t148 VDD.t7 sg13_lv_pmos ad=0.3808p pd=2.92u as=0.2128p ps=1.5u w=1.12u l=0.13u
X168 a_16108_289# a_23945_519# a_22590_1044# VDD.t0 sg13_lv_pmos ad=0.3808p pd=2.92u as=0.3808p ps=2.92u w=1.12u l=0.13u
X169 VDD.t58 a_6326_4590# a_6126_3816# VDD.t13 sg13_lv_pmos ad=0.38p pd=2.38u as=0.38p ps=2.38u w=2u l=1u
X170 a_9193_1842# a_8997_1842# VDD.t282 VDD.t7 sg13_lv_pmos ad=0.3808p pd=2.92u as=0.2128p ps=1.5u w=1.12u l=0.13u
X171 a_24631_2470# a_24393_1842# a_24523_1842# VDD.t7 sg13_lv_pmos ad=0.2128p pd=1.5u as=0.3808p ps=2.92u w=1.12u l=0.2u
X172 VSS.t3 a_15403_1842# a_15837_1842# VSS.t2 sg13_lv_nmos ad=0.1406p pd=1.12u as=0.2516p ps=2.16u w=0.74u l=0.13u
X173 a_8155_1044# a_7945_1044# VSS.t10 VSS.t9 sg13_lv_nmos ad=0.1406p pd=1.12u as=0.1665p ps=1.19u w=0.74u l=0.13u
X174 a_23633_1842# a_23437_1842# VDD.t166 VDD.t7 sg13_lv_pmos ad=0.3808p pd=2.92u as=0.2128p ps=1.5u w=1.12u l=0.13u
X175 VSS.t487 a_4763_1842# a_5197_1842# VSS.t486 sg13_lv_nmos ad=0.1406p pd=1.12u as=0.2516p ps=2.16u w=0.74u l=0.13u
X176 a_27048_1044# a_26477_1842# VSS.t327 VSS.t471 sg13_lv_nmos ad=0.1406p pd=1.12u as=0.2516p ps=2.16u w=0.74u l=0.13u
X177 VDD.t127 a_9323_1842# a_9757_1842# VDD.t7 sg13_lv_pmos ad=0.2128p pd=1.5u as=0.3808p ps=2.92u w=1.12u l=0.13u
X178 a_5768_1044# a_5197_1842# VSS.t321 VSS.t568 sg13_lv_nmos ad=0.1406p pd=1.12u as=0.2516p ps=2.16u w=0.74u l=0.13u
X179 a_6326_4590# a_6126_3816# a_5778_3367# VSS.t387 sg13_lv_nmos ad=0.38p pd=2.38u as=0.68p ps=4.68u w=2u l=1u
X180 DELAY_VBIASN DLL_RESETN VDD.t186 VDD.t38 sg13_lv_pmos ad=0.158p pd=1.245u as=0.272p ps=2.28u w=0.8u l=0.2u
X181 a_7390_1044# a_7364_1008# a_7288_1044# VDD.t0 sg13_lv_pmos ad=0.3808p pd=2.92u as=0.2128p ps=1.5u w=1.12u l=0.13u
X182 VSS.t533 DELAY_VBIASN VSS.t532 VSS.t515 sg13_lv_nmos ad=2.38p pd=14.68u as=0 ps=0 w=7u l=7u
X183 VSS.t285 DELAY_VBIASN a_7911_1842# VSS.t549 sg13_lv_nmos ad=0.2516p pd=2.16u as=0.1406p ps=1.12u w=0.74u l=0.6u
X184 VDD.t37 a_13019_5831# a_12943_5867# VDD.t13 sg13_lv_pmos ad=0.2128p pd=1.5u as=0.2128p ps=1.5u w=1.12u l=0.13u
X185 a_6854_5986# a_15304_4605# DELAY_VBIASN VDD.t38 sg13_lv_pmos ad=0.136p pd=1.14u as=0.158p ps=1.245u w=0.4u l=0.2u
X186 VDD.t195 VSS.t20 VDD.t193 VDD.t0 sg13_lv_pmos ad=0.19p pd=1.38u as=0 ps=0 w=1u l=1u
X187 a_11711_1842# a_11473_1842# a_11603_1842# VSS.t344 sg13_lv_nmos ad=0.1406p pd=1.12u as=0.2516p ps=2.16u w=0.74u l=0.2u
X188 VSS.t380 a_24197_1842# a_24665_1044# VSS.t565 sg13_lv_nmos ad=0.1665p pd=1.19u as=0.2516p ps=2.16u w=0.74u l=0.13u
X189 a_16510_1044# a_3171_1047.t5 a_17928_1044# VSS.t473 sg13_lv_nmos ad=0.2516p pd=2.16u as=0.1406p ps=1.12u w=0.74u l=0.13u
X190 a_15270_5105# a_12849_5867# VSS.t335 VSS.t334 sg13_lv_nmos ad=37.8f pd=0.6u as=79.8f ps=0.8u w=0.42u l=0.13u
X191 a_5974_5723# a_6126_3816# VSS.t391 VSS.t274 sg13_lv_nmos ad=0.38p pd=2.38u as=0.68p ps=4.68u w=2u l=1u
X192 VSS.t125 VDD.t405 VSS.t123 VSS.t124 sg13_lv_nmos ad=79.8f pd=0.8u as=0 ps=0 w=0.42u l=1u
X193 a_5631_2470# a_5393_1842# a_5523_1842# VDD.t7 sg13_lv_pmos ad=0.2128p pd=1.5u as=0.3808p ps=2.92u w=1.12u l=0.2u
X194 a_14513_1842# a_14317_1842# VDD.t78 VDD.t7 sg13_lv_pmos ad=0.3808p pd=2.92u as=0.2128p ps=1.5u w=1.12u l=0.13u
X195 a_4633_1842# a_4437_1842# VDD.t41 VDD.t7 sg13_lv_pmos ad=0.3808p pd=2.92u as=0.2128p ps=1.5u w=1.12u l=0.13u
X196 VSS.t179 a_10083_1842# a_10517_1842# VSS.t490 sg13_lv_nmos ad=0.1406p pd=1.12u as=0.2516p ps=2.16u w=0.74u l=0.13u
X197 VDD.t77 a_2019_1047.t4 a_19524_1008# VDD.t0 sg13_lv_pmos ad=0.3808p pd=2.92u as=0.3808p ps=2.92u w=1.12u l=0.13u
X198 VSS.t574 a_3171_1047.t4 a_21044_1008# VSS.t573 sg13_lv_nmos ad=0.2516p pd=2.16u as=0.2516p ps=2.16u w=0.74u l=0.13u
X199 VSS.t59 a_2873_331# a_3171_311.t1 VSS.t246 sg13_lv_nmos ad=0.2812p pd=2.24u as=0.1406p ps=1.12u w=0.74u l=0.13u
X200 a_13949_5496# a_13592_5423# VDD.t244 VDD.t13 sg13_lv_pmos ad=63f pd=0.72u as=0.1563p ps=1.22u w=0.42u l=0.13u
X201 VSS.t208 a_3449_331# a_3747_311.t1 VSS.t264 sg13_lv_nmos ad=0.2812p pd=2.24u as=0.1406p ps=1.12u w=0.74u l=0.13u
X202 a_15755_1044# a_15545_1044# VDD.t351 VDD.t0 sg13_lv_pmos ad=0.2128p pd=1.5u as=0.252p ps=1.57u w=1.12u l=0.13u
X203 VDD.t390 a_2595_1047.t6 a_14311_1008# VDD.t0 sg13_lv_pmos ad=0.3808p pd=2.92u as=0.3808p ps=2.92u w=1.12u l=0.13u
X204 VSS.t56 DELAY_VBIASN a_24631_1842# VSS.t500 sg13_lv_nmos ad=0.2516p pd=2.16u as=0.1406p ps=1.12u w=0.74u l=0.6u
X205 a_5115_1044# a_4905_1044# VDD.t40 VDD.t0 sg13_lv_pmos ad=0.2128p pd=1.5u as=0.252p ps=1.57u w=1.12u l=0.13u
X206 a_5974_5723# a_6126_3816# VSS.t393 VSS.t274 sg13_lv_nmos ad=0.38p pd=2.38u as=0.68p ps=4.68u w=2u l=1u
X207 VSS.t13 a_12907_5186# a_12907_5186# VSS.t43 sg13_lv_nmos ad=1.45407p pd=9.445u as=0.111p ps=1.34u w=0.3u l=0.13u
X208 a_18551_2470# a_18313_1842# a_18443_1842# VDD.t7 sg13_lv_pmos ad=0.2128p pd=1.5u as=0.3808p ps=2.92u w=1.12u l=0.2u
X209 VDD.t279 VSS.t152 VDD.t70 VDD.t0 sg13_lv_pmos ad=0.19p pd=1.38u as=0 ps=0 w=1u l=1u
X210 a_3171_1047.t1 a_2873_1395# VSS.t435 VSS.t458 sg13_lv_nmos ad=0.1406p pd=1.12u as=0.1331p ps=1.12u w=0.74u l=0.13u
X211 a_13121_5831# a_15688_5867# VSS.t36 VSS.t82 sg13_lv_nmos ad=0.2516p pd=2.16u as=0.1406p ps=1.12u w=0.74u l=0.13u
X212 VSS.t523 DELAY_VBIASN VSS.t525 VSS.t524 sg13_lv_nmos ad=1.33p pd=7.38u as=0 ps=0 w=7u l=7u
X213 VSS.t248 a_2297_1395# a_2595_1047.t1 VSS.t312 sg13_lv_nmos ad=0.2812p pd=2.24u as=0.1406p ps=1.12u w=0.74u l=0.13u
X214 VDD.t262 a_14851_5182# a_15108_5325# VDD.t13 sg13_lv_pmos ad=0.2639p pd=1.81u as=79.8f ps=0.8u w=0.42u l=0.13u
X215 a_22351_2470# a_22113_1842# a_22243_1842# VDD.t7 sg13_lv_pmos ad=0.2128p pd=1.5u as=0.3808p ps=2.92u w=1.12u l=0.2u
X216 VSS.t603 VSS.t603 VSS.t605 VSS.t604 sg13_lv_nmos ad=0.2516p pd=2.16u as=0 ps=0 w=0.74u l=0.13u
X217 a_26911_1842# a_26673_1842# a_26803_1842# VSS.t576 sg13_lv_nmos ad=0.1406p pd=1.12u as=0.2516p ps=2.16u w=0.74u l=0.2u
X218 VSS.t129 a_3171_311.t3 a_11785_519# VSS.t492 sg13_lv_nmos ad=0.2516p pd=2.16u as=0.2516p ps=2.16u w=0.74u l=0.13u
X219 VDD.t177 a_1721_1395# a_2019_1047.t0 VDD.t0 sg13_lv_pmos ad=0.4256p pd=3u as=0.2128p ps=1.5u w=1.12u l=0.13u
X220 a_12656_5864# DLL_RESETN VSS.t46 VSS.t283 sg13_lv_nmos ad=0.2516p pd=2.16u as=0.2516p ps=2.16u w=0.74u l=0.13u
X221 a_14851_6228# a_14009_5878# a_14757_6228# VSS.t34 sg13_lv_nmos ad=0.12665p pd=1.145u as=0.1428p ps=1.52u w=0.42u l=0.13u
X222 VDD.t270 a_16923_1842# a_17357_1842# VDD.t7 sg13_lv_pmos ad=0.2128p pd=1.5u as=0.3808p ps=2.92u w=1.12u l=0.13u
X223 a_2391_1395# MUX_SEL0 a_2297_1395# VSS.t428 sg13_lv_nmos ad=0.1216p pd=1.02u as=0.2176p ps=1.96u w=0.64u l=0.13u
X224 VSS.t248 a_1544_1044# a_1815_1395# VSS.t247 sg13_lv_nmos ad=0.1331p pd=1.12u as=0.1216p ps=1.02u w=0.64u l=0.13u
X225 a_13368_1044# a_12797_1842# VSS.t42 VSS.t41 sg13_lv_nmos ad=0.1406p pd=1.12u as=0.2516p ps=2.16u w=0.74u l=0.13u
X226 a_13400_5105# a_13132_5420# a_13306_5105# VSS.t341 sg13_lv_nmos ad=60.89999f pd=0.71u as=0.1428p ps=1.52u w=0.42u l=0.13u
X227 a_5731_289# a_3171_311.t3 a_10430_1044# VSS.t491 sg13_lv_nmos ad=0.2516p pd=2.16u as=0.2516p ps=2.16u w=0.74u l=0.13u
X228 VDD.t175 a_21157_1842# a_21625_1044# VDD.t0 sg13_lv_pmos ad=0.252p pd=1.57u as=0.3808p ps=2.92u w=1.12u l=0.13u
X229 VDD.t307 DELAY_VBIASP a_10951_2470# VDD.t7 sg13_lv_pmos ad=0.3808p pd=2.92u as=0.2128p ps=1.5u w=1.12u l=0.6u
X230 VSS.t3 DELAY_VBIASN a_15511_1842# VSS.t505 sg13_lv_nmos ad=0.2516p pd=2.16u as=0.1406p ps=1.12u w=0.74u l=0.6u
X231 a_6326_4590# a_6326_4590# VDD.t48 VDD.t13 sg13_lv_pmos ad=0.38p pd=2.38u as=0.38p ps=2.38u w=2u l=1u
X232 VSS.t535 DELAY_VBIASN VSS.t533 VSS.t518 sg13_lv_nmos ad=1.33p pd=7.38u as=0 ps=0 w=7u l=7u
X233 VDD.t180 a_20723_1842# a_21157_1842# VDD.t7 sg13_lv_pmos ad=0.2128p pd=1.5u as=0.3808p ps=2.92u w=1.12u l=0.13u
X234 VSS.t26 a_25283_1842# a_25717_1842# VSS.t191 sg13_lv_nmos ad=0.1406p pd=1.12u as=0.2516p ps=2.16u w=0.74u l=0.13u
X235 a_4350_1044# a_3747_1047.t9 a_6635_1044# VSS.t305 sg13_lv_nmos ad=0.2516p pd=2.16u as=0.1406p ps=1.12u w=0.74u l=0.13u
X236 VSS.t1 DELAY_VBIASN a_5631_1842# VSS.t508 sg13_lv_nmos ad=0.2516p pd=2.16u as=0.1406p ps=1.12u w=0.74u l=0.6u
X237 VDD.t207 a_2019_1047.t9 a_4324_1008# VDD.t0 sg13_lv_pmos ad=0.3808p pd=2.92u as=0.3808p ps=2.92u w=1.12u l=0.13u
X238 a_12849_5867# a_12656_5864# VSS.t46 VSS.t424 sg13_lv_nmos ad=0.1406p pd=1.12u as=0.2516p ps=2.16u w=0.74u l=0.13u
X239 a_16510_1044# a_18871_1008# a_18795_1044# VDD.t0 sg13_lv_pmos ad=0.3808p pd=2.92u as=0.2128p ps=1.5u w=1.12u l=0.13u
X240 a_19550_1044# a_2595_1047.t4 a_20315_1044# VSS.t173 sg13_lv_nmos ad=0.2516p pd=2.16u as=0.1406p ps=1.12u w=0.74u l=0.13u
X241 VDD.t52 a_6326_4590# a_6126_3816# VDD.t13 sg13_lv_pmos ad=0.38p pd=2.38u as=0.38p ps=2.38u w=2u l=1u
X242 VDD.t14 a_11491_6228# a_11748_6109# VDD.t13 sg13_lv_pmos ad=1.10612p pd=6.66u as=79.8f ps=0.8u w=0.42u l=0.13u
X243 a_12355_5867# a_12158_5867# VDD.t250 VDD.t13 sg13_lv_pmos ad=0.3808p pd=2.92u as=0.2128p ps=1.5u w=1.12u l=0.13u
X244 VDD.t289 DELAY_VBIASP a_23871_2470# VDD.t7 sg13_lv_pmos ad=0.3808p pd=2.92u as=0.2128p ps=1.5u w=1.12u l=0.6u
X245 VSS.t10 a_7477_1842# a_7945_1044# VSS.t290 sg13_lv_nmos ad=0.1665p pd=1.19u as=0.2516p ps=2.16u w=0.74u l=0.13u
X246 a_11910_6305# DLL_RESETN VSS.t46 VSS.t236 sg13_lv_nmos ad=37.8f pd=0.6u as=79.8f ps=0.8u w=0.42u l=0.13u
X247 VSS.t529 DELAY_VBIASN VSS.t531 VSS.t530 sg13_lv_nmos ad=1.33p pd=7.38u as=0 ps=0 w=7u l=7u
X248 a_13231_2470# a_12993_1842# a_13123_1842# VDD.t7 sg13_lv_pmos ad=0.2128p pd=1.5u as=0.3808p ps=2.92u w=1.12u l=0.2u
X249 VDD.t167 VSS.t108 VDD.t258 VDD.t0 sg13_lv_pmos ad=0.34p pd=2.68u as=0 ps=0 w=1u l=1u
X250 a_6326_4590# a_6126_3816# a_5778_3367# VSS.t387 sg13_lv_nmos ad=0.38p pd=2.38u as=0.68p ps=4.68u w=2u l=1u
X251 a_12233_1842# a_12037_1842# VDD.t142 VDD.t7 sg13_lv_pmos ad=0.3808p pd=2.92u as=0.2128p ps=1.5u w=1.12u l=0.13u
X252 a_7911_1842# a_7673_1842# a_7803_1842# VSS.t616 sg13_lv_nmos ad=0.1406p pd=1.12u as=0.2516p ps=2.16u w=0.74u l=0.2u
X253 a_16793_1842# a_16597_1842# VSS.t318 VSS.t317 sg13_lv_nmos ad=0.2516p pd=2.16u as=0.1406p ps=1.12u w=0.74u l=0.13u
X254 VDD.t16 a_3747_311.t3 a_14825_519# VDD.t0 sg13_lv_pmos ad=0.3808p pd=2.92u as=0.3808p ps=2.92u w=1.12u l=0.13u
X255 VDD.t173 a_12849_5867# a_13306_6305# VDD.t13 sg13_lv_pmos ad=0.36237p pd=2.605u as=79.8f ps=0.8u w=0.42u l=0.13u
X256 VDD.t90 VDD.t82 VDD.t55 VDD.t13 sg13_lv_pmos ad=0.68p pd=4.68u as=0 ps=0 w=2u l=1u
X257 VSS.t242 a_27563_1842# a_27997_1842# VSS.t489 sg13_lv_nmos ad=0.1406p pd=1.12u as=0.2516p ps=2.16u w=0.74u l=0.13u
X258 a_9675_1044# a_9465_1044# VSS.t28 VSS.t27 sg13_lv_nmos ad=0.1406p pd=1.12u as=0.1665p ps=1.19u w=0.74u l=0.13u
X259 VDD.t48 a_6326_4590# a_6854_5986# VDD.t13 sg13_lv_pmos ad=0.38p pd=2.38u as=0.38p ps=2.38u w=2u l=1u
X260 a_20593_1842# a_20397_1842# VSS.t333 VSS.t332 sg13_lv_nmos ad=0.2516p pd=2.16u as=0.1406p ps=1.12u w=0.74u l=0.13u
X261 VSS.t88 a_2595_1047.t8 a_8231_1008# VSS.t87 sg13_lv_nmos ad=0.2516p pd=2.16u as=0.2516p ps=2.16u w=0.74u l=0.13u
X262 VSS.t297 a_6283_1842# a_6717_1842# VSS.t296 sg13_lv_nmos ad=0.1406p pd=1.12u as=0.2516p ps=2.16u w=0.74u l=0.13u
X263 a_10430_1044# a_10404_1008# a_10328_1044# VDD.t0 sg13_lv_pmos ad=0.3808p pd=2.92u as=0.2128p ps=1.5u w=1.12u l=0.13u
X264 VDD.t316 DELAY_VBIASP a_26151_2470# VDD.t7 sg13_lv_pmos ad=0.3808p pd=2.92u as=0.2128p ps=1.5u w=1.12u l=0.6u
X265 a_7390_1044# a_8884_1008# a_8808_1044# VDD.t0 sg13_lv_pmos ad=0.3808p pd=2.92u as=0.2128p ps=1.5u w=1.12u l=0.13u
X266 a_11491_6228# a_10649_5878# a_11397_6228# VSS.t236 sg13_lv_nmos ad=0.12665p pd=1.145u as=0.1428p ps=1.52u w=0.42u l=0.13u
X267 VDD.t297 DELAY_VBIASP a_4871_2470# VDD.t7 sg13_lv_pmos ad=0.3808p pd=2.92u as=0.2128p ps=1.5u w=1.12u l=0.6u
X268 a_6126_3816# a_6126_3816# VSS.t389 VSS.t387 sg13_lv_nmos ad=0.38p pd=2.38u as=0.68p ps=4.68u w=2u l=1u
X269 a_3449_331# MUX_SEL2 VDD.t326 VDD.t0 sg13_lv_pmos ad=0.1596p pd=1.22u as=0.2856p ps=2.36u w=0.84u l=0.13u
X270 VDD.t6 VSS.t146 VDD.t4 VDD.t0 sg13_lv_pmos ad=0.19p pd=1.38u as=0 ps=0 w=1u l=1u
X271 a_19073_1842# a_18877_1842# VSS.t279 VSS.t417 sg13_lv_nmos ad=0.2516p pd=2.16u as=0.1406p ps=1.12u w=0.74u l=0.13u
X272 VDD.t351 a_15077_1842# a_15545_1044# VDD.t0 sg13_lv_pmos ad=0.252p pd=1.57u as=0.3808p ps=2.92u w=1.12u l=0.13u
X273 a_19550_1044# a_2019_1047.t4 a_19448_1044# VSS.t94 sg13_lv_nmos ad=0.2516p pd=2.16u as=0.1406p ps=1.12u w=0.74u l=0.13u
X274 VDD.t189 a_12849_5867# a_13306_5105# VDD.t13 sg13_lv_pmos ad=0.36237p pd=2.605u as=79.8f ps=0.8u w=0.42u l=0.13u
X275 VDD.t110 VDD.t108 VDD.t109 VDD.t7 sg13_lv_pmos ad=0.3808p pd=2.92u as=0 ps=0 w=1.12u l=0.6u
X276 VSS.t167 VDD.t393 VSS.t165 VSS.t166 sg13_lv_nmos ad=79.8f pd=0.8u as=0 ps=0 w=0.42u l=1u
X277 a_13592_5871# a_13566_5835# VSS.t267 VSS.t266 sg13_lv_nmos ad=0.2516p pd=2.16u as=0.1626p ps=1.415u w=0.74u l=0.13u
X278 VSS.t229 a_19203_1842# a_19637_1842# VSS.t262 sg13_lv_nmos ad=0.1406p pd=1.12u as=0.2516p ps=2.16u w=0.74u l=0.13u
X279 VDD.t2 VSS.t146 VDD.t1 VDD.t0 sg13_lv_pmos ad=0.19p pd=1.38u as=0 ps=0 w=1u l=1u
X280 a_15108_6109# a_12849_5867# VDD.t14 VDD.t13 sg13_lv_pmos ad=79.8f pd=0.8u as=1.03698p ps=6.245u w=0.42u l=0.13u
X281 VDD.t359 VSS.t125 VDD.t358 VDD.t0 sg13_lv_pmos ad=0.34p pd=2.68u as=0 ps=0 w=1u l=1u
X282 VSS.t340 a_15108_6109# a_14757_6228# VSS.t34 sg13_lv_nmos ad=79.8f pd=0.8u as=0.1428p ps=1.52u w=0.42u l=0.13u
X283 a_27433_1842# a_27237_1842# VDD.t149 VDD.t7 sg13_lv_pmos ad=0.3808p pd=2.92u as=0.2128p ps=1.5u w=1.12u l=0.13u
X284 VDD.t43 a_1256_289# a_2873_331# VDD.t0 sg13_lv_pmos ad=0.1918p pd=1.5u as=0.1596p ps=1.22u w=0.84u l=0.13u
X285 a_13470_1044# a_2595_1047.t6 a_14235_1044# VSS.t618 sg13_lv_nmos ad=0.2516p pd=2.16u as=0.1406p ps=1.12u w=0.74u l=0.13u
X286 VSS.t457 a_9444_4590# a_9444_4590# VSS.t448 sg13_lv_nmos ad=0.68p pd=4.68u as=0.38p ps=2.38u w=2u l=1u
X287 VSS.t405 a_8563_1842# a_8997_1842# VSS.t485 sg13_lv_nmos ad=0.1406p pd=1.12u as=0.2516p ps=2.16u w=0.74u l=0.13u
X288 VSS.t597 VSS.t597 VSS.t599 VSS.t598 sg13_lv_nmos ad=0.2516p pd=2.16u as=0 ps=0 w=0.74u l=0.13u
X289 VSS.t221 DELAY_VBIASN a_13231_1842# VSS.t506 sg13_lv_nmos ad=0.2516p pd=2.16u as=0.1406p ps=1.12u w=0.74u l=0.6u
X290 VDD.t236 a_3171_1047.t7 a_11924_1008# VDD.t0 sg13_lv_pmos ad=0.3808p pd=2.92u as=0.3808p ps=2.92u w=1.12u l=0.13u
X291 VSS.t370 a_2019_1047.t3 a_22564_1008# VSS.t369 sg13_lv_nmos ad=0.2516p pd=2.16u as=0.2516p ps=2.16u w=0.74u l=0.13u
X292 a_15053_5420# a_14111_5227# a_14851_5182# VDD.t13 sg13_lv_pmos ad=93.45f pd=0.865u as=0.2048p ps=1.63u w=0.42u l=0.13u
X293 VSS.t596 VSS.t592 VSS.t592 VSS.t594 sg13_lv_nmos ad=0.1406p pd=1.12u as=0 ps=0 w=0.74u l=0.13u
X294 VSS.t261 a_23003_1842# a_23437_1842# VSS.t330 sg13_lv_nmos ad=0.1406p pd=1.12u as=0.2516p ps=2.16u w=0.74u l=0.13u
X295 VSS.t167 VDD.t392 VSS.t167 VSS.t168 sg13_lv_nmos ad=0.1428p pd=1.52u as=0 ps=0 w=0.42u l=1u
X296 VDD.t303 DELAY_VBIASP a_7151_2470# VDD.t7 sg13_lv_pmos ad=0.3808p pd=2.92u as=0.2128p ps=1.5u w=1.12u l=0.6u
X297 a_5778_3367# VSS.t378 VSS.t377 rppd l=32u w=1u
X298 a_25630_1044# a_25604_1008# a_25528_1044# VDD.t0 sg13_lv_pmos ad=0.3808p pd=2.92u as=0.2128p ps=1.5u w=1.12u l=0.13u
X299 a_10206_5835# a_10649_5878# a_10589_5914# VDD.t13 sg13_lv_pmos ad=79.8f pd=0.8u as=63f ps=0.72u w=0.42u l=0.13u
X300 a_15511_1842# a_15273_1842# a_15403_1842# VSS.t398 sg13_lv_nmos ad=0.1406p pd=1.12u as=0.2516p ps=2.16u w=0.74u l=0.2u
X301 a_10520_6292# a_10751_5878# a_10206_5835# VSS.t257 sg13_lv_nmos ad=0.2373p pd=1.97u as=79.8f ps=0.8u w=0.42u l=0.13u
X302 a_11693_5990# a_10751_5878# a_11491_6228# VDD.t13 sg13_lv_pmos ad=93.45f pd=0.865u as=0.2048p ps=1.63u w=0.42u l=0.13u
X303 a_18313_1842# a_18117_1842# VDD.t17 VDD.t7 sg13_lv_pmos ad=0.3808p pd=2.92u as=0.2128p ps=1.5u w=1.12u l=0.13u
X304 a_5731_289# a_11785_519# a_10430_1044# VDD.t0 sg13_lv_pmos ad=0.3808p pd=2.92u as=0.3808p ps=2.92u w=1.12u l=0.13u
X305 VSS.t111 VDD.t409 VSS.t109 VSS.t110 sg13_lv_nmos ad=79.8f pd=0.8u as=0 ps=0 w=0.42u l=1u
X306 a_9431_2470# a_9193_1842# a_9323_1842# VDD.t7 sg13_lv_pmos ad=0.2128p pd=1.5u as=0.3808p ps=2.92u w=1.12u l=0.2u
X307 a_17275_1044# a_17065_1044# VSS.t33 VSS.t32 sg13_lv_nmos ad=0.1406p pd=1.12u as=0.1665p ps=1.19u w=0.74u l=0.13u
X308 VDD.t70 VSS.t81 VDD.t69 VDD.t0 sg13_lv_pmos ad=0.34p pd=2.68u as=0 ps=0 w=1u l=1u
X309 VSS.t74 a_3747_1047.t6 a_15831_1008# VSS.t73 sg13_lv_nmos ad=0.2516p pd=2.16u as=0.2516p ps=2.16u w=0.74u l=0.13u
X310 a_23871_2470# a_23633_1842# a_23763_1842# VDD.t7 sg13_lv_pmos ad=0.2128p pd=1.5u as=0.3808p ps=2.92u w=1.12u l=0.2u
X311 VSS.t98 a_13883_1842# a_14317_1842# VSS.t97 sg13_lv_nmos ad=0.1406p pd=1.12u as=0.2516p ps=2.16u w=0.74u l=0.13u
X312 VSS.t102 a_3747_311.t2 a_26985_519# VSS.t101 sg13_lv_nmos ad=0.2516p pd=2.16u as=0.2516p ps=2.16u w=0.74u l=0.13u
X313 a_8433_1842# a_8237_1842# VDD.t188 VDD.t7 sg13_lv_pmos ad=0.3808p pd=2.92u as=0.2128p ps=1.5u w=1.12u l=0.13u
X314 VDD.t181 a_18443_1842# a_18877_1842# VDD.t7 sg13_lv_pmos ad=0.2128p pd=1.5u as=0.3808p ps=2.92u w=1.12u l=0.13u
X315 a_22113_1842# a_21917_1842# VDD.t145 VDD.t7 sg13_lv_pmos ad=0.3808p pd=2.92u as=0.2128p ps=1.5u w=1.12u l=0.13u
X316 a_4350_1044# a_2019_1047.t9 a_4248_1044# VSS.t293 sg13_lv_nmos ad=0.2516p pd=2.16u as=0.1406p ps=1.12u w=0.74u l=0.13u
X317 a_14888_1044# a_14317_1842# VSS.t439 VSS.t438 sg13_lv_nmos ad=0.1406p pd=1.12u as=0.2516p ps=2.16u w=0.74u l=0.13u
X318 a_13880_5118# a_13592_5423# a_13818_5118# VSS.t357 sg13_lv_nmos ad=0.1428p pd=1.52u as=37.8f ps=0.6u w=0.42u l=0.13u
X319 a_16108_289# a_3747_311.t2 a_25630_1044# VSS.t100 sg13_lv_nmos ad=0.2516p pd=2.16u as=0.2516p ps=2.16u w=0.74u l=0.13u
X320 VDD.t306 DELAY_VBIASP a_12471_2470# VDD.t7 sg13_lv_pmos ad=0.3808p pd=2.92u as=0.2128p ps=1.5u w=1.12u l=0.6u
X321 VSS.t54 a_4003_1842# a_4437_1842# VSS.t288 sg13_lv_nmos ad=0.1406p pd=1.12u as=0.2516p ps=2.16u w=0.74u l=0.13u
X322 a_16510_1044# a_16484_1008# a_16408_1044# VDD.t0 sg13_lv_pmos ad=0.3808p pd=2.92u as=0.2128p ps=1.5u w=1.12u l=0.13u
X323 VSS.t46 a_13121_5831# a_13045_6215# VSS.t45 sg13_lv_nmos ad=0.2516p pd=2.16u as=0.1406p ps=1.12u w=0.74u l=0.13u
X324 VDD.t264 a_14851_5182# a_15688_5403# VDD.t13 sg13_lv_pmos ad=0.2128p pd=1.5u as=0.3864p ps=2.93u w=1.12u l=0.13u
X325 VDD.t10 a_22243_1842# a_22677_1842# VDD.t7 sg13_lv_pmos ad=0.2128p pd=1.5u as=0.3808p ps=2.92u w=1.12u l=0.13u
X326 VDD.t114 a_3171_1047.t2 a_27124_1008# VDD.t0 sg13_lv_pmos ad=0.3808p pd=2.92u as=0.3808p ps=2.92u w=1.12u l=0.13u
X327 VDD.t138 MUX_SEL3 a_3449_331# VDD.t0 sg13_lv_pmos ad=0.1918p pd=1.5u as=0.1596p ps=1.22u w=0.84u l=0.13u
X328 a_2595_311.t0 a_2297_331# VDD.t331 VDD.t0 sg13_lv_pmos ad=0.2128p pd=1.5u as=0.1918p ps=1.5u w=1.12u l=0.13u
X329 a_10430_1044# a_11271_1008# a_11195_1044# VDD.t0 sg13_lv_pmos ad=0.3808p pd=2.92u as=0.2128p ps=1.5u w=1.12u l=0.13u
X330 a_14009_5084# DELAY_OUT_LAST VSS.t13 VSS.t252 sg13_lv_nmos ad=0.2516p pd=2.16u as=1.45407p ps=9.445u w=0.74u l=0.13u
X331 a_23355_1044# a_23145_1044# VDD.t81 VDD.t0 sg13_lv_pmos ad=0.2128p pd=1.5u as=0.252p ps=1.57u w=1.12u l=0.13u
X332 VDD.t67 a_3747_1047.t4 a_21911_1008# VDD.t0 sg13_lv_pmos ad=0.3808p pd=2.92u as=0.3808p ps=2.92u w=1.12u l=0.13u
X333 VSS.t28 a_8997_1842# a_9465_1044# VSS.t403 sg13_lv_nmos ad=0.1665p pd=1.19u as=0.2516p ps=2.16u w=0.74u l=0.13u
X334 a_13592_5423# a_13566_5328# VDD.t189 VDD.t13 sg13_lv_pmos ad=0.34p pd=2.68u as=0.36237p ps=2.605u w=1u l=0.13u
X335 a_6126_3816# a_5974_5723# a_6326_4590# VSS.t274 sg13_lv_nmos ad=0.68p pd=4.68u as=0.38p ps=2.38u w=2u l=1u
X336 a_20968_1044# a_20397_1842# VDD.t240 VDD.t0 sg13_lv_pmos ad=0.2128p pd=1.5u as=0.3808p ps=2.92u w=1.12u l=0.13u
X337 a_10951_1842# a_10713_1842# a_10843_1842# VSS.t440 sg13_lv_nmos ad=0.1406p pd=1.12u as=0.2516p ps=2.16u w=0.74u l=0.2u
X338 VSS.t17 a_2019_1047.t5 a_16484_1008# VSS.t16 sg13_lv_nmos ad=0.2516p pd=2.16u as=0.2516p ps=2.16u w=0.74u l=0.13u
X339 a_26151_2470# a_25913_1842# a_26043_1842# VDD.t7 sg13_lv_pmos ad=0.2128p pd=1.5u as=0.3808p ps=2.92u w=1.12u l=0.2u
X340 a_9444_4590# a_6854_5454# a_6854_5454# VSS.t625 sg13_lv_nmos ad=0.68p pd=4.68u as=0.38p ps=2.38u w=2u l=1u
X341 a_13753_1842# a_13557_1842# VDD.t144 VDD.t7 sg13_lv_pmos ad=0.3808p pd=2.92u as=0.2128p ps=1.5u w=1.12u l=0.13u
X342 VDD.t257 a_1721_331# a_2019_311# VDD.t0 sg13_lv_pmos ad=0.4256p pd=3u as=0.2128p ps=1.5u w=1.12u l=0.13u
X343 a_4871_2470# a_4633_1842# a_4763_1842# VDD.t7 sg13_lv_pmos ad=0.2128p pd=1.5u as=0.3808p ps=2.92u w=1.12u l=0.2u
X344 VSS.t91 a_3171_1047.t9 a_5844_1008# VSS.t90 sg13_lv_nmos ad=0.2516p pd=2.16u as=0.2516p ps=2.16u w=0.74u l=0.13u
X345 VSS.t20 VDD.t401 VSS.t20 VSS.t137 sg13_lv_nmos ad=79.8f pd=0.8u as=0 ps=0 w=0.42u l=1u
X346 VDD.t72 a_2595_311.t2 a_20905_519# VDD.t0 sg13_lv_pmos ad=0.3808p pd=2.92u as=0.3808p ps=2.92u w=1.12u l=0.13u
X347 VDD.t373 a_2297_331# a_2595_311.t0 VDD.t0 sg13_lv_pmos ad=0.4256p pd=3u as=0.2128p ps=1.5u w=1.12u l=0.13u
X348 a_14009_5084# DELAY_OUT_LAST VDD.t14 VDD.t13 sg13_lv_pmos ad=0.4088p pd=2.97u as=1.10612p ps=6.66u w=1.12u l=0.13u
X349 VSS.t50 a_2595_1047.t7 a_11271_1008# VSS.t49 sg13_lv_nmos ad=0.2516p pd=2.16u as=0.2516p ps=2.16u w=0.74u l=0.13u
X350 VSS.t229 DELAY_VBIASN a_19311_1842# VSS.t498 sg13_lv_nmos ad=0.2516p pd=2.16u as=0.1406p ps=1.12u w=0.74u l=0.6u
X351 VSS.t449 a_9444_4590# a_9444_3912# VSS.t448 sg13_lv_nmos ad=0.68p pd=4.68u as=0.38p ps=2.38u w=2u l=1u
X352 a_13880_5118# a_14111_5227# a_13566_5328# VSS.t342 sg13_lv_nmos ad=0.2373p pd=1.97u as=79.8f ps=0.8u w=0.42u l=0.13u
X353 VDD.t42 a_24523_1842# a_24957_1842# VDD.t7 sg13_lv_pmos ad=0.2128p pd=1.5u as=0.3808p ps=2.92u w=1.12u l=0.13u
X354 VSS.t211 a_3747_1047.t8 a_9751_1008# VSS.t210 sg13_lv_nmos ad=0.2516p pd=2.16u as=0.2516p ps=2.16u w=0.74u l=0.13u
X355 VSS.t183 DELAY_VBIASN a_9431_1842# VSS.t509 sg13_lv_nmos ad=0.2516p pd=2.16u as=0.1406p ps=1.12u w=0.74u l=0.6u
X356 a_19448_1044# a_18877_1842# VDD.t323 VDD.t0 sg13_lv_pmos ad=0.2128p pd=1.5u as=0.3808p ps=2.92u w=1.12u l=0.13u
X357 VSS.t46 a_11491_6228# a_12158_5867# VSS.t470 sg13_lv_nmos ad=0.1406p pd=1.12u as=0.2516p ps=2.16u w=0.74u l=0.13u
X358 a_13566_5328# a_14009_5084# a_13949_5496# VDD.t13 sg13_lv_pmos ad=79.8f pd=0.8u as=63f ps=0.72u w=0.42u l=0.13u
X359 VSS.t261 DELAY_VBIASN a_23111_1842# VSS.t559 sg13_lv_nmos ad=0.2516p pd=2.16u as=0.1406p ps=1.12u w=0.74u l=0.6u
X360 a_10430_1044# a_11924_1008# a_11848_1044# VDD.t0 sg13_lv_pmos ad=0.3808p pd=2.92u as=0.2128p ps=1.5u w=1.12u l=0.13u
X361 VDD.t318 DELAY_VBIASP a_27671_2470# VDD.t7 sg13_lv_pmos ad=0.3808p pd=2.92u as=0.2128p ps=1.5u w=1.12u l=0.6u
X362 a_6854_5986# a_6326_4590# VDD.t47 VDD.t13 sg13_lv_pmos ad=0.38p pd=2.38u as=0.38p ps=2.38u w=2u l=1u
X363 VSS.t514 DELAY_VBIASN DELAY_VBIASP VSS.t513 sg13_lv_nmos ad=0.2516p pd=2.16u as=0.6808p ps=3.32u w=0.74u l=0.6u
X364 a_25630_1044# a_26471_1008# a_26395_1044# VDD.t0 sg13_lv_pmos ad=0.3808p pd=2.92u as=0.2128p ps=1.5u w=1.12u l=0.13u
X365 VSS.t519 DELAY_VBIASN VSS.t521 VSS.t520 sg13_lv_nmos ad=1.33p pd=7.38u as=0 ps=0 w=7u l=7u
X366 a_10040_6305# a_9772_5843# a_9946_6305# VSS.t442 sg13_lv_nmos ad=60.89999f pd=0.71u as=0.1428p ps=1.52u w=0.42u l=0.13u
X367 a_7151_2470# a_6913_1842# a_7043_1842# VDD.t7 sg13_lv_pmos ad=0.2128p pd=1.5u as=0.3808p ps=2.92u w=1.12u l=0.2u
X368 a_16033_1842# a_15837_1842# VDD.t9 VDD.t7 sg13_lv_pmos ad=0.3808p pd=2.92u as=0.2128p ps=1.5u w=1.12u l=0.13u
X369 VDD.t50 a_6326_4590# a_6326_4590# VDD.t13 sg13_lv_pmos ad=0.38p pd=2.38u as=0.38p ps=2.38u w=2u l=1u
X370 VDD.t254 a_15964_289# a_16851_309# VDD.t0 sg13_lv_pmos ad=0.2086p pd=1.5u as=0.34p ps=2.68u w=1u l=0.13u
X371 VDD.t4 VSS.t146 VDD.t3 VDD.t0 sg13_lv_pmos ad=0.34p pd=2.68u as=0 ps=0 w=1u l=1u
X372 a_15464_3684# a_14851_5182# VSS.t335 VSS.t363 sg13_lv_nmos ad=0.2849p pd=2.25u as=0.2516p ps=2.16u w=0.74u l=0.13u
X373 VSS.t217 a_11603_1842# a_12037_1842# VSS.t328 sg13_lv_nmos ad=0.1406p pd=1.12u as=0.2516p ps=2.16u w=0.74u l=0.13u
X374 VSS.t152 VDD.t397 VSS.t150 VSS.t151 sg13_lv_nmos ad=79.8f pd=0.8u as=0 ps=0 w=0.42u l=1u
X375 VDD.t268 VSS.t123 VDD.t267 VDD.t0 sg13_lv_pmos ad=0.34p pd=2.68u as=0 ps=0 w=1u l=1u
X376 VDD.t272 a_5957_1842# a_6425_1044# VDD.t0 sg13_lv_pmos ad=0.252p pd=1.57u as=0.3808p ps=2.92u w=1.12u l=0.13u
X377 a_24393_1842# a_24197_1842# VSS.t104 VSS.t566 sg13_lv_nmos ad=0.2516p pd=2.16u as=0.1406p ps=1.12u w=0.74u l=0.13u
X378 a_3747_1047.t1 a_3449_1395# VSS.t238 VSS.t237 sg13_lv_nmos ad=0.1406p pd=1.12u as=0.1331p ps=1.12u w=0.74u l=0.13u
X379 a_1544_1044# MUX_SEL1 VSS.t248 VSS.t413 sg13_lv_nmos ad=0.2516p pd=2.16u as=0.2516p ps=2.16u w=0.74u l=0.13u
X380 VDD.t1 VSS.t144 VDD.t27 VDD.t0 sg13_lv_pmos ad=0.34p pd=2.68u as=0 ps=0 w=1u l=1u
X381 a_3171_1047.t0 a_2873_1395# VDD.t339 VDD.t0 sg13_lv_pmos ad=0.2128p pd=1.5u as=0.1918p ps=1.5u w=1.12u l=0.13u
X382 a_13470_1044# a_3747_1047.t6 a_15755_1044# VSS.t72 sg13_lv_nmos ad=0.2516p pd=2.16u as=0.1406p ps=1.12u w=0.74u l=0.13u
X383 VDD.t285 a_15464_3684# a_9712_3912# VSS.t409 sg13_lv_nmos ad=0.232p pd=2.08u as=0.136p ps=1.14u w=0.4u l=0.2u
X384 VDD.t8 a_5523_1842# a_5957_1842# VDD.t7 sg13_lv_pmos ad=0.2128p pd=1.5u as=0.3808p ps=2.92u w=1.12u l=0.13u
X385 VDD.t223 a_2297_1395# a_2595_1047.t0 VDD.t0 sg13_lv_pmos ad=0.4256p pd=3u as=0.2128p ps=1.5u w=1.12u l=0.13u
X386 VSS.t468 DELAY_VBIASN a_14751_1842# VSS.t511 sg13_lv_nmos ad=0.2516p pd=2.16u as=0.1406p ps=1.12u w=0.74u l=0.6u
X387 a_2967_1395# MUX_SEL1 a_2873_1395# VSS.t414 sg13_lv_nmos ad=0.1216p pd=1.02u as=0.2176p ps=1.96u w=0.64u l=0.13u
X388 a_4350_1044# a_2595_1047.t9 a_5115_1044# VSS.t319 sg13_lv_nmos ad=0.2516p pd=2.16u as=0.1406p ps=1.12u w=0.74u l=0.13u
X389 VDD.t265 a_2019_1047.t6 a_13444_1008# VDD.t0 sg13_lv_pmos ad=0.3808p pd=2.92u as=0.3808p ps=2.92u w=1.12u l=0.13u
X390 VSS.t327 a_2595_1047.t2 a_26471_1008# VSS.t326 sg13_lv_nmos ad=0.2516p pd=2.16u as=0.2516p ps=2.16u w=0.74u l=0.13u
X391 a_2595_311.t1 a_2297_331# VSS.t59 VSS.t483 sg13_lv_nmos ad=0.1406p pd=1.12u as=0.1331p ps=1.12u w=0.74u l=0.13u
X392 VSS.t200 a_14009_5878# a_14111_5878# VSS.t254 sg13_lv_nmos ad=2.39977p pd=15.495u as=0.2516p ps=2.16u w=0.74u l=0.13u
X393 VSS.t54 DELAY_VBIASN a_4111_1842# VSS.t510 sg13_lv_nmos ad=0.2516p pd=2.16u as=0.1406p ps=1.12u w=0.74u l=0.6u
X394 a_2297_1395# MUX_SEL0 VDD.t333 VDD.t0 sg13_lv_pmos ad=0.1596p pd=1.22u as=0.2856p ps=2.36u w=0.84u l=0.13u
X395 VSS.t33 a_16597_1842# a_17065_1044# VSS.t316 sg13_lv_nmos ad=0.1665p pd=1.19u as=0.2516p ps=2.16u w=0.74u l=0.13u
X396 VDD.t304 DELAY_VBIASP a_8671_2470# VDD.t7 sg13_lv_pmos ad=0.3808p pd=2.92u as=0.2128p ps=1.5u w=1.12u l=0.6u
X397 VDD.t220 VSS.t121 VDD.t219 VDD.t0 sg13_lv_pmos ad=0.19p pd=1.38u as=0 ps=0 w=1u l=1u
X398 VDD.t157 a_1544_1044# a_1721_1395# VDD.t0 sg13_lv_pmos ad=0.1918p pd=1.5u as=0.1596p ps=1.22u w=0.84u l=0.13u
X399 a_9444_4590# a_9444_4590# VSS.t456 VSS.t446 sg13_lv_nmos ad=0.38p pd=2.38u as=0.68p ps=4.68u w=2u l=1u
X400 a_4248_1044# a_4157_1313# VDD.t224 VDD.t0 sg13_lv_pmos ad=0.2128p pd=1.5u as=0.3808p ps=2.92u w=1.12u l=0.13u
X401 a_5778_3367# a_6126_3816# a_6326_4590# VSS.t387 sg13_lv_nmos ad=0.68p pd=4.68u as=0.38p ps=2.38u w=2u l=1u
X402 a_12471_2470# a_12233_1842# a_12363_1842# VDD.t7 sg13_lv_pmos ad=0.2128p pd=1.5u as=0.3808p ps=2.92u w=1.12u l=0.2u
X403 a_17031_1842# a_16793_1842# a_16923_1842# VSS.t65 sg13_lv_nmos ad=0.1406p pd=1.12u as=0.2516p ps=2.16u w=0.74u l=0.2u
X404 VSS.t59 a_1721_331# a_2019_311# VSS.t356 sg13_lv_nmos ad=0.2812p pd=2.24u as=0.1406p ps=1.12u w=0.74u l=0.13u
X405 a_19550_1044# a_21911_1008# a_21835_1044# VDD.t0 sg13_lv_pmos ad=0.3808p pd=2.92u as=0.2128p ps=1.5u w=1.12u l=0.13u
X406 a_16108_289# a_26985_519# a_25630_1044# VDD.t0 sg13_lv_pmos ad=0.3808p pd=2.92u as=0.3808p ps=2.92u w=1.12u l=0.13u
X407 VSS.t59 a_2297_331# a_2595_311.t1 VSS.t484 sg13_lv_nmos ad=0.2812p pd=2.24u as=0.1406p ps=1.12u w=0.74u l=0.13u
X408 a_18795_1044# a_18585_1044# VSS.t226 VSS.t225 sg13_lv_nmos ad=0.1406p pd=1.12u as=0.1665p ps=1.19u w=0.74u l=0.13u
X409 a_9444_3912# a_6854_5454# a_9712_3912# VSS.t625 sg13_lv_nmos ad=0.68p pd=4.68u as=0.38p ps=2.38u w=2u l=1u
X410 a_20831_1842# a_20593_1842# a_20723_1842# VSS.t385 sg13_lv_nmos ad=0.1406p pd=1.12u as=0.2516p ps=2.16u w=0.74u l=0.2u
X411 VSS.t109 VDD.t409 VSS.t108 VSS.t107 sg13_lv_nmos ad=0.1428p pd=1.52u as=0 ps=0 w=0.42u l=1u
X412 VDD.t81 a_22677_1842# a_23145_1044# VDD.t0 sg13_lv_pmos ad=0.252p pd=1.57u as=0.3808p ps=2.92u w=1.12u l=0.13u
X413 VSS.t85 a_2595_1047.t5 a_17351_1008# VSS.t84 sg13_lv_nmos ad=0.2516p pd=2.16u as=0.2516p ps=2.16u w=0.74u l=0.13u
X414 a_5393_1842# a_5197_1842# VSS.t487 VSS.t569 sg13_lv_nmos ad=0.2516p pd=2.16u as=0.1406p ps=1.12u w=0.74u l=0.13u
X415 VSS.t373 DELAY_VBIASN a_17031_1842# VSS.t556 sg13_lv_nmos ad=0.2516p pd=2.16u as=0.1406p ps=1.12u w=0.74u l=0.6u
X416 a_25630_1044# a_3171_1047.t2 a_27048_1044# VSS.t170 sg13_lv_nmos ad=0.2516p pd=2.16u as=0.1406p ps=1.12u w=0.74u l=0.13u
X417 VDD.t95 VDD.t93 VDD.t94 VDD.t38 sg13_lv_pmos ad=0.3808p pd=2.92u as=0 ps=0 w=1.12u l=0.13u
X418 a_9953_1842# a_9757_1842# VDD.t127 VDD.t7 sg13_lv_pmos ad=0.3808p pd=2.92u as=0.2128p ps=1.5u w=1.12u l=0.13u
X419 VDD.t253 a_10843_1842# a_11277_1842# VDD.t7 sg13_lv_pmos ad=0.2128p pd=1.5u as=0.3808p ps=2.92u w=1.12u l=0.13u
X420 VSS.t231 a_26803_1842# a_27237_1842# VSS.t265 sg13_lv_nmos ad=0.1406p pd=1.12u as=0.2516p ps=2.16u w=0.74u l=0.13u
X421 a_4350_1044# a_3171_1047.t9 a_5768_1044# VSS.t89 sg13_lv_nmos ad=0.2516p pd=2.16u as=0.1406p ps=1.12u w=0.74u l=0.13u
X422 VDD.t244 a_12849_5867# a_13566_5328# VDD.t13 sg13_lv_pmos ad=0.1563p pd=1.22u as=0.147p ps=1.54u w=0.42u l=0.13u
X423 VDD.t100 VDD.t101 VDD.t102 VDD.t38 sg13_lv_pmos ad=0.2128p pd=1.5u as=0 ps=0 w=1.12u l=0.13u
X424 a_10430_1044# a_12791_1008# a_12715_1044# VDD.t0 sg13_lv_pmos ad=0.3808p pd=2.92u as=0.2128p ps=1.5u w=1.12u l=0.13u
X425 a_19311_1842# a_19073_1842# a_19203_1842# VSS.t418 sg13_lv_nmos ad=0.1406p pd=1.12u as=0.2516p ps=2.16u w=0.74u l=0.2u
X426 a_24875_1044# a_24665_1044# VDD.t273 VDD.t0 sg13_lv_pmos ad=0.2128p pd=1.5u as=0.252p ps=1.57u w=1.12u l=0.13u
X427 VDD.t391 a_2595_1047.t3 a_23431_1008# VDD.t0 sg13_lv_pmos ad=0.3808p pd=2.92u as=0.3808p ps=2.92u w=1.12u l=0.13u
X428 VDD.t14 a_14009_5878# a_14111_5878# VDD.t13 sg13_lv_pmos ad=1.10612p pd=6.66u as=0.3864p ps=2.93u w=1.12u l=0.13u
X429 a_13949_5914# a_13592_5871# VDD.t203 VDD.t13 sg13_lv_pmos ad=63f pd=0.72u as=0.1563p ps=1.22u w=0.42u l=0.13u
X430 VDD.t63 a_13557_1842# a_14025_1044# VDD.t0 sg13_lv_pmos ad=0.252p pd=1.57u as=0.3808p ps=2.92u w=1.12u l=0.13u
X431 a_23111_1842# a_22873_1842# a_23003_1842# VSS.t310 sg13_lv_nmos ad=0.1406p pd=1.12u as=0.2516p ps=2.16u w=0.74u l=0.2u
X432 VSS.t198 a_10649_5878# a_10751_5878# VSS.t235 sg13_lv_nmos ad=2.39977p pd=15.495u as=0.2516p ps=2.16u w=0.74u l=0.13u
X433 a_27671_2470# a_27433_1842# a_27563_1842# VDD.t7 sg13_lv_pmos ad=0.2128p pd=1.5u as=0.3808p ps=2.92u w=1.12u l=0.2u
X434 VSS.t22 a_17683_1842# a_18117_1842# VSS.t21 sg13_lv_nmos ad=0.1406p pd=1.12u as=0.2516p ps=2.16u w=0.74u l=0.13u
X435 VSS.t146 VDD.t398 VSS.t146 VSS.t148 sg13_lv_nmos ad=79.8f pd=0.8u as=0 ps=0 w=0.42u l=1u
X436 a_10713_1842# a_10517_1842# VSS.t179 VSS.t178 sg13_lv_nmos ad=0.2516p pd=2.16u as=0.1406p ps=1.12u w=0.74u l=0.13u
X437 VSS.t495 a_2019_1047.t8 a_7364_1008# VSS.t494 sg13_lv_nmos ad=0.2516p pd=2.16u as=0.2516p ps=2.16u w=0.74u l=0.13u
X438 VSS.t545 DELAY_VBIASN VSS.t543 VSS.t528 sg13_lv_nmos ad=1.33p pd=7.38u as=0 ps=0 w=7u l=7u
X439 VSS.t285 a_7803_1842# a_8237_1842# VSS.t284 sg13_lv_nmos ad=0.1406p pd=1.12u as=0.2516p ps=2.16u w=0.74u l=0.13u
X440 a_13592_5871# a_14111_5878# a_14851_6228# VSS.t34 sg13_lv_nmos ad=0.3473p pd=2.71u as=0.12665p ps=1.145u w=0.74u l=0.13u
X441 a_15304_4605# a_14851_6228# VSS.t38 VSS.t37 sg13_lv_nmos ad=0.2849p pd=2.25u as=0.2516p ps=2.16u w=0.74u l=0.13u
X442 VDD.t292 DELAY_VBIASP a_16271_2470# VDD.t7 sg13_lv_pmos ad=0.3808p pd=2.92u as=0.2128p ps=1.5u w=1.12u l=0.6u
X443 VSS.t146 VDD.t399 VSS.t144 VSS.t145 sg13_lv_nmos ad=79.8f pd=0.8u as=0 ps=0 w=0.42u l=1u
X444 VSS.t125 VDD.t404 VSS.t125 VSS.t126 sg13_lv_nmos ad=0.1428p pd=1.52u as=0 ps=0 w=0.42u l=1u
X445 a_6854_5454# a_6854_5454# a_9444_4590# VSS.t624 sg13_lv_nmos ad=0.38p pd=2.38u as=0.68p ps=4.68u w=2u l=1u
X446 VDD.t280 a_26043_1842# a_26477_1842# VDD.t7 sg13_lv_pmos ad=0.2128p pd=1.5u as=0.3808p ps=2.92u w=1.12u l=0.13u
X447 VDD.t34 DLL_RESETN a_10206_5835# VDD.t13 sg13_lv_pmos ad=0.1563p pd=1.22u as=0.147p ps=1.54u w=0.42u l=0.13u
X448 a_3543_331# MUX_SEL2 a_3449_331# VSS.t421 sg13_lv_nmos ad=0.1216p pd=1.02u as=0.2176p ps=1.96u w=0.64u l=0.13u
X449 a_22488_1044# a_21917_1842# VSS.t71 VSS.t406 sg13_lv_nmos ad=0.1406p pd=1.12u as=0.2516p ps=2.16u w=0.74u l=0.13u
X450 a_14851_5182# a_14009_5084# a_13592_5423# VDD.t13 sg13_lv_pmos ad=0.2048p pd=1.63u as=0.34p ps=2.68u w=1u l=0.13u
X451 VDD.t201 VSS.t115 VDD.t199 VDD.t0 sg13_lv_pmos ad=0.19p pd=1.38u as=0 ps=0 w=1u l=1u
X452 a_22590_1044# a_24084_1008# a_24008_1044# VDD.t0 sg13_lv_pmos ad=0.3808p pd=2.92u as=0.2128p ps=1.5u w=1.12u l=0.13u
X453 VDD.t312 DELAY_VBIASP a_20071_2470# VDD.t7 sg13_lv_pmos ad=0.3808p pd=2.92u as=0.2128p ps=1.5u w=1.12u l=0.6u
X454 a_9444_3912# a_9444_4590# VSS.t447 VSS.t446 sg13_lv_nmos ad=0.38p pd=2.38u as=0.68p ps=4.68u w=2u l=1u
X455 a_14751_1842# a_14513_1842# a_14643_1842# VSS.t360 sg13_lv_nmos ad=0.1406p pd=1.12u as=0.2516p ps=2.16u w=0.74u l=0.2u
X456 VSS.t435 a_2873_1395# a_3171_1047.t1 VSS.t459 sg13_lv_nmos ad=0.2812p pd=2.24u as=0.1406p ps=1.12u w=0.74u l=0.13u
X457 VDD.t355 VSS.t163 VDD.t218 VDD.t0 sg13_lv_pmos ad=0.19p pd=1.38u as=0 ps=0 w=1u l=1u
X458 a_25630_1044# a_27991_1008# a_27915_1044# VDD.t0 sg13_lv_pmos ad=0.3808p pd=2.92u as=0.2128p ps=1.5u w=1.12u l=0.13u
X459 VSS.t608 VSS.t605 VSS.t605 VSS.t606 sg13_lv_nmos ad=0.1406p pd=1.12u as=0 ps=0 w=0.74u l=0.13u
X460 a_4111_1842# REF_CLK a_4003_1842# VSS.t201 sg13_lv_nmos ad=0.1406p pd=1.12u as=0.2516p ps=2.16u w=0.74u l=0.2u
X461 a_8671_2470# a_8433_1842# a_8563_1842# VDD.t7 sg13_lv_pmos ad=0.2128p pd=1.5u as=0.3808p ps=2.92u w=1.12u l=0.2u
X462 a_17553_1842# a_17357_1842# VDD.t270 VDD.t7 sg13_lv_pmos ad=0.3808p pd=2.92u as=0.2128p ps=1.5u w=1.12u l=0.13u
X463 VSS.t248 a_1544_1044# a_2391_1395# VSS.t249 sg13_lv_nmos ad=0.1331p pd=1.12u as=0.1216p ps=1.02u w=0.64u l=0.13u
X464 VSS.t20 a_3747_311.t3 a_14825_519# VSS.t19 sg13_lv_nmos ad=0.2516p pd=2.16u as=0.2516p ps=2.16u w=0.74u l=0.13u
X465 VSS.t59 a_1256_289# a_2967_331# VSS.t58 sg13_lv_nmos ad=0.1331p pd=1.12u as=0.1216p ps=1.02u w=0.64u l=0.13u
X466 a_2019_1047.t1 a_1721_1395# VSS.t248 VSS.t272 sg13_lv_nmos ad=0.1406p pd=1.12u as=0.1331p ps=1.12u w=0.74u l=0.13u
X467 a_15964_289# a_15765_463# a_5731_289# VSS.t466 sg13_lv_nmos ad=0.2183p pd=1.33u as=0.2516p ps=2.16u w=0.74u l=0.13u
X468 a_13470_1044# a_2019_1047.t6 a_13368_1044# VSS.t365 sg13_lv_nmos ad=0.2516p pd=2.16u as=0.1406p ps=1.12u w=0.74u l=0.13u
X469 VDD.t84 VDD.t82 VDD.t47 VDD.t13 sg13_lv_pmos ad=0.68p pd=4.68u as=0 ps=0 w=2u l=1u
X470 VSS.t221 a_13123_1842# a_13557_1842# VSS.t220 sg13_lv_nmos ad=0.1406p pd=1.12u as=0.2516p ps=2.16u w=0.74u l=0.13u
X471 VDD.t65 VSS.t165 VDD.t64 VDD.t0 sg13_lv_pmos ad=0.34p pd=2.68u as=0 ps=0 w=1u l=1u
X472 VSS.t189 a_3171_1047.t3 a_24084_1008# VSS.t188 sg13_lv_nmos ad=0.2516p pd=2.16u as=0.2516p ps=2.16u w=0.74u l=0.13u
X473 a_25913_1842# a_25717_1842# VSS.t26 VSS.t25 sg13_lv_nmos ad=0.2516p pd=2.16u as=0.1406p ps=1.12u w=0.74u l=0.13u
X474 VDD.t14 a_10649_5878# a_10751_5878# VDD.t13 sg13_lv_pmos ad=1.10612p pd=6.66u as=0.3864p ps=2.93u w=1.12u l=0.13u
X475 a_21353_1842# a_21157_1842# VDD.t180 VDD.t7 sg13_lv_pmos ad=0.3808p pd=2.92u as=0.2128p ps=1.5u w=1.12u l=0.13u
X476 VSS.t150 VDD.t397 VSS.t81 VSS.t149 sg13_lv_nmos ad=0.1428p pd=1.52u as=0 ps=0 w=0.42u l=1u
X477 a_2297_331# MUX_SEL2 VDD.t327 VDD.t0 sg13_lv_pmos ad=0.1596p pd=1.22u as=0.2856p ps=2.36u w=0.84u l=0.13u
X478 VDD.t205 a_7043_1842# a_7477_1842# VDD.t7 sg13_lv_pmos ad=0.2128p pd=1.5u as=0.3808p ps=2.92u w=1.12u l=0.13u
X479 a_2873_331# MUX_SEL3 VDD.t137 VDD.t0 sg13_lv_pmos ad=0.1596p pd=1.22u as=0.2856p ps=2.36u w=0.84u l=0.13u
X480 a_10589_5914# a_10232_5871# VDD.t34 VDD.t13 sg13_lv_pmos ad=63f pd=0.72u as=0.1563p ps=1.22u w=0.42u l=0.13u
X481 a_8155_1044# a_7945_1044# VDD.t12 VDD.t0 sg13_lv_pmos ad=0.2128p pd=1.5u as=0.252p ps=1.57u w=1.12u l=0.13u
X482 a_13880_6292# a_13592_5871# a_13818_6292# VSS.t289 sg13_lv_nmos ad=0.1428p pd=1.52u as=37.8f ps=0.6u w=0.42u l=0.13u
X483 VSS.t226 a_18117_1842# a_18585_1044# VSS.t250 sg13_lv_nmos ad=0.1665p pd=1.19u as=0.2516p ps=2.16u w=0.74u l=0.13u
X484 a_27048_1044# a_26477_1842# VDD.t365 VDD.t0 sg13_lv_pmos ad=0.2128p pd=1.5u as=0.3808p ps=2.92u w=1.12u l=0.13u
X485 a_5768_1044# a_5197_1842# VDD.t384 VDD.t0 sg13_lv_pmos ad=0.2128p pd=1.5u as=0.3808p ps=2.92u w=1.12u l=0.13u
X486 a_10232_5871# a_10751_5878# a_11491_6228# VSS.t236 sg13_lv_nmos ad=0.3473p pd=2.71u as=0.12665p ps=1.145u w=0.74u l=0.13u
X487 a_12656_5864# DLL_RESETN VDD.t183 VDD.t13 sg13_lv_pmos ad=0.3808p pd=2.92u as=0.3808p ps=2.92u w=1.12u l=0.13u
X488 a_13991_2470# a_13753_1842# a_13883_1842# VDD.t7 sg13_lv_pmos ad=0.2128p pd=1.5u as=0.3808p ps=2.92u w=1.12u l=0.2u
X489 VSS.t186 a_3171_1047.t6 a_14964_1008# VSS.t185 sg13_lv_nmos ad=0.2516p pd=2.16u as=0.2516p ps=2.16u w=0.74u l=0.13u
X490 VDD.t252 a_2019_311# a_17865_519# VDD.t0 sg13_lv_pmos ad=0.3808p pd=2.92u as=0.3808p ps=2.92u w=1.12u l=0.13u
X491 DELAY_OUT_LAST a_27997_1842# VSS.t242 VSS.t241 sg13_lv_nmos ad=0.2516p pd=2.16u as=0.1406p ps=1.12u w=0.74u l=0.13u
X492 a_11195_1044# a_10985_1044# VSS.t177 VSS.t345 sg13_lv_nmos ad=0.1406p pd=1.12u as=0.1665p ps=1.19u w=0.74u l=0.13u
X493 VDD.t273 a_24197_1842# a_24665_1044# VDD.t0 sg13_lv_pmos ad=0.252p pd=1.57u as=0.3808p ps=2.92u w=1.12u l=0.13u
X494 a_6913_1842# a_6717_1842# VSS.t297 VSS.t462 sg13_lv_nmos ad=0.2516p pd=2.16u as=0.1406p ps=1.12u w=0.74u l=0.13u
X495 VSS.t279 DELAY_VBIASN a_18551_1842# VSS.t557 sg13_lv_nmos ad=0.2516p pd=2.16u as=0.1406p ps=1.12u w=0.74u l=0.6u
X496 a_16510_1044# a_18004_1008# a_17928_1044# VDD.t0 sg13_lv_pmos ad=0.3808p pd=2.92u as=0.2128p ps=1.5u w=1.12u l=0.13u
X497 a_13592_5423# a_13566_5328# VSS.t287 VSS.t286 sg13_lv_nmos ad=0.2516p pd=2.16u as=0.1626p ps=1.415u w=0.74u l=0.13u
X498 VDD.t31 a_12363_1842# a_12797_1842# VDD.t7 sg13_lv_pmos ad=0.2128p pd=1.5u as=0.3808p ps=2.92u w=1.12u l=0.13u
X499 VSS.t208 MUX_SEL3 a_3543_331# VSS.t207 sg13_lv_nmos ad=0.1331p pd=1.12u as=0.1216p ps=1.02u w=0.64u l=0.13u
X500 a_22590_1044# a_2595_1047.t3 a_23355_1044# VSS.t620 sg13_lv_nmos ad=0.2516p pd=2.16u as=0.1406p ps=1.12u w=0.74u l=0.13u
X501 a_9712_3912# a_6854_5454# a_9444_3912# VSS.t624 sg13_lv_nmos ad=0.38p pd=2.38u as=0.68p ps=4.68u w=2u l=1u
X502 VSS.t5 DELAY_VBIASN a_22351_1842# VSS.t502 sg13_lv_nmos ad=0.2516p pd=2.16u as=0.1406p ps=1.12u w=0.74u l=0.6u
X503 VDD.t387 a_3171_1047.t4 a_21044_1008# VDD.t0 sg13_lv_pmos ad=0.3808p pd=2.92u as=0.3808p ps=2.92u w=1.12u l=0.13u
X504 VDD.t121 VSS.t156 VDD.t119 VDD.t0 sg13_lv_pmos ad=0.19p pd=1.38u as=0 ps=0 w=1u l=1u
X505 a_16271_2470# a_16033_1842# a_16163_1842# VDD.t7 sg13_lv_pmos ad=0.2128p pd=1.5u as=0.3808p ps=2.92u w=1.12u l=0.2u
X506 VDD.t191 VSS.t20 VDD.t21 VDD.t0 sg13_lv_pmos ad=0.19p pd=1.38u as=0 ps=0 w=1u l=1u
X507 a_19833_1842# a_19637_1842# VSS.t229 VSS.t228 sg13_lv_nmos ad=0.2516p pd=2.16u as=0.1406p ps=1.12u w=0.74u l=0.13u
X508 VDD.t251 a_2019_311# a_5705_519# VDD.t0 sg13_lv_pmos ad=0.3808p pd=2.92u as=0.3808p ps=2.92u w=1.12u l=0.13u
X509 VDD.t28 a_14851_6228# a_15108_6109# VDD.t13 sg13_lv_pmos ad=0.2639p pd=1.81u as=79.8f ps=0.8u w=0.42u l=0.13u
X510 a_10520_6292# a_10232_5871# a_10458_6292# VSS.t44 sg13_lv_nmos ad=0.1428p pd=1.52u as=37.8f ps=0.6u w=0.42u l=0.13u
X511 a_15270_6305# a_12849_5867# VSS.t340 VSS.t34 sg13_lv_nmos ad=37.8f pd=0.6u as=79.8f ps=0.8u w=0.42u l=0.13u
X512 a_20071_2470# a_19833_1842# a_19963_1842# VDD.t7 sg13_lv_pmos ad=0.2128p pd=1.5u as=0.3808p ps=2.92u w=1.12u l=0.2u
X513 a_9193_1842# a_8997_1842# VSS.t405 VSS.t404 sg13_lv_nmos ad=0.2516p pd=2.16u as=0.1406p ps=1.12u w=0.74u l=0.13u
X514 a_24631_1842# a_24393_1842# a_24523_1842# VSS.t575 sg13_lv_nmos ad=0.1406p pd=1.12u as=0.2516p ps=2.16u w=0.74u l=0.2u
X515 VDD.t193 VSS.t20 VDD.t192 VDD.t0 sg13_lv_pmos ad=0.34p pd=2.68u as=0 ps=0 w=1u l=1u
X516 VSS.t8 a_2019_1047.t7 a_10404_1008# VSS.t7 sg13_lv_nmos ad=0.2516p pd=2.16u as=0.2516p ps=2.16u w=0.74u l=0.13u
X517 VSS.t525 DELAY_VBIASN VSS.t527 VSS.t526 sg13_lv_nmos ad=1.33p pd=7.38u as=0 ps=0 w=7u l=7u
X518 VDD.t352 a_14643_1842# a_15077_1842# VDD.t7 sg13_lv_pmos ad=0.2128p pd=1.5u as=0.3808p ps=2.92u w=1.12u l=0.13u
X519 VDD.t331 a_1544_289# a_2297_331# VDD.t0 sg13_lv_pmos ad=0.1918p pd=1.5u as=0.1596p ps=1.22u w=0.84u l=0.13u
X520 a_23633_1842# a_23437_1842# VSS.t261 VSS.t260 sg13_lv_nmos ad=0.2516p pd=2.16u as=0.1406p ps=1.12u w=0.74u l=0.13u
X521 VSS.t146 VDD.t398 VSS.t146 VSS.t147 sg13_lv_nmos ad=0.1428p pd=1.52u as=0 ps=0 w=0.42u l=1u
X522 a_2019_311# a_1721_331# VDD.t256 VDD.t0 sg13_lv_pmos ad=0.2128p pd=1.5u as=0.1918p ps=1.5u w=1.12u l=0.13u
X523 VSS.t183 a_9323_1842# a_9757_1842# VSS.t182 sg13_lv_nmos ad=0.1406p pd=1.12u as=0.2516p ps=2.16u w=0.74u l=0.13u
X524 a_26395_1044# a_26185_1044# VSS.t24 VSS.t68 sg13_lv_nmos ad=0.1406p pd=1.12u as=0.1665p ps=1.19u w=0.74u l=0.13u
X525 VDD.t310 DELAY_VBIASP a_17791_2470# VDD.t7 sg13_lv_pmos ad=0.3808p pd=2.92u as=0.2128p ps=1.5u w=1.12u l=0.6u
X526 VSS.t303 a_3747_1047.t3 a_24951_1008# VSS.t482 sg13_lv_nmos ad=0.2516p pd=2.16u as=0.2516p ps=2.16u w=0.74u l=0.13u
X527 VSS.t123 VDD.t405 VSS.t123 VSS.t122 sg13_lv_nmos ad=0.1428p pd=1.52u as=0 ps=0 w=0.42u l=1u
X528 VSS.t144 VDD.t399 VSS.t144 VSS.t143 sg13_lv_nmos ad=0.1428p pd=1.52u as=0 ps=0 w=0.42u l=1u
X529 a_3747_1047.t0 a_3449_1395# VDD.t152 VDD.t0 sg13_lv_pmos ad=0.2128p pd=1.5u as=0.1918p ps=1.5u w=1.12u l=0.13u
X530 a_13368_1044# a_12797_1842# VDD.t32 VDD.t0 sg13_lv_pmos ad=0.2128p pd=1.5u as=0.3808p ps=2.92u w=1.12u l=0.13u
X531 a_24008_1044# a_23437_1842# VSS.t259 VSS.t258 sg13_lv_nmos ad=0.1406p pd=1.12u as=0.2516p ps=2.16u w=0.74u l=0.13u
X532 VDD.t291 DELAY_VBIASP a_21591_2470# VDD.t7 sg13_lv_pmos ad=0.3808p pd=2.92u as=0.2128p ps=1.5u w=1.12u l=0.6u
X533 a_15964_289# MUX_SEL4 a_5731_289# VDD.t0 sg13_lv_pmos ad=0.3304p pd=1.71u as=0.3808p ps=2.92u w=1.12u l=0.13u
X534 a_4350_1044# a_6711_1008# a_6635_1044# VDD.t0 sg13_lv_pmos ad=0.3808p pd=2.92u as=0.2128p ps=1.5u w=1.12u l=0.13u
X535 a_2873_1395# MUX_SEL1 VDD.t322 VDD.t0 sg13_lv_pmos ad=0.1596p pd=1.22u as=0.2856p ps=2.36u w=0.84u l=0.13u
X536 VSS.t287 a_12849_5867# a_13400_5105# VSS.t339 sg13_lv_nmos ad=0.1626p pd=1.415u as=60.89999f ps=0.71u w=0.42u l=0.13u
X537 a_1256_1044# MUX_SEL0 VSS.t248 VSS.t427 sg13_lv_nmos ad=0.2516p pd=2.16u as=0.2516p ps=2.16u w=0.74u l=0.13u
X538 VSS.t121 VDD.t406 VSS.t119 VSS.t120 sg13_lv_nmos ad=79.8f pd=0.8u as=0 ps=0 w=0.42u l=1u
X539 a_19550_1044# a_20391_1008# a_20315_1044# VDD.t0 sg13_lv_pmos ad=0.3808p pd=2.92u as=0.2128p ps=1.5u w=1.12u l=0.13u
X540 VDD.t113 VDD.t111 VDD.t110 VDD.t7 sg13_lv_pmos ad=0.2128p pd=1.5u as=0 ps=0 w=1.12u l=0.2u
X541 a_5631_1842# a_5393_1842# a_5523_1842# VSS.t564 sg13_lv_nmos ad=0.1406p pd=1.12u as=0.2516p ps=2.16u w=0.74u l=0.2u
X542 a_14513_1842# a_14317_1842# VSS.t98 VSS.t437 sg13_lv_nmos ad=0.2516p pd=2.16u as=0.1406p ps=1.12u w=0.74u l=0.13u
X543 VSS.t81 a_2595_311.t2 a_20905_519# VSS.t80 sg13_lv_nmos ad=0.2516p pd=2.16u as=0.2516p ps=2.16u w=0.74u l=0.13u
X544 VDD.t12 a_7477_1842# a_7945_1044# VDD.t0 sg13_lv_pmos ad=0.252p pd=1.57u as=0.3808p ps=2.92u w=1.12u l=0.13u
X545 a_13470_1044# a_3171_1047.t6 a_14888_1044# VSS.t184 sg13_lv_nmos ad=0.2516p pd=2.16u as=0.1406p ps=1.12u w=0.74u l=0.13u
X546 a_4633_1842# a_4437_1842# VSS.t54 VSS.t53 sg13_lv_nmos ad=0.2516p pd=2.16u as=0.1406p ps=1.12u w=0.74u l=0.13u
X547 a_1256_289# MUX_SEL2 VSS.t205 VSS.t419 sg13_lv_nmos ad=0.2516p pd=2.16u as=0.2516p ps=2.16u w=0.74u l=0.13u
X548 VSS.t194 a_2019_1047.t2 a_25604_1008# VSS.t193 sg13_lv_nmos ad=0.2516p pd=2.16u as=0.2516p ps=2.16u w=0.74u l=0.13u
X549 a_13019_5831# a_15688_5403# VDD.t264 VDD.t13 sg13_lv_pmos ad=0.3808p pd=2.92u as=0.2128p ps=1.5u w=1.12u l=0.13u
X550 VSS.t521 DELAY_VBIASN VSS.t523 VSS.t522 sg13_lv_nmos ad=1.33p pd=7.38u as=0 ps=0 w=7u l=7u
X551 a_16108_289# MUX_SEL4 a_15964_289# VSS.t212 sg13_lv_nmos ad=0.2516p pd=2.16u as=0.2183p ps=1.33u w=0.74u l=0.13u
X552 a_13400_6305# a_12355_5867# a_13306_6305# VSS.t617 sg13_lv_nmos ad=60.89999f pd=0.71u as=0.1428p ps=1.52u w=0.42u l=0.13u
X553 a_22873_1842# a_22677_1842# VDD.t10 VDD.t7 sg13_lv_pmos ad=0.3808p pd=2.92u as=0.2128p ps=1.5u w=1.12u l=0.13u
X554 a_21835_1044# a_21625_1044# VSS.t271 VSS.t270 sg13_lv_nmos ad=0.1406p pd=1.12u as=0.1665p ps=1.19u w=0.74u l=0.13u
X555 VSS.t175 a_2595_1047.t4 a_20391_1008# VSS.t174 sg13_lv_nmos ad=0.2516p pd=2.16u as=0.2516p ps=2.16u w=0.74u l=0.13u
X556 a_9675_1044# a_9465_1044# VDD.t24 VDD.t0 sg13_lv_pmos ad=0.2128p pd=1.5u as=0.252p ps=1.57u w=1.12u l=0.13u
X557 VSS.t177 a_10517_1842# a_10985_1044# VSS.t176 sg13_lv_nmos ad=0.1665p pd=1.19u as=0.2516p ps=2.16u w=0.74u l=0.13u
X558 VDD.t75 a_2595_1047.t8 a_8231_1008# VDD.t0 sg13_lv_pmos ad=0.3808p pd=2.92u as=0.3808p ps=2.92u w=1.12u l=0.13u
X559 a_18551_1842# a_18313_1842# a_18443_1842# VSS.t243 sg13_lv_nmos ad=0.1406p pd=1.12u as=0.2516p ps=2.16u w=0.74u l=0.2u
X560 a_12943_5867# a_12656_5864# a_12849_5867# VDD.t13 sg13_lv_pmos ad=0.2128p pd=1.5u as=0.3808p ps=2.92u w=1.12u l=0.13u
X561 a_13566_5835# a_14009_5878# a_13949_5914# VDD.t13 sg13_lv_pmos ad=79.8f pd=0.8u as=63f ps=0.72u w=0.42u l=0.13u
X562 a_22351_1842# a_22113_1842# a_22243_1842# VSS.t329 sg13_lv_nmos ad=0.1406p pd=1.12u as=0.2516p ps=2.16u w=0.74u l=0.2u
X563 VSS.t412 a_3747_1047.t5 a_18871_1008# VSS.t411 sg13_lv_nmos ad=0.2516p pd=2.16u as=0.2516p ps=2.16u w=0.74u l=0.13u
X564 VSS.t373 a_16923_1842# a_17357_1842# VSS.t480 sg13_lv_nmos ad=0.1406p pd=1.12u as=0.2516p ps=2.16u w=0.74u l=0.13u
X565 VDD.t133 a_3171_311.t2 a_23945_519# VDD.t0 sg13_lv_pmos ad=0.3808p pd=2.92u as=0.3808p ps=2.92u w=1.12u l=0.13u
X566 a_2019_311# a_1721_331# VSS.t59 VSS.t355 sg13_lv_nmos ad=0.1406p pd=1.12u as=0.1331p ps=1.12u w=0.74u l=0.13u
X567 a_25153_1842# a_24957_1842# VDD.t42 VDD.t7 sg13_lv_pmos ad=0.3808p pd=2.92u as=0.2128p ps=1.5u w=1.12u l=0.13u
X568 a_17928_1044# a_17357_1842# VSS.t85 VSS.t371 sg13_lv_nmos ad=0.1406p pd=1.12u as=0.2516p ps=2.16u w=0.74u l=0.13u
X569 a_12715_1044# a_12505_1044# VSS.t219 VSS.t488 sg13_lv_nmos ad=0.1406p pd=1.12u as=0.1665p ps=1.19u w=0.74u l=0.13u
X570 a_13880_6292# a_14111_5878# a_13566_5835# VSS.t298 sg13_lv_nmos ad=0.2373p pd=1.97u as=79.8f ps=0.8u w=0.42u l=0.13u
X571 a_15053_5990# a_14111_5878# a_14851_6228# VDD.t13 sg13_lv_pmos ad=93.45f pd=0.865u as=0.2048p ps=1.63u w=0.42u l=0.13u
X572 VDD.t141 MUX_SEL4 a_15765_463# VDD.t0 sg13_lv_pmos ad=0.3808p pd=2.92u as=0.3808p ps=2.92u w=1.12u l=0.13u
X573 a_19550_1044# a_3171_1047.t4 a_20968_1044# VSS.t572 sg13_lv_nmos ad=0.2516p pd=2.16u as=0.1406p ps=1.12u w=0.74u l=0.13u
X574 VSS.t352 DELAY_VBIASN a_10951_1842# VSS.t550 sg13_lv_nmos ad=0.2516p pd=2.16u as=0.1406p ps=1.12u w=0.74u l=0.6u
X575 a_19550_1044# a_19524_1008# a_19448_1044# VDD.t0 sg13_lv_pmos ad=0.3808p pd=2.92u as=0.2128p ps=1.5u w=1.12u l=0.13u
X576 a_7288_1044# a_6717_1842# VSS.t307 VSS.t461 sg13_lv_nmos ad=0.1406p pd=1.12u as=0.2516p ps=2.16u w=0.74u l=0.13u
X577 a_12355_5867# a_12158_5867# VSS.t46 VSS.t346 sg13_lv_nmos ad=0.2516p pd=2.16u as=0.1406p ps=1.12u w=0.74u l=0.13u
X578 VSS.t276 a_20723_1842# a_21157_1842# VSS.t275 sg13_lv_nmos ad=0.1406p pd=1.12u as=0.2516p ps=2.16u w=0.74u l=0.13u
X579 VDD.t30 a_14851_6228# a_15688_5867# VDD.t13 sg13_lv_pmos ad=0.2128p pd=1.5u as=0.3864p ps=2.93u w=1.12u l=0.13u
X580 a_1544_289# MUX_SEL3 VSS.t205 VSS.t204 sg13_lv_nmos ad=0.2516p pd=2.16u as=0.2516p ps=2.16u w=0.74u l=0.13u
X581 a_13470_1044# a_14311_1008# a_14235_1044# VDD.t0 sg13_lv_pmos ad=0.3808p pd=2.92u as=0.2128p ps=1.5u w=1.12u l=0.13u
X582 a_22590_1044# a_3747_1047.t3 a_24875_1044# VSS.t481 sg13_lv_nmos ad=0.2516p pd=2.16u as=0.1406p ps=1.12u w=0.74u l=0.13u
X583 VSS.t104 DELAY_VBIASN a_23871_1842# VSS.t507 sg13_lv_nmos ad=0.2516p pd=2.16u as=0.1406p ps=1.12u w=0.74u l=0.6u
X584 VDD.t266 a_2019_1047.t3 a_22564_1008# VDD.t0 sg13_lv_pmos ad=0.3808p pd=2.92u as=0.3808p ps=2.92u w=1.12u l=0.13u
X585 VSS.t24 a_25717_1842# a_26185_1044# VSS.t23 sg13_lv_nmos ad=0.1665p pd=1.19u as=0.2516p ps=2.16u w=0.74u l=0.13u
X586 a_13231_1842# a_12993_1842# a_13123_1842# VSS.t222 sg13_lv_nmos ad=0.1406p pd=1.12u as=0.2516p ps=2.16u w=0.74u l=0.2u
X587 VSS.t115 VDD.t407 VSS.t115 VSS.t117 sg13_lv_nmos ad=79.8f pd=0.8u as=0 ps=0 w=0.42u l=1u
X588 a_17791_2470# a_17553_1842# a_17683_1842# VDD.t7 sg13_lv_pmos ad=0.2128p pd=1.5u as=0.3808p ps=2.92u w=1.12u l=0.2u
X589 VSS.t52 a_4437_1842# a_4905_1044# VSS.t51 sg13_lv_nmos ad=0.1665p pd=1.19u as=0.2516p ps=2.16u w=0.74u l=0.13u
X590 VDD.t119 VSS.t156 VDD.t118 VDD.t0 sg13_lv_pmos ad=0.34p pd=2.68u as=0 ps=0 w=1u l=1u
X591 a_12233_1842# a_12037_1842# VSS.t217 VSS.t216 sg13_lv_nmos ad=0.2516p pd=2.16u as=0.1406p ps=1.12u w=0.74u l=0.13u
X592 VDD.t14 a_9547_6172# a_9547_5942# VDD.t13 sg13_lv_pmos ad=1.10612p pd=6.66u as=0.2442p ps=2.06u w=0.66u l=0.13u
X593 a_15108_5325# a_14851_5182# a_15270_5105# VSS.t362 sg13_lv_nmos ad=0.1428p pd=1.52u as=37.8f ps=0.6u w=0.42u l=0.13u
X594 VSS.t240 a_3449_1395# a_3747_1047.t1 VSS.t239 sg13_lv_nmos ad=0.2812p pd=2.24u as=0.1406p ps=1.12u w=0.74u l=0.13u
X595 VDD.t21 VSS.t134 VDD.t20 VDD.t0 sg13_lv_pmos ad=0.34p pd=2.68u as=0 ps=0 w=1u l=1u
X596 VDD.t36 VSS.t142 VDD.t23 VDD.t0 sg13_lv_pmos ad=0.19p pd=1.38u as=0 ps=0 w=1u l=1u
X597 VSS.t163 VDD.t394 VSS.t161 VSS.t162 sg13_lv_nmos ad=79.8f pd=0.8u as=0 ps=0 w=0.42u l=1u
X598 VSS.t478 a_3171_1047.t8 a_8884_1008# VSS.t477 sg13_lv_nmos ad=0.2516p pd=2.16u as=0.2516p ps=2.16u w=0.74u l=0.13u
X599 a_21591_2470# a_21353_1842# a_21483_1842# VDD.t7 sg13_lv_pmos ad=0.2128p pd=1.5u as=0.3808p ps=2.92u w=1.12u l=0.2u
X600 VDD.t346 a_2873_1395# a_3171_1047.t0 VDD.t0 sg13_lv_pmos ad=0.4256p pd=3u as=0.2128p ps=1.5u w=1.12u l=0.13u
X601 a_6153_1842# a_5957_1842# VDD.t8 VDD.t7 sg13_lv_pmos ad=0.3808p pd=2.92u as=0.2128p ps=1.5u w=1.12u l=0.13u
X602 VDD.t228 a_16163_1842# a_16597_1842# VDD.t7 sg13_lv_pmos ad=0.2128p pd=1.5u as=0.3808p ps=2.92u w=1.12u l=0.13u
X603 a_3543_1395# MUX_SEL0 a_3449_1395# VSS.t429 sg13_lv_nmos ad=0.1216p pd=1.02u as=0.2176p ps=1.96u w=0.64u l=0.13u
X604 VDD.t158 a_1544_1044# a_2297_1395# VDD.t0 sg13_lv_pmos ad=0.1918p pd=1.5u as=0.1596p ps=1.22u w=0.84u l=0.13u
X605 VDD.t293 DELAY_VBIASP a_10191_2470# VDD.t7 sg13_lv_pmos ad=0.3808p pd=2.92u as=0.2128p ps=1.5u w=1.12u l=0.6u
X606 a_17275_1044# a_17065_1044# VDD.t26 VDD.t0 sg13_lv_pmos ad=0.2128p pd=1.5u as=0.252p ps=1.57u w=1.12u l=0.13u
X607 a_2019_1047.t0 a_1721_1395# VDD.t157 VDD.t0 sg13_lv_pmos ad=0.2128p pd=1.5u as=0.1918p ps=1.5u w=1.12u l=0.13u
X608 a_27915_1044# a_27705_1044# VSS.t233 VSS.t431 sg13_lv_nmos ad=0.1406p pd=1.12u as=0.1665p ps=1.19u w=0.74u l=0.13u
X609 VSS.t402 DELAY_VBIASN a_26151_1842# VSS.t561 sg13_lv_nmos ad=0.2516p pd=2.16u as=0.1406p ps=1.12u w=0.74u l=0.6u
X610 VDD.t68 a_3747_1047.t6 a_15831_1008# VDD.t0 sg13_lv_pmos ad=0.3808p pd=2.92u as=0.3808p ps=2.92u w=1.12u l=0.13u
X611 VDD.t241 a_19963_1842# a_20397_1842# VDD.t7 sg13_lv_pmos ad=0.2128p pd=1.5u as=0.3808p ps=2.92u w=1.12u l=0.13u
X612 VSS.t165 VDD.t393 VSS.t165 VSS.t164 sg13_lv_nmos ad=0.1428p pd=1.52u as=0 ps=0 w=0.42u l=1u
X613 VSS.t487 DELAY_VBIASN a_4871_1842# VSS.t501 sg13_lv_nmos ad=0.2516p pd=2.16u as=0.1406p ps=1.12u w=0.74u l=0.6u
X614 a_14888_1044# a_14317_1842# VDD.t341 VDD.t0 sg13_lv_pmos ad=0.2128p pd=1.5u as=0.3808p ps=2.92u w=1.12u l=0.13u
X615 a_4350_1044# a_4324_1008# a_4248_1044# VDD.t0 sg13_lv_pmos ad=0.3808p pd=2.92u as=0.2128p ps=1.5u w=1.12u l=0.13u
X616 a_1256_289# MUX_SEL2 VDD.t325 VDD.t0 sg13_lv_pmos ad=0.3808p pd=2.92u as=0.3808p ps=2.92u w=1.12u l=0.13u
X617 VSS.t612 VSS.t609 VSS.t611 VSS.t610 sg13_lv_nmos ad=0.2516p pd=2.16u as=0 ps=0 w=0.74u l=0.6u
X618 a_16108_289# a_15765_463# a_15964_289# VDD.t0 sg13_lv_pmos ad=0.3808p pd=2.92u as=0.3304p ps=1.71u w=1.12u l=0.13u
X619 VDD.t203 a_12849_5867# a_13566_5835# VDD.t13 sg13_lv_pmos ad=0.1563p pd=1.22u as=0.147p ps=1.54u w=0.42u l=0.13u
X620 VSS.t517 DELAY_VBIASN VSS.t516 VSS.t515 sg13_lv_nmos ad=2.38p pd=14.68u as=0 ps=0 w=7u l=7u
X621 a_11473_1842# a_11277_1842# VDD.t253 VDD.t7 sg13_lv_pmos ad=0.3808p pd=2.92u as=0.2128p ps=1.5u w=1.12u l=0.13u
X622 VDD.t24 a_8997_1842# a_9465_1044# VDD.t0 sg13_lv_pmos ad=0.252p pd=1.57u as=0.3808p ps=2.92u w=1.12u l=0.13u
X623 a_27433_1842# a_27237_1842# VSS.t231 VSS.t230 sg13_lv_nmos ad=0.2516p pd=2.16u as=0.1406p ps=1.12u w=0.74u l=0.13u
X624 a_2391_331# MUX_SEL2 a_2297_331# VSS.t420 sg13_lv_nmos ad=0.1216p pd=1.02u as=0.2176p ps=1.96u w=0.64u l=0.13u
X625 a_2967_331# MUX_SEL3 a_2873_331# VSS.t206 sg13_lv_nmos ad=0.1216p pd=1.02u as=0.2176p ps=1.96u w=0.64u l=0.13u
X626 VDD.t15 a_2019_1047.t5 a_16484_1008# VDD.t0 sg13_lv_pmos ad=0.3808p pd=2.92u as=0.3808p ps=2.92u w=1.12u l=0.13u
X627 a_7390_1044# a_2595_1047.t8 a_8155_1044# VSS.t86 sg13_lv_nmos ad=0.2516p pd=2.16u as=0.1406p ps=1.12u w=0.74u l=0.13u
X628 VSS.t393 a_6126_3816# a_5974_5723# VSS.t274 sg13_lv_nmos ad=0.68p pd=4.68u as=0.38p ps=2.38u w=2u l=1u
X629 VSS.t292 DELAY_VBIASN a_7151_1842# VSS.t499 sg13_lv_nmos ad=0.2516p pd=2.16u as=0.1406p ps=1.12u w=0.74u l=0.6u
X630 VDD.t76 a_3171_1047.t9 a_5844_1008# VDD.t0 sg13_lv_pmos ad=0.3808p pd=2.92u as=0.3808p ps=2.92u w=1.12u l=0.13u
X631 VDD.t313 DELAY_VBIASP a_25391_2470# VDD.t7 sg13_lv_pmos ad=0.3808p pd=2.92u as=0.2128p ps=1.5u w=1.12u l=0.6u
X632 VDD.t39 a_2595_1047.t7 a_11271_1008# VDD.t0 sg13_lv_pmos ad=0.3808p pd=2.92u as=0.3808p ps=2.92u w=1.12u l=0.13u
X633 VDD.t361 VSS.t125 VDD.t359 VDD.t0 sg13_lv_pmos ad=0.19p pd=1.38u as=0 ps=0 w=1u l=1u
X634 VSS.t219 a_12037_1842# a_12505_1044# VSS.t218 sg13_lv_nmos ad=0.1665p pd=1.19u as=0.2516p ps=2.16u w=0.74u l=0.13u
X635 VDD.t140 a_3747_1047.t8 a_9751_1008# VDD.t0 sg13_lv_pmos ad=0.3808p pd=2.92u as=0.3808p ps=2.92u w=1.12u l=0.13u
X636 a_12943_5867# a_13121_5831# VDD.t37 VDD.t13 sg13_lv_pmos ad=0.3808p pd=2.92u as=0.2128p ps=1.5u w=1.12u l=0.13u
X637 a_11748_6109# a_11491_6228# a_11910_6305# VSS.t236 sg13_lv_nmos ad=0.1428p pd=1.52u as=37.8f ps=0.6u w=0.42u l=0.13u
X638 a_9431_1842# a_9193_1842# a_9323_1842# VSS.t361 sg13_lv_nmos ad=0.1406p pd=1.12u as=0.2516p ps=2.16u w=0.74u l=0.2u
X639 a_18313_1842# a_18117_1842# VSS.t22 VSS.t251 sg13_lv_nmos ad=0.2516p pd=2.16u as=0.1406p ps=1.12u w=0.74u l=0.13u
X640 MUX_OUT a_16851_309# VSS.t214 VSS.t353 sg13_lv_nmos ad=0.1406p pd=1.12u as=0.1371p ps=1.12u w=0.74u l=0.13u
X641 a_10232_5871# a_10206_5835# VDD.t174 VDD.t13 sg13_lv_pmos ad=0.34p pd=2.68u as=0.36237p ps=2.605u w=1u l=0.13u
X642 a_14851_5182# a_14009_5084# a_14757_5182# VSS.t14 sg13_lv_nmos ad=0.12665p pd=1.145u as=0.1428p ps=1.52u w=0.42u l=0.13u
X643 VSS.t156 VDD.t395 VSS.t156 VSS.t158 sg13_lv_nmos ad=79.8f pd=0.8u as=0 ps=0 w=0.42u l=1u
X644 a_23871_1842# a_23633_1842# a_23763_1842# VSS.t408 sg13_lv_nmos ad=0.1406p pd=1.12u as=0.2516p ps=2.16u w=0.74u l=0.2u
X645 a_8433_1842# a_8237_1842# VSS.t285 VSS.t400 sg13_lv_nmos ad=0.2516p pd=2.16u as=0.1406p ps=1.12u w=0.74u l=0.13u
X646 VSS.t279 a_18443_1842# a_18877_1842# VSS.t278 sg13_lv_nmos ad=0.1406p pd=1.12u as=0.2516p ps=2.16u w=0.74u l=0.13u
X647 VSS.t20 VDD.t402 VSS.t134 VSS.t135 sg13_lv_nmos ad=79.8f pd=0.8u as=0 ps=0 w=0.42u l=1u
X648 VSS.t391 a_6126_3816# a_5974_5723# VSS.t274 sg13_lv_nmos ad=0.68p pd=4.68u as=0.38p ps=2.38u w=2u l=1u
X649 a_22113_1842# a_21917_1842# VSS.t224 VSS.t407 sg13_lv_nmos ad=0.2516p pd=2.16u as=0.1406p ps=1.12u w=0.74u l=0.13u
X650 a_1544_289# MUX_SEL3 VDD.t139 VDD.t0 sg13_lv_pmos ad=0.3808p pd=2.92u as=0.3808p ps=2.92u w=1.12u l=0.13u
X651 VDD.t62 VDD.t85 VDD.t92 VDD.t13 sg13_lv_pmos ad=0.38p pd=2.38u as=0 ps=0 w=2u l=1u
X652 a_26673_1842# a_26477_1842# VDD.t280 VDD.t7 sg13_lv_pmos ad=0.3808p pd=2.92u as=0.2128p ps=1.5u w=1.12u l=0.13u
X653 a_10328_1044# a_9757_1842# VSS.t211 VSS.t299 sg13_lv_nmos ad=0.1406p pd=1.12u as=0.2516p ps=2.16u w=0.74u l=0.13u
X654 VSS.t20 VDD.t401 VSS.t20 VSS.t136 sg13_lv_nmos ad=0.1428p pd=1.52u as=0 ps=0 w=0.42u l=1u
X655 a_22590_1044# a_2019_1047.t3 a_22488_1044# VSS.t368 sg13_lv_nmos ad=0.2516p pd=2.16u as=0.1406p ps=1.12u w=0.74u l=0.13u
X656 VSS.t40 DELAY_VBIASN a_12471_1842# VSS.t503 sg13_lv_nmos ad=0.2516p pd=2.16u as=0.1406p ps=1.12u w=0.74u l=0.6u
X657 a_8808_1044# a_8237_1842# VSS.t88 VSS.t399 sg13_lv_nmos ad=0.1406p pd=1.12u as=0.2516p ps=2.16u w=0.74u l=0.13u
X658 VSS.t5 a_22243_1842# a_22677_1842# VSS.t4 sg13_lv_nmos ad=0.1406p pd=1.12u as=0.2516p ps=2.16u w=0.74u l=0.13u
X659 VDD.t301 DELAY_VBIASP a_6391_2470# VDD.t7 sg13_lv_pmos ad=0.3808p pd=2.92u as=0.2128p ps=1.5u w=1.12u l=0.6u
X660 a_13470_1044# a_15831_1008# a_15755_1044# VDD.t0 sg13_lv_pmos ad=0.3808p pd=2.92u as=0.2128p ps=1.5u w=1.12u l=0.13u
X661 a_1544_1044# MUX_SEL1 VDD.t321 VDD.t0 sg13_lv_pmos ad=0.3808p pd=2.92u as=0.3808p ps=2.92u w=1.12u l=0.13u
X662 VDD.t294 DELAY_VBIASP a_20831_2470# VDD.t7 sg13_lv_pmos ad=0.3808p pd=2.92u as=0.2128p ps=1.5u w=1.12u l=0.6u
X663 VDD.t237 a_2595_1047.t2 a_26471_1008# VDD.t0 sg13_lv_pmos ad=0.3808p pd=2.92u as=0.3808p ps=2.92u w=1.12u l=0.13u
X664 a_4350_1044# a_5191_1008# a_5115_1044# VDD.t0 sg13_lv_pmos ad=0.3808p pd=2.92u as=0.2128p ps=1.5u w=1.12u l=0.13u
X665 VDD.t26 a_16597_1842# a_17065_1044# VDD.t0 sg13_lv_pmos ad=0.252p pd=1.57u as=0.3808p ps=2.92u w=1.12u l=0.13u
X666 VSS.t233 a_27237_1842# a_27705_1044# VSS.t232 sg13_lv_nmos ad=0.1665p pd=1.19u as=0.2516p ps=2.16u w=0.74u l=0.13u
X667 VSS.t516 DELAY_VBIASN VSS.t519 VSS.t518 sg13_lv_nmos ad=1.33p pd=7.38u as=0 ps=0 w=7u l=7u
X668 a_10191_2470# a_9953_1842# a_10083_1842# VDD.t7 sg13_lv_pmos ad=0.2128p pd=1.5u as=0.3808p ps=2.92u w=1.12u l=0.2u
X669 a_2595_1047.t1 a_2297_1395# VSS.t248 VSS.t311 sg13_lv_nmos ad=0.1406p pd=1.12u as=0.1331p ps=1.12u w=0.74u l=0.13u
X670 a_26151_1842# a_25913_1842# a_26043_1842# VSS.t441 sg13_lv_nmos ad=0.1406p pd=1.12u as=0.2516p ps=2.16u w=0.74u l=0.2u
X671 VSS.t139 a_2019_311# a_17865_519# VSS.t350 sg13_lv_nmos ad=0.2516p pd=2.16u as=0.2516p ps=2.16u w=0.74u l=0.13u
X672 VSS.t59 a_1544_289# a_2391_331# VSS.t426 sg13_lv_nmos ad=0.1331p pd=1.12u as=0.1216p ps=1.02u w=0.64u l=0.13u
X673 a_4871_1842# a_4633_1842# a_4763_1842# VSS.t436 sg13_lv_nmos ad=0.1406p pd=1.12u as=0.2516p ps=2.16u w=0.74u l=0.2u
X674 a_13753_1842# a_13557_1842# VSS.t221 VSS.t315 sg13_lv_nmos ad=0.2516p pd=2.16u as=0.1406p ps=1.12u w=0.74u l=0.13u
X675 a_1815_1395# a_1256_1044# a_1721_1395# VSS.t433 sg13_lv_nmos ad=0.1216p pd=1.02u as=0.2176p ps=1.96u w=0.64u l=0.13u
X676 a_7673_1842# a_7477_1842# VDD.t205 VDD.t7 sg13_lv_pmos ad=0.3808p pd=2.92u as=0.2128p ps=1.5u w=1.12u l=0.13u
X677 VDD.t23 VSS.t139 VDD.t22 VDD.t0 sg13_lv_pmos ad=0.34p pd=2.68u as=0 ps=0 w=1u l=1u
X678 a_1721_331# a_1256_289# VDD.t44 VDD.t0 sg13_lv_pmos ad=0.1596p pd=1.22u as=0.2856p ps=2.36u w=0.84u l=0.13u
X679 VSS.t56 a_24523_1842# a_24957_1842# VSS.t55 sg13_lv_nmos ad=0.1406p pd=1.12u as=0.2516p ps=2.16u w=0.74u l=0.13u
X680 a_6635_1044# a_6425_1044# VSS.t376 VSS.t384 sg13_lv_nmos ad=0.1406p pd=1.12u as=0.1665p ps=1.19u w=0.74u l=0.13u
X681 VDD.t14 a_15108_5325# a_15053_5420# VDD.t13 sg13_lv_pmos ad=1.10612p pd=6.66u as=93.45f ps=0.865u w=0.42u l=0.13u
X682 VSS.t321 a_2595_1047.t9 a_5191_1008# VSS.t320 sg13_lv_nmos ad=0.2516p pd=2.16u as=0.2516p ps=2.16u w=0.74u l=0.13u
X683 a_20315_1044# a_20105_1044# VSS.t31 VSS.t30 sg13_lv_nmos ad=0.1406p pd=1.12u as=0.1665p ps=1.19u w=0.74u l=0.13u
X684 VDD.t309 DELAY_VBIASP a_11711_2470# VDD.t7 sg13_lv_pmos ad=0.3808p pd=2.92u as=0.2128p ps=1.5u w=1.12u l=0.6u
X685 a_18795_1044# a_18585_1044# VDD.t146 VDD.t0 sg13_lv_pmos ad=0.2128p pd=1.5u as=0.252p ps=1.57u w=1.12u l=0.13u
X686 a_25528_1044# a_24957_1842# VSS.t303 VSS.t302 sg13_lv_nmos ad=0.1406p pd=1.12u as=0.2516p ps=2.16u w=0.74u l=0.13u
X687 a_5778_3367# a_6126_3816# a_6326_4590# VSS.t387 sg13_lv_nmos ad=0.68p pd=4.68u as=0.38p ps=2.38u w=2u l=1u
X688 VSS.t541 DELAY_VBIASN VSS.t539 VSS.t524 sg13_lv_nmos ad=1.33p pd=7.38u as=0 ps=0 w=7u l=7u
X689 VSS.t563 DELAY_VBIASN a_27671_1842# VSS.t562 sg13_lv_nmos ad=0.2516p pd=2.16u as=0.1406p ps=1.12u w=0.74u l=0.6u
X690 a_5731_289# a_3747_311.t3 a_13470_1044# VSS.t18 sg13_lv_nmos ad=0.2516p pd=2.16u as=0.2516p ps=2.16u w=0.74u l=0.13u
X691 a_25630_1044# a_27124_1008# a_27048_1044# VDD.t0 sg13_lv_pmos ad=0.3808p pd=2.92u as=0.2128p ps=1.5u w=1.12u l=0.13u
X692 VDD.t74 a_2595_1047.t5 a_17351_1008# VDD.t0 sg13_lv_pmos ad=0.3808p pd=2.92u as=0.3808p ps=2.92u w=1.12u l=0.13u
X693 VSS.t47 a_13121_5831# a_6854_5986# VDD.t38 sg13_lv_pmos ad=0.232p pd=2.08u as=0.136p ps=1.14u w=0.4u l=0.2u
X694 VDD.t145 a_21483_1842# a_21917_1842# VDD.t7 sg13_lv_pmos ad=0.2128p pd=1.5u as=0.3808p ps=2.92u w=1.12u l=0.13u
X695 a_4350_1044# a_5844_1008# a_5768_1044# VDD.t0 sg13_lv_pmos ad=0.3808p pd=2.92u as=0.2128p ps=1.5u w=1.12u l=0.13u
X696 VSS.t214 a_16851_309# MUX_OUT VSS.t354 sg13_lv_nmos ad=0.2516p pd=2.16u as=0.1406p ps=1.12u w=0.74u l=0.13u
X697 VSS.t108 a_2019_311# a_5705_519# VSS.t348 sg13_lv_nmos ad=0.2516p pd=2.16u as=0.2516p ps=2.16u w=0.74u l=0.13u
X698 VDD.t256 a_1544_289# a_1721_331# VDD.t0 sg13_lv_pmos ad=0.1918p pd=1.5u as=0.1596p ps=1.22u w=0.84u l=0.13u
X699 a_7151_1842# a_6913_1842# a_7043_1842# VSS.t381 sg13_lv_nmos ad=0.1406p pd=1.12u as=0.2516p ps=2.16u w=0.74u l=0.2u
X700 a_16033_1842# a_15837_1842# VSS.t3 VSS.t309 sg13_lv_nmos ad=0.2516p pd=2.16u as=0.1406p ps=1.12u w=0.74u l=0.13u
X701 a_10649_5878# REF_CLK VSS.t198 VSS.t197 sg13_lv_nmos ad=0.2516p pd=2.16u as=1.9998p ps=12.915u w=0.74u l=0.13u
X702 VDD.t14 a_11748_6109# a_11693_5990# VDD.t13 sg13_lv_pmos ad=1.10612p pd=6.66u as=93.45f ps=0.865u w=0.42u l=0.13u
X703 MUX_OUT a_16851_309# VDD.t254 VDD.t0 sg13_lv_pmos ad=0.2128p pd=1.5u as=0.2086p ps=1.5u w=1.12u l=0.13u
X704 a_25391_2470# a_25153_1842# a_25283_1842# VDD.t7 sg13_lv_pmos ad=0.2128p pd=1.5u as=0.3808p ps=2.92u w=1.12u l=0.2u
X705 VDD.t219 VSS.t78 VDD.t221 VDD.t0 sg13_lv_pmos ad=0.34p pd=2.68u as=0 ps=0 w=1u l=1u
X706 a_12993_1842# a_12797_1842# VDD.t31 VDD.t7 sg13_lv_pmos ad=0.3808p pd=2.92u as=0.2128p ps=1.5u w=1.12u l=0.13u
X707 a_16408_1044# a_15837_1842# VSS.t74 VSS.t308 sg13_lv_nmos ad=0.1406p pd=1.12u as=0.2516p ps=2.16u w=0.74u l=0.13u
X708 a_5778_3367# a_6126_3816# a_6326_4590# VSS.t387 sg13_lv_nmos ad=0.68p pd=4.68u as=0.38p ps=2.38u w=2u l=1u
X709 VSS.t1 a_5523_1842# a_5957_1842# VSS.t0 sg13_lv_nmos ad=0.1406p pd=1.12u as=0.2516p ps=2.16u w=0.74u l=0.13u
X710 VDD.t286 DELAY_VBIASP a_13991_2470# VDD.t7 sg13_lv_pmos ad=0.3808p pd=2.92u as=0.2128p ps=1.5u w=1.12u l=0.6u
X711 a_5731_289# a_2019_311# a_4350_1044# VSS.t347 sg13_lv_nmos ad=0.2516p pd=2.16u as=0.2516p ps=2.16u w=0.74u l=0.13u
X712 VSS.t93 a_9547_6172# a_9547_6172# VSS.t570 sg13_lv_nmos ad=2.39977p pd=15.495u as=0.111p ps=1.34u w=0.3u l=0.13u
X713 a_9444_3912# a_6854_5454# a_9712_3912# VSS.t623 sg13_lv_nmos ad=0.68p pd=4.68u as=0.38p ps=2.38u w=2u l=1u
X714 VSS.t547 DELAY_VBIASN VSS.t545 VSS.t530 sg13_lv_nmos ad=1.33p pd=7.38u as=0 ps=0 w=7u l=7u
X715 a_7390_1044# a_3747_1047.t8 a_9675_1044# VSS.t209 sg13_lv_nmos ad=0.2516p pd=2.16u as=0.1406p ps=1.12u w=0.74u l=0.13u
X716 VDD.t80 a_23763_1842# a_24197_1842# VDD.t7 sg13_lv_pmos ad=0.2128p pd=1.5u as=0.3808p ps=2.92u w=1.12u l=0.13u
X717 VSS.t405 DELAY_VBIASN a_8671_1842# VSS.t512 sg13_lv_nmos ad=0.2516p pd=2.16u as=0.1406p ps=1.12u w=0.74u l=0.6u
X718 VDD.t380 a_2019_1047.t8 a_7364_1008# VDD.t0 sg13_lv_pmos ad=0.3808p pd=2.92u as=0.3808p ps=2.92u w=1.12u l=0.13u
X719 VDD.t317 DELAY_VBIASP a_26911_2470# VDD.t7 sg13_lv_pmos ad=0.3808p pd=2.92u as=0.2128p ps=1.5u w=1.12u l=0.6u
X720 VSS.t13 a_14009_5084# a_14111_5227# VSS.t12 sg13_lv_nmos ad=1.45407p pd=9.445u as=0.2516p ps=2.16u w=0.74u l=0.13u
X721 VDD.t234 VSS.t167 VDD.t232 VDD.t0 sg13_lv_pmos ad=0.19p pd=1.38u as=0 ps=0 w=1u l=1u
X722 a_12471_1842# a_12233_1842# a_12363_1842# VSS.t99 sg13_lv_nmos ad=0.1406p pd=1.12u as=0.2516p ps=2.16u w=0.74u l=0.2u
X723 a_22488_1044# a_21917_1842# VDD.t283 VDD.t0 sg13_lv_pmos ad=0.2128p pd=1.5u as=0.3808p ps=2.92u w=1.12u l=0.13u
X724 VDD.t71 a_2595_311.t3 a_8745_519# VDD.t0 sg13_lv_pmos ad=0.3808p pd=2.92u as=0.3808p ps=2.92u w=1.12u l=0.13u
X725 VSS.t475 a_3171_1047.t5 a_18004_1008# VSS.t474 sg13_lv_nmos ad=0.2516p pd=2.16u as=0.2516p ps=2.16u w=0.74u l=0.13u
X726 a_6391_2470# a_6153_1842# a_6283_1842# VDD.t7 sg13_lv_pmos ad=0.2128p pd=1.5u as=0.3808p ps=2.92u w=1.12u l=0.2u
X727 a_15273_1842# a_15077_1842# VDD.t352 VDD.t7 sg13_lv_pmos ad=0.3808p pd=2.92u as=0.2128p ps=1.5u w=1.12u l=0.13u
X728 a_14235_1044# a_14025_1044# VSS.t67 VSS.t66 sg13_lv_nmos ad=0.1406p pd=1.12u as=0.1665p ps=1.19u w=0.74u l=0.13u
X729 a_6326_4590# a_6126_3816# a_5778_3367# VSS.t387 sg13_lv_nmos ad=0.42p pd=2.42u as=0.68p ps=4.68u w=2u l=1u
X730 VSS.t42 a_3747_1047.t7 a_12791_1008# VSS.t64 sg13_lv_nmos ad=0.2516p pd=2.16u as=0.2516p ps=2.16u w=0.74u l=0.13u
X731 VSS.t593 VSS.t590 VSS.t592 VSS.t591 sg13_lv_nmos ad=0.2516p pd=2.16u as=0 ps=0 w=0.74u l=0.13u
X732 a_9953_1842# a_9757_1842# VSS.t183 VSS.t300 sg13_lv_nmos ad=0.2516p pd=2.16u as=0.1406p ps=1.12u w=0.74u l=0.13u
X733 VSS.t352 a_10843_1842# a_11277_1842# VSS.t351 sg13_lv_nmos ad=0.1406p pd=1.12u as=0.2516p ps=2.16u w=0.74u l=0.13u
X734 VSS.t156 VDD.t395 VSS.t156 VSS.t157 sg13_lv_nmos ad=0.1428p pd=1.52u as=0 ps=0 w=0.42u l=1u
X735 a_10649_5878# REF_CLK VDD.t14 VDD.t13 sg13_lv_pmos ad=0.4088p pd=2.97u as=1.03698p ps=6.245u w=1.12u l=0.13u
X736 VDD.t9 a_15403_1842# a_15837_1842# VDD.t7 sg13_lv_pmos ad=0.2128p pd=1.5u as=0.3808p ps=2.92u w=1.12u l=0.13u
X737 VDD.t14 a_14009_5084# a_14111_5227# VDD.t13 sg13_lv_pmos ad=1.10612p pd=6.66u as=0.3864p ps=2.93u w=1.12u l=0.13u
X738 VSS.t134 VDD.t402 VSS.t134 VSS.t133 sg13_lv_nmos ad=0.1428p pd=1.52u as=0 ps=0 w=0.42u l=1u
X739 a_11848_1044# a_11277_1842# VSS.t50 VSS.t422 sg13_lv_nmos ad=0.1406p pd=1.12u as=0.2516p ps=2.16u w=0.74u l=0.13u
X740 a_6326_4590# a_6326_4590# VDD.t58 VDD.t13 sg13_lv_pmos ad=0.38p pd=2.38u as=0.38p ps=2.38u w=2u l=1u
X741 VDD.t375 a_4763_1842# a_5197_1842# VDD.t7 sg13_lv_pmos ad=0.2128p pd=1.5u as=0.3808p ps=2.92u w=1.12u l=0.13u
X742 VSS.t142 VDD.t400 VSS.t140 VSS.t141 sg13_lv_nmos ad=79.8f pd=0.8u as=0 ps=0 w=0.42u l=1u
X743 a_13470_1044# a_13444_1008# a_13368_1044# VDD.t0 sg13_lv_pmos ad=0.3808p pd=2.92u as=0.2128p ps=1.5u w=1.12u l=0.13u
X744 VDD.t153 a_3449_1395# a_3747_1047.t0 VDD.t0 sg13_lv_pmos ad=0.4256p pd=3u as=0.2128p ps=1.5u w=1.12u l=0.13u
X745 VSS.t602 VSS.t599 VSS.t599 VSS.t600 sg13_lv_nmos ad=0.1406p pd=1.12u as=0 ps=0 w=0.74u l=0.13u
X746 VDD.t129 a_3171_1047.t3 a_24084_1008# VDD.t0 sg13_lv_pmos ad=0.3808p pd=2.92u as=0.3808p ps=2.92u w=1.12u l=0.13u
X747 a_3449_1395# MUX_SEL0 VDD.t332 VDD.t0 sg13_lv_pmos ad=0.1596p pd=1.22u as=0.2856p ps=2.36u w=0.84u l=0.13u
X748 a_15464_3684# a_14851_5182# VDD.t262 VDD.t13 sg13_lv_pmos ad=0.4312p pd=3.01u as=0.2639p ps=1.81u w=1.12u l=0.13u
X749 a_5974_5723# a_6126_3816# VSS.t388 VSS.t274 sg13_lv_nmos ad=0.38p pd=2.38u as=0.68p ps=4.68u w=2u l=1u
X750 VDD.t302 DELAY_VBIASP a_7911_2470# VDD.t7 sg13_lv_pmos ad=0.3808p pd=2.92u as=0.2128p ps=1.5u w=1.12u l=0.6u
X751 VDD.t197 VSS.t115 VDD.t196 VDD.t0 sg13_lv_pmos ad=0.19p pd=1.38u as=0 ps=0 w=1u l=1u
X752 VDD.t62 a_6326_4590# a_6854_5986# VDD.t13 sg13_lv_pmos ad=0.38p pd=2.38u as=0.38p ps=2.38u w=2u l=1u
X753 a_10206_5835# a_10649_5878# a_9946_6305# VSS.t234 sg13_lv_nmos ad=79.8f pd=0.8u as=0.1296p ps=1.52u w=0.42u l=0.13u
X754 VDD.t199 VSS.t115 VDD.t198 VDD.t0 sg13_lv_pmos ad=0.34p pd=2.68u as=0 ps=0 w=1u l=1u
X755 a_9946_6305# a_9772_5843# VDD.t342 VDD.t13 sg13_lv_pmos ad=79.8f pd=0.8u as=0.1428p ps=1.52u w=0.42u l=0.13u
X756 a_9946_6305# a_10751_5878# a_10206_5835# VDD.t13 sg13_lv_pmos ad=0.1428p pd=1.52u as=79.8f ps=0.8u w=0.42u l=0.13u
X757 VDD.t255 a_16851_309# MUX_OUT VDD.t0 sg13_lv_pmos ad=0.7336p pd=3.55u as=0.2128p ps=1.5u w=1.12u l=0.13u
X758 VSS.t160 a_3171_311.t2 a_23945_519# VSS.t196 sg13_lv_nmos ad=0.2516p pd=2.16u as=0.2516p ps=2.16u w=0.74u l=0.13u
X759 VDD.t146 a_18117_1842# a_18585_1044# VDD.t0 sg13_lv_pmos ad=0.252p pd=1.57u as=0.3808p ps=2.92u w=1.12u l=0.13u
X760 VSS.t31 a_19637_1842# a_20105_1044# VSS.t227 sg13_lv_nmos ad=0.1665p pd=1.19u as=0.2516p ps=2.16u w=0.74u l=0.13u
X761 a_11711_2470# a_11473_1842# a_11603_1842# VDD.t7 sg13_lv_pmos ad=0.2128p pd=1.5u as=0.3808p ps=2.92u w=1.12u l=0.2u
X762 a_27671_1842# a_27433_1842# a_27563_1842# VSS.t383 sg13_lv_nmos ad=0.1406p pd=1.12u as=0.2516p ps=2.16u w=0.74u l=0.2u
X763 VSS.t214 MUX_SEL4 a_15765_463# VSS.t213 sg13_lv_nmos ad=0.2516p pd=2.16u as=0.2516p ps=2.16u w=0.74u l=0.13u
X764 a_5731_289# a_14825_519# a_13470_1044# VDD.t0 sg13_lv_pmos ad=0.3808p pd=2.92u as=0.3808p ps=2.92u w=1.12u l=0.13u
X765 a_16510_1044# a_2595_1047.t5 a_17275_1044# VSS.t83 sg13_lv_nmos ad=0.2516p pd=2.16u as=0.1406p ps=1.12u w=0.74u l=0.13u
X766 a_13045_6215# a_13019_5831# a_12849_5867# VSS.t577 sg13_lv_nmos ad=0.1406p pd=1.12u as=0.1406p ps=1.12u w=0.74u l=0.13u
X767 VSS.t318 DELAY_VBIASN a_16271_1842# VSS.t497 sg13_lv_nmos ad=0.2516p pd=2.16u as=0.1406p ps=1.12u w=0.74u l=0.6u
X768 VDD.t218 VSS.t160 VDD.t217 VDD.t0 sg13_lv_pmos ad=0.34p pd=2.68u as=0 ps=0 w=1u l=1u
X769 VDD.t128 a_3171_1047.t6 a_14964_1008# VDD.t0 sg13_lv_pmos ad=0.3808p pd=2.92u as=0.3808p ps=2.92u w=1.12u l=0.13u
X770 VDD.t123 a_10083_1842# a_10517_1842# VDD.t7 sg13_lv_pmos ad=0.2128p pd=1.5u as=0.3808p ps=2.92u w=1.12u l=0.13u
X771 VSS.t62 a_3747_1047.t2 a_27991_1008# VSS.t61 sg13_lv_nmos ad=0.2516p pd=2.16u as=0.2516p ps=2.16u w=0.74u l=0.13u
X772 a_9712_3912# a_13019_5831# DELAY_VBIASN VSS.t578 sg13_lv_nmos ad=0.136p pd=1.14u as=0.232p ps=2.08u w=0.4u l=0.2u
X773 VSS.t402 a_26043_1842# a_26477_1842# VSS.t401 sg13_lv_nmos ad=0.1406p pd=1.12u as=0.2516p ps=2.16u w=0.74u l=0.13u
X774 VSS.t397 a_6126_3816# a_5974_5723# VSS.t274 sg13_lv_nmos ad=0.68p pd=4.68u as=0.38p ps=2.38u w=2u l=1u
X775 a_11195_1044# a_10985_1044# VDD.t122 VDD.t0 sg13_lv_pmos ad=0.2128p pd=1.5u as=0.252p ps=1.57u w=1.12u l=0.13u
X776 VSS.t307 a_3747_1047.t9 a_6711_1008# VSS.t306 sg13_lv_nmos ad=0.2516p pd=2.16u as=0.2516p ps=2.16u w=0.74u l=0.13u
X777 a_9444_4590# a_6854_5454# a_6854_5454# VSS.t623 sg13_lv_nmos ad=0.68p pd=4.68u as=0.38p ps=2.38u w=2u l=1u
X778 a_16108_289# a_2595_311.t2 a_19550_1044# VSS.t79 sg13_lv_nmos ad=0.2516p pd=2.16u as=0.2516p ps=2.16u w=0.74u l=0.13u
X779 VSS.t333 DELAY_VBIASN a_20071_1842# VSS.t558 sg13_lv_nmos ad=0.2516p pd=2.16u as=0.1406p ps=1.12u w=0.74u l=0.6u
X780 VDD.t315 DELAY_VBIASP a_24631_2470# VDD.t7 sg13_lv_pmos ad=0.3808p pd=2.92u as=0.2128p ps=1.5u w=1.12u l=0.6u
X781 a_22590_1044# a_23431_1008# a_23355_1044# VDD.t0 sg13_lv_pmos ad=0.3808p pd=2.92u as=0.2128p ps=1.5u w=1.12u l=0.13u
X782 VSS.t125 VDD.t404 VSS.t125 VSS.t127 sg13_lv_nmos ad=79.8f pd=0.8u as=0 ps=0 w=0.42u l=1u
X783 a_10458_6292# DLL_RESETN VSS.t269 VSS.t281 sg13_lv_nmos ad=37.8f pd=0.6u as=0.1701p ps=1.65u w=0.42u l=0.13u
X784 a_11491_6228# a_10649_5878# a_10232_5871# VDD.t13 sg13_lv_pmos ad=0.2048p pd=1.63u as=0.34p ps=2.68u w=1u l=0.13u
X785 VSS.t395 a_6126_3816# a_5974_5723# VSS.t274 sg13_lv_nmos ad=0.76p pd=4.76u as=0.38p ps=2.38u w=2u l=1u
X786 a_8671_1842# a_8433_1842# a_8563_1842# VSS.t443 sg13_lv_nmos ad=0.1406p pd=1.12u as=0.2516p ps=2.16u w=0.74u l=0.2u
X787 a_17553_1842# a_17357_1842# VSS.t373 VSS.t372 sg13_lv_nmos ad=0.2516p pd=2.16u as=0.1406p ps=1.12u w=0.74u l=0.13u
X788 a_5731_289# a_5705_519# a_4350_1044# VDD.t0 sg13_lv_pmos ad=0.3808p pd=2.92u as=0.3808p ps=2.92u w=1.12u l=0.13u
X789 VDD.t105 VDD.t103 VDD.t104 VDD.t7 sg13_lv_pmos ad=0.3808p pd=2.92u as=0 ps=0 w=1.12u l=0.13u
X790 a_26911_2470# a_26673_1842# a_26803_1842# VDD.t7 sg13_lv_pmos ad=0.2128p pd=1.5u as=0.3808p ps=2.92u w=1.12u l=0.2u
X791 a_7390_1044# a_2019_1047.t8 a_7288_1044# VSS.t493 sg13_lv_nmos ad=0.2516p pd=2.16u as=0.1406p ps=1.12u w=0.74u l=0.13u
X792 a_13566_5328# a_14009_5084# a_13306_5105# VSS.t11 sg13_lv_nmos ad=79.8f pd=0.8u as=0.1296p ps=1.52u w=0.42u l=0.13u
X793 a_21353_1842# a_21157_1842# VSS.t276 VSS.t358 sg13_lv_nmos ad=0.2516p pd=2.16u as=0.1406p ps=1.12u w=0.74u l=0.13u
X794 VSS.t292 a_7043_1842# a_7477_1842# VSS.t445 sg13_lv_nmos ad=0.1406p pd=1.12u as=0.2516p ps=2.16u w=0.74u l=0.13u
X795 a_13121_5831# a_15688_5867# VDD.t30 VDD.t13 sg13_lv_pmos ad=0.3808p pd=2.92u as=0.2128p ps=1.5u w=1.12u l=0.13u
X796 VDD.t296 DELAY_VBIASP a_15511_2470# VDD.t7 sg13_lv_pmos ad=0.3808p pd=2.92u as=0.2128p ps=1.5u w=1.12u l=0.6u
X797 VDD.t11 a_2019_1047.t7 a_10404_1008# VDD.t0 sg13_lv_pmos ad=0.3808p pd=2.92u as=0.3808p ps=2.92u w=1.12u l=0.13u
X798 VSS.t455 a_9444_4590# a_9444_3912# VSS.t453 sg13_lv_nmos ad=0.68p pd=4.68u as=0.38p ps=2.38u w=2u l=1u
X799 VDD.t19 a_25283_1842# a_25717_1842# VDD.t7 sg13_lv_pmos ad=0.2128p pd=1.5u as=0.3808p ps=2.92u w=1.12u l=0.13u
X800 VDD.t299 DELAY_VBIASP a_5631_2470# VDD.t7 sg13_lv_pmos ad=0.3808p pd=2.92u as=0.2128p ps=1.5u w=1.12u l=0.6u
X801 a_26395_1044# a_26185_1044# VDD.t18 VDD.t0 sg13_lv_pmos ad=0.2128p pd=1.5u as=0.252p ps=1.57u w=1.12u l=0.13u
X802 a_13306_5105# a_14111_5227# a_13566_5328# VDD.t13 sg13_lv_pmos ad=0.1428p pd=1.52u as=79.8f ps=0.8u w=0.42u l=0.13u
X803 a_6326_4590# a_6126_3816# a_5778_3367# VSS.t387 sg13_lv_nmos ad=0.38p pd=2.38u as=0.68p ps=4.68u w=2u l=1u
X804 VDD.t371 a_3747_1047.t3 a_24951_1008# VDD.t0 sg13_lv_pmos ad=0.3808p pd=2.92u as=0.3808p ps=2.92u w=1.12u l=0.13u
X805 VDD.t117 VSS.t156 VDD.t116 VDD.t0 sg13_lv_pmos ad=0.19p pd=1.38u as=0 ps=0 w=1u l=1u
X806 a_13991_1842# a_13753_1842# a_13883_1842# VSS.t215 sg13_lv_nmos ad=0.1406p pd=1.12u as=0.2516p ps=2.16u w=0.74u l=0.2u
X807 a_24008_1044# a_23437_1842# VDD.t165 VDD.t0 sg13_lv_pmos ad=0.2128p pd=1.5u as=0.3808p ps=2.92u w=1.12u l=0.13u
X808 VDD.t164 VSS.t132 VDD.t163 VDD.t0 sg13_lv_pmos ad=0.19p pd=1.38u as=0 ps=0 w=1u l=1u
X809 VSS.t96 a_2019_1047.t4 a_19524_1008# VSS.t95 sg13_lv_nmos ad=0.2516p pd=2.16u as=0.2516p ps=2.16u w=0.74u l=0.13u
X810 a_9712_3912# a_6854_5454# a_9444_3912# VSS.t622 sg13_lv_nmos ad=0.38p pd=2.38u as=0.68p ps=4.68u w=2u l=1u
X811 a_7911_2470# a_7673_1842# a_7803_1842# VDD.t7 sg13_lv_pmos ad=0.2128p pd=1.5u as=0.3808p ps=2.92u w=1.12u l=0.2u
X812 a_16793_1842# a_16597_1842# VDD.t228 VDD.t7 sg13_lv_pmos ad=0.3808p pd=2.92u as=0.2128p ps=1.5u w=1.12u l=0.13u
X813 VSS.t238 MUX_SEL1 a_3543_1395# VSS.t415 sg13_lv_nmos ad=0.1331p pd=1.12u as=0.1216p ps=1.02u w=0.64u l=0.13u
X814 a_15755_1044# a_15545_1044# VSS.t465 VSS.t464 sg13_lv_nmos ad=0.1406p pd=1.12u as=0.1665p ps=1.19u w=0.74u l=0.13u
X815 a_13818_5118# a_12849_5867# VSS.t287 VSS.t337 sg13_lv_nmos ad=37.8f pd=0.6u as=0.1701p ps=1.65u w=0.42u l=0.13u
X816 a_2595_1047.t0 a_2297_1395# VDD.t158 VDD.t0 sg13_lv_pmos ad=0.2128p pd=1.5u as=0.1918p ps=1.5u w=1.12u l=0.13u
X817 VSS.t439 a_2595_1047.t6 a_14311_1008# VSS.t619 sg13_lv_nmos ad=0.2516p pd=2.16u as=0.2516p ps=2.16u w=0.74u l=0.13u
X818 VSS.t40 a_12363_1842# a_12797_1842# VSS.t301 sg13_lv_nmos ad=0.1406p pd=1.12u as=0.2516p ps=2.16u w=0.74u l=0.13u
X819 a_5115_1044# a_4905_1044# VSS.t52 VSS.t190 sg13_lv_nmos ad=0.1406p pd=1.12u as=0.1665p ps=1.19u w=0.74u l=0.13u
X820 a_1256_1044# MUX_SEL0 VDD.t334 VDD.t0 sg13_lv_pmos ad=0.3808p pd=2.92u as=0.3808p ps=2.92u w=1.12u l=0.13u
X821 a_9444_3912# a_9444_4590# VSS.t451 VSS.t450 sg13_lv_nmos ad=0.38p pd=2.38u as=0.68p ps=4.68u w=2u l=1u
X822 VSS.t537 DELAY_VBIASN VSS.t535 VSS.t520 sg13_lv_nmos ad=1.33p pd=7.38u as=0 ps=0 w=7u l=7u
X823 VDD.t154 a_27563_1842# a_27997_1842# VDD.t7 sg13_lv_pmos ad=0.2128p pd=1.5u as=0.3808p ps=2.92u w=1.12u l=0.13u
X824 a_20593_1842# a_20397_1842# VDD.t241 VDD.t7 sg13_lv_pmos ad=0.3808p pd=2.92u as=0.2128p ps=1.5u w=1.12u l=0.13u
X825 a_1721_1395# a_1256_1044# VDD.t338 VDD.t0 sg13_lv_pmos ad=0.1596p pd=1.22u as=0.2856p ps=2.36u w=0.84u l=0.13u
X826 VDD.t208 a_6283_1842# a_6717_1842# VDD.t7 sg13_lv_pmos ad=0.2128p pd=1.5u as=0.3808p ps=2.92u w=1.12u l=0.13u
X827 a_13470_1044# a_14964_1008# a_14888_1044# VDD.t0 sg13_lv_pmos ad=0.3808p pd=2.92u as=0.2128p ps=1.5u w=1.12u l=0.13u
X828 a_13592_5871# a_13566_5835# VDD.t173 VDD.t13 sg13_lv_pmos ad=0.34p pd=2.68u as=0.36237p ps=2.605u w=1u l=0.13u
X829 a_5778_3367# a_6126_3816# a_6326_4590# VSS.t387 sg13_lv_nmos ad=0.68p pd=4.68u as=0.42p ps=2.42u w=2u l=1u
X830 VSS.t140 VDD.t400 VSS.t139 VSS.t138 sg13_lv_nmos ad=0.1428p pd=1.52u as=0 ps=0 w=0.42u l=1u
X831 VDD.t132 a_2019_1047.t2 a_25604_1008# VDD.t0 sg13_lv_pmos ad=0.3808p pd=2.92u as=0.3808p ps=2.92u w=1.12u l=0.13u
X832 a_9746_5805# a_9547_5942# VSS.t93 VSS.t92 sg13_lv_nmos ad=0.27427p pd=2.28u as=2.39977p ps=15.495u w=0.795u l=0.13u
X833 a_16271_1842# a_16033_1842# a_16163_1842# VSS.t277 sg13_lv_nmos ad=0.1406p pd=1.12u as=0.2516p ps=2.16u w=0.74u l=0.2u
X834 a_21835_1044# a_21625_1044# VDD.t175 VDD.t0 sg13_lv_pmos ad=0.2128p pd=1.5u as=0.252p ps=1.57u w=1.12u l=0.13u
X835 VDD.t196 VSS.t113 VDD.t364 VDD.t0 sg13_lv_pmos ad=0.34p pd=2.68u as=0 ps=0 w=1u l=1u
X836 VDD.t115 a_2595_1047.t4 a_20391_1008# VDD.t0 sg13_lv_pmos ad=0.3808p pd=2.92u as=0.3808p ps=2.92u w=1.12u l=0.13u
X837 VSS.t335 a_14851_5182# a_15688_5403# VSS.t364 sg13_lv_nmos ad=0.1406p pd=1.12u as=0.2516p ps=2.16u w=0.74u l=0.13u
X838 a_19073_1842# a_18877_1842# VDD.t181 VDD.t7 sg13_lv_pmos ad=0.3808p pd=2.92u as=0.2128p ps=1.5u w=1.12u l=0.13u
X839 VDD.t122 a_10517_1842# a_10985_1044# VDD.t0 sg13_lv_pmos ad=0.252p pd=1.57u as=0.3808p ps=2.92u w=1.12u l=0.13u
X840 VSS.t271 a_21157_1842# a_21625_1044# VSS.t359 sg13_lv_nmos ad=0.1665p pd=1.19u as=0.2516p ps=2.16u w=0.74u l=0.13u
X841 VSS.t267 a_12849_5867# a_13400_6305# VSS.t266 sg13_lv_nmos ad=0.1626p pd=1.415u as=60.89999f ps=0.71u w=0.42u l=0.13u
X842 VSS.t390 a_6126_3816# a_6126_3816# VSS.t387 sg13_lv_nmos ad=0.68p pd=4.68u as=0.38p ps=2.38u w=2u l=1u
X843 a_20071_1842# a_19833_1842# a_19963_1842# VSS.t244 sg13_lv_nmos ad=0.1406p pd=1.12u as=0.2516p ps=2.16u w=0.74u l=0.2u
X844 VSS.t584 VSS.t582 VSS.t582 VSS.t583 sg13_lv_nmos ad=0.68p pd=4.68u as=0 ps=0 w=2u l=1u
X845 VSS.t468 a_14643_1842# a_15077_1842# VSS.t567 sg13_lv_nmos ad=0.1406p pd=1.12u as=0.2516p ps=2.16u w=0.74u l=0.13u
X846 a_1815_331# a_1256_289# a_1721_331# VSS.t57 sg13_lv_nmos ad=0.1216p pd=1.02u as=0.2176p ps=1.96u w=0.64u l=0.13u
X847 VDD.t87 VDD.t85 VDD.t54 VDD.t13 sg13_lv_pmos ad=0.38p pd=2.38u as=0 ps=0 w=2u l=1u
X848 VDD.t148 a_19203_1842# a_19637_1842# VDD.t7 sg13_lv_pmos ad=0.2128p pd=1.5u as=0.3808p ps=2.92u w=1.12u l=0.13u
X849 VSS.t295 a_2019_1047.t9 a_4324_1008# VSS.t294 sg13_lv_nmos ad=0.2516p pd=2.16u as=0.2516p ps=2.16u w=0.74u l=0.13u
X850 a_16108_289# a_20905_519# a_19550_1044# VDD.t0 sg13_lv_pmos ad=0.3808p pd=2.92u as=0.3808p ps=2.92u w=1.12u l=0.13u
X851 a_16510_1044# a_3747_1047.t5 a_18795_1044# VSS.t410 sg13_lv_nmos ad=0.2516p pd=2.16u as=0.1406p ps=1.12u w=0.74u l=0.13u
X852 VDD.t282 a_8563_1842# a_8997_1842# VDD.t7 sg13_lv_pmos ad=0.2128p pd=1.5u as=0.3808p ps=2.92u w=1.12u l=0.13u
X853 VDD.t308 DELAY_VBIASP a_13231_2470# VDD.t7 sg13_lv_pmos ad=0.3808p pd=2.92u as=0.2128p ps=1.5u w=1.12u l=0.6u
X854 VSS.t22 DELAY_VBIASN a_17791_1842# VSS.t555 sg13_lv_nmos ad=0.2516p pd=2.16u as=0.1406p ps=1.12u w=0.74u l=0.6u
X855 VSS.t119 VDD.t406 VSS.t78 VSS.t118 sg13_lv_nmos ad=0.1428p pd=1.52u as=0 ps=0 w=0.42u l=1u
X856 a_6854_5986# a_6326_4590# VDD.t60 VDD.t13 sg13_lv_pmos ad=0.38p pd=2.38u as=0.38p ps=2.38u w=2u l=1u
X857 VDD.t100 VDD.t98 VDD.t99 VDD.t38 sg13_lv_pmos ad=0.3808p pd=2.92u as=0 ps=0 w=1.12u l=0.13u
X858 VDD.t319 a_3747_1047.t5 a_18871_1008# VDD.t0 sg13_lv_pmos ad=0.3808p pd=2.92u as=0.3808p ps=2.92u w=1.12u l=0.13u
X859 VDD.t95 VDD.t96 VDD.t97 VDD.t38 sg13_lv_pmos ad=0.2128p pd=1.5u as=0 ps=0 w=1.12u l=0.13u
X860 VDD.t166 a_23003_1842# a_23437_1842# VDD.t7 sg13_lv_pmos ad=0.2128p pd=1.5u as=0.3808p ps=2.92u w=1.12u l=0.13u
X861 VSS.t454 a_9444_4590# a_9444_4590# VSS.t453 sg13_lv_nmos ad=0.68p pd=4.68u as=0.38p ps=2.38u w=2u l=1u
X862 VSS.t587 VSS.t579 VSS.t579 VSS.t580 sg13_lv_nmos ad=0.68p pd=4.68u as=0 ps=0 w=2u l=1u
X863 a_12715_1044# a_12505_1044# VDD.t143 VDD.t0 sg13_lv_pmos ad=0.2128p pd=1.5u as=0.252p ps=1.57u w=1.12u l=0.13u
X864 a_19550_1044# a_21044_1008# a_20968_1044# VDD.t0 sg13_lv_pmos ad=0.3808p pd=2.92u as=0.2128p ps=1.5u w=1.12u l=0.13u
X865 a_17928_1044# a_17357_1842# VDD.t269 VDD.t0 sg13_lv_pmos ad=0.2128p pd=1.5u as=0.3808p ps=2.92u w=1.12u l=0.13u
X866 VSS.t224 DELAY_VBIASN a_21591_1842# VSS.t553 sg13_lv_nmos ad=0.2516p pd=2.16u as=0.1406p ps=1.12u w=0.74u l=0.6u
X867 VSS.t59 a_1544_289# a_1815_331# VSS.t425 sg13_lv_nmos ad=0.1331p pd=1.12u as=0.1216p ps=1.02u w=0.64u l=0.13u
X868 a_7288_1044# a_6717_1842# VDD.t348 VDD.t0 sg13_lv_pmos ad=0.2128p pd=1.5u as=0.3808p ps=2.92u w=1.12u l=0.13u
X869 VSS.t527 DELAY_VBIASN VSS.t529 VSS.t528 sg13_lv_nmos ad=1.33p pd=7.38u as=0 ps=0 w=7u l=7u
X870 a_5974_5723# a_6126_3816# VSS.t395 VSS.t274 sg13_lv_nmos ad=0.38p pd=2.38u as=0.68p ps=4.68u w=2u l=1u
X871 a_15511_2470# a_15273_1842# a_15403_1842# VDD.t7 sg13_lv_pmos ad=0.2128p pd=1.5u as=0.3808p ps=2.92u w=1.12u l=0.2u
X872 VSS.t611 VSS.t613 VSS.t615 VSS.t614 sg13_lv_nmos ad=0.1406p pd=1.12u as=0 ps=0 w=0.74u l=0.2u
X873 a_22590_1044# a_24951_1008# a_24875_1044# VDD.t0 sg13_lv_pmos ad=0.3808p pd=2.92u as=0.2128p ps=1.5u w=1.12u l=0.13u
X874 VSS.t167 VDD.t392 VSS.t167 VSS.t169 sg13_lv_nmos ad=79.8f pd=0.8u as=0 ps=0 w=0.42u l=1u
X875 VSS.t335 a_15108_5325# a_14757_5182# VSS.t479 sg13_lv_nmos ad=79.8f pd=0.8u as=0.1428p ps=1.52u w=0.42u l=0.13u
X876 a_10430_1044# a_2019_1047.t7 a_10328_1044# VSS.t6 sg13_lv_nmos ad=0.2516p pd=2.16u as=0.1406p ps=1.12u w=0.74u l=0.13u
X877 VDD.t179 a_5974_5723# a_5974_5723# VDD.t13 sg13_lv_pmos ad=0.2448p pd=2.08u as=0.2826p ps=2.29u w=0.36u l=2u
X878 VDD.t18 a_25717_1842# a_26185_1044# VDD.t0 sg13_lv_pmos ad=0.252p pd=1.57u as=0.3808p ps=2.92u w=1.12u l=0.13u
X879 a_6854_5454# a_6854_5454# a_9444_4590# VSS.t622 sg13_lv_nmos ad=0.38p pd=2.38u as=0.68p ps=4.68u w=2u l=1u
X880 VDD.t78 a_13883_1842# a_14317_1842# VDD.t7 sg13_lv_pmos ad=0.2128p pd=1.5u as=0.3808p ps=2.92u w=1.12u l=0.13u
X881 VDD.t40 a_4437_1842# a_4905_1044# VDD.t0 sg13_lv_pmos ad=0.252p pd=1.57u as=0.3808p ps=2.92u w=1.12u l=0.13u
X882 a_4157_1313# REF_CLK VSS.t203 VSS.t202 sg13_lv_nmos ad=0.2516p pd=2.16u as=0.2553p ps=2.17u w=0.74u l=0.13u
X883 a_7390_1044# a_3171_1047.t8 a_8808_1044# VSS.t476 sg13_lv_nmos ad=0.2516p pd=2.16u as=0.1406p ps=1.12u w=0.74u l=0.13u
X884 a_22873_1842# a_22677_1842# VSS.t5 VSS.t181 sg13_lv_nmos ad=0.2516p pd=2.16u as=0.1406p ps=1.12u w=0.74u l=0.13u
X885 a_9444_4590# a_9444_4590# VSS.t452 VSS.t450 sg13_lv_nmos ad=0.38p pd=2.38u as=0.68p ps=4.68u w=2u l=1u
X886 VDD.t368 a_3171_1047.t8 a_8884_1008# VDD.t0 sg13_lv_pmos ad=0.3808p pd=2.92u as=0.3808p ps=2.92u w=1.12u l=0.13u
C0 MUX_SEL4 MUX_OUT 0.91933f
C1 a_8237_1842# a_8563_1842# 0.01427f
C2 a_13019_5831# DELAY_VBIASN 1.23663f
C3 a_22488_1044# a_22564_1008# 0.01176f
C4 a_11748_6109# a_11491_6228# 0.34468f
C5 a_26803_1842# a_26911_1842# 0.01163f
C6 a_5731_289# a_15765_463# 0.23301f
C7 a_12797_1842# a_13123_1842# 0.01427f
C8 a_19833_1842# a_20397_1842# 0.0114f
C9 a_4905_1044# VDD 0.30126f
C10 a_1256_1044# MUX_SEL0 0.3314f
C11 a_26673_1842# a_27237_1842# 0.0114f
C12 a_12943_5867# VDD 0.29479f
C13 a_10191_2470# VDD 0.01806f
C14 a_13592_5423# a_13880_5118# 0.43707f
C15 a_26803_1842# DELAY_VBIASP 0.06661f
C16 a_27997_1842# DELAY_VBIASN 0.04657f
C17 a_9465_1044# a_8997_1842# 0.2079f
C18 a_4350_1044# a_5197_1842# 0.08038f
C19 a_13444_1008# a_12797_1842# 0.02011f
C20 a_20071_2470# a_19963_1842# 0.01697f
C21 MUX_SEL0 MUX_SEL1 3.14917f
C22 a_12849_5867# VDD 2.56972f
C23 a_7477_1842# a_7673_1842# 0.73897f
C24 a_19637_1842# DELAY_VBIASP 0.04176f
C25 a_19833_1842# DELAY_VBIASN 0.10734f
C26 a_10232_5871# a_10520_6292# 0.43707f
C27 a_9757_1842# a_9953_1842# 0.76914f
C28 a_12037_1842# a_12233_1842# 0.77122f
C29 a_18877_1842# a_19637_1842# 0.06198f
C30 a_2297_1395# VDD 0.46536f
C31 DELAY_VBIASN a_13470_1044# 0.02115f
C32 a_4350_1044# a_4905_1044# 0.03209f
C33 a_4324_1008# a_4157_1313# 0.02463f
C34 a_25913_1842# a_26043_1842# 0.70845f
C35 a_4111_2470# VDD 0.01866f
C36 a_13592_5423# a_14111_5227# 0.34114f
C37 a_18551_2470# a_18443_1842# 0.01697f
C38 a_25913_1842# DELAY_VBIASP 0.11284f
C39 a_12158_5867# VDD 0.37862f
C40 a_6153_1842# a_6283_1842# 0.70845f
C41 a_19963_1842# VDD 0.4973f
C42 a_16923_1842# DELAY_VBIASP 0.06661f
C43 a_20968_1044# a_20397_1842# 0.10863f
C44 a_18117_1842# DELAY_VBIASN 0.09851f
C45 a_13231_2470# a_13123_1842# 0.01697f
C46 a_13019_5831# a_9712_3912# 0.03275f
C47 a_1256_289# MUX_SEL3 1.41161f
C48 a_10713_1842# a_10843_1842# 0.70845f
C49 a_18117_1842# a_17683_1842# 0.6972f
C50 a_16510_1044# a_17865_519# 0.02165f
C51 a_22351_2470# VDD 0.01806f
C52 a_26477_1842# VDD 0.86909f
C53 a_25717_1842# a_25283_1842# 0.69698f
C54 a_17031_2470# a_16923_1842# 0.01697f
C55 a_24197_1842# DELAY_VBIASP 0.04177f
C56 a_24393_1842# DELAY_VBIASN 0.10734f
C57 VDD DELAY_OUT_LAST 0.70591f
C58 a_22590_1044# a_23945_519# 0.02165f
C59 a_10206_5835# VDD 0.09392f
C60 a_15304_4605# REF_CLK 0.01066f
C61 a_5197_1842# a_5523_1842# 0.01427f
C62 a_10430_1044# a_11271_1008# 0.28268f
C63 a_27124_1008# a_26477_1842# 0.02312f
C64 a_18313_1842# VDD 0.49285f
C65 a_15273_1842# DELAY_VBIASP 0.11297f
C66 a_15403_1842# DELAY_VBIASN 0.08418f
C67 a_9772_5843# a_9946_6305# 0.27179f
C68 a_11711_2470# a_11603_1842# 0.01697f
C69 a_13121_5831# a_15688_5403# 0.01441f
C70 a_12849_5867# a_15108_5325# 0.10521f
C71 a_16851_309# MUX_OUT 0.45865f
C72 VDD a_11271_1008# 0.28336f
C73 a_16793_1842# a_17357_1842# 0.0114f
C74 a_16271_2470# VDD 0.01806f
C75 a_24393_1842# a_24957_1842# 0.0114f
C76 a_24523_1842# VDD 0.4973f
C77 a_27705_1044# a_27237_1842# 0.2079f
C78 a_15511_2470# a_15403_1842# 0.01697f
C79 a_21483_1842# DELAY_VBIASP 0.06661f
C80 a_22677_1842# DELAY_VBIASN 0.0907f
C81 a_5957_1842# a_6425_1044# 0.2079f
C82 a_9675_1044# a_9751_1008# 0.01194f
C83 a_16597_1842# VDD 0.86876f
C84 a_14851_6228# a_14757_6228# 0.28931f
C85 a_1256_289# VDD 0.40292f
C86 a_10191_2470# a_10083_1842# 0.01697f
C87 a_9323_1842# DELAY_VBIASP 0.06627f
C88 VDD a_8808_1044# 0.17499f
C89 a_15837_1842# a_16597_1842# 0.06198f
C90 a_13883_1842# DELAY_VBIASP 0.06627f
C91 a_15831_1008# a_13470_1044# 0.26208f
C92 a_15077_1842# DELAY_VBIASN 0.10039f
C93 a_6854_5986# VDD 1.20794f
C94 a_27915_1044# a_27991_1008# 0.01194f
C95 a_23437_1842# a_24197_1842# 0.03319f
C96 a_22873_1842# VDD 0.49294f
C97 a_18871_1008# VDD 0.2822f
C98 a_19550_1044# a_19524_1008# 0.277f
C99 a_5191_1008# VDD 0.28565f
C100 a_8155_1044# a_8231_1008# 0.01194f
C101 a_7390_1044# a_8884_1008# 0.28279f
C102 a_5864_3367# VDD 0.13532f
C103 a_15108_5325# DELAY_OUT_LAST 0.01399f
C104 a_14751_2470# a_14643_1842# 0.01697f
C105 a_16510_1044# a_16923_1842# 0.01012f
C106 a_13592_5871# a_14757_6228# 0.43239f
C107 a_24957_1842# a_24951_1008# 0.02354f
C108 a_6326_4590# a_5974_5723# 0.33136f
C109 a_25630_1044# VDD 0.89531f
C110 a_7673_1842# DELAY_VBIASP 0.11222f
C111 a_7803_1842# DELAY_VBIASN 0.07254f
C112 a_6717_1842# MUX_SEL4 0.0195f
C113 a_2019_311# MUX_SEL4 0.90276f
C114 a_12363_1842# DELAY_VBIASN 0.07254f
C115 a_12233_1842# DELAY_VBIASP 0.11222f
C116 a_12849_5867# a_15108_6109# 0.10225f
C117 a_13306_6305# a_14111_5878# 0.097f
C118 a_13019_5831# a_15688_5867# 0.0195f
C119 a_13121_5831# a_14851_6228# 0.03404f
C120 a_25630_1044# a_27124_1008# 0.28279f
C121 a_26395_1044# a_26471_1008# 0.01194f
C122 a_19203_1842# a_19311_1842# 0.01163f
C123 a_22677_1842# a_22243_1842# 0.69698f
C124 a_9712_3912# a_6326_4590# 0.04737f
C125 a_21157_1842# VDD 0.85848f
C126 a_21917_1842# a_19550_1044# 0.02479f
C127 a_16408_1044# VDD 0.17274f
C128 a_12849_5867# a_13566_5835# 0.27346f
C129 a_24665_1044# VDD 0.29722f
C130 a_13880_5118# VDD 0.02994f
C131 a_4350_1044# a_5191_1008# 0.28268f
C132 a_16408_1044# a_15837_1842# 0.10864f
C133 REF_CLK MUX_SEL0 0.14089f
C134 a_23437_1842# a_24084_1008# 0.02312f
C135 a_8997_1842# VDD 0.85848f
C136 a_22564_1008# VDD 0.28633f
C137 a_6153_1842# DELAY_VBIASN 0.0961f
C138 a_5957_1842# DELAY_VBIASP 0.04141f
C139 a_9444_3912# a_9712_3912# 0.81869f
C140 a_5778_3367# a_5864_3367# 0.07306f
C141 a_10649_5878# REF_CLK 0.25484f
C142 a_1544_289# MUX_SEL2 0.07405f
C143 a_13557_1842# VDD 0.86707f
C144 a_10517_1842# DELAY_VBIASP 0.0414f
C145 a_10713_1842# DELAY_VBIASN 0.0961f
C146 a_13121_5831# a_13592_5871# 0.01445f
C147 a_12505_1044# a_10430_1044# 0.03208f
C148 a_17683_1842# a_17791_1842# 0.01163f
C149 a_21353_1842# a_21917_1842# 0.0114f
C150 a_25630_1044# a_16108_289# 0.52614f
C151 a_12355_5867# a_12849_5867# 0.07687f
C152 a_16510_1044# a_17351_1008# 0.28268f
C153 a_8237_1842# a_8808_1044# 0.10863f
C154 a_12505_1044# VDD 0.29722f
C155 a_22677_1842# a_23145_1044# 0.19203f
C156 a_15077_1842# a_14643_1842# 0.6972f
C157 a_10843_1842# a_10430_1044# 0.01012f
C158 a_14111_5227# VDD 0.33926f
C159 a_22677_1842# a_22590_1044# 0.1088f
C160 a_6283_1842# VDD 0.4973f
C161 a_19550_1044# a_21044_1008# 0.28279f
C162 a_13132_5420# VDD 0.23863f
C163 a_24665_1044# a_24875_1044# 0.09424f
C164 a_16510_1044# a_15964_289# 0.05416f
C165 a_10843_1842# VDD 0.4973f
C166 a_9193_1842# a_9757_1842# 0.0114f
C167 a_22590_1044# a_24951_1008# 0.26208f
C168 a_16163_1842# a_16271_1842# 0.01163f
C169 a_1544_1044# a_2297_1395# 0.28651f
C170 a_15755_1044# a_15831_1008# 0.01194f
C171 a_12158_5867# a_12355_5867# 0.12454f
C172 a_18585_1044# a_16510_1044# 0.03208f
C173 a_13753_1842# a_14317_1842# 0.0114f
C174 a_27433_1842# a_27563_1842# 0.70845f
C175 a_4633_1842# VDD 0.49285f
C176 a_4350_1044# a_6283_1842# 0.01012f
C177 a_4003_1842# REF_CLK 0.55467f
C178 MUX_SEL3 MUX_OUT 0.79533f
C179 a_8237_1842# a_8997_1842# 0.03319f
C180 a_22488_1044# a_22590_1044# 0.37183f
C181 a_14235_1044# a_14311_1008# 0.01194f
C182 a_10751_5878# a_11491_6228# 0.26905f
C183 a_2019_311# a_16851_309# 0.01299f
C184 a_5731_289# a_14825_519# 0.28056f
C185 a_12797_1842# a_13557_1842# 0.06198f
C186 a_4157_1313# VDD 0.48935f
C187 a_26985_519# VDD 0.29292f
C188 MUX_SEL4 a_13470_1044# 0.256f
C189 a_26477_1842# a_26803_1842# 0.01427f
C190 a_9431_2470# VDD 0.01806f
C191 a_27237_1842# DELAY_VBIASP 0.06225f
C192 a_27433_1842# DELAY_VBIASN 0.10734f
C193 a_14111_5227# a_15108_5325# 0.03012f
C194 a_15304_4605# a_14757_5182# 0.02225f
C195 a_13121_5831# VDD 0.99724f
C196 a_7477_1842# a_7043_1842# 0.69698f
C197 a_19203_1842# DELAY_VBIASN 0.07852f
C198 a_19073_1842# DELAY_VBIASP 0.11286f
C199 a_13883_1842# a_13991_1842# 0.01163f
C200 a_12037_1842# a_11603_1842# 0.6972f
C201 a_18877_1842# a_19073_1842# 0.76914f
C202 a_27671_2470# VDD 0.01806f
C203 a_4350_1044# a_4157_1313# 0.04624f
C204 a_25913_1842# a_26477_1842# 0.0114f
C205 a_27563_1842# VDD 0.49811f
C206 a_13592_5423# a_14009_5084# 0.3749f
C207 a_10751_5878# a_9946_6305# 0.097f
C208 a_25283_1842# DELAY_VBIASP 0.06661f
C209 VDD MUX_OUT 0.35871f
C210 a_11491_6228# VDD 0.16753f
C211 a_13306_5105# REF_CLK 0.06166f
C212 a_6153_1842# a_6717_1842# 0.0114f
C213 a_16108_289# a_26985_519# 0.27952f
C214 a_20397_1842# VDD 0.86909f
C215 a_17553_1842# DELAY_VBIASN 0.10734f
C216 a_20391_1008# a_20397_1842# 0.02349f
C217 a_17357_1842# DELAY_VBIASP 0.04176f
C218 a_13106_5357# a_13132_5420# 0.1657f
C219 a_12907_5186# a_12907_5420# 0.1117f
C220 a_1256_289# MUX_SEL2 0.33134f
C221 a_5705_519# a_2019_311# 0.13872f
C222 a_12363_1842# a_12471_1842# 0.01163f
C223 a_10713_1842# a_11277_1842# 0.0114f
C224 a_17553_1842# a_17683_1842# 0.70845f
C225 DELAY_VBIASN a_10430_1044# 0.02115f
C226 a_21591_2470# VDD 0.01806f
C227 a_15403_1842# a_13470_1044# 0.01012f
C228 a_25153_1842# a_25283_1842# 0.70845f
C229 a_23763_1842# DELAY_VBIASN 0.08024f
C230 a_23633_1842# DELAY_VBIASP 0.11286f
C231 VDD DELAY_VBIASN 1.49209f
C232 DLL_RESETN REF_CLK 10.7961f
C233 a_15304_4605# DLL_RESETN 0.03137f
C234 a_5197_1842# a_5957_1842# 0.03319f
C235 a_10430_1044# a_11195_1044# 0.39037f
C236 a_27048_1044# a_26477_1842# 0.10863f
C237 a_17683_1842# VDD 0.49671f
C238 a_15837_1842# DELAY_VBIASN 0.10875f
C239 a_19524_1008# a_18877_1842# 0.02011f
C240 a_13019_5831# a_15688_5403# 0.1287f
C241 a_12849_5867# a_14851_5182# 0.13376f
C242 a_13121_5831# a_15108_5325# 0.05903f
C243 a_10843_1842# a_10951_1842# 0.01163f
C244 a_16108_289# MUX_OUT 0.24265f
C245 VDD a_11195_1044# 0.15389f
C246 a_15511_2470# VDD 0.01806f
C247 a_9946_6305# VDD 0.77198f
C248 a_24957_1842# VDD 0.87825f
C249 a_22113_1842# DELAY_VBIASN 0.10263f
C250 a_21917_1842# DELAY_VBIASP 0.04176f
C251 a_4350_1044# DELAY_VBIASN 0.02115f
C252 a_15077_1842# a_13470_1044# 0.05231f
C253 a_16033_1842# VDD 0.49413f
C254 a_18004_1008# a_18117_1842# 0.02055f
C255 a_14851_6228# a_15688_5867# 0.08776f
C256 a_27991_1008# VDD 0.28201f
C257 a_9757_1842# DELAY_VBIASP 0.0414f
C258 a_13306_6305# REF_CLK 0.05059f
C259 VDD a_8231_1008# 0.28336f
C260 a_14317_1842# DELAY_VBIASP 0.04316f
C261 a_15755_1044# a_13470_1044# 0.39036f
C262 a_15837_1842# a_16033_1842# 0.76914f
C263 a_14513_1842# DELAY_VBIASN 0.102f
C264 a_5974_5723# VDD 0.91576f
C265 a_23437_1842# a_23633_1842# 0.76914f
C266 a_22243_1842# VDD 0.49737f
C267 a_18795_1044# VDD 0.15406f
C268 a_19448_1044# a_19524_1008# 0.01176f
C269 a_5115_1044# VDD 0.15389f
C270 a_7390_1044# a_8808_1044# 0.38994f
C271 a_9712_3912# VDD 0.21864f
C272 a_14851_5182# DELAY_OUT_LAST 0.02109f
C273 a_16510_1044# a_17357_1842# 0.08038f
C274 a_25528_1044# VDD 0.17274f
C275 a_7043_1842# DELAY_VBIASP 0.06627f
C276 a_8237_1842# DELAY_VBIASN 0.09974f
C277 a_24957_1842# a_16108_289# 0.0157f
C278 a_5705_519# MUX_SEL4 0.03556f
C279 a_2019_311# MUX_SEL3 0.06209f
C280 a_14643_1842# VDD 0.49675f
C281 a_11603_1842# DELAY_VBIASP 0.06627f
C282 a_12797_1842# DELAY_VBIASN 0.09992f
C283 a_13306_6305# a_13880_6292# 0.31978f
C284 a_12849_5867# a_14111_5878# 0.42174f
C285 a_13121_5831# a_15108_6109# 0.03701f
C286 a_13019_5831# a_14851_6228# 0.01651f
C287 a_12505_1044# a_12791_1008# 0.01885f
C288 a_25630_1044# a_27048_1044# 0.38994f
C289 a_22113_1842# a_22243_1842# 0.70845f
C290 a_20593_1842# VDD 0.49417f
C291 a_5778_3367# a_5974_5723# 2.88221f
C292 a_15831_1008# VDD 0.2816f
C293 a_13121_5831# a_13566_5835# 0.01158f
C294 a_24197_1842# a_24665_1044# 0.2079f
C295 a_23145_1044# VDD 0.30409f
C296 a_12037_1842# a_11924_1008# 0.02055f
C297 a_4350_1044# a_5115_1044# 0.39037f
C298 a_15831_1008# a_15837_1842# 0.02354f
C299 REF_CLK DELAY_VBIASP 2.13371f
C300 a_13592_5871# a_14009_5878# 0.37583f
C301 a_23437_1842# a_24008_1044# 0.10863f
C302 a_8433_1842# VDD 0.49417f
C303 a_22590_1044# VDD 0.89557f
C304 a_5393_1842# DELAY_VBIASP 0.11222f
C305 a_5523_1842# DELAY_VBIASN 0.07254f
C306 a_10649_5878# DLL_RESETN 0.05713f
C307 a_10232_5871# REF_CLK 0.08086f
C308 a_26185_1044# a_26471_1008# 0.01885f
C309 a_12993_1842# VDD 0.49426f
C310 a_9953_1842# DELAY_VBIASP 0.11222f
C311 a_10083_1842# DELAY_VBIASN 0.07254f
C312 a_13019_5831# a_13592_5871# 0.04178f
C313 a_10985_1044# a_10430_1044# 0.03209f
C314 a_9444_4590# a_6854_5454# 1.24134f
C315 a_12355_5867# a_13121_5831# 0.05795f
C316 a_12656_5864# a_13019_5831# 0.04193f
C317 a_16510_1044# a_17275_1044# 0.39037f
C318 a_8997_1842# a_7390_1044# 0.05231f
C319 a_8237_1842# a_8231_1008# 0.02349f
C320 a_10985_1044# VDD 0.30409f
C321 a_18585_1044# a_18871_1008# 0.01885f
C322 a_14513_1842# a_14643_1842# 0.70845f
C323 a_11277_1842# a_10430_1044# 0.08038f
C324 a_14009_5084# VDD 0.31815f
C325 a_6717_1842# VDD 0.87726f
C326 a_12907_5420# VDD 0.07751f
C327 a_2019_311# VDD 1.43004f
C328 a_11277_1842# VDD 0.86909f
C329 a_7945_1044# a_8231_1008# 0.01885f
C330 a_22590_1044# a_24875_1044# 0.39036f
C331 a_1256_1044# a_2297_1395# 0.04619f
C332 a_22590_1044# a_16108_289# 0.58202f
C333 a_1256_289# a_2873_331# 0.27926f
C334 a_6854_5454# DLL_RESETN 0.03626f
C335 a_6717_1842# a_7364_1008# 0.02011f
C336 a_17065_1044# a_16510_1044# 0.03209f
C337 a_2297_1395# MUX_SEL1 0.01995f
C338 a_1544_1044# MUX_OUT 0.04258f
C339 a_27433_1842# a_27997_1842# 0.0114f
C340 a_15688_5867# VDD 0.30345f
C341 a_4350_1044# a_6717_1842# 0.02479f
C342 a_4437_1842# REF_CLK 0.05209f
C343 a_4350_1044# a_2019_311# 0.02042f
C344 MUX_SEL2 MUX_OUT 0.08497f
C345 MUX_SEL3 MUX_SEL4 0.75489f
C346 a_8237_1842# a_8433_1842# 0.76914f
C347 a_10649_5878# a_11397_6228# 0.01058f
C348 a_10751_5878# a_11748_6109# 0.03061f
C349 a_2019_311# a_16108_289# 0.33889f
C350 a_5731_289# a_11785_519# 0.28056f
C351 a_14025_1044# a_14311_1008# 0.01885f
C352 a_12797_1842# a_12993_1842# 0.76914f
C353 a_23945_519# VDD 0.29292f
C354 a_19637_1842# a_20397_1842# 0.01669f
C355 a_3449_1395# VDD 0.46731f
C356 a_26477_1842# a_27237_1842# 0.03319f
C357 a_14009_5878# VDD 0.23872f
C358 a_8671_2470# VDD 0.01806f
C359 a_14111_5227# a_14851_5182# 0.26905f
C360 a_26803_1842# DELAY_VBIASN 0.08024f
C361 a_26673_1842# DELAY_VBIASP 0.11284f
C362 a_13019_5831# VDD 0.41932f
C363 a_6913_1842# a_7043_1842# 0.70845f
C364 a_13368_1044# a_13470_1044# 0.37183f
C365 a_6425_1044# a_6711_1008# 0.01885f
C366 a_18443_1842# DELAY_VBIASP 0.06661f
C367 a_19637_1842# DELAY_VBIASN 0.0907f
C368 a_10232_5871# a_10649_5878# 0.37583f
C369 a_11473_1842# a_11603_1842# 0.70845f
C370 a_18877_1842# a_18443_1842# 0.6972f
C371 MUX_SEL4 a_10430_1044# 0.24983f
C372 a_24523_1842# a_24631_2470# 0.01697f
C373 a_26911_2470# VDD 0.01806f
C374 a_4248_1044# a_4157_1313# 0.11672f
C375 a_27997_1842# VDD 0.76025f
C376 a_10520_6292# a_9946_6305# 0.31978f
C377 a_9444_4590# DLL_RESETN 0.10269f
C378 a_25913_1842# DELAY_VBIASN 0.10734f
C379 a_25717_1842# DELAY_VBIASP 0.04176f
C380 VDD MUX_SEL4 2.63176f
C381 a_11748_6109# VDD 0.16819f
C382 a_13566_5328# REF_CLK 0.01093f
C383 a_16108_289# a_23945_519# 0.2906f
C384 a_11848_1044# a_11924_1008# 0.01176f
C385 a_9431_2470# a_9323_1842# 0.01697f
C386 a_19833_1842# VDD 0.49294f
C387 a_16793_1842# DELAY_VBIASP 0.11284f
C388 a_16923_1842# DELAY_VBIASN 0.08024f
C389 a_13106_5357# a_12907_5420# 0.14994f
C390 a_3449_331# a_2019_311# 0.01176f
C391 VDD a_13470_1044# 0.87936f
C392 a_17553_1842# a_18117_1842# 0.0114f
C393 a_23003_1842# a_23111_2470# 0.01697f
C394 a_20831_2470# VDD 0.01806f
C395 a_25153_1842# a_25717_1842# 0.0114f
C396 a_15837_1842# a_13470_1044# 0.02479f
C397 a_23003_1842# DELAY_VBIASP 0.06661f
C398 a_24197_1842# DELAY_VBIASN 0.09851f
C399 a_4350_1044# MUX_SEL4 0.31434f
C400 a_5197_1842# a_5393_1842# 0.76914f
C401 a_10430_1044# a_10404_1008# 0.277f
C402 a_7911_2470# a_7803_1842# 0.01697f
C403 a_4003_1842# DELAY_VBIASP 0.05992f
C404 a_25630_1044# a_27237_1842# 0.05253f
C405 a_26471_1008# a_26477_1842# 0.02349f
C406 a_18117_1842# VDD 0.85848f
C407 a_15273_1842# DELAY_VBIASN 0.10803f
C408 a_9746_5805# a_9772_5843# 0.1657f
C409 a_13121_5831# a_14851_5182# 0.03337f
C410 a_1544_289# a_2297_331# 0.27303f
C411 a_16108_289# MUX_SEL4 0.1283f
C412 a_15964_289# MUX_OUT 0.01307f
C413 VDD a_10404_1008# 0.28633f
C414 a_16597_1842# a_17357_1842# 0.01669f
C415 DELAY_VBIASN a_7390_1044# 0.02115f
C416 a_21483_1842# a_21591_2470# 0.01697f
C417 a_14751_2470# VDD 0.01806f
C418 a_9772_5843# VDD 0.24701f
C419 a_24197_1842# a_24957_1842# 0.02912f
C420 a_24393_1842# VDD 0.49285f
C421 a_21483_1842# DELAY_VBIASN 0.08024f
C422 a_21353_1842# DELAY_VBIASP 0.11284f
C423 a_20968_1044# VDD 0.17499f
C424 a_6391_1842# a_6283_1842# 0.01163f
C425 a_2019_311# a_17865_519# 0.13959f
C426 a_6391_2470# a_6283_1842# 0.01697f
C427 a_15464_3684# DELAY_OUT_LAST 0.02565f
C428 a_15403_1842# VDD 0.4973f
C429 a_16510_1044# a_18443_1842# 0.01012f
C430 a_25717_1842# a_25604_1008# 0.05157f
C431 a_6126_3816# a_6854_5454# 0.22705f
C432 a_27915_1044# VDD 0.15389f
C433 a_9323_1842# DELAY_VBIASN 0.07254f
C434 a_9193_1842# DELAY_VBIASP 0.11222f
C435 a_12849_5867# REF_CLK 0.26382f
C436 VDD a_8155_1044# 0.15389f
C437 a_15837_1842# a_15403_1842# 0.6972f
C438 a_13883_1842# DELAY_VBIASN 0.07254f
C439 a_14964_1008# a_13470_1044# 0.28279f
C440 a_12797_1842# MUX_SEL4 0.01829f
C441 a_13753_1842# DELAY_VBIASP 0.11222f
C442 a_6326_4590# VDD 7.53039f
C443 a_12849_5867# a_15304_4605# 0.0606f
C444 a_23437_1842# a_23003_1842# 0.6972f
C445 a_22677_1842# VDD 0.86707f
C446 a_18004_1008# VDD 0.28225f
C447 a_19448_1044# a_19550_1044# 0.37183f
C448 a_4871_1842# a_4763_1842# 0.01163f
C449 a_25717_1842# a_26185_1044# 0.19203f
C450 a_4324_1008# VDD 0.28597f
C451 a_9444_3912# VDD 0.0107f
C452 a_7390_1044# a_8231_1008# 0.28268f
C453 a_5768_1044# a_5844_1008# 0.01176f
C454 a_4871_2470# a_4763_1842# 0.01697f
C455 a_13592_5871# a_14851_6228# 0.01529f
C456 a_24951_1008# VDD 0.2822f
C457 a_7673_1842# DELAY_VBIASN 0.0961f
C458 a_7477_1842# DELAY_VBIASP 0.0414f
C459 a_4437_1842# a_4003_1842# 0.69698f
C460 a_12158_5867# REF_CLK 0.01309f
C461 a_16851_309# VDD 0.51536f
C462 a_3449_331# MUX_SEL4 0.05166f
C463 a_15077_1842# VDD 0.85965f
C464 a_12233_1842# DELAY_VBIASN 0.0961f
C465 a_12037_1842# DELAY_VBIASP 0.04141f
C466 a_13566_5835# a_14009_5878# 0.02242f
C467 a_13121_5831# a_14111_5878# 0.0235f
C468 a_12505_1044# a_12715_1044# 0.09424f
C469 a_25630_1044# a_26471_1008# 0.28268f
C470 a_15837_1842# a_15077_1842# 0.02912f
C471 a_22113_1842# a_22677_1842# 0.0114f
C472 a_5778_3367# a_6326_4590# 0.8779f
C473 a_15755_1044# VDD 0.15389f
C474 a_17928_1044# a_18004_1008# 0.01176f
C475 a_21625_1044# VDD 0.29722f
C476 a_6635_1044# a_6711_1008# 0.01194f
C477 a_15688_5403# VDD 0.30345f
C478 a_12363_1842# a_10430_1044# 0.01012f
C479 a_4350_1044# a_4324_1008# 0.277f
C480 DLL_RESETN DELAY_VBIASP 0.07017f
C481 a_24197_1842# a_22590_1044# 0.05231f
C482 a_23437_1842# a_23431_1008# 0.02349f
C483 a_7803_1842# VDD 0.4973f
C484 a_22488_1044# VDD 0.17274f
C485 a_17065_1044# a_16597_1842# 0.19203f
C486 a_5957_1842# DELAY_VBIASN 0.09156f
C487 a_4763_1842# DELAY_VBIASP 0.06627f
C488 a_10232_5871# DLL_RESETN 0.39088f
C489 a_15304_4605# DELAY_OUT_LAST 0.05582f
C490 a_26185_1044# a_26395_1044# 0.09424f
C491 a_12363_1842# VDD 0.4973f
C492 a_10517_1842# DELAY_VBIASN 0.08375f
C493 a_24875_1044# a_24951_1008# 0.01194f
C494 a_21157_1842# a_21917_1842# 0.02912f
C495 a_9444_4590# a_6126_3816# 0.03029f
C496 a_16510_1044# a_16484_1008# 0.277f
C497 a_12355_5867# a_13019_5831# 0.3846f
C498 a_9465_1044# VDD 0.29722f
C499 a_16108_289# a_16851_309# 0.06181f
C500 a_18585_1044# a_18795_1044# 0.09424f
C501 a_14513_1842# a_15077_1842# 0.0114f
C502 a_13592_5423# VDD 0.11685f
C503 a_21917_1842# a_22564_1008# 0.02011f
C504 a_6153_1842# VDD 0.49285f
C505 a_12907_5186# VDD 0.06323f
C506 a_5705_519# VDD 0.29556f
C507 a_22243_1842# a_22351_1842# 0.01163f
C508 a_10713_1842# VDD 0.49294f
C509 a_14964_1008# a_15077_1842# 0.02055f
C510 a_7945_1044# a_8155_1044# 0.09424f
C511 a_8997_1842# a_9757_1842# 0.02912f
C512 a_22590_1044# a_24084_1008# 0.28279f
C513 a_23355_1044# a_23431_1008# 0.01194f
C514 a_1256_289# a_2297_331# 0.04261f
C515 a_6854_5986# REF_CLK 0.05061f
C516 a_6126_3816# DLL_RESETN 0.06398f
C517 a_26911_2470# a_26803_1842# 0.01697f
C518 a_15304_4605# a_6854_5986# 0.08165f
C519 a_13557_1842# a_14317_1842# 0.01669f
C520 a_1256_1044# MUX_OUT 0.02466f
C521 a_2297_1395# MUX_SEL0 0.10655f
C522 a_1544_1044# MUX_SEL4 0.03407f
C523 a_21157_1842# a_21044_1008# 0.02055f
C524 a_13991_2470# VDD 0.01806f
C525 a_14851_6228# VDD 0.25326f
C526 a_5844_1008# a_5197_1842# 0.02312f
C527 a_20723_1842# a_20831_1842# 0.01163f
C528 a_21625_1044# a_21911_1008# 0.01885f
C529 a_4350_1044# a_5705_519# 0.02005f
C530 MUX_SEL2 MUX_SEL4 0.01978f
C531 MUX_SEL1 MUX_OUT 0.09357f
C532 a_8237_1842# a_7803_1842# 0.6972f
C533 a_10232_5871# a_11397_6228# 0.43239f
C534 a_2019_311# a_15964_289# 0.02413f
C535 a_14025_1044# a_14235_1044# 0.09424f
C536 a_12797_1842# a_12363_1842# 0.6972f
C537 a_20905_519# VDD 0.29292f
C538 a_19637_1842# a_19833_1842# 0.73897f
C539 a_26477_1842# a_26673_1842# 0.76914f
C540 a_7911_2470# VDD 0.01806f
C541 a_13592_5871# VDD 0.07242f
C542 a_26043_1842# DELAY_VBIASP 0.06661f
C543 a_27237_1842# DELAY_VBIASN 0.10152f
C544 a_12656_5864# VDD 0.26066f
C545 a_6913_1842# a_7477_1842# 0.0114f
C546 a_6425_1044# a_6635_1044# 0.09424f
C547 a_18877_1842# DELAY_VBIASP 0.04176f
C548 a_19073_1842# DELAY_VBIASN 0.10642f
C549 a_13566_5328# a_13306_5105# 0.75507f
C550 a_10206_5835# a_10649_5878# 0.02242f
C551 a_11473_1842# a_12037_1842# 0.0114f
C552 a_25283_1842# a_25391_1842# 0.01163f
C553 a_1721_1395# VDD 0.4533f
C554 a_18313_1842# a_18443_1842# 0.70845f
C555 a_26151_2470# VDD 0.01806f
C556 a_25717_1842# a_26477_1842# 0.01669f
C557 a_27433_1842# VDD 0.49285f
C558 a_4003_1842# a_4111_1842# 0.01163f
C559 a_25283_1842# DELAY_VBIASN 0.08024f
C560 a_25153_1842# DELAY_VBIASP 0.11284f
C561 VDD MUX_SEL3 0.4053f
C562 a_10985_1044# a_10517_1842# 0.19203f
C563 a_4003_1842# a_4111_2470# 0.01697f
C564 a_15304_4605# a_14111_5227# 0.01761f
C565 a_10751_5878# VDD 0.20377f
C566 a_5957_1842# a_6717_1842# 0.02912f
C567 a_13132_5420# REF_CLK 0.02025f
C568 a_16108_289# a_20905_519# 0.2906f
C569 a_19203_1842# VDD 0.49737f
C570 a_16163_1842# DELAY_VBIASP 0.06661f
C571 a_17357_1842# DELAY_VBIASN 0.10669f
C572 a_19550_1044# a_19963_1842# 0.01012f
C573 a_8563_1842# a_8671_1842# 0.01163f
C574 a_13106_5357# a_12907_5186# 0.02437f
C575 a_13121_5831# a_15464_3684# 0.33256f
C576 a_10517_1842# a_11277_1842# 0.01669f
C577 a_23763_1842# a_23871_1842# 0.01163f
C578 VDD a_13368_1044# 0.17274f
C579 a_17357_1842# a_17683_1842# 0.01427f
C580 MUX_SEL4 a_7390_1044# 0.34655f
C581 a_20071_2470# VDD 0.01806f
C582 a_6126_3816# DELAY_VBIASP 0.01821f
C583 a_24957_1842# a_25283_1842# 0.01427f
C584 a_23633_1842# DELAY_VBIASN 0.10349f
C585 a_23437_1842# DELAY_VBIASP 0.04176f
C586 a_5197_1842# a_4763_1842# 0.6972f
C587 a_10328_1044# a_10404_1008# 0.01176f
C588 a_4437_1842# DELAY_VBIASP 0.0414f
C589 a_17553_1842# VDD 0.49417f
C590 a_19448_1044# a_18877_1842# 0.10864f
C591 a_7043_1842# a_7151_1842# 0.01163f
C592 a_1544_289# a_1721_331# 0.36963f
C593 a_15964_289# MUX_SEL4 0.5544f
C594 VDD a_10430_1044# 0.88416f
C595 a_16597_1842# a_16793_1842# 0.73897f
C596 a_9746_5805# VDD 0.0918f
C597 a_12849_5867# a_13306_5105# 0.10976f
C598 a_24197_1842# a_24393_1842# 0.77122f
C599 a_23763_1842# VDD 0.49671f
C600 a_4157_1313# REF_CLK 0.50643f
C601 a_21917_1842# DELAY_VBIASN 0.10687f
C602 a_20391_1008# VDD 0.28336f
C603 a_20723_1842# DELAY_VBIASP 0.06661f
C604 a_12943_5867# DLL_RESETN 0.03616f
C605 a_13883_1842# a_13470_1044# 0.01012f
C606 a_15837_1842# VDD 0.87963f
C607 a_16510_1044# a_18877_1842# 0.02479f
C608 a_15108_6109# a_14851_6228# 0.29858f
C609 a_25717_1842# a_25630_1044# 0.1088f
C610 a_6854_5986# a_6854_5454# 0.30877f
C611 a_27124_1008# VDD 0.28225f
C612 a_9757_1842# DELAY_VBIASN 0.09992f
C613 a_8563_1842# DELAY_VBIASP 0.06627f
C614 a_13121_5831# REF_CLK 1.40135f
C615 a_12849_5867# DLL_RESETN 0.3501f
C616 a_8745_519# MUX_SEL4 0.04472f
C617 a_5731_289# MUX_OUT 1.04829f
C618 VDD a_7364_1008# 0.28633f
C619 a_15273_1842# a_15403_1842# 0.70845f
C620 a_13123_1842# DELAY_VBIASP 0.06627f
C621 a_14888_1044# a_13470_1044# 0.38994f
C622 a_14317_1842# DELAY_VBIASN 0.09974f
C623 a_13121_5831# a_15304_4605# 0.40921f
C624 a_21044_1008# a_20397_1842# 0.02312f
C625 a_22873_1842# a_23003_1842# 0.70845f
C626 a_22113_1842# VDD 0.49426f
C627 a_5864_3367# a_6854_5454# 0.03661f
C628 a_17928_1044# VDD 0.17499f
C629 a_4350_1044# VDD 0.87635f
C630 a_12797_1842# a_13368_1044# 0.10864f
C631 a_7390_1044# a_8155_1044# 0.39037f
C632 a_16484_1008# a_16597_1842# 0.05157f
C633 a_14009_5878# a_14111_5878# 0.47795f
C634 a_24875_1044# VDD 0.15406f
C635 a_18585_1044# a_18117_1842# 0.2079f
C636 a_6913_1842# DELAY_VBIASP 0.11222f
C637 a_7043_1842# DELAY_VBIASN 0.07254f
C638 a_12158_5867# DLL_RESETN 0.02442f
C639 a_11491_6228# REF_CLK 0.01827f
C640 a_16108_289# VDD 1.22378f
C641 a_3449_331# MUX_SEL3 0.28429f
C642 a_2873_331# MUX_SEL4 0.04916f
C643 a_2297_331# MUX_OUT 0.01179f
C644 a_14513_1842# VDD 0.49436f
C645 a_11473_1842# DELAY_VBIASP 0.11222f
C646 a_11603_1842# DELAY_VBIASN 0.07254f
C647 a_13566_5835# a_13592_5871# 0.36952f
C648 a_25630_1044# a_26395_1044# 0.39037f
C649 a_21917_1842# a_22243_1842# 0.01427f
C650 a_15273_1842# a_15077_1842# 0.77122f
C651 a_21157_1842# a_19550_1044# 0.05231f
C652 a_14964_1008# VDD 0.28225f
C653 a_12849_5867# a_13306_6305# 0.12097f
C654 a_20105_1044# VDD 0.30409f
C655 a_20105_1044# a_20391_1008# 0.01885f
C656 a_12797_1842# a_10430_1044# 0.02479f
C657 a_15108_5325# VDD 0.13728f
C658 a_4248_1044# a_4324_1008# 0.01176f
C659 REF_CLK DELAY_VBIASN 0.07156f
C660 a_8237_1842# VDD 0.86909f
C661 a_21911_1008# VDD 0.2822f
C662 a_5197_1842# DELAY_VBIASP 0.0414f
C663 a_5393_1842# DELAY_VBIASN 0.0961f
C664 a_15464_3684# a_9712_3912# 0.01237f
C665 a_10206_5835# DLL_RESETN 0.27343f
C666 a_15304_4605# DELAY_VBIASN 0.07802f
C667 a_27705_1044# a_25630_1044# 0.03208f
C668 a_12797_1842# VDD 0.87771f
C669 a_9953_1842# DELAY_VBIASN 0.0961f
C670 a_21157_1842# a_21353_1842# 0.77122f
C671 a_9444_4590# a_6854_5986# 0.05054f
C672 a_16408_1044# a_16484_1008# 0.01176f
C673 a_12355_5867# a_12656_5864# 0.03277f
C674 a_7803_1842# a_7390_1044# 0.01012f
C675 a_7945_1044# VDD 0.30409f
C676 a_15964_289# a_16851_309# 0.16757f
C677 a_10517_1842# a_10404_1008# 0.05157f
C678 a_14317_1842# a_14643_1842# 0.01427f
C679 a_3449_1395# MUX_SEL1 0.29404f
C680 a_5523_1842# VDD 0.49671f
C681 a_13106_5357# VDD 0.09228f
C682 a_9444_4590# a_5864_3367# 0.06832f
C683 a_3449_331# VDD 0.46596f
C684 a_10083_1842# VDD 0.49727f
C685 a_9465_1044# a_7390_1044# 0.03208f
C686 a_8997_1842# a_9193_1842# 0.77122f
C687 a_22590_1044# a_24008_1044# 0.38994f
C688 a_1544_1044# a_1721_1395# 0.38063f
C689 a_1256_289# a_1721_331# 0.13421f
C690 a_6854_5986# DLL_RESETN 0.50331f
C691 a_6717_1842# a_7288_1044# 0.10864f
C692 a_27563_1842# a_27671_1842# 0.01163f
C693 a_13557_1842# a_13753_1842# 0.73897f
C694 a_1256_1044# MUX_SEL4 0.04908f
C695 a_13231_2470# VDD 0.01806f
C696 a_15108_6109# VDD 0.1349f
C697 a_14851_5182# a_15688_5403# 0.08776f
C698 a_21625_1044# a_21835_1044# 0.09424f
C699 a_5768_1044# a_5197_1842# 0.10863f
C700 a_5864_3367# DLL_RESETN 0.1727f
C701 a_9712_3912# REF_CLK 0.06514f
C702 a_4437_1842# a_5197_1842# 0.01669f
C703 MUX_SEL2 MUX_SEL3 3.21891f
C704 MUX_SEL1 MUX_SEL4 0.03574f
C705 a_13306_5105# a_13880_5118# 0.31978f
C706 a_13566_5835# VDD 0.09466f
C707 a_7673_1842# a_7803_1842# 0.70845f
C708 a_19963_1842# DELAY_VBIASP 0.06661f
C709 a_10520_6292# a_10751_5878# 0.12701f
C710 a_26043_1842# a_26151_1842# 0.01163f
C711 a_2019_311# a_15765_463# 0.05969f
C712 a_12233_1842# a_12363_1842# 0.70845f
C713 a_17865_519# VDD 0.29444f
C714 a_19637_1842# a_19203_1842# 0.69698f
C715 a_26477_1842# a_26043_1842# 0.6972f
C716 a_7151_2470# VDD 0.01806f
C717 a_13592_5423# a_14851_5182# 0.01529f
C718 a_26673_1842# DELAY_VBIASN 0.105f
C719 a_26477_1842# DELAY_VBIASP 0.04181f
C720 a_4437_1842# a_4905_1044# 0.19203f
C721 a_19311_2470# a_19203_1842# 0.01697f
C722 DELAY_OUT_LAST DELAY_VBIASP 1.08837f
C723 a_12505_1044# a_12037_1842# 0.2079f
C724 a_13306_5105# a_14111_5227# 0.097f
C725 a_12355_5867# VDD 0.37639f
C726 a_6717_1842# a_7043_1842# 0.01427f
C727 a_18443_1842# DELAY_VBIASN 0.08024f
C728 a_18313_1842# DELAY_VBIASP 0.11284f
C729 a_10206_5835# a_10232_5871# 0.36952f
C730 a_13132_5420# a_13306_5105# 0.27179f
C731 a_13991_2470# a_13883_1842# 0.01697f
C732 a_2019_311# a_5731_289# 1.15781f
C733 a_11277_1842# a_11603_1842# 0.01427f
C734 a_18313_1842# a_18877_1842# 0.0114f
C735 a_1544_1044# VDD 0.45079f
C736 a_25391_2470# VDD 0.01806f
C737 a_26803_1842# VDD 0.49671f
C738 a_10649_5878# a_9946_6305# 0.02432f
C739 a_24523_1842# DELAY_VBIASP 0.06661f
C740 a_25717_1842# DELAY_VBIASN 0.09106f
C741 a_17791_2470# a_17683_1842# 0.01697f
C742 VDD MUX_SEL2 0.50938f
C743 a_13132_5420# DLL_RESETN 0.01689f
C744 a_5957_1842# a_6153_1842# 0.77122f
C745 a_16108_289# a_17865_519# 0.29564f
C746 a_10430_1044# a_12791_1008# 0.26208f
C747 a_19637_1842# VDD 0.86707f
C748 a_16793_1842# DELAY_VBIASN 0.10734f
C749 a_19550_1044# a_20397_1842# 0.08038f
C750 a_16597_1842# DELAY_VBIASP 0.04176f
C751 a_13019_5831# a_15464_3684# 0.59875f
C752 a_12471_2470# a_12363_1842# 0.01697f
C753 a_2297_331# a_2019_311# 0.04011f
C754 a_10517_1842# a_10713_1842# 0.73897f
C755 VDD a_12791_1008# 0.2822f
C756 a_17357_1842# a_18117_1842# 0.03319f
C757 a_19311_2470# VDD 0.01806f
C758 a_6854_5986# DELAY_VBIASP 0.01478f
C759 a_24957_1842# a_25717_1842# 0.06198f
C760 a_25913_1842# VDD 0.49294f
C761 a_23003_1842# DELAY_VBIASN 0.08024f
C762 a_16271_2470# a_16163_1842# 0.01697f
C763 a_22873_1842# DELAY_VBIASP 0.11284f
C764 a_19550_1044# DELAY_VBIASN 0.02115f
C765 a_4633_1842# a_4763_1842# 0.70845f
C766 a_10328_1044# a_10430_1044# 0.37183f
C767 a_5864_3367# DELAY_VBIASP 0.03252f
C768 a_4003_1842# DELAY_VBIASN 0.06486f
C769 a_25630_1044# a_26043_1842# 0.01012f
C770 a_16923_1842# VDD 0.4973f
C771 a_18871_1008# a_18877_1842# 0.02354f
C772 a_15688_5867# a_15304_4605# 0.19136f
C773 a_9547_5942# a_9772_5843# 0.02416f
C774 a_9547_6172# a_9746_5805# 0.02437f
C775 a_25630_1044# DELAY_VBIASP 0.01522f
C776 a_10951_2470# a_10843_1842# 0.01697f
C777 a_9757_1842# MUX_SEL4 0.01829f
C778 a_15765_463# MUX_SEL4 0.65508f
C779 VDD a_10328_1044# 0.17274f
C780 a_16597_1842# a_16163_1842# 0.69698f
C781 a_9547_6172# VDD 0.08695f
C782 a_12849_5867# a_13566_5328# 0.26617f
C783 a_24197_1842# a_23763_1842# 0.6972f
C784 a_24197_1842# VDD 0.85848f
C785 a_3449_1395# REF_CLK 0.01058f
C786 a_21353_1842# DELAY_VBIASN 0.10734f
C787 a_21157_1842# DELAY_VBIASP 0.04177f
C788 a_20315_1044# VDD 0.15389f
C789 a_20315_1044# a_20391_1008# 0.01194f
C790 a_14009_5878# REF_CLK 0.25847f
C791 a_8808_1044# a_8884_1008# 0.01176f
C792 a_14317_1842# a_13470_1044# 0.08038f
C793 a_15273_1842# VDD 0.49298f
C794 a_18004_1008# a_17357_1842# 0.02312f
C795 a_14111_5878# a_14851_6228# 0.26905f
C796 a_6854_5986# a_6126_3816# 0.18536f
C797 a_5974_5723# a_6854_5454# 0.01757f
C798 a_27048_1044# VDD 0.17499f
C799 a_20105_1044# a_19637_1842# 0.19203f
C800 a_9193_1842# DELAY_VBIASN 0.0961f
C801 a_8997_1842# DELAY_VBIASP 0.04141f
C802 a_13121_5831# DLL_RESETN 0.04337f
C803 a_13019_5831# REF_CLK 0.35409f
C804 a_5731_289# MUX_SEL4 4.60702f
C805 VDD a_7390_1044# 0.8686f
C806 a_15273_1842# a_15837_1842# 0.0114f
C807 a_13557_1842# DELAY_VBIASP 0.0414f
C808 a_13753_1842# DELAY_VBIASN 0.0961f
C809 a_14311_1008# a_13470_1044# 0.28268f
C810 a_13019_5831# a_15304_4605# 0.07025f
C811 a_27048_1044# a_27124_1008# 0.01176f
C812 a_19963_1842# a_20071_1842# 0.01163f
C813 a_22873_1842# a_23437_1842# 0.0114f
C814 a_9712_3912# a_6854_5454# 0.67835f
C815 a_21483_1842# VDD 0.4973f
C816 a_5864_3367# a_6126_3816# 0.23738f
C817 a_17351_1008# VDD 0.28565f
C818 a_9757_1842# a_10404_1008# 0.02011f
C819 a_4248_1044# VDD 0.17587f
C820 a_5731_289# a_13470_1044# 0.41365f
C821 a_12797_1842# a_12791_1008# 0.02354f
C822 a_7390_1044# a_7364_1008# 0.277f
C823 a_16510_1044# a_16597_1842# 0.1088f
C824 REF_CLK MUX_SEL4 0.0663f
C825 a_14009_5878# a_13880_6292# 0.01562f
C826 a_13592_5871# a_14111_5878# 0.34102f
C827 a_9323_1842# VDD 0.4973f
C828 a_24084_1008# VDD 0.28225f
C829 a_7477_1842# DELAY_VBIASN 0.08375f
C830 a_6283_1842# DELAY_VBIASP 0.06627f
C831 a_11491_6228# DLL_RESETN 0.14622f
C832 a_11748_6109# REF_CLK 0.0148f
C833 a_15964_289# VDD 0.31312f
C834 a_27705_1044# a_27991_1008# 0.01885f
C835 a_2297_331# MUX_SEL4 0.04338f
C836 a_3449_331# MUX_SEL2 0.10741f
C837 a_2873_331# MUX_SEL3 0.12606f
C838 a_13883_1842# VDD 0.49742f
C839 a_12037_1842# DELAY_VBIASN 0.09156f
C840 a_10843_1842# DELAY_VBIASP 0.06627f
C841 a_12849_5867# a_12943_5867# 0.16706f
C842 a_25630_1044# a_25604_1008# 0.277f
C843 a_15837_1842# a_15964_289# 0.02f
C844 a_18443_1842# a_18551_1842# 0.01163f
C845 a_21917_1842# a_22677_1842# 0.06198f
C846 a_14888_1044# VDD 0.17499f
C847 a_13121_5831# a_13306_6305# 0.01008f
C848 a_13019_5831# a_13045_6215# 0.01249f
C849 a_16510_1044# a_18871_1008# 0.26208f
C850 a_8997_1842# a_8884_1008# 0.02055f
C851 a_18585_1044# VDD 0.29722f
C852 a_20105_1044# a_20315_1044# 0.09424f
C853 a_11277_1842# a_11924_1008# 0.02312f
C854 a_14851_5182# VDD 0.26676f
C855 a_4248_1044# a_4350_1044# 0.37183f
C856 DLL_RESETN DELAY_VBIASN 0.12907f
C857 a_23003_1842# a_22590_1044# 0.01012f
C858 a_21835_1044# VDD 0.15406f
C859 a_7673_1842# VDD 0.49294f
C860 a_20968_1044# a_21044_1008# 0.01176f
C861 a_4633_1842# DELAY_VBIASP 0.11222f
C862 a_4763_1842# DELAY_VBIASN 0.07254f
C863 a_8745_519# VDD 0.29292f
C864 a_26185_1044# a_25630_1044# 0.03209f
C865 a_12233_1842# VDD 0.49285f
C866 a_9465_1044# a_9751_1008# 0.01885f
C867 a_16923_1842# a_17031_1842# 0.01163f
C868 a_21157_1842# a_20723_1842# 0.6972f
C869 a_16408_1044# a_16510_1044# 0.37183f
C870 a_9946_6305# DLL_RESETN 0.09997f
C871 a_8237_1842# a_7390_1044# 0.08038f
C872 a_15964_289# a_16108_289# 0.42202f
C873 a_14317_1842# a_15077_1842# 0.03319f
C874 a_10517_1842# a_10430_1044# 0.1088f
C875 a_3449_1395# MUX_SEL0 0.10753f
C876 a_21917_1842# a_22488_1044# 0.10864f
C877 a_5957_1842# VDD 0.85848f
C878 a_15688_5403# a_15464_3684# 0.1999f
C879 a_9444_4590# a_9712_3912# 0.68929f
C880 a_2873_331# VDD 0.46491f
C881 a_23145_1044# a_23431_1008# 0.01885f
C882 a_10517_1842# VDD 0.86707f
C883 a_7945_1044# a_7390_1044# 0.03209f
C884 a_8997_1842# a_8563_1842# 0.6972f
C885 a_22590_1044# a_23431_1008# 0.28268f
C886 a_12849_5867# DELAY_OUT_LAST 0.01791f
C887 a_15403_1842# a_15511_1842# 0.01163f
C888 a_1256_1044# a_1721_1395# 0.13421f
C889 a_1256_289# a_1544_289# 1.25711f
C890 a_14888_1044# a_14964_1008# 0.01176f
C891 a_11491_6228# a_11397_6228# 0.28931f
C892 a_5974_5723# DLL_RESETN 0.02002f
C893 a_6717_1842# a_6711_1008# 0.02354f
C894 a_15545_1044# a_15831_1008# 0.01885f
C895 a_13557_1842# a_13123_1842# 0.69698f
C896 a_27237_1842# a_27433_1842# 0.77122f
C897 a_12471_2470# VDD 0.01806f
C898 a_14111_5878# VDD 0.21331f
C899 a_14009_5084# a_14757_5182# 0.01058f
C900 a_14851_5182# a_15108_5325# 0.29858f
C901 a_27563_1842# DELAY_VBIASP 0.06663f
C902 a_4350_1044# a_5957_1842# 0.05231f
C903 a_5191_1008# a_5197_1842# 0.02349f
C904 a_9712_3912# DLL_RESETN 0.43103f
C905 a_13444_1008# a_13557_1842# 0.05157f
C906 a_4437_1842# a_4633_1842# 0.73897f
C907 a_14025_1044# a_13557_1842# 0.19203f
C908 a_7673_1842# a_8237_1842# 0.0114f
C909 a_21835_1044# a_21911_1008# 0.01194f
C910 a_20397_1842# DELAY_VBIASP 0.04176f
C911 a_10232_5871# a_11491_6228# 0.01529f
C912 a_14643_1842# a_14751_1842# 0.01163f
C913 a_12233_1842# a_12797_1842# 0.0114f
C914 a_2873_1395# VDD 0.46517f
C915 a_19073_1842# a_19203_1842# 0.70845f
C916 a_5191_1008# a_4905_1044# 0.01885f
C917 a_6391_2470# VDD 0.01806f
C918 a_26043_1842# DELAY_VBIASN 0.08024f
C919 a_12849_5867# a_6854_5986# 0.06216f
C920 a_4437_1842# a_4157_1313# 0.01771f
C921 DELAY_VBIASN DELAY_VBIASP 8.74838f
C922 a_13306_5105# a_14009_5084# 0.02454f
C923 a_6717_1842# a_7477_1842# 0.06198f
C924 a_17683_1842# DELAY_VBIASP 0.06661f
C925 a_18877_1842# DELAY_VBIASN 0.10687f
C926 a_5705_519# a_5731_289# 0.28954f
C927 a_13123_1842# a_13231_1842# 0.01163f
C928 a_11277_1842# a_12037_1842# 0.03319f
C929 a_1256_1044# VDD 0.475f
C930 a_24631_2470# VDD 0.01806f
C931 a_27237_1842# VDD 0.85969f
C932 a_10232_5871# a_9946_6305# 0.41329f
C933 a_13592_5423# REF_CLK 0.03445f
C934 a_24957_1842# DELAY_VBIASP 0.04176f
C935 a_25153_1842# DELAY_VBIASN 0.10332f
C936 VDD MUX_SEL1 0.50267f
C937 a_15304_4605# a_13592_5423# 0.01817f
C938 a_12907_5420# DLL_RESETN 0.04234f
C939 a_5957_1842# a_5523_1842# 0.6972f
C940 a_10430_1044# a_12715_1044# 0.39036f
C941 a_27124_1008# a_27237_1842# 0.02055f
C942 a_19073_1842# VDD 0.49426f
C943 a_16033_1842# DELAY_VBIASP 0.11287f
C944 a_16163_1842# DELAY_VBIASN 0.08306f
C945 a_1721_331# a_2019_311# 0.18452f
C946 a_11603_1842# a_11711_1842# 0.01163f
C947 a_10517_1842# a_10083_1842# 0.69698f
C948 VDD a_12715_1044# 0.15406f
C949 a_17357_1842# a_17553_1842# 0.76914f
C950 a_18551_2470# VDD 0.01806f
C951 a_6854_5986# DELAY_OUT_LAST 0.08491f
C952 a_24957_1842# a_25153_1842# 0.76914f
C953 a_25283_1842# VDD 0.49737f
C954 a_22243_1842# DELAY_VBIASP 0.06661f
C955 a_23437_1842# DELAY_VBIASN 0.10669f
C956 a_4633_1842# a_5197_1842# 0.0114f
C957 a_25630_1044# a_26477_1842# 0.08038f
C958 a_9712_3912# DELAY_VBIASP 0.14197f
C959 a_4437_1842# DELAY_VBIASN 0.08375f
C960 a_20723_1842# a_20397_1842# 0.01427f
C961 a_17357_1842# VDD 0.86909f
C962 a_14851_6228# a_15304_4605# 0.12139f
C963 a_9547_5942# a_9746_5805# 0.14994f
C964 a_12849_5867# a_14111_5227# 0.42064f
C965 a_10083_1842# a_10191_1842# 0.01163f
C966 a_14825_519# MUX_SEL4 0.03307f
C967 VDD a_9751_1008# 0.2822f
C968 a_14643_1842# DELAY_VBIASP 0.06668f
C969 a_16033_1842# a_16163_1842# 0.70845f
C970 a_9547_5942# VDD 0.1511f
C971 a_12849_5867# a_13132_5420# 0.06758f
C972 a_23633_1842# VDD 0.49417f
C973 a_23633_1842# a_23763_1842# 0.70845f
C974 a_20723_1842# DELAY_VBIASN 0.07937f
C975 a_20593_1842# DELAY_VBIASP 0.11287f
C976 a_19524_1008# VDD 0.28633f
C977 a_16510_1044# DELAY_VBIASN 0.02115f
C978 a_19550_1044# a_20968_1044# 0.38994f
C979 a_14825_519# a_13470_1044# 0.02058f
C980 a_13592_5871# REF_CLK 0.11539f
C981 a_17928_1044# a_17357_1842# 0.10863f
C982 a_14111_5878# a_15108_6109# 0.03093f
C983 a_6326_4590# a_6854_5454# 1.25249f
C984 a_5974_5723# a_6126_3816# 1.74589f
C985 a_24957_1842# a_25604_1008# 0.02011f
C986 a_26471_1008# VDD 0.28336f
C987 a_8433_1842# DELAY_VBIASP 0.11222f
C988 a_8563_1842# DELAY_VBIASN 0.07254f
C989 a_12656_5864# REF_CLK 0.01215f
C990 a_13019_5831# DLL_RESETN 0.01429f
C991 VDD a_7288_1044# 0.17274f
C992 a_12993_1842# DELAY_VBIASP 0.11222f
C993 a_14235_1044# a_13470_1044# 0.39037f
C994 a_13123_1842# DELAY_VBIASN 0.07254f
C995 a_15545_1044# a_13470_1044# 0.03208f
C996 a_21917_1842# VDD 0.87825f
C997 a_9444_3912# a_6854_5454# 0.8486f
C998 a_17275_1044# VDD 0.15389f
C999 a_7288_1044# a_7364_1008# 0.01176f
C1000 a_15464_3684# VDD 0.52511f
C1001 a_14111_5227# DELAY_OUT_LAST 0.02024f
C1002 a_13592_5871# a_13880_6292# 0.43707f
C1003 a_24197_1842# a_24084_1008# 0.02055f
C1004 a_9757_1842# VDD 0.87771f
C1005 a_24008_1044# VDD 0.17499f
C1006 a_6717_1842# DELAY_VBIASP 0.0414f
C1007 a_6913_1842# DELAY_VBIASN 0.0961f
C1008 a_10751_5878# REF_CLK 0.01931f
C1009 a_11748_6109# DLL_RESETN 0.11133f
C1010 a_15765_463# VDD 0.35368f
C1011 a_27705_1044# a_27915_1044# 0.09424f
C1012 a_1544_289# MUX_OUT 0.69943f
C1013 a_2297_331# MUX_SEL3 0.01595f
C1014 a_2873_331# MUX_SEL2 0.01422f
C1015 a_1721_331# MUX_SEL4 0.05813f
C1016 a_14317_1842# VDD 0.87229f
C1017 a_11473_1842# DELAY_VBIASN 0.0961f
C1018 a_11277_1842# DELAY_VBIASP 0.0414f
C1019 a_13121_5831# a_12943_5867# 0.09118f
C1020 a_13306_6305# a_14009_5878# 0.02432f
C1021 a_25528_1044# a_25604_1008# 0.01176f
C1022 a_21917_1842# a_22113_1842# 0.76914f
C1023 a_14311_1008# VDD 0.28336f
C1024 a_16510_1044# a_18795_1044# 0.39036f
C1025 a_13121_5831# a_12849_5867# 0.55272f
C1026 a_9323_1842# a_7390_1044# 0.01012f
C1027 a_17065_1044# VDD 0.30218f
C1028 a_21625_1044# a_19550_1044# 0.03208f
C1029 a_5731_289# a_10430_1044# 0.41176f
C1030 a_11277_1842# a_11848_1044# 0.10863f
C1031 a_23437_1842# a_22590_1044# 0.08038f
C1032 a_7043_1842# VDD 0.49723f
C1033 a_21044_1008# VDD 0.28225f
C1034 a_5197_1842# DELAY_VBIASN 0.09974f
C1035 a_21917_1842# a_16108_289# 0.0157f
C1036 a_5731_289# VDD 0.6143f
C1037 a_11603_1842# VDD 0.49671f
C1038 a_9465_1044# a_9675_1044# 0.09424f
C1039 a_20593_1842# a_20723_1842# 0.70845f
C1040 a_9444_4590# a_6326_4590# 0.01269f
C1041 a_9772_5843# DLL_RESETN 0.06592f
C1042 a_15765_463# a_16108_289# 0.42004f
C1043 a_8745_519# a_7390_1044# 0.01756f
C1044 a_13132_5420# a_6854_5986# 0.01367f
C1045 a_14317_1842# a_14513_1842# 0.76914f
C1046 VDD REF_CLK 2.08015f
C1047 a_21917_1842# a_21911_1008# 0.02354f
C1048 a_5393_1842# VDD 0.49417f
C1049 a_15304_4605# VDD 0.72158f
C1050 a_9444_4590# a_9444_3912# 2.19249f
C1051 a_15108_5325# a_15464_3684# 0.12158f
C1052 a_2297_331# VDD 0.46496f
C1053 a_23145_1044# a_23355_1044# 0.09424f
C1054 a_9953_1842# VDD 0.49426f
C1055 a_14964_1008# a_14317_1842# 0.02312f
C1056 a_4350_1044# a_5731_289# 0.41099f
C1057 a_15545_1044# a_15077_1842# 0.2079f
C1058 a_13121_5831# DELAY_OUT_LAST 0.13178f
C1059 a_13019_5831# DELAY_VBIASP 0.02377f
C1060 a_8433_1842# a_8563_1842# 0.70845f
C1061 a_22590_1044# a_23355_1044# 0.39037f
C1062 a_1256_1044# a_1544_1044# 1.26509f
C1063 a_11491_6228# a_12158_5867# 0.0894f
C1064 a_5731_289# a_16108_289# 0.01334f
C1065 a_15545_1044# a_15755_1044# 0.09424f
C1066 a_12993_1842# a_13123_1842# 0.70845f
C1067 a_20397_1842# a_19963_1842# 0.6972f
C1068 a_1544_1044# MUX_SEL1 0.1672f
C1069 a_1721_1395# MUX_SEL0 0.01315f
C1070 a_27237_1842# a_26803_1842# 0.6972f
C1071 a_11711_2470# VDD 0.01806f
C1072 a_14111_5227# a_13880_5118# 0.12701f
C1073 a_13592_5423# a_14757_5182# 0.43239f
C1074 a_27997_1842# DELAY_VBIASP 0.04038f
C1075 a_16510_1044# a_2019_311# 0.03139f
C1076 a_9444_3912# DLL_RESETN 0.03031f
C1077 a_19833_1842# DELAY_VBIASP 0.11284f
C1078 a_19963_1842# DELAY_VBIASN 0.08024f
C1079 a_10649_5878# a_10751_5878# 0.47795f
C1080 a_9757_1842# a_10083_1842# 0.01427f
C1081 a_19073_1842# a_19637_1842# 0.0114f
C1082 a_25283_1842# a_25391_2470# 0.01697f
C1083 a_19550_1044# a_20905_519# 0.02165f
C1084 a_5115_1044# a_4905_1044# 0.09424f
C1085 a_5631_2470# VDD 0.01806f
C1086 a_26477_1842# DELAY_VBIASN 0.1083f
C1087 a_13121_5831# a_6854_5986# 0.10056f
C1088 DELAY_VBIASN DELAY_OUT_LAST 3.19293f
C1089 a_25630_1044# a_26985_519# 0.02195f
C1090 a_13306_5105# a_13592_5423# 0.41329f
C1091 a_15304_4605# a_15108_5325# 0.01986f
C1092 a_13566_5328# a_14009_5084# 0.02242f
C1093 a_6717_1842# a_6913_1842# 0.76914f
C1094 a_12715_1044# a_12791_1008# 0.01194f
C1095 a_18117_1842# DELAY_VBIASP 0.04177f
C1096 a_18313_1842# DELAY_VBIASN 0.10734f
C1097 a_1256_289# MUX_OUT 0.1134f
C1098 a_11277_1842# a_11473_1842# 0.76914f
C1099 a_18117_1842# a_18877_1842# 0.02912f
C1100 a_23763_1842# a_23871_2470# 0.01697f
C1101 a_23871_2470# VDD 0.01806f
C1102 a_26673_1842# VDD 0.49417f
C1103 a_10206_5835# a_9946_6305# 0.75507f
C1104 a_24523_1842# DELAY_VBIASN 0.08024f
C1105 a_24393_1842# DELAY_VBIASP 0.11284f
C1106 VDD MUX_SEL0 0.56365f
C1107 a_10649_5878# VDD 0.23431f
C1108 a_12907_5186# DLL_RESETN 0.02177f
C1109 a_5393_1842# a_5523_1842# 0.70845f
C1110 a_11195_1044# a_11271_1008# 0.01194f
C1111 a_3449_331# REF_CLK 0.01017f
C1112 a_10430_1044# a_11924_1008# 0.28279f
C1113 a_8671_2470# a_8563_1842# 0.01697f
C1114 a_25630_1044# a_27563_1842# 0.01024f
C1115 a_18443_1842# VDD 0.4973f
C1116 a_19524_1008# a_19637_1842# 0.05157f
C1117 a_16597_1842# DELAY_VBIASN 0.0907f
C1118 a_15403_1842# DELAY_VBIASP 0.06668f
C1119 a_1544_289# a_2019_311# 0.01747f
C1120 a_9953_1842# a_10083_1842# 0.70845f
C1121 VDD a_11924_1008# 0.28225f
C1122 a_17357_1842# a_16923_1842# 0.6972f
C1123 a_22243_1842# a_22351_2470# 0.01697f
C1124 a_17791_2470# VDD 0.01806f
C1125 a_6854_5986# DELAY_VBIASN 0.15808f
C1126 a_24957_1842# a_24523_1842# 0.6972f
C1127 a_25717_1842# VDD 0.86707f
C1128 a_22677_1842# DELAY_VBIASP 0.04176f
C1129 a_22873_1842# DELAY_VBIASN 0.10734f
C1130 a_7151_2470# a_7043_1842# 0.01697f
C1131 a_21157_1842# a_20397_1842# 0.03319f
C1132 a_16793_1842# VDD 0.49277f
C1133 a_15108_6109# a_15304_4605# 0.17528f
C1134 a_9547_5942# a_9547_6172# 0.1117f
C1135 a_12849_5867# a_14009_5084# 0.03463f
C1136 a_25630_1044# DELAY_VBIASN 0.02756f
C1137 a_13566_5835# REF_CLK 0.01538f
C1138 a_11785_519# MUX_SEL4 0.03255f
C1139 VDD a_9675_1044# 0.15406f
C1140 a_16033_1842# a_16597_1842# 0.0114f
C1141 a_15077_1842# DELAY_VBIASP 0.04184f
C1142 a_20723_1842# a_20831_2470# 0.01697f
C1143 a_6854_5454# VDD 1.03678f
C1144 a_23633_1842# a_24197_1842# 0.0114f
C1145 a_23003_1842# VDD 0.4973f
C1146 a_21157_1842# DELAY_VBIASN 0.09851f
C1147 a_19550_1044# VDD 0.89766f
C1148 a_19550_1044# a_20391_1008# 0.28268f
C1149 a_5631_1842# a_5523_1842# 0.01163f
C1150 a_5844_1008# VDD 0.28225f
C1151 a_4003_1842# VDD 0.61559f
C1152 a_7390_1044# a_9751_1008# 0.26208f
C1153 a_5631_2470# a_5523_1842# 0.01697f
C1154 a_16510_1044# a_18117_1842# 0.05231f
C1155 a_17351_1008# a_17357_1842# 0.02349f
C1156 a_5974_5723# a_6854_5986# 0.029f
C1157 a_6326_4590# a_6126_3816# 2.84014f
C1158 a_26395_1044# VDD 0.15389f
C1159 a_8997_1842# DELAY_VBIASN 0.09156f
C1160 a_7803_1842# DELAY_VBIASP 0.06627f
C1161 a_12355_5867# REF_CLK 1.0042f
C1162 a_12656_5864# DLL_RESETN 0.11782f
C1163 VDD a_6711_1008# 0.2822f
C1164 a_13444_1008# a_13470_1044# 0.277f
C1165 a_12363_1842# DELAY_VBIASP 0.06627f
C1166 a_13557_1842# DELAY_VBIASN 0.08375f
C1167 a_14025_1044# a_13470_1044# 0.03209f
C1168 a_25630_1044# a_27991_1008# 0.26208f
C1169 a_22677_1842# a_23437_1842# 0.01669f
C1170 a_21353_1842# VDD 0.49285f
C1171 a_5864_3367# a_5974_5723# 0.01697f
C1172 a_5778_3367# a_6854_5454# 0.02695f
C1173 a_9712_3912# a_6854_5986# 0.13962f
C1174 a_9444_3912# a_6126_3816# 0.25721f
C1175 a_16484_1008# VDD 0.28597f
C1176 a_18795_1044# a_18871_1008# 0.01194f
C1177 a_9757_1842# a_10328_1044# 0.10864f
C1178 a_27705_1044# VDD 0.29918f
C1179 a_7288_1044# a_7390_1044# 0.37183f
C1180 a_4350_1044# a_5844_1008# 0.28279f
C1181 a_5115_1044# a_5191_1008# 0.01194f
C1182 a_14009_5084# DELAY_OUT_LAST 0.25594f
C1183 a_16484_1008# a_15837_1842# 0.02011f
C1184 a_4437_1842# a_4324_1008# 0.05157f
C1185 a_24523_1842# a_22590_1044# 0.01012f
C1186 a_23431_1008# VDD 0.28336f
C1187 a_9193_1842# VDD 0.49285f
C1188 a_6153_1842# DELAY_VBIASP 0.11222f
C1189 a_6283_1842# DELAY_VBIASN 0.07254f
C1190 a_10751_5878# DLL_RESETN 0.45018f
C1191 a_14825_519# VDD 0.29292f
C1192 a_19550_1044# a_16108_289# 0.58202f
C1193 a_13753_1842# VDD 0.49349f
C1194 a_1544_289# MUX_SEL4 0.47529f
C1195 a_2297_331# MUX_SEL2 0.10655f
C1196 a_10843_1842# DELAY_VBIASN 0.07254f
C1197 a_10713_1842# DELAY_VBIASP 0.11222f
C1198 a_13306_6305# a_13592_5871# 0.41329f
C1199 a_13019_5831# a_12943_5867# 0.03346f
C1200 a_12849_5867# a_14009_5878# 0.03525f
C1201 a_10985_1044# a_11271_1008# 0.01885f
C1202 a_4350_1044# a_6711_1008# 0.26208f
C1203 a_25528_1044# a_25630_1044# 0.37183f
C1204 a_21917_1842# a_21483_1842# 0.6972f
C1205 a_14235_1044# VDD 0.15389f
C1206 a_13019_5831# a_12849_5867# 0.12838f
C1207 a_16510_1044# a_18004_1008# 0.28279f
C1208 a_17275_1044# a_17351_1008# 0.01194f
C1209 a_9757_1842# a_7390_1044# 0.02479f
C1210 a_15545_1044# VDD 0.29918f
C1211 a_20105_1044# a_19550_1044# 0.03209f
C1212 a_12037_1842# a_10430_1044# 0.05231f
C1213 a_9444_4590# VDD 0.01557f
C1214 a_11277_1842# a_11271_1008# 0.02349f
C1215 a_7477_1842# VDD 0.86707f
C1216 a_19550_1044# a_21911_1008# 0.26208f
C1217 a_4633_1842# DELAY_VBIASN 0.0961f
C1218 a_13306_5105# VDD 0.79678f
C1219 a_23003_1842# a_23111_1842# 0.01163f
C1220 a_16510_1044# a_16851_309# 0.02131f
C1221 a_12037_1842# VDD 0.85848f
C1222 a_9757_1842# a_9323_1842# 0.6972f
C1223 a_24008_1044# a_24084_1008# 0.01176f
C1224 a_1256_1044# a_2873_1395# 0.28892f
C1225 a_20593_1842# a_21157_1842# 0.0114f
C1226 a_1256_289# a_2019_311# 0.02904f
C1227 a_7477_1842# a_7364_1008# 0.05157f
C1228 a_17065_1044# a_17351_1008# 0.01885f
C1229 a_15765_463# a_15964_289# 0.061f
C1230 a_5731_289# a_7390_1044# 0.41331f
C1231 a_27671_2470# a_27563_1842# 0.01697f
C1232 a_14317_1842# a_13883_1842# 0.6972f
C1233 a_4157_1313# DELAY_VBIASN 0.01202f
C1234 a_2873_1395# MUX_SEL1 0.13092f
C1235 VDD DLL_RESETN 2.47079f
C1236 a_4763_1842# VDD 0.4973f
C1237 a_9444_4590# a_5778_3367# 0.19787f
C1238 a_14851_5182# a_15464_3684# 0.04797f
C1239 a_1721_331# VDD 0.45259f
C1240 a_21483_1842# a_21591_1842# 0.01163f
C1241 a_24665_1044# a_22590_1044# 0.03208f
C1242 a_14888_1044# a_14317_1842# 0.10863f
C1243 a_8433_1842# a_8997_1842# 0.0114f
C1244 a_22590_1044# a_22564_1008# 0.277f
C1245 a_13019_5831# DELAY_OUT_LAST 0.08017f
C1246 a_11748_6109# a_12158_5867# 0.10373f
C1247 a_5731_289# a_15964_289# 0.2778f
C1248 a_26151_2470# a_26043_1842# 0.01697f
C1249 a_12993_1842# a_13557_1842# 0.0114f
C1250 a_6425_1044# VDD 0.29722f
C1251 a_19833_1842# a_19963_1842# 0.70845f
C1252 a_1256_1044# MUX_SEL1 1.44243f
C1253 a_1544_1044# MUX_SEL0 0.07603f
C1254 a_26673_1842# a_26803_1842# 0.70845f
C1255 a_10951_2470# VDD 0.01806f
C1256 a_27433_1842# DELAY_VBIASP 0.11284f
C1257 a_27563_1842# DELAY_VBIASN 0.08029f
C1258 a_27997_1842# DELAY_OUT_LAST 0.70957f
C1259 a_14009_5084# a_13880_5118# 0.01562f
C1260 a_4350_1044# a_4763_1842# 0.01012f
C1261 a_5778_3367# DLL_RESETN 0.01215f
C1262 MUX_SEL0 MUX_SEL2 0.01204f
C1263 a_13306_6305# VDD 0.77573f
C1264 a_7477_1842# a_8237_1842# 0.01669f
C1265 a_20397_1842# DELAY_VBIASN 0.10669f
C1266 a_19203_1842# DELAY_VBIASP 0.06661f
C1267 a_10232_5871# a_10751_5878# 0.34102f
C1268 a_9757_1842# a_10517_1842# 0.06198f
C1269 a_10649_5878# a_10520_6292# 0.01562f
C1270 a_5731_289# a_8745_519# 0.28635f
C1271 a_12037_1842# a_12797_1842# 0.02912f
C1272 a_18877_1842# a_19203_1842# 0.01427f
C1273 a_4350_1044# a_6425_1044# 0.03208f
C1274 a_4871_2470# VDD 0.01806f
C1275 a_14009_5084# a_14111_5227# 0.47622f
C1276 a_7945_1044# a_7477_1842# 0.19203f
C1277 a_15304_4605# a_14851_5182# 0.05156f
C1278 a_13566_5328# a_13592_5423# 0.36952f
C1279 a_6717_1842# a_6283_1842# 0.6972f
C1280 a_12797_1842# DLL_RESETN 0.0106f
C1281 a_17683_1842# DELAY_VBIASN 0.07847f
C1282 a_17553_1842# DELAY_VBIASP 0.11284f
C1283 a_9323_1842# a_9431_1842# 0.01163f
C1284 a_12907_5420# a_13132_5420# 0.02416f
C1285 a_1256_289# MUX_SEL4 0.65005f
C1286 a_11277_1842# a_10843_1842# 0.6972f
C1287 a_24523_1842# a_24631_1842# 0.01163f
C1288 a_18117_1842# a_18313_1842# 0.77122f
C1289 a_23111_2470# VDD 0.01806f
C1290 a_26043_1842# VDD 0.4973f
C1291 a_25717_1842# a_25913_1842# 0.73897f
C1292 a_24957_1842# DELAY_VBIASN 0.10687f
C1293 a_23763_1842# DELAY_VBIASP 0.06661f
C1294 VDD DELAY_VBIASP 14.6649f
C1295 a_10232_5871# VDD 0.07206f
C1296 a_5393_1842# a_5957_1842# 0.0114f
C1297 a_13106_5357# DLL_RESETN 0.01263f
C1298 a_10430_1044# a_11848_1044# 0.38994f
C1299 a_18877_1842# VDD 0.87825f
C1300 a_15837_1842# DELAY_VBIASP 0.04182f
C1301 a_16033_1842# DELAY_VBIASN 0.10793f
C1302 a_19550_1044# a_19637_1842# 0.1088f
C1303 a_7803_1842# a_7911_1842# 0.01163f
C1304 a_9953_1842# a_10517_1842# 0.0114f
C1305 VDD a_11848_1044# 0.17499f
C1306 a_16793_1842# a_16923_1842# 0.70845f
C1307 a_17031_2470# VDD 0.01806f
C1308 a_24393_1842# a_24523_1842# 0.70845f
C1309 a_25153_1842# VDD 0.49426f
C1310 a_22243_1842# DELAY_VBIASN 0.08024f
C1311 a_22113_1842# DELAY_VBIASP 0.11286f
C1312 a_14111_5878# REF_CLK 0.02263f
C1313 a_4157_1313# a_2019_311# 0.01018f
C1314 a_20593_1842# a_20397_1842# 0.76914f
C1315 a_9712_3912# DELAY_VBIASN 0.22281f
C1316 a_16163_1842# VDD 0.4973f
C1317 a_14111_5878# a_15304_4605# 0.01811f
C1318 a_12849_5867# a_13592_5423# 0.38497f
C1319 VDD a_8884_1008# 0.28225f
C1320 a_14513_1842# DELAY_VBIASP 0.12091f
C1321 a_14643_1842# DELAY_VBIASN 0.08431f
C1322 a_15837_1842# a_16163_1842# 0.01427f
C1323 a_6126_3816# VDD 0.84141f
C1324 a_18877_1842# a_16108_289# 0.0157f
C1325 a_23437_1842# VDD 0.86909f
C1326 a_23437_1842# a_23763_1842# 0.01427f
C1327 a_20593_1842# DELAY_VBIASN 0.10398f
C1328 a_19448_1044# VDD 0.17274f
C1329 a_19550_1044# a_20315_1044# 0.39037f
C1330 a_5768_1044# VDD 0.17499f
C1331 a_7390_1044# a_9675_1044# 0.39036f
C1332 a_13557_1842# a_13470_1044# 0.1088f
C1333 a_4437_1842# VDD 0.86998f
C1334 a_15688_5403# DELAY_OUT_LAST 0.01699f
C1335 a_14009_5878# a_14757_6228# 0.01058f
C1336 a_13880_6292# a_14111_5878# 0.12701f
C1337 a_6326_4590# a_6854_5986# 1.31745f
C1338 a_24957_1842# a_25528_1044# 0.10864f
C1339 a_25604_1008# VDD 0.28633f
C1340 a_8237_1842# DELAY_VBIASP 0.0414f
C1341 a_8433_1842# DELAY_VBIASN 0.0961f
C1342 a_22590_1044# DELAY_VBIASN 0.02115f
C1343 a_12355_5867# DLL_RESETN 0.04879f
C1344 a_2019_311# MUX_OUT 8.45486f
C1345 VDD a_6635_1044# 0.15406f
C1346 a_12797_1842# DELAY_VBIASP 0.0414f
C1347 a_13444_1008# a_13368_1044# 0.01176f
C1348 a_12993_1842# DELAY_VBIASN 0.0961f
C1349 a_13121_5831# a_15688_5867# 0.17255f
C1350 a_12849_5867# a_14851_6228# 0.13392f
C1351 a_25630_1044# a_27915_1044# 0.39036f
C1352 a_22677_1842# a_22873_1842# 0.73897f
C1353 a_20723_1842# VDD 0.49671f
C1354 a_9712_3912# a_5974_5723# 0.01152f
C1355 a_5778_3367# a_6126_3816# 1.6143f
C1356 a_9444_3912# a_6854_5986# 0.01142f
C1357 a_5864_3367# a_6326_4590# 0.01889f
C1358 a_21483_1842# a_19550_1044# 0.01012f
C1359 a_16510_1044# VDD 0.8795f
C1360 a_13306_6305# a_13566_5835# 0.75507f
C1361 a_9757_1842# a_9751_1008# 0.02354f
C1362 a_26185_1044# VDD 0.30409f
C1363 a_11785_519# a_10430_1044# 0.02058f
C1364 a_4350_1044# a_5768_1044# 0.38994f
C1365 a_13592_5423# DELAY_OUT_LAST 0.08062f
C1366 REF_CLK MUX_SEL1 0.01858f
C1367 a_4437_1842# a_4350_1044# 0.1088f
C1368 a_24957_1842# a_22590_1044# 0.02479f
C1369 a_8563_1842# VDD 0.49671f
C1370 a_23355_1044# VDD 0.15389f
C1371 a_6717_1842# DELAY_VBIASN 0.09992f
C1372 a_5523_1842# DELAY_VBIASP 0.06627f
C1373 a_9444_3912# a_5864_3367# 0.02483f
C1374 a_11785_519# VDD 0.29292f
C1375 a_1721_331# MUX_SEL2 0.01315f
C1376 a_1544_289# MUX_SEL3 0.15976f
C1377 a_13123_1842# VDD 0.49727f
C1378 a_11277_1842# DELAY_VBIASN 0.09974f
C1379 a_10083_1842# DELAY_VBIASP 0.06627f
C1380 a_13121_5831# a_14009_5878# 0.01604f
C1381 a_12849_5867# a_13592_5871# 0.38817f
C1382 a_10985_1044# a_11195_1044# 0.09424f
C1383 a_4350_1044# a_6635_1044# 0.39036f
C1384 a_21353_1842# a_21483_1842# 0.70845f
C1385 a_13444_1008# VDD 0.28633f
C1386 a_12656_5864# a_12849_5867# 0.33075f
C1387 a_12355_5867# a_13306_6305# 0.26489f
C1388 a_13019_5831# a_13121_5831# 0.56469f
C1389 a_16510_1044# a_17928_1044# 0.38994f
C1390 a_8237_1842# a_8884_1008# 0.02312f
C1391 a_14025_1044# VDD 0.30409f
C1392 a_4157_1313# MUX_SEL4 0.08229f
C1393 a_22677_1842# a_22564_1008# 0.05157f
C1394 a_6913_1842# VDD 0.49426f
C1395 a_19550_1044# a_21835_1044# 0.39036f
C1396 a_13566_5328# VDD 0.0947f
C1397 a_24665_1044# a_24951_1008# 0.01885f
C1398 a_16510_1044# a_16108_289# 0.56108f
C1399 a_11473_1842# VDD 0.49417f
C1400 a_9193_1842# a_9323_1842# 0.70845f
C1401 a_13592_5423# a_6854_5986# 0.01958f
C1402 a_7477_1842# a_7390_1044# 0.1088f
C1403 a_21157_1842# a_21625_1044# 0.2079f
C1404 a_17065_1044# a_17275_1044# 0.09424f
C1405 a_13753_1842# a_13883_1842# 0.70845f
C1406 a_2873_1395# MUX_SEL0 0.01504f
C1407 a_27997_1842# a_27563_1842# 0.69646f
C1408 a_5197_1842# VDD 0.86909f
C1409 a_14851_5182# a_14757_5182# 0.28931f
C1410 a_1544_289# VDD 0.39113f
C1411 a_23145_1044# a_22590_1044# 0.03209f
C1412 a_5844_1008# a_5957_1842# 0.02055f
C1413 a_14311_1008# a_14317_1842# 0.02349f
R0 VDD.n129 VDD.t34 17.3693
R1 VDD.n118 VDD.t244 17.3693
R2 VDD.n118 VDD.t203 17.3693
R3 VDD.n130 VDD.t342 17.3517
R4 VDD.n121 VDD.t248 17.3517
R5 VDD.n120 VDD.t389 17.3517
R6 VDD.n72 VDD.t254 17.2438
R7 VDD.n124 VDD.t37 17.2247
R8 VDD.n130 VDD.t174 17.0005
R9 VDD.n121 VDD.t189 17.0005
R10 VDD.n120 VDD.t173 17.0005
R11 VDD.t0 VDD.n99 4.19382
R12 VDD.n42 VDD.n43 0.189847
R13 VDD.n95 VDD.n94 0.149987
R14 VDD.t0 VDD.n94 2.39616
R15 VDD.n91 VDD.n53 0.149987
R16 VDD.n91 VDD.t0 2.39616
R17 VDD.n96 VDD.n88 0.149987
R18 VDD.t0 VDD.n88 2.39616
R19 VDD.n83 VDD.n50 0.149987
R20 VDD.n83 VDD.t0 2.39616
R21 VDD.n97 VDD.n80 0.149987
R22 VDD.t0 VDD.n80 2.39616
R23 VDD.n76 VDD.n47 0.149987
R24 VDD.t0 VDD.n76 2.39616
R25 VDD.t38 VDD.n37 2.05485
R26 VDD.n34 VDD.n65 0.448571
R27 VDD.n36 VDD.t108 15.1333
R28 VDD.n388 VDD.t111 15.0005
R29 VDD.n1 VDD.t106 15.0005
R30 VDD.n64 VDD.t93 15.0005
R31 VDD.n39 VDD.t98 15.0005
R32 VDD.n67 VDD.t285 17.9449
R33 VDD.n393 VDD.n392 9.51422
R34 VDD.n392 VDD.n391 9.17119
R35 VDD.n68 VDD.n67 0.341666
R36 VDD.n395 VDD.t179 9.02285
R37 VDD.n73 VDD.n74 0.0615821
R38 VDD.n115 VDD.n28 4.47071
R39 VDD.n114 VDD.t186 8.95516
R40 VDD.n148 VDD.t44 8.76154
R41 VDD.n12 VDD.t256 8.76154
R42 VDD.n12 VDD.t327 8.76154
R43 VDD.n12 VDD.t331 8.76154
R44 VDD.n11 VDD.t137 8.76154
R45 VDD.n149 VDD.t43 8.76154
R46 VDD.n44 VDD.t326 8.76154
R47 VDD.n150 VDD.t138 8.76154
R48 VDD.n72 VDD.t255 8.76154
R49 VDD.n108 VDD.t262 8.76054
R50 VDD.n108 VDD.t28 8.76054
R51 VDD.n148 VDD.t338 8.76054
R52 VDD.n12 VDD.t157 8.76054
R53 VDD.n12 VDD.t333 8.76054
R54 VDD.n12 VDD.t158 8.76054
R55 VDD.n11 VDD.t322 8.76054
R56 VDD.n149 VDD.t339 8.76054
R57 VDD.n44 VDD.t332 8.76054
R58 VDD.n150 VDD.t152 8.76054
R59 VDD.n94 VDD.n93 0.0442395
R60 VDD.n90 VDD.n91 0.0442395
R61 VDD.n88 VDD.n87 0.0442395
R62 VDD.n82 VDD.n83 0.0442395
R63 VDD.n80 VDD.n79 0.0442395
R64 VDD.n77 VDD.n76 0.0442395
R65 VDD VDD.t13 8.47732
R66 VDD.n46 VDD.n45 0.0953067
R67 VDD.t0 VDD.n46 4.19225
R68 VDD.t0 VDD.n41 3.34459
R69 VDD.n15 VDD.t0 0.28229
R70 VDD.t0 VDD.n9 0.793108
R71 VDD.t0 VDD.n18 1.13836
R72 VDD.n8 VDD.t0 0.793108
R73 VDD.n20 VDD.t0 1.13836
R74 VDD.t0 VDD.n6 0.793108
R75 VDD.t0 VDD.n21 0.315451
R76 VDD.n5 VDD.t0 0.793108
R77 VDD.n24 VDD.t0 1.13836
R78 VDD.t0 VDD.n3 0.793108
R79 VDD.t0 VDD.n26 1.13836
R80 VDD.t0 VDD.n10 0.793077
R81 VDD.t7 VDD.n56 4.20922
R82 VDD.t7 VDD.n60 4.20922
R83 VDD.t38 VDD.n57 1.61947
R84 VDD.t38 VDD.n34 0.894484
R85 VDD.t38 VDD.n73 8.47732
R86 VDD.n10 VDD.t409 7.62628
R87 VDD.n75 VDD.t408 7.62628
R88 VDD.n26 VDD.t407 7.62628
R89 VDD.n3 VDD.t406 7.62628
R90 VDD.n78 VDD.t405 7.62628
R91 VDD.n24 VDD.t404 7.62628
R92 VDD.n5 VDD.t403 7.62628
R93 VDD.n81 VDD.t402 7.62628
R94 VDD.n22 VDD.t401 7.62628
R95 VDD.n6 VDD.t400 7.62628
R96 VDD.n86 VDD.t399 7.62628
R97 VDD.n20 VDD.t398 7.62628
R98 VDD.n8 VDD.t397 7.62628
R99 VDD.n89 VDD.t396 7.62628
R100 VDD.n18 VDD.t395 7.62628
R101 VDD.n9 VDD.t394 7.62628
R102 VDD.n92 VDD.t393 7.62628
R103 VDD.n16 VDD.t392 7.62628
R104 VDD.n1 VDD.n30 3.11859
R105 VDD.n197 VDD.t41 6.09923
R106 VDD.n203 VDD.t375 6.09923
R107 VDD.n209 VDD.t8 6.09923
R108 VDD.n215 VDD.t208 6.09923
R109 VDD.n221 VDD.t205 6.09923
R110 VDD.n227 VDD.t188 6.09923
R111 VDD.n233 VDD.t282 6.09923
R112 VDD.n239 VDD.t127 6.09923
R113 VDD.n245 VDD.t123 6.09923
R114 VDD.n251 VDD.t253 6.09923
R115 VDD.n257 VDD.t142 6.09923
R116 VDD.n263 VDD.t31 6.09923
R117 VDD.n269 VDD.t144 6.09923
R118 VDD.n275 VDD.t78 6.09923
R119 VDD.n281 VDD.t352 6.09923
R120 VDD.n287 VDD.t9 6.09923
R121 VDD.n293 VDD.t228 6.09923
R122 VDD.n299 VDD.t270 6.09923
R123 VDD.n305 VDD.t17 6.09923
R124 VDD.n311 VDD.t181 6.09923
R125 VDD.n317 VDD.t148 6.09923
R126 VDD.n323 VDD.t241 6.09923
R127 VDD.n329 VDD.t180 6.09923
R128 VDD.n335 VDD.t145 6.09923
R129 VDD.n341 VDD.t10 6.09923
R130 VDD.n347 VDD.t166 6.09923
R131 VDD.n353 VDD.t80 6.09923
R132 VDD.n359 VDD.t42 6.09923
R133 VDD.n365 VDD.t19 6.09923
R134 VDD.n371 VDD.t280 6.09923
R135 VDD.n377 VDD.t149 6.09923
R136 VDD.n383 VDD.t154 6.09923
R137 VDD.n26 VDD.t12 5.99122
R138 VDD.n24 VDD.t122 5.99122
R139 VDD.n22 VDD.t63 5.99122
R140 VDD.n20 VDD.t25 5.99122
R141 VDD.n18 VDD.t81 5.99122
R142 VDD.n16 VDD.t18 5.99122
R143 VDD.n100 VDD.t136 5.98905
R144 VDD.n128 VDD.t250 5.9886
R145 VDD.n106 VDD.t264 5.97675
R146 VDD.n106 VDD.t30 5.97675
R147 VDD.n12 VDD.t257 5.97212
R148 VDD.n12 VDD.t373 5.97212
R149 VDD.n45 VDD.t156 5.97212
R150 VDD.n151 VDD.t171 5.97212
R151 VDD.n12 VDD.t177 5.97169
R152 VDD.n12 VDD.t223 5.97169
R153 VDD.n45 VDD.t346 5.97169
R154 VDD.n151 VDD.t153 5.97169
R155 VDD.n10 VDD.t258 5.97001
R156 VDD.n10 VDD.t364 5.97001
R157 VDD.n10 VDD.t168 5.97001
R158 VDD.n48 VDD.t198 5.97001
R159 VDD.n47 VDD.t197 5.97001
R160 VDD.n3 VDD.t221 5.97001
R161 VDD.n26 VDD.t201 5.97001
R162 VDD.n3 VDD.t267 5.97001
R163 VDD.n3 VDD.t220 5.97001
R164 VDD.n49 VDD.t358 5.97001
R165 VDD.n97 VDD.t357 5.97001
R166 VDD.n5 VDD.t178 5.97001
R167 VDD.n24 VDD.t361 5.97001
R168 VDD.n5 VDD.t20 5.97001
R169 VDD.n5 VDD.t164 5.97001
R170 VDD.n51 VDD.t192 5.97001
R171 VDD.n50 VDD.t191 5.97001
R172 VDD.n6 VDD.t22 5.97001
R173 VDD.n22 VDD.t195 5.97001
R174 VDD.n6 VDD.t27 5.97001
R175 VDD.n6 VDD.t36 5.97001
R176 VDD.n52 VDD.t3 5.97001
R177 VDD.n96 VDD.t2 5.97001
R178 VDD.n8 VDD.t69 5.97001
R179 VDD.n20 VDD.t6 5.97001
R180 VDD.n8 VDD.t187 5.97001
R181 VDD.n8 VDD.t279 5.97001
R182 VDD.n54 VDD.t118 5.97001
R183 VDD.n53 VDD.t117 5.97001
R184 VDD.n9 VDD.t217 5.97001
R185 VDD.n18 VDD.t121 5.97001
R186 VDD.n9 VDD.t64 5.97001
R187 VDD.n9 VDD.t355 5.97001
R188 VDD.n55 VDD.t231 5.97001
R189 VDD.n95 VDD.t230 5.97001
R190 VDD.n16 VDD.t234 5.97001
R191 VDD.n32 VDD.t251 5.96578
R192 VDD.n42 VDD.t325 5.96578
R193 VDD.n146 VDD.t139 5.96578
R194 VDD.n25 VDD.t71 5.96578
R195 VDD.n23 VDD.t379 5.96578
R196 VDD.n33 VDD.t252 5.96578
R197 VDD.n85 VDD.t141 5.96578
R198 VDD.n27 VDD.t16 5.96578
R199 VDD.n19 VDD.t72 5.96578
R200 VDD.n17 VDD.t133 5.96578
R201 VDD.n14 VDD.t79 5.96578
R202 VDD.n42 VDD.t334 5.96534
R203 VDD.n146 VDD.t321 5.96534
R204 VDD.n100 VDD.t224 5.96534
R205 VDD.n144 VDD.t207 5.96534
R206 VDD.n142 VDD.t40 5.96534
R207 VDD.n153 VDD.t235 5.96534
R208 VDD.n31 VDD.t384 5.96534
R209 VDD.n32 VDD.t76 5.96534
R210 VDD.n10 VDD.t272 5.96534
R211 VDD.n10 VDD.t214 5.96534
R212 VDD.n101 VDD.t348 5.96534
R213 VDD.n47 VDD.t380 5.96534
R214 VDD.n26 VDD.t75 5.96534
R215 VDD.n26 VDD.t276 5.96534
R216 VDD.n25 VDD.t368 5.96534
R217 VDD.n3 VDD.t24 5.96534
R218 VDD.n3 VDD.t140 5.96534
R219 VDD.n102 VDD.t209 5.96534
R220 VDD.n97 VDD.t11 5.96534
R221 VDD.n24 VDD.t39 5.96534
R222 VDD.n24 VDD.t328 5.96534
R223 VDD.n23 VDD.t236 5.96534
R224 VDD.n5 VDD.t143 5.96534
R225 VDD.n5 VDD.t46 5.96534
R226 VDD.n4 VDD.t32 5.96534
R227 VDD.n50 VDD.t265 5.96534
R228 VDD.n22 VDD.t390 5.96534
R229 VDD.n22 VDD.t341 5.96534
R230 VDD.n27 VDD.t128 5.96534
R231 VDD.n27 VDD.t351 5.96534
R232 VDD.n161 VDD.t68 5.96534
R233 VDD.n85 VDD.t215 5.96534
R234 VDD.n159 VDD.t15 5.96534
R235 VDD.n72 VDD.t26 5.96534
R236 VDD.n157 VDD.t74 5.96534
R237 VDD.n155 VDD.t269 5.96534
R238 VDD.n33 VDD.t367 5.96534
R239 VDD.n6 VDD.t146 5.96534
R240 VDD.n6 VDD.t319 5.96534
R241 VDD.n103 VDD.t323 5.96534
R242 VDD.n96 VDD.t77 5.96534
R243 VDD.n20 VDD.t115 5.96534
R244 VDD.n20 VDD.t240 5.96534
R245 VDD.n19 VDD.t387 5.96534
R246 VDD.n8 VDD.t175 5.96534
R247 VDD.n8 VDD.t67 5.96534
R248 VDD.n7 VDD.t283 5.96534
R249 VDD.n53 VDD.t266 5.96534
R250 VDD.n18 VDD.t391 5.96534
R251 VDD.n18 VDD.t165 5.96534
R252 VDD.n17 VDD.t129 5.96534
R253 VDD.n9 VDD.t273 5.96534
R254 VDD.n9 VDD.t371 5.96534
R255 VDD.n104 VDD.t212 5.96534
R256 VDD.n95 VDD.t132 5.96534
R257 VDD.n16 VDD.t237 5.96534
R258 VDD.n16 VDD.t365 5.96534
R259 VDD.n14 VDD.t114 5.96534
R260 VDD.n14 VDD.t150 5.96534
R261 VDD.n126 VDD.t183 5.96478
R262 VDD.n10 VDD.t167 5.65005
R263 VDD.n75 VDD.t196 5.65005
R264 VDD.n26 VDD.t199 5.65005
R265 VDD.n3 VDD.t219 5.65005
R266 VDD.n78 VDD.t268 5.65005
R267 VDD.n24 VDD.t359 5.65005
R268 VDD.n5 VDD.t163 5.65005
R269 VDD.n81 VDD.t21 5.65005
R270 VDD.n22 VDD.t193 5.65005
R271 VDD.n6 VDD.t23 5.65005
R272 VDD.n86 VDD.t1 5.65005
R273 VDD.n20 VDD.t4 5.65005
R274 VDD.n8 VDD.t70 5.65005
R275 VDD.n89 VDD.t116 5.65005
R276 VDD.n18 VDD.t119 5.65005
R277 VDD.n9 VDD.t218 5.65005
R278 VDD.n92 VDD.t65 5.65005
R279 VDD.n16 VDD.t232 5.65005
R280 VDD.t13 VDD.n394 5.62581
R281 VDD.t13 VDD.n396 5.62581
R282 VDD.t0 VDD.n154 5.62581
R283 VDD.t0 VDD.n152 5.62581
R284 VDD.t0 VDD.n145 5.62581
R285 VDD.n41 VDD.n149 0.160419
R286 VDD.t0 VDD.n13 1.07426
R287 VDD.n156 VDD.t0 5.62581
R288 VDD.n71 VDD.t0 1.79705
R289 VDD.n158 VDD.t0 5.62581
R290 VDD.n160 VDD.t0 5.62581
R291 VDD.t7 VDD.n196 5.62581
R292 VDD.t7 VDD.n202 5.62581
R293 VDD.t7 VDD.n208 5.62581
R294 VDD.t7 VDD.n214 5.62581
R295 VDD.t7 VDD.n220 5.62581
R296 VDD.t7 VDD.n226 5.62581
R297 VDD.t7 VDD.n232 5.62581
R298 VDD.t7 VDD.n238 5.62581
R299 VDD.t7 VDD.n244 5.62581
R300 VDD.t7 VDD.n250 5.62581
R301 VDD.t7 VDD.n256 5.62581
R302 VDD.t7 VDD.n262 5.62581
R303 VDD.t7 VDD.n268 5.62581
R304 VDD.t7 VDD.n274 5.62581
R305 VDD.t7 VDD.n280 5.62581
R306 VDD.t7 VDD.n286 5.62581
R307 VDD.t7 VDD.n292 5.62581
R308 VDD.t7 VDD.n298 5.62581
R309 VDD.t7 VDD.n304 5.62581
R310 VDD.t7 VDD.n310 5.62581
R311 VDD.t7 VDD.n316 5.62581
R312 VDD.t7 VDD.n322 5.62581
R313 VDD.t7 VDD.n328 5.62581
R314 VDD.t7 VDD.n334 5.62581
R315 VDD.t7 VDD.n340 5.62581
R316 VDD.t7 VDD.n346 5.62581
R317 VDD.t7 VDD.n352 5.62581
R318 VDD.t7 VDD.n358 5.62581
R319 VDD.t7 VDD.n364 5.62581
R320 VDD.t7 VDD.n370 5.62581
R321 VDD.t7 VDD.n376 5.62581
R322 VDD.t7 VDD.n382 5.62581
R323 VDD.t7 VDD.n384 5.62581
R324 VDD.t14 VDD.n123 5.61485
R325 VDD.t14 VDD.n127 5.61485
R326 VDD.n0 VDD.t104 5.7457
R327 VDD.n110 VDD.t94 5.60969
R328 VDD.n111 VDD.t99 5.60969
R329 VDD.n1 VDD.t107 5.71623
R330 VDD.n387 VDD.t113 5.60347
R331 VDD.n61 VDD.t110 5.60347
R332 VDD.n28 VDD.t97 5.60347
R333 VDD.n113 VDD.t102 5.60347
R334 VDD.n194 VDD.t290 5.59675
R335 VDD.n200 VDD.t297 5.59675
R336 VDD.n206 VDD.t299 5.59675
R337 VDD.n212 VDD.t301 5.59675
R338 VDD.n218 VDD.t303 5.59675
R339 VDD.n224 VDD.t302 5.59675
R340 VDD.n230 VDD.t304 5.59675
R341 VDD.n236 VDD.t305 5.59675
R342 VDD.n242 VDD.t293 5.59675
R343 VDD.n248 VDD.t307 5.59675
R344 VDD.n254 VDD.t309 5.59675
R345 VDD.n260 VDD.t306 5.59675
R346 VDD.n266 VDD.t308 5.59675
R347 VDD.n272 VDD.t286 5.59675
R348 VDD.n278 VDD.t300 5.59675
R349 VDD.n284 VDD.t296 5.59675
R350 VDD.n290 VDD.t292 5.59675
R351 VDD.n296 VDD.t288 5.59675
R352 VDD.n302 VDD.t310 5.59675
R353 VDD.n308 VDD.t311 5.59675
R354 VDD.n314 VDD.t295 5.59675
R355 VDD.n320 VDD.t312 5.59675
R356 VDD.n326 VDD.t294 5.59675
R357 VDD.n332 VDD.t291 5.59675
R358 VDD.n338 VDD.t314 5.59675
R359 VDD.n344 VDD.t287 5.59675
R360 VDD.n350 VDD.t289 5.59675
R361 VDD.n356 VDD.t315 5.59675
R362 VDD.n362 VDD.t313 5.59675
R363 VDD.n368 VDD.t316 5.59675
R364 VDD.n374 VDD.t317 5.59675
R365 VDD.n380 VDD.t318 5.59675
R366 VDD.n385 VDD.t109 5.59675
R367 VDD.n38 VDD.t298 5.59675
R368 VDD.n28 VDD.t95 5.59179
R369 VDD.n112 VDD.t100 5.59179
R370 VDD.n1 VDD.t105 5.59179
R371 VDD.n433 VDD.t85 4.9462
R372 VDD.n405 VDD.t82 4.9462
R373 VDD.n116 VDD.n115 4.90372
R374 VDD.t0 VDD.n147 4.19244
R375 VDD.t0 VDD.n43 3.32638
R376 VDD.t13 VDD.n135 4.19238
R377 VDD.n57 VDD.n28 0.406014
R378 VDD.n37 VDD.n74 0.379679
R379 VDD.t13 VDD.n397 4.19225
R380 VDD.t13 VDD.n425 4.19225
R381 VDD.t13 VDD.n140 4.19225
R382 VDD VDD.t14 1.47683
R383 VDD.t0 VDD.n98 3.3265
R384 VDD.n157 VDD.n71 0.341
R385 VDD.n84 VDD.t0 3.3265
R386 VDD.t14 VDD.n125 3.31208
R387 VDD.t14 VDD.n117 3.30706
R388 VDD.t14 VDD.n119 3.30688
R389 VDD.t14 VDD.n132 3.30688
R390 VDD VDD.n42 3.24291
R391 VDD.t14 VDD.n107 2.7751
R392 VDD.t0 VDD.n141 2.74446
R393 VDD.t0 VDD.n143 2.74446
R394 VDD.n15 VDD.n14 0.2867
R395 VDD.n161 VDD.n27 0.44578
R396 VDD.n27 VDD.n21 0.309939
R397 VDD.t13 VDD.n134 2.74414
R398 VDD.t7 VDD.n35 2.74414
R399 VDD.n2 VDD.n195 0.527966
R400 VDD.n435 VDD.t87 2.69937
R401 VDD.n403 VDD.t90 2.69937
R402 VDD.n401 VDD.t84 2.69937
R403 VDD.n427 VDD.t92 2.69937
R404 VDD.n431 VDD.t62 2.6992
R405 VDD.n429 VDD.t54 2.6992
R406 VDD.n399 VDD.t55 2.6992
R407 VDD.n407 VDD.t47 2.6992
R408 VDD.n412 VDD.t48 2.6992
R409 VDD.n411 VDD.t56 2.6992
R410 VDD.n417 VDD.t50 2.6992
R411 VDD.n416 VDD.t58 2.6992
R412 VDD.n422 VDD.t52 2.6992
R413 VDD.n421 VDD.t60 2.6992
R414 VDD.t13 VDD.n70 2.33382
R415 VDD.t13 VDD.n138 2.32439
R416 VDD.t7 VDD.n234 2.32439
R417 VDD.t7 VDD.n330 2.32439
R418 VDD.t7 VDD.n372 2.32439
R419 VDD.t7 VDD.n378 2.32439
R420 VDD.t13 VDD.n409 2.32432
R421 VDD.t7 VDD.n198 2.32432
R422 VDD.t7 VDD.n210 2.32432
R423 VDD.t7 VDD.n276 2.32432
R424 VDD.t7 VDD.n216 2.32425
R425 VDD.t7 VDD.n222 2.32425
R426 VDD.t7 VDD.n258 2.32425
R427 VDD.t7 VDD.n264 2.32425
R428 VDD.t7 VDD.n300 2.32425
R429 VDD.t7 VDD.n306 2.3242
R430 VDD.t13 VDD.n419 2.32417
R431 VDD.t13 VDD.n424 2.32417
R432 VDD.t7 VDD.n312 2.32417
R433 VDD.t7 VDD.n324 2.32417
R434 VDD.t7 VDD.n336 2.32417
R435 VDD.t7 VDD.n342 2.32417
R436 VDD.t7 VDD.n348 2.32417
R437 VDD.t7 VDD.n360 2.32417
R438 VDD.t13 VDD.n139 2.32417
R439 VDD.t13 VDD.n136 2.32417
R440 VDD.t38 VDD.n68 0.570319
R441 VDD.t7 VDD.n246 2.32417
R442 VDD.t7 VDD.n252 2.32417
R443 VDD.t7 VDD.n294 2.32417
R444 VDD.t7 VDD.n318 2.32417
R445 VDD.t7 VDD.n204 2.32414
R446 VDD.t7 VDD.n240 2.32414
R447 VDD.t7 VDD.n270 2.32414
R448 VDD.t7 VDD.n282 2.32414
R449 VDD.t7 VDD.n354 2.32414
R450 VDD.t7 VDD.n366 2.32414
R451 VDD.t7 VDD.n288 2.32407
R452 VDD.t7 VDD.n228 2.32406
R453 VDD.n14 VDD.t45 6.35403
R454 VDD.t13 VDD.n137 2.0061
R455 VDD.t13 VDD.n414 2.00599
R456 VDD.t13 VDD.n437 1.75938
R457 VDD.t7 VDD.n390 1.56886
R458 VDD.t7 VDD.n163 1.55381
R459 VDD.t7 VDD.n164 1.55381
R460 VDD.t7 VDD.n168 1.55381
R461 VDD.t7 VDD.n169 1.55381
R462 VDD.t7 VDD.n170 1.55381
R463 VDD.t7 VDD.n173 1.55381
R464 VDD.t7 VDD.n174 1.55381
R465 VDD.t7 VDD.n175 1.55381
R466 VDD.t7 VDD.n177 1.55381
R467 VDD.t7 VDD.n178 1.55381
R468 VDD.t7 VDD.n179 1.55381
R469 VDD.t7 VDD.n180 1.55381
R470 VDD.t7 VDD.n181 1.55381
R471 VDD.t7 VDD.n184 1.55381
R472 VDD.t7 VDD.n185 1.55381
R473 VDD.t7 VDD.n187 1.55381
R474 VDD.t7 VDD.n188 1.55381
R475 VDD.t7 VDD.n189 1.55381
R476 VDD.t7 VDD.n190 1.55381
R477 VDD.t7 VDD.n192 1.55381
R478 VDD.t7 VDD.n162 1.55341
R479 VDD.t7 VDD.n165 1.55341
R480 VDD.t7 VDD.n166 1.55341
R481 VDD.t7 VDD.n167 1.55341
R482 VDD.t7 VDD.n171 1.55341
R483 VDD.t7 VDD.n172 1.55341
R484 VDD.t7 VDD.n176 1.55341
R485 VDD.t7 VDD.n182 1.55341
R486 VDD.t7 VDD.n183 1.55341
R487 VDD.t7 VDD.n186 1.55341
R488 VDD.t7 VDD.n191 1.55341
R489 VDD.t14 VDD.n109 1.20461
R490 VDD.n68 VDD.n114 0.779651
R491 VDD.n412 VDD.n411 1.11007
R492 VDD.n417 VDD.n416 1.11007
R493 VDD.n422 VDD.n421 1.11007
R494 VDD.t13 VDD.n133 1.01949
R495 VDD.n129 VDD.n105 0.975304
R496 VDD.n105 VDD.n128 0.817678
R497 VDD.n392 VDD.n30 0.808112
R498 VDD.n116 VDD.n109 0.671512
R499 VDD.n109 VDD.n108 0.6645
R500 VDD.n393 VDD.n133 0.633311
R501 VDD.n391 VDD.n133 0.617798
R502 VDD.n436 VDD.n435 0.570444
R503 VDD.n401 VDD.n400 0.570444
R504 VDD.n429 VDD.n428 0.570274
R505 VDD.n408 VDD.n407 0.570274
R506 VDD.n413 VDD.n412 0.570274
R507 VDD.n418 VDD.n417 0.570274
R508 VDD.n423 VDD.n422 0.570274
R509 VDD.n431 VDD.n430 0.569912
R510 VDD.n399 VDD.n398 0.569912
R511 VDD.n411 VDD.n410 0.569912
R512 VDD.n416 VDD.n415 0.569912
R513 VDD.n421 VDD.n420 0.569912
R514 VDD.n403 VDD.n402 0.569733
R515 VDD.n427 VDD.n426 0.569733
R516 VDD.n29 VDD.n28 0.183807
R517 VDD.n112 VDD.n40 0.508375
R518 VDD.t14 VDD.n105 0.49685
R519 VDD.n194 VDD.n193 0.495398
R520 VDD.n200 VDD.n199 0.495398
R521 VDD.n206 VDD.n205 0.495398
R522 VDD.n212 VDD.n211 0.495398
R523 VDD.n218 VDD.n217 0.495398
R524 VDD.n224 VDD.n223 0.495398
R525 VDD.n230 VDD.n229 0.495398
R526 VDD.n236 VDD.n235 0.495398
R527 VDD.n242 VDD.n241 0.495398
R528 VDD.n248 VDD.n247 0.495398
R529 VDD.n254 VDD.n253 0.495398
R530 VDD.n260 VDD.n259 0.495398
R531 VDD.n266 VDD.n265 0.495398
R532 VDD.n272 VDD.n271 0.495398
R533 VDD.n278 VDD.n277 0.495398
R534 VDD.n284 VDD.n283 0.495398
R535 VDD.n290 VDD.n289 0.495398
R536 VDD.n296 VDD.n295 0.495398
R537 VDD.n302 VDD.n301 0.495398
R538 VDD.n308 VDD.n307 0.495398
R539 VDD.n314 VDD.n313 0.495398
R540 VDD.n320 VDD.n319 0.495398
R541 VDD.n326 VDD.n325 0.495398
R542 VDD.n332 VDD.n331 0.495398
R543 VDD.n338 VDD.n337 0.495398
R544 VDD.n344 VDD.n343 0.495398
R545 VDD.n350 VDD.n349 0.495398
R546 VDD.n356 VDD.n355 0.495398
R547 VDD.n362 VDD.n361 0.495398
R548 VDD.n368 VDD.n367 0.495398
R549 VDD.n374 VDD.n373 0.495398
R550 VDD.n380 VDD.n379 0.495398
R551 VDD.n385 VDD.n36 0.495398
R552 VDD.n38 VDD.n58 0.495398
R553 VDD.n404 VDD.n403 0.492175
R554 VDD.n434 VDD.n427 0.492175
R555 VDD.n432 VDD.n431 0.492005
R556 VDD.n406 VDD.n399 0.492005
R557 VDD.n432 VDD.n429 0.491643
R558 VDD.n407 VDD.n406 0.491643
R559 VDD.n435 VDD.n434 0.491464
R560 VDD.n404 VDD.n401 0.491464
R561 VDD.n195 VDD.n194 0.478641
R562 VDD.n201 VDD.n200 0.478641
R563 VDD.n207 VDD.n206 0.478641
R564 VDD.n213 VDD.n212 0.478641
R565 VDD.n219 VDD.n218 0.478641
R566 VDD.n225 VDD.n224 0.478641
R567 VDD.n231 VDD.n230 0.478641
R568 VDD.n237 VDD.n236 0.478641
R569 VDD.n243 VDD.n242 0.478641
R570 VDD.n249 VDD.n248 0.478641
R571 VDD.n255 VDD.n254 0.478641
R572 VDD.n261 VDD.n260 0.478641
R573 VDD.n267 VDD.n266 0.478641
R574 VDD.n273 VDD.n272 0.478641
R575 VDD.n279 VDD.n278 0.478641
R576 VDD.n285 VDD.n284 0.478641
R577 VDD.n291 VDD.n290 0.478641
R578 VDD.n297 VDD.n296 0.478641
R579 VDD.n303 VDD.n302 0.478641
R580 VDD.n309 VDD.n308 0.478641
R581 VDD.n315 VDD.n314 0.478641
R582 VDD.n321 VDD.n320 0.478641
R583 VDD.n327 VDD.n326 0.478641
R584 VDD.n333 VDD.n332 0.478641
R585 VDD.n339 VDD.n338 0.478641
R586 VDD.n345 VDD.n344 0.478641
R587 VDD.n351 VDD.n350 0.478641
R588 VDD.n357 VDD.n356 0.478641
R589 VDD.n363 VDD.n362 0.478641
R590 VDD.n369 VDD.n368 0.478641
R591 VDD.n375 VDD.n374 0.478641
R592 VDD.n381 VDD.n380 0.478641
R593 VDD.n59 VDD.n385 0.478641
R594 VDD.n40 VDD.n38 0.478641
R595 VDD.n193 VDD.n192 0.467341
R596 VDD.n205 VDD.n190 0.467341
R597 VDD.n211 VDD.n189 0.467341
R598 VDD.n217 VDD.n188 0.467341
R599 VDD.n223 VDD.n187 0.467341
R600 VDD.n235 VDD.n185 0.467341
R601 VDD.n241 VDD.n184 0.467341
R602 VDD.n259 VDD.n181 0.467341
R603 VDD.n265 VDD.n180 0.467341
R604 VDD.n271 VDD.n179 0.467341
R605 VDD.n277 VDD.n178 0.467341
R606 VDD.n283 VDD.n177 0.467341
R607 VDD.n295 VDD.n175 0.467341
R608 VDD.n301 VDD.n174 0.467341
R609 VDD.n307 VDD.n173 0.467341
R610 VDD.n325 VDD.n170 0.467341
R611 VDD.n331 VDD.n169 0.467341
R612 VDD.n337 VDD.n168 0.467341
R613 VDD.n361 VDD.n164 0.467341
R614 VDD.n367 VDD.n163 0.467341
R615 VDD.n199 VDD.n191 0.466909
R616 VDD.n229 VDD.n186 0.466909
R617 VDD.n247 VDD.n183 0.466909
R618 VDD.n253 VDD.n182 0.466909
R619 VDD.n289 VDD.n176 0.466909
R620 VDD.n313 VDD.n172 0.466909
R621 VDD.n319 VDD.n171 0.466909
R622 VDD.n343 VDD.n167 0.466909
R623 VDD.n349 VDD.n166 0.466909
R624 VDD.n355 VDD.n165 0.466909
R625 VDD.n373 VDD.n162 0.466909
R626 VDD.n205 VDD.n191 0.451022
R627 VDD.n235 VDD.n186 0.451022
R628 VDD.n253 VDD.n183 0.451022
R629 VDD.n259 VDD.n182 0.451022
R630 VDD.n295 VDD.n176 0.451022
R631 VDD.n319 VDD.n172 0.451022
R632 VDD.n325 VDD.n171 0.451022
R633 VDD.n349 VDD.n167 0.451022
R634 VDD.n355 VDD.n166 0.451022
R635 VDD.n361 VDD.n165 0.451022
R636 VDD.n379 VDD.n162 0.451022
R637 VDD.n199 VDD.n192 0.450618
R638 VDD.n211 VDD.n190 0.450618
R639 VDD.n217 VDD.n189 0.450618
R640 VDD.n223 VDD.n188 0.450618
R641 VDD.n229 VDD.n187 0.450618
R642 VDD.n241 VDD.n185 0.450618
R643 VDD.n247 VDD.n184 0.450618
R644 VDD.n265 VDD.n181 0.450618
R645 VDD.n271 VDD.n180 0.450618
R646 VDD.n277 VDD.n179 0.450618
R647 VDD.n283 VDD.n178 0.450618
R648 VDD.n289 VDD.n177 0.450618
R649 VDD.n301 VDD.n175 0.450618
R650 VDD.n307 VDD.n174 0.450618
R651 VDD.n313 VDD.n173 0.450618
R652 VDD.n331 VDD.n170 0.450618
R653 VDD.n337 VDD.n169 0.450618
R654 VDD.n343 VDD.n168 0.450618
R655 VDD.n367 VDD.n164 0.450618
R656 VDD.n373 VDD.n163 0.450618
R657 VDD.n61 VDD.n56 0.445771
R658 VDD.n437 VDD.n436 0.43335
R659 VDD.n73 VDD.n29 0.0930507
R660 VDD.n66 VDD.n113 0.429929
R661 VDD.n390 VDD.n389 0.429766
R662 VDD.n387 VDD.n386 0.427147
R663 VDD.n62 VDD.n61 0.427147
R664 VDD.n390 VDD.n386 0.426171
R665 VDD.n110 VDD.n28 0.413465
R666 VDD.n111 VDD.n58 0.413465
R667 VDD.n437 VDD.n69 0.403558
R668 VDD.t13 VDD.t14 0.383639
R669 VDD.n415 VDD.n138 0.372952
R670 VDD.n419 VDD.n418 0.372655
R671 VDD.n234 VDD.n233 0.355452
R672 VDD.n330 VDD.n329 0.355452
R673 VDD.n372 VDD.n371 0.355452
R674 VDD.n378 VDD.n377 0.355452
R675 VDD.n198 VDD.n197 0.355386
R676 VDD.n210 VDD.n209 0.355386
R677 VDD.n276 VDD.n275 0.355386
R678 VDD.n216 VDD.n215 0.355312
R679 VDD.n222 VDD.n221 0.355312
R680 VDD.n258 VDD.n257 0.355312
R681 VDD.n264 VDD.n263 0.355312
R682 VDD.n300 VDD.n299 0.355312
R683 VDD.n336 VDD.n335 0.355155
R684 VDD.n342 VDD.n341 0.355155
R685 VDD.n360 VDD.n359 0.355155
R686 VDD.n324 VDD.n323 0.355155
R687 VDD.n348 VDD.n347 0.355155
R688 VDD.n246 VDD.n245 0.35515
R689 VDD.n318 VDD.n317 0.35501
R690 VDD.n204 VDD.n203 0.354936
R691 VDD.n240 VDD.n239 0.354936
R692 VDD.n270 VDD.n269 0.354936
R693 VDD.n282 VDD.n281 0.354936
R694 VDD.n354 VDD.n353 0.354936
R695 VDD.n366 VDD.n365 0.354936
R696 VDD.n306 VDD.n305 0.354903
R697 VDD.n288 VDD.n287 0.354838
R698 VDD.n228 VDD.n227 0.354771
R699 VDD.n252 VDD.n251 0.354697
R700 VDD.n294 VDD.n293 0.354697
R701 VDD.n410 VDD.n136 0.354692
R702 VDD.n312 VDD.n311 0.354692
R703 VDD.n413 VDD.n409 0.354483
R704 VDD.n424 VDD.n423 0.347655
R705 VDD.n420 VDD.n139 0.347655
R706 VDD.n410 VDD.n137 0.347254
R707 VDD.n414 VDD.n413 0.346924
R708 VDD.n119 VDD.n118 0.335808
R709 VDD.n132 VDD.n129 0.335799
R710 VDD.n430 VDD.n139 0.334692
R711 VDD.n428 VDD.n424 0.334692
R712 VDD.n132 VDD.n131 0.332058
R713 VDD.n122 VDD.n119 0.332049
R714 VDD.n426 VDD.n70 0.33018
R715 VDD.n418 VDD.n414 0.329275
R716 VDD.n415 VDD.n137 0.328947
R717 VDD.n409 VDD.n408 0.327886
R718 VDD.n398 VDD.n136 0.327655
R719 VDD.t103 VDD.n0 15.0851
R720 VDD.n126 VDD.n125 0.327354
R721 VDD.n64 VDD.n110 0.327154
R722 VDD.n39 VDD.n111 0.327154
R723 VDD.n402 VDD.n134 0.319294
R724 VDD.n388 VDD.n387 0.313013
R725 VDD.n315 VDD.n312 0.310155
R726 VDD.n255 VDD.n252 0.31015
R727 VDD.n297 VDD.n294 0.31015
R728 VDD.n231 VDD.n228 0.310071
R729 VDD.n291 VDD.n288 0.309994
R730 VDD.n309 VDD.n306 0.309933
R731 VDD.n207 VDD.n204 0.309928
R732 VDD.n243 VDD.n240 0.309928
R733 VDD.n273 VDD.n270 0.309928
R734 VDD.n285 VDD.n282 0.309928
R735 VDD.n357 VDD.n354 0.309928
R736 VDD.n369 VDD.n366 0.309928
R737 VDD.n321 VDD.n318 0.309837
R738 VDD.n249 VDD.n246 0.309697
R739 VDD.n423 VDD.n419 0.309692
R740 VDD.n327 VDD.n324 0.309692
R741 VDD.n339 VDD.n336 0.309692
R742 VDD.n345 VDD.n342 0.309692
R743 VDD.n351 VDD.n348 0.309692
R744 VDD.n363 VDD.n360 0.309692
R745 VDD.n219 VDD.n216 0.309557
R746 VDD.n225 VDD.n222 0.309557
R747 VDD.n261 VDD.n258 0.309557
R748 VDD.n267 VDD.n264 0.309557
R749 VDD.n303 VDD.n300 0.309557
R750 VDD.n201 VDD.n198 0.309483
R751 VDD.n213 VDD.n210 0.309483
R752 VDD.n279 VDD.n276 0.309483
R753 VDD.n237 VDD.n234 0.309405
R754 VDD.n333 VDD.n330 0.309405
R755 VDD.n375 VDD.n372 0.309405
R756 VDD.n381 VDD.n378 0.309405
R757 VDD.n420 VDD.n138 0.309405
R758 VDD.n108 VDD.n107 0.306614
R759 VDD.n131 VDD 0.423614
R760 VDD.n117 VDD.n116 0.298721
R761 VDD.n379 VDD.n35 0.29124
R762 VDD.n2 VDD.t7 0.549201
R763 VDD.n142 VDD.n141 0.284268
R764 VDD.n143 VDD.n142 0.282549
R765 VDD.n125 VDD.n124 0.282297
R766 VDD.n98 VDD.n144 0.279247
R767 VDD.n84 VDD.n159 0.279247
R768 VDD.n193 VDD.n1 0.435454
R769 VDD.n2 VDD.n1 0.0990691
R770 VDD.n153 VDD.n141 0.268799
R771 VDD.n100 VDD.n98 0.267977
R772 VDD.n118 VDD.n117 0.260496
R773 VDD.n391 VDD.n134 0.25999
R774 VDD.n433 VDD.n432 0.253639
R775 VDD.n405 VDD.n404 0.253639
R776 VDD.n113 VDD.n58 0.25333
R777 VDD.n434 VDD.n433 0.253298
R778 VDD.n406 VDD.n405 0.253298
R779 VDD VDD.n70 0.250961
R780 VDD.n36 VDD.n35 0.243044
R781 VDD.n144 VDD.n143 0.241768
R782 VDD.n115 VDD.n74 4.71183
R783 VDD.n67 VDD.n66 0.706063
R784 VDD VDD.n69 0.521582
R785 VDD.n72 VDD.n71 0.484477
R786 VDD.n63 VDD.t101 15.0439
R787 VDD.n63 VDD.n58 0.130762
R788 VDD.n66 VDD.n40 0.291774
R789 VDD.n85 VDD.n84 0.222977
R790 VDD.n32 VDD.n31 0.251712
R791 VDD.n26 VDD.n25 0.251712
R792 VDD.n24 VDD.n23 0.251712
R793 VDD.n155 VDD.n33 0.251712
R794 VDD.n20 VDD.n19 0.251712
R795 VDD.n18 VDD.n17 0.251712
R796 VDD.n104 VDD.n9 0.272485
R797 VDD.n8 VDD.n7 0.272485
R798 VDD.n103 VDD.n6 0.272485
R799 VDD.n5 VDD.n4 0.272485
R800 VDD.n102 VDD.n3 0.272485
R801 VDD.n101 VDD.n10 0.272485
R802 VDD.n29 VDD.n65 0.109866
R803 VDD.n58 VDD.n57 0.0835447
R804 VDD.n40 VDD.n37 0.100238
R805 VDD.n128 VDD.n127 0.202075
R806 VDD.n398 VDD.n135 0.192052
R807 VDD.n408 VDD.n397 0.191924
R808 VDD.n434 VDD.n69 0.189333
R809 VDD.n428 VDD.n425 0.184424
R810 VDD.n430 VDD.n140 0.184424
R811 VDD.n147 VDD.n146 0.181058
R812 VDD.n400 VDD.n396 0.17955
R813 VDD.n127 VDD.n126 0.175486
R814 VDD.n124 VDD.n123 0.171736
R815 VDD.n395 VDD.n394 0.16955
R816 VDD.n384 VDD.n383 0.16955
R817 VDD.n151 VDD.n99 0.210474
R818 VDD.n196 VDD.n195 0.162388
R819 VDD.n202 VDD.n201 0.162388
R820 VDD.n226 VDD.n225 0.162388
R821 VDD.n232 VDD.n231 0.162388
R822 VDD.n238 VDD.n237 0.162388
R823 VDD.n244 VDD.n243 0.162388
R824 VDD.n250 VDD.n249 0.162388
R825 VDD.n280 VDD.n279 0.162388
R826 VDD.n316 VDD.n315 0.162388
R827 VDD.n322 VDD.n321 0.162388
R828 VDD.n340 VDD.n339 0.162388
R829 VDD.n352 VDD.n351 0.162388
R830 VDD.n358 VDD.n357 0.162388
R831 VDD.n364 VDD.n363 0.162388
R832 VDD.n382 VDD.n381 0.162388
R833 VDD.n208 VDD.n207 0.16205
R834 VDD.n214 VDD.n213 0.16205
R835 VDD.n220 VDD.n219 0.16205
R836 VDD.n256 VDD.n255 0.16205
R837 VDD.n262 VDD.n261 0.16205
R838 VDD.n268 VDD.n267 0.16205
R839 VDD.n274 VDD.n273 0.16205
R840 VDD.n286 VDD.n285 0.16205
R841 VDD.n292 VDD.n291 0.16205
R842 VDD.n298 VDD.n297 0.16205
R843 VDD.n304 VDD.n303 0.16205
R844 VDD.n310 VDD.n309 0.16205
R845 VDD.n328 VDD.n327 0.16205
R846 VDD.n334 VDD.n333 0.16205
R847 VDD.n346 VDD.n345 0.16205
R848 VDD.n370 VDD.n369 0.16205
R849 VDD.n376 VDD.n375 0.16205
R850 VDD.n426 VDD.n140 0.161924
R851 VDD.n436 VDD.n425 0.161924
R852 VDD.n30 VDD 0.485468
R853 VDD.n41 VDD.n11 0.0957379
R854 VDD.n148 VDD.n147 0.159043
R855 VDD.n154 VDD.n153 0.157388
R856 VDD.n161 VDD.n160 0.157388
R857 VDD.n157 VDD.n156 0.157388
R858 VDD.n400 VDD.n397 0.154424
R859 VDD.n402 VDD.n135 0.154293
R860 VDD.n131 VDD.n130 0.152808
R861 VDD.n122 VDD.n121 0.152808
R862 VDD.n122 VDD.n120 0.152808
R863 VDD.n150 VDD.n145 0.15205
R864 VDD.n158 VDD.n72 0.15205
R865 VDD.n123 VDD.n122 0.147075
R866 VDD.n46 VDD.n149 0.236924
R867 VDD.n152 VDD.n150 0.134888
R868 VDD.n45 VDD.n44 0.134618
R869 VDD.n389 VDD.n388 0.133259
R870 VDD.n65 VDD.n64 0.133259
R871 VDD.n100 VDD.n99 0.16225
R872 VDD.n77 VDD.n75 0.128884
R873 VDD.n79 VDD.n78 0.128884
R874 VDD.n82 VDD.n81 0.128884
R875 VDD.n87 VDD.n86 0.128884
R876 VDD.n90 VDD.n89 0.128884
R877 VDD.n93 VDD.n92 0.128884
R878 VDD.n107 VDD.n106 0.127628
R879 VDD.n13 VDD.n148 0.947265
R880 VDD.n60 VDD.n59 0.185493
R881 VDD.n160 VDD.n85 0.1583
R882 VDD.n93 VDD.n104 0.141235
R883 VDD.n7 VDD.n90 0.141235
R884 VDD.n87 VDD.n103 0.141235
R885 VDD.n4 VDD.n82 0.141235
R886 VDD.n79 VDD.n102 0.141235
R887 VDD.n77 VDD.n101 0.141235
R888 VDD.n62 VDD.n60 0.0613757
R889 VDD.n152 VDD.n151 0.12205
R890 VDD.n394 VDD.n393 0.119888
R891 VDD.n396 VDD.n395 0.117388
R892 VDD.n209 VDD.n208 0.117388
R893 VDD.n215 VDD.n214 0.117388
R894 VDD.n221 VDD.n220 0.117388
R895 VDD.n257 VDD.n256 0.117388
R896 VDD.n263 VDD.n262 0.117388
R897 VDD.n269 VDD.n268 0.117388
R898 VDD.n275 VDD.n274 0.117388
R899 VDD.n287 VDD.n286 0.117388
R900 VDD.n293 VDD.n292 0.117388
R901 VDD.n299 VDD.n298 0.117388
R902 VDD.n305 VDD.n304 0.117388
R903 VDD.n311 VDD.n310 0.117388
R904 VDD.n329 VDD.n328 0.117388
R905 VDD.n335 VDD.n334 0.117388
R906 VDD.n347 VDD.n346 0.117388
R907 VDD.n371 VDD.n370 0.117388
R908 VDD.n377 VDD.n376 0.117388
R909 VDD.n197 VDD.n196 0.11705
R910 VDD.n203 VDD.n202 0.11705
R911 VDD.n227 VDD.n226 0.11705
R912 VDD.n233 VDD.n232 0.11705
R913 VDD.n239 VDD.n238 0.11705
R914 VDD.n245 VDD.n244 0.11705
R915 VDD.n251 VDD.n250 0.11705
R916 VDD.n281 VDD.n280 0.11705
R917 VDD.n317 VDD.n316 0.11705
R918 VDD.n323 VDD.n322 0.11705
R919 VDD.n341 VDD.n340 0.11705
R920 VDD.n353 VDD.n352 0.11705
R921 VDD.n359 VDD.n358 0.11705
R922 VDD.n365 VDD.n364 0.11705
R923 VDD.n383 VDD.n382 0.11705
R924 VDD.n59 VDD.n384 0.114888
R925 VDD.n31 VDD.n154 0.1133
R926 VDD.n156 VDD.n155 0.1133
R927 VDD.n44 VDD.n145 0.104888
R928 VDD.n159 VDD.n158 0.101138
R929 VDD.n63 VDD.n112 0.340529
R930 VDD.n56 VDD.n36 0.257619
R931 VDD.n40 VDD.n39 0.251665
R932 VDD.n146 VDD.n43 0.24736
R933 VDD.n114 VDD.n58 0.205524
R934 VDD.n386 VDD.n62 0.146235
R935 VDD.n389 VDD.n56 0.146235
R936 VDD.n95 VDD.n55 0.224985
R937 VDD.n54 VDD.n53 0.224985
R938 VDD.n96 VDD.n52 0.224985
R939 VDD.n51 VDD.n50 0.224985
R940 VDD.n97 VDD.n49 0.224985
R941 VDD.n48 VDD.n47 0.224985
R942 VDD.n12 VDD.n11 0.211235
R943 VDD.n28 VDD.t96 15.0336
R944 VDD.n17 VDD.n9 1.20647
R945 VDD.n8 VDD.n19 1.20647
R946 VDD.n33 VDD.n6 1.20647
R947 VDD.n5 VDD.n23 1.20647
R948 VDD.n25 VDD.n3 1.20647
R949 VDD.n10 VDD.n32 1.20646
R950 VDD.n34 VDD.n28 1.17026
R951 VDD.n1 VDD.n0 1.10286
R952 VDD.n13 VDD.n12 0.134613
R953 VDD.n16 VDD.n15 0.432616
R954 VDD.n22 VDD.n21 0.409065
R955 VDD.n48 VDD.n26 1.01698
R956 VDD.n49 VDD.n24 1.01698
R957 VDD.n51 VDD.n22 1.01698
R958 VDD.n52 VDD.n20 1.01698
R959 VDD.n54 VDD.n18 1.01698
R960 VDD.n55 VDD.n16 1.01698
R961 VSS.t580 VSS.n520 119321
R962 VSS.n627 VSS.n626 22369.4
R963 VSS.n426 VSS.n297 7907.02
R964 VSS.n516 VSS.n195 4670.31
R965 VSS.n847 VSS.n846 3068.57
R966 VSS.t268 VSS.n61 310.202
R967 VSS.t266 VSS.n66 310.202
R968 VSS.t363 VSS.n619 849.322
R969 VSS.n680 VSS.n679 572.005
R970 VSS.t387 VSS.t274 571.348
R971 VSS.n695 VSS.t283 566.691
R972 VSS.n694 VSS.t424 560.899
R973 VSS.n684 VSS.t37 550.193
R974 VSS.n711 VSS.t343 539.653
R975 VSS.t577 VSS.n692 532.819
R976 VSS.n714 VSS.t12 522.508
R977 VSS.n705 VSS.t92 521.236
R978 VSS.t45 VSS.n691 514.091
R979 VSS.n701 VSS.t235 504.839
R980 VSS.n687 VSS.t254 504.839
R981 VSS.n712 VSS.t14 491.87
R982 VSS.n696 VSS.t346 474.904
R983 VSS.t479 VSS.n630 470.019
R984 VSS.n216 VSS.n215 469.783
R985 VSS.n233 VSS.n232 469.783
R986 VSS.n255 VSS.n254 469.783
R987 VSS.n274 VSS.n273 469.783
R988 VSS.n288 VSS.n287 469.783
R989 VSS.n302 VSS.n301 469.783
R990 VSS.n697 VSS.t470 456.175
R991 VSS.n907 VSS.n906 454.007
R992 VSS.n221 VSS.n218 454.007
R993 VSS.n238 VSS.n235 454.007
R994 VSS.n886 VSS.n885 454.007
R995 VSS.n877 VSS.n876 454.007
R996 VSS.n868 VSS.n867 454.007
R997 VSS.n904 VSS.n903 453.986
R998 VSS.n224 VSS.n223 453.986
R999 VSS.n241 VSS.n240 453.986
R1000 VSS.n883 VSS.n882 453.986
R1001 VSS.n874 VSS.n873 453.986
R1002 VSS.n865 VSS.n864 453.986
R1003 VSS.n903 VSS.n207 453.986
R1004 VSS.n230 VSS.n224 453.986
R1005 VSS.n252 VSS.n241 453.986
R1006 VSS.n882 VSS.n264 453.986
R1007 VSS.n873 VSS.n278 453.986
R1008 VSS.n864 VSS.n292 453.986
R1009 VSS.t213 VSS.n249 448.228
R1010 VSS.t246 VSS.n187 442.469
R1011 VSS.t206 VSS.n189 437.62
R1012 VSS.n258 VSS.t466 431.863
R1013 VSS.t442 VSS.n59 427.695
R1014 VSS.n691 VSS.t617 427.219
R1015 VSS.t432 VSS.n259 419.459
R1016 VSS.t168 VSS.n299 413.68
R1017 VSS.t157 VSS.n285 413.68
R1018 VSS.t147 VSS.n271 413.68
R1019 VSS.t136 VSS.n251 413.68
R1020 VSS.t126 VSS.n229 413.68
R1021 VSS.t116 VSS.n213 413.68
R1022 VSS.n699 VSS.n698 412.791
R1023 VSS.n685 VSS.n67 412.791
R1024 VSS.n820 VSS.n819 412.522
R1025 VSS.n202 VSS.t207 403.072
R1026 VSS.t252 VSS.n712 401.591
R1027 VSS.n258 VSS.t212 397.313
R1028 VSS.n200 VSS.t483 391.555
R1029 VSS.t363 VSS.n821 388.781
R1030 VSS.t112 VSS.n207 385.798
R1031 VSS.t122 VSS.n230 385.798
R1032 VSS.t133 VSS.n252 385.798
R1033 VSS.t143 VSS.n264 385.798
R1034 VSS.t153 VSS.n278 385.798
R1035 VSS.t164 VSS.n292 385.798
R1036 VSS.n197 VSS.t57 384.887
R1037 VSS.n198 VSS.t356 380.038
R1038 VSS.t570 VSS.n60 375.276
R1039 VSS.t197 VSS.n699 372.094
R1040 VSS.t199 VSS.n685 372.094
R1041 VSS.t268 VSS.n704 363.339
R1042 VSS.t266 VSS.n690 363.339
R1043 VSS.t334 VSS.t362 359.769
R1044 VSS.t425 VSS.n193 357.007
R1045 VSS.n681 VSS.t82 347.49
R1046 VSS.t426 VSS.n191 333.974
R1047 VSS.n197 VSS.t204 333.065
R1048 VSS.t117 VSS.n213 333.063
R1049 VSS.t127 VSS.n229 333.063
R1050 VSS.t137 VSS.n251 333.063
R1051 VSS.t148 VSS.n271 333.063
R1052 VSS.t158 VSS.n285 333.063
R1053 VSS.n299 VSS.t169 333.063
R1054 VSS.t35 VSS.n634 329.238
R1055 VSS.n796 VSS.t387 327.81
R1056 VSS.t263 VSS.n185 322.457
R1057 VSS.n261 VSS.t353 322.457
R1058 VSS.t580 VSS.n845 314.327
R1059 VSS.n715 VSS.t11 313.659
R1060 VSS.n904 VSS.t110 305.183
R1061 VSS.n223 VSS.t120 305.183
R1062 VSS.n240 VSS.t131 305.183
R1063 VSS.n883 VSS.t141 305.183
R1064 VSS.n874 VSS.t151 305.183
R1065 VSS.n865 VSS.t162 305.183
R1066 VSS.t281 VSS.t44 304.42
R1067 VSS.t234 VSS.n702 304.42
R1068 VSS.t338 VSS.t289 304.42
R1069 VSS.t253 VSS.n688 304.42
R1070 VSS.t342 VSS.n714 299.735
R1071 VSS.n201 VSS.t245 299.425
R1072 VSS.n906 VSS.t107 293.666
R1073 VSS.t118 VSS.n221 293.666
R1074 VSS.t128 VSS.n238 293.666
R1075 VSS.n885 VSS.t138 293.666
R1076 VSS.n876 VSS.t149 293.666
R1077 VSS.n867 VSS.t159 293.666
R1078 VSS.n303 VSS.t100 292.757
R1079 VSS.t195 VSS.n284 292.757
R1080 VSS.t79 VSS.n270 292.757
R1081 VSS.t349 VSS.n247 292.757
R1082 VSS.t18 VSS.n250 292.757
R1083 VSS.t491 VSS.n228 292.757
R1084 VSS.t76 VSS.n212 292.757
R1085 VSS.t347 VSS.n183 292.757
R1086 VSS.t257 VSS.n701 291.37
R1087 VSS.t298 VSS.n687 291.37
R1088 VSS.n201 VSS.t58 287.909
R1089 VSS.n204 VSS.t202 275.505
R1090 VSS.t421 VSS.n187 269.724
R1091 VSS.t264 VSS.n185 264.875
R1092 VSS.n261 VSS.t354 264.875
R1093 VSS.t101 VSS.n297 258.238
R1094 VSS.n257 VSS.t19 258.236
R1095 VSS.n868 VSS.t196 258.233
R1096 VSS.n877 VSS.t80 258.233
R1097 VSS.n886 VSS.t350 258.233
R1098 VSS.n907 VSS.t348 258.233
R1099 VSS.n218 VSS.t77 258.233
R1100 VSS.n235 VSS.t492 258.233
R1101 VSS.t484 VSS.n190 258.231
R1102 VSS.t420 VSS.n191 253.359
R1103 VSS.t361 VSS.n115 252.375
R1104 VSS.t201 VSS.n119 252.375
R1105 VSS.t436 VSS.n117 252.375
R1106 VSS.t255 VSS.n125 252.375
R1107 VSS.t616 VSS.n116 252.375
R1108 VSS.t440 VSS.n112 252.375
R1109 VSS.t99 VSS.n136 252.375
R1110 VSS.t215 VSS.n109 252.375
R1111 VSS.t398 VSS.n143 252.375
R1112 VSS.t65 VSS.n147 252.375
R1113 VSS.t243 VSS.n148 252.375
R1114 VSS.n105 VSS.t244 252.375
R1115 VSS.n102 VSS.t29 252.375
R1116 VSS.n154 VSS.t310 252.375
R1117 VSS.t383 VSS.n90 252.375
R1118 VSS.n162 VSS.t575 252.374
R1119 VSS.n160 VSS.t441 252.374
R1120 VSS.t564 VSS.n123 252.117
R1121 VSS.t443 VSS.n130 252.117
R1122 VSS.t386 VSS.n114 252.117
R1123 VSS.t344 VSS.n133 252.117
R1124 VSS.t222 VSS.n111 252.117
R1125 VSS.t360 VSS.n140 252.117
R1126 VSS.t277 VSS.n145 252.117
R1127 VSS.t385 VSS.n103 252.117
R1128 VSS.t329 VSS.n100 252.117
R1129 VSS.n92 VSS.t576 252.117
R1130 VSS.n172 VSS.t381 252.115
R1131 VSS.n167 VSS.t571 252.115
R1132 VSS.n165 VSS.t418 252.115
R1133 VSS.n163 VSS.t408 252.115
R1134 VSS.n161 VSS.t256 252.115
R1135 VSS.t510 VSS.n345 250.837
R1136 VSS.t501 VSS.n346 250.837
R1137 VSS.t508 VSS.n350 250.837
R1138 VSS.t548 VSS.n351 250.837
R1139 VSS.t499 VSS.n355 250.837
R1140 VSS.t549 VSS.n356 250.837
R1141 VSS.t512 VSS.n360 250.837
R1142 VSS.t509 VSS.n361 250.837
R1143 VSS.t496 VSS.n365 250.837
R1144 VSS.t550 VSS.n366 250.837
R1145 VSS.t551 VSS.n370 250.837
R1146 VSS.t503 VSS.n371 250.837
R1147 VSS.t506 VSS.n375 250.837
R1148 VSS.t552 VSS.n376 250.837
R1149 VSS.t511 VSS.n380 250.837
R1150 VSS.t505 VSS.n381 250.837
R1151 VSS.t497 VSS.n385 250.837
R1152 VSS.t556 VSS.n386 250.837
R1153 VSS.t555 VSS.n390 250.837
R1154 VSS.t557 VSS.n391 250.837
R1155 VSS.t498 VSS.n395 250.837
R1156 VSS.t558 VSS.n396 250.837
R1157 VSS.t554 VSS.n400 250.837
R1158 VSS.t553 VSS.n401 250.837
R1159 VSS.t502 VSS.n405 250.837
R1160 VSS.t559 VSS.n406 250.837
R1161 VSS.t507 VSS.n410 250.837
R1162 VSS.t500 VSS.n411 250.837
R1163 VSS.t560 VSS.n415 250.837
R1164 VSS.t561 VSS.n416 250.837
R1165 VSS.t504 VSS.n420 250.837
R1166 VSS.t562 VSS.n421 250.837
R1167 VSS.t442 VSS.n61 148.06
R1168 VSS.t617 VSS.n66 148.06
R1169 VSS.n681 VSS.t35 243.244
R1170 VSS.n196 VSS.t419 240.956
R1171 VSS.t114 VSS.n214 240.956
R1172 VSS.t124 VSS.n231 240.956
R1173 VSS.t135 VSS.n253 240.956
R1174 VSS.t145 VSS.n272 240.956
R1175 VSS.t155 VSS.n286 240.956
R1176 VSS.t166 VSS.n300 240.956
R1177 VSS.n504 VSS.t569 234.114
R1178 VSS.n499 VSS.t462 234.114
R1179 VSS.n494 VSS.t400 234.114
R1180 VSS.n489 VSS.t300 234.114
R1181 VSS.n484 VSS.t423 234.114
R1182 VSS.n479 VSS.t39 234.114
R1183 VSS.n474 VSS.t437 234.114
R1184 VSS.n469 VSS.t309 234.114
R1185 VSS.n464 VSS.t372 234.114
R1186 VSS.n459 VSS.t417 234.114
R1187 VSS.n454 VSS.t332 234.114
R1188 VSS.n449 VSS.t407 234.114
R1189 VSS.n444 VSS.t260 234.114
R1190 VSS.n439 VSS.t304 234.114
R1191 VSS.n434 VSS.t472 234.114
R1192 VSS.n429 VSS.t241 234.114
R1193 VSS.t355 VSS.n193 230.327
R1194 VSS.n215 VSS.t114 229.44
R1195 VSS.n232 VSS.t124 229.44
R1196 VSS.n254 VSS.t135 229.44
R1197 VSS.n273 VSS.t145 229.44
R1198 VSS.n287 VSS.t155 229.44
R1199 VSS.n301 VSS.t166 229.44
R1200 VSS.t419 VSS.n195 228.827
R1201 VSS.t313 VSS.n120 225.361
R1202 VSS.t461 VSS.n127 225.361
R1203 VSS.t422 VSS.n134 225.361
R1204 VSS.t41 VSS.n138 225.361
R1205 VSS.t438 VSS.n141 225.361
R1206 VSS.t308 VSS.n146 225.361
R1207 VSS.t416 VSS.n106 225.361
R1208 VSS.t331 VSS.n151 225.361
R1209 VSS.t406 VSS.n153 225.361
R1210 VSS.t258 VSS.n98 225.361
R1211 VSS.t302 VSS.n95 225.361
R1212 VSS.t471 VSS.n91 225.361
R1213 VSS.n173 VSS.t568 225.359
R1214 VSS.n171 VSS.t399 225.359
R1215 VSS.n170 VSS.t299 225.359
R1216 VSS.n166 VSS.t371 225.359
R1217 VSS.t82 VSS.n680 224.516
R1218 VSS.t348 VSS.n183 212.143
R1219 VSS.t77 VSS.n212 212.143
R1220 VSS.t492 VSS.n228 212.143
R1221 VSS.t19 VSS.n250 212.143
R1222 VSS.t350 VSS.n247 212.143
R1223 VSS.t80 VSS.n270 212.143
R1224 VSS.t196 VSS.n284 212.143
R1225 VSS.n303 VSS.t101 212.143
R1226 VSS.n164 VSS.t368 211.982
R1227 VSS.n159 VSS.t170 211.982
R1228 VSS.n121 VSS.t293 211.982
R1229 VSS.n124 VSS.t89 211.982
R1230 VSS.n128 VSS.t493 211.982
R1231 VSS.n131 VSS.t476 211.982
R1232 VSS.t6 VSS.n113 211.982
R1233 VSS.n135 VSS.t322 211.982
R1234 VSS.t365 VSS.n110 211.982
R1235 VSS.n142 VSS.t184 211.982
R1236 VSS.t15 VSS.n108 211.982
R1237 VSS.t473 VSS.n107 211.982
R1238 VSS.n150 VSS.t94 211.982
R1239 VSS.n152 VSS.t572 211.982
R1240 VSS.t187 VSS.n97 211.982
R1241 VSS.t192 VSS.n94 211.982
R1242 VSS.n713 VSS.t252 208.828
R1243 VSS.n198 VSS.t355 207.294
R1244 VSS.n715 VSS.t342 202.362
R1245 VSS.n700 VSS.t197 202.071
R1246 VSS.n686 VSS.t199 202.071
R1247 VSS.n192 VSS.t420 200.649
R1248 VSS.n627 VSS.n0 197.518
R1249 VSS.n705 VSS.t570 196.911
R1250 VSS.n702 VSS.t257 196.399
R1251 VSS.n688 VSS.t298 196.399
R1252 VSS.n200 VSS.t484 195.778
R1253 VSS.t51 VSS.n122 195.26
R1254 VSS.t375 VSS.n126 195.26
R1255 VSS.t290 VSS.n129 195.26
R1256 VSS.t403 VSS.n132 195.26
R1257 VSS.t218 VSS.n137 195.26
R1258 VSS.t314 VSS.n139 195.26
R1259 VSS.t469 VSS.n144 195.26
R1260 VSS.t250 VSS.n149 195.26
R1261 VSS.t227 VSS.n104 195.26
R1262 VSS.t359 VSS.n101 195.26
R1263 VSS.t180 VSS.n99 195.26
R1264 VSS.t565 VSS.n96 195.26
R1265 VSS.t23 VSS.n93 195.26
R1266 VSS.n169 VSS.t176 195.26
R1267 VSS.n168 VSS.t316 195.26
R1268 VSS.n158 VSS.t232 195.26
R1269 VSS.t202 VSS.n184 194.899
R1270 VSS.n822 VSS.t363 194.514
R1271 VSS.t354 VSS.n248 189.137
R1272 VSS.n204 VSS.t264 189.135
R1273 VSS.t11 VSS.n628 187.895
R1274 VSS.n505 VSS.t190 187.292
R1275 VSS.n500 VSS.t384 187.292
R1276 VSS.n495 VSS.t9 187.292
R1277 VSS.n490 VSS.t27 187.292
R1278 VSS.n485 VSS.t345 187.292
R1279 VSS.n480 VSS.t488 187.292
R1280 VSS.n475 VSS.t66 187.292
R1281 VSS.n470 VSS.t464 187.292
R1282 VSS.n465 VSS.t32 187.292
R1283 VSS.n460 VSS.t225 187.292
R1284 VSS.n455 VSS.t30 187.292
R1285 VSS.n450 VSS.t270 187.292
R1286 VSS.n445 VSS.t105 187.292
R1287 VSS.n440 VSS.t379 187.292
R1288 VSS.n435 VSS.t68 187.292
R1289 VSS.n430 VSS.t431 187.292
R1290 VSS.n202 VSS.t421 184.262
R1291 VSS.t236 VSS.n697 183.975
R1292 VSS.n703 VSS.t234 182.797
R1293 VSS.n689 VSS.t253 182.797
R1294 VSS.t409 VSS.n3 177.685
R1295 VSS.n184 VSS.t347 177.617
R1296 VSS.n248 VSS.t349 177.617
R1297 VSS.n217 VSS.t76 177.615
R1298 VSS.n234 VSS.t491 177.615
R1299 VSS.n256 VSS.t18 177.615
R1300 VSS.n275 VSS.t79 177.615
R1301 VSS.n289 VSS.t195 177.615
R1302 VSS.t100 VSS.n298 177.615
R1303 VSS.t320 VSS.n349 173.913
R1304 VSS.t306 VSS.n354 173.913
R1305 VSS.t87 VSS.n359 173.913
R1306 VSS.n364 VSS.t210 173.913
R1307 VSS.t49 VSS.n369 173.913
R1308 VSS.n374 VSS.t64 173.913
R1309 VSS.t619 VSS.n379 173.913
R1310 VSS.t73 VSS.n384 173.913
R1311 VSS.t84 VSS.n389 173.913
R1312 VSS.t411 VSS.n394 173.913
R1313 VSS.n399 VSS.t174 173.913
R1314 VSS.n404 VSS.t70 173.913
R1315 VSS.t621 VSS.n409 173.913
R1316 VSS.t482 VSS.n414 173.913
R1317 VSS.n419 VSS.t326 173.913
R1318 VSS.t61 VSS.n424 173.913
R1319 VSS.n427 VSS.n426 173.913
R1320 VSS.t34 VSS.n684 167.954
R1321 VSS.t294 VSS.t53 163.881
R1322 VSS.t90 VSS.t374 163.881
R1323 VSS.t494 VSS.t291 163.881
R1324 VSS.t477 VSS.t404 163.881
R1325 VSS.t7 VSS.t178 163.881
R1326 VSS.t323 VSS.t216 163.881
R1327 VSS.t366 VSS.t315 163.881
R1328 VSS.t185 VSS.t467 163.881
R1329 VSS.t16 VSS.t317 163.881
R1330 VSS.t474 VSS.t251 163.881
R1331 VSS.t95 VSS.t228 163.881
R1332 VSS.t573 VSS.t358 163.881
R1333 VSS.t369 VSS.t181 163.881
R1334 VSS.t188 VSS.t566 163.881
R1335 VSS.t193 VSS.t25 163.881
R1336 VSS.t171 VSS.t230 163.881
R1337 VSS.n205 VSS.t107 160.341
R1338 VSS.n222 VSS.t118 160.341
R1339 VSS.n239 VSS.t128 160.341
R1340 VSS.n262 VSS.t138 160.341
R1341 VSS.n276 VSS.t149 160.341
R1342 VSS.n290 VSS.t159 160.341
R1343 VSS.t414 VSS.n177 157.601
R1344 VSS.n178 VSS.t429 156.464
R1345 VSS.t288 VSS.n121 155.126
R1346 VSS.t0 VSS.n124 155.126
R1347 VSS.t445 VSS.n128 155.126
R1348 VSS.t485 VSS.n131 155.126
R1349 VSS.t490 VSS.n113 155.126
R1350 VSS.t328 VSS.n135 155.126
R1351 VSS.t220 VSS.n110 155.126
R1352 VSS.t567 VSS.n142 155.126
R1353 VSS.t430 VSS.n108 155.126
R1354 VSS.t21 VSS.n107 155.126
R1355 VSS.t262 VSS.n150 155.126
R1356 VSS.t275 VSS.n152 155.126
R1357 VSS.t103 VSS.n97 155.126
R1358 VSS.t191 VSS.n94 155.126
R1359 VSS.n164 VSS.t4 155.125
R1360 VSS.n159 VSS.t265 155.125
R1361 VSS.n600 VSS.t591 154.613
R1362 VSS.n611 VSS.t598 154.613
R1363 VSS.t245 VSS.n188 153.971
R1364 VSS.n178 VSS.t459 153.851
R1365 VSS.n514 VSS.t239 153.846
R1366 VSS.n505 VSS.t319 153.846
R1367 VSS.n500 VSS.t305 153.846
R1368 VSS.n495 VSS.t86 153.846
R1369 VSS.n490 VSS.t209 153.846
R1370 VSS.n485 VSS.t48 153.846
R1371 VSS.n480 VSS.t63 153.846
R1372 VSS.n475 VSS.t618 153.846
R1373 VSS.n470 VSS.t72 153.846
R1374 VSS.n465 VSS.t83 153.846
R1375 VSS.n460 VSS.t410 153.846
R1376 VSS.n455 VSS.t173 153.846
R1377 VSS.n450 VSS.t69 153.846
R1378 VSS.n445 VSS.t620 153.846
R1379 VSS.n440 VSS.t481 153.846
R1380 VSS.n435 VSS.t325 153.846
R1381 VSS.n430 VSS.t60 153.846
R1382 VSS.t415 VSS.n89 153.236
R1383 VSS.t58 VSS.n189 149.713
R1384 VSS.t110 VSS.n205 148.826
R1385 VSS.t120 VSS.n222 148.826
R1386 VSS.t131 VSS.n239 148.826
R1387 VSS.t141 VSS.n262 148.826
R1388 VSS.t151 VSS.n276 148.826
R1389 VSS.t162 VSS.n290 148.826
R1390 VSS.n6 VSS.t578 147.453
R1391 VSS.t486 VSS.n348 147.157
R1392 VSS.t296 VSS.n353 147.157
R1393 VSS.t284 VSS.n358 147.157
R1394 VSS.t182 VSS.n363 147.157
R1395 VSS.t351 VSS.n368 147.157
R1396 VSS.t301 VSS.n373 147.157
R1397 VSS.t97 VSS.n378 147.157
R1398 VSS.t2 VSS.n383 147.157
R1399 VSS.t480 VSS.n388 147.157
R1400 VSS.t278 VSS.n393 147.157
R1401 VSS.t444 VSS.n398 147.157
R1402 VSS.t223 VSS.n403 147.157
R1403 VSS.t330 VSS.n408 147.157
R1404 VSS.t55 VSS.n413 147.157
R1405 VSS.t401 VSS.n418 147.157
R1406 VSS.t489 VSS.n423 147.157
R1407 VSS.t614 VSS.n156 145.091
R1408 VSS.t44 VSS.n703 138.607
R1409 VSS.t289 VSS.n689 138.607
R1410 VSS.n156 VSS.t610 138.403
R1411 VSS.t169 VSS.n298 137.311
R1412 VSS.n289 VSS.t158 137.311
R1413 VSS.n275 VSS.t148 137.311
R1414 VSS.n256 VSS.t137 137.311
R1415 VSS.n234 VSS.t127 137.311
R1416 VSS.n217 VSS.t117 137.311
R1417 VSS.t204 VSS.n196 137.309
R1418 VSS.n679 VSS.n636 132.891
R1419 VSS.t610 VSS.n155 131.972
R1420 VSS.n186 VSS.t263 130.939
R1421 VSS.t353 VSS.n260 130.939
R1422 VSS.n854 VSS.t311 127.421
R1423 VSS.t513 VSS.n1 125.359
R1424 VSS.t273 VSS.n850 123.674
R1425 VSS.n628 VSS.n627 122.129
R1426 VSS.n630 VSS.t334 121.858
R1427 VSS.t429 VSS.n89 120.691
R1428 VSS.n199 VSS.t426 119.422
R1429 VSS.n175 VSS.t413 118.249
R1430 VSS.n427 VSS.t614 117.058
R1431 VSS.n849 VSS.t247 116.177
R1432 VSS.t470 VSS.n696 115.831
R1433 VSS.t75 VSS.n620 112.174
R1434 VSS.t249 VSS.n852 108.683
R1435 VSS.n679 VSS.n678 107.175
R1436 VSS.n507 VSS.t288 107.023
R1437 VSS.n504 VSS.t486 107.023
R1438 VSS.n502 VSS.t0 107.023
R1439 VSS.n499 VSS.t296 107.023
R1440 VSS.n497 VSS.t445 107.023
R1441 VSS.n494 VSS.t284 107.023
R1442 VSS.n492 VSS.t485 107.023
R1443 VSS.n489 VSS.t182 107.023
R1444 VSS.n487 VSS.t490 107.023
R1445 VSS.n484 VSS.t351 107.023
R1446 VSS.n482 VSS.t328 107.023
R1447 VSS.n479 VSS.t301 107.023
R1448 VSS.n477 VSS.t220 107.023
R1449 VSS.n474 VSS.t97 107.023
R1450 VSS.n472 VSS.t567 107.023
R1451 VSS.n469 VSS.t2 107.023
R1452 VSS.n467 VSS.t430 107.023
R1453 VSS.n464 VSS.t480 107.023
R1454 VSS.n462 VSS.t21 107.023
R1455 VSS.n459 VSS.t278 107.023
R1456 VSS.n457 VSS.t262 107.023
R1457 VSS.n454 VSS.t444 107.023
R1458 VSS.n452 VSS.t275 107.023
R1459 VSS.n449 VSS.t223 107.023
R1460 VSS.t4 VSS.n447 107.023
R1461 VSS.n444 VSS.t330 107.023
R1462 VSS.n442 VSS.t103 107.023
R1463 VSS.n439 VSS.t55 107.023
R1464 VSS.n437 VSS.t191 107.023
R1465 VSS.n434 VSS.t401 107.023
R1466 VSS.t265 VSS.n432 107.023
R1467 VSS.n429 VSS.t489 107.023
R1468 VSS.t433 VSS.n847 106.808
R1469 VSS.n710 VSS.t479 103.538
R1470 VSS.n717 VSS.t341 103.379
R1471 VSS.n514 VSS.t604 100.335
R1472 VSS.t319 VSS.n348 100.335
R1473 VSS.t305 VSS.n353 100.335
R1474 VSS.t86 VSS.n358 100.335
R1475 VSS.t209 VSS.n363 100.335
R1476 VSS.t48 VSS.n368 100.335
R1477 VSS.t63 VSS.n373 100.335
R1478 VSS.t618 VSS.n378 100.335
R1479 VSS.t72 VSS.n383 100.335
R1480 VSS.t83 VSS.n388 100.335
R1481 VSS.t410 VSS.n393 100.335
R1482 VSS.t173 VSS.n398 100.335
R1483 VSS.t69 VSS.n403 100.335
R1484 VSS.t620 VSS.n408 100.335
R1485 VSS.t481 VSS.n413 100.335
R1486 VSS.t325 VSS.n418 100.335
R1487 VSS.t60 VSS.n423 100.335
R1488 VSS.n600 VSS.t594 99.7511
R1489 VSS.t600 VSS.n611 99.7511
R1490 VSS.n716 VSS.t286 98.4633
R1491 VSS.t594 VSS.n1 97.9284
R1492 VSS.n5 VSS.t600 97.9273
R1493 VSS.t346 VSS.n695 97.5777
R1494 VSS.t458 VSS.n856 97.4396
R1495 VSS.n194 VSS.t425 96.3896
R1496 VSS.n177 VSS.t312 93.8889
R1497 VSS.n856 VSS.t434 93.6919
R1498 VSS.n155 VSS.t61 88.4947
R1499 VSS.n174 VSS.t427 88.4111
R1500 VSS.t12 VSS.n713 88.3462
R1501 VSS.n172 VSS.t306 88.2366
R1502 VSS.n167 VSS.t84 88.2366
R1503 VSS.n165 VSS.t411 88.2366
R1504 VSS.n163 VSS.t621 88.2366
R1505 VSS.n161 VSS.t482 88.2366
R1506 VSS.n123 VSS.t320 88.2359
R1507 VSS.n130 VSS.t87 88.2359
R1508 VSS.t210 VSS.n114 88.2359
R1509 VSS.n133 VSS.t49 88.2359
R1510 VSS.t64 VSS.n111 88.2359
R1511 VSS.n140 VSS.t619 88.2359
R1512 VSS.n145 VSS.t73 88.2359
R1513 VSS.t174 VSS.n103 88.2359
R1514 VSS.t70 VSS.n100 88.2359
R1515 VSS.t326 VSS.n92 88.2359
R1516 VSS.n426 VSS.n86 88.4708
R1517 VSS.t604 VSS.t237 86.957
R1518 VSS.t239 VSS.t606 86.957
R1519 VSS.t235 VSS.n700 85.7923
R1520 VSS.t254 VSS.n686 85.7923
R1521 VSS.t57 VSS.n194 84.8733
R1522 VSS.t427 VSS.n516 83.0562
R1523 VSS.n852 VSS.t428 82.449
R1524 VSS.t14 VSS.n711 81.2384
R1525 VSS.n2 VSS.t513 80.4704
R1526 VSS.n562 VSS.t622 77.8798
R1527 VSS.n820 VSS.t43 77.2751
R1528 VSS.t357 VSS.t337 77.2751
R1529 VSS.n821 VSS.t362 75.4357
R1530 VSS.t428 VSS.n176 75.2962
R1531 VSS.t272 VSS.n849 74.9537
R1532 VSS.t237 VSS.n118 74.8587
R1533 VSS.n645 VSS.t460 74.7824
R1534 VSS.t356 VSS.n192 73.9692
R1535 VSS.t339 VSS.n621 73.536
R1536 VSS.n626 VSS.n622 73.536
R1537 VSS.n507 VSS.t294 70.2346
R1538 VSS.n502 VSS.t90 70.2346
R1539 VSS.n497 VSS.t494 70.2346
R1540 VSS.n492 VSS.t477 70.2346
R1541 VSS.n487 VSS.t7 70.2346
R1542 VSS.n482 VSS.t323 70.2346
R1543 VSS.n477 VSS.t366 70.2346
R1544 VSS.n472 VSS.t185 70.2346
R1545 VSS.n467 VSS.t16 70.2346
R1546 VSS.n462 VSS.t474 70.2346
R1547 VSS.n457 VSS.t95 70.2346
R1548 VSS.n452 VSS.t573 70.2346
R1549 VSS.n447 VSS.t369 70.2346
R1550 VSS.n442 VSS.t188 70.2346
R1551 VSS.n437 VSS.t193 70.2346
R1552 VSS.n432 VSS.t171 70.2346
R1553 VSS.n549 VSS.t448 69.1047
R1554 VSS.n214 VSS.t112 68.211
R1555 VSS.n231 VSS.t122 68.211
R1556 VSS.n253 VSS.t133 68.211
R1557 VSS.n272 VSS.t143 68.211
R1558 VSS.n286 VSS.t153 68.211
R1559 VSS.n300 VSS.t164 68.211
R1560 VSS.n850 VSS.t272 67.4583
R1561 VSS.t624 VSS.n530 66.9109
R1562 VSS.n506 VSS.t51 66.8901
R1563 VSS.t190 VSS.n346 66.8901
R1564 VSS.n501 VSS.t375 66.8901
R1565 VSS.t384 VSS.n351 66.8901
R1566 VSS.n496 VSS.t290 66.8901
R1567 VSS.t9 VSS.n356 66.8901
R1568 VSS.n491 VSS.t403 66.8901
R1569 VSS.t27 VSS.n361 66.8901
R1570 VSS.t176 VSS.n486 66.8901
R1571 VSS.t345 VSS.n366 66.8901
R1572 VSS.n481 VSS.t218 66.8901
R1573 VSS.t488 VSS.n371 66.8901
R1574 VSS.n476 VSS.t314 66.8901
R1575 VSS.t66 VSS.n376 66.8901
R1576 VSS.n471 VSS.t469 66.8901
R1577 VSS.t464 VSS.n381 66.8901
R1578 VSS.t316 VSS.n466 66.8901
R1579 VSS.t32 VSS.n386 66.8901
R1580 VSS.n461 VSS.t250 66.8901
R1581 VSS.t225 VSS.n391 66.8901
R1582 VSS.n456 VSS.t227 66.8901
R1583 VSS.t30 VSS.n396 66.8901
R1584 VSS.n451 VSS.t359 66.8901
R1585 VSS.t270 VSS.n401 66.8901
R1586 VSS.n446 VSS.t180 66.8901
R1587 VSS.t105 VSS.n406 66.8901
R1588 VSS.n441 VSS.t565 66.8901
R1589 VSS.t379 VSS.n411 66.8901
R1590 VSS.n436 VSS.t23 66.8901
R1591 VSS.t68 VSS.n416 66.8901
R1592 VSS.t232 VSS.n431 66.8901
R1593 VSS.t431 VSS.n421 66.8901
R1594 VSS.t526 VSS.n672 65.3699
R1595 VSS.n678 VSS.t515 65.366
R1596 VSS.t312 VSS.n854 63.7107
R1597 VSS.t434 VSS.n855 62.4441
R1598 VSS.n671 VSS.t530 62.1568
R1599 VSS.t483 VSS.n199 61.8407
R1600 VSS.n626 VSS.n625 59.3547
R1601 VSS.n857 VSS.t458 58.6964
R1602 VSS.n746 VSS.t453 58.1358
R1603 VSS.t460 VSS.n636 58.1084
R1604 VSS.t578 VSS.n5 58.0281
R1605 VSS.n692 VSS.t45 57.9156
R1606 VSS.t212 VSS.n249 56.6734
R1607 VSS.n216 VSS.t116 56.0825
R1608 VSS.n233 VSS.t126 56.0825
R1609 VSS.n255 VSS.t136 56.0825
R1610 VSS.n274 VSS.t147 56.0825
R1611 VSS.n288 VSS.t157 56.0825
R1612 VSS.n302 VSS.t168 56.0825
R1613 VSS.n555 VSS.t450 55.942
R1614 VSS.n676 VSS.t520 55.7328
R1615 VSS.t522 VSS.n674 55.7328
R1616 VSS.t413 VSS.n174 54.6841
R1617 VSS.t580 VSS.n519 53.7482
R1618 VSS.n645 VSS.t364 52.3478
R1619 VSS.t92 VSS.n59 51.2456
R1620 VSS.t207 VSS.n186 50.3244
R1621 VSS.n260 VSS.t432 50.3244
R1622 VSS.t293 VSS.n345 50.1677
R1623 VSS.t89 VSS.n350 50.1677
R1624 VSS.t493 VSS.n355 50.1677
R1625 VSS.t476 VSS.n360 50.1677
R1626 VSS.n365 VSS.t6 50.1677
R1627 VSS.t322 VSS.n370 50.1677
R1628 VSS.n375 VSS.t365 50.1677
R1629 VSS.t184 VSS.n380 50.1677
R1630 VSS.n385 VSS.t15 50.1677
R1631 VSS.n390 VSS.t473 50.1677
R1632 VSS.t94 VSS.n395 50.1677
R1633 VSS.t572 VSS.n400 50.1677
R1634 VSS.t368 VSS.n405 50.1677
R1635 VSS.n410 VSS.t187 50.1677
R1636 VSS.n415 VSS.t192 50.1677
R1637 VSS.t170 VSS.n420 50.1677
R1638 VSS.t583 VSS.n545 49.3606
R1639 VSS.n853 VSS.t249 47.4535
R1640 VSS.t623 VSS.n561 47.1669
R1641 VSS.n736 VSS.t625 47.1669
R1642 VSS.n716 VSS.t339 46.116
R1643 VSS.t518 VSS.n676 46.1031
R1644 VSS.n674 VSS.t524 46.1011
R1645 VSS.t446 VSS.n536 44.9731
R1646 VSS.n704 VSS.t281 44.1903
R1647 VSS.n690 VSS.t338 44.1903
R1648 VSS.t598 VSS.n2 43.0642
R1649 VSS.t591 VSS.n0 43.0619
R1650 VSS.t43 VSS.n620 42.3769
R1651 VSS.t247 VSS.n848 39.9582
R1652 VSS.t528 VSS.n671 39.6761
R1653 VSS.n693 VSS.t577 39.1873
R1654 VSS.n550 VSS.t446 38.3917
R1655 VSS.n509 VSS.t313 36.7898
R1656 VSS.t568 VSS.n503 36.7898
R1657 VSS.n498 VSS.t461 36.7898
R1658 VSS.t399 VSS.n493 36.7898
R1659 VSS.t299 VSS.n488 36.7898
R1660 VSS.n483 VSS.t422 36.7898
R1661 VSS.n478 VSS.t41 36.7898
R1662 VSS.n473 VSS.t438 36.7898
R1663 VSS.n468 VSS.t308 36.7898
R1664 VSS.t371 VSS.n463 36.7898
R1665 VSS.n458 VSS.t416 36.7898
R1666 VSS.n453 VSS.t331 36.7898
R1667 VSS.n448 VSS.t406 36.7898
R1668 VSS.n443 VSS.t258 36.7898
R1669 VSS.n438 VSS.t302 36.7898
R1670 VSS.n433 VSS.t471 36.7898
R1671 VSS.n846 VSS.t580 36.5305
R1672 VSS.n672 VSS.t528 36.465
R1673 VSS.n848 VSS.t433 36.2105
R1674 VSS.n726 VSS.t623 36.1979
R1675 VSS.t625 VSS.n531 36.1979
R1676 VSS.n176 VSS.t273 34.07
R1677 VSS.n771 VSS.t583 34.0042
R1678 VSS.t343 VSS.n710 33.9067
R1679 VSS.t341 VSS.n621 31.1596
R1680 VSS.n677 VSS.t518 30.0445
R1681 VSS.t524 VSS.n673 30.0445
R1682 VSS.t311 VSS.n853 28.7152
R1683 VSS.n847 VSS.n175 28.3058
R1684 VSS.t53 VSS.n117 28.2938
R1685 VSS.t374 VSS.n125 28.2938
R1686 VSS.t178 VSS.n112 28.2938
R1687 VSS.t315 VSS.n109 28.2938
R1688 VSS.t467 VSS.n143 28.2938
R1689 VSS.t251 VSS.n148 28.2938
R1690 VSS.t228 VSS.n105 28.2938
R1691 VSS.t358 VSS.n102 28.2938
R1692 VSS.t291 VSS.n116 28.2938
R1693 VSS.t404 VSS.n115 28.2938
R1694 VSS.t216 VSS.n136 28.2938
R1695 VSS.t317 VSS.n147 28.2938
R1696 VSS.t181 VSS.n154 28.2938
R1697 VSS.t230 VSS.n90 28.2938
R1698 VSS.t566 VSS.n162 28.2936
R1699 VSS.t25 VSS.n160 28.2936
R1700 VSS.n118 VSS.t415 28.0352
R1701 VSS.n6 VSS.t409 27.7516
R1702 VSS.t424 VSS.n693 27.6043
R1703 VSS.t450 VSS.n533 27.4228
R1704 VSS.n188 VSS.t246 27.2918
R1705 VSS.t453 VSS.n553 25.229
R1706 VSS.t337 VSS.n625 24.4565
R1707 VSS.n717 VSS.t75 22.3643
R1708 VSS.t283 VSS.n694 22.2881
R1709 VSS.n634 VSS.t37 22.2881
R1710 VSS.n259 VSS.t213 22.1486
R1711 VSS.t466 VSS.n257 22.1466
R1712 VSS.t606 VSS.n119 21.6048
R1713 VSS.t286 VSS.n622 21.1887
R1714 VSS.t520 VSS.n675 20.4137
R1715 VSS.n675 VSS.t522 20.4123
R1716 VSS.t569 VSS.n349 20.0674
R1717 VSS.t462 VSS.n354 20.0674
R1718 VSS.t400 VSS.n359 20.0674
R1719 VSS.t300 VSS.n364 20.0674
R1720 VSS.t423 VSS.n369 20.0674
R1721 VSS.t39 VSS.n374 20.0674
R1722 VSS.t437 VSS.n379 20.0674
R1723 VSS.t309 VSS.n384 20.0674
R1724 VSS.t372 VSS.n389 20.0674
R1725 VSS.t417 VSS.n394 20.0674
R1726 VSS.t332 VSS.n399 20.0674
R1727 VSS.t407 VSS.n404 20.0674
R1728 VSS.t260 VSS.n409 20.0674
R1729 VSS.t304 VSS.n414 20.0674
R1730 VSS.t472 VSS.n419 20.0674
R1731 VSS.t241 VSS.n424 20.0674
R1732 VSS.t363 VSS.t364 19.9423
R1733 VSS.n173 VSS.t564 18.0025
R1734 VSS.n171 VSS.t443 18.0025
R1735 VSS.n170 VSS.t386 18.0025
R1736 VSS.n169 VSS.t440 18.0025
R1737 VSS.n168 VSS.t65 18.0025
R1738 VSS.t571 VSS.n166 18.0025
R1739 VSS.n158 VSS.t383 18.0025
R1740 VSS.n120 VSS.t201 18.0017
R1741 VSS.n122 VSS.t436 18.0017
R1742 VSS.n126 VSS.t255 18.0017
R1743 VSS.t381 VSS.n127 18.0017
R1744 VSS.n129 VSS.t616 18.0017
R1745 VSS.n132 VSS.t361 18.0017
R1746 VSS.n134 VSS.t344 18.0017
R1747 VSS.n137 VSS.t99 18.0017
R1748 VSS.n138 VSS.t222 18.0017
R1749 VSS.n139 VSS.t215 18.0017
R1750 VSS.n141 VSS.t360 18.0017
R1751 VSS.n144 VSS.t398 18.0017
R1752 VSS.n146 VSS.t277 18.0017
R1753 VSS.n149 VSS.t243 18.0017
R1754 VSS.t418 VSS.n106 18.0017
R1755 VSS.t244 VSS.n104 18.0017
R1756 VSS.n151 VSS.t385 18.0017
R1757 VSS.t29 VSS.n101 18.0017
R1758 VSS.n153 VSS.t329 18.0017
R1759 VSS.t310 VSS.n99 18.0017
R1760 VSS.t408 VSS.n98 18.0017
R1761 VSS.t575 VSS.n96 18.0017
R1762 VSS.t256 VSS.n95 18.0017
R1763 VSS.t441 VSS.n93 18.0017
R1764 VSS.t576 VSS.n91 18.0017
R1765 VSS.t459 VSS.n857 17.4722
R1766 VSS.n88 VSS.n517 17.0005
R1767 VSS.n88 VSS.n849 17.0005
R1768 VSS.n88 VSS.n850 17.0005
R1769 VSS.n88 VSS.n852 17.0005
R1770 VSS.n88 VSS.n854 17.0005
R1771 VSS.n88 VSS.n856 17.0005
R1772 VSS.n88 VSS.n515 17.0005
R1773 VSS.n88 VSS.t240 17.0005
R1774 VSS.n858 VSS.n88 17.0005
R1775 VSS.n88 VSS.n157 17.0005
R1776 VSS.n294 VSS.n292 17.0005
R1777 VSS.n863 VSS.n293 17.0005
R1778 VSS.n866 VSS.n865 17.0005
R1779 VSS.n867 VSS.n866 17.0005
R1780 VSS.n280 VSS.n278 17.0005
R1781 VSS.n872 VSS.n279 17.0005
R1782 VSS.n875 VSS.n874 17.0005
R1783 VSS.n876 VSS.n875 17.0005
R1784 VSS.n266 VSS.n264 17.0005
R1785 VSS.n881 VSS.n265 17.0005
R1786 VSS.n884 VSS.n883 17.0005
R1787 VSS.n885 VSS.n884 17.0005
R1788 VSS.n887 VSS.n261 17.0005
R1789 VSS.n887 VSS.n258 17.0005
R1790 VSS.n252 VSS.n242 17.0005
R1791 VSS.n890 VSS.n237 17.0005
R1792 VSS.n240 VSS.n236 17.0005
R1793 VSS.n238 VSS.n236 17.0005
R1794 VSS.n230 VSS.n225 17.0005
R1795 VSS.n896 VSS.n220 17.0005
R1796 VSS.n223 VSS.n219 17.0005
R1797 VSS.n221 VSS.n219 17.0005
R1798 VSS.n209 VSS.n207 17.0005
R1799 VSS.n902 VSS.n208 17.0005
R1800 VSS.n905 VSS.n904 17.0005
R1801 VSS.n906 VSS.n905 17.0005
R1802 VSS.n908 VSS.n185 17.0005
R1803 VSS.n908 VSS.n202 17.0005
R1804 VSS.n908 VSS.n201 17.0005
R1805 VSS.n908 VSS.n189 17.0005
R1806 VSS.n908 VSS.n200 17.0005
R1807 VSS.n908 VSS.n191 17.0005
R1808 VSS.n908 VSS.n198 17.0005
R1809 VSS.n908 VSS.n193 17.0005
R1810 VSS.n88 VSS.n340 17.0005
R1811 VSS.n88 VSS.n342 17.0005
R1812 VSS.t93 VSS.n705 17.0005
R1813 VSS.t93 VSS.n61 13.5064
R1814 VSS.n704 VSS.t198 17.0005
R1815 VSS.n702 VSS.t198 17.0005
R1816 VSS.n699 VSS.t198 17.0005
R1817 VSS.n696 VSS.n64 17.0005
R1818 VSS.n692 VSS.n64 17.0005
R1819 VSS.n66 VSS.n64 13.5064
R1820 VSS.n690 VSS.t200 17.0005
R1821 VSS.n688 VSS.t200 17.0005
R1822 VSS.n685 VSS.t200 17.0005
R1823 VSS.n684 VSS.n683 17.0005
R1824 VSS.n683 VSS.n681 17.0005
R1825 VSS.t13 VSS.n820 17.0005
R1826 VSS.t13 VSS.n620 17.0005
R1827 VSS.t13 VSS.n621 17.0005
R1828 VSS.t13 VSS.n716 17.0005
R1829 VSS.t13 VSS.n622 17.0005
R1830 VSS.t13 VSS.n715 17.0005
R1831 VSS.n646 VSS.n645 17.0005
R1832 VSS.n821 VSS.t13 17.0005
R1833 VSS.t13 VSS.n630 17.0005
R1834 VSS.t13 VSS.n711 17.0005
R1835 VSS.n7 VSS.n588 17.0005
R1836 VSS.n7 VSS.n592 17.0005
R1837 VSS.n7 VSS.n595 17.0005
R1838 VSS.n7 VSS.n610 17.0005
R1839 VSS.n7 VSS.n608 17.0005
R1840 VSS.n7 VSS.n4 17.0005
R1841 VSS.n718 VSS.n33 17.0005
R1842 VSS.n772 VSS.n33 17.0005
R1843 VSS.n545 VSS.n33 17.0005
R1844 VSS.n771 VSS.n33 17.0005
R1845 VSS.n768 VSS.n33 17.0005
R1846 VSS.n769 VSS.n33 17.0005
R1847 VSS.n763 VSS.n33 17.0005
R1848 VSS.n549 VSS.n33 17.0005
R1849 VSS.n538 VSS.n33 17.0005
R1850 VSS.n761 VSS.n33 17.0005
R1851 VSS.n759 VSS.n33 17.0005
R1852 VSS.n550 VSS.n33 17.0005
R1853 VSS.n536 VSS.n33 17.0005
R1854 VSS.n754 VSS.n33 17.0005
R1855 VSS.n747 VSS.n33 17.0005
R1856 VSS.n748 VSS.n33 17.0005
R1857 VSS.n746 VSS.n33 17.0005
R1858 VSS.n553 VSS.n33 17.0005
R1859 VSS.n744 VSS.n33 17.0005
R1860 VSS.n742 VSS.n33 17.0005
R1861 VSS.n533 VSS.n33 17.0005
R1862 VSS.n555 VSS.n33 17.0005
R1863 VSS.n740 VSS.n33 17.0005
R1864 VSS.n737 VSS.n33 17.0005
R1865 VSS.n738 VSS.n33 17.0005
R1866 VSS.n736 VSS.n33 17.0005
R1867 VSS.n531 VSS.n33 17.0005
R1868 VSS.n734 VSS.n33 17.0005
R1869 VSS.n732 VSS.n33 17.0005
R1870 VSS.n559 VSS.n33 17.0005
R1871 VSS.n530 VSS.n33 17.0005
R1872 VSS.n730 VSS.n33 17.0005
R1873 VSS.n727 VSS.n33 17.0005
R1874 VSS.n728 VSS.n33 17.0005
R1875 VSS.n726 VSS.n33 17.0005
R1876 VSS.n561 VSS.n33 17.0005
R1877 VSS.n724 VSS.n33 17.0005
R1878 VSS.n722 VSS.n33 17.0005
R1879 VSS.n527 VSS.n33 17.0005
R1880 VSS.n562 VSS.n33 17.0005
R1881 VSS.n720 VSS.n33 17.0005
R1882 VSS.n519 VSS.n33 17.0005
R1883 VSS.n12 VSS.n562 17.0005
R1884 VSS.n12 VSS.n527 17.0005
R1885 VSS.n12 VSS.n561 17.0005
R1886 VSS.n12 VSS.n530 17.0005
R1887 VSS.n12 VSS.n559 17.0005
R1888 VSS.n12 VSS.n531 17.0005
R1889 VSS.n12 VSS.n555 17.0005
R1890 VSS.n12 VSS.n533 17.0005
R1891 VSS.n12 VSS.n553 17.0005
R1892 VSS.n12 VSS.n535 17.0005
R1893 VSS.n12 VSS.n536 17.0005
R1894 VSS.n12 VSS.n550 17.0005
R1895 VSS.n12 VSS.n538 17.0005
R1896 VSS.n12 VSS.n549 17.0005
R1897 VSS.n817 VSS.n519 17.0005
R1898 VSS.n817 VSS.n726 17.0005
R1899 VSS.n817 VSS.n736 17.0005
R1900 VSS.n817 VSS.n746 17.0005
R1901 VSS.n817 VSS.n753 17.0005
R1902 VSS.n817 VSS.n771 17.0005
R1903 VSS.n12 VSS.n540 17.0005
R1904 VSS.n16 VSS.n786 17.0005
R1905 VSS.n787 VSS.n16 17.0005
R1906 VSS.n12 VSS.n545 17.0005
R1907 VSS.n12 VSS.n543 17.0005
R1908 VSS.n580 VSS.n33 17.0005
R1909 VSS.n12 VSS.n541 17.0005
R1910 VSS.n559 VSS.t624 16.4539
R1911 VSS.n190 VSS.t206 16.3876
R1912 VSS.n60 VSS.n520 16.2018
R1913 VSS.n822 VSS.n3 14.9664
R1914 VSS.t448 VSS.n538 14.2601
R1915 VSS.t530 VSS.n73 13.9916
R1916 VSS.n855 VSS.t414 13.7246
R1917 VSS.t580 VSS.t274 13.4836
R1918 VSS.n720 VSS.n563 12.0761
R1919 VSS.n722 VSS.n528 12.0761
R1920 VSS.n726 VSS.n560 12.0761
R1921 VSS.n730 VSS.n529 12.0761
R1922 VSS.n732 VSS.n558 12.0761
R1923 VSS.n738 VSS.n557 12.0761
R1924 VSS.n740 VSS.n556 12.0761
R1925 VSS.n744 VSS.n554 12.0761
R1926 VSS.n748 VSS.n534 12.0761
R1927 VSS.n747 VSS.n552 12.0761
R1928 VSS.n761 VSS.n537 12.0761
R1929 VSS.n763 VSS.n548 12.0761
R1930 VSS.n721 VSS.n562 12.0761
R1931 VSS.n723 VSS.n722 12.0761
R1932 VSS.n725 VSS.n561 12.0761
R1933 VSS.n729 VSS.n727 12.0761
R1934 VSS.n731 VSS.n530 12.0761
R1935 VSS.n733 VSS.n732 12.0761
R1936 VSS.n735 VSS.n531 12.0761
R1937 VSS.n739 VSS.n737 12.0761
R1938 VSS.n741 VSS.n555 12.0761
R1939 VSS.n743 VSS.n742 12.0761
R1940 VSS.n745 VSS.n553 12.0761
R1941 VSS.n749 VSS.n747 12.0761
R1942 VSS.n755 VSS.n536 12.0761
R1943 VSS.n760 VSS.n759 12.0761
R1944 VSS.n762 VSS.n538 12.0761
R1945 VSS.n764 VSS.n763 12.0761
R1946 VSS.n770 VSS.n768 12.0761
R1947 VSS.n773 VSS.n772 12.0761
R1948 VSS.n771 VSS.n547 12.0761
R1949 VSS.n718 VSS.n544 12.0761
R1950 VSS.n563 VSS.n519 12.0761
R1951 VSS.n721 VSS.n720 12.0761
R1952 VSS.n723 VSS.n527 12.0761
R1953 VSS.n724 VSS.n528 12.0761
R1954 VSS.n725 VSS.n724 12.0761
R1955 VSS.n728 VSS.n560 12.0761
R1956 VSS.n729 VSS.n728 12.0761
R1957 VSS.n727 VSS.n529 12.0761
R1958 VSS.n731 VSS.n730 12.0761
R1959 VSS.n733 VSS.n559 12.0761
R1960 VSS.n734 VSS.n558 12.0761
R1961 VSS.n735 VSS.n734 12.0761
R1962 VSS.n736 VSS.n557 12.0761
R1963 VSS.n739 VSS.n738 12.0761
R1964 VSS.n737 VSS.n556 12.0761
R1965 VSS.n741 VSS.n740 12.0761
R1966 VSS.n743 VSS.n533 12.0761
R1967 VSS.n742 VSS.n554 12.0761
R1968 VSS.n745 VSS.n744 12.0761
R1969 VSS.n746 VSS.n534 12.0761
R1970 VSS.n749 VSS.n748 12.0761
R1971 VSS.n754 VSS.n552 12.0761
R1972 VSS.n755 VSS.n754 12.0761
R1973 VSS.n760 VSS.n550 12.0761
R1974 VSS.n759 VSS.n537 12.0761
R1975 VSS.n762 VSS.n761 12.0761
R1976 VSS.n764 VSS.n549 12.0761
R1977 VSS.n769 VSS.n548 12.0761
R1978 VSS.n770 VSS.n769 12.0761
R1979 VSS.n768 VSS.n547 12.0761
R1980 VSS.n773 VSS.n545 12.0761
R1981 VSS.n772 VSS.n544 12.0761
R1982 VSS.n818 VSS.n718 11.454
R1983 VSS.n819 VSS.n818 11.454
R1984 VSS.t515 VSS.n677 10.7797
R1985 VSS.n673 VSS.t526 10.7787
R1986 VSS.n802 VSS.n579 9.81803
R1987 VSS.n833 VSS.n579 9.39094
R1988 VSS.n831 VSS.n830 9.38916
R1989 VSS.n597 VSS.t47 9.08698
R1990 VSS.t47 VSS.n596 9.0445
R1991 VSS.n824 VSS.n823 9.0005
R1992 VSS.n824 VSS.n583 9.0005
R1993 VSS.n587 VSS.n582 9.0005
R1994 VSS.n780 VSS.n582 9.0005
R1995 VSS.t167 VSS.n861 8.501
R1996 VSS.n862 VSS.t165 8.501
R1997 VSS.t163 VSS.n291 8.501
R1998 VSS.t160 VSS.n283 8.501
R1999 VSS.t156 VSS.n870 8.501
R2000 VSS.n871 VSS.t154 8.501
R2001 VSS.t152 VSS.n277 8.501
R2002 VSS.t81 VSS.n269 8.501
R2003 VSS.t146 VSS.n879 8.501
R2004 VSS.n880 VSS.t144 8.501
R2005 VSS.t142 VSS.n263 8.501
R2006 VSS.t139 VSS.n246 8.501
R2007 VSS.t20 VSS.n888 8.501
R2008 VSS.n889 VSS.t134 8.501
R2009 VSS.t132 VSS.n891 8.501
R2010 VSS.n892 VSS.t129 8.501
R2011 VSS.t125 VSS.n894 8.501
R2012 VSS.n895 VSS.t123 8.501
R2013 VSS.t121 VSS.n897 8.501
R2014 VSS.n898 VSS.t78 8.501
R2015 VSS.t115 VSS.n900 8.501
R2016 VSS.n901 VSS.t113 8.501
R2017 VSS.t111 VSS.n206 8.501
R2018 VSS.t108 VSS.n182 8.501
R2019 VSS.n796 VSS.n34 1.54642
R2020 VSS.n36 VSS.n38 0.00158329
R2021 VSS.n796 VSS.n42 2.4296
R2022 VSS.n796 VSS.n45 4.25113
R2023 VSS.n796 VSS.n48 3.40102
R2024 VSS.n796 VSS.n51 4.251
R2025 VSS.n51 VSS.n50 0.00149997
R2026 VSS.n796 VSS.n54 3.40102
R2027 VSS.n796 VSS.n57 2.4296
R2028 VSS.n845 VSS.n523 8.501
R2029 VSS.n845 VSS.n21 4.251
R2030 VSS.n21 VSS.n20 0.00149997
R2031 VSS.n845 VSS.n23 2.83417
R2032 VSS.n23 VSS.n22 0.00166658
R2033 VSS.n22 VSS.n24 0.00149997
R2034 VSS.n845 VSS.n25 3.40102
R2035 VSS.n845 VSS.n27 1.21524
R2036 VSS.n29 VSS.n30 0.0016189
R2037 VSS.n698 VSS.n63 406.622
R2038 VSS.n68 VSS.n67 406.622
R2039 VSS.n70 VSS.n68 0.00235708
R2040 VSS.n670 VSS.n73 1.22361
R2041 VSS.n72 VSS.n74 0.00172462
R2042 VSS.n74 VSS.n75 0.00170812
R2043 VSS.n75 VSS.n76 0.00166658
R2044 VSS.n76 VSS.n77 0.00149997
R2045 VSS.n670 VSS.n78 3.40102
R2046 VSS.n670 VSS.n80 3.40102
R2047 VSS.n670 VSS.n82 3.40102
R2048 VSS.n670 VSS.n84 3.40102
R2049 VSS.n8 VSS.n822 4.252
R2050 VSS.n8 VSS.n7 0.00116666
R2051 VSS.n819 VSS.n11 3.40102
R2052 VSS.n14 VSS.n13 0.00216499
R2053 VSS.n13 VSS.n15 0.00173273
R2054 VSS.n15 VSS.n16 0.00172462
R2055 VSS.n16 VSS.n17 0.00170812
R2056 VSS.n17 VSS.n18 0.00166658
R2057 VSS.n18 VSS.n19 0.00149997
R2058 VSS.n819 VSS.n33 8.501
R2059 VSS.n88 VSS.n514 8.5005
R2060 VSS.n88 VSS.n509 8.5005
R2061 VSS.n88 VSS.n345 8.5005
R2062 VSS.n88 VSS.n507 8.5005
R2063 VSS.n88 VSS.n506 8.5005
R2064 VSS.n88 VSS.n346 8.5005
R2065 VSS.n88 VSS.n505 8.5005
R2066 VSS.n88 VSS.n348 8.5005
R2067 VSS.n88 VSS.n504 8.5005
R2068 VSS.n88 VSS.n349 8.5005
R2069 VSS.n88 VSS.n503 8.5005
R2070 VSS.n88 VSS.n350 8.5005
R2071 VSS.n88 VSS.n502 8.5005
R2072 VSS.n88 VSS.n501 8.5005
R2073 VSS.n88 VSS.n351 8.5005
R2074 VSS.n88 VSS.n500 8.5005
R2075 VSS.n88 VSS.n353 8.5005
R2076 VSS.n88 VSS.n499 8.5005
R2077 VSS.n88 VSS.n354 8.5005
R2078 VSS.n88 VSS.n498 8.5005
R2079 VSS.n88 VSS.n355 8.5005
R2080 VSS.n88 VSS.n497 8.5005
R2081 VSS.n88 VSS.n496 8.5005
R2082 VSS.n88 VSS.n356 8.5005
R2083 VSS.n88 VSS.n495 8.5005
R2084 VSS.n88 VSS.n358 8.5005
R2085 VSS.n88 VSS.n494 8.5005
R2086 VSS.n88 VSS.n359 8.5005
R2087 VSS.n88 VSS.n493 8.5005
R2088 VSS.n88 VSS.n360 8.5005
R2089 VSS.n88 VSS.n492 8.5005
R2090 VSS.n88 VSS.n491 8.5005
R2091 VSS.n88 VSS.n361 8.5005
R2092 VSS.n88 VSS.n490 8.5005
R2093 VSS.n88 VSS.n363 8.5005
R2094 VSS.n88 VSS.n489 8.5005
R2095 VSS.n88 VSS.n364 8.5005
R2096 VSS.n88 VSS.n488 8.5005
R2097 VSS.n88 VSS.n365 8.5005
R2098 VSS.n88 VSS.n487 8.5005
R2099 VSS.n88 VSS.n486 8.5005
R2100 VSS.n88 VSS.n366 8.5005
R2101 VSS.n88 VSS.n485 8.5005
R2102 VSS.n88 VSS.n368 8.5005
R2103 VSS.n88 VSS.n484 8.5005
R2104 VSS.n88 VSS.n369 8.5005
R2105 VSS.n88 VSS.n483 8.5005
R2106 VSS.n88 VSS.n370 8.5005
R2107 VSS.n88 VSS.n482 8.5005
R2108 VSS.n88 VSS.n481 8.5005
R2109 VSS.n88 VSS.n371 8.5005
R2110 VSS.n88 VSS.n480 8.5005
R2111 VSS.n88 VSS.n373 8.5005
R2112 VSS.n88 VSS.n479 8.5005
R2113 VSS.n88 VSS.n374 8.5005
R2114 VSS.n88 VSS.n478 8.5005
R2115 VSS.n88 VSS.n375 8.5005
R2116 VSS.n88 VSS.n477 8.5005
R2117 VSS.n88 VSS.n476 8.5005
R2118 VSS.n88 VSS.n376 8.5005
R2119 VSS.n88 VSS.n475 8.5005
R2120 VSS.n88 VSS.n378 8.5005
R2121 VSS.n88 VSS.n474 8.5005
R2122 VSS.n88 VSS.n379 8.5005
R2123 VSS.n88 VSS.n473 8.5005
R2124 VSS.n88 VSS.n380 8.5005
R2125 VSS.n88 VSS.n472 8.5005
R2126 VSS.n88 VSS.n471 8.5005
R2127 VSS.n88 VSS.n381 8.5005
R2128 VSS.n88 VSS.n470 8.5005
R2129 VSS.n88 VSS.n383 8.5005
R2130 VSS.n88 VSS.n469 8.5005
R2131 VSS.n88 VSS.n384 8.5005
R2132 VSS.n88 VSS.n468 8.5005
R2133 VSS.n88 VSS.n385 8.5005
R2134 VSS.n88 VSS.n467 8.5005
R2135 VSS.n88 VSS.n466 8.5005
R2136 VSS.n88 VSS.n386 8.5005
R2137 VSS.n88 VSS.n465 8.5005
R2138 VSS.n88 VSS.n388 8.5005
R2139 VSS.n88 VSS.n464 8.5005
R2140 VSS.n88 VSS.n389 8.5005
R2141 VSS.n88 VSS.n463 8.5005
R2142 VSS.n88 VSS.n390 8.5005
R2143 VSS.n88 VSS.n462 8.5005
R2144 VSS.n88 VSS.n461 8.5005
R2145 VSS.n88 VSS.n391 8.5005
R2146 VSS.n88 VSS.n460 8.5005
R2147 VSS.n88 VSS.n393 8.5005
R2148 VSS.n88 VSS.n459 8.5005
R2149 VSS.n88 VSS.n394 8.5005
R2150 VSS.n88 VSS.n458 8.5005
R2151 VSS.n88 VSS.n395 8.5005
R2152 VSS.n88 VSS.n457 8.5005
R2153 VSS.n88 VSS.n456 8.5005
R2154 VSS.n88 VSS.n396 8.5005
R2155 VSS.n88 VSS.n455 8.5005
R2156 VSS.n88 VSS.n398 8.5005
R2157 VSS.n88 VSS.n454 8.5005
R2158 VSS.n88 VSS.n399 8.5005
R2159 VSS.n88 VSS.n453 8.5005
R2160 VSS.n88 VSS.n400 8.5005
R2161 VSS.n88 VSS.n452 8.5005
R2162 VSS.n88 VSS.n451 8.5005
R2163 VSS.n88 VSS.n401 8.5005
R2164 VSS.n88 VSS.n450 8.5005
R2165 VSS.n88 VSS.n403 8.5005
R2166 VSS.n88 VSS.n449 8.5005
R2167 VSS.n88 VSS.n404 8.5005
R2168 VSS.n88 VSS.n448 8.5005
R2169 VSS.n88 VSS.n405 8.5005
R2170 VSS.n88 VSS.n447 8.5005
R2171 VSS.n88 VSS.n446 8.5005
R2172 VSS.n88 VSS.n406 8.5005
R2173 VSS.n88 VSS.n445 8.5005
R2174 VSS.n88 VSS.n408 8.5005
R2175 VSS.n88 VSS.n444 8.5005
R2176 VSS.n88 VSS.n409 8.5005
R2177 VSS.n88 VSS.n443 8.5005
R2178 VSS.n88 VSS.n410 8.5005
R2179 VSS.n88 VSS.n442 8.5005
R2180 VSS.n88 VSS.n441 8.5005
R2181 VSS.n88 VSS.n411 8.5005
R2182 VSS.n88 VSS.n440 8.5005
R2183 VSS.n88 VSS.n413 8.5005
R2184 VSS.n88 VSS.n439 8.5005
R2185 VSS.n88 VSS.n414 8.5005
R2186 VSS.n88 VSS.n438 8.5005
R2187 VSS.n88 VSS.n415 8.5005
R2188 VSS.n88 VSS.n437 8.5005
R2189 VSS.n88 VSS.n436 8.5005
R2190 VSS.n88 VSS.n416 8.5005
R2191 VSS.n88 VSS.n435 8.5005
R2192 VSS.n88 VSS.n418 8.5005
R2193 VSS.n88 VSS.n434 8.5005
R2194 VSS.n88 VSS.n419 8.5005
R2195 VSS.n88 VSS.n433 8.5005
R2196 VSS.n88 VSS.n420 8.5005
R2197 VSS.n88 VSS.n432 8.5005
R2198 VSS.n88 VSS.n431 8.5005
R2199 VSS.n88 VSS.n421 8.5005
R2200 VSS.n88 VSS.n430 8.5005
R2201 VSS.n88 VSS.n423 8.5005
R2202 VSS.n88 VSS.n429 8.5005
R2203 VSS.n88 VSS.n424 8.5005
R2204 VSS.n88 VSS.n427 8.5005
R2205 VSS.n7 VSS.n611 8.5005
R2206 VSS.n7 VSS.n600 8.5005
R2207 VSS.n585 VSS.n7 8.48883
R2208 VSS.n7 VSS.n584 8.48883
R2209 VSS.n88 VSS.n428 8.48012
R2210 VSS.t547 VSS.n74 8.47784
R2211 VSS.n657 VSS.n75 8.47784
R2212 VSS.n658 VSS.n76 8.47784
R2213 VSS.n659 VSS.n77 8.47784
R2214 VSS.n662 VSS.n79 8.47784
R2215 VSS.n664 VSS.n81 8.47784
R2216 VSS.n666 VSS.n83 8.47784
R2217 VSS.n668 VSS.n85 8.47784
R2218 VSS.n71 VSS.t531 8.47784
R2219 VSS.n88 VSS.n344 8.47732
R2220 VSS.n88 VSS.t609 8.47732
R2221 VSS.n87 VSS.n86 4.19564
R2222 VSS.n88 VSS.n306 8.47732
R2223 VSS.n88 VSS.n307 8.47732
R2224 VSS.n88 VSS.n341 8.47732
R2225 VSS.n799 VSS.n33 8.47732
R2226 VSS.n576 VSS.n33 8.47732
R2227 VSS.t581 VSS.n35 8.47732
R2228 VSS.n803 VSS.n36 8.47732
R2229 VSS.n804 VSS.n38 8.47732
R2230 VSS.n805 VSS.n37 8.47732
R2231 VSS.n807 VSS.n41 8.47732
R2232 VSS.n808 VSS.n40 8.47732
R2233 VSS.n809 VSS.n43 8.47732
R2234 VSS.n795 VSS.n45 8.47732
R2235 VSS.n810 VSS.n47 8.47732
R2236 VSS.n794 VSS.n46 8.47732
R2237 VSS.t390 VSS.n50 8.47732
R2238 VSS.n811 VSS.n53 8.47732
R2239 VSS.n813 VSS.n56 8.47732
R2240 VSS.n814 VSS.n55 8.47732
R2241 VSS.t587 VSS.n574 8.47732
R2242 VSS.t388 VSS.n20 8.47732
R2243 VSS.t393 VSS.n838 8.47732
R2244 VSS.n839 VSS.n22 8.47732
R2245 VSS.n840 VSS.n24 8.47732
R2246 VSS.t395 VSS.n26 8.47732
R2247 VSS.n566 VSS.n28 8.47732
R2248 VSS.t397 VSS.n29 8.47732
R2249 VSS.n565 VSS.n30 8.47732
R2250 VSS.n843 VSS.n31 8.47732
R2251 VSS.n844 VSS.n32 8.47732
R2252 VSS.n656 VSS.n72 8.47732
R2253 VSS.n648 VSS.n72 8.47732
R2254 VSS.n7 VSS.n589 8.47732
R2255 VSS.n7 VSS.n591 8.47732
R2256 VSS.n7 VSS.n593 8.47732
R2257 VSS.n7 VSS.n599 8.47732
R2258 VSS.n7 VSS.n612 8.47732
R2259 VSS.n7 VSS.n601 8.47732
R2260 VSS.n12 VSS.n539 8.47732
R2261 VSS.n817 VSS.n767 8.47732
R2262 VSS.n784 VSS.n13 8.47732
R2263 VSS.n785 VSS.n15 8.47732
R2264 VSS.n788 VSS.n17 8.47732
R2265 VSS.n789 VSS.n18 8.47732
R2266 VSS.n790 VSS.n19 8.47732
R2267 VSS.n707 VSS.n62 8.47111
R2268 VSS.t46 VSS.n65 8.47111
R2269 VSS.n682 VSS.n69 8.47111
R2270 VSS.t340 VSS.n70 8.47111
R2271 VSS.t377 VSS.n33 8.1859
R2272 VSS.n845 VSS.t377 8.1722
R2273 VSS.n829 VSS.n828 6.85916
R2274 VSS.n706 VSS.n520 5.66985
R2275 VSS.n33 VSS.n34 0.00268168
R2276 VSS.n42 VSS.n39 0.0024999
R2277 VSS.n48 VSS.n44 0.00229996
R2278 VSS.n54 VSS.n49 0.00229996
R2279 VSS.n57 VSS.n52 0.0024999
R2280 VSS.n845 VSS.n524 5.66778
R2281 VSS.n845 VSS.n522 5.66778
R2282 VSS.n845 VSS.n525 5.66778
R2283 VSS.n845 VSS.n521 5.66778
R2284 VSS.n845 VSS.n526 5.66778
R2285 VSS.n25 VSS.n841 0.00229996
R2286 VSS.n27 VSS.n567 0.00274984
R2287 VSS.n670 VSS.n637 5.66778
R2288 VSS.n78 VSS.n654 0.00229996
R2289 VSS.n80 VSS.n653 0.00229996
R2290 VSS.n82 VSS.n652 0.00229996
R2291 VSS.n84 VSS.n651 0.00229996
R2292 VSS.n670 VSS.n638 5.66778
R2293 VSS.n670 VSS.n639 5.66778
R2294 VSS.n819 VSS.n14 1.13339
R2295 VSS.n10 VSS.t378 5.66778
R2296 VSS.n11 VSS.n10 0.00313328
R2297 VSS.n30 VSS.n31 0.00151425
R2298 VSS.n63 VSS.n65 0.00137142
R2299 VSS.n88 VSS.n305 5.63915
R2300 VSS.n782 VSS.n781 5.63075
R2301 VSS.n660 VSS.n655 5.62674
R2302 VSS.n661 VSS.n654 5.62674
R2303 VSS.n663 VSS.n653 5.62674
R2304 VSS.n665 VSS.n652 5.62674
R2305 VSS.n667 VSS.n651 5.62674
R2306 VSS.n669 VSS.n650 5.62674
R2307 VSS.n640 VSS.n649 5.62674
R2308 VSS.n797 VSS.n33 5.62581
R2309 VSS.n575 VSS.n33 5.62581
R2310 VSS.n806 VSS.n39 5.62581
R2311 VSS.t389 VSS.n44 5.62581
R2312 VSS.n793 VSS.n49 5.62581
R2313 VSS.n812 VSS.n52 5.62581
R2314 VSS.n815 VSS.n58 5.62581
R2315 VSS.n834 VSS.n573 5.62581
R2316 VSS.t391 VSS.n835 5.62581
R2317 VSS.n572 VSS.n571 5.62581
R2318 VSS.n836 VSS.n570 5.62581
R2319 VSS.n569 VSS.n837 5.62581
R2320 VSS.n568 VSS.n841 5.62581
R2321 VSS.n842 VSS.n567 5.62581
R2322 VSS.n7 VSS.n598 5.62581
R2323 VSS.n817 VSS.n791 5.62252
R2324 VSS.t622 VSS.n527 5.48496
R2325 VSS.n709 VSS.n708 5.13648
R2326 VSS.n627 VSS.t357 4.98596
R2327 VSS.n825 VSS.n824 4.63796
R2328 VSS.n698 VSS.t236 4.49152
R2329 VSS.n67 VSS.t34 4.49152
R2330 VSS.t287 VSS.n709 4.4712
R2331 VSS.n796 VSS.n719 4.25119
R2332 VSS.n7 VSS.n594 4.19238
R2333 VSS.n817 VSS.n774 4.19238
R2334 VSS.n866 VSS.t161 4.19225
R2335 VSS.n875 VSS.t150 4.19225
R2336 VSS.n884 VSS.t140 4.19225
R2337 VSS.t130 VSS.n236 4.19225
R2338 VSS.t119 VSS.n219 4.19225
R2339 VSS.n905 VSS.t109 4.19225
R2340 VSS.n12 VSS.n546 4.19225
R2341 VSS.t335 VSS.n646 4.177
R2342 VSS.n517 VSS.n179 3.84219
R2343 VSS.n909 VSS.t205 3.84041
R2344 VSS.n509 VSS.t510 3.34498
R2345 VSS.n506 VSS.t501 3.34498
R2346 VSS.n503 VSS.t508 3.34498
R2347 VSS.n501 VSS.t548 3.34498
R2348 VSS.n498 VSS.t499 3.34498
R2349 VSS.n496 VSS.t549 3.34498
R2350 VSS.n493 VSS.t512 3.34498
R2351 VSS.n491 VSS.t509 3.34498
R2352 VSS.n488 VSS.t496 3.34498
R2353 VSS.n486 VSS.t550 3.34498
R2354 VSS.n483 VSS.t551 3.34498
R2355 VSS.n481 VSS.t503 3.34498
R2356 VSS.n478 VSS.t506 3.34498
R2357 VSS.n476 VSS.t552 3.34498
R2358 VSS.n473 VSS.t511 3.34498
R2359 VSS.n471 VSS.t505 3.34498
R2360 VSS.n468 VSS.t497 3.34498
R2361 VSS.n466 VSS.t556 3.34498
R2362 VSS.n463 VSS.t555 3.34498
R2363 VSS.n461 VSS.t557 3.34498
R2364 VSS.n458 VSS.t498 3.34498
R2365 VSS.n456 VSS.t558 3.34498
R2366 VSS.n453 VSS.t554 3.34498
R2367 VSS.n451 VSS.t553 3.34498
R2368 VSS.n448 VSS.t502 3.34498
R2369 VSS.n446 VSS.t559 3.34498
R2370 VSS.n443 VSS.t507 3.34498
R2371 VSS.n441 VSS.t500 3.34498
R2372 VSS.n438 VSS.t560 3.34498
R2373 VSS.n436 VSS.t561 3.34498
R2374 VSS.n433 VSS.t504 3.34498
R2375 VSS.n431 VSS.t562 3.34498
R2376 VSS.n7 VSS.n586 3.32697
R2377 VSS.n832 VSS.n33 3.3265
R2378 VSS.n7 VSS.n590 3.32615
R2379 VSS.t267 VSS.t200 3.30696
R2380 VSS.n859 VSS.t102 3.28366
R2381 VSS.n818 VSS.n817 2.77448
R2382 VSS.n825 VSS.n581 2.7456
R2383 VSS.n88 VSS.n343 2.74463
R2384 VSS.n88 VSS.n425 2.7443
R2385 VSS.n88 VSS.t242 2.74402
R2386 VSS.n88 VSS.n508 2.74397
R2387 VSS.n88 VSS.n339 2.74397
R2388 VSS.n7 VSS.n606 2.74397
R2389 VSS.n12 VSS.n563 2.46343
R2390 VSS.n12 VSS.n528 2.46343
R2391 VSS.n12 VSS.n560 2.46343
R2392 VSS.n12 VSS.n529 2.46343
R2393 VSS.n12 VSS.n558 2.46343
R2394 VSS.n12 VSS.n557 2.46343
R2395 VSS.n12 VSS.n556 2.46343
R2396 VSS.n12 VSS.n554 2.46343
R2397 VSS.n12 VSS.n534 2.46343
R2398 VSS.n12 VSS.n552 2.46343
R2399 VSS.n12 VSS.n537 2.46343
R2400 VSS.n12 VSS.n548 2.46343
R2401 VSS.n817 VSS.n721 2.46343
R2402 VSS.n817 VSS.n723 2.46343
R2403 VSS.n817 VSS.n725 2.46343
R2404 VSS.n817 VSS.n729 2.46343
R2405 VSS.n817 VSS.n731 2.46343
R2406 VSS.n817 VSS.n733 2.46343
R2407 VSS.n817 VSS.n735 2.46343
R2408 VSS.n817 VSS.n739 2.46343
R2409 VSS.n817 VSS.n741 2.46343
R2410 VSS.n817 VSS.n743 2.46343
R2411 VSS.n817 VSS.n745 2.46343
R2412 VSS.n817 VSS.n749 2.46343
R2413 VSS.n817 VSS.n755 2.46343
R2414 VSS.n817 VSS.n760 2.46343
R2415 VSS.n817 VSS.n762 2.46343
R2416 VSS.n817 VSS.n764 2.46343
R2417 VSS.n817 VSS.n770 2.46343
R2418 VSS.n817 VSS.n773 2.46343
R2419 VSS.n12 VSS.n547 2.46343
R2420 VSS.n12 VSS.n544 2.46343
R2421 VSS.n295 VSS.n294 2.34876
R2422 VSS.n281 VSS.n280 2.34876
R2423 VSS.n267 VSS.n266 2.34876
R2424 VSS.n243 VSS.n242 2.34876
R2425 VSS.n226 VSS.n225 2.34876
R2426 VSS.n210 VSS.n209 2.34876
R2427 VSS.n12 VSS.n551 2.32483
R2428 VSS.n817 VSS.n758 2.32406
R2429 VSS.n12 VSS.n532 2.00687
R2430 VSS.n817 VSS.n750 2.00612
R2431 VSS.t200 VSS.n631 1.97699
R2432 VSS.t13 VSS.n625 1.88189
R2433 VSS.n646 VSS.n636 1.88189
R2434 VSS.n826 VSS.n825 1.83435
R2435 VSS.t269 VSS.n706 1.80539
R2436 VSS.n801 VSS.n33 1.75689
R2437 VSS.n578 VSS.n33 1.75689
R2438 VSS.n7 VSS.n617 1.75507
R2439 VSS.n683 VSS.t38 1.72297
R2440 VSS.n783 VSS.n780 1.66925
R2441 VSS.n88 VSS.n516 1.63922
R2442 VSS.n88 VSS.n848 1.63922
R2443 VSS.n88 VSS.n853 1.63922
R2444 VSS.n88 VSS.n855 1.63922
R2445 VSS.n88 VSS.n857 1.63922
R2446 VSS.n88 VSS.n347 1.55386
R2447 VSS.n88 VSS.n352 1.55386
R2448 VSS.n88 VSS.n357 1.55386
R2449 VSS.n88 VSS.n362 1.55386
R2450 VSS.n88 VSS.n367 1.55386
R2451 VSS.n88 VSS.n372 1.55386
R2452 VSS.n88 VSS.n377 1.55386
R2453 VSS.n88 VSS.n382 1.55386
R2454 VSS.n88 VSS.n387 1.55386
R2455 VSS.n88 VSS.n392 1.55386
R2456 VSS.n88 VSS.n397 1.55386
R2457 VSS.n88 VSS.n402 1.55386
R2458 VSS.n88 VSS.n407 1.55386
R2459 VSS.n88 VSS.n412 1.55386
R2460 VSS.n88 VSS.n417 1.55386
R2461 VSS.n88 VSS.n422 1.55386
R2462 VSS.n88 VSS.t321 1.55345
R2463 VSS.n88 VSS.t307 1.55345
R2464 VSS.n88 VSS.t88 1.55345
R2465 VSS.n88 VSS.t211 1.55345
R2466 VSS.n88 VSS.t50 1.55345
R2467 VSS.n88 VSS.t42 1.55345
R2468 VSS.n88 VSS.t439 1.55345
R2469 VSS.n88 VSS.t74 1.55345
R2470 VSS.n88 VSS.t85 1.55345
R2471 VSS.n88 VSS.t412 1.55345
R2472 VSS.n88 VSS.t175 1.55345
R2473 VSS.n88 VSS.t71 1.55345
R2474 VSS.n88 VSS.t259 1.55345
R2475 VSS.n88 VSS.t303 1.55345
R2476 VSS.n88 VSS.t327 1.55345
R2477 VSS.n88 VSS.n308 1.55338
R2478 VSS.n88 VSS.n309 1.55338
R2479 VSS.n88 VSS.n310 1.55338
R2480 VSS.n88 VSS.n311 1.55338
R2481 VSS.n88 VSS.n312 1.55338
R2482 VSS.n88 VSS.n313 1.55338
R2483 VSS.n88 VSS.n314 1.55338
R2484 VSS.n88 VSS.n315 1.55338
R2485 VSS.n88 VSS.n316 1.55338
R2486 VSS.n88 VSS.n317 1.55338
R2487 VSS.n88 VSS.n318 1.55338
R2488 VSS.n88 VSS.n319 1.55338
R2489 VSS.n88 VSS.n320 1.55338
R2490 VSS.n88 VSS.n321 1.55338
R2491 VSS.n88 VSS.n322 1.55338
R2492 VSS.n88 VSS.n323 1.55338
R2493 VSS.n88 VSS.n324 1.55338
R2494 VSS.n88 VSS.n325 1.55338
R2495 VSS.n88 VSS.n326 1.55338
R2496 VSS.n88 VSS.n327 1.55338
R2497 VSS.n88 VSS.n328 1.55338
R2498 VSS.n88 VSS.n329 1.55338
R2499 VSS.n88 VSS.n330 1.55338
R2500 VSS.n88 VSS.n331 1.55338
R2501 VSS.n88 VSS.n332 1.55338
R2502 VSS.n88 VSS.n333 1.55338
R2503 VSS.n88 VSS.n334 1.55338
R2504 VSS.n88 VSS.n335 1.55338
R2505 VSS.n88 VSS.n336 1.55338
R2506 VSS.n88 VSS.n337 1.55338
R2507 VSS.n88 VSS.n338 1.55338
R2508 VSS.n641 VSS.n72 1.55041
R2509 VSS.t584 VSS.n775 1.43372
R2510 VSS.t582 VSS.n776 1.43372
R2511 VSS.t584 VSS.n778 1.42949
R2512 VSS.t582 VSS.n777 1.42949
R2513 VSS.t449 VSS.t457 1.41892
R2514 VSS.t447 VSS.t456 1.41892
R2515 VSS.t454 VSS.t455 1.41892
R2516 VSS.t452 VSS.t451 1.41892
R2517 VSS.n908 VSS.n203 1.38589
R2518 VSS.n577 VSS.t579 1.37661
R2519 VSS.t579 VSS.n798 1.37661
R2520 VSS.n827 VSS.n826 1.30942
R2521 VSS.t214 VSS.n244 1.28795
R2522 VSS.n831 VSS.n827 1.26857
R2523 VSS.t547 VSS.t545 1.25698
R2524 VSS.t531 VSS.t529 1.24892
R2525 VSS.n644 VSS.n72 1.24506
R2526 VSS.t59 VSS.t208 1.23805
R2527 VSS.t267 VSS.n632 1.21874
R2528 VSS.t521 VSS.t519 1.1832
R2529 VSS.t535 VSS.t537 1.18293
R2530 VSS.t539 VSS.t537 1.17925
R2531 VSS.t523 VSS.t521 1.17908
R2532 VSS.t533 VSS.t532 1.1778
R2533 VSS.t516 VSS.t517 1.17752
R2534 VSS.t527 VSS.t525 1.17371
R2535 VSS.t543 VSS.t541 1.17364
R2536 VSS.t545 VSS.t543 1.16051
R2537 VSS.t529 VSS.t527 1.15299
R2538 VSS.n629 VSS.t335 1.12123
R2539 VSS.t523 VSS.t525 1.11346
R2540 VSS.t541 VSS.t539 1.11316
R2541 VSS.t535 VSS.t533 1.10881
R2542 VSS.t519 VSS.t516 1.10873
R2543 VSS.t13 VSS.n623 1.09664
R2544 VSS.n633 VSS.t198 1.08287
R2545 VSS.t20 VSS.n244 1.06717
R2546 VSS.n632 VSS.t46 1.0392
R2547 VSS.n181 VSS.t108 1.03359
R2548 VSS.n623 VSS.n624 1.02454
R2549 VSS.n518 VSS.t248 1.02124
R2550 VSS.n851 VSS.t435 1.00712
R2551 VSS.n181 VSS.t203 1.0064
R2552 VSS.n816 VSS.n815 0.986192
R2553 VSS.n180 VSS.t205 0.971887
R2554 VSS.t167 VSS.n296 0.950816
R2555 VSS.n9 VSS.n844 0.932604
R2556 VSS.n629 VSS.t287 0.885254
R2557 VSS.n9 VSS.n564 0.881792
R2558 VSS.n816 VSS.n792 0.873936
R2559 VSS.t139 VSS.n245 0.841394
R2560 VSS.n707 VSS.n633 0.839803
R2561 VSS.t36 VSS.n635 0.832423
R2562 VSS.t590 VSS.t593 0.806856
R2563 VSS.n609 VSS.t597 0.806855
R2564 VSS.t238 VSS.t603 0.806855
R2565 VSS.n607 VSS.t514 0.802775
R2566 VSS.t295 VSS.t54 0.802775
R2567 VSS.t52 VSS.t487 0.802775
R2568 VSS.t91 VSS.t1 0.802775
R2569 VSS.t376 VSS.t297 0.802775
R2570 VSS.t495 VSS.t292 0.802775
R2571 VSS.t10 VSS.t285 0.802775
R2572 VSS.t478 VSS.t405 0.802775
R2573 VSS.t28 VSS.t183 0.802775
R2574 VSS.t8 VSS.t179 0.802775
R2575 VSS.t177 VSS.t352 0.802775
R2576 VSS.t324 VSS.t217 0.802775
R2577 VSS.t219 VSS.t40 0.802775
R2578 VSS.t367 VSS.t221 0.802775
R2579 VSS.t67 VSS.t98 0.802775
R2580 VSS.t186 VSS.t468 0.802775
R2581 VSS.t465 VSS.t3 0.802775
R2582 VSS.t17 VSS.t318 0.802775
R2583 VSS.t33 VSS.t373 0.802775
R2584 VSS.t475 VSS.t22 0.802775
R2585 VSS.t226 VSS.t279 0.802775
R2586 VSS.t96 VSS.t229 0.802775
R2587 VSS.t31 VSS.t333 0.802775
R2588 VSS.t574 VSS.t276 0.802775
R2589 VSS.t271 VSS.t224 0.802775
R2590 VSS.t370 VSS.t5 0.802775
R2591 VSS.t106 VSS.t261 0.802775
R2592 VSS.t189 VSS.t104 0.802775
R2593 VSS.t380 VSS.t56 0.802775
R2594 VSS.t194 VSS.t26 0.802775
R2595 VSS.t24 VSS.t402 0.802775
R2596 VSS.t172 VSS.t231 0.802775
R2597 VSS.t233 VSS.t563 0.802775
R2598 VSS.t62 VSS.t612 0.802775
R2599 VSS.t160 VSS.n282 0.78864
R2600 VSS.t81 VSS.n268 0.78864
R2601 VSS.t129 VSS.n227 0.78864
R2602 VSS.t78 VSS.n211 0.78864
R2603 VSS.n633 VSS.t269 0.756052
R2604 VSS.t36 VSS.t38 0.745166
R2605 VSS.t13 VSS.n629 0.728354
R2606 VSS.t156 VSS.n282 0.724795
R2607 VSS.t146 VSS.n268 0.724795
R2608 VSS.t125 VSS.n227 0.724795
R2609 VSS.t115 VSS.n211 0.724795
R2610 VSS.t613 VSS.t615 0.723599
R2611 VSS.t611 VSS.n304 0.723599
R2612 VSS.n766 VSS.t449 0.722582
R2613 VSS.n757 VSS.t447 0.722582
R2614 VSS.n752 VSS.t454 0.722582
R2615 VSS.n792 VSS.t452 0.722582
R2616 VSS.t457 VSS.n765 0.72222
R2617 VSS.t456 VSS.n756 0.72222
R2618 VSS.t455 VSS.n751 0.72222
R2619 VSS.t451 VSS.n564 0.72222
R2620 VSS.n635 VSS.n647 0.711165
R2621 VSS.t287 VSS.n623 0.699997
R2622 VSS.n245 VSS.t214 0.699882
R2623 VSS.n643 VSS.n642 0.6955
R2624 VSS.n632 VSS.n64 0.662806
R2625 VSS.t340 VSS.t38 0.640524
R2626 VSS.n869 VSS.n282 0.62049
R2627 VSS.n878 VSS.n268 0.62049
R2628 VSS.n893 VSS.n227 0.62049
R2629 VSS.n899 VSS.n211 0.62049
R2630 VSS.n860 VSS.n302 0.613782
R2631 VSS.n869 VSS.n288 0.613782
R2632 VSS.n878 VSS.n274 0.613782
R2633 VSS.n887 VSS.n260 0.613782
R2634 VSS.n887 VSS.n255 0.613782
R2635 VSS.n893 VSS.n233 0.613782
R2636 VSS.n899 VSS.n216 0.613782
R2637 VSS.n908 VSS.n186 0.613782
R2638 VSS.n908 VSS.n188 0.613782
R2639 VSS.n908 VSS.n199 0.613782
R2640 VSS.n908 VSS.n194 0.613782
R2641 VSS.n908 VSS.n195 0.613782
R2642 VSS.n635 VSS.n72 0.599773
R2643 VSS.t602 VSS.n613 0.595317
R2644 VSS.t599 VSS.n614 0.595317
R2645 VSS.t596 VSS.n602 0.595317
R2646 VSS.t592 VSS.n603 0.595317
R2647 VSS.t608 VSS.n510 0.595317
R2648 VSS.t605 VSS.n511 0.595317
R2649 VSS.n682 VSS.n631 0.588545
R2650 VSS.n703 VSS.t198 0.572871
R2651 VSS.n689 VSS.t200 0.572871
R2652 VSS.n647 VSS.n644 0.56503
R2653 VSS.t13 VSS.n628 0.557126
R2654 VSS.n88 VSS.n89 0.556705
R2655 VSS.n12 VSS.n9 0.556483
R2656 VSS.n817 VSS.n816 0.55447
R2657 VSS.n887 VSS.n245 0.554008
R2658 VSS.t203 VSS.n203 0.539958
R2659 VSS.n618 VSS.n617 0.52186
R2660 VSS.t584 VSS.t582 0.492336
R2661 VSS.n697 VSS.n64 0.490843
R2662 VSS.n693 VSS.n64 0.490843
R2663 VSS.n691 VSS.n64 0.490843
R2664 VSS.n683 VSS.n680 0.490843
R2665 VSS.n700 VSS.t198 0.489061
R2666 VSS.n686 VSS.t200 0.489061
R2667 VSS.t54 VSS.n338 0.477689
R2668 VSS.t487 VSS.n337 0.477689
R2669 VSS.t1 VSS.n336 0.477689
R2670 VSS.t297 VSS.n335 0.477689
R2671 VSS.t292 VSS.n334 0.477689
R2672 VSS.t285 VSS.n333 0.477689
R2673 VSS.t405 VSS.n332 0.477689
R2674 VSS.t183 VSS.n331 0.477689
R2675 VSS.t179 VSS.n330 0.477689
R2676 VSS.t352 VSS.n329 0.477689
R2677 VSS.t217 VSS.n328 0.477689
R2678 VSS.t40 VSS.n327 0.477689
R2679 VSS.t221 VSS.n326 0.477689
R2680 VSS.t98 VSS.n325 0.477689
R2681 VSS.t468 VSS.n324 0.477689
R2682 VSS.t3 VSS.n323 0.477689
R2683 VSS.t318 VSS.n322 0.477689
R2684 VSS.t373 VSS.n321 0.477689
R2685 VSS.t22 VSS.n320 0.477689
R2686 VSS.t279 VSS.n319 0.477689
R2687 VSS.t229 VSS.n318 0.477689
R2688 VSS.t333 VSS.n317 0.477689
R2689 VSS.t276 VSS.n316 0.477689
R2690 VSS.t224 VSS.n315 0.477689
R2691 VSS.t5 VSS.n314 0.477689
R2692 VSS.t261 VSS.n313 0.477689
R2693 VSS.t104 VSS.n312 0.477689
R2694 VSS.t56 VSS.n311 0.477689
R2695 VSS.t26 VSS.n310 0.477689
R2696 VSS.t402 VSS.n309 0.477689
R2697 VSS.t231 VSS.n308 0.477689
R2698 VSS.n641 VSS.n581 0.47741
R2699 VSS.t13 VSS.n712 0.477286
R2700 VSS.t13 VSS.n713 0.472981
R2701 VSS.t327 VSS.t24 0.466542
R2702 VSS.t303 VSS.t380 0.466542
R2703 VSS.t259 VSS.t106 0.466542
R2704 VSS.t71 VSS.t271 0.466542
R2705 VSS.t175 VSS.t31 0.466542
R2706 VSS.t412 VSS.t226 0.466542
R2707 VSS.t85 VSS.t33 0.466542
R2708 VSS.t74 VSS.t465 0.466542
R2709 VSS.t439 VSS.t67 0.466542
R2710 VSS.t42 VSS.t219 0.466542
R2711 VSS.t50 VSS.t177 0.466542
R2712 VSS.t211 VSS.t28 0.466542
R2713 VSS.t88 VSS.t10 0.466542
R2714 VSS.t307 VSS.t376 0.466542
R2715 VSS.t321 VSS.t52 0.466542
R2716 VSS.n347 VSS.t295 0.466192
R2717 VSS.n352 VSS.t91 0.466192
R2718 VSS.n357 VSS.t495 0.466192
R2719 VSS.n362 VSS.t478 0.466192
R2720 VSS.n367 VSS.t8 0.466192
R2721 VSS.n372 VSS.t324 0.466192
R2722 VSS.n377 VSS.t367 0.466192
R2723 VSS.n382 VSS.t186 0.466192
R2724 VSS.n387 VSS.t17 0.466192
R2725 VSS.n392 VSS.t475 0.466192
R2726 VSS.n397 VSS.t96 0.466192
R2727 VSS.n402 VSS.t574 0.466192
R2728 VSS.n407 VSS.t370 0.466192
R2729 VSS.n412 VSS.t189 0.466192
R2730 VSS.n417 VSS.t194 0.466192
R2731 VSS.n422 VSS.t172 0.466192
R2732 VSS.n708 VSS.n631 0.465582
R2733 VSS.n647 VSS.t335 0.464894
R2734 VSS.n643 VSS.n641 0.460744
R2735 VSS.n644 VSS.n643 0.455207
R2736 VSS.t233 VSS.n422 0.451785
R2737 VSS.t24 VSS.n417 0.451785
R2738 VSS.t380 VSS.n412 0.451785
R2739 VSS.t106 VSS.n407 0.451785
R2740 VSS.t271 VSS.n402 0.451785
R2741 VSS.t31 VSS.n397 0.451785
R2742 VSS.t226 VSS.n392 0.451785
R2743 VSS.t33 VSS.n387 0.451785
R2744 VSS.t465 VSS.n382 0.451785
R2745 VSS.t67 VSS.n377 0.451785
R2746 VSS.t219 VSS.n372 0.451785
R2747 VSS.t177 VSS.n367 0.451785
R2748 VSS.t28 VSS.n362 0.451785
R2749 VSS.t10 VSS.n357 0.451785
R2750 VSS.t376 VSS.n352 0.451785
R2751 VSS.t52 VSS.n347 0.451785
R2752 VSS.t321 VSS.t91 0.451337
R2753 VSS.t307 VSS.t495 0.451337
R2754 VSS.t88 VSS.t478 0.451337
R2755 VSS.t211 VSS.t8 0.451337
R2756 VSS.t50 VSS.t324 0.451337
R2757 VSS.t42 VSS.t367 0.451337
R2758 VSS.t439 VSS.t186 0.451337
R2759 VSS.t74 VSS.t17 0.451337
R2760 VSS.t85 VSS.t475 0.451337
R2761 VSS.t412 VSS.t96 0.451337
R2762 VSS.t175 VSS.t574 0.451337
R2763 VSS.t71 VSS.t370 0.451337
R2764 VSS.t259 VSS.t189 0.451337
R2765 VSS.t303 VSS.t194 0.451337
R2766 VSS.t327 VSS.t172 0.451337
R2767 VSS.n617 VSS.n616 0.447348
R2768 VSS.n909 VSS.n179 0.44402
R2769 VSS.t487 VSS.n338 0.440228
R2770 VSS.t297 VSS.n336 0.440228
R2771 VSS.t405 VSS.n333 0.440228
R2772 VSS.t183 VSS.n332 0.440228
R2773 VSS.t179 VSS.n331 0.440228
R2774 VSS.t352 VSS.n330 0.440228
R2775 VSS.t221 VSS.n327 0.440228
R2776 VSS.t468 VSS.n325 0.440228
R2777 VSS.t3 VSS.n324 0.440228
R2778 VSS.t318 VSS.n323 0.440228
R2779 VSS.t229 VSS.n319 0.440228
R2780 VSS.t104 VSS.n313 0.440228
R2781 VSS.t26 VSS.n311 0.440228
R2782 VSS.t231 VSS.n309 0.440228
R2783 VSS.t563 VSS.n308 0.440228
R2784 VSS.n310 VSS.t402 0.440228
R2785 VSS.n312 VSS.t56 0.440228
R2786 VSS.n314 VSS.t261 0.440228
R2787 VSS.n315 VSS.t5 0.440228
R2788 VSS.n316 VSS.t224 0.440228
R2789 VSS.n317 VSS.t276 0.440228
R2790 VSS.n318 VSS.t333 0.440228
R2791 VSS.n320 VSS.t279 0.440228
R2792 VSS.n321 VSS.t22 0.440228
R2793 VSS.n322 VSS.t373 0.440228
R2794 VSS.n326 VSS.t98 0.440228
R2795 VSS.n328 VSS.t40 0.440228
R2796 VSS.n329 VSS.t217 0.440228
R2797 VSS.n334 VSS.t285 0.440228
R2798 VSS.n335 VSS.t292 0.440228
R2799 VSS.n337 VSS.t1 0.440228
R2800 VSS.n833 VSS.n578 0.418268
R2801 VSS.n801 VSS.n800 0.418268
R2802 VSS.n800 VSS.n578 0.414988
R2803 VSS.n802 VSS.n801 0.414988
R2804 VSS.n709 VSS.n582 0.41014
R2805 VSS.t93 VSS.n60 0.400619
R2806 VSS.n765 VSS.n551 0.376066
R2807 VSS.n766 VSS.n758 0.375071
R2808 VSS.n7 VSS.n6 0.351198
R2809 VSS.n792 VSS.n750 0.339435
R2810 VSS.n751 VSS.n532 0.338265
R2811 VSS.n564 VSS.n532 0.338019
R2812 VSS.n752 VSS.n750 0.336731
R2813 VSS.n828 VSS.n343 0.329994
R2814 VSS.n606 VSS.n605 0.312321
R2815 VSS.n830 VSS.n829 0.31114
R2816 VSS.n758 VSS.n757 0.307271
R2817 VSS.t113 VSS.n210 0.306378
R2818 VSS.t123 VSS.n226 0.306378
R2819 VSS.t134 VSS.n243 0.306378
R2820 VSS.t144 VSS.n267 0.306378
R2821 VSS.t154 VSS.n281 0.306378
R2822 VSS.t165 VSS.n295 0.306378
R2823 VSS.n756 VSS.n551 0.306341
R2824 VSS.t563 VSS.t242 0.302153
R2825 VSS.n708 VSS.t267 0.298621
R2826 VSS.n180 VSS.n908 0.295237
R2827 VSS.n586 VSS.n583 0.291601
R2828 VSS.n425 VSS.t233 0.290734
R2829 VSS.n780 VSS.n586 0.287886
R2830 VSS.t391 VSS.n834 0.286777
R2831 VSS.n569 VSS.n836 0.286777
R2832 VSS.n836 VSS.n572 0.286439
R2833 VSS.n572 VSS.t391 0.2861
R2834 VSS.n860 VSS.n296 0.282782
R2835 VSS.n661 VSS.n660 0.280152
R2836 VSS.n640 VSS.n669 0.280152
R2837 VSS.t514 VSS.n590 0.2761
R2838 VSS.n508 VSS.t295 0.275961
R2839 VSS.n908 VSS.n181 0.275933
R2840 VSS.n510 VSS.n339 0.272321
R2841 VSS.n513 VSS.n508 0.272065
R2842 VSS.n88 VSS.n118 0.267794
R2843 VSS.n88 VSS.n120 0.267794
R2844 VSS.n88 VSS.n121 0.267794
R2845 VSS.n88 VSS.n122 0.267794
R2846 VSS.n88 VSS.n123 0.267794
R2847 VSS.n88 VSS.n173 0.267794
R2848 VSS.n88 VSS.n124 0.267794
R2849 VSS.n88 VSS.n126 0.267794
R2850 VSS.n88 VSS.n172 0.267794
R2851 VSS.n88 VSS.n127 0.267794
R2852 VSS.n88 VSS.n128 0.267794
R2853 VSS.n88 VSS.n129 0.267794
R2854 VSS.n88 VSS.n130 0.267794
R2855 VSS.n88 VSS.n171 0.267794
R2856 VSS.n88 VSS.n131 0.267794
R2857 VSS.n88 VSS.n132 0.267794
R2858 VSS.n88 VSS.n170 0.267794
R2859 VSS.n88 VSS.n169 0.267794
R2860 VSS.n88 VSS.n133 0.267794
R2861 VSS.n88 VSS.n134 0.267794
R2862 VSS.n88 VSS.n135 0.267794
R2863 VSS.n88 VSS.n137 0.267794
R2864 VSS.n88 VSS.n138 0.267794
R2865 VSS.n88 VSS.n139 0.267794
R2866 VSS.n88 VSS.n140 0.267794
R2867 VSS.n88 VSS.n141 0.267794
R2868 VSS.n88 VSS.n142 0.267794
R2869 VSS.n88 VSS.n144 0.267794
R2870 VSS.n88 VSS.n145 0.267794
R2871 VSS.n88 VSS.n146 0.267794
R2872 VSS.n88 VSS.n168 0.267794
R2873 VSS.n88 VSS.n167 0.267794
R2874 VSS.n88 VSS.n166 0.267794
R2875 VSS.n88 VSS.n149 0.267794
R2876 VSS.n88 VSS.n165 0.267794
R2877 VSS.n88 VSS.n150 0.267794
R2878 VSS.n88 VSS.n151 0.267794
R2879 VSS.n88 VSS.n152 0.267794
R2880 VSS.n88 VSS.n153 0.267794
R2881 VSS.n88 VSS.n164 0.267794
R2882 VSS.n88 VSS.n163 0.267794
R2883 VSS.n88 VSS.n161 0.267794
R2884 VSS.n88 VSS.n159 0.267794
R2885 VSS.n88 VSS.n158 0.267794
R2886 VSS.n88 VSS.n91 0.267794
R2887 VSS.n88 VSS.n92 0.267794
R2888 VSS.n88 VSS.n93 0.267794
R2889 VSS.n88 VSS.n94 0.267794
R2890 VSS.n88 VSS.n95 0.267794
R2891 VSS.n88 VSS.n96 0.267794
R2892 VSS.n88 VSS.n97 0.267794
R2893 VSS.n88 VSS.n98 0.267794
R2894 VSS.n88 VSS.n99 0.267794
R2895 VSS.n88 VSS.n100 0.267794
R2896 VSS.n88 VSS.n101 0.267794
R2897 VSS.n88 VSS.n103 0.267794
R2898 VSS.n88 VSS.n104 0.267794
R2899 VSS.n88 VSS.n106 0.267794
R2900 VSS.n88 VSS.n107 0.267794
R2901 VSS.n88 VSS.n108 0.267794
R2902 VSS.n88 VSS.n110 0.267794
R2903 VSS.n88 VSS.n111 0.267794
R2904 VSS.n88 VSS.n113 0.267794
R2905 VSS.n88 VSS.n114 0.267794
R2906 VSS.n88 VSS.n156 0.267428
R2907 VSS.n602 VSS.n590 0.266107
R2908 VSS.n833 VSS.n832 0.265497
R2909 VSS.t54 VSS.n339 0.264468
R2910 VSS.n832 VSS.n831 0.264227
R2911 VSS.n203 VSS.t208 0.263148
R2912 VSS.n210 VSS.t115 0.255324
R2913 VSS.n226 VSS.t125 0.255324
R2914 VSS.n243 VSS.t20 0.255324
R2915 VSS.n267 VSS.t146 0.255324
R2916 VSS.n281 VSS.t156 0.255324
R2917 VSS.n295 VSS.t167 0.255324
R2918 VSS.t242 VSS.t612 0.254653
R2919 VSS.n88 VSS.n518 0.253549
R2920 VSS.t62 VSS.n425 0.24355
R2921 VSS.t46 VSS.n707 0.241078
R2922 VSS.t340 VSS.n682 0.241078
R2923 VSS.n851 VSS.n343 0.24011
R2924 VSS.n568 VSS.n840 0.239006
R2925 VSS.n566 VSS.n842 0.239006
R2926 VSS.n807 VSS.n806 0.239006
R2927 VSS.n810 VSS.t389 0.239006
R2928 VSS.n811 VSS.n793 0.239006
R2929 VSS.n813 VSS.n812 0.239006
R2930 VSS.t587 VSS.n575 0.239006
R2931 VSS.t581 VSS.n797 0.239006
R2932 VSS.n834 VSS.t388 0.238668
R2933 VSS.n842 VSS.t395 0.238668
R2934 VSS.n806 VSS.n805 0.238668
R2935 VSS.n812 VSS.n811 0.238668
R2936 VSS.n815 VSS.n814 0.238668
R2937 VSS.t389 VSS.n795 0.238668
R2938 VSS.n793 VSS.t390 0.238668
R2939 VSS.t393 VSS.n569 0.238668
R2940 VSS.t395 VSS.n568 0.238668
R2941 VSS.n607 VSS.n606 0.238218
R2942 VSS.n662 VSS.n661 0.233757
R2943 VSS.n664 VSS.n663 0.233757
R2944 VSS.n666 VSS.n665 0.233757
R2945 VSS.n668 VSS.n667 0.233757
R2946 VSS.t531 VSS.n640 0.233757
R2947 VSS.n660 VSS.n659 0.233419
R2948 VSS.n663 VSS.n662 0.233419
R2949 VSS.n665 VSS.n664 0.233419
R2950 VSS.n667 VSS.n666 0.233419
R2951 VSS.n669 VSS.n668 0.233419
R2952 VSS.n596 VSS.n594 0.225543
R2953 VSS.t119 VSS.t121 0.224424
R2954 VSS.t130 VSS.t132 0.224424
R2955 VSS.t161 VSS.t163 0.224424
R2956 VSS.t150 VSS.t152 0.224424
R2957 VSS.t140 VSS.t142 0.224424
R2958 VSS.t109 VSS.t111 0.224424
R2959 VSS.t78 VSS.t119 0.220674
R2960 VSS.t129 VSS.t130 0.220674
R2961 VSS.t161 VSS.t160 0.220674
R2962 VSS.t150 VSS.t81 0.220674
R2963 VSS.t140 VSS.t139 0.220674
R2964 VSS.t109 VSS.t108 0.220674
R2965 VSS.n613 VSS.n594 0.219552
R2966 VSS.t13 VSS.n717 0.211735
R2967 VSS.n824 VSS.n582 0.20686
R2968 VSS.n87 VSS.n305 0.297117
R2969 VSS.n618 VSS.n599 0.191235
R2970 VSS.n839 VSS.t393 0.191235
R2971 VSS.n840 VSS.n839 0.191235
R2972 VSS.t397 VSS.n566 0.191235
R2973 VSS.n843 VSS.n565 0.191235
R2974 VSS.n844 VSS.n843 0.191235
R2975 VSS.n803 VSS.t581 0.191235
R2976 VSS.n804 VSS.n803 0.191235
R2977 VSS.n805 VSS.n804 0.191235
R2978 VSS.n808 VSS.n807 0.191235
R2979 VSS.n809 VSS.n808 0.191235
R2980 VSS.n795 VSS.n809 0.191235
R2981 VSS.n794 VSS.n810 0.191235
R2982 VSS.t390 VSS.n794 0.191235
R2983 VSS.n814 VSS.n813 0.191235
R2984 VSS.n785 VSS.n784 0.191235
R2985 VSS.n789 VSS.n788 0.191235
R2986 VSS.n790 VSS.n789 0.191235
R2987 VSS.n428 VSS.n87 0.23732
R2988 VSS.t388 VSS.t587 0.191235
R2989 VSS.n565 VSS.t397 0.191235
R2990 VSS.t602 VSS.t599 0.1875
R2991 VSS.t596 VSS.t592 0.1875
R2992 VSS.t608 VSS.t605 0.1875
R2993 VSS.n657 VSS.t547 0.187025
R2994 VSS.n658 VSS.n657 0.187025
R2995 VSS.n659 VSS.n658 0.187025
R2996 VSS.n791 VSS.n775 0.185557
R2997 VSS.n782 VSS.n540 0.183391
R2998 VSS.n776 VSS.n774 0.182052
R2999 VSS.n777 VSS.n546 0.181924
R3000 VSS.n800 VSS.t579 0.167615
R3001 VSS.n778 VSS.n546 0.164424
R3002 VSS.n775 VSS.n774 0.164293
R3003 VSS.n88 VSS.n175 0.160396
R3004 VSS.n88 VSS.n177 0.160396
R3005 VSS.n88 VSS.n178 0.160396
R3006 VSS.n575 VSS.n577 0.15955
R3007 VSS.n797 VSS.n798 0.15955
R3008 VSS.n642 VSS.n598 0.156138
R3009 VSS.n830 VSS.n579 0.150687
R3010 VSS.t521 VSS.n72 0.149502
R3011 VSS.t537 VSS.n72 0.149428
R3012 VSS.n887 VSS.n244 0.144066
R3013 VSS.n786 VSS.n785 0.143368
R3014 VSS.n788 VSS.n787 0.143368
R3015 VSS.t615 VSS.n305 0.139294
R3016 VSS.t525 VSS.n72 0.138776
R3017 VSS.t541 VSS.n72 0.13875
R3018 VSS.t533 VSS.n72 0.138705
R3019 VSS.t516 VSS.n72 0.138693
R3020 VSS.n829 VSS.n179 0.138073
R3021 VSS.t609 VSS.t62 0.135868
R3022 VSS.t612 VSS.n307 0.124618
R3023 VSS.t609 VSS.n304 0.122118
R3024 VSS.n307 VSS.t611 0.122118
R3025 VSS.n779 VSS.t584 0.1171
R3026 VSS.t529 VSS.n72 0.11127
R3027 VSS.t102 VSS.n296 0.109701
R3028 VSS.n428 VSS.t613 0.109642
R3029 VSS.n777 VSS.n539 0.104618
R3030 VSS.n776 VSS.n767 0.104618
R3031 VSS.t545 VSS.n72 0.103408
R3032 VSS.t597 VSS.n591 0.0971176
R3033 VSS.n642 VSS.n599 0.0971176
R3034 VSS.n598 VSS.n597 0.0958002
R3035 VSS.n597 VSS.n595 0.0955
R3036 VSS.n791 VSS.n624 0.0949351
R3037 VSS.n608 VSS.n607 0.093
R3038 VSS.t603 VSS.n342 0.08925
R3039 VSS.n515 VSS.t238 0.08925
R3040 VSS.t599 VSS.n615 0.0851154
R3041 VSS.n616 VSS.t602 0.0851154
R3042 VSS.t592 VSS.n604 0.0851154
R3043 VSS.n605 VSS.t596 0.0851154
R3044 VSS.t605 VSS.n512 0.0851154
R3045 VSS.n513 VSS.t608 0.0851154
R3046 VSS.n648 VSS.t36 0.0846176
R3047 VSS.n656 VSS.n581 0.0846176
R3048 VSS.n751 VSS.n535 0.08425
R3049 VSS.n753 VSS.n752 0.08425
R3050 VSS.n604 VSS.n4 0.08175
R3051 VSS.n615 VSS.n610 0.08175
R3052 VSS.n603 VSS.n588 0.08175
R3053 VSS.n614 VSS.n592 0.08175
R3054 VSS.n783 VSS.n782 0.0812779
R3055 VSS.n859 VSS.n858 0.0805
R3056 VSS.n543 VSS.n542 0.0805
R3057 VSS.n577 VSS.n576 0.0796176
R3058 VSS.n798 VSS.n799 0.0796176
R3059 VSS.t248 VSS.n517 0.078
R3060 VSS.t615 VSS.n306 0.0771176
R3061 VSS.n542 VSS.n541 0.07675
R3062 VSS.n576 VSS.n833 0.0758676
R3063 VSS.n799 VSS.n802 0.0758676
R3064 VSS.n512 VSS.n344 0.0746176
R3065 VSS.n511 VSS.n341 0.0746176
R3066 VSS.n826 VSS.n580 0.07425
R3067 VSS.n778 VSS.n543 0.07425
R3068 VSS.t593 VSS.n585 0.0740901
R3069 VSS.t590 VSS.n584 0.0740901
R3070 VSS.t378 VSS.n580 0.07175
R3071 VSS.t435 VSS.n518 0.0715255
R3072 VSS.t517 VSS.n648 0.0708676
R3073 VSS.t532 VSS.n656 0.0708676
R3074 VSS.t611 VSS.n306 0.0696176
R3075 VSS.n512 VSS.t240 0.06925
R3076 VSS.t113 VSS.n208 0.06925
R3077 VSS.t123 VSS.n220 0.06925
R3078 VSS.t134 VSS.n237 0.06925
R3079 VSS.t144 VSS.n265 0.06925
R3080 VSS.t154 VSS.n279 0.06925
R3081 VSS.t165 VSS.n293 0.06925
R3082 VSS.n756 VSS.n535 0.06925
R3083 VSS.n757 VSS.n753 0.06925
R3084 VSS.t378 VSS.n541 0.06925
R3085 VSS.n511 VSS.n340 0.06925
R3086 VSS.n605 VSS.n601 0.0671176
R3087 VSS.n616 VSS.n612 0.0671176
R3088 VSS.n602 VSS.n589 0.0671176
R3089 VSS.n613 VSS.n593 0.0671176
R3090 VSS.n604 VSS.n601 0.0621177
R3091 VSS.n615 VSS.n612 0.0621177
R3092 VSS.n603 VSS.n589 0.0621177
R3093 VSS.n614 VSS.n593 0.0621177
R3094 VSS.n510 VSS.n340 0.05925
R3095 VSS.n513 VSS.t240 0.05925
R3096 VSS.t514 VSS.n591 0.0571176
R3097 VSS.n784 VSS.n783 0.0558676
R3098 VSS.t238 VSS.n344 0.0546176
R3099 VSS.t603 VSS.n341 0.0546176
R3100 VSS.n208 VSS.t111 0.05175
R3101 VSS.t121 VSS.n220 0.05175
R3102 VSS.t132 VSS.n237 0.05175
R3103 VSS.n265 VSS.t142 0.05175
R3104 VSS.n279 VSS.t152 0.05175
R3105 VSS.n293 VSS.t163 0.05175
R3106 VSS.n624 VSS.n790 0.0508676
R3107 VSS.n765 VSS.n539 0.0496177
R3108 VSS.n767 VSS.n766 0.0496177
R3109 VSS.n609 VSS.n608 0.04925
R3110 VSS.n787 VSS.n779 0.04925
R3111 VSS.n542 VSS.n540 0.048
R3112 VSS.n610 VSS.n609 0.04675
R3113 VSS.t597 VSS.n592 0.04675
R3114 VSS.n786 VSS.n779 0.04675
R3115 VSS.n7 VSS.n3 0.0423393
R3116 VSS.n823 VSS.n4 0.0305
R3117 VSS.n588 VSS.n587 0.0305
R3118 VSS.t613 VSS.n157 0.02925
R3119 VSS.n780 VSS.n584 0.0253401
R3120 VSS.n585 VSS.n583 0.0253401
R3121 VSS.n860 VSS.n303 0.023135
R3122 VSS.n860 VSS.n299 0.023135
R3123 VSS.n864 VSS.n863 0.023135
R3124 VSS.n869 VSS.n284 0.023135
R3125 VSS.n869 VSS.n285 0.023135
R3126 VSS.n873 VSS.n872 0.023135
R3127 VSS.n878 VSS.n270 0.023135
R3128 VSS.n878 VSS.n271 0.023135
R3129 VSS.n882 VSS.n881 0.023135
R3130 VSS.n887 VSS.n247 0.023135
R3131 VSS.n887 VSS.n249 0.023135
R3132 VSS.n887 VSS.n250 0.023135
R3133 VSS.n887 VSS.n251 0.023135
R3134 VSS.n890 VSS.n241 0.023135
R3135 VSS.n893 VSS.n228 0.023135
R3136 VSS.n893 VSS.n229 0.023135
R3137 VSS.n896 VSS.n224 0.023135
R3138 VSS.n899 VSS.n212 0.023135
R3139 VSS.n899 VSS.n213 0.023135
R3140 VSS.n903 VSS.n902 0.023135
R3141 VSS.n908 VSS.n183 0.023135
R3142 VSS.n908 VSS.n187 0.023135
R3143 VSS.n908 VSS.n197 0.023135
R3144 VSS.n858 VSS.n304 0.02175
R3145 VSS.n180 VSS.t59 0.0191553
R3146 VSS.n701 VSS.t198 0.0184075
R3147 VSS.n687 VSS.t200 0.0184075
R3148 VSS.t13 VSS.n714 0.0173993
R3149 VSS.n823 VSS.t593 0.01675
R3150 VSS.n587 VSS.t590 0.01675
R3151 VSS.n88 VSS.n174 0.0165542
R3152 VSS.n88 VSS.n176 0.0165542
R3153 VSS.n859 VSS.n157 0.0155
R3154 VSS.t93 VSS.n59 0.0151406
R3155 VSS.n695 VSS.n64 0.0151406
R3156 VSS.n694 VSS.n64 0.0151406
R3157 VSS.n683 VSS.n634 0.0151406
R3158 VSS.t13 VSS.n710 0.0150892
R3159 VSS VSS.n909 0.0134067
R3160 VSS.n596 VSS.n595 0.013
R3161 VSS.n88 VSS.n162 0.00962826
R3162 VSS.n88 VSS.n160 0.00962826
R3163 VSS.n88 VSS.n119 0.00937856
R3164 VSS.n88 VSS.n147 0.00937856
R3165 VSS.n88 VSS.n154 0.00937856
R3166 VSS.n88 VSS.n115 0.00937856
R3167 VSS.n88 VSS.n125 0.00937856
R3168 VSS.n88 VSS.n136 0.00937856
R3169 VSS.n88 VSS.n143 0.00937856
R3170 VSS.n88 VSS.n148 0.00937856
R3171 VSS.n88 VSS.n155 0.00937856
R3172 VSS.n88 VSS.n90 0.00937856
R3173 VSS.n88 VSS.n102 0.00937856
R3174 VSS.n88 VSS.n105 0.00937856
R3175 VSS.n88 VSS.n109 0.00937856
R3176 VSS.n88 VSS.n112 0.00937856
R3177 VSS.n88 VSS.n116 0.00937856
R3178 VSS.n88 VSS.n117 0.00937856
R3179 VSS.n851 VSS.n515 0.00675
R3180 VSS.n828 VSS.n342 0.00675
R3181 VSS.n14 VSS.n781 0.00649396
R3182 VSS.n28 VSS.n29 0.00566455
R3183 VSS.n675 VSS.n72 0.00489839
R3184 VSS.n35 VSS.n36 0.00466584
R3185 VSS.n827 VSS.n33 0.00459701
R3186 VSS.n7 VSS.n0 0.00296307
R3187 VSS.n56 VSS.n55 0.00249999
R3188 VSS.n41 VSS.n40 0.00249999
R3189 VSS.n23 VSS.n838 0.00283308
R3190 VSS.n45 VSS.n44 0.00224999
R3191 VSS.n65 VSS.n64 0.0022
R3192 VSS.n33 VSS.n10 0.00216667
R3193 VSS.n86 VSS.n88 0.00105218
R3194 VSS.n846 VSS.n33 0.00193134
R3195 VSS.n301 VSS.n294 0.00179957
R3196 VSS.n300 VSS.n294 0.00179957
R3197 VSS.n866 VSS.n290 0.00179957
R3198 VSS.n287 VSS.n280 0.00179957
R3199 VSS.n286 VSS.n280 0.00179957
R3200 VSS.n875 VSS.n276 0.00179957
R3201 VSS.n273 VSS.n266 0.00179957
R3202 VSS.n272 VSS.n266 0.00179957
R3203 VSS.n884 VSS.n262 0.00179957
R3204 VSS.n254 VSS.n242 0.00179957
R3205 VSS.n253 VSS.n242 0.00179957
R3206 VSS.n239 VSS.n236 0.00179957
R3207 VSS.n232 VSS.n225 0.00179957
R3208 VSS.n231 VSS.n225 0.00179957
R3209 VSS.n222 VSS.n219 0.00179957
R3210 VSS.n215 VSS.n209 0.00179957
R3211 VSS.n214 VSS.n209 0.00179957
R3212 VSS.n905 VSS.n205 0.00179957
R3213 VSS.n908 VSS.n190 0.00179957
R3214 VSS.n908 VSS.n192 0.00179957
R3215 VSS.n908 VSS.n196 0.00179957
R3216 VSS.n35 VSS.n34 0.00131814
R3217 VSS.n835 VSS.n524 0.00166667
R3218 VSS.n571 VSS.n522 0.00166667
R3219 VSS.n570 VSS.n525 0.00166667
R3220 VSS.n837 VSS.n521 0.00166667
R3221 VSS.n838 VSS.n526 0.00166667
R3222 VSS.n26 VSS.n25 0.00169993
R3223 VSS.n28 VSS.n27 0.00124996
R3224 VSS.n12 VSS.n11 0.00169993
R3225 VSS.n42 VSS.n41 0.00149995
R3226 VSS.n48 VSS.n47 0.00169993
R3227 VSS.n54 VSS.n53 0.00169993
R3228 VSS.n57 VSS.n56 0.00149995
R3229 VSS.n654 VSS.n637 0.00166667
R3230 VSS.n79 VSS.n78 0.00169993
R3231 VSS.n81 VSS.n80 0.00169993
R3232 VSS.n83 VSS.n82 0.00169993
R3233 VSS.n85 VSS.n84 0.00169993
R3234 VSS.n649 VSS.n638 0.00166667
R3235 VSS.n71 VSS.n639 0.00166667
R3236 VSS.n817 VSS.n719 0.00162501
R3237 VSS.n7 VSS.n2 0.00161188
R3238 VSS.n72 VSS.n71 0.0015
R3239 VSS.n650 VSS.n85 0.0015
R3240 VSS.n651 VSS.n83 0.0015
R3241 VSS.n652 VSS.n81 0.0015
R3242 VSS.n653 VSS.n79 0.0015
R3243 VSS.n69 VSS.n68 0.00214264
R3244 VSS.n69 VSS.t200 0.0015
R3245 VSS.n64 VSS.t200 0.0015
R3246 VSS.n58 VSS.n719 0.00137498
R3247 VSS.n706 VSS.t93 0.00136832
R3248 VSS.n573 VSS.n524 0.00133332
R3249 VSS.n835 VSS.n522 0.00133332
R3250 VSS.n571 VSS.n525 0.00133332
R3251 VSS.n570 VSS.n521 0.00133332
R3252 VSS.n837 VSS.n526 0.00133332
R3253 VSS.n655 VSS.n637 0.00133332
R3254 VSS.n650 VSS.n638 0.00133332
R3255 VSS.n649 VSS.n639 0.00133332
R3256 VSS.n7 VSS.n1 0.00128573
R3257 VSS.n908 VSS.n204 0.00104691
R3258 VSS.n7 VSS.n5 0.00103555
R3259 VSS.n671 VSS.n72 0.00103062
R3260 VSS.n672 VSS.n72 0.00103062
R3261 VSS.n73 VSS.n72 0.00121239
R3262 VSS.n860 VSS.n298 0.00101811
R3263 VSS.n869 VSS.n868 0.00101811
R3264 VSS.n869 VSS.n289 0.00101811
R3265 VSS.n878 VSS.n877 0.00101811
R3266 VSS.n878 VSS.n275 0.00101811
R3267 VSS.n887 VSS.n886 0.00101811
R3268 VSS.n887 VSS.n256 0.00101811
R3269 VSS.n893 VSS.n235 0.00101811
R3270 VSS.n893 VSS.n234 0.00101811
R3271 VSS.n899 VSS.n218 0.00101811
R3272 VSS.n899 VSS.n217 0.00101811
R3273 VSS.n908 VSS.n907 0.00101811
R3274 VSS.n674 VSS.n72 0.00100339
R3275 VSS.n887 VSS.n259 0.00100065
R3276 VSS.n860 VSS.n297 0.00100065
R3277 VSS.n887 VSS.n248 0.00100065
R3278 VSS.n887 VSS.n257 0.00100065
R3279 VSS.n908 VSS.n184 0.00100065
R3280 VSS.n673 VSS.n72 0.00100005
R3281 VSS.n676 VSS.n72 0.00100002
R3282 VSS.n678 VSS.n72 0.00100001
R3283 VSS.n677 VSS.n72 0.001
R3284 VSS.n861 VSS.n294 0.001
R3285 VSS.n863 VSS.n862 0.001
R3286 VSS.n866 VSS.n291 0.001
R3287 VSS.n869 VSS.n283 0.001
R3288 VSS.n870 VSS.n280 0.001
R3289 VSS.n872 VSS.n871 0.001
R3290 VSS.n875 VSS.n277 0.001
R3291 VSS.n878 VSS.n269 0.001
R3292 VSS.n879 VSS.n266 0.001
R3293 VSS.n881 VSS.n880 0.001
R3294 VSS.n884 VSS.n263 0.001
R3295 VSS.n887 VSS.n246 0.001
R3296 VSS.n888 VSS.n242 0.001
R3297 VSS.n890 VSS.n889 0.001
R3298 VSS.n891 VSS.n236 0.001
R3299 VSS.n893 VSS.n892 0.001
R3300 VSS.n894 VSS.n225 0.001
R3301 VSS.n896 VSS.n895 0.001
R3302 VSS.n897 VSS.n219 0.001
R3303 VSS.n899 VSS.n898 0.001
R3304 VSS.n900 VSS.n209 0.001
R3305 VSS.n902 VSS.n901 0.001
R3306 VSS.n905 VSS.n206 0.001
R3307 VSS.n908 VSS.n182 0.001
R3308 VSS.n905 VSS.n182 0.001
R3309 VSS.n902 VSS.n206 0.001
R3310 VSS.n901 VSS.n209 0.001
R3311 VSS.n900 VSS.n899 0.001
R3312 VSS.n898 VSS.n219 0.001
R3313 VSS.n897 VSS.n896 0.001
R3314 VSS.n895 VSS.n225 0.001
R3315 VSS.n894 VSS.n893 0.001
R3316 VSS.n892 VSS.n236 0.001
R3317 VSS.n891 VSS.n890 0.001
R3318 VSS.n889 VSS.n242 0.001
R3319 VSS.n888 VSS.n887 0.001
R3320 VSS.n884 VSS.n246 0.001
R3321 VSS.n881 VSS.n263 0.001
R3322 VSS.n880 VSS.n266 0.001
R3323 VSS.n879 VSS.n878 0.001
R3324 VSS.n875 VSS.n269 0.001
R3325 VSS.n872 VSS.n277 0.001
R3326 VSS.n871 VSS.n280 0.001
R3327 VSS.n870 VSS.n869 0.001
R3328 VSS.n866 VSS.n283 0.001
R3329 VSS.n863 VSS.n291 0.001
R3330 VSS.n862 VSS.n294 0.001
R3331 VSS.n861 VSS.n860 0.001
R3332 VSS.n38 VSS.n37 0.00124999
R3333 VSS.n45 VSS.n43 0.00174999
R3334 VSS.n50 VSS.n49 0.001
R3335 VSS.n574 VSS.n523 0.001
R3336 VSS.n573 VSS.n20 0.001
R3337 VSS.n841 VSS.n24 0.001
R3338 VSS.n32 VSS.n31 0.0012
R3339 VSS.n63 VSS.n62 0.00192843
R3340 VSS.n62 VSS.t198 0.0015
R3341 VSS.t93 VSS.t198 0.0015
R3342 VSS.n55 VSS.n58 0.0015
R3343 VSS.n53 VSS.n52 0.0015
R3344 VSS.n51 VSS.n46 0.00199997
R3345 VSS.n47 VSS.n46 0.0015
R3346 VSS.n40 VSS.n43 0.0015
R3347 VSS.n37 VSS.n39 0.0015
R3348 VSS.n523 VSS.n33 0.0015
R3349 VSS.n32 VSS.n12 0.0015
R3350 VSS.n567 VSS.n26 0.0015
R3351 VSS.n21 VSS.n574 0.00199997
R3352 VSS.n781 VSS.n12 0.0015
R3353 VSS.n683 VSS.n70 0.001
R3354 VSS.n655 VSS.n77 0.001
R3355 VSS.n817 VSS.n19 0.001
R3356 VSS.n646 VSS.n619 0.001
R3357 VSS.t13 VSS.n619 0.001
R3358 VSS.n618 VSS.n8 8.47807
R3359 a_3747_311.n0 a_3747_311.t2 52.0388
R3360 a_3747_311.t1 a_3747_311.n0 35.4491
R3361 a_3747_311.n0 a_3747_311.t3 33.5891
R3362 a_3747_311.t0 a_3747_311.t1 5.61942
R3363 a_3171_311.n0 a_3171_311.t2 51.8377
R3364 a_3171_311.n0 a_3171_311.t3 33.3881
R3365 a_3171_311.t1 a_3171_311.n0 31.8923
R3366 a_3171_311.t0 a_3171_311.t1 5.61777
R3367 a_2595_311.n0 a_2595_311.t2 51.6367
R3368 a_2595_311.n0 a_2595_311.t3 33.187
R3369 a_2595_311.t1 a_2595_311.n0 27.993
R3370 a_2595_311.t0 a_2595_311.t1 5.73018
R3371 a_3747_1047.n0 a_3747_1047.t2 38.0081
R3372 a_3747_1047.n0 a_3747_1047.t3 33.3957
R3373 a_3747_1047.n1 a_3747_1047.t4 33.3957
R3374 a_3747_1047.n2 a_3747_1047.t5 33.3957
R3375 a_3747_1047.n3 a_3747_1047.t6 33.3957
R3376 a_3747_1047.n4 a_3747_1047.t7 33.3957
R3377 a_3747_1047.n5 a_3747_1047.t8 33.3957
R3378 a_3747_1047.n6 a_3747_1047.t9 33.3957
R3379 a_3747_1047.t1 a_3747_1047.n6 23.2419
R3380 a_3747_1047.t0 a_3747_1047.t1 5.61942
R3381 a_3747_1047.n6 a_3747_1047.n5 4.61291
R3382 a_3747_1047.n5 a_3747_1047.n4 4.61291
R3383 a_3747_1047.n4 a_3747_1047.n3 4.61291
R3384 a_3747_1047.n3 a_3747_1047.n2 4.61291
R3385 a_3747_1047.n2 a_3747_1047.n1 4.61291
R3386 a_3747_1047.n1 a_3747_1047.n0 4.61291
R3387 a_3171_1047.n0 a_3171_1047.t2 37.8054
R3388 a_3171_1047.n0 a_3171_1047.t3 33.193
R3389 a_3171_1047.n1 a_3171_1047.t4 33.193
R3390 a_3171_1047.n2 a_3171_1047.t5 33.193
R3391 a_3171_1047.n3 a_3171_1047.t6 33.193
R3392 a_3171_1047.n4 a_3171_1047.t7 33.193
R3393 a_3171_1047.n5 a_3171_1047.t8 33.193
R3394 a_3171_1047.n6 a_3171_1047.t9 33.193
R3395 a_3171_1047.t1 a_3171_1047.n6 23.0313
R3396 a_3171_1047.t0 a_3171_1047.t1 5.61777
R3397 a_3171_1047.n6 a_3171_1047.n5 4.61291
R3398 a_3171_1047.n5 a_3171_1047.n4 4.61291
R3399 a_3171_1047.n4 a_3171_1047.n3 4.61291
R3400 a_3171_1047.n3 a_3171_1047.n2 4.61291
R3401 a_3171_1047.n2 a_3171_1047.n1 4.61291
R3402 a_3171_1047.n1 a_3171_1047.n0 4.61291
R3403 a_2595_1047.n0 a_2595_1047.t2 37.7691
R3404 a_2595_1047.n0 a_2595_1047.t3 33.1567
R3405 a_2595_1047.n1 a_2595_1047.t4 33.1567
R3406 a_2595_1047.n2 a_2595_1047.t5 33.1567
R3407 a_2595_1047.n3 a_2595_1047.t6 33.1567
R3408 a_2595_1047.n4 a_2595_1047.t7 33.1567
R3409 a_2595_1047.n5 a_2595_1047.t8 33.1567
R3410 a_2595_1047.n6 a_2595_1047.t9 33.1567
R3411 a_2595_1047.t1 a_2595_1047.n6 22.7941
R3412 a_2595_1047.t0 a_2595_1047.t1 5.65522
R3413 a_2595_1047.n6 a_2595_1047.n5 4.61291
R3414 a_2595_1047.n5 a_2595_1047.n4 4.61291
R3415 a_2595_1047.n4 a_2595_1047.n3 4.61291
R3416 a_2595_1047.n3 a_2595_1047.n2 4.61291
R3417 a_2595_1047.n2 a_2595_1047.n1 4.61291
R3418 a_2595_1047.n1 a_2595_1047.n0 4.61291
R3419 a_2019_1047.n0 a_2019_1047.t2 37.9701
R3420 a_2019_1047.n0 a_2019_1047.t3 33.3577
R3421 a_2019_1047.n1 a_2019_1047.t4 33.3577
R3422 a_2019_1047.n2 a_2019_1047.t5 33.3577
R3423 a_2019_1047.n3 a_2019_1047.t6 33.3577
R3424 a_2019_1047.n4 a_2019_1047.t7 33.3577
R3425 a_2019_1047.n5 a_2019_1047.t8 33.3577
R3426 a_2019_1047.t1 a_2019_1047.t9 22.5945
R3427 a_2019_1047.t0 a_2019_1047.t1 5.62052
R3428 a_2019_1047.t9 a_2019_1047.n5 4.61291
R3429 a_2019_1047.n5 a_2019_1047.n4 4.61291
R3430 a_2019_1047.n4 a_2019_1047.n3 4.61291
R3431 a_2019_1047.n3 a_2019_1047.n2 4.61291
R3432 a_2019_1047.n2 a_2019_1047.n1 4.61291
R3433 a_2019_1047.n1 a_2019_1047.n0 4.61291
C1414 MUX_OUT VSS 3.24058f
C1415 MUX_SEL4 VSS 1.60778f
C1416 MUX_SEL3 VSS 0.90686f
C1417 MUX_SEL2 VSS 1.81137f
C1418 MUX_SEL1 VSS 0.95075f
C1419 MUX_SEL0 VSS 1.5515f
C1420 DELAY_VBIASP VSS 5.14139f
C1421 DELAY_OUT_LAST VSS 2.97841f
C1422 DELAY_VBIASN VSS 0.11242p
C1423 REF_CLK VSS 3.19236f
C1424 DLL_RESETN VSS 4.18452f
C1425 VDD VSS 61.87566f
C1426 a_26985_519# VSS 0.17928f ; **FLOATING
C1427 a_23945_519# VSS 0.17928f ; **FLOATING
C1428 a_20905_519# VSS 0.17928f ; **FLOATING
C1429 a_17865_519# VSS 0.17593f ; **FLOATING
C1430 a_16851_309# VSS 0.38699f ; **FLOATING
C1431 a_16108_289# VSS 3.70428f ; **FLOATING
C1432 a_15964_289# VSS 0.17613f ; **FLOATING
C1433 a_15765_463# VSS 0.36132f ; **FLOATING
C1434 a_14825_519# VSS 0.17928f ; **FLOATING
C1435 a_11785_519# VSS 0.17928f ; **FLOATING
C1436 a_8745_519# VSS 0.17928f ; **FLOATING
C1437 a_5731_289# VSS 3.39133f ; **FLOATING
C1438 a_2019_311# VSS 1.61601f ; **FLOATING
C1439 a_5705_519# VSS 0.17638f ; **FLOATING
C1440 a_3449_331# VSS 0.18478f ; **FLOATING
C1441 a_2873_331# VSS 0.18321f ; **FLOATING
C1442 a_2297_331# VSS 0.18321f ; **FLOATING
C1443 a_1721_331# VSS 0.17001f ; **FLOATING
C1444 a_1544_289# VSS 0.30014f ; **FLOATING
C1445 a_1256_289# VSS 0.84266f ; **FLOATING
C1446 a_27991_1008# VSS 0.18706f ; **FLOATING
C1447 a_27915_1044# VSS 0.10926f ; **FLOATING
C1448 a_27124_1008# VSS 0.17878f ; **FLOATING
C1449 a_27048_1044# VSS 0.12122f ; **FLOATING
C1450 a_26471_1008# VSS 0.18175f ; **FLOATING
C1451 a_26395_1044# VSS 0.11073f ; **FLOATING
C1452 a_25604_1008# VSS 0.18087f ; **FLOATING
C1453 a_25630_1044# VSS 0.37805f ; **FLOATING
C1454 a_25528_1044# VSS 0.12433f ; **FLOATING
C1455 a_24951_1008# VSS 0.18335f ; **FLOATING
C1456 a_24875_1044# VSS 0.11016f ; **FLOATING
C1457 a_24084_1008# VSS 0.17878f ; **FLOATING
C1458 a_24008_1044# VSS 0.12122f ; **FLOATING
C1459 a_23431_1008# VSS 0.18175f ; **FLOATING
C1460 a_23355_1044# VSS 0.11073f ; **FLOATING
C1461 a_22564_1008# VSS 0.18087f ; **FLOATING
C1462 a_22590_1044# VSS 0.33314f ; **FLOATING
C1463 a_22488_1044# VSS 0.12433f ; **FLOATING
C1464 a_21911_1008# VSS 0.18335f ; **FLOATING
C1465 a_21835_1044# VSS 0.11016f ; **FLOATING
C1466 a_21044_1008# VSS 0.17878f ; **FLOATING
C1467 a_20968_1044# VSS 0.12122f ; **FLOATING
C1468 a_20391_1008# VSS 0.18175f ; **FLOATING
C1469 a_20315_1044# VSS 0.11073f ; **FLOATING
C1470 a_19524_1008# VSS 0.18087f ; **FLOATING
C1471 a_19550_1044# VSS 0.33563f ; **FLOATING
C1472 a_19448_1044# VSS 0.12433f ; **FLOATING
C1473 a_18871_1008# VSS 0.18335f ; **FLOATING
C1474 a_18795_1044# VSS 0.11016f ; **FLOATING
C1475 a_18004_1008# VSS 0.17878f ; **FLOATING
C1476 a_17928_1044# VSS 0.12122f ; **FLOATING
C1477 a_17351_1008# VSS 0.18022f ; **FLOATING
C1478 a_17275_1044# VSS 0.10926f ; **FLOATING
C1479 a_16484_1008# VSS 0.18023f ; **FLOATING
C1480 a_16510_1044# VSS 0.28935f ; **FLOATING
C1481 a_16408_1044# VSS 0.1229f ; **FLOATING
C1482 a_15831_1008# VSS 0.17846f ; **FLOATING
C1483 a_15755_1044# VSS 0.10926f ; **FLOATING
C1484 a_14964_1008# VSS 0.17878f ; **FLOATING
C1485 a_14888_1044# VSS 0.12122f ; **FLOATING
C1486 a_14311_1008# VSS 0.18175f ; **FLOATING
C1487 a_14235_1044# VSS 0.11073f ; **FLOATING
C1488 a_13444_1008# VSS 0.18087f ; **FLOATING
C1489 a_13470_1044# VSS 0.30333f ; **FLOATING
C1490 a_13368_1044# VSS 0.12433f ; **FLOATING
C1491 a_12791_1008# VSS 0.18335f ; **FLOATING
C1492 a_12715_1044# VSS 0.11016f ; **FLOATING
C1493 a_11924_1008# VSS 0.17878f ; **FLOATING
C1494 a_11848_1044# VSS 0.12122f ; **FLOATING
C1495 a_11271_1008# VSS 0.18175f ; **FLOATING
C1496 a_11195_1044# VSS 0.11073f ; **FLOATING
C1497 a_10404_1008# VSS 0.18087f ; **FLOATING
C1498 a_10430_1044# VSS 0.31665f ; **FLOATING
C1499 a_10328_1044# VSS 0.12433f ; **FLOATING
C1500 a_9751_1008# VSS 0.18335f ; **FLOATING
C1501 a_9675_1044# VSS 0.11016f ; **FLOATING
C1502 a_8884_1008# VSS 0.17878f ; **FLOATING
C1503 a_8808_1044# VSS 0.12122f ; **FLOATING
C1504 a_8231_1008# VSS 0.18175f ; **FLOATING
C1505 a_8155_1044# VSS 0.11073f ; **FLOATING
C1506 a_7364_1008# VSS 0.18087f ; **FLOATING
C1507 a_7390_1044# VSS 0.31357f ; **FLOATING
C1508 a_7288_1044# VSS 0.12433f ; **FLOATING
C1509 a_6711_1008# VSS 0.18335f ; **FLOATING
C1510 a_6635_1044# VSS 0.11016f ; **FLOATING
C1511 a_5844_1008# VSS 0.17878f ; **FLOATING
C1512 a_5768_1044# VSS 0.12122f ; **FLOATING
C1513 a_5191_1008# VSS 0.18022f ; **FLOATING
C1514 a_5115_1044# VSS 0.10926f ; **FLOATING
C1515 a_4324_1008# VSS 0.18023f ; **FLOATING
C1516 a_4350_1044# VSS 0.26655f ; **FLOATING
C1517 a_4248_1044# VSS 0.12443f ; **FLOATING
C1518 a_27705_1044# VSS 0.25297f ; **FLOATING
C1519 a_26185_1044# VSS 0.23475f ; **FLOATING
C1520 a_24665_1044# VSS 0.25433f ; **FLOATING
C1521 a_23145_1044# VSS 0.23475f ; **FLOATING
C1522 a_21625_1044# VSS 0.25433f ; **FLOATING
C1523 a_20105_1044# VSS 0.23475f ; **FLOATING
C1524 a_18585_1044# VSS 0.25433f ; **FLOATING
C1525 a_17065_1044# VSS 0.23386f ; **FLOATING
C1526 a_15545_1044# VSS 0.25297f ; **FLOATING
C1527 a_14025_1044# VSS 0.23475f ; **FLOATING
C1528 a_12505_1044# VSS 0.25433f ; **FLOATING
C1529 a_10985_1044# VSS 0.23475f ; **FLOATING
C1530 a_9465_1044# VSS 0.25433f ; **FLOATING
C1531 a_7945_1044# VSS 0.23475f ; **FLOATING
C1532 a_6425_1044# VSS 0.25433f ; **FLOATING
C1533 a_4905_1044# VSS 0.23549f ; **FLOATING
C1534 a_4157_1313# VSS 0.32875f ; **FLOATING
C1535 a_3449_1395# VSS 0.18629f ; **FLOATING
C1536 a_2873_1395# VSS 0.18349f ; **FLOATING
C1537 a_2297_1395# VSS 0.18349f ; **FLOATING
C1538 a_1721_1395# VSS 0.17029f ; **FLOATING
C1539 a_1544_1044# VSS 0.29829f ; **FLOATING
C1540 a_1256_1044# VSS 0.82974f ; **FLOATING
C1541 a_27671_1842# VSS 0.01336f ; **FLOATING
C1542 a_26911_1842# VSS 0.01336f ; **FLOATING
C1543 a_26151_1842# VSS 0.01336f ; **FLOATING
C1544 a_25391_1842# VSS 0.01336f ; **FLOATING
C1545 a_24631_1842# VSS 0.01336f ; **FLOATING
C1546 a_23871_1842# VSS 0.01336f ; **FLOATING
C1547 a_23111_1842# VSS 0.01336f ; **FLOATING
C1548 a_22351_1842# VSS 0.01336f ; **FLOATING
C1549 a_21591_1842# VSS 0.01336f ; **FLOATING
C1550 a_20831_1842# VSS 0.01336f ; **FLOATING
C1551 a_20071_1842# VSS 0.01336f ; **FLOATING
C1552 a_19311_1842# VSS 0.01336f ; **FLOATING
C1553 a_18551_1842# VSS 0.01336f ; **FLOATING
C1554 a_17791_1842# VSS 0.01336f ; **FLOATING
C1555 a_17031_1842# VSS 0.01336f ; **FLOATING
C1556 a_16271_1842# VSS 0.01336f ; **FLOATING
C1557 a_15511_1842# VSS 0.01336f ; **FLOATING
C1558 a_14751_1842# VSS 0.01336f ; **FLOATING
C1559 a_13991_1842# VSS 0.01336f ; **FLOATING
C1560 a_13231_1842# VSS 0.01336f ; **FLOATING
C1561 a_12471_1842# VSS 0.01336f ; **FLOATING
C1562 a_11711_1842# VSS 0.01336f ; **FLOATING
C1563 a_10951_1842# VSS 0.01336f ; **FLOATING
C1564 a_10191_1842# VSS 0.01336f ; **FLOATING
C1565 a_9431_1842# VSS 0.01336f ; **FLOATING
C1566 a_8671_1842# VSS 0.01336f ; **FLOATING
C1567 a_7911_1842# VSS 0.01336f ; **FLOATING
C1568 a_7151_1842# VSS 0.01336f ; **FLOATING
C1569 a_6391_1842# VSS 0.01336f ; **FLOATING
C1570 a_5631_1842# VSS 0.01336f ; **FLOATING
C1571 a_4871_1842# VSS 0.01336f ; **FLOATING
C1572 a_4111_1842# VSS 0.0139f ; **FLOATING
C1573 a_27563_1842# VSS 0.50316f ; **FLOATING
C1574 a_27997_1842# VSS 0.6484f ; **FLOATING
C1575 a_27433_1842# VSS 0.4463f ; **FLOATING
C1576 a_26803_1842# VSS 0.49934f ; **FLOATING
C1577 a_27237_1842# VSS 0.92967f ; **FLOATING
C1578 a_26673_1842# VSS 0.4492f ; **FLOATING
C1579 a_26043_1842# VSS 0.50169f ; **FLOATING
C1580 a_26477_1842# VSS 0.95928f ; **FLOATING
C1581 a_25913_1842# VSS 0.4508f ; **FLOATING
C1582 a_25283_1842# VSS 0.49938f ; **FLOATING
C1583 a_25717_1842# VSS 0.86841f ; **FLOATING
C1584 a_25153_1842# VSS 0.45035f ; **FLOATING
C1585 a_24523_1842# VSS 0.50075f ; **FLOATING
C1586 a_24957_1842# VSS 0.96341f ; **FLOATING
C1587 a_24393_1842# VSS 0.4463f ; **FLOATING
C1588 a_23763_1842# VSS 0.49934f ; **FLOATING
C1589 a_24197_1842# VSS 0.92543f ; **FLOATING
C1590 a_23633_1842# VSS 0.45062f ; **FLOATING
C1591 a_23003_1842# VSS 0.50169f ; **FLOATING
C1592 a_23437_1842# VSS 0.95769f ; **FLOATING
C1593 a_22873_1842# VSS 0.4508f ; **FLOATING
C1594 a_22243_1842# VSS 0.49938f ; **FLOATING
C1595 a_22677_1842# VSS 0.86841f ; **FLOATING
C1596 a_22113_1842# VSS 0.45249f ; **FLOATING
C1597 a_21483_1842# VSS 0.50075f ; **FLOATING
C1598 a_21917_1842# VSS 0.96341f ; **FLOATING
C1599 a_21353_1842# VSS 0.4463f ; **FLOATING
C1600 a_20723_1842# VSS 0.49992f ; **FLOATING
C1601 a_21157_1842# VSS 0.92543f ; **FLOATING
C1602 a_20593_1842# VSS 0.45196f ; **FLOATING
C1603 a_19963_1842# VSS 0.50169f ; **FLOATING
C1604 a_20397_1842# VSS 0.95769f ; **FLOATING
C1605 a_19833_1842# VSS 0.4508f ; **FLOATING
C1606 a_19203_1842# VSS 0.5005f ; **FLOATING
C1607 a_19637_1842# VSS 0.86841f ; **FLOATING
C1608 a_19073_1842# VSS 0.44947f ; **FLOATING
C1609 a_18443_1842# VSS 0.50075f ; **FLOATING
C1610 a_18877_1842# VSS 0.96341f ; **FLOATING
C1611 a_18313_1842# VSS 0.4463f ; **FLOATING
C1612 a_17683_1842# VSS 0.50046f ; **FLOATING
C1613 a_18117_1842# VSS 0.92543f ; **FLOATING
C1614 a_17553_1842# VSS 0.44782f ; **FLOATING
C1615 a_16923_1842# VSS 0.50165f ; **FLOATING
C1616 a_17357_1842# VSS 0.95769f ; **FLOATING
C1617 a_16793_1842# VSS 0.45049f ; **FLOATING
C1618 a_16163_1842# VSS 0.4946f ; **FLOATING
C1619 a_16597_1842# VSS 0.86359f ; **FLOATING
C1620 a_16033_1842# VSS 0.44618f ; **FLOATING
C1621 a_15403_1842# VSS 0.49465f ; **FLOATING
C1622 a_15837_1842# VSS 0.95171f ; **FLOATING
C1623 a_15273_1842# VSS 0.44439f ; **FLOATING
C1624 a_14643_1842# VSS 0.49305f ; **FLOATING
C1625 a_15077_1842# VSS 0.92116f ; **FLOATING
C1626 a_14513_1842# VSS 0.44501f ; **FLOATING
C1627 a_13883_1842# VSS 0.50862f ; **FLOATING
C1628 a_14317_1842# VSS 0.96009f ; **FLOATING
C1629 a_13753_1842# VSS 0.46427f ; **FLOATING
C1630 a_13123_1842# VSS 0.50173f ; **FLOATING
C1631 a_13557_1842# VSS 0.87587f ; **FLOATING
C1632 a_12993_1842# VSS 0.45643f ; **FLOATING
C1633 a_12363_1842# VSS 0.50854f ; **FLOATING
C1634 a_12797_1842# VSS 0.96142f ; **FLOATING
C1635 a_12233_1842# VSS 0.45757f ; **FLOATING
C1636 a_11603_1842# VSS 0.50267f ; **FLOATING
C1637 a_12037_1842# VSS 0.92866f ; **FLOATING
C1638 a_11473_1842# VSS 0.45177f ; **FLOATING
C1639 a_10843_1842# VSS 0.50491f ; **FLOATING
C1640 a_11277_1842# VSS 0.96053f ; **FLOATING
C1641 a_10713_1842# VSS 0.44901f ; **FLOATING
C1642 a_10083_1842# VSS 0.50223f ; **FLOATING
C1643 a_10517_1842# VSS 0.87053f ; **FLOATING
C1644 a_9953_1842# VSS 0.44673f ; **FLOATING
C1645 a_9323_1842# VSS 0.5026f ; **FLOATING
C1646 a_9757_1842# VSS 0.96312f ; **FLOATING
C1647 a_9193_1842# VSS 0.44361f ; **FLOATING
C1648 a_8563_1842# VSS 0.49203f ; **FLOATING
C1649 a_8997_1842# VSS 0.92196f ; **FLOATING
C1650 a_8433_1842# VSS 0.44439f ; **FLOATING
C1651 a_7803_1842# VSS 0.49435f ; **FLOATING
C1652 a_8237_1842# VSS 0.95422f ; **FLOATING
C1653 a_7673_1842# VSS 0.44737f ; **FLOATING
C1654 a_7043_1842# VSS 0.49204f ; **FLOATING
C1655 a_7477_1842# VSS 0.86493f ; **FLOATING
C1656 a_6913_1842# VSS 0.44442f ; **FLOATING
C1657 a_6283_1842# VSS 0.49343f ; **FLOATING
C1658 a_6717_1842# VSS 0.95763f ; **FLOATING
C1659 a_6153_1842# VSS 0.44292f ; **FLOATING
C1660 a_5523_1842# VSS 0.50322f ; **FLOATING
C1661 a_5957_1842# VSS 0.92646f ; **FLOATING
C1662 a_5393_1842# VSS 0.4596f ; **FLOATING
C1663 a_4763_1842# VSS 0.51043f ; **FLOATING
C1664 a_5197_1842# VSS 0.96509f ; **FLOATING
C1665 a_4633_1842# VSS 0.46282f ; **FLOATING
C1666 a_4003_1842# VSS 0.58808f ; **FLOATING
C1667 a_4437_1842# VSS 0.87628f ; **FLOATING
C1668 a_9712_3912# VSS 1.25906f ; **FLOATING
C1669 a_9444_3912# VSS 2.12877f ; **FLOATING
C1670 a_5778_3367# VSS 5.22809f ; **FLOATING
C1671 a_15464_3684# VSS 0.75391f ; **FLOATING
C1672 a_14757_5182# VSS 0.09495f ; **FLOATING
C1673 a_13880_5118# VSS 0.06985f ; **FLOATING
C1674 a_15688_5403# VSS 0.26291f ; **FLOATING
C1675 a_15108_5325# VSS 0.24458f ; **FLOATING
C1676 a_14851_5182# VSS 0.38123f ; **FLOATING
C1677 a_9444_4590# VSS 6.03808f ; **FLOATING
C1678 a_14111_5227# VSS 0.19866f ; **FLOATING
C1679 a_14009_5084# VSS 0.44622f ; **FLOATING
C1680 a_13592_5423# VSS 1.57456f ; **FLOATING
C1681 a_13306_5105# VSS 0.30095f ; **FLOATING
C1682 a_13566_5328# VSS 0.15441f ; **FLOATING
C1683 a_13132_5420# VSS 0.13036f ; **FLOATING
C1684 a_12907_5420# VSS 0.14377f ; **FLOATING
C1685 a_12907_5186# VSS 0.14861f ; **FLOATING
C1686 a_13106_5357# VSS 0.06343f ; **FLOATING
C1687 a_15304_4605# VSS 0.37009f ; **FLOATING
C1688 a_14757_6228# VSS 0.09586f ; **FLOATING
C1689 a_15688_5867# VSS 0.26405f ; **FLOATING
C1690 a_14851_6228# VSS 0.39588f ; **FLOATING
C1691 a_15108_6109# VSS 0.24582f ; **FLOATING
C1692 a_14111_5878# VSS 0.21915f ; **FLOATING
C1693 a_13880_6292# VSS 0.07345f ; **FLOATING
C1694 a_14009_5878# VSS 0.48187f ; **FLOATING
C1695 a_13592_5871# VSS 1.58208f ; **FLOATING
C1696 a_13566_5835# VSS 0.15442f ; **FLOATING
C1697 a_13045_6215# VSS 0.01124f ; **FLOATING
C1698 a_13306_6305# VSS 0.31701f ; **FLOATING
C1699 a_12849_5867# VSS 1.40248f ; **FLOATING
C1700 a_13121_5831# VSS 0.80439f ; **FLOATING
C1701 a_13019_5831# VSS 2.18715f ; **FLOATING
C1702 a_12656_5864# VSS 0.28393f ; **FLOATING
C1703 a_12355_5867# VSS 0.62262f ; **FLOATING
C1704 a_11397_6228# VSS 0.09495f ; **FLOATING
C1705 a_12158_5867# VSS 0.25874f ; **FLOATING
C1706 a_11491_6228# VSS 0.30073f ; **FLOATING
C1707 a_11748_6109# VSS 0.17021f ; **FLOATING
C1708 a_10751_5878# VSS 0.19918f ; **FLOATING
C1709 a_10520_6292# VSS 0.03671f ; **FLOATING
C1710 a_10649_5878# VSS 0.47308f ; **FLOATING
C1711 a_10232_5871# VSS 1.52123f ; **FLOATING
C1712 a_10206_5835# VSS 0.08466f ; **FLOATING
C1713 a_9946_6305# VSS 0.18126f ; **FLOATING
C1714 a_9772_5843# VSS 0.12435f ; **FLOATING
C1715 a_9746_5805# VSS 0.06613f ; **FLOATING
C1716 a_9547_6172# VSS 0.16037f ; **FLOATING
C1717 a_9547_5942# VSS 0.11966f ; **FLOATING
C1718 a_6854_5454# VSS 3.66026f ; **FLOATING
C1719 a_6126_3816# VSS 13.6177f ; **FLOATING
C1720 a_6854_5986# VSS 1.41376f ; **FLOATING
C1721 a_5974_5723# VSS 2.40124f ; **FLOATING
C1722 a_6326_4590# VSS 1.03474f ; **FLOATING
C1723 a_2019_1047.t2 VSS 0.93027f ; **FLOATING
C1724 a_2019_1047.t3 VSS 0.70623f ; **FLOATING
C1725 a_2019_1047.n0 VSS 5.00884f ; **FLOATING
C1726 a_2019_1047.t4 VSS 0.70623f ; **FLOATING
C1727 a_2019_1047.n1 VSS 3.38862f ; **FLOATING
C1728 a_2019_1047.t5 VSS 0.70623f ; **FLOATING
C1729 a_2019_1047.n2 VSS 3.38862f ; **FLOATING
C1730 a_2019_1047.t6 VSS 0.70623f ; **FLOATING
C1731 a_2019_1047.n3 VSS 3.38862f ; **FLOATING
C1732 a_2019_1047.t7 VSS 0.70623f ; **FLOATING
C1733 a_2019_1047.n4 VSS 3.38862f ; **FLOATING
C1734 a_2019_1047.t8 VSS 0.70623f ; **FLOATING
C1735 a_2019_1047.n5 VSS 3.38862f ; **FLOATING
C1736 a_2019_1047.t9 VSS 5.45485f ; **FLOATING
C1737 a_2019_1047.t1 VSS 1.07257f ; **FLOATING
C1738 a_2019_1047.t0 VSS 0.30486f ; **FLOATING
C1739 a_2595_1047.t2 VSS 1.36703f ; **FLOATING
C1740 a_2595_1047.t3 VSS 1.02094f ; **FLOATING
C1741 a_2595_1047.n0 VSS 7.76123f ; **FLOATING
C1742 a_2595_1047.t4 VSS 1.02094f ; **FLOATING
C1743 a_2595_1047.n1 VSS 5.2734f ; **FLOATING
C1744 a_2595_1047.t5 VSS 1.02094f ; **FLOATING
C1745 a_2595_1047.n2 VSS 5.2734f ; **FLOATING
C1746 a_2595_1047.t6 VSS 1.02094f ; **FLOATING
C1747 a_2595_1047.n3 VSS 5.2734f ; **FLOATING
C1748 a_2595_1047.t7 VSS 1.02094f ; **FLOATING
C1749 a_2595_1047.n4 VSS 5.2734f ; **FLOATING
C1750 a_2595_1047.t8 VSS 1.02094f ; **FLOATING
C1751 a_2595_1047.n5 VSS 5.2734f ; **FLOATING
C1752 a_2595_1047.t9 VSS 1.02094f ; **FLOATING
C1753 a_2595_1047.n6 VSS 7.58547f ; **FLOATING
C1754 a_2595_1047.t1 VSS 1.75119f ; **FLOATING
C1755 a_2595_1047.t0 VSS 0.48227f ; **FLOATING
C1756 a_3171_1047.t2 VSS 1.38442f ; **FLOATING
C1757 a_3171_1047.t3 VSS 1.03734f ; **FLOATING
C1758 a_3171_1047.n0 VSS 7.77858f ; **FLOATING
C1759 a_3171_1047.t4 VSS 1.03734f ; **FLOATING
C1760 a_3171_1047.n1 VSS 5.28084f ; **FLOATING
C1761 a_3171_1047.t5 VSS 1.03734f ; **FLOATING
C1762 a_3171_1047.n2 VSS 5.28084f ; **FLOATING
C1763 a_3171_1047.t6 VSS 1.03734f ; **FLOATING
C1764 a_3171_1047.n3 VSS 5.28084f ; **FLOATING
C1765 a_3171_1047.t7 VSS 1.03734f ; **FLOATING
C1766 a_3171_1047.n4 VSS 5.28084f ; **FLOATING
C1767 a_3171_1047.t8 VSS 1.03734f ; **FLOATING
C1768 a_3171_1047.n5 VSS 5.28084f ; **FLOATING
C1769 a_3171_1047.t9 VSS 1.03734f ; **FLOATING
C1770 a_3171_1047.n6 VSS 7.68349f ; **FLOATING
C1771 a_3171_1047.t1 VSS 1.77027f ; **FLOATING
C1772 a_3171_1047.t0 VSS 0.48084f ; **FLOATING
C1773 a_3747_1047.t2 VSS 0.96885f ; **FLOATING
C1774 a_3747_1047.t3 VSS 0.7376f ; **FLOATING
C1775 a_3747_1047.n0 VSS 5.16746f ; **FLOATING
C1776 a_3747_1047.t4 VSS 0.7376f ; **FLOATING
C1777 a_3747_1047.n1 VSS 3.49313f ; **FLOATING
C1778 a_3747_1047.t5 VSS 0.7376f ; **FLOATING
C1779 a_3747_1047.n2 VSS 3.49313f ; **FLOATING
C1780 a_3747_1047.t6 VSS 0.7376f ; **FLOATING
C1781 a_3747_1047.n3 VSS 3.49313f ; **FLOATING
C1782 a_3747_1047.t7 VSS 0.7376f ; **FLOATING
C1783 a_3747_1047.n4 VSS 3.49313f ; **FLOATING
C1784 a_3747_1047.t8 VSS 0.7376f ; **FLOATING
C1785 a_3747_1047.n5 VSS 3.49313f ; **FLOATING
C1786 a_3747_1047.t9 VSS 0.7376f ; **FLOATING
C1787 a_3747_1047.n6 VSS 5.1869f ; **FLOATING
C1788 a_3747_1047.t1 VSS 1.18535f ; **FLOATING
C1789 a_3747_1047.t0 VSS 0.31338f ; **FLOATING
C1790 a_2595_311.t1 VSS 3.27037f ; **FLOATING
C1791 a_2595_311.t2 VSS 5.04145f ; **FLOATING
C1792 a_2595_311.t3 VSS 1.20632f ; **FLOATING
C1793 a_2595_311.n0 VSS 26.8668f ; **FLOATING
C1794 a_2595_311.t0 VSS 0.49572f ; **FLOATING
C1795 a_3171_311.t2 VSS 5.05009f ; **FLOATING
C1796 a_3171_311.t3 VSS 1.21149f ; **FLOATING
C1797 a_3171_311.n0 VSS 29.8499f ; **FLOATING
C1798 a_3171_311.t1 VSS 4.61154f ; **FLOATING
C1799 a_3171_311.t0 VSS 0.4973f ; **FLOATING
C1800 a_3747_311.t2 VSS 3.08793f ; **FLOATING
C1801 a_3747_311.t3 VSS 0.74323f ; **FLOATING
C1802 a_3747_311.n0 VSS 19.8622f ; **FLOATING
C1803 a_3747_311.t1 VSS 3.68403f ; **FLOATING
C1804 a_3747_311.t0 VSS 0.30496f ; **FLOATING
C1805 VSS.t378 VSS 3.22049f ; **FLOATING
C1806 VDD.n0 VSS 0.03676f ; **FLOATING
C1807 VDD.n1 VSS 1.12809f ; **FLOATING
C1808 VDD.n2 VSS 0.03006f ; **FLOATING
C1809 VDD.n3 VSS 0.46878f ; **FLOATING
C1810 VDD.n4 VSS 0.04222f ; **FLOATING
C1811 VDD.t0 VSS 49.913f ; **FLOATING
C1812 VDD.n5 VSS 0.46878f ; **FLOATING
C1813 VDD.n6 VSS 0.46878f ; **FLOATING
C1814 VDD.n7 VSS 0.04222f ; **FLOATING
C1815 VDD.n8 VSS 0.46878f ; **FLOATING
C1816 VDD.n9 VSS 0.46878f ; **FLOATING
C1817 VDD.n10 VSS 0.46878f ; **FLOATING
C1818 VDD.n11 VSS 0.07683f ; **FLOATING
C1819 VDD.n12 VSS 0.40392f ; **FLOATING
C1820 VDD.n14 VSS 0.36467f ; **FLOATING
C1821 VDD.n16 VSS 0.44721f ; **FLOATING
C1822 VDD.n17 VSS 0.13597f ; **FLOATING
C1823 VDD.n18 VSS 0.44721f ; **FLOATING
C1824 VDD.n19 VSS 0.13597f ; **FLOATING
C1825 VDD.n20 VSS 0.44721f ; **FLOATING
C1826 VDD.n22 VSS 0.44721f ; **FLOATING
C1827 VDD.n23 VSS 0.13597f ; **FLOATING
C1828 VDD.n24 VSS 0.44721f ; **FLOATING
C1829 VDD.n25 VSS 0.13597f ; **FLOATING
C1830 VDD.n26 VSS 0.44721f ; **FLOATING
C1831 VDD.n27 VSS 0.26251f ; **FLOATING
C1832 VDD.n28 VSS 0.22968f ; **FLOATING
C1833 VDD.n30 VSS 1.61292f ; **FLOATING
C1834 VDD.t7 VSS 43.7414f ; **FLOATING
C1835 VDD.n31 VSS 0.06197f ; **FLOATING
C1836 VDD.n32 VSS 0.13597f ; **FLOATING
C1837 VDD.n33 VSS 0.13597f ; **FLOATING
C1838 VDD.n34 VSS 0.03108f ; **FLOATING
C1839 VDD.t96 VSS 0.0187f ; **FLOATING
C1840 VDD.n35 VSS 0.02515f ; **FLOATING
C1841 VDD.n36 VSS 0.07731f ; **FLOATING
C1842 VDD.n37 VSS 0.0214f ; **FLOATING
C1843 VDD.n38 VSS 0.02356f ; **FLOATING
C1844 VDD.n39 VSS 0.01579f ; **FLOATING
C1845 VDD.n40 VSS 0.10228f ; **FLOATING
C1846 VDD.n42 VSS 0.15078f ; **FLOATING
C1847 VDD.n43 VSS 0.01387f ; **FLOATING
C1848 VDD.n44 VSS 0.06541f ; **FLOATING
C1849 VDD.n45 VSS 0.08542f ; **FLOATING
C1850 VDD.n47 VSS 0.08434f ; **FLOATING
C1851 VDD.n48 VSS 0.05909f ; **FLOATING
C1852 VDD.n49 VSS 0.05909f ; **FLOATING
C1853 VDD.n50 VSS 0.08434f ; **FLOATING
C1854 VDD.n51 VSS 0.05909f ; **FLOATING
C1855 VDD.n52 VSS 0.05909f ; **FLOATING
C1856 VDD.n53 VSS 0.08434f ; **FLOATING
C1857 VDD.n54 VSS 0.05909f ; **FLOATING
C1858 VDD.n55 VSS 0.05909f ; **FLOATING
C1859 VDD.n56 VSS 0.04008f ; **FLOATING
C1860 VDD.n57 VSS 0.02073f ; **FLOATING
C1861 VDD.n58 VSS 0.1421f ; **FLOATING
C1862 VDD.n59 VSS 0.04089f ; **FLOATING
C1863 VDD.n60 VSS 0.01022f ; **FLOATING
C1864 VDD.n61 VSS 0.02576f ; **FLOATING
C1865 VDD.n62 VSS 0.03846f ; **FLOATING
C1866 VDD.n63 VSS 0.02115f ; **FLOATING
C1867 VDD.n64 VSS 0.01579f ; **FLOATING
C1868 VDD.n65 VSS 0.10654f ; **FLOATING
C1869 VDD.n66 VSS 0.0515f ; **FLOATING
C1870 VDD.n67 VSS 0.20407f ; **FLOATING
C1871 VDD.n68 VSS 0.05909f ; **FLOATING
C1872 VDD.n69 VSS 0.0562f ; **FLOATING
C1873 VDD.n70 VSS 0.03173f ; **FLOATING
C1874 VDD.n71 VSS 0.01696f ; **FLOATING
C1875 VDD.n72 VSS 0.15117f ; **FLOATING
C1876 VDD.n73 VSS 0.03161f ; **FLOATING
C1877 VDD.n74 VSS 0.03565f ; **FLOATING
C1878 VDD.n75 VSS 0.13354f ; **FLOATING
C1879 VDD.n77 VSS 0.08627f ; **FLOATING
C1880 VDD.n78 VSS 0.13354f ; **FLOATING
C1881 VDD.n79 VSS 0.08627f ; **FLOATING
C1882 VDD.n81 VSS 0.13354f ; **FLOATING
C1883 VDD.n82 VSS 0.08627f ; **FLOATING
C1884 VDD.n84 VSS 0.02632f ; **FLOATING
C1885 VDD.n85 VSS 0.09628f ; **FLOATING
C1886 VDD.n86 VSS 0.13354f ; **FLOATING
C1887 VDD.n87 VSS 0.08627f ; **FLOATING
C1888 VDD.n89 VSS 0.13354f ; **FLOATING
C1889 VDD.n90 VSS 0.08627f ; **FLOATING
C1890 VDD.n92 VSS 0.13354f ; **FLOATING
C1891 VDD.n93 VSS 0.08627f ; **FLOATING
C1892 VDD.n95 VSS 0.08434f ; **FLOATING
C1893 VDD.n96 VSS 0.08434f ; **FLOATING
C1894 VDD.n97 VSS 0.08434f ; **FLOATING
C1895 VDD.n98 VSS 0.03061f ; **FLOATING
C1896 VDD.n99 VSS 0.01586f ; **FLOATING
C1897 VDD.n100 VSS 0.10037f ; **FLOATING
C1898 VDD.n101 VSS 0.04222f ; **FLOATING
C1899 VDD.n102 VSS 0.04222f ; **FLOATING
C1900 VDD.n103 VSS 0.04222f ; **FLOATING
C1901 VDD.n104 VSS 0.04222f ; **FLOATING
C1902 VDD.n105 VSS 0.13174f ; **FLOATING
C1903 VDD.t14 VSS 8.26826f ; **FLOATING
C1904 VDD.t30 VSS 0.03685f ; **FLOATING
C1905 VDD.t264 VSS 0.03685f ; **FLOATING
C1906 VDD.n106 VSS 0.12584f ; **FLOATING
C1907 VDD.n107 VSS 0.01583f ; **FLOATING
C1908 VDD.t28 VSS 0.04457f ; **FLOATING
C1909 VDD.t262 VSS 0.04457f ; **FLOATING
C1910 VDD.n108 VSS 0.14191f ; **FLOATING
C1911 VDD.n109 VSS 0.07511f ; **FLOATING
C1912 VDD.t94 VSS 0.03177f ; **FLOATING
C1913 VDD.n110 VSS 0.02157f ; **FLOATING
C1914 VDD.t93 VSS 0.02294f ; **FLOATING
C1915 VDD.t95 VSS 0.03551f ; **FLOATING
C1916 VDD.t97 VSS 0.03177f ; **FLOATING
C1917 VDD.t298 VSS 0.03177f ; **FLOATING
C1918 VDD.t99 VSS 0.03177f ; **FLOATING
C1919 VDD.n111 VSS 0.02157f ; **FLOATING
C1920 VDD.t98 VSS 0.02294f ; **FLOATING
C1921 VDD.t100 VSS 0.03551f ; **FLOATING
C1922 VDD.n112 VSS 0.01804f ; **FLOATING
C1923 VDD.t101 VSS 0.0187f ; **FLOATING
C1924 VDD.t102 VSS 0.03177f ; **FLOATING
C1925 VDD.n113 VSS 0.01894f ; **FLOATING
C1926 VDD.t285 VSS 0.03488f ; **FLOATING
C1927 VDD.t186 VSS 0.02373f ; **FLOATING
C1928 VDD.n114 VSS 0.11936f ; **FLOATING
C1929 VDD.t38 VSS 3.33454f ; **FLOATING
C1930 VDD.n115 VSS 0.64929f ; **FLOATING
C1931 VDD.n116 VSS 0.11549f ; **FLOATING
C1932 VDD.n117 VSS 0.02728f ; **FLOATING
C1933 VDD.t203 VSS 0.02621f ; **FLOATING
C1934 VDD.t244 VSS 0.02621f ; **FLOATING
C1935 VDD.n118 VSS 0.07778f ; **FLOATING
C1936 VDD.n119 VSS 0.03694f ; **FLOATING
C1937 VDD.t389 VSS 0.01215f ; **FLOATING
C1938 VDD.t173 VSS 0.06047f ; **FLOATING
C1939 VDD.n120 VSS 0.02449f ; **FLOATING
C1940 VDD.t248 VSS 0.01215f ; **FLOATING
C1941 VDD.t189 VSS 0.06047f ; **FLOATING
C1942 VDD.n121 VSS 0.02449f ; **FLOATING
C1943 VDD.n122 VSS 0.05407f ; **FLOATING
C1944 VDD.n123 VSS 0.01437f ; **FLOATING
C1945 VDD.t37 VSS 0.03562f ; **FLOATING
C1946 VDD.n124 VSS 0.06404f ; **FLOATING
C1947 VDD.n125 VSS 0.03522f ; **FLOATING
C1948 VDD.t183 VSS 0.03289f ; **FLOATING
C1949 VDD.n126 VSS 0.07632f ; **FLOATING
C1950 VDD.n127 VSS 0.02008f ; **FLOATING
C1951 VDD.t250 VSS 0.03685f ; **FLOATING
C1952 VDD.n128 VSS 0.16466f ; **FLOATING
C1953 VDD.t34 VSS 0.02621f ; **FLOATING
C1954 VDD.n129 VSS 0.14748f ; **FLOATING
C1955 VDD.t342 VSS 0.01215f ; **FLOATING
C1956 VDD.t174 VSS 0.06047f ; **FLOATING
C1957 VDD.n130 VSS 0.02449f ; **FLOATING
C1958 VDD.n131 VSS 0.0737f ; **FLOATING
C1959 VDD.n132 VSS 0.03694f ; **FLOATING
C1960 VDD.n133 VSS 0.0715f ; **FLOATING
C1961 VDD.n134 VSS 0.02957f ; **FLOATING
C1962 VDD.n135 VSS 0.01558f ; **FLOATING
C1963 VDD.n136 VSS 0.03575f ; **FLOATING
C1964 VDD.n137 VSS 0.03117f ; **FLOATING
C1965 VDD.n138 VSS 0.0356f ; **FLOATING
C1966 VDD.n139 VSS 0.03577f ; **FLOATING
C1967 VDD.n140 VSS 0.01573f ; **FLOATING
C1968 VDD.t334 VSS 0.03289f ; **FLOATING
C1969 VDD.t325 VSS 0.03289f ; **FLOATING
C1970 VDD.t258 VSS 0.02953f ; **FLOATING
C1971 VDD.t76 VSS 0.03289f ; **FLOATING
C1972 VDD.n141 VSS 0.02716f ; **FLOATING
C1973 VDD.t40 VSS 0.04317f ; **FLOATING
C1974 VDD.n142 VSS 0.0828f ; **FLOATING
C1975 VDD.n143 VSS 0.02422f ; **FLOATING
C1976 VDD.t207 VSS 0.03289f ; **FLOATING
C1977 VDD.n144 VSS 0.07849f ; **FLOATING
C1978 VDD.n145 VSS 0.01153f ; **FLOATING
C1979 VDD.t223 VSS 0.03666f ; **FLOATING
C1980 VDD.t373 VSS 0.03666f ; **FLOATING
C1981 VDD.t177 VSS 0.03666f ; **FLOATING
C1982 VDD.t257 VSS 0.03666f ; **FLOATING
C1983 VDD.t321 VSS 0.03289f ; **FLOATING
C1984 VDD.t139 VSS 0.03289f ; **FLOATING
C1985 VDD.n146 VSS 0.09515f ; **FLOATING
C1986 VDD.n147 VSS 0.01506f ; **FLOATING
C1987 VDD.t338 VSS 0.02429f ; **FLOATING
C1988 VDD.t44 VSS 0.02429f ; **FLOATING
C1989 VDD.n148 VSS 0.08389f ; **FLOATING
C1990 VDD.t157 VSS 0.03247f ; **FLOATING
C1991 VDD.t256 VSS 0.03247f ; **FLOATING
C1992 VDD.t333 VSS 0.02429f ; **FLOATING
C1993 VDD.t327 VSS 0.02429f ; **FLOATING
C1994 VDD.t158 VSS 0.03247f ; **FLOATING
C1995 VDD.t331 VSS 0.03247f ; **FLOATING
C1996 VDD.t322 VSS 0.02429f ; **FLOATING
C1997 VDD.t137 VSS 0.02429f ; **FLOATING
C1998 VDD.t339 VSS 0.03247f ; **FLOATING
C1999 VDD.t43 VSS 0.03247f ; **FLOATING
C2000 VDD.n149 VSS 0.07663f ; **FLOATING
C2001 VDD.t346 VSS 0.03666f ; **FLOATING
C2002 VDD.t156 VSS 0.03666f ; **FLOATING
C2003 VDD.t332 VSS 0.02429f ; **FLOATING
C2004 VDD.t326 VSS 0.02429f ; **FLOATING
C2005 VDD.t152 VSS 0.03247f ; **FLOATING
C2006 VDD.t138 VSS 0.03247f ; **FLOATING
C2007 VDD.n150 VSS 0.06965f ; **FLOATING
C2008 VDD.t153 VSS 0.03666f ; **FLOATING
C2009 VDD.t171 VSS 0.03666f ; **FLOATING
C2010 VDD.n151 VSS 0.08755f ; **FLOATING
C2011 VDD.n152 VSS 0.01174f ; **FLOATING
C2012 VDD.t224 VSS 0.03289f ; **FLOATING
C2013 VDD.t136 VSS 0.033f ; **FLOATING
C2014 VDD.t235 VSS 0.03289f ; **FLOATING
C2015 VDD.n153 VSS 0.06891f ; **FLOATING
C2016 VDD.n154 VSS 0.01294f ; **FLOATING
C2017 VDD.t384 VSS 0.03289f ; **FLOATING
C2018 VDD.t251 VSS 0.03289f ; **FLOATING
C2019 VDD.t214 VSS 0.03289f ; **FLOATING
C2020 VDD.t168 VSS 0.02953f ; **FLOATING
C2021 VDD.t364 VSS 0.02953f ; **FLOATING
C2022 VDD.t348 VSS 0.03289f ; **FLOATING
C2023 VDD.t409 VSS 0.10909f ; **FLOATING
C2024 VDD.t167 VSS 0.03171f ; **FLOATING
C2025 VDD.t272 VSS 0.04317f ; **FLOATING
C2026 VDD.t408 VSS 0.10909f ; **FLOATING
C2027 VDD.t196 VSS 0.03171f ; **FLOATING
C2028 VDD.t380 VSS 0.03289f ; **FLOATING
C2029 VDD.t197 VSS 0.02953f ; **FLOATING
C2030 VDD.t198 VSS 0.02953f ; **FLOATING
C2031 VDD.t201 VSS 0.02953f ; **FLOATING
C2032 VDD.t75 VSS 0.03289f ; **FLOATING
C2033 VDD.t276 VSS 0.03289f ; **FLOATING
C2034 VDD.t71 VSS 0.03289f ; **FLOATING
C2035 VDD.t368 VSS 0.03289f ; **FLOATING
C2036 VDD.t221 VSS 0.02953f ; **FLOATING
C2037 VDD.t24 VSS 0.04317f ; **FLOATING
C2038 VDD.t140 VSS 0.03289f ; **FLOATING
C2039 VDD.t220 VSS 0.02953f ; **FLOATING
C2040 VDD.t209 VSS 0.03289f ; **FLOATING
C2041 VDD.t267 VSS 0.02953f ; **FLOATING
C2042 VDD.t11 VSS 0.03289f ; **FLOATING
C2043 VDD.t357 VSS 0.02953f ; **FLOATING
C2044 VDD.t358 VSS 0.02953f ; **FLOATING
C2045 VDD.t122 VSS 0.04333f ; **FLOATING
C2046 VDD.t328 VSS 0.03289f ; **FLOATING
C2047 VDD.t361 VSS 0.02953f ; **FLOATING
C2048 VDD.t39 VSS 0.03289f ; **FLOATING
C2049 VDD.t379 VSS 0.03289f ; **FLOATING
C2050 VDD.t236 VSS 0.03289f ; **FLOATING
C2051 VDD.t178 VSS 0.02953f ; **FLOATING
C2052 VDD.t143 VSS 0.04317f ; **FLOATING
C2053 VDD.t164 VSS 0.02953f ; **FLOATING
C2054 VDD.t46 VSS 0.03289f ; **FLOATING
C2055 VDD.t20 VSS 0.02953f ; **FLOATING
C2056 VDD.t32 VSS 0.03289f ; **FLOATING
C2057 VDD.t265 VSS 0.03289f ; **FLOATING
C2058 VDD.t191 VSS 0.02953f ; **FLOATING
C2059 VDD.t192 VSS 0.02953f ; **FLOATING
C2060 VDD.t195 VSS 0.02953f ; **FLOATING
C2061 VDD.t390 VSS 0.03289f ; **FLOATING
C2062 VDD.t341 VSS 0.03289f ; **FLOATING
C2063 VDD.t16 VSS 0.03289f ; **FLOATING
C2064 VDD.t128 VSS 0.03289f ; **FLOATING
C2065 VDD.t351 VSS 0.04317f ; **FLOATING
C2066 VDD.t68 VSS 0.03289f ; **FLOATING
C2067 VDD.t215 VSS 0.03289f ; **FLOATING
C2068 VDD.t141 VSS 0.03289f ; **FLOATING
C2069 VDD.t15 VSS 0.03289f ; **FLOATING
C2070 VDD.t254 VSS 0.03492f ; **FLOATING
C2071 VDD.t26 VSS 0.04317f ; **FLOATING
C2072 VDD.t255 VSS 0.06167f ; **FLOATING
C2073 VDD.t74 VSS 0.03289f ; **FLOATING
C2074 VDD.t269 VSS 0.03289f ; **FLOATING
C2075 VDD.t252 VSS 0.03289f ; **FLOATING
C2076 VDD.t367 VSS 0.03289f ; **FLOATING
C2077 VDD.t22 VSS 0.02953f ; **FLOATING
C2078 VDD.t146 VSS 0.04317f ; **FLOATING
C2079 VDD.t319 VSS 0.03289f ; **FLOATING
C2080 VDD.t36 VSS 0.02953f ; **FLOATING
C2081 VDD.t323 VSS 0.03289f ; **FLOATING
C2082 VDD.t27 VSS 0.02953f ; **FLOATING
C2083 VDD.t77 VSS 0.03289f ; **FLOATING
C2084 VDD.t2 VSS 0.02953f ; **FLOATING
C2085 VDD.t3 VSS 0.02953f ; **FLOATING
C2086 VDD.t25 VSS 0.04333f ; **FLOATING
C2087 VDD.t240 VSS 0.03289f ; **FLOATING
C2088 VDD.t6 VSS 0.02953f ; **FLOATING
C2089 VDD.t115 VSS 0.03289f ; **FLOATING
C2090 VDD.t72 VSS 0.03289f ; **FLOATING
C2091 VDD.t387 VSS 0.03289f ; **FLOATING
C2092 VDD.t69 VSS 0.02953f ; **FLOATING
C2093 VDD.t175 VSS 0.04317f ; **FLOATING
C2094 VDD.t279 VSS 0.02953f ; **FLOATING
C2095 VDD.t67 VSS 0.03289f ; **FLOATING
C2096 VDD.t187 VSS 0.02953f ; **FLOATING
C2097 VDD.t283 VSS 0.03289f ; **FLOATING
C2098 VDD.t266 VSS 0.03289f ; **FLOATING
C2099 VDD.t117 VSS 0.02953f ; **FLOATING
C2100 VDD.t118 VSS 0.02953f ; **FLOATING
C2101 VDD.t121 VSS 0.02953f ; **FLOATING
C2102 VDD.t391 VSS 0.03289f ; **FLOATING
C2103 VDD.t165 VSS 0.03289f ; **FLOATING
C2104 VDD.t133 VSS 0.03289f ; **FLOATING
C2105 VDD.t129 VSS 0.03289f ; **FLOATING
C2106 VDD.t217 VSS 0.02953f ; **FLOATING
C2107 VDD.t273 VSS 0.04317f ; **FLOATING
C2108 VDD.t371 VSS 0.03289f ; **FLOATING
C2109 VDD.t355 VSS 0.02953f ; **FLOATING
C2110 VDD.t212 VSS 0.03289f ; **FLOATING
C2111 VDD.t64 VSS 0.02953f ; **FLOATING
C2112 VDD.t132 VSS 0.03289f ; **FLOATING
C2113 VDD.t230 VSS 0.02953f ; **FLOATING
C2114 VDD.t231 VSS 0.02953f ; **FLOATING
C2115 VDD.t18 VSS 0.04333f ; **FLOATING
C2116 VDD.t365 VSS 0.03289f ; **FLOATING
C2117 VDD.t234 VSS 0.02953f ; **FLOATING
C2118 VDD.t237 VSS 0.03289f ; **FLOATING
C2119 VDD.t79 VSS 0.03289f ; **FLOATING
C2120 VDD.t114 VSS 0.03289f ; **FLOATING
C2121 VDD.t150 VSS 0.04317f ; **FLOATING
C2122 VDD.t45 VSS 0.03955f ; **FLOATING
C2123 VDD.t392 VSS 0.10909f ; **FLOATING
C2124 VDD.t232 VSS 0.03171f ; **FLOATING
C2125 VDD.t393 VSS 0.10909f ; **FLOATING
C2126 VDD.t65 VSS 0.03171f ; **FLOATING
C2127 VDD.t394 VSS 0.10909f ; **FLOATING
C2128 VDD.t218 VSS 0.03171f ; **FLOATING
C2129 VDD.t81 VSS 0.04333f ; **FLOATING
C2130 VDD.t395 VSS 0.10909f ; **FLOATING
C2131 VDD.t119 VSS 0.03171f ; **FLOATING
C2132 VDD.t396 VSS 0.10909f ; **FLOATING
C2133 VDD.t116 VSS 0.03171f ; **FLOATING
C2134 VDD.t397 VSS 0.10909f ; **FLOATING
C2135 VDD.t70 VSS 0.03171f ; **FLOATING
C2136 VDD.t398 VSS 0.10909f ; **FLOATING
C2137 VDD.t4 VSS 0.03171f ; **FLOATING
C2138 VDD.t399 VSS 0.10909f ; **FLOATING
C2139 VDD.t1 VSS 0.03171f ; **FLOATING
C2140 VDD.t400 VSS 0.10909f ; **FLOATING
C2141 VDD.t23 VSS 0.03171f ; **FLOATING
C2142 VDD.n155 VSS 0.06197f ; **FLOATING
C2143 VDD.n156 VSS 0.01294f ; **FLOATING
C2144 VDD.n157 VSS 0.07327f ; **FLOATING
C2145 VDD.n158 VSS 0.01109f ; **FLOATING
C2146 VDD.n159 VSS 0.06463f ; **FLOATING
C2147 VDD.n160 VSS 0.01294f ; **FLOATING
C2148 VDD.n161 VSS 0.0797f ; **FLOATING
C2149 VDD.t63 VSS 0.04333f ; **FLOATING
C2150 VDD.t401 VSS 0.10909f ; **FLOATING
C2151 VDD.t193 VSS 0.03171f ; **FLOATING
C2152 VDD.t402 VSS 0.10909f ; **FLOATING
C2153 VDD.t21 VSS 0.03171f ; **FLOATING
C2154 VDD.t403 VSS 0.10909f ; **FLOATING
C2155 VDD.t163 VSS 0.03171f ; **FLOATING
C2156 VDD.t404 VSS 0.10909f ; **FLOATING
C2157 VDD.t359 VSS 0.03171f ; **FLOATING
C2158 VDD.t405 VSS 0.10909f ; **FLOATING
C2159 VDD.t268 VSS 0.03171f ; **FLOATING
C2160 VDD.t406 VSS 0.10909f ; **FLOATING
C2161 VDD.t219 VSS 0.03171f ; **FLOATING
C2162 VDD.t12 VSS 0.04333f ; **FLOATING
C2163 VDD.t407 VSS 0.10909f ; **FLOATING
C2164 VDD.t199 VSS 0.03171f ; **FLOATING
C2165 VDD.t108 VSS 0.06665f ; **FLOATING
C2166 VDD.n162 VSS 0.04831f ; **FLOATING
C2167 VDD.n163 VSS 0.04822f ; **FLOATING
C2168 VDD.n164 VSS 0.04822f ; **FLOATING
C2169 VDD.n165 VSS 0.04831f ; **FLOATING
C2170 VDD.n166 VSS 0.04831f ; **FLOATING
C2171 VDD.n167 VSS 0.04831f ; **FLOATING
C2172 VDD.n168 VSS 0.04822f ; **FLOATING
C2173 VDD.n169 VSS 0.04822f ; **FLOATING
C2174 VDD.n170 VSS 0.04822f ; **FLOATING
C2175 VDD.n171 VSS 0.04831f ; **FLOATING
C2176 VDD.n172 VSS 0.04831f ; **FLOATING
C2177 VDD.n173 VSS 0.04822f ; **FLOATING
C2178 VDD.n174 VSS 0.04822f ; **FLOATING
C2179 VDD.n175 VSS 0.04822f ; **FLOATING
C2180 VDD.n176 VSS 0.04831f ; **FLOATING
C2181 VDD.n177 VSS 0.04822f ; **FLOATING
C2182 VDD.n178 VSS 0.04822f ; **FLOATING
C2183 VDD.n179 VSS 0.04822f ; **FLOATING
C2184 VDD.n180 VSS 0.04822f ; **FLOATING
C2185 VDD.n181 VSS 0.04822f ; **FLOATING
C2186 VDD.n182 VSS 0.04831f ; **FLOATING
C2187 VDD.n183 VSS 0.04831f ; **FLOATING
C2188 VDD.n184 VSS 0.04822f ; **FLOATING
C2189 VDD.n185 VSS 0.04822f ; **FLOATING
C2190 VDD.n186 VSS 0.04831f ; **FLOATING
C2191 VDD.n187 VSS 0.04822f ; **FLOATING
C2192 VDD.n188 VSS 0.04822f ; **FLOATING
C2193 VDD.n189 VSS 0.04822f ; **FLOATING
C2194 VDD.n190 VSS 0.04822f ; **FLOATING
C2195 VDD.n191 VSS 0.04831f ; **FLOATING
C2196 VDD.n192 VSS 0.04822f ; **FLOATING
C2197 VDD.t104 VSS 0.03228f ; **FLOATING
C2198 VDD.t103 VSS 0.02302f ; **FLOATING
C2199 VDD.t107 VSS 0.03215f ; **FLOATING
C2200 VDD.t105 VSS 0.03551f ; **FLOATING
C2201 VDD.t106 VSS 0.01868f ; **FLOATING
C2202 VDD.t290 VSS 0.03177f ; **FLOATING
C2203 VDD.n193 VSS 0.0962f ; **FLOATING
C2204 VDD.n194 VSS 0.02356f ; **FLOATING
C2205 VDD.n195 VSS 0.07474f ; **FLOATING
C2206 VDD.n196 VSS 0.01379f ; **FLOATING
C2207 VDD.t41 VSS 0.03726f ; **FLOATING
C2208 VDD.n197 VSS 0.07759f ; **FLOATING
C2209 VDD.n198 VSS 0.03402f ; **FLOATING
C2210 VDD.t297 VSS 0.03177f ; **FLOATING
C2211 VDD.n199 VSS 0.10444f ; **FLOATING
C2212 VDD.n200 VSS 0.02356f ; **FLOATING
C2213 VDD.n201 VSS 0.05906f ; **FLOATING
C2214 VDD.n202 VSS 0.01379f ; **FLOATING
C2215 VDD.t375 VSS 0.03726f ; **FLOATING
C2216 VDD.n203 VSS 0.07759f ; **FLOATING
C2217 VDD.n204 VSS 0.03407f ; **FLOATING
C2218 VDD.t299 VSS 0.03177f ; **FLOATING
C2219 VDD.n205 VSS 0.10441f ; **FLOATING
C2220 VDD.n206 VSS 0.02356f ; **FLOATING
C2221 VDD.n207 VSS 0.05903f ; **FLOATING
C2222 VDD.n208 VSS 0.01381f ; **FLOATING
C2223 VDD.t8 VSS 0.03726f ; **FLOATING
C2224 VDD.n209 VSS 0.07756f ; **FLOATING
C2225 VDD.n210 VSS 0.03402f ; **FLOATING
C2226 VDD.t301 VSS 0.03177f ; **FLOATING
C2227 VDD.n211 VSS 0.10447f ; **FLOATING
C2228 VDD.n212 VSS 0.02356f ; **FLOATING
C2229 VDD.n213 VSS 0.05907f ; **FLOATING
C2230 VDD.n214 VSS 0.01381f ; **FLOATING
C2231 VDD.t208 VSS 0.03726f ; **FLOATING
C2232 VDD.n215 VSS 0.07756f ; **FLOATING
C2233 VDD.n216 VSS 0.03404f ; **FLOATING
C2234 VDD.t303 VSS 0.03177f ; **FLOATING
C2235 VDD.n217 VSS 0.10447f ; **FLOATING
C2236 VDD.n218 VSS 0.02356f ; **FLOATING
C2237 VDD.n219 VSS 0.05906f ; **FLOATING
C2238 VDD.n220 VSS 0.01381f ; **FLOATING
C2239 VDD.t205 VSS 0.03726f ; **FLOATING
C2240 VDD.n221 VSS 0.07756f ; **FLOATING
C2241 VDD.n222 VSS 0.03404f ; **FLOATING
C2242 VDD.t302 VSS 0.03177f ; **FLOATING
C2243 VDD.n223 VSS 0.10447f ; **FLOATING
C2244 VDD.n224 VSS 0.02356f ; **FLOATING
C2245 VDD.n225 VSS 0.05905f ; **FLOATING
C2246 VDD.n226 VSS 0.01379f ; **FLOATING
C2247 VDD.t188 VSS 0.03726f ; **FLOATING
C2248 VDD.n227 VSS 0.07761f ; **FLOATING
C2249 VDD.n228 VSS 0.03403f ; **FLOATING
C2250 VDD.t304 VSS 0.03177f ; **FLOATING
C2251 VDD.n229 VSS 0.10444f ; **FLOATING
C2252 VDD.n230 VSS 0.02356f ; **FLOATING
C2253 VDD.n231 VSS 0.05903f ; **FLOATING
C2254 VDD.n232 VSS 0.01379f ; **FLOATING
C2255 VDD.t282 VSS 0.03726f ; **FLOATING
C2256 VDD.n233 VSS 0.07761f ; **FLOATING
C2257 VDD.n234 VSS 0.03396f ; **FLOATING
C2258 VDD.t305 VSS 0.03177f ; **FLOATING
C2259 VDD.n235 VSS 0.10441f ; **FLOATING
C2260 VDD.n236 VSS 0.02356f ; **FLOATING
C2261 VDD.n237 VSS 0.0591f ; **FLOATING
C2262 VDD.n238 VSS 0.01379f ; **FLOATING
C2263 VDD.t127 VSS 0.03726f ; **FLOATING
C2264 VDD.n239 VSS 0.07759f ; **FLOATING
C2265 VDD.n240 VSS 0.03407f ; **FLOATING
C2266 VDD.t293 VSS 0.03177f ; **FLOATING
C2267 VDD.n241 VSS 0.10447f ; **FLOATING
C2268 VDD.n242 VSS 0.02356f ; **FLOATING
C2269 VDD.n243 VSS 0.05902f ; **FLOATING
C2270 VDD.n244 VSS 0.01379f ; **FLOATING
C2271 VDD.t123 VSS 0.03726f ; **FLOATING
C2272 VDD.n245 VSS 0.07761f ; **FLOATING
C2273 VDD.n246 VSS 0.034f ; **FLOATING
C2274 VDD.t307 VSS 0.03177f ; **FLOATING
C2275 VDD.n247 VSS 0.10444f ; **FLOATING
C2276 VDD.n248 VSS 0.02356f ; **FLOATING
C2277 VDD.n249 VSS 0.05906f ; **FLOATING
C2278 VDD.n250 VSS 0.01379f ; **FLOATING
C2279 VDD.t253 VSS 0.03726f ; **FLOATING
C2280 VDD.n251 VSS 0.07762f ; **FLOATING
C2281 VDD.n252 VSS 0.03401f ; **FLOATING
C2282 VDD.t309 VSS 0.03177f ; **FLOATING
C2283 VDD.n253 VSS 0.10438f ; **FLOATING
C2284 VDD.n254 VSS 0.02356f ; **FLOATING
C2285 VDD.n255 VSS 0.05905f ; **FLOATING
C2286 VDD.n256 VSS 0.01381f ; **FLOATING
C2287 VDD.t142 VSS 0.03726f ; **FLOATING
C2288 VDD.n257 VSS 0.07756f ; **FLOATING
C2289 VDD.n258 VSS 0.03404f ; **FLOATING
C2290 VDD.t306 VSS 0.03177f ; **FLOATING
C2291 VDD.n259 VSS 0.10441f ; **FLOATING
C2292 VDD.n260 VSS 0.02356f ; **FLOATING
C2293 VDD.n261 VSS 0.05906f ; **FLOATING
C2294 VDD.n262 VSS 0.01381f ; **FLOATING
C2295 VDD.t31 VSS 0.03726f ; **FLOATING
C2296 VDD.n263 VSS 0.07756f ; **FLOATING
C2297 VDD.n264 VSS 0.03404f ; **FLOATING
C2298 VDD.t308 VSS 0.03177f ; **FLOATING
C2299 VDD.n265 VSS 0.10447f ; **FLOATING
C2300 VDD.n266 VSS 0.02356f ; **FLOATING
C2301 VDD.n267 VSS 0.05906f ; **FLOATING
C2302 VDD.n268 VSS 0.01381f ; **FLOATING
C2303 VDD.t144 VSS 0.03726f ; **FLOATING
C2304 VDD.n269 VSS 0.07756f ; **FLOATING
C2305 VDD.n270 VSS 0.03407f ; **FLOATING
C2306 VDD.t286 VSS 0.03177f ; **FLOATING
C2307 VDD.n271 VSS 0.10447f ; **FLOATING
C2308 VDD.n272 VSS 0.02356f ; **FLOATING
C2309 VDD.n273 VSS 0.05903f ; **FLOATING
C2310 VDD.n274 VSS 0.01381f ; **FLOATING
C2311 VDD.t78 VSS 0.03726f ; **FLOATING
C2312 VDD.n275 VSS 0.07756f ; **FLOATING
C2313 VDD.n276 VSS 0.03402f ; **FLOATING
C2314 VDD.t300 VSS 0.03177f ; **FLOATING
C2315 VDD.n277 VSS 0.10447f ; **FLOATING
C2316 VDD.n278 VSS 0.02356f ; **FLOATING
C2317 VDD.n279 VSS 0.05906f ; **FLOATING
C2318 VDD.n280 VSS 0.01379f ; **FLOATING
C2319 VDD.t352 VSS 0.03726f ; **FLOATING
C2320 VDD.n281 VSS 0.07759f ; **FLOATING
C2321 VDD.n282 VSS 0.03407f ; **FLOATING
C2322 VDD.t296 VSS 0.03177f ; **FLOATING
C2323 VDD.n283 VSS 0.10447f ; **FLOATING
C2324 VDD.n284 VSS 0.02356f ; **FLOATING
C2325 VDD.n285 VSS 0.05903f ; **FLOATING
C2326 VDD.n286 VSS 0.01381f ; **FLOATING
C2327 VDD.t9 VSS 0.03726f ; **FLOATING
C2328 VDD.n287 VSS 0.0776f ; **FLOATING
C2329 VDD.n288 VSS 0.03399f ; **FLOATING
C2330 VDD.t292 VSS 0.03177f ; **FLOATING
C2331 VDD.n289 VSS 0.10444f ; **FLOATING
C2332 VDD.n290 VSS 0.02356f ; **FLOATING
C2333 VDD.n291 VSS 0.05907f ; **FLOATING
C2334 VDD.n292 VSS 0.01381f ; **FLOATING
C2335 VDD.t228 VSS 0.03726f ; **FLOATING
C2336 VDD.n293 VSS 0.07759f ; **FLOATING
C2337 VDD.n294 VSS 0.03401f ; **FLOATING
C2338 VDD.t288 VSS 0.03177f ; **FLOATING
C2339 VDD.n295 VSS 0.10441f ; **FLOATING
C2340 VDD.n296 VSS 0.02356f ; **FLOATING
C2341 VDD.n297 VSS 0.05905f ; **FLOATING
C2342 VDD.n298 VSS 0.01381f ; **FLOATING
C2343 VDD.t270 VSS 0.03726f ; **FLOATING
C2344 VDD.n299 VSS 0.07756f ; **FLOATING
C2345 VDD.n300 VSS 0.03404f ; **FLOATING
C2346 VDD.t310 VSS 0.03177f ; **FLOATING
C2347 VDD.n301 VSS 0.10447f ; **FLOATING
C2348 VDD.n302 VSS 0.02356f ; **FLOATING
C2349 VDD.n303 VSS 0.05906f ; **FLOATING
C2350 VDD.n304 VSS 0.01381f ; **FLOATING
C2351 VDD.t17 VSS 0.03726f ; **FLOATING
C2352 VDD.n305 VSS 0.07761f ; **FLOATING
C2353 VDD.n306 VSS 0.03397f ; **FLOATING
C2354 VDD.t311 VSS 0.03177f ; **FLOATING
C2355 VDD.n307 VSS 0.10447f ; **FLOATING
C2356 VDD.n308 VSS 0.02356f ; **FLOATING
C2357 VDD.n309 VSS 0.05908f ; **FLOATING
C2358 VDD.n310 VSS 0.01381f ; **FLOATING
C2359 VDD.t181 VSS 0.03726f ; **FLOATING
C2360 VDD.n311 VSS 0.07759f ; **FLOATING
C2361 VDD.n312 VSS 0.03401f ; **FLOATING
C2362 VDD.t295 VSS 0.03177f ; **FLOATING
C2363 VDD.n313 VSS 0.10444f ; **FLOATING
C2364 VDD.n314 VSS 0.02356f ; **FLOATING
C2365 VDD.n315 VSS 0.05904f ; **FLOATING
C2366 VDD.n316 VSS 0.01379f ; **FLOATING
C2367 VDD.t148 VSS 0.03726f ; **FLOATING
C2368 VDD.n317 VSS 0.07761f ; **FLOATING
C2369 VDD.n318 VSS 0.03401f ; **FLOATING
C2370 VDD.t312 VSS 0.03177f ; **FLOATING
C2371 VDD.n319 VSS 0.10438f ; **FLOATING
C2372 VDD.n320 VSS 0.02356f ; **FLOATING
C2373 VDD.n321 VSS 0.05905f ; **FLOATING
C2374 VDD.n322 VSS 0.01379f ; **FLOATING
C2375 VDD.t241 VSS 0.03726f ; **FLOATING
C2376 VDD.n323 VSS 0.07761f ; **FLOATING
C2377 VDD.n324 VSS 0.034f ; **FLOATING
C2378 VDD.t294 VSS 0.03177f ; **FLOATING
C2379 VDD.n325 VSS 0.10441f ; **FLOATING
C2380 VDD.n326 VSS 0.02356f ; **FLOATING
C2381 VDD.n327 VSS 0.05907f ; **FLOATING
C2382 VDD.n328 VSS 0.01381f ; **FLOATING
C2383 VDD.t180 VSS 0.03726f ; **FLOATING
C2384 VDD.n329 VSS 0.07759f ; **FLOATING
C2385 VDD.n330 VSS 0.03396f ; **FLOATING
C2386 VDD.t291 VSS 0.03177f ; **FLOATING
C2387 VDD.n331 VSS 0.10447f ; **FLOATING
C2388 VDD.n332 VSS 0.02356f ; **FLOATING
C2389 VDD.n333 VSS 0.05911f ; **FLOATING
C2390 VDD.n334 VSS 0.01381f ; **FLOATING
C2391 VDD.t145 VSS 0.03726f ; **FLOATING
C2392 VDD.n335 VSS 0.07758f ; **FLOATING
C2393 VDD.n336 VSS 0.034f ; **FLOATING
C2394 VDD.t314 VSS 0.03177f ; **FLOATING
C2395 VDD.n337 VSS 0.10447f ; **FLOATING
C2396 VDD.n338 VSS 0.02356f ; **FLOATING
C2397 VDD.n339 VSS 0.05906f ; **FLOATING
C2398 VDD.n340 VSS 0.01379f ; **FLOATING
C2399 VDD.t10 VSS 0.03726f ; **FLOATING
C2400 VDD.n341 VSS 0.07761f ; **FLOATING
C2401 VDD.n342 VSS 0.034f ; **FLOATING
C2402 VDD.t287 VSS 0.03177f ; **FLOATING
C2403 VDD.n343 VSS 0.10444f ; **FLOATING
C2404 VDD.n344 VSS 0.02356f ; **FLOATING
C2405 VDD.n345 VSS 0.05907f ; **FLOATING
C2406 VDD.n346 VSS 0.01381f ; **FLOATING
C2407 VDD.t166 VSS 0.03726f ; **FLOATING
C2408 VDD.n347 VSS 0.07758f ; **FLOATING
C2409 VDD.n348 VSS 0.034f ; **FLOATING
C2410 VDD.t289 VSS 0.03177f ; **FLOATING
C2411 VDD.n349 VSS 0.10438f ; **FLOATING
C2412 VDD.n350 VSS 0.02356f ; **FLOATING
C2413 VDD.n351 VSS 0.05906f ; **FLOATING
C2414 VDD.n352 VSS 0.01379f ; **FLOATING
C2415 VDD.t80 VSS 0.03726f ; **FLOATING
C2416 VDD.n353 VSS 0.07759f ; **FLOATING
C2417 VDD.n354 VSS 0.03407f ; **FLOATING
C2418 VDD.t315 VSS 0.03177f ; **FLOATING
C2419 VDD.n355 VSS 0.10438f ; **FLOATING
C2420 VDD.n356 VSS 0.02356f ; **FLOATING
C2421 VDD.n357 VSS 0.05902f ; **FLOATING
C2422 VDD.n358 VSS 0.01379f ; **FLOATING
C2423 VDD.t42 VSS 0.03726f ; **FLOATING
C2424 VDD.n359 VSS 0.07761f ; **FLOATING
C2425 VDD.n360 VSS 0.034f ; **FLOATING
C2426 VDD.t313 VSS 0.03177f ; **FLOATING
C2427 VDD.n361 VSS 0.10441f ; **FLOATING
C2428 VDD.n362 VSS 0.02356f ; **FLOATING
C2429 VDD.n363 VSS 0.05906f ; **FLOATING
C2430 VDD.n364 VSS 0.01379f ; **FLOATING
C2431 VDD.t19 VSS 0.03726f ; **FLOATING
C2432 VDD.n365 VSS 0.07759f ; **FLOATING
C2433 VDD.n366 VSS 0.03407f ; **FLOATING
C2434 VDD.t316 VSS 0.03177f ; **FLOATING
C2435 VDD.n367 VSS 0.10447f ; **FLOATING
C2436 VDD.n368 VSS 0.02356f ; **FLOATING
C2437 VDD.n369 VSS 0.05903f ; **FLOATING
C2438 VDD.n370 VSS 0.01381f ; **FLOATING
C2439 VDD.t280 VSS 0.03726f ; **FLOATING
C2440 VDD.n371 VSS 0.07759f ; **FLOATING
C2441 VDD.n372 VSS 0.03396f ; **FLOATING
C2442 VDD.t317 VSS 0.03177f ; **FLOATING
C2443 VDD.n373 VSS 0.10444f ; **FLOATING
C2444 VDD.n374 VSS 0.02356f ; **FLOATING
C2445 VDD.n375 VSS 0.05911f ; **FLOATING
C2446 VDD.n376 VSS 0.01381f ; **FLOATING
C2447 VDD.t149 VSS 0.03726f ; **FLOATING
C2448 VDD.n377 VSS 0.07759f ; **FLOATING
C2449 VDD.n378 VSS 0.03396f ; **FLOATING
C2450 VDD.t318 VSS 0.03177f ; **FLOATING
C2451 VDD.n379 VSS 0.08641f ; **FLOATING
C2452 VDD.n380 VSS 0.02356f ; **FLOATING
C2453 VDD.n381 VSS 0.0591f ; **FLOATING
C2454 VDD.n382 VSS 0.01379f ; **FLOATING
C2455 VDD.t154 VSS 0.03726f ; **FLOATING
C2456 VDD.n383 VSS 0.05917f ; **FLOATING
C2457 VDD.n384 VSS 0.01422f ; **FLOATING
C2458 VDD.t109 VSS 0.03177f ; **FLOATING
C2459 VDD.n385 VSS 0.02356f ; **FLOATING
C2460 VDD.t110 VSS 0.03551f ; **FLOATING
C2461 VDD.n386 VSS 0.06977f ; **FLOATING
C2462 VDD.t113 VSS 0.03177f ; **FLOATING
C2463 VDD.n387 VSS 0.02109f ; **FLOATING
C2464 VDD.t111 VSS 0.0307f ; **FLOATING
C2465 VDD.n388 VSS 0.01566f ; **FLOATING
C2466 VDD.n389 VSS 0.05922f ; **FLOATING
C2467 VDD.n390 VSS 0.05086f ; **FLOATING
C2468 VDD.n391 VSS 0.70226f ; **FLOATING
C2469 VDD.n392 VSS 2.34917f ; **FLOATING
C2470 VDD.n393 VSS 0.71785f ; **FLOATING
C2471 VDD.n394 VSS 0.01474f ; **FLOATING
C2472 VDD.t179 VSS 0.0217f ; **FLOATING
C2473 VDD.n395 VSS 0.06124f ; **FLOATING
C2474 VDD.n396 VSS 0.01536f ; **FLOATING
C2475 VDD.n397 VSS 0.01566f ; **FLOATING
C2476 VDD.n398 VSS 0.06778f ; **FLOATING
C2477 VDD.t55 VSS 0.06341f ; **FLOATING
C2478 VDD.n399 VSS 0.02214f ; **FLOATING
C2479 VDD.n400 VSS 0.0496f ; **FLOATING
C2480 VDD.t84 VSS 0.05674f ; **FLOATING
C2481 VDD.n401 VSS 0.02212f ; **FLOATING
C2482 VDD.t90 VSS 0.05674f ; **FLOATING
C2483 VDD.n402 VSS 0.06353f ; **FLOATING
C2484 VDD.n403 VSS 0.02212f ; **FLOATING
C2485 VDD.n404 VSS 0.0448f ; **FLOATING
C2486 VDD.t82 VSS 0.35877f ; **FLOATING
C2487 VDD.n405 VSS 0.01448f ; **FLOATING
C2488 VDD.n406 VSS 0.04478f ; **FLOATING
C2489 VDD.t47 VSS 0.06341f ; **FLOATING
C2490 VDD.n407 VSS 0.02214f ; **FLOATING
C2491 VDD.n408 VSS 0.06774f ; **FLOATING
C2492 VDD.n409 VSS 0.03577f ; **FLOATING
C2493 VDD.n410 VSS 0.08624f ; **FLOATING
C2494 VDD.t56 VSS 0.06341f ; **FLOATING
C2495 VDD.n411 VSS 0.04114f ; **FLOATING
C2496 VDD.t48 VSS 0.06341f ; **FLOATING
C2497 VDD.n412 VSS 0.04115f ; **FLOATING
C2498 VDD.n413 VSS 0.08624f ; **FLOATING
C2499 VDD.n414 VSS 0.0312f ; **FLOATING
C2500 VDD.n415 VSS 0.08646f ; **FLOATING
C2501 VDD.t58 VSS 0.06341f ; **FLOATING
C2502 VDD.n416 VSS 0.04114f ; **FLOATING
C2503 VDD.t50 VSS 0.06341f ; **FLOATING
C2504 VDD.n417 VSS 0.04115f ; **FLOATING
C2505 VDD.n418 VSS 0.08642f ; **FLOATING
C2506 VDD.n419 VSS 0.03564f ; **FLOATING
C2507 VDD.n420 VSS 0.08172f ; **FLOATING
C2508 VDD.t60 VSS 0.06341f ; **FLOATING
C2509 VDD.n421 VSS 0.04114f ; **FLOATING
C2510 VDD.t52 VSS 0.06341f ; **FLOATING
C2511 VDD.n422 VSS 0.04115f ; **FLOATING
C2512 VDD.n423 VSS 0.08168f ; **FLOATING
C2513 VDD.n424 VSS 0.03577f ; **FLOATING
C2514 VDD.n425 VSS 0.01573f ; **FLOATING
C2515 VDD.t13 VSS 12.4896f ; **FLOATING
C2516 VDD.t87 VSS 0.05674f ; **FLOATING
C2517 VDD.t92 VSS 0.05674f ; **FLOATING
C2518 VDD.n426 VSS 0.06908f ; **FLOATING
C2519 VDD.n427 VSS 0.02212f ; **FLOATING
C2520 VDD.t54 VSS 0.06341f ; **FLOATING
C2521 VDD.n428 VSS 0.06777f ; **FLOATING
C2522 VDD.n429 VSS 0.02214f ; **FLOATING
C2523 VDD.n430 VSS 0.06777f ; **FLOATING
C2524 VDD.t62 VSS 0.06341f ; **FLOATING
C2525 VDD.n431 VSS 0.02214f ; **FLOATING
C2526 VDD.n432 VSS 0.04478f ; **FLOATING
C2527 VDD.t85 VSS 0.35877f ; **FLOATING
C2528 VDD.n433 VSS 0.01448f ; **FLOATING
C2529 VDD.n434 VSS 0.048f ; **FLOATING
C2530 VDD.n435 VSS 0.02212f ; **FLOATING
C2531 VDD.n436 VSS 0.08074f ; **FLOATING
C2532 VDD.n437 VSS 0.04702f ; **FLOATING
.ends
