* NGSPICE file created from hx_delay_line_with_mux_dll.ext - technology: ihp-sg13g2

.subckt hx_delay_line_with_mux_dll VDD DELAY_OUT_LAST VSS DELAY_VBIASN DELAY_VBIASP
+ DLL_RESETN REF_CLK MUX_SEL0 MUX_SEL1 MUX_OUT MUX_SEL4 MUX_SEL2 MUX_SEL3
X0 a_14009_5878# REF_CLK VSS.t325 VSS.t324 sg13_lv_nmos ad=0.2516p pd=2.16u as=1.9998p ps=12.915u w=0.74u l=0.13u
X1 VDD.t45 a_4003_1842# a_4437_1842# VDD.t0 sg13_lv_pmos ad=0.2128p pd=1.5u as=0.3808p ps=2.92u w=1.12u l=0.13u
X2 VSS.t312 DLL_RESETN a_10040_6305# VSS.t311 sg13_lv_nmos ad=0.1626p pd=1.415u as=60.89999f ps=0.71u w=0.42u l=0.13u
X3 VSS.t134 a_15077_1842# a_15545_1044# VSS.t133 sg13_lv_nmos ad=0.1665p pd=1.19u as=0.2516p ps=2.16u w=0.74u l=0.13u
X4 a_27915_1044# a_27705_1044# VDD.t101 VDD.t4 sg13_lv_pmos ad=0.2128p pd=1.5u as=0.252p ps=1.57u w=1.12u l=0.13u
X5 VSS.t513 VDD.t408 VSS.t511 VSS.t512 sg13_lv_nmos ad=79.8f pd=0.8u as=0 ps=0 w=0.42u l=1u
X6 a_10951_2470# a_10713_1842# a_10843_1842# VDD.t0 sg13_lv_pmos ad=0.2128p pd=1.5u as=0.3808p ps=2.92u w=1.12u l=0.2u
X7 VSS.t205 a_3171_1047.t7 a_11924_1008# VSS.t204 sg13_lv_nmos ad=0.2516p pd=2.16u as=0.2516p ps=2.16u w=0.74u l=0.13u
X8 VDD.t177 VSS.t551 VDD.t176 VDD.t4 sg13_lv_pmos ad=0.34p pd=2.68u as=0 ps=0 w=1u l=1u
X9 VSS.t19 a_1256_1044# a_2967_1395# VSS.t340 sg13_lv_nmos ad=0.1331p pd=1.12u as=0.1216p ps=1.02u w=0.64u l=0.13u
X10 VSS.t513 VDD.t407 VSS.t513 VSS.t514 sg13_lv_nmos ad=0.1428p pd=1.52u as=0 ps=0 w=0.42u l=1u
X11 a_25153_1842# a_24957_1842# VSS.t125 VSS.t229 sg13_lv_nmos ad=0.2516p pd=2.16u as=0.1406p ps=1.12u w=0.74u l=0.13u
X12 VDD.t162 VSS.t33 VDD.t221 VDD.t4 sg13_lv_pmos ad=0.34p pd=2.68u as=0 ps=0 w=1u l=1u
X13 a_15108_6109# a_14851_6228# a_15270_6305# VSS.t187 sg13_lv_nmos ad=0.1428p pd=1.52u as=37.8f ps=0.6u w=0.42u l=0.13u
X14 VSS.t343 a_14851_6228# a_15688_5867# VSS.t410 sg13_lv_nmos ad=0.1406p pd=1.12u as=0.2516p ps=2.16u w=0.74u l=0.13u
X15 VSS.t254 VSS.t252 VSS.t252 VSS.t253 sg13_lv_nmos ad=0.68p pd=4.68u as=0 ps=0 w=2u l=1u
X16 a_15108_5325# a_12849_5867# VDD.t7 VDD.t6 sg13_lv_pmos ad=79.8f pd=0.8u as=1.03698p ps=6.245u w=0.42u l=0.13u
X17 a_25630_1044# a_2019_1047.t2 a_25528_1044# VSS.t206 sg13_lv_nmos ad=0.2516p pd=2.16u as=0.1406p ps=1.12u w=0.74u l=0.13u
X18 VDD.t264 DELAY_VBIASP a_19311_2470# VDD.t0 sg13_lv_pmos ad=0.3808p pd=2.92u as=0.2128p ps=1.5u w=1.12u l=0.6u
X19 a_16108_289# a_2019_311# a_16510_1044# VSS.t573 sg13_lv_nmos ad=0.2516p pd=2.16u as=0.2516p ps=2.16u w=0.74u l=0.13u
X20 VDD.t269 DELAY_VBIASP a_9431_2470# VDD.t0 sg13_lv_pmos ad=0.3808p pd=2.92u as=0.2128p ps=1.5u w=1.12u l=0.6u
X21 VSS.t557 VDD.t394 VSS.t361 VSS.t556 sg13_lv_nmos ad=0.1428p pd=1.52u as=0 ps=0 w=0.42u l=1u
X22 VSS.t249 VSS.t249 VSS.t251 VSS.t250 sg13_lv_nmos ad=0.68p pd=4.68u as=0 ps=0 w=2u l=1u
X23 VDD.t281 DELAY_VBIASP a_23111_2470# VDD.t0 sg13_lv_pmos ad=0.3808p pd=2.92u as=0.2128p ps=1.5u w=1.12u l=0.6u
X24 a_7390_1044# a_8231_1008# a_8155_1044# VDD.t4 sg13_lv_pmos ad=0.3808p pd=2.92u as=0.2128p ps=1.5u w=1.12u l=0.13u
X25 a_14009_5878# REF_CLK VDD.t7 VDD.t6 sg13_lv_pmos ad=0.4088p pd=2.97u as=1.03698p ps=6.245u w=1.12u l=0.13u
X26 VSS.t175 a_2595_311.t3 a_8745_519# VSS.t174 sg13_lv_nmos ad=0.2516p pd=2.16u as=0.2516p ps=2.16u w=0.74u l=0.13u
X27 a_11748_6109# DLL_RESETN VDD.t7 VDD.t6 sg13_lv_pmos ad=79.8f pd=0.8u as=1.10612p ps=6.66u w=0.42u l=0.13u
X28 VDD.t41 a_11491_6228# a_12158_5867# VDD.t6 sg13_lv_pmos ad=0.2128p pd=1.5u as=0.3864p ps=2.93u w=1.12u l=0.13u
X29 VDD.t260 DELAY_VBIASP DELAY_VBIASP VDD.t38 sg13_lv_pmos ad=0.3808p pd=2.92u as=1.0304p ps=4.08u w=1.12u l=0.6u
X30 a_17791_1842# a_17553_1842# a_17683_1842# VSS.t480 sg13_lv_nmos ad=0.1406p pd=1.12u as=0.2516p ps=2.16u w=0.74u l=0.2u
X31 VSS.t153 a_11748_6109# a_11397_6228# VSS.t246 sg13_lv_nmos ad=79.8f pd=0.8u as=0.1428p ps=1.52u w=0.42u l=0.13u
X32 VDD.t39 a_12037_1842# a_12505_1044# VDD.t4 sg13_lv_pmos ad=0.252p pd=1.57u as=0.3808p ps=2.92u w=1.12u l=0.13u
X33 a_16510_1044# a_2019_1047.t5 a_16408_1044# VSS.t422 sg13_lv_nmos ad=0.2516p pd=2.16u as=0.1406p ps=1.12u w=0.74u l=0.13u
X34 a_21591_1842# a_21353_1842# a_21483_1842# VSS.t570 sg13_lv_nmos ad=0.1406p pd=1.12u as=0.2516p ps=2.16u w=0.74u l=0.2u
X35 a_6153_1842# a_5957_1842# VSS.t104 VSS.t345 sg13_lv_nmos ad=0.2516p pd=2.16u as=0.1406p ps=1.12u w=0.74u l=0.13u
X36 VSS.t119 a_16163_1842# a_16597_1842# VSS.t438 sg13_lv_nmos ad=0.1406p pd=1.12u as=0.2516p ps=2.16u w=0.74u l=0.13u
X37 VSS.t367 a_3171_1047.t2 a_27124_1008# VSS.t366 sg13_lv_nmos ad=0.2516p pd=2.16u as=0.2516p ps=2.16u w=0.74u l=0.13u
X38 VDD.t106 a_11603_1842# a_12037_1842# VDD.t0 sg13_lv_pmos ad=0.2128p pd=1.5u as=0.3808p ps=2.92u w=1.12u l=0.13u
X39 VDD.t18 a_3171_311.t3 a_11785_519# VDD.t4 sg13_lv_pmos ad=0.3808p pd=2.92u as=0.3808p ps=2.92u w=1.12u l=0.13u
X40 a_6126_3816# a_6326_4590# VDD.t198 VDD.t6 sg13_lv_pmos ad=0.38p pd=2.38u as=0.38p ps=2.38u w=2u l=1u
X41 a_24393_1842# a_24197_1842# VDD.t169 VDD.t0 sg13_lv_pmos ad=0.3808p pd=2.92u as=0.2128p ps=1.5u w=1.12u l=0.13u
X42 a_5731_289# a_2595_311.t3 a_7390_1044# VSS.t173 sg13_lv_nmos ad=0.2516p pd=2.16u as=0.2516p ps=2.16u w=0.74u l=0.13u
X43 a_10430_1044# a_2595_1047.t7 a_11195_1044# VSS.t370 sg13_lv_nmos ad=0.2516p pd=2.16u as=0.1406p ps=1.12u w=0.74u l=0.13u
X44 a_13306_6305# a_12355_5867# VDD.t70 VDD.t6 sg13_lv_pmos ad=79.8f pd=0.8u as=0.1428p ps=1.52u w=0.42u l=0.13u
X45 a_23355_1044# a_23145_1044# VSS.t299 VSS.t298 sg13_lv_nmos ad=0.1406p pd=1.12u as=0.1665p ps=1.19u w=0.74u l=0.13u
X46 VDD.t271 DELAY_VBIASP a_14751_2470# VDD.t0 sg13_lv_pmos ad=0.3808p pd=2.92u as=0.2128p ps=1.5u w=1.12u l=0.6u
X47 VSS.t50 DELAY_VBIASN a_10191_1842# VSS.t49 sg13_lv_nmos ad=0.2516p pd=2.16u as=0.1406p ps=1.12u w=0.74u l=0.6u
X48 VSS.t170 a_3747_1047.t4 a_21911_1008# VSS.t169 sg13_lv_nmos ad=0.2516p pd=2.16u as=0.2516p ps=2.16u w=0.74u l=0.13u
X49 VSS.t123 a_19963_1842# a_20397_1842# VSS.t313 sg13_lv_nmos ad=0.1406p pd=1.12u as=0.2516p ps=2.16u w=0.74u l=0.13u
X50 a_6126_3816# a_6326_4590# VDD.t204 VDD.t6 sg13_lv_pmos ad=0.38p pd=2.38u as=0.38p ps=2.38u w=2u l=1u
X51 VDD.t202 a_6326_4590# a_6854_5454# VDD.t6 sg13_lv_pmos ad=0.38p pd=2.38u as=0.38p ps=2.38u w=2u l=1u
X52 VDD.t261 DELAY_VBIASP a_4111_2470# VDD.t0 sg13_lv_pmos ad=0.3808p pd=2.92u as=0.2128p ps=1.5u w=1.12u l=0.6u
X53 a_10328_1044# a_9757_1842# VDD.t361 VDD.t4 sg13_lv_pmos ad=0.2128p pd=1.5u as=0.3808p ps=2.92u w=1.12u l=0.13u
X54 a_20968_1044# a_20397_1842# VSS.t192 VSS.t191 sg13_lv_nmos ad=0.1406p pd=1.12u as=0.2516p ps=2.16u w=0.74u l=0.13u
X55 a_22590_1044# a_22564_1008# a_22488_1044# VDD.t4 sg13_lv_pmos ad=0.3808p pd=2.92u as=0.2128p ps=1.5u w=1.12u l=0.13u
X56 VDD.t94 VSS.t523 VDD.t93 VDD.t4 sg13_lv_pmos ad=0.19p pd=1.38u as=0 ps=0 w=1u l=1u
X57 a_8808_1044# a_8237_1842# VDD.t126 VDD.t4 sg13_lv_pmos ad=0.2128p pd=1.5u as=0.3808p ps=2.92u w=1.12u l=0.13u
X58 VDD.t208 a_6326_4590# a_6326_4590# VDD.t6 sg13_lv_pmos ad=0.38p pd=2.38u as=0.38p ps=2.38u w=2u l=1u
X59 a_4157_1313# REF_CLK VDD.t144 VDD.t4 sg13_lv_pmos ad=0.3808p pd=2.92u as=0.3808p ps=2.92u w=1.12u l=0.13u
X60 a_17031_2470# a_16793_1842# a_16923_1842# VDD.t0 sg13_lv_pmos ad=0.2128p pd=1.5u as=0.3808p ps=2.92u w=1.12u l=0.2u
X61 a_11473_1842# a_11277_1842# VSS.t22 VSS.t21 sg13_lv_nmos ad=0.2516p pd=2.16u as=0.1406p ps=1.12u w=0.74u l=0.13u
X62 VSS.t553 VDD.t396 VSS.t551 VSS.t552 sg13_lv_nmos ad=79.8f pd=0.8u as=0 ps=0 w=0.42u l=1u
X63 a_13306_5105# a_13132_5420# VDD.t369 VDD.t6 sg13_lv_pmos ad=79.8f pd=0.8u as=0.1428p ps=1.52u w=0.42u l=0.13u
X64 a_19448_1044# a_18877_1842# VSS.t11 VSS.t10 sg13_lv_nmos ad=0.1406p pd=1.12u as=0.2516p ps=2.16u w=0.74u l=0.13u
X65 a_10430_1044# a_3171_1047.t7 a_11848_1044# VSS.t203 sg13_lv_nmos ad=0.2516p pd=2.16u as=0.1406p ps=1.12u w=0.74u l=0.13u
X66 a_20831_2470# a_20593_1842# a_20723_1842# VDD.t0 sg13_lv_pmos ad=0.2128p pd=1.5u as=0.3808p ps=2.92u w=1.12u l=0.2u
X67 VSS.t529 VDD.t403 VSS.t527 VSS.t528 sg13_lv_nmos ad=79.8f pd=0.8u as=0 ps=0 w=0.42u l=1u
X68 VDD.t101 a_27237_1842# a_27705_1044# VDD.t4 sg13_lv_pmos ad=0.252p pd=1.57u as=0.3808p ps=2.92u w=1.12u l=0.13u
X69 a_5393_1842# a_5197_1842# VDD.t48 VDD.t0 sg13_lv_pmos ad=0.3808p pd=2.92u as=0.2128p ps=1.5u w=1.12u l=0.13u
X70 VDD.t274 DELAY_VBIASP a_17031_2470# VDD.t0 sg13_lv_pmos ad=0.3808p pd=2.92u as=0.2128p ps=1.5u w=1.12u l=0.6u
X71 VDD.t7 a_15108_6109# a_15053_5990# VDD.t6 sg13_lv_pmos ad=1.10612p pd=6.66u as=93.45f ps=0.865u w=0.42u l=0.13u
X72 VDD.t204 a_6326_4590# a_6854_5454# VDD.t6 sg13_lv_pmos ad=0.38p pd=2.38u as=0.38p ps=2.38u w=2u l=1u
X73 a_13818_6292# a_12849_5867# VSS.t182 VSS.t185 sg13_lv_nmos ad=37.8f pd=0.6u as=0.1701p ps=1.65u w=0.42u l=0.13u
X74 VDD.t102 a_26803_1842# a_27237_1842# VDD.t0 sg13_lv_pmos ad=0.2128p pd=1.5u as=0.3808p ps=2.92u w=1.12u l=0.13u
X75 VDD.t73 MUX_SEL1 a_3449_1395# VDD.t4 sg13_lv_pmos ad=0.1918p pd=1.5u as=0.1596p ps=1.22u w=0.84u l=0.13u
X76 a_14851_6228# a_14009_5878# a_13592_5871# VDD.t6 sg13_lv_pmos ad=0.2048p pd=1.63u as=0.34p ps=2.68u w=1u l=0.13u
X77 a_25630_1044# a_2595_1047.t2 a_26395_1044# VSS.t617 sg13_lv_nmos ad=0.2516p pd=2.16u as=0.1406p ps=1.12u w=0.74u l=0.13u
X78 VSS.t127 DELAY_VBIASN a_25391_1842# VSS.t126 sg13_lv_nmos ad=0.2516p pd=2.16u as=0.1406p ps=1.12u w=0.74u l=0.6u
X79 VSS.t80 DELAY_VBIASN VSS.t79 VSS.t71 sg13_lv_nmos ad=1.33p pd=7.38u as=0 ps=0 w=7u l=7u
X80 a_6635_1044# a_6425_1044# VDD.t147 VDD.t4 sg13_lv_pmos ad=0.2128p pd=1.5u as=0.252p ps=1.57u w=1.12u l=0.13u
X81 VDD.t128 DLL_RESETN a_9946_6305# VDD.t6 sg13_lv_pmos ad=0.36237p pd=2.605u as=79.8f ps=0.8u w=0.42u l=0.13u
X82 a_20315_1044# a_20105_1044# VDD.t211 VDD.t4 sg13_lv_pmos ad=0.2128p pd=1.5u as=0.252p ps=1.57u w=1.12u l=0.13u
X83 VDD.t287 a_2595_1047.t9 a_5191_1008# VDD.t4 sg13_lv_pmos ad=0.3808p pd=2.92u as=0.3808p ps=2.92u w=1.12u l=0.13u
X84 a_19311_2470# a_19073_1842# a_19203_1842# VDD.t0 sg13_lv_pmos ad=0.2128p pd=1.5u as=0.3808p ps=2.92u w=1.12u l=0.2u
X85 VSS.t148 a_1721_1395# a_2019_1047.t0 VSS.t358 sg13_lv_nmos ad=0.2812p pd=2.24u as=0.1406p ps=1.12u w=0.74u l=0.13u
X86 a_25528_1044# a_24957_1842# VDD.t82 VDD.t4 sg13_lv_pmos ad=0.2128p pd=1.5u as=0.3808p ps=2.92u w=1.12u l=0.13u
X87 VSS.t333 a_5957_1842# a_6425_1044# VSS.t344 sg13_lv_nmos ad=0.1665p pd=1.19u as=0.2516p ps=2.16u w=0.74u l=0.13u
X88 VSS.t606 a_2019_1047.t6 a_13444_1008# VSS.t605 sg13_lv_nmos ad=0.2516p pd=2.16u as=0.2516p ps=2.16u w=0.74u l=0.13u
X89 a_23111_2470# a_22873_1842# a_23003_1842# VDD.t0 sg13_lv_pmos ad=0.2128p pd=1.5u as=0.3808p ps=2.92u w=1.12u l=0.2u
X90 VSS.t511 VDD.t408 VSS.t511 VSS.t510 sg13_lv_nmos ad=0.1428p pd=1.52u as=0 ps=0 w=0.42u l=1u
X91 VSS.t215 a_15964_289# a_16851_309# VSS.t579 sg13_lv_nmos ad=0.1371p pd=1.12u as=0.2176p ps=1.96u w=0.64u l=0.13u
X92 a_10713_1842# a_10517_1842# VDD.t296 VDD.t0 sg13_lv_pmos ad=0.3808p pd=2.92u as=0.2128p ps=1.5u w=1.12u l=0.13u
X93 VDD.t238 a_17683_1842# a_18117_1842# VDD.t0 sg13_lv_pmos ad=0.2128p pd=1.5u as=0.3808p ps=2.92u w=1.12u l=0.13u
X94 a_16108_289# a_17865_519# a_16510_1044# VDD.t4 sg13_lv_pmos ad=0.3808p pd=2.92u as=0.3808p ps=2.92u w=1.12u l=0.13u
X95 a_26673_1842# a_26477_1842# VSS.t54 VSS.t300 sg13_lv_nmos ad=0.2516p pd=2.16u as=0.1406p ps=1.12u w=0.74u l=0.13u
X96 VDD.t50 a_7803_1842# a_8237_1842# VDD.t0 sg13_lv_pmos ad=0.2128p pd=1.5u as=0.3808p ps=2.92u w=1.12u l=0.13u
X97 a_4248_1044# a_4157_1313# VSS.t402 VSS.t478 sg13_lv_nmos ad=0.1406p pd=1.12u as=0.2516p ps=2.16u w=0.74u l=0.13u
X98 a_16108_289# a_3171_311.t2 a_22590_1044# VSS.t359 sg13_lv_nmos ad=0.2516p pd=2.16u as=0.2516p ps=2.16u w=0.74u l=0.13u
X99 VSS.t3 DELAY_VBIASN a_6391_1842# VSS.t96 sg13_lv_nmos ad=0.2516p pd=2.16u as=0.1406p ps=1.12u w=0.74u l=0.6u
X100 a_16408_1044# a_15837_1842# VDD.t5 VDD.t4 sg13_lv_pmos ad=0.2128p pd=1.5u as=0.3808p ps=2.92u w=1.12u l=0.13u
X101 a_10232_5871# a_10206_5835# VSS.t312 VSS.t311 sg13_lv_nmos ad=0.2516p pd=2.16u as=0.1626p ps=1.415u w=0.74u l=0.13u
X102 a_19550_1044# a_3747_1047.t4 a_21835_1044# VSS.t168 sg13_lv_nmos ad=0.2516p pd=2.16u as=0.1406p ps=1.12u w=0.74u l=0.13u
X103 VSS.t117 DELAY_VBIASN a_20831_1842# VSS.t116 sg13_lv_nmos ad=0.2516p pd=2.16u as=0.1406p ps=1.12u w=0.74u l=0.6u
X104 a_3171_311.t1 a_2873_331# VDD.t317 VDD.t4 sg13_lv_pmos ad=0.2128p pd=1.5u as=0.1918p ps=1.5u w=1.12u l=0.13u
X105 a_15304_4605# a_14851_6228# VDD.t216 VDD.t6 sg13_lv_pmos ad=0.4312p pd=3.01u as=0.2639p ps=1.81u w=1.12u l=0.13u
X106 a_13106_5357# a_12907_5420# VSS.t338 VSS.t337 sg13_lv_nmos ad=0.27427p pd=2.28u as=1.45407p ps=9.445u w=0.795u l=0.13u
X107 a_3747_311.t1 a_3449_331# VDD.t20 VDD.t4 sg13_lv_pmos ad=0.2128p pd=1.5u as=0.1918p ps=1.5u w=1.12u l=0.13u
X108 a_13132_5420# a_13106_5357# VDD.t7 VDD.t6 sg13_lv_pmos ad=0.3927p pd=2.99u as=1.10612p ps=6.66u w=1.155u l=0.13u
X109 a_7390_1044# a_9751_1008# a_9675_1044# VDD.t4 sg13_lv_pmos ad=0.3808p pd=2.92u as=0.2128p ps=1.5u w=1.12u l=0.13u
X110 VSS.t88 DELAY_VBIASN VSS.t86 VSS.t67 sg13_lv_nmos ad=1.33p pd=7.38u as=0 ps=0 w=7u l=7u
X111 a_10191_1842# a_9953_1842# a_10083_1842# VSS.t180 sg13_lv_nmos ad=0.1406p pd=1.12u as=0.2516p ps=2.16u w=0.74u l=0.2u
X112 VSS.t299 a_22677_1842# a_23145_1044# VSS.t396 sg13_lv_nmos ad=0.1665p pd=1.19u as=0.2516p ps=2.16u w=0.74u l=0.13u
X113 a_14751_2470# a_14513_1842# a_14643_1842# VDD.t0 sg13_lv_pmos ad=0.2128p pd=1.5u as=0.3808p ps=2.92u w=1.12u l=0.2u
X114 a_5731_289# a_8745_519# a_7390_1044# VDD.t4 sg13_lv_pmos ad=0.3808p pd=2.92u as=0.3808p ps=2.92u w=1.12u l=0.13u
X115 VDD.t345 VDD.t346 VDD.t347 VDD.t0 sg13_lv_pmos ad=0.2128p pd=1.5u as=0 ps=0 w=1.12u l=0.13u
X116 a_4111_2470# REF_CLK a_4003_1842# VDD.t0 sg13_lv_pmos ad=0.2128p pd=1.5u as=0.3808p ps=2.92u w=1.12u l=0.2u
X117 a_13566_5835# a_14009_5878# a_13306_6305# VSS.t355 sg13_lv_nmos ad=79.8f pd=0.8u as=0.1296p ps=1.52u w=0.42u l=0.13u
X118 a_13306_6305# a_14111_5878# a_13566_5835# VDD.t6 sg13_lv_pmos ad=0.1428p pd=1.52u as=79.8f ps=0.8u w=0.42u l=0.13u
X119 a_13592_5423# a_14111_5227# a_14851_5182# VSS.t600 sg13_lv_nmos ad=0.3473p pd=2.71u as=0.12665p ps=1.145u w=0.74u l=0.13u
X120 a_7673_1842# a_7477_1842# VSS.t95 VSS.t287 sg13_lv_nmos ad=0.2516p pd=2.16u as=0.1406p ps=1.12u w=0.74u l=0.13u
X121 VDD.t114 a_3171_1047.t5 a_18004_1008# VDD.t4 sg13_lv_pmos ad=0.3808p pd=2.92u as=0.3808p ps=2.92u w=1.12u l=0.13u
X122 VDD.t250 a_13123_1842# a_13557_1842# VDD.t0 sg13_lv_pmos ad=0.2128p pd=1.5u as=0.3808p ps=2.92u w=1.12u l=0.13u
X123 VDD.t46 a_3747_311.t2 a_26985_519# VDD.t4 sg13_lv_pmos ad=0.3808p pd=2.92u as=0.3808p ps=2.92u w=1.12u l=0.13u
X124 a_25913_1842# a_25717_1842# VDD.t148 VDD.t0 sg13_lv_pmos ad=0.3808p pd=2.92u as=0.2128p ps=1.5u w=1.12u l=0.13u
X125 a_10430_1044# a_3747_1047.t7 a_12715_1044# VSS.t28 sg13_lv_nmos ad=0.2516p pd=2.16u as=0.1406p ps=1.12u w=0.74u l=0.13u
X126 a_6326_4590# a_5974_5723# a_6126_3816# VSS.t138 sg13_lv_nmos ad=0.38p pd=2.38u as=0.68p ps=4.68u w=2u l=1u
X127 a_14235_1044# a_14025_1044# VDD.t179 VDD.t4 sg13_lv_pmos ad=0.2128p pd=1.5u as=0.252p ps=1.57u w=1.12u l=0.13u
X128 a_24875_1044# a_24665_1044# VSS.t162 VSS.t161 sg13_lv_nmos ad=0.1406p pd=1.12u as=0.1665p ps=1.19u w=0.74u l=0.13u
X129 VSS.t57 DELAY_VBIASN a_11711_1842# VSS.t56 sg13_lv_nmos ad=0.2516p pd=2.16u as=0.1406p ps=1.12u w=0.74u l=0.6u
X130 VDD.t17 a_3747_1047.t7 a_12791_1008# VDD.t4 sg13_lv_pmos ad=0.3808p pd=2.92u as=0.3808p ps=2.92u w=1.12u l=0.13u
X131 VSS.t352 a_2595_1047.t3 a_23431_1008# VSS.t351 sg13_lv_nmos ad=0.2516p pd=2.16u as=0.2516p ps=2.16u w=0.74u l=0.13u
X132 VSS.t115 a_21483_1842# a_21917_1842# VSS.t383 sg13_lv_nmos ad=0.1406p pd=1.12u as=0.2516p ps=2.16u w=0.74u l=0.13u
X133 VSS.t376 a_13557_1842# a_14025_1044# VSS.t463 sg13_lv_nmos ad=0.1665p pd=1.19u as=0.2516p ps=2.16u w=0.74u l=0.13u
X134 a_11848_1044# a_11277_1842# VDD.t15 VDD.t4 sg13_lv_pmos ad=0.2128p pd=1.5u as=0.3808p ps=2.92u w=1.12u l=0.13u
X135 VDD.t31 VSS.t563 VDD.t30 VDD.t4 sg13_lv_pmos ad=0.19p pd=1.38u as=0 ps=0 w=1u l=1u
X136 VDD.t7 a_12907_5186# a_12907_5420# VDD.t6 sg13_lv_pmos ad=1.10612p pd=6.66u as=0.2442p ps=2.06u w=0.66u l=0.13u
X137 a_25391_1842# a_25153_1842# a_25283_1842# VSS.t364 sg13_lv_nmos ad=0.1406p pd=1.12u as=0.2516p ps=2.16u w=0.74u l=0.2u
X138 a_12993_1842# a_12797_1842# VSS.t1 VSS.t382 sg13_lv_nmos ad=0.2516p pd=2.16u as=0.1406p ps=1.12u w=0.74u l=0.13u
X139 DELAY_OUT_LAST a_27997_1842# VDD.t219 VDD.t0 sg13_lv_pmos ad=0.3808p pd=2.92u as=0.2128p ps=1.5u w=1.12u l=0.13u
X140 VDD.t33 VSS.t563 VDD.t32 VDD.t4 sg13_lv_pmos ad=0.34p pd=2.68u as=0 ps=0 w=1u l=1u
X141 VDD.t211 a_19637_1842# a_20105_1044# VDD.t4 sg13_lv_pmos ad=0.252p pd=1.57u as=0.3808p ps=2.92u w=1.12u l=0.13u
X142 a_6854_5454# a_6326_4590# VDD.t200 VDD.t6 sg13_lv_pmos ad=0.38p pd=2.38u as=0.38p ps=2.38u w=2u l=1u
X143 VSS.t111 DELAY_VBIASN a_13991_1842# VSS.t110 sg13_lv_nmos ad=0.2516p pd=2.16u as=0.1406p ps=1.12u w=0.74u l=0.6u
X144 VSS.t551 VDD.t396 VSS.t551 VSS.t550 sg13_lv_nmos ad=0.1428p pd=1.52u as=0 ps=0 w=0.42u l=1u
X145 a_22590_1044# a_3171_1047.t3 a_24008_1044# VSS.t455 sg13_lv_nmos ad=0.2516p pd=2.16u as=0.1406p ps=1.12u w=0.74u l=0.13u
X146 a_6913_1842# a_6717_1842# VDD.t2 VDD.t0 sg13_lv_pmos ad=0.3808p pd=2.92u as=0.2128p ps=1.5u w=1.12u l=0.13u
X147 VDD.t275 DELAY_VBIASP a_18551_2470# VDD.t0 sg13_lv_pmos ad=0.3808p pd=2.92u as=0.2128p ps=1.5u w=1.12u l=0.6u
X148 VSS.t59 a_23763_1842# a_24197_1842# VSS.t362 sg13_lv_nmos ad=0.1406p pd=1.12u as=0.2516p ps=2.16u w=0.74u l=0.13u
X149 VSS.t527 VDD.t403 VSS.t33 VSS.t526 sg13_lv_nmos ad=0.1428p pd=1.52u as=0 ps=0 w=0.42u l=1u
X150 VDD.t12 a_1256_1044# a_2873_1395# VDD.t4 sg13_lv_pmos ad=0.1918p pd=1.5u as=0.1596p ps=1.22u w=0.84u l=0.13u
X151 a_3171_311.t0 a_2873_331# VSS.t289 VSS.t585 sg13_lv_nmos ad=0.1406p pd=1.12u as=0.1331p ps=1.12u w=0.74u l=0.13u
X152 VDD.t365 a_2873_331# a_3171_311.t1 VDD.t4 sg13_lv_pmos ad=0.4256p pd=3u as=0.2128p ps=1.5u w=1.12u l=0.13u
X153 a_16510_1044# a_17351_1008# a_17275_1044# VDD.t4 sg13_lv_pmos ad=0.3808p pd=2.92u as=0.2128p ps=1.5u w=1.12u l=0.13u
X154 a_25630_1044# a_3747_1047.t2 a_27915_1044# VSS.t25 sg13_lv_nmos ad=0.2516p pd=2.16u as=0.1406p ps=1.12u w=0.74u l=0.13u
X155 VSS.t129 DELAY_VBIASN a_26911_1842# VSS.t128 sg13_lv_nmos ad=0.2516p pd=2.16u as=0.1406p ps=1.12u w=0.74u l=0.6u
X156 a_3747_311.t0 a_3449_331# VSS.t38 VSS.t379 sg13_lv_nmos ad=0.1406p pd=1.12u as=0.1331p ps=1.12u w=0.74u l=0.13u
X157 VDD.t182 a_3449_331# a_3747_311.t1 VDD.t4 sg13_lv_pmos ad=0.4256p pd=3u as=0.2128p ps=1.5u w=1.12u l=0.13u
X158 VDD.t253 DELAY_VBIASP a_22351_2470# VDD.t0 sg13_lv_pmos ad=0.3808p pd=2.92u as=0.2128p ps=1.5u w=1.12u l=0.6u
X159 VDD.t16 a_3747_1047.t2 a_27991_1008# VDD.t4 sg13_lv_pmos ad=0.3808p pd=2.92u as=0.3808p ps=2.92u w=1.12u l=0.13u
X160 VDD.t299 VSS.t509 VDD.t92 VDD.t4 sg13_lv_pmos ad=0.19p pd=1.38u as=0 ps=0 w=1u l=1u
X161 a_13019_5831# a_15688_5403# VSS.t190 VSS.t304 sg13_lv_nmos ad=0.2516p pd=2.16u as=0.1406p ps=1.12u w=0.74u l=0.13u
X162 VDD.t319 a_3747_1047.t9 a_6711_1008# VDD.t4 sg13_lv_pmos ad=0.3808p pd=2.92u as=0.3808p ps=2.92u w=1.12u l=0.13u
X163 a_6854_5454# a_6326_4590# VDD.t203 VDD.t6 sg13_lv_pmos ad=0.38p pd=2.38u as=0.38p ps=2.38u w=2u l=1u
X164 a_9772_5843# a_9746_5805# VDD.t7 VDD.t6 sg13_lv_pmos ad=0.3927p pd=2.99u as=1.10612p ps=6.66u w=1.155u l=0.13u
X165 a_6391_1842# a_6153_1842# a_6283_1842# VSS.t493 sg13_lv_nmos ad=0.1406p pd=1.12u as=0.2516p ps=2.16u w=0.74u l=0.2u
X166 a_15273_1842# a_15077_1842# VSS.t106 VSS.t132 sg13_lv_nmos ad=0.2516p pd=2.16u as=0.1406p ps=1.12u w=0.74u l=0.13u
X167 a_19833_1842# a_19637_1842# VDD.t212 VDD.t0 sg13_lv_pmos ad=0.3808p pd=2.92u as=0.2128p ps=1.5u w=1.12u l=0.13u
X168 a_16108_289# a_23945_519# a_22590_1044# VDD.t4 sg13_lv_pmos ad=0.3808p pd=2.92u as=0.3808p ps=2.92u w=1.12u l=0.13u
X169 VDD.t206 a_6326_4590# a_6126_3816# VDD.t6 sg13_lv_pmos ad=0.38p pd=2.38u as=0.38p ps=2.38u w=2u l=1u
X170 a_9193_1842# a_8997_1842# VDD.t138 VDD.t0 sg13_lv_pmos ad=0.3808p pd=2.92u as=0.2128p ps=1.5u w=1.12u l=0.13u
X171 a_24631_2470# a_24393_1842# a_24523_1842# VDD.t0 sg13_lv_pmos ad=0.2128p pd=1.5u as=0.3808p ps=2.92u w=1.12u l=0.2u
X172 VSS.t5 a_15403_1842# a_15837_1842# VSS.t230 sg13_lv_nmos ad=0.1406p pd=1.12u as=0.2516p ps=2.16u w=0.74u l=0.13u
X173 a_8155_1044# a_7945_1044# VSS.t286 VSS.t331 sg13_lv_nmos ad=0.1406p pd=1.12u as=0.1665p ps=1.19u w=0.74u l=0.13u
X174 a_23633_1842# a_23437_1842# VDD.t229 VDD.t0 sg13_lv_pmos ad=0.3808p pd=2.92u as=0.2128p ps=1.5u w=1.12u l=0.13u
X175 VSS.t47 a_4763_1842# a_5197_1842# VSS.t171 sg13_lv_nmos ad=0.1406p pd=1.12u as=0.2516p ps=2.16u w=0.74u l=0.13u
X176 a_27048_1044# a_26477_1842# VSS.t302 VSS.t301 sg13_lv_nmos ad=0.1406p pd=1.12u as=0.2516p ps=2.16u w=0.74u l=0.13u
X177 VDD.t360 a_9323_1842# a_9757_1842# VDD.t0 sg13_lv_pmos ad=0.2128p pd=1.5u as=0.3808p ps=2.92u w=1.12u l=0.13u
X178 a_5768_1044# a_5197_1842# VSS.t430 VSS.t429 sg13_lv_nmos ad=0.1406p pd=1.12u as=0.2516p ps=2.16u w=0.74u l=0.13u
X179 a_6326_4590# a_6126_3816# a_5778_3367# VSS.t135 sg13_lv_nmos ad=0.38p pd=2.38u as=0.68p ps=4.68u w=2u l=1u
X180 DELAY_VBIASN DLL_RESETN VDD.t382 VDD.t38 sg13_lv_pmos ad=0.158p pd=1.245u as=0.272p ps=2.28u w=0.8u l=0.2u
X181 a_7390_1044# a_7364_1008# a_7288_1044# VDD.t4 sg13_lv_pmos ad=0.3808p pd=2.92u as=0.2128p ps=1.5u w=1.12u l=0.13u
X182 VSS.t78 DELAY_VBIASN VSS.t77 VSS.t60 sg13_lv_nmos ad=2.38p pd=14.68u as=0 ps=0 w=7u l=7u
X183 VSS.t41 DELAY_VBIASN a_7911_1842# VSS.t40 sg13_lv_nmos ad=0.2516p pd=2.16u as=0.1406p ps=1.12u w=0.74u l=0.6u
X184 VDD.t37 a_13019_5831# a_12943_5867# VDD.t6 sg13_lv_pmos ad=0.2128p pd=1.5u as=0.2128p ps=1.5u w=1.12u l=0.13u
X185 a_6854_5986# a_15304_4605# DELAY_VBIASN VDD.t38 sg13_lv_pmos ad=0.136p pd=1.14u as=0.158p ps=1.245u w=0.4u l=0.2u
X186 VDD.t80 VSS.t316 VDD.t78 VDD.t4 sg13_lv_pmos ad=0.19p pd=1.38u as=0 ps=0 w=1u l=1u
X187 a_11711_1842# a_11473_1842# a_11603_1842# VSS.t244 sg13_lv_nmos ad=0.1406p pd=1.12u as=0.2516p ps=2.16u w=0.74u l=0.2u
X188 VSS.t162 a_24197_1842# a_24665_1044# VSS.t485 sg13_lv_nmos ad=0.1665p pd=1.19u as=0.2516p ps=2.16u w=0.74u l=0.13u
X189 a_16510_1044# a_3171_1047.t5 a_17928_1044# VSS.t293 sg13_lv_nmos ad=0.2516p pd=2.16u as=0.1406p ps=1.12u w=0.74u l=0.13u
X190 a_15270_5105# a_12849_5867# VSS.t190 VSS.t189 sg13_lv_nmos ad=37.8f pd=0.6u as=79.8f ps=0.8u w=0.42u l=0.13u
X191 a_5974_5723# a_6126_3816# VSS.t141 VSS.t138 sg13_lv_nmos ad=0.38p pd=2.38u as=0.68p ps=4.68u w=2u l=1u
X192 VSS.t523 VDD.t405 VSS.t521 VSS.t522 sg13_lv_nmos ad=79.8f pd=0.8u as=0 ps=0 w=0.42u l=1u
X193 a_5631_2470# a_5393_1842# a_5523_1842# VDD.t0 sg13_lv_pmos ad=0.2128p pd=1.5u as=0.3808p ps=2.92u w=1.12u l=0.2u
X194 a_14513_1842# a_14317_1842# VDD.t42 VDD.t0 sg13_lv_pmos ad=0.3808p pd=2.92u as=0.2128p ps=1.5u w=1.12u l=0.13u
X195 a_4633_1842# a_4437_1842# VDD.t45 VDD.t0 sg13_lv_pmos ad=0.3808p pd=2.92u as=0.2128p ps=1.5u w=1.12u l=0.13u
X196 VSS.t50 a_10083_1842# a_10517_1842# VSS.t479 sg13_lv_nmos ad=0.1406p pd=1.12u as=0.2516p ps=2.16u w=0.74u l=0.13u
X197 VDD.t178 a_2019_1047.t4 a_19524_1008# VDD.t4 sg13_lv_pmos ad=0.3808p pd=2.92u as=0.3808p ps=2.92u w=1.12u l=0.13u
X198 VSS.t415 a_3171_1047.t4 a_21044_1008# VSS.t414 sg13_lv_nmos ad=0.2516p pd=2.16u as=0.2516p ps=2.16u w=0.74u l=0.13u
X199 VSS.t289 a_2873_331# a_3171_311.t0 VSS.t586 sg13_lv_nmos ad=0.2812p pd=2.24u as=0.1406p ps=1.12u w=0.74u l=0.13u
X200 a_13949_5496# a_13592_5423# VDD.t58 VDD.t6 sg13_lv_pmos ad=63f pd=0.72u as=0.1563p ps=1.22u w=0.42u l=0.13u
X201 VSS.t38 a_3449_331# a_3747_311.t0 VSS.t380 sg13_lv_nmos ad=0.2812p pd=2.24u as=0.1406p ps=1.12u w=0.74u l=0.13u
X202 a_15755_1044# a_15545_1044# VDD.t27 VDD.t4 sg13_lv_pmos ad=0.2128p pd=1.5u as=0.252p ps=1.57u w=1.12u l=0.13u
X203 VDD.t158 a_2595_1047.t6 a_14311_1008# VDD.t4 sg13_lv_pmos ad=0.3808p pd=2.92u as=0.3808p ps=2.92u w=1.12u l=0.13u
X204 VSS.t125 DELAY_VBIASN a_24631_1842# VSS.t124 sg13_lv_nmos ad=0.2516p pd=2.16u as=0.1406p ps=1.12u w=0.74u l=0.6u
X205 a_5115_1044# a_4905_1044# VDD.t237 VDD.t4 sg13_lv_pmos ad=0.2128p pd=1.5u as=0.252p ps=1.57u w=1.12u l=0.13u
X206 a_5974_5723# a_6126_3816# VSS.t142 VSS.t138 sg13_lv_nmos ad=0.38p pd=2.38u as=0.68p ps=4.68u w=2u l=1u
X207 VSS.t338 a_12907_5186# a_12907_5186# VSS.t492 sg13_lv_nmos ad=1.45407p pd=9.445u as=0.111p ps=1.34u w=0.3u l=0.13u
X208 a_18551_2470# a_18313_1842# a_18443_1842# VDD.t0 sg13_lv_pmos ad=0.2128p pd=1.5u as=0.3808p ps=2.92u w=1.12u l=0.2u
X209 VDD.t171 VSS.t549 VDD.t140 VDD.t4 sg13_lv_pmos ad=0.19p pd=1.38u as=0 ps=0 w=1u l=1u
X210 a_3171_1047.t0 a_2873_1395# VSS.t19 VSS.t18 sg13_lv_nmos ad=0.1406p pd=1.12u as=0.1331p ps=1.12u w=0.74u l=0.13u
X211 a_13121_5831# a_15688_5867# VSS.t343 VSS.t342 sg13_lv_nmos ad=0.2516p pd=2.16u as=0.1406p ps=1.12u w=0.74u l=0.13u
X212 VSS.t68 DELAY_VBIASN VSS.t70 VSS.t69 sg13_lv_nmos ad=1.33p pd=7.38u as=0 ps=0 w=7u l=7u
X213 VSS.t148 a_2297_1395# a_2595_1047.t0 VSS.t149 sg13_lv_nmos ad=0.2812p pd=2.24u as=0.1406p ps=1.12u w=0.74u l=0.13u
X214 VDD.t355 a_14851_5182# a_15108_5325# VDD.t6 sg13_lv_pmos ad=0.2639p pd=1.81u as=79.8f ps=0.8u w=0.42u l=0.13u
X215 a_22351_2470# a_22113_1842# a_22243_1842# VDD.t0 sg13_lv_pmos ad=0.2128p pd=1.5u as=0.3808p ps=2.92u w=1.12u l=0.2u
X216 VSS.t272 VSS.t272 VSS.t274 VSS.t273 sg13_lv_nmos ad=0.2516p pd=2.16u as=0 ps=0 w=0.74u l=0.13u
X217 a_26911_1842# a_26673_1842# a_26803_1842# VSS.t341 sg13_lv_nmos ad=0.1406p pd=1.12u as=0.2516p ps=2.16u w=0.74u l=0.2u
X218 VSS.t33 a_3171_311.t3 a_11785_519# VSS.t32 sg13_lv_nmos ad=0.2516p pd=2.16u as=0.2516p ps=2.16u w=0.74u l=0.13u
X219 VDD.t167 a_1721_1395# a_2019_1047.t1 VDD.t4 sg13_lv_pmos ad=0.4256p pd=3u as=0.2128p ps=1.5u w=1.12u l=0.13u
X220 a_12656_5864# DLL_RESETN VSS.t153 VSS.t616 sg13_lv_nmos ad=0.2516p pd=2.16u as=0.2516p ps=2.16u w=0.74u l=0.13u
X221 a_14851_6228# a_14009_5878# a_14757_6228# VSS.t187 sg13_lv_nmos ad=0.12665p pd=1.145u as=0.1428p ps=1.52u w=0.42u l=0.13u
X222 VDD.t150 a_16923_1842# a_17357_1842# VDD.t0 sg13_lv_pmos ad=0.2128p pd=1.5u as=0.3808p ps=2.92u w=1.12u l=0.13u
X223 a_2391_1395# MUX_SEL0 a_2297_1395# VSS.t471 sg13_lv_nmos ad=0.1216p pd=1.02u as=0.2176p ps=1.96u w=0.64u l=0.13u
X224 VSS.t148 a_1544_1044# a_1815_1395# VSS.t389 sg13_lv_nmos ad=0.1331p pd=1.12u as=0.1216p ps=1.02u w=0.64u l=0.13u
X225 a_13368_1044# a_12797_1842# VSS.t30 VSS.t381 sg13_lv_nmos ad=0.1406p pd=1.12u as=0.2516p ps=2.16u w=0.74u l=0.13u
X226 a_13400_5105# a_13132_5420# a_13306_5105# VSS.t593 sg13_lv_nmos ad=60.89999f pd=0.71u as=0.1428p ps=1.52u w=0.42u l=0.13u
X227 a_5731_289# a_3171_311.t3 a_10430_1044# VSS.t31 sg13_lv_nmos ad=0.2516p pd=2.16u as=0.2516p ps=2.16u w=0.74u l=0.13u
X228 VDD.t137 a_21157_1842# a_21625_1044# VDD.t4 sg13_lv_pmos ad=0.252p pd=1.57u as=0.3808p ps=2.92u w=1.12u l=0.13u
X229 VDD.t270 DELAY_VBIASP a_10951_2470# VDD.t0 sg13_lv_pmos ad=0.3808p pd=2.92u as=0.2128p ps=1.5u w=1.12u l=0.6u
X230 VSS.t5 DELAY_VBIASN a_15511_1842# VSS.t48 sg13_lv_nmos ad=0.2516p pd=2.16u as=0.1406p ps=1.12u w=0.74u l=0.6u
X231 a_6326_4590# a_6326_4590# VDD.t196 VDD.t6 sg13_lv_pmos ad=0.38p pd=2.38u as=0.38p ps=2.38u w=2u l=1u
X232 VSS.t84 DELAY_VBIASN VSS.t78 VSS.t63 sg13_lv_nmos ad=1.33p pd=7.38u as=0 ps=0 w=7u l=7u
X233 VDD.t36 a_20723_1842# a_21157_1842# VDD.t0 sg13_lv_pmos ad=0.2128p pd=1.5u as=0.3808p ps=2.92u w=1.12u l=0.13u
X234 VSS.t127 a_25283_1842# a_25717_1842# VSS.t334 sg13_lv_nmos ad=0.1406p pd=1.12u as=0.2516p ps=2.16u w=0.74u l=0.13u
X235 a_4350_1044# a_3747_1047.t9 a_6635_1044# VSS.t500 sg13_lv_nmos ad=0.2516p pd=2.16u as=0.1406p ps=1.12u w=0.74u l=0.13u
X236 VSS.t104 DELAY_VBIASN a_5631_1842# VSS.t103 sg13_lv_nmos ad=0.2516p pd=2.16u as=0.1406p ps=1.12u w=0.74u l=0.6u
X237 VDD.t213 a_2019_1047.t9 a_4324_1008# VDD.t4 sg13_lv_pmos ad=0.3808p pd=2.92u as=0.3808p ps=2.92u w=1.12u l=0.13u
X238 a_12849_5867# a_12656_5864# VSS.t153 VSS.t440 sg13_lv_nmos ad=0.1406p pd=1.12u as=0.2516p ps=2.16u w=0.74u l=0.13u
X239 a_16510_1044# a_18871_1008# a_18795_1044# VDD.t4 sg13_lv_pmos ad=0.3808p pd=2.92u as=0.2128p ps=1.5u w=1.12u l=0.13u
X240 a_19550_1044# a_2595_1047.t4 a_20315_1044# VSS.t291 sg13_lv_nmos ad=0.2516p pd=2.16u as=0.1406p ps=1.12u w=0.74u l=0.13u
X241 VDD.t200 a_6326_4590# a_6126_3816# VDD.t6 sg13_lv_pmos ad=0.38p pd=2.38u as=0.38p ps=2.38u w=2u l=1u
X242 VDD.t7 a_11491_6228# a_11748_6109# VDD.t6 sg13_lv_pmos ad=1.10612p pd=6.66u as=79.8f ps=0.8u w=0.42u l=0.13u
X243 a_12355_5867# a_12158_5867# VDD.t41 VDD.t6 sg13_lv_pmos ad=0.3808p pd=2.92u as=0.2128p ps=1.5u w=1.12u l=0.13u
X244 VDD.t280 DELAY_VBIASP a_23871_2470# VDD.t0 sg13_lv_pmos ad=0.3808p pd=2.92u as=0.2128p ps=1.5u w=1.12u l=0.6u
X245 VSS.t286 a_7477_1842# a_7945_1044# VSS.t285 sg13_lv_nmos ad=0.1665p pd=1.19u as=0.2516p ps=2.16u w=0.74u l=0.13u
X246 a_11910_6305# DLL_RESETN VSS.t153 VSS.t246 sg13_lv_nmos ad=37.8f pd=0.6u as=79.8f ps=0.8u w=0.42u l=0.13u
X247 VSS.t74 DELAY_VBIASN VSS.t76 VSS.t75 sg13_lv_nmos ad=1.33p pd=7.38u as=0 ps=0 w=7u l=7u
X248 a_13231_2470# a_12993_1842# a_13123_1842# VDD.t0 sg13_lv_pmos ad=0.2128p pd=1.5u as=0.3808p ps=2.92u w=1.12u l=0.2u
X249 VDD.t92 VSS.t506 VDD.t91 VDD.t4 sg13_lv_pmos ad=0.34p pd=2.68u as=0 ps=0 w=1u l=1u
X250 a_6326_4590# a_6126_3816# a_5778_3367# VSS.t135 sg13_lv_nmos ad=0.38p pd=2.38u as=0.68p ps=4.68u w=2u l=1u
X251 a_12233_1842# a_12037_1842# VDD.t106 VDD.t0 sg13_lv_pmos ad=0.3808p pd=2.92u as=0.2128p ps=1.5u w=1.12u l=0.13u
X252 a_7911_1842# a_7673_1842# a_7803_1842# VSS.t490 sg13_lv_nmos ad=0.1406p pd=1.12u as=0.2516p ps=2.16u w=0.74u l=0.2u
X253 a_16793_1842# a_16597_1842# VSS.t119 VSS.t297 sg13_lv_nmos ad=0.2516p pd=2.16u as=0.1406p ps=1.12u w=0.74u l=0.13u
X254 VDD.t130 a_3747_311.t3 a_14825_519# VDD.t4 sg13_lv_pmos ad=0.3808p pd=2.92u as=0.3808p ps=2.92u w=1.12u l=0.13u
X255 VDD.t55 a_12849_5867# a_13306_6305# VDD.t6 sg13_lv_pmos ad=0.36237p pd=2.605u as=79.8f ps=0.8u w=0.42u l=0.13u
X256 VDD.t330 VDD.t322 VDD.t203 VDD.t6 sg13_lv_pmos ad=0.68p pd=4.68u as=0 ps=0 w=2u l=1u
X257 VSS.t412 a_27563_1842# a_27997_1842# VSS.t460 sg13_lv_nmos ad=0.1406p pd=1.12u as=0.2516p ps=2.16u w=0.74u l=0.13u
X258 a_9675_1044# a_9465_1044# VSS.t378 VSS.t377 sg13_lv_nmos ad=0.1406p pd=1.12u as=0.1665p ps=1.19u w=0.74u l=0.13u
X259 VDD.t196 a_6326_4590# a_6854_5986# VDD.t6 sg13_lv_pmos ad=0.38p pd=2.38u as=0.38p ps=2.38u w=2u l=1u
X260 a_20593_1842# a_20397_1842# VSS.t123 VSS.t193 sg13_lv_nmos ad=0.2516p pd=2.16u as=0.1406p ps=1.12u w=0.74u l=0.13u
X261 VSS.t309 a_2595_1047.t8 a_8231_1008# VSS.t369 sg13_lv_nmos ad=0.2516p pd=2.16u as=0.2516p ps=2.16u w=0.74u l=0.13u
X262 VSS.t3 a_6283_1842# a_6717_1842# VSS.t2 sg13_lv_nmos ad=0.1406p pd=1.12u as=0.2516p ps=2.16u w=0.74u l=0.13u
X263 a_10430_1044# a_10404_1008# a_10328_1044# VDD.t4 sg13_lv_pmos ad=0.3808p pd=2.92u as=0.2128p ps=1.5u w=1.12u l=0.13u
X264 VDD.t282 DELAY_VBIASP a_26151_2470# VDD.t0 sg13_lv_pmos ad=0.3808p pd=2.92u as=0.2128p ps=1.5u w=1.12u l=0.6u
X265 a_7390_1044# a_8884_1008# a_8808_1044# VDD.t4 sg13_lv_pmos ad=0.3808p pd=2.92u as=0.2128p ps=1.5u w=1.12u l=0.13u
X266 a_11491_6228# a_10649_5878# a_11397_6228# VSS.t246 sg13_lv_nmos ad=0.12665p pd=1.145u as=0.1428p ps=1.52u w=0.42u l=0.13u
X267 VDD.t259 DELAY_VBIASP a_4871_2470# VDD.t0 sg13_lv_pmos ad=0.3808p pd=2.92u as=0.2128p ps=1.5u w=1.12u l=0.6u
X268 a_6126_3816# a_6126_3816# VSS.t136 VSS.t135 sg13_lv_nmos ad=0.38p pd=2.38u as=0.68p ps=4.68u w=2u l=1u
X269 a_3449_331# MUX_SEL2 VDD.t69 VDD.t4 sg13_lv_pmos ad=0.1596p pd=1.22u as=0.2856p ps=2.36u w=0.84u l=0.13u
X270 VDD.t315 VSS.t543 VDD.t313 VDD.t4 sg13_lv_pmos ad=0.19p pd=1.38u as=0 ps=0 w=1u l=1u
X271 a_19073_1842# a_18877_1842# VSS.t9 VSS.t8 sg13_lv_nmos ad=0.2516p pd=2.16u as=0.1406p ps=1.12u w=0.74u l=0.13u
X272 VDD.t27 a_15077_1842# a_15545_1044# VDD.t4 sg13_lv_pmos ad=0.252p pd=1.57u as=0.3808p ps=2.92u w=1.12u l=0.13u
X273 a_19550_1044# a_2019_1047.t4 a_19448_1044# VSS.t372 sg13_lv_nmos ad=0.2516p pd=2.16u as=0.1406p ps=1.12u w=0.74u l=0.13u
X274 VDD.t57 a_12849_5867# a_13306_5105# VDD.t6 sg13_lv_pmos ad=0.36237p pd=2.605u as=79.8f ps=0.8u w=0.42u l=0.13u
X275 VDD.t350 VDD.t348 VDD.t349 VDD.t0 sg13_lv_pmos ad=0.3808p pd=2.92u as=0 ps=0 w=1.12u l=0.6u
X276 VSS.t563 VDD.t393 VSS.t561 VSS.t562 sg13_lv_nmos ad=79.8f pd=0.8u as=0 ps=0 w=0.42u l=1u
X277 a_13592_5871# a_13566_5835# VSS.t182 VSS.t181 sg13_lv_nmos ad=0.2516p pd=2.16u as=0.1626p ps=1.415u w=0.74u l=0.13u
X278 VSS.t121 a_19203_1842# a_19637_1842# VSS.t461 sg13_lv_nmos ad=0.1406p pd=1.12u as=0.2516p ps=2.16u w=0.74u l=0.13u
X279 VDD.t311 VSS.t543 VDD.t310 VDD.t4 sg13_lv_pmos ad=0.19p pd=1.38u as=0 ps=0 w=1u l=1u
X280 a_15108_6109# a_12849_5867# VDD.t7 VDD.t6 sg13_lv_pmos ad=79.8f pd=0.8u as=1.03698p ps=6.245u w=0.42u l=0.13u
X281 VDD.t96 VSS.t523 VDD.t95 VDD.t4 sg13_lv_pmos ad=0.34p pd=2.68u as=0 ps=0 w=1u l=1u
X282 VSS.t188 a_15108_6109# a_14757_6228# VSS.t187 sg13_lv_nmos ad=79.8f pd=0.8u as=0.1428p ps=1.52u w=0.42u l=0.13u
X283 a_27433_1842# a_27237_1842# VDD.t102 VDD.t0 sg13_lv_pmos ad=0.3808p pd=2.92u as=0.2128p ps=1.5u w=1.12u l=0.13u
X284 VDD.t317 a_1256_289# a_2873_331# VDD.t4 sg13_lv_pmos ad=0.1918p pd=1.5u as=0.1596p ps=1.22u w=0.84u l=0.13u
X285 a_13470_1044# a_2595_1047.t6 a_14235_1044# VSS.t347 sg13_lv_nmos ad=0.2516p pd=2.16u as=0.1406p ps=1.12u w=0.74u l=0.13u
X286 VSS.t453 a_9444_4590# a_9444_4590# VSS.t444 sg13_lv_nmos ad=0.68p pd=4.68u as=0.38p ps=2.38u w=2u l=1u
X287 VSS.t102 a_8563_1842# a_8997_1842# VSS.t323 sg13_lv_nmos ad=0.1406p pd=1.12u as=0.2516p ps=2.16u w=0.74u l=0.13u
X288 VSS.t266 VSS.t266 VSS.t268 VSS.t267 sg13_lv_nmos ad=0.2516p pd=2.16u as=0 ps=0 w=0.74u l=0.13u
X289 VSS.t113 DELAY_VBIASN a_13231_1842# VSS.t112 sg13_lv_nmos ad=0.2516p pd=2.16u as=0.1406p ps=1.12u w=0.74u l=0.6u
X290 VDD.t65 a_3171_1047.t7 a_11924_1008# VDD.t4 sg13_lv_pmos ad=0.3808p pd=2.92u as=0.3808p ps=2.92u w=1.12u l=0.13u
X291 VSS.t609 a_2019_1047.t3 a_22564_1008# VSS.t608 sg13_lv_nmos ad=0.2516p pd=2.16u as=0.2516p ps=2.16u w=0.74u l=0.13u
X292 a_15053_5420# a_14111_5227# a_14851_5182# VDD.t6 sg13_lv_pmos ad=93.45f pd=0.865u as=0.2048p ps=1.63u w=0.42u l=0.13u
X293 VSS.t265 VSS.t261 VSS.t261 VSS.t263 sg13_lv_nmos ad=0.1406p pd=1.12u as=0 ps=0 w=0.74u l=0.13u
X294 VSS.t52 a_23003_1842# a_23437_1842# VSS.t417 sg13_lv_nmos ad=0.1406p pd=1.12u as=0.2516p ps=2.16u w=0.74u l=0.13u
X295 VSS.t563 VDD.t392 VSS.t563 VSS.t564 sg13_lv_nmos ad=0.1428p pd=1.52u as=0 ps=0 w=0.42u l=1u
X296 VDD.t262 DELAY_VBIASP a_7151_2470# VDD.t0 sg13_lv_pmos ad=0.3808p pd=2.92u as=0.2128p ps=1.5u w=1.12u l=0.6u
X297 a_5778_3367# VSS.t419 VSS.t418 rppd l=32u w=1u
X298 a_25630_1044# a_25604_1008# a_25528_1044# VDD.t4 sg13_lv_pmos ad=0.3808p pd=2.92u as=0.2128p ps=1.5u w=1.12u l=0.13u
X299 a_10206_5835# a_10649_5878# a_10589_5914# VDD.t6 sg13_lv_pmos ad=79.8f pd=0.8u as=63f ps=0.72u w=0.42u l=0.13u
X300 a_15511_1842# a_15273_1842# a_15403_1842# VSS.t17 sg13_lv_nmos ad=0.1406p pd=1.12u as=0.2516p ps=2.16u w=0.74u l=0.2u
X301 a_10520_6292# a_10751_5878# a_10206_5835# VSS.t592 sg13_lv_nmos ad=0.2373p pd=1.97u as=79.8f ps=0.8u w=0.42u l=0.13u
X302 a_11693_5990# a_10751_5878# a_11491_6228# VDD.t6 sg13_lv_pmos ad=93.45f pd=0.865u as=0.2048p ps=1.63u w=0.42u l=0.13u
X303 a_18313_1842# a_18117_1842# VDD.t238 VDD.t0 sg13_lv_pmos ad=0.3808p pd=2.92u as=0.2128p ps=1.5u w=1.12u l=0.13u
X304 a_5731_289# a_11785_519# a_10430_1044# VDD.t4 sg13_lv_pmos ad=0.3808p pd=2.92u as=0.3808p ps=2.92u w=1.12u l=0.13u
X305 VSS.t509 VDD.t409 VSS.t507 VSS.t508 sg13_lv_nmos ad=79.8f pd=0.8u as=0 ps=0 w=0.42u l=1u
X306 a_9431_2470# a_9193_1842# a_9323_1842# VDD.t0 sg13_lv_pmos ad=0.2128p pd=1.5u as=0.3808p ps=2.92u w=1.12u l=0.2u
X307 a_17275_1044# a_17065_1044# VSS.t242 VSS.t241 sg13_lv_nmos ad=0.1406p pd=1.12u as=0.1665p ps=1.19u w=0.74u l=0.13u
X308 VDD.t140 VSS.t178 VDD.t139 VDD.t4 sg13_lv_pmos ad=0.34p pd=2.68u as=0 ps=0 w=1u l=1u
X309 VSS.t7 a_3747_1047.t6 a_15831_1008# VSS.t13 sg13_lv_nmos ad=0.2516p pd=2.16u as=0.2516p ps=2.16u w=0.74u l=0.13u
X310 a_23871_2470# a_23633_1842# a_23763_1842# VDD.t0 sg13_lv_pmos ad=0.2128p pd=1.5u as=0.3808p ps=2.92u w=1.12u l=0.2u
X311 VSS.t111 a_13883_1842# a_14317_1842# VSS.t159 sg13_lv_nmos ad=0.1406p pd=1.12u as=0.2516p ps=2.16u w=0.74u l=0.13u
X312 VSS.t167 a_3747_311.t2 a_26985_519# VSS.t166 sg13_lv_nmos ad=0.2516p pd=2.16u as=0.2516p ps=2.16u w=0.74u l=0.13u
X313 a_8433_1842# a_8237_1842# VDD.t50 VDD.t0 sg13_lv_pmos ad=0.3808p pd=2.92u as=0.2128p ps=1.5u w=1.12u l=0.13u
X314 VDD.t8 a_18443_1842# a_18877_1842# VDD.t0 sg13_lv_pmos ad=0.2128p pd=1.5u as=0.3808p ps=2.92u w=1.12u l=0.13u
X315 a_22113_1842# a_21917_1842# VDD.t185 VDD.t0 sg13_lv_pmos ad=0.3808p pd=2.92u as=0.2128p ps=1.5u w=1.12u l=0.13u
X316 a_4350_1044# a_2019_1047.t9 a_4248_1044# VSS.t400 sg13_lv_nmos ad=0.2516p pd=2.16u as=0.1406p ps=1.12u w=0.74u l=0.13u
X317 a_14888_1044# a_14317_1842# VSS.t349 VSS.t587 sg13_lv_nmos ad=0.1406p pd=1.12u as=0.2516p ps=2.16u w=0.74u l=0.13u
X318 a_13880_5118# a_13592_5423# a_13818_5118# VSS.t243 sg13_lv_nmos ad=0.1428p pd=1.52u as=37.8f ps=0.6u w=0.42u l=0.13u
X319 a_16108_289# a_3747_311.t2 a_25630_1044# VSS.t165 sg13_lv_nmos ad=0.2516p pd=2.16u as=0.2516p ps=2.16u w=0.74u l=0.13u
X320 VDD.t252 DELAY_VBIASP a_12471_2470# VDD.t0 sg13_lv_pmos ad=0.3808p pd=2.92u as=0.2128p ps=1.5u w=1.12u l=0.6u
X321 VSS.t108 a_4003_1842# a_4437_1842# VSS.t164 sg13_lv_nmos ad=0.1406p pd=1.12u as=0.2516p ps=2.16u w=0.74u l=0.13u
X322 a_16510_1044# a_16484_1008# a_16408_1044# VDD.t4 sg13_lv_pmos ad=0.3808p pd=2.92u as=0.2128p ps=1.5u w=1.12u l=0.13u
X323 VSS.t153 a_13121_5831# a_13045_6215# VSS.t152 sg13_lv_nmos ad=0.2516p pd=2.16u as=0.1406p ps=1.12u w=0.74u l=0.13u
X324 VDD.t121 a_14851_5182# a_15688_5403# VDD.t6 sg13_lv_pmos ad=0.2128p pd=1.5u as=0.3864p ps=2.93u w=1.12u l=0.13u
X325 VDD.t193 a_22243_1842# a_22677_1842# VDD.t0 sg13_lv_pmos ad=0.2128p pd=1.5u as=0.3808p ps=2.92u w=1.12u l=0.13u
X326 VDD.t172 a_3171_1047.t2 a_27124_1008# VDD.t4 sg13_lv_pmos ad=0.3808p pd=2.92u as=0.3808p ps=2.92u w=1.12u l=0.13u
X327 VDD.t20 MUX_SEL3 a_3449_331# VDD.t4 sg13_lv_pmos ad=0.1918p pd=1.5u as=0.1596p ps=1.22u w=0.84u l=0.13u
X328 a_2595_311.t1 a_2297_331# VDD.t111 VDD.t4 sg13_lv_pmos ad=0.2128p pd=1.5u as=0.1918p ps=1.5u w=1.12u l=0.13u
X329 a_10430_1044# a_11271_1008# a_11195_1044# VDD.t4 sg13_lv_pmos ad=0.3808p pd=2.92u as=0.2128p ps=1.5u w=1.12u l=0.13u
X330 a_14009_5084# DELAY_OUT_LAST VSS.t338 VSS.t354 sg13_lv_nmos ad=0.2516p pd=2.16u as=1.45407p ps=9.445u w=0.74u l=0.13u
X331 a_23355_1044# a_23145_1044# VDD.t117 VDD.t4 sg13_lv_pmos ad=0.2128p pd=1.5u as=0.252p ps=1.57u w=1.12u l=0.13u
X332 VDD.t47 a_3747_1047.t4 a_21911_1008# VDD.t4 sg13_lv_pmos ad=0.3808p pd=2.92u as=0.3808p ps=2.92u w=1.12u l=0.13u
X333 VSS.t378 a_8997_1842# a_9465_1044# VSS.t425 sg13_lv_nmos ad=0.1665p pd=1.19u as=0.2516p ps=2.16u w=0.74u l=0.13u
X334 a_13592_5423# a_13566_5328# VDD.t57 VDD.t6 sg13_lv_pmos ad=0.34p pd=2.68u as=0.36237p ps=2.605u w=1u l=0.13u
X335 a_6126_3816# a_5974_5723# a_6326_4590# VSS.t138 sg13_lv_nmos ad=0.68p pd=4.68u as=0.38p ps=2.38u w=2u l=1u
X336 a_20968_1044# a_20397_1842# VDD.t59 VDD.t4 sg13_lv_pmos ad=0.2128p pd=1.5u as=0.3808p ps=2.92u w=1.12u l=0.13u
X337 a_10951_1842# a_10713_1842# a_10843_1842# VSS.t247 sg13_lv_nmos ad=0.1406p pd=1.12u as=0.2516p ps=2.16u w=0.74u l=0.2u
X338 VSS.t424 a_2019_1047.t5 a_16484_1008# VSS.t423 sg13_lv_nmos ad=0.2516p pd=2.16u as=0.2516p ps=2.16u w=0.74u l=0.13u
X339 a_26151_2470# a_25913_1842# a_26043_1842# VDD.t0 sg13_lv_pmos ad=0.2128p pd=1.5u as=0.3808p ps=2.92u w=1.12u l=0.2u
X340 a_9444_4590# a_6854_5454# a_6854_5454# VSS.t583 sg13_lv_nmos ad=0.68p pd=4.68u as=0.38p ps=2.38u w=2u l=1u
X341 a_13753_1842# a_13557_1842# VDD.t250 VDD.t0 sg13_lv_pmos ad=0.3808p pd=2.92u as=0.2128p ps=1.5u w=1.12u l=0.13u
X342 VDD.t136 a_1721_331# a_2019_311# VDD.t4 sg13_lv_pmos ad=0.4256p pd=3u as=0.2128p ps=1.5u w=1.12u l=0.13u
X343 a_4871_2470# a_4633_1842# a_4763_1842# VDD.t0 sg13_lv_pmos ad=0.2128p pd=1.5u as=0.3808p ps=2.92u w=1.12u l=0.2u
X344 VSS.t591 a_3171_1047.t9 a_5844_1008# VSS.t590 sg13_lv_nmos ad=0.2516p pd=2.16u as=0.2516p ps=2.16u w=0.74u l=0.13u
X345 VSS.t316 VDD.t401 VSS.t316 VSS.t534 sg13_lv_nmos ad=79.8f pd=0.8u as=0 ps=0 w=0.42u l=1u
X346 VDD.t52 a_2595_311.t2 a_20905_519# VDD.t4 sg13_lv_pmos ad=0.3808p pd=2.92u as=0.3808p ps=2.92u w=1.12u l=0.13u
X347 VDD.t112 a_2297_331# a_2595_311.t1 VDD.t4 sg13_lv_pmos ad=0.4256p pd=3u as=0.2128p ps=1.5u w=1.12u l=0.13u
X348 a_14009_5084# DELAY_OUT_LAST VDD.t7 VDD.t6 sg13_lv_pmos ad=0.4088p pd=2.97u as=1.10612p ps=6.66u w=1.12u l=0.13u
X349 VSS.t24 a_2595_1047.t7 a_11271_1008# VSS.t371 sg13_lv_nmos ad=0.2516p pd=2.16u as=0.2516p ps=2.16u w=0.74u l=0.13u
X350 VSS.t121 DELAY_VBIASN a_19311_1842# VSS.t120 sg13_lv_nmos ad=0.2516p pd=2.16u as=0.1406p ps=1.12u w=0.74u l=0.6u
X351 VSS.t445 a_9444_4590# a_9444_3912# VSS.t444 sg13_lv_nmos ad=0.68p pd=4.68u as=0.38p ps=2.38u w=2u l=1u
X352 a_13880_5118# a_14111_5227# a_13566_5328# VSS.t599 sg13_lv_nmos ad=0.2373p pd=1.97u as=79.8f ps=0.8u w=0.42u l=0.13u
X353 VDD.t83 a_24523_1842# a_24957_1842# VDD.t0 sg13_lv_pmos ad=0.2128p pd=1.5u as=0.3808p ps=2.92u w=1.12u l=0.13u
X354 VSS.t234 a_3747_1047.t8 a_9751_1008# VSS.t233 sg13_lv_nmos ad=0.2516p pd=2.16u as=0.2516p ps=2.16u w=0.74u l=0.13u
X355 VSS.t100 DELAY_VBIASN a_9431_1842# VSS.t99 sg13_lv_nmos ad=0.2516p pd=2.16u as=0.1406p ps=1.12u w=0.74u l=0.6u
X356 a_19448_1044# a_18877_1842# VDD.t9 VDD.t4 sg13_lv_pmos ad=0.2128p pd=1.5u as=0.3808p ps=2.92u w=1.12u l=0.13u
X357 VSS.t153 a_11491_6228# a_12158_5867# VSS.t346 sg13_lv_nmos ad=0.1406p pd=1.12u as=0.2516p ps=2.16u w=0.74u l=0.13u
X358 a_13566_5328# a_14009_5084# a_13949_5496# VDD.t6 sg13_lv_pmos ad=79.8f pd=0.8u as=63f ps=0.72u w=0.42u l=0.13u
X359 VSS.t52 DELAY_VBIASN a_23111_1842# VSS.t51 sg13_lv_nmos ad=0.2516p pd=2.16u as=0.1406p ps=1.12u w=0.74u l=0.6u
X360 a_10430_1044# a_11924_1008# a_11848_1044# VDD.t4 sg13_lv_pmos ad=0.3808p pd=2.92u as=0.2128p ps=1.5u w=1.12u l=0.13u
X361 VDD.t284 DELAY_VBIASP a_27671_2470# VDD.t0 sg13_lv_pmos ad=0.3808p pd=2.92u as=0.2128p ps=1.5u w=1.12u l=0.6u
X362 a_6854_5986# a_6326_4590# VDD.t195 VDD.t6 sg13_lv_pmos ad=0.38p pd=2.38u as=0.38p ps=2.38u w=2u l=1u
X363 VSS.t82 DELAY_VBIASN DELAY_VBIASP VSS.t81 sg13_lv_nmos ad=0.2516p pd=2.16u as=0.6808p ps=3.32u w=0.74u l=0.6u
X364 a_25630_1044# a_26471_1008# a_26395_1044# VDD.t4 sg13_lv_pmos ad=0.3808p pd=2.92u as=0.2128p ps=1.5u w=1.12u l=0.13u
X365 VSS.t64 DELAY_VBIASN VSS.t66 VSS.t65 sg13_lv_nmos ad=1.33p pd=7.38u as=0 ps=0 w=7u l=7u
X366 a_10040_6305# a_9772_5843# a_9946_6305# VSS.t494 sg13_lv_nmos ad=60.89999f pd=0.71u as=0.1428p ps=1.52u w=0.42u l=0.13u
X367 a_7151_2470# a_6913_1842# a_7043_1842# VDD.t0 sg13_lv_pmos ad=0.2128p pd=1.5u as=0.3808p ps=2.92u w=1.12u l=0.2u
X368 a_16033_1842# a_15837_1842# VDD.t3 VDD.t0 sg13_lv_pmos ad=0.3808p pd=2.92u as=0.2128p ps=1.5u w=1.12u l=0.13u
X369 VDD.t198 a_6326_4590# a_6326_4590# VDD.t6 sg13_lv_pmos ad=0.38p pd=2.38u as=0.38p ps=2.38u w=2u l=1u
X370 VDD.t320 a_15964_289# a_16851_309# VDD.t4 sg13_lv_pmos ad=0.2086p pd=1.5u as=0.34p ps=2.68u w=1u l=0.13u
X371 VDD.t313 VSS.t543 VDD.t312 VDD.t4 sg13_lv_pmos ad=0.34p pd=2.68u as=0 ps=0 w=1u l=1u
X372 a_15464_3684# a_14851_5182# VSS.t190 VSS.t568 sg13_lv_nmos ad=0.2849p pd=2.25u as=0.2516p ps=2.16u w=0.74u l=0.13u
X373 VSS.t57 a_11603_1842# a_12037_1842# VSS.t245 sg13_lv_nmos ad=0.1406p pd=1.12u as=0.2516p ps=2.16u w=0.74u l=0.13u
X374 VSS.t549 VDD.t397 VSS.t547 VSS.t548 sg13_lv_nmos ad=79.8f pd=0.8u as=0 ps=0 w=0.42u l=1u
X375 VDD.t93 VSS.t521 VDD.t215 VDD.t4 sg13_lv_pmos ad=0.34p pd=2.68u as=0 ps=0 w=1u l=1u
X376 VDD.t147 a_5957_1842# a_6425_1044# VDD.t4 sg13_lv_pmos ad=0.252p pd=1.57u as=0.3808p ps=2.92u w=1.12u l=0.13u
X377 a_24393_1842# a_24197_1842# VSS.t59 VSS.t486 sg13_lv_nmos ad=0.2516p pd=2.16u as=0.1406p ps=1.12u w=0.74u l=0.13u
X378 a_3747_1047.t0 a_3449_1395# VSS.t222 VSS.t221 sg13_lv_nmos ad=0.1406p pd=1.12u as=0.1331p ps=1.12u w=0.74u l=0.13u
X379 a_1544_1044# MUX_SEL1 VSS.t148 VSS.t475 sg13_lv_nmos ad=0.2516p pd=2.16u as=0.2516p ps=2.16u w=0.74u l=0.13u
X380 VDD.t310 VSS.t541 VDD.t354 VDD.t4 sg13_lv_pmos ad=0.34p pd=2.68u as=0 ps=0 w=1u l=1u
X381 a_3171_1047.t1 a_2873_1395# VDD.t12 VDD.t4 sg13_lv_pmos ad=0.2128p pd=1.5u as=0.1918p ps=1.5u w=1.12u l=0.13u
X382 a_13470_1044# a_3747_1047.t6 a_15755_1044# VSS.t12 sg13_lv_nmos ad=0.2516p pd=2.16u as=0.1406p ps=1.12u w=0.74u l=0.13u
X383 VDD.t61 a_15464_3684# a_9712_3912# VSS.t194 sg13_lv_nmos ad=0.232p pd=2.08u as=0.136p ps=1.14u w=0.4u l=0.2u
X384 VDD.t44 a_5523_1842# a_5957_1842# VDD.t0 sg13_lv_pmos ad=0.2128p pd=1.5u as=0.3808p ps=2.92u w=1.12u l=0.13u
X385 VDD.t29 a_2297_1395# a_2595_1047.t1 VDD.t4 sg13_lv_pmos ad=0.4256p pd=3u as=0.2128p ps=1.5u w=1.12u l=0.13u
X386 VSS.t106 DELAY_VBIASN a_14751_1842# VSS.t105 sg13_lv_nmos ad=0.2516p pd=2.16u as=0.1406p ps=1.12u w=0.74u l=0.6u
X387 a_2967_1395# MUX_SEL1 a_2873_1395# VSS.t476 sg13_lv_nmos ad=0.1216p pd=1.02u as=0.2176p ps=1.96u w=0.64u l=0.13u
X388 a_4350_1044# a_2595_1047.t9 a_5115_1044# VSS.t468 sg13_lv_nmos ad=0.2516p pd=2.16u as=0.1406p ps=1.12u w=0.74u l=0.13u
X389 VDD.t377 a_2019_1047.t6 a_13444_1008# VDD.t4 sg13_lv_pmos ad=0.3808p pd=2.92u as=0.3808p ps=2.92u w=1.12u l=0.13u
X390 VSS.t302 a_2595_1047.t2 a_26471_1008# VSS.t618 sg13_lv_nmos ad=0.2516p pd=2.16u as=0.2516p ps=2.16u w=0.74u l=0.13u
X391 a_2595_311.t0 a_2297_331# VSS.t289 VSS.t288 sg13_lv_nmos ad=0.1406p pd=1.12u as=0.1331p ps=1.12u w=0.74u l=0.13u
X392 VSS.t325 a_14009_5878# a_14111_5878# VSS.t356 sg13_lv_nmos ad=2.39977p pd=15.495u as=0.2516p ps=2.16u w=0.74u l=0.13u
X393 VSS.t108 DELAY_VBIASN a_4111_1842# VSS.t107 sg13_lv_nmos ad=0.2516p pd=2.16u as=0.1406p ps=1.12u w=0.74u l=0.6u
X394 a_2297_1395# MUX_SEL0 VDD.t288 VDD.t4 sg13_lv_pmos ad=0.1596p pd=1.22u as=0.2856p ps=2.36u w=0.84u l=0.13u
X395 VSS.t242 a_16597_1842# a_17065_1044# VSS.t296 sg13_lv_nmos ad=0.1665p pd=1.19u as=0.2516p ps=2.16u w=0.74u l=0.13u
X396 VDD.t268 DELAY_VBIASP a_8671_2470# VDD.t0 sg13_lv_pmos ad=0.3808p pd=2.92u as=0.2128p ps=1.5u w=1.12u l=0.6u
X397 VDD.t161 VSS.t519 VDD.t124 VDD.t4 sg13_lv_pmos ad=0.19p pd=1.38u as=0 ps=0 w=1u l=1u
X398 VDD.t166 a_1544_1044# a_1721_1395# VDD.t4 sg13_lv_pmos ad=0.1918p pd=1.5u as=0.1596p ps=1.22u w=0.84u l=0.13u
X399 a_9444_4590# a_9444_4590# VSS.t452 VSS.t442 sg13_lv_nmos ad=0.38p pd=2.38u as=0.68p ps=4.68u w=2u l=1u
X400 a_4248_1044# a_4157_1313# VDD.t295 VDD.t4 sg13_lv_pmos ad=0.2128p pd=1.5u as=0.3808p ps=2.92u w=1.12u l=0.13u
X401 a_5778_3367# a_6126_3816# a_6326_4590# VSS.t135 sg13_lv_nmos ad=0.68p pd=4.68u as=0.38p ps=2.38u w=2u l=1u
X402 a_12471_2470# a_12233_1842# a_12363_1842# VDD.t0 sg13_lv_pmos ad=0.2128p pd=1.5u as=0.3808p ps=2.92u w=1.12u l=0.2u
X403 a_17031_1842# a_16793_1842# a_16923_1842# VSS.t566 sg13_lv_nmos ad=0.1406p pd=1.12u as=0.2516p ps=2.16u w=0.74u l=0.2u
X404 VSS.t289 a_1721_331# a_2019_311# VSS.t320 sg13_lv_nmos ad=0.2812p pd=2.24u as=0.1406p ps=1.12u w=0.74u l=0.13u
X405 a_19550_1044# a_21911_1008# a_21835_1044# VDD.t4 sg13_lv_pmos ad=0.3808p pd=2.92u as=0.2128p ps=1.5u w=1.12u l=0.13u
X406 a_16108_289# a_26985_519# a_25630_1044# VDD.t4 sg13_lv_pmos ad=0.3808p pd=2.92u as=0.3808p ps=2.92u w=1.12u l=0.13u
X407 VSS.t289 a_2297_331# a_2595_311.t0 VSS.t290 sg13_lv_nmos ad=0.2812p pd=2.24u as=0.1406p ps=1.12u w=0.74u l=0.13u
X408 a_18795_1044# a_18585_1044# VSS.t436 VSS.t584 sg13_lv_nmos ad=0.1406p pd=1.12u as=0.1665p ps=1.19u w=0.74u l=0.13u
X409 a_9444_3912# a_6854_5454# a_9712_3912# VSS.t583 sg13_lv_nmos ad=0.68p pd=4.68u as=0.38p ps=2.38u w=2u l=1u
X410 a_20831_1842# a_20593_1842# a_20723_1842# VSS.t428 sg13_lv_nmos ad=0.1406p pd=1.12u as=0.2516p ps=2.16u w=0.74u l=0.2u
X411 VSS.t507 VDD.t409 VSS.t506 VSS.t505 sg13_lv_nmos ad=0.1428p pd=1.52u as=0 ps=0 w=0.42u l=1u
X412 VDD.t117 a_22677_1842# a_23145_1044# VDD.t4 sg13_lv_pmos ad=0.252p pd=1.57u as=0.3808p ps=2.92u w=1.12u l=0.13u
X413 VSS.t197 a_2595_1047.t5 a_17351_1008# VSS.t196 sg13_lv_nmos ad=0.2516p pd=2.16u as=0.2516p ps=2.16u w=0.74u l=0.13u
X414 a_5393_1842# a_5197_1842# VSS.t47 VSS.t431 sg13_lv_nmos ad=0.2516p pd=2.16u as=0.1406p ps=1.12u w=0.74u l=0.13u
X415 VSS.t45 DELAY_VBIASN a_17031_1842# VSS.t44 sg13_lv_nmos ad=0.2516p pd=2.16u as=0.1406p ps=1.12u w=0.74u l=0.6u
X416 a_25630_1044# a_3171_1047.t2 a_27048_1044# VSS.t365 sg13_lv_nmos ad=0.2516p pd=2.16u as=0.1406p ps=1.12u w=0.74u l=0.13u
X417 VDD.t335 VDD.t333 VDD.t334 VDD.t38 sg13_lv_pmos ad=0.3808p pd=2.92u as=0 ps=0 w=1.12u l=0.13u
X418 a_9953_1842# a_9757_1842# VDD.t360 VDD.t0 sg13_lv_pmos ad=0.3808p pd=2.92u as=0.2128p ps=1.5u w=1.12u l=0.13u
X419 VDD.t14 a_10843_1842# a_11277_1842# VDD.t0 sg13_lv_pmos ad=0.2128p pd=1.5u as=0.3808p ps=2.92u w=1.12u l=0.13u
X420 VSS.t129 a_26803_1842# a_27237_1842# VSS.t482 sg13_lv_nmos ad=0.1406p pd=1.12u as=0.2516p ps=2.16u w=0.74u l=0.13u
X421 a_4350_1044# a_3171_1047.t9 a_5768_1044# VSS.t589 sg13_lv_nmos ad=0.2516p pd=2.16u as=0.1406p ps=1.12u w=0.74u l=0.13u
X422 VDD.t58 a_12849_5867# a_13566_5328# VDD.t6 sg13_lv_pmos ad=0.1563p pd=1.22u as=0.147p ps=1.54u w=0.42u l=0.13u
X423 VDD.t340 VDD.t341 VDD.t342 VDD.t38 sg13_lv_pmos ad=0.2128p pd=1.5u as=0 ps=0 w=1.12u l=0.13u
X424 a_10430_1044# a_12791_1008# a_12715_1044# VDD.t4 sg13_lv_pmos ad=0.3808p pd=2.92u as=0.2128p ps=1.5u w=1.12u l=0.13u
X425 a_19311_1842# a_19073_1842# a_19203_1842# VSS.t236 sg13_lv_nmos ad=0.1406p pd=1.12u as=0.2516p ps=2.16u w=0.74u l=0.2u
X426 a_24875_1044# a_24665_1044# VDD.t43 VDD.t4 sg13_lv_pmos ad=0.2128p pd=1.5u as=0.252p ps=1.57u w=1.12u l=0.13u
X427 VDD.t159 a_2595_1047.t3 a_23431_1008# VDD.t4 sg13_lv_pmos ad=0.3808p pd=2.92u as=0.3808p ps=2.92u w=1.12u l=0.13u
X428 VDD.t7 a_14009_5878# a_14111_5878# VDD.t6 sg13_lv_pmos ad=1.10612p pd=6.66u as=0.3864p ps=2.93u w=1.12u l=0.13u
X429 a_13949_5914# a_13592_5871# VDD.t54 VDD.t6 sg13_lv_pmos ad=63f pd=0.72u as=0.1563p ps=1.22u w=0.42u l=0.13u
X430 VDD.t179 a_13557_1842# a_14025_1044# VDD.t4 sg13_lv_pmos ad=0.252p pd=1.57u as=0.3808p ps=2.92u w=1.12u l=0.13u
X431 a_23111_1842# a_22873_1842# a_23003_1842# VSS.t155 sg13_lv_nmos ad=0.1406p pd=1.12u as=0.2516p ps=2.16u w=0.74u l=0.2u
X432 VSS.t329 a_10649_5878# a_10751_5878# VSS.t597 sg13_lv_nmos ad=2.39977p pd=15.495u as=0.2516p ps=2.16u w=0.74u l=0.13u
X433 a_27671_2470# a_27433_1842# a_27563_1842# VDD.t0 sg13_lv_pmos ad=0.2128p pd=1.5u as=0.3808p ps=2.92u w=1.12u l=0.2u
X434 VSS.t43 a_17683_1842# a_18117_1842# VSS.t499 sg13_lv_nmos ad=0.1406p pd=1.12u as=0.2516p ps=2.16u w=0.74u l=0.13u
X435 VSS.t543 VDD.t398 VSS.t543 VSS.t545 sg13_lv_nmos ad=79.8f pd=0.8u as=0 ps=0 w=0.42u l=1u
X436 a_10713_1842# a_10517_1842# VSS.t50 VSS.t620 sg13_lv_nmos ad=0.2516p pd=2.16u as=0.1406p ps=1.12u w=0.74u l=0.13u
X437 VSS.t489 a_2019_1047.t8 a_7364_1008# VSS.t488 sg13_lv_nmos ad=0.2516p pd=2.16u as=0.2516p ps=2.16u w=0.74u l=0.13u
X438 VSS.t91 DELAY_VBIASN VSS.t80 VSS.t73 sg13_lv_nmos ad=1.33p pd=7.38u as=0 ps=0 w=7u l=7u
X439 VSS.t41 a_7803_1842# a_8237_1842# VSS.t172 sg13_lv_nmos ad=0.1406p pd=1.12u as=0.2516p ps=2.16u w=0.74u l=0.13u
X440 a_13592_5871# a_14111_5878# a_14851_6228# VSS.t187 sg13_lv_nmos ad=0.3473p pd=2.71u as=0.12665p ps=1.145u w=0.74u l=0.13u
X441 a_15304_4605# a_14851_6228# VSS.t409 VSS.t408 sg13_lv_nmos ad=0.2849p pd=2.25u as=0.2516p ps=2.16u w=0.74u l=0.13u
X442 VDD.t254 DELAY_VBIASP a_16271_2470# VDD.t0 sg13_lv_pmos ad=0.3808p pd=2.92u as=0.2128p ps=1.5u w=1.12u l=0.6u
X443 VSS.t543 VDD.t399 VSS.t541 VSS.t542 sg13_lv_nmos ad=79.8f pd=0.8u as=0 ps=0 w=0.42u l=1u
X444 VSS.t523 VDD.t404 VSS.t523 VSS.t524 sg13_lv_nmos ad=0.1428p pd=1.52u as=0 ps=0 w=0.42u l=1u
X445 a_6854_5454# a_6854_5454# a_9444_4590# VSS.t582 sg13_lv_nmos ad=0.38p pd=2.38u as=0.68p ps=4.68u w=2u l=1u
X446 VDD.t108 a_26043_1842# a_26477_1842# VDD.t0 sg13_lv_pmos ad=0.2128p pd=1.5u as=0.3808p ps=2.92u w=1.12u l=0.13u
X447 VDD.t103 DLL_RESETN a_10206_5835# VDD.t6 sg13_lv_pmos ad=0.1563p pd=1.22u as=0.147p ps=1.54u w=0.42u l=0.13u
X448 a_3543_331# MUX_SEL2 a_3449_331# VSS.t211 sg13_lv_nmos ad=0.1216p pd=1.02u as=0.2176p ps=1.96u w=0.64u l=0.13u
X449 a_22488_1044# a_21917_1842# VSS.t170 VSS.t495 sg13_lv_nmos ad=0.1406p pd=1.12u as=0.2516p ps=2.16u w=0.74u l=0.13u
X450 a_14851_5182# a_14009_5084# a_13592_5423# VDD.t6 sg13_lv_pmos ad=0.2048p pd=1.63u as=0.34p ps=2.68u w=1u l=0.13u
X451 VDD.t90 VSS.t513 VDD.t88 VDD.t4 sg13_lv_pmos ad=0.19p pd=1.38u as=0 ps=0 w=1u l=1u
X452 a_22590_1044# a_24084_1008# a_24008_1044# VDD.t4 sg13_lv_pmos ad=0.3808p pd=2.92u as=0.2128p ps=1.5u w=1.12u l=0.13u
X453 VDD.t277 DELAY_VBIASP a_20071_2470# VDD.t0 sg13_lv_pmos ad=0.3808p pd=2.92u as=0.2128p ps=1.5u w=1.12u l=0.6u
X454 a_9444_3912# a_9444_4590# VSS.t443 VSS.t442 sg13_lv_nmos ad=0.38p pd=2.38u as=0.68p ps=4.68u w=2u l=1u
X455 a_14751_1842# a_14513_1842# a_14643_1842# VSS.t220 sg13_lv_nmos ad=0.1406p pd=1.12u as=0.2516p ps=2.16u w=0.74u l=0.2u
X456 VSS.t19 a_2873_1395# a_3171_1047.t0 VSS.t20 sg13_lv_nmos ad=0.2812p pd=2.24u as=0.1406p ps=1.12u w=0.74u l=0.13u
X457 VDD.t23 VSS.t559 VDD.t22 VDD.t4 sg13_lv_pmos ad=0.19p pd=1.38u as=0 ps=0 w=1u l=1u
X458 a_25630_1044# a_27991_1008# a_27915_1044# VDD.t4 sg13_lv_pmos ad=0.3808p pd=2.92u as=0.2128p ps=1.5u w=1.12u l=0.13u
X459 VSS.t277 VSS.t274 VSS.t274 VSS.t275 sg13_lv_nmos ad=0.1406p pd=1.12u as=0 ps=0 w=0.74u l=0.13u
X460 a_4111_1842# REF_CLK a_4003_1842# VSS.t330 sg13_lv_nmos ad=0.1406p pd=1.12u as=0.2516p ps=2.16u w=0.74u l=0.2u
X461 a_8671_2470# a_8433_1842# a_8563_1842# VDD.t0 sg13_lv_pmos ad=0.2128p pd=1.5u as=0.3808p ps=2.92u w=1.12u l=0.2u
X462 a_17553_1842# a_17357_1842# VDD.t150 VDD.t0 sg13_lv_pmos ad=0.3808p pd=2.92u as=0.2128p ps=1.5u w=1.12u l=0.13u
X463 VSS.t148 a_1544_1044# a_2391_1395# VSS.t388 sg13_lv_nmos ad=0.1331p pd=1.12u as=0.1216p ps=1.02u w=0.64u l=0.13u
X464 VSS.t316 a_3747_311.t3 a_14825_519# VSS.t315 sg13_lv_nmos ad=0.2516p pd=2.16u as=0.2516p ps=2.16u w=0.74u l=0.13u
X465 VSS.t289 a_1256_289# a_2967_331# VSS.t498 sg13_lv_nmos ad=0.1331p pd=1.12u as=0.1216p ps=1.02u w=0.64u l=0.13u
X466 a_2019_1047.t0 a_1721_1395# VSS.t148 VSS.t357 sg13_lv_nmos ad=0.1406p pd=1.12u as=0.1331p ps=1.12u w=0.74u l=0.13u
X467 a_15964_289# a_15765_463# a_5731_289# VSS.t216 sg13_lv_nmos ad=0.2183p pd=1.33u as=0.2516p ps=2.16u w=0.74u l=0.13u
X468 a_13470_1044# a_2019_1047.t6 a_13368_1044# VSS.t604 sg13_lv_nmos ad=0.2516p pd=2.16u as=0.1406p ps=1.12u w=0.74u l=0.13u
X469 VDD.t324 VDD.t322 VDD.t195 VDD.t6 sg13_lv_pmos ad=0.68p pd=4.68u as=0 ps=0 w=2u l=1u
X470 VSS.t113 a_13123_1842# a_13557_1842# VSS.t484 sg13_lv_nmos ad=0.1406p pd=1.12u as=0.2516p ps=2.16u w=0.74u l=0.13u
X471 VDD.t30 VSS.t561 VDD.t175 VDD.t4 sg13_lv_pmos ad=0.34p pd=2.68u as=0 ps=0 w=1u l=1u
X472 VSS.t457 a_3171_1047.t3 a_24084_1008# VSS.t456 sg13_lv_nmos ad=0.2516p pd=2.16u as=0.2516p ps=2.16u w=0.74u l=0.13u
X473 a_25913_1842# a_25717_1842# VSS.t127 VSS.t385 sg13_lv_nmos ad=0.2516p pd=2.16u as=0.1406p ps=1.12u w=0.74u l=0.13u
X474 VDD.t7 a_10649_5878# a_10751_5878# VDD.t6 sg13_lv_pmos ad=1.10612p pd=6.66u as=0.3864p ps=2.93u w=1.12u l=0.13u
X475 a_21353_1842# a_21157_1842# VDD.t36 VDD.t0 sg13_lv_pmos ad=0.3808p pd=2.92u as=0.2128p ps=1.5u w=1.12u l=0.13u
X476 VSS.t547 VDD.t397 VSS.t178 VSS.t546 sg13_lv_nmos ad=0.1428p pd=1.52u as=0 ps=0 w=0.42u l=1u
X477 a_2297_331# MUX_SEL2 VDD.t68 VDD.t4 sg13_lv_pmos ad=0.1596p pd=1.22u as=0.2856p ps=2.36u w=0.84u l=0.13u
X478 VDD.t110 a_7043_1842# a_7477_1842# VDD.t0 sg13_lv_pmos ad=0.2128p pd=1.5u as=0.3808p ps=2.92u w=1.12u l=0.13u
X479 a_2873_331# MUX_SEL3 VDD.t21 VDD.t4 sg13_lv_pmos ad=0.1596p pd=1.22u as=0.2856p ps=2.36u w=0.84u l=0.13u
X480 a_10589_5914# a_10232_5871# VDD.t103 VDD.t6 sg13_lv_pmos ad=63f pd=0.72u as=0.1563p ps=1.22u w=0.42u l=0.13u
X481 a_8155_1044# a_7945_1044# VDD.t109 VDD.t4 sg13_lv_pmos ad=0.2128p pd=1.5u as=0.252p ps=1.57u w=1.12u l=0.13u
X482 a_13880_6292# a_13592_5871# a_13818_6292# VSS.t231 sg13_lv_nmos ad=0.1428p pd=1.52u as=37.8f ps=0.6u w=0.42u l=0.13u
X483 VSS.t436 a_18117_1842# a_18585_1044# VSS.t435 sg13_lv_nmos ad=0.1665p pd=1.19u as=0.2516p ps=2.16u w=0.74u l=0.13u
X484 a_27048_1044# a_26477_1842# VDD.t119 VDD.t4 sg13_lv_pmos ad=0.2128p pd=1.5u as=0.3808p ps=2.92u w=1.12u l=0.13u
X485 a_5768_1044# a_5197_1842# VDD.t235 VDD.t4 sg13_lv_pmos ad=0.2128p pd=1.5u as=0.3808p ps=2.92u w=1.12u l=0.13u
X486 a_10232_5871# a_10751_5878# a_11491_6228# VSS.t246 sg13_lv_nmos ad=0.3473p pd=2.71u as=0.12665p ps=1.145u w=0.74u l=0.13u
X487 a_12656_5864# DLL_RESETN VDD.t385 VDD.t6 sg13_lv_pmos ad=0.3808p pd=2.92u as=0.3808p ps=2.92u w=1.12u l=0.13u
X488 a_13991_2470# a_13753_1842# a_13883_1842# VDD.t0 sg13_lv_pmos ad=0.2128p pd=1.5u as=0.3808p ps=2.92u w=1.12u l=0.2u
X489 VSS.t466 a_3171_1047.t6 a_14964_1008# VSS.t465 sg13_lv_nmos ad=0.2516p pd=2.16u as=0.2516p ps=2.16u w=0.74u l=0.13u
X490 VDD.t358 a_2019_311# a_17865_519# VDD.t4 sg13_lv_pmos ad=0.3808p pd=2.92u as=0.3808p ps=2.92u w=1.12u l=0.13u
X491 DELAY_OUT_LAST a_27997_1842# VSS.t412 VSS.t411 sg13_lv_nmos ad=0.2516p pd=2.16u as=0.1406p ps=1.12u w=0.74u l=0.13u
X492 a_11195_1044# a_10985_1044# VSS.t199 VSS.t198 sg13_lv_nmos ad=0.1406p pd=1.12u as=0.1665p ps=1.19u w=0.74u l=0.13u
X493 VDD.t43 a_24197_1842# a_24665_1044# VDD.t4 sg13_lv_pmos ad=0.252p pd=1.57u as=0.3808p ps=2.92u w=1.12u l=0.13u
X494 a_6913_1842# a_6717_1842# VSS.t3 VSS.t602 sg13_lv_nmos ad=0.2516p pd=2.16u as=0.1406p ps=1.12u w=0.74u l=0.13u
X495 VSS.t9 DELAY_VBIASN a_18551_1842# VSS.t39 sg13_lv_nmos ad=0.2516p pd=2.16u as=0.1406p ps=1.12u w=0.74u l=0.6u
X496 a_16510_1044# a_18004_1008# a_17928_1044# VDD.t4 sg13_lv_pmos ad=0.3808p pd=2.92u as=0.2128p ps=1.5u w=1.12u l=0.13u
X497 a_13592_5423# a_13566_5328# VSS.t184 VSS.t598 sg13_lv_nmos ad=0.2516p pd=2.16u as=0.1626p ps=1.415u w=0.74u l=0.13u
X498 VDD.t1 a_12363_1842# a_12797_1842# VDD.t0 sg13_lv_pmos ad=0.2128p pd=1.5u as=0.3808p ps=2.92u w=1.12u l=0.13u
X499 VSS.t38 MUX_SEL3 a_3543_331# VSS.t37 sg13_lv_nmos ad=0.1331p pd=1.12u as=0.1216p ps=1.02u w=0.64u l=0.13u
X500 a_22590_1044# a_2595_1047.t3 a_23355_1044# VSS.t350 sg13_lv_nmos ad=0.2516p pd=2.16u as=0.1406p ps=1.12u w=0.74u l=0.13u
X501 a_9712_3912# a_6854_5454# a_9444_3912# VSS.t582 sg13_lv_nmos ad=0.38p pd=2.38u as=0.68p ps=4.68u w=2u l=1u
X502 VSS.t98 DELAY_VBIASN a_22351_1842# VSS.t97 sg13_lv_nmos ad=0.2516p pd=2.16u as=0.1406p ps=1.12u w=0.74u l=0.6u
X503 VDD.t220 a_3171_1047.t4 a_21044_1008# VDD.t4 sg13_lv_pmos ad=0.3808p pd=2.92u as=0.3808p ps=2.92u w=1.12u l=0.13u
X504 VDD.t227 VSS.t553 VDD.t225 VDD.t4 sg13_lv_pmos ad=0.19p pd=1.38u as=0 ps=0 w=1u l=1u
X505 a_16271_2470# a_16033_1842# a_16163_1842# VDD.t0 sg13_lv_pmos ad=0.2128p pd=1.5u as=0.3808p ps=2.92u w=1.12u l=0.2u
X506 VDD.t76 VSS.t316 VDD.t75 VDD.t4 sg13_lv_pmos ad=0.19p pd=1.38u as=0 ps=0 w=1u l=1u
X507 a_19833_1842# a_19637_1842# VSS.t121 VSS.t399 sg13_lv_nmos ad=0.2516p pd=2.16u as=0.1406p ps=1.12u w=0.74u l=0.13u
X508 VDD.t359 a_2019_311# a_5705_519# VDD.t4 sg13_lv_pmos ad=0.3808p pd=2.92u as=0.3808p ps=2.92u w=1.12u l=0.13u
X509 VDD.t216 a_14851_6228# a_15108_6109# VDD.t6 sg13_lv_pmos ad=0.2639p pd=1.81u as=79.8f ps=0.8u w=0.42u l=0.13u
X510 a_10520_6292# a_10232_5871# a_10458_6292# VSS.t240 sg13_lv_nmos ad=0.1428p pd=1.52u as=37.8f ps=0.6u w=0.42u l=0.13u
X511 a_15270_6305# a_12849_5867# VSS.t188 VSS.t187 sg13_lv_nmos ad=37.8f pd=0.6u as=79.8f ps=0.8u w=0.42u l=0.13u
X512 a_20071_2470# a_19833_1842# a_19963_1842# VDD.t0 sg13_lv_pmos ad=0.2128p pd=1.5u as=0.3808p ps=2.92u w=1.12u l=0.2u
X513 a_9193_1842# a_8997_1842# VSS.t102 VSS.t426 sg13_lv_nmos ad=0.2516p pd=2.16u as=0.1406p ps=1.12u w=0.74u l=0.13u
X514 a_24631_1842# a_24393_1842# a_24523_1842# VSS.t363 sg13_lv_nmos ad=0.1406p pd=1.12u as=0.2516p ps=2.16u w=0.74u l=0.2u
X515 VDD.t78 VSS.t316 VDD.t77 VDD.t4 sg13_lv_pmos ad=0.34p pd=2.68u as=0 ps=0 w=1u l=1u
X516 VSS.t405 a_2019_1047.t7 a_10404_1008# VSS.t404 sg13_lv_nmos ad=0.2516p pd=2.16u as=0.2516p ps=2.16u w=0.74u l=0.13u
X517 VSS.t70 DELAY_VBIASN VSS.t72 VSS.t71 sg13_lv_nmos ad=1.33p pd=7.38u as=0 ps=0 w=7u l=7u
X518 VDD.t26 a_14643_1842# a_15077_1842# VDD.t0 sg13_lv_pmos ad=0.2128p pd=1.5u as=0.3808p ps=2.92u w=1.12u l=0.13u
X519 VDD.t111 a_1544_289# a_2297_331# VDD.t4 sg13_lv_pmos ad=0.1918p pd=1.5u as=0.1596p ps=1.22u w=0.84u l=0.13u
X520 a_23633_1842# a_23437_1842# VSS.t52 VSS.t420 sg13_lv_nmos ad=0.2516p pd=2.16u as=0.1406p ps=1.12u w=0.74u l=0.13u
X521 VSS.t543 VDD.t398 VSS.t543 VSS.t544 sg13_lv_nmos ad=0.1428p pd=1.52u as=0 ps=0 w=0.42u l=1u
X522 a_2019_311# a_1721_331# VDD.t134 VDD.t4 sg13_lv_pmos ad=0.2128p pd=1.5u as=0.1918p ps=1.5u w=1.12u l=0.13u
X523 VSS.t100 a_9323_1842# a_9757_1842# VSS.t595 sg13_lv_nmos ad=0.1406p pd=1.12u as=0.2516p ps=2.16u w=0.74u l=0.13u
X524 a_26395_1044# a_26185_1044# VSS.t387 VSS.t601 sg13_lv_nmos ad=0.1406p pd=1.12u as=0.1665p ps=1.19u w=0.74u l=0.13u
X525 VDD.t273 DELAY_VBIASP a_17791_2470# VDD.t0 sg13_lv_pmos ad=0.3808p pd=2.92u as=0.2128p ps=1.5u w=1.12u l=0.6u
X526 VSS.t16 a_3747_1047.t3 a_24951_1008# VSS.t15 sg13_lv_nmos ad=0.2516p pd=2.16u as=0.2516p ps=2.16u w=0.74u l=0.13u
X527 VSS.t521 VDD.t405 VSS.t521 VSS.t520 sg13_lv_nmos ad=0.1428p pd=1.52u as=0 ps=0 w=0.42u l=1u
X528 VSS.t541 VDD.t399 VSS.t541 VSS.t540 sg13_lv_nmos ad=0.1428p pd=1.52u as=0 ps=0 w=0.42u l=1u
X529 a_3747_1047.t1 a_3449_1395# VDD.t73 VDD.t4 sg13_lv_pmos ad=0.2128p pd=1.5u as=0.1918p ps=1.5u w=1.12u l=0.13u
X530 a_13368_1044# a_12797_1842# VDD.t183 VDD.t4 sg13_lv_pmos ad=0.2128p pd=1.5u as=0.3808p ps=2.92u w=1.12u l=0.13u
X531 a_24008_1044# a_23437_1842# VSS.t352 VSS.t421 sg13_lv_nmos ad=0.1406p pd=1.12u as=0.2516p ps=2.16u w=0.74u l=0.13u
X532 VDD.t278 DELAY_VBIASP a_21591_2470# VDD.t0 sg13_lv_pmos ad=0.3808p pd=2.92u as=0.2128p ps=1.5u w=1.12u l=0.6u
X533 a_15964_289# MUX_SEL4 a_5731_289# VDD.t4 sg13_lv_pmos ad=0.3304p pd=1.71u as=0.3808p ps=2.92u w=1.12u l=0.13u
X534 a_4350_1044# a_6711_1008# a_6635_1044# VDD.t4 sg13_lv_pmos ad=0.3808p pd=2.92u as=0.2128p ps=1.5u w=1.12u l=0.13u
X535 a_2873_1395# MUX_SEL1 VDD.t292 VDD.t4 sg13_lv_pmos ad=0.1596p pd=1.22u as=0.2856p ps=2.36u w=0.84u l=0.13u
X536 VSS.t184 a_12849_5867# a_13400_5105# VSS.t186 sg13_lv_nmos ad=0.1626p pd=1.415u as=60.89999f ps=0.71u w=0.42u l=0.13u
X537 a_1256_1044# MUX_SEL0 VSS.t148 VSS.t470 sg13_lv_nmos ad=0.2516p pd=2.16u as=0.2516p ps=2.16u w=0.74u l=0.13u
X538 VSS.t519 VDD.t406 VSS.t517 VSS.t518 sg13_lv_nmos ad=79.8f pd=0.8u as=0 ps=0 w=0.42u l=1u
X539 a_19550_1044# a_20391_1008# a_20315_1044# VDD.t4 sg13_lv_pmos ad=0.3808p pd=2.92u as=0.2128p ps=1.5u w=1.12u l=0.13u
X540 VDD.t353 VDD.t351 VDD.t350 VDD.t0 sg13_lv_pmos ad=0.2128p pd=1.5u as=0 ps=0 w=1.12u l=0.2u
X541 a_5631_1842# a_5393_1842# a_5523_1842# VSS.t491 sg13_lv_nmos ad=0.1406p pd=1.12u as=0.2516p ps=2.16u w=0.74u l=0.2u
X542 a_14513_1842# a_14317_1842# VSS.t111 VSS.t588 sg13_lv_nmos ad=0.2516p pd=2.16u as=0.1406p ps=1.12u w=0.74u l=0.13u
X543 VSS.t178 a_2595_311.t2 a_20905_519# VSS.t177 sg13_lv_nmos ad=0.2516p pd=2.16u as=0.2516p ps=2.16u w=0.74u l=0.13u
X544 VDD.t109 a_7477_1842# a_7945_1044# VDD.t4 sg13_lv_pmos ad=0.252p pd=1.57u as=0.3808p ps=2.92u w=1.12u l=0.13u
X545 a_13470_1044# a_3171_1047.t6 a_14888_1044# VSS.t464 sg13_lv_nmos ad=0.2516p pd=2.16u as=0.1406p ps=1.12u w=0.74u l=0.13u
X546 a_4633_1842# a_4437_1842# VSS.t108 VSS.t611 sg13_lv_nmos ad=0.2516p pd=2.16u as=0.1406p ps=1.12u w=0.74u l=0.13u
X547 a_1256_289# MUX_SEL2 VSS.t35 VSS.t209 sg13_lv_nmos ad=0.2516p pd=2.16u as=0.2516p ps=2.16u w=0.74u l=0.13u
X548 VSS.t208 a_2019_1047.t2 a_25604_1008# VSS.t207 sg13_lv_nmos ad=0.2516p pd=2.16u as=0.2516p ps=2.16u w=0.74u l=0.13u
X549 a_13019_5831# a_15688_5403# VDD.t121 VDD.t6 sg13_lv_pmos ad=0.3808p pd=2.92u as=0.2128p ps=1.5u w=1.12u l=0.13u
X550 VSS.t66 DELAY_VBIASN VSS.t68 VSS.t67 sg13_lv_nmos ad=1.33p pd=7.38u as=0 ps=0 w=7u l=7u
X551 a_16108_289# MUX_SEL4 a_15964_289# VSS.t213 sg13_lv_nmos ad=0.2516p pd=2.16u as=0.2183p ps=1.33u w=0.74u l=0.13u
X552 a_13400_6305# a_12355_5867# a_13306_6305# VSS.t212 sg13_lv_nmos ad=60.89999f pd=0.71u as=0.1428p ps=1.52u w=0.42u l=0.13u
X553 a_22873_1842# a_22677_1842# VDD.t193 VDD.t0 sg13_lv_pmos ad=0.3808p pd=2.92u as=0.2128p ps=1.5u w=1.12u l=0.13u
X554 a_21835_1044# a_21625_1044# VSS.t322 VSS.t321 sg13_lv_nmos ad=0.1406p pd=1.12u as=0.1665p ps=1.19u w=0.74u l=0.13u
X555 VSS.t192 a_2595_1047.t4 a_20391_1008# VSS.t292 sg13_lv_nmos ad=0.2516p pd=2.16u as=0.2516p ps=2.16u w=0.74u l=0.13u
X556 a_9675_1044# a_9465_1044# VDD.t180 VDD.t4 sg13_lv_pmos ad=0.2128p pd=1.5u as=0.252p ps=1.57u w=1.12u l=0.13u
X557 VSS.t199 a_10517_1842# a_10985_1044# VSS.t619 sg13_lv_nmos ad=0.1665p pd=1.19u as=0.2516p ps=2.16u w=0.74u l=0.13u
X558 VDD.t173 a_2595_1047.t8 a_8231_1008# VDD.t4 sg13_lv_pmos ad=0.3808p pd=2.92u as=0.3808p ps=2.92u w=1.12u l=0.13u
X559 a_18551_1842# a_18313_1842# a_18443_1842# VSS.t407 sg13_lv_nmos ad=0.1406p pd=1.12u as=0.2516p ps=2.16u w=0.74u l=0.2u
X560 a_12943_5867# a_12656_5864# a_12849_5867# VDD.t6 sg13_lv_pmos ad=0.2128p pd=1.5u as=0.3808p ps=2.92u w=1.12u l=0.13u
X561 a_13566_5835# a_14009_5878# a_13949_5914# VDD.t6 sg13_lv_pmos ad=79.8f pd=0.8u as=63f ps=0.72u w=0.42u l=0.13u
X562 a_22351_1842# a_22113_1842# a_22243_1842# VSS.t225 sg13_lv_nmos ad=0.1406p pd=1.12u as=0.2516p ps=2.16u w=0.74u l=0.2u
X563 VSS.t11 a_3747_1047.t5 a_18871_1008# VSS.t474 sg13_lv_nmos ad=0.2516p pd=2.16u as=0.2516p ps=2.16u w=0.74u l=0.13u
X564 VSS.t45 a_16923_1842# a_17357_1842# VSS.t467 sg13_lv_nmos ad=0.1406p pd=1.12u as=0.2516p ps=2.16u w=0.74u l=0.13u
X565 VDD.t168 a_3171_311.t2 a_23945_519# VDD.t4 sg13_lv_pmos ad=0.3808p pd=2.92u as=0.3808p ps=2.92u w=1.12u l=0.13u
X566 a_2019_311# a_1721_331# VSS.t289 VSS.t319 sg13_lv_nmos ad=0.1406p pd=1.12u as=0.1331p ps=1.12u w=0.74u l=0.13u
X567 a_25153_1842# a_24957_1842# VDD.t83 VDD.t0 sg13_lv_pmos ad=0.3808p pd=2.92u as=0.2128p ps=1.5u w=1.12u l=0.13u
X568 a_17928_1044# a_17357_1842# VSS.t197 VSS.t335 sg13_lv_nmos ad=0.1406p pd=1.12u as=0.2516p ps=2.16u w=0.74u l=0.13u
X569 a_12715_1044# a_12505_1044# VSS.t157 VSS.t156 sg13_lv_nmos ad=0.1406p pd=1.12u as=0.1665p ps=1.19u w=0.74u l=0.13u
X570 a_13880_6292# a_14111_5878# a_13566_5835# VSS.t406 sg13_lv_nmos ad=0.2373p pd=1.97u as=79.8f ps=0.8u w=0.42u l=0.13u
X571 a_15053_5990# a_14111_5878# a_14851_6228# VDD.t6 sg13_lv_pmos ad=93.45f pd=0.865u as=0.2048p ps=1.63u w=0.42u l=0.13u
X572 VDD.t71 MUX_SEL4 a_15765_463# VDD.t4 sg13_lv_pmos ad=0.3808p pd=2.92u as=0.3808p ps=2.92u w=1.12u l=0.13u
X573 a_19550_1044# a_3171_1047.t4 a_20968_1044# VSS.t413 sg13_lv_nmos ad=0.2516p pd=2.16u as=0.1406p ps=1.12u w=0.74u l=0.13u
X574 VSS.t22 DELAY_VBIASN a_10951_1842# VSS.t109 sg13_lv_nmos ad=0.2516p pd=2.16u as=0.1406p ps=1.12u w=0.74u l=0.6u
X575 a_19550_1044# a_19524_1008# a_19448_1044# VDD.t4 sg13_lv_pmos ad=0.3808p pd=2.92u as=0.2128p ps=1.5u w=1.12u l=0.13u
X576 a_7288_1044# a_6717_1842# VSS.t502 VSS.t603 sg13_lv_nmos ad=0.1406p pd=1.12u as=0.2516p ps=2.16u w=0.74u l=0.13u
X577 a_12355_5867# a_12158_5867# VSS.t153 VSS.t158 sg13_lv_nmos ad=0.2516p pd=2.16u as=0.1406p ps=1.12u w=0.74u l=0.13u
X578 VSS.t117 a_20723_1842# a_21157_1842# VSS.t151 sg13_lv_nmos ad=0.1406p pd=1.12u as=0.2516p ps=2.16u w=0.74u l=0.13u
X579 VDD.t153 a_14851_6228# a_15688_5867# VDD.t6 sg13_lv_pmos ad=0.2128p pd=1.5u as=0.3864p ps=2.93u w=1.12u l=0.13u
X580 a_1544_289# MUX_SEL3 VSS.t35 VSS.t34 sg13_lv_nmos ad=0.2516p pd=2.16u as=0.2516p ps=2.16u w=0.74u l=0.13u
X581 a_13470_1044# a_14311_1008# a_14235_1044# VDD.t4 sg13_lv_pmos ad=0.3808p pd=2.92u as=0.2128p ps=1.5u w=1.12u l=0.13u
X582 a_22590_1044# a_3747_1047.t3 a_24875_1044# VSS.t14 sg13_lv_nmos ad=0.2516p pd=2.16u as=0.1406p ps=1.12u w=0.74u l=0.13u
X583 VSS.t59 DELAY_VBIASN a_23871_1842# VSS.t58 sg13_lv_nmos ad=0.2516p pd=2.16u as=0.1406p ps=1.12u w=0.74u l=0.6u
X584 VDD.t378 a_2019_1047.t3 a_22564_1008# VDD.t4 sg13_lv_pmos ad=0.3808p pd=2.92u as=0.3808p ps=2.92u w=1.12u l=0.13u
X585 VSS.t387 a_25717_1842# a_26185_1044# VSS.t386 sg13_lv_nmos ad=0.1665p pd=1.19u as=0.2516p ps=2.16u w=0.74u l=0.13u
X586 a_13231_1842# a_12993_1842# a_13123_1842# VSS.t458 sg13_lv_nmos ad=0.1406p pd=1.12u as=0.2516p ps=2.16u w=0.74u l=0.2u
X587 VSS.t513 VDD.t407 VSS.t513 VSS.t515 sg13_lv_nmos ad=79.8f pd=0.8u as=0 ps=0 w=0.42u l=1u
X588 a_17791_2470# a_17553_1842# a_17683_1842# VDD.t0 sg13_lv_pmos ad=0.2128p pd=1.5u as=0.3808p ps=2.92u w=1.12u l=0.2u
X589 VSS.t433 a_4437_1842# a_4905_1044# VSS.t612 sg13_lv_nmos ad=0.1665p pd=1.19u as=0.2516p ps=2.16u w=0.74u l=0.13u
X590 VDD.t225 VSS.t553 VDD.t224 VDD.t4 sg13_lv_pmos ad=0.34p pd=2.68u as=0 ps=0 w=1u l=1u
X591 a_12233_1842# a_12037_1842# VSS.t57 VSS.t622 sg13_lv_nmos ad=0.2516p pd=2.16u as=0.1406p ps=1.12u w=0.74u l=0.13u
X592 VDD.t7 a_9547_6172# a_9547_5942# VDD.t6 sg13_lv_pmos ad=1.10612p pd=6.66u as=0.2442p ps=2.06u w=0.66u l=0.13u
X593 a_15108_5325# a_14851_5182# a_15270_5105# VSS.t567 sg13_lv_nmos ad=0.1428p pd=1.52u as=37.8f ps=0.6u w=0.42u l=0.13u
X594 VSS.t224 a_3449_1395# a_3747_1047.t0 VSS.t223 sg13_lv_nmos ad=0.2812p pd=2.24u as=0.1406p ps=1.12u w=0.74u l=0.13u
X595 VDD.t75 VSS.t531 VDD.t245 VDD.t4 sg13_lv_pmos ad=0.34p pd=2.68u as=0 ps=0 w=1u l=1u
X596 VDD.t142 VSS.t539 VDD.t132 VDD.t4 sg13_lv_pmos ad=0.19p pd=1.38u as=0 ps=0 w=1u l=1u
X597 VSS.t559 VDD.t394 VSS.t557 VSS.t558 sg13_lv_nmos ad=79.8f pd=0.8u as=0 ps=0 w=0.42u l=1u
X598 VSS.t202 a_3171_1047.t8 a_8884_1008# VSS.t201 sg13_lv_nmos ad=0.2516p pd=2.16u as=0.2516p ps=2.16u w=0.74u l=0.13u
X599 a_21591_2470# a_21353_1842# a_21483_1842# VDD.t0 sg13_lv_pmos ad=0.2128p pd=1.5u as=0.3808p ps=2.92u w=1.12u l=0.2u
X600 VDD.t13 a_2873_1395# a_3171_1047.t1 VDD.t4 sg13_lv_pmos ad=0.4256p pd=3u as=0.2128p ps=1.5u w=1.12u l=0.13u
X601 a_6153_1842# a_5957_1842# VDD.t44 VDD.t0 sg13_lv_pmos ad=0.3808p pd=2.92u as=0.2128p ps=1.5u w=1.12u l=0.13u
X602 VDD.t116 a_16163_1842# a_16597_1842# VDD.t0 sg13_lv_pmos ad=0.2128p pd=1.5u as=0.3808p ps=2.92u w=1.12u l=0.13u
X603 a_3543_1395# MUX_SEL0 a_3449_1395# VSS.t472 sg13_lv_nmos ad=0.1216p pd=1.02u as=0.2176p ps=1.96u w=0.64u l=0.13u
X604 VDD.t28 a_1544_1044# a_2297_1395# VDD.t4 sg13_lv_pmos ad=0.1918p pd=1.5u as=0.1596p ps=1.22u w=0.84u l=0.13u
X605 VDD.t266 DELAY_VBIASP a_10191_2470# VDD.t0 sg13_lv_pmos ad=0.3808p pd=2.92u as=0.2128p ps=1.5u w=1.12u l=0.6u
X606 a_17275_1044# a_17065_1044# VDD.t104 VDD.t4 sg13_lv_pmos ad=0.2128p pd=1.5u as=0.252p ps=1.57u w=1.12u l=0.13u
X607 a_2019_1047.t1 a_1721_1395# VDD.t166 VDD.t4 sg13_lv_pmos ad=0.2128p pd=1.5u as=0.1918p ps=1.5u w=1.12u l=0.13u
X608 a_27915_1044# a_27705_1044# VSS.t238 VSS.t416 sg13_lv_nmos ad=0.1406p pd=1.12u as=0.1665p ps=1.19u w=0.74u l=0.13u
X609 VSS.t54 DELAY_VBIASN a_26151_1842# VSS.t53 sg13_lv_nmos ad=0.2516p pd=2.16u as=0.1406p ps=1.12u w=0.74u l=0.6u
X610 VDD.t10 a_3747_1047.t6 a_15831_1008# VDD.t4 sg13_lv_pmos ad=0.3808p pd=2.92u as=0.3808p ps=2.92u w=1.12u l=0.13u
X611 VDD.t60 a_19963_1842# a_20397_1842# VDD.t0 sg13_lv_pmos ad=0.2128p pd=1.5u as=0.3808p ps=2.92u w=1.12u l=0.13u
X612 VSS.t561 VDD.t393 VSS.t561 VSS.t560 sg13_lv_nmos ad=0.1428p pd=1.52u as=0 ps=0 w=0.42u l=1u
X613 VSS.t47 DELAY_VBIASN a_4871_1842# VSS.t46 sg13_lv_nmos ad=0.2516p pd=2.16u as=0.1406p ps=1.12u w=0.74u l=0.6u
X614 a_14888_1044# a_14317_1842# VDD.t366 VDD.t4 sg13_lv_pmos ad=0.2128p pd=1.5u as=0.3808p ps=2.92u w=1.12u l=0.13u
X615 a_4350_1044# a_4324_1008# a_4248_1044# VDD.t4 sg13_lv_pmos ad=0.3808p pd=2.92u as=0.2128p ps=1.5u w=1.12u l=0.13u
X616 a_1256_289# MUX_SEL2 VDD.t67 VDD.t4 sg13_lv_pmos ad=0.3808p pd=2.92u as=0.3808p ps=2.92u w=1.12u l=0.13u
X617 VSS.t281 VSS.t278 VSS.t280 VSS.t279 sg13_lv_nmos ad=0.2516p pd=2.16u as=0 ps=0 w=0.74u l=0.6u
X618 a_16108_289# a_15765_463# a_15964_289# VDD.t4 sg13_lv_pmos ad=0.3808p pd=2.92u as=0.3304p ps=1.71u w=1.12u l=0.13u
X619 VDD.t54 a_12849_5867# a_13566_5835# VDD.t6 sg13_lv_pmos ad=0.1563p pd=1.22u as=0.147p ps=1.54u w=0.42u l=0.13u
X620 VSS.t62 DELAY_VBIASN VSS.t61 VSS.t60 sg13_lv_nmos ad=2.38p pd=14.68u as=0 ps=0 w=7u l=7u
X621 a_11473_1842# a_11277_1842# VDD.t14 VDD.t0 sg13_lv_pmos ad=0.3808p pd=2.92u as=0.2128p ps=1.5u w=1.12u l=0.13u
X622 VDD.t180 a_8997_1842# a_9465_1044# VDD.t4 sg13_lv_pmos ad=0.252p pd=1.57u as=0.3808p ps=2.92u w=1.12u l=0.13u
X623 a_27433_1842# a_27237_1842# VSS.t129 VSS.t239 sg13_lv_nmos ad=0.2516p pd=2.16u as=0.1406p ps=1.12u w=0.74u l=0.13u
X624 a_2391_331# MUX_SEL2 a_2297_331# VSS.t210 sg13_lv_nmos ad=0.1216p pd=1.02u as=0.2176p ps=1.96u w=0.64u l=0.13u
X625 a_2967_331# MUX_SEL3 a_2873_331# VSS.t36 sg13_lv_nmos ad=0.1216p pd=1.02u as=0.2176p ps=1.96u w=0.64u l=0.13u
X626 VDD.t232 a_2019_1047.t5 a_16484_1008# VDD.t4 sg13_lv_pmos ad=0.3808p pd=2.92u as=0.3808p ps=2.92u w=1.12u l=0.13u
X627 a_7390_1044# a_2595_1047.t8 a_8155_1044# VSS.t368 sg13_lv_nmos ad=0.2516p pd=2.16u as=0.1406p ps=1.12u w=0.74u l=0.13u
X628 VSS.t142 a_6126_3816# a_5974_5723# VSS.t138 sg13_lv_nmos ad=0.68p pd=4.68u as=0.38p ps=2.38u w=2u l=1u
X629 VSS.t95 DELAY_VBIASN a_7151_1842# VSS.t94 sg13_lv_nmos ad=0.2516p pd=2.16u as=0.1406p ps=1.12u w=0.74u l=0.6u
X630 VDD.t368 a_3171_1047.t9 a_5844_1008# VDD.t4 sg13_lv_pmos ad=0.3808p pd=2.92u as=0.3808p ps=2.92u w=1.12u l=0.13u
X631 VDD.t255 DELAY_VBIASP a_25391_2470# VDD.t0 sg13_lv_pmos ad=0.3808p pd=2.92u as=0.2128p ps=1.5u w=1.12u l=0.6u
X632 VDD.t174 a_2595_1047.t7 a_11271_1008# VDD.t4 sg13_lv_pmos ad=0.3808p pd=2.92u as=0.3808p ps=2.92u w=1.12u l=0.13u
X633 VDD.t98 VSS.t523 VDD.t96 VDD.t4 sg13_lv_pmos ad=0.19p pd=1.38u as=0 ps=0 w=1u l=1u
X634 VSS.t157 a_12037_1842# a_12505_1044# VSS.t621 sg13_lv_nmos ad=0.1665p pd=1.19u as=0.2516p ps=2.16u w=0.74u l=0.13u
X635 VDD.t100 a_3747_1047.t8 a_9751_1008# VDD.t4 sg13_lv_pmos ad=0.3808p pd=2.92u as=0.3808p ps=2.92u w=1.12u l=0.13u
X636 a_12943_5867# a_13121_5831# VDD.t37 VDD.t6 sg13_lv_pmos ad=0.3808p pd=2.92u as=0.2128p ps=1.5u w=1.12u l=0.13u
X637 a_11748_6109# a_11491_6228# a_11910_6305# VSS.t246 sg13_lv_nmos ad=0.1428p pd=1.52u as=37.8f ps=0.6u w=0.42u l=0.13u
X638 a_9431_1842# a_9193_1842# a_9323_1842# VSS.t578 sg13_lv_nmos ad=0.1406p pd=1.12u as=0.2516p ps=2.16u w=0.74u l=0.2u
X639 a_18313_1842# a_18117_1842# VSS.t43 VSS.t434 sg13_lv_nmos ad=0.2516p pd=2.16u as=0.1406p ps=1.12u w=0.74u l=0.13u
X640 MUX_OUT a_16851_309# VSS.t215 VSS.t503 sg13_lv_nmos ad=0.1406p pd=1.12u as=0.1371p ps=1.12u w=0.74u l=0.13u
X641 a_10232_5871# a_10206_5835# VDD.t128 VDD.t6 sg13_lv_pmos ad=0.34p pd=2.68u as=0.36237p ps=2.605u w=1u l=0.13u
X642 a_14851_5182# a_14009_5084# a_14757_5182# VSS.t392 sg13_lv_nmos ad=0.12665p pd=1.145u as=0.1428p ps=1.52u w=0.42u l=0.13u
X643 VSS.t553 VDD.t395 VSS.t553 VSS.t555 sg13_lv_nmos ad=79.8f pd=0.8u as=0 ps=0 w=0.42u l=1u
X644 a_23871_1842# a_23633_1842# a_23763_1842# VSS.t150 sg13_lv_nmos ad=0.1406p pd=1.12u as=0.2516p ps=2.16u w=0.74u l=0.2u
X645 a_8433_1842# a_8237_1842# VSS.t41 VSS.t310 sg13_lv_nmos ad=0.2516p pd=2.16u as=0.1406p ps=1.12u w=0.74u l=0.13u
X646 VSS.t9 a_18443_1842# a_18877_1842# VSS.t227 sg13_lv_nmos ad=0.1406p pd=1.12u as=0.2516p ps=2.16u w=0.74u l=0.13u
X647 VSS.t316 VDD.t402 VSS.t531 VSS.t532 sg13_lv_nmos ad=79.8f pd=0.8u as=0 ps=0 w=0.42u l=1u
X648 VSS.t140 a_6126_3816# a_5974_5723# VSS.t138 sg13_lv_nmos ad=0.68p pd=4.68u as=0.38p ps=2.38u w=2u l=1u
X649 a_22113_1842# a_21917_1842# VSS.t115 VSS.t496 sg13_lv_nmos ad=0.2516p pd=2.16u as=0.1406p ps=1.12u w=0.74u l=0.13u
X650 a_1544_289# MUX_SEL3 VDD.t19 VDD.t4 sg13_lv_pmos ad=0.3808p pd=2.92u as=0.3808p ps=2.92u w=1.12u l=0.13u
X651 VDD.t210 VDD.t325 VDD.t332 VDD.t6 sg13_lv_pmos ad=0.38p pd=2.38u as=0 ps=0 w=2u l=1u
X652 a_26673_1842# a_26477_1842# VDD.t108 VDD.t0 sg13_lv_pmos ad=0.3808p pd=2.92u as=0.2128p ps=1.5u w=1.12u l=0.13u
X653 a_10328_1044# a_9757_1842# VSS.t234 VSS.t577 sg13_lv_nmos ad=0.1406p pd=1.12u as=0.2516p ps=2.16u w=0.74u l=0.13u
X654 VSS.t316 VDD.t401 VSS.t316 VSS.t533 sg13_lv_nmos ad=0.1428p pd=1.52u as=0 ps=0 w=0.42u l=1u
X655 a_22590_1044# a_2019_1047.t3 a_22488_1044# VSS.t607 sg13_lv_nmos ad=0.2516p pd=2.16u as=0.1406p ps=1.12u w=0.74u l=0.13u
X656 VSS.t1 DELAY_VBIASN a_12471_1842# VSS.t55 sg13_lv_nmos ad=0.2516p pd=2.16u as=0.1406p ps=1.12u w=0.74u l=0.6u
X657 a_8808_1044# a_8237_1842# VSS.t309 VSS.t308 sg13_lv_nmos ad=0.1406p pd=1.12u as=0.2516p ps=2.16u w=0.74u l=0.13u
X658 VSS.t98 a_22243_1842# a_22677_1842# VSS.t594 sg13_lv_nmos ad=0.1406p pd=1.12u as=0.2516p ps=2.16u w=0.74u l=0.13u
X659 VDD.t263 DELAY_VBIASP a_6391_2470# VDD.t0 sg13_lv_pmos ad=0.3808p pd=2.92u as=0.2128p ps=1.5u w=1.12u l=0.6u
X660 a_13470_1044# a_15831_1008# a_15755_1044# VDD.t4 sg13_lv_pmos ad=0.3808p pd=2.92u as=0.2128p ps=1.5u w=1.12u l=0.13u
X661 a_1544_1044# MUX_SEL1 VDD.t293 VDD.t4 sg13_lv_pmos ad=0.3808p pd=2.92u as=0.3808p ps=2.92u w=1.12u l=0.13u
X662 VDD.t276 DELAY_VBIASP a_20831_2470# VDD.t0 sg13_lv_pmos ad=0.3808p pd=2.92u as=0.2128p ps=1.5u w=1.12u l=0.6u
X663 VDD.t387 a_2595_1047.t2 a_26471_1008# VDD.t4 sg13_lv_pmos ad=0.3808p pd=2.92u as=0.3808p ps=2.92u w=1.12u l=0.13u
X664 a_4350_1044# a_5191_1008# a_5115_1044# VDD.t4 sg13_lv_pmos ad=0.3808p pd=2.92u as=0.2128p ps=1.5u w=1.12u l=0.13u
X665 VDD.t104 a_16597_1842# a_17065_1044# VDD.t4 sg13_lv_pmos ad=0.252p pd=1.57u as=0.3808p ps=2.92u w=1.12u l=0.13u
X666 VSS.t238 a_27237_1842# a_27705_1044# VSS.t237 sg13_lv_nmos ad=0.1665p pd=1.19u as=0.2516p ps=2.16u w=0.74u l=0.13u
X667 VSS.t61 DELAY_VBIASN VSS.t64 VSS.t63 sg13_lv_nmos ad=1.33p pd=7.38u as=0 ps=0 w=7u l=7u
X668 a_10191_2470# a_9953_1842# a_10083_1842# VDD.t0 sg13_lv_pmos ad=0.2128p pd=1.5u as=0.3808p ps=2.92u w=1.12u l=0.2u
X669 a_2595_1047.t0 a_2297_1395# VSS.t148 VSS.t147 sg13_lv_nmos ad=0.1406p pd=1.12u as=0.1331p ps=1.12u w=0.74u l=0.13u
X670 a_26151_1842# a_25913_1842# a_26043_1842# VSS.t179 sg13_lv_nmos ad=0.1406p pd=1.12u as=0.2516p ps=2.16u w=0.74u l=0.2u
X671 VSS.t536 a_2019_311# a_17865_519# VSS.t574 sg13_lv_nmos ad=0.2516p pd=2.16u as=0.2516p ps=2.16u w=0.74u l=0.13u
X672 VSS.t289 a_1544_289# a_2391_331# VSS.t318 sg13_lv_nmos ad=0.1331p pd=1.12u as=0.1216p ps=1.02u w=0.64u l=0.13u
X673 a_4871_1842# a_4633_1842# a_4763_1842# VSS.t226 sg13_lv_nmos ad=0.1406p pd=1.12u as=0.2516p ps=2.16u w=0.74u l=0.2u
X674 a_13753_1842# a_13557_1842# VSS.t113 VSS.t462 sg13_lv_nmos ad=0.2516p pd=2.16u as=0.1406p ps=1.12u w=0.74u l=0.13u
X675 a_1815_1395# a_1256_1044# a_1721_1395# VSS.t339 sg13_lv_nmos ad=0.1216p pd=1.02u as=0.2176p ps=1.96u w=0.64u l=0.13u
X676 a_7673_1842# a_7477_1842# VDD.t110 VDD.t0 sg13_lv_pmos ad=0.3808p pd=2.92u as=0.2128p ps=1.5u w=1.12u l=0.13u
X677 VDD.t132 VSS.t536 VDD.t131 VDD.t4 sg13_lv_pmos ad=0.34p pd=2.68u as=0 ps=0 w=1u l=1u
X678 a_1721_331# a_1256_289# VDD.t316 VDD.t4 sg13_lv_pmos ad=0.1596p pd=1.22u as=0.2856p ps=2.36u w=0.84u l=0.13u
X679 VSS.t125 a_24523_1842# a_24957_1842# VSS.t303 sg13_lv_nmos ad=0.1406p pd=1.12u as=0.2516p ps=2.16u w=0.74u l=0.13u
X680 a_6635_1044# a_6425_1044# VSS.t333 VSS.t332 sg13_lv_nmos ad=0.1406p pd=1.12u as=0.1665p ps=1.19u w=0.74u l=0.13u
X681 VDD.t7 a_15108_5325# a_15053_5420# VDD.t6 sg13_lv_pmos ad=1.10612p pd=6.66u as=93.45f ps=0.865u w=0.42u l=0.13u
X682 VSS.t430 a_2595_1047.t9 a_5191_1008# VSS.t469 sg13_lv_nmos ad=0.2516p pd=2.16u as=0.2516p ps=2.16u w=0.74u l=0.13u
X683 a_20315_1044# a_20105_1044# VSS.t398 VSS.t454 sg13_lv_nmos ad=0.1406p pd=1.12u as=0.1665p ps=1.19u w=0.74u l=0.13u
X684 VDD.t265 DELAY_VBIASP a_11711_2470# VDD.t0 sg13_lv_pmos ad=0.3808p pd=2.92u as=0.2128p ps=1.5u w=1.12u l=0.6u
X685 a_18795_1044# a_18585_1044# VDD.t239 VDD.t4 sg13_lv_pmos ad=0.2128p pd=1.5u as=0.252p ps=1.57u w=1.12u l=0.13u
X686 a_25528_1044# a_24957_1842# VSS.t16 VSS.t228 sg13_lv_nmos ad=0.1406p pd=1.12u as=0.2516p ps=2.16u w=0.74u l=0.13u
X687 a_5778_3367# a_6126_3816# a_6326_4590# VSS.t135 sg13_lv_nmos ad=0.68p pd=4.68u as=0.38p ps=2.38u w=2u l=1u
X688 VSS.t79 DELAY_VBIASN VSS.t88 VSS.t69 sg13_lv_nmos ad=1.33p pd=7.38u as=0 ps=0 w=7u l=7u
X689 VSS.t131 DELAY_VBIASN a_27671_1842# VSS.t130 sg13_lv_nmos ad=0.2516p pd=2.16u as=0.1406p ps=1.12u w=0.74u l=0.6u
X690 a_5731_289# a_3747_311.t3 a_13470_1044# VSS.t314 sg13_lv_nmos ad=0.2516p pd=2.16u as=0.2516p ps=2.16u w=0.74u l=0.13u
X691 a_25630_1044# a_27124_1008# a_27048_1044# VDD.t4 sg13_lv_pmos ad=0.3808p pd=2.92u as=0.2128p ps=1.5u w=1.12u l=0.13u
X692 VDD.t62 a_2595_1047.t5 a_17351_1008# VDD.t4 sg13_lv_pmos ad=0.3808p pd=2.92u as=0.3808p ps=2.92u w=1.12u l=0.13u
X693 VSS.t154 a_13121_5831# a_6854_5986# VDD.t38 sg13_lv_pmos ad=0.232p pd=2.08u as=0.136p ps=1.14u w=0.4u l=0.2u
X694 VDD.t185 a_21483_1842# a_21917_1842# VDD.t0 sg13_lv_pmos ad=0.2128p pd=1.5u as=0.3808p ps=2.92u w=1.12u l=0.13u
X695 a_4350_1044# a_5844_1008# a_5768_1044# VDD.t4 sg13_lv_pmos ad=0.3808p pd=2.92u as=0.2128p ps=1.5u w=1.12u l=0.13u
X696 VSS.t215 a_16851_309# MUX_OUT VSS.t504 sg13_lv_nmos ad=0.2516p pd=2.16u as=0.1406p ps=1.12u w=0.74u l=0.13u
X697 VSS.t506 a_2019_311# a_5705_519# VSS.t572 sg13_lv_nmos ad=0.2516p pd=2.16u as=0.2516p ps=2.16u w=0.74u l=0.13u
X698 VDD.t134 a_1544_289# a_1721_331# VDD.t4 sg13_lv_pmos ad=0.1918p pd=1.5u as=0.1596p ps=1.22u w=0.84u l=0.13u
X699 a_7151_1842# a_6913_1842# a_7043_1842# VSS.t353 sg13_lv_nmos ad=0.1406p pd=1.12u as=0.2516p ps=2.16u w=0.74u l=0.2u
X700 a_16033_1842# a_15837_1842# VSS.t5 VSS.t4 sg13_lv_nmos ad=0.2516p pd=2.16u as=0.1406p ps=1.12u w=0.74u l=0.13u
X701 a_10649_5878# REF_CLK VSS.t329 VSS.t328 sg13_lv_nmos ad=0.2516p pd=2.16u as=1.9998p ps=12.915u w=0.74u l=0.13u
X702 VDD.t7 a_11748_6109# a_11693_5990# VDD.t6 sg13_lv_pmos ad=1.10612p pd=6.66u as=93.45f ps=0.865u w=0.42u l=0.13u
X703 MUX_OUT a_16851_309# VDD.t320 VDD.t4 sg13_lv_pmos ad=0.2128p pd=1.5u as=0.2086p ps=1.5u w=1.12u l=0.13u
X704 a_25391_2470# a_25153_1842# a_25283_1842# VDD.t0 sg13_lv_pmos ad=0.2128p pd=1.5u as=0.3808p ps=2.92u w=1.12u l=0.2u
X705 VDD.t124 VSS.t175 VDD.t123 VDD.t4 sg13_lv_pmos ad=0.34p pd=2.68u as=0 ps=0 w=1u l=1u
X706 a_12993_1842# a_12797_1842# VDD.t1 VDD.t0 sg13_lv_pmos ad=0.3808p pd=2.92u as=0.2128p ps=1.5u w=1.12u l=0.13u
X707 a_16408_1044# a_15837_1842# VSS.t7 VSS.t6 sg13_lv_nmos ad=0.1406p pd=1.12u as=0.2516p ps=2.16u w=0.74u l=0.13u
X708 a_5778_3367# a_6126_3816# a_6326_4590# VSS.t135 sg13_lv_nmos ad=0.68p pd=4.68u as=0.38p ps=2.38u w=2u l=1u
X709 VSS.t104 a_5523_1842# a_5957_1842# VSS.t163 sg13_lv_nmos ad=0.1406p pd=1.12u as=0.2516p ps=2.16u w=0.74u l=0.13u
X710 VDD.t257 DELAY_VBIASP a_13991_2470# VDD.t0 sg13_lv_pmos ad=0.3808p pd=2.92u as=0.2128p ps=1.5u w=1.12u l=0.6u
X711 a_5731_289# a_2019_311# a_4350_1044# VSS.t571 sg13_lv_nmos ad=0.2516p pd=2.16u as=0.2516p ps=2.16u w=0.74u l=0.13u
X712 VSS.t306 a_9547_6172# a_9547_6172# VSS.t305 sg13_lv_nmos ad=2.39977p pd=15.495u as=0.111p ps=1.34u w=0.3u l=0.13u
X713 a_9444_3912# a_6854_5454# a_9712_3912# VSS.t581 sg13_lv_nmos ad=0.68p pd=4.68u as=0.38p ps=2.38u w=2u l=1u
X714 VSS.t93 DELAY_VBIASN VSS.t91 VSS.t75 sg13_lv_nmos ad=1.33p pd=7.38u as=0 ps=0 w=7u l=7u
X715 a_7390_1044# a_3747_1047.t8 a_9675_1044# VSS.t232 sg13_lv_nmos ad=0.2516p pd=2.16u as=0.1406p ps=1.12u w=0.74u l=0.13u
X716 VDD.t169 a_23763_1842# a_24197_1842# VDD.t0 sg13_lv_pmos ad=0.2128p pd=1.5u as=0.3808p ps=2.92u w=1.12u l=0.13u
X717 VSS.t102 DELAY_VBIASN a_8671_1842# VSS.t101 sg13_lv_nmos ad=0.2516p pd=2.16u as=0.1406p ps=1.12u w=0.74u l=0.6u
X718 VDD.t305 a_2019_1047.t8 a_7364_1008# VDD.t4 sg13_lv_pmos ad=0.3808p pd=2.92u as=0.3808p ps=2.92u w=1.12u l=0.13u
X719 VDD.t283 DELAY_VBIASP a_26911_2470# VDD.t0 sg13_lv_pmos ad=0.3808p pd=2.92u as=0.2128p ps=1.5u w=1.12u l=0.6u
X720 VSS.t338 a_14009_5084# a_14111_5227# VSS.t391 sg13_lv_nmos ad=1.45407p pd=9.445u as=0.2516p ps=2.16u w=0.74u l=0.13u
X721 VDD.t35 VSS.t563 VDD.t33 VDD.t4 sg13_lv_pmos ad=0.19p pd=1.38u as=0 ps=0 w=1u l=1u
X722 a_12471_1842# a_12233_1842# a_12363_1842# VSS.t160 sg13_lv_nmos ad=0.1406p pd=1.12u as=0.2516p ps=2.16u w=0.74u l=0.2u
X723 a_22488_1044# a_21917_1842# VDD.t308 VDD.t4 sg13_lv_pmos ad=0.2128p pd=1.5u as=0.3808p ps=2.92u w=1.12u l=0.13u
X724 VDD.t51 a_2595_311.t3 a_8745_519# VDD.t4 sg13_lv_pmos ad=0.3808p pd=2.92u as=0.3808p ps=2.92u w=1.12u l=0.13u
X725 VSS.t295 a_3171_1047.t5 a_18004_1008# VSS.t294 sg13_lv_nmos ad=0.2516p pd=2.16u as=0.2516p ps=2.16u w=0.74u l=0.13u
X726 a_6391_2470# a_6153_1842# a_6283_1842# VDD.t0 sg13_lv_pmos ad=0.2128p pd=1.5u as=0.3808p ps=2.92u w=1.12u l=0.2u
X727 a_15273_1842# a_15077_1842# VDD.t26 VDD.t0 sg13_lv_pmos ad=0.3808p pd=2.92u as=0.2128p ps=1.5u w=1.12u l=0.13u
X728 a_14235_1044# a_14025_1044# VSS.t376 VSS.t375 sg13_lv_nmos ad=0.1406p pd=1.12u as=0.1665p ps=1.19u w=0.74u l=0.13u
X729 a_6326_4590# a_6126_3816# a_5778_3367# VSS.t135 sg13_lv_nmos ad=0.42p pd=2.42u as=0.68p ps=4.68u w=2u l=1u
X730 VSS.t30 a_3747_1047.t7 a_12791_1008# VSS.t29 sg13_lv_nmos ad=0.2516p pd=2.16u as=0.2516p ps=2.16u w=0.74u l=0.13u
X731 VSS.t262 VSS.t259 VSS.t261 VSS.t260 sg13_lv_nmos ad=0.2516p pd=2.16u as=0 ps=0 w=0.74u l=0.13u
X732 a_9953_1842# a_9757_1842# VSS.t100 VSS.t576 sg13_lv_nmos ad=0.2516p pd=2.16u as=0.1406p ps=1.12u w=0.74u l=0.13u
X733 VSS.t22 a_10843_1842# a_11277_1842# VSS.t610 sg13_lv_nmos ad=0.1406p pd=1.12u as=0.2516p ps=2.16u w=0.74u l=0.13u
X734 VSS.t553 VDD.t395 VSS.t553 VSS.t554 sg13_lv_nmos ad=0.1428p pd=1.52u as=0 ps=0 w=0.42u l=1u
X735 a_10649_5878# REF_CLK VDD.t7 VDD.t6 sg13_lv_pmos ad=0.4088p pd=2.97u as=1.03698p ps=6.245u w=1.12u l=0.13u
X736 VDD.t3 a_15403_1842# a_15837_1842# VDD.t0 sg13_lv_pmos ad=0.2128p pd=1.5u as=0.3808p ps=2.92u w=1.12u l=0.13u
X737 VDD.t7 a_14009_5084# a_14111_5227# VDD.t6 sg13_lv_pmos ad=1.10612p pd=6.66u as=0.3864p ps=2.93u w=1.12u l=0.13u
X738 VSS.t531 VDD.t402 VSS.t531 VSS.t530 sg13_lv_nmos ad=0.1428p pd=1.52u as=0 ps=0 w=0.42u l=1u
X739 a_11848_1044# a_11277_1842# VSS.t24 VSS.t23 sg13_lv_nmos ad=0.1406p pd=1.12u as=0.2516p ps=2.16u w=0.74u l=0.13u
X740 a_6326_4590# a_6326_4590# VDD.t206 VDD.t6 sg13_lv_pmos ad=0.38p pd=2.38u as=0.38p ps=2.38u w=2u l=1u
X741 VDD.t48 a_4763_1842# a_5197_1842# VDD.t0 sg13_lv_pmos ad=0.2128p pd=1.5u as=0.3808p ps=2.92u w=1.12u l=0.13u
X742 VSS.t539 VDD.t400 VSS.t537 VSS.t538 sg13_lv_nmos ad=79.8f pd=0.8u as=0 ps=0 w=0.42u l=1u
X743 a_13470_1044# a_13444_1008# a_13368_1044# VDD.t4 sg13_lv_pmos ad=0.3808p pd=2.92u as=0.2128p ps=1.5u w=1.12u l=0.13u
X744 VDD.t74 a_3449_1395# a_3747_1047.t1 VDD.t4 sg13_lv_pmos ad=0.4256p pd=3u as=0.2128p ps=1.5u w=1.12u l=0.13u
X745 VSS.t271 VSS.t268 VSS.t268 VSS.t269 sg13_lv_nmos ad=0.1406p pd=1.12u as=0 ps=0 w=0.74u l=0.13u
X746 VDD.t247 a_3171_1047.t3 a_24084_1008# VDD.t4 sg13_lv_pmos ad=0.3808p pd=2.92u as=0.3808p ps=2.92u w=1.12u l=0.13u
X747 a_3449_1395# MUX_SEL0 VDD.t289 VDD.t4 sg13_lv_pmos ad=0.1596p pd=1.22u as=0.2856p ps=2.36u w=0.84u l=0.13u
X748 a_15464_3684# a_14851_5182# VDD.t355 VDD.t6 sg13_lv_pmos ad=0.4312p pd=3.01u as=0.2639p ps=1.81u w=1.12u l=0.13u
X749 a_5974_5723# a_6126_3816# VSS.t139 VSS.t138 sg13_lv_nmos ad=0.38p pd=2.38u as=0.68p ps=4.68u w=2u l=1u
X750 VDD.t258 DELAY_VBIASP a_7911_2470# VDD.t0 sg13_lv_pmos ad=0.3808p pd=2.92u as=0.2128p ps=1.5u w=1.12u l=0.6u
X751 VDD.t86 VSS.t513 VDD.t25 VDD.t4 sg13_lv_pmos ad=0.19p pd=1.38u as=0 ps=0 w=1u l=1u
X752 VDD.t210 a_6326_4590# a_6854_5986# VDD.t6 sg13_lv_pmos ad=0.38p pd=2.38u as=0.38p ps=2.38u w=2u l=1u
X753 a_10206_5835# a_10649_5878# a_9946_6305# VSS.t596 sg13_lv_nmos ad=79.8f pd=0.8u as=0.1296p ps=1.52u w=0.42u l=0.13u
X754 VDD.t88 VSS.t513 VDD.t87 VDD.t4 sg13_lv_pmos ad=0.34p pd=2.68u as=0 ps=0 w=1u l=1u
X755 a_9946_6305# a_9772_5843# VDD.t307 VDD.t6 sg13_lv_pmos ad=79.8f pd=0.8u as=0.1428p ps=1.52u w=0.42u l=0.13u
X756 a_9946_6305# a_10751_5878# a_10206_5835# VDD.t6 sg13_lv_pmos ad=0.1428p pd=1.52u as=79.8f ps=0.8u w=0.42u l=0.13u
X757 VDD.t321 a_16851_309# MUX_OUT VDD.t4 sg13_lv_pmos ad=0.7336p pd=3.55u as=0.2128p ps=1.5u w=1.12u l=0.13u
X758 VSS.t361 a_3171_311.t2 a_23945_519# VSS.t360 sg13_lv_nmos ad=0.2516p pd=2.16u as=0.2516p ps=2.16u w=0.74u l=0.13u
X759 VDD.t239 a_18117_1842# a_18585_1044# VDD.t4 sg13_lv_pmos ad=0.252p pd=1.57u as=0.3808p ps=2.92u w=1.12u l=0.13u
X760 VSS.t398 a_19637_1842# a_20105_1044# VSS.t397 sg13_lv_nmos ad=0.1665p pd=1.19u as=0.2516p ps=2.16u w=0.74u l=0.13u
X761 a_11711_2470# a_11473_1842# a_11603_1842# VDD.t0 sg13_lv_pmos ad=0.2128p pd=1.5u as=0.3808p ps=2.92u w=1.12u l=0.2u
X762 a_27671_1842# a_27433_1842# a_27563_1842# VSS.t575 sg13_lv_nmos ad=0.1406p pd=1.12u as=0.2516p ps=2.16u w=0.74u l=0.2u
X763 VSS.t215 MUX_SEL4 a_15765_463# VSS.t214 sg13_lv_nmos ad=0.2516p pd=2.16u as=0.2516p ps=2.16u w=0.74u l=0.13u
X764 a_5731_289# a_14825_519# a_13470_1044# VDD.t4 sg13_lv_pmos ad=0.3808p pd=2.92u as=0.3808p ps=2.92u w=1.12u l=0.13u
X765 a_16510_1044# a_2595_1047.t5 a_17275_1044# VSS.t195 sg13_lv_nmos ad=0.2516p pd=2.16u as=0.1406p ps=1.12u w=0.74u l=0.13u
X766 a_13045_6215# a_13019_5831# a_12849_5867# VSS.t217 sg13_lv_nmos ad=0.1406p pd=1.12u as=0.1406p ps=1.12u w=0.74u l=0.13u
X767 VSS.t119 DELAY_VBIASN a_16271_1842# VSS.t118 sg13_lv_nmos ad=0.2516p pd=2.16u as=0.1406p ps=1.12u w=0.74u l=0.6u
X768 VDD.t22 VSS.t361 VDD.t244 VDD.t4 sg13_lv_pmos ad=0.34p pd=2.68u as=0 ps=0 w=1u l=1u
X769 VDD.t285 a_3171_1047.t6 a_14964_1008# VDD.t4 sg13_lv_pmos ad=0.3808p pd=2.92u as=0.3808p ps=2.92u w=1.12u l=0.13u
X770 VDD.t296 a_10083_1842# a_10517_1842# VDD.t0 sg13_lv_pmos ad=0.2128p pd=1.5u as=0.3808p ps=2.92u w=1.12u l=0.13u
X771 VSS.t27 a_3747_1047.t2 a_27991_1008# VSS.t26 sg13_lv_nmos ad=0.2516p pd=2.16u as=0.2516p ps=2.16u w=0.74u l=0.13u
X772 a_9712_3912# a_13019_5831# DELAY_VBIASN VSS.t218 sg13_lv_nmos ad=0.136p pd=1.14u as=0.232p ps=2.08u w=0.4u l=0.2u
X773 VSS.t54 a_26043_1842# a_26477_1842# VSS.t248 sg13_lv_nmos ad=0.1406p pd=1.12u as=0.2516p ps=2.16u w=0.74u l=0.13u
X774 VSS.t146 a_6126_3816# a_5974_5723# VSS.t138 sg13_lv_nmos ad=0.68p pd=4.68u as=0.38p ps=2.38u w=2u l=1u
X775 a_11195_1044# a_10985_1044# VDD.t63 VDD.t4 sg13_lv_pmos ad=0.2128p pd=1.5u as=0.252p ps=1.57u w=1.12u l=0.13u
X776 VSS.t502 a_3747_1047.t9 a_6711_1008# VSS.t501 sg13_lv_nmos ad=0.2516p pd=2.16u as=0.2516p ps=2.16u w=0.74u l=0.13u
X777 a_9444_4590# a_6854_5454# a_6854_5454# VSS.t581 sg13_lv_nmos ad=0.68p pd=4.68u as=0.38p ps=2.38u w=2u l=1u
X778 a_16108_289# a_2595_311.t2 a_19550_1044# VSS.t176 sg13_lv_nmos ad=0.2516p pd=2.16u as=0.2516p ps=2.16u w=0.74u l=0.13u
X779 VSS.t123 DELAY_VBIASN a_20071_1842# VSS.t122 sg13_lv_nmos ad=0.2516p pd=2.16u as=0.1406p ps=1.12u w=0.74u l=0.6u
X780 VDD.t279 DELAY_VBIASP a_24631_2470# VDD.t0 sg13_lv_pmos ad=0.3808p pd=2.92u as=0.2128p ps=1.5u w=1.12u l=0.6u
X781 a_22590_1044# a_23431_1008# a_23355_1044# VDD.t4 sg13_lv_pmos ad=0.3808p pd=2.92u as=0.2128p ps=1.5u w=1.12u l=0.13u
X782 VSS.t523 VDD.t404 VSS.t523 VSS.t525 sg13_lv_nmos ad=79.8f pd=0.8u as=0 ps=0 w=0.42u l=1u
X783 a_10458_6292# DLL_RESETN VSS.t312 VSS.t614 sg13_lv_nmos ad=37.8f pd=0.6u as=0.1701p ps=1.65u w=0.42u l=0.13u
X784 a_11491_6228# a_10649_5878# a_10232_5871# VDD.t6 sg13_lv_pmos ad=0.2048p pd=1.63u as=0.34p ps=2.68u w=1u l=0.13u
X785 VSS.t144 a_6126_3816# a_5974_5723# VSS.t138 sg13_lv_nmos ad=0.76p pd=4.76u as=0.38p ps=2.38u w=2u l=1u
X786 a_8671_1842# a_8433_1842# a_8563_1842# VSS.t235 sg13_lv_nmos ad=0.1406p pd=1.12u as=0.2516p ps=2.16u w=0.74u l=0.2u
X787 a_17553_1842# a_17357_1842# VSS.t45 VSS.t336 sg13_lv_nmos ad=0.2516p pd=2.16u as=0.1406p ps=1.12u w=0.74u l=0.13u
X788 a_5731_289# a_5705_519# a_4350_1044# VDD.t4 sg13_lv_pmos ad=0.3808p pd=2.92u as=0.3808p ps=2.92u w=1.12u l=0.13u
X789 VDD.t345 VDD.t343 VDD.t344 VDD.t0 sg13_lv_pmos ad=0.3808p pd=2.92u as=0 ps=0 w=1.12u l=0.13u
X790 a_26911_2470# a_26673_1842# a_26803_1842# VDD.t0 sg13_lv_pmos ad=0.2128p pd=1.5u as=0.3808p ps=2.92u w=1.12u l=0.2u
X791 a_7390_1044# a_2019_1047.t8 a_7288_1044# VSS.t487 sg13_lv_nmos ad=0.2516p pd=2.16u as=0.1406p ps=1.12u w=0.74u l=0.13u
X792 a_13566_5328# a_14009_5084# a_13306_5105# VSS.t390 sg13_lv_nmos ad=79.8f pd=0.8u as=0.1296p ps=1.52u w=0.42u l=0.13u
X793 a_21353_1842# a_21157_1842# VSS.t117 VSS.t394 sg13_lv_nmos ad=0.2516p pd=2.16u as=0.1406p ps=1.12u w=0.74u l=0.13u
X794 VSS.t95 a_7043_1842# a_7477_1842# VSS.t437 sg13_lv_nmos ad=0.1406p pd=1.12u as=0.2516p ps=2.16u w=0.74u l=0.13u
X795 a_13121_5831# a_15688_5867# VDD.t153 VDD.t6 sg13_lv_pmos ad=0.3808p pd=2.92u as=0.2128p ps=1.5u w=1.12u l=0.13u
X796 VDD.t267 DELAY_VBIASP a_15511_2470# VDD.t0 sg13_lv_pmos ad=0.3808p pd=2.92u as=0.2128p ps=1.5u w=1.12u l=0.6u
X797 VDD.t214 a_2019_1047.t7 a_10404_1008# VDD.t4 sg13_lv_pmos ad=0.3808p pd=2.92u as=0.3808p ps=2.92u w=1.12u l=0.13u
X798 VSS.t451 a_9444_4590# a_9444_3912# VSS.t449 sg13_lv_nmos ad=0.68p pd=4.68u as=0.38p ps=2.38u w=2u l=1u
X799 VDD.t148 a_25283_1842# a_25717_1842# VDD.t0 sg13_lv_pmos ad=0.2128p pd=1.5u as=0.3808p ps=2.92u w=1.12u l=0.13u
X800 VDD.t256 DELAY_VBIASP a_5631_2470# VDD.t0 sg13_lv_pmos ad=0.3808p pd=2.92u as=0.2128p ps=1.5u w=1.12u l=0.6u
X801 a_26395_1044# a_26185_1044# VDD.t187 VDD.t4 sg13_lv_pmos ad=0.2128p pd=1.5u as=0.252p ps=1.57u w=1.12u l=0.13u
X802 a_13306_5105# a_14111_5227# a_13566_5328# VDD.t6 sg13_lv_pmos ad=0.1428p pd=1.52u as=79.8f ps=0.8u w=0.42u l=0.13u
X803 a_6326_4590# a_6126_3816# a_5778_3367# VSS.t135 sg13_lv_nmos ad=0.38p pd=2.38u as=0.68p ps=4.68u w=2u l=1u
X804 VDD.t11 a_3747_1047.t3 a_24951_1008# VDD.t4 sg13_lv_pmos ad=0.3808p pd=2.92u as=0.3808p ps=2.92u w=1.12u l=0.13u
X805 VDD.t223 VSS.t553 VDD.t177 VDD.t4 sg13_lv_pmos ad=0.19p pd=1.38u as=0 ps=0 w=1u l=1u
X806 a_13991_1842# a_13753_1842# a_13883_1842# VSS.t219 sg13_lv_nmos ad=0.1406p pd=1.12u as=0.2516p ps=2.16u w=0.74u l=0.2u
X807 a_24008_1044# a_23437_1842# VDD.t231 VDD.t4 sg13_lv_pmos ad=0.2128p pd=1.5u as=0.3808p ps=2.92u w=1.12u l=0.13u
X808 VDD.t163 VSS.t529 VDD.t162 VDD.t4 sg13_lv_pmos ad=0.19p pd=1.38u as=0 ps=0 w=1u l=1u
X809 VSS.t374 a_2019_1047.t4 a_19524_1008# VSS.t373 sg13_lv_nmos ad=0.2516p pd=2.16u as=0.2516p ps=2.16u w=0.74u l=0.13u
X810 a_9712_3912# a_6854_5454# a_9444_3912# VSS.t580 sg13_lv_nmos ad=0.38p pd=2.38u as=0.68p ps=4.68u w=2u l=1u
X811 a_7911_2470# a_7673_1842# a_7803_1842# VDD.t0 sg13_lv_pmos ad=0.2128p pd=1.5u as=0.3808p ps=2.92u w=1.12u l=0.2u
X812 a_16793_1842# a_16597_1842# VDD.t116 VDD.t0 sg13_lv_pmos ad=0.3808p pd=2.92u as=0.2128p ps=1.5u w=1.12u l=0.13u
X813 VSS.t222 MUX_SEL1 a_3543_1395# VSS.t477 sg13_lv_nmos ad=0.1331p pd=1.12u as=0.1216p ps=1.02u w=0.64u l=0.13u
X814 a_15755_1044# a_15545_1044# VSS.t134 VSS.t483 sg13_lv_nmos ad=0.1406p pd=1.12u as=0.1665p ps=1.19u w=0.74u l=0.13u
X815 a_13818_5118# a_12849_5867# VSS.t184 VSS.t183 sg13_lv_nmos ad=37.8f pd=0.6u as=0.1701p ps=1.65u w=0.42u l=0.13u
X816 a_2595_1047.t1 a_2297_1395# VDD.t28 VDD.t4 sg13_lv_pmos ad=0.2128p pd=1.5u as=0.1918p ps=1.5u w=1.12u l=0.13u
X817 VSS.t349 a_2595_1047.t6 a_14311_1008# VSS.t348 sg13_lv_nmos ad=0.2516p pd=2.16u as=0.2516p ps=2.16u w=0.74u l=0.13u
X818 VSS.t1 a_12363_1842# a_12797_1842# VSS.t0 sg13_lv_nmos ad=0.1406p pd=1.12u as=0.2516p ps=2.16u w=0.74u l=0.13u
X819 a_5115_1044# a_4905_1044# VSS.t433 VSS.t432 sg13_lv_nmos ad=0.1406p pd=1.12u as=0.1665p ps=1.19u w=0.74u l=0.13u
X820 a_1256_1044# MUX_SEL0 VDD.t290 VDD.t4 sg13_lv_pmos ad=0.3808p pd=2.92u as=0.3808p ps=2.92u w=1.12u l=0.13u
X821 a_9444_3912# a_9444_4590# VSS.t447 VSS.t446 sg13_lv_nmos ad=0.38p pd=2.38u as=0.68p ps=4.68u w=2u l=1u
X822 VSS.t86 DELAY_VBIASN VSS.t84 VSS.t65 sg13_lv_nmos ad=1.33p pd=7.38u as=0 ps=0 w=7u l=7u
X823 VDD.t219 a_27563_1842# a_27997_1842# VDD.t0 sg13_lv_pmos ad=0.2128p pd=1.5u as=0.3808p ps=2.92u w=1.12u l=0.13u
X824 a_20593_1842# a_20397_1842# VDD.t60 VDD.t0 sg13_lv_pmos ad=0.3808p pd=2.92u as=0.2128p ps=1.5u w=1.12u l=0.13u
X825 a_1721_1395# a_1256_1044# VDD.t152 VDD.t4 sg13_lv_pmos ad=0.1596p pd=1.22u as=0.2856p ps=2.36u w=0.84u l=0.13u
X826 VDD.t2 a_6283_1842# a_6717_1842# VDD.t0 sg13_lv_pmos ad=0.2128p pd=1.5u as=0.3808p ps=2.92u w=1.12u l=0.13u
X827 a_13470_1044# a_14964_1008# a_14888_1044# VDD.t4 sg13_lv_pmos ad=0.3808p pd=2.92u as=0.2128p ps=1.5u w=1.12u l=0.13u
X828 a_13592_5871# a_13566_5835# VDD.t55 VDD.t6 sg13_lv_pmos ad=0.34p pd=2.68u as=0.36237p ps=2.605u w=1u l=0.13u
X829 a_5778_3367# a_6126_3816# a_6326_4590# VSS.t135 sg13_lv_nmos ad=0.68p pd=4.68u as=0.42p ps=2.42u w=2u l=1u
X830 VSS.t537 VDD.t400 VSS.t536 VSS.t535 sg13_lv_nmos ad=0.1428p pd=1.52u as=0 ps=0 w=0.42u l=1u
X831 VDD.t66 a_2019_1047.t2 a_25604_1008# VDD.t4 sg13_lv_pmos ad=0.3808p pd=2.92u as=0.3808p ps=2.92u w=1.12u l=0.13u
X832 a_9746_5805# a_9547_5942# VSS.t306 VSS.t427 sg13_lv_nmos ad=0.27427p pd=2.28u as=2.39977p ps=15.495u w=0.795u l=0.13u
X833 a_16271_1842# a_16033_1842# a_16163_1842# VSS.t384 sg13_lv_nmos ad=0.1406p pd=1.12u as=0.2516p ps=2.16u w=0.74u l=0.2u
X834 a_21835_1044# a_21625_1044# VDD.t137 VDD.t4 sg13_lv_pmos ad=0.2128p pd=1.5u as=0.252p ps=1.57u w=1.12u l=0.13u
X835 VDD.t25 VSS.t511 VDD.t24 VDD.t4 sg13_lv_pmos ad=0.34p pd=2.68u as=0 ps=0 w=1u l=1u
X836 VDD.t113 a_2595_1047.t4 a_20391_1008# VDD.t4 sg13_lv_pmos ad=0.3808p pd=2.92u as=0.3808p ps=2.92u w=1.12u l=0.13u
X837 VSS.t190 a_14851_5182# a_15688_5403# VSS.t569 sg13_lv_nmos ad=0.1406p pd=1.12u as=0.2516p ps=2.16u w=0.74u l=0.13u
X838 a_19073_1842# a_18877_1842# VDD.t8 VDD.t0 sg13_lv_pmos ad=0.3808p pd=2.92u as=0.2128p ps=1.5u w=1.12u l=0.13u
X839 VDD.t63 a_10517_1842# a_10985_1044# VDD.t4 sg13_lv_pmos ad=0.252p pd=1.57u as=0.3808p ps=2.92u w=1.12u l=0.13u
X840 VSS.t322 a_21157_1842# a_21625_1044# VSS.t393 sg13_lv_nmos ad=0.1665p pd=1.19u as=0.2516p ps=2.16u w=0.74u l=0.13u
X841 VSS.t182 a_12849_5867# a_13400_6305# VSS.t181 sg13_lv_nmos ad=0.1626p pd=1.415u as=60.89999f ps=0.71u w=0.42u l=0.13u
X842 VSS.t137 a_6126_3816# a_6126_3816# VSS.t135 sg13_lv_nmos ad=0.68p pd=4.68u as=0.38p ps=2.38u w=2u l=1u
X843 a_20071_1842# a_19833_1842# a_19963_1842# VSS.t459 sg13_lv_nmos ad=0.1406p pd=1.12u as=0.2516p ps=2.16u w=0.74u l=0.2u
X844 VSS.t254 VSS.t252 VSS.t252 VSS.t253 sg13_lv_nmos ad=0.68p pd=4.68u as=0 ps=0 w=2u l=1u
X845 VSS.t106 a_14643_1842# a_15077_1842# VSS.t439 sg13_lv_nmos ad=0.1406p pd=1.12u as=0.2516p ps=2.16u w=0.74u l=0.13u
X846 a_1815_331# a_1256_289# a_1721_331# VSS.t497 sg13_lv_nmos ad=0.1216p pd=1.02u as=0.2176p ps=1.96u w=0.64u l=0.13u
X847 VDD.t327 VDD.t325 VDD.t202 VDD.t6 sg13_lv_pmos ad=0.38p pd=2.38u as=0 ps=0 w=2u l=1u
X848 VDD.t212 a_19203_1842# a_19637_1842# VDD.t0 sg13_lv_pmos ad=0.2128p pd=1.5u as=0.3808p ps=2.92u w=1.12u l=0.13u
X849 VSS.t402 a_2019_1047.t9 a_4324_1008# VSS.t401 sg13_lv_nmos ad=0.2516p pd=2.16u as=0.2516p ps=2.16u w=0.74u l=0.13u
X850 a_16108_289# a_20905_519# a_19550_1044# VDD.t4 sg13_lv_pmos ad=0.3808p pd=2.92u as=0.3808p ps=2.92u w=1.12u l=0.13u
X851 a_16510_1044# a_3747_1047.t5 a_18795_1044# VSS.t473 sg13_lv_nmos ad=0.2516p pd=2.16u as=0.1406p ps=1.12u w=0.74u l=0.13u
X852 VDD.t138 a_8563_1842# a_8997_1842# VDD.t0 sg13_lv_pmos ad=0.2128p pd=1.5u as=0.3808p ps=2.92u w=1.12u l=0.13u
X853 VDD.t272 DELAY_VBIASP a_13231_2470# VDD.t0 sg13_lv_pmos ad=0.3808p pd=2.92u as=0.2128p ps=1.5u w=1.12u l=0.6u
X854 VSS.t43 DELAY_VBIASN a_17791_1842# VSS.t42 sg13_lv_nmos ad=0.2516p pd=2.16u as=0.1406p ps=1.12u w=0.74u l=0.6u
X855 VSS.t517 VDD.t406 VSS.t175 VSS.t516 sg13_lv_nmos ad=0.1428p pd=1.52u as=0 ps=0 w=0.42u l=1u
X856 a_6854_5986# a_6326_4590# VDD.t208 VDD.t6 sg13_lv_pmos ad=0.38p pd=2.38u as=0.38p ps=2.38u w=2u l=1u
X857 VDD.t340 VDD.t338 VDD.t339 VDD.t38 sg13_lv_pmos ad=0.3808p pd=2.92u as=0 ps=0 w=1.12u l=0.13u
X858 VDD.t291 a_3747_1047.t5 a_18871_1008# VDD.t4 sg13_lv_pmos ad=0.3808p pd=2.92u as=0.3808p ps=2.92u w=1.12u l=0.13u
X859 VDD.t335 VDD.t336 VDD.t337 VDD.t38 sg13_lv_pmos ad=0.2128p pd=1.5u as=0 ps=0 w=1.12u l=0.13u
X860 VDD.t229 a_23003_1842# a_23437_1842# VDD.t0 sg13_lv_pmos ad=0.2128p pd=1.5u as=0.3808p ps=2.92u w=1.12u l=0.13u
X861 VSS.t450 a_9444_4590# a_9444_4590# VSS.t449 sg13_lv_nmos ad=0.68p pd=4.68u as=0.38p ps=2.38u w=2u l=1u
X862 VSS.t139 VSS.t249 VSS.t249 VSS.t250 sg13_lv_nmos ad=0.68p pd=4.68u as=0 ps=0 w=2u l=1u
X863 a_12715_1044# a_12505_1044# VDD.t39 VDD.t4 sg13_lv_pmos ad=0.2128p pd=1.5u as=0.252p ps=1.57u w=1.12u l=0.13u
X864 a_19550_1044# a_21044_1008# a_20968_1044# VDD.t4 sg13_lv_pmos ad=0.3808p pd=2.92u as=0.2128p ps=1.5u w=1.12u l=0.13u
X865 a_17928_1044# a_17357_1842# VDD.t149 VDD.t4 sg13_lv_pmos ad=0.2128p pd=1.5u as=0.3808p ps=2.92u w=1.12u l=0.13u
X866 VSS.t115 DELAY_VBIASN a_21591_1842# VSS.t114 sg13_lv_nmos ad=0.2516p pd=2.16u as=0.1406p ps=1.12u w=0.74u l=0.6u
X867 VSS.t289 a_1544_289# a_1815_331# VSS.t317 sg13_lv_nmos ad=0.1331p pd=1.12u as=0.1216p ps=1.02u w=0.64u l=0.13u
X868 a_7288_1044# a_6717_1842# VDD.t376 VDD.t4 sg13_lv_pmos ad=0.2128p pd=1.5u as=0.3808p ps=2.92u w=1.12u l=0.13u
X869 VSS.t72 DELAY_VBIASN VSS.t74 VSS.t73 sg13_lv_nmos ad=1.33p pd=7.38u as=0 ps=0 w=7u l=7u
X870 a_5974_5723# a_6126_3816# VSS.t144 VSS.t138 sg13_lv_nmos ad=0.38p pd=2.38u as=0.68p ps=4.68u w=2u l=1u
X871 a_15511_2470# a_15273_1842# a_15403_1842# VDD.t0 sg13_lv_pmos ad=0.2128p pd=1.5u as=0.3808p ps=2.92u w=1.12u l=0.2u
X872 VSS.t280 VSS.t282 VSS.t284 VSS.t283 sg13_lv_nmos ad=0.1406p pd=1.12u as=0 ps=0 w=0.74u l=0.2u
X873 a_22590_1044# a_24951_1008# a_24875_1044# VDD.t4 sg13_lv_pmos ad=0.3808p pd=2.92u as=0.2128p ps=1.5u w=1.12u l=0.13u
X874 VSS.t563 VDD.t392 VSS.t563 VSS.t565 sg13_lv_nmos ad=79.8f pd=0.8u as=0 ps=0 w=0.42u l=1u
X875 VSS.t190 a_15108_5325# a_14757_5182# VSS.t481 sg13_lv_nmos ad=79.8f pd=0.8u as=0.1428p ps=1.52u w=0.42u l=0.13u
X876 a_10430_1044# a_2019_1047.t7 a_10328_1044# VSS.t403 sg13_lv_nmos ad=0.2516p pd=2.16u as=0.1406p ps=1.12u w=0.74u l=0.13u
X877 VDD.t40 a_5974_5723# a_5974_5723# VDD.t6 sg13_lv_pmos ad=0.2448p pd=2.08u as=0.2826p ps=2.29u w=0.36u l=2u
X878 VDD.t187 a_25717_1842# a_26185_1044# VDD.t4 sg13_lv_pmos ad=0.252p pd=1.57u as=0.3808p ps=2.92u w=1.12u l=0.13u
X879 a_6854_5454# a_6854_5454# a_9444_4590# VSS.t580 sg13_lv_nmos ad=0.38p pd=2.38u as=0.68p ps=4.68u w=2u l=1u
X880 VDD.t42 a_13883_1842# a_14317_1842# VDD.t0 sg13_lv_pmos ad=0.2128p pd=1.5u as=0.3808p ps=2.92u w=1.12u l=0.13u
X881 VDD.t237 a_4437_1842# a_4905_1044# VDD.t4 sg13_lv_pmos ad=0.252p pd=1.57u as=0.3808p ps=2.92u w=1.12u l=0.13u
X882 a_4157_1313# REF_CLK VSS.t327 VSS.t326 sg13_lv_nmos ad=0.2516p pd=2.16u as=0.2553p ps=2.17u w=0.74u l=0.13u
X883 a_7390_1044# a_3171_1047.t8 a_8808_1044# VSS.t200 sg13_lv_nmos ad=0.2516p pd=2.16u as=0.1406p ps=1.12u w=0.74u l=0.13u
X884 a_22873_1842# a_22677_1842# VSS.t98 VSS.t395 sg13_lv_nmos ad=0.2516p pd=2.16u as=0.1406p ps=1.12u w=0.74u l=0.13u
X885 a_9444_4590# a_9444_4590# VSS.t448 VSS.t446 sg13_lv_nmos ad=0.38p pd=2.38u as=0.68p ps=4.68u w=2u l=1u
X886 VDD.t64 a_3171_1047.t8 a_8884_1008# VDD.t4 sg13_lv_pmos ad=0.3808p pd=2.92u as=0.3808p ps=2.92u w=1.12u l=0.13u
C0 a_14009_5084# a_14111_5227# 0.47622f
C1 DELAY_VBIASP a_10517_1842# 0.0414f
C2 DELAY_VBIASN a_10713_1842# 0.0961f
C3 a_16793_1842# a_16923_1842# 0.70845f
C4 a_1256_289# a_1721_331# 0.13421f
C5 a_8997_1842# a_7390_1044# 0.05231f
C6 a_8237_1842# a_8231_1008# 0.02349f
C7 a_20105_1044# a_20315_1044# 0.09424f
C8 a_10843_1842# a_10951_2470# 0.01697f
C9 a_25153_1842# a_25717_1842# 0.0114f
C10 VDD a_20105_1044# 0.30409f
C11 MUX_SEL0 a_3449_1395# 0.10753f
C12 a_9946_6305# a_10649_5878# 0.02432f
C13 a_4437_1842# REF_CLK 0.05209f
C14 a_4905_1044# a_5115_1044# 0.09424f
C15 a_19963_1842# a_19550_1044# 0.01012f
C16 VDD a_19833_1842# 0.49294f
C17 a_5731_289# a_4350_1044# 0.41099f
C18 VDD a_17351_1008# 0.28565f
C19 a_10430_1044# a_11848_1044# 0.38994f
C20 MUX_SEL2 MUX_OUT 0.08497f
C21 MUX_SEL3 MUX_SEL4 0.75489f
C22 a_13883_1842# a_13470_1044# 0.01012f
C23 DELAY_VBIASP a_18117_1842# 0.04177f
C24 VDD a_10843_1842# 0.4973f
C25 a_6326_4590# a_5974_5723# 0.33136f
C26 DELAY_VBIASN a_8997_1842# 0.09156f
C27 DELAY_VBIASP a_7803_1842# 0.06627f
C28 a_7390_1044# a_8155_1044# 0.39037f
C29 a_7477_1842# a_8237_1842# 0.01669f
C30 a_15837_1842# a_16163_1842# 0.01427f
C31 a_22873_1842# a_23437_1842# 0.0114f
C32 a_9323_1842# a_9431_2470# 0.01697f
C33 a_24197_1842# a_24957_1842# 0.02912f
C34 VDD a_7945_1044# 0.30409f
C35 a_8745_519# VDD 0.29292f
C36 a_18877_1842# a_19448_1044# 0.10864f
C37 a_18795_1044# a_16510_1044# 0.39036f
C38 VDD a_14888_1044# 0.17499f
C39 a_9444_4590# DLL_RESETN 0.10275f
C40 DELAY_VBIASN a_16597_1842# 0.0907f
C41 DELAY_VBIASP a_15403_1842# 0.06668f
C42 VDD a_9193_1842# 0.49285f
C43 a_15077_1842# a_15273_1842# 0.77122f
C44 a_25630_1044# a_26395_1044# 0.39037f
C45 a_21917_1842# a_22677_1842# 0.06198f
C46 a_20905_519# a_19550_1044# 0.02165f
C47 a_7803_1842# a_7911_2470# 0.01697f
C48 a_16851_309# VDD 0.51536f
C49 VDD a_2873_1395# 0.46517f
C50 a_2873_331# VDD 0.46491f
C51 a_6854_5986# a_6854_5454# 0.30378f
C52 a_25630_1044# DELAY_VBIASP 0.01522f
C53 a_6854_5986# DELAY_VBIASP 0.01478f
C54 a_27915_1044# a_27705_1044# 0.09424f
C55 VDD a_11924_1008# 0.28225f
C56 DELAY_VBIASN DELAY_VBIASP 8.74838f
C57 VDD a_15688_5867# 0.30345f
C58 MUX_SEL1 REF_CLK 0.01858f
C59 a_13306_6305# a_13592_5871# 0.41329f
C60 a_13019_5831# a_12943_5867# 0.03346f
C61 a_12849_5867# a_14009_5878# 0.03525f
C62 a_12907_5420# DLL_RESETN 0.04234f
C63 a_6717_1842# DELAY_VBIASP 0.0414f
C64 a_6913_1842# DELAY_VBIASN 0.0961f
C65 VDD a_8808_1044# 0.17499f
C66 VDD a_16793_1842# 0.49277f
C67 VDD a_21591_2470# 0.01806f
C68 DELAY_VBIASN a_13883_1842# 0.07254f
C69 DELAY_VBIASP a_13753_1842# 0.11222f
C70 a_6717_1842# a_6913_1842# 0.76914f
C71 a_4350_1044# a_5768_1044# 0.38994f
C72 a_13753_1842# a_13883_1842# 0.70845f
C73 a_21157_1842# a_20723_1842# 0.6972f
C74 a_27048_1044# VDD 0.17499f
C75 a_22488_1044# a_22564_1008# 0.01176f
C76 a_9547_6172# VDD 0.08695f
C77 VDD a_24951_1008# 0.2822f
C78 VDD a_14009_5878# 0.23872f
C79 MUX_SEL4 a_4157_1313# 0.08229f
C80 a_13019_5831# a_12849_5867# 0.12838f
C81 a_7043_1842# VDD 0.49723f
C82 a_5197_1842# DELAY_VBIASN 0.09974f
C83 MUX_OUT a_2019_311# 8.45486f
C84 a_4003_1842# DELAY_VBIASP 0.05992f
C85 VDD a_5844_1008# 0.28225f
C86 VDD a_15077_1842# 0.85965f
C87 VDD a_15511_2470# 0.01806f
C88 a_5393_1842# a_5523_1842# 0.70845f
C89 a_12233_1842# a_12797_1842# 0.0114f
C90 a_4763_1842# a_4350_1044# 0.01012f
C91 MUX_SEL4 a_13470_1044# 0.256f
C92 a_19833_1842# a_20397_1842# 0.0114f
C93 a_16108_289# a_24957_1842# 0.0157f
C94 a_27124_1008# a_26477_1842# 0.02312f
C95 VDD a_22488_1044# 0.17274f
C96 MUX_SEL4 a_14825_519# 0.03307f
C97 VDD a_13019_5831# 0.41932f
C98 a_5393_1842# VDD 0.49417f
C99 DELAY_VBIASP a_27237_1842# 0.06225f
C100 DELAY_VBIASN a_27433_1842# 0.10734f
C101 MUX_SEL2 a_1721_331# 0.01315f
C102 MUX_SEL4 a_1256_289# 0.65005f
C103 MUX_SEL3 a_1544_289# 0.15976f
C104 a_15464_3684# DELAY_OUT_LAST 0.02565f
C105 VDD a_27705_1044# 0.29918f
C106 VDD a_9431_2470# 0.01806f
C107 a_11277_1842# a_12037_1842# 0.03319f
C108 a_9444_4590# a_6854_5454# 1.25013f
C109 a_18877_1842# a_19637_1842# 0.06198f
C110 a_18443_1842# a_16510_1044# 0.01012f
C111 MUX_SEL4 a_7390_1044# 0.34655f
C112 a_16408_1044# a_16510_1044# 0.37183f
C113 a_19550_1044# a_20315_1044# 0.39037f
C114 a_25630_1044# a_25717_1842# 0.1088f
C115 VDD a_19550_1044# 0.89766f
C116 VDD a_27563_1842# 0.49811f
C117 a_9444_3912# VDD 0.0107f
C118 DELAY_VBIASP a_24523_1842# 0.06661f
C119 DELAY_VBIASN a_25717_1842# 0.09106f
C120 a_6283_1842# a_6391_1842# 0.01163f
C121 a_10751_5878# REF_CLK 0.01931f
C122 a_11748_6109# DLL_RESETN 0.11133f
C123 a_15545_1044# a_13470_1044# 0.03208f
C124 a_9444_3912# a_5864_3367# 0.02483f
C125 a_10517_1842# a_10083_1842# 0.69698f
C126 MUX_SEL1 MUX_SEL0 3.14917f
C127 a_15688_5403# VDD 0.30345f
C128 a_13592_5423# a_12849_5867# 0.38497f
C129 a_23437_1842# a_23431_1008# 0.02349f
C130 a_6717_1842# MUX_SEL4 0.0195f
C131 a_14888_1044# a_14964_1008# 0.01176f
C132 DELAY_VBIASP a_22243_1842# 0.06661f
C133 DELAY_VBIASN a_23437_1842# 0.10669f
C134 a_18117_1842# a_16510_1044# 0.05231f
C135 a_17357_1842# a_17351_1008# 0.02349f
C136 a_12363_1842# a_10430_1044# 0.01012f
C137 VDD a_25913_1842# 0.49294f
C138 a_4763_1842# a_4871_1842# 0.01163f
C139 a_5705_519# a_5731_289# 0.28954f
C140 a_9946_6305# DLL_RESETN 0.09997f
C141 a_27237_1842# a_27433_1842# 0.77122f
C142 a_2297_1395# MUX_SEL0 0.10655f
C143 a_9193_1842# a_9757_1842# 0.0114f
C144 a_11491_6228# a_12158_5867# 0.0894f
C145 a_13592_5423# VDD 0.11685f
C146 a_15304_4605# a_12849_5867# 0.0606f
C147 a_21917_1842# a_22564_1008# 0.02011f
C148 a_13470_1044# a_13444_1008# 0.277f
C149 DELAY_VBIASN a_20723_1842# 0.07937f
C150 a_14851_5182# a_14757_5182# 0.28931f
C151 DELAY_VBIASP a_20593_1842# 0.11287f
C152 a_15837_1842# a_16484_1008# 0.02011f
C153 a_13592_5423# a_13880_5118# 0.43707f
C154 a_16108_289# a_20905_519# 0.2906f
C155 VDD a_26911_2470# 0.01806f
C156 DELAY_VBIASP a_11603_1842# 0.06627f
C157 DELAY_VBIASN a_12797_1842# 0.09992f
C158 a_2019_311# a_15964_289# 0.02413f
C159 VDD a_24197_1842# 0.85848f
C160 a_6326_4590# a_9712_3912# 0.04741f
C161 a_18117_1842# a_17683_1842# 0.6972f
C162 a_1721_331# a_2019_311# 0.18452f
C163 a_25913_1842# a_26043_1842# 0.70845f
C164 a_8237_1842# a_8997_1842# 0.03319f
C165 REF_CLK a_12849_5867# 0.26382f
C166 a_10649_5878# a_10751_5878# 0.47795f
C167 a_15304_4605# VDD 0.72158f
C168 a_21157_1842# a_21044_1008# 0.02055f
C169 VDD a_21917_1842# 0.87825f
C170 DELAY_VBIASP a_18877_1842# 0.04176f
C171 DELAY_VBIASN a_19073_1842# 0.10642f
C172 DELAY_VBIASN a_16510_1044# 0.02115f
C173 a_15077_1842# a_14964_1008# 0.02055f
C174 a_13592_5423# a_14111_5227# 0.34114f
C175 DELAY_VBIASP a_9953_1842# 0.11222f
C176 DELAY_VBIASN a_10083_1842# 0.07254f
C177 a_8808_1044# a_8884_1008# 0.01176f
C178 a_16793_1842# a_17357_1842# 0.0114f
C179 a_1256_289# a_1544_289# 1.25711f
C180 a_21625_1044# a_19550_1044# 0.03208f
C181 a_1721_1395# VDD 0.4533f
C182 a_24957_1842# a_25283_1842# 0.01427f
C183 VDD a_18585_1044# 0.29722f
C184 VDD REF_CLK 2.08015f
C185 a_9946_6305# a_10232_5871# 0.41329f
C186 a_6425_1044# a_4350_1044# 0.03208f
C187 a_20397_1842# a_19550_1044# 0.08038f
C188 a_15964_289# a_15837_1842# 0.02f
C189 VDD a_19203_1842# 0.49737f
C190 a_10430_1044# a_11271_1008# 0.28268f
C191 VDD a_17275_1044# 0.15389f
C192 a_14009_5878# a_14757_6228# 0.01058f
C193 a_13880_6292# a_14111_5878# 0.12701f
C194 MUX_SEL1 MUX_OUT 0.09357f
C195 MUX_SEL2 MUX_SEL4 0.01978f
C196 a_14317_1842# a_13470_1044# 0.08038f
C197 DELAY_VBIASN a_17683_1842# 0.07847f
C198 DELAY_VBIASP a_17553_1842# 0.11284f
C199 a_15304_4605# a_14111_5227# 0.01761f
C200 VDD a_11277_1842# 0.86909f
C201 DELAY_VBIASP a_8237_1842# 0.0414f
C202 DELAY_VBIASN a_8433_1842# 0.0961f
C203 a_7390_1044# a_7364_1008# 0.277f
C204 a_15837_1842# a_16597_1842# 0.06198f
C205 a_7477_1842# a_7673_1842# 0.73897f
C206 a_27048_1044# a_27124_1008# 0.01176f
C207 a_24197_1842# a_24393_1842# 0.77122f
C208 a_5731_289# VDD 0.6143f
C209 a_9547_5942# a_9772_5843# 0.02416f
C210 a_9547_6172# a_9746_5805# 0.02437f
C211 a_18877_1842# a_18871_1008# 0.02354f
C212 a_18004_1008# a_16510_1044# 0.28279f
C213 VDD a_14311_1008# 0.28336f
C214 a_13121_5831# a_15688_5867# 0.17255f
C215 a_12849_5867# a_14851_6228# 0.13392f
C216 DELAY_VBIASP a_15837_1842# 0.04182f
C217 DELAY_VBIASN a_16033_1842# 0.10793f
C218 VDD a_8563_1842# 0.49671f
C219 a_6717_1842# a_7364_1008# 0.02011f
C220 a_15077_1842# a_14643_1842# 0.6972f
C221 a_25630_1044# a_25604_1008# 0.277f
C222 a_21917_1842# a_22113_1842# 0.76914f
C223 a_16108_289# VDD 1.25759f
C224 a_2297_331# VDD 0.46496f
C225 a_6854_5986# a_6126_3816# 0.18536f
C226 a_22590_1044# a_24951_1008# 0.26208f
C227 a_10649_5878# VDD 0.23431f
C228 a_6854_5986# DELAY_OUT_LAST 0.08491f
C229 VDD a_11848_1044# 0.17499f
C230 a_1544_1044# MUX_SEL1 0.1672f
C231 VDD a_14851_6228# 0.25326f
C232 DELAY_VBIASN DELAY_OUT_LAST 3.19293f
C233 a_13121_5831# a_14009_5878# 0.01604f
C234 a_13306_6305# a_13566_5835# 0.75507f
C235 a_12849_5867# a_13592_5871# 0.38817f
C236 a_12907_5186# DLL_RESETN 0.02177f
C237 a_6153_1842# DELAY_VBIASP 0.11222f
C238 a_6283_1842# DELAY_VBIASN 0.07254f
C239 VDD a_8231_1008# 0.28336f
C240 VDD a_16163_1842# 0.4973f
C241 VDD a_20831_2470# 0.01806f
C242 DELAY_VBIASP a_13123_1842# 0.06627f
C243 DELAY_VBIASN a_14317_1842# 0.09974f
C244 a_6717_1842# a_6283_1842# 0.6972f
C245 a_5957_1842# a_5844_1008# 0.02055f
C246 a_4350_1044# a_5191_1008# 0.28268f
C247 a_13753_1842# a_14317_1842# 0.0114f
C248 a_20593_1842# a_20723_1842# 0.70845f
C249 a_26471_1008# VDD 0.28336f
C250 a_22488_1044# a_22590_1044# 0.37183f
C251 a_1544_1044# a_2297_1395# 0.28651f
C252 a_9547_5942# VDD 0.1511f
C253 VDD a_24875_1044# 0.15406f
C254 VDD MUX_SEL0 0.56365f
C255 VDD a_13592_5871# 0.07242f
C256 a_12656_5864# a_12849_5867# 0.33075f
C257 a_12355_5867# a_13306_6305# 0.26489f
C258 a_13019_5831# a_13121_5831# 0.56469f
C259 a_7477_1842# VDD 0.86707f
C260 a_4437_1842# DELAY_VBIASP 0.0414f
C261 MUX_SEL4 a_2019_311# 0.90276f
C262 a_4633_1842# DELAY_VBIASN 0.0961f
C263 VDD a_5768_1044# 0.17499f
C264 a_22351_1842# a_22243_1842# 0.01163f
C265 VDD a_14513_1842# 0.49436f
C266 a_14751_1842# a_14643_1842# 0.01163f
C267 VDD a_14751_2470# 0.01806f
C268 a_6283_1842# a_6391_2470# 0.01697f
C269 a_5393_1842# a_5957_1842# 0.0114f
C270 a_5197_1842# a_4350_1044# 0.08038f
C271 a_23003_1842# a_23111_2470# 0.01697f
C272 a_20968_1044# a_21044_1008# 0.01176f
C273 a_27048_1044# a_26477_1842# 0.10863f
C274 VDD a_21911_1008# 0.2822f
C275 VDD a_12656_5864# 0.26066f
C276 MUX_SEL4 a_11785_519# 0.03255f
C277 a_4763_1842# VDD 0.4973f
C278 DELAY_VBIASN a_26803_1842# 0.08024f
C279 DELAY_VBIASP a_26673_1842# 0.11284f
C280 MUX_SEL2 a_1544_289# 0.07405f
C281 VDD a_26185_1044# 0.30409f
C282 MUX_SEL3 a_1256_289# 1.41161f
C283 a_20831_1842# a_20723_1842# 0.01163f
C284 a_9712_3912# a_13019_5831# 0.03275f
C285 a_13231_1842# a_13123_1842# 0.01163f
C286 VDD a_8671_2470# 0.01806f
C287 a_4763_1842# a_4871_2470# 0.01697f
C288 a_15545_1044# a_15831_1008# 0.01885f
C289 a_4437_1842# a_5197_1842# 0.01669f
C290 a_11277_1842# a_11473_1842# 0.76914f
C291 a_9444_4590# a_6126_3816# 0.03029f
C292 MUX_SEL4 a_10430_1044# 0.24983f
C293 a_15688_5403# a_13121_5831# 0.01441f
C294 a_15108_5325# a_12849_5867# 0.10521f
C295 a_18877_1842# a_19073_1842# 0.76914f
C296 a_18877_1842# a_16510_1044# 0.02479f
C297 a_19550_1044# a_19524_1008# 0.277f
C298 a_21483_1842# a_21591_2470# 0.01697f
C299 VDD a_19448_1044# 0.17274f
C300 a_12797_1842# a_13368_1044# 0.10864f
C301 a_3449_331# REF_CLK 0.01017f
C302 VDD a_27997_1842# 0.76025f
C303 DELAY_VBIASP a_24957_1842# 0.04176f
C304 DELAY_VBIASN a_25153_1842# 0.10332f
C305 a_19311_1842# a_19203_1842# 0.01163f
C306 a_10751_5878# DLL_RESETN 0.45018f
C307 a_14025_1044# a_13470_1044# 0.03209f
C308 a_9444_3912# a_9712_3912# 0.72189f
C309 a_5778_3367# a_5864_3367# 0.07306f
C310 a_9953_1842# a_10083_1842# 0.70845f
C311 a_13132_5420# a_6854_5986# 0.01367f
C312 a_2019_311# a_16510_1044# 0.03139f
C313 a_15108_5325# VDD 0.13728f
C314 a_13306_5105# a_12849_5867# 0.10976f
C315 MUX_SEL4 a_4350_1044# 0.31434f
C316 DELAY_VBIASP a_22677_1842# 0.04176f
C317 DELAY_VBIASN a_22873_1842# 0.10734f
C318 a_19963_1842# a_20071_2470# 0.01697f
C319 a_12797_1842# a_10430_1044# 0.02479f
C320 a_24197_1842# a_22590_1044# 0.05231f
C321 VDD a_25283_1842# 0.49737f
C322 a_9772_5843# DLL_RESETN 0.06592f
C323 a_27237_1842# a_26803_1842# 0.6972f
C324 a_10985_1044# a_11271_1008# 0.01885f
C325 DLL_RESETN a_12943_5867# 0.03616f
C326 MUX_OUT VDD 0.35871f
C327 a_11748_6109# a_12158_5867# 0.10373f
C328 a_13306_5105# VDD 0.79678f
C329 a_15304_4605# a_13121_5831# 0.40921f
C330 VDD a_23003_1842# 0.4973f
C331 DELAY_VBIASN a_21157_1842# 0.09851f
C332 DELAY_VBIASP a_19963_1842# 0.06661f
C333 a_13368_1044# a_13444_1008# 0.01176f
C334 a_18443_1842# a_18551_2470# 0.01697f
C335 a_16108_289# a_17865_519# 0.29564f
C336 a_14111_5227# a_15108_5325# 0.03012f
C337 a_13306_5105# a_13880_5118# 0.31978f
C338 a_10517_1842# a_10404_1008# 0.05157f
C339 VDD a_26151_2470# 0.01806f
C340 DELAY_VBIASN a_12233_1842# 0.0961f
C341 DELAY_VBIASP a_12037_1842# 0.04141f
C342 a_2019_311# a_15765_463# 0.05969f
C343 VDD a_23633_1842# 0.49417f
C344 a_27671_2470# a_27563_1842# 0.01697f
C345 a_5974_5723# a_5778_3367# 2.88221f
C346 a_17553_1842# a_17683_1842# 0.70845f
C347 a_1544_289# a_2019_311# 0.01747f
C348 a_21625_1044# a_21911_1008# 0.01885f
C349 a_13123_1842# a_12797_1842# 0.01427f
C350 a_25913_1842# a_26477_1842# 0.0114f
C351 a_14825_519# a_13470_1044# 0.02058f
C352 a_8237_1842# a_8433_1842# 0.76914f
C353 REF_CLK a_13121_5831# 1.40135f
C354 DLL_RESETN a_12849_5867# 0.3501f
C355 a_10232_5871# a_10751_5878# 0.34102f
C356 a_10649_5878# a_10520_6292# 0.01562f
C357 a_17031_1842# a_16923_1842# 0.01163f
C358 a_6425_1044# a_6711_1008# 0.01885f
C359 a_21483_1842# a_19550_1044# 0.01012f
C360 VDD a_21353_1842# 0.49285f
C361 DELAY_VBIASN a_18443_1842# 0.08024f
C362 DELAY_VBIASP a_18313_1842# 0.11284f
C363 a_14851_6228# a_14757_6228# 0.28931f
C364 a_10328_1044# a_10404_1008# 0.01176f
C365 a_15403_1842# a_13470_1044# 0.01012f
C366 a_13592_5423# a_14009_5084# 0.3749f
C367 a_13306_5105# a_14111_5227# 0.097f
C368 VDD a_12363_1842# 0.4973f
C369 DELAY_VBIASP a_9323_1842# 0.06627f
C370 DELAY_VBIASN a_10517_1842# 0.08375f
C371 a_25630_1044# a_26985_519# 0.02165f
C372 a_26151_2470# a_26043_1842# 0.01697f
C373 a_17683_1842# a_17791_2470# 0.01697f
C374 a_7803_1842# a_7390_1044# 0.01012f
C375 a_20105_1044# a_19550_1044# 0.03209f
C376 a_1544_1044# VDD 0.45079f
C377 a_24957_1842# a_25717_1842# 0.06198f
C378 VDD a_17065_1044# 0.30218f
C379 DELAY_VBIASN a_4157_1313# 0.01202f
C380 VDD DLL_RESETN 2.47079f
C381 a_9946_6305# a_10206_5835# 0.75507f
C382 a_5864_3367# DLL_RESETN 0.1727f
C383 a_9712_3912# REF_CLK 0.06562f
C384 a_4905_1044# a_4350_1044# 0.03209f
C385 a_4157_1313# a_4324_1008# 0.02463f
C386 VDD a_19637_1842# 0.86707f
C387 a_10430_1044# a_11195_1044# 0.39037f
C388 VDD a_16484_1008# 0.28597f
C389 DELAY_VBIASN a_13470_1044# 0.02115f
C390 a_13592_5871# a_14757_6228# 0.43239f
C391 MUX_SEL2 MUX_SEL3 3.21891f
C392 MUX_SEL1 MUX_SEL4 0.03574f
C393 DELAY_VBIASP a_16923_1842# 0.06661f
C394 DELAY_VBIASN a_18117_1842# 0.09851f
C395 a_12907_5420# a_13132_5420# 0.02416f
C396 VDD a_10713_1842# 0.49294f
C397 DELAY_VBIASP a_7673_1842# 0.11222f
C398 DELAY_VBIASN a_7803_1842# 0.07254f
C399 a_7288_1044# a_7364_1008# 0.01176f
C400 a_24631_2470# a_24523_1842# 0.01697f
C401 a_15837_1842# a_16033_1842# 0.76914f
C402 a_16163_1842# a_16271_2470# 0.01697f
C403 a_22677_1842# a_23437_1842# 0.01669f
C404 a_16108_289# a_22590_1044# 0.58202f
C405 a_24197_1842# a_23763_1842# 0.6972f
C406 VDD a_6425_1044# 0.29722f
C407 a_26911_1842# a_26803_1842# 0.01163f
C408 a_9547_5942# a_9746_5805# 0.14994f
C409 a_4437_1842# a_4905_1044# 0.19203f
C410 a_17928_1044# a_16510_1044# 0.38994f
C411 VDD a_14235_1044# 0.15389f
C412 a_12849_5867# a_15108_6109# 0.10225f
C413 a_13306_6305# a_14111_5878# 0.097f
C414 a_13019_5831# a_15688_5867# 0.0195f
C415 a_13121_5831# a_14851_6228# 0.03404f
C416 DELAY_VBIASN a_7390_1044# 0.02115f
C417 DELAY_VBIASP a_15273_1842# 0.11297f
C418 DELAY_VBIASN a_15403_1842# 0.08418f
C419 VDD a_8997_1842# 0.85848f
C420 a_14513_1842# a_14643_1842# 0.70845f
C421 a_14643_1842# a_14751_2470# 0.01697f
C422 a_25528_1044# a_25604_1008# 0.01176f
C423 a_21917_1842# a_21483_1842# 0.6972f
C424 a_15964_289# VDD 0.31312f
C425 a_5974_5723# DLL_RESETN 0.02002f
C426 a_25391_1842# a_25283_1842# 0.01163f
C427 a_1721_331# VDD 0.45259f
C428 a_25630_1044# DELAY_VBIASN 0.02756f
C429 a_22590_1044# a_24875_1044# 0.39036f
C430 a_10232_5871# VDD 0.07206f
C431 a_6854_5986# DELAY_VBIASN 0.15808f
C432 VDD a_11271_1008# 0.28336f
C433 a_1256_1044# MUX_SEL1 1.44243f
C434 VDD a_15108_6109# 0.1349f
C435 a_13121_5831# a_13592_5871# 0.01445f
C436 a_12849_5867# a_13566_5835# 0.27346f
C437 a_13106_5357# DLL_RESETN 0.01263f
C438 a_6717_1842# DELAY_VBIASN 0.09992f
C439 a_18117_1842# a_18004_1008# 0.02055f
C440 a_5523_1842# DELAY_VBIASP 0.06627f
C441 VDD a_8155_1044# 0.15389f
C442 VDD a_16597_1842# 0.86876f
C443 VDD a_20071_2470# 0.01806f
C444 DELAY_VBIASP a_13557_1842# 0.0414f
C445 DELAY_VBIASN a_13753_1842# 0.0961f
C446 a_6153_1842# a_6283_1842# 0.70845f
C447 a_6283_1842# a_4350_1044# 0.01012f
C448 a_4350_1044# a_5115_1044# 0.39037f
C449 a_13123_1842# a_13231_2470# 0.01697f
C450 a_20593_1842# a_21157_1842# 0.0114f
C451 a_23871_1842# a_23763_1842# 0.01163f
C452 a_26395_1044# VDD 0.15389f
C453 a_1256_1044# a_2297_1395# 0.04619f
C454 a_6854_5454# VDD 1.03678f
C455 VDD a_24084_1008# 0.28225f
C456 VDD DELAY_VBIASP 14.6649f
C457 a_5864_3367# a_6854_5454# 0.03661f
C458 VDD a_13566_5835# 0.09466f
C459 a_12355_5867# a_12849_5867# 0.07687f
C460 a_6913_1842# VDD 0.49426f
C461 a_5864_3367# DELAY_VBIASP 0.03252f
C462 MUX_SEL4 a_5705_519# 0.03556f
C463 a_4003_1842# DELAY_VBIASN 0.06486f
C464 MUX_SEL3 a_2019_311# 0.06209f
C465 VDD a_5191_1008# 0.28565f
C466 VDD a_13883_1842# 0.49742f
C467 VDD a_13991_2470# 0.01806f
C468 a_5197_1842# a_5523_1842# 0.01427f
C469 a_12037_1842# a_12797_1842# 0.02912f
C470 a_19637_1842# a_20397_1842# 0.01669f
C471 a_17275_1044# a_17351_1008# 0.01194f
C472 a_25630_1044# a_27237_1842# 0.05253f
C473 a_26471_1008# a_26477_1842# 0.02349f
C474 VDD a_21835_1044# 0.15406f
C475 VDD a_12355_5867# 0.37639f
C476 a_5197_1842# VDD 0.86909f
C477 DELAY_VBIASP a_26043_1842# 0.06661f
C478 DELAY_VBIASN a_27237_1842# 0.10152f
C479 MUX_SEL2 a_1256_289# 0.33134f
C480 VDD a_7911_2470# 0.01806f
C481 a_15545_1044# a_15755_1044# 0.09424f
C482 a_4437_1842# a_4633_1842# 0.73897f
C483 a_11277_1842# a_10843_1842# 0.6972f
C484 a_9444_4590# a_6854_5986# 0.02502f
C485 a_15688_5403# a_13019_5831# 0.1287f
C486 a_14851_5182# a_12849_5867# 0.13376f
C487 a_15108_5325# a_13121_5831# 0.05903f
C488 a_18877_1842# a_18443_1842# 0.6972f
C489 a_15304_4605# a_15688_5867# 0.19136f
C490 a_19448_1044# a_19524_1008# 0.01176f
C491 a_25604_1008# a_24957_1842# 0.02011f
C492 a_5974_5723# a_6854_5454# 0.01757f
C493 VDD a_18871_1008# 0.2822f
C494 a_12797_1842# a_12791_1008# 0.02354f
C495 VDD a_27433_1842# 0.49285f
C496 DELAY_VBIASN a_24523_1842# 0.08024f
C497 DELAY_VBIASP a_24393_1842# 0.11284f
C498 a_5731_289# a_8745_519# 0.28635f
C499 VDD a_7151_2470# 0.01806f
C500 a_9953_1842# a_10517_1842# 0.0114f
C501 a_14851_5182# VDD 0.26676f
C502 a_23003_1842# a_22590_1044# 0.01012f
C503 a_13566_5328# a_12849_5867# 0.26617f
C504 a_13470_1044# a_15831_1008# 0.26208f
C505 a_8997_1842# a_9465_1044# 0.2079f
C506 DELAY_VBIASN a_22243_1842# 0.08024f
C507 DELAY_VBIASP a_22113_1842# 0.11286f
C508 a_18877_1842# a_18117_1842# 0.02912f
C509 a_16923_1842# a_16510_1044# 0.01012f
C510 a_11277_1842# a_11924_1008# 0.02312f
C511 a_2019_311# a_4157_1313# 0.01018f
C512 VDD a_25717_1842# 0.86707f
C513 a_26673_1842# a_26803_1842# 0.70845f
C514 a_10985_1044# a_11195_1044# 0.09424f
C515 a_8997_1842# a_9757_1842# 0.02912f
C516 MUX_SEL4 VDD 2.63176f
C517 REF_CLK a_14009_5878# 0.25847f
C518 a_11748_6109# a_11491_6228# 0.34468f
C519 a_13566_5328# VDD 0.0947f
C520 a_7945_1044# a_8231_1008# 0.01885f
C521 a_15304_4605# a_13019_5831# 0.07025f
C522 a_21917_1842# a_22488_1044# 0.10864f
C523 VDD a_23437_1842# 0.86909f
C524 a_13368_1044# a_13470_1044# 0.37183f
C525 DELAY_VBIASN a_20593_1842# 0.10398f
C526 DELAY_VBIASP a_20397_1842# 0.04176f
C527 a_15837_1842# a_16408_1044# 0.10864f
C528 a_16108_289# a_16851_309# 0.06181f
C529 a_14111_5227# a_14851_5182# 0.26905f
C530 a_10517_1842# a_10430_1044# 0.1088f
C531 VDD a_25391_2470# 0.01806f
C532 DELAY_VBIASP a_11473_1842# 0.11222f
C533 DELAY_VBIASN a_11603_1842# 0.07254f
C534 a_17553_1842# a_18117_1842# 0.0114f
C535 a_6326_4590# a_5778_3367# 0.8779f
C536 a_1256_289# a_2019_311# 0.02904f
C537 a_8997_1842# a_8884_1008# 0.02055f
C538 a_21625_1044# a_21835_1044# 0.09424f
C539 a_13557_1842# a_12797_1842# 0.06198f
C540 a_8237_1842# a_7803_1842# 0.6972f
C541 DLL_RESETN a_13121_5831# 0.04337f
C542 REF_CLK a_13019_5831# 0.35409f
C543 a_7477_1842# a_7945_1044# 0.19203f
C544 a_10232_5871# a_10520_6292# 0.43707f
C545 a_6425_1044# a_6635_1044# 0.09424f
C546 a_21917_1842# a_19550_1044# 0.02479f
C547 VDD a_20723_1842# 0.49671f
C548 a_11848_1044# a_11924_1008# 0.01176f
C549 DELAY_VBIASN a_18877_1842# 0.10687f
C550 a_14851_6228# a_15688_5867# 0.08776f
C551 a_10328_1044# a_10430_1044# 0.37183f
C552 a_15837_1842# a_13470_1044# 0.02479f
C553 a_13306_5105# a_14009_5084# 0.02454f
C554 VDD a_12797_1842# 0.87771f
C555 DELAY_VBIASP a_9757_1842# 0.0414f
C556 DELAY_VBIASN a_9953_1842# 0.0961f
C557 a_7390_1044# a_9751_1008# 0.26208f
C558 a_16597_1842# a_17357_1842# 0.01669f
C559 a_8237_1842# a_7390_1044# 0.08038f
C560 a_1256_1044# VDD 0.475f
C561 a_24957_1842# a_25153_1842# 0.76914f
C562 VDD a_15545_1044# 0.29918f
C563 MUX_SEL0 a_2873_1395# 0.01504f
C564 a_5957_1842# a_6425_1044# 0.2079f
C565 a_4157_1313# a_4350_1044# 0.04624f
C566 a_9712_3912# DLL_RESETN 0.4243f
C567 a_19637_1842# a_19524_1008# 0.05157f
C568 VDD a_19073_1842# 0.49426f
C569 a_10430_1044# a_10404_1008# 0.277f
C570 VDD a_16510_1044# 0.8795f
C571 a_13557_1842# a_13444_1008# 0.05157f
C572 DELAY_VBIASN a_17553_1842# 0.10734f
C573 DELAY_VBIASP a_17357_1842# 0.04176f
C574 a_15304_4605# a_13592_5423# 0.01817f
C575 a_11711_1842# a_11603_1842# 0.01163f
C576 VDD a_10083_1842# 0.49727f
C577 DELAY_VBIASN a_8237_1842# 0.09974f
C578 a_7288_1044# a_7390_1044# 0.37183f
C579 a_15837_1842# a_15403_1842# 0.6972f
C580 a_25630_1044# a_27991_1008# 0.26208f
C581 a_22677_1842# a_22873_1842# 0.73897f
C582 a_23633_1842# a_23763_1842# 0.70845f
C583 VDD a_4905_1044# 0.30126f
C584 a_9547_5942# a_9547_6172# 0.1117f
C585 a_4437_1842# a_4157_1313# 0.01771f
C586 a_24875_1044# a_24951_1008# 0.01194f
C587 a_12158_5867# VDD 0.37862f
C588 VDD a_13444_1008# 0.28633f
C589 DELAY_VBIASN a_10430_1044# 0.02115f
C590 a_12849_5867# a_14111_5878# 0.42174f
C591 a_13306_6305# a_13880_6292# 0.31978f
C592 a_13121_5831# a_15108_6109# 0.03701f
C593 a_13592_5871# a_14009_5878# 0.37583f
C594 a_13019_5831# a_14851_6228# 0.01651f
C595 a_13592_5423# REF_CLK 0.03445f
C596 VDD a_17683_1842# 0.49671f
C597 DELAY_VBIASN a_15837_1842# 0.10875f
C598 DELAY_VBIASP a_14643_1842# 0.06668f
C599 a_7477_1842# a_7043_1842# 0.69698f
C600 a_10191_1842# a_10083_1842# 0.01163f
C601 VDD a_8433_1842# 0.49417f
C602 a_6717_1842# a_7288_1044# 0.10864f
C603 a_5768_1044# a_5844_1008# 0.01176f
C604 a_14513_1842# a_15077_1842# 0.0114f
C605 a_25528_1044# a_25630_1044# 0.37183f
C606 a_21353_1842# a_21483_1842# 0.70845f
C607 a_16108_289# a_19550_1044# 0.58202f
C608 a_15765_463# VDD 0.35368f
C609 a_1544_289# VDD 0.39113f
C610 a_22590_1044# a_24084_1008# 0.28279f
C611 a_23355_1044# a_23431_1008# 0.01194f
C612 a_10206_5835# VDD 0.09392f
C613 VDD a_11195_1044# 0.15389f
C614 VDD a_14111_5878# 0.21331f
C615 DELAY_OUT_LAST a_12849_5867# 0.01791f
C616 a_13121_5831# a_13566_5835# 0.01158f
C617 a_13019_5831# a_13592_5871# 0.04178f
C618 a_15304_4605# REF_CLK 0.01066f
C619 a_6153_1842# DELAY_VBIASN 0.0961f
C620 a_5957_1842# DELAY_VBIASP 0.04141f
C621 VDD a_7364_1008# 0.28633f
C622 DELAY_VBIASN a_4350_1044# 0.02115f
C623 VDD a_16033_1842# 0.49413f
C624 VDD a_19311_2470# 0.01806f
C625 DELAY_VBIASP a_12993_1842# 0.11222f
C626 DELAY_VBIASN a_13123_1842# 0.07254f
C627 a_6153_1842# a_6717_1842# 0.0114f
C628 a_8671_1842# a_8563_1842# 0.01163f
C629 a_6717_1842# a_4350_1044# 0.02479f
C630 a_4350_1044# a_4324_1008# 0.277f
C631 a_13557_1842# a_14317_1842# 0.01669f
C632 a_20397_1842# a_20723_1842# 0.01427f
C633 a_25604_1008# VDD 0.28633f
C634 MUX_SEL4 a_9757_1842# 0.01829f
C635 a_6126_3816# VDD 0.84141f
C636 VDD a_24008_1044# 0.17499f
C637 VDD DELAY_OUT_LAST 0.70591f
C638 a_9712_3912# a_6854_5454# 0.6789f
C639 a_5864_3367# a_6126_3816# 0.23738f
C640 MUX_OUT a_16851_309# 0.45865f
C641 a_12355_5867# a_13121_5831# 0.05795f
C642 a_12656_5864# a_13019_5831# 0.04193f
C643 a_6283_1842# VDD 0.4973f
C644 a_9712_3912# DELAY_VBIASP 0.14197f
C645 a_4437_1842# DELAY_VBIASN 0.08375f
C646 MUX_SEL4 a_3449_331# 0.05166f
C647 VDD a_5115_1044# 0.15389f
C648 VDD a_14317_1842# 0.87229f
C649 a_19637_1842# a_20105_1044# 0.19203f
C650 VDD a_13231_2470# 0.01806f
C651 a_17065_1044# a_17351_1008# 0.01885f
C652 a_5197_1842# a_5957_1842# 0.03319f
C653 a_12037_1842# a_12233_1842# 0.77122f
C654 a_4437_1842# a_4324_1008# 0.05157f
C655 a_19637_1842# a_19833_1842# 0.73897f
C656 a_19550_1044# a_21911_1008# 0.26208f
C657 VDD a_21044_1008# 0.28225f
C658 a_4633_1842# VDD 0.49285f
C659 DELAY_VBIASN a_26673_1842# 0.105f
C660 DELAY_VBIASP a_26477_1842# 0.04181f
C661 a_16108_289# a_21917_1842# 0.0157f
C662 a_4437_1842# a_4003_1842# 0.69698f
C663 a_10713_1842# a_10843_1842# 0.70845f
C664 a_14111_5227# DELAY_OUT_LAST 0.02024f
C665 a_15304_4605# a_14851_6228# 0.12139f
C666 a_14851_5182# a_13121_5831# 0.03337f
C667 a_18313_1842# a_18443_1842# 0.70845f
C668 a_10517_1842# a_10985_1044# 0.19203f
C669 a_19448_1044# a_19550_1044# 0.37183f
C670 a_6326_4590# a_6854_5454# 1.25249f
C671 a_5974_5723# a_6126_3816# 1.74589f
C672 VDD a_18795_1044# 0.15406f
C673 VDD a_26803_1842# 0.49671f
C674 a_15464_3684# VDD 0.52511f
C675 DELAY_VBIASN a_24957_1842# 0.10687f
C676 DELAY_VBIASP a_23763_1842# 0.06661f
C677 a_10649_5878# REF_CLK 0.25484f
C678 a_27997_1842# a_27563_1842# 0.69646f
C679 a_17865_519# a_16510_1044# 0.02165f
C680 a_9757_1842# a_10083_1842# 0.01427f
C681 a_23437_1842# a_22590_1044# 0.08038f
C682 a_13132_5420# a_12849_5867# 0.06758f
C683 DELAY_VBIASP a_21483_1842# 0.06661f
C684 a_13470_1044# a_15755_1044# 0.39036f
C685 DELAY_VBIASN a_22677_1842# 0.0907f
C686 a_18313_1842# a_18117_1842# 0.77122f
C687 a_17928_1044# a_18004_1008# 0.01176f
C688 a_17357_1842# a_16510_1044# 0.08038f
C689 a_11277_1842# a_11848_1044# 0.10863f
C690 a_5731_289# a_16108_289# 0.01334f
C691 VDD a_25153_1842# 0.49426f
C692 a_23145_1044# a_23431_1008# 0.01885f
C693 a_26673_1842# a_27237_1842# 0.0114f
C694 a_12505_1044# a_10430_1044# 0.03208f
C695 a_1721_1395# MUX_SEL0 0.01315f
C696 a_8997_1842# a_9193_1842# 0.77122f
C697 REF_CLK MUX_SEL0 0.14089f
C698 REF_CLK a_13592_5871# 0.11539f
C699 MUX_SEL3 VDD 0.4053f
C700 a_10751_5878# a_11491_6228# 0.26905f
C701 a_13132_5420# VDD 0.23863f
C702 a_7945_1044# a_8155_1044# 0.09424f
C703 a_21917_1842# a_21911_1008# 0.02354f
C704 VDD a_22873_1842# 0.49294f
C705 DELAY_VBIASP a_19833_1842# 0.11284f
C706 DELAY_VBIASN a_19963_1842# 0.08024f
C707 a_15837_1842# a_15831_1008# 0.02354f
C708 a_15964_289# a_16851_309# 0.16757f
C709 VDD a_24631_2470# 0.01806f
C710 DELAY_VBIASN a_12037_1842# 0.09156f
C711 DELAY_VBIASP a_10843_1842# 0.06627f
C712 a_17357_1842# a_17683_1842# 0.01427f
C713 a_9323_1842# a_7390_1044# 0.01012f
C714 a_12993_1842# a_12797_1842# 0.76914f
C715 a_11603_1842# a_11711_2470# 0.01697f
C716 a_25717_1842# a_26477_1842# 0.01669f
C717 a_7673_1842# a_7803_1842# 0.70845f
C718 REF_CLK a_12656_5864# 0.01215f
C719 DLL_RESETN a_13019_5831# 0.01429f
C720 a_20397_1842# a_21044_1008# 0.02312f
C721 a_13557_1842# a_14025_1044# 0.19203f
C722 VDD a_21157_1842# 0.85848f
C723 DELAY_VBIASN a_18313_1842# 0.10734f
C724 a_14317_1842# a_14964_1008# 0.02312f
C725 VDD a_23871_2470# 0.01806f
C726 a_13306_5105# a_13592_5423# 0.41329f
C727 a_15304_4605# a_15108_5325# 0.01986f
C728 a_13566_5328# a_14009_5084# 0.02242f
C729 VDD a_12233_1842# 0.49285f
C730 DELAY_VBIASN a_9323_1842# 0.07254f
C731 DELAY_VBIASP a_9193_1842# 0.11222f
C732 a_7390_1044# a_9675_1044# 0.39036f
C733 a_16597_1842# a_16793_1842# 0.73897f
C734 a_10083_1842# a_10191_2470# 0.01697f
C735 a_24957_1842# a_24523_1842# 0.6972f
C736 a_11785_519# a_10430_1044# 0.02058f
C737 VDD a_14025_1044# 0.30409f
C738 a_9444_3912# DLL_RESETN 0.03031f
C739 a_4157_1313# a_4248_1044# 0.11672f
C740 a_19637_1842# a_19550_1044# 0.1088f
C741 VDD a_18443_1842# 0.4973f
C742 a_2019_311# a_4350_1044# 0.02042f
C743 VDD a_16408_1044# 0.17274f
C744 a_23763_1842# a_23437_1842# 0.01427f
C745 a_13592_5871# a_14851_6228# 0.01529f
C746 a_13557_1842# a_13470_1044# 0.1088f
C747 DELAY_VBIASP a_16793_1842# 0.11284f
C748 DELAY_VBIASN a_16923_1842# 0.08024f
C749 a_13106_5357# a_13132_5420# 0.1657f
C750 a_12907_5186# a_12907_5420# 0.1117f
C751 VDD a_10517_1842# 0.86707f
C752 DELAY_VBIASN a_7673_1842# 0.0961f
C753 a_15273_1842# a_15403_1842# 0.70845f
C754 a_25630_1044# a_27915_1044# 0.39036f
C755 a_22677_1842# a_22243_1842# 0.69698f
C756 a_8563_1842# a_8671_2470# 0.01697f
C757 a_23633_1842# a_24197_1842# 0.0114f
C758 a_26985_519# VDD 0.29292f
C759 VDD a_4157_1313# 0.48935f
C760 a_11491_6228# VDD 0.16753f
C761 VDD a_13470_1044# 0.87936f
C762 a_13566_5835# a_14009_5878# 0.02242f
C763 a_13121_5831# a_14111_5878# 0.0235f
C764 a_13306_5105# REF_CLK 0.06166f
C765 a_7043_1842# DELAY_VBIASP 0.06627f
C766 VDD a_10328_1044# 0.17274f
C767 VDD a_18117_1842# 0.85848f
C768 DELAY_VBIASP a_15077_1842# 0.04184f
C769 DELAY_VBIASN a_15273_1842# 0.10803f
C770 a_6913_1842# a_7043_1842# 0.70845f
C771 VDD a_7803_1842# 0.4973f
C772 a_6717_1842# a_6711_1008# 0.02354f
C773 a_14317_1842# a_14643_1842# 0.01427f
C774 a_21353_1842# a_21917_1842# 0.0114f
C775 a_14825_519# VDD 0.29292f
C776 a_1256_289# VDD 0.40292f
C777 a_22590_1044# a_24008_1044# 0.38994f
C778 a_6854_5986# a_12849_5867# 0.06216f
C779 a_26471_1008# a_26185_1044# 0.01885f
C780 VDD a_10404_1008# 0.28633f
C781 DELAY_OUT_LAST a_13121_5831# 0.13178f
C782 DELAY_VBIASP a_13019_5831# 0.02377f
C783 a_15304_4605# DLL_RESETN 0.03137f
C784 MUX_SEL4 a_8745_519# 0.04472f
C785 a_5393_1842# DELAY_VBIASP 0.11222f
C786 a_5523_1842# DELAY_VBIASN 0.07254f
C787 MUX_OUT a_5731_289# 1.04829f
C788 VDD a_7390_1044# 0.8686f
C789 a_21157_1842# a_21625_1044# 0.2079f
C790 VDD a_15403_1842# 0.4973f
C791 VDD a_18551_2470# 0.01806f
C792 DELAY_VBIASN a_13557_1842# 0.08375f
C793 a_5197_1842# a_5844_1008# 0.02312f
C794 a_4248_1044# a_4324_1008# 0.01176f
C795 a_13557_1842# a_13753_1842# 0.73897f
C796 a_20397_1842# a_21157_1842# 0.03319f
C797 a_25630_1044# VDD 0.89531f
C798 a_1544_1044# a_1721_1395# 0.38063f
C799 a_6854_5986# VDD 1.20794f
C800 VDD a_23431_1008# 0.28336f
C801 VDD DELAY_VBIASN 1.49209f
C802 DLL_RESETN REF_CLK 10.7961f
C803 a_9444_3912# a_6854_5454# 0.8486f
C804 MUX_SEL1 a_3449_1395# 0.29404f
C805 MUX_OUT a_16108_289# 0.24265f
C806 a_12355_5867# a_13019_5831# 0.3846f
C807 a_6717_1842# VDD 0.87726f
C808 DELAY_VBIASP a_27563_1842# 0.06663f
C809 MUX_SEL3 a_3449_331# 0.28429f
C810 MUX_SEL4 a_2873_331# 0.04916f
C811 MUX_OUT a_2297_331# 0.01179f
C812 VDD a_4324_1008# 0.28597f
C813 VDD a_13753_1842# 0.49349f
C814 VDD a_12471_2470# 0.01806f
C815 a_5197_1842# a_5393_1842# 0.76914f
C816 a_17065_1044# a_17275_1044# 0.09424f
C817 a_12037_1842# a_11603_1842# 0.6972f
C818 a_4437_1842# a_4350_1044# 0.1088f
C819 a_7043_1842# a_7151_2470# 0.01697f
C820 a_19637_1842# a_19203_1842# 0.69698f
C821 a_16510_1044# a_17351_1008# 0.28268f
C822 a_12037_1842# a_12505_1044# 0.2079f
C823 a_19550_1044# a_21835_1044# 0.39036f
C824 a_25630_1044# a_26043_1842# 0.01012f
C825 VDD a_20968_1044# 0.17499f
C826 VDD a_6391_2470# 0.01806f
C827 a_4003_1842# VDD 0.61559f
C828 DELAY_VBIASN a_26043_1842# 0.08024f
C829 DELAY_VBIASP a_25913_1842# 0.11284f
C830 a_7043_1842# a_7151_1842# 0.01163f
C831 a_15464_3684# a_13121_5831# 0.33256f
C832 a_10713_1842# a_11277_1842# 0.0114f
C833 a_14009_5084# DELAY_OUT_LAST 0.25594f
C834 a_15304_4605# a_15108_6109# 0.17528f
C835 a_18313_1842# a_18877_1842# 0.0114f
C836 a_15755_1044# a_15831_1008# 0.01194f
C837 a_5974_5723# a_6854_5986# 0.029f
C838 a_25528_1044# a_24957_1842# 0.10864f
C839 a_6326_4590# a_6126_3816# 2.84014f
C840 a_1256_1044# a_2873_1395# 0.28892f
C841 VDD a_18004_1008# 0.28225f
C842 a_24197_1842# a_24084_1008# 0.02055f
C843 VDD a_27237_1842# 0.85969f
C844 DELAY_VBIASP a_24197_1842# 0.04177f
C845 DELAY_VBIASN a_24393_1842# 0.10734f
C846 a_5523_1842# a_5631_1842# 0.01163f
C847 a_10649_5878# DLL_RESETN 0.05713f
C848 a_10232_5871# REF_CLK 0.08086f
C849 a_27433_1842# a_27563_1842# 0.70845f
C850 a_16851_309# a_16510_1044# 0.02131f
C851 a_15464_3684# a_9712_3912# 0.01237f
C852 a_12505_1044# a_12791_1008# 0.01885f
C853 a_9757_1842# a_10517_1842# 0.06198f
C854 a_9444_4590# VDD 0.01557f
C855 a_13470_1044# a_14964_1008# 0.28279f
C856 a_14235_1044# a_14311_1008# 0.01194f
C857 a_9444_4590# a_5864_3367# 0.06832f
C858 DELAY_VBIASN a_22113_1842# 0.10263f
C859 DELAY_VBIASP a_21917_1842# 0.04176f
C860 a_14851_5182# a_15688_5403# 0.08776f
C861 a_12037_1842# a_10430_1044# 0.05231f
C862 a_11277_1842# a_11271_1008# 0.02349f
C863 a_5731_289# a_15964_289# 0.2778f
C864 VDD a_24523_1842# 0.4973f
C865 a_4003_1842# a_4111_1842# 0.01163f
C866 a_5705_519# a_2019_311# 0.13872f
C867 a_9757_1842# a_10328_1044# 0.10864f
C868 a_23145_1044# a_23355_1044# 0.09424f
C869 a_10985_1044# a_10430_1044# 0.03209f
C870 a_26477_1842# a_26803_1842# 0.01427f
C871 a_1544_1044# MUX_SEL0 0.07603f
C872 a_8997_1842# a_8563_1842# 0.6972f
C873 REF_CLK DELAY_VBIASP 2.13371f
C874 REF_CLK a_13566_5835# 0.01538f
C875 MUX_SEL2 VDD 0.50938f
C876 a_10649_5878# a_11397_6228# 0.01058f
C877 a_10751_5878# a_11748_6109# 0.03061f
C878 a_12907_5420# VDD 0.07751f
C879 a_9465_1044# a_7390_1044# 0.03208f
C880 a_15077_1842# a_15545_1044# 0.2079f
C881 VDD a_22243_1842# 0.49737f
C882 DELAY_VBIASN a_20397_1842# 0.10669f
C883 DELAY_VBIASP a_19203_1842# 0.06661f
C884 a_15964_289# a_16108_289# 0.42202f
C885 a_13592_5423# a_14851_5182# 0.01529f
C886 a_9757_1842# a_10404_1008# 0.02011f
C887 DELAY_VBIASN a_11473_1842# 0.0961f
C888 DELAY_VBIASP a_11277_1842# 0.0414f
C889 a_9675_1044# a_9751_1008# 0.01194f
C890 a_17357_1842# a_18117_1842# 0.03319f
C891 a_9757_1842# a_7390_1044# 0.02479f
C892 a_25717_1842# a_25913_1842# 0.73897f
C893 VDD a_24665_1044# 0.29722f
C894 a_7673_1842# a_8237_1842# 0.0114f
C895 REF_CLK a_12355_5867# 1.0042f
C896 DLL_RESETN a_12656_5864# 0.11782f
C897 a_10232_5871# a_10649_5878# 0.37583f
C898 a_9946_6305# a_10751_5878# 0.097f
C899 a_20397_1842# a_20968_1044# 0.10863f
C900 VDD a_20593_1842# 0.49417f
C901 a_10430_1044# a_12791_1008# 0.26208f
C902 a_15108_6109# a_14851_6228# 0.29858f
C903 a_14317_1842# a_14888_1044# 0.10863f
C904 a_15304_4605# a_14851_5182# 0.05156f
C905 a_13566_5328# a_13592_5423# 0.36952f
C906 VDD a_11603_1842# 0.49671f
C907 DELAY_VBIASN a_9757_1842# 0.09992f
C908 DELAY_VBIASP a_8563_1842# 0.06627f
C909 a_8155_1044# a_8231_1008# 0.01194f
C910 a_7390_1044# a_8884_1008# 0.28279f
C911 a_16597_1842# a_16163_1842# 0.69698f
C912 a_27915_1044# a_27991_1008# 0.01194f
C913 a_18585_1044# a_18871_1008# 0.01885f
C914 a_24393_1842# a_24523_1842# 0.70845f
C915 VDD a_12505_1044# 0.29722f
C916 a_9772_5843# a_9946_6305# 0.27179f
C917 a_5778_3367# DLL_RESETN 0.01215f
C918 VDD a_18877_1842# 0.87825f
C919 a_5705_519# a_4350_1044# 0.02005f
C920 VDD a_15831_1008# 0.2816f
C921 a_24197_1842# a_23437_1842# 0.03319f
C922 a_14009_5878# a_14111_5878# 0.47795f
C923 DELAY_VBIASP a_16163_1842# 0.06661f
C924 DELAY_VBIASN a_17357_1842# 0.10669f
C925 a_13106_5357# a_12907_5420# 0.14994f
C926 VDD a_9953_1842# 0.49426f
C927 a_15273_1842# a_15837_1842# 0.0114f
C928 a_25630_1044# a_27124_1008# 0.28279f
C929 a_26395_1044# a_26471_1008# 0.01194f
C930 a_22113_1842# a_22243_1842# 0.70845f
C931 VDD a_3449_1395# 0.46731f
C932 a_23945_519# VDD 0.29292f
C933 a_2019_311# VDD 1.43004f
C934 a_11748_6109# VDD 0.16819f
C935 VDD a_13368_1044# 0.17274f
C936 a_2297_1395# MUX_SEL1 0.01995f
C937 a_1544_1044# MUX_OUT 0.04258f
C938 MUX_SEL4 REF_CLK 0.0663f
C939 a_13566_5835# a_13592_5871# 0.36952f
C940 a_13566_5328# REF_CLK 0.01093f
C941 a_7477_1842# DELAY_VBIASP 0.0414f
C942 VDD a_9751_1008# 0.2822f
C943 VDD a_17553_1842# 0.49417f
C944 a_22677_1842# a_23145_1044# 0.19203f
C945 DELAY_VBIASP a_14513_1842# 0.12091f
C946 DELAY_VBIASN a_14643_1842# 0.08431f
C947 a_6913_1842# a_7477_1842# 0.0114f
C948 VDD a_8237_1842# 0.86909f
C949 a_4350_1044# a_6711_1008# 0.26208f
C950 a_23871_2470# a_23763_1842# 0.01697f
C951 a_14317_1842# a_15077_1842# 0.03319f
C952 a_11785_519# VDD 0.29292f
C953 a_27991_1008# VDD 0.28201f
C954 a_22590_1044# a_23431_1008# 0.28268f
C955 a_9946_6305# VDD 0.77198f
C956 a_6854_5986# a_13121_5831# 0.10056f
C957 a_26395_1044# a_26185_1044# 0.09424f
C958 DELAY_VBIASN a_22590_1044# 0.02115f
C959 VDD a_10430_1044# 0.88416f
C960 DELAY_OUT_LAST a_13019_5831# 0.08017f
C961 a_12849_5867# a_13306_6305# 0.12097f
C962 a_17357_1842# a_18004_1008# 0.02312f
C963 MUX_SEL4 a_5731_289# 4.60702f
C964 a_5957_1842# DELAY_VBIASN 0.09156f
C965 a_4763_1842# DELAY_VBIASP 0.06627f
C966 a_23111_1842# a_23003_1842# 0.01163f
C967 VDD a_7288_1044# 0.17274f
C968 VDD a_15837_1842# 0.87963f
C969 VDD a_17791_2470# 0.01806f
C970 a_15511_1842# a_15403_1842# 0.01163f
C971 DELAY_VBIASN a_12993_1842# 0.0961f
C972 a_5957_1842# a_6717_1842# 0.02912f
C973 a_5197_1842# a_5768_1044# 0.10863f
C974 a_4248_1044# a_4350_1044# 0.37183f
C975 a_13557_1842# a_13123_1842# 0.69698f
C976 a_20397_1842# a_20593_1842# 0.76914f
C977 a_25528_1044# VDD 0.17274f
C978 a_21835_1044# a_21911_1008# 0.01194f
C979 a_1256_1044# a_1721_1395# 0.13421f
C980 a_27124_1008# a_27237_1842# 0.02055f
C981 VDD a_23355_1044# 0.15389f
C982 a_5778_3367# a_6854_5454# 0.02695f
C983 a_9712_3912# a_6854_5986# 0.83268f
C984 a_9444_3912# a_6126_3816# 0.25721f
C985 VDD a_13306_6305# 0.77573f
C986 MUX_SEL4 a_16108_289# 0.1283f
C987 MUX_OUT a_15964_289# 0.01307f
C988 a_12355_5867# a_12656_5864# 0.03277f
C989 a_6153_1842# VDD 0.49285f
C990 DELAY_VBIASP a_27997_1842# 0.04038f
C991 MUX_SEL4 a_2297_331# 0.04338f
C992 MUX_SEL2 a_3449_331# 0.10741f
C993 MUX_SEL3 a_2873_331# 0.12606f
C994 a_9712_3912# DELAY_VBIASN 0.22281f
C995 VDD a_4350_1044# 0.87635f
C996 a_21591_1842# a_21483_1842# 0.01163f
C997 VDD a_13123_1842# 0.49727f
C998 VDD a_11711_2470# 0.01806f
C999 a_13991_1842# a_13883_1842# 0.01163f
C1000 a_18585_1044# a_16510_1044# 0.03208f
C1001 a_5523_1842# a_5631_2470# 0.01697f
C1002 a_5197_1842# a_4763_1842# 0.6972f
C1003 a_11473_1842# a_11603_1842# 0.70845f
C1004 a_15688_5403# DELAY_OUT_LAST 0.01699f
C1005 a_19073_1842# a_19203_1842# 0.70845f
C1006 a_16510_1044# a_17275_1044# 0.39037f
C1007 a_22243_1842# a_22351_2470# 0.01697f
C1008 a_19550_1044# a_21044_1008# 0.28279f
C1009 a_20315_1044# a_20391_1008# 0.01194f
C1010 a_25630_1044# a_26477_1842# 0.08038f
C1011 VDD a_20391_1008# 0.28336f
C1012 VDD a_5631_2470# 0.01806f
C1013 a_4437_1842# VDD 0.86998f
C1014 DELAY_VBIASN a_26477_1842# 0.1083f
C1015 DELAY_VBIASP a_25283_1842# 0.06661f
C1016 a_15464_3684# a_13019_5831# 0.59875f
C1017 a_20071_1842# a_19963_1842# 0.01163f
C1018 a_12158_5867# REF_CLK 0.01309f
C1019 a_4003_1842# a_4111_2470# 0.01697f
C1020 a_13592_5423# DELAY_OUT_LAST 0.08062f
C1021 a_15304_4605# a_14111_5878# 0.01811f
C1022 DELAY_VBIASP a_23003_1842# 0.06661f
C1023 a_20723_1842# a_20831_2470# 0.01697f
C1024 a_6326_4590# a_6854_5986# 1.31745f
C1025 VDD a_17928_1044# 0.17499f
C1026 a_24523_1842# a_22590_1044# 0.01012f
C1027 VDD a_26673_1842# 0.49417f
C1028 DELAY_VBIASN a_23763_1842# 0.08024f
C1029 DELAY_VBIASP a_23633_1842# 0.11286f
C1030 a_18551_1842# a_18443_1842# 0.01163f
C1031 a_10232_5871# DLL_RESETN 0.39088f
C1032 a_27433_1842# a_27997_1842# 0.0114f
C1033 a_12505_1044# a_12715_1044# 0.09424f
C1034 a_16108_289# a_16510_1044# 0.56108f
C1035 a_9757_1842# a_9953_1842# 0.76914f
C1036 a_25717_1842# a_26185_1044# 0.19203f
C1037 REF_CLK a_14111_5878# 0.02263f
C1038 a_9465_1044# a_9751_1008# 0.01885f
C1039 a_15304_4605# DELAY_OUT_LAST 0.05582f
C1040 a_22677_1842# a_22564_1008# 0.05157f
C1041 a_16597_1842# a_17065_1044# 0.19203f
C1042 a_15688_5403# a_15464_3684# 0.1999f
C1043 DELAY_VBIASN a_21483_1842# 0.08024f
C1044 a_13470_1044# a_14888_1044# 0.38994f
C1045 DELAY_VBIASP a_21353_1842# 0.11284f
C1046 a_9444_4590# a_9712_3912# 0.39071f
C1047 a_19203_1842# a_19311_2470# 0.01697f
C1048 a_16597_1842# a_16484_1008# 0.05157f
C1049 a_14851_5182# a_15108_5325# 0.29858f
C1050 DELAY_VBIASP a_12363_1842# 0.06627f
C1051 a_5731_289# a_15765_463# 0.23301f
C1052 a_2019_311# a_17865_519# 0.13959f
C1053 VDD a_24957_1842# 0.87825f
C1054 a_9757_1842# a_9751_1008# 0.02354f
C1055 a_3449_331# a_2019_311# 0.01176f
C1056 a_6854_5454# DLL_RESETN 0.03626f
C1057 a_24665_1044# a_22590_1044# 0.03208f
C1058 a_26477_1842# a_27237_1842# 0.03319f
C1059 a_1256_1044# MUX_SEL0 0.3314f
C1060 a_8433_1842# a_8563_1842# 0.70845f
C1061 DLL_RESETN DELAY_VBIASP 0.07017f
C1062 MUX_SEL1 VDD 0.50267f
C1063 a_10232_5871# a_11397_6228# 0.43239f
C1064 a_12907_5186# VDD 0.06323f
C1065 a_17791_1842# a_17683_1842# 0.01163f
C1066 a_7945_1044# a_7390_1044# 0.03209f
C1067 VDD a_22677_1842# 0.86707f
C1068 a_8745_519# a_7390_1044# 0.01756f
C1069 DELAY_VBIASP a_19637_1842# 0.04176f
C1070 a_14009_5084# a_14757_5182# 0.01058f
C1071 DELAY_VBIASN a_19833_1842# 0.10734f
C1072 a_15765_463# a_16108_289# 0.42004f
C1073 DELAY_VBIASN a_10843_1842# 0.07254f
C1074 DELAY_VBIASP a_10713_1842# 0.11222f
C1075 a_26911_2470# a_26803_1842# 0.01697f
C1076 a_17357_1842# a_17553_1842# 0.76914f
C1077 a_8237_1842# a_8884_1008# 0.02312f
C1078 a_1544_289# a_2297_331# 0.27303f
C1079 a_1256_289# a_2873_331# 0.27926f
C1080 a_2297_1395# VDD 0.46536f
C1081 a_25717_1842# a_25283_1842# 0.69698f
C1082 VDD a_23145_1044# 0.30409f
C1083 DLL_RESETN a_12355_5867# 0.04879f
C1084 a_10206_5835# a_10649_5878# 0.02242f
C1085 a_9946_6305# a_10520_6292# 0.31978f
C1086 a_6326_4590# a_9444_4590# 0.01269f
C1087 a_16271_1842# a_16163_1842# 0.01163f
C1088 a_21157_1842# a_19550_1044# 0.05231f
C1089 a_20397_1842# a_20391_1008# 0.02349f
C1090 VDD a_19963_1842# 0.4973f
C1091 a_10430_1044# a_12715_1044# 0.39036f
C1092 a_14111_5878# a_14851_6228# 0.26905f
C1093 MUX_SEL4 MUX_OUT 0.91933f
C1094 a_15077_1842# a_13470_1044# 0.05231f
C1095 a_14317_1842# a_14311_1008# 0.02349f
C1096 a_13566_5328# a_13306_5105# 0.75507f
C1097 VDD a_12037_1842# 0.85848f
C1098 DELAY_VBIASN a_9193_1842# 0.0961f
C1099 DELAY_VBIASP a_8997_1842# 0.04141f
C1100 a_7390_1044# a_8808_1044# 0.38994f
C1101 a_25391_2470# a_25283_1842# 0.01697f
C1102 a_16923_1842# a_17031_2470# 0.01697f
C1103 a_16033_1842# a_16163_1842# 0.70845f
C1104 a_23437_1842# a_23003_1842# 0.6972f
C1105 a_18585_1044# a_18795_1044# 0.09424f
C1106 a_23945_519# a_22590_1044# 0.02165f
C1107 a_24393_1842# a_24957_1842# 0.0114f
C1108 VDD a_10985_1044# 0.30409f
C1109 a_27671_1842# a_27563_1842# 0.01163f
C1110 a_18877_1842# a_19524_1008# 0.02011f
C1111 VDD a_18313_1842# 0.49285f
C1112 VDD a_15755_1044# 0.15389f
C1113 a_23633_1842# a_23437_1842# 0.76914f
C1114 a_14009_5878# a_13880_6292# 0.01562f
C1115 a_13592_5871# a_14111_5878# 0.34102f
C1116 DELAY_VBIASN a_16793_1842# 0.10734f
C1117 DELAY_VBIASP a_16597_1842# 0.04176f
C1118 a_13106_5357# a_12907_5186# 0.02437f
C1119 VDD a_9323_1842# 0.4973f
C1120 a_7477_1842# a_7364_1008# 0.05157f
C1121 a_15403_1842# a_15511_2470# 0.01697f
C1122 a_25630_1044# a_27048_1044# 0.38994f
C1123 a_22113_1842# a_22677_1842# 0.0114f
C1124 a_20905_519# VDD 0.29292f
C1125 a_26151_1842# a_26043_1842# 0.01163f
C1126 a_5705_519# VDD 0.29556f
C1127 a_10751_5878# VDD 0.20377f
C1128 VDD a_12791_1008# 0.2822f
C1129 a_1256_1044# MUX_OUT 0.02466f
C1130 a_1544_1044# MUX_SEL4 0.03407f
C1131 a_12849_5867# a_12943_5867# 0.16706f
C1132 a_13132_5420# REF_CLK 0.02025f
C1133 a_6913_1842# DELAY_VBIASP 0.11222f
C1134 a_7043_1842# DELAY_VBIASN 0.07254f
C1135 VDD a_9675_1044# 0.15406f
C1136 VDD a_16923_1842# 0.4973f
C1137 VDD a_23111_2470# 0.01806f
C1138 DELAY_VBIASP a_13883_1842# 0.06627f
C1139 DELAY_VBIASN a_15077_1842# 0.10039f
C1140 a_6717_1842# a_7043_1842# 0.01427f
C1141 VDD a_7673_1842# 0.49294f
C1142 a_4350_1044# a_6635_1044# 0.39036f
C1143 a_13883_1842# a_13991_2470# 0.01697f
C1144 a_14317_1842# a_14513_1842# 0.76914f
C1145 a_21157_1842# a_21917_1842# 0.02912f
C1146 a_24631_1842# a_24523_1842# 0.01163f
C1147 a_27915_1044# VDD 0.15389f
C1148 a_22590_1044# a_23355_1044# 0.39037f
C1149 a_9772_5843# VDD 0.24701f
C1150 a_25630_1044# a_27705_1044# 0.03208f
C1151 VDD a_12943_5867# 0.29479f
C1152 DELAY_VBIASN a_13019_5831# 1.23663f
C1153 a_13121_5831# a_13306_6305# 0.01008f
C1154 a_13019_5831# a_13045_6215# 0.01249f
C1155 a_5197_1842# DELAY_VBIASP 0.0414f
C1156 a_17357_1842# a_17928_1044# 0.10863f
C1157 a_5393_1842# DELAY_VBIASN 0.0961f
C1158 VDD a_6711_1008# 0.2822f
C1159 VDD a_15273_1842# 0.49298f
C1160 VDD a_17031_2470# 0.01806f
C1161 a_5957_1842# a_6153_1842# 0.77122f
C1162 a_12797_1842# a_12363_1842# 0.6972f
C1163 a_5957_1842# a_4350_1044# 0.05231f
C1164 a_5197_1842# a_5191_1008# 0.02349f
C1165 a_12993_1842# a_13123_1842# 0.70845f
C1166 a_20397_1842# a_19963_1842# 0.6972f
C1167 DLL_RESETN a_12797_1842# 0.0106f
C1168 a_1256_1044# a_1544_1044# 1.26509f
C1169 a_25630_1044# a_27563_1842# 0.01024f
C1170 VDD a_22564_1008# 0.28633f
C1171 DELAY_VBIASN a_19550_1044# 0.02115f
C1172 a_5778_3367# a_6126_3816# 1.6143f
C1173 VDD a_12849_5867# 2.56972f
C1174 MUX_SEL4 a_15964_289# 0.5544f
C1175 a_5523_1842# VDD 0.49671f
C1176 DELAY_VBIASP a_27433_1842# 0.11284f
C1177 DELAY_VBIASN a_27563_1842# 0.08029f
C1178 DELAY_OUT_LAST a_27997_1842# 0.70957f
C1179 MUX_OUT a_1544_289# 0.69943f
C1180 MUX_SEL3 a_2297_331# 0.01595f
C1181 MUX_SEL2 a_2873_331# 0.01422f
C1182 MUX_SEL4 a_1721_331# 0.05813f
C1183 VDD a_4248_1044# 0.17587f
C1184 VDD a_13557_1842# 0.86707f
C1185 VDD a_10951_2470# 0.01806f
C1186 a_4633_1842# a_4763_1842# 0.70845f
C1187 a_17065_1044# a_16510_1044# 0.03209f
C1188 a_11473_1842# a_12037_1842# 0.0114f
C1189 a_15108_5325# DELAY_OUT_LAST 0.01399f
C1190 a_19073_1842# a_19637_1842# 0.0114f
C1191 a_16510_1044# a_16484_1008# 0.277f
C1192 a_19550_1044# a_20968_1044# 0.38994f
C1193 VDD a_20315_1044# 0.15389f
C1194 REF_CLK a_4157_1313# 0.50643f
C1195 VDD a_4871_2470# 0.01806f
C1196 a_5864_3367# VDD 0.13532f
C1197 DELAY_VBIASN a_25913_1842# 0.10734f
C1198 DELAY_VBIASP a_25717_1842# 0.04176f
C1199 a_12158_5867# DLL_RESETN 0.02442f
C1200 a_11491_6228# REF_CLK 0.01827f
C1201 a_14025_1044# a_14311_1008# 0.01885f
C1202 a_10517_1842# a_11277_1842# 0.01669f
C1203 a_27237_1842# a_27705_1044# 0.2079f
C1204 a_13592_5423# a_6854_5986# 0.01958f
C1205 a_13880_5118# VDD 0.02994f
C1206 a_18117_1842# a_18585_1044# 0.2079f
C1207 a_14111_5227# a_12849_5867# 0.42064f
C1208 a_23437_1842# a_24084_1008# 0.02312f
C1209 DELAY_VBIASP a_23437_1842# 0.04176f
C1210 a_24957_1842# a_22590_1044# 0.02479f
C1211 VDD a_26043_1842# 0.4973f
C1212 DELAY_VBIASN a_24197_1842# 0.09851f
C1213 a_24665_1044# a_24951_1008# 0.01885f
C1214 a_10206_5835# DLL_RESETN 0.27343f
C1215 a_15964_289# a_16510_1044# 0.05416f
C1216 a_9757_1842# a_9323_1842# 0.6972f
C1217 a_15304_4605# a_6854_5986# 0.08165f
C1218 a_5731_289# a_13470_1044# 0.41365f
C1219 a_14111_5227# VDD 0.33926f
C1220 a_9465_1044# a_9675_1044# 0.09424f
C1221 a_15304_4605# DELAY_VBIASN 0.07802f
C1222 a_22677_1842# a_22590_1044# 0.1088f
C1223 DELAY_VBIASN a_21917_1842# 0.10687f
C1224 a_9444_4590# a_9444_3912# 2.20289f
C1225 a_13470_1044# a_14311_1008# 0.28268f
C1226 a_15108_5325# a_15464_3684# 0.12158f
C1227 DELAY_VBIASP a_20723_1842# 0.06661f
C1228 a_16597_1842# a_16510_1044# 0.1088f
C1229 a_14111_5227# a_13880_5118# 0.12701f
C1230 a_16108_289# a_26985_519# 0.2906f
C1231 a_10843_1842# a_10430_1044# 0.01012f
C1232 a_5974_5723# VDD 0.91576f
C1233 DELAY_VBIASP a_12797_1842# 0.0414f
C1234 a_2019_311# a_16851_309# 0.01299f
C1235 a_5731_289# a_14825_519# 0.28056f
C1236 VDD a_24393_1842# 0.49285f
C1237 a_5974_5723# a_5864_3367# 0.01697f
C1238 a_6854_5986# REF_CLK 0.05061f
C1239 a_23145_1044# a_22590_1044# 0.03209f
C1240 a_6126_3816# DLL_RESETN 0.06398f
C1241 a_26477_1842# a_26673_1842# 0.76914f
C1242 a_8433_1842# a_8997_1842# 0.0114f
C1243 REF_CLK DELAY_VBIASN 0.07156f
C1244 a_10520_6292# a_10751_5878# 0.12701f
C1245 a_13106_5357# VDD 0.09228f
C1246 VDD a_22113_1842# 0.49426f
C1247 DELAY_VBIASN a_19203_1842# 0.07852f
C1248 a_5731_289# a_7390_1044# 0.41331f
C1249 a_12715_1044# a_12791_1008# 0.01194f
C1250 a_13592_5423# a_14757_5182# 0.43239f
C1251 DELAY_VBIASP a_19073_1842# 0.11286f
C1252 a_15765_463# a_15964_289# 0.061f
C1253 DELAY_VBIASN a_11277_1842# 0.09974f
C1254 DELAY_VBIASP a_10083_1842# 0.06627f
C1255 a_17357_1842# a_16923_1842# 0.6972f
C1256 a_1256_289# a_2297_331# 0.04261f
C1257 a_1544_289# a_1721_331# 0.36963f
C1258 a_8237_1842# a_8808_1044# 0.10863f
C1259 a_20105_1044# a_20391_1008# 0.01885f
C1260 a_25153_1842# a_25283_1842# 0.70845f
C1261 VDD a_21625_1044# 0.29722f
C1262 a_10206_5835# a_10232_5871# 0.36952f
C1263 a_4905_1044# a_5191_1008# 0.01885f
C1264 a_4003_1842# REF_CLK 0.55467f
C1265 VDD a_20397_1842# 0.86909f
C1266 a_15304_4605# a_14757_5182# 0.02225f
C1267 a_11195_1044# a_11271_1008# 0.01194f
C1268 a_10430_1044# a_11924_1008# 0.28279f
C1269 a_14111_5878# a_15108_6109# 0.03093f
C1270 MUX_SEL3 MUX_OUT 0.79533f
C1271 DELAY_VBIASP a_17683_1842# 0.06661f
C1272 a_13132_5420# a_13306_5105# 0.27179f
C1273 VDD a_11473_1842# 0.49417f
C1274 a_12471_1842# a_12363_1842# 0.01163f
C1275 DELAY_VBIASP a_8433_1842# 0.11222f
C1276 DELAY_VBIASN a_8563_1842# 0.07254f
C1277 a_25630_1044# a_16108_289# 0.55833f
C1278 a_7390_1044# a_8231_1008# 0.28268f
C1279 a_16033_1842# a_16597_1842# 0.0114f
C1280 a_22873_1842# a_23003_1842# 0.70845f
C1281 VDD a_9465_1044# 0.29722f
C1282 a_9746_5805# a_9772_5843# 0.1657f
C1283 a_18871_1008# a_16510_1044# 0.26208f
C1284 a_12158_5867# a_12355_5867# 0.12454f
C1285 VDD a_14964_1008# 0.28225f
C1286 a_13592_5871# a_13880_6292# 0.43707f
C1287 DELAY_VBIASN a_16163_1842# 0.08306f
C1288 DELAY_VBIASP a_16033_1842# 0.11287f
C1289 a_10951_1842# a_10843_1842# 0.01163f
C1290 VDD a_9757_1842# 0.87771f
C1291 a_7477_1842# a_7390_1044# 0.1088f
C1292 a_6635_1044# a_6711_1008# 0.01194f
C1293 a_15077_1842# a_15837_1842# 0.02912f
C1294 a_25630_1044# a_26471_1008# 0.28268f
C1295 a_21917_1842# a_22243_1842# 0.01427f
C1296 a_17865_519# VDD 0.29444f
C1297 a_3449_331# VDD 0.46596f
C1298 MUX_SEL4 a_12797_1842# 0.01829f
C1299 a_24197_1842# a_24665_1044# 0.2079f
C1300 a_6126_3816# a_6854_5454# 0.22705f
C1301 a_24008_1044# a_24084_1008# 0.01176f
C1302 a_6126_3816# DELAY_VBIASP 0.01821f
C1303 a_27991_1008# a_27705_1044# 0.01885f
C1304 VDD a_12715_1044# 0.15406f
C1305 a_1256_1044# MUX_SEL4 0.04908f
C1306 DELAY_OUT_LAST DELAY_VBIASP 1.08837f
C1307 a_13121_5831# a_12943_5867# 0.09118f
C1308 a_13306_6305# a_14009_5878# 0.02432f
C1309 a_13132_5420# DLL_RESETN 0.01689f
C1310 a_7477_1842# DELAY_VBIASN 0.08375f
C1311 a_6283_1842# DELAY_VBIASP 0.06627f
C1312 VDD a_8884_1008# 0.28225f
C1313 VDD a_17357_1842# 0.86909f
C1314 VDD a_22351_2470# 0.01806f
C1315 DELAY_VBIASP a_14317_1842# 0.04316f
C1316 DELAY_VBIASN a_14513_1842# 0.102f
C1317 a_6717_1842# a_7477_1842# 0.06198f
C1318 a_9431_1842# a_9323_1842# 0.01163f
C1319 a_4350_1044# a_5844_1008# 0.28279f
C1320 a_5115_1044# a_5191_1008# 0.01194f
C1321 a_14317_1842# a_13883_1842# 0.6972f
C1322 a_21157_1842# a_21353_1842# 0.77122f
C1323 a_27124_1008# VDD 0.28225f
C1324 a_22590_1044# a_22564_1008# 0.277f
C1325 a_9746_5805# VDD 0.0918f
C1326 a_25630_1044# a_26185_1044# 0.03209f
C1327 a_13121_5831# a_12849_5867# 0.55272f
C1328 a_4633_1842# DELAY_VBIASP 0.11222f
C1329 a_4763_1842# DELAY_VBIASN 0.07254f
C1330 VDD a_6635_1044# 0.15406f
C1331 VDD a_14643_1842# 0.49675f
C1332 VDD a_16271_2470# 0.01806f
C1333 a_5957_1842# a_5523_1842# 0.6972f
C1334 a_12233_1842# a_12363_1842# 0.70845f
C1335 a_7911_1842# a_7803_1842# 0.01163f
C1336 a_12993_1842# a_13557_1842# 0.0114f
C1337 a_19833_1842# a_19963_1842# 0.70845f
C1338 VDD a_22590_1044# 0.89557f
C1339 VDD a_13121_5831# 0.99724f
C1340 MUX_SEL1 a_2873_1395# 0.13092f
C1341 MUX_SEL4 a_15765_463# 0.65508f
C1342 a_5957_1842# VDD 0.85848f
C1343 DELAY_VBIASP a_26803_1842# 0.06661f
C1344 DELAY_VBIASN a_27997_1842# 0.04657f
C1345 MUX_OUT a_1256_289# 0.1134f
C1346 MUX_SEL4 a_1544_289# 0.47529f
C1347 MUX_SEL2 a_2297_331# 0.10655f
C1348 VDD a_12993_1842# 0.49426f
C1349 VDD a_10191_2470# 0.01806f
C1350 a_4633_1842# a_5197_1842# 0.0114f
C1351 a_11277_1842# a_11603_1842# 0.01427f
C1352 a_14851_5182# DELAY_OUT_LAST 0.02109f
C1353 a_18877_1842# a_19203_1842# 0.01427f
C1354 a_16408_1044# a_16484_1008# 0.01176f
C1355 a_19550_1044# a_20391_1008# 0.28268f
C1356 a_25604_1008# a_25717_1842# 0.05157f
C1357 VDD a_19524_1008# 0.28633f
C1358 a_12797_1842# a_13444_1008# 0.02011f
C1359 REF_CLK a_3449_1395# 0.01058f
C1360 a_24957_1842# a_24951_1008# 0.02354f
C1361 VDD a_4111_2470# 0.01866f
C1362 a_9712_3912# VDD 0.23242f
C1363 DELAY_VBIASN a_25283_1842# 0.08024f
C1364 DELAY_VBIASP a_25153_1842# 0.11284f
C1365 a_11491_6228# DLL_RESETN 0.14622f
C1366 a_11748_6109# REF_CLK 0.0148f
C1367 a_14025_1044# a_14235_1044# 0.09424f
C1368 a_10517_1842# a_10713_1842# 0.73897f
C1369 MUX_SEL2 MUX_SEL0 0.01204f
C1370 a_23437_1842# a_24008_1044# 0.10863f
C1371 a_14009_5084# a_12849_5867# 0.03463f
C1372 DELAY_VBIASN a_23003_1842# 0.08024f
C1373 DELAY_VBIASP a_22873_1842# 0.11284f
C1374 a_18795_1044# a_18871_1008# 0.01194f
C1375 a_12037_1842# a_11924_1008# 0.02055f
C1376 VDD a_26477_1842# 0.86909f
C1377 DELAY_VBIASN a_23633_1842# 0.10349f
C1378 a_2019_311# a_5731_289# 1.15781f
C1379 a_24665_1044# a_24875_1044# 0.09424f
C1380 a_16108_289# a_18877_1842# 0.0157f
C1381 a_9193_1842# a_9323_1842# 0.70845f
C1382 a_11491_6228# a_11397_6228# 0.28931f
C1383 a_14009_5084# VDD 0.31815f
C1384 a_9444_4590# a_5778_3367# 0.19787f
C1385 a_14851_5182# a_15464_3684# 0.04797f
C1386 DELAY_VBIASN a_21353_1842# 0.10734f
C1387 a_13470_1044# a_14235_1044# 0.39037f
C1388 DELAY_VBIASP a_21157_1842# 0.04177f
C1389 a_16108_289# a_23945_519# 0.2906f
C1390 a_14009_5084# a_13880_5118# 0.01562f
C1391 a_11277_1842# a_10430_1044# 0.08038f
C1392 a_6326_4590# VDD 7.53039f
C1393 VDD a_27671_2470# 0.01806f
C1394 DELAY_VBIASN a_12363_1842# 0.07254f
C1395 DELAY_VBIASP a_12233_1842# 0.11222f
C1396 a_2019_311# a_16108_289# 0.33889f
C1397 a_5731_289# a_11785_519# 0.28056f
C1398 VDD a_23763_1842# 0.49671f
C1399 a_5974_5723# a_9712_3912# 0.01152f
C1400 a_6326_4590# a_5864_3367# 0.01889f
C1401 a_2297_331# a_2019_311# 0.04011f
C1402 a_6854_5986# DLL_RESETN 0.50331f
C1403 a_12363_1842# a_12471_2470# 0.01697f
C1404 a_26477_1842# a_26043_1842# 0.6972f
C1405 a_8237_1842# a_8563_1842# 0.01427f
C1406 DLL_RESETN DELAY_VBIASN 0.12907f
C1407 a_5731_289# a_10430_1044# 0.41176f
C1408 REF_CLK a_13306_6305# 0.05059f
C1409 a_10232_5871# a_11491_6228# 0.01529f
C1410 VDD a_21483_1842# 0.4973f
C1411 DELAY_VBIASP a_18443_1842# 0.06661f
C1412 DELAY_VBIASN a_19637_1842# 0.0907f
R0 VDD.n130 VDD.t103 17.3693
R1 VDD.n119 VDD.t58 17.3693
R2 VDD.n119 VDD.t54 17.3693
R3 VDD.n131 VDD.t307 17.3517
R4 VDD.n122 VDD.t369 17.3517
R5 VDD.n121 VDD.t70 17.3517
R6 VDD.n73 VDD.t320 17.2438
R7 VDD.n125 VDD.t37 17.2247
R8 VDD.n131 VDD.t128 17.0005
R9 VDD.n122 VDD.t57 17.0005
R10 VDD.n121 VDD.t55 17.0005
R11 VDD.t4 VDD.n100 4.19382
R12 VDD.n42 VDD.n43 0.189847
R13 VDD.n96 VDD.n95 0.149987
R14 VDD.t4 VDD.n95 2.39616
R15 VDD.n92 VDD.n53 0.149987
R16 VDD.n92 VDD.t4 2.39616
R17 VDD.n97 VDD.n89 0.149987
R18 VDD.t4 VDD.n89 2.39616
R19 VDD.n84 VDD.n50 0.149987
R20 VDD.n84 VDD.t4 2.39616
R21 VDD.n98 VDD.n81 0.149987
R22 VDD.t4 VDD.n81 2.39616
R23 VDD.n77 VDD.n47 0.149987
R24 VDD.t4 VDD.n77 2.39616
R25 VDD.t38 VDD.n37 2.05485
R26 VDD.n34 VDD.n65 0.448571
R27 VDD.n36 VDD.t348 15.1333
R28 VDD.n388 VDD.t351 15.0005
R29 VDD.n1 VDD.t346 15.0005
R30 VDD.n64 VDD.t333 15.0005
R31 VDD.n39 VDD.t338 15.0005
R32 VDD.n67 VDD.t61 17.9449
R33 VDD.n393 VDD.n392 9.51422
R34 VDD.n392 VDD.n391 9.17119
R35 VDD.n68 VDD.n67 0.341666
R36 VDD.n395 VDD.t40 9.02285
R37 VDD.n74 VDD.n75 0.0615821
R38 VDD.n116 VDD.n28 4.47071
R39 VDD.n115 VDD.t382 8.95516
R40 VDD.n148 VDD.t316 8.76154
R41 VDD.n12 VDD.t134 8.76154
R42 VDD.n12 VDD.t68 8.76154
R43 VDD.n12 VDD.t111 8.76154
R44 VDD.n11 VDD.t21 8.76154
R45 VDD.n149 VDD.t317 8.76154
R46 VDD.n44 VDD.t69 8.76154
R47 VDD.n150 VDD.t20 8.76154
R48 VDD.n73 VDD.t321 8.76154
R49 VDD.n109 VDD.t355 8.76054
R50 VDD.n109 VDD.t216 8.76054
R51 VDD.n148 VDD.t152 8.76054
R52 VDD.n12 VDD.t166 8.76054
R53 VDD.n12 VDD.t288 8.76054
R54 VDD.n12 VDD.t28 8.76054
R55 VDD.n11 VDD.t292 8.76054
R56 VDD.n149 VDD.t12 8.76054
R57 VDD.n44 VDD.t289 8.76054
R58 VDD.n150 VDD.t73 8.76054
R59 VDD.n95 VDD.n94 0.0442395
R60 VDD.n91 VDD.n92 0.0442395
R61 VDD.n89 VDD.n88 0.0442395
R62 VDD.n83 VDD.n84 0.0442395
R63 VDD.n81 VDD.n80 0.0442395
R64 VDD.n78 VDD.n77 0.0442395
R65 VDD VDD.t6 8.47732
R66 VDD.n46 VDD.n45 0.0953067
R67 VDD.t4 VDD.n46 4.19225
R68 VDD.t4 VDD.n41 3.34459
R69 VDD.t4 VDD.n13 1.07426
R70 VDD.n15 VDD.t4 0.282264
R71 VDD.t4 VDD.n9 0.793108
R72 VDD.t4 VDD.n18 1.13836
R73 VDD.n8 VDD.t4 0.793108
R74 VDD.n20 VDD.t4 1.13836
R75 VDD.t4 VDD.n6 0.793108
R76 VDD.t4 VDD.n21 0.315451
R77 VDD.n5 VDD.t4 0.793108
R78 VDD.n24 VDD.t4 1.13836
R79 VDD.t4 VDD.n3 0.793108
R80 VDD.t4 VDD.n26 1.13836
R81 VDD.t4 VDD.n10 0.793077
R82 VDD.t0 VDD.n56 4.20922
R83 VDD.t0 VDD.n60 4.20922
R84 VDD.t38 VDD.n57 1.61947
R85 VDD.t38 VDD.n34 0.894484
R86 VDD.t38 VDD.n74 8.47732
R87 VDD.n10 VDD.t409 7.62628
R88 VDD.n76 VDD.t408 7.62628
R89 VDD.n26 VDD.t407 7.62628
R90 VDD.n3 VDD.t406 7.62628
R91 VDD.n79 VDD.t405 7.62628
R92 VDD.n24 VDD.t404 7.62628
R93 VDD.n5 VDD.t403 7.62628
R94 VDD.n82 VDD.t402 7.62628
R95 VDD.n22 VDD.t401 7.62628
R96 VDD.n6 VDD.t400 7.62628
R97 VDD.n87 VDD.t399 7.62628
R98 VDD.n20 VDD.t398 7.62628
R99 VDD.n8 VDD.t397 7.62628
R100 VDD.n90 VDD.t396 7.62628
R101 VDD.n18 VDD.t395 7.62628
R102 VDD.n9 VDD.t394 7.62628
R103 VDD.n93 VDD.t393 7.62628
R104 VDD.n16 VDD.t392 7.62628
R105 VDD.n1 VDD.n30 3.11859
R106 VDD.n197 VDD.t45 6.09923
R107 VDD.n203 VDD.t48 6.09923
R108 VDD.n209 VDD.t44 6.09923
R109 VDD.n215 VDD.t2 6.09923
R110 VDD.n221 VDD.t110 6.09923
R111 VDD.n227 VDD.t50 6.09923
R112 VDD.n233 VDD.t138 6.09923
R113 VDD.n239 VDD.t360 6.09923
R114 VDD.n245 VDD.t296 6.09923
R115 VDD.n251 VDD.t14 6.09923
R116 VDD.n257 VDD.t106 6.09923
R117 VDD.n263 VDD.t1 6.09923
R118 VDD.n269 VDD.t250 6.09923
R119 VDD.n275 VDD.t42 6.09923
R120 VDD.n281 VDD.t26 6.09923
R121 VDD.n287 VDD.t3 6.09923
R122 VDD.n293 VDD.t116 6.09923
R123 VDD.n299 VDD.t150 6.09923
R124 VDD.n305 VDD.t238 6.09923
R125 VDD.n311 VDD.t8 6.09923
R126 VDD.n317 VDD.t212 6.09923
R127 VDD.n323 VDD.t60 6.09923
R128 VDD.n329 VDD.t36 6.09923
R129 VDD.n335 VDD.t185 6.09923
R130 VDD.n341 VDD.t193 6.09923
R131 VDD.n347 VDD.t229 6.09923
R132 VDD.n353 VDD.t169 6.09923
R133 VDD.n359 VDD.t83 6.09923
R134 VDD.n365 VDD.t148 6.09923
R135 VDD.n371 VDD.t108 6.09923
R136 VDD.n377 VDD.t102 6.09923
R137 VDD.n383 VDD.t219 6.09923
R138 VDD.n26 VDD.t109 5.99122
R139 VDD.n24 VDD.t63 5.99122
R140 VDD.n22 VDD.t179 5.99122
R141 VDD.n20 VDD.t211 5.99122
R142 VDD.n18 VDD.t117 5.99122
R143 VDD.n16 VDD.t187 5.99122
R144 VDD.n101 VDD.t144 5.98905
R145 VDD.n129 VDD.t41 5.9886
R146 VDD.n107 VDD.t121 5.97675
R147 VDD.n107 VDD.t153 5.97675
R148 VDD.n12 VDD.t136 5.97212
R149 VDD.n12 VDD.t112 5.97212
R150 VDD.n45 VDD.t365 5.97212
R151 VDD.n151 VDD.t182 5.97212
R152 VDD.n12 VDD.t167 5.97169
R153 VDD.n12 VDD.t29 5.97169
R154 VDD.n45 VDD.t13 5.97169
R155 VDD.n151 VDD.t74 5.97169
R156 VDD.n10 VDD.t91 5.97001
R157 VDD.n10 VDD.t24 5.97001
R158 VDD.n10 VDD.t299 5.97001
R159 VDD.n48 VDD.t87 5.97001
R160 VDD.n47 VDD.t86 5.97001
R161 VDD.n3 VDD.t123 5.97001
R162 VDD.n26 VDD.t90 5.97001
R163 VDD.n3 VDD.t215 5.97001
R164 VDD.n3 VDD.t161 5.97001
R165 VDD.n49 VDD.t95 5.97001
R166 VDD.n98 VDD.t94 5.97001
R167 VDD.n5 VDD.t221 5.97001
R168 VDD.n24 VDD.t98 5.97001
R169 VDD.n5 VDD.t245 5.97001
R170 VDD.n5 VDD.t163 5.97001
R171 VDD.n51 VDD.t77 5.97001
R172 VDD.n50 VDD.t76 5.97001
R173 VDD.n6 VDD.t131 5.97001
R174 VDD.n22 VDD.t80 5.97001
R175 VDD.n6 VDD.t354 5.97001
R176 VDD.n6 VDD.t142 5.97001
R177 VDD.n52 VDD.t312 5.97001
R178 VDD.n97 VDD.t311 5.97001
R179 VDD.n8 VDD.t139 5.97001
R180 VDD.n20 VDD.t315 5.97001
R181 VDD.n8 VDD.t176 5.97001
R182 VDD.n8 VDD.t171 5.97001
R183 VDD.n54 VDD.t224 5.97001
R184 VDD.n53 VDD.t223 5.97001
R185 VDD.n9 VDD.t244 5.97001
R186 VDD.n18 VDD.t227 5.97001
R187 VDD.n9 VDD.t175 5.97001
R188 VDD.n9 VDD.t23 5.97001
R189 VDD.n55 VDD.t32 5.97001
R190 VDD.n96 VDD.t31 5.97001
R191 VDD.n16 VDD.t35 5.97001
R192 VDD.n32 VDD.t359 5.96578
R193 VDD.n42 VDD.t67 5.96578
R194 VDD.n146 VDD.t19 5.96578
R195 VDD.n25 VDD.t51 5.96578
R196 VDD.n23 VDD.t18 5.96578
R197 VDD.n33 VDD.t358 5.96578
R198 VDD.n86 VDD.t71 5.96578
R199 VDD.n27 VDD.t130 5.96578
R200 VDD.n19 VDD.t52 5.96578
R201 VDD.n17 VDD.t168 5.96578
R202 VDD.n14 VDD.t46 5.96578
R203 VDD.n42 VDD.t290 5.96534
R204 VDD.n146 VDD.t293 5.96534
R205 VDD.n101 VDD.t295 5.96534
R206 VDD.n144 VDD.t213 5.96534
R207 VDD.n142 VDD.t237 5.96534
R208 VDD.n153 VDD.t287 5.96534
R209 VDD.n31 VDD.t235 5.96534
R210 VDD.n32 VDD.t368 5.96534
R211 VDD.n10 VDD.t147 5.96534
R212 VDD.n10 VDD.t319 5.96534
R213 VDD.n102 VDD.t376 5.96534
R214 VDD.n47 VDD.t305 5.96534
R215 VDD.n26 VDD.t173 5.96534
R216 VDD.n26 VDD.t126 5.96534
R217 VDD.n25 VDD.t64 5.96534
R218 VDD.n3 VDD.t180 5.96534
R219 VDD.n3 VDD.t100 5.96534
R220 VDD.n103 VDD.t361 5.96534
R221 VDD.n98 VDD.t214 5.96534
R222 VDD.n24 VDD.t174 5.96534
R223 VDD.n24 VDD.t15 5.96534
R224 VDD.n23 VDD.t65 5.96534
R225 VDD.n5 VDD.t39 5.96534
R226 VDD.n5 VDD.t17 5.96534
R227 VDD.n4 VDD.t183 5.96534
R228 VDD.n50 VDD.t377 5.96534
R229 VDD.n22 VDD.t158 5.96534
R230 VDD.n22 VDD.t366 5.96534
R231 VDD.n27 VDD.t285 5.96534
R232 VDD.n27 VDD.t27 5.96534
R233 VDD.n161 VDD.t10 5.96534
R234 VDD.n86 VDD.t5 5.96534
R235 VDD.n159 VDD.t232 5.96534
R236 VDD.n73 VDD.t104 5.96534
R237 VDD.n157 VDD.t62 5.96534
R238 VDD.n155 VDD.t149 5.96534
R239 VDD.n33 VDD.t114 5.96534
R240 VDD.n6 VDD.t239 5.96534
R241 VDD.n6 VDD.t291 5.96534
R242 VDD.n104 VDD.t9 5.96534
R243 VDD.n97 VDD.t178 5.96534
R244 VDD.n20 VDD.t113 5.96534
R245 VDD.n20 VDD.t59 5.96534
R246 VDD.n19 VDD.t220 5.96534
R247 VDD.n8 VDD.t137 5.96534
R248 VDD.n8 VDD.t47 5.96534
R249 VDD.n7 VDD.t308 5.96534
R250 VDD.n53 VDD.t378 5.96534
R251 VDD.n18 VDD.t159 5.96534
R252 VDD.n18 VDD.t231 5.96534
R253 VDD.n17 VDD.t247 5.96534
R254 VDD.n9 VDD.t43 5.96534
R255 VDD.n9 VDD.t11 5.96534
R256 VDD.n105 VDD.t82 5.96534
R257 VDD.n96 VDD.t66 5.96534
R258 VDD.n16 VDD.t387 5.96534
R259 VDD.n16 VDD.t119 5.96534
R260 VDD.n14 VDD.t172 5.96534
R261 VDD.n14 VDD.t101 5.96534
R262 VDD.n127 VDD.t385 5.96478
R263 VDD.n10 VDD.t92 5.65005
R264 VDD.n76 VDD.t25 5.65005
R265 VDD.n26 VDD.t88 5.65005
R266 VDD.n3 VDD.t124 5.65005
R267 VDD.n79 VDD.t93 5.65005
R268 VDD.n24 VDD.t96 5.65005
R269 VDD.n5 VDD.t162 5.65005
R270 VDD.n82 VDD.t75 5.65005
R271 VDD.n22 VDD.t78 5.65005
R272 VDD.n6 VDD.t132 5.65005
R273 VDD.n87 VDD.t310 5.65005
R274 VDD.n20 VDD.t313 5.65005
R275 VDD.n8 VDD.t140 5.65005
R276 VDD.n90 VDD.t177 5.65005
R277 VDD.n18 VDD.t225 5.65005
R278 VDD.n9 VDD.t22 5.65005
R279 VDD.n93 VDD.t30 5.65005
R280 VDD.n16 VDD.t33 5.65005
R281 VDD.t6 VDD.n394 5.62581
R282 VDD.t6 VDD.n396 5.62581
R283 VDD.t4 VDD.n154 5.62581
R284 VDD.t4 VDD.n152 5.62581
R285 VDD.t4 VDD.n145 5.62581
R286 VDD.n41 VDD.n149 0.160419
R287 VDD.n13 VDD.n12 0.134613
R288 VDD.n156 VDD.t4 5.62581
R289 VDD.n72 VDD.t4 1.79705
R290 VDD.n158 VDD.t4 5.62581
R291 VDD.n160 VDD.t4 5.62581
R292 VDD.t0 VDD.n196 5.62581
R293 VDD.t0 VDD.n202 5.62581
R294 VDD.t0 VDD.n208 5.62581
R295 VDD.t0 VDD.n214 5.62581
R296 VDD.t0 VDD.n220 5.62581
R297 VDD.t0 VDD.n226 5.62581
R298 VDD.t0 VDD.n232 5.62581
R299 VDD.t0 VDD.n238 5.62581
R300 VDD.t0 VDD.n244 5.62581
R301 VDD.t0 VDD.n250 5.62581
R302 VDD.t0 VDD.n256 5.62581
R303 VDD.t0 VDD.n262 5.62581
R304 VDD.t0 VDD.n268 5.62581
R305 VDD.t0 VDD.n274 5.62581
R306 VDD.t0 VDD.n280 5.62581
R307 VDD.t0 VDD.n286 5.62581
R308 VDD.t0 VDD.n292 5.62581
R309 VDD.t0 VDD.n298 5.62581
R310 VDD.t0 VDD.n304 5.62581
R311 VDD.t0 VDD.n310 5.62581
R312 VDD.t0 VDD.n316 5.62581
R313 VDD.t0 VDD.n322 5.62581
R314 VDD.t0 VDD.n328 5.62581
R315 VDD.t0 VDD.n334 5.62581
R316 VDD.t0 VDD.n340 5.62581
R317 VDD.t0 VDD.n346 5.62581
R318 VDD.t0 VDD.n352 5.62581
R319 VDD.t0 VDD.n358 5.62581
R320 VDD.t0 VDD.n364 5.62581
R321 VDD.t0 VDD.n370 5.62581
R322 VDD.t0 VDD.n376 5.62581
R323 VDD.t0 VDD.n382 5.62581
R324 VDD.t0 VDD.n384 5.62581
R325 VDD.t7 VDD.n124 5.61485
R326 VDD.t7 VDD.n128 5.61485
R327 VDD.n0 VDD.t344 5.7457
R328 VDD.n111 VDD.t334 5.60969
R329 VDD.n112 VDD.t339 5.60969
R330 VDD.n1 VDD.t347 5.71623
R331 VDD.n387 VDD.t353 5.60347
R332 VDD.n61 VDD.t350 5.60347
R333 VDD.n28 VDD.t337 5.60347
R334 VDD.n114 VDD.t342 5.60347
R335 VDD.n194 VDD.t261 5.59675
R336 VDD.n200 VDD.t259 5.59675
R337 VDD.n206 VDD.t256 5.59675
R338 VDD.n212 VDD.t263 5.59675
R339 VDD.n218 VDD.t262 5.59675
R340 VDD.n224 VDD.t258 5.59675
R341 VDD.n230 VDD.t268 5.59675
R342 VDD.n236 VDD.t269 5.59675
R343 VDD.n242 VDD.t266 5.59675
R344 VDD.n248 VDD.t270 5.59675
R345 VDD.n254 VDD.t265 5.59675
R346 VDD.n260 VDD.t252 5.59675
R347 VDD.n266 VDD.t272 5.59675
R348 VDD.n272 VDD.t257 5.59675
R349 VDD.n278 VDD.t271 5.59675
R350 VDD.n284 VDD.t267 5.59675
R351 VDD.n290 VDD.t254 5.59675
R352 VDD.n296 VDD.t274 5.59675
R353 VDD.n302 VDD.t273 5.59675
R354 VDD.n308 VDD.t275 5.59675
R355 VDD.n314 VDD.t264 5.59675
R356 VDD.n320 VDD.t277 5.59675
R357 VDD.n326 VDD.t276 5.59675
R358 VDD.n332 VDD.t278 5.59675
R359 VDD.n338 VDD.t253 5.59675
R360 VDD.n344 VDD.t281 5.59675
R361 VDD.n350 VDD.t280 5.59675
R362 VDD.n356 VDD.t279 5.59675
R363 VDD.n362 VDD.t255 5.59675
R364 VDD.n368 VDD.t282 5.59675
R365 VDD.n374 VDD.t283 5.59675
R366 VDD.n380 VDD.t284 5.59675
R367 VDD.n385 VDD.t349 5.59675
R368 VDD.n38 VDD.t260 5.59675
R369 VDD.n28 VDD.t335 5.59179
R370 VDD.n113 VDD.t340 5.59179
R371 VDD.n1 VDD.t345 5.59179
R372 VDD.n433 VDD.t325 4.9462
R373 VDD.n405 VDD.t322 4.9462
R374 VDD.n117 VDD.n116 4.90372
R375 VDD.t4 VDD.n147 4.19244
R376 VDD.t4 VDD.n43 3.32638
R377 VDD.t6 VDD.n135 4.19238
R378 VDD.n57 VDD.n28 0.406014
R379 VDD.n37 VDD.n75 0.379679
R380 VDD.t6 VDD.n397 4.19225
R381 VDD.t6 VDD.n425 4.19225
R382 VDD.t6 VDD.n140 4.19225
R383 VDD.t4 VDD.n99 3.3265
R384 VDD.n157 VDD.n72 0.341
R385 VDD.n85 VDD.t4 3.3265
R386 VDD.t7 VDD.n126 3.31208
R387 VDD.t7 VDD.n118 3.30706
R388 VDD.t7 VDD.n120 3.30706
R389 VDD.t7 VDD.n132 3.30688
R390 VDD VDD.n42 3.24041
R391 VDD.t7 VDD.n108 2.77509
R392 VDD.t4 VDD.n141 2.74446
R393 VDD.t4 VDD.n143 2.74446
R394 VDD.n15 VDD.n14 0.286677
R395 VDD.n161 VDD.n27 0.44578
R396 VDD.n27 VDD.n21 0.309939
R397 VDD.t6 VDD.n134 2.74414
R398 VDD.t0 VDD.n35 2.74414
R399 VDD.n2 VDD.n195 0.528092
R400 VDD.n1 VDD.n193 0.435597
R401 VDD.t7 VDD 1.47683
R402 VDD.n435 VDD.t327 2.69937
R403 VDD.n403 VDD.t330 2.69937
R404 VDD.n401 VDD.t324 2.69937
R405 VDD.n427 VDD.t332 2.69937
R406 VDD.n431 VDD.t210 2.6992
R407 VDD.n429 VDD.t202 2.6992
R408 VDD.n399 VDD.t203 2.6992
R409 VDD.n407 VDD.t195 2.6992
R410 VDD.n412 VDD.t196 2.6992
R411 VDD.n411 VDD.t204 2.6992
R412 VDD.n417 VDD.t198 2.6992
R413 VDD.n416 VDD.t206 2.6992
R414 VDD.n422 VDD.t200 2.6992
R415 VDD.n421 VDD.t208 2.6992
R416 VDD.t6 VDD.n70 2.33382
R417 VDD.t0 VDD.n222 2.32446
R418 VDD.t0 VDD.n246 2.32439
R419 VDD.t0 VDD.n294 2.32439
R420 VDD.t0 VDD.n312 2.32439
R421 VDD.t0 VDD.n252 2.32432
R422 VDD.t0 VDD.n372 2.32432
R423 VDD.t6 VDD.n424 2.32425
R424 VDD.t0 VDD.n306 2.32425
R425 VDD.t0 VDD.n324 2.32425
R426 VDD.t0 VDD.n342 2.32425
R427 VDD.t0 VDD.n234 2.3242
R428 VDD.t0 VDD.n276 2.3242
R429 VDD.t0 VDD.n288 2.3242
R430 VDD.t6 VDD.n419 2.32417
R431 VDD.t0 VDD.n210 2.32417
R432 VDD.t0 VDD.n216 2.32417
R433 VDD.t0 VDD.n264 2.32417
R434 VDD.t0 VDD.n270 2.32417
R435 VDD.t0 VDD.n330 2.32417
R436 VDD.t0 VDD.n336 2.32417
R437 VDD.t0 VDD.n354 2.32417
R438 VDD.t0 VDD.n360 2.32417
R439 VDD.t0 VDD.n378 2.32417
R440 VDD.t6 VDD.n139 2.32417
R441 VDD.t6 VDD.n136 2.32417
R442 VDD.t38 VDD.n68 0.570319
R443 VDD.t0 VDD.n204 2.32417
R444 VDD.t0 VDD.n198 2.32414
R445 VDD.t0 VDD.n318 2.32414
R446 VDD.t0 VDD.n258 2.32407
R447 VDD.t0 VDD.n282 2.32407
R448 VDD.t6 VDD.n409 2.32406
R449 VDD.t6 VDD.n138 2.32406
R450 VDD.t0 VDD.n228 2.32406
R451 VDD.t0 VDD.n240 2.32406
R452 VDD.t0 VDD.n300 2.32406
R453 VDD.t0 VDD.n348 2.32406
R454 VDD.t0 VDD.n366 2.32406
R455 VDD.n14 VDD.t16 6.354
R456 VDD.t6 VDD.n414 2.00616
R457 VDD.t6 VDD.n137 2.0061
R458 VDD.t6 VDD.n437 1.75938
R459 VDD.t0 VDD.n390 1.56886
R460 VDD.t0 VDD.n164 1.55381
R461 VDD.t0 VDD.n165 1.55381
R462 VDD.t0 VDD.n166 1.55381
R463 VDD.t0 VDD.n167 1.55381
R464 VDD.t0 VDD.n169 1.55381
R465 VDD.t0 VDD.n172 1.55381
R466 VDD.t0 VDD.n174 1.55381
R467 VDD.t0 VDD.n175 1.55381
R468 VDD.t0 VDD.n178 1.55381
R469 VDD.t0 VDD.n179 1.55381
R470 VDD.t0 VDD.n181 1.55381
R471 VDD.t0 VDD.n182 1.55381
R472 VDD.t0 VDD.n183 1.55381
R473 VDD.t0 VDD.n185 1.55381
R474 VDD.t0 VDD.n186 1.55381
R475 VDD.t0 VDD.n189 1.55381
R476 VDD.t0 VDD.n191 1.55381
R477 VDD.t0 VDD.n192 1.55381
R478 VDD.t0 VDD.n162 1.55341
R479 VDD.t0 VDD.n163 1.55341
R480 VDD.t0 VDD.n168 1.55341
R481 VDD.t0 VDD.n170 1.55341
R482 VDD.t0 VDD.n171 1.55341
R483 VDD.t0 VDD.n173 1.55341
R484 VDD.t0 VDD.n176 1.55341
R485 VDD.t0 VDD.n177 1.55341
R486 VDD.t0 VDD.n180 1.55341
R487 VDD.t0 VDD.n184 1.55341
R488 VDD.t0 VDD.n187 1.55341
R489 VDD.t0 VDD.n188 1.55341
R490 VDD.t0 VDD.n190 1.55341
R491 VDD.t7 VDD.n110 1.20461
R492 VDD.n68 VDD.n115 0.779651
R493 VDD.n412 VDD.n411 1.11007
R494 VDD.n417 VDD.n416 1.11007
R495 VDD.n422 VDD.n421 1.11007
R496 VDD.t6 VDD.n133 1.01993
R497 VDD.n130 VDD.n106 0.975304
R498 VDD.n106 VDD.n129 0.817678
R499 VDD.n392 VDD.n30 0.808112
R500 VDD.n117 VDD.n110 0.671512
R501 VDD.n110 VDD.n109 0.6645
R502 VDD.n393 VDD.n133 0.632886
R503 VDD.n391 VDD.n133 0.618267
R504 VDD.n436 VDD.n435 0.570444
R505 VDD.n401 VDD.n400 0.570444
R506 VDD.n429 VDD.n428 0.570274
R507 VDD.n408 VDD.n407 0.570274
R508 VDD.n413 VDD.n412 0.570274
R509 VDD.n418 VDD.n417 0.570274
R510 VDD.n423 VDD.n422 0.570274
R511 VDD.n431 VDD.n430 0.569912
R512 VDD.n399 VDD.n398 0.569912
R513 VDD.n411 VDD.n410 0.569912
R514 VDD.n416 VDD.n415 0.569912
R515 VDD.n421 VDD.n420 0.569912
R516 VDD.n403 VDD.n402 0.569733
R517 VDD.n427 VDD.n426 0.569733
R518 VDD.n29 VDD.n28 0.183807
R519 VDD.n113 VDD.n40 0.508375
R520 VDD.t7 VDD.n106 0.49685
R521 VDD.n194 VDD.n193 0.495398
R522 VDD.n200 VDD.n199 0.495398
R523 VDD.n206 VDD.n205 0.495398
R524 VDD.n212 VDD.n211 0.495398
R525 VDD.n218 VDD.n217 0.495398
R526 VDD.n224 VDD.n223 0.495398
R527 VDD.n230 VDD.n229 0.495398
R528 VDD.n236 VDD.n235 0.495398
R529 VDD.n242 VDD.n241 0.495398
R530 VDD.n248 VDD.n247 0.495398
R531 VDD.n254 VDD.n253 0.495398
R532 VDD.n260 VDD.n259 0.495398
R533 VDD.n266 VDD.n265 0.495398
R534 VDD.n272 VDD.n271 0.495398
R535 VDD.n278 VDD.n277 0.495398
R536 VDD.n284 VDD.n283 0.495398
R537 VDD.n290 VDD.n289 0.495398
R538 VDD.n296 VDD.n295 0.495398
R539 VDD.n302 VDD.n301 0.495398
R540 VDD.n308 VDD.n307 0.495398
R541 VDD.n314 VDD.n313 0.495398
R542 VDD.n320 VDD.n319 0.495398
R543 VDD.n326 VDD.n325 0.495398
R544 VDD.n332 VDD.n331 0.495398
R545 VDD.n338 VDD.n337 0.495398
R546 VDD.n344 VDD.n343 0.495398
R547 VDD.n350 VDD.n349 0.495398
R548 VDD.n356 VDD.n355 0.495398
R549 VDD.n362 VDD.n361 0.495398
R550 VDD.n368 VDD.n367 0.495398
R551 VDD.n374 VDD.n373 0.495398
R552 VDD.n380 VDD.n379 0.495398
R553 VDD.n385 VDD.n36 0.495398
R554 VDD.n38 VDD.n58 0.495398
R555 VDD.n404 VDD.n403 0.492175
R556 VDD.n434 VDD.n427 0.492175
R557 VDD.n432 VDD.n431 0.492005
R558 VDD.n406 VDD.n399 0.492005
R559 VDD.n432 VDD.n429 0.491643
R560 VDD.n407 VDD.n406 0.491643
R561 VDD.n435 VDD.n434 0.491464
R562 VDD.n404 VDD.n401 0.491464
R563 VDD.n195 VDD.n194 0.478641
R564 VDD.n201 VDD.n200 0.478641
R565 VDD.n207 VDD.n206 0.478641
R566 VDD.n213 VDD.n212 0.478641
R567 VDD.n219 VDD.n218 0.478641
R568 VDD.n225 VDD.n224 0.478641
R569 VDD.n231 VDD.n230 0.478641
R570 VDD.n237 VDD.n236 0.478641
R571 VDD.n243 VDD.n242 0.478641
R572 VDD.n249 VDD.n248 0.478641
R573 VDD.n255 VDD.n254 0.478641
R574 VDD.n261 VDD.n260 0.478641
R575 VDD.n267 VDD.n266 0.478641
R576 VDD.n273 VDD.n272 0.478641
R577 VDD.n279 VDD.n278 0.478641
R578 VDD.n285 VDD.n284 0.478641
R579 VDD.n291 VDD.n290 0.478641
R580 VDD.n297 VDD.n296 0.478641
R581 VDD.n303 VDD.n302 0.478641
R582 VDD.n309 VDD.n308 0.478641
R583 VDD.n315 VDD.n314 0.478641
R584 VDD.n321 VDD.n320 0.478641
R585 VDD.n327 VDD.n326 0.478641
R586 VDD.n333 VDD.n332 0.478641
R587 VDD.n339 VDD.n338 0.478641
R588 VDD.n345 VDD.n344 0.478641
R589 VDD.n351 VDD.n350 0.478641
R590 VDD.n357 VDD.n356 0.478641
R591 VDD.n363 VDD.n362 0.478641
R592 VDD.n369 VDD.n368 0.478641
R593 VDD.n375 VDD.n374 0.478641
R594 VDD.n381 VDD.n380 0.478641
R595 VDD.n59 VDD.n385 0.478641
R596 VDD.n40 VDD.n38 0.478641
R597 VDD.n193 VDD.n192 0.467341
R598 VDD.n199 VDD.n191 0.467341
R599 VDD.n211 VDD.n189 0.467341
R600 VDD.n229 VDD.n186 0.467341
R601 VDD.n235 VDD.n185 0.467341
R602 VDD.n247 VDD.n183 0.467341
R603 VDD.n253 VDD.n182 0.467341
R604 VDD.n259 VDD.n181 0.467341
R605 VDD.n271 VDD.n179 0.467341
R606 VDD.n277 VDD.n178 0.467341
R607 VDD.n295 VDD.n175 0.467341
R608 VDD.n301 VDD.n174 0.467341
R609 VDD.n313 VDD.n172 0.467341
R610 VDD.n331 VDD.n169 0.467341
R611 VDD.n343 VDD.n167 0.467341
R612 VDD.n349 VDD.n166 0.467341
R613 VDD.n355 VDD.n165 0.467341
R614 VDD.n361 VDD.n164 0.467341
R615 VDD.n205 VDD.n190 0.466909
R616 VDD.n217 VDD.n188 0.466909
R617 VDD.n223 VDD.n187 0.466909
R618 VDD.n241 VDD.n184 0.466909
R619 VDD.n265 VDD.n180 0.466909
R620 VDD.n283 VDD.n177 0.466909
R621 VDD.n289 VDD.n176 0.466909
R622 VDD.n307 VDD.n173 0.466909
R623 VDD.n319 VDD.n171 0.466909
R624 VDD.n325 VDD.n170 0.466909
R625 VDD.n337 VDD.n168 0.466909
R626 VDD.n367 VDD.n163 0.466909
R627 VDD.n373 VDD.n162 0.466909
R628 VDD.n211 VDD.n190 0.451022
R629 VDD.n223 VDD.n188 0.451022
R630 VDD.n229 VDD.n187 0.451022
R631 VDD.n247 VDD.n184 0.451022
R632 VDD.n271 VDD.n180 0.451022
R633 VDD.n289 VDD.n177 0.451022
R634 VDD.n295 VDD.n176 0.451022
R635 VDD.n313 VDD.n173 0.451022
R636 VDD.n325 VDD.n171 0.451022
R637 VDD.n331 VDD.n170 0.451022
R638 VDD.n343 VDD.n168 0.451022
R639 VDD.n373 VDD.n163 0.451022
R640 VDD.n379 VDD.n162 0.451022
R641 VDD.n199 VDD.n192 0.450618
R642 VDD.n205 VDD.n191 0.450618
R643 VDD.n217 VDD.n189 0.450618
R644 VDD.n235 VDD.n186 0.450618
R645 VDD.n241 VDD.n185 0.450618
R646 VDD.n253 VDD.n183 0.450618
R647 VDD.n259 VDD.n182 0.450618
R648 VDD.n265 VDD.n181 0.450618
R649 VDD.n277 VDD.n179 0.450618
R650 VDD.n283 VDD.n178 0.450618
R651 VDD.n301 VDD.n175 0.450618
R652 VDD.n307 VDD.n174 0.450618
R653 VDD.n319 VDD.n172 0.450618
R654 VDD.n337 VDD.n169 0.450618
R655 VDD.n349 VDD.n167 0.450618
R656 VDD.n355 VDD.n166 0.450618
R657 VDD.n361 VDD.n165 0.450618
R658 VDD.n367 VDD.n164 0.450618
R659 VDD.n61 VDD.n56 0.445771
R660 VDD.n437 VDD.n436 0.43335
R661 VDD.n74 VDD.n29 0.0930507
R662 VDD.n66 VDD.n114 0.429929
R663 VDD.n390 VDD.n389 0.429766
R664 VDD.n387 VDD.n386 0.427147
R665 VDD.n62 VDD.n61 0.427147
R666 VDD.n390 VDD.n386 0.426171
R667 VDD.n111 VDD.n28 0.413465
R668 VDD.n112 VDD.n58 0.413465
R669 VDD.n437 VDD.n69 0.403558
R670 VDD.t6 VDD.t7 0.383639
R671 VDD.n419 VDD.n418 0.372655
R672 VDD.n415 VDD.n138 0.372571
R673 VDD.n222 VDD.n221 0.35553
R674 VDD.n246 VDD.n245 0.355452
R675 VDD.n294 VDD.n293 0.355452
R676 VDD.n312 VDD.n311 0.355452
R677 VDD.n252 VDD.n251 0.355386
R678 VDD.n372 VDD.n371 0.355386
R679 VDD.n324 VDD.n323 0.355312
R680 VDD.n342 VDD.n341 0.355312
R681 VDD.n306 VDD.n305 0.355312
R682 VDD.n264 VDD.n263 0.355155
R683 VDD.n270 VDD.n269 0.355155
R684 VDD.n336 VDD.n335 0.355155
R685 VDD.n210 VDD.n209 0.355155
R686 VDD.n216 VDD.n215 0.355155
R687 VDD.n330 VDD.n329 0.355155
R688 VDD.n354 VDD.n353 0.355155
R689 VDD.n360 VDD.n359 0.355155
R690 VDD.n378 VDD.n377 0.355155
R691 VDD.n300 VDD.n299 0.355071
R692 VDD.n204 VDD.n203 0.35501
R693 VDD.n198 VDD.n197 0.354936
R694 VDD.n318 VDD.n317 0.354936
R695 VDD.n234 VDD.n233 0.354903
R696 VDD.n276 VDD.n275 0.354903
R697 VDD.n288 VDD.n287 0.354903
R698 VDD.n258 VDD.n257 0.354838
R699 VDD.n282 VDD.n281 0.354838
R700 VDD.n413 VDD.n409 0.354771
R701 VDD.n228 VDD.n227 0.354771
R702 VDD.n240 VDD.n239 0.354771
R703 VDD.n348 VDD.n347 0.354771
R704 VDD.n366 VDD.n365 0.354771
R705 VDD.n410 VDD.n136 0.354692
R706 VDD.n424 VDD.n423 0.347812
R707 VDD.n420 VDD.n139 0.347655
R708 VDD.n414 VDD.n413 0.347324
R709 VDD.n410 VDD.n137 0.347254
R710 VDD.n132 VDD.n130 0.335799
R711 VDD.n120 VDD.n119 0.335496
R712 VDD.n430 VDD.n139 0.334692
R713 VDD.n428 VDD.n424 0.334557
R714 VDD.n123 VDD.n120 0.332368
R715 VDD.n132 VDD.n71 0.332058
R716 VDD.n426 VDD.n70 0.33018
R717 VDD.n415 VDD.n137 0.328947
R718 VDD.n418 VDD.n414 0.328884
R719 VDD.n398 VDD.n136 0.327655
R720 VDD.n409 VDD.n408 0.327571
R721 VDD.t343 VDD.n0 15.0851
R722 VDD.n127 VDD.n126 0.327354
R723 VDD.n64 VDD.n111 0.327154
R724 VDD.n39 VDD.n112 0.327154
R725 VDD.n402 VDD.n134 0.319294
R726 VDD.n388 VDD.n387 0.313013
R727 VDD.n231 VDD.n228 0.310071
R728 VDD.n243 VDD.n240 0.310071
R729 VDD.n351 VDD.n348 0.310071
R730 VDD.n369 VDD.n366 0.310071
R731 VDD.n261 VDD.n258 0.309994
R732 VDD.n285 VDD.n282 0.309994
R733 VDD.n237 VDD.n234 0.309933
R734 VDD.n279 VDD.n276 0.309933
R735 VDD.n291 VDD.n288 0.309933
R736 VDD.n201 VDD.n198 0.309928
R737 VDD.n321 VDD.n318 0.309928
R738 VDD.n207 VDD.n204 0.309837
R739 VDD.n420 VDD.n138 0.309771
R740 VDD.n303 VDD.n300 0.309771
R741 VDD.n423 VDD.n419 0.309692
R742 VDD.n219 VDD.n216 0.309692
R743 VDD.n267 VDD.n264 0.309692
R744 VDD.n333 VDD.n330 0.309692
R745 VDD.n213 VDD.n210 0.309692
R746 VDD.n273 VDD.n270 0.309692
R747 VDD.n339 VDD.n336 0.309692
R748 VDD.n357 VDD.n354 0.309692
R749 VDD.n363 VDD.n360 0.309692
R750 VDD.n381 VDD.n378 0.309692
R751 VDD.n309 VDD.n306 0.309557
R752 VDD.n327 VDD.n324 0.309557
R753 VDD.n345 VDD.n342 0.309557
R754 VDD.n255 VDD.n252 0.309483
R755 VDD.n375 VDD.n372 0.309483
R756 VDD.n249 VDD.n246 0.309405
R757 VDD.n297 VDD.n294 0.309405
R758 VDD.n315 VDD.n312 0.309405
R759 VDD.n225 VDD.n222 0.309333
R760 VDD.n109 VDD.n108 0.306263
R761 VDD.n118 VDD.n117 0.298721
R762 VDD.n379 VDD.n35 0.29124
R763 VDD VDD.n71 0.423614
R764 VDD.n2 VDD.t0 0.549263
R765 VDD.n142 VDD.n141 0.284268
R766 VDD.n143 VDD.n142 0.282549
R767 VDD.n126 VDD.n125 0.282297
R768 VDD.n99 VDD.n144 0.279247
R769 VDD.n85 VDD.n159 0.279247
R770 VDD.n2 VDD.n1 0.0990076
R771 VDD.n153 VDD.n141 0.268799
R772 VDD.n101 VDD.n99 0.267977
R773 VDD.n119 VDD.n118 0.260496
R774 VDD.n391 VDD.n134 0.25999
R775 VDD.n433 VDD.n432 0.253639
R776 VDD.n405 VDD.n404 0.253639
R777 VDD.n114 VDD.n58 0.25333
R778 VDD.n434 VDD.n433 0.253298
R779 VDD.n406 VDD.n405 0.253298
R780 VDD VDD.n70 0.250961
R781 VDD.n36 VDD.n35 0.243044
R782 VDD.n144 VDD.n143 0.241768
R783 VDD.n116 VDD.n75 4.71183
R784 VDD.n67 VDD.n66 0.706063
R785 VDD VDD.n69 0.521582
R786 VDD.n73 VDD.n72 0.484477
R787 VDD.n63 VDD.t341 15.0439
R788 VDD.n63 VDD.n58 0.130762
R789 VDD.n66 VDD.n40 0.291774
R790 VDD.n86 VDD.n85 0.222977
R791 VDD.n32 VDD.n31 0.251712
R792 VDD.n26 VDD.n25 0.251712
R793 VDD.n24 VDD.n23 0.251712
R794 VDD.n155 VDD.n33 0.251712
R795 VDD.n20 VDD.n19 0.251712
R796 VDD.n18 VDD.n17 0.251712
R797 VDD.n105 VDD.n9 0.272485
R798 VDD.n8 VDD.n7 0.272485
R799 VDD.n104 VDD.n6 0.272485
R800 VDD.n5 VDD.n4 0.272485
R801 VDD.n103 VDD.n3 0.272485
R802 VDD.n102 VDD.n10 0.272485
R803 VDD.n29 VDD.n65 0.109866
R804 VDD.n58 VDD.n57 0.0835447
R805 VDD.n40 VDD.n37 0.100238
R806 VDD.n129 VDD.n128 0.202075
R807 VDD.n398 VDD.n135 0.192052
R808 VDD.n408 VDD.n397 0.191924
R809 VDD.n434 VDD.n69 0.189333
R810 VDD.n428 VDD.n425 0.184424
R811 VDD.n430 VDD.n140 0.184424
R812 VDD.n147 VDD.n146 0.181058
R813 VDD.n400 VDD.n396 0.179888
R814 VDD.n128 VDD.n127 0.175486
R815 VDD.n125 VDD.n124 0.171736
R816 VDD.n395 VDD.n394 0.16955
R817 VDD.n384 VDD.n383 0.16955
R818 VDD.n151 VDD.n100 0.210474
R819 VDD.n202 VDD.n201 0.162388
R820 VDD.n232 VDD.n231 0.162388
R821 VDD.n238 VDD.n237 0.162388
R822 VDD.n250 VDD.n249 0.162388
R823 VDD.n280 VDD.n279 0.162388
R824 VDD.n292 VDD.n291 0.162388
R825 VDD.n328 VDD.n327 0.162388
R826 VDD.n358 VDD.n357 0.162388
R827 VDD.n382 VDD.n381 0.162388
R828 VDD.n196 VDD.n195 0.16205
R829 VDD.n208 VDD.n207 0.16205
R830 VDD.n214 VDD.n213 0.16205
R831 VDD.n220 VDD.n219 0.16205
R832 VDD.n226 VDD.n225 0.16205
R833 VDD.n244 VDD.n243 0.16205
R834 VDD.n256 VDD.n255 0.16205
R835 VDD.n262 VDD.n261 0.16205
R836 VDD.n268 VDD.n267 0.16205
R837 VDD.n274 VDD.n273 0.16205
R838 VDD.n286 VDD.n285 0.16205
R839 VDD.n298 VDD.n297 0.16205
R840 VDD.n304 VDD.n303 0.16205
R841 VDD.n310 VDD.n309 0.16205
R842 VDD.n316 VDD.n315 0.16205
R843 VDD.n322 VDD.n321 0.16205
R844 VDD.n334 VDD.n333 0.16205
R845 VDD.n340 VDD.n339 0.16205
R846 VDD.n346 VDD.n345 0.16205
R847 VDD.n352 VDD.n351 0.16205
R848 VDD.n364 VDD.n363 0.16205
R849 VDD.n370 VDD.n369 0.16205
R850 VDD.n376 VDD.n375 0.16205
R851 VDD.n426 VDD.n140 0.161924
R852 VDD.n436 VDD.n425 0.161924
R853 VDD.n30 VDD 0.485468
R854 VDD.n41 VDD.n11 0.0957379
R855 VDD.n148 VDD.n147 0.159043
R856 VDD.n154 VDD.n153 0.157388
R857 VDD.n161 VDD.n160 0.157388
R858 VDD.n157 VDD.n156 0.157388
R859 VDD.n400 VDD.n397 0.154424
R860 VDD.n402 VDD.n135 0.154293
R861 VDD.n71 VDD.n131 0.152808
R862 VDD.n123 VDD.n122 0.152808
R863 VDD.n123 VDD.n121 0.152808
R864 VDD.n150 VDD.n145 0.15205
R865 VDD.n158 VDD.n73 0.15205
R866 VDD.n124 VDD.n123 0.147075
R867 VDD.n46 VDD.n149 0.236924
R868 VDD.n152 VDD.n150 0.134888
R869 VDD.n45 VDD.n44 0.134618
R870 VDD.n389 VDD.n388 0.133259
R871 VDD.n65 VDD.n64 0.133259
R872 VDD.n101 VDD.n100 0.16225
R873 VDD.n78 VDD.n76 0.128884
R874 VDD.n80 VDD.n79 0.128884
R875 VDD.n83 VDD.n82 0.128884
R876 VDD.n88 VDD.n87 0.128884
R877 VDD.n91 VDD.n90 0.128884
R878 VDD.n94 VDD.n93 0.128884
R879 VDD.n108 VDD.n107 0.127973
R880 VDD.n13 VDD.n148 0.947265
R881 VDD.n60 VDD.n59 0.185493
R882 VDD.n160 VDD.n86 0.1583
R883 VDD.n94 VDD.n105 0.141235
R884 VDD.n7 VDD.n91 0.141235
R885 VDD.n88 VDD.n104 0.141235
R886 VDD.n4 VDD.n83 0.141235
R887 VDD.n80 VDD.n103 0.141235
R888 VDD.n78 VDD.n102 0.141235
R889 VDD.n62 VDD.n60 0.0613757
R890 VDD.n152 VDD.n151 0.12205
R891 VDD.n394 VDD.n393 0.119888
R892 VDD.n197 VDD.n196 0.117388
R893 VDD.n209 VDD.n208 0.117388
R894 VDD.n215 VDD.n214 0.117388
R895 VDD.n221 VDD.n220 0.117388
R896 VDD.n227 VDD.n226 0.117388
R897 VDD.n245 VDD.n244 0.117388
R898 VDD.n257 VDD.n256 0.117388
R899 VDD.n263 VDD.n262 0.117388
R900 VDD.n269 VDD.n268 0.117388
R901 VDD.n275 VDD.n274 0.117388
R902 VDD.n287 VDD.n286 0.117388
R903 VDD.n299 VDD.n298 0.117388
R904 VDD.n305 VDD.n304 0.117388
R905 VDD.n311 VDD.n310 0.117388
R906 VDD.n317 VDD.n316 0.117388
R907 VDD.n323 VDD.n322 0.117388
R908 VDD.n335 VDD.n334 0.117388
R909 VDD.n341 VDD.n340 0.117388
R910 VDD.n347 VDD.n346 0.117388
R911 VDD.n353 VDD.n352 0.117388
R912 VDD.n365 VDD.n364 0.117388
R913 VDD.n371 VDD.n370 0.117388
R914 VDD.n377 VDD.n376 0.117388
R915 VDD.n396 VDD.n395 0.11705
R916 VDD.n203 VDD.n202 0.11705
R917 VDD.n233 VDD.n232 0.11705
R918 VDD.n239 VDD.n238 0.11705
R919 VDD.n251 VDD.n250 0.11705
R920 VDD.n281 VDD.n280 0.11705
R921 VDD.n293 VDD.n292 0.11705
R922 VDD.n329 VDD.n328 0.11705
R923 VDD.n359 VDD.n358 0.11705
R924 VDD.n383 VDD.n382 0.11705
R925 VDD.n59 VDD.n384 0.114888
R926 VDD.n31 VDD.n154 0.1133
R927 VDD.n156 VDD.n155 0.1133
R928 VDD.n44 VDD.n145 0.104888
R929 VDD.n159 VDD.n158 0.101138
R930 VDD.n63 VDD.n113 0.340529
R931 VDD.n56 VDD.n36 0.257619
R932 VDD.n40 VDD.n39 0.251665
R933 VDD.n146 VDD.n43 0.24736
R934 VDD.n115 VDD.n58 0.205524
R935 VDD.n386 VDD.n62 0.146235
R936 VDD.n389 VDD.n56 0.146235
R937 VDD.n96 VDD.n55 0.224985
R938 VDD.n54 VDD.n53 0.224985
R939 VDD.n97 VDD.n52 0.224985
R940 VDD.n51 VDD.n50 0.224985
R941 VDD.n98 VDD.n49 0.224985
R942 VDD.n48 VDD.n47 0.224985
R943 VDD.n12 VDD.n11 0.211235
R944 VDD.n28 VDD.t336 15.0336
R945 VDD.n17 VDD.n9 1.20647
R946 VDD.n8 VDD.n19 1.20647
R947 VDD.n33 VDD.n6 1.20647
R948 VDD.n5 VDD.n23 1.20647
R949 VDD.n25 VDD.n3 1.20647
R950 VDD.n10 VDD.n32 1.20646
R951 VDD.n34 VDD.n28 1.17026
R952 VDD.n1 VDD.n0 1.10275
R953 VDD.n16 VDD.n15 0.432633
R954 VDD.n22 VDD.n21 0.409065
R955 VDD.n48 VDD.n26 1.01698
R956 VDD.n49 VDD.n24 1.01698
R957 VDD.n51 VDD.n22 1.01698
R958 VDD.n52 VDD.n20 1.01698
R959 VDD.n54 VDD.n18 1.01698
R960 VDD.n55 VDD.n16 1.01698
R961 VSS.t250 VSS.n532 119321
R962 VSS.n601 VSS.n600 22369.4
R963 VSS.n438 VSS.n309 7907.02
R964 VSS.n528 VSS.n200 4670.31
R965 VSS.n854 VSS.n853 3068.57
R966 VSS.t311 VSS.n61 310.202
R967 VSS.t181 VSS.n66 310.202
R968 VSS.t568 VSS.n593 849.322
R969 VSS.n648 VSS.n647 572.005
R970 VSS.t135 VSS.t138 571.348
R971 VSS.n663 VSS.t616 566.691
R972 VSS.n662 VSS.t440 560.899
R973 VSS.n652 VSS.t408 550.193
R974 VSS.n679 VSS.t600 539.653
R975 VSS.t217 VSS.n660 532.819
R976 VSS.n682 VSS.t391 522.508
R977 VSS.n673 VSS.t427 521.236
R978 VSS.t152 VSS.n659 514.091
R979 VSS.n669 VSS.t597 504.839
R980 VSS.n655 VSS.t356 504.839
R981 VSS.n680 VSS.t392 491.87
R982 VSS.n664 VSS.t158 474.904
R983 VSS.t481 VSS.n604 470.019
R984 VSS.n225 VSS.n224 469.783
R985 VSS.n243 VSS.n242 469.783
R986 VSS.n260 VSS.n259 469.783
R987 VSS.n282 VSS.n281 469.783
R988 VSS.n300 VSS.n299 469.783
R989 VSS.n314 VSS.n313 469.783
R990 VSS.n665 VSS.t346 456.175
R991 VSS.n213 VSS.n210 454.007
R992 VSS.n230 VSS.n227 454.007
R993 VSS.n896 VSS.n895 454.007
R994 VSS.n270 VSS.n267 454.007
R995 VSS.n287 VSS.n284 454.007
R996 VSS.n875 VSS.n874 454.007
R997 VSS.n216 VSS.n215 453.986
R998 VSS.n233 VSS.n232 453.986
R999 VSS.n893 VSS.n892 453.986
R1000 VSS.n273 VSS.n272 453.986
R1001 VSS.n290 VSS.n289 453.986
R1002 VSS.n872 VSS.n871 453.986
R1003 VSS.n222 VSS.n216 453.986
R1004 VSS.n240 VSS.n233 453.986
R1005 VSS.n892 VSS.n247 453.986
R1006 VSS.n279 VSS.n273 453.986
R1007 VSS.n297 VSS.n290 453.986
R1008 VSS.n871 VSS.n304 453.986
R1009 VSS.t214 VSS.n255 448.228
R1010 VSS.t586 VSS.n192 442.469
R1011 VSS.t36 VSS.n194 437.62
R1012 VSS.n263 VSS.t216 431.863
R1013 VSS.t494 VSS.n59 427.695
R1014 VSS.n659 VSS.t212 427.219
R1015 VSS.t579 VSS.n264 419.459
R1016 VSS.t564 VSS.n311 413.68
R1017 VSS.t554 VSS.n296 413.68
R1018 VSS.t544 VSS.n278 413.68
R1019 VSS.t533 VSS.n257 413.68
R1020 VSS.t524 VSS.n239 413.68
R1021 VSS.t514 VSS.n221 413.68
R1022 VSS.n667 VSS.n666 412.791
R1023 VSS.n653 VSS.n67 412.791
R1024 VSS.n833 VSS.n832 412.522
R1025 VSS.n207 VSS.t37 403.072
R1026 VSS.t354 VSS.n680 401.591
R1027 VSS.n263 VSS.t213 397.313
R1028 VSS.n205 VSS.t288 391.555
R1029 VSS.t568 VSS.n834 388.781
R1030 VSS.t510 VSS.n222 385.798
R1031 VSS.t520 VSS.n240 385.798
R1032 VSS.t530 VSS.n247 385.798
R1033 VSS.t540 VSS.n279 385.798
R1034 VSS.t550 VSS.n297 385.798
R1035 VSS.t560 VSS.n304 385.798
R1036 VSS.n202 VSS.t497 384.887
R1037 VSS.n203 VSS.t320 380.038
R1038 VSS.t305 VSS.n60 375.276
R1039 VSS.t328 VSS.n667 372.094
R1040 VSS.t324 VSS.n653 372.094
R1041 VSS.t311 VSS.n672 363.339
R1042 VSS.t181 VSS.n658 363.339
R1043 VSS.t189 VSS.t567 359.769
R1044 VSS.t317 VSS.n198 357.007
R1045 VSS.n649 VSS.t342 347.49
R1046 VSS.t318 VSS.n196 333.974
R1047 VSS.n202 VSS.t34 333.065
R1048 VSS.t515 VSS.n221 333.063
R1049 VSS.t525 VSS.n239 333.063
R1050 VSS.t534 VSS.n257 333.063
R1051 VSS.t545 VSS.n278 333.063
R1052 VSS.t555 VSS.n296 333.063
R1053 VSS.n311 VSS.t565 333.063
R1054 VSS.t410 VSS.n608 329.238
R1055 VSS.n809 VSS.t135 327.81
R1056 VSS.t379 VSS.n190 322.457
R1057 VSS.n266 VSS.t503 322.457
R1058 VSS.t250 VSS.n852 314.327
R1059 VSS.n683 VSS.t390 313.659
R1060 VSS.n215 VSS.t508 305.183
R1061 VSS.n232 VSS.t518 305.183
R1062 VSS.n893 VSS.t528 305.183
R1063 VSS.n272 VSS.t538 305.183
R1064 VSS.n289 VSS.t548 305.183
R1065 VSS.n872 VSS.t558 305.183
R1066 VSS.t614 VSS.t240 304.42
R1067 VSS.t596 VSS.n670 304.42
R1068 VSS.t185 VSS.t231 304.42
R1069 VSS.t355 VSS.n656 304.42
R1070 VSS.t599 VSS.n682 299.735
R1071 VSS.n206 VSS.t585 299.425
R1072 VSS.t505 VSS.n213 293.666
R1073 VSS.t516 VSS.n230 293.666
R1074 VSS.n895 VSS.t526 293.666
R1075 VSS.t535 VSS.n270 293.666
R1076 VSS.t546 VSS.n287 293.666
R1077 VSS.n874 VSS.t556 293.666
R1078 VSS.n315 VSS.t165 292.757
R1079 VSS.t359 VSS.n295 292.757
R1080 VSS.t176 VSS.n277 292.757
R1081 VSS.t573 VSS.n253 292.757
R1082 VSS.t314 VSS.n256 292.757
R1083 VSS.t31 VSS.n238 292.757
R1084 VSS.t173 VSS.n220 292.757
R1085 VSS.t571 VSS.n188 292.757
R1086 VSS.t592 VSS.n669 291.37
R1087 VSS.t406 VSS.n655 291.37
R1088 VSS.n206 VSS.t498 287.909
R1089 VSS.n209 VSS.t326 275.505
R1090 VSS.t211 VSS.n192 269.724
R1091 VSS.t380 VSS.n190 264.875
R1092 VSS.n266 VSS.t504 264.875
R1093 VSS.t166 VSS.n309 258.238
R1094 VSS.n262 VSS.t315 258.236
R1095 VSS.n875 VSS.t360 258.233
R1096 VSS.n896 VSS.t32 258.233
R1097 VSS.n210 VSS.t572 258.233
R1098 VSS.n227 VSS.t174 258.233
R1099 VSS.n267 VSS.t574 258.233
R1100 VSS.n284 VSS.t177 258.233
R1101 VSS.t290 VSS.n195 258.231
R1102 VSS.t210 VSS.n196 253.359
R1103 VSS.t570 VSS.n101 252.375
R1104 VSS.n114 VSS.t226 252.375
R1105 VSS.t330 VSS.n116 252.375
R1106 VSS.t493 VSS.n121 252.375
R1107 VSS.n125 VSS.t490 252.375
R1108 VSS.t578 VSS.n128 252.375
R1109 VSS.t247 VSS.n131 252.375
R1110 VSS.n135 VSS.t160 252.375
R1111 VSS.n108 VSS.t219 252.375
R1112 VSS.t566 VSS.n144 252.375
R1113 VSS.n153 VSS.t179 252.375
R1114 VSS.t575 VSS.n96 252.375
R1115 VSS.n175 VSS.t17 252.374
R1116 VSS.n171 VSS.t407 252.374
R1117 VSS.n168 VSS.t459 252.374
R1118 VSS.n165 VSS.t155 252.374
R1119 VSS.n163 VSS.t363 252.374
R1120 VSS.t353 VSS.n112 252.117
R1121 VSS.t235 VSS.n126 252.117
R1122 VSS.n129 VSS.t180 252.117
R1123 VSS.t458 VSS.n136 252.117
R1124 VSS.t220 VSS.n139 252.117
R1125 VSS.t384 VSS.n106 252.117
R1126 VSS.n105 VSS.t480 252.117
R1127 VSS.n147 VSS.t428 252.117
R1128 VSS.t225 VSS.n100 252.117
R1129 VSS.t150 VSS.n149 252.117
R1130 VSS.t364 VSS.n152 252.117
R1131 VSS.n179 VSS.t491 252.115
R1132 VSS.n176 VSS.t244 252.115
R1133 VSS.n170 VSS.t236 252.115
R1134 VSS.n160 VSS.t341 252.115
R1135 VSS.t107 VSS.n357 250.837
R1136 VSS.t46 VSS.n358 250.837
R1137 VSS.t103 VSS.n362 250.837
R1138 VSS.t96 VSS.n363 250.837
R1139 VSS.t94 VSS.n367 250.837
R1140 VSS.t40 VSS.n368 250.837
R1141 VSS.t101 VSS.n372 250.837
R1142 VSS.t99 VSS.n373 250.837
R1143 VSS.t49 VSS.n377 250.837
R1144 VSS.t109 VSS.n378 250.837
R1145 VSS.t56 VSS.n382 250.837
R1146 VSS.t55 VSS.n383 250.837
R1147 VSS.t112 VSS.n387 250.837
R1148 VSS.t110 VSS.n388 250.837
R1149 VSS.t105 VSS.n392 250.837
R1150 VSS.t48 VSS.n393 250.837
R1151 VSS.t118 VSS.n397 250.837
R1152 VSS.t44 VSS.n398 250.837
R1153 VSS.t42 VSS.n402 250.837
R1154 VSS.t39 VSS.n403 250.837
R1155 VSS.t120 VSS.n407 250.837
R1156 VSS.t122 VSS.n408 250.837
R1157 VSS.t116 VSS.n412 250.837
R1158 VSS.t114 VSS.n413 250.837
R1159 VSS.t97 VSS.n417 250.837
R1160 VSS.t51 VSS.n418 250.837
R1161 VSS.t58 VSS.n422 250.837
R1162 VSS.t124 VSS.n423 250.837
R1163 VSS.t126 VSS.n427 250.837
R1164 VSS.t53 VSS.n428 250.837
R1165 VSS.t128 VSS.n432 250.837
R1166 VSS.t130 VSS.n433 250.837
R1167 VSS.t494 VSS.n61 148.06
R1168 VSS.t212 VSS.n66 148.06
R1169 VSS.n649 VSS.t410 243.244
R1170 VSS.n201 VSS.t209 240.956
R1171 VSS.t512 VSS.n223 240.956
R1172 VSS.t522 VSS.n241 240.956
R1173 VSS.t532 VSS.n258 240.956
R1174 VSS.t542 VSS.n280 240.956
R1175 VSS.t552 VSS.n298 240.956
R1176 VSS.t562 VSS.n312 240.956
R1177 VSS.n516 VSS.t431 234.114
R1178 VSS.n511 VSS.t602 234.114
R1179 VSS.n506 VSS.t310 234.114
R1180 VSS.n501 VSS.t576 234.114
R1181 VSS.n496 VSS.t21 234.114
R1182 VSS.n491 VSS.t382 234.114
R1183 VSS.n486 VSS.t588 234.114
R1184 VSS.n481 VSS.t4 234.114
R1185 VSS.n476 VSS.t336 234.114
R1186 VSS.n471 VSS.t8 234.114
R1187 VSS.n466 VSS.t193 234.114
R1188 VSS.n461 VSS.t496 234.114
R1189 VSS.n456 VSS.t420 234.114
R1190 VSS.n451 VSS.t229 234.114
R1191 VSS.n446 VSS.t300 234.114
R1192 VSS.n441 VSS.t411 234.114
R1193 VSS.t319 VSS.n198 230.327
R1194 VSS.n224 VSS.t512 229.44
R1195 VSS.n242 VSS.t522 229.44
R1196 VSS.n259 VSS.t532 229.44
R1197 VSS.n281 VSS.t542 229.44
R1198 VSS.n299 VSS.t552 229.44
R1199 VSS.n313 VSS.t562 229.44
R1200 VSS.t209 VSS.n200 228.827
R1201 VSS.t478 VSS.n117 225.361
R1202 VSS.t429 VSS.n119 225.361
R1203 VSS.t603 VSS.n123 225.361
R1204 VSS.t308 VSS.n127 225.361
R1205 VSS.t577 VSS.n110 225.361
R1206 VSS.t23 VSS.n133 225.361
R1207 VSS.t381 VSS.n137 225.361
R1208 VSS.t587 VSS.n140 225.361
R1209 VSS.t335 VSS.n104 225.361
R1210 VSS.t10 VSS.n103 225.361
R1211 VSS.t191 VSS.n102 225.361
R1212 VSS.t421 VSS.n150 225.361
R1213 VSS.n174 VSS.t6 225.359
R1214 VSS.n166 VSS.t495 225.359
R1215 VSS.n162 VSS.t228 225.359
R1216 VSS.n159 VSS.t301 225.359
R1217 VSS.t342 VSS.n648 224.516
R1218 VSS.t418 VSS.n38 216.093
R1219 VSS.n852 VSS.t418 215.731
R1220 VSS.t572 VSS.n188 212.143
R1221 VSS.t174 VSS.n220 212.143
R1222 VSS.t32 VSS.n238 212.143
R1223 VSS.t315 VSS.n256 212.143
R1224 VSS.t574 VSS.n253 212.143
R1225 VSS.t177 VSS.n277 212.143
R1226 VSS.t360 VSS.n295 212.143
R1227 VSS.n315 VSS.t166 212.143
R1228 VSS.n178 VSS.t200 211.982
R1229 VSS.n172 VSS.t293 211.982
R1230 VSS.n169 VSS.t372 211.982
R1231 VSS.n167 VSS.t413 211.982
R1232 VSS.n161 VSS.t206 211.982
R1233 VSS.n158 VSS.t365 211.982
R1234 VSS.n118 VSS.t400 211.982
R1235 VSS.n120 VSS.t589 211.982
R1236 VSS.n124 VSS.t487 211.982
R1237 VSS.n130 VSS.t403 211.982
R1238 VSS.n134 VSS.t203 211.982
R1239 VSS.n138 VSS.t604 211.982
R1240 VSS.n141 VSS.t464 211.982
R1241 VSS.n143 VSS.t422 211.982
R1242 VSS.t607 VSS.n99 211.982
R1243 VSS.t455 VSS.n98 211.982
R1244 VSS.n681 VSS.t354 208.828
R1245 VSS.n203 VSS.t319 207.294
R1246 VSS.n683 VSS.t599 202.362
R1247 VSS.n668 VSS.t328 202.071
R1248 VSS.n654 VSS.t324 202.071
R1249 VSS.n197 VSS.t210 200.649
R1250 VSS.n601 VSS.n0 197.518
R1251 VSS.n673 VSS.t305 196.911
R1252 VSS.n670 VSS.t592 196.399
R1253 VSS.n656 VSS.t406 196.399
R1254 VSS.n205 VSS.t290 195.778
R1255 VSS.t612 VSS.n113 195.26
R1256 VSS.t344 VSS.n122 195.26
R1257 VSS.t285 VSS.n111 195.26
R1258 VSS.t619 VSS.n132 195.26
R1259 VSS.t621 VSS.n109 195.26
R1260 VSS.t463 VSS.n107 195.26
R1261 VSS.t133 VSS.n142 195.26
R1262 VSS.t435 VSS.n145 195.26
R1263 VSS.t397 VSS.n146 195.26
R1264 VSS.t393 VSS.n148 195.26
R1265 VSS.t485 VSS.n151 195.26
R1266 VSS.t386 VSS.n97 195.26
R1267 VSS.n177 VSS.t425 195.26
R1268 VSS.n173 VSS.t296 195.26
R1269 VSS.n164 VSS.t396 195.26
R1270 VSS.n157 VSS.t237 195.26
R1271 VSS.t326 VSS.n189 194.899
R1272 VSS.n835 VSS.t568 194.514
R1273 VSS.t504 VSS.n254 189.137
R1274 VSS.n209 VSS.t380 189.135
R1275 VSS.t390 VSS.n602 187.895
R1276 VSS.n517 VSS.t432 187.292
R1277 VSS.n512 VSS.t332 187.292
R1278 VSS.n507 VSS.t331 187.292
R1279 VSS.n502 VSS.t377 187.292
R1280 VSS.n497 VSS.t198 187.292
R1281 VSS.n492 VSS.t156 187.292
R1282 VSS.n487 VSS.t375 187.292
R1283 VSS.n482 VSS.t483 187.292
R1284 VSS.n477 VSS.t241 187.292
R1285 VSS.n472 VSS.t584 187.292
R1286 VSS.n467 VSS.t454 187.292
R1287 VSS.n462 VSS.t321 187.292
R1288 VSS.n457 VSS.t298 187.292
R1289 VSS.n452 VSS.t161 187.292
R1290 VSS.n447 VSS.t601 187.292
R1291 VSS.n442 VSS.t416 187.292
R1292 VSS.n207 VSS.t211 184.262
R1293 VSS.t246 VSS.n665 183.975
R1294 VSS.n671 VSS.t596 182.797
R1295 VSS.n657 VSS.t355 182.797
R1296 VSS.n5 VSS.t194 177.713
R1297 VSS.n189 VSS.t571 177.617
R1298 VSS.n254 VSS.t573 177.617
R1299 VSS.n226 VSS.t173 177.615
R1300 VSS.n244 VSS.t31 177.615
R1301 VSS.n261 VSS.t314 177.615
R1302 VSS.n283 VSS.t176 177.615
R1303 VSS.n301 VSS.t359 177.615
R1304 VSS.t165 VSS.n310 177.615
R1305 VSS.t469 VSS.n361 173.913
R1306 VSS.n366 VSS.t501 173.913
R1307 VSS.t369 VSS.n371 173.913
R1308 VSS.t233 VSS.n376 173.913
R1309 VSS.t371 VSS.n381 173.913
R1310 VSS.t29 VSS.n386 173.913
R1311 VSS.t348 VSS.n391 173.913
R1312 VSS.n396 VSS.t13 173.913
R1313 VSS.n401 VSS.t196 173.913
R1314 VSS.t474 VSS.n406 173.913
R1315 VSS.t292 VSS.n411 173.913
R1316 VSS.n416 VSS.t169 173.913
R1317 VSS.t351 VSS.n421 173.913
R1318 VSS.t15 VSS.n426 173.913
R1319 VSS.t618 VSS.n431 173.913
R1320 VSS.t26 VSS.n436 173.913
R1321 VSS.n439 VSS.n438 173.913
R1322 VSS.t187 VSS.n652 167.954
R1323 VSS.t401 VSS.t611 163.881
R1324 VSS.t590 VSS.t345 163.881
R1325 VSS.t488 VSS.t287 163.881
R1326 VSS.t201 VSS.t426 163.881
R1327 VSS.t404 VSS.t620 163.881
R1328 VSS.t204 VSS.t622 163.881
R1329 VSS.t605 VSS.t462 163.881
R1330 VSS.t465 VSS.t132 163.881
R1331 VSS.t423 VSS.t297 163.881
R1332 VSS.t294 VSS.t434 163.881
R1333 VSS.t373 VSS.t399 163.881
R1334 VSS.t414 VSS.t394 163.881
R1335 VSS.t608 VSS.t395 163.881
R1336 VSS.t456 VSS.t486 163.881
R1337 VSS.t207 VSS.t385 163.881
R1338 VSS.t366 VSS.t239 163.881
R1339 VSS.n214 VSS.t505 160.341
R1340 VSS.n231 VSS.t516 160.341
R1341 VSS.n245 VSS.t526 160.341
R1342 VSS.n271 VSS.t535 160.341
R1343 VSS.n288 VSS.t546 160.341
R1344 VSS.n302 VSS.t556 160.341
R1345 VSS.t476 VSS.n183 157.601
R1346 VSS.n184 VSS.t472 156.464
R1347 VSS.t164 VSS.n118 155.126
R1348 VSS.t163 VSS.n120 155.126
R1349 VSS.t437 VSS.n124 155.126
R1350 VSS.t479 VSS.n130 155.126
R1351 VSS.t245 VSS.n134 155.126
R1352 VSS.t484 VSS.n138 155.126
R1353 VSS.t439 VSS.n141 155.126
R1354 VSS.t438 VSS.n143 155.126
R1355 VSS.t594 VSS.n99 155.126
R1356 VSS.t362 VSS.n98 155.126
R1357 VSS.n178 VSS.t323 155.125
R1358 VSS.n172 VSS.t499 155.125
R1359 VSS.n169 VSS.t461 155.125
R1360 VSS.n167 VSS.t151 155.125
R1361 VSS.n161 VSS.t334 155.125
R1362 VSS.n158 VSS.t482 155.125
R1363 VSS.n574 VSS.t260 154.613
R1364 VSS.n585 VSS.t267 154.613
R1365 VSS.t585 VSS.n193 153.971
R1366 VSS.n184 VSS.t20 153.851
R1367 VSS.n526 VSS.t223 153.846
R1368 VSS.n517 VSS.t468 153.846
R1369 VSS.n512 VSS.t500 153.846
R1370 VSS.n507 VSS.t368 153.846
R1371 VSS.n502 VSS.t232 153.846
R1372 VSS.n497 VSS.t370 153.846
R1373 VSS.n492 VSS.t28 153.846
R1374 VSS.n487 VSS.t347 153.846
R1375 VSS.n482 VSS.t12 153.846
R1376 VSS.n477 VSS.t195 153.846
R1377 VSS.n472 VSS.t473 153.846
R1378 VSS.n467 VSS.t291 153.846
R1379 VSS.n462 VSS.t168 153.846
R1380 VSS.n457 VSS.t350 153.846
R1381 VSS.n452 VSS.t14 153.846
R1382 VSS.n447 VSS.t617 153.846
R1383 VSS.n442 VSS.t25 153.846
R1384 VSS.t477 VSS.n95 153.236
R1385 VSS.t498 VSS.n194 149.713
R1386 VSS.t508 VSS.n214 148.826
R1387 VSS.t518 VSS.n231 148.826
R1388 VSS.t528 VSS.n245 148.826
R1389 VSS.t538 VSS.n271 148.826
R1390 VSS.t548 VSS.n288 148.826
R1391 VSS.t558 VSS.n302 148.826
R1392 VSS.n4 VSS.t218 147.452
R1393 VSS.t171 VSS.n360 147.157
R1394 VSS.t2 VSS.n365 147.157
R1395 VSS.t172 VSS.n370 147.157
R1396 VSS.t595 VSS.n375 147.157
R1397 VSS.t610 VSS.n380 147.157
R1398 VSS.t0 VSS.n385 147.157
R1399 VSS.t159 VSS.n390 147.157
R1400 VSS.t230 VSS.n395 147.157
R1401 VSS.t467 VSS.n400 147.157
R1402 VSS.t227 VSS.n405 147.157
R1403 VSS.t313 VSS.n410 147.157
R1404 VSS.t383 VSS.n415 147.157
R1405 VSS.t417 VSS.n420 147.157
R1406 VSS.t303 VSS.n425 147.157
R1407 VSS.t248 VSS.n430 147.157
R1408 VSS.t460 VSS.n435 147.157
R1409 VSS.t283 VSS.n154 145.091
R1410 VSS.t240 VSS.n671 138.607
R1411 VSS.t231 VSS.n657 138.607
R1412 VSS.t279 VSS.n154 138.403
R1413 VSS.t565 VSS.n310 137.311
R1414 VSS.n301 VSS.t555 137.311
R1415 VSS.n283 VSS.t545 137.311
R1416 VSS.n261 VSS.t534 137.311
R1417 VSS.n244 VSS.t525 137.311
R1418 VSS.n226 VSS.t515 137.311
R1419 VSS.t34 VSS.n201 137.309
R1420 VSS.n647 VSS.n610 132.891
R1421 VSS.n156 VSS.t279 131.971
R1422 VSS.n191 VSS.t379 130.939
R1423 VSS.t503 VSS.n265 130.939
R1424 VSS.n861 VSS.t147 127.421
R1425 VSS.t81 VSS.n1 125.359
R1426 VSS.t358 VSS.n857 123.674
R1427 VSS.n602 VSS.n601 122.129
R1428 VSS.n604 VSS.t189 121.858
R1429 VSS.t472 VSS.n95 120.691
R1430 VSS.n204 VSS.t318 119.422
R1431 VSS.n181 VSS.t475 118.249
R1432 VSS.n439 VSS.t283 117.058
R1433 VSS.n856 VSS.t389 116.177
R1434 VSS.t346 VSS.n664 115.831
R1435 VSS.t337 VSS.n594 112.174
R1436 VSS.t388 VSS.n859 108.683
R1437 VSS.n647 VSS.n646 107.178
R1438 VSS.n519 VSS.t164 107.023
R1439 VSS.n516 VSS.t171 107.023
R1440 VSS.n514 VSS.t163 107.023
R1441 VSS.n511 VSS.t2 107.023
R1442 VSS.n509 VSS.t437 107.023
R1443 VSS.n506 VSS.t172 107.023
R1444 VSS.t323 VSS.n504 107.023
R1445 VSS.n501 VSS.t595 107.023
R1446 VSS.n499 VSS.t479 107.023
R1447 VSS.n496 VSS.t610 107.023
R1448 VSS.n494 VSS.t245 107.023
R1449 VSS.n491 VSS.t0 107.023
R1450 VSS.n489 VSS.t484 107.023
R1451 VSS.n486 VSS.t159 107.023
R1452 VSS.n484 VSS.t439 107.023
R1453 VSS.n481 VSS.t230 107.023
R1454 VSS.n479 VSS.t438 107.023
R1455 VSS.n476 VSS.t467 107.023
R1456 VSS.t499 VSS.n474 107.023
R1457 VSS.n471 VSS.t227 107.023
R1458 VSS.t461 VSS.n469 107.023
R1459 VSS.n466 VSS.t313 107.023
R1460 VSS.t151 VSS.n464 107.023
R1461 VSS.n461 VSS.t383 107.023
R1462 VSS.n459 VSS.t594 107.023
R1463 VSS.n456 VSS.t417 107.023
R1464 VSS.n454 VSS.t362 107.023
R1465 VSS.n451 VSS.t303 107.023
R1466 VSS.t334 VSS.n449 107.023
R1467 VSS.n446 VSS.t248 107.023
R1468 VSS.t482 VSS.n444 107.023
R1469 VSS.n441 VSS.t460 107.023
R1470 VSS.t339 VSS.n854 106.808
R1471 VSS.n678 VSS.t481 103.538
R1472 VSS.n685 VSS.t593 103.379
R1473 VSS.n526 VSS.t273 100.335
R1474 VSS.t468 VSS.n360 100.335
R1475 VSS.t500 VSS.n365 100.335
R1476 VSS.t368 VSS.n370 100.335
R1477 VSS.t232 VSS.n375 100.335
R1478 VSS.t370 VSS.n380 100.335
R1479 VSS.t28 VSS.n385 100.335
R1480 VSS.t347 VSS.n390 100.335
R1481 VSS.t12 VSS.n395 100.335
R1482 VSS.t195 VSS.n400 100.335
R1483 VSS.t473 VSS.n405 100.335
R1484 VSS.t291 VSS.n410 100.335
R1485 VSS.t168 VSS.n415 100.335
R1486 VSS.t350 VSS.n420 100.335
R1487 VSS.t14 VSS.n425 100.335
R1488 VSS.t617 VSS.n430 100.335
R1489 VSS.t25 VSS.n435 100.335
R1490 VSS.n574 VSS.t263 99.7511
R1491 VSS.n585 VSS.t269 99.7511
R1492 VSS.n684 VSS.t598 98.4633
R1493 VSS.t263 VSS.n1 97.9284
R1494 VSS.t269 VSS.n3 97.9279
R1495 VSS.t158 VSS.n663 97.5777
R1496 VSS.t18 VSS.n863 97.4396
R1497 VSS.n199 VSS.t317 96.3896
R1498 VSS.n183 VSS.t149 93.8889
R1499 VSS.n863 VSS.t340 93.6919
R1500 VSS.n156 VSS.t26 88.495
R1501 VSS.n180 VSS.t470 88.4111
R1502 VSS.t391 VSS.n681 88.3462
R1503 VSS.n179 VSS.t469 88.2366
R1504 VSS.n176 VSS.t371 88.2366
R1505 VSS.n170 VSS.t474 88.2366
R1506 VSS.n160 VSS.t618 88.2366
R1507 VSS.t501 VSS.n112 88.2359
R1508 VSS.n126 VSS.t369 88.2359
R1509 VSS.n129 VSS.t233 88.2359
R1510 VSS.n136 VSS.t29 88.2359
R1511 VSS.n139 VSS.t348 88.2359
R1512 VSS.t13 VSS.n106 88.2359
R1513 VSS.t196 VSS.n105 88.2359
R1514 VSS.n147 VSS.t292 88.2359
R1515 VSS.t169 VSS.n100 88.2359
R1516 VSS.n149 VSS.t351 88.2359
R1517 VSS.n152 VSS.t15 88.2359
R1518 VSS.t273 VSS.t221 86.957
R1519 VSS.t223 VSS.t275 86.957
R1520 VSS.t597 VSS.n668 85.7923
R1521 VSS.t356 VSS.n654 85.7923
R1522 VSS.t497 VSS.n199 84.8733
R1523 VSS.t470 VSS.n528 83.0562
R1524 VSS.n859 VSS.t471 82.449
R1525 VSS.t392 VSS.n679 81.2384
R1526 VSS.n2 VSS.t81 80.4712
R1527 VSS.t580 VSS.n698 77.8798
R1528 VSS.n833 VSS.t492 77.2751
R1529 VSS.t243 VSS.t183 77.2751
R1530 VSS.n834 VSS.t567 75.4357
R1531 VSS.t471 VSS.n182 75.2962
R1532 VSS.t357 VSS.n856 74.9537
R1533 VSS.t221 VSS.n115 74.8587
R1534 VSS.n615 VSS.t304 74.7824
R1535 VSS.t320 VSS.n197 73.9692
R1536 VSS.t186 VSS.n595 73.536
R1537 VSS.n600 VSS.n596 73.536
R1538 VSS.n519 VSS.t401 70.2346
R1539 VSS.n514 VSS.t590 70.2346
R1540 VSS.n509 VSS.t488 70.2346
R1541 VSS.n504 VSS.t201 70.2346
R1542 VSS.n499 VSS.t404 70.2346
R1543 VSS.n494 VSS.t204 70.2346
R1544 VSS.n489 VSS.t605 70.2346
R1545 VSS.n484 VSS.t465 70.2346
R1546 VSS.n479 VSS.t423 70.2346
R1547 VSS.n474 VSS.t294 70.2346
R1548 VSS.n469 VSS.t373 70.2346
R1549 VSS.n464 VSS.t414 70.2346
R1550 VSS.n459 VSS.t608 70.2346
R1551 VSS.n454 VSS.t456 70.2346
R1552 VSS.n449 VSS.t207 70.2346
R1553 VSS.n444 VSS.t366 70.2346
R1554 VSS.n758 VSS.t444 69.1047
R1555 VSS.n223 VSS.t510 68.211
R1556 VSS.n241 VSS.t520 68.211
R1557 VSS.n258 VSS.t530 68.211
R1558 VSS.n280 VSS.t540 68.211
R1559 VSS.n298 VSS.t550 68.211
R1560 VSS.n312 VSS.t560 68.211
R1561 VSS.n857 VSS.t357 67.4583
R1562 VSS.t582 VSS.n714 66.9109
R1563 VSS.n518 VSS.t612 66.8901
R1564 VSS.t432 VSS.n358 66.8901
R1565 VSS.n513 VSS.t344 66.8901
R1566 VSS.t332 VSS.n363 66.8901
R1567 VSS.n508 VSS.t285 66.8901
R1568 VSS.t331 VSS.n368 66.8901
R1569 VSS.t425 VSS.n503 66.8901
R1570 VSS.t377 VSS.n373 66.8901
R1571 VSS.n498 VSS.t619 66.8901
R1572 VSS.t198 VSS.n378 66.8901
R1573 VSS.n493 VSS.t621 66.8901
R1574 VSS.t156 VSS.n383 66.8901
R1575 VSS.n488 VSS.t463 66.8901
R1576 VSS.t375 VSS.n388 66.8901
R1577 VSS.n483 VSS.t133 66.8901
R1578 VSS.t483 VSS.n393 66.8901
R1579 VSS.t296 VSS.n478 66.8901
R1580 VSS.t241 VSS.n398 66.8901
R1581 VSS.n473 VSS.t435 66.8901
R1582 VSS.t584 VSS.n403 66.8901
R1583 VSS.n468 VSS.t397 66.8901
R1584 VSS.t454 VSS.n408 66.8901
R1585 VSS.n463 VSS.t393 66.8901
R1586 VSS.t321 VSS.n413 66.8901
R1587 VSS.t396 VSS.n458 66.8901
R1588 VSS.t298 VSS.n418 66.8901
R1589 VSS.n453 VSS.t485 66.8901
R1590 VSS.t161 VSS.n423 66.8901
R1591 VSS.n448 VSS.t386 66.8901
R1592 VSS.t601 VSS.n428 66.8901
R1593 VSS.t237 VSS.n443 66.8901
R1594 VSS.t416 VSS.n433 66.8901
R1595 VSS.t71 VSS.n640 65.3669
R1596 VSS.n646 VSS.t60 65.3649
R1597 VSS.t149 VSS.n861 63.7107
R1598 VSS.t340 VSS.n862 62.4441
R1599 VSS.n639 VSS.t75 62.1568
R1600 VSS.t288 VSS.n204 61.8407
R1601 VSS.n600 VSS.n599 59.3547
R1602 VSS.n864 VSS.t18 58.6964
R1603 VSS.n738 VSS.t449 58.1358
R1604 VSS.t304 VSS.n610 58.1084
R1605 VSS.t218 VSS.n3 58.0271
R1606 VSS.n660 VSS.t152 57.9156
R1607 VSS.t213 VSS.n255 56.6734
R1608 VSS.n225 VSS.t514 56.0825
R1609 VSS.n243 VSS.t524 56.0825
R1610 VSS.n260 VSS.t533 56.0825
R1611 VSS.n282 VSS.t544 56.0825
R1612 VSS.n300 VSS.t554 56.0825
R1613 VSS.n314 VSS.t564 56.0825
R1614 VSS.t446 VSS.n730 55.942
R1615 VSS.t67 VSS.n642 55.7341
R1616 VSS.n644 VSS.t65 55.7328
R1617 VSS.t475 VSS.n180 54.6841
R1618 VSS.t250 VSS.n531 53.7482
R1619 VSS.n615 VSS.t569 52.3478
R1620 VSS.t427 VSS.n59 51.2456
R1621 VSS.t37 VSS.n191 50.3244
R1622 VSS.n265 VSS.t579 50.3244
R1623 VSS.t400 VSS.n357 50.1677
R1624 VSS.t589 VSS.n362 50.1677
R1625 VSS.t487 VSS.n367 50.1677
R1626 VSS.t200 VSS.n372 50.1677
R1627 VSS.t403 VSS.n377 50.1677
R1628 VSS.t203 VSS.n382 50.1677
R1629 VSS.t604 VSS.n387 50.1677
R1630 VSS.t464 VSS.n392 50.1677
R1631 VSS.t422 VSS.n397 50.1677
R1632 VSS.t293 VSS.n402 50.1677
R1633 VSS.t372 VSS.n407 50.1677
R1634 VSS.t413 VSS.n412 50.1677
R1635 VSS.n417 VSS.t607 50.1677
R1636 VSS.n422 VSS.t455 50.1677
R1637 VSS.t206 VSS.n427 50.1677
R1638 VSS.t365 VSS.n432 50.1677
R1639 VSS.n772 VSS.t253 49.3606
R1640 VSS.n860 VSS.t388 47.4535
R1641 VSS.t581 VSS.n705 47.1669
R1642 VSS.n722 VSS.t583 47.1669
R1643 VSS.n684 VSS.t186 46.116
R1644 VSS.t63 VSS.n644 46.1002
R1645 VSS.n642 VSS.t69 46.0991
R1646 VSS.t442 VSS.n748 44.9731
R1647 VSS.n672 VSS.t614 44.1903
R1648 VSS.n658 VSS.t185 44.1903
R1649 VSS.t267 VSS.n2 43.0632
R1650 VSS.t260 VSS.n0 43.0619
R1651 VSS.t492 VSS.n594 42.3769
R1652 VSS.t389 VSS.n855 39.9582
R1653 VSS.t73 VSS.n639 39.6815
R1654 VSS.n661 VSS.t217 39.1873
R1655 VSS.n749 VSS.t442 38.3917
R1656 VSS.n521 VSS.t478 36.7898
R1657 VSS.n515 VSS.t429 36.7898
R1658 VSS.n510 VSS.t603 36.7898
R1659 VSS.n505 VSS.t308 36.7898
R1660 VSS.n500 VSS.t577 36.7898
R1661 VSS.n495 VSS.t23 36.7898
R1662 VSS.n490 VSS.t381 36.7898
R1663 VSS.n485 VSS.t587 36.7898
R1664 VSS.t6 VSS.n480 36.7898
R1665 VSS.n475 VSS.t335 36.7898
R1666 VSS.n470 VSS.t10 36.7898
R1667 VSS.n465 VSS.t191 36.7898
R1668 VSS.t495 VSS.n460 36.7898
R1669 VSS.n455 VSS.t421 36.7898
R1670 VSS.t228 VSS.n450 36.7898
R1671 VSS.t301 VSS.n445 36.7898
R1672 VSS.n853 VSS.t250 36.5305
R1673 VSS.n640 VSS.t73 36.4667
R1674 VSS.n855 VSS.t339 36.2105
R1675 VSS.n706 VSS.t581 36.1979
R1676 VSS.t583 VSS.n721 36.1979
R1677 VSS.n182 VSS.t358 34.07
R1678 VSS.t253 VSS.n768 34.0042
R1679 VSS.t600 VSS.n678 33.9067
R1680 VSS.t593 VSS.n595 31.1596
R1681 VSS.t69 VSS.n641 30.0455
R1682 VSS.n645 VSS.t63 30.0445
R1683 VSS.t147 VSS.n860 28.7152
R1684 VSS.n854 VSS.n181 28.3058
R1685 VSS.t345 VSS.n121 28.2938
R1686 VSS.t287 VSS.n125 28.2938
R1687 VSS.t620 VSS.n131 28.2938
R1688 VSS.t622 VSS.n135 28.2938
R1689 VSS.t462 VSS.n108 28.2938
R1690 VSS.t297 VSS.n144 28.2938
R1691 VSS.t611 VSS.n114 28.2938
R1692 VSS.t426 VSS.n128 28.2938
R1693 VSS.t394 VSS.n101 28.2938
R1694 VSS.t385 VSS.n153 28.2938
R1695 VSS.t239 VSS.n96 28.2938
R1696 VSS.t132 VSS.n175 28.2936
R1697 VSS.t434 VSS.n171 28.2936
R1698 VSS.t399 VSS.n168 28.2936
R1699 VSS.t395 VSS.n165 28.2936
R1700 VSS.t486 VSS.n163 28.2936
R1701 VSS.n115 VSS.t477 28.0352
R1702 VSS.t194 VSS.n4 27.7523
R1703 VSS.t440 VSS.n661 27.6043
R1704 VSS.n731 VSS.t446 27.4228
R1705 VSS.n193 VSS.t586 27.2918
R1706 VSS.t449 VSS.n737 25.229
R1707 VSS.t183 VSS.n599 24.4565
R1708 VSS.n685 VSS.t337 22.3643
R1709 VSS.t616 VSS.n662 22.2881
R1710 VSS.n608 VSS.t408 22.2881
R1711 VSS.n264 VSS.t214 22.1486
R1712 VSS.t216 VSS.n262 22.1466
R1713 VSS.t275 VSS.n116 21.6048
R1714 VSS.t598 VSS.n596 21.1887
R1715 VSS.t65 VSS.n643 20.4123
R1716 VSS.n643 VSS.t67 20.4103
R1717 VSS.t431 VSS.n361 20.0674
R1718 VSS.t602 VSS.n366 20.0674
R1719 VSS.t310 VSS.n371 20.0674
R1720 VSS.t576 VSS.n376 20.0674
R1721 VSS.t21 VSS.n381 20.0674
R1722 VSS.t382 VSS.n386 20.0674
R1723 VSS.t588 VSS.n391 20.0674
R1724 VSS.t4 VSS.n396 20.0674
R1725 VSS.t336 VSS.n401 20.0674
R1726 VSS.t8 VSS.n406 20.0674
R1727 VSS.t193 VSS.n411 20.0674
R1728 VSS.t496 VSS.n416 20.0674
R1729 VSS.t420 VSS.n421 20.0674
R1730 VSS.t229 VSS.n426 20.0674
R1731 VSS.t300 VSS.n431 20.0674
R1732 VSS.t411 VSS.n436 20.0674
R1733 VSS.t568 VSS.t569 19.9423
R1734 VSS.n177 VSS.t578 18.0025
R1735 VSS.n174 VSS.t384 18.0025
R1736 VSS.n173 VSS.t566 18.0025
R1737 VSS.n166 VSS.t225 18.0025
R1738 VSS.t155 VSS.n164 18.0025
R1739 VSS.n162 VSS.t364 18.0025
R1740 VSS.t341 VSS.n159 18.0025
R1741 VSS.n157 VSS.t575 18.0025
R1742 VSS.n117 VSS.t330 18.0017
R1743 VSS.t226 VSS.n113 18.0017
R1744 VSS.t491 VSS.n119 18.0017
R1745 VSS.n122 VSS.t493 18.0017
R1746 VSS.n123 VSS.t353 18.0017
R1747 VSS.t490 VSS.n111 18.0017
R1748 VSS.n127 VSS.t235 18.0017
R1749 VSS.t180 VSS.n110 18.0017
R1750 VSS.n132 VSS.t247 18.0017
R1751 VSS.t244 VSS.n133 18.0017
R1752 VSS.t160 VSS.n109 18.0017
R1753 VSS.n137 VSS.t458 18.0017
R1754 VSS.t219 VSS.n107 18.0017
R1755 VSS.n140 VSS.t220 18.0017
R1756 VSS.t17 VSS.n142 18.0017
R1757 VSS.t480 VSS.n104 18.0017
R1758 VSS.t407 VSS.n145 18.0017
R1759 VSS.t236 VSS.n103 18.0017
R1760 VSS.t459 VSS.n146 18.0017
R1761 VSS.t428 VSS.n102 18.0017
R1762 VSS.n148 VSS.t570 18.0017
R1763 VSS.n150 VSS.t150 18.0017
R1764 VSS.t363 VSS.n151 18.0017
R1765 VSS.t179 VSS.n97 18.0017
R1766 VSS.t20 VSS.n864 17.4722
R1767 VSS.n94 VSS.n529 17.0005
R1768 VSS.n94 VSS.n856 17.0005
R1769 VSS.n94 VSS.n857 17.0005
R1770 VSS.n94 VSS.n859 17.0005
R1771 VSS.n94 VSS.n861 17.0005
R1772 VSS.n94 VSS.n863 17.0005
R1773 VSS.n94 VSS.n527 17.0005
R1774 VSS.n94 VSS.t224 17.0005
R1775 VSS.n865 VSS.n94 17.0005
R1776 VSS.n94 VSS.n155 17.0005
R1777 VSS.n306 VSS.n304 17.0005
R1778 VSS.n870 VSS.n305 17.0005
R1779 VSS.n873 VSS.n872 17.0005
R1780 VSS.n874 VSS.n873 17.0005
R1781 VSS.n297 VSS.n291 17.0005
R1782 VSS.n879 VSS.n286 17.0005
R1783 VSS.n289 VSS.n285 17.0005
R1784 VSS.n287 VSS.n285 17.0005
R1785 VSS.n279 VSS.n274 17.0005
R1786 VSS.n885 VSS.n269 17.0005
R1787 VSS.n272 VSS.n268 17.0005
R1788 VSS.n270 VSS.n268 17.0005
R1789 VSS.n888 VSS.n266 17.0005
R1790 VSS.n888 VSS.n263 17.0005
R1791 VSS.n249 VSS.n247 17.0005
R1792 VSS.n891 VSS.n248 17.0005
R1793 VSS.n894 VSS.n893 17.0005
R1794 VSS.n895 VSS.n894 17.0005
R1795 VSS.n240 VSS.n234 17.0005
R1796 VSS.n900 VSS.n229 17.0005
R1797 VSS.n232 VSS.n228 17.0005
R1798 VSS.n230 VSS.n228 17.0005
R1799 VSS.n222 VSS.n217 17.0005
R1800 VSS.n906 VSS.n212 17.0005
R1801 VSS.n215 VSS.n211 17.0005
R1802 VSS.n213 VSS.n211 17.0005
R1803 VSS.n909 VSS.n190 17.0005
R1804 VSS.n909 VSS.n207 17.0005
R1805 VSS.n909 VSS.n206 17.0005
R1806 VSS.n909 VSS.n194 17.0005
R1807 VSS.n909 VSS.n205 17.0005
R1808 VSS.n909 VSS.n196 17.0005
R1809 VSS.n909 VSS.n203 17.0005
R1810 VSS.n909 VSS.n198 17.0005
R1811 VSS.n94 VSS.n352 17.0005
R1812 VSS.n94 VSS.n354 17.0005
R1813 VSS.t306 VSS.n673 17.0005
R1814 VSS.t306 VSS.n61 13.5064
R1815 VSS.n672 VSS.t329 17.0005
R1816 VSS.n670 VSS.t329 17.0005
R1817 VSS.n667 VSS.t329 17.0005
R1818 VSS.n664 VSS.n64 17.0005
R1819 VSS.n660 VSS.n64 17.0005
R1820 VSS.n66 VSS.n64 13.5064
R1821 VSS.n658 VSS.t325 17.0005
R1822 VSS.n656 VSS.t325 17.0005
R1823 VSS.n653 VSS.t325 17.0005
R1824 VSS.n652 VSS.n651 17.0005
R1825 VSS.n651 VSS.n649 17.0005
R1826 VSS.t338 VSS.n833 17.0005
R1827 VSS.t338 VSS.n594 17.0005
R1828 VSS.t338 VSS.n595 17.0005
R1829 VSS.t338 VSS.n684 17.0005
R1830 VSS.t338 VSS.n596 17.0005
R1831 VSS.t338 VSS.n683 17.0005
R1832 VSS.n616 VSS.n615 17.0005
R1833 VSS.n834 VSS.t338 17.0005
R1834 VSS.t338 VSS.n604 17.0005
R1835 VSS.t338 VSS.n679 17.0005
R1836 VSS.n8 VSS.n562 17.0005
R1837 VSS.n8 VSS.n566 17.0005
R1838 VSS.n8 VSS.n569 17.0005
R1839 VSS.n8 VSS.n584 17.0005
R1840 VSS.n8 VSS.n582 17.0005
R1841 VSS.n8 VSS.n6 17.0005
R1842 VSS.n769 VSS.n38 17.0005
R1843 VSS.n771 VSS.n38 17.0005
R1844 VSS.n772 VSS.n38 17.0005
R1845 VSS.n768 VSS.n38 17.0005
R1846 VSS.n766 VSS.n38 17.0005
R1847 VSS.n764 VSS.n38 17.0005
R1848 VSS.n762 VSS.n38 17.0005
R1849 VSS.n758 VSS.n38 17.0005
R1850 VSS.n757 VSS.n38 17.0005
R1851 VSS.n753 VSS.n38 17.0005
R1852 VSS.n751 VSS.n38 17.0005
R1853 VSS.n749 VSS.n38 17.0005
R1854 VSS.n748 VSS.n38 17.0005
R1855 VSS.n746 VSS.n38 17.0005
R1856 VSS.n744 VSS.n38 17.0005
R1857 VSS.n740 VSS.n38 17.0005
R1858 VSS.n738 VSS.n38 17.0005
R1859 VSS.n737 VSS.n38 17.0005
R1860 VSS.n735 VSS.n38 17.0005
R1861 VSS.n733 VSS.n38 17.0005
R1862 VSS.n731 VSS.n38 17.0005
R1863 VSS.n730 VSS.n38 17.0005
R1864 VSS.n728 VSS.n38 17.0005
R1865 VSS.n726 VSS.n38 17.0005
R1866 VSS.n724 VSS.n38 17.0005
R1867 VSS.n722 VSS.n38 17.0005
R1868 VSS.n721 VSS.n38 17.0005
R1869 VSS.n719 VSS.n38 17.0005
R1870 VSS.n717 VSS.n38 17.0005
R1871 VSS.n715 VSS.n38 17.0005
R1872 VSS.n714 VSS.n38 17.0005
R1873 VSS.n712 VSS.n38 17.0005
R1874 VSS.n710 VSS.n38 17.0005
R1875 VSS.n708 VSS.n38 17.0005
R1876 VSS.n706 VSS.n38 17.0005
R1877 VSS.n705 VSS.n38 17.0005
R1878 VSS.n703 VSS.n38 17.0005
R1879 VSS.n701 VSS.n38 17.0005
R1880 VSS.n699 VSS.n38 17.0005
R1881 VSS.n698 VSS.n38 17.0005
R1882 VSS.n696 VSS.n38 17.0005
R1883 VSS.n531 VSS.n38 17.0005
R1884 VSS.n698 VSS.n11 17.0005
R1885 VSS.n699 VSS.n11 17.0005
R1886 VSS.n705 VSS.n11 17.0005
R1887 VSS.n714 VSS.n11 17.0005
R1888 VSS.n715 VSS.n11 17.0005
R1889 VSS.n721 VSS.n11 17.0005
R1890 VSS.n730 VSS.n11 17.0005
R1891 VSS.n731 VSS.n11 17.0005
R1892 VSS.n737 VSS.n11 17.0005
R1893 VSS.n824 VSS.n11 17.0005
R1894 VSS.n748 VSS.n11 17.0005
R1895 VSS.n749 VSS.n11 17.0005
R1896 VSS.n757 VSS.n11 17.0005
R1897 VSS.n758 VSS.n11 17.0005
R1898 VSS.n788 VSS.n531 17.0005
R1899 VSS.n788 VSS.n706 17.0005
R1900 VSS.n788 VSS.n722 17.0005
R1901 VSS.n788 VSS.n738 17.0005
R1902 VSS.n788 VSS.n743 17.0005
R1903 VSS.n788 VSS.n768 17.0005
R1904 VSS.n687 VSS.n11 17.0005
R1905 VSS.n16 VSS.n782 17.0005
R1906 VSS.n783 VSS.n16 17.0005
R1907 VSS.n772 VSS.n11 17.0005
R1908 VSS.n828 VSS.n11 17.0005
R1909 VSS.n554 VSS.n38 17.0005
R1910 VSS.n830 VSS.n11 17.0005
R1911 VSS.n715 VSS.t582 16.4539
R1912 VSS.n195 VSS.t36 16.3876
R1913 VSS.n60 VSS.n532 16.2018
R1914 VSS.t444 VSS.n757 14.2601
R1915 VSS.t75 VSS.n72 13.9927
R1916 VSS.n862 VSS.t476 13.7246
R1917 VSS.t250 VSS.t138 13.4836
R1918 VSS.n696 VSS.n695 12.0761
R1919 VSS.n702 VSS.n701 12.0761
R1920 VSS.n707 VSS.n706 12.0761
R1921 VSS.n712 VSS.n711 12.0761
R1922 VSS.n719 VSS.n718 12.0761
R1923 VSS.n724 VSS.n723 12.0761
R1924 VSS.n727 VSS.n726 12.0761
R1925 VSS.n735 VSS.n734 12.0761
R1926 VSS.n740 VSS.n739 12.0761
R1927 VSS.n746 VSS.n745 12.0761
R1928 VSS.n753 VSS.n752 12.0761
R1929 VSS.n764 VSS.n763 12.0761
R1930 VSS.n698 VSS.n697 12.0761
R1931 VSS.n701 VSS.n700 12.0761
R1932 VSS.n705 VSS.n704 12.0761
R1933 VSS.n710 VSS.n709 12.0761
R1934 VSS.n714 VSS.n713 12.0761
R1935 VSS.n717 VSS.n716 12.0761
R1936 VSS.n721 VSS.n720 12.0761
R1937 VSS.n726 VSS.n725 12.0761
R1938 VSS.n730 VSS.n729 12.0761
R1939 VSS.n733 VSS.n732 12.0761
R1940 VSS.n737 VSS.n736 12.0761
R1941 VSS.n744 VSS.n741 12.0761
R1942 VSS.n748 VSS.n747 12.0761
R1943 VSS.n751 VSS.n750 12.0761
R1944 VSS.n757 VSS.n754 12.0761
R1945 VSS.n762 VSS.n759 12.0761
R1946 VSS.n766 VSS.n765 12.0761
R1947 VSS.n773 VSS.n771 12.0761
R1948 VSS.n768 VSS.n767 12.0761
R1949 VSS.n770 VSS.n769 12.0761
R1950 VSS.n695 VSS.n531 12.0761
R1951 VSS.n697 VSS.n696 12.0761
R1952 VSS.n700 VSS.n699 12.0761
R1953 VSS.n703 VSS.n702 12.0761
R1954 VSS.n704 VSS.n703 12.0761
R1955 VSS.n708 VSS.n707 12.0761
R1956 VSS.n709 VSS.n708 12.0761
R1957 VSS.n711 VSS.n710 12.0761
R1958 VSS.n713 VSS.n712 12.0761
R1959 VSS.n716 VSS.n715 12.0761
R1960 VSS.n718 VSS.n717 12.0761
R1961 VSS.n720 VSS.n719 12.0761
R1962 VSS.n723 VSS.n722 12.0761
R1963 VSS.n725 VSS.n724 12.0761
R1964 VSS.n728 VSS.n727 12.0761
R1965 VSS.n729 VSS.n728 12.0761
R1966 VSS.n732 VSS.n731 12.0761
R1967 VSS.n734 VSS.n733 12.0761
R1968 VSS.n736 VSS.n735 12.0761
R1969 VSS.n739 VSS.n738 12.0761
R1970 VSS.n741 VSS.n740 12.0761
R1971 VSS.n745 VSS.n744 12.0761
R1972 VSS.n747 VSS.n746 12.0761
R1973 VSS.n750 VSS.n749 12.0761
R1974 VSS.n752 VSS.n751 12.0761
R1975 VSS.n754 VSS.n753 12.0761
R1976 VSS.n759 VSS.n758 12.0761
R1977 VSS.n763 VSS.n762 12.0761
R1978 VSS.n765 VSS.n764 12.0761
R1979 VSS.n767 VSS.n766 12.0761
R1980 VSS.n773 VSS.n772 12.0761
R1981 VSS.n771 VSS.n770 12.0761
R1982 VSS.n769 VSS.n686 11.454
R1983 VSS.n832 VSS.n686 11.454
R1984 VSS.t60 VSS.n645 10.7807
R1985 VSS.n641 VSS.t71 10.7777
R1986 VSS.n801 VSS.n553 9.81803
R1987 VSS.n846 VSS.n553 9.39094
R1988 VSS.n844 VSS.n843 9.38916
R1989 VSS.n571 VSS.t154 9.08698
R1990 VSS.t154 VSS.n570 9.0445
R1991 VSS.n837 VSS.n836 9.0005
R1992 VSS.n837 VSS.n557 9.0005
R1993 VSS.n561 VSS.n556 9.0005
R1994 VSS.n776 VSS.n556 9.0005
R1995 VSS.n72 VSS.n638 1.71757
R1996 VSS.t563 VSS.n868 8.501
R1997 VSS.n869 VSS.t561 8.501
R1998 VSS.t559 VSS.n303 8.501
R1999 VSS.t361 VSS.n294 8.501
R2000 VSS.t553 VSS.n877 8.501
R2001 VSS.n878 VSS.t551 8.501
R2002 VSS.t549 VSS.n880 8.501
R2003 VSS.n881 VSS.t178 8.501
R2004 VSS.t543 VSS.n883 8.501
R2005 VSS.n884 VSS.t541 8.501
R2006 VSS.t539 VSS.n886 8.501
R2007 VSS.n887 VSS.t536 8.501
R2008 VSS.t316 VSS.n889 8.501
R2009 VSS.n890 VSS.t531 8.501
R2010 VSS.t529 VSS.n246 8.501
R2011 VSS.t33 VSS.n237 8.501
R2012 VSS.t523 VSS.n898 8.501
R2013 VSS.n899 VSS.t521 8.501
R2014 VSS.t519 VSS.n901 8.501
R2015 VSS.n902 VSS.t175 8.501
R2016 VSS.t513 VSS.n904 8.501
R2017 VSS.n905 VSS.t511 8.501
R2018 VSS.t509 VSS.n907 8.501
R2019 VSS.n908 VSS.t506 8.501
R2020 VSS.n438 VSS.n92 88.4708
R2021 VSS.n809 VSS.n38 2.83417
R2022 VSS.n39 VSS.n40 0.00149997
R2023 VSS.n809 VSS.n41 1.88985
R2024 VSS.n43 VSS.n44 0.00149997
R2025 VSS.n45 VSS.n809 2.4296
R2026 VSS.n809 VSS.n49 4.25113
R2027 VSS.n809 VSS.n50 2.12578
R2028 VSS.n50 VSS.n51 0.00166651
R2029 VSS.n51 VSS.n53 0.00158329
R2030 VSS.n809 VSS.n57 2.83428
R2031 VSS.n57 VSS.n56 0.00158329
R2032 VSS.n852 VSS.n21 4.251
R2033 VSS.n21 VSS.n20 0.00149997
R2034 VSS.n852 VSS.n22 3.40102
R2035 VSS.n852 VSS.n25 2.12569
R2036 VSS.n25 VSS.n24 0.00170812
R2037 VSS.n24 VSS.n26 0.00166658
R2038 VSS.n26 VSS.n27 0.00149997
R2039 VSS.n852 VSS.n28 1.88985
R2040 VSS.n30 VSS.n31 0.00149997
R2041 VSS.n852 VSS.n33 8.501
R2042 VSS.n852 VSS.n34 2.12588
R2043 VSS.n34 VSS.n35 0.00262484
R2044 VSS.n666 VSS.n63 406.622
R2045 VSS.n68 VSS.n67 406.622
R2046 VSS.n70 VSS.n68 0.00235708
R2047 VSS.n72 VSS.n71 0.00110118
R2048 VSS.n71 VSS.n73 0.00170812
R2049 VSS.n73 VSS.n74 0.00166658
R2050 VSS.n74 VSS.n75 0.00149997
R2051 VSS.n77 VSS.n76 0.00215245
R2052 VSS.n76 VSS.n78 0.00174253
R2053 VSS.n78 VSS.n79 0.00174154
R2054 VSS.n79 VSS.n80 0.0017399
R2055 VSS.n80 VSS.n81 0.00173723
R2056 VSS.n81 VSS.n82 0.00173273
R2057 VSS.n82 VSS.n83 0.00172462
R2058 VSS.n83 VSS.n84 0.00170812
R2059 VSS.n84 VSS.n85 0.00166658
R2060 VSS.n85 VSS.n86 0.00149997
R2061 VSS.n638 VSS.n87 3.40102
R2062 VSS.n638 VSS.n90 3.40102
R2063 VSS.n835 VSS.n5 5.41263
R2064 VSS.n832 VSS.n12 3.40102
R2065 VSS.n14 VSS.n13 0.00216499
R2066 VSS.n13 VSS.n15 0.00173273
R2067 VSS.n15 VSS.n16 0.00172462
R2068 VSS.n16 VSS.n17 0.00170812
R2069 VSS.n17 VSS.n18 0.00166658
R2070 VSS.n18 VSS.n19 0.00149997
R2071 VSS.n832 VSS.n38 8.501
R2072 VSS.n94 VSS.n526 8.5005
R2073 VSS.n94 VSS.n521 8.5005
R2074 VSS.n94 VSS.n357 8.5005
R2075 VSS.n94 VSS.n519 8.5005
R2076 VSS.n94 VSS.n518 8.5005
R2077 VSS.n94 VSS.n358 8.5005
R2078 VSS.n94 VSS.n517 8.5005
R2079 VSS.n94 VSS.n360 8.5005
R2080 VSS.n94 VSS.n516 8.5005
R2081 VSS.n94 VSS.n361 8.5005
R2082 VSS.n94 VSS.n515 8.5005
R2083 VSS.n94 VSS.n362 8.5005
R2084 VSS.n94 VSS.n514 8.5005
R2085 VSS.n94 VSS.n513 8.5005
R2086 VSS.n94 VSS.n363 8.5005
R2087 VSS.n94 VSS.n512 8.5005
R2088 VSS.n94 VSS.n365 8.5005
R2089 VSS.n94 VSS.n511 8.5005
R2090 VSS.n94 VSS.n366 8.5005
R2091 VSS.n94 VSS.n510 8.5005
R2092 VSS.n94 VSS.n367 8.5005
R2093 VSS.n94 VSS.n509 8.5005
R2094 VSS.n94 VSS.n508 8.5005
R2095 VSS.n94 VSS.n368 8.5005
R2096 VSS.n94 VSS.n507 8.5005
R2097 VSS.n94 VSS.n370 8.5005
R2098 VSS.n94 VSS.n506 8.5005
R2099 VSS.n94 VSS.n371 8.5005
R2100 VSS.n94 VSS.n505 8.5005
R2101 VSS.n94 VSS.n372 8.5005
R2102 VSS.n94 VSS.n504 8.5005
R2103 VSS.n94 VSS.n503 8.5005
R2104 VSS.n94 VSS.n373 8.5005
R2105 VSS.n94 VSS.n502 8.5005
R2106 VSS.n94 VSS.n375 8.5005
R2107 VSS.n94 VSS.n501 8.5005
R2108 VSS.n94 VSS.n376 8.5005
R2109 VSS.n94 VSS.n500 8.5005
R2110 VSS.n94 VSS.n377 8.5005
R2111 VSS.n94 VSS.n499 8.5005
R2112 VSS.n94 VSS.n498 8.5005
R2113 VSS.n94 VSS.n378 8.5005
R2114 VSS.n94 VSS.n497 8.5005
R2115 VSS.n94 VSS.n380 8.5005
R2116 VSS.n94 VSS.n496 8.5005
R2117 VSS.n94 VSS.n381 8.5005
R2118 VSS.n94 VSS.n495 8.5005
R2119 VSS.n94 VSS.n382 8.5005
R2120 VSS.n94 VSS.n494 8.5005
R2121 VSS.n94 VSS.n493 8.5005
R2122 VSS.n94 VSS.n383 8.5005
R2123 VSS.n94 VSS.n492 8.5005
R2124 VSS.n94 VSS.n385 8.5005
R2125 VSS.n94 VSS.n491 8.5005
R2126 VSS.n94 VSS.n386 8.5005
R2127 VSS.n94 VSS.n490 8.5005
R2128 VSS.n94 VSS.n387 8.5005
R2129 VSS.n94 VSS.n489 8.5005
R2130 VSS.n94 VSS.n488 8.5005
R2131 VSS.n94 VSS.n388 8.5005
R2132 VSS.n94 VSS.n487 8.5005
R2133 VSS.n94 VSS.n390 8.5005
R2134 VSS.n94 VSS.n486 8.5005
R2135 VSS.n94 VSS.n391 8.5005
R2136 VSS.n94 VSS.n485 8.5005
R2137 VSS.n94 VSS.n392 8.5005
R2138 VSS.n94 VSS.n484 8.5005
R2139 VSS.n94 VSS.n483 8.5005
R2140 VSS.n94 VSS.n393 8.5005
R2141 VSS.n94 VSS.n482 8.5005
R2142 VSS.n94 VSS.n395 8.5005
R2143 VSS.n94 VSS.n481 8.5005
R2144 VSS.n94 VSS.n396 8.5005
R2145 VSS.n94 VSS.n480 8.5005
R2146 VSS.n94 VSS.n397 8.5005
R2147 VSS.n94 VSS.n479 8.5005
R2148 VSS.n94 VSS.n478 8.5005
R2149 VSS.n94 VSS.n398 8.5005
R2150 VSS.n94 VSS.n477 8.5005
R2151 VSS.n94 VSS.n400 8.5005
R2152 VSS.n94 VSS.n476 8.5005
R2153 VSS.n94 VSS.n401 8.5005
R2154 VSS.n94 VSS.n475 8.5005
R2155 VSS.n94 VSS.n402 8.5005
R2156 VSS.n94 VSS.n474 8.5005
R2157 VSS.n94 VSS.n473 8.5005
R2158 VSS.n94 VSS.n403 8.5005
R2159 VSS.n94 VSS.n472 8.5005
R2160 VSS.n94 VSS.n405 8.5005
R2161 VSS.n94 VSS.n471 8.5005
R2162 VSS.n94 VSS.n406 8.5005
R2163 VSS.n94 VSS.n470 8.5005
R2164 VSS.n94 VSS.n407 8.5005
R2165 VSS.n94 VSS.n469 8.5005
R2166 VSS.n94 VSS.n468 8.5005
R2167 VSS.n94 VSS.n408 8.5005
R2168 VSS.n94 VSS.n467 8.5005
R2169 VSS.n94 VSS.n410 8.5005
R2170 VSS.n94 VSS.n466 8.5005
R2171 VSS.n94 VSS.n411 8.5005
R2172 VSS.n94 VSS.n465 8.5005
R2173 VSS.n94 VSS.n412 8.5005
R2174 VSS.n94 VSS.n464 8.5005
R2175 VSS.n94 VSS.n463 8.5005
R2176 VSS.n94 VSS.n413 8.5005
R2177 VSS.n94 VSS.n462 8.5005
R2178 VSS.n94 VSS.n415 8.5005
R2179 VSS.n94 VSS.n461 8.5005
R2180 VSS.n94 VSS.n416 8.5005
R2181 VSS.n94 VSS.n460 8.5005
R2182 VSS.n94 VSS.n417 8.5005
R2183 VSS.n94 VSS.n459 8.5005
R2184 VSS.n94 VSS.n458 8.5005
R2185 VSS.n94 VSS.n418 8.5005
R2186 VSS.n94 VSS.n457 8.5005
R2187 VSS.n94 VSS.n420 8.5005
R2188 VSS.n94 VSS.n456 8.5005
R2189 VSS.n94 VSS.n421 8.5005
R2190 VSS.n94 VSS.n455 8.5005
R2191 VSS.n94 VSS.n422 8.5005
R2192 VSS.n94 VSS.n454 8.5005
R2193 VSS.n94 VSS.n453 8.5005
R2194 VSS.n94 VSS.n423 8.5005
R2195 VSS.n94 VSS.n452 8.5005
R2196 VSS.n94 VSS.n425 8.5005
R2197 VSS.n94 VSS.n451 8.5005
R2198 VSS.n94 VSS.n426 8.5005
R2199 VSS.n94 VSS.n450 8.5005
R2200 VSS.n94 VSS.n427 8.5005
R2201 VSS.n94 VSS.n449 8.5005
R2202 VSS.n94 VSS.n448 8.5005
R2203 VSS.n94 VSS.n428 8.5005
R2204 VSS.n94 VSS.n447 8.5005
R2205 VSS.n94 VSS.n430 8.5005
R2206 VSS.n94 VSS.n446 8.5005
R2207 VSS.n94 VSS.n431 8.5005
R2208 VSS.n94 VSS.n445 8.5005
R2209 VSS.n94 VSS.n432 8.5005
R2210 VSS.n94 VSS.n444 8.5005
R2211 VSS.n94 VSS.n443 8.5005
R2212 VSS.n94 VSS.n433 8.5005
R2213 VSS.n94 VSS.n442 8.5005
R2214 VSS.n94 VSS.n435 8.5005
R2215 VSS.n94 VSS.n441 8.5005
R2216 VSS.n94 VSS.n436 8.5005
R2217 VSS.n94 VSS.n439 8.5005
R2218 VSS.n8 VSS.n585 8.5005
R2219 VSS.n8 VSS.n574 8.5005
R2220 VSS.n8 VSS.n558 8.48883
R2221 VSS.n559 VSS.n8 8.48883
R2222 VSS.n94 VSS.n440 8.48012
R2223 VSS.t93 VSS.n73 8.47784
R2224 VSS.n622 VSS.n74 8.47784
R2225 VSS.n623 VSS.n75 8.47784
R2226 VSS.n625 VSS.n76 8.47784
R2227 VSS.n626 VSS.n78 8.47784
R2228 VSS.n627 VSS.n79 8.47784
R2229 VSS.n628 VSS.n80 8.47784
R2230 VSS.n629 VSS.n81 8.47784
R2231 VSS.n630 VSS.n82 8.47784
R2232 VSS.n631 VSS.n83 8.47784
R2233 VSS.n632 VSS.n84 8.47784
R2234 VSS.n633 VSS.n85 8.47784
R2235 VSS.n634 VSS.n86 8.47784
R2236 VSS.n636 VSS.n89 8.47784
R2237 VSS.t76 VSS.n91 8.47784
R2238 VSS.n94 VSS.n356 8.47732
R2239 VSS.n94 VSS.t278 8.47732
R2240 VSS.n94 VSS.n318 8.47732
R2241 VSS.n94 VSS.n319 8.47732
R2242 VSS.n94 VSS.n353 8.47732
R2243 VSS.n798 VSS.n38 8.47732
R2244 VSS.n796 VSS.n38 8.47732
R2245 VSS.n550 VSS.n38 8.47732
R2246 VSS.n549 VSS.n38 8.47732
R2247 VSS.t251 VSS.n39 8.47732
R2248 VSS.n795 VSS.n40 8.47732
R2249 VSS.n803 VSS.n42 8.47732
R2250 VSS.n804 VSS.n43 8.47732
R2251 VSS.n805 VSS.n44 8.47732
R2252 VSS.n47 VSS.n807 8.47732
R2253 VSS.n791 VSS.n46 8.47732
R2254 VSS.t136 VSS.n810 8.47732
R2255 VSS.n811 VSS.n49 8.47732
R2256 VSS.n812 VSS.n48 8.47732
R2257 VSS.n790 VSS.n51 8.47732
R2258 VSS.t137 VSS.n53 8.47732
R2259 VSS.n813 VSS.n52 8.47732
R2260 VSS.n815 VSS.n789 8.47732
R2261 VSS.n816 VSS.n56 8.47732
R2262 VSS.n817 VSS.n55 8.47732
R2263 VSS.t139 VSS.n20 8.47732
R2264 VSS.n847 VSS.n23 8.47732
R2265 VSS.n545 VSS.n546 8.47732
R2266 VSS.t140 VSS.n24 8.47732
R2267 VSS.t141 VSS.n26 8.47732
R2268 VSS.n848 VSS.n27 8.47732
R2269 VSS.n849 VSS.n29 8.47732
R2270 VSS.n539 VSS.n30 8.47732
R2271 VSS.t144 VSS.n31 8.47732
R2272 VSS.n538 VSS.n537 8.47732
R2273 VSS.n850 VSS.n33 8.47732
R2274 VSS.n536 VSS.n32 8.47732
R2275 VSS.t146 VSS.n35 8.47732
R2276 VSS.n535 VSS.n37 8.47732
R2277 VSS.n621 VSS.n71 8.47732
R2278 VSS.n618 VSS.n71 8.47732
R2279 VSS.n8 VSS.n563 8.47732
R2280 VSS.n8 VSS.n565 8.47732
R2281 VSS.n8 VSS.n567 8.47732
R2282 VSS.n8 VSS.n573 8.47732
R2283 VSS.n8 VSS.n586 8.47732
R2284 VSS.n8 VSS.n575 8.47732
R2285 VSS.n691 VSS.n11 8.47732
R2286 VSS.n788 VSS.n761 8.47732
R2287 VSS.n780 VSS.n13 8.47732
R2288 VSS.n781 VSS.n15 8.47732
R2289 VSS.n784 VSS.n17 8.47732
R2290 VSS.n785 VSS.n18 8.47732
R2291 VSS.n786 VSS.n19 8.47732
R2292 VSS.n675 VSS.n62 8.47111
R2293 VSS.t153 VSS.n65 8.47111
R2294 VSS.n650 VSS.n69 8.47111
R2295 VSS.t188 VSS.n70 8.47111
R2296 VSS.n842 VSS.n841 6.85916
R2297 VSS.n674 VSS.n532 5.66985
R2298 VSS.n41 VSS.n794 0.00261099
R2299 VSS.n45 VSS.n793 0.0024999
R2300 VSS.n809 VSS.n792 5.66778
R2301 VSS.n22 VSS.n547 0.00229996
R2302 VSS.n852 VSS.n534 5.66778
R2303 VSS.n852 VSS.n533 5.66778
R2304 VSS.n28 VSS.n540 0.00261099
R2305 VSS.n638 VSS.n77 0.738794
R2306 VSS.n87 VSS.n619 0.00229996
R2307 VSS.n90 VSS.n88 0.00229996
R2308 VSS.n832 VSS.n14 1.13339
R2309 VSS.n831 VSS.t419 5.66778
R2310 VSS.n12 VSS.n831 0.00313328
R2311 VSS.n63 VSS.n65 0.00137142
R2312 VSS.n94 VSS.n317 5.63915
R2313 VSS.n778 VSS.n777 5.63075
R2314 VSS.n624 VSS.n620 5.62674
R2315 VSS.n635 VSS.n619 5.62674
R2316 VSS.n88 VSS.n637 5.62674
R2317 VSS.n802 VSS.n794 5.62581
R2318 VSS.n806 VSS.n793 5.62581
R2319 VSS.n814 VSS.n54 5.62581
R2320 VSS.n818 VSS.n58 5.62581
R2321 VSS.n548 VSS.n547 5.62581
R2322 VSS.n543 VSS.n544 5.62581
R2323 VSS.t142 VSS.n542 5.62581
R2324 VSS.n541 VSS.n540 5.62581
R2325 VSS.n36 VSS.n851 5.62581
R2326 VSS.n8 VSS.n572 5.62581
R2327 VSS.n788 VSS.n787 5.62252
R2328 VSS.n699 VSS.t580 5.48496
R2329 VSS.n677 VSS.n676 5.13648
R2330 VSS.n601 VSS.t243 4.98596
R2331 VSS.n838 VSS.n837 4.63796
R2332 VSS.n666 VSS.t246 4.49152
R2333 VSS.n67 VSS.t187 4.49152
R2334 VSS.t184 VSS.n677 4.4712
R2335 VSS.n809 VSS.n808 4.25119
R2336 VSS.n873 VSS.t557 4.19225
R2337 VSS.t547 VSS.n285 4.19225
R2338 VSS.t537 VSS.n268 4.19225
R2339 VSS.n894 VSS.t527 4.19225
R2340 VSS.t517 VSS.n228 4.19225
R2341 VSS.t507 VSS.n211 4.19225
R2342 VSS.n8 VSS.n568 4.19225
R2343 VSS.n788 VSS.n774 4.19225
R2344 VSS.n688 VSS.n11 4.19225
R2345 VSS.t190 VSS.n616 4.177
R2346 VSS.n529 VSS.n185 3.84219
R2347 VSS.n910 VSS.t35 3.84041
R2348 VSS.n852 VSS.n10 3.40112
R2349 VSS.n521 VSS.t107 3.34498
R2350 VSS.n518 VSS.t46 3.34498
R2351 VSS.n515 VSS.t103 3.34498
R2352 VSS.n513 VSS.t96 3.34498
R2353 VSS.n510 VSS.t94 3.34498
R2354 VSS.n508 VSS.t40 3.34498
R2355 VSS.n505 VSS.t101 3.34498
R2356 VSS.n503 VSS.t99 3.34498
R2357 VSS.n500 VSS.t49 3.34498
R2358 VSS.n498 VSS.t109 3.34498
R2359 VSS.n495 VSS.t56 3.34498
R2360 VSS.n493 VSS.t55 3.34498
R2361 VSS.n490 VSS.t112 3.34498
R2362 VSS.n488 VSS.t110 3.34498
R2363 VSS.n485 VSS.t105 3.34498
R2364 VSS.n483 VSS.t48 3.34498
R2365 VSS.n480 VSS.t118 3.34498
R2366 VSS.n478 VSS.t44 3.34498
R2367 VSS.n475 VSS.t42 3.34498
R2368 VSS.n473 VSS.t39 3.34498
R2369 VSS.n470 VSS.t120 3.34498
R2370 VSS.n468 VSS.t122 3.34498
R2371 VSS.n465 VSS.t116 3.34498
R2372 VSS.n463 VSS.t114 3.34498
R2373 VSS.n460 VSS.t97 3.34498
R2374 VSS.n458 VSS.t51 3.34498
R2375 VSS.n455 VSS.t58 3.34498
R2376 VSS.n453 VSS.t124 3.34498
R2377 VSS.n450 VSS.t126 3.34498
R2378 VSS.n448 VSS.t53 3.34498
R2379 VSS.n445 VSS.t128 3.34498
R2380 VSS.n443 VSS.t130 3.34498
R2381 VSS.n8 VSS.n560 3.32697
R2382 VSS.n845 VSS.n38 3.3265
R2383 VSS.n8 VSS.n564 3.32623
R2384 VSS.t182 VSS.t325 3.30696
R2385 VSS.n866 VSS.t167 3.28366
R2386 VSS.n788 VSS.n686 2.77448
R2387 VSS.n838 VSS.n555 2.7456
R2388 VSS.n94 VSS.n355 2.74463
R2389 VSS.n94 VSS.n437 2.7443
R2390 VSS.n94 VSS.t412 2.74402
R2391 VSS.n94 VSS.n520 2.74397
R2392 VSS.n94 VSS.n351 2.74397
R2393 VSS.n8 VSS.n580 2.74397
R2394 VSS.n695 VSS.n11 2.46343
R2395 VSS.n702 VSS.n11 2.46343
R2396 VSS.n707 VSS.n11 2.46343
R2397 VSS.n711 VSS.n11 2.46343
R2398 VSS.n718 VSS.n11 2.46343
R2399 VSS.n723 VSS.n11 2.46343
R2400 VSS.n727 VSS.n11 2.46343
R2401 VSS.n734 VSS.n11 2.46343
R2402 VSS.n739 VSS.n11 2.46343
R2403 VSS.n745 VSS.n11 2.46343
R2404 VSS.n752 VSS.n11 2.46343
R2405 VSS.n763 VSS.n11 2.46343
R2406 VSS.n788 VSS.n697 2.46343
R2407 VSS.n788 VSS.n700 2.46343
R2408 VSS.n788 VSS.n704 2.46343
R2409 VSS.n788 VSS.n709 2.46343
R2410 VSS.n788 VSS.n713 2.46343
R2411 VSS.n788 VSS.n716 2.46343
R2412 VSS.n788 VSS.n720 2.46343
R2413 VSS.n788 VSS.n725 2.46343
R2414 VSS.n788 VSS.n729 2.46343
R2415 VSS.n788 VSS.n732 2.46343
R2416 VSS.n788 VSS.n736 2.46343
R2417 VSS.n788 VSS.n741 2.46343
R2418 VSS.n788 VSS.n747 2.46343
R2419 VSS.n788 VSS.n750 2.46343
R2420 VSS.n788 VSS.n754 2.46343
R2421 VSS.n788 VSS.n759 2.46343
R2422 VSS.n788 VSS.n765 2.46343
R2423 VSS.n788 VSS.n773 2.46343
R2424 VSS.n767 VSS.n11 2.46343
R2425 VSS.n770 VSS.n11 2.46343
R2426 VSS.n307 VSS.n306 2.34876
R2427 VSS.n292 VSS.n291 2.34876
R2428 VSS.n275 VSS.n274 2.34876
R2429 VSS.n250 VSS.n249 2.34876
R2430 VSS.n235 VSS.n234 2.34876
R2431 VSS.n218 VSS.n217 2.34876
R2432 VSS.n826 VSS.n11 2.32483
R2433 VSS.n788 VSS.n756 2.32425
R2434 VSS.n822 VSS.n11 2.00687
R2435 VSS.n788 VSS.n694 2.00592
R2436 VSS.t325 VSS.n605 1.97699
R2437 VSS.t338 VSS.n599 1.88189
R2438 VSS.n616 VSS.n610 1.88189
R2439 VSS.n839 VSS.n838 1.83435
R2440 VSS.t312 VSS.n674 1.80539
R2441 VSS.n800 VSS.n38 1.75689
R2442 VSS.n552 VSS.n38 1.75689
R2443 VSS.n8 VSS.n591 1.75507
R2444 VSS.n651 VSS.t409 1.72297
R2445 VSS.n779 VSS.n776 1.66925
R2446 VSS.n94 VSS.n528 1.63922
R2447 VSS.n94 VSS.n855 1.63922
R2448 VSS.n94 VSS.n860 1.63922
R2449 VSS.n94 VSS.n862 1.63922
R2450 VSS.n94 VSS.n864 1.63922
R2451 VSS.n94 VSS.n359 1.55386
R2452 VSS.n94 VSS.n364 1.55386
R2453 VSS.n94 VSS.n369 1.55386
R2454 VSS.n94 VSS.n374 1.55386
R2455 VSS.n94 VSS.n379 1.55386
R2456 VSS.n94 VSS.n384 1.55386
R2457 VSS.n94 VSS.n389 1.55386
R2458 VSS.n94 VSS.n394 1.55386
R2459 VSS.n94 VSS.n399 1.55386
R2460 VSS.n94 VSS.n404 1.55386
R2461 VSS.n94 VSS.n409 1.55386
R2462 VSS.n94 VSS.n414 1.55386
R2463 VSS.n94 VSS.n419 1.55386
R2464 VSS.n94 VSS.n424 1.55386
R2465 VSS.n94 VSS.n429 1.55386
R2466 VSS.n94 VSS.n434 1.55386
R2467 VSS.n94 VSS.t430 1.55345
R2468 VSS.n94 VSS.t502 1.55345
R2469 VSS.n94 VSS.t309 1.55345
R2470 VSS.n94 VSS.t234 1.55345
R2471 VSS.n94 VSS.t24 1.55345
R2472 VSS.n94 VSS.t30 1.55345
R2473 VSS.n94 VSS.t349 1.55345
R2474 VSS.n94 VSS.t7 1.55345
R2475 VSS.n94 VSS.t197 1.55345
R2476 VSS.n94 VSS.t11 1.55345
R2477 VSS.n94 VSS.t192 1.55345
R2478 VSS.n94 VSS.t170 1.55345
R2479 VSS.n94 VSS.t352 1.55345
R2480 VSS.n94 VSS.t16 1.55345
R2481 VSS.n94 VSS.t302 1.55345
R2482 VSS.n94 VSS.n320 1.55338
R2483 VSS.n94 VSS.n321 1.55338
R2484 VSS.n94 VSS.n322 1.55338
R2485 VSS.n94 VSS.n323 1.55338
R2486 VSS.n94 VSS.n324 1.55338
R2487 VSS.n94 VSS.n325 1.55338
R2488 VSS.n94 VSS.n326 1.55338
R2489 VSS.n94 VSS.n327 1.55338
R2490 VSS.n94 VSS.n328 1.55338
R2491 VSS.n94 VSS.n329 1.55338
R2492 VSS.n94 VSS.n330 1.55338
R2493 VSS.n94 VSS.n331 1.55338
R2494 VSS.n94 VSS.n332 1.55338
R2495 VSS.n94 VSS.n333 1.55338
R2496 VSS.n94 VSS.n334 1.55338
R2497 VSS.n94 VSS.n335 1.55338
R2498 VSS.n94 VSS.n336 1.55338
R2499 VSS.n94 VSS.n337 1.55338
R2500 VSS.n94 VSS.n338 1.55338
R2501 VSS.n94 VSS.n339 1.55338
R2502 VSS.n94 VSS.n340 1.55338
R2503 VSS.n94 VSS.n341 1.55338
R2504 VSS.n94 VSS.n342 1.55338
R2505 VSS.n94 VSS.n343 1.55338
R2506 VSS.n94 VSS.n344 1.55338
R2507 VSS.n94 VSS.n345 1.55338
R2508 VSS.n94 VSS.n346 1.55338
R2509 VSS.n94 VSS.n347 1.55338
R2510 VSS.n94 VSS.n348 1.55338
R2511 VSS.n94 VSS.n349 1.55338
R2512 VSS.n94 VSS.n350 1.55338
R2513 VSS.n611 VSS.n71 1.55041
R2514 VSS.t254 VSS.n690 1.43372
R2515 VSS.t252 VSS.n693 1.43372
R2516 VSS.n692 VSS.t252 1.42949
R2517 VSS.n689 VSS.t254 1.42949
R2518 VSS.t445 VSS.t453 1.41892
R2519 VSS.t443 VSS.t452 1.41892
R2520 VSS.t450 VSS.t451 1.41892
R2521 VSS.t447 VSS.t448 1.41892
R2522 VSS.n909 VSS.n208 1.38589
R2523 VSS.n551 VSS.t249 1.37661
R2524 VSS.t249 VSS.n797 1.37661
R2525 VSS.n840 VSS.n839 1.30942
R2526 VSS.t215 VSS.n251 1.28795
R2527 VSS.n844 VSS.n840 1.26857
R2528 VSS.t93 VSS.t91 1.25706
R2529 VSS.t76 VSS.t74 1.24892
R2530 VSS.n614 VSS.n71 1.24506
R2531 VSS.t289 VSS.t38 1.23805
R2532 VSS.t182 VSS.n606 1.21874
R2533 VSS.t84 VSS.t86 1.18357
R2534 VSS.t66 VSS.t64 1.1832
R2535 VSS.t88 VSS.t86 1.17915
R2536 VSS.t68 VSS.t66 1.17908
R2537 VSS.t61 VSS.t62 1.17816
R2538 VSS.t78 VSS.t77 1.1778
R2539 VSS.t80 VSS.t79 1.17383
R2540 VSS.t72 VSS.t70 1.17371
R2541 VSS.t91 VSS.t80 1.15983
R2542 VSS.t74 VSS.t72 1.15299
R2543 VSS.n603 VSS.t190 1.12148
R2544 VSS.t68 VSS.t70 1.11346
R2545 VSS.t79 VSS.t88 1.11317
R2546 VSS.t84 VSS.t78 1.10881
R2547 VSS.t64 VSS.t61 1.10864
R2548 VSS.t338 VSS.n597 1.09664
R2549 VSS.n607 VSS.t329 1.08287
R2550 VSS.t316 VSS.n251 1.06717
R2551 VSS.n606 VSS.t153 1.0392
R2552 VSS.n187 VSS.t506 1.03359
R2553 VSS.n597 VSS.n598 1.02454
R2554 VSS.n530 VSS.t148 1.02121
R2555 VSS.n858 VSS.t19 1.00725
R2556 VSS.n851 VSS.n9 1.00681
R2557 VSS.n187 VSS.t327 1.0064
R2558 VSS.n819 VSS.n818 0.986192
R2559 VSS.n186 VSS.t35 0.971887
R2560 VSS.t563 VSS.n308 0.950816
R2561 VSS.n821 VSS.n9 0.908953
R2562 VSS.n603 VSS.t184 0.884808
R2563 VSS.n820 VSS.n819 0.873936
R2564 VSS.t536 VSS.n252 0.841394
R2565 VSS.n675 VSS.n607 0.839803
R2566 VSS.t343 VSS.n609 0.832423
R2567 VSS.t259 VSS.t262 0.806856
R2568 VSS.n583 VSS.t266 0.806855
R2569 VSS.t222 VSS.t272 0.806855
R2570 VSS.n581 VSS.t82 0.802775
R2571 VSS.t402 VSS.t108 0.802775
R2572 VSS.t433 VSS.t47 0.802775
R2573 VSS.t591 VSS.t104 0.802775
R2574 VSS.t333 VSS.t3 0.802775
R2575 VSS.t489 VSS.t95 0.802775
R2576 VSS.t286 VSS.t41 0.802775
R2577 VSS.t202 VSS.t102 0.802775
R2578 VSS.t378 VSS.t100 0.802775
R2579 VSS.t405 VSS.t50 0.802775
R2580 VSS.t199 VSS.t22 0.802775
R2581 VSS.t205 VSS.t57 0.802775
R2582 VSS.t157 VSS.t1 0.802775
R2583 VSS.t606 VSS.t113 0.802775
R2584 VSS.t376 VSS.t111 0.802775
R2585 VSS.t466 VSS.t106 0.802775
R2586 VSS.t134 VSS.t5 0.802775
R2587 VSS.t424 VSS.t119 0.802775
R2588 VSS.t242 VSS.t45 0.802775
R2589 VSS.t295 VSS.t43 0.802775
R2590 VSS.t436 VSS.t9 0.802775
R2591 VSS.t374 VSS.t121 0.802775
R2592 VSS.t398 VSS.t123 0.802775
R2593 VSS.t415 VSS.t117 0.802775
R2594 VSS.t322 VSS.t115 0.802775
R2595 VSS.t609 VSS.t98 0.802775
R2596 VSS.t299 VSS.t52 0.802775
R2597 VSS.t457 VSS.t59 0.802775
R2598 VSS.t162 VSS.t125 0.802775
R2599 VSS.t208 VSS.t127 0.802775
R2600 VSS.t387 VSS.t54 0.802775
R2601 VSS.t367 VSS.t129 0.802775
R2602 VSS.t238 VSS.t131 0.802775
R2603 VSS.t27 VSS.t281 0.802775
R2604 VSS.t361 VSS.n293 0.78864
R2605 VSS.t178 VSS.n276 0.78864
R2606 VSS.t33 VSS.n236 0.78864
R2607 VSS.t175 VSS.n219 0.78864
R2608 VSS.n607 VSS.t312 0.756052
R2609 VSS.t343 VSS.t409 0.745166
R2610 VSS.t338 VSS.n603 0.728098
R2611 VSS.t553 VSS.n293 0.724795
R2612 VSS.t543 VSS.n276 0.724795
R2613 VSS.t523 VSS.n236 0.724795
R2614 VSS.t513 VSS.n219 0.724795
R2615 VSS.t282 VSS.t284 0.723599
R2616 VSS.t280 VSS.n316 0.723599
R2617 VSS.n760 VSS.t445 0.722582
R2618 VSS.n755 VSS.t443 0.722582
R2619 VSS.n742 VSS.t450 0.722582
R2620 VSS.t448 VSS.n820 0.722582
R2621 VSS.n827 VSS.t453 0.72222
R2622 VSS.n825 VSS.t452 0.72222
R2623 VSS.n823 VSS.t451 0.72222
R2624 VSS.n821 VSS.t447 0.72222
R2625 VSS.n609 VSS.n617 0.711165
R2626 VSS.t184 VSS.n597 0.699997
R2627 VSS.n252 VSS.t215 0.699882
R2628 VSS.n613 VSS.n612 0.6955
R2629 VSS.n606 VSS.n64 0.662806
R2630 VSS.t188 VSS.t409 0.640524
R2631 VSS.n876 VSS.n293 0.62049
R2632 VSS.n882 VSS.n276 0.62049
R2633 VSS.n897 VSS.n236 0.62049
R2634 VSS.n903 VSS.n219 0.62049
R2635 VSS.n867 VSS.n314 0.613782
R2636 VSS.n876 VSS.n300 0.613782
R2637 VSS.n882 VSS.n282 0.613782
R2638 VSS.n888 VSS.n265 0.613782
R2639 VSS.n888 VSS.n260 0.613782
R2640 VSS.n897 VSS.n243 0.613782
R2641 VSS.n903 VSS.n225 0.613782
R2642 VSS.n909 VSS.n191 0.613782
R2643 VSS.n909 VSS.n193 0.613782
R2644 VSS.n909 VSS.n204 0.613782
R2645 VSS.n909 VSS.n199 0.613782
R2646 VSS.n909 VSS.n200 0.613782
R2647 VSS.n609 VSS.n71 0.599773
R2648 VSS.t271 VSS.n587 0.595317
R2649 VSS.t268 VSS.n588 0.595317
R2650 VSS.t265 VSS.n576 0.595317
R2651 VSS.t261 VSS.n577 0.595317
R2652 VSS.t277 VSS.n522 0.595317
R2653 VSS.t274 VSS.n523 0.595317
R2654 VSS.n650 VSS.n605 0.588545
R2655 VSS.n671 VSS.t329 0.572871
R2656 VSS.n657 VSS.t325 0.572871
R2657 VSS.n94 VSS.n92 0.00105218
R2658 VSS.n617 VSS.n614 0.56503
R2659 VSS.t338 VSS.n602 0.557126
R2660 VSS.n94 VSS.n95 0.556705
R2661 VSS.n819 VSS.n788 0.55447
R2662 VSS.n888 VSS.n252 0.554008
R2663 VSS.t327 VSS.n208 0.539958
R2664 VSS.n592 VSS.n591 0.52186
R2665 VSS.n11 VSS.n9 0.51356
R2666 VSS.t254 VSS.t252 0.492336
R2667 VSS.n665 VSS.n64 0.490843
R2668 VSS.n661 VSS.n64 0.490843
R2669 VSS.n659 VSS.n64 0.490843
R2670 VSS.n651 VSS.n648 0.490843
R2671 VSS.n668 VSS.t329 0.489061
R2672 VSS.n654 VSS.t325 0.489061
R2673 VSS.t108 VSS.n350 0.477689
R2674 VSS.t47 VSS.n349 0.477689
R2675 VSS.t104 VSS.n348 0.477689
R2676 VSS.t3 VSS.n347 0.477689
R2677 VSS.t95 VSS.n346 0.477689
R2678 VSS.t41 VSS.n345 0.477689
R2679 VSS.t102 VSS.n344 0.477689
R2680 VSS.t100 VSS.n343 0.477689
R2681 VSS.t50 VSS.n342 0.477689
R2682 VSS.t22 VSS.n341 0.477689
R2683 VSS.t57 VSS.n340 0.477689
R2684 VSS.t1 VSS.n339 0.477689
R2685 VSS.t113 VSS.n338 0.477689
R2686 VSS.t111 VSS.n337 0.477689
R2687 VSS.t106 VSS.n336 0.477689
R2688 VSS.t5 VSS.n335 0.477689
R2689 VSS.t119 VSS.n334 0.477689
R2690 VSS.t45 VSS.n333 0.477689
R2691 VSS.t43 VSS.n332 0.477689
R2692 VSS.t9 VSS.n331 0.477689
R2693 VSS.t121 VSS.n330 0.477689
R2694 VSS.t123 VSS.n329 0.477689
R2695 VSS.t117 VSS.n328 0.477689
R2696 VSS.t115 VSS.n327 0.477689
R2697 VSS.t98 VSS.n326 0.477689
R2698 VSS.t52 VSS.n325 0.477689
R2699 VSS.t59 VSS.n324 0.477689
R2700 VSS.t125 VSS.n323 0.477689
R2701 VSS.t127 VSS.n322 0.477689
R2702 VSS.t54 VSS.n321 0.477689
R2703 VSS.t129 VSS.n320 0.477689
R2704 VSS.n611 VSS.n555 0.47741
R2705 VSS.t338 VSS.n680 0.477286
R2706 VSS.t338 VSS.n681 0.472981
R2707 VSS.t302 VSS.t387 0.466542
R2708 VSS.t16 VSS.t162 0.466542
R2709 VSS.t352 VSS.t299 0.466542
R2710 VSS.t170 VSS.t322 0.466542
R2711 VSS.t192 VSS.t398 0.466542
R2712 VSS.t11 VSS.t436 0.466542
R2713 VSS.t197 VSS.t242 0.466542
R2714 VSS.t7 VSS.t134 0.466542
R2715 VSS.t349 VSS.t376 0.466542
R2716 VSS.t30 VSS.t157 0.466542
R2717 VSS.t24 VSS.t199 0.466542
R2718 VSS.t234 VSS.t378 0.466542
R2719 VSS.t309 VSS.t286 0.466542
R2720 VSS.t502 VSS.t333 0.466542
R2721 VSS.t430 VSS.t433 0.466542
R2722 VSS.n359 VSS.t402 0.466192
R2723 VSS.n364 VSS.t591 0.466192
R2724 VSS.n369 VSS.t489 0.466192
R2725 VSS.n374 VSS.t202 0.466192
R2726 VSS.n379 VSS.t405 0.466192
R2727 VSS.n384 VSS.t205 0.466192
R2728 VSS.n389 VSS.t606 0.466192
R2729 VSS.n394 VSS.t466 0.466192
R2730 VSS.n399 VSS.t424 0.466192
R2731 VSS.n404 VSS.t295 0.466192
R2732 VSS.n409 VSS.t374 0.466192
R2733 VSS.n414 VSS.t415 0.466192
R2734 VSS.n419 VSS.t609 0.466192
R2735 VSS.n424 VSS.t457 0.466192
R2736 VSS.n429 VSS.t208 0.466192
R2737 VSS.n434 VSS.t367 0.466192
R2738 VSS.n676 VSS.n605 0.465582
R2739 VSS.n617 VSS.t190 0.464894
R2740 VSS.n613 VSS.n611 0.460744
R2741 VSS.n614 VSS.n613 0.455207
R2742 VSS.t238 VSS.n434 0.451785
R2743 VSS.t387 VSS.n429 0.451785
R2744 VSS.t162 VSS.n424 0.451785
R2745 VSS.t299 VSS.n419 0.451785
R2746 VSS.t322 VSS.n414 0.451785
R2747 VSS.t398 VSS.n409 0.451785
R2748 VSS.t436 VSS.n404 0.451785
R2749 VSS.t242 VSS.n399 0.451785
R2750 VSS.t134 VSS.n394 0.451785
R2751 VSS.t376 VSS.n389 0.451785
R2752 VSS.t157 VSS.n384 0.451785
R2753 VSS.t199 VSS.n379 0.451785
R2754 VSS.t378 VSS.n374 0.451785
R2755 VSS.t286 VSS.n369 0.451785
R2756 VSS.t333 VSS.n364 0.451785
R2757 VSS.t433 VSS.n359 0.451785
R2758 VSS.t430 VSS.t591 0.451337
R2759 VSS.t502 VSS.t489 0.451337
R2760 VSS.t309 VSS.t202 0.451337
R2761 VSS.t234 VSS.t405 0.451337
R2762 VSS.t24 VSS.t205 0.451337
R2763 VSS.t30 VSS.t606 0.451337
R2764 VSS.t349 VSS.t466 0.451337
R2765 VSS.t7 VSS.t424 0.451337
R2766 VSS.t197 VSS.t295 0.451337
R2767 VSS.t11 VSS.t374 0.451337
R2768 VSS.t192 VSS.t415 0.451337
R2769 VSS.t170 VSS.t609 0.451337
R2770 VSS.t352 VSS.t457 0.451337
R2771 VSS.t16 VSS.t208 0.451337
R2772 VSS.t302 VSS.t367 0.451337
R2773 VSS.n591 VSS.n590 0.447348
R2774 VSS.n910 VSS.n185 0.44402
R2775 VSS.t47 VSS.n350 0.440228
R2776 VSS.t104 VSS.n349 0.440228
R2777 VSS.t100 VSS.n344 0.440228
R2778 VSS.t50 VSS.n343 0.440228
R2779 VSS.t22 VSS.n342 0.440228
R2780 VSS.t111 VSS.n338 0.440228
R2781 VSS.t106 VSS.n337 0.440228
R2782 VSS.t119 VSS.n335 0.440228
R2783 VSS.t43 VSS.n333 0.440228
R2784 VSS.t9 VSS.n332 0.440228
R2785 VSS.t121 VSS.n331 0.440228
R2786 VSS.t123 VSS.n330 0.440228
R2787 VSS.t115 VSS.n328 0.440228
R2788 VSS.t98 VSS.n327 0.440228
R2789 VSS.t59 VSS.n325 0.440228
R2790 VSS.t127 VSS.n323 0.440228
R2791 VSS.t129 VSS.n321 0.440228
R2792 VSS.t131 VSS.n320 0.440228
R2793 VSS.n322 VSS.t54 0.440228
R2794 VSS.n324 VSS.t125 0.440228
R2795 VSS.n326 VSS.t52 0.440228
R2796 VSS.n329 VSS.t117 0.440228
R2797 VSS.n334 VSS.t45 0.440228
R2798 VSS.n336 VSS.t5 0.440228
R2799 VSS.n339 VSS.t113 0.440228
R2800 VSS.n340 VSS.t1 0.440228
R2801 VSS.n341 VSS.t57 0.440228
R2802 VSS.n345 VSS.t102 0.440228
R2803 VSS.n346 VSS.t41 0.440228
R2804 VSS.n347 VSS.t95 0.440228
R2805 VSS.n348 VSS.t3 0.440228
R2806 VSS.n846 VSS.n552 0.418268
R2807 VSS.n800 VSS.n799 0.418268
R2808 VSS.n799 VSS.n552 0.414988
R2809 VSS.n801 VSS.n800 0.414988
R2810 VSS.n677 VSS.n556 0.41014
R2811 VSS.t306 VSS.n60 0.400619
R2812 VSS.n827 VSS.n826 0.376066
R2813 VSS.n760 VSS.n756 0.374557
R2814 VSS.n8 VSS.n4 0.351198
R2815 VSS.n820 VSS.n694 0.339345
R2816 VSS.n823 VSS.n822 0.338265
R2817 VSS.n822 VSS.n821 0.338019
R2818 VSS.n742 VSS.n694 0.336845
R2819 VSS.n841 VSS.n355 0.329994
R2820 VSS.n580 VSS.n579 0.312321
R2821 VSS.n843 VSS.n842 0.31114
R2822 VSS.n756 VSS.n755 0.307812
R2823 VSS.t511 VSS.n218 0.306378
R2824 VSS.t521 VSS.n235 0.306378
R2825 VSS.t531 VSS.n250 0.306378
R2826 VSS.t541 VSS.n275 0.306378
R2827 VSS.t551 VSS.n292 0.306378
R2828 VSS.t561 VSS.n307 0.306378
R2829 VSS.n826 VSS.n825 0.306341
R2830 VSS.t131 VSS.t412 0.302153
R2831 VSS.n676 VSS.t182 0.298621
R2832 VSS.n186 VSS.n909 0.295237
R2833 VSS.n560 VSS.n557 0.291601
R2834 VSS.n437 VSS.t238 0.290734
R2835 VSS.n776 VSS.n560 0.287886
R2836 VSS.t142 VSS.n543 0.286439
R2837 VSS.n541 VSS.t142 0.286439
R2838 VSS.n867 VSS.n308 0.282782
R2839 VSS.t82 VSS.n564 0.276315
R2840 VSS.n520 VSS.t402 0.275961
R2841 VSS.n909 VSS.n187 0.275933
R2842 VSS.n522 VSS.n351 0.272321
R2843 VSS.n525 VSS.n520 0.272065
R2844 VSS.n94 VSS.n115 0.267794
R2845 VSS.n94 VSS.n117 0.267794
R2846 VSS.n94 VSS.n118 0.267794
R2847 VSS.n94 VSS.n179 0.267794
R2848 VSS.n94 VSS.n119 0.267794
R2849 VSS.n94 VSS.n120 0.267794
R2850 VSS.n94 VSS.n122 0.267794
R2851 VSS.n94 VSS.n123 0.267794
R2852 VSS.n94 VSS.n124 0.267794
R2853 VSS.n94 VSS.n126 0.267794
R2854 VSS.n94 VSS.n127 0.267794
R2855 VSS.n94 VSS.n178 0.267794
R2856 VSS.n94 VSS.n177 0.267794
R2857 VSS.n94 VSS.n129 0.267794
R2858 VSS.n94 VSS.n130 0.267794
R2859 VSS.n94 VSS.n132 0.267794
R2860 VSS.n94 VSS.n176 0.267794
R2861 VSS.n94 VSS.n133 0.267794
R2862 VSS.n94 VSS.n134 0.267794
R2863 VSS.n94 VSS.n136 0.267794
R2864 VSS.n94 VSS.n137 0.267794
R2865 VSS.n94 VSS.n138 0.267794
R2866 VSS.n94 VSS.n139 0.267794
R2867 VSS.n94 VSS.n140 0.267794
R2868 VSS.n94 VSS.n141 0.267794
R2869 VSS.n94 VSS.n142 0.267794
R2870 VSS.n94 VSS.n174 0.267794
R2871 VSS.n94 VSS.n143 0.267794
R2872 VSS.n94 VSS.n173 0.267794
R2873 VSS.n94 VSS.n172 0.267794
R2874 VSS.n94 VSS.n145 0.267794
R2875 VSS.n94 VSS.n170 0.267794
R2876 VSS.n94 VSS.n169 0.267794
R2877 VSS.n94 VSS.n146 0.267794
R2878 VSS.n94 VSS.n147 0.267794
R2879 VSS.n94 VSS.n167 0.267794
R2880 VSS.n94 VSS.n148 0.267794
R2881 VSS.n94 VSS.n166 0.267794
R2882 VSS.n94 VSS.n164 0.267794
R2883 VSS.n94 VSS.n149 0.267794
R2884 VSS.n94 VSS.n150 0.267794
R2885 VSS.n94 VSS.n151 0.267794
R2886 VSS.n94 VSS.n152 0.267794
R2887 VSS.n94 VSS.n162 0.267794
R2888 VSS.n94 VSS.n161 0.267794
R2889 VSS.n94 VSS.n160 0.267794
R2890 VSS.n94 VSS.n159 0.267794
R2891 VSS.n94 VSS.n158 0.267794
R2892 VSS.n94 VSS.n157 0.267794
R2893 VSS.n94 VSS.n97 0.267794
R2894 VSS.n94 VSS.n98 0.267794
R2895 VSS.n94 VSS.n99 0.267794
R2896 VSS.n94 VSS.n100 0.267794
R2897 VSS.n94 VSS.n102 0.267794
R2898 VSS.n94 VSS.n103 0.267794
R2899 VSS.n94 VSS.n104 0.267794
R2900 VSS.n94 VSS.n105 0.267794
R2901 VSS.n94 VSS.n106 0.267794
R2902 VSS.n94 VSS.n107 0.267794
R2903 VSS.n94 VSS.n109 0.267794
R2904 VSS.n94 VSS.n110 0.267794
R2905 VSS.n94 VSS.n111 0.267794
R2906 VSS.n94 VSS.n112 0.267794
R2907 VSS.n94 VSS.n113 0.267794
R2908 VSS.n94 VSS.n154 0.267428
R2909 VSS.n576 VSS.n564 0.265903
R2910 VSS.n846 VSS.n845 0.265497
R2911 VSS.t108 VSS.n351 0.264468
R2912 VSS.n845 VSS.n844 0.264227
R2913 VSS.n208 VSS.t38 0.263148
R2914 VSS.n218 VSS.t513 0.255324
R2915 VSS.n235 VSS.t523 0.255324
R2916 VSS.n250 VSS.t316 0.255324
R2917 VSS.n275 VSS.t543 0.255324
R2918 VSS.n292 VSS.t553 0.255324
R2919 VSS.n307 VSS.t563 0.255324
R2920 VSS.t412 VSS.t281 0.254653
R2921 VSS.n94 VSS.n530 0.253563
R2922 VSS.t27 VSS.n437 0.24355
R2923 VSS.t153 VSS.n675 0.241078
R2924 VSS.t188 VSS.n650 0.241078
R2925 VSS.n858 VSS.n355 0.24011
R2926 VSS.n847 VSS.n548 0.239006
R2927 VSS.n849 VSS.n541 0.239006
R2928 VSS.n803 VSS.n802 0.239006
R2929 VSS.n807 VSS.n806 0.239006
R2930 VSS.n815 VSS.n814 0.239006
R2931 VSS.n543 VSS.n848 0.238668
R2932 VSS.n851 VSS.n535 0.238668
R2933 VSS.n802 VSS.n795 0.238668
R2934 VSS.n806 VSS.n805 0.238668
R2935 VSS.n814 VSS.n813 0.238668
R2936 VSS.n818 VSS.n817 0.238668
R2937 VSS.n548 VSS.t139 0.238668
R2938 VSS.n581 VSS.n580 0.238218
R2939 VSS.n625 VSS.n624 0.233757
R2940 VSS.n636 VSS.n635 0.233757
R2941 VSS.n637 VSS.t76 0.233757
R2942 VSS.n624 VSS.n623 0.233419
R2943 VSS.n635 VSS.n634 0.233419
R2944 VSS.n637 VSS.n636 0.233419
R2945 VSS.n570 VSS.n568 0.225674
R2946 VSS.t507 VSS.t509 0.224424
R2947 VSS.t517 VSS.t519 0.224424
R2948 VSS.t537 VSS.t539 0.224424
R2949 VSS.t547 VSS.t549 0.224424
R2950 VSS.t557 VSS.t559 0.224424
R2951 VSS.t527 VSS.t529 0.224424
R2952 VSS.t506 VSS.t507 0.220674
R2953 VSS.t175 VSS.t517 0.220674
R2954 VSS.t536 VSS.t537 0.220674
R2955 VSS.t178 VSS.t547 0.220674
R2956 VSS.t557 VSS.t361 0.220674
R2957 VSS.t527 VSS.t33 0.220674
R2958 VSS.n587 VSS.n568 0.219424
R2959 VSS.t338 VSS.n685 0.211735
R2960 VSS.n837 VSS.n556 0.20686
R2961 VSS.n93 VSS.n317 0.297117
R2962 VSS.n592 VSS.n573 0.191235
R2963 VSS.t139 VSS.n549 0.191235
R2964 VSS.n545 VSS.n847 0.191235
R2965 VSS.t140 VSS.n545 0.191235
R2966 VSS.n848 VSS.t141 0.191235
R2967 VSS.n539 VSS.n849 0.191235
R2968 VSS.n850 VSS.n538 0.191235
R2969 VSS.n536 VSS.n850 0.191235
R2970 VSS.t146 VSS.n536 0.191235
R2971 VSS.t251 VSS.n796 0.191235
R2972 VSS.n804 VSS.n803 0.191235
R2973 VSS.n805 VSS.n804 0.191235
R2974 VSS.n807 VSS.n791 0.191235
R2975 VSS.n811 VSS.t136 0.191235
R2976 VSS.n812 VSS.n811 0.191235
R2977 VSS.n790 VSS.n812 0.191235
R2978 VSS.n813 VSS.t137 0.191235
R2979 VSS.n816 VSS.n815 0.191235
R2980 VSS.n817 VSS.n816 0.191235
R2981 VSS.n781 VSS.n780 0.191235
R2982 VSS.n785 VSS.n784 0.191235
R2983 VSS.n786 VSS.n785 0.191235
R2984 VSS.n440 VSS.n93 0.23732
R2985 VSS.n538 VSS.t144 0.191235
R2986 VSS.t144 VSS.n539 0.191235
R2987 VSS.t137 VSS.n790 0.191235
R2988 VSS.n795 VSS.t251 0.191235
R2989 VSS.n791 VSS.t136 0.191235
R2990 VSS.t141 VSS.t140 0.191235
R2991 VSS.n535 VSS.t146 0.191235
R2992 VSS.t271 VSS.t268 0.1875
R2993 VSS.t265 VSS.t261 0.1875
R2994 VSS.t277 VSS.t274 0.1875
R2995 VSS.n622 VSS.t93 0.187025
R2996 VSS.n623 VSS.n622 0.187025
R2997 VSS.n626 VSS.n625 0.187025
R2998 VSS.n627 VSS.n626 0.187025
R2999 VSS.n628 VSS.n627 0.187025
R3000 VSS.n629 VSS.n628 0.187025
R3001 VSS.n630 VSS.n629 0.187025
R3002 VSS.n631 VSS.n630 0.187025
R3003 VSS.n632 VSS.n631 0.187025
R3004 VSS.n633 VSS.n632 0.187025
R3005 VSS.n634 VSS.n633 0.187025
R3006 VSS.n787 VSS.n690 0.185557
R3007 VSS.n778 VSS.n687 0.183391
R3008 VSS.n693 VSS.n774 0.181924
R3009 VSS.n688 VSS.n692 0.181924
R3010 VSS.n799 VSS.t249 0.167615
R3011 VSS.n690 VSS.n774 0.164424
R3012 VSS.n689 VSS.n688 0.164424
R3013 VSS.n94 VSS.n181 0.160396
R3014 VSS.n94 VSS.n183 0.160396
R3015 VSS.n94 VSS.n184 0.160396
R3016 VSS.n612 VSS.n572 0.156138
R3017 VSS.n843 VSS.n553 0.150687
R3018 VSS.t86 VSS.n71 0.14953
R3019 VSS.t66 VSS.n71 0.149502
R3020 VSS.n888 VSS.n251 0.144066
R3021 VSS.n782 VSS.n781 0.143368
R3022 VSS.n784 VSS.n783 0.143368
R3023 VSS.t284 VSS.n317 0.139294
R3024 VSS.t61 VSS.n71 0.138788
R3025 VSS.t70 VSS.n71 0.138776
R3026 VSS.t78 VSS.n71 0.138705
R3027 VSS.t79 VSS.n71 0.1387
R3028 VSS.n842 VSS.n185 0.138073
R3029 VSS.t278 VSS.t27 0.135868
R3030 VSS.t281 VSS.n319 0.124618
R3031 VSS.t278 VSS.n316 0.122118
R3032 VSS.n319 VSS.t280 0.122118
R3033 VSS.n775 VSS.t254 0.1171
R3034 VSS.n549 VSS.n551 0.112118
R3035 VSS.n796 VSS.n797 0.112118
R3036 VSS.t74 VSS.n71 0.11127
R3037 VSS.t167 VSS.n308 0.109701
R3038 VSS.n440 VSS.t282 0.109642
R3039 VSS.n692 VSS.n691 0.104618
R3040 VSS.n693 VSS.n761 0.104618
R3041 VSS.t91 VSS.n71 0.103331
R3042 VSS.t266 VSS.n565 0.0971176
R3043 VSS.n612 VSS.n573 0.0971176
R3044 VSS.n572 VSS.n571 0.0958002
R3045 VSS.n571 VSS.n569 0.0955
R3046 VSS.n787 VSS.n598 0.0949351
R3047 VSS.n582 VSS.n581 0.093
R3048 VSS.t272 VSS.n354 0.08925
R3049 VSS.n527 VSS.t222 0.08925
R3050 VSS.t268 VSS.n589 0.0851154
R3051 VSS.n590 VSS.t271 0.0851154
R3052 VSS.t261 VSS.n578 0.0851154
R3053 VSS.n579 VSS.t265 0.0851154
R3054 VSS.t274 VSS.n524 0.0851154
R3055 VSS.n525 VSS.t277 0.0851154
R3056 VSS.n618 VSS.t343 0.0846176
R3057 VSS.n621 VSS.n555 0.0846176
R3058 VSS.n824 VSS.n823 0.08425
R3059 VSS.n743 VSS.n742 0.08425
R3060 VSS.n578 VSS.n6 0.08175
R3061 VSS.n589 VSS.n584 0.08175
R3062 VSS.n577 VSS.n562 0.08175
R3063 VSS.n588 VSS.n566 0.08175
R3064 VSS.n779 VSS.n778 0.0812779
R3065 VSS.n866 VSS.n865 0.0805
R3066 VSS.n829 VSS.n828 0.0805
R3067 VSS.n551 VSS.n550 0.0796176
R3068 VSS.n797 VSS.n798 0.0796176
R3069 VSS.t148 VSS.n529 0.078
R3070 VSS.t284 VSS.n318 0.0771176
R3071 VSS.n830 VSS.n829 0.07675
R3072 VSS.n550 VSS.n846 0.0758676
R3073 VSS.n798 VSS.n801 0.0758676
R3074 VSS.n524 VSS.n356 0.0746176
R3075 VSS.n523 VSS.n353 0.0746176
R3076 VSS.n839 VSS.n554 0.07425
R3077 VSS.n828 VSS.n689 0.07425
R3078 VSS.t262 VSS.n559 0.0740901
R3079 VSS.t259 VSS.n558 0.0740901
R3080 VSS.t419 VSS.n554 0.07175
R3081 VSS.t19 VSS.n530 0.071543
R3082 VSS.t62 VSS.n618 0.0708676
R3083 VSS.t77 VSS.n621 0.0708676
R3084 VSS.t280 VSS.n318 0.0696176
R3085 VSS.n524 VSS.t224 0.06925
R3086 VSS.t511 VSS.n212 0.06925
R3087 VSS.t521 VSS.n229 0.06925
R3088 VSS.t531 VSS.n248 0.06925
R3089 VSS.t541 VSS.n269 0.06925
R3090 VSS.t551 VSS.n286 0.06925
R3091 VSS.t561 VSS.n305 0.06925
R3092 VSS.n825 VSS.n824 0.06925
R3093 VSS.n755 VSS.n743 0.06925
R3094 VSS.t419 VSS.n830 0.06925
R3095 VSS.n523 VSS.n352 0.06925
R3096 VSS.n579 VSS.n575 0.0671176
R3097 VSS.n590 VSS.n586 0.0671176
R3098 VSS.n576 VSS.n563 0.0671176
R3099 VSS.n587 VSS.n567 0.0671176
R3100 VSS.n578 VSS.n575 0.0621177
R3101 VSS.n589 VSS.n586 0.0621177
R3102 VSS.n577 VSS.n563 0.0621177
R3103 VSS.n588 VSS.n567 0.0621177
R3104 VSS.n522 VSS.n352 0.05925
R3105 VSS.n525 VSS.t224 0.05925
R3106 VSS.t82 VSS.n565 0.0571176
R3107 VSS.n780 VSS.n779 0.0558676
R3108 VSS.t222 VSS.n356 0.0546176
R3109 VSS.t272 VSS.n353 0.0546176
R3110 VSS.t509 VSS.n212 0.05175
R3111 VSS.t519 VSS.n229 0.05175
R3112 VSS.n248 VSS.t529 0.05175
R3113 VSS.t539 VSS.n269 0.05175
R3114 VSS.t549 VSS.n286 0.05175
R3115 VSS.n305 VSS.t559 0.05175
R3116 VSS.n598 VSS.n786 0.0508676
R3117 VSS.n691 VSS.n827 0.0496177
R3118 VSS.n761 VSS.n760 0.0496177
R3119 VSS.n583 VSS.n582 0.04925
R3120 VSS.n783 VSS.n775 0.04925
R3121 VSS.n829 VSS.n687 0.048
R3122 VSS.n584 VSS.n583 0.04675
R3123 VSS.t266 VSS.n566 0.04675
R3124 VSS.n782 VSS.n775 0.04675
R3125 VSS.n8 VSS.n5 0.0161289
R3126 VSS.n836 VSS.n6 0.0305
R3127 VSS.n562 VSS.n561 0.0305
R3128 VSS.t282 VSS.n155 0.02925
R3129 VSS.n559 VSS.n557 0.0253401
R3130 VSS.n776 VSS.n558 0.0253401
R3131 VSS.n867 VSS.n315 0.023135
R3132 VSS.n867 VSS.n311 0.023135
R3133 VSS.n871 VSS.n870 0.023135
R3134 VSS.n876 VSS.n295 0.023135
R3135 VSS.n876 VSS.n296 0.023135
R3136 VSS.n879 VSS.n290 0.023135
R3137 VSS.n882 VSS.n277 0.023135
R3138 VSS.n882 VSS.n278 0.023135
R3139 VSS.n885 VSS.n273 0.023135
R3140 VSS.n888 VSS.n253 0.023135
R3141 VSS.n888 VSS.n255 0.023135
R3142 VSS.n888 VSS.n256 0.023135
R3143 VSS.n888 VSS.n257 0.023135
R3144 VSS.n892 VSS.n891 0.023135
R3145 VSS.n897 VSS.n238 0.023135
R3146 VSS.n897 VSS.n239 0.023135
R3147 VSS.n900 VSS.n233 0.023135
R3148 VSS.n903 VSS.n220 0.023135
R3149 VSS.n903 VSS.n221 0.023135
R3150 VSS.n906 VSS.n216 0.023135
R3151 VSS.n909 VSS.n188 0.023135
R3152 VSS.n909 VSS.n192 0.023135
R3153 VSS.n909 VSS.n202 0.023135
R3154 VSS.n865 VSS.n316 0.02175
R3155 VSS.n186 VSS.t289 0.0191553
R3156 VSS.n669 VSS.t329 0.0184075
R3157 VSS.n655 VSS.t325 0.0184075
R3158 VSS.t338 VSS.n682 0.0173993
R3159 VSS.n836 VSS.t262 0.01675
R3160 VSS.n561 VSS.t259 0.01675
R3161 VSS.n94 VSS.n180 0.0165542
R3162 VSS.n94 VSS.n182 0.0165542
R3163 VSS.n866 VSS.n155 0.0155
R3164 VSS.t306 VSS.n59 0.0151406
R3165 VSS.n663 VSS.n64 0.0151406
R3166 VSS.n662 VSS.n64 0.0151406
R3167 VSS.n651 VSS.n608 0.0151406
R3168 VSS.t338 VSS.n678 0.0150892
R3169 VSS VSS.n910 0.0134067
R3170 VSS.n570 VSS.n569 0.013
R3171 VSS.n94 VSS.n175 0.00962826
R3172 VSS.n94 VSS.n171 0.00962826
R3173 VSS.n94 VSS.n168 0.00962826
R3174 VSS.n94 VSS.n165 0.00962826
R3175 VSS.n94 VSS.n163 0.00962826
R3176 VSS.n94 VSS.n156 0.00938635
R3177 VSS.n94 VSS.n128 0.00937856
R3178 VSS.n94 VSS.n101 0.00937856
R3179 VSS.n94 VSS.n114 0.00937856
R3180 VSS.n94 VSS.n116 0.00937856
R3181 VSS.n94 VSS.n121 0.00937856
R3182 VSS.n94 VSS.n125 0.00937856
R3183 VSS.n94 VSS.n131 0.00937856
R3184 VSS.n94 VSS.n135 0.00937856
R3185 VSS.n94 VSS.n144 0.00937856
R3186 VSS.n94 VSS.n153 0.00937856
R3187 VSS.n94 VSS.n96 0.00937856
R3188 VSS.n94 VSS.n108 0.00937856
R3189 VSS.n858 VSS.n527 0.00675
R3190 VSS.n841 VSS.n354 0.00675
R3191 VSS.n840 VSS.n38 0.00459701
R3192 VSS.n8 VSS.n0 0.00296307
R3193 VSS.n831 VSS.n38 0.00216667
R3194 VSS.n93 VSS.n92 4.19564
R3195 VSS.n77 VSS.n620 0.00952127
R3196 VSS.n14 VSS.n777 0.00649396
R3197 VSS.n639 VSS.n71 0.00412425
R3198 VSS.n42 VSS.n43 0.00399966
R3199 VSS.n29 VSS.n30 0.00399966
R3200 VSS.n48 VSS.n50 0.00349933
R3201 VSS.n21 VSS.n38 0.00433305
R3202 VSS.n25 VSS.n546 0.00362425
R3203 VSS.n789 VSS.n57 0.00266647
R3204 VSS.n47 VSS.n46 0.00249999
R3205 VSS.n49 VSS.n48 0.00224999
R3206 VSS.n34 VSS.n32 0.0026245
R3207 VSS.n65 VSS.n64 0.0022
R3208 VSS.n38 VSS.n39 0.00216658
R3209 VSS.n11 VSS.n10 0.00199999
R3210 VSS.n36 VSS.n10 0.00199992
R3211 VSS.n853 VSS.n38 0.00193134
R3212 VSS.n8 VSS.n2 0.00186142
R3213 VSS.n313 VSS.n306 0.00179957
R3214 VSS.n312 VSS.n306 0.00179957
R3215 VSS.n873 VSS.n302 0.00179957
R3216 VSS.n299 VSS.n291 0.00179957
R3217 VSS.n298 VSS.n291 0.00179957
R3218 VSS.n288 VSS.n285 0.00179957
R3219 VSS.n281 VSS.n274 0.00179957
R3220 VSS.n280 VSS.n274 0.00179957
R3221 VSS.n271 VSS.n268 0.00179957
R3222 VSS.n259 VSS.n249 0.00179957
R3223 VSS.n258 VSS.n249 0.00179957
R3224 VSS.n894 VSS.n245 0.00179957
R3225 VSS.n242 VSS.n234 0.00179957
R3226 VSS.n241 VSS.n234 0.00179957
R3227 VSS.n231 VSS.n228 0.00179957
R3228 VSS.n224 VSS.n217 0.00179957
R3229 VSS.n223 VSS.n217 0.00179957
R3230 VSS.n214 VSS.n211 0.00179957
R3231 VSS.n909 VSS.n195 0.00179957
R3232 VSS.n909 VSS.n197 0.00179957
R3233 VSS.n909 VSS.n201 0.00179957
R3234 VSS.n23 VSS.n22 0.00169993
R3235 VSS.n542 VSS.n534 0.00166667
R3236 VSS.n540 VSS.n533 0.00166667
R3237 VSS.n29 VSS.n28 0.00138884
R3238 VSS.n12 VSS.n11 0.00169993
R3239 VSS.n42 VSS.n41 0.00138884
R3240 VSS.n47 VSS.n45 0.00149995
R3241 VSS.n792 VSS.n789 0.00166667
R3242 VSS.n89 VSS.n87 0.00169993
R3243 VSS.n91 VSS.n90 0.00169993
R3244 VSS.n808 VSS.n788 0.00162501
R3245 VSS.n91 VSS.n71 0.0015
R3246 VSS.n89 VSS.n88 0.0015
R3247 VSS.n69 VSS.n68 0.00214264
R3248 VSS.n69 VSS.t325 0.0015
R3249 VSS.n64 VSS.t325 0.0015
R3250 VSS.n808 VSS.n58 0.00137498
R3251 VSS.n674 VSS.t306 0.00136832
R3252 VSS.n792 VSS.n54 0.00133332
R3253 VSS.n544 VSS.n534 0.00133332
R3254 VSS.n542 VSS.n533 0.00133332
R3255 VSS.n8 VSS.n1 0.00128573
R3256 VSS.n909 VSS.n209 0.00104691
R3257 VSS.n8 VSS.n3 0.00104112
R3258 VSS.n646 VSS.n71 0.00103066
R3259 VSS.n867 VSS.n310 0.00101811
R3260 VSS.n876 VSS.n875 0.00101811
R3261 VSS.n876 VSS.n301 0.00101811
R3262 VSS.n882 VSS.n284 0.00101811
R3263 VSS.n882 VSS.n283 0.00101811
R3264 VSS.n888 VSS.n267 0.00101811
R3265 VSS.n888 VSS.n261 0.00101811
R3266 VSS.n897 VSS.n896 0.00101811
R3267 VSS.n897 VSS.n244 0.00101811
R3268 VSS.n903 VSS.n227 0.00101811
R3269 VSS.n903 VSS.n226 0.00101811
R3270 VSS.n909 VSS.n210 0.00101811
R3271 VSS.n888 VSS.n264 0.00100065
R3272 VSS.n867 VSS.n309 0.00100065
R3273 VSS.n888 VSS.n254 0.00100065
R3274 VSS.n888 VSS.n262 0.00100065
R3275 VSS.n909 VSS.n189 0.00100065
R3276 VSS.n640 VSS.n71 0.00100005
R3277 VSS.n641 VSS.n71 0.00100002
R3278 VSS.n644 VSS.n71 0.00100001
R3279 VSS.n643 VSS.n71 0.00100001
R3280 VSS.n642 VSS.n71 0.00100001
R3281 VSS.n645 VSS.n71 0.001
R3282 VSS.n868 VSS.n306 0.001
R3283 VSS.n870 VSS.n869 0.001
R3284 VSS.n873 VSS.n303 0.001
R3285 VSS.n876 VSS.n294 0.001
R3286 VSS.n877 VSS.n291 0.001
R3287 VSS.n879 VSS.n878 0.001
R3288 VSS.n880 VSS.n285 0.001
R3289 VSS.n882 VSS.n881 0.001
R3290 VSS.n883 VSS.n274 0.001
R3291 VSS.n885 VSS.n884 0.001
R3292 VSS.n886 VSS.n268 0.001
R3293 VSS.n888 VSS.n887 0.001
R3294 VSS.n889 VSS.n249 0.001
R3295 VSS.n891 VSS.n890 0.001
R3296 VSS.n894 VSS.n246 0.001
R3297 VSS.n897 VSS.n237 0.001
R3298 VSS.n898 VSS.n234 0.001
R3299 VSS.n900 VSS.n899 0.001
R3300 VSS.n901 VSS.n228 0.001
R3301 VSS.n903 VSS.n902 0.001
R3302 VSS.n904 VSS.n217 0.001
R3303 VSS.n906 VSS.n905 0.001
R3304 VSS.n907 VSS.n211 0.001
R3305 VSS.n909 VSS.n908 0.001
R3306 VSS.n908 VSS.n211 0.001
R3307 VSS.n907 VSS.n906 0.001
R3308 VSS.n905 VSS.n217 0.001
R3309 VSS.n904 VSS.n903 0.001
R3310 VSS.n902 VSS.n228 0.001
R3311 VSS.n901 VSS.n900 0.001
R3312 VSS.n899 VSS.n234 0.001
R3313 VSS.n898 VSS.n897 0.001
R3314 VSS.n894 VSS.n237 0.001
R3315 VSS.n891 VSS.n246 0.001
R3316 VSS.n890 VSS.n249 0.001
R3317 VSS.n889 VSS.n888 0.001
R3318 VSS.n887 VSS.n268 0.001
R3319 VSS.n886 VSS.n885 0.001
R3320 VSS.n884 VSS.n274 0.001
R3321 VSS.n883 VSS.n882 0.001
R3322 VSS.n881 VSS.n285 0.001
R3323 VSS.n880 VSS.n879 0.001
R3324 VSS.n878 VSS.n291 0.001
R3325 VSS.n877 VSS.n876 0.001
R3326 VSS.n873 VSS.n294 0.001
R3327 VSS.n870 VSS.n303 0.001
R3328 VSS.n869 VSS.n306 0.001
R3329 VSS.n868 VSS.n867 0.001
R3330 VSS.n794 VSS.n40 0.001
R3331 VSS.n793 VSS.n44 0.001
R3332 VSS.n810 VSS.n49 0.00174999
R3333 VSS.n53 VSS.n52 0.00124999
R3334 VSS.n56 VSS.n55 0.00124999
R3335 VSS.n547 VSS.n20 0.001
R3336 VSS.n544 VSS.n27 0.001
R3337 VSS.n537 VSS.n31 0.001
R3338 VSS.n37 VSS.n35 0.00124999
R3339 VSS.n63 VSS.n62 0.00192843
R3340 VSS.n62 VSS.t329 0.0015
R3341 VSS.t306 VSS.t329 0.0015
R3342 VSS.n55 VSS.n58 0.0015
R3343 VSS.n52 VSS.n54 0.0015
R3344 VSS.n810 VSS.n46 0.0015
R3345 VSS.n37 VSS.n36 0.0015
R3346 VSS.n33 VSS.n32 0.0015
R3347 VSS.n537 VSS.n33 0.0015
R3348 VSS.n546 VSS.n23 0.0015
R3349 VSS.n777 VSS.n11 0.0015
R3350 VSS.n8 VSS.n7 0.00125
R3351 VSS.n651 VSS.n70 0.001
R3352 VSS.n620 VSS.n75 0.001
R3353 VSS.n619 VSS.n86 0.001
R3354 VSS.n788 VSS.n19 0.001
R3355 VSS.n616 VSS.n593 0.001
R3356 VSS.t338 VSS.n593 0.001
R3357 VSS.n592 VSS.n7 8.47794
R3358 VSS.n835 VSS.n7 8.50175
R3359 a_3747_311.n0 a_3747_311.t2 52.0388
R3360 a_3747_311.t0 a_3747_311.n0 35.4491
R3361 a_3747_311.n0 a_3747_311.t3 33.5891
R3362 a_3747_311.t1 a_3747_311.t0 5.61942
R3363 a_3171_311.n0 a_3171_311.t2 51.8377
R3364 a_3171_311.n0 a_3171_311.t3 33.3881
R3365 a_3171_311.t0 a_3171_311.n0 31.8923
R3366 a_3171_311.t1 a_3171_311.t0 5.61777
R3367 a_2595_311.n0 a_2595_311.t2 51.6367
R3368 a_2595_311.n0 a_2595_311.t3 33.187
R3369 a_2595_311.t0 a_2595_311.n0 27.993
R3370 a_2595_311.t1 a_2595_311.t0 5.73018
R3371 a_3747_1047.n0 a_3747_1047.t2 38.0081
R3372 a_3747_1047.n0 a_3747_1047.t3 33.3957
R3373 a_3747_1047.n1 a_3747_1047.t4 33.3957
R3374 a_3747_1047.n2 a_3747_1047.t5 33.3957
R3375 a_3747_1047.n3 a_3747_1047.t6 33.3957
R3376 a_3747_1047.n4 a_3747_1047.t7 33.3957
R3377 a_3747_1047.n5 a_3747_1047.t8 33.3957
R3378 a_3747_1047.n6 a_3747_1047.t9 33.3957
R3379 a_3747_1047.t0 a_3747_1047.n6 23.2419
R3380 a_3747_1047.t1 a_3747_1047.t0 5.61942
R3381 a_3747_1047.n6 a_3747_1047.n5 4.61291
R3382 a_3747_1047.n5 a_3747_1047.n4 4.61291
R3383 a_3747_1047.n4 a_3747_1047.n3 4.61291
R3384 a_3747_1047.n3 a_3747_1047.n2 4.61291
R3385 a_3747_1047.n2 a_3747_1047.n1 4.61291
R3386 a_3747_1047.n1 a_3747_1047.n0 4.61291
R3387 a_3171_1047.n0 a_3171_1047.t2 37.8054
R3388 a_3171_1047.n0 a_3171_1047.t3 33.193
R3389 a_3171_1047.n1 a_3171_1047.t4 33.193
R3390 a_3171_1047.n2 a_3171_1047.t5 33.193
R3391 a_3171_1047.n3 a_3171_1047.t6 33.193
R3392 a_3171_1047.n4 a_3171_1047.t7 33.193
R3393 a_3171_1047.n5 a_3171_1047.t8 33.193
R3394 a_3171_1047.n6 a_3171_1047.t9 33.193
R3395 a_3171_1047.t0 a_3171_1047.n6 23.0313
R3396 a_3171_1047.t1 a_3171_1047.t0 5.61777
R3397 a_3171_1047.n6 a_3171_1047.n5 4.61291
R3398 a_3171_1047.n5 a_3171_1047.n4 4.61291
R3399 a_3171_1047.n4 a_3171_1047.n3 4.61291
R3400 a_3171_1047.n3 a_3171_1047.n2 4.61291
R3401 a_3171_1047.n2 a_3171_1047.n1 4.61291
R3402 a_3171_1047.n1 a_3171_1047.n0 4.61291
R3403 a_2595_1047.n0 a_2595_1047.t2 37.7691
R3404 a_2595_1047.n0 a_2595_1047.t3 33.1567
R3405 a_2595_1047.n1 a_2595_1047.t4 33.1567
R3406 a_2595_1047.n2 a_2595_1047.t5 33.1567
R3407 a_2595_1047.n3 a_2595_1047.t6 33.1567
R3408 a_2595_1047.n4 a_2595_1047.t7 33.1567
R3409 a_2595_1047.n5 a_2595_1047.t8 33.1567
R3410 a_2595_1047.n6 a_2595_1047.t9 33.1567
R3411 a_2595_1047.t0 a_2595_1047.n6 22.7941
R3412 a_2595_1047.t1 a_2595_1047.t0 5.65522
R3413 a_2595_1047.n6 a_2595_1047.n5 4.61291
R3414 a_2595_1047.n5 a_2595_1047.n4 4.61291
R3415 a_2595_1047.n4 a_2595_1047.n3 4.61291
R3416 a_2595_1047.n3 a_2595_1047.n2 4.61291
R3417 a_2595_1047.n2 a_2595_1047.n1 4.61291
R3418 a_2595_1047.n1 a_2595_1047.n0 4.61291
R3419 a_2019_1047.n0 a_2019_1047.t2 37.9701
R3420 a_2019_1047.n0 a_2019_1047.t3 33.3577
R3421 a_2019_1047.n1 a_2019_1047.t4 33.3577
R3422 a_2019_1047.n2 a_2019_1047.t5 33.3577
R3423 a_2019_1047.n3 a_2019_1047.t6 33.3577
R3424 a_2019_1047.n4 a_2019_1047.t7 33.3577
R3425 a_2019_1047.n5 a_2019_1047.t8 33.3577
R3426 a_2019_1047.t0 a_2019_1047.t9 22.5945
R3427 a_2019_1047.t1 a_2019_1047.t0 5.62052
R3428 a_2019_1047.t9 a_2019_1047.n5 4.61291
R3429 a_2019_1047.n5 a_2019_1047.n4 4.61291
R3430 a_2019_1047.n4 a_2019_1047.n3 4.61291
R3431 a_2019_1047.n3 a_2019_1047.n2 4.61291
R3432 a_2019_1047.n2 a_2019_1047.n1 4.61291
R3433 a_2019_1047.n1 a_2019_1047.n0 4.61291
C1413 MUX_OUT VSS 3.24058f
C1414 MUX_SEL4 VSS 1.60778f
C1415 MUX_SEL3 VSS 0.90686f
C1416 MUX_SEL2 VSS 1.81137f
C1417 MUX_SEL1 VSS 0.95075f
C1418 MUX_SEL0 VSS 1.5515f
C1419 DELAY_VBIASP VSS 5.14023f
C1420 DELAY_OUT_LAST VSS 2.97841f
C1421 DELAY_VBIASN VSS 0.11242p
C1422 REF_CLK VSS 3.19236f
C1423 DLL_RESETN VSS 4.2198f
C1424 VDD VSS 61.876f
C1425 a_26985_519# VSS 0.17928f ; **FLOATING
C1426 a_23945_519# VSS 0.17928f ; **FLOATING
C1427 a_20905_519# VSS 0.17928f ; **FLOATING
C1428 a_17865_519# VSS 0.17593f ; **FLOATING
C1429 a_16851_309# VSS 0.38699f ; **FLOATING
C1430 a_16108_289# VSS 3.85084f ; **FLOATING
C1431 a_15964_289# VSS 0.17613f ; **FLOATING
C1432 a_15765_463# VSS 0.36132f ; **FLOATING
C1433 a_14825_519# VSS 0.17928f ; **FLOATING
C1434 a_11785_519# VSS 0.17928f ; **FLOATING
C1435 a_8745_519# VSS 0.17928f ; **FLOATING
C1436 a_5731_289# VSS 3.39133f ; **FLOATING
C1437 a_2019_311# VSS 1.61601f ; **FLOATING
C1438 a_5705_519# VSS 0.17638f ; **FLOATING
C1439 a_3449_331# VSS 0.18478f ; **FLOATING
C1440 a_2873_331# VSS 0.18321f ; **FLOATING
C1441 a_2297_331# VSS 0.18321f ; **FLOATING
C1442 a_1721_331# VSS 0.17001f ; **FLOATING
C1443 a_1544_289# VSS 0.30014f ; **FLOATING
C1444 a_1256_289# VSS 0.84266f ; **FLOATING
C1445 a_27991_1008# VSS 0.18706f ; **FLOATING
C1446 a_27915_1044# VSS 0.10926f ; **FLOATING
C1447 a_27124_1008# VSS 0.17878f ; **FLOATING
C1448 a_27048_1044# VSS 0.12122f ; **FLOATING
C1449 a_26471_1008# VSS 0.18175f ; **FLOATING
C1450 a_26395_1044# VSS 0.11073f ; **FLOATING
C1451 a_25604_1008# VSS 0.18087f ; **FLOATING
C1452 a_25630_1044# VSS 0.34158f ; **FLOATING
C1453 a_25528_1044# VSS 0.12433f ; **FLOATING
C1454 a_24951_1008# VSS 0.18335f ; **FLOATING
C1455 a_24875_1044# VSS 0.11016f ; **FLOATING
C1456 a_24084_1008# VSS 0.17878f ; **FLOATING
C1457 a_24008_1044# VSS 0.12122f ; **FLOATING
C1458 a_23431_1008# VSS 0.18175f ; **FLOATING
C1459 a_23355_1044# VSS 0.11073f ; **FLOATING
C1460 a_22564_1008# VSS 0.18087f ; **FLOATING
C1461 a_22590_1044# VSS 0.33314f ; **FLOATING
C1462 a_22488_1044# VSS 0.12433f ; **FLOATING
C1463 a_21911_1008# VSS 0.18335f ; **FLOATING
C1464 a_21835_1044# VSS 0.11016f ; **FLOATING
C1465 a_21044_1008# VSS 0.17878f ; **FLOATING
C1466 a_20968_1044# VSS 0.12122f ; **FLOATING
C1467 a_20391_1008# VSS 0.18175f ; **FLOATING
C1468 a_20315_1044# VSS 0.11073f ; **FLOATING
C1469 a_19524_1008# VSS 0.18087f ; **FLOATING
C1470 a_19550_1044# VSS 0.33563f ; **FLOATING
C1471 a_19448_1044# VSS 0.12433f ; **FLOATING
C1472 a_18871_1008# VSS 0.18335f ; **FLOATING
C1473 a_18795_1044# VSS 0.11016f ; **FLOATING
C1474 a_18004_1008# VSS 0.17878f ; **FLOATING
C1475 a_17928_1044# VSS 0.12122f ; **FLOATING
C1476 a_17351_1008# VSS 0.18022f ; **FLOATING
C1477 a_17275_1044# VSS 0.10926f ; **FLOATING
C1478 a_16484_1008# VSS 0.18023f ; **FLOATING
C1479 a_16510_1044# VSS 0.28935f ; **FLOATING
C1480 a_16408_1044# VSS 0.1229f ; **FLOATING
C1481 a_15831_1008# VSS 0.17846f ; **FLOATING
C1482 a_15755_1044# VSS 0.10926f ; **FLOATING
C1483 a_14964_1008# VSS 0.17878f ; **FLOATING
C1484 a_14888_1044# VSS 0.12122f ; **FLOATING
C1485 a_14311_1008# VSS 0.18175f ; **FLOATING
C1486 a_14235_1044# VSS 0.11073f ; **FLOATING
C1487 a_13444_1008# VSS 0.18087f ; **FLOATING
C1488 a_13470_1044# VSS 0.30333f ; **FLOATING
C1489 a_13368_1044# VSS 0.12433f ; **FLOATING
C1490 a_12791_1008# VSS 0.18335f ; **FLOATING
C1491 a_12715_1044# VSS 0.11016f ; **FLOATING
C1492 a_11924_1008# VSS 0.17878f ; **FLOATING
C1493 a_11848_1044# VSS 0.12122f ; **FLOATING
C1494 a_11271_1008# VSS 0.18175f ; **FLOATING
C1495 a_11195_1044# VSS 0.11073f ; **FLOATING
C1496 a_10404_1008# VSS 0.18087f ; **FLOATING
C1497 a_10430_1044# VSS 0.31665f ; **FLOATING
C1498 a_10328_1044# VSS 0.12433f ; **FLOATING
C1499 a_9751_1008# VSS 0.18335f ; **FLOATING
C1500 a_9675_1044# VSS 0.11016f ; **FLOATING
C1501 a_8884_1008# VSS 0.17878f ; **FLOATING
C1502 a_8808_1044# VSS 0.12122f ; **FLOATING
C1503 a_8231_1008# VSS 0.18175f ; **FLOATING
C1504 a_8155_1044# VSS 0.11073f ; **FLOATING
C1505 a_7364_1008# VSS 0.18087f ; **FLOATING
C1506 a_7390_1044# VSS 0.31357f ; **FLOATING
C1507 a_7288_1044# VSS 0.12433f ; **FLOATING
C1508 a_6711_1008# VSS 0.18335f ; **FLOATING
C1509 a_6635_1044# VSS 0.11016f ; **FLOATING
C1510 a_5844_1008# VSS 0.17878f ; **FLOATING
C1511 a_5768_1044# VSS 0.12122f ; **FLOATING
C1512 a_5191_1008# VSS 0.18022f ; **FLOATING
C1513 a_5115_1044# VSS 0.10926f ; **FLOATING
C1514 a_4324_1008# VSS 0.18023f ; **FLOATING
C1515 a_4350_1044# VSS 0.26655f ; **FLOATING
C1516 a_4248_1044# VSS 0.12443f ; **FLOATING
C1517 a_27705_1044# VSS 0.25297f ; **FLOATING
C1518 a_26185_1044# VSS 0.23475f ; **FLOATING
C1519 a_24665_1044# VSS 0.25433f ; **FLOATING
C1520 a_23145_1044# VSS 0.23475f ; **FLOATING
C1521 a_21625_1044# VSS 0.25433f ; **FLOATING
C1522 a_20105_1044# VSS 0.23475f ; **FLOATING
C1523 a_18585_1044# VSS 0.25433f ; **FLOATING
C1524 a_17065_1044# VSS 0.23386f ; **FLOATING
C1525 a_15545_1044# VSS 0.25297f ; **FLOATING
C1526 a_14025_1044# VSS 0.23475f ; **FLOATING
C1527 a_12505_1044# VSS 0.25433f ; **FLOATING
C1528 a_10985_1044# VSS 0.23475f ; **FLOATING
C1529 a_9465_1044# VSS 0.25433f ; **FLOATING
C1530 a_7945_1044# VSS 0.23475f ; **FLOATING
C1531 a_6425_1044# VSS 0.25433f ; **FLOATING
C1532 a_4905_1044# VSS 0.23549f ; **FLOATING
C1533 a_4157_1313# VSS 0.32875f ; **FLOATING
C1534 a_3449_1395# VSS 0.18629f ; **FLOATING
C1535 a_2873_1395# VSS 0.18349f ; **FLOATING
C1536 a_2297_1395# VSS 0.18349f ; **FLOATING
C1537 a_1721_1395# VSS 0.17029f ; **FLOATING
C1538 a_1544_1044# VSS 0.29829f ; **FLOATING
C1539 a_1256_1044# VSS 0.82974f ; **FLOATING
C1540 a_27671_1842# VSS 0.01336f ; **FLOATING
C1541 a_26911_1842# VSS 0.01336f ; **FLOATING
C1542 a_26151_1842# VSS 0.01336f ; **FLOATING
C1543 a_25391_1842# VSS 0.01336f ; **FLOATING
C1544 a_24631_1842# VSS 0.01336f ; **FLOATING
C1545 a_23871_1842# VSS 0.01336f ; **FLOATING
C1546 a_23111_1842# VSS 0.01336f ; **FLOATING
C1547 a_22351_1842# VSS 0.01336f ; **FLOATING
C1548 a_21591_1842# VSS 0.01336f ; **FLOATING
C1549 a_20831_1842# VSS 0.01336f ; **FLOATING
C1550 a_20071_1842# VSS 0.01336f ; **FLOATING
C1551 a_19311_1842# VSS 0.01336f ; **FLOATING
C1552 a_18551_1842# VSS 0.01336f ; **FLOATING
C1553 a_17791_1842# VSS 0.01336f ; **FLOATING
C1554 a_17031_1842# VSS 0.01336f ; **FLOATING
C1555 a_16271_1842# VSS 0.01336f ; **FLOATING
C1556 a_15511_1842# VSS 0.01336f ; **FLOATING
C1557 a_14751_1842# VSS 0.01336f ; **FLOATING
C1558 a_13991_1842# VSS 0.01336f ; **FLOATING
C1559 a_13231_1842# VSS 0.01336f ; **FLOATING
C1560 a_12471_1842# VSS 0.01336f ; **FLOATING
C1561 a_11711_1842# VSS 0.01336f ; **FLOATING
C1562 a_10951_1842# VSS 0.01336f ; **FLOATING
C1563 a_10191_1842# VSS 0.01336f ; **FLOATING
C1564 a_9431_1842# VSS 0.01336f ; **FLOATING
C1565 a_8671_1842# VSS 0.01336f ; **FLOATING
C1566 a_7911_1842# VSS 0.01336f ; **FLOATING
C1567 a_7151_1842# VSS 0.01336f ; **FLOATING
C1568 a_6391_1842# VSS 0.01336f ; **FLOATING
C1569 a_5631_1842# VSS 0.01336f ; **FLOATING
C1570 a_4871_1842# VSS 0.01336f ; **FLOATING
C1571 a_4111_1842# VSS 0.0139f ; **FLOATING
C1572 a_27563_1842# VSS 0.50316f ; **FLOATING
C1573 a_27997_1842# VSS 0.6484f ; **FLOATING
C1574 a_27433_1842# VSS 0.4463f ; **FLOATING
C1575 a_26803_1842# VSS 0.49934f ; **FLOATING
C1576 a_27237_1842# VSS 0.92967f ; **FLOATING
C1577 a_26673_1842# VSS 0.4492f ; **FLOATING
C1578 a_26043_1842# VSS 0.50169f ; **FLOATING
C1579 a_26477_1842# VSS 0.95928f ; **FLOATING
C1580 a_25913_1842# VSS 0.4508f ; **FLOATING
C1581 a_25283_1842# VSS 0.49938f ; **FLOATING
C1582 a_25717_1842# VSS 0.86841f ; **FLOATING
C1583 a_25153_1842# VSS 0.45035f ; **FLOATING
C1584 a_24523_1842# VSS 0.50075f ; **FLOATING
C1585 a_24957_1842# VSS 0.96341f ; **FLOATING
C1586 a_24393_1842# VSS 0.4463f ; **FLOATING
C1587 a_23763_1842# VSS 0.49934f ; **FLOATING
C1588 a_24197_1842# VSS 0.92543f ; **FLOATING
C1589 a_23633_1842# VSS 0.45062f ; **FLOATING
C1590 a_23003_1842# VSS 0.50169f ; **FLOATING
C1591 a_23437_1842# VSS 0.95769f ; **FLOATING
C1592 a_22873_1842# VSS 0.4508f ; **FLOATING
C1593 a_22243_1842# VSS 0.49938f ; **FLOATING
C1594 a_22677_1842# VSS 0.86841f ; **FLOATING
C1595 a_22113_1842# VSS 0.45249f ; **FLOATING
C1596 a_21483_1842# VSS 0.50075f ; **FLOATING
C1597 a_21917_1842# VSS 0.96341f ; **FLOATING
C1598 a_21353_1842# VSS 0.4463f ; **FLOATING
C1599 a_20723_1842# VSS 0.49992f ; **FLOATING
C1600 a_21157_1842# VSS 0.92543f ; **FLOATING
C1601 a_20593_1842# VSS 0.45196f ; **FLOATING
C1602 a_19963_1842# VSS 0.50169f ; **FLOATING
C1603 a_20397_1842# VSS 0.95769f ; **FLOATING
C1604 a_19833_1842# VSS 0.4508f ; **FLOATING
C1605 a_19203_1842# VSS 0.5005f ; **FLOATING
C1606 a_19637_1842# VSS 0.86841f ; **FLOATING
C1607 a_19073_1842# VSS 0.44947f ; **FLOATING
C1608 a_18443_1842# VSS 0.50075f ; **FLOATING
C1609 a_18877_1842# VSS 0.96341f ; **FLOATING
C1610 a_18313_1842# VSS 0.4463f ; **FLOATING
C1611 a_17683_1842# VSS 0.50046f ; **FLOATING
C1612 a_18117_1842# VSS 0.92543f ; **FLOATING
C1613 a_17553_1842# VSS 0.44782f ; **FLOATING
C1614 a_16923_1842# VSS 0.50165f ; **FLOATING
C1615 a_17357_1842# VSS 0.95769f ; **FLOATING
C1616 a_16793_1842# VSS 0.45049f ; **FLOATING
C1617 a_16163_1842# VSS 0.4946f ; **FLOATING
C1618 a_16597_1842# VSS 0.86359f ; **FLOATING
C1619 a_16033_1842# VSS 0.44618f ; **FLOATING
C1620 a_15403_1842# VSS 0.49465f ; **FLOATING
C1621 a_15837_1842# VSS 0.95171f ; **FLOATING
C1622 a_15273_1842# VSS 0.44439f ; **FLOATING
C1623 a_14643_1842# VSS 0.49305f ; **FLOATING
C1624 a_15077_1842# VSS 0.92116f ; **FLOATING
C1625 a_14513_1842# VSS 0.44501f ; **FLOATING
C1626 a_13883_1842# VSS 0.50862f ; **FLOATING
C1627 a_14317_1842# VSS 0.96009f ; **FLOATING
C1628 a_13753_1842# VSS 0.46427f ; **FLOATING
C1629 a_13123_1842# VSS 0.50173f ; **FLOATING
C1630 a_13557_1842# VSS 0.87587f ; **FLOATING
C1631 a_12993_1842# VSS 0.45643f ; **FLOATING
C1632 a_12363_1842# VSS 0.50854f ; **FLOATING
C1633 a_12797_1842# VSS 0.96142f ; **FLOATING
C1634 a_12233_1842# VSS 0.45757f ; **FLOATING
C1635 a_11603_1842# VSS 0.50267f ; **FLOATING
C1636 a_12037_1842# VSS 0.92866f ; **FLOATING
C1637 a_11473_1842# VSS 0.45177f ; **FLOATING
C1638 a_10843_1842# VSS 0.50491f ; **FLOATING
C1639 a_11277_1842# VSS 0.96053f ; **FLOATING
C1640 a_10713_1842# VSS 0.44901f ; **FLOATING
C1641 a_10083_1842# VSS 0.50223f ; **FLOATING
C1642 a_10517_1842# VSS 0.87053f ; **FLOATING
C1643 a_9953_1842# VSS 0.44673f ; **FLOATING
C1644 a_9323_1842# VSS 0.5026f ; **FLOATING
C1645 a_9757_1842# VSS 0.96312f ; **FLOATING
C1646 a_9193_1842# VSS 0.44361f ; **FLOATING
C1647 a_8563_1842# VSS 0.49203f ; **FLOATING
C1648 a_8997_1842# VSS 0.92196f ; **FLOATING
C1649 a_8433_1842# VSS 0.44439f ; **FLOATING
C1650 a_7803_1842# VSS 0.49435f ; **FLOATING
C1651 a_8237_1842# VSS 0.95422f ; **FLOATING
C1652 a_7673_1842# VSS 0.44737f ; **FLOATING
C1653 a_7043_1842# VSS 0.49204f ; **FLOATING
C1654 a_7477_1842# VSS 0.86493f ; **FLOATING
C1655 a_6913_1842# VSS 0.44442f ; **FLOATING
C1656 a_6283_1842# VSS 0.49343f ; **FLOATING
C1657 a_6717_1842# VSS 0.95763f ; **FLOATING
C1658 a_6153_1842# VSS 0.44292f ; **FLOATING
C1659 a_5523_1842# VSS 0.50322f ; **FLOATING
C1660 a_5957_1842# VSS 0.92646f ; **FLOATING
C1661 a_5393_1842# VSS 0.4596f ; **FLOATING
C1662 a_4763_1842# VSS 0.51043f ; **FLOATING
C1663 a_5197_1842# VSS 0.96509f ; **FLOATING
C1664 a_4633_1842# VSS 0.46282f ; **FLOATING
C1665 a_4003_1842# VSS 0.58808f ; **FLOATING
C1666 a_4437_1842# VSS 0.87628f ; **FLOATING
C1667 a_9712_3912# VSS 1.52086f ; **FLOATING
C1668 a_9444_3912# VSS 2.12877f ; **FLOATING
C1669 a_5778_3367# VSS 5.22809f ; **FLOATING
C1670 a_15464_3684# VSS 0.75391f ; **FLOATING
C1671 a_14757_5182# VSS 0.09495f ; **FLOATING
C1672 a_13880_5118# VSS 0.06985f ; **FLOATING
C1673 a_15688_5403# VSS 0.26291f ; **FLOATING
C1674 a_15108_5325# VSS 0.24458f ; **FLOATING
C1675 a_14851_5182# VSS 0.38123f ; **FLOATING
C1676 a_9444_4590# VSS 6.08222f ; **FLOATING
C1677 a_14111_5227# VSS 0.19866f ; **FLOATING
C1678 a_14009_5084# VSS 0.44622f ; **FLOATING
C1679 a_13592_5423# VSS 1.57456f ; **FLOATING
C1680 a_13306_5105# VSS 0.30095f ; **FLOATING
C1681 a_13566_5328# VSS 0.15441f ; **FLOATING
C1682 a_13132_5420# VSS 0.13036f ; **FLOATING
C1683 a_12907_5420# VSS 0.14377f ; **FLOATING
C1684 a_12907_5186# VSS 0.14861f ; **FLOATING
C1685 a_13106_5357# VSS 0.06343f ; **FLOATING
C1686 a_15304_4605# VSS 0.37009f ; **FLOATING
C1687 a_14757_6228# VSS 0.09586f ; **FLOATING
C1688 a_15688_5867# VSS 0.26405f ; **FLOATING
C1689 a_14851_6228# VSS 0.39588f ; **FLOATING
C1690 a_15108_6109# VSS 0.24582f ; **FLOATING
C1691 a_14111_5878# VSS 0.21915f ; **FLOATING
C1692 a_13880_6292# VSS 0.07345f ; **FLOATING
C1693 a_14009_5878# VSS 0.48187f ; **FLOATING
C1694 a_13592_5871# VSS 1.58208f ; **FLOATING
C1695 a_13566_5835# VSS 0.15442f ; **FLOATING
C1696 a_13045_6215# VSS 0.01124f ; **FLOATING
C1697 a_13306_6305# VSS 0.31701f ; **FLOATING
C1698 a_12849_5867# VSS 1.40248f ; **FLOATING
C1699 a_13121_5831# VSS 0.80439f ; **FLOATING
C1700 a_13019_5831# VSS 2.18715f ; **FLOATING
C1701 a_12656_5864# VSS 0.28393f ; **FLOATING
C1702 a_12355_5867# VSS 0.62262f ; **FLOATING
C1703 a_11397_6228# VSS 0.09495f ; **FLOATING
C1704 a_12158_5867# VSS 0.25874f ; **FLOATING
C1705 a_11491_6228# VSS 0.30073f ; **FLOATING
C1706 a_11748_6109# VSS 0.17021f ; **FLOATING
C1707 a_10751_5878# VSS 0.19918f ; **FLOATING
C1708 a_10520_6292# VSS 0.03671f ; **FLOATING
C1709 a_10649_5878# VSS 0.47308f ; **FLOATING
C1710 a_10232_5871# VSS 1.52123f ; **FLOATING
C1711 a_10206_5835# VSS 0.08466f ; **FLOATING
C1712 a_9946_6305# VSS 0.18126f ; **FLOATING
C1713 a_9772_5843# VSS 0.12435f ; **FLOATING
C1714 a_9746_5805# VSS 0.06613f ; **FLOATING
C1715 a_9547_6172# VSS 0.16037f ; **FLOATING
C1716 a_9547_5942# VSS 0.11966f ; **FLOATING
C1717 a_6854_5454# VSS 3.66026f ; **FLOATING
C1718 a_6126_3816# VSS 13.6177f ; **FLOATING
C1719 a_6854_5986# VSS 1.21519f ; **FLOATING
C1720 a_5974_5723# VSS 2.40124f ; **FLOATING
C1721 a_6326_4590# VSS 1.03474f ; **FLOATING
C1722 a_2019_1047.t2 VSS 0.93027f ; **FLOATING
C1723 a_2019_1047.t3 VSS 0.70623f ; **FLOATING
C1724 a_2019_1047.n0 VSS 5.00884f ; **FLOATING
C1725 a_2019_1047.t4 VSS 0.70623f ; **FLOATING
C1726 a_2019_1047.n1 VSS 3.38862f ; **FLOATING
C1727 a_2019_1047.t5 VSS 0.70623f ; **FLOATING
C1728 a_2019_1047.n2 VSS 3.38862f ; **FLOATING
C1729 a_2019_1047.t6 VSS 0.70623f ; **FLOATING
C1730 a_2019_1047.n3 VSS 3.38862f ; **FLOATING
C1731 a_2019_1047.t7 VSS 0.70623f ; **FLOATING
C1732 a_2019_1047.n4 VSS 3.38862f ; **FLOATING
C1733 a_2019_1047.t8 VSS 0.70623f ; **FLOATING
C1734 a_2019_1047.n5 VSS 3.38862f ; **FLOATING
C1735 a_2019_1047.t9 VSS 5.45485f ; **FLOATING
C1736 a_2019_1047.t0 VSS 1.07257f ; **FLOATING
C1737 a_2019_1047.t1 VSS 0.30486f ; **FLOATING
C1738 a_2595_1047.t2 VSS 1.36703f ; **FLOATING
C1739 a_2595_1047.t3 VSS 1.02094f ; **FLOATING
C1740 a_2595_1047.n0 VSS 7.76123f ; **FLOATING
C1741 a_2595_1047.t4 VSS 1.02094f ; **FLOATING
C1742 a_2595_1047.n1 VSS 5.2734f ; **FLOATING
C1743 a_2595_1047.t5 VSS 1.02094f ; **FLOATING
C1744 a_2595_1047.n2 VSS 5.2734f ; **FLOATING
C1745 a_2595_1047.t6 VSS 1.02094f ; **FLOATING
C1746 a_2595_1047.n3 VSS 5.2734f ; **FLOATING
C1747 a_2595_1047.t7 VSS 1.02094f ; **FLOATING
C1748 a_2595_1047.n4 VSS 5.2734f ; **FLOATING
C1749 a_2595_1047.t8 VSS 1.02094f ; **FLOATING
C1750 a_2595_1047.n5 VSS 5.2734f ; **FLOATING
C1751 a_2595_1047.t9 VSS 1.02094f ; **FLOATING
C1752 a_2595_1047.n6 VSS 7.58547f ; **FLOATING
C1753 a_2595_1047.t0 VSS 1.75119f ; **FLOATING
C1754 a_2595_1047.t1 VSS 0.48227f ; **FLOATING
C1755 a_3171_1047.t2 VSS 1.38443f ; **FLOATING
C1756 a_3171_1047.t3 VSS 1.03734f ; **FLOATING
C1757 a_3171_1047.n0 VSS 7.7786f ; **FLOATING
C1758 a_3171_1047.t4 VSS 1.03734f ; **FLOATING
C1759 a_3171_1047.n1 VSS 5.28085f ; **FLOATING
C1760 a_3171_1047.t5 VSS 1.03734f ; **FLOATING
C1761 a_3171_1047.n2 VSS 5.28085f ; **FLOATING
C1762 a_3171_1047.t6 VSS 1.03734f ; **FLOATING
C1763 a_3171_1047.n3 VSS 5.28085f ; **FLOATING
C1764 a_3171_1047.t7 VSS 1.03734f ; **FLOATING
C1765 a_3171_1047.n4 VSS 5.28085f ; **FLOATING
C1766 a_3171_1047.t8 VSS 1.03734f ; **FLOATING
C1767 a_3171_1047.n5 VSS 5.28085f ; **FLOATING
C1768 a_3171_1047.t9 VSS 1.03734f ; **FLOATING
C1769 a_3171_1047.n6 VSS 7.6835f ; **FLOATING
C1770 a_3171_1047.t0 VSS 1.77027f ; **FLOATING
C1771 a_3171_1047.t1 VSS 0.48084f ; **FLOATING
C1772 a_3747_1047.t2 VSS 0.96887f ; **FLOATING
C1773 a_3747_1047.t3 VSS 0.73761f ; **FLOATING
C1774 a_3747_1047.n0 VSS 5.16757f ; **FLOATING
C1775 a_3747_1047.t4 VSS 0.73761f ; **FLOATING
C1776 a_3747_1047.n1 VSS 3.49321f ; **FLOATING
C1777 a_3747_1047.t5 VSS 0.73761f ; **FLOATING
C1778 a_3747_1047.n2 VSS 3.49321f ; **FLOATING
C1779 a_3747_1047.t6 VSS 0.73761f ; **FLOATING
C1780 a_3747_1047.n3 VSS 3.49321f ; **FLOATING
C1781 a_3747_1047.t7 VSS 0.73761f ; **FLOATING
C1782 a_3747_1047.n4 VSS 3.49321f ; **FLOATING
C1783 a_3747_1047.t8 VSS 0.73761f ; **FLOATING
C1784 a_3747_1047.n5 VSS 3.49321f ; **FLOATING
C1785 a_3747_1047.t9 VSS 0.73761f ; **FLOATING
C1786 a_3747_1047.n6 VSS 5.187f ; **FLOATING
C1787 a_3747_1047.t0 VSS 1.18538f ; **FLOATING
C1788 a_3747_1047.t1 VSS 0.31338f ; **FLOATING
C1789 a_2595_311.t0 VSS 3.27037f ; **FLOATING
C1790 a_2595_311.t2 VSS 5.04145f ; **FLOATING
C1791 a_2595_311.t3 VSS 1.20632f ; **FLOATING
C1792 a_2595_311.n0 VSS 26.8668f ; **FLOATING
C1793 a_2595_311.t1 VSS 0.49572f ; **FLOATING
C1794 a_3171_311.t2 VSS 5.05009f ; **FLOATING
C1795 a_3171_311.t3 VSS 1.21149f ; **FLOATING
C1796 a_3171_311.n0 VSS 29.8499f ; **FLOATING
C1797 a_3171_311.t0 VSS 4.61154f ; **FLOATING
C1798 a_3171_311.t1 VSS 0.4973f ; **FLOATING
C1799 a_3747_311.t2 VSS 3.09203f ; **FLOATING
C1800 a_3747_311.t3 VSS 0.74422f ; **FLOATING
C1801 a_3747_311.n0 VSS 19.8885f ; **FLOATING
C1802 a_3747_311.t0 VSS 3.68893f ; **FLOATING
C1803 a_3747_311.t1 VSS 0.30537f ; **FLOATING
C1804 VSS.t419 VSS 3.22049f ; **FLOATING
C1805 VDD.n0 VSS 0.03677f ; **FLOATING
C1806 VDD.n1 VSS 1.12844f ; **FLOATING
C1807 VDD.n2 VSS 0.03011f ; **FLOATING
C1808 VDD.n3 VSS 0.46891f ; **FLOATING
C1809 VDD.n4 VSS 0.04223f ; **FLOATING
C1810 VDD.t4 VSS 49.9272f ; **FLOATING
C1811 VDD.n5 VSS 0.46891f ; **FLOATING
C1812 VDD.n6 VSS 0.46891f ; **FLOATING
C1813 VDD.n7 VSS 0.04223f ; **FLOATING
C1814 VDD.n8 VSS 0.46891f ; **FLOATING
C1815 VDD.n9 VSS 0.46891f ; **FLOATING
C1816 VDD.n10 VSS 0.46891f ; **FLOATING
C1817 VDD.n11 VSS 0.07686f ; **FLOATING
C1818 VDD.n12 VSS 0.40404f ; **FLOATING
C1819 VDD.n14 VSS 0.36478f ; **FLOATING
C1820 VDD.n16 VSS 0.44734f ; **FLOATING
C1821 VDD.n17 VSS 0.13601f ; **FLOATING
C1822 VDD.n18 VSS 0.44734f ; **FLOATING
C1823 VDD.n19 VSS 0.13601f ; **FLOATING
C1824 VDD.n20 VSS 0.44734f ; **FLOATING
C1825 VDD.n22 VSS 0.44734f ; **FLOATING
C1826 VDD.n23 VSS 0.13601f ; **FLOATING
C1827 VDD.n24 VSS 0.44734f ; **FLOATING
C1828 VDD.n25 VSS 0.13601f ; **FLOATING
C1829 VDD.n26 VSS 0.44734f ; **FLOATING
C1830 VDD.n27 VSS 0.26258f ; **FLOATING
C1831 VDD.n28 VSS 0.22975f ; **FLOATING
C1832 VDD.n30 VSS 1.61338f ; **FLOATING
C1833 VDD.t0 VSS 43.7538f ; **FLOATING
C1834 VDD.n31 VSS 0.06199f ; **FLOATING
C1835 VDD.n32 VSS 0.13601f ; **FLOATING
C1836 VDD.n33 VSS 0.13601f ; **FLOATING
C1837 VDD.n34 VSS 0.03109f ; **FLOATING
C1838 VDD.t336 VSS 0.0187f ; **FLOATING
C1839 VDD.n35 VSS 0.02516f ; **FLOATING
C1840 VDD.n36 VSS 0.07733f ; **FLOATING
C1841 VDD.n37 VSS 0.0214f ; **FLOATING
C1842 VDD.n38 VSS 0.02357f ; **FLOATING
C1843 VDD.n39 VSS 0.01579f ; **FLOATING
C1844 VDD.n40 VSS 0.10231f ; **FLOATING
C1845 VDD.n42 VSS 0.15084f ; **FLOATING
C1846 VDD.n43 VSS 0.01387f ; **FLOATING
C1847 VDD.n44 VSS 0.06543f ; **FLOATING
C1848 VDD.n45 VSS 0.08545f ; **FLOATING
C1849 VDD.n47 VSS 0.08436f ; **FLOATING
C1850 VDD.n48 VSS 0.05911f ; **FLOATING
C1851 VDD.n49 VSS 0.05911f ; **FLOATING
C1852 VDD.n50 VSS 0.08436f ; **FLOATING
C1853 VDD.n51 VSS 0.05911f ; **FLOATING
C1854 VDD.n52 VSS 0.05911f ; **FLOATING
C1855 VDD.n53 VSS 0.08436f ; **FLOATING
C1856 VDD.n54 VSS 0.05911f ; **FLOATING
C1857 VDD.n55 VSS 0.05911f ; **FLOATING
C1858 VDD.n56 VSS 0.0401f ; **FLOATING
C1859 VDD.n57 VSS 0.02073f ; **FLOATING
C1860 VDD.n58 VSS 0.14214f ; **FLOATING
C1861 VDD.n59 VSS 0.0409f ; **FLOATING
C1862 VDD.n60 VSS 0.01023f ; **FLOATING
C1863 VDD.n61 VSS 0.02577f ; **FLOATING
C1864 VDD.n62 VSS 0.03847f ; **FLOATING
C1865 VDD.n63 VSS 0.02115f ; **FLOATING
C1866 VDD.n64 VSS 0.01579f ; **FLOATING
C1867 VDD.n65 VSS 0.10657f ; **FLOATING
C1868 VDD.n66 VSS 0.05152f ; **FLOATING
C1869 VDD.n67 VSS 0.20413f ; **FLOATING
C1870 VDD.n68 VSS 0.05911f ; **FLOATING
C1871 VDD.n69 VSS 0.05622f ; **FLOATING
C1872 VDD.n70 VSS 0.03174f ; **FLOATING
C1873 VDD.n71 VSS 0.07372f ; **FLOATING
C1874 VDD.n72 VSS 0.01697f ; **FLOATING
C1875 VDD.n73 VSS 0.15122f ; **FLOATING
C1876 VDD.n74 VSS 0.03162f ; **FLOATING
C1877 VDD.n75 VSS 0.03566f ; **FLOATING
C1878 VDD.n76 VSS 0.13358f ; **FLOATING
C1879 VDD.n78 VSS 0.08629f ; **FLOATING
C1880 VDD.n79 VSS 0.13358f ; **FLOATING
C1881 VDD.n80 VSS 0.08629f ; **FLOATING
C1882 VDD.n82 VSS 0.13358f ; **FLOATING
C1883 VDD.n83 VSS 0.08629f ; **FLOATING
C1884 VDD.n85 VSS 0.02633f ; **FLOATING
C1885 VDD.n86 VSS 0.09631f ; **FLOATING
C1886 VDD.n87 VSS 0.13358f ; **FLOATING
C1887 VDD.n88 VSS 0.08629f ; **FLOATING
C1888 VDD.n90 VSS 0.13358f ; **FLOATING
C1889 VDD.n91 VSS 0.08629f ; **FLOATING
C1890 VDD.n93 VSS 0.13358f ; **FLOATING
C1891 VDD.n94 VSS 0.08629f ; **FLOATING
C1892 VDD.n96 VSS 0.08436f ; **FLOATING
C1893 VDD.n97 VSS 0.08436f ; **FLOATING
C1894 VDD.n98 VSS 0.08436f ; **FLOATING
C1895 VDD.n99 VSS 0.03062f ; **FLOATING
C1896 VDD.n100 VSS 0.01587f ; **FLOATING
C1897 VDD.n101 VSS 0.1004f ; **FLOATING
C1898 VDD.n102 VSS 0.04223f ; **FLOATING
C1899 VDD.n103 VSS 0.04223f ; **FLOATING
C1900 VDD.n104 VSS 0.04223f ; **FLOATING
C1901 VDD.n105 VSS 0.04223f ; **FLOATING
C1902 VDD.n106 VSS 0.13178f ; **FLOATING
C1903 VDD.t7 VSS 8.27061f ; **FLOATING
C1904 VDD.t153 VSS 0.03686f ; **FLOATING
C1905 VDD.t121 VSS 0.03686f ; **FLOATING
C1906 VDD.n107 VSS 0.12582f ; **FLOATING
C1907 VDD.n108 VSS 0.01589f ; **FLOATING
C1908 VDD.t216 VSS 0.04458f ; **FLOATING
C1909 VDD.t355 VSS 0.04458f ; **FLOATING
C1910 VDD.n109 VSS 0.14195f ; **FLOATING
C1911 VDD.n110 VSS 0.07513f ; **FLOATING
C1912 VDD.t334 VSS 0.03178f ; **FLOATING
C1913 VDD.n111 VSS 0.02157f ; **FLOATING
C1914 VDD.t333 VSS 0.02294f ; **FLOATING
C1915 VDD.t335 VSS 0.03552f ; **FLOATING
C1916 VDD.t337 VSS 0.03178f ; **FLOATING
C1917 VDD.t260 VSS 0.03178f ; **FLOATING
C1918 VDD.t339 VSS 0.03178f ; **FLOATING
C1919 VDD.n112 VSS 0.02157f ; **FLOATING
C1920 VDD.t338 VSS 0.02294f ; **FLOATING
C1921 VDD.t340 VSS 0.03552f ; **FLOATING
C1922 VDD.n113 VSS 0.01805f ; **FLOATING
C1923 VDD.t341 VSS 0.01871f ; **FLOATING
C1924 VDD.t342 VSS 0.03178f ; **FLOATING
C1925 VDD.n114 VSS 0.01895f ; **FLOATING
C1926 VDD.t61 VSS 0.03489f ; **FLOATING
C1927 VDD.t382 VSS 0.02373f ; **FLOATING
C1928 VDD.n115 VSS 0.11939f ; **FLOATING
C1929 VDD.t38 VSS 3.33549f ; **FLOATING
C1930 VDD.n116 VSS 0.64947f ; **FLOATING
C1931 VDD.n117 VSS 0.11552f ; **FLOATING
C1932 VDD.n118 VSS 0.02729f ; **FLOATING
C1933 VDD.t54 VSS 0.02621f ; **FLOATING
C1934 VDD.t58 VSS 0.02621f ; **FLOATING
C1935 VDD.n119 VSS 0.07782f ; **FLOATING
C1936 VDD.n120 VSS 0.03693f ; **FLOATING
C1937 VDD.t70 VSS 0.01216f ; **FLOATING
C1938 VDD.t55 VSS 0.06048f ; **FLOATING
C1939 VDD.n121 VSS 0.0245f ; **FLOATING
C1940 VDD.t369 VSS 0.01216f ; **FLOATING
C1941 VDD.t57 VSS 0.06048f ; **FLOATING
C1942 VDD.n122 VSS 0.0245f ; **FLOATING
C1943 VDD.n123 VSS 0.05408f ; **FLOATING
C1944 VDD.n124 VSS 0.01438f ; **FLOATING
C1945 VDD.t37 VSS 0.03563f ; **FLOATING
C1946 VDD.n125 VSS 0.06406f ; **FLOATING
C1947 VDD.n126 VSS 0.03523f ; **FLOATING
C1948 VDD.t385 VSS 0.0329f ; **FLOATING
C1949 VDD.n127 VSS 0.07634f ; **FLOATING
C1950 VDD.n128 VSS 0.02009f ; **FLOATING
C1951 VDD.t41 VSS 0.03686f ; **FLOATING
C1952 VDD.n129 VSS 0.16471f ; **FLOATING
C1953 VDD.t103 VSS 0.02621f ; **FLOATING
C1954 VDD.n130 VSS 0.14752f ; **FLOATING
C1955 VDD.t307 VSS 0.01216f ; **FLOATING
C1956 VDD.t128 VSS 0.06048f ; **FLOATING
C1957 VDD.n131 VSS 0.0245f ; **FLOATING
C1958 VDD.n132 VSS 0.03695f ; **FLOATING
C1959 VDD.n133 VSS 0.07142f ; **FLOATING
C1960 VDD.n134 VSS 0.02958f ; **FLOATING
C1961 VDD.n135 VSS 0.01559f ; **FLOATING
C1962 VDD.n136 VSS 0.03576f ; **FLOATING
C1963 VDD.n137 VSS 0.03118f ; **FLOATING
C1964 VDD.n138 VSS 0.03567f ; **FLOATING
C1965 VDD.n139 VSS 0.03578f ; **FLOATING
C1966 VDD.n140 VSS 0.01573f ; **FLOATING
C1967 VDD.t290 VSS 0.0329f ; **FLOATING
C1968 VDD.t67 VSS 0.0329f ; **FLOATING
C1969 VDD.t91 VSS 0.02954f ; **FLOATING
C1970 VDD.t368 VSS 0.0329f ; **FLOATING
C1971 VDD.n141 VSS 0.02717f ; **FLOATING
C1972 VDD.t237 VSS 0.04318f ; **FLOATING
C1973 VDD.n142 VSS 0.08282f ; **FLOATING
C1974 VDD.n143 VSS 0.02423f ; **FLOATING
C1975 VDD.t213 VSS 0.0329f ; **FLOATING
C1976 VDD.n144 VSS 0.07852f ; **FLOATING
C1977 VDD.n145 VSS 0.01153f ; **FLOATING
C1978 VDD.t29 VSS 0.03667f ; **FLOATING
C1979 VDD.t112 VSS 0.03667f ; **FLOATING
C1980 VDD.t167 VSS 0.03667f ; **FLOATING
C1981 VDD.t136 VSS 0.03667f ; **FLOATING
C1982 VDD.t293 VSS 0.0329f ; **FLOATING
C1983 VDD.t19 VSS 0.0329f ; **FLOATING
C1984 VDD.n146 VSS 0.09517f ; **FLOATING
C1985 VDD.n147 VSS 0.01506f ; **FLOATING
C1986 VDD.t152 VSS 0.0243f ; **FLOATING
C1987 VDD.t316 VSS 0.0243f ; **FLOATING
C1988 VDD.n148 VSS 0.08391f ; **FLOATING
C1989 VDD.t166 VSS 0.03248f ; **FLOATING
C1990 VDD.t134 VSS 0.03248f ; **FLOATING
C1991 VDD.t288 VSS 0.0243f ; **FLOATING
C1992 VDD.t68 VSS 0.0243f ; **FLOATING
C1993 VDD.t28 VSS 0.03248f ; **FLOATING
C1994 VDD.t111 VSS 0.03248f ; **FLOATING
C1995 VDD.t292 VSS 0.0243f ; **FLOATING
C1996 VDD.t21 VSS 0.0243f ; **FLOATING
C1997 VDD.t12 VSS 0.03248f ; **FLOATING
C1998 VDD.t317 VSS 0.03248f ; **FLOATING
C1999 VDD.n149 VSS 0.07665f ; **FLOATING
C2000 VDD.t13 VSS 0.03667f ; **FLOATING
C2001 VDD.t365 VSS 0.03667f ; **FLOATING
C2002 VDD.t289 VSS 0.0243f ; **FLOATING
C2003 VDD.t69 VSS 0.0243f ; **FLOATING
C2004 VDD.t73 VSS 0.03248f ; **FLOATING
C2005 VDD.t20 VSS 0.03248f ; **FLOATING
C2006 VDD.n150 VSS 0.06967f ; **FLOATING
C2007 VDD.t74 VSS 0.03667f ; **FLOATING
C2008 VDD.t182 VSS 0.03667f ; **FLOATING
C2009 VDD.n151 VSS 0.08757f ; **FLOATING
C2010 VDD.n152 VSS 0.01175f ; **FLOATING
C2011 VDD.t295 VSS 0.0329f ; **FLOATING
C2012 VDD.t144 VSS 0.03301f ; **FLOATING
C2013 VDD.t287 VSS 0.0329f ; **FLOATING
C2014 VDD.n153 VSS 0.06893f ; **FLOATING
C2015 VDD.n154 VSS 0.01294f ; **FLOATING
C2016 VDD.t235 VSS 0.0329f ; **FLOATING
C2017 VDD.t359 VSS 0.0329f ; **FLOATING
C2018 VDD.t319 VSS 0.0329f ; **FLOATING
C2019 VDD.t299 VSS 0.02954f ; **FLOATING
C2020 VDD.t24 VSS 0.02954f ; **FLOATING
C2021 VDD.t376 VSS 0.0329f ; **FLOATING
C2022 VDD.t409 VSS 0.10912f ; **FLOATING
C2023 VDD.t92 VSS 0.03171f ; **FLOATING
C2024 VDD.t147 VSS 0.04318f ; **FLOATING
C2025 VDD.t408 VSS 0.10912f ; **FLOATING
C2026 VDD.t25 VSS 0.03171f ; **FLOATING
C2027 VDD.t305 VSS 0.0329f ; **FLOATING
C2028 VDD.t86 VSS 0.02954f ; **FLOATING
C2029 VDD.t87 VSS 0.02954f ; **FLOATING
C2030 VDD.t90 VSS 0.02954f ; **FLOATING
C2031 VDD.t173 VSS 0.0329f ; **FLOATING
C2032 VDD.t126 VSS 0.0329f ; **FLOATING
C2033 VDD.t51 VSS 0.0329f ; **FLOATING
C2034 VDD.t64 VSS 0.0329f ; **FLOATING
C2035 VDD.t123 VSS 0.02954f ; **FLOATING
C2036 VDD.t180 VSS 0.04318f ; **FLOATING
C2037 VDD.t100 VSS 0.0329f ; **FLOATING
C2038 VDD.t161 VSS 0.02954f ; **FLOATING
C2039 VDD.t361 VSS 0.0329f ; **FLOATING
C2040 VDD.t215 VSS 0.02954f ; **FLOATING
C2041 VDD.t214 VSS 0.0329f ; **FLOATING
C2042 VDD.t94 VSS 0.02954f ; **FLOATING
C2043 VDD.t95 VSS 0.02954f ; **FLOATING
C2044 VDD.t63 VSS 0.04334f ; **FLOATING
C2045 VDD.t15 VSS 0.0329f ; **FLOATING
C2046 VDD.t98 VSS 0.02954f ; **FLOATING
C2047 VDD.t174 VSS 0.0329f ; **FLOATING
C2048 VDD.t18 VSS 0.0329f ; **FLOATING
C2049 VDD.t65 VSS 0.0329f ; **FLOATING
C2050 VDD.t221 VSS 0.02954f ; **FLOATING
C2051 VDD.t39 VSS 0.04318f ; **FLOATING
C2052 VDD.t163 VSS 0.02954f ; **FLOATING
C2053 VDD.t17 VSS 0.0329f ; **FLOATING
C2054 VDD.t245 VSS 0.02954f ; **FLOATING
C2055 VDD.t183 VSS 0.0329f ; **FLOATING
C2056 VDD.t377 VSS 0.0329f ; **FLOATING
C2057 VDD.t76 VSS 0.02954f ; **FLOATING
C2058 VDD.t77 VSS 0.02954f ; **FLOATING
C2059 VDD.t80 VSS 0.02954f ; **FLOATING
C2060 VDD.t158 VSS 0.0329f ; **FLOATING
C2061 VDD.t366 VSS 0.0329f ; **FLOATING
C2062 VDD.t130 VSS 0.0329f ; **FLOATING
C2063 VDD.t285 VSS 0.0329f ; **FLOATING
C2064 VDD.t27 VSS 0.04318f ; **FLOATING
C2065 VDD.t10 VSS 0.0329f ; **FLOATING
C2066 VDD.t5 VSS 0.0329f ; **FLOATING
C2067 VDD.t71 VSS 0.0329f ; **FLOATING
C2068 VDD.t232 VSS 0.0329f ; **FLOATING
C2069 VDD.t320 VSS 0.03493f ; **FLOATING
C2070 VDD.t104 VSS 0.04318f ; **FLOATING
C2071 VDD.t321 VSS 0.06169f ; **FLOATING
C2072 VDD.t62 VSS 0.0329f ; **FLOATING
C2073 VDD.t149 VSS 0.0329f ; **FLOATING
C2074 VDD.t358 VSS 0.0329f ; **FLOATING
C2075 VDD.t114 VSS 0.0329f ; **FLOATING
C2076 VDD.t131 VSS 0.02954f ; **FLOATING
C2077 VDD.t239 VSS 0.04318f ; **FLOATING
C2078 VDD.t291 VSS 0.0329f ; **FLOATING
C2079 VDD.t142 VSS 0.02954f ; **FLOATING
C2080 VDD.t9 VSS 0.0329f ; **FLOATING
C2081 VDD.t354 VSS 0.02954f ; **FLOATING
C2082 VDD.t178 VSS 0.0329f ; **FLOATING
C2083 VDD.t311 VSS 0.02954f ; **FLOATING
C2084 VDD.t312 VSS 0.02954f ; **FLOATING
C2085 VDD.t211 VSS 0.04334f ; **FLOATING
C2086 VDD.t59 VSS 0.0329f ; **FLOATING
C2087 VDD.t315 VSS 0.02954f ; **FLOATING
C2088 VDD.t113 VSS 0.0329f ; **FLOATING
C2089 VDD.t52 VSS 0.0329f ; **FLOATING
C2090 VDD.t220 VSS 0.0329f ; **FLOATING
C2091 VDD.t139 VSS 0.02954f ; **FLOATING
C2092 VDD.t137 VSS 0.04318f ; **FLOATING
C2093 VDD.t171 VSS 0.02954f ; **FLOATING
C2094 VDD.t47 VSS 0.0329f ; **FLOATING
C2095 VDD.t176 VSS 0.02954f ; **FLOATING
C2096 VDD.t308 VSS 0.0329f ; **FLOATING
C2097 VDD.t378 VSS 0.0329f ; **FLOATING
C2098 VDD.t223 VSS 0.02954f ; **FLOATING
C2099 VDD.t224 VSS 0.02954f ; **FLOATING
C2100 VDD.t227 VSS 0.02954f ; **FLOATING
C2101 VDD.t159 VSS 0.0329f ; **FLOATING
C2102 VDD.t231 VSS 0.0329f ; **FLOATING
C2103 VDD.t168 VSS 0.0329f ; **FLOATING
C2104 VDD.t247 VSS 0.0329f ; **FLOATING
C2105 VDD.t244 VSS 0.02954f ; **FLOATING
C2106 VDD.t43 VSS 0.04318f ; **FLOATING
C2107 VDD.t11 VSS 0.0329f ; **FLOATING
C2108 VDD.t23 VSS 0.02954f ; **FLOATING
C2109 VDD.t82 VSS 0.0329f ; **FLOATING
C2110 VDD.t175 VSS 0.02954f ; **FLOATING
C2111 VDD.t66 VSS 0.0329f ; **FLOATING
C2112 VDD.t31 VSS 0.02954f ; **FLOATING
C2113 VDD.t32 VSS 0.02954f ; **FLOATING
C2114 VDD.t187 VSS 0.04334f ; **FLOATING
C2115 VDD.t119 VSS 0.0329f ; **FLOATING
C2116 VDD.t35 VSS 0.02954f ; **FLOATING
C2117 VDD.t387 VSS 0.0329f ; **FLOATING
C2118 VDD.t46 VSS 0.0329f ; **FLOATING
C2119 VDD.t172 VSS 0.0329f ; **FLOATING
C2120 VDD.t101 VSS 0.04318f ; **FLOATING
C2121 VDD.t16 VSS 0.03956f ; **FLOATING
C2122 VDD.t392 VSS 0.10912f ; **FLOATING
C2123 VDD.t33 VSS 0.03171f ; **FLOATING
C2124 VDD.t393 VSS 0.10912f ; **FLOATING
C2125 VDD.t30 VSS 0.03171f ; **FLOATING
C2126 VDD.t394 VSS 0.10912f ; **FLOATING
C2127 VDD.t22 VSS 0.03171f ; **FLOATING
C2128 VDD.t117 VSS 0.04334f ; **FLOATING
C2129 VDD.t395 VSS 0.10912f ; **FLOATING
C2130 VDD.t225 VSS 0.03171f ; **FLOATING
C2131 VDD.t396 VSS 0.10912f ; **FLOATING
C2132 VDD.t177 VSS 0.03171f ; **FLOATING
C2133 VDD.t397 VSS 0.10912f ; **FLOATING
C2134 VDD.t140 VSS 0.03171f ; **FLOATING
C2135 VDD.t398 VSS 0.10912f ; **FLOATING
C2136 VDD.t313 VSS 0.03171f ; **FLOATING
C2137 VDD.t399 VSS 0.10912f ; **FLOATING
C2138 VDD.t310 VSS 0.03171f ; **FLOATING
C2139 VDD.t400 VSS 0.10912f ; **FLOATING
C2140 VDD.t132 VSS 0.03171f ; **FLOATING
C2141 VDD.n155 VSS 0.06199f ; **FLOATING
C2142 VDD.n156 VSS 0.01294f ; **FLOATING
C2143 VDD.n157 VSS 0.07329f ; **FLOATING
C2144 VDD.n158 VSS 0.0111f ; **FLOATING
C2145 VDD.n159 VSS 0.06465f ; **FLOATING
C2146 VDD.n160 VSS 0.01294f ; **FLOATING
C2147 VDD.n161 VSS 0.07973f ; **FLOATING
C2148 VDD.t179 VSS 0.04334f ; **FLOATING
C2149 VDD.t401 VSS 0.10912f ; **FLOATING
C2150 VDD.t78 VSS 0.03171f ; **FLOATING
C2151 VDD.t402 VSS 0.10912f ; **FLOATING
C2152 VDD.t75 VSS 0.03171f ; **FLOATING
C2153 VDD.t403 VSS 0.10912f ; **FLOATING
C2154 VDD.t162 VSS 0.03171f ; **FLOATING
C2155 VDD.t404 VSS 0.10912f ; **FLOATING
C2156 VDD.t96 VSS 0.03171f ; **FLOATING
C2157 VDD.t405 VSS 0.10912f ; **FLOATING
C2158 VDD.t93 VSS 0.03171f ; **FLOATING
C2159 VDD.t406 VSS 0.10912f ; **FLOATING
C2160 VDD.t124 VSS 0.03171f ; **FLOATING
C2161 VDD.t109 VSS 0.04334f ; **FLOATING
C2162 VDD.t407 VSS 0.10912f ; **FLOATING
C2163 VDD.t88 VSS 0.03171f ; **FLOATING
C2164 VDD.t348 VSS 0.06667f ; **FLOATING
C2165 VDD.n162 VSS 0.04832f ; **FLOATING
C2166 VDD.n163 VSS 0.04832f ; **FLOATING
C2167 VDD.n164 VSS 0.04824f ; **FLOATING
C2168 VDD.n165 VSS 0.04824f ; **FLOATING
C2169 VDD.n166 VSS 0.04824f ; **FLOATING
C2170 VDD.n167 VSS 0.04824f ; **FLOATING
C2171 VDD.n168 VSS 0.04832f ; **FLOATING
C2172 VDD.n169 VSS 0.04824f ; **FLOATING
C2173 VDD.n170 VSS 0.04832f ; **FLOATING
C2174 VDD.n171 VSS 0.04832f ; **FLOATING
C2175 VDD.n172 VSS 0.04824f ; **FLOATING
C2176 VDD.n173 VSS 0.04832f ; **FLOATING
C2177 VDD.n174 VSS 0.04824f ; **FLOATING
C2178 VDD.n175 VSS 0.04824f ; **FLOATING
C2179 VDD.n176 VSS 0.04832f ; **FLOATING
C2180 VDD.n177 VSS 0.04832f ; **FLOATING
C2181 VDD.n178 VSS 0.04824f ; **FLOATING
C2182 VDD.n179 VSS 0.04824f ; **FLOATING
C2183 VDD.n180 VSS 0.04832f ; **FLOATING
C2184 VDD.n181 VSS 0.04824f ; **FLOATING
C2185 VDD.n182 VSS 0.04824f ; **FLOATING
C2186 VDD.n183 VSS 0.04824f ; **FLOATING
C2187 VDD.n184 VSS 0.04832f ; **FLOATING
C2188 VDD.n185 VSS 0.04824f ; **FLOATING
C2189 VDD.n186 VSS 0.04824f ; **FLOATING
C2190 VDD.n187 VSS 0.04832f ; **FLOATING
C2191 VDD.n188 VSS 0.04832f ; **FLOATING
C2192 VDD.n189 VSS 0.04824f ; **FLOATING
C2193 VDD.n190 VSS 0.04832f ; **FLOATING
C2194 VDD.n191 VSS 0.04824f ; **FLOATING
C2195 VDD.n192 VSS 0.04824f ; **FLOATING
C2196 VDD.t344 VSS 0.03229f ; **FLOATING
C2197 VDD.t343 VSS 0.02303f ; **FLOATING
C2198 VDD.t347 VSS 0.03215f ; **FLOATING
C2199 VDD.t345 VSS 0.03552f ; **FLOATING
C2200 VDD.t346 VSS 0.01869f ; **FLOATING
C2201 VDD.t261 VSS 0.03178f ; **FLOATING
C2202 VDD.n193 VSS 0.09619f ; **FLOATING
C2203 VDD.n194 VSS 0.02357f ; **FLOATING
C2204 VDD.n195 VSS 0.07474f ; **FLOATING
C2205 VDD.n196 VSS 0.01381f ; **FLOATING
C2206 VDD.t45 VSS 0.03727f ; **FLOATING
C2207 VDD.n197 VSS 0.07758f ; **FLOATING
C2208 VDD.n198 VSS 0.03408f ; **FLOATING
C2209 VDD.t259 VSS 0.03178f ; **FLOATING
C2210 VDD.n199 VSS 0.1045f ; **FLOATING
C2211 VDD.n200 VSS 0.02357f ; **FLOATING
C2212 VDD.n201 VSS 0.05904f ; **FLOATING
C2213 VDD.n202 VSS 0.0138f ; **FLOATING
C2214 VDD.t48 VSS 0.03727f ; **FLOATING
C2215 VDD.n203 VSS 0.07763f ; **FLOATING
C2216 VDD.n204 VSS 0.03402f ; **FLOATING
C2217 VDD.t256 VSS 0.03178f ; **FLOATING
C2218 VDD.n205 VSS 0.10447f ; **FLOATING
C2219 VDD.n206 VSS 0.02357f ; **FLOATING
C2220 VDD.n207 VSS 0.05908f ; **FLOATING
C2221 VDD.n208 VSS 0.01381f ; **FLOATING
C2222 VDD.t44 VSS 0.03727f ; **FLOATING
C2223 VDD.n209 VSS 0.0776f ; **FLOATING
C2224 VDD.n210 VSS 0.03401f ; **FLOATING
C2225 VDD.t263 VSS 0.03178f ; **FLOATING
C2226 VDD.n211 VSS 0.10444f ; **FLOATING
C2227 VDD.n212 VSS 0.02357f ; **FLOATING
C2228 VDD.n213 VSS 0.05909f ; **FLOATING
C2229 VDD.n214 VSS 0.01381f ; **FLOATING
C2230 VDD.t2 VSS 0.03727f ; **FLOATING
C2231 VDD.n215 VSS 0.0776f ; **FLOATING
C2232 VDD.n216 VSS 0.03401f ; **FLOATING
C2233 VDD.t262 VSS 0.03178f ; **FLOATING
C2234 VDD.n217 VSS 0.10447f ; **FLOATING
C2235 VDD.n218 VSS 0.02357f ; **FLOATING
C2236 VDD.n219 VSS 0.05909f ; **FLOATING
C2237 VDD.n220 VSS 0.01381f ; **FLOATING
C2238 VDD.t110 VSS 0.03727f ; **FLOATING
C2239 VDD.n221 VSS 0.07761f ; **FLOATING
C2240 VDD.n222 VSS 0.03397f ; **FLOATING
C2241 VDD.t258 VSS 0.03178f ; **FLOATING
C2242 VDD.n223 VSS 0.10441f ; **FLOATING
C2243 VDD.n224 VSS 0.02357f ; **FLOATING
C2244 VDD.n225 VSS 0.05913f ; **FLOATING
C2245 VDD.n226 VSS 0.01381f ; **FLOATING
C2246 VDD.t50 VSS 0.03727f ; **FLOATING
C2247 VDD.n227 VSS 0.07761f ; **FLOATING
C2248 VDD.n228 VSS 0.03404f ; **FLOATING
C2249 VDD.t268 VSS 0.03178f ; **FLOATING
C2250 VDD.n229 VSS 0.10444f ; **FLOATING
C2251 VDD.n230 VSS 0.02357f ; **FLOATING
C2252 VDD.n231 VSS 0.05905f ; **FLOATING
C2253 VDD.n232 VSS 0.0138f ; **FLOATING
C2254 VDD.t138 VSS 0.03727f ; **FLOATING
C2255 VDD.n233 VSS 0.07765f ; **FLOATING
C2256 VDD.n234 VSS 0.03398f ; **FLOATING
C2257 VDD.t269 VSS 0.03178f ; **FLOATING
C2258 VDD.n235 VSS 0.1045f ; **FLOATING
C2259 VDD.n236 VSS 0.02357f ; **FLOATING
C2260 VDD.n237 VSS 0.05909f ; **FLOATING
C2261 VDD.n238 VSS 0.0138f ; **FLOATING
C2262 VDD.t360 VSS 0.03727f ; **FLOATING
C2263 VDD.n239 VSS 0.07763f ; **FLOATING
C2264 VDD.n240 VSS 0.03404f ; **FLOATING
C2265 VDD.t266 VSS 0.03178f ; **FLOATING
C2266 VDD.n241 VSS 0.10447f ; **FLOATING
C2267 VDD.n242 VSS 0.02357f ; **FLOATING
C2268 VDD.n243 VSS 0.05906f ; **FLOATING
C2269 VDD.n244 VSS 0.01381f ; **FLOATING
C2270 VDD.t296 VSS 0.03727f ; **FLOATING
C2271 VDD.n245 VSS 0.07761f ; **FLOATING
C2272 VDD.n246 VSS 0.03397f ; **FLOATING
C2273 VDD.t270 VSS 0.03178f ; **FLOATING
C2274 VDD.n247 VSS 0.10444f ; **FLOATING
C2275 VDD.n248 VSS 0.02357f ; **FLOATING
C2276 VDD.n249 VSS 0.05911f ; **FLOATING
C2277 VDD.n250 VSS 0.0138f ; **FLOATING
C2278 VDD.t14 VSS 0.03727f ; **FLOATING
C2279 VDD.n251 VSS 0.07761f ; **FLOATING
C2280 VDD.n252 VSS 0.03403f ; **FLOATING
C2281 VDD.t265 VSS 0.03178f ; **FLOATING
C2282 VDD.n253 VSS 0.1045f ; **FLOATING
C2283 VDD.n254 VSS 0.02357f ; **FLOATING
C2284 VDD.n255 VSS 0.05909f ; **FLOATING
C2285 VDD.n256 VSS 0.01381f ; **FLOATING
C2286 VDD.t106 VSS 0.03727f ; **FLOATING
C2287 VDD.n257 VSS 0.07762f ; **FLOATING
C2288 VDD.n258 VSS 0.034f ; **FLOATING
C2289 VDD.t252 VSS 0.03178f ; **FLOATING
C2290 VDD.n259 VSS 0.1045f ; **FLOATING
C2291 VDD.n260 VSS 0.02357f ; **FLOATING
C2292 VDD.n261 VSS 0.05908f ; **FLOATING
C2293 VDD.n262 VSS 0.01381f ; **FLOATING
C2294 VDD.t1 VSS 0.03727f ; **FLOATING
C2295 VDD.n263 VSS 0.0776f ; **FLOATING
C2296 VDD.n264 VSS 0.03401f ; **FLOATING
C2297 VDD.t272 VSS 0.03178f ; **FLOATING
C2298 VDD.n265 VSS 0.10447f ; **FLOATING
C2299 VDD.n266 VSS 0.02357f ; **FLOATING
C2300 VDD.n267 VSS 0.05909f ; **FLOATING
C2301 VDD.n268 VSS 0.01381f ; **FLOATING
C2302 VDD.t250 VSS 0.03727f ; **FLOATING
C2303 VDD.n269 VSS 0.0776f ; **FLOATING
C2304 VDD.n270 VSS 0.03401f ; **FLOATING
C2305 VDD.t257 VSS 0.03178f ; **FLOATING
C2306 VDD.n271 VSS 0.10444f ; **FLOATING
C2307 VDD.n272 VSS 0.02357f ; **FLOATING
C2308 VDD.n273 VSS 0.05909f ; **FLOATING
C2309 VDD.n274 VSS 0.01381f ; **FLOATING
C2310 VDD.t42 VSS 0.03727f ; **FLOATING
C2311 VDD.n275 VSS 0.07763f ; **FLOATING
C2312 VDD.n276 VSS 0.03398f ; **FLOATING
C2313 VDD.t271 VSS 0.03178f ; **FLOATING
C2314 VDD.n277 VSS 0.1045f ; **FLOATING
C2315 VDD.n278 VSS 0.02357f ; **FLOATING
C2316 VDD.n279 VSS 0.05909f ; **FLOATING
C2317 VDD.n280 VSS 0.0138f ; **FLOATING
C2318 VDD.t26 VSS 0.03727f ; **FLOATING
C2319 VDD.n281 VSS 0.07765f ; **FLOATING
C2320 VDD.n282 VSS 0.034f ; **FLOATING
C2321 VDD.t267 VSS 0.03178f ; **FLOATING
C2322 VDD.n283 VSS 0.10447f ; **FLOATING
C2323 VDD.n284 VSS 0.02357f ; **FLOATING
C2324 VDD.n285 VSS 0.05908f ; **FLOATING
C2325 VDD.n286 VSS 0.01381f ; **FLOATING
C2326 VDD.t3 VSS 0.03727f ; **FLOATING
C2327 VDD.n287 VSS 0.07763f ; **FLOATING
C2328 VDD.n288 VSS 0.03398f ; **FLOATING
C2329 VDD.t254 VSS 0.03178f ; **FLOATING
C2330 VDD.n289 VSS 0.10441f ; **FLOATING
C2331 VDD.n290 VSS 0.02357f ; **FLOATING
C2332 VDD.n291 VSS 0.05909f ; **FLOATING
C2333 VDD.n292 VSS 0.0138f ; **FLOATING
C2334 VDD.t116 VSS 0.03727f ; **FLOATING
C2335 VDD.n293 VSS 0.07764f ; **FLOATING
C2336 VDD.n294 VSS 0.03397f ; **FLOATING
C2337 VDD.t274 VSS 0.03178f ; **FLOATING
C2338 VDD.n295 VSS 0.10444f ; **FLOATING
C2339 VDD.n296 VSS 0.02357f ; **FLOATING
C2340 VDD.n297 VSS 0.05912f ; **FLOATING
C2341 VDD.n298 VSS 0.01381f ; **FLOATING
C2342 VDD.t150 VSS 0.03727f ; **FLOATING
C2343 VDD.n299 VSS 0.0776f ; **FLOATING
C2344 VDD.n300 VSS 0.03403f ; **FLOATING
C2345 VDD.t273 VSS 0.03178f ; **FLOATING
C2346 VDD.n301 VSS 0.1045f ; **FLOATING
C2347 VDD.n302 VSS 0.02357f ; **FLOATING
C2348 VDD.n303 VSS 0.05908f ; **FLOATING
C2349 VDD.n304 VSS 0.01381f ; **FLOATING
C2350 VDD.t238 VSS 0.03727f ; **FLOATING
C2351 VDD.n305 VSS 0.07758f ; **FLOATING
C2352 VDD.n306 VSS 0.03405f ; **FLOATING
C2353 VDD.t275 VSS 0.03178f ; **FLOATING
C2354 VDD.n307 VSS 0.10447f ; **FLOATING
C2355 VDD.n308 VSS 0.02357f ; **FLOATING
C2356 VDD.n309 VSS 0.05908f ; **FLOATING
C2357 VDD.n310 VSS 0.01381f ; **FLOATING
C2358 VDD.t8 VSS 0.03727f ; **FLOATING
C2359 VDD.n311 VSS 0.07761f ; **FLOATING
C2360 VDD.n312 VSS 0.03397f ; **FLOATING
C2361 VDD.t264 VSS 0.03178f ; **FLOATING
C2362 VDD.n313 VSS 0.10444f ; **FLOATING
C2363 VDD.n314 VSS 0.02357f ; **FLOATING
C2364 VDD.n315 VSS 0.05912f ; **FLOATING
C2365 VDD.n316 VSS 0.01381f ; **FLOATING
C2366 VDD.t212 VSS 0.03727f ; **FLOATING
C2367 VDD.n317 VSS 0.07758f ; **FLOATING
C2368 VDD.n318 VSS 0.03408f ; **FLOATING
C2369 VDD.t277 VSS 0.03178f ; **FLOATING
C2370 VDD.n319 VSS 0.10447f ; **FLOATING
C2371 VDD.n320 VSS 0.02357f ; **FLOATING
C2372 VDD.n321 VSS 0.05905f ; **FLOATING
C2373 VDD.n322 VSS 0.01381f ; **FLOATING
C2374 VDD.t60 VSS 0.03727f ; **FLOATING
C2375 VDD.n323 VSS 0.07758f ; **FLOATING
C2376 VDD.n324 VSS 0.03405f ; **FLOATING
C2377 VDD.t276 VSS 0.03178f ; **FLOATING
C2378 VDD.n325 VSS 0.10441f ; **FLOATING
C2379 VDD.n326 VSS 0.02357f ; **FLOATING
C2380 VDD.n327 VSS 0.05907f ; **FLOATING
C2381 VDD.n328 VSS 0.0138f ; **FLOATING
C2382 VDD.t36 VSS 0.03727f ; **FLOATING
C2383 VDD.n329 VSS 0.07763f ; **FLOATING
C2384 VDD.n330 VSS 0.03401f ; **FLOATING
C2385 VDD.t278 VSS 0.03178f ; **FLOATING
C2386 VDD.n331 VSS 0.10444f ; **FLOATING
C2387 VDD.n332 VSS 0.02357f ; **FLOATING
C2388 VDD.n333 VSS 0.05909f ; **FLOATING
C2389 VDD.n334 VSS 0.01381f ; **FLOATING
C2390 VDD.t185 VSS 0.03727f ; **FLOATING
C2391 VDD.n335 VSS 0.0776f ; **FLOATING
C2392 VDD.n336 VSS 0.03401f ; **FLOATING
C2393 VDD.t253 VSS 0.03178f ; **FLOATING
C2394 VDD.n337 VSS 0.10447f ; **FLOATING
C2395 VDD.n338 VSS 0.02357f ; **FLOATING
C2396 VDD.n339 VSS 0.05909f ; **FLOATING
C2397 VDD.n340 VSS 0.01381f ; **FLOATING
C2398 VDD.t193 VSS 0.03727f ; **FLOATING
C2399 VDD.n341 VSS 0.07758f ; **FLOATING
C2400 VDD.n342 VSS 0.03405f ; **FLOATING
C2401 VDD.t281 VSS 0.03178f ; **FLOATING
C2402 VDD.n343 VSS 0.10444f ; **FLOATING
C2403 VDD.n344 VSS 0.02357f ; **FLOATING
C2404 VDD.n345 VSS 0.05908f ; **FLOATING
C2405 VDD.n346 VSS 0.01381f ; **FLOATING
C2406 VDD.t229 VSS 0.03727f ; **FLOATING
C2407 VDD.n347 VSS 0.07761f ; **FLOATING
C2408 VDD.n348 VSS 0.03404f ; **FLOATING
C2409 VDD.t280 VSS 0.03178f ; **FLOATING
C2410 VDD.n349 VSS 0.1045f ; **FLOATING
C2411 VDD.n350 VSS 0.02357f ; **FLOATING
C2412 VDD.n351 VSS 0.05906f ; **FLOATING
C2413 VDD.n352 VSS 0.01381f ; **FLOATING
C2414 VDD.t169 VSS 0.03727f ; **FLOATING
C2415 VDD.n353 VSS 0.0776f ; **FLOATING
C2416 VDD.n354 VSS 0.03401f ; **FLOATING
C2417 VDD.t279 VSS 0.03178f ; **FLOATING
C2418 VDD.n355 VSS 0.1045f ; **FLOATING
C2419 VDD.n356 VSS 0.02357f ; **FLOATING
C2420 VDD.n357 VSS 0.05908f ; **FLOATING
C2421 VDD.n358 VSS 0.0138f ; **FLOATING
C2422 VDD.t83 VSS 0.03727f ; **FLOATING
C2423 VDD.n359 VSS 0.07763f ; **FLOATING
C2424 VDD.n360 VSS 0.03401f ; **FLOATING
C2425 VDD.t255 VSS 0.03178f ; **FLOATING
C2426 VDD.n361 VSS 0.1045f ; **FLOATING
C2427 VDD.n362 VSS 0.02357f ; **FLOATING
C2428 VDD.n363 VSS 0.05909f ; **FLOATING
C2429 VDD.n364 VSS 0.01381f ; **FLOATING
C2430 VDD.t148 VSS 0.03727f ; **FLOATING
C2431 VDD.n365 VSS 0.07761f ; **FLOATING
C2432 VDD.n366 VSS 0.03404f ; **FLOATING
C2433 VDD.t282 VSS 0.03178f ; **FLOATING
C2434 VDD.n367 VSS 0.10447f ; **FLOATING
C2435 VDD.n368 VSS 0.02357f ; **FLOATING
C2436 VDD.n369 VSS 0.05906f ; **FLOATING
C2437 VDD.n370 VSS 0.01381f ; **FLOATING
C2438 VDD.t108 VSS 0.03727f ; **FLOATING
C2439 VDD.n371 VSS 0.07759f ; **FLOATING
C2440 VDD.n372 VSS 0.03403f ; **FLOATING
C2441 VDD.t283 VSS 0.03178f ; **FLOATING
C2442 VDD.n373 VSS 0.10441f ; **FLOATING
C2443 VDD.n374 VSS 0.02357f ; **FLOATING
C2444 VDD.n375 VSS 0.05909f ; **FLOATING
C2445 VDD.n376 VSS 0.01381f ; **FLOATING
C2446 VDD.t102 VSS 0.03727f ; **FLOATING
C2447 VDD.n377 VSS 0.0776f ; **FLOATING
C2448 VDD.n378 VSS 0.03401f ; **FLOATING
C2449 VDD.t284 VSS 0.03178f ; **FLOATING
C2450 VDD.n379 VSS 0.08644f ; **FLOATING
C2451 VDD.n380 VSS 0.02357f ; **FLOATING
C2452 VDD.n381 VSS 0.05908f ; **FLOATING
C2453 VDD.n382 VSS 0.0138f ; **FLOATING
C2454 VDD.t219 VSS 0.03727f ; **FLOATING
C2455 VDD.n383 VSS 0.05918f ; **FLOATING
C2456 VDD.n384 VSS 0.01422f ; **FLOATING
C2457 VDD.t349 VSS 0.03178f ; **FLOATING
C2458 VDD.n385 VSS 0.02357f ; **FLOATING
C2459 VDD.t350 VSS 0.03552f ; **FLOATING
C2460 VDD.n386 VSS 0.06979f ; **FLOATING
C2461 VDD.t353 VSS 0.03178f ; **FLOATING
C2462 VDD.n387 VSS 0.0211f ; **FLOATING
C2463 VDD.t351 VSS 0.03071f ; **FLOATING
C2464 VDD.n388 VSS 0.01566f ; **FLOATING
C2465 VDD.n389 VSS 0.05923f ; **FLOATING
C2466 VDD.n390 VSS 0.05088f ; **FLOATING
C2467 VDD.n391 VSS 0.70249f ; **FLOATING
C2468 VDD.n392 VSS 2.34984f ; **FLOATING
C2469 VDD.n393 VSS 0.71812f ; **FLOATING
C2470 VDD.n394 VSS 0.01475f ; **FLOATING
C2471 VDD.t40 VSS 0.02171f ; **FLOATING
C2472 VDD.n395 VSS 0.06128f ; **FLOATING
C2473 VDD.n396 VSS 0.01535f ; **FLOATING
C2474 VDD.n397 VSS 0.01566f ; **FLOATING
C2475 VDD.n398 VSS 0.0678f ; **FLOATING
C2476 VDD.t203 VSS 0.06343f ; **FLOATING
C2477 VDD.n399 VSS 0.02215f ; **FLOATING
C2478 VDD.n400 VSS 0.04961f ; **FLOATING
C2479 VDD.t324 VSS 0.05675f ; **FLOATING
C2480 VDD.n401 VSS 0.02212f ; **FLOATING
C2481 VDD.t330 VSS 0.05675f ; **FLOATING
C2482 VDD.n402 VSS 0.06355f ; **FLOATING
C2483 VDD.n403 VSS 0.02213f ; **FLOATING
C2484 VDD.n404 VSS 0.04482f ; **FLOATING
C2485 VDD.t322 VSS 0.35887f ; **FLOATING
C2486 VDD.n405 VSS 0.01448f ; **FLOATING
C2487 VDD.n406 VSS 0.04479f ; **FLOATING
C2488 VDD.t195 VSS 0.06343f ; **FLOATING
C2489 VDD.n407 VSS 0.02214f ; **FLOATING
C2490 VDD.n408 VSS 0.06777f ; **FLOATING
C2491 VDD.n409 VSS 0.03578f ; **FLOATING
C2492 VDD.n410 VSS 0.08627f ; **FLOATING
C2493 VDD.t204 VSS 0.06343f ; **FLOATING
C2494 VDD.n411 VSS 0.04115f ; **FLOATING
C2495 VDD.t196 VSS 0.06343f ; **FLOATING
C2496 VDD.n412 VSS 0.04116f ; **FLOATING
C2497 VDD.n413 VSS 0.08625f ; **FLOATING
C2498 VDD.n414 VSS 0.03118f ; **FLOATING
C2499 VDD.n415 VSS 0.08647f ; **FLOATING
C2500 VDD.t206 VSS 0.06343f ; **FLOATING
C2501 VDD.n416 VSS 0.04115f ; **FLOATING
C2502 VDD.t198 VSS 0.06343f ; **FLOATING
C2503 VDD.n417 VSS 0.04116f ; **FLOATING
C2504 VDD.n418 VSS 0.08648f ; **FLOATING
C2505 VDD.n419 VSS 0.03565f ; **FLOATING
C2506 VDD.n420 VSS 0.08169f ; **FLOATING
C2507 VDD.t208 VSS 0.06343f ; **FLOATING
C2508 VDD.n421 VSS 0.04115f ; **FLOATING
C2509 VDD.t200 VSS 0.06343f ; **FLOATING
C2510 VDD.n422 VSS 0.04116f ; **FLOATING
C2511 VDD.n423 VSS 0.08168f ; **FLOATING
C2512 VDD.n424 VSS 0.03582f ; **FLOATING
C2513 VDD.n425 VSS 0.01573f ; **FLOATING
C2514 VDD.t327 VSS 0.05675f ; **FLOATING
C2515 VDD.t332 VSS 0.05675f ; **FLOATING
C2516 VDD.n426 VSS 0.0691f ; **FLOATING
C2517 VDD.n427 VSS 0.02213f ; **FLOATING
C2518 VDD.t202 VSS 0.06343f ; **FLOATING
C2519 VDD.n428 VSS 0.06778f ; **FLOATING
C2520 VDD.n429 VSS 0.02214f ; **FLOATING
C2521 VDD.n430 VSS 0.06779f ; **FLOATING
C2522 VDD.t210 VSS 0.06343f ; **FLOATING
C2523 VDD.n431 VSS 0.02215f ; **FLOATING
C2524 VDD.n432 VSS 0.04479f ; **FLOATING
C2525 VDD.t325 VSS 0.35887f ; **FLOATING
C2526 VDD.n433 VSS 0.01448f ; **FLOATING
C2527 VDD.n434 VSS 0.04801f ; **FLOATING
C2528 VDD.n435 VSS 0.02212f ; **FLOATING
C2529 VDD.n436 VSS 0.08076f ; **FLOATING
C2530 VDD.n437 VSS 0.04703f ; **FLOATING
C2531 VDD.t6 VSS 12.4932f ; **FLOATING
.ends
