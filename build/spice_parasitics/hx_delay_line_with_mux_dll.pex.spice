* NGSPICE file created from hx_delay_line_with_mux_dll.ext - technology: ihp-sg13g2

.subckt hx_delay_line_with_mux_dll VDD DELAY_OUT_LAST VSS DELAY_VBIASN DELAY_VBIASP
+ DLL_RESETN REF_CLK MUX_SEL0 MUX_SEL1 MUX_OUT MUX_SEL4 MUX_SEL2 MUX_SEL3
X0 a_14009_5878# REF_CLK VSS.t289 VSS.t446 sg13_lv_nmos ad=0.2516p pd=2.16u as=1.9998p ps=12.915u w=0.74u l=0.13u
X1 VDD.t350 a_4003_1842# a_4437_1842# VDD.t2 sg13_lv_pmos ad=0.2128p pd=1.5u as=0.3808p ps=2.92u w=1.12u l=0.13u
X2 VSS.t248 DLL_RESETN a_10040_6305# VSS.t247 sg13_lv_nmos ad=0.1626p pd=1.415u as=60.89999f ps=0.71u w=0.42u l=0.13u
X3 VSS.t293 a_15077_1842# a_15545_1044# VSS.t474 sg13_lv_nmos ad=0.1665p pd=1.19u as=0.2516p ps=2.16u w=0.74u l=0.13u
X4 a_27915_1044# a_27705_1044# VDD.t173 VDD.t0 sg13_lv_pmos ad=0.2128p pd=1.5u as=0.252p ps=1.57u w=1.12u l=0.13u
X5 VSS.t193 VDD.t408 VSS.t191 VSS.t192 sg13_lv_nmos ad=79.8f pd=0.8u as=0 ps=0 w=0.42u l=1u
X6 a_10951_2470# a_10713_1842# a_10843_1842# VDD.t2 sg13_lv_pmos ad=0.2128p pd=1.5u as=0.3808p ps=2.92u w=1.12u l=0.2u
X7 VSS.t94 a_3171_1047.t7 a_11924_1008# VSS.t93 sg13_lv_nmos ad=0.2516p pd=2.16u as=0.2516p ps=2.16u w=0.74u l=0.13u
X8 VDD.t65 VSS.t231 VDD.t64 VDD.t0 sg13_lv_pmos ad=0.34p pd=2.68u as=0 ps=0 w=1u l=1u
X9 VSS.t116 a_1256_1044# a_2967_1395# VSS.t183 sg13_lv_nmos ad=0.1331p pd=1.12u as=0.1216p ps=1.02u w=0.64u l=0.13u
X10 VSS.t193 VDD.t407 VSS.t193 VSS.t194 sg13_lv_nmos ad=0.1428p pd=1.52u as=0 ps=0 w=0.42u l=1u
X11 a_25153_1842# a_24957_1842# VSS.t365 VSS.t555 sg13_lv_nmos ad=0.2516p pd=2.16u as=0.1406p ps=1.12u w=0.74u l=0.13u
X12 VDD.t192 VSS.t152 VDD.t212 VDD.t0 sg13_lv_pmos ad=0.34p pd=2.68u as=0 ps=0 w=1u l=1u
X13 a_15108_6109# a_14851_6228# a_15270_6305# VSS.t64 sg13_lv_nmos ad=0.1428p pd=1.52u as=37.8f ps=0.6u w=0.42u l=0.13u
X14 VSS.t254 a_14851_6228# a_15688_5867# VSS.t521 sg13_lv_nmos ad=0.1406p pd=1.12u as=0.2516p ps=2.16u w=0.74u l=0.13u
X15 VSS.t583 VSS.t581 VSS.t581 VSS.t582 sg13_lv_nmos ad=0.68p pd=4.68u as=0 ps=0 w=2u l=1u
X16 a_15108_5325# a_12849_5867# VDD.t7 VDD.t6 sg13_lv_pmos ad=79.8f pd=0.8u as=1.03698p ps=6.245u w=0.42u l=0.13u
X17 a_25630_1044# a_2019_1047.t2 a_25528_1044# VSS.t147 sg13_lv_nmos ad=0.2516p pd=2.16u as=0.1406p ps=1.12u w=0.74u l=0.13u
X18 VDD.t316 DELAY_VBIASP a_19311_2470# VDD.t2 sg13_lv_pmos ad=0.3808p pd=2.92u as=0.2128p ps=1.5u w=1.12u l=0.6u
X19 a_16108_289# a_2019_311# a_16510_1044# VSS.t269 sg13_lv_nmos ad=0.2516p pd=2.16u as=0.2516p ps=2.16u w=0.74u l=0.13u
X20 VDD.t319 DELAY_VBIASP a_9431_2470# VDD.t2 sg13_lv_pmos ad=0.3808p pd=2.92u as=0.2128p ps=1.5u w=1.12u l=0.6u
X21 VSS.t237 VDD.t394 VSS.t71 VSS.t236 sg13_lv_nmos ad=0.1428p pd=1.52u as=0 ps=0 w=0.42u l=1u
X22 VSS.t578 VSS.t578 VSS.t580 VSS.t579 sg13_lv_nmos ad=0.68p pd=4.68u as=0 ps=0 w=2u l=1u
X23 VDD.t324 DELAY_VBIASP a_23111_2470# VDD.t2 sg13_lv_pmos ad=0.3808p pd=2.92u as=0.2128p ps=1.5u w=1.12u l=0.6u
X24 a_7390_1044# a_8231_1008# a_8155_1044# VDD.t0 sg13_lv_pmos ad=0.3808p pd=2.92u as=0.2128p ps=1.5u w=1.12u l=0.13u
X25 a_14009_5878# REF_CLK VDD.t7 VDD.t6 sg13_lv_pmos ad=0.4088p pd=2.97u as=1.03698p ps=6.245u w=1.12u l=0.13u
X26 VSS.t155 a_2595_311.t3 a_8745_519# VSS.t154 sg13_lv_nmos ad=0.2516p pd=2.16u as=0.2516p ps=2.16u w=0.74u l=0.13u
X27 a_11748_6109# DLL_RESETN VDD.t7 VDD.t6 sg13_lv_pmos ad=79.8f pd=0.8u as=1.10612p ps=6.66u w=0.42u l=0.13u
X28 VDD.t129 a_11491_6228# a_12158_5867# VDD.t6 sg13_lv_pmos ad=0.2128p pd=1.5u as=0.3864p ps=2.93u w=1.12u l=0.13u
X29 VDD.t312 DELAY_VBIASP DELAY_VBIASP VDD.t50 sg13_lv_pmos ad=0.3808p pd=2.92u as=1.0304p ps=4.08u w=1.12u l=0.6u
X30 a_17791_1842# a_17553_1842# a_17683_1842# VSS.t51 sg13_lv_nmos ad=0.1406p pd=1.12u as=0.2516p ps=2.16u w=0.74u l=0.2u
X31 VSS.t53 a_11748_6109# a_11397_6228# VSS.t246 sg13_lv_nmos ad=79.8f pd=0.8u as=0.1428p ps=1.52u w=0.42u l=0.13u
X32 VDD.t357 a_12037_1842# a_12505_1044# VDD.t0 sg13_lv_pmos ad=0.252p pd=1.57u as=0.3808p ps=2.92u w=1.12u l=0.13u
X33 a_16510_1044# a_2019_1047.t5 a_16408_1044# VSS.t309 sg13_lv_nmos ad=0.2516p pd=2.16u as=0.1406p ps=1.12u w=0.74u l=0.13u
X34 a_21591_1842# a_21353_1842# a_21483_1842# VSS.t2 sg13_lv_nmos ad=0.1406p pd=1.12u as=0.2516p ps=2.16u w=0.74u l=0.2u
X35 a_6153_1842# a_5957_1842# VSS.t295 VSS.t551 sg13_lv_nmos ad=0.2516p pd=2.16u as=0.1406p ps=1.12u w=0.74u l=0.13u
X36 VSS.t142 a_16163_1842# a_16597_1842# VSS.t141 sg13_lv_nmos ad=0.1406p pd=1.12u as=0.2516p ps=2.16u w=0.74u l=0.13u
X37 VSS.t330 a_3171_1047.t2 a_27124_1008# VSS.t329 sg13_lv_nmos ad=0.2516p pd=2.16u as=0.2516p ps=2.16u w=0.74u l=0.13u
X38 VDD.t358 a_11603_1842# a_12037_1842# VDD.t2 sg13_lv_pmos ad=0.2128p pd=1.5u as=0.3808p ps=2.92u w=1.12u l=0.13u
X39 VDD.t113 a_3171_311.t3 a_11785_519# VDD.t0 sg13_lv_pmos ad=0.3808p pd=2.92u as=0.3808p ps=2.92u w=1.12u l=0.13u
X40 a_6126_3816# a_6326_4590# VDD.t25 VDD.t6 sg13_lv_pmos ad=0.38p pd=2.38u as=0.38p ps=2.38u w=2u l=1u
X41 a_24393_1842# a_24197_1842# VDD.t79 VDD.t2 sg13_lv_pmos ad=0.3808p pd=2.92u as=0.2128p ps=1.5u w=1.12u l=0.13u
X42 a_5731_289# a_2595_311.t3 a_7390_1044# VSS.t153 sg13_lv_nmos ad=0.2516p pd=2.16u as=0.2516p ps=2.16u w=0.74u l=0.13u
X43 a_10430_1044# a_2595_1047.t7 a_11195_1044# VSS.t101 sg13_lv_nmos ad=0.2516p pd=2.16u as=0.1406p ps=1.12u w=0.74u l=0.13u
X44 a_13306_6305# a_12355_5867# VDD.t127 VDD.t6 sg13_lv_pmos ad=79.8f pd=0.8u as=0.1428p ps=1.52u w=0.42u l=0.13u
X45 a_23355_1044# a_23145_1044# VSS.t539 VSS.t562 sg13_lv_nmos ad=0.1406p pd=1.12u as=0.1665p ps=1.19u w=0.74u l=0.13u
X46 VDD.t322 DELAY_VBIASP a_14751_2470# VDD.t2 sg13_lv_pmos ad=0.3808p pd=2.92u as=0.2128p ps=1.5u w=1.12u l=0.6u
X47 VSS.t114 DELAY_VBIASN a_10191_1842# VSS.t419 sg13_lv_nmos ad=0.2516p pd=2.16u as=0.1406p ps=1.12u w=0.74u l=0.6u
X48 VSS.t34 a_3747_1047.t4 a_21911_1008# VSS.t88 sg13_lv_nmos ad=0.2516p pd=2.16u as=0.2516p ps=2.16u w=0.74u l=0.13u
X49 VSS.t425 a_19963_1842# a_20397_1842# VSS.t443 sg13_lv_nmos ad=0.1406p pd=1.12u as=0.2516p ps=2.16u w=0.74u l=0.13u
X50 a_6126_3816# a_6326_4590# VDD.t30 VDD.t6 sg13_lv_pmos ad=0.38p pd=2.38u as=0.38p ps=2.38u w=2u l=1u
X51 VDD.t29 a_6326_4590# a_6854_5454# VDD.t6 sg13_lv_pmos ad=0.38p pd=2.38u as=0.38p ps=2.38u w=2u l=1u
X52 VDD.t306 DELAY_VBIASP a_4111_2470# VDD.t2 sg13_lv_pmos ad=0.3808p pd=2.92u as=0.2128p ps=1.5u w=1.12u l=0.6u
X53 a_10328_1044# a_9757_1842# VDD.t74 VDD.t0 sg13_lv_pmos ad=0.2128p pd=1.5u as=0.3808p ps=2.92u w=1.12u l=0.13u
X54 a_20968_1044# a_20397_1842# VSS.t530 VSS.t529 sg13_lv_nmos ad=0.1406p pd=1.12u as=0.2516p ps=2.16u w=0.74u l=0.13u
X55 a_22590_1044# a_22564_1008# a_22488_1044# VDD.t0 sg13_lv_pmos ad=0.3808p pd=2.92u as=0.2128p ps=1.5u w=1.12u l=0.13u
X56 VDD.t98 VSS.t203 VDD.t97 VDD.t0 sg13_lv_pmos ad=0.19p pd=1.38u as=0 ps=0 w=1u l=1u
X57 a_8808_1044# a_8237_1842# VDD.t389 VDD.t0 sg13_lv_pmos ad=0.2128p pd=1.5u as=0.3808p ps=2.92u w=1.12u l=0.13u
X58 VDD.t34 a_6326_4590# a_6326_4590# VDD.t6 sg13_lv_pmos ad=0.38p pd=2.38u as=0.38p ps=2.38u w=2u l=1u
X59 a_4157_1313# REF_CLK VDD.t266 VDD.t0 sg13_lv_pmos ad=0.3808p pd=2.92u as=0.3808p ps=2.92u w=1.12u l=0.13u
X60 a_17031_2470# a_16793_1842# a_16923_1842# VDD.t2 sg13_lv_pmos ad=0.2128p pd=1.5u as=0.3808p ps=2.92u w=1.12u l=0.2u
X61 a_11473_1842# a_11277_1842# VSS.t46 VSS.t45 sg13_lv_nmos ad=0.2516p pd=2.16u as=0.1406p ps=1.12u w=0.74u l=0.13u
X62 VSS.t233 VDD.t396 VSS.t231 VSS.t232 sg13_lv_nmos ad=79.8f pd=0.8u as=0 ps=0 w=0.42u l=1u
X63 a_13306_5105# a_13132_5420# VDD.t126 VDD.t6 sg13_lv_pmos ad=79.8f pd=0.8u as=0.1428p ps=1.52u w=0.42u l=0.13u
X64 a_19448_1044# a_18877_1842# VSS.t488 VSS.t498 sg13_lv_nmos ad=0.1406p pd=1.12u as=0.2516p ps=2.16u w=0.74u l=0.13u
X65 a_10430_1044# a_3171_1047.t7 a_11848_1044# VSS.t92 sg13_lv_nmos ad=0.2516p pd=2.16u as=0.1406p ps=1.12u w=0.74u l=0.13u
X66 a_20831_2470# a_20593_1842# a_20723_1842# VDD.t2 sg13_lv_pmos ad=0.2128p pd=1.5u as=0.3808p ps=2.92u w=1.12u l=0.2u
X67 VSS.t209 VDD.t403 VSS.t207 VSS.t208 sg13_lv_nmos ad=79.8f pd=0.8u as=0 ps=0 w=0.42u l=1u
X68 VDD.t173 a_27237_1842# a_27705_1044# VDD.t0 sg13_lv_pmos ad=0.252p pd=1.57u as=0.3808p ps=2.92u w=1.12u l=0.13u
X69 a_5393_1842# a_5197_1842# VDD.t5 VDD.t2 sg13_lv_pmos ad=0.3808p pd=2.92u as=0.2128p ps=1.5u w=1.12u l=0.13u
X70 VDD.t303 DELAY_VBIASP a_17031_2470# VDD.t2 sg13_lv_pmos ad=0.3808p pd=2.92u as=0.2128p ps=1.5u w=1.12u l=0.6u
X71 VDD.t7 a_15108_6109# a_15053_5990# VDD.t6 sg13_lv_pmos ad=1.10612p pd=6.66u as=93.45f ps=0.865u w=0.42u l=0.13u
X72 VDD.t30 a_6326_4590# a_6854_5454# VDD.t6 sg13_lv_pmos ad=0.38p pd=2.38u as=0.38p ps=2.38u w=2u l=1u
X73 a_13818_6292# a_12849_5867# VSS.t73 VSS.t316 sg13_lv_nmos ad=37.8f pd=0.6u as=0.1701p ps=1.65u w=0.42u l=0.13u
X74 VDD.t42 a_26803_1842# a_27237_1842# VDD.t2 sg13_lv_pmos ad=0.2128p pd=1.5u as=0.3808p ps=2.92u w=1.12u l=0.13u
X75 VDD.t278 MUX_SEL1 a_3449_1395# VDD.t0 sg13_lv_pmos ad=0.1918p pd=1.5u as=0.1596p ps=1.22u w=0.84u l=0.13u
X76 a_14851_6228# a_14009_5878# a_13592_5871# VDD.t6 sg13_lv_pmos ad=0.2048p pd=1.63u as=0.34p ps=2.68u w=1u l=0.13u
X77 a_25630_1044# a_2595_1047.t2 a_26395_1044# VSS.t23 sg13_lv_nmos ad=0.2516p pd=2.16u as=0.1406p ps=1.12u w=0.74u l=0.13u
X78 VSS.t429 DELAY_VBIASN a_25391_1842# VSS.t428 sg13_lv_nmos ad=0.2516p pd=2.16u as=0.1406p ps=1.12u w=0.74u l=0.6u
X79 VSS.t405 DELAY_VBIASN VSS.t403 VSS.t388 sg13_lv_nmos ad=1.33p pd=7.38u as=0 ps=0 w=7u l=7u
X80 a_6635_1044# a_6425_1044# VDD.t364 VDD.t0 sg13_lv_pmos ad=0.2128p pd=1.5u as=0.252p ps=1.57u w=1.12u l=0.13u
X81 VDD.t170 DLL_RESETN a_9946_6305# VDD.t6 sg13_lv_pmos ad=0.36237p pd=2.605u as=79.8f ps=0.8u w=0.42u l=0.13u
X82 a_20315_1044# a_20105_1044# VDD.t184 VDD.t0 sg13_lv_pmos ad=0.2128p pd=1.5u as=0.252p ps=1.57u w=1.12u l=0.13u
X83 VDD.t66 a_2595_1047.t9 a_5191_1008# VDD.t0 sg13_lv_pmos ad=0.3808p pd=2.92u as=0.3808p ps=2.92u w=1.12u l=0.13u
X84 a_19311_2470# a_19073_1842# a_19203_1842# VDD.t2 sg13_lv_pmos ad=0.2128p pd=1.5u as=0.3808p ps=2.92u w=1.12u l=0.2u
X85 VSS.t12 a_1721_1395# a_2019_1047.t1 VSS.t535 sg13_lv_nmos ad=0.2812p pd=2.24u as=0.1406p ps=1.12u w=0.74u l=0.13u
X86 a_25528_1044# a_24957_1842# VDD.t365 VDD.t0 sg13_lv_pmos ad=0.2128p pd=1.5u as=0.3808p ps=2.92u w=1.12u l=0.13u
X87 VSS.t553 a_5957_1842# a_6425_1044# VSS.t552 sg13_lv_nmos ad=0.1665p pd=1.19u as=0.2516p ps=2.16u w=0.74u l=0.13u
X88 VSS.t339 a_2019_1047.t6 a_13444_1008# VSS.t338 sg13_lv_nmos ad=0.2516p pd=2.16u as=0.2516p ps=2.16u w=0.74u l=0.13u
X89 a_23111_2470# a_22873_1842# a_23003_1842# VDD.t2 sg13_lv_pmos ad=0.2128p pd=1.5u as=0.3808p ps=2.92u w=1.12u l=0.2u
X90 VSS.t191 VDD.t408 VSS.t191 VSS.t190 sg13_lv_nmos ad=0.1428p pd=1.52u as=0 ps=0 w=0.42u l=1u
X91 VSS.t278 a_15964_289# a_16851_309# VSS.t459 sg13_lv_nmos ad=0.1371p pd=1.12u as=0.2176p ps=1.96u w=0.64u l=0.13u
X92 a_10713_1842# a_10517_1842# VDD.t84 VDD.t2 sg13_lv_pmos ad=0.3808p pd=2.92u as=0.2128p ps=1.5u w=1.12u l=0.13u
X93 VDD.t179 a_17683_1842# a_18117_1842# VDD.t2 sg13_lv_pmos ad=0.2128p pd=1.5u as=0.3808p ps=2.92u w=1.12u l=0.13u
X94 a_16108_289# a_17865_519# a_16510_1044# VDD.t0 sg13_lv_pmos ad=0.3808p pd=2.92u as=0.3808p ps=2.92u w=1.12u l=0.13u
X95 a_26673_1842# a_26477_1842# VSS.t48 VSS.t47 sg13_lv_nmos ad=0.2516p pd=2.16u as=0.1406p ps=1.12u w=0.74u l=0.13u
X96 VDD.t286 a_7803_1842# a_8237_1842# VDD.t2 sg13_lv_pmos ad=0.2128p pd=1.5u as=0.3808p ps=2.92u w=1.12u l=0.13u
X97 a_4248_1044# a_4157_1313# VSS.t75 VSS.t74 sg13_lv_nmos ad=0.1406p pd=1.12u as=0.2516p ps=2.16u w=0.74u l=0.13u
X98 a_16108_289# a_3171_311.t2 a_22590_1044# VSS.t69 sg13_lv_nmos ad=0.2516p pd=2.16u as=0.2516p ps=2.16u w=0.74u l=0.13u
X99 VSS.t40 DELAY_VBIASN a_6391_1842# VSS.t413 sg13_lv_nmos ad=0.2516p pd=2.16u as=0.1406p ps=1.12u w=0.74u l=0.6u
X100 a_16408_1044# a_15837_1842# VDD.t253 VDD.t0 sg13_lv_pmos ad=0.2128p pd=1.5u as=0.3808p ps=2.92u w=1.12u l=0.13u
X101 a_10232_5871# a_10206_5835# VSS.t248 VSS.t247 sg13_lv_nmos ad=0.2516p pd=2.16u as=0.1626p ps=1.415u w=0.74u l=0.13u
X102 a_19550_1044# a_3747_1047.t4 a_21835_1044# VSS.t87 sg13_lv_nmos ad=0.2516p pd=2.16u as=0.1406p ps=1.12u w=0.74u l=0.13u
X103 VSS.t305 DELAY_VBIASN a_20831_1842# VSS.t368 sg13_lv_nmos ad=0.2516p pd=2.16u as=0.1406p ps=1.12u w=0.74u l=0.6u
X104 a_3171_311.t0 a_2873_331# VDD.t78 VDD.t0 sg13_lv_pmos ad=0.2128p pd=1.5u as=0.1918p ps=1.5u w=1.12u l=0.13u
X105 a_15304_4605# a_14851_6228# VDD.t342 VDD.t6 sg13_lv_pmos ad=0.4312p pd=3.01u as=0.2639p ps=1.81u w=1.12u l=0.13u
X106 a_13106_5357# a_12907_5420# VSS.t56 VSS.t118 sg13_lv_nmos ad=0.27427p pd=2.28u as=1.45407p ps=9.445u w=0.795u l=0.13u
X107 a_3747_311.t0 a_3449_331# VDD.t10 VDD.t0 sg13_lv_pmos ad=0.2128p pd=1.5u as=0.1918p ps=1.5u w=1.12u l=0.13u
X108 a_13132_5420# a_13106_5357# VDD.t7 VDD.t6 sg13_lv_pmos ad=0.3927p pd=2.99u as=1.10612p ps=6.66u w=1.155u l=0.13u
X109 a_7390_1044# a_9751_1008# a_9675_1044# VDD.t0 sg13_lv_pmos ad=0.3808p pd=2.92u as=0.2128p ps=1.5u w=1.12u l=0.13u
X110 VSS.t401 DELAY_VBIASN VSS.t399 VSS.t384 sg13_lv_nmos ad=1.33p pd=7.38u as=0 ps=0 w=7u l=7u
X111 a_10191_1842# a_9953_1842# a_10083_1842# VSS.t167 sg13_lv_nmos ad=0.1406p pd=1.12u as=0.2516p ps=2.16u w=0.74u l=0.2u
X112 VSS.t539 a_22677_1842# a_23145_1044# VSS.t538 sg13_lv_nmos ad=0.1665p pd=1.19u as=0.2516p ps=2.16u w=0.74u l=0.13u
X113 a_14751_2470# a_14513_1842# a_14643_1842# VDD.t2 sg13_lv_pmos ad=0.2128p pd=1.5u as=0.3808p ps=2.92u w=1.12u l=0.2u
X114 a_5731_289# a_8745_519# a_7390_1044# VDD.t0 sg13_lv_pmos ad=0.3808p pd=2.92u as=0.3808p ps=2.92u w=1.12u l=0.13u
X115 VDD.t157 VDD.t158 VDD.t159 VDD.t2 sg13_lv_pmos ad=0.2128p pd=1.5u as=0 ps=0 w=1.12u l=0.13u
X116 a_4111_2470# REF_CLK a_4003_1842# VDD.t2 sg13_lv_pmos ad=0.2128p pd=1.5u as=0.3808p ps=2.92u w=1.12u l=0.2u
X117 a_13566_5835# a_14009_5878# a_13306_6305# VSS.t287 sg13_lv_nmos ad=79.8f pd=0.8u as=0.1296p ps=1.52u w=0.42u l=0.13u
X118 a_13306_6305# a_14111_5878# a_13566_5835# VDD.t6 sg13_lv_pmos ad=0.1428p pd=1.52u as=79.8f ps=0.8u w=0.42u l=0.13u
X119 a_13592_5423# a_14111_5227# a_14851_5182# VSS.t564 sg13_lv_nmos ad=0.3473p pd=2.71u as=0.12665p ps=1.145u w=0.74u l=0.13u
X120 a_7673_1842# a_7477_1842# VSS.t412 VSS.t455 sg13_lv_nmos ad=0.2516p pd=2.16u as=0.1406p ps=1.12u w=0.74u l=0.13u
X121 VDD.t182 a_3171_1047.t5 a_18004_1008# VDD.t0 sg13_lv_pmos ad=0.3808p pd=2.92u as=0.3808p ps=2.92u w=1.12u l=0.13u
X122 VDD.t4 a_13123_1842# a_13557_1842# VDD.t2 sg13_lv_pmos ad=0.2128p pd=1.5u as=0.3808p ps=2.92u w=1.12u l=0.13u
X123 VDD.t116 a_3747_311.t2 a_26985_519# VDD.t0 sg13_lv_pmos ad=0.3808p pd=2.92u as=0.3808p ps=2.92u w=1.12u l=0.13u
X124 a_25913_1842# a_25717_1842# VDD.t287 VDD.t2 sg13_lv_pmos ad=0.3808p pd=2.92u as=0.2128p ps=1.5u w=1.12u l=0.13u
X125 a_10430_1044# a_3747_1047.t7 a_12715_1044# VSS.t84 sg13_lv_nmos ad=0.2516p pd=2.16u as=0.1406p ps=1.12u w=0.74u l=0.13u
X126 a_6326_4590# a_5974_5723# a_6126_3816# VSS.t127 sg13_lv_nmos ad=0.38p pd=2.38u as=0.68p ps=4.68u w=2u l=1u
X127 a_14235_1044# a_14025_1044# VDD.t1 VDD.t0 sg13_lv_pmos ad=0.2128p pd=1.5u as=0.252p ps=1.57u w=1.12u l=0.13u
X128 a_24875_1044# a_24665_1044# VSS.t110 VSS.t351 sg13_lv_nmos ad=0.1406p pd=1.12u as=0.1665p ps=1.19u w=0.74u l=0.13u
X129 VSS.t417 DELAY_VBIASN a_11711_1842# VSS.t416 sg13_lv_nmos ad=0.2516p pd=2.16u as=0.1406p ps=1.12u w=0.74u l=0.6u
X130 VDD.t69 a_3747_1047.t7 a_12791_1008# VDD.t0 sg13_lv_pmos ad=0.3808p pd=2.92u as=0.3808p ps=2.92u w=1.12u l=0.13u
X131 VSS.t347 a_2595_1047.t3 a_23431_1008# VSS.t346 sg13_lv_nmos ad=0.2516p pd=2.16u as=0.2516p ps=2.16u w=0.74u l=0.13u
X132 VSS.t32 a_21483_1842# a_21917_1842# VSS.t300 sg13_lv_nmos ad=0.1406p pd=1.12u as=0.2516p ps=2.16u w=0.74u l=0.13u
X133 VSS.t1 a_13557_1842# a_14025_1044# VSS.t3 sg13_lv_nmos ad=0.1665p pd=1.19u as=0.2516p ps=2.16u w=0.74u l=0.13u
X134 a_11848_1044# a_11277_1842# VDD.t45 VDD.t0 sg13_lv_pmos ad=0.2128p pd=1.5u as=0.3808p ps=2.92u w=1.12u l=0.13u
X135 VDD.t15 VSS.t243 VDD.t14 VDD.t0 sg13_lv_pmos ad=0.19p pd=1.38u as=0 ps=0 w=1u l=1u
X136 VDD.t7 a_12907_5186# a_12907_5420# VDD.t6 sg13_lv_pmos ad=1.10612p pd=6.66u as=0.2442p ps=2.06u w=0.66u l=0.13u
X137 a_25391_1842# a_25153_1842# a_25283_1842# VSS.t517 sg13_lv_nmos ad=0.1406p pd=1.12u as=0.2516p ps=2.16u w=0.74u l=0.2u
X138 a_12993_1842# a_12797_1842# VSS.t299 VSS.t303 sg13_lv_nmos ad=0.2516p pd=2.16u as=0.1406p ps=1.12u w=0.74u l=0.13u
X139 DELAY_OUT_LAST a_27997_1842# VDD.t281 VDD.t2 sg13_lv_pmos ad=0.3808p pd=2.92u as=0.2128p ps=1.5u w=1.12u l=0.13u
X140 VDD.t17 VSS.t243 VDD.t16 VDD.t0 sg13_lv_pmos ad=0.34p pd=2.68u as=0 ps=0 w=1u l=1u
X141 VDD.t184 a_19637_1842# a_20105_1044# VDD.t0 sg13_lv_pmos ad=0.252p pd=1.57u as=0.3808p ps=2.92u w=1.12u l=0.13u
X142 a_6854_5454# a_6326_4590# VDD.t27 VDD.t6 sg13_lv_pmos ad=0.38p pd=2.38u as=0.38p ps=2.38u w=2u l=1u
X143 VSS.t146 DELAY_VBIASN a_13991_1842# VSS.t422 sg13_lv_nmos ad=0.2516p pd=2.16u as=0.1406p ps=1.12u w=0.74u l=0.6u
X144 VSS.t231 VDD.t396 VSS.t231 VSS.t230 sg13_lv_nmos ad=0.1428p pd=1.52u as=0 ps=0 w=0.42u l=1u
X145 a_22590_1044# a_3171_1047.t3 a_24008_1044# VSS.t544 sg13_lv_nmos ad=0.2516p pd=2.16u as=0.1406p ps=1.12u w=0.74u l=0.13u
X146 a_6913_1842# a_6717_1842# VDD.t43 VDD.t2 sg13_lv_pmos ad=0.3808p pd=2.92u as=0.2128p ps=1.5u w=1.12u l=0.13u
X147 VDD.t323 DELAY_VBIASP a_18551_2470# VDD.t2 sg13_lv_pmos ad=0.3808p pd=2.92u as=0.2128p ps=1.5u w=1.12u l=0.6u
X148 VSS.t108 a_23763_1842# a_24197_1842# VSS.t526 sg13_lv_nmos ad=0.1406p pd=1.12u as=0.2516p ps=2.16u w=0.74u l=0.13u
X149 VSS.t207 VDD.t403 VSS.t152 VSS.t206 sg13_lv_nmos ad=0.1428p pd=1.52u as=0 ps=0 w=0.42u l=1u
X150 VDD.t91 a_1256_1044# a_2873_1395# VDD.t0 sg13_lv_pmos ad=0.1918p pd=1.5u as=0.1596p ps=1.22u w=0.84u l=0.13u
X151 a_3171_311.t1 a_2873_331# VSS.t106 VSS.t265 sg13_lv_nmos ad=0.1406p pd=1.12u as=0.1331p ps=1.12u w=0.74u l=0.13u
X152 VDD.t176 a_2873_331# a_3171_311.t0 VDD.t0 sg13_lv_pmos ad=0.4256p pd=3u as=0.2128p ps=1.5u w=1.12u l=0.13u
X153 a_16510_1044# a_17351_1008# a_17275_1044# VDD.t0 sg13_lv_pmos ad=0.3808p pd=2.92u as=0.2128p ps=1.5u w=1.12u l=0.13u
X154 a_25630_1044# a_3747_1047.t2 a_27915_1044# VSS.t284 sg13_lv_nmos ad=0.2516p pd=2.16u as=0.1406p ps=1.12u w=0.74u l=0.13u
X155 VSS.t38 DELAY_VBIASN a_26911_1842# VSS.t430 sg13_lv_nmos ad=0.2516p pd=2.16u as=0.1406p ps=1.12u w=0.74u l=0.6u
X156 a_3747_311.t1 a_3449_331# VSS.t15 VSS.t14 sg13_lv_nmos ad=0.1406p pd=1.12u as=0.1331p ps=1.12u w=0.74u l=0.13u
X157 VDD.t11 a_3449_331# a_3747_311.t0 VDD.t0 sg13_lv_pmos ad=0.4256p pd=3u as=0.2128p ps=1.5u w=1.12u l=0.13u
X158 VDD.t325 DELAY_VBIASP a_22351_2470# VDD.t2 sg13_lv_pmos ad=0.3808p pd=2.92u as=0.2128p ps=1.5u w=1.12u l=0.6u
X159 VDD.t186 a_3747_1047.t2 a_27991_1008# VDD.t0 sg13_lv_pmos ad=0.3808p pd=2.92u as=0.3808p ps=2.92u w=1.12u l=0.13u
X160 VDD.t82 VSS.t189 VDD.t81 VDD.t0 sg13_lv_pmos ad=0.19p pd=1.38u as=0 ps=0 w=1u l=1u
X161 a_13019_5831# a_15688_5403# VSS.t144 VSS.t489 sg13_lv_nmos ad=0.2516p pd=2.16u as=0.1406p ps=1.12u w=0.74u l=0.13u
X162 VDD.t185 a_3747_1047.t9 a_6711_1008# VDD.t0 sg13_lv_pmos ad=0.3808p pd=2.92u as=0.3808p ps=2.92u w=1.12u l=0.13u
X163 a_6854_5454# a_6326_4590# VDD.t21 VDD.t6 sg13_lv_pmos ad=0.38p pd=2.38u as=0.38p ps=2.38u w=2u l=1u
X164 a_9772_5843# a_9746_5805# VDD.t7 VDD.t6 sg13_lv_pmos ad=0.3927p pd=2.99u as=1.10612p ps=6.66u w=1.155u l=0.13u
X165 a_6391_1842# a_6153_1842# a_6283_1842# VSS.t76 sg13_lv_nmos ad=0.1406p pd=1.12u as=0.2516p ps=2.16u w=0.74u l=0.2u
X166 a_15273_1842# a_15077_1842# VSS.t376 VSS.t475 sg13_lv_nmos ad=0.2516p pd=2.16u as=0.1406p ps=1.12u w=0.74u l=0.13u
X167 a_19833_1842# a_19637_1842# VDD.t289 VDD.t2 sg13_lv_pmos ad=0.3808p pd=2.92u as=0.2128p ps=1.5u w=1.12u l=0.13u
X168 a_16108_289# a_23945_519# a_22590_1044# VDD.t0 sg13_lv_pmos ad=0.3808p pd=2.92u as=0.3808p ps=2.92u w=1.12u l=0.13u
X169 VDD.t32 a_6326_4590# a_6126_3816# VDD.t6 sg13_lv_pmos ad=0.38p pd=2.38u as=0.38p ps=2.38u w=2u l=1u
X170 a_9193_1842# a_8997_1842# VDD.t52 VDD.t2 sg13_lv_pmos ad=0.3808p pd=2.92u as=0.2128p ps=1.5u w=1.12u l=0.13u
X171 a_24631_2470# a_24393_1842# a_24523_1842# VDD.t2 sg13_lv_pmos ad=0.2128p pd=1.5u as=0.3808p ps=2.92u w=1.12u l=0.2u
X172 VSS.t370 a_15403_1842# a_15837_1842# VSS.t450 sg13_lv_nmos ad=0.1406p pd=1.12u as=0.2516p ps=2.16u w=0.74u l=0.13u
X173 a_8155_1044# a_7945_1044# VSS.t327 VSS.t326 sg13_lv_nmos ad=0.1406p pd=1.12u as=0.1665p ps=1.19u w=0.74u l=0.13u
X174 a_23633_1842# a_23437_1842# VDD.t249 VDD.t2 sg13_lv_pmos ad=0.3808p pd=2.92u as=0.2128p ps=1.5u w=1.12u l=0.13u
X175 VSS.t7 a_4763_1842# a_5197_1842# VSS.t6 sg13_lv_nmos ad=0.1406p pd=1.12u as=0.2516p ps=2.16u w=0.74u l=0.13u
X176 a_27048_1044# a_26477_1842# VSS.t25 VSS.t49 sg13_lv_nmos ad=0.1406p pd=1.12u as=0.2516p ps=2.16u w=0.74u l=0.13u
X177 VDD.t75 a_9323_1842# a_9757_1842# VDD.t2 sg13_lv_pmos ad=0.2128p pd=1.5u as=0.3808p ps=2.92u w=1.12u l=0.13u
X178 a_5768_1044# a_5197_1842# VSS.t82 VSS.t313 sg13_lv_nmos ad=0.1406p pd=1.12u as=0.2516p ps=2.16u w=0.74u l=0.13u
X179 a_6326_4590# a_6126_3816# a_5778_3367# VSS.t124 sg13_lv_nmos ad=0.38p pd=2.38u as=0.68p ps=4.68u w=2u l=1u
X180 DELAY_VBIASN DLL_RESETN VDD.t168 VDD.t50 sg13_lv_pmos ad=0.158p pd=1.245u as=0.272p ps=2.28u w=0.8u l=0.2u
X181 a_7390_1044# a_7364_1008# a_7288_1044# VDD.t0 sg13_lv_pmos ad=0.3808p pd=2.92u as=0.2128p ps=1.5u w=1.12u l=0.13u
X182 VSS.t395 DELAY_VBIASN VSS.t394 VSS.t377 sg13_lv_nmos ad=2.38p pd=14.68u as=0 ps=0 w=7u l=7u
X183 VSS.t415 DELAY_VBIASN a_7911_1842# VSS.t414 sg13_lv_nmos ad=0.2516p pd=2.16u as=0.1406p ps=1.12u w=0.74u l=0.6u
X184 VDD.t49 a_13019_5831# a_12943_5867# VDD.t6 sg13_lv_pmos ad=0.2128p pd=1.5u as=0.2128p ps=1.5u w=1.12u l=0.13u
X185 a_6854_5986# a_15304_4605# DELAY_VBIASN VDD.t50 sg13_lv_pmos ad=0.136p pd=1.14u as=0.158p ps=1.245u w=0.4u l=0.2u
X186 VDD.t211 VSS.t166 VDD.t209 VDD.t0 sg13_lv_pmos ad=0.19p pd=1.38u as=0 ps=0 w=1u l=1u
X187 a_11711_1842# a_11473_1842# a_11603_1842# VSS.t524 sg13_lv_nmos ad=0.1406p pd=1.12u as=0.2516p ps=2.16u w=0.74u l=0.2u
X188 VSS.t110 a_24197_1842# a_24665_1044# VSS.t109 sg13_lv_nmos ad=0.1665p pd=1.19u as=0.2516p ps=2.16u w=0.74u l=0.13u
X189 a_16510_1044# a_3171_1047.t5 a_17928_1044# VSS.t273 sg13_lv_nmos ad=0.2516p pd=2.16u as=0.1406p ps=1.12u w=0.74u l=0.13u
X190 a_15270_5105# a_12849_5867# VSS.t144 VSS.t319 sg13_lv_nmos ad=37.8f pd=0.6u as=79.8f ps=0.8u w=0.42u l=0.13u
X191 a_5974_5723# a_6126_3816# VSS.t129 VSS.t127 sg13_lv_nmos ad=0.38p pd=2.38u as=0.68p ps=4.68u w=2u l=1u
X192 VSS.t203 VDD.t405 VSS.t201 VSS.t202 sg13_lv_nmos ad=79.8f pd=0.8u as=0 ps=0 w=0.42u l=1u
X193 a_5631_2470# a_5393_1842# a_5523_1842# VDD.t2 sg13_lv_pmos ad=0.2128p pd=1.5u as=0.3808p ps=2.92u w=1.12u l=0.2u
X194 a_14513_1842# a_14317_1842# VDD.t111 VDD.t2 sg13_lv_pmos ad=0.3808p pd=2.92u as=0.2128p ps=1.5u w=1.12u l=0.13u
X195 a_4633_1842# a_4437_1842# VDD.t350 VDD.t2 sg13_lv_pmos ad=0.3808p pd=2.92u as=0.2128p ps=1.5u w=1.12u l=0.13u
X196 VSS.t114 a_10083_1842# a_10517_1842# VSS.t573 sg13_lv_nmos ad=0.1406p pd=1.12u as=0.2516p ps=2.16u w=0.74u l=0.13u
X197 VDD.t38 a_2019_1047.t4 a_19524_1008# VDD.t0 sg13_lv_pmos ad=0.3808p pd=2.92u as=0.3808p ps=2.92u w=1.12u l=0.13u
X198 VSS.t324 a_3171_1047.t4 a_21044_1008# VSS.t323 sg13_lv_nmos ad=0.2516p pd=2.16u as=0.2516p ps=2.16u w=0.74u l=0.13u
X199 VSS.t106 a_2873_331# a_3171_311.t1 VSS.t266 sg13_lv_nmos ad=0.2812p pd=2.24u as=0.1406p ps=1.12u w=0.74u l=0.13u
X200 a_13949_5496# a_13592_5423# VDD.t221 VDD.t6 sg13_lv_pmos ad=63f pd=0.72u as=0.1563p ps=1.22u w=0.42u l=0.13u
X201 VSS.t15 a_3449_331# a_3747_311.t1 VSS.t16 sg13_lv_nmos ad=0.2812p pd=2.24u as=0.1406p ps=1.12u w=0.74u l=0.13u
X202 a_15755_1044# a_15545_1044# VDD.t190 VDD.t0 sg13_lv_pmos ad=0.2128p pd=1.5u as=0.252p ps=1.57u w=1.12u l=0.13u
X203 VDD.t242 a_2595_1047.t6 a_14311_1008# VDD.t0 sg13_lv_pmos ad=0.3808p pd=2.92u as=0.3808p ps=2.92u w=1.12u l=0.13u
X204 VSS.t365 DELAY_VBIASN a_24631_1842# VSS.t364 sg13_lv_nmos ad=0.2516p pd=2.16u as=0.1406p ps=1.12u w=0.74u l=0.6u
X205 a_5115_1044# a_4905_1044# VDD.t171 VDD.t0 sg13_lv_pmos ad=0.2128p pd=1.5u as=0.252p ps=1.57u w=1.12u l=0.13u
X206 a_5974_5723# a_6126_3816# VSS.t131 VSS.t127 sg13_lv_nmos ad=0.38p pd=2.38u as=0.68p ps=4.68u w=2u l=1u
X207 VSS.t56 a_12907_5186# a_12907_5186# VSS.t55 sg13_lv_nmos ad=1.45407p pd=9.445u as=0.111p ps=1.34u w=0.3u l=0.13u
X208 a_18551_2470# a_18313_1842# a_18443_1842# VDD.t2 sg13_lv_pmos ad=0.2128p pd=1.5u as=0.3808p ps=2.92u w=1.12u l=0.2u
X209 VDD.t63 VSS.t229 VDD.t62 VDD.t0 sg13_lv_pmos ad=0.19p pd=1.38u as=0 ps=0 w=1u l=1u
X210 a_3171_1047.t1 a_2873_1395# VSS.t116 VSS.t115 sg13_lv_nmos ad=0.1406p pd=1.12u as=0.1331p ps=1.12u w=0.74u l=0.13u
X211 a_13121_5831# a_15688_5867# VSS.t254 VSS.t253 sg13_lv_nmos ad=0.2516p pd=2.16u as=0.1406p ps=1.12u w=0.74u l=0.13u
X212 VSS.t385 DELAY_VBIASN VSS.t387 VSS.t386 sg13_lv_nmos ad=1.33p pd=7.38u as=0 ps=0 w=7u l=7u
X213 VSS.t12 a_2297_1395# a_2595_1047.t1 VSS.t13 sg13_lv_nmos ad=0.2812p pd=2.24u as=0.1406p ps=1.12u w=0.74u l=0.13u
X214 VDD.t375 a_14851_5182# a_15108_5325# VDD.t6 sg13_lv_pmos ad=0.2639p pd=1.81u as=79.8f ps=0.8u w=0.42u l=0.13u
X215 a_22351_2470# a_22113_1842# a_22243_1842# VDD.t2 sg13_lv_pmos ad=0.2128p pd=1.5u as=0.3808p ps=2.92u w=1.12u l=0.2u
X216 VSS.t602 VSS.t602 VSS.t604 VSS.t603 sg13_lv_nmos ad=0.2516p pd=2.16u as=0 ps=0 w=0.74u l=0.13u
X217 a_26911_1842# a_26673_1842# a_26803_1842# VSS.t181 sg13_lv_nmos ad=0.1406p pd=1.12u as=0.2516p ps=2.16u w=0.74u l=0.2u
X218 VSS.t152 a_3171_311.t3 a_11785_519# VSS.t151 sg13_lv_nmos ad=0.2516p pd=2.16u as=0.2516p ps=2.16u w=0.74u l=0.13u
X219 VDD.t352 a_1721_1395# a_2019_1047.t0 VDD.t0 sg13_lv_pmos ad=0.4256p pd=3u as=0.2128p ps=1.5u w=1.12u l=0.13u
X220 a_12656_5864# DLL_RESETN VSS.t53 VSS.t250 sg13_lv_nmos ad=0.2516p pd=2.16u as=0.2516p ps=2.16u w=0.74u l=0.13u
X221 a_14851_6228# a_14009_5878# a_14757_6228# VSS.t64 sg13_lv_nmos ad=0.12665p pd=1.145u as=0.1428p ps=1.52u w=0.42u l=0.13u
X222 VDD.t203 a_16923_1842# a_17357_1842# VDD.t2 sg13_lv_pmos ad=0.2128p pd=1.5u as=0.3808p ps=2.92u w=1.12u l=0.13u
X223 a_2391_1395# MUX_SEL0 a_2297_1395# VSS.t512 sg13_lv_nmos ad=0.1216p pd=1.02u as=0.2176p ps=1.96u w=0.64u l=0.13u
X224 VSS.t12 a_1544_1044# a_1815_1395# VSS.t173 sg13_lv_nmos ad=0.1331p pd=1.12u as=0.1216p ps=1.02u w=0.64u l=0.13u
X225 a_13368_1044# a_12797_1842# VSS.t86 VSS.t302 sg13_lv_nmos ad=0.1406p pd=1.12u as=0.2516p ps=2.16u w=0.74u l=0.13u
X226 a_13400_5105# a_13132_5420# a_13306_5105# VSS.t175 sg13_lv_nmos ad=60.89999f pd=0.71u as=0.1428p ps=1.52u w=0.42u l=0.13u
X227 a_5731_289# a_3171_311.t3 a_10430_1044# VSS.t150 sg13_lv_nmos ad=0.2516p pd=2.16u as=0.2516p ps=2.16u w=0.74u l=0.13u
X228 VDD.t174 a_21157_1842# a_21625_1044# VDD.t0 sg13_lv_pmos ad=0.252p pd=1.57u as=0.3808p ps=2.92u w=1.12u l=0.13u
X229 VDD.t299 DELAY_VBIASP a_10951_2470# VDD.t2 sg13_lv_pmos ad=0.3808p pd=2.92u as=0.2128p ps=1.5u w=1.12u l=0.6u
X230 VSS.t370 DELAY_VBIASN a_15511_1842# VSS.t369 sg13_lv_nmos ad=0.2516p pd=2.16u as=0.1406p ps=1.12u w=0.74u l=0.6u
X231 a_6326_4590# a_6326_4590# VDD.t23 VDD.t6 sg13_lv_pmos ad=0.38p pd=2.38u as=0.38p ps=2.38u w=2u l=1u
X232 VSS.t397 DELAY_VBIASN VSS.t395 VSS.t380 sg13_lv_nmos ad=1.33p pd=7.38u as=0 ps=0 w=7u l=7u
X233 VDD.t201 a_20723_1842# a_21157_1842# VDD.t2 sg13_lv_pmos ad=0.2128p pd=1.5u as=0.3808p ps=2.92u w=1.12u l=0.13u
X234 VSS.t429 a_25283_1842# a_25717_1842# VSS.t477 sg13_lv_nmos ad=0.1406p pd=1.12u as=0.2516p ps=2.16u w=0.74u l=0.13u
X235 a_4350_1044# a_3747_1047.t9 a_6635_1044# VSS.t282 sg13_lv_nmos ad=0.2516p pd=2.16u as=0.1406p ps=1.12u w=0.74u l=0.13u
X236 VSS.t295 DELAY_VBIASN a_5631_1842# VSS.t355 sg13_lv_nmos ad=0.2516p pd=2.16u as=0.1406p ps=1.12u w=0.74u l=0.6u
X237 VDD.t93 a_2019_1047.t9 a_4324_1008# VDD.t0 sg13_lv_pmos ad=0.3808p pd=2.92u as=0.3808p ps=2.92u w=1.12u l=0.13u
X238 a_12849_5867# a_12656_5864# VSS.t53 VSS.t103 sg13_lv_nmos ad=0.1406p pd=1.12u as=0.2516p ps=2.16u w=0.74u l=0.13u
X239 a_16510_1044# a_18871_1008# a_18795_1044# VDD.t0 sg13_lv_pmos ad=0.3808p pd=2.92u as=0.2128p ps=1.5u w=1.12u l=0.13u
X240 a_19550_1044# a_2595_1047.t4 a_20315_1044# VSS.t571 sg13_lv_nmos ad=0.2516p pd=2.16u as=0.1406p ps=1.12u w=0.74u l=0.13u
X241 VDD.t27 a_6326_4590# a_6126_3816# VDD.t6 sg13_lv_pmos ad=0.38p pd=2.38u as=0.38p ps=2.38u w=2u l=1u
X242 VDD.t7 a_11491_6228# a_11748_6109# VDD.t6 sg13_lv_pmos ad=1.10612p pd=6.66u as=79.8f ps=0.8u w=0.42u l=0.13u
X243 a_12355_5867# a_12158_5867# VDD.t129 VDD.t6 sg13_lv_pmos ad=0.3808p pd=2.92u as=0.2128p ps=1.5u w=1.12u l=0.13u
X244 VDD.t308 DELAY_VBIASP a_23871_2470# VDD.t2 sg13_lv_pmos ad=0.3808p pd=2.92u as=0.2128p ps=1.5u w=1.12u l=0.6u
X245 VSS.t327 a_7477_1842# a_7945_1044# VSS.t454 sg13_lv_nmos ad=0.1665p pd=1.19u as=0.2516p ps=2.16u w=0.74u l=0.13u
X246 a_11910_6305# DLL_RESETN VSS.t53 VSS.t246 sg13_lv_nmos ad=37.8f pd=0.6u as=79.8f ps=0.8u w=0.42u l=0.13u
X247 VSS.t391 DELAY_VBIASN VSS.t393 VSS.t392 sg13_lv_nmos ad=1.33p pd=7.38u as=0 ps=0 w=7u l=7u
X248 a_13231_2470# a_12993_1842# a_13123_1842# VDD.t2 sg13_lv_pmos ad=0.2128p pd=1.5u as=0.3808p ps=2.92u w=1.12u l=0.2u
X249 VDD.t81 VSS.t186 VDD.t96 VDD.t0 sg13_lv_pmos ad=0.34p pd=2.68u as=0 ps=0 w=1u l=1u
X250 a_6326_4590# a_6126_3816# a_5778_3367# VSS.t124 sg13_lv_nmos ad=0.38p pd=2.38u as=0.68p ps=4.68u w=2u l=1u
X251 a_12233_1842# a_12037_1842# VDD.t358 VDD.t2 sg13_lv_pmos ad=0.3808p pd=2.92u as=0.2128p ps=1.5u w=1.12u l=0.13u
X252 a_7911_1842# a_7673_1842# a_7803_1842# VSS.t569 sg13_lv_nmos ad=0.1406p pd=1.12u as=0.2516p ps=2.16u w=0.74u l=0.2u
X253 a_16793_1842# a_16597_1842# VSS.t142 VSS.t291 sg13_lv_nmos ad=0.2516p pd=2.16u as=0.1406p ps=1.12u w=0.74u l=0.13u
X254 VDD.t119 a_3747_311.t3 a_14825_519# VDD.t0 sg13_lv_pmos ad=0.3808p pd=2.92u as=0.3808p ps=2.92u w=1.12u l=0.13u
X255 VDD.t59 a_12849_5867# a_13306_6305# VDD.t6 sg13_lv_pmos ad=0.36237p pd=2.605u as=79.8f ps=0.8u w=0.42u l=0.13u
X256 VDD.t142 VDD.t134 VDD.t21 VDD.t6 sg13_lv_pmos ad=0.68p pd=4.68u as=0 ps=0 w=2u l=1u
X257 VSS.t469 a_27563_1842# a_27997_1842# VSS.t550 sg13_lv_nmos ad=0.1406p pd=1.12u as=0.2516p ps=2.16u w=0.74u l=0.13u
X258 a_9675_1044# a_9465_1044# VSS.t60 VSS.t556 sg13_lv_nmos ad=0.1406p pd=1.12u as=0.1665p ps=1.19u w=0.74u l=0.13u
X259 VDD.t23 a_6326_4590# a_6854_5986# VDD.t6 sg13_lv_pmos ad=0.38p pd=2.38u as=0.38p ps=2.38u w=2u l=1u
X260 a_20593_1842# a_20397_1842# VSS.t425 VSS.t531 sg13_lv_nmos ad=0.2516p pd=2.16u as=0.1406p ps=1.12u w=0.74u l=0.13u
X261 VSS.t336 a_2595_1047.t8 a_8231_1008# VSS.t335 sg13_lv_nmos ad=0.2516p pd=2.16u as=0.2516p ps=2.16u w=0.74u l=0.13u
X262 VSS.t40 a_6283_1842# a_6717_1842# VSS.t137 sg13_lv_nmos ad=0.1406p pd=1.12u as=0.2516p ps=2.16u w=0.74u l=0.13u
X263 a_10430_1044# a_10404_1008# a_10328_1044# VDD.t0 sg13_lv_pmos ad=0.3808p pd=2.92u as=0.2128p ps=1.5u w=1.12u l=0.13u
X264 VDD.t328 DELAY_VBIASP a_26151_2470# VDD.t2 sg13_lv_pmos ad=0.3808p pd=2.92u as=0.2128p ps=1.5u w=1.12u l=0.6u
X265 a_7390_1044# a_8884_1008# a_8808_1044# VDD.t0 sg13_lv_pmos ad=0.3808p pd=2.92u as=0.2128p ps=1.5u w=1.12u l=0.13u
X266 a_11491_6228# a_10649_5878# a_11397_6228# VSS.t246 sg13_lv_nmos ad=0.12665p pd=1.145u as=0.1428p ps=1.52u w=0.42u l=0.13u
X267 VDD.t313 DELAY_VBIASP a_4871_2470# VDD.t2 sg13_lv_pmos ad=0.3808p pd=2.92u as=0.2128p ps=1.5u w=1.12u l=0.6u
X268 a_6126_3816# a_6126_3816# VSS.t125 VSS.t124 sg13_lv_nmos ad=0.38p pd=2.38u as=0.68p ps=4.68u w=2u l=1u
X269 a_3449_331# MUX_SEL2 VDD.t104 VDD.t0 sg13_lv_pmos ad=0.1596p pd=1.22u as=0.2856p ps=2.36u w=0.84u l=0.13u
X270 VDD.t260 VSS.t223 VDD.t258 VDD.t0 sg13_lv_pmos ad=0.19p pd=1.38u as=0 ps=0 w=1u l=1u
X271 a_19073_1842# a_18877_1842# VSS.t62 VSS.t497 sg13_lv_nmos ad=0.2516p pd=2.16u as=0.1406p ps=1.12u w=0.74u l=0.13u
X272 VDD.t190 a_15077_1842# a_15545_1044# VDD.t0 sg13_lv_pmos ad=0.252p pd=1.57u as=0.3808p ps=2.92u w=1.12u l=0.13u
X273 a_19550_1044# a_2019_1047.t4 a_19448_1044# VSS.t28 sg13_lv_nmos ad=0.2516p pd=2.16u as=0.1406p ps=1.12u w=0.74u l=0.13u
X274 VDD.t120 a_12849_5867# a_13306_5105# VDD.t6 sg13_lv_pmos ad=0.36237p pd=2.605u as=79.8f ps=0.8u w=0.42u l=0.13u
X275 VDD.t162 VDD.t160 VDD.t161 VDD.t2 sg13_lv_pmos ad=0.3808p pd=2.92u as=0 ps=0 w=1.12u l=0.6u
X276 VSS.t243 VDD.t393 VSS.t241 VSS.t242 sg13_lv_nmos ad=79.8f pd=0.8u as=0 ps=0 w=0.42u l=1u
X277 a_13592_5871# a_13566_5835# VSS.t73 VSS.t72 sg13_lv_nmos ad=0.2516p pd=2.16u as=0.1626p ps=1.415u w=0.74u l=0.13u
X278 VSS.t357 a_19203_1842# a_19637_1842# VSS.t565 sg13_lv_nmos ad=0.1406p pd=1.12u as=0.2516p ps=2.16u w=0.74u l=0.13u
X279 VDD.t256 VSS.t223 VDD.t181 VDD.t0 sg13_lv_pmos ad=0.19p pd=1.38u as=0 ps=0 w=1u l=1u
X280 a_15108_6109# a_12849_5867# VDD.t7 VDD.t6 sg13_lv_pmos ad=79.8f pd=0.8u as=1.03698p ps=6.245u w=0.42u l=0.13u
X281 VDD.t100 VSS.t203 VDD.t99 VDD.t0 sg13_lv_pmos ad=0.34p pd=2.68u as=0 ps=0 w=1u l=1u
X282 VSS.t317 a_15108_6109# a_14757_6228# VSS.t64 sg13_lv_nmos ad=79.8f pd=0.8u as=0.1428p ps=1.52u w=0.42u l=0.13u
X283 a_27433_1842# a_27237_1842# VDD.t42 VDD.t2 sg13_lv_pmos ad=0.3808p pd=2.92u as=0.2128p ps=1.5u w=1.12u l=0.13u
X284 VDD.t78 a_1256_289# a_2873_331# VDD.t0 sg13_lv_pmos ad=0.1918p pd=1.5u as=0.1596p ps=1.22u w=0.84u l=0.13u
X285 a_13470_1044# a_2595_1047.t6 a_14235_1044# VSS.t343 sg13_lv_nmos ad=0.2516p pd=2.16u as=0.1406p ps=1.12u w=0.74u l=0.13u
X286 VSS.t510 a_9444_4590# a_9444_4590# VSS.t501 sg13_lv_nmos ad=0.68p pd=4.68u as=0.38p ps=2.38u w=2u l=1u
X287 VSS.t58 a_8563_1842# a_8997_1842# VSS.t490 sg13_lv_nmos ad=0.1406p pd=1.12u as=0.2516p ps=2.16u w=0.74u l=0.13u
X288 VSS.t596 VSS.t596 VSS.t598 VSS.t597 sg13_lv_nmos ad=0.2516p pd=2.16u as=0 ps=0 w=0.74u l=0.13u
X289 VSS.t5 DELAY_VBIASN a_13231_1842# VSS.t421 sg13_lv_nmos ad=0.2516p pd=2.16u as=0.1406p ps=1.12u w=0.74u l=0.6u
X290 VDD.t72 a_3171_1047.t7 a_11924_1008# VDD.t0 sg13_lv_pmos ad=0.3808p pd=2.92u as=0.3808p ps=2.92u w=1.12u l=0.13u
X291 VSS.t342 a_2019_1047.t3 a_22564_1008# VSS.t341 sg13_lv_nmos ad=0.2516p pd=2.16u as=0.2516p ps=2.16u w=0.74u l=0.13u
X292 a_15053_5420# a_14111_5227# a_14851_5182# VDD.t6 sg13_lv_pmos ad=93.45f pd=0.865u as=0.2048p ps=1.63u w=0.42u l=0.13u
X293 VSS.t595 VSS.t591 VSS.t591 VSS.t593 sg13_lv_nmos ad=0.1406p pd=1.12u as=0 ps=0 w=0.74u l=0.13u
X294 VSS.t427 a_23003_1842# a_23437_1842# VSS.t470 sg13_lv_nmos ad=0.1406p pd=1.12u as=0.2516p ps=2.16u w=0.74u l=0.13u
X295 VSS.t243 VDD.t392 VSS.t243 VSS.t244 sg13_lv_nmos ad=0.1428p pd=1.52u as=0 ps=0 w=0.42u l=1u
X296 VDD.t314 DELAY_VBIASP a_7151_2470# VDD.t2 sg13_lv_pmos ad=0.3808p pd=2.92u as=0.2128p ps=1.5u w=1.12u l=0.6u
X297 a_5778_3367# VSS.t528 VSS.t527 rppd l=32u w=1u
X298 a_25630_1044# a_25604_1008# a_25528_1044# VDD.t0 sg13_lv_pmos ad=0.3808p pd=2.92u as=0.2128p ps=1.5u w=1.12u l=0.13u
X299 a_10206_5835# a_10649_5878# a_10589_5914# VDD.t6 sg13_lv_pmos ad=79.8f pd=0.8u as=63f ps=0.72u w=0.42u l=0.13u
X300 a_15511_1842# a_15273_1842# a_15403_1842# VSS.t561 sg13_lv_nmos ad=0.1406p pd=1.12u as=0.2516p ps=2.16u w=0.74u l=0.2u
X301 a_10520_6292# a_10751_5878# a_10206_5835# VSS.t461 sg13_lv_nmos ad=0.2373p pd=1.97u as=79.8f ps=0.8u w=0.42u l=0.13u
X302 a_11693_5990# a_10751_5878# a_11491_6228# VDD.t6 sg13_lv_pmos ad=93.45f pd=0.865u as=0.2048p ps=1.63u w=0.42u l=0.13u
X303 a_18313_1842# a_18117_1842# VDD.t179 VDD.t2 sg13_lv_pmos ad=0.3808p pd=2.92u as=0.2128p ps=1.5u w=1.12u l=0.13u
X304 a_5731_289# a_11785_519# a_10430_1044# VDD.t0 sg13_lv_pmos ad=0.3808p pd=2.92u as=0.3808p ps=2.92u w=1.12u l=0.13u
X305 VSS.t189 VDD.t409 VSS.t187 VSS.t188 sg13_lv_nmos ad=79.8f pd=0.8u as=0 ps=0 w=0.42u l=1u
X306 a_9431_2470# a_9193_1842# a_9323_1842# VDD.t2 sg13_lv_pmos ad=0.2128p pd=1.5u as=0.3808p ps=2.92u w=1.12u l=0.2u
X307 a_17275_1044# a_17065_1044# VSS.t36 VSS.t35 sg13_lv_nmos ad=0.1406p pd=1.12u as=0.1665p ps=1.19u w=0.74u l=0.13u
X308 VDD.t62 VSS.t158 VDD.t374 VDD.t0 sg13_lv_pmos ad=0.34p pd=2.68u as=0 ps=0 w=1u l=1u
X309 VSS.t438 a_3747_1047.t6 a_15831_1008# VSS.t482 sg13_lv_nmos ad=0.2516p pd=2.16u as=0.2516p ps=2.16u w=0.74u l=0.13u
X310 a_23871_2470# a_23633_1842# a_23763_1842# VDD.t2 sg13_lv_pmos ad=0.2128p pd=1.5u as=0.3808p ps=2.92u w=1.12u l=0.2u
X311 VSS.t146 a_13883_1842# a_14317_1842# VSS.t145 sg13_lv_nmos ad=0.1406p pd=1.12u as=0.2516p ps=2.16u w=0.74u l=0.13u
X312 VSS.t161 a_3747_311.t2 a_26985_519# VSS.t160 sg13_lv_nmos ad=0.2516p pd=2.16u as=0.2516p ps=2.16u w=0.74u l=0.13u
X313 a_8433_1842# a_8237_1842# VDD.t286 VDD.t2 sg13_lv_pmos ad=0.3808p pd=2.92u as=0.2128p ps=1.5u w=1.12u l=0.13u
X314 VDD.t54 a_18443_1842# a_18877_1842# VDD.t2 sg13_lv_pmos ad=0.2128p pd=1.5u as=0.3808p ps=2.92u w=1.12u l=0.13u
X315 a_22113_1842# a_21917_1842# VDD.t39 VDD.t2 sg13_lv_pmos ad=0.3808p pd=2.92u as=0.2128p ps=1.5u w=1.12u l=0.13u
X316 a_4350_1044# a_2019_1047.t9 a_4248_1044# VSS.t119 sg13_lv_nmos ad=0.2516p pd=2.16u as=0.1406p ps=1.12u w=0.74u l=0.13u
X317 a_14888_1044# a_14317_1842# VSS.t172 VSS.t171 sg13_lv_nmos ad=0.1406p pd=1.12u as=0.2516p ps=2.16u w=0.74u l=0.13u
X318 a_13880_5118# a_13592_5423# a_13818_5118# VSS.t520 sg13_lv_nmos ad=0.1428p pd=1.52u as=37.8f ps=0.6u w=0.42u l=0.13u
X319 a_16108_289# a_3747_311.t2 a_25630_1044# VSS.t159 sg13_lv_nmos ad=0.2516p pd=2.16u as=0.2516p ps=2.16u w=0.74u l=0.13u
X320 VDD.t320 DELAY_VBIASP a_12471_2470# VDD.t2 sg13_lv_pmos ad=0.3808p pd=2.92u as=0.2128p ps=1.5u w=1.12u l=0.6u
X321 VSS.t362 a_4003_1842# a_4437_1842# VSS.t616 sg13_lv_nmos ad=0.1406p pd=1.12u as=0.2516p ps=2.16u w=0.74u l=0.13u
X322 a_16510_1044# a_16484_1008# a_16408_1044# VDD.t0 sg13_lv_pmos ad=0.3808p pd=2.92u as=0.2128p ps=1.5u w=1.12u l=0.13u
X323 VSS.t53 a_13121_5831# a_13045_6215# VSS.t52 sg13_lv_nmos ad=0.2516p pd=2.16u as=0.1406p ps=1.12u w=0.74u l=0.13u
X324 VDD.t293 a_14851_5182# a_15688_5403# VDD.t6 sg13_lv_pmos ad=0.2128p pd=1.5u as=0.3864p ps=2.93u w=1.12u l=0.13u
X325 VDD.t37 a_22243_1842# a_22677_1842# VDD.t2 sg13_lv_pmos ad=0.2128p pd=1.5u as=0.3808p ps=2.92u w=1.12u l=0.13u
X326 VDD.t228 a_3171_1047.t2 a_27124_1008# VDD.t0 sg13_lv_pmos ad=0.3808p pd=2.92u as=0.3808p ps=2.92u w=1.12u l=0.13u
X327 VDD.t10 MUX_SEL3 a_3449_331# VDD.t0 sg13_lv_pmos ad=0.1918p pd=1.5u as=0.1596p ps=1.22u w=0.84u l=0.13u
X328 a_2595_311.t0 a_2297_331# VDD.t245 VDD.t0 sg13_lv_pmos ad=0.2128p pd=1.5u as=0.1918p ps=1.5u w=1.12u l=0.13u
X329 a_10430_1044# a_11271_1008# a_11195_1044# VDD.t0 sg13_lv_pmos ad=0.3808p pd=2.92u as=0.2128p ps=1.5u w=1.12u l=0.13u
X330 a_14009_5084# DELAY_OUT_LAST VSS.t56 VSS.t140 sg13_lv_nmos ad=0.2516p pd=2.16u as=1.45407p ps=9.445u w=0.74u l=0.13u
X331 a_23355_1044# a_23145_1044# VDD.t354 VDD.t0 sg13_lv_pmos ad=0.2128p pd=1.5u as=0.252p ps=1.57u w=1.12u l=0.13u
X332 VDD.t70 a_3747_1047.t4 a_21911_1008# VDD.t0 sg13_lv_pmos ad=0.3808p pd=2.92u as=0.3808p ps=2.92u w=1.12u l=0.13u
X333 VSS.t60 a_8997_1842# a_9465_1044# VSS.t59 sg13_lv_nmos ad=0.1665p pd=1.19u as=0.2516p ps=2.16u w=0.74u l=0.13u
X334 a_13592_5423# a_13566_5328# VDD.t120 VDD.t6 sg13_lv_pmos ad=0.34p pd=2.68u as=0.36237p ps=2.605u w=1u l=0.13u
X335 a_6126_3816# a_5974_5723# a_6326_4590# VSS.t127 sg13_lv_nmos ad=0.68p pd=4.68u as=0.38p ps=2.38u w=2u l=1u
X336 a_20968_1044# a_20397_1842# VDD.t347 VDD.t0 sg13_lv_pmos ad=0.2128p pd=1.5u as=0.3808p ps=2.92u w=1.12u l=0.13u
X337 a_10951_1842# a_10713_1842# a_10843_1842# VSS.t615 sg13_lv_nmos ad=0.1406p pd=1.12u as=0.2516p ps=2.16u w=0.74u l=0.2u
X338 VSS.t311 a_2019_1047.t5 a_16484_1008# VSS.t310 sg13_lv_nmos ad=0.2516p pd=2.16u as=0.2516p ps=2.16u w=0.74u l=0.13u
X339 a_26151_2470# a_25913_1842# a_26043_1842# VDD.t2 sg13_lv_pmos ad=0.2128p pd=1.5u as=0.3808p ps=2.92u w=1.12u l=0.2u
X340 a_9444_4590# a_6854_5454# a_6854_5454# VSS.t260 sg13_lv_nmos ad=0.68p pd=4.68u as=0.38p ps=2.38u w=2u l=1u
X341 a_13753_1842# a_13557_1842# VDD.t4 VDD.t2 sg13_lv_pmos ad=0.3808p pd=2.92u as=0.2128p ps=1.5u w=1.12u l=0.13u
X342 VDD.t118 a_1721_331# a_2019_311# VDD.t0 sg13_lv_pmos ad=0.4256p pd=3u as=0.2128p ps=1.5u w=1.12u l=0.13u
X343 a_4871_2470# a_4633_1842# a_4763_1842# VDD.t2 sg13_lv_pmos ad=0.2128p pd=1.5u as=0.3808p ps=2.92u w=1.12u l=0.2u
X344 VSS.t79 a_3171_1047.t9 a_5844_1008# VSS.t78 sg13_lv_nmos ad=0.2516p pd=2.16u as=0.2516p ps=2.16u w=0.74u l=0.13u
X345 VSS.t166 VDD.t401 VSS.t166 VSS.t214 sg13_lv_nmos ad=79.8f pd=0.8u as=0 ps=0 w=0.42u l=1u
X346 VDD.t115 a_2595_311.t2 a_20905_519# VDD.t0 sg13_lv_pmos ad=0.3808p pd=2.92u as=0.3808p ps=2.92u w=1.12u l=0.13u
X347 VDD.t246 a_2297_331# a_2595_311.t0 VDD.t0 sg13_lv_pmos ad=0.4256p pd=3u as=0.2128p ps=1.5u w=1.12u l=0.13u
X348 a_14009_5084# DELAY_OUT_LAST VDD.t7 VDD.t6 sg13_lv_pmos ad=0.4088p pd=2.97u as=1.10612p ps=6.66u w=1.12u l=0.13u
X349 VSS.t44 a_2595_1047.t7 a_11271_1008# VSS.t102 sg13_lv_nmos ad=0.2516p pd=2.16u as=0.2516p ps=2.16u w=0.74u l=0.13u
X350 VSS.t357 DELAY_VBIASN a_19311_1842# VSS.t356 sg13_lv_nmos ad=0.2516p pd=2.16u as=0.1406p ps=1.12u w=0.74u l=0.6u
X351 VSS.t502 a_9444_4590# a_9444_3912# VSS.t501 sg13_lv_nmos ad=0.68p pd=4.68u as=0.38p ps=2.38u w=2u l=1u
X352 a_13880_5118# a_14111_5227# a_13566_5328# VSS.t563 sg13_lv_nmos ad=0.2373p pd=1.97u as=79.8f ps=0.8u w=0.42u l=0.13u
X353 VDD.t331 a_24523_1842# a_24957_1842# VDD.t2 sg13_lv_pmos ad=0.2128p pd=1.5u as=0.3808p ps=2.92u w=1.12u l=0.13u
X354 VSS.t97 a_3747_1047.t8 a_9751_1008# VSS.t96 sg13_lv_nmos ad=0.2516p pd=2.16u as=0.2516p ps=2.16u w=0.74u l=0.13u
X355 VSS.t100 DELAY_VBIASN a_9431_1842# VSS.t358 sg13_lv_nmos ad=0.2516p pd=2.16u as=0.1406p ps=1.12u w=0.74u l=0.6u
X356 a_19448_1044# a_18877_1842# VDD.t333 VDD.t0 sg13_lv_pmos ad=0.2128p pd=1.5u as=0.3808p ps=2.92u w=1.12u l=0.13u
X357 VSS.t53 a_11491_6228# a_12158_5867# VSS.t441 sg13_lv_nmos ad=0.1406p pd=1.12u as=0.2516p ps=2.16u w=0.74u l=0.13u
X358 a_13566_5328# a_14009_5084# a_13949_5496# VDD.t6 sg13_lv_pmos ad=79.8f pd=0.8u as=63f ps=0.72u w=0.42u l=0.13u
X359 VSS.t427 DELAY_VBIASN a_23111_1842# VSS.t426 sg13_lv_nmos ad=0.2516p pd=2.16u as=0.1406p ps=1.12u w=0.74u l=0.6u
X360 a_10430_1044# a_11924_1008# a_11848_1044# VDD.t0 sg13_lv_pmos ad=0.3808p pd=2.92u as=0.2128p ps=1.5u w=1.12u l=0.13u
X361 VDD.t330 DELAY_VBIASP a_27671_2470# VDD.t2 sg13_lv_pmos ad=0.3808p pd=2.92u as=0.2128p ps=1.5u w=1.12u l=0.6u
X362 a_6854_5986# a_6326_4590# VDD.t22 VDD.t6 sg13_lv_pmos ad=0.38p pd=2.38u as=0.38p ps=2.38u w=2u l=1u
X363 VSS.t373 DELAY_VBIASN DELAY_VBIASP VSS.t372 sg13_lv_nmos ad=0.2516p pd=2.16u as=0.6808p ps=3.32u w=0.74u l=0.6u
X364 a_25630_1044# a_26471_1008# a_26395_1044# VDD.t0 sg13_lv_pmos ad=0.3808p pd=2.92u as=0.2128p ps=1.5u w=1.12u l=0.13u
X365 VSS.t381 DELAY_VBIASN VSS.t383 VSS.t382 sg13_lv_nmos ad=1.33p pd=7.38u as=0 ps=0 w=7u l=7u
X366 a_10040_6305# a_9772_5843# a_9946_6305# VSS.t442 sg13_lv_nmos ad=60.89999f pd=0.71u as=0.1428p ps=1.52u w=0.42u l=0.13u
X367 a_7151_2470# a_6913_1842# a_7043_1842# VDD.t2 sg13_lv_pmos ad=0.2128p pd=1.5u as=0.3808p ps=2.92u w=1.12u l=0.2u
X368 a_16033_1842# a_15837_1842# VDD.t254 VDD.t2 sg13_lv_pmos ad=0.3808p pd=2.92u as=0.2128p ps=1.5u w=1.12u l=0.13u
X369 VDD.t25 a_6326_4590# a_6326_4590# VDD.t6 sg13_lv_pmos ad=0.38p pd=2.38u as=0.38p ps=2.38u w=2u l=1u
X370 VDD.t251 a_15964_289# a_16851_309# VDD.t0 sg13_lv_pmos ad=0.2086p pd=1.5u as=0.34p ps=2.68u w=1u l=0.13u
X371 VDD.t258 VSS.t223 VDD.t257 VDD.t0 sg13_lv_pmos ad=0.34p pd=2.68u as=0 ps=0 w=1u l=1u
X372 a_15464_3684# a_14851_5182# VSS.t144 VSS.t567 sg13_lv_nmos ad=0.2849p pd=2.25u as=0.2516p ps=2.16u w=0.74u l=0.13u
X373 VSS.t417 a_11603_1842# a_12037_1842# VSS.t622 sg13_lv_nmos ad=0.1406p pd=1.12u as=0.2516p ps=2.16u w=0.74u l=0.13u
X374 VSS.t229 VDD.t397 VSS.t227 VSS.t228 sg13_lv_nmos ad=79.8f pd=0.8u as=0 ps=0 w=0.42u l=1u
X375 VDD.t97 VSS.t201 VDD.t359 VDD.t0 sg13_lv_pmos ad=0.34p pd=2.68u as=0 ps=0 w=1u l=1u
X376 VDD.t364 a_5957_1842# a_6425_1044# VDD.t0 sg13_lv_pmos ad=0.252p pd=1.57u as=0.3808p ps=2.92u w=1.12u l=0.13u
X377 a_24393_1842# a_24197_1842# VSS.t108 VSS.t107 sg13_lv_nmos ad=0.2516p pd=2.16u as=0.1406p ps=1.12u w=0.74u l=0.13u
X378 a_3747_1047.t1 a_3449_1395# VSS.t463 VSS.t462 sg13_lv_nmos ad=0.1406p pd=1.12u as=0.1331p ps=1.12u w=0.74u l=0.13u
X379 a_1544_1044# MUX_SEL1 VSS.t12 VSS.t514 sg13_lv_nmos ad=0.2516p pd=2.16u as=0.2516p ps=2.16u w=0.74u l=0.13u
X380 VDD.t181 VSS.t221 VDD.t180 VDD.t0 sg13_lv_pmos ad=0.34p pd=2.68u as=0 ps=0 w=1u l=1u
X381 a_3171_1047.t0 a_2873_1395# VDD.t91 VDD.t0 sg13_lv_pmos ad=0.2128p pd=1.5u as=0.1918p ps=1.5u w=1.12u l=0.13u
X382 a_13470_1044# a_3747_1047.t6 a_15755_1044# VSS.t481 sg13_lv_nmos ad=0.2516p pd=2.16u as=0.1406p ps=1.12u w=0.74u l=0.13u
X383 VDD.t369 a_15464_3684# a_9712_3912# VSS.t558 sg13_lv_nmos ad=0.232p pd=2.08u as=0.136p ps=1.14u w=0.4u l=0.2u
X384 VDD.t191 a_5523_1842# a_5957_1842# VDD.t2 sg13_lv_pmos ad=0.2128p pd=1.5u as=0.3808p ps=2.92u w=1.12u l=0.13u
X385 VDD.t9 a_2297_1395# a_2595_1047.t0 VDD.t0 sg13_lv_pmos ad=0.4256p pd=3u as=0.2128p ps=1.5u w=1.12u l=0.13u
X386 VSS.t376 DELAY_VBIASN a_14751_1842# VSS.t375 sg13_lv_nmos ad=0.2516p pd=2.16u as=0.1406p ps=1.12u w=0.74u l=0.6u
X387 a_2967_1395# MUX_SEL1 a_2873_1395# VSS.t515 sg13_lv_nmos ad=0.1216p pd=1.02u as=0.2176p ps=1.96u w=0.64u l=0.13u
X388 a_4350_1044# a_2595_1047.t9 a_5115_1044# VSS.t80 sg13_lv_nmos ad=0.2516p pd=2.16u as=0.1406p ps=1.12u w=0.74u l=0.13u
X389 VDD.t240 a_2019_1047.t6 a_13444_1008# VDD.t0 sg13_lv_pmos ad=0.3808p pd=2.92u as=0.3808p ps=2.92u w=1.12u l=0.13u
X390 VSS.t25 a_2595_1047.t2 a_26471_1008# VSS.t24 sg13_lv_nmos ad=0.2516p pd=2.16u as=0.2516p ps=2.16u w=0.74u l=0.13u
X391 a_2595_311.t1 a_2297_331# VSS.t106 VSS.t349 sg13_lv_nmos ad=0.1406p pd=1.12u as=0.1331p ps=1.12u w=0.74u l=0.13u
X392 VSS.t289 a_14009_5878# a_14111_5878# VSS.t288 sg13_lv_nmos ad=2.39977p pd=15.495u as=0.2516p ps=2.16u w=0.74u l=0.13u
X393 VSS.t362 DELAY_VBIASN a_4111_1842# VSS.t361 sg13_lv_nmos ad=0.2516p pd=2.16u as=0.1406p ps=1.12u w=0.74u l=0.6u
X394 a_2297_1395# MUX_SEL0 VDD.t334 VDD.t0 sg13_lv_pmos ad=0.1596p pd=1.22u as=0.2856p ps=2.36u w=0.84u l=0.13u
X395 VSS.t36 a_16597_1842# a_17065_1044# VSS.t290 sg13_lv_nmos ad=0.1665p pd=1.19u as=0.2516p ps=2.16u w=0.74u l=0.13u
X396 VDD.t317 DELAY_VBIASP a_8671_2470# VDD.t2 sg13_lv_pmos ad=0.3808p pd=2.92u as=0.2128p ps=1.5u w=1.12u l=0.6u
X397 VDD.t236 VSS.t199 VDD.t196 VDD.t0 sg13_lv_pmos ad=0.19p pd=1.38u as=0 ps=0 w=1u l=1u
X398 VDD.t125 a_1544_1044# a_1721_1395# VDD.t0 sg13_lv_pmos ad=0.1918p pd=1.5u as=0.1596p ps=1.22u w=0.84u l=0.13u
X399 a_9444_4590# a_9444_4590# VSS.t509 VSS.t499 sg13_lv_nmos ad=0.38p pd=2.38u as=0.68p ps=4.68u w=2u l=1u
X400 a_4248_1044# a_4157_1313# VDD.t60 VDD.t0 sg13_lv_pmos ad=0.2128p pd=1.5u as=0.3808p ps=2.92u w=1.12u l=0.13u
X401 a_5778_3367# a_6126_3816# a_6326_4590# VSS.t124 sg13_lv_nmos ad=0.68p pd=4.68u as=0.38p ps=2.38u w=2u l=1u
X402 a_12471_2470# a_12233_1842# a_12363_1842# VDD.t2 sg13_lv_pmos ad=0.2128p pd=1.5u as=0.3808p ps=2.92u w=1.12u l=0.2u
X403 a_17031_1842# a_16793_1842# a_16923_1842# VSS.t536 sg13_lv_nmos ad=0.1406p pd=1.12u as=0.2516p ps=2.16u w=0.74u l=0.2u
X404 VSS.t106 a_1721_331# a_2019_311# VSS.t163 sg13_lv_nmos ad=0.2812p pd=2.24u as=0.1406p ps=1.12u w=0.74u l=0.13u
X405 a_19550_1044# a_21911_1008# a_21835_1044# VDD.t0 sg13_lv_pmos ad=0.3808p pd=2.92u as=0.2128p ps=1.5u w=1.12u l=0.13u
X406 a_16108_289# a_26985_519# a_25630_1044# VDD.t0 sg13_lv_pmos ad=0.3808p pd=2.92u as=0.3808p ps=2.92u w=1.12u l=0.13u
X407 VSS.t106 a_2297_331# a_2595_311.t1 VSS.t350 sg13_lv_nmos ad=0.2812p pd=2.24u as=0.1406p ps=1.12u w=0.74u l=0.13u
X408 a_18795_1044# a_18585_1044# VSS.t139 VSS.t138 sg13_lv_nmos ad=0.1406p pd=1.12u as=0.1665p ps=1.19u w=0.74u l=0.13u
X409 a_9444_3912# a_6854_5454# a_9712_3912# VSS.t260 sg13_lv_nmos ad=0.68p pd=4.68u as=0.38p ps=2.38u w=2u l=1u
X410 a_20831_1842# a_20593_1842# a_20723_1842# VSS.t617 sg13_lv_nmos ad=0.1406p pd=1.12u as=0.2516p ps=2.16u w=0.74u l=0.2u
X411 VSS.t187 VDD.t409 VSS.t186 VSS.t185 sg13_lv_nmos ad=0.1428p pd=1.52u as=0 ps=0 w=0.42u l=1u
X412 VDD.t354 a_22677_1842# a_23145_1044# VDD.t0 sg13_lv_pmos ad=0.252p pd=1.57u as=0.3808p ps=2.92u w=1.12u l=0.13u
X413 VSS.t333 a_2595_1047.t5 a_17351_1008# VSS.t332 sg13_lv_nmos ad=0.2516p pd=2.16u as=0.2516p ps=2.16u w=0.74u l=0.13u
X414 a_5393_1842# a_5197_1842# VSS.t7 VSS.t312 sg13_lv_nmos ad=0.2516p pd=2.16u as=0.1406p ps=1.12u w=0.74u l=0.13u
X415 VSS.t308 DELAY_VBIASN a_17031_1842# VSS.t367 sg13_lv_nmos ad=0.2516p pd=2.16u as=0.1406p ps=1.12u w=0.74u l=0.6u
X416 a_25630_1044# a_3171_1047.t2 a_27048_1044# VSS.t328 sg13_lv_nmos ad=0.2516p pd=2.16u as=0.1406p ps=1.12u w=0.74u l=0.13u
X417 VDD.t147 VDD.t145 VDD.t146 VDD.t50 sg13_lv_pmos ad=0.3808p pd=2.92u as=0 ps=0 w=1.12u l=0.13u
X418 a_9953_1842# a_9757_1842# VDD.t75 VDD.t2 sg13_lv_pmos ad=0.3808p pd=2.92u as=0.2128p ps=1.5u w=1.12u l=0.13u
X419 VDD.t46 a_10843_1842# a_11277_1842# VDD.t2 sg13_lv_pmos ad=0.2128p pd=1.5u as=0.3808p ps=2.92u w=1.12u l=0.13u
X420 VSS.t38 a_26803_1842# a_27237_1842# VSS.t37 sg13_lv_nmos ad=0.1406p pd=1.12u as=0.2516p ps=2.16u w=0.74u l=0.13u
X421 a_4350_1044# a_3171_1047.t9 a_5768_1044# VSS.t77 sg13_lv_nmos ad=0.2516p pd=2.16u as=0.1406p ps=1.12u w=0.74u l=0.13u
X422 VDD.t221 a_12849_5867# a_13566_5328# VDD.t6 sg13_lv_pmos ad=0.1563p pd=1.22u as=0.147p ps=1.54u w=0.42u l=0.13u
X423 VDD.t152 VDD.t153 VDD.t154 VDD.t50 sg13_lv_pmos ad=0.2128p pd=1.5u as=0 ps=0 w=1.12u l=0.13u
X424 a_10430_1044# a_12791_1008# a_12715_1044# VDD.t0 sg13_lv_pmos ad=0.3808p pd=2.92u as=0.2128p ps=1.5u w=1.12u l=0.13u
X425 a_19311_1842# a_19073_1842# a_19203_1842# VSS.t177 sg13_lv_nmos ad=0.1406p pd=1.12u as=0.2516p ps=2.16u w=0.74u l=0.2u
X426 a_24875_1044# a_24665_1044# VDD.t80 VDD.t0 sg13_lv_pmos ad=0.2128p pd=1.5u as=0.252p ps=1.57u w=1.12u l=0.13u
X427 VDD.t243 a_2595_1047.t3 a_23431_1008# VDD.t0 sg13_lv_pmos ad=0.3808p pd=2.92u as=0.3808p ps=2.92u w=1.12u l=0.13u
X428 VDD.t7 a_14009_5878# a_14111_5878# VDD.t6 sg13_lv_pmos ad=1.10612p pd=6.66u as=0.3864p ps=2.93u w=1.12u l=0.13u
X429 a_13949_5914# a_13592_5871# VDD.t217 VDD.t6 sg13_lv_pmos ad=63f pd=0.72u as=0.1563p ps=1.22u w=0.42u l=0.13u
X430 VDD.t1 a_13557_1842# a_14025_1044# VDD.t0 sg13_lv_pmos ad=0.252p pd=1.57u as=0.3808p ps=2.92u w=1.12u l=0.13u
X431 a_23111_1842# a_22873_1842# a_23003_1842# VSS.t452 sg13_lv_nmos ad=0.1406p pd=1.12u as=0.2516p ps=2.16u w=0.74u l=0.2u
X432 VSS.t448 a_10649_5878# a_10751_5878# VSS.t472 sg13_lv_nmos ad=2.39977p pd=15.495u as=0.2516p ps=2.16u w=0.74u l=0.13u
X433 a_27671_2470# a_27433_1842# a_27563_1842# VDD.t2 sg13_lv_pmos ad=0.2128p pd=1.5u as=0.3808p ps=2.92u w=1.12u l=0.2u
X434 VSS.t272 a_17683_1842# a_18117_1842# VSS.t271 sg13_lv_nmos ad=0.1406p pd=1.12u as=0.2516p ps=2.16u w=0.74u l=0.13u
X435 VSS.t223 VDD.t398 VSS.t223 VSS.t225 sg13_lv_nmos ad=79.8f pd=0.8u as=0 ps=0 w=0.42u l=1u
X436 a_10713_1842# a_10517_1842# VSS.t114 VSS.t113 sg13_lv_nmos ad=0.2516p pd=2.16u as=0.1406p ps=1.12u w=0.74u l=0.13u
X437 VSS.t19 a_2019_1047.t8 a_7364_1008# VSS.t18 sg13_lv_nmos ad=0.2516p pd=2.16u as=0.2516p ps=2.16u w=0.74u l=0.13u
X438 VSS.t407 DELAY_VBIASN VSS.t405 VSS.t390 sg13_lv_nmos ad=1.33p pd=7.38u as=0 ps=0 w=7u l=7u
X439 VSS.t415 a_7803_1842# a_8237_1842# VSS.t476 sg13_lv_nmos ad=0.1406p pd=1.12u as=0.2516p ps=2.16u w=0.74u l=0.13u
X440 a_13592_5871# a_14111_5878# a_14851_6228# VSS.t64 sg13_lv_nmos ad=0.3473p pd=2.71u as=0.12665p ps=1.145u w=0.74u l=0.13u
X441 a_15304_4605# a_14851_6228# VSS.t523 VSS.t522 sg13_lv_nmos ad=0.2849p pd=2.25u as=0.2516p ps=2.16u w=0.74u l=0.13u
X442 VDD.t304 DELAY_VBIASP a_16271_2470# VDD.t2 sg13_lv_pmos ad=0.3808p pd=2.92u as=0.2128p ps=1.5u w=1.12u l=0.6u
X443 VSS.t223 VDD.t399 VSS.t221 VSS.t222 sg13_lv_nmos ad=79.8f pd=0.8u as=0 ps=0 w=0.42u l=1u
X444 VSS.t203 VDD.t404 VSS.t203 VSS.t204 sg13_lv_nmos ad=0.1428p pd=1.52u as=0 ps=0 w=0.42u l=1u
X445 a_6854_5454# a_6854_5454# a_9444_4590# VSS.t259 sg13_lv_nmos ad=0.38p pd=2.38u as=0.68p ps=4.68u w=2u l=1u
X446 VDD.t47 a_26043_1842# a_26477_1842# VDD.t2 sg13_lv_pmos ad=0.2128p pd=1.5u as=0.3808p ps=2.92u w=1.12u l=0.13u
X447 VDD.t169 DLL_RESETN a_10206_5835# VDD.t6 sg13_lv_pmos ad=0.1563p pd=1.22u as=0.147p ps=1.54u w=0.42u l=0.13u
X448 a_3543_331# MUX_SEL2 a_3449_331# VSS.t123 sg13_lv_nmos ad=0.1216p pd=1.02u as=0.2176p ps=1.96u w=0.64u l=0.13u
X449 a_22488_1044# a_21917_1842# VSS.t34 VSS.t33 sg13_lv_nmos ad=0.1406p pd=1.12u as=0.2516p ps=2.16u w=0.74u l=0.13u
X450 a_14851_5182# a_14009_5084# a_13592_5423# VDD.t6 sg13_lv_pmos ad=0.2048p pd=1.63u as=0.34p ps=2.68u w=1u l=0.13u
X451 VDD.t90 VSS.t193 VDD.t88 VDD.t0 sg13_lv_pmos ad=0.19p pd=1.38u as=0 ps=0 w=1u l=1u
X452 a_22590_1044# a_24084_1008# a_24008_1044# VDD.t0 sg13_lv_pmos ad=0.3808p pd=2.92u as=0.2128p ps=1.5u w=1.12u l=0.13u
X453 VDD.t298 DELAY_VBIASP a_20071_2470# VDD.t2 sg13_lv_pmos ad=0.3808p pd=2.92u as=0.2128p ps=1.5u w=1.12u l=0.6u
X454 a_9444_3912# a_9444_4590# VSS.t500 VSS.t499 sg13_lv_nmos ad=0.38p pd=2.38u as=0.68p ps=4.68u w=2u l=1u
X455 a_14751_1842# a_14513_1842# a_14643_1842# VSS.t261 sg13_lv_nmos ad=0.1406p pd=1.12u as=0.2516p ps=2.16u w=0.74u l=0.2u
X456 VSS.t116 a_2873_1395# a_3171_1047.t1 VSS.t117 sg13_lv_nmos ad=0.2812p pd=2.24u as=0.1406p ps=1.12u w=0.74u l=0.13u
X457 VDD.t225 VSS.t239 VDD.t68 VDD.t0 sg13_lv_pmos ad=0.19p pd=1.38u as=0 ps=0 w=1u l=1u
X458 a_25630_1044# a_27991_1008# a_27915_1044# VDD.t0 sg13_lv_pmos ad=0.3808p pd=2.92u as=0.2128p ps=1.5u w=1.12u l=0.13u
X459 VSS.t607 VSS.t604 VSS.t604 VSS.t605 sg13_lv_nmos ad=0.1406p pd=1.12u as=0 ps=0 w=0.74u l=0.13u
X460 a_4111_1842# REF_CLK a_4003_1842# VSS.t449 sg13_lv_nmos ad=0.1406p pd=1.12u as=0.2516p ps=2.16u w=0.74u l=0.2u
X461 a_8671_2470# a_8433_1842# a_8563_1842# VDD.t2 sg13_lv_pmos ad=0.2128p pd=1.5u as=0.3808p ps=2.92u w=1.12u l=0.2u
X462 a_17553_1842# a_17357_1842# VDD.t203 VDD.t2 sg13_lv_pmos ad=0.3808p pd=2.92u as=0.2128p ps=1.5u w=1.12u l=0.13u
X463 VSS.t12 a_1544_1044# a_2391_1395# VSS.t174 sg13_lv_nmos ad=0.1331p pd=1.12u as=0.1216p ps=1.02u w=0.64u l=0.13u
X464 VSS.t166 a_3747_311.t3 a_14825_519# VSS.t165 sg13_lv_nmos ad=0.2516p pd=2.16u as=0.2516p ps=2.16u w=0.74u l=0.13u
X465 VSS.t106 a_1256_289# a_2967_331# VSS.t105 sg13_lv_nmos ad=0.1331p pd=1.12u as=0.1216p ps=1.02u w=0.64u l=0.13u
X466 a_2019_1047.t1 a_1721_1395# VSS.t12 VSS.t534 sg13_lv_nmos ad=0.1406p pd=1.12u as=0.1331p ps=1.12u w=0.74u l=0.13u
X467 a_15964_289# a_15765_463# a_5731_289# VSS.t50 sg13_lv_nmos ad=0.2183p pd=1.33u as=0.2516p ps=2.16u w=0.74u l=0.13u
X468 a_13470_1044# a_2019_1047.t6 a_13368_1044# VSS.t337 sg13_lv_nmos ad=0.2516p pd=2.16u as=0.1406p ps=1.12u w=0.74u l=0.13u
X469 VDD.t136 VDD.t134 VDD.t22 VDD.t6 sg13_lv_pmos ad=0.68p pd=4.68u as=0 ps=0 w=2u l=1u
X470 VSS.t5 a_13123_1842# a_13557_1842# VSS.t178 sg13_lv_nmos ad=0.1406p pd=1.12u as=0.2516p ps=2.16u w=0.74u l=0.13u
X471 VDD.t14 VSS.t241 VDD.t237 VDD.t0 sg13_lv_pmos ad=0.34p pd=2.68u as=0 ps=0 w=1u l=1u
X472 VSS.t546 a_3171_1047.t3 a_24084_1008# VSS.t545 sg13_lv_nmos ad=0.2516p pd=2.16u as=0.2516p ps=2.16u w=0.74u l=0.13u
X473 a_25913_1842# a_25717_1842# VSS.t429 VSS.t559 sg13_lv_nmos ad=0.2516p pd=2.16u as=0.1406p ps=1.12u w=0.74u l=0.13u
X474 VDD.t7 a_10649_5878# a_10751_5878# VDD.t6 sg13_lv_pmos ad=1.10612p pd=6.66u as=0.3864p ps=2.93u w=1.12u l=0.13u
X475 a_21353_1842# a_21157_1842# VDD.t201 VDD.t2 sg13_lv_pmos ad=0.3808p pd=2.92u as=0.2128p ps=1.5u w=1.12u l=0.13u
X476 VSS.t227 VDD.t397 VSS.t158 VSS.t226 sg13_lv_nmos ad=0.1428p pd=1.52u as=0 ps=0 w=0.42u l=1u
X477 a_2297_331# MUX_SEL2 VDD.t105 VDD.t0 sg13_lv_pmos ad=0.1596p pd=1.22u as=0.2856p ps=2.36u w=0.84u l=0.13u
X478 VDD.t272 a_7043_1842# a_7477_1842# VDD.t2 sg13_lv_pmos ad=0.2128p pd=1.5u as=0.3808p ps=2.92u w=1.12u l=0.13u
X479 a_2873_331# MUX_SEL3 VDD.t56 VDD.t0 sg13_lv_pmos ad=0.1596p pd=1.22u as=0.2856p ps=2.36u w=0.84u l=0.13u
X480 a_10589_5914# a_10232_5871# VDD.t169 VDD.t6 sg13_lv_pmos ad=63f pd=0.72u as=0.1563p ps=1.22u w=0.42u l=0.13u
X481 a_8155_1044# a_7945_1044# VDD.t223 VDD.t0 sg13_lv_pmos ad=0.2128p pd=1.5u as=0.252p ps=1.57u w=1.12u l=0.13u
X482 a_13880_6292# a_13592_5871# a_13818_6292# VSS.t353 sg13_lv_nmos ad=0.1428p pd=1.52u as=37.8f ps=0.6u w=0.42u l=0.13u
X483 VSS.t139 a_18117_1842# a_18585_1044# VSS.t575 sg13_lv_nmos ad=0.1665p pd=1.19u as=0.2516p ps=2.16u w=0.74u l=0.13u
X484 a_27048_1044# a_26477_1842# VDD.t48 VDD.t0 sg13_lv_pmos ad=0.2128p pd=1.5u as=0.3808p ps=2.92u w=1.12u l=0.13u
X485 a_5768_1044# a_5197_1842# VDD.t215 VDD.t0 sg13_lv_pmos ad=0.2128p pd=1.5u as=0.3808p ps=2.92u w=1.12u l=0.13u
X486 a_10232_5871# a_10751_5878# a_11491_6228# VSS.t246 sg13_lv_nmos ad=0.3473p pd=2.71u as=0.12665p ps=1.145u w=0.74u l=0.13u
X487 a_12656_5864# DLL_RESETN VDD.t166 VDD.t6 sg13_lv_pmos ad=0.3808p pd=2.92u as=0.3808p ps=2.92u w=1.12u l=0.13u
X488 a_13991_2470# a_13753_1842# a_13883_1842# VDD.t2 sg13_lv_pmos ad=0.2128p pd=1.5u as=0.3808p ps=2.92u w=1.12u l=0.2u
X489 VSS.t543 a_3171_1047.t6 a_14964_1008# VSS.t542 sg13_lv_nmos ad=0.2516p pd=2.16u as=0.2516p ps=2.16u w=0.74u l=0.13u
X490 VDD.t178 a_2019_311# a_17865_519# VDD.t0 sg13_lv_pmos ad=0.3808p pd=2.92u as=0.3808p ps=2.92u w=1.12u l=0.13u
X491 DELAY_OUT_LAST a_27997_1842# VSS.t469 VSS.t468 sg13_lv_nmos ad=0.2516p pd=2.16u as=0.1406p ps=1.12u w=0.74u l=0.13u
X492 a_11195_1044# a_10985_1044# VSS.t112 VSS.t348 sg13_lv_nmos ad=0.1406p pd=1.12u as=0.1665p ps=1.19u w=0.74u l=0.13u
X493 VDD.t80 a_24197_1842# a_24665_1044# VDD.t0 sg13_lv_pmos ad=0.252p pd=1.57u as=0.3808p ps=2.92u w=1.12u l=0.13u
X494 a_6913_1842# a_6717_1842# VSS.t40 VSS.t39 sg13_lv_nmos ad=0.2516p pd=2.16u as=0.1406p ps=1.12u w=0.74u l=0.13u
X495 VSS.t62 DELAY_VBIASN a_18551_1842# VSS.t423 sg13_lv_nmos ad=0.2516p pd=2.16u as=0.1406p ps=1.12u w=0.74u l=0.6u
X496 a_16510_1044# a_18004_1008# a_17928_1044# VDD.t0 sg13_lv_pmos ad=0.3808p pd=2.92u as=0.2128p ps=1.5u w=1.12u l=0.13u
X497 a_13592_5423# a_13566_5328# VSS.t169 VSS.t168 sg13_lv_nmos ad=0.2516p pd=2.16u as=0.1626p ps=1.415u w=0.74u l=0.13u
X498 VDD.t197 a_12363_1842# a_12797_1842# VDD.t2 sg13_lv_pmos ad=0.2128p pd=1.5u as=0.3808p ps=2.92u w=1.12u l=0.13u
X499 VSS.t15 MUX_SEL3 a_3543_331# VSS.t68 sg13_lv_nmos ad=0.1331p pd=1.12u as=0.1216p ps=1.02u w=0.64u l=0.13u
X500 a_22590_1044# a_2595_1047.t3 a_23355_1044# VSS.t345 sg13_lv_nmos ad=0.2516p pd=2.16u as=0.1406p ps=1.12u w=0.74u l=0.13u
X501 a_9712_3912# a_6854_5454# a_9444_3912# VSS.t259 sg13_lv_nmos ad=0.38p pd=2.38u as=0.68p ps=4.68u w=2u l=1u
X502 VSS.t27 DELAY_VBIASN a_22351_1842# VSS.t360 sg13_lv_nmos ad=0.2516p pd=2.16u as=0.1406p ps=1.12u w=0.74u l=0.6u
X503 VDD.t222 a_3171_1047.t4 a_21044_1008# VDD.t0 sg13_lv_pmos ad=0.3808p pd=2.92u as=0.3808p ps=2.92u w=1.12u l=0.13u
X504 VDD.t234 VSS.t233 VDD.t232 VDD.t0 sg13_lv_pmos ad=0.19p pd=1.38u as=0 ps=0 w=1u l=1u
X505 a_16271_2470# a_16033_1842# a_16163_1842# VDD.t2 sg13_lv_pmos ad=0.2128p pd=1.5u as=0.3808p ps=2.92u w=1.12u l=0.2u
X506 VDD.t207 VSS.t166 VDD.t95 VDD.t0 sg13_lv_pmos ad=0.19p pd=1.38u as=0 ps=0 w=1u l=1u
X507 a_19833_1842# a_19637_1842# VSS.t357 VSS.t480 sg13_lv_nmos ad=0.2516p pd=2.16u as=0.1406p ps=1.12u w=0.74u l=0.13u
X508 VDD.t177 a_2019_311# a_5705_519# VDD.t0 sg13_lv_pmos ad=0.3808p pd=2.92u as=0.3808p ps=2.92u w=1.12u l=0.13u
X509 VDD.t342 a_14851_6228# a_15108_6109# VDD.t6 sg13_lv_pmos ad=0.2639p pd=1.81u as=79.8f ps=0.8u w=0.42u l=0.13u
X510 a_10520_6292# a_10232_5871# a_10458_6292# VSS.t623 sg13_lv_nmos ad=0.1428p pd=1.52u as=37.8f ps=0.6u w=0.42u l=0.13u
X511 a_15270_6305# a_12849_5867# VSS.t317 VSS.t64 sg13_lv_nmos ad=37.8f pd=0.6u as=79.8f ps=0.8u w=0.42u l=0.13u
X512 a_20071_2470# a_19833_1842# a_19963_1842# VDD.t2 sg13_lv_pmos ad=0.2128p pd=1.5u as=0.3808p ps=2.92u w=1.12u l=0.2u
X513 a_9193_1842# a_8997_1842# VSS.t58 VSS.t57 sg13_lv_nmos ad=0.2516p pd=2.16u as=0.1406p ps=1.12u w=0.74u l=0.13u
X514 a_24631_1842# a_24393_1842# a_24523_1842# VSS.t325 sg13_lv_nmos ad=0.1406p pd=1.12u as=0.2516p ps=2.16u w=0.74u l=0.2u
X515 VDD.t209 VSS.t166 VDD.t208 VDD.t0 sg13_lv_pmos ad=0.34p pd=2.68u as=0 ps=0 w=1u l=1u
X516 VSS.t22 a_2019_1047.t7 a_10404_1008# VSS.t21 sg13_lv_nmos ad=0.2516p pd=2.16u as=0.2516p ps=2.16u w=0.74u l=0.13u
X517 VSS.t387 DELAY_VBIASN VSS.t389 VSS.t388 sg13_lv_nmos ad=1.33p pd=7.38u as=0 ps=0 w=7u l=7u
X518 VDD.t277 a_14643_1842# a_15077_1842# VDD.t2 sg13_lv_pmos ad=0.2128p pd=1.5u as=0.3808p ps=2.92u w=1.12u l=0.13u
X519 VDD.t245 a_1544_289# a_2297_331# VDD.t0 sg13_lv_pmos ad=0.1918p pd=1.5u as=0.1596p ps=1.22u w=0.84u l=0.13u
X520 a_23633_1842# a_23437_1842# VSS.t427 VSS.t433 sg13_lv_nmos ad=0.2516p pd=2.16u as=0.1406p ps=1.12u w=0.74u l=0.13u
X521 VSS.t223 VDD.t398 VSS.t223 VSS.t224 sg13_lv_nmos ad=0.1428p pd=1.52u as=0 ps=0 w=0.42u l=1u
X522 a_2019_311# a_1721_331# VDD.t117 VDD.t0 sg13_lv_pmos ad=0.2128p pd=1.5u as=0.1918p ps=1.5u w=1.12u l=0.13u
X523 VSS.t100 a_9323_1842# a_9757_1842# VSS.t458 sg13_lv_nmos ad=0.1406p pd=1.12u as=0.2516p ps=2.16u w=0.74u l=0.13u
X524 a_26395_1044# a_26185_1044# VSS.t519 VSS.t518 sg13_lv_nmos ad=0.1406p pd=1.12u as=0.1665p ps=1.19u w=0.74u l=0.13u
X525 VDD.t300 DELAY_VBIASP a_17791_2470# VDD.t2 sg13_lv_pmos ad=0.3808p pd=2.92u as=0.2128p ps=1.5u w=1.12u l=0.6u
X526 VSS.t485 a_3747_1047.t3 a_24951_1008# VSS.t484 sg13_lv_nmos ad=0.2516p pd=2.16u as=0.2516p ps=2.16u w=0.74u l=0.13u
X527 VSS.t201 VDD.t405 VSS.t201 VSS.t200 sg13_lv_nmos ad=0.1428p pd=1.52u as=0 ps=0 w=0.42u l=1u
X528 VSS.t221 VDD.t399 VSS.t221 VSS.t220 sg13_lv_nmos ad=0.1428p pd=1.52u as=0 ps=0 w=0.42u l=1u
X529 a_3747_1047.t0 a_3449_1395# VDD.t278 VDD.t0 sg13_lv_pmos ad=0.2128p pd=1.5u as=0.1918p ps=1.5u w=1.12u l=0.13u
X530 a_13368_1044# a_12797_1842# VDD.t199 VDD.t0 sg13_lv_pmos ad=0.2128p pd=1.5u as=0.3808p ps=2.92u w=1.12u l=0.13u
X531 a_24008_1044# a_23437_1842# VSS.t347 VSS.t434 sg13_lv_nmos ad=0.1406p pd=1.12u as=0.2516p ps=2.16u w=0.74u l=0.13u
X532 VDD.t326 DELAY_VBIASP a_21591_2470# VDD.t2 sg13_lv_pmos ad=0.3808p pd=2.92u as=0.2128p ps=1.5u w=1.12u l=0.6u
X533 a_15964_289# MUX_SEL4 a_5731_289# VDD.t0 sg13_lv_pmos ad=0.3304p pd=1.71u as=0.3808p ps=2.92u w=1.12u l=0.13u
X534 a_4350_1044# a_6711_1008# a_6635_1044# VDD.t0 sg13_lv_pmos ad=0.3808p pd=2.92u as=0.2128p ps=1.5u w=1.12u l=0.13u
X535 a_2873_1395# MUX_SEL1 VDD.t337 VDD.t0 sg13_lv_pmos ad=0.1596p pd=1.22u as=0.2856p ps=2.36u w=0.84u l=0.13u
X536 VSS.t169 a_12849_5867# a_13400_5105# VSS.t318 sg13_lv_nmos ad=0.1626p pd=1.415u as=60.89999f ps=0.71u w=0.42u l=0.13u
X537 a_1256_1044# MUX_SEL0 VSS.t12 VSS.t511 sg13_lv_nmos ad=0.2516p pd=2.16u as=0.2516p ps=2.16u w=0.74u l=0.13u
X538 VSS.t199 VDD.t406 VSS.t197 VSS.t198 sg13_lv_nmos ad=79.8f pd=0.8u as=0 ps=0 w=0.42u l=1u
X539 a_19550_1044# a_20391_1008# a_20315_1044# VDD.t0 sg13_lv_pmos ad=0.3808p pd=2.92u as=0.2128p ps=1.5u w=1.12u l=0.13u
X540 VDD.t165 VDD.t163 VDD.t162 VDD.t2 sg13_lv_pmos ad=0.2128p pd=1.5u as=0 ps=0 w=1.12u l=0.2u
X541 a_5631_1842# a_5393_1842# a_5523_1842# VSS.t453 sg13_lv_nmos ad=0.1406p pd=1.12u as=0.2516p ps=2.16u w=0.74u l=0.2u
X542 a_14513_1842# a_14317_1842# VSS.t146 VSS.t170 sg13_lv_nmos ad=0.2516p pd=2.16u as=0.1406p ps=1.12u w=0.74u l=0.13u
X543 VSS.t158 a_2595_311.t2 a_20905_519# VSS.t157 sg13_lv_nmos ad=0.2516p pd=2.16u as=0.2516p ps=2.16u w=0.74u l=0.13u
X544 VDD.t223 a_7477_1842# a_7945_1044# VDD.t0 sg13_lv_pmos ad=0.252p pd=1.57u as=0.3808p ps=2.92u w=1.12u l=0.13u
X545 a_13470_1044# a_3171_1047.t6 a_14888_1044# VSS.t541 sg13_lv_nmos ad=0.2516p pd=2.16u as=0.1406p ps=1.12u w=0.74u l=0.13u
X546 a_4633_1842# a_4437_1842# VSS.t362 VSS.t533 sg13_lv_nmos ad=0.2516p pd=2.16u as=0.1406p ps=1.12u w=0.74u l=0.13u
X547 a_1256_289# MUX_SEL2 VSS.t66 VSS.t121 sg13_lv_nmos ad=0.2516p pd=2.16u as=0.2516p ps=2.16u w=0.74u l=0.13u
X548 VSS.t149 a_2019_1047.t2 a_25604_1008# VSS.t148 sg13_lv_nmos ad=0.2516p pd=2.16u as=0.2516p ps=2.16u w=0.74u l=0.13u
X549 a_13019_5831# a_15688_5403# VDD.t293 VDD.t6 sg13_lv_pmos ad=0.3808p pd=2.92u as=0.2128p ps=1.5u w=1.12u l=0.13u
X550 VSS.t383 DELAY_VBIASN VSS.t385 VSS.t384 sg13_lv_nmos ad=1.33p pd=7.38u as=0 ps=0 w=7u l=7u
X551 a_16108_289# MUX_SEL4 a_15964_289# VSS.t276 sg13_lv_nmos ad=0.2516p pd=2.16u as=0.2183p ps=1.33u w=0.74u l=0.13u
X552 a_13400_6305# a_12355_5867# a_13306_6305# VSS.t176 sg13_lv_nmos ad=60.89999f pd=0.71u as=0.1428p ps=1.52u w=0.42u l=0.13u
X553 a_22873_1842# a_22677_1842# VDD.t37 VDD.t2 sg13_lv_pmos ad=0.3808p pd=2.92u as=0.2128p ps=1.5u w=1.12u l=0.13u
X554 a_21835_1044# a_21625_1044# VSS.t264 VSS.t263 sg13_lv_nmos ad=0.1406p pd=1.12u as=0.1665p ps=1.19u w=0.74u l=0.13u
X555 VSS.t530 a_2595_1047.t4 a_20391_1008# VSS.t572 sg13_lv_nmos ad=0.2516p pd=2.16u as=0.2516p ps=2.16u w=0.74u l=0.13u
X556 a_9675_1044# a_9465_1044# VDD.t53 VDD.t0 sg13_lv_pmos ad=0.2128p pd=1.5u as=0.252p ps=1.57u w=1.12u l=0.13u
X557 VSS.t112 a_10517_1842# a_10985_1044# VSS.t111 sg13_lv_nmos ad=0.1665p pd=1.19u as=0.2516p ps=2.16u w=0.74u l=0.13u
X558 VDD.t239 a_2595_1047.t8 a_8231_1008# VDD.t0 sg13_lv_pmos ad=0.3808p pd=2.92u as=0.3808p ps=2.92u w=1.12u l=0.13u
X559 a_18551_1842# a_18313_1842# a_18443_1842# VSS.t8 sg13_lv_nmos ad=0.1406p pd=1.12u as=0.2516p ps=2.16u w=0.74u l=0.2u
X560 a_12943_5867# a_12656_5864# a_12849_5867# VDD.t6 sg13_lv_pmos ad=0.2128p pd=1.5u as=0.3808p ps=2.92u w=1.12u l=0.13u
X561 a_13566_5835# a_14009_5878# a_13949_5914# VDD.t6 sg13_lv_pmos ad=79.8f pd=0.8u as=63f ps=0.72u w=0.42u l=0.13u
X562 a_22351_1842# a_22113_1842# a_22243_1842# VSS.t321 sg13_lv_nmos ad=0.1406p pd=1.12u as=0.2516p ps=2.16u w=0.74u l=0.2u
X563 VSS.t488 a_3747_1047.t5 a_18871_1008# VSS.t487 sg13_lv_nmos ad=0.2516p pd=2.16u as=0.2516p ps=2.16u w=0.74u l=0.13u
X564 VSS.t308 a_16923_1842# a_17357_1842# VSS.t307 sg13_lv_nmos ad=0.1406p pd=1.12u as=0.2516p ps=2.16u w=0.74u l=0.13u
X565 VDD.t58 a_3171_311.t2 a_23945_519# VDD.t0 sg13_lv_pmos ad=0.3808p pd=2.92u as=0.3808p ps=2.92u w=1.12u l=0.13u
X566 a_2019_311# a_1721_331# VSS.t106 VSS.t162 sg13_lv_nmos ad=0.1406p pd=1.12u as=0.1331p ps=1.12u w=0.74u l=0.13u
X567 a_25153_1842# a_24957_1842# VDD.t331 VDD.t2 sg13_lv_pmos ad=0.3808p pd=2.92u as=0.2128p ps=1.5u w=1.12u l=0.13u
X568 a_17928_1044# a_17357_1842# VSS.t333 VSS.t619 sg13_lv_nmos ad=0.1406p pd=1.12u as=0.2516p ps=2.16u w=0.74u l=0.13u
X569 a_12715_1044# a_12505_1044# VSS.t548 VSS.t570 sg13_lv_nmos ad=0.1406p pd=1.12u as=0.1665p ps=1.19u w=0.74u l=0.13u
X570 a_13880_6292# a_14111_5878# a_13566_5835# VSS.t63 sg13_lv_nmos ad=0.2373p pd=1.97u as=79.8f ps=0.8u w=0.42u l=0.13u
X571 a_15053_5990# a_14111_5878# a_14851_6228# VDD.t6 sg13_lv_pmos ad=93.45f pd=0.865u as=0.2048p ps=1.63u w=0.42u l=0.13u
X572 VDD.t183 MUX_SEL4 a_15765_463# VDD.t0 sg13_lv_pmos ad=0.3808p pd=2.92u as=0.3808p ps=2.92u w=1.12u l=0.13u
X573 a_19550_1044# a_3171_1047.t4 a_20968_1044# VSS.t322 sg13_lv_nmos ad=0.2516p pd=2.16u as=0.1406p ps=1.12u w=0.74u l=0.13u
X574 VSS.t46 DELAY_VBIASN a_10951_1842# VSS.t418 sg13_lv_nmos ad=0.2516p pd=2.16u as=0.1406p ps=1.12u w=0.74u l=0.6u
X575 a_19550_1044# a_19524_1008# a_19448_1044# VDD.t0 sg13_lv_pmos ad=0.3808p pd=2.92u as=0.2128p ps=1.5u w=1.12u l=0.13u
X576 a_7288_1044# a_6717_1842# VSS.t42 VSS.t41 sg13_lv_nmos ad=0.1406p pd=1.12u as=0.2516p ps=2.16u w=0.74u l=0.13u
X577 a_12355_5867# a_12158_5867# VSS.t53 VSS.t179 sg13_lv_nmos ad=0.2516p pd=2.16u as=0.1406p ps=1.12u w=0.74u l=0.13u
X578 VSS.t305 a_20723_1842# a_21157_1842# VSS.t451 sg13_lv_nmos ad=0.1406p pd=1.12u as=0.2516p ps=2.16u w=0.74u l=0.13u
X579 VDD.t172 a_14851_6228# a_15688_5867# VDD.t6 sg13_lv_pmos ad=0.2128p pd=1.5u as=0.3864p ps=2.93u w=1.12u l=0.13u
X580 a_1544_289# MUX_SEL3 VSS.t66 VSS.t65 sg13_lv_nmos ad=0.2516p pd=2.16u as=0.2516p ps=2.16u w=0.74u l=0.13u
X581 a_13470_1044# a_14311_1008# a_14235_1044# VDD.t0 sg13_lv_pmos ad=0.3808p pd=2.92u as=0.2128p ps=1.5u w=1.12u l=0.13u
X582 a_22590_1044# a_3747_1047.t3 a_24875_1044# VSS.t483 sg13_lv_nmos ad=0.2516p pd=2.16u as=0.1406p ps=1.12u w=0.74u l=0.13u
X583 VSS.t108 DELAY_VBIASN a_23871_1842# VSS.t366 sg13_lv_nmos ad=0.2516p pd=2.16u as=0.1406p ps=1.12u w=0.74u l=0.6u
X584 VDD.t241 a_2019_1047.t3 a_22564_1008# VDD.t0 sg13_lv_pmos ad=0.3808p pd=2.92u as=0.3808p ps=2.92u w=1.12u l=0.13u
X585 VSS.t519 a_25717_1842# a_26185_1044# VSS.t560 sg13_lv_nmos ad=0.1665p pd=1.19u as=0.2516p ps=2.16u w=0.74u l=0.13u
X586 a_13231_1842# a_12993_1842# a_13123_1842# VSS.t320 sg13_lv_nmos ad=0.1406p pd=1.12u as=0.2516p ps=2.16u w=0.74u l=0.2u
X587 VSS.t193 VDD.t407 VSS.t193 VSS.t195 sg13_lv_nmos ad=79.8f pd=0.8u as=0 ps=0 w=0.42u l=1u
X588 a_17791_2470# a_17553_1842# a_17683_1842# VDD.t2 sg13_lv_pmos ad=0.2128p pd=1.5u as=0.3808p ps=2.92u w=1.12u l=0.2u
X589 VSS.t252 a_4437_1842# a_4905_1044# VSS.t532 sg13_lv_nmos ad=0.1665p pd=1.19u as=0.2516p ps=2.16u w=0.74u l=0.13u
X590 VDD.t232 VSS.t233 VDD.t231 VDD.t0 sg13_lv_pmos ad=0.34p pd=2.68u as=0 ps=0 w=1u l=1u
X591 a_12233_1842# a_12037_1842# VSS.t417 VSS.t549 sg13_lv_nmos ad=0.2516p pd=2.16u as=0.1406p ps=1.12u w=0.74u l=0.13u
X592 VDD.t7 a_9547_6172# a_9547_5942# VDD.t6 sg13_lv_pmos ad=1.10612p pd=6.66u as=0.2442p ps=2.06u w=0.66u l=0.13u
X593 a_15108_5325# a_14851_5182# a_15270_5105# VSS.t566 sg13_lv_nmos ad=0.1428p pd=1.52u as=37.8f ps=0.6u w=0.42u l=0.13u
X594 VSS.t465 a_3449_1395# a_3747_1047.t1 VSS.t464 sg13_lv_nmos ad=0.2812p pd=2.24u as=0.1406p ps=1.12u w=0.74u l=0.13u
X595 VDD.t95 VSS.t211 VDD.t94 VDD.t0 sg13_lv_pmos ad=0.34p pd=2.68u as=0 ps=0 w=1u l=1u
X596 VDD.t227 VSS.t219 VDD.t205 VDD.t0 sg13_lv_pmos ad=0.19p pd=1.38u as=0 ps=0 w=1u l=1u
X597 VSS.t239 VDD.t394 VSS.t237 VSS.t238 sg13_lv_nmos ad=79.8f pd=0.8u as=0 ps=0 w=0.42u l=1u
X598 VSS.t91 a_3171_1047.t8 a_8884_1008# VSS.t90 sg13_lv_nmos ad=0.2516p pd=2.16u as=0.2516p ps=2.16u w=0.74u l=0.13u
X599 a_21591_2470# a_21353_1842# a_21483_1842# VDD.t2 sg13_lv_pmos ad=0.2128p pd=1.5u as=0.3808p ps=2.92u w=1.12u l=0.2u
X600 VDD.t92 a_2873_1395# a_3171_1047.t0 VDD.t0 sg13_lv_pmos ad=0.4256p pd=3u as=0.2128p ps=1.5u w=1.12u l=0.13u
X601 a_6153_1842# a_5957_1842# VDD.t191 VDD.t2 sg13_lv_pmos ad=0.3808p pd=2.92u as=0.2128p ps=1.5u w=1.12u l=0.13u
X602 VDD.t109 a_16163_1842# a_16597_1842# VDD.t2 sg13_lv_pmos ad=0.2128p pd=1.5u as=0.3808p ps=2.92u w=1.12u l=0.13u
X603 a_3543_1395# MUX_SEL0 a_3449_1395# VSS.t513 sg13_lv_nmos ad=0.1216p pd=1.02u as=0.2176p ps=1.96u w=0.64u l=0.13u
X604 VDD.t8 a_1544_1044# a_2297_1395# VDD.t0 sg13_lv_pmos ad=0.1918p pd=1.5u as=0.1596p ps=1.22u w=0.84u l=0.13u
X605 VDD.t307 DELAY_VBIASP a_10191_2470# VDD.t2 sg13_lv_pmos ad=0.3808p pd=2.92u as=0.2128p ps=1.5u w=1.12u l=0.6u
X606 a_17275_1044# a_17065_1044# VDD.t41 VDD.t0 sg13_lv_pmos ad=0.2128p pd=1.5u as=0.252p ps=1.57u w=1.12u l=0.13u
X607 a_2019_1047.t0 a_1721_1395# VDD.t125 VDD.t0 sg13_lv_pmos ad=0.2128p pd=1.5u as=0.1918p ps=1.5u w=1.12u l=0.13u
X608 a_27915_1044# a_27705_1044# VSS.t256 VSS.t255 sg13_lv_nmos ad=0.1406p pd=1.12u as=0.1665p ps=1.19u w=0.74u l=0.13u
X609 VSS.t48 DELAY_VBIASN a_26151_1842# VSS.t363 sg13_lv_nmos ad=0.2516p pd=2.16u as=0.1406p ps=1.12u w=0.74u l=0.6u
X610 VDD.t290 a_3747_1047.t6 a_15831_1008# VDD.t0 sg13_lv_pmos ad=0.3808p pd=2.92u as=0.3808p ps=2.92u w=1.12u l=0.13u
X611 VDD.t265 a_19963_1842# a_20397_1842# VDD.t2 sg13_lv_pmos ad=0.2128p pd=1.5u as=0.3808p ps=2.92u w=1.12u l=0.13u
X612 VSS.t241 VDD.t393 VSS.t241 VSS.t240 sg13_lv_nmos ad=0.1428p pd=1.52u as=0 ps=0 w=0.42u l=1u
X613 VSS.t7 DELAY_VBIASN a_4871_1842# VSS.t410 sg13_lv_nmos ad=0.2516p pd=2.16u as=0.1406p ps=1.12u w=0.74u l=0.6u
X614 a_14888_1044# a_14317_1842# VDD.t123 VDD.t0 sg13_lv_pmos ad=0.2128p pd=1.5u as=0.3808p ps=2.92u w=1.12u l=0.13u
X615 a_4350_1044# a_4324_1008# a_4248_1044# VDD.t0 sg13_lv_pmos ad=0.3808p pd=2.92u as=0.2128p ps=1.5u w=1.12u l=0.13u
X616 a_1256_289# MUX_SEL2 VDD.t103 VDD.t0 sg13_lv_pmos ad=0.3808p pd=2.92u as=0.3808p ps=2.92u w=1.12u l=0.13u
X617 VSS.t611 VSS.t608 VSS.t610 VSS.t609 sg13_lv_nmos ad=0.2516p pd=2.16u as=0 ps=0 w=0.74u l=0.6u
X618 a_16108_289# a_15765_463# a_15964_289# VDD.t0 sg13_lv_pmos ad=0.3808p pd=2.92u as=0.3304p ps=1.71u w=1.12u l=0.13u
X619 VDD.t217 a_12849_5867# a_13566_5835# VDD.t6 sg13_lv_pmos ad=0.1563p pd=1.22u as=0.147p ps=1.54u w=0.42u l=0.13u
X620 VSS.t379 DELAY_VBIASN VSS.t378 VSS.t377 sg13_lv_nmos ad=2.38p pd=14.68u as=0 ps=0 w=7u l=7u
X621 a_11473_1842# a_11277_1842# VDD.t46 VDD.t2 sg13_lv_pmos ad=0.3808p pd=2.92u as=0.2128p ps=1.5u w=1.12u l=0.13u
X622 VDD.t53 a_8997_1842# a_9465_1044# VDD.t0 sg13_lv_pmos ad=0.252p pd=1.57u as=0.3808p ps=2.92u w=1.12u l=0.13u
X623 a_27433_1842# a_27237_1842# VSS.t38 VSS.t457 sg13_lv_nmos ad=0.2516p pd=2.16u as=0.1406p ps=1.12u w=0.74u l=0.13u
X624 a_2391_331# MUX_SEL2 a_2297_331# VSS.t122 sg13_lv_nmos ad=0.1216p pd=1.02u as=0.2176p ps=1.96u w=0.64u l=0.13u
X625 a_2967_331# MUX_SEL3 a_2873_331# VSS.t67 sg13_lv_nmos ad=0.1216p pd=1.02u as=0.2176p ps=1.96u w=0.64u l=0.13u
X626 VDD.t213 a_2019_1047.t5 a_16484_1008# VDD.t0 sg13_lv_pmos ad=0.3808p pd=2.92u as=0.3808p ps=2.92u w=1.12u l=0.13u
X627 a_7390_1044# a_2595_1047.t8 a_8155_1044# VSS.t334 sg13_lv_nmos ad=0.2516p pd=2.16u as=0.1406p ps=1.12u w=0.74u l=0.13u
X628 VSS.t131 a_6126_3816# a_5974_5723# VSS.t127 sg13_lv_nmos ad=0.68p pd=4.68u as=0.38p ps=2.38u w=2u l=1u
X629 VSS.t412 DELAY_VBIASN a_7151_1842# VSS.t411 sg13_lv_nmos ad=0.2516p pd=2.16u as=0.1406p ps=1.12u w=0.74u l=0.6u
X630 VDD.t61 a_3171_1047.t9 a_5844_1008# VDD.t0 sg13_lv_pmos ad=0.3808p pd=2.92u as=0.3808p ps=2.92u w=1.12u l=0.13u
X631 VDD.t302 DELAY_VBIASP a_25391_2470# VDD.t2 sg13_lv_pmos ad=0.3808p pd=2.92u as=0.2128p ps=1.5u w=1.12u l=0.6u
X632 VDD.t76 a_2595_1047.t7 a_11271_1008# VDD.t0 sg13_lv_pmos ad=0.3808p pd=2.92u as=0.3808p ps=2.92u w=1.12u l=0.13u
X633 VDD.t102 VSS.t203 VDD.t100 VDD.t0 sg13_lv_pmos ad=0.19p pd=1.38u as=0 ps=0 w=1u l=1u
X634 VSS.t548 a_12037_1842# a_12505_1044# VSS.t547 sg13_lv_nmos ad=0.1665p pd=1.19u as=0.2516p ps=2.16u w=0.74u l=0.13u
X635 VDD.t73 a_3747_1047.t8 a_9751_1008# VDD.t0 sg13_lv_pmos ad=0.3808p pd=2.92u as=0.3808p ps=2.92u w=1.12u l=0.13u
X636 a_12943_5867# a_13121_5831# VDD.t49 VDD.t6 sg13_lv_pmos ad=0.3808p pd=2.92u as=0.2128p ps=1.5u w=1.12u l=0.13u
X637 a_11748_6109# a_11491_6228# a_11910_6305# VSS.t246 sg13_lv_nmos ad=0.1428p pd=1.52u as=37.8f ps=0.6u w=0.42u l=0.13u
X638 a_9431_1842# a_9193_1842# a_9323_1842# VSS.t281 sg13_lv_nmos ad=0.1406p pd=1.12u as=0.2516p ps=2.16u w=0.74u l=0.2u
X639 a_18313_1842# a_18117_1842# VSS.t272 VSS.t574 sg13_lv_nmos ad=0.2516p pd=2.16u as=0.1406p ps=1.12u w=0.74u l=0.13u
X640 MUX_OUT a_16851_309# VSS.t278 VSS.t435 sg13_lv_nmos ad=0.1406p pd=1.12u as=0.1371p ps=1.12u w=0.74u l=0.13u
X641 a_10232_5871# a_10206_5835# VDD.t170 VDD.t6 sg13_lv_pmos ad=0.34p pd=2.68u as=0.36237p ps=2.605u w=1u l=0.13u
X642 a_14851_5182# a_14009_5084# a_14757_5182# VSS.t494 sg13_lv_nmos ad=0.12665p pd=1.145u as=0.1428p ps=1.52u w=0.42u l=0.13u
X643 VSS.t233 VDD.t395 VSS.t233 VSS.t235 sg13_lv_nmos ad=79.8f pd=0.8u as=0 ps=0 w=0.42u l=1u
X644 a_23871_1842# a_23633_1842# a_23763_1842# VSS.t296 sg13_lv_nmos ad=0.1406p pd=1.12u as=0.2516p ps=2.16u w=0.74u l=0.2u
X645 a_8433_1842# a_8237_1842# VSS.t415 VSS.t620 sg13_lv_nmos ad=0.2516p pd=2.16u as=0.1406p ps=1.12u w=0.74u l=0.13u
X646 VSS.t62 a_18443_1842# a_18877_1842# VSS.t61 sg13_lv_nmos ad=0.1406p pd=1.12u as=0.2516p ps=2.16u w=0.74u l=0.13u
X647 VSS.t166 VDD.t402 VSS.t211 VSS.t212 sg13_lv_nmos ad=79.8f pd=0.8u as=0 ps=0 w=0.42u l=1u
X648 VSS.t129 a_6126_3816# a_5974_5723# VSS.t127 sg13_lv_nmos ad=0.68p pd=4.68u as=0.38p ps=2.38u w=2u l=1u
X649 a_22113_1842# a_21917_1842# VSS.t32 VSS.t31 sg13_lv_nmos ad=0.2516p pd=2.16u as=0.1406p ps=1.12u w=0.74u l=0.13u
X650 a_1544_289# MUX_SEL3 VDD.t57 VDD.t0 sg13_lv_pmos ad=0.3808p pd=2.92u as=0.3808p ps=2.92u w=1.12u l=0.13u
X651 VDD.t36 VDD.t137 VDD.t144 VDD.t6 sg13_lv_pmos ad=0.38p pd=2.38u as=0 ps=0 w=2u l=1u
X652 a_26673_1842# a_26477_1842# VDD.t47 VDD.t2 sg13_lv_pmos ad=0.3808p pd=2.92u as=0.2128p ps=1.5u w=1.12u l=0.13u
X653 a_10328_1044# a_9757_1842# VSS.t97 VSS.t98 sg13_lv_nmos ad=0.1406p pd=1.12u as=0.2516p ps=2.16u w=0.74u l=0.13u
X654 VSS.t166 VDD.t401 VSS.t166 VSS.t213 sg13_lv_nmos ad=0.1428p pd=1.52u as=0 ps=0 w=0.42u l=1u
X655 a_22590_1044# a_2019_1047.t3 a_22488_1044# VSS.t340 sg13_lv_nmos ad=0.2516p pd=2.16u as=0.1406p ps=1.12u w=0.74u l=0.13u
X656 VSS.t299 DELAY_VBIASN a_12471_1842# VSS.t420 sg13_lv_nmos ad=0.2516p pd=2.16u as=0.1406p ps=1.12u w=0.74u l=0.6u
X657 a_8808_1044# a_8237_1842# VSS.t336 VSS.t621 sg13_lv_nmos ad=0.1406p pd=1.12u as=0.2516p ps=2.16u w=0.74u l=0.13u
X658 VSS.t27 a_22243_1842# a_22677_1842# VSS.t26 sg13_lv_nmos ad=0.1406p pd=1.12u as=0.2516p ps=2.16u w=0.74u l=0.13u
X659 VDD.t301 DELAY_VBIASP a_6391_2470# VDD.t2 sg13_lv_pmos ad=0.3808p pd=2.92u as=0.2128p ps=1.5u w=1.12u l=0.6u
X660 a_13470_1044# a_15831_1008# a_15755_1044# VDD.t0 sg13_lv_pmos ad=0.3808p pd=2.92u as=0.2128p ps=1.5u w=1.12u l=0.13u
X661 a_1544_1044# MUX_SEL1 VDD.t338 VDD.t0 sg13_lv_pmos ad=0.3808p pd=2.92u as=0.3808p ps=2.92u w=1.12u l=0.13u
X662 VDD.t309 DELAY_VBIASP a_20831_2470# VDD.t2 sg13_lv_pmos ad=0.3808p pd=2.92u as=0.2128p ps=1.5u w=1.12u l=0.6u
X663 VDD.t20 a_2595_1047.t2 a_26471_1008# VDD.t0 sg13_lv_pmos ad=0.3808p pd=2.92u as=0.3808p ps=2.92u w=1.12u l=0.13u
X664 a_4350_1044# a_5191_1008# a_5115_1044# VDD.t0 sg13_lv_pmos ad=0.3808p pd=2.92u as=0.2128p ps=1.5u w=1.12u l=0.13u
X665 VDD.t41 a_16597_1842# a_17065_1044# VDD.t0 sg13_lv_pmos ad=0.252p pd=1.57u as=0.3808p ps=2.92u w=1.12u l=0.13u
X666 VSS.t256 a_27237_1842# a_27705_1044# VSS.t456 sg13_lv_nmos ad=0.1665p pd=1.19u as=0.2516p ps=2.16u w=0.74u l=0.13u
X667 VSS.t378 DELAY_VBIASN VSS.t381 VSS.t380 sg13_lv_nmos ad=1.33p pd=7.38u as=0 ps=0 w=7u l=7u
X668 a_10191_2470# a_9953_1842# a_10083_1842# VDD.t2 sg13_lv_pmos ad=0.2128p pd=1.5u as=0.3808p ps=2.92u w=1.12u l=0.2u
X669 a_2595_1047.t1 a_2297_1395# VSS.t12 VSS.t11 sg13_lv_nmos ad=0.1406p pd=1.12u as=0.1331p ps=1.12u w=0.74u l=0.13u
X670 a_26151_1842# a_25913_1842# a_26043_1842# VSS.t83 sg13_lv_nmos ad=0.1406p pd=1.12u as=0.2516p ps=2.16u w=0.74u l=0.2u
X671 VSS.t216 a_2019_311# a_17865_519# VSS.t270 sg13_lv_nmos ad=0.2516p pd=2.16u as=0.2516p ps=2.16u w=0.74u l=0.13u
X672 VSS.t106 a_1544_289# a_2391_331# VSS.t577 sg13_lv_nmos ad=0.1331p pd=1.12u as=0.1216p ps=1.02u w=0.64u l=0.13u
X673 a_4871_1842# a_4633_1842# a_4763_1842# VSS.t262 sg13_lv_nmos ad=0.1406p pd=1.12u as=0.2516p ps=2.16u w=0.74u l=0.2u
X674 a_13753_1842# a_13557_1842# VSS.t5 VSS.t4 sg13_lv_nmos ad=0.2516p pd=2.16u as=0.1406p ps=1.12u w=0.74u l=0.13u
X675 a_1815_1395# a_1256_1044# a_1721_1395# VSS.t182 sg13_lv_nmos ad=0.1216p pd=1.02u as=0.2176p ps=1.96u w=0.64u l=0.13u
X676 a_7673_1842# a_7477_1842# VDD.t272 VDD.t2 sg13_lv_pmos ad=0.3808p pd=2.92u as=0.2128p ps=1.5u w=1.12u l=0.13u
X677 VDD.t205 VSS.t216 VDD.t204 VDD.t0 sg13_lv_pmos ad=0.34p pd=2.68u as=0 ps=0 w=1u l=1u
X678 a_1721_331# a_1256_289# VDD.t77 VDD.t0 sg13_lv_pmos ad=0.1596p pd=1.22u as=0.2856p ps=2.36u w=0.84u l=0.13u
X679 VSS.t365 a_24523_1842# a_24957_1842# VSS.t496 sg13_lv_nmos ad=0.1406p pd=1.12u as=0.2516p ps=2.16u w=0.74u l=0.13u
X680 a_6635_1044# a_6425_1044# VSS.t553 VSS.t557 sg13_lv_nmos ad=0.1406p pd=1.12u as=0.1665p ps=1.19u w=0.74u l=0.13u
X681 VDD.t7 a_15108_5325# a_15053_5420# VDD.t6 sg13_lv_pmos ad=1.10612p pd=6.66u as=93.45f ps=0.865u w=0.42u l=0.13u
X682 VSS.t82 a_2595_1047.t9 a_5191_1008# VSS.t81 sg13_lv_nmos ad=0.2516p pd=2.16u as=0.2516p ps=2.16u w=0.74u l=0.13u
X683 a_20315_1044# a_20105_1044# VSS.t280 VSS.t279 sg13_lv_nmos ad=0.1406p pd=1.12u as=0.1665p ps=1.19u w=0.74u l=0.13u
X684 VDD.t321 DELAY_VBIASP a_11711_2470# VDD.t2 sg13_lv_pmos ad=0.3808p pd=2.92u as=0.2128p ps=1.5u w=1.12u l=0.6u
X685 a_18795_1044# a_18585_1044# VDD.t107 VDD.t0 sg13_lv_pmos ad=0.2128p pd=1.5u as=0.252p ps=1.57u w=1.12u l=0.13u
X686 a_25528_1044# a_24957_1842# VSS.t485 VSS.t554 sg13_lv_nmos ad=0.1406p pd=1.12u as=0.2516p ps=2.16u w=0.74u l=0.13u
X687 a_5778_3367# a_6126_3816# a_6326_4590# VSS.t124 sg13_lv_nmos ad=0.68p pd=4.68u as=0.38p ps=2.38u w=2u l=1u
X688 VSS.t403 DELAY_VBIASN VSS.t401 VSS.t386 sg13_lv_nmos ad=1.33p pd=7.38u as=0 ps=0 w=7u l=7u
X689 VSS.t432 DELAY_VBIASN a_27671_1842# VSS.t431 sg13_lv_nmos ad=0.2516p pd=2.16u as=0.1406p ps=1.12u w=0.74u l=0.6u
X690 a_5731_289# a_3747_311.t3 a_13470_1044# VSS.t164 sg13_lv_nmos ad=0.2516p pd=2.16u as=0.2516p ps=2.16u w=0.74u l=0.13u
X691 a_25630_1044# a_27124_1008# a_27048_1044# VDD.t0 sg13_lv_pmos ad=0.3808p pd=2.92u as=0.2128p ps=1.5u w=1.12u l=0.13u
X692 VDD.t238 a_2595_1047.t5 a_17351_1008# VDD.t0 sg13_lv_pmos ad=0.3808p pd=2.92u as=0.3808p ps=2.92u w=1.12u l=0.13u
X693 VSS.t54 a_13121_5831# a_6854_5986# VDD.t50 sg13_lv_pmos ad=0.232p pd=2.08u as=0.136p ps=1.14u w=0.4u l=0.2u
X694 VDD.t39 a_21483_1842# a_21917_1842# VDD.t2 sg13_lv_pmos ad=0.2128p pd=1.5u as=0.3808p ps=2.92u w=1.12u l=0.13u
X695 a_4350_1044# a_5844_1008# a_5768_1044# VDD.t0 sg13_lv_pmos ad=0.3808p pd=2.92u as=0.2128p ps=1.5u w=1.12u l=0.13u
X696 VSS.t278 a_16851_309# MUX_OUT VSS.t436 sg13_lv_nmos ad=0.2516p pd=2.16u as=0.1406p ps=1.12u w=0.74u l=0.13u
X697 VSS.t186 a_2019_311# a_5705_519# VSS.t268 sg13_lv_nmos ad=0.2516p pd=2.16u as=0.2516p ps=2.16u w=0.74u l=0.13u
X698 VDD.t117 a_1544_289# a_1721_331# VDD.t0 sg13_lv_pmos ad=0.1918p pd=1.5u as=0.1596p ps=1.22u w=0.84u l=0.13u
X699 a_7151_1842# a_6913_1842# a_7043_1842# VSS.t136 sg13_lv_nmos ad=0.1406p pd=1.12u as=0.2516p ps=2.16u w=0.74u l=0.2u
X700 a_16033_1842# a_15837_1842# VSS.t370 VSS.t439 sg13_lv_nmos ad=0.2516p pd=2.16u as=0.1406p ps=1.12u w=0.74u l=0.13u
X701 a_10649_5878# REF_CLK VSS.t448 VSS.t447 sg13_lv_nmos ad=0.2516p pd=2.16u as=1.9998p ps=12.915u w=0.74u l=0.13u
X702 VDD.t7 a_11748_6109# a_11693_5990# VDD.t6 sg13_lv_pmos ad=1.10612p pd=6.66u as=93.45f ps=0.865u w=0.42u l=0.13u
X703 MUX_OUT a_16851_309# VDD.t251 VDD.t0 sg13_lv_pmos ad=0.2128p pd=1.5u as=0.2086p ps=1.5u w=1.12u l=0.13u
X704 a_25391_2470# a_25153_1842# a_25283_1842# VDD.t2 sg13_lv_pmos ad=0.2128p pd=1.5u as=0.3808p ps=2.92u w=1.12u l=0.2u
X705 VDD.t196 VSS.t155 VDD.t195 VDD.t0 sg13_lv_pmos ad=0.34p pd=2.68u as=0 ps=0 w=1u l=1u
X706 a_12993_1842# a_12797_1842# VDD.t197 VDD.t2 sg13_lv_pmos ad=0.3808p pd=2.92u as=0.2128p ps=1.5u w=1.12u l=0.13u
X707 a_16408_1044# a_15837_1842# VSS.t438 VSS.t437 sg13_lv_nmos ad=0.1406p pd=1.12u as=0.2516p ps=2.16u w=0.74u l=0.13u
X708 a_5778_3367# a_6126_3816# a_6326_4590# VSS.t124 sg13_lv_nmos ad=0.68p pd=4.68u as=0.38p ps=2.38u w=2u l=1u
X709 VSS.t295 a_5523_1842# a_5957_1842# VSS.t294 sg13_lv_nmos ad=0.1406p pd=1.12u as=0.2516p ps=2.16u w=0.74u l=0.13u
X710 VDD.t315 DELAY_VBIASP a_13991_2470# VDD.t2 sg13_lv_pmos ad=0.3808p pd=2.92u as=0.2128p ps=1.5u w=1.12u l=0.6u
X711 a_5731_289# a_2019_311# a_4350_1044# VSS.t267 sg13_lv_nmos ad=0.2516p pd=2.16u as=0.2516p ps=2.16u w=0.74u l=0.13u
X712 VSS.t10 a_9547_6172# a_9547_6172# VSS.t9 sg13_lv_nmos ad=2.39977p pd=15.495u as=0.111p ps=1.34u w=0.3u l=0.13u
X713 a_9444_3912# a_6854_5454# a_9712_3912# VSS.t258 sg13_lv_nmos ad=0.68p pd=4.68u as=0.38p ps=2.38u w=2u l=1u
X714 VSS.t409 DELAY_VBIASN VSS.t407 VSS.t392 sg13_lv_nmos ad=1.33p pd=7.38u as=0 ps=0 w=7u l=7u
X715 a_7390_1044# a_3747_1047.t8 a_9675_1044# VSS.t95 sg13_lv_nmos ad=0.2516p pd=2.16u as=0.1406p ps=1.12u w=0.74u l=0.13u
X716 VDD.t79 a_23763_1842# a_24197_1842# VDD.t2 sg13_lv_pmos ad=0.2128p pd=1.5u as=0.3808p ps=2.92u w=1.12u l=0.13u
X717 VSS.t58 DELAY_VBIASN a_8671_1842# VSS.t359 sg13_lv_nmos ad=0.2516p pd=2.16u as=0.1406p ps=1.12u w=0.74u l=0.6u
X718 VDD.t12 a_2019_1047.t8 a_7364_1008# VDD.t0 sg13_lv_pmos ad=0.3808p pd=2.92u as=0.3808p ps=2.92u w=1.12u l=0.13u
X719 VDD.t329 DELAY_VBIASP a_26911_2470# VDD.t2 sg13_lv_pmos ad=0.3808p pd=2.92u as=0.2128p ps=1.5u w=1.12u l=0.6u
X720 VSS.t56 a_14009_5084# a_14111_5227# VSS.t493 sg13_lv_nmos ad=1.45407p pd=9.445u as=0.2516p ps=2.16u w=0.74u l=0.13u
X721 VDD.t19 VSS.t243 VDD.t17 VDD.t0 sg13_lv_pmos ad=0.19p pd=1.38u as=0 ps=0 w=1u l=1u
X722 a_12471_1842# a_12233_1842# a_12363_1842# VSS.t624 sg13_lv_nmos ad=0.1406p pd=1.12u as=0.2516p ps=2.16u w=0.74u l=0.2u
X723 a_22488_1044# a_21917_1842# VDD.t40 VDD.t0 sg13_lv_pmos ad=0.2128p pd=1.5u as=0.3808p ps=2.92u w=1.12u l=0.13u
X724 VDD.t114 a_2595_311.t3 a_8745_519# VDD.t0 sg13_lv_pmos ad=0.3808p pd=2.92u as=0.3808p ps=2.92u w=1.12u l=0.13u
X725 VSS.t275 a_3171_1047.t5 a_18004_1008# VSS.t274 sg13_lv_nmos ad=0.2516p pd=2.16u as=0.2516p ps=2.16u w=0.74u l=0.13u
X726 a_6391_2470# a_6153_1842# a_6283_1842# VDD.t2 sg13_lv_pmos ad=0.2128p pd=1.5u as=0.3808p ps=2.92u w=1.12u l=0.2u
X727 a_15273_1842# a_15077_1842# VDD.t277 VDD.t2 sg13_lv_pmos ad=0.3808p pd=2.92u as=0.2128p ps=1.5u w=1.12u l=0.13u
X728 a_14235_1044# a_14025_1044# VSS.t1 VSS.t0 sg13_lv_nmos ad=0.1406p pd=1.12u as=0.1665p ps=1.19u w=0.74u l=0.13u
X729 a_6326_4590# a_6126_3816# a_5778_3367# VSS.t124 sg13_lv_nmos ad=0.42p pd=2.42u as=0.68p ps=4.68u w=2u l=1u
X730 VSS.t86 a_3747_1047.t7 a_12791_1008# VSS.t85 sg13_lv_nmos ad=0.2516p pd=2.16u as=0.2516p ps=2.16u w=0.74u l=0.13u
X731 VSS.t592 VSS.t589 VSS.t591 VSS.t590 sg13_lv_nmos ad=0.2516p pd=2.16u as=0 ps=0 w=0.74u l=0.13u
X732 a_9953_1842# a_9757_1842# VSS.t100 VSS.t99 sg13_lv_nmos ad=0.2516p pd=2.16u as=0.1406p ps=1.12u w=0.74u l=0.13u
X733 VSS.t46 a_10843_1842# a_11277_1842# VSS.t491 sg13_lv_nmos ad=0.1406p pd=1.12u as=0.2516p ps=2.16u w=0.74u l=0.13u
X734 VSS.t233 VDD.t395 VSS.t233 VSS.t234 sg13_lv_nmos ad=0.1428p pd=1.52u as=0 ps=0 w=0.42u l=1u
X735 a_10649_5878# REF_CLK VDD.t7 VDD.t6 sg13_lv_pmos ad=0.4088p pd=2.97u as=1.03698p ps=6.245u w=1.12u l=0.13u
X736 VDD.t254 a_15403_1842# a_15837_1842# VDD.t2 sg13_lv_pmos ad=0.2128p pd=1.5u as=0.3808p ps=2.92u w=1.12u l=0.13u
X737 VDD.t7 a_14009_5084# a_14111_5227# VDD.t6 sg13_lv_pmos ad=1.10612p pd=6.66u as=0.3864p ps=2.93u w=1.12u l=0.13u
X738 VSS.t211 VDD.t402 VSS.t211 VSS.t210 sg13_lv_nmos ad=0.1428p pd=1.52u as=0 ps=0 w=0.42u l=1u
X739 a_11848_1044# a_11277_1842# VSS.t44 VSS.t43 sg13_lv_nmos ad=0.1406p pd=1.12u as=0.2516p ps=2.16u w=0.74u l=0.13u
X740 a_6326_4590# a_6326_4590# VDD.t32 VDD.t6 sg13_lv_pmos ad=0.38p pd=2.38u as=0.38p ps=2.38u w=2u l=1u
X741 VDD.t5 a_4763_1842# a_5197_1842# VDD.t2 sg13_lv_pmos ad=0.2128p pd=1.5u as=0.3808p ps=2.92u w=1.12u l=0.13u
X742 VSS.t219 VDD.t400 VSS.t217 VSS.t218 sg13_lv_nmos ad=79.8f pd=0.8u as=0 ps=0 w=0.42u l=1u
X743 a_13470_1044# a_13444_1008# a_13368_1044# VDD.t0 sg13_lv_pmos ad=0.3808p pd=2.92u as=0.2128p ps=1.5u w=1.12u l=0.13u
X744 VDD.t279 a_3449_1395# a_3747_1047.t0 VDD.t0 sg13_lv_pmos ad=0.4256p pd=3u as=0.2128p ps=1.5u w=1.12u l=0.13u
X745 VSS.t601 VSS.t598 VSS.t598 VSS.t599 sg13_lv_nmos ad=0.1406p pd=1.12u as=0 ps=0 w=0.74u l=0.13u
X746 VDD.t356 a_3171_1047.t3 a_24084_1008# VDD.t0 sg13_lv_pmos ad=0.3808p pd=2.92u as=0.3808p ps=2.92u w=1.12u l=0.13u
X747 a_3449_1395# MUX_SEL0 VDD.t336 VDD.t0 sg13_lv_pmos ad=0.1596p pd=1.22u as=0.2856p ps=2.36u w=0.84u l=0.13u
X748 a_15464_3684# a_14851_5182# VDD.t375 VDD.t6 sg13_lv_pmos ad=0.4312p pd=3.01u as=0.2639p ps=1.81u w=1.12u l=0.13u
X749 a_5974_5723# a_6126_3816# VSS.t128 VSS.t127 sg13_lv_nmos ad=0.38p pd=2.38u as=0.68p ps=4.68u w=2u l=1u
X750 VDD.t310 DELAY_VBIASP a_7911_2470# VDD.t2 sg13_lv_pmos ad=0.3808p pd=2.92u as=0.2128p ps=1.5u w=1.12u l=0.6u
X751 VDD.t86 VSS.t193 VDD.t85 VDD.t0 sg13_lv_pmos ad=0.19p pd=1.38u as=0 ps=0 w=1u l=1u
X752 VDD.t36 a_6326_4590# a_6854_5986# VDD.t6 sg13_lv_pmos ad=0.38p pd=2.38u as=0.38p ps=2.38u w=2u l=1u
X753 a_10206_5835# a_10649_5878# a_9946_6305# VSS.t471 sg13_lv_nmos ad=79.8f pd=0.8u as=0.1296p ps=1.52u w=0.42u l=0.13u
X754 VDD.t88 VSS.t193 VDD.t87 VDD.t0 sg13_lv_pmos ad=0.34p pd=2.68u as=0 ps=0 w=1u l=1u
X755 a_9946_6305# a_9772_5843# VDD.t264 VDD.t6 sg13_lv_pmos ad=79.8f pd=0.8u as=0.1428p ps=1.52u w=0.42u l=0.13u
X756 a_9946_6305# a_10751_5878# a_10206_5835# VDD.t6 sg13_lv_pmos ad=0.1428p pd=1.52u as=79.8f ps=0.8u w=0.42u l=0.13u
X757 VDD.t252 a_16851_309# MUX_OUT VDD.t0 sg13_lv_pmos ad=0.7336p pd=3.55u as=0.2128p ps=1.5u w=1.12u l=0.13u
X758 VSS.t71 a_3171_311.t2 a_23945_519# VSS.t70 sg13_lv_nmos ad=0.2516p pd=2.16u as=0.2516p ps=2.16u w=0.74u l=0.13u
X759 VDD.t107 a_18117_1842# a_18585_1044# VDD.t0 sg13_lv_pmos ad=0.252p pd=1.57u as=0.3808p ps=2.92u w=1.12u l=0.13u
X760 VSS.t280 a_19637_1842# a_20105_1044# VSS.t479 sg13_lv_nmos ad=0.1665p pd=1.19u as=0.2516p ps=2.16u w=0.74u l=0.13u
X761 a_11711_2470# a_11473_1842# a_11603_1842# VDD.t2 sg13_lv_pmos ad=0.2128p pd=1.5u as=0.3808p ps=2.92u w=1.12u l=0.2u
X762 a_27671_1842# a_27433_1842# a_27563_1842# VSS.t301 sg13_lv_nmos ad=0.1406p pd=1.12u as=0.2516p ps=2.16u w=0.74u l=0.2u
X763 VSS.t278 MUX_SEL4 a_15765_463# VSS.t277 sg13_lv_nmos ad=0.2516p pd=2.16u as=0.2516p ps=2.16u w=0.74u l=0.13u
X764 a_5731_289# a_14825_519# a_13470_1044# VDD.t0 sg13_lv_pmos ad=0.3808p pd=2.92u as=0.3808p ps=2.92u w=1.12u l=0.13u
X765 a_16510_1044# a_2595_1047.t5 a_17275_1044# VSS.t331 sg13_lv_nmos ad=0.2516p pd=2.16u as=0.1406p ps=1.12u w=0.74u l=0.13u
X766 a_13045_6215# a_13019_5831# a_12849_5867# VSS.t466 sg13_lv_nmos ad=0.1406p pd=1.12u as=0.1406p ps=1.12u w=0.74u l=0.13u
X767 VSS.t142 DELAY_VBIASN a_16271_1842# VSS.t374 sg13_lv_nmos ad=0.2516p pd=2.16u as=0.1406p ps=1.12u w=0.74u l=0.6u
X768 VDD.t68 VSS.t71 VDD.t67 VDD.t0 sg13_lv_pmos ad=0.34p pd=2.68u as=0 ps=0 w=1u l=1u
X769 VDD.t355 a_3171_1047.t6 a_14964_1008# VDD.t0 sg13_lv_pmos ad=0.3808p pd=2.92u as=0.3808p ps=2.92u w=1.12u l=0.13u
X770 VDD.t84 a_10083_1842# a_10517_1842# VDD.t2 sg13_lv_pmos ad=0.2128p pd=1.5u as=0.3808p ps=2.92u w=1.12u l=0.13u
X771 VSS.t286 a_3747_1047.t2 a_27991_1008# VSS.t285 sg13_lv_nmos ad=0.2516p pd=2.16u as=0.2516p ps=2.16u w=0.74u l=0.13u
X772 a_9712_3912# a_13019_5831# DELAY_VBIASN VSS.t467 sg13_lv_nmos ad=0.136p pd=1.14u as=0.232p ps=2.08u w=0.4u l=0.2u
X773 VSS.t48 a_26043_1842# a_26477_1842# VSS.t184 sg13_lv_nmos ad=0.1406p pd=1.12u as=0.2516p ps=2.16u w=0.74u l=0.13u
X774 VSS.t135 a_6126_3816# a_5974_5723# VSS.t127 sg13_lv_nmos ad=0.68p pd=4.68u as=0.38p ps=2.38u w=2u l=1u
X775 a_11195_1044# a_10985_1044# VDD.t83 VDD.t0 sg13_lv_pmos ad=0.2128p pd=1.5u as=0.252p ps=1.57u w=1.12u l=0.13u
X776 VSS.t42 a_3747_1047.t9 a_6711_1008# VSS.t283 sg13_lv_nmos ad=0.2516p pd=2.16u as=0.2516p ps=2.16u w=0.74u l=0.13u
X777 a_9444_4590# a_6854_5454# a_6854_5454# VSS.t258 sg13_lv_nmos ad=0.68p pd=4.68u as=0.38p ps=2.38u w=2u l=1u
X778 a_16108_289# a_2595_311.t2 a_19550_1044# VSS.t156 sg13_lv_nmos ad=0.2516p pd=2.16u as=0.2516p ps=2.16u w=0.74u l=0.13u
X779 VSS.t425 DELAY_VBIASN a_20071_1842# VSS.t424 sg13_lv_nmos ad=0.2516p pd=2.16u as=0.1406p ps=1.12u w=0.74u l=0.6u
X780 VDD.t327 DELAY_VBIASP a_24631_2470# VDD.t2 sg13_lv_pmos ad=0.3808p pd=2.92u as=0.2128p ps=1.5u w=1.12u l=0.6u
X781 a_22590_1044# a_23431_1008# a_23355_1044# VDD.t0 sg13_lv_pmos ad=0.3808p pd=2.92u as=0.2128p ps=1.5u w=1.12u l=0.13u
X782 VSS.t203 VDD.t404 VSS.t203 VSS.t205 sg13_lv_nmos ad=79.8f pd=0.8u as=0 ps=0 w=0.42u l=1u
X783 a_10458_6292# DLL_RESETN VSS.t248 VSS.t249 sg13_lv_nmos ad=37.8f pd=0.6u as=0.1701p ps=1.65u w=0.42u l=0.13u
X784 a_11491_6228# a_10649_5878# a_10232_5871# VDD.t6 sg13_lv_pmos ad=0.2048p pd=1.63u as=0.34p ps=2.68u w=1u l=0.13u
X785 VSS.t133 a_6126_3816# a_5974_5723# VSS.t127 sg13_lv_nmos ad=0.76p pd=4.76u as=0.38p ps=2.38u w=2u l=1u
X786 a_8671_1842# a_8433_1842# a_8563_1842# VSS.t180 sg13_lv_nmos ad=0.1406p pd=1.12u as=0.2516p ps=2.16u w=0.74u l=0.2u
X787 a_17553_1842# a_17357_1842# VSS.t308 VSS.t618 sg13_lv_nmos ad=0.2516p pd=2.16u as=0.1406p ps=1.12u w=0.74u l=0.13u
X788 a_5731_289# a_5705_519# a_4350_1044# VDD.t0 sg13_lv_pmos ad=0.3808p pd=2.92u as=0.3808p ps=2.92u w=1.12u l=0.13u
X789 VDD.t157 VDD.t155 VDD.t156 VDD.t2 sg13_lv_pmos ad=0.3808p pd=2.92u as=0 ps=0 w=1.12u l=0.13u
X790 a_26911_2470# a_26673_1842# a_26803_1842# VDD.t2 sg13_lv_pmos ad=0.2128p pd=1.5u as=0.3808p ps=2.92u w=1.12u l=0.2u
X791 a_7390_1044# a_2019_1047.t8 a_7288_1044# VSS.t17 sg13_lv_nmos ad=0.2516p pd=2.16u as=0.1406p ps=1.12u w=0.74u l=0.13u
X792 a_13566_5328# a_14009_5084# a_13306_5105# VSS.t492 sg13_lv_nmos ad=79.8f pd=0.8u as=0.1296p ps=1.52u w=0.42u l=0.13u
X793 a_21353_1842# a_21157_1842# VSS.t305 VSS.t304 sg13_lv_nmos ad=0.2516p pd=2.16u as=0.1406p ps=1.12u w=0.74u l=0.13u
X794 VSS.t412 a_7043_1842# a_7477_1842# VSS.t495 sg13_lv_nmos ad=0.1406p pd=1.12u as=0.2516p ps=2.16u w=0.74u l=0.13u
X795 a_13121_5831# a_15688_5867# VDD.t172 VDD.t6 sg13_lv_pmos ad=0.3808p pd=2.92u as=0.2128p ps=1.5u w=1.12u l=0.13u
X796 VDD.t305 DELAY_VBIASP a_15511_2470# VDD.t2 sg13_lv_pmos ad=0.3808p pd=2.92u as=0.2128p ps=1.5u w=1.12u l=0.6u
X797 VDD.t13 a_2019_1047.t7 a_10404_1008# VDD.t0 sg13_lv_pmos ad=0.3808p pd=2.92u as=0.3808p ps=2.92u w=1.12u l=0.13u
X798 VSS.t508 a_9444_4590# a_9444_3912# VSS.t506 sg13_lv_nmos ad=0.68p pd=4.68u as=0.38p ps=2.38u w=2u l=1u
X799 VDD.t287 a_25283_1842# a_25717_1842# VDD.t2 sg13_lv_pmos ad=0.2128p pd=1.5u as=0.3808p ps=2.92u w=1.12u l=0.13u
X800 VDD.t311 DELAY_VBIASP a_5631_2470# VDD.t2 sg13_lv_pmos ad=0.3808p pd=2.92u as=0.2128p ps=1.5u w=1.12u l=0.6u
X801 a_26395_1044# a_26185_1044# VDD.t340 VDD.t0 sg13_lv_pmos ad=0.2128p pd=1.5u as=0.252p ps=1.57u w=1.12u l=0.13u
X802 a_13306_5105# a_14111_5227# a_13566_5328# VDD.t6 sg13_lv_pmos ad=0.1428p pd=1.52u as=79.8f ps=0.8u w=0.42u l=0.13u
X803 a_6326_4590# a_6126_3816# a_5778_3367# VSS.t124 sg13_lv_nmos ad=0.38p pd=2.38u as=0.68p ps=4.68u w=2u l=1u
X804 VDD.t291 a_3747_1047.t3 a_24951_1008# VDD.t0 sg13_lv_pmos ad=0.3808p pd=2.92u as=0.3808p ps=2.92u w=1.12u l=0.13u
X805 VDD.t230 VSS.t233 VDD.t65 VDD.t0 sg13_lv_pmos ad=0.19p pd=1.38u as=0 ps=0 w=1u l=1u
X806 a_13991_1842# a_13753_1842# a_13883_1842# VSS.t473 sg13_lv_nmos ad=0.1406p pd=1.12u as=0.2516p ps=2.16u w=0.74u l=0.2u
X807 a_24008_1044# a_23437_1842# VDD.t250 VDD.t0 sg13_lv_pmos ad=0.2128p pd=1.5u as=0.3808p ps=2.92u w=1.12u l=0.13u
X808 VDD.t193 VSS.t209 VDD.t192 VDD.t0 sg13_lv_pmos ad=0.19p pd=1.38u as=0 ps=0 w=1u l=1u
X809 VSS.t30 a_2019_1047.t4 a_19524_1008# VSS.t29 sg13_lv_nmos ad=0.2516p pd=2.16u as=0.2516p ps=2.16u w=0.74u l=0.13u
X810 a_9712_3912# a_6854_5454# a_9444_3912# VSS.t257 sg13_lv_nmos ad=0.38p pd=2.38u as=0.68p ps=4.68u w=2u l=1u
X811 a_7911_2470# a_7673_1842# a_7803_1842# VDD.t2 sg13_lv_pmos ad=0.2128p pd=1.5u as=0.3808p ps=2.92u w=1.12u l=0.2u
X812 a_16793_1842# a_16597_1842# VDD.t109 VDD.t2 sg13_lv_pmos ad=0.3808p pd=2.92u as=0.2128p ps=1.5u w=1.12u l=0.13u
X813 VSS.t463 MUX_SEL1 a_3543_1395# VSS.t516 sg13_lv_nmos ad=0.1331p pd=1.12u as=0.1216p ps=1.02u w=0.64u l=0.13u
X814 a_15755_1044# a_15545_1044# VSS.t293 VSS.t292 sg13_lv_nmos ad=0.1406p pd=1.12u as=0.1665p ps=1.19u w=0.74u l=0.13u
X815 a_13818_5118# a_12849_5867# VSS.t169 VSS.t314 sg13_lv_nmos ad=37.8f pd=0.6u as=0.1701p ps=1.65u w=0.42u l=0.13u
X816 a_2595_1047.t0 a_2297_1395# VDD.t8 VDD.t0 sg13_lv_pmos ad=0.2128p pd=1.5u as=0.1918p ps=1.5u w=1.12u l=0.13u
X817 VSS.t172 a_2595_1047.t6 a_14311_1008# VSS.t344 sg13_lv_nmos ad=0.2516p pd=2.16u as=0.2516p ps=2.16u w=0.74u l=0.13u
X818 VSS.t299 a_12363_1842# a_12797_1842# VSS.t298 sg13_lv_nmos ad=0.1406p pd=1.12u as=0.2516p ps=2.16u w=0.74u l=0.13u
X819 a_5115_1044# a_4905_1044# VSS.t252 VSS.t251 sg13_lv_nmos ad=0.1406p pd=1.12u as=0.1665p ps=1.19u w=0.74u l=0.13u
X820 a_1256_1044# MUX_SEL0 VDD.t335 VDD.t0 sg13_lv_pmos ad=0.3808p pd=2.92u as=0.3808p ps=2.92u w=1.12u l=0.13u
X821 a_9444_3912# a_9444_4590# VSS.t504 VSS.t503 sg13_lv_nmos ad=0.38p pd=2.38u as=0.68p ps=4.68u w=2u l=1u
X822 VSS.t399 DELAY_VBIASN VSS.t397 VSS.t382 sg13_lv_nmos ad=1.33p pd=7.38u as=0 ps=0 w=7u l=7u
X823 VDD.t281 a_27563_1842# a_27997_1842# VDD.t2 sg13_lv_pmos ad=0.2128p pd=1.5u as=0.3808p ps=2.92u w=1.12u l=0.13u
X824 a_20593_1842# a_20397_1842# VDD.t265 VDD.t2 sg13_lv_pmos ad=0.3808p pd=2.92u as=0.2128p ps=1.5u w=1.12u l=0.13u
X825 a_1721_1395# a_1256_1044# VDD.t132 VDD.t0 sg13_lv_pmos ad=0.1596p pd=1.22u as=0.2856p ps=2.36u w=0.84u l=0.13u
X826 VDD.t43 a_6283_1842# a_6717_1842# VDD.t2 sg13_lv_pmos ad=0.2128p pd=1.5u as=0.3808p ps=2.92u w=1.12u l=0.13u
X827 a_13470_1044# a_14964_1008# a_14888_1044# VDD.t0 sg13_lv_pmos ad=0.3808p pd=2.92u as=0.2128p ps=1.5u w=1.12u l=0.13u
X828 a_13592_5871# a_13566_5835# VDD.t59 VDD.t6 sg13_lv_pmos ad=0.34p pd=2.68u as=0.36237p ps=2.605u w=1u l=0.13u
X829 a_5778_3367# a_6126_3816# a_6326_4590# VSS.t124 sg13_lv_nmos ad=0.68p pd=4.68u as=0.42p ps=2.42u w=2u l=1u
X830 VSS.t217 VDD.t400 VSS.t216 VSS.t215 sg13_lv_nmos ad=0.1428p pd=1.52u as=0 ps=0 w=0.42u l=1u
X831 VDD.t112 a_2019_1047.t2 a_25604_1008# VDD.t0 sg13_lv_pmos ad=0.3808p pd=2.92u as=0.3808p ps=2.92u w=1.12u l=0.13u
X832 a_9746_5805# a_9547_5942# VSS.t10 VSS.t478 sg13_lv_nmos ad=0.27427p pd=2.28u as=2.39977p ps=15.495u w=0.795u l=0.13u
X833 a_16271_1842# a_16033_1842# a_16163_1842# VSS.t540 sg13_lv_nmos ad=0.1406p pd=1.12u as=0.2516p ps=2.16u w=0.74u l=0.2u
X834 a_21835_1044# a_21625_1044# VDD.t174 VDD.t0 sg13_lv_pmos ad=0.2128p pd=1.5u as=0.252p ps=1.57u w=1.12u l=0.13u
X835 VDD.t85 VSS.t191 VDD.t130 VDD.t0 sg13_lv_pmos ad=0.34p pd=2.68u as=0 ps=0 w=1u l=1u
X836 VDD.t379 a_2595_1047.t4 a_20391_1008# VDD.t0 sg13_lv_pmos ad=0.3808p pd=2.92u as=0.3808p ps=2.92u w=1.12u l=0.13u
X837 VSS.t144 a_14851_5182# a_15688_5403# VSS.t568 sg13_lv_nmos ad=0.1406p pd=1.12u as=0.2516p ps=2.16u w=0.74u l=0.13u
X838 a_19073_1842# a_18877_1842# VDD.t54 VDD.t2 sg13_lv_pmos ad=0.3808p pd=2.92u as=0.2128p ps=1.5u w=1.12u l=0.13u
X839 VDD.t83 a_10517_1842# a_10985_1044# VDD.t0 sg13_lv_pmos ad=0.252p pd=1.57u as=0.3808p ps=2.92u w=1.12u l=0.13u
X840 VSS.t264 a_21157_1842# a_21625_1044# VSS.t306 sg13_lv_nmos ad=0.1665p pd=1.19u as=0.2516p ps=2.16u w=0.74u l=0.13u
X841 VSS.t73 a_12849_5867# a_13400_6305# VSS.t72 sg13_lv_nmos ad=0.1626p pd=1.415u as=60.89999f ps=0.71u w=0.42u l=0.13u
X842 VSS.t126 a_6126_3816# a_6126_3816# VSS.t124 sg13_lv_nmos ad=0.68p pd=4.68u as=0.38p ps=2.38u w=2u l=1u
X843 a_20071_1842# a_19833_1842# a_19963_1842# VSS.t352 sg13_lv_nmos ad=0.1406p pd=1.12u as=0.2516p ps=2.16u w=0.74u l=0.2u
X844 VSS.t583 VSS.t581 VSS.t581 VSS.t582 sg13_lv_nmos ad=0.68p pd=4.68u as=0 ps=0 w=2u l=1u
X845 VSS.t376 a_14643_1842# a_15077_1842# VSS.t460 sg13_lv_nmos ad=0.1406p pd=1.12u as=0.2516p ps=2.16u w=0.74u l=0.13u
X846 a_1815_331# a_1256_289# a_1721_331# VSS.t104 sg13_lv_nmos ad=0.1216p pd=1.02u as=0.2176p ps=1.96u w=0.64u l=0.13u
X847 VDD.t139 VDD.t137 VDD.t29 VDD.t6 sg13_lv_pmos ad=0.38p pd=2.38u as=0 ps=0 w=2u l=1u
X848 VDD.t289 a_19203_1842# a_19637_1842# VDD.t2 sg13_lv_pmos ad=0.2128p pd=1.5u as=0.3808p ps=2.92u w=1.12u l=0.13u
X849 VSS.t75 a_2019_1047.t9 a_4324_1008# VSS.t120 sg13_lv_nmos ad=0.2516p pd=2.16u as=0.2516p ps=2.16u w=0.74u l=0.13u
X850 a_16108_289# a_20905_519# a_19550_1044# VDD.t0 sg13_lv_pmos ad=0.3808p pd=2.92u as=0.3808p ps=2.92u w=1.12u l=0.13u
X851 a_16510_1044# a_3747_1047.t5 a_18795_1044# VSS.t486 sg13_lv_nmos ad=0.2516p pd=2.16u as=0.1406p ps=1.12u w=0.74u l=0.13u
X852 VDD.t52 a_8563_1842# a_8997_1842# VDD.t2 sg13_lv_pmos ad=0.2128p pd=1.5u as=0.3808p ps=2.92u w=1.12u l=0.13u
X853 VDD.t318 DELAY_VBIASP a_13231_2470# VDD.t2 sg13_lv_pmos ad=0.3808p pd=2.92u as=0.2128p ps=1.5u w=1.12u l=0.6u
X854 VSS.t272 DELAY_VBIASN a_17791_1842# VSS.t371 sg13_lv_nmos ad=0.2516p pd=2.16u as=0.1406p ps=1.12u w=0.74u l=0.6u
X855 VSS.t197 VDD.t406 VSS.t155 VSS.t196 sg13_lv_nmos ad=0.1428p pd=1.52u as=0 ps=0 w=0.42u l=1u
X856 a_6854_5986# a_6326_4590# VDD.t34 VDD.t6 sg13_lv_pmos ad=0.38p pd=2.38u as=0.38p ps=2.38u w=2u l=1u
X857 VDD.t152 VDD.t150 VDD.t151 VDD.t50 sg13_lv_pmos ad=0.3808p pd=2.92u as=0 ps=0 w=1.12u l=0.13u
X858 VDD.t292 a_3747_1047.t5 a_18871_1008# VDD.t0 sg13_lv_pmos ad=0.3808p pd=2.92u as=0.3808p ps=2.92u w=1.12u l=0.13u
X859 VDD.t147 VDD.t148 VDD.t149 VDD.t50 sg13_lv_pmos ad=0.2128p pd=1.5u as=0 ps=0 w=1.12u l=0.13u
X860 VDD.t249 a_23003_1842# a_23437_1842# VDD.t2 sg13_lv_pmos ad=0.2128p pd=1.5u as=0.3808p ps=2.92u w=1.12u l=0.13u
X861 VSS.t507 a_9444_4590# a_9444_4590# VSS.t506 sg13_lv_nmos ad=0.68p pd=4.68u as=0.38p ps=2.38u w=2u l=1u
X862 VSS.t586 VSS.t578 VSS.t578 VSS.t579 sg13_lv_nmos ad=0.68p pd=4.68u as=0 ps=0 w=2u l=1u
X863 a_12715_1044# a_12505_1044# VDD.t357 VDD.t0 sg13_lv_pmos ad=0.2128p pd=1.5u as=0.252p ps=1.57u w=1.12u l=0.13u
X864 a_19550_1044# a_21044_1008# a_20968_1044# VDD.t0 sg13_lv_pmos ad=0.3808p pd=2.92u as=0.2128p ps=1.5u w=1.12u l=0.13u
X865 a_17928_1044# a_17357_1842# VDD.t387 VDD.t0 sg13_lv_pmos ad=0.2128p pd=1.5u as=0.3808p ps=2.92u w=1.12u l=0.13u
X866 VSS.t32 DELAY_VBIASN a_21591_1842# VSS.t354 sg13_lv_nmos ad=0.2516p pd=2.16u as=0.1406p ps=1.12u w=0.74u l=0.6u
X867 VSS.t106 a_1544_289# a_1815_331# VSS.t576 sg13_lv_nmos ad=0.1331p pd=1.12u as=0.1216p ps=1.02u w=0.64u l=0.13u
X868 a_7288_1044# a_6717_1842# VDD.t44 VDD.t0 sg13_lv_pmos ad=0.2128p pd=1.5u as=0.3808p ps=2.92u w=1.12u l=0.13u
X869 VSS.t389 DELAY_VBIASN VSS.t391 VSS.t390 sg13_lv_nmos ad=1.33p pd=7.38u as=0 ps=0 w=7u l=7u
X870 a_5974_5723# a_6126_3816# VSS.t133 VSS.t127 sg13_lv_nmos ad=0.38p pd=2.38u as=0.68p ps=4.68u w=2u l=1u
X871 a_15511_2470# a_15273_1842# a_15403_1842# VDD.t2 sg13_lv_pmos ad=0.2128p pd=1.5u as=0.3808p ps=2.92u w=1.12u l=0.2u
X872 VSS.t610 VSS.t612 VSS.t614 VSS.t613 sg13_lv_nmos ad=0.1406p pd=1.12u as=0 ps=0 w=0.74u l=0.2u
X873 a_22590_1044# a_24951_1008# a_24875_1044# VDD.t0 sg13_lv_pmos ad=0.3808p pd=2.92u as=0.2128p ps=1.5u w=1.12u l=0.13u
X874 VSS.t243 VDD.t392 VSS.t243 VSS.t245 sg13_lv_nmos ad=79.8f pd=0.8u as=0 ps=0 w=0.42u l=1u
X875 VSS.t144 a_15108_5325# a_14757_5182# VSS.t143 sg13_lv_nmos ad=79.8f pd=0.8u as=0.1428p ps=1.52u w=0.42u l=0.13u
X876 a_10430_1044# a_2019_1047.t7 a_10328_1044# VSS.t20 sg13_lv_nmos ad=0.2516p pd=2.16u as=0.1406p ps=1.12u w=0.74u l=0.13u
X877 VDD.t360 a_5974_5723# a_5974_5723# VDD.t6 sg13_lv_pmos ad=0.2448p pd=2.08u as=0.2826p ps=2.29u w=0.36u l=2u
X878 VDD.t340 a_25717_1842# a_26185_1044# VDD.t0 sg13_lv_pmos ad=0.252p pd=1.57u as=0.3808p ps=2.92u w=1.12u l=0.13u
X879 a_6854_5454# a_6854_5454# a_9444_4590# VSS.t257 sg13_lv_nmos ad=0.38p pd=2.38u as=0.68p ps=4.68u w=2u l=1u
X880 VDD.t111 a_13883_1842# a_14317_1842# VDD.t2 sg13_lv_pmos ad=0.2128p pd=1.5u as=0.3808p ps=2.92u w=1.12u l=0.13u
X881 VDD.t171 a_4437_1842# a_4905_1044# VDD.t0 sg13_lv_pmos ad=0.252p pd=1.57u as=0.3808p ps=2.92u w=1.12u l=0.13u
X882 a_4157_1313# REF_CLK VSS.t445 VSS.t444 sg13_lv_nmos ad=0.2516p pd=2.16u as=0.2553p ps=2.17u w=0.74u l=0.13u
X883 a_7390_1044# a_3171_1047.t8 a_8808_1044# VSS.t89 sg13_lv_nmos ad=0.2516p pd=2.16u as=0.1406p ps=1.12u w=0.74u l=0.13u
X884 a_22873_1842# a_22677_1842# VSS.t27 VSS.t537 sg13_lv_nmos ad=0.2516p pd=2.16u as=0.1406p ps=1.12u w=0.74u l=0.13u
X885 a_9444_4590# a_9444_4590# VSS.t505 VSS.t503 sg13_lv_nmos ad=0.38p pd=2.38u as=0.68p ps=4.68u w=2u l=1u
X886 VDD.t71 a_3171_1047.t8 a_8884_1008# VDD.t0 sg13_lv_pmos ad=0.3808p pd=2.92u as=0.3808p ps=2.92u w=1.12u l=0.13u
C0 a_25630_1044# a_26985_519# 0.02165f
C1 a_22113_1842# a_22677_1842# 0.0114f
C2 a_9953_1842# a_10083_1842# 0.70845f
C3 a_27563_1842# VDD 0.49811f
C4 a_24523_1842# DELAY_VBIASP 0.06661f
C5 a_25717_1842# DELAY_VBIASN 0.09106f
C6 a_2297_331# MUX_SEL2 0.10655f
C7 a_14964_1008# a_15077_1842# 0.02055f
C8 a_12907_5186# DLL_RESETN 0.02177f
C9 a_22590_1044# a_23431_1008# 0.28268f
C10 VDD a_7803_1842# 0.4973f
C11 VDD a_10328_1044# 0.17274f
C12 a_18585_1044# a_18795_1044# 0.09424f
C13 a_12158_5867# DLL_RESETN 0.02442f
C14 a_11491_6228# REF_CLK 0.01827f
C15 DELAY_VBIASP a_6153_1842# 0.11222f
C16 DELAY_VBIASN a_6283_1842# 0.07254f
C17 a_16108_289# a_26985_519# 0.2906f
C18 a_16597_1842# a_17065_1044# 0.19203f
C19 a_21157_1842# a_21917_1842# 0.02912f
C20 a_16108_289# a_22590_1044# 0.58202f
C21 a_25913_1842# VDD 0.49294f
C22 VDD a_15755_1044# 0.15389f
C23 MUX_SEL4 VDD 2.63176f
C24 VDD a_18551_2470# 0.01806f
C25 REF_CLK DELAY_VBIASN 0.07156f
C26 a_13470_1044# a_14317_1842# 0.08038f
C27 a_21835_1044# a_21911_1008# 0.01194f
C28 a_15108_6109# VDD 0.1349f
C29 VDD a_7390_1044# 0.8686f
C30 a_19550_1044# a_21483_1842# 0.01012f
C31 a_10206_5835# DLL_RESETN 0.27343f
C32 a_5523_1842# a_5631_1842# 0.01163f
C33 VDD a_7477_1842# 0.86707f
C34 DELAY_VBIASP a_23437_1842# 0.04176f
C35 DELAY_VBIASN a_23633_1842# 0.10349f
C36 DELAY_VBIASN a_4633_1842# 0.0961f
C37 DELAY_VBIASP a_4437_1842# 0.0414f
C38 a_15765_463# a_15964_289# 0.061f
C39 a_13306_5105# a_13592_5423# 0.41329f
C40 a_15304_4605# a_15108_5325# 0.01986f
C41 a_13566_5328# a_14009_5084# 0.02242f
C42 a_20397_1842# a_19963_1842# 0.6972f
C43 a_8237_1842# a_8433_1842# 0.76914f
C44 a_24197_1842# VDD 0.85848f
C45 VDD a_12791_1008# 0.2822f
C46 a_1544_1044# a_2297_1395# 0.28651f
C47 VDD a_12471_2470# 0.01806f
C48 a_1721_331# VDD 0.45259f
C49 a_25630_1044# DELAY_VBIASN 0.02756f
C50 a_19550_1044# a_21044_1008# 0.28279f
C51 a_20315_1044# a_20391_1008# 0.01194f
C52 a_26673_1842# a_26803_1842# 0.70845f
C53 a_13566_5835# VDD 0.09466f
C54 a_16510_1044# a_17275_1044# 0.39037f
C55 VDD a_4324_1008# 0.28597f
C56 a_6854_5986# REF_CLK 0.05061f
C57 a_6126_3816# DLL_RESETN 0.06398f
C58 a_4003_1842# a_4111_1842# 0.01163f
C59 VDD a_15545_1044# 0.29918f
C60 MUX_SEL0 a_2873_1395# 0.01504f
C61 VDD a_4763_1842# 0.4973f
C62 DELAY_VBIASN a_21917_1842# 0.10687f
C63 a_26803_1842# a_26911_1842# 0.01163f
C64 a_11848_1044# a_11277_1842# 0.10863f
C65 DELAY_VBIASP a_20723_1842# 0.06661f
C66 a_17357_1842# a_18117_1842# 0.03319f
C67 a_13106_5357# a_13132_5420# 0.1657f
C68 a_12907_5186# a_12907_5420# 0.1117f
C69 a_19073_1842# a_19637_1842# 0.0114f
C70 a_7390_1044# a_7803_1842# 0.01012f
C71 a_26395_1044# VDD 0.15389f
C72 a_12355_5867# VDD 0.37639f
C73 VDD a_24084_1008# 0.28225f
C74 a_23763_1842# a_23871_2470# 0.01697f
C75 MUX_SEL3 MUX_OUT 0.79533f
C76 a_15403_1842# a_15511_1842# 0.01163f
C77 a_17357_1842# a_18004_1008# 0.02312f
C78 a_2019_311# a_16510_1044# 0.03139f
C79 a_15108_5325# VDD 0.13728f
C80 DELAY_VBIASP a_16923_1842# 0.06661f
C81 DELAY_VBIASN a_18117_1842# 0.09851f
C82 VDD a_4905_1044# 0.30126f
C83 VDD a_22113_1842# 0.49426f
C84 DELAY_VBIASN a_19203_1842# 0.07852f
C85 a_25283_1842# a_25391_1842# 0.01163f
C86 DELAY_VBIASP a_19073_1842# 0.11286f
C87 a_16597_1842# a_16163_1842# 0.69698f
C88 MUX_SEL4 a_7390_1044# 0.34655f
C89 a_12715_1044# a_10430_1044# 0.39036f
C90 a_14111_5878# a_14851_6228# 0.26905f
C91 a_6126_3816# a_9444_4590# 0.03029f
C92 a_17865_519# VDD 0.29444f
C93 a_7288_1044# a_7364_1008# 0.01176f
C94 a_24957_1842# a_25153_1842# 0.76914f
C95 VDD a_21835_1044# 0.15406f
C96 a_13470_1044# a_14888_1044# 0.38994f
C97 a_10520_6292# a_10751_5878# 0.12701f
C98 a_7390_1044# a_7477_1842# 0.1088f
C99 a_13883_1842# a_13991_1842# 0.01163f
C100 DELAY_OUT_LAST DELAY_VBIASP 1.08837f
C101 MUX_OUT a_1544_289# 0.69943f
C102 MUX_SEL3 a_2297_331# 0.01595f
C103 MUX_SEL4 a_1721_331# 0.05813f
C104 a_13306_5105# VDD 0.79678f
C105 DELAY_VBIASP a_15273_1842# 0.11297f
C106 DELAY_VBIASN a_15403_1842# 0.08418f
C107 a_3449_331# a_2019_311# 0.01176f
C108 VDD a_20397_1842# 0.86909f
C109 a_23763_1842# a_23871_1842# 0.01163f
C110 a_15273_1842# a_15837_1842# 0.0114f
C111 a_27237_1842# a_27705_1044# 0.2079f
C112 a_14009_5878# a_13880_6292# 0.01562f
C113 a_13592_5871# a_14111_5878# 0.34102f
C114 a_5731_289# a_4350_1044# 0.41099f
C115 a_15755_1044# a_15545_1044# 0.09424f
C116 a_6854_5986# a_13132_5420# 0.01367f
C117 VDD a_18871_1008# 0.2822f
C118 a_10206_5835# a_10232_5871# 0.36952f
C119 VDD MUX_SEL2 0.50938f
C120 a_26043_1842# a_25630_1044# 0.01012f
C121 a_12363_1842# a_12471_1842# 0.01163f
C122 VDD a_16597_1842# 0.86876f
C123 DELAY_VBIASP a_13557_1842# 0.0414f
C124 DELAY_VBIASN a_13753_1842# 0.0961f
C125 a_1544_289# a_2297_331# 0.27303f
C126 a_1256_289# a_2873_331# 0.27926f
C127 a_14009_5878# REF_CLK 0.25847f
C128 a_14317_1842# a_15077_1842# 0.03319f
C129 a_12849_5867# a_12943_5867# 0.16706f
C130 a_6126_3816# DELAY_VBIASP 0.01821f
C131 a_26471_1008# a_26185_1044# 0.01885f
C132 DELAY_VBIASN a_11473_1842# 0.0961f
C133 DELAY_VBIASP a_11277_1842# 0.0414f
C134 a_24665_1044# a_24951_1008# 0.01885f
C135 a_4350_1044# a_5115_1044# 0.39037f
C136 a_2873_1395# a_1256_1044# 0.28892f
C137 MUX_OUT a_16851_309# 0.45865f
C138 a_15964_289# a_16510_1044# 0.05416f
C139 a_9746_5805# a_9772_5843# 0.1657f
C140 VDD a_13883_1842# 0.49742f
C141 a_5197_1842# a_5393_1842# 0.76914f
C142 a_24197_1842# a_24084_1008# 0.02055f
C143 a_12037_1842# a_12797_1842# 0.02912f
C144 a_13121_5831# DLL_RESETN 0.04337f
C145 a_13019_5831# REF_CLK 0.35409f
C146 a_13557_1842# a_13123_1842# 0.69698f
C147 a_13019_5831# a_13045_6215# 0.01249f
C148 a_13121_5831# a_13306_6305# 0.01008f
C149 a_9746_5805# VDD 0.0918f
C150 a_27915_1044# a_27705_1044# 0.09424f
C151 a_11195_1044# a_10985_1044# 0.09424f
C152 DLL_RESETN a_5864_3367# 0.1727f
C153 REF_CLK a_9712_3912# 0.06562f
C154 VDD a_11603_1842# 0.49671f
C155 DELAY_VBIASN a_9757_1842# 0.09992f
C156 DELAY_VBIASP a_8563_1842# 0.06627f
C157 MUX_SEL0 a_2297_1395# 0.10655f
C158 a_23145_1044# a_22590_1044# 0.03209f
C159 VDD a_25391_2470# 0.01806f
C160 a_4350_1044# a_6425_1044# 0.03208f
C161 a_6126_3816# a_6854_5454# 0.22705f
C162 a_22873_1842# a_23003_1842# 0.70845f
C163 a_25630_1044# a_27048_1044# 0.38994f
C164 a_11277_1842# a_10843_1842# 0.6972f
C165 a_26803_1842# DELAY_VBIASN 0.08024f
C166 a_26673_1842# DELAY_VBIASP 0.11284f
C167 MUX_OUT MUX_SEL1 0.09357f
C168 MUX_SEL4 MUX_SEL2 0.01978f
C169 VDD a_9953_1842# 0.49426f
C170 DELAY_VBIASN a_7043_1842# 0.07254f
C171 a_15304_4605# a_14111_5878# 0.01811f
C172 a_13019_5831# a_15464_3684# 0.59875f
C173 a_20105_1044# a_20391_1008# 0.01885f
C174 a_22590_1044# a_23003_1842# 0.01012f
C175 a_14851_5182# a_15688_5403# 0.08776f
C176 VDD a_7911_2470# 0.01806f
C177 a_18117_1842# a_18585_1044# 0.2079f
C178 a_9444_4590# a_5864_3367# 0.06832f
C179 a_20105_1044# a_19637_1842# 0.19203f
C180 a_21917_1842# a_22243_1842# 0.01427f
C181 a_15464_3684# a_9712_3912# 0.01237f
C182 a_9953_1842# a_10517_1842# 0.0114f
C183 a_27997_1842# VDD 0.76025f
C184 a_24957_1842# DELAY_VBIASP 0.04176f
C185 a_25153_1842# DELAY_VBIASN 0.10332f
C186 VDD a_17928_1044# 0.17499f
C187 VDD a_23871_2470# 0.01806f
C188 a_10430_1044# a_12037_1842# 0.05231f
C189 a_13470_1044# a_15403_1842# 0.01012f
C190 a_1721_331# MUX_SEL2 0.01315f
C191 a_13106_5357# DLL_RESETN 0.01263f
C192 a_22590_1044# a_23355_1044# 0.39037f
C193 VDD a_8237_1842# 0.86909f
C194 VDD a_1721_1395# 0.4533f
C195 VDD a_9751_1008# 0.2822f
C196 a_22488_1044# a_21917_1842# 0.10864f
C197 a_11748_6109# REF_CLK 0.0148f
C198 a_11491_6228# DLL_RESETN 0.14622f
C199 DELAY_VBIASN a_6717_1842# 0.09992f
C200 DELAY_VBIASP a_5523_1842# 0.06627f
C201 a_16108_289# a_23945_519# 0.2906f
C202 a_13592_5423# a_14851_5182# 0.01529f
C203 a_21157_1842# a_21353_1842# 0.77122f
C204 a_8997_1842# a_9757_1842# 0.02912f
C205 a_25283_1842# VDD 0.49737f
C206 MUX_SEL3 VDD 0.4053f
C207 VDD a_14964_1008# 0.28225f
C208 VDD a_17791_2470# 0.01806f
C209 DLL_RESETN DELAY_VBIASN 0.12907f
C210 a_27997_1842# a_27563_1842# 0.69646f
C211 a_14111_5878# VDD 0.21331f
C212 a_7911_2470# a_7803_1842# 0.01697f
C213 a_12849_5867# DELAY_OUT_LAST 0.01791f
C214 VDD a_7288_1044# 0.17274f
C215 a_19550_1044# a_21917_1842# 0.02479f
C216 VDD a_26185_1044# 0.30409f
C217 VDD a_6913_1842# 0.49426f
C218 DELAY_VBIASN a_23003_1842# 0.08024f
C219 DELAY_VBIASP a_22873_1842# 0.11284f
C220 DELAY_VBIASP a_5864_3367# 0.03252f
C221 DELAY_VBIASN a_4003_1842# 0.06486f
C222 a_15304_4605# a_14851_5182# 0.05156f
C223 a_13566_5328# a_13592_5423# 0.36952f
C224 a_19833_1842# a_19963_1842# 0.70845f
C225 a_8237_1842# a_7803_1842# 0.6972f
C226 a_16108_289# a_19550_1044# 0.58202f
C227 a_1256_1044# a_2297_1395# 0.04619f
C228 VDD a_12715_1044# 0.15406f
C229 a_8884_1008# a_8997_1842# 0.02055f
C230 VDD a_11711_2470# 0.01806f
C231 a_1544_289# VDD 0.39113f
C232 a_26673_1842# a_27237_1842# 0.0114f
C233 a_16108_289# a_18877_1842# 0.0157f
C234 a_19550_1044# a_20968_1044# 0.38994f
C235 a_16510_1044# a_16484_1008# 0.277f
C236 VDD a_4350_1044# 0.87635f
C237 a_19524_1008# a_19637_1842# 0.05157f
C238 a_6854_5986# DLL_RESETN 0.50331f
C239 VDD a_14025_1044# 0.30409f
C240 VDD a_5197_1842# 0.86909f
C241 DELAY_VBIASN a_21353_1842# 0.10734f
C242 a_11271_1008# a_11277_1842# 0.02349f
C243 DELAY_VBIASP a_21157_1842# 0.04177f
C244 a_17357_1842# a_17553_1842# 0.76914f
C245 MUX_OUT a_1544_1044# 0.04258f
C246 a_13106_5357# a_12907_5420# 0.14994f
C247 a_18117_1842# a_18877_1842# 0.02912f
C248 a_18877_1842# a_19203_1842# 0.01427f
C249 a_7390_1044# a_8237_1842# 0.08038f
C250 a_6854_5454# a_5864_3367# 0.03661f
C251 a_25604_1008# VDD 0.28633f
C252 a_7390_1044# a_9751_1008# 0.26208f
C253 a_8237_1842# a_7477_1842# 0.01669f
C254 a_25717_1842# a_26477_1842# 0.01669f
C255 VDD a_24008_1044# 0.17499f
C256 a_11491_6228# a_11397_6228# 0.28931f
C257 MUX_SEL3 MUX_SEL4 0.75489f
C258 a_14851_5182# VDD 0.26676f
C259 DELAY_VBIASN a_17553_1842# 0.10734f
C260 DELAY_VBIASP a_17357_1842# 0.04176f
C261 VDD a_4157_1313# 0.48935f
C262 VDD a_21483_1842# 0.4973f
C263 DELAY_VBIASP a_18443_1842# 0.06661f
C264 DELAY_VBIASN a_19637_1842# 0.0907f
C265 a_10404_1008# a_9757_1842# 0.02011f
C266 a_16033_1842# a_16163_1842# 0.70845f
C267 a_11924_1008# a_10430_1044# 0.28279f
C268 a_14111_5878# a_15108_6109# 0.03093f
C269 a_17351_1008# a_17065_1044# 0.01885f
C270 a_16851_309# VDD 0.51536f
C271 a_6854_5986# a_9444_4590# 0.02502f
C272 a_7288_1044# a_7390_1044# 0.37183f
C273 a_24957_1842# a_24523_1842# 0.6972f
C274 VDD a_21044_1008# 0.28225f
C275 a_10430_1044# a_12505_1044# 0.03208f
C276 a_10232_5871# a_11491_6228# 0.01529f
C277 a_13470_1044# a_14311_1008# 0.28268f
C278 a_27237_1842# a_27124_1008# 0.02055f
C279 DELAY_VBIASN DELAY_VBIASP 8.74838f
C280 MUX_OUT a_1256_289# 0.1134f
C281 MUX_SEL4 a_1544_289# 0.47529f
C282 VDD a_17683_1842# 0.49671f
C283 a_13566_5328# VDD 0.0947f
C284 a_6913_1842# a_7477_1842# 0.0114f
C285 DELAY_VBIASP a_14643_1842# 0.06668f
C286 DELAY_VBIASN a_15837_1842# 0.10875f
C287 VDD a_19833_1842# 0.49294f
C288 MUX_SEL4 a_4350_1044# 0.31434f
C289 a_13592_5871# a_13880_6292# 0.43707f
C290 a_22351_2470# a_22243_1842# 0.01697f
C291 a_5768_1044# a_5844_1008# 0.01176f
C292 VDD a_18795_1044# 0.15406f
C293 a_9946_6305# a_10649_5878# 0.02432f
C294 a_12715_1044# a_12791_1008# 0.01194f
C295 VDD MUX_SEL1 0.50267f
C296 a_26477_1842# a_25630_1044# 0.08038f
C297 VDD a_16033_1842# 0.49413f
C298 a_5957_1842# a_6717_1842# 0.02912f
C299 DELAY_VBIASP a_12993_1842# 0.11222f
C300 DELAY_VBIASN a_13123_1842# 0.07254f
C301 a_1256_289# a_2297_331# 0.04261f
C302 a_1544_289# a_1721_331# 0.36963f
C303 a_13592_5871# REF_CLK 0.11539f
C304 a_14317_1842# a_14513_1842# 0.76914f
C305 a_13121_5831# a_12943_5867# 0.09118f
C306 a_13306_6305# a_14009_5878# 0.02432f
C307 a_23763_1842# a_23633_1842# 0.70845f
C308 a_6854_5986# DELAY_VBIASP 0.01478f
C309 MUX_SEL4 a_4157_1313# 0.08229f
C310 a_20831_2470# a_20723_1842# 0.01697f
C311 a_26395_1044# a_26185_1044# 0.09424f
C312 DELAY_VBIASN a_10843_1842# 0.07254f
C313 DELAY_VBIASP a_10713_1842# 0.11222f
C314 a_4350_1044# a_4324_1008# 0.277f
C315 a_24665_1044# a_24875_1044# 0.09424f
C316 a_22351_1842# a_22243_1842# 0.01163f
C317 a_6711_1008# a_6425_1044# 0.01885f
C318 a_11195_1044# a_11271_1008# 0.01194f
C319 MUX_OUT a_16108_289# 0.24265f
C320 a_4350_1044# a_4763_1842# 0.01012f
C321 a_5731_289# a_16108_289# 0.01334f
C322 VDD a_14317_1842# 0.87229f
C323 a_5197_1842# a_4763_1842# 0.6972f
C324 a_24523_1842# a_22590_1044# 0.01012f
C325 a_12037_1842# a_12233_1842# 0.77122f
C326 a_12656_5864# REF_CLK 0.01215f
C327 a_13019_5831# DLL_RESETN 0.01429f
C328 a_12993_1842# a_13123_1842# 0.70845f
C329 a_16510_1044# a_16923_1842# 0.01012f
C330 a_13121_5831# a_12849_5867# 0.55272f
C331 a_9547_6172# VDD 0.08695f
C332 a_19311_2470# a_19203_1842# 0.01697f
C333 DLL_RESETN a_9712_3912# 0.4243f
C334 VDD a_12037_1842# 0.85848f
C335 DELAY_VBIASN a_9193_1842# 0.0961f
C336 DELAY_VBIASP a_8997_1842# 0.04141f
C337 a_20831_1842# a_20723_1842# 0.01163f
C338 VDD a_24631_2470# 0.01806f
C339 a_4350_1044# a_4905_1044# 0.03209f
C340 a_4324_1008# a_4157_1313# 0.02463f
C341 a_6854_5986# a_6854_5454# 0.30378f
C342 a_21625_1044# a_21157_1842# 0.2079f
C343 a_22873_1842# a_23437_1842# 0.0114f
C344 a_25630_1044# a_26471_1008# 0.28268f
C345 a_10713_1842# a_10843_1842# 0.70845f
C346 a_26043_1842# DELAY_VBIASP 0.06661f
C347 a_27237_1842# DELAY_VBIASN 0.10152f
C348 MUX_SEL3 MUX_SEL2 3.21891f
C349 MUX_SEL4 MUX_SEL1 0.03574f
C350 a_16408_1044# a_15837_1842# 0.10864f
C351 a_13592_5423# REF_CLK 0.03445f
C352 a_24008_1044# a_24084_1008# 0.01176f
C353 VDD a_9323_1842# 0.4973f
C354 a_14111_5227# a_12849_5867# 0.42064f
C355 a_20105_1044# a_20315_1044# 0.09424f
C356 a_22590_1044# a_23437_1842# 0.08038f
C357 a_19311_1842# a_19203_1842# 0.01163f
C358 a_14851_5182# a_15108_5325# 0.29858f
C359 a_15688_5403# a_15464_3684# 0.1999f
C360 a_9444_4590# a_9712_3912# 0.39071f
C361 a_21917_1842# a_22677_1842# 0.06198f
C362 a_26803_1842# a_26911_2470# 0.01697f
C363 a_9757_1842# a_10083_1842# 0.01427f
C364 a_27433_1842# VDD 0.49285f
C365 a_24523_1842# DELAY_VBIASN 0.08024f
C366 a_24393_1842# DELAY_VBIASP 0.11284f
C367 VDD a_17351_1008# 0.28565f
C368 VDD a_23111_2470# 0.01806f
C369 a_13470_1044# a_15837_1842# 0.02479f
C370 a_1544_289# MUX_SEL2 0.07405f
C371 a_15304_4605# REF_CLK 0.01066f
C372 a_22590_1044# a_22564_1008# 0.277f
C373 VDD a_7673_1842# 0.49294f
C374 VDD a_1544_1044# 0.45079f
C375 VDD a_9675_1044# 0.15406f
C376 a_10751_5878# REF_CLK 0.01931f
C377 a_21911_1008# a_21917_1842# 0.02354f
C378 a_11748_6109# DLL_RESETN 0.11133f
C379 DELAY_VBIASN a_6153_1842# 0.0961f
C380 DELAY_VBIASP a_5957_1842# 0.04141f
C381 a_16108_289# a_20905_519# 0.2906f
C382 a_14009_5084# a_14757_5182# 0.01058f
C383 a_21157_1842# a_20723_1842# 0.6972f
C384 a_25283_1842# a_25391_2470# 0.01697f
C385 a_8997_1842# a_9193_1842# 0.77122f
C386 a_25717_1842# VDD 0.86707f
C387 VDD a_14888_1044# 0.17499f
C388 VDD a_17031_2470# 0.01806f
C389 a_13444_1008# a_13557_1842# 0.05157f
C390 a_27433_1842# a_27563_1842# 0.70845f
C391 a_13121_5831# DELAY_OUT_LAST 0.13178f
C392 a_13019_5831# DELAY_VBIASP 0.02377f
C393 VDD a_6711_1008# 0.2822f
C394 a_9946_6305# DLL_RESETN 0.09997f
C395 a_21044_1008# a_20397_1842# 0.02312f
C396 VDD a_24665_1044# 0.29722f
C397 VDD a_6283_1842# 0.4973f
C398 DELAY_VBIASP a_22243_1842# 0.06661f
C399 DELAY_VBIASN a_23437_1842# 0.10669f
C400 DELAY_VBIASP a_9712_3912# 0.14197f
C401 DELAY_VBIASN a_4437_1842# 0.08375f
C402 DLL_RESETN a_12797_1842# 0.0106f
C403 a_13566_5328# a_13306_5105# 0.75507f
C404 a_11711_2470# a_11603_1842# 0.01697f
C405 a_19833_1842# a_20397_1842# 0.0114f
C406 a_7673_1842# a_7803_1842# 0.70845f
C407 VDD a_11924_1008# 0.28225f
C408 VDD REF_CLK 2.08015f
C409 a_7390_1044# a_9323_1842# 0.01012f
C410 VDD a_10951_2470# 0.01806f
C411 a_1256_289# VDD 0.40292f
C412 a_19550_1044# a_20391_1008# 0.28268f
C413 a_26477_1842# a_26803_1842# 0.01427f
C414 a_16408_1044# a_16484_1008# 0.01176f
C415 VDD a_4248_1044# 0.17587f
C416 a_19550_1044# a_19637_1842# 0.1088f
C417 a_5974_5723# DLL_RESETN 0.02002f
C418 a_14111_5227# DELAY_OUT_LAST 0.02024f
C419 VDD a_12505_1044# 0.29722f
C420 VDD a_23633_1842# 0.49417f
C421 VDD a_4633_1842# 0.49285f
C422 DELAY_VBIASN a_20723_1842# 0.07937f
C423 DELAY_VBIASP a_20593_1842# 0.11287f
C424 a_17357_1842# a_16923_1842# 0.6972f
C425 a_13106_5357# a_12907_5186# 0.02437f
C426 a_10191_2470# a_10083_1842# 0.01697f
C427 MUX_SEL4 a_1544_1044# 0.03407f
C428 MUX_OUT a_1256_1044# 0.02466f
C429 a_18117_1842# a_18313_1842# 0.77122f
C430 a_6854_5986# a_12849_5867# 0.06216f
C431 a_18877_1842# a_19637_1842# 0.06198f
C432 a_5631_2470# a_5523_1842# 0.01697f
C433 a_6854_5454# a_9712_3912# 0.6789f
C434 a_6126_3816# a_5864_3367# 0.23738f
C435 a_25630_1044# VDD 0.89531f
C436 a_7390_1044# a_9675_1044# 0.39036f
C437 a_18795_1044# a_18871_1008# 0.01194f
C438 a_7673_1842# a_7477_1842# 0.73897f
C439 a_25717_1842# a_25913_1842# 0.73897f
C440 VDD a_23431_1008# 0.28336f
C441 a_11491_6228# a_12158_5867# 0.0894f
C442 MUX_OUT a_2019_311# 8.45486f
C443 DELAY_VBIASP a_16793_1842# 0.11284f
C444 DELAY_VBIASN a_16923_1842# 0.08024f
C445 VDD a_3449_1395# 0.46731f
C446 a_2019_311# a_5731_289# 1.15781f
C447 VDD a_21917_1842# 0.87825f
C448 VDD a_15464_3684# 0.52511f
C449 DELAY_VBIASP a_18877_1842# 0.04176f
C450 DELAY_VBIASN a_19073_1842# 0.10642f
C451 a_16033_1842# a_16597_1842# 0.0114f
C452 a_8671_2470# a_8563_1842# 0.01697f
C453 a_11848_1044# a_10430_1044# 0.38994f
C454 a_4111_2470# a_4003_1842# 0.01697f
C455 a_17275_1044# a_17065_1044# 0.09424f
C456 a_16108_289# VDD 1.25759f
C457 a_8997_1842# a_9465_1044# 0.2079f
C458 a_24393_1842# a_24523_1842# 0.70845f
C459 VDD a_20968_1044# 0.17499f
C460 a_10430_1044# a_10985_1044# 0.03209f
C461 a_13470_1044# a_14235_1044# 0.39037f
C462 a_7364_1008# a_6717_1842# 0.02011f
C463 a_10649_5878# a_10751_5878# 0.47795f
C464 MUX_SEL4 REF_CLK 0.0663f
C465 a_27563_1842# a_25630_1044# 0.01024f
C466 DELAY_VBIASN DELAY_OUT_LAST 3.19293f
C467 MUX_SEL4 a_1256_289# 0.65005f
C468 MUX_SEL3 a_1544_289# 0.15976f
C469 a_13132_5420# VDD 0.23863f
C470 VDD a_18117_1842# 0.85848f
C471 a_9444_4590# a_6326_4590# 0.01269f
C472 DELAY_VBIASP a_15077_1842# 0.04184f
C473 DELAY_VBIASN a_15273_1842# 0.10803f
C474 a_2297_331# a_2019_311# 0.04011f
C475 VDD a_19203_1842# 0.49737f
C476 a_15077_1842# a_15837_1842# 0.02912f
C477 a_24197_1842# a_24665_1044# 0.2079f
C478 DELAY_VBIASP a_12797_1842# 0.0414f
C479 VDD a_18004_1008# 0.28225f
C480 a_8231_1008# a_7945_1044# 0.01885f
C481 a_9946_6305# a_10232_5871# 0.41329f
C482 a_5844_1008# a_5957_1842# 0.02055f
C483 VDD MUX_SEL0 0.56365f
C484 VDD a_15403_1842# 0.4973f
C485 DELAY_VBIASP a_12363_1842# 0.06627f
C486 DELAY_VBIASN a_13557_1842# 0.08375f
C487 a_5957_1842# a_6153_1842# 0.77122f
C488 a_24957_1842# a_25528_1044# 0.10864f
C489 a_1256_289# a_1721_331# 0.13421f
C490 a_13566_5835# REF_CLK 0.01538f
C491 a_14317_1842# a_13883_1842# 0.6972f
C492 a_13306_6305# a_13592_5871# 0.41329f
C493 a_13019_5831# a_12943_5867# 0.03346f
C494 a_12849_5867# a_14009_5878# 0.03525f
C495 a_10649_5878# VDD 0.23431f
C496 a_24197_1842# a_23633_1842# 0.0114f
C497 a_6854_5986# DELAY_OUT_LAST 0.08491f
C498 a_12791_1008# a_12505_1044# 0.01885f
C499 DELAY_VBIASN a_11277_1842# 0.09974f
C500 DELAY_VBIASP a_10083_1842# 0.06627f
C501 a_13123_1842# a_12797_1842# 0.01427f
C502 a_4248_1044# a_4324_1008# 0.01176f
C503 a_6635_1044# a_6425_1044# 0.09424f
C504 MUX_SEL4 a_16108_289# 0.1283f
C505 a_9547_5942# a_9772_5843# 0.02416f
C506 MUX_OUT a_15964_289# 0.01307f
C507 a_9547_6172# a_9746_5805# 0.02437f
C508 a_4350_1044# a_5197_1842# 0.08038f
C509 a_5731_289# a_15964_289# 0.2778f
C510 a_23145_1044# a_22677_1842# 0.19203f
C511 VDD a_13753_1842# 0.49349f
C512 a_4633_1842# a_4763_1842# 0.70845f
C513 a_24957_1842# a_22590_1044# 0.02479f
C514 a_12037_1842# a_11603_1842# 0.6972f
C515 a_12355_5867# REF_CLK 1.0042f
C516 a_12656_5864# DLL_RESETN 0.11782f
C517 a_12993_1842# a_13557_1842# 0.0114f
C518 a_13019_5831# a_12849_5867# 0.12838f
C519 a_16510_1044# a_17357_1842# 0.08038f
C520 a_9547_5942# VDD 0.1511f
C521 a_17791_2470# a_17683_1842# 0.01697f
C522 a_16510_1044# a_18443_1842# 0.01012f
C523 DLL_RESETN a_9444_3912# 0.03031f
C524 VDD a_11473_1842# 0.49417f
C525 DELAY_VBIASP a_8433_1842# 0.11222f
C526 DELAY_VBIASN a_8563_1842# 0.07254f
C527 a_4350_1044# a_4157_1313# 0.04624f
C528 a_6854_5986# a_6126_3816# 0.18536f
C529 a_5974_5723# a_6854_5454# 0.01757f
C530 a_25630_1044# a_26395_1044# 0.39037f
C531 a_10713_1842# a_11277_1842# 0.0114f
C532 a_7151_2470# VDD 0.01806f
C533 a_26673_1842# DELAY_VBIASN 0.105f
C534 a_26477_1842# DELAY_VBIASP 0.04181f
C535 DELAY_VBIASN a_16510_1044# 0.02115f
C536 a_15831_1008# a_15837_1842# 0.02354f
C537 a_6854_5454# a_6326_4590# 1.25249f
C538 a_13306_5105# REF_CLK 0.06166f
C539 a_16271_2470# a_16163_1842# 0.01697f
C540 VDD a_9757_1842# 0.87771f
C541 a_14009_5084# a_12849_5867# 0.03463f
C542 a_21625_1044# a_19550_1044# 0.03208f
C543 a_17683_1842# a_17791_1842# 0.01163f
C544 a_14111_5227# a_13880_5118# 0.12701f
C545 a_9444_4590# a_9444_3912# 2.20289f
C546 a_15108_5325# a_15464_3684# 0.12158f
C547 a_21917_1842# a_22113_1842# 0.76914f
C548 a_9757_1842# a_10517_1842# 0.06198f
C549 a_26803_1842# VDD 0.49671f
C550 a_24957_1842# DELAY_VBIASN 0.10687f
C551 a_23763_1842# DELAY_VBIASP 0.06661f
C552 VDD a_17275_1044# 0.15389f
C553 VDD a_22351_2470# 0.01806f
C554 a_10430_1044# a_10843_1842# 0.01012f
C555 a_14964_1008# a_14317_1842# 0.02312f
C556 a_1256_289# MUX_SEL2 0.33134f
C557 a_14751_2470# a_14643_1842# 0.01697f
C558 a_15304_4605# DLL_RESETN 0.03137f
C559 a_22488_1044# a_22564_1008# 0.01176f
C560 VDD a_7043_1842# 0.49723f
C561 VDD a_1256_1044# 0.475f
C562 VDD a_8884_1008# 0.28225f
C563 a_10751_5878# DLL_RESETN 0.45018f
C564 DELAY_VBIASP a_5393_1842# 0.11222f
C565 DELAY_VBIASN a_5523_1842# 0.07254f
C566 a_16108_289# a_17865_519# 0.29564f
C567 a_13592_5423# a_14757_5182# 0.43239f
C568 a_20593_1842# a_20723_1842# 0.70845f
C569 a_8997_1842# a_8563_1842# 0.6972f
C570 a_25153_1842# VDD 0.49426f
C571 VDD a_14311_1008# 0.28336f
C572 VDD a_16271_2470# 0.01806f
C573 a_10328_1044# a_9757_1842# 0.10864f
C574 a_2019_311# VDD 1.43004f
C575 a_13470_1044# a_13557_1842# 0.1088f
C576 a_13231_2470# a_13123_1842# 0.01697f
C577 a_27433_1842# a_27997_1842# 0.0114f
C578 a_13019_5831# DELAY_OUT_LAST 0.08017f
C579 VDD a_6635_1044# 0.15406f
C580 a_20968_1044# a_20397_1842# 0.10863f
C581 a_9772_5843# DLL_RESETN 0.06592f
C582 VDD a_23145_1044# 0.30409f
C583 VDD a_6717_1842# 0.87726f
C584 DELAY_VBIASP a_22677_1842# 0.04176f
C585 DELAY_VBIASN a_22873_1842# 0.10734f
C586 MUX_SEL4 a_9757_1842# 0.01829f
C587 a_13132_5420# a_13306_5105# 0.27179f
C588 a_15304_4605# a_14757_5182# 0.02225f
C589 a_7673_1842# a_8237_1842# 0.0114f
C590 a_1544_1044# a_1721_1395# 0.38063f
C591 VDD a_11848_1044# 0.17499f
C592 VDD DLL_RESETN 2.47079f
C593 VDD a_10191_2470# 0.01806f
C594 a_7390_1044# a_9757_1842# 0.02479f
C595 a_27991_1008# VDD 0.28201f
C596 a_9675_1044# a_9751_1008# 0.01194f
C597 a_19550_1044# a_20315_1044# 0.39037f
C598 a_26477_1842# a_27237_1842# 0.03319f
C599 a_13306_6305# VDD 0.77573f
C600 a_16408_1044# a_16510_1044# 0.37183f
C601 DELAY_VBIASN a_22590_1044# 0.02115f
C602 a_14009_5084# DELAY_OUT_LAST 0.25594f
C603 VDD a_10985_1044# 0.30409f
C604 VDD a_23003_1842# 0.4973f
C605 VDD a_4003_1842# 0.61559f
C606 DELAY_VBIASN a_21157_1842# 0.09851f
C607 DELAY_VBIASP a_19963_1842# 0.06661f
C608 a_16793_1842# a_16923_1842# 0.70845f
C609 MUX_SEL4 a_1256_1044# 0.04908f
C610 a_6854_5986# a_13121_5831# 0.10056f
C611 a_18877_1842# a_19073_1842# 0.76914f
C612 a_6854_5454# a_9444_3912# 0.8486f
C613 a_8155_1044# a_8231_1008# 0.01194f
C614 a_7390_1044# a_8884_1008# 0.28279f
C615 a_10517_1842# a_10985_1044# 0.19203f
C616 a_7043_1842# a_7477_1842# 0.69698f
C617 a_25717_1842# a_25283_1842# 0.69698f
C618 VDD a_23355_1044# 0.15389f
C619 a_14888_1044# a_14964_1008# 0.01176f
C620 a_11748_6109# a_12158_5867# 0.10373f
C621 MUX_SEL0 MUX_SEL2 0.01204f
C622 MUX_SEL4 a_2019_311# 0.90276f
C623 a_9444_4590# VDD 0.01557f
C624 DELAY_VBIASP a_16163_1842# 0.06661f
C625 DELAY_VBIASN a_17357_1842# 0.10669f
C626 a_5705_519# a_5731_289# 0.28954f
C627 VDD a_21353_1842# 0.49285f
C628 DELAY_VBIASN a_18443_1842# 0.08024f
C629 DELAY_VBIASP a_18313_1842# 0.11284f
C630 a_15837_1842# a_16163_1842# 0.01427f
C631 a_11271_1008# a_10430_1044# 0.28268f
C632 a_14009_5878# a_14757_6228# 0.01058f
C633 a_13880_6292# a_14111_5878# 0.12701f
C634 a_25717_1842# a_26185_1044# 0.19203f
C635 a_16510_1044# a_18585_1044# 0.03208f
C636 MUX_SEL4 a_6717_1842# 0.0195f
C637 a_15964_289# VDD 0.31312f
C638 a_24393_1842# a_24957_1842# 0.0114f
C639 VDD a_20391_1008# 0.28336f
C640 a_13470_1044# a_13444_1008# 0.277f
C641 a_10232_5871# a_10751_5878# 0.34102f
C642 a_10649_5878# a_10520_6292# 0.01562f
C643 MUX_SEL3 a_1256_289# 1.41161f
C644 VDD a_17553_1842# 0.49417f
C645 a_6717_1842# a_7477_1842# 0.06198f
C646 a_12907_5420# VDD 0.07751f
C647 DELAY_VBIASN a_14643_1842# 0.08431f
C648 DELAY_VBIASP a_14513_1842# 0.12091f
C649 a_1721_331# a_2019_311# 0.18452f
C650 VDD a_19637_1842# 0.86707f
C651 a_14111_5878# REF_CLK 0.02263f
C652 a_15077_1842# a_15273_1842# 0.77122f
C653 a_13121_5831# a_15688_5867# 0.17255f
C654 a_12849_5867# a_14851_6228# 0.13392f
C655 a_11603_1842# a_11711_1842# 0.01163f
C656 DELAY_VBIASP a_12233_1842# 0.11222f
C657 a_4350_1044# a_6711_1008# 0.26208f
C658 a_8155_1044# a_7945_1044# 0.09424f
C659 a_9946_6305# a_10206_5835# 0.75507f
C660 a_4350_1044# a_6283_1842# 0.01012f
C661 VDD DELAY_VBIASP 14.6649f
C662 a_25717_1842# a_25604_1008# 0.05157f
C663 VDD a_15837_1842# 0.87963f
C664 a_5957_1842# a_5523_1842# 0.6972f
C665 DELAY_VBIASN a_12993_1842# 0.0961f
C666 a_1256_289# a_1544_289# 1.25711f
C667 a_24957_1842# a_24951_1008# 0.02354f
C668 a_13753_1842# a_13883_1842# 0.70845f
C669 a_13306_6305# a_13566_5835# 0.75507f
C670 a_12849_5867# a_13592_5871# 0.38817f
C671 a_13121_5831# a_14009_5878# 0.01604f
C672 a_10232_5871# VDD 0.07206f
C673 a_23763_1842# a_23437_1842# 0.01427f
C674 a_12715_1044# a_12505_1044# 0.09424f
C675 a_6854_5986# DELAY_VBIASN 0.15808f
C676 a_10083_1842# a_10191_1842# 0.01163f
C677 a_25630_1044# a_26185_1044# 0.03209f
C678 DELAY_VBIASP a_10517_1842# 0.0414f
C679 DELAY_VBIASN a_10713_1842# 0.0961f
C680 a_13557_1842# a_12797_1842# 0.06198f
C681 a_4248_1044# a_4350_1044# 0.37183f
C682 MUX_SEL4 a_15964_289# 0.5544f
C683 a_9547_5942# a_9746_5805# 0.14994f
C684 a_5731_289# a_15765_463# 0.23301f
C685 a_2019_311# a_17865_519# 0.13959f
C686 VDD a_13123_1842# 0.49727f
C687 a_4633_1842# a_5197_1842# 0.0114f
C688 a_27048_1044# a_27124_1008# 0.01176f
C689 a_11473_1842# a_11603_1842# 0.70845f
C690 a_12355_5867# DLL_RESETN 0.04879f
C691 a_17928_1044# a_18004_1008# 0.01176f
C692 a_27563_1842# DELAY_VBIASP 0.06663f
C693 a_12656_5864# a_12849_5867# 0.33075f
C694 a_12355_5867# a_13306_6305# 0.26489f
C695 a_13019_5831# a_13121_5831# 0.56469f
C696 a_6854_5454# VDD 1.03678f
C697 a_16510_1044# a_18877_1842# 0.02479f
C698 a_8563_1842# a_8671_1842# 0.01163f
C699 REF_CLK a_4157_1313# 0.50643f
C700 DLL_RESETN a_5778_3367# 0.01215f
C701 VDD a_10843_1842# 0.4973f
C702 DELAY_VBIASN a_8997_1842# 0.09156f
C703 DELAY_VBIASP a_7803_1842# 0.06627f
C704 MUX_SEL0 a_1721_1395# 0.01315f
C705 MUX_SEL1 a_1544_1044# 0.1672f
C706 a_21625_1044# a_21911_1008# 0.01885f
C707 a_4248_1044# a_4157_1313# 0.11672f
C708 a_14825_519# a_13470_1044# 0.02058f
C709 a_5974_5723# a_6126_3816# 1.74589f
C710 a_22677_1842# a_23437_1842# 0.01669f
C711 a_25630_1044# a_25604_1008# 0.277f
C712 a_6391_2470# VDD 0.01806f
C713 a_26043_1842# DELAY_VBIASN 0.08024f
C714 a_25913_1842# DELAY_VBIASP 0.11284f
C715 a_6126_3816# a_6326_4590# 2.84014f
C716 a_13566_5328# REF_CLK 0.01093f
C717 a_7043_1842# a_7151_1842# 0.01163f
C718 a_22590_1044# a_24951_1008# 0.26208f
C719 VDD a_9193_1842# 0.49285f
C720 a_13592_5423# a_12849_5867# 0.38497f
C721 a_20105_1044# a_19550_1044# 0.03209f
C722 a_22564_1008# a_22677_1842# 0.05157f
C723 DELAY_VBIASP a_7477_1842# 0.0414f
C724 a_14009_5084# a_13880_5118# 0.01562f
C725 a_14851_5182# a_15464_3684# 0.04797f
C726 a_9444_4590# a_5778_3367# 0.19787f
C727 a_21917_1842# a_21483_1842# 0.6972f
C728 a_9757_1842# a_9953_1842# 0.76914f
C729 a_23945_519# a_22590_1044# 0.02165f
C730 a_27237_1842# VDD 0.85969f
C731 a_24197_1842# DELAY_VBIASP 0.04177f
C732 a_24393_1842# DELAY_VBIASN 0.10734f
C733 VDD a_16484_1008# 0.28597f
C734 DELAY_VBIASN a_13470_1044# 0.02115f
C735 a_10430_1044# a_11277_1842# 0.08038f
C736 VDD a_21591_2470# 0.01806f
C737 REF_CLK MUX_SEL1 0.01858f
C738 a_14888_1044# a_14317_1842# 0.10863f
C739 a_22488_1044# a_22590_1044# 0.37183f
C740 a_15304_4605# a_12849_5867# 0.0606f
C741 VDD a_8808_1044# 0.17499f
C742 a_6283_1842# a_6391_1842# 0.01163f
C743 a_13444_1008# a_12797_1842# 0.02011f
C744 DELAY_VBIASN a_5957_1842# 0.09156f
C745 DELAY_VBIASP a_4763_1842# 0.06627f
C746 a_16108_289# a_16851_309# 0.06181f
C747 a_14009_5084# a_14111_5227# 0.47622f
C748 a_20593_1842# a_21157_1842# 0.0114f
C749 a_8433_1842# a_8563_1842# 0.70845f
C750 a_24523_1842# VDD 0.4973f
C751 VDD a_14235_1044# 0.15389f
C752 a_9751_1008# a_9757_1842# 0.02354f
C753 VDD a_15511_2470# 0.01806f
C754 a_5705_519# VDD 0.29556f
C755 a_20968_1044# a_21044_1008# 0.01176f
C756 a_12943_5867# VDD 0.29479f
C757 a_13019_5831# DELAY_VBIASN 1.23663f
C758 VDD a_5844_1008# 0.28225f
C759 a_19550_1044# a_21157_1842# 0.05231f
C760 a_20391_1008# a_20397_1842# 0.02349f
C761 a_4763_1842# a_4871_1842# 0.01163f
C762 a_15688_5403# DELAY_OUT_LAST 0.01699f
C763 VDD a_21625_1044# 0.29722f
C764 MUX_SEL1 a_3449_1395# 0.29404f
C765 VDD a_6153_1842# 0.49285f
C766 a_11924_1008# a_12037_1842# 0.02055f
C767 DELAY_VBIASN a_22243_1842# 0.08024f
C768 a_27563_1842# a_27671_1842# 0.01163f
C769 DELAY_VBIASP a_22113_1842# 0.11286f
C770 DELAY_VBIASN a_9712_3912# 0.22281f
C771 a_18117_1842# a_17683_1842# 0.6972f
C772 a_19637_1842# a_20397_1842# 0.01669f
C773 VDD a_11271_1008# 0.28336f
C774 a_1256_1044# a_1721_1395# 0.13421f
C775 a_8884_1008# a_8237_1842# 0.02312f
C776 VDD a_9431_2470# 0.01806f
C777 a_27915_1044# VDD 0.15389f
C778 a_12037_1842# a_12505_1044# 0.2079f
C779 a_19550_1044# a_19524_1008# 0.277f
C780 a_26477_1842# a_26673_1842# 0.76914f
C781 a_12849_5867# VDD 2.56972f
C782 a_16163_1842# a_16271_1842# 0.01163f
C783 VDD a_27705_1044# 0.29918f
C784 a_19524_1008# a_18877_1842# 0.02011f
C785 a_13592_5423# DELAY_OUT_LAST 0.08062f
C786 VDD a_9465_1044# 0.29722f
C787 VDD a_23437_1842# 0.86909f
C788 VDD a_4437_1842# 0.86998f
C789 DELAY_VBIASN a_20593_1842# 0.10398f
C790 a_26043_1842# a_26151_1842# 0.01163f
C791 DELAY_VBIASP a_20397_1842# 0.04176f
C792 a_16793_1842# a_17357_1842# 0.0114f
C793 a_18877_1842# a_18443_1842# 0.6972f
C794 a_14851_6228# a_14757_6228# 0.28931f
C795 a_5974_5723# a_5864_3367# 0.01697f
C796 a_6854_5454# a_5778_3367# 0.02695f
C797 a_6854_5986# a_9712_3912# 0.83268f
C798 a_6126_3816# a_9444_3912# 0.25721f
C799 a_7390_1044# a_8808_1044# 0.38994f
C800 a_7043_1842# a_6913_1842# 0.70845f
C801 a_25153_1842# a_25283_1842# 0.70845f
C802 VDD a_22564_1008# 0.28633f
C803 DELAY_VBIASN a_19550_1044# 0.02115f
C804 a_11748_6109# a_11491_6228# 0.34468f
C805 MUX_SEL0 MUX_SEL1 3.14917f
C806 a_14643_1842# a_14751_1842# 0.01163f
C807 MUX_SEL4 a_5705_519# 0.03556f
C808 MUX_SEL3 a_2019_311# 0.06209f
C809 DELAY_VBIASN a_16793_1842# 0.10734f
C810 DELAY_VBIASP a_16597_1842# 0.04176f
C811 a_15304_4605# DELAY_OUT_LAST 0.05582f
C812 VDD a_20723_1842# 0.49671f
C813 a_5864_3367# a_6326_4590# 0.01889f
C814 a_24523_1842# a_24631_1842# 0.01163f
C815 DELAY_VBIASN a_18877_1842# 0.10687f
C816 a_15837_1842# a_16597_1842# 0.06198f
C817 a_11195_1044# a_10430_1044# 0.39037f
C818 a_13592_5871# a_14757_6228# 0.43239f
C819 a_16510_1044# a_17065_1044# 0.03209f
C820 a_15765_463# VDD 0.35368f
C821 VDD a_20315_1044# 0.15389f
C822 a_13368_1044# a_13444_1008# 0.01176f
C823 a_7288_1044# a_6717_1842# 0.10864f
C824 a_10232_5871# a_10520_6292# 0.43707f
C825 a_26477_1842# a_27124_1008# 0.02312f
C826 a_13123_1842# a_13231_1842# 0.01163f
C827 VDD a_16923_1842# 0.4973f
C828 a_12907_5186# VDD 0.06323f
C829 a_6717_1842# a_6913_1842# 0.76914f
C830 DELAY_VBIASP a_13883_1842# 0.06627f
C831 DELAY_VBIASN a_15077_1842# 0.10039f
C832 a_1544_289# a_2019_311# 0.01747f
C833 VDD a_19073_1842# 0.49426f
C834 a_15077_1842# a_14643_1842# 0.6972f
C835 a_12849_5867# a_15108_6109# 0.10225f
C836 a_13306_6305# a_14111_5878# 0.097f
C837 a_13019_5831# a_15688_5867# 0.0195f
C838 a_13121_5831# a_14851_6228# 0.03404f
C839 a_12158_5867# VDD 0.37862f
C840 a_2019_311# a_4350_1044# 0.02042f
C841 a_14311_1008# a_14025_1044# 0.01885f
C842 DELAY_VBIASP a_11603_1842# 0.06627f
C843 DELAY_VBIASN a_12797_1842# 0.09992f
C844 a_4350_1044# a_6635_1044# 0.39036f
C845 a_7390_1044# a_9465_1044# 0.03208f
C846 a_4350_1044# a_6717_1842# 0.02479f
C847 a_25717_1842# a_25630_1044# 0.1088f
C848 VDD DELAY_OUT_LAST 0.70591f
C849 VDD a_15273_1842# 0.49298f
C850 a_5393_1842# a_5523_1842# 0.70845f
C851 DELAY_VBIASN a_12363_1842# 0.07254f
C852 a_13753_1842# a_14317_1842# 0.0114f
C853 a_13121_5831# a_13592_5871# 0.01445f
C854 a_12849_5867# a_13566_5835# 0.27346f
C855 a_10206_5835# VDD 0.09392f
C856 a_24197_1842# a_23437_1842# 0.03319f
C857 a_2019_311# a_4157_1313# 0.01018f
C858 DELAY_VBIASP a_9953_1842# 0.11222f
C859 DELAY_VBIASN a_10083_1842# 0.07254f
C860 a_12993_1842# a_12797_1842# 0.76914f
C861 a_9547_5942# a_9547_6172# 0.1117f
C862 MUX_SEL4 a_15765_463# 0.65508f
C863 a_4324_1008# a_4437_1842# 0.05157f
C864 a_2019_311# a_16851_309# 0.01299f
C865 a_5731_289# a_14825_519# 0.28056f
C866 VDD a_13557_1842# 0.86707f
C867 a_11473_1842# a_12037_1842# 0.0114f
C868 a_27997_1842# DELAY_VBIASP 0.04038f
C869 a_12355_5867# a_12849_5867# 0.07687f
C870 a_16484_1008# a_16597_1842# 0.05157f
C871 a_6126_3816# VDD 0.84141f
C872 REF_CLK a_3449_1395# 0.01058f
C873 VDD a_11277_1842# 0.86909f
C874 DELAY_VBIASP a_8237_1842# 0.0414f
C875 DELAY_VBIASN a_8433_1842# 0.0961f
C876 MUX_SEL1 a_1256_1044# 1.44243f
C877 MUX_SEL0 a_1544_1044# 0.07603f
C878 a_15688_5403# a_13121_5831# 0.01441f
C879 a_15108_5325# a_12849_5867# 0.10521f
C880 DELAY_VBIASN a_10430_1044# 0.02115f
C881 a_21625_1044# a_21835_1044# 0.09424f
C882 a_13019_5831# a_9712_3912# 0.03275f
C883 a_24084_1008# a_23437_1842# 0.02312f
C884 a_5974_5723# a_6854_5986# 0.029f
C885 a_22677_1842# a_22873_1842# 0.73897f
C886 a_4437_1842# a_4905_1044# 0.19203f
C887 a_9444_3912# a_5864_3367# 0.02483f
C888 a_10517_1842# a_11277_1842# 0.01669f
C889 a_5631_2470# VDD 0.01806f
C890 a_26477_1842# DELAY_VBIASN 0.1083f
C891 a_25283_1842# DELAY_VBIASP 0.06661f
C892 a_6854_5986# a_6326_4590# 1.31745f
C893 a_13132_5420# REF_CLK 0.02025f
C894 a_22590_1044# a_24875_1044# 0.39036f
C895 VDD a_8563_1842# 0.49671f
C896 a_13306_5105# a_12849_5867# 0.10976f
C897 a_22590_1044# a_22677_1842# 0.1088f
C898 DELAY_VBIASP a_6913_1842# 0.11222f
C899 a_13592_5423# a_13880_5118# 0.43707f
C900 a_14851_5182# a_14757_5182# 0.28931f
C901 a_25630_1044# a_16108_289# 0.55833f
C902 a_21353_1842# a_21483_1842# 0.70845f
C903 a_9757_1842# a_9323_1842# 0.6972f
C904 a_26673_1842# VDD 0.49417f
C905 a_23763_1842# DELAY_VBIASN 0.08024f
C906 VDD a_16510_1044# 0.8795f
C907 VDD a_20831_2470# 0.01806f
C908 REF_CLK MUX_SEL0 0.14089f
C909 a_13470_1044# a_15077_1842# 0.05231f
C910 a_14311_1008# a_14317_1842# 0.02349f
C911 a_16108_289# a_21917_1842# 0.0157f
C912 a_15304_4605# a_13121_5831# 0.40921f
C913 VDD a_8231_1008# 0.28336f
C914 a_10649_5878# REF_CLK 0.25484f
C915 DELAY_VBIASP a_5197_1842# 0.0414f
C916 DELAY_VBIASN a_5393_1842# 0.0961f
C917 a_13592_5423# a_14111_5227# 0.34114f
C918 a_15964_289# a_16851_309# 0.16757f
C919 a_12158_5867# a_12355_5867# 0.12454f
C920 a_20397_1842# a_20723_1842# 0.01427f
C921 a_8433_1842# a_8997_1842# 0.0114f
C922 a_24957_1842# VDD 0.87825f
C923 VDD a_13444_1008# 0.28633f
C924 VDD a_14751_2470# 0.01806f
C925 a_3449_331# VDD 0.46596f
C926 a_17275_1044# a_17351_1008# 0.01194f
C927 VDD a_5768_1044# 0.17499f
C928 a_15108_5325# DELAY_OUT_LAST 0.01399f
C929 VDD a_20105_1044# 0.30409f
C930 VDD a_5523_1842# 0.49671f
C931 MUX_SEL0 a_3449_1395# 0.10753f
C932 DELAY_VBIASP a_21483_1842# 0.06661f
C933 DELAY_VBIASN a_22677_1842# 0.0907f
C934 a_17553_1842# a_17683_1842# 0.70845f
C935 a_15304_4605# a_14111_5227# 0.01761f
C936 a_19637_1842# a_19833_1842# 0.73897f
C937 a_1256_1044# a_1544_1044# 1.26509f
C938 VDD a_11195_1044# 0.15389f
C939 VDD a_8671_2470# 0.01806f
C940 a_8808_1044# a_8237_1842# 0.10863f
C941 a_27124_1008# VDD 0.28225f
C942 a_19448_1044# a_19524_1008# 0.01176f
C943 a_26477_1842# a_26043_1842# 0.6972f
C944 a_13121_5831# VDD 0.99724f
C945 VDD a_25528_1044# 0.17274f
C946 a_18117_1842# a_18004_1008# 0.02055f
C947 a_13880_5118# VDD 0.02994f
C948 DELAY_VBIASP a_17683_1842# 0.06661f
C949 a_5731_289# a_8745_519# 0.28635f
C950 VDD a_7945_1044# 0.30409f
C951 VDD a_22873_1842# 0.49294f
C952 VDD a_5864_3367# 0.13532f
C953 DELAY_VBIASP a_19833_1842# 0.11284f
C954 DELAY_VBIASN a_19963_1842# 0.08024f
C955 a_18313_1842# a_18443_1842# 0.70845f
C956 a_14851_6228# a_15688_5867# 0.08776f
C957 a_26985_519# VDD 0.29292f
C958 a_6126_3816# a_5778_3367# 1.6143f
C959 a_5974_5723# a_9712_3912# 0.01152f
C960 a_7390_1044# a_8231_1008# 0.28268f
C961 a_25153_1842# a_25717_1842# 0.0114f
C962 VDD a_22590_1044# 0.89557f
C963 a_13470_1044# a_15831_1008# 0.26208f
C964 a_10751_5878# a_11491_6228# 0.26905f
C965 a_5731_289# a_13470_1044# 0.41365f
C966 MUX_SEL4 a_3449_331# 0.05166f
C967 a_14111_5227# VDD 0.33926f
C968 DELAY_VBIASN a_16163_1842# 0.08306f
C969 DELAY_VBIASP a_16033_1842# 0.11287f
C970 a_15304_4605# DELAY_VBIASN 0.07802f
C971 VDD a_2873_1395# 0.46517f
C972 VDD a_21157_1842# 0.85848f
C973 a_9712_3912# a_6326_4590# 0.04741f
C974 DELAY_VBIASN a_18313_1842# 0.10734f
C975 a_15837_1842# a_16033_1842# 0.76914f
C976 a_10404_1008# a_10430_1044# 0.277f
C977 a_23111_2470# a_23003_1842# 0.01697f
C978 a_14825_519# VDD 0.29292f
C979 a_6854_5986# a_13592_5423# 0.01958f
C980 a_6635_1044# a_6711_1008# 0.01194f
C981 a_24197_1842# a_24957_1842# 0.02912f
C982 VDD a_19524_1008# 0.28633f
C983 a_9751_1008# a_9465_1044# 0.01885f
C984 a_13368_1044# a_13470_1044# 0.37183f
C985 a_6711_1008# a_6717_1842# 0.02354f
C986 a_26477_1842# a_27048_1044# 0.10863f
C987 VDD a_17357_1842# 0.86909f
C988 a_13106_5357# VDD 0.09228f
C989 a_6717_1842# a_6283_1842# 0.6972f
C990 DELAY_VBIASP a_14317_1842# 0.04316f
C991 DELAY_VBIASN a_14513_1842# 0.102f
C992 a_1256_289# a_2019_311# 0.02904f
C993 VDD a_18443_1842# 0.4973f
C994 a_14513_1842# a_14643_1842# 0.70845f
C995 a_12849_5867# a_14111_5878# 0.42174f
C996 a_13121_5831# a_15108_6109# 0.03701f
C997 a_13592_5871# a_14009_5878# 0.37583f
C998 a_13019_5831# a_14851_6228# 0.01651f
C999 a_13306_6305# a_13880_6292# 0.31978f
C1000 a_11491_6228# VDD 0.16753f
C1001 a_5705_519# a_4350_1044# 0.02005f
C1002 a_14235_1044# a_14025_1044# 0.09424f
C1003 a_21591_2470# a_21483_1842# 0.01697f
C1004 a_6854_5986# a_15304_4605# 0.08165f
C1005 DELAY_VBIASN a_12233_1842# 0.0961f
C1006 DELAY_VBIASP a_12037_1842# 0.04141f
C1007 a_4350_1044# a_5844_1008# 0.28279f
C1008 a_5115_1044# a_5191_1008# 0.01194f
C1009 a_23111_1842# a_23003_1842# 0.01163f
C1010 a_7390_1044# a_7945_1044# 0.03209f
C1011 a_17865_519# a_16510_1044# 0.02165f
C1012 a_11848_1044# a_11924_1008# 0.01176f
C1013 a_5844_1008# a_5197_1842# 0.02312f
C1014 DLL_RESETN REF_CLK 10.7961f
C1015 VDD DELAY_VBIASN 1.49209f
C1016 a_7477_1842# a_7945_1044# 0.19203f
C1017 VDD a_14643_1842# 0.49675f
C1018 a_5393_1842# a_5957_1842# 0.0114f
C1019 a_13306_6305# REF_CLK 0.05059f
C1020 a_11785_519# a_10430_1044# 0.02058f
C1021 a_13121_5831# a_13566_5835# 0.01158f
C1022 a_13019_5831# a_13592_5871# 0.04178f
C1023 REF_CLK a_4003_1842# 0.55467f
C1024 a_20071_2470# a_19963_1842# 0.01697f
C1025 DELAY_VBIASP a_9323_1842# 0.06627f
C1026 DELAY_VBIASN a_10517_1842# 0.08375f
C1027 a_12363_1842# a_12797_1842# 0.6972f
C1028 a_23145_1044# a_23431_1008# 0.01885f
C1029 a_21591_1842# a_21483_1842# 0.01163f
C1030 VDD a_27671_2470# 0.01806f
C1031 MUX_SEL4 a_14825_519# 0.03307f
C1032 a_4350_1044# a_4437_1842# 0.1088f
C1033 a_2019_311# a_16108_289# 0.33889f
C1034 a_5731_289# a_11785_519# 0.28056f
C1035 a_5957_1842# a_6425_1044# 0.2079f
C1036 VDD a_12993_1842# 0.49426f
C1037 a_4437_1842# a_5197_1842# 0.01669f
C1038 a_25630_1044# a_27991_1008# 0.26208f
C1039 a_24197_1842# a_22590_1044# 0.05231f
C1040 a_11277_1842# a_11603_1842# 0.01427f
C1041 a_16510_1044# a_18871_1008# 0.26208f
C1042 a_27563_1842# DELAY_VBIASN 0.08029f
C1043 a_27997_1842# DELAY_OUT_LAST 0.70957f
C1044 a_27433_1842# DELAY_VBIASP 0.11284f
C1045 a_12355_5867# a_13121_5831# 0.05795f
C1046 a_12656_5864# a_13019_5831# 0.04193f
C1047 a_16510_1044# a_16597_1842# 0.1088f
C1048 a_6854_5986# VDD 1.20794f
C1049 a_24875_1044# a_24951_1008# 0.01194f
C1050 a_18551_2470# a_18443_1842# 0.01697f
C1051 VDD a_10713_1842# 0.49294f
C1052 DELAY_VBIASN a_7803_1842# 0.07254f
C1053 DELAY_VBIASP a_7673_1842# 0.11222f
C1054 MUX_SEL0 a_1256_1044# 0.3314f
C1055 a_14851_5182# a_12849_5867# 0.13376f
C1056 a_15108_5325# a_13121_5831# 0.05903f
C1057 a_15304_4605# a_15688_5867# 0.19136f
C1058 a_15688_5403# a_13019_5831# 0.1287f
C1059 a_24008_1044# a_23437_1842# 0.10863f
C1060 a_20071_1842# a_19963_1842# 0.01163f
C1061 a_4437_1842# a_4157_1313# 0.01771f
C1062 a_22677_1842# a_22243_1842# 0.69698f
C1063 a_9444_3912# a_9712_3912# 0.72189f
C1064 a_5778_3367# a_5864_3367# 0.07306f
C1065 a_27563_1842# a_27671_2470# 0.01697f
C1066 a_10517_1842# a_10713_1842# 0.73897f
C1067 a_4871_2470# VDD 0.01806f
C1068 a_25913_1842# DELAY_VBIASN 0.10734f
C1069 a_25717_1842# DELAY_VBIASP 0.04176f
C1070 a_10430_1044# a_12797_1842# 0.02479f
C1071 a_3449_331# MUX_SEL2 0.10741f
C1072 a_5974_5723# a_6326_4590# 0.33136f
C1073 a_13132_5420# DLL_RESETN 0.01689f
C1074 a_23355_1044# a_23431_1008# 0.01194f
C1075 a_22590_1044# a_24084_1008# 0.28279f
C1076 VDD a_8997_1842# 0.85848f
C1077 VDD a_2297_1395# 0.46536f
C1078 a_13566_5328# a_12849_5867# 0.26617f
C1079 DELAY_VBIASN a_7390_1044# 0.02115f
C1080 a_18551_1842# a_18443_1842# 0.01163f
C1081 a_10430_1044# a_12363_1842# 0.01012f
C1082 DELAY_VBIASN a_7477_1842# 0.08375f
C1083 DELAY_VBIASP a_6283_1842# 0.06627f
C1084 a_14111_5227# a_15108_5325# 0.03012f
C1085 a_13306_5105# a_13880_5118# 0.31978f
C1086 a_21353_1842# a_21917_1842# 0.0114f
C1087 a_26043_1842# a_26151_2470# 0.01697f
C1088 a_9193_1842# a_9323_1842# 0.70845f
C1089 a_26043_1842# VDD 0.4973f
C1090 a_24197_1842# DELAY_VBIASN 0.09851f
C1091 VDD a_16408_1044# 0.17274f
C1092 VDD a_20071_2470# 0.01806f
C1093 REF_CLK DELAY_VBIASP 2.13371f
C1094 a_8745_519# VDD 0.29292f
C1095 a_15688_5867# VDD 0.30345f
C1096 a_15304_4605# a_13019_5831# 0.07025f
C1097 VDD a_8155_1044# 0.15389f
C1098 a_10232_5871# REF_CLK 0.08086f
C1099 a_10649_5878# DLL_RESETN 0.05713f
C1100 a_7151_2470# a_7043_1842# 0.01697f
C1101 a_13368_1044# a_12797_1842# 0.10864f
C1102 DELAY_VBIASP a_23633_1842# 0.11286f
C1103 DELAY_VBIASP a_4633_1842# 0.11222f
C1104 DELAY_VBIASN a_4763_1842# 0.07254f
C1105 a_15964_289# a_16108_289# 0.42202f
C1106 a_13592_5423# a_14009_5084# 0.3749f
C1107 a_13306_5105# a_14111_5227# 0.097f
C1108 a_20397_1842# a_21157_1842# 0.03319f
C1109 a_24523_1842# a_24631_2470# 0.01697f
C1110 a_8237_1842# a_8563_1842# 0.01427f
C1111 a_20905_519# a_19550_1044# 0.02165f
C1112 a_24393_1842# VDD 0.49285f
C1113 VDD a_13470_1044# 0.87936f
C1114 VDD a_13991_2470# 0.01806f
C1115 a_2873_331# VDD 0.46491f
C1116 a_25630_1044# DELAY_VBIASP 0.01522f
C1117 a_27237_1842# a_27433_1842# 0.77122f
C1118 a_19550_1044# a_21911_1008# 0.26208f
C1119 a_14009_5878# VDD 0.23872f
C1120 a_16510_1044# a_17928_1044# 0.38994f
C1121 VDD a_5191_1008# 0.28565f
C1122 a_19550_1044# a_19963_1842# 0.01012f
C1123 a_14851_5182# DELAY_OUT_LAST 0.02109f
C1124 VDD a_18585_1044# 0.29722f
C1125 VDD a_5957_1842# 0.85848f
C1126 DELAY_VBIASN a_22113_1842# 0.10263f
C1127 DELAY_VBIASP a_21917_1842# 0.04176f
C1128 a_17553_1842# a_18117_1842# 0.0114f
C1129 a_12907_5420# a_13132_5420# 0.02416f
C1130 a_10951_2470# a_10843_1842# 0.01697f
C1131 a_13557_1842# a_14025_1044# 0.19203f
C1132 a_19637_1842# a_19203_1842# 0.69698f
C1133 a_5731_289# a_10430_1044# 0.41176f
C1134 a_6391_2470# a_6283_1842# 0.01697f
C1135 VDD a_10404_1008# 0.28633f
C1136 a_7390_1044# a_8997_1842# 0.05231f
C1137 a_8231_1008# a_8237_1842# 0.02349f
C1138 a_27048_1044# VDD 0.17499f
C1139 a_19448_1044# a_19550_1044# 0.37183f
C1140 a_25913_1842# a_26043_1842# 0.70845f
C1141 a_13019_5831# VDD 0.41932f
C1142 VDD a_24951_1008# 0.2822f
C1143 MUX_SEL4 a_8745_519# 0.04472f
C1144 MUX_OUT a_5731_289# 1.04829f
C1145 a_19448_1044# a_18877_1842# 0.10864f
C1146 DELAY_VBIASP a_18117_1842# 0.04177f
C1147 VDD a_22243_1842# 0.49737f
C1148 VDD a_9712_3912# 0.23242f
C1149 DELAY_VBIASN a_20397_1842# 0.10669f
C1150 a_10404_1008# a_10517_1842# 0.05157f
C1151 DELAY_VBIASP a_19203_1842# 0.06661f
C1152 a_16597_1842# a_17357_1842# 0.01669f
C1153 a_9431_2470# a_9323_1842# 0.01697f
C1154 a_18313_1842# a_18877_1842# 0.0114f
C1155 a_8745_519# a_7390_1044# 0.01756f
C1156 a_4871_2470# a_4763_1842# 0.01697f
C1157 a_23945_519# VDD 0.29292f
C1158 a_7390_1044# a_8155_1044# 0.39037f
C1159 a_7043_1842# a_6717_1842# 0.01427f
C1160 a_24957_1842# a_25283_1842# 0.01427f
C1161 VDD a_22488_1044# 0.17274f
C1162 a_13470_1044# a_15755_1044# 0.39036f
C1163 a_10649_5878# a_11397_6228# 0.01058f
C1164 a_10751_5878# a_11748_6109# 0.03061f
C1165 MUX_SEL4 a_13470_1044# 0.256f
C1166 MUX_SEL3 a_3449_331# 0.28429f
C1167 MUX_SEL4 a_2873_331# 0.04916f
C1168 MUX_OUT a_2297_331# 0.01179f
C1169 a_14009_5084# VDD 0.31815f
C1170 DELAY_VBIASN a_16597_1842# 0.0907f
C1171 DELAY_VBIASP a_15403_1842# 0.06668f
C1172 VDD a_20593_1842# 0.49417f
C1173 a_15837_1842# a_15403_1842# 0.6972f
C1174 a_10404_1008# a_10328_1044# 0.01176f
C1175 a_13592_5871# a_14851_6228# 0.01529f
C1176 a_11785_519# VDD 0.29292f
C1177 a_24197_1842# a_24393_1842# 0.77122f
C1178 VDD a_19550_1044# 0.89766f
C1179 a_9675_1044# a_9465_1044# 0.09424f
C1180 a_10232_5871# a_10649_5878# 0.37583f
C1181 a_9946_6305# a_10751_5878# 0.097f
C1182 a_27237_1842# a_25630_1044# 0.05253f
C1183 a_26477_1842# a_26471_1008# 0.02349f
C1184 VDD a_16793_1842# 0.49277f
C1185 a_6153_1842# a_6283_1842# 0.70845f
C1186 DELAY_VBIASP a_13753_1842# 0.11222f
C1187 DELAY_VBIASN a_13883_1842# 0.07254f
C1188 VDD a_18877_1842# 0.87825f
C1189 a_14513_1842# a_15077_1842# 0.0114f
C1190 a_13566_5835# a_14009_5878# 0.02242f
C1191 a_13121_5831# a_14111_5878# 0.0235f
C1192 a_11748_6109# VDD 0.16819f
C1193 a_13470_1044# a_15545_1044# 0.03208f
C1194 DELAY_VBIASN a_11603_1842# 0.07254f
C1195 DELAY_VBIASP a_11473_1842# 0.11222f
C1196 a_4350_1044# a_5768_1044# 0.38994f
C1197 a_16851_309# a_16510_1044# 0.02131f
C1198 a_9772_5843# a_9946_6305# 0.27179f
C1199 a_5768_1044# a_5197_1842# 0.10863f
C1200 a_24957_1842# a_25604_1008# 0.02011f
C1201 VDD a_15077_1842# 0.85965f
C1202 a_5197_1842# a_5523_1842# 0.01427f
C1203 a_12233_1842# a_12797_1842# 0.0114f
C1204 a_12849_5867# REF_CLK 0.26382f
C1205 a_13557_1842# a_14317_1842# 0.01669f
C1206 a_17928_1044# a_17357_1842# 0.10863f
C1207 a_9946_6305# VDD 0.77198f
C1208 REF_CLK a_4437_1842# 0.05209f
C1209 VDD a_12797_1842# 0.87771f
C1210 DELAY_VBIASP a_9757_1842# 0.0414f
C1211 DELAY_VBIASN a_9953_1842# 0.0961f
C1212 a_12363_1842# a_12233_1842# 0.70845f
C1213 a_23145_1044# a_23355_1044# 0.09424f
C1214 VDD a_26911_2470# 0.01806f
C1215 a_5191_1008# a_4905_1044# 0.01885f
C1216 MUX_SEL4 a_11785_519# 0.03255f
C1217 a_2019_311# a_15964_289# 0.02413f
C1218 a_23437_1842# a_23633_1842# 0.76914f
C1219 VDD a_12363_1842# 0.4973f
C1220 a_4437_1842# a_4633_1842# 0.73897f
C1221 a_25630_1044# a_27915_1044# 0.39036f
C1222 a_11277_1842# a_12037_1842# 0.03319f
C1223 a_16510_1044# a_18795_1044# 0.39036f
C1224 a_26803_1842# DELAY_VBIASP 0.06661f
C1225 a_27997_1842# DELAY_VBIASN 0.04657f
C1226 a_25604_1008# a_25528_1044# 0.01176f
C1227 a_12355_5867# a_13019_5831# 0.3846f
C1228 a_5974_5723# VDD 0.91576f
C1229 a_9444_4590# DLL_RESETN 0.10275f
C1230 a_25630_1044# a_27705_1044# 0.03208f
C1231 a_17031_2470# a_16923_1842# 0.01697f
C1232 VDD a_10083_1842# 0.49727f
C1233 DELAY_VBIASP a_7043_1842# 0.06627f
C1234 DELAY_VBIASN a_8237_1842# 0.09974f
C1235 a_15304_4605# a_14851_6228# 0.12139f
C1236 a_14851_5182# a_13121_5831# 0.03337f
C1237 a_23431_1008# a_23437_1842# 0.02349f
C1238 VDD a_6326_4590# 7.53039f
C1239 a_22113_1842# a_22243_1842# 0.70845f
C1240 a_10517_1842# a_10083_1842# 0.69698f
C1241 a_4111_2470# VDD 0.01866f
C1242 a_25283_1842# DELAY_VBIASN 0.08024f
C1243 a_25153_1842# DELAY_VBIASP 0.11284f
C1244 a_2873_331# MUX_SEL2 0.01422f
C1245 a_15511_2470# a_15403_1842# 0.01697f
C1246 a_12907_5420# DLL_RESETN 0.04234f
C1247 a_22590_1044# a_24008_1044# 0.38994f
C1248 VDD a_8433_1842# 0.49417f
C1249 a_13132_5420# a_12849_5867# 0.06758f
C1250 VDD a_10430_1044# 0.88416f
C1251 a_16923_1842# a_17031_1842# 0.01163f
C1252 a_18585_1044# a_18871_1008# 0.01885f
C1253 a_12158_5867# REF_CLK 0.01309f
C1254 a_22564_1008# a_21917_1842# 0.02011f
C1255 MUX_SEL4 a_12797_1842# 0.01829f
C1256 DELAY_VBIASP a_6717_1842# 0.0414f
C1257 DELAY_VBIASN a_6913_1842# 0.0961f
C1258 a_14111_5227# a_14851_5182# 0.26905f
C1259 a_9193_1842# a_9757_1842# 0.0114f
C1260 a_26477_1842# VDD 0.86909f
C1261 MUX_OUT VDD 0.35871f
C1262 VDD a_15831_1008# 0.2816f
C1263 VDD a_19311_2470# 0.01806f
C1264 a_10430_1044# a_10517_1842# 0.1088f
C1265 DLL_RESETN DELAY_VBIASP 0.07017f
C1266 a_5731_289# VDD 0.6143f
C1267 a_13470_1044# a_13883_1842# 0.01012f
C1268 a_13991_2470# a_13883_1842# 0.01697f
C1269 a_14851_6228# VDD 0.25326f
C1270 VDD a_7364_1008# 0.28633f
C1271 DELAY_VBIASN a_4350_1044# 0.02115f
C1272 a_10232_5871# DLL_RESETN 0.39088f
C1273 a_21044_1008# a_21157_1842# 0.02055f
C1274 DELAY_VBIASP a_23003_1842# 0.06661f
C1275 DELAY_VBIASN a_5197_1842# 0.09974f
C1276 a_12791_1008# a_12797_1842# 0.02354f
C1277 DELAY_VBIASP a_4003_1842# 0.05992f
C1278 a_13306_5105# a_14009_5084# 0.02454f
C1279 a_15765_463# a_16108_289# 0.42004f
C1280 a_15077_1842# a_15545_1044# 0.2079f
C1281 a_20397_1842# a_20593_1842# 0.76914f
C1282 a_8237_1842# a_8997_1842# 0.03319f
C1283 a_23763_1842# VDD 0.49671f
C1284 VDD a_13368_1044# 0.17274f
C1285 VDD a_13231_2470# 0.01806f
C1286 a_2297_331# VDD 0.46496f
C1287 a_10328_1044# a_10430_1044# 0.37183f
C1288 a_12471_2470# a_12363_1842# 0.01697f
C1289 a_19550_1044# a_21835_1044# 0.39036f
C1290 a_27237_1842# a_26803_1842# 0.6972f
C1291 a_13592_5871# VDD 0.07242f
C1292 a_16510_1044# a_17351_1008# 0.28268f
C1293 VDD a_5115_1044# 0.15389f
C1294 a_19550_1044# a_20397_1842# 0.08038f
C1295 a_6854_5454# DLL_RESETN 0.03626f
C1296 VDD a_17065_1044# 0.30218f
C1297 DELAY_VBIASN a_4157_1313# 0.01202f
C1298 MUX_SEL1 a_2873_1395# 0.13092f
C1299 VDD a_5393_1842# 0.49417f
C1300 DELAY_VBIASN a_21483_1842# 0.08024f
C1301 DELAY_VBIASP a_21353_1842# 0.11284f
C1302 a_11924_1008# a_11277_1842# 0.02312f
C1303 DELAY_OUT_LAST a_15464_3684# 0.02565f
C1304 a_17357_1842# a_17683_1842# 0.01427f
C1305 a_15304_4605# a_13592_5423# 0.01817f
C1306 MUX_SEL4 a_10430_1044# 0.24983f
C1307 a_19073_1842# a_19203_1842# 0.70845f
C1308 a_26471_1008# VDD 0.28336f
C1309 a_15964_289# a_15837_1842# 0.02f
C1310 a_8808_1044# a_8884_1008# 0.01176f
C1311 a_25913_1842# a_26477_1842# 0.0114f
C1312 a_12656_5864# VDD 0.26066f
C1313 VDD a_24875_1044# 0.15406f
C1314 a_15755_1044# a_15831_1008# 0.01194f
C1315 MUX_SEL4 MUX_OUT 0.91933f
C1316 MUX_SEL4 a_5731_289# 4.60702f
C1317 a_18871_1008# a_18877_1842# 0.02354f
C1318 a_15688_5403# VDD 0.30345f
C1319 DELAY_VBIASN a_17683_1842# 0.07847f
C1320 DELAY_VBIASP a_17553_1842# 0.11284f
C1321 VDD a_6425_1044# 0.29722f
C1322 VDD a_22677_1842# 0.86707f
C1323 VDD a_9444_3912# 0.0107f
C1324 DELAY_VBIASP a_19637_1842# 0.04176f
C1325 DELAY_VBIASN a_19833_1842# 0.10734f
C1326 a_16597_1842# a_16793_1842# 0.73897f
C1327 a_12791_1008# a_10430_1044# 0.26208f
C1328 a_15108_6109# a_14851_6228# 0.29858f
C1329 a_5731_289# a_7390_1044# 0.41331f
C1330 a_20905_519# VDD 0.29292f
C1331 a_6854_5454# a_9444_4590# 1.25013f
C1332 a_5974_5723# a_5778_3367# 2.88221f
C1333 a_7390_1044# a_7364_1008# 0.277f
C1334 a_24957_1842# a_25717_1842# 0.06198f
C1335 VDD a_21911_1008# 0.2822f
C1336 a_13470_1044# a_14964_1008# 0.28279f
C1337 a_10232_5871# a_11397_6228# 0.43239f
C1338 a_14235_1044# a_14311_1008# 0.01194f
C1339 a_7364_1008# a_7477_1842# 0.05157f
C1340 MUX_SEL4 a_2297_331# 0.04338f
C1341 MUX_SEL3 a_2873_331# 0.12606f
C1342 a_13592_5423# VDD 0.11685f
C1343 DELAY_VBIASP a_15837_1842# 0.04182f
C1344 DELAY_VBIASN a_16033_1842# 0.10793f
C1345 a_5705_519# a_2019_311# 0.13872f
C1346 VDD a_19963_1842# 0.4973f
C1347 a_5778_3367# a_6326_4590# 0.8779f
C1348 a_15273_1842# a_15403_1842# 0.70845f
C1349 a_14009_5878# a_14111_5878# 0.47795f
C1350 a_15831_1008# a_15545_1044# 0.01885f
C1351 a_24197_1842# a_23763_1842# 0.6972f
C1352 VDD a_19448_1044# 0.17274f
C1353 a_10206_5835# a_10649_5878# 0.02242f
C1354 a_9946_6305# a_10520_6292# 0.31978f
C1355 a_3449_331# REF_CLK 0.01017f
C1356 VDD a_16163_1842# 0.4973f
C1357 a_15304_4605# VDD 0.72158f
C1358 a_6153_1842# a_6717_1842# 0.0114f
C1359 DELAY_VBIASP a_13123_1842# 0.06627f
C1360 DELAY_VBIASN a_14317_1842# 0.09974f
C1361 VDD a_18313_1842# 0.49285f
C1362 a_12943_5867# DLL_RESETN 0.03616f
C1363 a_14317_1842# a_14643_1842# 0.01427f
C1364 a_13566_5835# a_13592_5871# 0.36952f
C1365 a_10751_5878# VDD 0.20377f
C1366 a_13470_1044# a_14025_1044# 0.03209f
C1367 a_10843_1842# a_10951_1842# 0.01163f
C1368 DELAY_VBIASN a_12037_1842# 0.09156f
C1369 DELAY_VBIASP a_10843_1842# 0.06627f
C1370 a_4350_1044# a_5191_1008# 0.28268f
C1371 a_16108_289# a_16510_1044# 0.56108f
C1372 a_4350_1044# a_5957_1842# 0.05231f
C1373 a_5191_1008# a_5197_1842# 0.02349f
C1374 VDD a_14513_1842# 0.49436f
C1375 a_5197_1842# a_5957_1842# 0.03319f
C1376 a_27915_1044# a_27991_1008# 0.01194f
C1377 a_12849_5867# DLL_RESETN 0.3501f
C1378 a_13121_5831# REF_CLK 1.40135f
C1379 a_13557_1842# a_13753_1842# 0.73897f
C1380 a_16510_1044# a_18117_1842# 0.05231f
C1381 a_17351_1008# a_17357_1842# 0.02349f
C1382 a_12849_5867# a_13306_6305# 0.12097f
C1383 a_9772_5843# VDD 0.24701f
C1384 a_27991_1008# a_27705_1044# 0.01885f
C1385 a_11271_1008# a_10985_1044# 0.01885f
C1386 a_9323_1842# a_9431_1842# 0.01163f
C1387 VDD a_12233_1842# 0.49285f
C1388 DELAY_VBIASN a_9323_1842# 0.07254f
C1389 DELAY_VBIASP a_9193_1842# 0.11222f
C1390 MUX_SEL1 a_2297_1395# 0.01995f
C1391 a_24665_1044# a_22590_1044# 0.03208f
C1392 a_24957_1842# a_16108_289# 0.0157f
C1393 VDD a_26151_2470# 0.01806f
C1394 a_5115_1044# a_4905_1044# 0.09424f
C1395 a_2019_311# a_15765_463# 0.05969f
C1396 a_23437_1842# a_23003_1842# 0.6972f
C1397 a_4437_1842# a_4003_1842# 0.69698f
C1398 a_25630_1044# a_27124_1008# 0.28279f
C1399 a_26395_1044# a_26471_1008# 0.01194f
C1400 a_11277_1842# a_11473_1842# 0.76914f
C1401 a_16510_1044# a_18004_1008# 0.28279f
C1402 a_27237_1842# DELAY_VBIASP 0.06225f
C1403 a_27433_1842# DELAY_VBIASN 0.10734f
C1404 a_25630_1044# a_25528_1044# 0.37183f
C1405 MUX_OUT MUX_SEL2 0.08497f
C1406 a_16484_1008# a_15837_1842# 0.02011f
C1407 a_12355_5867# a_12656_5864# 0.03277f
C1408 a_7803_1842# a_7911_1842# 0.01163f
C1409 VDD a_10517_1842# 0.86707f
C1410 DELAY_VBIASN a_7673_1842# 0.0961f
C1411 a_15304_4605# a_15108_6109# 0.17528f
C1412 a_13121_5831# a_15464_3684# 0.33256f
R0 VDD.n131 VDD.t169 17.3693
R1 VDD.n118 VDD.t221 17.3693
R2 VDD.n118 VDD.t217 17.3693
R3 VDD.n129 VDD.t264 17.3517
R4 VDD.n121 VDD.t126 17.3517
R5 VDD.n120 VDD.t127 17.3517
R6 VDD.n72 VDD.t251 17.2438
R7 VDD.n124 VDD.t49 17.2247
R8 VDD.n129 VDD.t170 17.0005
R9 VDD.n121 VDD.t120 17.0005
R10 VDD.n120 VDD.t59 17.0005
R11 VDD.t0 VDD.n99 4.19382
R12 VDD.n42 VDD.n43 0.189847
R13 VDD.n95 VDD.n94 0.149987
R14 VDD.t0 VDD.n94 2.39616
R15 VDD.n91 VDD.n53 0.149987
R16 VDD.n91 VDD.t0 2.39616
R17 VDD.n96 VDD.n88 0.149987
R18 VDD.t0 VDD.n88 2.39616
R19 VDD.n83 VDD.n50 0.149987
R20 VDD.n83 VDD.t0 2.39616
R21 VDD.n97 VDD.n80 0.149987
R22 VDD.t0 VDD.n80 2.39616
R23 VDD.n76 VDD.n47 0.149987
R24 VDD.t0 VDD.n76 2.39616
R25 VDD.t50 VDD.n37 2.05485
R26 VDD.n34 VDD.n65 0.448571
R27 VDD.n36 VDD.t160 15.1333
R28 VDD.n383 VDD.t163 15.0005
R29 VDD.n1 VDD.t158 15.0005
R30 VDD.n64 VDD.t145 15.0005
R31 VDD.n39 VDD.t150 15.0005
R32 VDD.n67 VDD.t369 17.9449
R33 VDD.n386 VDD.n135 9.51422
R34 VDD.n387 VDD.n386 9.17119
R35 VDD.n68 VDD.n67 0.341666
R36 VDD.n395 VDD.t360 9.02285
R37 VDD.n73 VDD.n74 0.0615821
R38 VDD.n115 VDD.n28 4.47071
R39 VDD.n114 VDD.t168 8.95516
R40 VDD.n143 VDD.t77 8.76154
R41 VDD.n12 VDD.t117 8.76154
R42 VDD.n12 VDD.t105 8.76154
R43 VDD.n12 VDD.t245 8.76154
R44 VDD.n11 VDD.t56 8.76154
R45 VDD.n144 VDD.t78 8.76154
R46 VDD.n44 VDD.t104 8.76154
R47 VDD.n145 VDD.t10 8.76154
R48 VDD.n72 VDD.t252 8.76154
R49 VDD.n108 VDD.t375 8.76054
R50 VDD.n108 VDD.t342 8.76054
R51 VDD.n143 VDD.t132 8.76054
R52 VDD.n12 VDD.t125 8.76054
R53 VDD.n12 VDD.t334 8.76054
R54 VDD.n12 VDD.t8 8.76054
R55 VDD.n11 VDD.t337 8.76054
R56 VDD.n144 VDD.t91 8.76054
R57 VDD.n44 VDD.t336 8.76054
R58 VDD.n145 VDD.t278 8.76054
R59 VDD.n94 VDD.n93 0.0442395
R60 VDD.n90 VDD.n91 0.0442395
R61 VDD.n88 VDD.n87 0.0442395
R62 VDD.n82 VDD.n83 0.0442395
R63 VDD.n80 VDD.n79 0.0442395
R64 VDD.n77 VDD.n76 0.0442395
R65 VDD VDD.t6 8.47732
R66 VDD.n46 VDD.n45 0.0953067
R67 VDD.t0 VDD.n46 4.19225
R68 VDD.t0 VDD.n41 3.34459
R69 VDD.t0 VDD.n13 1.07426
R70 VDD.n15 VDD.t0 0.282297
R71 VDD.t0 VDD.n9 0.793108
R72 VDD.t0 VDD.n18 1.13836
R73 VDD.n8 VDD.t0 0.793108
R74 VDD.n20 VDD.t0 1.13836
R75 VDD.t0 VDD.n6 0.793108
R76 VDD.t0 VDD.n21 0.315451
R77 VDD.n5 VDD.t0 0.793108
R78 VDD.n24 VDD.t0 1.13836
R79 VDD.t0 VDD.n3 0.793108
R80 VDD.t0 VDD.n26 1.13836
R81 VDD.t0 VDD.n10 0.793077
R82 VDD.t2 VDD.n56 4.20922
R83 VDD.t2 VDD.n60 4.20922
R84 VDD.t50 VDD.n57 1.61947
R85 VDD.t50 VDD.n34 0.894484
R86 VDD.t50 VDD.n73 8.47732
R87 VDD.n10 VDD.t409 7.62628
R88 VDD.n75 VDD.t408 7.62628
R89 VDD.n26 VDD.t407 7.62628
R90 VDD.n3 VDD.t406 7.62628
R91 VDD.n78 VDD.t405 7.62628
R92 VDD.n24 VDD.t404 7.62628
R93 VDD.n5 VDD.t403 7.62628
R94 VDD.n81 VDD.t402 7.62628
R95 VDD.n22 VDD.t401 7.62628
R96 VDD.n6 VDD.t400 7.62628
R97 VDD.n86 VDD.t399 7.62628
R98 VDD.n20 VDD.t398 7.62628
R99 VDD.n8 VDD.t397 7.62628
R100 VDD.n89 VDD.t396 7.62628
R101 VDD.n18 VDD.t395 7.62628
R102 VDD.n9 VDD.t394 7.62628
R103 VDD.n92 VDD.t393 7.62628
R104 VDD.n16 VDD.t392 7.62628
R105 VDD.n1 VDD.n30 3.11859
R106 VDD.n192 VDD.t350 6.09923
R107 VDD.n198 VDD.t5 6.09923
R108 VDD.n204 VDD.t191 6.09923
R109 VDD.n210 VDD.t43 6.09923
R110 VDD.n216 VDD.t272 6.09923
R111 VDD.n222 VDD.t286 6.09923
R112 VDD.n228 VDD.t52 6.09923
R113 VDD.n234 VDD.t75 6.09923
R114 VDD.n240 VDD.t84 6.09923
R115 VDD.n246 VDD.t46 6.09923
R116 VDD.n252 VDD.t358 6.09923
R117 VDD.n258 VDD.t197 6.09923
R118 VDD.n264 VDD.t4 6.09923
R119 VDD.n270 VDD.t111 6.09923
R120 VDD.n276 VDD.t277 6.09923
R121 VDD.n282 VDD.t254 6.09923
R122 VDD.n288 VDD.t109 6.09923
R123 VDD.n294 VDD.t203 6.09923
R124 VDD.n300 VDD.t179 6.09923
R125 VDD.n306 VDD.t54 6.09923
R126 VDD.n312 VDD.t289 6.09923
R127 VDD.n318 VDD.t265 6.09923
R128 VDD.n324 VDD.t201 6.09923
R129 VDD.n330 VDD.t39 6.09923
R130 VDD.n336 VDD.t37 6.09923
R131 VDD.n342 VDD.t249 6.09923
R132 VDD.n348 VDD.t79 6.09923
R133 VDD.n354 VDD.t331 6.09923
R134 VDD.n360 VDD.t287 6.09923
R135 VDD.n366 VDD.t47 6.09923
R136 VDD.n372 VDD.t42 6.09923
R137 VDD.n378 VDD.t281 6.09923
R138 VDD.n26 VDD.t223 5.99122
R139 VDD.n24 VDD.t83 5.99122
R140 VDD.n22 VDD.t1 5.99122
R141 VDD.n20 VDD.t184 5.99122
R142 VDD.n18 VDD.t354 5.99122
R143 VDD.n16 VDD.t340 5.99122
R144 VDD.n100 VDD.t266 5.98905
R145 VDD.n128 VDD.t129 5.9886
R146 VDD.n106 VDD.t293 5.97675
R147 VDD.n106 VDD.t172 5.97675
R148 VDD.n12 VDD.t118 5.97212
R149 VDD.n12 VDD.t246 5.97212
R150 VDD.n45 VDD.t176 5.97212
R151 VDD.n146 VDD.t11 5.97212
R152 VDD.n12 VDD.t352 5.97169
R153 VDD.n12 VDD.t9 5.97169
R154 VDD.n45 VDD.t92 5.97169
R155 VDD.n146 VDD.t279 5.97169
R156 VDD.n10 VDD.t96 5.97001
R157 VDD.n10 VDD.t130 5.97001
R158 VDD.n10 VDD.t82 5.97001
R159 VDD.n48 VDD.t87 5.97001
R160 VDD.n47 VDD.t86 5.97001
R161 VDD.n3 VDD.t195 5.97001
R162 VDD.n26 VDD.t90 5.97001
R163 VDD.n3 VDD.t359 5.97001
R164 VDD.n3 VDD.t236 5.97001
R165 VDD.n49 VDD.t99 5.97001
R166 VDD.n97 VDD.t98 5.97001
R167 VDD.n5 VDD.t212 5.97001
R168 VDD.n24 VDD.t102 5.97001
R169 VDD.n5 VDD.t94 5.97001
R170 VDD.n5 VDD.t193 5.97001
R171 VDD.n51 VDD.t208 5.97001
R172 VDD.n50 VDD.t207 5.97001
R173 VDD.n6 VDD.t204 5.97001
R174 VDD.n22 VDD.t211 5.97001
R175 VDD.n6 VDD.t180 5.97001
R176 VDD.n6 VDD.t227 5.97001
R177 VDD.n52 VDD.t257 5.97001
R178 VDD.n96 VDD.t256 5.97001
R179 VDD.n8 VDD.t374 5.97001
R180 VDD.n20 VDD.t260 5.97001
R181 VDD.n8 VDD.t64 5.97001
R182 VDD.n8 VDD.t63 5.97001
R183 VDD.n54 VDD.t231 5.97001
R184 VDD.n53 VDD.t230 5.97001
R185 VDD.n9 VDD.t67 5.97001
R186 VDD.n18 VDD.t234 5.97001
R187 VDD.n9 VDD.t237 5.97001
R188 VDD.n9 VDD.t225 5.97001
R189 VDD.n55 VDD.t16 5.97001
R190 VDD.n95 VDD.t15 5.97001
R191 VDD.n16 VDD.t19 5.97001
R192 VDD.n32 VDD.t177 5.96578
R193 VDD.n42 VDD.t103 5.96578
R194 VDD.n141 VDD.t57 5.96578
R195 VDD.n25 VDD.t114 5.96578
R196 VDD.n23 VDD.t113 5.96578
R197 VDD.n33 VDD.t178 5.96578
R198 VDD.n85 VDD.t183 5.96578
R199 VDD.n27 VDD.t119 5.96578
R200 VDD.n19 VDD.t115 5.96578
R201 VDD.n17 VDD.t58 5.96578
R202 VDD.n14 VDD.t116 5.96578
R203 VDD.n42 VDD.t335 5.96534
R204 VDD.n141 VDD.t338 5.96534
R205 VDD.n100 VDD.t60 5.96534
R206 VDD.n139 VDD.t93 5.96534
R207 VDD.n137 VDD.t171 5.96534
R208 VDD.n148 VDD.t66 5.96534
R209 VDD.n31 VDD.t215 5.96534
R210 VDD.n32 VDD.t61 5.96534
R211 VDD.n10 VDD.t364 5.96534
R212 VDD.n10 VDD.t185 5.96534
R213 VDD.n101 VDD.t44 5.96534
R214 VDD.n47 VDD.t12 5.96534
R215 VDD.n26 VDD.t239 5.96534
R216 VDD.n26 VDD.t389 5.96534
R217 VDD.n25 VDD.t71 5.96534
R218 VDD.n3 VDD.t53 5.96534
R219 VDD.n3 VDD.t73 5.96534
R220 VDD.n102 VDD.t74 5.96534
R221 VDD.n97 VDD.t13 5.96534
R222 VDD.n24 VDD.t76 5.96534
R223 VDD.n24 VDD.t45 5.96534
R224 VDD.n23 VDD.t72 5.96534
R225 VDD.n5 VDD.t357 5.96534
R226 VDD.n5 VDD.t69 5.96534
R227 VDD.n4 VDD.t199 5.96534
R228 VDD.n50 VDD.t240 5.96534
R229 VDD.n22 VDD.t242 5.96534
R230 VDD.n22 VDD.t123 5.96534
R231 VDD.n27 VDD.t355 5.96534
R232 VDD.n27 VDD.t190 5.96534
R233 VDD.n156 VDD.t290 5.96534
R234 VDD.n85 VDD.t253 5.96534
R235 VDD.n154 VDD.t213 5.96534
R236 VDD.n72 VDD.t41 5.96534
R237 VDD.n152 VDD.t238 5.96534
R238 VDD.n150 VDD.t387 5.96534
R239 VDD.n33 VDD.t182 5.96534
R240 VDD.n6 VDD.t107 5.96534
R241 VDD.n6 VDD.t292 5.96534
R242 VDD.n103 VDD.t333 5.96534
R243 VDD.n96 VDD.t38 5.96534
R244 VDD.n20 VDD.t379 5.96534
R245 VDD.n20 VDD.t347 5.96534
R246 VDD.n19 VDD.t222 5.96534
R247 VDD.n8 VDD.t174 5.96534
R248 VDD.n8 VDD.t70 5.96534
R249 VDD.n7 VDD.t40 5.96534
R250 VDD.n53 VDD.t241 5.96534
R251 VDD.n18 VDD.t243 5.96534
R252 VDD.n18 VDD.t250 5.96534
R253 VDD.n17 VDD.t356 5.96534
R254 VDD.n9 VDD.t80 5.96534
R255 VDD.n9 VDD.t291 5.96534
R256 VDD.n104 VDD.t365 5.96534
R257 VDD.n95 VDD.t112 5.96534
R258 VDD.n16 VDD.t20 5.96534
R259 VDD.n16 VDD.t48 5.96534
R260 VDD.n14 VDD.t228 5.96534
R261 VDD.n14 VDD.t173 5.96534
R262 VDD.n126 VDD.t166 5.96478
R263 VDD.n10 VDD.t81 5.65005
R264 VDD.n75 VDD.t85 5.65005
R265 VDD.n26 VDD.t88 5.65005
R266 VDD.n3 VDD.t196 5.65005
R267 VDD.n78 VDD.t97 5.65005
R268 VDD.n24 VDD.t100 5.65005
R269 VDD.n5 VDD.t192 5.65005
R270 VDD.n81 VDD.t95 5.65005
R271 VDD.n22 VDD.t209 5.65005
R272 VDD.n6 VDD.t205 5.65005
R273 VDD.n86 VDD.t181 5.65005
R274 VDD.n20 VDD.t258 5.65005
R275 VDD.n8 VDD.t62 5.65005
R276 VDD.n89 VDD.t65 5.65005
R277 VDD.n18 VDD.t232 5.65005
R278 VDD.n9 VDD.t68 5.65005
R279 VDD.n92 VDD.t14 5.65005
R280 VDD.n16 VDD.t17 5.65005
R281 VDD.t6 VDD.n133 5.62581
R282 VDD.t6 VDD.n396 5.62581
R283 VDD.t0 VDD.n149 5.62581
R284 VDD.t0 VDD.n147 5.62581
R285 VDD.t0 VDD.n140 5.62581
R286 VDD.n41 VDD.n144 0.160419
R287 VDD.n13 VDD.n12 0.134613
R288 VDD.n151 VDD.t0 5.62581
R289 VDD.n71 VDD.t0 1.79705
R290 VDD.n153 VDD.t0 5.62581
R291 VDD.n155 VDD.t0 5.62581
R292 VDD.t2 VDD.n191 5.62581
R293 VDD.t2 VDD.n197 5.62581
R294 VDD.t2 VDD.n203 5.62581
R295 VDD.t2 VDD.n209 5.62581
R296 VDD.t2 VDD.n215 5.62581
R297 VDD.t2 VDD.n221 5.62581
R298 VDD.t2 VDD.n227 5.62581
R299 VDD.t2 VDD.n233 5.62581
R300 VDD.t2 VDD.n239 5.62581
R301 VDD.t2 VDD.n245 5.62581
R302 VDD.t2 VDD.n251 5.62581
R303 VDD.t2 VDD.n257 5.62581
R304 VDD.t2 VDD.n263 5.62581
R305 VDD.t2 VDD.n269 5.62581
R306 VDD.t2 VDD.n275 5.62581
R307 VDD.t2 VDD.n281 5.62581
R308 VDD.t2 VDD.n287 5.62581
R309 VDD.t2 VDD.n293 5.62581
R310 VDD.t2 VDD.n299 5.62581
R311 VDD.t2 VDD.n305 5.62581
R312 VDD.t2 VDD.n311 5.62581
R313 VDD.t2 VDD.n317 5.62581
R314 VDD.t2 VDD.n323 5.62581
R315 VDD.t2 VDD.n329 5.62581
R316 VDD.t2 VDD.n335 5.62581
R317 VDD.t2 VDD.n341 5.62581
R318 VDD.t2 VDD.n347 5.62581
R319 VDD.t2 VDD.n353 5.62581
R320 VDD.t2 VDD.n359 5.62581
R321 VDD.t2 VDD.n365 5.62581
R322 VDD.t2 VDD.n371 5.62581
R323 VDD.t2 VDD.n377 5.62581
R324 VDD.t2 VDD.n379 5.62581
R325 VDD.t7 VDD.n123 5.61485
R326 VDD.t7 VDD.n127 5.61485
R327 VDD.n0 VDD.t156 5.7457
R328 VDD.n110 VDD.t146 5.60969
R329 VDD.n111 VDD.t151 5.60969
R330 VDD.n1 VDD.t159 5.71623
R331 VDD.n382 VDD.t165 5.60347
R332 VDD.n61 VDD.t162 5.60347
R333 VDD.n28 VDD.t149 5.60347
R334 VDD.n113 VDD.t154 5.60347
R335 VDD.n189 VDD.t306 5.59675
R336 VDD.n195 VDD.t313 5.59675
R337 VDD.n201 VDD.t311 5.59675
R338 VDD.n207 VDD.t301 5.59675
R339 VDD.n213 VDD.t314 5.59675
R340 VDD.n219 VDD.t310 5.59675
R341 VDD.n225 VDD.t317 5.59675
R342 VDD.n231 VDD.t319 5.59675
R343 VDD.n237 VDD.t307 5.59675
R344 VDD.n243 VDD.t299 5.59675
R345 VDD.n249 VDD.t321 5.59675
R346 VDD.n255 VDD.t320 5.59675
R347 VDD.n261 VDD.t318 5.59675
R348 VDD.n267 VDD.t315 5.59675
R349 VDD.n273 VDD.t322 5.59675
R350 VDD.n279 VDD.t305 5.59675
R351 VDD.n285 VDD.t304 5.59675
R352 VDD.n291 VDD.t303 5.59675
R353 VDD.n297 VDD.t300 5.59675
R354 VDD.n303 VDD.t323 5.59675
R355 VDD.n309 VDD.t316 5.59675
R356 VDD.n315 VDD.t298 5.59675
R357 VDD.n321 VDD.t309 5.59675
R358 VDD.n327 VDD.t326 5.59675
R359 VDD.n333 VDD.t325 5.59675
R360 VDD.n339 VDD.t324 5.59675
R361 VDD.n345 VDD.t308 5.59675
R362 VDD.n351 VDD.t327 5.59675
R363 VDD.n357 VDD.t302 5.59675
R364 VDD.n363 VDD.t328 5.59675
R365 VDD.n369 VDD.t329 5.59675
R366 VDD.n375 VDD.t330 5.59675
R367 VDD.n380 VDD.t161 5.59675
R368 VDD.n38 VDD.t312 5.59675
R369 VDD.n28 VDD.t147 5.59179
R370 VDD.n112 VDD.t152 5.59179
R371 VDD.n1 VDD.t157 5.59179
R372 VDD.n433 VDD.t137 4.9462
R373 VDD.n405 VDD.t134 4.9462
R374 VDD.n116 VDD.n115 4.90372
R375 VDD.t0 VDD.n142 4.19244
R376 VDD.t0 VDD.n43 3.32638
R377 VDD.t6 VDD.n397 4.19238
R378 VDD.t6 VDD.n425 4.19238
R379 VDD.t6 VDD.n389 4.19238
R380 VDD.n57 VDD.n28 0.406014
R381 VDD.n37 VDD.n74 0.379679
R382 VDD.t6 VDD.n394 4.19225
R383 VDD VDD.t7 1.47683
R384 VDD.t0 VDD.n98 3.3265
R385 VDD.n152 VDD.n71 0.341
R386 VDD.n84 VDD.t0 3.3265
R387 VDD.t7 VDD.n125 3.31208
R388 VDD.t7 VDD.n117 3.30706
R389 VDD.t7 VDD.n119 3.30706
R390 VDD.t7 VDD.n132 3.30688
R391 VDD VDD.n42 3.24041
R392 VDD.t7 VDD.n107 2.77509
R393 VDD.t0 VDD.n136 2.74446
R394 VDD.t0 VDD.n138 2.74446
R395 VDD.n15 VDD.n14 0.286705
R396 VDD.n156 VDD.n27 0.44578
R397 VDD.n27 VDD.n21 0.309939
R398 VDD.t6 VDD.n388 2.74414
R399 VDD.t2 VDD.n35 2.74414
R400 VDD.n2 VDD.n190 0.528094
R401 VDD.n435 VDD.t139 2.69937
R402 VDD.n403 VDD.t142 2.69937
R403 VDD.n401 VDD.t136 2.69937
R404 VDD.n427 VDD.t144 2.69937
R405 VDD.n431 VDD.t36 2.6992
R406 VDD.n429 VDD.t29 2.6992
R407 VDD.n399 VDD.t21 2.6992
R408 VDD.n407 VDD.t22 2.6992
R409 VDD.n412 VDD.t23 2.6992
R410 VDD.n411 VDD.t30 2.6992
R411 VDD.n417 VDD.t25 2.6992
R412 VDD.n416 VDD.t32 2.6992
R413 VDD.n422 VDD.t27 2.6992
R414 VDD.n421 VDD.t34 2.6992
R415 VDD.t6 VDD.n70 2.33382
R416 VDD.t2 VDD.n313 2.32446
R417 VDD.t2 VDD.n319 2.32446
R418 VDD.t6 VDD.n424 2.32439
R419 VDD.t6 VDD.n392 2.32439
R420 VDD.t2 VDD.n217 2.32439
R421 VDD.t2 VDD.n235 2.32439
R422 VDD.t2 VDD.n259 2.32439
R423 VDD.t2 VDD.n325 2.32439
R424 VDD.t2 VDD.n349 2.32439
R425 VDD.t2 VDD.n367 2.32439
R426 VDD.t2 VDD.n277 2.32432
R427 VDD.t2 VDD.n193 2.32425
R428 VDD.t2 VDD.n241 2.3242
R429 VDD.t2 VDD.n373 2.3242
R430 VDD.t6 VDD.n409 2.32417
R431 VDD.t2 VDD.n199 2.32417
R432 VDD.t2 VDD.n205 2.32417
R433 VDD.t2 VDD.n247 2.32417
R434 VDD.t2 VDD.n265 2.32417
R435 VDD.t2 VDD.n283 2.32417
R436 VDD.t2 VDD.n295 2.32417
R437 VDD.t2 VDD.n301 2.32417
R438 VDD.t2 VDD.n307 2.32417
R439 VDD.t2 VDD.n331 2.32417
R440 VDD.t2 VDD.n337 2.32417
R441 VDD.t2 VDD.n343 2.32417
R442 VDD.t6 VDD.n393 2.32417
R443 VDD.t6 VDD.n390 2.32417
R444 VDD.t50 VDD.n68 0.570319
R445 VDD.t2 VDD.n223 2.32417
R446 VDD.t2 VDD.n211 2.32414
R447 VDD.t2 VDD.n229 2.32414
R448 VDD.t2 VDD.n253 2.32407
R449 VDD.t6 VDD.n419 2.32406
R450 VDD.t2 VDD.n271 2.32406
R451 VDD.t2 VDD.n289 2.32406
R452 VDD.t2 VDD.n355 2.32406
R453 VDD.t2 VDD.n361 2.32406
R454 VDD.n14 VDD.t186 6.35403
R455 VDD.t6 VDD.n414 2.00628
R456 VDD.t6 VDD.n391 2.0061
R457 VDD.t6 VDD.n437 1.75938
R458 VDD.t2 VDD.n385 1.56886
R459 VDD.t2 VDD.n157 1.55381
R460 VDD.t2 VDD.n159 1.55381
R461 VDD.t2 VDD.n160 1.55381
R462 VDD.t2 VDD.n162 1.55381
R463 VDD.t2 VDD.n163 1.55381
R464 VDD.t2 VDD.n164 1.55381
R465 VDD.t2 VDD.n166 1.55381
R466 VDD.t2 VDD.n168 1.55381
R467 VDD.t2 VDD.n169 1.55381
R468 VDD.t2 VDD.n170 1.55381
R469 VDD.t2 VDD.n171 1.55381
R470 VDD.t2 VDD.n172 1.55381
R471 VDD.t2 VDD.n173 1.55381
R472 VDD.t2 VDD.n174 1.55381
R473 VDD.t2 VDD.n175 1.55381
R474 VDD.t2 VDD.n176 1.55381
R475 VDD.t2 VDD.n180 1.55381
R476 VDD.t2 VDD.n181 1.55381
R477 VDD.t2 VDD.n182 1.55381
R478 VDD.t2 VDD.n184 1.55381
R479 VDD.t2 VDD.n158 1.55341
R480 VDD.t2 VDD.n161 1.55341
R481 VDD.t2 VDD.n165 1.55341
R482 VDD.t2 VDD.n167 1.55341
R483 VDD.t2 VDD.n177 1.55341
R484 VDD.t2 VDD.n178 1.55341
R485 VDD.t2 VDD.n179 1.55341
R486 VDD.t2 VDD.n183 1.55341
R487 VDD.t2 VDD.n185 1.55341
R488 VDD.t2 VDD.n186 1.55341
R489 VDD.t2 VDD.n187 1.55341
R490 VDD.t7 VDD.n109 1.20461
R491 VDD.n68 VDD.n114 0.779651
R492 VDD.n412 VDD.n411 1.11007
R493 VDD.n417 VDD.n416 1.11007
R494 VDD.n422 VDD.n421 1.11007
R495 VDD.t6 VDD.n134 1.01949
R496 VDD.n131 VDD.n105 0.975304
R497 VDD.n105 VDD.n128 0.817678
R498 VDD.n386 VDD.n30 0.808112
R499 VDD.n116 VDD.n109 0.671512
R500 VDD.n109 VDD.n108 0.6645
R501 VDD.n135 VDD.n134 0.633311
R502 VDD.n387 VDD.n134 0.617798
R503 VDD.n436 VDD.n435 0.570444
R504 VDD.n401 VDD.n400 0.570444
R505 VDD.n429 VDD.n428 0.570274
R506 VDD.n408 VDD.n407 0.570274
R507 VDD.n413 VDD.n412 0.570274
R508 VDD.n418 VDD.n417 0.570274
R509 VDD.n423 VDD.n422 0.570274
R510 VDD.n431 VDD.n430 0.569912
R511 VDD.n399 VDD.n398 0.569912
R512 VDD.n411 VDD.n410 0.569912
R513 VDD.n416 VDD.n415 0.569912
R514 VDD.n421 VDD.n420 0.569912
R515 VDD.n403 VDD.n402 0.569733
R516 VDD.n427 VDD.n426 0.569733
R517 VDD.n29 VDD.n28 0.183807
R518 VDD.n112 VDD.n40 0.508375
R519 VDD.t7 VDD.n105 0.49685
R520 VDD.n189 VDD.n188 0.495398
R521 VDD.n195 VDD.n194 0.495398
R522 VDD.n201 VDD.n200 0.495398
R523 VDD.n207 VDD.n206 0.495398
R524 VDD.n213 VDD.n212 0.495398
R525 VDD.n219 VDD.n218 0.495398
R526 VDD.n225 VDD.n224 0.495398
R527 VDD.n231 VDD.n230 0.495398
R528 VDD.n237 VDD.n236 0.495398
R529 VDD.n243 VDD.n242 0.495398
R530 VDD.n249 VDD.n248 0.495398
R531 VDD.n255 VDD.n254 0.495398
R532 VDD.n261 VDD.n260 0.495398
R533 VDD.n267 VDD.n266 0.495398
R534 VDD.n273 VDD.n272 0.495398
R535 VDD.n279 VDD.n278 0.495398
R536 VDD.n285 VDD.n284 0.495398
R537 VDD.n291 VDD.n290 0.495398
R538 VDD.n297 VDD.n296 0.495398
R539 VDD.n303 VDD.n302 0.495398
R540 VDD.n309 VDD.n308 0.495398
R541 VDD.n315 VDD.n314 0.495398
R542 VDD.n321 VDD.n320 0.495398
R543 VDD.n327 VDD.n326 0.495398
R544 VDD.n333 VDD.n332 0.495398
R545 VDD.n339 VDD.n338 0.495398
R546 VDD.n345 VDD.n344 0.495398
R547 VDD.n351 VDD.n350 0.495398
R548 VDD.n357 VDD.n356 0.495398
R549 VDD.n363 VDD.n362 0.495398
R550 VDD.n369 VDD.n368 0.495398
R551 VDD.n375 VDD.n374 0.495398
R552 VDD.n380 VDD.n36 0.495398
R553 VDD.n38 VDD.n58 0.495398
R554 VDD.n404 VDD.n403 0.492175
R555 VDD.n434 VDD.n427 0.492175
R556 VDD.n432 VDD.n431 0.492005
R557 VDD.n406 VDD.n399 0.492005
R558 VDD.n432 VDD.n429 0.491643
R559 VDD.n407 VDD.n406 0.491643
R560 VDD.n435 VDD.n434 0.491464
R561 VDD.n404 VDD.n401 0.491464
R562 VDD.n190 VDD.n189 0.478641
R563 VDD.n196 VDD.n195 0.478641
R564 VDD.n202 VDD.n201 0.478641
R565 VDD.n208 VDD.n207 0.478641
R566 VDD.n214 VDD.n213 0.478641
R567 VDD.n220 VDD.n219 0.478641
R568 VDD.n226 VDD.n225 0.478641
R569 VDD.n232 VDD.n231 0.478641
R570 VDD.n238 VDD.n237 0.478641
R571 VDD.n244 VDD.n243 0.478641
R572 VDD.n250 VDD.n249 0.478641
R573 VDD.n256 VDD.n255 0.478641
R574 VDD.n262 VDD.n261 0.478641
R575 VDD.n268 VDD.n267 0.478641
R576 VDD.n274 VDD.n273 0.478641
R577 VDD.n280 VDD.n279 0.478641
R578 VDD.n286 VDD.n285 0.478641
R579 VDD.n292 VDD.n291 0.478641
R580 VDD.n298 VDD.n297 0.478641
R581 VDD.n304 VDD.n303 0.478641
R582 VDD.n310 VDD.n309 0.478641
R583 VDD.n316 VDD.n315 0.478641
R584 VDD.n322 VDD.n321 0.478641
R585 VDD.n328 VDD.n327 0.478641
R586 VDD.n334 VDD.n333 0.478641
R587 VDD.n340 VDD.n339 0.478641
R588 VDD.n346 VDD.n345 0.478641
R589 VDD.n352 VDD.n351 0.478641
R590 VDD.n358 VDD.n357 0.478641
R591 VDD.n364 VDD.n363 0.478641
R592 VDD.n370 VDD.n369 0.478641
R593 VDD.n376 VDD.n375 0.478641
R594 VDD.n59 VDD.n380 0.478641
R595 VDD.n40 VDD.n38 0.478641
R596 VDD.n206 VDD.n184 0.467341
R597 VDD.n218 VDD.n182 0.467341
R598 VDD.n224 VDD.n181 0.467341
R599 VDD.n230 VDD.n180 0.467341
R600 VDD.n254 VDD.n176 0.467341
R601 VDD.n260 VDD.n175 0.467341
R602 VDD.n266 VDD.n174 0.467341
R603 VDD.n272 VDD.n173 0.467341
R604 VDD.n278 VDD.n172 0.467341
R605 VDD.n284 VDD.n171 0.467341
R606 VDD.n290 VDD.n170 0.467341
R607 VDD.n296 VDD.n169 0.467341
R608 VDD.n302 VDD.n168 0.467341
R609 VDD.n314 VDD.n166 0.467341
R610 VDD.n326 VDD.n164 0.467341
R611 VDD.n332 VDD.n163 0.467341
R612 VDD.n338 VDD.n162 0.467341
R613 VDD.n350 VDD.n160 0.467341
R614 VDD.n356 VDD.n159 0.467341
R615 VDD.n368 VDD.n157 0.467341
R616 VDD.n188 VDD.n187 0.466909
R617 VDD.n194 VDD.n186 0.466909
R618 VDD.n200 VDD.n185 0.466909
R619 VDD.n212 VDD.n183 0.466909
R620 VDD.n236 VDD.n179 0.466909
R621 VDD.n242 VDD.n178 0.466909
R622 VDD.n248 VDD.n177 0.466909
R623 VDD.n308 VDD.n167 0.466909
R624 VDD.n320 VDD.n165 0.466909
R625 VDD.n344 VDD.n161 0.466909
R626 VDD.n362 VDD.n158 0.466909
R627 VDD.n194 VDD.n187 0.451022
R628 VDD.n200 VDD.n186 0.451022
R629 VDD.n206 VDD.n185 0.451022
R630 VDD.n218 VDD.n183 0.451022
R631 VDD.n242 VDD.n179 0.451022
R632 VDD.n248 VDD.n178 0.451022
R633 VDD.n254 VDD.n177 0.451022
R634 VDD.n314 VDD.n167 0.451022
R635 VDD.n326 VDD.n165 0.451022
R636 VDD.n350 VDD.n161 0.451022
R637 VDD.n368 VDD.n158 0.451022
R638 VDD.n212 VDD.n184 0.450618
R639 VDD.n224 VDD.n182 0.450618
R640 VDD.n230 VDD.n181 0.450618
R641 VDD.n236 VDD.n180 0.450618
R642 VDD.n260 VDD.n176 0.450618
R643 VDD.n266 VDD.n175 0.450618
R644 VDD.n272 VDD.n174 0.450618
R645 VDD.n278 VDD.n173 0.450618
R646 VDD.n284 VDD.n172 0.450618
R647 VDD.n290 VDD.n171 0.450618
R648 VDD.n296 VDD.n170 0.450618
R649 VDD.n302 VDD.n169 0.450618
R650 VDD.n308 VDD.n168 0.450618
R651 VDD.n320 VDD.n166 0.450618
R652 VDD.n332 VDD.n164 0.450618
R653 VDD.n338 VDD.n163 0.450618
R654 VDD.n344 VDD.n162 0.450618
R655 VDD.n356 VDD.n160 0.450618
R656 VDD.n362 VDD.n159 0.450618
R657 VDD.n374 VDD.n157 0.450618
R658 VDD.n61 VDD.n56 0.445771
R659 VDD.n437 VDD.n436 0.43335
R660 VDD.n73 VDD.n29 0.0930507
R661 VDD.n66 VDD.n113 0.429929
R662 VDD.n385 VDD.n384 0.429766
R663 VDD.n382 VDD.n381 0.427147
R664 VDD.n62 VDD.n61 0.427147
R665 VDD.n385 VDD.n381 0.426171
R666 VDD.n110 VDD.n28 0.413465
R667 VDD.n111 VDD.n58 0.413465
R668 VDD.n437 VDD.n69 0.403558
R669 VDD.t6 VDD.t7 0.383639
R670 VDD.n415 VDD.n392 0.372952
R671 VDD.n419 VDD.n418 0.372271
R672 VDD.n313 VDD.n312 0.35553
R673 VDD.n319 VDD.n318 0.35553
R674 VDD.n259 VDD.n258 0.355452
R675 VDD.n325 VDD.n324 0.355452
R676 VDD.n217 VDD.n216 0.355452
R677 VDD.n235 VDD.n234 0.355452
R678 VDD.n349 VDD.n348 0.355452
R679 VDD.n367 VDD.n366 0.355452
R680 VDD.n277 VDD.n276 0.355386
R681 VDD.n193 VDD.n192 0.355312
R682 VDD.n301 VDD.n300 0.355155
R683 VDD.n199 VDD.n198 0.355155
R684 VDD.n205 VDD.n204 0.355155
R685 VDD.n247 VDD.n246 0.355155
R686 VDD.n265 VDD.n264 0.355155
R687 VDD.n283 VDD.n282 0.355155
R688 VDD.n295 VDD.n294 0.355155
R689 VDD.n307 VDD.n306 0.355155
R690 VDD.n331 VDD.n330 0.355155
R691 VDD.n337 VDD.n336 0.355155
R692 VDD.n343 VDD.n342 0.355155
R693 VDD.n271 VDD.n270 0.355071
R694 VDD.n211 VDD.n210 0.354936
R695 VDD.n229 VDD.n228 0.354936
R696 VDD.n241 VDD.n240 0.354903
R697 VDD.n373 VDD.n372 0.354903
R698 VDD.n253 VDD.n252 0.354838
R699 VDD.n223 VDD.n222 0.354837
R700 VDD.n289 VDD.n288 0.354771
R701 VDD.n355 VDD.n354 0.354771
R702 VDD.n361 VDD.n360 0.354771
R703 VDD.n413 VDD.n409 0.354692
R704 VDD.n410 VDD.n390 0.354692
R705 VDD.n424 VDD.n423 0.347952
R706 VDD.n420 VDD.n393 0.347655
R707 VDD.n414 VDD.n413 0.347437
R708 VDD.n410 VDD.n391 0.347254
R709 VDD.n132 VDD.n131 0.335799
R710 VDD.n119 VDD.n118 0.335496
R711 VDD.n430 VDD.n393 0.334692
R712 VDD.n428 VDD.n424 0.334405
R713 VDD.n122 VDD.n119 0.332368
R714 VDD.n132 VDD.n130 0.332058
R715 VDD.n426 VDD.n70 0.33018
R716 VDD.n415 VDD.n391 0.328947
R717 VDD.n418 VDD.n414 0.328754
R718 VDD.n409 VDD.n408 0.327655
R719 VDD.n398 VDD.n390 0.327655
R720 VDD.t155 VDD.n0 15.0851
R721 VDD.n126 VDD.n125 0.327354
R722 VDD.n64 VDD.n110 0.327154
R723 VDD.n39 VDD.n111 0.327154
R724 VDD.n402 VDD.n388 0.319294
R725 VDD.n383 VDD.n382 0.313013
R726 VDD.n423 VDD.n419 0.310071
R727 VDD.n292 VDD.n289 0.310071
R728 VDD.n358 VDD.n355 0.310071
R729 VDD.n364 VDD.n361 0.310071
R730 VDD.n226 VDD.n223 0.31001
R731 VDD.n256 VDD.n253 0.309994
R732 VDD.n244 VDD.n241 0.309933
R733 VDD.n376 VDD.n373 0.309933
R734 VDD.n214 VDD.n211 0.309928
R735 VDD.n232 VDD.n229 0.309928
R736 VDD.n274 VDD.n271 0.309771
R737 VDD.n268 VDD.n265 0.309692
R738 VDD.n298 VDD.n295 0.309692
R739 VDD.n334 VDD.n331 0.309692
R740 VDD.n202 VDD.n199 0.309692
R741 VDD.n208 VDD.n205 0.309692
R742 VDD.n250 VDD.n247 0.309692
R743 VDD.n286 VDD.n283 0.309692
R744 VDD.n304 VDD.n301 0.309692
R745 VDD.n310 VDD.n307 0.309692
R746 VDD.n340 VDD.n337 0.309692
R747 VDD.n346 VDD.n343 0.309692
R748 VDD.n196 VDD.n193 0.309557
R749 VDD.n280 VDD.n277 0.309483
R750 VDD.n220 VDD.n217 0.309405
R751 VDD.n238 VDD.n235 0.309405
R752 VDD.n262 VDD.n259 0.309405
R753 VDD.n328 VDD.n325 0.309405
R754 VDD.n352 VDD.n349 0.309405
R755 VDD.n370 VDD.n367 0.309405
R756 VDD.n420 VDD.n392 0.309405
R757 VDD.n316 VDD.n313 0.309333
R758 VDD.n322 VDD.n319 0.309333
R759 VDD.n108 VDD.n107 0.306263
R760 VDD.n130 VDD 0.423614
R761 VDD.n117 VDD.n116 0.298721
R762 VDD.n374 VDD.n35 0.29124
R763 VDD.n2 VDD.t2 0.549251
R764 VDD.n137 VDD.n136 0.284268
R765 VDD.n138 VDD.n137 0.282549
R766 VDD.n125 VDD.n124 0.282297
R767 VDD.n98 VDD.n139 0.279247
R768 VDD.n84 VDD.n154 0.279247
R769 VDD.n188 VDD.n1 0.435454
R770 VDD.n2 VDD.n1 0.0990054
R771 VDD.n148 VDD.n136 0.268799
R772 VDD.n100 VDD.n98 0.267977
R773 VDD.n118 VDD.n117 0.260496
R774 VDD.n388 VDD.n387 0.25999
R775 VDD.n433 VDD.n432 0.253639
R776 VDD.n405 VDD.n404 0.253639
R777 VDD.n113 VDD.n58 0.25333
R778 VDD.n434 VDD.n433 0.253298
R779 VDD.n406 VDD.n405 0.253298
R780 VDD VDD.n70 0.250961
R781 VDD.n36 VDD.n35 0.243044
R782 VDD.n139 VDD.n138 0.241768
R783 VDD.n115 VDD.n74 4.71183
R784 VDD.n67 VDD.n66 0.706063
R785 VDD VDD.n69 0.521582
R786 VDD.n72 VDD.n71 0.484477
R787 VDD.n63 VDD.t153 15.0439
R788 VDD.n63 VDD.n58 0.130762
R789 VDD.n66 VDD.n40 0.291774
R790 VDD.n85 VDD.n84 0.222977
R791 VDD.n32 VDD.n31 0.251712
R792 VDD.n26 VDD.n25 0.251712
R793 VDD.n24 VDD.n23 0.251712
R794 VDD.n150 VDD.n33 0.251712
R795 VDD.n20 VDD.n19 0.251712
R796 VDD.n18 VDD.n17 0.251712
R797 VDD.n104 VDD.n9 0.272485
R798 VDD.n8 VDD.n7 0.272485
R799 VDD.n103 VDD.n6 0.272485
R800 VDD.n5 VDD.n4 0.272485
R801 VDD.n102 VDD.n3 0.272485
R802 VDD.n101 VDD.n10 0.272485
R803 VDD.n29 VDD.n65 0.109866
R804 VDD.n58 VDD.n57 0.0835447
R805 VDD.n40 VDD.n37 0.100238
R806 VDD.n128 VDD.n127 0.202075
R807 VDD.n408 VDD.n397 0.191793
R808 VDD.n398 VDD.n389 0.191793
R809 VDD.n434 VDD.n69 0.189333
R810 VDD.n428 VDD.n425 0.184552
R811 VDD.n430 VDD.n394 0.184424
R812 VDD.n142 VDD.n141 0.181058
R813 VDD.n400 VDD.n396 0.17955
R814 VDD.n127 VDD.n126 0.175486
R815 VDD.n124 VDD.n123 0.171736
R816 VDD.n395 VDD.n133 0.169888
R817 VDD.n379 VDD.n378 0.16955
R818 VDD.n146 VDD.n99 0.210474
R819 VDD.n227 VDD.n226 0.162388
R820 VDD.n287 VDD.n286 0.162388
R821 VDD.n293 VDD.n292 0.162388
R822 VDD.n305 VDD.n304 0.162388
R823 VDD.n347 VDD.n346 0.162388
R824 VDD.n353 VDD.n352 0.162388
R825 VDD.n371 VDD.n370 0.162388
R826 VDD.n191 VDD.n190 0.16205
R827 VDD.n197 VDD.n196 0.16205
R828 VDD.n203 VDD.n202 0.16205
R829 VDD.n209 VDD.n208 0.16205
R830 VDD.n215 VDD.n214 0.16205
R831 VDD.n221 VDD.n220 0.16205
R832 VDD.n233 VDD.n232 0.16205
R833 VDD.n239 VDD.n238 0.16205
R834 VDD.n245 VDD.n244 0.16205
R835 VDD.n251 VDD.n250 0.16205
R836 VDD.n257 VDD.n256 0.16205
R837 VDD.n263 VDD.n262 0.16205
R838 VDD.n269 VDD.n268 0.16205
R839 VDD.n275 VDD.n274 0.16205
R840 VDD.n281 VDD.n280 0.16205
R841 VDD.n299 VDD.n298 0.16205
R842 VDD.n311 VDD.n310 0.16205
R843 VDD.n317 VDD.n316 0.16205
R844 VDD.n323 VDD.n322 0.16205
R845 VDD.n329 VDD.n328 0.16205
R846 VDD.n335 VDD.n334 0.16205
R847 VDD.n341 VDD.n340 0.16205
R848 VDD.n359 VDD.n358 0.16205
R849 VDD.n365 VDD.n364 0.16205
R850 VDD.n377 VDD.n376 0.16205
R851 VDD.n426 VDD.n394 0.161924
R852 VDD.n436 VDD.n425 0.161793
R853 VDD.n30 VDD 0.485468
R854 VDD.n41 VDD.n11 0.0957379
R855 VDD.n143 VDD.n142 0.159043
R856 VDD.n149 VDD.n148 0.157388
R857 VDD.n156 VDD.n155 0.157388
R858 VDD.n152 VDD.n151 0.157388
R859 VDD.n400 VDD.n397 0.154552
R860 VDD.n402 VDD.n389 0.154552
R861 VDD.n130 VDD.n129 0.152808
R862 VDD.n122 VDD.n121 0.152808
R863 VDD.n122 VDD.n120 0.152808
R864 VDD.n145 VDD.n140 0.15205
R865 VDD.n153 VDD.n72 0.15205
R866 VDD.n123 VDD.n122 0.147075
R867 VDD.n46 VDD.n144 0.236924
R868 VDD.n147 VDD.n145 0.134888
R869 VDD.n45 VDD.n44 0.134618
R870 VDD.n384 VDD.n383 0.133259
R871 VDD.n65 VDD.n64 0.133259
R872 VDD.n100 VDD.n99 0.16225
R873 VDD.n77 VDD.n75 0.128884
R874 VDD.n79 VDD.n78 0.128884
R875 VDD.n82 VDD.n81 0.128884
R876 VDD.n87 VDD.n86 0.128884
R877 VDD.n90 VDD.n89 0.128884
R878 VDD.n93 VDD.n92 0.128884
R879 VDD.n107 VDD.n106 0.127973
R880 VDD.n13 VDD.n143 0.947265
R881 VDD.n60 VDD.n59 0.185493
R882 VDD.n155 VDD.n85 0.1583
R883 VDD.n93 VDD.n104 0.141235
R884 VDD.n7 VDD.n90 0.141235
R885 VDD.n87 VDD.n103 0.141235
R886 VDD.n4 VDD.n82 0.141235
R887 VDD.n79 VDD.n102 0.141235
R888 VDD.n77 VDD.n101 0.141235
R889 VDD.n62 VDD.n60 0.0613757
R890 VDD.n147 VDD.n146 0.12205
R891 VDD.n135 VDD.n133 0.11955
R892 VDD.n396 VDD.n395 0.117388
R893 VDD.n192 VDD.n191 0.117388
R894 VDD.n198 VDD.n197 0.117388
R895 VDD.n204 VDD.n203 0.117388
R896 VDD.n210 VDD.n209 0.117388
R897 VDD.n216 VDD.n215 0.117388
R898 VDD.n222 VDD.n221 0.117388
R899 VDD.n234 VDD.n233 0.117388
R900 VDD.n240 VDD.n239 0.117388
R901 VDD.n246 VDD.n245 0.117388
R902 VDD.n252 VDD.n251 0.117388
R903 VDD.n258 VDD.n257 0.117388
R904 VDD.n264 VDD.n263 0.117388
R905 VDD.n270 VDD.n269 0.117388
R906 VDD.n276 VDD.n275 0.117388
R907 VDD.n282 VDD.n281 0.117388
R908 VDD.n300 VDD.n299 0.117388
R909 VDD.n312 VDD.n311 0.117388
R910 VDD.n318 VDD.n317 0.117388
R911 VDD.n324 VDD.n323 0.117388
R912 VDD.n330 VDD.n329 0.117388
R913 VDD.n336 VDD.n335 0.117388
R914 VDD.n342 VDD.n341 0.117388
R915 VDD.n360 VDD.n359 0.117388
R916 VDD.n366 VDD.n365 0.117388
R917 VDD.n378 VDD.n377 0.117388
R918 VDD.n228 VDD.n227 0.11705
R919 VDD.n288 VDD.n287 0.11705
R920 VDD.n294 VDD.n293 0.11705
R921 VDD.n306 VDD.n305 0.11705
R922 VDD.n348 VDD.n347 0.11705
R923 VDD.n354 VDD.n353 0.11705
R924 VDD.n372 VDD.n371 0.11705
R925 VDD.n59 VDD.n379 0.114888
R926 VDD.n31 VDD.n149 0.1133
R927 VDD.n151 VDD.n150 0.1133
R928 VDD.n44 VDD.n140 0.104888
R929 VDD.n154 VDD.n153 0.101138
R930 VDD.n63 VDD.n112 0.340529
R931 VDD.n56 VDD.n36 0.257619
R932 VDD.n40 VDD.n39 0.251665
R933 VDD.n141 VDD.n43 0.24736
R934 VDD.n114 VDD.n58 0.205524
R935 VDD.n381 VDD.n62 0.146235
R936 VDD.n384 VDD.n56 0.146235
R937 VDD.n95 VDD.n55 0.224985
R938 VDD.n54 VDD.n53 0.224985
R939 VDD.n96 VDD.n52 0.224985
R940 VDD.n51 VDD.n50 0.224985
R941 VDD.n97 VDD.n49 0.224985
R942 VDD.n48 VDD.n47 0.224985
R943 VDD.n12 VDD.n11 0.211235
R944 VDD.n28 VDD.t148 15.0336
R945 VDD.n17 VDD.n9 1.20647
R946 VDD.n8 VDD.n19 1.20647
R947 VDD.n33 VDD.n6 1.20647
R948 VDD.n5 VDD.n23 1.20647
R949 VDD.n25 VDD.n3 1.20647
R950 VDD.n10 VDD.n32 1.20646
R951 VDD.n34 VDD.n28 1.17026
R952 VDD.n1 VDD.n0 1.10286
R953 VDD.n16 VDD.n15 0.432612
R954 VDD.n22 VDD.n21 0.409065
R955 VDD.n48 VDD.n26 1.01698
R956 VDD.n49 VDD.n24 1.01698
R957 VDD.n51 VDD.n22 1.01698
R958 VDD.n52 VDD.n20 1.01698
R959 VDD.n54 VDD.n18 1.01698
R960 VDD.n55 VDD.n16 1.01698
R961 VSS.t579 VSS.n526 119321
R962 VSS.n595 VSS.n594 22369.4
R963 VSS.n91 VSS.n302 7907.02
R964 VSS.n522 VSS.n197 4670.31
R965 VSS.n854 VSS.n853 3068.57
R966 VSS.t247 VSS.n62 310.202
R967 VSS.t72 VSS.n67 310.202
R968 VSS.t567 VSS.n587 849.322
R969 VSS.n651 VSS.n650 572.005
R970 VSS.t124 VSS.t127 571.348
R971 VSS.n666 VSS.t250 566.691
R972 VSS.n665 VSS.t103 560.899
R973 VSS.n655 VSS.t522 550.193
R974 VSS.n681 VSS.t564 539.653
R975 VSS.t466 VSS.n663 532.819
R976 VSS.n684 VSS.t493 522.508
R977 VSS.n676 VSS.t478 521.236
R978 VSS.t52 VSS.n662 514.091
R979 VSS.n672 VSS.t472 504.839
R980 VSS.n658 VSS.t288 504.839
R981 VSS.n682 VSS.t494 491.87
R982 VSS.n667 VSS.t179 474.904
R983 VSS.t143 VSS.n598 470.019
R984 VSS.n223 VSS.n222 469.783
R985 VSS.n236 VSS.n235 469.783
R986 VSS.n258 VSS.n257 469.783
R987 VSS.n277 VSS.n276 469.783
R988 VSS.n290 VSS.n289 469.783
R989 VSS.n308 VSS.n307 469.783
R990 VSS.n668 VSS.t441 456.175
R991 VSS.n210 VSS.n207 454.007
R992 VSS.n905 VSS.n904 454.007
R993 VSS.n241 VSS.n238 454.007
R994 VSS.n890 VSS.n889 454.007
R995 VSS.n881 VSS.n880 454.007
R996 VSS.n295 VSS.n292 454.007
R997 VSS.n213 VSS.n212 453.986
R998 VSS.n902 VSS.n901 453.986
R999 VSS.n244 VSS.n243 453.986
R1000 VSS.n887 VSS.n886 453.986
R1001 VSS.n878 VSS.n877 453.986
R1002 VSS.n298 VSS.n297 453.986
R1003 VSS.n220 VSS.n213 453.986
R1004 VSS.n901 VSS.n227 453.986
R1005 VSS.n255 VSS.n244 453.986
R1006 VSS.n886 VSS.n267 453.986
R1007 VSS.n877 VSS.n281 453.986
R1008 VSS.n305 VSS.n298 453.986
R1009 VSS.t277 VSS.n252 448.228
R1010 VSS.t266 VSS.n189 442.469
R1011 VSS.t67 VSS.n191 437.62
R1012 VSS.n261 VSS.t50 431.863
R1013 VSS.t442 VSS.n60 427.695
R1014 VSS.n662 VSS.t176 427.219
R1015 VSS.t459 VSS.n262 419.459
R1016 VSS.t244 VSS.n304 413.68
R1017 VSS.t234 VSS.n287 413.68
R1018 VSS.t224 VSS.n274 413.68
R1019 VSS.t213 VSS.n254 413.68
R1020 VSS.t204 VSS.n233 413.68
R1021 VSS.t194 VSS.n219 413.68
R1022 VSS.n670 VSS.n669 412.791
R1023 VSS.n656 VSS.n68 412.791
R1024 VSS.n831 VSS.n830 412.522
R1025 VSS.n204 VSS.t68 403.072
R1026 VSS.t140 VSS.n682 401.591
R1027 VSS.n261 VSS.t276 397.313
R1028 VSS.n202 VSS.t349 391.555
R1029 VSS.t567 VSS.n832 388.781
R1030 VSS.t190 VSS.n220 385.798
R1031 VSS.t200 VSS.n227 385.798
R1032 VSS.t210 VSS.n255 385.798
R1033 VSS.t220 VSS.n267 385.798
R1034 VSS.t230 VSS.n281 385.798
R1035 VSS.t240 VSS.n305 385.798
R1036 VSS.n199 VSS.t104 384.887
R1037 VSS.n200 VSS.t163 380.038
R1038 VSS.t9 VSS.n61 375.276
R1039 VSS.t447 VSS.n670 372.094
R1040 VSS.t446 VSS.n656 372.094
R1041 VSS.t247 VSS.n675 363.339
R1042 VSS.t72 VSS.n661 363.339
R1043 VSS.t319 VSS.t566 359.769
R1044 VSS.t576 VSS.n195 357.007
R1045 VSS.n652 VSS.t253 347.49
R1046 VSS.t577 VSS.n193 333.974
R1047 VSS.n199 VSS.t65 333.065
R1048 VSS.t195 VSS.n219 333.063
R1049 VSS.t205 VSS.n233 333.063
R1050 VSS.t214 VSS.n254 333.063
R1051 VSS.t225 VSS.n274 333.063
R1052 VSS.t235 VSS.n287 333.063
R1053 VSS.n304 VSS.t245 333.063
R1054 VSS.t521 VSS.n603 329.238
R1055 VSS.n811 VSS.t124 327.81
R1056 VSS.t14 VSS.n187 322.457
R1057 VSS.n264 VSS.t435 322.457
R1058 VSS.t579 VSS.n852 314.327
R1059 VSS.n685 VSS.t492 313.659
R1060 VSS.n212 VSS.t188 305.183
R1061 VSS.n902 VSS.t198 305.183
R1062 VSS.n243 VSS.t208 305.183
R1063 VSS.n887 VSS.t218 305.183
R1064 VSS.n878 VSS.t228 305.183
R1065 VSS.n297 VSS.t238 305.183
R1066 VSS.t249 VSS.t623 304.42
R1067 VSS.t471 VSS.n673 304.42
R1068 VSS.t316 VSS.t353 304.42
R1069 VSS.t287 VSS.n659 304.42
R1070 VSS.t563 VSS.n684 299.735
R1071 VSS.n203 VSS.t265 299.425
R1072 VSS.t185 VSS.n210 293.666
R1073 VSS.n904 VSS.t196 293.666
R1074 VSS.t206 VSS.n241 293.666
R1075 VSS.n889 VSS.t215 293.666
R1076 VSS.n880 VSS.t226 293.666
R1077 VSS.t236 VSS.n295 293.666
R1078 VSS.n309 VSS.t159 292.757
R1079 VSS.t69 VSS.n286 292.757
R1080 VSS.t156 VSS.n273 292.757
R1081 VSS.t269 VSS.n250 292.757
R1082 VSS.t164 VSS.n253 292.757
R1083 VSS.t150 VSS.n232 292.757
R1084 VSS.t153 VSS.n218 292.757
R1085 VSS.t267 VSS.n185 292.757
R1086 VSS.t461 VSS.n672 291.37
R1087 VSS.t63 VSS.n658 291.37
R1088 VSS.n203 VSS.t105 287.909
R1089 VSS.n206 VSS.t444 275.505
R1090 VSS.t123 VSS.n189 269.724
R1091 VSS.t16 VSS.n187 264.875
R1092 VSS.n264 VSS.t436 264.875
R1093 VSS.t160 VSS.n302 258.238
R1094 VSS.n260 VSS.t165 258.236
R1095 VSS.n881 VSS.t157 258.233
R1096 VSS.n890 VSS.t270 258.233
R1097 VSS.n905 VSS.t154 258.233
R1098 VSS.n207 VSS.t268 258.233
R1099 VSS.n238 VSS.t151 258.233
R1100 VSS.n292 VSS.t70 258.233
R1101 VSS.t350 VSS.n192 258.231
R1102 VSS.t122 VSS.n193 253.359
R1103 VSS.t301 VSS.n93 252.375
R1104 VSS.t352 VSS.n103 252.375
R1105 VSS.t561 VSS.n107 252.375
R1106 VSS.t281 VSS.n116 252.375
R1107 VSS.n125 VSS.t262 252.375
R1108 VSS.t76 VSS.n127 252.375
R1109 VSS.n119 VSS.t569 252.375
R1110 VSS.t615 VSS.n136 252.375
R1111 VSS.t473 VSS.n109 252.375
R1112 VSS.n143 VSS.t536 252.375
R1113 VSS.t8 VSS.n104 252.375
R1114 VSS.t2 VSS.n152 252.375
R1115 VSS.n102 VSS.t452 252.375
R1116 VSS.n155 VSS.t325 252.375
R1117 VSS.n176 VSS.t449 252.374
R1118 VSS.n172 VSS.t624 252.374
R1119 VSS.n163 VSS.t83 252.374
R1120 VSS.t453 VSS.n126 252.117
R1121 VSS.t136 VSS.n129 252.117
R1122 VSS.t180 VSS.n117 252.117
R1123 VSS.t167 VSS.n135 252.117
R1124 VSS.t524 VSS.n114 252.117
R1125 VSS.t320 VSS.n111 252.117
R1126 VSS.n141 VSS.t540 252.117
R1127 VSS.n100 VSS.t296 252.117
R1128 VSS.t517 VSS.n156 252.117
R1129 VSS.n95 VSS.t181 252.117
R1130 VSS.n170 VSS.t261 252.115
R1131 VSS.n169 VSS.t51 252.115
R1132 VSS.n168 VSS.t177 252.115
R1133 VSS.n167 VSS.t617 252.115
R1134 VSS.n165 VSS.t321 252.115
R1135 VSS.t361 VSS.n351 250.837
R1136 VSS.t410 VSS.n352 250.837
R1137 VSS.t355 VSS.n356 250.837
R1138 VSS.t413 VSS.n357 250.837
R1139 VSS.t411 VSS.n361 250.837
R1140 VSS.t414 VSS.n362 250.837
R1141 VSS.t359 VSS.n366 250.837
R1142 VSS.t358 VSS.n367 250.837
R1143 VSS.t419 VSS.n371 250.837
R1144 VSS.t418 VSS.n372 250.837
R1145 VSS.t416 VSS.n376 250.837
R1146 VSS.t420 VSS.n377 250.837
R1147 VSS.t421 VSS.n381 250.837
R1148 VSS.t422 VSS.n382 250.837
R1149 VSS.t375 VSS.n386 250.837
R1150 VSS.t369 VSS.n387 250.837
R1151 VSS.t374 VSS.n391 250.837
R1152 VSS.t367 VSS.n392 250.837
R1153 VSS.t371 VSS.n396 250.837
R1154 VSS.t423 VSS.n397 250.837
R1155 VSS.t356 VSS.n401 250.837
R1156 VSS.t424 VSS.n402 250.837
R1157 VSS.t368 VSS.n406 250.837
R1158 VSS.t354 VSS.n407 250.837
R1159 VSS.t360 VSS.n411 250.837
R1160 VSS.t426 VSS.n412 250.837
R1161 VSS.t366 VSS.n416 250.837
R1162 VSS.t364 VSS.n417 250.837
R1163 VSS.t428 VSS.n421 250.837
R1164 VSS.t363 VSS.n422 250.837
R1165 VSS.t430 VSS.n426 250.837
R1166 VSS.t431 VSS.n427 250.837
R1167 VSS.t442 VSS.n62 148.06
R1168 VSS.t176 VSS.n67 148.06
R1169 VSS.n652 VSS.t521 243.244
R1170 VSS.n198 VSS.t121 240.956
R1171 VSS.t192 VSS.n221 240.956
R1172 VSS.t202 VSS.n234 240.956
R1173 VSS.t212 VSS.n256 240.956
R1174 VSS.t222 VSS.n275 240.956
R1175 VSS.t232 VSS.n288 240.956
R1176 VSS.t242 VSS.n306 240.956
R1177 VSS.n510 VSS.t312 234.114
R1178 VSS.n505 VSS.t39 234.114
R1179 VSS.n500 VSS.t620 234.114
R1180 VSS.n495 VSS.t99 234.114
R1181 VSS.n490 VSS.t45 234.114
R1182 VSS.n485 VSS.t303 234.114
R1183 VSS.n480 VSS.t170 234.114
R1184 VSS.n475 VSS.t439 234.114
R1185 VSS.n470 VSS.t618 234.114
R1186 VSS.n465 VSS.t497 234.114
R1187 VSS.n460 VSS.t531 234.114
R1188 VSS.n455 VSS.t31 234.114
R1189 VSS.n450 VSS.t433 234.114
R1190 VSS.n445 VSS.t555 234.114
R1191 VSS.n440 VSS.t47 234.114
R1192 VSS.n435 VSS.t468 234.114
R1193 VSS.t162 VSS.n195 230.327
R1194 VSS.n222 VSS.t192 229.44
R1195 VSS.n235 VSS.t202 229.44
R1196 VSS.n257 VSS.t212 229.44
R1197 VSS.n276 VSS.t222 229.44
R1198 VSS.n289 VSS.t232 229.44
R1199 VSS.n307 VSS.t242 229.44
R1200 VSS.t121 VSS.n197 228.827
R1201 VSS.t74 VSS.n123 225.361
R1202 VSS.t41 VSS.n130 225.361
R1203 VSS.t621 VSS.n132 225.361
R1204 VSS.t43 VSS.n137 225.361
R1205 VSS.t302 VSS.n138 225.361
R1206 VSS.t171 VSS.n139 225.361
R1207 VSS.t437 VSS.n106 225.361
R1208 VSS.t619 VSS.n144 225.361
R1209 VSS.t498 VSS.n147 225.361
R1210 VSS.t529 VSS.n150 225.361
R1211 VSS.t33 VSS.n153 225.361
R1212 VSS.t434 VSS.n99 225.361
R1213 VSS.t49 VSS.n94 225.361
R1214 VSS.n175 VSS.t313 225.359
R1215 VSS.n174 VSS.t98 225.359
R1216 VSS.n164 VSS.t554 225.359
R1217 VSS.t253 VSS.n651 224.516
R1218 VSS.t527 VSS.n40 216.093
R1219 VSS.n852 VSS.t527 215.731
R1220 VSS.t268 VSS.n185 212.143
R1221 VSS.t154 VSS.n218 212.143
R1222 VSS.t151 VSS.n232 212.143
R1223 VSS.t165 VSS.n253 212.143
R1224 VSS.t270 VSS.n250 212.143
R1225 VSS.t157 VSS.n273 212.143
R1226 VSS.t70 VSS.n286 212.143
R1227 VSS.n309 VSS.t160 212.143
R1228 VSS.n162 VSS.t328 211.982
R1229 VSS.n124 VSS.t119 211.982
R1230 VSS.t77 VSS.n120 211.982
R1231 VSS.n131 VSS.t17 211.982
R1232 VSS.n133 VSS.t89 211.982
R1233 VSS.t20 VSS.n115 211.982
R1234 VSS.t92 VSS.n113 211.982
R1235 VSS.t337 VSS.n110 211.982
R1236 VSS.t541 VSS.n108 211.982
R1237 VSS.n142 VSS.t309 211.982
R1238 VSS.n145 VSS.t273 211.982
R1239 VSS.n148 VSS.t28 211.982
R1240 VSS.n151 VSS.t322 211.982
R1241 VSS.n154 VSS.t340 211.982
R1242 VSS.t544 VSS.n98 211.982
R1243 VSS.n157 VSS.t147 211.982
R1244 VSS.n683 VSS.t140 208.828
R1245 VSS.n200 VSS.t162 207.294
R1246 VSS.n685 VSS.t563 202.362
R1247 VSS.n671 VSS.t447 202.071
R1248 VSS.n657 VSS.t446 202.071
R1249 VSS.n194 VSS.t122 200.649
R1250 VSS.n595 VSS.n0 197.518
R1251 VSS.n676 VSS.t9 196.911
R1252 VSS.n673 VSS.t461 196.399
R1253 VSS.n659 VSS.t63 196.399
R1254 VSS.n202 VSS.t350 195.778
R1255 VSS.t532 VSS.n121 195.26
R1256 VSS.t552 VSS.n128 195.26
R1257 VSS.t454 VSS.n118 195.26
R1258 VSS.t59 VSS.n134 195.26
R1259 VSS.t547 VSS.n112 195.26
R1260 VSS.t474 VSS.n140 195.26
R1261 VSS.t290 VSS.n105 195.26
R1262 VSS.t575 VSS.n146 195.26
R1263 VSS.t479 VSS.n149 195.26
R1264 VSS.t538 VSS.n101 195.26
R1265 VSS.t109 VSS.n97 195.26
R1266 VSS.t560 VSS.n96 195.26
R1267 VSS.n173 VSS.t111 195.26
R1268 VSS.n171 VSS.t3 195.26
R1269 VSS.n166 VSS.t306 195.26
R1270 VSS.n161 VSS.t456 195.26
R1271 VSS.t444 VSS.n186 194.899
R1272 VSS.n833 VSS.t567 194.514
R1273 VSS.t436 VSS.n251 189.137
R1274 VSS.n206 VSS.t16 189.135
R1275 VSS.t492 VSS.n596 187.895
R1276 VSS.n511 VSS.t251 187.292
R1277 VSS.n506 VSS.t557 187.292
R1278 VSS.n501 VSS.t326 187.292
R1279 VSS.n496 VSS.t556 187.292
R1280 VSS.n491 VSS.t348 187.292
R1281 VSS.n486 VSS.t570 187.292
R1282 VSS.n481 VSS.t0 187.292
R1283 VSS.n476 VSS.t292 187.292
R1284 VSS.n471 VSS.t35 187.292
R1285 VSS.n466 VSS.t138 187.292
R1286 VSS.n461 VSS.t279 187.292
R1287 VSS.n456 VSS.t263 187.292
R1288 VSS.n451 VSS.t562 187.292
R1289 VSS.n446 VSS.t351 187.292
R1290 VSS.n441 VSS.t518 187.292
R1291 VSS.n436 VSS.t255 187.292
R1292 VSS.n204 VSS.t123 184.262
R1293 VSS.t246 VSS.n668 183.975
R1294 VSS.n674 VSS.t471 182.797
R1295 VSS.n660 VSS.t287 182.797
R1296 VSS.n8 VSS.t558 177.713
R1297 VSS.n186 VSS.t267 177.617
R1298 VSS.n251 VSS.t269 177.617
R1299 VSS.n224 VSS.t153 177.615
R1300 VSS.n237 VSS.t150 177.615
R1301 VSS.n259 VSS.t164 177.615
R1302 VSS.n278 VSS.t156 177.615
R1303 VSS.n291 VSS.t69 177.615
R1304 VSS.t159 VSS.n303 177.615
R1305 VSS.t81 VSS.n355 173.913
R1306 VSS.t283 VSS.n360 173.913
R1307 VSS.n365 VSS.t335 173.913
R1308 VSS.t96 VSS.n370 173.913
R1309 VSS.n375 VSS.t102 173.913
R1310 VSS.n380 VSS.t85 173.913
R1311 VSS.t344 VSS.n385 173.913
R1312 VSS.t482 VSS.n390 173.913
R1313 VSS.t332 VSS.n395 173.913
R1314 VSS.t487 VSS.n400 173.913
R1315 VSS.t572 VSS.n405 173.913
R1316 VSS.t88 VSS.n410 173.913
R1317 VSS.n415 VSS.t346 173.913
R1318 VSS.t484 VSS.n420 173.913
R1319 VSS.n425 VSS.t24 173.913
R1320 VSS.t285 VSS.n430 173.913
R1321 VSS.n432 VSS.n91 173.913
R1322 VSS.t64 VSS.n655 167.954
R1323 VSS.t120 VSS.t533 163.881
R1324 VSS.t78 VSS.t551 163.881
R1325 VSS.t18 VSS.t455 163.881
R1326 VSS.t90 VSS.t57 163.881
R1327 VSS.t21 VSS.t113 163.881
R1328 VSS.t93 VSS.t549 163.881
R1329 VSS.t338 VSS.t4 163.881
R1330 VSS.t542 VSS.t475 163.881
R1331 VSS.t310 VSS.t291 163.881
R1332 VSS.t274 VSS.t574 163.881
R1333 VSS.t29 VSS.t480 163.881
R1334 VSS.t323 VSS.t304 163.881
R1335 VSS.t341 VSS.t537 163.881
R1336 VSS.t545 VSS.t107 163.881
R1337 VSS.t148 VSS.t559 163.881
R1338 VSS.t329 VSS.t457 163.881
R1339 VSS.n211 VSS.t185 160.341
R1340 VSS.n225 VSS.t196 160.341
R1341 VSS.n242 VSS.t206 160.341
R1342 VSS.n265 VSS.t215 160.341
R1343 VSS.n279 VSS.t226 160.341
R1344 VSS.n296 VSS.t236 160.341
R1345 VSS.t515 VSS.n180 157.601
R1346 VSS.n181 VSS.t513 156.464
R1347 VSS.t616 VSS.n124 155.126
R1348 VSS.t294 VSS.n120 155.126
R1349 VSS.t495 VSS.n131 155.126
R1350 VSS.t490 VSS.n133 155.126
R1351 VSS.t573 VSS.n115 155.126
R1352 VSS.t622 VSS.n113 155.126
R1353 VSS.t178 VSS.n110 155.126
R1354 VSS.t460 VSS.n108 155.126
R1355 VSS.t141 VSS.n142 155.126
R1356 VSS.t271 VSS.n145 155.126
R1357 VSS.t565 VSS.n148 155.126
R1358 VSS.t451 VSS.n151 155.126
R1359 VSS.t26 VSS.n154 155.126
R1360 VSS.t526 VSS.n98 155.126
R1361 VSS.t477 VSS.n157 155.126
R1362 VSS.n162 VSS.t37 155.125
R1363 VSS.n568 VSS.t590 154.613
R1364 VSS.n579 VSS.t597 154.613
R1365 VSS.t265 VSS.n190 153.971
R1366 VSS.n181 VSS.t117 153.851
R1367 VSS.n520 VSS.t464 153.846
R1368 VSS.n511 VSS.t80 153.846
R1369 VSS.n506 VSS.t282 153.846
R1370 VSS.n501 VSS.t334 153.846
R1371 VSS.n496 VSS.t95 153.846
R1372 VSS.n491 VSS.t101 153.846
R1373 VSS.n486 VSS.t84 153.846
R1374 VSS.n481 VSS.t343 153.846
R1375 VSS.n476 VSS.t481 153.846
R1376 VSS.n471 VSS.t331 153.846
R1377 VSS.n466 VSS.t486 153.846
R1378 VSS.n461 VSS.t571 153.846
R1379 VSS.n456 VSS.t87 153.846
R1380 VSS.n451 VSS.t345 153.846
R1381 VSS.n446 VSS.t483 153.846
R1382 VSS.n441 VSS.t23 153.846
R1383 VSS.n436 VSS.t284 153.846
R1384 VSS.t516 VSS.n90 153.236
R1385 VSS.t105 VSS.n191 149.713
R1386 VSS.t188 VSS.n211 148.826
R1387 VSS.t198 VSS.n225 148.826
R1388 VSS.t208 VSS.n242 148.826
R1389 VSS.t218 VSS.n265 148.826
R1390 VSS.t228 VSS.n279 148.826
R1391 VSS.t238 VSS.n296 148.826
R1392 VSS.n3 VSS.t467 147.453
R1393 VSS.t6 VSS.n354 147.157
R1394 VSS.t137 VSS.n359 147.157
R1395 VSS.t476 VSS.n364 147.157
R1396 VSS.t458 VSS.n369 147.157
R1397 VSS.t491 VSS.n374 147.157
R1398 VSS.t298 VSS.n379 147.157
R1399 VSS.t145 VSS.n384 147.157
R1400 VSS.t450 VSS.n389 147.157
R1401 VSS.t307 VSS.n394 147.157
R1402 VSS.t61 VSS.n399 147.157
R1403 VSS.t443 VSS.n404 147.157
R1404 VSS.t300 VSS.n409 147.157
R1405 VSS.t470 VSS.n414 147.157
R1406 VSS.t496 VSS.n419 147.157
R1407 VSS.t184 VSS.n424 147.157
R1408 VSS.t550 VSS.n429 147.157
R1409 VSS.t613 VSS.n159 145.091
R1410 VSS.t623 VSS.n674 138.607
R1411 VSS.t353 VSS.n660 138.607
R1412 VSS.n159 VSS.t609 138.403
R1413 VSS.t245 VSS.n303 137.311
R1414 VSS.n291 VSS.t235 137.311
R1415 VSS.n278 VSS.t225 137.311
R1416 VSS.n259 VSS.t214 137.311
R1417 VSS.n237 VSS.t205 137.311
R1418 VSS.n224 VSS.t195 137.311
R1419 VSS.t65 VSS.n198 137.309
R1420 VSS.n650 VSS.n605 132.891
R1421 VSS.t609 VSS.n158 131.972
R1422 VSS.n188 VSS.t14 130.939
R1423 VSS.t435 VSS.n263 130.939
R1424 VSS.n861 VSS.t11 127.421
R1425 VSS.t372 VSS.n1 125.359
R1426 VSS.t535 VSS.n857 123.674
R1427 VSS.n596 VSS.n595 122.129
R1428 VSS.n598 VSS.t319 121.858
R1429 VSS.t513 VSS.n90 120.691
R1430 VSS.n201 VSS.t577 119.422
R1431 VSS.n178 VSS.t514 118.249
R1432 VSS.n432 VSS.t613 117.058
R1433 VSS.n856 VSS.t173 116.177
R1434 VSS.t441 VSS.n667 115.831
R1435 VSS.t118 VSS.n588 112.174
R1436 VSS.t174 VSS.n859 108.683
R1437 VSS.n650 VSS.n649 107.175
R1438 VSS.n513 VSS.t616 107.023
R1439 VSS.n510 VSS.t6 107.023
R1440 VSS.n508 VSS.t294 107.023
R1441 VSS.n505 VSS.t137 107.023
R1442 VSS.n503 VSS.t495 107.023
R1443 VSS.n500 VSS.t476 107.023
R1444 VSS.n498 VSS.t490 107.023
R1445 VSS.n495 VSS.t458 107.023
R1446 VSS.n493 VSS.t573 107.023
R1447 VSS.n490 VSS.t491 107.023
R1448 VSS.n488 VSS.t622 107.023
R1449 VSS.n485 VSS.t298 107.023
R1450 VSS.n483 VSS.t178 107.023
R1451 VSS.n480 VSS.t145 107.023
R1452 VSS.n478 VSS.t460 107.023
R1453 VSS.n475 VSS.t450 107.023
R1454 VSS.n473 VSS.t141 107.023
R1455 VSS.n470 VSS.t307 107.023
R1456 VSS.n468 VSS.t271 107.023
R1457 VSS.n465 VSS.t61 107.023
R1458 VSS.n463 VSS.t565 107.023
R1459 VSS.n460 VSS.t443 107.023
R1460 VSS.n458 VSS.t451 107.023
R1461 VSS.n455 VSS.t300 107.023
R1462 VSS.n453 VSS.t26 107.023
R1463 VSS.n450 VSS.t470 107.023
R1464 VSS.n448 VSS.t526 107.023
R1465 VSS.n445 VSS.t496 107.023
R1466 VSS.n443 VSS.t477 107.023
R1467 VSS.n440 VSS.t184 107.023
R1468 VSS.t37 VSS.n438 107.023
R1469 VSS.n435 VSS.t550 107.023
R1470 VSS.t182 VSS.n854 106.808
R1471 VSS.n599 VSS.t143 103.538
R1472 VSS.n687 VSS.t175 103.379
R1473 VSS.n520 VSS.t603 100.335
R1474 VSS.t80 VSS.n354 100.335
R1475 VSS.t282 VSS.n359 100.335
R1476 VSS.t334 VSS.n364 100.335
R1477 VSS.t95 VSS.n369 100.335
R1478 VSS.t101 VSS.n374 100.335
R1479 VSS.t84 VSS.n379 100.335
R1480 VSS.t343 VSS.n384 100.335
R1481 VSS.t481 VSS.n389 100.335
R1482 VSS.t331 VSS.n394 100.335
R1483 VSS.t486 VSS.n399 100.335
R1484 VSS.t571 VSS.n404 100.335
R1485 VSS.t87 VSS.n409 100.335
R1486 VSS.t345 VSS.n414 100.335
R1487 VSS.t483 VSS.n419 100.335
R1488 VSS.t23 VSS.n424 100.335
R1489 VSS.t284 VSS.n429 100.335
R1490 VSS.n568 VSS.t593 99.7511
R1491 VSS.n579 VSS.t599 99.7511
R1492 VSS.n686 VSS.t168 98.4633
R1493 VSS.t599 VSS.n2 97.9284
R1494 VSS.t593 VSS.n1 97.9284
R1495 VSS.t179 VSS.n666 97.5777
R1496 VSS.t115 VSS.n863 97.4396
R1497 VSS.n196 VSS.t576 96.3896
R1498 VSS.n180 VSS.t13 93.8889
R1499 VSS.n863 VSS.t183 93.6919
R1500 VSS.n158 VSS.t285 88.4947
R1501 VSS.n177 VSS.t511 88.4111
R1502 VSS.t493 VSS.n683 88.3462
R1503 VSS.n170 VSS.t344 88.2366
R1504 VSS.n169 VSS.t332 88.2366
R1505 VSS.n168 VSS.t487 88.2366
R1506 VSS.n167 VSS.t572 88.2366
R1507 VSS.n165 VSS.t88 88.2366
R1508 VSS.n126 VSS.t81 88.2359
R1509 VSS.n129 VSS.t283 88.2359
R1510 VSS.t335 VSS.n117 88.2359
R1511 VSS.n135 VSS.t96 88.2359
R1512 VSS.t102 VSS.n114 88.2359
R1513 VSS.t85 VSS.n111 88.2359
R1514 VSS.n141 VSS.t482 88.2359
R1515 VSS.t346 VSS.n100 88.2359
R1516 VSS.n156 VSS.t484 88.2359
R1517 VSS.t24 VSS.n95 88.2359
R1518 VSS.t603 VSS.t462 86.957
R1519 VSS.t464 VSS.t605 86.957
R1520 VSS.t472 VSS.n671 85.7923
R1521 VSS.t288 VSS.n657 85.7923
R1522 VSS.t104 VSS.n196 84.8733
R1523 VSS.t511 VSS.n522 83.0562
R1524 VSS.n859 VSS.t512 82.449
R1525 VSS.t494 VSS.n681 81.2384
R1526 VSS.n5 VSS.t372 80.4704
R1527 VSS.n781 VSS.t257 77.8798
R1528 VSS.n831 VSS.t55 77.2751
R1529 VSS.t520 VSS.t314 77.2751
R1530 VSS.n832 VSS.t566 75.4357
R1531 VSS.t512 VSS.n179 75.2962
R1532 VSS.t534 VSS.n856 74.9537
R1533 VSS.t462 VSS.n122 74.8587
R1534 VSS.n614 VSS.t489 74.7824
R1535 VSS.t163 VSS.n194 73.9692
R1536 VSS.t318 VSS.n589 73.536
R1537 VSS.n594 VSS.n590 73.536
R1538 VSS.n513 VSS.t120 70.2346
R1539 VSS.n508 VSS.t78 70.2346
R1540 VSS.n503 VSS.t18 70.2346
R1541 VSS.n498 VSS.t90 70.2346
R1542 VSS.n493 VSS.t21 70.2346
R1543 VSS.n488 VSS.t93 70.2346
R1544 VSS.n483 VSS.t338 70.2346
R1545 VSS.n478 VSS.t542 70.2346
R1546 VSS.n473 VSS.t310 70.2346
R1547 VSS.n468 VSS.t274 70.2346
R1548 VSS.n463 VSS.t29 70.2346
R1549 VSS.n458 VSS.t323 70.2346
R1550 VSS.n453 VSS.t341 70.2346
R1551 VSS.n448 VSS.t545 70.2346
R1552 VSS.n443 VSS.t148 70.2346
R1553 VSS.n438 VSS.t329 70.2346
R1554 VSS.n830 VSS.n41 6.23647
R1555 VSS.n730 VSS.t501 69.1047
R1556 VSS.n221 VSS.t190 68.211
R1557 VSS.n234 VSS.t200 68.211
R1558 VSS.n256 VSS.t210 68.211
R1559 VSS.n275 VSS.t220 68.211
R1560 VSS.n288 VSS.t230 68.211
R1561 VSS.n306 VSS.t240 68.211
R1562 VSS.n857 VSS.t534 67.4583
R1563 VSS.t259 VSS.n705 66.9109
R1564 VSS.n512 VSS.t532 66.8901
R1565 VSS.t251 VSS.n352 66.8901
R1566 VSS.n507 VSS.t552 66.8901
R1567 VSS.t557 VSS.n357 66.8901
R1568 VSS.n502 VSS.t454 66.8901
R1569 VSS.t326 VSS.n362 66.8901
R1570 VSS.n497 VSS.t59 66.8901
R1571 VSS.t556 VSS.n367 66.8901
R1572 VSS.t111 VSS.n492 66.8901
R1573 VSS.t348 VSS.n372 66.8901
R1574 VSS.n487 VSS.t547 66.8901
R1575 VSS.t570 VSS.n377 66.8901
R1576 VSS.t3 VSS.n482 66.8901
R1577 VSS.t0 VSS.n382 66.8901
R1578 VSS.n477 VSS.t474 66.8901
R1579 VSS.t292 VSS.n387 66.8901
R1580 VSS.n472 VSS.t290 66.8901
R1581 VSS.t35 VSS.n392 66.8901
R1582 VSS.n467 VSS.t575 66.8901
R1583 VSS.t138 VSS.n397 66.8901
R1584 VSS.n462 VSS.t479 66.8901
R1585 VSS.t279 VSS.n402 66.8901
R1586 VSS.t306 VSS.n457 66.8901
R1587 VSS.t263 VSS.n407 66.8901
R1588 VSS.n452 VSS.t538 66.8901
R1589 VSS.t562 VSS.n412 66.8901
R1590 VSS.n447 VSS.t109 66.8901
R1591 VSS.t351 VSS.n417 66.8901
R1592 VSS.n442 VSS.t560 66.8901
R1593 VSS.t518 VSS.n422 66.8901
R1594 VSS.t456 VSS.n437 66.8901
R1595 VSS.t255 VSS.n427 66.8901
R1596 VSS.t388 VSS.n643 65.367
R1597 VSS.n649 VSS.t377 65.3639
R1598 VSS.t13 VSS.n861 63.7107
R1599 VSS.t183 VSS.n862 62.4441
R1600 VSS.n642 VSS.t392 62.1548
R1601 VSS.t349 VSS.n201 61.8407
R1602 VSS.n594 VSS.n593 59.3547
R1603 VSS.n864 VSS.t115 58.6964
R1604 VSS.t506 VSS.n712 58.1358
R1605 VSS.t489 VSS.n605 58.1084
R1606 VSS.t467 VSS.n2 58.0264
R1607 VSS.n663 VSS.t52 57.9156
R1608 VSS.t276 VSS.n252 56.6734
R1609 VSS.n223 VSS.t194 56.0825
R1610 VSS.n236 VSS.t204 56.0825
R1611 VSS.n258 VSS.t213 56.0825
R1612 VSS.n277 VSS.t224 56.0825
R1613 VSS.n290 VSS.t234 56.0825
R1614 VSS.n308 VSS.t244 56.0825
R1615 VSS.n762 VSS.t503 55.942
R1616 VSS.t384 VSS.n645 55.7348
R1617 VSS.n647 VSS.t382 55.7328
R1618 VSS.t514 VSS.n177 54.6841
R1619 VSS.t579 VSS.n525 53.7482
R1620 VSS.n614 VSS.t568 52.3478
R1621 VSS.t478 VSS.n60 51.2456
R1622 VSS.t68 VSS.n188 50.3244
R1623 VSS.n263 VSS.t459 50.3244
R1624 VSS.t119 VSS.n351 50.1677
R1625 VSS.n356 VSS.t77 50.1677
R1626 VSS.t17 VSS.n361 50.1677
R1627 VSS.t89 VSS.n366 50.1677
R1628 VSS.n371 VSS.t20 50.1677
R1629 VSS.n376 VSS.t92 50.1677
R1630 VSS.n381 VSS.t337 50.1677
R1631 VSS.n386 VSS.t541 50.1677
R1632 VSS.t309 VSS.n391 50.1677
R1633 VSS.t273 VSS.n396 50.1677
R1634 VSS.t28 VSS.n401 50.1677
R1635 VSS.t322 VSS.n406 50.1677
R1636 VSS.t340 VSS.n411 50.1677
R1637 VSS.n416 VSS.t544 50.1677
R1638 VSS.t147 VSS.n421 50.1677
R1639 VSS.t328 VSS.n426 50.1677
R1640 VSS.t582 VSS.n748 49.3606
R1641 VSS.n860 VSS.t174 47.4535
R1642 VSS.n772 VSS.t258 47.1669
R1643 VSS.n771 VSS.t260 47.1669
R1644 VSS.n686 VSS.t318 46.116
R1645 VSS.n645 VSS.t386 46.1011
R1646 VSS.t380 VSS.n647 46.1002
R1647 VSS.t499 VSS.n722 44.9731
R1648 VSS.n675 VSS.t249 44.1903
R1649 VSS.n661 VSS.t316 44.1903
R1650 VSS.t597 VSS.n5 43.0642
R1651 VSS.t590 VSS.n0 43.0619
R1652 VSS.t55 VSS.n588 42.3769
R1653 VSS.t173 VSS.n855 39.9582
R1654 VSS.t390 VSS.n642 39.6805
R1655 VSS.n664 VSS.t466 39.1873
R1656 VSS.n723 VSS.t499 38.3917
R1657 VSS.n515 VSS.t74 36.7898
R1658 VSS.t313 VSS.n509 36.7898
R1659 VSS.n504 VSS.t41 36.7898
R1660 VSS.n499 VSS.t621 36.7898
R1661 VSS.t98 VSS.n494 36.7898
R1662 VSS.n489 VSS.t43 36.7898
R1663 VSS.n484 VSS.t302 36.7898
R1664 VSS.n479 VSS.t171 36.7898
R1665 VSS.n474 VSS.t437 36.7898
R1666 VSS.n469 VSS.t619 36.7898
R1667 VSS.n464 VSS.t498 36.7898
R1668 VSS.n459 VSS.t529 36.7898
R1669 VSS.n454 VSS.t33 36.7898
R1670 VSS.n449 VSS.t434 36.7898
R1671 VSS.t554 VSS.n444 36.7898
R1672 VSS.n439 VSS.t49 36.7898
R1673 VSS.n853 VSS.t579 36.5305
R1674 VSS.n643 VSS.t390 36.4683
R1675 VSS.n855 VSS.t182 36.2105
R1676 VSS.t258 VSS.n697 36.1979
R1677 VSS.t260 VSS.n770 36.1979
R1678 VSS.n179 VSS.t535 34.07
R1679 VSS.n751 VSS.t582 34.0042
R1680 VSS.t564 VSS.n599 33.9067
R1681 VSS.t175 VSS.n589 31.1596
R1682 VSS.t386 VSS.n644 30.0494
R1683 VSS.n648 VSS.t380 30.0425
R1684 VSS.t11 VSS.n860 28.7152
R1685 VSS.n854 VSS.n178 28.3058
R1686 VSS.t533 VSS.n125 28.2938
R1687 VSS.t113 VSS.n136 28.2938
R1688 VSS.t4 VSS.n109 28.2938
R1689 VSS.t291 VSS.n143 28.2938
R1690 VSS.t574 VSS.n104 28.2938
R1691 VSS.t537 VSS.n102 28.2938
R1692 VSS.t551 VSS.n127 28.2938
R1693 VSS.t455 VSS.n119 28.2938
R1694 VSS.t57 VSS.n116 28.2938
R1695 VSS.t475 VSS.n107 28.2938
R1696 VSS.t480 VSS.n103 28.2938
R1697 VSS.t304 VSS.n152 28.2938
R1698 VSS.t107 VSS.n155 28.2938
R1699 VSS.t457 VSS.n93 28.2938
R1700 VSS.t549 VSS.n172 28.2936
R1701 VSS.t559 VSS.n163 28.2936
R1702 VSS.n122 VSS.t516 28.0352
R1703 VSS.t558 VSS.n3 27.7516
R1704 VSS.t103 VSS.n664 27.6043
R1705 VSS.t503 VSS.n761 27.4228
R1706 VSS.n190 VSS.t266 27.2918
R1707 VSS.n755 VSS.t506 25.229
R1708 VSS.t314 VSS.n593 24.4565
R1709 VSS.n687 VSS.t118 22.3643
R1710 VSS.t250 VSS.n665 22.2881
R1711 VSS.n603 VSS.t522 22.2881
R1712 VSS.n262 VSS.t277 22.1486
R1713 VSS.t50 VSS.n260 22.1466
R1714 VSS.t605 VSS.n176 21.6046
R1715 VSS.t168 VSS.n590 21.1887
R1716 VSS.t382 VSS.n646 20.4117
R1717 VSS.n646 VSS.t384 20.4113
R1718 VSS.t312 VSS.n355 20.0674
R1719 VSS.t39 VSS.n360 20.0674
R1720 VSS.t620 VSS.n365 20.0674
R1721 VSS.t99 VSS.n370 20.0674
R1722 VSS.t45 VSS.n375 20.0674
R1723 VSS.t303 VSS.n380 20.0674
R1724 VSS.t170 VSS.n385 20.0674
R1725 VSS.t439 VSS.n390 20.0674
R1726 VSS.t618 VSS.n395 20.0674
R1727 VSS.t497 VSS.n400 20.0674
R1728 VSS.t531 VSS.n405 20.0674
R1729 VSS.t31 VSS.n410 20.0674
R1730 VSS.t433 VSS.n415 20.0674
R1731 VSS.t555 VSS.n420 20.0674
R1732 VSS.t47 VSS.n425 20.0674
R1733 VSS.t468 VSS.n430 20.0674
R1734 VSS.t567 VSS.t568 19.9423
R1735 VSS.n175 VSS.t453 18.0025
R1736 VSS.n174 VSS.t167 18.0025
R1737 VSS.n173 VSS.t615 18.0025
R1738 VSS.n171 VSS.t473 18.0025
R1739 VSS.n166 VSS.t2 18.0025
R1740 VSS.n164 VSS.t517 18.0025
R1741 VSS.n161 VSS.t301 18.0025
R1742 VSS.t449 VSS.n123 18.0017
R1743 VSS.t262 VSS.n121 18.0017
R1744 VSS.n128 VSS.t76 18.0017
R1745 VSS.n130 VSS.t136 18.0017
R1746 VSS.t569 VSS.n118 18.0017
R1747 VSS.n132 VSS.t180 18.0017
R1748 VSS.n134 VSS.t281 18.0017
R1749 VSS.n137 VSS.t524 18.0017
R1750 VSS.t624 VSS.n112 18.0017
R1751 VSS.n138 VSS.t320 18.0017
R1752 VSS.t261 VSS.n139 18.0017
R1753 VSS.n140 VSS.t561 18.0017
R1754 VSS.t540 VSS.n106 18.0017
R1755 VSS.t536 VSS.n105 18.0017
R1756 VSS.t51 VSS.n144 18.0017
R1757 VSS.n146 VSS.t8 18.0017
R1758 VSS.t177 VSS.n147 18.0017
R1759 VSS.n149 VSS.t352 18.0017
R1760 VSS.t617 VSS.n150 18.0017
R1761 VSS.t321 VSS.n153 18.0017
R1762 VSS.t452 VSS.n101 18.0017
R1763 VSS.t296 VSS.n99 18.0017
R1764 VSS.t325 VSS.n97 18.0017
R1765 VSS.t83 VSS.n96 18.0017
R1766 VSS.t181 VSS.n94 18.0017
R1767 VSS.t117 VSS.n864 17.4722
R1768 VSS.n88 VSS.n523 17.0005
R1769 VSS.n88 VSS.n856 17.0005
R1770 VSS.n88 VSS.n857 17.0005
R1771 VSS.n88 VSS.n859 17.0005
R1772 VSS.n88 VSS.n861 17.0005
R1773 VSS.n88 VSS.n863 17.0005
R1774 VSS.n88 VSS.n521 17.0005
R1775 VSS.n88 VSS.t465 17.0005
R1776 VSS.n865 VSS.n88 17.0005
R1777 VSS.n88 VSS.n160 17.0005
R1778 VSS.n305 VSS.n299 17.0005
R1779 VSS.n870 VSS.n294 17.0005
R1780 VSS.n297 VSS.n293 17.0005
R1781 VSS.n295 VSS.n293 17.0005
R1782 VSS.n283 VSS.n281 17.0005
R1783 VSS.n876 VSS.n282 17.0005
R1784 VSS.n879 VSS.n878 17.0005
R1785 VSS.n880 VSS.n879 17.0005
R1786 VSS.n269 VSS.n267 17.0005
R1787 VSS.n885 VSS.n268 17.0005
R1788 VSS.n888 VSS.n887 17.0005
R1789 VSS.n889 VSS.n888 17.0005
R1790 VSS.n891 VSS.n264 17.0005
R1791 VSS.n891 VSS.n261 17.0005
R1792 VSS.n255 VSS.n245 17.0005
R1793 VSS.n894 VSS.n240 17.0005
R1794 VSS.n243 VSS.n239 17.0005
R1795 VSS.n241 VSS.n239 17.0005
R1796 VSS.n229 VSS.n227 17.0005
R1797 VSS.n900 VSS.n228 17.0005
R1798 VSS.n903 VSS.n902 17.0005
R1799 VSS.n904 VSS.n903 17.0005
R1800 VSS.n220 VSS.n214 17.0005
R1801 VSS.n909 VSS.n209 17.0005
R1802 VSS.n212 VSS.n208 17.0005
R1803 VSS.n210 VSS.n208 17.0005
R1804 VSS.n912 VSS.n187 17.0005
R1805 VSS.n912 VSS.n204 17.0005
R1806 VSS.n912 VSS.n203 17.0005
R1807 VSS.n912 VSS.n191 17.0005
R1808 VSS.n912 VSS.n202 17.0005
R1809 VSS.n912 VSS.n193 17.0005
R1810 VSS.n912 VSS.n200 17.0005
R1811 VSS.n912 VSS.n195 17.0005
R1812 VSS.n88 VSS.n346 17.0005
R1813 VSS.n88 VSS.n348 17.0005
R1814 VSS.t10 VSS.n676 17.0005
R1815 VSS.t10 VSS.n62 13.5064
R1816 VSS.n675 VSS.t448 17.0005
R1817 VSS.n673 VSS.t448 17.0005
R1818 VSS.n670 VSS.t448 17.0005
R1819 VSS.n667 VSS.n65 17.0005
R1820 VSS.n663 VSS.n65 17.0005
R1821 VSS.n67 VSS.n65 13.5064
R1822 VSS.n661 VSS.t289 17.0005
R1823 VSS.n659 VSS.t289 17.0005
R1824 VSS.n656 VSS.t289 17.0005
R1825 VSS.n655 VSS.n654 17.0005
R1826 VSS.n654 VSS.n652 17.0005
R1827 VSS.t56 VSS.n831 17.0005
R1828 VSS.t56 VSS.n588 17.0005
R1829 VSS.t56 VSS.n589 17.0005
R1830 VSS.t56 VSS.n686 17.0005
R1831 VSS.t56 VSS.n590 17.0005
R1832 VSS.t56 VSS.n685 17.0005
R1833 VSS.n615 VSS.n614 17.0005
R1834 VSS.n832 VSS.t56 17.0005
R1835 VSS.t56 VSS.n598 17.0005
R1836 VSS.t56 VSS.n681 17.0005
R1837 VSS.n7 VSS.n555 17.0005
R1838 VSS.n7 VSS.n559 17.0005
R1839 VSS.n7 VSS.n562 17.0005
R1840 VSS.n7 VSS.n578 17.0005
R1841 VSS.n7 VSS.n576 17.0005
R1842 VSS.n7 VSS.n4 17.0005
R1843 VSS.n553 VSS.n7 17.0005
R1844 VSS.n688 VSS.n41 12.4712
R1845 VSS.n746 VSS.n40 17.0005
R1846 VSS.n748 VSS.n40 17.0005
R1847 VSS.n751 VSS.n40 17.0005
R1848 VSS.n749 VSS.n40 17.0005
R1849 VSS.n735 VSS.n40 17.0005
R1850 VSS.n733 VSS.n40 17.0005
R1851 VSS.n730 VSS.n40 17.0005
R1852 VSS.n729 VSS.n40 17.0005
R1853 VSS.n727 VSS.n40 17.0005
R1854 VSS.n725 VSS.n40 17.0005
R1855 VSS.n723 VSS.n40 17.0005
R1856 VSS.n722 VSS.n40 17.0005
R1857 VSS.n720 VSS.n40 17.0005
R1858 VSS.n718 VSS.n40 17.0005
R1859 VSS.n714 VSS.n40 17.0005
R1860 VSS.n712 VSS.n40 17.0005
R1861 VSS.n755 VSS.n40 17.0005
R1862 VSS.n757 VSS.n40 17.0005
R1863 VSS.n759 VSS.n40 17.0005
R1864 VSS.n761 VSS.n40 17.0005
R1865 VSS.n762 VSS.n40 17.0005
R1866 VSS.n764 VSS.n40 17.0005
R1867 VSS.n766 VSS.n40 17.0005
R1868 VSS.n768 VSS.n40 17.0005
R1869 VSS.n771 VSS.n40 17.0005
R1870 VSS.n770 VSS.n40 17.0005
R1871 VSS.n710 VSS.n40 17.0005
R1872 VSS.n708 VSS.n40 17.0005
R1873 VSS.n706 VSS.n40 17.0005
R1874 VSS.n705 VSS.n40 17.0005
R1875 VSS.n703 VSS.n40 17.0005
R1876 VSS.n701 VSS.n40 17.0005
R1877 VSS.n699 VSS.n40 17.0005
R1878 VSS.n697 VSS.n40 17.0005
R1879 VSS.n772 VSS.n40 17.0005
R1880 VSS.n774 VSS.n40 17.0005
R1881 VSS.n776 VSS.n40 17.0005
R1882 VSS.n780 VSS.n40 17.0005
R1883 VSS.n781 VSS.n40 17.0005
R1884 VSS.n779 VSS.n40 17.0005
R1885 VSS.n525 VSS.n40 17.0005
R1886 VSS.n781 VSS.n14 17.0005
R1887 VSS.n780 VSS.n14 17.0005
R1888 VSS.n772 VSS.n14 17.0005
R1889 VSS.n705 VSS.n14 17.0005
R1890 VSS.n706 VSS.n14 17.0005
R1891 VSS.n770 VSS.n14 17.0005
R1892 VSS.n762 VSS.n14 17.0005
R1893 VSS.n761 VSS.n14 17.0005
R1894 VSS.n755 VSS.n14 17.0005
R1895 VSS.n822 VSS.n14 17.0005
R1896 VSS.n722 VSS.n14 17.0005
R1897 VSS.n723 VSS.n14 17.0005
R1898 VSS.n729 VSS.n14 17.0005
R1899 VSS.n730 VSS.n14 17.0005
R1900 VSS.n783 VSS.n525 17.0005
R1901 VSS.n783 VSS.n697 17.0005
R1902 VSS.n783 VSS.n771 17.0005
R1903 VSS.n783 VSS.n712 17.0005
R1904 VSS.n783 VSS.n717 17.0005
R1905 VSS.n783 VSS.n751 17.0005
R1906 VSS.n783 VSS.n688 17.0005
R1907 VSS.n689 VSS.n14 17.0005
R1908 VSS.n743 VSS.n19 17.0005
R1909 VSS.n19 VSS.n18 17.0005
R1910 VSS.n748 VSS.n14 17.0005
R1911 VSS.n826 VSS.n14 17.0005
R1912 VSS.n548 VSS.n40 17.0005
R1913 VSS.n828 VSS.n14 17.0005
R1914 VSS.n706 VSS.t259 16.4539
R1915 VSS.n192 VSS.t67 16.3876
R1916 VSS.n61 VSS.n526 16.2018
R1917 VSS.n92 VSS.n91 88.2779
R1918 VSS.n833 VSS.n8 5.41263
R1919 VSS.t501 VSS.n729 14.2601
R1920 VSS.t392 VSS.n73 13.9896
R1921 VSS.n862 VSS.t515 13.7246
R1922 VSS.t579 VSS.t127 13.4836
R1923 VSS.n778 VSS.n525 12.0761
R1924 VSS.n776 VSS.n775 12.0761
R1925 VSS.n699 VSS.n698 12.0761
R1926 VSS.n703 VSS.n702 12.0761
R1927 VSS.n709 VSS.n708 12.0761
R1928 VSS.n771 VSS.n769 12.0761
R1929 VSS.n765 VSS.n764 12.0761
R1930 VSS.n758 VSS.n757 12.0761
R1931 VSS.n714 VSS.n713 12.0761
R1932 VSS.n720 VSS.n719 12.0761
R1933 VSS.n727 VSS.n726 12.0761
R1934 VSS.n735 VSS.n734 12.0761
R1935 VSS.n782 VSS.n779 12.0761
R1936 VSS.n780 VSS.n777 12.0761
R1937 VSS.n774 VSS.n773 12.0761
R1938 VSS.n700 VSS.n699 12.0761
R1939 VSS.n704 VSS.n703 12.0761
R1940 VSS.n707 VSS.n706 12.0761
R1941 VSS.n711 VSS.n710 12.0761
R1942 VSS.n768 VSS.n767 12.0761
R1943 VSS.n764 VSS.n763 12.0761
R1944 VSS.n761 VSS.n760 12.0761
R1945 VSS.n757 VSS.n756 12.0761
R1946 VSS.n715 VSS.n714 12.0761
R1947 VSS.n721 VSS.n720 12.0761
R1948 VSS.n724 VSS.n723 12.0761
R1949 VSS.n728 VSS.n727 12.0761
R1950 VSS.n731 VSS.n730 12.0761
R1951 VSS.n736 VSS.n735 12.0761
R1952 VSS.n748 VSS.n747 12.0761
R1953 VSS.n751 VSS.n750 12.0761
R1954 VSS.n745 VSS.n688 12.0761
R1955 VSS.n779 VSS.n778 12.0761
R1956 VSS.n782 VSS.n781 12.0761
R1957 VSS.n777 VSS.n776 12.0761
R1958 VSS.n775 VSS.n774 12.0761
R1959 VSS.n773 VSS.n772 12.0761
R1960 VSS.n698 VSS.n697 12.0761
R1961 VSS.n701 VSS.n700 12.0761
R1962 VSS.n702 VSS.n701 12.0761
R1963 VSS.n705 VSS.n704 12.0761
R1964 VSS.n708 VSS.n707 12.0761
R1965 VSS.n710 VSS.n709 12.0761
R1966 VSS.n770 VSS.n711 12.0761
R1967 VSS.n769 VSS.n768 12.0761
R1968 VSS.n767 VSS.n766 12.0761
R1969 VSS.n766 VSS.n765 12.0761
R1970 VSS.n763 VSS.n762 12.0761
R1971 VSS.n760 VSS.n759 12.0761
R1972 VSS.n759 VSS.n758 12.0761
R1973 VSS.n756 VSS.n755 12.0761
R1974 VSS.n713 VSS.n712 12.0761
R1975 VSS.n718 VSS.n715 12.0761
R1976 VSS.n719 VSS.n718 12.0761
R1977 VSS.n722 VSS.n721 12.0761
R1978 VSS.n725 VSS.n724 12.0761
R1979 VSS.n726 VSS.n725 12.0761
R1980 VSS.n729 VSS.n728 12.0761
R1981 VSS.n733 VSS.n731 12.0761
R1982 VSS.n734 VSS.n733 12.0761
R1983 VSS.n749 VSS.n736 12.0761
R1984 VSS.n750 VSS.n749 12.0761
R1985 VSS.n747 VSS.n746 12.0761
R1986 VSS.n746 VSS.n745 12.0761
R1987 VSS.t377 VSS.n648 10.7777
R1988 VSS.n644 VSS.t388 10.7747
R1989 VSS.n801 VSS.n547 9.81803
R1990 VSS.n844 VSS.n547 9.39094
R1991 VSS.n842 VSS.n841 9.38916
R1992 VSS.n564 VSS.t54 9.08698
R1993 VSS.t54 VSS.n563 9.0445
R1994 VSS.n835 VSS.n834 9.0005
R1995 VSS.n835 VSS.n551 9.0005
R1996 VSS.n554 VSS.n550 9.0005
R1997 VSS.n741 VSS.n550 9.0005
R1998 VSS.t243 VSS.n868 8.501
R1999 VSS.n869 VSS.t241 8.501
R2000 VSS.t239 VSS.n871 8.501
R2001 VSS.n872 VSS.t71 8.501
R2002 VSS.t233 VSS.n874 8.501
R2003 VSS.n875 VSS.t231 8.501
R2004 VSS.t229 VSS.n280 8.501
R2005 VSS.t158 VSS.n272 8.501
R2006 VSS.t223 VSS.n883 8.501
R2007 VSS.n884 VSS.t221 8.501
R2008 VSS.t219 VSS.n266 8.501
R2009 VSS.t216 VSS.n249 8.501
R2010 VSS.t166 VSS.n892 8.501
R2011 VSS.n893 VSS.t211 8.501
R2012 VSS.t209 VSS.n895 8.501
R2013 VSS.n896 VSS.t152 8.501
R2014 VSS.t203 VSS.n898 8.501
R2015 VSS.n899 VSS.t201 8.501
R2016 VSS.t199 VSS.n226 8.501
R2017 VSS.t155 VSS.n217 8.501
R2018 VSS.t193 VSS.n907 8.501
R2019 VSS.n908 VSS.t191 8.501
R2020 VSS.t189 VSS.n910 8.501
R2021 VSS.n911 VSS.t186 8.501
R2022 VSS.n86 VSS.n85 0.00174993
R2023 VSS.n86 VSS.n92 9.59049
R2024 VSS.n811 VSS.n40 4.251
R2025 VSS.n811 VSS.n44 4.251
R2026 VSS.n44 VSS.n43 0.00149997
R2027 VSS.n811 VSS.n46 4.251
R2028 VSS.n46 VSS.n45 0.00149997
R2029 VSS.n811 VSS.n47 3.40102
R2030 VSS.n811 VSS.n50 2.12569
R2031 VSS.n50 VSS.n49 0.00170812
R2032 VSS.n52 VSS.n49 0.00166658
R2033 VSS.n52 VSS.n51 0.00149997
R2034 VSS.n811 VSS.n56 3.40102
R2035 VSS.n811 VSS.n59 4.25113
R2036 VSS.n852 VSS.n528 8.501
R2037 VSS.n852 VSS.n23 4.251
R2038 VSS.n23 VSS.n22 0.00149997
R2039 VSS.n852 VSS.n24 3.40102
R2040 VSS.n27 VSS.n26 0.00216959
R2041 VSS.n26 VSS.n28 0.00170812
R2042 VSS.n28 VSS.n29 0.00166658
R2043 VSS.n29 VSS.n30 0.00149997
R2044 VSS.n852 VSS.n31 1.88985
R2045 VSS.n33 VSS.n34 0.00149997
R2046 VSS.n852 VSS.n36 1.70056
R2047 VSS.n36 VSS.n35 0.00172462
R2048 VSS.n35 VSS.n37 0.00170812
R2049 VSS.n37 VSS.n38 0.00166658
R2050 VSS.n38 VSS.n39 0.00149997
R2051 VSS.n669 VSS.n64 406.622
R2052 VSS.n69 VSS.n68 406.622
R2053 VSS.n71 VSS.n69 0.00235708
R2054 VSS.n641 VSS.n73 4.35561
R2055 VSS.n641 VSS.n74 3.40102
R2056 VSS.n641 VSS.n76 3.40102
R2057 VSS.n641 VSS.n78 3.40102
R2058 VSS.n641 VSS.n80 3.40102
R2059 VSS.n641 VSS.n82 2.42956
R2060 VSS.n830 VSS.n20 3.40102
R2061 VSS.n8 VSS.n7 0.0161289
R2062 VSS.n15 VSS.n14 0.00138884
R2063 VSS.n14 VSS.n16 0.00166658
R2064 VSS.n830 VSS.n17 2.42956
R2065 VSS.n41 VSS.n40 1.51099
R2066 VSS.n88 VSS.n520 8.5005
R2067 VSS.n88 VSS.n515 8.5005
R2068 VSS.n88 VSS.n351 8.5005
R2069 VSS.n88 VSS.n513 8.5005
R2070 VSS.n88 VSS.n512 8.5005
R2071 VSS.n88 VSS.n352 8.5005
R2072 VSS.n88 VSS.n511 8.5005
R2073 VSS.n88 VSS.n354 8.5005
R2074 VSS.n88 VSS.n510 8.5005
R2075 VSS.n88 VSS.n355 8.5005
R2076 VSS.n88 VSS.n509 8.5005
R2077 VSS.n88 VSS.n356 8.5005
R2078 VSS.n88 VSS.n508 8.5005
R2079 VSS.n88 VSS.n507 8.5005
R2080 VSS.n88 VSS.n357 8.5005
R2081 VSS.n88 VSS.n506 8.5005
R2082 VSS.n88 VSS.n359 8.5005
R2083 VSS.n88 VSS.n505 8.5005
R2084 VSS.n88 VSS.n360 8.5005
R2085 VSS.n88 VSS.n504 8.5005
R2086 VSS.n88 VSS.n361 8.5005
R2087 VSS.n88 VSS.n503 8.5005
R2088 VSS.n88 VSS.n502 8.5005
R2089 VSS.n88 VSS.n362 8.5005
R2090 VSS.n88 VSS.n501 8.5005
R2091 VSS.n88 VSS.n364 8.5005
R2092 VSS.n88 VSS.n500 8.5005
R2093 VSS.n88 VSS.n365 8.5005
R2094 VSS.n88 VSS.n499 8.5005
R2095 VSS.n88 VSS.n366 8.5005
R2096 VSS.n88 VSS.n498 8.5005
R2097 VSS.n88 VSS.n497 8.5005
R2098 VSS.n88 VSS.n367 8.5005
R2099 VSS.n88 VSS.n496 8.5005
R2100 VSS.n88 VSS.n369 8.5005
R2101 VSS.n88 VSS.n495 8.5005
R2102 VSS.n88 VSS.n370 8.5005
R2103 VSS.n88 VSS.n494 8.5005
R2104 VSS.n88 VSS.n371 8.5005
R2105 VSS.n88 VSS.n493 8.5005
R2106 VSS.n88 VSS.n492 8.5005
R2107 VSS.n88 VSS.n372 8.5005
R2108 VSS.n88 VSS.n491 8.5005
R2109 VSS.n88 VSS.n374 8.5005
R2110 VSS.n88 VSS.n490 8.5005
R2111 VSS.n88 VSS.n375 8.5005
R2112 VSS.n88 VSS.n489 8.5005
R2113 VSS.n88 VSS.n376 8.5005
R2114 VSS.n88 VSS.n488 8.5005
R2115 VSS.n88 VSS.n487 8.5005
R2116 VSS.n88 VSS.n377 8.5005
R2117 VSS.n88 VSS.n486 8.5005
R2118 VSS.n88 VSS.n379 8.5005
R2119 VSS.n88 VSS.n485 8.5005
R2120 VSS.n88 VSS.n380 8.5005
R2121 VSS.n88 VSS.n484 8.5005
R2122 VSS.n88 VSS.n381 8.5005
R2123 VSS.n88 VSS.n483 8.5005
R2124 VSS.n88 VSS.n482 8.5005
R2125 VSS.n88 VSS.n382 8.5005
R2126 VSS.n88 VSS.n481 8.5005
R2127 VSS.n88 VSS.n384 8.5005
R2128 VSS.n88 VSS.n480 8.5005
R2129 VSS.n88 VSS.n385 8.5005
R2130 VSS.n88 VSS.n479 8.5005
R2131 VSS.n88 VSS.n386 8.5005
R2132 VSS.n88 VSS.n478 8.5005
R2133 VSS.n88 VSS.n477 8.5005
R2134 VSS.n88 VSS.n387 8.5005
R2135 VSS.n88 VSS.n476 8.5005
R2136 VSS.n88 VSS.n389 8.5005
R2137 VSS.n88 VSS.n475 8.5005
R2138 VSS.n88 VSS.n390 8.5005
R2139 VSS.n88 VSS.n474 8.5005
R2140 VSS.n88 VSS.n391 8.5005
R2141 VSS.n88 VSS.n473 8.5005
R2142 VSS.n88 VSS.n472 8.5005
R2143 VSS.n88 VSS.n392 8.5005
R2144 VSS.n88 VSS.n471 8.5005
R2145 VSS.n88 VSS.n394 8.5005
R2146 VSS.n88 VSS.n470 8.5005
R2147 VSS.n88 VSS.n395 8.5005
R2148 VSS.n88 VSS.n469 8.5005
R2149 VSS.n88 VSS.n396 8.5005
R2150 VSS.n88 VSS.n468 8.5005
R2151 VSS.n88 VSS.n467 8.5005
R2152 VSS.n88 VSS.n397 8.5005
R2153 VSS.n88 VSS.n466 8.5005
R2154 VSS.n88 VSS.n399 8.5005
R2155 VSS.n88 VSS.n465 8.5005
R2156 VSS.n88 VSS.n400 8.5005
R2157 VSS.n88 VSS.n464 8.5005
R2158 VSS.n88 VSS.n401 8.5005
R2159 VSS.n88 VSS.n463 8.5005
R2160 VSS.n88 VSS.n462 8.5005
R2161 VSS.n88 VSS.n402 8.5005
R2162 VSS.n88 VSS.n461 8.5005
R2163 VSS.n88 VSS.n404 8.5005
R2164 VSS.n88 VSS.n460 8.5005
R2165 VSS.n88 VSS.n405 8.5005
R2166 VSS.n88 VSS.n459 8.5005
R2167 VSS.n88 VSS.n406 8.5005
R2168 VSS.n88 VSS.n458 8.5005
R2169 VSS.n88 VSS.n457 8.5005
R2170 VSS.n88 VSS.n407 8.5005
R2171 VSS.n88 VSS.n456 8.5005
R2172 VSS.n88 VSS.n409 8.5005
R2173 VSS.n88 VSS.n455 8.5005
R2174 VSS.n88 VSS.n410 8.5005
R2175 VSS.n88 VSS.n454 8.5005
R2176 VSS.n88 VSS.n411 8.5005
R2177 VSS.n88 VSS.n453 8.5005
R2178 VSS.n88 VSS.n452 8.5005
R2179 VSS.n88 VSS.n412 8.5005
R2180 VSS.n88 VSS.n451 8.5005
R2181 VSS.n88 VSS.n414 8.5005
R2182 VSS.n88 VSS.n450 8.5005
R2183 VSS.n88 VSS.n415 8.5005
R2184 VSS.n88 VSS.n449 8.5005
R2185 VSS.n88 VSS.n416 8.5005
R2186 VSS.n88 VSS.n448 8.5005
R2187 VSS.n88 VSS.n447 8.5005
R2188 VSS.n88 VSS.n417 8.5005
R2189 VSS.n88 VSS.n446 8.5005
R2190 VSS.n88 VSS.n419 8.5005
R2191 VSS.n88 VSS.n445 8.5005
R2192 VSS.n88 VSS.n420 8.5005
R2193 VSS.n88 VSS.n444 8.5005
R2194 VSS.n88 VSS.n421 8.5005
R2195 VSS.n88 VSS.n443 8.5005
R2196 VSS.n88 VSS.n442 8.5005
R2197 VSS.n88 VSS.n422 8.5005
R2198 VSS.n88 VSS.n441 8.5005
R2199 VSS.n88 VSS.n424 8.5005
R2200 VSS.n88 VSS.n440 8.5005
R2201 VSS.n88 VSS.n425 8.5005
R2202 VSS.n88 VSS.n439 8.5005
R2203 VSS.n88 VSS.n426 8.5005
R2204 VSS.n88 VSS.n438 8.5005
R2205 VSS.n88 VSS.n437 8.5005
R2206 VSS.n88 VSS.n427 8.5005
R2207 VSS.n88 VSS.n436 8.5005
R2208 VSS.n88 VSS.n429 8.5005
R2209 VSS.n88 VSS.n435 8.5005
R2210 VSS.n88 VSS.n430 8.5005
R2211 VSS.n88 VSS.n432 8.5005
R2212 VSS.n7 VSS.n579 8.5005
R2213 VSS.n7 VSS.n568 8.5005
R2214 VSS.n739 VSS.n21 8.50038
R2215 VSS.n7 VSS.n552 8.48883
R2216 VSS.n88 VSS.n434 8.48012
R2217 VSS.n627 VSS.n75 8.47784
R2218 VSS.n629 VSS.n77 8.47784
R2219 VSS.n631 VSS.n79 8.47784
R2220 VSS.n633 VSS.n81 8.47784
R2221 VSS.n637 VSS.n83 8.47784
R2222 VSS.n638 VSS.n84 8.47784
R2223 VSS.n88 VSS.n350 8.47732
R2224 VSS.n88 VSS.t608 8.47732
R2225 VSS.n433 VSS.n85 8.47732
R2226 VSS.n89 VSS.n87 8.47732
R2227 VSS.n88 VSS.n312 8.47732
R2228 VSS.n88 VSS.n313 8.47732
R2229 VSS.n88 VSS.n347 8.47732
R2230 VSS.n798 VSS.n40 8.47732
R2231 VSS.n796 VSS.n40 8.47732
R2232 VSS.n544 VSS.n40 8.47732
R2233 VSS.n543 VSS.n40 8.47732
R2234 VSS.t580 VSS.n42 8.47732
R2235 VSS.n802 VSS.n793 8.47732
R2236 VSS.n803 VSS.n43 8.47732
R2237 VSS.n804 VSS.n792 8.47732
R2238 VSS.n805 VSS.n45 8.47732
R2239 VSS.t125 VSS.n48 8.47732
R2240 VSS.n808 VSS.n789 8.47732
R2241 VSS.n788 VSS.n49 8.47732
R2242 VSS.n787 VSS.n52 8.47732
R2243 VSS.t126 VSS.n51 8.47732
R2244 VSS.n812 VSS.n55 8.47732
R2245 VSS.n814 VSS.n57 8.47732
R2246 VSS.n815 VSS.n59 8.47732
R2247 VSS.t586 VSS.n845 8.47732
R2248 VSS.t128 VSS.n22 8.47732
R2249 VSS.n846 VSS.n25 8.47732
R2250 VSS.n539 VSS.n26 8.47732
R2251 VSS.n847 VSS.n28 8.47732
R2252 VSS.n538 VSS.n29 8.47732
R2253 VSS.t131 VSS.n30 8.47732
R2254 VSS.n534 VSS.n32 8.47732
R2255 VSS.t133 VSS.n33 8.47732
R2256 VSS.n533 VSS.n34 8.47732
R2257 VSS.n849 VSS.n532 8.47732
R2258 VSS.n531 VSS.n35 8.47732
R2259 VSS.t135 VSS.n37 8.47732
R2260 VSS.n530 VSS.n38 8.47732
R2261 VSS.n850 VSS.n39 8.47732
R2262 VSS.n13 VSS.n851 8.47732
R2263 VSS.n626 VSS.n72 8.47732
R2264 VSS.n617 VSS.n72 8.47732
R2265 VSS.n7 VSS.n556 8.47732
R2266 VSS.n7 VSS.n558 8.47732
R2267 VSS.n7 VSS.n560 8.47732
R2268 VSS.n7 VSS.n566 8.47732
R2269 VSS.n7 VSS.n580 8.47732
R2270 VSS.n7 VSS.n569 8.47732
R2271 VSS.n693 VSS.n14 8.47732
R2272 VSS.n783 VSS.n732 8.47732
R2273 VSS.n740 VSS.n16 8.47732
R2274 VSS.n12 VSS.n11 3.32623
R2275 VSS.n678 VSS.n63 8.47111
R2276 VSS.t53 VSS.n66 8.47111
R2277 VSS.n653 VSS.n70 8.47111
R2278 VSS.t317 VSS.n71 8.47111
R2279 VSS.n783 VSS.n744 8.46924
R2280 VSS.n840 VSS.n839 6.85916
R2281 VSS.n677 VSS.n526 5.66985
R2282 VSS.n811 VSS.n785 5.66778
R2283 VSS.n811 VSS.n786 5.66778
R2284 VSS.n47 VSS.n790 0.00229996
R2285 VSS.n56 VSS.n53 0.00229996
R2286 VSS.n811 VSS.n809 5.66778
R2287 VSS.n24 VSS.n541 0.00229996
R2288 VSS.n852 VSS.n27 1.54575
R2289 VSS.n852 VSS.n527 5.66778
R2290 VSS.n31 VSS.n535 0.00261099
R2291 VSS.n74 VSS.n625 0.00229996
R2292 VSS.n76 VSS.n624 0.00229996
R2293 VSS.n78 VSS.n623 0.00229996
R2294 VSS.n80 VSS.n622 0.00229996
R2295 VSS.n641 VSS.n606 5.66778
R2296 VSS.n641 VSS.n607 5.66778
R2297 VSS.n82 VSS.n619 0.00249991
R2298 VSS.n641 VSS.n608 5.66778
R2299 VSS.n641 VSS.n640 5.66778
R2300 VSS.n17 VSS.n9 0.00249991
R2301 VSS.n829 VSS.t528 5.66778
R2302 VSS.n830 VSS.n15 1.88985
R2303 VSS.n852 VSS.n14 5.66767
R2304 VSS.n64 VSS.n66 0.00137142
R2305 VSS.n88 VSS.n311 5.63915
R2306 VSS.t409 VSS.n625 5.62674
R2307 VSS.n628 VSS.n624 5.62674
R2308 VSS.n630 VSS.n623 5.62674
R2309 VSS.n632 VSS.n622 5.62674
R2310 VSS.n634 VSS.n621 5.62674
R2311 VSS.n635 VSS.n620 5.62674
R2312 VSS.n636 VSS.n619 5.62674
R2313 VSS.n609 VSS.n618 5.62674
R2314 VSS.n639 VSS.t393 5.62674
R2315 VSS.n795 VSS.n794 5.62581
R2316 VSS.n806 VSS.n791 5.62581
R2317 VSS.n807 VSS.n790 5.62581
R2318 VSS.n784 VSS.n53 5.62581
R2319 VSS.n813 VSS.n54 5.62581
R2320 VSS.n816 VSS.n58 5.62581
R2321 VSS.n542 VSS.n541 5.62581
R2322 VSS.t129 VSS.n540 5.62581
R2323 VSS.n537 VSS.n536 5.62581
R2324 VSS.n848 VSS.n535 5.62581
R2325 VSS.n7 VSS.n565 5.62581
R2326 VSS.n10 VSS.n9 3.33986
R2327 VSS.t257 VSS.n780 5.48496
R2328 VSS.n680 VSS.n679 5.13648
R2329 VSS.n595 VSS.t520 4.98596
R2330 VSS.n836 VSS.n835 4.63796
R2331 VSS.n669 VSS.t246 4.49152
R2332 VSS.n68 VSS.t64 4.49152
R2333 VSS.t169 VSS.n680 4.4712
R2334 VSS.n811 VSS.n810 4.25119
R2335 VSS.n783 VSS.n737 4.19244
R2336 VSS.n7 VSS.n561 4.19238
R2337 VSS.t237 VSS.n293 4.19225
R2338 VSS.n879 VSS.t227 4.19225
R2339 VSS.n888 VSS.t217 4.19225
R2340 VSS.t207 VSS.n239 4.19225
R2341 VSS.n903 VSS.t197 4.19225
R2342 VSS.t187 VSS.n208 4.19225
R2343 VSS.n690 VSS.n14 4.19225
R2344 VSS.t144 VSS.n615 4.177
R2345 VSS.n523 VSS.n182 3.84219
R2346 VSS.n913 VSS.t66 3.84041
R2347 VSS.n515 VSS.t361 3.34498
R2348 VSS.n512 VSS.t410 3.34498
R2349 VSS.n509 VSS.t355 3.34498
R2350 VSS.n507 VSS.t413 3.34498
R2351 VSS.n504 VSS.t411 3.34498
R2352 VSS.n502 VSS.t414 3.34498
R2353 VSS.n499 VSS.t359 3.34498
R2354 VSS.n497 VSS.t358 3.34498
R2355 VSS.n494 VSS.t419 3.34498
R2356 VSS.n492 VSS.t418 3.34498
R2357 VSS.n489 VSS.t416 3.34498
R2358 VSS.n487 VSS.t420 3.34498
R2359 VSS.n484 VSS.t421 3.34498
R2360 VSS.n482 VSS.t422 3.34498
R2361 VSS.n479 VSS.t375 3.34498
R2362 VSS.n477 VSS.t369 3.34498
R2363 VSS.n474 VSS.t374 3.34498
R2364 VSS.n472 VSS.t367 3.34498
R2365 VSS.n469 VSS.t371 3.34498
R2366 VSS.n467 VSS.t423 3.34498
R2367 VSS.n464 VSS.t356 3.34498
R2368 VSS.n462 VSS.t424 3.34498
R2369 VSS.n459 VSS.t368 3.34498
R2370 VSS.n457 VSS.t354 3.34498
R2371 VSS.n454 VSS.t360 3.34498
R2372 VSS.n452 VSS.t426 3.34498
R2373 VSS.n449 VSS.t366 3.34498
R2374 VSS.n447 VSS.t364 3.34498
R2375 VSS.n444 VSS.t428 3.34498
R2376 VSS.n442 VSS.t363 3.34498
R2377 VSS.n439 VSS.t430 3.34498
R2378 VSS.n437 VSS.t431 3.34498
R2379 VSS.n843 VSS.n40 3.3265
R2380 VSS.n7 VSS.n557 3.32615
R2381 VSS.t73 VSS.t289 3.30696
R2382 VSS.n866 VSS.t161 3.28366
R2383 VSS.n836 VSS.n549 2.7456
R2384 VSS.n88 VSS.n349 2.74463
R2385 VSS.n88 VSS.n431 2.7443
R2386 VSS.n88 VSS.t469 2.74402
R2387 VSS.n88 VSS.n514 2.74397
R2388 VSS.n88 VSS.n345 2.74397
R2389 VSS.n7 VSS.n574 2.74397
R2390 VSS.n7 VSS.n567 2.74364
R2391 VSS.n778 VSS.n14 2.46343
R2392 VSS.n775 VSS.n14 2.46343
R2393 VSS.n698 VSS.n14 2.46343
R2394 VSS.n702 VSS.n14 2.46343
R2395 VSS.n709 VSS.n14 2.46343
R2396 VSS.n769 VSS.n14 2.46343
R2397 VSS.n765 VSS.n14 2.46343
R2398 VSS.n758 VSS.n14 2.46343
R2399 VSS.n713 VSS.n14 2.46343
R2400 VSS.n719 VSS.n14 2.46343
R2401 VSS.n726 VSS.n14 2.46343
R2402 VSS.n734 VSS.n14 2.46343
R2403 VSS.n783 VSS.n782 2.46343
R2404 VSS.n783 VSS.n777 2.46343
R2405 VSS.n783 VSS.n773 2.46343
R2406 VSS.n783 VSS.n700 2.46343
R2407 VSS.n783 VSS.n704 2.46343
R2408 VSS.n783 VSS.n707 2.46343
R2409 VSS.n783 VSS.n711 2.46343
R2410 VSS.n783 VSS.n767 2.46343
R2411 VSS.n783 VSS.n763 2.46343
R2412 VSS.n783 VSS.n760 2.46343
R2413 VSS.n783 VSS.n756 2.46343
R2414 VSS.n783 VSS.n715 2.46343
R2415 VSS.n783 VSS.n721 2.46343
R2416 VSS.n783 VSS.n724 2.46343
R2417 VSS.n783 VSS.n728 2.46343
R2418 VSS.n783 VSS.n731 2.46343
R2419 VSS.n783 VSS.n736 2.46343
R2420 VSS.n783 VSS.n747 2.46343
R2421 VSS.n750 VSS.n14 2.46343
R2422 VSS.n745 VSS.n14 2.46343
R2423 VSS.n300 VSS.n299 2.34876
R2424 VSS.n284 VSS.n283 2.34876
R2425 VSS.n270 VSS.n269 2.34876
R2426 VSS.n246 VSS.n245 2.34876
R2427 VSS.n230 VSS.n229 2.34876
R2428 VSS.n215 VSS.n214 2.34876
R2429 VSS.n824 VSS.n14 2.32483
R2430 VSS.n783 VSS.n754 2.32483
R2431 VSS.n820 VSS.n14 2.00687
R2432 VSS.n783 VSS.n696 2.00687
R2433 VSS.t289 VSS.n600 1.97699
R2434 VSS.t56 VSS.n593 1.88189
R2435 VSS.n615 VSS.n605 1.88189
R2436 VSS.n837 VSS.n836 1.83435
R2437 VSS.t248 VSS.n677 1.80539
R2438 VSS.n800 VSS.n40 1.75689
R2439 VSS.n546 VSS.n40 1.75689
R2440 VSS.n7 VSS.n585 1.75507
R2441 VSS.n654 VSS.t523 1.72297
R2442 VSS.n742 VSS.n741 1.66925
R2443 VSS.n88 VSS.n522 1.63922
R2444 VSS.n88 VSS.n855 1.63922
R2445 VSS.n88 VSS.n860 1.63922
R2446 VSS.n88 VSS.n862 1.63922
R2447 VSS.n88 VSS.n864 1.63922
R2448 VSS.n88 VSS.n353 1.55386
R2449 VSS.n88 VSS.n358 1.55386
R2450 VSS.n88 VSS.n363 1.55386
R2451 VSS.n88 VSS.n368 1.55386
R2452 VSS.n88 VSS.n373 1.55386
R2453 VSS.n88 VSS.n378 1.55386
R2454 VSS.n88 VSS.n383 1.55386
R2455 VSS.n88 VSS.n388 1.55386
R2456 VSS.n88 VSS.n393 1.55386
R2457 VSS.n88 VSS.n398 1.55386
R2458 VSS.n88 VSS.n403 1.55386
R2459 VSS.n88 VSS.n408 1.55386
R2460 VSS.n88 VSS.n413 1.55386
R2461 VSS.n88 VSS.n418 1.55386
R2462 VSS.n88 VSS.n423 1.55386
R2463 VSS.n88 VSS.n428 1.55386
R2464 VSS.n88 VSS.t82 1.55345
R2465 VSS.n88 VSS.t42 1.55345
R2466 VSS.n88 VSS.t336 1.55345
R2467 VSS.n88 VSS.t97 1.55345
R2468 VSS.n88 VSS.t44 1.55345
R2469 VSS.n88 VSS.t86 1.55345
R2470 VSS.n88 VSS.t172 1.55345
R2471 VSS.n88 VSS.t438 1.55345
R2472 VSS.n88 VSS.t333 1.55345
R2473 VSS.n88 VSS.t488 1.55345
R2474 VSS.n88 VSS.t530 1.55345
R2475 VSS.n88 VSS.t34 1.55345
R2476 VSS.n88 VSS.t347 1.55345
R2477 VSS.n88 VSS.t485 1.55345
R2478 VSS.n88 VSS.t25 1.55345
R2479 VSS.n88 VSS.n314 1.55338
R2480 VSS.n88 VSS.n315 1.55338
R2481 VSS.n88 VSS.n316 1.55338
R2482 VSS.n88 VSS.n317 1.55338
R2483 VSS.n88 VSS.n318 1.55338
R2484 VSS.n88 VSS.n319 1.55338
R2485 VSS.n88 VSS.n320 1.55338
R2486 VSS.n88 VSS.n321 1.55338
R2487 VSS.n88 VSS.n322 1.55338
R2488 VSS.n88 VSS.n323 1.55338
R2489 VSS.n88 VSS.n324 1.55338
R2490 VSS.n88 VSS.n325 1.55338
R2491 VSS.n88 VSS.n326 1.55338
R2492 VSS.n88 VSS.n327 1.55338
R2493 VSS.n88 VSS.n328 1.55338
R2494 VSS.n88 VSS.n329 1.55338
R2495 VSS.n88 VSS.n330 1.55338
R2496 VSS.n88 VSS.n331 1.55338
R2497 VSS.n88 VSS.n332 1.55338
R2498 VSS.n88 VSS.n333 1.55338
R2499 VSS.n88 VSS.n334 1.55338
R2500 VSS.n88 VSS.n335 1.55338
R2501 VSS.n88 VSS.n336 1.55338
R2502 VSS.n88 VSS.n337 1.55338
R2503 VSS.n88 VSS.n338 1.55338
R2504 VSS.n88 VSS.n339 1.55338
R2505 VSS.n88 VSS.n340 1.55338
R2506 VSS.n88 VSS.n341 1.55338
R2507 VSS.n88 VSS.n342 1.55338
R2508 VSS.n88 VSS.n343 1.55338
R2509 VSS.n88 VSS.n344 1.55338
R2510 VSS.n610 VSS.n72 1.55041
R2511 VSS.n738 VSS.t583 1.43372
R2512 VSS.t581 VSS.n695 1.43372
R2513 VSS.n694 VSS.t581 1.42949
R2514 VSS.n691 VSS.t583 1.42949
R2515 VSS.t502 VSS.t510 1.41892
R2516 VSS.t500 VSS.t509 1.41892
R2517 VSS.t507 VSS.t508 1.41892
R2518 VSS.t504 VSS.t505 1.41892
R2519 VSS.n912 VSS.n205 1.38589
R2520 VSS.n545 VSS.t578 1.37661
R2521 VSS.t578 VSS.n797 1.37661
R2522 VSS.n838 VSS.n837 1.30942
R2523 VSS.t409 VSS.t407 1.30345
R2524 VSS.t393 VSS.t391 1.29565
R2525 VSS.t278 VSS.n247 1.28795
R2526 VSS.n842 VSS.n838 1.26857
R2527 VSS.n613 VSS.n72 1.24506
R2528 VSS.t106 VSS.t15 1.23805
R2529 VSS.t73 VSS.n601 1.21874
R2530 VSS.t397 VSS.t399 1.18357
R2531 VSS.t383 VSS.t381 1.18321
R2532 VSS.t385 VSS.t383 1.17927
R2533 VSS.t401 VSS.t399 1.17915
R2534 VSS.t378 VSS.t379 1.17817
R2535 VSS.t395 VSS.t394 1.1778
R2536 VSS.t389 VSS.t387 1.17371
R2537 VSS.t405 VSS.t403 1.17364
R2538 VSS.t407 VSS.t405 1.15983
R2539 VSS.t391 VSS.t389 1.15299
R2540 VSS.n597 VSS.t144 1.12123
R2541 VSS.t385 VSS.t387 1.11346
R2542 VSS.t403 VSS.t401 1.11316
R2543 VSS.t381 VSS.t378 1.10882
R2544 VSS.t397 VSS.t395 1.10881
R2545 VSS.t56 VSS.n591 1.09664
R2546 VSS.n602 VSS.t448 1.08287
R2547 VSS.t166 VSS.n247 1.06717
R2548 VSS.n601 VSS.t53 1.0392
R2549 VSS.n184 VSS.t186 1.03359
R2550 VSS.n591 VSS.n592 1.02454
R2551 VSS.n524 VSS.t12 1.02124
R2552 VSS.n858 VSS.t116 1.00722
R2553 VSS.n184 VSS.t445 1.0064
R2554 VSS.n817 VSS.n816 0.980375
R2555 VSS.n183 VSS.t66 0.971887
R2556 VSS.t243 VSS.n301 0.950816
R2557 VSS.n851 VSS.n529 0.932604
R2558 VSS.n597 VSS.t169 0.885254
R2559 VSS.n819 VSS.n529 0.881792
R2560 VSS.n818 VSS.n817 0.881792
R2561 VSS.t216 VSS.n248 0.841394
R2562 VSS.n678 VSS.n602 0.839803
R2563 VSS.t254 VSS.n604 0.832423
R2564 VSS.t589 VSS.t592 0.806856
R2565 VSS.n577 VSS.t596 0.806855
R2566 VSS.t463 VSS.t602 0.806855
R2567 VSS.n575 VSS.t373 0.802775
R2568 VSS.t75 VSS.t362 0.802775
R2569 VSS.t252 VSS.t7 0.802775
R2570 VSS.t79 VSS.t295 0.802775
R2571 VSS.t553 VSS.t40 0.802775
R2572 VSS.t19 VSS.t412 0.802775
R2573 VSS.t327 VSS.t415 0.802775
R2574 VSS.t91 VSS.t58 0.802775
R2575 VSS.t60 VSS.t100 0.802775
R2576 VSS.t22 VSS.t114 0.802775
R2577 VSS.t112 VSS.t46 0.802775
R2578 VSS.t94 VSS.t417 0.802775
R2579 VSS.t548 VSS.t299 0.802775
R2580 VSS.t339 VSS.t5 0.802775
R2581 VSS.t1 VSS.t146 0.802775
R2582 VSS.t543 VSS.t376 0.802775
R2583 VSS.t293 VSS.t370 0.802775
R2584 VSS.t311 VSS.t142 0.802775
R2585 VSS.t36 VSS.t308 0.802775
R2586 VSS.t275 VSS.t272 0.802775
R2587 VSS.t139 VSS.t62 0.802775
R2588 VSS.t30 VSS.t357 0.802775
R2589 VSS.t280 VSS.t425 0.802775
R2590 VSS.t324 VSS.t305 0.802775
R2591 VSS.t264 VSS.t32 0.802775
R2592 VSS.t342 VSS.t27 0.802775
R2593 VSS.t539 VSS.t427 0.802775
R2594 VSS.t546 VSS.t108 0.802775
R2595 VSS.t110 VSS.t365 0.802775
R2596 VSS.t149 VSS.t429 0.802775
R2597 VSS.t519 VSS.t48 0.802775
R2598 VSS.t330 VSS.t38 0.802775
R2599 VSS.t256 VSS.t432 0.802775
R2600 VSS.t286 VSS.t611 0.802775
R2601 VSS.t71 VSS.n285 0.78864
R2602 VSS.t158 VSS.n271 0.78864
R2603 VSS.t152 VSS.n231 0.78864
R2604 VSS.t155 VSS.n216 0.78864
R2605 VSS.n602 VSS.t248 0.756052
R2606 VSS.t254 VSS.t523 0.745166
R2607 VSS.t56 VSS.n597 0.728354
R2608 VSS.t233 VSS.n285 0.724795
R2609 VSS.t223 VSS.n271 0.724795
R2610 VSS.t203 VSS.n231 0.724795
R2611 VSS.t193 VSS.n216 0.724795
R2612 VSS.t612 VSS.t614 0.723599
R2613 VSS.t610 VSS.n310 0.723599
R2614 VSS.n752 VSS.t502 0.722582
R2615 VSS.n753 VSS.t500 0.722582
R2616 VSS.n716 VSS.t507 0.722582
R2617 VSS.t505 VSS.n818 0.722582
R2618 VSS.n825 VSS.t510 0.72222
R2619 VSS.n823 VSS.t509 0.72222
R2620 VSS.n821 VSS.t508 0.72222
R2621 VSS.n819 VSS.t504 0.72222
R2622 VSS.n604 VSS.n616 0.711165
R2623 VSS.t169 VSS.n591 0.699997
R2624 VSS.n248 VSS.t278 0.699882
R2625 VSS.n612 VSS.n611 0.6955
R2626 VSS.n601 VSS.n65 0.662806
R2627 VSS.t317 VSS.t523 0.640524
R2628 VSS.n873 VSS.n285 0.62049
R2629 VSS.n882 VSS.n271 0.62049
R2630 VSS.n897 VSS.n231 0.62049
R2631 VSS.n906 VSS.n216 0.62049
R2632 VSS.n867 VSS.n308 0.613782
R2633 VSS.n873 VSS.n290 0.613782
R2634 VSS.n882 VSS.n277 0.613782
R2635 VSS.n891 VSS.n263 0.613782
R2636 VSS.n891 VSS.n258 0.613782
R2637 VSS.n897 VSS.n236 0.613782
R2638 VSS.n906 VSS.n223 0.613782
R2639 VSS.n912 VSS.n188 0.613782
R2640 VSS.n912 VSS.n190 0.613782
R2641 VSS.n912 VSS.n201 0.613782
R2642 VSS.n912 VSS.n196 0.613782
R2643 VSS.n912 VSS.n197 0.613782
R2644 VSS.n604 VSS.n72 0.599773
R2645 VSS.t601 VSS.n581 0.595317
R2646 VSS.t598 VSS.n582 0.595317
R2647 VSS.t595 VSS.n570 0.595317
R2648 VSS.t591 VSS.n571 0.595317
R2649 VSS.t607 VSS.n516 0.595317
R2650 VSS.t604 VSS.n517 0.595317
R2651 VSS.n653 VSS.n600 0.588545
R2652 VSS.n674 VSS.t448 0.572871
R2653 VSS.n660 VSS.t289 0.572871
R2654 VSS.n88 VSS.n92 0.1979
R2655 VSS.n616 VSS.n613 0.56503
R2656 VSS.t56 VSS.n596 0.557126
R2657 VSS.n88 VSS.n90 0.556705
R2658 VSS.n817 VSS.n783 0.556483
R2659 VSS.n529 VSS.n14 0.556483
R2660 VSS.n891 VSS.n248 0.554008
R2661 VSS.t445 VSS.n205 0.539958
R2662 VSS.n586 VSS.n585 0.52186
R2663 VSS.t583 VSS.t581 0.492336
R2664 VSS.n668 VSS.n65 0.490843
R2665 VSS.n664 VSS.n65 0.490843
R2666 VSS.n662 VSS.n65 0.490843
R2667 VSS.n654 VSS.n651 0.490843
R2668 VSS.n671 VSS.t448 0.489061
R2669 VSS.n657 VSS.t289 0.489061
R2670 VSS.t362 VSS.n344 0.477689
R2671 VSS.t7 VSS.n343 0.477689
R2672 VSS.t295 VSS.n342 0.477689
R2673 VSS.t40 VSS.n341 0.477689
R2674 VSS.t412 VSS.n340 0.477689
R2675 VSS.t415 VSS.n339 0.477689
R2676 VSS.t58 VSS.n338 0.477689
R2677 VSS.t100 VSS.n337 0.477689
R2678 VSS.t114 VSS.n336 0.477689
R2679 VSS.t46 VSS.n335 0.477689
R2680 VSS.t417 VSS.n334 0.477689
R2681 VSS.t299 VSS.n333 0.477689
R2682 VSS.t5 VSS.n332 0.477689
R2683 VSS.t146 VSS.n331 0.477689
R2684 VSS.t376 VSS.n330 0.477689
R2685 VSS.t370 VSS.n329 0.477689
R2686 VSS.t142 VSS.n328 0.477689
R2687 VSS.t308 VSS.n327 0.477689
R2688 VSS.t272 VSS.n326 0.477689
R2689 VSS.t62 VSS.n325 0.477689
R2690 VSS.t357 VSS.n324 0.477689
R2691 VSS.t425 VSS.n323 0.477689
R2692 VSS.t305 VSS.n322 0.477689
R2693 VSS.t32 VSS.n321 0.477689
R2694 VSS.t27 VSS.n320 0.477689
R2695 VSS.t427 VSS.n319 0.477689
R2696 VSS.t108 VSS.n318 0.477689
R2697 VSS.t365 VSS.n317 0.477689
R2698 VSS.t429 VSS.n316 0.477689
R2699 VSS.t48 VSS.n315 0.477689
R2700 VSS.t38 VSS.n314 0.477689
R2701 VSS.n610 VSS.n549 0.47741
R2702 VSS.t56 VSS.n682 0.477286
R2703 VSS.t56 VSS.n683 0.472981
R2704 VSS.t25 VSS.t519 0.466542
R2705 VSS.t485 VSS.t110 0.466542
R2706 VSS.t347 VSS.t539 0.466542
R2707 VSS.t34 VSS.t264 0.466542
R2708 VSS.t530 VSS.t280 0.466542
R2709 VSS.t488 VSS.t139 0.466542
R2710 VSS.t333 VSS.t36 0.466542
R2711 VSS.t438 VSS.t293 0.466542
R2712 VSS.t172 VSS.t1 0.466542
R2713 VSS.t86 VSS.t548 0.466542
R2714 VSS.t44 VSS.t112 0.466542
R2715 VSS.t97 VSS.t60 0.466542
R2716 VSS.t336 VSS.t327 0.466542
R2717 VSS.t42 VSS.t553 0.466542
R2718 VSS.t82 VSS.t252 0.466542
R2719 VSS.n353 VSS.t75 0.466192
R2720 VSS.n358 VSS.t79 0.466192
R2721 VSS.n363 VSS.t19 0.466192
R2722 VSS.n368 VSS.t91 0.466192
R2723 VSS.n373 VSS.t22 0.466192
R2724 VSS.n378 VSS.t94 0.466192
R2725 VSS.n383 VSS.t339 0.466192
R2726 VSS.n388 VSS.t543 0.466192
R2727 VSS.n393 VSS.t311 0.466192
R2728 VSS.n398 VSS.t275 0.466192
R2729 VSS.n403 VSS.t30 0.466192
R2730 VSS.n408 VSS.t324 0.466192
R2731 VSS.n413 VSS.t342 0.466192
R2732 VSS.n418 VSS.t546 0.466192
R2733 VSS.n423 VSS.t149 0.466192
R2734 VSS.n428 VSS.t330 0.466192
R2735 VSS.n679 VSS.n600 0.465582
R2736 VSS.n616 VSS.t144 0.464894
R2737 VSS.n612 VSS.n610 0.460744
R2738 VSS.n613 VSS.n612 0.455207
R2739 VSS.t256 VSS.n428 0.451785
R2740 VSS.t519 VSS.n423 0.451785
R2741 VSS.t110 VSS.n418 0.451785
R2742 VSS.t539 VSS.n413 0.451785
R2743 VSS.t264 VSS.n408 0.451785
R2744 VSS.t280 VSS.n403 0.451785
R2745 VSS.t139 VSS.n398 0.451785
R2746 VSS.t36 VSS.n393 0.451785
R2747 VSS.t293 VSS.n388 0.451785
R2748 VSS.t1 VSS.n383 0.451785
R2749 VSS.t548 VSS.n378 0.451785
R2750 VSS.t112 VSS.n373 0.451785
R2751 VSS.t60 VSS.n368 0.451785
R2752 VSS.t327 VSS.n363 0.451785
R2753 VSS.t553 VSS.n358 0.451785
R2754 VSS.t252 VSS.n353 0.451785
R2755 VSS.t82 VSS.t79 0.451337
R2756 VSS.t42 VSS.t19 0.451337
R2757 VSS.t336 VSS.t91 0.451337
R2758 VSS.t97 VSS.t22 0.451337
R2759 VSS.t44 VSS.t94 0.451337
R2760 VSS.t86 VSS.t339 0.451337
R2761 VSS.t172 VSS.t543 0.451337
R2762 VSS.t438 VSS.t311 0.451337
R2763 VSS.t333 VSS.t275 0.451337
R2764 VSS.t488 VSS.t30 0.451337
R2765 VSS.t530 VSS.t324 0.451337
R2766 VSS.t34 VSS.t342 0.451337
R2767 VSS.t347 VSS.t546 0.451337
R2768 VSS.t485 VSS.t149 0.451337
R2769 VSS.t25 VSS.t330 0.451337
R2770 VSS.n585 VSS.n584 0.447348
R2771 VSS.n913 VSS.n182 0.44402
R2772 VSS.t7 VSS.n344 0.440228
R2773 VSS.t40 VSS.n342 0.440228
R2774 VSS.t412 VSS.n341 0.440228
R2775 VSS.t415 VSS.n340 0.440228
R2776 VSS.t58 VSS.n339 0.440228
R2777 VSS.t46 VSS.n336 0.440228
R2778 VSS.t5 VSS.n333 0.440228
R2779 VSS.t146 VSS.n332 0.440228
R2780 VSS.t376 VSS.n331 0.440228
R2781 VSS.t370 VSS.n330 0.440228
R2782 VSS.t272 VSS.n327 0.440228
R2783 VSS.t32 VSS.n322 0.440228
R2784 VSS.t427 VSS.n320 0.440228
R2785 VSS.t108 VSS.n319 0.440228
R2786 VSS.t365 VSS.n318 0.440228
R2787 VSS.t429 VSS.n317 0.440228
R2788 VSS.t48 VSS.n316 0.440228
R2789 VSS.t432 VSS.n314 0.440228
R2790 VSS.n315 VSS.t38 0.440228
R2791 VSS.n321 VSS.t27 0.440228
R2792 VSS.n323 VSS.t305 0.440228
R2793 VSS.n324 VSS.t425 0.440228
R2794 VSS.n325 VSS.t357 0.440228
R2795 VSS.n326 VSS.t62 0.440228
R2796 VSS.n328 VSS.t308 0.440228
R2797 VSS.n329 VSS.t142 0.440228
R2798 VSS.n334 VSS.t299 0.440228
R2799 VSS.n335 VSS.t417 0.440228
R2800 VSS.n337 VSS.t114 0.440228
R2801 VSS.n338 VSS.t100 0.440228
R2802 VSS.n343 VSS.t295 0.440228
R2803 VSS.n844 VSS.n546 0.418268
R2804 VSS.n800 VSS.n799 0.418268
R2805 VSS.n799 VSS.n546 0.414988
R2806 VSS.n801 VSS.n800 0.414988
R2807 VSS.n680 VSS.n550 0.41014
R2808 VSS.t10 VSS.n61 0.400619
R2809 VSS.n825 VSS.n824 0.376066
R2810 VSS.n754 VSS.n752 0.376066
R2811 VSS.n7 VSS.n3 0.351198
R2812 VSS.n821 VSS.n820 0.338265
R2813 VSS.n716 VSS.n696 0.338265
R2814 VSS.n820 VSS.n819 0.338019
R2815 VSS.n818 VSS.n696 0.338019
R2816 VSS.n741 VSS.n567 0.33508
R2817 VSS.n839 VSS.n349 0.329994
R2818 VSS.n574 VSS.n573 0.312321
R2819 VSS.n841 VSS.n840 0.31114
R2820 VSS.t191 VSS.n215 0.306378
R2821 VSS.t201 VSS.n230 0.306378
R2822 VSS.t211 VSS.n246 0.306378
R2823 VSS.t221 VSS.n270 0.306378
R2824 VSS.t231 VSS.n284 0.306378
R2825 VSS.t241 VSS.n300 0.306378
R2826 VSS.n824 VSS.n823 0.306341
R2827 VSS.n754 VSS.n753 0.306341
R2828 VSS.t432 VSS.t469 0.302153
R2829 VSS.n679 VSS.t73 0.298621
R2830 VSS.n183 VSS.n912 0.295237
R2831 VSS.n431 VSS.t256 0.290734
R2832 VSS.n848 VSS.n537 0.286439
R2833 VSS.n807 VSS.n806 0.286439
R2834 VSS.n867 VSS.n301 0.282782
R2835 VSS.n635 VSS.n634 0.280152
R2836 VSS.n636 VSS.n635 0.280152
R2837 VSS.t393 VSS.n609 0.280152
R2838 VSS.t373 VSS.n557 0.2761
R2839 VSS.n514 VSS.t75 0.275961
R2840 VSS.n912 VSS.n184 0.275933
R2841 VSS.n516 VSS.n345 0.272321
R2842 VSS.n519 VSS.n514 0.272065
R2843 VSS.n88 VSS.n122 0.267794
R2844 VSS.n88 VSS.n123 0.267794
R2845 VSS.n88 VSS.n124 0.267794
R2846 VSS.n88 VSS.n126 0.267794
R2847 VSS.n88 VSS.n175 0.267794
R2848 VSS.n88 VSS.n128 0.267794
R2849 VSS.n88 VSS.n129 0.267794
R2850 VSS.n88 VSS.n130 0.267794
R2851 VSS.n88 VSS.n131 0.267794
R2852 VSS.n88 VSS.n132 0.267794
R2853 VSS.n88 VSS.n133 0.267794
R2854 VSS.n88 VSS.n134 0.267794
R2855 VSS.n88 VSS.n135 0.267794
R2856 VSS.n88 VSS.n174 0.267794
R2857 VSS.n88 VSS.n173 0.267794
R2858 VSS.n88 VSS.n137 0.267794
R2859 VSS.n88 VSS.n138 0.267794
R2860 VSS.n88 VSS.n171 0.267794
R2861 VSS.n88 VSS.n170 0.267794
R2862 VSS.n88 VSS.n139 0.267794
R2863 VSS.n88 VSS.n140 0.267794
R2864 VSS.n88 VSS.n141 0.267794
R2865 VSS.n88 VSS.n142 0.267794
R2866 VSS.n88 VSS.n169 0.267794
R2867 VSS.n88 VSS.n144 0.267794
R2868 VSS.n88 VSS.n145 0.267794
R2869 VSS.n88 VSS.n146 0.267794
R2870 VSS.n88 VSS.n168 0.267794
R2871 VSS.n88 VSS.n147 0.267794
R2872 VSS.n88 VSS.n148 0.267794
R2873 VSS.n88 VSS.n149 0.267794
R2874 VSS.n88 VSS.n167 0.267794
R2875 VSS.n88 VSS.n150 0.267794
R2876 VSS.n88 VSS.n151 0.267794
R2877 VSS.n88 VSS.n166 0.267794
R2878 VSS.n88 VSS.n165 0.267794
R2879 VSS.n88 VSS.n153 0.267794
R2880 VSS.n88 VSS.n154 0.267794
R2881 VSS.n88 VSS.n156 0.267794
R2882 VSS.n88 VSS.n164 0.267794
R2883 VSS.n88 VSS.n157 0.267794
R2884 VSS.n88 VSS.n162 0.267794
R2885 VSS.n88 VSS.n161 0.267794
R2886 VSS.n88 VSS.n94 0.267794
R2887 VSS.n88 VSS.n95 0.267794
R2888 VSS.n88 VSS.n96 0.267794
R2889 VSS.n88 VSS.n97 0.267794
R2890 VSS.n88 VSS.n98 0.267794
R2891 VSS.n88 VSS.n99 0.267794
R2892 VSS.n88 VSS.n100 0.267794
R2893 VSS.n88 VSS.n101 0.267794
R2894 VSS.n88 VSS.n105 0.267794
R2895 VSS.n88 VSS.n106 0.267794
R2896 VSS.n88 VSS.n108 0.267794
R2897 VSS.n88 VSS.n110 0.267794
R2898 VSS.n88 VSS.n111 0.267794
R2899 VSS.n88 VSS.n112 0.267794
R2900 VSS.n88 VSS.n113 0.267794
R2901 VSS.n88 VSS.n114 0.267794
R2902 VSS.n88 VSS.n115 0.267794
R2903 VSS.n88 VSS.n117 0.267794
R2904 VSS.n88 VSS.n118 0.267794
R2905 VSS.n88 VSS.n120 0.267794
R2906 VSS.n88 VSS.n121 0.267794
R2907 VSS.n88 VSS.n159 0.267428
R2908 VSS.n570 VSS.n557 0.266107
R2909 VSS.n844 VSS.n843 0.265497
R2910 VSS.t362 VSS.n345 0.264468
R2911 VSS.n843 VSS.n842 0.264227
R2912 VSS.n205 VSS.t15 0.263148
R2913 VSS.n215 VSS.t193 0.255324
R2914 VSS.n230 VSS.t203 0.255324
R2915 VSS.n246 VSS.t166 0.255324
R2916 VSS.n270 VSS.t223 0.255324
R2917 VSS.n284 VSS.t233 0.255324
R2918 VSS.n300 VSS.t243 0.255324
R2919 VSS.t611 VSS.t469 0.254653
R2920 VSS.n88 VSS.n524 0.253567
R2921 VSS.t286 VSS.n431 0.24355
R2922 VSS.n567 VSS.n551 0.241289
R2923 VSS.t53 VSS.n678 0.241078
R2924 VSS.t317 VSS.n653 0.241078
R2925 VSS.n858 VSS.n349 0.24011
R2926 VSS.n846 VSS.n542 0.239006
R2927 VSS.n534 VSS.n848 0.239006
R2928 VSS.n802 VSS.n795 0.239006
R2929 VSS.t125 VSS.n807 0.239006
R2930 VSS.n812 VSS.n784 0.239006
R2931 VSS.n814 VSS.n813 0.239006
R2932 VSS.n539 VSS.t129 0.239006
R2933 VSS.n806 VSS.n805 0.238668
R2934 VSS.n813 VSS.n812 0.238668
R2935 VSS.n816 VSS.n815 0.238668
R2936 VSS.n18 VSS.n12 0.284653
R2937 VSS.t129 VSS.n846 0.238668
R2938 VSS.n795 VSS.t580 0.238668
R2939 VSS.n784 VSS.t126 0.238668
R2940 VSS.n542 VSS.t128 0.238668
R2941 VSS.n537 VSS.t131 0.238668
R2942 VSS.n575 VSS.n574 0.238218
R2943 VSS.n627 VSS.t409 0.233757
R2944 VSS.n629 VSS.n628 0.233757
R2945 VSS.n631 VSS.n630 0.233757
R2946 VSS.n633 VSS.n632 0.233757
R2947 VSS.n637 VSS.n636 0.233757
R2948 VSS.n628 VSS.n627 0.233419
R2949 VSS.n630 VSS.n629 0.233419
R2950 VSS.n632 VSS.n631 0.233419
R2951 VSS.n634 VSS.n633 0.233419
R2952 VSS.n609 VSS.n638 0.233419
R2953 VSS.n563 VSS.n561 0.225543
R2954 VSS.t187 VSS.t189 0.224424
R2955 VSS.t207 VSS.t209 0.224424
R2956 VSS.t237 VSS.t239 0.224424
R2957 VSS.t227 VSS.t229 0.224424
R2958 VSS.t217 VSS.t219 0.224424
R2959 VSS.t197 VSS.t199 0.224424
R2960 VSS.t186 VSS.t187 0.220674
R2961 VSS.t152 VSS.t207 0.220674
R2962 VSS.t71 VSS.t237 0.220674
R2963 VSS.t227 VSS.t158 0.220674
R2964 VSS.t217 VSS.t216 0.220674
R2965 VSS.t197 VSS.t155 0.220674
R2966 VSS.n581 VSS.n561 0.219552
R2967 VSS.t56 VSS.n687 0.211735
R2968 VSS.n835 VSS.n550 0.20686
R2969 VSS.n87 VSS.n311 0.20231
R2970 VSS.n12 VSS.n739 0.286815
R2971 VSS.n586 VSS.n566 0.191235
R2972 VSS.t586 VSS.n543 0.191235
R2973 VSS.n847 VSS.n539 0.191235
R2974 VSS.n538 VSS.n847 0.191235
R2975 VSS.t131 VSS.n538 0.191235
R2976 VSS.n849 VSS.n533 0.191235
R2977 VSS.n531 VSS.n849 0.191235
R2978 VSS.t135 VSS.n531 0.191235
R2979 VSS.n850 VSS.n530 0.191235
R2980 VSS.n851 VSS.n850 0.191235
R2981 VSS.t580 VSS.n796 0.191235
R2982 VSS.n803 VSS.n802 0.191235
R2983 VSS.n804 VSS.n803 0.191235
R2984 VSS.n805 VSS.n804 0.191235
R2985 VSS.n789 VSS.n788 0.191235
R2986 VSS.n788 VSS.n787 0.191235
R2987 VSS.n787 VSS.t126 0.191235
R2988 VSS.n815 VSS.n814 0.191235
R2989 VSS.n433 VSS.n87 0.191235
R2990 VSS.n533 VSS.t133 0.191235
R2991 VSS.t133 VSS.n534 0.191235
R2992 VSS.n789 VSS.t125 0.191235
R2993 VSS.t128 VSS.t586 0.191235
R2994 VSS.n530 VSS.t135 0.191235
R2995 VSS.n743 VSS.n10 0.268071
R2996 VSS.t601 VSS.t598 0.1875
R2997 VSS.t595 VSS.t591 0.1875
R2998 VSS.t607 VSS.t604 0.1875
R2999 VSS.n638 VSS.n637 0.187025
R3000 VSS.n690 VSS.n694 0.181924
R3001 VSS.n695 VSS.n737 0.181543
R3002 VSS.n799 VSS.t578 0.167615
R3003 VSS.n738 VSS.n737 0.164808
R3004 VSS.n691 VSS.n690 0.164424
R3005 VSS.n88 VSS.n178 0.160396
R3006 VSS.n88 VSS.n180 0.160396
R3007 VSS.n88 VSS.n181 0.160396
R3008 VSS.n611 VSS.n565 0.156138
R3009 VSS.n841 VSS.n547 0.150687
R3010 VSS.t399 VSS.n72 0.14953
R3011 VSS.t383 VSS.n72 0.149447
R3012 VSS.n891 VSS.n247 0.144066
R3013 VSS.n740 VSS.n689 0.143368
R3014 VSS.n434 VSS.n433 0.142513
R3015 VSS.n744 VSS.n592 0.142012
R3016 VSS.t614 VSS.n311 0.139294
R3017 VSS.t387 VSS.n72 0.138776
R3018 VSS.t403 VSS.n72 0.13875
R3019 VSS.t378 VSS.n72 0.138729
R3020 VSS.t395 VSS.n72 0.138705
R3021 VSS.n744 VSS.n738 0.138262
R3022 VSS.n840 VSS.n182 0.138073
R3023 VSS.t608 VSS.t286 0.135868
R3024 VSS.t611 VSS.n313 0.124618
R3025 VSS.t608 VSS.n310 0.122118
R3026 VSS.n313 VSS.t610 0.122118
R3027 VSS.n742 VSS.n740 0.120868
R3028 VSS.t583 VSS.n692 0.1171
R3029 VSS.n543 VSS.n545 0.112118
R3030 VSS.n796 VSS.n797 0.112118
R3031 VSS.t391 VSS.n72 0.11127
R3032 VSS.t161 VSS.n301 0.109701
R3033 VSS.n434 VSS.t612 0.109642
R3034 VSS.n694 VSS.n693 0.104618
R3035 VSS.n695 VSS.n732 0.104618
R3036 VSS.t407 VSS.n72 0.103331
R3037 VSS.t596 VSS.n558 0.0971176
R3038 VSS.n611 VSS.n566 0.0971176
R3039 VSS.n565 VSS.n564 0.0958002
R3040 VSS.n564 VSS.n562 0.0955
R3041 VSS.n576 VSS.n575 0.093
R3042 VSS.t602 VSS.n348 0.08925
R3043 VSS.n521 VSS.t463 0.08925
R3044 VSS.t598 VSS.n583 0.0851154
R3045 VSS.n584 VSS.t601 0.0851154
R3046 VSS.t591 VSS.n572 0.0851154
R3047 VSS.n573 VSS.t595 0.0851154
R3048 VSS.t604 VSS.n518 0.0851154
R3049 VSS.n519 VSS.t607 0.0851154
R3050 VSS.n617 VSS.t254 0.0846176
R3051 VSS.n626 VSS.n549 0.0846176
R3052 VSS.n822 VSS.n821 0.08425
R3053 VSS.n717 VSS.n716 0.08425
R3054 VSS.n572 VSS.n4 0.08175
R3055 VSS.n583 VSS.n578 0.08175
R3056 VSS.n571 VSS.n555 0.08175
R3057 VSS.n582 VSS.n559 0.08175
R3058 VSS.n866 VSS.n865 0.0805
R3059 VSS.n827 VSS.n826 0.0805
R3060 VSS.n545 VSS.n544 0.0796176
R3061 VSS.n797 VSS.n798 0.0796176
R3062 VSS.t12 VSS.n523 0.078
R3063 VSS.t614 VSS.n312 0.0771176
R3064 VSS.n828 VSS.n827 0.07675
R3065 VSS.n544 VSS.n844 0.0758676
R3066 VSS.n798 VSS.n801 0.0758676
R3067 VSS.n518 VSS.n350 0.0746176
R3068 VSS.n517 VSS.n347 0.0746176
R3069 VSS.n837 VSS.n548 0.07425
R3070 VSS.n826 VSS.n691 0.07425
R3071 VSS.t589 VSS.n552 0.0740901
R3072 VSS.t528 VSS.n548 0.07175
R3073 VSS.t116 VSS.n524 0.0715476
R3074 VSS.t379 VSS.n617 0.0708676
R3075 VSS.t394 VSS.n626 0.0708676
R3076 VSS.t610 VSS.n312 0.0696176
R3077 VSS.n518 VSS.t465 0.06925
R3078 VSS.t191 VSS.n209 0.06925
R3079 VSS.t201 VSS.n228 0.06925
R3080 VSS.t211 VSS.n240 0.06925
R3081 VSS.t221 VSS.n268 0.06925
R3082 VSS.t231 VSS.n282 0.06925
R3083 VSS.t241 VSS.n294 0.06925
R3084 VSS.n823 VSS.n822 0.06925
R3085 VSS.n753 VSS.n717 0.06925
R3086 VSS.t528 VSS.n828 0.06925
R3087 VSS.n517 VSS.n346 0.06925
R3088 VSS.n573 VSS.n569 0.0671176
R3089 VSS.n584 VSS.n580 0.0671176
R3090 VSS.n570 VSS.n556 0.0671176
R3091 VSS.n581 VSS.n560 0.0671176
R3092 VSS.n572 VSS.n569 0.0621177
R3093 VSS.n583 VSS.n580 0.0621177
R3094 VSS.n571 VSS.n556 0.0621177
R3095 VSS.n582 VSS.n560 0.0621177
R3096 VSS.n516 VSS.n346 0.05925
R3097 VSS.n519 VSS.t465 0.05925
R3098 VSS.t373 VSS.n558 0.0571176
R3099 VSS.t463 VSS.n350 0.0546176
R3100 VSS.t602 VSS.n347 0.0546176
R3101 VSS.t189 VSS.n209 0.05175
R3102 VSS.n228 VSS.t199 0.05175
R3103 VSS.t209 VSS.n240 0.05175
R3104 VSS.n268 VSS.t219 0.05175
R3105 VSS.n282 VSS.t229 0.05175
R3106 VSS.t239 VSS.n294 0.05175
R3107 VSS.n693 VSS.n825 0.0496177
R3108 VSS.n752 VSS.n732 0.0496177
R3109 VSS.n553 VSS.n551 0.04925
R3110 VSS.t592 VSS.n553 0.04925
R3111 VSS.n577 VSS.n576 0.04925
R3112 VSS.n692 VSS.n18 0.04925
R3113 VSS.n827 VSS.n689 0.048
R3114 VSS.n578 VSS.n577 0.04675
R3115 VSS.t596 VSS.n559 0.04675
R3116 VSS.n692 VSS.n743 0.04675
R3117 VSS.n834 VSS.n4 0.0305
R3118 VSS.n555 VSS.n554 0.0305
R3119 VSS.t612 VSS.n160 0.02925
R3120 VSS.n741 VSS.n552 0.0253401
R3121 VSS.n867 VSS.n309 0.023135
R3122 VSS.n867 VSS.n304 0.023135
R3123 VSS.n870 VSS.n298 0.023135
R3124 VSS.n873 VSS.n286 0.023135
R3125 VSS.n873 VSS.n287 0.023135
R3126 VSS.n877 VSS.n876 0.023135
R3127 VSS.n882 VSS.n273 0.023135
R3128 VSS.n882 VSS.n274 0.023135
R3129 VSS.n886 VSS.n885 0.023135
R3130 VSS.n891 VSS.n250 0.023135
R3131 VSS.n891 VSS.n252 0.023135
R3132 VSS.n891 VSS.n253 0.023135
R3133 VSS.n891 VSS.n254 0.023135
R3134 VSS.n894 VSS.n244 0.023135
R3135 VSS.n897 VSS.n232 0.023135
R3136 VSS.n897 VSS.n233 0.023135
R3137 VSS.n901 VSS.n900 0.023135
R3138 VSS.n906 VSS.n218 0.023135
R3139 VSS.n906 VSS.n219 0.023135
R3140 VSS.n909 VSS.n213 0.023135
R3141 VSS.n912 VSS.n185 0.023135
R3142 VSS.n912 VSS.n189 0.023135
R3143 VSS.n912 VSS.n199 0.023135
R3144 VSS.n865 VSS.n310 0.02175
R3145 VSS.n183 VSS.t106 0.0191553
R3146 VSS.n672 VSS.t448 0.0184075
R3147 VSS.n658 VSS.t289 0.0184075
R3148 VSS.t56 VSS.n684 0.0173993
R3149 VSS.n834 VSS.t592 0.01675
R3150 VSS.n554 VSS.t589 0.01675
R3151 VSS.n88 VSS.n177 0.0165542
R3152 VSS.n88 VSS.n179 0.0165542
R3153 VSS.n866 VSS.n160 0.0155
R3154 VSS.t10 VSS.n60 0.0151406
R3155 VSS.n666 VSS.n65 0.0151406
R3156 VSS.n665 VSS.n65 0.0151406
R3157 VSS.n654 VSS.n603 0.0151406
R3158 VSS.t56 VSS.n599 0.0150892
R3159 VSS VSS.n913 0.0134067
R3160 VSS.n563 VSS.n562 0.013
R3161 VSS.n88 VSS.n176 0.00962826
R3162 VSS.n88 VSS.n172 0.00962826
R3163 VSS.n88 VSS.n163 0.00962826
R3164 VSS.n88 VSS.n127 0.00937856
R3165 VSS.n88 VSS.n152 0.00937856
R3166 VSS.n88 VSS.n93 0.00937856
R3167 VSS.n88 VSS.n103 0.00937856
R3168 VSS.n88 VSS.n107 0.00937856
R3169 VSS.n88 VSS.n116 0.00937856
R3170 VSS.n88 VSS.n125 0.00937856
R3171 VSS.n88 VSS.n136 0.00937856
R3172 VSS.n88 VSS.n143 0.00937856
R3173 VSS.n88 VSS.n155 0.00937856
R3174 VSS.n88 VSS.n158 0.00937856
R3175 VSS.n88 VSS.n102 0.00937856
R3176 VSS.n88 VSS.n104 0.00937856
R3177 VSS.n88 VSS.n109 0.00937856
R3178 VSS.n88 VSS.n119 0.00937856
R3179 VSS.n858 VSS.n521 0.00675
R3180 VSS.n839 VSS.n348 0.00675
R3181 VSS.n27 VSS.n540 0.00495229
R3182 VSS.n10 VSS.n742 0.120722
R3183 VSS.n838 VSS.n40 0.00459701
R3184 VSS.n36 VSS.n532 0.00439839
R3185 VSS.n32 VSS.n33 0.00399966
R3186 VSS.n14 VSS.n13 0.00383308
R3187 VSS.n808 VSS.n50 0.00362425
R3188 VSS.n83 VSS.n84 0.00299994
R3189 VSS.n19 VSS.n11 0.00299994
R3190 VSS.n7 VSS.n0 0.00296307
R3191 VSS.n528 VSS.n40 0.00249997
R3192 VSS.n59 VSS.n58 0.00224999
R3193 VSS.n739 VSS.n592 0.00224991
R3194 VSS.n66 VSS.n65 0.0022
R3195 VSS.n829 VSS.n40 0.00216667
R3196 VSS.n86 VSS.n89 0.00174993
R3197 VSS.n853 VSS.n40 0.00193134
R3198 VSS.n307 VSS.n299 0.00179957
R3199 VSS.n306 VSS.n299 0.00179957
R3200 VSS.n296 VSS.n293 0.00179957
R3201 VSS.n289 VSS.n283 0.00179957
R3202 VSS.n288 VSS.n283 0.00179957
R3203 VSS.n879 VSS.n279 0.00179957
R3204 VSS.n276 VSS.n269 0.00179957
R3205 VSS.n275 VSS.n269 0.00179957
R3206 VSS.n888 VSS.n265 0.00179957
R3207 VSS.n257 VSS.n245 0.00179957
R3208 VSS.n256 VSS.n245 0.00179957
R3209 VSS.n242 VSS.n239 0.00179957
R3210 VSS.n235 VSS.n229 0.00179957
R3211 VSS.n234 VSS.n229 0.00179957
R3212 VSS.n903 VSS.n225 0.00179957
R3213 VSS.n222 VSS.n214 0.00179957
R3214 VSS.n221 VSS.n214 0.00179957
R3215 VSS.n211 VSS.n208 0.00179957
R3216 VSS.n912 VSS.n192 0.00179957
R3217 VSS.n912 VSS.n194 0.00179957
R3218 VSS.n912 VSS.n198 0.00179957
R3219 VSS.n19 VSS.n17 0.00149995
R3220 VSS.n21 VSS.n20 0.00169993
R3221 VSS.n25 VSS.n24 0.00169993
R3222 VSS.n535 VSS.n527 0.00166667
R3223 VSS.n32 VSS.n31 0.00138884
R3224 VSS.n829 VSS.n15 0.00344431
R3225 VSS.n20 VSS.n11 0.00279996
R3226 VSS.n793 VSS.n785 0.00166667
R3227 VSS.n790 VSS.n786 0.00166667
R3228 VSS.n48 VSS.n47 0.00169993
R3229 VSS.n56 VSS.n55 0.00169993
R3230 VSS.n809 VSS.n57 0.00166667
R3231 VSS.n75 VSS.n74 0.00169993
R3232 VSS.n77 VSS.n76 0.00169993
R3233 VSS.n79 VSS.n78 0.00169993
R3234 VSS.n81 VSS.n80 0.00169993
R3235 VSS.n620 VSS.n606 0.00166667
R3236 VSS.n619 VSS.n607 0.00166667
R3237 VSS.n83 VSS.n82 0.00149995
R3238 VSS.n639 VSS.n608 0.00166667
R3239 VSS.n640 VSS.n72 0.00166667
R3240 VSS.n810 VSS.n783 0.00162501
R3241 VSS.n7 VSS.n5 0.00161188
R3242 VSS.n88 VSS.n85 0.0015
R3243 VSS.n621 VSS.n81 0.0015
R3244 VSS.n622 VSS.n79 0.0015
R3245 VSS.n623 VSS.n77 0.0015
R3246 VSS.n624 VSS.n75 0.0015
R3247 VSS.n625 VSS.n72 0.0015
R3248 VSS.n70 VSS.n69 0.00214264
R3249 VSS.n70 VSS.t289 0.0015
R3250 VSS.n65 VSS.t289 0.0015
R3251 VSS.n810 VSS.n58 0.00137498
R3252 VSS.n677 VSS.t10 0.00136832
R3253 VSS.n794 VSS.n785 0.00133332
R3254 VSS.n791 VSS.n786 0.00133332
R3255 VSS.n809 VSS.n54 0.00133332
R3256 VSS.n536 VSS.n527 0.00133332
R3257 VSS.n621 VSS.n606 0.00133332
R3258 VSS.n620 VSS.n607 0.00133332
R3259 VSS.n618 VSS.n608 0.00133332
R3260 VSS.n640 VSS.n639 0.00133332
R3261 VSS.n7 VSS.n1 0.00128573
R3262 VSS.n7 VSS.n2 0.00128573
R3263 VSS.n73 VSS.n72 0.00130817
R3264 VSS.n649 VSS.n72 0.00105852
R3265 VSS.n644 VSS.n72 0.00105852
R3266 VSS.n912 VSS.n206 0.00104691
R3267 VSS.n867 VSS.n303 0.00101811
R3268 VSS.n873 VSS.n292 0.00101811
R3269 VSS.n873 VSS.n291 0.00101811
R3270 VSS.n882 VSS.n881 0.00101811
R3271 VSS.n882 VSS.n278 0.00101811
R3272 VSS.n891 VSS.n890 0.00101811
R3273 VSS.n891 VSS.n259 0.00101811
R3274 VSS.n897 VSS.n238 0.00101811
R3275 VSS.n897 VSS.n237 0.00101811
R3276 VSS.n906 VSS.n905 0.00101811
R3277 VSS.n906 VSS.n224 0.00101811
R3278 VSS.n912 VSS.n207 0.00101811
R3279 VSS.n891 VSS.n262 0.00100065
R3280 VSS.n867 VSS.n302 0.00100065
R3281 VSS.n891 VSS.n251 0.00100065
R3282 VSS.n891 VSS.n260 0.00100065
R3283 VSS.n912 VSS.n186 0.00100065
R3284 VSS.n648 VSS.n72 0.00100006
R3285 VSS.n642 VSS.n72 0.00100001
R3286 VSS.n643 VSS.n72 0.00100001
R3287 VSS.n645 VSS.n72 0.00100001
R3288 VSS.n647 VSS.n72 0.00100001
R3289 VSS.n646 VSS.n72 0.00100001
R3290 VSS.n868 VSS.n299 0.001
R3291 VSS.n870 VSS.n869 0.001
R3292 VSS.n871 VSS.n293 0.001
R3293 VSS.n873 VSS.n872 0.001
R3294 VSS.n874 VSS.n283 0.001
R3295 VSS.n876 VSS.n875 0.001
R3296 VSS.n879 VSS.n280 0.001
R3297 VSS.n882 VSS.n272 0.001
R3298 VSS.n883 VSS.n269 0.001
R3299 VSS.n885 VSS.n884 0.001
R3300 VSS.n888 VSS.n266 0.001
R3301 VSS.n891 VSS.n249 0.001
R3302 VSS.n892 VSS.n245 0.001
R3303 VSS.n894 VSS.n893 0.001
R3304 VSS.n895 VSS.n239 0.001
R3305 VSS.n897 VSS.n896 0.001
R3306 VSS.n898 VSS.n229 0.001
R3307 VSS.n900 VSS.n899 0.001
R3308 VSS.n903 VSS.n226 0.001
R3309 VSS.n906 VSS.n217 0.001
R3310 VSS.n907 VSS.n214 0.001
R3311 VSS.n909 VSS.n908 0.001
R3312 VSS.n910 VSS.n208 0.001
R3313 VSS.n912 VSS.n911 0.001
R3314 VSS.n911 VSS.n208 0.001
R3315 VSS.n910 VSS.n909 0.001
R3316 VSS.n908 VSS.n214 0.001
R3317 VSS.n907 VSS.n906 0.001
R3318 VSS.n903 VSS.n217 0.001
R3319 VSS.n900 VSS.n226 0.001
R3320 VSS.n899 VSS.n229 0.001
R3321 VSS.n898 VSS.n897 0.001
R3322 VSS.n896 VSS.n239 0.001
R3323 VSS.n895 VSS.n894 0.001
R3324 VSS.n893 VSS.n245 0.001
R3325 VSS.n892 VSS.n891 0.001
R3326 VSS.n888 VSS.n249 0.001
R3327 VSS.n885 VSS.n266 0.001
R3328 VSS.n884 VSS.n269 0.001
R3329 VSS.n883 VSS.n882 0.001
R3330 VSS.n879 VSS.n272 0.001
R3331 VSS.n876 VSS.n280 0.001
R3332 VSS.n875 VSS.n283 0.001
R3333 VSS.n874 VSS.n873 0.001
R3334 VSS.n872 VSS.n293 0.001
R3335 VSS.n871 VSS.n870 0.001
R3336 VSS.n869 VSS.n299 0.001
R3337 VSS.n868 VSS.n867 0.001
R3338 VSS.n89 VSS.n88 0.001
R3339 VSS.n794 VSS.n42 0.001
R3340 VSS.n792 VSS.n43 0.001
R3341 VSS.n791 VSS.n45 0.001
R3342 VSS.n51 VSS.n53 0.001
R3343 VSS.n59 VSS.n57 0.00174999
R3344 VSS.n845 VSS.n528 0.001
R3345 VSS.n541 VSS.n22 0.001
R3346 VSS.n536 VSS.n30 0.001
R3347 VSS.n532 VSS.n34 0.001
R3348 VSS.n13 VSS.n39 0.001
R3349 VSS.n64 VSS.n63 0.00192843
R3350 VSS.n63 VSS.t448 0.0015
R3351 VSS.t10 VSS.t448 0.0015
R3352 VSS.n55 VSS.n54 0.0015
R3353 VSS.n808 VSS.n48 0.0015
R3354 VSS.n46 VSS.n792 0.00199997
R3355 VSS.n44 VSS.n793 0.00199997
R3356 VSS.n40 VSS.n42 0.00199997
R3357 VSS.n540 VSS.n25 0.0015
R3358 VSS.n23 VSS.n845 0.00199997
R3359 VSS.n16 VSS.n9 0.00199997
R3360 VSS.n783 VSS.n21 0.0015
R3361 VSS.n7 VSS.n6 0.00125
R3362 VSS.n654 VSS.n71 0.001
R3363 VSS.n618 VSS.n84 0.001
R3364 VSS.n615 VSS.n587 0.001
R3365 VSS.t56 VSS.n587 0.001
R3366 VSS.n586 VSS.n6 8.47794
R3367 VSS.n833 VSS.n6 8.50175
R3368 a_3747_311.n0 a_3747_311.t2 52.0388
R3369 a_3747_311.t1 a_3747_311.n0 35.4491
R3370 a_3747_311.n0 a_3747_311.t3 33.5891
R3371 a_3747_311.t0 a_3747_311.t1 5.61942
R3372 a_3171_311.n0 a_3171_311.t2 51.8377
R3373 a_3171_311.n0 a_3171_311.t3 33.3881
R3374 a_3171_311.t1 a_3171_311.n0 31.8923
R3375 a_3171_311.t0 a_3171_311.t1 5.61777
R3376 a_2595_311.n0 a_2595_311.t2 51.6367
R3377 a_2595_311.n0 a_2595_311.t3 33.187
R3378 a_2595_311.t1 a_2595_311.n0 27.993
R3379 a_2595_311.t0 a_2595_311.t1 5.73018
R3380 a_3747_1047.n0 a_3747_1047.t2 38.0081
R3381 a_3747_1047.n0 a_3747_1047.t3 33.3957
R3382 a_3747_1047.n1 a_3747_1047.t4 33.3957
R3383 a_3747_1047.n2 a_3747_1047.t5 33.3957
R3384 a_3747_1047.n3 a_3747_1047.t6 33.3957
R3385 a_3747_1047.n4 a_3747_1047.t7 33.3957
R3386 a_3747_1047.n5 a_3747_1047.t8 33.3957
R3387 a_3747_1047.n6 a_3747_1047.t9 33.3957
R3388 a_3747_1047.t1 a_3747_1047.n6 23.2419
R3389 a_3747_1047.t0 a_3747_1047.t1 5.61942
R3390 a_3747_1047.n6 a_3747_1047.n5 4.61291
R3391 a_3747_1047.n5 a_3747_1047.n4 4.61291
R3392 a_3747_1047.n4 a_3747_1047.n3 4.61291
R3393 a_3747_1047.n3 a_3747_1047.n2 4.61291
R3394 a_3747_1047.n2 a_3747_1047.n1 4.61291
R3395 a_3747_1047.n1 a_3747_1047.n0 4.61291
R3396 a_3171_1047.n0 a_3171_1047.t2 37.8054
R3397 a_3171_1047.n0 a_3171_1047.t3 33.193
R3398 a_3171_1047.n1 a_3171_1047.t4 33.193
R3399 a_3171_1047.n2 a_3171_1047.t5 33.193
R3400 a_3171_1047.n3 a_3171_1047.t6 33.193
R3401 a_3171_1047.n4 a_3171_1047.t7 33.193
R3402 a_3171_1047.n5 a_3171_1047.t8 33.193
R3403 a_3171_1047.n6 a_3171_1047.t9 33.193
R3404 a_3171_1047.t1 a_3171_1047.n6 23.0313
R3405 a_3171_1047.t0 a_3171_1047.t1 5.61777
R3406 a_3171_1047.n6 a_3171_1047.n5 4.61291
R3407 a_3171_1047.n5 a_3171_1047.n4 4.61291
R3408 a_3171_1047.n4 a_3171_1047.n3 4.61291
R3409 a_3171_1047.n3 a_3171_1047.n2 4.61291
R3410 a_3171_1047.n2 a_3171_1047.n1 4.61291
R3411 a_3171_1047.n1 a_3171_1047.n0 4.61291
R3412 a_2595_1047.n0 a_2595_1047.t2 37.7691
R3413 a_2595_1047.n0 a_2595_1047.t3 33.1567
R3414 a_2595_1047.n1 a_2595_1047.t4 33.1567
R3415 a_2595_1047.n2 a_2595_1047.t5 33.1567
R3416 a_2595_1047.n3 a_2595_1047.t6 33.1567
R3417 a_2595_1047.n4 a_2595_1047.t7 33.1567
R3418 a_2595_1047.n5 a_2595_1047.t8 33.1567
R3419 a_2595_1047.n6 a_2595_1047.t9 33.1567
R3420 a_2595_1047.t1 a_2595_1047.n6 22.7941
R3421 a_2595_1047.t0 a_2595_1047.t1 5.65522
R3422 a_2595_1047.n6 a_2595_1047.n5 4.61291
R3423 a_2595_1047.n5 a_2595_1047.n4 4.61291
R3424 a_2595_1047.n4 a_2595_1047.n3 4.61291
R3425 a_2595_1047.n3 a_2595_1047.n2 4.61291
R3426 a_2595_1047.n2 a_2595_1047.n1 4.61291
R3427 a_2595_1047.n1 a_2595_1047.n0 4.61291
R3428 a_2019_1047.n0 a_2019_1047.t2 37.9701
R3429 a_2019_1047.n0 a_2019_1047.t3 33.3577
R3430 a_2019_1047.n1 a_2019_1047.t4 33.3577
R3431 a_2019_1047.n2 a_2019_1047.t5 33.3577
R3432 a_2019_1047.n3 a_2019_1047.t6 33.3577
R3433 a_2019_1047.n4 a_2019_1047.t7 33.3577
R3434 a_2019_1047.n5 a_2019_1047.t8 33.3577
R3435 a_2019_1047.t1 a_2019_1047.t9 22.5945
R3436 a_2019_1047.t0 a_2019_1047.t1 5.62052
R3437 a_2019_1047.t9 a_2019_1047.n5 4.61291
R3438 a_2019_1047.n5 a_2019_1047.n4 4.61291
R3439 a_2019_1047.n4 a_2019_1047.n3 4.61291
R3440 a_2019_1047.n3 a_2019_1047.n2 4.61291
R3441 a_2019_1047.n2 a_2019_1047.n1 4.61291
R3442 a_2019_1047.n1 a_2019_1047.n0 4.61291
C1413 MUX_OUT VSS 3.24058f
C1414 MUX_SEL4 VSS 1.60778f
C1415 MUX_SEL3 VSS 0.90686f
C1416 MUX_SEL2 VSS 1.81137f
C1417 MUX_SEL1 VSS 0.95075f
C1418 MUX_SEL0 VSS 1.5515f
C1419 DELAY_VBIASP VSS 5.14023f
C1420 DELAY_OUT_LAST VSS 2.97841f
C1421 DELAY_VBIASN VSS 0.11242p
C1422 REF_CLK VSS 3.19236f
C1423 DLL_RESETN VSS 4.2198f
C1424 VDD VSS 61.876f
C1425 a_26985_519# VSS 0.17928f ; **FLOATING
C1426 a_23945_519# VSS 0.17928f ; **FLOATING
C1427 a_20905_519# VSS 0.17928f ; **FLOATING
C1428 a_17865_519# VSS 0.17593f ; **FLOATING
C1429 a_16851_309# VSS 0.38699f ; **FLOATING
C1430 a_16108_289# VSS 3.85084f ; **FLOATING
C1431 a_15964_289# VSS 0.17613f ; **FLOATING
C1432 a_15765_463# VSS 0.36132f ; **FLOATING
C1433 a_14825_519# VSS 0.17928f ; **FLOATING
C1434 a_11785_519# VSS 0.17928f ; **FLOATING
C1435 a_8745_519# VSS 0.17928f ; **FLOATING
C1436 a_5731_289# VSS 3.39133f ; **FLOATING
C1437 a_2019_311# VSS 1.61601f ; **FLOATING
C1438 a_5705_519# VSS 0.17638f ; **FLOATING
C1439 a_3449_331# VSS 0.18478f ; **FLOATING
C1440 a_2873_331# VSS 0.18321f ; **FLOATING
C1441 a_2297_331# VSS 0.18321f ; **FLOATING
C1442 a_1721_331# VSS 0.17001f ; **FLOATING
C1443 a_1544_289# VSS 0.30014f ; **FLOATING
C1444 a_1256_289# VSS 0.84266f ; **FLOATING
C1445 a_27991_1008# VSS 0.18706f ; **FLOATING
C1446 a_27915_1044# VSS 0.10926f ; **FLOATING
C1447 a_27124_1008# VSS 0.17878f ; **FLOATING
C1448 a_27048_1044# VSS 0.12122f ; **FLOATING
C1449 a_26471_1008# VSS 0.18175f ; **FLOATING
C1450 a_26395_1044# VSS 0.11073f ; **FLOATING
C1451 a_25604_1008# VSS 0.18087f ; **FLOATING
C1452 a_25630_1044# VSS 0.34158f ; **FLOATING
C1453 a_25528_1044# VSS 0.12433f ; **FLOATING
C1454 a_24951_1008# VSS 0.18335f ; **FLOATING
C1455 a_24875_1044# VSS 0.11016f ; **FLOATING
C1456 a_24084_1008# VSS 0.17878f ; **FLOATING
C1457 a_24008_1044# VSS 0.12122f ; **FLOATING
C1458 a_23431_1008# VSS 0.18175f ; **FLOATING
C1459 a_23355_1044# VSS 0.11073f ; **FLOATING
C1460 a_22564_1008# VSS 0.18087f ; **FLOATING
C1461 a_22590_1044# VSS 0.33314f ; **FLOATING
C1462 a_22488_1044# VSS 0.12433f ; **FLOATING
C1463 a_21911_1008# VSS 0.18335f ; **FLOATING
C1464 a_21835_1044# VSS 0.11016f ; **FLOATING
C1465 a_21044_1008# VSS 0.17878f ; **FLOATING
C1466 a_20968_1044# VSS 0.12122f ; **FLOATING
C1467 a_20391_1008# VSS 0.18175f ; **FLOATING
C1468 a_20315_1044# VSS 0.11073f ; **FLOATING
C1469 a_19524_1008# VSS 0.18087f ; **FLOATING
C1470 a_19550_1044# VSS 0.33563f ; **FLOATING
C1471 a_19448_1044# VSS 0.12433f ; **FLOATING
C1472 a_18871_1008# VSS 0.18335f ; **FLOATING
C1473 a_18795_1044# VSS 0.11016f ; **FLOATING
C1474 a_18004_1008# VSS 0.17878f ; **FLOATING
C1475 a_17928_1044# VSS 0.12122f ; **FLOATING
C1476 a_17351_1008# VSS 0.18022f ; **FLOATING
C1477 a_17275_1044# VSS 0.10926f ; **FLOATING
C1478 a_16484_1008# VSS 0.18023f ; **FLOATING
C1479 a_16510_1044# VSS 0.28935f ; **FLOATING
C1480 a_16408_1044# VSS 0.1229f ; **FLOATING
C1481 a_15831_1008# VSS 0.17846f ; **FLOATING
C1482 a_15755_1044# VSS 0.10926f ; **FLOATING
C1483 a_14964_1008# VSS 0.17878f ; **FLOATING
C1484 a_14888_1044# VSS 0.12122f ; **FLOATING
C1485 a_14311_1008# VSS 0.18175f ; **FLOATING
C1486 a_14235_1044# VSS 0.11073f ; **FLOATING
C1487 a_13444_1008# VSS 0.18087f ; **FLOATING
C1488 a_13470_1044# VSS 0.30333f ; **FLOATING
C1489 a_13368_1044# VSS 0.12433f ; **FLOATING
C1490 a_12791_1008# VSS 0.18335f ; **FLOATING
C1491 a_12715_1044# VSS 0.11016f ; **FLOATING
C1492 a_11924_1008# VSS 0.17878f ; **FLOATING
C1493 a_11848_1044# VSS 0.12122f ; **FLOATING
C1494 a_11271_1008# VSS 0.18175f ; **FLOATING
C1495 a_11195_1044# VSS 0.11073f ; **FLOATING
C1496 a_10404_1008# VSS 0.18087f ; **FLOATING
C1497 a_10430_1044# VSS 0.31665f ; **FLOATING
C1498 a_10328_1044# VSS 0.12433f ; **FLOATING
C1499 a_9751_1008# VSS 0.18335f ; **FLOATING
C1500 a_9675_1044# VSS 0.11016f ; **FLOATING
C1501 a_8884_1008# VSS 0.17878f ; **FLOATING
C1502 a_8808_1044# VSS 0.12122f ; **FLOATING
C1503 a_8231_1008# VSS 0.18175f ; **FLOATING
C1504 a_8155_1044# VSS 0.11073f ; **FLOATING
C1505 a_7364_1008# VSS 0.18087f ; **FLOATING
C1506 a_7390_1044# VSS 0.31357f ; **FLOATING
C1507 a_7288_1044# VSS 0.12433f ; **FLOATING
C1508 a_6711_1008# VSS 0.18335f ; **FLOATING
C1509 a_6635_1044# VSS 0.11016f ; **FLOATING
C1510 a_5844_1008# VSS 0.17878f ; **FLOATING
C1511 a_5768_1044# VSS 0.12122f ; **FLOATING
C1512 a_5191_1008# VSS 0.18022f ; **FLOATING
C1513 a_5115_1044# VSS 0.10926f ; **FLOATING
C1514 a_4324_1008# VSS 0.18023f ; **FLOATING
C1515 a_4350_1044# VSS 0.26655f ; **FLOATING
C1516 a_4248_1044# VSS 0.12443f ; **FLOATING
C1517 a_27705_1044# VSS 0.25297f ; **FLOATING
C1518 a_26185_1044# VSS 0.23475f ; **FLOATING
C1519 a_24665_1044# VSS 0.25433f ; **FLOATING
C1520 a_23145_1044# VSS 0.23475f ; **FLOATING
C1521 a_21625_1044# VSS 0.25433f ; **FLOATING
C1522 a_20105_1044# VSS 0.23475f ; **FLOATING
C1523 a_18585_1044# VSS 0.25433f ; **FLOATING
C1524 a_17065_1044# VSS 0.23386f ; **FLOATING
C1525 a_15545_1044# VSS 0.25297f ; **FLOATING
C1526 a_14025_1044# VSS 0.23475f ; **FLOATING
C1527 a_12505_1044# VSS 0.25433f ; **FLOATING
C1528 a_10985_1044# VSS 0.23475f ; **FLOATING
C1529 a_9465_1044# VSS 0.25433f ; **FLOATING
C1530 a_7945_1044# VSS 0.23475f ; **FLOATING
C1531 a_6425_1044# VSS 0.25433f ; **FLOATING
C1532 a_4905_1044# VSS 0.23549f ; **FLOATING
C1533 a_4157_1313# VSS 0.32875f ; **FLOATING
C1534 a_3449_1395# VSS 0.18629f ; **FLOATING
C1535 a_2873_1395# VSS 0.18349f ; **FLOATING
C1536 a_2297_1395# VSS 0.18349f ; **FLOATING
C1537 a_1721_1395# VSS 0.17029f ; **FLOATING
C1538 a_1544_1044# VSS 0.29829f ; **FLOATING
C1539 a_1256_1044# VSS 0.82974f ; **FLOATING
C1540 a_27671_1842# VSS 0.01336f ; **FLOATING
C1541 a_26911_1842# VSS 0.01336f ; **FLOATING
C1542 a_26151_1842# VSS 0.01336f ; **FLOATING
C1543 a_25391_1842# VSS 0.01336f ; **FLOATING
C1544 a_24631_1842# VSS 0.01336f ; **FLOATING
C1545 a_23871_1842# VSS 0.01336f ; **FLOATING
C1546 a_23111_1842# VSS 0.01336f ; **FLOATING
C1547 a_22351_1842# VSS 0.01336f ; **FLOATING
C1548 a_21591_1842# VSS 0.01336f ; **FLOATING
C1549 a_20831_1842# VSS 0.01336f ; **FLOATING
C1550 a_20071_1842# VSS 0.01336f ; **FLOATING
C1551 a_19311_1842# VSS 0.01336f ; **FLOATING
C1552 a_18551_1842# VSS 0.01336f ; **FLOATING
C1553 a_17791_1842# VSS 0.01336f ; **FLOATING
C1554 a_17031_1842# VSS 0.01336f ; **FLOATING
C1555 a_16271_1842# VSS 0.01336f ; **FLOATING
C1556 a_15511_1842# VSS 0.01336f ; **FLOATING
C1557 a_14751_1842# VSS 0.01336f ; **FLOATING
C1558 a_13991_1842# VSS 0.01336f ; **FLOATING
C1559 a_13231_1842# VSS 0.01336f ; **FLOATING
C1560 a_12471_1842# VSS 0.01336f ; **FLOATING
C1561 a_11711_1842# VSS 0.01336f ; **FLOATING
C1562 a_10951_1842# VSS 0.01336f ; **FLOATING
C1563 a_10191_1842# VSS 0.01336f ; **FLOATING
C1564 a_9431_1842# VSS 0.01336f ; **FLOATING
C1565 a_8671_1842# VSS 0.01336f ; **FLOATING
C1566 a_7911_1842# VSS 0.01336f ; **FLOATING
C1567 a_7151_1842# VSS 0.01336f ; **FLOATING
C1568 a_6391_1842# VSS 0.01336f ; **FLOATING
C1569 a_5631_1842# VSS 0.01336f ; **FLOATING
C1570 a_4871_1842# VSS 0.01336f ; **FLOATING
C1571 a_4111_1842# VSS 0.0139f ; **FLOATING
C1572 a_27563_1842# VSS 0.50316f ; **FLOATING
C1573 a_27997_1842# VSS 0.6484f ; **FLOATING
C1574 a_27433_1842# VSS 0.4463f ; **FLOATING
C1575 a_26803_1842# VSS 0.49934f ; **FLOATING
C1576 a_27237_1842# VSS 0.92967f ; **FLOATING
C1577 a_26673_1842# VSS 0.4492f ; **FLOATING
C1578 a_26043_1842# VSS 0.50169f ; **FLOATING
C1579 a_26477_1842# VSS 0.95928f ; **FLOATING
C1580 a_25913_1842# VSS 0.4508f ; **FLOATING
C1581 a_25283_1842# VSS 0.49938f ; **FLOATING
C1582 a_25717_1842# VSS 0.86841f ; **FLOATING
C1583 a_25153_1842# VSS 0.45035f ; **FLOATING
C1584 a_24523_1842# VSS 0.50075f ; **FLOATING
C1585 a_24957_1842# VSS 0.96341f ; **FLOATING
C1586 a_24393_1842# VSS 0.4463f ; **FLOATING
C1587 a_23763_1842# VSS 0.49934f ; **FLOATING
C1588 a_24197_1842# VSS 0.92543f ; **FLOATING
C1589 a_23633_1842# VSS 0.45062f ; **FLOATING
C1590 a_23003_1842# VSS 0.50169f ; **FLOATING
C1591 a_23437_1842# VSS 0.95769f ; **FLOATING
C1592 a_22873_1842# VSS 0.4508f ; **FLOATING
C1593 a_22243_1842# VSS 0.49938f ; **FLOATING
C1594 a_22677_1842# VSS 0.86841f ; **FLOATING
C1595 a_22113_1842# VSS 0.45249f ; **FLOATING
C1596 a_21483_1842# VSS 0.50075f ; **FLOATING
C1597 a_21917_1842# VSS 0.96341f ; **FLOATING
C1598 a_21353_1842# VSS 0.4463f ; **FLOATING
C1599 a_20723_1842# VSS 0.49992f ; **FLOATING
C1600 a_21157_1842# VSS 0.92543f ; **FLOATING
C1601 a_20593_1842# VSS 0.45196f ; **FLOATING
C1602 a_19963_1842# VSS 0.50169f ; **FLOATING
C1603 a_20397_1842# VSS 0.95769f ; **FLOATING
C1604 a_19833_1842# VSS 0.4508f ; **FLOATING
C1605 a_19203_1842# VSS 0.5005f ; **FLOATING
C1606 a_19637_1842# VSS 0.86841f ; **FLOATING
C1607 a_19073_1842# VSS 0.44947f ; **FLOATING
C1608 a_18443_1842# VSS 0.50075f ; **FLOATING
C1609 a_18877_1842# VSS 0.96341f ; **FLOATING
C1610 a_18313_1842# VSS 0.4463f ; **FLOATING
C1611 a_17683_1842# VSS 0.50046f ; **FLOATING
C1612 a_18117_1842# VSS 0.92543f ; **FLOATING
C1613 a_17553_1842# VSS 0.44782f ; **FLOATING
C1614 a_16923_1842# VSS 0.50165f ; **FLOATING
C1615 a_17357_1842# VSS 0.95769f ; **FLOATING
C1616 a_16793_1842# VSS 0.45049f ; **FLOATING
C1617 a_16163_1842# VSS 0.4946f ; **FLOATING
C1618 a_16597_1842# VSS 0.86359f ; **FLOATING
C1619 a_16033_1842# VSS 0.44618f ; **FLOATING
C1620 a_15403_1842# VSS 0.49465f ; **FLOATING
C1621 a_15837_1842# VSS 0.95171f ; **FLOATING
C1622 a_15273_1842# VSS 0.44439f ; **FLOATING
C1623 a_14643_1842# VSS 0.49305f ; **FLOATING
C1624 a_15077_1842# VSS 0.92116f ; **FLOATING
C1625 a_14513_1842# VSS 0.44501f ; **FLOATING
C1626 a_13883_1842# VSS 0.50862f ; **FLOATING
C1627 a_14317_1842# VSS 0.96009f ; **FLOATING
C1628 a_13753_1842# VSS 0.46427f ; **FLOATING
C1629 a_13123_1842# VSS 0.50173f ; **FLOATING
C1630 a_13557_1842# VSS 0.87587f ; **FLOATING
C1631 a_12993_1842# VSS 0.45643f ; **FLOATING
C1632 a_12363_1842# VSS 0.50854f ; **FLOATING
C1633 a_12797_1842# VSS 0.96142f ; **FLOATING
C1634 a_12233_1842# VSS 0.45757f ; **FLOATING
C1635 a_11603_1842# VSS 0.50267f ; **FLOATING
C1636 a_12037_1842# VSS 0.92866f ; **FLOATING
C1637 a_11473_1842# VSS 0.45177f ; **FLOATING
C1638 a_10843_1842# VSS 0.50491f ; **FLOATING
C1639 a_11277_1842# VSS 0.96053f ; **FLOATING
C1640 a_10713_1842# VSS 0.44901f ; **FLOATING
C1641 a_10083_1842# VSS 0.50223f ; **FLOATING
C1642 a_10517_1842# VSS 0.87053f ; **FLOATING
C1643 a_9953_1842# VSS 0.44673f ; **FLOATING
C1644 a_9323_1842# VSS 0.5026f ; **FLOATING
C1645 a_9757_1842# VSS 0.96312f ; **FLOATING
C1646 a_9193_1842# VSS 0.44361f ; **FLOATING
C1647 a_8563_1842# VSS 0.49203f ; **FLOATING
C1648 a_8997_1842# VSS 0.92196f ; **FLOATING
C1649 a_8433_1842# VSS 0.44439f ; **FLOATING
C1650 a_7803_1842# VSS 0.49435f ; **FLOATING
C1651 a_8237_1842# VSS 0.95422f ; **FLOATING
C1652 a_7673_1842# VSS 0.44737f ; **FLOATING
C1653 a_7043_1842# VSS 0.49204f ; **FLOATING
C1654 a_7477_1842# VSS 0.86493f ; **FLOATING
C1655 a_6913_1842# VSS 0.44442f ; **FLOATING
C1656 a_6283_1842# VSS 0.49343f ; **FLOATING
C1657 a_6717_1842# VSS 0.95763f ; **FLOATING
C1658 a_6153_1842# VSS 0.44292f ; **FLOATING
C1659 a_5523_1842# VSS 0.50322f ; **FLOATING
C1660 a_5957_1842# VSS 0.92646f ; **FLOATING
C1661 a_5393_1842# VSS 0.4596f ; **FLOATING
C1662 a_4763_1842# VSS 0.51043f ; **FLOATING
C1663 a_5197_1842# VSS 0.96509f ; **FLOATING
C1664 a_4633_1842# VSS 0.46282f ; **FLOATING
C1665 a_4003_1842# VSS 0.58808f ; **FLOATING
C1666 a_4437_1842# VSS 0.87628f ; **FLOATING
C1667 a_9712_3912# VSS 1.52086f ; **FLOATING
C1668 a_9444_3912# VSS 2.12877f ; **FLOATING
C1669 a_5778_3367# VSS 5.22809f ; **FLOATING
C1670 a_15464_3684# VSS 0.75391f ; **FLOATING
C1671 a_14757_5182# VSS 0.09495f ; **FLOATING
C1672 a_13880_5118# VSS 0.06985f ; **FLOATING
C1673 a_15688_5403# VSS 0.26291f ; **FLOATING
C1674 a_15108_5325# VSS 0.24458f ; **FLOATING
C1675 a_14851_5182# VSS 0.38123f ; **FLOATING
C1676 a_9444_4590# VSS 6.08222f ; **FLOATING
C1677 a_14111_5227# VSS 0.19866f ; **FLOATING
C1678 a_14009_5084# VSS 0.44622f ; **FLOATING
C1679 a_13592_5423# VSS 1.57456f ; **FLOATING
C1680 a_13306_5105# VSS 0.30095f ; **FLOATING
C1681 a_13566_5328# VSS 0.15441f ; **FLOATING
C1682 a_13132_5420# VSS 0.13036f ; **FLOATING
C1683 a_12907_5420# VSS 0.14377f ; **FLOATING
C1684 a_12907_5186# VSS 0.14861f ; **FLOATING
C1685 a_13106_5357# VSS 0.06343f ; **FLOATING
C1686 a_15304_4605# VSS 0.37009f ; **FLOATING
C1687 a_14757_6228# VSS 0.09586f ; **FLOATING
C1688 a_15688_5867# VSS 0.26405f ; **FLOATING
C1689 a_14851_6228# VSS 0.39588f ; **FLOATING
C1690 a_15108_6109# VSS 0.24582f ; **FLOATING
C1691 a_14111_5878# VSS 0.21915f ; **FLOATING
C1692 a_13880_6292# VSS 0.07345f ; **FLOATING
C1693 a_14009_5878# VSS 0.48187f ; **FLOATING
C1694 a_13592_5871# VSS 1.58208f ; **FLOATING
C1695 a_13566_5835# VSS 0.15442f ; **FLOATING
C1696 a_13045_6215# VSS 0.01124f ; **FLOATING
C1697 a_13306_6305# VSS 0.31701f ; **FLOATING
C1698 a_12849_5867# VSS 1.40248f ; **FLOATING
C1699 a_13121_5831# VSS 0.80439f ; **FLOATING
C1700 a_13019_5831# VSS 2.18715f ; **FLOATING
C1701 a_12656_5864# VSS 0.28393f ; **FLOATING
C1702 a_12355_5867# VSS 0.62262f ; **FLOATING
C1703 a_11397_6228# VSS 0.09495f ; **FLOATING
C1704 a_12158_5867# VSS 0.25874f ; **FLOATING
C1705 a_11491_6228# VSS 0.30073f ; **FLOATING
C1706 a_11748_6109# VSS 0.17021f ; **FLOATING
C1707 a_10751_5878# VSS 0.19918f ; **FLOATING
C1708 a_10520_6292# VSS 0.03671f ; **FLOATING
C1709 a_10649_5878# VSS 0.47308f ; **FLOATING
C1710 a_10232_5871# VSS 1.52123f ; **FLOATING
C1711 a_10206_5835# VSS 0.08466f ; **FLOATING
C1712 a_9946_6305# VSS 0.18126f ; **FLOATING
C1713 a_9772_5843# VSS 0.12435f ; **FLOATING
C1714 a_9746_5805# VSS 0.06613f ; **FLOATING
C1715 a_9547_6172# VSS 0.16037f ; **FLOATING
C1716 a_9547_5942# VSS 0.11966f ; **FLOATING
C1717 a_6854_5454# VSS 3.66026f ; **FLOATING
C1718 a_6126_3816# VSS 13.6177f ; **FLOATING
C1719 a_6854_5986# VSS 1.21519f ; **FLOATING
C1720 a_5974_5723# VSS 2.40124f ; **FLOATING
C1721 a_6326_4590# VSS 1.03474f ; **FLOATING
C1722 a_2019_1047.t2 VSS 0.93027f ; **FLOATING
C1723 a_2019_1047.t3 VSS 0.70623f ; **FLOATING
C1724 a_2019_1047.n0 VSS 5.00884f ; **FLOATING
C1725 a_2019_1047.t4 VSS 0.70623f ; **FLOATING
C1726 a_2019_1047.n1 VSS 3.38862f ; **FLOATING
C1727 a_2019_1047.t5 VSS 0.70623f ; **FLOATING
C1728 a_2019_1047.n2 VSS 3.38862f ; **FLOATING
C1729 a_2019_1047.t6 VSS 0.70623f ; **FLOATING
C1730 a_2019_1047.n3 VSS 3.38862f ; **FLOATING
C1731 a_2019_1047.t7 VSS 0.70623f ; **FLOATING
C1732 a_2019_1047.n4 VSS 3.38862f ; **FLOATING
C1733 a_2019_1047.t8 VSS 0.70623f ; **FLOATING
C1734 a_2019_1047.n5 VSS 3.38862f ; **FLOATING
C1735 a_2019_1047.t9 VSS 5.45485f ; **FLOATING
C1736 a_2019_1047.t1 VSS 1.07257f ; **FLOATING
C1737 a_2019_1047.t0 VSS 0.30486f ; **FLOATING
C1738 a_2595_1047.t2 VSS 1.36703f ; **FLOATING
C1739 a_2595_1047.t3 VSS 1.02094f ; **FLOATING
C1740 a_2595_1047.n0 VSS 7.76123f ; **FLOATING
C1741 a_2595_1047.t4 VSS 1.02094f ; **FLOATING
C1742 a_2595_1047.n1 VSS 5.2734f ; **FLOATING
C1743 a_2595_1047.t5 VSS 1.02094f ; **FLOATING
C1744 a_2595_1047.n2 VSS 5.2734f ; **FLOATING
C1745 a_2595_1047.t6 VSS 1.02094f ; **FLOATING
C1746 a_2595_1047.n3 VSS 5.2734f ; **FLOATING
C1747 a_2595_1047.t7 VSS 1.02094f ; **FLOATING
C1748 a_2595_1047.n4 VSS 5.2734f ; **FLOATING
C1749 a_2595_1047.t8 VSS 1.02094f ; **FLOATING
C1750 a_2595_1047.n5 VSS 5.2734f ; **FLOATING
C1751 a_2595_1047.t9 VSS 1.02094f ; **FLOATING
C1752 a_2595_1047.n6 VSS 7.58547f ; **FLOATING
C1753 a_2595_1047.t1 VSS 1.75119f ; **FLOATING
C1754 a_2595_1047.t0 VSS 0.48227f ; **FLOATING
C1755 a_3171_1047.t2 VSS 1.38443f ; **FLOATING
C1756 a_3171_1047.t3 VSS 1.03734f ; **FLOATING
C1757 a_3171_1047.n0 VSS 7.7786f ; **FLOATING
C1758 a_3171_1047.t4 VSS 1.03734f ; **FLOATING
C1759 a_3171_1047.n1 VSS 5.28085f ; **FLOATING
C1760 a_3171_1047.t5 VSS 1.03734f ; **FLOATING
C1761 a_3171_1047.n2 VSS 5.28085f ; **FLOATING
C1762 a_3171_1047.t6 VSS 1.03734f ; **FLOATING
C1763 a_3171_1047.n3 VSS 5.28085f ; **FLOATING
C1764 a_3171_1047.t7 VSS 1.03734f ; **FLOATING
C1765 a_3171_1047.n4 VSS 5.28085f ; **FLOATING
C1766 a_3171_1047.t8 VSS 1.03734f ; **FLOATING
C1767 a_3171_1047.n5 VSS 5.28085f ; **FLOATING
C1768 a_3171_1047.t9 VSS 1.03734f ; **FLOATING
C1769 a_3171_1047.n6 VSS 7.68351f ; **FLOATING
C1770 a_3171_1047.t1 VSS 1.77027f ; **FLOATING
C1771 a_3171_1047.t0 VSS 0.48084f ; **FLOATING
C1772 a_3747_1047.t2 VSS 0.96887f ; **FLOATING
C1773 a_3747_1047.t3 VSS 0.73761f ; **FLOATING
C1774 a_3747_1047.n0 VSS 5.16757f ; **FLOATING
C1775 a_3747_1047.t4 VSS 0.73761f ; **FLOATING
C1776 a_3747_1047.n1 VSS 3.49321f ; **FLOATING
C1777 a_3747_1047.t5 VSS 0.73761f ; **FLOATING
C1778 a_3747_1047.n2 VSS 3.49321f ; **FLOATING
C1779 a_3747_1047.t6 VSS 0.73761f ; **FLOATING
C1780 a_3747_1047.n3 VSS 3.49321f ; **FLOATING
C1781 a_3747_1047.t7 VSS 0.73761f ; **FLOATING
C1782 a_3747_1047.n4 VSS 3.49321f ; **FLOATING
C1783 a_3747_1047.t8 VSS 0.73761f ; **FLOATING
C1784 a_3747_1047.n5 VSS 3.49321f ; **FLOATING
C1785 a_3747_1047.t9 VSS 0.73761f ; **FLOATING
C1786 a_3747_1047.n6 VSS 5.187f ; **FLOATING
C1787 a_3747_1047.t1 VSS 1.18538f ; **FLOATING
C1788 a_3747_1047.t0 VSS 0.31338f ; **FLOATING
C1789 a_2595_311.t1 VSS 3.27037f ; **FLOATING
C1790 a_2595_311.t2 VSS 5.04145f ; **FLOATING
C1791 a_2595_311.t3 VSS 1.20632f ; **FLOATING
C1792 a_2595_311.n0 VSS 26.8668f ; **FLOATING
C1793 a_2595_311.t0 VSS 0.49572f ; **FLOATING
C1794 a_3171_311.t2 VSS 5.05009f ; **FLOATING
C1795 a_3171_311.t3 VSS 1.21149f ; **FLOATING
C1796 a_3171_311.n0 VSS 29.8499f ; **FLOATING
C1797 a_3171_311.t1 VSS 4.61154f ; **FLOATING
C1798 a_3171_311.t0 VSS 0.4973f ; **FLOATING
C1799 a_3747_311.t2 VSS 3.09203f ; **FLOATING
C1800 a_3747_311.t3 VSS 0.74422f ; **FLOATING
C1801 a_3747_311.n0 VSS 19.8885f ; **FLOATING
C1802 a_3747_311.t1 VSS 3.68893f ; **FLOATING
C1803 a_3747_311.t0 VSS 0.30537f ; **FLOATING
C1804 VSS.t528 VSS 3.22049f ; **FLOATING
C1805 VDD.n0 VSS 0.03677f ; **FLOATING
C1806 VDD.n1 VSS 1.1284f ; **FLOATING
C1807 VDD.n2 VSS 0.03011f ; **FLOATING
C1808 VDD.n3 VSS 0.46891f ; **FLOATING
C1809 VDD.n4 VSS 0.04223f ; **FLOATING
C1810 VDD.t0 VSS 49.9272f ; **FLOATING
C1811 VDD.n5 VSS 0.46891f ; **FLOATING
C1812 VDD.n6 VSS 0.46891f ; **FLOATING
C1813 VDD.n7 VSS 0.04223f ; **FLOATING
C1814 VDD.n8 VSS 0.46891f ; **FLOATING
C1815 VDD.n9 VSS 0.46891f ; **FLOATING
C1816 VDD.n10 VSS 0.46891f ; **FLOATING
C1817 VDD.n11 VSS 0.07686f ; **FLOATING
C1818 VDD.n12 VSS 0.40404f ; **FLOATING
C1819 VDD.n14 VSS 0.36478f ; **FLOATING
C1820 VDD.n16 VSS 0.44734f ; **FLOATING
C1821 VDD.n17 VSS 0.13601f ; **FLOATING
C1822 VDD.n18 VSS 0.44734f ; **FLOATING
C1823 VDD.n19 VSS 0.13601f ; **FLOATING
C1824 VDD.n20 VSS 0.44734f ; **FLOATING
C1825 VDD.n22 VSS 0.44734f ; **FLOATING
C1826 VDD.n23 VSS 0.13601f ; **FLOATING
C1827 VDD.n24 VSS 0.44734f ; **FLOATING
C1828 VDD.n25 VSS 0.13601f ; **FLOATING
C1829 VDD.n26 VSS 0.44734f ; **FLOATING
C1830 VDD.n27 VSS 0.26258f ; **FLOATING
C1831 VDD.n28 VSS 0.22975f ; **FLOATING
C1832 VDD.n30 VSS 1.61338f ; **FLOATING
C1833 VDD.t2 VSS 43.7538f ; **FLOATING
C1834 VDD.n31 VSS 0.06199f ; **FLOATING
C1835 VDD.n32 VSS 0.13601f ; **FLOATING
C1836 VDD.n33 VSS 0.13601f ; **FLOATING
C1837 VDD.n34 VSS 0.03109f ; **FLOATING
C1838 VDD.t148 VSS 0.0187f ; **FLOATING
C1839 VDD.n35 VSS 0.02516f ; **FLOATING
C1840 VDD.n36 VSS 0.07733f ; **FLOATING
C1841 VDD.n37 VSS 0.0214f ; **FLOATING
C1842 VDD.n38 VSS 0.02357f ; **FLOATING
C1843 VDD.n39 VSS 0.01579f ; **FLOATING
C1844 VDD.n40 VSS 0.10231f ; **FLOATING
C1845 VDD.n42 VSS 0.15084f ; **FLOATING
C1846 VDD.n43 VSS 0.01387f ; **FLOATING
C1847 VDD.n44 VSS 0.06543f ; **FLOATING
C1848 VDD.n45 VSS 0.08545f ; **FLOATING
C1849 VDD.n47 VSS 0.08436f ; **FLOATING
C1850 VDD.n48 VSS 0.05911f ; **FLOATING
C1851 VDD.n49 VSS 0.05911f ; **FLOATING
C1852 VDD.n50 VSS 0.08436f ; **FLOATING
C1853 VDD.n51 VSS 0.05911f ; **FLOATING
C1854 VDD.n52 VSS 0.05911f ; **FLOATING
C1855 VDD.n53 VSS 0.08436f ; **FLOATING
C1856 VDD.n54 VSS 0.05911f ; **FLOATING
C1857 VDD.n55 VSS 0.05911f ; **FLOATING
C1858 VDD.n56 VSS 0.0401f ; **FLOATING
C1859 VDD.n57 VSS 0.02073f ; **FLOATING
C1860 VDD.n58 VSS 0.14214f ; **FLOATING
C1861 VDD.n59 VSS 0.0409f ; **FLOATING
C1862 VDD.n60 VSS 0.01023f ; **FLOATING
C1863 VDD.n61 VSS 0.02577f ; **FLOATING
C1864 VDD.n62 VSS 0.03847f ; **FLOATING
C1865 VDD.n63 VSS 0.02115f ; **FLOATING
C1866 VDD.n64 VSS 0.01579f ; **FLOATING
C1867 VDD.n65 VSS 0.10657f ; **FLOATING
C1868 VDD.n66 VSS 0.05152f ; **FLOATING
C1869 VDD.n67 VSS 0.20413f ; **FLOATING
C1870 VDD.n68 VSS 0.05911f ; **FLOATING
C1871 VDD.n69 VSS 0.05622f ; **FLOATING
C1872 VDD.n70 VSS 0.03174f ; **FLOATING
C1873 VDD.n71 VSS 0.01697f ; **FLOATING
C1874 VDD.n72 VSS 0.15122f ; **FLOATING
C1875 VDD.n73 VSS 0.03162f ; **FLOATING
C1876 VDD.n74 VSS 0.03566f ; **FLOATING
C1877 VDD.n75 VSS 0.13358f ; **FLOATING
C1878 VDD.n77 VSS 0.08629f ; **FLOATING
C1879 VDD.n78 VSS 0.13358f ; **FLOATING
C1880 VDD.n79 VSS 0.08629f ; **FLOATING
C1881 VDD.n81 VSS 0.13358f ; **FLOATING
C1882 VDD.n82 VSS 0.08629f ; **FLOATING
C1883 VDD.n84 VSS 0.02633f ; **FLOATING
C1884 VDD.n85 VSS 0.09631f ; **FLOATING
C1885 VDD.n86 VSS 0.13358f ; **FLOATING
C1886 VDD.n87 VSS 0.08629f ; **FLOATING
C1887 VDD.n89 VSS 0.13358f ; **FLOATING
C1888 VDD.n90 VSS 0.08629f ; **FLOATING
C1889 VDD.n92 VSS 0.13358f ; **FLOATING
C1890 VDD.n93 VSS 0.08629f ; **FLOATING
C1891 VDD.n95 VSS 0.08436f ; **FLOATING
C1892 VDD.n96 VSS 0.08436f ; **FLOATING
C1893 VDD.n97 VSS 0.08436f ; **FLOATING
C1894 VDD.n98 VSS 0.03062f ; **FLOATING
C1895 VDD.n99 VSS 0.01587f ; **FLOATING
C1896 VDD.n100 VSS 0.1004f ; **FLOATING
C1897 VDD.n101 VSS 0.04223f ; **FLOATING
C1898 VDD.n102 VSS 0.04223f ; **FLOATING
C1899 VDD.n103 VSS 0.04223f ; **FLOATING
C1900 VDD.n104 VSS 0.04223f ; **FLOATING
C1901 VDD.n105 VSS 0.13178f ; **FLOATING
C1902 VDD.t7 VSS 8.27061f ; **FLOATING
C1903 VDD.t172 VSS 0.03686f ; **FLOATING
C1904 VDD.t293 VSS 0.03686f ; **FLOATING
C1905 VDD.n106 VSS 0.12582f ; **FLOATING
C1906 VDD.n107 VSS 0.01589f ; **FLOATING
C1907 VDD.t342 VSS 0.04458f ; **FLOATING
C1908 VDD.t375 VSS 0.04458f ; **FLOATING
C1909 VDD.n108 VSS 0.14195f ; **FLOATING
C1910 VDD.n109 VSS 0.07513f ; **FLOATING
C1911 VDD.t146 VSS 0.03178f ; **FLOATING
C1912 VDD.n110 VSS 0.02157f ; **FLOATING
C1913 VDD.t145 VSS 0.02294f ; **FLOATING
C1914 VDD.t147 VSS 0.03552f ; **FLOATING
C1915 VDD.t149 VSS 0.03178f ; **FLOATING
C1916 VDD.t312 VSS 0.03178f ; **FLOATING
C1917 VDD.t151 VSS 0.03178f ; **FLOATING
C1918 VDD.n111 VSS 0.02157f ; **FLOATING
C1919 VDD.t150 VSS 0.02294f ; **FLOATING
C1920 VDD.t152 VSS 0.03552f ; **FLOATING
C1921 VDD.n112 VSS 0.01805f ; **FLOATING
C1922 VDD.t153 VSS 0.01871f ; **FLOATING
C1923 VDD.t154 VSS 0.03178f ; **FLOATING
C1924 VDD.n113 VSS 0.01895f ; **FLOATING
C1925 VDD.t369 VSS 0.03489f ; **FLOATING
C1926 VDD.t168 VSS 0.02373f ; **FLOATING
C1927 VDD.n114 VSS 0.11939f ; **FLOATING
C1928 VDD.t50 VSS 3.33549f ; **FLOATING
C1929 VDD.n115 VSS 0.64947f ; **FLOATING
C1930 VDD.n116 VSS 0.11552f ; **FLOATING
C1931 VDD.n117 VSS 0.02729f ; **FLOATING
C1932 VDD.t217 VSS 0.02621f ; **FLOATING
C1933 VDD.t221 VSS 0.02621f ; **FLOATING
C1934 VDD.n118 VSS 0.07782f ; **FLOATING
C1935 VDD.n119 VSS 0.03693f ; **FLOATING
C1936 VDD.t127 VSS 0.01216f ; **FLOATING
C1937 VDD.t59 VSS 0.06048f ; **FLOATING
C1938 VDD.n120 VSS 0.0245f ; **FLOATING
C1939 VDD.t126 VSS 0.01216f ; **FLOATING
C1940 VDD.t120 VSS 0.06048f ; **FLOATING
C1941 VDD.n121 VSS 0.0245f ; **FLOATING
C1942 VDD.n122 VSS 0.05408f ; **FLOATING
C1943 VDD.n123 VSS 0.01438f ; **FLOATING
C1944 VDD.t49 VSS 0.03563f ; **FLOATING
C1945 VDD.n124 VSS 0.06406f ; **FLOATING
C1946 VDD.n125 VSS 0.03523f ; **FLOATING
C1947 VDD.t166 VSS 0.0329f ; **FLOATING
C1948 VDD.n126 VSS 0.07634f ; **FLOATING
C1949 VDD.n127 VSS 0.02009f ; **FLOATING
C1950 VDD.t129 VSS 0.03686f ; **FLOATING
C1951 VDD.n128 VSS 0.16471f ; **FLOATING
C1952 VDD.t264 VSS 0.01216f ; **FLOATING
C1953 VDD.t170 VSS 0.06048f ; **FLOATING
C1954 VDD.n129 VSS 0.0245f ; **FLOATING
C1955 VDD.n130 VSS 0.07372f ; **FLOATING
C1956 VDD.t169 VSS 0.02621f ; **FLOATING
C1957 VDD.n131 VSS 0.14752f ; **FLOATING
C1958 VDD.n132 VSS 0.03695f ; **FLOATING
C1959 VDD.n133 VSS 0.01473f ; **FLOATING
C1960 VDD.n134 VSS 0.07152f ; **FLOATING
C1961 VDD.n135 VSS 0.71808f ; **FLOATING
C1962 VDD.t335 VSS 0.0329f ; **FLOATING
C1963 VDD.t103 VSS 0.0329f ; **FLOATING
C1964 VDD.t96 VSS 0.02954f ; **FLOATING
C1965 VDD.t61 VSS 0.0329f ; **FLOATING
C1966 VDD.n136 VSS 0.02717f ; **FLOATING
C1967 VDD.t171 VSS 0.04318f ; **FLOATING
C1968 VDD.n137 VSS 0.08282f ; **FLOATING
C1969 VDD.n138 VSS 0.02423f ; **FLOATING
C1970 VDD.t93 VSS 0.0329f ; **FLOATING
C1971 VDD.n139 VSS 0.07852f ; **FLOATING
C1972 VDD.n140 VSS 0.01153f ; **FLOATING
C1973 VDD.t9 VSS 0.03667f ; **FLOATING
C1974 VDD.t246 VSS 0.03667f ; **FLOATING
C1975 VDD.t352 VSS 0.03667f ; **FLOATING
C1976 VDD.t118 VSS 0.03667f ; **FLOATING
C1977 VDD.t338 VSS 0.0329f ; **FLOATING
C1978 VDD.t57 VSS 0.0329f ; **FLOATING
C1979 VDD.n141 VSS 0.09517f ; **FLOATING
C1980 VDD.n142 VSS 0.01506f ; **FLOATING
C1981 VDD.t132 VSS 0.0243f ; **FLOATING
C1982 VDD.t77 VSS 0.0243f ; **FLOATING
C1983 VDD.n143 VSS 0.08391f ; **FLOATING
C1984 VDD.t125 VSS 0.03248f ; **FLOATING
C1985 VDD.t117 VSS 0.03248f ; **FLOATING
C1986 VDD.t334 VSS 0.0243f ; **FLOATING
C1987 VDD.t105 VSS 0.0243f ; **FLOATING
C1988 VDD.t8 VSS 0.03248f ; **FLOATING
C1989 VDD.t245 VSS 0.03248f ; **FLOATING
C1990 VDD.t337 VSS 0.0243f ; **FLOATING
C1991 VDD.t56 VSS 0.0243f ; **FLOATING
C1992 VDD.t91 VSS 0.03248f ; **FLOATING
C1993 VDD.t78 VSS 0.03248f ; **FLOATING
C1994 VDD.n144 VSS 0.07665f ; **FLOATING
C1995 VDD.t92 VSS 0.03667f ; **FLOATING
C1996 VDD.t176 VSS 0.03667f ; **FLOATING
C1997 VDD.t336 VSS 0.0243f ; **FLOATING
C1998 VDD.t104 VSS 0.0243f ; **FLOATING
C1999 VDD.t278 VSS 0.03248f ; **FLOATING
C2000 VDD.t10 VSS 0.03248f ; **FLOATING
C2001 VDD.n145 VSS 0.06967f ; **FLOATING
C2002 VDD.t279 VSS 0.03667f ; **FLOATING
C2003 VDD.t11 VSS 0.03667f ; **FLOATING
C2004 VDD.n146 VSS 0.08757f ; **FLOATING
C2005 VDD.n147 VSS 0.01175f ; **FLOATING
C2006 VDD.t60 VSS 0.0329f ; **FLOATING
C2007 VDD.t266 VSS 0.03301f ; **FLOATING
C2008 VDD.t66 VSS 0.0329f ; **FLOATING
C2009 VDD.n148 VSS 0.06893f ; **FLOATING
C2010 VDD.n149 VSS 0.01294f ; **FLOATING
C2011 VDD.t215 VSS 0.0329f ; **FLOATING
C2012 VDD.t177 VSS 0.0329f ; **FLOATING
C2013 VDD.t185 VSS 0.0329f ; **FLOATING
C2014 VDD.t82 VSS 0.02954f ; **FLOATING
C2015 VDD.t130 VSS 0.02954f ; **FLOATING
C2016 VDD.t44 VSS 0.0329f ; **FLOATING
C2017 VDD.t409 VSS 0.10912f ; **FLOATING
C2018 VDD.t81 VSS 0.03171f ; **FLOATING
C2019 VDD.t364 VSS 0.04318f ; **FLOATING
C2020 VDD.t408 VSS 0.10912f ; **FLOATING
C2021 VDD.t85 VSS 0.03171f ; **FLOATING
C2022 VDD.t12 VSS 0.0329f ; **FLOATING
C2023 VDD.t86 VSS 0.02954f ; **FLOATING
C2024 VDD.t87 VSS 0.02954f ; **FLOATING
C2025 VDD.t90 VSS 0.02954f ; **FLOATING
C2026 VDD.t239 VSS 0.0329f ; **FLOATING
C2027 VDD.t389 VSS 0.0329f ; **FLOATING
C2028 VDD.t114 VSS 0.0329f ; **FLOATING
C2029 VDD.t71 VSS 0.0329f ; **FLOATING
C2030 VDD.t195 VSS 0.02954f ; **FLOATING
C2031 VDD.t53 VSS 0.04318f ; **FLOATING
C2032 VDD.t73 VSS 0.0329f ; **FLOATING
C2033 VDD.t236 VSS 0.02954f ; **FLOATING
C2034 VDD.t74 VSS 0.0329f ; **FLOATING
C2035 VDD.t359 VSS 0.02954f ; **FLOATING
C2036 VDD.t13 VSS 0.0329f ; **FLOATING
C2037 VDD.t98 VSS 0.02954f ; **FLOATING
C2038 VDD.t99 VSS 0.02954f ; **FLOATING
C2039 VDD.t83 VSS 0.04334f ; **FLOATING
C2040 VDD.t45 VSS 0.0329f ; **FLOATING
C2041 VDD.t102 VSS 0.02954f ; **FLOATING
C2042 VDD.t76 VSS 0.0329f ; **FLOATING
C2043 VDD.t113 VSS 0.0329f ; **FLOATING
C2044 VDD.t72 VSS 0.0329f ; **FLOATING
C2045 VDD.t212 VSS 0.02954f ; **FLOATING
C2046 VDD.t357 VSS 0.04318f ; **FLOATING
C2047 VDD.t193 VSS 0.02954f ; **FLOATING
C2048 VDD.t69 VSS 0.0329f ; **FLOATING
C2049 VDD.t94 VSS 0.02954f ; **FLOATING
C2050 VDD.t199 VSS 0.0329f ; **FLOATING
C2051 VDD.t240 VSS 0.0329f ; **FLOATING
C2052 VDD.t207 VSS 0.02954f ; **FLOATING
C2053 VDD.t208 VSS 0.02954f ; **FLOATING
C2054 VDD.t211 VSS 0.02954f ; **FLOATING
C2055 VDD.t242 VSS 0.0329f ; **FLOATING
C2056 VDD.t123 VSS 0.0329f ; **FLOATING
C2057 VDD.t119 VSS 0.0329f ; **FLOATING
C2058 VDD.t355 VSS 0.0329f ; **FLOATING
C2059 VDD.t190 VSS 0.04318f ; **FLOATING
C2060 VDD.t290 VSS 0.0329f ; **FLOATING
C2061 VDD.t253 VSS 0.0329f ; **FLOATING
C2062 VDD.t183 VSS 0.0329f ; **FLOATING
C2063 VDD.t213 VSS 0.0329f ; **FLOATING
C2064 VDD.t251 VSS 0.03493f ; **FLOATING
C2065 VDD.t41 VSS 0.04318f ; **FLOATING
C2066 VDD.t252 VSS 0.06169f ; **FLOATING
C2067 VDD.t238 VSS 0.0329f ; **FLOATING
C2068 VDD.t387 VSS 0.0329f ; **FLOATING
C2069 VDD.t178 VSS 0.0329f ; **FLOATING
C2070 VDD.t182 VSS 0.0329f ; **FLOATING
C2071 VDD.t204 VSS 0.02954f ; **FLOATING
C2072 VDD.t107 VSS 0.04318f ; **FLOATING
C2073 VDD.t292 VSS 0.0329f ; **FLOATING
C2074 VDD.t227 VSS 0.02954f ; **FLOATING
C2075 VDD.t333 VSS 0.0329f ; **FLOATING
C2076 VDD.t180 VSS 0.02954f ; **FLOATING
C2077 VDD.t38 VSS 0.0329f ; **FLOATING
C2078 VDD.t256 VSS 0.02954f ; **FLOATING
C2079 VDD.t257 VSS 0.02954f ; **FLOATING
C2080 VDD.t184 VSS 0.04334f ; **FLOATING
C2081 VDD.t347 VSS 0.0329f ; **FLOATING
C2082 VDD.t260 VSS 0.02954f ; **FLOATING
C2083 VDD.t379 VSS 0.0329f ; **FLOATING
C2084 VDD.t115 VSS 0.0329f ; **FLOATING
C2085 VDD.t222 VSS 0.0329f ; **FLOATING
C2086 VDD.t374 VSS 0.02954f ; **FLOATING
C2087 VDD.t174 VSS 0.04318f ; **FLOATING
C2088 VDD.t63 VSS 0.02954f ; **FLOATING
C2089 VDD.t70 VSS 0.0329f ; **FLOATING
C2090 VDD.t64 VSS 0.02954f ; **FLOATING
C2091 VDD.t40 VSS 0.0329f ; **FLOATING
C2092 VDD.t241 VSS 0.0329f ; **FLOATING
C2093 VDD.t230 VSS 0.02954f ; **FLOATING
C2094 VDD.t231 VSS 0.02954f ; **FLOATING
C2095 VDD.t234 VSS 0.02954f ; **FLOATING
C2096 VDD.t243 VSS 0.0329f ; **FLOATING
C2097 VDD.t250 VSS 0.0329f ; **FLOATING
C2098 VDD.t58 VSS 0.0329f ; **FLOATING
C2099 VDD.t356 VSS 0.0329f ; **FLOATING
C2100 VDD.t67 VSS 0.02954f ; **FLOATING
C2101 VDD.t80 VSS 0.04318f ; **FLOATING
C2102 VDD.t291 VSS 0.0329f ; **FLOATING
C2103 VDD.t225 VSS 0.02954f ; **FLOATING
C2104 VDD.t365 VSS 0.0329f ; **FLOATING
C2105 VDD.t237 VSS 0.02954f ; **FLOATING
C2106 VDD.t112 VSS 0.0329f ; **FLOATING
C2107 VDD.t15 VSS 0.02954f ; **FLOATING
C2108 VDD.t16 VSS 0.02954f ; **FLOATING
C2109 VDD.t340 VSS 0.04334f ; **FLOATING
C2110 VDD.t48 VSS 0.0329f ; **FLOATING
C2111 VDD.t19 VSS 0.02954f ; **FLOATING
C2112 VDD.t20 VSS 0.0329f ; **FLOATING
C2113 VDD.t116 VSS 0.0329f ; **FLOATING
C2114 VDD.t228 VSS 0.0329f ; **FLOATING
C2115 VDD.t173 VSS 0.04318f ; **FLOATING
C2116 VDD.t186 VSS 0.03956f ; **FLOATING
C2117 VDD.t392 VSS 0.10912f ; **FLOATING
C2118 VDD.t17 VSS 0.03171f ; **FLOATING
C2119 VDD.t393 VSS 0.10912f ; **FLOATING
C2120 VDD.t14 VSS 0.03171f ; **FLOATING
C2121 VDD.t394 VSS 0.10912f ; **FLOATING
C2122 VDD.t68 VSS 0.03171f ; **FLOATING
C2123 VDD.t354 VSS 0.04334f ; **FLOATING
C2124 VDD.t395 VSS 0.10912f ; **FLOATING
C2125 VDD.t232 VSS 0.03171f ; **FLOATING
C2126 VDD.t396 VSS 0.10912f ; **FLOATING
C2127 VDD.t65 VSS 0.03171f ; **FLOATING
C2128 VDD.t397 VSS 0.10912f ; **FLOATING
C2129 VDD.t62 VSS 0.03171f ; **FLOATING
C2130 VDD.t398 VSS 0.10912f ; **FLOATING
C2131 VDD.t258 VSS 0.03171f ; **FLOATING
C2132 VDD.t399 VSS 0.10912f ; **FLOATING
C2133 VDD.t181 VSS 0.03171f ; **FLOATING
C2134 VDD.t400 VSS 0.10912f ; **FLOATING
C2135 VDD.t205 VSS 0.03171f ; **FLOATING
C2136 VDD.n150 VSS 0.06199f ; **FLOATING
C2137 VDD.n151 VSS 0.01294f ; **FLOATING
C2138 VDD.n152 VSS 0.07329f ; **FLOATING
C2139 VDD.n153 VSS 0.0111f ; **FLOATING
C2140 VDD.n154 VSS 0.06465f ; **FLOATING
C2141 VDD.n155 VSS 0.01294f ; **FLOATING
C2142 VDD.n156 VSS 0.07973f ; **FLOATING
C2143 VDD.t1 VSS 0.04334f ; **FLOATING
C2144 VDD.t401 VSS 0.10912f ; **FLOATING
C2145 VDD.t209 VSS 0.03171f ; **FLOATING
C2146 VDD.t402 VSS 0.10912f ; **FLOATING
C2147 VDD.t95 VSS 0.03171f ; **FLOATING
C2148 VDD.t403 VSS 0.10912f ; **FLOATING
C2149 VDD.t192 VSS 0.03171f ; **FLOATING
C2150 VDD.t404 VSS 0.10912f ; **FLOATING
C2151 VDD.t100 VSS 0.03171f ; **FLOATING
C2152 VDD.t405 VSS 0.10912f ; **FLOATING
C2153 VDD.t97 VSS 0.03171f ; **FLOATING
C2154 VDD.t406 VSS 0.10912f ; **FLOATING
C2155 VDD.t196 VSS 0.03171f ; **FLOATING
C2156 VDD.t223 VSS 0.04334f ; **FLOATING
C2157 VDD.t407 VSS 0.10912f ; **FLOATING
C2158 VDD.t88 VSS 0.03171f ; **FLOATING
C2159 VDD.t160 VSS 0.06667f ; **FLOATING
C2160 VDD.n157 VSS 0.04824f ; **FLOATING
C2161 VDD.n158 VSS 0.04832f ; **FLOATING
C2162 VDD.n159 VSS 0.04824f ; **FLOATING
C2163 VDD.n160 VSS 0.04824f ; **FLOATING
C2164 VDD.n161 VSS 0.04832f ; **FLOATING
C2165 VDD.n162 VSS 0.04824f ; **FLOATING
C2166 VDD.n163 VSS 0.04824f ; **FLOATING
C2167 VDD.n164 VSS 0.04824f ; **FLOATING
C2168 VDD.n165 VSS 0.04832f ; **FLOATING
C2169 VDD.n166 VSS 0.04824f ; **FLOATING
C2170 VDD.n167 VSS 0.04832f ; **FLOATING
C2171 VDD.n168 VSS 0.04824f ; **FLOATING
C2172 VDD.n169 VSS 0.04824f ; **FLOATING
C2173 VDD.n170 VSS 0.04824f ; **FLOATING
C2174 VDD.n171 VSS 0.04824f ; **FLOATING
C2175 VDD.n172 VSS 0.04824f ; **FLOATING
C2176 VDD.n173 VSS 0.04824f ; **FLOATING
C2177 VDD.n174 VSS 0.04824f ; **FLOATING
C2178 VDD.n175 VSS 0.04824f ; **FLOATING
C2179 VDD.n176 VSS 0.04824f ; **FLOATING
C2180 VDD.n177 VSS 0.04832f ; **FLOATING
C2181 VDD.n178 VSS 0.04832f ; **FLOATING
C2182 VDD.n179 VSS 0.04832f ; **FLOATING
C2183 VDD.n180 VSS 0.04824f ; **FLOATING
C2184 VDD.n181 VSS 0.04824f ; **FLOATING
C2185 VDD.n182 VSS 0.04824f ; **FLOATING
C2186 VDD.n183 VSS 0.04832f ; **FLOATING
C2187 VDD.n184 VSS 0.04824f ; **FLOATING
C2188 VDD.n185 VSS 0.04832f ; **FLOATING
C2189 VDD.n186 VSS 0.04832f ; **FLOATING
C2190 VDD.n187 VSS 0.04832f ; **FLOATING
C2191 VDD.t156 VSS 0.03229f ; **FLOATING
C2192 VDD.t155 VSS 0.02303f ; **FLOATING
C2193 VDD.t159 VSS 0.03215f ; **FLOATING
C2194 VDD.t157 VSS 0.03552f ; **FLOATING
C2195 VDD.t158 VSS 0.01869f ; **FLOATING
C2196 VDD.t306 VSS 0.03178f ; **FLOATING
C2197 VDD.n188 VSS 0.09621f ; **FLOATING
C2198 VDD.n189 VSS 0.02357f ; **FLOATING
C2199 VDD.n190 VSS 0.07474f ; **FLOATING
C2200 VDD.n191 VSS 0.01381f ; **FLOATING
C2201 VDD.t350 VSS 0.03727f ; **FLOATING
C2202 VDD.n192 VSS 0.07758f ; **FLOATING
C2203 VDD.n193 VSS 0.03405f ; **FLOATING
C2204 VDD.t313 VSS 0.03178f ; **FLOATING
C2205 VDD.n194 VSS 0.10441f ; **FLOATING
C2206 VDD.n195 VSS 0.02357f ; **FLOATING
C2207 VDD.n196 VSS 0.05908f ; **FLOATING
C2208 VDD.n197 VSS 0.01381f ; **FLOATING
C2209 VDD.t5 VSS 0.03727f ; **FLOATING
C2210 VDD.n198 VSS 0.0776f ; **FLOATING
C2211 VDD.n199 VSS 0.03401f ; **FLOATING
C2212 VDD.t311 VSS 0.03178f ; **FLOATING
C2213 VDD.n200 VSS 0.10441f ; **FLOATING
C2214 VDD.n201 VSS 0.02357f ; **FLOATING
C2215 VDD.n202 VSS 0.05909f ; **FLOATING
C2216 VDD.n203 VSS 0.01381f ; **FLOATING
C2217 VDD.t191 VSS 0.03727f ; **FLOATING
C2218 VDD.n204 VSS 0.0776f ; **FLOATING
C2219 VDD.n205 VSS 0.03401f ; **FLOATING
C2220 VDD.t301 VSS 0.03178f ; **FLOATING
C2221 VDD.n206 VSS 0.10444f ; **FLOATING
C2222 VDD.n207 VSS 0.02357f ; **FLOATING
C2223 VDD.n208 VSS 0.05909f ; **FLOATING
C2224 VDD.n209 VSS 0.01381f ; **FLOATING
C2225 VDD.t43 VSS 0.03727f ; **FLOATING
C2226 VDD.n210 VSS 0.07758f ; **FLOATING
C2227 VDD.n211 VSS 0.03408f ; **FLOATING
C2228 VDD.t314 VSS 0.03178f ; **FLOATING
C2229 VDD.n212 VSS 0.10447f ; **FLOATING
C2230 VDD.n213 VSS 0.02357f ; **FLOATING
C2231 VDD.n214 VSS 0.05905f ; **FLOATING
C2232 VDD.n215 VSS 0.01381f ; **FLOATING
C2233 VDD.t272 VSS 0.03727f ; **FLOATING
C2234 VDD.n216 VSS 0.07761f ; **FLOATING
C2235 VDD.n217 VSS 0.03397f ; **FLOATING
C2236 VDD.t310 VSS 0.03178f ; **FLOATING
C2237 VDD.n218 VSS 0.10444f ; **FLOATING
C2238 VDD.n219 VSS 0.02357f ; **FLOATING
C2239 VDD.n220 VSS 0.05912f ; **FLOATING
C2240 VDD.n221 VSS 0.01381f ; **FLOATING
C2241 VDD.t286 VSS 0.03727f ; **FLOATING
C2242 VDD.n222 VSS 0.07761f ; **FLOATING
C2243 VDD.n223 VSS 0.03402f ; **FLOATING
C2244 VDD.t317 VSS 0.03178f ; **FLOATING
C2245 VDD.n224 VSS 0.1045f ; **FLOATING
C2246 VDD.n225 VSS 0.02357f ; **FLOATING
C2247 VDD.n226 VSS 0.05906f ; **FLOATING
C2248 VDD.n227 VSS 0.0138f ; **FLOATING
C2249 VDD.t52 VSS 0.03727f ; **FLOATING
C2250 VDD.n228 VSS 0.07761f ; **FLOATING
C2251 VDD.n229 VSS 0.03408f ; **FLOATING
C2252 VDD.t319 VSS 0.03178f ; **FLOATING
C2253 VDD.n230 VSS 0.1045f ; **FLOATING
C2254 VDD.n231 VSS 0.02357f ; **FLOATING
C2255 VDD.n232 VSS 0.05905f ; **FLOATING
C2256 VDD.n233 VSS 0.01381f ; **FLOATING
C2257 VDD.t75 VSS 0.03727f ; **FLOATING
C2258 VDD.n234 VSS 0.07761f ; **FLOATING
C2259 VDD.n235 VSS 0.03397f ; **FLOATING
C2260 VDD.t307 VSS 0.03178f ; **FLOATING
C2261 VDD.n236 VSS 0.10447f ; **FLOATING
C2262 VDD.n237 VSS 0.02357f ; **FLOATING
C2263 VDD.n238 VSS 0.05912f ; **FLOATING
C2264 VDD.n239 VSS 0.01381f ; **FLOATING
C2265 VDD.t84 VSS 0.03727f ; **FLOATING
C2266 VDD.n240 VSS 0.07763f ; **FLOATING
C2267 VDD.n241 VSS 0.03398f ; **FLOATING
C2268 VDD.t299 VSS 0.03178f ; **FLOATING
C2269 VDD.n242 VSS 0.10441f ; **FLOATING
C2270 VDD.n243 VSS 0.02357f ; **FLOATING
C2271 VDD.n244 VSS 0.0591f ; **FLOATING
C2272 VDD.n245 VSS 0.01381f ; **FLOATING
C2273 VDD.t46 VSS 0.03727f ; **FLOATING
C2274 VDD.n246 VSS 0.0776f ; **FLOATING
C2275 VDD.n247 VSS 0.03401f ; **FLOATING
C2276 VDD.t321 VSS 0.03178f ; **FLOATING
C2277 VDD.n248 VSS 0.10441f ; **FLOATING
C2278 VDD.n249 VSS 0.02357f ; **FLOATING
C2279 VDD.n250 VSS 0.05909f ; **FLOATING
C2280 VDD.n251 VSS 0.01381f ; **FLOATING
C2281 VDD.t358 VSS 0.03727f ; **FLOATING
C2282 VDD.n252 VSS 0.07762f ; **FLOATING
C2283 VDD.n253 VSS 0.034f ; **FLOATING
C2284 VDD.t320 VSS 0.03178f ; **FLOATING
C2285 VDD.n254 VSS 0.10444f ; **FLOATING
C2286 VDD.n255 VSS 0.02357f ; **FLOATING
C2287 VDD.n256 VSS 0.05908f ; **FLOATING
C2288 VDD.n257 VSS 0.01381f ; **FLOATING
C2289 VDD.t197 VSS 0.03727f ; **FLOATING
C2290 VDD.n258 VSS 0.07761f ; **FLOATING
C2291 VDD.n259 VSS 0.03397f ; **FLOATING
C2292 VDD.t318 VSS 0.03178f ; **FLOATING
C2293 VDD.n260 VSS 0.1045f ; **FLOATING
C2294 VDD.n261 VSS 0.02357f ; **FLOATING
C2295 VDD.n262 VSS 0.05912f ; **FLOATING
C2296 VDD.n263 VSS 0.01381f ; **FLOATING
C2297 VDD.t4 VSS 0.03727f ; **FLOATING
C2298 VDD.n264 VSS 0.0776f ; **FLOATING
C2299 VDD.n265 VSS 0.03401f ; **FLOATING
C2300 VDD.t315 VSS 0.03178f ; **FLOATING
C2301 VDD.n266 VSS 0.1045f ; **FLOATING
C2302 VDD.n267 VSS 0.02357f ; **FLOATING
C2303 VDD.n268 VSS 0.05909f ; **FLOATING
C2304 VDD.n269 VSS 0.01381f ; **FLOATING
C2305 VDD.t111 VSS 0.03727f ; **FLOATING
C2306 VDD.n270 VSS 0.0776f ; **FLOATING
C2307 VDD.n271 VSS 0.03403f ; **FLOATING
C2308 VDD.t322 VSS 0.03178f ; **FLOATING
C2309 VDD.n272 VSS 0.1045f ; **FLOATING
C2310 VDD.n273 VSS 0.02357f ; **FLOATING
C2311 VDD.n274 VSS 0.05908f ; **FLOATING
C2312 VDD.n275 VSS 0.01381f ; **FLOATING
C2313 VDD.t277 VSS 0.03727f ; **FLOATING
C2314 VDD.n276 VSS 0.07759f ; **FLOATING
C2315 VDD.n277 VSS 0.03403f ; **FLOATING
C2316 VDD.t305 VSS 0.03178f ; **FLOATING
C2317 VDD.n278 VSS 0.1045f ; **FLOATING
C2318 VDD.n279 VSS 0.02357f ; **FLOATING
C2319 VDD.n280 VSS 0.05909f ; **FLOATING
C2320 VDD.n281 VSS 0.01381f ; **FLOATING
C2321 VDD.t254 VSS 0.03727f ; **FLOATING
C2322 VDD.n282 VSS 0.0776f ; **FLOATING
C2323 VDD.n283 VSS 0.03401f ; **FLOATING
C2324 VDD.t304 VSS 0.03178f ; **FLOATING
C2325 VDD.n284 VSS 0.1045f ; **FLOATING
C2326 VDD.n285 VSS 0.02357f ; **FLOATING
C2327 VDD.n286 VSS 0.05908f ; **FLOATING
C2328 VDD.n287 VSS 0.0138f ; **FLOATING
C2329 VDD.t109 VSS 0.03727f ; **FLOATING
C2330 VDD.n288 VSS 0.07763f ; **FLOATING
C2331 VDD.n289 VSS 0.03404f ; **FLOATING
C2332 VDD.t303 VSS 0.03178f ; **FLOATING
C2333 VDD.n290 VSS 0.1045f ; **FLOATING
C2334 VDD.n291 VSS 0.02357f ; **FLOATING
C2335 VDD.n292 VSS 0.05905f ; **FLOATING
C2336 VDD.n293 VSS 0.0138f ; **FLOATING
C2337 VDD.t203 VSS 0.03727f ; **FLOATING
C2338 VDD.n294 VSS 0.07763f ; **FLOATING
C2339 VDD.n295 VSS 0.03401f ; **FLOATING
C2340 VDD.t300 VSS 0.03178f ; **FLOATING
C2341 VDD.n296 VSS 0.1045f ; **FLOATING
C2342 VDD.n297 VSS 0.02357f ; **FLOATING
C2343 VDD.n298 VSS 0.05909f ; **FLOATING
C2344 VDD.n299 VSS 0.01381f ; **FLOATING
C2345 VDD.t179 VSS 0.03727f ; **FLOATING
C2346 VDD.n300 VSS 0.0776f ; **FLOATING
C2347 VDD.n301 VSS 0.03401f ; **FLOATING
C2348 VDD.t323 VSS 0.03178f ; **FLOATING
C2349 VDD.n302 VSS 0.1045f ; **FLOATING
C2350 VDD.n303 VSS 0.02357f ; **FLOATING
C2351 VDD.n304 VSS 0.05908f ; **FLOATING
C2352 VDD.n305 VSS 0.0138f ; **FLOATING
C2353 VDD.t54 VSS 0.03727f ; **FLOATING
C2354 VDD.n306 VSS 0.07763f ; **FLOATING
C2355 VDD.n307 VSS 0.03401f ; **FLOATING
C2356 VDD.t316 VSS 0.03178f ; **FLOATING
C2357 VDD.n308 VSS 0.10447f ; **FLOATING
C2358 VDD.n309 VSS 0.02357f ; **FLOATING
C2359 VDD.n310 VSS 0.05909f ; **FLOATING
C2360 VDD.n311 VSS 0.01381f ; **FLOATING
C2361 VDD.t289 VSS 0.03727f ; **FLOATING
C2362 VDD.n312 VSS 0.07761f ; **FLOATING
C2363 VDD.n313 VSS 0.03397f ; **FLOATING
C2364 VDD.t298 VSS 0.03178f ; **FLOATING
C2365 VDD.n314 VSS 0.10444f ; **FLOATING
C2366 VDD.n315 VSS 0.02357f ; **FLOATING
C2367 VDD.n316 VSS 0.05913f ; **FLOATING
C2368 VDD.n317 VSS 0.01381f ; **FLOATING
C2369 VDD.t265 VSS 0.03727f ; **FLOATING
C2370 VDD.n318 VSS 0.07761f ; **FLOATING
C2371 VDD.n319 VSS 0.03397f ; **FLOATING
C2372 VDD.t309 VSS 0.03178f ; **FLOATING
C2373 VDD.n320 VSS 0.10447f ; **FLOATING
C2374 VDD.n321 VSS 0.02357f ; **FLOATING
C2375 VDD.n322 VSS 0.05913f ; **FLOATING
C2376 VDD.n323 VSS 0.01381f ; **FLOATING
C2377 VDD.t201 VSS 0.03727f ; **FLOATING
C2378 VDD.n324 VSS 0.07761f ; **FLOATING
C2379 VDD.n325 VSS 0.03397f ; **FLOATING
C2380 VDD.t326 VSS 0.03178f ; **FLOATING
C2381 VDD.n326 VSS 0.10444f ; **FLOATING
C2382 VDD.n327 VSS 0.02357f ; **FLOATING
C2383 VDD.n328 VSS 0.05912f ; **FLOATING
C2384 VDD.n329 VSS 0.01381f ; **FLOATING
C2385 VDD.t39 VSS 0.03727f ; **FLOATING
C2386 VDD.n330 VSS 0.0776f ; **FLOATING
C2387 VDD.n331 VSS 0.03401f ; **FLOATING
C2388 VDD.t325 VSS 0.03178f ; **FLOATING
C2389 VDD.n332 VSS 0.1045f ; **FLOATING
C2390 VDD.n333 VSS 0.02357f ; **FLOATING
C2391 VDD.n334 VSS 0.05909f ; **FLOATING
C2392 VDD.n335 VSS 0.01381f ; **FLOATING
C2393 VDD.t37 VSS 0.03727f ; **FLOATING
C2394 VDD.n336 VSS 0.0776f ; **FLOATING
C2395 VDD.n337 VSS 0.03401f ; **FLOATING
C2396 VDD.t324 VSS 0.03178f ; **FLOATING
C2397 VDD.n338 VSS 0.1045f ; **FLOATING
C2398 VDD.n339 VSS 0.02357f ; **FLOATING
C2399 VDD.n340 VSS 0.05909f ; **FLOATING
C2400 VDD.n341 VSS 0.01381f ; **FLOATING
C2401 VDD.t249 VSS 0.03727f ; **FLOATING
C2402 VDD.n342 VSS 0.0776f ; **FLOATING
C2403 VDD.n343 VSS 0.03401f ; **FLOATING
C2404 VDD.t308 VSS 0.03178f ; **FLOATING
C2405 VDD.n344 VSS 0.10447f ; **FLOATING
C2406 VDD.n345 VSS 0.02357f ; **FLOATING
C2407 VDD.n346 VSS 0.05908f ; **FLOATING
C2408 VDD.n347 VSS 0.0138f ; **FLOATING
C2409 VDD.t79 VSS 0.03727f ; **FLOATING
C2410 VDD.n348 VSS 0.07764f ; **FLOATING
C2411 VDD.n349 VSS 0.03397f ; **FLOATING
C2412 VDD.t327 VSS 0.03178f ; **FLOATING
C2413 VDD.n350 VSS 0.10444f ; **FLOATING
C2414 VDD.n351 VSS 0.02357f ; **FLOATING
C2415 VDD.n352 VSS 0.05911f ; **FLOATING
C2416 VDD.n353 VSS 0.0138f ; **FLOATING
C2417 VDD.t331 VSS 0.03727f ; **FLOATING
C2418 VDD.n354 VSS 0.07763f ; **FLOATING
C2419 VDD.n355 VSS 0.03404f ; **FLOATING
C2420 VDD.t302 VSS 0.03178f ; **FLOATING
C2421 VDD.n356 VSS 0.1045f ; **FLOATING
C2422 VDD.n357 VSS 0.02357f ; **FLOATING
C2423 VDD.n358 VSS 0.05906f ; **FLOATING
C2424 VDD.n359 VSS 0.01381f ; **FLOATING
C2425 VDD.t287 VSS 0.03727f ; **FLOATING
C2426 VDD.n360 VSS 0.07761f ; **FLOATING
C2427 VDD.n361 VSS 0.03404f ; **FLOATING
C2428 VDD.t328 VSS 0.03178f ; **FLOATING
C2429 VDD.n362 VSS 0.10447f ; **FLOATING
C2430 VDD.n363 VSS 0.02357f ; **FLOATING
C2431 VDD.n364 VSS 0.05906f ; **FLOATING
C2432 VDD.n365 VSS 0.01381f ; **FLOATING
C2433 VDD.t47 VSS 0.03727f ; **FLOATING
C2434 VDD.n366 VSS 0.07761f ; **FLOATING
C2435 VDD.n367 VSS 0.03397f ; **FLOATING
C2436 VDD.t329 VSS 0.03178f ; **FLOATING
C2437 VDD.n368 VSS 0.10444f ; **FLOATING
C2438 VDD.n369 VSS 0.02357f ; **FLOATING
C2439 VDD.n370 VSS 0.05911f ; **FLOATING
C2440 VDD.n371 VSS 0.0138f ; **FLOATING
C2441 VDD.t42 VSS 0.03727f ; **FLOATING
C2442 VDD.n372 VSS 0.07765f ; **FLOATING
C2443 VDD.n373 VSS 0.03398f ; **FLOATING
C2444 VDD.t330 VSS 0.03178f ; **FLOATING
C2445 VDD.n374 VSS 0.0865f ; **FLOATING
C2446 VDD.n375 VSS 0.02357f ; **FLOATING
C2447 VDD.n376 VSS 0.0591f ; **FLOATING
C2448 VDD.n377 VSS 0.01381f ; **FLOATING
C2449 VDD.t281 VSS 0.03727f ; **FLOATING
C2450 VDD.n378 VSS 0.05916f ; **FLOATING
C2451 VDD.n379 VSS 0.01422f ; **FLOATING
C2452 VDD.t161 VSS 0.03178f ; **FLOATING
C2453 VDD.n380 VSS 0.02357f ; **FLOATING
C2454 VDD.t162 VSS 0.03552f ; **FLOATING
C2455 VDD.n381 VSS 0.06979f ; **FLOATING
C2456 VDD.t165 VSS 0.03178f ; **FLOATING
C2457 VDD.n382 VSS 0.0211f ; **FLOATING
C2458 VDD.t163 VSS 0.03071f ; **FLOATING
C2459 VDD.n383 VSS 0.01566f ; **FLOATING
C2460 VDD.n384 VSS 0.05923f ; **FLOATING
C2461 VDD.n385 VSS 0.05088f ; **FLOATING
C2462 VDD.n386 VSS 2.34984f ; **FLOATING
C2463 VDD.n387 VSS 0.70246f ; **FLOATING
C2464 VDD.n388 VSS 0.02958f ; **FLOATING
C2465 VDD.n389 VSS 0.0156f ; **FLOATING
C2466 VDD.n390 VSS 0.03576f ; **FLOATING
C2467 VDD.n391 VSS 0.03118f ; **FLOATING
C2468 VDD.n392 VSS 0.03561f ; **FLOATING
C2469 VDD.n393 VSS 0.03578f ; **FLOATING
C2470 VDD.n394 VSS 0.01573f ; **FLOATING
C2471 VDD.t360 VSS 0.02171f ; **FLOATING
C2472 VDD.n395 VSS 0.06125f ; **FLOATING
C2473 VDD.n396 VSS 0.01537f ; **FLOATING
C2474 VDD.n397 VSS 0.0156f ; **FLOATING
C2475 VDD.n398 VSS 0.06781f ; **FLOATING
C2476 VDD.t21 VSS 0.06343f ; **FLOATING
C2477 VDD.n399 VSS 0.02215f ; **FLOATING
C2478 VDD.n400 VSS 0.04964f ; **FLOATING
C2479 VDD.t136 VSS 0.05675f ; **FLOATING
C2480 VDD.n401 VSS 0.02212f ; **FLOATING
C2481 VDD.t142 VSS 0.05675f ; **FLOATING
C2482 VDD.n402 VSS 0.06353f ; **FLOATING
C2483 VDD.n403 VSS 0.02213f ; **FLOATING
C2484 VDD.n404 VSS 0.04482f ; **FLOATING
C2485 VDD.t134 VSS 0.35887f ; **FLOATING
C2486 VDD.n405 VSS 0.01448f ; **FLOATING
C2487 VDD.n406 VSS 0.04479f ; **FLOATING
C2488 VDD.t22 VSS 0.06343f ; **FLOATING
C2489 VDD.n407 VSS 0.02214f ; **FLOATING
C2490 VDD.n408 VSS 0.06781f ; **FLOATING
C2491 VDD.n409 VSS 0.03576f ; **FLOATING
C2492 VDD.n410 VSS 0.08627f ; **FLOATING
C2493 VDD.t30 VSS 0.06343f ; **FLOATING
C2494 VDD.n411 VSS 0.04115f ; **FLOATING
C2495 VDD.t23 VSS 0.06343f ; **FLOATING
C2496 VDD.n412 VSS 0.04116f ; **FLOATING
C2497 VDD.n413 VSS 0.0863f ; **FLOATING
C2498 VDD.n414 VSS 0.03109f ; **FLOATING
C2499 VDD.n415 VSS 0.08649f ; **FLOATING
C2500 VDD.t32 VSS 0.06343f ; **FLOATING
C2501 VDD.n416 VSS 0.04115f ; **FLOATING
C2502 VDD.t25 VSS 0.06343f ; **FLOATING
C2503 VDD.n417 VSS 0.04116f ; **FLOATING
C2504 VDD.n418 VSS 0.08654f ; **FLOATING
C2505 VDD.n419 VSS 0.03568f ; **FLOATING
C2506 VDD.n420 VSS 0.08174f ; **FLOATING
C2507 VDD.t34 VSS 0.06343f ; **FLOATING
C2508 VDD.n421 VSS 0.04115f ; **FLOATING
C2509 VDD.t27 VSS 0.06343f ; **FLOATING
C2510 VDD.n422 VSS 0.04116f ; **FLOATING
C2511 VDD.n423 VSS 0.08168f ; **FLOATING
C2512 VDD.n424 VSS 0.03574f ; **FLOATING
C2513 VDD.n425 VSS 0.01566f ; **FLOATING
C2514 VDD.t139 VSS 0.05675f ; **FLOATING
C2515 VDD.t144 VSS 0.05675f ; **FLOATING
C2516 VDD.n426 VSS 0.0691f ; **FLOATING
C2517 VDD.n427 VSS 0.02213f ; **FLOATING
C2518 VDD.t29 VSS 0.06343f ; **FLOATING
C2519 VDD.n428 VSS 0.06784f ; **FLOATING
C2520 VDD.n429 VSS 0.02214f ; **FLOATING
C2521 VDD.n430 VSS 0.06779f ; **FLOATING
C2522 VDD.t36 VSS 0.06343f ; **FLOATING
C2523 VDD.n431 VSS 0.02215f ; **FLOATING
C2524 VDD.n432 VSS 0.04479f ; **FLOATING
C2525 VDD.t137 VSS 0.35887f ; **FLOATING
C2526 VDD.n433 VSS 0.01448f ; **FLOATING
C2527 VDD.n434 VSS 0.04801f ; **FLOATING
C2528 VDD.n435 VSS 0.02212f ; **FLOATING
C2529 VDD.n436 VSS 0.08081f ; **FLOATING
C2530 VDD.n437 VSS 0.04703f ; **FLOATING
C2531 VDD.t6 VSS 12.4932f ; **FLOATING
.ends
