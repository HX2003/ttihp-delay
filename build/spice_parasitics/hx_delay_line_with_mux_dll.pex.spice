* NGSPICE file created from hx_delay_line_with_mux_dll.ext - technology: ihp-sg13g2

.subckt hx_delay_line_with_mux_dll VDD DELAY_OUT_LAST VSS DELAY_VBIASN DELAY_VBIASP
+ DLL_RESETN REF_CLK MUX_SEL0 MUX_SEL1 MUX_OUT MUX_SEL4 MUX_SEL2 MUX_SEL3
X0 a_14009_5878# REF_CLK VSS.t90 VSS.t497 sg13_lv_nmos ad=0.2516p pd=2.16u as=1.9998p ps=12.915u w=0.74u l=0.13u
X1 VDD.t127 a_4003_1842# a_4437_1842# VDD.t3 sg13_lv_pmos ad=0.2128p pd=1.5u as=0.3808p ps=2.92u w=1.12u l=0.13u
X2 VSS.t177 DLL_RESETN a_10040_6305# VSS.t176 sg13_lv_nmos ad=0.1626p pd=1.415u as=60.89999f ps=0.71u w=0.42u l=0.13u
X3 VSS.t481 a_15077_1842# a_15545_1044# VSS.t480 sg13_lv_nmos ad=0.1665p pd=1.19u as=0.2516p ps=2.16u w=0.74u l=0.13u
X4 a_27915_1044# a_27705_1044# VDD.t122 VDD.t0 sg13_lv_pmos ad=0.2128p pd=1.5u as=0.252p ps=1.57u w=1.12u l=0.13u
X5 VSS.t21 VDD.t408 VSS.t19 VSS.t20 sg13_lv_nmos ad=79.8f pd=0.8u as=0 ps=0 w=0.42u l=1u
X6 a_10951_2470# a_10713_1842# a_10843_1842# VDD.t3 sg13_lv_pmos ad=0.2128p pd=1.5u as=0.3808p ps=2.92u w=1.12u l=0.2u
X7 VSS.t414 a_3171_1047.t7 a_11924_1008# VSS.t413 sg13_lv_nmos ad=0.2516p pd=2.16u as=0.2516p ps=2.16u w=0.74u l=0.13u
X8 VDD.t53 VSS.t63 VDD.t214 VDD.t0 sg13_lv_pmos ad=0.34p pd=2.68u as=0 ps=0 w=1u l=1u
X9 VSS.t380 a_1256_1044# a_2967_1395# VSS.t379 sg13_lv_nmos ad=0.1331p pd=1.12u as=0.1216p ps=1.02u w=0.64u l=0.13u
X10 VSS.t21 VDD.t407 VSS.t21 VSS.t22 sg13_lv_nmos ad=0.1428p pd=1.52u as=0 ps=0 w=0.42u l=1u
X11 a_25153_1842# a_24957_1842# VSS.t360 VSS.t383 sg13_lv_nmos ad=0.2516p pd=2.16u as=0.1406p ps=1.12u w=0.74u l=0.13u
X12 VDD.t1 VSS.t36 VDD.t126 VDD.t0 sg13_lv_pmos ad=0.34p pd=2.68u as=0 ps=0 w=1u l=1u
X13 a_15108_6109# a_14851_6228# a_15270_6305# VSS.t91 sg13_lv_nmos ad=0.1428p pd=1.52u as=37.8f ps=0.6u w=0.42u l=0.13u
X14 VSS.t353 a_14851_6228# a_15688_5867# VSS.t352 sg13_lv_nmos ad=0.1406p pd=1.12u as=0.2516p ps=2.16u w=0.74u l=0.13u
X15 VSS.t437 VSS.t435 VSS.t435 VSS.t436 sg13_lv_nmos ad=0.68p pd=4.68u as=0 ps=0 w=2u l=1u
X16 a_15108_5325# a_12849_5867# VDD.t48 VDD.t9 sg13_lv_pmos ad=79.8f pd=0.8u as=1.03698p ps=6.245u w=0.42u l=0.13u
X17 a_25630_1044# a_2019_1047.t2 a_25528_1044# VSS.t209 sg13_lv_nmos ad=0.2516p pd=2.16u as=0.1406p ps=1.12u w=0.74u l=0.13u
X18 VDD.t302 DELAY_VBIASP a_19311_2470# VDD.t3 sg13_lv_pmos ad=0.3808p pd=2.92u as=0.2128p ps=1.5u w=1.12u l=0.6u
X19 a_16108_289# a_2019_311# a_16510_1044# VSS.t273 sg13_lv_nmos ad=0.2516p pd=2.16u as=0.2516p ps=2.16u w=0.74u l=0.13u
X20 VDD.t293 DELAY_VBIASP a_9431_2470# VDD.t3 sg13_lv_pmos ad=0.3808p pd=2.92u as=0.2128p ps=1.5u w=1.12u l=0.6u
X21 VSS.t70 VDD.t394 VSS.t69 VSS.t68 sg13_lv_nmos ad=0.1428p pd=1.52u as=0 ps=0 w=0.42u l=1u
X22 VSS.t432 VSS.t432 VSS.t434 VSS.t433 sg13_lv_nmos ad=0.68p pd=4.68u as=0 ps=0 w=2u l=1u
X23 VDD.t305 DELAY_VBIASP a_23111_2470# VDD.t3 sg13_lv_pmos ad=0.3808p pd=2.92u as=0.2128p ps=1.5u w=1.12u l=0.6u
X24 a_7390_1044# a_8231_1008# a_8155_1044# VDD.t0 sg13_lv_pmos ad=0.3808p pd=2.92u as=0.2128p ps=1.5u w=1.12u l=0.13u
X25 a_14009_5878# REF_CLK VDD.t48 VDD.t9 sg13_lv_pmos ad=0.4088p pd=2.97u as=1.03698p ps=6.245u w=1.12u l=0.13u
X26 VSS.t25 a_2595_311.t3 a_8745_519# VSS.t85 sg13_lv_nmos ad=0.2516p pd=2.16u as=0.2516p ps=2.16u w=0.74u l=0.13u
X27 a_11748_6109# DLL_RESETN VDD.t48 VDD.t9 sg13_lv_pmos ad=79.8f pd=0.8u as=1.10612p ps=6.66u w=0.42u l=0.13u
X28 VDD.t145 a_11491_6228# a_12158_5867# VDD.t9 sg13_lv_pmos ad=0.2128p pd=1.5u as=0.3864p ps=2.93u w=1.12u l=0.13u
X29 VDD.t290 DELAY_VBIASP DELAY_VBIASP VDD.t22 sg13_lv_pmos ad=0.3808p pd=2.92u as=1.0304p ps=4.08u w=1.12u l=0.6u
X30 a_17791_1842# a_17553_1842# a_17683_1842# VSS.t387 sg13_lv_nmos ad=0.1406p pd=1.12u as=0.2516p ps=2.16u w=0.74u l=0.2u
X31 VSS.t237 a_11748_6109# a_11397_6228# VSS.t311 sg13_lv_nmos ad=79.8f pd=0.8u as=0.1428p ps=1.52u w=0.42u l=0.13u
X32 VDD.t221 a_12037_1842# a_12505_1044# VDD.t0 sg13_lv_pmos ad=0.252p pd=1.57u as=0.3808p ps=2.92u w=1.12u l=0.13u
X33 a_16510_1044# a_2019_1047.t5 a_16408_1044# VSS.t364 sg13_lv_nmos ad=0.2516p pd=2.16u as=0.1406p ps=1.12u w=0.74u l=0.13u
X34 a_21591_1842# a_21353_1842# a_21483_1842# VSS.t406 sg13_lv_nmos ad=0.1406p pd=1.12u as=0.2516p ps=2.16u w=0.74u l=0.2u
X35 a_6153_1842# a_5957_1842# VSS.t131 VSS.t222 sg13_lv_nmos ad=0.2516p pd=2.16u as=0.1406p ps=1.12u w=0.74u l=0.13u
X36 VSS.t478 a_16163_1842# a_16597_1842# VSS.t477 sg13_lv_nmos ad=0.1406p pd=1.12u as=0.2516p ps=2.16u w=0.74u l=0.13u
X37 VSS.t318 a_3171_1047.t2 a_27124_1008# VSS.t317 sg13_lv_nmos ad=0.2516p pd=2.16u as=0.2516p ps=2.16u w=0.74u l=0.13u
X38 VDD.t172 a_11603_1842# a_12037_1842# VDD.t3 sg13_lv_pmos ad=0.2128p pd=1.5u as=0.3808p ps=2.92u w=1.12u l=0.13u
X39 VDD.t135 a_3171_311.t3 a_11785_519# VDD.t0 sg13_lv_pmos ad=0.3808p pd=2.92u as=0.3808p ps=2.92u w=1.12u l=0.13u
X40 a_6126_3816# a_6326_4590# VDD.t79 VDD.t9 sg13_lv_pmos ad=0.38p pd=2.38u as=0.38p ps=2.38u w=2u l=1u
X41 a_24393_1842# a_24197_1842# VDD.t130 VDD.t3 sg13_lv_pmos ad=0.3808p pd=2.92u as=0.2128p ps=1.5u w=1.12u l=0.13u
X42 a_5731_289# a_2595_311.t3 a_7390_1044# VSS.t84 sg13_lv_nmos ad=0.2516p pd=2.16u as=0.2516p ps=2.16u w=0.74u l=0.13u
X43 a_10430_1044# a_2595_1047.t7 a_11195_1044# VSS.t321 sg13_lv_nmos ad=0.2516p pd=2.16u as=0.1406p ps=1.12u w=0.74u l=0.13u
X44 a_13306_6305# a_12355_5867# VDD.t44 VDD.t9 sg13_lv_pmos ad=79.8f pd=0.8u as=0.1428p ps=1.52u w=0.42u l=0.13u
X45 a_23355_1044# a_23145_1044# VSS.t235 VSS.t234 sg13_lv_nmos ad=0.1406p pd=1.12u as=0.1665p ps=1.19u w=0.74u l=0.13u
X46 VDD.t280 DELAY_VBIASP a_14751_2470# VDD.t3 sg13_lv_pmos ad=0.3808p pd=2.92u as=0.2128p ps=1.5u w=1.12u l=0.6u
X47 VSS.t183 DELAY_VBIASN a_10191_1842# VSS.t569 sg13_lv_nmos ad=0.2516p pd=2.16u as=0.1406p ps=1.12u w=0.74u l=0.6u
X48 VSS.t136 a_3747_1047.t4 a_21911_1008# VSS.t135 sg13_lv_nmos ad=0.2516p pd=2.16u as=0.2516p ps=2.16u w=0.74u l=0.13u
X49 VSS.t112 a_19963_1842# a_20397_1842# VSS.t230 sg13_lv_nmos ad=0.1406p pd=1.12u as=0.2516p ps=2.16u w=0.74u l=0.13u
X50 a_6126_3816# a_6326_4590# VDD.t84 VDD.t9 sg13_lv_pmos ad=0.38p pd=2.38u as=0.38p ps=2.38u w=2u l=1u
X51 VDD.t13 a_6326_4590# a_6854_5454# VDD.t9 sg13_lv_pmos ad=0.38p pd=2.38u as=0.38p ps=2.38u w=2u l=1u
X52 VDD.t288 DELAY_VBIASP a_4111_2470# VDD.t3 sg13_lv_pmos ad=0.3808p pd=2.92u as=0.2128p ps=1.5u w=1.12u l=0.6u
X53 a_10328_1044# a_9757_1842# VDD.t114 VDD.t0 sg13_lv_pmos ad=0.2128p pd=1.5u as=0.3808p ps=2.92u w=1.12u l=0.13u
X54 a_20968_1044# a_20397_1842# VSS.t114 VSS.t113 sg13_lv_nmos ad=0.1406p pd=1.12u as=0.2516p ps=2.16u w=0.74u l=0.13u
X55 a_22590_1044# a_22564_1008# a_22488_1044# VDD.t0 sg13_lv_pmos ad=0.3808p pd=2.92u as=0.2128p ps=1.5u w=1.12u l=0.13u
X56 VDD.t108 VSS.t32 VDD.t107 VDD.t0 sg13_lv_pmos ad=0.19p pd=1.38u as=0 ps=0 w=1u l=1u
X57 a_8808_1044# a_8237_1842# VDD.t73 VDD.t0 sg13_lv_pmos ad=0.2128p pd=1.5u as=0.3808p ps=2.92u w=1.12u l=0.13u
X58 VDD.t88 a_6326_4590# a_6326_4590# VDD.t9 sg13_lv_pmos ad=0.38p pd=2.38u as=0.38p ps=2.38u w=2u l=1u
X59 a_4157_1313# REF_CLK VDD.t350 VDD.t0 sg13_lv_pmos ad=0.3808p pd=2.92u as=0.3808p ps=2.92u w=1.12u l=0.13u
X60 a_17031_2470# a_16793_1842# a_16923_1842# VDD.t3 sg13_lv_pmos ad=0.2128p pd=1.5u as=0.3808p ps=2.92u w=1.12u l=0.2u
X61 a_11473_1842# a_11277_1842# VSS.t160 VSS.t291 sg13_lv_nmos ad=0.2516p pd=2.16u as=0.1406p ps=1.12u w=0.74u l=0.13u
X62 VSS.t65 VDD.t396 VSS.t63 VSS.t64 sg13_lv_nmos ad=79.8f pd=0.8u as=0 ps=0 w=0.42u l=1u
X63 a_13306_5105# a_13132_5420# VDD.t271 VDD.t9 sg13_lv_pmos ad=79.8f pd=0.8u as=0.1428p ps=1.52u w=0.42u l=0.13u
X64 a_19448_1044# a_18877_1842# VSS.t217 VSS.t216 sg13_lv_nmos ad=0.1406p pd=1.12u as=0.2516p ps=2.16u w=0.74u l=0.13u
X65 a_10430_1044# a_3171_1047.t7 a_11848_1044# VSS.t412 sg13_lv_nmos ad=0.2516p pd=2.16u as=0.1406p ps=1.12u w=0.74u l=0.13u
X66 a_20831_2470# a_20593_1842# a_20723_1842# VDD.t3 sg13_lv_pmos ad=0.2128p pd=1.5u as=0.3808p ps=2.92u w=1.12u l=0.2u
X67 VSS.t39 VDD.t403 VSS.t37 VSS.t38 sg13_lv_nmos ad=79.8f pd=0.8u as=0 ps=0 w=0.42u l=1u
X68 VDD.t122 a_27237_1842# a_27705_1044# VDD.t0 sg13_lv_pmos ad=0.252p pd=1.57u as=0.3808p ps=2.92u w=1.12u l=0.13u
X69 a_5393_1842# a_5197_1842# VDD.t70 VDD.t3 sg13_lv_pmos ad=0.3808p pd=2.92u as=0.2128p ps=1.5u w=1.12u l=0.13u
X70 VDD.t300 DELAY_VBIASP a_17031_2470# VDD.t3 sg13_lv_pmos ad=0.3808p pd=2.92u as=0.2128p ps=1.5u w=1.12u l=0.6u
X71 VDD.t48 a_15108_6109# a_15053_5990# VDD.t9 sg13_lv_pmos ad=1.10612p pd=6.66u as=93.45f ps=0.865u w=0.42u l=0.13u
X72 VDD.t84 a_6326_4590# a_6854_5454# VDD.t9 sg13_lv_pmos ad=0.38p pd=2.38u as=0.38p ps=2.38u w=2u l=1u
X73 a_13818_6292# a_12849_5867# VSS.t123 VSS.t424 sg13_lv_nmos ad=37.8f pd=0.6u as=0.1701p ps=1.65u w=0.42u l=0.13u
X74 VDD.t121 a_26803_1842# a_27237_1842# VDD.t3 sg13_lv_pmos ad=0.2128p pd=1.5u as=0.3808p ps=2.92u w=1.12u l=0.13u
X75 VDD.t97 MUX_SEL1 a_3449_1395# VDD.t0 sg13_lv_pmos ad=0.1918p pd=1.5u as=0.1596p ps=1.22u w=0.84u l=0.13u
X76 a_14851_6228# a_14009_5878# a_13592_5871# VDD.t9 sg13_lv_pmos ad=0.2048p pd=1.63u as=0.34p ps=2.68u w=1u l=0.13u
X77 a_25630_1044# a_2595_1047.t2 a_26395_1044# VSS.t314 sg13_lv_nmos ad=0.2516p pd=2.16u as=0.1406p ps=1.12u w=0.74u l=0.13u
X78 VSS.t141 DELAY_VBIASN a_25391_1842# VSS.t582 sg13_lv_nmos ad=0.2516p pd=2.16u as=0.1406p ps=1.12u w=0.74u l=0.6u
X79 VSS.t558 DELAY_VBIASN VSS.t556 VSS.t541 sg13_lv_nmos ad=1.33p pd=7.38u as=0 ps=0 w=7u l=7u
X80 a_6635_1044# a_6425_1044# VDD.t136 VDD.t0 sg13_lv_pmos ad=0.2128p pd=1.5u as=0.252p ps=1.57u w=1.12u l=0.13u
X81 VDD.t113 DLL_RESETN a_9946_6305# VDD.t9 sg13_lv_pmos ad=0.36237p pd=2.605u as=79.8f ps=0.8u w=0.42u l=0.13u
X82 a_20315_1044# a_20105_1044# VDD.t146 VDD.t0 sg13_lv_pmos ad=0.2128p pd=1.5u as=0.252p ps=1.57u w=1.12u l=0.13u
X83 VDD.t342 a_2595_1047.t9 a_5191_1008# VDD.t0 sg13_lv_pmos ad=0.3808p pd=2.92u as=0.3808p ps=2.92u w=1.12u l=0.13u
X84 a_19311_2470# a_19073_1842# a_19203_1842# VDD.t3 sg13_lv_pmos ad=0.2128p pd=1.5u as=0.3808p ps=2.92u w=1.12u l=0.2u
X85 VSS.t244 a_1721_1395# a_2019_1047.t1 VSS.t249 sg13_lv_nmos ad=0.2812p pd=2.24u as=0.1406p ps=1.12u w=0.74u l=0.13u
X86 a_25528_1044# a_24957_1842# VDD.t257 VDD.t0 sg13_lv_pmos ad=0.2128p pd=1.5u as=0.3808p ps=2.92u w=1.12u l=0.13u
X87 VSS.t221 a_5957_1842# a_6425_1044# VSS.t220 sg13_lv_nmos ad=0.1665p pd=1.19u as=0.2516p ps=2.16u w=0.74u l=0.13u
X88 VSS.t606 a_2019_1047.t6 a_13444_1008# VSS.t605 sg13_lv_nmos ad=0.2516p pd=2.16u as=0.2516p ps=2.16u w=0.74u l=0.13u
X89 a_23111_2470# a_22873_1842# a_23003_1842# VDD.t3 sg13_lv_pmos ad=0.2128p pd=1.5u as=0.3808p ps=2.92u w=1.12u l=0.2u
X90 VSS.t19 VDD.t408 VSS.t19 VSS.t18 sg13_lv_nmos ad=0.1428p pd=1.52u as=0 ps=0 w=0.42u l=1u
X91 VSS.t362 a_15964_289# a_16851_309# VSS.t517 sg13_lv_nmos ad=0.1371p pd=1.12u as=0.2176p ps=1.96u w=0.64u l=0.13u
X92 a_10713_1842# a_10517_1842# VDD.t116 VDD.t3 sg13_lv_pmos ad=0.3808p pd=2.92u as=0.2128p ps=1.5u w=1.12u l=0.13u
X93 VDD.t61 a_17683_1842# a_18117_1842# VDD.t3 sg13_lv_pmos ad=0.2128p pd=1.5u as=0.3808p ps=2.92u w=1.12u l=0.13u
X94 a_16108_289# a_17865_519# a_16510_1044# VDD.t0 sg13_lv_pmos ad=0.3808p pd=2.92u as=0.3808p ps=2.92u w=1.12u l=0.13u
X95 a_26673_1842# a_26477_1842# VSS.t101 VSS.t100 sg13_lv_nmos ad=0.2516p pd=2.16u as=0.1406p ps=1.12u w=0.74u l=0.13u
X96 VDD.t45 a_7803_1842# a_8237_1842# VDD.t3 sg13_lv_pmos ad=0.2128p pd=1.5u as=0.3808p ps=2.92u w=1.12u l=0.13u
X97 a_4248_1044# a_4157_1313# VSS.t266 VSS.t265 sg13_lv_nmos ad=0.1406p pd=1.12u as=0.2516p ps=2.16u w=0.74u l=0.13u
X98 a_16108_289# a_3171_311.t2 a_22590_1044# VSS.t312 sg13_lv_nmos ad=0.2516p pd=2.16u as=0.2516p ps=2.16u w=0.74u l=0.13u
X99 VSS.t356 DELAY_VBIASN a_6391_1842# VSS.t565 sg13_lv_nmos ad=0.2516p pd=2.16u as=0.1406p ps=1.12u w=0.74u l=0.6u
X100 a_16408_1044# a_15837_1842# VDD.t181 VDD.t0 sg13_lv_pmos ad=0.2128p pd=1.5u as=0.3808p ps=2.92u w=1.12u l=0.13u
X101 a_10232_5871# a_10206_5835# VSS.t177 VSS.t176 sg13_lv_nmos ad=0.2516p pd=2.16u as=0.1626p ps=1.415u w=0.74u l=0.13u
X102 a_19550_1044# a_3747_1047.t4 a_21835_1044# VSS.t134 sg13_lv_nmos ad=0.2516p pd=2.16u as=0.1406p ps=1.12u w=0.74u l=0.13u
X103 VSS.t511 DELAY_VBIASN a_20831_1842# VSS.t577 sg13_lv_nmos ad=0.2516p pd=2.16u as=0.1406p ps=1.12u w=0.74u l=0.6u
X104 a_3171_311.t0 a_2873_331# VDD.t124 VDD.t0 sg13_lv_pmos ad=0.2128p pd=1.5u as=0.1918p ps=1.5u w=1.12u l=0.13u
X105 a_15304_4605# a_14851_6228# VDD.t232 VDD.t9 sg13_lv_pmos ad=0.4312p pd=3.01u as=0.2639p ps=1.81u w=1.12u l=0.13u
X106 a_13106_5357# a_12907_5420# VSS.t93 VSS.t358 sg13_lv_nmos ad=0.27427p pd=2.28u as=1.45407p ps=9.445u w=0.795u l=0.13u
X107 a_3747_311.t0 a_3449_331# VDD.t203 VDD.t0 sg13_lv_pmos ad=0.2128p pd=1.5u as=0.1918p ps=1.5u w=1.12u l=0.13u
X108 a_13132_5420# a_13106_5357# VDD.t48 VDD.t9 sg13_lv_pmos ad=0.3927p pd=2.99u as=1.10612p ps=6.66u w=1.155u l=0.13u
X109 a_7390_1044# a_9751_1008# a_9675_1044# VDD.t0 sg13_lv_pmos ad=0.3808p pd=2.92u as=0.2128p ps=1.5u w=1.12u l=0.13u
X110 VSS.t554 DELAY_VBIASN VSS.t552 VSS.t537 sg13_lv_nmos ad=1.33p pd=7.38u as=0 ps=0 w=7u l=7u
X111 a_10191_1842# a_9953_1842# a_10083_1842# VSS.t385 sg13_lv_nmos ad=0.1406p pd=1.12u as=0.2516p ps=2.16u w=0.74u l=0.2u
X112 VSS.t235 a_22677_1842# a_23145_1044# VSS.t262 sg13_lv_nmos ad=0.1665p pd=1.19u as=0.2516p ps=2.16u w=0.74u l=0.13u
X113 a_14751_2470# a_14513_1842# a_14643_1842# VDD.t3 sg13_lv_pmos ad=0.2128p pd=1.5u as=0.3808p ps=2.92u w=1.12u l=0.2u
X114 a_5731_289# a_8745_519# a_7390_1044# VDD.t0 sg13_lv_pmos ad=0.3808p pd=2.92u as=0.3808p ps=2.92u w=1.12u l=0.13u
X115 VDD.t34 VDD.t35 VDD.t36 VDD.t3 sg13_lv_pmos ad=0.2128p pd=1.5u as=0 ps=0 w=1.12u l=0.13u
X116 a_4111_2470# REF_CLK a_4003_1842# VDD.t3 sg13_lv_pmos ad=0.2128p pd=1.5u as=0.3808p ps=2.92u w=1.12u l=0.2u
X117 a_13566_5835# a_14009_5878# a_13306_6305# VSS.t88 sg13_lv_nmos ad=79.8f pd=0.8u as=0.1296p ps=1.52u w=0.42u l=0.13u
X118 a_13306_6305# a_14111_5878# a_13566_5835# VDD.t9 sg13_lv_pmos ad=0.1428p pd=1.52u as=79.8f ps=0.8u w=0.42u l=0.13u
X119 a_13592_5423# a_14111_5227# a_14851_5182# VSS.t405 sg13_lv_nmos ad=0.3473p pd=2.71u as=0.12665p ps=1.145u w=0.74u l=0.13u
X120 a_7673_1842# a_7477_1842# VSS.t280 VSS.t287 sg13_lv_nmos ad=0.2516p pd=2.16u as=0.1406p ps=1.12u w=0.74u l=0.13u
X121 VDD.t387 a_3171_1047.t5 a_18004_1008# VDD.t0 sg13_lv_pmos ad=0.3808p pd=2.92u as=0.3808p ps=2.92u w=1.12u l=0.13u
X122 VDD.t65 a_13123_1842# a_13557_1842# VDD.t3 sg13_lv_pmos ad=0.2128p pd=1.5u as=0.3808p ps=2.92u w=1.12u l=0.13u
X123 VDD.t343 a_3747_311.t2 a_26985_519# VDD.t0 sg13_lv_pmos ad=0.3808p pd=2.92u as=0.3808p ps=2.92u w=1.12u l=0.13u
X124 a_25913_1842# a_25717_1842# VDD.t93 VDD.t3 sg13_lv_pmos ad=0.3808p pd=2.92u as=0.2128p ps=1.5u w=1.12u l=0.13u
X125 a_10430_1044# a_3747_1047.t7 a_12715_1044# VSS.t10 sg13_lv_nmos ad=0.2516p pd=2.16u as=0.1406p ps=1.12u w=0.74u l=0.13u
X126 a_6326_4590# a_5974_5723# a_6126_3816# VSS.t328 sg13_lv_nmos ad=0.38p pd=2.38u as=0.68p ps=4.68u w=2u l=1u
X127 a_14235_1044# a_14025_1044# VDD.t66 VDD.t0 sg13_lv_pmos ad=0.2128p pd=1.5u as=0.252p ps=1.57u w=1.12u l=0.13u
X128 a_24875_1044# a_24665_1044# VSS.t251 VSS.t250 sg13_lv_nmos ad=0.1406p pd=1.12u as=0.1665p ps=1.19u w=0.74u l=0.13u
X129 VSS.t264 DELAY_VBIASN a_11711_1842# VSS.t571 sg13_lv_nmos ad=0.2516p pd=2.16u as=0.1406p ps=1.12u w=0.74u l=0.6u
X130 VDD.t7 a_3747_1047.t7 a_12791_1008# VDD.t0 sg13_lv_pmos ad=0.3808p pd=2.92u as=0.3808p ps=2.92u w=1.12u l=0.13u
X131 VSS.t344 a_2595_1047.t3 a_23431_1008# VSS.t614 sg13_lv_nmos ad=0.2516p pd=2.16u as=0.2516p ps=2.16u w=0.74u l=0.13u
X132 VSS.t157 a_21483_1842# a_21917_1842# VSS.t348 sg13_lv_nmos ad=0.1406p pd=1.12u as=0.2516p ps=2.16u w=0.74u l=0.13u
X133 VSS.t118 a_13557_1842# a_14025_1044# VSS.t117 sg13_lv_nmos ad=0.1665p pd=1.19u as=0.2516p ps=2.16u w=0.74u l=0.13u
X134 a_11848_1044# a_11277_1842# VDD.t199 VDD.t0 sg13_lv_pmos ad=0.2128p pd=1.5u as=0.3808p ps=2.92u w=1.12u l=0.13u
X135 VDD.t159 VSS.t76 VDD.t158 VDD.t0 sg13_lv_pmos ad=0.19p pd=1.38u as=0 ps=0 w=1u l=1u
X136 VDD.t48 a_12907_5186# a_12907_5420# VDD.t9 sg13_lv_pmos ad=1.10612p pd=6.66u as=0.2442p ps=2.06u w=0.66u l=0.13u
X137 a_25391_1842# a_25153_1842# a_25283_1842# VSS.t175 sg13_lv_nmos ad=0.1406p pd=1.12u as=0.2516p ps=2.16u w=0.74u l=0.2u
X138 a_12993_1842# a_12797_1842# VSS.t228 VSS.t227 sg13_lv_nmos ad=0.2516p pd=2.16u as=0.1406p ps=1.12u w=0.74u l=0.13u
X139 DELAY_OUT_LAST a_27997_1842# VDD.t99 VDD.t3 sg13_lv_pmos ad=0.3808p pd=2.92u as=0.2128p ps=1.5u w=1.12u l=0.13u
X140 VDD.t161 VSS.t76 VDD.t160 VDD.t0 sg13_lv_pmos ad=0.34p pd=2.68u as=0 ps=0 w=1u l=1u
X141 VDD.t146 a_19637_1842# a_20105_1044# VDD.t0 sg13_lv_pmos ad=0.252p pd=1.57u as=0.3808p ps=2.92u w=1.12u l=0.13u
X142 a_6854_5454# a_6326_4590# VDD.t81 VDD.t9 sg13_lv_pmos ad=0.38p pd=2.38u as=0.38p ps=2.38u w=2u l=1u
X143 VSS.t373 DELAY_VBIASN a_13991_1842# VSS.t572 sg13_lv_nmos ad=0.2516p pd=2.16u as=0.1406p ps=1.12u w=0.74u l=0.6u
X144 VSS.t63 VDD.t396 VSS.t63 VSS.t62 sg13_lv_nmos ad=0.1428p pd=1.52u as=0 ps=0 w=0.42u l=1u
X145 a_22590_1044# a_3171_1047.t3 a_24008_1044# VSS.t4 sg13_lv_nmos ad=0.2516p pd=2.16u as=0.1406p ps=1.12u w=0.74u l=0.13u
X146 a_6913_1842# a_6717_1842# VDD.t236 VDD.t3 sg13_lv_pmos ad=0.3808p pd=2.92u as=0.2128p ps=1.5u w=1.12u l=0.13u
X147 VDD.t301 DELAY_VBIASP a_18551_2470# VDD.t3 sg13_lv_pmos ad=0.3808p pd=2.92u as=0.2128p ps=1.5u w=1.12u l=0.6u
X148 VSS.t208 a_23763_1842# a_24197_1842# VSS.t207 sg13_lv_nmos ad=0.1406p pd=1.12u as=0.2516p ps=2.16u w=0.74u l=0.13u
X149 VSS.t37 VDD.t403 VSS.t36 VSS.t35 sg13_lv_nmos ad=0.1428p pd=1.52u as=0 ps=0 w=0.42u l=1u
X150 VDD.t256 a_1256_1044# a_2873_1395# VDD.t0 sg13_lv_pmos ad=0.1918p pd=1.5u as=0.1596p ps=1.22u w=0.84u l=0.13u
X151 a_3171_311.t1 a_2873_331# VSS.t146 VSS.t197 sg13_lv_nmos ad=0.1406p pd=1.12u as=0.1331p ps=1.12u w=0.74u l=0.13u
X152 VDD.t125 a_2873_331# a_3171_311.t0 VDD.t0 sg13_lv_pmos ad=0.4256p pd=3u as=0.2128p ps=1.5u w=1.12u l=0.13u
X153 a_16510_1044# a_17351_1008# a_17275_1044# VDD.t0 sg13_lv_pmos ad=0.3808p pd=2.92u as=0.2128p ps=1.5u w=1.12u l=0.13u
X154 a_25630_1044# a_3747_1047.t2 a_27915_1044# VSS.t7 sg13_lv_nmos ad=0.2516p pd=2.16u as=0.1406p ps=1.12u w=0.74u l=0.13u
X155 VSS.t193 DELAY_VBIASN a_26911_1842# VSS.t580 sg13_lv_nmos ad=0.2516p pd=2.16u as=0.1406p ps=1.12u w=0.74u l=0.6u
X156 a_3747_311.t1 a_3449_331# VSS.t300 VSS.t504 sg13_lv_nmos ad=0.1406p pd=1.12u as=0.1331p ps=1.12u w=0.74u l=0.13u
X157 VDD.t355 a_3449_331# a_3747_311.t0 VDD.t0 sg13_lv_pmos ad=0.4256p pd=3u as=0.2128p ps=1.5u w=1.12u l=0.13u
X158 VDD.t285 DELAY_VBIASP a_22351_2470# VDD.t3 sg13_lv_pmos ad=0.3808p pd=2.92u as=0.2128p ps=1.5u w=1.12u l=0.6u
X159 VDD.t6 a_3747_1047.t2 a_27991_1008# VDD.t0 sg13_lv_pmos ad=0.3808p pd=2.92u as=0.3808p ps=2.92u w=1.12u l=0.13u
X160 VDD.t244 VSS.t17 VDD.t243 VDD.t0 sg13_lv_pmos ad=0.19p pd=1.38u as=0 ps=0 w=1u l=1u
X161 a_13019_5831# a_15688_5403# VSS.t339 VSS.t621 sg13_lv_nmos ad=0.2516p pd=2.16u as=0.1406p ps=1.12u w=0.74u l=0.13u
X162 VDD.t208 a_3747_1047.t9 a_6711_1008# VDD.t0 sg13_lv_pmos ad=0.3808p pd=2.92u as=0.3808p ps=2.92u w=1.12u l=0.13u
X163 a_6854_5454# a_6326_4590# VDD.t16 VDD.t9 sg13_lv_pmos ad=0.38p pd=2.38u as=0.38p ps=2.38u w=2u l=1u
X164 a_9772_5843# a_9746_5805# VDD.t48 VDD.t9 sg13_lv_pmos ad=0.3927p pd=2.99u as=1.10612p ps=6.66u w=1.155u l=0.13u
X165 a_6391_1842# a_6153_1842# a_6283_1842# VSS.t475 sg13_lv_nmos ad=0.1406p pd=1.12u as=0.2516p ps=2.16u w=0.74u l=0.2u
X166 a_15273_1842# a_15077_1842# VSS.t371 VSS.t479 sg13_lv_nmos ad=0.2516p pd=2.16u as=0.1406p ps=1.12u w=0.74u l=0.13u
X167 a_19833_1842# a_19637_1842# VDD.t120 VDD.t3 sg13_lv_pmos ad=0.3808p pd=2.92u as=0.2128p ps=1.5u w=1.12u l=0.13u
X168 a_16108_289# a_23945_519# a_22590_1044# VDD.t0 sg13_lv_pmos ad=0.3808p pd=2.92u as=0.3808p ps=2.92u w=1.12u l=0.13u
X169 VDD.t86 a_6326_4590# a_6126_3816# VDD.t9 sg13_lv_pmos ad=0.38p pd=2.38u as=0.38p ps=2.38u w=2u l=1u
X170 a_9193_1842# a_8997_1842# VDD.t118 VDD.t3 sg13_lv_pmos ad=0.3808p pd=2.92u as=0.2128p ps=1.5u w=1.12u l=0.13u
X171 a_24631_2470# a_24393_1842# a_24523_1842# VDD.t3 sg13_lv_pmos ad=0.2128p pd=1.5u as=0.3808p ps=2.92u w=1.12u l=0.2u
X172 VSS.t268 a_15403_1842# a_15837_1842# VSS.t587 sg13_lv_nmos ad=0.1406p pd=1.12u as=0.2516p ps=2.16u w=0.74u l=0.13u
X173 a_8155_1044# a_7945_1044# VSS.t259 VSS.t258 sg13_lv_nmos ad=0.1406p pd=1.12u as=0.1665p ps=1.19u w=0.74u l=0.13u
X174 a_23633_1842# a_23437_1842# VDD.t156 VDD.t3 sg13_lv_pmos ad=0.3808p pd=2.92u as=0.2128p ps=1.5u w=1.12u l=0.13u
X175 VSS.t129 a_4763_1842# a_5197_1842# VSS.t162 sg13_lv_nmos ad=0.1406p pd=1.12u as=0.2516p ps=2.16u w=0.74u l=0.13u
X176 a_27048_1044# a_26477_1842# VSS.t99 VSS.t98 sg13_lv_nmos ad=0.1406p pd=1.12u as=0.2516p ps=2.16u w=0.74u l=0.13u
X177 VDD.t115 a_9323_1842# a_9757_1842# VDD.t3 sg13_lv_pmos ad=0.2128p pd=1.5u as=0.3808p ps=2.92u w=1.12u l=0.13u
X178 a_5768_1044# a_5197_1842# VSS.t127 VSS.t126 sg13_lv_nmos ad=0.1406p pd=1.12u as=0.2516p ps=2.16u w=0.74u l=0.13u
X179 a_6326_4590# a_6126_3816# a_5778_3367# VSS.t325 sg13_lv_nmos ad=0.38p pd=2.38u as=0.68p ps=4.68u w=2u l=1u
X180 DELAY_VBIASN DLL_RESETN VDD.t324 VDD.t22 sg13_lv_pmos ad=0.158p pd=1.245u as=0.272p ps=2.28u w=0.8u l=0.2u
X181 a_7390_1044# a_7364_1008# a_7288_1044# VDD.t0 sg13_lv_pmos ad=0.3808p pd=2.92u as=0.2128p ps=1.5u w=1.12u l=0.13u
X182 VSS.t548 DELAY_VBIASN VSS.t547 VSS.t530 sg13_lv_nmos ad=2.38p pd=14.68u as=0 ps=0 w=7u l=7u
X183 VSS.t83 DELAY_VBIASN a_7911_1842# VSS.t522 sg13_lv_nmos ad=0.2516p pd=2.16u as=0.1406p ps=1.12u w=0.74u l=0.6u
X184 VDD.t207 a_13019_5831# a_12943_5867# VDD.t9 sg13_lv_pmos ad=0.2128p pd=1.5u as=0.2128p ps=1.5u w=1.12u l=0.13u
X185 a_6854_5986# a_15304_4605# DELAY_VBIASN VDD.t22 sg13_lv_pmos ad=0.136p pd=1.14u as=0.158p ps=1.245u w=0.4u l=0.2u
X186 VDD.t179 VSS.t43 VDD.t177 VDD.t0 sg13_lv_pmos ad=0.19p pd=1.38u as=0 ps=0 w=1u l=1u
X187 a_11711_1842# a_11473_1842# a_11603_1842# VSS.t155 sg13_lv_nmos ad=0.1406p pd=1.12u as=0.2516p ps=2.16u w=0.74u l=0.2u
X188 VSS.t251 a_24197_1842# a_24665_1044# VSS.t493 sg13_lv_nmos ad=0.1665p pd=1.19u as=0.2516p ps=2.16u w=0.74u l=0.13u
X189 a_16510_1044# a_3171_1047.t5 a_17928_1044# VSS.t615 sg13_lv_nmos ad=0.2516p pd=2.16u as=0.1406p ps=1.12u w=0.74u l=0.13u
X190 a_15270_5105# a_12849_5867# VSS.t339 VSS.t426 sg13_lv_nmos ad=37.8f pd=0.6u as=79.8f ps=0.8u w=0.42u l=0.13u
X191 a_5974_5723# a_6126_3816# VSS.t330 VSS.t328 sg13_lv_nmos ad=0.38p pd=2.38u as=0.68p ps=4.68u w=2u l=1u
X192 VSS.t32 VDD.t405 VSS.t30 VSS.t31 sg13_lv_nmos ad=79.8f pd=0.8u as=0 ps=0 w=0.42u l=1u
X193 a_5631_2470# a_5393_1842# a_5523_1842# VDD.t3 sg13_lv_pmos ad=0.2128p pd=1.5u as=0.3808p ps=2.92u w=1.12u l=0.2u
X194 a_14513_1842# a_14317_1842# VDD.t253 VDD.t3 sg13_lv_pmos ad=0.3808p pd=2.92u as=0.2128p ps=1.5u w=1.12u l=0.13u
X195 a_4633_1842# a_4437_1842# VDD.t127 VDD.t3 sg13_lv_pmos ad=0.3808p pd=2.92u as=0.2128p ps=1.5u w=1.12u l=0.13u
X196 VSS.t183 a_10083_1842# a_10517_1842# VSS.t233 sg13_lv_nmos ad=0.1406p pd=1.12u as=0.2516p ps=2.16u w=0.74u l=0.13u
X197 VDD.t270 a_2019_1047.t4 a_19524_1008# VDD.t0 sg13_lv_pmos ad=0.3808p pd=2.92u as=0.3808p ps=2.92u w=1.12u l=0.13u
X198 VSS.t395 a_3171_1047.t4 a_21044_1008# VSS.t394 sg13_lv_nmos ad=0.2516p pd=2.16u as=0.2516p ps=2.16u w=0.74u l=0.13u
X199 VSS.t146 a_2873_331# a_3171_311.t1 VSS.t198 sg13_lv_nmos ad=0.2812p pd=2.24u as=0.1406p ps=1.12u w=0.74u l=0.13u
X200 a_13949_5496# a_13592_5423# VDD.t319 VDD.t9 sg13_lv_pmos ad=63f pd=0.72u as=0.1563p ps=1.22u w=0.42u l=0.13u
X201 VSS.t300 a_3449_331# a_3747_311.t1 VSS.t505 sg13_lv_nmos ad=0.2812p pd=2.24u as=0.1406p ps=1.12u w=0.74u l=0.13u
X202 a_15755_1044# a_15545_1044# VDD.t336 VDD.t0 sg13_lv_pmos ad=0.2128p pd=1.5u as=0.252p ps=1.57u w=1.12u l=0.13u
X203 VDD.t385 a_2595_1047.t6 a_14311_1008# VDD.t0 sg13_lv_pmos ad=0.3808p pd=2.92u as=0.3808p ps=2.92u w=1.12u l=0.13u
X204 VSS.t360 DELAY_VBIASN a_24631_1842# VSS.t583 sg13_lv_nmos ad=0.2516p pd=2.16u as=0.1406p ps=1.12u w=0.74u l=0.6u
X205 a_5115_1044# a_4905_1044# VDD.t138 VDD.t0 sg13_lv_pmos ad=0.2128p pd=1.5u as=0.252p ps=1.57u w=1.12u l=0.13u
X206 a_5974_5723# a_6126_3816# VSS.t333 VSS.t328 sg13_lv_nmos ad=0.38p pd=2.38u as=0.68p ps=4.68u w=2u l=1u
X207 VSS.t93 a_12907_5186# a_12907_5186# VSS.t92 sg13_lv_nmos ad=1.45407p pd=9.445u as=0.111p ps=1.34u w=0.3u l=0.13u
X208 a_18551_2470# a_18313_1842# a_18443_1842# VDD.t3 sg13_lv_pmos ad=0.2128p pd=1.5u as=0.3808p ps=2.92u w=1.12u l=0.2u
X209 VDD.t250 VSS.t61 VDD.t248 VDD.t0 sg13_lv_pmos ad=0.19p pd=1.38u as=0 ps=0 w=1u l=1u
X210 a_3171_1047.t1 a_2873_1395# VSS.t380 VSS.t407 sg13_lv_nmos ad=0.1406p pd=1.12u as=0.1331p ps=1.12u w=0.74u l=0.13u
X211 a_13121_5831# a_15688_5867# VSS.t353 VSS.t486 sg13_lv_nmos ad=0.2516p pd=2.16u as=0.1406p ps=1.12u w=0.74u l=0.13u
X212 VSS.t538 DELAY_VBIASN VSS.t540 VSS.t539 sg13_lv_nmos ad=1.33p pd=7.38u as=0 ps=0 w=7u l=7u
X213 VSS.t244 a_2297_1395# a_2595_1047.t1 VSS.t485 sg13_lv_nmos ad=0.2812p pd=2.24u as=0.1406p ps=1.12u w=0.74u l=0.13u
X214 VDD.t222 a_14851_5182# a_15108_5325# VDD.t9 sg13_lv_pmos ad=0.2639p pd=1.81u as=79.8f ps=0.8u w=0.42u l=0.13u
X215 a_22351_2470# a_22113_1842# a_22243_1842# VDD.t3 sg13_lv_pmos ad=0.2128p pd=1.5u as=0.3808p ps=2.92u w=1.12u l=0.2u
X216 VSS.t455 VSS.t455 VSS.t457 VSS.t456 sg13_lv_nmos ad=0.2516p pd=2.16u as=0 ps=0 w=0.74u l=0.13u
X217 a_26911_1842# a_26673_1842# a_26803_1842# VSS.t418 sg13_lv_nmos ad=0.1406p pd=1.12u as=0.2516p ps=2.16u w=0.74u l=0.2u
X218 VSS.t36 a_3171_311.t3 a_11785_519# VSS.t219 sg13_lv_nmos ad=0.2516p pd=2.16u as=0.2516p ps=2.16u w=0.74u l=0.13u
X219 VDD.t152 a_1721_1395# a_2019_1047.t0 VDD.t0 sg13_lv_pmos ad=0.4256p pd=3u as=0.2128p ps=1.5u w=1.12u l=0.13u
X220 a_12656_5864# DLL_RESETN VSS.t237 VSS.t429 sg13_lv_nmos ad=0.2516p pd=2.16u as=0.2516p ps=2.16u w=0.74u l=0.13u
X221 a_14851_6228# a_14009_5878# a_14757_6228# VSS.t91 sg13_lv_nmos ad=0.12665p pd=1.145u as=0.1428p ps=1.52u w=0.42u l=0.13u
X222 VDD.t67 a_16923_1842# a_17357_1842# VDD.t3 sg13_lv_pmos ad=0.2128p pd=1.5u as=0.3808p ps=2.92u w=1.12u l=0.13u
X223 a_2391_1395# MUX_SEL0 a_2297_1395# VSS.t470 sg13_lv_nmos ad=0.1216p pd=1.02u as=0.2176p ps=1.96u w=0.64u l=0.13u
X224 VSS.t244 a_1544_1044# a_1815_1395# VSS.t243 sg13_lv_nmos ad=0.1331p pd=1.12u as=0.1216p ps=1.02u w=0.64u l=0.13u
X225 a_13368_1044# a_12797_1842# VSS.t12 VSS.t229 sg13_lv_nmos ad=0.1406p pd=1.12u as=0.2516p ps=2.16u w=0.74u l=0.13u
X226 a_13400_5105# a_13132_5420# a_13306_5105# VSS.t403 sg13_lv_nmos ad=60.89999f pd=0.71u as=0.1428p ps=1.52u w=0.42u l=0.13u
X227 a_5731_289# a_3171_311.t3 a_10430_1044# VSS.t218 sg13_lv_nmos ad=0.2516p pd=2.16u as=0.2516p ps=2.16u w=0.74u l=0.13u
X228 VDD.t206 a_21157_1842# a_21625_1044# VDD.t0 sg13_lv_pmos ad=0.252p pd=1.57u as=0.3808p ps=2.92u w=1.12u l=0.13u
X229 VDD.t294 DELAY_VBIASP a_10951_2470# VDD.t3 sg13_lv_pmos ad=0.3808p pd=2.92u as=0.2128p ps=1.5u w=1.12u l=0.6u
X230 VSS.t268 DELAY_VBIASN a_15511_1842# VSS.t574 sg13_lv_nmos ad=0.2516p pd=2.16u as=0.1406p ps=1.12u w=0.74u l=0.6u
X231 a_6326_4590# a_6326_4590# VDD.t77 VDD.t9 sg13_lv_pmos ad=0.38p pd=2.38u as=0.38p ps=2.38u w=2u l=1u
X232 VSS.t550 DELAY_VBIASN VSS.t548 VSS.t533 sg13_lv_nmos ad=1.33p pd=7.38u as=0 ps=0 w=7u l=7u
X233 VDD.t360 a_20723_1842# a_21157_1842# VDD.t3 sg13_lv_pmos ad=0.2128p pd=1.5u as=0.3808p ps=2.92u w=1.12u l=0.13u
X234 VSS.t141 a_25283_1842# a_25717_1842# VSS.t140 sg13_lv_nmos ad=0.1406p pd=1.12u as=0.2516p ps=2.16u w=0.74u l=0.13u
X235 a_4350_1044# a_3747_1047.t9 a_6635_1044# VSS.t305 sg13_lv_nmos ad=0.2516p pd=2.16u as=0.1406p ps=1.12u w=0.74u l=0.13u
X236 VSS.t131 DELAY_VBIASN a_5631_1842# VSS.t526 sg13_lv_nmos ad=0.2516p pd=2.16u as=0.1406p ps=1.12u w=0.74u l=0.6u
X237 VDD.t269 a_2019_1047.t9 a_4324_1008# VDD.t0 sg13_lv_pmos ad=0.3808p pd=2.92u as=0.3808p ps=2.92u w=1.12u l=0.13u
X238 a_12849_5867# a_12656_5864# VSS.t237 VSS.t254 sg13_lv_nmos ad=0.1406p pd=1.12u as=0.2516p ps=2.16u w=0.74u l=0.13u
X239 a_16510_1044# a_18871_1008# a_18795_1044# VDD.t0 sg13_lv_pmos ad=0.3808p pd=2.92u as=0.2128p ps=1.5u w=1.12u l=0.13u
X240 a_19550_1044# a_2595_1047.t4 a_20315_1044# VSS.t506 sg13_lv_nmos ad=0.2516p pd=2.16u as=0.1406p ps=1.12u w=0.74u l=0.13u
X241 VDD.t81 a_6326_4590# a_6126_3816# VDD.t9 sg13_lv_pmos ad=0.38p pd=2.38u as=0.38p ps=2.38u w=2u l=1u
X242 VDD.t48 a_11491_6228# a_11748_6109# VDD.t9 sg13_lv_pmos ad=1.10612p pd=6.66u as=79.8f ps=0.8u w=0.42u l=0.13u
X243 a_12355_5867# a_12158_5867# VDD.t145 VDD.t9 sg13_lv_pmos ad=0.3808p pd=2.92u as=0.2128p ps=1.5u w=1.12u l=0.13u
X244 VDD.t304 DELAY_VBIASP a_23871_2470# VDD.t3 sg13_lv_pmos ad=0.3808p pd=2.92u as=0.2128p ps=1.5u w=1.12u l=0.6u
X245 VSS.t259 a_7477_1842# a_7945_1044# VSS.t286 sg13_lv_nmos ad=0.1665p pd=1.19u as=0.2516p ps=2.16u w=0.74u l=0.13u
X246 a_11910_6305# DLL_RESETN VSS.t237 VSS.t311 sg13_lv_nmos ad=37.8f pd=0.6u as=79.8f ps=0.8u w=0.42u l=0.13u
X247 VSS.t544 DELAY_VBIASN VSS.t546 VSS.t545 sg13_lv_nmos ad=1.33p pd=7.38u as=0 ps=0 w=7u l=7u
X248 a_13231_2470# a_12993_1842# a_13123_1842# VDD.t3 sg13_lv_pmos ad=0.2128p pd=1.5u as=0.3808p ps=2.92u w=1.12u l=0.2u
X249 VDD.t243 VSS.t14 VDD.t356 VDD.t0 sg13_lv_pmos ad=0.34p pd=2.68u as=0 ps=0 w=1u l=1u
X250 a_6326_4590# a_6126_3816# a_5778_3367# VSS.t325 sg13_lv_nmos ad=0.38p pd=2.38u as=0.68p ps=4.68u w=2u l=1u
X251 a_12233_1842# a_12037_1842# VDD.t172 VDD.t3 sg13_lv_pmos ad=0.3808p pd=2.92u as=0.2128p ps=1.5u w=1.12u l=0.13u
X252 a_7911_1842# a_7673_1842# a_7803_1842# VSS.t341 sg13_lv_nmos ad=0.1406p pd=1.12u as=0.2516p ps=2.16u w=0.74u l=0.2u
X253 a_16793_1842# a_16597_1842# VSS.t478 VSS.t596 sg13_lv_nmos ad=0.2516p pd=2.16u as=0.1406p ps=1.12u w=0.74u l=0.13u
X254 VDD.t200 a_3747_311.t3 a_14825_519# VDD.t0 sg13_lv_pmos ad=0.3808p pd=2.92u as=0.3808p ps=2.92u w=1.12u l=0.13u
X255 VDD.t68 a_12849_5867# a_13306_6305# VDD.t9 sg13_lv_pmos ad=0.36237p pd=2.605u as=79.8f ps=0.8u w=0.42u l=0.13u
X256 VDD.t17 VDD.t8 VDD.t16 VDD.t9 sg13_lv_pmos ad=0.68p pd=4.68u as=0 ps=0 w=2u l=1u
X257 VSS.t154 a_27563_1842# a_27997_1842# VSS.t496 sg13_lv_nmos ad=0.1406p pd=1.12u as=0.2516p ps=2.16u w=0.74u l=0.13u
X258 a_9675_1044# a_9465_1044# VSS.t189 VSS.t508 sg13_lv_nmos ad=0.1406p pd=1.12u as=0.1665p ps=1.19u w=0.74u l=0.13u
X259 VDD.t77 a_6326_4590# a_6854_5986# VDD.t9 sg13_lv_pmos ad=0.38p pd=2.38u as=0.38p ps=2.38u w=2u l=1u
X260 a_20593_1842# a_20397_1842# VSS.t112 VSS.t111 sg13_lv_nmos ad=0.2516p pd=2.16u as=0.1406p ps=1.12u w=0.74u l=0.13u
X261 VSS.t138 a_2595_1047.t8 a_8231_1008# VSS.t320 sg13_lv_nmos ad=0.2516p pd=2.16u as=0.2516p ps=2.16u w=0.74u l=0.13u
X262 VSS.t356 a_6283_1842# a_6717_1842# VSS.t495 sg13_lv_nmos ad=0.1406p pd=1.12u as=0.2516p ps=2.16u w=0.74u l=0.13u
X263 a_10430_1044# a_10404_1008# a_10328_1044# VDD.t0 sg13_lv_pmos ad=0.3808p pd=2.92u as=0.2128p ps=1.5u w=1.12u l=0.13u
X264 VDD.t306 DELAY_VBIASP a_26151_2470# VDD.t3 sg13_lv_pmos ad=0.3808p pd=2.92u as=0.2128p ps=1.5u w=1.12u l=0.6u
X265 a_7390_1044# a_8884_1008# a_8808_1044# VDD.t0 sg13_lv_pmos ad=0.3808p pd=2.92u as=0.2128p ps=1.5u w=1.12u l=0.13u
X266 a_11491_6228# a_10649_5878# a_11397_6228# VSS.t311 sg13_lv_nmos ad=0.12665p pd=1.145u as=0.1428p ps=1.52u w=0.42u l=0.13u
X267 VDD.t282 DELAY_VBIASP a_4871_2470# VDD.t3 sg13_lv_pmos ad=0.3808p pd=2.92u as=0.2128p ps=1.5u w=1.12u l=0.6u
X268 a_6126_3816# a_6126_3816# VSS.t326 VSS.t325 sg13_lv_nmos ad=0.38p pd=2.38u as=0.68p ps=4.68u w=2u l=1u
X269 a_3449_331# MUX_SEL2 VDD.t370 VDD.t0 sg13_lv_pmos ad=0.1596p pd=1.22u as=0.2856p ps=2.36u w=0.84u l=0.13u
X270 VDD.t266 VSS.t54 VDD.t264 VDD.t0 sg13_lv_pmos ad=0.19p pd=1.38u as=0 ps=0 w=1u l=1u
X271 a_19073_1842# a_18877_1842# VSS.t215 VSS.t214 sg13_lv_nmos ad=0.2516p pd=2.16u as=0.1406p ps=1.12u w=0.74u l=0.13u
X272 VDD.t336 a_15077_1842# a_15545_1044# VDD.t0 sg13_lv_pmos ad=0.252p pd=1.57u as=0.3808p ps=2.92u w=1.12u l=0.13u
X273 a_19550_1044# a_2019_1047.t4 a_19448_1044# VSS.t400 sg13_lv_nmos ad=0.2516p pd=2.16u as=0.1406p ps=1.12u w=0.74u l=0.13u
X274 VDD.t313 a_12849_5867# a_13306_5105# VDD.t9 sg13_lv_pmos ad=0.36237p pd=2.605u as=79.8f ps=0.8u w=0.42u l=0.13u
X275 VDD.t39 VDD.t37 VDD.t38 VDD.t3 sg13_lv_pmos ad=0.3808p pd=2.92u as=0 ps=0 w=1.12u l=0.6u
X276 VSS.t76 VDD.t393 VSS.t74 VSS.t75 sg13_lv_nmos ad=79.8f pd=0.8u as=0 ps=0 w=0.42u l=1u
X277 a_13592_5871# a_13566_5835# VSS.t123 VSS.t122 sg13_lv_nmos ad=0.2516p pd=2.16u as=0.1626p ps=1.415u w=0.74u l=0.13u
X278 VSS.t191 a_19203_1842# a_19637_1842# VSS.t190 sg13_lv_nmos ad=0.1406p pd=1.12u as=0.2516p ps=2.16u w=0.74u l=0.13u
X279 VDD.t262 VSS.t54 VDD.t205 VDD.t0 sg13_lv_pmos ad=0.19p pd=1.38u as=0 ps=0 w=1u l=1u
X280 a_15108_6109# a_12849_5867# VDD.t48 VDD.t9 sg13_lv_pmos ad=79.8f pd=0.8u as=1.03698p ps=6.245u w=0.42u l=0.13u
X281 VDD.t110 VSS.t32 VDD.t109 VDD.t0 sg13_lv_pmos ad=0.34p pd=2.68u as=0 ps=0 w=1u l=1u
X282 VSS.t196 a_15108_6109# a_14757_6228# VSS.t91 sg13_lv_nmos ad=79.8f pd=0.8u as=0.1428p ps=1.52u w=0.42u l=0.13u
X283 a_27433_1842# a_27237_1842# VDD.t121 VDD.t3 sg13_lv_pmos ad=0.3808p pd=2.92u as=0.2128p ps=1.5u w=1.12u l=0.13u
X284 VDD.t124 a_1256_289# a_2873_331# VDD.t0 sg13_lv_pmos ad=0.1918p pd=1.5u as=0.1596p ps=1.22u w=0.84u l=0.13u
X285 a_13470_1044# a_2595_1047.t6 a_14235_1044# VSS.t611 sg13_lv_nmos ad=0.2516p pd=2.16u as=0.1406p ps=1.12u w=0.74u l=0.13u
X286 VSS.t174 a_9444_4590# a_9444_4590# VSS.t169 sg13_lv_nmos ad=0.68p pd=4.68u as=0.38p ps=2.38u w=2u l=1u
X287 VSS.t187 a_8563_1842# a_8997_1842# VSS.t342 sg13_lv_nmos ad=0.1406p pd=1.12u as=0.2516p ps=2.16u w=0.74u l=0.13u
X288 VSS.t449 VSS.t449 VSS.t451 VSS.t450 sg13_lv_nmos ad=0.2516p pd=2.16u as=0 ps=0 w=0.74u l=0.13u
X289 VSS.t116 DELAY_VBIASN a_13231_1842# VSS.t570 sg13_lv_nmos ad=0.2516p pd=2.16u as=0.1406p ps=1.12u w=0.74u l=0.6u
X290 VDD.t309 a_3171_1047.t7 a_11924_1008# VDD.t0 sg13_lv_pmos ad=0.3808p pd=2.92u as=0.3808p ps=2.92u w=1.12u l=0.13u
X291 VSS.t609 a_2019_1047.t3 a_22564_1008# VSS.t608 sg13_lv_nmos ad=0.2516p pd=2.16u as=0.2516p ps=2.16u w=0.74u l=0.13u
X292 a_15053_5420# a_14111_5227# a_14851_5182# VDD.t9 sg13_lv_pmos ad=93.45f pd=0.865u as=0.2048p ps=1.63u w=0.42u l=0.13u
X293 VSS.t448 VSS.t444 VSS.t444 VSS.t446 sg13_lv_nmos ad=0.1406p pd=1.12u as=0 ps=0 w=0.74u l=0.13u
X294 VSS.t256 a_23003_1842# a_23437_1842# VSS.t255 sg13_lv_nmos ad=0.1406p pd=1.12u as=0.2516p ps=2.16u w=0.74u l=0.13u
X295 VSS.t76 VDD.t392 VSS.t76 VSS.t77 sg13_lv_nmos ad=0.1428p pd=1.52u as=0 ps=0 w=0.42u l=1u
X296 VDD.t279 DELAY_VBIASP a_7151_2470# VDD.t3 sg13_lv_pmos ad=0.3808p pd=2.92u as=0.2128p ps=1.5u w=1.12u l=0.6u
X297 a_5778_3367# VSS.t247 VSS.t246 rppd l=32u w=1u
X298 a_25630_1044# a_25604_1008# a_25528_1044# VDD.t0 sg13_lv_pmos ad=0.3808p pd=2.92u as=0.2128p ps=1.5u w=1.12u l=0.13u
X299 a_10206_5835# a_10649_5878# a_10589_5914# VDD.t9 sg13_lv_pmos ad=79.8f pd=0.8u as=63f ps=0.72u w=0.42u l=0.13u
X300 a_15511_1842# a_15273_1842# a_15403_1842# VSS.t257 sg13_lv_nmos ad=0.1406p pd=1.12u as=0.2516p ps=2.16u w=0.74u l=0.2u
X301 a_10520_6292# a_10751_5878# a_10206_5835# VSS.t391 sg13_lv_nmos ad=0.2373p pd=1.97u as=79.8f ps=0.8u w=0.42u l=0.13u
X302 a_11693_5990# a_10751_5878# a_11491_6228# VDD.t9 sg13_lv_pmos ad=93.45f pd=0.865u as=0.2048p ps=1.63u w=0.42u l=0.13u
X303 a_18313_1842# a_18117_1842# VDD.t61 VDD.t3 sg13_lv_pmos ad=0.3808p pd=2.92u as=0.2128p ps=1.5u w=1.12u l=0.13u
X304 a_5731_289# a_11785_519# a_10430_1044# VDD.t0 sg13_lv_pmos ad=0.3808p pd=2.92u as=0.3808p ps=2.92u w=1.12u l=0.13u
X305 VSS.t17 VDD.t409 VSS.t15 VSS.t16 sg13_lv_nmos ad=79.8f pd=0.8u as=0 ps=0 w=0.42u l=1u
X306 a_9431_2470# a_9193_1842# a_9323_1842# VDD.t3 sg13_lv_pmos ad=0.2128p pd=1.5u as=0.3808p ps=2.92u w=1.12u l=0.2u
X307 a_17275_1044# a_17065_1044# VSS.t80 VSS.t79 sg13_lv_nmos ad=0.1406p pd=1.12u as=0.1665p ps=1.19u w=0.74u l=0.13u
X308 VDD.t248 VSS.t58 VDD.t247 VDD.t0 sg13_lv_pmos ad=0.34p pd=2.68u as=0 ps=0 w=1u l=1u
X309 VSS.t203 a_3747_1047.t6 a_15831_1008# VSS.t202 sg13_lv_nmos ad=0.2516p pd=2.16u as=0.2516p ps=2.16u w=0.74u l=0.13u
X310 a_23871_2470# a_23633_1842# a_23763_1842# VDD.t3 sg13_lv_pmos ad=0.2128p pd=1.5u as=0.3808p ps=2.92u w=1.12u l=0.2u
X311 VSS.t373 a_13883_1842# a_14317_1842# VSS.t476 sg13_lv_nmos ad=0.1406p pd=1.12u as=0.2516p ps=2.16u w=0.74u l=0.13u
X312 VSS.t491 a_3747_311.t2 a_26985_519# VSS.t490 sg13_lv_nmos ad=0.2516p pd=2.16u as=0.2516p ps=2.16u w=0.74u l=0.13u
X313 a_8433_1842# a_8237_1842# VDD.t45 VDD.t3 sg13_lv_pmos ad=0.3808p pd=2.92u as=0.2128p ps=1.5u w=1.12u l=0.13u
X314 VDD.t133 a_18443_1842# a_18877_1842# VDD.t3 sg13_lv_pmos ad=0.2128p pd=1.5u as=0.3808p ps=2.92u w=1.12u l=0.13u
X315 a_22113_1842# a_21917_1842# VDD.t100 VDD.t3 sg13_lv_pmos ad=0.3808p pd=2.92u as=0.2128p ps=1.5u w=1.12u l=0.13u
X316 a_4350_1044# a_2019_1047.t9 a_4248_1044# VSS.t398 sg13_lv_nmos ad=0.2516p pd=2.16u as=0.1406p ps=1.12u w=0.74u l=0.13u
X317 a_14888_1044# a_14317_1842# VSS.t375 VSS.t374 sg13_lv_nmos ad=0.1406p pd=1.12u as=0.2516p ps=2.16u w=0.74u l=0.13u
X318 a_13880_5118# a_13592_5423# a_13818_5118# VSS.t512 sg13_lv_nmos ad=0.1428p pd=1.52u as=37.8f ps=0.6u w=0.42u l=0.13u
X319 a_16108_289# a_3747_311.t2 a_25630_1044# VSS.t489 sg13_lv_nmos ad=0.2516p pd=2.16u as=0.2516p ps=2.16u w=0.74u l=0.13u
X320 VDD.t297 DELAY_VBIASP a_12471_2470# VDD.t3 sg13_lv_pmos ad=0.3808p pd=2.92u as=0.2128p ps=1.5u w=1.12u l=0.6u
X321 VSS.t200 a_4003_1842# a_4437_1842# VSS.t199 sg13_lv_nmos ad=0.1406p pd=1.12u as=0.2516p ps=2.16u w=0.74u l=0.13u
X322 a_16510_1044# a_16484_1008# a_16408_1044# VDD.t0 sg13_lv_pmos ad=0.3808p pd=2.92u as=0.2128p ps=1.5u w=1.12u l=0.13u
X323 VSS.t237 a_13121_5831# a_13045_6215# VSS.t304 sg13_lv_nmos ad=0.2516p pd=2.16u as=0.1406p ps=1.12u w=0.74u l=0.13u
X324 VDD.t224 a_14851_5182# a_15688_5403# VDD.t9 sg13_lv_pmos ad=0.2128p pd=1.5u as=0.3864p ps=2.93u w=1.12u l=0.13u
X325 VDD.t170 a_22243_1842# a_22677_1842# VDD.t3 sg13_lv_pmos ad=0.2128p pd=1.5u as=0.3808p ps=2.92u w=1.12u l=0.13u
X326 VDD.t218 a_3171_1047.t2 a_27124_1008# VDD.t0 sg13_lv_pmos ad=0.3808p pd=2.92u as=0.3808p ps=2.92u w=1.12u l=0.13u
X327 VDD.t203 MUX_SEL3 a_3449_331# VDD.t0 sg13_lv_pmos ad=0.1918p pd=1.5u as=0.1596p ps=1.22u w=0.84u l=0.13u
X328 a_2595_311.t0 a_2297_331# VDD.t95 VDD.t0 sg13_lv_pmos ad=0.2128p pd=1.5u as=0.1918p ps=1.5u w=1.12u l=0.13u
X329 a_10430_1044# a_11271_1008# a_11195_1044# VDD.t0 sg13_lv_pmos ad=0.3808p pd=2.92u as=0.2128p ps=1.5u w=1.12u l=0.13u
X330 a_14009_5084# DELAY_OUT_LAST VSS.t93 VSS.t281 sg13_lv_nmos ad=0.2516p pd=2.16u as=1.45407p ps=9.445u w=0.74u l=0.13u
X331 a_23355_1044# a_23145_1044# VDD.t144 VDD.t0 sg13_lv_pmos ad=0.2128p pd=1.5u as=0.252p ps=1.57u w=1.12u l=0.13u
X332 VDD.t72 a_3747_1047.t4 a_21911_1008# VDD.t0 sg13_lv_pmos ad=0.3808p pd=2.92u as=0.3808p ps=2.92u w=1.12u l=0.13u
X333 VSS.t189 a_8997_1842# a_9465_1044# VSS.t188 sg13_lv_nmos ad=0.1665p pd=1.19u as=0.2516p ps=2.16u w=0.74u l=0.13u
X334 a_13592_5423# a_13566_5328# VDD.t313 VDD.t9 sg13_lv_pmos ad=0.34p pd=2.68u as=0.36237p ps=2.605u w=1u l=0.13u
X335 a_6126_3816# a_5974_5723# a_6326_4590# VSS.t328 sg13_lv_nmos ad=0.68p pd=4.68u as=0.38p ps=2.38u w=2u l=1u
X336 a_20968_1044# a_20397_1842# VDD.t64 VDD.t0 sg13_lv_pmos ad=0.2128p pd=1.5u as=0.3808p ps=2.92u w=1.12u l=0.13u
X337 a_10951_1842# a_10713_1842# a_10843_1842# VSS.t277 sg13_lv_nmos ad=0.1406p pd=1.12u as=0.2516p ps=2.16u w=0.74u l=0.2u
X338 VSS.t366 a_2019_1047.t5 a_16484_1008# VSS.t365 sg13_lv_nmos ad=0.2516p pd=2.16u as=0.2516p ps=2.16u w=0.74u l=0.13u
X339 a_26151_2470# a_25913_1842# a_26043_1842# VDD.t3 sg13_lv_pmos ad=0.2128p pd=1.5u as=0.3808p ps=2.92u w=1.12u l=0.2u
X340 a_9444_4590# a_6854_5454# a_6854_5454# VSS.t110 sg13_lv_nmos ad=0.68p pd=4.68u as=0.38p ps=2.38u w=2u l=1u
X341 a_13753_1842# a_13557_1842# VDD.t65 VDD.t3 sg13_lv_pmos ad=0.3808p pd=2.92u as=0.2128p ps=1.5u w=1.12u l=0.13u
X342 VDD.t229 a_1721_331# a_2019_311# VDD.t0 sg13_lv_pmos ad=0.4256p pd=3u as=0.2128p ps=1.5u w=1.12u l=0.13u
X343 a_4871_2470# a_4633_1842# a_4763_1842# VDD.t3 sg13_lv_pmos ad=0.2128p pd=1.5u as=0.3808p ps=2.92u w=1.12u l=0.2u
X344 VSS.t624 a_3171_1047.t9 a_5844_1008# VSS.t623 sg13_lv_nmos ad=0.2516p pd=2.16u as=0.2516p ps=2.16u w=0.74u l=0.13u
X345 VSS.t43 VDD.t401 VSS.t43 VSS.t45 sg13_lv_nmos ad=79.8f pd=0.8u as=0 ps=0 w=0.42u l=1u
X346 VDD.t47 a_2595_311.t2 a_20905_519# VDD.t0 sg13_lv_pmos ad=0.3808p pd=2.92u as=0.3808p ps=2.92u w=1.12u l=0.13u
X347 VDD.t96 a_2297_331# a_2595_311.t0 VDD.t0 sg13_lv_pmos ad=0.4256p pd=3u as=0.2128p ps=1.5u w=1.12u l=0.13u
X348 a_14009_5084# DELAY_OUT_LAST VDD.t48 VDD.t9 sg13_lv_pmos ad=0.4088p pd=2.97u as=1.10612p ps=6.66u w=1.12u l=0.13u
X349 VSS.t293 a_2595_1047.t7 a_11271_1008# VSS.t322 sg13_lv_nmos ad=0.2516p pd=2.16u as=0.2516p ps=2.16u w=0.74u l=0.13u
X350 VSS.t191 DELAY_VBIASN a_19311_1842# VSS.t573 sg13_lv_nmos ad=0.2516p pd=2.16u as=0.1406p ps=1.12u w=0.74u l=0.6u
X351 VSS.t170 a_9444_4590# a_9444_3912# VSS.t169 sg13_lv_nmos ad=0.68p pd=4.68u as=0.38p ps=2.38u w=2u l=1u
X352 a_13880_5118# a_14111_5227# a_13566_5328# VSS.t404 sg13_lv_nmos ad=0.2373p pd=1.97u as=79.8f ps=0.8u w=0.42u l=0.13u
X353 VDD.t239 a_24523_1842# a_24957_1842# VDD.t3 sg13_lv_pmos ad=0.2128p pd=1.5u as=0.3808p ps=2.92u w=1.12u l=0.13u
X354 VSS.t179 a_3747_1047.t8 a_9751_1008# VSS.t397 sg13_lv_nmos ad=0.2516p pd=2.16u as=0.2516p ps=2.16u w=0.74u l=0.13u
X355 VSS.t181 DELAY_VBIASN a_9431_1842# VSS.t566 sg13_lv_nmos ad=0.2516p pd=2.16u as=0.1406p ps=1.12u w=0.74u l=0.6u
X356 a_19448_1044# a_18877_1842# VDD.t134 VDD.t0 sg13_lv_pmos ad=0.2128p pd=1.5u as=0.3808p ps=2.92u w=1.12u l=0.13u
X357 VSS.t237 a_11491_6228# a_12158_5867# VSS.t357 sg13_lv_nmos ad=0.1406p pd=1.12u as=0.2516p ps=2.16u w=0.74u l=0.13u
X358 a_13566_5328# a_14009_5084# a_13949_5496# VDD.t9 sg13_lv_pmos ad=79.8f pd=0.8u as=63f ps=0.72u w=0.42u l=0.13u
X359 VSS.t256 DELAY_VBIASN a_23111_1842# VSS.t524 sg13_lv_nmos ad=0.2516p pd=2.16u as=0.1406p ps=1.12u w=0.74u l=0.6u
X360 a_10430_1044# a_11924_1008# a_11848_1044# VDD.t0 sg13_lv_pmos ad=0.3808p pd=2.92u as=0.2128p ps=1.5u w=1.12u l=0.13u
X361 VDD.t308 DELAY_VBIASP a_27671_2470# VDD.t3 sg13_lv_pmos ad=0.3808p pd=2.92u as=0.2128p ps=1.5u w=1.12u l=0.6u
X362 a_6854_5986# a_6326_4590# VDD.t10 VDD.t9 sg13_lv_pmos ad=0.38p pd=2.38u as=0.38p ps=2.38u w=2u l=1u
X363 VSS.t528 DELAY_VBIASN DELAY_VBIASP VSS.t527 sg13_lv_nmos ad=0.2516p pd=2.16u as=0.6808p ps=3.32u w=0.74u l=0.6u
X364 a_25630_1044# a_26471_1008# a_26395_1044# VDD.t0 sg13_lv_pmos ad=0.3808p pd=2.92u as=0.2128p ps=1.5u w=1.12u l=0.13u
X365 VSS.t534 DELAY_VBIASN VSS.t536 VSS.t535 sg13_lv_nmos ad=1.33p pd=7.38u as=0 ps=0 w=7u l=7u
X366 a_10040_6305# a_9772_5843# a_9946_6305# VSS.t431 sg13_lv_nmos ad=60.89999f pd=0.71u as=0.1428p ps=1.52u w=0.42u l=0.13u
X367 a_7151_2470# a_6913_1842# a_7043_1842# VDD.t3 sg13_lv_pmos ad=0.2128p pd=1.5u as=0.3808p ps=2.92u w=1.12u l=0.2u
X368 a_16033_1842# a_15837_1842# VDD.t180 VDD.t3 sg13_lv_pmos ad=0.3808p pd=2.92u as=0.2128p ps=1.5u w=1.12u l=0.13u
X369 VDD.t79 a_6326_4590# a_6326_4590# VDD.t9 sg13_lv_pmos ad=0.38p pd=2.38u as=0.38p ps=2.38u w=2u l=1u
X370 VDD.t240 a_15964_289# a_16851_309# VDD.t0 sg13_lv_pmos ad=0.2086p pd=1.5u as=0.34p ps=2.68u w=1u l=0.13u
X371 VDD.t264 VSS.t54 VDD.t263 VDD.t0 sg13_lv_pmos ad=0.34p pd=2.68u as=0 ps=0 w=1u l=1u
X372 a_15464_3684# a_14851_5182# VSS.t339 VSS.t338 sg13_lv_nmos ad=0.2849p pd=2.25u as=0.2516p ps=2.16u w=0.74u l=0.13u
X373 VSS.t264 a_11603_1842# a_12037_1842# VSS.t263 sg13_lv_nmos ad=0.1406p pd=1.12u as=0.2516p ps=2.16u w=0.74u l=0.13u
X374 VSS.t61 VDD.t397 VSS.t59 VSS.t60 sg13_lv_nmos ad=79.8f pd=0.8u as=0 ps=0 w=0.42u l=1u
X375 VDD.t107 VSS.t30 VDD.t391 VDD.t0 sg13_lv_pmos ad=0.34p pd=2.68u as=0 ps=0 w=1u l=1u
X376 VDD.t136 a_5957_1842# a_6425_1044# VDD.t0 sg13_lv_pmos ad=0.252p pd=1.57u as=0.3808p ps=2.92u w=1.12u l=0.13u
X377 a_24393_1842# a_24197_1842# VSS.t208 VSS.t494 sg13_lv_nmos ad=0.2516p pd=2.16u as=0.1406p ps=1.12u w=0.74u l=0.13u
X378 a_3747_1047.t1 a_3449_1395# VSS.t150 VSS.t149 sg13_lv_nmos ad=0.1406p pd=1.12u as=0.1331p ps=1.12u w=0.74u l=0.13u
X379 a_1544_1044# MUX_SEL1 VSS.t244 VSS.t415 sg13_lv_nmos ad=0.2516p pd=2.16u as=0.2516p ps=2.16u w=0.74u l=0.13u
X380 VDD.t205 VSS.t52 VDD.t204 VDD.t0 sg13_lv_pmos ad=0.34p pd=2.68u as=0 ps=0 w=1u l=1u
X381 a_3171_1047.t0 a_2873_1395# VDD.t256 VDD.t0 sg13_lv_pmos ad=0.2128p pd=1.5u as=0.1918p ps=1.5u w=1.12u l=0.13u
X382 a_13470_1044# a_3747_1047.t6 a_15755_1044# VSS.t201 sg13_lv_nmos ad=0.2516p pd=2.16u as=0.1406p ps=1.12u w=0.74u l=0.13u
X383 VDD.t328 a_15464_3684# a_9712_3912# VSS.t468 sg13_lv_nmos ad=0.232p pd=2.08u as=0.136p ps=1.14u w=0.4u l=0.2u
X384 VDD.t71 a_5523_1842# a_5957_1842# VDD.t3 sg13_lv_pmos ad=0.2128p pd=1.5u as=0.3808p ps=2.92u w=1.12u l=0.13u
X385 VDD.t340 a_2297_1395# a_2595_1047.t0 VDD.t0 sg13_lv_pmos ad=0.4256p pd=3u as=0.2128p ps=1.5u w=1.12u l=0.13u
X386 VSS.t371 DELAY_VBIASN a_14751_1842# VSS.t525 sg13_lv_nmos ad=0.2516p pd=2.16u as=0.1406p ps=1.12u w=0.74u l=0.6u
X387 a_2967_1395# MUX_SEL1 a_2873_1395# VSS.t416 sg13_lv_nmos ad=0.1216p pd=1.02u as=0.2176p ps=1.96u w=0.64u l=0.13u
X388 a_4350_1044# a_2595_1047.t9 a_5115_1044# VSS.t487 sg13_lv_nmos ad=0.2516p pd=2.16u as=0.1406p ps=1.12u w=0.74u l=0.13u
X389 VDD.t382 a_2019_1047.t6 a_13444_1008# VDD.t0 sg13_lv_pmos ad=0.3808p pd=2.92u as=0.3808p ps=2.92u w=1.12u l=0.13u
X390 VSS.t99 a_2595_1047.t2 a_26471_1008# VSS.t315 sg13_lv_nmos ad=0.2516p pd=2.16u as=0.2516p ps=2.16u w=0.74u l=0.13u
X391 a_2595_311.t1 a_2297_331# VSS.t146 VSS.t145 sg13_lv_nmos ad=0.1406p pd=1.12u as=0.1331p ps=1.12u w=0.74u l=0.13u
X392 VSS.t90 a_14009_5878# a_14111_5878# VSS.t89 sg13_lv_nmos ad=2.39977p pd=15.495u as=0.2516p ps=2.16u w=0.74u l=0.13u
X393 VSS.t200 DELAY_VBIASN a_4111_1842# VSS.t529 sg13_lv_nmos ad=0.2516p pd=2.16u as=0.1406p ps=1.12u w=0.74u l=0.6u
X394 a_2297_1395# MUX_SEL0 VDD.t331 VDD.t0 sg13_lv_pmos ad=0.1596p pd=1.22u as=0.2856p ps=2.36u w=0.84u l=0.13u
X395 VSS.t80 a_16597_1842# a_17065_1044# VSS.t595 sg13_lv_nmos ad=0.1665p pd=1.19u as=0.2516p ps=2.16u w=0.74u l=0.13u
X396 VDD.t292 DELAY_VBIASP a_8671_2470# VDD.t3 sg13_lv_pmos ad=0.3808p pd=2.92u as=0.2128p ps=1.5u w=1.12u l=0.6u
X397 VDD.t191 VSS.t28 VDD.t92 VDD.t0 sg13_lv_pmos ad=0.19p pd=1.38u as=0 ps=0 w=1u l=1u
X398 VDD.t149 a_1544_1044# a_1721_1395# VDD.t0 sg13_lv_pmos ad=0.1918p pd=1.5u as=0.1596p ps=1.22u w=0.84u l=0.13u
X399 a_9444_4590# a_9444_4590# VSS.t172 VSS.t167 sg13_lv_nmos ad=0.38p pd=2.38u as=0.68p ps=4.68u w=2u l=1u
X400 a_4248_1044# a_4157_1313# VDD.t173 VDD.t0 sg13_lv_pmos ad=0.2128p pd=1.5u as=0.3808p ps=2.92u w=1.12u l=0.13u
X401 a_5778_3367# a_6126_3816# a_6326_4590# VSS.t325 sg13_lv_nmos ad=0.68p pd=4.68u as=0.38p ps=2.38u w=2u l=1u
X402 a_12471_2470# a_12233_1842# a_12363_1842# VDD.t3 sg13_lv_pmos ad=0.2128p pd=1.5u as=0.3808p ps=2.92u w=1.12u l=0.2u
X403 a_17031_1842# a_16793_1842# a_16923_1842# VSS.t232 sg13_lv_nmos ad=0.1406p pd=1.12u as=0.2516p ps=2.16u w=0.74u l=0.2u
X404 VSS.t146 a_1721_331# a_2019_311# VSS.t347 sg13_lv_nmos ad=0.2812p pd=2.24u as=0.1406p ps=1.12u w=0.74u l=0.13u
X405 a_19550_1044# a_21911_1008# a_21835_1044# VDD.t0 sg13_lv_pmos ad=0.3808p pd=2.92u as=0.2128p ps=1.5u w=1.12u l=0.13u
X406 a_16108_289# a_26985_519# a_25630_1044# VDD.t0 sg13_lv_pmos ad=0.3808p pd=2.92u as=0.3808p ps=2.92u w=1.12u l=0.13u
X407 VSS.t146 a_2297_331# a_2595_311.t1 VSS.t147 sg13_lv_nmos ad=0.2812p pd=2.24u as=0.1406p ps=1.12u w=0.74u l=0.13u
X408 a_18795_1044# a_18585_1044# VSS.t105 VSS.t592 sg13_lv_nmos ad=0.1406p pd=1.12u as=0.1665p ps=1.19u w=0.74u l=0.13u
X409 a_9444_3912# a_6854_5454# a_9712_3912# VSS.t110 sg13_lv_nmos ad=0.68p pd=4.68u as=0.38p ps=2.38u w=2u l=1u
X410 a_20831_1842# a_20593_1842# a_20723_1842# VSS.t132 sg13_lv_nmos ad=0.1406p pd=1.12u as=0.2516p ps=2.16u w=0.74u l=0.2u
X411 VSS.t15 VDD.t409 VSS.t14 VSS.t13 sg13_lv_nmos ad=0.1428p pd=1.52u as=0 ps=0 w=0.42u l=1u
X412 VDD.t144 a_22677_1842# a_23145_1044# VDD.t0 sg13_lv_pmos ad=0.252p pd=1.57u as=0.3808p ps=2.92u w=1.12u l=0.13u
X413 VSS.t144 a_2595_1047.t5 a_17351_1008# VSS.t143 sg13_lv_nmos ad=0.2516p pd=2.16u as=0.2516p ps=2.16u w=0.74u l=0.13u
X414 a_5393_1842# a_5197_1842# VSS.t129 VSS.t128 sg13_lv_nmos ad=0.2516p pd=2.16u as=0.1406p ps=1.12u w=0.74u l=0.13u
X415 VSS.t121 DELAY_VBIASN a_17031_1842# VSS.t578 sg13_lv_nmos ad=0.2516p pd=2.16u as=0.1406p ps=1.12u w=0.74u l=0.6u
X416 a_25630_1044# a_3171_1047.t2 a_27048_1044# VSS.t316 sg13_lv_nmos ad=0.2516p pd=2.16u as=0.1406p ps=1.12u w=0.74u l=0.13u
X417 VDD.t24 VDD.t21 VDD.t23 VDD.t22 sg13_lv_pmos ad=0.3808p pd=2.92u as=0 ps=0 w=1.12u l=0.13u
X418 a_9953_1842# a_9757_1842# VDD.t115 VDD.t3 sg13_lv_pmos ad=0.3808p pd=2.92u as=0.2128p ps=1.5u w=1.12u l=0.13u
X419 VDD.t102 a_10843_1842# a_11277_1842# VDD.t3 sg13_lv_pmos ad=0.2128p pd=1.5u as=0.3808p ps=2.92u w=1.12u l=0.13u
X420 VSS.t193 a_26803_1842# a_27237_1842# VSS.t513 sg13_lv_nmos ad=0.1406p pd=1.12u as=0.2516p ps=2.16u w=0.74u l=0.13u
X421 a_4350_1044# a_3171_1047.t9 a_5768_1044# VSS.t622 sg13_lv_nmos ad=0.2516p pd=2.16u as=0.1406p ps=1.12u w=0.74u l=0.13u
X422 VDD.t319 a_12849_5867# a_13566_5328# VDD.t9 sg13_lv_pmos ad=0.1563p pd=1.22u as=0.147p ps=1.54u w=0.42u l=0.13u
X423 VDD.t29 VDD.t30 VDD.t31 VDD.t22 sg13_lv_pmos ad=0.2128p pd=1.5u as=0 ps=0 w=1.12u l=0.13u
X424 a_10430_1044# a_12791_1008# a_12715_1044# VDD.t0 sg13_lv_pmos ad=0.3808p pd=2.92u as=0.2128p ps=1.5u w=1.12u l=0.13u
X425 a_19311_1842# a_19073_1842# a_19203_1842# VSS.t270 sg13_lv_nmos ad=0.1406p pd=1.12u as=0.2516p ps=2.16u w=0.74u l=0.2u
X426 a_24875_1044# a_24665_1044# VDD.t153 VDD.t0 sg13_lv_pmos ad=0.2128p pd=1.5u as=0.252p ps=1.57u w=1.12u l=0.13u
X427 VDD.t386 a_2595_1047.t3 a_23431_1008# VDD.t0 sg13_lv_pmos ad=0.3808p pd=2.92u as=0.3808p ps=2.92u w=1.12u l=0.13u
X428 VDD.t48 a_14009_5878# a_14111_5878# VDD.t9 sg13_lv_pmos ad=1.10612p pd=6.66u as=0.3864p ps=2.93u w=1.12u l=0.13u
X429 a_13949_5914# a_13592_5871# VDD.t315 VDD.t9 sg13_lv_pmos ad=63f pd=0.72u as=0.1563p ps=1.22u w=0.42u l=0.13u
X430 VDD.t66 a_13557_1842# a_14025_1044# VDD.t0 sg13_lv_pmos ad=0.252p pd=1.57u as=0.3808p ps=2.92u w=1.12u l=0.13u
X431 a_23111_1842# a_22873_1842# a_23003_1842# VSS.t226 sg13_lv_nmos ad=0.1406p pd=1.12u as=0.2516p ps=2.16u w=0.74u l=0.2u
X432 VSS.t310 a_10649_5878# a_10751_5878# VSS.t309 sg13_lv_nmos ad=2.39977p pd=15.495u as=0.2516p ps=2.16u w=0.74u l=0.13u
X433 a_27671_2470# a_27433_1842# a_27563_1842# VDD.t3 sg13_lv_pmos ad=0.2128p pd=1.5u as=0.3808p ps=2.92u w=1.12u l=0.2u
X434 VSS.t103 a_17683_1842# a_18117_1842# VSS.t161 sg13_lv_nmos ad=0.1406p pd=1.12u as=0.2516p ps=2.16u w=0.74u l=0.13u
X435 VSS.t54 VDD.t398 VSS.t54 VSS.t56 sg13_lv_nmos ad=79.8f pd=0.8u as=0 ps=0 w=0.42u l=1u
X436 a_10713_1842# a_10517_1842# VSS.t183 VSS.t182 sg13_lv_nmos ad=0.2516p pd=2.16u as=0.1406p ps=1.12u w=0.74u l=0.13u
X437 VSS.t96 a_2019_1047.t8 a_7364_1008# VSS.t95 sg13_lv_nmos ad=0.2516p pd=2.16u as=0.2516p ps=2.16u w=0.74u l=0.13u
X438 VSS.t560 DELAY_VBIASN VSS.t558 VSS.t543 sg13_lv_nmos ad=1.33p pd=7.38u as=0 ps=0 w=7u l=7u
X439 VSS.t83 a_7803_1842# a_8237_1842# VSS.t82 sg13_lv_nmos ad=0.1406p pd=1.12u as=0.2516p ps=2.16u w=0.74u l=0.13u
X440 a_13592_5871# a_14111_5878# a_14851_6228# VSS.t91 sg13_lv_nmos ad=0.3473p pd=2.71u as=0.12665p ps=1.145u w=0.74u l=0.13u
X441 a_15304_4605# a_14851_6228# VSS.t351 VSS.t350 sg13_lv_nmos ad=0.2849p pd=2.25u as=0.2516p ps=2.16u w=0.74u l=0.13u
X442 VDD.t298 DELAY_VBIASP a_16271_2470# VDD.t3 sg13_lv_pmos ad=0.3808p pd=2.92u as=0.2128p ps=1.5u w=1.12u l=0.6u
X443 VSS.t54 VDD.t399 VSS.t52 VSS.t53 sg13_lv_nmos ad=79.8f pd=0.8u as=0 ps=0 w=0.42u l=1u
X444 VSS.t32 VDD.t404 VSS.t32 VSS.t33 sg13_lv_nmos ad=0.1428p pd=1.52u as=0 ps=0 w=0.42u l=1u
X445 a_6854_5454# a_6854_5454# a_9444_4590# VSS.t109 sg13_lv_nmos ad=0.38p pd=2.38u as=0.68p ps=4.68u w=2u l=1u
X446 VDD.t60 a_26043_1842# a_26477_1842# VDD.t3 sg13_lv_pmos ad=0.2128p pd=1.5u as=0.3808p ps=2.92u w=1.12u l=0.13u
X447 VDD.t184 DLL_RESETN a_10206_5835# VDD.t9 sg13_lv_pmos ad=0.1563p pd=1.22u as=0.147p ps=1.54u w=0.42u l=0.13u
X448 a_3543_331# MUX_SEL2 a_3449_331# VSS.t590 sg13_lv_nmos ad=0.1216p pd=1.02u as=0.2176p ps=1.96u w=0.64u l=0.13u
X449 a_22488_1044# a_21917_1842# VSS.t136 VSS.t158 sg13_lv_nmos ad=0.1406p pd=1.12u as=0.2516p ps=2.16u w=0.74u l=0.13u
X450 a_14851_5182# a_14009_5084# a_13592_5423# VDD.t9 sg13_lv_pmos ad=0.2048p pd=1.63u as=0.34p ps=2.68u w=1u l=0.13u
X451 VDD.t169 VSS.t21 VDD.t167 VDD.t0 sg13_lv_pmos ad=0.19p pd=1.38u as=0 ps=0 w=1u l=1u
X452 a_22590_1044# a_24084_1008# a_24008_1044# VDD.t0 sg13_lv_pmos ad=0.3808p pd=2.92u as=0.2128p ps=1.5u w=1.12u l=0.13u
X453 VDD.t296 DELAY_VBIASP a_20071_2470# VDD.t3 sg13_lv_pmos ad=0.3808p pd=2.92u as=0.2128p ps=1.5u w=1.12u l=0.6u
X454 a_9444_3912# a_9444_4590# VSS.t168 VSS.t167 sg13_lv_nmos ad=0.38p pd=2.38u as=0.68p ps=4.68u w=2u l=1u
X455 a_14751_1842# a_14513_1842# a_14643_1842# VSS.t119 sg13_lv_nmos ad=0.1406p pd=1.12u as=0.2516p ps=2.16u w=0.74u l=0.2u
X456 VSS.t380 a_2873_1395# a_3171_1047.t1 VSS.t408 sg13_lv_nmos ad=0.2812p pd=2.24u as=0.1406p ps=1.12u w=0.74u l=0.13u
X457 VDD.t217 VSS.t72 VDD.t216 VDD.t0 sg13_lv_pmos ad=0.19p pd=1.38u as=0 ps=0 w=1u l=1u
X458 a_25630_1044# a_27991_1008# a_27915_1044# VDD.t0 sg13_lv_pmos ad=0.3808p pd=2.92u as=0.2128p ps=1.5u w=1.12u l=0.13u
X459 VSS.t460 VSS.t457 VSS.t457 VSS.t458 sg13_lv_nmos ad=0.1406p pd=1.12u as=0 ps=0 w=0.74u l=0.13u
X460 a_4111_1842# REF_CLK a_4003_1842# VSS.t501 sg13_lv_nmos ad=0.1406p pd=1.12u as=0.2516p ps=2.16u w=0.74u l=0.2u
X461 a_8671_2470# a_8433_1842# a_8563_1842# VDD.t3 sg13_lv_pmos ad=0.2128p pd=1.5u as=0.3808p ps=2.92u w=1.12u l=0.2u
X462 a_17553_1842# a_17357_1842# VDD.t67 VDD.t3 sg13_lv_pmos ad=0.3808p pd=2.92u as=0.2128p ps=1.5u w=1.12u l=0.13u
X463 VSS.t244 a_1544_1044# a_2391_1395# VSS.t245 sg13_lv_nmos ad=0.1331p pd=1.12u as=0.1216p ps=1.02u w=0.64u l=0.13u
X464 VSS.t43 a_3747_311.t3 a_14825_519# VSS.t295 sg13_lv_nmos ad=0.2516p pd=2.16u as=0.2516p ps=2.16u w=0.74u l=0.13u
X465 VSS.t146 a_1256_289# a_2967_331# VSS.t515 sg13_lv_nmos ad=0.1331p pd=1.12u as=0.1216p ps=1.02u w=0.64u l=0.13u
X466 a_2019_1047.t1 a_1721_1395# VSS.t244 VSS.t248 sg13_lv_nmos ad=0.1406p pd=1.12u as=0.1331p ps=1.12u w=0.74u l=0.13u
X467 a_15964_289# a_15765_463# a_5731_289# VSS.t388 sg13_lv_nmos ad=0.2183p pd=1.33u as=0.2516p ps=2.16u w=0.74u l=0.13u
X468 a_13470_1044# a_2019_1047.t6 a_13368_1044# VSS.t604 sg13_lv_nmos ad=0.2516p pd=2.16u as=0.1406p ps=1.12u w=0.74u l=0.13u
X469 VDD.t11 VDD.t8 VDD.t10 VDD.t9 sg13_lv_pmos ad=0.68p pd=4.68u as=0 ps=0 w=2u l=1u
X470 VSS.t116 a_13123_1842# a_13557_1842# VSS.t392 sg13_lv_nmos ad=0.1406p pd=1.12u as=0.2516p ps=2.16u w=0.74u l=0.13u
X471 VDD.t158 VSS.t74 VDD.t213 VDD.t0 sg13_lv_pmos ad=0.34p pd=2.68u as=0 ps=0 w=1u l=1u
X472 VSS.t6 a_3171_1047.t3 a_24084_1008# VSS.t5 sg13_lv_nmos ad=0.2516p pd=2.16u as=0.2516p ps=2.16u w=0.74u l=0.13u
X473 a_25913_1842# a_25717_1842# VSS.t141 VSS.t240 sg13_lv_nmos ad=0.2516p pd=2.16u as=0.1406p ps=1.12u w=0.74u l=0.13u
X474 VDD.t48 a_10649_5878# a_10751_5878# VDD.t9 sg13_lv_pmos ad=1.10612p pd=6.66u as=0.3864p ps=2.93u w=1.12u l=0.13u
X475 a_21353_1842# a_21157_1842# VDD.t360 VDD.t3 sg13_lv_pmos ad=0.3808p pd=2.92u as=0.2128p ps=1.5u w=1.12u l=0.13u
X476 VSS.t59 VDD.t397 VSS.t58 VSS.t57 sg13_lv_nmos ad=0.1428p pd=1.52u as=0 ps=0 w=0.42u l=1u
X477 a_2297_331# MUX_SEL2 VDD.t369 VDD.t0 sg13_lv_pmos ad=0.1596p pd=1.22u as=0.2856p ps=2.36u w=0.84u l=0.13u
X478 VDD.t185 a_7043_1842# a_7477_1842# VDD.t3 sg13_lv_pmos ad=0.2128p pd=1.5u as=0.3808p ps=2.92u w=1.12u l=0.13u
X479 a_2873_331# MUX_SEL3 VDD.t201 VDD.t0 sg13_lv_pmos ad=0.1596p pd=1.22u as=0.2856p ps=2.36u w=0.84u l=0.13u
X480 a_10589_5914# a_10232_5871# VDD.t184 VDD.t9 sg13_lv_pmos ad=63f pd=0.72u as=0.1563p ps=1.22u w=0.42u l=0.13u
X481 a_8155_1044# a_7945_1044# VDD.t157 VDD.t0 sg13_lv_pmos ad=0.2128p pd=1.5u as=0.252p ps=1.57u w=1.12u l=0.13u
X482 a_13880_6292# a_13592_5871# a_13818_6292# VSS.t492 sg13_lv_nmos ad=0.1428p pd=1.52u as=37.8f ps=0.6u w=0.42u l=0.13u
X483 VSS.t105 a_18117_1842# a_18585_1044# VSS.t104 sg13_lv_nmos ad=0.1665p pd=1.19u as=0.2516p ps=2.16u w=0.74u l=0.13u
X484 a_27048_1044# a_26477_1842# VDD.t59 VDD.t0 sg13_lv_pmos ad=0.2128p pd=1.5u as=0.3808p ps=2.92u w=1.12u l=0.13u
X485 a_5768_1044# a_5197_1842# VDD.t69 VDD.t0 sg13_lv_pmos ad=0.2128p pd=1.5u as=0.3808p ps=2.92u w=1.12u l=0.13u
X486 a_10232_5871# a_10751_5878# a_11491_6228# VSS.t311 sg13_lv_nmos ad=0.3473p pd=2.71u as=0.12665p ps=1.145u w=0.74u l=0.13u
X487 a_12656_5864# DLL_RESETN VDD.t322 VDD.t9 sg13_lv_pmos ad=0.3808p pd=2.92u as=0.3808p ps=2.92u w=1.12u l=0.13u
X488 a_13991_2470# a_13753_1842# a_13883_1842# VDD.t3 sg13_lv_pmos ad=0.2128p pd=1.5u as=0.3808p ps=2.92u w=1.12u l=0.2u
X489 VSS.t3 a_3171_1047.t6 a_14964_1008# VSS.t2 sg13_lv_nmos ad=0.2516p pd=2.16u as=0.2516p ps=2.16u w=0.74u l=0.13u
X490 VDD.t183 a_2019_311# a_17865_519# VDD.t0 sg13_lv_pmos ad=0.3808p pd=2.92u as=0.3808p ps=2.92u w=1.12u l=0.13u
X491 DELAY_OUT_LAST a_27997_1842# VSS.t154 VSS.t153 sg13_lv_nmos ad=0.2516p pd=2.16u as=0.1406p ps=1.12u w=0.74u l=0.13u
X492 a_11195_1044# a_10985_1044# VSS.t185 VSS.t367 sg13_lv_nmos ad=0.1406p pd=1.12u as=0.1665p ps=1.19u w=0.74u l=0.13u
X493 VDD.t153 a_24197_1842# a_24665_1044# VDD.t0 sg13_lv_pmos ad=0.252p pd=1.57u as=0.3808p ps=2.92u w=1.12u l=0.13u
X494 a_6913_1842# a_6717_1842# VSS.t356 VSS.t355 sg13_lv_nmos ad=0.2516p pd=2.16u as=0.1406p ps=1.12u w=0.74u l=0.13u
X495 VSS.t215 DELAY_VBIASN a_18551_1842# VSS.t520 sg13_lv_nmos ad=0.2516p pd=2.16u as=0.1406p ps=1.12u w=0.74u l=0.6u
X496 a_16510_1044# a_18004_1008# a_17928_1044# VDD.t0 sg13_lv_pmos ad=0.3808p pd=2.92u as=0.2128p ps=1.5u w=1.12u l=0.13u
X497 a_13592_5423# a_13566_5328# VSS.t420 VSS.t419 sg13_lv_nmos ad=0.2516p pd=2.16u as=0.1626p ps=1.415u w=0.74u l=0.13u
X498 VDD.t140 a_12363_1842# a_12797_1842# VDD.t3 sg13_lv_pmos ad=0.2128p pd=1.5u as=0.3808p ps=2.92u w=1.12u l=0.13u
X499 VSS.t300 MUX_SEL3 a_3543_331# VSS.t299 sg13_lv_nmos ad=0.1331p pd=1.12u as=0.1216p ps=1.02u w=0.64u l=0.13u
X500 a_22590_1044# a_2595_1047.t3 a_23355_1044# VSS.t613 sg13_lv_nmos ad=0.2516p pd=2.16u as=0.1406p ps=1.12u w=0.74u l=0.13u
X501 a_9712_3912# a_6854_5454# a_9444_3912# VSS.t109 sg13_lv_nmos ad=0.38p pd=2.38u as=0.68p ps=4.68u w=2u l=1u
X502 VSS.t261 DELAY_VBIASN a_22351_1842# VSS.t579 sg13_lv_nmos ad=0.2516p pd=2.16u as=0.1406p ps=1.12u w=0.74u l=0.6u
X503 VDD.t267 a_3171_1047.t4 a_21044_1008# VDD.t0 sg13_lv_pmos ad=0.3808p pd=2.92u as=0.3808p ps=2.92u w=1.12u l=0.13u
X504 VDD.t58 VSS.t65 VDD.t56 VDD.t0 sg13_lv_pmos ad=0.19p pd=1.38u as=0 ps=0 w=1u l=1u
X505 a_16271_2470# a_16033_1842# a_16163_1842# VDD.t3 sg13_lv_pmos ad=0.2128p pd=1.5u as=0.3808p ps=2.92u w=1.12u l=0.2u
X506 VDD.t175 VSS.t43 VDD.t52 VDD.t0 sg13_lv_pmos ad=0.19p pd=1.38u as=0 ps=0 w=1u l=1u
X507 a_19833_1842# a_19637_1842# VSS.t191 VSS.t253 sg13_lv_nmos ad=0.2516p pd=2.16u as=0.1406p ps=1.12u w=0.74u l=0.13u
X508 VDD.t182 a_2019_311# a_5705_519# VDD.t0 sg13_lv_pmos ad=0.3808p pd=2.92u as=0.3808p ps=2.92u w=1.12u l=0.13u
X509 VDD.t232 a_14851_6228# a_15108_6109# VDD.t9 sg13_lv_pmos ad=0.2639p pd=1.81u as=79.8f ps=0.8u w=0.42u l=0.13u
X510 a_10520_6292# a_10232_5871# a_10458_6292# VSS.t276 sg13_lv_nmos ad=0.1428p pd=1.52u as=37.8f ps=0.6u w=0.42u l=0.13u
X511 a_15270_6305# a_12849_5867# VSS.t196 VSS.t91 sg13_lv_nmos ad=37.8f pd=0.6u as=79.8f ps=0.8u w=0.42u l=0.13u
X512 a_20071_2470# a_19833_1842# a_19963_1842# VDD.t3 sg13_lv_pmos ad=0.2128p pd=1.5u as=0.3808p ps=2.92u w=1.12u l=0.2u
X513 a_9193_1842# a_8997_1842# VSS.t187 VSS.t186 sg13_lv_nmos ad=0.2516p pd=2.16u as=0.1406p ps=1.12u w=0.74u l=0.13u
X514 a_24631_1842# a_24393_1842# a_24523_1842# VSS.t376 sg13_lv_nmos ad=0.1406p pd=1.12u as=0.2516p ps=2.16u w=0.74u l=0.2u
X515 VDD.t177 VSS.t43 VDD.t176 VDD.t0 sg13_lv_pmos ad=0.34p pd=2.68u as=0 ps=0 w=1u l=1u
X516 VSS.t411 a_2019_1047.t7 a_10404_1008# VSS.t410 sg13_lv_nmos ad=0.2516p pd=2.16u as=0.2516p ps=2.16u w=0.74u l=0.13u
X517 VSS.t540 DELAY_VBIASN VSS.t542 VSS.t541 sg13_lv_nmos ad=1.33p pd=7.38u as=0 ps=0 w=7u l=7u
X518 VDD.t252 a_14643_1842# a_15077_1842# VDD.t3 sg13_lv_pmos ad=0.2128p pd=1.5u as=0.3808p ps=2.92u w=1.12u l=0.13u
X519 VDD.t95 a_1544_289# a_2297_331# VDD.t0 sg13_lv_pmos ad=0.1918p pd=1.5u as=0.1596p ps=1.22u w=0.84u l=0.13u
X520 a_23633_1842# a_23437_1842# VSS.t256 VSS.t345 sg13_lv_nmos ad=0.2516p pd=2.16u as=0.1406p ps=1.12u w=0.74u l=0.13u
X521 VSS.t54 VDD.t398 VSS.t54 VSS.t55 sg13_lv_nmos ad=0.1428p pd=1.52u as=0 ps=0 w=0.42u l=1u
X522 a_2019_311# a_1721_331# VDD.t189 VDD.t0 sg13_lv_pmos ad=0.2128p pd=1.5u as=0.1918p ps=1.5u w=1.12u l=0.13u
X523 VSS.t181 a_9323_1842# a_9757_1842# VSS.t601 sg13_lv_nmos ad=0.1406p pd=1.12u as=0.2516p ps=2.16u w=0.74u l=0.13u
X524 a_26395_1044# a_26185_1044# VSS.t242 VSS.t602 sg13_lv_nmos ad=0.1406p pd=1.12u as=0.1665p ps=1.19u w=0.74u l=0.13u
X525 VDD.t276 DELAY_VBIASP a_17791_2470# VDD.t3 sg13_lv_pmos ad=0.3808p pd=2.92u as=0.2128p ps=1.5u w=1.12u l=0.6u
X526 VSS.t206 a_3747_1047.t3 a_24951_1008# VSS.t205 sg13_lv_nmos ad=0.2516p pd=2.16u as=0.2516p ps=2.16u w=0.74u l=0.13u
X527 VSS.t30 VDD.t405 VSS.t30 VSS.t29 sg13_lv_nmos ad=0.1428p pd=1.52u as=0 ps=0 w=0.42u l=1u
X528 VSS.t52 VDD.t399 VSS.t52 VSS.t51 sg13_lv_nmos ad=0.1428p pd=1.52u as=0 ps=0 w=0.42u l=1u
X529 a_3747_1047.t0 a_3449_1395# VDD.t97 VDD.t0 sg13_lv_pmos ad=0.2128p pd=1.5u as=0.1918p ps=1.5u w=1.12u l=0.13u
X530 a_13368_1044# a_12797_1842# VDD.t141 VDD.t0 sg13_lv_pmos ad=0.2128p pd=1.5u as=0.3808p ps=2.92u w=1.12u l=0.13u
X531 a_24008_1044# a_23437_1842# VSS.t344 VSS.t343 sg13_lv_nmos ad=0.1406p pd=1.12u as=0.2516p ps=2.16u w=0.74u l=0.13u
X532 VDD.t283 DELAY_VBIASP a_21591_2470# VDD.t3 sg13_lv_pmos ad=0.3808p pd=2.92u as=0.2128p ps=1.5u w=1.12u l=0.6u
X533 a_15964_289# MUX_SEL4 a_5731_289# VDD.t0 sg13_lv_pmos ad=0.3304p pd=1.71u as=0.3808p ps=2.92u w=1.12u l=0.13u
X534 a_4350_1044# a_6711_1008# a_6635_1044# VDD.t0 sg13_lv_pmos ad=0.3808p pd=2.92u as=0.2128p ps=1.5u w=1.12u l=0.13u
X535 a_2873_1395# MUX_SEL1 VDD.t312 VDD.t0 sg13_lv_pmos ad=0.1596p pd=1.22u as=0.2856p ps=2.36u w=0.84u l=0.13u
X536 VSS.t420 a_12849_5867# a_13400_5105# VSS.t422 sg13_lv_nmos ad=0.1626p pd=1.415u as=60.89999f ps=0.71u w=0.42u l=0.13u
X537 a_1256_1044# MUX_SEL0 VSS.t244 VSS.t469 sg13_lv_nmos ad=0.2516p pd=2.16u as=0.2516p ps=2.16u w=0.74u l=0.13u
X538 VSS.t28 VDD.t406 VSS.t26 VSS.t27 sg13_lv_nmos ad=79.8f pd=0.8u as=0 ps=0 w=0.42u l=1u
X539 a_19550_1044# a_20391_1008# a_20315_1044# VDD.t0 sg13_lv_pmos ad=0.3808p pd=2.92u as=0.2128p ps=1.5u w=1.12u l=0.13u
X540 VDD.t42 VDD.t40 VDD.t39 VDD.t3 sg13_lv_pmos ad=0.2128p pd=1.5u as=0 ps=0 w=1.12u l=0.2u
X541 a_5631_1842# a_5393_1842# a_5523_1842# VSS.t594 sg13_lv_nmos ad=0.1406p pd=1.12u as=0.2516p ps=2.16u w=0.74u l=0.2u
X542 a_14513_1842# a_14317_1842# VSS.t373 VSS.t372 sg13_lv_nmos ad=0.2516p pd=2.16u as=0.1406p ps=1.12u w=0.74u l=0.13u
X543 VSS.t58 a_2595_311.t2 a_20905_519# VSS.t87 sg13_lv_nmos ad=0.2516p pd=2.16u as=0.2516p ps=2.16u w=0.74u l=0.13u
X544 VDD.t157 a_7477_1842# a_7945_1044# VDD.t0 sg13_lv_pmos ad=0.252p pd=1.57u as=0.3808p ps=2.92u w=1.12u l=0.13u
X545 a_13470_1044# a_3171_1047.t6 a_14888_1044# VSS.t1 sg13_lv_nmos ad=0.2516p pd=2.16u as=0.1406p ps=1.12u w=0.74u l=0.13u
X546 a_4633_1842# a_4437_1842# VSS.t200 VSS.t502 sg13_lv_nmos ad=0.2516p pd=2.16u as=0.1406p ps=1.12u w=0.74u l=0.13u
X547 a_1256_289# MUX_SEL2 VSS.t297 VSS.t588 sg13_lv_nmos ad=0.2516p pd=2.16u as=0.2516p ps=2.16u w=0.74u l=0.13u
X548 VSS.t211 a_2019_1047.t2 a_25604_1008# VSS.t210 sg13_lv_nmos ad=0.2516p pd=2.16u as=0.2516p ps=2.16u w=0.74u l=0.13u
X549 a_13019_5831# a_15688_5403# VDD.t224 VDD.t9 sg13_lv_pmos ad=0.3808p pd=2.92u as=0.2128p ps=1.5u w=1.12u l=0.13u
X550 VSS.t536 DELAY_VBIASN VSS.t538 VSS.t537 sg13_lv_nmos ad=1.33p pd=7.38u as=0 ps=0 w=7u l=7u
X551 a_16108_289# MUX_SEL4 a_15964_289# VSS.t389 sg13_lv_nmos ad=0.2516p pd=2.16u as=0.2183p ps=1.33u w=0.74u l=0.13u
X552 a_13400_6305# a_12355_5867# a_13306_6305# VSS.t81 sg13_lv_nmos ad=60.89999f pd=0.71u as=0.1428p ps=1.52u w=0.42u l=0.13u
X553 a_22873_1842# a_22677_1842# VDD.t170 VDD.t3 sg13_lv_pmos ad=0.3808p pd=2.92u as=0.2128p ps=1.5u w=1.12u l=0.13u
X554 a_21835_1044# a_21625_1044# VSS.t302 VSS.t301 sg13_lv_nmos ad=0.1406p pd=1.12u as=0.1665p ps=1.19u w=0.74u l=0.13u
X555 VSS.t114 a_2595_1047.t4 a_20391_1008# VSS.t507 sg13_lv_nmos ad=0.2516p pd=2.16u as=0.2516p ps=2.16u w=0.74u l=0.13u
X556 a_9675_1044# a_9465_1044# VDD.t119 VDD.t0 sg13_lv_pmos ad=0.2128p pd=1.5u as=0.252p ps=1.57u w=1.12u l=0.13u
X557 VSS.t185 a_10517_1842# a_10985_1044# VSS.t184 sg13_lv_nmos ad=0.1665p pd=1.19u as=0.2516p ps=2.16u w=0.74u l=0.13u
X558 VDD.t219 a_2595_1047.t8 a_8231_1008# VDD.t0 sg13_lv_pmos ad=0.3808p pd=2.92u as=0.3808p ps=2.92u w=1.12u l=0.13u
X559 a_18551_1842# a_18313_1842# a_18443_1842# VSS.t278 sg13_lv_nmos ad=0.1406p pd=1.12u as=0.2516p ps=2.16u w=0.74u l=0.2u
X560 a_12943_5867# a_12656_5864# a_12849_5867# VDD.t9 sg13_lv_pmos ad=0.2128p pd=1.5u as=0.3808p ps=2.92u w=1.12u l=0.13u
X561 a_13566_5835# a_14009_5878# a_13949_5914# VDD.t9 sg13_lv_pmos ad=79.8f pd=0.8u as=63f ps=0.72u w=0.42u l=0.13u
X562 a_22351_1842# a_22113_1842# a_22243_1842# VSS.t133 sg13_lv_nmos ad=0.1406p pd=1.12u as=0.2516p ps=2.16u w=0.74u l=0.2u
X563 VSS.t217 a_3747_1047.t5 a_18871_1008# VSS.t290 sg13_lv_nmos ad=0.2516p pd=2.16u as=0.2516p ps=2.16u w=0.74u l=0.13u
X564 VSS.t121 a_16923_1842# a_17357_1842# VSS.t120 sg13_lv_nmos ad=0.1406p pd=1.12u as=0.2516p ps=2.16u w=0.74u l=0.13u
X565 VDD.t212 a_3171_311.t2 a_23945_519# VDD.t0 sg13_lv_pmos ad=0.3808p pd=2.92u as=0.3808p ps=2.92u w=1.12u l=0.13u
X566 a_2019_311# a_1721_331# VSS.t146 VSS.t346 sg13_lv_nmos ad=0.1406p pd=1.12u as=0.1331p ps=1.12u w=0.74u l=0.13u
X567 a_25153_1842# a_24957_1842# VDD.t239 VDD.t3 sg13_lv_pmos ad=0.3808p pd=2.92u as=0.2128p ps=1.5u w=1.12u l=0.13u
X568 a_17928_1044# a_17357_1842# VSS.t144 VSS.t598 sg13_lv_nmos ad=0.1406p pd=1.12u as=0.2516p ps=2.16u w=0.74u l=0.13u
X569 a_12715_1044# a_12505_1044# VSS.t324 VSS.t323 sg13_lv_nmos ad=0.1406p pd=1.12u as=0.1665p ps=1.19u w=0.74u l=0.13u
X570 a_13880_6292# a_14111_5878# a_13566_5835# VSS.t377 sg13_lv_nmos ad=0.2373p pd=1.97u as=79.8f ps=0.8u w=0.42u l=0.13u
X571 a_15053_5990# a_14111_5878# a_14851_6228# VDD.t9 sg13_lv_pmos ad=93.45f pd=0.865u as=0.2048p ps=1.63u w=0.42u l=0.13u
X572 VDD.t259 MUX_SEL4 a_15765_463# VDD.t0 sg13_lv_pmos ad=0.3808p pd=2.92u as=0.3808p ps=2.92u w=1.12u l=0.13u
X573 a_19550_1044# a_3171_1047.t4 a_20968_1044# VSS.t393 sg13_lv_nmos ad=0.2516p pd=2.16u as=0.1406p ps=1.12u w=0.74u l=0.13u
X574 VSS.t160 DELAY_VBIASN a_10951_1842# VSS.t568 sg13_lv_nmos ad=0.2516p pd=2.16u as=0.1406p ps=1.12u w=0.74u l=0.6u
X575 a_19550_1044# a_19524_1008# a_19448_1044# VDD.t0 sg13_lv_pmos ad=0.3808p pd=2.92u as=0.2128p ps=1.5u w=1.12u l=0.13u
X576 a_7288_1044# a_6717_1842# VSS.t307 VSS.t354 sg13_lv_nmos ad=0.1406p pd=1.12u as=0.2516p ps=2.16u w=0.74u l=0.13u
X577 a_12355_5867# a_12158_5867# VSS.t237 VSS.t236 sg13_lv_nmos ad=0.2516p pd=2.16u as=0.1406p ps=1.12u w=0.74u l=0.13u
X578 VSS.t511 a_20723_1842# a_21157_1842# VSS.t610 sg13_lv_nmos ad=0.1406p pd=1.12u as=0.2516p ps=2.16u w=0.74u l=0.13u
X579 VDD.t234 a_14851_6228# a_15688_5867# VDD.t9 sg13_lv_pmos ad=0.2128p pd=1.5u as=0.3864p ps=2.93u w=1.12u l=0.13u
X580 a_1544_289# MUX_SEL3 VSS.t297 VSS.t296 sg13_lv_nmos ad=0.2516p pd=2.16u as=0.2516p ps=2.16u w=0.74u l=0.13u
X581 a_13470_1044# a_14311_1008# a_14235_1044# VDD.t0 sg13_lv_pmos ad=0.3808p pd=2.92u as=0.2128p ps=1.5u w=1.12u l=0.13u
X582 a_22590_1044# a_3747_1047.t3 a_24875_1044# VSS.t204 sg13_lv_nmos ad=0.2516p pd=2.16u as=0.1406p ps=1.12u w=0.74u l=0.13u
X583 VSS.t208 DELAY_VBIASN a_23871_1842# VSS.t518 sg13_lv_nmos ad=0.2516p pd=2.16u as=0.1406p ps=1.12u w=0.74u l=0.6u
X584 VDD.t383 a_2019_1047.t3 a_22564_1008# VDD.t0 sg13_lv_pmos ad=0.3808p pd=2.92u as=0.3808p ps=2.92u w=1.12u l=0.13u
X585 VSS.t242 a_25717_1842# a_26185_1044# VSS.t241 sg13_lv_nmos ad=0.1665p pd=1.19u as=0.2516p ps=2.16u w=0.74u l=0.13u
X586 a_13231_1842# a_12993_1842# a_13123_1842# VSS.t0 sg13_lv_nmos ad=0.1406p pd=1.12u as=0.2516p ps=2.16u w=0.74u l=0.2u
X587 VSS.t21 VDD.t407 VSS.t21 VSS.t23 sg13_lv_nmos ad=79.8f pd=0.8u as=0 ps=0 w=0.42u l=1u
X588 a_17791_2470# a_17553_1842# a_17683_1842# VDD.t3 sg13_lv_pmos ad=0.2128p pd=1.5u as=0.3808p ps=2.92u w=1.12u l=0.2u
X589 VSS.t224 a_4437_1842# a_4905_1044# VSS.t503 sg13_lv_nmos ad=0.1665p pd=1.19u as=0.2516p ps=2.16u w=0.74u l=0.13u
X590 VDD.t56 VSS.t65 VDD.t55 VDD.t0 sg13_lv_pmos ad=0.34p pd=2.68u as=0 ps=0 w=1u l=1u
X591 a_12233_1842# a_12037_1842# VSS.t264 VSS.t482 sg13_lv_nmos ad=0.2516p pd=2.16u as=0.1406p ps=1.12u w=0.74u l=0.13u
X592 VDD.t48 a_9547_6172# a_9547_5942# VDD.t9 sg13_lv_pmos ad=1.10612p pd=6.66u as=0.2442p ps=2.06u w=0.66u l=0.13u
X593 a_15108_5325# a_14851_5182# a_15270_5105# VSS.t337 sg13_lv_nmos ad=0.1428p pd=1.52u as=37.8f ps=0.6u w=0.42u l=0.13u
X594 VSS.t152 a_3449_1395# a_3747_1047.t1 VSS.t151 sg13_lv_nmos ad=0.2812p pd=2.24u as=0.1406p ps=1.12u w=0.74u l=0.13u
X595 VDD.t52 VSS.t41 VDD.t51 VDD.t0 sg13_lv_pmos ad=0.34p pd=2.68u as=0 ps=0 w=1u l=1u
X596 VDD.t211 VSS.t50 VDD.t104 VDD.t0 sg13_lv_pmos ad=0.19p pd=1.38u as=0 ps=0 w=1u l=1u
X597 VSS.t72 VDD.t394 VSS.t70 VSS.t71 sg13_lv_nmos ad=79.8f pd=0.8u as=0 ps=0 w=0.42u l=1u
X598 VSS.t620 a_3171_1047.t8 a_8884_1008# VSS.t619 sg13_lv_nmos ad=0.2516p pd=2.16u as=0.2516p ps=2.16u w=0.74u l=0.13u
X599 a_21591_2470# a_21353_1842# a_21483_1842# VDD.t3 sg13_lv_pmos ad=0.2128p pd=1.5u as=0.3808p ps=2.92u w=1.12u l=0.2u
X600 VDD.t273 a_2873_1395# a_3171_1047.t0 VDD.t0 sg13_lv_pmos ad=0.4256p pd=3u as=0.2128p ps=1.5u w=1.12u l=0.13u
X601 a_6153_1842# a_5957_1842# VDD.t71 VDD.t3 sg13_lv_pmos ad=0.3808p pd=2.92u as=0.2128p ps=1.5u w=1.12u l=0.13u
X602 VDD.t334 a_16163_1842# a_16597_1842# VDD.t3 sg13_lv_pmos ad=0.2128p pd=1.5u as=0.3808p ps=2.92u w=1.12u l=0.13u
X603 a_3543_1395# MUX_SEL0 a_3449_1395# VSS.t471 sg13_lv_nmos ad=0.1216p pd=1.02u as=0.2176p ps=1.96u w=0.64u l=0.13u
X604 VDD.t150 a_1544_1044# a_2297_1395# VDD.t0 sg13_lv_pmos ad=0.1918p pd=1.5u as=0.1596p ps=1.22u w=0.84u l=0.13u
X605 VDD.t286 DELAY_VBIASP a_10191_2470# VDD.t3 sg13_lv_pmos ad=0.3808p pd=2.92u as=0.2128p ps=1.5u w=1.12u l=0.6u
X606 a_17275_1044# a_17065_1044# VDD.t43 VDD.t0 sg13_lv_pmos ad=0.2128p pd=1.5u as=0.252p ps=1.57u w=1.12u l=0.13u
X607 a_2019_1047.t0 a_1721_1395# VDD.t149 VDD.t0 sg13_lv_pmos ad=0.2128p pd=1.5u as=0.1918p ps=1.5u w=1.12u l=0.13u
X608 a_27915_1044# a_27705_1044# VSS.t195 VSS.t591 sg13_lv_nmos ad=0.1406p pd=1.12u as=0.1665p ps=1.19u w=0.74u l=0.13u
X609 VSS.t101 DELAY_VBIASN a_26151_1842# VSS.t581 sg13_lv_nmos ad=0.2516p pd=2.16u as=0.1406p ps=1.12u w=0.74u l=0.6u
X610 VDD.t128 a_3747_1047.t6 a_15831_1008# VDD.t0 sg13_lv_pmos ad=0.3808p pd=2.92u as=0.3808p ps=2.92u w=1.12u l=0.13u
X611 VDD.t63 a_19963_1842# a_20397_1842# VDD.t3 sg13_lv_pmos ad=0.2128p pd=1.5u as=0.3808p ps=2.92u w=1.12u l=0.13u
X612 VSS.t74 VDD.t393 VSS.t74 VSS.t73 sg13_lv_nmos ad=0.1428p pd=1.52u as=0 ps=0 w=0.42u l=1u
X613 VSS.t129 DELAY_VBIASN a_4871_1842# VSS.t563 sg13_lv_nmos ad=0.2516p pd=2.16u as=0.1406p ps=1.12u w=0.74u l=0.6u
X614 a_14888_1044# a_14317_1842# VDD.t254 VDD.t0 sg13_lv_pmos ad=0.2128p pd=1.5u as=0.3808p ps=2.92u w=1.12u l=0.13u
X615 a_4350_1044# a_4324_1008# a_4248_1044# VDD.t0 sg13_lv_pmos ad=0.3808p pd=2.92u as=0.2128p ps=1.5u w=1.12u l=0.13u
X616 a_1256_289# MUX_SEL2 VDD.t368 VDD.t0 sg13_lv_pmos ad=0.3808p pd=2.92u as=0.3808p ps=2.92u w=1.12u l=0.13u
X617 VSS.t464 VSS.t461 VSS.t463 VSS.t462 sg13_lv_nmos ad=0.2516p pd=2.16u as=0 ps=0 w=0.74u l=0.6u
X618 a_16108_289# a_15765_463# a_15964_289# VDD.t0 sg13_lv_pmos ad=0.3808p pd=2.92u as=0.3304p ps=1.71u w=1.12u l=0.13u
X619 VDD.t315 a_12849_5867# a_13566_5835# VDD.t9 sg13_lv_pmos ad=0.1563p pd=1.22u as=0.147p ps=1.54u w=0.42u l=0.13u
X620 VSS.t532 DELAY_VBIASN VSS.t531 VSS.t530 sg13_lv_nmos ad=2.38p pd=14.68u as=0 ps=0 w=7u l=7u
X621 a_11473_1842# a_11277_1842# VDD.t102 VDD.t3 sg13_lv_pmos ad=0.3808p pd=2.92u as=0.2128p ps=1.5u w=1.12u l=0.13u
X622 VDD.t119 a_8997_1842# a_9465_1044# VDD.t0 sg13_lv_pmos ad=0.252p pd=1.57u as=0.3808p ps=2.92u w=1.12u l=0.13u
X623 a_27433_1842# a_27237_1842# VSS.t193 VSS.t192 sg13_lv_nmos ad=0.2516p pd=2.16u as=0.1406p ps=1.12u w=0.74u l=0.13u
X624 a_2391_331# MUX_SEL2 a_2297_331# VSS.t589 sg13_lv_nmos ad=0.1216p pd=1.02u as=0.2176p ps=1.96u w=0.64u l=0.13u
X625 a_2967_331# MUX_SEL3 a_2873_331# VSS.t298 sg13_lv_nmos ad=0.1216p pd=1.02u as=0.2176p ps=1.96u w=0.64u l=0.13u
X626 VDD.t242 a_2019_1047.t5 a_16484_1008# VDD.t0 sg13_lv_pmos ad=0.3808p pd=2.92u as=0.3808p ps=2.92u w=1.12u l=0.13u
X627 a_7390_1044# a_2595_1047.t8 a_8155_1044# VSS.t319 sg13_lv_nmos ad=0.2516p pd=2.16u as=0.1406p ps=1.12u w=0.74u l=0.13u
X628 VSS.t332 a_6126_3816# a_5974_5723# VSS.t328 sg13_lv_nmos ad=0.68p pd=4.68u as=0.38p ps=2.38u w=2u l=1u
X629 VSS.t280 DELAY_VBIASN a_7151_1842# VSS.t564 sg13_lv_nmos ad=0.2516p pd=2.16u as=0.1406p ps=1.12u w=0.74u l=0.6u
X630 VDD.t390 a_3171_1047.t9 a_5844_1008# VDD.t0 sg13_lv_pmos ad=0.3808p pd=2.92u as=0.3808p ps=2.92u w=1.12u l=0.13u
X631 VDD.t295 DELAY_VBIASP a_25391_2470# VDD.t3 sg13_lv_pmos ad=0.3808p pd=2.92u as=0.2128p ps=1.5u w=1.12u l=0.6u
X632 VDD.t220 a_2595_1047.t7 a_11271_1008# VDD.t0 sg13_lv_pmos ad=0.3808p pd=2.92u as=0.3808p ps=2.92u w=1.12u l=0.13u
X633 VDD.t112 VSS.t32 VDD.t110 VDD.t0 sg13_lv_pmos ad=0.19p pd=1.38u as=0 ps=0 w=1u l=1u
X634 VSS.t324 a_12037_1842# a_12505_1044# VSS.t483 sg13_lv_nmos ad=0.1665p pd=1.19u as=0.2516p ps=2.16u w=0.74u l=0.13u
X635 VDD.t268 a_3747_1047.t8 a_9751_1008# VDD.t0 sg13_lv_pmos ad=0.3808p pd=2.92u as=0.3808p ps=2.92u w=1.12u l=0.13u
X636 a_12943_5867# a_13121_5831# VDD.t207 VDD.t9 sg13_lv_pmos ad=0.3808p pd=2.92u as=0.2128p ps=1.5u w=1.12u l=0.13u
X637 a_11748_6109# a_11491_6228# a_11910_6305# VSS.t311 sg13_lv_nmos ad=0.1428p pd=1.52u as=37.8f ps=0.6u w=0.42u l=0.13u
X638 a_9431_1842# a_9193_1842# a_9323_1842# VSS.t231 sg13_lv_nmos ad=0.1406p pd=1.12u as=0.2516p ps=2.16u w=0.74u l=0.2u
X639 a_18313_1842# a_18117_1842# VSS.t103 VSS.t102 sg13_lv_nmos ad=0.2516p pd=2.16u as=0.1406p ps=1.12u w=0.74u l=0.13u
X640 MUX_OUT a_16851_309# VSS.t362 VSS.t361 sg13_lv_nmos ad=0.1406p pd=1.12u as=0.1371p ps=1.12u w=0.74u l=0.13u
X641 a_10232_5871# a_10206_5835# VDD.t113 VDD.t9 sg13_lv_pmos ad=0.34p pd=2.68u as=0.36237p ps=2.605u w=1u l=0.13u
X642 a_14851_5182# a_14009_5084# a_14757_5182# VSS.t474 sg13_lv_nmos ad=0.12665p pd=1.145u as=0.1428p ps=1.52u w=0.42u l=0.13u
X643 VSS.t65 VDD.t395 VSS.t65 VSS.t67 sg13_lv_nmos ad=79.8f pd=0.8u as=0 ps=0 w=0.42u l=1u
X644 a_23871_1842# a_23633_1842# a_23763_1842# VSS.t586 sg13_lv_nmos ad=0.1406p pd=1.12u as=0.2516p ps=2.16u w=0.74u l=0.2u
X645 a_8433_1842# a_8237_1842# VSS.t83 VSS.t139 sg13_lv_nmos ad=0.2516p pd=2.16u as=0.1406p ps=1.12u w=0.74u l=0.13u
X646 VSS.t215 a_18443_1842# a_18877_1842# VSS.t225 sg13_lv_nmos ad=0.1406p pd=1.12u as=0.2516p ps=2.16u w=0.74u l=0.13u
X647 VSS.t43 VDD.t402 VSS.t41 VSS.t42 sg13_lv_nmos ad=79.8f pd=0.8u as=0 ps=0 w=0.42u l=1u
X648 VSS.t330 a_6126_3816# a_5974_5723# VSS.t328 sg13_lv_nmos ad=0.68p pd=4.68u as=0.38p ps=2.38u w=2u l=1u
X649 a_22113_1842# a_21917_1842# VSS.t157 VSS.t156 sg13_lv_nmos ad=0.2516p pd=2.16u as=0.1406p ps=1.12u w=0.74u l=0.13u
X650 a_1544_289# MUX_SEL3 VDD.t202 VDD.t0 sg13_lv_pmos ad=0.3808p pd=2.92u as=0.3808p ps=2.92u w=1.12u l=0.13u
X651 VDD.t20 VDD.t12 VDD.t19 VDD.t9 sg13_lv_pmos ad=0.38p pd=2.38u as=0 ps=0 w=2u l=1u
X652 a_26673_1842# a_26477_1842# VDD.t60 VDD.t3 sg13_lv_pmos ad=0.3808p pd=2.92u as=0.2128p ps=1.5u w=1.12u l=0.13u
X653 a_10328_1044# a_9757_1842# VSS.t179 VSS.t178 sg13_lv_nmos ad=0.1406p pd=1.12u as=0.2516p ps=2.16u w=0.74u l=0.13u
X654 VSS.t43 VDD.t401 VSS.t43 VSS.t44 sg13_lv_nmos ad=0.1428p pd=1.52u as=0 ps=0 w=0.42u l=1u
X655 a_22590_1044# a_2019_1047.t3 a_22488_1044# VSS.t607 sg13_lv_nmos ad=0.2516p pd=2.16u as=0.1406p ps=1.12u w=0.74u l=0.13u
X656 VSS.t228 DELAY_VBIASN a_12471_1842# VSS.t567 sg13_lv_nmos ad=0.2516p pd=2.16u as=0.1406p ps=1.12u w=0.74u l=0.6u
X657 a_8808_1044# a_8237_1842# VSS.t138 VSS.t137 sg13_lv_nmos ad=0.1406p pd=1.12u as=0.2516p ps=2.16u w=0.74u l=0.13u
X658 VSS.t261 a_22243_1842# a_22677_1842# VSS.t285 sg13_lv_nmos ad=0.1406p pd=1.12u as=0.2516p ps=2.16u w=0.74u l=0.13u
X659 VDD.t291 DELAY_VBIASP a_6391_2470# VDD.t3 sg13_lv_pmos ad=0.3808p pd=2.92u as=0.2128p ps=1.5u w=1.12u l=0.6u
X660 a_13470_1044# a_15831_1008# a_15755_1044# VDD.t0 sg13_lv_pmos ad=0.3808p pd=2.92u as=0.2128p ps=1.5u w=1.12u l=0.13u
X661 a_1544_1044# MUX_SEL1 VDD.t311 VDD.t0 sg13_lv_pmos ad=0.3808p pd=2.92u as=0.3808p ps=2.92u w=1.12u l=0.13u
X662 VDD.t284 DELAY_VBIASP a_20831_2470# VDD.t3 sg13_lv_pmos ad=0.3808p pd=2.92u as=0.2128p ps=1.5u w=1.12u l=0.6u
X663 VDD.t215 a_2595_1047.t2 a_26471_1008# VDD.t0 sg13_lv_pmos ad=0.3808p pd=2.92u as=0.3808p ps=2.92u w=1.12u l=0.13u
X664 a_4350_1044# a_5191_1008# a_5115_1044# VDD.t0 sg13_lv_pmos ad=0.3808p pd=2.92u as=0.2128p ps=1.5u w=1.12u l=0.13u
X665 VDD.t43 a_16597_1842# a_17065_1044# VDD.t0 sg13_lv_pmos ad=0.252p pd=1.57u as=0.3808p ps=2.92u w=1.12u l=0.13u
X666 VSS.t195 a_27237_1842# a_27705_1044# VSS.t194 sg13_lv_nmos ad=0.1665p pd=1.19u as=0.2516p ps=2.16u w=0.74u l=0.13u
X667 VSS.t531 DELAY_VBIASN VSS.t534 VSS.t533 sg13_lv_nmos ad=1.33p pd=7.38u as=0 ps=0 w=7u l=7u
X668 a_10191_2470# a_9953_1842# a_10083_1842# VDD.t3 sg13_lv_pmos ad=0.2128p pd=1.5u as=0.3808p ps=2.92u w=1.12u l=0.2u
X669 a_2595_1047.t1 a_2297_1395# VSS.t244 VSS.t484 sg13_lv_nmos ad=0.1406p pd=1.12u as=0.1331p ps=1.12u w=0.74u l=0.13u
X670 a_26151_1842# a_25913_1842# a_26043_1842# VSS.t125 sg13_lv_nmos ad=0.1406p pd=1.12u as=0.2516p ps=2.16u w=0.74u l=0.2u
X671 VSS.t47 a_2019_311# a_17865_519# VSS.t274 sg13_lv_nmos ad=0.2516p pd=2.16u as=0.2516p ps=2.16u w=0.74u l=0.13u
X672 VSS.t146 a_1544_289# a_2391_331# VSS.t284 sg13_lv_nmos ad=0.1331p pd=1.12u as=0.1216p ps=1.02u w=0.64u l=0.13u
X673 a_4871_1842# a_4633_1842# a_4763_1842# VSS.t106 sg13_lv_nmos ad=0.1406p pd=1.12u as=0.2516p ps=2.16u w=0.74u l=0.2u
X674 a_13753_1842# a_13557_1842# VSS.t116 VSS.t115 sg13_lv_nmos ad=0.2516p pd=2.16u as=0.1406p ps=1.12u w=0.74u l=0.13u
X675 a_1815_1395# a_1256_1044# a_1721_1395# VSS.t378 sg13_lv_nmos ad=0.1216p pd=1.02u as=0.2176p ps=1.96u w=0.64u l=0.13u
X676 a_7673_1842# a_7477_1842# VDD.t185 VDD.t3 sg13_lv_pmos ad=0.3808p pd=2.92u as=0.2128p ps=1.5u w=1.12u l=0.13u
X677 VDD.t104 VSS.t47 VDD.t103 VDD.t0 sg13_lv_pmos ad=0.34p pd=2.68u as=0 ps=0 w=1u l=1u
X678 a_1721_331# a_1256_289# VDD.t364 VDD.t0 sg13_lv_pmos ad=0.1596p pd=1.22u as=0.2856p ps=2.36u w=0.84u l=0.13u
X679 VSS.t360 a_24523_1842# a_24957_1842# VSS.t359 sg13_lv_nmos ad=0.1406p pd=1.12u as=0.2516p ps=2.16u w=0.74u l=0.13u
X680 a_6635_1044# a_6425_1044# VSS.t221 VSS.t349 sg13_lv_nmos ad=0.1406p pd=1.12u as=0.1665p ps=1.19u w=0.74u l=0.13u
X681 VDD.t48 a_15108_5325# a_15053_5420# VDD.t9 sg13_lv_pmos ad=1.10612p pd=6.66u as=93.45f ps=0.865u w=0.42u l=0.13u
X682 VSS.t127 a_2595_1047.t9 a_5191_1008# VSS.t488 sg13_lv_nmos ad=0.2516p pd=2.16u as=0.2516p ps=2.16u w=0.74u l=0.13u
X683 a_20315_1044# a_20105_1044# VSS.t239 VSS.t238 sg13_lv_nmos ad=0.1406p pd=1.12u as=0.1665p ps=1.19u w=0.74u l=0.13u
X684 VDD.t281 DELAY_VBIASP a_11711_2470# VDD.t3 sg13_lv_pmos ad=0.3808p pd=2.92u as=0.2128p ps=1.5u w=1.12u l=0.6u
X685 a_18795_1044# a_18585_1044# VDD.t62 VDD.t0 sg13_lv_pmos ad=0.2128p pd=1.5u as=0.252p ps=1.57u w=1.12u l=0.13u
X686 a_25528_1044# a_24957_1842# VSS.t206 VSS.t382 sg13_lv_nmos ad=0.1406p pd=1.12u as=0.2516p ps=2.16u w=0.74u l=0.13u
X687 a_5778_3367# a_6126_3816# a_6326_4590# VSS.t325 sg13_lv_nmos ad=0.68p pd=4.68u as=0.38p ps=2.38u w=2u l=1u
X688 VSS.t556 DELAY_VBIASN VSS.t554 VSS.t539 sg13_lv_nmos ad=1.33p pd=7.38u as=0 ps=0 w=7u l=7u
X689 VSS.t585 DELAY_VBIASN a_27671_1842# VSS.t584 sg13_lv_nmos ad=0.2516p pd=2.16u as=0.1406p ps=1.12u w=0.74u l=0.6u
X690 a_5731_289# a_3747_311.t3 a_13470_1044# VSS.t294 sg13_lv_nmos ad=0.2516p pd=2.16u as=0.2516p ps=2.16u w=0.74u l=0.13u
X691 a_25630_1044# a_27124_1008# a_27048_1044# VDD.t0 sg13_lv_pmos ad=0.3808p pd=2.92u as=0.2128p ps=1.5u w=1.12u l=0.13u
X692 VDD.t94 a_2595_1047.t5 a_17351_1008# VDD.t0 sg13_lv_pmos ad=0.3808p pd=2.92u as=0.3808p ps=2.92u w=1.12u l=0.13u
X693 VSS.t303 a_13121_5831# a_6854_5986# VDD.t22 sg13_lv_pmos ad=0.232p pd=2.08u as=0.136p ps=1.14u w=0.4u l=0.2u
X694 VDD.t100 a_21483_1842# a_21917_1842# VDD.t3 sg13_lv_pmos ad=0.2128p pd=1.5u as=0.3808p ps=2.92u w=1.12u l=0.13u
X695 a_4350_1044# a_5844_1008# a_5768_1044# VDD.t0 sg13_lv_pmos ad=0.3808p pd=2.92u as=0.2128p ps=1.5u w=1.12u l=0.13u
X696 VSS.t362 a_16851_309# MUX_OUT VSS.t363 sg13_lv_nmos ad=0.2516p pd=2.16u as=0.1406p ps=1.12u w=0.74u l=0.13u
X697 VSS.t14 a_2019_311# a_5705_519# VSS.t272 sg13_lv_nmos ad=0.2516p pd=2.16u as=0.2516p ps=2.16u w=0.74u l=0.13u
X698 VDD.t189 a_1544_289# a_1721_331# VDD.t0 sg13_lv_pmos ad=0.1918p pd=1.5u as=0.1596p ps=1.22u w=0.84u l=0.13u
X699 a_7151_1842# a_6913_1842# a_7043_1842# VSS.t386 sg13_lv_nmos ad=0.1406p pd=1.12u as=0.2516p ps=2.16u w=0.74u l=0.2u
X700 a_16033_1842# a_15837_1842# VSS.t268 VSS.t267 sg13_lv_nmos ad=0.2516p pd=2.16u as=0.1406p ps=1.12u w=0.74u l=0.13u
X701 a_10649_5878# REF_CLK VSS.t310 VSS.t500 sg13_lv_nmos ad=0.2516p pd=2.16u as=1.9998p ps=12.915u w=0.74u l=0.13u
X702 VDD.t48 a_11748_6109# a_11693_5990# VDD.t9 sg13_lv_pmos ad=1.10612p pd=6.66u as=93.45f ps=0.865u w=0.42u l=0.13u
X703 MUX_OUT a_16851_309# VDD.t240 VDD.t0 sg13_lv_pmos ad=0.2128p pd=1.5u as=0.2086p ps=1.5u w=1.12u l=0.13u
X704 a_25391_2470# a_25153_1842# a_25283_1842# VDD.t3 sg13_lv_pmos ad=0.2128p pd=1.5u as=0.3808p ps=2.92u w=1.12u l=0.2u
X705 VDD.t92 VSS.t25 VDD.t91 VDD.t0 sg13_lv_pmos ad=0.34p pd=2.68u as=0 ps=0 w=1u l=1u
X706 a_12993_1842# a_12797_1842# VDD.t140 VDD.t3 sg13_lv_pmos ad=0.3808p pd=2.92u as=0.2128p ps=1.5u w=1.12u l=0.13u
X707 a_16408_1044# a_15837_1842# VSS.t203 VSS.t269 sg13_lv_nmos ad=0.1406p pd=1.12u as=0.2516p ps=2.16u w=0.74u l=0.13u
X708 a_5778_3367# a_6126_3816# a_6326_4590# VSS.t325 sg13_lv_nmos ad=0.68p pd=4.68u as=0.38p ps=2.38u w=2u l=1u
X709 VSS.t131 a_5523_1842# a_5957_1842# VSS.t130 sg13_lv_nmos ad=0.1406p pd=1.12u as=0.2516p ps=2.16u w=0.74u l=0.13u
X710 VDD.t278 DELAY_VBIASP a_13991_2470# VDD.t3 sg13_lv_pmos ad=0.3808p pd=2.92u as=0.2128p ps=1.5u w=1.12u l=0.6u
X711 a_5731_289# a_2019_311# a_4350_1044# VSS.t271 sg13_lv_nmos ad=0.2516p pd=2.16u as=0.2516p ps=2.16u w=0.74u l=0.13u
X712 VSS.t213 a_9547_6172# a_9547_6172# VSS.t212 sg13_lv_nmos ad=2.39977p pd=15.495u as=0.111p ps=1.34u w=0.3u l=0.13u
X713 a_9444_3912# a_6854_5454# a_9712_3912# VSS.t108 sg13_lv_nmos ad=0.68p pd=4.68u as=0.38p ps=2.38u w=2u l=1u
X714 VSS.t562 DELAY_VBIASN VSS.t560 VSS.t545 sg13_lv_nmos ad=1.33p pd=7.38u as=0 ps=0 w=7u l=7u
X715 a_7390_1044# a_3747_1047.t8 a_9675_1044# VSS.t396 sg13_lv_nmos ad=0.2516p pd=2.16u as=0.1406p ps=1.12u w=0.74u l=0.13u
X716 VDD.t130 a_23763_1842# a_24197_1842# VDD.t3 sg13_lv_pmos ad=0.2128p pd=1.5u as=0.3808p ps=2.92u w=1.12u l=0.13u
X717 VSS.t187 DELAY_VBIASN a_8671_1842# VSS.t519 sg13_lv_nmos ad=0.2516p pd=2.16u as=0.1406p ps=1.12u w=0.74u l=0.6u
X718 VDD.t50 a_2019_1047.t8 a_7364_1008# VDD.t0 sg13_lv_pmos ad=0.3808p pd=2.92u as=0.3808p ps=2.92u w=1.12u l=0.13u
X719 VDD.t307 DELAY_VBIASP a_26911_2470# VDD.t3 sg13_lv_pmos ad=0.3808p pd=2.92u as=0.2128p ps=1.5u w=1.12u l=0.6u
X720 VSS.t93 a_14009_5084# a_14111_5227# VSS.t473 sg13_lv_nmos ad=1.45407p pd=9.445u as=0.2516p ps=2.16u w=0.74u l=0.13u
X721 VDD.t163 VSS.t76 VDD.t161 VDD.t0 sg13_lv_pmos ad=0.19p pd=1.38u as=0 ps=0 w=1u l=1u
X722 a_12471_1842# a_12233_1842# a_12363_1842# VSS.t148 sg13_lv_nmos ad=0.1406p pd=1.12u as=0.2516p ps=2.16u w=0.74u l=0.2u
X723 a_22488_1044# a_21917_1842# VDD.t101 VDD.t0 sg13_lv_pmos ad=0.2128p pd=1.5u as=0.3808p ps=2.92u w=1.12u l=0.13u
X724 VDD.t46 a_2595_311.t3 a_8745_519# VDD.t0 sg13_lv_pmos ad=0.3808p pd=2.92u as=0.3808p ps=2.92u w=1.12u l=0.13u
X725 VSS.t617 a_3171_1047.t5 a_18004_1008# VSS.t616 sg13_lv_nmos ad=0.2516p pd=2.16u as=0.2516p ps=2.16u w=0.74u l=0.13u
X726 a_6391_2470# a_6153_1842# a_6283_1842# VDD.t3 sg13_lv_pmos ad=0.2128p pd=1.5u as=0.3808p ps=2.92u w=1.12u l=0.2u
X727 a_15273_1842# a_15077_1842# VDD.t252 VDD.t3 sg13_lv_pmos ad=0.3808p pd=2.92u as=0.2128p ps=1.5u w=1.12u l=0.13u
X728 a_14235_1044# a_14025_1044# VSS.t118 VSS.t288 sg13_lv_nmos ad=0.1406p pd=1.12u as=0.1665p ps=1.19u w=0.74u l=0.13u
X729 a_6326_4590# a_6126_3816# a_5778_3367# VSS.t325 sg13_lv_nmos ad=0.42p pd=2.42u as=0.68p ps=4.68u w=2u l=1u
X730 VSS.t12 a_3747_1047.t7 a_12791_1008# VSS.t11 sg13_lv_nmos ad=0.2516p pd=2.16u as=0.2516p ps=2.16u w=0.74u l=0.13u
X731 VSS.t445 VSS.t442 VSS.t444 VSS.t443 sg13_lv_nmos ad=0.2516p pd=2.16u as=0 ps=0 w=0.74u l=0.13u
X732 a_9953_1842# a_9757_1842# VSS.t181 VSS.t180 sg13_lv_nmos ad=0.2516p pd=2.16u as=0.1406p ps=1.12u w=0.74u l=0.13u
X733 VSS.t160 a_10843_1842# a_11277_1842# VSS.t159 sg13_lv_nmos ad=0.1406p pd=1.12u as=0.2516p ps=2.16u w=0.74u l=0.13u
X734 VSS.t65 VDD.t395 VSS.t65 VSS.t66 sg13_lv_nmos ad=0.1428p pd=1.52u as=0 ps=0 w=0.42u l=1u
X735 a_10649_5878# REF_CLK VDD.t48 VDD.t9 sg13_lv_pmos ad=0.4088p pd=2.97u as=1.03698p ps=6.245u w=1.12u l=0.13u
X736 VDD.t180 a_15403_1842# a_15837_1842# VDD.t3 sg13_lv_pmos ad=0.2128p pd=1.5u as=0.3808p ps=2.92u w=1.12u l=0.13u
X737 VDD.t48 a_14009_5084# a_14111_5227# VDD.t9 sg13_lv_pmos ad=1.10612p pd=6.66u as=0.3864p ps=2.93u w=1.12u l=0.13u
X738 VSS.t41 VDD.t402 VSS.t41 VSS.t40 sg13_lv_nmos ad=0.1428p pd=1.52u as=0 ps=0 w=0.42u l=1u
X739 a_11848_1044# a_11277_1842# VSS.t293 VSS.t292 sg13_lv_nmos ad=0.1406p pd=1.12u as=0.2516p ps=2.16u w=0.74u l=0.13u
X740 a_6326_4590# a_6326_4590# VDD.t86 VDD.t9 sg13_lv_pmos ad=0.38p pd=2.38u as=0.38p ps=2.38u w=2u l=1u
X741 VDD.t70 a_4763_1842# a_5197_1842# VDD.t3 sg13_lv_pmos ad=0.2128p pd=1.5u as=0.3808p ps=2.92u w=1.12u l=0.13u
X742 VSS.t50 VDD.t400 VSS.t48 VSS.t49 sg13_lv_nmos ad=79.8f pd=0.8u as=0 ps=0 w=0.42u l=1u
X743 a_13470_1044# a_13444_1008# a_13368_1044# VDD.t0 sg13_lv_pmos ad=0.3808p pd=2.92u as=0.2128p ps=1.5u w=1.12u l=0.13u
X744 VDD.t98 a_3449_1395# a_3747_1047.t0 VDD.t0 sg13_lv_pmos ad=0.4256p pd=3u as=0.2128p ps=1.5u w=1.12u l=0.13u
X745 VSS.t454 VSS.t451 VSS.t451 VSS.t452 sg13_lv_nmos ad=0.1406p pd=1.12u as=0 ps=0 w=0.74u l=0.13u
X746 VDD.t5 a_3171_1047.t3 a_24084_1008# VDD.t0 sg13_lv_pmos ad=0.3808p pd=2.92u as=0.3808p ps=2.92u w=1.12u l=0.13u
X747 a_3449_1395# MUX_SEL0 VDD.t329 VDD.t0 sg13_lv_pmos ad=0.1596p pd=1.22u as=0.2856p ps=2.36u w=0.84u l=0.13u
X748 a_15464_3684# a_14851_5182# VDD.t222 VDD.t9 sg13_lv_pmos ad=0.4312p pd=3.01u as=0.2639p ps=1.81u w=1.12u l=0.13u
X749 a_5974_5723# a_6126_3816# VSS.t329 VSS.t328 sg13_lv_nmos ad=0.38p pd=2.38u as=0.68p ps=4.68u w=2u l=1u
X750 VDD.t289 DELAY_VBIASP a_7911_2470# VDD.t3 sg13_lv_pmos ad=0.3808p pd=2.92u as=0.2128p ps=1.5u w=1.12u l=0.6u
X751 VDD.t165 VSS.t21 VDD.t164 VDD.t0 sg13_lv_pmos ad=0.19p pd=1.38u as=0 ps=0 w=1u l=1u
X752 VDD.t20 a_6326_4590# a_6854_5986# VDD.t9 sg13_lv_pmos ad=0.38p pd=2.38u as=0.38p ps=2.38u w=2u l=1u
X753 a_10206_5835# a_10649_5878# a_9946_6305# VSS.t308 sg13_lv_nmos ad=79.8f pd=0.8u as=0.1296p ps=1.52u w=0.42u l=0.13u
X754 VDD.t167 VSS.t21 VDD.t166 VDD.t0 sg13_lv_pmos ad=0.34p pd=2.68u as=0 ps=0 w=1u l=1u
X755 a_9946_6305# a_9772_5843# VDD.t327 VDD.t9 sg13_lv_pmos ad=79.8f pd=0.8u as=0.1428p ps=1.52u w=0.42u l=0.13u
X756 a_9946_6305# a_10751_5878# a_10206_5835# VDD.t9 sg13_lv_pmos ad=0.1428p pd=1.52u as=79.8f ps=0.8u w=0.42u l=0.13u
X757 VDD.t241 a_16851_309# MUX_OUT VDD.t0 sg13_lv_pmos ad=0.7336p pd=3.55u as=0.2128p ps=1.5u w=1.12u l=0.13u
X758 VSS.t69 a_3171_311.t2 a_23945_519# VSS.t313 sg13_lv_nmos ad=0.2516p pd=2.16u as=0.2516p ps=2.16u w=0.74u l=0.13u
X759 VDD.t62 a_18117_1842# a_18585_1044# VDD.t0 sg13_lv_pmos ad=0.252p pd=1.57u as=0.3808p ps=2.92u w=1.12u l=0.13u
X760 VSS.t239 a_19637_1842# a_20105_1044# VSS.t252 sg13_lv_nmos ad=0.1665p pd=1.19u as=0.2516p ps=2.16u w=0.74u l=0.13u
X761 a_11711_2470# a_11473_1842# a_11603_1842# VDD.t3 sg13_lv_pmos ad=0.2128p pd=1.5u as=0.3808p ps=2.92u w=1.12u l=0.2u
X762 a_27671_1842# a_27433_1842# a_27563_1842# VSS.t275 sg13_lv_nmos ad=0.1406p pd=1.12u as=0.2516p ps=2.16u w=0.74u l=0.2u
X763 VSS.t362 MUX_SEL4 a_15765_463# VSS.t390 sg13_lv_nmos ad=0.2516p pd=2.16u as=0.2516p ps=2.16u w=0.74u l=0.13u
X764 a_5731_289# a_14825_519# a_13470_1044# VDD.t0 sg13_lv_pmos ad=0.3808p pd=2.92u as=0.3808p ps=2.92u w=1.12u l=0.13u
X765 a_16510_1044# a_2595_1047.t5 a_17275_1044# VSS.t142 sg13_lv_nmos ad=0.2516p pd=2.16u as=0.1406p ps=1.12u w=0.74u l=0.13u
X766 a_13045_6215# a_13019_5831# a_12849_5867# VSS.t368 sg13_lv_nmos ad=0.1406p pd=1.12u as=0.1406p ps=1.12u w=0.74u l=0.13u
X767 VSS.t478 DELAY_VBIASN a_16271_1842# VSS.t523 sg13_lv_nmos ad=0.2516p pd=2.16u as=0.1406p ps=1.12u w=0.74u l=0.6u
X768 VDD.t216 VSS.t69 VDD.t245 VDD.t0 sg13_lv_pmos ad=0.34p pd=2.68u as=0 ps=0 w=1u l=1u
X769 VDD.t4 a_3171_1047.t6 a_14964_1008# VDD.t0 sg13_lv_pmos ad=0.3808p pd=2.92u as=0.3808p ps=2.92u w=1.12u l=0.13u
X770 VDD.t116 a_10083_1842# a_10517_1842# VDD.t3 sg13_lv_pmos ad=0.2128p pd=1.5u as=0.3808p ps=2.92u w=1.12u l=0.13u
X771 VSS.t9 a_3747_1047.t2 a_27991_1008# VSS.t8 sg13_lv_nmos ad=0.2516p pd=2.16u as=0.2516p ps=2.16u w=0.74u l=0.13u
X772 a_9712_3912# a_13019_5831# DELAY_VBIASN VSS.t369 sg13_lv_nmos ad=0.136p pd=1.14u as=0.232p ps=2.08u w=0.4u l=0.2u
X773 VSS.t101 a_26043_1842# a_26477_1842# VSS.t282 sg13_lv_nmos ad=0.1406p pd=1.12u as=0.2516p ps=2.16u w=0.74u l=0.13u
X774 VSS.t336 a_6126_3816# a_5974_5723# VSS.t328 sg13_lv_nmos ad=0.68p pd=4.68u as=0.38p ps=2.38u w=2u l=1u
X775 a_11195_1044# a_10985_1044# VDD.t117 VDD.t0 sg13_lv_pmos ad=0.2128p pd=1.5u as=0.252p ps=1.57u w=1.12u l=0.13u
X776 VSS.t307 a_3747_1047.t9 a_6711_1008# VSS.t306 sg13_lv_nmos ad=0.2516p pd=2.16u as=0.2516p ps=2.16u w=0.74u l=0.13u
X777 a_9444_4590# a_6854_5454# a_6854_5454# VSS.t108 sg13_lv_nmos ad=0.68p pd=4.68u as=0.38p ps=2.38u w=2u l=1u
X778 a_16108_289# a_2595_311.t2 a_19550_1044# VSS.t86 sg13_lv_nmos ad=0.2516p pd=2.16u as=0.2516p ps=2.16u w=0.74u l=0.13u
X779 VSS.t112 DELAY_VBIASN a_20071_1842# VSS.t521 sg13_lv_nmos ad=0.2516p pd=2.16u as=0.1406p ps=1.12u w=0.74u l=0.6u
X780 VDD.t303 DELAY_VBIASP a_24631_2470# VDD.t3 sg13_lv_pmos ad=0.3808p pd=2.92u as=0.2128p ps=1.5u w=1.12u l=0.6u
X781 a_22590_1044# a_23431_1008# a_23355_1044# VDD.t0 sg13_lv_pmos ad=0.3808p pd=2.92u as=0.2128p ps=1.5u w=1.12u l=0.13u
X782 VSS.t32 VDD.t404 VSS.t32 VSS.t34 sg13_lv_nmos ad=79.8f pd=0.8u as=0 ps=0 w=0.42u l=1u
X783 a_10458_6292# DLL_RESETN VSS.t177 VSS.t430 sg13_lv_nmos ad=37.8f pd=0.6u as=0.1701p ps=1.65u w=0.42u l=0.13u
X784 a_11491_6228# a_10649_5878# a_10232_5871# VDD.t9 sg13_lv_pmos ad=0.2048p pd=1.63u as=0.34p ps=2.68u w=1u l=0.13u
X785 VSS.t334 a_6126_3816# a_5974_5723# VSS.t328 sg13_lv_nmos ad=0.76p pd=4.76u as=0.38p ps=2.38u w=2u l=1u
X786 a_8671_1842# a_8433_1842# a_8563_1842# VSS.t381 sg13_lv_nmos ad=0.1406p pd=1.12u as=0.2516p ps=2.16u w=0.74u l=0.2u
X787 a_17553_1842# a_17357_1842# VSS.t121 VSS.t599 sg13_lv_nmos ad=0.2516p pd=2.16u as=0.1406p ps=1.12u w=0.74u l=0.13u
X788 a_5731_289# a_5705_519# a_4350_1044# VDD.t0 sg13_lv_pmos ad=0.3808p pd=2.92u as=0.3808p ps=2.92u w=1.12u l=0.13u
X789 VDD.t34 VDD.t32 VDD.t33 VDD.t3 sg13_lv_pmos ad=0.3808p pd=2.92u as=0 ps=0 w=1.12u l=0.13u
X790 a_26911_2470# a_26673_1842# a_26803_1842# VDD.t3 sg13_lv_pmos ad=0.2128p pd=1.5u as=0.3808p ps=2.92u w=1.12u l=0.2u
X791 a_7390_1044# a_2019_1047.t8 a_7288_1044# VSS.t94 sg13_lv_nmos ad=0.2516p pd=2.16u as=0.1406p ps=1.12u w=0.74u l=0.13u
X792 a_13566_5328# a_14009_5084# a_13306_5105# VSS.t472 sg13_lv_nmos ad=79.8f pd=0.8u as=0.1296p ps=1.52u w=0.42u l=0.13u
X793 a_21353_1842# a_21157_1842# VSS.t511 VSS.t510 sg13_lv_nmos ad=0.2516p pd=2.16u as=0.1406p ps=1.12u w=0.74u l=0.13u
X794 VSS.t280 a_7043_1842# a_7477_1842# VSS.t279 sg13_lv_nmos ad=0.1406p pd=1.12u as=0.2516p ps=2.16u w=0.74u l=0.13u
X795 a_13121_5831# a_15688_5867# VDD.t234 VDD.t9 sg13_lv_pmos ad=0.3808p pd=2.92u as=0.2128p ps=1.5u w=1.12u l=0.13u
X796 VDD.t299 DELAY_VBIASP a_15511_2470# VDD.t3 sg13_lv_pmos ad=0.3808p pd=2.92u as=0.2128p ps=1.5u w=1.12u l=0.6u
X797 VDD.t275 a_2019_1047.t7 a_10404_1008# VDD.t0 sg13_lv_pmos ad=0.3808p pd=2.92u as=0.3808p ps=2.92u w=1.12u l=0.13u
X798 VSS.t173 a_9444_4590# a_9444_3912# VSS.t165 sg13_lv_nmos ad=0.68p pd=4.68u as=0.38p ps=2.38u w=2u l=1u
X799 VDD.t93 a_25283_1842# a_25717_1842# VDD.t3 sg13_lv_pmos ad=0.2128p pd=1.5u as=0.3808p ps=2.92u w=1.12u l=0.13u
X800 VDD.t277 DELAY_VBIASP a_5631_2470# VDD.t3 sg13_lv_pmos ad=0.3808p pd=2.92u as=0.2128p ps=1.5u w=1.12u l=0.6u
X801 a_26395_1044# a_26185_1044# VDD.t148 VDD.t0 sg13_lv_pmos ad=0.2128p pd=1.5u as=0.252p ps=1.57u w=1.12u l=0.13u
X802 a_13306_5105# a_14111_5227# a_13566_5328# VDD.t9 sg13_lv_pmos ad=0.1428p pd=1.52u as=79.8f ps=0.8u w=0.42u l=0.13u
X803 a_6326_4590# a_6126_3816# a_5778_3367# VSS.t325 sg13_lv_nmos ad=0.38p pd=2.38u as=0.68p ps=4.68u w=2u l=1u
X804 VDD.t129 a_3747_1047.t3 a_24951_1008# VDD.t0 sg13_lv_pmos ad=0.3808p pd=2.92u as=0.3808p ps=2.92u w=1.12u l=0.13u
X805 VDD.t54 VSS.t65 VDD.t53 VDD.t0 sg13_lv_pmos ad=0.19p pd=1.38u as=0 ps=0 w=1u l=1u
X806 a_13991_1842# a_13753_1842# a_13883_1842# VSS.t97 sg13_lv_nmos ad=0.1406p pd=1.12u as=0.2516p ps=2.16u w=0.74u l=0.2u
X807 a_24008_1044# a_23437_1842# VDD.t226 VDD.t0 sg13_lv_pmos ad=0.2128p pd=1.5u as=0.3808p ps=2.92u w=1.12u l=0.13u
X808 VDD.t2 VSS.t39 VDD.t1 VDD.t0 sg13_lv_pmos ad=0.19p pd=1.38u as=0 ps=0 w=1u l=1u
X809 VSS.t402 a_2019_1047.t4 a_19524_1008# VSS.t401 sg13_lv_nmos ad=0.2516p pd=2.16u as=0.2516p ps=2.16u w=0.74u l=0.13u
X810 a_9712_3912# a_6854_5454# a_9444_3912# VSS.t107 sg13_lv_nmos ad=0.38p pd=2.38u as=0.68p ps=4.68u w=2u l=1u
X811 a_7911_2470# a_7673_1842# a_7803_1842# VDD.t3 sg13_lv_pmos ad=0.2128p pd=1.5u as=0.3808p ps=2.92u w=1.12u l=0.2u
X812 a_16793_1842# a_16597_1842# VDD.t334 VDD.t3 sg13_lv_pmos ad=0.3808p pd=2.92u as=0.2128p ps=1.5u w=1.12u l=0.13u
X813 VSS.t150 MUX_SEL1 a_3543_1395# VSS.t417 sg13_lv_nmos ad=0.1331p pd=1.12u as=0.1216p ps=1.02u w=0.64u l=0.13u
X814 a_15755_1044# a_15545_1044# VSS.t481 VSS.t603 sg13_lv_nmos ad=0.1406p pd=1.12u as=0.1665p ps=1.19u w=0.74u l=0.13u
X815 a_13818_5118# a_12849_5867# VSS.t420 VSS.t421 sg13_lv_nmos ad=37.8f pd=0.6u as=0.1701p ps=1.65u w=0.42u l=0.13u
X816 a_2595_1047.t0 a_2297_1395# VDD.t150 VDD.t0 sg13_lv_pmos ad=0.2128p pd=1.5u as=0.1918p ps=1.5u w=1.12u l=0.13u
X817 VSS.t375 a_2595_1047.t6 a_14311_1008# VSS.t612 sg13_lv_nmos ad=0.2516p pd=2.16u as=0.2516p ps=2.16u w=0.74u l=0.13u
X818 VSS.t228 a_12363_1842# a_12797_1842# VSS.t600 sg13_lv_nmos ad=0.1406p pd=1.12u as=0.2516p ps=2.16u w=0.74u l=0.13u
X819 a_5115_1044# a_4905_1044# VSS.t224 VSS.t223 sg13_lv_nmos ad=0.1406p pd=1.12u as=0.1665p ps=1.19u w=0.74u l=0.13u
X820 a_1256_1044# MUX_SEL0 VDD.t330 VDD.t0 sg13_lv_pmos ad=0.3808p pd=2.92u as=0.3808p ps=2.92u w=1.12u l=0.13u
X821 a_9444_3912# a_9444_4590# VSS.t171 VSS.t163 sg13_lv_nmos ad=0.38p pd=2.38u as=0.68p ps=4.68u w=2u l=1u
X822 VSS.t552 DELAY_VBIASN VSS.t550 VSS.t535 sg13_lv_nmos ad=1.33p pd=7.38u as=0 ps=0 w=7u l=7u
X823 VDD.t99 a_27563_1842# a_27997_1842# VDD.t3 sg13_lv_pmos ad=0.2128p pd=1.5u as=0.3808p ps=2.92u w=1.12u l=0.13u
X824 a_20593_1842# a_20397_1842# VDD.t63 VDD.t3 sg13_lv_pmos ad=0.3808p pd=2.92u as=0.2128p ps=1.5u w=1.12u l=0.13u
X825 a_1721_1395# a_1256_1044# VDD.t255 VDD.t0 sg13_lv_pmos ad=0.1596p pd=1.22u as=0.2856p ps=2.36u w=0.84u l=0.13u
X826 VDD.t236 a_6283_1842# a_6717_1842# VDD.t3 sg13_lv_pmos ad=0.2128p pd=1.5u as=0.3808p ps=2.92u w=1.12u l=0.13u
X827 a_13470_1044# a_14964_1008# a_14888_1044# VDD.t0 sg13_lv_pmos ad=0.3808p pd=2.92u as=0.2128p ps=1.5u w=1.12u l=0.13u
X828 a_13592_5871# a_13566_5835# VDD.t68 VDD.t9 sg13_lv_pmos ad=0.34p pd=2.68u as=0.36237p ps=2.605u w=1u l=0.13u
X829 a_5778_3367# a_6126_3816# a_6326_4590# VSS.t325 sg13_lv_nmos ad=0.68p pd=4.68u as=0.42p ps=2.42u w=2u l=1u
X830 VSS.t48 VDD.t400 VSS.t47 VSS.t46 sg13_lv_nmos ad=0.1428p pd=1.52u as=0 ps=0 w=0.42u l=1u
X831 VDD.t131 a_2019_1047.t2 a_25604_1008# VDD.t0 sg13_lv_pmos ad=0.3808p pd=2.92u as=0.3808p ps=2.92u w=1.12u l=0.13u
X832 a_9746_5805# a_9547_5942# VSS.t213 VSS.t384 sg13_lv_nmos ad=0.27427p pd=2.28u as=2.39977p ps=15.495u w=0.795u l=0.13u
X833 a_16271_1842# a_16033_1842# a_16163_1842# VSS.t124 sg13_lv_nmos ad=0.1406p pd=1.12u as=0.2516p ps=2.16u w=0.74u l=0.2u
X834 a_21835_1044# a_21625_1044# VDD.t206 VDD.t0 sg13_lv_pmos ad=0.2128p pd=1.5u as=0.252p ps=1.57u w=1.12u l=0.13u
X835 VDD.t164 VSS.t19 VDD.t192 VDD.t0 sg13_lv_pmos ad=0.34p pd=2.68u as=0 ps=0 w=1u l=1u
X836 VDD.t357 a_2595_1047.t4 a_20391_1008# VDD.t0 sg13_lv_pmos ad=0.3808p pd=2.92u as=0.3808p ps=2.92u w=1.12u l=0.13u
X837 VSS.t339 a_14851_5182# a_15688_5403# VSS.t340 sg13_lv_nmos ad=0.1406p pd=1.12u as=0.2516p ps=2.16u w=0.74u l=0.13u
X838 a_19073_1842# a_18877_1842# VDD.t133 VDD.t3 sg13_lv_pmos ad=0.3808p pd=2.92u as=0.2128p ps=1.5u w=1.12u l=0.13u
X839 VDD.t117 a_10517_1842# a_10985_1044# VDD.t0 sg13_lv_pmos ad=0.252p pd=1.57u as=0.3808p ps=2.92u w=1.12u l=0.13u
X840 VSS.t302 a_21157_1842# a_21625_1044# VSS.t509 sg13_lv_nmos ad=0.1665p pd=1.19u as=0.2516p ps=2.16u w=0.74u l=0.13u
X841 VSS.t123 a_12849_5867# a_13400_6305# VSS.t122 sg13_lv_nmos ad=0.1626p pd=1.415u as=60.89999f ps=0.71u w=0.42u l=0.13u
X842 VSS.t327 a_6126_3816# a_6126_3816# VSS.t325 sg13_lv_nmos ad=0.68p pd=4.68u as=0.38p ps=2.38u w=2u l=1u
X843 a_20071_1842# a_19833_1842# a_19963_1842# VSS.t593 sg13_lv_nmos ad=0.1406p pd=1.12u as=0.2516p ps=2.16u w=0.74u l=0.2u
X844 VSS.t437 VSS.t435 VSS.t435 VSS.t436 sg13_lv_nmos ad=0.68p pd=4.68u as=0 ps=0 w=2u l=1u
X845 VSS.t371 a_14643_1842# a_15077_1842# VSS.t370 sg13_lv_nmos ad=0.1406p pd=1.12u as=0.2516p ps=2.16u w=0.74u l=0.13u
X846 a_1815_331# a_1256_289# a_1721_331# VSS.t514 sg13_lv_nmos ad=0.1216p pd=1.02u as=0.2176p ps=1.96u w=0.64u l=0.13u
X847 VDD.t14 VDD.t12 VDD.t13 VDD.t9 sg13_lv_pmos ad=0.38p pd=2.38u as=0 ps=0 w=2u l=1u
X848 VDD.t120 a_19203_1842# a_19637_1842# VDD.t3 sg13_lv_pmos ad=0.2128p pd=1.5u as=0.3808p ps=2.92u w=1.12u l=0.13u
X849 VSS.t266 a_2019_1047.t9 a_4324_1008# VSS.t399 sg13_lv_nmos ad=0.2516p pd=2.16u as=0.2516p ps=2.16u w=0.74u l=0.13u
X850 a_16108_289# a_20905_519# a_19550_1044# VDD.t0 sg13_lv_pmos ad=0.3808p pd=2.92u as=0.3808p ps=2.92u w=1.12u l=0.13u
X851 a_16510_1044# a_3747_1047.t5 a_18795_1044# VSS.t289 sg13_lv_nmos ad=0.2516p pd=2.16u as=0.1406p ps=1.12u w=0.74u l=0.13u
X852 VDD.t118 a_8563_1842# a_8997_1842# VDD.t3 sg13_lv_pmos ad=0.2128p pd=1.5u as=0.3808p ps=2.92u w=1.12u l=0.13u
X853 VDD.t287 DELAY_VBIASP a_13231_2470# VDD.t3 sg13_lv_pmos ad=0.3808p pd=2.92u as=0.2128p ps=1.5u w=1.12u l=0.6u
X854 VSS.t103 DELAY_VBIASN a_17791_1842# VSS.t575 sg13_lv_nmos ad=0.2516p pd=2.16u as=0.1406p ps=1.12u w=0.74u l=0.6u
X855 VSS.t26 VDD.t406 VSS.t25 VSS.t24 sg13_lv_nmos ad=0.1428p pd=1.52u as=0 ps=0 w=0.42u l=1u
X856 a_6854_5986# a_6326_4590# VDD.t88 VDD.t9 sg13_lv_pmos ad=0.38p pd=2.38u as=0.38p ps=2.38u w=2u l=1u
X857 VDD.t29 VDD.t27 VDD.t28 VDD.t22 sg13_lv_pmos ad=0.3808p pd=2.92u as=0 ps=0 w=1.12u l=0.13u
X858 VDD.t197 a_3747_1047.t5 a_18871_1008# VDD.t0 sg13_lv_pmos ad=0.3808p pd=2.92u as=0.3808p ps=2.92u w=1.12u l=0.13u
X859 VDD.t24 VDD.t25 VDD.t26 VDD.t22 sg13_lv_pmos ad=0.2128p pd=1.5u as=0 ps=0 w=1.12u l=0.13u
X860 VDD.t156 a_23003_1842# a_23437_1842# VDD.t3 sg13_lv_pmos ad=0.2128p pd=1.5u as=0.3808p ps=2.92u w=1.12u l=0.13u
X861 VSS.t166 a_9444_4590# a_9444_4590# VSS.t165 sg13_lv_nmos ad=0.68p pd=4.68u as=0.38p ps=2.38u w=2u l=1u
X862 VSS.t329 VSS.t432 VSS.t432 VSS.t433 sg13_lv_nmos ad=0.68p pd=4.68u as=0 ps=0 w=2u l=1u
X863 a_12715_1044# a_12505_1044# VDD.t221 VDD.t0 sg13_lv_pmos ad=0.2128p pd=1.5u as=0.252p ps=1.57u w=1.12u l=0.13u
X864 a_19550_1044# a_21044_1008# a_20968_1044# VDD.t0 sg13_lv_pmos ad=0.3808p pd=2.92u as=0.2128p ps=1.5u w=1.12u l=0.13u
X865 a_17928_1044# a_17357_1842# VDD.t376 VDD.t0 sg13_lv_pmos ad=0.2128p pd=1.5u as=0.3808p ps=2.92u w=1.12u l=0.13u
X866 VSS.t157 DELAY_VBIASN a_21591_1842# VSS.t576 sg13_lv_nmos ad=0.2516p pd=2.16u as=0.1406p ps=1.12u w=0.74u l=0.6u
X867 VSS.t146 a_1544_289# a_1815_331# VSS.t283 sg13_lv_nmos ad=0.1331p pd=1.12u as=0.1216p ps=1.02u w=0.64u l=0.13u
X868 a_7288_1044# a_6717_1842# VDD.t235 VDD.t0 sg13_lv_pmos ad=0.2128p pd=1.5u as=0.3808p ps=2.92u w=1.12u l=0.13u
X869 VSS.t542 DELAY_VBIASN VSS.t544 VSS.t543 sg13_lv_nmos ad=1.33p pd=7.38u as=0 ps=0 w=7u l=7u
X870 a_5974_5723# a_6126_3816# VSS.t334 VSS.t328 sg13_lv_nmos ad=0.38p pd=2.38u as=0.68p ps=4.68u w=2u l=1u
X871 a_15511_2470# a_15273_1842# a_15403_1842# VDD.t3 sg13_lv_pmos ad=0.2128p pd=1.5u as=0.3808p ps=2.92u w=1.12u l=0.2u
X872 VSS.t463 VSS.t465 VSS.t467 VSS.t466 sg13_lv_nmos ad=0.1406p pd=1.12u as=0 ps=0 w=0.74u l=0.2u
X873 a_22590_1044# a_24951_1008# a_24875_1044# VDD.t0 sg13_lv_pmos ad=0.3808p pd=2.92u as=0.2128p ps=1.5u w=1.12u l=0.13u
X874 VSS.t76 VDD.t392 VSS.t76 VSS.t78 sg13_lv_nmos ad=79.8f pd=0.8u as=0 ps=0 w=0.42u l=1u
X875 VSS.t339 a_15108_5325# a_14757_5182# VSS.t597 sg13_lv_nmos ad=79.8f pd=0.8u as=0.1428p ps=1.52u w=0.42u l=0.13u
X876 a_10430_1044# a_2019_1047.t7 a_10328_1044# VSS.t409 sg13_lv_nmos ad=0.2516p pd=2.16u as=0.1406p ps=1.12u w=0.74u l=0.13u
X877 VDD.t326 a_5974_5723# a_5974_5723# VDD.t9 sg13_lv_pmos ad=0.2448p pd=2.08u as=0.2826p ps=2.29u w=0.36u l=2u
X878 VDD.t148 a_25717_1842# a_26185_1044# VDD.t0 sg13_lv_pmos ad=0.252p pd=1.57u as=0.3808p ps=2.92u w=1.12u l=0.13u
X879 a_6854_5454# a_6854_5454# a_9444_4590# VSS.t107 sg13_lv_nmos ad=0.38p pd=2.38u as=0.68p ps=4.68u w=2u l=1u
X880 VDD.t253 a_13883_1842# a_14317_1842# VDD.t3 sg13_lv_pmos ad=0.2128p pd=1.5u as=0.3808p ps=2.92u w=1.12u l=0.13u
X881 VDD.t138 a_4437_1842# a_4905_1044# VDD.t0 sg13_lv_pmos ad=0.252p pd=1.57u as=0.3808p ps=2.92u w=1.12u l=0.13u
X882 a_4157_1313# REF_CLK VSS.t499 VSS.t498 sg13_lv_nmos ad=0.2516p pd=2.16u as=0.2553p ps=2.17u w=0.74u l=0.13u
X883 a_7390_1044# a_3171_1047.t8 a_8808_1044# VSS.t618 sg13_lv_nmos ad=0.2516p pd=2.16u as=0.1406p ps=1.12u w=0.74u l=0.13u
X884 a_22873_1842# a_22677_1842# VSS.t261 VSS.t260 sg13_lv_nmos ad=0.2516p pd=2.16u as=0.1406p ps=1.12u w=0.74u l=0.13u
X885 a_9444_4590# a_9444_4590# VSS.t164 VSS.t163 sg13_lv_nmos ad=0.38p pd=2.38u as=0.68p ps=4.68u w=2u l=1u
X886 VDD.t388 a_3171_1047.t8 a_8884_1008# VDD.t0 sg13_lv_pmos ad=0.3808p pd=2.92u as=0.3808p ps=2.92u w=1.12u l=0.13u
C0 a_4350_1044# a_6711_1008# 0.26208f
C1 a_27991_1008# VDD 0.28201f
C2 a_12943_5867# VDD 0.29479f
C3 a_13019_5831# DELAY_VBIASN 1.23663f
C4 DELAY_OUT_LAST a_14851_5182# 0.02109f
C5 a_26803_1842# a_26911_2470# 0.01697f
C6 a_15837_1842# a_16484_1008# 0.02011f
C7 DELAY_VBIASP a_8237_1842# 0.0414f
C8 a_26477_1842# VDD 0.86909f
C9 a_17065_1044# VDD 0.30218f
C10 a_23633_1842# DELAY_VBIASN 0.10349f
C11 MUX_SEL4 VDD 2.63176f
C12 a_4157_1313# DELAY_VBIASN 0.01202f
C13 a_6717_1842# a_7477_1842# 0.06198f
C14 a_10232_5871# a_10520_6292# 0.43707f
C15 a_10430_1044# a_11271_1008# 0.28268f
C16 a_22590_1044# a_24084_1008# 0.28279f
C17 a_4003_1842# DELAY_VBIASN 0.06486f
C18 a_11603_1842# VDD 0.49671f
C19 a_20397_1842# a_20723_1842# 0.01427f
C20 a_10430_1044# a_10517_1842# 0.1088f
C21 a_23945_519# VDD 0.29292f
C22 a_6854_5986# a_13121_5831# 0.10056f
C23 a_14964_1008# VDD 0.28225f
C24 a_10843_1842# a_10951_1842# 0.01163f
C25 a_13592_5423# a_12849_5867# 0.38497f
C26 a_9757_1842# a_10517_1842# 0.06198f
C27 a_23003_1842# a_22590_1044# 0.01012f
C28 a_26803_1842# a_26911_1842# 0.01163f
C29 a_4248_1044# a_4350_1044# 0.37183f
C30 a_25528_1044# VDD 0.17274f
C31 a_18585_1044# a_18795_1044# 0.09424f
C32 MUX_OUT a_1544_1044# 0.04258f
C33 a_10083_1842# DELAY_VBIASN 0.07254f
C34 a_12849_5867# VDD 2.56972f
C35 a_25283_1842# a_25391_2470# 0.01697f
C36 a_16163_1842# a_16271_1842# 0.01163f
C37 a_23763_1842# VDD 0.49671f
C38 a_6425_1044# VDD 0.29722f
C39 a_16510_1044# a_17351_1008# 0.28268f
C40 a_9444_4590# a_5864_3367# 0.06832f
C41 a_7288_1044# VDD 0.17274f
C42 a_4763_1842# a_4871_1842# 0.01163f
C43 a_9675_1044# a_9751_1008# 0.01194f
C44 a_5197_1842# VDD 0.86909f
C45 a_19637_1842# a_19833_1842# 0.73897f
C46 a_11785_519# VDD 0.29292f
C47 a_11491_6228# VDD 0.16753f
C48 a_12715_1044# VDD 0.15406f
C49 a_9323_1842# a_9431_1842# 0.01163f
C50 a_15304_4605# a_12849_5867# 0.0606f
C51 a_14851_6228# a_13592_5871# 0.01529f
C52 a_8997_1842# a_8563_1842# 0.6972f
C53 a_25283_1842# a_25391_1842# 0.01163f
C54 a_15837_1842# a_16033_1842# 0.76914f
C55 a_11277_1842# VDD 0.86909f
C56 a_8433_1842# DELAY_VBIASN 0.0961f
C57 a_12158_5867# VDD 0.37862f
C58 a_23145_1044# a_23431_1008# 0.01885f
C59 a_23763_1842# a_23871_2470# 0.01697f
C60 a_14643_1842# a_14751_1842# 0.01163f
C61 a_22590_1044# a_23431_1008# 0.28268f
C62 a_16923_1842# a_17357_1842# 0.6972f
C63 a_5778_3367# a_6326_4590# 0.8779f
C64 a_4350_1044# a_6283_1842# 0.01012f
C65 a_14851_5182# a_15688_5403# 0.08776f
C66 a_4350_1044# VDD 0.87635f
C67 a_9547_5942# a_9547_6172# 0.1117f
C68 a_3449_331# a_2019_311# 0.01176f
C69 a_18313_1842# a_18443_1842# 0.70845f
C70 a_14111_5227# a_15108_5325# 0.03012f
C71 a_9751_1008# VDD 0.2822f
C72 a_7803_1842# a_7911_1842# 0.01163f
C73 a_7673_1842# a_8237_1842# 0.0114f
C74 a_23763_1842# a_23871_1842# 0.01163f
C75 a_14513_1842# a_14643_1842# 0.70845f
C76 a_2873_1395# a_1256_1044# 0.28892f
C77 a_8563_1842# VDD 0.49671f
C78 DELAY_VBIASP a_21917_1842# 0.04176f
C79 a_21835_1044# a_21911_1008# 0.01194f
C80 a_6326_4590# a_6126_3816# 2.84014f
C81 a_5974_5723# a_6854_5986# 0.029f
C82 a_1544_289# a_2297_331# 0.27303f
C83 a_1256_289# a_2873_331# 0.27926f
C84 a_13592_5423# a_6854_5986# 0.01958f
C85 DELAY_VBIASP a_16793_1842# 0.11284f
C86 a_21911_1008# VDD 0.2822f
C87 a_13592_5423# a_14009_5084# 0.3749f
C88 a_13306_5105# a_14111_5227# 0.097f
C89 a_6854_5986# VDD 1.20794f
C90 a_6283_1842# a_6391_1842# 0.01163f
C91 a_14009_5084# VDD 0.31815f
C92 a_20071_2470# VDD 0.01806f
C93 a_6913_1842# VDD 0.49426f
C94 MUX_SEL4 a_3449_331# 0.05166f
C95 DELAY_VBIASP a_19203_1842# 0.06661f
C96 a_19550_1044# a_21044_1008# 0.28279f
C97 a_20315_1044# a_20391_1008# 0.01194f
C98 a_26673_1842# a_26803_1842# 0.70845f
C99 a_2019_311# a_17865_519# 0.13959f
C100 a_16923_1842# a_16510_1044# 0.01012f
C101 a_15304_4605# a_6854_5986# 0.08165f
C102 a_19448_1044# VDD 0.17274f
C103 DELAY_VBIASP a_15077_1842# 0.04184f
C104 a_12907_5420# a_13132_5420# 0.02416f
C105 DELAY_VBIASP DLL_RESETN 0.07017f
C106 a_22113_1842# DELAY_VBIASN 0.10263f
C107 a_13991_2470# VDD 0.01806f
C108 a_26477_1842# a_27124_1008# 0.02312f
C109 a_12797_1842# a_12993_1842# 0.76914f
C110 a_4157_1313# a_2019_311# 0.01018f
C111 VDD a_24631_2470# 0.01806f
C112 DELAY_VBIASP a_17553_1842# 0.11284f
C113 a_13470_1044# a_15077_1842# 0.05231f
C114 a_14311_1008# a_14317_1842# 0.02349f
C115 a_21917_1842# a_22564_1008# 0.02011f
C116 a_27237_1842# DELAY_VBIASP 0.06225f
C117 MUX_SEL1 MUX_OUT 0.09357f
C118 MUX_SEL2 MUX_SEL4 0.01978f
C119 a_4111_2470# a_4003_1842# 0.01697f
C120 a_25630_1044# a_27048_1044# 0.38994f
C121 MUX_SEL4 a_6717_1842# 0.0195f
C122 DELAY_VBIASP a_12363_1842# 0.06627f
C123 MUX_OUT a_16851_309# 0.45865f
C124 a_22243_1842# VDD 0.49737f
C125 a_13306_6305# a_13592_5871# 0.41329f
C126 a_13019_5831# a_12943_5867# 0.03346f
C127 a_12849_5867# a_14009_5878# 0.03525f
C128 a_20397_1842# DELAY_VBIASN 0.10669f
C129 a_25717_1842# a_25630_1044# 0.1088f
C130 a_7911_2470# VDD 0.01806f
C131 a_9712_3912# DLL_RESETN 0.43103f
C132 a_13444_1008# a_12797_1842# 0.02011f
C133 a_10232_5871# REF_CLK 0.08086f
C134 a_10649_5878# DLL_RESETN 0.05713f
C135 a_24957_1842# a_25153_1842# 0.76914f
C136 a_21157_1842# a_21044_1008# 0.02055f
C137 a_24523_1842# DELAY_VBIASP 0.06661f
C138 MUX_SEL4 a_4157_1313# 0.08229f
C139 a_15273_1842# DELAY_VBIASN 0.10803f
C140 a_8231_1008# a_7945_1044# 0.01885f
C141 a_19963_1842# a_20071_2470# 0.01697f
C142 a_7390_1044# a_8808_1044# 0.38994f
C143 DELAY_VBIASP a_5957_1842# 0.04141f
C144 a_24957_1842# a_16108_289# 0.0157f
C145 a_20593_1842# VDD 0.49417f
C146 a_6717_1842# a_7288_1044# 0.10864f
C147 a_13019_5831# a_12849_5867# 0.12838f
C148 a_17683_1842# DELAY_VBIASN 0.07847f
C149 a_12505_1044# a_12791_1008# 0.01885f
C150 a_5393_1842# a_5523_1842# 0.70845f
C151 DELAY_VBIASP a_12037_1842# 0.04141f
C152 a_15765_463# a_16108_289# 0.42004f
C153 a_27433_1842# DELAY_VBIASN 0.10734f
C154 a_13368_1044# a_13444_1008# 0.01176f
C155 a_9444_4590# DLL_RESETN 0.10269f
C156 a_23633_1842# a_23763_1842# 0.70845f
C157 a_20397_1842# a_19550_1044# 0.08038f
C158 a_22873_1842# DELAY_VBIASP 0.11284f
C159 a_22677_1842# a_22243_1842# 0.69698f
C160 a_15403_1842# VDD 0.4973f
C161 MUX_SEL0 a_2873_1395# 0.01504f
C162 a_13557_1842# DELAY_VBIASN 0.08375f
C163 a_6635_1044# a_6425_1044# 0.09424f
C164 a_18443_1842# a_18551_2470# 0.01697f
C165 DELAY_VBIASP a_9712_3912# 0.14197f
C166 a_5705_519# VDD 0.29556f
C167 a_18877_1842# VDD 0.87825f
C168 a_6717_1842# a_4350_1044# 0.02479f
C169 a_10985_1044# a_10430_1044# 0.03209f
C170 DELAY_VBIASP a_9323_1842# 0.06627f
C171 a_27563_1842# VDD 0.49811f
C172 a_25717_1842# DELAY_VBIASN 0.09106f
C173 a_5731_289# a_16108_289# 0.01334f
C174 a_27705_1044# a_25630_1044# 0.03208f
C175 a_10751_5878# a_11491_6228# 0.26905f
C176 a_12907_5420# DLL_RESETN 0.04234f
C177 a_15464_3684# a_13121_5831# 0.33256f
C178 a_18877_1842# a_18871_1008# 0.02354f
C179 a_6153_1842# DELAY_VBIASN 0.0961f
C180 a_13753_1842# VDD 0.49349f
C181 a_21353_1842# a_21917_1842# 0.0114f
C182 a_11848_1044# a_11277_1842# 0.10863f
C183 a_4350_1044# a_4157_1313# 0.04624f
C184 a_15108_5325# a_12849_5867# 0.10521f
C185 a_16923_1842# a_17031_2470# 0.01697f
C186 a_4350_1044# a_6635_1044# 0.39036f
C187 a_20105_1044# a_20391_1008# 0.01885f
C188 a_27915_1044# VDD 0.15389f
C189 a_4437_1842# a_4324_1008# 0.05157f
C190 a_9444_3912# a_5864_3367# 0.02483f
C191 DELAY_VBIASP a_7673_1842# 0.11222f
C192 a_22590_1044# a_16108_289# 0.58202f
C193 a_25913_1842# VDD 0.49294f
C194 a_23003_1842# DELAY_VBIASN 0.08024f
C195 a_15545_1044# VDD 0.29918f
C196 MUX_SEL3 VDD 0.4053f
C197 a_7390_1044# a_7803_1842# 0.01012f
C198 a_10430_1044# a_11195_1044# 0.39037f
C199 a_6717_1842# a_6913_1842# 0.76914f
C200 a_4437_1842# DELAY_VBIASN 0.08375f
C201 a_20397_1842# a_21157_1842# 0.03319f
C202 a_20905_519# VDD 0.29292f
C203 a_14888_1044# VDD 0.17499f
C204 a_9757_1842# a_9953_1842# 0.76914f
C205 a_14851_6228# a_15108_6109# 0.29858f
C206 a_13306_5105# a_12849_5867# 0.10976f
C207 a_23437_1842# a_22590_1044# 0.08038f
C208 a_16597_1842# a_17357_1842# 0.01669f
C209 a_24951_1008# VDD 0.2822f
C210 MUX_SEL4 a_1544_1044# 0.03407f
C211 MUX_OUT a_1256_1044# 0.02466f
C212 a_10517_1842# DELAY_VBIASN 0.08375f
C213 a_13121_5831# VDD 0.99724f
C214 a_24197_1842# VDD 0.85848f
C215 a_5864_3367# a_6854_5454# 0.03661f
C216 a_4905_1044# VDD 0.30126f
C217 a_16510_1044# a_17275_1044# 0.39037f
C218 a_9444_4590# a_9712_3912# 0.68929f
C219 a_6711_1008# VDD 0.2822f
C220 a_4633_1842# VDD 0.49285f
C221 a_19637_1842# a_19203_1842# 0.69698f
C222 a_11748_6109# VDD 0.16819f
C223 a_11924_1008# VDD 0.28225f
C224 a_8433_1842# a_8563_1842# 0.70845f
C225 a_15304_4605# a_13121_5831# 0.40921f
C226 a_15837_1842# a_15403_1842# 0.6972f
C227 a_10713_1842# VDD 0.49294f
C228 a_7803_1842# DELAY_VBIASN 0.07254f
C229 a_23145_1044# a_23355_1044# 0.09424f
C230 a_22590_1044# a_23355_1044# 0.39037f
C231 a_16923_1842# a_16793_1842# 0.70845f
C232 a_2297_1395# VDD 0.46536f
C233 a_14009_5084# a_14757_5182# 0.01058f
C234 a_4248_1044# VDD 0.17587f
C235 a_15464_3684# VDD 0.52511f
C236 a_18313_1842# a_18877_1842# 0.0114f
C237 a_14111_5227# a_14851_5182# 0.26905f
C238 a_9675_1044# VDD 0.15406f
C239 a_9946_6305# VDD 0.77198f
C240 a_14513_1842# a_15077_1842# 0.0114f
C241 a_8997_1842# VDD 0.85848f
C242 DELAY_VBIASP a_21353_1842# 0.11284f
C243 a_16510_1044# a_16597_1842# 0.1088f
C244 a_27997_1842# a_27563_1842# 0.69646f
C245 a_6326_4590# a_6854_5986# 1.31745f
C246 a_1256_289# a_2297_331# 0.04261f
C247 a_1544_289# a_1721_331# 0.36963f
C248 DELAY_VBIASP a_16163_1842# 0.06661f
C249 a_21835_1044# VDD 0.15406f
C250 a_13306_5105# a_14009_5084# 0.02454f
C251 a_13880_6292# a_14111_5878# 0.12701f
C252 a_5974_5723# VDD 0.91576f
C253 a_13592_5423# VDD 0.11685f
C254 a_19311_2470# VDD 0.01806f
C255 a_13557_1842# a_14317_1842# 0.01669f
C256 MUX_SEL3 a_3449_331# 0.28429f
C257 MUX_SEL4 a_2873_331# 0.04916f
C258 a_6283_1842# VDD 0.4973f
C259 MUX_OUT a_2297_331# 0.01179f
C260 a_18585_1044# a_18117_1842# 0.2079f
C261 a_12797_1842# DLL_RESETN 0.0106f
C262 DELAY_VBIASP a_19637_1842# 0.04176f
C263 a_26673_1842# a_27237_1842# 0.0114f
C264 a_19550_1044# a_20968_1044# 0.38994f
C265 a_2019_311# a_16851_309# 0.01299f
C266 a_4763_1842# a_4871_2470# 0.01697f
C267 a_13306_6305# REF_CLK 0.05059f
C268 a_1721_1395# VDD 0.4533f
C269 a_18871_1008# VDD 0.2822f
C270 DELAY_VBIASP a_14513_1842# 0.12091f
C271 a_15304_4605# a_13592_5423# 0.01817f
C272 a_21483_1842# DELAY_VBIASN 0.08024f
C273 a_18585_1044# a_16510_1044# 0.03208f
C274 a_15304_4605# VDD 0.72158f
C275 a_13231_2470# VDD 0.01806f
C276 a_26477_1842# a_27048_1044# 0.10863f
C277 VDD a_23871_2470# 0.01806f
C278 a_12797_1842# a_12363_1842# 0.6972f
C279 DELAY_VBIASP a_16923_1842# 0.06661f
C280 a_25717_1842# a_26477_1842# 0.01669f
C281 a_26673_1842# DELAY_VBIASP 0.11284f
C282 MUX_SEL2 MUX_SEL3 3.21891f
C283 a_17357_1842# DELAY_VBIASN 0.10669f
C284 MUX_SEL1 MUX_SEL4 0.03574f
C285 a_25630_1044# a_26471_1008# 0.28268f
C286 DELAY_VBIASP a_12797_1842# 0.0414f
C287 a_22677_1842# VDD 0.86707f
C288 MUX_OUT a_16108_289# 0.24265f
C289 a_12849_5867# a_13592_5871# 0.38817f
C290 a_19833_1842# DELAY_VBIASN 0.10734f
C291 a_13121_5831# a_14009_5878# 0.01604f
C292 a_13306_6305# a_13566_5835# 0.75507f
C293 a_7151_2470# VDD 0.01806f
C294 a_9444_3912# DLL_RESETN 0.03031f
C295 a_16108_289# a_26985_519# 0.27952f
C296 a_10232_5871# DLL_RESETN 0.39088f
C297 a_13470_1044# a_15831_1008# 0.26208f
C298 a_12797_1842# a_12037_1842# 0.02912f
C299 a_24957_1842# a_24523_1842# 0.6972f
C300 a_25630_1044# a_16108_289# 0.52614f
C301 a_21483_1842# a_19550_1044# 0.01012f
C302 a_24957_1842# DELAY_VBIASP 0.04176f
C303 a_14643_1842# DELAY_VBIASN 0.08431f
C304 DELAY_OUT_LAST DELAY_VBIASP 1.08837f
C305 REF_CLK DELAY_VBIASN 0.07156f
C306 a_8155_1044# a_7945_1044# 0.09424f
C307 a_24875_1044# a_24951_1008# 0.01194f
C308 a_7390_1044# a_8231_1008# 0.28268f
C309 DELAY_VBIASP a_5393_1842# 0.11222f
C310 a_19963_1842# VDD 0.4973f
C311 a_14851_6228# a_14757_6228# 0.28931f
C312 a_6717_1842# a_6711_1008# 0.02354f
C313 a_12355_5867# a_13306_6305# 0.26489f
C314 a_13019_5831# a_13121_5831# 0.56469f
C315 a_18117_1842# DELAY_VBIASN 0.09851f
C316 a_12656_5864# a_12849_5867# 0.33075f
C317 a_12505_1044# a_12715_1044# 0.09424f
C318 a_5393_1842# a_5957_1842# 0.0114f
C319 DELAY_VBIASP a_11473_1842# 0.11222f
C320 a_26803_1842# DELAY_VBIASN 0.08024f
C321 a_15765_463# a_15964_289# 0.061f
C322 a_27705_1044# a_27991_1008# 0.01885f
C323 a_10430_1044# a_12363_1842# 0.01012f
C324 a_6854_5454# DLL_RESETN 0.03626f
C325 a_16271_2470# a_16163_1842# 0.01697f
C326 a_13368_1044# a_13470_1044# 0.37183f
C327 a_23633_1842# a_24197_1842# 0.0114f
C328 a_22113_1842# a_22243_1842# 0.70845f
C329 a_15837_1842# VDD 0.87963f
C330 a_12993_1842# DELAY_VBIASN 0.0961f
C331 a_16510_1044# DELAY_VBIASN 0.02115f
C332 a_11473_1842# a_12037_1842# 0.0114f
C333 a_6635_1044# a_6711_1008# 0.01194f
C334 a_3449_331# VDD 0.46596f
C335 a_18313_1842# VDD 0.49285f
C336 a_5197_1842# a_5844_1008# 0.02312f
C337 a_4437_1842# a_5197_1842# 0.01669f
C338 DELAY_VBIASP a_9757_1842# 0.0414f
C339 a_27997_1842# VDD 0.76025f
C340 a_5731_289# a_15964_289# 0.2778f
C341 a_25153_1842# DELAY_VBIASN 0.10332f
C342 a_8884_1008# a_8997_1842# 0.02055f
C343 a_26185_1044# a_25630_1044# 0.03209f
C344 a_13470_1044# a_5731_289# 0.41365f
C345 a_14751_2470# a_14643_1842# 0.01697f
C346 a_10751_5878# a_11748_6109# 0.03061f
C347 a_11848_1044# a_11924_1008# 0.01176f
C348 a_12907_5186# DLL_RESETN 0.02177f
C349 a_15464_3684# a_13019_5831# 0.59875f
C350 a_5523_1842# DELAY_VBIASN 0.07254f
C351 a_13123_1842# VDD 0.49727f
C352 a_11271_1008# a_11277_1842# 0.02349f
C353 a_10430_1044# a_12037_1842# 0.05231f
C354 a_4248_1044# a_4157_1313# 0.11672f
C355 a_15108_5325# a_13121_5831# 0.05903f
C356 a_14851_5182# a_12849_5867# 0.13376f
C357 a_10517_1842# a_11277_1842# 0.01669f
C358 a_24523_1842# a_22590_1044# 0.01012f
C359 a_4350_1044# a_5844_1008# 0.28279f
C360 a_5115_1044# a_5191_1008# 0.01194f
C361 a_20105_1044# a_20315_1044# 0.09424f
C362 a_27124_1008# VDD 0.28225f
C363 a_4437_1842# a_4350_1044# 0.1088f
C364 a_14009_5878# VDD 0.23872f
C365 a_9444_3912# a_9712_3912# 0.81869f
C366 a_5778_3367# a_5864_3367# 0.07306f
C367 DELAY_VBIASP a_7043_1842# 0.06627f
C368 a_25283_1842# VDD 0.49737f
C369 a_23437_1842# DELAY_VBIASN 0.10669f
C370 a_5731_289# a_8745_519# 0.28635f
C371 a_14025_1044# VDD 0.30409f
C372 MUX_SEL2 VDD 0.50938f
C373 a_7390_1044# a_8237_1842# 0.08038f
C374 a_8884_1008# VDD 0.28225f
C375 a_13231_2470# a_13123_1842# 0.01697f
C376 a_10232_5871# a_10649_5878# 0.37583f
C377 a_6717_1842# a_6283_1842# 0.6972f
C378 a_9946_6305# a_10751_5878# 0.097f
C379 a_10430_1044# a_10404_1008# 0.277f
C380 a_6717_1842# VDD 0.87726f
C381 a_20397_1842# a_20593_1842# 0.76914f
C382 a_17865_519# VDD 0.29444f
C383 a_10404_1008# a_9757_1842# 0.02011f
C384 a_14311_1008# VDD 0.28336f
C385 a_13566_5328# a_12849_5867# 0.26617f
C386 a_14851_6228# a_14111_5878# 0.26905f
C387 a_9757_1842# a_9323_1842# 0.6972f
C388 a_16597_1842# a_16793_1842# 0.73897f
C389 MUX_SEL4 a_1256_1044# 0.04908f
C390 a_24875_1044# VDD 0.15406f
C391 a_9953_1842# DELAY_VBIASN 0.0961f
C392 a_13019_5831# VDD 0.41932f
C393 a_19550_1044# a_16108_289# 0.58202f
C394 a_23633_1842# VDD 0.49417f
C395 a_9712_3912# a_6854_5454# 0.67835f
C396 a_5864_3367# a_6126_3816# 0.23738f
C397 a_4157_1313# VDD 0.48935f
C398 a_16510_1044# a_16484_1008# 0.277f
C399 a_9444_4590# a_9444_3912# 2.19249f
C400 a_15108_5325# a_15464_3684# 0.12158f
C401 a_6635_1044# VDD 0.15406f
C402 a_11711_2470# a_11603_1842# 0.01697f
C403 a_9772_5843# a_9946_6305# 0.27179f
C404 a_4003_1842# VDD 0.61559f
C405 a_19073_1842# a_19203_1842# 0.70845f
C406 a_10751_5878# VDD 0.20377f
C407 a_11848_1044# VDD 0.17499f
C408 a_15304_4605# a_13019_5831# 0.07025f
C409 a_8433_1842# a_8997_1842# 0.0114f
C410 a_15273_1842# a_15403_1842# 0.70845f
C411 a_10083_1842# VDD 0.49727f
C412 a_8237_1842# DELAY_VBIASN 0.09974f
C413 a_24665_1044# a_22590_1044# 0.03208f
C414 a_22590_1044# a_22564_1008# 0.277f
C415 a_14111_5227# a_13880_5118# 0.12701f
C416 a_13592_5423# a_14757_5182# 0.43239f
C417 a_2297_331# a_2019_311# 0.04011f
C418 a_9444_4590# a_6854_5454# 1.24134f
C419 a_24008_1044# VDD 0.17499f
C420 a_9772_5843# VDD 0.24701f
C421 a_10951_2470# a_10843_1842# 0.01697f
C422 a_15108_5325# VDD 0.13728f
C423 a_7477_1842# a_8237_1842# 0.01669f
C424 a_14317_1842# a_14643_1842# 0.01427f
C425 a_2297_1395# a_1544_1044# 0.28651f
C426 a_8433_1842# VDD 0.49417f
C427 a_20105_1044# a_19637_1842# 0.19203f
C428 DELAY_VBIASP a_20723_1842# 0.06661f
C429 a_27433_1842# a_27563_1842# 0.70845f
C430 a_16510_1044# a_2019_311# 0.03139f
C431 a_18443_1842# a_16510_1044# 0.01012f
C432 a_15304_4605# a_14757_5182# 0.02225f
C433 a_6326_4590# a_5974_5723# 0.33136f
C434 a_1256_289# a_1721_331# 0.13421f
C435 DELAY_VBIASP a_16597_1842# 0.04176f
C436 a_21044_1008# VDD 0.28225f
C437 a_13306_5105# a_13592_5423# 0.41329f
C438 a_15304_4605# a_15108_5325# 0.01986f
C439 a_13566_5328# a_14009_5084# 0.02242f
C440 MUX_SEL4 REF_CLK 0.0663f
C441 a_6326_4590# VDD 7.53039f
C442 a_9431_2470# a_9323_1842# 0.01697f
C443 a_13306_5105# VDD 0.79678f
C444 a_18551_2470# VDD 0.01806f
C445 a_13557_1842# a_13753_1842# 0.73897f
C446 MUX_SEL4 a_2297_331# 0.04338f
C447 MUX_SEL2 a_3449_331# 0.10741f
C448 MUX_SEL3 a_2873_331# 0.12606f
C449 DELAY_VBIASP a_19073_1842# 0.11286f
C450 a_19550_1044# a_20391_1008# 0.28268f
C451 a_26477_1842# a_26803_1842# 0.01427f
C452 a_2019_311# a_16108_289# 0.33889f
C453 a_12849_5867# REF_CLK 0.26382f
C454 a_1544_1044# VDD 0.45079f
C455 DELAY_VBIASP a_13883_1842# 0.06627f
C456 a_18795_1044# VDD 0.15406f
C457 a_13106_5357# a_13132_5420# 0.1657f
C458 a_12907_5186# a_12907_5420# 0.1117f
C459 a_13306_6305# a_14111_5878# 0.097f
C460 a_12849_5867# a_15108_6109# 0.10225f
C461 a_21917_1842# DELAY_VBIASN 0.10687f
C462 a_17065_1044# a_16510_1044# 0.03209f
C463 a_7911_2470# a_7803_1842# 0.01697f
C464 a_12471_2470# VDD 0.01806f
C465 a_27237_1842# a_25630_1044# 0.05253f
C466 a_26477_1842# a_26471_1008# 0.02349f
C467 a_12233_1842# a_12363_1842# 0.70845f
C468 VDD a_23111_2470# 0.01806f
C469 a_13470_1044# a_13883_1842# 0.01012f
C470 a_11491_6228# REF_CLK 0.01827f
C471 a_1544_1044# a_1721_1395# 0.38063f
C472 a_18795_1044# a_18871_1008# 0.01194f
C473 a_25717_1842# a_25913_1842# 0.73897f
C474 a_21917_1842# a_22488_1044# 0.10864f
C475 a_26043_1842# DELAY_VBIASP 0.06661f
C476 a_16793_1842# DELAY_VBIASN 0.10734f
C477 a_12158_5867# REF_CLK 0.01309f
C478 a_25630_1044# a_26395_1044# 0.39037f
C479 DELAY_VBIASP a_12233_1842# 0.11222f
C480 MUX_SEL4 a_16108_289# 0.1283f
C481 MUX_OUT a_15964_289# 0.01307f
C482 a_22113_1842# VDD 0.49426f
C483 a_13121_5831# a_13592_5871# 0.01445f
C484 a_12849_5867# a_13566_5835# 0.27346f
C485 a_19203_1842# DELAY_VBIASN 0.07852f
C486 a_14025_1044# a_14311_1008# 0.01885f
C487 a_6391_2470# a_6283_1842# 0.01697f
C488 a_24957_1842# a_25604_1008# 0.02011f
C489 a_6391_2470# VDD 0.01806f
C490 DELAY_VBIASP a_25630_1044# 0.01522f
C491 a_5778_3367# DLL_RESETN 0.01215f
C492 a_16108_289# a_23945_519# 0.2906f
C493 a_13368_1044# a_12797_1842# 0.10864f
C494 a_10206_5835# DLL_RESETN 0.27343f
C495 a_13470_1044# a_15755_1044# 0.39036f
C496 a_12233_1842# a_12037_1842# 0.77122f
C497 a_17275_1044# a_17351_1008# 0.01194f
C498 a_24393_1842# a_24523_1842# 0.70845f
C499 a_21917_1842# a_19550_1044# 0.02479f
C500 a_24393_1842# DELAY_VBIASP 0.11284f
C501 a_15077_1842# DELAY_VBIASN 0.10039f
C502 DLL_RESETN DELAY_VBIASN 0.12907f
C503 a_7390_1044# a_9465_1044# 0.03208f
C504 a_7390_1044# a_8155_1044# 0.39037f
C505 a_22243_1842# a_22351_2470# 0.01697f
C506 DELAY_VBIASP a_4763_1842# 0.06627f
C507 a_14851_6228# a_15688_5867# 0.08776f
C508 a_20397_1842# VDD 0.86909f
C509 a_12355_5867# a_12849_5867# 0.07687f
C510 a_17553_1842# DELAY_VBIASN 0.10734f
C511 a_5197_1842# a_5523_1842# 0.01427f
C512 a_24197_1842# a_24084_1008# 0.02055f
C513 DELAY_VBIASP a_10843_1842# 0.06627f
C514 a_27237_1842# DELAY_VBIASN 0.10152f
C515 a_10430_1044# a_12797_1842# 0.02479f
C516 a_27705_1044# a_27915_1044# 0.09424f
C517 a_13470_1044# a_14825_519# 0.02058f
C518 a_6854_5986# REF_CLK 0.05061f
C519 a_6126_3816# DLL_RESETN 0.06398f
C520 a_23437_1842# a_23763_1842# 0.01427f
C521 a_22243_1842# a_22351_1842# 0.01163f
C522 a_19637_1842# a_19524_1008# 0.05157f
C523 a_15273_1842# VDD 0.49298f
C524 a_22113_1842# a_22677_1842# 0.0114f
C525 MUX_SEL1 a_2297_1395# 0.01995f
C526 a_12363_1842# DELAY_VBIASN 0.07254f
C527 a_4437_1842# a_4905_1044# 0.19203f
C528 a_2873_331# VDD 0.46491f
C529 a_17683_1842# VDD 0.49671f
C530 a_5197_1842# a_5768_1044# 0.10863f
C531 a_12158_5867# a_12355_5867# 0.12454f
C532 a_7390_1044# a_8745_519# 0.01756f
C533 a_4437_1842# a_4633_1842# 0.73897f
C534 DELAY_VBIASP a_9193_1842# 0.11222f
C535 a_27433_1842# VDD 0.49285f
C536 a_5731_289# a_15765_463# 0.23301f
C537 a_24523_1842# DELAY_VBIASN 0.08024f
C538 a_7390_1044# a_9323_1842# 0.01012f
C539 DELAY_VBIASP DELAY_VBIASN 8.74838f
C540 a_13106_5357# DLL_RESETN 0.01263f
C541 a_20723_1842# a_20831_1842# 0.01163f
C542 a_5957_1842# DELAY_VBIASN 0.09156f
C543 a_21157_1842# a_21917_1842# 0.02912f
C544 a_13557_1842# VDD 0.86707f
C545 a_10649_5878# a_11397_6228# 0.01058f
C546 a_13470_1044# DELAY_VBIASN 0.02115f
C547 a_14851_5182# a_13121_5831# 0.03337f
C548 a_10517_1842# a_10713_1842# 0.73897f
C549 a_4350_1044# a_5768_1044# 0.38994f
C550 a_24957_1842# a_22590_1044# 0.02479f
C551 DELAY_OUT_LAST a_15688_5403# 0.01699f
C552 a_27048_1044# VDD 0.17499f
C553 a_12037_1842# DELAY_VBIASN 0.09156f
C554 a_13592_5871# VDD 0.07242f
C555 DELAY_VBIASP a_6126_3816# 0.01821f
C556 DELAY_VBIASP a_7477_1842# 0.0414f
C557 a_25717_1842# VDD 0.86707f
C558 a_22873_1842# DELAY_VBIASN 0.10734f
C559 a_12505_1044# VDD 0.29722f
C560 MUX_SEL1 VDD 0.50267f
C561 a_10430_1044# a_5731_289# 0.41176f
C562 a_8808_1044# VDD 0.17499f
C563 a_10206_5835# a_10649_5878# 0.02242f
C564 a_9946_6305# a_10520_6292# 0.31978f
C565 a_6153_1842# a_6283_1842# 0.70845f
C566 a_10328_1044# a_10404_1008# 0.01176f
C567 a_6153_1842# VDD 0.49285f
C568 a_19203_1842# a_19311_1842# 0.01163f
C569 a_9712_3912# DELAY_VBIASN 0.22281f
C570 a_20397_1842# a_19963_1842# 0.6972f
C571 a_16851_309# VDD 0.51536f
C572 a_14235_1044# VDD 0.15389f
C573 a_13132_5420# a_12849_5867# 0.06758f
C574 a_9193_1842# a_9323_1842# 0.70845f
C575 a_16597_1842# a_16163_1842# 0.69698f
C576 a_24084_1008# VDD 0.28225f
C577 a_9323_1842# DELAY_VBIASN 0.07254f
C578 a_12656_5864# VDD 0.26066f
C579 a_23003_1842# VDD 0.4973f
C580 a_9444_3912# a_6854_5454# 0.8486f
C581 a_3449_1395# VDD 0.46731f
C582 a_16408_1044# a_16484_1008# 0.01176f
C583 a_14851_5182# a_15464_3684# 0.04797f
C584 a_9444_4590# a_5778_3367# 0.19787f
C585 a_5844_1008# VDD 0.28225f
C586 a_4437_1842# VDD 0.86998f
C587 a_17683_1842# a_17791_1842# 0.01163f
C588 a_19073_1842# a_19637_1842# 0.0114f
C589 a_11271_1008# VDD 0.28336f
C590 a_8237_1842# a_8563_1842# 0.01427f
C591 a_15273_1842# a_15837_1842# 0.0114f
C592 a_10517_1842# VDD 0.86707f
C593 a_7673_1842# DELAY_VBIASN 0.0961f
C594 a_23145_1044# a_22590_1044# 0.03209f
C595 a_22488_1044# a_22564_1008# 0.01176f
C596 a_14009_5084# a_13880_5118# 0.01562f
C597 a_27705_1044# VDD 0.29918f
C598 a_1721_331# a_2019_311# 0.18452f
C599 a_9444_4590# a_6126_3816# 0.03029f
C600 a_23431_1008# VDD 0.28336f
C601 a_18117_1842# a_18877_1842# 0.02912f
C602 a_13592_5423# a_14851_5182# 0.01529f
C603 a_9746_5805# VDD 0.0918f
C604 a_7477_1842# a_7673_1842# 0.73897f
C605 a_14851_5182# VDD 0.26676f
C606 a_14317_1842# a_15077_1842# 0.03319f
C607 a_7803_1842# VDD 0.4973f
C608 a_2297_1395# a_1256_1044# 0.04619f
C609 DELAY_VBIASP a_21157_1842# 0.04177f
C610 a_27433_1842# a_27997_1842# 0.0114f
C611 a_12943_5867# DLL_RESETN 0.03616f
C612 a_18877_1842# a_16510_1044# 0.02479f
C613 a_1256_289# a_1544_289# 1.25711f
C614 a_13132_5420# a_6854_5986# 0.01367f
C615 DELAY_VBIASP a_16033_1842# 0.11287f
C616 a_20968_1044# VDD 0.17499f
C617 a_15304_4605# a_14851_5182# 0.05156f
C618 a_13566_5328# a_13592_5423# 0.36952f
C619 a_13566_5328# VDD 0.0947f
C620 a_17791_2470# VDD 0.01806f
C621 a_13557_1842# a_13123_1842# 0.69698f
C622 MUX_OUT a_1544_289# 0.69943f
C623 MUX_SEL3 a_2297_331# 0.01595f
C624 MUX_SEL2 a_2873_331# 0.01422f
C625 MUX_SEL4 a_1721_331# 0.05813f
C626 DELAY_VBIASP a_18443_1842# 0.06661f
C627 a_14964_1008# a_15077_1842# 0.02055f
C628 a_19550_1044# a_20315_1044# 0.39037f
C629 a_26477_1842# a_27237_1842# 0.03319f
C630 a_2019_311# a_15964_289# 0.02413f
C631 a_18877_1842# a_16108_289# 0.0157f
C632 a_12849_5867# DLL_RESETN 0.3501f
C633 a_13121_5831# REF_CLK 1.40135f
C634 a_27048_1044# a_27124_1008# 0.01176f
C635 a_14025_1044# a_13557_1842# 0.19203f
C636 a_1256_1044# VDD 0.475f
C637 DELAY_VBIASP a_14317_1842# 0.04316f
C638 a_18004_1008# VDD 0.28225f
C639 a_13106_5357# a_12907_5420# 0.14994f
C640 a_21353_1842# DELAY_VBIASN 0.10734f
C641 a_13121_5831# a_15108_6109# 0.03701f
C642 a_13592_5871# a_14009_5878# 0.37583f
C643 a_13306_6305# a_13880_6292# 0.31978f
C644 a_12849_5867# a_14111_5878# 0.42174f
C645 a_11711_2470# VDD 0.01806f
C646 a_12233_1842# a_12797_1842# 0.0114f
C647 VDD a_22351_2470# 0.01806f
C648 a_13470_1044# a_14317_1842# 0.08038f
C649 a_11748_6109# REF_CLK 0.0148f
C650 a_11491_6228# DLL_RESETN 0.14622f
C651 a_15755_1044# a_15831_1008# 0.01194f
C652 a_1256_1044# a_1721_1395# 0.13421f
C653 a_25717_1842# a_25283_1842# 0.69698f
C654 a_21917_1842# a_21911_1008# 0.02354f
C655 a_26477_1842# DELAY_VBIASP 0.04181f
C656 a_16163_1842# DELAY_VBIASN 0.08306f
C657 a_12158_5867# DLL_RESETN 0.02442f
C658 a_25630_1044# a_25604_1008# 0.277f
C659 a_8808_1044# a_8884_1008# 0.01176f
C660 DELAY_VBIASP a_11603_1842# 0.06627f
C661 MUX_SEL4 a_15964_289# 0.5544f
C662 a_21483_1842# VDD 0.4973f
C663 a_13121_5831# a_13566_5835# 0.01158f
C664 a_19637_1842# DELAY_VBIASN 0.0907f
C665 a_13019_5831# a_13592_5871# 0.04178f
C666 MUX_SEL4 a_13470_1044# 0.256f
C667 a_14025_1044# a_14235_1044# 0.09424f
C668 a_6153_1842# a_6717_1842# 0.0114f
C669 a_5631_2470# VDD 0.01806f
C670 a_16108_289# a_20905_519# 0.2906f
C671 a_12791_1008# a_12797_1842# 0.02354f
C672 a_13470_1044# a_14964_1008# 0.28279f
C673 a_14235_1044# a_14311_1008# 0.01194f
C674 a_11603_1842# a_12037_1842# 0.6972f
C675 a_24393_1842# a_24957_1842# 0.0114f
C676 a_20397_1842# a_21044_1008# 0.02312f
C677 a_23763_1842# DELAY_VBIASP 0.06661f
C678 a_17357_1842# VDD 0.86909f
C679 a_14513_1842# DELAY_VBIASN 0.102f
C680 a_7390_1044# a_7945_1044# 0.03209f
C681 a_7390_1044# a_7364_1008# 0.277f
C682 DELAY_VBIASP a_5197_1842# 0.0414f
C683 a_5957_1842# a_6425_1044# 0.2079f
C684 MUX_SEL4 a_8745_519# 0.04472f
C685 a_19833_1842# VDD 0.49294f
C686 MUX_OUT a_5731_289# 1.04829f
C687 a_12355_5867# a_13121_5831# 0.05795f
C688 a_12656_5864# a_13019_5831# 0.04193f
C689 a_16923_1842# DELAY_VBIASN 0.08024f
C690 a_5197_1842# a_5957_1842# 0.03319f
C691 a_4871_2470# VDD 0.01806f
C692 DELAY_VBIASP a_11277_1842# 0.0414f
C693 a_26673_1842# DELAY_VBIASN 0.105f
C694 a_6854_5986# DLL_RESETN 0.50331f
C695 a_12363_1842# a_12471_1842# 0.01163f
C696 a_13592_5423# REF_CLK 0.03445f
C697 a_23437_1842# a_24197_1842# 0.03319f
C698 a_19637_1842# a_19550_1044# 0.1088f
C699 a_14643_1842# VDD 0.49675f
C700 a_21917_1842# a_22243_1842# 0.01427f
C701 a_12797_1842# DELAY_VBIASN 0.09992f
C702 MUX_SEL0 a_2297_1395# 0.10655f
C703 VDD REF_CLK 2.08015f
C704 a_11277_1842# a_12037_1842# 0.03319f
C705 a_4437_1842# a_4157_1313# 0.01771f
C706 a_2297_331# VDD 0.46496f
C707 a_18117_1842# VDD 0.85848f
C708 a_5957_1842# a_4350_1044# 0.05231f
C709 a_5197_1842# a_5191_1008# 0.02349f
C710 a_15108_6109# VDD 0.1349f
C711 a_9465_1044# a_9751_1008# 0.01885f
C712 a_7390_1044# a_5731_289# 0.41331f
C713 a_4437_1842# a_4003_1842# 0.69698f
C714 a_27563_1842# a_27671_2470# 0.01697f
C715 DELAY_VBIASP a_8563_1842# 0.06627f
C716 a_26803_1842# VDD 0.49671f
C717 a_5731_289# a_14825_519# 0.28056f
C718 a_24957_1842# DELAY_VBIASN 0.10687f
C719 a_7390_1044# a_9757_1842# 0.02479f
C720 DELAY_OUT_LAST DELAY_VBIASN 3.19293f
C721 a_10520_6292# a_10751_5878# 0.12701f
C722 a_10430_1044# a_12791_1008# 0.26208f
C723 a_24008_1044# a_24084_1008# 0.01176f
C724 a_15304_4605# REF_CLK 0.01066f
C725 a_5393_1842# DELAY_VBIASN 0.0961f
C726 a_21157_1842# a_21353_1842# 0.77122f
C727 a_12993_1842# VDD 0.49426f
C728 a_10430_1044# a_10843_1842# 0.01012f
C729 a_10232_5871# a_11397_6228# 0.43239f
C730 a_16510_1044# VDD 0.8795f
C731 a_15304_4605# a_15108_6109# 0.17528f
C732 a_10517_1842# a_10083_1842# 0.69698f
C733 a_27563_1842# a_27671_1842# 0.01163f
C734 a_4350_1044# a_5191_1008# 0.28268f
C735 a_20105_1044# a_19550_1044# 0.03209f
C736 a_26471_1008# VDD 0.28336f
C737 a_11473_1842# DELAY_VBIASN 0.0961f
C738 a_13566_5835# VDD 0.09466f
C739 DELAY_VBIASP a_6854_5986# 0.01478f
C740 DELAY_OUT_LAST a_14111_5227# 0.02024f
C741 a_26043_1842# a_26151_2470# 0.01697f
C742 DELAY_VBIASP a_6913_1842# 0.11222f
C743 a_7945_1044# a_7477_1842# 0.19203f
C744 a_25153_1842# VDD 0.49426f
C745 a_10985_1044# VDD 0.30409f
C746 MUX_SEL0 VDD 0.56365f
C747 a_7364_1008# a_7477_1842# 0.05157f
C748 a_16510_1044# a_18871_1008# 0.26208f
C749 a_8231_1008# VDD 0.28336f
C750 a_5523_1842# a_5631_1842# 0.01163f
C751 a_10206_5835# a_10232_5871# 0.36952f
C752 a_10328_1044# a_10430_1044# 0.37183f
C753 a_5523_1842# VDD 0.49671f
C754 a_19833_1842# a_19963_1842# 0.70845f
C755 a_16108_289# VDD 1.22378f
C756 a_10328_1044# a_9757_1842# 0.10864f
C757 a_13444_1008# VDD 0.28633f
C758 a_10430_1044# DELAY_VBIASN 0.02115f
C759 a_10083_1842# a_10191_1842# 0.01163f
C760 a_9193_1842# a_9757_1842# 0.0114f
C761 a_26043_1842# a_26151_1842# 0.01163f
C762 a_16033_1842# a_16163_1842# 0.70845f
C763 MUX_SEL0 a_1721_1395# 0.01315f
C764 a_17065_1044# a_17351_1008# 0.01885f
C765 MUX_SEL1 a_1544_1044# 0.1672f
C766 a_9757_1842# DELAY_VBIASN 0.09992f
C767 a_12355_5867# VDD 0.37639f
C768 a_24523_1842# a_24631_2470# 0.01697f
C769 a_15403_1842# a_15511_1842# 0.01163f
C770 a_23437_1842# VDD 0.86909f
C771 a_5864_3367# a_5974_5723# 0.01697f
C772 a_5778_3367# a_6854_5454# 0.02695f
C773 a_9712_3912# a_6854_5986# 0.13962f
C774 a_9444_3912# a_6126_3816# 0.25721f
C775 a_14851_5182# a_14757_5182# 0.28931f
C776 a_5768_1044# VDD 0.17499f
C777 a_4003_1842# a_4111_1842# 0.01163f
C778 a_9746_5805# a_9772_5843# 0.1657f
C779 a_5864_3367# VDD 0.13532f
C780 a_18877_1842# a_19203_1842# 0.01427f
C781 a_22590_1044# DELAY_VBIASN 0.02115f
C782 a_14851_5182# a_15108_5325# 0.29858f
C783 a_11195_1044# VDD 0.15389f
C784 a_8563_1842# a_8671_1842# 0.01163f
C785 a_8237_1842# a_8997_1842# 0.03319f
C786 a_24523_1842# a_24631_1842# 0.01163f
C787 a_9953_1842# VDD 0.49426f
C788 a_7043_1842# DELAY_VBIASN 0.07254f
C789 DELAY_VBIASP a_22243_1842# 0.06661f
C790 a_23003_1842# a_23111_2470# 0.01697f
C791 a_22488_1044# a_22590_1044# 0.37183f
C792 a_13883_1842# a_13991_1842# 0.01163f
C793 a_3449_331# REF_CLK 0.01017f
C794 a_13592_5423# a_13880_5118# 0.43707f
C795 a_26185_1044# VDD 0.30409f
C796 a_6126_3816# a_6854_5454# 0.22705f
C797 a_1544_289# a_2019_311# 0.01747f
C798 a_9444_4590# a_6854_5986# 0.05054f
C799 a_13880_5118# VDD 0.02994f
C800 a_23355_1044# VDD 0.15389f
C801 a_18117_1842# a_18313_1842# 0.77122f
C802 a_9547_6172# VDD 0.08695f
C803 a_7043_1842# a_7151_1842# 0.01163f
C804 a_7477_1842# a_7043_1842# 0.69698f
C805 a_23003_1842# a_23111_1842# 0.01163f
C806 a_14317_1842# a_14513_1842# 0.76914f
C807 a_23437_1842# a_22677_1842# 0.01669f
C808 a_8237_1842# VDD 0.86909f
C809 DELAY_VBIASP a_20593_1842# 0.11287f
C810 a_20968_1044# a_21044_1008# 0.01176f
C811 a_14009_5878# REF_CLK 0.25847f
C812 DELAY_VBIASP a_15403_1842# 0.06668f
C813 a_20391_1008# VDD 0.28336f
C814 a_15545_1044# a_15077_1842# 0.2079f
C815 a_13566_5328# a_13306_5105# 0.75507f
C816 a_13132_5420# VDD 0.23863f
C817 a_17031_2470# VDD 0.01806f
C818 a_12993_1842# a_13123_1842# 0.70845f
C819 VDD a_27671_2470# 0.01806f
C820 MUX_OUT a_1256_289# 0.1134f
C821 MUX_SEL4 a_1544_289# 0.47529f
C822 MUX_SEL2 a_2297_331# 0.10655f
C823 DELAY_VBIASP a_18877_1842# 0.04176f
C824 a_13470_1044# a_15403_1842# 0.01012f
C825 a_19550_1044# a_19524_1008# 0.277f
C826 a_26477_1842# a_26673_1842# 0.76914f
C827 a_2019_311# a_15765_463# 0.05969f
C828 a_27563_1842# DELAY_VBIASP 0.06663f
C829 a_13121_5831# DLL_RESETN 0.04337f
C830 a_13019_5831# REF_CLK 0.35409f
C831 a_17928_1044# VDD 0.17499f
C832 MUX_SEL4 a_12797_1842# 0.01829f
C833 DELAY_VBIASP a_13753_1842# 0.11222f
C834 a_13106_5357# a_12907_5186# 0.02437f
C835 a_13566_5835# a_14009_5878# 0.02242f
C836 a_13121_5831# a_14111_5878# 0.0235f
C837 a_4157_1313# REF_CLK 0.50643f
C838 a_20723_1842# DELAY_VBIASN 0.07937f
C839 a_26043_1842# a_25630_1044# 0.01012f
C840 a_10951_2470# VDD 0.01806f
C841 VDD a_21591_2470# 0.01806f
C842 a_4003_1842# REF_CLK 0.55467f
C843 a_16510_1044# a_17865_519# 0.02165f
C844 a_10751_5878# REF_CLK 0.01931f
C845 a_11748_6109# DLL_RESETN 0.11133f
C846 a_1256_1044# a_1544_1044# 1.26509f
C847 a_25153_1842# a_25283_1842# 0.70845f
C848 a_2019_311# a_5731_289# 1.15781f
C849 a_25630_1044# a_26985_519# 0.02195f
C850 a_25913_1842# DELAY_VBIASP 0.11284f
C851 a_16597_1842# DELAY_VBIASN 0.0907f
C852 MUX_SEL0 MUX_SEL2 0.01204f
C853 a_20723_1842# a_20831_2470# 0.01697f
C854 a_25528_1044# a_25604_1008# 0.01176f
C855 MUX_SEL4 a_15765_463# 0.65508f
C856 a_21917_1842# VDD 0.87825f
C857 a_19073_1842# DELAY_VBIASN 0.10642f
C858 a_15545_1044# a_13470_1044# 0.03208f
C859 a_24957_1842# a_25528_1044# 0.10864f
C860 a_16108_289# a_17865_519# 0.29564f
C861 DELAY_OUT_LAST a_12849_5867# 0.01791f
C862 a_9946_6305# DLL_RESETN 0.09997f
C863 a_13470_1044# a_14888_1044# 0.38994f
C864 a_11603_1842# a_11473_1842# 0.70845f
C865 a_20397_1842# a_20968_1044# 0.10863f
C866 a_24197_1842# DELAY_VBIASP 0.04177f
C867 a_16793_1842# VDD 0.49277f
C868 MUX_SEL1 a_3449_1395# 0.29404f
C869 a_13883_1842# DELAY_VBIASN 0.07254f
C870 a_19203_1842# a_19311_2470# 0.01697f
C871 a_7288_1044# a_7364_1008# 0.01176f
C872 DELAY_VBIASP a_4633_1842# 0.11222f
C873 MUX_SEL4 a_5731_289# 4.60702f
C874 a_19203_1842# VDD 0.49737f
C875 a_12355_5867# a_13019_5831# 0.3846f
C876 MUX_SEL4 a_10430_1044# 0.24983f
C877 a_5197_1842# a_5393_1842# 0.76914f
C878 MUX_SEL4 a_9757_1842# 0.01829f
C879 DELAY_VBIASP a_10713_1842# 0.11222f
C880 a_26043_1842# DELAY_VBIASN 0.08024f
C881 a_5974_5723# DLL_RESETN 0.02002f
C882 a_13306_5105# REF_CLK 0.06166f
C883 a_23437_1842# a_23633_1842# 0.76914f
C884 a_15077_1842# VDD 0.85965f
C885 a_21917_1842# a_22677_1842# 0.06198f
C886 a_11924_1008# a_12037_1842# 0.02055f
C887 a_12233_1842# DELAY_VBIASN 0.0961f
C888 VDD DLL_RESETN 2.47079f
C889 a_5191_1008# a_4905_1044# 0.01885f
C890 a_17683_1842# a_17791_2470# 0.01697f
C891 a_11277_1842# a_11473_1842# 0.76914f
C892 a_1721_331# VDD 0.45259f
C893 a_25630_1044# DELAY_VBIASN 0.02756f
C894 a_17553_1842# VDD 0.49417f
C895 a_14111_5878# VDD 0.21331f
C896 a_9465_1044# a_9675_1044# 0.09424f
C897 a_16597_1842# a_16484_1008# 0.05157f
C898 a_9465_1044# a_8997_1842# 0.2079f
C899 DELAY_VBIASP a_8997_1842# 0.04141f
C900 a_22590_1044# a_23945_519# 0.02165f
C901 a_27237_1842# VDD 0.85969f
C902 a_24393_1842# DELAY_VBIASN 0.10734f
C903 a_5731_289# a_11785_519# 0.28056f
C904 a_8884_1008# a_8237_1842# 0.02312f
C905 a_24665_1044# a_24951_1008# 0.01885f
C906 a_10430_1044# a_11785_519# 0.02058f
C907 a_10232_5871# a_11491_6228# 0.01529f
C908 a_7390_1044# DELAY_VBIASN 0.02115f
C909 a_10430_1044# a_12715_1044# 0.39036f
C910 a_15304_4605# DLL_RESETN 0.03137f
C911 a_4763_1842# DELAY_VBIASN 0.07254f
C912 a_21157_1842# a_20723_1842# 0.6972f
C913 a_12363_1842# VDD 0.4973f
C914 a_10430_1044# a_11277_1842# 0.08038f
C915 a_24197_1842# a_24665_1044# 0.2079f
C916 a_16408_1044# VDD 0.17274f
C917 a_15304_4605# a_14111_5878# 0.01811f
C918 a_9953_1842# a_10083_1842# 0.70845f
C919 a_4350_1044# a_5115_1044# 0.39037f
C920 a_23437_1842# a_24008_1044# 0.10863f
C921 a_26395_1044# VDD 0.15389f
C922 a_10843_1842# DELAY_VBIASN 0.07254f
C923 DELAY_OUT_LAST a_6854_5986# 0.08491f
C924 a_4350_1044# a_5731_289# 0.41099f
C925 a_15464_3684# a_9712_3912# 0.01237f
C926 DELAY_OUT_LAST a_14009_5084# 0.25594f
C927 DELAY_VBIASP a_6283_1842# 0.06627f
C928 a_24523_1842# VDD 0.4973f
C929 DELAY_VBIASP VDD 14.6649f
C930 a_9465_1044# VDD 0.29722f
C931 a_16510_1044# a_18795_1044# 0.39036f
C932 a_7390_1044# a_7477_1842# 0.1088f
C933 a_8155_1044# VDD 0.15389f
C934 a_9946_6305# a_10649_5878# 0.02432f
C935 a_5957_1842# VDD 0.85848f
C936 a_19833_1842# a_20397_1842# 0.0114f
C937 a_9751_1008# a_9757_1842# 0.02354f
C938 a_15964_289# VDD 0.31312f
C939 a_13470_1044# VDD 0.87936f
C940 a_14757_6228# a_14009_5878# 0.01058f
C941 a_16033_1842# a_16597_1842# 0.0114f
C942 a_12037_1842# VDD 0.85848f
C943 MUX_SEL1 a_1256_1044# 1.44243f
C944 MUX_SEL0 a_1544_1044# 0.07603f
C945 a_17065_1044# a_17275_1044# 0.09424f
C946 a_9193_1842# DELAY_VBIASN 0.0961f
C947 a_17683_1842# a_17357_1842# 0.01427f
C948 a_22873_1842# VDD 0.49294f
C949 a_5778_3367# a_6126_3816# 1.6143f
C950 a_9444_3912# a_6854_5986# 0.01142f
C951 a_5864_3367# a_6326_4590# 0.01889f
C952 a_9712_3912# a_5974_5723# 0.01152f
C953 a_5191_1008# VDD 0.28565f
C954 a_9712_3912# VDD 0.21864f
C955 a_18877_1842# a_19637_1842# 0.06198f
C956 a_8745_519# VDD 0.29292f
C957 a_10649_5878# VDD 0.23431f
C958 a_10404_1008# VDD 0.28633f
C959 a_8237_1842# a_8433_1842# 0.76914f
C960 a_15688_5867# a_13121_5831# 0.17255f
C961 a_14851_6228# a_12849_5867# 0.13392f
C962 a_15077_1842# a_15837_1842# 0.02912f
C963 a_9323_1842# VDD 0.4973f
C964 a_7477_1842# DELAY_VBIASN 0.08375f
C965 DELAY_VBIASP a_22677_1842# 0.04176f
C966 a_13306_5105# a_13880_5118# 0.31978f
C967 a_24665_1044# VDD 0.29722f
C968 a_6854_5986# a_6854_5454# 0.30877f
C969 a_1256_289# a_2019_311# 0.02904f
C970 a_17065_1044# a_16597_1842# 0.19203f
C971 a_22564_1008# VDD 0.28633f
C972 a_18117_1842# a_17683_1842# 0.6972f
C973 a_19550_1044# DELAY_VBIASN 0.02115f
C974 a_9547_5942# VDD 0.1511f
C975 a_6913_1842# a_7043_1842# 0.70845f
C976 a_9444_4590# VDD 0.01557f
C977 a_14317_1842# a_13883_1842# 0.6972f
C978 a_22873_1842# a_22677_1842# 0.73897f
C979 a_7673_1842# VDD 0.49294f
C980 MUX_OUT a_2019_311# 8.45486f
C981 DELAY_VBIASP a_19963_1842# 0.06661f
C982 a_21625_1044# a_19550_1044# 0.03208f
C983 a_16408_1044# a_15837_1842# 0.10864f
C984 a_13592_5871# REF_CLK 0.11539f
C985 a_20315_1044# VDD 0.15389f
C986 DELAY_VBIASP a_15837_1842# 0.04182f
C987 a_13132_5420# a_13306_5105# 0.27179f
C988 MUX_SEL1 REF_CLK 0.01858f
C989 a_14009_5878# a_14111_5878# 0.47795f
C990 a_12907_5420# VDD 0.07751f
C991 a_16271_2470# VDD 0.01806f
C992 a_27237_1842# a_27124_1008# 0.02055f
C993 a_12993_1842# a_13557_1842# 0.0114f
C994 VDD a_26911_2470# 0.01806f
C995 MUX_SEL2 a_1721_331# 0.01315f
C996 MUX_SEL4 a_1256_289# 0.65005f
C997 MUX_SEL3 a_1544_289# 0.15976f
C998 a_15837_1842# a_15964_289# 0.02f
C999 DELAY_VBIASP a_18313_1842# 0.11284f
C1000 a_13470_1044# a_15837_1842# 0.02479f
C1001 a_19448_1044# a_19524_1008# 0.01176f
C1002 a_26477_1842# a_26043_1842# 0.6972f
C1003 a_22677_1842# a_22564_1008# 0.05157f
C1004 a_27997_1842# DELAY_VBIASP 0.04038f
C1005 MUX_SEL4 MUX_OUT 0.91933f
C1006 a_12656_5864# REF_CLK 0.01215f
C1007 a_13019_5831# DLL_RESETN 0.01429f
C1008 a_25630_1044# a_27991_1008# 0.26208f
C1009 a_17351_1008# VDD 0.28565f
C1010 DELAY_VBIASP a_13123_1842# 0.06627f
C1011 a_21157_1842# DELAY_VBIASN 0.09851f
C1012 a_13566_5835# a_13592_5871# 0.36952f
C1013 a_3449_1395# REF_CLK 0.01058f
C1014 a_15545_1044# a_15831_1008# 0.01885f
C1015 a_15688_5867# VDD 0.30345f
C1016 a_10191_2470# VDD 0.01806f
C1017 a_26477_1842# a_25630_1044# 0.08038f
C1018 a_4437_1842# REF_CLK 0.05209f
C1019 a_13444_1008# a_13557_1842# 0.05157f
C1020 a_16510_1044# a_16851_309# 0.02131f
C1021 a_10751_5878# DLL_RESETN 0.45018f
C1022 a_21625_1044# a_21157_1842# 0.2079f
C1023 a_25153_1842# a_25717_1842# 0.0114f
C1024 a_5705_519# a_5731_289# 0.28954f
C1025 a_25283_1842# DELAY_VBIASP 0.06661f
C1026 a_16033_1842# DELAY_VBIASN 0.10793f
C1027 MUX_SEL0 MUX_SEL1 3.14917f
C1028 MUX_SEL4 a_7390_1044# 0.34655f
C1029 a_25528_1044# a_25630_1044# 0.37183f
C1030 DELAY_VBIASP a_6717_1842# 0.0414f
C1031 a_21353_1842# VDD 0.49285f
C1032 MUX_SEL4 a_14825_519# 0.03307f
C1033 a_15688_5867# a_15304_4605# 0.19136f
C1034 a_12849_5867# a_13306_6305# 0.12097f
C1035 a_18443_1842# DELAY_VBIASN 0.08024f
C1036 a_14025_1044# a_13470_1044# 0.03209f
C1037 a_5957_1842# a_6717_1842# 0.02912f
C1038 a_24957_1842# a_24951_1008# 0.02354f
C1039 a_16108_289# a_16851_309# 0.06181f
C1040 DELAY_OUT_LAST a_13121_5831# 0.13178f
C1041 DELAY_VBIASP a_13019_5831# 0.02377f
C1042 a_9772_5843# DLL_RESETN 0.06592f
C1043 a_13470_1044# a_14311_1008# 0.28268f
C1044 a_24197_1842# a_24957_1842# 0.02912f
C1045 a_21157_1842# a_19550_1044# 0.05231f
C1046 a_20397_1842# a_20391_1008# 0.02349f
C1047 a_23633_1842# DELAY_VBIASP 0.11286f
C1048 a_16163_1842# VDD 0.4973f
C1049 MUX_SEL0 a_3449_1395# 0.10753f
C1050 a_14317_1842# DELAY_VBIASN 0.09974f
C1051 a_7288_1044# a_7390_1044# 0.37183f
C1052 DELAY_VBIASP a_4003_1842# 0.05992f
C1053 a_19637_1842# VDD 0.86707f
C1054 a_12355_5867# a_12656_5864# 0.03277f
C1055 a_10985_1044# a_11271_1008# 0.01885f
C1056 a_5197_1842# a_4763_1842# 0.6972f
C1057 a_23437_1842# a_24084_1008# 0.02312f
C1058 a_17357_1842# a_18004_1008# 0.02312f
C1059 a_10985_1044# a_10517_1842# 0.19203f
C1060 DELAY_VBIASP a_10083_1842# 0.06627f
C1061 a_26477_1842# DELAY_VBIASN 0.1083f
C1062 a_15511_2470# a_15403_1842# 0.01697f
C1063 a_12715_1044# a_12791_1008# 0.01194f
C1064 a_13566_5328# REF_CLK 0.01093f
C1065 a_23437_1842# a_23003_1842# 0.6972f
C1066 a_9712_3912# a_13019_5831# 0.03275f
C1067 a_18877_1842# a_19524_1008# 0.02011f
C1068 a_21917_1842# a_22113_1842# 0.76914f
C1069 a_14513_1842# VDD 0.49436f
C1070 a_11603_1842# DELAY_VBIASN 0.07254f
C1071 a_25717_1842# a_26185_1044# 0.19203f
C1072 a_11491_6228# a_11397_6228# 0.28931f
C1073 a_5115_1044# a_4905_1044# 0.09424f
C1074 a_11277_1842# a_10843_1842# 0.6972f
C1075 a_5768_1044# a_5844_1008# 0.01176f
C1076 DELAY_OUT_LAST a_15464_3684# 0.02565f
C1077 a_1544_289# VDD 0.39113f
C1078 a_16923_1842# VDD 0.4973f
C1079 a_4763_1842# a_4350_1044# 0.01012f
C1080 a_7390_1044# a_9751_1008# 0.26208f
C1081 DELAY_VBIASP a_8433_1842# 0.11222f
C1082 a_26673_1842# VDD 0.49417f
C1083 a_23763_1842# DELAY_VBIASN 0.08024f
C1084 a_20105_1044# VDD 0.30409f
C1085 a_24665_1044# a_24875_1044# 0.09424f
C1086 a_8808_1044# a_8237_1842# 0.10863f
C1087 a_13991_2470# a_13883_1842# 0.01697f
C1088 a_10649_5878# a_10751_5878# 0.47795f
C1089 a_11195_1044# a_11271_1008# 0.01194f
C1090 a_10430_1044# a_11924_1008# 0.28279f
C1091 a_22590_1044# a_24951_1008# 0.26208f
C1092 a_15688_5403# a_13121_5831# 0.01441f
C1093 a_18117_1842# a_18004_1008# 0.02055f
C1094 a_5197_1842# DELAY_VBIASN 0.09974f
C1095 a_12797_1842# VDD 0.87771f
C1096 a_20593_1842# a_20723_1842# 0.70845f
C1097 a_15831_1008# VDD 0.2816f
C1098 a_14111_5227# a_12849_5867# 0.42064f
C1099 a_9953_1842# a_10517_1842# 0.0114f
C1100 a_24197_1842# a_22590_1044# 0.05231f
C1101 a_23437_1842# a_23431_1008# 0.02349f
C1102 a_4350_1044# a_4324_1008# 0.277f
C1103 a_25604_1008# VDD 0.28633f
C1104 a_11277_1842# DELAY_VBIASN 0.09974f
C1105 DELAY_OUT_LAST a_13592_5423# 0.08062f
C1106 a_24957_1842# VDD 0.87825f
C1107 a_7945_1044# VDD 0.30409f
C1108 DELAY_OUT_LAST VDD 0.70591f
C1109 a_16510_1044# a_18004_1008# 0.28279f
C1110 a_7364_1008# VDD 0.28633f
C1111 a_12471_2470# a_12363_1842# 0.01697f
C1112 a_9946_6305# a_10232_5871# 0.41329f
C1113 a_4350_1044# DELAY_VBIASN 0.02115f
C1114 a_5393_1842# VDD 0.49417f
C1115 a_15765_463# VDD 0.35368f
C1116 a_13368_1044# VDD 0.17274f
C1117 a_14757_6228# a_13592_5871# 0.43239f
C1118 a_8997_1842# a_9757_1842# 0.02912f
C1119 a_15837_1842# a_16163_1842# 0.01427f
C1120 a_11473_1842# VDD 0.49417f
C1121 MUX_SEL0 a_1256_1044# 0.3314f
C1122 a_8563_1842# DELAY_VBIASN 0.07254f
C1123 a_15688_5403# a_15464_3684# 0.1999f
C1124 DELAY_OUT_LAST a_15304_4605# 0.05582f
C1125 a_23355_1044# a_23431_1008# 0.01194f
C1126 a_18117_1842# a_17357_1842# 0.03319f
C1127 a_9712_3912# a_6326_4590# 0.04737f
C1128 a_2873_1395# VDD 0.46517f
C1129 a_5115_1044# VDD 0.15389f
C1130 a_9547_5942# a_9772_5843# 0.02416f
C1131 a_9547_6172# a_9746_5805# 0.02437f
C1132 a_9444_3912# VDD 0.0107f
C1133 a_18877_1842# a_19073_1842# 0.76914f
C1134 a_5731_289# VDD 0.6143f
C1135 a_10232_5871# VDD 0.07206f
C1136 a_10430_1044# VDD 0.88416f
C1137 a_6854_5986# DELAY_VBIASN 0.15808f
C1138 a_15688_5867# a_13019_5831# 0.0195f
C1139 a_14851_6228# a_13121_5831# 0.03404f
C1140 a_8237_1842# a_7803_1842# 0.6972f
C1141 a_15077_1842# a_15273_1842# 0.77122f
C1142 a_9757_1842# VDD 0.87771f
C1143 a_6913_1842# DELAY_VBIASN 0.0961f
C1144 DELAY_VBIASP a_22113_1842# 0.11286f
C1145 a_16510_1044# a_17357_1842# 0.08038f
C1146 a_21625_1044# a_21911_1008# 0.01885f
C1147 a_5523_1842# a_5631_2470# 0.01697f
C1148 a_23145_1044# VDD 0.30409f
C1149 a_5974_5723# a_6854_5454# 0.01757f
C1150 a_6854_5986# a_6126_3816# 0.18536f
C1151 a_9444_4590# a_6326_4590# 0.01269f
C1152 a_15688_5403# VDD 0.30345f
C1153 a_22590_1044# VDD 0.89557f
C1154 a_17553_1842# a_17683_1842# 0.70845f
C1155 a_14009_5084# a_14111_5227# 0.47622f
C1156 a_6854_5454# VDD 1.03678f
C1157 a_10191_2470# a_10083_1842# 0.01697f
C1158 a_6913_1842# a_7477_1842# 0.0114f
C1159 a_13753_1842# a_13883_1842# 0.70845f
C1160 MUX_SEL4 a_2019_311# 0.90276f
C1161 a_7043_1842# VDD 0.49723f
C1162 DELAY_VBIASP a_20397_1842# 0.04176f
C1163 a_15831_1008# a_15837_1842# 0.02354f
C1164 a_27237_1842# a_27433_1842# 0.77122f
C1165 a_19550_1044# a_21911_1008# 0.26208f
C1166 a_13566_5835# REF_CLK 0.01538f
C1167 a_18117_1842# a_16510_1044# 0.05231f
C1168 a_19524_1008# VDD 0.28633f
C1169 DELAY_VBIASP a_15273_1842# 0.11297f
C1170 a_13592_5871# a_14111_5878# 0.34102f
C1171 a_14009_5878# a_13880_6292# 0.01562f
C1172 a_22243_1842# DELAY_VBIASN 0.08024f
C1173 MUX_SEL0 REF_CLK 0.14089f
C1174 a_8671_2470# a_8563_1842# 0.01697f
C1175 a_12907_5186# VDD 0.06323f
C1176 a_15511_2470# VDD 0.01806f
C1177 a_27563_1842# a_25630_1044# 0.01024f
C1178 a_12797_1842# a_13123_1842# 0.01427f
C1179 VDD a_26151_2470# 0.01806f
C1180 MUX_SEL3 a_1256_289# 1.41161f
C1181 MUX_SEL2 a_1544_289# 0.07405f
C1182 DELAY_VBIASP a_17683_1842# 0.06661f
C1183 a_14964_1008# a_14317_1842# 0.02312f
C1184 a_23145_1044# a_22677_1842# 0.19203f
C1185 a_19448_1044# a_19550_1044# 0.37183f
C1186 a_25913_1842# a_26043_1842# 0.70845f
C1187 a_22677_1842# a_22590_1044# 0.1088f
C1188 a_27997_1842# DELAY_OUT_LAST 0.70957f
C1189 a_27433_1842# DELAY_VBIASP 0.11284f
C1190 MUX_SEL3 MUX_OUT 0.79533f
C1191 a_12355_5867# REF_CLK 1.0042f
C1192 a_12656_5864# DLL_RESETN 0.11782f
C1193 a_25630_1044# a_27915_1044# 0.39036f
C1194 DELAY_VBIASP a_13557_1842# 0.0414f
C1195 a_17275_1044# VDD 0.15389f
C1196 a_12849_5867# a_12943_5867# 0.16706f
C1197 a_20593_1842# DELAY_VBIASN 0.10398f
C1198 a_15545_1044# a_15755_1044# 0.09424f
C1199 a_7151_2470# a_7043_1842# 0.01697f
C1200 a_14851_6228# VDD 0.25326f
C1201 a_9431_2470# VDD 0.01806f
C1202 a_4350_1044# a_2019_311# 0.02042f
C1203 a_13470_1044# a_13557_1842# 0.1088f
C1204 a_16510_1044# a_16108_289# 0.56108f
C1205 a_17928_1044# a_18004_1008# 0.01176f
C1206 a_24957_1842# a_25283_1842# 0.01427f
C1207 a_25717_1842# DELAY_VBIASP 0.04176f
C1208 a_15403_1842# DELAY_VBIASN 0.08418f
C1209 DELAY_VBIASP a_6153_1842# 0.11222f
C1210 MUX_SEL4 a_11785_519# 0.03255f
C1211 a_14851_6228# a_15304_4605# 0.12139f
C1212 a_6717_1842# a_7364_1008# 0.02011f
C1213 a_20723_1842# VDD 0.49671f
C1214 a_13019_5831# a_13045_6215# 0.01249f
C1215 a_13121_5831# a_13306_6305# 0.01008f
C1216 a_18877_1842# DELAY_VBIASN 0.10687f
C1217 a_5957_1842# a_6153_1842# 0.77122f
C1218 a_12505_1044# a_12037_1842# 0.2079f
C1219 a_27563_1842# DELAY_VBIASN 0.08029f
C1220 a_15964_289# a_16851_309# 0.16757f
C1221 DELAY_OUT_LAST a_13019_5831# 0.08017f
C1222 a_13470_1044# a_14235_1044# 0.39037f
C1223 a_11603_1842# a_11277_1842# 0.01427f
C1224 a_24197_1842# a_24393_1842# 0.77122f
C1225 a_23003_1842# DELAY_VBIASP 0.06661f
C1226 a_16597_1842# VDD 0.86876f
C1227 a_13753_1842# DELAY_VBIASN 0.0961f
C1228 a_27237_1842# a_27705_1044# 0.2079f
C1229 MUX_SEL4 a_4350_1044# 0.31434f
C1230 a_21483_1842# a_21591_2470# 0.01697f
C1231 DELAY_VBIASP a_4437_1842# 0.0414f
C1232 a_19073_1842# VDD 0.49426f
C1233 a_5957_1842# a_5844_1008# 0.02055f
C1234 a_10985_1044# a_11195_1044# 0.09424f
C1235 a_4633_1842# a_4763_1842# 0.70845f
C1236 a_17357_1842# a_17928_1044# 0.10863f
C1237 DELAY_VBIASP a_10517_1842# 0.0414f
C1238 a_25913_1842# DELAY_VBIASN 0.10734f
C1239 a_26185_1044# a_26471_1008# 0.01885f
C1240 a_13132_5420# REF_CLK 0.02025f
C1241 a_22873_1842# a_23003_1842# 0.70845f
C1242 a_21483_1842# a_21591_1842# 0.01163f
C1243 a_21917_1842# a_21483_1842# 0.6972f
C1244 a_13883_1842# VDD 0.49742f
C1245 a_11491_6228# a_12158_5867# 0.0894f
C1246 a_4350_1044# a_6425_1044# 0.03208f
C1247 a_10713_1842# a_10843_1842# 0.70845f
C1248 a_1256_289# VDD 0.40292f
C1249 a_5197_1842# a_4350_1044# 0.08038f
C1250 DELAY_OUT_LAST a_15108_5325# 0.01399f
C1251 a_7390_1044# a_9675_1044# 0.39036f
C1252 DELAY_VBIASP a_7803_1842# 0.06627f
C1253 a_26043_1842# VDD 0.4973f
C1254 a_24197_1842# DELAY_VBIASN 0.09851f
C1255 MUX_OUT VDD 0.35871f
C1256 a_18585_1044# VDD 0.29722f
C1257 a_7390_1044# a_8997_1842# 0.05231f
C1258 a_8231_1008# a_8237_1842# 0.02349f
C1259 a_10232_5871# a_10751_5878# 0.34102f
C1260 a_10649_5878# a_10520_6292# 0.01562f
C1261 a_6717_1842# a_7043_1842# 0.01427f
C1262 a_10430_1044# a_11848_1044# 0.38994f
C1263 a_22590_1044# a_24875_1044# 0.39036f
C1264 a_15688_5403# a_13019_5831# 0.1287f
C1265 a_19963_1842# a_20071_1842# 0.01163f
C1266 a_4633_1842# DELAY_VBIASN 0.0961f
C1267 a_12233_1842# VDD 0.49285f
C1268 a_20593_1842# a_21157_1842# 0.0114f
C1269 a_10404_1008# a_10517_1842# 0.05157f
C1270 a_26985_519# VDD 0.29292f
C1271 a_6854_5986# a_12849_5867# 0.06216f
C1272 a_15755_1044# VDD 0.15389f
C1273 a_9757_1842# a_10083_1842# 0.01427f
C1274 a_14009_5084# a_12849_5867# 0.03463f
C1275 a_4248_1044# a_4324_1008# 0.01176f
C1276 a_16793_1842# a_17357_1842# 0.0114f
C1277 a_18585_1044# a_18871_1008# 0.01885f
C1278 a_25630_1044# VDD 0.89531f
C1279 a_10713_1842# DELAY_VBIASN 0.0961f
C1280 a_13306_6305# VDD 0.77573f
C1281 a_19550_1044# a_20905_519# 0.02165f
C1282 a_24393_1842# VDD 0.49285f
C1283 a_16510_1044# a_17928_1044# 0.38994f
C1284 a_7390_1044# VDD 0.8686f
C1285 a_9946_6305# a_10206_5835# 0.75507f
C1286 a_4763_1842# VDD 0.4973f
C1287 a_18443_1842# a_18551_1842# 0.01163f
C1288 a_19637_1842# a_20397_1842# 0.01669f
C1289 a_14825_519# VDD 0.29292f
C1290 a_12791_1008# VDD 0.2822f
C1291 a_8997_1842# a_9193_1842# 0.77122f
C1292 a_15837_1842# a_16597_1842# 0.06198f
C1293 a_10843_1842# VDD 0.4973f
C1294 a_8997_1842# DELAY_VBIASN 0.09156f
C1295 a_22590_1044# a_24008_1044# 0.38994f
C1296 a_17553_1842# a_17357_1842# 0.76914f
C1297 a_5778_3367# a_5974_5723# 2.88221f
C1298 a_4324_1008# VDD 0.28597f
C1299 a_9547_5942# a_9746_5805# 0.14994f
C1300 a_5705_519# a_2019_311# 0.13872f
C1301 a_16923_1842# a_17031_1842# 0.01163f
C1302 a_18877_1842# a_18443_1842# 0.6972f
C1303 a_10328_1044# VDD 0.17274f
C1304 a_10206_5835# VDD 0.09392f
C1305 a_7673_1842# a_7803_1842# 0.70845f
C1306 a_14851_6228# a_13019_5831# 0.01651f
C1307 a_15077_1842# a_14643_1842# 0.6972f
C1308 a_9193_1842# VDD 0.49285f
C1309 a_6283_1842# DELAY_VBIASN 0.07254f
C1310 DELAY_VBIASP a_21483_1842# 0.06661f
C1311 a_21625_1044# a_21835_1044# 0.09424f
C1312 DLL_RESETN REF_CLK 10.7961f
C1313 VDD DELAY_VBIASN 1.49209f
C1314 a_21917_1842# a_16108_289# 0.0157f
C1315 a_14111_5878# REF_CLK 0.02263f
C1316 a_21625_1044# VDD 0.29722f
C1317 a_5974_5723# a_6126_3816# 1.74589f
C1318 a_6326_4590# a_6854_5454# 1.25249f
C1319 a_22488_1044# VDD 0.17274f
C1320 DELAY_VBIASP a_17357_1842# 0.04176f
C1321 a_17553_1842# a_18117_1842# 0.0114f
C1322 a_13592_5423# a_14111_5227# 0.34114f
C1323 a_14111_5878# a_15108_6109# 0.03093f
C1324 a_6126_3816# VDD 0.84141f
C1325 a_14111_5227# VDD 0.33926f
C1326 a_20831_2470# VDD 0.01806f
C1327 a_15304_4605# DELAY_VBIASN 0.07802f
C1328 a_13753_1842# a_14317_1842# 0.0114f
C1329 a_7477_1842# VDD 0.86707f
C1330 MUX_SEL3 a_2019_311# 0.06209f
C1331 MUX_SEL4 a_5705_519# 0.03556f
C1332 DELAY_VBIASP a_19833_1842# 0.11284f
C1333 a_19550_1044# a_21835_1044# 0.39036f
C1334 a_27237_1842# a_26803_1842# 0.6972f
C1335 a_27915_1044# a_27991_1008# 0.01194f
C1336 a_19550_1044# VDD 0.89766f
C1337 DELAY_VBIASP a_14643_1842# 0.06668f
C1338 a_15304_4605# a_14111_5227# 0.01761f
C1339 a_13592_5871# a_13880_6292# 0.43707f
C1340 a_22677_1842# DELAY_VBIASN 0.0907f
C1341 DELAY_VBIASP REF_CLK 2.13371f
C1342 a_13106_5357# VDD 0.09228f
C1343 a_14751_2470# VDD 0.01806f
C1344 VDD a_25391_2470# 0.01806f
C1345 a_12797_1842# a_13557_1842# 0.06198f
C1346 MUX_SEL2 a_1256_289# 0.33134f
C1347 DELAY_VBIASP a_18117_1842# 0.04177f
C1348 a_14888_1044# a_14317_1842# 0.10863f
C1349 a_16408_1044# a_16510_1044# 0.37183f
C1350 a_25913_1842# a_26477_1842# 0.0114f
C1351 a_26803_1842# DELAY_VBIASP 0.06661f
C1352 MUX_SEL2 MUX_OUT 0.08497f
C1353 MUX_SEL3 MUX_SEL4 0.75489f
C1354 a_12355_5867# DLL_RESETN 0.04879f
C1355 a_25630_1044# a_27124_1008# 0.28279f
C1356 a_26395_1044# a_26471_1008# 0.01194f
C1357 DELAY_VBIASP a_12993_1842# 0.11222f
C1358 a_16484_1008# VDD 0.28597f
C1359 a_13121_5831# a_12943_5867# 0.09118f
C1360 a_19963_1842# DELAY_VBIASN 0.08024f
C1361 a_13306_6305# a_14009_5878# 0.02432f
C1362 a_8671_2470# VDD 0.01806f
C1363 a_25717_1842# a_25604_1008# 0.05157f
C1364 a_5864_3367# DLL_RESETN 0.1727f
C1365 a_9712_3912# REF_CLK 0.06514f
C1366 a_4350_1044# a_5705_519# 0.02005f
C1367 a_16510_1044# a_15964_289# 0.05416f
C1368 a_10649_5878# REF_CLK 0.25484f
C1369 a_14888_1044# a_14964_1008# 0.01176f
C1370 a_24957_1842# a_25717_1842# 0.06198f
C1371 a_25153_1842# DELAY_VBIASP 0.11284f
C1372 a_15837_1842# DELAY_VBIASN 0.10875f
C1373 a_8155_1044# a_8231_1008# 0.01194f
C1374 a_7390_1044# a_8884_1008# 0.28279f
C1375 DELAY_VBIASP a_5523_1842# 0.06627f
C1376 a_21157_1842# VDD 0.85848f
C1377 a_18313_1842# DELAY_VBIASN 0.10734f
C1378 a_13121_5831# a_12849_5867# 0.55272f
C1379 a_5957_1842# a_5523_1842# 0.6972f
C1380 a_15964_289# a_16108_289# 0.42202f
C1381 a_27997_1842# DELAY_VBIASN 0.04657f
C1382 a_13470_1044# a_13444_1008# 0.277f
C1383 a_13123_1842# a_13231_1842# 0.01163f
C1384 a_24197_1842# a_23763_1842# 0.6972f
C1385 a_19963_1842# a_19550_1044# 0.01012f
C1386 a_23437_1842# DELAY_VBIASP 0.04176f
C1387 a_16033_1842# VDD 0.49413f
C1388 MUX_SEL1 a_2873_1395# 0.13092f
C1389 a_13123_1842# DELAY_VBIASN 0.07254f
C1390 a_6711_1008# a_6425_1044# 0.01885f
C1391 DELAY_VBIASP a_5864_3367# 0.03252f
C1392 a_2019_311# VDD 1.43004f
C1393 a_18443_1842# VDD 0.4973f
C1394 a_12505_1044# a_10430_1044# 0.03208f
C1395 a_4633_1842# a_5197_1842# 0.0114f
C1396 a_17357_1842# a_17351_1008# 0.02349f
C1397 DELAY_VBIASP a_9953_1842# 0.11222f
C1398 a_4111_2470# VDD 0.01866f
C1399 a_25283_1842# DELAY_VBIASN 0.08024f
C1400 a_26185_1044# a_26395_1044# 0.09424f
C1401 a_11748_6109# a_11491_6228# 0.34468f
C1402 a_11603_1842# a_11711_1842# 0.01163f
C1403 a_13132_5420# DLL_RESETN 0.01689f
C1404 a_22873_1842# a_23437_1842# 0.0114f
C1405 a_18877_1842# a_19448_1044# 0.10864f
C1406 a_6717_1842# DELAY_VBIASN 0.09992f
C1407 a_14317_1842# VDD 0.87229f
C1408 a_21353_1842# a_21483_1842# 0.70845f
C1409 a_11924_1008# a_11277_1842# 0.02312f
C1410 a_11748_6109# a_12158_5867# 0.10373f
C1411 a_4350_1044# a_4905_1044# 0.03209f
C1412 a_4324_1008# a_4157_1313# 0.02463f
C1413 a_10713_1842# a_11277_1842# 0.0114f
R0 VDD.n131 VDD.t184 17.3693
R1 VDD.n118 VDD.t319 17.3693
R2 VDD.n118 VDD.t315 17.3693
R3 VDD.n129 VDD.t327 17.3517
R4 VDD.n121 VDD.t271 17.3517
R5 VDD.n120 VDD.t44 17.3517
R6 VDD.n72 VDD.t240 17.2438
R7 VDD.n124 VDD.t207 17.2247
R8 VDD.n129 VDD.t113 17.0005
R9 VDD.n121 VDD.t313 17.0005
R10 VDD.n120 VDD.t68 17.0005
R11 VDD.t0 VDD.n99 4.19382
R12 VDD.n42 VDD.n43 0.189847
R13 VDD.n95 VDD.n94 0.149987
R14 VDD.t0 VDD.n94 2.39616
R15 VDD.n91 VDD.n53 0.149987
R16 VDD.n91 VDD.t0 2.39616
R17 VDD.n96 VDD.n88 0.149987
R18 VDD.t0 VDD.n88 2.39616
R19 VDD.n83 VDD.n50 0.149987
R20 VDD.n83 VDD.t0 2.39616
R21 VDD.n97 VDD.n80 0.149987
R22 VDD.t0 VDD.n80 2.39616
R23 VDD.n76 VDD.n47 0.149987
R24 VDD.t0 VDD.n76 2.39616
R25 VDD.t22 VDD.n37 2.05485
R26 VDD.n34 VDD.n65 0.448571
R27 VDD.n36 VDD.t37 15.1333
R28 VDD.n383 VDD.t40 15.0005
R29 VDD.n1 VDD.t35 15.0005
R30 VDD.n64 VDD.t21 15.0005
R31 VDD.n39 VDD.t27 15.0005
R32 VDD.n67 VDD.t328 17.9449
R33 VDD.n386 VDD.n135 9.51422
R34 VDD.n387 VDD.n386 9.17119
R35 VDD.n68 VDD.n67 0.341666
R36 VDD.n395 VDD.t326 9.02285
R37 VDD.n73 VDD.n74 0.0615821
R38 VDD.n115 VDD.n28 4.47071
R39 VDD.n114 VDD.t324 8.95516
R40 VDD.n143 VDD.t364 8.76154
R41 VDD.n12 VDD.t189 8.76154
R42 VDD.n12 VDD.t369 8.76154
R43 VDD.n12 VDD.t95 8.76154
R44 VDD.n11 VDD.t201 8.76154
R45 VDD.n144 VDD.t124 8.76154
R46 VDD.n44 VDD.t370 8.76154
R47 VDD.n145 VDD.t203 8.76154
R48 VDD.n72 VDD.t241 8.76154
R49 VDD.n108 VDD.t222 8.76054
R50 VDD.n108 VDD.t232 8.76054
R51 VDD.n143 VDD.t255 8.76054
R52 VDD.n12 VDD.t149 8.76054
R53 VDD.n12 VDD.t331 8.76054
R54 VDD.n12 VDD.t150 8.76054
R55 VDD.n11 VDD.t312 8.76054
R56 VDD.n144 VDD.t256 8.76054
R57 VDD.n44 VDD.t329 8.76054
R58 VDD.n145 VDD.t97 8.76054
R59 VDD.n94 VDD.n93 0.0442395
R60 VDD.n90 VDD.n91 0.0442395
R61 VDD.n88 VDD.n87 0.0442395
R62 VDD.n82 VDD.n83 0.0442395
R63 VDD.n80 VDD.n79 0.0442395
R64 VDD.n77 VDD.n76 0.0442395
R65 VDD VDD.t9 8.47732
R66 VDD.n46 VDD.n45 0.0953067
R67 VDD.t0 VDD.n46 4.19225
R68 VDD.t0 VDD.n41 3.34459
R69 VDD.n15 VDD.t0 0.282279
R70 VDD.t0 VDD.n9 0.793108
R71 VDD.t0 VDD.n18 1.13836
R72 VDD.n8 VDD.t0 0.793108
R73 VDD.n20 VDD.t0 1.13836
R74 VDD.t0 VDD.n6 0.793108
R75 VDD.t0 VDD.n21 0.315451
R76 VDD.n5 VDD.t0 0.793108
R77 VDD.n24 VDD.t0 1.13836
R78 VDD.t0 VDD.n3 0.793108
R79 VDD.t0 VDD.n26 1.13836
R80 VDD.t0 VDD.n10 0.793077
R81 VDD.t3 VDD.n56 4.20922
R82 VDD.t3 VDD.n60 4.20922
R83 VDD.t22 VDD.n57 1.61941
R84 VDD.t22 VDD.n34 0.894484
R85 VDD.t22 VDD.n73 8.47732
R86 VDD.n10 VDD.t409 7.62628
R87 VDD.n75 VDD.t408 7.62628
R88 VDD.n26 VDD.t407 7.62628
R89 VDD.n3 VDD.t406 7.62628
R90 VDD.n78 VDD.t405 7.62628
R91 VDD.n24 VDD.t404 7.62628
R92 VDD.n5 VDD.t403 7.62628
R93 VDD.n81 VDD.t402 7.62628
R94 VDD.n22 VDD.t401 7.62628
R95 VDD.n6 VDD.t400 7.62628
R96 VDD.n86 VDD.t399 7.62628
R97 VDD.n20 VDD.t398 7.62628
R98 VDD.n8 VDD.t397 7.62628
R99 VDD.n89 VDD.t396 7.62628
R100 VDD.n18 VDD.t395 7.62628
R101 VDD.n9 VDD.t394 7.62628
R102 VDD.n92 VDD.t393 7.62628
R103 VDD.n16 VDD.t392 7.62628
R104 VDD.n1 VDD.n30 3.11859
R105 VDD.n192 VDD.t127 6.09923
R106 VDD.n198 VDD.t70 6.09923
R107 VDD.n204 VDD.t71 6.09923
R108 VDD.n210 VDD.t236 6.09923
R109 VDD.n216 VDD.t185 6.09923
R110 VDD.n222 VDD.t45 6.09923
R111 VDD.n228 VDD.t118 6.09923
R112 VDD.n234 VDD.t115 6.09923
R113 VDD.n240 VDD.t116 6.09923
R114 VDD.n246 VDD.t102 6.09923
R115 VDD.n252 VDD.t172 6.09923
R116 VDD.n258 VDD.t140 6.09923
R117 VDD.n264 VDD.t65 6.09923
R118 VDD.n270 VDD.t253 6.09923
R119 VDD.n276 VDD.t252 6.09923
R120 VDD.n282 VDD.t180 6.09923
R121 VDD.n288 VDD.t334 6.09923
R122 VDD.n294 VDD.t67 6.09923
R123 VDD.n300 VDD.t61 6.09923
R124 VDD.n306 VDD.t133 6.09923
R125 VDD.n312 VDD.t120 6.09923
R126 VDD.n318 VDD.t63 6.09923
R127 VDD.n324 VDD.t360 6.09923
R128 VDD.n330 VDD.t100 6.09923
R129 VDD.n336 VDD.t170 6.09923
R130 VDD.n342 VDD.t156 6.09923
R131 VDD.n348 VDD.t130 6.09923
R132 VDD.n354 VDD.t239 6.09923
R133 VDD.n360 VDD.t93 6.09923
R134 VDD.n366 VDD.t60 6.09923
R135 VDD.n372 VDD.t121 6.09923
R136 VDD.n378 VDD.t99 6.09923
R137 VDD.n26 VDD.t157 5.99122
R138 VDD.n24 VDD.t117 5.99122
R139 VDD.n22 VDD.t66 5.99122
R140 VDD.n20 VDD.t146 5.99122
R141 VDD.n18 VDD.t144 5.99122
R142 VDD.n16 VDD.t148 5.99122
R143 VDD.n100 VDD.t350 5.98905
R144 VDD.n128 VDD.t145 5.9886
R145 VDD.n106 VDD.t224 5.97675
R146 VDD.n106 VDD.t234 5.97675
R147 VDD.n12 VDD.t229 5.97212
R148 VDD.n12 VDD.t96 5.97212
R149 VDD.n45 VDD.t125 5.97212
R150 VDD.n146 VDD.t355 5.97212
R151 VDD.n12 VDD.t152 5.97169
R152 VDD.n12 VDD.t340 5.97169
R153 VDD.n45 VDD.t273 5.97169
R154 VDD.n146 VDD.t98 5.97169
R155 VDD.n10 VDD.t356 5.97001
R156 VDD.n10 VDD.t192 5.97001
R157 VDD.n10 VDD.t244 5.97001
R158 VDD.n48 VDD.t166 5.97001
R159 VDD.n47 VDD.t165 5.97001
R160 VDD.n3 VDD.t91 5.97001
R161 VDD.n26 VDD.t169 5.97001
R162 VDD.n3 VDD.t391 5.97001
R163 VDD.n3 VDD.t191 5.97001
R164 VDD.n49 VDD.t109 5.97001
R165 VDD.n97 VDD.t108 5.97001
R166 VDD.n5 VDD.t126 5.97001
R167 VDD.n24 VDD.t112 5.97001
R168 VDD.n5 VDD.t51 5.97001
R169 VDD.n5 VDD.t2 5.97001
R170 VDD.n51 VDD.t176 5.97001
R171 VDD.n50 VDD.t175 5.97001
R172 VDD.n6 VDD.t103 5.97001
R173 VDD.n22 VDD.t179 5.97001
R174 VDD.n6 VDD.t204 5.97001
R175 VDD.n6 VDD.t211 5.97001
R176 VDD.n52 VDD.t263 5.97001
R177 VDD.n96 VDD.t262 5.97001
R178 VDD.n8 VDD.t247 5.97001
R179 VDD.n20 VDD.t266 5.97001
R180 VDD.n8 VDD.t214 5.97001
R181 VDD.n8 VDD.t250 5.97001
R182 VDD.n54 VDD.t55 5.97001
R183 VDD.n53 VDD.t54 5.97001
R184 VDD.n9 VDD.t245 5.97001
R185 VDD.n18 VDD.t58 5.97001
R186 VDD.n9 VDD.t213 5.97001
R187 VDD.n9 VDD.t217 5.97001
R188 VDD.n55 VDD.t160 5.97001
R189 VDD.n95 VDD.t159 5.97001
R190 VDD.n16 VDD.t163 5.97001
R191 VDD.n32 VDD.t182 5.96578
R192 VDD.n42 VDD.t368 5.96578
R193 VDD.n141 VDD.t202 5.96578
R194 VDD.n25 VDD.t46 5.96578
R195 VDD.n23 VDD.t135 5.96578
R196 VDD.n33 VDD.t183 5.96578
R197 VDD.n85 VDD.t259 5.96578
R198 VDD.n27 VDD.t200 5.96578
R199 VDD.n19 VDD.t47 5.96578
R200 VDD.n17 VDD.t212 5.96578
R201 VDD.n14 VDD.t343 5.96578
R202 VDD.n42 VDD.t330 5.96534
R203 VDD.n141 VDD.t311 5.96534
R204 VDD.n100 VDD.t173 5.96534
R205 VDD.n139 VDD.t269 5.96534
R206 VDD.n137 VDD.t138 5.96534
R207 VDD.n148 VDD.t342 5.96534
R208 VDD.n31 VDD.t69 5.96534
R209 VDD.n32 VDD.t390 5.96534
R210 VDD.n10 VDD.t136 5.96534
R211 VDD.n10 VDD.t208 5.96534
R212 VDD.n101 VDD.t235 5.96534
R213 VDD.n47 VDD.t50 5.96534
R214 VDD.n26 VDD.t219 5.96534
R215 VDD.n26 VDD.t73 5.96534
R216 VDD.n25 VDD.t388 5.96534
R217 VDD.n3 VDD.t119 5.96534
R218 VDD.n3 VDD.t268 5.96534
R219 VDD.n102 VDD.t114 5.96534
R220 VDD.n97 VDD.t275 5.96534
R221 VDD.n24 VDD.t220 5.96534
R222 VDD.n24 VDD.t199 5.96534
R223 VDD.n23 VDD.t309 5.96534
R224 VDD.n5 VDD.t221 5.96534
R225 VDD.n5 VDD.t7 5.96534
R226 VDD.n4 VDD.t141 5.96534
R227 VDD.n50 VDD.t382 5.96534
R228 VDD.n22 VDD.t385 5.96534
R229 VDD.n22 VDD.t254 5.96534
R230 VDD.n27 VDD.t4 5.96534
R231 VDD.n27 VDD.t336 5.96534
R232 VDD.n156 VDD.t128 5.96534
R233 VDD.n85 VDD.t181 5.96534
R234 VDD.n154 VDD.t242 5.96534
R235 VDD.n72 VDD.t43 5.96534
R236 VDD.n152 VDD.t94 5.96534
R237 VDD.n150 VDD.t376 5.96534
R238 VDD.n33 VDD.t387 5.96534
R239 VDD.n6 VDD.t62 5.96534
R240 VDD.n6 VDD.t197 5.96534
R241 VDD.n103 VDD.t134 5.96534
R242 VDD.n96 VDD.t270 5.96534
R243 VDD.n20 VDD.t357 5.96534
R244 VDD.n20 VDD.t64 5.96534
R245 VDD.n19 VDD.t267 5.96534
R246 VDD.n8 VDD.t206 5.96534
R247 VDD.n8 VDD.t72 5.96534
R248 VDD.n7 VDD.t101 5.96534
R249 VDD.n53 VDD.t383 5.96534
R250 VDD.n18 VDD.t386 5.96534
R251 VDD.n18 VDD.t226 5.96534
R252 VDD.n17 VDD.t5 5.96534
R253 VDD.n9 VDD.t153 5.96534
R254 VDD.n9 VDD.t129 5.96534
R255 VDD.n104 VDD.t257 5.96534
R256 VDD.n95 VDD.t131 5.96534
R257 VDD.n16 VDD.t215 5.96534
R258 VDD.n16 VDD.t59 5.96534
R259 VDD.n14 VDD.t218 5.96534
R260 VDD.n14 VDD.t122 5.96534
R261 VDD.n126 VDD.t322 5.96478
R262 VDD.n10 VDD.t243 5.65005
R263 VDD.n75 VDD.t164 5.65005
R264 VDD.n26 VDD.t167 5.65005
R265 VDD.n3 VDD.t92 5.65005
R266 VDD.n78 VDD.t107 5.65005
R267 VDD.n24 VDD.t110 5.65005
R268 VDD.n5 VDD.t1 5.65005
R269 VDD.n81 VDD.t52 5.65005
R270 VDD.n22 VDD.t177 5.65005
R271 VDD.n6 VDD.t104 5.65005
R272 VDD.n86 VDD.t205 5.65005
R273 VDD.n20 VDD.t264 5.65005
R274 VDD.n8 VDD.t248 5.65005
R275 VDD.n89 VDD.t53 5.65005
R276 VDD.n18 VDD.t56 5.65005
R277 VDD.n9 VDD.t216 5.65005
R278 VDD.n92 VDD.t158 5.65005
R279 VDD.n16 VDD.t161 5.65005
R280 VDD.t9 VDD.n133 5.62581
R281 VDD.t9 VDD.n396 5.62581
R282 VDD.t0 VDD.n149 5.62581
R283 VDD.t0 VDD.n147 5.62581
R284 VDD.t0 VDD.n140 5.62581
R285 VDD.n41 VDD.n144 0.160419
R286 VDD.t0 VDD.n13 1.07426
R287 VDD.n151 VDD.t0 5.62581
R288 VDD.n71 VDD.t0 1.79705
R289 VDD.n153 VDD.t0 5.62581
R290 VDD.n155 VDD.t0 5.62581
R291 VDD.t3 VDD.n191 5.62581
R292 VDD.t3 VDD.n197 5.62581
R293 VDD.t3 VDD.n203 5.62581
R294 VDD.t3 VDD.n209 5.62581
R295 VDD.t3 VDD.n215 5.62581
R296 VDD.t3 VDD.n221 5.62581
R297 VDD.t3 VDD.n227 5.62581
R298 VDD.t3 VDD.n233 5.62581
R299 VDD.t3 VDD.n239 5.62581
R300 VDD.t3 VDD.n245 5.62581
R301 VDD.t3 VDD.n251 5.62581
R302 VDD.t3 VDD.n257 5.62581
R303 VDD.t3 VDD.n263 5.62581
R304 VDD.t3 VDD.n269 5.62581
R305 VDD.t3 VDD.n275 5.62581
R306 VDD.t3 VDD.n281 5.62581
R307 VDD.t3 VDD.n287 5.62581
R308 VDD.t3 VDD.n293 5.62581
R309 VDD.t3 VDD.n299 5.62581
R310 VDD.t3 VDD.n305 5.62581
R311 VDD.t3 VDD.n311 5.62581
R312 VDD.t3 VDD.n317 5.62581
R313 VDD.t3 VDD.n323 5.62581
R314 VDD.t3 VDD.n329 5.62581
R315 VDD.t3 VDD.n335 5.62581
R316 VDD.t3 VDD.n341 5.62581
R317 VDD.t3 VDD.n347 5.62581
R318 VDD.t3 VDD.n353 5.62581
R319 VDD.t3 VDD.n359 5.62581
R320 VDD.t3 VDD.n365 5.62581
R321 VDD.t3 VDD.n371 5.62581
R322 VDD.t3 VDD.n377 5.62581
R323 VDD.t3 VDD.n379 5.62581
R324 VDD.t48 VDD.n123 5.61485
R325 VDD.t48 VDD.n127 5.61485
R326 VDD.n0 VDD.t33 5.7457
R327 VDD.n110 VDD.t23 5.60969
R328 VDD.n111 VDD.t28 5.60969
R329 VDD.n1 VDD.t36 5.71623
R330 VDD.n382 VDD.t42 5.60347
R331 VDD.n61 VDD.t39 5.60347
R332 VDD.n28 VDD.t26 5.60347
R333 VDD.n113 VDD.t31 5.60347
R334 VDD.n189 VDD.t288 5.59675
R335 VDD.n195 VDD.t282 5.59675
R336 VDD.n201 VDD.t277 5.59675
R337 VDD.n207 VDD.t291 5.59675
R338 VDD.n213 VDD.t279 5.59675
R339 VDD.n219 VDD.t289 5.59675
R340 VDD.n225 VDD.t292 5.59675
R341 VDD.n231 VDD.t293 5.59675
R342 VDD.n237 VDD.t286 5.59675
R343 VDD.n243 VDD.t294 5.59675
R344 VDD.n249 VDD.t281 5.59675
R345 VDD.n255 VDD.t297 5.59675
R346 VDD.n261 VDD.t287 5.59675
R347 VDD.n267 VDD.t278 5.59675
R348 VDD.n273 VDD.t280 5.59675
R349 VDD.n279 VDD.t299 5.59675
R350 VDD.n285 VDD.t298 5.59675
R351 VDD.n291 VDD.t300 5.59675
R352 VDD.n297 VDD.t276 5.59675
R353 VDD.n303 VDD.t301 5.59675
R354 VDD.n309 VDD.t302 5.59675
R355 VDD.n315 VDD.t296 5.59675
R356 VDD.n321 VDD.t284 5.59675
R357 VDD.n327 VDD.t283 5.59675
R358 VDD.n333 VDD.t285 5.59675
R359 VDD.n339 VDD.t305 5.59675
R360 VDD.n345 VDD.t304 5.59675
R361 VDD.n351 VDD.t303 5.59675
R362 VDD.n357 VDD.t295 5.59675
R363 VDD.n363 VDD.t306 5.59675
R364 VDD.n369 VDD.t307 5.59675
R365 VDD.n375 VDD.t308 5.59675
R366 VDD.n380 VDD.t38 5.59675
R367 VDD.n38 VDD.t290 5.59675
R368 VDD.n28 VDD.t24 5.59179
R369 VDD.n112 VDD.t29 5.59179
R370 VDD.n1 VDD.t34 5.59179
R371 VDD.n433 VDD.t12 4.9462
R372 VDD.n405 VDD.t8 4.9462
R373 VDD.n116 VDD.n115 4.90372
R374 VDD.t0 VDD.n142 4.19244
R375 VDD.t0 VDD.n43 3.32638
R376 VDD.t9 VDD.n397 4.19238
R377 VDD.t9 VDD.n389 4.19238
R378 VDD.n57 VDD.n28 0.405902
R379 VDD.n37 VDD.n74 0.379679
R380 VDD.t9 VDD.n425 4.19225
R381 VDD.t9 VDD.n394 4.19225
R382 VDD VDD.t48 1.47683
R383 VDD.t0 VDD.n98 3.3265
R384 VDD.n152 VDD.n71 0.341
R385 VDD.n84 VDD.t0 3.3265
R386 VDD.t48 VDD.n125 3.31208
R387 VDD.t48 VDD.n117 3.30706
R388 VDD.t48 VDD.n119 3.30706
R389 VDD.t48 VDD.n132 3.30688
R390 VDD VDD.n42 3.24291
R391 VDD.t48 VDD.n107 2.7751
R392 VDD.t0 VDD.n136 2.74446
R393 VDD.t0 VDD.n138 2.74446
R394 VDD.n15 VDD.n14 0.28669
R395 VDD.n156 VDD.n27 0.44578
R396 VDD.n27 VDD.n21 0.309939
R397 VDD.t3 VDD.n35 2.74414
R398 VDD.n2 VDD.n190 0.528091
R399 VDD.t9 VDD.n388 2.74386
R400 VDD.n435 VDD.t14 2.69937
R401 VDD.n403 VDD.t17 2.69937
R402 VDD.n401 VDD.t11 2.69937
R403 VDD.n427 VDD.t19 2.69937
R404 VDD.n431 VDD.t20 2.6992
R405 VDD.n429 VDD.t13 2.6992
R406 VDD.n399 VDD.t16 2.6992
R407 VDD.n407 VDD.t10 2.6992
R408 VDD.n412 VDD.t77 2.6992
R409 VDD.n411 VDD.t84 2.6992
R410 VDD.n417 VDD.t79 2.6992
R411 VDD.n416 VDD.t86 2.6992
R412 VDD.n422 VDD.t81 2.6992
R413 VDD.n421 VDD.t88 2.6992
R414 VDD.t9 VDD.n70 2.33382
R415 VDD.t3 VDD.n241 2.32446
R416 VDD.t3 VDD.n319 2.32446
R417 VDD.t3 VDD.n337 2.32446
R418 VDD.t9 VDD.n409 2.32439
R419 VDD.t9 VDD.n424 2.32439
R420 VDD.t3 VDD.n289 2.32439
R421 VDD.t3 VDD.n367 2.32439
R422 VDD.t3 VDD.n205 2.32432
R423 VDD.t3 VDD.n301 2.32425
R424 VDD.t3 VDD.n313 2.32425
R425 VDD.t3 VDD.n247 2.3242
R426 VDD.t3 VDD.n277 2.3242
R427 VDD.t3 VDD.n193 2.32417
R428 VDD.t3 VDD.n199 2.32417
R429 VDD.t3 VDD.n229 2.32417
R430 VDD.t3 VDD.n265 2.32417
R431 VDD.t3 VDD.n325 2.32417
R432 VDD.t3 VDD.n343 2.32417
R433 VDD.t9 VDD.n393 2.32417
R434 VDD.t9 VDD.n390 2.32417
R435 VDD.t22 VDD.n68 0.570319
R436 VDD.t9 VDD.n419 2.32417
R437 VDD.t3 VDD.n217 2.32417
R438 VDD.t3 VDD.n223 2.32417
R439 VDD.t3 VDD.n283 2.32417
R440 VDD.t3 VDD.n349 2.32417
R441 VDD.t3 VDD.n361 2.32417
R442 VDD.t3 VDD.n211 2.32414
R443 VDD.t3 VDD.n253 2.32407
R444 VDD.t3 VDD.n355 2.32407
R445 VDD.t9 VDD.n392 2.32406
R446 VDD.t3 VDD.n235 2.32406
R447 VDD.t3 VDD.n259 2.32406
R448 VDD.t3 VDD.n271 2.32406
R449 VDD.t3 VDD.n295 2.32406
R450 VDD.t3 VDD.n307 2.32406
R451 VDD.t3 VDD.n331 2.32406
R452 VDD.t3 VDD.n373 2.32406
R453 VDD.n14 VDD.t6 6.35402
R454 VDD.t9 VDD.n414 2.00628
R455 VDD.t9 VDD.n391 2.0061
R456 VDD.t9 VDD.n437 1.75938
R457 VDD.t3 VDD.n385 1.56886
R458 VDD.t3 VDD.n157 1.55381
R459 VDD.t3 VDD.n158 1.55381
R460 VDD.t3 VDD.n159 1.55381
R461 VDD.t3 VDD.n160 1.55381
R462 VDD.t3 VDD.n161 1.55381
R463 VDD.t3 VDD.n163 1.55381
R464 VDD.t3 VDD.n164 1.55381
R465 VDD.t3 VDD.n165 1.55381
R466 VDD.t3 VDD.n168 1.55381
R467 VDD.t3 VDD.n169 1.55381
R468 VDD.t3 VDD.n171 1.55381
R469 VDD.t3 VDD.n172 1.55381
R470 VDD.t3 VDD.n173 1.55381
R471 VDD.t3 VDD.n174 1.55381
R472 VDD.t3 VDD.n175 1.55381
R473 VDD.t3 VDD.n177 1.55381
R474 VDD.t3 VDD.n178 1.55381
R475 VDD.t3 VDD.n179 1.55381
R476 VDD.t3 VDD.n180 1.55381
R477 VDD.t3 VDD.n181 1.55381
R478 VDD.t3 VDD.n182 1.55381
R479 VDD.t3 VDD.n183 1.55381
R480 VDD.t3 VDD.n185 1.55381
R481 VDD.t3 VDD.n186 1.55381
R482 VDD.t3 VDD.n162 1.55341
R483 VDD.t3 VDD.n166 1.55341
R484 VDD.t3 VDD.n167 1.55341
R485 VDD.t3 VDD.n170 1.55341
R486 VDD.t3 VDD.n176 1.55341
R487 VDD.t3 VDD.n184 1.55341
R488 VDD.t3 VDD.n187 1.55341
R489 VDD.t48 VDD.n109 1.20461
R490 VDD.n68 VDD.n114 0.779651
R491 VDD.n412 VDD.n411 1.11007
R492 VDD.n417 VDD.n416 1.11007
R493 VDD.n422 VDD.n421 1.11007
R494 VDD.t9 VDD.n134 1.01949
R495 VDD.n131 VDD.n105 0.975304
R496 VDD.n105 VDD.n128 0.817678
R497 VDD.n386 VDD.n30 0.808112
R498 VDD.n116 VDD.n109 0.671512
R499 VDD.n109 VDD.n108 0.6645
R500 VDD.n135 VDD.n134 0.633311
R501 VDD.n387 VDD.n134 0.617798
R502 VDD.n436 VDD.n435 0.570444
R503 VDD.n401 VDD.n400 0.570444
R504 VDD.n429 VDD.n428 0.570274
R505 VDD.n408 VDD.n407 0.570274
R506 VDD.n413 VDD.n412 0.570274
R507 VDD.n418 VDD.n417 0.570274
R508 VDD.n423 VDD.n422 0.570274
R509 VDD.n431 VDD.n430 0.569912
R510 VDD.n399 VDD.n398 0.569912
R511 VDD.n411 VDD.n410 0.569912
R512 VDD.n416 VDD.n415 0.569912
R513 VDD.n421 VDD.n420 0.569912
R514 VDD.n403 VDD.n402 0.569733
R515 VDD.n427 VDD.n426 0.569733
R516 VDD.n29 VDD.n28 0.183807
R517 VDD.n112 VDD.n40 0.508375
R518 VDD.t48 VDD.n105 0.49685
R519 VDD.n189 VDD.n188 0.495398
R520 VDD.n195 VDD.n194 0.495398
R521 VDD.n201 VDD.n200 0.495398
R522 VDD.n207 VDD.n206 0.495398
R523 VDD.n213 VDD.n212 0.495398
R524 VDD.n219 VDD.n218 0.495398
R525 VDD.n225 VDD.n224 0.495398
R526 VDD.n231 VDD.n230 0.495398
R527 VDD.n237 VDD.n236 0.495398
R528 VDD.n243 VDD.n242 0.495398
R529 VDD.n249 VDD.n248 0.495398
R530 VDD.n255 VDD.n254 0.495398
R531 VDD.n261 VDD.n260 0.495398
R532 VDD.n267 VDD.n266 0.495398
R533 VDD.n273 VDD.n272 0.495398
R534 VDD.n279 VDD.n278 0.495398
R535 VDD.n285 VDD.n284 0.495398
R536 VDD.n291 VDD.n290 0.495398
R537 VDD.n297 VDD.n296 0.495398
R538 VDD.n303 VDD.n302 0.495398
R539 VDD.n309 VDD.n308 0.495398
R540 VDD.n315 VDD.n314 0.495398
R541 VDD.n321 VDD.n320 0.495398
R542 VDD.n327 VDD.n326 0.495398
R543 VDD.n333 VDD.n332 0.495398
R544 VDD.n339 VDD.n338 0.495398
R545 VDD.n345 VDD.n344 0.495398
R546 VDD.n351 VDD.n350 0.495398
R547 VDD.n357 VDD.n356 0.495398
R548 VDD.n363 VDD.n362 0.495398
R549 VDD.n369 VDD.n368 0.495398
R550 VDD.n375 VDD.n374 0.495398
R551 VDD.n380 VDD.n36 0.495398
R552 VDD.n38 VDD.n58 0.495398
R553 VDD.n404 VDD.n403 0.492175
R554 VDD.n434 VDD.n427 0.492175
R555 VDD.n432 VDD.n431 0.492005
R556 VDD.n406 VDD.n399 0.492005
R557 VDD.n432 VDD.n429 0.491643
R558 VDD.n407 VDD.n406 0.491643
R559 VDD.n435 VDD.n434 0.491464
R560 VDD.n404 VDD.n401 0.491464
R561 VDD.n190 VDD.n189 0.478641
R562 VDD.n196 VDD.n195 0.478641
R563 VDD.n202 VDD.n201 0.478641
R564 VDD.n208 VDD.n207 0.478641
R565 VDD.n214 VDD.n213 0.478641
R566 VDD.n220 VDD.n219 0.478641
R567 VDD.n226 VDD.n225 0.478641
R568 VDD.n232 VDD.n231 0.478641
R569 VDD.n238 VDD.n237 0.478641
R570 VDD.n244 VDD.n243 0.478641
R571 VDD.n250 VDD.n249 0.478641
R572 VDD.n256 VDD.n255 0.478641
R573 VDD.n262 VDD.n261 0.478641
R574 VDD.n268 VDD.n267 0.478641
R575 VDD.n274 VDD.n273 0.478641
R576 VDD.n280 VDD.n279 0.478641
R577 VDD.n286 VDD.n285 0.478641
R578 VDD.n292 VDD.n291 0.478641
R579 VDD.n298 VDD.n297 0.478641
R580 VDD.n304 VDD.n303 0.478641
R581 VDD.n310 VDD.n309 0.478641
R582 VDD.n316 VDD.n315 0.478641
R583 VDD.n322 VDD.n321 0.478641
R584 VDD.n328 VDD.n327 0.478641
R585 VDD.n334 VDD.n333 0.478641
R586 VDD.n340 VDD.n339 0.478641
R587 VDD.n346 VDD.n345 0.478641
R588 VDD.n352 VDD.n351 0.478641
R589 VDD.n358 VDD.n357 0.478641
R590 VDD.n364 VDD.n363 0.478641
R591 VDD.n370 VDD.n369 0.478641
R592 VDD.n376 VDD.n375 0.478641
R593 VDD.n59 VDD.n380 0.478641
R594 VDD.n40 VDD.n38 0.478641
R595 VDD.n194 VDD.n186 0.467341
R596 VDD.n200 VDD.n185 0.467341
R597 VDD.n212 VDD.n183 0.467341
R598 VDD.n218 VDD.n182 0.467341
R599 VDD.n224 VDD.n181 0.467341
R600 VDD.n230 VDD.n180 0.467341
R601 VDD.n236 VDD.n179 0.467341
R602 VDD.n242 VDD.n178 0.467341
R603 VDD.n248 VDD.n177 0.467341
R604 VDD.n260 VDD.n175 0.467341
R605 VDD.n266 VDD.n174 0.467341
R606 VDD.n272 VDD.n173 0.467341
R607 VDD.n278 VDD.n172 0.467341
R608 VDD.n284 VDD.n171 0.467341
R609 VDD.n296 VDD.n169 0.467341
R610 VDD.n302 VDD.n168 0.467341
R611 VDD.n320 VDD.n165 0.467341
R612 VDD.n326 VDD.n164 0.467341
R613 VDD.n332 VDD.n163 0.467341
R614 VDD.n344 VDD.n161 0.467341
R615 VDD.n350 VDD.n160 0.467341
R616 VDD.n356 VDD.n159 0.467341
R617 VDD.n362 VDD.n158 0.467341
R618 VDD.n368 VDD.n157 0.467341
R619 VDD.n188 VDD.n187 0.466909
R620 VDD.n206 VDD.n184 0.466909
R621 VDD.n254 VDD.n176 0.466909
R622 VDD.n290 VDD.n170 0.466909
R623 VDD.n308 VDD.n167 0.466909
R624 VDD.n314 VDD.n166 0.466909
R625 VDD.n338 VDD.n162 0.466909
R626 VDD.n194 VDD.n187 0.451022
R627 VDD.n212 VDD.n184 0.451022
R628 VDD.n260 VDD.n176 0.451022
R629 VDD.n296 VDD.n170 0.451022
R630 VDD.n314 VDD.n167 0.451022
R631 VDD.n320 VDD.n166 0.451022
R632 VDD.n344 VDD.n162 0.451022
R633 VDD.n200 VDD.n186 0.450618
R634 VDD.n206 VDD.n185 0.450618
R635 VDD.n218 VDD.n183 0.450618
R636 VDD.n224 VDD.n182 0.450618
R637 VDD.n230 VDD.n181 0.450618
R638 VDD.n236 VDD.n180 0.450618
R639 VDD.n242 VDD.n179 0.450618
R640 VDD.n248 VDD.n178 0.450618
R641 VDD.n254 VDD.n177 0.450618
R642 VDD.n266 VDD.n175 0.450618
R643 VDD.n272 VDD.n174 0.450618
R644 VDD.n278 VDD.n173 0.450618
R645 VDD.n284 VDD.n172 0.450618
R646 VDD.n290 VDD.n171 0.450618
R647 VDD.n302 VDD.n169 0.450618
R648 VDD.n308 VDD.n168 0.450618
R649 VDD.n326 VDD.n165 0.450618
R650 VDD.n332 VDD.n164 0.450618
R651 VDD.n338 VDD.n163 0.450618
R652 VDD.n350 VDD.n161 0.450618
R653 VDD.n356 VDD.n160 0.450618
R654 VDD.n362 VDD.n159 0.450618
R655 VDD.n368 VDD.n158 0.450618
R656 VDD.n374 VDD.n157 0.450618
R657 VDD.n61 VDD.n56 0.445771
R658 VDD.n437 VDD.n436 0.43335
R659 VDD.n73 VDD.n29 0.0930507
R660 VDD.n66 VDD.n113 0.429929
R661 VDD.n385 VDD.n384 0.429766
R662 VDD.n382 VDD.n381 0.427147
R663 VDD.n62 VDD.n61 0.427147
R664 VDD.n385 VDD.n381 0.426171
R665 VDD.n110 VDD.n28 0.413465
R666 VDD.n111 VDD.n58 0.413465
R667 VDD.n437 VDD.n69 0.403558
R668 VDD.t9 VDD.t48 0.383639
R669 VDD.n419 VDD.n418 0.37265
R670 VDD.n415 VDD.n392 0.372571
R671 VDD.n241 VDD.n240 0.35553
R672 VDD.n319 VDD.n318 0.35553
R673 VDD.n337 VDD.n336 0.35553
R674 VDD.n289 VDD.n288 0.355452
R675 VDD.n367 VDD.n366 0.355452
R676 VDD.n205 VDD.n204 0.355386
R677 VDD.n301 VDD.n300 0.355312
R678 VDD.n313 VDD.n312 0.355312
R679 VDD.n199 VDD.n198 0.355155
R680 VDD.n325 VDD.n324 0.355155
R681 VDD.n343 VDD.n342 0.355155
R682 VDD.n193 VDD.n192 0.355155
R683 VDD.n229 VDD.n228 0.355155
R684 VDD.n265 VDD.n264 0.355155
R685 VDD.n217 VDD.n216 0.35515
R686 VDD.n283 VDD.n282 0.35515
R687 VDD.n361 VDD.n360 0.35515
R688 VDD.n259 VDD.n258 0.355071
R689 VDD.n373 VDD.n372 0.355071
R690 VDD.n211 VDD.n210 0.354936
R691 VDD.n247 VDD.n246 0.354903
R692 VDD.n277 VDD.n276 0.354903
R693 VDD.n253 VDD.n252 0.354838
R694 VDD.n355 VDD.n354 0.354838
R695 VDD.n223 VDD.n222 0.354837
R696 VDD.n235 VDD.n234 0.354771
R697 VDD.n271 VDD.n270 0.354771
R698 VDD.n295 VDD.n294 0.354771
R699 VDD.n307 VDD.n306 0.354771
R700 VDD.n331 VDD.n330 0.354771
R701 VDD.n349 VDD.n348 0.354697
R702 VDD.n410 VDD.n390 0.354692
R703 VDD.n413 VDD.n409 0.354405
R704 VDD.n424 VDD.n423 0.347952
R705 VDD.n420 VDD.n393 0.347655
R706 VDD.n414 VDD.n413 0.347437
R707 VDD.n410 VDD.n391 0.347254
R708 VDD.n132 VDD.n131 0.335799
R709 VDD.n119 VDD.n118 0.335496
R710 VDD.n430 VDD.n393 0.334692
R711 VDD.n428 VDD.n424 0.334405
R712 VDD.n122 VDD.n119 0.332368
R713 VDD.n132 VDD.n130 0.332058
R714 VDD.n426 VDD.n70 0.33018
R715 VDD.n415 VDD.n391 0.328947
R716 VDD.n418 VDD.n414 0.328754
R717 VDD.n409 VDD.n408 0.327952
R718 VDD.n398 VDD.n390 0.327655
R719 VDD.t32 VDD.n0 15.0851
R720 VDD.n126 VDD.n125 0.327354
R721 VDD.n64 VDD.n110 0.327154
R722 VDD.n39 VDD.n111 0.327154
R723 VDD.n402 VDD.n388 0.319637
R724 VDD.n383 VDD.n382 0.313013
R725 VDD.n352 VDD.n349 0.31015
R726 VDD.n238 VDD.n235 0.310071
R727 VDD.n274 VDD.n271 0.310071
R728 VDD.n298 VDD.n295 0.310071
R729 VDD.n310 VDD.n307 0.310071
R730 VDD.n334 VDD.n331 0.310071
R731 VDD.n226 VDD.n223 0.31001
R732 VDD.n256 VDD.n253 0.309994
R733 VDD.n358 VDD.n355 0.309994
R734 VDD.n250 VDD.n247 0.309933
R735 VDD.n280 VDD.n277 0.309933
R736 VDD.n214 VDD.n211 0.309928
R737 VDD.n420 VDD.n392 0.309771
R738 VDD.n262 VDD.n259 0.309771
R739 VDD.n376 VDD.n373 0.309771
R740 VDD.n423 VDD.n419 0.309697
R741 VDD.n220 VDD.n217 0.309697
R742 VDD.n286 VDD.n283 0.309697
R743 VDD.n364 VDD.n361 0.309697
R744 VDD.n196 VDD.n193 0.309692
R745 VDD.n202 VDD.n199 0.309692
R746 VDD.n232 VDD.n229 0.309692
R747 VDD.n268 VDD.n265 0.309692
R748 VDD.n328 VDD.n325 0.309692
R749 VDD.n346 VDD.n343 0.309692
R750 VDD.n304 VDD.n301 0.309557
R751 VDD.n316 VDD.n313 0.309557
R752 VDD.n208 VDD.n205 0.309483
R753 VDD.n292 VDD.n289 0.309405
R754 VDD.n370 VDD.n367 0.309405
R755 VDD.n244 VDD.n241 0.309333
R756 VDD.n322 VDD.n319 0.309333
R757 VDD.n340 VDD.n337 0.309333
R758 VDD.n108 VDD.n107 0.306614
R759 VDD.n130 VDD 0.423614
R760 VDD.n117 VDD.n116 0.298721
R761 VDD.n374 VDD.n35 0.29124
R762 VDD.n2 VDD.t3 0.549248
R763 VDD.n137 VDD.n136 0.284268
R764 VDD.n138 VDD.n137 0.282549
R765 VDD.n125 VDD.n124 0.282297
R766 VDD.n98 VDD.n139 0.279247
R767 VDD.n84 VDD.n154 0.279247
R768 VDD.n188 VDD.n1 0.435454
R769 VDD.n2 VDD.n1 0.0990072
R770 VDD.n148 VDD.n136 0.268799
R771 VDD.n100 VDD.n98 0.267977
R772 VDD.n118 VDD.n117 0.260496
R773 VDD.n388 VDD.n387 0.259637
R774 VDD.n433 VDD.n432 0.253639
R775 VDD.n405 VDD.n404 0.253639
R776 VDD.n113 VDD.n58 0.25333
R777 VDD.n434 VDD.n433 0.253298
R778 VDD.n406 VDD.n405 0.253298
R779 VDD VDD.n70 0.250961
R780 VDD.n36 VDD.n35 0.243044
R781 VDD.n139 VDD.n138 0.241768
R782 VDD.n115 VDD.n74 4.71183
R783 VDD.n67 VDD.n66 0.706063
R784 VDD VDD.n69 0.521582
R785 VDD.n72 VDD.n71 0.484477
R786 VDD.n63 VDD.t30 15.0439
R787 VDD.n63 VDD.n58 0.130762
R788 VDD.n66 VDD.n40 0.291774
R789 VDD.n85 VDD.n84 0.222977
R790 VDD.n32 VDD.n31 0.251712
R791 VDD.n26 VDD.n25 0.251712
R792 VDD.n24 VDD.n23 0.251712
R793 VDD.n150 VDD.n33 0.251712
R794 VDD.n20 VDD.n19 0.251712
R795 VDD.n18 VDD.n17 0.251712
R796 VDD.n104 VDD.n9 0.272485
R797 VDD.n8 VDD.n7 0.272485
R798 VDD.n103 VDD.n6 0.272485
R799 VDD.n5 VDD.n4 0.272485
R800 VDD.n102 VDD.n3 0.272485
R801 VDD.n101 VDD.n10 0.272485
R802 VDD.n29 VDD.n65 0.109866
R803 VDD.n58 VDD.n57 0.0836418
R804 VDD.n40 VDD.n37 0.100238
R805 VDD.n128 VDD.n127 0.202075
R806 VDD.n398 VDD.n389 0.192052
R807 VDD.n408 VDD.n397 0.191793
R808 VDD.n434 VDD.n69 0.189333
R809 VDD.n428 VDD.n425 0.184424
R810 VDD.n430 VDD.n394 0.184424
R811 VDD.n142 VDD.n141 0.181058
R812 VDD.n400 VDD.n396 0.179888
R813 VDD.n127 VDD.n126 0.175486
R814 VDD.n124 VDD.n123 0.171736
R815 VDD.n395 VDD.n133 0.169888
R816 VDD.n379 VDD.n378 0.16955
R817 VDD.n146 VDD.n99 0.210474
R818 VDD.n191 VDD.n190 0.162388
R819 VDD.n197 VDD.n196 0.162388
R820 VDD.n209 VDD.n208 0.162388
R821 VDD.n215 VDD.n214 0.162388
R822 VDD.n221 VDD.n220 0.162388
R823 VDD.n233 VDD.n232 0.162388
R824 VDD.n239 VDD.n238 0.162388
R825 VDD.n245 VDD.n244 0.162388
R826 VDD.n251 VDD.n250 0.162388
R827 VDD.n263 VDD.n262 0.162388
R828 VDD.n287 VDD.n286 0.162388
R829 VDD.n311 VDD.n310 0.162388
R830 VDD.n347 VDD.n346 0.162388
R831 VDD.n359 VDD.n358 0.162388
R832 VDD.n365 VDD.n364 0.162388
R833 VDD.n203 VDD.n202 0.16205
R834 VDD.n227 VDD.n226 0.16205
R835 VDD.n257 VDD.n256 0.16205
R836 VDD.n269 VDD.n268 0.16205
R837 VDD.n275 VDD.n274 0.16205
R838 VDD.n281 VDD.n280 0.16205
R839 VDD.n293 VDD.n292 0.16205
R840 VDD.n299 VDD.n298 0.16205
R841 VDD.n305 VDD.n304 0.16205
R842 VDD.n317 VDD.n316 0.16205
R843 VDD.n323 VDD.n322 0.16205
R844 VDD.n329 VDD.n328 0.16205
R845 VDD.n335 VDD.n334 0.16205
R846 VDD.n341 VDD.n340 0.16205
R847 VDD.n353 VDD.n352 0.16205
R848 VDD.n371 VDD.n370 0.16205
R849 VDD.n377 VDD.n376 0.16205
R850 VDD.n436 VDD.n425 0.161924
R851 VDD.n426 VDD.n394 0.161924
R852 VDD.n30 VDD 0.485468
R853 VDD.n41 VDD.n11 0.0957379
R854 VDD.n143 VDD.n142 0.159043
R855 VDD.n149 VDD.n148 0.157388
R856 VDD.n156 VDD.n155 0.157388
R857 VDD.n152 VDD.n151 0.157388
R858 VDD.n400 VDD.n397 0.154552
R859 VDD.n402 VDD.n389 0.154293
R860 VDD.n130 VDD.n129 0.152808
R861 VDD.n122 VDD.n121 0.152808
R862 VDD.n122 VDD.n120 0.152808
R863 VDD.n145 VDD.n140 0.15205
R864 VDD.n153 VDD.n72 0.15205
R865 VDD.n123 VDD.n122 0.147075
R866 VDD.n46 VDD.n144 0.236924
R867 VDD.n147 VDD.n145 0.134888
R868 VDD.n45 VDD.n44 0.134618
R869 VDD.n384 VDD.n383 0.133259
R870 VDD.n65 VDD.n64 0.133259
R871 VDD.n100 VDD.n99 0.16225
R872 VDD.n77 VDD.n75 0.128884
R873 VDD.n79 VDD.n78 0.128884
R874 VDD.n82 VDD.n81 0.128884
R875 VDD.n87 VDD.n86 0.128884
R876 VDD.n90 VDD.n89 0.128884
R877 VDD.n93 VDD.n92 0.128884
R878 VDD.n107 VDD.n106 0.127628
R879 VDD.n13 VDD.n143 0.947265
R880 VDD.n60 VDD.n59 0.185493
R881 VDD.n155 VDD.n85 0.1583
R882 VDD.n93 VDD.n104 0.141235
R883 VDD.n7 VDD.n90 0.141235
R884 VDD.n87 VDD.n103 0.141235
R885 VDD.n4 VDD.n82 0.141235
R886 VDD.n79 VDD.n102 0.141235
R887 VDD.n77 VDD.n101 0.141235
R888 VDD.n62 VDD.n60 0.0613757
R889 VDD.n147 VDD.n146 0.12205
R890 VDD.n135 VDD.n133 0.11955
R891 VDD.n204 VDD.n203 0.117388
R892 VDD.n228 VDD.n227 0.117388
R893 VDD.n258 VDD.n257 0.117388
R894 VDD.n270 VDD.n269 0.117388
R895 VDD.n276 VDD.n275 0.117388
R896 VDD.n282 VDD.n281 0.117388
R897 VDD.n294 VDD.n293 0.117388
R898 VDD.n300 VDD.n299 0.117388
R899 VDD.n306 VDD.n305 0.117388
R900 VDD.n318 VDD.n317 0.117388
R901 VDD.n324 VDD.n323 0.117388
R902 VDD.n330 VDD.n329 0.117388
R903 VDD.n336 VDD.n335 0.117388
R904 VDD.n342 VDD.n341 0.117388
R905 VDD.n354 VDD.n353 0.117388
R906 VDD.n372 VDD.n371 0.117388
R907 VDD.n378 VDD.n377 0.117388
R908 VDD.n396 VDD.n395 0.11705
R909 VDD.n192 VDD.n191 0.11705
R910 VDD.n198 VDD.n197 0.11705
R911 VDD.n210 VDD.n209 0.11705
R912 VDD.n216 VDD.n215 0.11705
R913 VDD.n222 VDD.n221 0.11705
R914 VDD.n234 VDD.n233 0.11705
R915 VDD.n240 VDD.n239 0.11705
R916 VDD.n246 VDD.n245 0.11705
R917 VDD.n252 VDD.n251 0.11705
R918 VDD.n264 VDD.n263 0.11705
R919 VDD.n288 VDD.n287 0.11705
R920 VDD.n312 VDD.n311 0.11705
R921 VDD.n348 VDD.n347 0.11705
R922 VDD.n360 VDD.n359 0.11705
R923 VDD.n366 VDD.n365 0.11705
R924 VDD.n59 VDD.n379 0.114888
R925 VDD.n31 VDD.n149 0.1133
R926 VDD.n151 VDD.n150 0.1133
R927 VDD.n44 VDD.n140 0.104888
R928 VDD.n154 VDD.n153 0.101138
R929 VDD.n63 VDD.n112 0.340529
R930 VDD.n56 VDD.n36 0.257619
R931 VDD.n40 VDD.n39 0.251665
R932 VDD.n141 VDD.n43 0.24736
R933 VDD.n114 VDD.n58 0.205524
R934 VDD.n381 VDD.n62 0.146235
R935 VDD.n384 VDD.n56 0.146235
R936 VDD.n95 VDD.n55 0.224985
R937 VDD.n54 VDD.n53 0.224985
R938 VDD.n96 VDD.n52 0.224985
R939 VDD.n51 VDD.n50 0.224985
R940 VDD.n97 VDD.n49 0.224985
R941 VDD.n48 VDD.n47 0.224985
R942 VDD.n12 VDD.n11 0.211235
R943 VDD.n28 VDD.t25 15.0336
R944 VDD.n17 VDD.n9 1.20647
R945 VDD.n8 VDD.n19 1.20647
R946 VDD.n33 VDD.n6 1.20647
R947 VDD.n5 VDD.n23 1.20647
R948 VDD.n25 VDD.n3 1.20647
R949 VDD.n10 VDD.n32 1.20646
R950 VDD.n34 VDD.n28 1.17026
R951 VDD.n1 VDD.n0 1.10286
R952 VDD.n13 VDD.n12 0.134613
R953 VDD.n16 VDD.n15 0.432623
R954 VDD.n22 VDD.n21 0.409065
R955 VDD.n48 VDD.n26 1.01698
R956 VDD.n49 VDD.n24 1.01698
R957 VDD.n51 VDD.n22 1.01698
R958 VDD.n52 VDD.n20 1.01698
R959 VDD.n54 VDD.n18 1.01698
R960 VDD.n55 VDD.n16 1.01698
R961 VSS.t433 VSS.n527 119321
R962 VSS.n631 VSS.n630 22369.4
R963 VSS.n95 VSS.n304 7907.02
R964 VSS.n523 VSS.n201 4670.31
R965 VSS.n853 VSS.n852 3068.57
R966 VSS.t176 VSS.n64 310.202
R967 VSS.t122 VSS.n69 310.202
R968 VSS.t338 VSS.n623 849.322
R969 VSS.n685 VSS.n684 572.005
R970 VSS.t325 VSS.t328 571.348
R971 VSS.n700 VSS.t429 566.691
R972 VSS.n699 VSS.t254 560.899
R973 VSS.n689 VSS.t350 550.193
R974 VSS.n715 VSS.t405 539.653
R975 VSS.t368 VSS.n697 532.819
R976 VSS.n718 VSS.t473 522.508
R977 VSS.n710 VSS.t384 521.236
R978 VSS.t304 VSS.n696 514.091
R979 VSS.n706 VSS.t309 504.839
R980 VSS.n692 VSS.t89 504.839
R981 VSS.n716 VSS.t474 491.87
R982 VSS.n701 VSS.t236 474.904
R983 VSS.t597 VSS.n634 470.019
R984 VSS.n227 VSS.n226 469.783
R985 VSS.n240 VSS.n239 469.783
R986 VSS.n262 VSS.n261 469.783
R987 VSS.n281 VSS.n280 469.783
R988 VSS.n295 VSS.n294 469.783
R989 VSS.n309 VSS.n308 469.783
R990 VSS.n702 VSS.t357 456.175
R991 VSS.n214 VSS.n211 454.007
R992 VSS.n907 VSS.n906 454.007
R993 VSS.n245 VSS.n242 454.007
R994 VSS.n892 VSS.n891 454.007
R995 VSS.n883 VSS.n882 454.007
R996 VSS.n874 VSS.n873 454.007
R997 VSS.n217 VSS.n216 453.986
R998 VSS.n904 VSS.n903 453.986
R999 VSS.n248 VSS.n247 453.986
R1000 VSS.n889 VSS.n888 453.986
R1001 VSS.n880 VSS.n879 453.986
R1002 VSS.n871 VSS.n870 453.986
R1003 VSS.n224 VSS.n217 453.986
R1004 VSS.n903 VSS.n231 453.986
R1005 VSS.n259 VSS.n248 453.986
R1006 VSS.n888 VSS.n271 453.986
R1007 VSS.n879 VSS.n285 453.986
R1008 VSS.n870 VSS.n299 453.986
R1009 VSS.t390 VSS.n256 448.228
R1010 VSS.t198 VSS.n193 442.469
R1011 VSS.t298 VSS.n195 437.62
R1012 VSS.n265 VSS.t388 431.863
R1013 VSS.t431 VSS.n62 427.695
R1014 VSS.n696 VSS.t81 427.219
R1015 VSS.t517 VSS.n266 419.459
R1016 VSS.t77 VSS.n306 413.68
R1017 VSS.t66 VSS.n292 413.68
R1018 VSS.t55 VSS.n278 413.68
R1019 VSS.t44 VSS.n258 413.68
R1020 VSS.t33 VSS.n237 413.68
R1021 VSS.t22 VSS.n223 413.68
R1022 VSS.n704 VSS.n703 412.791
R1023 VSS.n690 VSS.n70 412.791
R1024 VSS.n825 VSS.n824 412.522
R1025 VSS.n208 VSS.t299 403.072
R1026 VSS.t281 VSS.n716 401.591
R1027 VSS.n265 VSS.t389 397.313
R1028 VSS.n206 VSS.t145 391.555
R1029 VSS.t338 VSS.n826 388.781
R1030 VSS.t18 VSS.n224 385.798
R1031 VSS.t29 VSS.n231 385.798
R1032 VSS.t40 VSS.n259 385.798
R1033 VSS.t51 VSS.n271 385.798
R1034 VSS.t62 VSS.n285 385.798
R1035 VSS.t73 VSS.n299 385.798
R1036 VSS.n203 VSS.t514 384.887
R1037 VSS.n204 VSS.t347 380.038
R1038 VSS.t212 VSS.n63 375.276
R1039 VSS.t500 VSS.n704 372.094
R1040 VSS.t497 VSS.n690 372.094
R1041 VSS.t176 VSS.n709 363.339
R1042 VSS.t122 VSS.n695 363.339
R1043 VSS.t426 VSS.t337 359.769
R1044 VSS.t283 VSS.n199 357.007
R1045 VSS.n686 VSS.t486 347.49
R1046 VSS.t284 VSS.n197 333.974
R1047 VSS.n203 VSS.t296 333.065
R1048 VSS.t23 VSS.n223 333.063
R1049 VSS.t34 VSS.n237 333.063
R1050 VSS.t45 VSS.n258 333.063
R1051 VSS.t56 VSS.n278 333.063
R1052 VSS.t67 VSS.n292 333.063
R1053 VSS.n306 VSS.t78 333.063
R1054 VSS.t352 VSS.n639 329.238
R1055 VSS.n813 VSS.t325 327.81
R1056 VSS.t504 VSS.n191 322.457
R1057 VSS.n268 VSS.t361 322.457
R1058 VSS.t433 VSS.n851 314.327
R1059 VSS.n719 VSS.t472 313.659
R1060 VSS.n216 VSS.t16 305.183
R1061 VSS.n904 VSS.t27 305.183
R1062 VSS.n247 VSS.t38 305.183
R1063 VSS.n889 VSS.t49 305.183
R1064 VSS.n880 VSS.t60 305.183
R1065 VSS.n871 VSS.t71 305.183
R1066 VSS.t430 VSS.t276 304.42
R1067 VSS.t308 VSS.n707 304.42
R1068 VSS.t424 VSS.t492 304.42
R1069 VSS.t88 VSS.n693 304.42
R1070 VSS.t404 VSS.n718 299.735
R1071 VSS.n207 VSS.t197 299.425
R1072 VSS.t13 VSS.n214 293.666
R1073 VSS.n906 VSS.t24 293.666
R1074 VSS.t35 VSS.n245 293.666
R1075 VSS.n891 VSS.t46 293.666
R1076 VSS.n882 VSS.t57 293.666
R1077 VSS.n873 VSS.t68 293.666
R1078 VSS.n310 VSS.t489 292.757
R1079 VSS.t312 VSS.n291 292.757
R1080 VSS.t86 VSS.n277 292.757
R1081 VSS.t273 VSS.n254 292.757
R1082 VSS.t294 VSS.n257 292.757
R1083 VSS.t218 VSS.n236 292.757
R1084 VSS.t84 VSS.n222 292.757
R1085 VSS.t271 VSS.n189 292.757
R1086 VSS.t391 VSS.n706 291.37
R1087 VSS.t377 VSS.n692 291.37
R1088 VSS.n207 VSS.t515 287.909
R1089 VSS.n210 VSS.t498 275.505
R1090 VSS.t590 VSS.n193 269.724
R1091 VSS.t505 VSS.n191 264.875
R1092 VSS.n268 VSS.t363 264.875
R1093 VSS.t490 VSS.n304 258.238
R1094 VSS.n264 VSS.t295 258.236
R1095 VSS.n874 VSS.t313 258.233
R1096 VSS.n883 VSS.t87 258.233
R1097 VSS.n892 VSS.t274 258.233
R1098 VSS.n907 VSS.t85 258.233
R1099 VSS.n211 VSS.t272 258.233
R1100 VSS.n242 VSS.t219 258.233
R1101 VSS.t147 VSS.n196 258.231
R1102 VSS.t589 VSS.n197 253.359
R1103 VSS.n98 VSS.t275 252.375
R1104 VSS.t406 VSS.n104 252.375
R1105 VSS.t257 VSS.n114 252.375
R1106 VSS.t97 VSS.n116 252.375
R1107 VSS.t501 VSS.n129 252.375
R1108 VSS.t475 VSS.n134 252.375
R1109 VSS.n125 VSS.t341 252.375
R1110 VSS.t231 VSS.n139 252.375
R1111 VSS.n141 VSS.t277 252.375
R1112 VSS.n112 VSS.t232 252.375
R1113 VSS.n110 VSS.t278 252.375
R1114 VSS.t593 VSS.n151 252.375
R1115 VSS.t226 VSS.n155 252.375
R1116 VSS.t376 VSS.n160 252.375
R1117 VSS.t125 VSS.n101 252.375
R1118 VSS.n180 VSS.t106 252.374
R1119 VSS.n175 VSS.t148 252.374
R1120 VSS.n133 VSS.t594 252.117
R1121 VSS.t386 VSS.n126 252.117
R1122 VSS.n123 VSS.t381 252.117
R1123 VSS.t385 VSS.n140 252.117
R1124 VSS.t155 VSS.n142 252.117
R1125 VSS.t0 VSS.n118 252.117
R1126 VSS.t124 VSS.n147 252.117
R1127 VSS.t387 VSS.n148 252.117
R1128 VSS.n108 VSS.t270 252.117
R1129 VSS.n152 VSS.t132 252.117
R1130 VSS.t586 VSS.n157 252.117
R1131 VSS.t175 VSS.n102 252.117
R1132 VSS.t418 VSS.n100 252.117
R1133 VSS.n174 VSS.t119 252.115
R1134 VSS.n169 VSS.t133 252.115
R1135 VSS.t529 VSS.n352 250.837
R1136 VSS.t563 VSS.n353 250.837
R1137 VSS.t526 VSS.n357 250.837
R1138 VSS.t565 VSS.n358 250.837
R1139 VSS.t564 VSS.n362 250.837
R1140 VSS.t522 VSS.n363 250.837
R1141 VSS.t519 VSS.n367 250.837
R1142 VSS.t566 VSS.n368 250.837
R1143 VSS.t569 VSS.n372 250.837
R1144 VSS.t568 VSS.n373 250.837
R1145 VSS.t571 VSS.n377 250.837
R1146 VSS.t567 VSS.n378 250.837
R1147 VSS.t570 VSS.n382 250.837
R1148 VSS.t572 VSS.n383 250.837
R1149 VSS.t525 VSS.n387 250.837
R1150 VSS.t574 VSS.n388 250.837
R1151 VSS.t523 VSS.n392 250.837
R1152 VSS.t578 VSS.n393 250.837
R1153 VSS.t575 VSS.n397 250.837
R1154 VSS.t520 VSS.n398 250.837
R1155 VSS.t573 VSS.n402 250.837
R1156 VSS.t521 VSS.n403 250.837
R1157 VSS.t577 VSS.n407 250.837
R1158 VSS.t576 VSS.n408 250.837
R1159 VSS.t579 VSS.n412 250.837
R1160 VSS.t524 VSS.n413 250.837
R1161 VSS.t518 VSS.n417 250.837
R1162 VSS.t583 VSS.n418 250.837
R1163 VSS.t582 VSS.n422 250.837
R1164 VSS.t581 VSS.n423 250.837
R1165 VSS.t580 VSS.n427 250.837
R1166 VSS.t584 VSS.n428 250.837
R1167 VSS.t431 VSS.n64 148.06
R1168 VSS.t81 VSS.n69 148.06
R1169 VSS.n686 VSS.t352 243.244
R1170 VSS.n202 VSS.t588 240.956
R1171 VSS.t20 VSS.n225 240.956
R1172 VSS.t31 VSS.n238 240.956
R1173 VSS.t42 VSS.n260 240.956
R1174 VSS.t53 VSS.n279 240.956
R1175 VSS.t64 VSS.n293 240.956
R1176 VSS.t75 VSS.n307 240.956
R1177 VSS.n511 VSS.t128 234.114
R1178 VSS.n506 VSS.t355 234.114
R1179 VSS.n501 VSS.t139 234.114
R1180 VSS.n496 VSS.t180 234.114
R1181 VSS.n491 VSS.t291 234.114
R1182 VSS.n486 VSS.t227 234.114
R1183 VSS.n481 VSS.t372 234.114
R1184 VSS.n476 VSS.t267 234.114
R1185 VSS.n471 VSS.t599 234.114
R1186 VSS.n466 VSS.t214 234.114
R1187 VSS.n461 VSS.t111 234.114
R1188 VSS.n456 VSS.t156 234.114
R1189 VSS.n451 VSS.t345 234.114
R1190 VSS.n446 VSS.t383 234.114
R1191 VSS.n441 VSS.t100 234.114
R1192 VSS.n436 VSS.t153 234.114
R1193 VSS.t346 VSS.n199 230.327
R1194 VSS.n226 VSS.t20 229.44
R1195 VSS.n239 VSS.t31 229.44
R1196 VSS.n261 VSS.t42 229.44
R1197 VSS.n280 VSS.t53 229.44
R1198 VSS.n294 VSS.t64 229.44
R1199 VSS.n308 VSS.t75 229.44
R1200 VSS.t588 VSS.n201 228.827
R1201 VSS.t265 VSS.n130 225.361
R1202 VSS.t126 VSS.n127 225.361
R1203 VSS.t354 VSS.n136 225.361
R1204 VSS.t137 VSS.n122 225.361
R1205 VSS.t292 VSS.n143 225.361
R1206 VSS.t229 VSS.n144 225.361
R1207 VSS.t374 VSS.n146 225.361
R1208 VSS.t598 VSS.n149 225.361
R1209 VSS.t216 VSS.n107 225.361
R1210 VSS.t113 VSS.n106 225.361
R1211 VSS.t158 VSS.n103 225.361
R1212 VSS.t343 VSS.n158 225.361
R1213 VSS.t98 VSS.n162 225.361
R1214 VSS.n177 VSS.t178 225.359
R1215 VSS.n172 VSS.t269 225.359
R1216 VSS.n168 VSS.t382 225.359
R1217 VSS.t486 VSS.n685 224.516
R1218 VSS.t246 VSS.n39 216.093
R1219 VSS.n851 VSS.t246 215.731
R1220 VSS.t272 VSS.n189 212.143
R1221 VSS.t85 VSS.n222 212.143
R1222 VSS.t219 VSS.n236 212.143
R1223 VSS.t295 VSS.n257 212.143
R1224 VSS.t274 VSS.n254 212.143
R1225 VSS.t87 VSS.n277 212.143
R1226 VSS.t313 VSS.n291 212.143
R1227 VSS.n310 VSS.t490 212.143
R1228 VSS.n179 VSS.t622 211.982
R1229 VSS.n176 VSS.t412 211.982
R1230 VSS.n171 VSS.t400 211.982
R1231 VSS.n167 VSS.t209 211.982
R1232 VSS.n131 VSS.t398 211.982
R1233 VSS.n137 VSS.t94 211.982
R1234 VSS.n138 VSS.t618 211.982
R1235 VSS.t409 VSS.n121 211.982
R1236 VSS.t604 VSS.n117 211.982
R1237 VSS.t1 VSS.n115 211.982
R1238 VSS.t364 VSS.n113 211.982
R1239 VSS.n150 VSS.t615 211.982
R1240 VSS.t393 VSS.n105 211.982
R1241 VSS.n154 VSS.t607 211.982
R1242 VSS.n159 VSS.t4 211.982
R1243 VSS.t316 VSS.n99 211.982
R1244 VSS.n717 VSS.t281 208.828
R1245 VSS.n204 VSS.t346 207.294
R1246 VSS.n719 VSS.t404 202.362
R1247 VSS.n705 VSS.t500 202.071
R1248 VSS.n691 VSS.t497 202.071
R1249 VSS.n198 VSS.t589 200.649
R1250 VSS.n631 VSS.n0 197.518
R1251 VSS.n710 VSS.t212 196.911
R1252 VSS.n707 VSS.t391 196.399
R1253 VSS.n693 VSS.t377 196.399
R1254 VSS.n206 VSS.t147 195.778
R1255 VSS.t503 VSS.n132 195.26
R1256 VSS.t220 VSS.n135 195.26
R1257 VSS.t286 VSS.n124 195.26
R1258 VSS.t184 VSS.n120 195.26
R1259 VSS.t483 VSS.n119 195.26
R1260 VSS.t117 VSS.n145 195.26
R1261 VSS.t595 VSS.n111 195.26
R1262 VSS.t104 VSS.n109 195.26
R1263 VSS.t509 VSS.n153 195.26
R1264 VSS.t262 VSS.n156 195.26
R1265 VSS.t493 VSS.n161 195.26
R1266 VSS.t194 VSS.n97 195.26
R1267 VSS.n178 VSS.t188 195.26
R1268 VSS.n173 VSS.t480 195.26
R1269 VSS.n170 VSS.t252 195.26
R1270 VSS.n166 VSS.t241 195.26
R1271 VSS.t498 VSS.n190 194.899
R1272 VSS.n827 VSS.t338 194.514
R1273 VSS.t363 VSS.n255 189.137
R1274 VSS.n210 VSS.t505 189.135
R1275 VSS.t472 VSS.n632 187.895
R1276 VSS.n512 VSS.t223 187.292
R1277 VSS.n507 VSS.t349 187.292
R1278 VSS.n502 VSS.t258 187.292
R1279 VSS.n497 VSS.t508 187.292
R1280 VSS.n492 VSS.t367 187.292
R1281 VSS.n487 VSS.t323 187.292
R1282 VSS.n482 VSS.t288 187.292
R1283 VSS.n477 VSS.t603 187.292
R1284 VSS.n472 VSS.t79 187.292
R1285 VSS.n467 VSS.t592 187.292
R1286 VSS.n462 VSS.t238 187.292
R1287 VSS.n457 VSS.t301 187.292
R1288 VSS.n452 VSS.t234 187.292
R1289 VSS.n447 VSS.t250 187.292
R1290 VSS.n442 VSS.t602 187.292
R1291 VSS.n437 VSS.t591 187.292
R1292 VSS.n208 VSS.t590 184.262
R1293 VSS.t311 VSS.n702 183.975
R1294 VSS.n708 VSS.t308 182.797
R1295 VSS.n694 VSS.t88 182.797
R1296 VSS.n6 VSS.t468 177.713
R1297 VSS.n190 VSS.t271 177.617
R1298 VSS.n255 VSS.t273 177.617
R1299 VSS.n228 VSS.t84 177.615
R1300 VSS.n241 VSS.t218 177.615
R1301 VSS.n263 VSS.t294 177.615
R1302 VSS.n282 VSS.t86 177.615
R1303 VSS.n296 VSS.t312 177.615
R1304 VSS.t489 VSS.n305 177.615
R1305 VSS.t488 VSS.n356 173.913
R1306 VSS.n361 VSS.t306 173.913
R1307 VSS.n366 VSS.t320 173.913
R1308 VSS.t397 VSS.n371 173.913
R1309 VSS.t322 VSS.n376 173.913
R1310 VSS.n381 VSS.t11 173.913
R1311 VSS.t612 VSS.n386 173.913
R1312 VSS.t202 VSS.n391 173.913
R1313 VSS.t143 VSS.n396 173.913
R1314 VSS.n401 VSS.t290 173.913
R1315 VSS.t507 VSS.n406 173.913
R1316 VSS.t135 VSS.n411 173.913
R1317 VSS.t614 VSS.n416 173.913
R1318 VSS.n421 VSS.t205 173.913
R1319 VSS.n426 VSS.t315 173.913
R1320 VSS.t8 VSS.n431 173.913
R1321 VSS.n433 VSS.n95 173.913
R1322 VSS.t91 VSS.n689 167.954
R1323 VSS.t399 VSS.t502 163.881
R1324 VSS.t623 VSS.t222 163.881
R1325 VSS.t95 VSS.t287 163.881
R1326 VSS.t619 VSS.t186 163.881
R1327 VSS.t410 VSS.t182 163.881
R1328 VSS.t413 VSS.t482 163.881
R1329 VSS.t605 VSS.t115 163.881
R1330 VSS.t2 VSS.t479 163.881
R1331 VSS.t365 VSS.t596 163.881
R1332 VSS.t616 VSS.t102 163.881
R1333 VSS.t401 VSS.t253 163.881
R1334 VSS.t394 VSS.t510 163.881
R1335 VSS.t608 VSS.t260 163.881
R1336 VSS.t5 VSS.t494 163.881
R1337 VSS.t210 VSS.t240 163.881
R1338 VSS.t317 VSS.t192 163.881
R1339 VSS.n215 VSS.t13 160.341
R1340 VSS.n229 VSS.t24 160.341
R1341 VSS.n246 VSS.t35 160.341
R1342 VSS.n269 VSS.t46 160.341
R1343 VSS.n283 VSS.t57 160.341
R1344 VSS.n297 VSS.t68 160.341
R1345 VSS.t416 VSS.n184 157.601
R1346 VSS.n185 VSS.t471 156.464
R1347 VSS.t199 VSS.n131 155.126
R1348 VSS.t279 VSS.n137 155.126
R1349 VSS.t342 VSS.n138 155.126
R1350 VSS.t233 VSS.n121 155.126
R1351 VSS.t392 VSS.n117 155.126
R1352 VSS.t370 VSS.n115 155.126
R1353 VSS.t477 VSS.n113 155.126
R1354 VSS.t161 VSS.n150 155.126
R1355 VSS.t610 VSS.n105 155.126
R1356 VSS.t285 VSS.n154 155.126
R1357 VSS.t207 VSS.n159 155.126
R1358 VSS.t513 VSS.n99 155.126
R1359 VSS.n179 VSS.t130 155.125
R1360 VSS.n176 VSS.t263 155.125
R1361 VSS.n171 VSS.t190 155.125
R1362 VSS.n167 VSS.t140 155.125
R1363 VSS.n604 VSS.t443 154.613
R1364 VSS.n615 VSS.t450 154.613
R1365 VSS.t197 VSS.n194 153.971
R1366 VSS.n185 VSS.t408 153.851
R1367 VSS.n521 VSS.t151 153.846
R1368 VSS.n512 VSS.t487 153.846
R1369 VSS.n507 VSS.t305 153.846
R1370 VSS.n502 VSS.t319 153.846
R1371 VSS.n497 VSS.t396 153.846
R1372 VSS.n492 VSS.t321 153.846
R1373 VSS.n487 VSS.t10 153.846
R1374 VSS.n482 VSS.t611 153.846
R1375 VSS.n477 VSS.t201 153.846
R1376 VSS.n472 VSS.t142 153.846
R1377 VSS.n467 VSS.t289 153.846
R1378 VSS.n462 VSS.t506 153.846
R1379 VSS.n457 VSS.t134 153.846
R1380 VSS.n452 VSS.t613 153.846
R1381 VSS.n447 VSS.t204 153.846
R1382 VSS.n442 VSS.t314 153.846
R1383 VSS.n437 VSS.t7 153.846
R1384 VSS.t417 VSS.n94 153.236
R1385 VSS.t515 VSS.n195 149.713
R1386 VSS.t16 VSS.n215 148.826
R1387 VSS.t27 VSS.n229 148.826
R1388 VSS.t38 VSS.n246 148.826
R1389 VSS.t49 VSS.n269 148.826
R1390 VSS.t60 VSS.n283 148.826
R1391 VSS.t71 VSS.n297 148.826
R1392 VSS.n5 VSS.t369 147.453
R1393 VSS.t162 VSS.n355 147.157
R1394 VSS.t495 VSS.n360 147.157
R1395 VSS.t82 VSS.n365 147.157
R1396 VSS.t601 VSS.n370 147.157
R1397 VSS.t159 VSS.n375 147.157
R1398 VSS.t600 VSS.n380 147.157
R1399 VSS.t476 VSS.n385 147.157
R1400 VSS.t587 VSS.n390 147.157
R1401 VSS.t120 VSS.n395 147.157
R1402 VSS.t225 VSS.n400 147.157
R1403 VSS.t230 VSS.n405 147.157
R1404 VSS.t348 VSS.n410 147.157
R1405 VSS.t255 VSS.n415 147.157
R1406 VSS.t359 VSS.n420 147.157
R1407 VSS.t282 VSS.n425 147.157
R1408 VSS.t496 VSS.n430 147.157
R1409 VSS.t466 VSS.n164 145.091
R1410 VSS.t276 VSS.n708 138.607
R1411 VSS.t492 VSS.n694 138.607
R1412 VSS.n164 VSS.t462 138.403
R1413 VSS.t78 VSS.n305 137.311
R1414 VSS.n296 VSS.t67 137.311
R1415 VSS.n282 VSS.t56 137.311
R1416 VSS.n263 VSS.t45 137.311
R1417 VSS.n241 VSS.t34 137.311
R1418 VSS.n228 VSS.t23 137.311
R1419 VSS.t296 VSS.n202 137.309
R1420 VSS.n684 VSS.n641 132.891
R1421 VSS.t462 VSS.n163 131.972
R1422 VSS.n192 VSS.t504 130.939
R1423 VSS.t361 VSS.n267 130.939
R1424 VSS.n860 VSS.t484 127.421
R1425 VSS.t527 VSS.n1 125.359
R1426 VSS.t249 VSS.n856 123.674
R1427 VSS.n632 VSS.n631 122.129
R1428 VSS.n634 VSS.t426 121.858
R1429 VSS.t471 VSS.n94 120.691
R1430 VSS.n205 VSS.t284 119.422
R1431 VSS.n182 VSS.t415 118.249
R1432 VSS.n433 VSS.t466 117.058
R1433 VSS.n855 VSS.t243 116.177
R1434 VSS.t357 VSS.n701 115.831
R1435 VSS.t358 VSS.n624 112.174
R1436 VSS.t245 VSS.n858 108.683
R1437 VSS.n684 VSS.n683 107.177
R1438 VSS.n514 VSS.t199 107.023
R1439 VSS.n511 VSS.t162 107.023
R1440 VSS.t130 VSS.n509 107.023
R1441 VSS.n506 VSS.t495 107.023
R1442 VSS.n504 VSS.t279 107.023
R1443 VSS.n501 VSS.t82 107.023
R1444 VSS.n499 VSS.t342 107.023
R1445 VSS.n496 VSS.t601 107.023
R1446 VSS.n494 VSS.t233 107.023
R1447 VSS.n491 VSS.t159 107.023
R1448 VSS.t263 VSS.n489 107.023
R1449 VSS.n486 VSS.t600 107.023
R1450 VSS.n484 VSS.t392 107.023
R1451 VSS.n481 VSS.t476 107.023
R1452 VSS.n479 VSS.t370 107.023
R1453 VSS.n476 VSS.t587 107.023
R1454 VSS.n474 VSS.t477 107.023
R1455 VSS.n471 VSS.t120 107.023
R1456 VSS.n469 VSS.t161 107.023
R1457 VSS.n466 VSS.t225 107.023
R1458 VSS.t190 VSS.n464 107.023
R1459 VSS.n461 VSS.t230 107.023
R1460 VSS.n459 VSS.t610 107.023
R1461 VSS.n456 VSS.t348 107.023
R1462 VSS.n454 VSS.t285 107.023
R1463 VSS.n451 VSS.t255 107.023
R1464 VSS.n449 VSS.t207 107.023
R1465 VSS.n446 VSS.t359 107.023
R1466 VSS.t140 VSS.n444 107.023
R1467 VSS.n441 VSS.t282 107.023
R1468 VSS.n439 VSS.t513 107.023
R1469 VSS.n436 VSS.t496 107.023
R1470 VSS.t378 VSS.n853 106.808
R1471 VSS.n635 VSS.t597 103.538
R1472 VSS.n721 VSS.t403 103.379
R1473 VSS.n521 VSS.t456 100.335
R1474 VSS.t487 VSS.n355 100.335
R1475 VSS.t305 VSS.n360 100.335
R1476 VSS.t319 VSS.n365 100.335
R1477 VSS.t396 VSS.n370 100.335
R1478 VSS.t321 VSS.n375 100.335
R1479 VSS.t10 VSS.n380 100.335
R1480 VSS.t611 VSS.n385 100.335
R1481 VSS.t201 VSS.n390 100.335
R1482 VSS.t142 VSS.n395 100.335
R1483 VSS.t289 VSS.n400 100.335
R1484 VSS.t506 VSS.n405 100.335
R1485 VSS.t134 VSS.n410 100.335
R1486 VSS.t613 VSS.n415 100.335
R1487 VSS.t204 VSS.n420 100.335
R1488 VSS.t314 VSS.n425 100.335
R1489 VSS.t7 VSS.n430 100.335
R1490 VSS.n604 VSS.t446 99.7511
R1491 VSS.t452 VSS.n615 99.7511
R1492 VSS.n720 VSS.t419 98.4633
R1493 VSS.n4 VSS.t452 97.9283
R1494 VSS.t446 VSS.n1 97.9279
R1495 VSS.t236 VSS.n700 97.5777
R1496 VSS.t407 VSS.n862 97.4396
R1497 VSS.n200 VSS.t283 96.3896
R1498 VSS.n184 VSS.t485 93.8889
R1499 VSS.n862 VSS.t379 93.6919
R1500 VSS.n163 VSS.t8 88.4947
R1501 VSS.n181 VSS.t469 88.4111
R1502 VSS.t473 VSS.n717 88.3462
R1503 VSS.n174 VSS.t612 88.2366
R1504 VSS.n169 VSS.t135 88.2366
R1505 VSS.n133 VSS.t488 88.2359
R1506 VSS.t306 VSS.n126 88.2359
R1507 VSS.t320 VSS.n123 88.2359
R1508 VSS.n140 VSS.t397 88.2359
R1509 VSS.n142 VSS.t322 88.2359
R1510 VSS.t11 VSS.n118 88.2359
R1511 VSS.n147 VSS.t202 88.2359
R1512 VSS.n148 VSS.t143 88.2359
R1513 VSS.t290 VSS.n108 88.2359
R1514 VSS.n152 VSS.t507 88.2359
R1515 VSS.n157 VSS.t614 88.2359
R1516 VSS.t205 VSS.n102 88.2359
R1517 VSS.t315 VSS.n100 88.2359
R1518 VSS.t456 VSS.t149 86.957
R1519 VSS.t151 VSS.t458 86.957
R1520 VSS.t309 VSS.n705 85.7923
R1521 VSS.t89 VSS.n691 85.7923
R1522 VSS.t514 VSS.n200 84.8733
R1523 VSS.t469 VSS.n523 83.0562
R1524 VSS.n858 VSS.t470 82.449
R1525 VSS.t474 VSS.n715 81.2384
R1526 VSS.n2 VSS.t527 80.4704
R1527 VSS.t107 VSS.n532 77.8798
R1528 VSS.n825 VSS.t92 77.2751
R1529 VSS.t512 VSS.t421 77.2751
R1530 VSS.n826 VSS.t337 75.4357
R1531 VSS.t470 VSS.n183 75.2962
R1532 VSS.t248 VSS.n855 74.9537
R1533 VSS.t149 VSS.n128 74.8587
R1534 VSS.n650 VSS.t621 74.7824
R1535 VSS.t347 VSS.n198 73.9692
R1536 VSS.t422 VSS.n625 73.536
R1537 VSS.n630 VSS.n626 73.536
R1538 VSS.n514 VSS.t399 70.2346
R1539 VSS.n509 VSS.t623 70.2346
R1540 VSS.n504 VSS.t95 70.2346
R1541 VSS.n499 VSS.t619 70.2346
R1542 VSS.n494 VSS.t410 70.2346
R1543 VSS.n489 VSS.t413 70.2346
R1544 VSS.n484 VSS.t605 70.2346
R1545 VSS.n479 VSS.t2 70.2346
R1546 VSS.n474 VSS.t365 70.2346
R1547 VSS.n469 VSS.t616 70.2346
R1548 VSS.n464 VSS.t401 70.2346
R1549 VSS.n459 VSS.t394 70.2346
R1550 VSS.n454 VSS.t608 70.2346
R1551 VSS.n449 VSS.t5 70.2346
R1552 VSS.n444 VSS.t210 70.2346
R1553 VSS.n439 VSS.t317 70.2346
R1554 VSS.t169 VSS.n543 69.1047
R1555 VSS.n225 VSS.t18 68.211
R1556 VSS.n238 VSS.t29 68.211
R1557 VSS.n260 VSS.t40 68.211
R1558 VSS.n279 VSS.t51 68.211
R1559 VSS.n293 VSS.t62 68.211
R1560 VSS.n307 VSS.t73 68.211
R1561 VSS.n856 VSS.t248 67.4583
R1562 VSS.n564 VSS.t109 66.9109
R1563 VSS.n513 VSS.t503 66.8901
R1564 VSS.t223 VSS.n353 66.8901
R1565 VSS.n508 VSS.t220 66.8901
R1566 VSS.t349 VSS.n358 66.8901
R1567 VSS.n503 VSS.t286 66.8901
R1568 VSS.t258 VSS.n363 66.8901
R1569 VSS.t188 VSS.n498 66.8901
R1570 VSS.t508 VSS.n368 66.8901
R1571 VSS.n493 VSS.t184 66.8901
R1572 VSS.t367 VSS.n373 66.8901
R1573 VSS.n488 VSS.t483 66.8901
R1574 VSS.t323 VSS.n378 66.8901
R1575 VSS.n483 VSS.t117 66.8901
R1576 VSS.t288 VSS.n383 66.8901
R1577 VSS.t480 VSS.n478 66.8901
R1578 VSS.t603 VSS.n388 66.8901
R1579 VSS.n473 VSS.t595 66.8901
R1580 VSS.t79 VSS.n393 66.8901
R1581 VSS.n468 VSS.t104 66.8901
R1582 VSS.t592 VSS.n398 66.8901
R1583 VSS.t252 VSS.n463 66.8901
R1584 VSS.t238 VSS.n403 66.8901
R1585 VSS.n458 VSS.t509 66.8901
R1586 VSS.t301 VSS.n408 66.8901
R1587 VSS.n453 VSS.t262 66.8901
R1588 VSS.t234 VSS.n413 66.8901
R1589 VSS.n448 VSS.t493 66.8901
R1590 VSS.t250 VSS.n418 66.8901
R1591 VSS.t241 VSS.n443 66.8901
R1592 VSS.t602 VSS.n423 66.8901
R1593 VSS.n438 VSS.t194 66.8901
R1594 VSS.t591 VSS.n428 66.8901
R1595 VSS.t541 VSS.n677 65.3699
R1596 VSS.n683 VSS.t530 65.3659
R1597 VSS.t485 VSS.n860 63.7107
R1598 VSS.t379 VSS.n861 62.4441
R1599 VSS.n676 VSS.t545 62.1568
R1600 VSS.t145 VSS.n205 61.8407
R1601 VSS.n630 VSS.n629 59.3547
R1602 VSS.n863 VSS.t407 58.6964
R1603 VSS.n749 VSS.t165 58.1358
R1604 VSS.t621 VSS.n641 58.1084
R1605 VSS.t369 VSS.n4 58.0274
R1606 VSS.n697 VSS.t304 57.9156
R1607 VSS.t389 VSS.n256 56.6734
R1608 VSS.n227 VSS.t22 56.0825
R1609 VSS.n240 VSS.t33 56.0825
R1610 VSS.n262 VSS.t44 56.0825
R1611 VSS.n281 VSS.t55 56.0825
R1612 VSS.n295 VSS.t66 56.0825
R1613 VSS.n309 VSS.t77 56.0825
R1614 VSS.t163 VSS.n538 55.942
R1615 VSS.n681 VSS.t535 55.7347
R1616 VSS.t537 VSS.n679 55.7328
R1617 VSS.t415 VSS.n181 54.6841
R1618 VSS.t433 VSS.n526 53.7482
R1619 VSS.n650 VSS.t340 52.3478
R1620 VSS.t384 VSS.n62 51.2456
R1621 VSS.t299 VSS.n192 50.3244
R1622 VSS.n267 VSS.t517 50.3244
R1623 VSS.t398 VSS.n352 50.1677
R1624 VSS.t622 VSS.n357 50.1677
R1625 VSS.t94 VSS.n362 50.1677
R1626 VSS.t618 VSS.n367 50.1677
R1627 VSS.n372 VSS.t409 50.1677
R1628 VSS.t412 VSS.n377 50.1677
R1629 VSS.n382 VSS.t604 50.1677
R1630 VSS.n387 VSS.t1 50.1677
R1631 VSS.n392 VSS.t364 50.1677
R1632 VSS.t615 VSS.n397 50.1677
R1633 VSS.t400 VSS.n402 50.1677
R1634 VSS.n407 VSS.t393 50.1677
R1635 VSS.t607 VSS.n412 50.1677
R1636 VSS.t4 VSS.n417 50.1677
R1637 VSS.t209 VSS.n422 50.1677
R1638 VSS.n427 VSS.t316 50.1677
R1639 VSS.t436 VSS.n546 49.3606
R1640 VSS.n859 VSS.t245 47.4535
R1641 VSS.t108 VSS.n533 47.1669
R1642 VSS.n739 VSS.t110 47.1669
R1643 VSS.n720 VSS.t422 46.116
R1644 VSS.n679 VSS.t539 46.1011
R1645 VSS.t533 VSS.n681 46.0981
R1646 VSS.n556 VSS.t167 44.9731
R1647 VSS.n709 VSS.t430 44.1903
R1648 VSS.n695 VSS.t424 44.1903
R1649 VSS.t450 VSS.n2 43.0642
R1650 VSS.t443 VSS.n0 43.0619
R1651 VSS.t92 VSS.n624 42.3769
R1652 VSS.t243 VSS.n854 39.9582
R1653 VSS.t543 VSS.n676 39.6765
R1654 VSS.n698 VSS.t368 39.1873
R1655 VSS.t167 VSS.n542 38.3917
R1656 VSS.n516 VSS.t265 36.7898
R1657 VSS.n510 VSS.t126 36.7898
R1658 VSS.n505 VSS.t354 36.7898
R1659 VSS.n500 VSS.t137 36.7898
R1660 VSS.t178 VSS.n495 36.7898
R1661 VSS.n490 VSS.t292 36.7898
R1662 VSS.n485 VSS.t229 36.7898
R1663 VSS.n480 VSS.t374 36.7898
R1664 VSS.t269 VSS.n475 36.7898
R1665 VSS.n470 VSS.t598 36.7898
R1666 VSS.n465 VSS.t216 36.7898
R1667 VSS.n460 VSS.t113 36.7898
R1668 VSS.n455 VSS.t158 36.7898
R1669 VSS.n450 VSS.t343 36.7898
R1670 VSS.t382 VSS.n445 36.7898
R1671 VSS.n440 VSS.t98 36.7898
R1672 VSS.n852 VSS.t433 36.5305
R1673 VSS.n677 VSS.t543 36.4657
R1674 VSS.n854 VSS.t378 36.2105
R1675 VSS.n729 VSS.t108 36.1979
R1676 VSS.t110 VSS.n563 36.1979
R1677 VSS.n183 VSS.t249 34.07
R1678 VSS.n774 VSS.t436 34.0042
R1679 VSS.t405 VSS.n635 33.9067
R1680 VSS.t403 VSS.n625 31.1596
R1681 VSS.t539 VSS.n678 30.0445
R1682 VSS.n682 VSS.t533 30.0445
R1683 VSS.t484 VSS.n859 28.7152
R1684 VSS.n853 VSS.n182 28.3058
R1685 VSS.t287 VSS.n125 28.2938
R1686 VSS.t186 VSS.n139 28.2938
R1687 VSS.t182 VSS.n141 28.2938
R1688 VSS.t260 VSS.n155 28.2938
R1689 VSS.t240 VSS.n101 28.2938
R1690 VSS.t222 VSS.n134 28.2938
R1691 VSS.t115 VSS.n116 28.2938
R1692 VSS.t479 VSS.n114 28.2938
R1693 VSS.t596 VSS.n112 28.2938
R1694 VSS.t102 VSS.n110 28.2938
R1695 VSS.t253 VSS.n151 28.2938
R1696 VSS.t510 VSS.n104 28.2938
R1697 VSS.t494 VSS.n160 28.2938
R1698 VSS.t192 VSS.n98 28.2938
R1699 VSS.t502 VSS.n180 28.2936
R1700 VSS.t482 VSS.n175 28.2936
R1701 VSS.n128 VSS.t417 28.0352
R1702 VSS.t468 VSS.n5 27.7516
R1703 VSS.t254 VSS.n698 27.6043
R1704 VSS.n560 VSS.t163 27.4228
R1705 VSS.n194 VSS.t198 27.2918
R1706 VSS.t165 VSS.n539 25.229
R1707 VSS.t421 VSS.n629 24.4565
R1708 VSS.n721 VSS.t358 22.3643
R1709 VSS.t429 VSS.n699 22.2881
R1710 VSS.n639 VSS.t350 22.2881
R1711 VSS.n266 VSS.t390 22.1486
R1712 VSS.t388 VSS.n264 22.1466
R1713 VSS.t458 VSS.n129 21.6048
R1714 VSS.t419 VSS.n626 21.1887
R1715 VSS.n680 VSS.t537 20.4123
R1716 VSS.t535 VSS.n680 20.4093
R1717 VSS.t128 VSS.n356 20.0674
R1718 VSS.t355 VSS.n361 20.0674
R1719 VSS.t139 VSS.n366 20.0674
R1720 VSS.t180 VSS.n371 20.0674
R1721 VSS.t291 VSS.n376 20.0674
R1722 VSS.t227 VSS.n381 20.0674
R1723 VSS.t372 VSS.n386 20.0674
R1724 VSS.t267 VSS.n391 20.0674
R1725 VSS.t599 VSS.n396 20.0674
R1726 VSS.t214 VSS.n401 20.0674
R1727 VSS.t111 VSS.n406 20.0674
R1728 VSS.t156 VSS.n411 20.0674
R1729 VSS.t345 VSS.n416 20.0674
R1730 VSS.t383 VSS.n421 20.0674
R1731 VSS.t100 VSS.n426 20.0674
R1732 VSS.t153 VSS.n431 20.0674
R1733 VSS.t338 VSS.t340 19.9423
R1734 VSS.n178 VSS.t231 18.0025
R1735 VSS.n177 VSS.t385 18.0025
R1736 VSS.n173 VSS.t257 18.0025
R1737 VSS.n172 VSS.t124 18.0025
R1738 VSS.n170 VSS.t593 18.0025
R1739 VSS.n168 VSS.t175 18.0025
R1740 VSS.n166 VSS.t125 18.0025
R1741 VSS.n130 VSS.t501 18.0017
R1742 VSS.t106 VSS.n132 18.0017
R1743 VSS.t594 VSS.n127 18.0017
R1744 VSS.n135 VSS.t475 18.0017
R1745 VSS.n136 VSS.t386 18.0017
R1746 VSS.t341 VSS.n124 18.0017
R1747 VSS.t381 VSS.n122 18.0017
R1748 VSS.t277 VSS.n120 18.0017
R1749 VSS.n143 VSS.t155 18.0017
R1750 VSS.t148 VSS.n119 18.0017
R1751 VSS.n144 VSS.t0 18.0017
R1752 VSS.n145 VSS.t97 18.0017
R1753 VSS.t119 VSS.n146 18.0017
R1754 VSS.t232 VSS.n111 18.0017
R1755 VSS.n149 VSS.t387 18.0017
R1756 VSS.t278 VSS.n109 18.0017
R1757 VSS.t270 VSS.n107 18.0017
R1758 VSS.t132 VSS.n106 18.0017
R1759 VSS.n153 VSS.t406 18.0017
R1760 VSS.t133 VSS.n103 18.0017
R1761 VSS.n156 VSS.t226 18.0017
R1762 VSS.n158 VSS.t586 18.0017
R1763 VSS.n161 VSS.t376 18.0017
R1764 VSS.n162 VSS.t418 18.0017
R1765 VSS.t275 VSS.n97 18.0017
R1766 VSS.t408 VSS.n863 17.4722
R1767 VSS.n92 VSS.n524 17.0005
R1768 VSS.n92 VSS.n855 17.0005
R1769 VSS.n92 VSS.n856 17.0005
R1770 VSS.n92 VSS.n858 17.0005
R1771 VSS.n92 VSS.n860 17.0005
R1772 VSS.n92 VSS.n862 17.0005
R1773 VSS.n92 VSS.n522 17.0005
R1774 VSS.n92 VSS.t152 17.0005
R1775 VSS.n864 VSS.n92 17.0005
R1776 VSS.n92 VSS.n165 17.0005
R1777 VSS.n301 VSS.n299 17.0005
R1778 VSS.n869 VSS.n300 17.0005
R1779 VSS.n872 VSS.n871 17.0005
R1780 VSS.n873 VSS.n872 17.0005
R1781 VSS.n287 VSS.n285 17.0005
R1782 VSS.n878 VSS.n286 17.0005
R1783 VSS.n881 VSS.n880 17.0005
R1784 VSS.n882 VSS.n881 17.0005
R1785 VSS.n273 VSS.n271 17.0005
R1786 VSS.n887 VSS.n272 17.0005
R1787 VSS.n890 VSS.n889 17.0005
R1788 VSS.n891 VSS.n890 17.0005
R1789 VSS.n893 VSS.n268 17.0005
R1790 VSS.n893 VSS.n265 17.0005
R1791 VSS.n259 VSS.n249 17.0005
R1792 VSS.n896 VSS.n244 17.0005
R1793 VSS.n247 VSS.n243 17.0005
R1794 VSS.n245 VSS.n243 17.0005
R1795 VSS.n233 VSS.n231 17.0005
R1796 VSS.n902 VSS.n232 17.0005
R1797 VSS.n905 VSS.n904 17.0005
R1798 VSS.n906 VSS.n905 17.0005
R1799 VSS.n224 VSS.n218 17.0005
R1800 VSS.n911 VSS.n213 17.0005
R1801 VSS.n216 VSS.n212 17.0005
R1802 VSS.n214 VSS.n212 17.0005
R1803 VSS.n914 VSS.n191 17.0005
R1804 VSS.n914 VSS.n208 17.0005
R1805 VSS.n914 VSS.n207 17.0005
R1806 VSS.n914 VSS.n195 17.0005
R1807 VSS.n914 VSS.n206 17.0005
R1808 VSS.n914 VSS.n197 17.0005
R1809 VSS.n914 VSS.n204 17.0005
R1810 VSS.n914 VSS.n199 17.0005
R1811 VSS.n92 VSS.n347 17.0005
R1812 VSS.n92 VSS.n349 17.0005
R1813 VSS.t213 VSS.n710 17.0005
R1814 VSS.t213 VSS.n64 13.5064
R1815 VSS.n709 VSS.t310 17.0005
R1816 VSS.n707 VSS.t310 17.0005
R1817 VSS.n704 VSS.t310 17.0005
R1818 VSS.n701 VSS.n67 17.0005
R1819 VSS.n697 VSS.n67 17.0005
R1820 VSS.n69 VSS.n67 13.5064
R1821 VSS.n695 VSS.t90 17.0005
R1822 VSS.n693 VSS.t90 17.0005
R1823 VSS.n690 VSS.t90 17.0005
R1824 VSS.n689 VSS.n688 17.0005
R1825 VSS.n688 VSS.n686 17.0005
R1826 VSS.t93 VSS.n825 17.0005
R1827 VSS.t93 VSS.n624 17.0005
R1828 VSS.t93 VSS.n625 17.0005
R1829 VSS.t93 VSS.n720 17.0005
R1830 VSS.t93 VSS.n626 17.0005
R1831 VSS.t93 VSS.n719 17.0005
R1832 VSS.n651 VSS.n650 17.0005
R1833 VSS.n826 VSS.t93 17.0005
R1834 VSS.t93 VSS.n634 17.0005
R1835 VSS.t93 VSS.n715 17.0005
R1836 VSS.n8 VSS.n592 17.0005
R1837 VSS.n8 VSS.n596 17.0005
R1838 VSS.n8 VSS.n599 17.0005
R1839 VSS.n8 VSS.n614 17.0005
R1840 VSS.n8 VSS.n612 17.0005
R1841 VSS.n8 VSS.n3 17.0005
R1842 VSS.n722 VSS.n39 17.0005
R1843 VSS.n775 VSS.n39 17.0005
R1844 VSS.n546 VSS.n39 17.0005
R1845 VSS.n774 VSS.n39 17.0005
R1846 VSS.n771 VSS.n39 17.0005
R1847 VSS.n772 VSS.n39 17.0005
R1848 VSS.n763 VSS.n39 17.0005
R1849 VSS.n543 VSS.n39 17.0005
R1850 VSS.n554 VSS.n39 17.0005
R1851 VSS.n761 VSS.n39 17.0005
R1852 VSS.n759 VSS.n39 17.0005
R1853 VSS.n542 VSS.n39 17.0005
R1854 VSS.n556 VSS.n39 17.0005
R1855 VSS.n757 VSS.n39 17.0005
R1856 VSS.n750 VSS.n39 17.0005
R1857 VSS.n751 VSS.n39 17.0005
R1858 VSS.n749 VSS.n39 17.0005
R1859 VSS.n539 VSS.n39 17.0005
R1860 VSS.n747 VSS.n39 17.0005
R1861 VSS.n745 VSS.n39 17.0005
R1862 VSS.n560 VSS.n39 17.0005
R1863 VSS.n538 VSS.n39 17.0005
R1864 VSS.n743 VSS.n39 17.0005
R1865 VSS.n740 VSS.n39 17.0005
R1866 VSS.n741 VSS.n39 17.0005
R1867 VSS.n739 VSS.n39 17.0005
R1868 VSS.n563 VSS.n39 17.0005
R1869 VSS.n737 VSS.n39 17.0005
R1870 VSS.n735 VSS.n39 17.0005
R1871 VSS.n535 VSS.n39 17.0005
R1872 VSS.n564 VSS.n39 17.0005
R1873 VSS.n733 VSS.n39 17.0005
R1874 VSS.n730 VSS.n39 17.0005
R1875 VSS.n731 VSS.n39 17.0005
R1876 VSS.n729 VSS.n39 17.0005
R1877 VSS.n533 VSS.n39 17.0005
R1878 VSS.n727 VSS.n39 17.0005
R1879 VSS.n725 VSS.n39 17.0005
R1880 VSS.n567 VSS.n39 17.0005
R1881 VSS.n532 VSS.n39 17.0005
R1882 VSS.n723 VSS.n39 17.0005
R1883 VSS.n526 VSS.n39 17.0005
R1884 VSS.n12 VSS.n532 17.0005
R1885 VSS.n12 VSS.n567 17.0005
R1886 VSS.n12 VSS.n533 17.0005
R1887 VSS.n12 VSS.n564 17.0005
R1888 VSS.n12 VSS.n535 17.0005
R1889 VSS.n12 VSS.n563 17.0005
R1890 VSS.n12 VSS.n538 17.0005
R1891 VSS.n12 VSS.n560 17.0005
R1892 VSS.n12 VSS.n539 17.0005
R1893 VSS.n12 VSS.n557 17.0005
R1894 VSS.n12 VSS.n556 17.0005
R1895 VSS.n12 VSS.n542 17.0005
R1896 VSS.n12 VSS.n554 17.0005
R1897 VSS.n12 VSS.n543 17.0005
R1898 VSS.n822 VSS.n526 17.0005
R1899 VSS.n822 VSS.n729 17.0005
R1900 VSS.n822 VSS.n739 17.0005
R1901 VSS.n822 VSS.n749 17.0005
R1902 VSS.n822 VSS.n756 17.0005
R1903 VSS.n822 VSS.n774 17.0005
R1904 VSS.n12 VSS.n551 17.0005
R1905 VSS.n15 VSS.n786 17.0005
R1906 VSS.n787 VSS.n15 17.0005
R1907 VSS.n12 VSS.n546 17.0005
R1908 VSS.n12 VSS.n548 17.0005
R1909 VSS.n584 VSS.n39 17.0005
R1910 VSS.n12 VSS.n549 17.0005
R1911 VSS.t109 VSS.n535 16.4539
R1912 VSS.n196 VSS.t298 16.3876
R1913 VSS.n63 VSS.n527 16.2018
R1914 VSS.n96 VSS.n95 88.2779
R1915 VSS.n554 VSS.t169 14.2601
R1916 VSS.n861 VSS.t416 13.7246
R1917 VSS.t433 VSS.t328 13.4836
R1918 VSS.n723 VSS.n531 12.0761
R1919 VSS.n725 VSS.n566 12.0761
R1920 VSS.n729 VSS.n534 12.0761
R1921 VSS.n733 VSS.n565 12.0761
R1922 VSS.n735 VSS.n536 12.0761
R1923 VSS.n741 VSS.n537 12.0761
R1924 VSS.n740 VSS.n562 12.0761
R1925 VSS.n745 VSS.n559 12.0761
R1926 VSS.n751 VSS.n558 12.0761
R1927 VSS.n750 VSS.n540 12.0761
R1928 VSS.n761 VSS.n555 12.0761
R1929 VSS.n772 VSS.n553 12.0761
R1930 VSS.n724 VSS.n532 12.0761
R1931 VSS.n726 VSS.n725 12.0761
R1932 VSS.n728 VSS.n533 12.0761
R1933 VSS.n732 VSS.n730 12.0761
R1934 VSS.n734 VSS.n564 12.0761
R1935 VSS.n736 VSS.n735 12.0761
R1936 VSS.n738 VSS.n563 12.0761
R1937 VSS.n742 VSS.n740 12.0761
R1938 VSS.n744 VSS.n538 12.0761
R1939 VSS.n746 VSS.n745 12.0761
R1940 VSS.n748 VSS.n539 12.0761
R1941 VSS.n752 VSS.n750 12.0761
R1942 VSS.n758 VSS.n556 12.0761
R1943 VSS.n760 VSS.n759 12.0761
R1944 VSS.n762 VSS.n554 12.0761
R1945 VSS.n764 VSS.n763 12.0761
R1946 VSS.n773 VSS.n771 12.0761
R1947 VSS.n776 VSS.n775 12.0761
R1948 VSS.n774 VSS.n544 12.0761
R1949 VSS.n722 VSS.n547 12.0761
R1950 VSS.n531 VSS.n526 12.0761
R1951 VSS.n724 VSS.n723 12.0761
R1952 VSS.n726 VSS.n567 12.0761
R1953 VSS.n727 VSS.n566 12.0761
R1954 VSS.n728 VSS.n727 12.0761
R1955 VSS.n731 VSS.n534 12.0761
R1956 VSS.n732 VSS.n731 12.0761
R1957 VSS.n730 VSS.n565 12.0761
R1958 VSS.n734 VSS.n733 12.0761
R1959 VSS.n736 VSS.n535 12.0761
R1960 VSS.n737 VSS.n536 12.0761
R1961 VSS.n738 VSS.n737 12.0761
R1962 VSS.n739 VSS.n537 12.0761
R1963 VSS.n742 VSS.n741 12.0761
R1964 VSS.n743 VSS.n562 12.0761
R1965 VSS.n744 VSS.n743 12.0761
R1966 VSS.n746 VSS.n560 12.0761
R1967 VSS.n747 VSS.n559 12.0761
R1968 VSS.n748 VSS.n747 12.0761
R1969 VSS.n749 VSS.n558 12.0761
R1970 VSS.n752 VSS.n751 12.0761
R1971 VSS.n757 VSS.n540 12.0761
R1972 VSS.n758 VSS.n757 12.0761
R1973 VSS.n760 VSS.n542 12.0761
R1974 VSS.n759 VSS.n555 12.0761
R1975 VSS.n762 VSS.n761 12.0761
R1976 VSS.n764 VSS.n543 12.0761
R1977 VSS.n763 VSS.n553 12.0761
R1978 VSS.n773 VSS.n772 12.0761
R1979 VSS.n771 VSS.n544 12.0761
R1980 VSS.n776 VSS.n546 12.0761
R1981 VSS.n775 VSS.n547 12.0761
R1982 VSS.n823 VSS.n722 11.454
R1983 VSS.n824 VSS.n823 11.454
R1984 VSS.t530 VSS.n682 10.7807
R1985 VSS.n678 VSS.t541 10.7787
R1986 VSS.n806 VSS.n583 9.81803
R1987 VSS.n838 VSS.n583 9.39094
R1988 VSS.n836 VSS.n835 9.38916
R1989 VSS.n601 VSS.t303 9.08698
R1990 VSS.t303 VSS.n600 9.0445
R1991 VSS.n829 VSS.n828 9.0005
R1992 VSS.n829 VSS.n587 9.0005
R1993 VSS.n591 VSS.n586 9.0005
R1994 VSS.n784 VSS.n586 9.0005
R1995 VSS.t545 VSS.n76 13.9896
R1996 VSS.t76 VSS.n867 8.501
R1997 VSS.n868 VSS.t74 8.501
R1998 VSS.t72 VSS.n298 8.501
R1999 VSS.t69 VSS.n290 8.501
R2000 VSS.t65 VSS.n876 8.501
R2001 VSS.n877 VSS.t63 8.501
R2002 VSS.t61 VSS.n284 8.501
R2003 VSS.t58 VSS.n276 8.501
R2004 VSS.t54 VSS.n885 8.501
R2005 VSS.n886 VSS.t52 8.501
R2006 VSS.t50 VSS.n270 8.501
R2007 VSS.t47 VSS.n253 8.501
R2008 VSS.t43 VSS.n894 8.501
R2009 VSS.n895 VSS.t41 8.501
R2010 VSS.t39 VSS.n897 8.501
R2011 VSS.n898 VSS.t36 8.501
R2012 VSS.t32 VSS.n900 8.501
R2013 VSS.n901 VSS.t30 8.501
R2014 VSS.t28 VSS.n230 8.501
R2015 VSS.t25 VSS.n221 8.501
R2016 VSS.t21 VSS.n909 8.501
R2017 VSS.n910 VSS.t19 8.501
R2018 VSS.t17 VSS.n912 8.501
R2019 VSS.n913 VSS.t14 8.501
R2020 VSS.n90 VSS.n89 0.00174993
R2021 VSS.n90 VSS.n96 9.59049
R2022 VSS.n813 VSS.n41 2.83417
R2023 VSS.n41 VSS.n40 0.00166658
R2024 VSS.n40 VSS.n42 0.00149997
R2025 VSS.n813 VSS.n43 3.40102
R2026 VSS.n813 VSS.n45 3.40102
R2027 VSS.n813 VSS.n48 2.12569
R2028 VSS.n48 VSS.n47 0.00170812
R2029 VSS.n50 VSS.n47 0.00166658
R2030 VSS.n50 VSS.n49 0.00149997
R2031 VSS.n813 VSS.n54 3.40102
R2032 VSS.n813 VSS.n57 3.40102
R2033 VSS.n813 VSS.n59 1.701
R2034 VSS.n21 VSS.n20 0.00216959
R2035 VSS.n20 VSS.n22 0.00170812
R2036 VSS.n22 VSS.n23 0.00166658
R2037 VSS.n23 VSS.n24 0.00149997
R2038 VSS.n851 VSS.n26 4.251
R2039 VSS.n26 VSS.n25 0.00149997
R2040 VSS.n851 VSS.n28 2.83417
R2041 VSS.n28 VSS.n27 0.00166658
R2042 VSS.n27 VSS.n29 0.00149997
R2043 VSS.n851 VSS.n31 4.251
R2044 VSS.n31 VSS.n30 0.00149997
R2045 VSS.n851 VSS.n33 4.251
R2046 VSS.n33 VSS.n32 0.00149997
R2047 VSS.n851 VSS.n35 2.12578
R2048 VSS.n35 VSS.n36 0.00274975
R2049 VSS.n36 VSS.n37 0.00149997
R2050 VSS.n703 VSS.n66 406.622
R2051 VSS.n71 VSS.n70 406.622
R2052 VSS.n73 VSS.n71 0.00235708
R2053 VSS.n675 VSS.n76 1.4291
R2054 VSS.n75 VSS.n77 0.00170812
R2055 VSS.n77 VSS.n78 0.00166658
R2056 VSS.n78 VSS.n79 0.00149997
R2057 VSS.n675 VSS.n80 3.40102
R2058 VSS.n675 VSS.n82 3.40102
R2059 VSS.n675 VSS.n84 3.40102
R2060 VSS.n675 VSS.n86 2.42956
R2061 VSS.n76 VSS.n75 0.00124813
R2062 VSS.n827 VSS.n6 5.41263
R2063 VSS.n13 VSS.n12 0.00138884
R2064 VSS.n12 VSS.n14 0.00166658
R2065 VSS.n16 VSS.n15 0.00216959
R2066 VSS.n15 VSS.n17 0.00170812
R2067 VSS.n17 VSS.n18 0.00166658
R2068 VSS.n18 VSS.n19 0.00149997
R2069 VSS.n824 VSS.n39 8.501
R2070 VSS.n92 VSS.n521 8.5005
R2071 VSS.n92 VSS.n516 8.5005
R2072 VSS.n92 VSS.n352 8.5005
R2073 VSS.n92 VSS.n514 8.5005
R2074 VSS.n92 VSS.n513 8.5005
R2075 VSS.n92 VSS.n353 8.5005
R2076 VSS.n92 VSS.n512 8.5005
R2077 VSS.n92 VSS.n355 8.5005
R2078 VSS.n92 VSS.n511 8.5005
R2079 VSS.n92 VSS.n356 8.5005
R2080 VSS.n92 VSS.n510 8.5005
R2081 VSS.n92 VSS.n357 8.5005
R2082 VSS.n92 VSS.n509 8.5005
R2083 VSS.n92 VSS.n508 8.5005
R2084 VSS.n92 VSS.n358 8.5005
R2085 VSS.n92 VSS.n507 8.5005
R2086 VSS.n92 VSS.n360 8.5005
R2087 VSS.n92 VSS.n506 8.5005
R2088 VSS.n92 VSS.n361 8.5005
R2089 VSS.n92 VSS.n505 8.5005
R2090 VSS.n92 VSS.n362 8.5005
R2091 VSS.n92 VSS.n504 8.5005
R2092 VSS.n92 VSS.n503 8.5005
R2093 VSS.n92 VSS.n363 8.5005
R2094 VSS.n92 VSS.n502 8.5005
R2095 VSS.n92 VSS.n365 8.5005
R2096 VSS.n92 VSS.n501 8.5005
R2097 VSS.n92 VSS.n366 8.5005
R2098 VSS.n92 VSS.n500 8.5005
R2099 VSS.n92 VSS.n367 8.5005
R2100 VSS.n92 VSS.n499 8.5005
R2101 VSS.n92 VSS.n498 8.5005
R2102 VSS.n92 VSS.n368 8.5005
R2103 VSS.n92 VSS.n497 8.5005
R2104 VSS.n92 VSS.n370 8.5005
R2105 VSS.n92 VSS.n496 8.5005
R2106 VSS.n92 VSS.n371 8.5005
R2107 VSS.n92 VSS.n495 8.5005
R2108 VSS.n92 VSS.n372 8.5005
R2109 VSS.n92 VSS.n494 8.5005
R2110 VSS.n92 VSS.n493 8.5005
R2111 VSS.n92 VSS.n373 8.5005
R2112 VSS.n92 VSS.n492 8.5005
R2113 VSS.n92 VSS.n375 8.5005
R2114 VSS.n92 VSS.n491 8.5005
R2115 VSS.n92 VSS.n376 8.5005
R2116 VSS.n92 VSS.n490 8.5005
R2117 VSS.n92 VSS.n377 8.5005
R2118 VSS.n92 VSS.n489 8.5005
R2119 VSS.n92 VSS.n488 8.5005
R2120 VSS.n92 VSS.n378 8.5005
R2121 VSS.n92 VSS.n487 8.5005
R2122 VSS.n92 VSS.n380 8.5005
R2123 VSS.n92 VSS.n486 8.5005
R2124 VSS.n92 VSS.n381 8.5005
R2125 VSS.n92 VSS.n485 8.5005
R2126 VSS.n92 VSS.n382 8.5005
R2127 VSS.n92 VSS.n484 8.5005
R2128 VSS.n92 VSS.n483 8.5005
R2129 VSS.n92 VSS.n383 8.5005
R2130 VSS.n92 VSS.n482 8.5005
R2131 VSS.n92 VSS.n385 8.5005
R2132 VSS.n92 VSS.n481 8.5005
R2133 VSS.n92 VSS.n386 8.5005
R2134 VSS.n92 VSS.n480 8.5005
R2135 VSS.n92 VSS.n387 8.5005
R2136 VSS.n92 VSS.n479 8.5005
R2137 VSS.n92 VSS.n478 8.5005
R2138 VSS.n92 VSS.n388 8.5005
R2139 VSS.n92 VSS.n477 8.5005
R2140 VSS.n92 VSS.n390 8.5005
R2141 VSS.n92 VSS.n476 8.5005
R2142 VSS.n92 VSS.n391 8.5005
R2143 VSS.n92 VSS.n475 8.5005
R2144 VSS.n92 VSS.n392 8.5005
R2145 VSS.n92 VSS.n474 8.5005
R2146 VSS.n92 VSS.n473 8.5005
R2147 VSS.n92 VSS.n393 8.5005
R2148 VSS.n92 VSS.n472 8.5005
R2149 VSS.n92 VSS.n395 8.5005
R2150 VSS.n92 VSS.n471 8.5005
R2151 VSS.n92 VSS.n396 8.5005
R2152 VSS.n92 VSS.n470 8.5005
R2153 VSS.n92 VSS.n397 8.5005
R2154 VSS.n92 VSS.n469 8.5005
R2155 VSS.n92 VSS.n468 8.5005
R2156 VSS.n92 VSS.n398 8.5005
R2157 VSS.n92 VSS.n467 8.5005
R2158 VSS.n92 VSS.n400 8.5005
R2159 VSS.n92 VSS.n466 8.5005
R2160 VSS.n92 VSS.n401 8.5005
R2161 VSS.n92 VSS.n465 8.5005
R2162 VSS.n92 VSS.n402 8.5005
R2163 VSS.n92 VSS.n464 8.5005
R2164 VSS.n92 VSS.n463 8.5005
R2165 VSS.n92 VSS.n403 8.5005
R2166 VSS.n92 VSS.n462 8.5005
R2167 VSS.n92 VSS.n405 8.5005
R2168 VSS.n92 VSS.n461 8.5005
R2169 VSS.n92 VSS.n406 8.5005
R2170 VSS.n92 VSS.n460 8.5005
R2171 VSS.n92 VSS.n407 8.5005
R2172 VSS.n92 VSS.n459 8.5005
R2173 VSS.n92 VSS.n458 8.5005
R2174 VSS.n92 VSS.n408 8.5005
R2175 VSS.n92 VSS.n457 8.5005
R2176 VSS.n92 VSS.n410 8.5005
R2177 VSS.n92 VSS.n456 8.5005
R2178 VSS.n92 VSS.n411 8.5005
R2179 VSS.n92 VSS.n455 8.5005
R2180 VSS.n92 VSS.n412 8.5005
R2181 VSS.n92 VSS.n454 8.5005
R2182 VSS.n92 VSS.n453 8.5005
R2183 VSS.n92 VSS.n413 8.5005
R2184 VSS.n92 VSS.n452 8.5005
R2185 VSS.n92 VSS.n415 8.5005
R2186 VSS.n92 VSS.n451 8.5005
R2187 VSS.n92 VSS.n416 8.5005
R2188 VSS.n92 VSS.n450 8.5005
R2189 VSS.n92 VSS.n417 8.5005
R2190 VSS.n92 VSS.n449 8.5005
R2191 VSS.n92 VSS.n448 8.5005
R2192 VSS.n92 VSS.n418 8.5005
R2193 VSS.n92 VSS.n447 8.5005
R2194 VSS.n92 VSS.n420 8.5005
R2195 VSS.n92 VSS.n446 8.5005
R2196 VSS.n92 VSS.n421 8.5005
R2197 VSS.n92 VSS.n445 8.5005
R2198 VSS.n92 VSS.n422 8.5005
R2199 VSS.n92 VSS.n444 8.5005
R2200 VSS.n92 VSS.n443 8.5005
R2201 VSS.n92 VSS.n423 8.5005
R2202 VSS.n92 VSS.n442 8.5005
R2203 VSS.n92 VSS.n425 8.5005
R2204 VSS.n92 VSS.n441 8.5005
R2205 VSS.n92 VSS.n426 8.5005
R2206 VSS.n92 VSS.n440 8.5005
R2207 VSS.n92 VSS.n427 8.5005
R2208 VSS.n92 VSS.n439 8.5005
R2209 VSS.n92 VSS.n438 8.5005
R2210 VSS.n92 VSS.n428 8.5005
R2211 VSS.n92 VSS.n437 8.5005
R2212 VSS.n92 VSS.n430 8.5005
R2213 VSS.n92 VSS.n436 8.5005
R2214 VSS.n92 VSS.n431 8.5005
R2215 VSS.n92 VSS.n433 8.5005
R2216 VSS.n8 VSS.n615 8.5005
R2217 VSS.n8 VSS.n604 8.5005
R2218 VSS.n589 VSS.n8 8.48883
R2219 VSS.n8 VSS.n588 8.48883
R2220 VSS.n92 VSS.n435 8.48012
R2221 VSS.t562 VSS.n77 8.47784
R2222 VSS.n662 VSS.n78 8.47784
R2223 VSS.n663 VSS.n79 8.47784
R2224 VSS.n665 VSS.n81 8.47784
R2225 VSS.n667 VSS.n83 8.47784
R2226 VSS.n669 VSS.n85 8.47784
R2227 VSS.n673 VSS.n87 8.47784
R2228 VSS.n674 VSS.n88 8.47784
R2229 VSS.n74 VSS.t546 8.47784
R2230 VSS.n92 VSS.n351 8.47732
R2231 VSS.n92 VSS.t461 8.47732
R2232 VSS.n434 VSS.n89 8.47732
R2233 VSS.n93 VSS.n91 8.47732
R2234 VSS.n92 VSS.n313 8.47732
R2235 VSS.n92 VSS.n314 8.47732
R2236 VSS.n92 VSS.n348 8.47732
R2237 VSS.n803 VSS.n39 8.47732
R2238 VSS.n801 VSS.n39 8.47732
R2239 VSS.n581 VSS.n39 8.47732
R2240 VSS.t434 VSS.n40 8.47732
R2241 VSS.n800 VSS.n42 8.47732
R2242 VSS.n808 VSS.n44 8.47732
R2243 VSS.n810 VSS.n46 8.47732
R2244 VSS.n811 VSS.n797 8.47732
R2245 VSS.n47 VSS.n812 8.47732
R2246 VSS.n795 VSS.n50 8.47732
R2247 VSS.t326 VSS.n49 8.47732
R2248 VSS.n794 VSS.n53 8.47732
R2249 VSS.n815 VSS.n56 8.47732
R2250 VSS.n818 VSS.n58 8.47732
R2251 VSS.n819 VSS.n61 8.47732
R2252 VSS.n820 VSS.n60 8.47732
R2253 VSS.n578 VSS.n20 8.47732
R2254 VSS.n840 VSS.n22 8.47732
R2255 VSS.n577 VSS.n23 8.47732
R2256 VSS.t330 VSS.n24 8.47732
R2257 VSS.n576 VSS.n575 8.47732
R2258 VSS.n841 VSS.n25 8.47732
R2259 VSS.n573 VSS.n574 8.47732
R2260 VSS.t332 VSS.n27 8.47732
R2261 VSS.t333 VSS.n29 8.47732
R2262 VSS.n842 VSS.n572 8.47732
R2263 VSS.n843 VSS.n30 8.47732
R2264 VSS.t334 VSS.n845 8.47732
R2265 VSS.n846 VSS.n32 8.47732
R2266 VSS.n847 VSS.n570 8.47732
R2267 VSS.n569 VSS.n34 8.47732
R2268 VSS.t336 VSS.n36 8.47732
R2269 VSS.n848 VSS.n37 8.47732
R2270 VSS.n849 VSS.n530 8.47732
R2271 VSS.n661 VSS.n75 8.47732
R2272 VSS.n653 VSS.n75 8.47732
R2273 VSS.n8 VSS.n593 8.47732
R2274 VSS.n8 VSS.n595 8.47732
R2275 VSS.n8 VSS.n597 8.47732
R2276 VSS.n8 VSS.n603 8.47732
R2277 VSS.n8 VSS.n616 8.47732
R2278 VSS.n8 VSS.n605 8.47732
R2279 VSS.n12 VSS.n552 8.47732
R2280 VSS.n822 VSS.n770 8.47732
R2281 VSS.n783 VSS.n14 8.47732
R2282 VSS.n788 VSS.n17 8.47732
R2283 VSS.n789 VSS.n18 8.47732
R2284 VSS.n790 VSS.n19 8.47732
R2285 VSS.n712 VSS.n65 8.47111
R2286 VSS.t237 VSS.n68 8.47111
R2287 VSS.n687 VSS.n72 8.47111
R2288 VSS.t196 VSS.n73 8.47111
R2289 VSS.n834 VSS.n833 6.85916
R2290 VSS.n711 VSS.n527 5.66985
R2291 VSS.n43 VSS.n799 0.00229996
R2292 VSS.n45 VSS.n798 0.00229996
R2293 VSS.n54 VSS.n51 0.00229996
R2294 VSS.n57 VSS.n52 0.00229996
R2295 VSS.n813 VSS.n796 5.66778
R2296 VSS.n59 VSS.n793 0.00264986
R2297 VSS.n851 VSS.n529 5.66778
R2298 VSS.n851 VSS.n21 1.54575
R2299 VSS.n851 VSS.n528 5.66778
R2300 VSS.n80 VSS.n660 0.00229996
R2301 VSS.n82 VSS.n659 0.00229996
R2302 VSS.n84 VSS.n658 0.00229996
R2303 VSS.n675 VSS.n644 5.66778
R2304 VSS.n675 VSS.n643 5.66778
R2305 VSS.n86 VSS.n655 0.00249991
R2306 VSS.n675 VSS.n642 5.66778
R2307 VSS.n824 VSS.n16 1.54575
R2308 VSS.n38 VSS.t247 5.66778
R2309 VSS.n824 VSS.n13 1.88985
R2310 VSS.n61 VSS.n60 0.00139998
R2311 VSS.n66 VSS.n68 0.00137142
R2312 VSS.n92 VSS.n312 5.63915
R2313 VSS.n664 VSS.n660 5.62674
R2314 VSS.n666 VSS.n659 5.62674
R2315 VSS.n668 VSS.n658 5.62674
R2316 VSS.n670 VSS.n657 5.62674
R2317 VSS.n671 VSS.n656 5.62674
R2318 VSS.n672 VSS.n655 5.62674
R2319 VSS.n645 VSS.n654 5.62674
R2320 VSS.n580 VSS.n39 5.62581
R2321 VSS.n807 VSS.n799 5.62581
R2322 VSS.n809 VSS.n798 5.62581
R2323 VSS.n814 VSS.n51 5.62581
R2324 VSS.t327 VSS.n52 5.62581
R2325 VSS.n816 VSS.n55 5.62581
R2326 VSS.n817 VSS.n793 5.62581
R2327 VSS.t329 VSS.n839 5.62581
R2328 VSS.n571 VSS.n844 5.62581
R2329 VSS.n8 VSS.n602 5.62581
R2330 VSS.n10 VSS.n9 3.33986
R2331 VSS.n822 VSS.n791 5.62252
R2332 VSS.n567 VSS.t107 5.48496
R2333 VSS.n714 VSS.n713 5.13648
R2334 VSS.n631 VSS.t512 4.98596
R2335 VSS.n830 VSS.n829 4.63796
R2336 VSS.n703 VSS.t311 4.49152
R2337 VSS.n70 VSS.t91 4.49152
R2338 VSS.t420 VSS.n714 4.4712
R2339 VSS.n851 VSS.n850 4.251
R2340 VSS.n8 VSS.n598 4.19238
R2341 VSS.n872 VSS.t70 4.19225
R2342 VSS.n881 VSS.t59 4.19225
R2343 VSS.n890 VSS.t48 4.19225
R2344 VSS.t37 VSS.n243 4.19225
R2345 VSS.n905 VSS.t26 4.19225
R2346 VSS.t15 VSS.n212 4.19225
R2347 VSS.n822 VSS.n777 4.19225
R2348 VSS.n12 VSS.n545 4.19225
R2349 VSS.t339 VSS.n651 4.177
R2350 VSS.n524 VSS.n186 3.84219
R2351 VSS.n915 VSS.t297 3.84041
R2352 VSS.n516 VSS.t529 3.34498
R2353 VSS.n513 VSS.t563 3.34498
R2354 VSS.n510 VSS.t526 3.34498
R2355 VSS.n508 VSS.t565 3.34498
R2356 VSS.n505 VSS.t564 3.34498
R2357 VSS.n503 VSS.t522 3.34498
R2358 VSS.n500 VSS.t519 3.34498
R2359 VSS.n498 VSS.t566 3.34498
R2360 VSS.n495 VSS.t569 3.34498
R2361 VSS.n493 VSS.t568 3.34498
R2362 VSS.n490 VSS.t571 3.34498
R2363 VSS.n488 VSS.t567 3.34498
R2364 VSS.n485 VSS.t570 3.34498
R2365 VSS.n483 VSS.t572 3.34498
R2366 VSS.n480 VSS.t525 3.34498
R2367 VSS.n478 VSS.t574 3.34498
R2368 VSS.n475 VSS.t523 3.34498
R2369 VSS.n473 VSS.t578 3.34498
R2370 VSS.n470 VSS.t575 3.34498
R2371 VSS.n468 VSS.t520 3.34498
R2372 VSS.n465 VSS.t573 3.34498
R2373 VSS.n463 VSS.t521 3.34498
R2374 VSS.n460 VSS.t577 3.34498
R2375 VSS.n458 VSS.t576 3.34498
R2376 VSS.n455 VSS.t579 3.34498
R2377 VSS.n453 VSS.t524 3.34498
R2378 VSS.n450 VSS.t518 3.34498
R2379 VSS.n448 VSS.t583 3.34498
R2380 VSS.n445 VSS.t582 3.34498
R2381 VSS.n443 VSS.t581 3.34498
R2382 VSS.n440 VSS.t580 3.34498
R2383 VSS.n438 VSS.t584 3.34498
R2384 VSS.n8 VSS.n590 3.32697
R2385 VSS.n837 VSS.n39 3.3265
R2386 VSS.n8 VSS.n594 3.32615
R2387 VSS.t123 VSS.t90 3.30696
R2388 VSS.n865 VSS.t491 3.28366
R2389 VSS.n823 VSS.n822 2.77448
R2390 VSS.n830 VSS.n585 2.7456
R2391 VSS.n92 VSS.n350 2.74463
R2392 VSS.n92 VSS.n432 2.7443
R2393 VSS.n92 VSS.t154 2.74402
R2394 VSS.n92 VSS.n515 2.74397
R2395 VSS.n92 VSS.n346 2.74397
R2396 VSS.n8 VSS.n610 2.74397
R2397 VSS.n12 VSS.n531 2.46343
R2398 VSS.n12 VSS.n566 2.46343
R2399 VSS.n12 VSS.n534 2.46343
R2400 VSS.n12 VSS.n565 2.46343
R2401 VSS.n12 VSS.n536 2.46343
R2402 VSS.n12 VSS.n537 2.46343
R2403 VSS.n12 VSS.n562 2.46343
R2404 VSS.n12 VSS.n559 2.46343
R2405 VSS.n12 VSS.n558 2.46343
R2406 VSS.n12 VSS.n540 2.46343
R2407 VSS.n12 VSS.n555 2.46343
R2408 VSS.n12 VSS.n553 2.46343
R2409 VSS.n822 VSS.n724 2.46343
R2410 VSS.n822 VSS.n726 2.46343
R2411 VSS.n822 VSS.n728 2.46343
R2412 VSS.n822 VSS.n732 2.46343
R2413 VSS.n822 VSS.n734 2.46343
R2414 VSS.n822 VSS.n736 2.46343
R2415 VSS.n822 VSS.n738 2.46343
R2416 VSS.n822 VSS.n742 2.46343
R2417 VSS.n822 VSS.n744 2.46343
R2418 VSS.n822 VSS.n746 2.46343
R2419 VSS.n822 VSS.n748 2.46343
R2420 VSS.n822 VSS.n752 2.46343
R2421 VSS.n822 VSS.n758 2.46343
R2422 VSS.n822 VSS.n760 2.46343
R2423 VSS.n822 VSS.n762 2.46343
R2424 VSS.n822 VSS.n764 2.46343
R2425 VSS.n822 VSS.n773 2.46343
R2426 VSS.n822 VSS.n776 2.46343
R2427 VSS.n12 VSS.n544 2.46343
R2428 VSS.n12 VSS.n547 2.46343
R2429 VSS.n302 VSS.n301 2.34876
R2430 VSS.n288 VSS.n287 2.34876
R2431 VSS.n274 VSS.n273 2.34876
R2432 VSS.n250 VSS.n249 2.34876
R2433 VSS.n234 VSS.n233 2.34876
R2434 VSS.n219 VSS.n218 2.34876
R2435 VSS.n12 VSS.n541 2.32483
R2436 VSS.n822 VSS.n767 2.32439
R2437 VSS.n12 VSS.n561 2.00687
R2438 VSS.n822 VSS.n753 2.00642
R2439 VSS.t90 VSS.n636 1.97699
R2440 VSS.t93 VSS.n629 1.88189
R2441 VSS.n651 VSS.n641 1.88189
R2442 VSS.n831 VSS.n830 1.83435
R2443 VSS.t177 VSS.n711 1.80539
R2444 VSS.n805 VSS.n39 1.75689
R2445 VSS.n582 VSS.n39 1.75689
R2446 VSS.n8 VSS.n621 1.75507
R2447 VSS.n688 VSS.t351 1.72297
R2448 VSS.n785 VSS.n784 1.66925
R2449 VSS.n92 VSS.n523 1.63922
R2450 VSS.n92 VSS.n854 1.63922
R2451 VSS.n92 VSS.n859 1.63922
R2452 VSS.n92 VSS.n861 1.63922
R2453 VSS.n92 VSS.n863 1.63922
R2454 VSS.n92 VSS.n354 1.55386
R2455 VSS.n92 VSS.n359 1.55386
R2456 VSS.n92 VSS.n364 1.55386
R2457 VSS.n92 VSS.n369 1.55386
R2458 VSS.n92 VSS.n374 1.55386
R2459 VSS.n92 VSS.n379 1.55386
R2460 VSS.n92 VSS.n384 1.55386
R2461 VSS.n92 VSS.n389 1.55386
R2462 VSS.n92 VSS.n394 1.55386
R2463 VSS.n92 VSS.n399 1.55386
R2464 VSS.n92 VSS.n404 1.55386
R2465 VSS.n92 VSS.n409 1.55386
R2466 VSS.n92 VSS.n414 1.55386
R2467 VSS.n92 VSS.n419 1.55386
R2468 VSS.n92 VSS.n424 1.55386
R2469 VSS.n92 VSS.n429 1.55386
R2470 VSS.n92 VSS.t127 1.55345
R2471 VSS.n92 VSS.t307 1.55345
R2472 VSS.n92 VSS.t138 1.55345
R2473 VSS.n92 VSS.t179 1.55345
R2474 VSS.n92 VSS.t293 1.55345
R2475 VSS.n92 VSS.t12 1.55345
R2476 VSS.n92 VSS.t375 1.55345
R2477 VSS.n92 VSS.t203 1.55345
R2478 VSS.n92 VSS.t144 1.55345
R2479 VSS.n92 VSS.t217 1.55345
R2480 VSS.n92 VSS.t114 1.55345
R2481 VSS.n92 VSS.t136 1.55345
R2482 VSS.n92 VSS.t344 1.55345
R2483 VSS.n92 VSS.t206 1.55345
R2484 VSS.n92 VSS.t99 1.55345
R2485 VSS.n92 VSS.n315 1.55338
R2486 VSS.n92 VSS.n316 1.55338
R2487 VSS.n92 VSS.n317 1.55338
R2488 VSS.n92 VSS.n318 1.55338
R2489 VSS.n92 VSS.n319 1.55338
R2490 VSS.n92 VSS.n320 1.55338
R2491 VSS.n92 VSS.n321 1.55338
R2492 VSS.n92 VSS.n322 1.55338
R2493 VSS.n92 VSS.n323 1.55338
R2494 VSS.n92 VSS.n324 1.55338
R2495 VSS.n92 VSS.n325 1.55338
R2496 VSS.n92 VSS.n326 1.55338
R2497 VSS.n92 VSS.n327 1.55338
R2498 VSS.n92 VSS.n328 1.55338
R2499 VSS.n92 VSS.n329 1.55338
R2500 VSS.n92 VSS.n330 1.55338
R2501 VSS.n92 VSS.n331 1.55338
R2502 VSS.n92 VSS.n332 1.55338
R2503 VSS.n92 VSS.n333 1.55338
R2504 VSS.n92 VSS.n334 1.55338
R2505 VSS.n92 VSS.n335 1.55338
R2506 VSS.n92 VSS.n336 1.55338
R2507 VSS.n92 VSS.n337 1.55338
R2508 VSS.n92 VSS.n338 1.55338
R2509 VSS.n92 VSS.n339 1.55338
R2510 VSS.n92 VSS.n340 1.55338
R2511 VSS.n92 VSS.n341 1.55338
R2512 VSS.n92 VSS.n342 1.55338
R2513 VSS.n92 VSS.n343 1.55338
R2514 VSS.n92 VSS.n344 1.55338
R2515 VSS.n92 VSS.n345 1.55338
R2516 VSS.n646 VSS.n75 1.55041
R2517 VSS.t437 VSS.n778 1.43372
R2518 VSS.t435 VSS.n779 1.43372
R2519 VSS.t437 VSS.n781 1.42949
R2520 VSS.t435 VSS.n780 1.42949
R2521 VSS.t170 VSS.t174 1.41892
R2522 VSS.t168 VSS.t172 1.41892
R2523 VSS.t166 VSS.t173 1.41892
R2524 VSS.t164 VSS.t171 1.41892
R2525 VSS.n914 VSS.n209 1.38589
R2526 VSS.n579 VSS.t432 1.37661
R2527 VSS.t432 VSS.n802 1.37661
R2528 VSS.n832 VSS.n831 1.30942
R2529 VSS.t362 VSS.n251 1.28795
R2530 VSS.n836 VSS.n832 1.26857
R2531 VSS.t562 VSS.t560 1.25698
R2532 VSS.t546 VSS.t544 1.24892
R2533 VSS.n649 VSS.n75 1.24506
R2534 VSS.t146 VSS.t300 1.23805
R2535 VSS.t123 VSS.n637 1.21874
R2536 VSS.t536 VSS.t534 1.1832
R2537 VSS.t550 VSS.t552 1.18293
R2538 VSS.t554 VSS.t552 1.17925
R2539 VSS.t538 VSS.t536 1.17908
R2540 VSS.t548 VSS.t547 1.1778
R2541 VSS.t531 VSS.t532 1.17752
R2542 VSS.t542 VSS.t540 1.17381
R2543 VSS.t558 VSS.t556 1.17364
R2544 VSS.t560 VSS.t558 1.16051
R2545 VSS.t544 VSS.t542 1.15299
R2546 VSS.n633 VSS.t339 1.12123
R2547 VSS.t556 VSS.t554 1.11316
R2548 VSS.t538 VSS.t540 1.1128
R2549 VSS.t550 VSS.t548 1.10881
R2550 VSS.t534 VSS.t531 1.10873
R2551 VSS.t93 VSS.n627 1.09664
R2552 VSS.n638 VSS.t310 1.08287
R2553 VSS.t43 VSS.n251 1.06717
R2554 VSS.n637 VSS.t237 1.0392
R2555 VSS.n188 VSS.t14 1.03359
R2556 VSS.n627 VSS.n628 1.02454
R2557 VSS.n525 VSS.t244 1.02109
R2558 VSS.n857 VSS.t380 1.00724
R2559 VSS.n188 VSS.t499 1.0064
R2560 VSS.n187 VSS.t297 0.971887
R2561 VSS.n11 VSS.n849 0.959044
R2562 VSS.t76 VSS.n303 0.950816
R2563 VSS.n821 VSS.n820 0.938421
R2564 VSS.n11 VSS.n568 0.908953
R2565 VSS.n633 VSS.t420 0.885254
R2566 VSS.n821 VSS.n792 0.873936
R2567 VSS.t47 VSS.n252 0.841394
R2568 VSS.n712 VSS.n638 0.839803
R2569 VSS.t353 VSS.n640 0.832423
R2570 VSS.t442 VSS.t445 0.806856
R2571 VSS.n613 VSS.t449 0.806855
R2572 VSS.t150 VSS.t455 0.806855
R2573 VSS.n611 VSS.t528 0.802775
R2574 VSS.t266 VSS.t200 0.802775
R2575 VSS.t224 VSS.t129 0.802775
R2576 VSS.t624 VSS.t131 0.802775
R2577 VSS.t221 VSS.t356 0.802775
R2578 VSS.t96 VSS.t280 0.802775
R2579 VSS.t259 VSS.t83 0.802775
R2580 VSS.t620 VSS.t187 0.802775
R2581 VSS.t189 VSS.t181 0.802775
R2582 VSS.t411 VSS.t183 0.802775
R2583 VSS.t185 VSS.t160 0.802775
R2584 VSS.t414 VSS.t264 0.802775
R2585 VSS.t324 VSS.t228 0.802775
R2586 VSS.t606 VSS.t116 0.802775
R2587 VSS.t118 VSS.t373 0.802775
R2588 VSS.t3 VSS.t371 0.802775
R2589 VSS.t481 VSS.t268 0.802775
R2590 VSS.t366 VSS.t478 0.802775
R2591 VSS.t80 VSS.t121 0.802775
R2592 VSS.t617 VSS.t103 0.802775
R2593 VSS.t105 VSS.t215 0.802775
R2594 VSS.t402 VSS.t191 0.802775
R2595 VSS.t239 VSS.t112 0.802775
R2596 VSS.t395 VSS.t511 0.802775
R2597 VSS.t302 VSS.t157 0.802775
R2598 VSS.t609 VSS.t261 0.802775
R2599 VSS.t235 VSS.t256 0.802775
R2600 VSS.t6 VSS.t208 0.802775
R2601 VSS.t251 VSS.t360 0.802775
R2602 VSS.t211 VSS.t141 0.802775
R2603 VSS.t242 VSS.t101 0.802775
R2604 VSS.t318 VSS.t193 0.802775
R2605 VSS.t195 VSS.t585 0.802775
R2606 VSS.t9 VSS.t464 0.802775
R2607 VSS.t69 VSS.n289 0.78864
R2608 VSS.t58 VSS.n275 0.78864
R2609 VSS.t36 VSS.n235 0.78864
R2610 VSS.t25 VSS.n220 0.78864
R2611 VSS.n638 VSS.t177 0.756052
R2612 VSS.t353 VSS.t351 0.745166
R2613 VSS.t93 VSS.n633 0.728354
R2614 VSS.t65 VSS.n289 0.724795
R2615 VSS.t54 VSS.n275 0.724795
R2616 VSS.t32 VSS.n235 0.724795
R2617 VSS.t21 VSS.n220 0.724795
R2618 VSS.t465 VSS.t467 0.723599
R2619 VSS.t463 VSS.n311 0.723599
R2620 VSS.n769 VSS.t170 0.722582
R2621 VSS.n766 VSS.t168 0.722582
R2622 VSS.n755 VSS.t166 0.722582
R2623 VSS.n792 VSS.t164 0.722582
R2624 VSS.t174 VSS.n768 0.72222
R2625 VSS.t172 VSS.n765 0.72222
R2626 VSS.t173 VSS.n754 0.72222
R2627 VSS.t171 VSS.n568 0.72222
R2628 VSS.n640 VSS.n652 0.711165
R2629 VSS.t420 VSS.n627 0.699997
R2630 VSS.n252 VSS.t362 0.699882
R2631 VSS.n648 VSS.n647 0.6955
R2632 VSS.n637 VSS.n67 0.662806
R2633 VSS.t196 VSS.t351 0.640524
R2634 VSS.n875 VSS.n289 0.62049
R2635 VSS.n884 VSS.n275 0.62049
R2636 VSS.n899 VSS.n235 0.62049
R2637 VSS.n908 VSS.n220 0.62049
R2638 VSS.n866 VSS.n309 0.613782
R2639 VSS.n875 VSS.n295 0.613782
R2640 VSS.n884 VSS.n281 0.613782
R2641 VSS.n893 VSS.n267 0.613782
R2642 VSS.n893 VSS.n262 0.613782
R2643 VSS.n899 VSS.n240 0.613782
R2644 VSS.n908 VSS.n227 0.613782
R2645 VSS.n914 VSS.n192 0.613782
R2646 VSS.n914 VSS.n194 0.613782
R2647 VSS.n914 VSS.n205 0.613782
R2648 VSS.n914 VSS.n200 0.613782
R2649 VSS.n914 VSS.n201 0.613782
R2650 VSS.n640 VSS.n75 0.599773
R2651 VSS.t454 VSS.n617 0.595317
R2652 VSS.t451 VSS.n618 0.595317
R2653 VSS.t448 VSS.n606 0.595317
R2654 VSS.t444 VSS.n607 0.595317
R2655 VSS.t460 VSS.n517 0.595317
R2656 VSS.t457 VSS.n518 0.595317
R2657 VSS.n687 VSS.n636 0.588545
R2658 VSS.n708 VSS.t310 0.572871
R2659 VSS.n694 VSS.t90 0.572871
R2660 VSS.n92 VSS.n96 0.1979
R2661 VSS.n652 VSS.n649 0.56503
R2662 VSS.t93 VSS.n632 0.557126
R2663 VSS.n92 VSS.n94 0.556705
R2664 VSS.n822 VSS.n821 0.55447
R2665 VSS.n893 VSS.n252 0.554008
R2666 VSS.t499 VSS.n209 0.539958
R2667 VSS.n622 VSS.n621 0.52186
R2668 VSS.n12 VSS.n11 0.51356
R2669 VSS.t437 VSS.t435 0.492336
R2670 VSS.n702 VSS.n67 0.490843
R2671 VSS.n698 VSS.n67 0.490843
R2672 VSS.n696 VSS.n67 0.490843
R2673 VSS.n688 VSS.n685 0.490843
R2674 VSS.n705 VSS.t310 0.489061
R2675 VSS.n691 VSS.t90 0.489061
R2676 VSS.t200 VSS.n345 0.477689
R2677 VSS.t129 VSS.n344 0.477689
R2678 VSS.t131 VSS.n343 0.477689
R2679 VSS.t356 VSS.n342 0.477689
R2680 VSS.t280 VSS.n341 0.477689
R2681 VSS.t83 VSS.n340 0.477689
R2682 VSS.t187 VSS.n339 0.477689
R2683 VSS.t181 VSS.n338 0.477689
R2684 VSS.t183 VSS.n337 0.477689
R2685 VSS.t160 VSS.n336 0.477689
R2686 VSS.t264 VSS.n335 0.477689
R2687 VSS.t228 VSS.n334 0.477689
R2688 VSS.t116 VSS.n333 0.477689
R2689 VSS.t373 VSS.n332 0.477689
R2690 VSS.t371 VSS.n331 0.477689
R2691 VSS.t268 VSS.n330 0.477689
R2692 VSS.t478 VSS.n329 0.477689
R2693 VSS.t121 VSS.n328 0.477689
R2694 VSS.t103 VSS.n327 0.477689
R2695 VSS.t215 VSS.n326 0.477689
R2696 VSS.t191 VSS.n325 0.477689
R2697 VSS.t112 VSS.n324 0.477689
R2698 VSS.t511 VSS.n323 0.477689
R2699 VSS.t157 VSS.n322 0.477689
R2700 VSS.t261 VSS.n321 0.477689
R2701 VSS.t256 VSS.n320 0.477689
R2702 VSS.t208 VSS.n319 0.477689
R2703 VSS.t360 VSS.n318 0.477689
R2704 VSS.t141 VSS.n317 0.477689
R2705 VSS.t101 VSS.n316 0.477689
R2706 VSS.t193 VSS.n315 0.477689
R2707 VSS.n646 VSS.n585 0.47741
R2708 VSS.t93 VSS.n716 0.477286
R2709 VSS.t93 VSS.n717 0.472981
R2710 VSS.t99 VSS.t242 0.466542
R2711 VSS.t206 VSS.t251 0.466542
R2712 VSS.t344 VSS.t235 0.466542
R2713 VSS.t136 VSS.t302 0.466542
R2714 VSS.t114 VSS.t239 0.466542
R2715 VSS.t217 VSS.t105 0.466542
R2716 VSS.t144 VSS.t80 0.466542
R2717 VSS.t203 VSS.t481 0.466542
R2718 VSS.t375 VSS.t118 0.466542
R2719 VSS.t12 VSS.t324 0.466542
R2720 VSS.t293 VSS.t185 0.466542
R2721 VSS.t179 VSS.t189 0.466542
R2722 VSS.t138 VSS.t259 0.466542
R2723 VSS.t307 VSS.t221 0.466542
R2724 VSS.t127 VSS.t224 0.466542
R2725 VSS.n354 VSS.t266 0.466192
R2726 VSS.n359 VSS.t624 0.466192
R2727 VSS.n364 VSS.t96 0.466192
R2728 VSS.n369 VSS.t620 0.466192
R2729 VSS.n374 VSS.t411 0.466192
R2730 VSS.n379 VSS.t414 0.466192
R2731 VSS.n384 VSS.t606 0.466192
R2732 VSS.n389 VSS.t3 0.466192
R2733 VSS.n394 VSS.t366 0.466192
R2734 VSS.n399 VSS.t617 0.466192
R2735 VSS.n404 VSS.t402 0.466192
R2736 VSS.n409 VSS.t395 0.466192
R2737 VSS.n414 VSS.t609 0.466192
R2738 VSS.n419 VSS.t6 0.466192
R2739 VSS.n424 VSS.t211 0.466192
R2740 VSS.n429 VSS.t318 0.466192
R2741 VSS.n713 VSS.n636 0.465582
R2742 VSS.n652 VSS.t339 0.464894
R2743 VSS.n648 VSS.n646 0.460744
R2744 VSS.n649 VSS.n648 0.455207
R2745 VSS.t195 VSS.n429 0.451785
R2746 VSS.t242 VSS.n424 0.451785
R2747 VSS.t251 VSS.n419 0.451785
R2748 VSS.t235 VSS.n414 0.451785
R2749 VSS.t302 VSS.n409 0.451785
R2750 VSS.t239 VSS.n404 0.451785
R2751 VSS.t105 VSS.n399 0.451785
R2752 VSS.t80 VSS.n394 0.451785
R2753 VSS.t481 VSS.n389 0.451785
R2754 VSS.t118 VSS.n384 0.451785
R2755 VSS.t324 VSS.n379 0.451785
R2756 VSS.t185 VSS.n374 0.451785
R2757 VSS.t189 VSS.n369 0.451785
R2758 VSS.t259 VSS.n364 0.451785
R2759 VSS.t221 VSS.n359 0.451785
R2760 VSS.t224 VSS.n354 0.451785
R2761 VSS.t127 VSS.t624 0.451337
R2762 VSS.t307 VSS.t96 0.451337
R2763 VSS.t138 VSS.t620 0.451337
R2764 VSS.t179 VSS.t411 0.451337
R2765 VSS.t293 VSS.t414 0.451337
R2766 VSS.t12 VSS.t606 0.451337
R2767 VSS.t375 VSS.t3 0.451337
R2768 VSS.t203 VSS.t366 0.451337
R2769 VSS.t144 VSS.t617 0.451337
R2770 VSS.t217 VSS.t402 0.451337
R2771 VSS.t114 VSS.t395 0.451337
R2772 VSS.t136 VSS.t609 0.451337
R2773 VSS.t344 VSS.t6 0.451337
R2774 VSS.t206 VSS.t211 0.451337
R2775 VSS.t99 VSS.t318 0.451337
R2776 VSS.n621 VSS.n620 0.447348
R2777 VSS.n915 VSS.n186 0.44402
R2778 VSS.t131 VSS.n344 0.440228
R2779 VSS.t280 VSS.n342 0.440228
R2780 VSS.t183 VSS.n338 0.440228
R2781 VSS.t160 VSS.n337 0.440228
R2782 VSS.t478 VSS.n330 0.440228
R2783 VSS.t121 VSS.n329 0.440228
R2784 VSS.t103 VSS.n328 0.440228
R2785 VSS.t215 VSS.n327 0.440228
R2786 VSS.t208 VSS.n320 0.440228
R2787 VSS.n315 VSS.t585 0.440228
R2788 VSS.n316 VSS.t193 0.440228
R2789 VSS.n317 VSS.t101 0.440228
R2790 VSS.n318 VSS.t141 0.440228
R2791 VSS.n319 VSS.t360 0.440228
R2792 VSS.n321 VSS.t256 0.440228
R2793 VSS.n322 VSS.t261 0.440228
R2794 VSS.n323 VSS.t157 0.440228
R2795 VSS.n324 VSS.t511 0.440228
R2796 VSS.n325 VSS.t112 0.440228
R2797 VSS.n326 VSS.t191 0.440228
R2798 VSS.n331 VSS.t268 0.440228
R2799 VSS.n332 VSS.t371 0.440228
R2800 VSS.n333 VSS.t373 0.440228
R2801 VSS.n334 VSS.t116 0.440228
R2802 VSS.n335 VSS.t228 0.440228
R2803 VSS.n336 VSS.t264 0.440228
R2804 VSS.n339 VSS.t181 0.440228
R2805 VSS.n340 VSS.t187 0.440228
R2806 VSS.n341 VSS.t83 0.440228
R2807 VSS.n343 VSS.t356 0.440228
R2808 VSS.n345 VSS.t129 0.440228
R2809 VSS.n838 VSS.n582 0.418268
R2810 VSS.n805 VSS.n804 0.418268
R2811 VSS.n804 VSS.n582 0.414988
R2812 VSS.n806 VSS.n805 0.414988
R2813 VSS.n714 VSS.n586 0.41014
R2814 VSS.t213 VSS.n63 0.400619
R2815 VSS.n768 VSS.n541 0.376066
R2816 VSS.n769 VSS.n767 0.374405
R2817 VSS.n8 VSS.n5 0.351198
R2818 VSS.n792 VSS.n753 0.340151
R2819 VSS.n754 VSS.n561 0.338265
R2820 VSS.n568 VSS.n561 0.338019
R2821 VSS.n755 VSS.n753 0.336071
R2822 VSS.n833 VSS.n350 0.329994
R2823 VSS.n610 VSS.n609 0.312321
R2824 VSS.n835 VSS.n834 0.31114
R2825 VSS.n767 VSS.n766 0.307952
R2826 VSS.t19 VSS.n219 0.306378
R2827 VSS.t30 VSS.n234 0.306378
R2828 VSS.t41 VSS.n250 0.306378
R2829 VSS.t52 VSS.n274 0.306378
R2830 VSS.t63 VSS.n288 0.306378
R2831 VSS.t74 VSS.n302 0.306378
R2832 VSS.n765 VSS.n541 0.306341
R2833 VSS.t585 VSS.t154 0.302153
R2834 VSS.n713 VSS.t123 0.298621
R2835 VSS.n187 VSS.n914 0.295237
R2836 VSS.n590 VSS.n587 0.291601
R2837 VSS.n432 VSS.t195 0.290734
R2838 VSS.n784 VSS.n590 0.287886
R2839 VSS.t329 VSS.n580 0.286777
R2840 VSS.n817 VSS.n816 0.286439
R2841 VSS.n866 VSS.n303 0.282782
R2842 VSS.n671 VSS.n670 0.280152
R2843 VSS.n672 VSS.n671 0.280152
R2844 VSS.t528 VSS.n594 0.2761
R2845 VSS.n515 VSS.t266 0.275961
R2846 VSS.n914 VSS.n188 0.275933
R2847 VSS.n517 VSS.n346 0.272321
R2848 VSS.n520 VSS.n515 0.272065
R2849 VSS.n92 VSS.n128 0.267794
R2850 VSS.n92 VSS.n130 0.267794
R2851 VSS.n92 VSS.n131 0.267794
R2852 VSS.n92 VSS.n132 0.267794
R2853 VSS.n92 VSS.n133 0.267794
R2854 VSS.n92 VSS.n179 0.267794
R2855 VSS.n92 VSS.n135 0.267794
R2856 VSS.n92 VSS.n136 0.267794
R2857 VSS.n92 VSS.n137 0.267794
R2858 VSS.n92 VSS.n138 0.267794
R2859 VSS.n92 VSS.n178 0.267794
R2860 VSS.n92 VSS.n140 0.267794
R2861 VSS.n92 VSS.n177 0.267794
R2862 VSS.n92 VSS.n142 0.267794
R2863 VSS.n92 VSS.n143 0.267794
R2864 VSS.n92 VSS.n176 0.267794
R2865 VSS.n92 VSS.n144 0.267794
R2866 VSS.n92 VSS.n145 0.267794
R2867 VSS.n92 VSS.n174 0.267794
R2868 VSS.n92 VSS.n146 0.267794
R2869 VSS.n92 VSS.n173 0.267794
R2870 VSS.n92 VSS.n147 0.267794
R2871 VSS.n92 VSS.n172 0.267794
R2872 VSS.n92 VSS.n148 0.267794
R2873 VSS.n92 VSS.n149 0.267794
R2874 VSS.n92 VSS.n150 0.267794
R2875 VSS.n92 VSS.n171 0.267794
R2876 VSS.n92 VSS.n170 0.267794
R2877 VSS.n92 VSS.n152 0.267794
R2878 VSS.n92 VSS.n153 0.267794
R2879 VSS.n92 VSS.n169 0.267794
R2880 VSS.n92 VSS.n154 0.267794
R2881 VSS.n92 VSS.n156 0.267794
R2882 VSS.n92 VSS.n157 0.267794
R2883 VSS.n92 VSS.n158 0.267794
R2884 VSS.n92 VSS.n159 0.267794
R2885 VSS.n92 VSS.n161 0.267794
R2886 VSS.n92 VSS.n168 0.267794
R2887 VSS.n92 VSS.n167 0.267794
R2888 VSS.n92 VSS.n166 0.267794
R2889 VSS.n92 VSS.n162 0.267794
R2890 VSS.n92 VSS.n97 0.267794
R2891 VSS.n92 VSS.n99 0.267794
R2892 VSS.n92 VSS.n100 0.267794
R2893 VSS.n92 VSS.n102 0.267794
R2894 VSS.n92 VSS.n103 0.267794
R2895 VSS.n92 VSS.n105 0.267794
R2896 VSS.n92 VSS.n106 0.267794
R2897 VSS.n92 VSS.n107 0.267794
R2898 VSS.n92 VSS.n108 0.267794
R2899 VSS.n92 VSS.n109 0.267794
R2900 VSS.n92 VSS.n111 0.267794
R2901 VSS.n92 VSS.n113 0.267794
R2902 VSS.n92 VSS.n115 0.267794
R2903 VSS.n92 VSS.n117 0.267794
R2904 VSS.n92 VSS.n118 0.267794
R2905 VSS.n92 VSS.n119 0.267794
R2906 VSS.n92 VSS.n120 0.267794
R2907 VSS.n92 VSS.n121 0.267794
R2908 VSS.n92 VSS.n122 0.267794
R2909 VSS.n92 VSS.n123 0.267794
R2910 VSS.n92 VSS.n124 0.267794
R2911 VSS.n92 VSS.n126 0.267794
R2912 VSS.n92 VSS.n127 0.267794
R2913 VSS.n92 VSS.n164 0.267428
R2914 VSS.n606 VSS.n594 0.266107
R2915 VSS.n838 VSS.n837 0.265497
R2916 VSS.t200 VSS.n346 0.264468
R2917 VSS.n837 VSS.n836 0.264227
R2918 VSS.n209 VSS.t300 0.263148
R2919 VSS.n219 VSS.t21 0.255324
R2920 VSS.n234 VSS.t32 0.255324
R2921 VSS.n250 VSS.t43 0.255324
R2922 VSS.n274 VSS.t54 0.255324
R2923 VSS.n288 VSS.t65 0.255324
R2924 VSS.n302 VSS.t76 0.255324
R2925 VSS.t154 VSS.t464 0.254653
R2926 VSS.n92 VSS.n525 0.253543
R2927 VSS.t9 VSS.n432 0.24355
R2928 VSS.t237 VSS.n712 0.241078
R2929 VSS.t196 VSS.n687 0.241078
R2930 VSS.n857 VSS.n350 0.24011
R2931 VSS.n571 VSS.n843 0.239006
R2932 VSS.n808 VSS.n807 0.239006
R2933 VSS.n810 VSS.n809 0.239006
R2934 VSS.n794 VSS.n814 0.239006
R2935 VSS.n815 VSS.t327 0.239006
R2936 VSS.n818 VSS.n817 0.239006
R2937 VSS.n807 VSS.n800 0.238668
R2938 VSS.n809 VSS.n808 0.238668
R2939 VSS.n814 VSS.t326 0.238668
R2940 VSS.n816 VSS.n815 0.238668
R2941 VSS.t327 VSS.n794 0.238668
R2942 VSS.n578 VSS.t329 0.238668
R2943 VSS.t334 VSS.n571 0.238668
R2944 VSS.n611 VSS.n610 0.238218
R2945 VSS.n665 VSS.n664 0.233757
R2946 VSS.n667 VSS.n666 0.233757
R2947 VSS.n669 VSS.n668 0.233757
R2948 VSS.n673 VSS.n672 0.233757
R2949 VSS.t546 VSS.n645 0.233757
R2950 VSS.n664 VSS.n663 0.233419
R2951 VSS.n666 VSS.n665 0.233419
R2952 VSS.n668 VSS.n667 0.233419
R2953 VSS.n670 VSS.n669 0.233419
R2954 VSS.n645 VSS.n674 0.233419
R2955 VSS.n600 VSS.n598 0.225543
R2956 VSS.t15 VSS.t17 0.224424
R2957 VSS.t37 VSS.t39 0.224424
R2958 VSS.t70 VSS.t72 0.224424
R2959 VSS.t59 VSS.t61 0.224424
R2960 VSS.t48 VSS.t50 0.224424
R2961 VSS.t26 VSS.t28 0.224424
R2962 VSS.t14 VSS.t15 0.220674
R2963 VSS.t36 VSS.t37 0.220674
R2964 VSS.t70 VSS.t69 0.220674
R2965 VSS.t59 VSS.t58 0.220674
R2966 VSS.t48 VSS.t47 0.220674
R2967 VSS.t26 VSS.t25 0.220674
R2968 VSS.n617 VSS.n598 0.219552
R2969 VSS.t93 VSS.n721 0.211735
R2970 VSS.n829 VSS.n586 0.20686
R2971 VSS.n91 VSS.n312 0.20231
R2972 VSS.n622 VSS.n603 0.191235
R2973 VSS.n840 VSS.n578 0.191235
R2974 VSS.n577 VSS.n840 0.191235
R2975 VSS.n841 VSS.n576 0.191235
R2976 VSS.n573 VSS.n841 0.191235
R2977 VSS.t332 VSS.n573 0.191235
R2978 VSS.n842 VSS.t333 0.191235
R2979 VSS.n843 VSS.n842 0.191235
R2980 VSS.n846 VSS.t334 0.191235
R2981 VSS.n847 VSS.n846 0.191235
R2982 VSS.n569 VSS.n847 0.191235
R2983 VSS.n848 VSS.t336 0.191235
R2984 VSS.n849 VSS.n848 0.191235
R2985 VSS.t434 VSS.n801 0.191235
R2986 VSS.n811 VSS.n810 0.191235
R2987 VSS.n812 VSS.n811 0.191235
R2988 VSS.n812 VSS.n795 0.191235
R2989 VSS.n819 VSS.n818 0.191235
R2990 VSS.n820 VSS.n819 0.191235
R2991 VSS.n789 VSS.n788 0.191235
R2992 VSS.n790 VSS.n789 0.191235
R2993 VSS.n434 VSS.n91 0.191235
R2994 VSS.t336 VSS.n569 0.191235
R2995 VSS.n576 VSS.t330 0.191235
R2996 VSS.t330 VSS.n577 0.191235
R2997 VSS.n800 VSS.t434 0.191235
R2998 VSS.n795 VSS.t326 0.191235
R2999 VSS.t333 VSS.t332 0.191235
R3000 VSS.n786 VSS.n10 0.268071
R3001 VSS.t454 VSS.t451 0.1875
R3002 VSS.t448 VSS.t444 0.1875
R3003 VSS.t460 VSS.t457 0.1875
R3004 VSS.n662 VSS.t562 0.187025
R3005 VSS.n663 VSS.n662 0.187025
R3006 VSS.n674 VSS.n673 0.187025
R3007 VSS.n791 VSS.n778 0.185557
R3008 VSS.n779 VSS.n777 0.181924
R3009 VSS.n780 VSS.n545 0.181924
R3010 VSS.n804 VSS.t432 0.167615
R3011 VSS.n778 VSS.n777 0.164424
R3012 VSS.n781 VSS.n545 0.164424
R3013 VSS.n92 VSS.n182 0.160396
R3014 VSS.n92 VSS.n184 0.160396
R3015 VSS.n92 VSS.n185 0.160396
R3016 VSS.n580 VSS.n579 0.15955
R3017 VSS.n647 VSS.n602 0.156138
R3018 VSS.n835 VSS.n583 0.150687
R3019 VSS.t536 VSS.n75 0.149502
R3020 VSS.t552 VSS.n75 0.149428
R3021 VSS.n893 VSS.n251 0.144066
R3022 VSS.n788 VSS.n787 0.143368
R3023 VSS.n783 VSS.n551 0.143368
R3024 VSS.n435 VSS.n434 0.142513
R3025 VSS.t467 VSS.n312 0.139294
R3026 VSS.t556 VSS.n75 0.13875
R3027 VSS.t548 VSS.n75 0.138705
R3028 VSS.t531 VSS.n75 0.138693
R3029 VSS.t540 VSS.n75 0.138673
R3030 VSS.n834 VSS.n186 0.138073
R3031 VSS.t461 VSS.t9 0.135868
R3032 VSS.t464 VSS.n314 0.124618
R3033 VSS.t461 VSS.n311 0.122118
R3034 VSS.n314 VSS.t463 0.122118
R3035 VSS.n785 VSS.n783 0.120868
R3036 VSS.n782 VSS.t437 0.1171
R3037 VSS.n801 VSS.n802 0.112118
R3038 VSS.t544 VSS.n75 0.11127
R3039 VSS.t491 VSS.n303 0.109701
R3040 VSS.n435 VSS.t465 0.109642
R3041 VSS.n780 VSS.n552 0.104618
R3042 VSS.n779 VSS.n770 0.104618
R3043 VSS.t560 VSS.n75 0.103408
R3044 VSS.t449 VSS.n595 0.0971176
R3045 VSS.n647 VSS.n603 0.0971176
R3046 VSS.n602 VSS.n601 0.0958002
R3047 VSS.n601 VSS.n599 0.0955
R3048 VSS.n791 VSS.n628 0.0949351
R3049 VSS.n612 VSS.n611 0.093
R3050 VSS.t455 VSS.n349 0.08925
R3051 VSS.n522 VSS.t150 0.08925
R3052 VSS.t451 VSS.n619 0.0851154
R3053 VSS.n620 VSS.t454 0.0851154
R3054 VSS.t444 VSS.n608 0.0851154
R3055 VSS.n609 VSS.t448 0.0851154
R3056 VSS.t457 VSS.n519 0.0851154
R3057 VSS.n520 VSS.t460 0.0851154
R3058 VSS.n653 VSS.t353 0.0846176
R3059 VSS.n661 VSS.n585 0.0846176
R3060 VSS.n754 VSS.n557 0.08425
R3061 VSS.n756 VSS.n755 0.08425
R3062 VSS.n608 VSS.n3 0.08175
R3063 VSS.n619 VSS.n614 0.08175
R3064 VSS.n607 VSS.n592 0.08175
R3065 VSS.n618 VSS.n596 0.08175
R3066 VSS.n865 VSS.n864 0.0805
R3067 VSS.n550 VSS.n548 0.0805
R3068 VSS.n579 VSS.n581 0.0796176
R3069 VSS.n802 VSS.n803 0.0796176
R3070 VSS.t244 VSS.n524 0.078
R3071 VSS.t467 VSS.n313 0.0771176
R3072 VSS.n550 VSS.n549 0.07675
R3073 VSS.n581 VSS.n838 0.0758676
R3074 VSS.n803 VSS.n806 0.0758676
R3075 VSS.n519 VSS.n351 0.0746176
R3076 VSS.n518 VSS.n348 0.0746176
R3077 VSS.n831 VSS.n584 0.07425
R3078 VSS.n781 VSS.n548 0.07425
R3079 VSS.t445 VSS.n589 0.0740901
R3080 VSS.t442 VSS.n588 0.0740901
R3081 VSS.t247 VSS.n584 0.07175
R3082 VSS.t380 VSS.n525 0.0715239
R3083 VSS.t532 VSS.n653 0.0708676
R3084 VSS.t547 VSS.n661 0.0708676
R3085 VSS.t463 VSS.n313 0.0696176
R3086 VSS.n519 VSS.t152 0.06925
R3087 VSS.t19 VSS.n213 0.06925
R3088 VSS.t30 VSS.n232 0.06925
R3089 VSS.t41 VSS.n244 0.06925
R3090 VSS.t52 VSS.n272 0.06925
R3091 VSS.t63 VSS.n286 0.06925
R3092 VSS.t74 VSS.n300 0.06925
R3093 VSS.n765 VSS.n557 0.06925
R3094 VSS.n766 VSS.n756 0.06925
R3095 VSS.t247 VSS.n549 0.06925
R3096 VSS.n518 VSS.n347 0.06925
R3097 VSS.n609 VSS.n605 0.0671176
R3098 VSS.n620 VSS.n616 0.0671176
R3099 VSS.n606 VSS.n593 0.0671176
R3100 VSS.n617 VSS.n597 0.0671176
R3101 VSS.n608 VSS.n605 0.0621177
R3102 VSS.n619 VSS.n616 0.0621177
R3103 VSS.n607 VSS.n593 0.0621177
R3104 VSS.n618 VSS.n597 0.0621177
R3105 VSS.n517 VSS.n347 0.05925
R3106 VSS.n520 VSS.t152 0.05925
R3107 VSS.t528 VSS.n595 0.0571176
R3108 VSS.t150 VSS.n351 0.0546176
R3109 VSS.t455 VSS.n348 0.0546176
R3110 VSS.t17 VSS.n213 0.05175
R3111 VSS.n232 VSS.t28 0.05175
R3112 VSS.t39 VSS.n244 0.05175
R3113 VSS.n272 VSS.t50 0.05175
R3114 VSS.n286 VSS.t61 0.05175
R3115 VSS.n300 VSS.t72 0.05175
R3116 VSS.n628 VSS.n790 0.0508676
R3117 VSS.n768 VSS.n552 0.0496177
R3118 VSS.n770 VSS.n769 0.0496177
R3119 VSS.n613 VSS.n612 0.04925
R3120 VSS.n787 VSS.n782 0.04925
R3121 VSS.n551 VSS.n550 0.048
R3122 VSS.n614 VSS.n613 0.04675
R3123 VSS.t449 VSS.n596 0.04675
R3124 VSS.n786 VSS.n782 0.04675
R3125 VSS.n8 VSS.n6 0.0161289
R3126 VSS.n828 VSS.n3 0.0305
R3127 VSS.n592 VSS.n591 0.0305
R3128 VSS.t465 VSS.n165 0.02925
R3129 VSS.n784 VSS.n588 0.0253401
R3130 VSS.n589 VSS.n587 0.0253401
R3131 VSS.n866 VSS.n310 0.023135
R3132 VSS.n866 VSS.n306 0.023135
R3133 VSS.n870 VSS.n869 0.023135
R3134 VSS.n875 VSS.n291 0.023135
R3135 VSS.n875 VSS.n292 0.023135
R3136 VSS.n879 VSS.n878 0.023135
R3137 VSS.n884 VSS.n277 0.023135
R3138 VSS.n884 VSS.n278 0.023135
R3139 VSS.n888 VSS.n887 0.023135
R3140 VSS.n893 VSS.n254 0.023135
R3141 VSS.n893 VSS.n256 0.023135
R3142 VSS.n893 VSS.n257 0.023135
R3143 VSS.n893 VSS.n258 0.023135
R3144 VSS.n896 VSS.n248 0.023135
R3145 VSS.n899 VSS.n236 0.023135
R3146 VSS.n899 VSS.n237 0.023135
R3147 VSS.n903 VSS.n902 0.023135
R3148 VSS.n908 VSS.n222 0.023135
R3149 VSS.n908 VSS.n223 0.023135
R3150 VSS.n911 VSS.n217 0.023135
R3151 VSS.n914 VSS.n189 0.023135
R3152 VSS.n914 VSS.n193 0.023135
R3153 VSS.n914 VSS.n203 0.023135
R3154 VSS.n864 VSS.n311 0.02175
R3155 VSS.n187 VSS.t146 0.0191553
R3156 VSS.n706 VSS.t310 0.0184075
R3157 VSS.n692 VSS.t90 0.0184075
R3158 VSS.t93 VSS.n718 0.0173993
R3159 VSS.n828 VSS.t445 0.01675
R3160 VSS.n591 VSS.t442 0.01675
R3161 VSS.n92 VSS.n181 0.0165542
R3162 VSS.n92 VSS.n183 0.0165542
R3163 VSS.n865 VSS.n165 0.0155
R3164 VSS.t213 VSS.n62 0.0151406
R3165 VSS.n700 VSS.n67 0.0151406
R3166 VSS.n699 VSS.n67 0.0151406
R3167 VSS.n688 VSS.n639 0.0151406
R3168 VSS.t93 VSS.n635 0.0150892
R3169 VSS VSS.n915 0.0134067
R3170 VSS.n600 VSS.n599 0.013
R3171 VSS.n92 VSS.n180 0.00962826
R3172 VSS.n92 VSS.n175 0.00962826
R3173 VSS.n92 VSS.n134 0.00937856
R3174 VSS.n92 VSS.n151 0.00937856
R3175 VSS.n92 VSS.n160 0.00937856
R3176 VSS.n92 VSS.n98 0.00937856
R3177 VSS.n92 VSS.n104 0.00937856
R3178 VSS.n92 VSS.n114 0.00937856
R3179 VSS.n92 VSS.n116 0.00937856
R3180 VSS.n92 VSS.n129 0.00937856
R3181 VSS.n92 VSS.n139 0.00937856
R3182 VSS.n92 VSS.n141 0.00937856
R3183 VSS.n92 VSS.n155 0.00937856
R3184 VSS.n92 VSS.n163 0.00937856
R3185 VSS.n92 VSS.n101 0.00937856
R3186 VSS.n92 VSS.n110 0.00937856
R3187 VSS.n92 VSS.n112 0.00937856
R3188 VSS.n92 VSS.n125 0.00937856
R3189 VSS.n857 VSS.n522 0.00675
R3190 VSS.n833 VSS.n349 0.00675
R3191 VSS.n21 VSS.n839 0.00495229
R3192 VSS.n16 VSS.n9 0.00495229
R3193 VSS.n10 VSS.n785 0.120722
R3194 VSS.n832 VSS.n39 0.00459701
R3195 VSS.n678 VSS.n75 0.00412425
R3196 VSS.n58 VSS.n61 0.00409958
R3197 VSS.n48 VSS.n797 0.00362425
R3198 VSS.n850 VSS.n12 0.00358306
R3199 VSS.n87 VSS.n88 0.00299994
R3200 VSS.n8 VSS.n0 0.00296307
R3201 VSS.n41 VSS.n39 0.00283308
R3202 VSS.n35 VSS.n34 0.00274942
R3203 VSS.n28 VSS.n574 0.00283308
R3204 VSS.n68 VSS.n67 0.0022
R3205 VSS.n39 VSS.n38 0.00216667
R3206 VSS.n90 VSS.n93 0.00174993
R3207 VSS.n852 VSS.n39 0.00193134
R3208 VSS.n308 VSS.n301 0.00179957
R3209 VSS.n307 VSS.n301 0.00179957
R3210 VSS.n872 VSS.n297 0.00179957
R3211 VSS.n294 VSS.n287 0.00179957
R3212 VSS.n293 VSS.n287 0.00179957
R3213 VSS.n881 VSS.n283 0.00179957
R3214 VSS.n280 VSS.n273 0.00179957
R3215 VSS.n279 VSS.n273 0.00179957
R3216 VSS.n890 VSS.n269 0.00179957
R3217 VSS.n261 VSS.n249 0.00179957
R3218 VSS.n260 VSS.n249 0.00179957
R3219 VSS.n246 VSS.n243 0.00179957
R3220 VSS.n239 VSS.n233 0.00179957
R3221 VSS.n238 VSS.n233 0.00179957
R3222 VSS.n905 VSS.n229 0.00179957
R3223 VSS.n226 VSS.n218 0.00179957
R3224 VSS.n225 VSS.n218 0.00179957
R3225 VSS.n215 VSS.n212 0.00179957
R3226 VSS.n914 VSS.n196 0.00179957
R3227 VSS.n914 VSS.n198 0.00179957
R3228 VSS.n914 VSS.n202 0.00179957
R3229 VSS.n850 VSS.n530 0.00175
R3230 VSS.n839 VSS.n529 0.00166667
R3231 VSS.n845 VSS.n528 0.00166667
R3232 VSS.n13 VSS.n38 0.00344431
R3233 VSS.n44 VSS.n43 0.00169993
R3234 VSS.n46 VSS.n45 0.00169993
R3235 VSS.n54 VSS.n53 0.00169993
R3236 VSS.n57 VSS.n56 0.00169993
R3237 VSS.n796 VSS.n793 0.00166667
R3238 VSS.n59 VSS.n58 0.00134996
R3239 VSS.n81 VSS.n80 0.00169993
R3240 VSS.n83 VSS.n82 0.00169993
R3241 VSS.n85 VSS.n84 0.00169993
R3242 VSS.n656 VSS.n644 0.00166667
R3243 VSS.n655 VSS.n643 0.00166667
R3244 VSS.n87 VSS.n86 0.00149995
R3245 VSS.n74 VSS.n642 0.00166667
R3246 VSS.n8 VSS.n2 0.00161188
R3247 VSS.n92 VSS.n89 0.0015
R3248 VSS.n75 VSS.n74 0.0015
R3249 VSS.n657 VSS.n85 0.0015
R3250 VSS.n658 VSS.n83 0.0015
R3251 VSS.n659 VSS.n81 0.0015
R3252 VSS.n72 VSS.n71 0.00214264
R3253 VSS.n72 VSS.t90 0.0015
R3254 VSS.n67 VSS.t90 0.0015
R3255 VSS.n711 VSS.t213 0.00136832
R3256 VSS.n796 VSS.n55 0.00133332
R3257 VSS.n844 VSS.n528 0.00133332
R3258 VSS.n657 VSS.n644 0.00133332
R3259 VSS.n656 VSS.n643 0.00133332
R3260 VSS.n654 VSS.n642 0.00133332
R3261 VSS.n914 VSS.n210 0.00104691
R3262 VSS.n8 VSS.n1 0.00104112
R3263 VSS.n680 VSS.n75 0.00103062
R3264 VSS.n681 VSS.n75 0.00103062
R3265 VSS.n8 VSS.n4 0.00102569
R3266 VSS.n866 VSS.n305 0.00101811
R3267 VSS.n875 VSS.n874 0.00101811
R3268 VSS.n875 VSS.n296 0.00101811
R3269 VSS.n884 VSS.n883 0.00101811
R3270 VSS.n884 VSS.n282 0.00101811
R3271 VSS.n893 VSS.n892 0.00101811
R3272 VSS.n893 VSS.n263 0.00101811
R3273 VSS.n899 VSS.n242 0.00101811
R3274 VSS.n899 VSS.n241 0.00101811
R3275 VSS.n908 VSS.n907 0.00101811
R3276 VSS.n908 VSS.n228 0.00101811
R3277 VSS.n914 VSS.n211 0.00101811
R3278 VSS.n676 VSS.n75 0.00100609
R3279 VSS.n679 VSS.n75 0.00100339
R3280 VSS.n893 VSS.n266 0.00100065
R3281 VSS.n866 VSS.n304 0.00100065
R3282 VSS.n893 VSS.n255 0.00100065
R3283 VSS.n893 VSS.n264 0.00100065
R3284 VSS.n914 VSS.n190 0.00100065
R3285 VSS.n683 VSS.n75 0.00100006
R3286 VSS.n682 VSS.n75 0.00100001
R3287 VSS.n677 VSS.n75 0.00100001
R3288 VSS.n867 VSS.n301 0.001
R3289 VSS.n869 VSS.n868 0.001
R3290 VSS.n872 VSS.n298 0.001
R3291 VSS.n875 VSS.n290 0.001
R3292 VSS.n876 VSS.n287 0.001
R3293 VSS.n878 VSS.n877 0.001
R3294 VSS.n881 VSS.n284 0.001
R3295 VSS.n884 VSS.n276 0.001
R3296 VSS.n885 VSS.n273 0.001
R3297 VSS.n887 VSS.n886 0.001
R3298 VSS.n890 VSS.n270 0.001
R3299 VSS.n893 VSS.n253 0.001
R3300 VSS.n894 VSS.n249 0.001
R3301 VSS.n896 VSS.n895 0.001
R3302 VSS.n897 VSS.n243 0.001
R3303 VSS.n899 VSS.n898 0.001
R3304 VSS.n900 VSS.n233 0.001
R3305 VSS.n902 VSS.n901 0.001
R3306 VSS.n905 VSS.n230 0.001
R3307 VSS.n908 VSS.n221 0.001
R3308 VSS.n909 VSS.n218 0.001
R3309 VSS.n911 VSS.n910 0.001
R3310 VSS.n912 VSS.n212 0.001
R3311 VSS.n914 VSS.n913 0.001
R3312 VSS.n913 VSS.n212 0.001
R3313 VSS.n912 VSS.n911 0.001
R3314 VSS.n910 VSS.n218 0.001
R3315 VSS.n909 VSS.n908 0.001
R3316 VSS.n905 VSS.n221 0.001
R3317 VSS.n902 VSS.n230 0.001
R3318 VSS.n901 VSS.n233 0.001
R3319 VSS.n900 VSS.n899 0.001
R3320 VSS.n898 VSS.n243 0.001
R3321 VSS.n897 VSS.n896 0.001
R3322 VSS.n895 VSS.n249 0.001
R3323 VSS.n894 VSS.n893 0.001
R3324 VSS.n890 VSS.n253 0.001
R3325 VSS.n887 VSS.n270 0.001
R3326 VSS.n886 VSS.n273 0.001
R3327 VSS.n885 VSS.n884 0.001
R3328 VSS.n881 VSS.n276 0.001
R3329 VSS.n878 VSS.n284 0.001
R3330 VSS.n877 VSS.n287 0.001
R3331 VSS.n876 VSS.n875 0.001
R3332 VSS.n872 VSS.n290 0.001
R3333 VSS.n869 VSS.n298 0.001
R3334 VSS.n868 VSS.n301 0.001
R3335 VSS.n867 VSS.n866 0.001
R3336 VSS.n93 VSS.n92 0.001
R3337 VSS.n799 VSS.n42 0.001
R3338 VSS.n49 VSS.n51 0.001
R3339 VSS.n822 VSS.n60 0.001
R3340 VSS.n575 VSS.n24 0.001
R3341 VSS.n574 VSS.n25 0.001
R3342 VSS.n572 VSS.n29 0.001
R3343 VSS.n844 VSS.n30 0.001
R3344 VSS.n570 VSS.n32 0.001
R3345 VSS.n530 VSS.n37 0.001
R3346 VSS.n66 VSS.n65 0.00192843
R3347 VSS.n529 VSS.n39 0.00183332
R3348 VSS.n65 VSS.t310 0.0015
R3349 VSS.t213 VSS.t310 0.0015
R3350 VSS.n56 VSS.n55 0.0015
R3351 VSS.n53 VSS.n52 0.0015
R3352 VSS.n797 VSS.n46 0.0015
R3353 VSS.n798 VSS.n44 0.0015
R3354 VSS.n570 VSS.n34 0.0015
R3355 VSS.n33 VSS.n845 0.00199997
R3356 VSS.n31 VSS.n572 0.00199997
R3357 VSS.n26 VSS.n575 0.00199997
R3358 VSS.n14 VSS.n9 0.00199997
R3359 VSS.n8 VSS.n7 0.00125
R3360 VSS.n688 VSS.n73 0.001
R3361 VSS.n660 VSS.n79 0.001
R3362 VSS.n654 VSS.n88 0.001
R3363 VSS.n822 VSS.n19 0.001
R3364 VSS.n651 VSS.n623 0.001
R3365 VSS.t93 VSS.n623 0.001
R3366 VSS.n622 VSS.n7 8.47794
R3367 VSS.n827 VSS.n7 8.50175
R3368 a_3747_311.n0 a_3747_311.t2 52.0388
R3369 a_3747_311.t1 a_3747_311.n0 35.4491
R3370 a_3747_311.n0 a_3747_311.t3 33.5891
R3371 a_3747_311.t0 a_3747_311.t1 5.61942
R3372 a_3171_311.n0 a_3171_311.t2 51.8377
R3373 a_3171_311.n0 a_3171_311.t3 33.3881
R3374 a_3171_311.t1 a_3171_311.n0 31.8923
R3375 a_3171_311.t0 a_3171_311.t1 5.61777
R3376 a_2595_311.n0 a_2595_311.t2 51.6367
R3377 a_2595_311.n0 a_2595_311.t3 33.187
R3378 a_2595_311.t1 a_2595_311.n0 27.993
R3379 a_2595_311.t0 a_2595_311.t1 5.73018
R3380 a_3747_1047.n0 a_3747_1047.t2 38.0081
R3381 a_3747_1047.n0 a_3747_1047.t3 33.3957
R3382 a_3747_1047.n1 a_3747_1047.t4 33.3957
R3383 a_3747_1047.n2 a_3747_1047.t5 33.3957
R3384 a_3747_1047.n3 a_3747_1047.t6 33.3957
R3385 a_3747_1047.n4 a_3747_1047.t7 33.3957
R3386 a_3747_1047.n5 a_3747_1047.t8 33.3957
R3387 a_3747_1047.n6 a_3747_1047.t9 33.3957
R3388 a_3747_1047.t1 a_3747_1047.n6 23.2419
R3389 a_3747_1047.t0 a_3747_1047.t1 5.61942
R3390 a_3747_1047.n6 a_3747_1047.n5 4.61291
R3391 a_3747_1047.n5 a_3747_1047.n4 4.61291
R3392 a_3747_1047.n4 a_3747_1047.n3 4.61291
R3393 a_3747_1047.n3 a_3747_1047.n2 4.61291
R3394 a_3747_1047.n2 a_3747_1047.n1 4.61291
R3395 a_3747_1047.n1 a_3747_1047.n0 4.61291
R3396 a_3171_1047.n0 a_3171_1047.t2 37.8054
R3397 a_3171_1047.n0 a_3171_1047.t3 33.193
R3398 a_3171_1047.n1 a_3171_1047.t4 33.193
R3399 a_3171_1047.n2 a_3171_1047.t5 33.193
R3400 a_3171_1047.n3 a_3171_1047.t6 33.193
R3401 a_3171_1047.n4 a_3171_1047.t7 33.193
R3402 a_3171_1047.n5 a_3171_1047.t8 33.193
R3403 a_3171_1047.n6 a_3171_1047.t9 33.193
R3404 a_3171_1047.t1 a_3171_1047.n6 23.0313
R3405 a_3171_1047.t0 a_3171_1047.t1 5.61777
R3406 a_3171_1047.n6 a_3171_1047.n5 4.61291
R3407 a_3171_1047.n5 a_3171_1047.n4 4.61291
R3408 a_3171_1047.n4 a_3171_1047.n3 4.61291
R3409 a_3171_1047.n3 a_3171_1047.n2 4.61291
R3410 a_3171_1047.n2 a_3171_1047.n1 4.61291
R3411 a_3171_1047.n1 a_3171_1047.n0 4.61291
R3412 a_2595_1047.n0 a_2595_1047.t2 37.7691
R3413 a_2595_1047.n0 a_2595_1047.t3 33.1567
R3414 a_2595_1047.n1 a_2595_1047.t4 33.1567
R3415 a_2595_1047.n2 a_2595_1047.t5 33.1567
R3416 a_2595_1047.n3 a_2595_1047.t6 33.1567
R3417 a_2595_1047.n4 a_2595_1047.t7 33.1567
R3418 a_2595_1047.n5 a_2595_1047.t8 33.1567
R3419 a_2595_1047.n6 a_2595_1047.t9 33.1567
R3420 a_2595_1047.t1 a_2595_1047.n6 22.7941
R3421 a_2595_1047.t0 a_2595_1047.t1 5.65522
R3422 a_2595_1047.n6 a_2595_1047.n5 4.61291
R3423 a_2595_1047.n5 a_2595_1047.n4 4.61291
R3424 a_2595_1047.n4 a_2595_1047.n3 4.61291
R3425 a_2595_1047.n3 a_2595_1047.n2 4.61291
R3426 a_2595_1047.n2 a_2595_1047.n1 4.61291
R3427 a_2595_1047.n1 a_2595_1047.n0 4.61291
R3428 a_2019_1047.n0 a_2019_1047.t2 37.9701
R3429 a_2019_1047.n0 a_2019_1047.t3 33.3577
R3430 a_2019_1047.n1 a_2019_1047.t4 33.3577
R3431 a_2019_1047.n2 a_2019_1047.t5 33.3577
R3432 a_2019_1047.n3 a_2019_1047.t6 33.3577
R3433 a_2019_1047.n4 a_2019_1047.t7 33.3577
R3434 a_2019_1047.n5 a_2019_1047.t8 33.3577
R3435 a_2019_1047.t1 a_2019_1047.t9 22.5945
R3436 a_2019_1047.t0 a_2019_1047.t1 5.62052
R3437 a_2019_1047.t9 a_2019_1047.n5 4.61291
R3438 a_2019_1047.n5 a_2019_1047.n4 4.61291
R3439 a_2019_1047.n4 a_2019_1047.n3 4.61291
R3440 a_2019_1047.n3 a_2019_1047.n2 4.61291
R3441 a_2019_1047.n2 a_2019_1047.n1 4.61291
R3442 a_2019_1047.n1 a_2019_1047.n0 4.61291
C1414 MUX_OUT VSS 3.24058f
C1415 MUX_SEL4 VSS 1.60778f
C1416 MUX_SEL3 VSS 0.90686f
C1417 MUX_SEL2 VSS 1.81137f
C1418 MUX_SEL1 VSS 0.95075f
C1419 MUX_SEL0 VSS 1.5515f
C1420 DELAY_VBIASP VSS 5.14139f
C1421 DELAY_OUT_LAST VSS 2.97841f
C1422 DELAY_VBIASN VSS 0.11242p
C1423 REF_CLK VSS 3.19236f
C1424 DLL_RESETN VSS 4.18452f
C1425 VDD VSS 61.87566f
C1426 a_26985_519# VSS 0.17928f ; **FLOATING
C1427 a_23945_519# VSS 0.17928f ; **FLOATING
C1428 a_20905_519# VSS 0.17928f ; **FLOATING
C1429 a_17865_519# VSS 0.17593f ; **FLOATING
C1430 a_16851_309# VSS 0.38699f ; **FLOATING
C1431 a_16108_289# VSS 3.70428f ; **FLOATING
C1432 a_15964_289# VSS 0.17613f ; **FLOATING
C1433 a_15765_463# VSS 0.36132f ; **FLOATING
C1434 a_14825_519# VSS 0.17928f ; **FLOATING
C1435 a_11785_519# VSS 0.17928f ; **FLOATING
C1436 a_8745_519# VSS 0.17928f ; **FLOATING
C1437 a_5731_289# VSS 3.39133f ; **FLOATING
C1438 a_2019_311# VSS 1.61601f ; **FLOATING
C1439 a_5705_519# VSS 0.17638f ; **FLOATING
C1440 a_3449_331# VSS 0.18478f ; **FLOATING
C1441 a_2873_331# VSS 0.18321f ; **FLOATING
C1442 a_2297_331# VSS 0.18321f ; **FLOATING
C1443 a_1721_331# VSS 0.17001f ; **FLOATING
C1444 a_1544_289# VSS 0.30014f ; **FLOATING
C1445 a_1256_289# VSS 0.84266f ; **FLOATING
C1446 a_27991_1008# VSS 0.18706f ; **FLOATING
C1447 a_27915_1044# VSS 0.10926f ; **FLOATING
C1448 a_27124_1008# VSS 0.17878f ; **FLOATING
C1449 a_27048_1044# VSS 0.12122f ; **FLOATING
C1450 a_26471_1008# VSS 0.18175f ; **FLOATING
C1451 a_26395_1044# VSS 0.11073f ; **FLOATING
C1452 a_25604_1008# VSS 0.18087f ; **FLOATING
C1453 a_25630_1044# VSS 0.37805f ; **FLOATING
C1454 a_25528_1044# VSS 0.12433f ; **FLOATING
C1455 a_24951_1008# VSS 0.18335f ; **FLOATING
C1456 a_24875_1044# VSS 0.11016f ; **FLOATING
C1457 a_24084_1008# VSS 0.17878f ; **FLOATING
C1458 a_24008_1044# VSS 0.12122f ; **FLOATING
C1459 a_23431_1008# VSS 0.18175f ; **FLOATING
C1460 a_23355_1044# VSS 0.11073f ; **FLOATING
C1461 a_22564_1008# VSS 0.18087f ; **FLOATING
C1462 a_22590_1044# VSS 0.33314f ; **FLOATING
C1463 a_22488_1044# VSS 0.12433f ; **FLOATING
C1464 a_21911_1008# VSS 0.18335f ; **FLOATING
C1465 a_21835_1044# VSS 0.11016f ; **FLOATING
C1466 a_21044_1008# VSS 0.17878f ; **FLOATING
C1467 a_20968_1044# VSS 0.12122f ; **FLOATING
C1468 a_20391_1008# VSS 0.18175f ; **FLOATING
C1469 a_20315_1044# VSS 0.11073f ; **FLOATING
C1470 a_19524_1008# VSS 0.18087f ; **FLOATING
C1471 a_19550_1044# VSS 0.33563f ; **FLOATING
C1472 a_19448_1044# VSS 0.12433f ; **FLOATING
C1473 a_18871_1008# VSS 0.18335f ; **FLOATING
C1474 a_18795_1044# VSS 0.11016f ; **FLOATING
C1475 a_18004_1008# VSS 0.17878f ; **FLOATING
C1476 a_17928_1044# VSS 0.12122f ; **FLOATING
C1477 a_17351_1008# VSS 0.18022f ; **FLOATING
C1478 a_17275_1044# VSS 0.10926f ; **FLOATING
C1479 a_16484_1008# VSS 0.18023f ; **FLOATING
C1480 a_16510_1044# VSS 0.28935f ; **FLOATING
C1481 a_16408_1044# VSS 0.1229f ; **FLOATING
C1482 a_15831_1008# VSS 0.17846f ; **FLOATING
C1483 a_15755_1044# VSS 0.10926f ; **FLOATING
C1484 a_14964_1008# VSS 0.17878f ; **FLOATING
C1485 a_14888_1044# VSS 0.12122f ; **FLOATING
C1486 a_14311_1008# VSS 0.18175f ; **FLOATING
C1487 a_14235_1044# VSS 0.11073f ; **FLOATING
C1488 a_13444_1008# VSS 0.18087f ; **FLOATING
C1489 a_13470_1044# VSS 0.30333f ; **FLOATING
C1490 a_13368_1044# VSS 0.12433f ; **FLOATING
C1491 a_12791_1008# VSS 0.18335f ; **FLOATING
C1492 a_12715_1044# VSS 0.11016f ; **FLOATING
C1493 a_11924_1008# VSS 0.17878f ; **FLOATING
C1494 a_11848_1044# VSS 0.12122f ; **FLOATING
C1495 a_11271_1008# VSS 0.18175f ; **FLOATING
C1496 a_11195_1044# VSS 0.11073f ; **FLOATING
C1497 a_10404_1008# VSS 0.18087f ; **FLOATING
C1498 a_10430_1044# VSS 0.31665f ; **FLOATING
C1499 a_10328_1044# VSS 0.12433f ; **FLOATING
C1500 a_9751_1008# VSS 0.18335f ; **FLOATING
C1501 a_9675_1044# VSS 0.11016f ; **FLOATING
C1502 a_8884_1008# VSS 0.17878f ; **FLOATING
C1503 a_8808_1044# VSS 0.12122f ; **FLOATING
C1504 a_8231_1008# VSS 0.18175f ; **FLOATING
C1505 a_8155_1044# VSS 0.11073f ; **FLOATING
C1506 a_7364_1008# VSS 0.18087f ; **FLOATING
C1507 a_7390_1044# VSS 0.31357f ; **FLOATING
C1508 a_7288_1044# VSS 0.12433f ; **FLOATING
C1509 a_6711_1008# VSS 0.18335f ; **FLOATING
C1510 a_6635_1044# VSS 0.11016f ; **FLOATING
C1511 a_5844_1008# VSS 0.17878f ; **FLOATING
C1512 a_5768_1044# VSS 0.12122f ; **FLOATING
C1513 a_5191_1008# VSS 0.18022f ; **FLOATING
C1514 a_5115_1044# VSS 0.10926f ; **FLOATING
C1515 a_4324_1008# VSS 0.18023f ; **FLOATING
C1516 a_4350_1044# VSS 0.26655f ; **FLOATING
C1517 a_4248_1044# VSS 0.12443f ; **FLOATING
C1518 a_27705_1044# VSS 0.25297f ; **FLOATING
C1519 a_26185_1044# VSS 0.23475f ; **FLOATING
C1520 a_24665_1044# VSS 0.25433f ; **FLOATING
C1521 a_23145_1044# VSS 0.23475f ; **FLOATING
C1522 a_21625_1044# VSS 0.25433f ; **FLOATING
C1523 a_20105_1044# VSS 0.23475f ; **FLOATING
C1524 a_18585_1044# VSS 0.25433f ; **FLOATING
C1525 a_17065_1044# VSS 0.23386f ; **FLOATING
C1526 a_15545_1044# VSS 0.25297f ; **FLOATING
C1527 a_14025_1044# VSS 0.23475f ; **FLOATING
C1528 a_12505_1044# VSS 0.25433f ; **FLOATING
C1529 a_10985_1044# VSS 0.23475f ; **FLOATING
C1530 a_9465_1044# VSS 0.25433f ; **FLOATING
C1531 a_7945_1044# VSS 0.23475f ; **FLOATING
C1532 a_6425_1044# VSS 0.25433f ; **FLOATING
C1533 a_4905_1044# VSS 0.23549f ; **FLOATING
C1534 a_4157_1313# VSS 0.32875f ; **FLOATING
C1535 a_3449_1395# VSS 0.18629f ; **FLOATING
C1536 a_2873_1395# VSS 0.18349f ; **FLOATING
C1537 a_2297_1395# VSS 0.18349f ; **FLOATING
C1538 a_1721_1395# VSS 0.17029f ; **FLOATING
C1539 a_1544_1044# VSS 0.29829f ; **FLOATING
C1540 a_1256_1044# VSS 0.82974f ; **FLOATING
C1541 a_27671_1842# VSS 0.01336f ; **FLOATING
C1542 a_26911_1842# VSS 0.01336f ; **FLOATING
C1543 a_26151_1842# VSS 0.01336f ; **FLOATING
C1544 a_25391_1842# VSS 0.01336f ; **FLOATING
C1545 a_24631_1842# VSS 0.01336f ; **FLOATING
C1546 a_23871_1842# VSS 0.01336f ; **FLOATING
C1547 a_23111_1842# VSS 0.01336f ; **FLOATING
C1548 a_22351_1842# VSS 0.01336f ; **FLOATING
C1549 a_21591_1842# VSS 0.01336f ; **FLOATING
C1550 a_20831_1842# VSS 0.01336f ; **FLOATING
C1551 a_20071_1842# VSS 0.01336f ; **FLOATING
C1552 a_19311_1842# VSS 0.01336f ; **FLOATING
C1553 a_18551_1842# VSS 0.01336f ; **FLOATING
C1554 a_17791_1842# VSS 0.01336f ; **FLOATING
C1555 a_17031_1842# VSS 0.01336f ; **FLOATING
C1556 a_16271_1842# VSS 0.01336f ; **FLOATING
C1557 a_15511_1842# VSS 0.01336f ; **FLOATING
C1558 a_14751_1842# VSS 0.01336f ; **FLOATING
C1559 a_13991_1842# VSS 0.01336f ; **FLOATING
C1560 a_13231_1842# VSS 0.01336f ; **FLOATING
C1561 a_12471_1842# VSS 0.01336f ; **FLOATING
C1562 a_11711_1842# VSS 0.01336f ; **FLOATING
C1563 a_10951_1842# VSS 0.01336f ; **FLOATING
C1564 a_10191_1842# VSS 0.01336f ; **FLOATING
C1565 a_9431_1842# VSS 0.01336f ; **FLOATING
C1566 a_8671_1842# VSS 0.01336f ; **FLOATING
C1567 a_7911_1842# VSS 0.01336f ; **FLOATING
C1568 a_7151_1842# VSS 0.01336f ; **FLOATING
C1569 a_6391_1842# VSS 0.01336f ; **FLOATING
C1570 a_5631_1842# VSS 0.01336f ; **FLOATING
C1571 a_4871_1842# VSS 0.01336f ; **FLOATING
C1572 a_4111_1842# VSS 0.0139f ; **FLOATING
C1573 a_27563_1842# VSS 0.50316f ; **FLOATING
C1574 a_27997_1842# VSS 0.6484f ; **FLOATING
C1575 a_27433_1842# VSS 0.4463f ; **FLOATING
C1576 a_26803_1842# VSS 0.49934f ; **FLOATING
C1577 a_27237_1842# VSS 0.92967f ; **FLOATING
C1578 a_26673_1842# VSS 0.4492f ; **FLOATING
C1579 a_26043_1842# VSS 0.50169f ; **FLOATING
C1580 a_26477_1842# VSS 0.95928f ; **FLOATING
C1581 a_25913_1842# VSS 0.4508f ; **FLOATING
C1582 a_25283_1842# VSS 0.49938f ; **FLOATING
C1583 a_25717_1842# VSS 0.86841f ; **FLOATING
C1584 a_25153_1842# VSS 0.45035f ; **FLOATING
C1585 a_24523_1842# VSS 0.50075f ; **FLOATING
C1586 a_24957_1842# VSS 0.96341f ; **FLOATING
C1587 a_24393_1842# VSS 0.4463f ; **FLOATING
C1588 a_23763_1842# VSS 0.49934f ; **FLOATING
C1589 a_24197_1842# VSS 0.92543f ; **FLOATING
C1590 a_23633_1842# VSS 0.45062f ; **FLOATING
C1591 a_23003_1842# VSS 0.50169f ; **FLOATING
C1592 a_23437_1842# VSS 0.95769f ; **FLOATING
C1593 a_22873_1842# VSS 0.4508f ; **FLOATING
C1594 a_22243_1842# VSS 0.49938f ; **FLOATING
C1595 a_22677_1842# VSS 0.86841f ; **FLOATING
C1596 a_22113_1842# VSS 0.45249f ; **FLOATING
C1597 a_21483_1842# VSS 0.50075f ; **FLOATING
C1598 a_21917_1842# VSS 0.96341f ; **FLOATING
C1599 a_21353_1842# VSS 0.4463f ; **FLOATING
C1600 a_20723_1842# VSS 0.49992f ; **FLOATING
C1601 a_21157_1842# VSS 0.92543f ; **FLOATING
C1602 a_20593_1842# VSS 0.45196f ; **FLOATING
C1603 a_19963_1842# VSS 0.50169f ; **FLOATING
C1604 a_20397_1842# VSS 0.95769f ; **FLOATING
C1605 a_19833_1842# VSS 0.4508f ; **FLOATING
C1606 a_19203_1842# VSS 0.5005f ; **FLOATING
C1607 a_19637_1842# VSS 0.86841f ; **FLOATING
C1608 a_19073_1842# VSS 0.44947f ; **FLOATING
C1609 a_18443_1842# VSS 0.50075f ; **FLOATING
C1610 a_18877_1842# VSS 0.96341f ; **FLOATING
C1611 a_18313_1842# VSS 0.4463f ; **FLOATING
C1612 a_17683_1842# VSS 0.50046f ; **FLOATING
C1613 a_18117_1842# VSS 0.92543f ; **FLOATING
C1614 a_17553_1842# VSS 0.44782f ; **FLOATING
C1615 a_16923_1842# VSS 0.50165f ; **FLOATING
C1616 a_17357_1842# VSS 0.95769f ; **FLOATING
C1617 a_16793_1842# VSS 0.45049f ; **FLOATING
C1618 a_16163_1842# VSS 0.4946f ; **FLOATING
C1619 a_16597_1842# VSS 0.86359f ; **FLOATING
C1620 a_16033_1842# VSS 0.44618f ; **FLOATING
C1621 a_15403_1842# VSS 0.49465f ; **FLOATING
C1622 a_15837_1842# VSS 0.95171f ; **FLOATING
C1623 a_15273_1842# VSS 0.44439f ; **FLOATING
C1624 a_14643_1842# VSS 0.49305f ; **FLOATING
C1625 a_15077_1842# VSS 0.92116f ; **FLOATING
C1626 a_14513_1842# VSS 0.44501f ; **FLOATING
C1627 a_13883_1842# VSS 0.50862f ; **FLOATING
C1628 a_14317_1842# VSS 0.96009f ; **FLOATING
C1629 a_13753_1842# VSS 0.46427f ; **FLOATING
C1630 a_13123_1842# VSS 0.50173f ; **FLOATING
C1631 a_13557_1842# VSS 0.87587f ; **FLOATING
C1632 a_12993_1842# VSS 0.45643f ; **FLOATING
C1633 a_12363_1842# VSS 0.50854f ; **FLOATING
C1634 a_12797_1842# VSS 0.96142f ; **FLOATING
C1635 a_12233_1842# VSS 0.45757f ; **FLOATING
C1636 a_11603_1842# VSS 0.50267f ; **FLOATING
C1637 a_12037_1842# VSS 0.92866f ; **FLOATING
C1638 a_11473_1842# VSS 0.45177f ; **FLOATING
C1639 a_10843_1842# VSS 0.50491f ; **FLOATING
C1640 a_11277_1842# VSS 0.96053f ; **FLOATING
C1641 a_10713_1842# VSS 0.44901f ; **FLOATING
C1642 a_10083_1842# VSS 0.50223f ; **FLOATING
C1643 a_10517_1842# VSS 0.87053f ; **FLOATING
C1644 a_9953_1842# VSS 0.44673f ; **FLOATING
C1645 a_9323_1842# VSS 0.5026f ; **FLOATING
C1646 a_9757_1842# VSS 0.96312f ; **FLOATING
C1647 a_9193_1842# VSS 0.44361f ; **FLOATING
C1648 a_8563_1842# VSS 0.49203f ; **FLOATING
C1649 a_8997_1842# VSS 0.92196f ; **FLOATING
C1650 a_8433_1842# VSS 0.44439f ; **FLOATING
C1651 a_7803_1842# VSS 0.49435f ; **FLOATING
C1652 a_8237_1842# VSS 0.95422f ; **FLOATING
C1653 a_7673_1842# VSS 0.44737f ; **FLOATING
C1654 a_7043_1842# VSS 0.49204f ; **FLOATING
C1655 a_7477_1842# VSS 0.86493f ; **FLOATING
C1656 a_6913_1842# VSS 0.44442f ; **FLOATING
C1657 a_6283_1842# VSS 0.49343f ; **FLOATING
C1658 a_6717_1842# VSS 0.95763f ; **FLOATING
C1659 a_6153_1842# VSS 0.44292f ; **FLOATING
C1660 a_5523_1842# VSS 0.50322f ; **FLOATING
C1661 a_5957_1842# VSS 0.92646f ; **FLOATING
C1662 a_5393_1842# VSS 0.4596f ; **FLOATING
C1663 a_4763_1842# VSS 0.51043f ; **FLOATING
C1664 a_5197_1842# VSS 0.96509f ; **FLOATING
C1665 a_4633_1842# VSS 0.46282f ; **FLOATING
C1666 a_4003_1842# VSS 0.58808f ; **FLOATING
C1667 a_4437_1842# VSS 0.87628f ; **FLOATING
C1668 a_9712_3912# VSS 1.25906f ; **FLOATING
C1669 a_9444_3912# VSS 2.12877f ; **FLOATING
C1670 a_5778_3367# VSS 5.22809f ; **FLOATING
C1671 a_15464_3684# VSS 0.75391f ; **FLOATING
C1672 a_14757_5182# VSS 0.09495f ; **FLOATING
C1673 a_13880_5118# VSS 0.06985f ; **FLOATING
C1674 a_15688_5403# VSS 0.26291f ; **FLOATING
C1675 a_15108_5325# VSS 0.24458f ; **FLOATING
C1676 a_14851_5182# VSS 0.38123f ; **FLOATING
C1677 a_9444_4590# VSS 6.03808f ; **FLOATING
C1678 a_14111_5227# VSS 0.19866f ; **FLOATING
C1679 a_14009_5084# VSS 0.44622f ; **FLOATING
C1680 a_13592_5423# VSS 1.57456f ; **FLOATING
C1681 a_13306_5105# VSS 0.30095f ; **FLOATING
C1682 a_13566_5328# VSS 0.15441f ; **FLOATING
C1683 a_13132_5420# VSS 0.13036f ; **FLOATING
C1684 a_12907_5420# VSS 0.14377f ; **FLOATING
C1685 a_12907_5186# VSS 0.14861f ; **FLOATING
C1686 a_13106_5357# VSS 0.06343f ; **FLOATING
C1687 a_15304_4605# VSS 0.37009f ; **FLOATING
C1688 a_14757_6228# VSS 0.09586f ; **FLOATING
C1689 a_15688_5867# VSS 0.26405f ; **FLOATING
C1690 a_14851_6228# VSS 0.39588f ; **FLOATING
C1691 a_15108_6109# VSS 0.24582f ; **FLOATING
C1692 a_14111_5878# VSS 0.21915f ; **FLOATING
C1693 a_13880_6292# VSS 0.07345f ; **FLOATING
C1694 a_14009_5878# VSS 0.48187f ; **FLOATING
C1695 a_13592_5871# VSS 1.58208f ; **FLOATING
C1696 a_13566_5835# VSS 0.15442f ; **FLOATING
C1697 a_13045_6215# VSS 0.01124f ; **FLOATING
C1698 a_13306_6305# VSS 0.31701f ; **FLOATING
C1699 a_12849_5867# VSS 1.40248f ; **FLOATING
C1700 a_13121_5831# VSS 0.80439f ; **FLOATING
C1701 a_13019_5831# VSS 2.18715f ; **FLOATING
C1702 a_12656_5864# VSS 0.28393f ; **FLOATING
C1703 a_12355_5867# VSS 0.62262f ; **FLOATING
C1704 a_11397_6228# VSS 0.09495f ; **FLOATING
C1705 a_12158_5867# VSS 0.25874f ; **FLOATING
C1706 a_11491_6228# VSS 0.30073f ; **FLOATING
C1707 a_11748_6109# VSS 0.17021f ; **FLOATING
C1708 a_10751_5878# VSS 0.19918f ; **FLOATING
C1709 a_10520_6292# VSS 0.03671f ; **FLOATING
C1710 a_10649_5878# VSS 0.47308f ; **FLOATING
C1711 a_10232_5871# VSS 1.52123f ; **FLOATING
C1712 a_10206_5835# VSS 0.08466f ; **FLOATING
C1713 a_9946_6305# VSS 0.18126f ; **FLOATING
C1714 a_9772_5843# VSS 0.12435f ; **FLOATING
C1715 a_9746_5805# VSS 0.06613f ; **FLOATING
C1716 a_9547_6172# VSS 0.16037f ; **FLOATING
C1717 a_9547_5942# VSS 0.11966f ; **FLOATING
C1718 a_6854_5454# VSS 3.66026f ; **FLOATING
C1719 a_6126_3816# VSS 13.6177f ; **FLOATING
C1720 a_6854_5986# VSS 1.41376f ; **FLOATING
C1721 a_5974_5723# VSS 2.40124f ; **FLOATING
C1722 a_6326_4590# VSS 1.03474f ; **FLOATING
C1723 a_2019_1047.t2 VSS 0.93027f ; **FLOATING
C1724 a_2019_1047.t3 VSS 0.70623f ; **FLOATING
C1725 a_2019_1047.n0 VSS 5.00884f ; **FLOATING
C1726 a_2019_1047.t4 VSS 0.70623f ; **FLOATING
C1727 a_2019_1047.n1 VSS 3.38862f ; **FLOATING
C1728 a_2019_1047.t5 VSS 0.70623f ; **FLOATING
C1729 a_2019_1047.n2 VSS 3.38862f ; **FLOATING
C1730 a_2019_1047.t6 VSS 0.70623f ; **FLOATING
C1731 a_2019_1047.n3 VSS 3.38862f ; **FLOATING
C1732 a_2019_1047.t7 VSS 0.70623f ; **FLOATING
C1733 a_2019_1047.n4 VSS 3.38862f ; **FLOATING
C1734 a_2019_1047.t8 VSS 0.70623f ; **FLOATING
C1735 a_2019_1047.n5 VSS 3.38862f ; **FLOATING
C1736 a_2019_1047.t9 VSS 5.45485f ; **FLOATING
C1737 a_2019_1047.t1 VSS 1.07257f ; **FLOATING
C1738 a_2019_1047.t0 VSS 0.30486f ; **FLOATING
C1739 a_2595_1047.t2 VSS 1.36703f ; **FLOATING
C1740 a_2595_1047.t3 VSS 1.02094f ; **FLOATING
C1741 a_2595_1047.n0 VSS 7.76124f ; **FLOATING
C1742 a_2595_1047.t4 VSS 1.02094f ; **FLOATING
C1743 a_2595_1047.n1 VSS 5.2734f ; **FLOATING
C1744 a_2595_1047.t5 VSS 1.02094f ; **FLOATING
C1745 a_2595_1047.n2 VSS 5.2734f ; **FLOATING
C1746 a_2595_1047.t6 VSS 1.02094f ; **FLOATING
C1747 a_2595_1047.n3 VSS 5.2734f ; **FLOATING
C1748 a_2595_1047.t7 VSS 1.02094f ; **FLOATING
C1749 a_2595_1047.n4 VSS 5.2734f ; **FLOATING
C1750 a_2595_1047.t8 VSS 1.02094f ; **FLOATING
C1751 a_2595_1047.n5 VSS 5.2734f ; **FLOATING
C1752 a_2595_1047.t9 VSS 1.02094f ; **FLOATING
C1753 a_2595_1047.n6 VSS 7.58547f ; **FLOATING
C1754 a_2595_1047.t1 VSS 1.75119f ; **FLOATING
C1755 a_2595_1047.t0 VSS 0.48227f ; **FLOATING
C1756 a_3171_1047.t2 VSS 1.38442f ; **FLOATING
C1757 a_3171_1047.t3 VSS 1.03734f ; **FLOATING
C1758 a_3171_1047.n0 VSS 7.77858f ; **FLOATING
C1759 a_3171_1047.t4 VSS 1.03734f ; **FLOATING
C1760 a_3171_1047.n1 VSS 5.28084f ; **FLOATING
C1761 a_3171_1047.t5 VSS 1.03734f ; **FLOATING
C1762 a_3171_1047.n2 VSS 5.28084f ; **FLOATING
C1763 a_3171_1047.t6 VSS 1.03734f ; **FLOATING
C1764 a_3171_1047.n3 VSS 5.28084f ; **FLOATING
C1765 a_3171_1047.t7 VSS 1.03734f ; **FLOATING
C1766 a_3171_1047.n4 VSS 5.28084f ; **FLOATING
C1767 a_3171_1047.t8 VSS 1.03734f ; **FLOATING
C1768 a_3171_1047.n5 VSS 5.28084f ; **FLOATING
C1769 a_3171_1047.t9 VSS 1.03734f ; **FLOATING
C1770 a_3171_1047.n6 VSS 7.68349f ; **FLOATING
C1771 a_3171_1047.t1 VSS 1.77027f ; **FLOATING
C1772 a_3171_1047.t0 VSS 0.48084f ; **FLOATING
C1773 a_3747_1047.t2 VSS 0.96885f ; **FLOATING
C1774 a_3747_1047.t3 VSS 0.7376f ; **FLOATING
C1775 a_3747_1047.n0 VSS 5.16746f ; **FLOATING
C1776 a_3747_1047.t4 VSS 0.7376f ; **FLOATING
C1777 a_3747_1047.n1 VSS 3.49313f ; **FLOATING
C1778 a_3747_1047.t5 VSS 0.7376f ; **FLOATING
C1779 a_3747_1047.n2 VSS 3.49313f ; **FLOATING
C1780 a_3747_1047.t6 VSS 0.7376f ; **FLOATING
C1781 a_3747_1047.n3 VSS 3.49313f ; **FLOATING
C1782 a_3747_1047.t7 VSS 0.7376f ; **FLOATING
C1783 a_3747_1047.n4 VSS 3.49313f ; **FLOATING
C1784 a_3747_1047.t8 VSS 0.7376f ; **FLOATING
C1785 a_3747_1047.n5 VSS 3.49313f ; **FLOATING
C1786 a_3747_1047.t9 VSS 0.7376f ; **FLOATING
C1787 a_3747_1047.n6 VSS 5.18689f ; **FLOATING
C1788 a_3747_1047.t1 VSS 1.18535f ; **FLOATING
C1789 a_3747_1047.t0 VSS 0.31338f ; **FLOATING
C1790 a_2595_311.t1 VSS 3.27037f ; **FLOATING
C1791 a_2595_311.t2 VSS 5.04145f ; **FLOATING
C1792 a_2595_311.t3 VSS 1.20632f ; **FLOATING
C1793 a_2595_311.n0 VSS 26.8668f ; **FLOATING
C1794 a_2595_311.t0 VSS 0.49572f ; **FLOATING
C1795 a_3171_311.t2 VSS 5.05009f ; **FLOATING
C1796 a_3171_311.t3 VSS 1.21149f ; **FLOATING
C1797 a_3171_311.n0 VSS 29.8499f ; **FLOATING
C1798 a_3171_311.t1 VSS 4.61154f ; **FLOATING
C1799 a_3171_311.t0 VSS 0.4973f ; **FLOATING
C1800 a_3747_311.t2 VSS 3.08793f ; **FLOATING
C1801 a_3747_311.t3 VSS 0.74323f ; **FLOATING
C1802 a_3747_311.n0 VSS 19.8622f ; **FLOATING
C1803 a_3747_311.t1 VSS 3.68404f ; **FLOATING
C1804 a_3747_311.t0 VSS 0.30496f ; **FLOATING
C1805 VSS.t247 VSS 3.22049f ; **FLOATING
C1806 VDD.n0 VSS 0.03676f ; **FLOATING
C1807 VDD.n1 VSS 1.12808f ; **FLOATING
C1808 VDD.n2 VSS 0.0301f ; **FLOATING
C1809 VDD.n3 VSS 0.46878f ; **FLOATING
C1810 VDD.n4 VSS 0.04222f ; **FLOATING
C1811 VDD.t0 VSS 49.913f ; **FLOATING
C1812 VDD.n5 VSS 0.46878f ; **FLOATING
C1813 VDD.n6 VSS 0.46878f ; **FLOATING
C1814 VDD.n7 VSS 0.04222f ; **FLOATING
C1815 VDD.n8 VSS 0.46878f ; **FLOATING
C1816 VDD.n9 VSS 0.46878f ; **FLOATING
C1817 VDD.n10 VSS 0.46878f ; **FLOATING
C1818 VDD.n11 VSS 0.07683f ; **FLOATING
C1819 VDD.n12 VSS 0.40392f ; **FLOATING
C1820 VDD.n14 VSS 0.36467f ; **FLOATING
C1821 VDD.n16 VSS 0.44721f ; **FLOATING
C1822 VDD.n17 VSS 0.13597f ; **FLOATING
C1823 VDD.n18 VSS 0.44721f ; **FLOATING
C1824 VDD.n19 VSS 0.13597f ; **FLOATING
C1825 VDD.n20 VSS 0.44721f ; **FLOATING
C1826 VDD.n22 VSS 0.44721f ; **FLOATING
C1827 VDD.n23 VSS 0.13597f ; **FLOATING
C1828 VDD.n24 VSS 0.44721f ; **FLOATING
C1829 VDD.n25 VSS 0.13597f ; **FLOATING
C1830 VDD.n26 VSS 0.44721f ; **FLOATING
C1831 VDD.n27 VSS 0.26251f ; **FLOATING
C1832 VDD.n28 VSS 0.2297f ; **FLOATING
C1833 VDD.n30 VSS 1.61292f ; **FLOATING
C1834 VDD.t3 VSS 43.7414f ; **FLOATING
C1835 VDD.n31 VSS 0.06197f ; **FLOATING
C1836 VDD.n32 VSS 0.13597f ; **FLOATING
C1837 VDD.n33 VSS 0.13597f ; **FLOATING
C1838 VDD.n34 VSS 0.03108f ; **FLOATING
C1839 VDD.t25 VSS 0.0187f ; **FLOATING
C1840 VDD.n35 VSS 0.02515f ; **FLOATING
C1841 VDD.n36 VSS 0.07731f ; **FLOATING
C1842 VDD.n37 VSS 0.0214f ; **FLOATING
C1843 VDD.n38 VSS 0.02356f ; **FLOATING
C1844 VDD.n39 VSS 0.01579f ; **FLOATING
C1845 VDD.n40 VSS 0.10228f ; **FLOATING
C1846 VDD.n42 VSS 0.15078f ; **FLOATING
C1847 VDD.n43 VSS 0.01387f ; **FLOATING
C1848 VDD.n44 VSS 0.06541f ; **FLOATING
C1849 VDD.n45 VSS 0.08542f ; **FLOATING
C1850 VDD.n47 VSS 0.08434f ; **FLOATING
C1851 VDD.n48 VSS 0.05909f ; **FLOATING
C1852 VDD.n49 VSS 0.05909f ; **FLOATING
C1853 VDD.n50 VSS 0.08434f ; **FLOATING
C1854 VDD.n51 VSS 0.05909f ; **FLOATING
C1855 VDD.n52 VSS 0.05909f ; **FLOATING
C1856 VDD.n53 VSS 0.08434f ; **FLOATING
C1857 VDD.n54 VSS 0.05909f ; **FLOATING
C1858 VDD.n55 VSS 0.05909f ; **FLOATING
C1859 VDD.n56 VSS 0.04008f ; **FLOATING
C1860 VDD.n57 VSS 0.02072f ; **FLOATING
C1861 VDD.n58 VSS 0.14209f ; **FLOATING
C1862 VDD.n59 VSS 0.04089f ; **FLOATING
C1863 VDD.n60 VSS 0.01022f ; **FLOATING
C1864 VDD.n61 VSS 0.02576f ; **FLOATING
C1865 VDD.n62 VSS 0.03846f ; **FLOATING
C1866 VDD.n63 VSS 0.02115f ; **FLOATING
C1867 VDD.n64 VSS 0.01579f ; **FLOATING
C1868 VDD.n65 VSS 0.10654f ; **FLOATING
C1869 VDD.n66 VSS 0.0515f ; **FLOATING
C1870 VDD.n67 VSS 0.20407f ; **FLOATING
C1871 VDD.n68 VSS 0.05909f ; **FLOATING
C1872 VDD.n69 VSS 0.0562f ; **FLOATING
C1873 VDD.n70 VSS 0.03173f ; **FLOATING
C1874 VDD.n71 VSS 0.01696f ; **FLOATING
C1875 VDD.n72 VSS 0.15117f ; **FLOATING
C1876 VDD.n73 VSS 0.03161f ; **FLOATING
C1877 VDD.n74 VSS 0.03565f ; **FLOATING
C1878 VDD.n75 VSS 0.13354f ; **FLOATING
C1879 VDD.n77 VSS 0.08627f ; **FLOATING
C1880 VDD.n78 VSS 0.13354f ; **FLOATING
C1881 VDD.n79 VSS 0.08627f ; **FLOATING
C1882 VDD.n81 VSS 0.13354f ; **FLOATING
C1883 VDD.n82 VSS 0.08627f ; **FLOATING
C1884 VDD.n84 VSS 0.02632f ; **FLOATING
C1885 VDD.n85 VSS 0.09628f ; **FLOATING
C1886 VDD.n86 VSS 0.13354f ; **FLOATING
C1887 VDD.n87 VSS 0.08627f ; **FLOATING
C1888 VDD.n89 VSS 0.13354f ; **FLOATING
C1889 VDD.n90 VSS 0.08627f ; **FLOATING
C1890 VDD.n92 VSS 0.13354f ; **FLOATING
C1891 VDD.n93 VSS 0.08627f ; **FLOATING
C1892 VDD.n95 VSS 0.08434f ; **FLOATING
C1893 VDD.n96 VSS 0.08434f ; **FLOATING
C1894 VDD.n97 VSS 0.08434f ; **FLOATING
C1895 VDD.n98 VSS 0.03061f ; **FLOATING
C1896 VDD.n99 VSS 0.01586f ; **FLOATING
C1897 VDD.n100 VSS 0.10037f ; **FLOATING
C1898 VDD.n101 VSS 0.04222f ; **FLOATING
C1899 VDD.n102 VSS 0.04222f ; **FLOATING
C1900 VDD.n103 VSS 0.04222f ; **FLOATING
C1901 VDD.n104 VSS 0.04222f ; **FLOATING
C1902 VDD.n105 VSS 0.13174f ; **FLOATING
C1903 VDD.t48 VSS 8.26825f ; **FLOATING
C1904 VDD.t234 VSS 0.03685f ; **FLOATING
C1905 VDD.t224 VSS 0.03685f ; **FLOATING
C1906 VDD.n106 VSS 0.12584f ; **FLOATING
C1907 VDD.n107 VSS 0.01583f ; **FLOATING
C1908 VDD.t232 VSS 0.04457f ; **FLOATING
C1909 VDD.t222 VSS 0.04457f ; **FLOATING
C1910 VDD.n108 VSS 0.14191f ; **FLOATING
C1911 VDD.n109 VSS 0.07511f ; **FLOATING
C1912 VDD.t23 VSS 0.03177f ; **FLOATING
C1913 VDD.n110 VSS 0.02157f ; **FLOATING
C1914 VDD.t21 VSS 0.02294f ; **FLOATING
C1915 VDD.t24 VSS 0.03551f ; **FLOATING
C1916 VDD.t26 VSS 0.03177f ; **FLOATING
C1917 VDD.t290 VSS 0.03177f ; **FLOATING
C1918 VDD.t28 VSS 0.03177f ; **FLOATING
C1919 VDD.n111 VSS 0.02157f ; **FLOATING
C1920 VDD.t27 VSS 0.02294f ; **FLOATING
C1921 VDD.t29 VSS 0.03551f ; **FLOATING
C1922 VDD.n112 VSS 0.01804f ; **FLOATING
C1923 VDD.t30 VSS 0.0187f ; **FLOATING
C1924 VDD.t31 VSS 0.03177f ; **FLOATING
C1925 VDD.n113 VSS 0.01894f ; **FLOATING
C1926 VDD.t328 VSS 0.03488f ; **FLOATING
C1927 VDD.t324 VSS 0.02373f ; **FLOATING
C1928 VDD.n114 VSS 0.11936f ; **FLOATING
C1929 VDD.t22 VSS 3.33454f ; **FLOATING
C1930 VDD.n115 VSS 0.64929f ; **FLOATING
C1931 VDD.n116 VSS 0.11549f ; **FLOATING
C1932 VDD.n117 VSS 0.02728f ; **FLOATING
C1933 VDD.t315 VSS 0.02621f ; **FLOATING
C1934 VDD.t319 VSS 0.02621f ; **FLOATING
C1935 VDD.n118 VSS 0.0778f ; **FLOATING
C1936 VDD.n119 VSS 0.03692f ; **FLOATING
C1937 VDD.t44 VSS 0.01215f ; **FLOATING
C1938 VDD.t68 VSS 0.06047f ; **FLOATING
C1939 VDD.n120 VSS 0.02449f ; **FLOATING
C1940 VDD.t271 VSS 0.01215f ; **FLOATING
C1941 VDD.t313 VSS 0.06047f ; **FLOATING
C1942 VDD.n121 VSS 0.02449f ; **FLOATING
C1943 VDD.n122 VSS 0.05407f ; **FLOATING
C1944 VDD.n123 VSS 0.01437f ; **FLOATING
C1945 VDD.t207 VSS 0.03562f ; **FLOATING
C1946 VDD.n124 VSS 0.06404f ; **FLOATING
C1947 VDD.n125 VSS 0.03522f ; **FLOATING
C1948 VDD.t322 VSS 0.03289f ; **FLOATING
C1949 VDD.n126 VSS 0.07632f ; **FLOATING
C1950 VDD.n127 VSS 0.02008f ; **FLOATING
C1951 VDD.t145 VSS 0.03685f ; **FLOATING
C1952 VDD.n128 VSS 0.16466f ; **FLOATING
C1953 VDD.t327 VSS 0.01215f ; **FLOATING
C1954 VDD.t113 VSS 0.06047f ; **FLOATING
C1955 VDD.n129 VSS 0.02449f ; **FLOATING
C1956 VDD.n130 VSS 0.0737f ; **FLOATING
C1957 VDD.t184 VSS 0.02621f ; **FLOATING
C1958 VDD.n131 VSS 0.14748f ; **FLOATING
C1959 VDD.n132 VSS 0.03694f ; **FLOATING
C1960 VDD.n133 VSS 0.01473f ; **FLOATING
C1961 VDD.n134 VSS 0.0715f ; **FLOATING
C1962 VDD.n135 VSS 0.71787f ; **FLOATING
C1963 VDD.t330 VSS 0.03289f ; **FLOATING
C1964 VDD.t368 VSS 0.03289f ; **FLOATING
C1965 VDD.t356 VSS 0.02953f ; **FLOATING
C1966 VDD.t390 VSS 0.03289f ; **FLOATING
C1967 VDD.n136 VSS 0.02716f ; **FLOATING
C1968 VDD.t138 VSS 0.04317f ; **FLOATING
C1969 VDD.n137 VSS 0.0828f ; **FLOATING
C1970 VDD.n138 VSS 0.02422f ; **FLOATING
C1971 VDD.t269 VSS 0.03289f ; **FLOATING
C1972 VDD.n139 VSS 0.07849f ; **FLOATING
C1973 VDD.n140 VSS 0.01153f ; **FLOATING
C1974 VDD.t340 VSS 0.03666f ; **FLOATING
C1975 VDD.t96 VSS 0.03666f ; **FLOATING
C1976 VDD.t152 VSS 0.03666f ; **FLOATING
C1977 VDD.t229 VSS 0.03666f ; **FLOATING
C1978 VDD.t311 VSS 0.03289f ; **FLOATING
C1979 VDD.t202 VSS 0.03289f ; **FLOATING
C1980 VDD.n141 VSS 0.09515f ; **FLOATING
C1981 VDD.n142 VSS 0.01506f ; **FLOATING
C1982 VDD.t255 VSS 0.02429f ; **FLOATING
C1983 VDD.t364 VSS 0.02429f ; **FLOATING
C1984 VDD.n143 VSS 0.08389f ; **FLOATING
C1985 VDD.t149 VSS 0.03247f ; **FLOATING
C1986 VDD.t189 VSS 0.03247f ; **FLOATING
C1987 VDD.t331 VSS 0.02429f ; **FLOATING
C1988 VDD.t369 VSS 0.02429f ; **FLOATING
C1989 VDD.t150 VSS 0.03247f ; **FLOATING
C1990 VDD.t95 VSS 0.03247f ; **FLOATING
C1991 VDD.t312 VSS 0.02429f ; **FLOATING
C1992 VDD.t201 VSS 0.02429f ; **FLOATING
C1993 VDD.t256 VSS 0.03247f ; **FLOATING
C1994 VDD.t124 VSS 0.03247f ; **FLOATING
C1995 VDD.n144 VSS 0.07663f ; **FLOATING
C1996 VDD.t273 VSS 0.03666f ; **FLOATING
C1997 VDD.t125 VSS 0.03666f ; **FLOATING
C1998 VDD.t329 VSS 0.02429f ; **FLOATING
C1999 VDD.t370 VSS 0.02429f ; **FLOATING
C2000 VDD.t97 VSS 0.03247f ; **FLOATING
C2001 VDD.t203 VSS 0.03247f ; **FLOATING
C2002 VDD.n145 VSS 0.06965f ; **FLOATING
C2003 VDD.t98 VSS 0.03666f ; **FLOATING
C2004 VDD.t355 VSS 0.03666f ; **FLOATING
C2005 VDD.n146 VSS 0.08755f ; **FLOATING
C2006 VDD.n147 VSS 0.01174f ; **FLOATING
C2007 VDD.t173 VSS 0.03289f ; **FLOATING
C2008 VDD.t350 VSS 0.033f ; **FLOATING
C2009 VDD.t342 VSS 0.03289f ; **FLOATING
C2010 VDD.n148 VSS 0.06891f ; **FLOATING
C2011 VDD.n149 VSS 0.01294f ; **FLOATING
C2012 VDD.t69 VSS 0.03289f ; **FLOATING
C2013 VDD.t182 VSS 0.03289f ; **FLOATING
C2014 VDD.t208 VSS 0.03289f ; **FLOATING
C2015 VDD.t244 VSS 0.02953f ; **FLOATING
C2016 VDD.t192 VSS 0.02953f ; **FLOATING
C2017 VDD.t235 VSS 0.03289f ; **FLOATING
C2018 VDD.t409 VSS 0.10909f ; **FLOATING
C2019 VDD.t243 VSS 0.03171f ; **FLOATING
C2020 VDD.t136 VSS 0.04317f ; **FLOATING
C2021 VDD.t408 VSS 0.10909f ; **FLOATING
C2022 VDD.t164 VSS 0.03171f ; **FLOATING
C2023 VDD.t50 VSS 0.03289f ; **FLOATING
C2024 VDD.t165 VSS 0.02953f ; **FLOATING
C2025 VDD.t166 VSS 0.02953f ; **FLOATING
C2026 VDD.t169 VSS 0.02953f ; **FLOATING
C2027 VDD.t219 VSS 0.03289f ; **FLOATING
C2028 VDD.t73 VSS 0.03289f ; **FLOATING
C2029 VDD.t46 VSS 0.03289f ; **FLOATING
C2030 VDD.t388 VSS 0.03289f ; **FLOATING
C2031 VDD.t91 VSS 0.02953f ; **FLOATING
C2032 VDD.t119 VSS 0.04317f ; **FLOATING
C2033 VDD.t268 VSS 0.03289f ; **FLOATING
C2034 VDD.t191 VSS 0.02953f ; **FLOATING
C2035 VDD.t114 VSS 0.03289f ; **FLOATING
C2036 VDD.t391 VSS 0.02953f ; **FLOATING
C2037 VDD.t275 VSS 0.03289f ; **FLOATING
C2038 VDD.t108 VSS 0.02953f ; **FLOATING
C2039 VDD.t109 VSS 0.02953f ; **FLOATING
C2040 VDD.t117 VSS 0.04333f ; **FLOATING
C2041 VDD.t199 VSS 0.03289f ; **FLOATING
C2042 VDD.t112 VSS 0.02953f ; **FLOATING
C2043 VDD.t220 VSS 0.03289f ; **FLOATING
C2044 VDD.t135 VSS 0.03289f ; **FLOATING
C2045 VDD.t309 VSS 0.03289f ; **FLOATING
C2046 VDD.t126 VSS 0.02953f ; **FLOATING
C2047 VDD.t221 VSS 0.04317f ; **FLOATING
C2048 VDD.t2 VSS 0.02953f ; **FLOATING
C2049 VDD.t7 VSS 0.03289f ; **FLOATING
C2050 VDD.t51 VSS 0.02953f ; **FLOATING
C2051 VDD.t141 VSS 0.03289f ; **FLOATING
C2052 VDD.t382 VSS 0.03289f ; **FLOATING
C2053 VDD.t175 VSS 0.02953f ; **FLOATING
C2054 VDD.t176 VSS 0.02953f ; **FLOATING
C2055 VDD.t179 VSS 0.02953f ; **FLOATING
C2056 VDD.t385 VSS 0.03289f ; **FLOATING
C2057 VDD.t254 VSS 0.03289f ; **FLOATING
C2058 VDD.t200 VSS 0.03289f ; **FLOATING
C2059 VDD.t4 VSS 0.03289f ; **FLOATING
C2060 VDD.t336 VSS 0.04317f ; **FLOATING
C2061 VDD.t128 VSS 0.03289f ; **FLOATING
C2062 VDD.t181 VSS 0.03289f ; **FLOATING
C2063 VDD.t259 VSS 0.03289f ; **FLOATING
C2064 VDD.t242 VSS 0.03289f ; **FLOATING
C2065 VDD.t240 VSS 0.03492f ; **FLOATING
C2066 VDD.t43 VSS 0.04317f ; **FLOATING
C2067 VDD.t241 VSS 0.06167f ; **FLOATING
C2068 VDD.t94 VSS 0.03289f ; **FLOATING
C2069 VDD.t376 VSS 0.03289f ; **FLOATING
C2070 VDD.t183 VSS 0.03289f ; **FLOATING
C2071 VDD.t387 VSS 0.03289f ; **FLOATING
C2072 VDD.t103 VSS 0.02953f ; **FLOATING
C2073 VDD.t62 VSS 0.04317f ; **FLOATING
C2074 VDD.t197 VSS 0.03289f ; **FLOATING
C2075 VDD.t211 VSS 0.02953f ; **FLOATING
C2076 VDD.t134 VSS 0.03289f ; **FLOATING
C2077 VDD.t204 VSS 0.02953f ; **FLOATING
C2078 VDD.t270 VSS 0.03289f ; **FLOATING
C2079 VDD.t262 VSS 0.02953f ; **FLOATING
C2080 VDD.t263 VSS 0.02953f ; **FLOATING
C2081 VDD.t146 VSS 0.04333f ; **FLOATING
C2082 VDD.t64 VSS 0.03289f ; **FLOATING
C2083 VDD.t266 VSS 0.02953f ; **FLOATING
C2084 VDD.t357 VSS 0.03289f ; **FLOATING
C2085 VDD.t47 VSS 0.03289f ; **FLOATING
C2086 VDD.t267 VSS 0.03289f ; **FLOATING
C2087 VDD.t247 VSS 0.02953f ; **FLOATING
C2088 VDD.t206 VSS 0.04317f ; **FLOATING
C2089 VDD.t250 VSS 0.02953f ; **FLOATING
C2090 VDD.t72 VSS 0.03289f ; **FLOATING
C2091 VDD.t214 VSS 0.02953f ; **FLOATING
C2092 VDD.t101 VSS 0.03289f ; **FLOATING
C2093 VDD.t383 VSS 0.03289f ; **FLOATING
C2094 VDD.t54 VSS 0.02953f ; **FLOATING
C2095 VDD.t55 VSS 0.02953f ; **FLOATING
C2096 VDD.t58 VSS 0.02953f ; **FLOATING
C2097 VDD.t386 VSS 0.03289f ; **FLOATING
C2098 VDD.t226 VSS 0.03289f ; **FLOATING
C2099 VDD.t212 VSS 0.03289f ; **FLOATING
C2100 VDD.t5 VSS 0.03289f ; **FLOATING
C2101 VDD.t245 VSS 0.02953f ; **FLOATING
C2102 VDD.t153 VSS 0.04317f ; **FLOATING
C2103 VDD.t129 VSS 0.03289f ; **FLOATING
C2104 VDD.t217 VSS 0.02953f ; **FLOATING
C2105 VDD.t257 VSS 0.03289f ; **FLOATING
C2106 VDD.t213 VSS 0.02953f ; **FLOATING
C2107 VDD.t131 VSS 0.03289f ; **FLOATING
C2108 VDD.t159 VSS 0.02953f ; **FLOATING
C2109 VDD.t160 VSS 0.02953f ; **FLOATING
C2110 VDD.t148 VSS 0.04333f ; **FLOATING
C2111 VDD.t59 VSS 0.03289f ; **FLOATING
C2112 VDD.t163 VSS 0.02953f ; **FLOATING
C2113 VDD.t215 VSS 0.03289f ; **FLOATING
C2114 VDD.t343 VSS 0.03289f ; **FLOATING
C2115 VDD.t218 VSS 0.03289f ; **FLOATING
C2116 VDD.t122 VSS 0.04317f ; **FLOATING
C2117 VDD.t6 VSS 0.03955f ; **FLOATING
C2118 VDD.t392 VSS 0.10909f ; **FLOATING
C2119 VDD.t161 VSS 0.03171f ; **FLOATING
C2120 VDD.t393 VSS 0.10909f ; **FLOATING
C2121 VDD.t158 VSS 0.03171f ; **FLOATING
C2122 VDD.t394 VSS 0.10909f ; **FLOATING
C2123 VDD.t216 VSS 0.03171f ; **FLOATING
C2124 VDD.t144 VSS 0.04333f ; **FLOATING
C2125 VDD.t395 VSS 0.10909f ; **FLOATING
C2126 VDD.t56 VSS 0.03171f ; **FLOATING
C2127 VDD.t396 VSS 0.10909f ; **FLOATING
C2128 VDD.t53 VSS 0.03171f ; **FLOATING
C2129 VDD.t397 VSS 0.10909f ; **FLOATING
C2130 VDD.t248 VSS 0.03171f ; **FLOATING
C2131 VDD.t398 VSS 0.10909f ; **FLOATING
C2132 VDD.t264 VSS 0.03171f ; **FLOATING
C2133 VDD.t399 VSS 0.10909f ; **FLOATING
C2134 VDD.t205 VSS 0.03171f ; **FLOATING
C2135 VDD.t400 VSS 0.10909f ; **FLOATING
C2136 VDD.t104 VSS 0.03171f ; **FLOATING
C2137 VDD.n150 VSS 0.06197f ; **FLOATING
C2138 VDD.n151 VSS 0.01294f ; **FLOATING
C2139 VDD.n152 VSS 0.07327f ; **FLOATING
C2140 VDD.n153 VSS 0.01109f ; **FLOATING
C2141 VDD.n154 VSS 0.06463f ; **FLOATING
C2142 VDD.n155 VSS 0.01294f ; **FLOATING
C2143 VDD.n156 VSS 0.0797f ; **FLOATING
C2144 VDD.t66 VSS 0.04333f ; **FLOATING
C2145 VDD.t401 VSS 0.10909f ; **FLOATING
C2146 VDD.t177 VSS 0.03171f ; **FLOATING
C2147 VDD.t402 VSS 0.10909f ; **FLOATING
C2148 VDD.t52 VSS 0.03171f ; **FLOATING
C2149 VDD.t403 VSS 0.10909f ; **FLOATING
C2150 VDD.t1 VSS 0.03171f ; **FLOATING
C2151 VDD.t404 VSS 0.10909f ; **FLOATING
C2152 VDD.t110 VSS 0.03171f ; **FLOATING
C2153 VDD.t405 VSS 0.10909f ; **FLOATING
C2154 VDD.t107 VSS 0.03171f ; **FLOATING
C2155 VDD.t406 VSS 0.10909f ; **FLOATING
C2156 VDD.t92 VSS 0.03171f ; **FLOATING
C2157 VDD.t157 VSS 0.04333f ; **FLOATING
C2158 VDD.t407 VSS 0.10909f ; **FLOATING
C2159 VDD.t167 VSS 0.03171f ; **FLOATING
C2160 VDD.t37 VSS 0.06665f ; **FLOATING
C2161 VDD.n157 VSS 0.04822f ; **FLOATING
C2162 VDD.n158 VSS 0.04822f ; **FLOATING
C2163 VDD.n159 VSS 0.04822f ; **FLOATING
C2164 VDD.n160 VSS 0.04822f ; **FLOATING
C2165 VDD.n161 VSS 0.04822f ; **FLOATING
C2166 VDD.n162 VSS 0.04831f ; **FLOATING
C2167 VDD.n163 VSS 0.04822f ; **FLOATING
C2168 VDD.n164 VSS 0.04822f ; **FLOATING
C2169 VDD.n165 VSS 0.04822f ; **FLOATING
C2170 VDD.n166 VSS 0.04831f ; **FLOATING
C2171 VDD.n167 VSS 0.04831f ; **FLOATING
C2172 VDD.n168 VSS 0.04822f ; **FLOATING
C2173 VDD.n169 VSS 0.04822f ; **FLOATING
C2174 VDD.n170 VSS 0.04831f ; **FLOATING
C2175 VDD.n171 VSS 0.04822f ; **FLOATING
C2176 VDD.n172 VSS 0.04822f ; **FLOATING
C2177 VDD.n173 VSS 0.04822f ; **FLOATING
C2178 VDD.n174 VSS 0.04822f ; **FLOATING
C2179 VDD.n175 VSS 0.04822f ; **FLOATING
C2180 VDD.n176 VSS 0.04831f ; **FLOATING
C2181 VDD.n177 VSS 0.04822f ; **FLOATING
C2182 VDD.n178 VSS 0.04822f ; **FLOATING
C2183 VDD.n179 VSS 0.04822f ; **FLOATING
C2184 VDD.n180 VSS 0.04822f ; **FLOATING
C2185 VDD.n181 VSS 0.04822f ; **FLOATING
C2186 VDD.n182 VSS 0.04822f ; **FLOATING
C2187 VDD.n183 VSS 0.04822f ; **FLOATING
C2188 VDD.n184 VSS 0.04831f ; **FLOATING
C2189 VDD.n185 VSS 0.04822f ; **FLOATING
C2190 VDD.n186 VSS 0.04822f ; **FLOATING
C2191 VDD.n187 VSS 0.04831f ; **FLOATING
C2192 VDD.t33 VSS 0.03228f ; **FLOATING
C2193 VDD.t32 VSS 0.02302f ; **FLOATING
C2194 VDD.t36 VSS 0.03215f ; **FLOATING
C2195 VDD.t34 VSS 0.03551f ; **FLOATING
C2196 VDD.t35 VSS 0.01868f ; **FLOATING
C2197 VDD.t288 VSS 0.03177f ; **FLOATING
C2198 VDD.n188 VSS 0.09618f ; **FLOATING
C2199 VDD.n189 VSS 0.02356f ; **FLOATING
C2200 VDD.n190 VSS 0.07471f ; **FLOATING
C2201 VDD.n191 VSS 0.01379f ; **FLOATING
C2202 VDD.t127 VSS 0.03726f ; **FLOATING
C2203 VDD.n192 VSS 0.07761f ; **FLOATING
C2204 VDD.n193 VSS 0.034f ; **FLOATING
C2205 VDD.t282 VSS 0.03177f ; **FLOATING
C2206 VDD.n194 VSS 0.10441f ; **FLOATING
C2207 VDD.n195 VSS 0.02356f ; **FLOATING
C2208 VDD.n196 VSS 0.05906f ; **FLOATING
C2209 VDD.n197 VSS 0.01379f ; **FLOATING
C2210 VDD.t70 VSS 0.03726f ; **FLOATING
C2211 VDD.n198 VSS 0.07761f ; **FLOATING
C2212 VDD.n199 VSS 0.034f ; **FLOATING
C2213 VDD.t277 VSS 0.03177f ; **FLOATING
C2214 VDD.n200 VSS 0.10447f ; **FLOATING
C2215 VDD.n201 VSS 0.02356f ; **FLOATING
C2216 VDD.n202 VSS 0.05907f ; **FLOATING
C2217 VDD.n203 VSS 0.01381f ; **FLOATING
C2218 VDD.t71 VSS 0.03726f ; **FLOATING
C2219 VDD.n204 VSS 0.07756f ; **FLOATING
C2220 VDD.n205 VSS 0.03402f ; **FLOATING
C2221 VDD.t291 VSS 0.03177f ; **FLOATING
C2222 VDD.n206 VSS 0.10444f ; **FLOATING
C2223 VDD.n207 VSS 0.02356f ; **FLOATING
C2224 VDD.n208 VSS 0.05906f ; **FLOATING
C2225 VDD.n209 VSS 0.01379f ; **FLOATING
C2226 VDD.t236 VSS 0.03726f ; **FLOATING
C2227 VDD.n210 VSS 0.07759f ; **FLOATING
C2228 VDD.n211 VSS 0.03407f ; **FLOATING
C2229 VDD.t279 VSS 0.03177f ; **FLOATING
C2230 VDD.n212 VSS 0.10441f ; **FLOATING
C2231 VDD.n213 VSS 0.02356f ; **FLOATING
C2232 VDD.n214 VSS 0.05902f ; **FLOATING
C2233 VDD.n215 VSS 0.01379f ; **FLOATING
C2234 VDD.t185 VSS 0.03726f ; **FLOATING
C2235 VDD.n216 VSS 0.07761f ; **FLOATING
C2236 VDD.n217 VSS 0.034f ; **FLOATING
C2237 VDD.t289 VSS 0.03177f ; **FLOATING
C2238 VDD.n218 VSS 0.10447f ; **FLOATING
C2239 VDD.n219 VSS 0.02356f ; **FLOATING
C2240 VDD.n220 VSS 0.05906f ; **FLOATING
C2241 VDD.n221 VSS 0.01379f ; **FLOATING
C2242 VDD.t45 VSS 0.03726f ; **FLOATING
C2243 VDD.n222 VSS 0.07762f ; **FLOATING
C2244 VDD.n223 VSS 0.03401f ; **FLOATING
C2245 VDD.t292 VSS 0.03177f ; **FLOATING
C2246 VDD.n224 VSS 0.10447f ; **FLOATING
C2247 VDD.n225 VSS 0.02356f ; **FLOATING
C2248 VDD.n226 VSS 0.05906f ; **FLOATING
C2249 VDD.n227 VSS 0.01381f ; **FLOATING
C2250 VDD.t118 VSS 0.03726f ; **FLOATING
C2251 VDD.n228 VSS 0.07758f ; **FLOATING
C2252 VDD.n229 VSS 0.034f ; **FLOATING
C2253 VDD.t293 VSS 0.03177f ; **FLOATING
C2254 VDD.n230 VSS 0.10447f ; **FLOATING
C2255 VDD.n231 VSS 0.02356f ; **FLOATING
C2256 VDD.n232 VSS 0.05906f ; **FLOATING
C2257 VDD.n233 VSS 0.01379f ; **FLOATING
C2258 VDD.t115 VSS 0.03726f ; **FLOATING
C2259 VDD.n234 VSS 0.07761f ; **FLOATING
C2260 VDD.n235 VSS 0.03403f ; **FLOATING
C2261 VDD.t286 VSS 0.03177f ; **FLOATING
C2262 VDD.n236 VSS 0.10447f ; **FLOATING
C2263 VDD.n237 VSS 0.02356f ; **FLOATING
C2264 VDD.n238 VSS 0.05903f ; **FLOATING
C2265 VDD.n239 VSS 0.01379f ; **FLOATING
C2266 VDD.t116 VSS 0.03726f ; **FLOATING
C2267 VDD.n240 VSS 0.07761f ; **FLOATING
C2268 VDD.n241 VSS 0.03396f ; **FLOATING
C2269 VDD.t294 VSS 0.03177f ; **FLOATING
C2270 VDD.n242 VSS 0.10447f ; **FLOATING
C2271 VDD.n243 VSS 0.02356f ; **FLOATING
C2272 VDD.n244 VSS 0.0591f ; **FLOATING
C2273 VDD.n245 VSS 0.01379f ; **FLOATING
C2274 VDD.t102 VSS 0.03726f ; **FLOATING
C2275 VDD.n246 VSS 0.07763f ; **FLOATING
C2276 VDD.n247 VSS 0.03397f ; **FLOATING
C2277 VDD.t281 VSS 0.03177f ; **FLOATING
C2278 VDD.n248 VSS 0.10447f ; **FLOATING
C2279 VDD.n249 VSS 0.02356f ; **FLOATING
C2280 VDD.n250 VSS 0.05907f ; **FLOATING
C2281 VDD.n251 VSS 0.01379f ; **FLOATING
C2282 VDD.t172 VSS 0.03726f ; **FLOATING
C2283 VDD.n252 VSS 0.07762f ; **FLOATING
C2284 VDD.n253 VSS 0.03399f ; **FLOATING
C2285 VDD.t297 VSS 0.03177f ; **FLOATING
C2286 VDD.n254 VSS 0.10444f ; **FLOATING
C2287 VDD.n255 VSS 0.02356f ; **FLOATING
C2288 VDD.n256 VSS 0.05907f ; **FLOATING
C2289 VDD.n257 VSS 0.01381f ; **FLOATING
C2290 VDD.t140 VSS 0.03726f ; **FLOATING
C2291 VDD.n258 VSS 0.07757f ; **FLOATING
C2292 VDD.n259 VSS 0.03402f ; **FLOATING
C2293 VDD.t287 VSS 0.03177f ; **FLOATING
C2294 VDD.n260 VSS 0.10441f ; **FLOATING
C2295 VDD.n261 VSS 0.02356f ; **FLOATING
C2296 VDD.n262 VSS 0.05905f ; **FLOATING
C2297 VDD.n263 VSS 0.01379f ; **FLOATING
C2298 VDD.t65 VSS 0.03726f ; **FLOATING
C2299 VDD.n264 VSS 0.07761f ; **FLOATING
C2300 VDD.n265 VSS 0.034f ; **FLOATING
C2301 VDD.t278 VSS 0.03177f ; **FLOATING
C2302 VDD.n266 VSS 0.10447f ; **FLOATING
C2303 VDD.n267 VSS 0.02356f ; **FLOATING
C2304 VDD.n268 VSS 0.05907f ; **FLOATING
C2305 VDD.n269 VSS 0.01381f ; **FLOATING
C2306 VDD.t253 VSS 0.03726f ; **FLOATING
C2307 VDD.n270 VSS 0.07758f ; **FLOATING
C2308 VDD.n271 VSS 0.03403f ; **FLOATING
C2309 VDD.t280 VSS 0.03177f ; **FLOATING
C2310 VDD.n272 VSS 0.10447f ; **FLOATING
C2311 VDD.n273 VSS 0.02356f ; **FLOATING
C2312 VDD.n274 VSS 0.05904f ; **FLOATING
C2313 VDD.n275 VSS 0.01381f ; **FLOATING
C2314 VDD.t252 VSS 0.03726f ; **FLOATING
C2315 VDD.n276 VSS 0.07761f ; **FLOATING
C2316 VDD.n277 VSS 0.03397f ; **FLOATING
C2317 VDD.t299 VSS 0.03177f ; **FLOATING
C2318 VDD.n278 VSS 0.10447f ; **FLOATING
C2319 VDD.n279 VSS 0.02356f ; **FLOATING
C2320 VDD.n280 VSS 0.05908f ; **FLOATING
C2321 VDD.n281 VSS 0.01381f ; **FLOATING
C2322 VDD.t180 VSS 0.03726f ; **FLOATING
C2323 VDD.n282 VSS 0.07758f ; **FLOATING
C2324 VDD.n283 VSS 0.034f ; **FLOATING
C2325 VDD.t298 VSS 0.03177f ; **FLOATING
C2326 VDD.n284 VSS 0.10447f ; **FLOATING
C2327 VDD.n285 VSS 0.02356f ; **FLOATING
C2328 VDD.n286 VSS 0.05906f ; **FLOATING
C2329 VDD.n287 VSS 0.01379f ; **FLOATING
C2330 VDD.t334 VSS 0.03726f ; **FLOATING
C2331 VDD.n288 VSS 0.07761f ; **FLOATING
C2332 VDD.n289 VSS 0.03396f ; **FLOATING
C2333 VDD.t300 VSS 0.03177f ; **FLOATING
C2334 VDD.n290 VSS 0.10444f ; **FLOATING
C2335 VDD.n291 VSS 0.02356f ; **FLOATING
C2336 VDD.n292 VSS 0.05911f ; **FLOATING
C2337 VDD.n293 VSS 0.01381f ; **FLOATING
C2338 VDD.t67 VSS 0.03726f ; **FLOATING
C2339 VDD.n294 VSS 0.07758f ; **FLOATING
C2340 VDD.n295 VSS 0.03403f ; **FLOATING
C2341 VDD.t276 VSS 0.03177f ; **FLOATING
C2342 VDD.n296 VSS 0.10441f ; **FLOATING
C2343 VDD.n297 VSS 0.02356f ; **FLOATING
C2344 VDD.n298 VSS 0.05904f ; **FLOATING
C2345 VDD.n299 VSS 0.01381f ; **FLOATING
C2346 VDD.t61 VSS 0.03726f ; **FLOATING
C2347 VDD.n300 VSS 0.07756f ; **FLOATING
C2348 VDD.n301 VSS 0.03404f ; **FLOATING
C2349 VDD.t301 VSS 0.03177f ; **FLOATING
C2350 VDD.n302 VSS 0.10447f ; **FLOATING
C2351 VDD.n303 VSS 0.02356f ; **FLOATING
C2352 VDD.n304 VSS 0.05906f ; **FLOATING
C2353 VDD.n305 VSS 0.01381f ; **FLOATING
C2354 VDD.t133 VSS 0.03726f ; **FLOATING
C2355 VDD.n306 VSS 0.07758f ; **FLOATING
C2356 VDD.n307 VSS 0.03403f ; **FLOATING
C2357 VDD.t302 VSS 0.03177f ; **FLOATING
C2358 VDD.n308 VSS 0.10444f ; **FLOATING
C2359 VDD.n309 VSS 0.02356f ; **FLOATING
C2360 VDD.n310 VSS 0.05903f ; **FLOATING
C2361 VDD.n311 VSS 0.01379f ; **FLOATING
C2362 VDD.t120 VSS 0.03726f ; **FLOATING
C2363 VDD.n312 VSS 0.07758f ; **FLOATING
C2364 VDD.n313 VSS 0.03404f ; **FLOATING
C2365 VDD.t296 VSS 0.03177f ; **FLOATING
C2366 VDD.n314 VSS 0.10438f ; **FLOATING
C2367 VDD.n315 VSS 0.02356f ; **FLOATING
C2368 VDD.n316 VSS 0.05906f ; **FLOATING
C2369 VDD.n317 VSS 0.01381f ; **FLOATING
C2370 VDD.t63 VSS 0.03726f ; **FLOATING
C2371 VDD.n318 VSS 0.07759f ; **FLOATING
C2372 VDD.n319 VSS 0.03396f ; **FLOATING
C2373 VDD.t284 VSS 0.03177f ; **FLOATING
C2374 VDD.n320 VSS 0.10441f ; **FLOATING
C2375 VDD.n321 VSS 0.02356f ; **FLOATING
C2376 VDD.n322 VSS 0.05911f ; **FLOATING
C2377 VDD.n323 VSS 0.01381f ; **FLOATING
C2378 VDD.t360 VSS 0.03726f ; **FLOATING
C2379 VDD.n324 VSS 0.07758f ; **FLOATING
C2380 VDD.n325 VSS 0.034f ; **FLOATING
C2381 VDD.t283 VSS 0.03177f ; **FLOATING
C2382 VDD.n326 VSS 0.10447f ; **FLOATING
C2383 VDD.n327 VSS 0.02356f ; **FLOATING
C2384 VDD.n328 VSS 0.05907f ; **FLOATING
C2385 VDD.n329 VSS 0.01381f ; **FLOATING
C2386 VDD.t100 VSS 0.03726f ; **FLOATING
C2387 VDD.n330 VSS 0.07758f ; **FLOATING
C2388 VDD.n331 VSS 0.03403f ; **FLOATING
C2389 VDD.t285 VSS 0.03177f ; **FLOATING
C2390 VDD.n332 VSS 0.10447f ; **FLOATING
C2391 VDD.n333 VSS 0.02356f ; **FLOATING
C2392 VDD.n334 VSS 0.05904f ; **FLOATING
C2393 VDD.n335 VSS 0.01381f ; **FLOATING
C2394 VDD.t170 VSS 0.03726f ; **FLOATING
C2395 VDD.n336 VSS 0.07759f ; **FLOATING
C2396 VDD.n337 VSS 0.03396f ; **FLOATING
C2397 VDD.t305 VSS 0.03177f ; **FLOATING
C2398 VDD.n338 VSS 0.10444f ; **FLOATING
C2399 VDD.n339 VSS 0.02356f ; **FLOATING
C2400 VDD.n340 VSS 0.05911f ; **FLOATING
C2401 VDD.n341 VSS 0.01381f ; **FLOATING
C2402 VDD.t156 VSS 0.03726f ; **FLOATING
C2403 VDD.n342 VSS 0.07758f ; **FLOATING
C2404 VDD.n343 VSS 0.034f ; **FLOATING
C2405 VDD.t304 VSS 0.03177f ; **FLOATING
C2406 VDD.n344 VSS 0.10441f ; **FLOATING
C2407 VDD.n345 VSS 0.02356f ; **FLOATING
C2408 VDD.n346 VSS 0.05906f ; **FLOATING
C2409 VDD.n347 VSS 0.01379f ; **FLOATING
C2410 VDD.t130 VSS 0.03726f ; **FLOATING
C2411 VDD.n348 VSS 0.07762f ; **FLOATING
C2412 VDD.n349 VSS 0.03401f ; **FLOATING
C2413 VDD.t303 VSS 0.03177f ; **FLOATING
C2414 VDD.n350 VSS 0.10447f ; **FLOATING
C2415 VDD.n351 VSS 0.02356f ; **FLOATING
C2416 VDD.n352 VSS 0.05905f ; **FLOATING
C2417 VDD.n353 VSS 0.01381f ; **FLOATING
C2418 VDD.t239 VSS 0.03726f ; **FLOATING
C2419 VDD.n354 VSS 0.0776f ; **FLOATING
C2420 VDD.n355 VSS 0.03399f ; **FLOATING
C2421 VDD.t295 VSS 0.03177f ; **FLOATING
C2422 VDD.n356 VSS 0.10447f ; **FLOATING
C2423 VDD.n357 VSS 0.02356f ; **FLOATING
C2424 VDD.n358 VSS 0.05906f ; **FLOATING
C2425 VDD.n359 VSS 0.01379f ; **FLOATING
C2426 VDD.t93 VSS 0.03726f ; **FLOATING
C2427 VDD.n360 VSS 0.07761f ; **FLOATING
C2428 VDD.n361 VSS 0.034f ; **FLOATING
C2429 VDD.t306 VSS 0.03177f ; **FLOATING
C2430 VDD.n362 VSS 0.10447f ; **FLOATING
C2431 VDD.n363 VSS 0.02356f ; **FLOATING
C2432 VDD.n364 VSS 0.05906f ; **FLOATING
C2433 VDD.n365 VSS 0.01379f ; **FLOATING
C2434 VDD.t60 VSS 0.03726f ; **FLOATING
C2435 VDD.n366 VSS 0.07761f ; **FLOATING
C2436 VDD.n367 VSS 0.03396f ; **FLOATING
C2437 VDD.t307 VSS 0.03177f ; **FLOATING
C2438 VDD.n368 VSS 0.10447f ; **FLOATING
C2439 VDD.n369 VSS 0.02356f ; **FLOATING
C2440 VDD.n370 VSS 0.05911f ; **FLOATING
C2441 VDD.n371 VSS 0.01381f ; **FLOATING
C2442 VDD.t121 VSS 0.03726f ; **FLOATING
C2443 VDD.n372 VSS 0.07757f ; **FLOATING
C2444 VDD.n373 VSS 0.03402f ; **FLOATING
C2445 VDD.t308 VSS 0.03177f ; **FLOATING
C2446 VDD.n374 VSS 0.08647f ; **FLOATING
C2447 VDD.n375 VSS 0.02356f ; **FLOATING
C2448 VDD.n376 VSS 0.05906f ; **FLOATING
C2449 VDD.n377 VSS 0.01381f ; **FLOATING
C2450 VDD.t99 VSS 0.03726f ; **FLOATING
C2451 VDD.n378 VSS 0.05914f ; **FLOATING
C2452 VDD.n379 VSS 0.01422f ; **FLOATING
C2453 VDD.t38 VSS 0.03177f ; **FLOATING
C2454 VDD.n380 VSS 0.02356f ; **FLOATING
C2455 VDD.t39 VSS 0.03551f ; **FLOATING
C2456 VDD.n381 VSS 0.06977f ; **FLOATING
C2457 VDD.t42 VSS 0.03177f ; **FLOATING
C2458 VDD.n382 VSS 0.02109f ; **FLOATING
C2459 VDD.t40 VSS 0.0307f ; **FLOATING
C2460 VDD.n383 VSS 0.01566f ; **FLOATING
C2461 VDD.n384 VSS 0.05922f ; **FLOATING
C2462 VDD.n385 VSS 0.05086f ; **FLOATING
C2463 VDD.n386 VSS 2.34917f ; **FLOATING
C2464 VDD.n387 VSS 0.70225f ; **FLOATING
C2465 VDD.n388 VSS 0.0296f ; **FLOATING
C2466 VDD.n389 VSS 0.01558f ; **FLOATING
C2467 VDD.n390 VSS 0.03575f ; **FLOATING
C2468 VDD.n391 VSS 0.03117f ; **FLOATING
C2469 VDD.n392 VSS 0.03566f ; **FLOATING
C2470 VDD.n393 VSS 0.03577f ; **FLOATING
C2471 VDD.n394 VSS 0.01573f ; **FLOATING
C2472 VDD.t326 VSS 0.0217f ; **FLOATING
C2473 VDD.n395 VSS 0.06126f ; **FLOATING
C2474 VDD.n396 VSS 0.01534f ; **FLOATING
C2475 VDD.n397 VSS 0.01559f ; **FLOATING
C2476 VDD.n398 VSS 0.06778f ; **FLOATING
C2477 VDD.t16 VSS 0.06341f ; **FLOATING
C2478 VDD.n399 VSS 0.02214f ; **FLOATING
C2479 VDD.n400 VSS 0.04962f ; **FLOATING
C2480 VDD.t11 VSS 0.05674f ; **FLOATING
C2481 VDD.n401 VSS 0.02212f ; **FLOATING
C2482 VDD.t17 VSS 0.05674f ; **FLOATING
C2483 VDD.n402 VSS 0.0635f ; **FLOATING
C2484 VDD.n403 VSS 0.02212f ; **FLOATING
C2485 VDD.n404 VSS 0.0448f ; **FLOATING
C2486 VDD.t8 VSS 0.35877f ; **FLOATING
C2487 VDD.n405 VSS 0.01448f ; **FLOATING
C2488 VDD.n406 VSS 0.04478f ; **FLOATING
C2489 VDD.t10 VSS 0.06341f ; **FLOATING
C2490 VDD.n407 VSS 0.02214f ; **FLOATING
C2491 VDD.n408 VSS 0.0678f ; **FLOATING
C2492 VDD.n409 VSS 0.03572f ; **FLOATING
C2493 VDD.n410 VSS 0.08624f ; **FLOATING
C2494 VDD.t84 VSS 0.06341f ; **FLOATING
C2495 VDD.n411 VSS 0.04114f ; **FLOATING
C2496 VDD.t77 VSS 0.06341f ; **FLOATING
C2497 VDD.n412 VSS 0.04115f ; **FLOATING
C2498 VDD.n413 VSS 0.0863f ; **FLOATING
C2499 VDD.n414 VSS 0.03108f ; **FLOATING
C2500 VDD.n415 VSS 0.08645f ; **FLOATING
C2501 VDD.t86 VSS 0.06341f ; **FLOATING
C2502 VDD.n416 VSS 0.04114f ; **FLOATING
C2503 VDD.t79 VSS 0.06341f ; **FLOATING
C2504 VDD.n417 VSS 0.04115f ; **FLOATING
C2505 VDD.n418 VSS 0.08651f ; **FLOATING
C2506 VDD.n419 VSS 0.03564f ; **FLOATING
C2507 VDD.n420 VSS 0.08167f ; **FLOATING
C2508 VDD.t88 VSS 0.06341f ; **FLOATING
C2509 VDD.n421 VSS 0.04114f ; **FLOATING
C2510 VDD.t81 VSS 0.06341f ; **FLOATING
C2511 VDD.n422 VSS 0.04115f ; **FLOATING
C2512 VDD.n423 VSS 0.08169f ; **FLOATING
C2513 VDD.n424 VSS 0.03573f ; **FLOATING
C2514 VDD.n425 VSS 0.01573f ; **FLOATING
C2515 VDD.t9 VSS 12.4896f ; **FLOATING
C2516 VDD.t14 VSS 0.05674f ; **FLOATING
C2517 VDD.t19 VSS 0.05674f ; **FLOATING
C2518 VDD.n426 VSS 0.06908f ; **FLOATING
C2519 VDD.n427 VSS 0.02212f ; **FLOATING
C2520 VDD.t13 VSS 0.06341f ; **FLOATING
C2521 VDD.n428 VSS 0.0678f ; **FLOATING
C2522 VDD.n429 VSS 0.02214f ; **FLOATING
C2523 VDD.n430 VSS 0.06777f ; **FLOATING
C2524 VDD.t20 VSS 0.06341f ; **FLOATING
C2525 VDD.n431 VSS 0.02214f ; **FLOATING
C2526 VDD.n432 VSS 0.04478f ; **FLOATING
C2527 VDD.t12 VSS 0.35877f ; **FLOATING
C2528 VDD.n433 VSS 0.01448f ; **FLOATING
C2529 VDD.n434 VSS 0.048f ; **FLOATING
C2530 VDD.n435 VSS 0.02212f ; **FLOATING
C2531 VDD.n436 VSS 0.08074f ; **FLOATING
C2532 VDD.n437 VSS 0.04702f ; **FLOATING
.ends
