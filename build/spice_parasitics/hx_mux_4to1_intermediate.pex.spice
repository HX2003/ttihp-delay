* NGSPICE file created from hx_mux_4to1_intermediate.ext - technology: ihp-sg13g2

.subckt hx_mux_4to1_intermediate MUX_ONEHOT_SEL0 MUX_ONEHOT_SEL1 MUX_ONEHOT_SEL2 MUX_ONEHOT_SEL3
+ MUX_OUT MUX_IN0 MUX_IN1 MUX_IN2 MUX_IN3 VDD VSS
X0 VDD VSS.t10 VDD VDD sg13_lv_pmos ad=0.19p pd=1.38u as=52.00497p ps=0.2193m w=1u l=1u
X1 VSS.t31 VDD VSS.t30 VSS.t29 sg13_lv_nmos ad=0.1428p pd=1.52u as=0 ps=0 w=0.42u l=1u
X2 VSS.t7 MUX_ONEHOT_SEL0 a_1621_392# VSS.t6 sg13_lv_nmos ad=0.2516p pd=2.16u as=0.2516p ps=2.16u w=0.74u l=0.13u
X3 VDD VSS.t46 VDD VDD sg13_lv_pmos ad=0.19p pd=1.38u as=0 ps=0 w=1u l=1u
X4 VSS.t2 MUX_ONEHOT_SEL3 a_10741_392# VSS.t1 sg13_lv_nmos ad=0.2516p pd=2.16u as=0.2516p ps=2.16u w=0.74u l=0.13u
X5 VSS.t27 VDD VSS.t27 VSS.t28 sg13_lv_nmos ad=79.8f pd=0.8u as=0 ps=0 w=0.42u l=1u
X6 VDD VSS.t9 VDD VDD sg13_lv_pmos ad=0.34p pd=2.68u as=0 ps=0 w=1u l=1u
X7 VSS.t27 VDD VSS.t26 VSS.t25 sg13_lv_nmos ad=0.1428p pd=1.52u as=0 ps=0 w=0.42u l=1u
X8 MUX_OUT MUX_ONEHOT_SEL2 MUX_IN2 VSS.t3 sg13_lv_nmos ad=0.2516p pd=2.16u as=0.2516p ps=2.16u w=0.74u l=0.13u
X9 VDD MUX_ONEHOT_SEL3 a_10741_392# VDD sg13_lv_pmos ad=0.3808p pd=2.92u as=0.3808p ps=2.92u w=1.12u l=0.13u
X10 MUX_OUT a_1621_392# MUX_IN0 VDD sg13_lv_pmos ad=0.3808p pd=2.92u as=0.3808p ps=2.92u w=1.12u l=0.13u
X11 VDD MUX_ONEHOT_SEL0 a_1621_392# VDD sg13_lv_pmos ad=0.3808p pd=2.92u as=0.3808p ps=2.92u w=1.12u l=0.13u
X12 MUX_OUT a_10741_392# MUX_IN3 VDD sg13_lv_pmos ad=0.3808p pd=2.92u as=0.3808p ps=2.92u w=1.12u l=0.13u
X13 VDD VSS.t27 VDD VDD sg13_lv_pmos ad=0.19p pd=1.38u as=0 ps=0 w=1u l=1u
X14 VDD VSS.t30 VDD VDD sg13_lv_pmos ad=0.34p pd=2.68u as=0 ps=0 w=1u l=1u
X15 VSS.t20 VDD VSS.t18 VSS.t19 sg13_lv_nmos ad=79.8f pd=0.8u as=0 ps=0 w=0.42u l=1u
X16 VDD VSS.t26 VDD VDD sg13_lv_pmos ad=0.34p pd=2.68u as=0 ps=0 w=1u l=1u
X17 VSS.t44 VDD VSS.t43 VSS.t42 sg13_lv_nmos ad=0.1428p pd=1.52u as=0 ps=0 w=0.42u l=1u
X18 VDD VSS.t20 VDD VDD sg13_lv_pmos ad=0.19p pd=1.38u as=0 ps=0 w=1u l=1u
X19 VSS.t49 MUX_ONEHOT_SEL1 a_4661_392# VSS.t48 sg13_lv_nmos ad=0.2516p pd=2.16u as=0.2516p ps=2.16u w=0.74u l=0.13u
X20 VSS.t40 VDD VSS.t40 VSS.t41 sg13_lv_nmos ad=79.8f pd=0.8u as=0 ps=0 w=0.42u l=1u
X21 MUX_OUT MUX_ONEHOT_SEL0 MUX_IN0 VSS.t1 sg13_lv_nmos ad=0.2516p pd=2.16u as=0.2516p ps=2.16u w=0.74u l=0.13u
X22 VSS.t40 VDD VSS.t39 VSS.t38 sg13_lv_nmos ad=0.1428p pd=1.52u as=0 ps=0 w=0.42u l=1u
X23 MUX_OUT MUX_ONEHOT_SEL3 MUX_IN3 VSS.t0 sg13_lv_nmos ad=0.2516p pd=2.16u as=0.2516p ps=2.16u w=0.74u l=0.13u
X24 MUX_OUT a_4661_392# MUX_IN1 VDD sg13_lv_pmos ad=0.3808p pd=2.92u as=0.3808p ps=2.92u w=1.12u l=0.13u
X25 VDD MUX_ONEHOT_SEL1 a_4661_392# VDD sg13_lv_pmos ad=0.3808p pd=2.92u as=0.3808p ps=2.92u w=1.12u l=0.13u
X26 VDD VSS.t40 VDD VDD sg13_lv_pmos ad=0.19p pd=1.38u as=0 ps=0 w=1u l=1u
X27 VDD VSS.t43 VDD VDD sg13_lv_pmos ad=0.34p pd=2.68u as=0 ps=0 w=1u l=1u
X28 VSS.t23 VDD VSS.t23 VSS.t24 sg13_lv_nmos ad=79.8f pd=0.8u as=0 ps=0 w=0.42u l=1u
X29 VSS.t23 VDD VSS.t22 VSS.t21 sg13_lv_nmos ad=0.1428p pd=1.52u as=0 ps=0 w=0.42u l=1u
X30 VDD VSS.t23 VDD VDD sg13_lv_pmos ad=0.19p pd=1.38u as=0 ps=0 w=1u l=1u
X31 VSS.t18 VDD VSS.t17 VSS.t16 sg13_lv_nmos ad=0.1428p pd=1.52u as=0 ps=0 w=0.42u l=1u
X32 VDD VSS.t39 VDD VDD sg13_lv_pmos ad=0.34p pd=2.68u as=0 ps=0 w=1u l=1u
X33 VSS.t14 VDD VSS.t14 VSS.t15 sg13_lv_nmos ad=79.8f pd=0.8u as=0 ps=0 w=0.42u l=1u
X34 VDD VSS.t22 VDD VDD sg13_lv_pmos ad=0.34p pd=2.68u as=0 ps=0 w=1u l=1u
X35 VSS.t14 VDD VSS.t13 VSS.t12 sg13_lv_nmos ad=0.1428p pd=1.52u as=0 ps=0 w=0.42u l=1u
X36 MUX_OUT MUX_ONEHOT_SEL1 MUX_IN1 VSS.t47 sg13_lv_nmos ad=0.2516p pd=2.16u as=0.2516p ps=2.16u w=0.74u l=0.13u
X37 VDD VSS.t14 VDD VDD sg13_lv_pmos ad=0.19p pd=1.38u as=0 ps=0 w=1u l=1u
X38 VDD VSS.t17 VDD VDD sg13_lv_pmos ad=0.34p pd=2.68u as=0 ps=0 w=1u l=1u
X39 VSS.t36 VDD VSS.t36 VSS.t37 sg13_lv_nmos ad=79.8f pd=0.8u as=0 ps=0 w=0.42u l=1u
X40 VSS.t33 VDD VSS.t31 VSS.t32 sg13_lv_nmos ad=79.8f pd=0.8u as=0 ps=0 w=0.42u l=1u
X41 VSS.t36 VDD VSS.t35 VSS.t34 sg13_lv_nmos ad=0.1428p pd=1.52u as=0 ps=0 w=0.42u l=1u
X42 VDD VSS.t13 VDD VDD sg13_lv_pmos ad=0.34p pd=2.68u as=0 ps=0 w=1u l=1u
X43 VDD VSS.t36 VDD VDD sg13_lv_pmos ad=0.19p pd=1.38u as=0 ps=0 w=1u l=1u
X44 VDD VSS.t33 VDD VDD sg13_lv_pmos ad=0.19p pd=1.38u as=0 ps=0 w=1u l=1u
X45 VSS.t5 MUX_ONEHOT_SEL2 a_7701_392# VSS.t4 sg13_lv_nmos ad=0.2516p pd=2.16u as=0.2516p ps=2.16u w=0.74u l=0.13u
X46 VDD VSS.t35 VDD VDD sg13_lv_pmos ad=0.34p pd=2.68u as=0 ps=0 w=1u l=1u
X47 VSS.t10 VDD VSS.t10 VSS.t11 sg13_lv_nmos ad=79.8f pd=0.8u as=0 ps=0 w=0.42u l=1u
X48 VDD MUX_ONEHOT_SEL2 a_7701_392# VDD sg13_lv_pmos ad=0.3808p pd=2.92u as=0.3808p ps=2.92u w=1.12u l=0.13u
X49 MUX_OUT a_7701_392# MUX_IN2 VDD sg13_lv_pmos ad=0.3808p pd=2.92u as=0.3808p ps=2.92u w=1.12u l=0.13u
X50 VSS.t10 VDD VSS.t9 VSS.t8 sg13_lv_nmos ad=0.1428p pd=1.52u as=0 ps=0 w=0.42u l=1u
X51 VSS.t46 VDD VSS.t44 VSS.t45 sg13_lv_nmos ad=79.8f pd=0.8u as=0 ps=0 w=0.42u l=1u
C0 VDD MUX_ONEHOT_SEL1 0.44766f
C1 MUX_OUT MUX_IN2 0.4238f
C2 MUX_ONEHOT_SEL2 MUX_OUT 0.04345f
C3 a_7701_392# MUX_OUT 0.2906f
C4 MUX_IN3 MUX_OUT 0.4238f
C5 VDD MUX_IN2 0.31117f
C6 MUX_IN3 a_10741_392# 0.01637f
C7 a_4661_392# MUX_IN1 0.01637f
C8 a_4661_392# MUX_OUT 0.2906f
C9 a_1621_392# MUX_IN0 0.01637f
C10 VDD MUX_ONEHOT_SEL2 0.44766f
C11 VDD a_7701_392# 0.30291f
C12 MUX_IN3 VDD 0.31532f
C13 a_4661_392# VDD 0.30291f
C14 MUX_IN0 MUX_OUT 0.42148f
C15 a_4661_392# MUX_ONEHOT_SEL1 0.13134f
C16 a_1621_392# MUX_OUT 0.29558f
C17 a_7701_392# MUX_IN2 0.01637f
C18 MUX_IN0 VDD 0.3137f
C19 MUX_IN1 MUX_OUT 0.4238f
C20 a_1621_392# MUX_ONEHOT_SEL0 0.13134f
C21 a_10741_392# MUX_OUT 0.27952f
C22 a_1621_392# VDD 0.30562f
C23 a_7701_392# MUX_ONEHOT_SEL2 0.13134f
C24 VDD MUX_IN1 0.31178f
C25 MUX_OUT MUX_ONEHOT_SEL0 0.03902f
C26 VDD MUX_OUT 1.8637f
C27 MUX_ONEHOT_SEL3 MUX_OUT 0.01733f
C28 VDD a_10741_392# 0.30361f
C29 a_10741_392# MUX_ONEHOT_SEL3 0.13134f
C30 MUX_ONEHOT_SEL1 MUX_OUT 0.04345f
C31 VDD MUX_ONEHOT_SEL0 0.4462f
C32 VDD MUX_ONEHOT_SEL3 0.44109f
R0 VSS.t48 VSS.t1 147.181
R1 VSS.t4 VSS.t1 147.181
R2 VSS.t11 VSS.t1 127.996
R3 VSS.t16 VSS.t1 60.4089
R4 VSS.t12 VSS.t1 71.4291
R5 VSS.t25 VSS.t1 71.4335
R6 VSS.t38 VSS.t1 71.429
R7 VSS.t32 VSS.t1 122.118
R8 VSS.t1 VSS.t45 122.118
R9 VSS.t1 VSS.t24 127.993
R10 VSS.t1 VSS.t37 127.993
R11 VSS.t8 VSS.t1 133.135
R12 VSS.t1 VSS.t21 133.136
R13 VSS.t1 VSS.t34 133.136
R14 VSS.t0 VSS.t1 139.468
R15 VSS.t3 VSS.t1 139.468
R16 VSS.t47 VSS.t1 139.468
R17 VSS.t1 VSS.t6 147.181
R18 VSS.t15 VSS.t1 148.562
R19 VSS.t1 VSS.t28 148.562
R20 VSS.t1 VSS.t41 148.56
R21 VSS.t1 VSS.t19 122.118
R22 VSS.t1 VSS.t29 60.4089
R23 VSS.t1 VSS.t42 60.4089
R24 VSS.t1 VSS.t39 5.65652
R25 VSS.t1 VSS.t5 2.79003
R26 VSS.t1 VSS.t26 5.65652
R27 VSS.t1 VSS.t49 2.79003
R28 VSS.t1 VSS.t13 5.65652
R29 VSS.t7 VSS.t1 2.79003
R30 VSS.n217 VSS.n61 9.14317
R31 VSS VSS.n217 9.0005
R32 VSS.n62 VSS.n5 9.0005
R33 VSS.n216 VSS.n215 9.0005
R34 VSS.n214 VSS.n58 9.0005
R35 VSS.n213 VSS.n212 9.0005
R36 VSS.n53 VSS.n76 9.0005
R37 VSS.n211 VSS.n210 9.0005
R38 VSS.n209 VSS.n50 9.0005
R39 VSS.n208 VSS.n207 9.0005
R40 VSS.n45 VSS.n77 9.0005
R41 VSS.n206 VSS.n205 9.0005
R42 VSS.n204 VSS.n78 9.0005
R43 VSS.n203 VSS.n202 9.0005
R44 VSS.n42 VSS.n79 9.0005
R45 VSS.n201 VSS.n200 9.0005
R46 VSS.n199 VSS.n33 9.0005
R47 VSS.n198 VSS.n197 9.0005
R48 VSS.n41 VSS.n80 9.0005
R49 VSS.n193 VSS.n192 9.0005
R50 VSS.n194 VSS.n81 9.0005
R51 VSS.n196 VSS.n195 9.0005
R52 VSS.n191 VSS.n64 9.0005
R53 VSS.n190 VSS.n189 9.0005
R54 VSS.n72 VSS.n82 9.0005
R55 VSS.n163 VSS.n83 9.0005
R56 VSS.n165 VSS.n164 9.0005
R57 VSS.n167 VSS.n166 9.0005
R58 VSS.n168 VSS.n162 9.0005
R59 VSS.n170 VSS.n169 9.0005
R60 VSS.n171 VSS.n161 9.0005
R61 VSS.n173 VSS.n172 9.0005
R62 VSS.n174 VSS.n160 9.0005
R63 VSS.n176 VSS.n175 9.0005
R64 VSS.n177 VSS.n158 9.0005
R65 VSS.n179 VSS.n178 9.0005
R66 VSS.n180 VSS.n157 9.0005
R67 VSS.n182 VSS.n181 9.0005
R68 VSS.n183 VSS.n156 9.0005
R69 VSS.n185 VSS.n184 9.0005
R70 VSS.n186 VSS.n84 9.0005
R71 VSS.n188 VSS.n187 9.0005
R72 VSS.n155 VSS.n65 9.0005
R73 VSS.n154 VSS.n153 9.0005
R74 VSS.n71 VSS.n85 9.0005
R75 VSS.n127 VSS.n86 9.0005
R76 VSS.n129 VSS.n128 9.0005
R77 VSS.n131 VSS.n130 9.0005
R78 VSS.n132 VSS.n126 9.0005
R79 VSS.n134 VSS.n133 9.0005
R80 VSS.n135 VSS.n125 9.0005
R81 VSS.n137 VSS.n136 9.0005
R82 VSS.n138 VSS.n124 9.0005
R83 VSS.n140 VSS.n139 9.0005
R84 VSS.n141 VSS.n122 9.0005
R85 VSS.n143 VSS.n142 9.0005
R86 VSS.n144 VSS.n121 9.0005
R87 VSS.n146 VSS.n145 9.0005
R88 VSS.n147 VSS.n120 9.0005
R89 VSS.n149 VSS.n148 9.0005
R90 VSS.n150 VSS.n87 9.0005
R91 VSS.n152 VSS.n151 9.0005
R92 VSS.n119 VSS.n66 9.0005
R93 VSS.n118 VSS.n117 9.0005
R94 VSS.n70 VSS.n88 9.0005
R95 VSS.n97 VSS.n89 9.0005
R96 VSS.n99 VSS.n98 9.0005
R97 VSS.n100 VSS.n96 9.0005
R98 VSS.n102 VSS.n101 9.0005
R99 VSS.n103 VSS.n95 9.0005
R100 VSS.n105 VSS.n104 9.0005
R101 VSS.n106 VSS.n93 9.0005
R102 VSS.n108 VSS.n107 9.0005
R103 VSS.n109 VSS.n92 9.0005
R104 VSS.n111 VSS.n110 9.0005
R105 VSS.n112 VSS.n91 9.0005
R106 VSS.n114 VSS.n113 9.0005
R107 VSS.n115 VSS.n90 9.0005
R108 VSS.n63 VSS.n62 9.0005
R109 VSS.n60 VSS.n216 9.0005
R110 VSS.n56 VSS.n58 9.0005
R111 VSS.n212 VSS.n57 9.0005
R112 VSS.n54 VSS.n53 9.0005
R113 VSS.n52 VSS.n211 9.0005
R114 VSS.n48 VSS.n50 9.0005
R115 VSS.n207 VSS.n49 9.0005
R116 VSS.n46 VSS.n45 9.0005
R117 VSS.n44 VSS.n206 9.0005
R118 VSS.n4 VSS.n78 9.0005
R119 VSS.n202 VSS.t7 9.0005
R120 VSS.n43 VSS.n42 9.0005
R121 VSS.t9 VSS.n201 9.0005
R122 VSS.t9 VSS.n34 4.44407
R123 VSS.n197 VSS.n34 0.114852
R124 VSS.t10 VSS.n26 4.44407
R125 VSS.n192 VSS.n26 0.114852
R126 VSS.n81 VSS.n3 0.114852
R127 VSS.t13 VSS.n3 4.44407
R128 VSS.t14 VSS.n64 9.0005
R129 VSS.n189 VSS.n36 0.114852
R130 VSS.t14 VSS.n36 4.44407
R131 VSS.t17 VSS.n67 4.44407
R132 VSS.n165 VSS.n67 0.114852
R133 VSS.n166 VSS.t18 9.0005
R134 VSS.n75 VSS.t20 4.44407
R135 VSS.n170 VSS.n75 0.114852
R136 VSS.n171 VSS.n40 9.0005
R137 VSS.n172 VSS.n39 9.0005
R138 VSS.n160 VSS.n159 9.0005
R139 VSS.n176 VSS.t49 9.0005
R140 VSS.n177 VSS.n31 9.0005
R141 VSS.n178 VSS.t22 9.0005
R142 VSS.n35 VSS.t22 4.44407
R143 VSS.n182 VSS.n35 0.114852
R144 VSS.n30 VSS.t23 4.44407
R145 VSS.n184 VSS.n30 0.114852
R146 VSS.n84 VSS.n2 0.114852
R147 VSS.t26 VSS.n2 4.44407
R148 VSS.t27 VSS.n65 9.0005
R149 VSS.n153 VSS.n37 0.114852
R150 VSS.t27 VSS.n37 4.44407
R151 VSS.t30 VSS.n68 4.44407
R152 VSS.n129 VSS.n68 0.114852
R153 VSS.n130 VSS.t31 9.0005
R154 VSS.n73 VSS.t33 4.44407
R155 VSS.n134 VSS.n73 0.114852
R156 VSS.n135 VSS.n24 9.0005
R157 VSS.n136 VSS.n22 9.0005
R158 VSS.n124 VSS.n123 9.0005
R159 VSS.n140 VSS.t5 9.0005
R160 VSS.n141 VSS.n18 9.0005
R161 VSS.n142 VSS.t35 9.0005
R162 VSS.n20 VSS.t35 4.44407
R163 VSS.n146 VSS.n20 0.114852
R164 VSS.n17 VSS.t36 4.44407
R165 VSS.n148 VSS.n17 0.114852
R166 VSS.n87 VSS.t39 9.0005
R167 VSS.t39 VSS.n25 4.44407
R168 VSS.n25 VSS.n66 0.114852
R169 VSS.n117 VSS.n21 0.114852
R170 VSS.t40 VSS.n21 4.44407
R171 VSS.t43 VSS.n69 4.44407
R172 VSS.n99 VSS.n69 0.114852
R173 VSS.n100 VSS.t44 9.0005
R174 VSS.n74 VSS.t46 4.44407
R175 VSS.n95 VSS.n74 0.114852
R176 VSS.n105 VSS.n15 9.0005
R177 VSS.n106 VSS.n13 9.0005
R178 VSS.n107 VSS.n94 9.0005
R179 VSS.n92 VSS.t2 9.0005
R180 VSS.n111 VSS.n11 9.0005
R181 VSS.n112 VSS.n12 9.0005
R182 VSS.n113 VSS.n8 9.0005
R183 VSS.n90 VSS.n9 9.0005
R184 VSS.n116 VSS.n6 9.0005
R185 VSS.t40 VSS.n16 0.0565081
R186 VSS.n32 VSS.t1 2.05901
R187 VSS.t14 VSS.n29 0.0565081
R188 VSS.t1 VSS.t44 2.77841
R189 VSS.t27 VSS.n28 0.0565081
R190 VSS.n7 VSS.n6 0.0953067
R191 VSS.t1 VSS.n7 4.19225
R192 VSS.n10 VSS.n8 0.0953067
R193 VSS.t1 VSS.n10 4.19225
R194 VSS.n14 VSS.n13 0.0953067
R195 VSS.t1 VSS.n14 4.19225
R196 VSS.t1 VSS.n16 1.22081
R197 VSS.n19 VSS.t36 0.168248
R198 VSS.t1 VSS.n19 2.05901
R199 VSS.n23 VSS.n22 0.0953067
R200 VSS.t1 VSS.n23 4.19225
R201 VSS.t1 VSS.n28 1.22081
R202 VSS.n32 VSS.t23 0.168248
R203 VSS.t1 VSS.n38 4.19225
R204 VSS.n38 VSS.n40 0.0953067
R205 VSS.t20 VSS.n40 0.159765
R206 VSS.t1 VSS.n29 1.22081
R207 VSS.n27 VSS.t10 0.168248
R208 VSS.n27 VSS.t1 2.05901
R209 VSS.n44 VSS.t1 8.47732
R210 VSS.n47 VSS.t1 4.19225
R211 VSS.n49 VSS.n47 0.0953067
R212 VSS.n51 VSS.t1 4.19225
R213 VSS.n52 VSS.n51 0.0953067
R214 VSS.n55 VSS.t1 4.19225
R215 VSS.n57 VSS.n55 0.0953067
R216 VSS.n59 VSS.t1 4.20399
R217 VSS.n60 VSS.n59 0.0718369
R218 VSS.n63 VSS.n61 0.0953067
R219 VSS.n61 VSS.t1 4.19225
R220 VSS.t1 VSS.t2 2.76687
R221 VSS.t1 VSS.t18 2.77818
R222 VSS.n1 VSS.n0 4.63378
R223 VSS.t1 VSS.t31 2.79329
R224 VSS.n1 VSS.n116 0.220682
R225 VSS.n16 VSS.t43 0.31686
R226 VSS.t30 VSS.n28 0.31686
R227 VSS.n29 VSS.t17 0.31686
R228 VSS.t10 VSS.t13 0.298382
R229 VSS.t23 VSS.t26 0.298382
R230 VSS.t36 VSS.t39 0.298382
R231 VSS.t22 VSS.n31 0.288306
R232 VSS.n43 VSS.t9 0.288306
R233 VSS.t35 VSS.n18 0.288306
R234 VSS.t31 VSS.t33 0.276457
R235 VSS.t44 VSS.t46 0.276452
R236 VSS.t27 VSS.t26 0.264748
R237 VSS.t13 VSS.t14 0.264748
R238 VSS.t39 VSS.t40 0.264748
R239 VSS.t18 VSS.t20 0.259934
R240 VSS.t49 VSS.n31 0.238571
R241 VSS.n43 VSS.t7 0.238571
R242 VSS.t5 VSS.n18 0.238571
R243 VSS.t2 VSS.n11 0.236406
R244 VSS.n215 VSS.n5 0.231121
R245 VSS.n215 VSS.n214 0.231121
R246 VSS.n214 VSS.n213 0.231121
R247 VSS.n213 VSS.n76 0.231121
R248 VSS.n210 VSS.n76 0.231121
R249 VSS.n210 VSS.n209 0.231121
R250 VSS.n209 VSS.n208 0.231121
R251 VSS.n208 VSS.n77 0.231121
R252 VSS.n205 VSS.n77 0.231121
R253 VSS.n205 VSS.n204 0.231121
R254 VSS.n204 VSS.n203 0.231121
R255 VSS.n203 VSS.n79 0.231121
R256 VSS.n200 VSS.n79 0.231121
R257 VSS.n200 VSS.n199 0.231121
R258 VSS.n199 VSS.n198 0.231121
R259 VSS.n198 VSS.n80 0.231121
R260 VSS.n193 VSS.n80 0.231121
R261 VSS.n194 VSS.n193 0.231121
R262 VSS.n195 VSS.n194 0.231121
R263 VSS.n195 VSS.n191 0.231121
R264 VSS.n191 VSS.n190 0.231121
R265 VSS.n190 VSS.n82 0.231121
R266 VSS.n163 VSS.n82 0.231121
R267 VSS.n164 VSS.n163 0.231121
R268 VSS.n167 VSS.n164 0.231121
R269 VSS.n168 VSS.n167 0.231121
R270 VSS.n169 VSS.n168 0.231121
R271 VSS.n169 VSS.n161 0.231121
R272 VSS.n173 VSS.n161 0.231121
R273 VSS.n174 VSS.n173 0.231121
R274 VSS.n175 VSS.n174 0.231121
R275 VSS.n175 VSS.n158 0.231121
R276 VSS.n179 VSS.n158 0.231121
R277 VSS.n180 VSS.n179 0.231121
R278 VSS.n181 VSS.n180 0.231121
R279 VSS.n181 VSS.n156 0.231121
R280 VSS.n185 VSS.n156 0.231121
R281 VSS.n186 VSS.n185 0.231121
R282 VSS.n187 VSS.n186 0.231121
R283 VSS.n187 VSS.n155 0.231121
R284 VSS.n155 VSS.n154 0.231121
R285 VSS.n154 VSS.n85 0.231121
R286 VSS.n127 VSS.n85 0.231121
R287 VSS.n128 VSS.n127 0.231121
R288 VSS.n131 VSS.n128 0.231121
R289 VSS.n132 VSS.n131 0.231121
R290 VSS.n133 VSS.n132 0.231121
R291 VSS.n133 VSS.n125 0.231121
R292 VSS.n137 VSS.n125 0.231121
R293 VSS.n138 VSS.n137 0.231121
R294 VSS.n139 VSS.n138 0.231121
R295 VSS.n139 VSS.n122 0.231121
R296 VSS.n143 VSS.n122 0.231121
R297 VSS.n144 VSS.n143 0.231121
R298 VSS.n145 VSS.n144 0.231121
R299 VSS.n145 VSS.n120 0.231121
R300 VSS.n149 VSS.n120 0.231121
R301 VSS.n150 VSS.n149 0.231121
R302 VSS.n151 VSS.n150 0.231121
R303 VSS.n151 VSS.n119 0.231121
R304 VSS.n119 VSS.n118 0.231121
R305 VSS.n118 VSS.n88 0.231121
R306 VSS.n97 VSS.n88 0.231121
R307 VSS.n98 VSS.n97 0.231121
R308 VSS.n98 VSS.n96 0.231121
R309 VSS.n102 VSS.n96 0.231121
R310 VSS.n103 VSS.n102 0.231121
R311 VSS.n104 VSS.n103 0.231121
R312 VSS.n104 VSS.n93 0.231121
R313 VSS.n108 VSS.n93 0.231121
R314 VSS.n109 VSS.n108 0.231121
R315 VSS.n110 VSS.n109 0.231121
R316 VSS.n110 VSS.n91 0.231121
R317 VSS.n114 VSS.n91 0.231121
R318 VSS.n115 VSS.n114 0.231121
R319 VSS.n1 VSS.n115 3.25692
R320 VSS.n217 VSS.n62 0.231121
R321 VSS.n216 VSS.n62 0.231121
R322 VSS.n216 VSS.n58 0.231121
R323 VSS.n212 VSS.n58 0.231121
R324 VSS.n212 VSS.n53 0.231121
R325 VSS.n211 VSS.n53 0.231121
R326 VSS.n211 VSS.n50 0.231121
R327 VSS.n207 VSS.n50 0.231121
R328 VSS.n207 VSS.n45 0.231121
R329 VSS.n206 VSS.n45 0.231121
R330 VSS.n206 VSS.n78 0.231121
R331 VSS.n202 VSS.n78 0.231121
R332 VSS.n202 VSS.n42 0.231121
R333 VSS.n201 VSS.n42 0.231121
R334 VSS.n201 VSS.n33 0.231121
R335 VSS.n34 VSS.n33 0.114852
R336 VSS.n197 VSS.n41 0.231121
R337 VSS.n26 VSS.n41 0.114852
R338 VSS.n192 VSS.n81 0.231121
R339 VSS.n196 VSS.n3 0.114852
R340 VSS.n196 VSS.n64 0.231121
R341 VSS.n189 VSS.n64 0.231121
R342 VSS.n36 VSS.n72 0.114852
R343 VSS.n83 VSS.n72 0.231121
R344 VSS.n67 VSS.n83 0.114852
R345 VSS.n166 VSS.n165 0.231121
R346 VSS.n166 VSS.n162 0.231121
R347 VSS.n75 VSS.n162 0.114852
R348 VSS.n171 VSS.n170 0.231121
R349 VSS.n172 VSS.n171 0.231121
R350 VSS.n172 VSS.n160 0.231121
R351 VSS.n176 VSS.n160 0.231121
R352 VSS.n177 VSS.n176 0.231121
R353 VSS.n178 VSS.n177 0.231121
R354 VSS.n178 VSS.n157 0.231121
R355 VSS.n35 VSS.n157 0.114852
R356 VSS.n183 VSS.n182 0.231121
R357 VSS.n30 VSS.n183 0.114852
R358 VSS.n184 VSS.n84 0.231121
R359 VSS.n188 VSS.n2 0.114852
R360 VSS.n188 VSS.n65 0.231121
R361 VSS.n153 VSS.n65 0.231121
R362 VSS.n37 VSS.n71 0.114852
R363 VSS.n86 VSS.n71 0.231121
R364 VSS.n68 VSS.n86 0.114852
R365 VSS.n130 VSS.n129 0.231121
R366 VSS.n130 VSS.n126 0.231121
R367 VSS.n73 VSS.n126 0.114852
R368 VSS.n135 VSS.n134 0.231121
R369 VSS.n136 VSS.n135 0.231121
R370 VSS.n136 VSS.n124 0.231121
R371 VSS.n140 VSS.n124 0.231121
R372 VSS.n141 VSS.n140 0.231121
R373 VSS.n142 VSS.n141 0.231121
R374 VSS.n142 VSS.n121 0.231121
R375 VSS.n20 VSS.n121 0.114852
R376 VSS.n147 VSS.n146 0.231121
R377 VSS.n17 VSS.n147 0.114852
R378 VSS.n148 VSS.n87 0.231121
R379 VSS.n152 VSS.n87 0.231121
R380 VSS.n152 VSS.n25 0.114852
R381 VSS.n117 VSS.n66 0.231121
R382 VSS.n21 VSS.n70 0.114852
R383 VSS.n89 VSS.n70 0.231121
R384 VSS.n69 VSS.n89 0.114852
R385 VSS.n100 VSS.n99 0.231121
R386 VSS.n101 VSS.n100 0.231121
R387 VSS.n101 VSS.n74 0.114852
R388 VSS.n105 VSS.n95 0.231121
R389 VSS.n106 VSS.n105 0.231121
R390 VSS.n107 VSS.n106 0.231121
R391 VSS.n107 VSS.n92 0.231121
R392 VSS.n111 VSS.n92 0.231121
R393 VSS.n112 VSS.n111 0.231121
R394 VSS.n113 VSS.n112 0.231121
R395 VSS.n113 VSS.n90 0.231121
R396 VSS.n116 VSS.n90 0.231121
R397 VSS VSS.n5 0.231121
R398 VSS.n19 VSS.t35 0.0973057
R399 VSS.n32 VSS.t22 0.0973057
R400 VSS.n27 VSS.t9 0.0973057
R401 VSS.n123 VSS.t5 0.191638
R402 VSS.t7 VSS.n4 0.191638
R403 VSS.n159 VSS.t49 0.191638
R404 VSS.n94 VSS.t2 0.191439
R405 VSS.n63 VSS.n60 0.191235
R406 VSS.n57 VSS.n56 0.191235
R407 VSS.n55 VSS.n54 0.0953067
R408 VSS.n54 VSS.n52 0.191235
R409 VSS.n48 VSS.n51 0.0953067
R410 VSS.n49 VSS.n48 0.191235
R411 VSS.n47 VSS.n46 0.0953067
R412 VSS.n46 VSS.n44 0.191235
R413 VSS.n4 VSS.n44 0.191235
R414 VSS.n39 VSS.n38 0.0953067
R415 VSS.n159 VSS.n39 0.191235
R416 VSS.n24 VSS.t33 0.191235
R417 VSS.n15 VSS.t46 0.191235
R418 VSS.n12 VSS.n11 0.191235
R419 VSS.n9 VSS.n8 0.191235
R420 VSS.n7 VSS.n9 0.0953067
R421 VSS.n10 VSS.n12 0.0953067
R422 VSS.n14 VSS.n15 0.0953067
R423 VSS.n23 VSS.n24 0.0953067
R424 VSS.n94 VSS.n13 0.143368
R425 VSS.n0 VSS.n6 0.202377
R426 VSS.n56 VSS.n59 0.0718369
R427 VSS.n123 VSS.n22 0.143368
R428 VSS.t18 VSS.t17 0.143368
R429 VSS.t31 VSS.t30 0.143368
R430 VSS.t44 VSS.t43 0.143368
R431 VSS.t1 VSS.n0 4.2759
C33 MUX_IN3 VSS 0.13513f
C34 MUX_ONEHOT_SEL3 VSS 0.39206f
C35 MUX_IN2 VSS 0.13718f
C36 MUX_ONEHOT_SEL2 VSS 0.37687f
C37 MUX_IN1 VSS 0.13715f
C38 MUX_ONEHOT_SEL1 VSS 0.37687f
C39 MUX_OUT VSS 4.55369f
C40 MUX_IN0 VSS 0.13343f
C41 MUX_ONEHOT_SEL0 VSS 0.3773f
C42 VDD VSS 19.9994f
C43 a_10741_392# VSS 0.19794f ; **FLOATING
C44 a_7701_392# VSS 0.19489f ; **FLOATING
C45 a_4661_392# VSS 0.19489f ; **FLOATING
C46 a_1621_392# VSS 0.19298f ; **FLOATING
.ends
