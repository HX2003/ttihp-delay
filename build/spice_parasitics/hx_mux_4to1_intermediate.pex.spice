* NGSPICE file created from hx_mux_4to1_intermediate.ext - technology: ihp-sg13g2

.subckt hx_mux_4to1_intermediate VSS VDD MUX_ONEHOT_SEL0 MUX_ONEHOT_SEL1 MUX_ONEHOT_SEL2
+ MUX_ONEHOT_SEL3 MUX_IN0 MUX_IN1 MUX_IN2 MUX_IN3 MUX_OUT
X0 VDD VSS.t67 VDD VDD sg13_lv_pmos ad=0.19p pd=1.38u as=52.17217p ps=0.22006m w=1u l=1u
X1 VSS.t35 VDD VSS.t34 VSS.t33 sg13_lv_nmos ad=0.1428p pd=1.52u as=0 ps=0 w=0.42u l=1u
X2 VSS.t8 MUX_ONEHOT_SEL0 a_1621_392# VSS.t7 sg13_lv_nmos ad=0.2516p pd=2.16u as=0.2516p ps=2.16u w=0.74u l=0.13u
X3 VDD VSS.t54 VDD VDD sg13_lv_pmos ad=0.19p pd=1.38u as=0 ps=0 w=1u l=1u
X4 VSS.t2 MUX_ONEHOT_SEL3 a_10741_392# VSS.t1 sg13_lv_nmos ad=0.2516p pd=2.16u as=0.2516p ps=2.16u w=0.74u l=0.13u
X5 VSS.t32 VDD VSS.t29 VSS.t31 sg13_lv_nmos ad=79.8f pd=0.8u as=0 ps=0 w=0.42u l=1u
X6 VDD VSS.t68 VDD VDD sg13_lv_pmos ad=0.34p pd=2.68u as=0 ps=0 w=1u l=1u
X7 VSS.t30 VDD VSS.t29 VSS.t28 sg13_lv_nmos ad=0.1428p pd=1.52u as=0 ps=0 w=0.42u l=1u
X8 MUX_OUT MUX_ONEHOT_SEL2 MUX_IN2 VSS.t3 sg13_lv_nmos ad=0.2516p pd=2.16u as=0.2516p ps=2.16u w=0.74u l=0.13u
X9 VDD MUX_ONEHOT_SEL3 a_10741_392# VDD sg13_lv_pmos ad=0.3808p pd=2.92u as=0.3808p ps=2.92u w=1.12u l=0.13u
X10 MUX_OUT a_1621_392# MUX_IN0 VDD sg13_lv_pmos ad=0.3808p pd=2.92u as=0.3808p ps=2.92u w=1.12u l=0.13u
X11 VDD MUX_ONEHOT_SEL0 a_1621_392# VDD sg13_lv_pmos ad=0.3808p pd=2.92u as=0.3808p ps=2.92u w=1.12u l=0.13u
X12 MUX_OUT a_10741_392# MUX_IN3 VDD sg13_lv_pmos ad=0.3808p pd=2.92u as=0.3808p ps=2.92u w=1.12u l=0.13u
X13 VDD VSS.t61 VDD VDD sg13_lv_pmos ad=0.19p pd=1.38u as=0 ps=0 w=1u l=1u
X14 VDD VSS.t60 VDD VDD sg13_lv_pmos ad=0.34p pd=2.68u as=0 ps=0 w=1u l=1u
X15 VSS.t22 VDD VSS.t19 VSS.t21 sg13_lv_nmos ad=79.8f pd=0.8u as=0 ps=0 w=0.42u l=1u
X16 VDD VSS.t29 VDD VDD sg13_lv_pmos ad=0.34p pd=2.68u as=0 ps=0 w=1u l=1u
X17 VSS.t49 VDD VSS.t48 VSS.t47 sg13_lv_nmos ad=0.1428p pd=1.52u as=0 ps=0 w=0.42u l=1u
X18 VDD VSS.t64 VDD VDD sg13_lv_pmos ad=0.19p pd=1.38u as=0 ps=0 w=1u l=1u
X19 VSS.t25 MUX_ONEHOT_SEL1 a_4661_392# VSS.t53 sg13_lv_nmos ad=0.2516p pd=2.16u as=0.2516p ps=2.16u w=0.74u l=0.13u
X20 VSS.t46 VDD VSS.t43 VSS.t45 sg13_lv_nmos ad=79.8f pd=0.8u as=0 ps=0 w=0.42u l=1u
X21 MUX_OUT MUX_ONEHOT_SEL0 MUX_IN0 VSS.t6 sg13_lv_nmos ad=0.2516p pd=2.16u as=0.2516p ps=2.16u w=0.74u l=0.13u
X22 VSS.t44 VDD VSS.t43 VSS.t42 sg13_lv_nmos ad=0.1428p pd=1.52u as=0 ps=0 w=0.42u l=1u
X23 MUX_OUT MUX_ONEHOT_SEL3 MUX_IN3 VSS.t0 sg13_lv_nmos ad=0.2516p pd=2.16u as=0.2516p ps=2.16u w=0.74u l=0.13u
X24 MUX_OUT a_4661_392# MUX_IN1 VDD sg13_lv_pmos ad=0.3808p pd=2.92u as=0.3808p ps=2.92u w=1.12u l=0.13u
X25 VDD MUX_ONEHOT_SEL1 a_4661_392# VDD sg13_lv_pmos ad=0.3808p pd=2.92u as=0.3808p ps=2.92u w=1.12u l=0.13u
X26 VDD VSS.t56 VDD VDD sg13_lv_pmos ad=0.19p pd=1.38u as=0 ps=0 w=1u l=1u
X27 VDD VSS.t55 VDD VDD sg13_lv_pmos ad=0.34p pd=2.68u as=0 ps=0 w=1u l=1u
X28 VSS.t27 VDD VSS.t24 VSS.t26 sg13_lv_nmos ad=79.8f pd=0.8u as=0 ps=0 w=0.42u l=1u
X29 VSS.t25 VDD VSS.t24 VSS.t23 sg13_lv_nmos ad=0.1428p pd=1.52u as=0 ps=0 w=0.42u l=1u
X30 VDD VSS.t62 VDD VDD sg13_lv_pmos ad=0.19p pd=1.38u as=0 ps=0 w=1u l=1u
X31 VSS.t20 VDD VSS.t19 VSS.t18 sg13_lv_nmos ad=0.1428p pd=1.52u as=0 ps=0 w=0.42u l=1u
X32 VDD VSS.t43 VDD VDD sg13_lv_pmos ad=0.34p pd=2.68u as=0 ps=0 w=1u l=1u
X33 VSS.t17 VDD VSS.t14 VSS.t16 sg13_lv_nmos ad=79.8f pd=0.8u as=0 ps=0 w=0.42u l=1u
X34 VDD VSS.t63 VDD VDD sg13_lv_pmos ad=0.34p pd=2.68u as=0 ps=0 w=1u l=1u
X35 VSS.t15 VDD VSS.t14 VSS.t13 sg13_lv_nmos ad=0.1428p pd=1.52u as=0 ps=0 w=0.42u l=1u
X36 MUX_OUT MUX_ONEHOT_SEL1 MUX_IN1 VSS.t52 sg13_lv_nmos ad=0.2516p pd=2.16u as=0.2516p ps=2.16u w=0.74u l=0.13u
X37 VDD VSS.t66 VDD VDD sg13_lv_pmos ad=0.19p pd=1.38u as=0 ps=0 w=1u l=1u
X38 VDD VSS.t65 VDD VDD sg13_lv_pmos ad=0.34p pd=2.68u as=0 ps=0 w=1u l=1u
X39 VSS.t41 VDD VSS.t39 VSS.t40 sg13_lv_nmos ad=79.8f pd=0.8u as=0 ps=0 w=0.42u l=1u
X40 VSS.t37 VDD VSS.t34 VSS.t36 sg13_lv_nmos ad=79.8f pd=0.8u as=0 ps=0 w=0.42u l=1u
X41 VSS.t5 VDD VSS.t39 VSS.t38 sg13_lv_nmos ad=0.1428p pd=1.52u as=0 ps=0 w=0.42u l=1u
X42 VDD VSS.t14 VDD VDD sg13_lv_pmos ad=0.34p pd=2.68u as=0 ps=0 w=1u l=1u
X43 VDD VSS.t57 VDD VDD sg13_lv_pmos ad=0.19p pd=1.38u as=0 ps=0 w=1u l=1u
X44 VDD VSS.t59 VDD VDD sg13_lv_pmos ad=0.19p pd=1.38u as=0 ps=0 w=1u l=1u
X45 VSS.t5 MUX_ONEHOT_SEL2 a_7701_392# VSS.t4 sg13_lv_nmos ad=0.2516p pd=2.16u as=0.2516p ps=2.16u w=0.74u l=0.13u
X46 VDD VSS.t58 VDD VDD sg13_lv_pmos ad=0.34p pd=2.68u as=0 ps=0 w=1u l=1u
X47 VSS.t12 VDD VSS.t10 VSS.t11 sg13_lv_nmos ad=79.8f pd=0.8u as=0 ps=0 w=0.42u l=1u
X48 VDD MUX_ONEHOT_SEL2 a_7701_392# VDD sg13_lv_pmos ad=0.3808p pd=2.92u as=0.3808p ps=2.92u w=1.12u l=0.13u
X49 MUX_OUT a_7701_392# MUX_IN2 VDD sg13_lv_pmos ad=0.3808p pd=2.92u as=0.3808p ps=2.92u w=1.12u l=0.13u
X50 VSS.t8 VDD VSS.t10 VSS.t9 sg13_lv_nmos ad=0.1428p pd=1.52u as=0 ps=0 w=0.42u l=1u
X51 VSS.t51 VDD VSS.t48 VSS.t50 sg13_lv_nmos ad=79.8f pd=0.8u as=0 ps=0 w=0.42u l=1u
C0 VDD a_7701_392# 0.28906f
C1 MUX_OUT MUX_ONEHOT_SEL1 0.04345f
C2 MUX_IN0 a_1621_392# 0.01637f
C3 VDD MUX_IN1 0.19774f
C4 MUX_OUT MUX_IN3 0.4238f
C5 MUX_IN1 a_4661_392# 0.01637f
C6 VDD MUX_ONEHOT_SEL1 0.42911f
C7 MUX_ONEHOT_SEL2 MUX_OUT 0.04345f
C8 MUX_IN3 a_10741_392# 0.01637f
C9 VDD MUX_IN3 0.20185f
C10 MUX_ONEHOT_SEL0 a_1621_392# 0.13134f
C11 MUX_OUT MUX_ONEHOT_SEL3 0.04341f
C12 MUX_OUT a_10741_392# 0.2906f
C13 a_4661_392# MUX_ONEHOT_SEL1 0.13134f
C14 VDD MUX_OUT 1.11646f
C15 a_7701_392# MUX_IN2 0.01637f
C16 VDD MUX_ONEHOT_SEL2 0.42911f
C17 a_4661_392# MUX_OUT 0.2906f
C18 MUX_ONEHOT_SEL3 a_10741_392# 0.13134f
C19 MUX_OUT MUX_IN0 0.42148f
C20 VDD MUX_ONEHOT_SEL3 0.42172f
C21 VDD a_10741_392# 0.28906f
C22 VDD a_4661_392# 0.28906f
C23 MUX_OUT a_1621_392# 0.29558f
C24 VDD MUX_IN0 0.19967f
C25 MUX_OUT MUX_IN2 0.4238f
C26 MUX_OUT MUX_ONEHOT_SEL0 0.03902f
C27 a_7701_392# MUX_OUT 0.2906f
C28 MUX_IN1 MUX_OUT 0.4238f
C29 VDD a_1621_392# 0.29178f
C30 MUX_ONEHOT_SEL2 a_7701_392# 0.13134f
C31 VDD MUX_IN2 0.19774f
C32 VDD MUX_ONEHOT_SEL0 0.42767f
R0 VSS.t18 VSS.n16 526.365
R1 VSS.n4 VSS.t36 422.92
R2 VSS.t47 VSS.n17 526.365
R3 VSS.n1 VSS.t13 71.4281
R4 VSS.n9 VSS.t28 511.592
R5 VSS.n11 VSS.t42 71.4281
R6 VSS.t21 VSS.n16 122.112
R7 VSS.t50 VSS.n17 122.112
R8 VSS.n11 VSS.n13 0.00197663
R9 VSS.n9 VSS.t26 408.14
R10 VSS.n11 VSS.n14 0.00175043
R11 VSS.t23 VSS.n2 133.135
R12 VSS.t38 VSS.n14 133.136
R13 VSS.t9 VSS.n0 393.363
R14 VSS.t52 VSS.n15 139.469
R15 VSS.t3 VSS.n5 371.188
R16 VSS.t7 VSS.n0 326.863
R17 VSS.n7 VSS.t1 326.861
R18 VSS.n15 VSS.t53 147.181
R19 VSS.n5 VSS.t4 147.177
R20 VSS.t16 VSS.n1 304.693
R21 VSS.n3 VSS.t28 83.0194
R22 VSS.n10 VSS.t16 289.914
R23 VSS.n3 VSS.t31 148.56
R24 VSS.n12 VSS.t45 148.56
R25 VSS.t6 VSS.t7 267.743
R26 VSS.t1 VSS.n6 267.743
R27 VSS.n11 VSS.n15 0.00424415
R28 VSS.n8 VSS.t3 223.412
R29 VSS.n6 VSS.t0 139.465
R30 VSS.n13 VSS.t9 201.245
R31 VSS.t11 VSS.n13 127.992
R32 VSS.t26 VSS.n2 186.468
R33 VSS.t40 VSS.n14 127.993
R34 VSS.n11 VSS.n16 0.00515102
R35 VSS.n8 VSS.t36 171.689
R36 VSS.n11 VSS.n17 0.00515102
R37 VSS.n11 VSS.n12 0.00152034
R38 VSS.n10 VSS.t18 68.2425
R39 VSS.n4 VSS.t33 60.4094
R40 VSS.n11 VSS.n47 17.0005
R41 VSS.n11 VSS.t17 17.0005
R42 VSS.n11 VSS.n45 17.0005
R43 VSS.n11 VSS.n21 17.0005
R44 VSS.n11 VSS.n40 17.0005
R45 VSS.n11 VSS.t32 17.0005
R46 VSS.n11 VSS.n38 17.0005
R47 VSS.n11 VSS.n24 17.0005
R48 VSS.n11 VSS.n33 17.0005
R49 VSS.n11 VSS.t46 17.0005
R50 VSS.n11 VSS.n31 17.0005
R51 VSS.n11 VSS.n27 17.0005
R52 VSS.t51 VSS 12.9568
R53 VSS.t55 VSS 12.3605
R54 VSS.n30 VSS 12.0818
R55 VSS.t43 VSS 11.4855
R56 VSS.t41 VSS 11.2068
R57 VSS.t58 VSS 10.6105
R58 VSS.t37 VSS 9.15675
R59 VSS.t60 VSS 8.5605
R60 VSS.n11 VSS.n18 8.49237
R61 VSS.n11 VSS.n48 8.49237
R62 VSS.n11 VSS.n46 8.49237
R63 VSS.n11 VSS.n43 8.49237
R64 VSS.n11 VSS.n22 8.49237
R65 VSS.n11 VSS.n41 8.49237
R66 VSS.n11 VSS.n39 8.49237
R67 VSS.n11 VSS.n36 8.49237
R68 VSS.n11 VSS.n25 8.49237
R69 VSS.n11 VSS.n34 8.49237
R70 VSS.n11 VSS.n32 8.49237
R71 VSS.n11 VSS.n29 8.49237
R72 VSS.n37 VSS 8.28175
R73 VSS.t29 VSS 7.6855
R74 VSS.t27 VSS 7.40675
R75 VSS.t63 VSS 6.8105
R76 VSS.t22 VSS 5.35675
R77 VSS.t65 VSS 4.7605
R78 VSS.t54 VSS 4.65641
R79 VSS.n44 VSS 4.48175
R80 VSS.t49 VSS 4.43732
R81 VSS.t56 VSS 4.33823
R82 VSS.n11 VSS.t10 4.19225
R83 VSS.n11 VSS.t24 4.19225
R84 VSS.n11 VSS.t39 4.19225
R85 VSS.t44 VSS 4.11914
R86 VSS.t57 VSS 4.02005
R87 VSS.t14 VSS 3.8855
R88 VSS.t5 VSS 3.80095
R89 VSS.t12 VSS 3.60675
R90 VSS.n11 VSS.n20 3.32615
R91 VSS.n11 VSS.t19 3.32615
R92 VSS.n11 VSS.n23 3.32615
R93 VSS.n11 VSS.t34 3.32615
R94 VSS.n11 VSS.n26 3.32615
R95 VSS.n11 VSS.t48 3.32615
R96 VSS.t59 VSS 3.27459
R97 VSS.t35 VSS 3.0555
R98 VSS.t68 VSS 3.0105
R99 VSS.t61 VSS 2.95641
R100 VSS.t30 VSS 2.73732
R101 VSS.t62 VSS 2.63823
R102 VSS.t25 VSS 2.41914
R103 VSS.t64 VSS 1.89277
R104 VSS.n11 VSS.n28 1.7562
R105 VSS.t20 VSS 1.67368
R106 VSS.n7 VSS.t2 1.62487
R107 VSS.t66 VSS 1.57459
R108 VSS.t15 VSS 1.3555
R109 VSS.t67 VSS 1.25641
R110 VSS.n19 VSS 1.0464
R111 VSS VSS.t8 1.03732
R112 VSS.t8 VSS.n19 1.03359
R113 VSS.n11 VSS.n42 1.01937
R114 VSS.n11 VSS.n35 1.01937
R115 VSS.n42 VSS.t25 0.617374
R116 VSS.n35 VSS.t5 0.617374
R117 VSS.n42 VSS.t22 0.581287
R118 VSS.n35 VSS.t37 0.581287
R119 VSS.n28 VSS.t51 0.381086
R120 VSS.t2 VSS.n28 0.379546
R121 VSS.n19 VSS.n11 0.275933
R122 VSS.t43 VSS.n26 0.24735
R123 VSS.t29 VSS.n23 0.24735
R124 VSS.t14 VSS.n20 0.24735
R125 VSS.t65 VSS.t19 0.22735
R126 VSS.t60 VSS.t34 0.22735
R127 VSS.t55 VSS.t48 0.22735
R128 VSS.t67 VSS.t10 0.224424
R129 VSS.t62 VSS.t24 0.224424
R130 VSS.t57 VSS.t39 0.224424
R131 VSS.t39 VSS.t58 0.220674
R132 VSS.t24 VSS.t63 0.220674
R133 VSS.t10 VSS.t68 0.220674
R134 VSS.t19 VSS.t64 0.216107
R135 VSS.t48 VSS.t54 0.216107
R136 VSS.t59 VSS.t34 0.216107
R137 VSS.t66 VSS.n20 0.196107
R138 VSS.t61 VSS.n23 0.196107
R139 VSS.t56 VSS.n26 0.196107
R140 VSS.n45 VSS.t20 0.08925
R141 VSS.n38 VSS.t35 0.08925
R142 VSS.n31 VSS.t49 0.08925
R143 VSS.n47 VSS.t15 0.06925
R144 VSS.n40 VSS.t30 0.06925
R145 VSS.n33 VSS.t44 0.06925
R146 VSS.t12 VSS.n47 0.05175
R147 VSS.t27 VSS.n40 0.05175
R148 VSS.t41 VSS.n33 0.05175
R149 VSS.n43 VSS.t65 0.0391643
R150 VSS.n36 VSS.t60 0.0391643
R151 VSS.n29 VSS.t55 0.0391643
R152 VSS.t25 VSS.n22 0.0350734
R153 VSS.t5 VSS.n25 0.0350734
R154 VSS.n18 VSS.t8 0.0350734
R155 VSS.n48 VSS.t12 0.0341643
R156 VSS.n41 VSS.t27 0.0341643
R157 VSS.n34 VSS.t41 0.0341643
R158 VSS.t46 VSS.t56 0.0327727
R159 VSS.t32 VSS.t61 0.0327727
R160 VSS.t17 VSS.t66 0.0327727
R161 VSS.n46 VSS.t14 0.0318916
R162 VSS.n39 VSS.t29 0.0318916
R163 VSS.n32 VSS.t43 0.0318916
R164 VSS.n45 VSS.n44 0.03175
R165 VSS.n38 VSS.n37 0.03175
R166 VSS.n31 VSS.n30 0.03175
R167 VSS.t51 VSS.n27 0.0309545
R168 VSS.n24 VSS.t37 0.0309545
R169 VSS.n21 VSS.t22 0.0309545
R170 VSS.t15 VSS.n46 0.0278007
R171 VSS.t30 VSS.n39 0.0278007
R172 VSS.t44 VSS.n32 0.0278007
R173 VSS.t64 VSS.n21 0.0255
R174 VSS.t54 VSS.n27 0.0255
R175 VSS.n24 VSS.t59 0.0255
R176 VSS.t58 VSS.n25 0.0246188
R177 VSS.t63 VSS.n22 0.0246188
R178 VSS.t68 VSS.n18 0.0246188
R179 VSS.n44 VSS.t17 0.0236818
R180 VSS.n37 VSS.t32 0.0236818
R181 VSS.n30 VSS.t46 0.0236818
R182 VSS.t67 VSS.n48 0.0232552
R183 VSS.t62 VSS.n41 0.0232552
R184 VSS.t57 VSS.n34 0.0232552
R185 VSS.t20 VSS.n43 0.0205279
R186 VSS.t35 VSS.n36 0.0205279
R187 VSS.t49 VSS.n29 0.0205279
R188 VSS.n11 VSS.n4 0.00264993
R189 VSS.n11 VSS.n5 0.00890273
R190 VSS.n11 VSS.n6 0.0064016
R191 VSS.n11 VSS.t6 0.00621412
R192 VSS.n11 VSS.n3 0.00270886
R193 VSS.n11 VSS.n0 0.00150082
R194 VSS.n11 VSS.n7 0.00150043
R195 VSS.n11 VSS.n8 0.00150004
R196 VSS.n11 VSS.n1 0.0017716
R197 VSS.n11 VSS.n2 0.00159329
R198 VSS.n11 VSS.n9 0.00155203
R199 VSS.n11 VSS.n10 0.00153005
R200 VSS.n12 VSS.t47 68.2435
C33 MUX_IN3 VSS 0.13252f
C34 MUX_ONEHOT_SEL3 VSS 0.37394f
C35 MUX_IN2 VSS 0.13453f
C36 MUX_ONEHOT_SEL2 VSS 0.36587f
C37 MUX_IN1 VSS 0.13453f
C38 MUX_ONEHOT_SEL1 VSS 0.36587f
C39 MUX_OUT VSS 4.24511f
C40 MUX_IN0 VSS 0.13087f
C41 MUX_ONEHOT_SEL0 VSS 0.36686f
C42 VDD VSS 15.1117f
C43 a_10741_392# VSS 0.18639f ; **FLOATING
C44 a_7701_392# VSS 0.18639f ; **FLOATING
C45 a_4661_392# VSS 0.18639f ; **FLOATING
C46 a_1621_392# VSS 0.18451f ; **FLOATING
.ends
