* NGSPICE file created from hx_mux_4to1_intermediate.ext - technology: ihp-sg13g2

.subckt hx_mux_4to1_intermediate VSS VDD MUX_ONEHOT_SEL0 MUX_ONEHOT_SEL1 MUX_ONEHOT_SEL2
+ MUX_ONEHOT_SEL3 MUX_IN0 MUX_IN1 MUX_IN2 MUX_IN3 MUX_OUT
X0 VDD VSS.t2 VDD VDD sg13_lv_pmos ad=0.19p pd=1.38u as=52.17217p ps=0.22006m w=1u l=1u
X1 VSS.t17 VDD VSS.t17 VSS.t19 sg13_lv_nmos ad=0.1428p pd=1.52u as=0 ps=0 w=0.42u l=1u
X2 VSS.t2 MUX_ONEHOT_SEL0 a_1621_392# VSS.t6 sg13_lv_nmos ad=0.2516p pd=2.16u as=0.2516p ps=2.16u w=0.74u l=0.13u
X3 VDD VSS.t2 VDD VDD sg13_lv_pmos ad=0.19p pd=1.38u as=0 ps=0 w=1u l=1u
X4 VSS.t2 MUX_ONEHOT_SEL3 a_10741_392# VSS.t1 sg13_lv_nmos ad=0.2516p pd=2.16u as=0.2516p ps=2.16u w=0.74u l=0.13u
X5 VSS.t17 VDD VSS.t17 VSS.t18 sg13_lv_nmos ad=79.8f pd=0.8u as=0 ps=0 w=0.42u l=1u
X6 VDD VSS.t2 VDD VDD sg13_lv_pmos ad=0.34p pd=2.68u as=0 ps=0 w=1u l=1u
X7 VSS.t17 VDD VSS.t17 VSS.t16 sg13_lv_nmos ad=0.1428p pd=1.52u as=0 ps=0 w=0.42u l=1u
X8 MUX_OUT MUX_ONEHOT_SEL2 MUX_IN2 VSS.t3 sg13_lv_nmos ad=0.2516p pd=2.16u as=0.2516p ps=2.16u w=0.74u l=0.13u
X9 VDD MUX_ONEHOT_SEL3 a_10741_392# VDD sg13_lv_pmos ad=0.3808p pd=2.92u as=0.3808p ps=2.92u w=1.12u l=0.13u
X10 MUX_OUT a_1621_392# MUX_IN0 VDD sg13_lv_pmos ad=0.3808p pd=2.92u as=0.3808p ps=2.92u w=1.12u l=0.13u
X11 VDD MUX_ONEHOT_SEL0 a_1621_392# VDD sg13_lv_pmos ad=0.3808p pd=2.92u as=0.3808p ps=2.92u w=1.12u l=0.13u
X12 MUX_OUT a_10741_392# MUX_IN3 VDD sg13_lv_pmos ad=0.3808p pd=2.92u as=0.3808p ps=2.92u w=1.12u l=0.13u
X13 VDD VSS.t17 VDD VDD sg13_lv_pmos ad=0.19p pd=1.38u as=0 ps=0 w=1u l=1u
X14 VDD VSS.t17 VDD VDD sg13_lv_pmos ad=0.34p pd=2.68u as=0 ps=0 w=1u l=1u
X15 VSS.t10 VDD VSS.t10 VSS.t13 sg13_lv_nmos ad=79.8f pd=0.8u as=0 ps=0 w=0.42u l=1u
X16 VDD VSS.t17 VDD VDD sg13_lv_pmos ad=0.34p pd=2.68u as=0 ps=0 w=1u l=1u
X17 VSS.t2 VDD VSS.t2 VSS.t25 sg13_lv_nmos ad=0.1428p pd=1.52u as=0 ps=0 w=0.42u l=1u
X18 VDD VSS.t10 VDD VDD sg13_lv_pmos ad=0.19p pd=1.38u as=0 ps=0 w=1u l=1u
X19 VSS.t2 MUX_ONEHOT_SEL1 a_4661_392# VSS.t28 sg13_lv_nmos ad=0.2516p pd=2.16u as=0.2516p ps=2.16u w=0.74u l=0.13u
X20 VSS.t2 VDD VSS.t2 VSS.t24 sg13_lv_nmos ad=79.8f pd=0.8u as=0 ps=0 w=0.42u l=1u
X21 MUX_OUT MUX_ONEHOT_SEL0 MUX_IN0 VSS.t2 sg13_lv_nmos ad=0.2516p pd=2.16u as=0.2516p ps=2.16u w=0.74u l=0.13u
X22 VSS.t2 VDD VSS.t2 VSS.t23 sg13_lv_nmos ad=0.1428p pd=1.52u as=0 ps=0 w=0.42u l=1u
X23 MUX_OUT MUX_ONEHOT_SEL3 MUX_IN3 VSS.t0 sg13_lv_nmos ad=0.2516p pd=2.16u as=0.2516p ps=2.16u w=0.74u l=0.13u
X24 MUX_OUT a_4661_392# MUX_IN1 VDD sg13_lv_pmos ad=0.3808p pd=2.92u as=0.3808p ps=2.92u w=1.12u l=0.13u
X25 VDD MUX_ONEHOT_SEL1 a_4661_392# VDD sg13_lv_pmos ad=0.3808p pd=2.92u as=0.3808p ps=2.92u w=1.12u l=0.13u
X26 VDD VSS.t2 VDD VDD sg13_lv_pmos ad=0.19p pd=1.38u as=0 ps=0 w=1u l=1u
X27 VDD VSS.t2 VDD VDD sg13_lv_pmos ad=0.34p pd=2.68u as=0 ps=0 w=1u l=1u
X28 VSS.t2 VDD VSS.t2 VSS.t15 sg13_lv_nmos ad=79.8f pd=0.8u as=0 ps=0 w=0.42u l=1u
X29 VSS.t2 VDD VSS.t2 VSS.t14 sg13_lv_nmos ad=0.1428p pd=1.52u as=0 ps=0 w=0.42u l=1u
X30 VDD VSS.t2 VDD VDD sg13_lv_pmos ad=0.19p pd=1.38u as=0 ps=0 w=1u l=1u
X31 VSS.t10 VDD VSS.t10 VSS.t12 sg13_lv_nmos ad=0.1428p pd=1.52u as=0 ps=0 w=0.42u l=1u
X32 VDD VSS.t2 VDD VDD sg13_lv_pmos ad=0.34p pd=2.68u as=0 ps=0 w=1u l=1u
X33 VSS.t10 VDD VSS.t10 VSS.t11 sg13_lv_nmos ad=79.8f pd=0.8u as=0 ps=0 w=0.42u l=1u
X34 VDD VSS.t2 VDD VDD sg13_lv_pmos ad=0.34p pd=2.68u as=0 ps=0 w=1u l=1u
X35 VSS.t10 VDD VSS.t10 VSS.t9 sg13_lv_nmos ad=0.1428p pd=1.52u as=0 ps=0 w=0.42u l=1u
X36 MUX_OUT MUX_ONEHOT_SEL1 MUX_IN1 VSS.t27 sg13_lv_nmos ad=0.2516p pd=2.16u as=0.2516p ps=2.16u w=0.74u l=0.13u
X37 VDD VSS.t10 VDD VDD sg13_lv_pmos ad=0.19p pd=1.38u as=0 ps=0 w=1u l=1u
X38 VDD VSS.t10 VDD VDD sg13_lv_pmos ad=0.34p pd=2.68u as=0 ps=0 w=1u l=1u
X39 VSS.t5 VDD VSS.t5 VSS.t22 sg13_lv_nmos ad=79.8f pd=0.8u as=0 ps=0 w=0.42u l=1u
X40 VSS.t17 VDD VSS.t17 VSS.t20 sg13_lv_nmos ad=79.8f pd=0.8u as=0 ps=0 w=0.42u l=1u
X41 VSS.t5 VDD VSS.t5 VSS.t21 sg13_lv_nmos ad=0.1428p pd=1.52u as=0 ps=0 w=0.42u l=1u
X42 VDD VSS.t10 VDD VDD sg13_lv_pmos ad=0.34p pd=2.68u as=0 ps=0 w=1u l=1u
X43 VDD VSS.t5 VDD VDD sg13_lv_pmos ad=0.19p pd=1.38u as=0 ps=0 w=1u l=1u
X44 VDD VSS.t17 VDD VDD sg13_lv_pmos ad=0.19p pd=1.38u as=0 ps=0 w=1u l=1u
X45 VSS.t5 MUX_ONEHOT_SEL2 a_7701_392# VSS.t4 sg13_lv_nmos ad=0.2516p pd=2.16u as=0.2516p ps=2.16u w=0.74u l=0.13u
X46 VDD VSS.t5 VDD VDD sg13_lv_pmos ad=0.34p pd=2.68u as=0 ps=0 w=1u l=1u
X47 VSS.t2 VDD VSS.t2 VSS.t8 sg13_lv_nmos ad=79.8f pd=0.8u as=0 ps=0 w=0.42u l=1u
X48 VDD MUX_ONEHOT_SEL2 a_7701_392# VDD sg13_lv_pmos ad=0.3808p pd=2.92u as=0.3808p ps=2.92u w=1.12u l=0.13u
X49 MUX_OUT a_7701_392# MUX_IN2 VDD sg13_lv_pmos ad=0.3808p pd=2.92u as=0.3808p ps=2.92u w=1.12u l=0.13u
X50 VSS.t2 VDD VSS.t2 VSS.t7 sg13_lv_nmos ad=0.1428p pd=1.52u as=0 ps=0 w=0.42u l=1u
X51 VSS.t2 VDD VSS.t2 VSS.t26 sg13_lv_nmos ad=79.8f pd=0.8u as=0 ps=0 w=0.42u l=1u
C0 MUX_OUT MUX_ONEHOT_SEL1 0.04345f
C1 a_4661_392# MUX_ONEHOT_SEL1 0.13134f
C2 MUX_ONEHOT_SEL0 a_1621_392# 0.13134f
C3 MUX_OUT a_10741_392# 0.2906f
C4 MUX_ONEHOT_SEL2 a_7701_392# 0.13134f
C5 MUX_ONEHOT_SEL3 MUX_OUT 0.04341f
C6 MUX_IN0 MUX_OUT 0.42148f
C7 VDD MUX_IN1 0.19774f
C8 a_10741_392# MUX_IN3 0.01637f
C9 MUX_ONEHOT_SEL0 VDD 0.42767f
C10 VDD a_7701_392# 0.28906f
C11 MUX_ONEHOT_SEL2 MUX_OUT 0.04345f
C12 a_1621_392# MUX_OUT 0.29558f
C13 VDD MUX_IN2 0.19774f
C14 VDD MUX_OUT 1.11646f
C15 VDD a_4661_392# 0.28906f
C16 MUX_ONEHOT_SEL3 a_10741_392# 0.13134f
C17 VDD MUX_IN3 0.20185f
C18 MUX_IN2 a_7701_392# 0.01637f
C19 MUX_IN1 MUX_OUT 0.4238f
C20 a_4661_392# MUX_IN1 0.01637f
C21 MUX_ONEHOT_SEL0 MUX_OUT 0.03902f
C22 MUX_OUT a_7701_392# 0.2906f
C23 a_1621_392# MUX_IN0 0.01637f
C24 MUX_IN2 MUX_OUT 0.4238f
C25 VDD MUX_ONEHOT_SEL1 0.42911f
C26 VDD a_10741_392# 0.28906f
C27 VDD MUX_ONEHOT_SEL3 0.42172f
C28 MUX_IN0 VDD 0.19967f
C29 a_4661_392# MUX_OUT 0.2906f
C30 MUX_OUT MUX_IN3 0.4238f
C31 VDD MUX_ONEHOT_SEL2 0.42911f
C32 a_1621_392# VDD 0.29178f
R0 VSS.t19 VSS.t2 60.4114
R1 VSS.t25 VSS.t2 60.4113
R2 VSS.t2 VSS.t23 71.4281
R3 VSS.t2 VSS.t12 60.4105
R4 VSS.t26 VSS.t2 122.117
R5 VSS.t7 VSS.t2 133.135
R6 VSS.t27 VSS.t2 139.469
R7 VSS.t3 VSS.t2 139.468
R8 VSS.t2 VSS.t1 147.181
R9 VSS.t2 VSS.t28 147.181
R10 VSS.t2 VSS.t16 71.4286
R11 VSS.t2 VSS.t11 148.56
R12 VSS.t2 VSS.t18 148.561
R13 VSS.t2 VSS.t24 148.56
R14 VSS.t2 VSS.t6 147.181
R15 VSS.t4 VSS.t2 147.181
R16 VSS.t2 VSS.t0 139.469
R17 VSS.t2 VSS.t14 133.136
R18 VSS.t2 VSS.t21 133.136
R19 VSS.t8 VSS.t2 127.993
R20 VSS.t15 VSS.t2 127.993
R21 VSS.t22 VSS.t2 127.993
R22 VSS.t2 VSS.t13 122.117
R23 VSS.t2 VSS.t20 122.115
R24 VSS.t9 VSS.t2 71.4292
R25 VSS.t2 VSS 12.9568
R26 VSS.t2 VSS 12.3605
R27 VSS.t2 VSS 12.0818
R28 VSS.t2 VSS 11.4855
R29 VSS.t5 VSS 11.2068
R30 VSS.t5 VSS 10.6105
R31 VSS.t17 VSS 9.15675
R32 VSS.t17 VSS 8.5605
R33 VSS.t17 VSS 8.28175
R34 VSS.t17 VSS 7.6855
R35 VSS.t2 VSS 7.40675
R36 VSS.t2 VSS 6.8105
R37 VSS.t10 VSS 5.35675
R38 VSS.t10 VSS 4.7605
R39 VSS.t2 VSS 4.65641
R40 VSS.t10 VSS 4.48175
R41 VSS.t2 VSS 4.43732
R42 VSS.t2 VSS 4.33823
R43 VSS.t2 VSS 4.11914
R44 VSS.t5 VSS 4.02005
R45 VSS.t10 VSS 3.8855
R46 VSS.t5 VSS 3.80095
R47 VSS.t2 VSS 3.60675
R48 VSS.t17 VSS 3.27459
R49 VSS.t17 VSS 3.0555
R50 VSS.t2 VSS 3.0105
R51 VSS.t17 VSS 2.95641
R52 VSS.t17 VSS 2.73732
R53 VSS.t2 VSS 2.63823
R54 VSS.t2 VSS 2.41914
R55 VSS.t10 VSS 1.89277
R56 VSS.t10 VSS 1.67368
R57 VSS.t10 VSS 1.57459
R58 VSS.t10 VSS 1.3555
R59 VSS.t2 VSS 1.25641
R60 VSS.n0 VSS.t17 0.506295
R61 VSS.t2 VSS.t10 1.26357
R62 VSS.t5 VSS.n0 0.383824
R63 VSS.t2 VSS.n0 0.209983
R64 VSS.t2 VSS 1.07594
R65 VSS VSS.t2 1.03732
C33 MUX_IN3 VSS 0.13252f
C34 MUX_ONEHOT_SEL3 VSS 0.37394f
C35 MUX_IN2 VSS 0.13453f
C36 MUX_ONEHOT_SEL2 VSS 0.36587f
C37 MUX_IN1 VSS 0.13453f
C38 MUX_ONEHOT_SEL1 VSS 0.36587f
C39 MUX_OUT VSS 4.24511f
C40 MUX_IN0 VSS 0.13087f
C41 MUX_ONEHOT_SEL0 VSS 0.36686f
C42 VDD VSS 15.1117f
C43 a_10741_392# VSS 0.18639f ; **FLOATING
C44 a_7701_392# VSS 0.18639f ; **FLOATING
C45 a_4661_392# VSS 0.18639f ; **FLOATING
C46 a_1621_392# VSS 0.18451f ; **FLOATING
.ends
