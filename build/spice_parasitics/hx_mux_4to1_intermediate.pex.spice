* NGSPICE file created from hx_mux_4to1_intermediate.ext - technology: ihp-sg13g2

.subckt hx_mux_4to1_intermediate VSS VDD MUX_ONEHOT_SEL0 MUX_ONEHOT_SEL1 MUX_ONEHOT_SEL2
+ MUX_ONEHOT_SEL3 MUX_OUT MUX_IN0 MUX_IN1 MUX_IN2 MUX_IN3
X0 VDD VSS.t67 VDD VDD sg13_lv_pmos ad=0.19p pd=1.38u as=52.17217p ps=0.22006m w=1u l=1u
X1 VSS.t35 VDD VSS.t34 VSS.t33 sg13_lv_nmos ad=0.1428p pd=1.52u as=0 ps=0 w=0.42u l=1u
X2 VSS.t8 MUX_ONEHOT_SEL0 a_1621_392# VSS.t7 sg13_lv_nmos ad=0.2516p pd=2.16u as=0.2516p ps=2.16u w=0.74u l=0.13u
X3 VDD VSS.t54 VDD VDD sg13_lv_pmos ad=0.19p pd=1.38u as=0 ps=0 w=1u l=1u
X4 VSS.t2 MUX_ONEHOT_SEL3 a_10741_392# VSS.t1 sg13_lv_nmos ad=0.2516p pd=2.16u as=0.2516p ps=2.16u w=0.74u l=0.13u
X5 VSS.t32 VDD VSS.t29 VSS.t31 sg13_lv_nmos ad=79.8f pd=0.8u as=0 ps=0 w=0.42u l=1u
X6 VDD VSS.t68 VDD VDD sg13_lv_pmos ad=0.34p pd=2.68u as=0 ps=0 w=1u l=1u
X7 VSS.t30 VDD VSS.t29 VSS.t28 sg13_lv_nmos ad=0.1428p pd=1.52u as=0 ps=0 w=0.42u l=1u
X8 MUX_OUT MUX_ONEHOT_SEL2 MUX_IN2 VSS.t3 sg13_lv_nmos ad=0.2516p pd=2.16u as=0.2516p ps=2.16u w=0.74u l=0.13u
X9 VDD MUX_ONEHOT_SEL3 a_10741_392# VDD sg13_lv_pmos ad=0.3808p pd=2.92u as=0.3808p ps=2.92u w=1.12u l=0.13u
X10 MUX_OUT a_1621_392# MUX_IN0 VDD sg13_lv_pmos ad=0.3808p pd=2.92u as=0.3808p ps=2.92u w=1.12u l=0.13u
X11 VDD MUX_ONEHOT_SEL0 a_1621_392# VDD sg13_lv_pmos ad=0.3808p pd=2.92u as=0.3808p ps=2.92u w=1.12u l=0.13u
X12 MUX_OUT a_10741_392# MUX_IN3 VDD sg13_lv_pmos ad=0.3808p pd=2.92u as=0.3808p ps=2.92u w=1.12u l=0.13u
X13 VDD VSS.t61 VDD VDD sg13_lv_pmos ad=0.19p pd=1.38u as=0 ps=0 w=1u l=1u
X14 VDD VSS.t60 VDD VDD sg13_lv_pmos ad=0.34p pd=2.68u as=0 ps=0 w=1u l=1u
X15 VSS.t22 VDD VSS.t19 VSS.t21 sg13_lv_nmos ad=79.8f pd=0.8u as=0 ps=0 w=0.42u l=1u
X16 VDD VSS.t29 VDD VDD sg13_lv_pmos ad=0.34p pd=2.68u as=0 ps=0 w=1u l=1u
X17 VSS.t49 VDD VSS.t48 VSS.t47 sg13_lv_nmos ad=0.1428p pd=1.52u as=0 ps=0 w=0.42u l=1u
X18 VDD VSS.t64 VDD VDD sg13_lv_pmos ad=0.19p pd=1.38u as=0 ps=0 w=1u l=1u
X19 VSS.t25 MUX_ONEHOT_SEL1 a_4661_392# VSS.t53 sg13_lv_nmos ad=0.2516p pd=2.16u as=0.2516p ps=2.16u w=0.74u l=0.13u
X20 VSS.t46 VDD VSS.t43 VSS.t45 sg13_lv_nmos ad=79.8f pd=0.8u as=0 ps=0 w=0.42u l=1u
X21 MUX_OUT MUX_ONEHOT_SEL0 MUX_IN0 VSS.t6 sg13_lv_nmos ad=0.2516p pd=2.16u as=0.2516p ps=2.16u w=0.74u l=0.13u
X22 VSS.t44 VDD VSS.t43 VSS.t42 sg13_lv_nmos ad=0.1428p pd=1.52u as=0 ps=0 w=0.42u l=1u
X23 MUX_OUT MUX_ONEHOT_SEL3 MUX_IN3 VSS.t0 sg13_lv_nmos ad=0.2516p pd=2.16u as=0.2516p ps=2.16u w=0.74u l=0.13u
X24 MUX_OUT a_4661_392# MUX_IN1 VDD sg13_lv_pmos ad=0.3808p pd=2.92u as=0.3808p ps=2.92u w=1.12u l=0.13u
X25 VDD MUX_ONEHOT_SEL1 a_4661_392# VDD sg13_lv_pmos ad=0.3808p pd=2.92u as=0.3808p ps=2.92u w=1.12u l=0.13u
X26 VDD VSS.t56 VDD VDD sg13_lv_pmos ad=0.19p pd=1.38u as=0 ps=0 w=1u l=1u
X27 VDD VSS.t55 VDD VDD sg13_lv_pmos ad=0.34p pd=2.68u as=0 ps=0 w=1u l=1u
X28 VSS.t27 VDD VSS.t24 VSS.t26 sg13_lv_nmos ad=79.8f pd=0.8u as=0 ps=0 w=0.42u l=1u
X29 VSS.t25 VDD VSS.t24 VSS.t23 sg13_lv_nmos ad=0.1428p pd=1.52u as=0 ps=0 w=0.42u l=1u
X30 VDD VSS.t62 VDD VDD sg13_lv_pmos ad=0.19p pd=1.38u as=0 ps=0 w=1u l=1u
X31 VSS.t20 VDD VSS.t19 VSS.t18 sg13_lv_nmos ad=0.1428p pd=1.52u as=0 ps=0 w=0.42u l=1u
X32 VDD VSS.t43 VDD VDD sg13_lv_pmos ad=0.34p pd=2.68u as=0 ps=0 w=1u l=1u
X33 VSS.t17 VDD VSS.t14 VSS.t16 sg13_lv_nmos ad=79.8f pd=0.8u as=0 ps=0 w=0.42u l=1u
X34 VDD VSS.t63 VDD VDD sg13_lv_pmos ad=0.34p pd=2.68u as=0 ps=0 w=1u l=1u
X35 VSS.t15 VDD VSS.t14 VSS.t13 sg13_lv_nmos ad=0.1428p pd=1.52u as=0 ps=0 w=0.42u l=1u
X36 MUX_OUT MUX_ONEHOT_SEL1 MUX_IN1 VSS.t52 sg13_lv_nmos ad=0.2516p pd=2.16u as=0.2516p ps=2.16u w=0.74u l=0.13u
X37 VDD VSS.t66 VDD VDD sg13_lv_pmos ad=0.19p pd=1.38u as=0 ps=0 w=1u l=1u
X38 VDD VSS.t65 VDD VDD sg13_lv_pmos ad=0.34p pd=2.68u as=0 ps=0 w=1u l=1u
X39 VSS.t41 VDD VSS.t39 VSS.t40 sg13_lv_nmos ad=79.8f pd=0.8u as=0 ps=0 w=0.42u l=1u
X40 VSS.t37 VDD VSS.t34 VSS.t36 sg13_lv_nmos ad=79.8f pd=0.8u as=0 ps=0 w=0.42u l=1u
X41 VSS.t5 VDD VSS.t39 VSS.t38 sg13_lv_nmos ad=0.1428p pd=1.52u as=0 ps=0 w=0.42u l=1u
X42 VDD VSS.t14 VDD VDD sg13_lv_pmos ad=0.34p pd=2.68u as=0 ps=0 w=1u l=1u
X43 VDD VSS.t57 VDD VDD sg13_lv_pmos ad=0.19p pd=1.38u as=0 ps=0 w=1u l=1u
X44 VDD VSS.t59 VDD VDD sg13_lv_pmos ad=0.19p pd=1.38u as=0 ps=0 w=1u l=1u
X45 VSS.t5 MUX_ONEHOT_SEL2 a_7701_392# VSS.t4 sg13_lv_nmos ad=0.2516p pd=2.16u as=0.2516p ps=2.16u w=0.74u l=0.13u
X46 VDD VSS.t58 VDD VDD sg13_lv_pmos ad=0.34p pd=2.68u as=0 ps=0 w=1u l=1u
X47 VSS.t12 VDD VSS.t10 VSS.t11 sg13_lv_nmos ad=79.8f pd=0.8u as=0 ps=0 w=0.42u l=1u
X48 VDD MUX_ONEHOT_SEL2 a_7701_392# VDD sg13_lv_pmos ad=0.3808p pd=2.92u as=0.3808p ps=2.92u w=1.12u l=0.13u
X49 MUX_OUT a_7701_392# MUX_IN2 VDD sg13_lv_pmos ad=0.3808p pd=2.92u as=0.3808p ps=2.92u w=1.12u l=0.13u
X50 VSS.t8 VDD VSS.t10 VSS.t9 sg13_lv_nmos ad=0.1428p pd=1.52u as=0 ps=0 w=0.42u l=1u
X51 VSS.t51 VDD VSS.t48 VSS.t50 sg13_lv_nmos ad=79.8f pd=0.8u as=0 ps=0 w=0.42u l=1u
C0 MUX_IN2 a_7701_392# 0.01637f
C1 VDD a_1621_392# 0.29178f
C2 MUX_IN1 VDD 0.19774f
C3 MUX_IN2 MUX_OUT 0.4238f
C4 MUX_IN0 a_1621_392# 0.01637f
C5 MUX_ONEHOT_SEL1 a_4661_392# 0.13134f
C6 VDD MUX_ONEHOT_SEL2 0.42911f
C7 VDD MUX_ONEHOT_SEL3 0.42172f
C8 VDD a_10741_392# 0.28906f
C9 VDD MUX_IN0 0.19967f
C10 VDD MUX_IN3 0.20185f
C11 a_1621_392# MUX_OUT 0.29558f
C12 MUX_IN1 MUX_OUT 0.4238f
C13 VDD a_7701_392# 0.28906f
C14 a_10741_392# MUX_ONEHOT_SEL3 0.13134f
C15 a_10741_392# MUX_IN3 0.01637f
C16 MUX_ONEHOT_SEL2 a_7701_392# 0.13134f
C17 VDD MUX_OUT 1.083f
C18 MUX_ONEHOT_SEL2 MUX_OUT 0.04345f
C19 MUX_OUT MUX_ONEHOT_SEL3 0.01733f
C20 a_10741_392# MUX_OUT 0.27952f
C21 MUX_IN0 MUX_OUT 0.42148f
C22 MUX_IN3 MUX_OUT 0.4238f
C23 MUX_OUT a_7701_392# 0.2906f
C24 MUX_IN1 a_4661_392# 0.01637f
C25 MUX_ONEHOT_SEL0 a_1621_392# 0.13134f
C26 VDD a_4661_392# 0.28906f
C27 VDD MUX_ONEHOT_SEL0 0.42767f
C28 MUX_ONEHOT_SEL1 VDD 0.42911f
C29 a_4661_392# MUX_OUT 0.2906f
C30 MUX_ONEHOT_SEL0 MUX_OUT 0.03902f
C31 MUX_ONEHOT_SEL1 MUX_OUT 0.04345f
C32 VDD MUX_IN2 0.19774f
R0 VSS.t33 VSS.t6 60.4094
R1 VSS.t6 VSS.t50 122.117
R2 VSS.t6 VSS.t28 71.4286
R3 VSS.t21 VSS.t6 122.117
R4 VSS.t36 VSS.t6 122.115
R5 VSS.t6 VSS.t11 127.992
R6 VSS.t6 VSS.t26 127.993
R7 VSS.t6 VSS.t40 127.993
R8 VSS.t9 VSS.t6 133.135
R9 VSS.t52 VSS.t6 139.469
R10 VSS.t0 VSS.t6 139.469
R11 VSS.t6 VSS.t1 147.181
R12 VSS.t6 VSS.t13 71.4292
R13 VSS.t31 VSS.t6 148.561
R14 VSS.t45 VSS.t6 148.56
R15 VSS.t6 VSS.t16 148.56
R16 VSS.t53 VSS.t6 147.181
R17 VSS.t4 VSS.t6 147.181
R18 VSS.t6 VSS.t23 133.136
R19 VSS.t6 VSS.t38 133.136
R20 VSS.t3 VSS.t6 139.469
R21 VSS.t42 VSS.t6 71.4292
R22 VSS.t6 VSS.t18 60.4105
R23 VSS.t6 VSS.t47 60.4105
R24 VSS.t6 VSS.n28 17.0005
R25 VSS.t6 VSS.t17 17.0005
R26 VSS.t6 VSS.n26 17.0005
R27 VSS.t6 VSS.n3 17.0005
R28 VSS.t6 VSS.n22 17.0005
R29 VSS.t6 VSS.t32 17.0005
R30 VSS.t6 VSS.n20 17.0005
R31 VSS.t6 VSS.n7 17.0005
R32 VSS.t6 VSS.n16 17.0005
R33 VSS.t6 VSS.t46 17.0005
R34 VSS.t6 VSS.n14 17.0005
R35 VSS.t6 VSS.n11 17.0005
R36 VSS.t51 VSS 12.9568
R37 VSS.t55 VSS 12.3605
R38 VSS.n13 VSS 12.0818
R39 VSS.t43 VSS 11.4855
R40 VSS.t41 VSS 11.2068
R41 VSS.t58 VSS 10.6105
R42 VSS.t37 VSS 9.15675
R43 VSS.t60 VSS 8.5605
R44 VSS.t6 VSS.n0 0.918708
R45 VSS.t6 VSS.n29 8.49237
R46 VSS.t6 VSS.n27 8.49237
R47 VSS.t6 VSS.n24 8.49237
R48 VSS.t6 VSS.n5 8.49237
R49 VSS.t6 VSS.n23 8.49237
R50 VSS.t6 VSS.n21 8.49237
R51 VSS.t6 VSS.n18 8.49237
R52 VSS.t6 VSS.n9 8.49237
R53 VSS.t6 VSS.n17 8.49237
R54 VSS.t6 VSS.n15 8.49237
R55 VSS.t6 VSS.n12 8.49237
R56 VSS.n19 VSS 8.28175
R57 VSS.t29 VSS 7.6855
R58 VSS.t27 VSS 7.40675
R59 VSS.t63 VSS 6.8105
R60 VSS.t22 VSS 5.35675
R61 VSS.t65 VSS 4.7605
R62 VSS.t54 VSS 4.65641
R63 VSS.n25 VSS 4.48175
R64 VSS.t49 VSS 4.43732
R65 VSS.t56 VSS 4.33823
R66 VSS.t6 VSS.t10 4.19225
R67 VSS.t6 VSS.t24 4.19225
R68 VSS.t6 VSS.t39 4.19225
R69 VSS.t44 VSS 4.11914
R70 VSS.t57 VSS 4.02005
R71 VSS.t14 VSS 3.8855
R72 VSS.t5 VSS 3.80095
R73 VSS.t12 VSS 3.60675
R74 VSS.t6 VSS.n2 3.32615
R75 VSS.t6 VSS.t19 3.32615
R76 VSS.t6 VSS.n6 3.32615
R77 VSS.t6 VSS.t34 3.32615
R78 VSS.t6 VSS.n10 3.32615
R79 VSS.t6 VSS.t48 3.32615
R80 VSS.t59 VSS 3.27459
R81 VSS.t35 VSS 3.0555
R82 VSS.t68 VSS 3.0105
R83 VSS.t61 VSS 2.95641
R84 VSS.t30 VSS 2.73732
R85 VSS.t62 VSS 2.63823
R86 VSS.t25 VSS 2.41914
R87 VSS.t64 VSS 1.89277
R88 VSS.n1 VSS.t51 0.55862
R89 VSS.t20 VSS 1.67368
R90 VSS.t66 VSS 1.57459
R91 VSS.t15 VSS 1.3555
R92 VSS.t67 VSS 1.25641
R93 VSS.t6 VSS 1.0464
R94 VSS VSS.t8 1.03732
R95 VSS.t8 VSS.n0 0.00473631
R96 VSS.t6 VSS.n4 1.01914
R97 VSS.t6 VSS.n8 1.01914
R98 VSS.t5 VSS.n8 0.617603
R99 VSS.t25 VSS.n4 0.617603
R100 VSS.n4 VSS.t22 0.580944
R101 VSS.n8 VSS.t37 0.580944
R102 VSS.t2 VSS.n1 0.164792
R103 VSS.t43 VSS.n10 0.24735
R104 VSS.t29 VSS.n6 0.24735
R105 VSS.t14 VSS.n2 0.24735
R106 VSS.t65 VSS.t19 0.22735
R107 VSS.t60 VSS.t34 0.22735
R108 VSS.t55 VSS.t48 0.22735
R109 VSS.t67 VSS.t10 0.224424
R110 VSS.t62 VSS.t24 0.224424
R111 VSS.t57 VSS.t39 0.224424
R112 VSS.t39 VSS.t58 0.220674
R113 VSS.t24 VSS.t63 0.220674
R114 VSS.t10 VSS.t68 0.220674
R115 VSS.t19 VSS.t64 0.216107
R116 VSS.t54 VSS.t48 0.216107
R117 VSS.t59 VSS.t34 0.216107
R118 VSS.n6 VSS.t61 0.196107
R119 VSS.t66 VSS.n2 0.196107
R120 VSS.t56 VSS.n10 0.196107
R121 VSS.n26 VSS.t20 0.08925
R122 VSS.n20 VSS.t35 0.08925
R123 VSS.n14 VSS.t49 0.08925
R124 VSS.n28 VSS.t15 0.06925
R125 VSS.n22 VSS.t30 0.06925
R126 VSS.n16 VSS.t44 0.06925
R127 VSS.t12 VSS.n28 0.05175
R128 VSS.t27 VSS.n22 0.05175
R129 VSS.t41 VSS.n16 0.05175
R130 VSS.n24 VSS.t65 0.0391643
R131 VSS.n18 VSS.t60 0.0391643
R132 VSS.n12 VSS.t55 0.0391643
R133 VSS.n5 VSS.t25 0.0350734
R134 VSS.n9 VSS.t5 0.0350734
R135 VSS.n29 VSS.t12 0.0341643
R136 VSS.n23 VSS.t27 0.0341643
R137 VSS.n17 VSS.t41 0.0341643
R138 VSS.t61 VSS.t32 0.0327727
R139 VSS.t46 VSS.t56 0.0327727
R140 VSS.t17 VSS.t66 0.0327727
R141 VSS.n27 VSS.t14 0.0318916
R142 VSS.n21 VSS.t29 0.0318916
R143 VSS.n15 VSS.t43 0.0318916
R144 VSS.n26 VSS.n25 0.03175
R145 VSS.n20 VSS.n19 0.03175
R146 VSS.n14 VSS.n13 0.03175
R147 VSS.t51 VSS.n11 0.0309545
R148 VSS.n7 VSS.t37 0.0309545
R149 VSS.n3 VSS.t22 0.0309545
R150 VSS.t15 VSS.n27 0.0278007
R151 VSS.t30 VSS.n21 0.0278007
R152 VSS.t44 VSS.n15 0.0278007
R153 VSS.t64 VSS.n3 0.0255
R154 VSS.n11 VSS.t54 0.0255
R155 VSS.n7 VSS.t59 0.0255
R156 VSS.t58 VSS.n9 0.0246188
R157 VSS.t63 VSS.n5 0.0246188
R158 VSS.t68 VSS.n0 0.0558309
R159 VSS.n25 VSS.t17 0.0236818
R160 VSS.n19 VSS.t32 0.0236818
R161 VSS.n13 VSS.t46 0.0236818
R162 VSS.t67 VSS.n29 0.0232552
R163 VSS.t62 VSS.n23 0.0232552
R164 VSS.t57 VSS.n17 0.0232552
R165 VSS.t20 VSS.n24 0.0205279
R166 VSS.t35 VSS.n18 0.0205279
R167 VSS.t49 VSS.n12 0.0205279
R168 VSS.t6 VSS.t7 147.181
R169 VSS.t6 VSS.n1 1.05874
C33 MUX_IN3 VSS 0.13252f
C34 MUX_ONEHOT_SEL3 VSS 0.37394f
C35 MUX_IN2 VSS 0.13453f
C36 MUX_ONEHOT_SEL2 VSS 0.36587f
C37 MUX_IN1 VSS 0.13453f
C38 MUX_ONEHOT_SEL1 VSS 0.36587f
C39 MUX_OUT VSS 4.0514f
C40 MUX_IN0 VSS 0.13087f
C41 MUX_ONEHOT_SEL0 VSS 0.36686f
C42 VDD VSS 15.1117f
C43 a_10741_392# VSS 0.18639f ; **FLOATING
C44 a_7701_392# VSS 0.18639f ; **FLOATING
C45 a_4661_392# VSS 0.18639f ; **FLOATING
C46 a_1621_392# VSS 0.18451f ; **FLOATING
.ends
