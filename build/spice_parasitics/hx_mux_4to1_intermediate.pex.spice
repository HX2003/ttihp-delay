* NGSPICE file created from hx_mux_4to1_intermediate.ext - technology: ihp-sg13g2

.subckt hx_mux_4to1_intermediate VSS VDD MUX_ONEHOT_SEL0 MUX_ONEHOT_SEL1 MUX_ONEHOT_SEL2
+ MUX_ONEHOT_SEL3 MUX_IN0 MUX_IN1 MUX_IN2 MUX_IN3 MUX_OUT
X0 VDD VSS.t6 VDD VDD sg13_lv_pmos ad=0.19p pd=1.38u as=52.17217p ps=0.22006m w=1u l=1u
X1 VSS.t19 VDD VSS.t19 VSS.t21 sg13_lv_nmos ad=0.1428p pd=1.52u as=0 ps=0 w=0.42u l=1u
X2 VSS.t6 MUX_ONEHOT_SEL0 a_1621_392# VSS.t7 sg13_lv_nmos ad=0.2516p pd=2.16u as=0.2516p ps=2.16u w=0.74u l=0.13u
X3 VDD VSS.t2 VDD VDD sg13_lv_pmos ad=0.19p pd=1.38u as=0 ps=0 w=1u l=1u
X4 VSS.t2 MUX_ONEHOT_SEL3 a_10741_392# VSS.t1 sg13_lv_nmos ad=0.2516p pd=2.16u as=0.2516p ps=2.16u w=0.74u l=0.13u
X5 VSS.t19 VDD VSS.t19 VSS.t20 sg13_lv_nmos ad=79.8f pd=0.8u as=0 ps=0 w=0.42u l=1u
X6 VDD VSS.t6 VDD VDD sg13_lv_pmos ad=0.34p pd=2.68u as=0 ps=0 w=1u l=1u
X7 VSS.t19 VDD VSS.t19 VSS.t18 sg13_lv_nmos ad=0.1428p pd=1.52u as=0 ps=0 w=0.42u l=1u
X8 MUX_OUT MUX_ONEHOT_SEL2 MUX_IN2 VSS.t3 sg13_lv_nmos ad=0.2516p pd=2.16u as=0.2516p ps=2.16u w=0.74u l=0.13u
X9 VDD MUX_ONEHOT_SEL3 a_10741_392# VDD sg13_lv_pmos ad=0.3808p pd=2.92u as=0.3808p ps=2.92u w=1.12u l=0.13u
X10 MUX_OUT a_1621_392# MUX_IN0 VDD sg13_lv_pmos ad=0.3808p pd=2.92u as=0.3808p ps=2.92u w=1.12u l=0.13u
X11 VDD MUX_ONEHOT_SEL0 a_1621_392# VDD sg13_lv_pmos ad=0.3808p pd=2.92u as=0.3808p ps=2.92u w=1.12u l=0.13u
X12 MUX_OUT a_10741_392# MUX_IN3 VDD sg13_lv_pmos ad=0.3808p pd=2.92u as=0.3808p ps=2.92u w=1.12u l=0.13u
X13 VDD VSS.t19 VDD VDD sg13_lv_pmos ad=0.19p pd=1.38u as=0 ps=0 w=1u l=1u
X14 VDD VSS.t19 VDD VDD sg13_lv_pmos ad=0.34p pd=2.68u as=0 ps=0 w=1u l=1u
X15 VSS.t11 VDD VSS.t11 VSS.t14 sg13_lv_nmos ad=79.8f pd=0.8u as=0 ps=0 w=0.42u l=1u
X16 VDD VSS.t19 VDD VDD sg13_lv_pmos ad=0.34p pd=2.68u as=0 ps=0 w=1u l=1u
X17 VSS.t2 VDD VSS.t2 VSS.t27 sg13_lv_nmos ad=0.1428p pd=1.52u as=0 ps=0 w=0.42u l=1u
X18 VDD VSS.t11 VDD VDD sg13_lv_pmos ad=0.19p pd=1.38u as=0 ps=0 w=1u l=1u
X19 VSS.t16 MUX_ONEHOT_SEL1 a_4661_392# VSS.t30 sg13_lv_nmos ad=0.2516p pd=2.16u as=0.2516p ps=2.16u w=0.74u l=0.13u
X20 VSS.t2 VDD VSS.t2 VSS.t26 sg13_lv_nmos ad=79.8f pd=0.8u as=0 ps=0 w=0.42u l=1u
X21 MUX_OUT MUX_ONEHOT_SEL0 MUX_IN0 VSS.t6 sg13_lv_nmos ad=0.2516p pd=2.16u as=0.2516p ps=2.16u w=0.74u l=0.13u
X22 VSS.t2 VDD VSS.t2 VSS.t25 sg13_lv_nmos ad=0.1428p pd=1.52u as=0 ps=0 w=0.42u l=1u
X23 MUX_OUT MUX_ONEHOT_SEL3 MUX_IN3 VSS.t0 sg13_lv_nmos ad=0.2516p pd=2.16u as=0.2516p ps=2.16u w=0.74u l=0.13u
X24 MUX_OUT a_4661_392# MUX_IN1 VDD sg13_lv_pmos ad=0.3808p pd=2.92u as=0.3808p ps=2.92u w=1.12u l=0.13u
X25 VDD MUX_ONEHOT_SEL1 a_4661_392# VDD sg13_lv_pmos ad=0.3808p pd=2.92u as=0.3808p ps=2.92u w=1.12u l=0.13u
X26 VDD VSS.t2 VDD VDD sg13_lv_pmos ad=0.19p pd=1.38u as=0 ps=0 w=1u l=1u
X27 VDD VSS.t2 VDD VDD sg13_lv_pmos ad=0.34p pd=2.68u as=0 ps=0 w=1u l=1u
X28 VSS.t16 VDD VSS.t16 VSS.t17 sg13_lv_nmos ad=79.8f pd=0.8u as=0 ps=0 w=0.42u l=1u
X29 VSS.t16 VDD VSS.t16 VSS.t15 sg13_lv_nmos ad=0.1428p pd=1.52u as=0 ps=0 w=0.42u l=1u
X30 VDD VSS.t16 VDD VDD sg13_lv_pmos ad=0.19p pd=1.38u as=0 ps=0 w=1u l=1u
X31 VSS.t11 VDD VSS.t11 VSS.t13 sg13_lv_nmos ad=0.1428p pd=1.52u as=0 ps=0 w=0.42u l=1u
X32 VDD VSS.t2 VDD VDD sg13_lv_pmos ad=0.34p pd=2.68u as=0 ps=0 w=1u l=1u
X33 VSS.t11 VDD VSS.t11 VSS.t12 sg13_lv_nmos ad=79.8f pd=0.8u as=0 ps=0 w=0.42u l=1u
X34 VDD VSS.t16 VDD VDD sg13_lv_pmos ad=0.34p pd=2.68u as=0 ps=0 w=1u l=1u
X35 VSS.t11 VDD VSS.t11 VSS.t10 sg13_lv_nmos ad=0.1428p pd=1.52u as=0 ps=0 w=0.42u l=1u
X36 MUX_OUT MUX_ONEHOT_SEL1 MUX_IN1 VSS.t29 sg13_lv_nmos ad=0.2516p pd=2.16u as=0.2516p ps=2.16u w=0.74u l=0.13u
X37 VDD VSS.t11 VDD VDD sg13_lv_pmos ad=0.19p pd=1.38u as=0 ps=0 w=1u l=1u
X38 VDD VSS.t11 VDD VDD sg13_lv_pmos ad=0.34p pd=2.68u as=0 ps=0 w=1u l=1u
X39 VSS.t5 VDD VSS.t5 VSS.t24 sg13_lv_nmos ad=79.8f pd=0.8u as=0 ps=0 w=0.42u l=1u
X40 VSS.t19 VDD VSS.t19 VSS.t22 sg13_lv_nmos ad=79.8f pd=0.8u as=0 ps=0 w=0.42u l=1u
X41 VSS.t5 VDD VSS.t5 VSS.t23 sg13_lv_nmos ad=0.1428p pd=1.52u as=0 ps=0 w=0.42u l=1u
X42 VDD VSS.t11 VDD VDD sg13_lv_pmos ad=0.34p pd=2.68u as=0 ps=0 w=1u l=1u
X43 VDD VSS.t5 VDD VDD sg13_lv_pmos ad=0.19p pd=1.38u as=0 ps=0 w=1u l=1u
X44 VDD VSS.t19 VDD VDD sg13_lv_pmos ad=0.19p pd=1.38u as=0 ps=0 w=1u l=1u
X45 VSS.t5 MUX_ONEHOT_SEL2 a_7701_392# VSS.t4 sg13_lv_nmos ad=0.2516p pd=2.16u as=0.2516p ps=2.16u w=0.74u l=0.13u
X46 VDD VSS.t5 VDD VDD sg13_lv_pmos ad=0.34p pd=2.68u as=0 ps=0 w=1u l=1u
X47 VSS.t6 VDD VSS.t6 VSS.t9 sg13_lv_nmos ad=79.8f pd=0.8u as=0 ps=0 w=0.42u l=1u
X48 VDD MUX_ONEHOT_SEL2 a_7701_392# VDD sg13_lv_pmos ad=0.3808p pd=2.92u as=0.3808p ps=2.92u w=1.12u l=0.13u
X49 MUX_OUT a_7701_392# MUX_IN2 VDD sg13_lv_pmos ad=0.3808p pd=2.92u as=0.3808p ps=2.92u w=1.12u l=0.13u
X50 VSS.t6 VDD VSS.t6 VSS.t8 sg13_lv_nmos ad=0.1428p pd=1.52u as=0 ps=0 w=0.42u l=1u
X51 VSS.t2 VDD VSS.t2 VSS.t28 sg13_lv_nmos ad=79.8f pd=0.8u as=0 ps=0 w=0.42u l=1u
C0 MUX_ONEHOT_SEL1 MUX_OUT 0.04345f
C1 a_7701_392# MUX_OUT 0.2906f
C2 MUX_IN3 MUX_OUT 0.4238f
C3 a_1621_392# MUX_IN0 0.01637f
C4 a_7701_392# MUX_IN2 0.01637f
C5 MUX_IN1 MUX_OUT 0.4238f
C6 a_4661_392# MUX_ONEHOT_SEL1 0.13134f
C7 a_1621_392# VDD 0.29178f
C8 MUX_OUT MUX_IN2 0.4238f
C9 MUX_IN3 a_10741_392# 0.01637f
C10 a_10741_392# MUX_OUT 0.2906f
C11 MUX_ONEHOT_SEL2 VDD 0.42911f
C12 MUX_ONEHOT_SEL0 VDD 0.42767f
C13 MUX_ONEHOT_SEL3 MUX_OUT 0.04341f
C14 MUX_ONEHOT_SEL1 VDD 0.42911f
C15 MUX_IN0 MUX_OUT 0.42148f
C16 a_4661_392# MUX_OUT 0.2906f
C17 VDD a_7701_392# 0.28906f
C18 a_4661_392# MUX_IN1 0.01637f
C19 VDD MUX_IN3 0.20185f
C20 VDD MUX_OUT 1.11646f
C21 MUX_ONEHOT_SEL3 a_10741_392# 0.13134f
C22 MUX_IN1 VDD 0.19774f
C23 a_1621_392# MUX_ONEHOT_SEL0 0.13134f
C24 VDD MUX_IN2 0.19774f
C25 VDD a_10741_392# 0.28906f
C26 MUX_ONEHOT_SEL3 VDD 0.42172f
C27 MUX_IN0 VDD 0.19967f
C28 a_4661_392# VDD 0.28906f
C29 MUX_ONEHOT_SEL2 a_7701_392# 0.13134f
C30 a_1621_392# MUX_OUT 0.29558f
C31 MUX_ONEHOT_SEL2 MUX_OUT 0.04345f
C32 MUX_ONEHOT_SEL0 MUX_OUT 0.03902f
R0 VSS.t21 VSS.t6 60.4114
R1 VSS.t6 VSS.t18 71.4286
R2 VSS.t6 VSS.t25 71.4281
R3 VSS.t14 VSS.t6 122.117
R4 VSS.t22 VSS.t6 122.115
R5 VSS.t28 VSS.t6 122.117
R6 VSS.t6 VSS.t17 127.992
R7 VSS.t6 VSS.t24 127.993
R8 VSS.t8 VSS.t6 133.135
R9 VSS.t29 VSS.t6 139.469
R10 VSS.t6 VSS.t4 147.181
R11 VSS.t7 VSS.t6 147.181
R12 VSS.t20 VSS.t6 148.561
R13 VSS.t26 VSS.t6 148.56
R14 VSS.t6 VSS.t12 148.56
R15 VSS.t27 VSS.t6 60.4113
R16 VSS.t30 VSS.t6 147.181
R17 VSS.t1 VSS.t6 147.181
R18 VSS.t6 VSS.t3 139.468
R19 VSS.t6 VSS.t0 139.469
R20 VSS.t6 VSS.t15 133.136
R21 VSS.t9 VSS.t6 127.993
R22 VSS.t6 VSS.t23 133.136
R23 VSS.t10 VSS.t6 71.4292
R24 VSS.t6 VSS.t13 60.4105
R25 VSS.t2 VSS 12.9568
R26 VSS.t2 VSS 12.3605
R27 VSS.t2 VSS 12.0818
R28 VSS.t2 VSS 11.4855
R29 VSS.t5 VSS 11.2068
R30 VSS.t5 VSS 10.6105
R31 VSS.t19 VSS 9.15675
R32 VSS.t19 VSS 8.5605
R33 VSS.n0 VSS.t16 0.180992
R34 VSS.t19 VSS 8.28175
R35 VSS.t19 VSS 7.6855
R36 VSS.t16 VSS 7.40675
R37 VSS.t16 VSS 6.8105
R38 VSS.t11 VSS 5.35675
R39 VSS.t11 VSS 4.7605
R40 VSS.t2 VSS 4.65641
R41 VSS.t11 VSS 4.48175
R42 VSS.t2 VSS 4.43732
R43 VSS.t2 VSS 4.33823
R44 VSS.t2 VSS 4.11914
R45 VSS.t5 VSS 4.02005
R46 VSS.t11 VSS 3.8855
R47 VSS.t5 VSS 3.80095
R48 VSS.t6 VSS 3.60675
R49 VSS.t19 VSS 3.27459
R50 VSS.t19 VSS 3.0555
R51 VSS.t6 VSS 3.0105
R52 VSS.t19 VSS 2.95641
R53 VSS.t19 VSS 2.73732
R54 VSS.t16 VSS 2.63823
R55 VSS.t16 VSS 2.41914
R56 VSS.t11 VSS 1.89277
R57 VSS.t11 VSS 1.67368
R58 VSS.t11 VSS 1.57459
R59 VSS.t11 VSS 1.3555
R60 VSS.t6 VSS 1.25641
R61 VSS.t6 VSS.n0 0.190971
R62 VSS.t6 VSS.t11 0.533914
R63 VSS.t6 VSS 1.1844
R64 VSS.t5 VSS.t6 1.1666
R65 VSS.n0 VSS.t19 0.490834
R66 VSS.t6 VSS.t2 0.537227
R67 VSS VSS.t6 1.03732
C33 MUX_IN3 VSS 0.13252f
C34 MUX_ONEHOT_SEL3 VSS 0.37394f
C35 MUX_IN2 VSS 0.13453f
C36 MUX_ONEHOT_SEL2 VSS 0.36587f
C37 MUX_IN1 VSS 0.13453f
C38 MUX_ONEHOT_SEL1 VSS 0.36587f
C39 MUX_OUT VSS 4.24511f
C40 MUX_IN0 VSS 0.13087f
C41 MUX_ONEHOT_SEL0 VSS 0.36686f
C42 VDD VSS 15.1117f
C43 a_10741_392# VSS 0.18639f ; **FLOATING
C44 a_7701_392# VSS 0.18639f ; **FLOATING
C45 a_4661_392# VSS 0.18639f ; **FLOATING
C46 a_1621_392# VSS 0.18451f ; **FLOATING
.ends
